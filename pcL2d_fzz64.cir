pcL 2D
.model NNR NMOS (LEVEL=1 VTO=0.2 KP=120u LAMBDA=0.02 GAMMA=0 PHI=0.7)
.model PNR PMOS (LEVEL=1 VTO=-0.2 KP=40u LAMBDA=0.02 GAMMA=0 PHI=0.7)
.subckt gsyn inp inn wp wn outp outn vdd vbn
Mtail nt vbn 0 0 NNR W=400u L=100u
M5 na wp nt 0 NNR W=200u L=100u
M6 nb wn nt 0 NNR W=200u L=100u
M1 outp inp na 0 NNR W=200u L=100u
M2 outn inn na 0 NNR W=200u L=100u
M3 outn inp nb 0 NNR W=200u L=100u
M4 outp inn nb 0 NNR W=200u L=100u
.ends
.subckt cmld p n vdd
Rcs1 p cmx 300k
Rcs2 n cmx 300k
MLp p cmx vdd vdd PNR W=1000u L=100u
MLn n cmx vdd vdd PNR W=1000u L=100u
.ends
.subckt dneuron up un ap an vdd vbn
M1 an up tn 0 NNR W=200u L=100u
M2 ap un tn 0 NNR W=200u L=100u
Mt tn vbn 0 0 NNR W=200u L=100u
Xcm ap an vdd cmld
.ends
.subckt esub xp xn mp mn ep en vdd vbn
Mt nt vbn 0 0 NNR W=400u L=100u
M1x ep xn nt 0 NNR W=200u L=100u
M2x en xp nt 0 NNR W=200u L=100u
M1m ep mp nt 0 NNR W=200u L=100u
M2m en mn nt 0 NNR W=200u L=100u
RLp vdd ep 50k
RLn vdd en 50k
.ends
.subckt gprod xp xn yp yn wp wn vdd vbn
Mtail nt vbn 0 0 NNR W=400u L=100u
M5 na yp nt 0 NNR W=200u L=100u
M6 nb yn nt 0 NNR W=200u L=100u
M1 iop xp na 0 NNR W=200u L=100u
M2 ion xn na 0 NNR W=200u L=100u
M3 ion xp nb 0 NNR W=200u L=100u
M4 iop xn nb 0 NNR W=200u L=100u
Mlp iop iop vdd vdd PNR W=200u L=100u
Mln ion ion vdd vdd PNR W=200u L=100u
Mpu_wp wp iop vdd vdd PNR W=200u L=100u
MpRn nrn ion vdd vdd PNR W=200u L=100u
MnRn nrn nrn 0 0 NNR W=200u L=100u
Mpd_wp wp nrn 0 0 NNR W=200u L=100u
Mpu_wn wn ion vdd vdd PNR W=200u L=100u
MpRp nrp iop vdd vdd PNR W=200u L=100u
MnRp nrp nrp 0 0 NNR W=200u L=100u
Mpd_wn wn nrp 0 0 NNR W=200u L=100u
.ends
Vdd vdd 0 1.0
Vbsyn vbsyn 0 0.6
Vbneu vbneu 0 0.35
Vgm_h gm_h 0 0.6
Vgm_o gm_o 0 PWL(0 0.6 59999.9n 0.6 60000.0n 0)
Vgblh gblh 0 PWL(0 0.001 59999.9n 0.001 60000.0n 0)
Vgblo gblo 0 PWL(0 1.4 59999.9n 1.4 60000.0n 0)
Vwcm wcm 0 0.5
Vx1p a_xp1 0 PWL(0.0n 0.2980 249.9n 0.2980 250.0n 0.4410 499.9n 0.4410 500.0n 0.4561 749.9n 0.4561 750.0n 0.6110 999.9n 0.6110 1000.0n 0.4603 1249.9n 0.4603 1250.0n 0.4110 1499.9n 0.4110 1500.0n 0.6589 1749.9n 0.6589 1750.0n 0.8948 1999.9n 0.8948 2000.0n 0.4823 2249.9n 0.4823 2250.0n 0.4240 2499.9n 0.4240 2500.0n 0.7782 2749.9n 0.7782 2750.0n 0.8420 2999.9n 0.8420 3000.0n 0.2987 3249.9n 0.2987 3250.0n 0.4093 3499.9n 0.4093 3500.0n 0.1528 3749.9n 0.1528 3750.0n 0.3464 3999.9n 0.3464 4000.0n 0.4596 4249.9n 0.4596 4250.0n 0.3276 4499.9n 0.3276 4500.0n 0.4907 4749.9n 0.4907 4750.0n 0.1318 4999.9n 0.1318 5000.0n 0.6068 5249.9n 0.6068 5250.0n 0.6530 5499.9n 0.6530 5500.0n 0.6701 5749.9n 0.6701 5750.0n 0.4957 5999.9n 0.4957 6000.0n 0.6871 6249.9n 0.6871 6250.0n 0.8333 6499.9n 0.8333 6500.0n 0.9157 6749.9n 0.9157 6750.0n 0.5523 6999.9n 0.5523 7000.0n 0.7979 7249.9n 0.7979 7250.0n 0.5717 7499.9n 0.5717 7500.0n 0.6701 7749.9n 0.6701 7750.0n 0.4561 7999.9n 0.4561 8000.0n 0.7979 8249.9n 0.7979 8250.0n 0.5523 8499.9n 0.5523 8500.0n 0.4823 8749.9n 0.4823 8750.0n 0.4110 8999.9n 0.4110 9000.0n 0.6110 9249.9n 0.6110 9250.0n 0.7782 9499.9n 0.7782 9500.0n 0.6068 9749.9n 0.6068 9750.0n 0.6589 9999.9n 0.6589 10000.0n 0.4957 10249.9n 0.4957 10250.0n 0.1318 10499.9n 0.1318 10500.0n 0.2987 10749.9n 0.2987 10750.0n 0.4093 10999.9n 0.4093 11000.0n 0.6530 11249.9n 0.6530 11250.0n 0.8333 11499.9n 0.8333 11500.0n 0.5717 11749.9n 0.5717 11750.0n 0.1528 11999.9n 0.1528 12000.0n 0.2980 12249.9n 0.2980 12250.0n 0.9157 12499.9n 0.9157 12500.0n 0.4410 12749.9n 0.4410 12750.0n 0.4596 12999.9n 0.4596 13000.0n 0.4907 13249.9n 0.4907 13250.0n 0.3276 13499.9n 0.3276 13500.0n 0.8420 13749.9n 0.8420 13750.0n 0.8948 13999.9n 0.8948 14000.0n 0.4240 14249.9n 0.4240 14250.0n 0.3464 14499.9n 0.3464 14500.0n 0.6871 14749.9n 0.6871 14750.0n 0.4603 14999.9n 0.4603 15000.0n 0.1528 15249.9n 0.1528 15250.0n 0.4093 15499.9n 0.4093 15500.0n 0.4957 15749.9n 0.4957 15750.0n 0.7782 15999.9n 0.7782 16000.0n 0.2987 16249.9n 0.2987 16250.0n 0.8333 16499.9n 0.8333 16500.0n 0.7979 16749.9n 0.7979 16750.0n 0.8948 16999.9n 0.8948 17000.0n 0.4410 17249.9n 0.4410 17250.0n 0.5717 17499.9n 0.5717 17500.0n 0.6068 17749.9n 0.6068 17750.0n 0.4561 17999.9n 0.4561 18000.0n 0.8420 18249.9n 0.8420 18250.0n 0.1318 18499.9n 0.1318 18500.0n 0.9157 18749.9n 0.9157 18750.0n 0.6530 18999.9n 0.6530 19000.0n 0.4110 19249.9n 0.4110 19250.0n 0.5523 19499.9n 0.5523 19500.0n 0.6701 19749.9n 0.6701 19750.0n 0.4907 19999.9n 0.4907 20000.0n 0.4240 20249.9n 0.4240 20250.0n 0.4823 20499.9n 0.4823 20500.0n 0.4596 20749.9n 0.4596 20750.0n 0.6110 20999.9n 0.6110 21000.0n 0.6871 21249.9n 0.6871 21250.0n 0.6589 21499.9n 0.6589 21500.0n 0.4603 21749.9n 0.4603 21750.0n 0.3464 21999.9n 0.3464 22000.0n 0.3276 22249.9n 0.3276 22250.0n 0.2980 22499.9n 0.2980 22500.0n 0.3464 22749.9n 0.3464 22750.0n 0.4957 22999.9n 0.4957 23000.0n 0.6530 23249.9n 0.6530 23250.0n 0.1528 23499.9n 0.1528 23500.0n 0.6701 23749.9n 0.6701 23750.0n 0.8948 23999.9n 0.8948 24000.0n 0.4603 24249.9n 0.4603 24250.0n 0.3276 24499.9n 0.3276 24500.0n 0.4907 24749.9n 0.4907 24750.0n 0.4410 24999.9n 0.4410 25000.0n 0.5717 25249.9n 0.5717 25250.0n 0.9157 25499.9n 0.9157 25500.0n 0.4240 25749.9n 0.4240 25750.0n 0.6871 25999.9n 0.6871 26000.0n 0.2980 26249.9n 0.2980 26250.0n 0.8420 26499.9n 0.8420 26500.0n 0.6110 26749.9n 0.6110 26750.0n 0.7979 26999.9n 0.7979 27000.0n 0.6068 27249.9n 0.6068 27250.0n 0.4596 27499.9n 0.4596 27500.0n 0.4093 27749.9n 0.4093 27750.0n 0.4110 27999.9n 0.4110 28000.0n 0.1318 28249.9n 0.1318 28250.0n 0.4561 28499.9n 0.4561 28500.0n 0.5523 28749.9n 0.5523 28750.0n 0.2987 28999.9n 0.2987 29000.0n 0.4823 29249.9n 0.4823 29250.0n 0.7782 29499.9n 0.7782 29500.0n 0.6589 29749.9n 0.6589 29750.0n 0.8333 29999.9n 0.8333 30000.0n 0.4561 30249.9n 0.4561 30250.0n 0.5717 30499.9n 0.5717 30500.0n 0.1528 30749.9n 0.1528 30750.0n 0.4240 30999.9n 0.4240 31000.0n 0.9157 31249.9n 0.9157 31250.0n 0.2987 31499.9n 0.2987 31500.0n 0.8948 31749.9n 0.8948 31750.0n 0.4110 31999.9n 0.4110 32000.0n 0.2980 32249.9n 0.2980 32250.0n 0.1318 32499.9n 0.1318 32500.0n 0.6871 32749.9n 0.6871 32750.0n 0.6068 32999.9n 0.6068 33000.0n 0.7782 33249.9n 0.7782 33250.0n 0.6530 33499.9n 0.6530 33500.0n 0.7979 33749.9n 0.7979 33750.0n 0.5523 33999.9n 0.5523 34000.0n 0.8420 34249.9n 0.8420 34250.0n 0.4603 34499.9n 0.4603 34500.0n 0.6589 34749.9n 0.6589 34750.0n 0.6701 34999.9n 0.6701 35000.0n 0.3276 35249.9n 0.3276 35250.0n 0.4907 35499.9n 0.4907 35500.0n 0.4410 35749.9n 0.4410 35750.0n 0.3464 35999.9n 0.3464 36000.0n 0.4823 36249.9n 0.4823 36250.0n 0.4957 36499.9n 0.4957 36500.0n 0.4093 36749.9n 0.4093 36750.0n 0.4596 36999.9n 0.4596 37000.0n 0.8333 37249.9n 0.8333 37250.0n 0.6110 37499.9n 0.6110 37500.0n 0.4907 37749.9n 0.4907 37750.0n 0.8948 37999.9n 0.8948 38000.0n 0.7782 38249.9n 0.7782 38250.0n 0.2980 38499.9n 0.2980 38500.0n 0.1528 38749.9n 0.1528 38750.0n 0.8420 38999.9n 0.8420 39000.0n 0.3464 39249.9n 0.3464 39250.0n 0.5717 39499.9n 0.5717 39500.0n 0.4561 39749.9n 0.4561 39750.0n 0.4410 39999.9n 0.4410 40000.0n 0.5523 40249.9n 0.5523 40250.0n 0.4603 40499.9n 0.4603 40500.0n 0.6110 40749.9n 0.6110 40750.0n 0.6530 40999.9n 0.6530 41000.0n 0.7979 41249.9n 0.7979 41250.0n 0.9157 41499.9n 0.9157 41500.0n 0.4240 41749.9n 0.4240 41750.0n 0.1318 41999.9n 0.1318 42000.0n 0.2987 42249.9n 0.2987 42250.0n 0.4110 42499.9n 0.4110 42500.0n 0.8333 42749.9n 0.8333 42750.0n 0.6068 42999.9n 0.6068 43000.0n 0.4093 43249.9n 0.4093 43250.0n 0.4823 43499.9n 0.4823 43500.0n 0.3276 43749.9n 0.3276 43750.0n 0.4596 43999.9n 0.4596 44000.0n 0.6701 44249.9n 0.6701 44250.0n 0.4957 44499.9n 0.4957 44500.0n 0.6589 44749.9n 0.6589 44750.0n 0.6871 44999.9n 0.6871 45000.0n 0.4410 45249.9n 0.4410 45250.0n 0.6589 45499.9n 0.6589 45500.0n 0.8420 45749.9n 0.8420 45750.0n 0.1318 45999.9n 0.1318 46000.0n 0.5523 46249.9n 0.5523 46250.0n 0.2980 46499.9n 0.2980 46500.0n 0.4561 46749.9n 0.4561 46750.0n 0.6110 46999.9n 0.6110 47000.0n 0.6530 47249.9n 0.6530 47250.0n 0.6068 47499.9n 0.6068 47500.0n 0.3464 47749.9n 0.3464 47750.0n 0.4823 47999.9n 0.4823 48000.0n 0.4603 48249.9n 0.4603 48250.0n 0.9157 48499.9n 0.9157 48500.0n 0.2987 48749.9n 0.2987 48750.0n 0.1528 48999.9n 0.1528 49000.0n 0.4093 49249.9n 0.4093 49250.0n 0.8333 49499.9n 0.8333 49500.0n 0.4957 49749.9n 0.4957 49750.0n 0.5717 49999.9n 0.5717 50000.0n 0.3276 50249.9n 0.3276 50250.0n 0.4110 50499.9n 0.4110 50500.0n 0.6871 50749.9n 0.6871 50750.0n 0.4907 50999.9n 0.4907 51000.0n 0.4596 51249.9n 0.4596 51250.0n 0.7782 51499.9n 0.7782 51500.0n 0.6701 51749.9n 0.6701 51750.0n 0.7979 51999.9n 0.7979 52000.0n 0.4240 52249.9n 0.4240 52250.0n 0.8948 52499.9n 0.8948 52500.0n 0.6589 52749.9n 0.6589 52750.0n 0.6068 52999.9n 0.6068 53000.0n 0.4907 53249.9n 0.4907 53250.0n 0.7979 53499.9n 0.7979 53500.0n 0.2987 53749.9n 0.2987 53750.0n 0.8948 53999.9n 0.8948 54000.0n 0.1318 54249.9n 0.1318 54250.0n 0.4957 54499.9n 0.4957 54500.0n 0.1528 54749.9n 0.1528 54750.0n 0.7782 54999.9n 0.7782 55000.0n 0.4561 55249.9n 0.4561 55250.0n 0.4603 55499.9n 0.4603 55500.0n 0.4596 55749.9n 0.4596 55750.0n 0.3276 55999.9n 0.3276 56000.0n 0.4823 56249.9n 0.4823 56250.0n 0.4240 56499.9n 0.4240 56500.0n 0.8333 56749.9n 0.8333 56750.0n 0.3464 56999.9n 0.3464 57000.0n 0.4110 57249.9n 0.4110 57250.0n 0.8420 57499.9n 0.8420 57500.0n 0.5717 57749.9n 0.5717 57750.0n 0.4410 57999.9n 0.4410 58000.0n 0.6110 58249.9n 0.6110 58250.0n 0.6701 58499.9n 0.6701 58500.0n 0.4093 58749.9n 0.4093 58750.0n 0.6530 58999.9n 0.6530 59000.0n 0.6871 59249.9n 0.6871 59250.0n 0.5523 59499.9n 0.5523 59500.0n 0.9157 59749.9n 0.9157 59750.0n 0.2980 59999.9n 0.2980 60000.0n 0.7862 60249.9n 0.7862 60250.0n 0.2681 60499.9n 0.2681 60500.0n 0.7669 60749.9n 0.7669 60750.0n 0.5529 60999.9n 0.5529 61000.0n 0.5987 61249.9n 0.5987 61250.0n 0.0543 61499.9n 0.0543 61500.0n 0.4903 61749.9n 0.4903 61750.0n 0.1277 61999.9n 0.1277 62000.0n 0.5027 62249.9n 0.5027 62250.0n 0.3940 62499.9n 0.3940 62500.0n 0.7589 62749.9n 0.7589 62750.0n 0.4688 62999.9n 0.4688 63000.0n 0.6135 63249.9n 0.6135 63250.0n 0.4859 63499.9n 0.4859 63500.0n 0.8917 63749.9n 0.8917 63750.0n 0.9386 63999.9n 0.9386 64000.0n 0.1432 64249.9n 0.1432 64250.0n 0.3736 64499.9n 0.3736 64500.0n 0.6971 64749.9n 0.6971 64750.0n 0.3183 64999.9n 0.3183 65000.0n 0.5646 65249.9n 0.5646 65250.0n 0.4138 65499.9n 0.4138 65500.0n 0.3857 65749.9n 0.3857 65750.0n 0.6198 65999.9n 0.6198 66000.0n 0.6320 66249.9n 0.6320 66250.0n 0.1879 66499.9n 0.1879 66500.0n 0.5510 66749.9n 0.5510 66750.0n 0.4071 66999.9n 0.4071 67000.0n 0.6952 67249.9n 0.6952 67250.0n 0.1733 67499.9n 0.1733 67500.0n 0.5260 67749.9n 0.5260 67750.0n 0.4479 67999.9n 0.4479 68000.0n 0.0662 68249.9n 0.0662 68250.0n 0.6344 68499.9n 0.6344 68500.0n 0.4378 68749.9n 0.4378 68750.0n 0.4666 68999.9n 0.4666 69000.0n 0.2226 69249.9n 0.2226 69250.0n 0.1684 69499.9n 0.1684 69500.0n 0.4887 69749.9n 0.4887 69750.0n 0.3912 69999.9n 0.3912 70000.0n 0.6331 70249.9n 0.6331 70250.0n 0.0916 70499.9n 0.0916 70500.0n 0.1896 70749.9n 0.1896 70750.0n 0.3937 70999.9n 0.3937 71000.0n 0.8125 71249.9n 0.8125 71250.0n 0.8888 71499.9n 0.8888 71500.0n 0.5216 71749.9n 0.5216 71750.0n 0.9119 71999.9n 0.9119 72000.0n 0.4149 72249.9n 0.4149 72250.0n 0.5958 72499.9n 0.5958 72500.0n 0.3037 72749.9n 0.3037 72750.0n 0.8943 72999.9n 0.8943 73000.0n 0.5708 73249.9n 0.5708 73250.0n 0.3608 73499.9n 0.3608 73500.0n 0.4865 73749.9n 0.4865 73750.0n 0.5433 73999.9n 0.5433 74000.0n 0.5941 74249.9n 0.5941 74250.0n 0.1528 74499.9n 0.1528 74500.0n 0.6346 74749.9n 0.6346 74750.0n 0.5209 74999.9n 0.5209 75000.0n 0.4645 75249.9n 0.4645 75250.0n 0.4957 75499.9n 0.4957 75500.0n 0.3720 75749.9n 0.3720 75750.0n 0.3352 75999.9n 0.3352 76000.0n 0.9541 76249.9n 0.9541 76250.0n 0.6681 76499.9n 0.6681 76500.0n 0.3664 76749.9n 0.3664 76750.0n 0.7930 76999.9n 0.7930 77000.0n 0.3627 77249.9n 0.3627 77250.0n 0.3181 77499.9n 0.3181 77500.0n 0.4717 77749.9n 0.4717 77750.0n 0.4193 77999.9n 0.4193 78000.0n 0.5941 78249.9n 0.5941 78250.0n 0.1752 78499.9n 0.1752 78500.0n 0.3574 78749.9n 0.3574 78750.0n 0.7938 78999.9n 0.7938 79000.0n 0.6578 79249.9n 0.6578 79250.0n 0.4866 79499.9n 0.4866 79500.0n 0.1821 79749.9n 0.1821 79750.0n 0.9426 79999.9n 0.9426 80000.0n 0.5574 80249.9n 0.5574 80250.0n 0.5475 80499.9n 0.5475 80500.0n 0.4601 80749.9n 0.4601 80750.0n 0.5278 80999.9n 0.5278 81000.0n 0.6854 81249.9n 0.6854 81250.0n 0.5603 81499.9n 0.5603 81500.0n 0.5420 81749.9n 0.5420 81750.0n 0.4338 81999.9n 0.4338 82000.0n 0.6646 82249.9n 0.6646 82250.0n 0.3749 82499.9n 0.3749 82500.0n 0.1742 82749.9n 0.1742 82750.0n 0.4073 82999.9n 0.4073 83000.0n 0.7919 83249.9n 0.7919 83250.0n 0.4282 83499.9n 0.4282 83500.0n 0.5414 83749.9n 0.5414 83750.0n 0.8375 83999.9n 0.8375 84000.0n 0.3672 84249.9n 0.3672 84250.0n 0.6522 84499.9n 0.6522 84500.0n 0.2097 84749.9n 0.2097 84750.0n 0.5170 84999.9n 0.5170 85000.0n 0.4734 85249.9n 0.4734 85250.0n 0.4382 85499.9n 0.4382 85500.0n 0.5660 85749.9n 0.5660 85750.0n 0.4134 85999.9n 0.4134 86000.0n 0.2348 86249.9n 0.2348 86250.0n 0.4806 86499.9n 0.4806 86500.0n 0.4131 86749.9n 0.4131 86750.0n 0.2064 86999.9n 0.2064 87000.0n 0.9118 87249.9n 0.9118 87250.0n 0.5609 87499.9n 0.5609 87500.0n 0.1784 87749.9n 0.1784 87750.0n 0.3829 87999.9n 0.3829 88000.0n 0.2288 88249.9n 0.2288 88250.0n 0.5872 88499.9n 0.5872 88500.0n 0.6060 88749.9n 0.6060 88750.0n 0.5092 88999.9n 0.5092 89000.0n 0.4833 89249.9n 0.4833 89250.0n 0.4728 89499.9n 0.4728 89500.0n 0.5093 89749.9n 0.5093 89750.0n 0.8176)
Vx1n a_xn1 0 PWL(0.0n 0.7020 249.9n 0.7020 250.0n 0.5590 499.9n 0.5590 500.0n 0.5439 749.9n 0.5439 750.0n 0.3890 999.9n 0.3890 1000.0n 0.5397 1249.9n 0.5397 1250.0n 0.5890 1499.9n 0.5890 1500.0n 0.3411 1749.9n 0.3411 1750.0n 0.1052 1999.9n 0.1052 2000.0n 0.5177 2249.9n 0.5177 2250.0n 0.5760 2499.9n 0.5760 2500.0n 0.2218 2749.9n 0.2218 2750.0n 0.1580 2999.9n 0.1580 3000.0n 0.7013 3249.9n 0.7013 3250.0n 0.5907 3499.9n 0.5907 3500.0n 0.8472 3749.9n 0.8472 3750.0n 0.6536 3999.9n 0.6536 4000.0n 0.5404 4249.9n 0.5404 4250.0n 0.6724 4499.9n 0.6724 4500.0n 0.5093 4749.9n 0.5093 4750.0n 0.8682 4999.9n 0.8682 5000.0n 0.3932 5249.9n 0.3932 5250.0n 0.3470 5499.9n 0.3470 5500.0n 0.3299 5749.9n 0.3299 5750.0n 0.5043 5999.9n 0.5043 6000.0n 0.3129 6249.9n 0.3129 6250.0n 0.1667 6499.9n 0.1667 6500.0n 0.0843 6749.9n 0.0843 6750.0n 0.4477 6999.9n 0.4477 7000.0n 0.2021 7249.9n 0.2021 7250.0n 0.4283 7499.9n 0.4283 7500.0n 0.3299 7749.9n 0.3299 7750.0n 0.5439 7999.9n 0.5439 8000.0n 0.2021 8249.9n 0.2021 8250.0n 0.4477 8499.9n 0.4477 8500.0n 0.5177 8749.9n 0.5177 8750.0n 0.5890 8999.9n 0.5890 9000.0n 0.3890 9249.9n 0.3890 9250.0n 0.2218 9499.9n 0.2218 9500.0n 0.3932 9749.9n 0.3932 9750.0n 0.3411 9999.9n 0.3411 10000.0n 0.5043 10249.9n 0.5043 10250.0n 0.8682 10499.9n 0.8682 10500.0n 0.7013 10749.9n 0.7013 10750.0n 0.5907 10999.9n 0.5907 11000.0n 0.3470 11249.9n 0.3470 11250.0n 0.1667 11499.9n 0.1667 11500.0n 0.4283 11749.9n 0.4283 11750.0n 0.8472 11999.9n 0.8472 12000.0n 0.7020 12249.9n 0.7020 12250.0n 0.0843 12499.9n 0.0843 12500.0n 0.5590 12749.9n 0.5590 12750.0n 0.5404 12999.9n 0.5404 13000.0n 0.5093 13249.9n 0.5093 13250.0n 0.6724 13499.9n 0.6724 13500.0n 0.1580 13749.9n 0.1580 13750.0n 0.1052 13999.9n 0.1052 14000.0n 0.5760 14249.9n 0.5760 14250.0n 0.6536 14499.9n 0.6536 14500.0n 0.3129 14749.9n 0.3129 14750.0n 0.5397 14999.9n 0.5397 15000.0n 0.8472 15249.9n 0.8472 15250.0n 0.5907 15499.9n 0.5907 15500.0n 0.5043 15749.9n 0.5043 15750.0n 0.2218 15999.9n 0.2218 16000.0n 0.7013 16249.9n 0.7013 16250.0n 0.1667 16499.9n 0.1667 16500.0n 0.2021 16749.9n 0.2021 16750.0n 0.1052 16999.9n 0.1052 17000.0n 0.5590 17249.9n 0.5590 17250.0n 0.4283 17499.9n 0.4283 17500.0n 0.3932 17749.9n 0.3932 17750.0n 0.5439 17999.9n 0.5439 18000.0n 0.1580 18249.9n 0.1580 18250.0n 0.8682 18499.9n 0.8682 18500.0n 0.0843 18749.9n 0.0843 18750.0n 0.3470 18999.9n 0.3470 19000.0n 0.5890 19249.9n 0.5890 19250.0n 0.4477 19499.9n 0.4477 19500.0n 0.3299 19749.9n 0.3299 19750.0n 0.5093 19999.9n 0.5093 20000.0n 0.5760 20249.9n 0.5760 20250.0n 0.5177 20499.9n 0.5177 20500.0n 0.5404 20749.9n 0.5404 20750.0n 0.3890 20999.9n 0.3890 21000.0n 0.3129 21249.9n 0.3129 21250.0n 0.3411 21499.9n 0.3411 21500.0n 0.5397 21749.9n 0.5397 21750.0n 0.6536 21999.9n 0.6536 22000.0n 0.6724 22249.9n 0.6724 22250.0n 0.7020 22499.9n 0.7020 22500.0n 0.6536 22749.9n 0.6536 22750.0n 0.5043 22999.9n 0.5043 23000.0n 0.3470 23249.9n 0.3470 23250.0n 0.8472 23499.9n 0.8472 23500.0n 0.3299 23749.9n 0.3299 23750.0n 0.1052 23999.9n 0.1052 24000.0n 0.5397 24249.9n 0.5397 24250.0n 0.6724 24499.9n 0.6724 24500.0n 0.5093 24749.9n 0.5093 24750.0n 0.5590 24999.9n 0.5590 25000.0n 0.4283 25249.9n 0.4283 25250.0n 0.0843 25499.9n 0.0843 25500.0n 0.5760 25749.9n 0.5760 25750.0n 0.3129 25999.9n 0.3129 26000.0n 0.7020 26249.9n 0.7020 26250.0n 0.1580 26499.9n 0.1580 26500.0n 0.3890 26749.9n 0.3890 26750.0n 0.2021 26999.9n 0.2021 27000.0n 0.3932 27249.9n 0.3932 27250.0n 0.5404 27499.9n 0.5404 27500.0n 0.5907 27749.9n 0.5907 27750.0n 0.5890 27999.9n 0.5890 28000.0n 0.8682 28249.9n 0.8682 28250.0n 0.5439 28499.9n 0.5439 28500.0n 0.4477 28749.9n 0.4477 28750.0n 0.7013 28999.9n 0.7013 29000.0n 0.5177 29249.9n 0.5177 29250.0n 0.2218 29499.9n 0.2218 29500.0n 0.3411 29749.9n 0.3411 29750.0n 0.1667 29999.9n 0.1667 30000.0n 0.5439 30249.9n 0.5439 30250.0n 0.4283 30499.9n 0.4283 30500.0n 0.8472 30749.9n 0.8472 30750.0n 0.5760 30999.9n 0.5760 31000.0n 0.0843 31249.9n 0.0843 31250.0n 0.7013 31499.9n 0.7013 31500.0n 0.1052 31749.9n 0.1052 31750.0n 0.5890 31999.9n 0.5890 32000.0n 0.7020 32249.9n 0.7020 32250.0n 0.8682 32499.9n 0.8682 32500.0n 0.3129 32749.9n 0.3129 32750.0n 0.3932 32999.9n 0.3932 33000.0n 0.2218 33249.9n 0.2218 33250.0n 0.3470 33499.9n 0.3470 33500.0n 0.2021 33749.9n 0.2021 33750.0n 0.4477 33999.9n 0.4477 34000.0n 0.1580 34249.9n 0.1580 34250.0n 0.5397 34499.9n 0.5397 34500.0n 0.3411 34749.9n 0.3411 34750.0n 0.3299 34999.9n 0.3299 35000.0n 0.6724 35249.9n 0.6724 35250.0n 0.5093 35499.9n 0.5093 35500.0n 0.5590 35749.9n 0.5590 35750.0n 0.6536 35999.9n 0.6536 36000.0n 0.5177 36249.9n 0.5177 36250.0n 0.5043 36499.9n 0.5043 36500.0n 0.5907 36749.9n 0.5907 36750.0n 0.5404 36999.9n 0.5404 37000.0n 0.1667 37249.9n 0.1667 37250.0n 0.3890 37499.9n 0.3890 37500.0n 0.5093 37749.9n 0.5093 37750.0n 0.1052 37999.9n 0.1052 38000.0n 0.2218 38249.9n 0.2218 38250.0n 0.7020 38499.9n 0.7020 38500.0n 0.8472 38749.9n 0.8472 38750.0n 0.1580 38999.9n 0.1580 39000.0n 0.6536 39249.9n 0.6536 39250.0n 0.4283 39499.9n 0.4283 39500.0n 0.5439 39749.9n 0.5439 39750.0n 0.5590 39999.9n 0.5590 40000.0n 0.4477 40249.9n 0.4477 40250.0n 0.5397 40499.9n 0.5397 40500.0n 0.3890 40749.9n 0.3890 40750.0n 0.3470 40999.9n 0.3470 41000.0n 0.2021 41249.9n 0.2021 41250.0n 0.0843 41499.9n 0.0843 41500.0n 0.5760 41749.9n 0.5760 41750.0n 0.8682 41999.9n 0.8682 42000.0n 0.7013 42249.9n 0.7013 42250.0n 0.5890 42499.9n 0.5890 42500.0n 0.1667 42749.9n 0.1667 42750.0n 0.3932 42999.9n 0.3932 43000.0n 0.5907 43249.9n 0.5907 43250.0n 0.5177 43499.9n 0.5177 43500.0n 0.6724 43749.9n 0.6724 43750.0n 0.5404 43999.9n 0.5404 44000.0n 0.3299 44249.9n 0.3299 44250.0n 0.5043 44499.9n 0.5043 44500.0n 0.3411 44749.9n 0.3411 44750.0n 0.3129 44999.9n 0.3129 45000.0n 0.5590 45249.9n 0.5590 45250.0n 0.3411 45499.9n 0.3411 45500.0n 0.1580 45749.9n 0.1580 45750.0n 0.8682 45999.9n 0.8682 46000.0n 0.4477 46249.9n 0.4477 46250.0n 0.7020 46499.9n 0.7020 46500.0n 0.5439 46749.9n 0.5439 46750.0n 0.3890 46999.9n 0.3890 47000.0n 0.3470 47249.9n 0.3470 47250.0n 0.3932 47499.9n 0.3932 47500.0n 0.6536 47749.9n 0.6536 47750.0n 0.5177 47999.9n 0.5177 48000.0n 0.5397 48249.9n 0.5397 48250.0n 0.0843 48499.9n 0.0843 48500.0n 0.7013 48749.9n 0.7013 48750.0n 0.8472 48999.9n 0.8472 49000.0n 0.5907 49249.9n 0.5907 49250.0n 0.1667 49499.9n 0.1667 49500.0n 0.5043 49749.9n 0.5043 49750.0n 0.4283 49999.9n 0.4283 50000.0n 0.6724 50249.9n 0.6724 50250.0n 0.5890 50499.9n 0.5890 50500.0n 0.3129 50749.9n 0.3129 50750.0n 0.5093 50999.9n 0.5093 51000.0n 0.5404 51249.9n 0.5404 51250.0n 0.2218 51499.9n 0.2218 51500.0n 0.3299 51749.9n 0.3299 51750.0n 0.2021 51999.9n 0.2021 52000.0n 0.5760 52249.9n 0.5760 52250.0n 0.1052 52499.9n 0.1052 52500.0n 0.3411 52749.9n 0.3411 52750.0n 0.3932 52999.9n 0.3932 53000.0n 0.5093 53249.9n 0.5093 53250.0n 0.2021 53499.9n 0.2021 53500.0n 0.7013 53749.9n 0.7013 53750.0n 0.1052 53999.9n 0.1052 54000.0n 0.8682 54249.9n 0.8682 54250.0n 0.5043 54499.9n 0.5043 54500.0n 0.8472 54749.9n 0.8472 54750.0n 0.2218 54999.9n 0.2218 55000.0n 0.5439 55249.9n 0.5439 55250.0n 0.5397 55499.9n 0.5397 55500.0n 0.5404 55749.9n 0.5404 55750.0n 0.6724 55999.9n 0.6724 56000.0n 0.5177 56249.9n 0.5177 56250.0n 0.5760 56499.9n 0.5760 56500.0n 0.1667 56749.9n 0.1667 56750.0n 0.6536 56999.9n 0.6536 57000.0n 0.5890 57249.9n 0.5890 57250.0n 0.1580 57499.9n 0.1580 57500.0n 0.4283 57749.9n 0.4283 57750.0n 0.5590 57999.9n 0.5590 58000.0n 0.3890 58249.9n 0.3890 58250.0n 0.3299 58499.9n 0.3299 58500.0n 0.5907 58749.9n 0.5907 58750.0n 0.3470 58999.9n 0.3470 59000.0n 0.3129 59249.9n 0.3129 59250.0n 0.4477 59499.9n 0.4477 59500.0n 0.0843 59749.9n 0.0843 59750.0n 0.7020 59999.9n 0.7020 60000.0n 0.2138 60249.9n 0.2138 60250.0n 0.7319 60499.9n 0.7319 60500.0n 0.2331 60749.9n 0.2331 60750.0n 0.4471 60999.9n 0.4471 61000.0n 0.4013 61249.9n 0.4013 61250.0n 0.9457 61499.9n 0.9457 61500.0n 0.5097 61749.9n 0.5097 61750.0n 0.8723 61999.9n 0.8723 62000.0n 0.4973 62249.9n 0.4973 62250.0n 0.6060 62499.9n 0.6060 62500.0n 0.2411 62749.9n 0.2411 62750.0n 0.5312 62999.9n 0.5312 63000.0n 0.3865 63249.9n 0.3865 63250.0n 0.5141 63499.9n 0.5141 63500.0n 0.1083 63749.9n 0.1083 63750.0n 0.0614 63999.9n 0.0614 64000.0n 0.8568 64249.9n 0.8568 64250.0n 0.6264 64499.9n 0.6264 64500.0n 0.3029 64749.9n 0.3029 64750.0n 0.6817 64999.9n 0.6817 65000.0n 0.4354 65249.9n 0.4354 65250.0n 0.5862 65499.9n 0.5862 65500.0n 0.6143 65749.9n 0.6143 65750.0n 0.3802 65999.9n 0.3802 66000.0n 0.3680 66249.9n 0.3680 66250.0n 0.8121 66499.9n 0.8121 66500.0n 0.4490 66749.9n 0.4490 66750.0n 0.5929 66999.9n 0.5929 67000.0n 0.3048 67249.9n 0.3048 67250.0n 0.8267 67499.9n 0.8267 67500.0n 0.4740 67749.9n 0.4740 67750.0n 0.5521 67999.9n 0.5521 68000.0n 0.9338 68249.9n 0.9338 68250.0n 0.3656 68499.9n 0.3656 68500.0n 0.5622 68749.9n 0.5622 68750.0n 0.5334 68999.9n 0.5334 69000.0n 0.7774 69249.9n 0.7774 69250.0n 0.8316 69499.9n 0.8316 69500.0n 0.5113 69749.9n 0.5113 69750.0n 0.6088 69999.9n 0.6088 70000.0n 0.3669 70249.9n 0.3669 70250.0n 0.9084 70499.9n 0.9084 70500.0n 0.8104 70749.9n 0.8104 70750.0n 0.6063 70999.9n 0.6063 71000.0n 0.1875 71249.9n 0.1875 71250.0n 0.1112 71499.9n 0.1112 71500.0n 0.4784 71749.9n 0.4784 71750.0n 0.0881 71999.9n 0.0881 72000.0n 0.5851 72249.9n 0.5851 72250.0n 0.4042 72499.9n 0.4042 72500.0n 0.6963 72749.9n 0.6963 72750.0n 0.1057 72999.9n 0.1057 73000.0n 0.4292 73249.9n 0.4292 73250.0n 0.6392 73499.9n 0.6392 73500.0n 0.5135 73749.9n 0.5135 73750.0n 0.4567 73999.9n 0.4567 74000.0n 0.4059 74249.9n 0.4059 74250.0n 0.8472 74499.9n 0.8472 74500.0n 0.3654 74749.9n 0.3654 74750.0n 0.4791 74999.9n 0.4791 75000.0n 0.5355 75249.9n 0.5355 75250.0n 0.5043 75499.9n 0.5043 75500.0n 0.6280 75749.9n 0.6280 75750.0n 0.6648 75999.9n 0.6648 76000.0n 0.0459 76249.9n 0.0459 76250.0n 0.3319 76499.9n 0.3319 76500.0n 0.6336 76749.9n 0.6336 76750.0n 0.2070 76999.9n 0.2070 77000.0n 0.6373 77249.9n 0.6373 77250.0n 0.6819 77499.9n 0.6819 77500.0n 0.5283 77749.9n 0.5283 77750.0n 0.5807 77999.9n 0.5807 78000.0n 0.4059 78249.9n 0.4059 78250.0n 0.8248 78499.9n 0.8248 78500.0n 0.6426 78749.9n 0.6426 78750.0n 0.2062 78999.9n 0.2062 79000.0n 0.3422 79249.9n 0.3422 79250.0n 0.5134 79499.9n 0.5134 79500.0n 0.8179 79749.9n 0.8179 79750.0n 0.0574 79999.9n 0.0574 80000.0n 0.4426 80249.9n 0.4426 80250.0n 0.4525 80499.9n 0.4525 80500.0n 0.5399 80749.9n 0.5399 80750.0n 0.4722 80999.9n 0.4722 81000.0n 0.3146 81249.9n 0.3146 81250.0n 0.4397 81499.9n 0.4397 81500.0n 0.4580 81749.9n 0.4580 81750.0n 0.5662 81999.9n 0.5662 82000.0n 0.3354 82249.9n 0.3354 82250.0n 0.6251 82499.9n 0.6251 82500.0n 0.8258 82749.9n 0.8258 82750.0n 0.5927 82999.9n 0.5927 83000.0n 0.2081 83249.9n 0.2081 83250.0n 0.5718 83499.9n 0.5718 83500.0n 0.4586 83749.9n 0.4586 83750.0n 0.1625 83999.9n 0.1625 84000.0n 0.6328 84249.9n 0.6328 84250.0n 0.3478 84499.9n 0.3478 84500.0n 0.7903 84749.9n 0.7903 84750.0n 0.4830 84999.9n 0.4830 85000.0n 0.5266 85249.9n 0.5266 85250.0n 0.5618 85499.9n 0.5618 85500.0n 0.4340 85749.9n 0.4340 85750.0n 0.5866 85999.9n 0.5866 86000.0n 0.7652 86249.9n 0.7652 86250.0n 0.5194 86499.9n 0.5194 86500.0n 0.5869 86749.9n 0.5869 86750.0n 0.7936 86999.9n 0.7936 87000.0n 0.0882 87249.9n 0.0882 87250.0n 0.4391 87499.9n 0.4391 87500.0n 0.8216 87749.9n 0.8216 87750.0n 0.6171 87999.9n 0.6171 88000.0n 0.7712 88249.9n 0.7712 88250.0n 0.4128 88499.9n 0.4128 88500.0n 0.3940 88749.9n 0.3940 88750.0n 0.4908 88999.9n 0.4908 89000.0n 0.5167 89249.9n 0.5167 89250.0n 0.5272 89499.9n 0.5272 89500.0n 0.4907 89749.9n 0.4907 89750.0n 0.1824)
Vx2p a_xp2 0 PWL(0.0n 0.2725 249.9n 0.2725 250.0n 0.0756 499.9n 0.0756 500.0n 0.1967 749.9n 0.1967 750.0n 0.2269 999.9n 0.2269 1000.0n 0.5365 1249.9n 0.5365 1250.0n 0.4369 1499.9n 0.4369 1500.0n 0.4846 1749.9n 0.4846 1750.0n 0.5771 1999.9n 0.5771 2000.0n 0.6126 2249.9n 0.6126 2250.0n 0.4086 2499.9n 0.4086 2500.0n 0.1732 2749.9n 0.1732 2750.0n 0.2909 2999.9n 0.2909 3000.0n 0.2292 3249.9n 0.2292 3250.0n 0.4813 3499.9n 0.4813 3500.0n 0.4072 3749.9n 0.4072 3750.0n 0.2279 3999.9n 0.2279 4000.0n 0.6174 4249.9n 0.6174 4250.0n 0.1086 4499.9n 0.1086 4500.0n 0.5072 4749.9n 0.5072 4750.0n 0.1790 4999.9n 0.1790 5000.0n 0.3642 5249.9n 0.3642 5250.0n 0.5018 5499.9n 0.5018 5500.0n 0.5510 5749.9n 0.5510 5750.0n 0.5046 5999.9n 0.5046 6000.0n 0.8881 6249.9n 0.8881 6250.0n 0.3572 6499.9n 0.3572 6500.0n 0.5119 6749.9n 0.5119 6750.0n 0.5168 6999.9n 0.5168 7000.0n 0.5364 7249.9n 0.5364 7250.0n 0.3295 7499.9n 0.3295 7500.0n 0.5510 7749.9n 0.5510 7750.0n 0.1967 7999.9n 0.1967 8000.0n 0.5364 8249.9n 0.5364 8250.0n 0.5168 8499.9n 0.5168 8500.0n 0.6126 8749.9n 0.6126 8750.0n 0.4369 8999.9n 0.4369 9000.0n 0.2269 9249.9n 0.2269 9250.0n 0.1732 9499.9n 0.1732 9500.0n 0.3642 9749.9n 0.3642 9750.0n 0.4846 9999.9n 0.4846 10000.0n 0.5046 10249.9n 0.5046 10250.0n 0.1790 10499.9n 0.1790 10500.0n 0.2292 10749.9n 0.2292 10750.0n 0.4813 10999.9n 0.4813 11000.0n 0.5018 11249.9n 0.5018 11250.0n 0.3572 11499.9n 0.3572 11500.0n 0.3295 11749.9n 0.3295 11750.0n 0.4072 11999.9n 0.4072 12000.0n 0.2725 12249.9n 0.2725 12250.0n 0.5119 12499.9n 0.5119 12500.0n 0.0756 12749.9n 0.0756 12750.0n 0.6174 12999.9n 0.6174 13000.0n 0.5072 13249.9n 0.5072 13250.0n 0.1086 13499.9n 0.1086 13500.0n 0.2909 13749.9n 0.2909 13750.0n 0.5771 13999.9n 0.5771 14000.0n 0.4086 14249.9n 0.4086 14250.0n 0.2279 14499.9n 0.2279 14500.0n 0.8881 14749.9n 0.8881 14750.0n 0.5365 14999.9n 0.5365 15000.0n 0.4072 15249.9n 0.4072 15250.0n 0.4813 15499.9n 0.4813 15500.0n 0.5046 15749.9n 0.5046 15750.0n 0.1732 15999.9n 0.1732 16000.0n 0.2292 16249.9n 0.2292 16250.0n 0.3572 16499.9n 0.3572 16500.0n 0.5364 16749.9n 0.5364 16750.0n 0.5771 16999.9n 0.5771 17000.0n 0.0756 17249.9n 0.0756 17250.0n 0.3295 17499.9n 0.3295 17500.0n 0.3642 17749.9n 0.3642 17750.0n 0.1967 17999.9n 0.1967 18000.0n 0.2909 18249.9n 0.2909 18250.0n 0.1790 18499.9n 0.1790 18500.0n 0.5119 18749.9n 0.5119 18750.0n 0.5018 18999.9n 0.5018 19000.0n 0.4369 19249.9n 0.4369 19250.0n 0.5168 19499.9n 0.5168 19500.0n 0.5510 19749.9n 0.5510 19750.0n 0.5072 19999.9n 0.5072 20000.0n 0.4086 20249.9n 0.4086 20250.0n 0.6126 20499.9n 0.6126 20500.0n 0.6174 20749.9n 0.6174 20750.0n 0.2269 20999.9n 0.2269 21000.0n 0.8881 21249.9n 0.8881 21250.0n 0.4846 21499.9n 0.4846 21500.0n 0.5365 21749.9n 0.5365 21750.0n 0.2279 21999.9n 0.2279 22000.0n 0.1086 22249.9n 0.1086 22250.0n 0.2725 22499.9n 0.2725 22500.0n 0.2279 22749.9n 0.2279 22750.0n 0.5046 22999.9n 0.5046 23000.0n 0.5018 23249.9n 0.5018 23250.0n 0.4072 23499.9n 0.4072 23500.0n 0.5510 23749.9n 0.5510 23750.0n 0.5771 23999.9n 0.5771 24000.0n 0.5365 24249.9n 0.5365 24250.0n 0.1086 24499.9n 0.1086 24500.0n 0.5072 24749.9n 0.5072 24750.0n 0.0756 24999.9n 0.0756 25000.0n 0.3295 25249.9n 0.3295 25250.0n 0.5119 25499.9n 0.5119 25500.0n 0.4086 25749.9n 0.4086 25750.0n 0.8881 25999.9n 0.8881 26000.0n 0.2725 26249.9n 0.2725 26250.0n 0.2909 26499.9n 0.2909 26500.0n 0.2269 26749.9n 0.2269 26750.0n 0.5364 26999.9n 0.5364 27000.0n 0.3642 27249.9n 0.3642 27250.0n 0.6174 27499.9n 0.6174 27500.0n 0.4813 27749.9n 0.4813 27750.0n 0.4369 27999.9n 0.4369 28000.0n 0.1790 28249.9n 0.1790 28250.0n 0.1967 28499.9n 0.1967 28500.0n 0.5168 28749.9n 0.5168 28750.0n 0.2292 28999.9n 0.2292 29000.0n 0.6126 29249.9n 0.6126 29250.0n 0.1732 29499.9n 0.1732 29500.0n 0.4846 29749.9n 0.4846 29750.0n 0.3572 29999.9n 0.3572 30000.0n 0.1967 30249.9n 0.1967 30250.0n 0.3295 30499.9n 0.3295 30500.0n 0.4072 30749.9n 0.4072 30750.0n 0.4086 30999.9n 0.4086 31000.0n 0.5119 31249.9n 0.5119 31250.0n 0.2292 31499.9n 0.2292 31500.0n 0.5771 31749.9n 0.5771 31750.0n 0.4369 31999.9n 0.4369 32000.0n 0.2725 32249.9n 0.2725 32250.0n 0.1790 32499.9n 0.1790 32500.0n 0.8881 32749.9n 0.8881 32750.0n 0.3642 32999.9n 0.3642 33000.0n 0.1732 33249.9n 0.1732 33250.0n 0.5018 33499.9n 0.5018 33500.0n 0.5364 33749.9n 0.5364 33750.0n 0.5168 33999.9n 0.5168 34000.0n 0.2909 34249.9n 0.2909 34250.0n 0.5365 34499.9n 0.5365 34500.0n 0.4846 34749.9n 0.4846 34750.0n 0.5510 34999.9n 0.5510 35000.0n 0.1086 35249.9n 0.1086 35250.0n 0.5072 35499.9n 0.5072 35500.0n 0.0756 35749.9n 0.0756 35750.0n 0.2279 35999.9n 0.2279 36000.0n 0.6126 36249.9n 0.6126 36250.0n 0.5046 36499.9n 0.5046 36500.0n 0.4813 36749.9n 0.4813 36750.0n 0.6174 36999.9n 0.6174 37000.0n 0.3572 37249.9n 0.3572 37250.0n 0.2269 37499.9n 0.2269 37500.0n 0.5072 37749.9n 0.5072 37750.0n 0.5771 37999.9n 0.5771 38000.0n 0.1732 38249.9n 0.1732 38250.0n 0.2725 38499.9n 0.2725 38500.0n 0.4072 38749.9n 0.4072 38750.0n 0.2909 38999.9n 0.2909 39000.0n 0.2279 39249.9n 0.2279 39250.0n 0.3295 39499.9n 0.3295 39500.0n 0.1967 39749.9n 0.1967 39750.0n 0.0756 39999.9n 0.0756 40000.0n 0.5168 40249.9n 0.5168 40250.0n 0.5365 40499.9n 0.5365 40500.0n 0.2269 40749.9n 0.2269 40750.0n 0.5018 40999.9n 0.5018 41000.0n 0.5364 41249.9n 0.5364 41250.0n 0.5119 41499.9n 0.5119 41500.0n 0.4086 41749.9n 0.4086 41750.0n 0.1790 41999.9n 0.1790 42000.0n 0.2292 42249.9n 0.2292 42250.0n 0.4369 42499.9n 0.4369 42500.0n 0.3572 42749.9n 0.3572 42750.0n 0.3642 42999.9n 0.3642 43000.0n 0.4813 43249.9n 0.4813 43250.0n 0.6126 43499.9n 0.6126 43500.0n 0.1086 43749.9n 0.1086 43750.0n 0.6174 43999.9n 0.6174 44000.0n 0.5510 44249.9n 0.5510 44250.0n 0.5046 44499.9n 0.5046 44500.0n 0.4846 44749.9n 0.4846 44750.0n 0.8881 44999.9n 0.8881 45000.0n 0.0756 45249.9n 0.0756 45250.0n 0.4846 45499.9n 0.4846 45500.0n 0.2909 45749.9n 0.2909 45750.0n 0.1790 45999.9n 0.1790 46000.0n 0.5168 46249.9n 0.5168 46250.0n 0.2725 46499.9n 0.2725 46500.0n 0.1967 46749.9n 0.1967 46750.0n 0.2269 46999.9n 0.2269 47000.0n 0.5018 47249.9n 0.5018 47250.0n 0.3642 47499.9n 0.3642 47500.0n 0.2279 47749.9n 0.2279 47750.0n 0.6126 47999.9n 0.6126 48000.0n 0.5365 48249.9n 0.5365 48250.0n 0.5119 48499.9n 0.5119 48500.0n 0.2292 48749.9n 0.2292 48750.0n 0.4072 48999.9n 0.4072 49000.0n 0.4813 49249.9n 0.4813 49250.0n 0.3572 49499.9n 0.3572 49500.0n 0.5046 49749.9n 0.5046 49750.0n 0.3295 49999.9n 0.3295 50000.0n 0.1086 50249.9n 0.1086 50250.0n 0.4369 50499.9n 0.4369 50500.0n 0.8881 50749.9n 0.8881 50750.0n 0.5072 50999.9n 0.5072 51000.0n 0.6174 51249.9n 0.6174 51250.0n 0.1732 51499.9n 0.1732 51500.0n 0.5510 51749.9n 0.5510 51750.0n 0.5364 51999.9n 0.5364 52000.0n 0.4086 52249.9n 0.4086 52250.0n 0.5771 52499.9n 0.5771 52500.0n 0.4846 52749.9n 0.4846 52750.0n 0.3642 52999.9n 0.3642 53000.0n 0.5072 53249.9n 0.5072 53250.0n 0.5364 53499.9n 0.5364 53500.0n 0.2292 53749.9n 0.2292 53750.0n 0.5771 53999.9n 0.5771 54000.0n 0.1790 54249.9n 0.1790 54250.0n 0.5046 54499.9n 0.5046 54500.0n 0.4072 54749.9n 0.4072 54750.0n 0.1732 54999.9n 0.1732 55000.0n 0.1967 55249.9n 0.1967 55250.0n 0.5365 55499.9n 0.5365 55500.0n 0.6174 55749.9n 0.6174 55750.0n 0.1086 55999.9n 0.1086 56000.0n 0.6126 56249.9n 0.6126 56250.0n 0.4086 56499.9n 0.4086 56500.0n 0.3572 56749.9n 0.3572 56750.0n 0.2279 56999.9n 0.2279 57000.0n 0.4369 57249.9n 0.4369 57250.0n 0.2909 57499.9n 0.2909 57500.0n 0.3295 57749.9n 0.3295 57750.0n 0.0756 57999.9n 0.0756 58000.0n 0.2269 58249.9n 0.2269 58250.0n 0.5510 58499.9n 0.5510 58500.0n 0.4813 58749.9n 0.4813 58750.0n 0.5018 58999.9n 0.5018 59000.0n 0.8881 59249.9n 0.8881 59250.0n 0.5168 59499.9n 0.5168 59500.0n 0.5119 59749.9n 0.5119 59750.0n 0.2725 59999.9n 0.2725 60000.0n 0.5628 60249.9n 0.5628 60250.0n 0.7224 60499.9n 0.7224 60500.0n 0.2013 60749.9n 0.2013 60750.0n 0.5698 60999.9n 0.5698 61000.0n 0.5080 61249.9n 0.5080 61250.0n 0.5550 61499.9n 0.5550 61500.0n 0.5064 61749.9n 0.5064 61750.0n 0.6573 61999.9n 0.6573 62000.0n 0.5605 62249.9n 0.5605 62250.0n 0.1019 62499.9n 0.1019 62500.0n 0.1465 62749.9n 0.1465 62750.0n 0.5126 62999.9n 0.5126 63000.0n 0.4447 63249.9n 0.4447 63250.0n 0.4585 63499.9n 0.4585 63500.0n 0.7141 63749.9n 0.7141 63750.0n 0.3288 63999.9n 0.3288 64000.0n 0.7884 64249.9n 0.7884 64250.0n 0.3762 64499.9n 0.3762 64500.0n 0.9071 64749.9n 0.9071 64750.0n 0.4805 64999.9n 0.4805 65000.0n 0.8757 65249.9n 0.8757 65250.0n 0.3833 65499.9n 0.3833 65500.0n 0.8079 65749.9n 0.8079 65750.0n 0.5021 65999.9n 0.5021 66000.0n 0.6169 66249.9n 0.6169 66250.0n 0.3723 66499.9n 0.3723 66500.0n 0.6307 66749.9n 0.6307 66750.0n 0.8091 66999.9n 0.8091 67000.0n 0.2620 67249.9n 0.2620 67250.0n 0.5020 67499.9n 0.5020 67500.0n 0.5238 67749.9n 0.5238 67750.0n 0.1481 67999.9n 0.1481 68000.0n 0.6635 68249.9n 0.6635 68250.0n 0.5848 68499.9n 0.5848 68500.0n 0.5103 68749.9n 0.5103 68750.0n 0.5150 68999.9n 0.5150 69000.0n 0.3443 69249.9n 0.3443 69250.0n 0.6492 69499.9n 0.6492 69500.0n 0.4994 69749.9n 0.4994 69750.0n 0.1510 69999.9n 0.1510 70000.0n 0.4954 70249.9n 0.4954 70250.0n 0.3500 70499.9n 0.3500 70500.0n 0.6256 70749.9n 0.6256 70750.0n 0.0810 70999.9n 0.0810 71000.0n 0.3122 71249.9n 0.3122 71250.0n 0.5624 71499.9n 0.5624 71500.0n 0.5106 71749.9n 0.5106 71750.0n 0.4443 71999.9n 0.4443 72000.0n 0.4803 72249.9n 0.4803 72250.0n 0.5387 72499.9n 0.5387 72500.0n 0.1975 72749.9n 0.1975 72750.0n 0.7840 72999.9n 0.7840 73000.0n 0.5644 73249.9n 0.5644 73250.0n 0.6000 73499.9n 0.6000 73500.0n 0.4892 73749.9n 0.4892 73750.0n 0.4024 73999.9n 0.4024 74000.0n 0.3745 74249.9n 0.3745 74250.0n 0.8031 74499.9n 0.8031 74500.0n 0.4870 74749.9n 0.4870 74750.0n 0.5352 74999.9n 0.5352 75000.0n 0.4469 75249.9n 0.4469 75250.0n 0.5053 75499.9n 0.5053 75500.0n 0.0397 75749.9n 0.0397 75750.0n 0.5362 75999.9n 0.5362 76000.0n 0.5938 76249.9n 0.5938 76250.0n 0.5548 76499.9n 0.5548 76500.0n 0.9446 76749.9n 0.9446 76750.0n 0.7154 76999.9n 0.7154 77000.0n 0.1771 77249.9n 0.1771 77250.0n 0.5497 77499.9n 0.5497 77500.0n 0.4738 77749.9n 0.4738 77750.0n 0.3712 77999.9n 0.3712 78000.0n 0.5352 78249.9n 0.5352 78250.0n 0.6972 78499.9n 0.6972 78500.0n 0.1934 78749.9n 0.1934 78750.0n 0.2946 78999.9n 0.2946 79000.0n 0.4468 79249.9n 0.4468 79250.0n 0.5128 79499.9n 0.5128 79500.0n 0.3398 79749.9n 0.3398 79750.0n 0.3059 79999.9n 0.3059 80000.0n 0.5228 80249.9n 0.5228 80250.0n 0.4967 80499.9n 0.4967 80500.0n 0.5150 80749.9n 0.5150 80750.0n 0.4595 80999.9n 0.4595 81000.0n 0.8423 81249.9n 0.8423 81250.0n 0.4767 81499.9n 0.4767 81500.0n 0.2020 81749.9n 0.2020 81750.0n 0.4152 81999.9n 0.4152 82000.0n 0.8297 82249.9n 0.8297 82250.0n 0.5544 82499.9n 0.5544 82500.0n 0.3106 82749.9n 0.3106 82750.0n 0.5677 82999.9n 0.5677 83000.0n 0.2659 83249.9n 0.2659 83250.0n 0.4821 83499.9n 0.4821 83500.0n 0.5335 83749.9n 0.5335 83750.0n 0.1607 83999.9n 0.1607 84000.0n 0.8245 84249.9n 0.8245 84250.0n 0.7992 84499.9n 0.7992 84500.0n 0.1423 84749.9n 0.1423 84750.0n 0.4480 84999.9n 0.4480 85000.0n 0.5915 85249.9n 0.5915 85250.0n 0.5092 85499.9n 0.5092 85500.0n 0.4901 85749.9n 0.4901 85750.0n 0.5363 85999.9n 0.5363 86000.0n 0.7746 86249.9n 0.7746 86250.0n 0.4996 86499.9n 0.4996 86500.0n 0.2029 86749.9n 0.2029 86750.0n 0.1365 86999.9n 0.1365 87000.0n 0.5936 87249.9n 0.5936 87250.0n 0.4783 87499.9n 0.4783 87500.0n 0.5901 87749.9n 0.5901 87750.0n 0.1198 87999.9n 0.1198 88000.0n 0.3122 88249.9n 0.3122 88250.0n 0.6592 88499.9n 0.6592 88500.0n 0.5009 88749.9n 0.5009 88750.0n 0.4467 88999.9n 0.4467 89000.0n 0.4810 89249.9n 0.4810 89250.0n 0.6896 89499.9n 0.6896 89500.0n 0.5404 89749.9n 0.5404 89750.0n 0.7100)
Vx2n a_xn2 0 PWL(0.0n 0.7275 249.9n 0.7275 250.0n 0.9244 499.9n 0.9244 500.0n 0.8033 749.9n 0.8033 750.0n 0.7731 999.9n 0.7731 1000.0n 0.4635 1249.9n 0.4635 1250.0n 0.5631 1499.9n 0.5631 1500.0n 0.5154 1749.9n 0.5154 1750.0n 0.4229 1999.9n 0.4229 2000.0n 0.3874 2249.9n 0.3874 2250.0n 0.5914 2499.9n 0.5914 2500.0n 0.8268 2749.9n 0.8268 2750.0n 0.7091 2999.9n 0.7091 3000.0n 0.7708 3249.9n 0.7708 3250.0n 0.5187 3499.9n 0.5187 3500.0n 0.5928 3749.9n 0.5928 3750.0n 0.7721 3999.9n 0.7721 4000.0n 0.3826 4249.9n 0.3826 4250.0n 0.8914 4499.9n 0.8914 4500.0n 0.4928 4749.9n 0.4928 4750.0n 0.8210 4999.9n 0.8210 5000.0n 0.6358 5249.9n 0.6358 5250.0n 0.4982 5499.9n 0.4982 5500.0n 0.4490 5749.9n 0.4490 5750.0n 0.4954 5999.9n 0.4954 6000.0n 0.1119 6249.9n 0.1119 6250.0n 0.6428 6499.9n 0.6428 6500.0n 0.4881 6749.9n 0.4881 6750.0n 0.4832 6999.9n 0.4832 7000.0n 0.4636 7249.9n 0.4636 7250.0n 0.6705 7499.9n 0.6705 7500.0n 0.4490 7749.9n 0.4490 7750.0n 0.8033 7999.9n 0.8033 8000.0n 0.4636 8249.9n 0.4636 8250.0n 0.4832 8499.9n 0.4832 8500.0n 0.3874 8749.9n 0.3874 8750.0n 0.5631 8999.9n 0.5631 9000.0n 0.7731 9249.9n 0.7731 9250.0n 0.8268 9499.9n 0.8268 9500.0n 0.6358 9749.9n 0.6358 9750.0n 0.5154 9999.9n 0.5154 10000.0n 0.4954 10249.9n 0.4954 10250.0n 0.8210 10499.9n 0.8210 10500.0n 0.7708 10749.9n 0.7708 10750.0n 0.5187 10999.9n 0.5187 11000.0n 0.4982 11249.9n 0.4982 11250.0n 0.6428 11499.9n 0.6428 11500.0n 0.6705 11749.9n 0.6705 11750.0n 0.5928 11999.9n 0.5928 12000.0n 0.7275 12249.9n 0.7275 12250.0n 0.4881 12499.9n 0.4881 12500.0n 0.9244 12749.9n 0.9244 12750.0n 0.3826 12999.9n 0.3826 13000.0n 0.4928 13249.9n 0.4928 13250.0n 0.8914 13499.9n 0.8914 13500.0n 0.7091 13749.9n 0.7091 13750.0n 0.4229 13999.9n 0.4229 14000.0n 0.5914 14249.9n 0.5914 14250.0n 0.7721 14499.9n 0.7721 14500.0n 0.1119 14749.9n 0.1119 14750.0n 0.4635 14999.9n 0.4635 15000.0n 0.5928 15249.9n 0.5928 15250.0n 0.5187 15499.9n 0.5187 15500.0n 0.4954 15749.9n 0.4954 15750.0n 0.8268 15999.9n 0.8268 16000.0n 0.7708 16249.9n 0.7708 16250.0n 0.6428 16499.9n 0.6428 16500.0n 0.4636 16749.9n 0.4636 16750.0n 0.4229 16999.9n 0.4229 17000.0n 0.9244 17249.9n 0.9244 17250.0n 0.6705 17499.9n 0.6705 17500.0n 0.6358 17749.9n 0.6358 17750.0n 0.8033 17999.9n 0.8033 18000.0n 0.7091 18249.9n 0.7091 18250.0n 0.8210 18499.9n 0.8210 18500.0n 0.4881 18749.9n 0.4881 18750.0n 0.4982 18999.9n 0.4982 19000.0n 0.5631 19249.9n 0.5631 19250.0n 0.4832 19499.9n 0.4832 19500.0n 0.4490 19749.9n 0.4490 19750.0n 0.4928 19999.9n 0.4928 20000.0n 0.5914 20249.9n 0.5914 20250.0n 0.3874 20499.9n 0.3874 20500.0n 0.3826 20749.9n 0.3826 20750.0n 0.7731 20999.9n 0.7731 21000.0n 0.1119 21249.9n 0.1119 21250.0n 0.5154 21499.9n 0.5154 21500.0n 0.4635 21749.9n 0.4635 21750.0n 0.7721 21999.9n 0.7721 22000.0n 0.8914 22249.9n 0.8914 22250.0n 0.7275 22499.9n 0.7275 22500.0n 0.7721 22749.9n 0.7721 22750.0n 0.4954 22999.9n 0.4954 23000.0n 0.4982 23249.9n 0.4982 23250.0n 0.5928 23499.9n 0.5928 23500.0n 0.4490 23749.9n 0.4490 23750.0n 0.4229 23999.9n 0.4229 24000.0n 0.4635 24249.9n 0.4635 24250.0n 0.8914 24499.9n 0.8914 24500.0n 0.4928 24749.9n 0.4928 24750.0n 0.9244 24999.9n 0.9244 25000.0n 0.6705 25249.9n 0.6705 25250.0n 0.4881 25499.9n 0.4881 25500.0n 0.5914 25749.9n 0.5914 25750.0n 0.1119 25999.9n 0.1119 26000.0n 0.7275 26249.9n 0.7275 26250.0n 0.7091 26499.9n 0.7091 26500.0n 0.7731 26749.9n 0.7731 26750.0n 0.4636 26999.9n 0.4636 27000.0n 0.6358 27249.9n 0.6358 27250.0n 0.3826 27499.9n 0.3826 27500.0n 0.5187 27749.9n 0.5187 27750.0n 0.5631 27999.9n 0.5631 28000.0n 0.8210 28249.9n 0.8210 28250.0n 0.8033 28499.9n 0.8033 28500.0n 0.4832 28749.9n 0.4832 28750.0n 0.7708 28999.9n 0.7708 29000.0n 0.3874 29249.9n 0.3874 29250.0n 0.8268 29499.9n 0.8268 29500.0n 0.5154 29749.9n 0.5154 29750.0n 0.6428 29999.9n 0.6428 30000.0n 0.8033 30249.9n 0.8033 30250.0n 0.6705 30499.9n 0.6705 30500.0n 0.5928 30749.9n 0.5928 30750.0n 0.5914 30999.9n 0.5914 31000.0n 0.4881 31249.9n 0.4881 31250.0n 0.7708 31499.9n 0.7708 31500.0n 0.4229 31749.9n 0.4229 31750.0n 0.5631 31999.9n 0.5631 32000.0n 0.7275 32249.9n 0.7275 32250.0n 0.8210 32499.9n 0.8210 32500.0n 0.1119 32749.9n 0.1119 32750.0n 0.6358 32999.9n 0.6358 33000.0n 0.8268 33249.9n 0.8268 33250.0n 0.4982 33499.9n 0.4982 33500.0n 0.4636 33749.9n 0.4636 33750.0n 0.4832 33999.9n 0.4832 34000.0n 0.7091 34249.9n 0.7091 34250.0n 0.4635 34499.9n 0.4635 34500.0n 0.5154 34749.9n 0.5154 34750.0n 0.4490 34999.9n 0.4490 35000.0n 0.8914 35249.9n 0.8914 35250.0n 0.4928 35499.9n 0.4928 35500.0n 0.9244 35749.9n 0.9244 35750.0n 0.7721 35999.9n 0.7721 36000.0n 0.3874 36249.9n 0.3874 36250.0n 0.4954 36499.9n 0.4954 36500.0n 0.5187 36749.9n 0.5187 36750.0n 0.3826 36999.9n 0.3826 37000.0n 0.6428 37249.9n 0.6428 37250.0n 0.7731 37499.9n 0.7731 37500.0n 0.4928 37749.9n 0.4928 37750.0n 0.4229 37999.9n 0.4229 38000.0n 0.8268 38249.9n 0.8268 38250.0n 0.7275 38499.9n 0.7275 38500.0n 0.5928 38749.9n 0.5928 38750.0n 0.7091 38999.9n 0.7091 39000.0n 0.7721 39249.9n 0.7721 39250.0n 0.6705 39499.9n 0.6705 39500.0n 0.8033 39749.9n 0.8033 39750.0n 0.9244 39999.9n 0.9244 40000.0n 0.4832 40249.9n 0.4832 40250.0n 0.4635 40499.9n 0.4635 40500.0n 0.7731 40749.9n 0.7731 40750.0n 0.4982 40999.9n 0.4982 41000.0n 0.4636 41249.9n 0.4636 41250.0n 0.4881 41499.9n 0.4881 41500.0n 0.5914 41749.9n 0.5914 41750.0n 0.8210 41999.9n 0.8210 42000.0n 0.7708 42249.9n 0.7708 42250.0n 0.5631 42499.9n 0.5631 42500.0n 0.6428 42749.9n 0.6428 42750.0n 0.6358 42999.9n 0.6358 43000.0n 0.5187 43249.9n 0.5187 43250.0n 0.3874 43499.9n 0.3874 43500.0n 0.8914 43749.9n 0.8914 43750.0n 0.3826 43999.9n 0.3826 44000.0n 0.4490 44249.9n 0.4490 44250.0n 0.4954 44499.9n 0.4954 44500.0n 0.5154 44749.9n 0.5154 44750.0n 0.1119 44999.9n 0.1119 45000.0n 0.9244 45249.9n 0.9244 45250.0n 0.5154 45499.9n 0.5154 45500.0n 0.7091 45749.9n 0.7091 45750.0n 0.8210 45999.9n 0.8210 46000.0n 0.4832 46249.9n 0.4832 46250.0n 0.7275 46499.9n 0.7275 46500.0n 0.8033 46749.9n 0.8033 46750.0n 0.7731 46999.9n 0.7731 47000.0n 0.4982 47249.9n 0.4982 47250.0n 0.6358 47499.9n 0.6358 47500.0n 0.7721 47749.9n 0.7721 47750.0n 0.3874 47999.9n 0.3874 48000.0n 0.4635 48249.9n 0.4635 48250.0n 0.4881 48499.9n 0.4881 48500.0n 0.7708 48749.9n 0.7708 48750.0n 0.5928 48999.9n 0.5928 49000.0n 0.5187 49249.9n 0.5187 49250.0n 0.6428 49499.9n 0.6428 49500.0n 0.4954 49749.9n 0.4954 49750.0n 0.6705 49999.9n 0.6705 50000.0n 0.8914 50249.9n 0.8914 50250.0n 0.5631 50499.9n 0.5631 50500.0n 0.1119 50749.9n 0.1119 50750.0n 0.4928 50999.9n 0.4928 51000.0n 0.3826 51249.9n 0.3826 51250.0n 0.8268 51499.9n 0.8268 51500.0n 0.4490 51749.9n 0.4490 51750.0n 0.4636 51999.9n 0.4636 52000.0n 0.5914 52249.9n 0.5914 52250.0n 0.4229 52499.9n 0.4229 52500.0n 0.5154 52749.9n 0.5154 52750.0n 0.6358 52999.9n 0.6358 53000.0n 0.4928 53249.9n 0.4928 53250.0n 0.4636 53499.9n 0.4636 53500.0n 0.7708 53749.9n 0.7708 53750.0n 0.4229 53999.9n 0.4229 54000.0n 0.8210 54249.9n 0.8210 54250.0n 0.4954 54499.9n 0.4954 54500.0n 0.5928 54749.9n 0.5928 54750.0n 0.8268 54999.9n 0.8268 55000.0n 0.8033 55249.9n 0.8033 55250.0n 0.4635 55499.9n 0.4635 55500.0n 0.3826 55749.9n 0.3826 55750.0n 0.8914 55999.9n 0.8914 56000.0n 0.3874 56249.9n 0.3874 56250.0n 0.5914 56499.9n 0.5914 56500.0n 0.6428 56749.9n 0.6428 56750.0n 0.7721 56999.9n 0.7721 57000.0n 0.5631 57249.9n 0.5631 57250.0n 0.7091 57499.9n 0.7091 57500.0n 0.6705 57749.9n 0.6705 57750.0n 0.9244 57999.9n 0.9244 58000.0n 0.7731 58249.9n 0.7731 58250.0n 0.4490 58499.9n 0.4490 58500.0n 0.5187 58749.9n 0.5187 58750.0n 0.4982 58999.9n 0.4982 59000.0n 0.1119 59249.9n 0.1119 59250.0n 0.4832 59499.9n 0.4832 59500.0n 0.4881 59749.9n 0.4881 59750.0n 0.7275 59999.9n 0.7275 60000.0n 0.4372 60249.9n 0.4372 60250.0n 0.2776 60499.9n 0.2776 60500.0n 0.7987 60749.9n 0.7987 60750.0n 0.4302 60999.9n 0.4302 61000.0n 0.4920 61249.9n 0.4920 61250.0n 0.4450 61499.9n 0.4450 61500.0n 0.4936 61749.9n 0.4936 61750.0n 0.3427 61999.9n 0.3427 62000.0n 0.4395 62249.9n 0.4395 62250.0n 0.8981 62499.9n 0.8981 62500.0n 0.8535 62749.9n 0.8535 62750.0n 0.4874 62999.9n 0.4874 63000.0n 0.5553 63249.9n 0.5553 63250.0n 0.5415 63499.9n 0.5415 63500.0n 0.2859 63749.9n 0.2859 63750.0n 0.6712 63999.9n 0.6712 64000.0n 0.2116 64249.9n 0.2116 64250.0n 0.6238 64499.9n 0.6238 64500.0n 0.0929 64749.9n 0.0929 64750.0n 0.5195 64999.9n 0.5195 65000.0n 0.1243 65249.9n 0.1243 65250.0n 0.6167 65499.9n 0.6167 65500.0n 0.1921 65749.9n 0.1921 65750.0n 0.4979 65999.9n 0.4979 66000.0n 0.3831 66249.9n 0.3831 66250.0n 0.6277 66499.9n 0.6277 66500.0n 0.3693 66749.9n 0.3693 66750.0n 0.1909 66999.9n 0.1909 67000.0n 0.7380 67249.9n 0.7380 67250.0n 0.4980 67499.9n 0.4980 67500.0n 0.4762 67749.9n 0.4762 67750.0n 0.8519 67999.9n 0.8519 68000.0n 0.3365 68249.9n 0.3365 68250.0n 0.4152 68499.9n 0.4152 68500.0n 0.4897 68749.9n 0.4897 68750.0n 0.4850 68999.9n 0.4850 69000.0n 0.6557 69249.9n 0.6557 69250.0n 0.3508 69499.9n 0.3508 69500.0n 0.5006 69749.9n 0.5006 69750.0n 0.8490 69999.9n 0.8490 70000.0n 0.5046 70249.9n 0.5046 70250.0n 0.6500 70499.9n 0.6500 70500.0n 0.3744 70749.9n 0.3744 70750.0n 0.9190 70999.9n 0.9190 71000.0n 0.6878 71249.9n 0.6878 71250.0n 0.4376 71499.9n 0.4376 71500.0n 0.4894 71749.9n 0.4894 71750.0n 0.5557 71999.9n 0.5557 72000.0n 0.5197 72249.9n 0.5197 72250.0n 0.4613 72499.9n 0.4613 72500.0n 0.8025 72749.9n 0.8025 72750.0n 0.2160 72999.9n 0.2160 73000.0n 0.4356 73249.9n 0.4356 73250.0n 0.4000 73499.9n 0.4000 73500.0n 0.5108 73749.9n 0.5108 73750.0n 0.5976 73999.9n 0.5976 74000.0n 0.6255 74249.9n 0.6255 74250.0n 0.1969 74499.9n 0.1969 74500.0n 0.5130 74749.9n 0.5130 74750.0n 0.4648 74999.9n 0.4648 75000.0n 0.5531 75249.9n 0.5531 75250.0n 0.4947 75499.9n 0.4947 75500.0n 0.9603 75749.9n 0.9603 75750.0n 0.4638 75999.9n 0.4638 76000.0n 0.4062 76249.9n 0.4062 76250.0n 0.4452 76499.9n 0.4452 76500.0n 0.0554 76749.9n 0.0554 76750.0n 0.2846 76999.9n 0.2846 77000.0n 0.8229 77249.9n 0.8229 77250.0n 0.4503 77499.9n 0.4503 77500.0n 0.5262 77749.9n 0.5262 77750.0n 0.6288 77999.9n 0.6288 78000.0n 0.4648 78249.9n 0.4648 78250.0n 0.3028 78499.9n 0.3028 78500.0n 0.8066 78749.9n 0.8066 78750.0n 0.7054 78999.9n 0.7054 79000.0n 0.5532 79249.9n 0.5532 79250.0n 0.4872 79499.9n 0.4872 79500.0n 0.6602 79749.9n 0.6602 79750.0n 0.6941 79999.9n 0.6941 80000.0n 0.4772 80249.9n 0.4772 80250.0n 0.5033 80499.9n 0.5033 80500.0n 0.4850 80749.9n 0.4850 80750.0n 0.5405 80999.9n 0.5405 81000.0n 0.1577 81249.9n 0.1577 81250.0n 0.5233 81499.9n 0.5233 81500.0n 0.7980 81749.9n 0.7980 81750.0n 0.5848 81999.9n 0.5848 82000.0n 0.1703 82249.9n 0.1703 82250.0n 0.4456 82499.9n 0.4456 82500.0n 0.6894 82749.9n 0.6894 82750.0n 0.4323 82999.9n 0.4323 83000.0n 0.7341 83249.9n 0.7341 83250.0n 0.5179 83499.9n 0.5179 83500.0n 0.4665 83749.9n 0.4665 83750.0n 0.8393 83999.9n 0.8393 84000.0n 0.1755 84249.9n 0.1755 84250.0n 0.2008 84499.9n 0.2008 84500.0n 0.8577 84749.9n 0.8577 84750.0n 0.5520 84999.9n 0.5520 85000.0n 0.4085 85249.9n 0.4085 85250.0n 0.4908 85499.9n 0.4908 85500.0n 0.5099 85749.9n 0.5099 85750.0n 0.4637 85999.9n 0.4637 86000.0n 0.2254 86249.9n 0.2254 86250.0n 0.5004 86499.9n 0.5004 86500.0n 0.7971 86749.9n 0.7971 86750.0n 0.8635 86999.9n 0.8635 87000.0n 0.4064 87249.9n 0.4064 87250.0n 0.5217 87499.9n 0.5217 87500.0n 0.4099 87749.9n 0.4099 87750.0n 0.8802 87999.9n 0.8802 88000.0n 0.6878 88249.9n 0.6878 88250.0n 0.3408 88499.9n 0.3408 88500.0n 0.4991 88749.9n 0.4991 88750.0n 0.5533 88999.9n 0.5533 89000.0n 0.5190 89249.9n 0.5190 89250.0n 0.3104 89499.9n 0.3104 89500.0n 0.4596 89749.9n 0.4596 89750.0n 0.2900)
Vxop xop 0 PWL(0.0n 0.7000 249.9n 0.7000 250.0n 0.7000 499.9n 0.7000 500.0n 0.7000 749.9n 0.7000 750.0n 0.7000 999.9n 0.7000 1000.0n 0.3000 1249.9n 0.3000 1250.0n 0.3000 1499.9n 0.3000 1500.0n 0.3000 1749.9n 0.3000 1750.0n 0.7000 1999.9n 0.7000 2000.0n 0.3000 2249.9n 0.3000 2250.0n 0.3000 2499.9n 0.3000 2500.0n 0.7000 2749.9n 0.7000 2750.0n 0.7000 2999.9n 0.7000 3000.0n 0.7000 3249.9n 0.7000 3250.0n 0.3000 3499.9n 0.3000 3500.0n 0.7000 3749.9n 0.7000 3750.0n 0.7000 3999.9n 0.7000 4000.0n 0.3000 4249.9n 0.3000 4250.0n 0.7000 4499.9n 0.7000 4500.0n 0.3000 4749.9n 0.3000 4750.0n 0.7000 4999.9n 0.7000 5000.0n 0.3000 5249.9n 0.3000 5250.0n 0.3000 5499.9n 0.3000 5500.0n 0.3000 5749.9n 0.3000 5750.0n 0.3000 5999.9n 0.3000 6000.0n 0.7000 6249.9n 0.7000 6250.0n 0.7000 6499.9n 0.7000 6500.0n 0.7000 6749.9n 0.7000 6750.0n 0.3000 6999.9n 0.3000 7000.0n 0.7000 7249.9n 0.7000 7250.0n 0.3000 7499.9n 0.3000 7500.0n 0.3000 7749.9n 0.3000 7750.0n 0.7000 7999.9n 0.7000 8000.0n 0.7000 8249.9n 0.7000 8250.0n 0.3000 8499.9n 0.3000 8500.0n 0.3000 8749.9n 0.3000 8750.0n 0.3000 8999.9n 0.3000 9000.0n 0.7000 9249.9n 0.7000 9250.0n 0.7000 9499.9n 0.7000 9500.0n 0.3000 9749.9n 0.3000 9750.0n 0.3000 9999.9n 0.3000 10000.0n 0.3000 10249.9n 0.3000 10250.0n 0.7000 10499.9n 0.7000 10500.0n 0.7000 10749.9n 0.7000 10750.0n 0.3000 10999.9n 0.3000 11000.0n 0.3000 11249.9n 0.3000 11250.0n 0.7000 11499.9n 0.7000 11500.0n 0.3000 11749.9n 0.3000 11750.0n 0.7000 11999.9n 0.7000 12000.0n 0.7000 12249.9n 0.7000 12250.0n 0.7000 12499.9n 0.7000 12500.0n 0.7000 12749.9n 0.7000 12750.0n 0.3000 12999.9n 0.3000 13000.0n 0.3000 13249.9n 0.3000 13250.0n 0.7000 13499.9n 0.7000 13500.0n 0.7000 13749.9n 0.7000 13750.0n 0.7000 13999.9n 0.7000 14000.0n 0.3000 14249.9n 0.3000 14250.0n 0.7000 14499.9n 0.7000 14500.0n 0.7000 14749.9n 0.7000 14750.0n 0.3000 14999.9n 0.3000 15000.0n 0.7000 15249.9n 0.7000 15250.0n 0.3000 15499.9n 0.3000 15500.0n 0.3000 15749.9n 0.3000 15750.0n 0.7000 15999.9n 0.7000 16000.0n 0.7000 16249.9n 0.7000 16250.0n 0.7000 16499.9n 0.7000 16500.0n 0.7000 16749.9n 0.7000 16750.0n 0.7000 16999.9n 0.7000 17000.0n 0.7000 17249.9n 0.7000 17250.0n 0.3000 17499.9n 0.3000 17500.0n 0.3000 17749.9n 0.3000 17750.0n 0.7000 17999.9n 0.7000 18000.0n 0.7000 18249.9n 0.7000 18250.0n 0.7000 18499.9n 0.7000 18500.0n 0.7000 18749.9n 0.7000 18750.0n 0.3000 18999.9n 0.3000 19000.0n 0.3000 19249.9n 0.3000 19250.0n 0.3000 19499.9n 0.3000 19500.0n 0.3000 19749.9n 0.3000 19750.0n 0.3000 19999.9n 0.3000 20000.0n 0.3000 20249.9n 0.3000 20250.0n 0.3000 20499.9n 0.3000 20500.0n 0.3000 20749.9n 0.3000 20750.0n 0.7000 20999.9n 0.7000 21000.0n 0.7000 21249.9n 0.7000 21250.0n 0.3000 21499.9n 0.3000 21500.0n 0.3000 21749.9n 0.3000 21750.0n 0.7000 21999.9n 0.7000 22000.0n 0.7000 22249.9n 0.7000 22250.0n 0.7000 22499.9n 0.7000 22500.0n 0.7000 22749.9n 0.7000 22750.0n 0.3000 22999.9n 0.3000 23000.0n 0.3000 23249.9n 0.3000 23250.0n 0.7000 23499.9n 0.7000 23500.0n 0.3000 23749.9n 0.3000 23750.0n 0.7000 23999.9n 0.7000 24000.0n 0.3000 24249.9n 0.3000 24250.0n 0.7000 24499.9n 0.7000 24500.0n 0.3000 24749.9n 0.3000 24750.0n 0.7000 24999.9n 0.7000 25000.0n 0.3000 25249.9n 0.3000 25250.0n 0.7000 25499.9n 0.7000 25500.0n 0.3000 25749.9n 0.3000 25750.0n 0.7000 25999.9n 0.7000 26000.0n 0.7000 26249.9n 0.7000 26250.0n 0.7000 26499.9n 0.7000 26500.0n 0.7000 26749.9n 0.7000 26750.0n 0.7000 26999.9n 0.7000 27000.0n 0.3000 27249.9n 0.3000 27250.0n 0.3000 27499.9n 0.3000 27500.0n 0.3000 27749.9n 0.3000 27750.0n 0.3000 27999.9n 0.3000 28000.0n 0.7000 28249.9n 0.7000 28250.0n 0.7000 28499.9n 0.7000 28500.0n 0.3000 28749.9n 0.3000 28750.0n 0.7000 28999.9n 0.7000 29000.0n 0.3000 29249.9n 0.3000 29250.0n 0.7000 29499.9n 0.7000 29500.0n 0.3000 29749.9n 0.3000 29750.0n 0.7000 29999.9n 0.7000 30000.0n 0.7000 30249.9n 0.7000 30250.0n 0.3000 30499.9n 0.3000 30500.0n 0.7000 30749.9n 0.7000 30750.0n 0.3000 30999.9n 0.3000 31000.0n 0.7000 31249.9n 0.7000 31250.0n 0.7000 31499.9n 0.7000 31500.0n 0.7000 31749.9n 0.7000 31750.0n 0.3000 31999.9n 0.3000 32000.0n 0.7000 32249.9n 0.7000 32250.0n 0.7000 32499.9n 0.7000 32500.0n 0.7000 32749.9n 0.7000 32750.0n 0.3000 32999.9n 0.3000 33000.0n 0.7000 33249.9n 0.7000 33250.0n 0.3000 33499.9n 0.3000 33500.0n 0.7000 33749.9n 0.7000 33750.0n 0.3000 33999.9n 0.3000 34000.0n 0.7000 34249.9n 0.7000 34250.0n 0.3000 34499.9n 0.3000 34500.0n 0.3000 34749.9n 0.3000 34750.0n 0.3000 34999.9n 0.3000 35000.0n 0.7000 35249.9n 0.7000 35250.0n 0.3000 35499.9n 0.3000 35500.0n 0.7000 35749.9n 0.7000 35750.0n 0.7000 35999.9n 0.7000 36000.0n 0.3000 36249.9n 0.3000 36250.0n 0.3000 36499.9n 0.3000 36500.0n 0.3000 36749.9n 0.3000 36750.0n 0.3000 36999.9n 0.3000 37000.0n 0.7000 37249.9n 0.7000 37250.0n 0.7000 37499.9n 0.7000 37500.0n 0.3000 37749.9n 0.3000 37750.0n 0.7000 37999.9n 0.7000 38000.0n 0.7000 38249.9n 0.7000 38250.0n 0.7000 38499.9n 0.7000 38500.0n 0.7000 38749.9n 0.7000 38750.0n 0.7000 38999.9n 0.7000 39000.0n 0.7000 39249.9n 0.7000 39250.0n 0.3000 39499.9n 0.3000 39500.0n 0.7000 39749.9n 0.7000 39750.0n 0.7000 39999.9n 0.7000 40000.0n 0.3000 40249.9n 0.3000 40250.0n 0.3000 40499.9n 0.3000 40500.0n 0.7000 40749.9n 0.7000 40750.0n 0.3000 40999.9n 0.3000 41000.0n 0.7000 41249.9n 0.7000 41250.0n 0.7000 41499.9n 0.7000 41500.0n 0.3000 41749.9n 0.3000 41750.0n 0.7000 41999.9n 0.7000 42000.0n 0.7000 42249.9n 0.7000 42250.0n 0.3000 42499.9n 0.3000 42500.0n 0.7000 42749.9n 0.7000 42750.0n 0.3000 42999.9n 0.3000 43000.0n 0.3000 43249.9n 0.3000 43250.0n 0.3000 43499.9n 0.3000 43500.0n 0.7000 43749.9n 0.7000 43750.0n 0.3000 43999.9n 0.3000 44000.0n 0.3000 44249.9n 0.3000 44250.0n 0.3000 44499.9n 0.3000 44500.0n 0.3000 44749.9n 0.3000 44750.0n 0.7000 44999.9n 0.7000 45000.0n 0.7000 45249.9n 0.7000 45250.0n 0.3000 45499.9n 0.3000 45500.0n 0.7000 45749.9n 0.7000 45750.0n 0.7000 45999.9n 0.7000 46000.0n 0.3000 46249.9n 0.3000 46250.0n 0.7000 46499.9n 0.7000 46500.0n 0.7000 46749.9n 0.7000 46750.0n 0.7000 46999.9n 0.7000 47000.0n 0.3000 47249.9n 0.3000 47250.0n 0.3000 47499.9n 0.3000 47500.0n 0.7000 47749.9n 0.7000 47750.0n 0.3000 47999.9n 0.3000 48000.0n 0.3000 48249.9n 0.3000 48250.0n 0.7000 48499.9n 0.7000 48500.0n 0.7000 48749.9n 0.7000 48750.0n 0.7000 48999.9n 0.7000 49000.0n 0.3000 49249.9n 0.3000 49250.0n 0.7000 49499.9n 0.7000 49500.0n 0.3000 49749.9n 0.3000 49750.0n 0.3000 49999.9n 0.3000 50000.0n 0.7000 50249.9n 0.7000 50250.0n 0.3000 50499.9n 0.3000 50500.0n 0.7000 50749.9n 0.7000 50750.0n 0.3000 50999.9n 0.3000 51000.0n 0.3000 51249.9n 0.3000 51250.0n 0.7000 51499.9n 0.7000 51500.0n 0.3000 51749.9n 0.3000 51750.0n 0.7000 51999.9n 0.7000 52000.0n 0.3000 52249.9n 0.3000 52250.0n 0.7000 52499.9n 0.7000 52500.0n 0.3000 52749.9n 0.3000 52750.0n 0.3000 52999.9n 0.3000 53000.0n 0.3000 53249.9n 0.3000 53250.0n 0.7000 53499.9n 0.7000 53500.0n 0.7000 53749.9n 0.7000 53750.0n 0.7000 53999.9n 0.7000 54000.0n 0.7000 54249.9n 0.7000 54250.0n 0.3000 54499.9n 0.3000 54500.0n 0.7000 54749.9n 0.7000 54750.0n 0.7000 54999.9n 0.7000 55000.0n 0.7000 55249.9n 0.7000 55250.0n 0.3000 55499.9n 0.3000 55500.0n 0.3000 55749.9n 0.3000 55750.0n 0.7000 55999.9n 0.7000 56000.0n 0.3000 56249.9n 0.3000 56250.0n 0.3000 56499.9n 0.3000 56500.0n 0.7000 56749.9n 0.7000 56750.0n 0.7000 56999.9n 0.7000 57000.0n 0.3000 57249.9n 0.3000 57250.0n 0.7000 57499.9n 0.7000 57500.0n 0.3000 57749.9n 0.3000 57750.0n 0.7000 57999.9n 0.7000 58000.0n 0.7000 58249.9n 0.7000 58250.0n 0.3000 58499.9n 0.3000 58500.0n 0.3000 58749.9n 0.3000 58750.0n 0.3000 58999.9n 0.3000 59000.0n 0.7000 59249.9n 0.7000 59250.0n 0.3000 59499.9n 0.3000 59500.0n 0.7000 59749.9n 0.7000 59750.0n 0.7000 59999.9n 0.7000 60000.0n 0.5000 60249.9n 0.5000 60250.0n 0.5000 60499.9n 0.5000 60500.0n 0.5000 60749.9n 0.5000 60750.0n 0.5000 60999.9n 0.5000 61000.0n 0.5000 61249.9n 0.5000 61250.0n 0.5000 61499.9n 0.5000 61500.0n 0.5000 61749.9n 0.5000 61750.0n 0.5000 61999.9n 0.5000 62000.0n 0.5000 62249.9n 0.5000 62250.0n 0.5000 62499.9n 0.5000 62500.0n 0.5000 62749.9n 0.5000 62750.0n 0.5000 62999.9n 0.5000 63000.0n 0.5000 63249.9n 0.5000 63250.0n 0.5000 63499.9n 0.5000 63500.0n 0.5000 63749.9n 0.5000 63750.0n 0.5000 63999.9n 0.5000 64000.0n 0.5000 64249.9n 0.5000 64250.0n 0.5000 64499.9n 0.5000 64500.0n 0.5000 64749.9n 0.5000 64750.0n 0.5000 64999.9n 0.5000 65000.0n 0.5000 65249.9n 0.5000 65250.0n 0.5000 65499.9n 0.5000 65500.0n 0.5000 65749.9n 0.5000 65750.0n 0.5000 65999.9n 0.5000 66000.0n 0.5000 66249.9n 0.5000 66250.0n 0.5000 66499.9n 0.5000 66500.0n 0.5000 66749.9n 0.5000 66750.0n 0.5000 66999.9n 0.5000 67000.0n 0.5000 67249.9n 0.5000 67250.0n 0.5000 67499.9n 0.5000 67500.0n 0.5000 67749.9n 0.5000 67750.0n 0.5000 67999.9n 0.5000 68000.0n 0.5000 68249.9n 0.5000 68250.0n 0.5000 68499.9n 0.5000 68500.0n 0.5000 68749.9n 0.5000 68750.0n 0.5000 68999.9n 0.5000 69000.0n 0.5000 69249.9n 0.5000 69250.0n 0.5000 69499.9n 0.5000 69500.0n 0.5000 69749.9n 0.5000 69750.0n 0.5000 69999.9n 0.5000 70000.0n 0.5000 70249.9n 0.5000 70250.0n 0.5000 70499.9n 0.5000 70500.0n 0.5000 70749.9n 0.5000 70750.0n 0.5000 70999.9n 0.5000 71000.0n 0.5000 71249.9n 0.5000 71250.0n 0.5000 71499.9n 0.5000 71500.0n 0.5000 71749.9n 0.5000 71750.0n 0.5000 71999.9n 0.5000 72000.0n 0.5000 72249.9n 0.5000 72250.0n 0.5000 72499.9n 0.5000 72500.0n 0.5000 72749.9n 0.5000 72750.0n 0.5000 72999.9n 0.5000 73000.0n 0.5000 73249.9n 0.5000 73250.0n 0.5000 73499.9n 0.5000 73500.0n 0.5000 73749.9n 0.5000 73750.0n 0.5000 73999.9n 0.5000 74000.0n 0.5000 74249.9n 0.5000 74250.0n 0.5000 74499.9n 0.5000 74500.0n 0.5000 74749.9n 0.5000 74750.0n 0.5000 74999.9n 0.5000 75000.0n 0.5000 75249.9n 0.5000 75250.0n 0.5000 75499.9n 0.5000 75500.0n 0.5000 75749.9n 0.5000 75750.0n 0.5000 75999.9n 0.5000 76000.0n 0.5000 76249.9n 0.5000 76250.0n 0.5000 76499.9n 0.5000 76500.0n 0.5000 76749.9n 0.5000 76750.0n 0.5000 76999.9n 0.5000 77000.0n 0.5000 77249.9n 0.5000 77250.0n 0.5000 77499.9n 0.5000 77500.0n 0.5000 77749.9n 0.5000 77750.0n 0.5000 77999.9n 0.5000 78000.0n 0.5000 78249.9n 0.5000 78250.0n 0.5000 78499.9n 0.5000 78500.0n 0.5000 78749.9n 0.5000 78750.0n 0.5000 78999.9n 0.5000 79000.0n 0.5000 79249.9n 0.5000 79250.0n 0.5000 79499.9n 0.5000 79500.0n 0.5000 79749.9n 0.5000 79750.0n 0.5000 79999.9n 0.5000 80000.0n 0.5000 80249.9n 0.5000 80250.0n 0.5000 80499.9n 0.5000 80500.0n 0.5000 80749.9n 0.5000 80750.0n 0.5000 80999.9n 0.5000 81000.0n 0.5000 81249.9n 0.5000 81250.0n 0.5000 81499.9n 0.5000 81500.0n 0.5000 81749.9n 0.5000 81750.0n 0.5000 81999.9n 0.5000 82000.0n 0.5000 82249.9n 0.5000 82250.0n 0.5000 82499.9n 0.5000 82500.0n 0.5000 82749.9n 0.5000 82750.0n 0.5000 82999.9n 0.5000 83000.0n 0.5000 83249.9n 0.5000 83250.0n 0.5000 83499.9n 0.5000 83500.0n 0.5000 83749.9n 0.5000 83750.0n 0.5000 83999.9n 0.5000 84000.0n 0.5000 84249.9n 0.5000 84250.0n 0.5000 84499.9n 0.5000 84500.0n 0.5000 84749.9n 0.5000 84750.0n 0.5000 84999.9n 0.5000 85000.0n 0.5000 85249.9n 0.5000 85250.0n 0.5000 85499.9n 0.5000 85500.0n 0.5000 85749.9n 0.5000 85750.0n 0.5000 85999.9n 0.5000 86000.0n 0.5000 86249.9n 0.5000 86250.0n 0.5000 86499.9n 0.5000 86500.0n 0.5000 86749.9n 0.5000 86750.0n 0.5000 86999.9n 0.5000 87000.0n 0.5000 87249.9n 0.5000 87250.0n 0.5000 87499.9n 0.5000 87500.0n 0.5000 87749.9n 0.5000 87750.0n 0.5000 87999.9n 0.5000 88000.0n 0.5000 88249.9n 0.5000 88250.0n 0.5000 88499.9n 0.5000 88500.0n 0.5000 88749.9n 0.5000 88750.0n 0.5000 88999.9n 0.5000 89000.0n 0.5000 89249.9n 0.5000 89250.0n 0.5000 89499.9n 0.5000 89500.0n 0.5000 89749.9n 0.5000 89750.0n 0.5000)
Vxon xon 0 PWL(0.0n 0.3000 249.9n 0.3000 250.0n 0.3000 499.9n 0.3000 500.0n 0.3000 749.9n 0.3000 750.0n 0.3000 999.9n 0.3000 1000.0n 0.7000 1249.9n 0.7000 1250.0n 0.7000 1499.9n 0.7000 1500.0n 0.7000 1749.9n 0.7000 1750.0n 0.3000 1999.9n 0.3000 2000.0n 0.7000 2249.9n 0.7000 2250.0n 0.7000 2499.9n 0.7000 2500.0n 0.3000 2749.9n 0.3000 2750.0n 0.3000 2999.9n 0.3000 3000.0n 0.3000 3249.9n 0.3000 3250.0n 0.7000 3499.9n 0.7000 3500.0n 0.3000 3749.9n 0.3000 3750.0n 0.3000 3999.9n 0.3000 4000.0n 0.7000 4249.9n 0.7000 4250.0n 0.3000 4499.9n 0.3000 4500.0n 0.7000 4749.9n 0.7000 4750.0n 0.3000 4999.9n 0.3000 5000.0n 0.7000 5249.9n 0.7000 5250.0n 0.7000 5499.9n 0.7000 5500.0n 0.7000 5749.9n 0.7000 5750.0n 0.7000 5999.9n 0.7000 6000.0n 0.3000 6249.9n 0.3000 6250.0n 0.3000 6499.9n 0.3000 6500.0n 0.3000 6749.9n 0.3000 6750.0n 0.7000 6999.9n 0.7000 7000.0n 0.3000 7249.9n 0.3000 7250.0n 0.7000 7499.9n 0.7000 7500.0n 0.7000 7749.9n 0.7000 7750.0n 0.3000 7999.9n 0.3000 8000.0n 0.3000 8249.9n 0.3000 8250.0n 0.7000 8499.9n 0.7000 8500.0n 0.7000 8749.9n 0.7000 8750.0n 0.7000 8999.9n 0.7000 9000.0n 0.3000 9249.9n 0.3000 9250.0n 0.3000 9499.9n 0.3000 9500.0n 0.7000 9749.9n 0.7000 9750.0n 0.7000 9999.9n 0.7000 10000.0n 0.7000 10249.9n 0.7000 10250.0n 0.3000 10499.9n 0.3000 10500.0n 0.3000 10749.9n 0.3000 10750.0n 0.7000 10999.9n 0.7000 11000.0n 0.7000 11249.9n 0.7000 11250.0n 0.3000 11499.9n 0.3000 11500.0n 0.7000 11749.9n 0.7000 11750.0n 0.3000 11999.9n 0.3000 12000.0n 0.3000 12249.9n 0.3000 12250.0n 0.3000 12499.9n 0.3000 12500.0n 0.3000 12749.9n 0.3000 12750.0n 0.7000 12999.9n 0.7000 13000.0n 0.7000 13249.9n 0.7000 13250.0n 0.3000 13499.9n 0.3000 13500.0n 0.3000 13749.9n 0.3000 13750.0n 0.3000 13999.9n 0.3000 14000.0n 0.7000 14249.9n 0.7000 14250.0n 0.3000 14499.9n 0.3000 14500.0n 0.3000 14749.9n 0.3000 14750.0n 0.7000 14999.9n 0.7000 15000.0n 0.3000 15249.9n 0.3000 15250.0n 0.7000 15499.9n 0.7000 15500.0n 0.7000 15749.9n 0.7000 15750.0n 0.3000 15999.9n 0.3000 16000.0n 0.3000 16249.9n 0.3000 16250.0n 0.3000 16499.9n 0.3000 16500.0n 0.3000 16749.9n 0.3000 16750.0n 0.3000 16999.9n 0.3000 17000.0n 0.3000 17249.9n 0.3000 17250.0n 0.7000 17499.9n 0.7000 17500.0n 0.7000 17749.9n 0.7000 17750.0n 0.3000 17999.9n 0.3000 18000.0n 0.3000 18249.9n 0.3000 18250.0n 0.3000 18499.9n 0.3000 18500.0n 0.3000 18749.9n 0.3000 18750.0n 0.7000 18999.9n 0.7000 19000.0n 0.7000 19249.9n 0.7000 19250.0n 0.7000 19499.9n 0.7000 19500.0n 0.7000 19749.9n 0.7000 19750.0n 0.7000 19999.9n 0.7000 20000.0n 0.7000 20249.9n 0.7000 20250.0n 0.7000 20499.9n 0.7000 20500.0n 0.7000 20749.9n 0.7000 20750.0n 0.3000 20999.9n 0.3000 21000.0n 0.3000 21249.9n 0.3000 21250.0n 0.7000 21499.9n 0.7000 21500.0n 0.7000 21749.9n 0.7000 21750.0n 0.3000 21999.9n 0.3000 22000.0n 0.3000 22249.9n 0.3000 22250.0n 0.3000 22499.9n 0.3000 22500.0n 0.3000 22749.9n 0.3000 22750.0n 0.7000 22999.9n 0.7000 23000.0n 0.7000 23249.9n 0.7000 23250.0n 0.3000 23499.9n 0.3000 23500.0n 0.7000 23749.9n 0.7000 23750.0n 0.3000 23999.9n 0.3000 24000.0n 0.7000 24249.9n 0.7000 24250.0n 0.3000 24499.9n 0.3000 24500.0n 0.7000 24749.9n 0.7000 24750.0n 0.3000 24999.9n 0.3000 25000.0n 0.7000 25249.9n 0.7000 25250.0n 0.3000 25499.9n 0.3000 25500.0n 0.7000 25749.9n 0.7000 25750.0n 0.3000 25999.9n 0.3000 26000.0n 0.3000 26249.9n 0.3000 26250.0n 0.3000 26499.9n 0.3000 26500.0n 0.3000 26749.9n 0.3000 26750.0n 0.3000 26999.9n 0.3000 27000.0n 0.7000 27249.9n 0.7000 27250.0n 0.7000 27499.9n 0.7000 27500.0n 0.7000 27749.9n 0.7000 27750.0n 0.7000 27999.9n 0.7000 28000.0n 0.3000 28249.9n 0.3000 28250.0n 0.3000 28499.9n 0.3000 28500.0n 0.7000 28749.9n 0.7000 28750.0n 0.3000 28999.9n 0.3000 29000.0n 0.7000 29249.9n 0.7000 29250.0n 0.3000 29499.9n 0.3000 29500.0n 0.7000 29749.9n 0.7000 29750.0n 0.3000 29999.9n 0.3000 30000.0n 0.3000 30249.9n 0.3000 30250.0n 0.7000 30499.9n 0.7000 30500.0n 0.3000 30749.9n 0.3000 30750.0n 0.7000 30999.9n 0.7000 31000.0n 0.3000 31249.9n 0.3000 31250.0n 0.3000 31499.9n 0.3000 31500.0n 0.3000 31749.9n 0.3000 31750.0n 0.7000 31999.9n 0.7000 32000.0n 0.3000 32249.9n 0.3000 32250.0n 0.3000 32499.9n 0.3000 32500.0n 0.3000 32749.9n 0.3000 32750.0n 0.7000 32999.9n 0.7000 33000.0n 0.3000 33249.9n 0.3000 33250.0n 0.7000 33499.9n 0.7000 33500.0n 0.3000 33749.9n 0.3000 33750.0n 0.7000 33999.9n 0.7000 34000.0n 0.3000 34249.9n 0.3000 34250.0n 0.7000 34499.9n 0.7000 34500.0n 0.7000 34749.9n 0.7000 34750.0n 0.7000 34999.9n 0.7000 35000.0n 0.3000 35249.9n 0.3000 35250.0n 0.7000 35499.9n 0.7000 35500.0n 0.3000 35749.9n 0.3000 35750.0n 0.3000 35999.9n 0.3000 36000.0n 0.7000 36249.9n 0.7000 36250.0n 0.7000 36499.9n 0.7000 36500.0n 0.7000 36749.9n 0.7000 36750.0n 0.7000 36999.9n 0.7000 37000.0n 0.3000 37249.9n 0.3000 37250.0n 0.3000 37499.9n 0.3000 37500.0n 0.7000 37749.9n 0.7000 37750.0n 0.3000 37999.9n 0.3000 38000.0n 0.3000 38249.9n 0.3000 38250.0n 0.3000 38499.9n 0.3000 38500.0n 0.3000 38749.9n 0.3000 38750.0n 0.3000 38999.9n 0.3000 39000.0n 0.3000 39249.9n 0.3000 39250.0n 0.7000 39499.9n 0.7000 39500.0n 0.3000 39749.9n 0.3000 39750.0n 0.3000 39999.9n 0.3000 40000.0n 0.7000 40249.9n 0.7000 40250.0n 0.7000 40499.9n 0.7000 40500.0n 0.3000 40749.9n 0.3000 40750.0n 0.7000 40999.9n 0.7000 41000.0n 0.3000 41249.9n 0.3000 41250.0n 0.3000 41499.9n 0.3000 41500.0n 0.7000 41749.9n 0.7000 41750.0n 0.3000 41999.9n 0.3000 42000.0n 0.3000 42249.9n 0.3000 42250.0n 0.7000 42499.9n 0.7000 42500.0n 0.3000 42749.9n 0.3000 42750.0n 0.7000 42999.9n 0.7000 43000.0n 0.7000 43249.9n 0.7000 43250.0n 0.7000 43499.9n 0.7000 43500.0n 0.3000 43749.9n 0.3000 43750.0n 0.7000 43999.9n 0.7000 44000.0n 0.7000 44249.9n 0.7000 44250.0n 0.7000 44499.9n 0.7000 44500.0n 0.7000 44749.9n 0.7000 44750.0n 0.3000 44999.9n 0.3000 45000.0n 0.3000 45249.9n 0.3000 45250.0n 0.7000 45499.9n 0.7000 45500.0n 0.3000 45749.9n 0.3000 45750.0n 0.3000 45999.9n 0.3000 46000.0n 0.7000 46249.9n 0.7000 46250.0n 0.3000 46499.9n 0.3000 46500.0n 0.3000 46749.9n 0.3000 46750.0n 0.3000 46999.9n 0.3000 47000.0n 0.7000 47249.9n 0.7000 47250.0n 0.7000 47499.9n 0.7000 47500.0n 0.3000 47749.9n 0.3000 47750.0n 0.7000 47999.9n 0.7000 48000.0n 0.7000 48249.9n 0.7000 48250.0n 0.3000 48499.9n 0.3000 48500.0n 0.3000 48749.9n 0.3000 48750.0n 0.3000 48999.9n 0.3000 49000.0n 0.7000 49249.9n 0.7000 49250.0n 0.3000 49499.9n 0.3000 49500.0n 0.7000 49749.9n 0.7000 49750.0n 0.7000 49999.9n 0.7000 50000.0n 0.3000 50249.9n 0.3000 50250.0n 0.7000 50499.9n 0.7000 50500.0n 0.3000 50749.9n 0.3000 50750.0n 0.7000 50999.9n 0.7000 51000.0n 0.7000 51249.9n 0.7000 51250.0n 0.3000 51499.9n 0.3000 51500.0n 0.7000 51749.9n 0.7000 51750.0n 0.3000 51999.9n 0.3000 52000.0n 0.7000 52249.9n 0.7000 52250.0n 0.3000 52499.9n 0.3000 52500.0n 0.7000 52749.9n 0.7000 52750.0n 0.7000 52999.9n 0.7000 53000.0n 0.7000 53249.9n 0.7000 53250.0n 0.3000 53499.9n 0.3000 53500.0n 0.3000 53749.9n 0.3000 53750.0n 0.3000 53999.9n 0.3000 54000.0n 0.3000 54249.9n 0.3000 54250.0n 0.7000 54499.9n 0.7000 54500.0n 0.3000 54749.9n 0.3000 54750.0n 0.3000 54999.9n 0.3000 55000.0n 0.3000 55249.9n 0.3000 55250.0n 0.7000 55499.9n 0.7000 55500.0n 0.7000 55749.9n 0.7000 55750.0n 0.3000 55999.9n 0.3000 56000.0n 0.7000 56249.9n 0.7000 56250.0n 0.7000 56499.9n 0.7000 56500.0n 0.3000 56749.9n 0.3000 56750.0n 0.3000 56999.9n 0.3000 57000.0n 0.7000 57249.9n 0.7000 57250.0n 0.3000 57499.9n 0.3000 57500.0n 0.7000 57749.9n 0.7000 57750.0n 0.3000 57999.9n 0.3000 58000.0n 0.3000 58249.9n 0.3000 58250.0n 0.7000 58499.9n 0.7000 58500.0n 0.7000 58749.9n 0.7000 58750.0n 0.7000 58999.9n 0.7000 59000.0n 0.3000 59249.9n 0.3000 59250.0n 0.7000 59499.9n 0.7000 59500.0n 0.3000 59749.9n 0.3000 59750.0n 0.3000 59999.9n 0.3000 60000.0n 0.5000 60249.9n 0.5000 60250.0n 0.5000 60499.9n 0.5000 60500.0n 0.5000 60749.9n 0.5000 60750.0n 0.5000 60999.9n 0.5000 61000.0n 0.5000 61249.9n 0.5000 61250.0n 0.5000 61499.9n 0.5000 61500.0n 0.5000 61749.9n 0.5000 61750.0n 0.5000 61999.9n 0.5000 62000.0n 0.5000 62249.9n 0.5000 62250.0n 0.5000 62499.9n 0.5000 62500.0n 0.5000 62749.9n 0.5000 62750.0n 0.5000 62999.9n 0.5000 63000.0n 0.5000 63249.9n 0.5000 63250.0n 0.5000 63499.9n 0.5000 63500.0n 0.5000 63749.9n 0.5000 63750.0n 0.5000 63999.9n 0.5000 64000.0n 0.5000 64249.9n 0.5000 64250.0n 0.5000 64499.9n 0.5000 64500.0n 0.5000 64749.9n 0.5000 64750.0n 0.5000 64999.9n 0.5000 65000.0n 0.5000 65249.9n 0.5000 65250.0n 0.5000 65499.9n 0.5000 65500.0n 0.5000 65749.9n 0.5000 65750.0n 0.5000 65999.9n 0.5000 66000.0n 0.5000 66249.9n 0.5000 66250.0n 0.5000 66499.9n 0.5000 66500.0n 0.5000 66749.9n 0.5000 66750.0n 0.5000 66999.9n 0.5000 67000.0n 0.5000 67249.9n 0.5000 67250.0n 0.5000 67499.9n 0.5000 67500.0n 0.5000 67749.9n 0.5000 67750.0n 0.5000 67999.9n 0.5000 68000.0n 0.5000 68249.9n 0.5000 68250.0n 0.5000 68499.9n 0.5000 68500.0n 0.5000 68749.9n 0.5000 68750.0n 0.5000 68999.9n 0.5000 69000.0n 0.5000 69249.9n 0.5000 69250.0n 0.5000 69499.9n 0.5000 69500.0n 0.5000 69749.9n 0.5000 69750.0n 0.5000 69999.9n 0.5000 70000.0n 0.5000 70249.9n 0.5000 70250.0n 0.5000 70499.9n 0.5000 70500.0n 0.5000 70749.9n 0.5000 70750.0n 0.5000 70999.9n 0.5000 71000.0n 0.5000 71249.9n 0.5000 71250.0n 0.5000 71499.9n 0.5000 71500.0n 0.5000 71749.9n 0.5000 71750.0n 0.5000 71999.9n 0.5000 72000.0n 0.5000 72249.9n 0.5000 72250.0n 0.5000 72499.9n 0.5000 72500.0n 0.5000 72749.9n 0.5000 72750.0n 0.5000 72999.9n 0.5000 73000.0n 0.5000 73249.9n 0.5000 73250.0n 0.5000 73499.9n 0.5000 73500.0n 0.5000 73749.9n 0.5000 73750.0n 0.5000 73999.9n 0.5000 74000.0n 0.5000 74249.9n 0.5000 74250.0n 0.5000 74499.9n 0.5000 74500.0n 0.5000 74749.9n 0.5000 74750.0n 0.5000 74999.9n 0.5000 75000.0n 0.5000 75249.9n 0.5000 75250.0n 0.5000 75499.9n 0.5000 75500.0n 0.5000 75749.9n 0.5000 75750.0n 0.5000 75999.9n 0.5000 76000.0n 0.5000 76249.9n 0.5000 76250.0n 0.5000 76499.9n 0.5000 76500.0n 0.5000 76749.9n 0.5000 76750.0n 0.5000 76999.9n 0.5000 77000.0n 0.5000 77249.9n 0.5000 77250.0n 0.5000 77499.9n 0.5000 77500.0n 0.5000 77749.9n 0.5000 77750.0n 0.5000 77999.9n 0.5000 78000.0n 0.5000 78249.9n 0.5000 78250.0n 0.5000 78499.9n 0.5000 78500.0n 0.5000 78749.9n 0.5000 78750.0n 0.5000 78999.9n 0.5000 79000.0n 0.5000 79249.9n 0.5000 79250.0n 0.5000 79499.9n 0.5000 79500.0n 0.5000 79749.9n 0.5000 79750.0n 0.5000 79999.9n 0.5000 80000.0n 0.5000 80249.9n 0.5000 80250.0n 0.5000 80499.9n 0.5000 80500.0n 0.5000 80749.9n 0.5000 80750.0n 0.5000 80999.9n 0.5000 81000.0n 0.5000 81249.9n 0.5000 81250.0n 0.5000 81499.9n 0.5000 81500.0n 0.5000 81749.9n 0.5000 81750.0n 0.5000 81999.9n 0.5000 82000.0n 0.5000 82249.9n 0.5000 82250.0n 0.5000 82499.9n 0.5000 82500.0n 0.5000 82749.9n 0.5000 82750.0n 0.5000 82999.9n 0.5000 83000.0n 0.5000 83249.9n 0.5000 83250.0n 0.5000 83499.9n 0.5000 83500.0n 0.5000 83749.9n 0.5000 83750.0n 0.5000 83999.9n 0.5000 84000.0n 0.5000 84249.9n 0.5000 84250.0n 0.5000 84499.9n 0.5000 84500.0n 0.5000 84749.9n 0.5000 84750.0n 0.5000 84999.9n 0.5000 85000.0n 0.5000 85249.9n 0.5000 85250.0n 0.5000 85499.9n 0.5000 85500.0n 0.5000 85749.9n 0.5000 85750.0n 0.5000 85999.9n 0.5000 86000.0n 0.5000 86249.9n 0.5000 86250.0n 0.5000 86499.9n 0.5000 86500.0n 0.5000 86749.9n 0.5000 86750.0n 0.5000 86999.9n 0.5000 87000.0n 0.5000 87249.9n 0.5000 87250.0n 0.5000 87499.9n 0.5000 87500.0n 0.5000 87749.9n 0.5000 87750.0n 0.5000 87999.9n 0.5000 88000.0n 0.5000 88249.9n 0.5000 88250.0n 0.5000 88499.9n 0.5000 88500.0n 0.5000 88749.9n 0.5000 88750.0n 0.5000 88999.9n 0.5000 89000.0n 0.5000 89249.9n 0.5000 89250.0n 0.5000 89499.9n 0.5000 89500.0n 0.5000 89749.9n 0.5000 89750.0n 0.5000)
Cwp_wih_1_0 wp_wih_1_0 0 30p
Cwn_wih_1_0 wn_wih_1_0 0 30p
Rwp_wih_1_0 wp_wih_1_0 wcm 2g
Rwn_wih_1_0 wn_wih_1_0 wcm 2g
Cwp_wih_2_0 wp_wih_2_0 0 30p
Cwn_wih_2_0 wn_wih_2_0 0 30p
Rwp_wih_2_0 wp_wih_2_0 wcm 2g
Rwn_wih_2_0 wn_wih_2_0 wcm 2g
Cwp_who_0 wp_who_0 0 30p
Cwn_who_0 wn_who_0 0 30p
Rwp_who_0 wp_who_0 wcm 2g
Rwn_who_0 wn_who_0 wcm 2g
Cwp_wih_1_1 wp_wih_1_1 0 30p
Cwn_wih_1_1 wn_wih_1_1 0 30p
Rwp_wih_1_1 wp_wih_1_1 wcm 2g
Rwn_wih_1_1 wn_wih_1_1 wcm 2g
Cwp_wih_2_1 wp_wih_2_1 0 30p
Cwn_wih_2_1 wn_wih_2_1 0 30p
Rwp_wih_2_1 wp_wih_2_1 wcm 2g
Rwn_wih_2_1 wn_wih_2_1 wcm 2g
Cwp_who_1 wp_who_1 0 30p
Cwn_who_1 wn_who_1 0 30p
Rwp_who_1 wp_who_1 wcm 2g
Rwn_who_1 wn_who_1 wcm 2g
Cwp_wih_1_2 wp_wih_1_2 0 30p
Cwn_wih_1_2 wn_wih_1_2 0 30p
Rwp_wih_1_2 wp_wih_1_2 wcm 2g
Rwn_wih_1_2 wn_wih_1_2 wcm 2g
Cwp_wih_2_2 wp_wih_2_2 0 30p
Cwn_wih_2_2 wn_wih_2_2 0 30p
Rwp_wih_2_2 wp_wih_2_2 wcm 2g
Rwn_wih_2_2 wn_wih_2_2 wcm 2g
Cwp_who_2 wp_who_2 0 30p
Cwn_who_2 wn_who_2 0 30p
Rwp_who_2 wp_who_2 wcm 2g
Rwn_who_2 wn_who_2 wcm 2g
Cwp_wih_1_3 wp_wih_1_3 0 30p
Cwn_wih_1_3 wn_wih_1_3 0 30p
Rwp_wih_1_3 wp_wih_1_3 wcm 2g
Rwn_wih_1_3 wn_wih_1_3 wcm 2g
Cwp_wih_2_3 wp_wih_2_3 0 30p
Cwn_wih_2_3 wn_wih_2_3 0 30p
Rwp_wih_2_3 wp_wih_2_3 wcm 2g
Rwn_wih_2_3 wn_wih_2_3 wcm 2g
Cwp_who_3 wp_who_3 0 30p
Cwn_who_3 wn_who_3 0 30p
Rwp_who_3 wp_who_3 wcm 2g
Rwn_who_3 wn_who_3 wcm 2g
Cwp_wih_1_4 wp_wih_1_4 0 30p
Cwn_wih_1_4 wn_wih_1_4 0 30p
Rwp_wih_1_4 wp_wih_1_4 wcm 2g
Rwn_wih_1_4 wn_wih_1_4 wcm 2g
Cwp_wih_2_4 wp_wih_2_4 0 30p
Cwn_wih_2_4 wn_wih_2_4 0 30p
Rwp_wih_2_4 wp_wih_2_4 wcm 2g
Rwn_wih_2_4 wn_wih_2_4 wcm 2g
Cwp_who_4 wp_who_4 0 30p
Cwn_who_4 wn_who_4 0 30p
Rwp_who_4 wp_who_4 wcm 2g
Rwn_who_4 wn_who_4 wcm 2g
Cwp_wih_1_5 wp_wih_1_5 0 30p
Cwn_wih_1_5 wn_wih_1_5 0 30p
Rwp_wih_1_5 wp_wih_1_5 wcm 2g
Rwn_wih_1_5 wn_wih_1_5 wcm 2g
Cwp_wih_2_5 wp_wih_2_5 0 30p
Cwn_wih_2_5 wn_wih_2_5 0 30p
Rwp_wih_2_5 wp_wih_2_5 wcm 2g
Rwn_wih_2_5 wn_wih_2_5 wcm 2g
Cwp_who_5 wp_who_5 0 30p
Cwn_who_5 wn_who_5 0 30p
Rwp_who_5 wp_who_5 wcm 2g
Rwn_who_5 wn_who_5 wcm 2g
Cwp_wih_1_6 wp_wih_1_6 0 30p
Cwn_wih_1_6 wn_wih_1_6 0 30p
Rwp_wih_1_6 wp_wih_1_6 wcm 2g
Rwn_wih_1_6 wn_wih_1_6 wcm 2g
Cwp_wih_2_6 wp_wih_2_6 0 30p
Cwn_wih_2_6 wn_wih_2_6 0 30p
Rwp_wih_2_6 wp_wih_2_6 wcm 2g
Rwn_wih_2_6 wn_wih_2_6 wcm 2g
Cwp_who_6 wp_who_6 0 30p
Cwn_who_6 wn_who_6 0 30p
Rwp_who_6 wp_who_6 wcm 2g
Rwn_who_6 wn_who_6 wcm 2g
Cwp_wih_1_7 wp_wih_1_7 0 30p
Cwn_wih_1_7 wn_wih_1_7 0 30p
Rwp_wih_1_7 wp_wih_1_7 wcm 2g
Rwn_wih_1_7 wn_wih_1_7 wcm 2g
Cwp_wih_2_7 wp_wih_2_7 0 30p
Cwn_wih_2_7 wn_wih_2_7 0 30p
Rwp_wih_2_7 wp_wih_2_7 wcm 2g
Rwn_wih_2_7 wn_wih_2_7 wcm 2g
Cwp_who_7 wp_who_7 0 30p
Cwn_who_7 wn_who_7 0 30p
Rwp_who_7 wp_who_7 wcm 2g
Rwn_who_7 wn_who_7 wcm 2g
Cwp_wih_1_8 wp_wih_1_8 0 30p
Cwn_wih_1_8 wn_wih_1_8 0 30p
Rwp_wih_1_8 wp_wih_1_8 wcm 2g
Rwn_wih_1_8 wn_wih_1_8 wcm 2g
Cwp_wih_2_8 wp_wih_2_8 0 30p
Cwn_wih_2_8 wn_wih_2_8 0 30p
Rwp_wih_2_8 wp_wih_2_8 wcm 2g
Rwn_wih_2_8 wn_wih_2_8 wcm 2g
Cwp_who_8 wp_who_8 0 30p
Cwn_who_8 wn_who_8 0 30p
Rwp_who_8 wp_who_8 wcm 2g
Rwn_who_8 wn_who_8 wcm 2g
Cwp_wih_1_9 wp_wih_1_9 0 30p
Cwn_wih_1_9 wn_wih_1_9 0 30p
Rwp_wih_1_9 wp_wih_1_9 wcm 2g
Rwn_wih_1_9 wn_wih_1_9 wcm 2g
Cwp_wih_2_9 wp_wih_2_9 0 30p
Cwn_wih_2_9 wn_wih_2_9 0 30p
Rwp_wih_2_9 wp_wih_2_9 wcm 2g
Rwn_wih_2_9 wn_wih_2_9 wcm 2g
Cwp_who_9 wp_who_9 0 30p
Cwn_who_9 wn_who_9 0 30p
Rwp_who_9 wp_who_9 wcm 2g
Rwn_who_9 wn_who_9 wcm 2g
Cwp_wih_1_10 wp_wih_1_10 0 30p
Cwn_wih_1_10 wn_wih_1_10 0 30p
Rwp_wih_1_10 wp_wih_1_10 wcm 2g
Rwn_wih_1_10 wn_wih_1_10 wcm 2g
Cwp_wih_2_10 wp_wih_2_10 0 30p
Cwn_wih_2_10 wn_wih_2_10 0 30p
Rwp_wih_2_10 wp_wih_2_10 wcm 2g
Rwn_wih_2_10 wn_wih_2_10 wcm 2g
Cwp_who_10 wp_who_10 0 30p
Cwn_who_10 wn_who_10 0 30p
Rwp_who_10 wp_who_10 wcm 2g
Rwn_who_10 wn_who_10 wcm 2g
Cwp_wih_1_11 wp_wih_1_11 0 30p
Cwn_wih_1_11 wn_wih_1_11 0 30p
Rwp_wih_1_11 wp_wih_1_11 wcm 2g
Rwn_wih_1_11 wn_wih_1_11 wcm 2g
Cwp_wih_2_11 wp_wih_2_11 0 30p
Cwn_wih_2_11 wn_wih_2_11 0 30p
Rwp_wih_2_11 wp_wih_2_11 wcm 2g
Rwn_wih_2_11 wn_wih_2_11 wcm 2g
Cwp_who_11 wp_who_11 0 30p
Cwn_who_11 wn_who_11 0 30p
Rwp_who_11 wp_who_11 wcm 2g
Rwn_who_11 wn_who_11 wcm 2g
Cwp_wih_1_12 wp_wih_1_12 0 30p
Cwn_wih_1_12 wn_wih_1_12 0 30p
Rwp_wih_1_12 wp_wih_1_12 wcm 2g
Rwn_wih_1_12 wn_wih_1_12 wcm 2g
Cwp_wih_2_12 wp_wih_2_12 0 30p
Cwn_wih_2_12 wn_wih_2_12 0 30p
Rwp_wih_2_12 wp_wih_2_12 wcm 2g
Rwn_wih_2_12 wn_wih_2_12 wcm 2g
Cwp_who_12 wp_who_12 0 30p
Cwn_who_12 wn_who_12 0 30p
Rwp_who_12 wp_who_12 wcm 2g
Rwn_who_12 wn_who_12 wcm 2g
Cwp_wih_1_13 wp_wih_1_13 0 30p
Cwn_wih_1_13 wn_wih_1_13 0 30p
Rwp_wih_1_13 wp_wih_1_13 wcm 2g
Rwn_wih_1_13 wn_wih_1_13 wcm 2g
Cwp_wih_2_13 wp_wih_2_13 0 30p
Cwn_wih_2_13 wn_wih_2_13 0 30p
Rwp_wih_2_13 wp_wih_2_13 wcm 2g
Rwn_wih_2_13 wn_wih_2_13 wcm 2g
Cwp_who_13 wp_who_13 0 30p
Cwn_who_13 wn_who_13 0 30p
Rwp_who_13 wp_who_13 wcm 2g
Rwn_who_13 wn_who_13 wcm 2g
Cwp_wih_1_14 wp_wih_1_14 0 30p
Cwn_wih_1_14 wn_wih_1_14 0 30p
Rwp_wih_1_14 wp_wih_1_14 wcm 2g
Rwn_wih_1_14 wn_wih_1_14 wcm 2g
Cwp_wih_2_14 wp_wih_2_14 0 30p
Cwn_wih_2_14 wn_wih_2_14 0 30p
Rwp_wih_2_14 wp_wih_2_14 wcm 2g
Rwn_wih_2_14 wn_wih_2_14 wcm 2g
Cwp_who_14 wp_who_14 0 30p
Cwn_who_14 wn_who_14 0 30p
Rwp_who_14 wp_who_14 wcm 2g
Rwn_who_14 wn_who_14 wcm 2g
Cwp_wih_1_15 wp_wih_1_15 0 30p
Cwn_wih_1_15 wn_wih_1_15 0 30p
Rwp_wih_1_15 wp_wih_1_15 wcm 2g
Rwn_wih_1_15 wn_wih_1_15 wcm 2g
Cwp_wih_2_15 wp_wih_2_15 0 30p
Cwn_wih_2_15 wn_wih_2_15 0 30p
Rwp_wih_2_15 wp_wih_2_15 wcm 2g
Rwn_wih_2_15 wn_wih_2_15 wcm 2g
Cwp_who_15 wp_who_15 0 30p
Cwn_who_15 wn_who_15 0 30p
Rwp_who_15 wp_who_15 wcm 2g
Rwn_who_15 wn_who_15 wcm 2g
Cwp_wih_1_16 wp_wih_1_16 0 30p
Cwn_wih_1_16 wn_wih_1_16 0 30p
Rwp_wih_1_16 wp_wih_1_16 wcm 2g
Rwn_wih_1_16 wn_wih_1_16 wcm 2g
Cwp_wih_2_16 wp_wih_2_16 0 30p
Cwn_wih_2_16 wn_wih_2_16 0 30p
Rwp_wih_2_16 wp_wih_2_16 wcm 2g
Rwn_wih_2_16 wn_wih_2_16 wcm 2g
Cwp_who_16 wp_who_16 0 30p
Cwn_who_16 wn_who_16 0 30p
Rwp_who_16 wp_who_16 wcm 2g
Rwn_who_16 wn_who_16 wcm 2g
Cwp_wih_1_17 wp_wih_1_17 0 30p
Cwn_wih_1_17 wn_wih_1_17 0 30p
Rwp_wih_1_17 wp_wih_1_17 wcm 2g
Rwn_wih_1_17 wn_wih_1_17 wcm 2g
Cwp_wih_2_17 wp_wih_2_17 0 30p
Cwn_wih_2_17 wn_wih_2_17 0 30p
Rwp_wih_2_17 wp_wih_2_17 wcm 2g
Rwn_wih_2_17 wn_wih_2_17 wcm 2g
Cwp_who_17 wp_who_17 0 30p
Cwn_who_17 wn_who_17 0 30p
Rwp_who_17 wp_who_17 wcm 2g
Rwn_who_17 wn_who_17 wcm 2g
Cwp_wih_1_18 wp_wih_1_18 0 30p
Cwn_wih_1_18 wn_wih_1_18 0 30p
Rwp_wih_1_18 wp_wih_1_18 wcm 2g
Rwn_wih_1_18 wn_wih_1_18 wcm 2g
Cwp_wih_2_18 wp_wih_2_18 0 30p
Cwn_wih_2_18 wn_wih_2_18 0 30p
Rwp_wih_2_18 wp_wih_2_18 wcm 2g
Rwn_wih_2_18 wn_wih_2_18 wcm 2g
Cwp_who_18 wp_who_18 0 30p
Cwn_who_18 wn_who_18 0 30p
Rwp_who_18 wp_who_18 wcm 2g
Rwn_who_18 wn_who_18 wcm 2g
Cwp_wih_1_19 wp_wih_1_19 0 30p
Cwn_wih_1_19 wn_wih_1_19 0 30p
Rwp_wih_1_19 wp_wih_1_19 wcm 2g
Rwn_wih_1_19 wn_wih_1_19 wcm 2g
Cwp_wih_2_19 wp_wih_2_19 0 30p
Cwn_wih_2_19 wn_wih_2_19 0 30p
Rwp_wih_2_19 wp_wih_2_19 wcm 2g
Rwn_wih_2_19 wn_wih_2_19 wcm 2g
Cwp_who_19 wp_who_19 0 30p
Cwn_who_19 wn_who_19 0 30p
Rwp_who_19 wp_who_19 wcm 2g
Rwn_who_19 wn_who_19 wcm 2g
Cwp_wih_1_20 wp_wih_1_20 0 30p
Cwn_wih_1_20 wn_wih_1_20 0 30p
Rwp_wih_1_20 wp_wih_1_20 wcm 2g
Rwn_wih_1_20 wn_wih_1_20 wcm 2g
Cwp_wih_2_20 wp_wih_2_20 0 30p
Cwn_wih_2_20 wn_wih_2_20 0 30p
Rwp_wih_2_20 wp_wih_2_20 wcm 2g
Rwn_wih_2_20 wn_wih_2_20 wcm 2g
Cwp_who_20 wp_who_20 0 30p
Cwn_who_20 wn_who_20 0 30p
Rwp_who_20 wp_who_20 wcm 2g
Rwn_who_20 wn_who_20 wcm 2g
Cwp_wih_1_21 wp_wih_1_21 0 30p
Cwn_wih_1_21 wn_wih_1_21 0 30p
Rwp_wih_1_21 wp_wih_1_21 wcm 2g
Rwn_wih_1_21 wn_wih_1_21 wcm 2g
Cwp_wih_2_21 wp_wih_2_21 0 30p
Cwn_wih_2_21 wn_wih_2_21 0 30p
Rwp_wih_2_21 wp_wih_2_21 wcm 2g
Rwn_wih_2_21 wn_wih_2_21 wcm 2g
Cwp_who_21 wp_who_21 0 30p
Cwn_who_21 wn_who_21 0 30p
Rwp_who_21 wp_who_21 wcm 2g
Rwn_who_21 wn_who_21 wcm 2g
Cwp_wih_1_22 wp_wih_1_22 0 30p
Cwn_wih_1_22 wn_wih_1_22 0 30p
Rwp_wih_1_22 wp_wih_1_22 wcm 2g
Rwn_wih_1_22 wn_wih_1_22 wcm 2g
Cwp_wih_2_22 wp_wih_2_22 0 30p
Cwn_wih_2_22 wn_wih_2_22 0 30p
Rwp_wih_2_22 wp_wih_2_22 wcm 2g
Rwn_wih_2_22 wn_wih_2_22 wcm 2g
Cwp_who_22 wp_who_22 0 30p
Cwn_who_22 wn_who_22 0 30p
Rwp_who_22 wp_who_22 wcm 2g
Rwn_who_22 wn_who_22 wcm 2g
Cwp_wih_1_23 wp_wih_1_23 0 30p
Cwn_wih_1_23 wn_wih_1_23 0 30p
Rwp_wih_1_23 wp_wih_1_23 wcm 2g
Rwn_wih_1_23 wn_wih_1_23 wcm 2g
Cwp_wih_2_23 wp_wih_2_23 0 30p
Cwn_wih_2_23 wn_wih_2_23 0 30p
Rwp_wih_2_23 wp_wih_2_23 wcm 2g
Rwn_wih_2_23 wn_wih_2_23 wcm 2g
Cwp_who_23 wp_who_23 0 30p
Cwn_who_23 wn_who_23 0 30p
Rwp_who_23 wp_who_23 wcm 2g
Rwn_who_23 wn_who_23 wcm 2g
Cwp_wih_1_24 wp_wih_1_24 0 30p
Cwn_wih_1_24 wn_wih_1_24 0 30p
Rwp_wih_1_24 wp_wih_1_24 wcm 2g
Rwn_wih_1_24 wn_wih_1_24 wcm 2g
Cwp_wih_2_24 wp_wih_2_24 0 30p
Cwn_wih_2_24 wn_wih_2_24 0 30p
Rwp_wih_2_24 wp_wih_2_24 wcm 2g
Rwn_wih_2_24 wn_wih_2_24 wcm 2g
Cwp_who_24 wp_who_24 0 30p
Cwn_who_24 wn_who_24 0 30p
Rwp_who_24 wp_who_24 wcm 2g
Rwn_who_24 wn_who_24 wcm 2g
Cwp_wih_1_25 wp_wih_1_25 0 30p
Cwn_wih_1_25 wn_wih_1_25 0 30p
Rwp_wih_1_25 wp_wih_1_25 wcm 2g
Rwn_wih_1_25 wn_wih_1_25 wcm 2g
Cwp_wih_2_25 wp_wih_2_25 0 30p
Cwn_wih_2_25 wn_wih_2_25 0 30p
Rwp_wih_2_25 wp_wih_2_25 wcm 2g
Rwn_wih_2_25 wn_wih_2_25 wcm 2g
Cwp_who_25 wp_who_25 0 30p
Cwn_who_25 wn_who_25 0 30p
Rwp_who_25 wp_who_25 wcm 2g
Rwn_who_25 wn_who_25 wcm 2g
Cwp_wih_1_26 wp_wih_1_26 0 30p
Cwn_wih_1_26 wn_wih_1_26 0 30p
Rwp_wih_1_26 wp_wih_1_26 wcm 2g
Rwn_wih_1_26 wn_wih_1_26 wcm 2g
Cwp_wih_2_26 wp_wih_2_26 0 30p
Cwn_wih_2_26 wn_wih_2_26 0 30p
Rwp_wih_2_26 wp_wih_2_26 wcm 2g
Rwn_wih_2_26 wn_wih_2_26 wcm 2g
Cwp_who_26 wp_who_26 0 30p
Cwn_who_26 wn_who_26 0 30p
Rwp_who_26 wp_who_26 wcm 2g
Rwn_who_26 wn_who_26 wcm 2g
Cwp_wih_1_27 wp_wih_1_27 0 30p
Cwn_wih_1_27 wn_wih_1_27 0 30p
Rwp_wih_1_27 wp_wih_1_27 wcm 2g
Rwn_wih_1_27 wn_wih_1_27 wcm 2g
Cwp_wih_2_27 wp_wih_2_27 0 30p
Cwn_wih_2_27 wn_wih_2_27 0 30p
Rwp_wih_2_27 wp_wih_2_27 wcm 2g
Rwn_wih_2_27 wn_wih_2_27 wcm 2g
Cwp_who_27 wp_who_27 0 30p
Cwn_who_27 wn_who_27 0 30p
Rwp_who_27 wp_who_27 wcm 2g
Rwn_who_27 wn_who_27 wcm 2g
Cwp_wih_1_28 wp_wih_1_28 0 30p
Cwn_wih_1_28 wn_wih_1_28 0 30p
Rwp_wih_1_28 wp_wih_1_28 wcm 2g
Rwn_wih_1_28 wn_wih_1_28 wcm 2g
Cwp_wih_2_28 wp_wih_2_28 0 30p
Cwn_wih_2_28 wn_wih_2_28 0 30p
Rwp_wih_2_28 wp_wih_2_28 wcm 2g
Rwn_wih_2_28 wn_wih_2_28 wcm 2g
Cwp_who_28 wp_who_28 0 30p
Cwn_who_28 wn_who_28 0 30p
Rwp_who_28 wp_who_28 wcm 2g
Rwn_who_28 wn_who_28 wcm 2g
Cwp_wih_1_29 wp_wih_1_29 0 30p
Cwn_wih_1_29 wn_wih_1_29 0 30p
Rwp_wih_1_29 wp_wih_1_29 wcm 2g
Rwn_wih_1_29 wn_wih_1_29 wcm 2g
Cwp_wih_2_29 wp_wih_2_29 0 30p
Cwn_wih_2_29 wn_wih_2_29 0 30p
Rwp_wih_2_29 wp_wih_2_29 wcm 2g
Rwn_wih_2_29 wn_wih_2_29 wcm 2g
Cwp_who_29 wp_who_29 0 30p
Cwn_who_29 wn_who_29 0 30p
Rwp_who_29 wp_who_29 wcm 2g
Rwn_who_29 wn_who_29 wcm 2g
Cwp_wih_1_30 wp_wih_1_30 0 30p
Cwn_wih_1_30 wn_wih_1_30 0 30p
Rwp_wih_1_30 wp_wih_1_30 wcm 2g
Rwn_wih_1_30 wn_wih_1_30 wcm 2g
Cwp_wih_2_30 wp_wih_2_30 0 30p
Cwn_wih_2_30 wn_wih_2_30 0 30p
Rwp_wih_2_30 wp_wih_2_30 wcm 2g
Rwn_wih_2_30 wn_wih_2_30 wcm 2g
Cwp_who_30 wp_who_30 0 30p
Cwn_who_30 wn_who_30 0 30p
Rwp_who_30 wp_who_30 wcm 2g
Rwn_who_30 wn_who_30 wcm 2g
Cwp_wih_1_31 wp_wih_1_31 0 30p
Cwn_wih_1_31 wn_wih_1_31 0 30p
Rwp_wih_1_31 wp_wih_1_31 wcm 2g
Rwn_wih_1_31 wn_wih_1_31 wcm 2g
Cwp_wih_2_31 wp_wih_2_31 0 30p
Cwn_wih_2_31 wn_wih_2_31 0 30p
Rwp_wih_2_31 wp_wih_2_31 wcm 2g
Rwn_wih_2_31 wn_wih_2_31 wcm 2g
Cwp_who_31 wp_who_31 0 30p
Cwn_who_31 wn_who_31 0 30p
Rwp_who_31 wp_who_31 wcm 2g
Rwn_who_31 wn_who_31 wcm 2g
Cwp_wih_1_32 wp_wih_1_32 0 30p
Cwn_wih_1_32 wn_wih_1_32 0 30p
Rwp_wih_1_32 wp_wih_1_32 wcm 2g
Rwn_wih_1_32 wn_wih_1_32 wcm 2g
Cwp_wih_2_32 wp_wih_2_32 0 30p
Cwn_wih_2_32 wn_wih_2_32 0 30p
Rwp_wih_2_32 wp_wih_2_32 wcm 2g
Rwn_wih_2_32 wn_wih_2_32 wcm 2g
Cwp_who_32 wp_who_32 0 30p
Cwn_who_32 wn_who_32 0 30p
Rwp_who_32 wp_who_32 wcm 2g
Rwn_who_32 wn_who_32 wcm 2g
Cwp_wih_1_33 wp_wih_1_33 0 30p
Cwn_wih_1_33 wn_wih_1_33 0 30p
Rwp_wih_1_33 wp_wih_1_33 wcm 2g
Rwn_wih_1_33 wn_wih_1_33 wcm 2g
Cwp_wih_2_33 wp_wih_2_33 0 30p
Cwn_wih_2_33 wn_wih_2_33 0 30p
Rwp_wih_2_33 wp_wih_2_33 wcm 2g
Rwn_wih_2_33 wn_wih_2_33 wcm 2g
Cwp_who_33 wp_who_33 0 30p
Cwn_who_33 wn_who_33 0 30p
Rwp_who_33 wp_who_33 wcm 2g
Rwn_who_33 wn_who_33 wcm 2g
Cwp_wih_1_34 wp_wih_1_34 0 30p
Cwn_wih_1_34 wn_wih_1_34 0 30p
Rwp_wih_1_34 wp_wih_1_34 wcm 2g
Rwn_wih_1_34 wn_wih_1_34 wcm 2g
Cwp_wih_2_34 wp_wih_2_34 0 30p
Cwn_wih_2_34 wn_wih_2_34 0 30p
Rwp_wih_2_34 wp_wih_2_34 wcm 2g
Rwn_wih_2_34 wn_wih_2_34 wcm 2g
Cwp_who_34 wp_who_34 0 30p
Cwn_who_34 wn_who_34 0 30p
Rwp_who_34 wp_who_34 wcm 2g
Rwn_who_34 wn_who_34 wcm 2g
Cwp_wih_1_35 wp_wih_1_35 0 30p
Cwn_wih_1_35 wn_wih_1_35 0 30p
Rwp_wih_1_35 wp_wih_1_35 wcm 2g
Rwn_wih_1_35 wn_wih_1_35 wcm 2g
Cwp_wih_2_35 wp_wih_2_35 0 30p
Cwn_wih_2_35 wn_wih_2_35 0 30p
Rwp_wih_2_35 wp_wih_2_35 wcm 2g
Rwn_wih_2_35 wn_wih_2_35 wcm 2g
Cwp_who_35 wp_who_35 0 30p
Cwn_who_35 wn_who_35 0 30p
Rwp_who_35 wp_who_35 wcm 2g
Rwn_who_35 wn_who_35 wcm 2g
Cwp_wih_1_36 wp_wih_1_36 0 30p
Cwn_wih_1_36 wn_wih_1_36 0 30p
Rwp_wih_1_36 wp_wih_1_36 wcm 2g
Rwn_wih_1_36 wn_wih_1_36 wcm 2g
Cwp_wih_2_36 wp_wih_2_36 0 30p
Cwn_wih_2_36 wn_wih_2_36 0 30p
Rwp_wih_2_36 wp_wih_2_36 wcm 2g
Rwn_wih_2_36 wn_wih_2_36 wcm 2g
Cwp_who_36 wp_who_36 0 30p
Cwn_who_36 wn_who_36 0 30p
Rwp_who_36 wp_who_36 wcm 2g
Rwn_who_36 wn_who_36 wcm 2g
Cwp_wih_1_37 wp_wih_1_37 0 30p
Cwn_wih_1_37 wn_wih_1_37 0 30p
Rwp_wih_1_37 wp_wih_1_37 wcm 2g
Rwn_wih_1_37 wn_wih_1_37 wcm 2g
Cwp_wih_2_37 wp_wih_2_37 0 30p
Cwn_wih_2_37 wn_wih_2_37 0 30p
Rwp_wih_2_37 wp_wih_2_37 wcm 2g
Rwn_wih_2_37 wn_wih_2_37 wcm 2g
Cwp_who_37 wp_who_37 0 30p
Cwn_who_37 wn_who_37 0 30p
Rwp_who_37 wp_who_37 wcm 2g
Rwn_who_37 wn_who_37 wcm 2g
Cwp_wih_1_38 wp_wih_1_38 0 30p
Cwn_wih_1_38 wn_wih_1_38 0 30p
Rwp_wih_1_38 wp_wih_1_38 wcm 2g
Rwn_wih_1_38 wn_wih_1_38 wcm 2g
Cwp_wih_2_38 wp_wih_2_38 0 30p
Cwn_wih_2_38 wn_wih_2_38 0 30p
Rwp_wih_2_38 wp_wih_2_38 wcm 2g
Rwn_wih_2_38 wn_wih_2_38 wcm 2g
Cwp_who_38 wp_who_38 0 30p
Cwn_who_38 wn_who_38 0 30p
Rwp_who_38 wp_who_38 wcm 2g
Rwn_who_38 wn_who_38 wcm 2g
Cwp_wih_1_39 wp_wih_1_39 0 30p
Cwn_wih_1_39 wn_wih_1_39 0 30p
Rwp_wih_1_39 wp_wih_1_39 wcm 2g
Rwn_wih_1_39 wn_wih_1_39 wcm 2g
Cwp_wih_2_39 wp_wih_2_39 0 30p
Cwn_wih_2_39 wn_wih_2_39 0 30p
Rwp_wih_2_39 wp_wih_2_39 wcm 2g
Rwn_wih_2_39 wn_wih_2_39 wcm 2g
Cwp_who_39 wp_who_39 0 30p
Cwn_who_39 wn_who_39 0 30p
Rwp_who_39 wp_who_39 wcm 2g
Rwn_who_39 wn_who_39 wcm 2g
Cwp_wih_1_40 wp_wih_1_40 0 30p
Cwn_wih_1_40 wn_wih_1_40 0 30p
Rwp_wih_1_40 wp_wih_1_40 wcm 2g
Rwn_wih_1_40 wn_wih_1_40 wcm 2g
Cwp_wih_2_40 wp_wih_2_40 0 30p
Cwn_wih_2_40 wn_wih_2_40 0 30p
Rwp_wih_2_40 wp_wih_2_40 wcm 2g
Rwn_wih_2_40 wn_wih_2_40 wcm 2g
Cwp_who_40 wp_who_40 0 30p
Cwn_who_40 wn_who_40 0 30p
Rwp_who_40 wp_who_40 wcm 2g
Rwn_who_40 wn_who_40 wcm 2g
Cwp_wih_1_41 wp_wih_1_41 0 30p
Cwn_wih_1_41 wn_wih_1_41 0 30p
Rwp_wih_1_41 wp_wih_1_41 wcm 2g
Rwn_wih_1_41 wn_wih_1_41 wcm 2g
Cwp_wih_2_41 wp_wih_2_41 0 30p
Cwn_wih_2_41 wn_wih_2_41 0 30p
Rwp_wih_2_41 wp_wih_2_41 wcm 2g
Rwn_wih_2_41 wn_wih_2_41 wcm 2g
Cwp_who_41 wp_who_41 0 30p
Cwn_who_41 wn_who_41 0 30p
Rwp_who_41 wp_who_41 wcm 2g
Rwn_who_41 wn_who_41 wcm 2g
Cwp_wih_1_42 wp_wih_1_42 0 30p
Cwn_wih_1_42 wn_wih_1_42 0 30p
Rwp_wih_1_42 wp_wih_1_42 wcm 2g
Rwn_wih_1_42 wn_wih_1_42 wcm 2g
Cwp_wih_2_42 wp_wih_2_42 0 30p
Cwn_wih_2_42 wn_wih_2_42 0 30p
Rwp_wih_2_42 wp_wih_2_42 wcm 2g
Rwn_wih_2_42 wn_wih_2_42 wcm 2g
Cwp_who_42 wp_who_42 0 30p
Cwn_who_42 wn_who_42 0 30p
Rwp_who_42 wp_who_42 wcm 2g
Rwn_who_42 wn_who_42 wcm 2g
Cwp_wih_1_43 wp_wih_1_43 0 30p
Cwn_wih_1_43 wn_wih_1_43 0 30p
Rwp_wih_1_43 wp_wih_1_43 wcm 2g
Rwn_wih_1_43 wn_wih_1_43 wcm 2g
Cwp_wih_2_43 wp_wih_2_43 0 30p
Cwn_wih_2_43 wn_wih_2_43 0 30p
Rwp_wih_2_43 wp_wih_2_43 wcm 2g
Rwn_wih_2_43 wn_wih_2_43 wcm 2g
Cwp_who_43 wp_who_43 0 30p
Cwn_who_43 wn_who_43 0 30p
Rwp_who_43 wp_who_43 wcm 2g
Rwn_who_43 wn_who_43 wcm 2g
Cwp_wih_1_44 wp_wih_1_44 0 30p
Cwn_wih_1_44 wn_wih_1_44 0 30p
Rwp_wih_1_44 wp_wih_1_44 wcm 2g
Rwn_wih_1_44 wn_wih_1_44 wcm 2g
Cwp_wih_2_44 wp_wih_2_44 0 30p
Cwn_wih_2_44 wn_wih_2_44 0 30p
Rwp_wih_2_44 wp_wih_2_44 wcm 2g
Rwn_wih_2_44 wn_wih_2_44 wcm 2g
Cwp_who_44 wp_who_44 0 30p
Cwn_who_44 wn_who_44 0 30p
Rwp_who_44 wp_who_44 wcm 2g
Rwn_who_44 wn_who_44 wcm 2g
Cwp_wih_1_45 wp_wih_1_45 0 30p
Cwn_wih_1_45 wn_wih_1_45 0 30p
Rwp_wih_1_45 wp_wih_1_45 wcm 2g
Rwn_wih_1_45 wn_wih_1_45 wcm 2g
Cwp_wih_2_45 wp_wih_2_45 0 30p
Cwn_wih_2_45 wn_wih_2_45 0 30p
Rwp_wih_2_45 wp_wih_2_45 wcm 2g
Rwn_wih_2_45 wn_wih_2_45 wcm 2g
Cwp_who_45 wp_who_45 0 30p
Cwn_who_45 wn_who_45 0 30p
Rwp_who_45 wp_who_45 wcm 2g
Rwn_who_45 wn_who_45 wcm 2g
Cwp_wih_1_46 wp_wih_1_46 0 30p
Cwn_wih_1_46 wn_wih_1_46 0 30p
Rwp_wih_1_46 wp_wih_1_46 wcm 2g
Rwn_wih_1_46 wn_wih_1_46 wcm 2g
Cwp_wih_2_46 wp_wih_2_46 0 30p
Cwn_wih_2_46 wn_wih_2_46 0 30p
Rwp_wih_2_46 wp_wih_2_46 wcm 2g
Rwn_wih_2_46 wn_wih_2_46 wcm 2g
Cwp_who_46 wp_who_46 0 30p
Cwn_who_46 wn_who_46 0 30p
Rwp_who_46 wp_who_46 wcm 2g
Rwn_who_46 wn_who_46 wcm 2g
Cwp_wih_1_47 wp_wih_1_47 0 30p
Cwn_wih_1_47 wn_wih_1_47 0 30p
Rwp_wih_1_47 wp_wih_1_47 wcm 2g
Rwn_wih_1_47 wn_wih_1_47 wcm 2g
Cwp_wih_2_47 wp_wih_2_47 0 30p
Cwn_wih_2_47 wn_wih_2_47 0 30p
Rwp_wih_2_47 wp_wih_2_47 wcm 2g
Rwn_wih_2_47 wn_wih_2_47 wcm 2g
Cwp_who_47 wp_who_47 0 30p
Cwn_who_47 wn_who_47 0 30p
Rwp_who_47 wp_who_47 wcm 2g
Rwn_who_47 wn_who_47 wcm 2g
Cwp_wih_1_48 wp_wih_1_48 0 30p
Cwn_wih_1_48 wn_wih_1_48 0 30p
Rwp_wih_1_48 wp_wih_1_48 wcm 2g
Rwn_wih_1_48 wn_wih_1_48 wcm 2g
Cwp_wih_2_48 wp_wih_2_48 0 30p
Cwn_wih_2_48 wn_wih_2_48 0 30p
Rwp_wih_2_48 wp_wih_2_48 wcm 2g
Rwn_wih_2_48 wn_wih_2_48 wcm 2g
Cwp_who_48 wp_who_48 0 30p
Cwn_who_48 wn_who_48 0 30p
Rwp_who_48 wp_who_48 wcm 2g
Rwn_who_48 wn_who_48 wcm 2g
Cwp_wih_1_49 wp_wih_1_49 0 30p
Cwn_wih_1_49 wn_wih_1_49 0 30p
Rwp_wih_1_49 wp_wih_1_49 wcm 2g
Rwn_wih_1_49 wn_wih_1_49 wcm 2g
Cwp_wih_2_49 wp_wih_2_49 0 30p
Cwn_wih_2_49 wn_wih_2_49 0 30p
Rwp_wih_2_49 wp_wih_2_49 wcm 2g
Rwn_wih_2_49 wn_wih_2_49 wcm 2g
Cwp_who_49 wp_who_49 0 30p
Cwn_who_49 wn_who_49 0 30p
Rwp_who_49 wp_who_49 wcm 2g
Rwn_who_49 wn_who_49 wcm 2g
Cwp_wih_1_50 wp_wih_1_50 0 30p
Cwn_wih_1_50 wn_wih_1_50 0 30p
Rwp_wih_1_50 wp_wih_1_50 wcm 2g
Rwn_wih_1_50 wn_wih_1_50 wcm 2g
Cwp_wih_2_50 wp_wih_2_50 0 30p
Cwn_wih_2_50 wn_wih_2_50 0 30p
Rwp_wih_2_50 wp_wih_2_50 wcm 2g
Rwn_wih_2_50 wn_wih_2_50 wcm 2g
Cwp_who_50 wp_who_50 0 30p
Cwn_who_50 wn_who_50 0 30p
Rwp_who_50 wp_who_50 wcm 2g
Rwn_who_50 wn_who_50 wcm 2g
Cwp_wih_1_51 wp_wih_1_51 0 30p
Cwn_wih_1_51 wn_wih_1_51 0 30p
Rwp_wih_1_51 wp_wih_1_51 wcm 2g
Rwn_wih_1_51 wn_wih_1_51 wcm 2g
Cwp_wih_2_51 wp_wih_2_51 0 30p
Cwn_wih_2_51 wn_wih_2_51 0 30p
Rwp_wih_2_51 wp_wih_2_51 wcm 2g
Rwn_wih_2_51 wn_wih_2_51 wcm 2g
Cwp_who_51 wp_who_51 0 30p
Cwn_who_51 wn_who_51 0 30p
Rwp_who_51 wp_who_51 wcm 2g
Rwn_who_51 wn_who_51 wcm 2g
Cwp_wih_1_52 wp_wih_1_52 0 30p
Cwn_wih_1_52 wn_wih_1_52 0 30p
Rwp_wih_1_52 wp_wih_1_52 wcm 2g
Rwn_wih_1_52 wn_wih_1_52 wcm 2g
Cwp_wih_2_52 wp_wih_2_52 0 30p
Cwn_wih_2_52 wn_wih_2_52 0 30p
Rwp_wih_2_52 wp_wih_2_52 wcm 2g
Rwn_wih_2_52 wn_wih_2_52 wcm 2g
Cwp_who_52 wp_who_52 0 30p
Cwn_who_52 wn_who_52 0 30p
Rwp_who_52 wp_who_52 wcm 2g
Rwn_who_52 wn_who_52 wcm 2g
Cwp_wih_1_53 wp_wih_1_53 0 30p
Cwn_wih_1_53 wn_wih_1_53 0 30p
Rwp_wih_1_53 wp_wih_1_53 wcm 2g
Rwn_wih_1_53 wn_wih_1_53 wcm 2g
Cwp_wih_2_53 wp_wih_2_53 0 30p
Cwn_wih_2_53 wn_wih_2_53 0 30p
Rwp_wih_2_53 wp_wih_2_53 wcm 2g
Rwn_wih_2_53 wn_wih_2_53 wcm 2g
Cwp_who_53 wp_who_53 0 30p
Cwn_who_53 wn_who_53 0 30p
Rwp_who_53 wp_who_53 wcm 2g
Rwn_who_53 wn_who_53 wcm 2g
Cwp_wih_1_54 wp_wih_1_54 0 30p
Cwn_wih_1_54 wn_wih_1_54 0 30p
Rwp_wih_1_54 wp_wih_1_54 wcm 2g
Rwn_wih_1_54 wn_wih_1_54 wcm 2g
Cwp_wih_2_54 wp_wih_2_54 0 30p
Cwn_wih_2_54 wn_wih_2_54 0 30p
Rwp_wih_2_54 wp_wih_2_54 wcm 2g
Rwn_wih_2_54 wn_wih_2_54 wcm 2g
Cwp_who_54 wp_who_54 0 30p
Cwn_who_54 wn_who_54 0 30p
Rwp_who_54 wp_who_54 wcm 2g
Rwn_who_54 wn_who_54 wcm 2g
Cwp_wih_1_55 wp_wih_1_55 0 30p
Cwn_wih_1_55 wn_wih_1_55 0 30p
Rwp_wih_1_55 wp_wih_1_55 wcm 2g
Rwn_wih_1_55 wn_wih_1_55 wcm 2g
Cwp_wih_2_55 wp_wih_2_55 0 30p
Cwn_wih_2_55 wn_wih_2_55 0 30p
Rwp_wih_2_55 wp_wih_2_55 wcm 2g
Rwn_wih_2_55 wn_wih_2_55 wcm 2g
Cwp_who_55 wp_who_55 0 30p
Cwn_who_55 wn_who_55 0 30p
Rwp_who_55 wp_who_55 wcm 2g
Rwn_who_55 wn_who_55 wcm 2g
Cwp_wih_1_56 wp_wih_1_56 0 30p
Cwn_wih_1_56 wn_wih_1_56 0 30p
Rwp_wih_1_56 wp_wih_1_56 wcm 2g
Rwn_wih_1_56 wn_wih_1_56 wcm 2g
Cwp_wih_2_56 wp_wih_2_56 0 30p
Cwn_wih_2_56 wn_wih_2_56 0 30p
Rwp_wih_2_56 wp_wih_2_56 wcm 2g
Rwn_wih_2_56 wn_wih_2_56 wcm 2g
Cwp_who_56 wp_who_56 0 30p
Cwn_who_56 wn_who_56 0 30p
Rwp_who_56 wp_who_56 wcm 2g
Rwn_who_56 wn_who_56 wcm 2g
Cwp_wih_1_57 wp_wih_1_57 0 30p
Cwn_wih_1_57 wn_wih_1_57 0 30p
Rwp_wih_1_57 wp_wih_1_57 wcm 2g
Rwn_wih_1_57 wn_wih_1_57 wcm 2g
Cwp_wih_2_57 wp_wih_2_57 0 30p
Cwn_wih_2_57 wn_wih_2_57 0 30p
Rwp_wih_2_57 wp_wih_2_57 wcm 2g
Rwn_wih_2_57 wn_wih_2_57 wcm 2g
Cwp_who_57 wp_who_57 0 30p
Cwn_who_57 wn_who_57 0 30p
Rwp_who_57 wp_who_57 wcm 2g
Rwn_who_57 wn_who_57 wcm 2g
Cwp_wih_1_58 wp_wih_1_58 0 30p
Cwn_wih_1_58 wn_wih_1_58 0 30p
Rwp_wih_1_58 wp_wih_1_58 wcm 2g
Rwn_wih_1_58 wn_wih_1_58 wcm 2g
Cwp_wih_2_58 wp_wih_2_58 0 30p
Cwn_wih_2_58 wn_wih_2_58 0 30p
Rwp_wih_2_58 wp_wih_2_58 wcm 2g
Rwn_wih_2_58 wn_wih_2_58 wcm 2g
Cwp_who_58 wp_who_58 0 30p
Cwn_who_58 wn_who_58 0 30p
Rwp_who_58 wp_who_58 wcm 2g
Rwn_who_58 wn_who_58 wcm 2g
Cwp_wih_1_59 wp_wih_1_59 0 30p
Cwn_wih_1_59 wn_wih_1_59 0 30p
Rwp_wih_1_59 wp_wih_1_59 wcm 2g
Rwn_wih_1_59 wn_wih_1_59 wcm 2g
Cwp_wih_2_59 wp_wih_2_59 0 30p
Cwn_wih_2_59 wn_wih_2_59 0 30p
Rwp_wih_2_59 wp_wih_2_59 wcm 2g
Rwn_wih_2_59 wn_wih_2_59 wcm 2g
Cwp_who_59 wp_who_59 0 30p
Cwn_who_59 wn_who_59 0 30p
Rwp_who_59 wp_who_59 wcm 2g
Rwn_who_59 wn_who_59 wcm 2g
Cwp_wih_1_60 wp_wih_1_60 0 30p
Cwn_wih_1_60 wn_wih_1_60 0 30p
Rwp_wih_1_60 wp_wih_1_60 wcm 2g
Rwn_wih_1_60 wn_wih_1_60 wcm 2g
Cwp_wih_2_60 wp_wih_2_60 0 30p
Cwn_wih_2_60 wn_wih_2_60 0 30p
Rwp_wih_2_60 wp_wih_2_60 wcm 2g
Rwn_wih_2_60 wn_wih_2_60 wcm 2g
Cwp_who_60 wp_who_60 0 30p
Cwn_who_60 wn_who_60 0 30p
Rwp_who_60 wp_who_60 wcm 2g
Rwn_who_60 wn_who_60 wcm 2g
Cwp_wih_1_61 wp_wih_1_61 0 30p
Cwn_wih_1_61 wn_wih_1_61 0 30p
Rwp_wih_1_61 wp_wih_1_61 wcm 2g
Rwn_wih_1_61 wn_wih_1_61 wcm 2g
Cwp_wih_2_61 wp_wih_2_61 0 30p
Cwn_wih_2_61 wn_wih_2_61 0 30p
Rwp_wih_2_61 wp_wih_2_61 wcm 2g
Rwn_wih_2_61 wn_wih_2_61 wcm 2g
Cwp_who_61 wp_who_61 0 30p
Cwn_who_61 wn_who_61 0 30p
Rwp_who_61 wp_who_61 wcm 2g
Rwn_who_61 wn_who_61 wcm 2g
Cwp_wih_1_62 wp_wih_1_62 0 30p
Cwn_wih_1_62 wn_wih_1_62 0 30p
Rwp_wih_1_62 wp_wih_1_62 wcm 2g
Rwn_wih_1_62 wn_wih_1_62 wcm 2g
Cwp_wih_2_62 wp_wih_2_62 0 30p
Cwn_wih_2_62 wn_wih_2_62 0 30p
Rwp_wih_2_62 wp_wih_2_62 wcm 2g
Rwn_wih_2_62 wn_wih_2_62 wcm 2g
Cwp_who_62 wp_who_62 0 30p
Cwn_who_62 wn_who_62 0 30p
Rwp_who_62 wp_who_62 wcm 2g
Rwn_who_62 wn_who_62 wcm 2g
Cwp_wih_1_63 wp_wih_1_63 0 30p
Cwn_wih_1_63 wn_wih_1_63 0 30p
Rwp_wih_1_63 wp_wih_1_63 wcm 2g
Rwn_wih_1_63 wn_wih_1_63 wcm 2g
Cwp_wih_2_63 wp_wih_2_63 0 30p
Cwn_wih_2_63 wn_wih_2_63 0 30p
Rwp_wih_2_63 wp_wih_2_63 wcm 2g
Rwn_wih_2_63 wn_wih_2_63 wcm 2g
Cwp_who_63 wp_who_63 0 30p
Cwn_who_63 wn_who_63 0 30p
Rwp_who_63 wp_who_63 wcm 2g
Rwn_who_63 wn_who_63 wcm 2g
Xcm_mh0 mhp0 mhn0 vdd cmld
Xcm_xh0 xhp0 xhn0 vdd cmld
Rnd_mh0 mhp0 mhn0 20k
Rnd_xh0 xhp0 xhn0 20k
Cxhp0 xhp0 0 0.4p
Cxhn0 xhn0 0 0.4p
X_ihm_1_0 a_xp1 a_xn1 wp_wih_1_0 wn_wih_1_0 mhp0 mhn0 vdd vbsyn gsyn
X_ihx_1_0 a_xp1 a_xn1 wp_wih_1_0 wn_wih_1_0 xhp0 xhn0 vdd vbsyn gsyn
X_ihm_2_0 a_xp2 a_xn2 wp_wih_2_0 wn_wih_2_0 mhp0 mhn0 vdd vbsyn gsyn
X_ihx_2_0 a_xp2 a_xn2 wp_wih_2_0 wn_wih_2_0 xhp0 xhn0 vdd vbsyn gsyn
X_bk_0 eop eon wp_who_0 wn_who_0 xhp0 xhn0 vdd vbsyn gsyn
Xn0 xhp0 xhn0 ahp0 ahn0 vdd vbneu dneuron
Xeh0 xhp0 xhn0 mhp0 mhn0 ehp0 ehn0 vdd gm_h esub
Xcm_mh1 mhp1 mhn1 vdd cmld
Xcm_xh1 xhp1 xhn1 vdd cmld
Rnd_mh1 mhp1 mhn1 20k
Rnd_xh1 xhp1 xhn1 20k
Cxhp1 xhp1 0 0.4p
Cxhn1 xhn1 0 0.4p
X_ihm_1_1 a_xp1 a_xn1 wp_wih_1_1 wn_wih_1_1 mhp1 mhn1 vdd vbsyn gsyn
X_ihx_1_1 a_xp1 a_xn1 wp_wih_1_1 wn_wih_1_1 xhp1 xhn1 vdd vbsyn gsyn
X_ihm_2_1 a_xp2 a_xn2 wp_wih_2_1 wn_wih_2_1 mhp1 mhn1 vdd vbsyn gsyn
X_ihx_2_1 a_xp2 a_xn2 wp_wih_2_1 wn_wih_2_1 xhp1 xhn1 vdd vbsyn gsyn
X_bk_1 eop eon wp_who_1 wn_who_1 xhp1 xhn1 vdd vbsyn gsyn
Xn1 xhp1 xhn1 ahp1 ahn1 vdd vbneu dneuron
Xeh1 xhp1 xhn1 mhp1 mhn1 ehp1 ehn1 vdd gm_h esub
Xcm_mh2 mhp2 mhn2 vdd cmld
Xcm_xh2 xhp2 xhn2 vdd cmld
Rnd_mh2 mhp2 mhn2 20k
Rnd_xh2 xhp2 xhn2 20k
Cxhp2 xhp2 0 0.4p
Cxhn2 xhn2 0 0.4p
X_ihm_1_2 a_xp1 a_xn1 wp_wih_1_2 wn_wih_1_2 mhp2 mhn2 vdd vbsyn gsyn
X_ihx_1_2 a_xp1 a_xn1 wp_wih_1_2 wn_wih_1_2 xhp2 xhn2 vdd vbsyn gsyn
X_ihm_2_2 a_xp2 a_xn2 wp_wih_2_2 wn_wih_2_2 mhp2 mhn2 vdd vbsyn gsyn
X_ihx_2_2 a_xp2 a_xn2 wp_wih_2_2 wn_wih_2_2 xhp2 xhn2 vdd vbsyn gsyn
X_bk_2 eop eon wp_who_2 wn_who_2 xhp2 xhn2 vdd vbsyn gsyn
Xn2 xhp2 xhn2 ahp2 ahn2 vdd vbneu dneuron
Xeh2 xhp2 xhn2 mhp2 mhn2 ehp2 ehn2 vdd gm_h esub
Xcm_mh3 mhp3 mhn3 vdd cmld
Xcm_xh3 xhp3 xhn3 vdd cmld
Rnd_mh3 mhp3 mhn3 20k
Rnd_xh3 xhp3 xhn3 20k
Cxhp3 xhp3 0 0.4p
Cxhn3 xhn3 0 0.4p
X_ihm_1_3 a_xp1 a_xn1 wp_wih_1_3 wn_wih_1_3 mhp3 mhn3 vdd vbsyn gsyn
X_ihx_1_3 a_xp1 a_xn1 wp_wih_1_3 wn_wih_1_3 xhp3 xhn3 vdd vbsyn gsyn
X_ihm_2_3 a_xp2 a_xn2 wp_wih_2_3 wn_wih_2_3 mhp3 mhn3 vdd vbsyn gsyn
X_ihx_2_3 a_xp2 a_xn2 wp_wih_2_3 wn_wih_2_3 xhp3 xhn3 vdd vbsyn gsyn
X_bk_3 eop eon wp_who_3 wn_who_3 xhp3 xhn3 vdd vbsyn gsyn
Xn3 xhp3 xhn3 ahp3 ahn3 vdd vbneu dneuron
Xeh3 xhp3 xhn3 mhp3 mhn3 ehp3 ehn3 vdd gm_h esub
Xcm_mh4 mhp4 mhn4 vdd cmld
Xcm_xh4 xhp4 xhn4 vdd cmld
Rnd_mh4 mhp4 mhn4 20k
Rnd_xh4 xhp4 xhn4 20k
Cxhp4 xhp4 0 0.4p
Cxhn4 xhn4 0 0.4p
X_ihm_1_4 a_xp1 a_xn1 wp_wih_1_4 wn_wih_1_4 mhp4 mhn4 vdd vbsyn gsyn
X_ihx_1_4 a_xp1 a_xn1 wp_wih_1_4 wn_wih_1_4 xhp4 xhn4 vdd vbsyn gsyn
X_ihm_2_4 a_xp2 a_xn2 wp_wih_2_4 wn_wih_2_4 mhp4 mhn4 vdd vbsyn gsyn
X_ihx_2_4 a_xp2 a_xn2 wp_wih_2_4 wn_wih_2_4 xhp4 xhn4 vdd vbsyn gsyn
X_bk_4 eop eon wp_who_4 wn_who_4 xhp4 xhn4 vdd vbsyn gsyn
Xn4 xhp4 xhn4 ahp4 ahn4 vdd vbneu dneuron
Xeh4 xhp4 xhn4 mhp4 mhn4 ehp4 ehn4 vdd gm_h esub
Xcm_mh5 mhp5 mhn5 vdd cmld
Xcm_xh5 xhp5 xhn5 vdd cmld
Rnd_mh5 mhp5 mhn5 20k
Rnd_xh5 xhp5 xhn5 20k
Cxhp5 xhp5 0 0.4p
Cxhn5 xhn5 0 0.4p
X_ihm_1_5 a_xp1 a_xn1 wp_wih_1_5 wn_wih_1_5 mhp5 mhn5 vdd vbsyn gsyn
X_ihx_1_5 a_xp1 a_xn1 wp_wih_1_5 wn_wih_1_5 xhp5 xhn5 vdd vbsyn gsyn
X_ihm_2_5 a_xp2 a_xn2 wp_wih_2_5 wn_wih_2_5 mhp5 mhn5 vdd vbsyn gsyn
X_ihx_2_5 a_xp2 a_xn2 wp_wih_2_5 wn_wih_2_5 xhp5 xhn5 vdd vbsyn gsyn
X_bk_5 eop eon wp_who_5 wn_who_5 xhp5 xhn5 vdd vbsyn gsyn
Xn5 xhp5 xhn5 ahp5 ahn5 vdd vbneu dneuron
Xeh5 xhp5 xhn5 mhp5 mhn5 ehp5 ehn5 vdd gm_h esub
Xcm_mh6 mhp6 mhn6 vdd cmld
Xcm_xh6 xhp6 xhn6 vdd cmld
Rnd_mh6 mhp6 mhn6 20k
Rnd_xh6 xhp6 xhn6 20k
Cxhp6 xhp6 0 0.4p
Cxhn6 xhn6 0 0.4p
X_ihm_1_6 a_xp1 a_xn1 wp_wih_1_6 wn_wih_1_6 mhp6 mhn6 vdd vbsyn gsyn
X_ihx_1_6 a_xp1 a_xn1 wp_wih_1_6 wn_wih_1_6 xhp6 xhn6 vdd vbsyn gsyn
X_ihm_2_6 a_xp2 a_xn2 wp_wih_2_6 wn_wih_2_6 mhp6 mhn6 vdd vbsyn gsyn
X_ihx_2_6 a_xp2 a_xn2 wp_wih_2_6 wn_wih_2_6 xhp6 xhn6 vdd vbsyn gsyn
X_bk_6 eop eon wp_who_6 wn_who_6 xhp6 xhn6 vdd vbsyn gsyn
Xn6 xhp6 xhn6 ahp6 ahn6 vdd vbneu dneuron
Xeh6 xhp6 xhn6 mhp6 mhn6 ehp6 ehn6 vdd gm_h esub
Xcm_mh7 mhp7 mhn7 vdd cmld
Xcm_xh7 xhp7 xhn7 vdd cmld
Rnd_mh7 mhp7 mhn7 20k
Rnd_xh7 xhp7 xhn7 20k
Cxhp7 xhp7 0 0.4p
Cxhn7 xhn7 0 0.4p
X_ihm_1_7 a_xp1 a_xn1 wp_wih_1_7 wn_wih_1_7 mhp7 mhn7 vdd vbsyn gsyn
X_ihx_1_7 a_xp1 a_xn1 wp_wih_1_7 wn_wih_1_7 xhp7 xhn7 vdd vbsyn gsyn
X_ihm_2_7 a_xp2 a_xn2 wp_wih_2_7 wn_wih_2_7 mhp7 mhn7 vdd vbsyn gsyn
X_ihx_2_7 a_xp2 a_xn2 wp_wih_2_7 wn_wih_2_7 xhp7 xhn7 vdd vbsyn gsyn
X_bk_7 eop eon wp_who_7 wn_who_7 xhp7 xhn7 vdd vbsyn gsyn
Xn7 xhp7 xhn7 ahp7 ahn7 vdd vbneu dneuron
Xeh7 xhp7 xhn7 mhp7 mhn7 ehp7 ehn7 vdd gm_h esub
Xcm_mh8 mhp8 mhn8 vdd cmld
Xcm_xh8 xhp8 xhn8 vdd cmld
Rnd_mh8 mhp8 mhn8 20k
Rnd_xh8 xhp8 xhn8 20k
Cxhp8 xhp8 0 0.4p
Cxhn8 xhn8 0 0.4p
X_ihm_1_8 a_xp1 a_xn1 wp_wih_1_8 wn_wih_1_8 mhp8 mhn8 vdd vbsyn gsyn
X_ihx_1_8 a_xp1 a_xn1 wp_wih_1_8 wn_wih_1_8 xhp8 xhn8 vdd vbsyn gsyn
X_ihm_2_8 a_xp2 a_xn2 wp_wih_2_8 wn_wih_2_8 mhp8 mhn8 vdd vbsyn gsyn
X_ihx_2_8 a_xp2 a_xn2 wp_wih_2_8 wn_wih_2_8 xhp8 xhn8 vdd vbsyn gsyn
X_bk_8 eop eon wp_who_8 wn_who_8 xhp8 xhn8 vdd vbsyn gsyn
Xn8 xhp8 xhn8 ahp8 ahn8 vdd vbneu dneuron
Xeh8 xhp8 xhn8 mhp8 mhn8 ehp8 ehn8 vdd gm_h esub
Xcm_mh9 mhp9 mhn9 vdd cmld
Xcm_xh9 xhp9 xhn9 vdd cmld
Rnd_mh9 mhp9 mhn9 20k
Rnd_xh9 xhp9 xhn9 20k
Cxhp9 xhp9 0 0.4p
Cxhn9 xhn9 0 0.4p
X_ihm_1_9 a_xp1 a_xn1 wp_wih_1_9 wn_wih_1_9 mhp9 mhn9 vdd vbsyn gsyn
X_ihx_1_9 a_xp1 a_xn1 wp_wih_1_9 wn_wih_1_9 xhp9 xhn9 vdd vbsyn gsyn
X_ihm_2_9 a_xp2 a_xn2 wp_wih_2_9 wn_wih_2_9 mhp9 mhn9 vdd vbsyn gsyn
X_ihx_2_9 a_xp2 a_xn2 wp_wih_2_9 wn_wih_2_9 xhp9 xhn9 vdd vbsyn gsyn
X_bk_9 eop eon wp_who_9 wn_who_9 xhp9 xhn9 vdd vbsyn gsyn
Xn9 xhp9 xhn9 ahp9 ahn9 vdd vbneu dneuron
Xeh9 xhp9 xhn9 mhp9 mhn9 ehp9 ehn9 vdd gm_h esub
Xcm_mh10 mhp10 mhn10 vdd cmld
Xcm_xh10 xhp10 xhn10 vdd cmld
Rnd_mh10 mhp10 mhn10 20k
Rnd_xh10 xhp10 xhn10 20k
Cxhp10 xhp10 0 0.4p
Cxhn10 xhn10 0 0.4p
X_ihm_1_10 a_xp1 a_xn1 wp_wih_1_10 wn_wih_1_10 mhp10 mhn10 vdd vbsyn gsyn
X_ihx_1_10 a_xp1 a_xn1 wp_wih_1_10 wn_wih_1_10 xhp10 xhn10 vdd vbsyn gsyn
X_ihm_2_10 a_xp2 a_xn2 wp_wih_2_10 wn_wih_2_10 mhp10 mhn10 vdd vbsyn gsyn
X_ihx_2_10 a_xp2 a_xn2 wp_wih_2_10 wn_wih_2_10 xhp10 xhn10 vdd vbsyn gsyn
X_bk_10 eop eon wp_who_10 wn_who_10 xhp10 xhn10 vdd vbsyn gsyn
Xn10 xhp10 xhn10 ahp10 ahn10 vdd vbneu dneuron
Xeh10 xhp10 xhn10 mhp10 mhn10 ehp10 ehn10 vdd gm_h esub
Xcm_mh11 mhp11 mhn11 vdd cmld
Xcm_xh11 xhp11 xhn11 vdd cmld
Rnd_mh11 mhp11 mhn11 20k
Rnd_xh11 xhp11 xhn11 20k
Cxhp11 xhp11 0 0.4p
Cxhn11 xhn11 0 0.4p
X_ihm_1_11 a_xp1 a_xn1 wp_wih_1_11 wn_wih_1_11 mhp11 mhn11 vdd vbsyn gsyn
X_ihx_1_11 a_xp1 a_xn1 wp_wih_1_11 wn_wih_1_11 xhp11 xhn11 vdd vbsyn gsyn
X_ihm_2_11 a_xp2 a_xn2 wp_wih_2_11 wn_wih_2_11 mhp11 mhn11 vdd vbsyn gsyn
X_ihx_2_11 a_xp2 a_xn2 wp_wih_2_11 wn_wih_2_11 xhp11 xhn11 vdd vbsyn gsyn
X_bk_11 eop eon wp_who_11 wn_who_11 xhp11 xhn11 vdd vbsyn gsyn
Xn11 xhp11 xhn11 ahp11 ahn11 vdd vbneu dneuron
Xeh11 xhp11 xhn11 mhp11 mhn11 ehp11 ehn11 vdd gm_h esub
Xcm_mh12 mhp12 mhn12 vdd cmld
Xcm_xh12 xhp12 xhn12 vdd cmld
Rnd_mh12 mhp12 mhn12 20k
Rnd_xh12 xhp12 xhn12 20k
Cxhp12 xhp12 0 0.4p
Cxhn12 xhn12 0 0.4p
X_ihm_1_12 a_xp1 a_xn1 wp_wih_1_12 wn_wih_1_12 mhp12 mhn12 vdd vbsyn gsyn
X_ihx_1_12 a_xp1 a_xn1 wp_wih_1_12 wn_wih_1_12 xhp12 xhn12 vdd vbsyn gsyn
X_ihm_2_12 a_xp2 a_xn2 wp_wih_2_12 wn_wih_2_12 mhp12 mhn12 vdd vbsyn gsyn
X_ihx_2_12 a_xp2 a_xn2 wp_wih_2_12 wn_wih_2_12 xhp12 xhn12 vdd vbsyn gsyn
X_bk_12 eop eon wp_who_12 wn_who_12 xhp12 xhn12 vdd vbsyn gsyn
Xn12 xhp12 xhn12 ahp12 ahn12 vdd vbneu dneuron
Xeh12 xhp12 xhn12 mhp12 mhn12 ehp12 ehn12 vdd gm_h esub
Xcm_mh13 mhp13 mhn13 vdd cmld
Xcm_xh13 xhp13 xhn13 vdd cmld
Rnd_mh13 mhp13 mhn13 20k
Rnd_xh13 xhp13 xhn13 20k
Cxhp13 xhp13 0 0.4p
Cxhn13 xhn13 0 0.4p
X_ihm_1_13 a_xp1 a_xn1 wp_wih_1_13 wn_wih_1_13 mhp13 mhn13 vdd vbsyn gsyn
X_ihx_1_13 a_xp1 a_xn1 wp_wih_1_13 wn_wih_1_13 xhp13 xhn13 vdd vbsyn gsyn
X_ihm_2_13 a_xp2 a_xn2 wp_wih_2_13 wn_wih_2_13 mhp13 mhn13 vdd vbsyn gsyn
X_ihx_2_13 a_xp2 a_xn2 wp_wih_2_13 wn_wih_2_13 xhp13 xhn13 vdd vbsyn gsyn
X_bk_13 eop eon wp_who_13 wn_who_13 xhp13 xhn13 vdd vbsyn gsyn
Xn13 xhp13 xhn13 ahp13 ahn13 vdd vbneu dneuron
Xeh13 xhp13 xhn13 mhp13 mhn13 ehp13 ehn13 vdd gm_h esub
Xcm_mh14 mhp14 mhn14 vdd cmld
Xcm_xh14 xhp14 xhn14 vdd cmld
Rnd_mh14 mhp14 mhn14 20k
Rnd_xh14 xhp14 xhn14 20k
Cxhp14 xhp14 0 0.4p
Cxhn14 xhn14 0 0.4p
X_ihm_1_14 a_xp1 a_xn1 wp_wih_1_14 wn_wih_1_14 mhp14 mhn14 vdd vbsyn gsyn
X_ihx_1_14 a_xp1 a_xn1 wp_wih_1_14 wn_wih_1_14 xhp14 xhn14 vdd vbsyn gsyn
X_ihm_2_14 a_xp2 a_xn2 wp_wih_2_14 wn_wih_2_14 mhp14 mhn14 vdd vbsyn gsyn
X_ihx_2_14 a_xp2 a_xn2 wp_wih_2_14 wn_wih_2_14 xhp14 xhn14 vdd vbsyn gsyn
X_bk_14 eop eon wp_who_14 wn_who_14 xhp14 xhn14 vdd vbsyn gsyn
Xn14 xhp14 xhn14 ahp14 ahn14 vdd vbneu dneuron
Xeh14 xhp14 xhn14 mhp14 mhn14 ehp14 ehn14 vdd gm_h esub
Xcm_mh15 mhp15 mhn15 vdd cmld
Xcm_xh15 xhp15 xhn15 vdd cmld
Rnd_mh15 mhp15 mhn15 20k
Rnd_xh15 xhp15 xhn15 20k
Cxhp15 xhp15 0 0.4p
Cxhn15 xhn15 0 0.4p
X_ihm_1_15 a_xp1 a_xn1 wp_wih_1_15 wn_wih_1_15 mhp15 mhn15 vdd vbsyn gsyn
X_ihx_1_15 a_xp1 a_xn1 wp_wih_1_15 wn_wih_1_15 xhp15 xhn15 vdd vbsyn gsyn
X_ihm_2_15 a_xp2 a_xn2 wp_wih_2_15 wn_wih_2_15 mhp15 mhn15 vdd vbsyn gsyn
X_ihx_2_15 a_xp2 a_xn2 wp_wih_2_15 wn_wih_2_15 xhp15 xhn15 vdd vbsyn gsyn
X_bk_15 eop eon wp_who_15 wn_who_15 xhp15 xhn15 vdd vbsyn gsyn
Xn15 xhp15 xhn15 ahp15 ahn15 vdd vbneu dneuron
Xeh15 xhp15 xhn15 mhp15 mhn15 ehp15 ehn15 vdd gm_h esub
Xcm_mh16 mhp16 mhn16 vdd cmld
Xcm_xh16 xhp16 xhn16 vdd cmld
Rnd_mh16 mhp16 mhn16 20k
Rnd_xh16 xhp16 xhn16 20k
Cxhp16 xhp16 0 0.4p
Cxhn16 xhn16 0 0.4p
X_ihm_1_16 a_xp1 a_xn1 wp_wih_1_16 wn_wih_1_16 mhp16 mhn16 vdd vbsyn gsyn
X_ihx_1_16 a_xp1 a_xn1 wp_wih_1_16 wn_wih_1_16 xhp16 xhn16 vdd vbsyn gsyn
X_ihm_2_16 a_xp2 a_xn2 wp_wih_2_16 wn_wih_2_16 mhp16 mhn16 vdd vbsyn gsyn
X_ihx_2_16 a_xp2 a_xn2 wp_wih_2_16 wn_wih_2_16 xhp16 xhn16 vdd vbsyn gsyn
X_bk_16 eop eon wp_who_16 wn_who_16 xhp16 xhn16 vdd vbsyn gsyn
Xn16 xhp16 xhn16 ahp16 ahn16 vdd vbneu dneuron
Xeh16 xhp16 xhn16 mhp16 mhn16 ehp16 ehn16 vdd gm_h esub
Xcm_mh17 mhp17 mhn17 vdd cmld
Xcm_xh17 xhp17 xhn17 vdd cmld
Rnd_mh17 mhp17 mhn17 20k
Rnd_xh17 xhp17 xhn17 20k
Cxhp17 xhp17 0 0.4p
Cxhn17 xhn17 0 0.4p
X_ihm_1_17 a_xp1 a_xn1 wp_wih_1_17 wn_wih_1_17 mhp17 mhn17 vdd vbsyn gsyn
X_ihx_1_17 a_xp1 a_xn1 wp_wih_1_17 wn_wih_1_17 xhp17 xhn17 vdd vbsyn gsyn
X_ihm_2_17 a_xp2 a_xn2 wp_wih_2_17 wn_wih_2_17 mhp17 mhn17 vdd vbsyn gsyn
X_ihx_2_17 a_xp2 a_xn2 wp_wih_2_17 wn_wih_2_17 xhp17 xhn17 vdd vbsyn gsyn
X_bk_17 eop eon wp_who_17 wn_who_17 xhp17 xhn17 vdd vbsyn gsyn
Xn17 xhp17 xhn17 ahp17 ahn17 vdd vbneu dneuron
Xeh17 xhp17 xhn17 mhp17 mhn17 ehp17 ehn17 vdd gm_h esub
Xcm_mh18 mhp18 mhn18 vdd cmld
Xcm_xh18 xhp18 xhn18 vdd cmld
Rnd_mh18 mhp18 mhn18 20k
Rnd_xh18 xhp18 xhn18 20k
Cxhp18 xhp18 0 0.4p
Cxhn18 xhn18 0 0.4p
X_ihm_1_18 a_xp1 a_xn1 wp_wih_1_18 wn_wih_1_18 mhp18 mhn18 vdd vbsyn gsyn
X_ihx_1_18 a_xp1 a_xn1 wp_wih_1_18 wn_wih_1_18 xhp18 xhn18 vdd vbsyn gsyn
X_ihm_2_18 a_xp2 a_xn2 wp_wih_2_18 wn_wih_2_18 mhp18 mhn18 vdd vbsyn gsyn
X_ihx_2_18 a_xp2 a_xn2 wp_wih_2_18 wn_wih_2_18 xhp18 xhn18 vdd vbsyn gsyn
X_bk_18 eop eon wp_who_18 wn_who_18 xhp18 xhn18 vdd vbsyn gsyn
Xn18 xhp18 xhn18 ahp18 ahn18 vdd vbneu dneuron
Xeh18 xhp18 xhn18 mhp18 mhn18 ehp18 ehn18 vdd gm_h esub
Xcm_mh19 mhp19 mhn19 vdd cmld
Xcm_xh19 xhp19 xhn19 vdd cmld
Rnd_mh19 mhp19 mhn19 20k
Rnd_xh19 xhp19 xhn19 20k
Cxhp19 xhp19 0 0.4p
Cxhn19 xhn19 0 0.4p
X_ihm_1_19 a_xp1 a_xn1 wp_wih_1_19 wn_wih_1_19 mhp19 mhn19 vdd vbsyn gsyn
X_ihx_1_19 a_xp1 a_xn1 wp_wih_1_19 wn_wih_1_19 xhp19 xhn19 vdd vbsyn gsyn
X_ihm_2_19 a_xp2 a_xn2 wp_wih_2_19 wn_wih_2_19 mhp19 mhn19 vdd vbsyn gsyn
X_ihx_2_19 a_xp2 a_xn2 wp_wih_2_19 wn_wih_2_19 xhp19 xhn19 vdd vbsyn gsyn
X_bk_19 eop eon wp_who_19 wn_who_19 xhp19 xhn19 vdd vbsyn gsyn
Xn19 xhp19 xhn19 ahp19 ahn19 vdd vbneu dneuron
Xeh19 xhp19 xhn19 mhp19 mhn19 ehp19 ehn19 vdd gm_h esub
Xcm_mh20 mhp20 mhn20 vdd cmld
Xcm_xh20 xhp20 xhn20 vdd cmld
Rnd_mh20 mhp20 mhn20 20k
Rnd_xh20 xhp20 xhn20 20k
Cxhp20 xhp20 0 0.4p
Cxhn20 xhn20 0 0.4p
X_ihm_1_20 a_xp1 a_xn1 wp_wih_1_20 wn_wih_1_20 mhp20 mhn20 vdd vbsyn gsyn
X_ihx_1_20 a_xp1 a_xn1 wp_wih_1_20 wn_wih_1_20 xhp20 xhn20 vdd vbsyn gsyn
X_ihm_2_20 a_xp2 a_xn2 wp_wih_2_20 wn_wih_2_20 mhp20 mhn20 vdd vbsyn gsyn
X_ihx_2_20 a_xp2 a_xn2 wp_wih_2_20 wn_wih_2_20 xhp20 xhn20 vdd vbsyn gsyn
X_bk_20 eop eon wp_who_20 wn_who_20 xhp20 xhn20 vdd vbsyn gsyn
Xn20 xhp20 xhn20 ahp20 ahn20 vdd vbneu dneuron
Xeh20 xhp20 xhn20 mhp20 mhn20 ehp20 ehn20 vdd gm_h esub
Xcm_mh21 mhp21 mhn21 vdd cmld
Xcm_xh21 xhp21 xhn21 vdd cmld
Rnd_mh21 mhp21 mhn21 20k
Rnd_xh21 xhp21 xhn21 20k
Cxhp21 xhp21 0 0.4p
Cxhn21 xhn21 0 0.4p
X_ihm_1_21 a_xp1 a_xn1 wp_wih_1_21 wn_wih_1_21 mhp21 mhn21 vdd vbsyn gsyn
X_ihx_1_21 a_xp1 a_xn1 wp_wih_1_21 wn_wih_1_21 xhp21 xhn21 vdd vbsyn gsyn
X_ihm_2_21 a_xp2 a_xn2 wp_wih_2_21 wn_wih_2_21 mhp21 mhn21 vdd vbsyn gsyn
X_ihx_2_21 a_xp2 a_xn2 wp_wih_2_21 wn_wih_2_21 xhp21 xhn21 vdd vbsyn gsyn
X_bk_21 eop eon wp_who_21 wn_who_21 xhp21 xhn21 vdd vbsyn gsyn
Xn21 xhp21 xhn21 ahp21 ahn21 vdd vbneu dneuron
Xeh21 xhp21 xhn21 mhp21 mhn21 ehp21 ehn21 vdd gm_h esub
Xcm_mh22 mhp22 mhn22 vdd cmld
Xcm_xh22 xhp22 xhn22 vdd cmld
Rnd_mh22 mhp22 mhn22 20k
Rnd_xh22 xhp22 xhn22 20k
Cxhp22 xhp22 0 0.4p
Cxhn22 xhn22 0 0.4p
X_ihm_1_22 a_xp1 a_xn1 wp_wih_1_22 wn_wih_1_22 mhp22 mhn22 vdd vbsyn gsyn
X_ihx_1_22 a_xp1 a_xn1 wp_wih_1_22 wn_wih_1_22 xhp22 xhn22 vdd vbsyn gsyn
X_ihm_2_22 a_xp2 a_xn2 wp_wih_2_22 wn_wih_2_22 mhp22 mhn22 vdd vbsyn gsyn
X_ihx_2_22 a_xp2 a_xn2 wp_wih_2_22 wn_wih_2_22 xhp22 xhn22 vdd vbsyn gsyn
X_bk_22 eop eon wp_who_22 wn_who_22 xhp22 xhn22 vdd vbsyn gsyn
Xn22 xhp22 xhn22 ahp22 ahn22 vdd vbneu dneuron
Xeh22 xhp22 xhn22 mhp22 mhn22 ehp22 ehn22 vdd gm_h esub
Xcm_mh23 mhp23 mhn23 vdd cmld
Xcm_xh23 xhp23 xhn23 vdd cmld
Rnd_mh23 mhp23 mhn23 20k
Rnd_xh23 xhp23 xhn23 20k
Cxhp23 xhp23 0 0.4p
Cxhn23 xhn23 0 0.4p
X_ihm_1_23 a_xp1 a_xn1 wp_wih_1_23 wn_wih_1_23 mhp23 mhn23 vdd vbsyn gsyn
X_ihx_1_23 a_xp1 a_xn1 wp_wih_1_23 wn_wih_1_23 xhp23 xhn23 vdd vbsyn gsyn
X_ihm_2_23 a_xp2 a_xn2 wp_wih_2_23 wn_wih_2_23 mhp23 mhn23 vdd vbsyn gsyn
X_ihx_2_23 a_xp2 a_xn2 wp_wih_2_23 wn_wih_2_23 xhp23 xhn23 vdd vbsyn gsyn
X_bk_23 eop eon wp_who_23 wn_who_23 xhp23 xhn23 vdd vbsyn gsyn
Xn23 xhp23 xhn23 ahp23 ahn23 vdd vbneu dneuron
Xeh23 xhp23 xhn23 mhp23 mhn23 ehp23 ehn23 vdd gm_h esub
Xcm_mh24 mhp24 mhn24 vdd cmld
Xcm_xh24 xhp24 xhn24 vdd cmld
Rnd_mh24 mhp24 mhn24 20k
Rnd_xh24 xhp24 xhn24 20k
Cxhp24 xhp24 0 0.4p
Cxhn24 xhn24 0 0.4p
X_ihm_1_24 a_xp1 a_xn1 wp_wih_1_24 wn_wih_1_24 mhp24 mhn24 vdd vbsyn gsyn
X_ihx_1_24 a_xp1 a_xn1 wp_wih_1_24 wn_wih_1_24 xhp24 xhn24 vdd vbsyn gsyn
X_ihm_2_24 a_xp2 a_xn2 wp_wih_2_24 wn_wih_2_24 mhp24 mhn24 vdd vbsyn gsyn
X_ihx_2_24 a_xp2 a_xn2 wp_wih_2_24 wn_wih_2_24 xhp24 xhn24 vdd vbsyn gsyn
X_bk_24 eop eon wp_who_24 wn_who_24 xhp24 xhn24 vdd vbsyn gsyn
Xn24 xhp24 xhn24 ahp24 ahn24 vdd vbneu dneuron
Xeh24 xhp24 xhn24 mhp24 mhn24 ehp24 ehn24 vdd gm_h esub
Xcm_mh25 mhp25 mhn25 vdd cmld
Xcm_xh25 xhp25 xhn25 vdd cmld
Rnd_mh25 mhp25 mhn25 20k
Rnd_xh25 xhp25 xhn25 20k
Cxhp25 xhp25 0 0.4p
Cxhn25 xhn25 0 0.4p
X_ihm_1_25 a_xp1 a_xn1 wp_wih_1_25 wn_wih_1_25 mhp25 mhn25 vdd vbsyn gsyn
X_ihx_1_25 a_xp1 a_xn1 wp_wih_1_25 wn_wih_1_25 xhp25 xhn25 vdd vbsyn gsyn
X_ihm_2_25 a_xp2 a_xn2 wp_wih_2_25 wn_wih_2_25 mhp25 mhn25 vdd vbsyn gsyn
X_ihx_2_25 a_xp2 a_xn2 wp_wih_2_25 wn_wih_2_25 xhp25 xhn25 vdd vbsyn gsyn
X_bk_25 eop eon wp_who_25 wn_who_25 xhp25 xhn25 vdd vbsyn gsyn
Xn25 xhp25 xhn25 ahp25 ahn25 vdd vbneu dneuron
Xeh25 xhp25 xhn25 mhp25 mhn25 ehp25 ehn25 vdd gm_h esub
Xcm_mh26 mhp26 mhn26 vdd cmld
Xcm_xh26 xhp26 xhn26 vdd cmld
Rnd_mh26 mhp26 mhn26 20k
Rnd_xh26 xhp26 xhn26 20k
Cxhp26 xhp26 0 0.4p
Cxhn26 xhn26 0 0.4p
X_ihm_1_26 a_xp1 a_xn1 wp_wih_1_26 wn_wih_1_26 mhp26 mhn26 vdd vbsyn gsyn
X_ihx_1_26 a_xp1 a_xn1 wp_wih_1_26 wn_wih_1_26 xhp26 xhn26 vdd vbsyn gsyn
X_ihm_2_26 a_xp2 a_xn2 wp_wih_2_26 wn_wih_2_26 mhp26 mhn26 vdd vbsyn gsyn
X_ihx_2_26 a_xp2 a_xn2 wp_wih_2_26 wn_wih_2_26 xhp26 xhn26 vdd vbsyn gsyn
X_bk_26 eop eon wp_who_26 wn_who_26 xhp26 xhn26 vdd vbsyn gsyn
Xn26 xhp26 xhn26 ahp26 ahn26 vdd vbneu dneuron
Xeh26 xhp26 xhn26 mhp26 mhn26 ehp26 ehn26 vdd gm_h esub
Xcm_mh27 mhp27 mhn27 vdd cmld
Xcm_xh27 xhp27 xhn27 vdd cmld
Rnd_mh27 mhp27 mhn27 20k
Rnd_xh27 xhp27 xhn27 20k
Cxhp27 xhp27 0 0.4p
Cxhn27 xhn27 0 0.4p
X_ihm_1_27 a_xp1 a_xn1 wp_wih_1_27 wn_wih_1_27 mhp27 mhn27 vdd vbsyn gsyn
X_ihx_1_27 a_xp1 a_xn1 wp_wih_1_27 wn_wih_1_27 xhp27 xhn27 vdd vbsyn gsyn
X_ihm_2_27 a_xp2 a_xn2 wp_wih_2_27 wn_wih_2_27 mhp27 mhn27 vdd vbsyn gsyn
X_ihx_2_27 a_xp2 a_xn2 wp_wih_2_27 wn_wih_2_27 xhp27 xhn27 vdd vbsyn gsyn
X_bk_27 eop eon wp_who_27 wn_who_27 xhp27 xhn27 vdd vbsyn gsyn
Xn27 xhp27 xhn27 ahp27 ahn27 vdd vbneu dneuron
Xeh27 xhp27 xhn27 mhp27 mhn27 ehp27 ehn27 vdd gm_h esub
Xcm_mh28 mhp28 mhn28 vdd cmld
Xcm_xh28 xhp28 xhn28 vdd cmld
Rnd_mh28 mhp28 mhn28 20k
Rnd_xh28 xhp28 xhn28 20k
Cxhp28 xhp28 0 0.4p
Cxhn28 xhn28 0 0.4p
X_ihm_1_28 a_xp1 a_xn1 wp_wih_1_28 wn_wih_1_28 mhp28 mhn28 vdd vbsyn gsyn
X_ihx_1_28 a_xp1 a_xn1 wp_wih_1_28 wn_wih_1_28 xhp28 xhn28 vdd vbsyn gsyn
X_ihm_2_28 a_xp2 a_xn2 wp_wih_2_28 wn_wih_2_28 mhp28 mhn28 vdd vbsyn gsyn
X_ihx_2_28 a_xp2 a_xn2 wp_wih_2_28 wn_wih_2_28 xhp28 xhn28 vdd vbsyn gsyn
X_bk_28 eop eon wp_who_28 wn_who_28 xhp28 xhn28 vdd vbsyn gsyn
Xn28 xhp28 xhn28 ahp28 ahn28 vdd vbneu dneuron
Xeh28 xhp28 xhn28 mhp28 mhn28 ehp28 ehn28 vdd gm_h esub
Xcm_mh29 mhp29 mhn29 vdd cmld
Xcm_xh29 xhp29 xhn29 vdd cmld
Rnd_mh29 mhp29 mhn29 20k
Rnd_xh29 xhp29 xhn29 20k
Cxhp29 xhp29 0 0.4p
Cxhn29 xhn29 0 0.4p
X_ihm_1_29 a_xp1 a_xn1 wp_wih_1_29 wn_wih_1_29 mhp29 mhn29 vdd vbsyn gsyn
X_ihx_1_29 a_xp1 a_xn1 wp_wih_1_29 wn_wih_1_29 xhp29 xhn29 vdd vbsyn gsyn
X_ihm_2_29 a_xp2 a_xn2 wp_wih_2_29 wn_wih_2_29 mhp29 mhn29 vdd vbsyn gsyn
X_ihx_2_29 a_xp2 a_xn2 wp_wih_2_29 wn_wih_2_29 xhp29 xhn29 vdd vbsyn gsyn
X_bk_29 eop eon wp_who_29 wn_who_29 xhp29 xhn29 vdd vbsyn gsyn
Xn29 xhp29 xhn29 ahp29 ahn29 vdd vbneu dneuron
Xeh29 xhp29 xhn29 mhp29 mhn29 ehp29 ehn29 vdd gm_h esub
Xcm_mh30 mhp30 mhn30 vdd cmld
Xcm_xh30 xhp30 xhn30 vdd cmld
Rnd_mh30 mhp30 mhn30 20k
Rnd_xh30 xhp30 xhn30 20k
Cxhp30 xhp30 0 0.4p
Cxhn30 xhn30 0 0.4p
X_ihm_1_30 a_xp1 a_xn1 wp_wih_1_30 wn_wih_1_30 mhp30 mhn30 vdd vbsyn gsyn
X_ihx_1_30 a_xp1 a_xn1 wp_wih_1_30 wn_wih_1_30 xhp30 xhn30 vdd vbsyn gsyn
X_ihm_2_30 a_xp2 a_xn2 wp_wih_2_30 wn_wih_2_30 mhp30 mhn30 vdd vbsyn gsyn
X_ihx_2_30 a_xp2 a_xn2 wp_wih_2_30 wn_wih_2_30 xhp30 xhn30 vdd vbsyn gsyn
X_bk_30 eop eon wp_who_30 wn_who_30 xhp30 xhn30 vdd vbsyn gsyn
Xn30 xhp30 xhn30 ahp30 ahn30 vdd vbneu dneuron
Xeh30 xhp30 xhn30 mhp30 mhn30 ehp30 ehn30 vdd gm_h esub
Xcm_mh31 mhp31 mhn31 vdd cmld
Xcm_xh31 xhp31 xhn31 vdd cmld
Rnd_mh31 mhp31 mhn31 20k
Rnd_xh31 xhp31 xhn31 20k
Cxhp31 xhp31 0 0.4p
Cxhn31 xhn31 0 0.4p
X_ihm_1_31 a_xp1 a_xn1 wp_wih_1_31 wn_wih_1_31 mhp31 mhn31 vdd vbsyn gsyn
X_ihx_1_31 a_xp1 a_xn1 wp_wih_1_31 wn_wih_1_31 xhp31 xhn31 vdd vbsyn gsyn
X_ihm_2_31 a_xp2 a_xn2 wp_wih_2_31 wn_wih_2_31 mhp31 mhn31 vdd vbsyn gsyn
X_ihx_2_31 a_xp2 a_xn2 wp_wih_2_31 wn_wih_2_31 xhp31 xhn31 vdd vbsyn gsyn
X_bk_31 eop eon wp_who_31 wn_who_31 xhp31 xhn31 vdd vbsyn gsyn
Xn31 xhp31 xhn31 ahp31 ahn31 vdd vbneu dneuron
Xeh31 xhp31 xhn31 mhp31 mhn31 ehp31 ehn31 vdd gm_h esub
Xcm_mh32 mhp32 mhn32 vdd cmld
Xcm_xh32 xhp32 xhn32 vdd cmld
Rnd_mh32 mhp32 mhn32 20k
Rnd_xh32 xhp32 xhn32 20k
Cxhp32 xhp32 0 0.4p
Cxhn32 xhn32 0 0.4p
X_ihm_1_32 a_xp1 a_xn1 wp_wih_1_32 wn_wih_1_32 mhp32 mhn32 vdd vbsyn gsyn
X_ihx_1_32 a_xp1 a_xn1 wp_wih_1_32 wn_wih_1_32 xhp32 xhn32 vdd vbsyn gsyn
X_ihm_2_32 a_xp2 a_xn2 wp_wih_2_32 wn_wih_2_32 mhp32 mhn32 vdd vbsyn gsyn
X_ihx_2_32 a_xp2 a_xn2 wp_wih_2_32 wn_wih_2_32 xhp32 xhn32 vdd vbsyn gsyn
X_bk_32 eop eon wp_who_32 wn_who_32 xhp32 xhn32 vdd vbsyn gsyn
Xn32 xhp32 xhn32 ahp32 ahn32 vdd vbneu dneuron
Xeh32 xhp32 xhn32 mhp32 mhn32 ehp32 ehn32 vdd gm_h esub
Xcm_mh33 mhp33 mhn33 vdd cmld
Xcm_xh33 xhp33 xhn33 vdd cmld
Rnd_mh33 mhp33 mhn33 20k
Rnd_xh33 xhp33 xhn33 20k
Cxhp33 xhp33 0 0.4p
Cxhn33 xhn33 0 0.4p
X_ihm_1_33 a_xp1 a_xn1 wp_wih_1_33 wn_wih_1_33 mhp33 mhn33 vdd vbsyn gsyn
X_ihx_1_33 a_xp1 a_xn1 wp_wih_1_33 wn_wih_1_33 xhp33 xhn33 vdd vbsyn gsyn
X_ihm_2_33 a_xp2 a_xn2 wp_wih_2_33 wn_wih_2_33 mhp33 mhn33 vdd vbsyn gsyn
X_ihx_2_33 a_xp2 a_xn2 wp_wih_2_33 wn_wih_2_33 xhp33 xhn33 vdd vbsyn gsyn
X_bk_33 eop eon wp_who_33 wn_who_33 xhp33 xhn33 vdd vbsyn gsyn
Xn33 xhp33 xhn33 ahp33 ahn33 vdd vbneu dneuron
Xeh33 xhp33 xhn33 mhp33 mhn33 ehp33 ehn33 vdd gm_h esub
Xcm_mh34 mhp34 mhn34 vdd cmld
Xcm_xh34 xhp34 xhn34 vdd cmld
Rnd_mh34 mhp34 mhn34 20k
Rnd_xh34 xhp34 xhn34 20k
Cxhp34 xhp34 0 0.4p
Cxhn34 xhn34 0 0.4p
X_ihm_1_34 a_xp1 a_xn1 wp_wih_1_34 wn_wih_1_34 mhp34 mhn34 vdd vbsyn gsyn
X_ihx_1_34 a_xp1 a_xn1 wp_wih_1_34 wn_wih_1_34 xhp34 xhn34 vdd vbsyn gsyn
X_ihm_2_34 a_xp2 a_xn2 wp_wih_2_34 wn_wih_2_34 mhp34 mhn34 vdd vbsyn gsyn
X_ihx_2_34 a_xp2 a_xn2 wp_wih_2_34 wn_wih_2_34 xhp34 xhn34 vdd vbsyn gsyn
X_bk_34 eop eon wp_who_34 wn_who_34 xhp34 xhn34 vdd vbsyn gsyn
Xn34 xhp34 xhn34 ahp34 ahn34 vdd vbneu dneuron
Xeh34 xhp34 xhn34 mhp34 mhn34 ehp34 ehn34 vdd gm_h esub
Xcm_mh35 mhp35 mhn35 vdd cmld
Xcm_xh35 xhp35 xhn35 vdd cmld
Rnd_mh35 mhp35 mhn35 20k
Rnd_xh35 xhp35 xhn35 20k
Cxhp35 xhp35 0 0.4p
Cxhn35 xhn35 0 0.4p
X_ihm_1_35 a_xp1 a_xn1 wp_wih_1_35 wn_wih_1_35 mhp35 mhn35 vdd vbsyn gsyn
X_ihx_1_35 a_xp1 a_xn1 wp_wih_1_35 wn_wih_1_35 xhp35 xhn35 vdd vbsyn gsyn
X_ihm_2_35 a_xp2 a_xn2 wp_wih_2_35 wn_wih_2_35 mhp35 mhn35 vdd vbsyn gsyn
X_ihx_2_35 a_xp2 a_xn2 wp_wih_2_35 wn_wih_2_35 xhp35 xhn35 vdd vbsyn gsyn
X_bk_35 eop eon wp_who_35 wn_who_35 xhp35 xhn35 vdd vbsyn gsyn
Xn35 xhp35 xhn35 ahp35 ahn35 vdd vbneu dneuron
Xeh35 xhp35 xhn35 mhp35 mhn35 ehp35 ehn35 vdd gm_h esub
Xcm_mh36 mhp36 mhn36 vdd cmld
Xcm_xh36 xhp36 xhn36 vdd cmld
Rnd_mh36 mhp36 mhn36 20k
Rnd_xh36 xhp36 xhn36 20k
Cxhp36 xhp36 0 0.4p
Cxhn36 xhn36 0 0.4p
X_ihm_1_36 a_xp1 a_xn1 wp_wih_1_36 wn_wih_1_36 mhp36 mhn36 vdd vbsyn gsyn
X_ihx_1_36 a_xp1 a_xn1 wp_wih_1_36 wn_wih_1_36 xhp36 xhn36 vdd vbsyn gsyn
X_ihm_2_36 a_xp2 a_xn2 wp_wih_2_36 wn_wih_2_36 mhp36 mhn36 vdd vbsyn gsyn
X_ihx_2_36 a_xp2 a_xn2 wp_wih_2_36 wn_wih_2_36 xhp36 xhn36 vdd vbsyn gsyn
X_bk_36 eop eon wp_who_36 wn_who_36 xhp36 xhn36 vdd vbsyn gsyn
Xn36 xhp36 xhn36 ahp36 ahn36 vdd vbneu dneuron
Xeh36 xhp36 xhn36 mhp36 mhn36 ehp36 ehn36 vdd gm_h esub
Xcm_mh37 mhp37 mhn37 vdd cmld
Xcm_xh37 xhp37 xhn37 vdd cmld
Rnd_mh37 mhp37 mhn37 20k
Rnd_xh37 xhp37 xhn37 20k
Cxhp37 xhp37 0 0.4p
Cxhn37 xhn37 0 0.4p
X_ihm_1_37 a_xp1 a_xn1 wp_wih_1_37 wn_wih_1_37 mhp37 mhn37 vdd vbsyn gsyn
X_ihx_1_37 a_xp1 a_xn1 wp_wih_1_37 wn_wih_1_37 xhp37 xhn37 vdd vbsyn gsyn
X_ihm_2_37 a_xp2 a_xn2 wp_wih_2_37 wn_wih_2_37 mhp37 mhn37 vdd vbsyn gsyn
X_ihx_2_37 a_xp2 a_xn2 wp_wih_2_37 wn_wih_2_37 xhp37 xhn37 vdd vbsyn gsyn
X_bk_37 eop eon wp_who_37 wn_who_37 xhp37 xhn37 vdd vbsyn gsyn
Xn37 xhp37 xhn37 ahp37 ahn37 vdd vbneu dneuron
Xeh37 xhp37 xhn37 mhp37 mhn37 ehp37 ehn37 vdd gm_h esub
Xcm_mh38 mhp38 mhn38 vdd cmld
Xcm_xh38 xhp38 xhn38 vdd cmld
Rnd_mh38 mhp38 mhn38 20k
Rnd_xh38 xhp38 xhn38 20k
Cxhp38 xhp38 0 0.4p
Cxhn38 xhn38 0 0.4p
X_ihm_1_38 a_xp1 a_xn1 wp_wih_1_38 wn_wih_1_38 mhp38 mhn38 vdd vbsyn gsyn
X_ihx_1_38 a_xp1 a_xn1 wp_wih_1_38 wn_wih_1_38 xhp38 xhn38 vdd vbsyn gsyn
X_ihm_2_38 a_xp2 a_xn2 wp_wih_2_38 wn_wih_2_38 mhp38 mhn38 vdd vbsyn gsyn
X_ihx_2_38 a_xp2 a_xn2 wp_wih_2_38 wn_wih_2_38 xhp38 xhn38 vdd vbsyn gsyn
X_bk_38 eop eon wp_who_38 wn_who_38 xhp38 xhn38 vdd vbsyn gsyn
Xn38 xhp38 xhn38 ahp38 ahn38 vdd vbneu dneuron
Xeh38 xhp38 xhn38 mhp38 mhn38 ehp38 ehn38 vdd gm_h esub
Xcm_mh39 mhp39 mhn39 vdd cmld
Xcm_xh39 xhp39 xhn39 vdd cmld
Rnd_mh39 mhp39 mhn39 20k
Rnd_xh39 xhp39 xhn39 20k
Cxhp39 xhp39 0 0.4p
Cxhn39 xhn39 0 0.4p
X_ihm_1_39 a_xp1 a_xn1 wp_wih_1_39 wn_wih_1_39 mhp39 mhn39 vdd vbsyn gsyn
X_ihx_1_39 a_xp1 a_xn1 wp_wih_1_39 wn_wih_1_39 xhp39 xhn39 vdd vbsyn gsyn
X_ihm_2_39 a_xp2 a_xn2 wp_wih_2_39 wn_wih_2_39 mhp39 mhn39 vdd vbsyn gsyn
X_ihx_2_39 a_xp2 a_xn2 wp_wih_2_39 wn_wih_2_39 xhp39 xhn39 vdd vbsyn gsyn
X_bk_39 eop eon wp_who_39 wn_who_39 xhp39 xhn39 vdd vbsyn gsyn
Xn39 xhp39 xhn39 ahp39 ahn39 vdd vbneu dneuron
Xeh39 xhp39 xhn39 mhp39 mhn39 ehp39 ehn39 vdd gm_h esub
Xcm_mh40 mhp40 mhn40 vdd cmld
Xcm_xh40 xhp40 xhn40 vdd cmld
Rnd_mh40 mhp40 mhn40 20k
Rnd_xh40 xhp40 xhn40 20k
Cxhp40 xhp40 0 0.4p
Cxhn40 xhn40 0 0.4p
X_ihm_1_40 a_xp1 a_xn1 wp_wih_1_40 wn_wih_1_40 mhp40 mhn40 vdd vbsyn gsyn
X_ihx_1_40 a_xp1 a_xn1 wp_wih_1_40 wn_wih_1_40 xhp40 xhn40 vdd vbsyn gsyn
X_ihm_2_40 a_xp2 a_xn2 wp_wih_2_40 wn_wih_2_40 mhp40 mhn40 vdd vbsyn gsyn
X_ihx_2_40 a_xp2 a_xn2 wp_wih_2_40 wn_wih_2_40 xhp40 xhn40 vdd vbsyn gsyn
X_bk_40 eop eon wp_who_40 wn_who_40 xhp40 xhn40 vdd vbsyn gsyn
Xn40 xhp40 xhn40 ahp40 ahn40 vdd vbneu dneuron
Xeh40 xhp40 xhn40 mhp40 mhn40 ehp40 ehn40 vdd gm_h esub
Xcm_mh41 mhp41 mhn41 vdd cmld
Xcm_xh41 xhp41 xhn41 vdd cmld
Rnd_mh41 mhp41 mhn41 20k
Rnd_xh41 xhp41 xhn41 20k
Cxhp41 xhp41 0 0.4p
Cxhn41 xhn41 0 0.4p
X_ihm_1_41 a_xp1 a_xn1 wp_wih_1_41 wn_wih_1_41 mhp41 mhn41 vdd vbsyn gsyn
X_ihx_1_41 a_xp1 a_xn1 wp_wih_1_41 wn_wih_1_41 xhp41 xhn41 vdd vbsyn gsyn
X_ihm_2_41 a_xp2 a_xn2 wp_wih_2_41 wn_wih_2_41 mhp41 mhn41 vdd vbsyn gsyn
X_ihx_2_41 a_xp2 a_xn2 wp_wih_2_41 wn_wih_2_41 xhp41 xhn41 vdd vbsyn gsyn
X_bk_41 eop eon wp_who_41 wn_who_41 xhp41 xhn41 vdd vbsyn gsyn
Xn41 xhp41 xhn41 ahp41 ahn41 vdd vbneu dneuron
Xeh41 xhp41 xhn41 mhp41 mhn41 ehp41 ehn41 vdd gm_h esub
Xcm_mh42 mhp42 mhn42 vdd cmld
Xcm_xh42 xhp42 xhn42 vdd cmld
Rnd_mh42 mhp42 mhn42 20k
Rnd_xh42 xhp42 xhn42 20k
Cxhp42 xhp42 0 0.4p
Cxhn42 xhn42 0 0.4p
X_ihm_1_42 a_xp1 a_xn1 wp_wih_1_42 wn_wih_1_42 mhp42 mhn42 vdd vbsyn gsyn
X_ihx_1_42 a_xp1 a_xn1 wp_wih_1_42 wn_wih_1_42 xhp42 xhn42 vdd vbsyn gsyn
X_ihm_2_42 a_xp2 a_xn2 wp_wih_2_42 wn_wih_2_42 mhp42 mhn42 vdd vbsyn gsyn
X_ihx_2_42 a_xp2 a_xn2 wp_wih_2_42 wn_wih_2_42 xhp42 xhn42 vdd vbsyn gsyn
X_bk_42 eop eon wp_who_42 wn_who_42 xhp42 xhn42 vdd vbsyn gsyn
Xn42 xhp42 xhn42 ahp42 ahn42 vdd vbneu dneuron
Xeh42 xhp42 xhn42 mhp42 mhn42 ehp42 ehn42 vdd gm_h esub
Xcm_mh43 mhp43 mhn43 vdd cmld
Xcm_xh43 xhp43 xhn43 vdd cmld
Rnd_mh43 mhp43 mhn43 20k
Rnd_xh43 xhp43 xhn43 20k
Cxhp43 xhp43 0 0.4p
Cxhn43 xhn43 0 0.4p
X_ihm_1_43 a_xp1 a_xn1 wp_wih_1_43 wn_wih_1_43 mhp43 mhn43 vdd vbsyn gsyn
X_ihx_1_43 a_xp1 a_xn1 wp_wih_1_43 wn_wih_1_43 xhp43 xhn43 vdd vbsyn gsyn
X_ihm_2_43 a_xp2 a_xn2 wp_wih_2_43 wn_wih_2_43 mhp43 mhn43 vdd vbsyn gsyn
X_ihx_2_43 a_xp2 a_xn2 wp_wih_2_43 wn_wih_2_43 xhp43 xhn43 vdd vbsyn gsyn
X_bk_43 eop eon wp_who_43 wn_who_43 xhp43 xhn43 vdd vbsyn gsyn
Xn43 xhp43 xhn43 ahp43 ahn43 vdd vbneu dneuron
Xeh43 xhp43 xhn43 mhp43 mhn43 ehp43 ehn43 vdd gm_h esub
Xcm_mh44 mhp44 mhn44 vdd cmld
Xcm_xh44 xhp44 xhn44 vdd cmld
Rnd_mh44 mhp44 mhn44 20k
Rnd_xh44 xhp44 xhn44 20k
Cxhp44 xhp44 0 0.4p
Cxhn44 xhn44 0 0.4p
X_ihm_1_44 a_xp1 a_xn1 wp_wih_1_44 wn_wih_1_44 mhp44 mhn44 vdd vbsyn gsyn
X_ihx_1_44 a_xp1 a_xn1 wp_wih_1_44 wn_wih_1_44 xhp44 xhn44 vdd vbsyn gsyn
X_ihm_2_44 a_xp2 a_xn2 wp_wih_2_44 wn_wih_2_44 mhp44 mhn44 vdd vbsyn gsyn
X_ihx_2_44 a_xp2 a_xn2 wp_wih_2_44 wn_wih_2_44 xhp44 xhn44 vdd vbsyn gsyn
X_bk_44 eop eon wp_who_44 wn_who_44 xhp44 xhn44 vdd vbsyn gsyn
Xn44 xhp44 xhn44 ahp44 ahn44 vdd vbneu dneuron
Xeh44 xhp44 xhn44 mhp44 mhn44 ehp44 ehn44 vdd gm_h esub
Xcm_mh45 mhp45 mhn45 vdd cmld
Xcm_xh45 xhp45 xhn45 vdd cmld
Rnd_mh45 mhp45 mhn45 20k
Rnd_xh45 xhp45 xhn45 20k
Cxhp45 xhp45 0 0.4p
Cxhn45 xhn45 0 0.4p
X_ihm_1_45 a_xp1 a_xn1 wp_wih_1_45 wn_wih_1_45 mhp45 mhn45 vdd vbsyn gsyn
X_ihx_1_45 a_xp1 a_xn1 wp_wih_1_45 wn_wih_1_45 xhp45 xhn45 vdd vbsyn gsyn
X_ihm_2_45 a_xp2 a_xn2 wp_wih_2_45 wn_wih_2_45 mhp45 mhn45 vdd vbsyn gsyn
X_ihx_2_45 a_xp2 a_xn2 wp_wih_2_45 wn_wih_2_45 xhp45 xhn45 vdd vbsyn gsyn
X_bk_45 eop eon wp_who_45 wn_who_45 xhp45 xhn45 vdd vbsyn gsyn
Xn45 xhp45 xhn45 ahp45 ahn45 vdd vbneu dneuron
Xeh45 xhp45 xhn45 mhp45 mhn45 ehp45 ehn45 vdd gm_h esub
Xcm_mh46 mhp46 mhn46 vdd cmld
Xcm_xh46 xhp46 xhn46 vdd cmld
Rnd_mh46 mhp46 mhn46 20k
Rnd_xh46 xhp46 xhn46 20k
Cxhp46 xhp46 0 0.4p
Cxhn46 xhn46 0 0.4p
X_ihm_1_46 a_xp1 a_xn1 wp_wih_1_46 wn_wih_1_46 mhp46 mhn46 vdd vbsyn gsyn
X_ihx_1_46 a_xp1 a_xn1 wp_wih_1_46 wn_wih_1_46 xhp46 xhn46 vdd vbsyn gsyn
X_ihm_2_46 a_xp2 a_xn2 wp_wih_2_46 wn_wih_2_46 mhp46 mhn46 vdd vbsyn gsyn
X_ihx_2_46 a_xp2 a_xn2 wp_wih_2_46 wn_wih_2_46 xhp46 xhn46 vdd vbsyn gsyn
X_bk_46 eop eon wp_who_46 wn_who_46 xhp46 xhn46 vdd vbsyn gsyn
Xn46 xhp46 xhn46 ahp46 ahn46 vdd vbneu dneuron
Xeh46 xhp46 xhn46 mhp46 mhn46 ehp46 ehn46 vdd gm_h esub
Xcm_mh47 mhp47 mhn47 vdd cmld
Xcm_xh47 xhp47 xhn47 vdd cmld
Rnd_mh47 mhp47 mhn47 20k
Rnd_xh47 xhp47 xhn47 20k
Cxhp47 xhp47 0 0.4p
Cxhn47 xhn47 0 0.4p
X_ihm_1_47 a_xp1 a_xn1 wp_wih_1_47 wn_wih_1_47 mhp47 mhn47 vdd vbsyn gsyn
X_ihx_1_47 a_xp1 a_xn1 wp_wih_1_47 wn_wih_1_47 xhp47 xhn47 vdd vbsyn gsyn
X_ihm_2_47 a_xp2 a_xn2 wp_wih_2_47 wn_wih_2_47 mhp47 mhn47 vdd vbsyn gsyn
X_ihx_2_47 a_xp2 a_xn2 wp_wih_2_47 wn_wih_2_47 xhp47 xhn47 vdd vbsyn gsyn
X_bk_47 eop eon wp_who_47 wn_who_47 xhp47 xhn47 vdd vbsyn gsyn
Xn47 xhp47 xhn47 ahp47 ahn47 vdd vbneu dneuron
Xeh47 xhp47 xhn47 mhp47 mhn47 ehp47 ehn47 vdd gm_h esub
Xcm_mh48 mhp48 mhn48 vdd cmld
Xcm_xh48 xhp48 xhn48 vdd cmld
Rnd_mh48 mhp48 mhn48 20k
Rnd_xh48 xhp48 xhn48 20k
Cxhp48 xhp48 0 0.4p
Cxhn48 xhn48 0 0.4p
X_ihm_1_48 a_xp1 a_xn1 wp_wih_1_48 wn_wih_1_48 mhp48 mhn48 vdd vbsyn gsyn
X_ihx_1_48 a_xp1 a_xn1 wp_wih_1_48 wn_wih_1_48 xhp48 xhn48 vdd vbsyn gsyn
X_ihm_2_48 a_xp2 a_xn2 wp_wih_2_48 wn_wih_2_48 mhp48 mhn48 vdd vbsyn gsyn
X_ihx_2_48 a_xp2 a_xn2 wp_wih_2_48 wn_wih_2_48 xhp48 xhn48 vdd vbsyn gsyn
X_bk_48 eop eon wp_who_48 wn_who_48 xhp48 xhn48 vdd vbsyn gsyn
Xn48 xhp48 xhn48 ahp48 ahn48 vdd vbneu dneuron
Xeh48 xhp48 xhn48 mhp48 mhn48 ehp48 ehn48 vdd gm_h esub
Xcm_mh49 mhp49 mhn49 vdd cmld
Xcm_xh49 xhp49 xhn49 vdd cmld
Rnd_mh49 mhp49 mhn49 20k
Rnd_xh49 xhp49 xhn49 20k
Cxhp49 xhp49 0 0.4p
Cxhn49 xhn49 0 0.4p
X_ihm_1_49 a_xp1 a_xn1 wp_wih_1_49 wn_wih_1_49 mhp49 mhn49 vdd vbsyn gsyn
X_ihx_1_49 a_xp1 a_xn1 wp_wih_1_49 wn_wih_1_49 xhp49 xhn49 vdd vbsyn gsyn
X_ihm_2_49 a_xp2 a_xn2 wp_wih_2_49 wn_wih_2_49 mhp49 mhn49 vdd vbsyn gsyn
X_ihx_2_49 a_xp2 a_xn2 wp_wih_2_49 wn_wih_2_49 xhp49 xhn49 vdd vbsyn gsyn
X_bk_49 eop eon wp_who_49 wn_who_49 xhp49 xhn49 vdd vbsyn gsyn
Xn49 xhp49 xhn49 ahp49 ahn49 vdd vbneu dneuron
Xeh49 xhp49 xhn49 mhp49 mhn49 ehp49 ehn49 vdd gm_h esub
Xcm_mh50 mhp50 mhn50 vdd cmld
Xcm_xh50 xhp50 xhn50 vdd cmld
Rnd_mh50 mhp50 mhn50 20k
Rnd_xh50 xhp50 xhn50 20k
Cxhp50 xhp50 0 0.4p
Cxhn50 xhn50 0 0.4p
X_ihm_1_50 a_xp1 a_xn1 wp_wih_1_50 wn_wih_1_50 mhp50 mhn50 vdd vbsyn gsyn
X_ihx_1_50 a_xp1 a_xn1 wp_wih_1_50 wn_wih_1_50 xhp50 xhn50 vdd vbsyn gsyn
X_ihm_2_50 a_xp2 a_xn2 wp_wih_2_50 wn_wih_2_50 mhp50 mhn50 vdd vbsyn gsyn
X_ihx_2_50 a_xp2 a_xn2 wp_wih_2_50 wn_wih_2_50 xhp50 xhn50 vdd vbsyn gsyn
X_bk_50 eop eon wp_who_50 wn_who_50 xhp50 xhn50 vdd vbsyn gsyn
Xn50 xhp50 xhn50 ahp50 ahn50 vdd vbneu dneuron
Xeh50 xhp50 xhn50 mhp50 mhn50 ehp50 ehn50 vdd gm_h esub
Xcm_mh51 mhp51 mhn51 vdd cmld
Xcm_xh51 xhp51 xhn51 vdd cmld
Rnd_mh51 mhp51 mhn51 20k
Rnd_xh51 xhp51 xhn51 20k
Cxhp51 xhp51 0 0.4p
Cxhn51 xhn51 0 0.4p
X_ihm_1_51 a_xp1 a_xn1 wp_wih_1_51 wn_wih_1_51 mhp51 mhn51 vdd vbsyn gsyn
X_ihx_1_51 a_xp1 a_xn1 wp_wih_1_51 wn_wih_1_51 xhp51 xhn51 vdd vbsyn gsyn
X_ihm_2_51 a_xp2 a_xn2 wp_wih_2_51 wn_wih_2_51 mhp51 mhn51 vdd vbsyn gsyn
X_ihx_2_51 a_xp2 a_xn2 wp_wih_2_51 wn_wih_2_51 xhp51 xhn51 vdd vbsyn gsyn
X_bk_51 eop eon wp_who_51 wn_who_51 xhp51 xhn51 vdd vbsyn gsyn
Xn51 xhp51 xhn51 ahp51 ahn51 vdd vbneu dneuron
Xeh51 xhp51 xhn51 mhp51 mhn51 ehp51 ehn51 vdd gm_h esub
Xcm_mh52 mhp52 mhn52 vdd cmld
Xcm_xh52 xhp52 xhn52 vdd cmld
Rnd_mh52 mhp52 mhn52 20k
Rnd_xh52 xhp52 xhn52 20k
Cxhp52 xhp52 0 0.4p
Cxhn52 xhn52 0 0.4p
X_ihm_1_52 a_xp1 a_xn1 wp_wih_1_52 wn_wih_1_52 mhp52 mhn52 vdd vbsyn gsyn
X_ihx_1_52 a_xp1 a_xn1 wp_wih_1_52 wn_wih_1_52 xhp52 xhn52 vdd vbsyn gsyn
X_ihm_2_52 a_xp2 a_xn2 wp_wih_2_52 wn_wih_2_52 mhp52 mhn52 vdd vbsyn gsyn
X_ihx_2_52 a_xp2 a_xn2 wp_wih_2_52 wn_wih_2_52 xhp52 xhn52 vdd vbsyn gsyn
X_bk_52 eop eon wp_who_52 wn_who_52 xhp52 xhn52 vdd vbsyn gsyn
Xn52 xhp52 xhn52 ahp52 ahn52 vdd vbneu dneuron
Xeh52 xhp52 xhn52 mhp52 mhn52 ehp52 ehn52 vdd gm_h esub
Xcm_mh53 mhp53 mhn53 vdd cmld
Xcm_xh53 xhp53 xhn53 vdd cmld
Rnd_mh53 mhp53 mhn53 20k
Rnd_xh53 xhp53 xhn53 20k
Cxhp53 xhp53 0 0.4p
Cxhn53 xhn53 0 0.4p
X_ihm_1_53 a_xp1 a_xn1 wp_wih_1_53 wn_wih_1_53 mhp53 mhn53 vdd vbsyn gsyn
X_ihx_1_53 a_xp1 a_xn1 wp_wih_1_53 wn_wih_1_53 xhp53 xhn53 vdd vbsyn gsyn
X_ihm_2_53 a_xp2 a_xn2 wp_wih_2_53 wn_wih_2_53 mhp53 mhn53 vdd vbsyn gsyn
X_ihx_2_53 a_xp2 a_xn2 wp_wih_2_53 wn_wih_2_53 xhp53 xhn53 vdd vbsyn gsyn
X_bk_53 eop eon wp_who_53 wn_who_53 xhp53 xhn53 vdd vbsyn gsyn
Xn53 xhp53 xhn53 ahp53 ahn53 vdd vbneu dneuron
Xeh53 xhp53 xhn53 mhp53 mhn53 ehp53 ehn53 vdd gm_h esub
Xcm_mh54 mhp54 mhn54 vdd cmld
Xcm_xh54 xhp54 xhn54 vdd cmld
Rnd_mh54 mhp54 mhn54 20k
Rnd_xh54 xhp54 xhn54 20k
Cxhp54 xhp54 0 0.4p
Cxhn54 xhn54 0 0.4p
X_ihm_1_54 a_xp1 a_xn1 wp_wih_1_54 wn_wih_1_54 mhp54 mhn54 vdd vbsyn gsyn
X_ihx_1_54 a_xp1 a_xn1 wp_wih_1_54 wn_wih_1_54 xhp54 xhn54 vdd vbsyn gsyn
X_ihm_2_54 a_xp2 a_xn2 wp_wih_2_54 wn_wih_2_54 mhp54 mhn54 vdd vbsyn gsyn
X_ihx_2_54 a_xp2 a_xn2 wp_wih_2_54 wn_wih_2_54 xhp54 xhn54 vdd vbsyn gsyn
X_bk_54 eop eon wp_who_54 wn_who_54 xhp54 xhn54 vdd vbsyn gsyn
Xn54 xhp54 xhn54 ahp54 ahn54 vdd vbneu dneuron
Xeh54 xhp54 xhn54 mhp54 mhn54 ehp54 ehn54 vdd gm_h esub
Xcm_mh55 mhp55 mhn55 vdd cmld
Xcm_xh55 xhp55 xhn55 vdd cmld
Rnd_mh55 mhp55 mhn55 20k
Rnd_xh55 xhp55 xhn55 20k
Cxhp55 xhp55 0 0.4p
Cxhn55 xhn55 0 0.4p
X_ihm_1_55 a_xp1 a_xn1 wp_wih_1_55 wn_wih_1_55 mhp55 mhn55 vdd vbsyn gsyn
X_ihx_1_55 a_xp1 a_xn1 wp_wih_1_55 wn_wih_1_55 xhp55 xhn55 vdd vbsyn gsyn
X_ihm_2_55 a_xp2 a_xn2 wp_wih_2_55 wn_wih_2_55 mhp55 mhn55 vdd vbsyn gsyn
X_ihx_2_55 a_xp2 a_xn2 wp_wih_2_55 wn_wih_2_55 xhp55 xhn55 vdd vbsyn gsyn
X_bk_55 eop eon wp_who_55 wn_who_55 xhp55 xhn55 vdd vbsyn gsyn
Xn55 xhp55 xhn55 ahp55 ahn55 vdd vbneu dneuron
Xeh55 xhp55 xhn55 mhp55 mhn55 ehp55 ehn55 vdd gm_h esub
Xcm_mh56 mhp56 mhn56 vdd cmld
Xcm_xh56 xhp56 xhn56 vdd cmld
Rnd_mh56 mhp56 mhn56 20k
Rnd_xh56 xhp56 xhn56 20k
Cxhp56 xhp56 0 0.4p
Cxhn56 xhn56 0 0.4p
X_ihm_1_56 a_xp1 a_xn1 wp_wih_1_56 wn_wih_1_56 mhp56 mhn56 vdd vbsyn gsyn
X_ihx_1_56 a_xp1 a_xn1 wp_wih_1_56 wn_wih_1_56 xhp56 xhn56 vdd vbsyn gsyn
X_ihm_2_56 a_xp2 a_xn2 wp_wih_2_56 wn_wih_2_56 mhp56 mhn56 vdd vbsyn gsyn
X_ihx_2_56 a_xp2 a_xn2 wp_wih_2_56 wn_wih_2_56 xhp56 xhn56 vdd vbsyn gsyn
X_bk_56 eop eon wp_who_56 wn_who_56 xhp56 xhn56 vdd vbsyn gsyn
Xn56 xhp56 xhn56 ahp56 ahn56 vdd vbneu dneuron
Xeh56 xhp56 xhn56 mhp56 mhn56 ehp56 ehn56 vdd gm_h esub
Xcm_mh57 mhp57 mhn57 vdd cmld
Xcm_xh57 xhp57 xhn57 vdd cmld
Rnd_mh57 mhp57 mhn57 20k
Rnd_xh57 xhp57 xhn57 20k
Cxhp57 xhp57 0 0.4p
Cxhn57 xhn57 0 0.4p
X_ihm_1_57 a_xp1 a_xn1 wp_wih_1_57 wn_wih_1_57 mhp57 mhn57 vdd vbsyn gsyn
X_ihx_1_57 a_xp1 a_xn1 wp_wih_1_57 wn_wih_1_57 xhp57 xhn57 vdd vbsyn gsyn
X_ihm_2_57 a_xp2 a_xn2 wp_wih_2_57 wn_wih_2_57 mhp57 mhn57 vdd vbsyn gsyn
X_ihx_2_57 a_xp2 a_xn2 wp_wih_2_57 wn_wih_2_57 xhp57 xhn57 vdd vbsyn gsyn
X_bk_57 eop eon wp_who_57 wn_who_57 xhp57 xhn57 vdd vbsyn gsyn
Xn57 xhp57 xhn57 ahp57 ahn57 vdd vbneu dneuron
Xeh57 xhp57 xhn57 mhp57 mhn57 ehp57 ehn57 vdd gm_h esub
Xcm_mh58 mhp58 mhn58 vdd cmld
Xcm_xh58 xhp58 xhn58 vdd cmld
Rnd_mh58 mhp58 mhn58 20k
Rnd_xh58 xhp58 xhn58 20k
Cxhp58 xhp58 0 0.4p
Cxhn58 xhn58 0 0.4p
X_ihm_1_58 a_xp1 a_xn1 wp_wih_1_58 wn_wih_1_58 mhp58 mhn58 vdd vbsyn gsyn
X_ihx_1_58 a_xp1 a_xn1 wp_wih_1_58 wn_wih_1_58 xhp58 xhn58 vdd vbsyn gsyn
X_ihm_2_58 a_xp2 a_xn2 wp_wih_2_58 wn_wih_2_58 mhp58 mhn58 vdd vbsyn gsyn
X_ihx_2_58 a_xp2 a_xn2 wp_wih_2_58 wn_wih_2_58 xhp58 xhn58 vdd vbsyn gsyn
X_bk_58 eop eon wp_who_58 wn_who_58 xhp58 xhn58 vdd vbsyn gsyn
Xn58 xhp58 xhn58 ahp58 ahn58 vdd vbneu dneuron
Xeh58 xhp58 xhn58 mhp58 mhn58 ehp58 ehn58 vdd gm_h esub
Xcm_mh59 mhp59 mhn59 vdd cmld
Xcm_xh59 xhp59 xhn59 vdd cmld
Rnd_mh59 mhp59 mhn59 20k
Rnd_xh59 xhp59 xhn59 20k
Cxhp59 xhp59 0 0.4p
Cxhn59 xhn59 0 0.4p
X_ihm_1_59 a_xp1 a_xn1 wp_wih_1_59 wn_wih_1_59 mhp59 mhn59 vdd vbsyn gsyn
X_ihx_1_59 a_xp1 a_xn1 wp_wih_1_59 wn_wih_1_59 xhp59 xhn59 vdd vbsyn gsyn
X_ihm_2_59 a_xp2 a_xn2 wp_wih_2_59 wn_wih_2_59 mhp59 mhn59 vdd vbsyn gsyn
X_ihx_2_59 a_xp2 a_xn2 wp_wih_2_59 wn_wih_2_59 xhp59 xhn59 vdd vbsyn gsyn
X_bk_59 eop eon wp_who_59 wn_who_59 xhp59 xhn59 vdd vbsyn gsyn
Xn59 xhp59 xhn59 ahp59 ahn59 vdd vbneu dneuron
Xeh59 xhp59 xhn59 mhp59 mhn59 ehp59 ehn59 vdd gm_h esub
Xcm_mh60 mhp60 mhn60 vdd cmld
Xcm_xh60 xhp60 xhn60 vdd cmld
Rnd_mh60 mhp60 mhn60 20k
Rnd_xh60 xhp60 xhn60 20k
Cxhp60 xhp60 0 0.4p
Cxhn60 xhn60 0 0.4p
X_ihm_1_60 a_xp1 a_xn1 wp_wih_1_60 wn_wih_1_60 mhp60 mhn60 vdd vbsyn gsyn
X_ihx_1_60 a_xp1 a_xn1 wp_wih_1_60 wn_wih_1_60 xhp60 xhn60 vdd vbsyn gsyn
X_ihm_2_60 a_xp2 a_xn2 wp_wih_2_60 wn_wih_2_60 mhp60 mhn60 vdd vbsyn gsyn
X_ihx_2_60 a_xp2 a_xn2 wp_wih_2_60 wn_wih_2_60 xhp60 xhn60 vdd vbsyn gsyn
X_bk_60 eop eon wp_who_60 wn_who_60 xhp60 xhn60 vdd vbsyn gsyn
Xn60 xhp60 xhn60 ahp60 ahn60 vdd vbneu dneuron
Xeh60 xhp60 xhn60 mhp60 mhn60 ehp60 ehn60 vdd gm_h esub
Xcm_mh61 mhp61 mhn61 vdd cmld
Xcm_xh61 xhp61 xhn61 vdd cmld
Rnd_mh61 mhp61 mhn61 20k
Rnd_xh61 xhp61 xhn61 20k
Cxhp61 xhp61 0 0.4p
Cxhn61 xhn61 0 0.4p
X_ihm_1_61 a_xp1 a_xn1 wp_wih_1_61 wn_wih_1_61 mhp61 mhn61 vdd vbsyn gsyn
X_ihx_1_61 a_xp1 a_xn1 wp_wih_1_61 wn_wih_1_61 xhp61 xhn61 vdd vbsyn gsyn
X_ihm_2_61 a_xp2 a_xn2 wp_wih_2_61 wn_wih_2_61 mhp61 mhn61 vdd vbsyn gsyn
X_ihx_2_61 a_xp2 a_xn2 wp_wih_2_61 wn_wih_2_61 xhp61 xhn61 vdd vbsyn gsyn
X_bk_61 eop eon wp_who_61 wn_who_61 xhp61 xhn61 vdd vbsyn gsyn
Xn61 xhp61 xhn61 ahp61 ahn61 vdd vbneu dneuron
Xeh61 xhp61 xhn61 mhp61 mhn61 ehp61 ehn61 vdd gm_h esub
Xcm_mh62 mhp62 mhn62 vdd cmld
Xcm_xh62 xhp62 xhn62 vdd cmld
Rnd_mh62 mhp62 mhn62 20k
Rnd_xh62 xhp62 xhn62 20k
Cxhp62 xhp62 0 0.4p
Cxhn62 xhn62 0 0.4p
X_ihm_1_62 a_xp1 a_xn1 wp_wih_1_62 wn_wih_1_62 mhp62 mhn62 vdd vbsyn gsyn
X_ihx_1_62 a_xp1 a_xn1 wp_wih_1_62 wn_wih_1_62 xhp62 xhn62 vdd vbsyn gsyn
X_ihm_2_62 a_xp2 a_xn2 wp_wih_2_62 wn_wih_2_62 mhp62 mhn62 vdd vbsyn gsyn
X_ihx_2_62 a_xp2 a_xn2 wp_wih_2_62 wn_wih_2_62 xhp62 xhn62 vdd vbsyn gsyn
X_bk_62 eop eon wp_who_62 wn_who_62 xhp62 xhn62 vdd vbsyn gsyn
Xn62 xhp62 xhn62 ahp62 ahn62 vdd vbneu dneuron
Xeh62 xhp62 xhn62 mhp62 mhn62 ehp62 ehn62 vdd gm_h esub
Xcm_mh63 mhp63 mhn63 vdd cmld
Xcm_xh63 xhp63 xhn63 vdd cmld
Rnd_mh63 mhp63 mhn63 20k
Rnd_xh63 xhp63 xhn63 20k
Cxhp63 xhp63 0 0.4p
Cxhn63 xhn63 0 0.4p
X_ihm_1_63 a_xp1 a_xn1 wp_wih_1_63 wn_wih_1_63 mhp63 mhn63 vdd vbsyn gsyn
X_ihx_1_63 a_xp1 a_xn1 wp_wih_1_63 wn_wih_1_63 xhp63 xhn63 vdd vbsyn gsyn
X_ihm_2_63 a_xp2 a_xn2 wp_wih_2_63 wn_wih_2_63 mhp63 mhn63 vdd vbsyn gsyn
X_ihx_2_63 a_xp2 a_xn2 wp_wih_2_63 wn_wih_2_63 xhp63 xhn63 vdd vbsyn gsyn
X_bk_63 eop eon wp_who_63 wn_who_63 xhp63 xhn63 vdd vbsyn gsyn
Xn63 xhp63 xhn63 ahp63 ahn63 vdd vbneu dneuron
Xeh63 xhp63 xhn63 mhp63 mhn63 ehp63 ehn63 vdd gm_h esub
Xcm_mo mop mon vdd cmld
Rnd_mo mop mon 20k
X_ho_0 ahp0 ahn0 wp_who_0 wn_who_0 mop mon vdd vbsyn gsyn
X_ho_1 ahp1 ahn1 wp_who_1 wn_who_1 mop mon vdd vbsyn gsyn
X_ho_2 ahp2 ahn2 wp_who_2 wn_who_2 mop mon vdd vbsyn gsyn
X_ho_3 ahp3 ahn3 wp_who_3 wn_who_3 mop mon vdd vbsyn gsyn
X_ho_4 ahp4 ahn4 wp_who_4 wn_who_4 mop mon vdd vbsyn gsyn
X_ho_5 ahp5 ahn5 wp_who_5 wn_who_5 mop mon vdd vbsyn gsyn
X_ho_6 ahp6 ahn6 wp_who_6 wn_who_6 mop mon vdd vbsyn gsyn
X_ho_7 ahp7 ahn7 wp_who_7 wn_who_7 mop mon vdd vbsyn gsyn
X_ho_8 ahp8 ahn8 wp_who_8 wn_who_8 mop mon vdd vbsyn gsyn
X_ho_9 ahp9 ahn9 wp_who_9 wn_who_9 mop mon vdd vbsyn gsyn
X_ho_10 ahp10 ahn10 wp_who_10 wn_who_10 mop mon vdd vbsyn gsyn
X_ho_11 ahp11 ahn11 wp_who_11 wn_who_11 mop mon vdd vbsyn gsyn
X_ho_12 ahp12 ahn12 wp_who_12 wn_who_12 mop mon vdd vbsyn gsyn
X_ho_13 ahp13 ahn13 wp_who_13 wn_who_13 mop mon vdd vbsyn gsyn
X_ho_14 ahp14 ahn14 wp_who_14 wn_who_14 mop mon vdd vbsyn gsyn
X_ho_15 ahp15 ahn15 wp_who_15 wn_who_15 mop mon vdd vbsyn gsyn
X_ho_16 ahp16 ahn16 wp_who_16 wn_who_16 mop mon vdd vbsyn gsyn
X_ho_17 ahp17 ahn17 wp_who_17 wn_who_17 mop mon vdd vbsyn gsyn
X_ho_18 ahp18 ahn18 wp_who_18 wn_who_18 mop mon vdd vbsyn gsyn
X_ho_19 ahp19 ahn19 wp_who_19 wn_who_19 mop mon vdd vbsyn gsyn
X_ho_20 ahp20 ahn20 wp_who_20 wn_who_20 mop mon vdd vbsyn gsyn
X_ho_21 ahp21 ahn21 wp_who_21 wn_who_21 mop mon vdd vbsyn gsyn
X_ho_22 ahp22 ahn22 wp_who_22 wn_who_22 mop mon vdd vbsyn gsyn
X_ho_23 ahp23 ahn23 wp_who_23 wn_who_23 mop mon vdd vbsyn gsyn
X_ho_24 ahp24 ahn24 wp_who_24 wn_who_24 mop mon vdd vbsyn gsyn
X_ho_25 ahp25 ahn25 wp_who_25 wn_who_25 mop mon vdd vbsyn gsyn
X_ho_26 ahp26 ahn26 wp_who_26 wn_who_26 mop mon vdd vbsyn gsyn
X_ho_27 ahp27 ahn27 wp_who_27 wn_who_27 mop mon vdd vbsyn gsyn
X_ho_28 ahp28 ahn28 wp_who_28 wn_who_28 mop mon vdd vbsyn gsyn
X_ho_29 ahp29 ahn29 wp_who_29 wn_who_29 mop mon vdd vbsyn gsyn
X_ho_30 ahp30 ahn30 wp_who_30 wn_who_30 mop mon vdd vbsyn gsyn
X_ho_31 ahp31 ahn31 wp_who_31 wn_who_31 mop mon vdd vbsyn gsyn
X_ho_32 ahp32 ahn32 wp_who_32 wn_who_32 mop mon vdd vbsyn gsyn
X_ho_33 ahp33 ahn33 wp_who_33 wn_who_33 mop mon vdd vbsyn gsyn
X_ho_34 ahp34 ahn34 wp_who_34 wn_who_34 mop mon vdd vbsyn gsyn
X_ho_35 ahp35 ahn35 wp_who_35 wn_who_35 mop mon vdd vbsyn gsyn
X_ho_36 ahp36 ahn36 wp_who_36 wn_who_36 mop mon vdd vbsyn gsyn
X_ho_37 ahp37 ahn37 wp_who_37 wn_who_37 mop mon vdd vbsyn gsyn
X_ho_38 ahp38 ahn38 wp_who_38 wn_who_38 mop mon vdd vbsyn gsyn
X_ho_39 ahp39 ahn39 wp_who_39 wn_who_39 mop mon vdd vbsyn gsyn
X_ho_40 ahp40 ahn40 wp_who_40 wn_who_40 mop mon vdd vbsyn gsyn
X_ho_41 ahp41 ahn41 wp_who_41 wn_who_41 mop mon vdd vbsyn gsyn
X_ho_42 ahp42 ahn42 wp_who_42 wn_who_42 mop mon vdd vbsyn gsyn
X_ho_43 ahp43 ahn43 wp_who_43 wn_who_43 mop mon vdd vbsyn gsyn
X_ho_44 ahp44 ahn44 wp_who_44 wn_who_44 mop mon vdd vbsyn gsyn
X_ho_45 ahp45 ahn45 wp_who_45 wn_who_45 mop mon vdd vbsyn gsyn
X_ho_46 ahp46 ahn46 wp_who_46 wn_who_46 mop mon vdd vbsyn gsyn
X_ho_47 ahp47 ahn47 wp_who_47 wn_who_47 mop mon vdd vbsyn gsyn
X_ho_48 ahp48 ahn48 wp_who_48 wn_who_48 mop mon vdd vbsyn gsyn
X_ho_49 ahp49 ahn49 wp_who_49 wn_who_49 mop mon vdd vbsyn gsyn
X_ho_50 ahp50 ahn50 wp_who_50 wn_who_50 mop mon vdd vbsyn gsyn
X_ho_51 ahp51 ahn51 wp_who_51 wn_who_51 mop mon vdd vbsyn gsyn
X_ho_52 ahp52 ahn52 wp_who_52 wn_who_52 mop mon vdd vbsyn gsyn
X_ho_53 ahp53 ahn53 wp_who_53 wn_who_53 mop mon vdd vbsyn gsyn
X_ho_54 ahp54 ahn54 wp_who_54 wn_who_54 mop mon vdd vbsyn gsyn
X_ho_55 ahp55 ahn55 wp_who_55 wn_who_55 mop mon vdd vbsyn gsyn
X_ho_56 ahp56 ahn56 wp_who_56 wn_who_56 mop mon vdd vbsyn gsyn
X_ho_57 ahp57 ahn57 wp_who_57 wn_who_57 mop mon vdd vbsyn gsyn
X_ho_58 ahp58 ahn58 wp_who_58 wn_who_58 mop mon vdd vbsyn gsyn
X_ho_59 ahp59 ahn59 wp_who_59 wn_who_59 mop mon vdd vbsyn gsyn
X_ho_60 ahp60 ahn60 wp_who_60 wn_who_60 mop mon vdd vbsyn gsyn
X_ho_61 ahp61 ahn61 wp_who_61 wn_who_61 mop mon vdd vbsyn gsyn
X_ho_62 ahp62 ahn62 wp_who_62 wn_who_62 mop mon vdd vbsyn gsyn
X_ho_63 ahp63 ahn63 wp_who_63 wn_who_63 mop mon vdd vbsyn gsyn
Xeo xop xon mop mon eop eon vdd gm_o esub
Xcm_mo2 mop2 mon2 vdd cmld
Rnd_mo2 mop2 mon2 20k
X_ho2_0 ahp0 ahn0 wp_who_0 wn_who_0 mop2 mon2 vdd vbsyn gsyn
X_ho2_1 ahp1 ahn1 wp_who_1 wn_who_1 mop2 mon2 vdd vbsyn gsyn
X_ho2_2 ahp2 ahn2 wp_who_2 wn_who_2 mop2 mon2 vdd vbsyn gsyn
X_ho2_3 ahp3 ahn3 wp_who_3 wn_who_3 mop2 mon2 vdd vbsyn gsyn
X_ho2_4 ahp4 ahn4 wp_who_4 wn_who_4 mop2 mon2 vdd vbsyn gsyn
X_ho2_5 ahp5 ahn5 wp_who_5 wn_who_5 mop2 mon2 vdd vbsyn gsyn
X_ho2_6 ahp6 ahn6 wp_who_6 wn_who_6 mop2 mon2 vdd vbsyn gsyn
X_ho2_7 ahp7 ahn7 wp_who_7 wn_who_7 mop2 mon2 vdd vbsyn gsyn
X_ho2_8 ahp8 ahn8 wp_who_8 wn_who_8 mop2 mon2 vdd vbsyn gsyn
X_ho2_9 ahp9 ahn9 wp_who_9 wn_who_9 mop2 mon2 vdd vbsyn gsyn
X_ho2_10 ahp10 ahn10 wp_who_10 wn_who_10 mop2 mon2 vdd vbsyn gsyn
X_ho2_11 ahp11 ahn11 wp_who_11 wn_who_11 mop2 mon2 vdd vbsyn gsyn
X_ho2_12 ahp12 ahn12 wp_who_12 wn_who_12 mop2 mon2 vdd vbsyn gsyn
X_ho2_13 ahp13 ahn13 wp_who_13 wn_who_13 mop2 mon2 vdd vbsyn gsyn
X_ho2_14 ahp14 ahn14 wp_who_14 wn_who_14 mop2 mon2 vdd vbsyn gsyn
X_ho2_15 ahp15 ahn15 wp_who_15 wn_who_15 mop2 mon2 vdd vbsyn gsyn
X_ho2_16 ahp16 ahn16 wp_who_16 wn_who_16 mop2 mon2 vdd vbsyn gsyn
X_ho2_17 ahp17 ahn17 wp_who_17 wn_who_17 mop2 mon2 vdd vbsyn gsyn
X_ho2_18 ahp18 ahn18 wp_who_18 wn_who_18 mop2 mon2 vdd vbsyn gsyn
X_ho2_19 ahp19 ahn19 wp_who_19 wn_who_19 mop2 mon2 vdd vbsyn gsyn
X_ho2_20 ahp20 ahn20 wp_who_20 wn_who_20 mop2 mon2 vdd vbsyn gsyn
X_ho2_21 ahp21 ahn21 wp_who_21 wn_who_21 mop2 mon2 vdd vbsyn gsyn
X_ho2_22 ahp22 ahn22 wp_who_22 wn_who_22 mop2 mon2 vdd vbsyn gsyn
X_ho2_23 ahp23 ahn23 wp_who_23 wn_who_23 mop2 mon2 vdd vbsyn gsyn
X_ho2_24 ahp24 ahn24 wp_who_24 wn_who_24 mop2 mon2 vdd vbsyn gsyn
X_ho2_25 ahp25 ahn25 wp_who_25 wn_who_25 mop2 mon2 vdd vbsyn gsyn
X_ho2_26 ahp26 ahn26 wp_who_26 wn_who_26 mop2 mon2 vdd vbsyn gsyn
X_ho2_27 ahp27 ahn27 wp_who_27 wn_who_27 mop2 mon2 vdd vbsyn gsyn
X_ho2_28 ahp28 ahn28 wp_who_28 wn_who_28 mop2 mon2 vdd vbsyn gsyn
X_ho2_29 ahp29 ahn29 wp_who_29 wn_who_29 mop2 mon2 vdd vbsyn gsyn
X_ho2_30 ahp30 ahn30 wp_who_30 wn_who_30 mop2 mon2 vdd vbsyn gsyn
X_ho2_31 ahp31 ahn31 wp_who_31 wn_who_31 mop2 mon2 vdd vbsyn gsyn
X_ho2_32 ahp32 ahn32 wp_who_32 wn_who_32 mop2 mon2 vdd vbsyn gsyn
X_ho2_33 ahp33 ahn33 wp_who_33 wn_who_33 mop2 mon2 vdd vbsyn gsyn
X_ho2_34 ahp34 ahn34 wp_who_34 wn_who_34 mop2 mon2 vdd vbsyn gsyn
X_ho2_35 ahp35 ahn35 wp_who_35 wn_who_35 mop2 mon2 vdd vbsyn gsyn
X_ho2_36 ahp36 ahn36 wp_who_36 wn_who_36 mop2 mon2 vdd vbsyn gsyn
X_ho2_37 ahp37 ahn37 wp_who_37 wn_who_37 mop2 mon2 vdd vbsyn gsyn
X_ho2_38 ahp38 ahn38 wp_who_38 wn_who_38 mop2 mon2 vdd vbsyn gsyn
X_ho2_39 ahp39 ahn39 wp_who_39 wn_who_39 mop2 mon2 vdd vbsyn gsyn
X_ho2_40 ahp40 ahn40 wp_who_40 wn_who_40 mop2 mon2 vdd vbsyn gsyn
X_ho2_41 ahp41 ahn41 wp_who_41 wn_who_41 mop2 mon2 vdd vbsyn gsyn
X_ho2_42 ahp42 ahn42 wp_who_42 wn_who_42 mop2 mon2 vdd vbsyn gsyn
X_ho2_43 ahp43 ahn43 wp_who_43 wn_who_43 mop2 mon2 vdd vbsyn gsyn
X_ho2_44 ahp44 ahn44 wp_who_44 wn_who_44 mop2 mon2 vdd vbsyn gsyn
X_ho2_45 ahp45 ahn45 wp_who_45 wn_who_45 mop2 mon2 vdd vbsyn gsyn
X_ho2_46 ahp46 ahn46 wp_who_46 wn_who_46 mop2 mon2 vdd vbsyn gsyn
X_ho2_47 ahp47 ahn47 wp_who_47 wn_who_47 mop2 mon2 vdd vbsyn gsyn
X_ho2_48 ahp48 ahn48 wp_who_48 wn_who_48 mop2 mon2 vdd vbsyn gsyn
X_ho2_49 ahp49 ahn49 wp_who_49 wn_who_49 mop2 mon2 vdd vbsyn gsyn
X_ho2_50 ahp50 ahn50 wp_who_50 wn_who_50 mop2 mon2 vdd vbsyn gsyn
X_ho2_51 ahp51 ahn51 wp_who_51 wn_who_51 mop2 mon2 vdd vbsyn gsyn
X_ho2_52 ahp52 ahn52 wp_who_52 wn_who_52 mop2 mon2 vdd vbsyn gsyn
X_ho2_53 ahp53 ahn53 wp_who_53 wn_who_53 mop2 mon2 vdd vbsyn gsyn
X_ho2_54 ahp54 ahn54 wp_who_54 wn_who_54 mop2 mon2 vdd vbsyn gsyn
X_ho2_55 ahp55 ahn55 wp_who_55 wn_who_55 mop2 mon2 vdd vbsyn gsyn
X_ho2_56 ahp56 ahn56 wp_who_56 wn_who_56 mop2 mon2 vdd vbsyn gsyn
X_ho2_57 ahp57 ahn57 wp_who_57 wn_who_57 mop2 mon2 vdd vbsyn gsyn
X_ho2_58 ahp58 ahn58 wp_who_58 wn_who_58 mop2 mon2 vdd vbsyn gsyn
X_ho2_59 ahp59 ahn59 wp_who_59 wn_who_59 mop2 mon2 vdd vbsyn gsyn
X_ho2_60 ahp60 ahn60 wp_who_60 wn_who_60 mop2 mon2 vdd vbsyn gsyn
X_ho2_61 ahp61 ahn61 wp_who_61 wn_who_61 mop2 mon2 vdd vbsyn gsyn
X_ho2_62 ahp62 ahn62 wp_who_62 wn_who_62 mop2 mon2 vdd vbsyn gsyn
X_ho2_63 ahp63 ahn63 wp_who_63 wn_who_63 mop2 mon2 vdd vbsyn gsyn
Xlih_1_0 ehp0 ehn0 a_xp1 a_xn1 wp_wih_1_0 wn_wih_1_0 vdd gblh gprod
Xlih_2_0 ehp0 ehn0 a_xp2 a_xn2 wp_wih_2_0 wn_wih_2_0 vdd gblh gprod
Xlho_0 eon eop ahp0 ahn0 wp_who_0 wn_who_0 vdd gblo gprod
Xlih_1_1 ehp1 ehn1 a_xp1 a_xn1 wp_wih_1_1 wn_wih_1_1 vdd gblh gprod
Xlih_2_1 ehp1 ehn1 a_xp2 a_xn2 wp_wih_2_1 wn_wih_2_1 vdd gblh gprod
Xlho_1 eon eop ahp1 ahn1 wp_who_1 wn_who_1 vdd gblo gprod
Xlih_1_2 ehp2 ehn2 a_xp1 a_xn1 wp_wih_1_2 wn_wih_1_2 vdd gblh gprod
Xlih_2_2 ehp2 ehn2 a_xp2 a_xn2 wp_wih_2_2 wn_wih_2_2 vdd gblh gprod
Xlho_2 eon eop ahp2 ahn2 wp_who_2 wn_who_2 vdd gblo gprod
Xlih_1_3 ehp3 ehn3 a_xp1 a_xn1 wp_wih_1_3 wn_wih_1_3 vdd gblh gprod
Xlih_2_3 ehp3 ehn3 a_xp2 a_xn2 wp_wih_2_3 wn_wih_2_3 vdd gblh gprod
Xlho_3 eon eop ahp3 ahn3 wp_who_3 wn_who_3 vdd gblo gprod
Xlih_1_4 ehp4 ehn4 a_xp1 a_xn1 wp_wih_1_4 wn_wih_1_4 vdd gblh gprod
Xlih_2_4 ehp4 ehn4 a_xp2 a_xn2 wp_wih_2_4 wn_wih_2_4 vdd gblh gprod
Xlho_4 eon eop ahp4 ahn4 wp_who_4 wn_who_4 vdd gblo gprod
Xlih_1_5 ehp5 ehn5 a_xp1 a_xn1 wp_wih_1_5 wn_wih_1_5 vdd gblh gprod
Xlih_2_5 ehp5 ehn5 a_xp2 a_xn2 wp_wih_2_5 wn_wih_2_5 vdd gblh gprod
Xlho_5 eon eop ahp5 ahn5 wp_who_5 wn_who_5 vdd gblo gprod
Xlih_1_6 ehp6 ehn6 a_xp1 a_xn1 wp_wih_1_6 wn_wih_1_6 vdd gblh gprod
Xlih_2_6 ehp6 ehn6 a_xp2 a_xn2 wp_wih_2_6 wn_wih_2_6 vdd gblh gprod
Xlho_6 eon eop ahp6 ahn6 wp_who_6 wn_who_6 vdd gblo gprod
Xlih_1_7 ehp7 ehn7 a_xp1 a_xn1 wp_wih_1_7 wn_wih_1_7 vdd gblh gprod
Xlih_2_7 ehp7 ehn7 a_xp2 a_xn2 wp_wih_2_7 wn_wih_2_7 vdd gblh gprod
Xlho_7 eon eop ahp7 ahn7 wp_who_7 wn_who_7 vdd gblo gprod
Xlih_1_8 ehp8 ehn8 a_xp1 a_xn1 wp_wih_1_8 wn_wih_1_8 vdd gblh gprod
Xlih_2_8 ehp8 ehn8 a_xp2 a_xn2 wp_wih_2_8 wn_wih_2_8 vdd gblh gprod
Xlho_8 eon eop ahp8 ahn8 wp_who_8 wn_who_8 vdd gblo gprod
Xlih_1_9 ehp9 ehn9 a_xp1 a_xn1 wp_wih_1_9 wn_wih_1_9 vdd gblh gprod
Xlih_2_9 ehp9 ehn9 a_xp2 a_xn2 wp_wih_2_9 wn_wih_2_9 vdd gblh gprod
Xlho_9 eon eop ahp9 ahn9 wp_who_9 wn_who_9 vdd gblo gprod
Xlih_1_10 ehp10 ehn10 a_xp1 a_xn1 wp_wih_1_10 wn_wih_1_10 vdd gblh gprod
Xlih_2_10 ehp10 ehn10 a_xp2 a_xn2 wp_wih_2_10 wn_wih_2_10 vdd gblh gprod
Xlho_10 eon eop ahp10 ahn10 wp_who_10 wn_who_10 vdd gblo gprod
Xlih_1_11 ehp11 ehn11 a_xp1 a_xn1 wp_wih_1_11 wn_wih_1_11 vdd gblh gprod
Xlih_2_11 ehp11 ehn11 a_xp2 a_xn2 wp_wih_2_11 wn_wih_2_11 vdd gblh gprod
Xlho_11 eon eop ahp11 ahn11 wp_who_11 wn_who_11 vdd gblo gprod
Xlih_1_12 ehp12 ehn12 a_xp1 a_xn1 wp_wih_1_12 wn_wih_1_12 vdd gblh gprod
Xlih_2_12 ehp12 ehn12 a_xp2 a_xn2 wp_wih_2_12 wn_wih_2_12 vdd gblh gprod
Xlho_12 eon eop ahp12 ahn12 wp_who_12 wn_who_12 vdd gblo gprod
Xlih_1_13 ehp13 ehn13 a_xp1 a_xn1 wp_wih_1_13 wn_wih_1_13 vdd gblh gprod
Xlih_2_13 ehp13 ehn13 a_xp2 a_xn2 wp_wih_2_13 wn_wih_2_13 vdd gblh gprod
Xlho_13 eon eop ahp13 ahn13 wp_who_13 wn_who_13 vdd gblo gprod
Xlih_1_14 ehp14 ehn14 a_xp1 a_xn1 wp_wih_1_14 wn_wih_1_14 vdd gblh gprod
Xlih_2_14 ehp14 ehn14 a_xp2 a_xn2 wp_wih_2_14 wn_wih_2_14 vdd gblh gprod
Xlho_14 eon eop ahp14 ahn14 wp_who_14 wn_who_14 vdd gblo gprod
Xlih_1_15 ehp15 ehn15 a_xp1 a_xn1 wp_wih_1_15 wn_wih_1_15 vdd gblh gprod
Xlih_2_15 ehp15 ehn15 a_xp2 a_xn2 wp_wih_2_15 wn_wih_2_15 vdd gblh gprod
Xlho_15 eon eop ahp15 ahn15 wp_who_15 wn_who_15 vdd gblo gprod
Xlih_1_16 ehp16 ehn16 a_xp1 a_xn1 wp_wih_1_16 wn_wih_1_16 vdd gblh gprod
Xlih_2_16 ehp16 ehn16 a_xp2 a_xn2 wp_wih_2_16 wn_wih_2_16 vdd gblh gprod
Xlho_16 eon eop ahp16 ahn16 wp_who_16 wn_who_16 vdd gblo gprod
Xlih_1_17 ehp17 ehn17 a_xp1 a_xn1 wp_wih_1_17 wn_wih_1_17 vdd gblh gprod
Xlih_2_17 ehp17 ehn17 a_xp2 a_xn2 wp_wih_2_17 wn_wih_2_17 vdd gblh gprod
Xlho_17 eon eop ahp17 ahn17 wp_who_17 wn_who_17 vdd gblo gprod
Xlih_1_18 ehp18 ehn18 a_xp1 a_xn1 wp_wih_1_18 wn_wih_1_18 vdd gblh gprod
Xlih_2_18 ehp18 ehn18 a_xp2 a_xn2 wp_wih_2_18 wn_wih_2_18 vdd gblh gprod
Xlho_18 eon eop ahp18 ahn18 wp_who_18 wn_who_18 vdd gblo gprod
Xlih_1_19 ehp19 ehn19 a_xp1 a_xn1 wp_wih_1_19 wn_wih_1_19 vdd gblh gprod
Xlih_2_19 ehp19 ehn19 a_xp2 a_xn2 wp_wih_2_19 wn_wih_2_19 vdd gblh gprod
Xlho_19 eon eop ahp19 ahn19 wp_who_19 wn_who_19 vdd gblo gprod
Xlih_1_20 ehp20 ehn20 a_xp1 a_xn1 wp_wih_1_20 wn_wih_1_20 vdd gblh gprod
Xlih_2_20 ehp20 ehn20 a_xp2 a_xn2 wp_wih_2_20 wn_wih_2_20 vdd gblh gprod
Xlho_20 eon eop ahp20 ahn20 wp_who_20 wn_who_20 vdd gblo gprod
Xlih_1_21 ehp21 ehn21 a_xp1 a_xn1 wp_wih_1_21 wn_wih_1_21 vdd gblh gprod
Xlih_2_21 ehp21 ehn21 a_xp2 a_xn2 wp_wih_2_21 wn_wih_2_21 vdd gblh gprod
Xlho_21 eon eop ahp21 ahn21 wp_who_21 wn_who_21 vdd gblo gprod
Xlih_1_22 ehp22 ehn22 a_xp1 a_xn1 wp_wih_1_22 wn_wih_1_22 vdd gblh gprod
Xlih_2_22 ehp22 ehn22 a_xp2 a_xn2 wp_wih_2_22 wn_wih_2_22 vdd gblh gprod
Xlho_22 eon eop ahp22 ahn22 wp_who_22 wn_who_22 vdd gblo gprod
Xlih_1_23 ehp23 ehn23 a_xp1 a_xn1 wp_wih_1_23 wn_wih_1_23 vdd gblh gprod
Xlih_2_23 ehp23 ehn23 a_xp2 a_xn2 wp_wih_2_23 wn_wih_2_23 vdd gblh gprod
Xlho_23 eon eop ahp23 ahn23 wp_who_23 wn_who_23 vdd gblo gprod
Xlih_1_24 ehp24 ehn24 a_xp1 a_xn1 wp_wih_1_24 wn_wih_1_24 vdd gblh gprod
Xlih_2_24 ehp24 ehn24 a_xp2 a_xn2 wp_wih_2_24 wn_wih_2_24 vdd gblh gprod
Xlho_24 eon eop ahp24 ahn24 wp_who_24 wn_who_24 vdd gblo gprod
Xlih_1_25 ehp25 ehn25 a_xp1 a_xn1 wp_wih_1_25 wn_wih_1_25 vdd gblh gprod
Xlih_2_25 ehp25 ehn25 a_xp2 a_xn2 wp_wih_2_25 wn_wih_2_25 vdd gblh gprod
Xlho_25 eon eop ahp25 ahn25 wp_who_25 wn_who_25 vdd gblo gprod
Xlih_1_26 ehp26 ehn26 a_xp1 a_xn1 wp_wih_1_26 wn_wih_1_26 vdd gblh gprod
Xlih_2_26 ehp26 ehn26 a_xp2 a_xn2 wp_wih_2_26 wn_wih_2_26 vdd gblh gprod
Xlho_26 eon eop ahp26 ahn26 wp_who_26 wn_who_26 vdd gblo gprod
Xlih_1_27 ehp27 ehn27 a_xp1 a_xn1 wp_wih_1_27 wn_wih_1_27 vdd gblh gprod
Xlih_2_27 ehp27 ehn27 a_xp2 a_xn2 wp_wih_2_27 wn_wih_2_27 vdd gblh gprod
Xlho_27 eon eop ahp27 ahn27 wp_who_27 wn_who_27 vdd gblo gprod
Xlih_1_28 ehp28 ehn28 a_xp1 a_xn1 wp_wih_1_28 wn_wih_1_28 vdd gblh gprod
Xlih_2_28 ehp28 ehn28 a_xp2 a_xn2 wp_wih_2_28 wn_wih_2_28 vdd gblh gprod
Xlho_28 eon eop ahp28 ahn28 wp_who_28 wn_who_28 vdd gblo gprod
Xlih_1_29 ehp29 ehn29 a_xp1 a_xn1 wp_wih_1_29 wn_wih_1_29 vdd gblh gprod
Xlih_2_29 ehp29 ehn29 a_xp2 a_xn2 wp_wih_2_29 wn_wih_2_29 vdd gblh gprod
Xlho_29 eon eop ahp29 ahn29 wp_who_29 wn_who_29 vdd gblo gprod
Xlih_1_30 ehp30 ehn30 a_xp1 a_xn1 wp_wih_1_30 wn_wih_1_30 vdd gblh gprod
Xlih_2_30 ehp30 ehn30 a_xp2 a_xn2 wp_wih_2_30 wn_wih_2_30 vdd gblh gprod
Xlho_30 eon eop ahp30 ahn30 wp_who_30 wn_who_30 vdd gblo gprod
Xlih_1_31 ehp31 ehn31 a_xp1 a_xn1 wp_wih_1_31 wn_wih_1_31 vdd gblh gprod
Xlih_2_31 ehp31 ehn31 a_xp2 a_xn2 wp_wih_2_31 wn_wih_2_31 vdd gblh gprod
Xlho_31 eon eop ahp31 ahn31 wp_who_31 wn_who_31 vdd gblo gprod
Xlih_1_32 ehp32 ehn32 a_xp1 a_xn1 wp_wih_1_32 wn_wih_1_32 vdd gblh gprod
Xlih_2_32 ehp32 ehn32 a_xp2 a_xn2 wp_wih_2_32 wn_wih_2_32 vdd gblh gprod
Xlho_32 eon eop ahp32 ahn32 wp_who_32 wn_who_32 vdd gblo gprod
Xlih_1_33 ehp33 ehn33 a_xp1 a_xn1 wp_wih_1_33 wn_wih_1_33 vdd gblh gprod
Xlih_2_33 ehp33 ehn33 a_xp2 a_xn2 wp_wih_2_33 wn_wih_2_33 vdd gblh gprod
Xlho_33 eon eop ahp33 ahn33 wp_who_33 wn_who_33 vdd gblo gprod
Xlih_1_34 ehp34 ehn34 a_xp1 a_xn1 wp_wih_1_34 wn_wih_1_34 vdd gblh gprod
Xlih_2_34 ehp34 ehn34 a_xp2 a_xn2 wp_wih_2_34 wn_wih_2_34 vdd gblh gprod
Xlho_34 eon eop ahp34 ahn34 wp_who_34 wn_who_34 vdd gblo gprod
Xlih_1_35 ehp35 ehn35 a_xp1 a_xn1 wp_wih_1_35 wn_wih_1_35 vdd gblh gprod
Xlih_2_35 ehp35 ehn35 a_xp2 a_xn2 wp_wih_2_35 wn_wih_2_35 vdd gblh gprod
Xlho_35 eon eop ahp35 ahn35 wp_who_35 wn_who_35 vdd gblo gprod
Xlih_1_36 ehp36 ehn36 a_xp1 a_xn1 wp_wih_1_36 wn_wih_1_36 vdd gblh gprod
Xlih_2_36 ehp36 ehn36 a_xp2 a_xn2 wp_wih_2_36 wn_wih_2_36 vdd gblh gprod
Xlho_36 eon eop ahp36 ahn36 wp_who_36 wn_who_36 vdd gblo gprod
Xlih_1_37 ehp37 ehn37 a_xp1 a_xn1 wp_wih_1_37 wn_wih_1_37 vdd gblh gprod
Xlih_2_37 ehp37 ehn37 a_xp2 a_xn2 wp_wih_2_37 wn_wih_2_37 vdd gblh gprod
Xlho_37 eon eop ahp37 ahn37 wp_who_37 wn_who_37 vdd gblo gprod
Xlih_1_38 ehp38 ehn38 a_xp1 a_xn1 wp_wih_1_38 wn_wih_1_38 vdd gblh gprod
Xlih_2_38 ehp38 ehn38 a_xp2 a_xn2 wp_wih_2_38 wn_wih_2_38 vdd gblh gprod
Xlho_38 eon eop ahp38 ahn38 wp_who_38 wn_who_38 vdd gblo gprod
Xlih_1_39 ehp39 ehn39 a_xp1 a_xn1 wp_wih_1_39 wn_wih_1_39 vdd gblh gprod
Xlih_2_39 ehp39 ehn39 a_xp2 a_xn2 wp_wih_2_39 wn_wih_2_39 vdd gblh gprod
Xlho_39 eon eop ahp39 ahn39 wp_who_39 wn_who_39 vdd gblo gprod
Xlih_1_40 ehp40 ehn40 a_xp1 a_xn1 wp_wih_1_40 wn_wih_1_40 vdd gblh gprod
Xlih_2_40 ehp40 ehn40 a_xp2 a_xn2 wp_wih_2_40 wn_wih_2_40 vdd gblh gprod
Xlho_40 eon eop ahp40 ahn40 wp_who_40 wn_who_40 vdd gblo gprod
Xlih_1_41 ehp41 ehn41 a_xp1 a_xn1 wp_wih_1_41 wn_wih_1_41 vdd gblh gprod
Xlih_2_41 ehp41 ehn41 a_xp2 a_xn2 wp_wih_2_41 wn_wih_2_41 vdd gblh gprod
Xlho_41 eon eop ahp41 ahn41 wp_who_41 wn_who_41 vdd gblo gprod
Xlih_1_42 ehp42 ehn42 a_xp1 a_xn1 wp_wih_1_42 wn_wih_1_42 vdd gblh gprod
Xlih_2_42 ehp42 ehn42 a_xp2 a_xn2 wp_wih_2_42 wn_wih_2_42 vdd gblh gprod
Xlho_42 eon eop ahp42 ahn42 wp_who_42 wn_who_42 vdd gblo gprod
Xlih_1_43 ehp43 ehn43 a_xp1 a_xn1 wp_wih_1_43 wn_wih_1_43 vdd gblh gprod
Xlih_2_43 ehp43 ehn43 a_xp2 a_xn2 wp_wih_2_43 wn_wih_2_43 vdd gblh gprod
Xlho_43 eon eop ahp43 ahn43 wp_who_43 wn_who_43 vdd gblo gprod
Xlih_1_44 ehp44 ehn44 a_xp1 a_xn1 wp_wih_1_44 wn_wih_1_44 vdd gblh gprod
Xlih_2_44 ehp44 ehn44 a_xp2 a_xn2 wp_wih_2_44 wn_wih_2_44 vdd gblh gprod
Xlho_44 eon eop ahp44 ahn44 wp_who_44 wn_who_44 vdd gblo gprod
Xlih_1_45 ehp45 ehn45 a_xp1 a_xn1 wp_wih_1_45 wn_wih_1_45 vdd gblh gprod
Xlih_2_45 ehp45 ehn45 a_xp2 a_xn2 wp_wih_2_45 wn_wih_2_45 vdd gblh gprod
Xlho_45 eon eop ahp45 ahn45 wp_who_45 wn_who_45 vdd gblo gprod
Xlih_1_46 ehp46 ehn46 a_xp1 a_xn1 wp_wih_1_46 wn_wih_1_46 vdd gblh gprod
Xlih_2_46 ehp46 ehn46 a_xp2 a_xn2 wp_wih_2_46 wn_wih_2_46 vdd gblh gprod
Xlho_46 eon eop ahp46 ahn46 wp_who_46 wn_who_46 vdd gblo gprod
Xlih_1_47 ehp47 ehn47 a_xp1 a_xn1 wp_wih_1_47 wn_wih_1_47 vdd gblh gprod
Xlih_2_47 ehp47 ehn47 a_xp2 a_xn2 wp_wih_2_47 wn_wih_2_47 vdd gblh gprod
Xlho_47 eon eop ahp47 ahn47 wp_who_47 wn_who_47 vdd gblo gprod
Xlih_1_48 ehp48 ehn48 a_xp1 a_xn1 wp_wih_1_48 wn_wih_1_48 vdd gblh gprod
Xlih_2_48 ehp48 ehn48 a_xp2 a_xn2 wp_wih_2_48 wn_wih_2_48 vdd gblh gprod
Xlho_48 eon eop ahp48 ahn48 wp_who_48 wn_who_48 vdd gblo gprod
Xlih_1_49 ehp49 ehn49 a_xp1 a_xn1 wp_wih_1_49 wn_wih_1_49 vdd gblh gprod
Xlih_2_49 ehp49 ehn49 a_xp2 a_xn2 wp_wih_2_49 wn_wih_2_49 vdd gblh gprod
Xlho_49 eon eop ahp49 ahn49 wp_who_49 wn_who_49 vdd gblo gprod
Xlih_1_50 ehp50 ehn50 a_xp1 a_xn1 wp_wih_1_50 wn_wih_1_50 vdd gblh gprod
Xlih_2_50 ehp50 ehn50 a_xp2 a_xn2 wp_wih_2_50 wn_wih_2_50 vdd gblh gprod
Xlho_50 eon eop ahp50 ahn50 wp_who_50 wn_who_50 vdd gblo gprod
Xlih_1_51 ehp51 ehn51 a_xp1 a_xn1 wp_wih_1_51 wn_wih_1_51 vdd gblh gprod
Xlih_2_51 ehp51 ehn51 a_xp2 a_xn2 wp_wih_2_51 wn_wih_2_51 vdd gblh gprod
Xlho_51 eon eop ahp51 ahn51 wp_who_51 wn_who_51 vdd gblo gprod
Xlih_1_52 ehp52 ehn52 a_xp1 a_xn1 wp_wih_1_52 wn_wih_1_52 vdd gblh gprod
Xlih_2_52 ehp52 ehn52 a_xp2 a_xn2 wp_wih_2_52 wn_wih_2_52 vdd gblh gprod
Xlho_52 eon eop ahp52 ahn52 wp_who_52 wn_who_52 vdd gblo gprod
Xlih_1_53 ehp53 ehn53 a_xp1 a_xn1 wp_wih_1_53 wn_wih_1_53 vdd gblh gprod
Xlih_2_53 ehp53 ehn53 a_xp2 a_xn2 wp_wih_2_53 wn_wih_2_53 vdd gblh gprod
Xlho_53 eon eop ahp53 ahn53 wp_who_53 wn_who_53 vdd gblo gprod
Xlih_1_54 ehp54 ehn54 a_xp1 a_xn1 wp_wih_1_54 wn_wih_1_54 vdd gblh gprod
Xlih_2_54 ehp54 ehn54 a_xp2 a_xn2 wp_wih_2_54 wn_wih_2_54 vdd gblh gprod
Xlho_54 eon eop ahp54 ahn54 wp_who_54 wn_who_54 vdd gblo gprod
Xlih_1_55 ehp55 ehn55 a_xp1 a_xn1 wp_wih_1_55 wn_wih_1_55 vdd gblh gprod
Xlih_2_55 ehp55 ehn55 a_xp2 a_xn2 wp_wih_2_55 wn_wih_2_55 vdd gblh gprod
Xlho_55 eon eop ahp55 ahn55 wp_who_55 wn_who_55 vdd gblo gprod
Xlih_1_56 ehp56 ehn56 a_xp1 a_xn1 wp_wih_1_56 wn_wih_1_56 vdd gblh gprod
Xlih_2_56 ehp56 ehn56 a_xp2 a_xn2 wp_wih_2_56 wn_wih_2_56 vdd gblh gprod
Xlho_56 eon eop ahp56 ahn56 wp_who_56 wn_who_56 vdd gblo gprod
Xlih_1_57 ehp57 ehn57 a_xp1 a_xn1 wp_wih_1_57 wn_wih_1_57 vdd gblh gprod
Xlih_2_57 ehp57 ehn57 a_xp2 a_xn2 wp_wih_2_57 wn_wih_2_57 vdd gblh gprod
Xlho_57 eon eop ahp57 ahn57 wp_who_57 wn_who_57 vdd gblo gprod
Xlih_1_58 ehp58 ehn58 a_xp1 a_xn1 wp_wih_1_58 wn_wih_1_58 vdd gblh gprod
Xlih_2_58 ehp58 ehn58 a_xp2 a_xn2 wp_wih_2_58 wn_wih_2_58 vdd gblh gprod
Xlho_58 eon eop ahp58 ahn58 wp_who_58 wn_who_58 vdd gblo gprod
Xlih_1_59 ehp59 ehn59 a_xp1 a_xn1 wp_wih_1_59 wn_wih_1_59 vdd gblh gprod
Xlih_2_59 ehp59 ehn59 a_xp2 a_xn2 wp_wih_2_59 wn_wih_2_59 vdd gblh gprod
Xlho_59 eon eop ahp59 ahn59 wp_who_59 wn_who_59 vdd gblo gprod
Xlih_1_60 ehp60 ehn60 a_xp1 a_xn1 wp_wih_1_60 wn_wih_1_60 vdd gblh gprod
Xlih_2_60 ehp60 ehn60 a_xp2 a_xn2 wp_wih_2_60 wn_wih_2_60 vdd gblh gprod
Xlho_60 eon eop ahp60 ahn60 wp_who_60 wn_who_60 vdd gblo gprod
Xlih_1_61 ehp61 ehn61 a_xp1 a_xn1 wp_wih_1_61 wn_wih_1_61 vdd gblh gprod
Xlih_2_61 ehp61 ehn61 a_xp2 a_xn2 wp_wih_2_61 wn_wih_2_61 vdd gblh gprod
Xlho_61 eon eop ahp61 ahn61 wp_who_61 wn_who_61 vdd gblo gprod
Xlih_1_62 ehp62 ehn62 a_xp1 a_xn1 wp_wih_1_62 wn_wih_1_62 vdd gblh gprod
Xlih_2_62 ehp62 ehn62 a_xp2 a_xn2 wp_wih_2_62 wn_wih_2_62 vdd gblh gprod
Xlho_62 eon eop ahp62 ahn62 wp_who_62 wn_who_62 vdd gblo gprod
Xlih_1_63 ehp63 ehn63 a_xp1 a_xn1 wp_wih_1_63 wn_wih_1_63 vdd gblh gprod
Xlih_2_63 ehp63 ehn63 a_xp2 a_xn2 wp_wih_2_63 wn_wih_2_63 vdd gblh gprod
Xlho_63 eon eop ahp63 ahn63 wp_who_63 wn_who_63 vdd gblo gprod
.ic v(wp_wih_1_0)=0.5473 v(wn_wih_1_0)=0.4527
.ic v(wp_wih_2_0)=0.3693 v(wn_wih_2_0)=0.6307
.ic v(wp_who_0)=0.3967 v(wn_who_0)=0.6033
.ic v(wp_wih_1_1)=0.3000 v(wn_wih_1_1)=0.9000
.ic v(wp_wih_2_1)=0.9000 v(wn_wih_2_1)=0.3000
.ic v(wp_who_1)=0.7860 v(wn_who_1)=0.3000
.ic v(wp_wih_1_2)=0.4186 v(wn_wih_1_2)=0.5814
.ic v(wp_wih_2_2)=0.6935 v(wn_wih_2_2)=0.3065
.ic v(wp_who_2)=0.5703 v(wn_who_2)=0.4297
.ic v(wp_wih_1_3)=0.3615 v(wn_wih_1_3)=0.6385
.ic v(wp_wih_2_3)=0.7444 v(wn_wih_2_3)=0.3000
.ic v(wp_who_3)=0.4224 v(wn_who_3)=0.5776
.ic v(wp_wih_1_4)=0.4178 v(wn_wih_1_4)=0.5822
.ic v(wp_wih_2_4)=0.3020 v(wn_wih_2_4)=0.6980
.ic v(wp_who_4)=0.6137 v(wn_who_4)=0.3863
.ic v(wp_wih_1_5)=0.4752 v(wn_wih_1_5)=0.5248
.ic v(wp_wih_2_5)=0.6363 v(wn_wih_2_5)=0.3637
.ic v(wp_who_5)=0.3482 v(wn_who_5)=0.6518
.ic v(wp_wih_1_6)=0.5317 v(wn_wih_1_6)=0.4683
.ic v(wp_wih_2_6)=0.3000 v(wn_wih_2_6)=0.7231
.ic v(wp_who_6)=0.7104 v(wn_who_6)=0.3000
.ic v(wp_wih_1_7)=0.5470 v(wn_wih_1_7)=0.4530
.ic v(wp_wih_2_7)=0.5826 v(wn_wih_2_7)=0.4174
.ic v(wp_who_7)=0.6026 v(wn_who_7)=0.3974
.ic v(wp_wih_1_8)=0.3000 v(wn_wih_1_8)=0.7527
.ic v(wp_wih_2_8)=0.6958 v(wn_wih_2_8)=0.3042
.ic v(wp_who_8)=0.9000 v(wn_who_8)=0.3000
.ic v(wp_wih_1_9)=0.3000 v(wn_wih_1_9)=0.9000
.ic v(wp_wih_2_9)=0.3000 v(wn_wih_2_9)=0.9000
.ic v(wp_who_9)=0.3000 v(wn_who_9)=0.8762
.ic v(wp_wih_1_10)=0.7104 v(wn_wih_1_10)=0.3000
.ic v(wp_wih_2_10)=0.5322 v(wn_wih_2_10)=0.4678
.ic v(wp_who_10)=0.7696 v(wn_who_10)=0.3000
.ic v(wp_wih_1_11)=0.6806 v(wn_wih_1_11)=0.3194
.ic v(wp_wih_2_11)=0.5526 v(wn_wih_2_11)=0.4474
.ic v(wp_who_11)=0.5710 v(wn_who_11)=0.4290
.ic v(wp_wih_1_12)=0.4576 v(wn_wih_1_12)=0.5424
.ic v(wp_wih_2_12)=0.7171 v(wn_wih_2_12)=0.3000
.ic v(wp_who_12)=0.3000 v(wn_who_12)=0.7824
.ic v(wp_wih_1_13)=0.3945 v(wn_wih_1_13)=0.6055
.ic v(wp_wih_2_13)=0.5607 v(wn_wih_2_13)=0.4393
.ic v(wp_who_13)=0.9000 v(wn_who_13)=0.3000
.ic v(wp_wih_1_14)=0.3089 v(wn_wih_1_14)=0.6911
.ic v(wp_wih_2_14)=0.3000 v(wn_wih_2_14)=0.7698
.ic v(wp_who_14)=0.3592 v(wn_who_14)=0.6408
.ic v(wp_wih_1_15)=0.7423 v(wn_wih_1_15)=0.3000
.ic v(wp_wih_2_15)=0.4412 v(wn_wih_2_15)=0.5588
.ic v(wp_who_15)=0.8311 v(wn_who_15)=0.3000
.ic v(wp_wih_1_16)=0.3000 v(wn_wih_1_16)=0.9000
.ic v(wp_wih_2_16)=0.7821 v(wn_wih_2_16)=0.3000
.ic v(wp_who_16)=0.7587 v(wn_who_16)=0.3000
.ic v(wp_wih_1_17)=0.3000 v(wn_wih_1_17)=0.8547
.ic v(wp_wih_2_17)=0.5384 v(wn_wih_2_17)=0.4616
.ic v(wp_who_17)=0.8039 v(wn_who_17)=0.3000
.ic v(wp_wih_1_18)=0.5220 v(wn_wih_1_18)=0.4780
.ic v(wp_wih_2_18)=0.7499 v(wn_wih_2_18)=0.3000
.ic v(wp_who_18)=0.9000 v(wn_who_18)=0.3000
.ic v(wp_wih_1_19)=0.5685 v(wn_wih_1_19)=0.4315
.ic v(wp_wih_2_19)=0.4299 v(wn_wih_2_19)=0.5701
.ic v(wp_who_19)=0.3072 v(wn_who_19)=0.6928
.ic v(wp_wih_1_20)=0.6620 v(wn_wih_1_20)=0.3380
.ic v(wp_wih_2_20)=0.4508 v(wn_wih_2_20)=0.5492
.ic v(wp_who_20)=0.4553 v(wn_who_20)=0.5447
.ic v(wp_wih_1_21)=0.4737 v(wn_wih_1_21)=0.5263
.ic v(wp_wih_2_21)=0.6625 v(wn_wih_2_21)=0.3375
.ic v(wp_who_21)=0.3000 v(wn_who_21)=0.7666
.ic v(wp_wih_1_22)=0.3000 v(wn_wih_1_22)=0.8825
.ic v(wp_wih_2_22)=0.3000 v(wn_wih_2_22)=0.9000
.ic v(wp_who_22)=0.7997 v(wn_who_22)=0.3000
.ic v(wp_wih_1_23)=0.5184 v(wn_wih_1_23)=0.4816
.ic v(wp_wih_2_23)=0.8775 v(wn_wih_2_23)=0.3000
.ic v(wp_who_23)=0.4978 v(wn_who_23)=0.5022
.ic v(wp_wih_1_24)=0.3145 v(wn_wih_1_24)=0.6855
.ic v(wp_wih_2_24)=0.6195 v(wn_wih_2_24)=0.3805
.ic v(wp_who_24)=0.4809 v(wn_who_24)=0.5191
.ic v(wp_wih_1_25)=0.3000 v(wn_wih_1_25)=0.8135
.ic v(wp_wih_2_25)=0.3000 v(wn_wih_2_25)=0.7213
.ic v(wp_who_25)=0.9000 v(wn_who_25)=0.3000
.ic v(wp_wih_1_26)=0.5886 v(wn_wih_1_26)=0.4114
.ic v(wp_wih_2_26)=0.6041 v(wn_wih_2_26)=0.3959
.ic v(wp_who_26)=0.4309 v(wn_who_26)=0.5691
.ic v(wp_wih_1_27)=0.3276 v(wn_wih_1_27)=0.6724
.ic v(wp_wih_2_27)=0.7229 v(wn_wih_2_27)=0.3000
.ic v(wp_who_27)=0.4738 v(wn_who_27)=0.5262
.ic v(wp_wih_1_28)=0.3102 v(wn_wih_1_28)=0.6898
.ic v(wp_wih_2_28)=0.4665 v(wn_wih_2_28)=0.5335
.ic v(wp_who_28)=0.3000 v(wn_who_28)=0.7264
.ic v(wp_wih_1_29)=0.5475 v(wn_wih_1_29)=0.4525
.ic v(wp_wih_2_29)=0.7823 v(wn_wih_2_29)=0.3000
.ic v(wp_who_29)=0.3000 v(wn_who_29)=0.7090
.ic v(wp_wih_1_30)=0.8571 v(wn_wih_1_30)=0.3000
.ic v(wp_wih_2_30)=0.3331 v(wn_wih_2_30)=0.6669
.ic v(wp_who_30)=0.5384 v(wn_who_30)=0.4616
.ic v(wp_wih_1_31)=0.3000 v(wn_wih_1_31)=0.7091
.ic v(wp_wih_2_31)=0.4444 v(wn_wih_2_31)=0.5556
.ic v(wp_who_31)=0.5119 v(wn_who_31)=0.4881
.ic v(wp_wih_1_32)=0.3913 v(wn_wih_1_32)=0.6087
.ic v(wp_wih_2_32)=0.3243 v(wn_wih_2_32)=0.6757
.ic v(wp_who_32)=0.3305 v(wn_who_32)=0.6695
.ic v(wp_wih_1_33)=0.3000 v(wn_wih_1_33)=0.7053
.ic v(wp_wih_2_33)=0.3000 v(wn_wih_2_33)=0.8925
.ic v(wp_who_33)=0.4343 v(wn_who_33)=0.5657
.ic v(wp_wih_1_34)=0.6003 v(wn_wih_1_34)=0.3997
.ic v(wp_wih_2_34)=0.7271 v(wn_wih_2_34)=0.3000
.ic v(wp_who_34)=0.6618 v(wn_who_34)=0.3382
.ic v(wp_wih_1_35)=0.9000 v(wn_wih_1_35)=0.3000
.ic v(wp_wih_2_35)=0.5797 v(wn_wih_2_35)=0.4203
.ic v(wp_who_35)=0.3859 v(wn_who_35)=0.6141
.ic v(wp_wih_1_36)=0.9000 v(wn_wih_1_36)=0.3000
.ic v(wp_wih_2_36)=0.3000 v(wn_wih_2_36)=0.7618
.ic v(wp_who_36)=0.7421 v(wn_who_36)=0.3000
.ic v(wp_wih_1_37)=0.3000 v(wn_wih_1_37)=0.7388
.ic v(wp_wih_2_37)=0.5885 v(wn_wih_2_37)=0.4115
.ic v(wp_who_37)=0.3000 v(wn_who_37)=0.9000
.ic v(wp_wih_1_38)=0.7248 v(wn_wih_1_38)=0.3000
.ic v(wp_wih_2_38)=0.4604 v(wn_wih_2_38)=0.5396
.ic v(wp_who_38)=0.3000 v(wn_who_38)=0.7419
.ic v(wp_wih_1_39)=0.9000 v(wn_wih_1_39)=0.3000
.ic v(wp_wih_2_39)=0.6913 v(wn_wih_2_39)=0.3087
.ic v(wp_who_39)=0.5115 v(wn_who_39)=0.4885
.ic v(wp_wih_1_40)=0.3136 v(wn_wih_1_40)=0.6864
.ic v(wp_wih_2_40)=0.4892 v(wn_wih_2_40)=0.5108
.ic v(wp_who_40)=0.4590 v(wn_who_40)=0.5410
.ic v(wp_wih_1_41)=0.6812 v(wn_wih_1_41)=0.3188
.ic v(wp_wih_2_41)=0.6995 v(wn_wih_2_41)=0.3005
.ic v(wp_who_41)=0.3331 v(wn_who_41)=0.6669
.ic v(wp_wih_1_42)=0.3627 v(wn_wih_1_42)=0.6373
.ic v(wp_wih_2_42)=0.3670 v(wn_wih_2_42)=0.6330
.ic v(wp_who_42)=0.3000 v(wn_who_42)=0.8373
.ic v(wp_wih_1_43)=0.3521 v(wn_wih_1_43)=0.6479
.ic v(wp_wih_2_43)=0.4769 v(wn_wih_2_43)=0.5231
.ic v(wp_who_43)=0.6727 v(wn_who_43)=0.3273
.ic v(wp_wih_1_44)=0.8301 v(wn_wih_1_44)=0.3000
.ic v(wp_wih_2_44)=0.3000 v(wn_wih_2_44)=0.7021
.ic v(wp_who_44)=0.6377 v(wn_who_44)=0.3623
.ic v(wp_wih_1_45)=0.3889 v(wn_wih_1_45)=0.6111
.ic v(wp_wih_2_45)=0.9000 v(wn_wih_2_45)=0.3000
.ic v(wp_who_45)=0.4878 v(wn_who_45)=0.5122
.ic v(wp_wih_1_46)=0.6255 v(wn_wih_1_46)=0.3745
.ic v(wp_wih_2_46)=0.3000 v(wn_wih_2_46)=0.7340
.ic v(wp_who_46)=0.3000 v(wn_who_46)=0.7027
.ic v(wp_wih_1_47)=0.5504 v(wn_wih_1_47)=0.4496
.ic v(wp_wih_2_47)=0.4040 v(wn_wih_2_47)=0.5960
.ic v(wp_who_47)=0.5883 v(wn_who_47)=0.4117
.ic v(wp_wih_1_48)=0.3000 v(wn_wih_1_48)=0.8905
.ic v(wp_wih_2_48)=0.6655 v(wn_wih_2_48)=0.3345
.ic v(wp_who_48)=0.3000 v(wn_who_48)=0.7249
.ic v(wp_wih_1_49)=0.9000 v(wn_wih_1_49)=0.3000
.ic v(wp_wih_2_49)=0.4279 v(wn_wih_2_49)=0.5721
.ic v(wp_who_49)=0.7743 v(wn_who_49)=0.3000
.ic v(wp_wih_1_50)=0.3000 v(wn_wih_1_50)=0.8487
.ic v(wp_wih_2_50)=0.6072 v(wn_wih_2_50)=0.3928
.ic v(wp_who_50)=0.3000 v(wn_who_50)=0.7220
.ic v(wp_wih_1_51)=0.3783 v(wn_wih_1_51)=0.6217
.ic v(wp_wih_2_51)=0.5061 v(wn_wih_2_51)=0.4939
.ic v(wp_who_51)=0.4207 v(wn_who_51)=0.5793
.ic v(wp_wih_1_52)=0.5661 v(wn_wih_1_52)=0.4339
.ic v(wp_wih_2_52)=0.6869 v(wn_wih_2_52)=0.3131
.ic v(wp_who_52)=0.6632 v(wn_who_52)=0.3368
.ic v(wp_wih_1_53)=0.4781 v(wn_wih_1_53)=0.5219
.ic v(wp_wih_2_53)=0.3000 v(wn_wih_2_53)=0.8409
.ic v(wp_who_53)=0.3000 v(wn_who_53)=0.7012
.ic v(wp_wih_1_54)=0.4511 v(wn_wih_1_54)=0.5489
.ic v(wp_wih_2_54)=0.3000 v(wn_wih_2_54)=0.9000
.ic v(wp_who_54)=0.6880 v(wn_who_54)=0.3120
.ic v(wp_wih_1_55)=0.4401 v(wn_wih_1_55)=0.5599
.ic v(wp_wih_2_55)=0.4372 v(wn_wih_2_55)=0.5628
.ic v(wp_who_55)=0.7371 v(wn_who_55)=0.3000
.ic v(wp_wih_1_56)=0.6670 v(wn_wih_1_56)=0.3330
.ic v(wp_wih_2_56)=0.5553 v(wn_wih_2_56)=0.4447
.ic v(wp_who_56)=0.3000 v(wn_who_56)=0.7503
.ic v(wp_wih_1_57)=0.5776 v(wn_wih_1_57)=0.4224
.ic v(wp_wih_2_57)=0.5865 v(wn_wih_2_57)=0.4135
.ic v(wp_who_57)=0.3000 v(wn_who_57)=0.7212
.ic v(wp_wih_1_58)=0.7608 v(wn_wih_1_58)=0.3000
.ic v(wp_wih_2_58)=0.6270 v(wn_wih_2_58)=0.3730
.ic v(wp_who_58)=0.3000 v(wn_who_58)=0.9000
.ic v(wp_wih_1_59)=0.5305 v(wn_wih_1_59)=0.4695
.ic v(wp_wih_2_59)=0.3000 v(wn_wih_2_59)=0.8162
.ic v(wp_who_59)=0.7841 v(wn_who_59)=0.3000
.ic v(wp_wih_1_60)=0.7018 v(wn_wih_1_60)=0.3000
.ic v(wp_wih_2_60)=0.3000 v(wn_wih_2_60)=0.7759
.ic v(wp_who_60)=0.3000 v(wn_who_60)=0.7212
.ic v(wp_wih_1_61)=0.5255 v(wn_wih_1_61)=0.4745
.ic v(wp_wih_2_61)=0.4403 v(wn_wih_2_61)=0.5597
.ic v(wp_who_61)=0.8813 v(wn_who_61)=0.3000
.ic v(wp_wih_1_62)=0.6852 v(wn_wih_1_62)=0.3148
.ic v(wp_wih_2_62)=0.4294 v(wn_wih_2_62)=0.5706
.ic v(wp_who_62)=0.6443 v(wn_who_62)=0.3557
.ic v(wp_wih_1_63)=0.3000 v(wn_wih_1_63)=0.9000
.ic v(wp_wih_2_63)=0.5775 v(wn_wih_2_63)=0.4225
.ic v(wp_who_63)=0.7166 v(wn_who_63)=0.3000
.options cshunt=1e-14 gmin=1e-10 reltol=2e-3
.tran 2n 90000n uic
.control
run
wrdata pcL2dfzz64.dat v(mop) v(mon) v(mop2) v(mon2)
wrdata pcL2dwfzz64.dat v(wp_wih_1_0) v(wn_wih_1_0) v(wp_wih_2_0) v(wn_wih_2_0) v(wp_who_0) v(wn_who_0) v(wp_wih_1_1) v(wn_wih_1_1) v(wp_wih_2_1) v(wn_wih_2_1) v(wp_who_1) v(wn_who_1) v(wp_wih_1_2) v(wn_wih_1_2) v(wp_wih_2_2) v(wn_wih_2_2) v(wp_who_2) v(wn_who_2) v(wp_wih_1_3) v(wn_wih_1_3) v(wp_wih_2_3) v(wn_wih_2_3) v(wp_who_3) v(wn_who_3) v(wp_wih_1_4) v(wn_wih_1_4) v(wp_wih_2_4) v(wn_wih_2_4) v(wp_who_4) v(wn_who_4) v(wp_wih_1_5) v(wn_wih_1_5) v(wp_wih_2_5) v(wn_wih_2_5) v(wp_who_5) v(wn_who_5) v(wp_wih_1_6) v(wn_wih_1_6) v(wp_wih_2_6) v(wn_wih_2_6) v(wp_who_6) v(wn_who_6) v(wp_wih_1_7) v(wn_wih_1_7) v(wp_wih_2_7) v(wn_wih_2_7) v(wp_who_7) v(wn_who_7) v(wp_wih_1_8) v(wn_wih_1_8) v(wp_wih_2_8) v(wn_wih_2_8) v(wp_who_8) v(wn_who_8) v(wp_wih_1_9) v(wn_wih_1_9) v(wp_wih_2_9) v(wn_wih_2_9) v(wp_who_9) v(wn_who_9) v(wp_wih_1_10) v(wn_wih_1_10) v(wp_wih_2_10) v(wn_wih_2_10) v(wp_who_10) v(wn_who_10) v(wp_wih_1_11) v(wn_wih_1_11) v(wp_wih_2_11) v(wn_wih_2_11) v(wp_who_11) v(wn_who_11) v(wp_wih_1_12) v(wn_wih_1_12) v(wp_wih_2_12) v(wn_wih_2_12) v(wp_who_12) v(wn_who_12) v(wp_wih_1_13) v(wn_wih_1_13) v(wp_wih_2_13) v(wn_wih_2_13) v(wp_who_13) v(wn_who_13) v(wp_wih_1_14) v(wn_wih_1_14) v(wp_wih_2_14) v(wn_wih_2_14) v(wp_who_14) v(wn_who_14) v(wp_wih_1_15) v(wn_wih_1_15) v(wp_wih_2_15) v(wn_wih_2_15) v(wp_who_15) v(wn_who_15) v(wp_wih_1_16) v(wn_wih_1_16) v(wp_wih_2_16) v(wn_wih_2_16) v(wp_who_16) v(wn_who_16) v(wp_wih_1_17) v(wn_wih_1_17) v(wp_wih_2_17) v(wn_wih_2_17) v(wp_who_17) v(wn_who_17) v(wp_wih_1_18) v(wn_wih_1_18) v(wp_wih_2_18) v(wn_wih_2_18) v(wp_who_18) v(wn_who_18) v(wp_wih_1_19) v(wn_wih_1_19) v(wp_wih_2_19) v(wn_wih_2_19) v(wp_who_19) v(wn_who_19) v(wp_wih_1_20) v(wn_wih_1_20) v(wp_wih_2_20) v(wn_wih_2_20) v(wp_who_20) v(wn_who_20) v(wp_wih_1_21) v(wn_wih_1_21) v(wp_wih_2_21) v(wn_wih_2_21) v(wp_who_21) v(wn_who_21) v(wp_wih_1_22) v(wn_wih_1_22) v(wp_wih_2_22) v(wn_wih_2_22) v(wp_who_22) v(wn_who_22) v(wp_wih_1_23) v(wn_wih_1_23) v(wp_wih_2_23) v(wn_wih_2_23) v(wp_who_23) v(wn_who_23) v(wp_wih_1_24) v(wn_wih_1_24) v(wp_wih_2_24) v(wn_wih_2_24) v(wp_who_24) v(wn_who_24) v(wp_wih_1_25) v(wn_wih_1_25) v(wp_wih_2_25) v(wn_wih_2_25) v(wp_who_25) v(wn_who_25) v(wp_wih_1_26) v(wn_wih_1_26) v(wp_wih_2_26) v(wn_wih_2_26) v(wp_who_26) v(wn_who_26) v(wp_wih_1_27) v(wn_wih_1_27) v(wp_wih_2_27) v(wn_wih_2_27) v(wp_who_27) v(wn_who_27) v(wp_wih_1_28) v(wn_wih_1_28) v(wp_wih_2_28) v(wn_wih_2_28) v(wp_who_28) v(wn_who_28) v(wp_wih_1_29) v(wn_wih_1_29) v(wp_wih_2_29) v(wn_wih_2_29) v(wp_who_29) v(wn_who_29) v(wp_wih_1_30) v(wn_wih_1_30) v(wp_wih_2_30) v(wn_wih_2_30) v(wp_who_30) v(wn_who_30) v(wp_wih_1_31) v(wn_wih_1_31) v(wp_wih_2_31) v(wn_wih_2_31) v(wp_who_31) v(wn_who_31) v(wp_wih_1_32) v(wn_wih_1_32) v(wp_wih_2_32) v(wn_wih_2_32) v(wp_who_32) v(wn_who_32) v(wp_wih_1_33) v(wn_wih_1_33) v(wp_wih_2_33) v(wn_wih_2_33) v(wp_who_33) v(wn_who_33) v(wp_wih_1_34) v(wn_wih_1_34) v(wp_wih_2_34) v(wn_wih_2_34) v(wp_who_34) v(wn_who_34) v(wp_wih_1_35) v(wn_wih_1_35) v(wp_wih_2_35) v(wn_wih_2_35) v(wp_who_35) v(wn_who_35) v(wp_wih_1_36) v(wn_wih_1_36) v(wp_wih_2_36) v(wn_wih_2_36) v(wp_who_36) v(wn_who_36) v(wp_wih_1_37) v(wn_wih_1_37) v(wp_wih_2_37) v(wn_wih_2_37) v(wp_who_37) v(wn_who_37) v(wp_wih_1_38) v(wn_wih_1_38) v(wp_wih_2_38) v(wn_wih_2_38) v(wp_who_38) v(wn_who_38) v(wp_wih_1_39) v(wn_wih_1_39) v(wp_wih_2_39) v(wn_wih_2_39) v(wp_who_39) v(wn_who_39) v(wp_wih_1_40) v(wn_wih_1_40) v(wp_wih_2_40) v(wn_wih_2_40) v(wp_who_40) v(wn_who_40) v(wp_wih_1_41) v(wn_wih_1_41) v(wp_wih_2_41) v(wn_wih_2_41) v(wp_who_41) v(wn_who_41) v(wp_wih_1_42) v(wn_wih_1_42) v(wp_wih_2_42) v(wn_wih_2_42) v(wp_who_42) v(wn_who_42) v(wp_wih_1_43) v(wn_wih_1_43) v(wp_wih_2_43) v(wn_wih_2_43) v(wp_who_43) v(wn_who_43) v(wp_wih_1_44) v(wn_wih_1_44) v(wp_wih_2_44) v(wn_wih_2_44) v(wp_who_44) v(wn_who_44) v(wp_wih_1_45) v(wn_wih_1_45) v(wp_wih_2_45) v(wn_wih_2_45) v(wp_who_45) v(wn_who_45) v(wp_wih_1_46) v(wn_wih_1_46) v(wp_wih_2_46) v(wn_wih_2_46) v(wp_who_46) v(wn_who_46) v(wp_wih_1_47) v(wn_wih_1_47) v(wp_wih_2_47) v(wn_wih_2_47) v(wp_who_47) v(wn_who_47) v(wp_wih_1_48) v(wn_wih_1_48) v(wp_wih_2_48) v(wn_wih_2_48) v(wp_who_48) v(wn_who_48) v(wp_wih_1_49) v(wn_wih_1_49) v(wp_wih_2_49) v(wn_wih_2_49) v(wp_who_49) v(wn_who_49) v(wp_wih_1_50) v(wn_wih_1_50) v(wp_wih_2_50) v(wn_wih_2_50) v(wp_who_50) v(wn_who_50) v(wp_wih_1_51) v(wn_wih_1_51) v(wp_wih_2_51) v(wn_wih_2_51) v(wp_who_51) v(wn_who_51) v(wp_wih_1_52) v(wn_wih_1_52) v(wp_wih_2_52) v(wn_wih_2_52) v(wp_who_52) v(wn_who_52) v(wp_wih_1_53) v(wn_wih_1_53) v(wp_wih_2_53) v(wn_wih_2_53) v(wp_who_53) v(wn_who_53) v(wp_wih_1_54) v(wn_wih_1_54) v(wp_wih_2_54) v(wn_wih_2_54) v(wp_who_54) v(wn_who_54) v(wp_wih_1_55) v(wn_wih_1_55) v(wp_wih_2_55) v(wn_wih_2_55) v(wp_who_55) v(wn_who_55) v(wp_wih_1_56) v(wn_wih_1_56) v(wp_wih_2_56) v(wn_wih_2_56) v(wp_who_56) v(wn_who_56) v(wp_wih_1_57) v(wn_wih_1_57) v(wp_wih_2_57) v(wn_wih_2_57) v(wp_who_57) v(wn_who_57) v(wp_wih_1_58) v(wn_wih_1_58) v(wp_wih_2_58) v(wn_wih_2_58) v(wp_who_58) v(wn_who_58) v(wp_wih_1_59) v(wn_wih_1_59) v(wp_wih_2_59) v(wn_wih_2_59) v(wp_who_59) v(wn_who_59) v(wp_wih_1_60) v(wn_wih_1_60) v(wp_wih_2_60) v(wn_wih_2_60) v(wp_who_60) v(wn_who_60) v(wp_wih_1_61) v(wn_wih_1_61) v(wp_wih_2_61) v(wn_wih_2_61) v(wp_who_61) v(wn_who_61) v(wp_wih_1_62) v(wn_wih_1_62) v(wp_wih_2_62) v(wn_wih_2_62) v(wp_who_62) v(wn_who_62) v(wp_wih_1_63) v(wn_wih_1_63) v(wp_wih_2_63) v(wn_wih_2_63) v(wp_who_63) v(wn_who_63)
.endc
.end
