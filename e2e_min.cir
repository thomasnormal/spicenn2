continuous-time end-to-end EP -- minimal 1-weight linear regression
.model NNR NMOS (LEVEL=1 VTO=0.2  KP=120u LAMBDA=0.02 GAMMA=0 PHI=0.7)
.model PNR PMOS (LEVEL=1 VTO=-0.2 KP=40u  LAMBDA=0.02 GAMMA=0 PHI=0.7)
.subckt dsyn inp inn outp outn wp wn vdd
M1 outp inp tp 0 NNR W=200u L=100u
M2 outn inn tp 0 NNR W=200u L=100u
Mtp tp wp 0 0 NNR W=200u L=100u
M3 outn inp tn 0 NNR W=200u L=100u
M4 outp inn tn 0 NNR W=200u L=100u
Mtn tn wn 0 0 NNR W=200u L=100u
.ends
* 4-quadrant Gilbert update integrator: charges (wp,wn) by (x.y)_nudge-(x.y)_free
.subckt gupd xp xn yp yn wp wn psig psigb vdd vbn
Mtail nt vbn 0 0 NNR W=400u L=100u
M5 na yp nt 0 NNR W=200u L=100u
M6 nb yn nt 0 NNR W=200u L=100u
M1 iop xp na 0 NNR W=200u L=100u
M2 ion xn na 0 NNR W=200u L=100u
M3 ion xp nb 0 NNR W=200u L=100u
M4 iop xn nb 0 NNR W=200u L=100u
Mlp iop iop vdd vdd PNR W=200u L=100u
Mln ion ion vdd vdd PNR W=200u L=100u
MopA ca iop vdd vdd PNR W=200u L=100u
MopB cb ion vdd vdd PNR W=200u L=100u
Msw1 ca psig  wp 0 NNR W=300u L=100u
Msw2 cb psig  wn 0 NNR W=300u L=100u
Msw3 ca psigb wn 0 NNR W=300u L=100u
Msw4 cb psigb wp 0 NNR W=300u L=100u
.ends
Vdd vdd 0 1.0
Vbn vbn 0 0.30
Vgbn gbn 0 0.7
* --- input x (constant differential here: a fixed regression sample) ---
Vxp a_xp 0 0.8
Vxn a_xn 0 0.2
* --- target t (constant differential) ---
Vtp vtp 0 0.38
Vtn vtn 0 0.62
* --- phase clocks ---
Vpsig  psig  0 PWL(0.0n 0.0 199.5n 0.0 200.5n 2.0 399.5n 2.0 400.5n 0.0 599.5n 0.0 600.5n 2.0 799.5n 2.0 800.5n 0.0 999.5n 0.0 1000.5n 2.0 1199.5n 2.0 1200.5n 0.0 1399.5n 0.0 1400.5n 2.0 1599.5n 2.0 1600.5n 0.0 1799.5n 0.0 1800.5n 2.0 1999.5n 2.0 2000.5n 0.0 2199.5n 0.0 2200.5n 2.0 2399.5n 2.0 2400.5n 0.0 2599.5n 0.0 2600.5n 2.0 2799.5n 2.0 2800.5n 0.0 2999.5n 0.0 3000.5n 2.0 3199.5n 2.0 3200.5n 0.0 3399.5n 0.0 3400.5n 2.0 3599.5n 2.0 3600.5n 0.0 3799.5n 0.0 3800.5n 2.0 3999.5n 2.0 4000.5n 0.0 4199.5n 0.0 4200.5n 2.0 4399.5n 2.0 4400.5n 0.0 4599.5n 0.0 4600.5n 2.0 4799.5n 2.0 4800.5n 0.0 4999.5n 0.0 5000.5n 2.0 5199.5n 2.0 5200.5n 0.0 5399.5n 0.0 5400.5n 2.0 5599.5n 2.0 5600.5n 0.0 5799.5n 0.0 5800.5n 2.0 5999.5n 2.0 6000.5n 0.0 6199.5n 0.0 6200.5n 2.0 6399.5n 2.0 6400.5n 0.0 6599.5n 0.0 6600.5n 2.0 6799.5n 2.0 6800.5n 0.0 6999.5n 0.0 7000.5n 2.0 7199.5n 2.0 7200.5n 0.0 7399.5n 0.0 7400.5n 2.0 7599.5n 2.0 7600.5n 0.0 7799.5n 0.0 7800.5n 2.0 7999.5n 2.0 8000.5n 0.0 8199.5n 0.0 8200.5n 2.0 8399.5n 2.0 8400.5n 0.0 8599.5n 0.0 8600.5n 2.0 8799.5n 2.0 8800.5n 0.0 8999.5n 0.0 9000.5n 2.0 9199.5n 2.0 9200.5n 0.0 9399.5n 0.0 9400.5n 2.0 9599.5n 2.0 9600.5n 0.0 9799.5n 0.0 9800.5n 2.0 9999.5n 2.0 10000.5n 0.0 10199.5n 0.0 10200.5n 2.0 10399.5n 2.0 10400.5n 0.0 10599.5n 0.0 10600.5n 2.0 10799.5n 2.0 10800.5n 0.0 10999.5n 0.0 11000.5n 2.0 11199.5n 2.0 11200.5n 0.0 11399.5n 0.0 11400.5n 2.0 11599.5n 2.0 11600.5n 0.0 11799.5n 0.0 11800.5n 2.0 11999.5n 2.0 12000.5n 0.0 12199.5n 0.0 12200.5n 2.0 12399.5n 2.0 12400.5n 0.0 12599.5n 0.0 12600.5n 2.0 12799.5n 2.0 12800.5n 0.0 12999.5n 0.0 13000.5n 2.0 13199.5n 2.0 13200.5n 0.0 13399.5n 0.0 13400.5n 2.0 13599.5n 2.0 13600.5n 0.0 13799.5n 0.0 13800.5n 2.0 13999.5n 2.0 14000.5n 0.0 14199.5n 0.0 14200.5n 2.0 14399.5n 2.0 14400.5n 0.0 14599.5n 0.0 14600.5n 2.0 14799.5n 2.0 14800.5n 0.0 14999.5n 0.0 15000.5n 2.0 15199.5n 2.0 15200.5n 0.0 15399.5n 0.0 15400.5n 2.0 15599.5n 2.0 15600.5n 0.0 15799.5n 0.0 15800.5n 2.0 15999.5n 2.0 16000.5n 0.0 16199.5n 0.0 16200.5n 2.0 16399.5n 2.0 16400.5n 0.0 16599.5n 0.0 16600.5n 2.0 16799.5n 2.0 16800.5n 0.0 16999.5n 0.0 17000.5n 2.0 17199.5n 2.0 17200.5n 0.0 17399.5n 0.0 17400.5n 2.0 17599.5n 2.0 17600.5n 0.0 17799.5n 0.0 17800.5n 2.0 17999.5n 2.0 18000.5n 0.0 18199.5n 0.0 18200.5n 2.0 18399.5n 2.0 18400.5n 0.0 18599.5n 0.0 18600.5n 2.0 18799.5n 2.0 18800.5n 0.0 18999.5n 0.0 19000.5n 2.0 19199.5n 2.0 19200.5n 0.0 19399.5n 0.0 19400.5n 2.0 19599.5n 2.0 19600.5n 0.0 19799.5n 0.0 19800.5n 2.0 19999.5n 2.0 20000.5n 0.0 20199.5n 0.0 20200.5n 2.0 20399.5n 2.0 20400.5n 0.0 20599.5n 0.0 20600.5n 2.0 20799.5n 2.0 20800.5n 0.0 20999.5n 0.0 21000.5n 2.0 21199.5n 2.0 21200.5n 0.0 21399.5n 0.0 21400.5n 2.0 21599.5n 2.0 21600.5n 0.0 21799.5n 0.0 21800.5n 2.0 21999.5n 2.0 22000.5n 0.0 22199.5n 0.0 22200.5n 2.0 22399.5n 2.0 22400.5n 0.0 22599.5n 0.0 22600.5n 2.0 22799.5n 2.0 22800.5n 0.0 22999.5n 0.0 23000.5n 2.0 23199.5n 2.0 23200.5n 0.0 23399.5n 0.0 23400.5n 2.0 23599.5n 2.0 23600.5n 0.0 23799.5n 0.0 23800.5n 2.0 23999.5n 2.0 24000.5n 0.0 24199.5n 0.0 24200.5n 2.0 24399.5n 2.0 24400.5n 0.0 24599.5n 0.0 24600.5n 2.0 24799.5n 2.0 24800.5n 0.0 24999.5n 0.0 25000.5n 2.0 25199.5n 2.0 25200.5n 0.0 25399.5n 0.0 25400.5n 2.0 25599.5n 2.0 25600.5n 0.0 25799.5n 0.0 25800.5n 2.0 25999.5n 2.0 26000.5n 0.0 26199.5n 0.0 26200.5n 2.0 26399.5n 2.0 26400.5n 0.0 26599.5n 0.0 26600.5n 2.0 26799.5n 2.0 26800.5n 0.0 26999.5n 0.0 27000.5n 2.0 27199.5n 2.0 27200.5n 0.0 27399.5n 0.0 27400.5n 2.0 27599.5n 2.0 27600.5n 0.0 27799.5n 0.0 27800.5n 2.0 27999.5n 2.0 28000.5n 0.0 28199.5n 0.0 28200.5n 2.0 28399.5n 2.0 28400.5n 0.0 28599.5n 0.0 28600.5n 2.0 28799.5n 2.0 28800.5n 0.0 28999.5n 0.0 29000.5n 2.0 29199.5n 2.0 29200.5n 0.0 29399.5n 0.0 29400.5n 2.0 29599.5n 2.0 29600.5n 0.0 29799.5n 0.0 29800.5n 2.0 29999.5n 2.0 30000.5n 0.0 30199.5n 0.0 30200.5n 2.0 30399.5n 2.0 30400.5n 0.0 30599.5n 0.0 30600.5n 2.0 30799.5n 2.0 30800.5n 0.0 30999.5n 0.0 31000.5n 2.0 31199.5n 2.0 31200.5n 0.0 31399.5n 0.0 31400.5n 2.0 31599.5n 2.0 31600.5n 0.0 31799.5n 0.0 31800.5n 2.0 31999.5n 2.0 32000.5n 0.0)
Vpsigb psigb 0 PWL(0.0n 2.0 199.5n 2.0 200.5n 0.0 399.5n 0.0 400.5n 2.0 599.5n 2.0 600.5n 0.0 799.5n 0.0 800.5n 2.0 999.5n 2.0 1000.5n 0.0 1199.5n 0.0 1200.5n 2.0 1399.5n 2.0 1400.5n 0.0 1599.5n 0.0 1600.5n 2.0 1799.5n 2.0 1800.5n 0.0 1999.5n 0.0 2000.5n 2.0 2199.5n 2.0 2200.5n 0.0 2399.5n 0.0 2400.5n 2.0 2599.5n 2.0 2600.5n 0.0 2799.5n 0.0 2800.5n 2.0 2999.5n 2.0 3000.5n 0.0 3199.5n 0.0 3200.5n 2.0 3399.5n 2.0 3400.5n 0.0 3599.5n 0.0 3600.5n 2.0 3799.5n 2.0 3800.5n 0.0 3999.5n 0.0 4000.5n 2.0 4199.5n 2.0 4200.5n 0.0 4399.5n 0.0 4400.5n 2.0 4599.5n 2.0 4600.5n 0.0 4799.5n 0.0 4800.5n 2.0 4999.5n 2.0 5000.5n 0.0 5199.5n 0.0 5200.5n 2.0 5399.5n 2.0 5400.5n 0.0 5599.5n 0.0 5600.5n 2.0 5799.5n 2.0 5800.5n 0.0 5999.5n 0.0 6000.5n 2.0 6199.5n 2.0 6200.5n 0.0 6399.5n 0.0 6400.5n 2.0 6599.5n 2.0 6600.5n 0.0 6799.5n 0.0 6800.5n 2.0 6999.5n 2.0 7000.5n 0.0 7199.5n 0.0 7200.5n 2.0 7399.5n 2.0 7400.5n 0.0 7599.5n 0.0 7600.5n 2.0 7799.5n 2.0 7800.5n 0.0 7999.5n 0.0 8000.5n 2.0 8199.5n 2.0 8200.5n 0.0 8399.5n 0.0 8400.5n 2.0 8599.5n 2.0 8600.5n 0.0 8799.5n 0.0 8800.5n 2.0 8999.5n 2.0 9000.5n 0.0 9199.5n 0.0 9200.5n 2.0 9399.5n 2.0 9400.5n 0.0 9599.5n 0.0 9600.5n 2.0 9799.5n 2.0 9800.5n 0.0 9999.5n 0.0 10000.5n 2.0 10199.5n 2.0 10200.5n 0.0 10399.5n 0.0 10400.5n 2.0 10599.5n 2.0 10600.5n 0.0 10799.5n 0.0 10800.5n 2.0 10999.5n 2.0 11000.5n 0.0 11199.5n 0.0 11200.5n 2.0 11399.5n 2.0 11400.5n 0.0 11599.5n 0.0 11600.5n 2.0 11799.5n 2.0 11800.5n 0.0 11999.5n 0.0 12000.5n 2.0 12199.5n 2.0 12200.5n 0.0 12399.5n 0.0 12400.5n 2.0 12599.5n 2.0 12600.5n 0.0 12799.5n 0.0 12800.5n 2.0 12999.5n 2.0 13000.5n 0.0 13199.5n 0.0 13200.5n 2.0 13399.5n 2.0 13400.5n 0.0 13599.5n 0.0 13600.5n 2.0 13799.5n 2.0 13800.5n 0.0 13999.5n 0.0 14000.5n 2.0 14199.5n 2.0 14200.5n 0.0 14399.5n 0.0 14400.5n 2.0 14599.5n 2.0 14600.5n 0.0 14799.5n 0.0 14800.5n 2.0 14999.5n 2.0 15000.5n 0.0 15199.5n 0.0 15200.5n 2.0 15399.5n 2.0 15400.5n 0.0 15599.5n 0.0 15600.5n 2.0 15799.5n 2.0 15800.5n 0.0 15999.5n 0.0 16000.5n 2.0 16199.5n 2.0 16200.5n 0.0 16399.5n 0.0 16400.5n 2.0 16599.5n 2.0 16600.5n 0.0 16799.5n 0.0 16800.5n 2.0 16999.5n 2.0 17000.5n 0.0 17199.5n 0.0 17200.5n 2.0 17399.5n 2.0 17400.5n 0.0 17599.5n 0.0 17600.5n 2.0 17799.5n 2.0 17800.5n 0.0 17999.5n 0.0 18000.5n 2.0 18199.5n 2.0 18200.5n 0.0 18399.5n 0.0 18400.5n 2.0 18599.5n 2.0 18600.5n 0.0 18799.5n 0.0 18800.5n 2.0 18999.5n 2.0 19000.5n 0.0 19199.5n 0.0 19200.5n 2.0 19399.5n 2.0 19400.5n 0.0 19599.5n 0.0 19600.5n 2.0 19799.5n 2.0 19800.5n 0.0 19999.5n 0.0 20000.5n 2.0 20199.5n 2.0 20200.5n 0.0 20399.5n 0.0 20400.5n 2.0 20599.5n 2.0 20600.5n 0.0 20799.5n 0.0 20800.5n 2.0 20999.5n 2.0 21000.5n 0.0 21199.5n 0.0 21200.5n 2.0 21399.5n 2.0 21400.5n 0.0 21599.5n 0.0 21600.5n 2.0 21799.5n 2.0 21800.5n 0.0 21999.5n 0.0 22000.5n 2.0 22199.5n 2.0 22200.5n 0.0 22399.5n 0.0 22400.5n 2.0 22599.5n 2.0 22600.5n 0.0 22799.5n 0.0 22800.5n 2.0 22999.5n 2.0 23000.5n 0.0 23199.5n 0.0 23200.5n 2.0 23399.5n 2.0 23400.5n 0.0 23599.5n 0.0 23600.5n 2.0 23799.5n 2.0 23800.5n 0.0 23999.5n 0.0 24000.5n 2.0 24199.5n 2.0 24200.5n 0.0 24399.5n 0.0 24400.5n 2.0 24599.5n 2.0 24600.5n 0.0 24799.5n 0.0 24800.5n 2.0 24999.5n 2.0 25000.5n 0.0 25199.5n 0.0 25200.5n 2.0 25399.5n 2.0 25400.5n 0.0 25599.5n 0.0 25600.5n 2.0 25799.5n 2.0 25800.5n 0.0 25999.5n 0.0 26000.5n 2.0 26199.5n 2.0 26200.5n 0.0 26399.5n 0.0 26400.5n 2.0 26599.5n 2.0 26600.5n 0.0 26799.5n 0.0 26800.5n 2.0 26999.5n 2.0 27000.5n 0.0 27199.5n 0.0 27200.5n 2.0 27399.5n 2.0 27400.5n 0.0 27599.5n 0.0 27600.5n 2.0 27799.5n 2.0 27800.5n 0.0 27999.5n 0.0 28000.5n 2.0 28199.5n 2.0 28200.5n 0.0 28399.5n 0.0 28400.5n 2.0 28599.5n 2.0 28600.5n 0.0 28799.5n 0.0 28800.5n 2.0 28999.5n 2.0 29000.5n 0.0 29199.5n 0.0 29200.5n 2.0 29399.5n 2.0 29400.5n 0.0 29599.5n 0.0 29600.5n 2.0 29799.5n 2.0 29800.5n 0.0 29999.5n 0.0 30000.5n 2.0 30199.5n 2.0 30200.5n 0.0 30399.5n 0.0 30400.5n 2.0 30599.5n 2.0 30600.5n 0.0 30799.5n 0.0 30800.5n 2.0 30999.5n 2.0 31000.5n 0.0 31199.5n 0.0 31200.5n 2.0 31399.5n 2.0 31400.5n 0.0 31599.5n 0.0 31600.5n 2.0 31799.5n 2.0 31800.5n 0.0 31999.5n 0.0 32000.5n 2.0)
Vnen   nen   0 PWL(0.0n 0.0 199.5n 0.0 200.5n 2.0 399.5n 2.0 400.5n 0.0 599.5n 0.0 600.5n 2.0 799.5n 2.0 800.5n 0.0 999.5n 0.0 1000.5n 2.0 1199.5n 2.0 1200.5n 0.0 1399.5n 0.0 1400.5n 2.0 1599.5n 2.0 1600.5n 0.0 1799.5n 0.0 1800.5n 2.0 1999.5n 2.0 2000.5n 0.0 2199.5n 0.0 2200.5n 2.0 2399.5n 2.0 2400.5n 0.0 2599.5n 0.0 2600.5n 2.0 2799.5n 2.0 2800.5n 0.0 2999.5n 0.0 3000.5n 2.0 3199.5n 2.0 3200.5n 0.0 3399.5n 0.0 3400.5n 2.0 3599.5n 2.0 3600.5n 0.0 3799.5n 0.0 3800.5n 2.0 3999.5n 2.0 4000.5n 0.0 4199.5n 0.0 4200.5n 2.0 4399.5n 2.0 4400.5n 0.0 4599.5n 0.0 4600.5n 2.0 4799.5n 2.0 4800.5n 0.0 4999.5n 0.0 5000.5n 2.0 5199.5n 2.0 5200.5n 0.0 5399.5n 0.0 5400.5n 2.0 5599.5n 2.0 5600.5n 0.0 5799.5n 0.0 5800.5n 2.0 5999.5n 2.0 6000.5n 0.0 6199.5n 0.0 6200.5n 2.0 6399.5n 2.0 6400.5n 0.0 6599.5n 0.0 6600.5n 2.0 6799.5n 2.0 6800.5n 0.0 6999.5n 0.0 7000.5n 2.0 7199.5n 2.0 7200.5n 0.0 7399.5n 0.0 7400.5n 2.0 7599.5n 2.0 7600.5n 0.0 7799.5n 0.0 7800.5n 2.0 7999.5n 2.0 8000.5n 0.0 8199.5n 0.0 8200.5n 2.0 8399.5n 2.0 8400.5n 0.0 8599.5n 0.0 8600.5n 2.0 8799.5n 2.0 8800.5n 0.0 8999.5n 0.0 9000.5n 2.0 9199.5n 2.0 9200.5n 0.0 9399.5n 0.0 9400.5n 2.0 9599.5n 2.0 9600.5n 0.0 9799.5n 0.0 9800.5n 2.0 9999.5n 2.0 10000.5n 0.0 10199.5n 0.0 10200.5n 2.0 10399.5n 2.0 10400.5n 0.0 10599.5n 0.0 10600.5n 2.0 10799.5n 2.0 10800.5n 0.0 10999.5n 0.0 11000.5n 2.0 11199.5n 2.0 11200.5n 0.0 11399.5n 0.0 11400.5n 2.0 11599.5n 2.0 11600.5n 0.0 11799.5n 0.0 11800.5n 2.0 11999.5n 2.0 12000.5n 0.0 12199.5n 0.0 12200.5n 2.0 12399.5n 2.0 12400.5n 0.0 12599.5n 0.0 12600.5n 2.0 12799.5n 2.0 12800.5n 0.0 12999.5n 0.0 13000.5n 2.0 13199.5n 2.0 13200.5n 0.0 13399.5n 0.0 13400.5n 2.0 13599.5n 2.0 13600.5n 0.0 13799.5n 0.0 13800.5n 2.0 13999.5n 2.0 14000.5n 0.0 14199.5n 0.0 14200.5n 2.0 14399.5n 2.0 14400.5n 0.0 14599.5n 0.0 14600.5n 2.0 14799.5n 2.0 14800.5n 0.0 14999.5n 0.0 15000.5n 2.0 15199.5n 2.0 15200.5n 0.0 15399.5n 0.0 15400.5n 2.0 15599.5n 2.0 15600.5n 0.0 15799.5n 0.0 15800.5n 2.0 15999.5n 2.0 16000.5n 0.0 16199.5n 0.0 16200.5n 2.0 16399.5n 2.0 16400.5n 0.0 16599.5n 0.0 16600.5n 2.0 16799.5n 2.0 16800.5n 0.0 16999.5n 0.0 17000.5n 2.0 17199.5n 2.0 17200.5n 0.0 17399.5n 0.0 17400.5n 2.0 17599.5n 2.0 17600.5n 0.0 17799.5n 0.0 17800.5n 2.0 17999.5n 2.0 18000.5n 0.0 18199.5n 0.0 18200.5n 2.0 18399.5n 2.0 18400.5n 0.0 18599.5n 0.0 18600.5n 2.0 18799.5n 2.0 18800.5n 0.0 18999.5n 0.0 19000.5n 2.0 19199.5n 2.0 19200.5n 0.0 19399.5n 0.0 19400.5n 2.0 19599.5n 2.0 19600.5n 0.0 19799.5n 0.0 19800.5n 2.0 19999.5n 2.0 20000.5n 0.0 20199.5n 0.0 20200.5n 2.0 20399.5n 2.0 20400.5n 0.0 20599.5n 0.0 20600.5n 2.0 20799.5n 2.0 20800.5n 0.0 20999.5n 0.0 21000.5n 2.0 21199.5n 2.0 21200.5n 0.0 21399.5n 0.0 21400.5n 2.0 21599.5n 2.0 21600.5n 0.0 21799.5n 0.0 21800.5n 2.0 21999.5n 2.0 22000.5n 0.0 22199.5n 0.0 22200.5n 2.0 22399.5n 2.0 22400.5n 0.0 22599.5n 0.0 22600.5n 2.0 22799.5n 2.0 22800.5n 0.0 22999.5n 0.0 23000.5n 2.0 23199.5n 2.0 23200.5n 0.0 23399.5n 0.0 23400.5n 2.0 23599.5n 2.0 23600.5n 0.0 23799.5n 0.0 23800.5n 2.0 23999.5n 2.0 24000.5n 0.0 24199.5n 0.0 24200.5n 2.0 24399.5n 2.0 24400.5n 0.0 24599.5n 0.0 24600.5n 2.0 24799.5n 2.0 24800.5n 0.0 24999.5n 0.0 25000.5n 2.0 25199.5n 2.0 25200.5n 0.0 25399.5n 0.0 25400.5n 2.0 25599.5n 2.0 25600.5n 0.0 25799.5n 0.0 25800.5n 2.0 25999.5n 2.0 26000.5n 0.0 26199.5n 0.0 26200.5n 2.0 26399.5n 2.0 26400.5n 0.0 26599.5n 0.0 26600.5n 2.0 26799.5n 2.0 26800.5n 0.0 26999.5n 0.0 27000.5n 2.0 27199.5n 2.0 27200.5n 0.0 27399.5n 0.0 27400.5n 2.0 27599.5n 2.0 27600.5n 0.0 27799.5n 0.0 27800.5n 2.0 27999.5n 2.0 28000.5n 0.0 28199.5n 0.0 28200.5n 2.0 28399.5n 2.0 28400.5n 0.0 28599.5n 0.0 28600.5n 2.0 28799.5n 2.0 28800.5n 0.0 28999.5n 0.0 29000.5n 2.0 29199.5n 2.0 29200.5n 0.0 29399.5n 0.0 29400.5n 2.0 29599.5n 2.0 29600.5n 0.0 29799.5n 0.0 29800.5n 2.0 29999.5n 2.0 30000.5n 0.0 30199.5n 0.0 30200.5n 2.0 30399.5n 2.0 30400.5n 0.0 30599.5n 0.0 30600.5n 2.0 30799.5n 2.0 30800.5n 0.0 30999.5n 0.0 31000.5n 2.0 31199.5n 2.0 31200.5n 0.0 31399.5n 0.0 31400.5n 2.0 31599.5n 2.0 31600.5n 0.0 31799.5n 0.0 31800.5n 2.0 31999.5n 2.0 32000.5n 0.0)
* --- weight caps (the trainable parameter) + CMFB to hold common mode ---
Cwp wp 0 8p
Cwn wn 0 8p
Rcp wp cmn 200meg
Rcn wn cmn 200meg
Msp wp cmn 0 0 NNR W=700u L=100u
Msn wn cmn 0 0 NNR W=700u L=100u
* --- forward synapse: o = w * x ---
Mlp_o up_o up_o vdd vdd PNR W=3000u L=100u
Mln_o un_o un_o vdd vdd PNR W=3000u L=100u
Co_p up_o 0 0.2p
Co_n un_o 0 0.2p
Xsyn a_xp a_xn up_o un_o wp wn vdd dsyn
* --- nudge: in nudge phase, pull output softly toward target (switch transistors) ---
Mnp up_o nen vtp 0 NNR W=60u L=100u
Mnn un_o nen vtn 0 NNR W=60u L=100u
* --- update cell: correlate input activity x with output activity o (SGN sets polarity) ---
Xupd a_xp a_xn up_o un_o wp wn psigb psig vdd gbn gupd
.ic v(wp)=0.5 v(wn)=0.5 v(up_o)=0.5 v(un_o)=0.5 v(cmn)=0.5
.tran 1n 32000n uic
.control
run
wrdata e2e_min.dat v(wp) v(wn) v(up_o) v(un_o)
.endc
.end
