batched
.model NNR NMOS (LEVEL=1 VTO=0.2 KP=120u LAMBDA=0.02 GAMMA=0 PHI=0.7)
.model PNR PMOS (LEVEL=1 VTO=-0.2 KP=40u LAMBDA=0.02 GAMMA=0 PHI=0.7)
.subckt gsyn inp inn wp wn outp outn vdd vbn
Mtail nt vbn 0 0 NNR W=400u L=100u
M5 na wp s5 0 NNR W=200u L=100u
Rd5 s5 nt 20k
M6 nb wn s6 0 NNR W=200u L=100u
Rd6 s6 nt 20k
M1 outp inp s1 0 NNR W=200u L=100u
Rd1 s1 na 20k
M2 outn inn s2 0 NNR W=200u L=100u
Rd2 s2 na 20k
M3 outn inp s3 0 NNR W=200u L=100u
Rd3 s3 nb 20k
M4 outp inn s4 0 NNR W=200u L=100u
Rd4 s4 nb 20k
.ends
.subckt cmld p n vdd
Rcs1 p cmx 300k
Rcs2 n cmx 300k
MLp p cmx vdd vdd PNR W=4000u L=100u
MLn n cmx vdd vdd PNR W=4000u L=100u
.ends
.subckt dneuron up un ap an vdd vbn
M1 an up s1 0 NNR W=200u L=100u
Rn1 s1 tn 10k
M2 ap un s2 0 NNR W=200u L=100u
Rn2 s2 tn 10k
Mt tn vbn 0 0 NNR W=200u L=100u
Xcm ap an vdd cmld
.ends

Vdd vdd 0 1.0
Vbsyn vbsyn 0 0.45
Vbbk vbbk 0 0.30
Vbneu vbneu 0 0.35
Vgm gm 0 0.6
Vxp0 a_xp0 0 PWL(0.01n 0.1703 20.00n 0.1703 20.01n 0.7553 40.00n 0.7553 40.01n 0.8832 60.00n 0.8832 60.01n 0.2371 80.00n 0.2371 80.01n 0.5716 100.00n 0.5716 100.01n 0.1668 120.00n 0.1668 120.01n 0.8828 140.00n 0.8828 140.01n 0.5151 160.00n 0.5151 160.01n 0.0980 180.00n 0.0980 180.01n 0.0842 200.00n 0.0842 200.01n 0.4543 220.00n 0.4543 220.01n 0.1972 240.00n 0.1972 240.01n 0.6859 260.00n 0.6859 260.01n 0.8847 280.00n 0.8847 280.01n 0.0556 300.00n 0.0556 300.01n 0.3782 320.00n 0.3782 320.01n 0.4044 340.00n 0.4044 340.01n 0.3412 360.00n 0.3412 360.01n 0.1226 380.00n 0.1226 380.01n 0.9117 400.00n 0.9117 400.01n 0.6094 420.00n 0.6094 420.01n 0.5589 440.00n 0.5589 440.01n 0.6973 460.00n 0.6973 460.01n 0.8302 480.00n 0.8302 480.01n 0.5255 500.00n 0.5255 500.01n 0.6640 520.00n 0.6640 520.01n 0.7078 540.00n 0.7078 540.01n 0.6468 560.00n 0.6468 560.01n 0.1985 580.00n 0.1985 580.01n 0.3690 600.00n 0.3690 600.01n 0.0703 620.00n 0.0703 620.01n 0.6598)
Vxn0 a_xn0 0 PWL(0.01n 0.8297 20.00n 0.8297 20.01n 0.2447 40.00n 0.2447 40.01n 0.1168 60.00n 0.1168 60.01n 0.7629 80.00n 0.7629 80.01n 0.4284 100.00n 0.4284 100.01n 0.8332 120.00n 0.8332 120.01n 0.1172 140.00n 0.1172 140.01n 0.4849 160.00n 0.4849 160.01n 0.9020 180.00n 0.9020 180.01n 0.9158 200.00n 0.9158 200.01n 0.5457 220.00n 0.5457 220.01n 0.8028 240.00n 0.8028 240.01n 0.3141 260.00n 0.3141 260.01n 0.1153 280.00n 0.1153 280.01n 0.9444 300.00n 0.9444 300.01n 0.6218 320.00n 0.6218 320.01n 0.5956 340.00n 0.5956 340.01n 0.6588 360.00n 0.6588 360.01n 0.8774 380.00n 0.8774 380.01n 0.0883 400.00n 0.0883 400.01n 0.3906 420.00n 0.3906 420.01n 0.4411 440.00n 0.4411 440.01n 0.3027 460.00n 0.3027 460.01n 0.1698 480.00n 0.1698 480.01n 0.4745 500.00n 0.4745 500.01n 0.3360 520.00n 0.3360 520.01n 0.2922 540.00n 0.2922 540.01n 0.3532 560.00n 0.3532 560.01n 0.8015 580.00n 0.8015 580.01n 0.6310 600.00n 0.6310 600.01n 0.9297 620.00n 0.9297 620.01n 0.3402)
Vxp1 a_xp1 0 PWL(0.01n 0.2639 20.00n 0.2639 20.01n 0.1343 40.00n 0.1343 40.01n 0.3334 60.00n 0.3334 60.01n 0.8292 80.00n 0.8292 80.01n 0.8850 100.00n 0.8850 100.01n 0.2427 120.00n 0.2427 120.01n 0.5742 140.00n 0.5742 140.01n 0.9304 160.00n 0.9304 160.01n 0.6418 180.00n 0.6418 180.01n 0.6259 200.00n 0.6259 200.01n 0.0560 220.00n 0.0560 220.01n 0.8014 240.00n 0.8014 240.01n 0.8759 260.00n 0.8759 260.01n 0.4781 280.00n 0.4781 280.01n 0.4657 300.00n 0.4657 300.01n 0.0601 320.00n 0.0601 320.01n 0.1358 340.00n 0.1358 340.01n 0.0730 360.00n 0.0730 360.01n 0.2725 380.00n 0.2725 380.01n 0.5964 400.00n 0.5964 400.01n 0.8533 420.00n 0.8533 420.01n 0.1169 440.00n 0.1169 440.01n 0.8660 460.00n 0.8660 460.01n 0.2835 480.00n 0.2835 480.01n 0.1095 500.00n 0.1095 500.01n 0.8630 520.00n 0.8630 520.01n 0.1731 540.00n 0.1731 540.01n 0.0730 560.00n 0.0730 560.01n 0.1740 580.00n 0.1740 580.01n 0.0761 600.00n 0.0761 600.01n 0.3982 620.00n 0.3982 620.01n 0.0861)
Vxn1 a_xn1 0 PWL(0.01n 0.7361 20.00n 0.7361 20.01n 0.8657 40.00n 0.8657 40.01n 0.6666 60.00n 0.6666 60.01n 0.1708 80.00n 0.1708 80.01n 0.1150 100.00n 0.1150 100.01n 0.7573 120.00n 0.7573 120.01n 0.4258 140.00n 0.4258 140.01n 0.0696 160.00n 0.0696 160.01n 0.3582 180.00n 0.3582 180.01n 0.3741 200.00n 0.3741 200.01n 0.9440 220.00n 0.9440 220.01n 0.1986 240.00n 0.1986 240.01n 0.1241 260.00n 0.1241 260.01n 0.5219 280.00n 0.5219 280.01n 0.5343 300.00n 0.5343 300.01n 0.9399 320.00n 0.9399 320.01n 0.8642 340.00n 0.8642 340.01n 0.9270 360.00n 0.9270 360.01n 0.7275 380.00n 0.7275 380.01n 0.4036 400.00n 0.4036 400.01n 0.1467 420.00n 0.1467 420.01n 0.8831 440.00n 0.8831 440.01n 0.1340 460.00n 0.1340 460.01n 0.7165 480.00n 0.7165 480.01n 0.8905 500.00n 0.8905 500.01n 0.1370 520.00n 0.1370 520.01n 0.8269 540.00n 0.8269 540.01n 0.9270 560.00n 0.9270 560.01n 0.8260 580.00n 0.8260 580.01n 0.9239 600.00n 0.9239 600.01n 0.6018 620.00n 0.6018 620.01n 0.9139)
Vxp2 a_xp2 0 PWL(0.01n 0.6800 20.00n 0.6800 20.01n 0.6800 40.00n 0.6800 40.01n 0.6800 60.00n 0.6800 60.01n 0.6800 80.00n 0.6800 80.01n 0.6800 100.00n 0.6800 100.01n 0.6800 120.00n 0.6800 120.01n 0.6800 140.00n 0.6800 140.01n 0.6800 160.00n 0.6800 160.01n 0.6800 180.00n 0.6800 180.01n 0.6800 200.00n 0.6800 200.01n 0.6800 220.00n 0.6800 220.01n 0.6800 240.00n 0.6800 240.01n 0.6800 260.00n 0.6800 260.01n 0.6800 280.00n 0.6800 280.01n 0.6800 300.00n 0.6800 300.01n 0.6800 320.00n 0.6800 320.01n 0.6800 340.00n 0.6800 340.01n 0.6800 360.00n 0.6800 360.01n 0.6800 380.00n 0.6800 380.01n 0.6800 400.00n 0.6800 400.01n 0.6800 420.00n 0.6800 420.01n 0.6800 440.00n 0.6800 440.01n 0.6800 460.00n 0.6800 460.01n 0.6800 480.00n 0.6800 480.01n 0.6800 500.00n 0.6800 500.01n 0.6800 520.00n 0.6800 520.01n 0.6800 540.00n 0.6800 540.01n 0.6800 560.00n 0.6800 560.01n 0.6800 580.00n 0.6800 580.01n 0.6800 600.00n 0.6800 600.01n 0.6800 620.00n 0.6800 620.01n 0.6800)
Vxn2 a_xn2 0 PWL(0.01n 0.3200 20.00n 0.3200 20.01n 0.3200 40.00n 0.3200 40.01n 0.3200 60.00n 0.3200 60.01n 0.3200 80.00n 0.3200 80.01n 0.3200 100.00n 0.3200 100.01n 0.3200 120.00n 0.3200 120.01n 0.3200 140.00n 0.3200 140.01n 0.3200 160.00n 0.3200 160.01n 0.3200 180.00n 0.3200 180.01n 0.3200 200.00n 0.3200 200.01n 0.3200 220.00n 0.3200 220.01n 0.3200 240.00n 0.3200 240.01n 0.3200 260.00n 0.3200 260.01n 0.3200 280.00n 0.3200 280.01n 0.3200 300.00n 0.3200 300.01n 0.3200 320.00n 0.3200 320.01n 0.3200 340.00n 0.3200 340.01n 0.3200 360.00n 0.3200 360.01n 0.3200 380.00n 0.3200 380.01n 0.3200 400.00n 0.3200 400.01n 0.3200 420.00n 0.3200 420.01n 0.3200 440.00n 0.3200 440.01n 0.3200 460.00n 0.3200 460.01n 0.3200 480.00n 0.3200 480.01n 0.3200 500.00n 0.3200 500.01n 0.3200 520.00n 0.3200 520.01n 0.3200 540.00n 0.3200 540.01n 0.3200 560.00n 0.3200 560.01n 0.3200 580.00n 0.3200 580.01n 0.3200 600.00n 0.3200 600.01n 0.3200 620.00n 0.3200 620.01n 0.3200)
Vwp_ih_0_0 wp_ih_0_0 0 0.899
Vwn_ih_0_0 wn_ih_0_0 0 0.3
Vwp_ih_1_0 wp_ih_1_0 0 0.3
Vwn_ih_1_0 wn_ih_1_0 0 0.8849439450919543
Vwp_ih_2_0 wp_ih_2_0 0 0.3
Vwn_ih_2_0 wn_ih_2_0 0 0.8917787507674537
Vwp_ih_0_1 wp_ih_0_1 0 0.8989811454598704
Vwn_ih_0_1 wn_ih_0_1 0 0.3
Vwp_ih_1_1 wp_ih_1_1 0 0.6027103299098749
Vwn_ih_1_1 wn_ih_1_1 0 0.39728967009012506
Vwp_ih_2_1 wp_ih_2_1 0 0.3
Vwn_ih_2_1 wn_ih_2_1 0 0.8314927842888213
Vwp_ih_0_2 wp_ih_0_2 0 0.42823181800833865
Vwn_ih_0_2 wn_ih_0_2 0 0.5717681819916614
Vwp_ih_1_2 wp_ih_1_2 0 0.653159861412038
Vwn_ih_1_2 wn_ih_1_2 0 0.34684013858796203
Vwp_ih_2_2 wp_ih_2_2 0 0.3
Vwn_ih_2_2 wn_ih_2_2 0 0.899
Vwp_ih_0_3 wp_ih_0_3 0 0.8434063654770831
Vwn_ih_0_3 wn_ih_0_3 0 0.3
Vwp_ih_1_3 wp_ih_1_3 0 0.5754573937550272
Vwn_ih_1_3 wn_ih_1_3 0 0.4245426062449728
Vwp_ih_2_3 wp_ih_2_3 0 0.899
Vwn_ih_2_3 wn_ih_2_3 0 0.3
Vwp_ih_0_4 wp_ih_0_4 0 0.445133770823353
Vwn_ih_0_4 wn_ih_0_4 0 0.5548662291766471
Vwp_ih_1_4 wp_ih_1_4 0 0.6636293527821605
Vwn_ih_1_4 wn_ih_1_4 0 0.3363706472178395
Vwp_ih_2_4 wp_ih_2_4 0 0.899
Vwn_ih_2_4 wn_ih_2_4 0 0.3
Vwp_ih_0_5 wp_ih_0_5 0 0.39208888821654597
Vwn_ih_0_5 wn_ih_0_5 0 0.607911111783454
Vwp_ih_1_5 wp_ih_1_5 0 0.8016259377198964
Vwn_ih_1_5 wn_ih_1_5 0 0.3
Vwp_ih_2_5 wp_ih_2_5 0 0.3
Vwn_ih_2_5 wn_ih_2_5 0 0.8974144563944045
Vwp_ih_0_6 wp_ih_0_6 0 0.603762739521678
Vwn_ih_0_6 wn_ih_0_6 0 0.396237260478322
Vwp_ih_1_6 wp_ih_1_6 0 0.3
Vwn_ih_1_6 wn_ih_1_6 0 0.899
Vwp_ih_2_6 wp_ih_2_6 0 0.3
Vwn_ih_2_6 wn_ih_2_6 0 0.7884631147290531
Vwp_ih_0_7 wp_ih_0_7 0 0.3
Vwn_ih_0_7 wn_ih_0_7 0 0.899
Vwp_ih_1_7 wp_ih_1_7 0 0.6590050679595201
Vwn_ih_1_7 wn_ih_1_7 0 0.3409949320404799
Vwp_ih_2_7 wp_ih_2_7 0 0.3
Vwn_ih_2_7 wn_ih_2_7 0 0.7927277783480942
Vwp_ih_0_8 wp_ih_0_8 0 0.3895370545075305
Vwn_ih_0_8 wn_ih_0_8 0 0.6104629454924695
Vwp_ih_1_8 wp_ih_1_8 0 0.3
Vwn_ih_1_8 wn_ih_1_8 0 0.899
Vwp_ih_2_8 wp_ih_2_8 0 0.7421312535684854
Vwn_ih_2_8 wn_ih_2_8 0 0.3
Vwp_ih_0_9 wp_ih_0_9 0 0.42558310853420067
Vwn_ih_0_9 wn_ih_0_9 0 0.5744168914657993
Vwp_ih_1_9 wp_ih_1_9 0 0.6520027677155666
Vwn_ih_1_9 wn_ih_1_9 0 0.34799723228443336
Vwp_ih_2_9 wp_ih_2_9 0 0.3
Vwn_ih_2_9 wn_ih_2_9 0 0.899
Vwp_ih_0_10 wp_ih_0_10 0 0.6767017039316949
Vwn_ih_0_10 wn_ih_0_10 0 0.323298296068305
Vwp_ih_1_10 wp_ih_1_10 0 0.5452134537376615
Vwn_ih_1_10 wn_ih_1_10 0 0.45478654626233855
Vwp_ih_2_10 wp_ih_2_10 0 0.899
Vwn_ih_2_10 wn_ih_2_10 0 0.3
Vwp_ih_0_11 wp_ih_0_11 0 0.3961611027087502
Vwn_ih_0_11 wn_ih_0_11 0 0.6038388972912498
Vwp_ih_1_11 wp_ih_1_11 0 0.8759884013064738
Vwn_ih_1_11 wn_ih_1_11 0 0.3
Vwp_ih_2_11 wp_ih_2_11 0 0.3
Vwn_ih_2_11 wn_ih_2_11 0 0.8947106165096766
Vwp_ih_0_12 wp_ih_0_12 0 0.5019810205123837
Vwn_ih_0_12 wn_ih_0_12 0 0.4980189794876163
Vwp_ih_1_12 wp_ih_1_12 0 0.500786404639716
Vwn_ih_1_12 wn_ih_1_12 0 0.49921359536028403
Vwp_ih_2_12 wp_ih_2_12 0 0.8967845258677241
Vwn_ih_2_12 wn_ih_2_12 0 0.3
Vwp_ih_0_13 wp_ih_0_13 0 0.6202501672619012
Vwn_ih_0_13 wn_ih_0_13 0 0.37974983273809876
Vwp_ih_1_13 wp_ih_1_13 0 0.899
Vwn_ih_1_13 wn_ih_1_13 0 0.3
Vwp_ih_2_13 wp_ih_2_13 0 0.74665774606287
Vwn_ih_2_13 wn_ih_2_13 0 0.3
Vwp_ih_0_14 wp_ih_0_14 0 0.49745411797666583
Vwn_ih_0_14 wn_ih_0_14 0 0.5025458820233342
Vwp_ih_1_14 wp_ih_1_14 0 0.49969922825808316
Vwn_ih_1_14 wn_ih_1_14 0 0.5003007717419168
Vwp_ih_2_14 wp_ih_2_14 0 0.3
Vwn_ih_2_14 wn_ih_2_14 0 0.8857075380937838
Vwp_ih_0_15 wp_ih_0_15 0 0.3
Vwn_ih_0_15 wn_ih_0_15 0 0.7824795931360615
Vwp_ih_1_15 wp_ih_1_15 0 0.3
Vwn_ih_1_15 wn_ih_1_15 0 0.899
Vwp_ih_2_15 wp_ih_2_15 0 0.3
Vwn_ih_2_15 wn_ih_2_15 0 0.8916006822045232
Vwp_ih_0_16 wp_ih_0_16 0 0.4262373806672155
Vwn_ih_0_16 wn_ih_0_16 0 0.5737626193327845
Vwp_ih_1_16 wp_ih_1_16 0 0.3
Vwn_ih_1_16 wn_ih_1_16 0 0.8156920627342515
Vwp_ih_2_16 wp_ih_2_16 0 0.899
Vwn_ih_2_16 wn_ih_2_16 0 0.3
Vwp_ih_0_17 wp_ih_0_17 0 0.5030520102901842
Vwn_ih_0_17 wn_ih_0_17 0 0.49694798970981574
Vwp_ih_1_17 wp_ih_1_17 0 0.5006232020109217
Vwn_ih_1_17 wn_ih_1_17 0 0.49937679798907836
Vwp_ih_2_17 wp_ih_2_17 0 0.8965409001784168
Vwn_ih_2_17 wn_ih_2_17 0 0.3
Vwp_ih_0_18 wp_ih_0_18 0 0.8958508830313368
Vwn_ih_0_18 wn_ih_0_18 0 0.3
Vwp_ih_1_18 wp_ih_1_18 0 0.3
Vwn_ih_1_18 wn_ih_1_18 0 0.8487953256032772
Vwp_ih_2_18 wp_ih_2_18 0 0.899
Vwn_ih_2_18 wn_ih_2_18 0 0.3
Vwp_ih_0_19 wp_ih_0_19 0 0.6742483822850791
Vwn_ih_0_19 wn_ih_0_19 0 0.3257516177149209
Vwp_ih_1_19 wp_ih_1_19 0 0.49807590185922734
Vwn_ih_1_19 wn_ih_1_19 0 0.5019240981407727
Vwp_ih_2_19 wp_ih_2_19 0 0.3
Vwn_ih_2_19 wn_ih_2_19 0 0.899
Vwp_ih_0_20 wp_ih_0_20 0 0.7413663401996315
Vwn_ih_0_20 wn_ih_0_20 0 0.3
Vwp_ih_1_20 wp_ih_1_20 0 0.7520701084899759
Vwn_ih_1_20 wn_ih_1_20 0 0.3
Vwp_ih_2_20 wp_ih_2_20 0 0.3
Vwn_ih_2_20 wn_ih_2_20 0 0.8985463484809063
Vwp_ih_0_21 wp_ih_0_21 0 0.8197317007846419
Vwn_ih_0_21 wn_ih_0_21 0 0.3
Vwp_ih_1_21 wp_ih_1_21 0 0.5419309280255441
Vwn_ih_1_21 wn_ih_1_21 0 0.45806907197445595
Vwp_ih_2_21 wp_ih_2_21 0 0.3
Vwn_ih_2_21 wn_ih_2_21 0 0.899
Vwp_ih_0_22 wp_ih_0_22 0 0.49228885115193277
Vwn_ih_0_22 wn_ih_0_22 0 0.5077111488480672
Vwp_ih_1_22 wp_ih_1_22 0 0.899
Vwn_ih_1_22 wn_ih_1_22 0 0.3
Vwp_ih_2_22 wp_ih_2_22 0 0.3
Vwn_ih_2_22 wn_ih_2_22 0 0.7375829196711619
Vwp_ih_0_23 wp_ih_0_23 0 0.3
Vwn_ih_0_23 wn_ih_0_23 0 0.8942991230956236
Vwp_ih_1_23 wp_ih_1_23 0 0.3
Vwn_ih_1_23 wn_ih_1_23 0 0.899
Vwp_ih_2_23 wp_ih_2_23 0 0.854104002211723
Vwn_ih_2_23 wn_ih_2_23 0 0.3
Vwp_ih_0_24 wp_ih_0_24 0 0.49820488956566195
Vwn_ih_0_24 wn_ih_0_24 0 0.5017951104343381
Vwp_ih_1_24 wp_ih_1_24 0 0.49919381950339675
Vwn_ih_1_24 wn_ih_1_24 0 0.5008061804966033
Vwp_ih_2_24 wp_ih_2_24 0 0.3
Vwn_ih_2_24 wn_ih_2_24 0 0.8966089448555099
Vwp_ih_0_25 wp_ih_0_25 0 0.6236556081098547
Vwn_ih_0_25 wn_ih_0_25 0 0.37634439189014535
Vwp_ih_1_25 wp_ih_1_25 0 0.6110094517330421
Vwn_ih_1_25 wn_ih_1_25 0 0.3889905482669579
Vwp_ih_2_25 wp_ih_2_25 0 0.3
Vwn_ih_2_25 wn_ih_2_25 0 0.899
Vwp_ih_0_26 wp_ih_0_26 0 0.4709639290893125
Vwn_ih_0_26 wn_ih_0_26 0 0.5290360709106875
Vwp_ih_1_26 wp_ih_1_26 0 0.8112085771025347
Vwn_ih_1_26 wn_ih_1_26 0 0.3
Vwp_ih_2_26 wp_ih_2_26 0 0.8981463726411067
Vwn_ih_2_26 wn_ih_2_26 0 0.3
Vwp_ih_0_27 wp_ih_0_27 0 0.5744413587470095
Vwn_ih_0_27 wn_ih_0_27 0 0.4255586412529905
Vwp_ih_1_27 wp_ih_1_27 0 0.3453808244649817
Vwn_ih_1_27 wn_ih_1_27 0 0.6546191755350184
Vwp_ih_2_27 wp_ih_2_27 0 0.3
Vwn_ih_2_27 wn_ih_2_27 0 0.899
Vwp_ih_0_28 wp_ih_0_28 0 0.3
Vwn_ih_0_28 wn_ih_0_28 0 0.7595586488653878
Vwp_ih_1_28 wp_ih_1_28 0 0.7340307835254947
Vwn_ih_1_28 wn_ih_1_28 0 0.3
Vwp_ih_2_28 wp_ih_2_28 0 0.3
Vwn_ih_2_28 wn_ih_2_28 0 0.899
Vwp_ih_0_29 wp_ih_0_29 0 0.4999591300845372
Vwn_ih_0_29 wn_ih_0_29 0 0.5000408699154628
Vwp_ih_1_29 wp_ih_1_29 0 0.5030287012805752
Vwn_ih_1_29 wn_ih_1_29 0 0.4969712987194248
Vwp_ih_2_29 wp_ih_2_29 0 0.5013393650162352
Vwn_ih_2_29 wn_ih_2_29 0 0.4986606349837648
Vwp_ih_0_30 wp_ih_0_30 0 0.4999569628351597
Vwn_ih_0_30 wn_ih_0_30 0 0.5000430371648403
Vwp_ih_1_30 wp_ih_1_30 0 0.5000100216894071
Vwn_ih_1_30 wn_ih_1_30 0 0.4999899783105929
Vwp_ih_2_30 wp_ih_2_30 0 0.49998898217671933
Vwn_ih_2_30 wn_ih_2_30 0 0.5000110178232806
Vwp_ih_0_31 wp_ih_0_31 0 0.3337280315506075
Vwn_ih_0_31 wn_ih_0_31 0 0.6662719684493925
Vwp_ih_1_31 wp_ih_1_31 0 0.3
Vwn_ih_1_31 wn_ih_1_31 0 0.7707993406062472
Vwp_ih_2_31 wp_ih_2_31 0 0.3
Vwn_ih_2_31 wn_ih_2_31 0 0.899
Vwp_ih_0_32 wp_ih_0_32 0 0.5010558083845404
Vwn_ih_0_32 wn_ih_0_32 0 0.4989441916154596
Vwp_ih_1_32 wp_ih_1_32 0 0.5009177104567756
Vwn_ih_1_32 wn_ih_1_32 0 0.4990822895432244
Vwp_ih_2_32 wp_ih_2_32 0 0.8966589957989723
Vwn_ih_2_32 wn_ih_2_32 0 0.3
Vwp_ih_0_33 wp_ih_0_33 0 0.5782300242360856
Vwn_ih_0_33 wn_ih_0_33 0 0.42176997576391434
Vwp_ih_1_33 wp_ih_1_33 0 0.34934027628833425
Vwn_ih_1_33 wn_ih_1_33 0 0.6506597237116658
Vwp_ih_2_33 wp_ih_2_33 0 0.899
Vwn_ih_2_33 wn_ih_2_33 0 0.3
Vwp_ih_0_34 wp_ih_0_34 0 0.899
Vwn_ih_0_34 wn_ih_0_34 0 0.3
Vwp_ih_1_34 wp_ih_1_34 0 0.3877944627424947
Vwn_ih_1_34 wn_ih_1_34 0 0.6122055372575054
Vwp_ih_2_34 wp_ih_2_34 0 0.3
Vwn_ih_2_34 wn_ih_2_34 0 0.7019441909845079
Vwp_ih_0_35 wp_ih_0_35 0 0.33958519084841565
Vwn_ih_0_35 wn_ih_0_35 0 0.6604148091515843
Vwp_ih_1_35 wp_ih_1_35 0 0.5512470391772055
Vwn_ih_1_35 wn_ih_1_35 0 0.44875296082279453
Vwp_ih_2_35 wp_ih_2_35 0 0.899
Vwn_ih_2_35 wn_ih_2_35 0 0.3
Vwp_ih_0_36 wp_ih_0_36 0 0.33572503636892814
Vwn_ih_0_36 wn_ih_0_36 0 0.6642749636310719
Vwp_ih_1_36 wp_ih_1_36 0 0.46903898888387613
Vwn_ih_1_36 wn_ih_1_36 0 0.5309610111161238
Vwp_ih_2_36 wp_ih_2_36 0 0.899
Vwn_ih_2_36 wn_ih_2_36 0 0.3
Vwp_ih_0_37 wp_ih_0_37 0 0.5319716438999489
Vwn_ih_0_37 wn_ih_0_37 0 0.46802835610005117
Vwp_ih_1_37 wp_ih_1_37 0 0.48000110818846575
Vwn_ih_1_37 wn_ih_1_37 0 0.5199988918115342
Vwp_ih_2_37 wp_ih_2_37 0 0.5566929249475032
Vwn_ih_2_37 wn_ih_2_37 0 0.4433070750524968
Vwp_ih_0_38 wp_ih_0_38 0 0.3
Vwn_ih_0_38 wn_ih_0_38 0 0.8969166945846772
Vwp_ih_1_38 wp_ih_1_38 0 0.5552460149956534
Vwn_ih_1_38 wn_ih_1_38 0 0.4447539850043466
Vwp_ih_2_38 wp_ih_2_38 0 0.3
Vwn_ih_2_38 wn_ih_2_38 0 0.7350214092942701
Vwp_ih_0_39 wp_ih_0_39 0 0.3
Vwn_ih_0_39 wn_ih_0_39 0 0.899
Vwp_ih_1_39 wp_ih_1_39 0 0.3348218837933773
Vwn_ih_1_39 wn_ih_1_39 0 0.6651781162066227
Vwp_ih_2_39 wp_ih_2_39 0 0.3
Vwn_ih_2_39 wn_ih_2_39 0 0.8006598796977715
Vwp_ih_0_40 wp_ih_0_40 0 0.7406107718399038
Vwn_ih_0_40 wn_ih_0_40 0 0.3
Vwp_ih_1_40 wp_ih_1_40 0 0.3
Vwn_ih_1_40 wn_ih_1_40 0 0.8971544078393597
Vwp_ih_2_40 wp_ih_2_40 0 0.8030204497447326
Vwn_ih_2_40 wn_ih_2_40 0 0.3
Vwp_ih_0_41 wp_ih_0_41 0 0.500866562634168
Vwn_ih_0_41 wn_ih_0_41 0 0.499133437365832
Vwp_ih_1_41 wp_ih_1_41 0 0.5018745123818988
Vwn_ih_1_41 wn_ih_1_41 0 0.49812548761810116
Vwp_ih_2_41 wp_ih_2_41 0 0.8968197834649914
Vwn_ih_2_41 wn_ih_2_41 0 0.3
Vwp_ih_0_42 wp_ih_0_42 0 0.39532615637707974
Vwn_ih_0_42 wn_ih_0_42 0 0.6046738436229202
Vwp_ih_1_42 wp_ih_1_42 0 0.5211915063803941
Vwn_ih_1_42 wn_ih_1_42 0 0.47880849361960587
Vwp_ih_2_42 wp_ih_2_42 0 0.31718218235720486
Vwn_ih_2_42 wn_ih_2_42 0 0.6828178176427951
Vwp_ih_0_43 wp_ih_0_43 0 0.46572787208912647
Vwn_ih_0_43 wn_ih_0_43 0 0.5342721279108735
Vwp_ih_1_43 wp_ih_1_43 0 0.583749834353456
Vwn_ih_1_43 wn_ih_1_43 0 0.4162501656465441
Vwp_ih_2_43 wp_ih_2_43 0 0.3819718381606587
Vwn_ih_2_43 wn_ih_2_43 0 0.6180281618393413
Vwp_ih_0_44 wp_ih_0_44 0 0.6287553311212086
Vwn_ih_0_44 wn_ih_0_44 0 0.3712446688787914
Vwp_ih_1_44 wp_ih_1_44 0 0.6256199900738724
Vwn_ih_1_44 wn_ih_1_44 0 0.3743800099261276
Vwp_ih_2_44 wp_ih_2_44 0 0.899
Vwn_ih_2_44 wn_ih_2_44 0 0.3
Vwp_ih_0_45 wp_ih_0_45 0 0.7473414345671073
Vwn_ih_0_45 wn_ih_0_45 0 0.3
Vwp_ih_1_45 wp_ih_1_45 0 0.3
Vwn_ih_1_45 wn_ih_1_45 0 0.7375436484690924
Vwp_ih_2_45 wp_ih_2_45 0 0.3
Vwn_ih_2_45 wn_ih_2_45 0 0.8985235708462803
Vwp_ih_0_46 wp_ih_0_46 0 0.8219075547530383
Vwn_ih_0_46 wn_ih_0_46 0 0.3
Vwp_ih_1_46 wp_ih_1_46 0 0.4417047710077049
Vwn_ih_1_46 wn_ih_1_46 0 0.5582952289922951
Vwp_ih_2_46 wp_ih_2_46 0 0.899
Vwn_ih_2_46 wn_ih_2_46 0 0.3
Vwp_ih_0_47 wp_ih_0_47 0 0.671947169290497
Vwn_ih_0_47 wn_ih_0_47 0 0.328052830709503
Vwp_ih_1_47 wp_ih_1_47 0 0.5386044299132783
Vwn_ih_1_47 wn_ih_1_47 0 0.4613955700867218
Vwp_ih_2_47 wp_ih_2_47 0 0.899
Vwn_ih_2_47 wn_ih_2_47 0 0.3
Vwp_ho_0_0 wp_ho_0_0 0 0.3481528122488118
Vwn_ho_0_0 wn_ho_0_0 0 0.6518471877511882
Vwp_ho_1_0 wp_ho_1_0 0 0.3
Vwn_ho_1_0 wn_ho_1_0 0 0.7387979725370883
Vwp_ho_2_0 wp_ho_2_0 0 0.5242555761888072
Vwn_ho_2_0 wn_ho_2_0 0 0.4757444238111928
Vwp_ho_3_0 wp_ho_3_0 0 0.5381723952719973
Vwn_ho_3_0 wn_ho_3_0 0 0.46182760472800266
Vwp_ho_4_0 wp_ho_4_0 0 0.37822545025604526
Vwn_ho_4_0 wn_ho_4_0 0 0.6217745497439547
Vwp_ho_5_0 wp_ho_5_0 0 0.5932881166520192
Vwn_ho_5_0 wn_ho_5_0 0 0.4067118833479808
Vwp_ho_6_0 wp_ho_6_0 0 0.3
Vwn_ho_6_0 wn_ho_6_0 0 0.729569546558718
Vwp_ho_7_0 wp_ho_7_0 0 0.4289104404448932
Vwn_ho_7_0 wn_ho_7_0 0 0.5710895595551069
Vwp_ho_8_0 wp_ho_8_0 0 0.668193829872327
Vwn_ho_8_0 wn_ho_8_0 0 0.331806170127673
Vwp_ho_9_0 wp_ho_9_0 0 0.5433496539523593
Vwn_ho_9_0 wn_ho_9_0 0 0.45665034604764065
Vwp_ho_10_0 wp_ho_10_0 0 0.34036320429276967
Vwn_ho_10_0 wn_ho_10_0 0 0.6596367957072303
Vwp_ho_11_0 wp_ho_11_0 0 0.42561255928637454
Vwn_ho_11_0 wn_ho_11_0 0 0.5743874407136255
Vwp_ho_12_0 wp_ho_12_0 0 0.5248254489469428
Vwn_ho_12_0 wn_ho_12_0 0 0.47517455105305717
Vwp_ho_13_0 wp_ho_13_0 0 0.693931154971182
Vwn_ho_13_0 wn_ho_13_0 0 0.30606884502881804
Vwp_ho_14_0 wp_ho_14_0 0 0.4548885715719899
Vwn_ho_14_0 wn_ho_14_0 0 0.5451114284280101
Vwp_ho_15_0 wp_ho_15_0 0 0.31881149584489676
Vwn_ho_15_0 wn_ho_15_0 0 0.6811885041551032
Vwp_ho_16_0 wp_ho_16_0 0 0.33865511820542593
Vwn_ho_16_0 wn_ho_16_0 0 0.6613448817945741
Vwp_ho_17_0 wp_ho_17_0 0 0.5697796010392632
Vwn_ho_17_0 wn_ho_17_0 0 0.4302203989607369
Vwp_ho_18_0 wp_ho_18_0 0 0.6426800599600373
Vwn_ho_18_0 wn_ho_18_0 0 0.35731994003996276
Vwp_ho_19_0 wp_ho_19_0 0 0.5735454563260817
Vwn_ho_19_0 wn_ho_19_0 0 0.42645454367391833
Vwp_ho_20_0 wp_ho_20_0 0 0.5697554304088142
Vwn_ho_20_0 wn_ho_20_0 0 0.4302445695911859
Vwp_ho_21_0 wp_ho_21_0 0 0.6454379445836725
Vwn_ho_21_0 wn_ho_21_0 0 0.35456205541632746
Vwp_ho_22_0 wp_ho_22_0 0 0.31144592944324356
Vwn_ho_22_0 wn_ho_22_0 0 0.6885540705567564
Vwp_ho_23_0 wp_ho_23_0 0 0.674871706914759
Vwn_ho_23_0 wn_ho_23_0 0 0.32512829308524105
Vwp_ho_24_0 wp_ho_24_0 0 0.5320710321943422
Vwn_ho_24_0 wn_ho_24_0 0 0.4679289678056579
Vwp_ho_25_0 wp_ho_25_0 0 0.5755045007480255
Vwn_ho_25_0 wn_ho_25_0 0 0.4244954992519745
Vwp_ho_26_0 wp_ho_26_0 0 0.4124999063306805
Vwn_ho_26_0 wn_ho_26_0 0 0.5875000936693195
Vwp_ho_27_0 wp_ho_27_0 0 0.5642814466654398
Vwn_ho_27_0 wn_ho_27_0 0 0.4357185533345603
Vwp_ho_28_0 wp_ho_28_0 0 0.5771258724715836
Vwn_ho_28_0 wn_ho_28_0 0 0.4228741275284163
Vwp_ho_29_0 wp_ho_29_0 0 0.4981136931091977
Vwn_ho_29_0 wn_ho_29_0 0 0.5018863068908023
Vwp_ho_30_0 wp_ho_30_0 0 0.4994513184333771
Vwn_ho_30_0 wn_ho_30_0 0 0.5005486815666229
Vwp_ho_31_0 wp_ho_31_0 0 0.5954396084335407
Vwn_ho_31_0 wn_ho_31_0 0 0.40456039156645923
Vwp_ho_32_0 wp_ho_32_0 0 0.4231618731171223
Vwn_ho_32_0 wn_ho_32_0 0 0.5768381268828777
Vwp_ho_33_0 wp_ho_33_0 0 0.4648626318309647
Vwn_ho_33_0 wn_ho_33_0 0 0.5351373681690353
Vwp_ho_34_0 wp_ho_34_0 0 0.3
Vwn_ho_34_0 wn_ho_34_0 0 0.7193888666116772
Vwp_ho_35_0 wp_ho_35_0 0 0.5069336034395422
Vwn_ho_35_0 wn_ho_35_0 0 0.4930663965604578
Vwp_ho_36_0 wp_ho_36_0 0 0.4898883024067352
Vwn_ho_36_0 wn_ho_36_0 0 0.5101116975932648
Vwp_ho_37_0 wp_ho_37_0 0 0.4781300457957133
Vwn_ho_37_0 wn_ho_37_0 0 0.5218699542042867
Vwp_ho_38_0 wp_ho_38_0 0 0.30550517177431835
Vwn_ho_38_0 wn_ho_38_0 0 0.6944948282256816
Vwp_ho_39_0 wp_ho_39_0 0 0.3822842889000352
Vwn_ho_39_0 wn_ho_39_0 0 0.6177157110999648
Vwp_ho_40_0 wp_ho_40_0 0 0.5954920604762218
Vwn_ho_40_0 wn_ho_40_0 0 0.40450793952377817
Vwp_ho_41_0 wp_ho_41_0 0 0.42898637805801754
Vwn_ho_41_0 wn_ho_41_0 0 0.5710136219419825
Vwp_ho_42_0 wp_ho_42_0 0 0.5173555144378827
Vwn_ho_42_0 wn_ho_42_0 0 0.48264448556211725
Vwp_ho_43_0 wp_ho_43_0 0 0.4939391788045371
Vwn_ho_43_0 wn_ho_43_0 0 0.5060608211954629
Vwp_ho_44_0 wp_ho_44_0 0 0.47073204490485804
Vwn_ho_44_0 wn_ho_44_0 0 0.5292679550951419
Vwp_ho_45_0 wp_ho_45_0 0 0.6052346482624039
Vwn_ho_45_0 wn_ho_45_0 0 0.39476535173759614
Vwp_ho_46_0 wp_ho_46_0 0 0.4574605980611892
Vwn_ho_46_0 wn_ho_46_0 0 0.5425394019388108
Vwp_ho_47_0 wp_ho_47_0 0 0.4504718584882256
Vwn_ho_47_0 wn_ho_47_0 0 0.5495281415117744
Vwp_ho_0_1 wp_ho_0_1 0 0.7536151196446179
Vwn_ho_0_1 wn_ho_0_1 0 0.3
Vwp_ho_1_1 wp_ho_1_1 0 0.757169579496592
Vwn_ho_1_1 wn_ho_1_1 0 0.3
Vwp_ho_2_1 wp_ho_2_1 0 0.46013340281440274
Vwn_ho_2_1 wn_ho_2_1 0 0.5398665971855973
Vwp_ho_3_1 wp_ho_3_1 0 0.5350920164862184
Vwn_ho_3_1 wn_ho_3_1 0 0.4649079835137816
Vwp_ho_4_1 wp_ho_4_1 0 0.5594213964072154
Vwn_ho_4_1 wn_ho_4_1 0 0.44057860359278456
Vwp_ho_5_1 wp_ho_5_1 0 0.3
Vwn_ho_5_1 wn_ho_5_1 0 0.8128058738445896
Vwp_ho_6_1 wp_ho_6_1 0 0.7770484602415674
Vwn_ho_6_1 wn_ho_6_1 0 0.3
Vwp_ho_7_1 wp_ho_7_1 0 0.6452327643976732
Vwn_ho_7_1 wn_ho_7_1 0 0.3547672356023268
Vwp_ho_8_1 wp_ho_8_1 0 0.3
Vwn_ho_8_1 wn_ho_8_1 0 0.7552450601116187
Vwp_ho_9_1 wp_ho_9_1 0 0.5248527839831836
Vwn_ho_9_1 wn_ho_9_1 0 0.4751472160168165
Vwp_ho_10_1 wp_ho_10_1 0 0.6403202469342724
Vwn_ho_10_1 wn_ho_10_1 0 0.35967975306572764
Vwp_ho_11_1 wp_ho_11_1 0 0.6223889611309746
Vwn_ho_11_1 wn_ho_11_1 0 0.3776110388690253
Vwp_ho_12_1 wp_ho_12_1 0 0.3
Vwn_ho_12_1 wn_ho_12_1 0 0.784883383256979
Vwp_ho_13_1 wp_ho_13_1 0 0.3
Vwn_ho_13_1 wn_ho_13_1 0 0.7953734473511479
Vwp_ho_14_1 wp_ho_14_1 0 0.6577890186043407
Vwn_ho_14_1 wn_ho_14_1 0 0.34221098139565936
Vwp_ho_15_1 wp_ho_15_1 0 0.7363056303000228
Vwn_ho_15_1 wn_ho_15_1 0 0.3
Vwp_ho_16_1 wp_ho_16_1 0 0.8831576697846846
Vwn_ho_16_1 wn_ho_16_1 0 0.3
Vwp_ho_17_1 wp_ho_17_1 0 0.3663773828297642
Vwn_ho_17_1 wn_ho_17_1 0 0.6336226171702358
Vwp_ho_18_1 wp_ho_18_1 0 0.3
Vwn_ho_18_1 wn_ho_18_1 0 0.7170055107327957
Vwp_ho_19_1 wp_ho_19_1 0 0.4211091579781822
Vwn_ho_19_1 wn_ho_19_1 0 0.5788908420218178
Vwp_ho_20_1 wp_ho_20_1 0 0.3
Vwn_ho_20_1 wn_ho_20_1 0 0.8007595970627337
Vwp_ho_21_1 wp_ho_21_1 0 0.3
Vwn_ho_21_1 wn_ho_21_1 0 0.851156062799306
Vwp_ho_22_1 wp_ho_22_1 0 0.7350358142324233
Vwn_ho_22_1 wn_ho_22_1 0 0.3
Vwp_ho_23_1 wp_ho_23_1 0 0.3
Vwn_ho_23_1 wn_ho_23_1 0 0.810350365885433
Vwp_ho_24_1 wp_ho_24_1 0 0.7590922434355274
Vwn_ho_24_1 wn_ho_24_1 0 0.3
Vwp_ho_25_1 wp_ho_25_1 0 0.4703863941723202
Vwn_ho_25_1 wn_ho_25_1 0 0.5296136058276798
Vwp_ho_26_1 wp_ho_26_1 0 0.783057049772069
Vwn_ho_26_1 wn_ho_26_1 0 0.3
Vwp_ho_27_1 wp_ho_27_1 0 0.35872546166966135
Vwn_ho_27_1 wn_ho_27_1 0 0.6412745383303387
Vwp_ho_28_1 wp_ho_28_1 0 0.3
Vwn_ho_28_1 wn_ho_28_1 0 0.8192296950556257
Vwp_ho_29_1 wp_ho_29_1 0 0.4941391101087672
Vwn_ho_29_1 wn_ho_29_1 0 0.5058608898912328
Vwp_ho_30_1 wp_ho_30_1 0 0.4996210378645448
Vwn_ho_30_1 wn_ho_30_1 0 0.5003789621354552
Vwp_ho_31_1 wp_ho_31_1 0 0.3
Vwn_ho_31_1 wn_ho_31_1 0 0.8125129266366693
Vwp_ho_32_1 wp_ho_32_1 0 0.3
Vwn_ho_32_1 wn_ho_32_1 0 0.7191687512647018
Vwp_ho_33_1 wp_ho_33_1 0 0.5277795091533728
Vwn_ho_33_1 wn_ho_33_1 0 0.47222049084662726
Vwp_ho_34_1 wp_ho_34_1 0 0.7939344109975275
Vwn_ho_34_1 wn_ho_34_1 0 0.3
Vwp_ho_35_1 wp_ho_35_1 0 0.5187530858871513
Vwn_ho_35_1 wn_ho_35_1 0 0.48124691411284864
Vwp_ho_36_1 wp_ho_36_1 0 0.5540684110376679
Vwn_ho_36_1 wn_ho_36_1 0 0.44593158896233215
Vwp_ho_37_1 wp_ho_37_1 0 0.5218047090888779
Vwn_ho_37_1 wn_ho_37_1 0 0.4781952909111222
Vwp_ho_38_1 wp_ho_38_1 0 0.7509121252506005
Vwn_ho_38_1 wn_ho_38_1 0 0.3
Vwp_ho_39_1 wp_ho_39_1 0 0.6513585619879936
Vwn_ho_39_1 wn_ho_39_1 0 0.3486414380120064
Vwp_ho_40_1 wp_ho_40_1 0 0.33816377024131095
Vwn_ho_40_1 wn_ho_40_1 0 0.661836229758689
Vwp_ho_41_1 wp_ho_41_1 0 0.3
Vwn_ho_41_1 wn_ho_41_1 0 0.715517459089573
Vwp_ho_42_1 wp_ho_42_1 0 0.45742827538298075
Vwn_ho_42_1 wn_ho_42_1 0 0.5425717246170193
Vwp_ho_43_1 wp_ho_43_1 0 0.47245631591646275
Vwn_ho_43_1 wn_ho_43_1 0 0.5275436840835372
Vwp_ho_44_1 wp_ho_44_1 0 0.6528171465588879
Vwn_ho_44_1 wn_ho_44_1 0 0.3471828534411121
Vwp_ho_45_1 wp_ho_45_1 0 0.3
Vwn_ho_45_1 wn_ho_45_1 0 0.86315263460686
Vwp_ho_46_1 wp_ho_46_1 0 0.734642582941184
Vwn_ho_46_1 wn_ho_46_1 0 0.3
Vwp_ho_47_1 wp_ho_47_1 0 0.5822241487937813
Vwn_ho_47_1 wn_ho_47_1 0 0.4177758512062188
Vwp_ho_0_2 wp_ho_0_2 0 0.48931946046436625
Vwn_ho_0_2 wn_ho_0_2 0 0.5106805395356337
Vwp_ho_1_2 wp_ho_1_2 0 0.6434394477984107
Vwn_ho_1_2 wn_ho_1_2 0 0.35656055220158933
Vwp_ho_2_2 wp_ho_2_2 0 0.3
Vwn_ho_2_2 wn_ho_2_2 0 0.7606107988511466
Vwp_ho_3_2 wp_ho_3_2 0 0.3
Vwn_ho_3_2 wn_ho_3_2 0 0.7126946397311729
Vwp_ho_4_2 wp_ho_4_2 0 0.6724072827908445
Vwn_ho_4_2 wn_ho_4_2 0 0.32759271720915545
Vwp_ho_5_2 wp_ho_5_2 0 0.5522389676989143
Vwn_ho_5_2 wn_ho_5_2 0 0.44776103230108566
Vwp_ho_6_2 wp_ho_6_2 0 0.5451371038850389
Vwn_ho_6_2 wn_ho_6_2 0 0.4548628961149611
Vwp_ho_7_2 wp_ho_7_2 0 0.48974339708013764
Vwn_ho_7_2 wn_ho_7_2 0 0.5102566029198624
Vwp_ho_8_2 wp_ho_8_2 0 0.4970227024412446
Vwn_ho_8_2 wn_ho_8_2 0 0.5029772975587554
Vwp_ho_9_2 wp_ho_9_2 0 0.33883949239525063
Vwn_ho_9_2 wn_ho_9_2 0 0.6611605076047493
Vwp_ho_10_2 wp_ho_10_2 0 0.7165343554888071
Vwn_ho_10_2 wn_ho_10_2 0 0.3
Vwp_ho_11_2 wp_ho_11_2 0 0.6786093947147873
Vwn_ho_11_2 wn_ho_11_2 0 0.3213906052852127
Vwp_ho_12_2 wp_ho_12_2 0 0.3
Vwn_ho_12_2 wn_ho_12_2 0 0.7173881468957939
Vwp_ho_13_2 wp_ho_13_2 0 0.486820625554862
Vwn_ho_13_2 wn_ho_13_2 0 0.513179374445138
Vwp_ho_14_2 wp_ho_14_2 0 0.6844239229415967
Vwn_ho_14_2 wn_ho_14_2 0 0.3155760770584033
Vwp_ho_15_2 wp_ho_15_2 0 0.5403347409787471
Vwn_ho_15_2 wn_ho_15_2 0 0.4596652590212528
Vwp_ho_16_2 wp_ho_16_2 0 0.4053090065385089
Vwn_ho_16_2 wn_ho_16_2 0 0.5946909934614911
Vwp_ho_17_2 wp_ho_17_2 0 0.32857613412098596
Vwn_ho_17_2 wn_ho_17_2 0 0.671423865879014
Vwp_ho_18_2 wp_ho_18_2 0 0.4737863422451896
Vwn_ho_18_2 wn_ho_18_2 0 0.5262136577548103
Vwp_ho_19_2 wp_ho_19_2 0 0.3737240530847161
Vwn_ho_19_2 wn_ho_19_2 0 0.6262759469152839
Vwp_ho_20_2 wp_ho_20_2 0 0.728771765073443
Vwn_ho_20_2 wn_ho_20_2 0 0.3
Vwp_ho_21_2 wp_ho_21_2 0 0.5826139439329222
Vwn_ho_21_2 wn_ho_21_2 0 0.4173860560670778
Vwp_ho_22_2 wp_ho_22_2 0 0.49466625124289043
Vwn_ho_22_2 wn_ho_22_2 0 0.5053337487571096
Vwp_ho_23_2 wp_ho_23_2 0 0.5674196910699989
Vwn_ho_23_2 wn_ho_23_2 0 0.4325803089300011
Vwp_ho_24_2 wp_ho_24_2 0 0.6975289384751747
Vwn_ho_24_2 wn_ho_24_2 0 0.3024710615248253
Vwp_ho_25_2 wp_ho_25_2 0 0.3
Vwn_ho_25_2 wn_ho_25_2 0 0.7834045460705266
Vwp_ho_26_2 wp_ho_26_2 0 0.41569704423269227
Vwn_ho_26_2 wn_ho_26_2 0 0.5843029557673077
Vwp_ho_27_2 wp_ho_27_2 0 0.3
Vwn_ho_27_2 wn_ho_27_2 0 0.7351247397441417
Vwp_ho_28_2 wp_ho_28_2 0 0.6943806000821814
Vwn_ho_28_2 wn_ho_28_2 0 0.3056193999178186
Vwp_ho_29_2 wp_ho_29_2 0 0.5003441357051212
Vwn_ho_29_2 wn_ho_29_2 0 0.4996558642948788
Vwp_ho_30_2 wp_ho_30_2 0 0.49955221940721306
Vwn_ho_30_2 wn_ho_30_2 0 0.5004477805927869
Vwp_ho_31_2 wp_ho_31_2 0 0.5999948780999811
Vwn_ho_31_2 wn_ho_31_2 0 0.4000051219000189
Vwp_ho_32_2 wp_ho_32_2 0 0.33817071747312777
Vwn_ho_32_2 wn_ho_32_2 0 0.6618292825268722
Vwp_ho_33_2 wp_ho_33_2 0 0.7206543655855477
Vwn_ho_33_2 wn_ho_33_2 0 0.3
Vwp_ho_34_2 wp_ho_34_2 0 0.46544501218052714
Vwn_ho_34_2 wn_ho_34_2 0 0.5345549878194729
Vwp_ho_35_2 wp_ho_35_2 0 0.63480086128638
Vwn_ho_35_2 wn_ho_35_2 0 0.36519913871362
Vwp_ho_36_2 wp_ho_36_2 0 0.6464540307757425
Vwn_ho_36_2 wn_ho_36_2 0 0.3535459692242575
Vwp_ho_37_2 wp_ho_37_2 0 0.5139135700394784
Vwn_ho_37_2 wn_ho_37_2 0 0.4860864299605216
Vwp_ho_38_2 wp_ho_38_2 0 0.4734991286706822
Vwn_ho_38_2 wn_ho_38_2 0 0.5265008713293178
Vwp_ho_39_2 wp_ho_39_2 0 0.4972600872025996
Vwn_ho_39_2 wn_ho_39_2 0 0.5027399127974004
Vwp_ho_40_2 wp_ho_40_2 0 0.5676780001905857
Vwn_ho_40_2 wn_ho_40_2 0 0.4323219998094143
Vwp_ho_41_2 wp_ho_41_2 0 0.30522552093726024
Vwn_ho_41_2 wn_ho_41_2 0 0.6947744790627397
Vwp_ho_42_2 wp_ho_42_2 0 0.4396096300750234
Vwn_ho_42_2 wn_ho_42_2 0 0.5603903699249766
Vwp_ho_43_2 wp_ho_43_2 0 0.47292657252625153
Vwn_ho_43_2 wn_ho_43_2 0 0.5270734274737484
Vwp_ho_44_2 wp_ho_44_2 0 0.6652904754330128
Vwn_ho_44_2 wn_ho_44_2 0 0.3347095245669872
Vwp_ho_45_2 wp_ho_45_2 0 0.7315556366085829
Vwn_ho_45_2 wn_ho_45_2 0 0.3
Vwp_ho_46_2 wp_ho_46_2 0 0.3226663948242412
Vwn_ho_46_2 wn_ho_46_2 0 0.6773336051757588
Vwp_ho_47_2 wp_ho_47_2 0 0.7294302775298636
Vwn_ho_47_2 wn_ho_47_2 0 0.3
Vwp_ho_0_3 wp_ho_0_3 0 0.4371979879698318
Vwn_ho_0_3 wn_ho_0_3 0 0.5628020120301682
Vwp_ho_1_3 wp_ho_1_3 0 0.3363328134708904
Vwn_ho_1_3 wn_ho_1_3 0 0.6636671865291096
Vwp_ho_2_3 wp_ho_2_3 0 0.7735747950845581
Vwn_ho_2_3 wn_ho_2_3 0 0.3
Vwp_ho_3_3 wp_ho_3_3 0 0.6149941440493786
Vwn_ho_3_3 wn_ho_3_3 0 0.3850058559506214
Vwp_ho_4_3 wp_ho_4_3 0 0.32397557184562786
Vwn_ho_4_3 wn_ho_4_3 0 0.6760244281543721
Vwp_ho_5_3 wp_ho_5_3 0 0.5898642461447571
Vwn_ho_5_3 wn_ho_5_3 0 0.4101357538552429
Vwp_ho_6_3 wp_ho_6_3 0 0.39948114937600265
Vwn_ho_6_3 wn_ho_6_3 0 0.6005188506239973
Vwp_ho_7_3 wp_ho_7_3 0 0.4635883928335927
Vwn_ho_7_3 wn_ho_7_3 0 0.5364116071664073
Vwp_ho_8_3 wp_ho_8_3 0 0.5588700811629612
Vwn_ho_8_3 wn_ho_8_3 0 0.4411299188370387
Vwp_ho_9_3 wp_ho_9_3 0 0.6444290868152285
Vwn_ho_9_3 wn_ho_9_3 0 0.3555709131847715
Vwp_ho_10_3 wp_ho_10_3 0 0.3
Vwn_ho_10_3 wn_ho_10_3 0 0.7640533998393382
Vwp_ho_11_3 wp_ho_11_3 0 0.3733834631356735
Vwn_ho_11_3 wn_ho_11_3 0 0.6266165368643265
Vwp_ho_12_3 wp_ho_12_3 0 0.8737593953344749
Vwn_ho_12_3 wn_ho_12_3 0 0.3
Vwp_ho_13_3 wp_ho_13_3 0 0.6031312921978529
Vwn_ho_13_3 wn_ho_13_3 0 0.3968687078021471
Vwp_ho_14_3 wp_ho_14_3 0 0.3
Vwn_ho_14_3 wn_ho_14_3 0 0.7376721585403007
Vwp_ho_15_3 wp_ho_15_3 0 0.4118368459762082
Vwn_ho_15_3 wn_ho_15_3 0 0.5881631540237918
Vwp_ho_16_3 wp_ho_16_3 0 0.38063625861964656
Vwn_ho_16_3 wn_ho_16_3 0 0.6193637413803534
Vwp_ho_17_3 wp_ho_17_3 0 0.7308208460509376
Vwn_ho_17_3 wn_ho_17_3 0 0.3
Vwp_ho_18_3 wp_ho_18_3 0 0.5757258746227669
Vwn_ho_18_3 wn_ho_18_3 0 0.4242741253772331
Vwp_ho_19_3 wp_ho_19_3 0 0.7026697342722465
Vwn_ho_19_3 wn_ho_19_3 0 0.3
Vwp_ho_20_3 wp_ho_20_3 0 0.4566205830884154
Vwn_ho_20_3 wn_ho_20_3 0 0.5433794169115845
Vwp_ho_21_3 wp_ho_21_3 0 0.5976677015940502
Vwn_ho_21_3 wn_ho_21_3 0 0.4023322984059498
Vwp_ho_22_3 wp_ho_22_3 0 0.41264750987879817
Vwn_ho_22_3 wn_ho_22_3 0 0.5873524901212018
Vwp_ho_23_3 wp_ho_23_3 0 0.5428787597909107
Vwn_ho_23_3 wn_ho_23_3 0 0.45712124020908923
Vwp_ho_24_3 wp_ho_24_3 0 0.3
Vwn_ho_24_3 wn_ho_24_3 0 0.833707543314385
Vwp_ho_25_3 wp_ho_25_3 0 0.8265054039826574
Vwn_ho_25_3 wn_ho_25_3 0 0.3
Vwp_ho_26_3 wp_ho_26_3 0 0.41820006932789777
Vwn_ho_26_3 wn_ho_26_3 0 0.5817999306721022
Vwp_ho_27_3 wp_ho_27_3 0 0.8757628368798613
Vwn_ho_27_3 wn_ho_27_3 0 0.3
Vwp_ho_28_3 wp_ho_28_3 0 0.5082612858613255
Vwn_ho_28_3 wn_ho_28_3 0 0.4917387141386746
Vwp_ho_29_3 wp_ho_29_3 0 0.4992604983280464
Vwn_ho_29_3 wn_ho_29_3 0 0.5007395016719536
Vwp_ho_30_3 wp_ho_30_3 0 0.4994298935854246
Vwn_ho_30_3 wn_ho_30_3 0 0.5005701064145754
Vwp_ho_31_3 wp_ho_31_3 0 0.5885438428230553
Vwn_ho_31_3 wn_ho_31_3 0 0.4114561571769447
Vwp_ho_32_3 wp_ho_32_3 0 0.796877583155708
Vwn_ho_32_3 wn_ho_32_3 0 0.3
Vwp_ho_33_3 wp_ho_33_3 0 0.31024244615215435
Vwn_ho_33_3 wn_ho_33_3 0 0.6897575538478457
Vwp_ho_34_3 wp_ho_34_3 0 0.45943401758261
Vwn_ho_34_3 wn_ho_34_3 0 0.54056598241739
Vwp_ho_35_3 wp_ho_35_3 0 0.35453936288915183
Vwn_ho_35_3 wn_ho_35_3 0 0.6454606371108482
Vwp_ho_36_3 wp_ho_36_3 0 0.3652846061775449
Vwn_ho_36_3 wn_ho_36_3 0 0.6347153938224551
Vwp_ho_37_3 wp_ho_37_3 0 0.47274032788825887
Vwn_ho_37_3 wn_ho_37_3 0 0.5272596721117412
Vwp_ho_38_3 wp_ho_38_3 0 0.4386854498314528
Vwn_ho_38_3 wn_ho_38_3 0 0.5613145501685473
Vwp_ho_39_3 wp_ho_39_3 0 0.47170516926242895
Vwn_ho_39_3 wn_ho_39_3 0 0.528294830737571
Vwp_ho_40_3 wp_ho_40_3 0 0.5304565032518984
Vwn_ho_40_3 wn_ho_40_3 0 0.4695434967481016
Vwp_ho_41_3 wp_ho_41_3 0 0.878990710811351
Vwn_ho_41_3 wn_ho_41_3 0 0.3
Vwp_ho_42_3 wp_ho_42_3 0 0.5533320261174639
Vwn_ho_42_3 wn_ho_42_3 0 0.44666797388253615
Vwp_ho_43_3 wp_ho_43_3 0 0.5392612597314955
Vwn_ho_43_3 wn_ho_43_3 0 0.4607387402685045
Vwp_ho_44_3 wp_ho_44_3 0 0.3
Vwn_ho_44_3 wn_ho_44_3 0 0.7428210847797314
Vwp_ho_45_3 wp_ho_45_3 0 0.4722263938601286
Vwn_ho_45_3 wn_ho_45_3 0 0.5277736061398715
Vwp_ho_46_3 wp_ho_46_3 0 0.49067072994364386
Vwn_ho_46_3 wn_ho_46_3 0 0.5093292700563561
Vwp_ho_47_3 wp_ho_47_3 0 0.3
Vwn_ho_47_3 wn_ho_47_3 0 0.7590428905256883
Xcm_xh0 xhp0 xhn0 vdd cmld
Rnd_xh0 xhp0 xhn0 20k
Cxh0p xhp0 0 1e-13
Cxh0n xhn0 0 1e-13
Xihx_0_0 a_xp0 a_xn0 wp_ih_0_0 wn_ih_0_0 xhp0 xhn0 vdd vbsyn gsyn
Xihx_1_0 a_xp1 a_xn1 wp_ih_1_0 wn_ih_1_0 xhp0 xhn0 vdd vbsyn gsyn
Xihx_2_0 a_xp2 a_xn2 wp_ih_2_0 wn_ih_2_0 xhp0 xhn0 vdd vbsyn gsyn
Xn0 xhp0 xhn0 ahp0 ahn0 vdd vbneu dneuron
Xcm_xh1 xhp1 xhn1 vdd cmld
Rnd_xh1 xhp1 xhn1 20k
Cxh1p xhp1 0 1e-13
Cxh1n xhn1 0 1e-13
Xihx_0_1 a_xp0 a_xn0 wp_ih_0_1 wn_ih_0_1 xhp1 xhn1 vdd vbsyn gsyn
Xihx_1_1 a_xp1 a_xn1 wp_ih_1_1 wn_ih_1_1 xhp1 xhn1 vdd vbsyn gsyn
Xihx_2_1 a_xp2 a_xn2 wp_ih_2_1 wn_ih_2_1 xhp1 xhn1 vdd vbsyn gsyn
Xn1 xhp1 xhn1 ahp1 ahn1 vdd vbneu dneuron
Xcm_xh2 xhp2 xhn2 vdd cmld
Rnd_xh2 xhp2 xhn2 20k
Cxh2p xhp2 0 1e-13
Cxh2n xhn2 0 1e-13
Xihx_0_2 a_xp0 a_xn0 wp_ih_0_2 wn_ih_0_2 xhp2 xhn2 vdd vbsyn gsyn
Xihx_1_2 a_xp1 a_xn1 wp_ih_1_2 wn_ih_1_2 xhp2 xhn2 vdd vbsyn gsyn
Xihx_2_2 a_xp2 a_xn2 wp_ih_2_2 wn_ih_2_2 xhp2 xhn2 vdd vbsyn gsyn
Xn2 xhp2 xhn2 ahp2 ahn2 vdd vbneu dneuron
Xcm_xh3 xhp3 xhn3 vdd cmld
Rnd_xh3 xhp3 xhn3 20k
Cxh3p xhp3 0 1e-13
Cxh3n xhn3 0 1e-13
Xihx_0_3 a_xp0 a_xn0 wp_ih_0_3 wn_ih_0_3 xhp3 xhn3 vdd vbsyn gsyn
Xihx_1_3 a_xp1 a_xn1 wp_ih_1_3 wn_ih_1_3 xhp3 xhn3 vdd vbsyn gsyn
Xihx_2_3 a_xp2 a_xn2 wp_ih_2_3 wn_ih_2_3 xhp3 xhn3 vdd vbsyn gsyn
Xn3 xhp3 xhn3 ahp3 ahn3 vdd vbneu dneuron
Xcm_xh4 xhp4 xhn4 vdd cmld
Rnd_xh4 xhp4 xhn4 20k
Cxh4p xhp4 0 1e-13
Cxh4n xhn4 0 1e-13
Xihx_0_4 a_xp0 a_xn0 wp_ih_0_4 wn_ih_0_4 xhp4 xhn4 vdd vbsyn gsyn
Xihx_1_4 a_xp1 a_xn1 wp_ih_1_4 wn_ih_1_4 xhp4 xhn4 vdd vbsyn gsyn
Xihx_2_4 a_xp2 a_xn2 wp_ih_2_4 wn_ih_2_4 xhp4 xhn4 vdd vbsyn gsyn
Xn4 xhp4 xhn4 ahp4 ahn4 vdd vbneu dneuron
Xcm_xh5 xhp5 xhn5 vdd cmld
Rnd_xh5 xhp5 xhn5 20k
Cxh5p xhp5 0 1e-13
Cxh5n xhn5 0 1e-13
Xihx_0_5 a_xp0 a_xn0 wp_ih_0_5 wn_ih_0_5 xhp5 xhn5 vdd vbsyn gsyn
Xihx_1_5 a_xp1 a_xn1 wp_ih_1_5 wn_ih_1_5 xhp5 xhn5 vdd vbsyn gsyn
Xihx_2_5 a_xp2 a_xn2 wp_ih_2_5 wn_ih_2_5 xhp5 xhn5 vdd vbsyn gsyn
Xn5 xhp5 xhn5 ahp5 ahn5 vdd vbneu dneuron
Xcm_xh6 xhp6 xhn6 vdd cmld
Rnd_xh6 xhp6 xhn6 20k
Cxh6p xhp6 0 1e-13
Cxh6n xhn6 0 1e-13
Xihx_0_6 a_xp0 a_xn0 wp_ih_0_6 wn_ih_0_6 xhp6 xhn6 vdd vbsyn gsyn
Xihx_1_6 a_xp1 a_xn1 wp_ih_1_6 wn_ih_1_6 xhp6 xhn6 vdd vbsyn gsyn
Xihx_2_6 a_xp2 a_xn2 wp_ih_2_6 wn_ih_2_6 xhp6 xhn6 vdd vbsyn gsyn
Xn6 xhp6 xhn6 ahp6 ahn6 vdd vbneu dneuron
Xcm_xh7 xhp7 xhn7 vdd cmld
Rnd_xh7 xhp7 xhn7 20k
Cxh7p xhp7 0 1e-13
Cxh7n xhn7 0 1e-13
Xihx_0_7 a_xp0 a_xn0 wp_ih_0_7 wn_ih_0_7 xhp7 xhn7 vdd vbsyn gsyn
Xihx_1_7 a_xp1 a_xn1 wp_ih_1_7 wn_ih_1_7 xhp7 xhn7 vdd vbsyn gsyn
Xihx_2_7 a_xp2 a_xn2 wp_ih_2_7 wn_ih_2_7 xhp7 xhn7 vdd vbsyn gsyn
Xn7 xhp7 xhn7 ahp7 ahn7 vdd vbneu dneuron
Xcm_xh8 xhp8 xhn8 vdd cmld
Rnd_xh8 xhp8 xhn8 20k
Cxh8p xhp8 0 1e-13
Cxh8n xhn8 0 1e-13
Xihx_0_8 a_xp0 a_xn0 wp_ih_0_8 wn_ih_0_8 xhp8 xhn8 vdd vbsyn gsyn
Xihx_1_8 a_xp1 a_xn1 wp_ih_1_8 wn_ih_1_8 xhp8 xhn8 vdd vbsyn gsyn
Xihx_2_8 a_xp2 a_xn2 wp_ih_2_8 wn_ih_2_8 xhp8 xhn8 vdd vbsyn gsyn
Xn8 xhp8 xhn8 ahp8 ahn8 vdd vbneu dneuron
Xcm_xh9 xhp9 xhn9 vdd cmld
Rnd_xh9 xhp9 xhn9 20k
Cxh9p xhp9 0 1e-13
Cxh9n xhn9 0 1e-13
Xihx_0_9 a_xp0 a_xn0 wp_ih_0_9 wn_ih_0_9 xhp9 xhn9 vdd vbsyn gsyn
Xihx_1_9 a_xp1 a_xn1 wp_ih_1_9 wn_ih_1_9 xhp9 xhn9 vdd vbsyn gsyn
Xihx_2_9 a_xp2 a_xn2 wp_ih_2_9 wn_ih_2_9 xhp9 xhn9 vdd vbsyn gsyn
Xn9 xhp9 xhn9 ahp9 ahn9 vdd vbneu dneuron
Xcm_xh10 xhp10 xhn10 vdd cmld
Rnd_xh10 xhp10 xhn10 20k
Cxh10p xhp10 0 1e-13
Cxh10n xhn10 0 1e-13
Xihx_0_10 a_xp0 a_xn0 wp_ih_0_10 wn_ih_0_10 xhp10 xhn10 vdd vbsyn gsyn
Xihx_1_10 a_xp1 a_xn1 wp_ih_1_10 wn_ih_1_10 xhp10 xhn10 vdd vbsyn gsyn
Xihx_2_10 a_xp2 a_xn2 wp_ih_2_10 wn_ih_2_10 xhp10 xhn10 vdd vbsyn gsyn
Xn10 xhp10 xhn10 ahp10 ahn10 vdd vbneu dneuron
Xcm_xh11 xhp11 xhn11 vdd cmld
Rnd_xh11 xhp11 xhn11 20k
Cxh11p xhp11 0 1e-13
Cxh11n xhn11 0 1e-13
Xihx_0_11 a_xp0 a_xn0 wp_ih_0_11 wn_ih_0_11 xhp11 xhn11 vdd vbsyn gsyn
Xihx_1_11 a_xp1 a_xn1 wp_ih_1_11 wn_ih_1_11 xhp11 xhn11 vdd vbsyn gsyn
Xihx_2_11 a_xp2 a_xn2 wp_ih_2_11 wn_ih_2_11 xhp11 xhn11 vdd vbsyn gsyn
Xn11 xhp11 xhn11 ahp11 ahn11 vdd vbneu dneuron
Xcm_xh12 xhp12 xhn12 vdd cmld
Rnd_xh12 xhp12 xhn12 20k
Cxh12p xhp12 0 1e-13
Cxh12n xhn12 0 1e-13
Xihx_0_12 a_xp0 a_xn0 wp_ih_0_12 wn_ih_0_12 xhp12 xhn12 vdd vbsyn gsyn
Xihx_1_12 a_xp1 a_xn1 wp_ih_1_12 wn_ih_1_12 xhp12 xhn12 vdd vbsyn gsyn
Xihx_2_12 a_xp2 a_xn2 wp_ih_2_12 wn_ih_2_12 xhp12 xhn12 vdd vbsyn gsyn
Xn12 xhp12 xhn12 ahp12 ahn12 vdd vbneu dneuron
Xcm_xh13 xhp13 xhn13 vdd cmld
Rnd_xh13 xhp13 xhn13 20k
Cxh13p xhp13 0 1e-13
Cxh13n xhn13 0 1e-13
Xihx_0_13 a_xp0 a_xn0 wp_ih_0_13 wn_ih_0_13 xhp13 xhn13 vdd vbsyn gsyn
Xihx_1_13 a_xp1 a_xn1 wp_ih_1_13 wn_ih_1_13 xhp13 xhn13 vdd vbsyn gsyn
Xihx_2_13 a_xp2 a_xn2 wp_ih_2_13 wn_ih_2_13 xhp13 xhn13 vdd vbsyn gsyn
Xn13 xhp13 xhn13 ahp13 ahn13 vdd vbneu dneuron
Xcm_xh14 xhp14 xhn14 vdd cmld
Rnd_xh14 xhp14 xhn14 20k
Cxh14p xhp14 0 1e-13
Cxh14n xhn14 0 1e-13
Xihx_0_14 a_xp0 a_xn0 wp_ih_0_14 wn_ih_0_14 xhp14 xhn14 vdd vbsyn gsyn
Xihx_1_14 a_xp1 a_xn1 wp_ih_1_14 wn_ih_1_14 xhp14 xhn14 vdd vbsyn gsyn
Xihx_2_14 a_xp2 a_xn2 wp_ih_2_14 wn_ih_2_14 xhp14 xhn14 vdd vbsyn gsyn
Xn14 xhp14 xhn14 ahp14 ahn14 vdd vbneu dneuron
Xcm_xh15 xhp15 xhn15 vdd cmld
Rnd_xh15 xhp15 xhn15 20k
Cxh15p xhp15 0 1e-13
Cxh15n xhn15 0 1e-13
Xihx_0_15 a_xp0 a_xn0 wp_ih_0_15 wn_ih_0_15 xhp15 xhn15 vdd vbsyn gsyn
Xihx_1_15 a_xp1 a_xn1 wp_ih_1_15 wn_ih_1_15 xhp15 xhn15 vdd vbsyn gsyn
Xihx_2_15 a_xp2 a_xn2 wp_ih_2_15 wn_ih_2_15 xhp15 xhn15 vdd vbsyn gsyn
Xn15 xhp15 xhn15 ahp15 ahn15 vdd vbneu dneuron
Xcm_xh16 xhp16 xhn16 vdd cmld
Rnd_xh16 xhp16 xhn16 20k
Cxh16p xhp16 0 1e-13
Cxh16n xhn16 0 1e-13
Xihx_0_16 a_xp0 a_xn0 wp_ih_0_16 wn_ih_0_16 xhp16 xhn16 vdd vbsyn gsyn
Xihx_1_16 a_xp1 a_xn1 wp_ih_1_16 wn_ih_1_16 xhp16 xhn16 vdd vbsyn gsyn
Xihx_2_16 a_xp2 a_xn2 wp_ih_2_16 wn_ih_2_16 xhp16 xhn16 vdd vbsyn gsyn
Xn16 xhp16 xhn16 ahp16 ahn16 vdd vbneu dneuron
Xcm_xh17 xhp17 xhn17 vdd cmld
Rnd_xh17 xhp17 xhn17 20k
Cxh17p xhp17 0 1e-13
Cxh17n xhn17 0 1e-13
Xihx_0_17 a_xp0 a_xn0 wp_ih_0_17 wn_ih_0_17 xhp17 xhn17 vdd vbsyn gsyn
Xihx_1_17 a_xp1 a_xn1 wp_ih_1_17 wn_ih_1_17 xhp17 xhn17 vdd vbsyn gsyn
Xihx_2_17 a_xp2 a_xn2 wp_ih_2_17 wn_ih_2_17 xhp17 xhn17 vdd vbsyn gsyn
Xn17 xhp17 xhn17 ahp17 ahn17 vdd vbneu dneuron
Xcm_xh18 xhp18 xhn18 vdd cmld
Rnd_xh18 xhp18 xhn18 20k
Cxh18p xhp18 0 1e-13
Cxh18n xhn18 0 1e-13
Xihx_0_18 a_xp0 a_xn0 wp_ih_0_18 wn_ih_0_18 xhp18 xhn18 vdd vbsyn gsyn
Xihx_1_18 a_xp1 a_xn1 wp_ih_1_18 wn_ih_1_18 xhp18 xhn18 vdd vbsyn gsyn
Xihx_2_18 a_xp2 a_xn2 wp_ih_2_18 wn_ih_2_18 xhp18 xhn18 vdd vbsyn gsyn
Xn18 xhp18 xhn18 ahp18 ahn18 vdd vbneu dneuron
Xcm_xh19 xhp19 xhn19 vdd cmld
Rnd_xh19 xhp19 xhn19 20k
Cxh19p xhp19 0 1e-13
Cxh19n xhn19 0 1e-13
Xihx_0_19 a_xp0 a_xn0 wp_ih_0_19 wn_ih_0_19 xhp19 xhn19 vdd vbsyn gsyn
Xihx_1_19 a_xp1 a_xn1 wp_ih_1_19 wn_ih_1_19 xhp19 xhn19 vdd vbsyn gsyn
Xihx_2_19 a_xp2 a_xn2 wp_ih_2_19 wn_ih_2_19 xhp19 xhn19 vdd vbsyn gsyn
Xn19 xhp19 xhn19 ahp19 ahn19 vdd vbneu dneuron
Xcm_xh20 xhp20 xhn20 vdd cmld
Rnd_xh20 xhp20 xhn20 20k
Cxh20p xhp20 0 1e-13
Cxh20n xhn20 0 1e-13
Xihx_0_20 a_xp0 a_xn0 wp_ih_0_20 wn_ih_0_20 xhp20 xhn20 vdd vbsyn gsyn
Xihx_1_20 a_xp1 a_xn1 wp_ih_1_20 wn_ih_1_20 xhp20 xhn20 vdd vbsyn gsyn
Xihx_2_20 a_xp2 a_xn2 wp_ih_2_20 wn_ih_2_20 xhp20 xhn20 vdd vbsyn gsyn
Xn20 xhp20 xhn20 ahp20 ahn20 vdd vbneu dneuron
Xcm_xh21 xhp21 xhn21 vdd cmld
Rnd_xh21 xhp21 xhn21 20k
Cxh21p xhp21 0 1e-13
Cxh21n xhn21 0 1e-13
Xihx_0_21 a_xp0 a_xn0 wp_ih_0_21 wn_ih_0_21 xhp21 xhn21 vdd vbsyn gsyn
Xihx_1_21 a_xp1 a_xn1 wp_ih_1_21 wn_ih_1_21 xhp21 xhn21 vdd vbsyn gsyn
Xihx_2_21 a_xp2 a_xn2 wp_ih_2_21 wn_ih_2_21 xhp21 xhn21 vdd vbsyn gsyn
Xn21 xhp21 xhn21 ahp21 ahn21 vdd vbneu dneuron
Xcm_xh22 xhp22 xhn22 vdd cmld
Rnd_xh22 xhp22 xhn22 20k
Cxh22p xhp22 0 1e-13
Cxh22n xhn22 0 1e-13
Xihx_0_22 a_xp0 a_xn0 wp_ih_0_22 wn_ih_0_22 xhp22 xhn22 vdd vbsyn gsyn
Xihx_1_22 a_xp1 a_xn1 wp_ih_1_22 wn_ih_1_22 xhp22 xhn22 vdd vbsyn gsyn
Xihx_2_22 a_xp2 a_xn2 wp_ih_2_22 wn_ih_2_22 xhp22 xhn22 vdd vbsyn gsyn
Xn22 xhp22 xhn22 ahp22 ahn22 vdd vbneu dneuron
Xcm_xh23 xhp23 xhn23 vdd cmld
Rnd_xh23 xhp23 xhn23 20k
Cxh23p xhp23 0 1e-13
Cxh23n xhn23 0 1e-13
Xihx_0_23 a_xp0 a_xn0 wp_ih_0_23 wn_ih_0_23 xhp23 xhn23 vdd vbsyn gsyn
Xihx_1_23 a_xp1 a_xn1 wp_ih_1_23 wn_ih_1_23 xhp23 xhn23 vdd vbsyn gsyn
Xihx_2_23 a_xp2 a_xn2 wp_ih_2_23 wn_ih_2_23 xhp23 xhn23 vdd vbsyn gsyn
Xn23 xhp23 xhn23 ahp23 ahn23 vdd vbneu dneuron
Xcm_xh24 xhp24 xhn24 vdd cmld
Rnd_xh24 xhp24 xhn24 20k
Cxh24p xhp24 0 1e-13
Cxh24n xhn24 0 1e-13
Xihx_0_24 a_xp0 a_xn0 wp_ih_0_24 wn_ih_0_24 xhp24 xhn24 vdd vbsyn gsyn
Xihx_1_24 a_xp1 a_xn1 wp_ih_1_24 wn_ih_1_24 xhp24 xhn24 vdd vbsyn gsyn
Xihx_2_24 a_xp2 a_xn2 wp_ih_2_24 wn_ih_2_24 xhp24 xhn24 vdd vbsyn gsyn
Xn24 xhp24 xhn24 ahp24 ahn24 vdd vbneu dneuron
Xcm_xh25 xhp25 xhn25 vdd cmld
Rnd_xh25 xhp25 xhn25 20k
Cxh25p xhp25 0 1e-13
Cxh25n xhn25 0 1e-13
Xihx_0_25 a_xp0 a_xn0 wp_ih_0_25 wn_ih_0_25 xhp25 xhn25 vdd vbsyn gsyn
Xihx_1_25 a_xp1 a_xn1 wp_ih_1_25 wn_ih_1_25 xhp25 xhn25 vdd vbsyn gsyn
Xihx_2_25 a_xp2 a_xn2 wp_ih_2_25 wn_ih_2_25 xhp25 xhn25 vdd vbsyn gsyn
Xn25 xhp25 xhn25 ahp25 ahn25 vdd vbneu dneuron
Xcm_xh26 xhp26 xhn26 vdd cmld
Rnd_xh26 xhp26 xhn26 20k
Cxh26p xhp26 0 1e-13
Cxh26n xhn26 0 1e-13
Xihx_0_26 a_xp0 a_xn0 wp_ih_0_26 wn_ih_0_26 xhp26 xhn26 vdd vbsyn gsyn
Xihx_1_26 a_xp1 a_xn1 wp_ih_1_26 wn_ih_1_26 xhp26 xhn26 vdd vbsyn gsyn
Xihx_2_26 a_xp2 a_xn2 wp_ih_2_26 wn_ih_2_26 xhp26 xhn26 vdd vbsyn gsyn
Xn26 xhp26 xhn26 ahp26 ahn26 vdd vbneu dneuron
Xcm_xh27 xhp27 xhn27 vdd cmld
Rnd_xh27 xhp27 xhn27 20k
Cxh27p xhp27 0 1e-13
Cxh27n xhn27 0 1e-13
Xihx_0_27 a_xp0 a_xn0 wp_ih_0_27 wn_ih_0_27 xhp27 xhn27 vdd vbsyn gsyn
Xihx_1_27 a_xp1 a_xn1 wp_ih_1_27 wn_ih_1_27 xhp27 xhn27 vdd vbsyn gsyn
Xihx_2_27 a_xp2 a_xn2 wp_ih_2_27 wn_ih_2_27 xhp27 xhn27 vdd vbsyn gsyn
Xn27 xhp27 xhn27 ahp27 ahn27 vdd vbneu dneuron
Xcm_xh28 xhp28 xhn28 vdd cmld
Rnd_xh28 xhp28 xhn28 20k
Cxh28p xhp28 0 1e-13
Cxh28n xhn28 0 1e-13
Xihx_0_28 a_xp0 a_xn0 wp_ih_0_28 wn_ih_0_28 xhp28 xhn28 vdd vbsyn gsyn
Xihx_1_28 a_xp1 a_xn1 wp_ih_1_28 wn_ih_1_28 xhp28 xhn28 vdd vbsyn gsyn
Xihx_2_28 a_xp2 a_xn2 wp_ih_2_28 wn_ih_2_28 xhp28 xhn28 vdd vbsyn gsyn
Xn28 xhp28 xhn28 ahp28 ahn28 vdd vbneu dneuron
Xcm_xh29 xhp29 xhn29 vdd cmld
Rnd_xh29 xhp29 xhn29 20k
Cxh29p xhp29 0 1e-13
Cxh29n xhn29 0 1e-13
Xihx_0_29 a_xp0 a_xn0 wp_ih_0_29 wn_ih_0_29 xhp29 xhn29 vdd vbsyn gsyn
Xihx_1_29 a_xp1 a_xn1 wp_ih_1_29 wn_ih_1_29 xhp29 xhn29 vdd vbsyn gsyn
Xihx_2_29 a_xp2 a_xn2 wp_ih_2_29 wn_ih_2_29 xhp29 xhn29 vdd vbsyn gsyn
Xn29 xhp29 xhn29 ahp29 ahn29 vdd vbneu dneuron
Xcm_xh30 xhp30 xhn30 vdd cmld
Rnd_xh30 xhp30 xhn30 20k
Cxh30p xhp30 0 1e-13
Cxh30n xhn30 0 1e-13
Xihx_0_30 a_xp0 a_xn0 wp_ih_0_30 wn_ih_0_30 xhp30 xhn30 vdd vbsyn gsyn
Xihx_1_30 a_xp1 a_xn1 wp_ih_1_30 wn_ih_1_30 xhp30 xhn30 vdd vbsyn gsyn
Xihx_2_30 a_xp2 a_xn2 wp_ih_2_30 wn_ih_2_30 xhp30 xhn30 vdd vbsyn gsyn
Xn30 xhp30 xhn30 ahp30 ahn30 vdd vbneu dneuron
Xcm_xh31 xhp31 xhn31 vdd cmld
Rnd_xh31 xhp31 xhn31 20k
Cxh31p xhp31 0 1e-13
Cxh31n xhn31 0 1e-13
Xihx_0_31 a_xp0 a_xn0 wp_ih_0_31 wn_ih_0_31 xhp31 xhn31 vdd vbsyn gsyn
Xihx_1_31 a_xp1 a_xn1 wp_ih_1_31 wn_ih_1_31 xhp31 xhn31 vdd vbsyn gsyn
Xihx_2_31 a_xp2 a_xn2 wp_ih_2_31 wn_ih_2_31 xhp31 xhn31 vdd vbsyn gsyn
Xn31 xhp31 xhn31 ahp31 ahn31 vdd vbneu dneuron
Xcm_xh32 xhp32 xhn32 vdd cmld
Rnd_xh32 xhp32 xhn32 20k
Cxh32p xhp32 0 1e-13
Cxh32n xhn32 0 1e-13
Xihx_0_32 a_xp0 a_xn0 wp_ih_0_32 wn_ih_0_32 xhp32 xhn32 vdd vbsyn gsyn
Xihx_1_32 a_xp1 a_xn1 wp_ih_1_32 wn_ih_1_32 xhp32 xhn32 vdd vbsyn gsyn
Xihx_2_32 a_xp2 a_xn2 wp_ih_2_32 wn_ih_2_32 xhp32 xhn32 vdd vbsyn gsyn
Xn32 xhp32 xhn32 ahp32 ahn32 vdd vbneu dneuron
Xcm_xh33 xhp33 xhn33 vdd cmld
Rnd_xh33 xhp33 xhn33 20k
Cxh33p xhp33 0 1e-13
Cxh33n xhn33 0 1e-13
Xihx_0_33 a_xp0 a_xn0 wp_ih_0_33 wn_ih_0_33 xhp33 xhn33 vdd vbsyn gsyn
Xihx_1_33 a_xp1 a_xn1 wp_ih_1_33 wn_ih_1_33 xhp33 xhn33 vdd vbsyn gsyn
Xihx_2_33 a_xp2 a_xn2 wp_ih_2_33 wn_ih_2_33 xhp33 xhn33 vdd vbsyn gsyn
Xn33 xhp33 xhn33 ahp33 ahn33 vdd vbneu dneuron
Xcm_xh34 xhp34 xhn34 vdd cmld
Rnd_xh34 xhp34 xhn34 20k
Cxh34p xhp34 0 1e-13
Cxh34n xhn34 0 1e-13
Xihx_0_34 a_xp0 a_xn0 wp_ih_0_34 wn_ih_0_34 xhp34 xhn34 vdd vbsyn gsyn
Xihx_1_34 a_xp1 a_xn1 wp_ih_1_34 wn_ih_1_34 xhp34 xhn34 vdd vbsyn gsyn
Xihx_2_34 a_xp2 a_xn2 wp_ih_2_34 wn_ih_2_34 xhp34 xhn34 vdd vbsyn gsyn
Xn34 xhp34 xhn34 ahp34 ahn34 vdd vbneu dneuron
Xcm_xh35 xhp35 xhn35 vdd cmld
Rnd_xh35 xhp35 xhn35 20k
Cxh35p xhp35 0 1e-13
Cxh35n xhn35 0 1e-13
Xihx_0_35 a_xp0 a_xn0 wp_ih_0_35 wn_ih_0_35 xhp35 xhn35 vdd vbsyn gsyn
Xihx_1_35 a_xp1 a_xn1 wp_ih_1_35 wn_ih_1_35 xhp35 xhn35 vdd vbsyn gsyn
Xihx_2_35 a_xp2 a_xn2 wp_ih_2_35 wn_ih_2_35 xhp35 xhn35 vdd vbsyn gsyn
Xn35 xhp35 xhn35 ahp35 ahn35 vdd vbneu dneuron
Xcm_xh36 xhp36 xhn36 vdd cmld
Rnd_xh36 xhp36 xhn36 20k
Cxh36p xhp36 0 1e-13
Cxh36n xhn36 0 1e-13
Xihx_0_36 a_xp0 a_xn0 wp_ih_0_36 wn_ih_0_36 xhp36 xhn36 vdd vbsyn gsyn
Xihx_1_36 a_xp1 a_xn1 wp_ih_1_36 wn_ih_1_36 xhp36 xhn36 vdd vbsyn gsyn
Xihx_2_36 a_xp2 a_xn2 wp_ih_2_36 wn_ih_2_36 xhp36 xhn36 vdd vbsyn gsyn
Xn36 xhp36 xhn36 ahp36 ahn36 vdd vbneu dneuron
Xcm_xh37 xhp37 xhn37 vdd cmld
Rnd_xh37 xhp37 xhn37 20k
Cxh37p xhp37 0 1e-13
Cxh37n xhn37 0 1e-13
Xihx_0_37 a_xp0 a_xn0 wp_ih_0_37 wn_ih_0_37 xhp37 xhn37 vdd vbsyn gsyn
Xihx_1_37 a_xp1 a_xn1 wp_ih_1_37 wn_ih_1_37 xhp37 xhn37 vdd vbsyn gsyn
Xihx_2_37 a_xp2 a_xn2 wp_ih_2_37 wn_ih_2_37 xhp37 xhn37 vdd vbsyn gsyn
Xn37 xhp37 xhn37 ahp37 ahn37 vdd vbneu dneuron
Xcm_xh38 xhp38 xhn38 vdd cmld
Rnd_xh38 xhp38 xhn38 20k
Cxh38p xhp38 0 1e-13
Cxh38n xhn38 0 1e-13
Xihx_0_38 a_xp0 a_xn0 wp_ih_0_38 wn_ih_0_38 xhp38 xhn38 vdd vbsyn gsyn
Xihx_1_38 a_xp1 a_xn1 wp_ih_1_38 wn_ih_1_38 xhp38 xhn38 vdd vbsyn gsyn
Xihx_2_38 a_xp2 a_xn2 wp_ih_2_38 wn_ih_2_38 xhp38 xhn38 vdd vbsyn gsyn
Xn38 xhp38 xhn38 ahp38 ahn38 vdd vbneu dneuron
Xcm_xh39 xhp39 xhn39 vdd cmld
Rnd_xh39 xhp39 xhn39 20k
Cxh39p xhp39 0 1e-13
Cxh39n xhn39 0 1e-13
Xihx_0_39 a_xp0 a_xn0 wp_ih_0_39 wn_ih_0_39 xhp39 xhn39 vdd vbsyn gsyn
Xihx_1_39 a_xp1 a_xn1 wp_ih_1_39 wn_ih_1_39 xhp39 xhn39 vdd vbsyn gsyn
Xihx_2_39 a_xp2 a_xn2 wp_ih_2_39 wn_ih_2_39 xhp39 xhn39 vdd vbsyn gsyn
Xn39 xhp39 xhn39 ahp39 ahn39 vdd vbneu dneuron
Xcm_xh40 xhp40 xhn40 vdd cmld
Rnd_xh40 xhp40 xhn40 20k
Cxh40p xhp40 0 1e-13
Cxh40n xhn40 0 1e-13
Xihx_0_40 a_xp0 a_xn0 wp_ih_0_40 wn_ih_0_40 xhp40 xhn40 vdd vbsyn gsyn
Xihx_1_40 a_xp1 a_xn1 wp_ih_1_40 wn_ih_1_40 xhp40 xhn40 vdd vbsyn gsyn
Xihx_2_40 a_xp2 a_xn2 wp_ih_2_40 wn_ih_2_40 xhp40 xhn40 vdd vbsyn gsyn
Xn40 xhp40 xhn40 ahp40 ahn40 vdd vbneu dneuron
Xcm_xh41 xhp41 xhn41 vdd cmld
Rnd_xh41 xhp41 xhn41 20k
Cxh41p xhp41 0 1e-13
Cxh41n xhn41 0 1e-13
Xihx_0_41 a_xp0 a_xn0 wp_ih_0_41 wn_ih_0_41 xhp41 xhn41 vdd vbsyn gsyn
Xihx_1_41 a_xp1 a_xn1 wp_ih_1_41 wn_ih_1_41 xhp41 xhn41 vdd vbsyn gsyn
Xihx_2_41 a_xp2 a_xn2 wp_ih_2_41 wn_ih_2_41 xhp41 xhn41 vdd vbsyn gsyn
Xn41 xhp41 xhn41 ahp41 ahn41 vdd vbneu dneuron
Xcm_xh42 xhp42 xhn42 vdd cmld
Rnd_xh42 xhp42 xhn42 20k
Cxh42p xhp42 0 1e-13
Cxh42n xhn42 0 1e-13
Xihx_0_42 a_xp0 a_xn0 wp_ih_0_42 wn_ih_0_42 xhp42 xhn42 vdd vbsyn gsyn
Xihx_1_42 a_xp1 a_xn1 wp_ih_1_42 wn_ih_1_42 xhp42 xhn42 vdd vbsyn gsyn
Xihx_2_42 a_xp2 a_xn2 wp_ih_2_42 wn_ih_2_42 xhp42 xhn42 vdd vbsyn gsyn
Xn42 xhp42 xhn42 ahp42 ahn42 vdd vbneu dneuron
Xcm_xh43 xhp43 xhn43 vdd cmld
Rnd_xh43 xhp43 xhn43 20k
Cxh43p xhp43 0 1e-13
Cxh43n xhn43 0 1e-13
Xihx_0_43 a_xp0 a_xn0 wp_ih_0_43 wn_ih_0_43 xhp43 xhn43 vdd vbsyn gsyn
Xihx_1_43 a_xp1 a_xn1 wp_ih_1_43 wn_ih_1_43 xhp43 xhn43 vdd vbsyn gsyn
Xihx_2_43 a_xp2 a_xn2 wp_ih_2_43 wn_ih_2_43 xhp43 xhn43 vdd vbsyn gsyn
Xn43 xhp43 xhn43 ahp43 ahn43 vdd vbneu dneuron
Xcm_xh44 xhp44 xhn44 vdd cmld
Rnd_xh44 xhp44 xhn44 20k
Cxh44p xhp44 0 1e-13
Cxh44n xhn44 0 1e-13
Xihx_0_44 a_xp0 a_xn0 wp_ih_0_44 wn_ih_0_44 xhp44 xhn44 vdd vbsyn gsyn
Xihx_1_44 a_xp1 a_xn1 wp_ih_1_44 wn_ih_1_44 xhp44 xhn44 vdd vbsyn gsyn
Xihx_2_44 a_xp2 a_xn2 wp_ih_2_44 wn_ih_2_44 xhp44 xhn44 vdd vbsyn gsyn
Xn44 xhp44 xhn44 ahp44 ahn44 vdd vbneu dneuron
Xcm_xh45 xhp45 xhn45 vdd cmld
Rnd_xh45 xhp45 xhn45 20k
Cxh45p xhp45 0 1e-13
Cxh45n xhn45 0 1e-13
Xihx_0_45 a_xp0 a_xn0 wp_ih_0_45 wn_ih_0_45 xhp45 xhn45 vdd vbsyn gsyn
Xihx_1_45 a_xp1 a_xn1 wp_ih_1_45 wn_ih_1_45 xhp45 xhn45 vdd vbsyn gsyn
Xihx_2_45 a_xp2 a_xn2 wp_ih_2_45 wn_ih_2_45 xhp45 xhn45 vdd vbsyn gsyn
Xn45 xhp45 xhn45 ahp45 ahn45 vdd vbneu dneuron
Xcm_xh46 xhp46 xhn46 vdd cmld
Rnd_xh46 xhp46 xhn46 20k
Cxh46p xhp46 0 1e-13
Cxh46n xhn46 0 1e-13
Xihx_0_46 a_xp0 a_xn0 wp_ih_0_46 wn_ih_0_46 xhp46 xhn46 vdd vbsyn gsyn
Xihx_1_46 a_xp1 a_xn1 wp_ih_1_46 wn_ih_1_46 xhp46 xhn46 vdd vbsyn gsyn
Xihx_2_46 a_xp2 a_xn2 wp_ih_2_46 wn_ih_2_46 xhp46 xhn46 vdd vbsyn gsyn
Xn46 xhp46 xhn46 ahp46 ahn46 vdd vbneu dneuron
Xcm_xh47 xhp47 xhn47 vdd cmld
Rnd_xh47 xhp47 xhn47 20k
Cxh47p xhp47 0 1e-13
Cxh47n xhn47 0 1e-13
Xihx_0_47 a_xp0 a_xn0 wp_ih_0_47 wn_ih_0_47 xhp47 xhn47 vdd vbsyn gsyn
Xihx_1_47 a_xp1 a_xn1 wp_ih_1_47 wn_ih_1_47 xhp47 xhn47 vdd vbsyn gsyn
Xihx_2_47 a_xp2 a_xn2 wp_ih_2_47 wn_ih_2_47 xhp47 xhn47 vdd vbsyn gsyn
Xn47 xhp47 xhn47 ahp47 ahn47 vdd vbneu dneuron
Xcm_mo0 mop0 mon0 vdd cmld
Rnd_mo0 mop0 mon0 20k
Cmo0p mop0 0 1e-13
Cmo0n mon0 0 1e-13
Xho_0_0 ahp0 ahn0 wp_ho_0_0 wn_ho_0_0 mop0 mon0 vdd vbsyn gsyn
Xho_1_0 ahp1 ahn1 wp_ho_1_0 wn_ho_1_0 mop0 mon0 vdd vbsyn gsyn
Xho_2_0 ahp2 ahn2 wp_ho_2_0 wn_ho_2_0 mop0 mon0 vdd vbsyn gsyn
Xho_3_0 ahp3 ahn3 wp_ho_3_0 wn_ho_3_0 mop0 mon0 vdd vbsyn gsyn
Xho_4_0 ahp4 ahn4 wp_ho_4_0 wn_ho_4_0 mop0 mon0 vdd vbsyn gsyn
Xho_5_0 ahp5 ahn5 wp_ho_5_0 wn_ho_5_0 mop0 mon0 vdd vbsyn gsyn
Xho_6_0 ahp6 ahn6 wp_ho_6_0 wn_ho_6_0 mop0 mon0 vdd vbsyn gsyn
Xho_7_0 ahp7 ahn7 wp_ho_7_0 wn_ho_7_0 mop0 mon0 vdd vbsyn gsyn
Xho_8_0 ahp8 ahn8 wp_ho_8_0 wn_ho_8_0 mop0 mon0 vdd vbsyn gsyn
Xho_9_0 ahp9 ahn9 wp_ho_9_0 wn_ho_9_0 mop0 mon0 vdd vbsyn gsyn
Xho_10_0 ahp10 ahn10 wp_ho_10_0 wn_ho_10_0 mop0 mon0 vdd vbsyn gsyn
Xho_11_0 ahp11 ahn11 wp_ho_11_0 wn_ho_11_0 mop0 mon0 vdd vbsyn gsyn
Xho_12_0 ahp12 ahn12 wp_ho_12_0 wn_ho_12_0 mop0 mon0 vdd vbsyn gsyn
Xho_13_0 ahp13 ahn13 wp_ho_13_0 wn_ho_13_0 mop0 mon0 vdd vbsyn gsyn
Xho_14_0 ahp14 ahn14 wp_ho_14_0 wn_ho_14_0 mop0 mon0 vdd vbsyn gsyn
Xho_15_0 ahp15 ahn15 wp_ho_15_0 wn_ho_15_0 mop0 mon0 vdd vbsyn gsyn
Xho_16_0 ahp16 ahn16 wp_ho_16_0 wn_ho_16_0 mop0 mon0 vdd vbsyn gsyn
Xho_17_0 ahp17 ahn17 wp_ho_17_0 wn_ho_17_0 mop0 mon0 vdd vbsyn gsyn
Xho_18_0 ahp18 ahn18 wp_ho_18_0 wn_ho_18_0 mop0 mon0 vdd vbsyn gsyn
Xho_19_0 ahp19 ahn19 wp_ho_19_0 wn_ho_19_0 mop0 mon0 vdd vbsyn gsyn
Xho_20_0 ahp20 ahn20 wp_ho_20_0 wn_ho_20_0 mop0 mon0 vdd vbsyn gsyn
Xho_21_0 ahp21 ahn21 wp_ho_21_0 wn_ho_21_0 mop0 mon0 vdd vbsyn gsyn
Xho_22_0 ahp22 ahn22 wp_ho_22_0 wn_ho_22_0 mop0 mon0 vdd vbsyn gsyn
Xho_23_0 ahp23 ahn23 wp_ho_23_0 wn_ho_23_0 mop0 mon0 vdd vbsyn gsyn
Xho_24_0 ahp24 ahn24 wp_ho_24_0 wn_ho_24_0 mop0 mon0 vdd vbsyn gsyn
Xho_25_0 ahp25 ahn25 wp_ho_25_0 wn_ho_25_0 mop0 mon0 vdd vbsyn gsyn
Xho_26_0 ahp26 ahn26 wp_ho_26_0 wn_ho_26_0 mop0 mon0 vdd vbsyn gsyn
Xho_27_0 ahp27 ahn27 wp_ho_27_0 wn_ho_27_0 mop0 mon0 vdd vbsyn gsyn
Xho_28_0 ahp28 ahn28 wp_ho_28_0 wn_ho_28_0 mop0 mon0 vdd vbsyn gsyn
Xho_29_0 ahp29 ahn29 wp_ho_29_0 wn_ho_29_0 mop0 mon0 vdd vbsyn gsyn
Xho_30_0 ahp30 ahn30 wp_ho_30_0 wn_ho_30_0 mop0 mon0 vdd vbsyn gsyn
Xho_31_0 ahp31 ahn31 wp_ho_31_0 wn_ho_31_0 mop0 mon0 vdd vbsyn gsyn
Xho_32_0 ahp32 ahn32 wp_ho_32_0 wn_ho_32_0 mop0 mon0 vdd vbsyn gsyn
Xho_33_0 ahp33 ahn33 wp_ho_33_0 wn_ho_33_0 mop0 mon0 vdd vbsyn gsyn
Xho_34_0 ahp34 ahn34 wp_ho_34_0 wn_ho_34_0 mop0 mon0 vdd vbsyn gsyn
Xho_35_0 ahp35 ahn35 wp_ho_35_0 wn_ho_35_0 mop0 mon0 vdd vbsyn gsyn
Xho_36_0 ahp36 ahn36 wp_ho_36_0 wn_ho_36_0 mop0 mon0 vdd vbsyn gsyn
Xho_37_0 ahp37 ahn37 wp_ho_37_0 wn_ho_37_0 mop0 mon0 vdd vbsyn gsyn
Xho_38_0 ahp38 ahn38 wp_ho_38_0 wn_ho_38_0 mop0 mon0 vdd vbsyn gsyn
Xho_39_0 ahp39 ahn39 wp_ho_39_0 wn_ho_39_0 mop0 mon0 vdd vbsyn gsyn
Xho_40_0 ahp40 ahn40 wp_ho_40_0 wn_ho_40_0 mop0 mon0 vdd vbsyn gsyn
Xho_41_0 ahp41 ahn41 wp_ho_41_0 wn_ho_41_0 mop0 mon0 vdd vbsyn gsyn
Xho_42_0 ahp42 ahn42 wp_ho_42_0 wn_ho_42_0 mop0 mon0 vdd vbsyn gsyn
Xho_43_0 ahp43 ahn43 wp_ho_43_0 wn_ho_43_0 mop0 mon0 vdd vbsyn gsyn
Xho_44_0 ahp44 ahn44 wp_ho_44_0 wn_ho_44_0 mop0 mon0 vdd vbsyn gsyn
Xho_45_0 ahp45 ahn45 wp_ho_45_0 wn_ho_45_0 mop0 mon0 vdd vbsyn gsyn
Xho_46_0 ahp46 ahn46 wp_ho_46_0 wn_ho_46_0 mop0 mon0 vdd vbsyn gsyn
Xho_47_0 ahp47 ahn47 wp_ho_47_0 wn_ho_47_0 mop0 mon0 vdd vbsyn gsyn
Xcm_mo1 mop1 mon1 vdd cmld
Rnd_mo1 mop1 mon1 20k
Cmo1p mop1 0 1e-13
Cmo1n mon1 0 1e-13
Xho_0_1 ahp0 ahn0 wp_ho_0_1 wn_ho_0_1 mop1 mon1 vdd vbsyn gsyn
Xho_1_1 ahp1 ahn1 wp_ho_1_1 wn_ho_1_1 mop1 mon1 vdd vbsyn gsyn
Xho_2_1 ahp2 ahn2 wp_ho_2_1 wn_ho_2_1 mop1 mon1 vdd vbsyn gsyn
Xho_3_1 ahp3 ahn3 wp_ho_3_1 wn_ho_3_1 mop1 mon1 vdd vbsyn gsyn
Xho_4_1 ahp4 ahn4 wp_ho_4_1 wn_ho_4_1 mop1 mon1 vdd vbsyn gsyn
Xho_5_1 ahp5 ahn5 wp_ho_5_1 wn_ho_5_1 mop1 mon1 vdd vbsyn gsyn
Xho_6_1 ahp6 ahn6 wp_ho_6_1 wn_ho_6_1 mop1 mon1 vdd vbsyn gsyn
Xho_7_1 ahp7 ahn7 wp_ho_7_1 wn_ho_7_1 mop1 mon1 vdd vbsyn gsyn
Xho_8_1 ahp8 ahn8 wp_ho_8_1 wn_ho_8_1 mop1 mon1 vdd vbsyn gsyn
Xho_9_1 ahp9 ahn9 wp_ho_9_1 wn_ho_9_1 mop1 mon1 vdd vbsyn gsyn
Xho_10_1 ahp10 ahn10 wp_ho_10_1 wn_ho_10_1 mop1 mon1 vdd vbsyn gsyn
Xho_11_1 ahp11 ahn11 wp_ho_11_1 wn_ho_11_1 mop1 mon1 vdd vbsyn gsyn
Xho_12_1 ahp12 ahn12 wp_ho_12_1 wn_ho_12_1 mop1 mon1 vdd vbsyn gsyn
Xho_13_1 ahp13 ahn13 wp_ho_13_1 wn_ho_13_1 mop1 mon1 vdd vbsyn gsyn
Xho_14_1 ahp14 ahn14 wp_ho_14_1 wn_ho_14_1 mop1 mon1 vdd vbsyn gsyn
Xho_15_1 ahp15 ahn15 wp_ho_15_1 wn_ho_15_1 mop1 mon1 vdd vbsyn gsyn
Xho_16_1 ahp16 ahn16 wp_ho_16_1 wn_ho_16_1 mop1 mon1 vdd vbsyn gsyn
Xho_17_1 ahp17 ahn17 wp_ho_17_1 wn_ho_17_1 mop1 mon1 vdd vbsyn gsyn
Xho_18_1 ahp18 ahn18 wp_ho_18_1 wn_ho_18_1 mop1 mon1 vdd vbsyn gsyn
Xho_19_1 ahp19 ahn19 wp_ho_19_1 wn_ho_19_1 mop1 mon1 vdd vbsyn gsyn
Xho_20_1 ahp20 ahn20 wp_ho_20_1 wn_ho_20_1 mop1 mon1 vdd vbsyn gsyn
Xho_21_1 ahp21 ahn21 wp_ho_21_1 wn_ho_21_1 mop1 mon1 vdd vbsyn gsyn
Xho_22_1 ahp22 ahn22 wp_ho_22_1 wn_ho_22_1 mop1 mon1 vdd vbsyn gsyn
Xho_23_1 ahp23 ahn23 wp_ho_23_1 wn_ho_23_1 mop1 mon1 vdd vbsyn gsyn
Xho_24_1 ahp24 ahn24 wp_ho_24_1 wn_ho_24_1 mop1 mon1 vdd vbsyn gsyn
Xho_25_1 ahp25 ahn25 wp_ho_25_1 wn_ho_25_1 mop1 mon1 vdd vbsyn gsyn
Xho_26_1 ahp26 ahn26 wp_ho_26_1 wn_ho_26_1 mop1 mon1 vdd vbsyn gsyn
Xho_27_1 ahp27 ahn27 wp_ho_27_1 wn_ho_27_1 mop1 mon1 vdd vbsyn gsyn
Xho_28_1 ahp28 ahn28 wp_ho_28_1 wn_ho_28_1 mop1 mon1 vdd vbsyn gsyn
Xho_29_1 ahp29 ahn29 wp_ho_29_1 wn_ho_29_1 mop1 mon1 vdd vbsyn gsyn
Xho_30_1 ahp30 ahn30 wp_ho_30_1 wn_ho_30_1 mop1 mon1 vdd vbsyn gsyn
Xho_31_1 ahp31 ahn31 wp_ho_31_1 wn_ho_31_1 mop1 mon1 vdd vbsyn gsyn
Xho_32_1 ahp32 ahn32 wp_ho_32_1 wn_ho_32_1 mop1 mon1 vdd vbsyn gsyn
Xho_33_1 ahp33 ahn33 wp_ho_33_1 wn_ho_33_1 mop1 mon1 vdd vbsyn gsyn
Xho_34_1 ahp34 ahn34 wp_ho_34_1 wn_ho_34_1 mop1 mon1 vdd vbsyn gsyn
Xho_35_1 ahp35 ahn35 wp_ho_35_1 wn_ho_35_1 mop1 mon1 vdd vbsyn gsyn
Xho_36_1 ahp36 ahn36 wp_ho_36_1 wn_ho_36_1 mop1 mon1 vdd vbsyn gsyn
Xho_37_1 ahp37 ahn37 wp_ho_37_1 wn_ho_37_1 mop1 mon1 vdd vbsyn gsyn
Xho_38_1 ahp38 ahn38 wp_ho_38_1 wn_ho_38_1 mop1 mon1 vdd vbsyn gsyn
Xho_39_1 ahp39 ahn39 wp_ho_39_1 wn_ho_39_1 mop1 mon1 vdd vbsyn gsyn
Xho_40_1 ahp40 ahn40 wp_ho_40_1 wn_ho_40_1 mop1 mon1 vdd vbsyn gsyn
Xho_41_1 ahp41 ahn41 wp_ho_41_1 wn_ho_41_1 mop1 mon1 vdd vbsyn gsyn
Xho_42_1 ahp42 ahn42 wp_ho_42_1 wn_ho_42_1 mop1 mon1 vdd vbsyn gsyn
Xho_43_1 ahp43 ahn43 wp_ho_43_1 wn_ho_43_1 mop1 mon1 vdd vbsyn gsyn
Xho_44_1 ahp44 ahn44 wp_ho_44_1 wn_ho_44_1 mop1 mon1 vdd vbsyn gsyn
Xho_45_1 ahp45 ahn45 wp_ho_45_1 wn_ho_45_1 mop1 mon1 vdd vbsyn gsyn
Xho_46_1 ahp46 ahn46 wp_ho_46_1 wn_ho_46_1 mop1 mon1 vdd vbsyn gsyn
Xho_47_1 ahp47 ahn47 wp_ho_47_1 wn_ho_47_1 mop1 mon1 vdd vbsyn gsyn
Xcm_mo2 mop2 mon2 vdd cmld
Rnd_mo2 mop2 mon2 20k
Cmo2p mop2 0 1e-13
Cmo2n mon2 0 1e-13
Xho_0_2 ahp0 ahn0 wp_ho_0_2 wn_ho_0_2 mop2 mon2 vdd vbsyn gsyn
Xho_1_2 ahp1 ahn1 wp_ho_1_2 wn_ho_1_2 mop2 mon2 vdd vbsyn gsyn
Xho_2_2 ahp2 ahn2 wp_ho_2_2 wn_ho_2_2 mop2 mon2 vdd vbsyn gsyn
Xho_3_2 ahp3 ahn3 wp_ho_3_2 wn_ho_3_2 mop2 mon2 vdd vbsyn gsyn
Xho_4_2 ahp4 ahn4 wp_ho_4_2 wn_ho_4_2 mop2 mon2 vdd vbsyn gsyn
Xho_5_2 ahp5 ahn5 wp_ho_5_2 wn_ho_5_2 mop2 mon2 vdd vbsyn gsyn
Xho_6_2 ahp6 ahn6 wp_ho_6_2 wn_ho_6_2 mop2 mon2 vdd vbsyn gsyn
Xho_7_2 ahp7 ahn7 wp_ho_7_2 wn_ho_7_2 mop2 mon2 vdd vbsyn gsyn
Xho_8_2 ahp8 ahn8 wp_ho_8_2 wn_ho_8_2 mop2 mon2 vdd vbsyn gsyn
Xho_9_2 ahp9 ahn9 wp_ho_9_2 wn_ho_9_2 mop2 mon2 vdd vbsyn gsyn
Xho_10_2 ahp10 ahn10 wp_ho_10_2 wn_ho_10_2 mop2 mon2 vdd vbsyn gsyn
Xho_11_2 ahp11 ahn11 wp_ho_11_2 wn_ho_11_2 mop2 mon2 vdd vbsyn gsyn
Xho_12_2 ahp12 ahn12 wp_ho_12_2 wn_ho_12_2 mop2 mon2 vdd vbsyn gsyn
Xho_13_2 ahp13 ahn13 wp_ho_13_2 wn_ho_13_2 mop2 mon2 vdd vbsyn gsyn
Xho_14_2 ahp14 ahn14 wp_ho_14_2 wn_ho_14_2 mop2 mon2 vdd vbsyn gsyn
Xho_15_2 ahp15 ahn15 wp_ho_15_2 wn_ho_15_2 mop2 mon2 vdd vbsyn gsyn
Xho_16_2 ahp16 ahn16 wp_ho_16_2 wn_ho_16_2 mop2 mon2 vdd vbsyn gsyn
Xho_17_2 ahp17 ahn17 wp_ho_17_2 wn_ho_17_2 mop2 mon2 vdd vbsyn gsyn
Xho_18_2 ahp18 ahn18 wp_ho_18_2 wn_ho_18_2 mop2 mon2 vdd vbsyn gsyn
Xho_19_2 ahp19 ahn19 wp_ho_19_2 wn_ho_19_2 mop2 mon2 vdd vbsyn gsyn
Xho_20_2 ahp20 ahn20 wp_ho_20_2 wn_ho_20_2 mop2 mon2 vdd vbsyn gsyn
Xho_21_2 ahp21 ahn21 wp_ho_21_2 wn_ho_21_2 mop2 mon2 vdd vbsyn gsyn
Xho_22_2 ahp22 ahn22 wp_ho_22_2 wn_ho_22_2 mop2 mon2 vdd vbsyn gsyn
Xho_23_2 ahp23 ahn23 wp_ho_23_2 wn_ho_23_2 mop2 mon2 vdd vbsyn gsyn
Xho_24_2 ahp24 ahn24 wp_ho_24_2 wn_ho_24_2 mop2 mon2 vdd vbsyn gsyn
Xho_25_2 ahp25 ahn25 wp_ho_25_2 wn_ho_25_2 mop2 mon2 vdd vbsyn gsyn
Xho_26_2 ahp26 ahn26 wp_ho_26_2 wn_ho_26_2 mop2 mon2 vdd vbsyn gsyn
Xho_27_2 ahp27 ahn27 wp_ho_27_2 wn_ho_27_2 mop2 mon2 vdd vbsyn gsyn
Xho_28_2 ahp28 ahn28 wp_ho_28_2 wn_ho_28_2 mop2 mon2 vdd vbsyn gsyn
Xho_29_2 ahp29 ahn29 wp_ho_29_2 wn_ho_29_2 mop2 mon2 vdd vbsyn gsyn
Xho_30_2 ahp30 ahn30 wp_ho_30_2 wn_ho_30_2 mop2 mon2 vdd vbsyn gsyn
Xho_31_2 ahp31 ahn31 wp_ho_31_2 wn_ho_31_2 mop2 mon2 vdd vbsyn gsyn
Xho_32_2 ahp32 ahn32 wp_ho_32_2 wn_ho_32_2 mop2 mon2 vdd vbsyn gsyn
Xho_33_2 ahp33 ahn33 wp_ho_33_2 wn_ho_33_2 mop2 mon2 vdd vbsyn gsyn
Xho_34_2 ahp34 ahn34 wp_ho_34_2 wn_ho_34_2 mop2 mon2 vdd vbsyn gsyn
Xho_35_2 ahp35 ahn35 wp_ho_35_2 wn_ho_35_2 mop2 mon2 vdd vbsyn gsyn
Xho_36_2 ahp36 ahn36 wp_ho_36_2 wn_ho_36_2 mop2 mon2 vdd vbsyn gsyn
Xho_37_2 ahp37 ahn37 wp_ho_37_2 wn_ho_37_2 mop2 mon2 vdd vbsyn gsyn
Xho_38_2 ahp38 ahn38 wp_ho_38_2 wn_ho_38_2 mop2 mon2 vdd vbsyn gsyn
Xho_39_2 ahp39 ahn39 wp_ho_39_2 wn_ho_39_2 mop2 mon2 vdd vbsyn gsyn
Xho_40_2 ahp40 ahn40 wp_ho_40_2 wn_ho_40_2 mop2 mon2 vdd vbsyn gsyn
Xho_41_2 ahp41 ahn41 wp_ho_41_2 wn_ho_41_2 mop2 mon2 vdd vbsyn gsyn
Xho_42_2 ahp42 ahn42 wp_ho_42_2 wn_ho_42_2 mop2 mon2 vdd vbsyn gsyn
Xho_43_2 ahp43 ahn43 wp_ho_43_2 wn_ho_43_2 mop2 mon2 vdd vbsyn gsyn
Xho_44_2 ahp44 ahn44 wp_ho_44_2 wn_ho_44_2 mop2 mon2 vdd vbsyn gsyn
Xho_45_2 ahp45 ahn45 wp_ho_45_2 wn_ho_45_2 mop2 mon2 vdd vbsyn gsyn
Xho_46_2 ahp46 ahn46 wp_ho_46_2 wn_ho_46_2 mop2 mon2 vdd vbsyn gsyn
Xho_47_2 ahp47 ahn47 wp_ho_47_2 wn_ho_47_2 mop2 mon2 vdd vbsyn gsyn
Xcm_mo3 mop3 mon3 vdd cmld
Rnd_mo3 mop3 mon3 20k
Cmo3p mop3 0 1e-13
Cmo3n mon3 0 1e-13
Xho_0_3 ahp0 ahn0 wp_ho_0_3 wn_ho_0_3 mop3 mon3 vdd vbsyn gsyn
Xho_1_3 ahp1 ahn1 wp_ho_1_3 wn_ho_1_3 mop3 mon3 vdd vbsyn gsyn
Xho_2_3 ahp2 ahn2 wp_ho_2_3 wn_ho_2_3 mop3 mon3 vdd vbsyn gsyn
Xho_3_3 ahp3 ahn3 wp_ho_3_3 wn_ho_3_3 mop3 mon3 vdd vbsyn gsyn
Xho_4_3 ahp4 ahn4 wp_ho_4_3 wn_ho_4_3 mop3 mon3 vdd vbsyn gsyn
Xho_5_3 ahp5 ahn5 wp_ho_5_3 wn_ho_5_3 mop3 mon3 vdd vbsyn gsyn
Xho_6_3 ahp6 ahn6 wp_ho_6_3 wn_ho_6_3 mop3 mon3 vdd vbsyn gsyn
Xho_7_3 ahp7 ahn7 wp_ho_7_3 wn_ho_7_3 mop3 mon3 vdd vbsyn gsyn
Xho_8_3 ahp8 ahn8 wp_ho_8_3 wn_ho_8_3 mop3 mon3 vdd vbsyn gsyn
Xho_9_3 ahp9 ahn9 wp_ho_9_3 wn_ho_9_3 mop3 mon3 vdd vbsyn gsyn
Xho_10_3 ahp10 ahn10 wp_ho_10_3 wn_ho_10_3 mop3 mon3 vdd vbsyn gsyn
Xho_11_3 ahp11 ahn11 wp_ho_11_3 wn_ho_11_3 mop3 mon3 vdd vbsyn gsyn
Xho_12_3 ahp12 ahn12 wp_ho_12_3 wn_ho_12_3 mop3 mon3 vdd vbsyn gsyn
Xho_13_3 ahp13 ahn13 wp_ho_13_3 wn_ho_13_3 mop3 mon3 vdd vbsyn gsyn
Xho_14_3 ahp14 ahn14 wp_ho_14_3 wn_ho_14_3 mop3 mon3 vdd vbsyn gsyn
Xho_15_3 ahp15 ahn15 wp_ho_15_3 wn_ho_15_3 mop3 mon3 vdd vbsyn gsyn
Xho_16_3 ahp16 ahn16 wp_ho_16_3 wn_ho_16_3 mop3 mon3 vdd vbsyn gsyn
Xho_17_3 ahp17 ahn17 wp_ho_17_3 wn_ho_17_3 mop3 mon3 vdd vbsyn gsyn
Xho_18_3 ahp18 ahn18 wp_ho_18_3 wn_ho_18_3 mop3 mon3 vdd vbsyn gsyn
Xho_19_3 ahp19 ahn19 wp_ho_19_3 wn_ho_19_3 mop3 mon3 vdd vbsyn gsyn
Xho_20_3 ahp20 ahn20 wp_ho_20_3 wn_ho_20_3 mop3 mon3 vdd vbsyn gsyn
Xho_21_3 ahp21 ahn21 wp_ho_21_3 wn_ho_21_3 mop3 mon3 vdd vbsyn gsyn
Xho_22_3 ahp22 ahn22 wp_ho_22_3 wn_ho_22_3 mop3 mon3 vdd vbsyn gsyn
Xho_23_3 ahp23 ahn23 wp_ho_23_3 wn_ho_23_3 mop3 mon3 vdd vbsyn gsyn
Xho_24_3 ahp24 ahn24 wp_ho_24_3 wn_ho_24_3 mop3 mon3 vdd vbsyn gsyn
Xho_25_3 ahp25 ahn25 wp_ho_25_3 wn_ho_25_3 mop3 mon3 vdd vbsyn gsyn
Xho_26_3 ahp26 ahn26 wp_ho_26_3 wn_ho_26_3 mop3 mon3 vdd vbsyn gsyn
Xho_27_3 ahp27 ahn27 wp_ho_27_3 wn_ho_27_3 mop3 mon3 vdd vbsyn gsyn
Xho_28_3 ahp28 ahn28 wp_ho_28_3 wn_ho_28_3 mop3 mon3 vdd vbsyn gsyn
Xho_29_3 ahp29 ahn29 wp_ho_29_3 wn_ho_29_3 mop3 mon3 vdd vbsyn gsyn
Xho_30_3 ahp30 ahn30 wp_ho_30_3 wn_ho_30_3 mop3 mon3 vdd vbsyn gsyn
Xho_31_3 ahp31 ahn31 wp_ho_31_3 wn_ho_31_3 mop3 mon3 vdd vbsyn gsyn
Xho_32_3 ahp32 ahn32 wp_ho_32_3 wn_ho_32_3 mop3 mon3 vdd vbsyn gsyn
Xho_33_3 ahp33 ahn33 wp_ho_33_3 wn_ho_33_3 mop3 mon3 vdd vbsyn gsyn
Xho_34_3 ahp34 ahn34 wp_ho_34_3 wn_ho_34_3 mop3 mon3 vdd vbsyn gsyn
Xho_35_3 ahp35 ahn35 wp_ho_35_3 wn_ho_35_3 mop3 mon3 vdd vbsyn gsyn
Xho_36_3 ahp36 ahn36 wp_ho_36_3 wn_ho_36_3 mop3 mon3 vdd vbsyn gsyn
Xho_37_3 ahp37 ahn37 wp_ho_37_3 wn_ho_37_3 mop3 mon3 vdd vbsyn gsyn
Xho_38_3 ahp38 ahn38 wp_ho_38_3 wn_ho_38_3 mop3 mon3 vdd vbsyn gsyn
Xho_39_3 ahp39 ahn39 wp_ho_39_3 wn_ho_39_3 mop3 mon3 vdd vbsyn gsyn
Xho_40_3 ahp40 ahn40 wp_ho_40_3 wn_ho_40_3 mop3 mon3 vdd vbsyn gsyn
Xho_41_3 ahp41 ahn41 wp_ho_41_3 wn_ho_41_3 mop3 mon3 vdd vbsyn gsyn
Xho_42_3 ahp42 ahn42 wp_ho_42_3 wn_ho_42_3 mop3 mon3 vdd vbsyn gsyn
Xho_43_3 ahp43 ahn43 wp_ho_43_3 wn_ho_43_3 mop3 mon3 vdd vbsyn gsyn
Xho_44_3 ahp44 ahn44 wp_ho_44_3 wn_ho_44_3 mop3 mon3 vdd vbsyn gsyn
Xho_45_3 ahp45 ahn45 wp_ho_45_3 wn_ho_45_3 mop3 mon3 vdd vbsyn gsyn
Xho_46_3 ahp46 ahn46 wp_ho_46_3 wn_ho_46_3 mop3 mon3 vdd vbsyn gsyn
Xho_47_3 ahp47 ahn47 wp_ho_47_3 wn_ho_47_3 mop3 mon3 vdd vbsyn gsyn
.options gmin=1e-10 reltol=2e-3 cshunt=1e-15
.control
tran 1n 640.0n uic
wrdata pb_rn3163.dat v(ahp0) v(ahn0) v(ahp1) v(ahn1) v(ahp2) v(ahn2) v(ahp3) v(ahn3) v(ahp4) v(ahn4) v(ahp5) v(ahn5) v(ahp6) v(ahn6) v(ahp7) v(ahn7) v(ahp8) v(ahn8) v(ahp9) v(ahn9) v(ahp10) v(ahn10) v(ahp11) v(ahn11) v(ahp12) v(ahn12) v(ahp13) v(ahn13) v(ahp14) v(ahn14) v(ahp15) v(ahn15) v(ahp16) v(ahn16) v(ahp17) v(ahn17) v(ahp18) v(ahn18) v(ahp19) v(ahn19) v(ahp20) v(ahn20) v(ahp21) v(ahn21) v(ahp22) v(ahn22) v(ahp23) v(ahn23) v(ahp24) v(ahn24) v(ahp25) v(ahn25) v(ahp26) v(ahn26) v(ahp27) v(ahn27) v(ahp28) v(ahn28) v(ahp29) v(ahn29) v(ahp30) v(ahn30) v(ahp31) v(ahn31) v(ahp32) v(ahn32) v(ahp33) v(ahn33) v(ahp34) v(ahn34) v(ahp35) v(ahn35) v(ahp36) v(ahn36) v(ahp37) v(ahn37) v(ahp38) v(ahn38) v(ahp39) v(ahn39) v(ahp40) v(ahn40) v(ahp41) v(ahn41) v(ahp42) v(ahn42) v(ahp43) v(ahn43) v(ahp44) v(ahn44) v(ahp45) v(ahn45) v(ahp46) v(ahn46) v(ahp47) v(ahn47) v(mop0) v(mon0) v(mop1) v(mon1) v(mop2) v(mon2) v(mop3) v(mon3)
.endc
.end
