single-layer continuous PC
.model NNR NMOS (LEVEL=1 VTO=0.2 KP=120u LAMBDA=0.02 GAMMA=0 PHI=0.7)
.model PNR PMOS (LEVEL=1 VTO=-0.2 KP=40u LAMBDA=0.02 GAMMA=0 PHI=0.7)
.subckt gsyn inp inn wp wn outp outn vdd vbn
Mtail nt vbn 0 0 NNR W=400u L=100u
M5 na wp nt 0 NNR W=200u L=100u
M6 nb wn nt 0 NNR W=200u L=100u
M1 outp inp na 0 NNR W=200u L=100u
M2 outn inn na 0 NNR W=200u L=100u
M3 outn inp nb 0 NNR W=200u L=100u
M4 outp inn nb 0 NNR W=200u L=100u
.ends
.subckt cmld p n vdd
Rcs1 p cmx 300k
Rcs2 n cmx 300k
MLp p cmx vdd vdd PNR W=1000u L=100u
MLn n cmx vdd vdd PNR W=1000u L=100u
.ends
.subckt esub xp xn mp mn ep en vdd vbn
Mt nt vbn 0 0 NNR W=400u L=100u
M1x ep xn nt 0 NNR W=200u L=100u
M2x en xp nt 0 NNR W=200u L=100u
M1m ep mp nt 0 NNR W=200u L=100u
M2m en mn nt 0 NNR W=200u L=100u
RLp vdd ep 50k
RLn vdd en 50k
.ends
.subckt gprod xp xn yp yn wp wn vdd vbn
* chopper-free Gilbert product -> differential current onto (wp,wn): integrates  x.y
Mtail nt vbn 0 0 NNR W=400u L=100u
M5 na yp nt 0 NNR W=200u L=100u
M6 nb yn nt 0 NNR W=200u L=100u
M1 iop xp na 0 NNR W=200u L=100u
M2 ion xn na 0 NNR W=200u L=100u
M3 ion xp nb 0 NNR W=200u L=100u
M4 iop xn nb 0 NNR W=200u L=100u
Mlp iop iop vdd vdd PNR W=200u L=100u
Mln ion ion vdd vdd PNR W=200u L=100u
Mpu_wp wp iop vdd vdd PNR W=200u L=100u
MpRn nrn ion vdd vdd PNR W=200u L=100u
MnRn nrn nrn 0 0 NNR W=200u L=100u
Mpd_wp wp nrn 0 0 NNR W=200u L=100u
Mpu_wn wn ion vdd vdd PNR W=200u L=100u
MpRp nrp iop vdd vdd PNR W=200u L=100u
MnRp nrp nrp 0 0 NNR W=200u L=100u
Mpd_wn wn nrp 0 0 NNR W=200u L=100u
.ends
Vdd vdd 0 1.0
Vbsyn vbsyn 0 0.45
Vgbl gbl 0 0.7
Vgm gm 0 0.6
Vx1p a_xp1 0 PWL(0.0n 0.2000 299.9n 0.2000 300.0n 0.2000 599.9n 0.2000 600.0n 0.8000 899.9n 0.8000 900.0n 0.8000 1199.9n 0.8000 1200.0n 0.2000 1499.9n 0.2000 1500.0n 0.2000 1799.9n 0.2000 1800.0n 0.8000 2099.9n 0.8000 2100.0n 0.8000 2399.9n 0.8000 2400.0n 0.2000 2699.9n 0.2000 2700.0n 0.2000 2999.9n 0.2000 3000.0n 0.8000 3299.9n 0.8000 3300.0n 0.8000 3599.9n 0.8000 3600.0n 0.2000 3899.9n 0.2000 3900.0n 0.2000 4199.9n 0.2000 4200.0n 0.8000 4499.9n 0.8000 4500.0n 0.8000 4799.9n 0.8000 4800.0n 0.2000 5099.9n 0.2000 5100.0n 0.2000 5399.9n 0.2000 5400.0n 0.8000 5699.9n 0.8000 5700.0n 0.8000 5999.9n 0.8000 6000.0n 0.2000 6299.9n 0.2000 6300.0n 0.2000 6599.9n 0.2000 6600.0n 0.8000 6899.9n 0.8000 6900.0n 0.8000 7199.9n 0.8000 7200.0n 0.2000 7499.9n 0.2000 7500.0n 0.2000 7799.9n 0.2000 7800.0n 0.8000 8099.9n 0.8000 8100.0n 0.8000 8399.9n 0.8000 8400.0n 0.2000 8699.9n 0.2000 8700.0n 0.2000 8999.9n 0.2000 9000.0n 0.8000 9299.9n 0.8000 9300.0n 0.8000 9599.9n 0.8000 9600.0n 0.2000 9899.9n 0.2000 9900.0n 0.2000 10199.9n 0.2000 10200.0n 0.8000 10499.9n 0.8000 10500.0n 0.8000 10799.9n 0.8000 10800.0n 0.2000 11099.9n 0.2000 11100.0n 0.2000 11399.9n 0.2000 11400.0n 0.8000 11699.9n 0.8000 11700.0n 0.8000 11999.9n 0.8000 12000.0n 0.2000 12299.9n 0.2000 12300.0n 0.2000 12599.9n 0.2000 12600.0n 0.8000 12899.9n 0.8000 12900.0n 0.8000 13199.9n 0.8000 13200.0n 0.2000 13499.9n 0.2000 13500.0n 0.2000 13799.9n 0.2000 13800.0n 0.8000 14099.9n 0.8000 14100.0n 0.8000 14399.9n 0.8000 14400.0n 0.2000 14699.9n 0.2000 14700.0n 0.2000 14999.9n 0.2000 15000.0n 0.8000 15299.9n 0.8000 15300.0n 0.8000 15599.9n 0.8000 15600.0n 0.2000 15899.9n 0.2000 15900.0n 0.2000 16199.9n 0.2000 16200.0n 0.8000 16499.9n 0.8000 16500.0n 0.8000 16799.9n 0.8000 16800.0n 0.2000 17099.9n 0.2000 17100.0n 0.2000 17399.9n 0.2000 17400.0n 0.8000 17699.9n 0.8000 17700.0n 0.8000 17999.9n 0.8000 18000.0n 0.2000 18299.9n 0.2000 18300.0n 0.2000 18599.9n 0.2000 18600.0n 0.8000 18899.9n 0.8000 18900.0n 0.8000 19199.9n 0.8000 19200.0n 0.2000 19499.9n 0.2000 19500.0n 0.2000 19799.9n 0.2000 19800.0n 0.8000 20099.9n 0.8000 20100.0n 0.8000 20399.9n 0.8000 20400.0n 0.2000 20699.9n 0.2000 20700.0n 0.2000 20999.9n 0.2000 21000.0n 0.8000 21299.9n 0.8000 21300.0n 0.8000 21599.9n 0.8000 21600.0n 0.2000 21899.9n 0.2000 21900.0n 0.2000 22199.9n 0.2000 22200.0n 0.8000 22499.9n 0.8000 22500.0n 0.8000 22799.9n 0.8000 22800.0n 0.2000 23099.9n 0.2000 23100.0n 0.2000 23399.9n 0.2000 23400.0n 0.8000 23699.9n 0.8000 23700.0n 0.8000 23999.9n 0.8000 24000.0n 0.2000 24299.9n 0.2000 24300.0n 0.2000 24599.9n 0.2000 24600.0n 0.8000 24899.9n 0.8000 24900.0n 0.8000 25199.9n 0.8000 25200.0n 0.2000 25499.9n 0.2000 25500.0n 0.2000 25799.9n 0.2000 25800.0n 0.8000 26099.9n 0.8000 26100.0n 0.8000 26399.9n 0.8000 26400.0n 0.2000 26699.9n 0.2000 26700.0n 0.2000 26999.9n 0.2000 27000.0n 0.8000 27299.9n 0.8000 27300.0n 0.8000 27599.9n 0.8000 27600.0n 0.2000 27899.9n 0.2000 27900.0n 0.2000 28199.9n 0.2000 28200.0n 0.8000 28499.9n 0.8000 28500.0n 0.8000 28799.9n 0.8000 28800.0n 0.2000 29099.9n 0.2000 29100.0n 0.2000 29399.9n 0.2000 29400.0n 0.8000 29699.9n 0.8000 29700.0n 0.8000 29999.9n 0.8000 30000.0n 0.2000 30299.9n 0.2000 30300.0n 0.2000 30599.9n 0.2000 30600.0n 0.8000 30899.9n 0.8000 30900.0n 0.8000 31199.9n 0.8000 31200.0n 0.2000 31499.9n 0.2000 31500.0n 0.2000 31799.9n 0.2000 31800.0n 0.8000 32099.9n 0.8000 32100.0n 0.8000 32399.9n 0.8000 32400.0n 0.2000 32699.9n 0.2000 32700.0n 0.2000 32999.9n 0.2000 33000.0n 0.8000 33299.9n 0.8000 33300.0n 0.8000 33599.9n 0.8000 33600.0n 0.2000 33899.9n 0.2000 33900.0n 0.2000 34199.9n 0.2000 34200.0n 0.8000 34499.9n 0.8000 34500.0n 0.8000 34799.9n 0.8000 34800.0n 0.2000 35099.9n 0.2000 35100.0n 0.2000 35399.9n 0.2000 35400.0n 0.8000 35699.9n 0.8000 35700.0n 0.8000 35999.9n 0.8000 36000.0n 0.2000 36299.9n 0.2000 36300.0n 0.2000 36599.9n 0.2000 36600.0n 0.8000 36899.9n 0.8000 36900.0n 0.8000 37199.9n 0.8000 37200.0n 0.2000 37499.9n 0.2000 37500.0n 0.2000 37799.9n 0.2000 37800.0n 0.8000 38099.9n 0.8000 38100.0n 0.8000 38399.9n 0.8000 38400.0n 0.2000 38699.9n 0.2000 38700.0n 0.2000 38999.9n 0.2000 39000.0n 0.8000 39299.9n 0.8000 39300.0n 0.8000 39599.9n 0.8000 39600.0n 0.2000 39899.9n 0.2000 39900.0n 0.2000 40199.9n 0.2000 40200.0n 0.8000 40499.9n 0.8000 40500.0n 0.8000 40799.9n 0.8000 40800.0n 0.2000 41099.9n 0.2000 41100.0n 0.2000 41399.9n 0.2000 41400.0n 0.8000 41699.9n 0.8000 41700.0n 0.8000 41999.9n 0.8000 42000.0n 0.2000 42299.9n 0.2000 42300.0n 0.2000 42599.9n 0.2000 42600.0n 0.8000 42899.9n 0.8000 42900.0n 0.8000 43199.9n 0.8000 43200.0n 0.2000 43499.9n 0.2000 43500.0n 0.2000 43799.9n 0.2000 43800.0n 0.8000 44099.9n 0.8000 44100.0n 0.8000 44399.9n 0.8000 44400.0n 0.2000 44699.9n 0.2000 44700.0n 0.2000 44999.9n 0.2000 45000.0n 0.8000 45299.9n 0.8000 45300.0n 0.8000 45599.9n 0.8000 45600.0n 0.2000 45899.9n 0.2000 45900.0n 0.2000 46199.9n 0.2000 46200.0n 0.8000 46499.9n 0.8000 46500.0n 0.8000 46799.9n 0.8000 46800.0n 0.2000 47099.9n 0.2000 47100.0n 0.2000 47399.9n 0.2000 47400.0n 0.8000 47699.9n 0.8000 47700.0n 0.8000 47999.9n 0.8000 48000.0n 0.2000 48299.9n 0.2000 48300.0n 0.2000 48599.9n 0.2000 48600.0n 0.8000 48899.9n 0.8000 48900.0n 0.8000 49199.9n 0.8000 49200.0n 0.2000 49499.9n 0.2000 49500.0n 0.2000 49799.9n 0.2000 49800.0n 0.8000 50099.9n 0.8000 50100.0n 0.8000 50399.9n 0.8000 50400.0n 0.2000 50699.9n 0.2000 50700.0n 0.2000 50999.9n 0.2000 51000.0n 0.8000 51299.9n 0.8000 51300.0n 0.8000 51599.9n 0.8000 51600.0n 0.2000 51899.9n 0.2000 51900.0n 0.2000 52199.9n 0.2000 52200.0n 0.8000 52499.9n 0.8000 52500.0n 0.8000 52799.9n 0.8000 52800.0n 0.2000 53099.9n 0.2000 53100.0n 0.2000 53399.9n 0.2000 53400.0n 0.8000 53699.9n 0.8000 53700.0n 0.8000 53999.9n 0.8000 54000.0n 0.2000 54299.9n 0.2000 54300.0n 0.2000 54599.9n 0.2000 54600.0n 0.8000 54899.9n 0.8000 54900.0n 0.8000 55199.9n 0.8000 55200.0n 0.2000 55499.9n 0.2000 55500.0n 0.2000 55799.9n 0.2000 55800.0n 0.8000 56099.9n 0.8000 56100.0n 0.8000 56399.9n 0.8000 56400.0n 0.2000 56699.9n 0.2000 56700.0n 0.2000 56999.9n 0.2000 57000.0n 0.8000 57299.9n 0.8000 57300.0n 0.8000 57599.9n 0.8000 57600.0n 0.2000 57899.9n 0.2000 57900.0n 0.2000 58199.9n 0.2000 58200.0n 0.8000 58499.9n 0.8000 58500.0n 0.8000 58799.9n 0.8000 58800.0n 0.2000 59099.9n 0.2000 59100.0n 0.2000 59399.9n 0.2000 59400.0n 0.8000 59699.9n 0.8000 59700.0n 0.8000 59999.9n 0.8000 60000.0n 0.2000 60299.9n 0.2000 60300.0n 0.2000 60599.9n 0.2000 60600.0n 0.8000 60899.9n 0.8000 60900.0n 0.8000 61199.9n 0.8000 61200.0n 0.2000 61499.9n 0.2000 61500.0n 0.2000 61799.9n 0.2000 61800.0n 0.8000 62099.9n 0.8000 62100.0n 0.8000 62399.9n 0.8000 62400.0n 0.2000 62699.9n 0.2000 62700.0n 0.2000 62999.9n 0.2000 63000.0n 0.8000 63299.9n 0.8000 63300.0n 0.8000 63599.9n 0.8000 63600.0n 0.2000 63899.9n 0.2000 63900.0n 0.2000 64199.9n 0.2000 64200.0n 0.8000 64499.9n 0.8000 64500.0n 0.8000 64799.9n 0.8000 64800.0n 0.2000 65099.9n 0.2000 65100.0n 0.2000 65399.9n 0.2000 65400.0n 0.8000 65699.9n 0.8000 65700.0n 0.8000 65999.9n 0.8000 66000.0n 0.2000 66299.9n 0.2000 66300.0n 0.2000 66599.9n 0.2000 66600.0n 0.8000 66899.9n 0.8000 66900.0n 0.8000 67199.9n 0.8000 67200.0n 0.2000 67499.9n 0.2000 67500.0n 0.2000 67799.9n 0.2000 67800.0n 0.8000 68099.9n 0.8000 68100.0n 0.8000 68399.9n 0.8000 68400.0n 0.2000 68699.9n 0.2000 68700.0n 0.2000 68999.9n 0.2000 69000.0n 0.8000 69299.9n 0.8000 69300.0n 0.8000 69599.9n 0.8000 69600.0n 0.2000 69899.9n 0.2000 69900.0n 0.2000 70199.9n 0.2000 70200.0n 0.8000 70499.9n 0.8000 70500.0n 0.8000 70799.9n 0.8000 70800.0n 0.2000 71099.9n 0.2000 71100.0n 0.2000 71399.9n 0.2000 71400.0n 0.8000 71699.9n 0.8000 71700.0n 0.8000 71999.9n 0.8000 72000.0n 0.2000 72299.9n 0.2000 72300.0n 0.2000 72599.9n 0.2000 72600.0n 0.8000 72899.9n 0.8000 72900.0n 0.8000 73199.9n 0.8000 73200.0n 0.2000 73499.9n 0.2000 73500.0n 0.2000 73799.9n 0.2000 73800.0n 0.8000 74099.9n 0.8000 74100.0n 0.8000 74399.9n 0.8000 74400.0n 0.2000 74699.9n 0.2000 74700.0n 0.2000 74999.9n 0.2000 75000.0n 0.8000 75299.9n 0.8000 75300.0n 0.8000 75599.9n 0.8000 75600.0n 0.2000 75899.9n 0.2000 75900.0n 0.2000 76199.9n 0.2000 76200.0n 0.8000 76499.9n 0.8000 76500.0n 0.8000 76799.9n 0.8000 76800.0n 0.2000 77099.9n 0.2000 77100.0n 0.2000 77399.9n 0.2000 77400.0n 0.8000 77699.9n 0.8000 77700.0n 0.8000 77999.9n 0.8000 78000.0n 0.2000 78299.9n 0.2000 78300.0n 0.2000 78599.9n 0.2000 78600.0n 0.8000 78899.9n 0.8000 78900.0n 0.8000 79199.9n 0.8000 79200.0n 0.2000 79499.9n 0.2000 79500.0n 0.2000 79799.9n 0.2000 79800.0n 0.8000 80099.9n 0.8000 80100.0n 0.8000 80399.9n 0.8000 80400.0n 0.2000 80699.9n 0.2000 80700.0n 0.2000 80999.9n 0.2000 81000.0n 0.8000 81299.9n 0.8000 81300.0n 0.8000 81599.9n 0.8000 81600.0n 0.2000 81899.9n 0.2000 81900.0n 0.2000 82199.9n 0.2000 82200.0n 0.8000 82499.9n 0.8000 82500.0n 0.8000 82799.9n 0.8000 82800.0n 0.2000 83099.9n 0.2000 83100.0n 0.2000 83399.9n 0.2000 83400.0n 0.8000 83699.9n 0.8000 83700.0n 0.8000 83999.9n 0.8000 84000.0n 0.2000 84299.9n 0.2000 84300.0n 0.2000 84599.9n 0.2000 84600.0n 0.8000 84899.9n 0.8000 84900.0n 0.8000 85199.9n 0.8000 85200.0n 0.2000 85499.9n 0.2000 85500.0n 0.2000 85799.9n 0.2000 85800.0n 0.8000 86099.9n 0.8000 86100.0n 0.8000 86399.9n 0.8000 86400.0n 0.2000 86699.9n 0.2000 86700.0n 0.2000 86999.9n 0.2000 87000.0n 0.8000 87299.9n 0.8000 87300.0n 0.8000 87599.9n 0.8000 87600.0n 0.2000 87899.9n 0.2000 87900.0n 0.2000 88199.9n 0.2000 88200.0n 0.8000 88499.9n 0.8000 88500.0n 0.8000 88799.9n 0.8000 88800.0n 0.2000 89099.9n 0.2000 89100.0n 0.2000 89399.9n 0.2000 89400.0n 0.8000 89699.9n 0.8000 89700.0n 0.8000 89999.9n 0.8000 90000.0n 0.2000 90299.9n 0.2000 90300.0n 0.2000 90599.9n 0.2000 90600.0n 0.8000 90899.9n 0.8000 90900.0n 0.8000 91199.9n 0.8000 91200.0n 0.2000 91499.9n 0.2000 91500.0n 0.2000 91799.9n 0.2000 91800.0n 0.8000 92099.9n 0.8000 92100.0n 0.8000 92399.9n 0.8000 92400.0n 0.2000 92699.9n 0.2000 92700.0n 0.2000 92999.9n 0.2000 93000.0n 0.8000 93299.9n 0.8000 93300.0n 0.8000 93599.9n 0.8000 93600.0n 0.2000 93899.9n 0.2000 93900.0n 0.2000 94199.9n 0.2000 94200.0n 0.8000 94499.9n 0.8000 94500.0n 0.8000 94799.9n 0.8000 94800.0n 0.2000 95099.9n 0.2000 95100.0n 0.2000 95399.9n 0.2000 95400.0n 0.8000 95699.9n 0.8000 95700.0n 0.8000 95999.9n 0.8000 96000.0n 0.2000 96299.9n 0.2000 96300.0n 0.2000 96599.9n 0.2000 96600.0n 0.8000 96899.9n 0.8000 96900.0n 0.8000 97199.9n 0.8000 97200.0n 0.2000 97499.9n 0.2000 97500.0n 0.2000 97799.9n 0.2000 97800.0n 0.8000 98099.9n 0.8000 98100.0n 0.8000 98399.9n 0.8000 98400.0n 0.2000 98699.9n 0.2000 98700.0n 0.2000 98999.9n 0.2000 99000.0n 0.8000 99299.9n 0.8000 99300.0n 0.8000 99599.9n 0.8000 99600.0n 0.2000 99899.9n 0.2000 99900.0n 0.2000 100199.9n 0.2000 100200.0n 0.8000 100499.9n 0.8000 100500.0n 0.8000 100799.9n 0.8000 100800.0n 0.2000 101099.9n 0.2000 101100.0n 0.2000 101399.9n 0.2000 101400.0n 0.8000 101699.9n 0.8000 101700.0n 0.8000 101999.9n 0.8000 102000.0n 0.2000 102299.9n 0.2000 102300.0n 0.2000 102599.9n 0.2000 102600.0n 0.8000 102899.9n 0.8000 102900.0n 0.8000 103199.9n 0.8000 103200.0n 0.2000 103499.9n 0.2000 103500.0n 0.2000 103799.9n 0.2000 103800.0n 0.8000 104099.9n 0.8000 104100.0n 0.8000 104399.9n 0.8000 104400.0n 0.2000 104699.9n 0.2000 104700.0n 0.2000 104999.9n 0.2000 105000.0n 0.8000 105299.9n 0.8000 105300.0n 0.8000 105599.9n 0.8000 105600.0n 0.2000 105899.9n 0.2000 105900.0n 0.2000 106199.9n 0.2000 106200.0n 0.8000 106499.9n 0.8000 106500.0n 0.8000 106799.9n 0.8000 106800.0n 0.2000 107099.9n 0.2000 107100.0n 0.2000 107399.9n 0.2000 107400.0n 0.8000 107699.9n 0.8000 107700.0n 0.8000 107999.9n 0.8000 108000.0n 0.2000 108299.9n 0.2000 108300.0n 0.2000 108599.9n 0.2000 108600.0n 0.8000 108899.9n 0.8000 108900.0n 0.8000 109199.9n 0.8000 109200.0n 0.2000 109499.9n 0.2000 109500.0n 0.2000 109799.9n 0.2000 109800.0n 0.8000 110099.9n 0.8000 110100.0n 0.8000 110399.9n 0.8000 110400.0n 0.2000 110699.9n 0.2000 110700.0n 0.2000 110999.9n 0.2000 111000.0n 0.8000 111299.9n 0.8000 111300.0n 0.8000 111599.9n 0.8000 111600.0n 0.2000 111899.9n 0.2000 111900.0n 0.2000 112199.9n 0.2000 112200.0n 0.8000 112499.9n 0.8000 112500.0n 0.8000 112799.9n 0.8000 112800.0n 0.2000 113099.9n 0.2000 113100.0n 0.2000 113399.9n 0.2000 113400.0n 0.8000 113699.9n 0.8000 113700.0n 0.8000 113999.9n 0.8000 114000.0n 0.2000 114299.9n 0.2000 114300.0n 0.2000 114599.9n 0.2000 114600.0n 0.8000 114899.9n 0.8000 114900.0n 0.8000 115199.9n 0.8000 115200.0n 0.2000 115499.9n 0.2000 115500.0n 0.2000 115799.9n 0.2000 115800.0n 0.8000 116099.9n 0.8000 116100.0n 0.8000 116399.9n 0.8000 116400.0n 0.2000 116699.9n 0.2000 116700.0n 0.2000 116999.9n 0.2000 117000.0n 0.8000 117299.9n 0.8000 117300.0n 0.8000 117599.9n 0.8000 117600.0n 0.2000 117899.9n 0.2000 117900.0n 0.2000 118199.9n 0.2000 118200.0n 0.8000 118499.9n 0.8000 118500.0n 0.8000 118799.9n 0.8000 118800.0n 0.2000 119099.9n 0.2000 119100.0n 0.2000 119399.9n 0.2000 119400.0n 0.8000 119699.9n 0.8000 119700.0n 0.8000 119999.9n 0.8000 120000.0n 0.2000 120299.9n 0.2000 120300.0n 0.2000 120599.9n 0.2000 120600.0n 0.8000 120899.9n 0.8000 120900.0n 0.8000 121199.9n 0.8000 121200.0n 0.2000 121499.9n 0.2000 121500.0n 0.2000 121799.9n 0.2000 121800.0n 0.8000 122099.9n 0.8000 122100.0n 0.8000 122399.9n 0.8000 122400.0n 0.2000 122699.9n 0.2000 122700.0n 0.2000 122999.9n 0.2000 123000.0n 0.8000 123299.9n 0.8000 123300.0n 0.8000 123599.9n 0.8000 123600.0n 0.2000 123899.9n 0.2000 123900.0n 0.2000 124199.9n 0.2000 124200.0n 0.8000 124499.9n 0.8000 124500.0n 0.8000 124799.9n 0.8000 124800.0n 0.2000 125099.9n 0.2000 125100.0n 0.2000 125399.9n 0.2000 125400.0n 0.8000 125699.9n 0.8000 125700.0n 0.8000 125999.9n 0.8000 126000.0n 0.2000 126299.9n 0.2000 126300.0n 0.2000 126599.9n 0.2000 126600.0n 0.8000 126899.9n 0.8000 126900.0n 0.8000 127199.9n 0.8000 127200.0n 0.2000 127499.9n 0.2000 127500.0n 0.2000 127799.9n 0.2000 127800.0n 0.8000 128099.9n 0.8000 128100.0n 0.8000 128399.9n 0.8000 128400.0n 0.2000 128699.9n 0.2000 128700.0n 0.2000 128999.9n 0.2000 129000.0n 0.8000 129299.9n 0.8000 129300.0n 0.8000 129599.9n 0.8000 129600.0n 0.2000 129899.9n 0.2000 129900.0n 0.2000 130199.9n 0.2000 130200.0n 0.8000 130499.9n 0.8000 130500.0n 0.8000 130799.9n 0.8000 130800.0n 0.2000 131099.9n 0.2000 131100.0n 0.2000 131399.9n 0.2000 131400.0n 0.8000 131699.9n 0.8000 131700.0n 0.8000 131999.9n 0.8000 132000.0n 0.2000 132299.9n 0.2000 132300.0n 0.2000 132599.9n 0.2000 132600.0n 0.8000 132899.9n 0.8000 132900.0n 0.8000 133199.9n 0.8000 133200.0n 0.2000 133499.9n 0.2000 133500.0n 0.2000 133799.9n 0.2000 133800.0n 0.8000 134099.9n 0.8000 134100.0n 0.8000 134399.9n 0.8000 134400.0n 0.2000 134699.9n 0.2000 134700.0n 0.2000 134999.9n 0.2000 135000.0n 0.8000 135299.9n 0.8000 135300.0n 0.8000 135599.9n 0.8000 135600.0n 0.2000 135899.9n 0.2000 135900.0n 0.2000 136199.9n 0.2000 136200.0n 0.8000 136499.9n 0.8000 136500.0n 0.8000 136799.9n 0.8000 136800.0n 0.2000 137099.9n 0.2000 137100.0n 0.2000 137399.9n 0.2000 137400.0n 0.8000 137699.9n 0.8000 137700.0n 0.8000 137999.9n 0.8000 138000.0n 0.2000 138299.9n 0.2000 138300.0n 0.2000 138599.9n 0.2000 138600.0n 0.8000 138899.9n 0.8000 138900.0n 0.8000 139199.9n 0.8000 139200.0n 0.2000 139499.9n 0.2000 139500.0n 0.2000 139799.9n 0.2000 139800.0n 0.8000 140099.9n 0.8000 140100.0n 0.8000 140399.9n 0.8000 140400.0n 0.2000 140699.9n 0.2000 140700.0n 0.2000 140999.9n 0.2000 141000.0n 0.8000 141299.9n 0.8000 141300.0n 0.8000 141599.9n 0.8000 141600.0n 0.2000 141899.9n 0.2000 141900.0n 0.2000 142199.9n 0.2000 142200.0n 0.8000 142499.9n 0.8000 142500.0n 0.8000 142799.9n 0.8000 142800.0n 0.2000 143099.9n 0.2000 143100.0n 0.2000 143399.9n 0.2000 143400.0n 0.8000 143699.9n 0.8000 143700.0n 0.8000)
Vx1n a_xn1 0 PWL(0.0n 0.8000 299.9n 0.8000 300.0n 0.8000 599.9n 0.8000 600.0n 0.2000 899.9n 0.2000 900.0n 0.2000 1199.9n 0.2000 1200.0n 0.8000 1499.9n 0.8000 1500.0n 0.8000 1799.9n 0.8000 1800.0n 0.2000 2099.9n 0.2000 2100.0n 0.2000 2399.9n 0.2000 2400.0n 0.8000 2699.9n 0.8000 2700.0n 0.8000 2999.9n 0.8000 3000.0n 0.2000 3299.9n 0.2000 3300.0n 0.2000 3599.9n 0.2000 3600.0n 0.8000 3899.9n 0.8000 3900.0n 0.8000 4199.9n 0.8000 4200.0n 0.2000 4499.9n 0.2000 4500.0n 0.2000 4799.9n 0.2000 4800.0n 0.8000 5099.9n 0.8000 5100.0n 0.8000 5399.9n 0.8000 5400.0n 0.2000 5699.9n 0.2000 5700.0n 0.2000 5999.9n 0.2000 6000.0n 0.8000 6299.9n 0.8000 6300.0n 0.8000 6599.9n 0.8000 6600.0n 0.2000 6899.9n 0.2000 6900.0n 0.2000 7199.9n 0.2000 7200.0n 0.8000 7499.9n 0.8000 7500.0n 0.8000 7799.9n 0.8000 7800.0n 0.2000 8099.9n 0.2000 8100.0n 0.2000 8399.9n 0.2000 8400.0n 0.8000 8699.9n 0.8000 8700.0n 0.8000 8999.9n 0.8000 9000.0n 0.2000 9299.9n 0.2000 9300.0n 0.2000 9599.9n 0.2000 9600.0n 0.8000 9899.9n 0.8000 9900.0n 0.8000 10199.9n 0.8000 10200.0n 0.2000 10499.9n 0.2000 10500.0n 0.2000 10799.9n 0.2000 10800.0n 0.8000 11099.9n 0.8000 11100.0n 0.8000 11399.9n 0.8000 11400.0n 0.2000 11699.9n 0.2000 11700.0n 0.2000 11999.9n 0.2000 12000.0n 0.8000 12299.9n 0.8000 12300.0n 0.8000 12599.9n 0.8000 12600.0n 0.2000 12899.9n 0.2000 12900.0n 0.2000 13199.9n 0.2000 13200.0n 0.8000 13499.9n 0.8000 13500.0n 0.8000 13799.9n 0.8000 13800.0n 0.2000 14099.9n 0.2000 14100.0n 0.2000 14399.9n 0.2000 14400.0n 0.8000 14699.9n 0.8000 14700.0n 0.8000 14999.9n 0.8000 15000.0n 0.2000 15299.9n 0.2000 15300.0n 0.2000 15599.9n 0.2000 15600.0n 0.8000 15899.9n 0.8000 15900.0n 0.8000 16199.9n 0.8000 16200.0n 0.2000 16499.9n 0.2000 16500.0n 0.2000 16799.9n 0.2000 16800.0n 0.8000 17099.9n 0.8000 17100.0n 0.8000 17399.9n 0.8000 17400.0n 0.2000 17699.9n 0.2000 17700.0n 0.2000 17999.9n 0.2000 18000.0n 0.8000 18299.9n 0.8000 18300.0n 0.8000 18599.9n 0.8000 18600.0n 0.2000 18899.9n 0.2000 18900.0n 0.2000 19199.9n 0.2000 19200.0n 0.8000 19499.9n 0.8000 19500.0n 0.8000 19799.9n 0.8000 19800.0n 0.2000 20099.9n 0.2000 20100.0n 0.2000 20399.9n 0.2000 20400.0n 0.8000 20699.9n 0.8000 20700.0n 0.8000 20999.9n 0.8000 21000.0n 0.2000 21299.9n 0.2000 21300.0n 0.2000 21599.9n 0.2000 21600.0n 0.8000 21899.9n 0.8000 21900.0n 0.8000 22199.9n 0.8000 22200.0n 0.2000 22499.9n 0.2000 22500.0n 0.2000 22799.9n 0.2000 22800.0n 0.8000 23099.9n 0.8000 23100.0n 0.8000 23399.9n 0.8000 23400.0n 0.2000 23699.9n 0.2000 23700.0n 0.2000 23999.9n 0.2000 24000.0n 0.8000 24299.9n 0.8000 24300.0n 0.8000 24599.9n 0.8000 24600.0n 0.2000 24899.9n 0.2000 24900.0n 0.2000 25199.9n 0.2000 25200.0n 0.8000 25499.9n 0.8000 25500.0n 0.8000 25799.9n 0.8000 25800.0n 0.2000 26099.9n 0.2000 26100.0n 0.2000 26399.9n 0.2000 26400.0n 0.8000 26699.9n 0.8000 26700.0n 0.8000 26999.9n 0.8000 27000.0n 0.2000 27299.9n 0.2000 27300.0n 0.2000 27599.9n 0.2000 27600.0n 0.8000 27899.9n 0.8000 27900.0n 0.8000 28199.9n 0.8000 28200.0n 0.2000 28499.9n 0.2000 28500.0n 0.2000 28799.9n 0.2000 28800.0n 0.8000 29099.9n 0.8000 29100.0n 0.8000 29399.9n 0.8000 29400.0n 0.2000 29699.9n 0.2000 29700.0n 0.2000 29999.9n 0.2000 30000.0n 0.8000 30299.9n 0.8000 30300.0n 0.8000 30599.9n 0.8000 30600.0n 0.2000 30899.9n 0.2000 30900.0n 0.2000 31199.9n 0.2000 31200.0n 0.8000 31499.9n 0.8000 31500.0n 0.8000 31799.9n 0.8000 31800.0n 0.2000 32099.9n 0.2000 32100.0n 0.2000 32399.9n 0.2000 32400.0n 0.8000 32699.9n 0.8000 32700.0n 0.8000 32999.9n 0.8000 33000.0n 0.2000 33299.9n 0.2000 33300.0n 0.2000 33599.9n 0.2000 33600.0n 0.8000 33899.9n 0.8000 33900.0n 0.8000 34199.9n 0.8000 34200.0n 0.2000 34499.9n 0.2000 34500.0n 0.2000 34799.9n 0.2000 34800.0n 0.8000 35099.9n 0.8000 35100.0n 0.8000 35399.9n 0.8000 35400.0n 0.2000 35699.9n 0.2000 35700.0n 0.2000 35999.9n 0.2000 36000.0n 0.8000 36299.9n 0.8000 36300.0n 0.8000 36599.9n 0.8000 36600.0n 0.2000 36899.9n 0.2000 36900.0n 0.2000 37199.9n 0.2000 37200.0n 0.8000 37499.9n 0.8000 37500.0n 0.8000 37799.9n 0.8000 37800.0n 0.2000 38099.9n 0.2000 38100.0n 0.2000 38399.9n 0.2000 38400.0n 0.8000 38699.9n 0.8000 38700.0n 0.8000 38999.9n 0.8000 39000.0n 0.2000 39299.9n 0.2000 39300.0n 0.2000 39599.9n 0.2000 39600.0n 0.8000 39899.9n 0.8000 39900.0n 0.8000 40199.9n 0.8000 40200.0n 0.2000 40499.9n 0.2000 40500.0n 0.2000 40799.9n 0.2000 40800.0n 0.8000 41099.9n 0.8000 41100.0n 0.8000 41399.9n 0.8000 41400.0n 0.2000 41699.9n 0.2000 41700.0n 0.2000 41999.9n 0.2000 42000.0n 0.8000 42299.9n 0.8000 42300.0n 0.8000 42599.9n 0.8000 42600.0n 0.2000 42899.9n 0.2000 42900.0n 0.2000 43199.9n 0.2000 43200.0n 0.8000 43499.9n 0.8000 43500.0n 0.8000 43799.9n 0.8000 43800.0n 0.2000 44099.9n 0.2000 44100.0n 0.2000 44399.9n 0.2000 44400.0n 0.8000 44699.9n 0.8000 44700.0n 0.8000 44999.9n 0.8000 45000.0n 0.2000 45299.9n 0.2000 45300.0n 0.2000 45599.9n 0.2000 45600.0n 0.8000 45899.9n 0.8000 45900.0n 0.8000 46199.9n 0.8000 46200.0n 0.2000 46499.9n 0.2000 46500.0n 0.2000 46799.9n 0.2000 46800.0n 0.8000 47099.9n 0.8000 47100.0n 0.8000 47399.9n 0.8000 47400.0n 0.2000 47699.9n 0.2000 47700.0n 0.2000 47999.9n 0.2000 48000.0n 0.8000 48299.9n 0.8000 48300.0n 0.8000 48599.9n 0.8000 48600.0n 0.2000 48899.9n 0.2000 48900.0n 0.2000 49199.9n 0.2000 49200.0n 0.8000 49499.9n 0.8000 49500.0n 0.8000 49799.9n 0.8000 49800.0n 0.2000 50099.9n 0.2000 50100.0n 0.2000 50399.9n 0.2000 50400.0n 0.8000 50699.9n 0.8000 50700.0n 0.8000 50999.9n 0.8000 51000.0n 0.2000 51299.9n 0.2000 51300.0n 0.2000 51599.9n 0.2000 51600.0n 0.8000 51899.9n 0.8000 51900.0n 0.8000 52199.9n 0.8000 52200.0n 0.2000 52499.9n 0.2000 52500.0n 0.2000 52799.9n 0.2000 52800.0n 0.8000 53099.9n 0.8000 53100.0n 0.8000 53399.9n 0.8000 53400.0n 0.2000 53699.9n 0.2000 53700.0n 0.2000 53999.9n 0.2000 54000.0n 0.8000 54299.9n 0.8000 54300.0n 0.8000 54599.9n 0.8000 54600.0n 0.2000 54899.9n 0.2000 54900.0n 0.2000 55199.9n 0.2000 55200.0n 0.8000 55499.9n 0.8000 55500.0n 0.8000 55799.9n 0.8000 55800.0n 0.2000 56099.9n 0.2000 56100.0n 0.2000 56399.9n 0.2000 56400.0n 0.8000 56699.9n 0.8000 56700.0n 0.8000 56999.9n 0.8000 57000.0n 0.2000 57299.9n 0.2000 57300.0n 0.2000 57599.9n 0.2000 57600.0n 0.8000 57899.9n 0.8000 57900.0n 0.8000 58199.9n 0.8000 58200.0n 0.2000 58499.9n 0.2000 58500.0n 0.2000 58799.9n 0.2000 58800.0n 0.8000 59099.9n 0.8000 59100.0n 0.8000 59399.9n 0.8000 59400.0n 0.2000 59699.9n 0.2000 59700.0n 0.2000 59999.9n 0.2000 60000.0n 0.8000 60299.9n 0.8000 60300.0n 0.8000 60599.9n 0.8000 60600.0n 0.2000 60899.9n 0.2000 60900.0n 0.2000 61199.9n 0.2000 61200.0n 0.8000 61499.9n 0.8000 61500.0n 0.8000 61799.9n 0.8000 61800.0n 0.2000 62099.9n 0.2000 62100.0n 0.2000 62399.9n 0.2000 62400.0n 0.8000 62699.9n 0.8000 62700.0n 0.8000 62999.9n 0.8000 63000.0n 0.2000 63299.9n 0.2000 63300.0n 0.2000 63599.9n 0.2000 63600.0n 0.8000 63899.9n 0.8000 63900.0n 0.8000 64199.9n 0.8000 64200.0n 0.2000 64499.9n 0.2000 64500.0n 0.2000 64799.9n 0.2000 64800.0n 0.8000 65099.9n 0.8000 65100.0n 0.8000 65399.9n 0.8000 65400.0n 0.2000 65699.9n 0.2000 65700.0n 0.2000 65999.9n 0.2000 66000.0n 0.8000 66299.9n 0.8000 66300.0n 0.8000 66599.9n 0.8000 66600.0n 0.2000 66899.9n 0.2000 66900.0n 0.2000 67199.9n 0.2000 67200.0n 0.8000 67499.9n 0.8000 67500.0n 0.8000 67799.9n 0.8000 67800.0n 0.2000 68099.9n 0.2000 68100.0n 0.2000 68399.9n 0.2000 68400.0n 0.8000 68699.9n 0.8000 68700.0n 0.8000 68999.9n 0.8000 69000.0n 0.2000 69299.9n 0.2000 69300.0n 0.2000 69599.9n 0.2000 69600.0n 0.8000 69899.9n 0.8000 69900.0n 0.8000 70199.9n 0.8000 70200.0n 0.2000 70499.9n 0.2000 70500.0n 0.2000 70799.9n 0.2000 70800.0n 0.8000 71099.9n 0.8000 71100.0n 0.8000 71399.9n 0.8000 71400.0n 0.2000 71699.9n 0.2000 71700.0n 0.2000 71999.9n 0.2000 72000.0n 0.8000 72299.9n 0.8000 72300.0n 0.8000 72599.9n 0.8000 72600.0n 0.2000 72899.9n 0.2000 72900.0n 0.2000 73199.9n 0.2000 73200.0n 0.8000 73499.9n 0.8000 73500.0n 0.8000 73799.9n 0.8000 73800.0n 0.2000 74099.9n 0.2000 74100.0n 0.2000 74399.9n 0.2000 74400.0n 0.8000 74699.9n 0.8000 74700.0n 0.8000 74999.9n 0.8000 75000.0n 0.2000 75299.9n 0.2000 75300.0n 0.2000 75599.9n 0.2000 75600.0n 0.8000 75899.9n 0.8000 75900.0n 0.8000 76199.9n 0.8000 76200.0n 0.2000 76499.9n 0.2000 76500.0n 0.2000 76799.9n 0.2000 76800.0n 0.8000 77099.9n 0.8000 77100.0n 0.8000 77399.9n 0.8000 77400.0n 0.2000 77699.9n 0.2000 77700.0n 0.2000 77999.9n 0.2000 78000.0n 0.8000 78299.9n 0.8000 78300.0n 0.8000 78599.9n 0.8000 78600.0n 0.2000 78899.9n 0.2000 78900.0n 0.2000 79199.9n 0.2000 79200.0n 0.8000 79499.9n 0.8000 79500.0n 0.8000 79799.9n 0.8000 79800.0n 0.2000 80099.9n 0.2000 80100.0n 0.2000 80399.9n 0.2000 80400.0n 0.8000 80699.9n 0.8000 80700.0n 0.8000 80999.9n 0.8000 81000.0n 0.2000 81299.9n 0.2000 81300.0n 0.2000 81599.9n 0.2000 81600.0n 0.8000 81899.9n 0.8000 81900.0n 0.8000 82199.9n 0.8000 82200.0n 0.2000 82499.9n 0.2000 82500.0n 0.2000 82799.9n 0.2000 82800.0n 0.8000 83099.9n 0.8000 83100.0n 0.8000 83399.9n 0.8000 83400.0n 0.2000 83699.9n 0.2000 83700.0n 0.2000 83999.9n 0.2000 84000.0n 0.8000 84299.9n 0.8000 84300.0n 0.8000 84599.9n 0.8000 84600.0n 0.2000 84899.9n 0.2000 84900.0n 0.2000 85199.9n 0.2000 85200.0n 0.8000 85499.9n 0.8000 85500.0n 0.8000 85799.9n 0.8000 85800.0n 0.2000 86099.9n 0.2000 86100.0n 0.2000 86399.9n 0.2000 86400.0n 0.8000 86699.9n 0.8000 86700.0n 0.8000 86999.9n 0.8000 87000.0n 0.2000 87299.9n 0.2000 87300.0n 0.2000 87599.9n 0.2000 87600.0n 0.8000 87899.9n 0.8000 87900.0n 0.8000 88199.9n 0.8000 88200.0n 0.2000 88499.9n 0.2000 88500.0n 0.2000 88799.9n 0.2000 88800.0n 0.8000 89099.9n 0.8000 89100.0n 0.8000 89399.9n 0.8000 89400.0n 0.2000 89699.9n 0.2000 89700.0n 0.2000 89999.9n 0.2000 90000.0n 0.8000 90299.9n 0.8000 90300.0n 0.8000 90599.9n 0.8000 90600.0n 0.2000 90899.9n 0.2000 90900.0n 0.2000 91199.9n 0.2000 91200.0n 0.8000 91499.9n 0.8000 91500.0n 0.8000 91799.9n 0.8000 91800.0n 0.2000 92099.9n 0.2000 92100.0n 0.2000 92399.9n 0.2000 92400.0n 0.8000 92699.9n 0.8000 92700.0n 0.8000 92999.9n 0.8000 93000.0n 0.2000 93299.9n 0.2000 93300.0n 0.2000 93599.9n 0.2000 93600.0n 0.8000 93899.9n 0.8000 93900.0n 0.8000 94199.9n 0.8000 94200.0n 0.2000 94499.9n 0.2000 94500.0n 0.2000 94799.9n 0.2000 94800.0n 0.8000 95099.9n 0.8000 95100.0n 0.8000 95399.9n 0.8000 95400.0n 0.2000 95699.9n 0.2000 95700.0n 0.2000 95999.9n 0.2000 96000.0n 0.8000 96299.9n 0.8000 96300.0n 0.8000 96599.9n 0.8000 96600.0n 0.2000 96899.9n 0.2000 96900.0n 0.2000 97199.9n 0.2000 97200.0n 0.8000 97499.9n 0.8000 97500.0n 0.8000 97799.9n 0.8000 97800.0n 0.2000 98099.9n 0.2000 98100.0n 0.2000 98399.9n 0.2000 98400.0n 0.8000 98699.9n 0.8000 98700.0n 0.8000 98999.9n 0.8000 99000.0n 0.2000 99299.9n 0.2000 99300.0n 0.2000 99599.9n 0.2000 99600.0n 0.8000 99899.9n 0.8000 99900.0n 0.8000 100199.9n 0.8000 100200.0n 0.2000 100499.9n 0.2000 100500.0n 0.2000 100799.9n 0.2000 100800.0n 0.8000 101099.9n 0.8000 101100.0n 0.8000 101399.9n 0.8000 101400.0n 0.2000 101699.9n 0.2000 101700.0n 0.2000 101999.9n 0.2000 102000.0n 0.8000 102299.9n 0.8000 102300.0n 0.8000 102599.9n 0.8000 102600.0n 0.2000 102899.9n 0.2000 102900.0n 0.2000 103199.9n 0.2000 103200.0n 0.8000 103499.9n 0.8000 103500.0n 0.8000 103799.9n 0.8000 103800.0n 0.2000 104099.9n 0.2000 104100.0n 0.2000 104399.9n 0.2000 104400.0n 0.8000 104699.9n 0.8000 104700.0n 0.8000 104999.9n 0.8000 105000.0n 0.2000 105299.9n 0.2000 105300.0n 0.2000 105599.9n 0.2000 105600.0n 0.8000 105899.9n 0.8000 105900.0n 0.8000 106199.9n 0.8000 106200.0n 0.2000 106499.9n 0.2000 106500.0n 0.2000 106799.9n 0.2000 106800.0n 0.8000 107099.9n 0.8000 107100.0n 0.8000 107399.9n 0.8000 107400.0n 0.2000 107699.9n 0.2000 107700.0n 0.2000 107999.9n 0.2000 108000.0n 0.8000 108299.9n 0.8000 108300.0n 0.8000 108599.9n 0.8000 108600.0n 0.2000 108899.9n 0.2000 108900.0n 0.2000 109199.9n 0.2000 109200.0n 0.8000 109499.9n 0.8000 109500.0n 0.8000 109799.9n 0.8000 109800.0n 0.2000 110099.9n 0.2000 110100.0n 0.2000 110399.9n 0.2000 110400.0n 0.8000 110699.9n 0.8000 110700.0n 0.8000 110999.9n 0.8000 111000.0n 0.2000 111299.9n 0.2000 111300.0n 0.2000 111599.9n 0.2000 111600.0n 0.8000 111899.9n 0.8000 111900.0n 0.8000 112199.9n 0.8000 112200.0n 0.2000 112499.9n 0.2000 112500.0n 0.2000 112799.9n 0.2000 112800.0n 0.8000 113099.9n 0.8000 113100.0n 0.8000 113399.9n 0.8000 113400.0n 0.2000 113699.9n 0.2000 113700.0n 0.2000 113999.9n 0.2000 114000.0n 0.8000 114299.9n 0.8000 114300.0n 0.8000 114599.9n 0.8000 114600.0n 0.2000 114899.9n 0.2000 114900.0n 0.2000 115199.9n 0.2000 115200.0n 0.8000 115499.9n 0.8000 115500.0n 0.8000 115799.9n 0.8000 115800.0n 0.2000 116099.9n 0.2000 116100.0n 0.2000 116399.9n 0.2000 116400.0n 0.8000 116699.9n 0.8000 116700.0n 0.8000 116999.9n 0.8000 117000.0n 0.2000 117299.9n 0.2000 117300.0n 0.2000 117599.9n 0.2000 117600.0n 0.8000 117899.9n 0.8000 117900.0n 0.8000 118199.9n 0.8000 118200.0n 0.2000 118499.9n 0.2000 118500.0n 0.2000 118799.9n 0.2000 118800.0n 0.8000 119099.9n 0.8000 119100.0n 0.8000 119399.9n 0.8000 119400.0n 0.2000 119699.9n 0.2000 119700.0n 0.2000 119999.9n 0.2000 120000.0n 0.8000 120299.9n 0.8000 120300.0n 0.8000 120599.9n 0.8000 120600.0n 0.2000 120899.9n 0.2000 120900.0n 0.2000 121199.9n 0.2000 121200.0n 0.8000 121499.9n 0.8000 121500.0n 0.8000 121799.9n 0.8000 121800.0n 0.2000 122099.9n 0.2000 122100.0n 0.2000 122399.9n 0.2000 122400.0n 0.8000 122699.9n 0.8000 122700.0n 0.8000 122999.9n 0.8000 123000.0n 0.2000 123299.9n 0.2000 123300.0n 0.2000 123599.9n 0.2000 123600.0n 0.8000 123899.9n 0.8000 123900.0n 0.8000 124199.9n 0.8000 124200.0n 0.2000 124499.9n 0.2000 124500.0n 0.2000 124799.9n 0.2000 124800.0n 0.8000 125099.9n 0.8000 125100.0n 0.8000 125399.9n 0.8000 125400.0n 0.2000 125699.9n 0.2000 125700.0n 0.2000 125999.9n 0.2000 126000.0n 0.8000 126299.9n 0.8000 126300.0n 0.8000 126599.9n 0.8000 126600.0n 0.2000 126899.9n 0.2000 126900.0n 0.2000 127199.9n 0.2000 127200.0n 0.8000 127499.9n 0.8000 127500.0n 0.8000 127799.9n 0.8000 127800.0n 0.2000 128099.9n 0.2000 128100.0n 0.2000 128399.9n 0.2000 128400.0n 0.8000 128699.9n 0.8000 128700.0n 0.8000 128999.9n 0.8000 129000.0n 0.2000 129299.9n 0.2000 129300.0n 0.2000 129599.9n 0.2000 129600.0n 0.8000 129899.9n 0.8000 129900.0n 0.8000 130199.9n 0.8000 130200.0n 0.2000 130499.9n 0.2000 130500.0n 0.2000 130799.9n 0.2000 130800.0n 0.8000 131099.9n 0.8000 131100.0n 0.8000 131399.9n 0.8000 131400.0n 0.2000 131699.9n 0.2000 131700.0n 0.2000 131999.9n 0.2000 132000.0n 0.8000 132299.9n 0.8000 132300.0n 0.8000 132599.9n 0.8000 132600.0n 0.2000 132899.9n 0.2000 132900.0n 0.2000 133199.9n 0.2000 133200.0n 0.8000 133499.9n 0.8000 133500.0n 0.8000 133799.9n 0.8000 133800.0n 0.2000 134099.9n 0.2000 134100.0n 0.2000 134399.9n 0.2000 134400.0n 0.8000 134699.9n 0.8000 134700.0n 0.8000 134999.9n 0.8000 135000.0n 0.2000 135299.9n 0.2000 135300.0n 0.2000 135599.9n 0.2000 135600.0n 0.8000 135899.9n 0.8000 135900.0n 0.8000 136199.9n 0.8000 136200.0n 0.2000 136499.9n 0.2000 136500.0n 0.2000 136799.9n 0.2000 136800.0n 0.8000 137099.9n 0.8000 137100.0n 0.8000 137399.9n 0.8000 137400.0n 0.2000 137699.9n 0.2000 137700.0n 0.2000 137999.9n 0.2000 138000.0n 0.8000 138299.9n 0.8000 138300.0n 0.8000 138599.9n 0.8000 138600.0n 0.2000 138899.9n 0.2000 138900.0n 0.2000 139199.9n 0.2000 139200.0n 0.8000 139499.9n 0.8000 139500.0n 0.8000 139799.9n 0.8000 139800.0n 0.2000 140099.9n 0.2000 140100.0n 0.2000 140399.9n 0.2000 140400.0n 0.8000 140699.9n 0.8000 140700.0n 0.8000 140999.9n 0.8000 141000.0n 0.2000 141299.9n 0.2000 141300.0n 0.2000 141599.9n 0.2000 141600.0n 0.8000 141899.9n 0.8000 141900.0n 0.8000 142199.9n 0.8000 142200.0n 0.2000 142499.9n 0.2000 142500.0n 0.2000 142799.9n 0.2000 142800.0n 0.8000 143099.9n 0.8000 143100.0n 0.8000 143399.9n 0.8000 143400.0n 0.2000 143699.9n 0.2000 143700.0n 0.2000)
Vx2p a_xp2 0 PWL(0.0n 0.2000 299.9n 0.2000 300.0n 0.8000 599.9n 0.8000 600.0n 0.2000 899.9n 0.2000 900.0n 0.8000 1199.9n 0.8000 1200.0n 0.2000 1499.9n 0.2000 1500.0n 0.8000 1799.9n 0.8000 1800.0n 0.2000 2099.9n 0.2000 2100.0n 0.8000 2399.9n 0.8000 2400.0n 0.2000 2699.9n 0.2000 2700.0n 0.8000 2999.9n 0.8000 3000.0n 0.2000 3299.9n 0.2000 3300.0n 0.8000 3599.9n 0.8000 3600.0n 0.2000 3899.9n 0.2000 3900.0n 0.8000 4199.9n 0.8000 4200.0n 0.2000 4499.9n 0.2000 4500.0n 0.8000 4799.9n 0.8000 4800.0n 0.2000 5099.9n 0.2000 5100.0n 0.8000 5399.9n 0.8000 5400.0n 0.2000 5699.9n 0.2000 5700.0n 0.8000 5999.9n 0.8000 6000.0n 0.2000 6299.9n 0.2000 6300.0n 0.8000 6599.9n 0.8000 6600.0n 0.2000 6899.9n 0.2000 6900.0n 0.8000 7199.9n 0.8000 7200.0n 0.2000 7499.9n 0.2000 7500.0n 0.8000 7799.9n 0.8000 7800.0n 0.2000 8099.9n 0.2000 8100.0n 0.8000 8399.9n 0.8000 8400.0n 0.2000 8699.9n 0.2000 8700.0n 0.8000 8999.9n 0.8000 9000.0n 0.2000 9299.9n 0.2000 9300.0n 0.8000 9599.9n 0.8000 9600.0n 0.2000 9899.9n 0.2000 9900.0n 0.8000 10199.9n 0.8000 10200.0n 0.2000 10499.9n 0.2000 10500.0n 0.8000 10799.9n 0.8000 10800.0n 0.2000 11099.9n 0.2000 11100.0n 0.8000 11399.9n 0.8000 11400.0n 0.2000 11699.9n 0.2000 11700.0n 0.8000 11999.9n 0.8000 12000.0n 0.2000 12299.9n 0.2000 12300.0n 0.8000 12599.9n 0.8000 12600.0n 0.2000 12899.9n 0.2000 12900.0n 0.8000 13199.9n 0.8000 13200.0n 0.2000 13499.9n 0.2000 13500.0n 0.8000 13799.9n 0.8000 13800.0n 0.2000 14099.9n 0.2000 14100.0n 0.8000 14399.9n 0.8000 14400.0n 0.2000 14699.9n 0.2000 14700.0n 0.8000 14999.9n 0.8000 15000.0n 0.2000 15299.9n 0.2000 15300.0n 0.8000 15599.9n 0.8000 15600.0n 0.2000 15899.9n 0.2000 15900.0n 0.8000 16199.9n 0.8000 16200.0n 0.2000 16499.9n 0.2000 16500.0n 0.8000 16799.9n 0.8000 16800.0n 0.2000 17099.9n 0.2000 17100.0n 0.8000 17399.9n 0.8000 17400.0n 0.2000 17699.9n 0.2000 17700.0n 0.8000 17999.9n 0.8000 18000.0n 0.2000 18299.9n 0.2000 18300.0n 0.8000 18599.9n 0.8000 18600.0n 0.2000 18899.9n 0.2000 18900.0n 0.8000 19199.9n 0.8000 19200.0n 0.2000 19499.9n 0.2000 19500.0n 0.8000 19799.9n 0.8000 19800.0n 0.2000 20099.9n 0.2000 20100.0n 0.8000 20399.9n 0.8000 20400.0n 0.2000 20699.9n 0.2000 20700.0n 0.8000 20999.9n 0.8000 21000.0n 0.2000 21299.9n 0.2000 21300.0n 0.8000 21599.9n 0.8000 21600.0n 0.2000 21899.9n 0.2000 21900.0n 0.8000 22199.9n 0.8000 22200.0n 0.2000 22499.9n 0.2000 22500.0n 0.8000 22799.9n 0.8000 22800.0n 0.2000 23099.9n 0.2000 23100.0n 0.8000 23399.9n 0.8000 23400.0n 0.2000 23699.9n 0.2000 23700.0n 0.8000 23999.9n 0.8000 24000.0n 0.2000 24299.9n 0.2000 24300.0n 0.8000 24599.9n 0.8000 24600.0n 0.2000 24899.9n 0.2000 24900.0n 0.8000 25199.9n 0.8000 25200.0n 0.2000 25499.9n 0.2000 25500.0n 0.8000 25799.9n 0.8000 25800.0n 0.2000 26099.9n 0.2000 26100.0n 0.8000 26399.9n 0.8000 26400.0n 0.2000 26699.9n 0.2000 26700.0n 0.8000 26999.9n 0.8000 27000.0n 0.2000 27299.9n 0.2000 27300.0n 0.8000 27599.9n 0.8000 27600.0n 0.2000 27899.9n 0.2000 27900.0n 0.8000 28199.9n 0.8000 28200.0n 0.2000 28499.9n 0.2000 28500.0n 0.8000 28799.9n 0.8000 28800.0n 0.2000 29099.9n 0.2000 29100.0n 0.8000 29399.9n 0.8000 29400.0n 0.2000 29699.9n 0.2000 29700.0n 0.8000 29999.9n 0.8000 30000.0n 0.2000 30299.9n 0.2000 30300.0n 0.8000 30599.9n 0.8000 30600.0n 0.2000 30899.9n 0.2000 30900.0n 0.8000 31199.9n 0.8000 31200.0n 0.2000 31499.9n 0.2000 31500.0n 0.8000 31799.9n 0.8000 31800.0n 0.2000 32099.9n 0.2000 32100.0n 0.8000 32399.9n 0.8000 32400.0n 0.2000 32699.9n 0.2000 32700.0n 0.8000 32999.9n 0.8000 33000.0n 0.2000 33299.9n 0.2000 33300.0n 0.8000 33599.9n 0.8000 33600.0n 0.2000 33899.9n 0.2000 33900.0n 0.8000 34199.9n 0.8000 34200.0n 0.2000 34499.9n 0.2000 34500.0n 0.8000 34799.9n 0.8000 34800.0n 0.2000 35099.9n 0.2000 35100.0n 0.8000 35399.9n 0.8000 35400.0n 0.2000 35699.9n 0.2000 35700.0n 0.8000 35999.9n 0.8000 36000.0n 0.2000 36299.9n 0.2000 36300.0n 0.8000 36599.9n 0.8000 36600.0n 0.2000 36899.9n 0.2000 36900.0n 0.8000 37199.9n 0.8000 37200.0n 0.2000 37499.9n 0.2000 37500.0n 0.8000 37799.9n 0.8000 37800.0n 0.2000 38099.9n 0.2000 38100.0n 0.8000 38399.9n 0.8000 38400.0n 0.2000 38699.9n 0.2000 38700.0n 0.8000 38999.9n 0.8000 39000.0n 0.2000 39299.9n 0.2000 39300.0n 0.8000 39599.9n 0.8000 39600.0n 0.2000 39899.9n 0.2000 39900.0n 0.8000 40199.9n 0.8000 40200.0n 0.2000 40499.9n 0.2000 40500.0n 0.8000 40799.9n 0.8000 40800.0n 0.2000 41099.9n 0.2000 41100.0n 0.8000 41399.9n 0.8000 41400.0n 0.2000 41699.9n 0.2000 41700.0n 0.8000 41999.9n 0.8000 42000.0n 0.2000 42299.9n 0.2000 42300.0n 0.8000 42599.9n 0.8000 42600.0n 0.2000 42899.9n 0.2000 42900.0n 0.8000 43199.9n 0.8000 43200.0n 0.2000 43499.9n 0.2000 43500.0n 0.8000 43799.9n 0.8000 43800.0n 0.2000 44099.9n 0.2000 44100.0n 0.8000 44399.9n 0.8000 44400.0n 0.2000 44699.9n 0.2000 44700.0n 0.8000 44999.9n 0.8000 45000.0n 0.2000 45299.9n 0.2000 45300.0n 0.8000 45599.9n 0.8000 45600.0n 0.2000 45899.9n 0.2000 45900.0n 0.8000 46199.9n 0.8000 46200.0n 0.2000 46499.9n 0.2000 46500.0n 0.8000 46799.9n 0.8000 46800.0n 0.2000 47099.9n 0.2000 47100.0n 0.8000 47399.9n 0.8000 47400.0n 0.2000 47699.9n 0.2000 47700.0n 0.8000 47999.9n 0.8000 48000.0n 0.2000 48299.9n 0.2000 48300.0n 0.8000 48599.9n 0.8000 48600.0n 0.2000 48899.9n 0.2000 48900.0n 0.8000 49199.9n 0.8000 49200.0n 0.2000 49499.9n 0.2000 49500.0n 0.8000 49799.9n 0.8000 49800.0n 0.2000 50099.9n 0.2000 50100.0n 0.8000 50399.9n 0.8000 50400.0n 0.2000 50699.9n 0.2000 50700.0n 0.8000 50999.9n 0.8000 51000.0n 0.2000 51299.9n 0.2000 51300.0n 0.8000 51599.9n 0.8000 51600.0n 0.2000 51899.9n 0.2000 51900.0n 0.8000 52199.9n 0.8000 52200.0n 0.2000 52499.9n 0.2000 52500.0n 0.8000 52799.9n 0.8000 52800.0n 0.2000 53099.9n 0.2000 53100.0n 0.8000 53399.9n 0.8000 53400.0n 0.2000 53699.9n 0.2000 53700.0n 0.8000 53999.9n 0.8000 54000.0n 0.2000 54299.9n 0.2000 54300.0n 0.8000 54599.9n 0.8000 54600.0n 0.2000 54899.9n 0.2000 54900.0n 0.8000 55199.9n 0.8000 55200.0n 0.2000 55499.9n 0.2000 55500.0n 0.8000 55799.9n 0.8000 55800.0n 0.2000 56099.9n 0.2000 56100.0n 0.8000 56399.9n 0.8000 56400.0n 0.2000 56699.9n 0.2000 56700.0n 0.8000 56999.9n 0.8000 57000.0n 0.2000 57299.9n 0.2000 57300.0n 0.8000 57599.9n 0.8000 57600.0n 0.2000 57899.9n 0.2000 57900.0n 0.8000 58199.9n 0.8000 58200.0n 0.2000 58499.9n 0.2000 58500.0n 0.8000 58799.9n 0.8000 58800.0n 0.2000 59099.9n 0.2000 59100.0n 0.8000 59399.9n 0.8000 59400.0n 0.2000 59699.9n 0.2000 59700.0n 0.8000 59999.9n 0.8000 60000.0n 0.2000 60299.9n 0.2000 60300.0n 0.8000 60599.9n 0.8000 60600.0n 0.2000 60899.9n 0.2000 60900.0n 0.8000 61199.9n 0.8000 61200.0n 0.2000 61499.9n 0.2000 61500.0n 0.8000 61799.9n 0.8000 61800.0n 0.2000 62099.9n 0.2000 62100.0n 0.8000 62399.9n 0.8000 62400.0n 0.2000 62699.9n 0.2000 62700.0n 0.8000 62999.9n 0.8000 63000.0n 0.2000 63299.9n 0.2000 63300.0n 0.8000 63599.9n 0.8000 63600.0n 0.2000 63899.9n 0.2000 63900.0n 0.8000 64199.9n 0.8000 64200.0n 0.2000 64499.9n 0.2000 64500.0n 0.8000 64799.9n 0.8000 64800.0n 0.2000 65099.9n 0.2000 65100.0n 0.8000 65399.9n 0.8000 65400.0n 0.2000 65699.9n 0.2000 65700.0n 0.8000 65999.9n 0.8000 66000.0n 0.2000 66299.9n 0.2000 66300.0n 0.8000 66599.9n 0.8000 66600.0n 0.2000 66899.9n 0.2000 66900.0n 0.8000 67199.9n 0.8000 67200.0n 0.2000 67499.9n 0.2000 67500.0n 0.8000 67799.9n 0.8000 67800.0n 0.2000 68099.9n 0.2000 68100.0n 0.8000 68399.9n 0.8000 68400.0n 0.2000 68699.9n 0.2000 68700.0n 0.8000 68999.9n 0.8000 69000.0n 0.2000 69299.9n 0.2000 69300.0n 0.8000 69599.9n 0.8000 69600.0n 0.2000 69899.9n 0.2000 69900.0n 0.8000 70199.9n 0.8000 70200.0n 0.2000 70499.9n 0.2000 70500.0n 0.8000 70799.9n 0.8000 70800.0n 0.2000 71099.9n 0.2000 71100.0n 0.8000 71399.9n 0.8000 71400.0n 0.2000 71699.9n 0.2000 71700.0n 0.8000 71999.9n 0.8000 72000.0n 0.2000 72299.9n 0.2000 72300.0n 0.8000 72599.9n 0.8000 72600.0n 0.2000 72899.9n 0.2000 72900.0n 0.8000 73199.9n 0.8000 73200.0n 0.2000 73499.9n 0.2000 73500.0n 0.8000 73799.9n 0.8000 73800.0n 0.2000 74099.9n 0.2000 74100.0n 0.8000 74399.9n 0.8000 74400.0n 0.2000 74699.9n 0.2000 74700.0n 0.8000 74999.9n 0.8000 75000.0n 0.2000 75299.9n 0.2000 75300.0n 0.8000 75599.9n 0.8000 75600.0n 0.2000 75899.9n 0.2000 75900.0n 0.8000 76199.9n 0.8000 76200.0n 0.2000 76499.9n 0.2000 76500.0n 0.8000 76799.9n 0.8000 76800.0n 0.2000 77099.9n 0.2000 77100.0n 0.8000 77399.9n 0.8000 77400.0n 0.2000 77699.9n 0.2000 77700.0n 0.8000 77999.9n 0.8000 78000.0n 0.2000 78299.9n 0.2000 78300.0n 0.8000 78599.9n 0.8000 78600.0n 0.2000 78899.9n 0.2000 78900.0n 0.8000 79199.9n 0.8000 79200.0n 0.2000 79499.9n 0.2000 79500.0n 0.8000 79799.9n 0.8000 79800.0n 0.2000 80099.9n 0.2000 80100.0n 0.8000 80399.9n 0.8000 80400.0n 0.2000 80699.9n 0.2000 80700.0n 0.8000 80999.9n 0.8000 81000.0n 0.2000 81299.9n 0.2000 81300.0n 0.8000 81599.9n 0.8000 81600.0n 0.2000 81899.9n 0.2000 81900.0n 0.8000 82199.9n 0.8000 82200.0n 0.2000 82499.9n 0.2000 82500.0n 0.8000 82799.9n 0.8000 82800.0n 0.2000 83099.9n 0.2000 83100.0n 0.8000 83399.9n 0.8000 83400.0n 0.2000 83699.9n 0.2000 83700.0n 0.8000 83999.9n 0.8000 84000.0n 0.2000 84299.9n 0.2000 84300.0n 0.8000 84599.9n 0.8000 84600.0n 0.2000 84899.9n 0.2000 84900.0n 0.8000 85199.9n 0.8000 85200.0n 0.2000 85499.9n 0.2000 85500.0n 0.8000 85799.9n 0.8000 85800.0n 0.2000 86099.9n 0.2000 86100.0n 0.8000 86399.9n 0.8000 86400.0n 0.2000 86699.9n 0.2000 86700.0n 0.8000 86999.9n 0.8000 87000.0n 0.2000 87299.9n 0.2000 87300.0n 0.8000 87599.9n 0.8000 87600.0n 0.2000 87899.9n 0.2000 87900.0n 0.8000 88199.9n 0.8000 88200.0n 0.2000 88499.9n 0.2000 88500.0n 0.8000 88799.9n 0.8000 88800.0n 0.2000 89099.9n 0.2000 89100.0n 0.8000 89399.9n 0.8000 89400.0n 0.2000 89699.9n 0.2000 89700.0n 0.8000 89999.9n 0.8000 90000.0n 0.2000 90299.9n 0.2000 90300.0n 0.8000 90599.9n 0.8000 90600.0n 0.2000 90899.9n 0.2000 90900.0n 0.8000 91199.9n 0.8000 91200.0n 0.2000 91499.9n 0.2000 91500.0n 0.8000 91799.9n 0.8000 91800.0n 0.2000 92099.9n 0.2000 92100.0n 0.8000 92399.9n 0.8000 92400.0n 0.2000 92699.9n 0.2000 92700.0n 0.8000 92999.9n 0.8000 93000.0n 0.2000 93299.9n 0.2000 93300.0n 0.8000 93599.9n 0.8000 93600.0n 0.2000 93899.9n 0.2000 93900.0n 0.8000 94199.9n 0.8000 94200.0n 0.2000 94499.9n 0.2000 94500.0n 0.8000 94799.9n 0.8000 94800.0n 0.2000 95099.9n 0.2000 95100.0n 0.8000 95399.9n 0.8000 95400.0n 0.2000 95699.9n 0.2000 95700.0n 0.8000 95999.9n 0.8000 96000.0n 0.2000 96299.9n 0.2000 96300.0n 0.8000 96599.9n 0.8000 96600.0n 0.2000 96899.9n 0.2000 96900.0n 0.8000 97199.9n 0.8000 97200.0n 0.2000 97499.9n 0.2000 97500.0n 0.8000 97799.9n 0.8000 97800.0n 0.2000 98099.9n 0.2000 98100.0n 0.8000 98399.9n 0.8000 98400.0n 0.2000 98699.9n 0.2000 98700.0n 0.8000 98999.9n 0.8000 99000.0n 0.2000 99299.9n 0.2000 99300.0n 0.8000 99599.9n 0.8000 99600.0n 0.2000 99899.9n 0.2000 99900.0n 0.8000 100199.9n 0.8000 100200.0n 0.2000 100499.9n 0.2000 100500.0n 0.8000 100799.9n 0.8000 100800.0n 0.2000 101099.9n 0.2000 101100.0n 0.8000 101399.9n 0.8000 101400.0n 0.2000 101699.9n 0.2000 101700.0n 0.8000 101999.9n 0.8000 102000.0n 0.2000 102299.9n 0.2000 102300.0n 0.8000 102599.9n 0.8000 102600.0n 0.2000 102899.9n 0.2000 102900.0n 0.8000 103199.9n 0.8000 103200.0n 0.2000 103499.9n 0.2000 103500.0n 0.8000 103799.9n 0.8000 103800.0n 0.2000 104099.9n 0.2000 104100.0n 0.8000 104399.9n 0.8000 104400.0n 0.2000 104699.9n 0.2000 104700.0n 0.8000 104999.9n 0.8000 105000.0n 0.2000 105299.9n 0.2000 105300.0n 0.8000 105599.9n 0.8000 105600.0n 0.2000 105899.9n 0.2000 105900.0n 0.8000 106199.9n 0.8000 106200.0n 0.2000 106499.9n 0.2000 106500.0n 0.8000 106799.9n 0.8000 106800.0n 0.2000 107099.9n 0.2000 107100.0n 0.8000 107399.9n 0.8000 107400.0n 0.2000 107699.9n 0.2000 107700.0n 0.8000 107999.9n 0.8000 108000.0n 0.2000 108299.9n 0.2000 108300.0n 0.8000 108599.9n 0.8000 108600.0n 0.2000 108899.9n 0.2000 108900.0n 0.8000 109199.9n 0.8000 109200.0n 0.2000 109499.9n 0.2000 109500.0n 0.8000 109799.9n 0.8000 109800.0n 0.2000 110099.9n 0.2000 110100.0n 0.8000 110399.9n 0.8000 110400.0n 0.2000 110699.9n 0.2000 110700.0n 0.8000 110999.9n 0.8000 111000.0n 0.2000 111299.9n 0.2000 111300.0n 0.8000 111599.9n 0.8000 111600.0n 0.2000 111899.9n 0.2000 111900.0n 0.8000 112199.9n 0.8000 112200.0n 0.2000 112499.9n 0.2000 112500.0n 0.8000 112799.9n 0.8000 112800.0n 0.2000 113099.9n 0.2000 113100.0n 0.8000 113399.9n 0.8000 113400.0n 0.2000 113699.9n 0.2000 113700.0n 0.8000 113999.9n 0.8000 114000.0n 0.2000 114299.9n 0.2000 114300.0n 0.8000 114599.9n 0.8000 114600.0n 0.2000 114899.9n 0.2000 114900.0n 0.8000 115199.9n 0.8000 115200.0n 0.2000 115499.9n 0.2000 115500.0n 0.8000 115799.9n 0.8000 115800.0n 0.2000 116099.9n 0.2000 116100.0n 0.8000 116399.9n 0.8000 116400.0n 0.2000 116699.9n 0.2000 116700.0n 0.8000 116999.9n 0.8000 117000.0n 0.2000 117299.9n 0.2000 117300.0n 0.8000 117599.9n 0.8000 117600.0n 0.2000 117899.9n 0.2000 117900.0n 0.8000 118199.9n 0.8000 118200.0n 0.2000 118499.9n 0.2000 118500.0n 0.8000 118799.9n 0.8000 118800.0n 0.2000 119099.9n 0.2000 119100.0n 0.8000 119399.9n 0.8000 119400.0n 0.2000 119699.9n 0.2000 119700.0n 0.8000 119999.9n 0.8000 120000.0n 0.2000 120299.9n 0.2000 120300.0n 0.8000 120599.9n 0.8000 120600.0n 0.2000 120899.9n 0.2000 120900.0n 0.8000 121199.9n 0.8000 121200.0n 0.2000 121499.9n 0.2000 121500.0n 0.8000 121799.9n 0.8000 121800.0n 0.2000 122099.9n 0.2000 122100.0n 0.8000 122399.9n 0.8000 122400.0n 0.2000 122699.9n 0.2000 122700.0n 0.8000 122999.9n 0.8000 123000.0n 0.2000 123299.9n 0.2000 123300.0n 0.8000 123599.9n 0.8000 123600.0n 0.2000 123899.9n 0.2000 123900.0n 0.8000 124199.9n 0.8000 124200.0n 0.2000 124499.9n 0.2000 124500.0n 0.8000 124799.9n 0.8000 124800.0n 0.2000 125099.9n 0.2000 125100.0n 0.8000 125399.9n 0.8000 125400.0n 0.2000 125699.9n 0.2000 125700.0n 0.8000 125999.9n 0.8000 126000.0n 0.2000 126299.9n 0.2000 126300.0n 0.8000 126599.9n 0.8000 126600.0n 0.2000 126899.9n 0.2000 126900.0n 0.8000 127199.9n 0.8000 127200.0n 0.2000 127499.9n 0.2000 127500.0n 0.8000 127799.9n 0.8000 127800.0n 0.2000 128099.9n 0.2000 128100.0n 0.8000 128399.9n 0.8000 128400.0n 0.2000 128699.9n 0.2000 128700.0n 0.8000 128999.9n 0.8000 129000.0n 0.2000 129299.9n 0.2000 129300.0n 0.8000 129599.9n 0.8000 129600.0n 0.2000 129899.9n 0.2000 129900.0n 0.8000 130199.9n 0.8000 130200.0n 0.2000 130499.9n 0.2000 130500.0n 0.8000 130799.9n 0.8000 130800.0n 0.2000 131099.9n 0.2000 131100.0n 0.8000 131399.9n 0.8000 131400.0n 0.2000 131699.9n 0.2000 131700.0n 0.8000 131999.9n 0.8000 132000.0n 0.2000 132299.9n 0.2000 132300.0n 0.8000 132599.9n 0.8000 132600.0n 0.2000 132899.9n 0.2000 132900.0n 0.8000 133199.9n 0.8000 133200.0n 0.2000 133499.9n 0.2000 133500.0n 0.8000 133799.9n 0.8000 133800.0n 0.2000 134099.9n 0.2000 134100.0n 0.8000 134399.9n 0.8000 134400.0n 0.2000 134699.9n 0.2000 134700.0n 0.8000 134999.9n 0.8000 135000.0n 0.2000 135299.9n 0.2000 135300.0n 0.8000 135599.9n 0.8000 135600.0n 0.2000 135899.9n 0.2000 135900.0n 0.8000 136199.9n 0.8000 136200.0n 0.2000 136499.9n 0.2000 136500.0n 0.8000 136799.9n 0.8000 136800.0n 0.2000 137099.9n 0.2000 137100.0n 0.8000 137399.9n 0.8000 137400.0n 0.2000 137699.9n 0.2000 137700.0n 0.8000 137999.9n 0.8000 138000.0n 0.2000 138299.9n 0.2000 138300.0n 0.8000 138599.9n 0.8000 138600.0n 0.2000 138899.9n 0.2000 138900.0n 0.8000 139199.9n 0.8000 139200.0n 0.2000 139499.9n 0.2000 139500.0n 0.8000 139799.9n 0.8000 139800.0n 0.2000 140099.9n 0.2000 140100.0n 0.8000 140399.9n 0.8000 140400.0n 0.2000 140699.9n 0.2000 140700.0n 0.8000 140999.9n 0.8000 141000.0n 0.2000 141299.9n 0.2000 141300.0n 0.8000 141599.9n 0.8000 141600.0n 0.2000 141899.9n 0.2000 141900.0n 0.8000 142199.9n 0.8000 142200.0n 0.2000 142499.9n 0.2000 142500.0n 0.8000 142799.9n 0.8000 142800.0n 0.2000 143099.9n 0.2000 143100.0n 0.8000 143399.9n 0.8000 143400.0n 0.2000 143699.9n 0.2000 143700.0n 0.8000)
Vx2n a_xn2 0 PWL(0.0n 0.8000 299.9n 0.8000 300.0n 0.2000 599.9n 0.2000 600.0n 0.8000 899.9n 0.8000 900.0n 0.2000 1199.9n 0.2000 1200.0n 0.8000 1499.9n 0.8000 1500.0n 0.2000 1799.9n 0.2000 1800.0n 0.8000 2099.9n 0.8000 2100.0n 0.2000 2399.9n 0.2000 2400.0n 0.8000 2699.9n 0.8000 2700.0n 0.2000 2999.9n 0.2000 3000.0n 0.8000 3299.9n 0.8000 3300.0n 0.2000 3599.9n 0.2000 3600.0n 0.8000 3899.9n 0.8000 3900.0n 0.2000 4199.9n 0.2000 4200.0n 0.8000 4499.9n 0.8000 4500.0n 0.2000 4799.9n 0.2000 4800.0n 0.8000 5099.9n 0.8000 5100.0n 0.2000 5399.9n 0.2000 5400.0n 0.8000 5699.9n 0.8000 5700.0n 0.2000 5999.9n 0.2000 6000.0n 0.8000 6299.9n 0.8000 6300.0n 0.2000 6599.9n 0.2000 6600.0n 0.8000 6899.9n 0.8000 6900.0n 0.2000 7199.9n 0.2000 7200.0n 0.8000 7499.9n 0.8000 7500.0n 0.2000 7799.9n 0.2000 7800.0n 0.8000 8099.9n 0.8000 8100.0n 0.2000 8399.9n 0.2000 8400.0n 0.8000 8699.9n 0.8000 8700.0n 0.2000 8999.9n 0.2000 9000.0n 0.8000 9299.9n 0.8000 9300.0n 0.2000 9599.9n 0.2000 9600.0n 0.8000 9899.9n 0.8000 9900.0n 0.2000 10199.9n 0.2000 10200.0n 0.8000 10499.9n 0.8000 10500.0n 0.2000 10799.9n 0.2000 10800.0n 0.8000 11099.9n 0.8000 11100.0n 0.2000 11399.9n 0.2000 11400.0n 0.8000 11699.9n 0.8000 11700.0n 0.2000 11999.9n 0.2000 12000.0n 0.8000 12299.9n 0.8000 12300.0n 0.2000 12599.9n 0.2000 12600.0n 0.8000 12899.9n 0.8000 12900.0n 0.2000 13199.9n 0.2000 13200.0n 0.8000 13499.9n 0.8000 13500.0n 0.2000 13799.9n 0.2000 13800.0n 0.8000 14099.9n 0.8000 14100.0n 0.2000 14399.9n 0.2000 14400.0n 0.8000 14699.9n 0.8000 14700.0n 0.2000 14999.9n 0.2000 15000.0n 0.8000 15299.9n 0.8000 15300.0n 0.2000 15599.9n 0.2000 15600.0n 0.8000 15899.9n 0.8000 15900.0n 0.2000 16199.9n 0.2000 16200.0n 0.8000 16499.9n 0.8000 16500.0n 0.2000 16799.9n 0.2000 16800.0n 0.8000 17099.9n 0.8000 17100.0n 0.2000 17399.9n 0.2000 17400.0n 0.8000 17699.9n 0.8000 17700.0n 0.2000 17999.9n 0.2000 18000.0n 0.8000 18299.9n 0.8000 18300.0n 0.2000 18599.9n 0.2000 18600.0n 0.8000 18899.9n 0.8000 18900.0n 0.2000 19199.9n 0.2000 19200.0n 0.8000 19499.9n 0.8000 19500.0n 0.2000 19799.9n 0.2000 19800.0n 0.8000 20099.9n 0.8000 20100.0n 0.2000 20399.9n 0.2000 20400.0n 0.8000 20699.9n 0.8000 20700.0n 0.2000 20999.9n 0.2000 21000.0n 0.8000 21299.9n 0.8000 21300.0n 0.2000 21599.9n 0.2000 21600.0n 0.8000 21899.9n 0.8000 21900.0n 0.2000 22199.9n 0.2000 22200.0n 0.8000 22499.9n 0.8000 22500.0n 0.2000 22799.9n 0.2000 22800.0n 0.8000 23099.9n 0.8000 23100.0n 0.2000 23399.9n 0.2000 23400.0n 0.8000 23699.9n 0.8000 23700.0n 0.2000 23999.9n 0.2000 24000.0n 0.8000 24299.9n 0.8000 24300.0n 0.2000 24599.9n 0.2000 24600.0n 0.8000 24899.9n 0.8000 24900.0n 0.2000 25199.9n 0.2000 25200.0n 0.8000 25499.9n 0.8000 25500.0n 0.2000 25799.9n 0.2000 25800.0n 0.8000 26099.9n 0.8000 26100.0n 0.2000 26399.9n 0.2000 26400.0n 0.8000 26699.9n 0.8000 26700.0n 0.2000 26999.9n 0.2000 27000.0n 0.8000 27299.9n 0.8000 27300.0n 0.2000 27599.9n 0.2000 27600.0n 0.8000 27899.9n 0.8000 27900.0n 0.2000 28199.9n 0.2000 28200.0n 0.8000 28499.9n 0.8000 28500.0n 0.2000 28799.9n 0.2000 28800.0n 0.8000 29099.9n 0.8000 29100.0n 0.2000 29399.9n 0.2000 29400.0n 0.8000 29699.9n 0.8000 29700.0n 0.2000 29999.9n 0.2000 30000.0n 0.8000 30299.9n 0.8000 30300.0n 0.2000 30599.9n 0.2000 30600.0n 0.8000 30899.9n 0.8000 30900.0n 0.2000 31199.9n 0.2000 31200.0n 0.8000 31499.9n 0.8000 31500.0n 0.2000 31799.9n 0.2000 31800.0n 0.8000 32099.9n 0.8000 32100.0n 0.2000 32399.9n 0.2000 32400.0n 0.8000 32699.9n 0.8000 32700.0n 0.2000 32999.9n 0.2000 33000.0n 0.8000 33299.9n 0.8000 33300.0n 0.2000 33599.9n 0.2000 33600.0n 0.8000 33899.9n 0.8000 33900.0n 0.2000 34199.9n 0.2000 34200.0n 0.8000 34499.9n 0.8000 34500.0n 0.2000 34799.9n 0.2000 34800.0n 0.8000 35099.9n 0.8000 35100.0n 0.2000 35399.9n 0.2000 35400.0n 0.8000 35699.9n 0.8000 35700.0n 0.2000 35999.9n 0.2000 36000.0n 0.8000 36299.9n 0.8000 36300.0n 0.2000 36599.9n 0.2000 36600.0n 0.8000 36899.9n 0.8000 36900.0n 0.2000 37199.9n 0.2000 37200.0n 0.8000 37499.9n 0.8000 37500.0n 0.2000 37799.9n 0.2000 37800.0n 0.8000 38099.9n 0.8000 38100.0n 0.2000 38399.9n 0.2000 38400.0n 0.8000 38699.9n 0.8000 38700.0n 0.2000 38999.9n 0.2000 39000.0n 0.8000 39299.9n 0.8000 39300.0n 0.2000 39599.9n 0.2000 39600.0n 0.8000 39899.9n 0.8000 39900.0n 0.2000 40199.9n 0.2000 40200.0n 0.8000 40499.9n 0.8000 40500.0n 0.2000 40799.9n 0.2000 40800.0n 0.8000 41099.9n 0.8000 41100.0n 0.2000 41399.9n 0.2000 41400.0n 0.8000 41699.9n 0.8000 41700.0n 0.2000 41999.9n 0.2000 42000.0n 0.8000 42299.9n 0.8000 42300.0n 0.2000 42599.9n 0.2000 42600.0n 0.8000 42899.9n 0.8000 42900.0n 0.2000 43199.9n 0.2000 43200.0n 0.8000 43499.9n 0.8000 43500.0n 0.2000 43799.9n 0.2000 43800.0n 0.8000 44099.9n 0.8000 44100.0n 0.2000 44399.9n 0.2000 44400.0n 0.8000 44699.9n 0.8000 44700.0n 0.2000 44999.9n 0.2000 45000.0n 0.8000 45299.9n 0.8000 45300.0n 0.2000 45599.9n 0.2000 45600.0n 0.8000 45899.9n 0.8000 45900.0n 0.2000 46199.9n 0.2000 46200.0n 0.8000 46499.9n 0.8000 46500.0n 0.2000 46799.9n 0.2000 46800.0n 0.8000 47099.9n 0.8000 47100.0n 0.2000 47399.9n 0.2000 47400.0n 0.8000 47699.9n 0.8000 47700.0n 0.2000 47999.9n 0.2000 48000.0n 0.8000 48299.9n 0.8000 48300.0n 0.2000 48599.9n 0.2000 48600.0n 0.8000 48899.9n 0.8000 48900.0n 0.2000 49199.9n 0.2000 49200.0n 0.8000 49499.9n 0.8000 49500.0n 0.2000 49799.9n 0.2000 49800.0n 0.8000 50099.9n 0.8000 50100.0n 0.2000 50399.9n 0.2000 50400.0n 0.8000 50699.9n 0.8000 50700.0n 0.2000 50999.9n 0.2000 51000.0n 0.8000 51299.9n 0.8000 51300.0n 0.2000 51599.9n 0.2000 51600.0n 0.8000 51899.9n 0.8000 51900.0n 0.2000 52199.9n 0.2000 52200.0n 0.8000 52499.9n 0.8000 52500.0n 0.2000 52799.9n 0.2000 52800.0n 0.8000 53099.9n 0.8000 53100.0n 0.2000 53399.9n 0.2000 53400.0n 0.8000 53699.9n 0.8000 53700.0n 0.2000 53999.9n 0.2000 54000.0n 0.8000 54299.9n 0.8000 54300.0n 0.2000 54599.9n 0.2000 54600.0n 0.8000 54899.9n 0.8000 54900.0n 0.2000 55199.9n 0.2000 55200.0n 0.8000 55499.9n 0.8000 55500.0n 0.2000 55799.9n 0.2000 55800.0n 0.8000 56099.9n 0.8000 56100.0n 0.2000 56399.9n 0.2000 56400.0n 0.8000 56699.9n 0.8000 56700.0n 0.2000 56999.9n 0.2000 57000.0n 0.8000 57299.9n 0.8000 57300.0n 0.2000 57599.9n 0.2000 57600.0n 0.8000 57899.9n 0.8000 57900.0n 0.2000 58199.9n 0.2000 58200.0n 0.8000 58499.9n 0.8000 58500.0n 0.2000 58799.9n 0.2000 58800.0n 0.8000 59099.9n 0.8000 59100.0n 0.2000 59399.9n 0.2000 59400.0n 0.8000 59699.9n 0.8000 59700.0n 0.2000 59999.9n 0.2000 60000.0n 0.8000 60299.9n 0.8000 60300.0n 0.2000 60599.9n 0.2000 60600.0n 0.8000 60899.9n 0.8000 60900.0n 0.2000 61199.9n 0.2000 61200.0n 0.8000 61499.9n 0.8000 61500.0n 0.2000 61799.9n 0.2000 61800.0n 0.8000 62099.9n 0.8000 62100.0n 0.2000 62399.9n 0.2000 62400.0n 0.8000 62699.9n 0.8000 62700.0n 0.2000 62999.9n 0.2000 63000.0n 0.8000 63299.9n 0.8000 63300.0n 0.2000 63599.9n 0.2000 63600.0n 0.8000 63899.9n 0.8000 63900.0n 0.2000 64199.9n 0.2000 64200.0n 0.8000 64499.9n 0.8000 64500.0n 0.2000 64799.9n 0.2000 64800.0n 0.8000 65099.9n 0.8000 65100.0n 0.2000 65399.9n 0.2000 65400.0n 0.8000 65699.9n 0.8000 65700.0n 0.2000 65999.9n 0.2000 66000.0n 0.8000 66299.9n 0.8000 66300.0n 0.2000 66599.9n 0.2000 66600.0n 0.8000 66899.9n 0.8000 66900.0n 0.2000 67199.9n 0.2000 67200.0n 0.8000 67499.9n 0.8000 67500.0n 0.2000 67799.9n 0.2000 67800.0n 0.8000 68099.9n 0.8000 68100.0n 0.2000 68399.9n 0.2000 68400.0n 0.8000 68699.9n 0.8000 68700.0n 0.2000 68999.9n 0.2000 69000.0n 0.8000 69299.9n 0.8000 69300.0n 0.2000 69599.9n 0.2000 69600.0n 0.8000 69899.9n 0.8000 69900.0n 0.2000 70199.9n 0.2000 70200.0n 0.8000 70499.9n 0.8000 70500.0n 0.2000 70799.9n 0.2000 70800.0n 0.8000 71099.9n 0.8000 71100.0n 0.2000 71399.9n 0.2000 71400.0n 0.8000 71699.9n 0.8000 71700.0n 0.2000 71999.9n 0.2000 72000.0n 0.8000 72299.9n 0.8000 72300.0n 0.2000 72599.9n 0.2000 72600.0n 0.8000 72899.9n 0.8000 72900.0n 0.2000 73199.9n 0.2000 73200.0n 0.8000 73499.9n 0.8000 73500.0n 0.2000 73799.9n 0.2000 73800.0n 0.8000 74099.9n 0.8000 74100.0n 0.2000 74399.9n 0.2000 74400.0n 0.8000 74699.9n 0.8000 74700.0n 0.2000 74999.9n 0.2000 75000.0n 0.8000 75299.9n 0.8000 75300.0n 0.2000 75599.9n 0.2000 75600.0n 0.8000 75899.9n 0.8000 75900.0n 0.2000 76199.9n 0.2000 76200.0n 0.8000 76499.9n 0.8000 76500.0n 0.2000 76799.9n 0.2000 76800.0n 0.8000 77099.9n 0.8000 77100.0n 0.2000 77399.9n 0.2000 77400.0n 0.8000 77699.9n 0.8000 77700.0n 0.2000 77999.9n 0.2000 78000.0n 0.8000 78299.9n 0.8000 78300.0n 0.2000 78599.9n 0.2000 78600.0n 0.8000 78899.9n 0.8000 78900.0n 0.2000 79199.9n 0.2000 79200.0n 0.8000 79499.9n 0.8000 79500.0n 0.2000 79799.9n 0.2000 79800.0n 0.8000 80099.9n 0.8000 80100.0n 0.2000 80399.9n 0.2000 80400.0n 0.8000 80699.9n 0.8000 80700.0n 0.2000 80999.9n 0.2000 81000.0n 0.8000 81299.9n 0.8000 81300.0n 0.2000 81599.9n 0.2000 81600.0n 0.8000 81899.9n 0.8000 81900.0n 0.2000 82199.9n 0.2000 82200.0n 0.8000 82499.9n 0.8000 82500.0n 0.2000 82799.9n 0.2000 82800.0n 0.8000 83099.9n 0.8000 83100.0n 0.2000 83399.9n 0.2000 83400.0n 0.8000 83699.9n 0.8000 83700.0n 0.2000 83999.9n 0.2000 84000.0n 0.8000 84299.9n 0.8000 84300.0n 0.2000 84599.9n 0.2000 84600.0n 0.8000 84899.9n 0.8000 84900.0n 0.2000 85199.9n 0.2000 85200.0n 0.8000 85499.9n 0.8000 85500.0n 0.2000 85799.9n 0.2000 85800.0n 0.8000 86099.9n 0.8000 86100.0n 0.2000 86399.9n 0.2000 86400.0n 0.8000 86699.9n 0.8000 86700.0n 0.2000 86999.9n 0.2000 87000.0n 0.8000 87299.9n 0.8000 87300.0n 0.2000 87599.9n 0.2000 87600.0n 0.8000 87899.9n 0.8000 87900.0n 0.2000 88199.9n 0.2000 88200.0n 0.8000 88499.9n 0.8000 88500.0n 0.2000 88799.9n 0.2000 88800.0n 0.8000 89099.9n 0.8000 89100.0n 0.2000 89399.9n 0.2000 89400.0n 0.8000 89699.9n 0.8000 89700.0n 0.2000 89999.9n 0.2000 90000.0n 0.8000 90299.9n 0.8000 90300.0n 0.2000 90599.9n 0.2000 90600.0n 0.8000 90899.9n 0.8000 90900.0n 0.2000 91199.9n 0.2000 91200.0n 0.8000 91499.9n 0.8000 91500.0n 0.2000 91799.9n 0.2000 91800.0n 0.8000 92099.9n 0.8000 92100.0n 0.2000 92399.9n 0.2000 92400.0n 0.8000 92699.9n 0.8000 92700.0n 0.2000 92999.9n 0.2000 93000.0n 0.8000 93299.9n 0.8000 93300.0n 0.2000 93599.9n 0.2000 93600.0n 0.8000 93899.9n 0.8000 93900.0n 0.2000 94199.9n 0.2000 94200.0n 0.8000 94499.9n 0.8000 94500.0n 0.2000 94799.9n 0.2000 94800.0n 0.8000 95099.9n 0.8000 95100.0n 0.2000 95399.9n 0.2000 95400.0n 0.8000 95699.9n 0.8000 95700.0n 0.2000 95999.9n 0.2000 96000.0n 0.8000 96299.9n 0.8000 96300.0n 0.2000 96599.9n 0.2000 96600.0n 0.8000 96899.9n 0.8000 96900.0n 0.2000 97199.9n 0.2000 97200.0n 0.8000 97499.9n 0.8000 97500.0n 0.2000 97799.9n 0.2000 97800.0n 0.8000 98099.9n 0.8000 98100.0n 0.2000 98399.9n 0.2000 98400.0n 0.8000 98699.9n 0.8000 98700.0n 0.2000 98999.9n 0.2000 99000.0n 0.8000 99299.9n 0.8000 99300.0n 0.2000 99599.9n 0.2000 99600.0n 0.8000 99899.9n 0.8000 99900.0n 0.2000 100199.9n 0.2000 100200.0n 0.8000 100499.9n 0.8000 100500.0n 0.2000 100799.9n 0.2000 100800.0n 0.8000 101099.9n 0.8000 101100.0n 0.2000 101399.9n 0.2000 101400.0n 0.8000 101699.9n 0.8000 101700.0n 0.2000 101999.9n 0.2000 102000.0n 0.8000 102299.9n 0.8000 102300.0n 0.2000 102599.9n 0.2000 102600.0n 0.8000 102899.9n 0.8000 102900.0n 0.2000 103199.9n 0.2000 103200.0n 0.8000 103499.9n 0.8000 103500.0n 0.2000 103799.9n 0.2000 103800.0n 0.8000 104099.9n 0.8000 104100.0n 0.2000 104399.9n 0.2000 104400.0n 0.8000 104699.9n 0.8000 104700.0n 0.2000 104999.9n 0.2000 105000.0n 0.8000 105299.9n 0.8000 105300.0n 0.2000 105599.9n 0.2000 105600.0n 0.8000 105899.9n 0.8000 105900.0n 0.2000 106199.9n 0.2000 106200.0n 0.8000 106499.9n 0.8000 106500.0n 0.2000 106799.9n 0.2000 106800.0n 0.8000 107099.9n 0.8000 107100.0n 0.2000 107399.9n 0.2000 107400.0n 0.8000 107699.9n 0.8000 107700.0n 0.2000 107999.9n 0.2000 108000.0n 0.8000 108299.9n 0.8000 108300.0n 0.2000 108599.9n 0.2000 108600.0n 0.8000 108899.9n 0.8000 108900.0n 0.2000 109199.9n 0.2000 109200.0n 0.8000 109499.9n 0.8000 109500.0n 0.2000 109799.9n 0.2000 109800.0n 0.8000 110099.9n 0.8000 110100.0n 0.2000 110399.9n 0.2000 110400.0n 0.8000 110699.9n 0.8000 110700.0n 0.2000 110999.9n 0.2000 111000.0n 0.8000 111299.9n 0.8000 111300.0n 0.2000 111599.9n 0.2000 111600.0n 0.8000 111899.9n 0.8000 111900.0n 0.2000 112199.9n 0.2000 112200.0n 0.8000 112499.9n 0.8000 112500.0n 0.2000 112799.9n 0.2000 112800.0n 0.8000 113099.9n 0.8000 113100.0n 0.2000 113399.9n 0.2000 113400.0n 0.8000 113699.9n 0.8000 113700.0n 0.2000 113999.9n 0.2000 114000.0n 0.8000 114299.9n 0.8000 114300.0n 0.2000 114599.9n 0.2000 114600.0n 0.8000 114899.9n 0.8000 114900.0n 0.2000 115199.9n 0.2000 115200.0n 0.8000 115499.9n 0.8000 115500.0n 0.2000 115799.9n 0.2000 115800.0n 0.8000 116099.9n 0.8000 116100.0n 0.2000 116399.9n 0.2000 116400.0n 0.8000 116699.9n 0.8000 116700.0n 0.2000 116999.9n 0.2000 117000.0n 0.8000 117299.9n 0.8000 117300.0n 0.2000 117599.9n 0.2000 117600.0n 0.8000 117899.9n 0.8000 117900.0n 0.2000 118199.9n 0.2000 118200.0n 0.8000 118499.9n 0.8000 118500.0n 0.2000 118799.9n 0.2000 118800.0n 0.8000 119099.9n 0.8000 119100.0n 0.2000 119399.9n 0.2000 119400.0n 0.8000 119699.9n 0.8000 119700.0n 0.2000 119999.9n 0.2000 120000.0n 0.8000 120299.9n 0.8000 120300.0n 0.2000 120599.9n 0.2000 120600.0n 0.8000 120899.9n 0.8000 120900.0n 0.2000 121199.9n 0.2000 121200.0n 0.8000 121499.9n 0.8000 121500.0n 0.2000 121799.9n 0.2000 121800.0n 0.8000 122099.9n 0.8000 122100.0n 0.2000 122399.9n 0.2000 122400.0n 0.8000 122699.9n 0.8000 122700.0n 0.2000 122999.9n 0.2000 123000.0n 0.8000 123299.9n 0.8000 123300.0n 0.2000 123599.9n 0.2000 123600.0n 0.8000 123899.9n 0.8000 123900.0n 0.2000 124199.9n 0.2000 124200.0n 0.8000 124499.9n 0.8000 124500.0n 0.2000 124799.9n 0.2000 124800.0n 0.8000 125099.9n 0.8000 125100.0n 0.2000 125399.9n 0.2000 125400.0n 0.8000 125699.9n 0.8000 125700.0n 0.2000 125999.9n 0.2000 126000.0n 0.8000 126299.9n 0.8000 126300.0n 0.2000 126599.9n 0.2000 126600.0n 0.8000 126899.9n 0.8000 126900.0n 0.2000 127199.9n 0.2000 127200.0n 0.8000 127499.9n 0.8000 127500.0n 0.2000 127799.9n 0.2000 127800.0n 0.8000 128099.9n 0.8000 128100.0n 0.2000 128399.9n 0.2000 128400.0n 0.8000 128699.9n 0.8000 128700.0n 0.2000 128999.9n 0.2000 129000.0n 0.8000 129299.9n 0.8000 129300.0n 0.2000 129599.9n 0.2000 129600.0n 0.8000 129899.9n 0.8000 129900.0n 0.2000 130199.9n 0.2000 130200.0n 0.8000 130499.9n 0.8000 130500.0n 0.2000 130799.9n 0.2000 130800.0n 0.8000 131099.9n 0.8000 131100.0n 0.2000 131399.9n 0.2000 131400.0n 0.8000 131699.9n 0.8000 131700.0n 0.2000 131999.9n 0.2000 132000.0n 0.8000 132299.9n 0.8000 132300.0n 0.2000 132599.9n 0.2000 132600.0n 0.8000 132899.9n 0.8000 132900.0n 0.2000 133199.9n 0.2000 133200.0n 0.8000 133499.9n 0.8000 133500.0n 0.2000 133799.9n 0.2000 133800.0n 0.8000 134099.9n 0.8000 134100.0n 0.2000 134399.9n 0.2000 134400.0n 0.8000 134699.9n 0.8000 134700.0n 0.2000 134999.9n 0.2000 135000.0n 0.8000 135299.9n 0.8000 135300.0n 0.2000 135599.9n 0.2000 135600.0n 0.8000 135899.9n 0.8000 135900.0n 0.2000 136199.9n 0.2000 136200.0n 0.8000 136499.9n 0.8000 136500.0n 0.2000 136799.9n 0.2000 136800.0n 0.8000 137099.9n 0.8000 137100.0n 0.2000 137399.9n 0.2000 137400.0n 0.8000 137699.9n 0.8000 137700.0n 0.2000 137999.9n 0.2000 138000.0n 0.8000 138299.9n 0.8000 138300.0n 0.2000 138599.9n 0.2000 138600.0n 0.8000 138899.9n 0.8000 138900.0n 0.2000 139199.9n 0.2000 139200.0n 0.8000 139499.9n 0.8000 139500.0n 0.2000 139799.9n 0.2000 139800.0n 0.8000 140099.9n 0.8000 140100.0n 0.2000 140399.9n 0.2000 140400.0n 0.8000 140699.9n 0.8000 140700.0n 0.2000 140999.9n 0.2000 141000.0n 0.8000 141299.9n 0.8000 141300.0n 0.2000 141599.9n 0.2000 141600.0n 0.8000 141899.9n 0.8000 141900.0n 0.2000 142199.9n 0.2000 142200.0n 0.8000 142499.9n 0.8000 142500.0n 0.2000 142799.9n 0.2000 142800.0n 0.8000 143099.9n 0.8000 143100.0n 0.2000 143399.9n 0.2000 143400.0n 0.8000 143699.9n 0.8000 143700.0n 0.2000)
Vxop xop 0 PWL(0.0n 0.2500 299.9n 0.2500 300.0n 0.7500 599.9n 0.7500 600.0n 0.7500 899.9n 0.7500 900.0n 0.7500 1199.9n 0.7500 1200.0n 0.2500 1499.9n 0.2500 1500.0n 0.7500 1799.9n 0.7500 1800.0n 0.7500 2099.9n 0.7500 2100.0n 0.7500 2399.9n 0.7500 2400.0n 0.2500 2699.9n 0.2500 2700.0n 0.7500 2999.9n 0.7500 3000.0n 0.7500 3299.9n 0.7500 3300.0n 0.7500 3599.9n 0.7500 3600.0n 0.2500 3899.9n 0.2500 3900.0n 0.7500 4199.9n 0.7500 4200.0n 0.7500 4499.9n 0.7500 4500.0n 0.7500 4799.9n 0.7500 4800.0n 0.2500 5099.9n 0.2500 5100.0n 0.7500 5399.9n 0.7500 5400.0n 0.7500 5699.9n 0.7500 5700.0n 0.7500 5999.9n 0.7500 6000.0n 0.2500 6299.9n 0.2500 6300.0n 0.7500 6599.9n 0.7500 6600.0n 0.7500 6899.9n 0.7500 6900.0n 0.7500 7199.9n 0.7500 7200.0n 0.2500 7499.9n 0.2500 7500.0n 0.7500 7799.9n 0.7500 7800.0n 0.7500 8099.9n 0.7500 8100.0n 0.7500 8399.9n 0.7500 8400.0n 0.2500 8699.9n 0.2500 8700.0n 0.7500 8999.9n 0.7500 9000.0n 0.7500 9299.9n 0.7500 9300.0n 0.7500 9599.9n 0.7500 9600.0n 0.2500 9899.9n 0.2500 9900.0n 0.7500 10199.9n 0.7500 10200.0n 0.7500 10499.9n 0.7500 10500.0n 0.7500 10799.9n 0.7500 10800.0n 0.2500 11099.9n 0.2500 11100.0n 0.7500 11399.9n 0.7500 11400.0n 0.7500 11699.9n 0.7500 11700.0n 0.7500 11999.9n 0.7500 12000.0n 0.2500 12299.9n 0.2500 12300.0n 0.7500 12599.9n 0.7500 12600.0n 0.7500 12899.9n 0.7500 12900.0n 0.7500 13199.9n 0.7500 13200.0n 0.2500 13499.9n 0.2500 13500.0n 0.7500 13799.9n 0.7500 13800.0n 0.7500 14099.9n 0.7500 14100.0n 0.7500 14399.9n 0.7500 14400.0n 0.2500 14699.9n 0.2500 14700.0n 0.7500 14999.9n 0.7500 15000.0n 0.7500 15299.9n 0.7500 15300.0n 0.7500 15599.9n 0.7500 15600.0n 0.2500 15899.9n 0.2500 15900.0n 0.7500 16199.9n 0.7500 16200.0n 0.7500 16499.9n 0.7500 16500.0n 0.7500 16799.9n 0.7500 16800.0n 0.2500 17099.9n 0.2500 17100.0n 0.7500 17399.9n 0.7500 17400.0n 0.7500 17699.9n 0.7500 17700.0n 0.7500 17999.9n 0.7500 18000.0n 0.2500 18299.9n 0.2500 18300.0n 0.7500 18599.9n 0.7500 18600.0n 0.7500 18899.9n 0.7500 18900.0n 0.7500 19199.9n 0.7500 19200.0n 0.2500 19499.9n 0.2500 19500.0n 0.7500 19799.9n 0.7500 19800.0n 0.7500 20099.9n 0.7500 20100.0n 0.7500 20399.9n 0.7500 20400.0n 0.2500 20699.9n 0.2500 20700.0n 0.7500 20999.9n 0.7500 21000.0n 0.7500 21299.9n 0.7500 21300.0n 0.7500 21599.9n 0.7500 21600.0n 0.2500 21899.9n 0.2500 21900.0n 0.7500 22199.9n 0.7500 22200.0n 0.7500 22499.9n 0.7500 22500.0n 0.7500 22799.9n 0.7500 22800.0n 0.2500 23099.9n 0.2500 23100.0n 0.7500 23399.9n 0.7500 23400.0n 0.7500 23699.9n 0.7500 23700.0n 0.7500 23999.9n 0.7500 24000.0n 0.2500 24299.9n 0.2500 24300.0n 0.7500 24599.9n 0.7500 24600.0n 0.7500 24899.9n 0.7500 24900.0n 0.7500 25199.9n 0.7500 25200.0n 0.2500 25499.9n 0.2500 25500.0n 0.7500 25799.9n 0.7500 25800.0n 0.7500 26099.9n 0.7500 26100.0n 0.7500 26399.9n 0.7500 26400.0n 0.2500 26699.9n 0.2500 26700.0n 0.7500 26999.9n 0.7500 27000.0n 0.7500 27299.9n 0.7500 27300.0n 0.7500 27599.9n 0.7500 27600.0n 0.2500 27899.9n 0.2500 27900.0n 0.7500 28199.9n 0.7500 28200.0n 0.7500 28499.9n 0.7500 28500.0n 0.7500 28799.9n 0.7500 28800.0n 0.2500 29099.9n 0.2500 29100.0n 0.7500 29399.9n 0.7500 29400.0n 0.7500 29699.9n 0.7500 29700.0n 0.7500 29999.9n 0.7500 30000.0n 0.2500 30299.9n 0.2500 30300.0n 0.7500 30599.9n 0.7500 30600.0n 0.7500 30899.9n 0.7500 30900.0n 0.7500 31199.9n 0.7500 31200.0n 0.2500 31499.9n 0.2500 31500.0n 0.7500 31799.9n 0.7500 31800.0n 0.7500 32099.9n 0.7500 32100.0n 0.7500 32399.9n 0.7500 32400.0n 0.2500 32699.9n 0.2500 32700.0n 0.7500 32999.9n 0.7500 33000.0n 0.7500 33299.9n 0.7500 33300.0n 0.7500 33599.9n 0.7500 33600.0n 0.2500 33899.9n 0.2500 33900.0n 0.7500 34199.9n 0.7500 34200.0n 0.7500 34499.9n 0.7500 34500.0n 0.7500 34799.9n 0.7500 34800.0n 0.2500 35099.9n 0.2500 35100.0n 0.7500 35399.9n 0.7500 35400.0n 0.7500 35699.9n 0.7500 35700.0n 0.7500 35999.9n 0.7500 36000.0n 0.2500 36299.9n 0.2500 36300.0n 0.7500 36599.9n 0.7500 36600.0n 0.7500 36899.9n 0.7500 36900.0n 0.7500 37199.9n 0.7500 37200.0n 0.2500 37499.9n 0.2500 37500.0n 0.7500 37799.9n 0.7500 37800.0n 0.7500 38099.9n 0.7500 38100.0n 0.7500 38399.9n 0.7500 38400.0n 0.2500 38699.9n 0.2500 38700.0n 0.7500 38999.9n 0.7500 39000.0n 0.7500 39299.9n 0.7500 39300.0n 0.7500 39599.9n 0.7500 39600.0n 0.2500 39899.9n 0.2500 39900.0n 0.7500 40199.9n 0.7500 40200.0n 0.7500 40499.9n 0.7500 40500.0n 0.7500 40799.9n 0.7500 40800.0n 0.2500 41099.9n 0.2500 41100.0n 0.7500 41399.9n 0.7500 41400.0n 0.7500 41699.9n 0.7500 41700.0n 0.7500 41999.9n 0.7500 42000.0n 0.2500 42299.9n 0.2500 42300.0n 0.7500 42599.9n 0.7500 42600.0n 0.7500 42899.9n 0.7500 42900.0n 0.7500 43199.9n 0.7500 43200.0n 0.2500 43499.9n 0.2500 43500.0n 0.7500 43799.9n 0.7500 43800.0n 0.7500 44099.9n 0.7500 44100.0n 0.7500 44399.9n 0.7500 44400.0n 0.2500 44699.9n 0.2500 44700.0n 0.7500 44999.9n 0.7500 45000.0n 0.7500 45299.9n 0.7500 45300.0n 0.7500 45599.9n 0.7500 45600.0n 0.2500 45899.9n 0.2500 45900.0n 0.7500 46199.9n 0.7500 46200.0n 0.7500 46499.9n 0.7500 46500.0n 0.7500 46799.9n 0.7500 46800.0n 0.2500 47099.9n 0.2500 47100.0n 0.7500 47399.9n 0.7500 47400.0n 0.7500 47699.9n 0.7500 47700.0n 0.7500 47999.9n 0.7500 48000.0n 0.2500 48299.9n 0.2500 48300.0n 0.7500 48599.9n 0.7500 48600.0n 0.7500 48899.9n 0.7500 48900.0n 0.7500 49199.9n 0.7500 49200.0n 0.2500 49499.9n 0.2500 49500.0n 0.7500 49799.9n 0.7500 49800.0n 0.7500 50099.9n 0.7500 50100.0n 0.7500 50399.9n 0.7500 50400.0n 0.2500 50699.9n 0.2500 50700.0n 0.7500 50999.9n 0.7500 51000.0n 0.7500 51299.9n 0.7500 51300.0n 0.7500 51599.9n 0.7500 51600.0n 0.2500 51899.9n 0.2500 51900.0n 0.7500 52199.9n 0.7500 52200.0n 0.7500 52499.9n 0.7500 52500.0n 0.7500 52799.9n 0.7500 52800.0n 0.2500 53099.9n 0.2500 53100.0n 0.7500 53399.9n 0.7500 53400.0n 0.7500 53699.9n 0.7500 53700.0n 0.7500 53999.9n 0.7500 54000.0n 0.2500 54299.9n 0.2500 54300.0n 0.7500 54599.9n 0.7500 54600.0n 0.7500 54899.9n 0.7500 54900.0n 0.7500 55199.9n 0.7500 55200.0n 0.2500 55499.9n 0.2500 55500.0n 0.7500 55799.9n 0.7500 55800.0n 0.7500 56099.9n 0.7500 56100.0n 0.7500 56399.9n 0.7500 56400.0n 0.2500 56699.9n 0.2500 56700.0n 0.7500 56999.9n 0.7500 57000.0n 0.7500 57299.9n 0.7500 57300.0n 0.7500 57599.9n 0.7500 57600.0n 0.2500 57899.9n 0.2500 57900.0n 0.7500 58199.9n 0.7500 58200.0n 0.7500 58499.9n 0.7500 58500.0n 0.7500 58799.9n 0.7500 58800.0n 0.2500 59099.9n 0.2500 59100.0n 0.7500 59399.9n 0.7500 59400.0n 0.7500 59699.9n 0.7500 59700.0n 0.7500 59999.9n 0.7500 60000.0n 0.2500 60299.9n 0.2500 60300.0n 0.7500 60599.9n 0.7500 60600.0n 0.7500 60899.9n 0.7500 60900.0n 0.7500 61199.9n 0.7500 61200.0n 0.2500 61499.9n 0.2500 61500.0n 0.7500 61799.9n 0.7500 61800.0n 0.7500 62099.9n 0.7500 62100.0n 0.7500 62399.9n 0.7500 62400.0n 0.2500 62699.9n 0.2500 62700.0n 0.7500 62999.9n 0.7500 63000.0n 0.7500 63299.9n 0.7500 63300.0n 0.7500 63599.9n 0.7500 63600.0n 0.2500 63899.9n 0.2500 63900.0n 0.7500 64199.9n 0.7500 64200.0n 0.7500 64499.9n 0.7500 64500.0n 0.7500 64799.9n 0.7500 64800.0n 0.2500 65099.9n 0.2500 65100.0n 0.7500 65399.9n 0.7500 65400.0n 0.7500 65699.9n 0.7500 65700.0n 0.7500 65999.9n 0.7500 66000.0n 0.2500 66299.9n 0.2500 66300.0n 0.7500 66599.9n 0.7500 66600.0n 0.7500 66899.9n 0.7500 66900.0n 0.7500 67199.9n 0.7500 67200.0n 0.2500 67499.9n 0.2500 67500.0n 0.7500 67799.9n 0.7500 67800.0n 0.7500 68099.9n 0.7500 68100.0n 0.7500 68399.9n 0.7500 68400.0n 0.2500 68699.9n 0.2500 68700.0n 0.7500 68999.9n 0.7500 69000.0n 0.7500 69299.9n 0.7500 69300.0n 0.7500 69599.9n 0.7500 69600.0n 0.2500 69899.9n 0.2500 69900.0n 0.7500 70199.9n 0.7500 70200.0n 0.7500 70499.9n 0.7500 70500.0n 0.7500 70799.9n 0.7500 70800.0n 0.2500 71099.9n 0.2500 71100.0n 0.7500 71399.9n 0.7500 71400.0n 0.7500 71699.9n 0.7500 71700.0n 0.7500 71999.9n 0.7500 72000.0n 0.2500 72299.9n 0.2500 72300.0n 0.7500 72599.9n 0.7500 72600.0n 0.7500 72899.9n 0.7500 72900.0n 0.7500 73199.9n 0.7500 73200.0n 0.2500 73499.9n 0.2500 73500.0n 0.7500 73799.9n 0.7500 73800.0n 0.7500 74099.9n 0.7500 74100.0n 0.7500 74399.9n 0.7500 74400.0n 0.2500 74699.9n 0.2500 74700.0n 0.7500 74999.9n 0.7500 75000.0n 0.7500 75299.9n 0.7500 75300.0n 0.7500 75599.9n 0.7500 75600.0n 0.2500 75899.9n 0.2500 75900.0n 0.7500 76199.9n 0.7500 76200.0n 0.7500 76499.9n 0.7500 76500.0n 0.7500 76799.9n 0.7500 76800.0n 0.2500 77099.9n 0.2500 77100.0n 0.7500 77399.9n 0.7500 77400.0n 0.7500 77699.9n 0.7500 77700.0n 0.7500 77999.9n 0.7500 78000.0n 0.2500 78299.9n 0.2500 78300.0n 0.7500 78599.9n 0.7500 78600.0n 0.7500 78899.9n 0.7500 78900.0n 0.7500 79199.9n 0.7500 79200.0n 0.2500 79499.9n 0.2500 79500.0n 0.7500 79799.9n 0.7500 79800.0n 0.7500 80099.9n 0.7500 80100.0n 0.7500 80399.9n 0.7500 80400.0n 0.2500 80699.9n 0.2500 80700.0n 0.7500 80999.9n 0.7500 81000.0n 0.7500 81299.9n 0.7500 81300.0n 0.7500 81599.9n 0.7500 81600.0n 0.2500 81899.9n 0.2500 81900.0n 0.7500 82199.9n 0.7500 82200.0n 0.7500 82499.9n 0.7500 82500.0n 0.7500 82799.9n 0.7500 82800.0n 0.2500 83099.9n 0.2500 83100.0n 0.7500 83399.9n 0.7500 83400.0n 0.7500 83699.9n 0.7500 83700.0n 0.7500 83999.9n 0.7500 84000.0n 0.2500 84299.9n 0.2500 84300.0n 0.7500 84599.9n 0.7500 84600.0n 0.7500 84899.9n 0.7500 84900.0n 0.7500 85199.9n 0.7500 85200.0n 0.2500 85499.9n 0.2500 85500.0n 0.7500 85799.9n 0.7500 85800.0n 0.7500 86099.9n 0.7500 86100.0n 0.7500 86399.9n 0.7500 86400.0n 0.2500 86699.9n 0.2500 86700.0n 0.7500 86999.9n 0.7500 87000.0n 0.7500 87299.9n 0.7500 87300.0n 0.7500 87599.9n 0.7500 87600.0n 0.2500 87899.9n 0.2500 87900.0n 0.7500 88199.9n 0.7500 88200.0n 0.7500 88499.9n 0.7500 88500.0n 0.7500 88799.9n 0.7500 88800.0n 0.2500 89099.9n 0.2500 89100.0n 0.7500 89399.9n 0.7500 89400.0n 0.7500 89699.9n 0.7500 89700.0n 0.7500 89999.9n 0.7500 90000.0n 0.2500 90299.9n 0.2500 90300.0n 0.7500 90599.9n 0.7500 90600.0n 0.7500 90899.9n 0.7500 90900.0n 0.7500 91199.9n 0.7500 91200.0n 0.2500 91499.9n 0.2500 91500.0n 0.7500 91799.9n 0.7500 91800.0n 0.7500 92099.9n 0.7500 92100.0n 0.7500 92399.9n 0.7500 92400.0n 0.2500 92699.9n 0.2500 92700.0n 0.7500 92999.9n 0.7500 93000.0n 0.7500 93299.9n 0.7500 93300.0n 0.7500 93599.9n 0.7500 93600.0n 0.2500 93899.9n 0.2500 93900.0n 0.7500 94199.9n 0.7500 94200.0n 0.7500 94499.9n 0.7500 94500.0n 0.7500 94799.9n 0.7500 94800.0n 0.2500 95099.9n 0.2500 95100.0n 0.7500 95399.9n 0.7500 95400.0n 0.7500 95699.9n 0.7500 95700.0n 0.7500 95999.9n 0.7500 96000.0n 0.2500 96299.9n 0.2500 96300.0n 0.7500 96599.9n 0.7500 96600.0n 0.7500 96899.9n 0.7500 96900.0n 0.7500 97199.9n 0.7500 97200.0n 0.2500 97499.9n 0.2500 97500.0n 0.7500 97799.9n 0.7500 97800.0n 0.7500 98099.9n 0.7500 98100.0n 0.7500 98399.9n 0.7500 98400.0n 0.2500 98699.9n 0.2500 98700.0n 0.7500 98999.9n 0.7500 99000.0n 0.7500 99299.9n 0.7500 99300.0n 0.7500 99599.9n 0.7500 99600.0n 0.2500 99899.9n 0.2500 99900.0n 0.7500 100199.9n 0.7500 100200.0n 0.7500 100499.9n 0.7500 100500.0n 0.7500 100799.9n 0.7500 100800.0n 0.2500 101099.9n 0.2500 101100.0n 0.7500 101399.9n 0.7500 101400.0n 0.7500 101699.9n 0.7500 101700.0n 0.7500 101999.9n 0.7500 102000.0n 0.2500 102299.9n 0.2500 102300.0n 0.7500 102599.9n 0.7500 102600.0n 0.7500 102899.9n 0.7500 102900.0n 0.7500 103199.9n 0.7500 103200.0n 0.2500 103499.9n 0.2500 103500.0n 0.7500 103799.9n 0.7500 103800.0n 0.7500 104099.9n 0.7500 104100.0n 0.7500 104399.9n 0.7500 104400.0n 0.2500 104699.9n 0.2500 104700.0n 0.7500 104999.9n 0.7500 105000.0n 0.7500 105299.9n 0.7500 105300.0n 0.7500 105599.9n 0.7500 105600.0n 0.2500 105899.9n 0.2500 105900.0n 0.7500 106199.9n 0.7500 106200.0n 0.7500 106499.9n 0.7500 106500.0n 0.7500 106799.9n 0.7500 106800.0n 0.2500 107099.9n 0.2500 107100.0n 0.7500 107399.9n 0.7500 107400.0n 0.7500 107699.9n 0.7500 107700.0n 0.7500 107999.9n 0.7500 108000.0n 0.2500 108299.9n 0.2500 108300.0n 0.7500 108599.9n 0.7500 108600.0n 0.7500 108899.9n 0.7500 108900.0n 0.7500 109199.9n 0.7500 109200.0n 0.2500 109499.9n 0.2500 109500.0n 0.7500 109799.9n 0.7500 109800.0n 0.7500 110099.9n 0.7500 110100.0n 0.7500 110399.9n 0.7500 110400.0n 0.2500 110699.9n 0.2500 110700.0n 0.7500 110999.9n 0.7500 111000.0n 0.7500 111299.9n 0.7500 111300.0n 0.7500 111599.9n 0.7500 111600.0n 0.2500 111899.9n 0.2500 111900.0n 0.7500 112199.9n 0.7500 112200.0n 0.7500 112499.9n 0.7500 112500.0n 0.7500 112799.9n 0.7500 112800.0n 0.2500 113099.9n 0.2500 113100.0n 0.7500 113399.9n 0.7500 113400.0n 0.7500 113699.9n 0.7500 113700.0n 0.7500 113999.9n 0.7500 114000.0n 0.2500 114299.9n 0.2500 114300.0n 0.7500 114599.9n 0.7500 114600.0n 0.7500 114899.9n 0.7500 114900.0n 0.7500 115199.9n 0.7500 115200.0n 0.2500 115499.9n 0.2500 115500.0n 0.7500 115799.9n 0.7500 115800.0n 0.7500 116099.9n 0.7500 116100.0n 0.7500 116399.9n 0.7500 116400.0n 0.2500 116699.9n 0.2500 116700.0n 0.7500 116999.9n 0.7500 117000.0n 0.7500 117299.9n 0.7500 117300.0n 0.7500 117599.9n 0.7500 117600.0n 0.2500 117899.9n 0.2500 117900.0n 0.7500 118199.9n 0.7500 118200.0n 0.7500 118499.9n 0.7500 118500.0n 0.7500 118799.9n 0.7500 118800.0n 0.2500 119099.9n 0.2500 119100.0n 0.7500 119399.9n 0.7500 119400.0n 0.7500 119699.9n 0.7500 119700.0n 0.7500 119999.9n 0.7500 120000.0n 0.2500 120299.9n 0.2500 120300.0n 0.7500 120599.9n 0.7500 120600.0n 0.7500 120899.9n 0.7500 120900.0n 0.7500 121199.9n 0.7500 121200.0n 0.2500 121499.9n 0.2500 121500.0n 0.7500 121799.9n 0.7500 121800.0n 0.7500 122099.9n 0.7500 122100.0n 0.7500 122399.9n 0.7500 122400.0n 0.2500 122699.9n 0.2500 122700.0n 0.7500 122999.9n 0.7500 123000.0n 0.7500 123299.9n 0.7500 123300.0n 0.7500 123599.9n 0.7500 123600.0n 0.2500 123899.9n 0.2500 123900.0n 0.7500 124199.9n 0.7500 124200.0n 0.7500 124499.9n 0.7500 124500.0n 0.7500 124799.9n 0.7500 124800.0n 0.2500 125099.9n 0.2500 125100.0n 0.7500 125399.9n 0.7500 125400.0n 0.7500 125699.9n 0.7500 125700.0n 0.7500 125999.9n 0.7500 126000.0n 0.2500 126299.9n 0.2500 126300.0n 0.7500 126599.9n 0.7500 126600.0n 0.7500 126899.9n 0.7500 126900.0n 0.7500 127199.9n 0.7500 127200.0n 0.2500 127499.9n 0.2500 127500.0n 0.7500 127799.9n 0.7500 127800.0n 0.7500 128099.9n 0.7500 128100.0n 0.7500 128399.9n 0.7500 128400.0n 0.2500 128699.9n 0.2500 128700.0n 0.7500 128999.9n 0.7500 129000.0n 0.7500 129299.9n 0.7500 129300.0n 0.7500 129599.9n 0.7500 129600.0n 0.2500 129899.9n 0.2500 129900.0n 0.7500 130199.9n 0.7500 130200.0n 0.7500 130499.9n 0.7500 130500.0n 0.7500 130799.9n 0.7500 130800.0n 0.2500 131099.9n 0.2500 131100.0n 0.7500 131399.9n 0.7500 131400.0n 0.7500 131699.9n 0.7500 131700.0n 0.7500 131999.9n 0.7500 132000.0n 0.2500 132299.9n 0.2500 132300.0n 0.7500 132599.9n 0.7500 132600.0n 0.7500 132899.9n 0.7500 132900.0n 0.7500 133199.9n 0.7500 133200.0n 0.2500 133499.9n 0.2500 133500.0n 0.7500 133799.9n 0.7500 133800.0n 0.7500 134099.9n 0.7500 134100.0n 0.7500 134399.9n 0.7500 134400.0n 0.2500 134699.9n 0.2500 134700.0n 0.7500 134999.9n 0.7500 135000.0n 0.7500 135299.9n 0.7500 135300.0n 0.7500 135599.9n 0.7500 135600.0n 0.2500 135899.9n 0.2500 135900.0n 0.7500 136199.9n 0.7500 136200.0n 0.7500 136499.9n 0.7500 136500.0n 0.7500 136799.9n 0.7500 136800.0n 0.2500 137099.9n 0.2500 137100.0n 0.7500 137399.9n 0.7500 137400.0n 0.7500 137699.9n 0.7500 137700.0n 0.7500 137999.9n 0.7500 138000.0n 0.2500 138299.9n 0.2500 138300.0n 0.7500 138599.9n 0.7500 138600.0n 0.7500 138899.9n 0.7500 138900.0n 0.7500 139199.9n 0.7500 139200.0n 0.2500 139499.9n 0.2500 139500.0n 0.7500 139799.9n 0.7500 139800.0n 0.7500 140099.9n 0.7500 140100.0n 0.7500 140399.9n 0.7500 140400.0n 0.2500 140699.9n 0.2500 140700.0n 0.7500 140999.9n 0.7500 141000.0n 0.7500 141299.9n 0.7500 141300.0n 0.7500 141599.9n 0.7500 141600.0n 0.2500 141899.9n 0.2500 141900.0n 0.7500 142199.9n 0.7500 142200.0n 0.7500 142499.9n 0.7500 142500.0n 0.7500 142799.9n 0.7500 142800.0n 0.2500 143099.9n 0.2500 143100.0n 0.7500 143399.9n 0.7500 143400.0n 0.7500 143699.9n 0.7500 143700.0n 0.7500)
Vxon xon 0 PWL(0.0n 0.7500 299.9n 0.7500 300.0n 0.2500 599.9n 0.2500 600.0n 0.2500 899.9n 0.2500 900.0n 0.2500 1199.9n 0.2500 1200.0n 0.7500 1499.9n 0.7500 1500.0n 0.2500 1799.9n 0.2500 1800.0n 0.2500 2099.9n 0.2500 2100.0n 0.2500 2399.9n 0.2500 2400.0n 0.7500 2699.9n 0.7500 2700.0n 0.2500 2999.9n 0.2500 3000.0n 0.2500 3299.9n 0.2500 3300.0n 0.2500 3599.9n 0.2500 3600.0n 0.7500 3899.9n 0.7500 3900.0n 0.2500 4199.9n 0.2500 4200.0n 0.2500 4499.9n 0.2500 4500.0n 0.2500 4799.9n 0.2500 4800.0n 0.7500 5099.9n 0.7500 5100.0n 0.2500 5399.9n 0.2500 5400.0n 0.2500 5699.9n 0.2500 5700.0n 0.2500 5999.9n 0.2500 6000.0n 0.7500 6299.9n 0.7500 6300.0n 0.2500 6599.9n 0.2500 6600.0n 0.2500 6899.9n 0.2500 6900.0n 0.2500 7199.9n 0.2500 7200.0n 0.7500 7499.9n 0.7500 7500.0n 0.2500 7799.9n 0.2500 7800.0n 0.2500 8099.9n 0.2500 8100.0n 0.2500 8399.9n 0.2500 8400.0n 0.7500 8699.9n 0.7500 8700.0n 0.2500 8999.9n 0.2500 9000.0n 0.2500 9299.9n 0.2500 9300.0n 0.2500 9599.9n 0.2500 9600.0n 0.7500 9899.9n 0.7500 9900.0n 0.2500 10199.9n 0.2500 10200.0n 0.2500 10499.9n 0.2500 10500.0n 0.2500 10799.9n 0.2500 10800.0n 0.7500 11099.9n 0.7500 11100.0n 0.2500 11399.9n 0.2500 11400.0n 0.2500 11699.9n 0.2500 11700.0n 0.2500 11999.9n 0.2500 12000.0n 0.7500 12299.9n 0.7500 12300.0n 0.2500 12599.9n 0.2500 12600.0n 0.2500 12899.9n 0.2500 12900.0n 0.2500 13199.9n 0.2500 13200.0n 0.7500 13499.9n 0.7500 13500.0n 0.2500 13799.9n 0.2500 13800.0n 0.2500 14099.9n 0.2500 14100.0n 0.2500 14399.9n 0.2500 14400.0n 0.7500 14699.9n 0.7500 14700.0n 0.2500 14999.9n 0.2500 15000.0n 0.2500 15299.9n 0.2500 15300.0n 0.2500 15599.9n 0.2500 15600.0n 0.7500 15899.9n 0.7500 15900.0n 0.2500 16199.9n 0.2500 16200.0n 0.2500 16499.9n 0.2500 16500.0n 0.2500 16799.9n 0.2500 16800.0n 0.7500 17099.9n 0.7500 17100.0n 0.2500 17399.9n 0.2500 17400.0n 0.2500 17699.9n 0.2500 17700.0n 0.2500 17999.9n 0.2500 18000.0n 0.7500 18299.9n 0.7500 18300.0n 0.2500 18599.9n 0.2500 18600.0n 0.2500 18899.9n 0.2500 18900.0n 0.2500 19199.9n 0.2500 19200.0n 0.7500 19499.9n 0.7500 19500.0n 0.2500 19799.9n 0.2500 19800.0n 0.2500 20099.9n 0.2500 20100.0n 0.2500 20399.9n 0.2500 20400.0n 0.7500 20699.9n 0.7500 20700.0n 0.2500 20999.9n 0.2500 21000.0n 0.2500 21299.9n 0.2500 21300.0n 0.2500 21599.9n 0.2500 21600.0n 0.7500 21899.9n 0.7500 21900.0n 0.2500 22199.9n 0.2500 22200.0n 0.2500 22499.9n 0.2500 22500.0n 0.2500 22799.9n 0.2500 22800.0n 0.7500 23099.9n 0.7500 23100.0n 0.2500 23399.9n 0.2500 23400.0n 0.2500 23699.9n 0.2500 23700.0n 0.2500 23999.9n 0.2500 24000.0n 0.7500 24299.9n 0.7500 24300.0n 0.2500 24599.9n 0.2500 24600.0n 0.2500 24899.9n 0.2500 24900.0n 0.2500 25199.9n 0.2500 25200.0n 0.7500 25499.9n 0.7500 25500.0n 0.2500 25799.9n 0.2500 25800.0n 0.2500 26099.9n 0.2500 26100.0n 0.2500 26399.9n 0.2500 26400.0n 0.7500 26699.9n 0.7500 26700.0n 0.2500 26999.9n 0.2500 27000.0n 0.2500 27299.9n 0.2500 27300.0n 0.2500 27599.9n 0.2500 27600.0n 0.7500 27899.9n 0.7500 27900.0n 0.2500 28199.9n 0.2500 28200.0n 0.2500 28499.9n 0.2500 28500.0n 0.2500 28799.9n 0.2500 28800.0n 0.7500 29099.9n 0.7500 29100.0n 0.2500 29399.9n 0.2500 29400.0n 0.2500 29699.9n 0.2500 29700.0n 0.2500 29999.9n 0.2500 30000.0n 0.7500 30299.9n 0.7500 30300.0n 0.2500 30599.9n 0.2500 30600.0n 0.2500 30899.9n 0.2500 30900.0n 0.2500 31199.9n 0.2500 31200.0n 0.7500 31499.9n 0.7500 31500.0n 0.2500 31799.9n 0.2500 31800.0n 0.2500 32099.9n 0.2500 32100.0n 0.2500 32399.9n 0.2500 32400.0n 0.7500 32699.9n 0.7500 32700.0n 0.2500 32999.9n 0.2500 33000.0n 0.2500 33299.9n 0.2500 33300.0n 0.2500 33599.9n 0.2500 33600.0n 0.7500 33899.9n 0.7500 33900.0n 0.2500 34199.9n 0.2500 34200.0n 0.2500 34499.9n 0.2500 34500.0n 0.2500 34799.9n 0.2500 34800.0n 0.7500 35099.9n 0.7500 35100.0n 0.2500 35399.9n 0.2500 35400.0n 0.2500 35699.9n 0.2500 35700.0n 0.2500 35999.9n 0.2500 36000.0n 0.7500 36299.9n 0.7500 36300.0n 0.2500 36599.9n 0.2500 36600.0n 0.2500 36899.9n 0.2500 36900.0n 0.2500 37199.9n 0.2500 37200.0n 0.7500 37499.9n 0.7500 37500.0n 0.2500 37799.9n 0.2500 37800.0n 0.2500 38099.9n 0.2500 38100.0n 0.2500 38399.9n 0.2500 38400.0n 0.7500 38699.9n 0.7500 38700.0n 0.2500 38999.9n 0.2500 39000.0n 0.2500 39299.9n 0.2500 39300.0n 0.2500 39599.9n 0.2500 39600.0n 0.7500 39899.9n 0.7500 39900.0n 0.2500 40199.9n 0.2500 40200.0n 0.2500 40499.9n 0.2500 40500.0n 0.2500 40799.9n 0.2500 40800.0n 0.7500 41099.9n 0.7500 41100.0n 0.2500 41399.9n 0.2500 41400.0n 0.2500 41699.9n 0.2500 41700.0n 0.2500 41999.9n 0.2500 42000.0n 0.7500 42299.9n 0.7500 42300.0n 0.2500 42599.9n 0.2500 42600.0n 0.2500 42899.9n 0.2500 42900.0n 0.2500 43199.9n 0.2500 43200.0n 0.7500 43499.9n 0.7500 43500.0n 0.2500 43799.9n 0.2500 43800.0n 0.2500 44099.9n 0.2500 44100.0n 0.2500 44399.9n 0.2500 44400.0n 0.7500 44699.9n 0.7500 44700.0n 0.2500 44999.9n 0.2500 45000.0n 0.2500 45299.9n 0.2500 45300.0n 0.2500 45599.9n 0.2500 45600.0n 0.7500 45899.9n 0.7500 45900.0n 0.2500 46199.9n 0.2500 46200.0n 0.2500 46499.9n 0.2500 46500.0n 0.2500 46799.9n 0.2500 46800.0n 0.7500 47099.9n 0.7500 47100.0n 0.2500 47399.9n 0.2500 47400.0n 0.2500 47699.9n 0.2500 47700.0n 0.2500 47999.9n 0.2500 48000.0n 0.7500 48299.9n 0.7500 48300.0n 0.2500 48599.9n 0.2500 48600.0n 0.2500 48899.9n 0.2500 48900.0n 0.2500 49199.9n 0.2500 49200.0n 0.7500 49499.9n 0.7500 49500.0n 0.2500 49799.9n 0.2500 49800.0n 0.2500 50099.9n 0.2500 50100.0n 0.2500 50399.9n 0.2500 50400.0n 0.7500 50699.9n 0.7500 50700.0n 0.2500 50999.9n 0.2500 51000.0n 0.2500 51299.9n 0.2500 51300.0n 0.2500 51599.9n 0.2500 51600.0n 0.7500 51899.9n 0.7500 51900.0n 0.2500 52199.9n 0.2500 52200.0n 0.2500 52499.9n 0.2500 52500.0n 0.2500 52799.9n 0.2500 52800.0n 0.7500 53099.9n 0.7500 53100.0n 0.2500 53399.9n 0.2500 53400.0n 0.2500 53699.9n 0.2500 53700.0n 0.2500 53999.9n 0.2500 54000.0n 0.7500 54299.9n 0.7500 54300.0n 0.2500 54599.9n 0.2500 54600.0n 0.2500 54899.9n 0.2500 54900.0n 0.2500 55199.9n 0.2500 55200.0n 0.7500 55499.9n 0.7500 55500.0n 0.2500 55799.9n 0.2500 55800.0n 0.2500 56099.9n 0.2500 56100.0n 0.2500 56399.9n 0.2500 56400.0n 0.7500 56699.9n 0.7500 56700.0n 0.2500 56999.9n 0.2500 57000.0n 0.2500 57299.9n 0.2500 57300.0n 0.2500 57599.9n 0.2500 57600.0n 0.7500 57899.9n 0.7500 57900.0n 0.2500 58199.9n 0.2500 58200.0n 0.2500 58499.9n 0.2500 58500.0n 0.2500 58799.9n 0.2500 58800.0n 0.7500 59099.9n 0.7500 59100.0n 0.2500 59399.9n 0.2500 59400.0n 0.2500 59699.9n 0.2500 59700.0n 0.2500 59999.9n 0.2500 60000.0n 0.7500 60299.9n 0.7500 60300.0n 0.2500 60599.9n 0.2500 60600.0n 0.2500 60899.9n 0.2500 60900.0n 0.2500 61199.9n 0.2500 61200.0n 0.7500 61499.9n 0.7500 61500.0n 0.2500 61799.9n 0.2500 61800.0n 0.2500 62099.9n 0.2500 62100.0n 0.2500 62399.9n 0.2500 62400.0n 0.7500 62699.9n 0.7500 62700.0n 0.2500 62999.9n 0.2500 63000.0n 0.2500 63299.9n 0.2500 63300.0n 0.2500 63599.9n 0.2500 63600.0n 0.7500 63899.9n 0.7500 63900.0n 0.2500 64199.9n 0.2500 64200.0n 0.2500 64499.9n 0.2500 64500.0n 0.2500 64799.9n 0.2500 64800.0n 0.7500 65099.9n 0.7500 65100.0n 0.2500 65399.9n 0.2500 65400.0n 0.2500 65699.9n 0.2500 65700.0n 0.2500 65999.9n 0.2500 66000.0n 0.7500 66299.9n 0.7500 66300.0n 0.2500 66599.9n 0.2500 66600.0n 0.2500 66899.9n 0.2500 66900.0n 0.2500 67199.9n 0.2500 67200.0n 0.7500 67499.9n 0.7500 67500.0n 0.2500 67799.9n 0.2500 67800.0n 0.2500 68099.9n 0.2500 68100.0n 0.2500 68399.9n 0.2500 68400.0n 0.7500 68699.9n 0.7500 68700.0n 0.2500 68999.9n 0.2500 69000.0n 0.2500 69299.9n 0.2500 69300.0n 0.2500 69599.9n 0.2500 69600.0n 0.7500 69899.9n 0.7500 69900.0n 0.2500 70199.9n 0.2500 70200.0n 0.2500 70499.9n 0.2500 70500.0n 0.2500 70799.9n 0.2500 70800.0n 0.7500 71099.9n 0.7500 71100.0n 0.2500 71399.9n 0.2500 71400.0n 0.2500 71699.9n 0.2500 71700.0n 0.2500 71999.9n 0.2500 72000.0n 0.7500 72299.9n 0.7500 72300.0n 0.2500 72599.9n 0.2500 72600.0n 0.2500 72899.9n 0.2500 72900.0n 0.2500 73199.9n 0.2500 73200.0n 0.7500 73499.9n 0.7500 73500.0n 0.2500 73799.9n 0.2500 73800.0n 0.2500 74099.9n 0.2500 74100.0n 0.2500 74399.9n 0.2500 74400.0n 0.7500 74699.9n 0.7500 74700.0n 0.2500 74999.9n 0.2500 75000.0n 0.2500 75299.9n 0.2500 75300.0n 0.2500 75599.9n 0.2500 75600.0n 0.7500 75899.9n 0.7500 75900.0n 0.2500 76199.9n 0.2500 76200.0n 0.2500 76499.9n 0.2500 76500.0n 0.2500 76799.9n 0.2500 76800.0n 0.7500 77099.9n 0.7500 77100.0n 0.2500 77399.9n 0.2500 77400.0n 0.2500 77699.9n 0.2500 77700.0n 0.2500 77999.9n 0.2500 78000.0n 0.7500 78299.9n 0.7500 78300.0n 0.2500 78599.9n 0.2500 78600.0n 0.2500 78899.9n 0.2500 78900.0n 0.2500 79199.9n 0.2500 79200.0n 0.7500 79499.9n 0.7500 79500.0n 0.2500 79799.9n 0.2500 79800.0n 0.2500 80099.9n 0.2500 80100.0n 0.2500 80399.9n 0.2500 80400.0n 0.7500 80699.9n 0.7500 80700.0n 0.2500 80999.9n 0.2500 81000.0n 0.2500 81299.9n 0.2500 81300.0n 0.2500 81599.9n 0.2500 81600.0n 0.7500 81899.9n 0.7500 81900.0n 0.2500 82199.9n 0.2500 82200.0n 0.2500 82499.9n 0.2500 82500.0n 0.2500 82799.9n 0.2500 82800.0n 0.7500 83099.9n 0.7500 83100.0n 0.2500 83399.9n 0.2500 83400.0n 0.2500 83699.9n 0.2500 83700.0n 0.2500 83999.9n 0.2500 84000.0n 0.7500 84299.9n 0.7500 84300.0n 0.2500 84599.9n 0.2500 84600.0n 0.2500 84899.9n 0.2500 84900.0n 0.2500 85199.9n 0.2500 85200.0n 0.7500 85499.9n 0.7500 85500.0n 0.2500 85799.9n 0.2500 85800.0n 0.2500 86099.9n 0.2500 86100.0n 0.2500 86399.9n 0.2500 86400.0n 0.7500 86699.9n 0.7500 86700.0n 0.2500 86999.9n 0.2500 87000.0n 0.2500 87299.9n 0.2500 87300.0n 0.2500 87599.9n 0.2500 87600.0n 0.7500 87899.9n 0.7500 87900.0n 0.2500 88199.9n 0.2500 88200.0n 0.2500 88499.9n 0.2500 88500.0n 0.2500 88799.9n 0.2500 88800.0n 0.7500 89099.9n 0.7500 89100.0n 0.2500 89399.9n 0.2500 89400.0n 0.2500 89699.9n 0.2500 89700.0n 0.2500 89999.9n 0.2500 90000.0n 0.7500 90299.9n 0.7500 90300.0n 0.2500 90599.9n 0.2500 90600.0n 0.2500 90899.9n 0.2500 90900.0n 0.2500 91199.9n 0.2500 91200.0n 0.7500 91499.9n 0.7500 91500.0n 0.2500 91799.9n 0.2500 91800.0n 0.2500 92099.9n 0.2500 92100.0n 0.2500 92399.9n 0.2500 92400.0n 0.7500 92699.9n 0.7500 92700.0n 0.2500 92999.9n 0.2500 93000.0n 0.2500 93299.9n 0.2500 93300.0n 0.2500 93599.9n 0.2500 93600.0n 0.7500 93899.9n 0.7500 93900.0n 0.2500 94199.9n 0.2500 94200.0n 0.2500 94499.9n 0.2500 94500.0n 0.2500 94799.9n 0.2500 94800.0n 0.7500 95099.9n 0.7500 95100.0n 0.2500 95399.9n 0.2500 95400.0n 0.2500 95699.9n 0.2500 95700.0n 0.2500 95999.9n 0.2500 96000.0n 0.7500 96299.9n 0.7500 96300.0n 0.2500 96599.9n 0.2500 96600.0n 0.2500 96899.9n 0.2500 96900.0n 0.2500 97199.9n 0.2500 97200.0n 0.7500 97499.9n 0.7500 97500.0n 0.2500 97799.9n 0.2500 97800.0n 0.2500 98099.9n 0.2500 98100.0n 0.2500 98399.9n 0.2500 98400.0n 0.7500 98699.9n 0.7500 98700.0n 0.2500 98999.9n 0.2500 99000.0n 0.2500 99299.9n 0.2500 99300.0n 0.2500 99599.9n 0.2500 99600.0n 0.7500 99899.9n 0.7500 99900.0n 0.2500 100199.9n 0.2500 100200.0n 0.2500 100499.9n 0.2500 100500.0n 0.2500 100799.9n 0.2500 100800.0n 0.7500 101099.9n 0.7500 101100.0n 0.2500 101399.9n 0.2500 101400.0n 0.2500 101699.9n 0.2500 101700.0n 0.2500 101999.9n 0.2500 102000.0n 0.7500 102299.9n 0.7500 102300.0n 0.2500 102599.9n 0.2500 102600.0n 0.2500 102899.9n 0.2500 102900.0n 0.2500 103199.9n 0.2500 103200.0n 0.7500 103499.9n 0.7500 103500.0n 0.2500 103799.9n 0.2500 103800.0n 0.2500 104099.9n 0.2500 104100.0n 0.2500 104399.9n 0.2500 104400.0n 0.7500 104699.9n 0.7500 104700.0n 0.2500 104999.9n 0.2500 105000.0n 0.2500 105299.9n 0.2500 105300.0n 0.2500 105599.9n 0.2500 105600.0n 0.7500 105899.9n 0.7500 105900.0n 0.2500 106199.9n 0.2500 106200.0n 0.2500 106499.9n 0.2500 106500.0n 0.2500 106799.9n 0.2500 106800.0n 0.7500 107099.9n 0.7500 107100.0n 0.2500 107399.9n 0.2500 107400.0n 0.2500 107699.9n 0.2500 107700.0n 0.2500 107999.9n 0.2500 108000.0n 0.7500 108299.9n 0.7500 108300.0n 0.2500 108599.9n 0.2500 108600.0n 0.2500 108899.9n 0.2500 108900.0n 0.2500 109199.9n 0.2500 109200.0n 0.7500 109499.9n 0.7500 109500.0n 0.2500 109799.9n 0.2500 109800.0n 0.2500 110099.9n 0.2500 110100.0n 0.2500 110399.9n 0.2500 110400.0n 0.7500 110699.9n 0.7500 110700.0n 0.2500 110999.9n 0.2500 111000.0n 0.2500 111299.9n 0.2500 111300.0n 0.2500 111599.9n 0.2500 111600.0n 0.7500 111899.9n 0.7500 111900.0n 0.2500 112199.9n 0.2500 112200.0n 0.2500 112499.9n 0.2500 112500.0n 0.2500 112799.9n 0.2500 112800.0n 0.7500 113099.9n 0.7500 113100.0n 0.2500 113399.9n 0.2500 113400.0n 0.2500 113699.9n 0.2500 113700.0n 0.2500 113999.9n 0.2500 114000.0n 0.7500 114299.9n 0.7500 114300.0n 0.2500 114599.9n 0.2500 114600.0n 0.2500 114899.9n 0.2500 114900.0n 0.2500 115199.9n 0.2500 115200.0n 0.7500 115499.9n 0.7500 115500.0n 0.2500 115799.9n 0.2500 115800.0n 0.2500 116099.9n 0.2500 116100.0n 0.2500 116399.9n 0.2500 116400.0n 0.7500 116699.9n 0.7500 116700.0n 0.2500 116999.9n 0.2500 117000.0n 0.2500 117299.9n 0.2500 117300.0n 0.2500 117599.9n 0.2500 117600.0n 0.7500 117899.9n 0.7500 117900.0n 0.2500 118199.9n 0.2500 118200.0n 0.2500 118499.9n 0.2500 118500.0n 0.2500 118799.9n 0.2500 118800.0n 0.7500 119099.9n 0.7500 119100.0n 0.2500 119399.9n 0.2500 119400.0n 0.2500 119699.9n 0.2500 119700.0n 0.2500 119999.9n 0.2500 120000.0n 0.7500 120299.9n 0.7500 120300.0n 0.2500 120599.9n 0.2500 120600.0n 0.2500 120899.9n 0.2500 120900.0n 0.2500 121199.9n 0.2500 121200.0n 0.7500 121499.9n 0.7500 121500.0n 0.2500 121799.9n 0.2500 121800.0n 0.2500 122099.9n 0.2500 122100.0n 0.2500 122399.9n 0.2500 122400.0n 0.7500 122699.9n 0.7500 122700.0n 0.2500 122999.9n 0.2500 123000.0n 0.2500 123299.9n 0.2500 123300.0n 0.2500 123599.9n 0.2500 123600.0n 0.7500 123899.9n 0.7500 123900.0n 0.2500 124199.9n 0.2500 124200.0n 0.2500 124499.9n 0.2500 124500.0n 0.2500 124799.9n 0.2500 124800.0n 0.7500 125099.9n 0.7500 125100.0n 0.2500 125399.9n 0.2500 125400.0n 0.2500 125699.9n 0.2500 125700.0n 0.2500 125999.9n 0.2500 126000.0n 0.7500 126299.9n 0.7500 126300.0n 0.2500 126599.9n 0.2500 126600.0n 0.2500 126899.9n 0.2500 126900.0n 0.2500 127199.9n 0.2500 127200.0n 0.7500 127499.9n 0.7500 127500.0n 0.2500 127799.9n 0.2500 127800.0n 0.2500 128099.9n 0.2500 128100.0n 0.2500 128399.9n 0.2500 128400.0n 0.7500 128699.9n 0.7500 128700.0n 0.2500 128999.9n 0.2500 129000.0n 0.2500 129299.9n 0.2500 129300.0n 0.2500 129599.9n 0.2500 129600.0n 0.7500 129899.9n 0.7500 129900.0n 0.2500 130199.9n 0.2500 130200.0n 0.2500 130499.9n 0.2500 130500.0n 0.2500 130799.9n 0.2500 130800.0n 0.7500 131099.9n 0.7500 131100.0n 0.2500 131399.9n 0.2500 131400.0n 0.2500 131699.9n 0.2500 131700.0n 0.2500 131999.9n 0.2500 132000.0n 0.7500 132299.9n 0.7500 132300.0n 0.2500 132599.9n 0.2500 132600.0n 0.2500 132899.9n 0.2500 132900.0n 0.2500 133199.9n 0.2500 133200.0n 0.7500 133499.9n 0.7500 133500.0n 0.2500 133799.9n 0.2500 133800.0n 0.2500 134099.9n 0.2500 134100.0n 0.2500 134399.9n 0.2500 134400.0n 0.7500 134699.9n 0.7500 134700.0n 0.2500 134999.9n 0.2500 135000.0n 0.2500 135299.9n 0.2500 135300.0n 0.2500 135599.9n 0.2500 135600.0n 0.7500 135899.9n 0.7500 135900.0n 0.2500 136199.9n 0.2500 136200.0n 0.2500 136499.9n 0.2500 136500.0n 0.2500 136799.9n 0.2500 136800.0n 0.7500 137099.9n 0.7500 137100.0n 0.2500 137399.9n 0.2500 137400.0n 0.2500 137699.9n 0.2500 137700.0n 0.2500 137999.9n 0.2500 138000.0n 0.7500 138299.9n 0.7500 138300.0n 0.2500 138599.9n 0.2500 138600.0n 0.2500 138899.9n 0.2500 138900.0n 0.2500 139199.9n 0.2500 139200.0n 0.7500 139499.9n 0.7500 139500.0n 0.2500 139799.9n 0.2500 139800.0n 0.2500 140099.9n 0.2500 140100.0n 0.2500 140399.9n 0.2500 140400.0n 0.7500 140699.9n 0.7500 140700.0n 0.2500 140999.9n 0.2500 141000.0n 0.2500 141299.9n 0.2500 141300.0n 0.2500 141599.9n 0.2500 141600.0n 0.7500 141899.9n 0.7500 141900.0n 0.2500 142199.9n 0.2500 142200.0n 0.2500 142499.9n 0.2500 142500.0n 0.2500 142799.9n 0.2500 142800.0n 0.7500 143099.9n 0.7500 143100.0n 0.2500 143399.9n 0.2500 143400.0n 0.2500 143699.9n 0.2500 143700.0n 0.2500)
Cwp1 wp1 0 30p
Cwn1 wn1 0 30p
Rwp1 wp1 wcm 2g
Rwn1 wn1 wcm 2g
X_syn1 a_xp1 a_xn1 wp1 wn1 mop mon vdd vbsyn gsyn
Cwp2 wp2 0 30p
Cwn2 wn2 0 30p
Rwp2 wp2 wcm 2g
Rwn2 wn2 wcm 2g
X_syn2 a_xp2 a_xn2 wp2 wn2 mop mon vdd vbsyn gsyn
Vwcm wcm 0 0.5
Xcm_mo mop mon vdd cmld
Rmo mop mon 20k
Xeo xop xon mop mon eop eon vdd gm esub
X_lrn1 eon eop a_xp1 a_xn1 wp1 wn1 vdd gbl gprod
X_lrn2 eon eop a_xp2 a_xn2 wp2 wn2 vdd gbl gprod
.ic v(wp1)=0.6837 v(wn1)=0.3163
.ic v(wp2)=0.3000 v(wn2)=0.7300
.tran 2n 144000n uic
.control
run
wrdata pc1ror3.dat v(mop) v(mon) v(xop) v(wp1) v(wn1) v(wp2) v(wn2)
.endc
.end
