fully in-spice PC learner
.model NNR NMOS (LEVEL=1 VTO=0.2 KP=120u LAMBDA=0.02 GAMMA=0 PHI=0.7)
.model PNR PMOS (LEVEL=1 VTO=-0.2 KP=40u LAMBDA=0.02 GAMMA=0 PHI=0.7)
.subckt gsyn inp inn wp wn outp outn vdd vbn
Mtail nt vbn 0 0 NNR W=400u L=100u
M5 na wp s5 0 NNR W=200u L=100u
Rd5 s5 nt 12k
M6 nb wn s6 0 NNR W=200u L=100u
Rd6 s6 nt 12k
M1 outp inp s1 0 NNR W=200u L=100u
Rd1 s1 na 12k
M2 outn inn s2 0 NNR W=200u L=100u
Rd2 s2 na 12k
M3 outn inp s3 0 NNR W=200u L=100u
Rd3 s3 nb 12k
M4 outp inn s4 0 NNR W=200u L=100u
Rd4 s4 nb 12k
.ends
.subckt cmld p n vdd
Rcs1 p cmx 300k
Rcs2 n cmx 300k
MLp p cmx vdd vdd PNR W=12000u L=100u
MLn n cmx vdd vdd PNR W=12000u L=100u
.ends
.subckt dneuron up un ap an vdd vbn
M1 an up tn 0 NNR W=200u L=100u
M2 ap un tn 0 NNR W=200u L=100u
Mt tn vbn 0 0 NNR W=200u L=100u
Xcm ap an vdd cmld
.ends
.subckt esub xp xn mp mn ep en vdd vbn
Mt nt vbn 0 0 NNR W=400u L=100u
M1x ep xn nt 0 NNR W=200u L=100u
M2x en xp nt 0 NNR W=200u L=100u
M1m ep mp nt 0 NNR W=200u L=100u
M2m en mn nt 0 NNR W=200u L=100u
RLp vdd ep 50k
RLn vdd en 50k
.ends
.subckt gprod xp xn yp yn wp wn vdd vbn
Mtail nt vbn 0 0 NNR W=400u L=100u
M5 na yp sy5 0 NNR W=200u L=100u
Rg5 sy5 nt 12k
M6 nb yn sy6 0 NNR W=200u L=100u
Rg6 sy6 nt 12k
M1 iop xp sx1 0 NNR W=200u L=100u
Rg1 sx1 na 12k
M2 ion xn sx2 0 NNR W=200u L=100u
Rg2 sx2 na 12k
M3 ion xp sx3 0 NNR W=200u L=100u
Rg3 sx3 nb 12k
M4 iop xn sx4 0 NNR W=200u L=100u
Rg4 sx4 nb 12k
Mlp iop iop vdd vdd PNR W=200u L=100u
Mln ion ion vdd vdd PNR W=200u L=100u
Mpu_wp wp iop vdd vdd PNR W=200u L=100u
MpRn nrn ion vdd vdd PNR W=200u L=100u
MnRn nrn nrn 0 0 NNR W=200u L=100u
Mpd_wp wp nrn 0 0 NNR W=200u L=100u
Mpu_wn wn ion vdd vdd PNR W=200u L=100u
MpRp nrp iop vdd vdd PNR W=200u L=100u
MnRp nrp nrp 0 0 NNR W=200u L=100u
Mpd_wn wn nrp 0 0 NNR W=200u L=100u
.ends
.subckt comp inp inn out vdd vbn
Mt nt vbn 0 0 NNR W=200u L=100u
M1 d1 inp nt 0 NNR W=200u L=100u
M2 out inn nt 0 NNR W=200u L=100u
M3 d1 d1 vdd vdd PNR W=200u L=100u
M4 out d1 vdd vdd PNR W=200u L=100u
.ends
Vdd vdd 0 1.0
Vbsyn vbsyn 0 0.6
Vbneu vbneu 0 0.35
Vgm gm 0 0.6
Vwcm wcm 0 0.5
Vgbl gbl 0 PWL(0.0n 0.00000 139.9n 0.00000 140.0n 0.00000 279.9n 0.00000 280.0n 0.00000 419.9n 0.00000 420.0n 0.00000 559.9n 0.00000 560.0n 0.00000 699.9n 0.00000 700.0n 0.00000 839.9n 0.00000 840.0n 0.00000 979.9n 0.00000 980.0n 0.00000 1119.9n 0.00000 1120.0n 0.00000 1259.9n 0.00000 1260.0n 0.00000 1399.9n 0.00000 1400.0n 0.00000 1539.9n 0.00000 1540.0n 0.00000 1679.9n 0.00000 1680.0n 0.00000 1819.9n 0.00000 1820.0n 0.00000 1959.9n 0.00000 1960.0n 0.00000 2099.9n 0.00000 2100.0n 0.00000 2239.9n 0.00000 2240.0n 0.00000 2379.9n 0.00000 2380.0n 0.00000 2519.9n 0.00000 2520.0n 0.00000 2659.9n 0.00000 2660.0n 0.00000 2799.9n 0.00000 2800.0n 0.00000 2939.9n 0.00000 2940.0n 0.00000 3079.9n 0.00000 3080.0n 0.00000 3219.9n 0.00000 3220.0n 0.00000 3359.9n 0.00000 3360.0n 0.00000 3499.9n 0.00000 3500.0n 0.00000 3639.9n 0.00000 3640.0n 0.00000 3779.9n 0.00000 3780.0n 0.00000 3919.9n 0.00000 3920.0n 0.00000 4059.9n 0.00000 4060.0n 0.00000 4199.9n 0.00000 4200.0n 0.00000 4339.9n 0.00000 4340.0n 0.00000 4479.9n 0.00000 4480.0n 0.00000 4619.9n 0.00000 4620.0n 0.00000 4759.9n 0.00000 4760.0n 0.00000 4899.9n 0.00000 4900.0n 0.00000 5039.9n 0.00000 5040.0n 0.00000 5179.9n 0.00000 5180.0n 0.00000 5319.9n 0.00000 5320.0n 0.00000 5459.9n 0.00000 5460.0n 0.00000 5599.9n 0.00000 5600.0n 0.00000 5739.9n 0.00000 5740.0n 0.00000 5879.9n 0.00000 5880.0n 0.00000 6019.9n 0.00000 6020.0n 0.00000 6159.9n 0.00000 6160.0n 0.00000 6299.9n 0.00000 6300.0n 0.00000 6439.9n 0.00000 6440.0n 0.00000 6579.9n 0.00000 6580.0n 0.00000 6719.9n 0.00000 6720.0n 0.00000 6859.9n 0.00000 6860.0n 0.00000 6999.9n 0.00000 7000.0n 0.00000 7139.9n 0.00000 7140.0n 0.00000 7279.9n 0.00000 7280.0n 0.00000 7419.9n 0.00000 7420.0n 0.00000 7559.9n 0.00000 7560.0n 0.00000 7699.9n 0.00000 7700.0n 0.00000 7839.9n 0.00000 7840.0n 0.00000 7979.9n 0.00000 7980.0n 0.00000 8119.9n 0.00000 8120.0n 0.00000 8259.9n 0.00000 8260.0n 0.00000 8399.9n 0.00000 8400.0n 0.00000 8539.9n 0.00000 8540.0n 0.00000 8679.9n 0.00000 8680.0n 0.00000 8819.9n 0.00000 8820.0n 0.00000 8959.9n 0.00000 8960.0n 0.00000 9099.9n 0.00000 9100.0n 0.00000 9239.9n 0.00000 9240.0n 0.00000 9379.9n 0.00000 9380.0n 0.00000 9519.9n 0.00000 9520.0n 0.00000 9659.9n 0.00000 9660.0n 0.00000 9799.9n 0.00000 9800.0n 0.00000 9939.9n 0.00000 9940.0n 0.00000 10079.9n 0.00000 10080.0n 0.00000 10219.9n 0.00000 10220.0n 0.00000 10359.9n 0.00000 10360.0n 0.00000 10499.9n 0.00000 10500.0n 0.00000 10639.9n 0.00000 10640.0n 0.00000 10779.9n 0.00000 10780.0n 0.00000 10919.9n 0.00000 10920.0n 0.00000 11059.9n 0.00000 11060.0n 0.00000 11199.9n 0.00000 11200.0n 0.00000 11339.9n 0.00000 11340.0n 0.00000 11479.9n 0.00000 11480.0n 0.00000 11619.9n 0.00000 11620.0n 0.00000 11759.9n 0.00000 11760.0n 0.00000 11899.9n 0.00000 11900.0n 0.00000 12039.9n 0.00000 12040.0n 0.00000 12179.9n 0.00000 12180.0n 0.00000 12319.9n 0.00000 12320.0n 0.00000 12459.9n 0.00000 12460.0n 0.00000 12599.9n 0.00000 12600.0n 0.00000 12739.9n 0.00000 12740.0n 0.00000 12879.9n 0.00000 12880.0n 0.00000 13019.9n 0.00000 13020.0n 0.00000 13159.9n 0.00000 13160.0n 0.00000 13299.9n 0.00000 13300.0n 0.00000 13439.9n 0.00000 13440.0n 0.00000 13579.9n 0.00000 13580.0n 0.00000 13719.9n 0.00000 13720.0n 0.00000 13859.9n 0.00000 13860.0n 0.00000 13999.9n 0.00000 14000.0n 0.00000 14139.9n 0.00000 14140.0n 0.00000 14279.9n 0.00000 14280.0n 0.00000 14419.9n 0.00000 14420.0n 0.00000 14559.9n 0.00000 14560.0n 0.00000 14699.9n 0.00000 14700.0n 0.00000 14839.9n 0.00000 14840.0n 0.00000 14979.9n 0.00000 14980.0n 0.00000 15119.9n 0.00000 15120.0n 0.00000 15259.9n 0.00000 15260.0n 0.00000 15399.9n 0.00000 15400.0n 0.00000 15539.9n 0.00000 15540.0n 0.00000)
Vxp0 a_xp0 0 PWL(0.0n 0.17082 139.9n 0.17082 140.0n 0.20119 279.9n 0.20119 280.0n 0.70685 419.9n 0.70685 420.0n 0.55006 559.9n 0.55006 560.0n 0.35630 699.9n 0.35630 700.0n 0.21498 839.9n 0.21498 840.0n 0.56449 979.9n 0.56449 980.0n 0.31139 1119.9n 0.31139 1120.0n 0.55066 1259.9n 0.55066 1260.0n 0.52079 1399.9n 0.52079 1400.0n 0.24079 1539.9n 0.24079 1540.0n 0.73600 1679.9n 0.73600 1680.0n 0.43581 1819.9n 0.43581 1820.0n 0.69502 1959.9n 0.69502 1960.0n 0.48508 2099.9n 0.48508 2100.0n 0.86030 2239.9n 0.86030 2240.0n 0.27643 2379.9n 0.27643 2380.0n 1.36668 2519.9n 1.36668 2520.0n 0.96459 2659.9n 0.96459 2660.0n -0.04662 2799.9n -0.04662 2800.0n 0.88832 2939.9n 0.88832 2940.0n 0.47556 3079.9n 0.47556 3080.0n 0.53141 3219.9n 0.53141 3220.0n 0.69969 3359.9n 0.69969 3360.0n -0.31038 3499.9n -0.31038 3500.0n 0.27076 3639.9n 0.27076 3640.0n 0.26419 3779.9n 0.26419 3780.0n 1.07007 3919.9n 1.07007 3920.0n 0.10559 4059.9n 0.10559 4060.0n -0.14927 4199.9n -0.14927 4200.0n 1.38855 4339.9n 1.38855 4340.0n 1.21890 4479.9n 1.21890 4480.0n 0.57742 4619.9n 0.57742 4620.0n 0.79287 4759.9n 0.79287 4760.0n 0.60090 4899.9n 0.60090 4900.0n 0.23371 5039.9n 0.23371 5040.0n 0.12484 5179.9n 0.12484 5180.0n 0.48351 5319.9n 0.48351 5320.0n 0.52272 5459.9n 0.52272 5460.0n 0.10421 5599.9n 0.10421 5600.0n 0.26187 5739.9n 0.26187 5740.0n 0.26993 5879.9n 0.26993 5880.0n 0.61195 6019.9n 0.61195 6020.0n 0.55435 6159.9n 0.55435 6160.0n 0.15028 6299.9n 0.15028 6300.0n 0.68626 6439.9n 0.68626 6440.0n 0.46500 6579.9n 0.46500 6580.0n 0.34619 6719.9n 0.34619 6720.0n 0.41172 6859.9n 0.41172 6860.0n 0.70707 6999.9n 0.70707 7000.0n 0.65136 7139.9n 0.65136 7140.0n 0.60081 7279.9n 0.60081 7280.0n 0.71496 7419.9n 0.71496 7420.0n 0.09082 7559.9n 0.09082 7560.0n 0.49669 7699.9n 0.49669 7700.0n 0.71193 7839.9n 0.71193 7840.0n 0.76576 7979.9n 0.76576 7980.0n 0.46112 8119.9n 0.46112 8120.0n 0.51272 8259.9n 0.51272 8260.0n 0.49148 8399.9n 0.49148 8400.0n 0.41550 8539.9n 0.41550 8540.0n 0.63432 8679.9n 0.63432 8680.0n 0.79064 8819.9n 0.79064 8820.0n 0.63627 8959.9n 0.63627 8960.0n 0.67402 9099.9n 0.67402 9100.0n 0.45368 9239.9n 0.45368 9240.0n 0.50002 9379.9n 0.50002 9380.0n 0.38242 9519.9n 0.38242 9520.0n 0.31138 9659.9n 0.31138 9660.0n 0.53431 9799.9n 0.53431 9800.0n 0.45766 9939.9n 0.45766 9940.0n 0.55544 10079.9n 0.55544 10080.0n 1.28851 10219.9n 1.28851 10220.0n 1.24585 10359.9n 1.24585 10360.0n -0.15208 10499.9n -0.15208 10500.0n 0.58159 10639.9n 0.58159 10640.0n 0.75662 10779.9n 0.75662 10780.0n -0.49277 10919.9n -0.49277 10920.0n -0.19260 11059.9n -0.19260 11060.0n 1.27962 11199.9n 1.27962 11200.0n 0.44267 11339.9n 0.44267 11340.0n 0.04400 11479.9n 0.04400 11480.0n 1.04710 11619.9n 1.04710 11620.0n 0.19758 11759.9n 0.19758 11760.0n 0.60264 11899.9n 0.60264 11900.0n -0.04029 12039.9n -0.04029 12040.0n 0.36851 12179.9n 0.36851 12180.0n 0.18248 12319.9n 0.18248 12320.0n -0.19808 12459.9n -0.19808 12460.0n -0.39872 12599.9n -0.39872 12600.0n 0.71881 12739.9n 0.71881 12740.0n -0.46004 12879.9n -0.46004 12880.0n 1.19303 13019.9n 1.19303 13020.0n 0.06458 13159.9n 0.06458 13160.0n -0.06311 13299.9n -0.06311 13300.0n -0.11193 13439.9n -0.11193 13440.0n -0.17413 13579.9n -0.17413 13580.0n -0.01300 13719.9n -0.01300 13720.0n -0.13586 13859.9n -0.13586 13860.0n -0.03731 13999.9n -0.03731 14000.0n 0.53061 14139.9n 0.53061 14140.0n 0.42812 14279.9n 0.42812 14280.0n 0.06930 14419.9n 0.06930 14420.0n 0.30688 14559.9n 0.30688 14560.0n 1.13184 14699.9n 1.13184 14700.0n 1.28270 14839.9n 1.28270 14840.0n 0.11220 14979.9n 0.11220 14980.0n 1.03405 15119.9n 1.03405 15120.0n -0.39372 15259.9n -0.39372 15260.0n 0.92206 15399.9n 0.92206 15400.0n 1.41016 15539.9n 1.41016 15540.0n 1.03850)
Vxn0 a_xn0 0 PWL(0.0n 0.82918 139.9n 0.82918 140.0n 0.79881 279.9n 0.79881 280.0n 0.29315 419.9n 0.29315 420.0n 0.44994 559.9n 0.44994 560.0n 0.64370 699.9n 0.64370 700.0n 0.78502 839.9n 0.78502 840.0n 0.43551 979.9n 0.43551 980.0n 0.68861 1119.9n 0.68861 1120.0n 0.44934 1259.9n 0.44934 1260.0n 0.47921 1399.9n 0.47921 1400.0n 0.75921 1539.9n 0.75921 1540.0n 0.26400 1679.9n 0.26400 1680.0n 0.56419 1819.9n 0.56419 1820.0n 0.30498 1959.9n 0.30498 1960.0n 0.51492 2099.9n 0.51492 2100.0n 0.13970 2239.9n 0.13970 2240.0n 0.72357 2379.9n 0.72357 2380.0n -0.36668 2519.9n -0.36668 2520.0n 0.03541 2659.9n 0.03541 2660.0n 1.04662 2799.9n 1.04662 2800.0n 0.11168 2939.9n 0.11168 2940.0n 0.52444 3079.9n 0.52444 3080.0n 0.46859 3219.9n 0.46859 3220.0n 0.30031 3359.9n 0.30031 3360.0n 1.31038 3499.9n 1.31038 3500.0n 0.72924 3639.9n 0.72924 3640.0n 0.73581 3779.9n 0.73581 3780.0n -0.07007 3919.9n -0.07007 3920.0n 0.89441 4059.9n 0.89441 4060.0n 1.14927 4199.9n 1.14927 4200.0n -0.38855 4339.9n -0.38855 4340.0n -0.21890 4479.9n -0.21890 4480.0n 0.42258 4619.9n 0.42258 4620.0n 0.20713 4759.9n 0.20713 4760.0n 0.39910 4899.9n 0.39910 4900.0n 0.76629 5039.9n 0.76629 5040.0n 0.87516 5179.9n 0.87516 5180.0n 0.51649 5319.9n 0.51649 5320.0n 0.47728 5459.9n 0.47728 5460.0n 0.89579 5599.9n 0.89579 5600.0n 0.73813 5739.9n 0.73813 5740.0n 0.73007 5879.9n 0.73007 5880.0n 0.38805 6019.9n 0.38805 6020.0n 0.44565 6159.9n 0.44565 6160.0n 0.84972 6299.9n 0.84972 6300.0n 0.31374 6439.9n 0.31374 6440.0n 0.53500 6579.9n 0.53500 6580.0n 0.65381 6719.9n 0.65381 6720.0n 0.58828 6859.9n 0.58828 6860.0n 0.29293 6999.9n 0.29293 7000.0n 0.34864 7139.9n 0.34864 7140.0n 0.39919 7279.9n 0.39919 7280.0n 0.28504 7419.9n 0.28504 7420.0n 0.90918 7559.9n 0.90918 7560.0n 0.50331 7699.9n 0.50331 7700.0n 0.28807 7839.9n 0.28807 7840.0n 0.23424 7979.9n 0.23424 7980.0n 0.53888 8119.9n 0.53888 8120.0n 0.48728 8259.9n 0.48728 8260.0n 0.50852 8399.9n 0.50852 8400.0n 0.58450 8539.9n 0.58450 8540.0n 0.36568 8679.9n 0.36568 8680.0n 0.20936 8819.9n 0.20936 8820.0n 0.36373 8959.9n 0.36373 8960.0n 0.32598 9099.9n 0.32598 9100.0n 0.54632 9239.9n 0.54632 9240.0n 0.49998 9379.9n 0.49998 9380.0n 0.61758 9519.9n 0.61758 9520.0n 0.68862 9659.9n 0.68862 9660.0n 0.46569 9799.9n 0.46569 9800.0n 0.54234 9939.9n 0.54234 9940.0n 0.44456 10079.9n 0.44456 10080.0n -0.28851 10219.9n -0.28851 10220.0n -0.24585 10359.9n -0.24585 10360.0n 1.15208 10499.9n 1.15208 10500.0n 0.41841 10639.9n 0.41841 10640.0n 0.24338 10779.9n 0.24338 10780.0n 1.49277 10919.9n 1.49277 10920.0n 1.19260 11059.9n 1.19260 11060.0n -0.27962 11199.9n -0.27962 11200.0n 0.55733 11339.9n 0.55733 11340.0n 0.95600 11479.9n 0.95600 11480.0n -0.04710 11619.9n -0.04710 11620.0n 0.80242 11759.9n 0.80242 11760.0n 0.39736 11899.9n 0.39736 11900.0n 1.04029 12039.9n 1.04029 12040.0n 0.63149 12179.9n 0.63149 12180.0n 0.81752 12319.9n 0.81752 12320.0n 1.19808 12459.9n 1.19808 12460.0n 1.39872 12599.9n 1.39872 12600.0n 0.28119 12739.9n 0.28119 12740.0n 1.46004 12879.9n 1.46004 12880.0n -0.19303 13019.9n -0.19303 13020.0n 0.93542 13159.9n 0.93542 13160.0n 1.06311 13299.9n 1.06311 13300.0n 1.11193 13439.9n 1.11193 13440.0n 1.17413 13579.9n 1.17413 13580.0n 1.01300 13719.9n 1.01300 13720.0n 1.13586 13859.9n 1.13586 13860.0n 1.03731 13999.9n 1.03731 14000.0n 0.46939 14139.9n 0.46939 14140.0n 0.57188 14279.9n 0.57188 14280.0n 0.93070 14419.9n 0.93070 14420.0n 0.69312 14559.9n 0.69312 14560.0n -0.13184 14699.9n -0.13184 14700.0n -0.28270 14839.9n -0.28270 14840.0n 0.88780 14979.9n 0.88780 14980.0n -0.03405 15119.9n -0.03405 15120.0n 1.39372 15259.9n 1.39372 15260.0n 0.07794 15399.9n 0.07794 15400.0n -0.41016 15539.9n -0.41016 15540.0n -0.03850)
Vxp1 a_xp1 0 PWL(0.0n 0.66096 139.9n 0.66096 140.0n 0.25911 279.9n 0.25911 280.0n 0.33171 419.9n 0.33171 420.0n 0.63482 559.9n 0.63482 560.0n 0.42554 699.9n 0.42554 700.0n 0.65842 839.9n 0.65842 840.0n 0.28189 979.9n 0.28189 980.0n 0.70122 1119.9n 0.70122 1120.0n 0.76415 1259.9n 0.76415 1260.0n 0.34013 1399.9n 0.34013 1400.0n 0.56595 1539.9n 0.56595 1540.0n 0.23835 1679.9n 0.23835 1680.0n 0.67130 1819.9n 0.67130 1820.0n 0.48458 1959.9n 0.48458 1960.0n 0.29915 2099.9n 0.29915 2100.0n 0.40313 2239.9n 0.40313 2240.0n -0.23386 2379.9n -0.23386 2380.0n 0.13226 2519.9n 0.13226 2520.0n -0.33158 2659.9n -0.33158 2660.0n 1.18224 2799.9n 1.18224 2800.0n -0.08309 2939.9n -0.08309 2940.0n -0.37792 3079.9n -0.37792 3080.0n -0.21828 3219.9n -0.21828 3220.0n 1.23180 3359.9n 1.23180 3360.0n 0.28700 3499.9n 0.28700 3500.0n 1.27694 3639.9n 1.27694 3640.0n -0.15161 3779.9n -0.15161 3780.0n 1.28574 3919.9n 1.28574 3920.0n 1.11225 4059.9n 1.11225 4060.0n 1.17517 4199.9n 1.17517 4200.0n 0.59247 4339.9n 0.59247 4340.0n 1.20712 4479.9n 1.20712 4480.0n 0.36576 4619.9n 0.36576 4620.0n 0.33730 4759.9n 0.33730 4760.0n 0.38385 4899.9n 0.38385 4900.0n 0.59706 5039.9n 0.59706 5040.0n 0.62307 5179.9n 0.62307 5180.0n 0.67018 5319.9n 0.67018 5320.0n 0.70540 5459.9n 0.70540 5460.0n 0.53582 5599.9n 0.53582 5600.0n 0.33357 5739.9n 0.33357 5740.0n 0.52885 5879.9n 0.52885 5880.0n 0.74383 6019.9n 0.74383 6020.0n 0.78409 6159.9n 0.78409 6160.0n 0.51936 6299.9n 0.51936 6300.0n 0.50532 6439.9n 0.50532 6440.0n 0.68189 6579.9n 0.68189 6580.0n 0.79862 6719.9n 0.79862 6720.0n 0.35050 6859.9n 0.35050 6860.0n 0.16858 6999.9n 0.16858 7000.0n 0.55253 7139.9n 0.55253 7140.0n 0.60823 7279.9n 0.60823 7280.0n 0.63611 7419.9n 0.63611 7420.0n 0.41197 7559.9n 0.41197 7560.0n 0.69413 7699.9n 0.69413 7700.0n 0.58457 7839.9n 0.58457 7840.0n 0.33751 7979.9n 0.33751 7980.0n 0.71381 8119.9n 0.71381 8120.0n 0.64266 8259.9n 0.64266 8260.0n 0.16018 8399.9n 0.16018 8400.0n 0.78157 8539.9n 0.78157 8540.0n 0.22203 8679.9n 0.22203 8680.0n 0.66919 8819.9n 0.66919 8820.0n 0.14590 8959.9n 0.14590 8960.0n 0.40891 9099.9n 0.40891 9100.0n 0.15353 9239.9n 0.15353 9240.0n 0.34548 9379.9n 0.34548 9380.0n 0.21355 9519.9n 0.21355 9520.0n 0.50776 9659.9n 0.50776 9660.0n 0.83997 9799.9n 0.83997 9800.0n 0.14358 9939.9n 0.14358 9940.0n 0.24414 10079.9n 0.24414 10080.0n 0.87402 10219.9n 0.87402 10220.0n -0.10545 10359.9n -0.10545 10360.0n -0.25282 10499.9n -0.25282 10500.0n -0.37666 10639.9n -0.37666 10640.0n 1.43391 10779.9n 1.43391 10780.0n 0.37511 10919.9n 0.37511 10920.0n 0.35780 11059.9n 0.35780 11060.0n 1.04281 11199.9n 1.04281 11200.0n 1.30757 11339.9n 1.30757 11340.0n -0.27950 11479.9n -0.27950 11480.0n 0.10137 11619.9n 0.10137 11620.0n 1.20727 11759.9n 1.20727 11760.0n 1.40210 11899.9n 1.40210 11900.0n 1.03003 12039.9n 1.03003 12040.0n -0.27250 12179.9n -0.27250 12180.0n -0.24444 12319.9n -0.24444 12320.0n 0.81835 12459.9n 0.81835 12460.0n 0.11792 12599.9n 0.11792 12600.0n -0.41822 12739.9n -0.41822 12740.0n 0.75242 12879.9n 0.75242 12880.0n 0.57354 13019.9n 0.57354 13020.0n 1.22124 13159.9n 1.22124 13160.0n 1.07258 13299.9n 1.07258 13300.0n 1.14286 13439.9n 1.14286 13440.0n -0.14226 13579.9n -0.14226 13580.0n 1.32817 13719.9n 1.32817 13720.0n 1.08864 13859.9n 1.08864 13860.0n 1.09055 13999.9n 1.09055 14000.0n 1.50665 14139.9n 1.50665 14140.0n -0.21520 14279.9n -0.21520 14280.0n -0.40129 14419.9n -0.40129 14420.0n 1.34099 14559.9n 1.34099 14560.0n -0.28183 14699.9n -0.28183 14700.0n 0.40874 14839.9n 0.40874 14840.0n 1.37702 14979.9n 1.37702 14980.0n -0.18907 15119.9n -0.18907 15120.0n 0.30212 15259.9n 0.30212 15260.0n 1.37596 15399.9n 1.37596 15400.0n 0.59762 15539.9n 0.59762 15540.0n -0.23003)
Vxn1 a_xn1 0 PWL(0.0n 0.33904 139.9n 0.33904 140.0n 0.74089 279.9n 0.74089 280.0n 0.66829 419.9n 0.66829 420.0n 0.36518 559.9n 0.36518 560.0n 0.57446 699.9n 0.57446 700.0n 0.34158 839.9n 0.34158 840.0n 0.71811 979.9n 0.71811 980.0n 0.29878 1119.9n 0.29878 1120.0n 0.23585 1259.9n 0.23585 1260.0n 0.65987 1399.9n 0.65987 1400.0n 0.43405 1539.9n 0.43405 1540.0n 0.76165 1679.9n 0.76165 1680.0n 0.32870 1819.9n 0.32870 1820.0n 0.51542 1959.9n 0.51542 1960.0n 0.70085 2099.9n 0.70085 2100.0n 0.59687 2239.9n 0.59687 2240.0n 1.23386 2379.9n 1.23386 2380.0n 0.86774 2519.9n 0.86774 2520.0n 1.33158 2659.9n 1.33158 2660.0n -0.18224 2799.9n -0.18224 2800.0n 1.08309 2939.9n 1.08309 2940.0n 1.37792 3079.9n 1.37792 3080.0n 1.21828 3219.9n 1.21828 3220.0n -0.23180 3359.9n -0.23180 3360.0n 0.71300 3499.9n 0.71300 3500.0n -0.27694 3639.9n -0.27694 3640.0n 1.15161 3779.9n 1.15161 3780.0n -0.28574 3919.9n -0.28574 3920.0n -0.11225 4059.9n -0.11225 4060.0n -0.17517 4199.9n -0.17517 4200.0n 0.40753 4339.9n 0.40753 4340.0n -0.20712 4479.9n -0.20712 4480.0n 0.63424 4619.9n 0.63424 4620.0n 0.66270 4759.9n 0.66270 4760.0n 0.61615 4899.9n 0.61615 4900.0n 0.40294 5039.9n 0.40294 5040.0n 0.37693 5179.9n 0.37693 5180.0n 0.32982 5319.9n 0.32982 5320.0n 0.29460 5459.9n 0.29460 5460.0n 0.46418 5599.9n 0.46418 5600.0n 0.66643 5739.9n 0.66643 5740.0n 0.47115 5879.9n 0.47115 5880.0n 0.25617 6019.9n 0.25617 6020.0n 0.21591 6159.9n 0.21591 6160.0n 0.48064 6299.9n 0.48064 6300.0n 0.49468 6439.9n 0.49468 6440.0n 0.31811 6579.9n 0.31811 6580.0n 0.20138 6719.9n 0.20138 6720.0n 0.64950 6859.9n 0.64950 6860.0n 0.83142 6999.9n 0.83142 7000.0n 0.44747 7139.9n 0.44747 7140.0n 0.39177 7279.9n 0.39177 7280.0n 0.36389 7419.9n 0.36389 7420.0n 0.58803 7559.9n 0.58803 7560.0n 0.30587 7699.9n 0.30587 7700.0n 0.41543 7839.9n 0.41543 7840.0n 0.66249 7979.9n 0.66249 7980.0n 0.28619 8119.9n 0.28619 8120.0n 0.35734 8259.9n 0.35734 8260.0n 0.83982 8399.9n 0.83982 8400.0n 0.21843 8539.9n 0.21843 8540.0n 0.77797 8679.9n 0.77797 8680.0n 0.33081 8819.9n 0.33081 8820.0n 0.85410 8959.9n 0.85410 8960.0n 0.59109 9099.9n 0.59109 9100.0n 0.84647 9239.9n 0.84647 9240.0n 0.65452 9379.9n 0.65452 9380.0n 0.78645 9519.9n 0.78645 9520.0n 0.49224 9659.9n 0.49224 9660.0n 0.16003 9799.9n 0.16003 9800.0n 0.85642 9939.9n 0.85642 9940.0n 0.75586 10079.9n 0.75586 10080.0n 0.12598 10219.9n 0.12598 10220.0n 1.10545 10359.9n 1.10545 10360.0n 1.25282 10499.9n 1.25282 10500.0n 1.37666 10639.9n 1.37666 10640.0n -0.43391 10779.9n -0.43391 10780.0n 0.62489 10919.9n 0.62489 10920.0n 0.64220 11059.9n 0.64220 11060.0n -0.04281 11199.9n -0.04281 11200.0n -0.30757 11339.9n -0.30757 11340.0n 1.27950 11479.9n 1.27950 11480.0n 0.89863 11619.9n 0.89863 11620.0n -0.20727 11759.9n -0.20727 11760.0n -0.40210 11899.9n -0.40210 11900.0n -0.03003 12039.9n -0.03003 12040.0n 1.27250 12179.9n 1.27250 12180.0n 1.24444 12319.9n 1.24444 12320.0n 0.18165 12459.9n 0.18165 12460.0n 0.88208 12599.9n 0.88208 12600.0n 1.41822 12739.9n 1.41822 12740.0n 0.24758 12879.9n 0.24758 12880.0n 0.42646 13019.9n 0.42646 13020.0n -0.22124 13159.9n -0.22124 13160.0n -0.07258 13299.9n -0.07258 13300.0n -0.14286 13439.9n -0.14286 13440.0n 1.14226 13579.9n 1.14226 13580.0n -0.32817 13719.9n -0.32817 13720.0n -0.08864 13859.9n -0.08864 13860.0n -0.09055 13999.9n -0.09055 14000.0n -0.50665 14139.9n -0.50665 14140.0n 1.21520 14279.9n 1.21520 14280.0n 1.40129 14419.9n 1.40129 14420.0n -0.34099 14559.9n -0.34099 14560.0n 1.28183 14699.9n 1.28183 14700.0n 0.59126 14839.9n 0.59126 14840.0n -0.37702 14979.9n -0.37702 14980.0n 1.18907 15119.9n 1.18907 15120.0n 0.69788 15259.9n 0.69788 15260.0n -0.37596 15399.9n -0.37596 15400.0n 0.40238 15539.9n 0.40238 15540.0n 1.23003)
Vxp2 a_xp2 0 PWL(0.0n 0.80000 139.9n 0.80000 140.0n 0.80000 279.9n 0.80000 280.0n 0.80000 419.9n 0.80000 420.0n 0.80000 559.9n 0.80000 560.0n 0.80000 699.9n 0.80000 700.0n 0.80000 839.9n 0.80000 840.0n 0.80000 979.9n 0.80000 980.0n 0.80000 1119.9n 0.80000 1120.0n 0.80000 1259.9n 0.80000 1260.0n 0.80000 1399.9n 0.80000 1400.0n 0.80000 1539.9n 0.80000 1540.0n 0.80000 1679.9n 0.80000 1680.0n 0.80000 1819.9n 0.80000 1820.0n 0.80000 1959.9n 0.80000 1960.0n 0.80000 2099.9n 0.80000 2100.0n 0.80000 2239.9n 0.80000 2240.0n 0.80000 2379.9n 0.80000 2380.0n 0.80000 2519.9n 0.80000 2520.0n 0.80000 2659.9n 0.80000 2660.0n 0.80000 2799.9n 0.80000 2800.0n 0.80000 2939.9n 0.80000 2940.0n 0.80000 3079.9n 0.80000 3080.0n 0.80000 3219.9n 0.80000 3220.0n 0.80000 3359.9n 0.80000 3360.0n 0.80000 3499.9n 0.80000 3500.0n 0.80000 3639.9n 0.80000 3640.0n 0.80000 3779.9n 0.80000 3780.0n 0.80000 3919.9n 0.80000 3920.0n 0.80000 4059.9n 0.80000 4060.0n 0.80000 4199.9n 0.80000 4200.0n 0.80000 4339.9n 0.80000 4340.0n 0.80000 4479.9n 0.80000 4480.0n 0.80000 4619.9n 0.80000 4620.0n 0.80000 4759.9n 0.80000 4760.0n 0.80000 4899.9n 0.80000 4900.0n 0.80000 5039.9n 0.80000 5040.0n 0.80000 5179.9n 0.80000 5180.0n 0.80000 5319.9n 0.80000 5320.0n 0.80000 5459.9n 0.80000 5460.0n 0.80000 5599.9n 0.80000 5600.0n 0.80000 5739.9n 0.80000 5740.0n 0.80000 5879.9n 0.80000 5880.0n 0.80000 6019.9n 0.80000 6020.0n 0.80000 6159.9n 0.80000 6160.0n 0.80000 6299.9n 0.80000 6300.0n 0.80000 6439.9n 0.80000 6440.0n 0.80000 6579.9n 0.80000 6580.0n 0.80000 6719.9n 0.80000 6720.0n 0.80000 6859.9n 0.80000 6860.0n 0.80000 6999.9n 0.80000 7000.0n 0.80000 7139.9n 0.80000 7140.0n 0.80000 7279.9n 0.80000 7280.0n 0.80000 7419.9n 0.80000 7420.0n 0.80000 7559.9n 0.80000 7560.0n 0.80000 7699.9n 0.80000 7700.0n 0.80000 7839.9n 0.80000 7840.0n 0.80000 7979.9n 0.80000 7980.0n 0.80000 8119.9n 0.80000 8120.0n 0.80000 8259.9n 0.80000 8260.0n 0.80000 8399.9n 0.80000 8400.0n 0.80000 8539.9n 0.80000 8540.0n 0.80000 8679.9n 0.80000 8680.0n 0.80000 8819.9n 0.80000 8820.0n 0.80000 8959.9n 0.80000 8960.0n 0.80000 9099.9n 0.80000 9100.0n 0.80000 9239.9n 0.80000 9240.0n 0.80000 9379.9n 0.80000 9380.0n 0.80000 9519.9n 0.80000 9520.0n 0.80000 9659.9n 0.80000 9660.0n 0.80000 9799.9n 0.80000 9800.0n 0.80000 9939.9n 0.80000 9940.0n 0.80000 10079.9n 0.80000 10080.0n 0.80000 10219.9n 0.80000 10220.0n 0.80000 10359.9n 0.80000 10360.0n 0.80000 10499.9n 0.80000 10500.0n 0.80000 10639.9n 0.80000 10640.0n 0.80000 10779.9n 0.80000 10780.0n 0.80000 10919.9n 0.80000 10920.0n 0.80000 11059.9n 0.80000 11060.0n 0.80000 11199.9n 0.80000 11200.0n 0.80000 11339.9n 0.80000 11340.0n 0.80000 11479.9n 0.80000 11480.0n 0.80000 11619.9n 0.80000 11620.0n 0.80000 11759.9n 0.80000 11760.0n 0.80000 11899.9n 0.80000 11900.0n 0.80000 12039.9n 0.80000 12040.0n 0.80000 12179.9n 0.80000 12180.0n 0.80000 12319.9n 0.80000 12320.0n 0.80000 12459.9n 0.80000 12460.0n 0.80000 12599.9n 0.80000 12600.0n 0.80000 12739.9n 0.80000 12740.0n 0.80000 12879.9n 0.80000 12880.0n 0.80000 13019.9n 0.80000 13020.0n 0.80000 13159.9n 0.80000 13160.0n 0.80000 13299.9n 0.80000 13300.0n 0.80000 13439.9n 0.80000 13440.0n 0.80000 13579.9n 0.80000 13580.0n 0.80000 13719.9n 0.80000 13720.0n 0.80000 13859.9n 0.80000 13860.0n 0.80000 13999.9n 0.80000 14000.0n 0.80000 14139.9n 0.80000 14140.0n 0.80000 14279.9n 0.80000 14280.0n 0.80000 14419.9n 0.80000 14420.0n 0.80000 14559.9n 0.80000 14560.0n 0.80000 14699.9n 0.80000 14700.0n 0.80000 14839.9n 0.80000 14840.0n 0.80000 14979.9n 0.80000 14980.0n 0.80000 15119.9n 0.80000 15120.0n 0.80000 15259.9n 0.80000 15260.0n 0.80000 15399.9n 0.80000 15400.0n 0.80000 15539.9n 0.80000 15540.0n 0.80000)
Vxn2 a_xn2 0 PWL(0.0n 0.20000 139.9n 0.20000 140.0n 0.20000 279.9n 0.20000 280.0n 0.20000 419.9n 0.20000 420.0n 0.20000 559.9n 0.20000 560.0n 0.20000 699.9n 0.20000 700.0n 0.20000 839.9n 0.20000 840.0n 0.20000 979.9n 0.20000 980.0n 0.20000 1119.9n 0.20000 1120.0n 0.20000 1259.9n 0.20000 1260.0n 0.20000 1399.9n 0.20000 1400.0n 0.20000 1539.9n 0.20000 1540.0n 0.20000 1679.9n 0.20000 1680.0n 0.20000 1819.9n 0.20000 1820.0n 0.20000 1959.9n 0.20000 1960.0n 0.20000 2099.9n 0.20000 2100.0n 0.20000 2239.9n 0.20000 2240.0n 0.20000 2379.9n 0.20000 2380.0n 0.20000 2519.9n 0.20000 2520.0n 0.20000 2659.9n 0.20000 2660.0n 0.20000 2799.9n 0.20000 2800.0n 0.20000 2939.9n 0.20000 2940.0n 0.20000 3079.9n 0.20000 3080.0n 0.20000 3219.9n 0.20000 3220.0n 0.20000 3359.9n 0.20000 3360.0n 0.20000 3499.9n 0.20000 3500.0n 0.20000 3639.9n 0.20000 3640.0n 0.20000 3779.9n 0.20000 3780.0n 0.20000 3919.9n 0.20000 3920.0n 0.20000 4059.9n 0.20000 4060.0n 0.20000 4199.9n 0.20000 4200.0n 0.20000 4339.9n 0.20000 4340.0n 0.20000 4479.9n 0.20000 4480.0n 0.20000 4619.9n 0.20000 4620.0n 0.20000 4759.9n 0.20000 4760.0n 0.20000 4899.9n 0.20000 4900.0n 0.20000 5039.9n 0.20000 5040.0n 0.20000 5179.9n 0.20000 5180.0n 0.20000 5319.9n 0.20000 5320.0n 0.20000 5459.9n 0.20000 5460.0n 0.20000 5599.9n 0.20000 5600.0n 0.20000 5739.9n 0.20000 5740.0n 0.20000 5879.9n 0.20000 5880.0n 0.20000 6019.9n 0.20000 6020.0n 0.20000 6159.9n 0.20000 6160.0n 0.20000 6299.9n 0.20000 6300.0n 0.20000 6439.9n 0.20000 6440.0n 0.20000 6579.9n 0.20000 6580.0n 0.20000 6719.9n 0.20000 6720.0n 0.20000 6859.9n 0.20000 6860.0n 0.20000 6999.9n 0.20000 7000.0n 0.20000 7139.9n 0.20000 7140.0n 0.20000 7279.9n 0.20000 7280.0n 0.20000 7419.9n 0.20000 7420.0n 0.20000 7559.9n 0.20000 7560.0n 0.20000 7699.9n 0.20000 7700.0n 0.20000 7839.9n 0.20000 7840.0n 0.20000 7979.9n 0.20000 7980.0n 0.20000 8119.9n 0.20000 8120.0n 0.20000 8259.9n 0.20000 8260.0n 0.20000 8399.9n 0.20000 8400.0n 0.20000 8539.9n 0.20000 8540.0n 0.20000 8679.9n 0.20000 8680.0n 0.20000 8819.9n 0.20000 8820.0n 0.20000 8959.9n 0.20000 8960.0n 0.20000 9099.9n 0.20000 9100.0n 0.20000 9239.9n 0.20000 9240.0n 0.20000 9379.9n 0.20000 9380.0n 0.20000 9519.9n 0.20000 9520.0n 0.20000 9659.9n 0.20000 9660.0n 0.20000 9799.9n 0.20000 9800.0n 0.20000 9939.9n 0.20000 9940.0n 0.20000 10079.9n 0.20000 10080.0n 0.20000 10219.9n 0.20000 10220.0n 0.20000 10359.9n 0.20000 10360.0n 0.20000 10499.9n 0.20000 10500.0n 0.20000 10639.9n 0.20000 10640.0n 0.20000 10779.9n 0.20000 10780.0n 0.20000 10919.9n 0.20000 10920.0n 0.20000 11059.9n 0.20000 11060.0n 0.20000 11199.9n 0.20000 11200.0n 0.20000 11339.9n 0.20000 11340.0n 0.20000 11479.9n 0.20000 11480.0n 0.20000 11619.9n 0.20000 11620.0n 0.20000 11759.9n 0.20000 11760.0n 0.20000 11899.9n 0.20000 11900.0n 0.20000 12039.9n 0.20000 12040.0n 0.20000 12179.9n 0.20000 12180.0n 0.20000 12319.9n 0.20000 12320.0n 0.20000 12459.9n 0.20000 12460.0n 0.20000 12599.9n 0.20000 12600.0n 0.20000 12739.9n 0.20000 12740.0n 0.20000 12879.9n 0.20000 12880.0n 0.20000 13019.9n 0.20000 13020.0n 0.20000 13159.9n 0.20000 13160.0n 0.20000 13299.9n 0.20000 13300.0n 0.20000 13439.9n 0.20000 13440.0n 0.20000 13579.9n 0.20000 13580.0n 0.20000 13719.9n 0.20000 13720.0n 0.20000 13859.9n 0.20000 13860.0n 0.20000 13999.9n 0.20000 14000.0n 0.20000 14139.9n 0.20000 14140.0n 0.20000 14279.9n 0.20000 14280.0n 0.20000 14419.9n 0.20000 14420.0n 0.20000 14559.9n 0.20000 14560.0n 0.20000 14699.9n 0.20000 14700.0n 0.20000 14839.9n 0.20000 14840.0n 0.20000 14979.9n 0.20000 14980.0n 0.20000 15119.9n 0.20000 15120.0n 0.20000 15259.9n 0.20000 15260.0n 0.20000 15399.9n 0.20000 15400.0n 0.20000 15539.9n 0.20000 15540.0n 0.20000)
Vxop0 xop0 0 PWL(0.0n 0.50000 139.9n 0.50000 140.0n 0.50000 279.9n 0.50000 280.0n 0.50000 419.9n 0.50000 420.0n 0.50000 559.9n 0.50000 560.0n 0.50000 699.9n 0.50000 700.0n 0.50000 839.9n 0.50000 840.0n 0.50000 979.9n 0.50000 980.0n 0.50000 1119.9n 0.50000 1120.0n 0.50000 1259.9n 0.50000 1260.0n 0.50000 1399.9n 0.50000 1400.0n 0.50000 1539.9n 0.50000 1540.0n 0.50000 1679.9n 0.50000 1680.0n 0.50000 1819.9n 0.50000 1820.0n 0.50000 1959.9n 0.50000 1960.0n 0.50000 2099.9n 0.50000 2100.0n 0.50000 2239.9n 0.50000 2240.0n 0.50000 2379.9n 0.50000 2380.0n 0.50000 2519.9n 0.50000 2520.0n 0.50000 2659.9n 0.50000 2660.0n 0.50000 2799.9n 0.50000 2800.0n 0.50000 2939.9n 0.50000 2940.0n 0.50000 3079.9n 0.50000 3080.0n 0.50000 3219.9n 0.50000 3220.0n 0.50000 3359.9n 0.50000 3360.0n 0.50000 3499.9n 0.50000 3500.0n 0.50000 3639.9n 0.50000 3640.0n 0.50000 3779.9n 0.50000 3780.0n 0.50000 3919.9n 0.50000 3920.0n 0.50000 4059.9n 0.50000 4060.0n 0.50000 4199.9n 0.50000 4200.0n 0.50000 4339.9n 0.50000 4340.0n 0.50000 4479.9n 0.50000 4480.0n 0.50000 4619.9n 0.50000 4620.0n 0.50000 4759.9n 0.50000 4760.0n 0.50000 4899.9n 0.50000 4900.0n 0.50000 5039.9n 0.50000 5040.0n 0.50000 5179.9n 0.50000 5180.0n 0.50000 5319.9n 0.50000 5320.0n 0.50000 5459.9n 0.50000 5460.0n 0.50000 5599.9n 0.50000 5600.0n 0.50000 5739.9n 0.50000 5740.0n 0.50000 5879.9n 0.50000 5880.0n 0.50000 6019.9n 0.50000 6020.0n 0.50000 6159.9n 0.50000 6160.0n 0.50000 6299.9n 0.50000 6300.0n 0.50000 6439.9n 0.50000 6440.0n 0.50000 6579.9n 0.50000 6580.0n 0.50000 6719.9n 0.50000 6720.0n 0.50000 6859.9n 0.50000 6860.0n 0.50000 6999.9n 0.50000 7000.0n 0.50000 7139.9n 0.50000 7140.0n 0.50000 7279.9n 0.50000 7280.0n 0.50000 7419.9n 0.50000 7420.0n 0.50000 7559.9n 0.50000 7560.0n 0.50000 7699.9n 0.50000 7700.0n 0.50000 7839.9n 0.50000 7840.0n 0.50000 7979.9n 0.50000 7980.0n 0.50000 8119.9n 0.50000 8120.0n 0.50000 8259.9n 0.50000 8260.0n 0.50000 8399.9n 0.50000 8400.0n 0.50000 8539.9n 0.50000 8540.0n 0.50000 8679.9n 0.50000 8680.0n 0.50000 8819.9n 0.50000 8820.0n 0.50000 8959.9n 0.50000 8960.0n 0.50000 9099.9n 0.50000 9100.0n 0.50000 9239.9n 0.50000 9240.0n 0.50000 9379.9n 0.50000 9380.0n 0.50000 9519.9n 0.50000 9520.0n 0.50000 9659.9n 0.50000 9660.0n 0.50000 9799.9n 0.50000 9800.0n 0.50000 9939.9n 0.50000 9940.0n 0.50000 10079.9n 0.50000 10080.0n 0.50000 10219.9n 0.50000 10220.0n 0.50000 10359.9n 0.50000 10360.0n 0.50000 10499.9n 0.50000 10500.0n 0.50000 10639.9n 0.50000 10640.0n 0.50000 10779.9n 0.50000 10780.0n 0.50000 10919.9n 0.50000 10920.0n 0.50000 11059.9n 0.50000 11060.0n 0.50000 11199.9n 0.50000 11200.0n 0.50000 11339.9n 0.50000 11340.0n 0.50000 11479.9n 0.50000 11480.0n 0.50000 11619.9n 0.50000 11620.0n 0.50000 11759.9n 0.50000 11760.0n 0.50000 11899.9n 0.50000 11900.0n 0.50000 12039.9n 0.50000 12040.0n 0.50000 12179.9n 0.50000 12180.0n 0.50000 12319.9n 0.50000 12320.0n 0.50000 12459.9n 0.50000 12460.0n 0.50000 12599.9n 0.50000 12600.0n 0.50000 12739.9n 0.50000 12740.0n 0.50000 12879.9n 0.50000 12880.0n 0.50000 13019.9n 0.50000 13020.0n 0.50000 13159.9n 0.50000 13160.0n 0.50000 13299.9n 0.50000 13300.0n 0.50000 13439.9n 0.50000 13440.0n 0.50000 13579.9n 0.50000 13580.0n 0.50000 13719.9n 0.50000 13720.0n 0.50000 13859.9n 0.50000 13860.0n 0.50000 13999.9n 0.50000 14000.0n 0.50000 14139.9n 0.50000 14140.0n 0.50000 14279.9n 0.50000 14280.0n 0.50000 14419.9n 0.50000 14420.0n 0.50000 14559.9n 0.50000 14560.0n 0.50000 14699.9n 0.50000 14700.0n 0.50000 14839.9n 0.50000 14840.0n 0.50000 14979.9n 0.50000 14980.0n 0.50000 15119.9n 0.50000 15120.0n 0.50000 15259.9n 0.50000 15260.0n 0.50000 15399.9n 0.50000 15400.0n 0.50000 15539.9n 0.50000 15540.0n 0.50000)
Vxon0 xon0 0 PWL(0.0n 0.50000 139.9n 0.50000 140.0n 0.50000 279.9n 0.50000 280.0n 0.50000 419.9n 0.50000 420.0n 0.50000 559.9n 0.50000 560.0n 0.50000 699.9n 0.50000 700.0n 0.50000 839.9n 0.50000 840.0n 0.50000 979.9n 0.50000 980.0n 0.50000 1119.9n 0.50000 1120.0n 0.50000 1259.9n 0.50000 1260.0n 0.50000 1399.9n 0.50000 1400.0n 0.50000 1539.9n 0.50000 1540.0n 0.50000 1679.9n 0.50000 1680.0n 0.50000 1819.9n 0.50000 1820.0n 0.50000 1959.9n 0.50000 1960.0n 0.50000 2099.9n 0.50000 2100.0n 0.50000 2239.9n 0.50000 2240.0n 0.50000 2379.9n 0.50000 2380.0n 0.50000 2519.9n 0.50000 2520.0n 0.50000 2659.9n 0.50000 2660.0n 0.50000 2799.9n 0.50000 2800.0n 0.50000 2939.9n 0.50000 2940.0n 0.50000 3079.9n 0.50000 3080.0n 0.50000 3219.9n 0.50000 3220.0n 0.50000 3359.9n 0.50000 3360.0n 0.50000 3499.9n 0.50000 3500.0n 0.50000 3639.9n 0.50000 3640.0n 0.50000 3779.9n 0.50000 3780.0n 0.50000 3919.9n 0.50000 3920.0n 0.50000 4059.9n 0.50000 4060.0n 0.50000 4199.9n 0.50000 4200.0n 0.50000 4339.9n 0.50000 4340.0n 0.50000 4479.9n 0.50000 4480.0n 0.50000 4619.9n 0.50000 4620.0n 0.50000 4759.9n 0.50000 4760.0n 0.50000 4899.9n 0.50000 4900.0n 0.50000 5039.9n 0.50000 5040.0n 0.50000 5179.9n 0.50000 5180.0n 0.50000 5319.9n 0.50000 5320.0n 0.50000 5459.9n 0.50000 5460.0n 0.50000 5599.9n 0.50000 5600.0n 0.50000 5739.9n 0.50000 5740.0n 0.50000 5879.9n 0.50000 5880.0n 0.50000 6019.9n 0.50000 6020.0n 0.50000 6159.9n 0.50000 6160.0n 0.50000 6299.9n 0.50000 6300.0n 0.50000 6439.9n 0.50000 6440.0n 0.50000 6579.9n 0.50000 6580.0n 0.50000 6719.9n 0.50000 6720.0n 0.50000 6859.9n 0.50000 6860.0n 0.50000 6999.9n 0.50000 7000.0n 0.50000 7139.9n 0.50000 7140.0n 0.50000 7279.9n 0.50000 7280.0n 0.50000 7419.9n 0.50000 7420.0n 0.50000 7559.9n 0.50000 7560.0n 0.50000 7699.9n 0.50000 7700.0n 0.50000 7839.9n 0.50000 7840.0n 0.50000 7979.9n 0.50000 7980.0n 0.50000 8119.9n 0.50000 8120.0n 0.50000 8259.9n 0.50000 8260.0n 0.50000 8399.9n 0.50000 8400.0n 0.50000 8539.9n 0.50000 8540.0n 0.50000 8679.9n 0.50000 8680.0n 0.50000 8819.9n 0.50000 8820.0n 0.50000 8959.9n 0.50000 8960.0n 0.50000 9099.9n 0.50000 9100.0n 0.50000 9239.9n 0.50000 9240.0n 0.50000 9379.9n 0.50000 9380.0n 0.50000 9519.9n 0.50000 9520.0n 0.50000 9659.9n 0.50000 9660.0n 0.50000 9799.9n 0.50000 9800.0n 0.50000 9939.9n 0.50000 9940.0n 0.50000 10079.9n 0.50000 10080.0n 0.50000 10219.9n 0.50000 10220.0n 0.50000 10359.9n 0.50000 10360.0n 0.50000 10499.9n 0.50000 10500.0n 0.50000 10639.9n 0.50000 10640.0n 0.50000 10779.9n 0.50000 10780.0n 0.50000 10919.9n 0.50000 10920.0n 0.50000 11059.9n 0.50000 11060.0n 0.50000 11199.9n 0.50000 11200.0n 0.50000 11339.9n 0.50000 11340.0n 0.50000 11479.9n 0.50000 11480.0n 0.50000 11619.9n 0.50000 11620.0n 0.50000 11759.9n 0.50000 11760.0n 0.50000 11899.9n 0.50000 11900.0n 0.50000 12039.9n 0.50000 12040.0n 0.50000 12179.9n 0.50000 12180.0n 0.50000 12319.9n 0.50000 12320.0n 0.50000 12459.9n 0.50000 12460.0n 0.50000 12599.9n 0.50000 12600.0n 0.50000 12739.9n 0.50000 12740.0n 0.50000 12879.9n 0.50000 12880.0n 0.50000 13019.9n 0.50000 13020.0n 0.50000 13159.9n 0.50000 13160.0n 0.50000 13299.9n 0.50000 13300.0n 0.50000 13439.9n 0.50000 13440.0n 0.50000 13579.9n 0.50000 13580.0n 0.50000 13719.9n 0.50000 13720.0n 0.50000 13859.9n 0.50000 13860.0n 0.50000 13999.9n 0.50000 14000.0n 0.50000 14139.9n 0.50000 14140.0n 0.50000 14279.9n 0.50000 14280.0n 0.50000 14419.9n 0.50000 14420.0n 0.50000 14559.9n 0.50000 14560.0n 0.50000 14699.9n 0.50000 14700.0n 0.50000 14839.9n 0.50000 14840.0n 0.50000 14979.9n 0.50000 14980.0n 0.50000 15119.9n 0.50000 15120.0n 0.50000 15259.9n 0.50000 15260.0n 0.50000 15399.9n 0.50000 15400.0n 0.50000 15539.9n 0.50000 15540.0n 0.50000)
Vxop1 xop1 0 PWL(0.0n 0.50000 139.9n 0.50000 140.0n 0.50000 279.9n 0.50000 280.0n 0.50000 419.9n 0.50000 420.0n 0.50000 559.9n 0.50000 560.0n 0.50000 699.9n 0.50000 700.0n 0.50000 839.9n 0.50000 840.0n 0.50000 979.9n 0.50000 980.0n 0.50000 1119.9n 0.50000 1120.0n 0.50000 1259.9n 0.50000 1260.0n 0.50000 1399.9n 0.50000 1400.0n 0.50000 1539.9n 0.50000 1540.0n 0.50000 1679.9n 0.50000 1680.0n 0.50000 1819.9n 0.50000 1820.0n 0.50000 1959.9n 0.50000 1960.0n 0.50000 2099.9n 0.50000 2100.0n 0.50000 2239.9n 0.50000 2240.0n 0.50000 2379.9n 0.50000 2380.0n 0.50000 2519.9n 0.50000 2520.0n 0.50000 2659.9n 0.50000 2660.0n 0.50000 2799.9n 0.50000 2800.0n 0.50000 2939.9n 0.50000 2940.0n 0.50000 3079.9n 0.50000 3080.0n 0.50000 3219.9n 0.50000 3220.0n 0.50000 3359.9n 0.50000 3360.0n 0.50000 3499.9n 0.50000 3500.0n 0.50000 3639.9n 0.50000 3640.0n 0.50000 3779.9n 0.50000 3780.0n 0.50000 3919.9n 0.50000 3920.0n 0.50000 4059.9n 0.50000 4060.0n 0.50000 4199.9n 0.50000 4200.0n 0.50000 4339.9n 0.50000 4340.0n 0.50000 4479.9n 0.50000 4480.0n 0.50000 4619.9n 0.50000 4620.0n 0.50000 4759.9n 0.50000 4760.0n 0.50000 4899.9n 0.50000 4900.0n 0.50000 5039.9n 0.50000 5040.0n 0.50000 5179.9n 0.50000 5180.0n 0.50000 5319.9n 0.50000 5320.0n 0.50000 5459.9n 0.50000 5460.0n 0.50000 5599.9n 0.50000 5600.0n 0.50000 5739.9n 0.50000 5740.0n 0.50000 5879.9n 0.50000 5880.0n 0.50000 6019.9n 0.50000 6020.0n 0.50000 6159.9n 0.50000 6160.0n 0.50000 6299.9n 0.50000 6300.0n 0.50000 6439.9n 0.50000 6440.0n 0.50000 6579.9n 0.50000 6580.0n 0.50000 6719.9n 0.50000 6720.0n 0.50000 6859.9n 0.50000 6860.0n 0.50000 6999.9n 0.50000 7000.0n 0.50000 7139.9n 0.50000 7140.0n 0.50000 7279.9n 0.50000 7280.0n 0.50000 7419.9n 0.50000 7420.0n 0.50000 7559.9n 0.50000 7560.0n 0.50000 7699.9n 0.50000 7700.0n 0.50000 7839.9n 0.50000 7840.0n 0.50000 7979.9n 0.50000 7980.0n 0.50000 8119.9n 0.50000 8120.0n 0.50000 8259.9n 0.50000 8260.0n 0.50000 8399.9n 0.50000 8400.0n 0.50000 8539.9n 0.50000 8540.0n 0.50000 8679.9n 0.50000 8680.0n 0.50000 8819.9n 0.50000 8820.0n 0.50000 8959.9n 0.50000 8960.0n 0.50000 9099.9n 0.50000 9100.0n 0.50000 9239.9n 0.50000 9240.0n 0.50000 9379.9n 0.50000 9380.0n 0.50000 9519.9n 0.50000 9520.0n 0.50000 9659.9n 0.50000 9660.0n 0.50000 9799.9n 0.50000 9800.0n 0.50000 9939.9n 0.50000 9940.0n 0.50000 10079.9n 0.50000 10080.0n 0.50000 10219.9n 0.50000 10220.0n 0.50000 10359.9n 0.50000 10360.0n 0.50000 10499.9n 0.50000 10500.0n 0.50000 10639.9n 0.50000 10640.0n 0.50000 10779.9n 0.50000 10780.0n 0.50000 10919.9n 0.50000 10920.0n 0.50000 11059.9n 0.50000 11060.0n 0.50000 11199.9n 0.50000 11200.0n 0.50000 11339.9n 0.50000 11340.0n 0.50000 11479.9n 0.50000 11480.0n 0.50000 11619.9n 0.50000 11620.0n 0.50000 11759.9n 0.50000 11760.0n 0.50000 11899.9n 0.50000 11900.0n 0.50000 12039.9n 0.50000 12040.0n 0.50000 12179.9n 0.50000 12180.0n 0.50000 12319.9n 0.50000 12320.0n 0.50000 12459.9n 0.50000 12460.0n 0.50000 12599.9n 0.50000 12600.0n 0.50000 12739.9n 0.50000 12740.0n 0.50000 12879.9n 0.50000 12880.0n 0.50000 13019.9n 0.50000 13020.0n 0.50000 13159.9n 0.50000 13160.0n 0.50000 13299.9n 0.50000 13300.0n 0.50000 13439.9n 0.50000 13440.0n 0.50000 13579.9n 0.50000 13580.0n 0.50000 13719.9n 0.50000 13720.0n 0.50000 13859.9n 0.50000 13860.0n 0.50000 13999.9n 0.50000 14000.0n 0.50000 14139.9n 0.50000 14140.0n 0.50000 14279.9n 0.50000 14280.0n 0.50000 14419.9n 0.50000 14420.0n 0.50000 14559.9n 0.50000 14560.0n 0.50000 14699.9n 0.50000 14700.0n 0.50000 14839.9n 0.50000 14840.0n 0.50000 14979.9n 0.50000 14980.0n 0.50000 15119.9n 0.50000 15120.0n 0.50000 15259.9n 0.50000 15260.0n 0.50000 15399.9n 0.50000 15400.0n 0.50000 15539.9n 0.50000 15540.0n 0.50000)
Vxon1 xon1 0 PWL(0.0n 0.50000 139.9n 0.50000 140.0n 0.50000 279.9n 0.50000 280.0n 0.50000 419.9n 0.50000 420.0n 0.50000 559.9n 0.50000 560.0n 0.50000 699.9n 0.50000 700.0n 0.50000 839.9n 0.50000 840.0n 0.50000 979.9n 0.50000 980.0n 0.50000 1119.9n 0.50000 1120.0n 0.50000 1259.9n 0.50000 1260.0n 0.50000 1399.9n 0.50000 1400.0n 0.50000 1539.9n 0.50000 1540.0n 0.50000 1679.9n 0.50000 1680.0n 0.50000 1819.9n 0.50000 1820.0n 0.50000 1959.9n 0.50000 1960.0n 0.50000 2099.9n 0.50000 2100.0n 0.50000 2239.9n 0.50000 2240.0n 0.50000 2379.9n 0.50000 2380.0n 0.50000 2519.9n 0.50000 2520.0n 0.50000 2659.9n 0.50000 2660.0n 0.50000 2799.9n 0.50000 2800.0n 0.50000 2939.9n 0.50000 2940.0n 0.50000 3079.9n 0.50000 3080.0n 0.50000 3219.9n 0.50000 3220.0n 0.50000 3359.9n 0.50000 3360.0n 0.50000 3499.9n 0.50000 3500.0n 0.50000 3639.9n 0.50000 3640.0n 0.50000 3779.9n 0.50000 3780.0n 0.50000 3919.9n 0.50000 3920.0n 0.50000 4059.9n 0.50000 4060.0n 0.50000 4199.9n 0.50000 4200.0n 0.50000 4339.9n 0.50000 4340.0n 0.50000 4479.9n 0.50000 4480.0n 0.50000 4619.9n 0.50000 4620.0n 0.50000 4759.9n 0.50000 4760.0n 0.50000 4899.9n 0.50000 4900.0n 0.50000 5039.9n 0.50000 5040.0n 0.50000 5179.9n 0.50000 5180.0n 0.50000 5319.9n 0.50000 5320.0n 0.50000 5459.9n 0.50000 5460.0n 0.50000 5599.9n 0.50000 5600.0n 0.50000 5739.9n 0.50000 5740.0n 0.50000 5879.9n 0.50000 5880.0n 0.50000 6019.9n 0.50000 6020.0n 0.50000 6159.9n 0.50000 6160.0n 0.50000 6299.9n 0.50000 6300.0n 0.50000 6439.9n 0.50000 6440.0n 0.50000 6579.9n 0.50000 6580.0n 0.50000 6719.9n 0.50000 6720.0n 0.50000 6859.9n 0.50000 6860.0n 0.50000 6999.9n 0.50000 7000.0n 0.50000 7139.9n 0.50000 7140.0n 0.50000 7279.9n 0.50000 7280.0n 0.50000 7419.9n 0.50000 7420.0n 0.50000 7559.9n 0.50000 7560.0n 0.50000 7699.9n 0.50000 7700.0n 0.50000 7839.9n 0.50000 7840.0n 0.50000 7979.9n 0.50000 7980.0n 0.50000 8119.9n 0.50000 8120.0n 0.50000 8259.9n 0.50000 8260.0n 0.50000 8399.9n 0.50000 8400.0n 0.50000 8539.9n 0.50000 8540.0n 0.50000 8679.9n 0.50000 8680.0n 0.50000 8819.9n 0.50000 8820.0n 0.50000 8959.9n 0.50000 8960.0n 0.50000 9099.9n 0.50000 9100.0n 0.50000 9239.9n 0.50000 9240.0n 0.50000 9379.9n 0.50000 9380.0n 0.50000 9519.9n 0.50000 9520.0n 0.50000 9659.9n 0.50000 9660.0n 0.50000 9799.9n 0.50000 9800.0n 0.50000 9939.9n 0.50000 9940.0n 0.50000 10079.9n 0.50000 10080.0n 0.50000 10219.9n 0.50000 10220.0n 0.50000 10359.9n 0.50000 10360.0n 0.50000 10499.9n 0.50000 10500.0n 0.50000 10639.9n 0.50000 10640.0n 0.50000 10779.9n 0.50000 10780.0n 0.50000 10919.9n 0.50000 10920.0n 0.50000 11059.9n 0.50000 11060.0n 0.50000 11199.9n 0.50000 11200.0n 0.50000 11339.9n 0.50000 11340.0n 0.50000 11479.9n 0.50000 11480.0n 0.50000 11619.9n 0.50000 11620.0n 0.50000 11759.9n 0.50000 11760.0n 0.50000 11899.9n 0.50000 11900.0n 0.50000 12039.9n 0.50000 12040.0n 0.50000 12179.9n 0.50000 12180.0n 0.50000 12319.9n 0.50000 12320.0n 0.50000 12459.9n 0.50000 12460.0n 0.50000 12599.9n 0.50000 12600.0n 0.50000 12739.9n 0.50000 12740.0n 0.50000 12879.9n 0.50000 12880.0n 0.50000 13019.9n 0.50000 13020.0n 0.50000 13159.9n 0.50000 13160.0n 0.50000 13299.9n 0.50000 13300.0n 0.50000 13439.9n 0.50000 13440.0n 0.50000 13579.9n 0.50000 13580.0n 0.50000 13719.9n 0.50000 13720.0n 0.50000 13859.9n 0.50000 13860.0n 0.50000 13999.9n 0.50000 14000.0n 0.50000 14139.9n 0.50000 14140.0n 0.50000 14279.9n 0.50000 14280.0n 0.50000 14419.9n 0.50000 14420.0n 0.50000 14559.9n 0.50000 14560.0n 0.50000 14699.9n 0.50000 14700.0n 0.50000 14839.9n 0.50000 14840.0n 0.50000 14979.9n 0.50000 14980.0n 0.50000 15119.9n 0.50000 15120.0n 0.50000 15259.9n 0.50000 15260.0n 0.50000 15399.9n 0.50000 15400.0n 0.50000 15539.9n 0.50000 15540.0n 0.50000)
Vwih_p_0_0 wih_p_0_0 0 0.9
Vwih_n_0_0 wih_n_0_0 0 0.3
Vwih_p_1_0 wih_p_1_0 0 0.3
Vwih_n_1_0 wih_n_1_0 0 0.8077526372768347
Vwih_p_2_0 wih_p_2_0 0 0.9
Vwih_n_2_0 wih_n_2_0 0 0.3
Xcm_xh0 xhp0 xhn0 vdd cmld
Rnd_xh0 xhp0 xhn0 20k
Cxh0p xhp0 0 1e-13
Cxh0n xhn0 0 1e-13
Xih_0_0 a_xp0 a_xn0 wih_p_0_0 wih_n_0_0 xhp0 xhn0 vdd vbsyn gsyn
Xih_1_0 a_xp1 a_xn1 wih_p_1_0 wih_n_1_0 xhp0 xhn0 vdd vbsyn gsyn
Xih_2_0 a_xp2 a_xn2 wih_p_2_0 wih_n_2_0 xhp0 xhn0 vdd vbsyn gsyn
Xn0 xhp0 xhn0 ahp0 ahn0 vdd vbneu dneuron
Vwih_p_0_1 wih_p_0_1 0 0.4076074543279496
Vwih_n_0_1 wih_n_0_1 0 0.5923925456720505
Vwih_p_1_1 wih_p_1_1 0 0.6875517955179162
Vwih_n_1_1 wih_n_1_1 0 0.31244820448208377
Vwih_p_2_1 wih_p_2_1 0 0.9
Vwih_n_2_1 wih_n_2_1 0 0.3
Xcm_xh1 xhp1 xhn1 vdd cmld
Rnd_xh1 xhp1 xhn1 20k
Cxh1p xhp1 0 1e-13
Cxh1n xhn1 0 1e-13
Xih_0_1 a_xp0 a_xn0 wih_p_0_1 wih_n_0_1 xhp1 xhn1 vdd vbsyn gsyn
Xih_1_1 a_xp1 a_xn1 wih_p_1_1 wih_n_1_1 xhp1 xhn1 vdd vbsyn gsyn
Xih_2_1 a_xp2 a_xn2 wih_p_2_1 wih_n_2_1 xhp1 xhn1 vdd vbsyn gsyn
Xn1 xhp1 xhn1 ahp1 ahn1 vdd vbneu dneuron
Vwih_p_0_2 wih_p_0_2 0 0.6986905748958001
Vwih_n_0_2 wih_n_0_2 0 0.30130942510419984
Vwih_p_1_2 wih_p_1_2 0 0.8611596583173695
Vwih_n_1_2 wih_n_1_2 0 0.3
Vwih_p_2_2 wih_p_2_2 0 0.3
Vwih_n_2_2 wih_n_2_2 0 0.9
Xcm_xh2 xhp2 xhn2 vdd cmld
Rnd_xh2 xhp2 xhn2 20k
Cxh2p xhp2 0 1e-13
Cxh2n xhn2 0 1e-13
Xih_0_2 a_xp0 a_xn0 wih_p_0_2 wih_n_0_2 xhp2 xhn2 vdd vbsyn gsyn
Xih_1_2 a_xp1 a_xn1 wih_p_1_2 wih_n_1_2 xhp2 xhn2 vdd vbsyn gsyn
Xih_2_2 a_xp2 a_xn2 wih_p_2_2 wih_n_2_2 xhp2 xhn2 vdd vbsyn gsyn
Xn2 xhp2 xhn2 ahp2 ahn2 vdd vbneu dneuron
Vwih_p_0_3 wih_p_0_3 0 0.3
Vwih_n_0_3 wih_n_0_3 0 0.7073156875091838
Vwih_p_1_3 wih_p_1_3 0 0.9
Vwih_n_1_3 wih_n_1_3 0 0.3
Vwih_p_2_3 wih_p_2_3 0 0.3968886139217385
Vwih_n_2_3 wih_n_2_3 0 0.6031113860782614
Xcm_xh3 xhp3 xhn3 vdd cmld
Rnd_xh3 xhp3 xhn3 20k
Cxh3p xhp3 0 1e-13
Cxh3n xhn3 0 1e-13
Xih_0_3 a_xp0 a_xn0 wih_p_0_3 wih_n_0_3 xhp3 xhn3 vdd vbsyn gsyn
Xih_1_3 a_xp1 a_xn1 wih_p_1_3 wih_n_1_3 xhp3 xhn3 vdd vbsyn gsyn
Xih_2_3 a_xp2 a_xn2 wih_p_2_3 wih_n_2_3 xhp3 xhn3 vdd vbsyn gsyn
Xn3 xhp3 xhn3 ahp3 ahn3 vdd vbneu dneuron
Vwih_p_0_4 wih_p_0_4 0 0.643383333655023
Vwih_n_0_4 wih_n_0_4 0 0.356616666344977
Vwih_p_1_4 wih_p_1_4 0 0.426609605197966
Vwih_n_1_4 wih_n_1_4 0 0.573390394802034
Vwih_p_2_4 wih_p_2_4 0 0.3
Vwih_n_2_4 wih_n_2_4 0 0.779710110256914
Xcm_xh4 xhp4 xhn4 vdd cmld
Rnd_xh4 xhp4 xhn4 20k
Cxh4p xhp4 0 1e-13
Cxh4n xhn4 0 1e-13
Xih_0_4 a_xp0 a_xn0 wih_p_0_4 wih_n_0_4 xhp4 xhn4 vdd vbsyn gsyn
Xih_1_4 a_xp1 a_xn1 wih_p_1_4 wih_n_1_4 xhp4 xhn4 vdd vbsyn gsyn
Xih_2_4 a_xp2 a_xn2 wih_p_2_4 wih_n_2_4 xhp4 xhn4 vdd vbsyn gsyn
Xn4 xhp4 xhn4 ahp4 ahn4 vdd vbneu dneuron
Vwih_p_0_5 wih_p_0_5 0 0.3
Vwih_n_0_5 wih_n_0_5 0 0.9
Vwih_p_1_5 wih_p_1_5 0 0.3
Vwih_n_1_5 wih_n_1_5 0 0.9
Vwih_p_2_5 wih_p_2_5 0 0.9
Vwih_n_2_5 wih_n_2_5 0 0.3
Xcm_xh5 xhp5 xhn5 vdd cmld
Rnd_xh5 xhp5 xhn5 20k
Cxh5p xhp5 0 1e-13
Cxh5n xhn5 0 1e-13
Xih_0_5 a_xp0 a_xn0 wih_p_0_5 wih_n_0_5 xhp5 xhn5 vdd vbsyn gsyn
Xih_1_5 a_xp1 a_xn1 wih_p_1_5 wih_n_1_5 xhp5 xhn5 vdd vbsyn gsyn
Xih_2_5 a_xp2 a_xn2 wih_p_2_5 wih_n_2_5 xhp5 xhn5 vdd vbsyn gsyn
Xn5 xhp5 xhn5 ahp5 ahn5 vdd vbneu dneuron
Vwih_p_0_6 wih_p_0_6 0 0.4644227134047597
Vwih_n_0_6 wih_n_0_6 0 0.5355772865952403
Vwih_p_1_6 wih_p_1_6 0 0.3
Vwih_n_1_6 wih_n_1_6 0 0.9
Vwih_p_2_6 wih_p_2_6 0 0.3
Vwih_n_2_6 wih_n_2_6 0 0.9
Xcm_xh6 xhp6 xhn6 vdd cmld
Rnd_xh6 xhp6 xhn6 20k
Cxh6p xhp6 0 1e-13
Cxh6n xhn6 0 1e-13
Xih_0_6 a_xp0 a_xn0 wih_p_0_6 wih_n_0_6 xhp6 xhn6 vdd vbsyn gsyn
Xih_1_6 a_xp1 a_xn1 wih_p_1_6 wih_n_1_6 xhp6 xhn6 vdd vbsyn gsyn
Xih_2_6 a_xp2 a_xn2 wih_p_2_6 wih_n_2_6 xhp6 xhn6 vdd vbsyn gsyn
Xn6 xhp6 xhn6 ahp6 ahn6 vdd vbneu dneuron
Vwih_p_0_7 wih_p_0_7 0 0.8930428788399948
Vwih_n_0_7 wih_n_0_7 0 0.3
Vwih_p_1_7 wih_p_1_7 0 0.3
Vwih_n_1_7 wih_n_1_7 0 0.9
Vwih_p_2_7 wih_p_2_7 0 0.3
Vwih_n_2_7 wih_n_2_7 0 0.7814083238372862
Xcm_xh7 xhp7 xhn7 vdd cmld
Rnd_xh7 xhp7 xhn7 20k
Cxh7p xhp7 0 1e-13
Cxh7n xhn7 0 1e-13
Xih_0_7 a_xp0 a_xn0 wih_p_0_7 wih_n_0_7 xhp7 xhn7 vdd vbsyn gsyn
Xih_1_7 a_xp1 a_xn1 wih_p_1_7 wih_n_1_7 xhp7 xhn7 vdd vbsyn gsyn
Xih_2_7 a_xp2 a_xn2 wih_p_2_7 wih_n_2_7 xhp7 xhn7 vdd vbsyn gsyn
Xn7 xhp7 xhn7 ahp7 ahn7 vdd vbneu dneuron
Vwih_p_0_8 wih_p_0_8 0 0.3
Vwih_n_0_8 wih_n_0_8 0 0.9
Vwih_p_1_8 wih_p_1_8 0 0.3
Vwih_n_1_8 wih_n_1_8 0 0.9
Vwih_p_2_8 wih_p_2_8 0 0.9
Vwih_n_2_8 wih_n_2_8 0 0.3
Xcm_xh8 xhp8 xhn8 vdd cmld
Rnd_xh8 xhp8 xhn8 20k
Cxh8p xhp8 0 1e-13
Cxh8n xhn8 0 1e-13
Xih_0_8 a_xp0 a_xn0 wih_p_0_8 wih_n_0_8 xhp8 xhn8 vdd vbsyn gsyn
Xih_1_8 a_xp1 a_xn1 wih_p_1_8 wih_n_1_8 xhp8 xhn8 vdd vbsyn gsyn
Xih_2_8 a_xp2 a_xn2 wih_p_2_8 wih_n_2_8 xhp8 xhn8 vdd vbsyn gsyn
Xn8 xhp8 xhn8 ahp8 ahn8 vdd vbneu dneuron
Vwih_p_0_9 wih_p_0_9 0 0.43659969851895275
Vwih_n_0_9 wih_n_0_9 0 0.5634003014810472
Vwih_p_1_9 wih_p_1_9 0 0.35532188681769517
Vwih_n_1_9 wih_n_1_9 0 0.6446781131823048
Vwih_p_2_9 wih_p_2_9 0 0.3
Vwih_n_2_9 wih_n_2_9 0 0.770652332104687
Xcm_xh9 xhp9 xhn9 vdd cmld
Rnd_xh9 xhp9 xhn9 20k
Cxh9p xhp9 0 1e-13
Cxh9n xhn9 0 1e-13
Xih_0_9 a_xp0 a_xn0 wih_p_0_9 wih_n_0_9 xhp9 xhn9 vdd vbsyn gsyn
Xih_1_9 a_xp1 a_xn1 wih_p_1_9 wih_n_1_9 xhp9 xhn9 vdd vbsyn gsyn
Xih_2_9 a_xp2 a_xn2 wih_p_2_9 wih_n_2_9 xhp9 xhn9 vdd vbsyn gsyn
Xn9 xhp9 xhn9 ahp9 ahn9 vdd vbneu dneuron
Vwih_p_0_10 wih_p_0_10 0 0.8206037983083873
Vwih_n_0_10 wih_n_0_10 0 0.3
Vwih_p_1_10 wih_p_1_10 0 0.5276620970012434
Vwih_n_1_10 wih_n_1_10 0 0.47233790299875655
Vwih_p_2_10 wih_p_2_10 0 0.6315537008964082
Vwih_n_2_10 wih_n_2_10 0 0.36844629910359183
Xcm_xh10 xhp10 xhn10 vdd cmld
Rnd_xh10 xhp10 xhn10 20k
Cxh10p xhp10 0 1e-13
Cxh10n xhn10 0 1e-13
Xih_0_10 a_xp0 a_xn0 wih_p_0_10 wih_n_0_10 xhp10 xhn10 vdd vbsyn gsyn
Xih_1_10 a_xp1 a_xn1 wih_p_1_10 wih_n_1_10 xhp10 xhn10 vdd vbsyn gsyn
Xih_2_10 a_xp2 a_xn2 wih_p_2_10 wih_n_2_10 xhp10 xhn10 vdd vbsyn gsyn
Xn10 xhp10 xhn10 ahp10 ahn10 vdd vbneu dneuron
Vwih_p_0_11 wih_p_0_11 0 0.5615896328228672
Vwih_n_0_11 wih_n_0_11 0 0.4384103671771328
Vwih_p_1_11 wih_p_1_11 0 0.3392052445189821
Vwih_n_1_11 wih_n_1_11 0 0.6607947554810178
Vwih_p_2_11 wih_p_2_11 0 0.3
Vwih_n_2_11 wih_n_2_11 0 0.7163998120574444
Xcm_xh11 xhp11 xhn11 vdd cmld
Rnd_xh11 xhp11 xhn11 20k
Cxh11p xhp11 0 1e-13
Cxh11n xhn11 0 1e-13
Xih_0_11 a_xp0 a_xn0 wih_p_0_11 wih_n_0_11 xhp11 xhn11 vdd vbsyn gsyn
Xih_1_11 a_xp1 a_xn1 wih_p_1_11 wih_n_1_11 xhp11 xhn11 vdd vbsyn gsyn
Xih_2_11 a_xp2 a_xn2 wih_p_2_11 wih_n_2_11 xhp11 xhn11 vdd vbsyn gsyn
Xn11 xhp11 xhn11 ahp11 ahn11 vdd vbneu dneuron
Vwih_p_0_12 wih_p_0_12 0 0.3
Vwih_n_0_12 wih_n_0_12 0 0.9
Vwih_p_1_12 wih_p_1_12 0 0.3
Vwih_n_1_12 wih_n_1_12 0 0.7213002021183876
Vwih_p_2_12 wih_p_2_12 0 0.9
Vwih_n_2_12 wih_n_2_12 0 0.3
Xcm_xh12 xhp12 xhn12 vdd cmld
Rnd_xh12 xhp12 xhn12 20k
Cxh12p xhp12 0 1e-13
Cxh12n xhn12 0 1e-13
Xih_0_12 a_xp0 a_xn0 wih_p_0_12 wih_n_0_12 xhp12 xhn12 vdd vbsyn gsyn
Xih_1_12 a_xp1 a_xn1 wih_p_1_12 wih_n_1_12 xhp12 xhn12 vdd vbsyn gsyn
Xih_2_12 a_xp2 a_xn2 wih_p_2_12 wih_n_2_12 xhp12 xhn12 vdd vbsyn gsyn
Xn12 xhp12 xhn12 ahp12 ahn12 vdd vbneu dneuron
Vwih_p_0_13 wih_p_0_13 0 0.3
Vwih_n_0_13 wih_n_0_13 0 0.9
Vwih_p_1_13 wih_p_1_13 0 0.5019673310802524
Vwih_n_1_13 wih_n_1_13 0 0.4980326689197476
Vwih_p_2_13 wih_p_2_13 0 0.6510764412903762
Vwih_n_2_13 wih_n_2_13 0 0.3489235587096237
Xcm_xh13 xhp13 xhn13 vdd cmld
Rnd_xh13 xhp13 xhn13 20k
Cxh13p xhp13 0 1e-13
Cxh13n xhn13 0 1e-13
Xih_0_13 a_xp0 a_xn0 wih_p_0_13 wih_n_0_13 xhp13 xhn13 vdd vbsyn gsyn
Xih_1_13 a_xp1 a_xn1 wih_p_1_13 wih_n_1_13 xhp13 xhn13 vdd vbsyn gsyn
Xih_2_13 a_xp2 a_xn2 wih_p_2_13 wih_n_2_13 xhp13 xhn13 vdd vbsyn gsyn
Xn13 xhp13 xhn13 ahp13 ahn13 vdd vbneu dneuron
Vwih_p_0_14 wih_p_0_14 0 0.9
Vwih_n_0_14 wih_n_0_14 0 0.3
Vwih_p_1_14 wih_p_1_14 0 0.9
Vwih_n_1_14 wih_n_1_14 0 0.3
Vwih_p_2_14 wih_p_2_14 0 0.321441830538693
Vwih_n_2_14 wih_n_2_14 0 0.678558169461307
Xcm_xh14 xhp14 xhn14 vdd cmld
Rnd_xh14 xhp14 xhn14 20k
Cxh14p xhp14 0 1e-13
Cxh14n xhn14 0 1e-13
Xih_0_14 a_xp0 a_xn0 wih_p_0_14 wih_n_0_14 xhp14 xhn14 vdd vbsyn gsyn
Xih_1_14 a_xp1 a_xn1 wih_p_1_14 wih_n_1_14 xhp14 xhn14 vdd vbsyn gsyn
Xih_2_14 a_xp2 a_xn2 wih_p_2_14 wih_n_2_14 xhp14 xhn14 vdd vbsyn gsyn
Xn14 xhp14 xhn14 ahp14 ahn14 vdd vbneu dneuron
Vwih_p_0_15 wih_p_0_15 0 0.3
Vwih_n_0_15 wih_n_0_15 0 0.8946964794631206
Vwih_p_1_15 wih_p_1_15 0 0.9
Vwih_n_1_15 wih_n_1_15 0 0.3
Vwih_p_2_15 wih_p_2_15 0 0.5958540050197993
Vwih_n_2_15 wih_n_2_15 0 0.4041459949802006
Xcm_xh15 xhp15 xhn15 vdd cmld
Rnd_xh15 xhp15 xhn15 20k
Cxh15p xhp15 0 1e-13
Cxh15n xhn15 0 1e-13
Xih_0_15 a_xp0 a_xn0 wih_p_0_15 wih_n_0_15 xhp15 xhn15 vdd vbsyn gsyn
Xih_1_15 a_xp1 a_xn1 wih_p_1_15 wih_n_1_15 xhp15 xhn15 vdd vbsyn gsyn
Xih_2_15 a_xp2 a_xn2 wih_p_2_15 wih_n_2_15 xhp15 xhn15 vdd vbsyn gsyn
Xn15 xhp15 xhn15 ahp15 ahn15 vdd vbneu dneuron
Vwih_p_0_16 wih_p_0_16 0 0.9
Vwih_n_0_16 wih_n_0_16 0 0.3
Vwih_p_1_16 wih_p_1_16 0 0.8264016782997259
Vwih_n_1_16 wih_n_1_16 0 0.3
Vwih_p_2_16 wih_p_2_16 0 0.3
Vwih_n_2_16 wih_n_2_16 0 0.8009587065328215
Xcm_xh16 xhp16 xhn16 vdd cmld
Rnd_xh16 xhp16 xhn16 20k
Cxh16p xhp16 0 1e-13
Cxh16n xhn16 0 1e-13
Xih_0_16 a_xp0 a_xn0 wih_p_0_16 wih_n_0_16 xhp16 xhn16 vdd vbsyn gsyn
Xih_1_16 a_xp1 a_xn1 wih_p_1_16 wih_n_1_16 xhp16 xhn16 vdd vbsyn gsyn
Xih_2_16 a_xp2 a_xn2 wih_p_2_16 wih_n_2_16 xhp16 xhn16 vdd vbsyn gsyn
Xn16 xhp16 xhn16 ahp16 ahn16 vdd vbneu dneuron
Vwih_p_0_17 wih_p_0_17 0 0.4115141976338063
Vwih_n_0_17 wih_n_0_17 0 0.5884858023661936
Vwih_p_1_17 wih_p_1_17 0 0.6903674851964131
Vwih_n_1_17 wih_n_1_17 0 0.3096325148035869
Vwih_p_2_17 wih_p_2_17 0 0.7253099866650734
Vwih_n_2_17 wih_n_2_17 0 0.3
Xcm_xh17 xhp17 xhn17 vdd cmld
Rnd_xh17 xhp17 xhn17 20k
Cxh17p xhp17 0 1e-13
Cxh17n xhn17 0 1e-13
Xih_0_17 a_xp0 a_xn0 wih_p_0_17 wih_n_0_17 xhp17 xhn17 vdd vbsyn gsyn
Xih_1_17 a_xp1 a_xn1 wih_p_1_17 wih_n_1_17 xhp17 xhn17 vdd vbsyn gsyn
Xih_2_17 a_xp2 a_xn2 wih_p_2_17 wih_n_2_17 xhp17 xhn17 vdd vbsyn gsyn
Xn17 xhp17 xhn17 ahp17 ahn17 vdd vbneu dneuron
Vwih_p_0_18 wih_p_0_18 0 0.3
Vwih_n_0_18 wih_n_0_18 0 0.9
Vwih_p_1_18 wih_p_1_18 0 0.3
Vwih_n_1_18 wih_n_1_18 0 0.9
Vwih_p_2_18 wih_p_2_18 0 0.3
Vwih_n_2_18 wih_n_2_18 0 0.9
Xcm_xh18 xhp18 xhn18 vdd cmld
Rnd_xh18 xhp18 xhn18 20k
Cxh18p xhp18 0 1e-13
Cxh18n xhn18 0 1e-13
Xih_0_18 a_xp0 a_xn0 wih_p_0_18 wih_n_0_18 xhp18 xhn18 vdd vbsyn gsyn
Xih_1_18 a_xp1 a_xn1 wih_p_1_18 wih_n_1_18 xhp18 xhn18 vdd vbsyn gsyn
Xih_2_18 a_xp2 a_xn2 wih_p_2_18 wih_n_2_18 xhp18 xhn18 vdd vbsyn gsyn
Xn18 xhp18 xhn18 ahp18 ahn18 vdd vbneu dneuron
Vwih_p_0_19 wih_p_0_19 0 0.7777220499589362
Vwih_n_0_19 wih_n_0_19 0 0.3
Vwih_p_1_19 wih_p_1_19 0 0.4310427827422266
Vwih_n_1_19 wih_n_1_19 0 0.5689572172577734
Vwih_p_2_19 wih_p_2_19 0 0.3
Vwih_n_2_19 wih_n_2_19 0 0.9
Xcm_xh19 xhp19 xhn19 vdd cmld
Rnd_xh19 xhp19 xhn19 20k
Cxh19p xhp19 0 1e-13
Cxh19n xhn19 0 1e-13
Xih_0_19 a_xp0 a_xn0 wih_p_0_19 wih_n_0_19 xhp19 xhn19 vdd vbsyn gsyn
Xih_1_19 a_xp1 a_xn1 wih_p_1_19 wih_n_1_19 xhp19 xhn19 vdd vbsyn gsyn
Xih_2_19 a_xp2 a_xn2 wih_p_2_19 wih_n_2_19 xhp19 xhn19 vdd vbsyn gsyn
Xn19 xhp19 xhn19 ahp19 ahn19 vdd vbneu dneuron
Vwih_p_0_20 wih_p_0_20 0 0.3
Vwih_n_0_20 wih_n_0_20 0 0.7478781116735951
Vwih_p_1_20 wih_p_1_20 0 0.3
Vwih_n_1_20 wih_n_1_20 0 0.9
Vwih_p_2_20 wih_p_2_20 0 0.3815696565850669
Vwih_n_2_20 wih_n_2_20 0 0.6184303434149331
Xcm_xh20 xhp20 xhn20 vdd cmld
Rnd_xh20 xhp20 xhn20 20k
Cxh20p xhp20 0 1e-13
Cxh20n xhn20 0 1e-13
Xih_0_20 a_xp0 a_xn0 wih_p_0_20 wih_n_0_20 xhp20 xhn20 vdd vbsyn gsyn
Xih_1_20 a_xp1 a_xn1 wih_p_1_20 wih_n_1_20 xhp20 xhn20 vdd vbsyn gsyn
Xih_2_20 a_xp2 a_xn2 wih_p_2_20 wih_n_2_20 xhp20 xhn20 vdd vbsyn gsyn
Xn20 xhp20 xhn20 ahp20 ahn20 vdd vbneu dneuron
Vwih_p_0_21 wih_p_0_21 0 0.3
Vwih_n_0_21 wih_n_0_21 0 0.8894118236059116
Vwih_p_1_21 wih_p_1_21 0 0.3
Vwih_n_1_21 wih_n_1_21 0 0.7510846099149556
Vwih_p_2_21 wih_p_2_21 0 0.46204030518827083
Vwih_n_2_21 wih_n_2_21 0 0.5379596948117292
Xcm_xh21 xhp21 xhn21 vdd cmld
Rnd_xh21 xhp21 xhn21 20k
Cxh21p xhp21 0 1e-13
Cxh21n xhn21 0 1e-13
Xih_0_21 a_xp0 a_xn0 wih_p_0_21 wih_n_0_21 xhp21 xhn21 vdd vbsyn gsyn
Xih_1_21 a_xp1 a_xn1 wih_p_1_21 wih_n_1_21 xhp21 xhn21 vdd vbsyn gsyn
Xih_2_21 a_xp2 a_xn2 wih_p_2_21 wih_n_2_21 xhp21 xhn21 vdd vbsyn gsyn
Xn21 xhp21 xhn21 ahp21 ahn21 vdd vbneu dneuron
Vwih_p_0_22 wih_p_0_22 0 0.582183485192292
Vwih_n_0_22 wih_n_0_22 0 0.417816514807708
Vwih_p_1_22 wih_p_1_22 0 0.5267999164136071
Vwih_n_1_22 wih_n_1_22 0 0.47320008358639293
Vwih_p_2_22 wih_p_2_22 0 0.9
Vwih_n_2_22 wih_n_2_22 0 0.3
Xcm_xh22 xhp22 xhn22 vdd cmld
Rnd_xh22 xhp22 xhn22 20k
Cxh22p xhp22 0 1e-13
Cxh22n xhn22 0 1e-13
Xih_0_22 a_xp0 a_xn0 wih_p_0_22 wih_n_0_22 xhp22 xhn22 vdd vbsyn gsyn
Xih_1_22 a_xp1 a_xn1 wih_p_1_22 wih_n_1_22 xhp22 xhn22 vdd vbsyn gsyn
Xih_2_22 a_xp2 a_xn2 wih_p_2_22 wih_n_2_22 xhp22 xhn22 vdd vbsyn gsyn
Xn22 xhp22 xhn22 ahp22 ahn22 vdd vbneu dneuron
Vwih_p_0_23 wih_p_0_23 0 0.9
Vwih_n_0_23 wih_n_0_23 0 0.3
Vwih_p_1_23 wih_p_1_23 0 0.8833839713323164
Vwih_n_1_23 wih_n_1_23 0 0.3
Vwih_p_2_23 wih_p_2_23 0 0.41466542792757277
Vwih_n_2_23 wih_n_2_23 0 0.5853345720724272
Xcm_xh23 xhp23 xhn23 vdd cmld
Rnd_xh23 xhp23 xhn23 20k
Cxh23p xhp23 0 1e-13
Cxh23n xhn23 0 1e-13
Xih_0_23 a_xp0 a_xn0 wih_p_0_23 wih_n_0_23 xhp23 xhn23 vdd vbsyn gsyn
Xih_1_23 a_xp1 a_xn1 wih_p_1_23 wih_n_1_23 xhp23 xhn23 vdd vbsyn gsyn
Xih_2_23 a_xp2 a_xn2 wih_p_2_23 wih_n_2_23 xhp23 xhn23 vdd vbsyn gsyn
Xn23 xhp23 xhn23 ahp23 ahn23 vdd vbneu dneuron
Vwih_p_0_24 wih_p_0_24 0 0.8383855046538757
Vwih_n_0_24 wih_n_0_24 0 0.3
Vwih_p_1_24 wih_p_1_24 0 0.3
Vwih_n_1_24 wih_n_1_24 0 0.8272699221557627
Vwih_p_2_24 wih_p_2_24 0 0.3
Vwih_n_2_24 wih_n_2_24 0 0.8716267349962367
Xcm_xh24 xhp24 xhn24 vdd cmld
Rnd_xh24 xhp24 xhn24 20k
Cxh24p xhp24 0 1e-13
Cxh24n xhn24 0 1e-13
Xih_0_24 a_xp0 a_xn0 wih_p_0_24 wih_n_0_24 xhp24 xhn24 vdd vbsyn gsyn
Xih_1_24 a_xp1 a_xn1 wih_p_1_24 wih_n_1_24 xhp24 xhn24 vdd vbsyn gsyn
Xih_2_24 a_xp2 a_xn2 wih_p_2_24 wih_n_2_24 xhp24 xhn24 vdd vbsyn gsyn
Xn24 xhp24 xhn24 ahp24 ahn24 vdd vbneu dneuron
Vwih_p_0_25 wih_p_0_25 0 0.3
Vwih_n_0_25 wih_n_0_25 0 0.8920600682828617
Vwih_p_1_25 wih_p_1_25 0 0.6315617547273517
Vwih_n_1_25 wih_n_1_25 0 0.36843824527264835
Vwih_p_2_25 wih_p_2_25 0 0.9
Vwih_n_2_25 wih_n_2_25 0 0.3
Xcm_xh25 xhp25 xhn25 vdd cmld
Rnd_xh25 xhp25 xhn25 20k
Cxh25p xhp25 0 1e-13
Cxh25n xhn25 0 1e-13
Xih_0_25 a_xp0 a_xn0 wih_p_0_25 wih_n_0_25 xhp25 xhn25 vdd vbsyn gsyn
Xih_1_25 a_xp1 a_xn1 wih_p_1_25 wih_n_1_25 xhp25 xhn25 vdd vbsyn gsyn
Xih_2_25 a_xp2 a_xn2 wih_p_2_25 wih_n_2_25 xhp25 xhn25 vdd vbsyn gsyn
Xn25 xhp25 xhn25 ahp25 ahn25 vdd vbneu dneuron
Vwih_p_0_26 wih_p_0_26 0 0.9
Vwih_n_0_26 wih_n_0_26 0 0.3
Vwih_p_1_26 wih_p_1_26 0 0.9
Vwih_n_1_26 wih_n_1_26 0 0.3
Vwih_p_2_26 wih_p_2_26 0 0.8139593149778681
Vwih_n_2_26 wih_n_2_26 0 0.3
Xcm_xh26 xhp26 xhn26 vdd cmld
Rnd_xh26 xhp26 xhn26 20k
Cxh26p xhp26 0 1e-13
Cxh26n xhn26 0 1e-13
Xih_0_26 a_xp0 a_xn0 wih_p_0_26 wih_n_0_26 xhp26 xhn26 vdd vbsyn gsyn
Xih_1_26 a_xp1 a_xn1 wih_p_1_26 wih_n_1_26 xhp26 xhn26 vdd vbsyn gsyn
Xih_2_26 a_xp2 a_xn2 wih_p_2_26 wih_n_2_26 xhp26 xhn26 vdd vbsyn gsyn
Xn26 xhp26 xhn26 ahp26 ahn26 vdd vbneu dneuron
Vwih_p_0_27 wih_p_0_27 0 0.3
Vwih_n_0_27 wih_n_0_27 0 0.8097470131671487
Vwih_p_1_27 wih_p_1_27 0 0.5344916941866533
Vwih_n_1_27 wih_n_1_27 0 0.4655083058133466
Vwih_p_2_27 wih_p_2_27 0 0.7445566783958016
Vwih_n_2_27 wih_n_2_27 0 0.3
Xcm_xh27 xhp27 xhn27 vdd cmld
Rnd_xh27 xhp27 xhn27 20k
Cxh27p xhp27 0 1e-13
Cxh27n xhn27 0 1e-13
Xih_0_27 a_xp0 a_xn0 wih_p_0_27 wih_n_0_27 xhp27 xhn27 vdd vbsyn gsyn
Xih_1_27 a_xp1 a_xn1 wih_p_1_27 wih_n_1_27 xhp27 xhn27 vdd vbsyn gsyn
Xih_2_27 a_xp2 a_xn2 wih_p_2_27 wih_n_2_27 xhp27 xhn27 vdd vbsyn gsyn
Xn27 xhp27 xhn27 ahp27 ahn27 vdd vbneu dneuron
Vwih_p_0_28 wih_p_0_28 0 0.44498611311859815
Vwih_n_0_28 wih_n_0_28 0 0.5550138868814019
Vwih_p_1_28 wih_p_1_28 0 0.9
Vwih_n_1_28 wih_n_1_28 0 0.3
Vwih_p_2_28 wih_p_2_28 0 0.3
Vwih_n_2_28 wih_n_2_28 0 0.8689778346029556
Xcm_xh28 xhp28 xhn28 vdd cmld
Rnd_xh28 xhp28 xhn28 20k
Cxh28p xhp28 0 1e-13
Cxh28n xhn28 0 1e-13
Xih_0_28 a_xp0 a_xn0 wih_p_0_28 wih_n_0_28 xhp28 xhn28 vdd vbsyn gsyn
Xih_1_28 a_xp1 a_xn1 wih_p_1_28 wih_n_1_28 xhp28 xhn28 vdd vbsyn gsyn
Xih_2_28 a_xp2 a_xn2 wih_p_2_28 wih_n_2_28 xhp28 xhn28 vdd vbsyn gsyn
Xn28 xhp28 xhn28 ahp28 ahn28 vdd vbneu dneuron
Vwih_p_0_29 wih_p_0_29 0 0.3
Vwih_n_0_29 wih_n_0_29 0 0.8213620141203385
Vwih_p_1_29 wih_p_1_29 0 0.6710202455048602
Vwih_n_1_29 wih_n_1_29 0 0.32897975449513983
Vwih_p_2_29 wih_p_2_29 0 0.9
Vwih_n_2_29 wih_n_2_29 0 0.3
Xcm_xh29 xhp29 xhn29 vdd cmld
Rnd_xh29 xhp29 xhn29 20k
Cxh29p xhp29 0 1e-13
Cxh29n xhn29 0 1e-13
Xih_0_29 a_xp0 a_xn0 wih_p_0_29 wih_n_0_29 xhp29 xhn29 vdd vbsyn gsyn
Xih_1_29 a_xp1 a_xn1 wih_p_1_29 wih_n_1_29 xhp29 xhn29 vdd vbsyn gsyn
Xih_2_29 a_xp2 a_xn2 wih_p_2_29 wih_n_2_29 xhp29 xhn29 vdd vbsyn gsyn
Xn29 xhp29 xhn29 ahp29 ahn29 vdd vbneu dneuron
Vwih_p_0_30 wih_p_0_30 0 0.3
Vwih_n_0_30 wih_n_0_30 0 0.9
Vwih_p_1_30 wih_p_1_30 0 0.3
Vwih_n_1_30 wih_n_1_30 0 0.88071809457155
Vwih_p_2_30 wih_p_2_30 0 0.9
Vwih_n_2_30 wih_n_2_30 0 0.3
Xcm_xh30 xhp30 xhn30 vdd cmld
Rnd_xh30 xhp30 xhn30 20k
Cxh30p xhp30 0 1e-13
Cxh30n xhn30 0 1e-13
Xih_0_30 a_xp0 a_xn0 wih_p_0_30 wih_n_0_30 xhp30 xhn30 vdd vbsyn gsyn
Xih_1_30 a_xp1 a_xn1 wih_p_1_30 wih_n_1_30 xhp30 xhn30 vdd vbsyn gsyn
Xih_2_30 a_xp2 a_xn2 wih_p_2_30 wih_n_2_30 xhp30 xhn30 vdd vbsyn gsyn
Xn30 xhp30 xhn30 ahp30 ahn30 vdd vbneu dneuron
Vwih_p_0_31 wih_p_0_31 0 0.3
Vwih_n_0_31 wih_n_0_31 0 0.80552795301878
Vwih_p_1_31 wih_p_1_31 0 0.9
Vwih_n_1_31 wih_n_1_31 0 0.3
Vwih_p_2_31 wih_p_2_31 0 0.3
Vwih_n_2_31 wih_n_2_31 0 0.869683849401294
Xcm_xh31 xhp31 xhn31 vdd cmld
Rnd_xh31 xhp31 xhn31 20k
Cxh31p xhp31 0 1e-13
Cxh31n xhn31 0 1e-13
Xih_0_31 a_xp0 a_xn0 wih_p_0_31 wih_n_0_31 xhp31 xhn31 vdd vbsyn gsyn
Xih_1_31 a_xp1 a_xn1 wih_p_1_31 wih_n_1_31 xhp31 xhn31 vdd vbsyn gsyn
Xih_2_31 a_xp2 a_xn2 wih_p_2_31 wih_n_2_31 xhp31 xhn31 vdd vbsyn gsyn
Xn31 xhp31 xhn31 ahp31 ahn31 vdd vbneu dneuron
Vwih_p_0_32 wih_p_0_32 0 0.9
Vwih_n_0_32 wih_n_0_32 0 0.3
Vwih_p_1_32 wih_p_1_32 0 0.46032013524786275
Vwih_n_1_32 wih_n_1_32 0 0.5396798647521373
Vwih_p_2_32 wih_p_2_32 0 0.7068015234877614
Vwih_n_2_32 wih_n_2_32 0 0.3
Xcm_xh32 xhp32 xhn32 vdd cmld
Rnd_xh32 xhp32 xhn32 20k
Cxh32p xhp32 0 1e-13
Cxh32n xhn32 0 1e-13
Xih_0_32 a_xp0 a_xn0 wih_p_0_32 wih_n_0_32 xhp32 xhn32 vdd vbsyn gsyn
Xih_1_32 a_xp1 a_xn1 wih_p_1_32 wih_n_1_32 xhp32 xhn32 vdd vbsyn gsyn
Xih_2_32 a_xp2 a_xn2 wih_p_2_32 wih_n_2_32 xhp32 xhn32 vdd vbsyn gsyn
Xn32 xhp32 xhn32 ahp32 ahn32 vdd vbneu dneuron
Vwih_p_0_33 wih_p_0_33 0 0.3
Vwih_n_0_33 wih_n_0_33 0 0.9
Vwih_p_1_33 wih_p_1_33 0 0.3
Vwih_n_1_33 wih_n_1_33 0 0.9
Vwih_p_2_33 wih_p_2_33 0 0.8489973052653754
Vwih_n_2_33 wih_n_2_33 0 0.3
Xcm_xh33 xhp33 xhn33 vdd cmld
Rnd_xh33 xhp33 xhn33 20k
Cxh33p xhp33 0 1e-13
Cxh33n xhn33 0 1e-13
Xih_0_33 a_xp0 a_xn0 wih_p_0_33 wih_n_0_33 xhp33 xhn33 vdd vbsyn gsyn
Xih_1_33 a_xp1 a_xn1 wih_p_1_33 wih_n_1_33 xhp33 xhn33 vdd vbsyn gsyn
Xih_2_33 a_xp2 a_xn2 wih_p_2_33 wih_n_2_33 xhp33 xhn33 vdd vbsyn gsyn
Xn33 xhp33 xhn33 ahp33 ahn33 vdd vbneu dneuron
Vwih_p_0_34 wih_p_0_34 0 0.3
Vwih_n_0_34 wih_n_0_34 0 0.7381884171432876
Vwih_p_1_34 wih_p_1_34 0 0.3
Vwih_n_1_34 wih_n_1_34 0 0.9
Vwih_p_2_34 wih_p_2_34 0 0.3
Vwih_n_2_34 wih_n_2_34 0 0.9
Xcm_xh34 xhp34 xhn34 vdd cmld
Rnd_xh34 xhp34 xhn34 20k
Cxh34p xhp34 0 1e-13
Cxh34n xhn34 0 1e-13
Xih_0_34 a_xp0 a_xn0 wih_p_0_34 wih_n_0_34 xhp34 xhn34 vdd vbsyn gsyn
Xih_1_34 a_xp1 a_xn1 wih_p_1_34 wih_n_1_34 xhp34 xhn34 vdd vbsyn gsyn
Xih_2_34 a_xp2 a_xn2 wih_p_2_34 wih_n_2_34 xhp34 xhn34 vdd vbsyn gsyn
Xn34 xhp34 xhn34 ahp34 ahn34 vdd vbneu dneuron
Vwih_p_0_35 wih_p_0_35 0 0.3
Vwih_n_0_35 wih_n_0_35 0 0.9
Vwih_p_1_35 wih_p_1_35 0 0.9
Vwih_n_1_35 wih_n_1_35 0 0.3
Vwih_p_2_35 wih_p_2_35 0 0.3
Vwih_n_2_35 wih_n_2_35 0 0.9
Xcm_xh35 xhp35 xhn35 vdd cmld
Rnd_xh35 xhp35 xhn35 20k
Cxh35p xhp35 0 1e-13
Cxh35n xhn35 0 1e-13
Xih_0_35 a_xp0 a_xn0 wih_p_0_35 wih_n_0_35 xhp35 xhn35 vdd vbsyn gsyn
Xih_1_35 a_xp1 a_xn1 wih_p_1_35 wih_n_1_35 xhp35 xhn35 vdd vbsyn gsyn
Xih_2_35 a_xp2 a_xn2 wih_p_2_35 wih_n_2_35 xhp35 xhn35 vdd vbsyn gsyn
Xn35 xhp35 xhn35 ahp35 ahn35 vdd vbneu dneuron
Vwih_p_0_36 wih_p_0_36 0 0.3
Vwih_n_0_36 wih_n_0_36 0 0.7441127802641893
Vwih_p_1_36 wih_p_1_36 0 0.9
Vwih_n_1_36 wih_n_1_36 0 0.3
Vwih_p_2_36 wih_p_2_36 0 0.30545784665024955
Vwih_n_2_36 wih_n_2_36 0 0.6945421533497504
Xcm_xh36 xhp36 xhn36 vdd cmld
Rnd_xh36 xhp36 xhn36 20k
Cxh36p xhp36 0 1e-13
Cxh36n xhn36 0 1e-13
Xih_0_36 a_xp0 a_xn0 wih_p_0_36 wih_n_0_36 xhp36 xhn36 vdd vbsyn gsyn
Xih_1_36 a_xp1 a_xn1 wih_p_1_36 wih_n_1_36 xhp36 xhn36 vdd vbsyn gsyn
Xih_2_36 a_xp2 a_xn2 wih_p_2_36 wih_n_2_36 xhp36 xhn36 vdd vbsyn gsyn
Xn36 xhp36 xhn36 ahp36 ahn36 vdd vbneu dneuron
Vwih_p_0_37 wih_p_0_37 0 0.49745463332008677
Vwih_n_0_37 wih_n_0_37 0 0.5025453666799132
Vwih_p_1_37 wih_p_1_37 0 0.6654429058906062
Vwih_n_1_37 wih_n_1_37 0 0.33455709410939377
Vwih_p_2_37 wih_p_2_37 0 0.3668004096194789
Vwih_n_2_37 wih_n_2_37 0 0.6331995903805211
Xcm_xh37 xhp37 xhn37 vdd cmld
Rnd_xh37 xhp37 xhn37 20k
Cxh37p xhp37 0 1e-13
Cxh37n xhn37 0 1e-13
Xih_0_37 a_xp0 a_xn0 wih_p_0_37 wih_n_0_37 xhp37 xhn37 vdd vbsyn gsyn
Xih_1_37 a_xp1 a_xn1 wih_p_1_37 wih_n_1_37 xhp37 xhn37 vdd vbsyn gsyn
Xih_2_37 a_xp2 a_xn2 wih_p_2_37 wih_n_2_37 xhp37 xhn37 vdd vbsyn gsyn
Xn37 xhp37 xhn37 ahp37 ahn37 vdd vbneu dneuron
Vwih_p_0_38 wih_p_0_38 0 0.3
Vwih_n_0_38 wih_n_0_38 0 0.8096569867443947
Vwih_p_1_38 wih_p_1_38 0 0.9
Vwih_n_1_38 wih_n_1_38 0 0.3
Vwih_p_2_38 wih_p_2_38 0 0.6439238158355183
Vwih_n_2_38 wih_n_2_38 0 0.3560761841644817
Xcm_xh38 xhp38 xhn38 vdd cmld
Rnd_xh38 xhp38 xhn38 20k
Cxh38p xhp38 0 1e-13
Cxh38n xhn38 0 1e-13
Xih_0_38 a_xp0 a_xn0 wih_p_0_38 wih_n_0_38 xhp38 xhn38 vdd vbsyn gsyn
Xih_1_38 a_xp1 a_xn1 wih_p_1_38 wih_n_1_38 xhp38 xhn38 vdd vbsyn gsyn
Xih_2_38 a_xp2 a_xn2 wih_p_2_38 wih_n_2_38 xhp38 xhn38 vdd vbsyn gsyn
Xn38 xhp38 xhn38 ahp38 ahn38 vdd vbneu dneuron
Vwih_p_0_39 wih_p_0_39 0 0.3
Vwih_n_0_39 wih_n_0_39 0 0.7832721220996146
Vwih_p_1_39 wih_p_1_39 0 0.3
Vwih_n_1_39 wih_n_1_39 0 0.9
Vwih_p_2_39 wih_p_2_39 0 0.3
Vwih_n_2_39 wih_n_2_39 0 0.9
Xcm_xh39 xhp39 xhn39 vdd cmld
Rnd_xh39 xhp39 xhn39 20k
Cxh39p xhp39 0 1e-13
Cxh39n xhn39 0 1e-13
Xih_0_39 a_xp0 a_xn0 wih_p_0_39 wih_n_0_39 xhp39 xhn39 vdd vbsyn gsyn
Xih_1_39 a_xp1 a_xn1 wih_p_1_39 wih_n_1_39 xhp39 xhn39 vdd vbsyn gsyn
Xih_2_39 a_xp2 a_xn2 wih_p_2_39 wih_n_2_39 xhp39 xhn39 vdd vbsyn gsyn
Xn39 xhp39 xhn39 ahp39 ahn39 vdd vbneu dneuron
Vwih_p_0_40 wih_p_0_40 0 0.3
Vwih_n_0_40 wih_n_0_40 0 0.9
Vwih_p_1_40 wih_p_1_40 0 0.3
Vwih_n_1_40 wih_n_1_40 0 0.9
Vwih_p_2_40 wih_p_2_40 0 0.9
Vwih_n_2_40 wih_n_2_40 0 0.3
Xcm_xh40 xhp40 xhn40 vdd cmld
Rnd_xh40 xhp40 xhn40 20k
Cxh40p xhp40 0 1e-13
Cxh40n xhn40 0 1e-13
Xih_0_40 a_xp0 a_xn0 wih_p_0_40 wih_n_0_40 xhp40 xhn40 vdd vbsyn gsyn
Xih_1_40 a_xp1 a_xn1 wih_p_1_40 wih_n_1_40 xhp40 xhn40 vdd vbsyn gsyn
Xih_2_40 a_xp2 a_xn2 wih_p_2_40 wih_n_2_40 xhp40 xhn40 vdd vbsyn gsyn
Xn40 xhp40 xhn40 ahp40 ahn40 vdd vbneu dneuron
Vwih_p_0_41 wih_p_0_41 0 0.545945311956818
Vwih_n_0_41 wih_n_0_41 0 0.45405468804318205
Vwih_p_1_41 wih_p_1_41 0 0.7414942389409386
Vwih_n_1_41 wih_n_1_41 0 0.3
Vwih_p_2_41 wih_p_2_41 0 0.3
Vwih_n_2_41 wih_n_2_41 0 0.9
Xcm_xh41 xhp41 xhn41 vdd cmld
Rnd_xh41 xhp41 xhn41 20k
Cxh41p xhp41 0 1e-13
Cxh41n xhn41 0 1e-13
Xih_0_41 a_xp0 a_xn0 wih_p_0_41 wih_n_0_41 xhp41 xhn41 vdd vbsyn gsyn
Xih_1_41 a_xp1 a_xn1 wih_p_1_41 wih_n_1_41 xhp41 xhn41 vdd vbsyn gsyn
Xih_2_41 a_xp2 a_xn2 wih_p_2_41 wih_n_2_41 xhp41 xhn41 vdd vbsyn gsyn
Xn41 xhp41 xhn41 ahp41 ahn41 vdd vbneu dneuron
Vwih_p_0_42 wih_p_0_42 0 0.3
Vwih_n_0_42 wih_n_0_42 0 0.7182984640498192
Vwih_p_1_42 wih_p_1_42 0 0.391955216733866
Vwih_n_1_42 wih_n_1_42 0 0.608044783266134
Vwih_p_2_42 wih_p_2_42 0 0.5340154011067261
Vwih_n_2_42 wih_n_2_42 0 0.4659845988932739
Xcm_xh42 xhp42 xhn42 vdd cmld
Rnd_xh42 xhp42 xhn42 20k
Cxh42p xhp42 0 1e-13
Cxh42n xhn42 0 1e-13
Xih_0_42 a_xp0 a_xn0 wih_p_0_42 wih_n_0_42 xhp42 xhn42 vdd vbsyn gsyn
Xih_1_42 a_xp1 a_xn1 wih_p_1_42 wih_n_1_42 xhp42 xhn42 vdd vbsyn gsyn
Xih_2_42 a_xp2 a_xn2 wih_p_2_42 wih_n_2_42 xhp42 xhn42 vdd vbsyn gsyn
Xn42 xhp42 xhn42 ahp42 ahn42 vdd vbneu dneuron
Vwih_p_0_43 wih_p_0_43 0 0.40717131769752773
Vwih_n_0_43 wih_n_0_43 0 0.5928286823024723
Vwih_p_1_43 wih_p_1_43 0 0.3
Vwih_n_1_43 wih_n_1_43 0 0.9
Vwih_p_2_43 wih_p_2_43 0 0.9
Vwih_n_2_43 wih_n_2_43 0 0.3
Xcm_xh43 xhp43 xhn43 vdd cmld
Rnd_xh43 xhp43 xhn43 20k
Cxh43p xhp43 0 1e-13
Cxh43n xhn43 0 1e-13
Xih_0_43 a_xp0 a_xn0 wih_p_0_43 wih_n_0_43 xhp43 xhn43 vdd vbsyn gsyn
Xih_1_43 a_xp1 a_xn1 wih_p_1_43 wih_n_1_43 xhp43 xhn43 vdd vbsyn gsyn
Xih_2_43 a_xp2 a_xn2 wih_p_2_43 wih_n_2_43 xhp43 xhn43 vdd vbsyn gsyn
Xn43 xhp43 xhn43 ahp43 ahn43 vdd vbneu dneuron
Vwih_p_0_44 wih_p_0_44 0 0.819627809974411
Vwih_n_0_44 wih_n_0_44 0 0.3
Vwih_p_1_44 wih_p_1_44 0 0.5336870102570914
Vwih_n_1_44 wih_n_1_44 0 0.4663129897429086
Vwih_p_2_44 wih_p_2_44 0 0.9
Vwih_n_2_44 wih_n_2_44 0 0.3
Xcm_xh44 xhp44 xhn44 vdd cmld
Rnd_xh44 xhp44 xhn44 20k
Cxh44p xhp44 0 1e-13
Cxh44n xhn44 0 1e-13
Xih_0_44 a_xp0 a_xn0 wih_p_0_44 wih_n_0_44 xhp44 xhn44 vdd vbsyn gsyn
Xih_1_44 a_xp1 a_xn1 wih_p_1_44 wih_n_1_44 xhp44 xhn44 vdd vbsyn gsyn
Xih_2_44 a_xp2 a_xn2 wih_p_2_44 wih_n_2_44 xhp44 xhn44 vdd vbsyn gsyn
Xn44 xhp44 xhn44 ahp44 ahn44 vdd vbneu dneuron
Vwih_p_0_45 wih_p_0_45 0 0.9
Vwih_n_0_45 wih_n_0_45 0 0.3
Vwih_p_1_45 wih_p_1_45 0 0.9
Vwih_n_1_45 wih_n_1_45 0 0.3
Vwih_p_2_45 wih_p_2_45 0 0.5733614275646088
Vwih_n_2_45 wih_n_2_45 0 0.42663857243539116
Xcm_xh45 xhp45 xhn45 vdd cmld
Rnd_xh45 xhp45 xhn45 20k
Cxh45p xhp45 0 1e-13
Cxh45n xhn45 0 1e-13
Xih_0_45 a_xp0 a_xn0 wih_p_0_45 wih_n_0_45 xhp45 xhn45 vdd vbsyn gsyn
Xih_1_45 a_xp1 a_xn1 wih_p_1_45 wih_n_1_45 xhp45 xhn45 vdd vbsyn gsyn
Xih_2_45 a_xp2 a_xn2 wih_p_2_45 wih_n_2_45 xhp45 xhn45 vdd vbsyn gsyn
Xn45 xhp45 xhn45 ahp45 ahn45 vdd vbneu dneuron
Vwih_p_0_46 wih_p_0_46 0 0.35834223316014435
Vwih_n_0_46 wih_n_0_46 0 0.6416577668398556
Vwih_p_1_46 wih_p_1_46 0 0.3
Vwih_n_1_46 wih_n_1_46 0 0.7159153700612526
Vwih_p_2_46 wih_p_2_46 0 0.9
Vwih_n_2_46 wih_n_2_46 0 0.3
Xcm_xh46 xhp46 xhn46 vdd cmld
Rnd_xh46 xhp46 xhn46 20k
Cxh46p xhp46 0 1e-13
Cxh46n xhn46 0 1e-13
Xih_0_46 a_xp0 a_xn0 wih_p_0_46 wih_n_0_46 xhp46 xhn46 vdd vbsyn gsyn
Xih_1_46 a_xp1 a_xn1 wih_p_1_46 wih_n_1_46 xhp46 xhn46 vdd vbsyn gsyn
Xih_2_46 a_xp2 a_xn2 wih_p_2_46 wih_n_2_46 xhp46 xhn46 vdd vbsyn gsyn
Xn46 xhp46 xhn46 ahp46 ahn46 vdd vbneu dneuron
Vwih_p_0_47 wih_p_0_47 0 0.3
Vwih_n_0_47 wih_n_0_47 0 0.8156592033861805
Vwih_p_1_47 wih_p_1_47 0 0.3
Vwih_n_1_47 wih_n_1_47 0 0.9
Vwih_p_2_47 wih_p_2_47 0 0.7494786102536782
Vwih_n_2_47 wih_n_2_47 0 0.3
Xcm_xh47 xhp47 xhn47 vdd cmld
Rnd_xh47 xhp47 xhn47 20k
Cxh47p xhp47 0 1e-13
Cxh47n xhn47 0 1e-13
Xih_0_47 a_xp0 a_xn0 wih_p_0_47 wih_n_0_47 xhp47 xhn47 vdd vbsyn gsyn
Xih_1_47 a_xp1 a_xn1 wih_p_1_47 wih_n_1_47 xhp47 xhn47 vdd vbsyn gsyn
Xih_2_47 a_xp2 a_xn2 wih_p_2_47 wih_n_2_47 xhp47 xhn47 vdd vbsyn gsyn
Xn47 xhp47 xhn47 ahp47 ahn47 vdd vbneu dneuron
Vahb_p ahbias_p 0 0.8
Vahb_n ahbias_n 0 0.2
Cmocmp mocmp 0 1e-13
Cmocmn mocmn 0 1e-13
Xcm_mo0 mop0 mon0 vdd cmld
Rmo0 mop0 mon0 20k
Cmo0p mop0 0 1e-13
Cmo0n mon0 0 1e-13
Cwp_0_0 who_p_0_0 0 20p
Cwn_0_0 who_n_0_0 0 20p
Rwp_0_0 who_p_0_0 wcm 2g
Rwn_0_0 who_n_0_0 wcm 2g
Xsyn_0_0 ahp0 ahn0 who_p_0_0 who_n_0_0 mop0 mon0 vdd vbsyn gsyn
Cwp_1_0 who_p_1_0 0 20p
Cwn_1_0 who_n_1_0 0 20p
Rwp_1_0 who_p_1_0 wcm 2g
Rwn_1_0 who_n_1_0 wcm 2g
Xsyn_1_0 ahp1 ahn1 who_p_1_0 who_n_1_0 mop0 mon0 vdd vbsyn gsyn
Cwp_2_0 who_p_2_0 0 20p
Cwn_2_0 who_n_2_0 0 20p
Rwp_2_0 who_p_2_0 wcm 2g
Rwn_2_0 who_n_2_0 wcm 2g
Xsyn_2_0 ahp2 ahn2 who_p_2_0 who_n_2_0 mop0 mon0 vdd vbsyn gsyn
Cwp_3_0 who_p_3_0 0 20p
Cwn_3_0 who_n_3_0 0 20p
Rwp_3_0 who_p_3_0 wcm 2g
Rwn_3_0 who_n_3_0 wcm 2g
Xsyn_3_0 ahp3 ahn3 who_p_3_0 who_n_3_0 mop0 mon0 vdd vbsyn gsyn
Cwp_4_0 who_p_4_0 0 20p
Cwn_4_0 who_n_4_0 0 20p
Rwp_4_0 who_p_4_0 wcm 2g
Rwn_4_0 who_n_4_0 wcm 2g
Xsyn_4_0 ahp4 ahn4 who_p_4_0 who_n_4_0 mop0 mon0 vdd vbsyn gsyn
Cwp_5_0 who_p_5_0 0 20p
Cwn_5_0 who_n_5_0 0 20p
Rwp_5_0 who_p_5_0 wcm 2g
Rwn_5_0 who_n_5_0 wcm 2g
Xsyn_5_0 ahp5 ahn5 who_p_5_0 who_n_5_0 mop0 mon0 vdd vbsyn gsyn
Cwp_6_0 who_p_6_0 0 20p
Cwn_6_0 who_n_6_0 0 20p
Rwp_6_0 who_p_6_0 wcm 2g
Rwn_6_0 who_n_6_0 wcm 2g
Xsyn_6_0 ahp6 ahn6 who_p_6_0 who_n_6_0 mop0 mon0 vdd vbsyn gsyn
Cwp_7_0 who_p_7_0 0 20p
Cwn_7_0 who_n_7_0 0 20p
Rwp_7_0 who_p_7_0 wcm 2g
Rwn_7_0 who_n_7_0 wcm 2g
Xsyn_7_0 ahp7 ahn7 who_p_7_0 who_n_7_0 mop0 mon0 vdd vbsyn gsyn
Cwp_8_0 who_p_8_0 0 20p
Cwn_8_0 who_n_8_0 0 20p
Rwp_8_0 who_p_8_0 wcm 2g
Rwn_8_0 who_n_8_0 wcm 2g
Xsyn_8_0 ahp8 ahn8 who_p_8_0 who_n_8_0 mop0 mon0 vdd vbsyn gsyn
Cwp_9_0 who_p_9_0 0 20p
Cwn_9_0 who_n_9_0 0 20p
Rwp_9_0 who_p_9_0 wcm 2g
Rwn_9_0 who_n_9_0 wcm 2g
Xsyn_9_0 ahp9 ahn9 who_p_9_0 who_n_9_0 mop0 mon0 vdd vbsyn gsyn
Cwp_10_0 who_p_10_0 0 20p
Cwn_10_0 who_n_10_0 0 20p
Rwp_10_0 who_p_10_0 wcm 2g
Rwn_10_0 who_n_10_0 wcm 2g
Xsyn_10_0 ahp10 ahn10 who_p_10_0 who_n_10_0 mop0 mon0 vdd vbsyn gsyn
Cwp_11_0 who_p_11_0 0 20p
Cwn_11_0 who_n_11_0 0 20p
Rwp_11_0 who_p_11_0 wcm 2g
Rwn_11_0 who_n_11_0 wcm 2g
Xsyn_11_0 ahp11 ahn11 who_p_11_0 who_n_11_0 mop0 mon0 vdd vbsyn gsyn
Cwp_12_0 who_p_12_0 0 20p
Cwn_12_0 who_n_12_0 0 20p
Rwp_12_0 who_p_12_0 wcm 2g
Rwn_12_0 who_n_12_0 wcm 2g
Xsyn_12_0 ahp12 ahn12 who_p_12_0 who_n_12_0 mop0 mon0 vdd vbsyn gsyn
Cwp_13_0 who_p_13_0 0 20p
Cwn_13_0 who_n_13_0 0 20p
Rwp_13_0 who_p_13_0 wcm 2g
Rwn_13_0 who_n_13_0 wcm 2g
Xsyn_13_0 ahp13 ahn13 who_p_13_0 who_n_13_0 mop0 mon0 vdd vbsyn gsyn
Cwp_14_0 who_p_14_0 0 20p
Cwn_14_0 who_n_14_0 0 20p
Rwp_14_0 who_p_14_0 wcm 2g
Rwn_14_0 who_n_14_0 wcm 2g
Xsyn_14_0 ahp14 ahn14 who_p_14_0 who_n_14_0 mop0 mon0 vdd vbsyn gsyn
Cwp_15_0 who_p_15_0 0 20p
Cwn_15_0 who_n_15_0 0 20p
Rwp_15_0 who_p_15_0 wcm 2g
Rwn_15_0 who_n_15_0 wcm 2g
Xsyn_15_0 ahp15 ahn15 who_p_15_0 who_n_15_0 mop0 mon0 vdd vbsyn gsyn
Cwp_16_0 who_p_16_0 0 20p
Cwn_16_0 who_n_16_0 0 20p
Rwp_16_0 who_p_16_0 wcm 2g
Rwn_16_0 who_n_16_0 wcm 2g
Xsyn_16_0 ahp16 ahn16 who_p_16_0 who_n_16_0 mop0 mon0 vdd vbsyn gsyn
Cwp_17_0 who_p_17_0 0 20p
Cwn_17_0 who_n_17_0 0 20p
Rwp_17_0 who_p_17_0 wcm 2g
Rwn_17_0 who_n_17_0 wcm 2g
Xsyn_17_0 ahp17 ahn17 who_p_17_0 who_n_17_0 mop0 mon0 vdd vbsyn gsyn
Cwp_18_0 who_p_18_0 0 20p
Cwn_18_0 who_n_18_0 0 20p
Rwp_18_0 who_p_18_0 wcm 2g
Rwn_18_0 who_n_18_0 wcm 2g
Xsyn_18_0 ahp18 ahn18 who_p_18_0 who_n_18_0 mop0 mon0 vdd vbsyn gsyn
Cwp_19_0 who_p_19_0 0 20p
Cwn_19_0 who_n_19_0 0 20p
Rwp_19_0 who_p_19_0 wcm 2g
Rwn_19_0 who_n_19_0 wcm 2g
Xsyn_19_0 ahp19 ahn19 who_p_19_0 who_n_19_0 mop0 mon0 vdd vbsyn gsyn
Cwp_20_0 who_p_20_0 0 20p
Cwn_20_0 who_n_20_0 0 20p
Rwp_20_0 who_p_20_0 wcm 2g
Rwn_20_0 who_n_20_0 wcm 2g
Xsyn_20_0 ahp20 ahn20 who_p_20_0 who_n_20_0 mop0 mon0 vdd vbsyn gsyn
Cwp_21_0 who_p_21_0 0 20p
Cwn_21_0 who_n_21_0 0 20p
Rwp_21_0 who_p_21_0 wcm 2g
Rwn_21_0 who_n_21_0 wcm 2g
Xsyn_21_0 ahp21 ahn21 who_p_21_0 who_n_21_0 mop0 mon0 vdd vbsyn gsyn
Cwp_22_0 who_p_22_0 0 20p
Cwn_22_0 who_n_22_0 0 20p
Rwp_22_0 who_p_22_0 wcm 2g
Rwn_22_0 who_n_22_0 wcm 2g
Xsyn_22_0 ahp22 ahn22 who_p_22_0 who_n_22_0 mop0 mon0 vdd vbsyn gsyn
Cwp_23_0 who_p_23_0 0 20p
Cwn_23_0 who_n_23_0 0 20p
Rwp_23_0 who_p_23_0 wcm 2g
Rwn_23_0 who_n_23_0 wcm 2g
Xsyn_23_0 ahp23 ahn23 who_p_23_0 who_n_23_0 mop0 mon0 vdd vbsyn gsyn
Cwp_24_0 who_p_24_0 0 20p
Cwn_24_0 who_n_24_0 0 20p
Rwp_24_0 who_p_24_0 wcm 2g
Rwn_24_0 who_n_24_0 wcm 2g
Xsyn_24_0 ahp24 ahn24 who_p_24_0 who_n_24_0 mop0 mon0 vdd vbsyn gsyn
Cwp_25_0 who_p_25_0 0 20p
Cwn_25_0 who_n_25_0 0 20p
Rwp_25_0 who_p_25_0 wcm 2g
Rwn_25_0 who_n_25_0 wcm 2g
Xsyn_25_0 ahp25 ahn25 who_p_25_0 who_n_25_0 mop0 mon0 vdd vbsyn gsyn
Cwp_26_0 who_p_26_0 0 20p
Cwn_26_0 who_n_26_0 0 20p
Rwp_26_0 who_p_26_0 wcm 2g
Rwn_26_0 who_n_26_0 wcm 2g
Xsyn_26_0 ahp26 ahn26 who_p_26_0 who_n_26_0 mop0 mon0 vdd vbsyn gsyn
Cwp_27_0 who_p_27_0 0 20p
Cwn_27_0 who_n_27_0 0 20p
Rwp_27_0 who_p_27_0 wcm 2g
Rwn_27_0 who_n_27_0 wcm 2g
Xsyn_27_0 ahp27 ahn27 who_p_27_0 who_n_27_0 mop0 mon0 vdd vbsyn gsyn
Cwp_28_0 who_p_28_0 0 20p
Cwn_28_0 who_n_28_0 0 20p
Rwp_28_0 who_p_28_0 wcm 2g
Rwn_28_0 who_n_28_0 wcm 2g
Xsyn_28_0 ahp28 ahn28 who_p_28_0 who_n_28_0 mop0 mon0 vdd vbsyn gsyn
Cwp_29_0 who_p_29_0 0 20p
Cwn_29_0 who_n_29_0 0 20p
Rwp_29_0 who_p_29_0 wcm 2g
Rwn_29_0 who_n_29_0 wcm 2g
Xsyn_29_0 ahp29 ahn29 who_p_29_0 who_n_29_0 mop0 mon0 vdd vbsyn gsyn
Cwp_30_0 who_p_30_0 0 20p
Cwn_30_0 who_n_30_0 0 20p
Rwp_30_0 who_p_30_0 wcm 2g
Rwn_30_0 who_n_30_0 wcm 2g
Xsyn_30_0 ahp30 ahn30 who_p_30_0 who_n_30_0 mop0 mon0 vdd vbsyn gsyn
Cwp_31_0 who_p_31_0 0 20p
Cwn_31_0 who_n_31_0 0 20p
Rwp_31_0 who_p_31_0 wcm 2g
Rwn_31_0 who_n_31_0 wcm 2g
Xsyn_31_0 ahp31 ahn31 who_p_31_0 who_n_31_0 mop0 mon0 vdd vbsyn gsyn
Cwp_32_0 who_p_32_0 0 20p
Cwn_32_0 who_n_32_0 0 20p
Rwp_32_0 who_p_32_0 wcm 2g
Rwn_32_0 who_n_32_0 wcm 2g
Xsyn_32_0 ahp32 ahn32 who_p_32_0 who_n_32_0 mop0 mon0 vdd vbsyn gsyn
Cwp_33_0 who_p_33_0 0 20p
Cwn_33_0 who_n_33_0 0 20p
Rwp_33_0 who_p_33_0 wcm 2g
Rwn_33_0 who_n_33_0 wcm 2g
Xsyn_33_0 ahp33 ahn33 who_p_33_0 who_n_33_0 mop0 mon0 vdd vbsyn gsyn
Cwp_34_0 who_p_34_0 0 20p
Cwn_34_0 who_n_34_0 0 20p
Rwp_34_0 who_p_34_0 wcm 2g
Rwn_34_0 who_n_34_0 wcm 2g
Xsyn_34_0 ahp34 ahn34 who_p_34_0 who_n_34_0 mop0 mon0 vdd vbsyn gsyn
Cwp_35_0 who_p_35_0 0 20p
Cwn_35_0 who_n_35_0 0 20p
Rwp_35_0 who_p_35_0 wcm 2g
Rwn_35_0 who_n_35_0 wcm 2g
Xsyn_35_0 ahp35 ahn35 who_p_35_0 who_n_35_0 mop0 mon0 vdd vbsyn gsyn
Cwp_36_0 who_p_36_0 0 20p
Cwn_36_0 who_n_36_0 0 20p
Rwp_36_0 who_p_36_0 wcm 2g
Rwn_36_0 who_n_36_0 wcm 2g
Xsyn_36_0 ahp36 ahn36 who_p_36_0 who_n_36_0 mop0 mon0 vdd vbsyn gsyn
Cwp_37_0 who_p_37_0 0 20p
Cwn_37_0 who_n_37_0 0 20p
Rwp_37_0 who_p_37_0 wcm 2g
Rwn_37_0 who_n_37_0 wcm 2g
Xsyn_37_0 ahp37 ahn37 who_p_37_0 who_n_37_0 mop0 mon0 vdd vbsyn gsyn
Cwp_38_0 who_p_38_0 0 20p
Cwn_38_0 who_n_38_0 0 20p
Rwp_38_0 who_p_38_0 wcm 2g
Rwn_38_0 who_n_38_0 wcm 2g
Xsyn_38_0 ahp38 ahn38 who_p_38_0 who_n_38_0 mop0 mon0 vdd vbsyn gsyn
Cwp_39_0 who_p_39_0 0 20p
Cwn_39_0 who_n_39_0 0 20p
Rwp_39_0 who_p_39_0 wcm 2g
Rwn_39_0 who_n_39_0 wcm 2g
Xsyn_39_0 ahp39 ahn39 who_p_39_0 who_n_39_0 mop0 mon0 vdd vbsyn gsyn
Cwp_40_0 who_p_40_0 0 20p
Cwn_40_0 who_n_40_0 0 20p
Rwp_40_0 who_p_40_0 wcm 2g
Rwn_40_0 who_n_40_0 wcm 2g
Xsyn_40_0 ahp40 ahn40 who_p_40_0 who_n_40_0 mop0 mon0 vdd vbsyn gsyn
Cwp_41_0 who_p_41_0 0 20p
Cwn_41_0 who_n_41_0 0 20p
Rwp_41_0 who_p_41_0 wcm 2g
Rwn_41_0 who_n_41_0 wcm 2g
Xsyn_41_0 ahp41 ahn41 who_p_41_0 who_n_41_0 mop0 mon0 vdd vbsyn gsyn
Cwp_42_0 who_p_42_0 0 20p
Cwn_42_0 who_n_42_0 0 20p
Rwp_42_0 who_p_42_0 wcm 2g
Rwn_42_0 who_n_42_0 wcm 2g
Xsyn_42_0 ahp42 ahn42 who_p_42_0 who_n_42_0 mop0 mon0 vdd vbsyn gsyn
Cwp_43_0 who_p_43_0 0 20p
Cwn_43_0 who_n_43_0 0 20p
Rwp_43_0 who_p_43_0 wcm 2g
Rwn_43_0 who_n_43_0 wcm 2g
Xsyn_43_0 ahp43 ahn43 who_p_43_0 who_n_43_0 mop0 mon0 vdd vbsyn gsyn
Cwp_44_0 who_p_44_0 0 20p
Cwn_44_0 who_n_44_0 0 20p
Rwp_44_0 who_p_44_0 wcm 2g
Rwn_44_0 who_n_44_0 wcm 2g
Xsyn_44_0 ahp44 ahn44 who_p_44_0 who_n_44_0 mop0 mon0 vdd vbsyn gsyn
Cwp_45_0 who_p_45_0 0 20p
Cwn_45_0 who_n_45_0 0 20p
Rwp_45_0 who_p_45_0 wcm 2g
Rwn_45_0 who_n_45_0 wcm 2g
Xsyn_45_0 ahp45 ahn45 who_p_45_0 who_n_45_0 mop0 mon0 vdd vbsyn gsyn
Cwp_46_0 who_p_46_0 0 20p
Cwn_46_0 who_n_46_0 0 20p
Rwp_46_0 who_p_46_0 wcm 2g
Rwn_46_0 who_n_46_0 wcm 2g
Xsyn_46_0 ahp46 ahn46 who_p_46_0 who_n_46_0 mop0 mon0 vdd vbsyn gsyn
Cwp_47_0 who_p_47_0 0 20p
Cwn_47_0 who_n_47_0 0 20p
Rwp_47_0 who_p_47_0 wcm 2g
Rwn_47_0 who_n_47_0 wcm 2g
Xsyn_47_0 ahp47 ahn47 who_p_47_0 who_n_47_0 mop0 mon0 vdd vbsyn gsyn
Cwp_48_0 who_p_48_0 0 20p
Cwn_48_0 who_n_48_0 0 20p
Rwp_48_0 who_p_48_0 wcm 2g
Rwn_48_0 who_n_48_0 wcm 2g
Xsyn_48_0 ahbias_p ahbias_n who_p_48_0 who_n_48_0 mop0 mon0 vdd vbsyn gsyn
Rcmp0 mop0 mocmp 40k
Rcmn0 mon0 mocmn 40k
Xcms0 mop0 mon0 mocmp mocmn cmop0 cmon0 vdd gm esub
Xeo0 xop0 xon0 cmop0 cmon0 eop0 eon0 vdd gm esub
Xcm_mo1 mop1 mon1 vdd cmld
Rmo1 mop1 mon1 20k
Cmo1p mop1 0 1e-13
Cmo1n mon1 0 1e-13
Cwp_0_1 who_p_0_1 0 20p
Cwn_0_1 who_n_0_1 0 20p
Rwp_0_1 who_p_0_1 wcm 2g
Rwn_0_1 who_n_0_1 wcm 2g
Xsyn_0_1 ahp0 ahn0 who_p_0_1 who_n_0_1 mop1 mon1 vdd vbsyn gsyn
Cwp_1_1 who_p_1_1 0 20p
Cwn_1_1 who_n_1_1 0 20p
Rwp_1_1 who_p_1_1 wcm 2g
Rwn_1_1 who_n_1_1 wcm 2g
Xsyn_1_1 ahp1 ahn1 who_p_1_1 who_n_1_1 mop1 mon1 vdd vbsyn gsyn
Cwp_2_1 who_p_2_1 0 20p
Cwn_2_1 who_n_2_1 0 20p
Rwp_2_1 who_p_2_1 wcm 2g
Rwn_2_1 who_n_2_1 wcm 2g
Xsyn_2_1 ahp2 ahn2 who_p_2_1 who_n_2_1 mop1 mon1 vdd vbsyn gsyn
Cwp_3_1 who_p_3_1 0 20p
Cwn_3_1 who_n_3_1 0 20p
Rwp_3_1 who_p_3_1 wcm 2g
Rwn_3_1 who_n_3_1 wcm 2g
Xsyn_3_1 ahp3 ahn3 who_p_3_1 who_n_3_1 mop1 mon1 vdd vbsyn gsyn
Cwp_4_1 who_p_4_1 0 20p
Cwn_4_1 who_n_4_1 0 20p
Rwp_4_1 who_p_4_1 wcm 2g
Rwn_4_1 who_n_4_1 wcm 2g
Xsyn_4_1 ahp4 ahn4 who_p_4_1 who_n_4_1 mop1 mon1 vdd vbsyn gsyn
Cwp_5_1 who_p_5_1 0 20p
Cwn_5_1 who_n_5_1 0 20p
Rwp_5_1 who_p_5_1 wcm 2g
Rwn_5_1 who_n_5_1 wcm 2g
Xsyn_5_1 ahp5 ahn5 who_p_5_1 who_n_5_1 mop1 mon1 vdd vbsyn gsyn
Cwp_6_1 who_p_6_1 0 20p
Cwn_6_1 who_n_6_1 0 20p
Rwp_6_1 who_p_6_1 wcm 2g
Rwn_6_1 who_n_6_1 wcm 2g
Xsyn_6_1 ahp6 ahn6 who_p_6_1 who_n_6_1 mop1 mon1 vdd vbsyn gsyn
Cwp_7_1 who_p_7_1 0 20p
Cwn_7_1 who_n_7_1 0 20p
Rwp_7_1 who_p_7_1 wcm 2g
Rwn_7_1 who_n_7_1 wcm 2g
Xsyn_7_1 ahp7 ahn7 who_p_7_1 who_n_7_1 mop1 mon1 vdd vbsyn gsyn
Cwp_8_1 who_p_8_1 0 20p
Cwn_8_1 who_n_8_1 0 20p
Rwp_8_1 who_p_8_1 wcm 2g
Rwn_8_1 who_n_8_1 wcm 2g
Xsyn_8_1 ahp8 ahn8 who_p_8_1 who_n_8_1 mop1 mon1 vdd vbsyn gsyn
Cwp_9_1 who_p_9_1 0 20p
Cwn_9_1 who_n_9_1 0 20p
Rwp_9_1 who_p_9_1 wcm 2g
Rwn_9_1 who_n_9_1 wcm 2g
Xsyn_9_1 ahp9 ahn9 who_p_9_1 who_n_9_1 mop1 mon1 vdd vbsyn gsyn
Cwp_10_1 who_p_10_1 0 20p
Cwn_10_1 who_n_10_1 0 20p
Rwp_10_1 who_p_10_1 wcm 2g
Rwn_10_1 who_n_10_1 wcm 2g
Xsyn_10_1 ahp10 ahn10 who_p_10_1 who_n_10_1 mop1 mon1 vdd vbsyn gsyn
Cwp_11_1 who_p_11_1 0 20p
Cwn_11_1 who_n_11_1 0 20p
Rwp_11_1 who_p_11_1 wcm 2g
Rwn_11_1 who_n_11_1 wcm 2g
Xsyn_11_1 ahp11 ahn11 who_p_11_1 who_n_11_1 mop1 mon1 vdd vbsyn gsyn
Cwp_12_1 who_p_12_1 0 20p
Cwn_12_1 who_n_12_1 0 20p
Rwp_12_1 who_p_12_1 wcm 2g
Rwn_12_1 who_n_12_1 wcm 2g
Xsyn_12_1 ahp12 ahn12 who_p_12_1 who_n_12_1 mop1 mon1 vdd vbsyn gsyn
Cwp_13_1 who_p_13_1 0 20p
Cwn_13_1 who_n_13_1 0 20p
Rwp_13_1 who_p_13_1 wcm 2g
Rwn_13_1 who_n_13_1 wcm 2g
Xsyn_13_1 ahp13 ahn13 who_p_13_1 who_n_13_1 mop1 mon1 vdd vbsyn gsyn
Cwp_14_1 who_p_14_1 0 20p
Cwn_14_1 who_n_14_1 0 20p
Rwp_14_1 who_p_14_1 wcm 2g
Rwn_14_1 who_n_14_1 wcm 2g
Xsyn_14_1 ahp14 ahn14 who_p_14_1 who_n_14_1 mop1 mon1 vdd vbsyn gsyn
Cwp_15_1 who_p_15_1 0 20p
Cwn_15_1 who_n_15_1 0 20p
Rwp_15_1 who_p_15_1 wcm 2g
Rwn_15_1 who_n_15_1 wcm 2g
Xsyn_15_1 ahp15 ahn15 who_p_15_1 who_n_15_1 mop1 mon1 vdd vbsyn gsyn
Cwp_16_1 who_p_16_1 0 20p
Cwn_16_1 who_n_16_1 0 20p
Rwp_16_1 who_p_16_1 wcm 2g
Rwn_16_1 who_n_16_1 wcm 2g
Xsyn_16_1 ahp16 ahn16 who_p_16_1 who_n_16_1 mop1 mon1 vdd vbsyn gsyn
Cwp_17_1 who_p_17_1 0 20p
Cwn_17_1 who_n_17_1 0 20p
Rwp_17_1 who_p_17_1 wcm 2g
Rwn_17_1 who_n_17_1 wcm 2g
Xsyn_17_1 ahp17 ahn17 who_p_17_1 who_n_17_1 mop1 mon1 vdd vbsyn gsyn
Cwp_18_1 who_p_18_1 0 20p
Cwn_18_1 who_n_18_1 0 20p
Rwp_18_1 who_p_18_1 wcm 2g
Rwn_18_1 who_n_18_1 wcm 2g
Xsyn_18_1 ahp18 ahn18 who_p_18_1 who_n_18_1 mop1 mon1 vdd vbsyn gsyn
Cwp_19_1 who_p_19_1 0 20p
Cwn_19_1 who_n_19_1 0 20p
Rwp_19_1 who_p_19_1 wcm 2g
Rwn_19_1 who_n_19_1 wcm 2g
Xsyn_19_1 ahp19 ahn19 who_p_19_1 who_n_19_1 mop1 mon1 vdd vbsyn gsyn
Cwp_20_1 who_p_20_1 0 20p
Cwn_20_1 who_n_20_1 0 20p
Rwp_20_1 who_p_20_1 wcm 2g
Rwn_20_1 who_n_20_1 wcm 2g
Xsyn_20_1 ahp20 ahn20 who_p_20_1 who_n_20_1 mop1 mon1 vdd vbsyn gsyn
Cwp_21_1 who_p_21_1 0 20p
Cwn_21_1 who_n_21_1 0 20p
Rwp_21_1 who_p_21_1 wcm 2g
Rwn_21_1 who_n_21_1 wcm 2g
Xsyn_21_1 ahp21 ahn21 who_p_21_1 who_n_21_1 mop1 mon1 vdd vbsyn gsyn
Cwp_22_1 who_p_22_1 0 20p
Cwn_22_1 who_n_22_1 0 20p
Rwp_22_1 who_p_22_1 wcm 2g
Rwn_22_1 who_n_22_1 wcm 2g
Xsyn_22_1 ahp22 ahn22 who_p_22_1 who_n_22_1 mop1 mon1 vdd vbsyn gsyn
Cwp_23_1 who_p_23_1 0 20p
Cwn_23_1 who_n_23_1 0 20p
Rwp_23_1 who_p_23_1 wcm 2g
Rwn_23_1 who_n_23_1 wcm 2g
Xsyn_23_1 ahp23 ahn23 who_p_23_1 who_n_23_1 mop1 mon1 vdd vbsyn gsyn
Cwp_24_1 who_p_24_1 0 20p
Cwn_24_1 who_n_24_1 0 20p
Rwp_24_1 who_p_24_1 wcm 2g
Rwn_24_1 who_n_24_1 wcm 2g
Xsyn_24_1 ahp24 ahn24 who_p_24_1 who_n_24_1 mop1 mon1 vdd vbsyn gsyn
Cwp_25_1 who_p_25_1 0 20p
Cwn_25_1 who_n_25_1 0 20p
Rwp_25_1 who_p_25_1 wcm 2g
Rwn_25_1 who_n_25_1 wcm 2g
Xsyn_25_1 ahp25 ahn25 who_p_25_1 who_n_25_1 mop1 mon1 vdd vbsyn gsyn
Cwp_26_1 who_p_26_1 0 20p
Cwn_26_1 who_n_26_1 0 20p
Rwp_26_1 who_p_26_1 wcm 2g
Rwn_26_1 who_n_26_1 wcm 2g
Xsyn_26_1 ahp26 ahn26 who_p_26_1 who_n_26_1 mop1 mon1 vdd vbsyn gsyn
Cwp_27_1 who_p_27_1 0 20p
Cwn_27_1 who_n_27_1 0 20p
Rwp_27_1 who_p_27_1 wcm 2g
Rwn_27_1 who_n_27_1 wcm 2g
Xsyn_27_1 ahp27 ahn27 who_p_27_1 who_n_27_1 mop1 mon1 vdd vbsyn gsyn
Cwp_28_1 who_p_28_1 0 20p
Cwn_28_1 who_n_28_1 0 20p
Rwp_28_1 who_p_28_1 wcm 2g
Rwn_28_1 who_n_28_1 wcm 2g
Xsyn_28_1 ahp28 ahn28 who_p_28_1 who_n_28_1 mop1 mon1 vdd vbsyn gsyn
Cwp_29_1 who_p_29_1 0 20p
Cwn_29_1 who_n_29_1 0 20p
Rwp_29_1 who_p_29_1 wcm 2g
Rwn_29_1 who_n_29_1 wcm 2g
Xsyn_29_1 ahp29 ahn29 who_p_29_1 who_n_29_1 mop1 mon1 vdd vbsyn gsyn
Cwp_30_1 who_p_30_1 0 20p
Cwn_30_1 who_n_30_1 0 20p
Rwp_30_1 who_p_30_1 wcm 2g
Rwn_30_1 who_n_30_1 wcm 2g
Xsyn_30_1 ahp30 ahn30 who_p_30_1 who_n_30_1 mop1 mon1 vdd vbsyn gsyn
Cwp_31_1 who_p_31_1 0 20p
Cwn_31_1 who_n_31_1 0 20p
Rwp_31_1 who_p_31_1 wcm 2g
Rwn_31_1 who_n_31_1 wcm 2g
Xsyn_31_1 ahp31 ahn31 who_p_31_1 who_n_31_1 mop1 mon1 vdd vbsyn gsyn
Cwp_32_1 who_p_32_1 0 20p
Cwn_32_1 who_n_32_1 0 20p
Rwp_32_1 who_p_32_1 wcm 2g
Rwn_32_1 who_n_32_1 wcm 2g
Xsyn_32_1 ahp32 ahn32 who_p_32_1 who_n_32_1 mop1 mon1 vdd vbsyn gsyn
Cwp_33_1 who_p_33_1 0 20p
Cwn_33_1 who_n_33_1 0 20p
Rwp_33_1 who_p_33_1 wcm 2g
Rwn_33_1 who_n_33_1 wcm 2g
Xsyn_33_1 ahp33 ahn33 who_p_33_1 who_n_33_1 mop1 mon1 vdd vbsyn gsyn
Cwp_34_1 who_p_34_1 0 20p
Cwn_34_1 who_n_34_1 0 20p
Rwp_34_1 who_p_34_1 wcm 2g
Rwn_34_1 who_n_34_1 wcm 2g
Xsyn_34_1 ahp34 ahn34 who_p_34_1 who_n_34_1 mop1 mon1 vdd vbsyn gsyn
Cwp_35_1 who_p_35_1 0 20p
Cwn_35_1 who_n_35_1 0 20p
Rwp_35_1 who_p_35_1 wcm 2g
Rwn_35_1 who_n_35_1 wcm 2g
Xsyn_35_1 ahp35 ahn35 who_p_35_1 who_n_35_1 mop1 mon1 vdd vbsyn gsyn
Cwp_36_1 who_p_36_1 0 20p
Cwn_36_1 who_n_36_1 0 20p
Rwp_36_1 who_p_36_1 wcm 2g
Rwn_36_1 who_n_36_1 wcm 2g
Xsyn_36_1 ahp36 ahn36 who_p_36_1 who_n_36_1 mop1 mon1 vdd vbsyn gsyn
Cwp_37_1 who_p_37_1 0 20p
Cwn_37_1 who_n_37_1 0 20p
Rwp_37_1 who_p_37_1 wcm 2g
Rwn_37_1 who_n_37_1 wcm 2g
Xsyn_37_1 ahp37 ahn37 who_p_37_1 who_n_37_1 mop1 mon1 vdd vbsyn gsyn
Cwp_38_1 who_p_38_1 0 20p
Cwn_38_1 who_n_38_1 0 20p
Rwp_38_1 who_p_38_1 wcm 2g
Rwn_38_1 who_n_38_1 wcm 2g
Xsyn_38_1 ahp38 ahn38 who_p_38_1 who_n_38_1 mop1 mon1 vdd vbsyn gsyn
Cwp_39_1 who_p_39_1 0 20p
Cwn_39_1 who_n_39_1 0 20p
Rwp_39_1 who_p_39_1 wcm 2g
Rwn_39_1 who_n_39_1 wcm 2g
Xsyn_39_1 ahp39 ahn39 who_p_39_1 who_n_39_1 mop1 mon1 vdd vbsyn gsyn
Cwp_40_1 who_p_40_1 0 20p
Cwn_40_1 who_n_40_1 0 20p
Rwp_40_1 who_p_40_1 wcm 2g
Rwn_40_1 who_n_40_1 wcm 2g
Xsyn_40_1 ahp40 ahn40 who_p_40_1 who_n_40_1 mop1 mon1 vdd vbsyn gsyn
Cwp_41_1 who_p_41_1 0 20p
Cwn_41_1 who_n_41_1 0 20p
Rwp_41_1 who_p_41_1 wcm 2g
Rwn_41_1 who_n_41_1 wcm 2g
Xsyn_41_1 ahp41 ahn41 who_p_41_1 who_n_41_1 mop1 mon1 vdd vbsyn gsyn
Cwp_42_1 who_p_42_1 0 20p
Cwn_42_1 who_n_42_1 0 20p
Rwp_42_1 who_p_42_1 wcm 2g
Rwn_42_1 who_n_42_1 wcm 2g
Xsyn_42_1 ahp42 ahn42 who_p_42_1 who_n_42_1 mop1 mon1 vdd vbsyn gsyn
Cwp_43_1 who_p_43_1 0 20p
Cwn_43_1 who_n_43_1 0 20p
Rwp_43_1 who_p_43_1 wcm 2g
Rwn_43_1 who_n_43_1 wcm 2g
Xsyn_43_1 ahp43 ahn43 who_p_43_1 who_n_43_1 mop1 mon1 vdd vbsyn gsyn
Cwp_44_1 who_p_44_1 0 20p
Cwn_44_1 who_n_44_1 0 20p
Rwp_44_1 who_p_44_1 wcm 2g
Rwn_44_1 who_n_44_1 wcm 2g
Xsyn_44_1 ahp44 ahn44 who_p_44_1 who_n_44_1 mop1 mon1 vdd vbsyn gsyn
Cwp_45_1 who_p_45_1 0 20p
Cwn_45_1 who_n_45_1 0 20p
Rwp_45_1 who_p_45_1 wcm 2g
Rwn_45_1 who_n_45_1 wcm 2g
Xsyn_45_1 ahp45 ahn45 who_p_45_1 who_n_45_1 mop1 mon1 vdd vbsyn gsyn
Cwp_46_1 who_p_46_1 0 20p
Cwn_46_1 who_n_46_1 0 20p
Rwp_46_1 who_p_46_1 wcm 2g
Rwn_46_1 who_n_46_1 wcm 2g
Xsyn_46_1 ahp46 ahn46 who_p_46_1 who_n_46_1 mop1 mon1 vdd vbsyn gsyn
Cwp_47_1 who_p_47_1 0 20p
Cwn_47_1 who_n_47_1 0 20p
Rwp_47_1 who_p_47_1 wcm 2g
Rwn_47_1 who_n_47_1 wcm 2g
Xsyn_47_1 ahp47 ahn47 who_p_47_1 who_n_47_1 mop1 mon1 vdd vbsyn gsyn
Cwp_48_1 who_p_48_1 0 20p
Cwn_48_1 who_n_48_1 0 20p
Rwp_48_1 who_p_48_1 wcm 2g
Rwn_48_1 who_n_48_1 wcm 2g
Xsyn_48_1 ahbias_p ahbias_n who_p_48_1 who_n_48_1 mop1 mon1 vdd vbsyn gsyn
Rcmp1 mop1 mocmp 40k
Rcmn1 mon1 mocmn 40k
Xcms1 mop1 mon1 mocmp mocmn cmop1 cmon1 vdd gm esub
Xeo1 xop1 xon1 cmop1 cmon1 eop1 eon1 vdd gm esub
Xlrn_0_0 eop0 eon0 ahp0 ahn0 who_p_0_0 who_n_0_0 vdd gbl gprod
Xlrn_1_0 eop0 eon0 ahp1 ahn1 who_p_1_0 who_n_1_0 vdd gbl gprod
Xlrn_2_0 eop0 eon0 ahp2 ahn2 who_p_2_0 who_n_2_0 vdd gbl gprod
Xlrn_3_0 eop0 eon0 ahp3 ahn3 who_p_3_0 who_n_3_0 vdd gbl gprod
Xlrn_4_0 eop0 eon0 ahp4 ahn4 who_p_4_0 who_n_4_0 vdd gbl gprod
Xlrn_5_0 eop0 eon0 ahp5 ahn5 who_p_5_0 who_n_5_0 vdd gbl gprod
Xlrn_6_0 eop0 eon0 ahp6 ahn6 who_p_6_0 who_n_6_0 vdd gbl gprod
Xlrn_7_0 eop0 eon0 ahp7 ahn7 who_p_7_0 who_n_7_0 vdd gbl gprod
Xlrn_8_0 eop0 eon0 ahp8 ahn8 who_p_8_0 who_n_8_0 vdd gbl gprod
Xlrn_9_0 eop0 eon0 ahp9 ahn9 who_p_9_0 who_n_9_0 vdd gbl gprod
Xlrn_10_0 eop0 eon0 ahp10 ahn10 who_p_10_0 who_n_10_0 vdd gbl gprod
Xlrn_11_0 eop0 eon0 ahp11 ahn11 who_p_11_0 who_n_11_0 vdd gbl gprod
Xlrn_12_0 eop0 eon0 ahp12 ahn12 who_p_12_0 who_n_12_0 vdd gbl gprod
Xlrn_13_0 eop0 eon0 ahp13 ahn13 who_p_13_0 who_n_13_0 vdd gbl gprod
Xlrn_14_0 eop0 eon0 ahp14 ahn14 who_p_14_0 who_n_14_0 vdd gbl gprod
Xlrn_15_0 eop0 eon0 ahp15 ahn15 who_p_15_0 who_n_15_0 vdd gbl gprod
Xlrn_16_0 eop0 eon0 ahp16 ahn16 who_p_16_0 who_n_16_0 vdd gbl gprod
Xlrn_17_0 eop0 eon0 ahp17 ahn17 who_p_17_0 who_n_17_0 vdd gbl gprod
Xlrn_18_0 eop0 eon0 ahp18 ahn18 who_p_18_0 who_n_18_0 vdd gbl gprod
Xlrn_19_0 eop0 eon0 ahp19 ahn19 who_p_19_0 who_n_19_0 vdd gbl gprod
Xlrn_20_0 eop0 eon0 ahp20 ahn20 who_p_20_0 who_n_20_0 vdd gbl gprod
Xlrn_21_0 eop0 eon0 ahp21 ahn21 who_p_21_0 who_n_21_0 vdd gbl gprod
Xlrn_22_0 eop0 eon0 ahp22 ahn22 who_p_22_0 who_n_22_0 vdd gbl gprod
Xlrn_23_0 eop0 eon0 ahp23 ahn23 who_p_23_0 who_n_23_0 vdd gbl gprod
Xlrn_24_0 eop0 eon0 ahp24 ahn24 who_p_24_0 who_n_24_0 vdd gbl gprod
Xlrn_25_0 eop0 eon0 ahp25 ahn25 who_p_25_0 who_n_25_0 vdd gbl gprod
Xlrn_26_0 eop0 eon0 ahp26 ahn26 who_p_26_0 who_n_26_0 vdd gbl gprod
Xlrn_27_0 eop0 eon0 ahp27 ahn27 who_p_27_0 who_n_27_0 vdd gbl gprod
Xlrn_28_0 eop0 eon0 ahp28 ahn28 who_p_28_0 who_n_28_0 vdd gbl gprod
Xlrn_29_0 eop0 eon0 ahp29 ahn29 who_p_29_0 who_n_29_0 vdd gbl gprod
Xlrn_30_0 eop0 eon0 ahp30 ahn30 who_p_30_0 who_n_30_0 vdd gbl gprod
Xlrn_31_0 eop0 eon0 ahp31 ahn31 who_p_31_0 who_n_31_0 vdd gbl gprod
Xlrn_32_0 eop0 eon0 ahp32 ahn32 who_p_32_0 who_n_32_0 vdd gbl gprod
Xlrn_33_0 eop0 eon0 ahp33 ahn33 who_p_33_0 who_n_33_0 vdd gbl gprod
Xlrn_34_0 eop0 eon0 ahp34 ahn34 who_p_34_0 who_n_34_0 vdd gbl gprod
Xlrn_35_0 eop0 eon0 ahp35 ahn35 who_p_35_0 who_n_35_0 vdd gbl gprod
Xlrn_36_0 eop0 eon0 ahp36 ahn36 who_p_36_0 who_n_36_0 vdd gbl gprod
Xlrn_37_0 eop0 eon0 ahp37 ahn37 who_p_37_0 who_n_37_0 vdd gbl gprod
Xlrn_38_0 eop0 eon0 ahp38 ahn38 who_p_38_0 who_n_38_0 vdd gbl gprod
Xlrn_39_0 eop0 eon0 ahp39 ahn39 who_p_39_0 who_n_39_0 vdd gbl gprod
Xlrn_40_0 eop0 eon0 ahp40 ahn40 who_p_40_0 who_n_40_0 vdd gbl gprod
Xlrn_41_0 eop0 eon0 ahp41 ahn41 who_p_41_0 who_n_41_0 vdd gbl gprod
Xlrn_42_0 eop0 eon0 ahp42 ahn42 who_p_42_0 who_n_42_0 vdd gbl gprod
Xlrn_43_0 eop0 eon0 ahp43 ahn43 who_p_43_0 who_n_43_0 vdd gbl gprod
Xlrn_44_0 eop0 eon0 ahp44 ahn44 who_p_44_0 who_n_44_0 vdd gbl gprod
Xlrn_45_0 eop0 eon0 ahp45 ahn45 who_p_45_0 who_n_45_0 vdd gbl gprod
Xlrn_46_0 eop0 eon0 ahp46 ahn46 who_p_46_0 who_n_46_0 vdd gbl gprod
Xlrn_47_0 eop0 eon0 ahp47 ahn47 who_p_47_0 who_n_47_0 vdd gbl gprod
Xlrn_48_0 eop0 eon0 ahbias_p ahbias_n who_p_48_0 who_n_48_0 vdd gbl gprod
Xlrn_0_1 eop1 eon1 ahp0 ahn0 who_p_0_1 who_n_0_1 vdd gbl gprod
Xlrn_1_1 eop1 eon1 ahp1 ahn1 who_p_1_1 who_n_1_1 vdd gbl gprod
Xlrn_2_1 eop1 eon1 ahp2 ahn2 who_p_2_1 who_n_2_1 vdd gbl gprod
Xlrn_3_1 eop1 eon1 ahp3 ahn3 who_p_3_1 who_n_3_1 vdd gbl gprod
Xlrn_4_1 eop1 eon1 ahp4 ahn4 who_p_4_1 who_n_4_1 vdd gbl gprod
Xlrn_5_1 eop1 eon1 ahp5 ahn5 who_p_5_1 who_n_5_1 vdd gbl gprod
Xlrn_6_1 eop1 eon1 ahp6 ahn6 who_p_6_1 who_n_6_1 vdd gbl gprod
Xlrn_7_1 eop1 eon1 ahp7 ahn7 who_p_7_1 who_n_7_1 vdd gbl gprod
Xlrn_8_1 eop1 eon1 ahp8 ahn8 who_p_8_1 who_n_8_1 vdd gbl gprod
Xlrn_9_1 eop1 eon1 ahp9 ahn9 who_p_9_1 who_n_9_1 vdd gbl gprod
Xlrn_10_1 eop1 eon1 ahp10 ahn10 who_p_10_1 who_n_10_1 vdd gbl gprod
Xlrn_11_1 eop1 eon1 ahp11 ahn11 who_p_11_1 who_n_11_1 vdd gbl gprod
Xlrn_12_1 eop1 eon1 ahp12 ahn12 who_p_12_1 who_n_12_1 vdd gbl gprod
Xlrn_13_1 eop1 eon1 ahp13 ahn13 who_p_13_1 who_n_13_1 vdd gbl gprod
Xlrn_14_1 eop1 eon1 ahp14 ahn14 who_p_14_1 who_n_14_1 vdd gbl gprod
Xlrn_15_1 eop1 eon1 ahp15 ahn15 who_p_15_1 who_n_15_1 vdd gbl gprod
Xlrn_16_1 eop1 eon1 ahp16 ahn16 who_p_16_1 who_n_16_1 vdd gbl gprod
Xlrn_17_1 eop1 eon1 ahp17 ahn17 who_p_17_1 who_n_17_1 vdd gbl gprod
Xlrn_18_1 eop1 eon1 ahp18 ahn18 who_p_18_1 who_n_18_1 vdd gbl gprod
Xlrn_19_1 eop1 eon1 ahp19 ahn19 who_p_19_1 who_n_19_1 vdd gbl gprod
Xlrn_20_1 eop1 eon1 ahp20 ahn20 who_p_20_1 who_n_20_1 vdd gbl gprod
Xlrn_21_1 eop1 eon1 ahp21 ahn21 who_p_21_1 who_n_21_1 vdd gbl gprod
Xlrn_22_1 eop1 eon1 ahp22 ahn22 who_p_22_1 who_n_22_1 vdd gbl gprod
Xlrn_23_1 eop1 eon1 ahp23 ahn23 who_p_23_1 who_n_23_1 vdd gbl gprod
Xlrn_24_1 eop1 eon1 ahp24 ahn24 who_p_24_1 who_n_24_1 vdd gbl gprod
Xlrn_25_1 eop1 eon1 ahp25 ahn25 who_p_25_1 who_n_25_1 vdd gbl gprod
Xlrn_26_1 eop1 eon1 ahp26 ahn26 who_p_26_1 who_n_26_1 vdd gbl gprod
Xlrn_27_1 eop1 eon1 ahp27 ahn27 who_p_27_1 who_n_27_1 vdd gbl gprod
Xlrn_28_1 eop1 eon1 ahp28 ahn28 who_p_28_1 who_n_28_1 vdd gbl gprod
Xlrn_29_1 eop1 eon1 ahp29 ahn29 who_p_29_1 who_n_29_1 vdd gbl gprod
Xlrn_30_1 eop1 eon1 ahp30 ahn30 who_p_30_1 who_n_30_1 vdd gbl gprod
Xlrn_31_1 eop1 eon1 ahp31 ahn31 who_p_31_1 who_n_31_1 vdd gbl gprod
Xlrn_32_1 eop1 eon1 ahp32 ahn32 who_p_32_1 who_n_32_1 vdd gbl gprod
Xlrn_33_1 eop1 eon1 ahp33 ahn33 who_p_33_1 who_n_33_1 vdd gbl gprod
Xlrn_34_1 eop1 eon1 ahp34 ahn34 who_p_34_1 who_n_34_1 vdd gbl gprod
Xlrn_35_1 eop1 eon1 ahp35 ahn35 who_p_35_1 who_n_35_1 vdd gbl gprod
Xlrn_36_1 eop1 eon1 ahp36 ahn36 who_p_36_1 who_n_36_1 vdd gbl gprod
Xlrn_37_1 eop1 eon1 ahp37 ahn37 who_p_37_1 who_n_37_1 vdd gbl gprod
Xlrn_38_1 eop1 eon1 ahp38 ahn38 who_p_38_1 who_n_38_1 vdd gbl gprod
Xlrn_39_1 eop1 eon1 ahp39 ahn39 who_p_39_1 who_n_39_1 vdd gbl gprod
Xlrn_40_1 eop1 eon1 ahp40 ahn40 who_p_40_1 who_n_40_1 vdd gbl gprod
Xlrn_41_1 eop1 eon1 ahp41 ahn41 who_p_41_1 who_n_41_1 vdd gbl gprod
Xlrn_42_1 eop1 eon1 ahp42 ahn42 who_p_42_1 who_n_42_1 vdd gbl gprod
Xlrn_43_1 eop1 eon1 ahp43 ahn43 who_p_43_1 who_n_43_1 vdd gbl gprod
Xlrn_44_1 eop1 eon1 ahp44 ahn44 who_p_44_1 who_n_44_1 vdd gbl gprod
Xlrn_45_1 eop1 eon1 ahp45 ahn45 who_p_45_1 who_n_45_1 vdd gbl gprod
Xlrn_46_1 eop1 eon1 ahp46 ahn46 who_p_46_1 who_n_46_1 vdd gbl gprod
Xlrn_47_1 eop1 eon1 ahp47 ahn47 who_p_47_1 who_n_47_1 vdd gbl gprod
Xlrn_48_1 eop1 eon1 ahbias_p ahbias_n who_p_48_1 who_n_48_1 vdd gbl gprod
.ic v(who_p_0_0)=0.5 v(who_n_0_0)=0.5
.ic v(who_p_1_0)=0.5 v(who_n_1_0)=0.5
.ic v(who_p_2_0)=0.5 v(who_n_2_0)=0.5
.ic v(who_p_3_0)=0.5 v(who_n_3_0)=0.5
.ic v(who_p_4_0)=0.5 v(who_n_4_0)=0.5
.ic v(who_p_5_0)=0.5 v(who_n_5_0)=0.5
.ic v(who_p_6_0)=0.5 v(who_n_6_0)=0.5
.ic v(who_p_7_0)=0.5 v(who_n_7_0)=0.5
.ic v(who_p_8_0)=0.5 v(who_n_8_0)=0.5
.ic v(who_p_9_0)=0.5 v(who_n_9_0)=0.5
.ic v(who_p_10_0)=0.5 v(who_n_10_0)=0.5
.ic v(who_p_11_0)=0.5 v(who_n_11_0)=0.5
.ic v(who_p_12_0)=0.5 v(who_n_12_0)=0.5
.ic v(who_p_13_0)=0.5 v(who_n_13_0)=0.5
.ic v(who_p_14_0)=0.5 v(who_n_14_0)=0.5
.ic v(who_p_15_0)=0.5 v(who_n_15_0)=0.5
.ic v(who_p_16_0)=0.5 v(who_n_16_0)=0.5
.ic v(who_p_17_0)=0.5 v(who_n_17_0)=0.5
.ic v(who_p_18_0)=0.5 v(who_n_18_0)=0.5
.ic v(who_p_19_0)=0.5 v(who_n_19_0)=0.5
.ic v(who_p_20_0)=0.5 v(who_n_20_0)=0.5
.ic v(who_p_21_0)=0.5 v(who_n_21_0)=0.5
.ic v(who_p_22_0)=0.5 v(who_n_22_0)=0.5
.ic v(who_p_23_0)=0.5 v(who_n_23_0)=0.5
.ic v(who_p_24_0)=0.5 v(who_n_24_0)=0.5
.ic v(who_p_25_0)=0.5 v(who_n_25_0)=0.5
.ic v(who_p_26_0)=0.5 v(who_n_26_0)=0.5
.ic v(who_p_27_0)=0.5 v(who_n_27_0)=0.5
.ic v(who_p_28_0)=0.5 v(who_n_28_0)=0.5
.ic v(who_p_29_0)=0.5 v(who_n_29_0)=0.5
.ic v(who_p_30_0)=0.5 v(who_n_30_0)=0.5
.ic v(who_p_31_0)=0.5 v(who_n_31_0)=0.5
.ic v(who_p_32_0)=0.5 v(who_n_32_0)=0.5
.ic v(who_p_33_0)=0.5 v(who_n_33_0)=0.5
.ic v(who_p_34_0)=0.5 v(who_n_34_0)=0.5
.ic v(who_p_35_0)=0.5 v(who_n_35_0)=0.5
.ic v(who_p_36_0)=0.5 v(who_n_36_0)=0.5
.ic v(who_p_37_0)=0.5 v(who_n_37_0)=0.5
.ic v(who_p_38_0)=0.5 v(who_n_38_0)=0.5
.ic v(who_p_39_0)=0.5 v(who_n_39_0)=0.5
.ic v(who_p_40_0)=0.5 v(who_n_40_0)=0.5
.ic v(who_p_41_0)=0.5 v(who_n_41_0)=0.5
.ic v(who_p_42_0)=0.5 v(who_n_42_0)=0.5
.ic v(who_p_43_0)=0.5 v(who_n_43_0)=0.5
.ic v(who_p_44_0)=0.5 v(who_n_44_0)=0.5
.ic v(who_p_45_0)=0.5 v(who_n_45_0)=0.5
.ic v(who_p_46_0)=0.5 v(who_n_46_0)=0.5
.ic v(who_p_47_0)=0.5 v(who_n_47_0)=0.5
.ic v(who_p_48_0)=0.5 v(who_n_48_0)=0.5
.ic v(who_p_0_1)=0.5 v(who_n_0_1)=0.5
.ic v(who_p_1_1)=0.5 v(who_n_1_1)=0.5
.ic v(who_p_2_1)=0.5 v(who_n_2_1)=0.5
.ic v(who_p_3_1)=0.5 v(who_n_3_1)=0.5
.ic v(who_p_4_1)=0.5 v(who_n_4_1)=0.5
.ic v(who_p_5_1)=0.5 v(who_n_5_1)=0.5
.ic v(who_p_6_1)=0.5 v(who_n_6_1)=0.5
.ic v(who_p_7_1)=0.5 v(who_n_7_1)=0.5
.ic v(who_p_8_1)=0.5 v(who_n_8_1)=0.5
.ic v(who_p_9_1)=0.5 v(who_n_9_1)=0.5
.ic v(who_p_10_1)=0.5 v(who_n_10_1)=0.5
.ic v(who_p_11_1)=0.5 v(who_n_11_1)=0.5
.ic v(who_p_12_1)=0.5 v(who_n_12_1)=0.5
.ic v(who_p_13_1)=0.5 v(who_n_13_1)=0.5
.ic v(who_p_14_1)=0.5 v(who_n_14_1)=0.5
.ic v(who_p_15_1)=0.5 v(who_n_15_1)=0.5
.ic v(who_p_16_1)=0.5 v(who_n_16_1)=0.5
.ic v(who_p_17_1)=0.5 v(who_n_17_1)=0.5
.ic v(who_p_18_1)=0.5 v(who_n_18_1)=0.5
.ic v(who_p_19_1)=0.5 v(who_n_19_1)=0.5
.ic v(who_p_20_1)=0.5 v(who_n_20_1)=0.5
.ic v(who_p_21_1)=0.5 v(who_n_21_1)=0.5
.ic v(who_p_22_1)=0.5 v(who_n_22_1)=0.5
.ic v(who_p_23_1)=0.5 v(who_n_23_1)=0.5
.ic v(who_p_24_1)=0.5 v(who_n_24_1)=0.5
.ic v(who_p_25_1)=0.5 v(who_n_25_1)=0.5
.ic v(who_p_26_1)=0.5 v(who_n_26_1)=0.5
.ic v(who_p_27_1)=0.5 v(who_n_27_1)=0.5
.ic v(who_p_28_1)=0.5 v(who_n_28_1)=0.5
.ic v(who_p_29_1)=0.5 v(who_n_29_1)=0.5
.ic v(who_p_30_1)=0.5 v(who_n_30_1)=0.5
.ic v(who_p_31_1)=0.5 v(who_n_31_1)=0.5
.ic v(who_p_32_1)=0.5 v(who_n_32_1)=0.5
.ic v(who_p_33_1)=0.5 v(who_n_33_1)=0.5
.ic v(who_p_34_1)=0.5 v(who_n_34_1)=0.5
.ic v(who_p_35_1)=0.5 v(who_n_35_1)=0.5
.ic v(who_p_36_1)=0.5 v(who_n_36_1)=0.5
.ic v(who_p_37_1)=0.5 v(who_n_37_1)=0.5
.ic v(who_p_38_1)=0.5 v(who_n_38_1)=0.5
.ic v(who_p_39_1)=0.5 v(who_n_39_1)=0.5
.ic v(who_p_40_1)=0.5 v(who_n_40_1)=0.5
.ic v(who_p_41_1)=0.5 v(who_n_41_1)=0.5
.ic v(who_p_42_1)=0.5 v(who_n_42_1)=0.5
.ic v(who_p_43_1)=0.5 v(who_n_43_1)=0.5
.ic v(who_p_44_1)=0.5 v(who_n_44_1)=0.5
.ic v(who_p_45_1)=0.5 v(who_n_45_1)=0.5
.ic v(who_p_46_1)=0.5 v(who_n_46_1)=0.5
.ic v(who_p_47_1)=0.5 v(who_n_47_1)=0.5
.ic v(who_p_48_1)=0.5 v(who_n_48_1)=0.5
.options gmin=1e-10 reltol=2e-3 cshunt=1e-14 method=gear
.control
save mop0 mon0 mop1 mon1 ahp0 ahn0 ahp1 ahn1 ahp2 ahn2 ahp3 ahn3 ahp4 ahn4 ahp5 ahn5 ahp6 ahn6 ahp7 ahn7 ahp8 ahn8 ahp9 ahn9 ahp10 ahn10 ahp11 ahn11 ahp12 ahn12 ahp13 ahn13 ahp14 ahn14 ahp15 ahn15 ahp16 ahn16 ahp17 ahn17 ahp18 ahn18 ahp19 ahn19 ahp20 ahn20 ahp21 ahn21 ahp22 ahn22 ahp23 ahn23 ahp24 ahn24 ahp25 ahn25 ahp26 ahn26 ahp27 ahn27 ahp28 ahn28 ahp29 ahn29 ahp30 ahn30 ahp31 ahn31 ahp32 ahn32 ahp33 ahn33 ahp34 ahn34 ahp35 ahn35 ahp36 ahn36 ahp37 ahn37 ahp38 ahn38 ahp39 ahn39 ahp40 ahn40 ahp41 ahn41 ahp42 ahn42 ahp43 ahn43 ahp44 ahn44 ahp45 ahn45 ahp46 ahn46 ahp47 ahn47
tran 2n 15680n uic
wrdata ps_ext.dat v(mop0) v(mon0) v(mop1) v(mon1) v(ahp0) v(ahn0) v(ahp1) v(ahn1) v(ahp2) v(ahn2) v(ahp3) v(ahn3) v(ahp4) v(ahn4) v(ahp5) v(ahn5) v(ahp6) v(ahn6) v(ahp7) v(ahn7) v(ahp8) v(ahn8) v(ahp9) v(ahn9) v(ahp10) v(ahn10) v(ahp11) v(ahn11) v(ahp12) v(ahn12) v(ahp13) v(ahn13) v(ahp14) v(ahn14) v(ahp15) v(ahn15) v(ahp16) v(ahn16) v(ahp17) v(ahn17) v(ahp18) v(ahn18) v(ahp19) v(ahn19) v(ahp20) v(ahn20) v(ahp21) v(ahn21) v(ahp22) v(ahn22) v(ahp23) v(ahn23) v(ahp24) v(ahn24) v(ahp25) v(ahn25) v(ahp26) v(ahn26) v(ahp27) v(ahn27) v(ahp28) v(ahn28) v(ahp29) v(ahn29) v(ahp30) v(ahn30) v(ahp31) v(ahn31) v(ahp32) v(ahn32) v(ahp33) v(ahn33) v(ahp34) v(ahn34) v(ahp35) v(ahn35) v(ahp36) v(ahn36) v(ahp37) v(ahn37) v(ahp38) v(ahn38) v(ahp39) v(ahn39) v(ahp40) v(ahn40) v(ahp41) v(ahn41) v(ahp42) v(ahn42) v(ahp43) v(ahn43) v(ahp44) v(ahn44) v(ahp45) v(ahn45) v(ahp46) v(ahn46) v(ahp47) v(ahn47)
.endc
.end
