rc test
Vin in 0 0.0
R1 in cap 20k
C1 cap 0 1n
.end
