pc forward eval
.model NNR NMOS (LEVEL=1 VTO=0.2 KP=120u LAMBDA=0.02 GAMMA=0 PHI=0.7)
.model PNR PMOS (LEVEL=1 VTO=-0.2 KP=40u LAMBDA=0.02 GAMMA=0 PHI=0.7)
.subckt gsyn inp inn wp wn outp outn vdd vbn
Mtail nt vbn 0 0 NNR W=400u L=100u
M5 na wp nt 0 NNR W=200u L=100u
M6 nb wn nt 0 NNR W=200u L=100u
M1 outp inp na 0 NNR W=200u L=100u
M2 outn inn na 0 NNR W=200u L=100u
M3 outn inp nb 0 NNR W=200u L=100u
M4 outp inn nb 0 NNR W=200u L=100u
.ends
.subckt cmld p n vdd
Rcs1 p cmx 300k
Rcs2 n cmx 300k
MLp p cmx vdd vdd PNR W=1000u L=100u
MLn n cmx vdd vdd PNR W=1000u L=100u
.ends
.subckt dneuron up un ap an vdd vbn
M1 an up tn 0 NNR W=200u L=100u
M2 ap un tn 0 NNR W=200u L=100u
Mt tn vbn 0 0 NNR W=200u L=100u
Xcm ap an vdd cmld
.ends
.subckt esub xp xn mp mn ep en vdd vbn
Mt nt vbn 0 0 NNR W=400u L=100u
M1x ep xn nt 0 NNR W=200u L=100u
M2x en xp nt 0 NNR W=200u L=100u
M1m ep mp nt 0 NNR W=200u L=100u
M2m en mn nt 0 NNR W=200u L=100u
RLp vdd ep 50k
RLn vdd en 50k
.ends
.subckt gprod xp xn yp yn wp wn vdd vbn
Mtail nt vbn 0 0 NNR W=400u L=100u
Ctail nt 0 15f
M5 na yp nt 0 NNR W=200u L=100u
M6 nb yn nt 0 NNR W=200u L=100u
M1 iop xp na 0 NNR W=200u L=100u
M2 ion xn na 0 NNR W=200u L=100u
M3 ion xp nb 0 NNR W=200u L=100u
M4 iop xn nb 0 NNR W=200u L=100u
Mlp iop iop vdd vdd PNR W=200u L=100u
Mln ion ion vdd vdd PNR W=200u L=100u
Mpu_wp wp iop vdd vdd PNR W=200u L=100u
MpRn nrn ion vdd vdd PNR W=200u L=100u
MnRn nrn nrn 0 0 NNR W=200u L=100u
Mpd_wp wp nrn 0 0 NNR W=200u L=100u
Mpu_wn wn ion vdd vdd PNR W=200u L=100u
MpRp nrp iop vdd vdd PNR W=200u L=100u
MnRp nrp nrp 0 0 NNR W=200u L=100u
Mpd_wn wn nrp 0 0 NNR W=200u L=100u
.ends
Vdd vdd 0 1.0
Vbsyn vbsyn 0 0.45
Vbneu vbneu 0 0.35
Vxp0 a_xp0 0 0.5
Vxn0 a_xn0 0 0.5
Vxp1 a_xp1 0 0.5
Vxn1 a_xn1 0 0.5
Vxp2 a_xp2 0 0.5
Vxn2 a_xn2 0 0.5
Vxp3 a_xp3 0 0.5
Vxn3 a_xn3 0 0.5
Vxp4 a_xp4 0 0.5
Vxn4 a_xn4 0 0.5
Vxp5 a_xp5 0 0.5
Vxn5 a_xn5 0 0.5
Vxp6 a_xp6 0 0.5
Vxn6 a_xn6 0 0.5
Vxp7 a_xp7 0 0.5
Vxn7 a_xn7 0 0.5
Vxp8 a_xp8 0 0.5
Vxn8 a_xn8 0 0.5
Vxp9 a_xp9 0 0.5
Vxn9 a_xn9 0 0.5
Vxp10 a_xp10 0 0.5
Vxn10 a_xn10 0 0.5
Vxp11 a_xp11 0 0.5
Vxn11 a_xn11 0 0.5
Vxp12 a_xp12 0 0.5
Vxn12 a_xn12 0 0.5
Vxp13 a_xp13 0 0.5
Vxn13 a_xn13 0 0.5
Vxp14 a_xp14 0 0.5
Vxn14 a_xn14 0 0.5
Vxp15 a_xp15 0 0.5
Vxn15 a_xn15 0 0.5
Vwp_wih_0_0 wp_wih_0_0 0 0.4156
Vwn_wih_0_0 wn_wih_0_0 0 0.5119
Vwp_wih_1_0 wp_wih_1_0 0 0.4023
Vwn_wih_1_0 wn_wih_1_0 0 0.5177
Vwp_wih_2_0 wp_wih_2_0 0 0.5091
Vwn_wih_2_0 wn_wih_2_0 0 0.4193
Vwp_wih_3_0 wp_wih_3_0 0 0.4971
Vwn_wih_3_0 wn_wih_3_0 0 0.4261
Vwp_wih_4_0 wp_wih_4_0 0 0.4389
Vwn_wih_4_0 wn_wih_4_0 0 0.4888
Vwp_wih_5_0 wp_wih_5_0 0 0.4880
Vwn_wih_5_0 wn_wih_5_0 0 0.4412
Vwp_wih_6_0 wp_wih_6_0 0 0.4663
Vwn_wih_6_0 wn_wih_6_0 0 0.4605
Vwp_wih_7_0 wp_wih_7_0 0 0.4909
Vwn_wih_7_0 wn_wih_7_0 0 0.4369
Vwp_wih_8_0 wp_wih_8_0 0 0.4798
Vwn_wih_8_0 wn_wih_8_0 0 0.4471
Vwp_wih_9_0 wp_wih_9_0 0 0.4923
Vwn_wih_9_0 wn_wih_9_0 0 0.4140
Vwp_wih_10_0 wp_wih_10_0 0 0.4680
Vwn_wih_10_0 wn_wih_10_0 0 0.4572
Vwp_wih_11_0 wp_wih_11_0 0 0.4794
Vwn_wih_11_0 wn_wih_11_0 0 0.4510
Vwp_wih_12_0 wp_wih_12_0 0 0.4653
Vwn_wih_12_0 wn_wih_12_0 0 0.4614
Vwp_wih_13_0 wp_wih_13_0 0 0.4175
Vwn_wih_13_0 wn_wih_13_0 0 0.5169
Vwp_wih_14_0 wp_wih_14_0 0 0.4687
Vwn_wih_14_0 wn_wih_14_0 0 0.4580
Vwp_wih_15_0 wp_wih_15_0 0 0.3949
Vwn_wih_15_0 wn_wih_15_0 0 0.5142
Vwp_who_0_0 wp_who_0_0 0 0.5601
Vwn_who_0_0 wn_who_0_0 0 0.2691
Vwp_who_0_1 wp_who_0_1 0 0.5717
Vwn_who_0_1 wn_who_0_1 0 0.2587
Vwp_who_0_2 wp_who_0_2 0 0.2496
Vwn_who_0_2 wn_who_0_2 0 0.5841
Vwp_wih_0_1 wp_wih_0_1 0 0.4264
Vwn_wih_0_1 wn_wih_0_1 0 0.4952
Vwp_wih_1_1 wp_wih_1_1 0 0.4728
Vwn_wih_1_1 wn_wih_1_1 0 0.4477
Vwp_wih_2_1 wp_wih_2_1 0 0.4496
Vwn_wih_2_1 wn_wih_2_1 0 0.4788
Vwp_wih_3_1 wp_wih_3_1 0 0.4671
Vwn_wih_3_1 wn_wih_3_1 0 0.4579
Vwp_wih_4_1 wp_wih_4_1 0 0.4533
Vwn_wih_4_1 wn_wih_4_1 0 0.4747
Vwp_wih_5_1 wp_wih_5_1 0 0.5031
Vwn_wih_5_1 wn_wih_5_1 0 0.4180
Vwp_wih_6_1 wp_wih_6_1 0 0.4569
Vwn_wih_6_1 wn_wih_6_1 0 0.4701
Vwp_wih_7_1 wp_wih_7_1 0 0.4105
Vwn_wih_7_1 wn_wih_7_1 0 0.4961
Vwp_wih_8_1 wp_wih_8_1 0 0.4336
Vwn_wih_8_1 wn_wih_8_1 0 0.4915
Vwp_wih_9_1 wp_wih_9_1 0 0.4770
Vwn_wih_9_1 wn_wih_9_1 0 0.4490
Vwp_wih_10_1 wp_wih_10_1 0 0.4706
Vwn_wih_10_1 wn_wih_10_1 0 0.4633
Vwp_wih_11_1 wp_wih_11_1 0 0.4766
Vwn_wih_11_1 wn_wih_11_1 0 0.4516
Vwp_wih_12_1 wp_wih_12_1 0 0.4808
Vwn_wih_12_1 wn_wih_12_1 0 0.4395
Vwp_wih_13_1 wp_wih_13_1 0 0.4473
Vwn_wih_13_1 wn_wih_13_1 0 0.4876
Vwp_wih_14_1 wp_wih_14_1 0 0.4128
Vwn_wih_14_1 wn_wih_14_1 0 0.4971
Vwp_wih_15_1 wp_wih_15_1 0 0.4780
Vwn_wih_15_1 wn_wih_15_1 0 0.4357
Vwp_who_1_0 wp_who_1_0 0 0.4961
Vwn_who_1_0 wn_who_1_0 0 0.5128
Vwp_who_1_1 wp_who_1_1 0 0.2880
Vwn_who_1_1 wn_who_1_1 0 0.5418
Vwp_who_1_2 wp_who_1_2 0 0.5475
Vwn_who_1_2 wn_who_1_2 0 0.2808
Vwp_wih_0_2 wp_wih_0_2 0 0.3631
Vwn_wih_0_2 wn_wih_0_2 0 0.5615
Vwp_wih_1_2 wp_wih_1_2 0 0.3007
Vwn_wih_1_2 wn_wih_1_2 0 0.5825
Vwp_wih_2_2 wp_wih_2_2 0 0.5662
Vwn_wih_2_2 wn_wih_2_2 0 0.3614
Vwp_wih_3_2 wp_wih_3_2 0 0.5555
Vwn_wih_3_2 wn_wih_3_2 0 0.3613
Vwp_wih_4_2 wp_wih_4_2 0 0.3906
Vwn_wih_4_2 wn_wih_4_2 0 0.5305
Vwp_wih_5_2 wp_wih_5_2 0 0.5831
Vwn_wih_5_2 wn_wih_5_2 0 0.2995
Vwp_wih_6_2 wp_wih_6_2 0 0.5247
Vwn_wih_6_2 wn_wih_6_2 0 0.3989
Vwp_wih_7_2 wp_wih_7_2 0 0.4997
Vwn_wih_7_2 wn_wih_7_2 0 0.4226
Vwp_wih_8_2 wp_wih_8_2 0 0.4888
Vwn_wih_8_2 wn_wih_8_2 0 0.4378
Vwp_wih_9_2 wp_wih_9_2 0 0.4593
Vwn_wih_9_2 wn_wih_9_2 0 0.4666
Vwp_wih_10_2 wp_wih_10_2 0 0.5901
Vwn_wih_10_2 wn_wih_10_2 0 0.2752
Vwp_wih_11_2 wp_wih_11_2 0 0.4046
Vwn_wih_11_2 wn_wih_11_2 0 0.5074
Vwp_wih_12_2 wp_wih_12_2 0 0.4472
Vwn_wih_12_2 wn_wih_12_2 0 0.4664
Vwp_wih_13_2 wp_wih_13_2 0 0.3070
Vwn_wih_13_2 wn_wih_13_2 0 0.5874
Vwp_wih_14_2 wp_wih_14_2 0 0.4100
Vwn_wih_14_2 wn_wih_14_2 0 0.5165
Vwp_wih_15_2 wp_wih_15_2 0 0.4031
Vwn_wih_15_2 wn_wih_15_2 0 0.5243
Vwp_who_2_0 wp_who_2_0 0 0.6024
Vwn_who_2_0 wn_who_2_0 0 0.2401
Vwp_who_2_1 wp_who_2_1 0 0.6569
Vwn_who_2_1 wn_who_2_1 0 0.2012
Vwp_who_2_2 wp_who_2_2 0 0.2050
Vwn_who_2_2 wn_who_2_2 0 0.6520
Vwp_wih_0_3 wp_wih_0_3 0 0.5121
Vwn_wih_0_3 wn_wih_0_3 0 0.4065
Vwp_wih_1_3 wp_wih_1_3 0 0.5338
Vwn_wih_1_3 wn_wih_1_3 0 0.3770
Vwp_wih_2_3 wp_wih_2_3 0 0.4090
Vwn_wih_2_3 wn_wih_2_3 0 0.5191
Vwp_wih_3_3 wp_wih_3_3 0 0.4409
Vwn_wih_3_3 wn_wih_3_3 0 0.4842
Vwp_wih_4_3 wp_wih_4_3 0 0.4966
Vwn_wih_4_3 wn_wih_4_3 0 0.4307
Vwp_wih_5_3 wp_wih_5_3 0 0.4275
Vwn_wih_5_3 wn_wih_5_3 0 0.5017
Vwp_wih_6_3 wp_wih_6_3 0 0.4267
Vwn_wih_6_3 wn_wih_6_3 0 0.5002
Vwp_wih_7_3 wp_wih_7_3 0 0.4813
Vwn_wih_7_3 wn_wih_7_3 0 0.4466
Vwp_wih_8_3 wp_wih_8_3 0 0.4896
Vwn_wih_8_3 wn_wih_8_3 0 0.4346
Vwp_wih_9_3 wp_wih_9_3 0 0.4611
Vwn_wih_9_3 wn_wih_9_3 0 0.4650
Vwp_wih_10_3 wp_wih_10_3 0 0.3938
Vwn_wih_10_3 wn_wih_10_3 0 0.5399
Vwp_wih_11_3 wp_wih_11_3 0 0.4634
Vwn_wih_11_3 wn_wih_11_3 0 0.4632
Vwp_wih_12_3 wp_wih_12_3 0 0.4543
Vwn_wih_12_3 wn_wih_12_3 0 0.4691
Vwp_wih_13_3 wp_wih_13_3 0 0.5450
Vwn_wih_13_3 wn_wih_13_3 0 0.3688
Vwp_wih_14_3 wp_wih_14_3 0 0.4722
Vwn_wih_14_3 wn_wih_14_3 0 0.4546
Vwp_wih_15_3 wp_wih_15_3 0 0.5089
Vwn_wih_15_3 wn_wih_15_3 0 0.4158
Vwp_who_3_0 wp_who_3_0 0 0.2742
Vwn_who_3_0 wn_who_3_0 0 0.5553
Vwp_who_3_1 wp_who_3_1 0 0.2444
Vwn_who_3_1 wn_who_3_1 0 0.5906
Vwp_who_3_2 wp_who_3_2 0 0.5921
Vwn_who_3_2 wn_who_3_2 0 0.2436
Vwp_wih_0_4 wp_wih_0_4 0 0.4875
Vwn_wih_0_4 wn_wih_0_4 0 0.4316
Vwp_wih_1_4 wp_wih_1_4 0 0.4822
Vwn_wih_1_4 wn_wih_1_4 0 0.4402
Vwp_wih_2_4 wp_wih_2_4 0 0.4706
Vwn_wih_2_4 wn_wih_2_4 0 0.4578
Vwp_wih_3_4 wp_wih_3_4 0 0.4391
Vwn_wih_3_4 wn_wih_3_4 0 0.4841
Vwp_wih_4_4 wp_wih_4_4 0 0.4505
Vwn_wih_4_4 wn_wih_4_4 0 0.4774
Vwp_wih_5_4 wp_wih_5_4 0 0.4586
Vwn_wih_5_4 wn_wih_5_4 0 0.4707
Vwp_wih_6_4 wp_wih_6_4 0 0.4667
Vwn_wih_6_4 wn_wih_6_4 0 0.4603
Vwp_wih_7_4 wp_wih_7_4 0 0.4020
Vwn_wih_7_4 wn_wih_7_4 0 0.5029
Vwp_wih_8_4 wp_wih_8_4 0 0.4305
Vwn_wih_8_4 wn_wih_8_4 0 0.4926
Vwp_wih_9_4 wp_wih_9_4 0 0.4712
Vwn_wih_9_4 wn_wih_9_4 0 0.4548
Vwp_wih_10_4 wp_wih_10_4 0 0.5008
Vwn_wih_10_4 wn_wih_10_4 0 0.4136
Vwp_wih_11_4 wp_wih_11_4 0 0.4504
Vwn_wih_11_4 wn_wih_11_4 0 0.4801
Vwp_wih_12_4 wp_wih_12_4 0 0.4931
Vwn_wih_12_4 wn_wih_12_4 0 0.4180
Vwp_wih_13_4 wp_wih_13_4 0 0.4503
Vwn_wih_13_4 wn_wih_13_4 0 0.4844
Vwp_wih_14_4 wp_wih_14_4 0 0.4420
Vwn_wih_14_4 wn_wih_14_4 0 0.4849
Vwp_wih_15_4 wp_wih_15_4 0 0.4139
Vwn_wih_15_4 wn_wih_15_4 0 0.4945
Vwp_who_4_0 wp_who_4_0 0 0.2716
Vwn_who_4_0 wn_who_4_0 0 0.5570
Vwp_who_4_1 wp_who_4_1 0 0.5171
Vwn_who_4_1 wn_who_4_1 0 0.4812
Vwp_who_4_2 wp_who_4_2 0 0.5538
Vwn_who_4_2 wn_who_4_2 0 0.2744
Vwp_wih_0_5 wp_wih_0_5 0 0.4311
Vwn_wih_0_5 wn_wih_0_5 0 0.4997
Vwp_wih_1_5 wp_wih_1_5 0 0.4479
Vwn_wih_1_5 wn_wih_1_5 0 0.4850
Vwp_wih_2_5 wp_wih_2_5 0 0.4574
Vwn_wih_2_5 wn_wih_2_5 0 0.4698
Vwp_wih_3_5 wp_wih_3_5 0 0.4346
Vwn_wih_3_5 wn_wih_3_5 0 0.4816
Vwp_wih_4_5 wp_wih_4_5 0 0.4333
Vwn_wih_4_5 wn_wih_4_5 0 0.4926
Vwp_wih_5_5 wp_wih_5_5 0 0.4670
Vwn_wih_5_5 wn_wih_5_5 0 0.4624
Vwp_wih_6_5 wp_wih_6_5 0 0.4920
Vwn_wih_6_5 wn_wih_6_5 0 0.4204
Vwp_wih_7_5 wp_wih_7_5 0 0.4692
Vwn_wih_7_5 wn_wih_7_5 0 0.4588
Vwp_wih_8_5 wp_wih_8_5 0 0.4501
Vwn_wih_8_5 wn_wih_8_5 0 0.4745
Vwp_wih_9_5 wp_wih_9_5 0 0.4712
Vwn_wih_9_5 wn_wih_9_5 0 0.4549
Vwp_wih_10_5 wp_wih_10_5 0 0.4884
Vwn_wih_10_5 wn_wih_10_5 0 0.4456
Vwp_wih_11_5 wp_wih_11_5 0 0.4543
Vwn_wih_11_5 wn_wih_11_5 0 0.4743
Vwp_wih_12_5 wp_wih_12_5 0 0.4752
Vwn_wih_12_5 wn_wih_12_5 0 0.4428
Vwp_wih_13_5 wp_wih_13_5 0 0.4048
Vwn_wih_13_5 wn_wih_13_5 0 0.5057
Vwp_wih_14_5 wp_wih_14_5 0 0.4528
Vwn_wih_14_5 wn_wih_14_5 0 0.4741
Vwp_wih_15_5 wp_wih_15_5 0 0.4656
Vwn_wih_15_5 wn_wih_15_5 0 0.4626
Vwp_who_5_0 wp_who_5_0 0 0.2694
Vwn_who_5_0 wn_who_5_0 0 0.5598
Vwp_who_5_1 wp_who_5_1 0 0.5526
Vwn_who_5_1 wn_who_5_1 0 0.2759
Vwp_who_5_2 wp_who_5_2 0 0.5326
Vwn_who_5_2 wn_who_5_2 0 0.3051
Vwp_wih_0_6 wp_wih_0_6 0 0.4731
Vwn_wih_0_6 wn_wih_0_6 0 0.4577
Vwp_wih_1_6 wp_wih_1_6 0 0.3965
Vwn_wih_1_6 wn_wih_1_6 0 0.5130
Vwp_wih_2_6 wp_wih_2_6 0 0.4544
Vwn_wih_2_6 wn_wih_2_6 0 0.4725
Vwp_wih_3_6 wp_wih_3_6 0 0.4975
Vwn_wih_3_6 wn_wih_3_6 0 0.4173
Vwp_wih_4_6 wp_wih_4_6 0 0.4631
Vwn_wih_4_6 wn_wih_4_6 0 0.4648
Vwp_wih_5_6 wp_wih_5_6 0 0.4825
Vwn_wih_5_6 wn_wih_5_6 0 0.4468
Vwp_wih_6_6 wp_wih_6_6 0 0.5045
Vwn_wih_6_6 wn_wih_6_6 0 0.4224
Vwp_wih_7_6 wp_wih_7_6 0 0.4619
Vwn_wih_7_6 wn_wih_7_6 0 0.4650
Vwp_wih_8_6 wp_wih_8_6 0 0.4212
Vwn_wih_8_6 wn_wih_8_6 0 0.5044
Vwp_wih_9_6 wp_wih_9_6 0 0.4490
Vwn_wih_9_6 wn_wih_9_6 0 0.4771
Vwp_wih_10_6 wp_wih_10_6 0 0.5164
Vwn_wih_10_6 wn_wih_10_6 0 0.4177
Vwp_wih_11_6 wp_wih_11_6 0 0.4222
Vwn_wih_11_6 wn_wih_11_6 0 0.5075
Vwp_wih_12_6 wp_wih_12_6 0 0.4502
Vwn_wih_12_6 wn_wih_12_6 0 0.4766
Vwp_wih_13_6 wp_wih_13_6 0 0.4470
Vwn_wih_13_6 wn_wih_13_6 0 0.4739
Vwp_wih_14_6 wp_wih_14_6 0 0.4421
Vwn_wih_14_6 wn_wih_14_6 0 0.4800
Vwp_wih_15_6 wp_wih_15_6 0 0.4886
Vwn_wih_15_6 wn_wih_15_6 0 0.4175
Vwp_who_6_0 wp_who_6_0 0 0.4358
Vwn_who_6_0 wn_who_6_0 0 0.5355
Vwp_who_6_1 wp_who_6_1 0 0.3215
Vwn_who_6_1 wn_who_6_1 0 0.5281
Vwp_who_6_2 wp_who_6_2 0 0.5483
Vwn_who_6_2 wn_who_6_2 0 0.2800
Vwp_wih_0_7 wp_wih_0_7 0 0.4855
Vwn_wih_0_7 wn_wih_0_7 0 0.4458
Vwp_wih_1_7 wp_wih_1_7 0 0.4690
Vwn_wih_1_7 wn_wih_1_7 0 0.4607
Vwp_wih_2_7 wp_wih_2_7 0 0.4311
Vwn_wih_2_7 wn_wih_2_7 0 0.4955
Vwp_wih_3_7 wp_wih_3_7 0 0.4439
Vwn_wih_3_7 wn_wih_3_7 0 0.4812
Vwp_wih_4_7 wp_wih_4_7 0 0.4875
Vwn_wih_4_7 wn_wih_4_7 0 0.4385
Vwp_wih_5_7 wp_wih_5_7 0 0.4328
Vwn_wih_5_7 wn_wih_5_7 0 0.4965
Vwp_wih_6_7 wp_wih_6_7 0 0.4722
Vwn_wih_6_7 wn_wih_6_7 0 0.4342
Vwp_wih_7_7 wp_wih_7_7 0 0.4735
Vwn_wih_7_7 wn_wih_7_7 0 0.4545
Vwp_wih_8_7 wp_wih_8_7 0 0.4661
Vwn_wih_8_7 wn_wih_8_7 0 0.4609
Vwp_wih_9_7 wp_wih_9_7 0 0.4918
Vwn_wih_9_7 wn_wih_9_7 0 0.4185
Vwp_wih_10_7 wp_wih_10_7 0 0.4586
Vwn_wih_10_7 wn_wih_10_7 0 0.4744
Vwp_wih_11_7 wp_wih_11_7 0 0.4802
Vwn_wih_11_7 wn_wih_11_7 0 0.4504
Vwp_wih_12_7 wp_wih_12_7 0 0.4603
Vwn_wih_12_7 wn_wih_12_7 0 0.4665
Vwp_wih_13_7 wp_wih_13_7 0 0.5107
Vwn_wih_13_7 wn_wih_13_7 0 0.3995
Vwp_wih_14_7 wp_wih_14_7 0 0.4924
Vwn_wih_14_7 wn_wih_14_7 0 0.4320
Vwp_wih_15_7 wp_wih_15_7 0 0.4704
Vwn_wih_15_7 wn_wih_15_7 0 0.4597
Vwp_who_7_0 wp_who_7_0 0 0.2799
Vwn_who_7_0 wn_who_7_0 0 0.5489
Vwp_who_7_1 wp_who_7_1 0 0.3396
Vwn_who_7_1 wn_who_7_1 0 0.5537
Vwp_who_7_2 wp_who_7_2 0 0.5661
Vwn_who_7_2 wn_who_7_2 0 0.2634
Vwp_wih_0_8 wp_wih_0_8 0 0.3866
Vwn_wih_0_8 wn_wih_0_8 0 0.5167
Vwp_wih_1_8 wp_wih_1_8 0 0.4274
Vwn_wih_1_8 wn_wih_1_8 0 0.5051
Vwp_wih_2_8 wp_wih_2_8 0 0.5050
Vwn_wih_2_8 wn_wih_2_8 0 0.4233
Vwp_wih_3_8 wp_wih_3_8 0 0.5027
Vwn_wih_3_8 wn_wih_3_8 0 0.4103
Vwp_wih_4_8 wp_wih_4_8 0 0.4702
Vwn_wih_4_8 wn_wih_4_8 0 0.4577
Vwp_wih_5_8 wp_wih_5_8 0 0.5178
Vwn_wih_5_8 wn_wih_5_8 0 0.4072
Vwp_wih_6_8 wp_wih_6_8 0 0.4350
Vwn_wih_6_8 wn_wih_6_8 0 0.4810
Vwp_wih_7_8 wp_wih_7_8 0 0.4937
Vwn_wih_7_8 wn_wih_7_8 0 0.4343
Vwp_wih_8_8 wp_wih_8_8 0 0.4904
Vwn_wih_8_8 wn_wih_8_8 0 0.4365
Vwp_wih_9_8 wp_wih_9_8 0 0.4807
Vwn_wih_9_8 wn_wih_9_8 0 0.4422
Vwp_wih_10_8 wp_wih_10_8 0 0.4893
Vwn_wih_10_8 wn_wih_10_8 0 0.4446
Vwp_wih_11_8 wp_wih_11_8 0 0.5030
Vwn_wih_11_8 wn_wih_11_8 0 0.4228
Vwp_wih_12_8 wp_wih_12_8 0 0.4353
Vwn_wih_12_8 wn_wih_12_8 0 0.4913
Vwp_wih_13_8 wp_wih_13_8 0 0.4453
Vwn_wih_13_8 wn_wih_13_8 0 0.4894
Vwp_wih_14_8 wp_wih_14_8 0 0.4654
Vwn_wih_14_8 wn_wih_14_8 0 0.4615
Vwp_wih_15_8 wp_wih_15_8 0 0.4013
Vwn_wih_15_8 wn_wih_15_8 0 0.5123
Vwp_who_8_0 wp_who_8_0 0 0.5686
Vwn_who_8_0 wn_who_8_0 0 0.2619
Vwp_who_8_1 wp_who_8_1 0 0.5713
Vwn_who_8_1 wn_who_8_1 0 0.2591
Vwp_who_8_2 wp_who_8_2 0 0.2473
Vwn_who_8_2 wn_who_8_2 0 0.5876
Xcm_xh0 xhp0 xhn0 vdd cmld
Rnd_xh0 xhp0 xhn0 20k
X_ihx_0_0 a_xp0 a_xn0 wp_wih_0_0 wn_wih_0_0 xhp0 xhn0 vdd vbsyn gsyn
X_ihx_1_0 a_xp1 a_xn1 wp_wih_1_0 wn_wih_1_0 xhp0 xhn0 vdd vbsyn gsyn
X_ihx_2_0 a_xp2 a_xn2 wp_wih_2_0 wn_wih_2_0 xhp0 xhn0 vdd vbsyn gsyn
X_ihx_3_0 a_xp3 a_xn3 wp_wih_3_0 wn_wih_3_0 xhp0 xhn0 vdd vbsyn gsyn
X_ihx_4_0 a_xp4 a_xn4 wp_wih_4_0 wn_wih_4_0 xhp0 xhn0 vdd vbsyn gsyn
X_ihx_5_0 a_xp5 a_xn5 wp_wih_5_0 wn_wih_5_0 xhp0 xhn0 vdd vbsyn gsyn
X_ihx_6_0 a_xp6 a_xn6 wp_wih_6_0 wn_wih_6_0 xhp0 xhn0 vdd vbsyn gsyn
X_ihx_7_0 a_xp7 a_xn7 wp_wih_7_0 wn_wih_7_0 xhp0 xhn0 vdd vbsyn gsyn
X_ihx_8_0 a_xp8 a_xn8 wp_wih_8_0 wn_wih_8_0 xhp0 xhn0 vdd vbsyn gsyn
X_ihx_9_0 a_xp9 a_xn9 wp_wih_9_0 wn_wih_9_0 xhp0 xhn0 vdd vbsyn gsyn
X_ihx_10_0 a_xp10 a_xn10 wp_wih_10_0 wn_wih_10_0 xhp0 xhn0 vdd vbsyn gsyn
X_ihx_11_0 a_xp11 a_xn11 wp_wih_11_0 wn_wih_11_0 xhp0 xhn0 vdd vbsyn gsyn
X_ihx_12_0 a_xp12 a_xn12 wp_wih_12_0 wn_wih_12_0 xhp0 xhn0 vdd vbsyn gsyn
X_ihx_13_0 a_xp13 a_xn13 wp_wih_13_0 wn_wih_13_0 xhp0 xhn0 vdd vbsyn gsyn
X_ihx_14_0 a_xp14 a_xn14 wp_wih_14_0 wn_wih_14_0 xhp0 xhn0 vdd vbsyn gsyn
X_ihx_15_0 a_xp15 a_xn15 wp_wih_15_0 wn_wih_15_0 xhp0 xhn0 vdd vbsyn gsyn
Xn0 xhp0 xhn0 ahp0 ahn0 vdd vbneu dneuron
Xcm_xh1 xhp1 xhn1 vdd cmld
Rnd_xh1 xhp1 xhn1 20k
X_ihx_0_1 a_xp0 a_xn0 wp_wih_0_1 wn_wih_0_1 xhp1 xhn1 vdd vbsyn gsyn
X_ihx_1_1 a_xp1 a_xn1 wp_wih_1_1 wn_wih_1_1 xhp1 xhn1 vdd vbsyn gsyn
X_ihx_2_1 a_xp2 a_xn2 wp_wih_2_1 wn_wih_2_1 xhp1 xhn1 vdd vbsyn gsyn
X_ihx_3_1 a_xp3 a_xn3 wp_wih_3_1 wn_wih_3_1 xhp1 xhn1 vdd vbsyn gsyn
X_ihx_4_1 a_xp4 a_xn4 wp_wih_4_1 wn_wih_4_1 xhp1 xhn1 vdd vbsyn gsyn
X_ihx_5_1 a_xp5 a_xn5 wp_wih_5_1 wn_wih_5_1 xhp1 xhn1 vdd vbsyn gsyn
X_ihx_6_1 a_xp6 a_xn6 wp_wih_6_1 wn_wih_6_1 xhp1 xhn1 vdd vbsyn gsyn
X_ihx_7_1 a_xp7 a_xn7 wp_wih_7_1 wn_wih_7_1 xhp1 xhn1 vdd vbsyn gsyn
X_ihx_8_1 a_xp8 a_xn8 wp_wih_8_1 wn_wih_8_1 xhp1 xhn1 vdd vbsyn gsyn
X_ihx_9_1 a_xp9 a_xn9 wp_wih_9_1 wn_wih_9_1 xhp1 xhn1 vdd vbsyn gsyn
X_ihx_10_1 a_xp10 a_xn10 wp_wih_10_1 wn_wih_10_1 xhp1 xhn1 vdd vbsyn gsyn
X_ihx_11_1 a_xp11 a_xn11 wp_wih_11_1 wn_wih_11_1 xhp1 xhn1 vdd vbsyn gsyn
X_ihx_12_1 a_xp12 a_xn12 wp_wih_12_1 wn_wih_12_1 xhp1 xhn1 vdd vbsyn gsyn
X_ihx_13_1 a_xp13 a_xn13 wp_wih_13_1 wn_wih_13_1 xhp1 xhn1 vdd vbsyn gsyn
X_ihx_14_1 a_xp14 a_xn14 wp_wih_14_1 wn_wih_14_1 xhp1 xhn1 vdd vbsyn gsyn
X_ihx_15_1 a_xp15 a_xn15 wp_wih_15_1 wn_wih_15_1 xhp1 xhn1 vdd vbsyn gsyn
Xn1 xhp1 xhn1 ahp1 ahn1 vdd vbneu dneuron
Xcm_xh2 xhp2 xhn2 vdd cmld
Rnd_xh2 xhp2 xhn2 20k
X_ihx_0_2 a_xp0 a_xn0 wp_wih_0_2 wn_wih_0_2 xhp2 xhn2 vdd vbsyn gsyn
X_ihx_1_2 a_xp1 a_xn1 wp_wih_1_2 wn_wih_1_2 xhp2 xhn2 vdd vbsyn gsyn
X_ihx_2_2 a_xp2 a_xn2 wp_wih_2_2 wn_wih_2_2 xhp2 xhn2 vdd vbsyn gsyn
X_ihx_3_2 a_xp3 a_xn3 wp_wih_3_2 wn_wih_3_2 xhp2 xhn2 vdd vbsyn gsyn
X_ihx_4_2 a_xp4 a_xn4 wp_wih_4_2 wn_wih_4_2 xhp2 xhn2 vdd vbsyn gsyn
X_ihx_5_2 a_xp5 a_xn5 wp_wih_5_2 wn_wih_5_2 xhp2 xhn2 vdd vbsyn gsyn
X_ihx_6_2 a_xp6 a_xn6 wp_wih_6_2 wn_wih_6_2 xhp2 xhn2 vdd vbsyn gsyn
X_ihx_7_2 a_xp7 a_xn7 wp_wih_7_2 wn_wih_7_2 xhp2 xhn2 vdd vbsyn gsyn
X_ihx_8_2 a_xp8 a_xn8 wp_wih_8_2 wn_wih_8_2 xhp2 xhn2 vdd vbsyn gsyn
X_ihx_9_2 a_xp9 a_xn9 wp_wih_9_2 wn_wih_9_2 xhp2 xhn2 vdd vbsyn gsyn
X_ihx_10_2 a_xp10 a_xn10 wp_wih_10_2 wn_wih_10_2 xhp2 xhn2 vdd vbsyn gsyn
X_ihx_11_2 a_xp11 a_xn11 wp_wih_11_2 wn_wih_11_2 xhp2 xhn2 vdd vbsyn gsyn
X_ihx_12_2 a_xp12 a_xn12 wp_wih_12_2 wn_wih_12_2 xhp2 xhn2 vdd vbsyn gsyn
X_ihx_13_2 a_xp13 a_xn13 wp_wih_13_2 wn_wih_13_2 xhp2 xhn2 vdd vbsyn gsyn
X_ihx_14_2 a_xp14 a_xn14 wp_wih_14_2 wn_wih_14_2 xhp2 xhn2 vdd vbsyn gsyn
X_ihx_15_2 a_xp15 a_xn15 wp_wih_15_2 wn_wih_15_2 xhp2 xhn2 vdd vbsyn gsyn
Xn2 xhp2 xhn2 ahp2 ahn2 vdd vbneu dneuron
Xcm_xh3 xhp3 xhn3 vdd cmld
Rnd_xh3 xhp3 xhn3 20k
X_ihx_0_3 a_xp0 a_xn0 wp_wih_0_3 wn_wih_0_3 xhp3 xhn3 vdd vbsyn gsyn
X_ihx_1_3 a_xp1 a_xn1 wp_wih_1_3 wn_wih_1_3 xhp3 xhn3 vdd vbsyn gsyn
X_ihx_2_3 a_xp2 a_xn2 wp_wih_2_3 wn_wih_2_3 xhp3 xhn3 vdd vbsyn gsyn
X_ihx_3_3 a_xp3 a_xn3 wp_wih_3_3 wn_wih_3_3 xhp3 xhn3 vdd vbsyn gsyn
X_ihx_4_3 a_xp4 a_xn4 wp_wih_4_3 wn_wih_4_3 xhp3 xhn3 vdd vbsyn gsyn
X_ihx_5_3 a_xp5 a_xn5 wp_wih_5_3 wn_wih_5_3 xhp3 xhn3 vdd vbsyn gsyn
X_ihx_6_3 a_xp6 a_xn6 wp_wih_6_3 wn_wih_6_3 xhp3 xhn3 vdd vbsyn gsyn
X_ihx_7_3 a_xp7 a_xn7 wp_wih_7_3 wn_wih_7_3 xhp3 xhn3 vdd vbsyn gsyn
X_ihx_8_3 a_xp8 a_xn8 wp_wih_8_3 wn_wih_8_3 xhp3 xhn3 vdd vbsyn gsyn
X_ihx_9_3 a_xp9 a_xn9 wp_wih_9_3 wn_wih_9_3 xhp3 xhn3 vdd vbsyn gsyn
X_ihx_10_3 a_xp10 a_xn10 wp_wih_10_3 wn_wih_10_3 xhp3 xhn3 vdd vbsyn gsyn
X_ihx_11_3 a_xp11 a_xn11 wp_wih_11_3 wn_wih_11_3 xhp3 xhn3 vdd vbsyn gsyn
X_ihx_12_3 a_xp12 a_xn12 wp_wih_12_3 wn_wih_12_3 xhp3 xhn3 vdd vbsyn gsyn
X_ihx_13_3 a_xp13 a_xn13 wp_wih_13_3 wn_wih_13_3 xhp3 xhn3 vdd vbsyn gsyn
X_ihx_14_3 a_xp14 a_xn14 wp_wih_14_3 wn_wih_14_3 xhp3 xhn3 vdd vbsyn gsyn
X_ihx_15_3 a_xp15 a_xn15 wp_wih_15_3 wn_wih_15_3 xhp3 xhn3 vdd vbsyn gsyn
Xn3 xhp3 xhn3 ahp3 ahn3 vdd vbneu dneuron
Xcm_xh4 xhp4 xhn4 vdd cmld
Rnd_xh4 xhp4 xhn4 20k
X_ihx_0_4 a_xp0 a_xn0 wp_wih_0_4 wn_wih_0_4 xhp4 xhn4 vdd vbsyn gsyn
X_ihx_1_4 a_xp1 a_xn1 wp_wih_1_4 wn_wih_1_4 xhp4 xhn4 vdd vbsyn gsyn
X_ihx_2_4 a_xp2 a_xn2 wp_wih_2_4 wn_wih_2_4 xhp4 xhn4 vdd vbsyn gsyn
X_ihx_3_4 a_xp3 a_xn3 wp_wih_3_4 wn_wih_3_4 xhp4 xhn4 vdd vbsyn gsyn
X_ihx_4_4 a_xp4 a_xn4 wp_wih_4_4 wn_wih_4_4 xhp4 xhn4 vdd vbsyn gsyn
X_ihx_5_4 a_xp5 a_xn5 wp_wih_5_4 wn_wih_5_4 xhp4 xhn4 vdd vbsyn gsyn
X_ihx_6_4 a_xp6 a_xn6 wp_wih_6_4 wn_wih_6_4 xhp4 xhn4 vdd vbsyn gsyn
X_ihx_7_4 a_xp7 a_xn7 wp_wih_7_4 wn_wih_7_4 xhp4 xhn4 vdd vbsyn gsyn
X_ihx_8_4 a_xp8 a_xn8 wp_wih_8_4 wn_wih_8_4 xhp4 xhn4 vdd vbsyn gsyn
X_ihx_9_4 a_xp9 a_xn9 wp_wih_9_4 wn_wih_9_4 xhp4 xhn4 vdd vbsyn gsyn
X_ihx_10_4 a_xp10 a_xn10 wp_wih_10_4 wn_wih_10_4 xhp4 xhn4 vdd vbsyn gsyn
X_ihx_11_4 a_xp11 a_xn11 wp_wih_11_4 wn_wih_11_4 xhp4 xhn4 vdd vbsyn gsyn
X_ihx_12_4 a_xp12 a_xn12 wp_wih_12_4 wn_wih_12_4 xhp4 xhn4 vdd vbsyn gsyn
X_ihx_13_4 a_xp13 a_xn13 wp_wih_13_4 wn_wih_13_4 xhp4 xhn4 vdd vbsyn gsyn
X_ihx_14_4 a_xp14 a_xn14 wp_wih_14_4 wn_wih_14_4 xhp4 xhn4 vdd vbsyn gsyn
X_ihx_15_4 a_xp15 a_xn15 wp_wih_15_4 wn_wih_15_4 xhp4 xhn4 vdd vbsyn gsyn
Xn4 xhp4 xhn4 ahp4 ahn4 vdd vbneu dneuron
Xcm_xh5 xhp5 xhn5 vdd cmld
Rnd_xh5 xhp5 xhn5 20k
X_ihx_0_5 a_xp0 a_xn0 wp_wih_0_5 wn_wih_0_5 xhp5 xhn5 vdd vbsyn gsyn
X_ihx_1_5 a_xp1 a_xn1 wp_wih_1_5 wn_wih_1_5 xhp5 xhn5 vdd vbsyn gsyn
X_ihx_2_5 a_xp2 a_xn2 wp_wih_2_5 wn_wih_2_5 xhp5 xhn5 vdd vbsyn gsyn
X_ihx_3_5 a_xp3 a_xn3 wp_wih_3_5 wn_wih_3_5 xhp5 xhn5 vdd vbsyn gsyn
X_ihx_4_5 a_xp4 a_xn4 wp_wih_4_5 wn_wih_4_5 xhp5 xhn5 vdd vbsyn gsyn
X_ihx_5_5 a_xp5 a_xn5 wp_wih_5_5 wn_wih_5_5 xhp5 xhn5 vdd vbsyn gsyn
X_ihx_6_5 a_xp6 a_xn6 wp_wih_6_5 wn_wih_6_5 xhp5 xhn5 vdd vbsyn gsyn
X_ihx_7_5 a_xp7 a_xn7 wp_wih_7_5 wn_wih_7_5 xhp5 xhn5 vdd vbsyn gsyn
X_ihx_8_5 a_xp8 a_xn8 wp_wih_8_5 wn_wih_8_5 xhp5 xhn5 vdd vbsyn gsyn
X_ihx_9_5 a_xp9 a_xn9 wp_wih_9_5 wn_wih_9_5 xhp5 xhn5 vdd vbsyn gsyn
X_ihx_10_5 a_xp10 a_xn10 wp_wih_10_5 wn_wih_10_5 xhp5 xhn5 vdd vbsyn gsyn
X_ihx_11_5 a_xp11 a_xn11 wp_wih_11_5 wn_wih_11_5 xhp5 xhn5 vdd vbsyn gsyn
X_ihx_12_5 a_xp12 a_xn12 wp_wih_12_5 wn_wih_12_5 xhp5 xhn5 vdd vbsyn gsyn
X_ihx_13_5 a_xp13 a_xn13 wp_wih_13_5 wn_wih_13_5 xhp5 xhn5 vdd vbsyn gsyn
X_ihx_14_5 a_xp14 a_xn14 wp_wih_14_5 wn_wih_14_5 xhp5 xhn5 vdd vbsyn gsyn
X_ihx_15_5 a_xp15 a_xn15 wp_wih_15_5 wn_wih_15_5 xhp5 xhn5 vdd vbsyn gsyn
Xn5 xhp5 xhn5 ahp5 ahn5 vdd vbneu dneuron
Xcm_xh6 xhp6 xhn6 vdd cmld
Rnd_xh6 xhp6 xhn6 20k
X_ihx_0_6 a_xp0 a_xn0 wp_wih_0_6 wn_wih_0_6 xhp6 xhn6 vdd vbsyn gsyn
X_ihx_1_6 a_xp1 a_xn1 wp_wih_1_6 wn_wih_1_6 xhp6 xhn6 vdd vbsyn gsyn
X_ihx_2_6 a_xp2 a_xn2 wp_wih_2_6 wn_wih_2_6 xhp6 xhn6 vdd vbsyn gsyn
X_ihx_3_6 a_xp3 a_xn3 wp_wih_3_6 wn_wih_3_6 xhp6 xhn6 vdd vbsyn gsyn
X_ihx_4_6 a_xp4 a_xn4 wp_wih_4_6 wn_wih_4_6 xhp6 xhn6 vdd vbsyn gsyn
X_ihx_5_6 a_xp5 a_xn5 wp_wih_5_6 wn_wih_5_6 xhp6 xhn6 vdd vbsyn gsyn
X_ihx_6_6 a_xp6 a_xn6 wp_wih_6_6 wn_wih_6_6 xhp6 xhn6 vdd vbsyn gsyn
X_ihx_7_6 a_xp7 a_xn7 wp_wih_7_6 wn_wih_7_6 xhp6 xhn6 vdd vbsyn gsyn
X_ihx_8_6 a_xp8 a_xn8 wp_wih_8_6 wn_wih_8_6 xhp6 xhn6 vdd vbsyn gsyn
X_ihx_9_6 a_xp9 a_xn9 wp_wih_9_6 wn_wih_9_6 xhp6 xhn6 vdd vbsyn gsyn
X_ihx_10_6 a_xp10 a_xn10 wp_wih_10_6 wn_wih_10_6 xhp6 xhn6 vdd vbsyn gsyn
X_ihx_11_6 a_xp11 a_xn11 wp_wih_11_6 wn_wih_11_6 xhp6 xhn6 vdd vbsyn gsyn
X_ihx_12_6 a_xp12 a_xn12 wp_wih_12_6 wn_wih_12_6 xhp6 xhn6 vdd vbsyn gsyn
X_ihx_13_6 a_xp13 a_xn13 wp_wih_13_6 wn_wih_13_6 xhp6 xhn6 vdd vbsyn gsyn
X_ihx_14_6 a_xp14 a_xn14 wp_wih_14_6 wn_wih_14_6 xhp6 xhn6 vdd vbsyn gsyn
X_ihx_15_6 a_xp15 a_xn15 wp_wih_15_6 wn_wih_15_6 xhp6 xhn6 vdd vbsyn gsyn
Xn6 xhp6 xhn6 ahp6 ahn6 vdd vbneu dneuron
Xcm_xh7 xhp7 xhn7 vdd cmld
Rnd_xh7 xhp7 xhn7 20k
X_ihx_0_7 a_xp0 a_xn0 wp_wih_0_7 wn_wih_0_7 xhp7 xhn7 vdd vbsyn gsyn
X_ihx_1_7 a_xp1 a_xn1 wp_wih_1_7 wn_wih_1_7 xhp7 xhn7 vdd vbsyn gsyn
X_ihx_2_7 a_xp2 a_xn2 wp_wih_2_7 wn_wih_2_7 xhp7 xhn7 vdd vbsyn gsyn
X_ihx_3_7 a_xp3 a_xn3 wp_wih_3_7 wn_wih_3_7 xhp7 xhn7 vdd vbsyn gsyn
X_ihx_4_7 a_xp4 a_xn4 wp_wih_4_7 wn_wih_4_7 xhp7 xhn7 vdd vbsyn gsyn
X_ihx_5_7 a_xp5 a_xn5 wp_wih_5_7 wn_wih_5_7 xhp7 xhn7 vdd vbsyn gsyn
X_ihx_6_7 a_xp6 a_xn6 wp_wih_6_7 wn_wih_6_7 xhp7 xhn7 vdd vbsyn gsyn
X_ihx_7_7 a_xp7 a_xn7 wp_wih_7_7 wn_wih_7_7 xhp7 xhn7 vdd vbsyn gsyn
X_ihx_8_7 a_xp8 a_xn8 wp_wih_8_7 wn_wih_8_7 xhp7 xhn7 vdd vbsyn gsyn
X_ihx_9_7 a_xp9 a_xn9 wp_wih_9_7 wn_wih_9_7 xhp7 xhn7 vdd vbsyn gsyn
X_ihx_10_7 a_xp10 a_xn10 wp_wih_10_7 wn_wih_10_7 xhp7 xhn7 vdd vbsyn gsyn
X_ihx_11_7 a_xp11 a_xn11 wp_wih_11_7 wn_wih_11_7 xhp7 xhn7 vdd vbsyn gsyn
X_ihx_12_7 a_xp12 a_xn12 wp_wih_12_7 wn_wih_12_7 xhp7 xhn7 vdd vbsyn gsyn
X_ihx_13_7 a_xp13 a_xn13 wp_wih_13_7 wn_wih_13_7 xhp7 xhn7 vdd vbsyn gsyn
X_ihx_14_7 a_xp14 a_xn14 wp_wih_14_7 wn_wih_14_7 xhp7 xhn7 vdd vbsyn gsyn
X_ihx_15_7 a_xp15 a_xn15 wp_wih_15_7 wn_wih_15_7 xhp7 xhn7 vdd vbsyn gsyn
Xn7 xhp7 xhn7 ahp7 ahn7 vdd vbneu dneuron
Xcm_xh8 xhp8 xhn8 vdd cmld
Rnd_xh8 xhp8 xhn8 20k
X_ihx_0_8 a_xp0 a_xn0 wp_wih_0_8 wn_wih_0_8 xhp8 xhn8 vdd vbsyn gsyn
X_ihx_1_8 a_xp1 a_xn1 wp_wih_1_8 wn_wih_1_8 xhp8 xhn8 vdd vbsyn gsyn
X_ihx_2_8 a_xp2 a_xn2 wp_wih_2_8 wn_wih_2_8 xhp8 xhn8 vdd vbsyn gsyn
X_ihx_3_8 a_xp3 a_xn3 wp_wih_3_8 wn_wih_3_8 xhp8 xhn8 vdd vbsyn gsyn
X_ihx_4_8 a_xp4 a_xn4 wp_wih_4_8 wn_wih_4_8 xhp8 xhn8 vdd vbsyn gsyn
X_ihx_5_8 a_xp5 a_xn5 wp_wih_5_8 wn_wih_5_8 xhp8 xhn8 vdd vbsyn gsyn
X_ihx_6_8 a_xp6 a_xn6 wp_wih_6_8 wn_wih_6_8 xhp8 xhn8 vdd vbsyn gsyn
X_ihx_7_8 a_xp7 a_xn7 wp_wih_7_8 wn_wih_7_8 xhp8 xhn8 vdd vbsyn gsyn
X_ihx_8_8 a_xp8 a_xn8 wp_wih_8_8 wn_wih_8_8 xhp8 xhn8 vdd vbsyn gsyn
X_ihx_9_8 a_xp9 a_xn9 wp_wih_9_8 wn_wih_9_8 xhp8 xhn8 vdd vbsyn gsyn
X_ihx_10_8 a_xp10 a_xn10 wp_wih_10_8 wn_wih_10_8 xhp8 xhn8 vdd vbsyn gsyn
X_ihx_11_8 a_xp11 a_xn11 wp_wih_11_8 wn_wih_11_8 xhp8 xhn8 vdd vbsyn gsyn
X_ihx_12_8 a_xp12 a_xn12 wp_wih_12_8 wn_wih_12_8 xhp8 xhn8 vdd vbsyn gsyn
X_ihx_13_8 a_xp13 a_xn13 wp_wih_13_8 wn_wih_13_8 xhp8 xhn8 vdd vbsyn gsyn
X_ihx_14_8 a_xp14 a_xn14 wp_wih_14_8 wn_wih_14_8 xhp8 xhn8 vdd vbsyn gsyn
X_ihx_15_8 a_xp15 a_xn15 wp_wih_15_8 wn_wih_15_8 xhp8 xhn8 vdd vbsyn gsyn
Xn8 xhp8 xhn8 ahp8 ahn8 vdd vbneu dneuron
Xcm_mo0 mop0 mon0 vdd cmld
Rnd_mo0 mop0 mon0 20k
X_ho_0_0 ahp0 ahn0 wp_who_0_0 wn_who_0_0 mop0 mon0 vdd vbsyn gsyn
X_ho_1_0 ahp1 ahn1 wp_who_1_0 wn_who_1_0 mop0 mon0 vdd vbsyn gsyn
X_ho_2_0 ahp2 ahn2 wp_who_2_0 wn_who_2_0 mop0 mon0 vdd vbsyn gsyn
X_ho_3_0 ahp3 ahn3 wp_who_3_0 wn_who_3_0 mop0 mon0 vdd vbsyn gsyn
X_ho_4_0 ahp4 ahn4 wp_who_4_0 wn_who_4_0 mop0 mon0 vdd vbsyn gsyn
X_ho_5_0 ahp5 ahn5 wp_who_5_0 wn_who_5_0 mop0 mon0 vdd vbsyn gsyn
X_ho_6_0 ahp6 ahn6 wp_who_6_0 wn_who_6_0 mop0 mon0 vdd vbsyn gsyn
X_ho_7_0 ahp7 ahn7 wp_who_7_0 wn_who_7_0 mop0 mon0 vdd vbsyn gsyn
X_ho_8_0 ahp8 ahn8 wp_who_8_0 wn_who_8_0 mop0 mon0 vdd vbsyn gsyn
Xcm_mo1 mop1 mon1 vdd cmld
Rnd_mo1 mop1 mon1 20k
X_ho_0_1 ahp0 ahn0 wp_who_0_1 wn_who_0_1 mop1 mon1 vdd vbsyn gsyn
X_ho_1_1 ahp1 ahn1 wp_who_1_1 wn_who_1_1 mop1 mon1 vdd vbsyn gsyn
X_ho_2_1 ahp2 ahn2 wp_who_2_1 wn_who_2_1 mop1 mon1 vdd vbsyn gsyn
X_ho_3_1 ahp3 ahn3 wp_who_3_1 wn_who_3_1 mop1 mon1 vdd vbsyn gsyn
X_ho_4_1 ahp4 ahn4 wp_who_4_1 wn_who_4_1 mop1 mon1 vdd vbsyn gsyn
X_ho_5_1 ahp5 ahn5 wp_who_5_1 wn_who_5_1 mop1 mon1 vdd vbsyn gsyn
X_ho_6_1 ahp6 ahn6 wp_who_6_1 wn_who_6_1 mop1 mon1 vdd vbsyn gsyn
X_ho_7_1 ahp7 ahn7 wp_who_7_1 wn_who_7_1 mop1 mon1 vdd vbsyn gsyn
X_ho_8_1 ahp8 ahn8 wp_who_8_1 wn_who_8_1 mop1 mon1 vdd vbsyn gsyn
Xcm_mo2 mop2 mon2 vdd cmld
Rnd_mo2 mop2 mon2 20k
X_ho_0_2 ahp0 ahn0 wp_who_0_2 wn_who_0_2 mop2 mon2 vdd vbsyn gsyn
X_ho_1_2 ahp1 ahn1 wp_who_1_2 wn_who_1_2 mop2 mon2 vdd vbsyn gsyn
X_ho_2_2 ahp2 ahn2 wp_who_2_2 wn_who_2_2 mop2 mon2 vdd vbsyn gsyn
X_ho_3_2 ahp3 ahn3 wp_who_3_2 wn_who_3_2 mop2 mon2 vdd vbsyn gsyn
X_ho_4_2 ahp4 ahn4 wp_who_4_2 wn_who_4_2 mop2 mon2 vdd vbsyn gsyn
X_ho_5_2 ahp5 ahn5 wp_who_5_2 wn_who_5_2 mop2 mon2 vdd vbsyn gsyn
X_ho_6_2 ahp6 ahn6 wp_who_6_2 wn_who_6_2 mop2 mon2 vdd vbsyn gsyn
X_ho_7_2 ahp7 ahn7 wp_who_7_2 wn_who_7_2 mop2 mon2 vdd vbsyn gsyn
X_ho_8_2 ahp8 ahn8 wp_who_8_2 wn_who_8_2 mop2 mon2 vdd vbsyn gsyn
.options gmin=1e-10
.control
alter Vxp0 = 0.4393
alter Vxn0 = 0.5607
alter Vxp1 = 0.4967
alter Vxn1 = 0.5033
alter Vxp2 = 0.4994
alter Vxn2 = 0.5006
alter Vxp3 = 0.4537
alter Vxn3 = 0.5463
alter Vxp4 = 0.4811
alter Vxn4 = 0.5189
alter Vxp5 = 0.5675
alter Vxn5 = 0.4325
alter Vxp6 = 0.4072
alter Vxn6 = 0.5928
alter Vxp7 = 0.6229
alter Vxn7 = 0.3771
alter Vxp8 = 0.5348
alter Vxn8 = 0.4652
alter Vxp9 = 0.4635
alter Vxn9 = 0.5365
alter Vxp10 = 0.3699
alter Vxn10 = 0.6301
alter Vxp11 = 0.6549
alter Vxn11 = 0.3451
alter Vxp12 = 0.4570
alter Vxn12 = 0.5430
alter Vxp13 = 0.5637
alter Vxn13 = 0.4363
alter Vxp14 = 0.5765
alter Vxn14 = 0.4235
alter Vxp15 = 0.4443
alter Vxn15 = 0.5557
op
wrdata pcMevc3_0.dat v(mop0) v(mon0) v(mop1) v(mon1) v(mop2) v(mon2)
alter Vxp0 = 0.4393
alter Vxn0 = 0.5607
alter Vxp1 = 0.5129
alter Vxn1 = 0.4871
alter Vxp2 = 0.5550
alter Vxn2 = 0.4450
alter Vxp3 = 0.4806
alter Vxn3 = 0.5194
alter Vxp4 = 0.5513
alter Vxn4 = 0.4487
alter Vxp5 = 0.4880
alter Vxn5 = 0.5120
alter Vxp6 = 0.4133
alter Vxn6 = 0.5867
alter Vxp7 = 0.6229
alter Vxn7 = 0.3771
alter Vxp8 = 0.6189
alter Vxn8 = 0.3811
alter Vxp9 = 0.4902
alter Vxn9 = 0.5098
alter Vxp10 = 0.3771
alter Vxn10 = 0.6229
alter Vxp11 = 0.5673
alter Vxn11 = 0.4327
alter Vxp12 = 0.5004
alter Vxn12 = 0.4996
alter Vxp13 = 0.5484
alter Vxn13 = 0.4516
alter Vxp14 = 0.5493
alter Vxn14 = 0.4507
alter Vxp15 = 0.4443
alter Vxn15 = 0.5557
op
wrdata pcMevc3_1.dat v(mop0) v(mon0) v(mop1) v(mon1) v(mop2) v(mon2)
alter Vxp0 = 0.4657
alter Vxn0 = 0.5343
alter Vxp1 = 0.6020
alter Vxn1 = 0.3980
alter Vxp2 = 0.5480
alter Vxn2 = 0.4520
alter Vxp3 = 0.4671
alter Vxn3 = 0.5329
alter Vxp4 = 0.6566
alter Vxn4 = 0.3434
alter Vxp5 = 0.4217
alter Vxn5 = 0.5783
alter Vxp6 = 0.4313
alter Vxn6 = 0.5687
alter Vxp7 = 0.6857
alter Vxn7 = 0.3143
alter Vxp8 = 0.6525
alter Vxn8 = 0.3475
alter Vxp9 = 0.4742
alter Vxn9 = 0.5258
alter Vxp10 = 0.3916
alter Vxn10 = 0.6084
alter Vxp11 = 0.7279
alter Vxn11 = 0.2721
alter Vxp12 = 0.5871
alter Vxn12 = 0.4129
alter Vxp13 = 0.6251
alter Vxn13 = 0.3749
alter Vxp14 = 0.6377
alter Vxn14 = 0.3623
alter Vxp15 = 0.5274
alter Vxn15 = 0.4726
op
wrdata pcMevc3_2.dat v(mop0) v(mon0) v(mop1) v(mon1) v(mop2) v(mon2)
alter Vxp0 = 0.4393
alter Vxn0 = 0.5607
alter Vxp1 = 0.4400
alter Vxn1 = 0.5600
alter Vxp2 = 0.5064
alter Vxn2 = 0.4936
alter Vxp3 = 0.4806
alter Vxn3 = 0.5194
alter Vxp4 = 0.5162
alter Vxn4 = 0.4838
alter Vxp5 = 0.4217
alter Vxn5 = 0.5783
alter Vxp6 = 0.4012
alter Vxn6 = 0.5988
alter Vxp7 = 0.6543
alter Vxn7 = 0.3457
alter Vxp8 = 0.5516
alter Vxn8 = 0.4484
alter Vxp9 = 0.4422
alter Vxn9 = 0.5578
alter Vxp10 = 0.3699
alter Vxn10 = 0.6301
alter Vxp11 = 0.5819
alter Vxn11 = 0.4181
alter Vxp12 = 0.4570
alter Vxn12 = 0.5430
alter Vxp13 = 0.4563
alter Vxn13 = 0.5437
alter Vxp14 = 0.5561
alter Vxn14 = 0.4439
alter Vxp15 = 0.4650
alter Vxn15 = 0.5350
op
wrdata pcMevc3_3.dat v(mop0) v(mon0) v(mop1) v(mon1) v(mop2) v(mon2)
alter Vxp0 = 0.4393
alter Vxn0 = 0.5607
alter Vxp1 = 0.5453
alter Vxn1 = 0.4547
alter Vxp2 = 0.4647
alter Vxn2 = 0.5353
alter Vxp3 = 0.4537
alter Vxn3 = 0.5463
alter Vxp4 = 0.4110
alter Vxn4 = 0.5890
alter Vxp5 = 0.6206
alter Vxn5 = 0.3794
alter Vxp6 = 0.4253
alter Vxn6 = 0.5747
alter Vxp7 = 0.4975
alter Vxn7 = 0.5025
alter Vxp8 = 0.5011
alter Vxn8 = 0.4989
alter Vxp9 = 0.5861
alter Vxn9 = 0.4139
alter Vxp10 = 0.3046
alter Vxn10 = 0.6954
alter Vxp11 = 0.6987
alter Vxn11 = 0.3013
alter Vxp12 = 0.5004
alter Vxn12 = 0.4996
alter Vxp13 = 0.5791
alter Vxn13 = 0.4209
alter Vxp14 = 0.6173
alter Vxn14 = 0.3827
alter Vxp15 = 0.4962
alter Vxn15 = 0.5038
op
wrdata pcMevc3_4.dat v(mop0) v(mon0) v(mop1) v(mon1) v(mop2) v(mon2)
alter Vxp0 = 0.4393
alter Vxn0 = 0.5607
alter Vxp1 = 0.4886
alter Vxn1 = 0.5114
alter Vxp2 = 0.5133
alter Vxn2 = 0.4867
alter Vxp3 = 0.4671
alter Vxn3 = 0.5329
alter Vxp4 = 0.5689
alter Vxn4 = 0.4311
alter Vxp5 = 0.4615
alter Vxn5 = 0.5385
alter Vxp6 = 0.3831
alter Vxn6 = 0.6169
alter Vxp7 = 0.6543
alter Vxn7 = 0.3457
alter Vxp8 = 0.5180
alter Vxn8 = 0.4820
alter Vxp9 = 0.4529
alter Vxn9 = 0.5471
alter Vxp10 = 0.3119
alter Vxn10 = 0.6881
alter Vxp11 = 0.6403
alter Vxn11 = 0.3597
alter Vxp12 = 0.4570
alter Vxn12 = 0.5430
alter Vxp13 = 0.5330
alter Vxn13 = 0.4670
alter Vxp14 = 0.5289
alter Vxn14 = 0.4711
alter Vxp15 = 0.4754
alter Vxn15 = 0.5246
op
wrdata pcMevc3_5.dat v(mop0) v(mon0) v(mop1) v(mon1) v(mop2) v(mon2)
alter Vxp0 = 0.4657
alter Vxn0 = 0.5343
alter Vxp1 = 0.5129
alter Vxn1 = 0.4871
alter Vxp2 = 0.5064
alter Vxn2 = 0.4936
alter Vxp3 = 0.4537
alter Vxn3 = 0.5463
alter Vxp4 = 0.6390
alter Vxn4 = 0.3610
alter Vxp5 = 0.6007
alter Vxn5 = 0.3993
alter Vxp6 = 0.4313
alter Vxn6 = 0.5687
alter Vxp7 = 0.6229
alter Vxn7 = 0.3771
alter Vxp8 = 0.6021
alter Vxn8 = 0.3979
alter Vxp9 = 0.4848
alter Vxn9 = 0.5152
alter Vxp10 = 0.4134
alter Vxn10 = 0.5866
alter Vxp11 = 0.6987
alter Vxn11 = 0.3013
alter Vxp12 = 0.4570
alter Vxn12 = 0.5430
alter Vxp13 = 0.5407
alter Vxn13 = 0.4593
alter Vxp14 = 0.5697
alter Vxn14 = 0.4303
alter Vxp15 = 0.4650
alter Vxn15 = 0.5350
op
wrdata pcMevc3_6.dat v(mop0) v(mon0) v(mop1) v(mon1) v(mop2) v(mon2)
alter Vxp0 = 0.5710
alter Vxn0 = 0.4290
alter Vxp1 = 0.5453
alter Vxn1 = 0.4547
alter Vxp2 = 0.4786
alter Vxn2 = 0.5214
alter Vxp3 = 0.4537
alter Vxn3 = 0.5463
alter Vxp4 = 0.6039
alter Vxn4 = 0.3961
alter Vxp5 = 0.5013
alter Vxn5 = 0.4987
alter Vxp6 = 0.4133
alter Vxn6 = 0.5867
alter Vxp7 = 0.5289
alter Vxn7 = 0.4711
alter Vxp8 = 0.5180
alter Vxn8 = 0.4820
alter Vxp9 = 0.4529
alter Vxn9 = 0.5471
alter Vxp10 = 0.3844
alter Vxn10 = 0.6156
alter Vxp11 = 0.5527
alter Vxn11 = 0.4473
alter Vxp12 = 0.4570
alter Vxn12 = 0.5430
alter Vxp13 = 0.4257
alter Vxn13 = 0.5743
alter Vxp14 = 0.5017
alter Vxn14 = 0.4983
alter Vxp15 = 0.4339
alter Vxn15 = 0.5661
op
wrdata pcMevc3_7.dat v(mop0) v(mon0) v(mop1) v(mon1) v(mop2) v(mon2)
alter Vxp0 = 0.5184
alter Vxn0 = 0.4816
alter Vxp1 = 0.5939
alter Vxn1 = 0.4061
alter Vxp2 = 0.5133
alter Vxn2 = 0.4867
alter Vxp3 = 0.4537
alter Vxn3 = 0.5463
alter Vxp4 = 0.5864
alter Vxn4 = 0.4136
alter Vxp5 = 0.5212
alter Vxn5 = 0.4788
alter Vxp6 = 0.4796
alter Vxn6 = 0.5204
alter Vxp7 = 0.6857
alter Vxn7 = 0.3143
alter Vxp8 = 0.6694
alter Vxn8 = 0.3306
alter Vxp9 = 0.5008
alter Vxn9 = 0.4992
alter Vxp10 = 0.4713
alter Vxn10 = 0.5287
alter Vxp11 = 0.6403
alter Vxn11 = 0.3597
alter Vxp12 = 0.6305
alter Vxn12 = 0.3695
alter Vxp13 = 0.6097
alter Vxn13 = 0.3903
alter Vxp14 = 0.5221
alter Vxn14 = 0.4779
alter Vxp15 = 0.4443
alter Vxn15 = 0.5557
op
wrdata pcMevc3_8.dat v(mop0) v(mon0) v(mop1) v(mon1) v(mop2) v(mon2)
alter Vxp0 = 0.4393
alter Vxn0 = 0.5607
alter Vxp1 = 0.4562
alter Vxn1 = 0.5438
alter Vxp2 = 0.5411
alter Vxn2 = 0.4589
alter Vxp3 = 0.4537
alter Vxn3 = 0.5463
alter Vxp4 = 0.5513
alter Vxn4 = 0.4487
alter Vxp5 = 0.6073
alter Vxn5 = 0.3927
alter Vxp6 = 0.4736
alter Vxn6 = 0.5264
alter Vxp7 = 0.5289
alter Vxn7 = 0.4711
alter Vxp8 = 0.5684
alter Vxn8 = 0.4316
alter Vxp9 = 0.4955
alter Vxn9 = 0.5045
alter Vxp10 = 0.5076
alter Vxn10 = 0.4924
alter Vxp11 = 0.5235
alter Vxn11 = 0.4765
alter Vxp12 = 0.4570
alter Vxn12 = 0.5430
alter Vxp13 = 0.5330
alter Vxn13 = 0.4670
alter Vxp14 = 0.5833
alter Vxn14 = 0.4167
alter Vxp15 = 0.4443
alter Vxn15 = 0.5557
op
wrdata pcMevc3_9.dat v(mop0) v(mon0) v(mop1) v(mon1) v(mop2) v(mon2)
alter Vxp0 = 0.5184
alter Vxn0 = 0.4816
alter Vxp1 = 0.6182
alter Vxn1 = 0.3818
alter Vxp2 = 0.4230
alter Vxn2 = 0.5770
alter Vxp3 = 0.4537
alter Vxn3 = 0.5463
alter Vxp4 = 0.7267
alter Vxn4 = 0.2733
alter Vxp5 = 0.4416
alter Vxn5 = 0.5584
alter Vxp6 = 0.5158
alter Vxn6 = 0.4842
alter Vxp7 = 0.5132
alter Vxn7 = 0.4868
alter Vxp8 = 0.6525
alter Vxn8 = 0.3475
alter Vxp9 = 0.4529
alter Vxn9 = 0.5471
alter Vxp10 = 0.4061
alter Vxn10 = 0.5939
alter Vxp11 = 0.6403
alter Vxn11 = 0.3597
alter Vxp12 = 0.4570
alter Vxn12 = 0.5430
alter Vxp13 = 0.6021
alter Vxn13 = 0.3979
alter Vxp14 = 0.5901
alter Vxn14 = 0.4099
alter Vxp15 = 0.4754
alter Vxn15 = 0.5246
op
wrdata pcMevc3_10.dat v(mop0) v(mon0) v(mop1) v(mon1) v(mop2) v(mon2)
alter Vxp0 = 0.4393
alter Vxn0 = 0.5607
alter Vxp1 = 0.5858
alter Vxn1 = 0.4142
alter Vxp2 = 0.3883
alter Vxn2 = 0.6117
alter Vxp3 = 0.4537
alter Vxn3 = 0.5463
alter Vxp4 = 0.5513
alter Vxn4 = 0.4487
alter Vxp5 = 0.5145
alter Vxn5 = 0.4855
alter Vxp6 = 0.5037
alter Vxn6 = 0.4963
alter Vxp7 = 0.4818
alter Vxn7 = 0.5182
alter Vxp8 = 0.6694
alter Vxn8 = 0.3306
alter Vxp9 = 0.4688
alter Vxn9 = 0.5312
alter Vxp10 = 0.3554
alter Vxn10 = 0.6446
alter Vxp11 = 0.6403
alter Vxn11 = 0.3597
alter Vxp12 = 0.5004
alter Vxn12 = 0.4996
alter Vxp13 = 0.6174
alter Vxn13 = 0.3826
alter Vxp14 = 0.5425
alter Vxn14 = 0.4575
alter Vxp15 = 0.4650
alter Vxn15 = 0.5350
op
wrdata pcMevc3_11.dat v(mop0) v(mon0) v(mop1) v(mon1) v(mop2) v(mon2)
alter Vxp0 = 0.4393
alter Vxn0 = 0.5607
alter Vxp1 = 0.5696
alter Vxn1 = 0.4304
alter Vxp2 = 0.4994
alter Vxn2 = 0.5006
alter Vxp3 = 0.5209
alter Vxn3 = 0.4791
alter Vxp4 = 0.6215
alter Vxn4 = 0.3785
alter Vxp5 = 0.4085
alter Vxn5 = 0.5915
alter Vxp6 = 0.3348
alter Vxn6 = 0.6652
alter Vxp7 = 0.6857
alter Vxn7 = 0.3143
alter Vxp8 = 0.6694
alter Vxn8 = 0.3306
alter Vxp9 = 0.3889
alter Vxn9 = 0.6111
alter Vxp10 = 0.3771
alter Vxn10 = 0.6229
alter Vxp11 = 0.5089
alter Vxn11 = 0.4911
alter Vxp12 = 0.5004
alter Vxn12 = 0.4996
alter Vxp13 = 0.5254
alter Vxn13 = 0.4746
alter Vxp14 = 0.5085
alter Vxn14 = 0.4915
alter Vxp15 = 0.4339
alter Vxn15 = 0.5661
op
wrdata pcMevc3_12.dat v(mop0) v(mon0) v(mop1) v(mon1) v(mop2) v(mon2)
alter Vxp0 = 0.5184
alter Vxn0 = 0.4816
alter Vxp1 = 0.5696
alter Vxn1 = 0.4304
alter Vxp2 = 0.4994
alter Vxn2 = 0.5006
alter Vxp3 = 0.4537
alter Vxn3 = 0.5463
alter Vxp4 = 0.6917
alter Vxn4 = 0.3083
alter Vxp5 = 0.4350
alter Vxn5 = 0.5650
alter Vxp6 = 0.4615
alter Vxn6 = 0.5385
alter Vxp7 = 0.5445
alter Vxn7 = 0.4555
alter Vxp8 = 0.6525
alter Vxn8 = 0.3475
alter Vxp9 = 0.4742
alter Vxn9 = 0.5258
alter Vxp10 = 0.3626
alter Vxn10 = 0.6374
alter Vxp11 = 0.6403
alter Vxn11 = 0.3597
alter Vxp12 = 0.5438
alter Vxn12 = 0.4562
alter Vxp13 = 0.6174
alter Vxn13 = 0.3826
alter Vxp14 = 0.5901
alter Vxn14 = 0.4099
alter Vxp15 = 0.4962
alter Vxn15 = 0.5038
op
wrdata pcMevc3_13.dat v(mop0) v(mon0) v(mop1) v(mon1) v(mop2) v(mon2)
alter Vxp0 = 0.4393
alter Vxn0 = 0.5607
alter Vxp1 = 0.4076
alter Vxn1 = 0.5924
alter Vxp2 = 0.4369
alter Vxn2 = 0.5631
alter Vxp3 = 0.4537
alter Vxn3 = 0.5463
alter Vxp4 = 0.4110
alter Vxn4 = 0.5890
alter Vxp5 = 0.5941
alter Vxn5 = 0.4059
alter Vxp6 = 0.4856
alter Vxn6 = 0.5144
alter Vxp7 = 0.4348
alter Vxn7 = 0.5652
alter Vxp8 = 0.4339
alter Vxn8 = 0.5661
alter Vxp9 = 0.5914
alter Vxn9 = 0.4086
alter Vxp10 = 0.5801
alter Vxn10 = 0.4199
alter Vxp11 = 0.4066
alter Vxn11 = 0.5934
alter Vxp12 = 0.4570
alter Vxn12 = 0.5430
alter Vxp13 = 0.5024
alter Vxn13 = 0.4976
alter Vxp14 = 0.4609
alter Vxn14 = 0.5391
alter Vxp15 = 0.4339
alter Vxn15 = 0.5661
op
wrdata pcMevc3_14.dat v(mop0) v(mon0) v(mop1) v(mon1) v(mop2) v(mon2)
alter Vxp0 = 0.4393
alter Vxn0 = 0.5607
alter Vxp1 = 0.5453
alter Vxn1 = 0.4547
alter Vxp2 = 0.5272
alter Vxn2 = 0.4728
alter Vxp3 = 0.4671
alter Vxn3 = 0.5329
alter Vxp4 = 0.5689
alter Vxn4 = 0.4311
alter Vxp5 = 0.4416
alter Vxn5 = 0.5584
alter Vxp6 = 0.4253
alter Vxn6 = 0.5747
alter Vxp7 = 0.6229
alter Vxn7 = 0.3771
alter Vxp8 = 0.6189
alter Vxn8 = 0.3811
alter Vxp9 = 0.4422
alter Vxn9 = 0.5578
alter Vxp10 = 0.3481
alter Vxn10 = 0.6519
alter Vxp11 = 0.6111
alter Vxn11 = 0.3889
alter Vxp12 = 0.4570
alter Vxn12 = 0.5430
alter Vxp13 = 0.5407
alter Vxn13 = 0.4593
alter Vxp14 = 0.5697
alter Vxn14 = 0.4303
alter Vxp15 = 0.4546
alter Vxn15 = 0.5454
op
wrdata pcMevc3_15.dat v(mop0) v(mon0) v(mop1) v(mon1) v(mop2) v(mon2)
alter Vxp0 = 0.4393
alter Vxn0 = 0.5607
alter Vxp1 = 0.6020
alter Vxn1 = 0.3980
alter Vxp2 = 0.5480
alter Vxn2 = 0.4520
alter Vxp3 = 0.4537
alter Vxn3 = 0.5463
alter Vxp4 = 0.4987
alter Vxn4 = 0.5013
alter Vxp5 = 0.5344
alter Vxn5 = 0.4656
alter Vxp6 = 0.4012
alter Vxn6 = 0.5988
alter Vxp7 = 0.5759
alter Vxn7 = 0.4241
alter Vxp8 = 0.5348
alter Vxn8 = 0.4652
alter Vxp9 = 0.4529
alter Vxn9 = 0.5471
alter Vxp10 = 0.3989
alter Vxn10 = 0.6011
alter Vxp11 = 0.5089
alter Vxn11 = 0.4911
alter Vxp12 = 0.5004
alter Vxn12 = 0.4996
alter Vxp13 = 0.5560
alter Vxn13 = 0.4440
alter Vxp14 = 0.5085
alter Vxn14 = 0.4915
alter Vxp15 = 0.4339
alter Vxn15 = 0.5661
op
wrdata pcMevc3_16.dat v(mop0) v(mon0) v(mop1) v(mon1) v(mop2) v(mon2)
alter Vxp0 = 0.4393
alter Vxn0 = 0.5607
alter Vxp1 = 0.5129
alter Vxn1 = 0.4871
alter Vxp2 = 0.5411
alter Vxn2 = 0.4589
alter Vxp3 = 0.4537
alter Vxn3 = 0.5463
alter Vxp4 = 0.4110
alter Vxn4 = 0.5890
alter Vxp5 = 0.6007
alter Vxn5 = 0.3993
alter Vxp6 = 0.4675
alter Vxn6 = 0.5325
alter Vxp7 = 0.6543
alter Vxn7 = 0.3457
alter Vxp8 = 0.5180
alter Vxn8 = 0.4820
alter Vxp9 = 0.5807
alter Vxn9 = 0.4193
alter Vxp10 = 0.4641
alter Vxn10 = 0.5359
alter Vxp11 = 0.6257
alter Vxn11 = 0.3743
alter Vxp12 = 0.5004
alter Vxn12 = 0.4996
alter Vxp13 = 0.5714
alter Vxn13 = 0.4286
alter Vxp14 = 0.5833
alter Vxn14 = 0.4167
alter Vxp15 = 0.4339
alter Vxn15 = 0.5661
op
wrdata pcMevc3_17.dat v(mop0) v(mon0) v(mop1) v(mon1) v(mop2) v(mon2)
alter Vxp0 = 0.4920
alter Vxn0 = 0.5080
alter Vxp1 = 0.5291
alter Vxn1 = 0.4709
alter Vxp2 = 0.5480
alter Vxn2 = 0.4520
alter Vxp3 = 0.5074
alter Vxn3 = 0.4926
alter Vxp4 = 0.6917
alter Vxn4 = 0.3083
alter Vxp5 = 0.3820
alter Vxn5 = 0.6180
alter Vxp6 = 0.5098
alter Vxn6 = 0.4902
alter Vxp7 = 0.6229
alter Vxn7 = 0.3771
alter Vxp8 = 0.6021
alter Vxn8 = 0.3979
alter Vxp9 = 0.4475
alter Vxn9 = 0.5525
alter Vxp10 = 0.4568
alter Vxn10 = 0.5432
alter Vxp11 = 0.5089
alter Vxn11 = 0.4911
alter Vxp12 = 0.4570
alter Vxn12 = 0.5430
alter Vxp13 = 0.5330
alter Vxn13 = 0.4670
alter Vxp14 = 0.4881
alter Vxn14 = 0.5119
alter Vxp15 = 0.4339
alter Vxn15 = 0.5661
op
wrdata pcMevc3_18.dat v(mop0) v(mon0) v(mop1) v(mon1) v(mop2) v(mon2)
alter Vxp0 = 0.4393
alter Vxn0 = 0.5607
alter Vxp1 = 0.5453
alter Vxn1 = 0.4547
alter Vxp2 = 0.5689
alter Vxn2 = 0.4311
alter Vxp3 = 0.4537
alter Vxn3 = 0.5463
alter Vxp4 = 0.5338
alter Vxn4 = 0.4662
alter Vxp5 = 0.3820
alter Vxn5 = 0.6180
alter Vxp6 = 0.3831
alter Vxn6 = 0.6169
alter Vxp7 = 0.6073
alter Vxn7 = 0.3927
alter Vxp8 = 0.5684
alter Vxn8 = 0.4316
alter Vxp9 = 0.4369
alter Vxn9 = 0.5631
alter Vxp10 = 0.4134
alter Vxn10 = 0.5866
alter Vxp11 = 0.4651
alter Vxn11 = 0.5349
alter Vxp12 = 0.4570
alter Vxn12 = 0.5430
alter Vxp13 = 0.5867
alter Vxn13 = 0.4133
alter Vxp14 = 0.4813
alter Vxn14 = 0.5187
alter Vxp15 = 0.4339
alter Vxn15 = 0.5661
op
wrdata pcMevc3_19.dat v(mop0) v(mon0) v(mop1) v(mon1) v(mop2) v(mon2)
alter Vxp0 = 0.4393
alter Vxn0 = 0.5607
alter Vxp1 = 0.2000
alter Vxn1 = 0.8000
alter Vxp2 = 0.6591
alter Vxn2 = 0.3409
alter Vxp3 = 0.5074
alter Vxn3 = 0.4926
alter Vxp4 = 0.5689
alter Vxn4 = 0.4311
alter Vxp5 = 0.6471
alter Vxn5 = 0.3529
alter Vxp6 = 0.6847
alter Vxn6 = 0.3153
alter Vxp7 = 0.4348
alter Vxn7 = 0.5652
alter Vxp8 = 0.4339
alter Vxn8 = 0.5661
alter Vxp9 = 0.4315
alter Vxn9 = 0.5685
alter Vxp10 = 0.5511
alter Vxn10 = 0.4489
alter Vxp11 = 0.4066
alter Vxn11 = 0.5934
alter Vxp12 = 0.4570
alter Vxn12 = 0.5430
alter Vxp13 = 0.3106
alter Vxn13 = 0.6894
alter Vxp14 = 0.5901
alter Vxn14 = 0.4099
alter Vxp15 = 0.4546
alter Vxn15 = 0.5454
op
wrdata pcMevc3_20.dat v(mop0) v(mon0) v(mop1) v(mon1) v(mop2) v(mon2)
alter Vxp0 = 0.4393
alter Vxn0 = 0.5607
alter Vxp1 = 0.4562
alter Vxn1 = 0.5438
alter Vxp2 = 0.5689
alter Vxn2 = 0.4311
alter Vxp3 = 0.4537
alter Vxn3 = 0.5463
alter Vxp4 = 0.4110
alter Vxn4 = 0.5890
alter Vxp5 = 0.5278
alter Vxn5 = 0.4722
alter Vxp6 = 0.6002
alter Vxn6 = 0.3998
alter Vxp7 = 0.4348
alter Vxn7 = 0.5652
alter Vxp8 = 0.5011
alter Vxn8 = 0.4989
alter Vxp9 = 0.6660
alter Vxn9 = 0.3340
alter Vxp10 = 0.4206
alter Vxn10 = 0.5794
alter Vxp11 = 0.4066
alter Vxn11 = 0.5934
alter Vxp12 = 0.5871
alter Vxn12 = 0.4129
alter Vxp13 = 0.6251
alter Vxn13 = 0.3749
alter Vxp14 = 0.4065
alter Vxn14 = 0.5935
alter Vxp15 = 0.4339
alter Vxn15 = 0.5661
op
wrdata pcMevc3_21.dat v(mop0) v(mon0) v(mop1) v(mon1) v(mop2) v(mon2)
alter Vxp0 = 0.4393
alter Vxn0 = 0.5607
alter Vxp1 = 0.2618
alter Vxn1 = 0.7382
alter Vxp2 = 0.6452
alter Vxn2 = 0.3548
alter Vxp3 = 0.5881
alter Vxn3 = 0.4119
alter Vxp4 = 0.4987
alter Vxn4 = 0.5013
alter Vxp5 = 0.6537
alter Vxn5 = 0.3463
alter Vxp6 = 0.6907
alter Vxn6 = 0.3093
alter Vxp7 = 0.4505
alter Vxn7 = 0.5495
alter Vxp8 = 0.4507
alter Vxn8 = 0.5493
alter Vxp9 = 0.4475
alter Vxn9 = 0.5525
alter Vxp10 = 0.7105
alter Vxn10 = 0.2895
alter Vxp11 = 0.4066
alter Vxn11 = 0.5934
alter Vxp12 = 0.4570
alter Vxn12 = 0.5430
alter Vxp13 = 0.2339
alter Vxn13 = 0.7661
alter Vxp14 = 0.5765
alter Vxn14 = 0.4235
alter Vxp15 = 0.4339
alter Vxn15 = 0.5661
op
wrdata pcMevc3_22.dat v(mop0) v(mon0) v(mop1) v(mon1) v(mop2) v(mon2)
alter Vxp0 = 0.4393
alter Vxn0 = 0.5607
alter Vxp1 = 0.5129
alter Vxn1 = 0.4871
alter Vxp2 = 0.5619
alter Vxn2 = 0.4381
alter Vxp3 = 0.4537
alter Vxn3 = 0.5463
alter Vxp4 = 0.4110
alter Vxn4 = 0.5890
alter Vxp5 = 0.6670
alter Vxn5 = 0.3330
alter Vxp6 = 0.5942
alter Vxn6 = 0.4058
alter Vxp7 = 0.4348
alter Vxn7 = 0.5652
alter Vxp8 = 0.4339
alter Vxn8 = 0.5661
alter Vxp9 = 0.6180
alter Vxn9 = 0.3820
alter Vxp10 = 0.5728
alter Vxn10 = 0.4272
alter Vxp11 = 0.4066
alter Vxn11 = 0.5934
alter Vxp12 = 0.4570
alter Vxn12 = 0.5430
alter Vxp13 = 0.6097
alter Vxn13 = 0.3903
alter Vxp14 = 0.6718
alter Vxn14 = 0.3282
alter Vxp15 = 0.4962
alter Vxn15 = 0.5038
op
wrdata pcMevc3_23.dat v(mop0) v(mon0) v(mop1) v(mon1) v(mop2) v(mon2)
alter Vxp0 = 0.4393
alter Vxn0 = 0.5607
alter Vxp1 = 0.6020
alter Vxn1 = 0.3980
alter Vxp2 = 0.2494
alter Vxn2 = 0.7506
alter Vxp3 = 0.4537
alter Vxn3 = 0.5463
alter Vxp4 = 0.6566
alter Vxn4 = 0.3434
alter Vxp5 = 0.6537
alter Vxn5 = 0.3463
alter Vxp6 = 0.3469
alter Vxn6 = 0.6531
alter Vxp7 = 0.4348
alter Vxn7 = 0.5652
alter Vxp8 = 0.4339
alter Vxn8 = 0.5661
alter Vxp9 = 0.4635
alter Vxn9 = 0.5365
alter Vxp10 = 0.4206
alter Vxn10 = 0.5794
alter Vxp11 = 0.4066
alter Vxn11 = 0.5934
alter Vxp12 = 0.4570
alter Vxn12 = 0.5430
alter Vxp13 = 0.6251
alter Vxn13 = 0.3749
alter Vxp14 = 0.6514
alter Vxn14 = 0.3486
alter Vxp15 = 0.7560
alter Vxn15 = 0.2440
op
wrdata pcMevc3_24.dat v(mop0) v(mon0) v(mop1) v(mon1) v(mop2) v(mon2)
alter Vxp0 = 0.4393
alter Vxn0 = 0.5607
alter Vxp1 = 0.2052
alter Vxn1 = 0.7948
alter Vxp2 = 0.5619
alter Vxn2 = 0.4381
alter Vxp3 = 0.4537
alter Vxn3 = 0.5463
alter Vxp4 = 0.4110
alter Vxn4 = 0.5890
alter Vxp5 = 0.4217
alter Vxn5 = 0.5783
alter Vxp6 = 0.5942
alter Vxn6 = 0.4058
alter Vxp7 = 0.4348
alter Vxn7 = 0.5652
alter Vxp8 = 0.4507
alter Vxn8 = 0.5493
alter Vxp9 = 0.6180
alter Vxn9 = 0.3820
alter Vxp10 = 0.5438
alter Vxn10 = 0.4562
alter Vxp11 = 0.4066
alter Vxn11 = 0.5934
alter Vxp12 = 0.4570
alter Vxn12 = 0.5430
alter Vxp13 = 0.2646
alter Vxn13 = 0.7354
alter Vxp14 = 0.5833
alter Vxn14 = 0.4167
alter Vxp15 = 0.4339
alter Vxn15 = 0.5661
op
wrdata pcMevc3_25.dat v(mop0) v(mon0) v(mop1) v(mon1) v(mop2) v(mon2)
alter Vxp0 = 0.4393
alter Vxn0 = 0.5607
alter Vxp1 = 0.5453
alter Vxn1 = 0.4547
alter Vxp2 = 0.5689
alter Vxn2 = 0.4311
alter Vxp3 = 0.4671
alter Vxn3 = 0.5329
alter Vxp4 = 0.4110
alter Vxn4 = 0.5890
alter Vxp5 = 0.5874
alter Vxn5 = 0.4126
alter Vxp6 = 0.6304
alter Vxn6 = 0.3696
alter Vxp7 = 0.4348
alter Vxn7 = 0.5652
alter Vxp8 = 0.5180
alter Vxn8 = 0.4820
alter Vxp9 = 0.6766
alter Vxn9 = 0.3234
alter Vxp10 = 0.5221
alter Vxn10 = 0.4779
alter Vxp11 = 0.4066
alter Vxn11 = 0.5934
alter Vxp12 = 0.5871
alter Vxn12 = 0.4129
alter Vxp13 = 0.6711
alter Vxn13 = 0.3289
alter Vxp14 = 0.4949
alter Vxn14 = 0.5051
alter Vxp15 = 0.4339
alter Vxn15 = 0.5661
op
wrdata pcMevc3_26.dat v(mop0) v(mon0) v(mop1) v(mon1) v(mop2) v(mon2)
alter Vxp0 = 0.4393
alter Vxn0 = 0.5607
alter Vxp1 = 0.5777
alter Vxn1 = 0.4223
alter Vxp2 = 0.4994
alter Vxn2 = 0.5006
alter Vxp3 = 0.4537
alter Vxn3 = 0.5463
alter Vxp4 = 0.4110
alter Vxn4 = 0.5890
alter Vxp5 = 0.6471
alter Vxn5 = 0.3529
alter Vxp6 = 0.6726
alter Vxn6 = 0.3274
alter Vxp7 = 0.4818
alter Vxn7 = 0.5182
alter Vxp8 = 0.4675
alter Vxn8 = 0.5325
alter Vxp9 = 0.6660
alter Vxn9 = 0.3340
alter Vxp10 = 0.4931
alter Vxn10 = 0.5069
alter Vxp11 = 0.4066
alter Vxn11 = 0.5934
alter Vxp12 = 0.4570
alter Vxn12 = 0.5430
alter Vxp13 = 0.6481
alter Vxn13 = 0.3519
alter Vxp14 = 0.4405
alter Vxn14 = 0.5595
alter Vxp15 = 0.4339
alter Vxn15 = 0.5661
op
wrdata pcMevc3_27.dat v(mop0) v(mon0) v(mop1) v(mon1) v(mop2) v(mon2)
alter Vxp0 = 0.4393
alter Vxn0 = 0.5607
alter Vxp1 = 0.2861
alter Vxn1 = 0.7139
alter Vxp2 = 0.6661
alter Vxn2 = 0.3339
alter Vxp3 = 0.6150
alter Vxn3 = 0.3850
alter Vxp4 = 0.4811
alter Vxn4 = 0.5189
alter Vxp5 = 0.6073
alter Vxn5 = 0.3927
alter Vxp6 = 0.6605
alter Vxn6 = 0.3395
alter Vxp7 = 0.4818
alter Vxn7 = 0.5182
alter Vxp8 = 0.5180
alter Vxn8 = 0.4820
alter Vxp9 = 0.5701
alter Vxn9 = 0.4299
alter Vxp10 = 0.6598
alter Vxn10 = 0.3402
alter Vxp11 = 0.4212
alter Vxn11 = 0.5788
alter Vxp12 = 0.4570
alter Vxn12 = 0.5430
alter Vxp13 = 0.3260
alter Vxn13 = 0.6740
alter Vxp14 = 0.6650
alter Vxn14 = 0.3350
alter Vxp15 = 0.5690
alter Vxn15 = 0.4310
op
wrdata pcMevc3_28.dat v(mop0) v(mon0) v(mop1) v(mon1) v(mop2) v(mon2)
alter Vxp0 = 0.4393
alter Vxn0 = 0.5607
alter Vxp1 = 0.5372
alter Vxn1 = 0.4628
alter Vxp2 = 0.4577
alter Vxn2 = 0.5423
alter Vxp3 = 0.4537
alter Vxn3 = 0.5463
alter Vxp4 = 0.4110
alter Vxn4 = 0.5890
alter Vxp5 = 0.6338
alter Vxn5 = 0.3662
alter Vxp6 = 0.4736
alter Vxn6 = 0.5264
alter Vxp7 = 0.4348
alter Vxn7 = 0.5652
alter Vxp8 = 0.4339
alter Vxn8 = 0.5661
alter Vxp9 = 0.6074
alter Vxn9 = 0.3926
alter Vxp10 = 0.4351
alter Vxn10 = 0.5649
alter Vxp11 = 0.4066
alter Vxn11 = 0.5934
alter Vxp12 = 0.4570
alter Vxn12 = 0.5430
alter Vxp13 = 0.5484
alter Vxn13 = 0.4516
alter Vxp14 = 0.4269
alter Vxn14 = 0.5731
alter Vxp15 = 0.4339
alter Vxn15 = 0.5661
op
wrdata pcMevc3_29.dat v(mop0) v(mon0) v(mop1) v(mon1) v(mop2) v(mon2)
alter Vxp0 = 0.4393
alter Vxn0 = 0.5607
alter Vxp1 = 0.4400
alter Vxn1 = 0.5600
alter Vxp2 = 0.5272
alter Vxn2 = 0.4728
alter Vxp3 = 0.4537
alter Vxn3 = 0.5463
alter Vxp4 = 0.7794
alter Vxn4 = 0.2206
alter Vxp5 = 0.6471
alter Vxn5 = 0.3529
alter Vxp6 = 0.4736
alter Vxn6 = 0.5264
alter Vxp7 = 0.4348
alter Vxn7 = 0.5652
alter Vxp8 = 0.4339
alter Vxn8 = 0.5661
alter Vxp9 = 0.5328
alter Vxn9 = 0.4672
alter Vxp10 = 0.3554
alter Vxn10 = 0.6446
alter Vxp11 = 0.4066
alter Vxn11 = 0.5934
alter Vxp12 = 0.4570
alter Vxn12 = 0.5430
alter Vxp13 = 0.4333
alter Vxn13 = 0.5667
alter Vxp14 = 0.4201
alter Vxn14 = 0.5799
alter Vxp15 = 0.4339
alter Vxn15 = 0.5661
op
wrdata pcMevc3_30.dat v(mop0) v(mon0) v(mop1) v(mon1) v(mop2) v(mon2)
alter Vxp0 = 0.4393
alter Vxn0 = 0.5607
alter Vxp1 = 0.2000
alter Vxn1 = 0.8000
alter Vxp2 = 0.6591
alter Vxn2 = 0.3409
alter Vxp3 = 0.5074
alter Vxn3 = 0.4926
alter Vxp4 = 0.4110
alter Vxn4 = 0.5890
alter Vxp5 = 0.4946
alter Vxn5 = 0.5054
alter Vxp6 = 0.6907
alter Vxn6 = 0.3093
alter Vxp7 = 0.4505
alter Vxn7 = 0.5495
alter Vxp8 = 0.5516
alter Vxn8 = 0.4484
alter Vxp9 = 0.5381
alter Vxn9 = 0.4619
alter Vxp10 = 0.6743
alter Vxn10 = 0.3257
alter Vxp11 = 0.4066
alter Vxn11 = 0.5934
alter Vxp12 = 0.4570
alter Vxn12 = 0.5430
alter Vxp13 = 0.2799
alter Vxn13 = 0.7201
alter Vxp14 = 0.6241
alter Vxn14 = 0.3759
alter Vxp15 = 0.4339
alter Vxn15 = 0.5661
op
wrdata pcMevc3_31.dat v(mop0) v(mon0) v(mop1) v(mon1) v(mop2) v(mon2)
alter Vxp0 = 0.4393
alter Vxn0 = 0.5607
alter Vxp1 = 0.2942
alter Vxn1 = 0.7058
alter Vxp2 = 0.5897
alter Vxn2 = 0.4103
alter Vxp3 = 0.4537
alter Vxn3 = 0.5463
alter Vxp4 = 0.6917
alter Vxn4 = 0.3083
alter Vxp5 = 0.6206
alter Vxn5 = 0.3794
alter Vxp6 = 0.5942
alter Vxn6 = 0.4058
alter Vxp7 = 0.4348
alter Vxn7 = 0.5652
alter Vxp8 = 0.4507
alter Vxn8 = 0.5493
alter Vxp9 = 0.3569
alter Vxn9 = 0.6431
alter Vxp10 = 0.5656
alter Vxn10 = 0.4344
alter Vxp11 = 0.4066
alter Vxn11 = 0.5934
alter Vxp12 = 0.4570
alter Vxn12 = 0.5430
alter Vxp13 = 0.2569
alter Vxn13 = 0.7431
alter Vxp14 = 0.5697
alter Vxn14 = 0.4303
alter Vxp15 = 0.4339
alter Vxn15 = 0.5661
op
wrdata pcMevc3_32.dat v(mop0) v(mon0) v(mop1) v(mon1) v(mop2) v(mon2)
alter Vxp0 = 0.4393
alter Vxn0 = 0.5607
alter Vxp1 = 0.4805
alter Vxn1 = 0.5195
alter Vxp2 = 0.4161
alter Vxn2 = 0.5839
alter Vxp3 = 0.4537
alter Vxn3 = 0.5463
alter Vxp4 = 0.4110
alter Vxn4 = 0.5890
alter Vxp5 = 0.5675
alter Vxn5 = 0.4325
alter Vxp6 = 0.4856
alter Vxn6 = 0.5144
alter Vxp7 = 0.4348
alter Vxn7 = 0.5652
alter Vxp8 = 0.4339
alter Vxn8 = 0.5661
alter Vxp9 = 0.5594
alter Vxn9 = 0.4406
alter Vxp10 = 0.4786
alter Vxn10 = 0.5214
alter Vxp11 = 0.4066
alter Vxn11 = 0.5934
alter Vxp12 = 0.4570
alter Vxn12 = 0.5430
alter Vxp13 = 0.5100
alter Vxn13 = 0.4900
alter Vxp14 = 0.5629
alter Vxn14 = 0.4371
alter Vxp15 = 0.4339
alter Vxn15 = 0.5661
op
wrdata pcMevc3_33.dat v(mop0) v(mon0) v(mop1) v(mon1) v(mop2) v(mon2)
alter Vxp0 = 0.4393
alter Vxn0 = 0.5607
alter Vxp1 = 0.3509
alter Vxn1 = 0.6491
alter Vxp2 = 0.6522
alter Vxn2 = 0.3478
alter Vxp3 = 0.4671
alter Vxn3 = 0.5329
alter Vxp4 = 0.5864
alter Vxn4 = 0.4136
alter Vxp5 = 0.6603
alter Vxn5 = 0.3397
alter Vxp6 = 0.6063
alter Vxn6 = 0.3937
alter Vxp7 = 0.4348
alter Vxn7 = 0.5652
alter Vxp8 = 0.4843
alter Vxn8 = 0.5157
alter Vxp9 = 0.4369
alter Vxn9 = 0.5631
alter Vxp10 = 0.5221
alter Vxn10 = 0.4779
alter Vxp11 = 0.4066
alter Vxn11 = 0.5934
alter Vxp12 = 0.4570
alter Vxn12 = 0.5430
alter Vxp13 = 0.3336
alter Vxn13 = 0.6664
alter Vxp14 = 0.5697
alter Vxn14 = 0.4303
alter Vxp15 = 0.4443
alter Vxn15 = 0.5557
op
wrdata pcMevc3_34.dat v(mop0) v(mon0) v(mop1) v(mon1) v(mop2) v(mon2)
alter Vxp0 = 0.4393
alter Vxn0 = 0.5607
alter Vxp1 = 0.4886
alter Vxn1 = 0.5114
alter Vxp2 = 0.5689
alter Vxn2 = 0.4311
alter Vxp3 = 0.4940
alter Vxn3 = 0.5060
alter Vxp4 = 0.4110
alter Vxn4 = 0.5890
alter Vxp5 = 0.5013
alter Vxn5 = 0.4987
alter Vxp6 = 0.6726
alter Vxn6 = 0.3274
alter Vxp7 = 0.4348
alter Vxn7 = 0.5652
alter Vxp8 = 0.4339
alter Vxn8 = 0.5661
alter Vxp9 = 0.5701
alter Vxn9 = 0.4299
alter Vxp10 = 0.6236
alter Vxn10 = 0.3764
alter Vxp11 = 0.4066
alter Vxn11 = 0.5934
alter Vxp12 = 0.4570
alter Vxn12 = 0.5430
alter Vxp13 = 0.5867
alter Vxn13 = 0.4133
alter Vxp14 = 0.5153
alter Vxn14 = 0.4847
alter Vxp15 = 0.4339
alter Vxn15 = 0.5661
op
wrdata pcMevc3_35.dat v(mop0) v(mon0) v(mop1) v(mon1) v(mop2) v(mon2)
alter Vxp0 = 0.4393
alter Vxn0 = 0.5607
alter Vxp1 = 0.2456
alter Vxn1 = 0.7544
alter Vxp2 = 0.6383
alter Vxn2 = 0.3617
alter Vxp3 = 0.4940
alter Vxn3 = 0.5060
alter Vxp4 = 0.4811
alter Vxn4 = 0.5189
alter Vxp5 = 0.6537
alter Vxn5 = 0.3463
alter Vxp6 = 0.6485
alter Vxn6 = 0.3515
alter Vxp7 = 0.4348
alter Vxn7 = 0.5652
alter Vxp8 = 0.5011
alter Vxn8 = 0.4989
alter Vxp9 = 0.3996
alter Vxn9 = 0.6004
alter Vxp10 = 0.5801
alter Vxn10 = 0.4199
alter Vxp11 = 0.4066
alter Vxn11 = 0.5934
alter Vxp12 = 0.4570
alter Vxn12 = 0.5430
alter Vxp13 = 0.2416
alter Vxn13 = 0.7584
alter Vxp14 = 0.5765
alter Vxn14 = 0.4235
alter Vxp15 = 0.4339
alter Vxn15 = 0.5661
op
wrdata pcMevc3_36.dat v(mop0) v(mon0) v(mop1) v(mon1) v(mop2) v(mon2)
alter Vxp0 = 0.4393
alter Vxn0 = 0.5607
alter Vxp1 = 0.4400
alter Vxn1 = 0.5600
alter Vxp2 = 0.5341
alter Vxn2 = 0.4659
alter Vxp3 = 0.4537
alter Vxn3 = 0.5463
alter Vxp4 = 0.4110
alter Vxn4 = 0.5890
alter Vxp5 = 0.6007
alter Vxn5 = 0.3993
alter Vxp6 = 0.6002
alter Vxn6 = 0.3998
alter Vxp7 = 0.4348
alter Vxn7 = 0.5652
alter Vxp8 = 0.4339
alter Vxn8 = 0.5661
alter Vxp9 = 0.6180
alter Vxn9 = 0.3820
alter Vxp10 = 0.4858
alter Vxn10 = 0.5142
alter Vxp11 = 0.4066
alter Vxn11 = 0.5934
alter Vxp12 = 0.4570
alter Vxn12 = 0.5430
alter Vxp13 = 0.5254
alter Vxn13 = 0.4746
alter Vxp14 = 0.5085
alter Vxn14 = 0.4915
alter Vxp15 = 0.4339
alter Vxn15 = 0.5661
op
wrdata pcMevc3_37.dat v(mop0) v(mon0) v(mop1) v(mon1) v(mop2) v(mon2)
alter Vxp0 = 0.4393
alter Vxn0 = 0.5607
alter Vxp1 = 0.4238
alter Vxn1 = 0.5762
alter Vxp2 = 0.4925
alter Vxn2 = 0.5075
alter Vxp3 = 0.4537
alter Vxn3 = 0.5463
alter Vxp4 = 0.4110
alter Vxn4 = 0.5890
alter Vxp5 = 0.4085
alter Vxn5 = 0.5915
alter Vxp6 = 0.5399
alter Vxn6 = 0.4601
alter Vxp7 = 0.4348
alter Vxn7 = 0.5652
alter Vxp8 = 0.4339
alter Vxn8 = 0.5661
alter Vxp9 = 0.4955
alter Vxn9 = 0.5045
alter Vxp10 = 0.5511
alter Vxn10 = 0.4489
alter Vxp11 = 0.4066
alter Vxn11 = 0.5934
alter Vxp12 = 0.4570
alter Vxn12 = 0.5430
alter Vxp13 = 0.4180
alter Vxn13 = 0.5820
alter Vxp14 = 0.6241
alter Vxn14 = 0.3759
alter Vxp15 = 0.4443
alter Vxn15 = 0.5557
op
wrdata pcMevc3_38.dat v(mop0) v(mon0) v(mop1) v(mon1) v(mop2) v(mon2)
alter Vxp0 = 0.4393
alter Vxn0 = 0.5607
alter Vxp1 = 0.5210
alter Vxn1 = 0.4790
alter Vxp2 = 0.2494
alter Vxn2 = 0.7506
alter Vxp3 = 0.4537
alter Vxn3 = 0.5463
alter Vxp4 = 0.4110
alter Vxn4 = 0.5890
alter Vxp5 = 0.5808
alter Vxn5 = 0.4192
alter Vxp6 = 0.3891
alter Vxn6 = 0.6109
alter Vxp7 = 0.4348
alter Vxn7 = 0.5652
alter Vxp8 = 0.4339
alter Vxn8 = 0.5661
alter Vxp9 = 0.3783
alter Vxn9 = 0.6217
alter Vxp10 = 0.5003
alter Vxn10 = 0.4997
alter Vxp11 = 0.4066
alter Vxn11 = 0.5934
alter Vxp12 = 0.4570
alter Vxn12 = 0.5430
alter Vxp13 = 0.4487
alter Vxn13 = 0.5513
alter Vxp14 = 0.6446
alter Vxn14 = 0.3554
alter Vxp15 = 0.7041
alter Vxn15 = 0.2959
op
wrdata pcMevc3_39.dat v(mop0) v(mon0) v(mop1) v(mon1) v(mop2) v(mon2)
alter Vxp0 = 0.8000
alter Vxn0 = 0.2000
alter Vxp1 = 0.6182
alter Vxn1 = 0.3818
alter Vxp2 = 0.4300
alter Vxn2 = 0.5700
alter Vxp3 = 0.4537
alter Vxn3 = 0.5463
alter Vxp4 = 0.4987
alter Vxn4 = 0.5013
alter Vxp5 = 0.3223
alter Vxn5 = 0.6777
alter Vxp6 = 0.5218
alter Vxn6 = 0.4782
alter Vxp7 = 0.4348
alter Vxn7 = 0.5652
alter Vxp8 = 0.4339
alter Vxn8 = 0.5661
alter Vxp9 = 0.4742
alter Vxn9 = 0.5258
alter Vxp10 = 0.3916
alter Vxn10 = 0.6084
alter Vxp11 = 0.4358
alter Vxn11 = 0.5642
alter Vxp12 = 0.5438
alter Vxn12 = 0.4562
alter Vxp13 = 0.6634
alter Vxn13 = 0.3366
alter Vxp14 = 0.6377
alter Vxn14 = 0.3623
alter Vxp15 = 0.6833
alter Vxn15 = 0.3167
op
wrdata pcMevc3_40.dat v(mop0) v(mon0) v(mop1) v(mon1) v(mop2) v(mon2)
alter Vxp0 = 0.6501
alter Vxn0 = 0.3499
alter Vxp1 = 0.5291
alter Vxn1 = 0.4709
alter Vxp2 = 0.5480
alter Vxn2 = 0.4520
alter Vxp3 = 0.4537
alter Vxn3 = 0.5463
alter Vxp4 = 0.4110
alter Vxn4 = 0.5890
alter Vxp5 = 0.2826
alter Vxn5 = 0.7174
alter Vxp6 = 0.5158
alter Vxn6 = 0.4842
alter Vxp7 = 0.4348
alter Vxn7 = 0.5652
alter Vxp8 = 0.4339
alter Vxn8 = 0.5661
alter Vxp9 = 0.4955
alter Vxn9 = 0.5045
alter Vxp10 = 0.3046
alter Vxn10 = 0.6954
alter Vxp11 = 0.4066
alter Vxn11 = 0.5934
alter Vxp12 = 0.5004
alter Vxn12 = 0.4996
alter Vxp13 = 0.6174
alter Vxn13 = 0.3826
alter Vxp14 = 0.5017
alter Vxn14 = 0.4983
alter Vxp15 = 0.4962
alter Vxn15 = 0.5038
op
wrdata pcMevc3_41.dat v(mop0) v(mon0) v(mop1) v(mon1) v(mop2) v(mon2)
alter Vxp0 = 0.4393
alter Vxn0 = 0.5607
alter Vxp1 = 0.4643
alter Vxn1 = 0.5357
alter Vxp2 = 0.5966
alter Vxn2 = 0.4034
alter Vxp3 = 0.4537
alter Vxn3 = 0.5463
alter Vxp4 = 0.4110
alter Vxn4 = 0.5890
alter Vxp5 = 0.3621
alter Vxn5 = 0.6379
alter Vxp6 = 0.5459
alter Vxn6 = 0.4541
alter Vxp7 = 0.4505
alter Vxn7 = 0.5495
alter Vxp8 = 0.4675
alter Vxn8 = 0.5325
alter Vxp9 = 0.5328
alter Vxn9 = 0.4672
alter Vxp10 = 0.3409
alter Vxn10 = 0.6591
alter Vxp11 = 0.4066
alter Vxn11 = 0.5934
alter Vxp12 = 0.6305
alter Vxn12 = 0.3695
alter Vxp13 = 0.5484
alter Vxn13 = 0.4516
alter Vxp14 = 0.5221
alter Vxn14 = 0.4779
alter Vxp15 = 0.4858
alter Vxn15 = 0.5142
op
wrdata pcMevc3_42.dat v(mop0) v(mon0) v(mop1) v(mon1) v(mop2) v(mon2)
alter Vxp0 = 0.6501
alter Vxn0 = 0.3499
alter Vxp1 = 0.6587
alter Vxn1 = 0.3413
alter Vxp2 = 0.4022
alter Vxn2 = 0.5978
alter Vxp3 = 0.4537
alter Vxn3 = 0.5463
alter Vxp4 = 0.4110
alter Vxn4 = 0.5890
alter Vxp5 = 0.3952
alter Vxn5 = 0.6048
alter Vxp6 = 0.4555
alter Vxn6 = 0.5445
alter Vxp7 = 0.4348
alter Vxn7 = 0.5652
alter Vxp8 = 0.4507
alter Vxn8 = 0.5493
alter Vxp9 = 0.5754
alter Vxn9 = 0.4246
alter Vxp10 = 0.2684
alter Vxn10 = 0.7316
alter Vxp11 = 0.4066
alter Vxn11 = 0.5934
alter Vxp12 = 0.8000
alter Vxn12 = 0.2000
alter Vxp13 = 0.6634
alter Vxn13 = 0.3366
alter Vxp14 = 0.5765
alter Vxn14 = 0.4235
alter Vxp15 = 0.5170
alter Vxn15 = 0.4830
op
wrdata pcMevc3_43.dat v(mop0) v(mon0) v(mop1) v(mon1) v(mop2) v(mon2)
alter Vxp0 = 0.4393
alter Vxn0 = 0.5607
alter Vxp1 = 0.5939
alter Vxn1 = 0.4061
alter Vxp2 = 0.3327
alter Vxn2 = 0.6673
alter Vxp3 = 0.4537
alter Vxn3 = 0.5463
alter Vxp4 = 0.4110
alter Vxn4 = 0.5890
alter Vxp5 = 0.4217
alter Vxn5 = 0.5783
alter Vxp6 = 0.5037
alter Vxn6 = 0.4963
alter Vxp7 = 0.4348
alter Vxn7 = 0.5652
alter Vxp8 = 0.4339
alter Vxn8 = 0.5661
alter Vxp9 = 0.4102
alter Vxn9 = 0.5898
alter Vxp10 = 0.4786
alter Vxn10 = 0.5214
alter Vxp11 = 0.4066
alter Vxn11 = 0.5934
alter Vxp12 = 0.4570
alter Vxn12 = 0.5430
alter Vxp13 = 0.6481
alter Vxn13 = 0.3519
alter Vxp14 = 0.5765
alter Vxn14 = 0.4235
alter Vxp15 = 0.7041
alter Vxn15 = 0.2959
op
wrdata pcMevc3_44.dat v(mop0) v(mon0) v(mop1) v(mon1) v(mop2) v(mon2)
alter Vxp0 = 0.8000
alter Vxn0 = 0.2000
alter Vxp1 = 0.6506
alter Vxn1 = 0.3494
alter Vxp2 = 0.3952
alter Vxn2 = 0.6048
alter Vxp3 = 0.4537
alter Vxn3 = 0.5463
alter Vxp4 = 0.4461
alter Vxn4 = 0.5539
alter Vxp5 = 0.2958
alter Vxn5 = 0.7042
alter Vxp6 = 0.5459
alter Vxn6 = 0.4541
alter Vxp7 = 0.4348
alter Vxn7 = 0.5652
alter Vxp8 = 0.4339
alter Vxn8 = 0.5661
alter Vxp9 = 0.4209
alter Vxn9 = 0.5791
alter Vxp10 = 0.5076
alter Vxn10 = 0.4924
alter Vxp11 = 0.4212
alter Vxn11 = 0.5788
alter Vxp12 = 0.6739
alter Vxn12 = 0.3261
alter Vxp13 = 0.6634
alter Vxn13 = 0.3366
alter Vxp14 = 0.6037
alter Vxn14 = 0.3963
alter Vxp15 = 0.5794
alter Vxn15 = 0.4206
op
wrdata pcMevc3_45.dat v(mop0) v(mon0) v(mop1) v(mon1) v(mop2) v(mon2)
alter Vxp0 = 0.4393
alter Vxn0 = 0.5607
alter Vxp1 = 0.2052
alter Vxn1 = 0.7948
alter Vxp2 = 0.6522
alter Vxn2 = 0.3478
alter Vxp3 = 0.6688
alter Vxn3 = 0.3312
alter Vxp4 = 0.4110
alter Vxn4 = 0.5890
alter Vxp5 = 0.3555
alter Vxn5 = 0.6445
alter Vxp6 = 0.6424
alter Vxn6 = 0.3576
alter Vxp7 = 0.7170
alter Vxn7 = 0.2830
alter Vxp8 = 0.6021
alter Vxn8 = 0.3979
alter Vxp9 = 0.6020
alter Vxn9 = 0.3980
alter Vxp10 = 0.5656
alter Vxn10 = 0.4344
alter Vxp11 = 0.4066
alter Vxn11 = 0.5934
alter Vxp12 = 0.5871
alter Vxn12 = 0.4129
alter Vxp13 = 0.4103
alter Vxn13 = 0.5897
alter Vxp14 = 0.6037
alter Vxn14 = 0.3963
alter Vxp15 = 0.5586
alter Vxn15 = 0.4414
op
wrdata pcMevc3_46.dat v(mop0) v(mon0) v(mop1) v(mon1) v(mop2) v(mon2)
alter Vxp0 = 0.5184
alter Vxn0 = 0.4816
alter Vxp1 = 0.6344
alter Vxn1 = 0.3656
alter Vxp2 = 0.4647
alter Vxn2 = 0.5353
alter Vxp3 = 0.4537
alter Vxn3 = 0.5463
alter Vxp4 = 0.4285
alter Vxn4 = 0.5715
alter Vxp5 = 0.3952
alter Vxn5 = 0.6048
alter Vxp6 = 0.5218
alter Vxn6 = 0.4782
alter Vxp7 = 0.4348
alter Vxn7 = 0.5652
alter Vxp8 = 0.4339
alter Vxn8 = 0.5661
alter Vxp9 = 0.4955
alter Vxn9 = 0.5045
alter Vxp10 = 0.3481
alter Vxn10 = 0.6519
alter Vxp11 = 0.4066
alter Vxn11 = 0.5934
alter Vxp12 = 0.4570
alter Vxn12 = 0.5430
alter Vxp13 = 0.6481
alter Vxn13 = 0.3519
alter Vxp14 = 0.5493
alter Vxn14 = 0.4507
alter Vxp15 = 0.4650
alter Vxn15 = 0.5350
op
wrdata pcMevc3_47.dat v(mop0) v(mon0) v(mop1) v(mon1) v(mop2) v(mon2)
alter Vxp0 = 0.8000
alter Vxn0 = 0.2000
alter Vxp1 = 0.6344
alter Vxn1 = 0.3656
alter Vxp2 = 0.3952
alter Vxn2 = 0.6048
alter Vxp3 = 0.4537
alter Vxn3 = 0.5463
alter Vxp4 = 0.6039
alter Vxn4 = 0.3961
alter Vxp5 = 0.4085
alter Vxn5 = 0.5915
alter Vxp6 = 0.4434
alter Vxn6 = 0.5566
alter Vxp7 = 0.4348
alter Vxn7 = 0.5652
alter Vxp8 = 0.4339
alter Vxn8 = 0.5661
alter Vxp9 = 0.5381
alter Vxn9 = 0.4619
alter Vxp10 = 0.2756
alter Vxn10 = 0.7244
alter Vxp11 = 0.4066
alter Vxn11 = 0.5934
alter Vxp12 = 0.5871
alter Vxn12 = 0.4129
alter Vxp13 = 0.6788
alter Vxn13 = 0.3212
alter Vxp14 = 0.5697
alter Vxn14 = 0.4303
alter Vxp15 = 0.5898
alter Vxn15 = 0.4102
op
wrdata pcMevc3_48.dat v(mop0) v(mon0) v(mop1) v(mon1) v(mop2) v(mon2)
alter Vxp0 = 0.4920
alter Vxn0 = 0.5080
alter Vxp1 = 0.6101
alter Vxn1 = 0.3899
alter Vxp2 = 0.5897
alter Vxn2 = 0.4103
alter Vxp3 = 0.4537
alter Vxn3 = 0.5463
alter Vxp4 = 0.4110
alter Vxn4 = 0.5890
alter Vxp5 = 0.4350
alter Vxn5 = 0.5650
alter Vxp6 = 0.5520
alter Vxn6 = 0.4480
alter Vxp7 = 0.4975
alter Vxn7 = 0.5025
alter Vxp8 = 0.4339
alter Vxn8 = 0.5661
alter Vxp9 = 0.3410
alter Vxn9 = 0.6590
alter Vxp10 = 0.5728
alter Vxn10 = 0.4272
alter Vxp11 = 0.4066
alter Vxn11 = 0.5934
alter Vxp12 = 0.4570
alter Vxn12 = 0.5430
alter Vxp13 = 0.5407
alter Vxn13 = 0.4593
alter Vxp14 = 0.6105
alter Vxn14 = 0.3895
alter Vxp15 = 0.7560
alter Vxn15 = 0.2440
op
wrdata pcMevc3_49.dat v(mop0) v(mon0) v(mop1) v(mon1) v(mop2) v(mon2)
alter Vxp0 = 0.6764
alter Vxn0 = 0.3236
alter Vxp1 = 0.6182
alter Vxn1 = 0.3818
alter Vxp2 = 0.5897
alter Vxn2 = 0.4103
alter Vxp3 = 0.4671
alter Vxn3 = 0.5329
alter Vxp4 = 0.5338
alter Vxn4 = 0.4662
alter Vxp5 = 0.3555
alter Vxn5 = 0.6445
alter Vxp6 = 0.5580
alter Vxn6 = 0.4420
alter Vxp7 = 0.4662
alter Vxn7 = 0.5338
alter Vxp8 = 0.4339
alter Vxn8 = 0.5661
alter Vxp9 = 0.3516
alter Vxn9 = 0.6484
alter Vxp10 = 0.5728
alter Vxn10 = 0.4272
alter Vxp11 = 0.4066
alter Vxn11 = 0.5934
alter Vxp12 = 0.4570
alter Vxn12 = 0.5430
alter Vxp13 = 0.6174
alter Vxn13 = 0.3826
alter Vxp14 = 0.6105
alter Vxn14 = 0.3895
alter Vxp15 = 0.7145
alter Vxn15 = 0.2855
op
wrdata pcMevc3_50.dat v(mop0) v(mon0) v(mop1) v(mon1) v(mop2) v(mon2)
alter Vxp0 = 0.6764
alter Vxn0 = 0.3236
alter Vxp1 = 0.6182
alter Vxn1 = 0.3818
alter Vxp2 = 0.3050
alter Vxn2 = 0.6950
alter Vxp3 = 0.4537
alter Vxn3 = 0.5463
alter Vxp4 = 0.6390
alter Vxn4 = 0.3610
alter Vxp5 = 0.4615
alter Vxn5 = 0.5385
alter Vxp6 = 0.4494
alter Vxn6 = 0.5506
alter Vxp7 = 0.4348
alter Vxn7 = 0.5652
alter Vxp8 = 0.4339
alter Vxn8 = 0.5661
alter Vxp9 = 0.4848
alter Vxn9 = 0.5152
alter Vxp10 = 0.3191
alter Vxn10 = 0.6809
alter Vxp11 = 0.4066
alter Vxn11 = 0.5934
alter Vxp12 = 0.5871
alter Vxn12 = 0.4129
alter Vxp13 = 0.6404
alter Vxn13 = 0.3596
alter Vxp14 = 0.5969
alter Vxn14 = 0.4031
alter Vxp15 = 0.5690
alter Vxn15 = 0.4310
op
wrdata pcMevc3_51.dat v(mop0) v(mon0) v(mop1) v(mon1) v(mop2) v(mon2)
alter Vxp0 = 0.4393
alter Vxn0 = 0.5607
alter Vxp1 = 0.5534
alter Vxn1 = 0.4466
alter Vxp2 = 0.3050
alter Vxn2 = 0.6950
alter Vxp3 = 0.4537
alter Vxn3 = 0.5463
alter Vxp4 = 0.4461
alter Vxn4 = 0.5539
alter Vxp5 = 0.4284
alter Vxn5 = 0.5716
alter Vxp6 = 0.4615
alter Vxn6 = 0.5385
alter Vxp7 = 0.4348
alter Vxn7 = 0.5652
alter Vxp8 = 0.4339
alter Vxn8 = 0.5661
alter Vxp9 = 0.3783
alter Vxn9 = 0.6217
alter Vxp10 = 0.4786
alter Vxn10 = 0.5214
alter Vxp11 = 0.4066
alter Vxn11 = 0.5934
alter Vxp12 = 0.4570
alter Vxn12 = 0.5430
alter Vxp13 = 0.5330
alter Vxn13 = 0.4670
alter Vxp14 = 0.5561
alter Vxn14 = 0.4439
alter Vxp15 = 0.7041
alter Vxn15 = 0.2959
op
wrdata pcMevc3_52.dat v(mop0) v(mon0) v(mop1) v(mon1) v(mop2) v(mon2)
alter Vxp0 = 0.5710
alter Vxn0 = 0.4290
alter Vxp1 = 0.6020
alter Vxn1 = 0.3980
alter Vxp2 = 0.5758
alter Vxn2 = 0.4242
alter Vxp3 = 0.4940
alter Vxn3 = 0.5060
alter Vxp4 = 0.4110
alter Vxn4 = 0.5890
alter Vxp5 = 0.2759
alter Vxn5 = 0.7241
alter Vxp6 = 0.5942
alter Vxn6 = 0.4058
alter Vxp7 = 0.4818
alter Vxn7 = 0.5182
alter Vxp8 = 0.4339
alter Vxn8 = 0.5661
alter Vxp9 = 0.5008
alter Vxn9 = 0.4992
alter Vxp10 = 0.4713
alter Vxn10 = 0.5287
alter Vxp11 = 0.4066
alter Vxn11 = 0.5934
alter Vxp12 = 0.5004
alter Vxn12 = 0.4996
alter Vxp13 = 0.6788
alter Vxn13 = 0.3212
alter Vxp14 = 0.5629
alter Vxn14 = 0.4371
alter Vxp15 = 0.6417
alter Vxn15 = 0.3583
op
wrdata pcMevc3_53.dat v(mop0) v(mon0) v(mop1) v(mon1) v(mop2) v(mon2)
alter Vxp0 = 0.7028
alter Vxn0 = 0.2972
alter Vxp1 = 0.5858
alter Vxn1 = 0.4142
alter Vxp2 = 0.5341
alter Vxn2 = 0.4659
alter Vxp3 = 0.4537
alter Vxn3 = 0.5463
alter Vxp4 = 0.4987
alter Vxn4 = 0.5013
alter Vxp5 = 0.3753
alter Vxn5 = 0.6247
alter Vxp6 = 0.5640
alter Vxn6 = 0.4360
alter Vxp7 = 0.4348
alter Vxn7 = 0.5652
alter Vxp8 = 0.4675
alter Vxn8 = 0.5325
alter Vxp9 = 0.5914
alter Vxn9 = 0.4086
alter Vxp10 = 0.3191
alter Vxn10 = 0.6809
alter Vxp11 = 0.4066
alter Vxn11 = 0.5934
alter Vxp12 = 0.7173
alter Vxn12 = 0.2827
alter Vxp13 = 0.6404
alter Vxn13 = 0.3596
alter Vxp14 = 0.5765
alter Vxn14 = 0.4235
alter Vxp15 = 0.6521
alter Vxn15 = 0.3479
op
wrdata pcMevc3_54.dat v(mop0) v(mon0) v(mop1) v(mon1) v(mop2) v(mon2)
alter Vxp0 = 0.5184
alter Vxn0 = 0.4816
alter Vxp1 = 0.6182
alter Vxn1 = 0.3818
alter Vxp2 = 0.3188
alter Vxn2 = 0.6812
alter Vxp3 = 0.4537
alter Vxn3 = 0.5463
alter Vxp4 = 0.5162
alter Vxn4 = 0.4838
alter Vxp5 = 0.4748
alter Vxn5 = 0.5252
alter Vxp6 = 0.4253
alter Vxn6 = 0.5747
alter Vxp7 = 0.4348
alter Vxn7 = 0.5652
alter Vxp8 = 0.4339
alter Vxn8 = 0.5661
alter Vxp9 = 0.4742
alter Vxn9 = 0.5258
alter Vxp10 = 0.3771
alter Vxn10 = 0.6229
alter Vxp11 = 0.4797
alter Vxn11 = 0.5203
alter Vxp12 = 0.5004
alter Vxn12 = 0.4996
alter Vxp13 = 0.6404
alter Vxn13 = 0.3596
alter Vxp14 = 0.6037
alter Vxn14 = 0.3963
alter Vxp15 = 0.5378
alter Vxn15 = 0.4622
op
wrdata pcMevc3_55.dat v(mop0) v(mon0) v(mop1) v(mon1) v(mop2) v(mon2)
alter Vxp0 = 0.5710
alter Vxn0 = 0.4290
alter Vxp1 = 0.5615
alter Vxn1 = 0.4385
alter Vxp2 = 0.4994
alter Vxn2 = 0.5006
alter Vxp3 = 0.4537
alter Vxn3 = 0.5463
alter Vxp4 = 0.4110
alter Vxn4 = 0.5890
alter Vxp5 = 0.2958
alter Vxn5 = 0.7042
alter Vxp6 = 0.5218
alter Vxn6 = 0.4782
alter Vxp7 = 0.4348
alter Vxn7 = 0.5652
alter Vxp8 = 0.4339
alter Vxn8 = 0.5661
alter Vxp9 = 0.5541
alter Vxn9 = 0.4459
alter Vxp10 = 0.2829
alter Vxn10 = 0.7171
alter Vxp11 = 0.4066
alter Vxn11 = 0.5934
alter Vxp12 = 0.8000
alter Vxn12 = 0.2000
alter Vxp13 = 0.6251
alter Vxn13 = 0.3749
alter Vxp14 = 0.5153
alter Vxn14 = 0.4847
alter Vxp15 = 0.5794
alter Vxn15 = 0.4206
op
wrdata pcMevc3_56.dat v(mop0) v(mon0) v(mop1) v(mon1) v(mop2) v(mon2)
alter Vxp0 = 0.4393
alter Vxn0 = 0.5607
alter Vxp1 = 0.5858
alter Vxn1 = 0.4142
alter Vxp2 = 0.4369
alter Vxn2 = 0.5631
alter Vxp3 = 0.4537
alter Vxn3 = 0.5463
alter Vxp4 = 0.4110
alter Vxn4 = 0.5890
alter Vxp5 = 0.3621
alter Vxn5 = 0.6379
alter Vxp6 = 0.4977
alter Vxn6 = 0.5023
alter Vxp7 = 0.4348
alter Vxn7 = 0.5652
alter Vxp8 = 0.4675
alter Vxn8 = 0.5325
alter Vxp9 = 0.6020
alter Vxn9 = 0.3980
alter Vxp10 = 0.3989
alter Vxn10 = 0.6011
alter Vxp11 = 0.4504
alter Vxn11 = 0.5496
alter Vxp12 = 0.6739
alter Vxn12 = 0.3261
alter Vxp13 = 0.6481
alter Vxn13 = 0.3519
alter Vxp14 = 0.5289
alter Vxn14 = 0.4711
alter Vxp15 = 0.4650
alter Vxn15 = 0.5350
op
wrdata pcMevc3_57.dat v(mop0) v(mon0) v(mop1) v(mon1) v(mop2) v(mon2)
alter Vxp0 = 0.5710
alter Vxn0 = 0.4290
alter Vxp1 = 0.5858
alter Vxn1 = 0.4142
alter Vxp2 = 0.5341
alter Vxn2 = 0.4659
alter Vxp3 = 0.4537
alter Vxn3 = 0.5463
alter Vxp4 = 0.5513
alter Vxn4 = 0.4487
alter Vxp5 = 0.3753
alter Vxn5 = 0.6247
alter Vxp6 = 0.5459
alter Vxn6 = 0.4541
alter Vxp7 = 0.4348
alter Vxn7 = 0.5652
alter Vxp8 = 0.4339
alter Vxn8 = 0.5661
alter Vxp9 = 0.4955
alter Vxn9 = 0.5045
alter Vxp10 = 0.4351
alter Vxn10 = 0.5649
alter Vxp11 = 0.5235
alter Vxn11 = 0.4765
alter Vxp12 = 0.4570
alter Vxn12 = 0.5430
alter Vxp13 = 0.5714
alter Vxn13 = 0.4286
alter Vxp14 = 0.5425
alter Vxn14 = 0.4575
alter Vxp15 = 0.4650
alter Vxn15 = 0.5350
op
wrdata pcMevc3_58.dat v(mop0) v(mon0) v(mop1) v(mon1) v(mop2) v(mon2)
alter Vxp0 = 0.5184
alter Vxn0 = 0.4816
alter Vxp1 = 0.4967
alter Vxn1 = 0.5033
alter Vxp2 = 0.3952
alter Vxn2 = 0.6048
alter Vxp3 = 0.4537
alter Vxn3 = 0.5463
alter Vxp4 = 0.7267
alter Vxn4 = 0.2733
alter Vxp5 = 0.4350
alter Vxn5 = 0.5650
alter Vxp6 = 0.4675
alter Vxn6 = 0.5325
alter Vxp7 = 0.4348
alter Vxn7 = 0.5652
alter Vxp8 = 0.4339
alter Vxn8 = 0.5661
alter Vxp9 = 0.4049
alter Vxn9 = 0.5951
alter Vxp10 = 0.3916
alter Vxn10 = 0.6084
alter Vxp11 = 0.4066
alter Vxn11 = 0.5934
alter Vxp12 = 0.4570
alter Vxn12 = 0.5430
alter Vxp13 = 0.4563
alter Vxn13 = 0.5437
alter Vxp14 = 0.5425
alter Vxn14 = 0.4575
alter Vxp15 = 0.7249
alter Vxn15 = 0.2751
op
wrdata pcMevc3_59.dat v(mop0) v(mon0) v(mop1) v(mon1) v(mop2) v(mon2)
.endc
.end
