cds product run
.model NNR NMOS (LEVEL=1 VTO=0.2 KP=120u LAMBDA=0.02 GAMMA=0 PHI=0.7)
.model PNR PMOS (LEVEL=1 VTO=-0.2 KP=40u LAMBDA=0.02 GAMMA=0 PHI=0.7)
.subckt gprod xp xn yp yn wp wn vdd vbn
Mtail nt vbn 0 0 NNR W=400u L=100u
M5 na yp nt 0 NNR W=200u L=100u
M6 nb yn nt 0 NNR W=200u L=100u
M1 iop xp na 0 NNR W=200u L=100u
M2 ion xn na 0 NNR W=200u L=100u
M3 ion xp nb 0 NNR W=200u L=100u
M4 iop xn nb 0 NNR W=200u L=100u
Mlp iop iop vdd vdd PNR W=200u L=100u
Mln ion ion vdd vdd PNR W=200u L=100u
Mpu_wp wp iop vdd vdd PNR W=200u L=100u
MpRn nrn ion vdd vdd PNR W=200u L=100u
MnRn nrn nrn 0 0 NNR W=200u L=100u
Mpd_wp wp nrn 0 0 NNR W=200u L=100u
Mpu_wn wn ion vdd vdd PNR W=200u L=100u
MpRp nrp iop vdd vdd PNR W=200u L=100u
MnRp nrp nrp 0 0 NNR W=200u L=100u
Mpd_wn wn nrp 0 0 NNR W=200u L=100u
.ends
Vdd vdd 0 1.0
Vgbn gbn 0 1.1
Vxp_w11 xp_w11 0 PWL(0.0n 0.2900 599.5n 0.2900 600.0n 0.2900 1199.5n 0.2900 1200.0n 0.7100 1799.5n 0.7100 1800.0n 0.7100 2399.5n 0.7100)
Vxn_w11 xn_w11 0 PWL(0.0n 0.7100 599.5n 0.7100 600.0n 0.7100 1199.5n 0.7100 1200.0n 0.2900 1799.5n 0.2900 1800.0n 0.2900 2399.5n 0.2900)
Vyp_w11 yp_w11 0 PWL(0.0n 0.5689 599.5n 0.5689 600.0n 0.4274 1199.5n 0.4274 1200.0n 0.5901 1799.5n 0.5901 1800.0n 0.5744 2399.5n 0.5744)
Vyn_w11 yn_w11 0 PWL(0.0n 0.4311 599.5n 0.4311 600.0n 0.5726 1199.5n 0.5726 1200.0n 0.4099 1799.5n 0.4099 1800.0n 0.4256 2399.5n 0.4256)
Cwp_w11 wp_w11 0 400p
Cwn_w11 wn_w11 0 400p
Xu_w11 xp_w11 xn_w11 yp_w11 yn_w11 wp_w11 wn_w11 vdd gbn gprod
Vxp_w21 xp_w21 0 PWL(0.0n 0.2900 599.5n 0.2900 600.0n 0.7100 1199.5n 0.7100 1200.0n 0.2900 1799.5n 0.2900 1800.0n 0.7100 2399.5n 0.7100)
Vxn_w21 xn_w21 0 PWL(0.0n 0.7100 599.5n 0.7100 600.0n 0.2900 1199.5n 0.2900 1200.0n 0.7100 1799.5n 0.7100 1800.0n 0.2900 2399.5n 0.2900)
Vyp_w21 yp_w21 0 PWL(0.0n 0.5689 599.5n 0.5689 600.0n 0.4274 1199.5n 0.4274 1200.0n 0.5901 1799.5n 0.5901 1800.0n 0.5744 2399.5n 0.5744)
Vyn_w21 yn_w21 0 PWL(0.0n 0.4311 599.5n 0.4311 600.0n 0.5726 1199.5n 0.5726 1200.0n 0.4099 1799.5n 0.4099 1800.0n 0.4256 2399.5n 0.4256)
Cwp_w21 wp_w21 0 400p
Cwn_w21 wn_w21 0 400p
Xu_w21 xp_w21 xn_w21 yp_w21 yn_w21 wp_w21 wn_w21 vdd gbn gprod
Vxp_o1 xp_o1 0 PWL(0.0n 0.5689 599.5n 0.5689 600.0n 0.4274 1199.5n 0.4274 1200.0n 0.5901 1799.5n 0.5901 1800.0n 0.5744 2399.5n 0.5744)
Vxn_o1 xn_o1 0 PWL(0.0n 0.4311 599.5n 0.4311 600.0n 0.5726 1199.5n 0.5726 1200.0n 0.4099 1799.5n 0.4099 1800.0n 0.4256 2399.5n 0.4256)
Vyp_o1 yp_o1 0 PWL(0.0n 0.4689 599.5n 0.4689 600.0n 0.5070 1199.5n 0.5070 1200.0n 0.5147 1799.5n 0.5147 1800.0n 0.4865 2399.5n 0.4865)
Vyn_o1 yn_o1 0 PWL(0.0n 0.5311 599.5n 0.5311 600.0n 0.4930 1199.5n 0.4930 1200.0n 0.4853 1799.5n 0.4853 1800.0n 0.5135 2399.5n 0.5135)
Cwp_o1 wp_o1 0 400p
Cwn_o1 wn_o1 0 400p
Xu_o1 xp_o1 xn_o1 yp_o1 yn_o1 wp_o1 wn_o1 vdd gbn gprod
Vxp_bh1 xp_bh1 0 PWL(0.0n 0.7100 599.5n 0.7100 600.0n 0.7100 1199.5n 0.7100 1200.0n 0.7100 1799.5n 0.7100 1800.0n 0.7100 2399.5n 0.7100)
Vxn_bh1 xn_bh1 0 PWL(0.0n 0.2900 599.5n 0.2900 600.0n 0.2900 1199.5n 0.2900 1200.0n 0.2900 1799.5n 0.2900 1800.0n 0.2900 2399.5n 0.2900)
Vyp_bh1 yp_bh1 0 PWL(0.0n 0.5689 599.5n 0.5689 600.0n 0.4274 1199.5n 0.4274 1200.0n 0.5901 1799.5n 0.5901 1800.0n 0.5744 2399.5n 0.5744)
Vyn_bh1 yn_bh1 0 PWL(0.0n 0.4311 599.5n 0.4311 600.0n 0.5726 1199.5n 0.5726 1200.0n 0.4099 1799.5n 0.4099 1800.0n 0.4256 2399.5n 0.4256)
Cwp_bh1 wp_bh1 0 400p
Cwn_bh1 wn_bh1 0 400p
Xu_bh1 xp_bh1 xn_bh1 yp_bh1 yn_bh1 wp_bh1 wn_bh1 vdd gbn gprod
Vxp_w12 xp_w12 0 PWL(0.0n 0.2900 599.5n 0.2900 600.0n 0.2900 1199.5n 0.2900 1200.0n 0.7100 1799.5n 0.7100 1800.0n 0.7100 2399.5n 0.7100)
Vxn_w12 xn_w12 0 PWL(0.0n 0.7100 599.5n 0.7100 600.0n 0.7100 1199.5n 0.7100 1200.0n 0.2900 1799.5n 0.2900 1800.0n 0.2900 2399.5n 0.2900)
Vyp_w12 yp_w12 0 PWL(0.0n 0.4247 599.5n 0.4247 600.0n 0.5777 1199.5n 0.5777 1200.0n 0.5765 1799.5n 0.5765 1800.0n 0.5964 2399.5n 0.5964)
Vyn_w12 yn_w12 0 PWL(0.0n 0.5753 599.5n 0.5753 600.0n 0.4223 1199.5n 0.4223 1200.0n 0.4235 1799.5n 0.4235 1800.0n 0.4036 2399.5n 0.4036)
Cwp_w12 wp_w12 0 400p
Cwn_w12 wn_w12 0 400p
Xu_w12 xp_w12 xn_w12 yp_w12 yn_w12 wp_w12 wn_w12 vdd gbn gprod
Vxp_w22 xp_w22 0 PWL(0.0n 0.2900 599.5n 0.2900 600.0n 0.7100 1199.5n 0.7100 1200.0n 0.2900 1799.5n 0.2900 1800.0n 0.7100 2399.5n 0.7100)
Vxn_w22 xn_w22 0 PWL(0.0n 0.7100 599.5n 0.7100 600.0n 0.2900 1199.5n 0.2900 1200.0n 0.7100 1799.5n 0.7100 1800.0n 0.2900 2399.5n 0.2900)
Vyp_w22 yp_w22 0 PWL(0.0n 0.4247 599.5n 0.4247 600.0n 0.5777 1199.5n 0.5777 1200.0n 0.5765 1799.5n 0.5765 1800.0n 0.5964 2399.5n 0.5964)
Vyn_w22 yn_w22 0 PWL(0.0n 0.5753 599.5n 0.5753 600.0n 0.4223 1199.5n 0.4223 1200.0n 0.4235 1799.5n 0.4235 1800.0n 0.4036 2399.5n 0.4036)
Cwp_w22 wp_w22 0 400p
Cwn_w22 wn_w22 0 400p
Xu_w22 xp_w22 xn_w22 yp_w22 yn_w22 wp_w22 wn_w22 vdd gbn gprod
Vxp_o2 xp_o2 0 PWL(0.0n 0.4247 599.5n 0.4247 600.0n 0.5777 1199.5n 0.5777 1200.0n 0.5765 1799.5n 0.5765 1800.0n 0.5964 2399.5n 0.5964)
Vxn_o2 xn_o2 0 PWL(0.0n 0.5753 599.5n 0.5753 600.0n 0.4223 1199.5n 0.4223 1200.0n 0.4235 1799.5n 0.4235 1800.0n 0.4036 2399.5n 0.4036)
Vyp_o2 yp_o2 0 PWL(0.0n 0.4689 599.5n 0.4689 600.0n 0.5070 1199.5n 0.5070 1200.0n 0.5147 1799.5n 0.5147 1800.0n 0.4865 2399.5n 0.4865)
Vyn_o2 yn_o2 0 PWL(0.0n 0.5311 599.5n 0.5311 600.0n 0.4930 1199.5n 0.4930 1200.0n 0.4853 1799.5n 0.4853 1800.0n 0.5135 2399.5n 0.5135)
Cwp_o2 wp_o2 0 400p
Cwn_o2 wn_o2 0 400p
Xu_o2 xp_o2 xn_o2 yp_o2 yn_o2 wp_o2 wn_o2 vdd gbn gprod
Vxp_bh2 xp_bh2 0 PWL(0.0n 0.7100 599.5n 0.7100 600.0n 0.7100 1199.5n 0.7100 1200.0n 0.7100 1799.5n 0.7100 1800.0n 0.7100 2399.5n 0.7100)
Vxn_bh2 xn_bh2 0 PWL(0.0n 0.2900 599.5n 0.2900 600.0n 0.2900 1199.5n 0.2900 1200.0n 0.2900 1799.5n 0.2900 1800.0n 0.2900 2399.5n 0.2900)
Vyp_bh2 yp_bh2 0 PWL(0.0n 0.4247 599.5n 0.4247 600.0n 0.5777 1199.5n 0.5777 1200.0n 0.5765 1799.5n 0.5765 1800.0n 0.5964 2399.5n 0.5964)
Vyn_bh2 yn_bh2 0 PWL(0.0n 0.5753 599.5n 0.5753 600.0n 0.4223 1199.5n 0.4223 1200.0n 0.4235 1799.5n 0.4235 1800.0n 0.4036 2399.5n 0.4036)
Cwp_bh2 wp_bh2 0 400p
Cwn_bh2 wn_bh2 0 400p
Xu_bh2 xp_bh2 xn_bh2 yp_bh2 yn_bh2 wp_bh2 wn_bh2 vdd gbn gprod
Vxp_w13 xp_w13 0 PWL(0.0n 0.2900 599.5n 0.2900 600.0n 0.2900 1199.5n 0.2900 1200.0n 0.7100 1799.5n 0.7100 1800.0n 0.7100 2399.5n 0.7100)
Vxn_w13 xn_w13 0 PWL(0.0n 0.7100 599.5n 0.7100 600.0n 0.7100 1199.5n 0.7100 1200.0n 0.2900 1799.5n 0.2900 1800.0n 0.2900 2399.5n 0.2900)
Vyp_w13 yp_w13 0 PWL(0.0n 0.4582 599.5n 0.4582 600.0n 0.4027 1199.5n 0.4027 1200.0n 0.5851 1799.5n 0.5851 1800.0n 0.4486 2399.5n 0.4486)
Vyn_w13 yn_w13 0 PWL(0.0n 0.5418 599.5n 0.5418 600.0n 0.5973 1199.5n 0.5973 1200.0n 0.4149 1799.5n 0.4149 1800.0n 0.5514 2399.5n 0.5514)
Cwp_w13 wp_w13 0 400p
Cwn_w13 wn_w13 0 400p
Xu_w13 xp_w13 xn_w13 yp_w13 yn_w13 wp_w13 wn_w13 vdd gbn gprod
Vxp_w23 xp_w23 0 PWL(0.0n 0.2900 599.5n 0.2900 600.0n 0.7100 1199.5n 0.7100 1200.0n 0.2900 1799.5n 0.2900 1800.0n 0.7100 2399.5n 0.7100)
Vxn_w23 xn_w23 0 PWL(0.0n 0.7100 599.5n 0.7100 600.0n 0.2900 1199.5n 0.2900 1200.0n 0.7100 1799.5n 0.7100 1800.0n 0.2900 2399.5n 0.2900)
Vyp_w23 yp_w23 0 PWL(0.0n 0.4582 599.5n 0.4582 600.0n 0.4027 1199.5n 0.4027 1200.0n 0.5851 1799.5n 0.5851 1800.0n 0.4486 2399.5n 0.4486)
Vyn_w23 yn_w23 0 PWL(0.0n 0.5418 599.5n 0.5418 600.0n 0.5973 1199.5n 0.5973 1200.0n 0.4149 1799.5n 0.4149 1800.0n 0.5514 2399.5n 0.5514)
Cwp_w23 wp_w23 0 400p
Cwn_w23 wn_w23 0 400p
Xu_w23 xp_w23 xn_w23 yp_w23 yn_w23 wp_w23 wn_w23 vdd gbn gprod
Vxp_o3 xp_o3 0 PWL(0.0n 0.4582 599.5n 0.4582 600.0n 0.4027 1199.5n 0.4027 1200.0n 0.5851 1799.5n 0.5851 1800.0n 0.4486 2399.5n 0.4486)
Vxn_o3 xn_o3 0 PWL(0.0n 0.5418 599.5n 0.5418 600.0n 0.5973 1199.5n 0.5973 1200.0n 0.4149 1799.5n 0.4149 1800.0n 0.5514 2399.5n 0.5514)
Vyp_o3 yp_o3 0 PWL(0.0n 0.4689 599.5n 0.4689 600.0n 0.5070 1199.5n 0.5070 1200.0n 0.5147 1799.5n 0.5147 1800.0n 0.4865 2399.5n 0.4865)
Vyn_o3 yn_o3 0 PWL(0.0n 0.5311 599.5n 0.5311 600.0n 0.4930 1199.5n 0.4930 1200.0n 0.4853 1799.5n 0.4853 1800.0n 0.5135 2399.5n 0.5135)
Cwp_o3 wp_o3 0 400p
Cwn_o3 wn_o3 0 400p
Xu_o3 xp_o3 xn_o3 yp_o3 yn_o3 wp_o3 wn_o3 vdd gbn gprod
Vxp_bh3 xp_bh3 0 PWL(0.0n 0.7100 599.5n 0.7100 600.0n 0.7100 1199.5n 0.7100 1200.0n 0.7100 1799.5n 0.7100 1800.0n 0.7100 2399.5n 0.7100)
Vxn_bh3 xn_bh3 0 PWL(0.0n 0.2900 599.5n 0.2900 600.0n 0.2900 1199.5n 0.2900 1200.0n 0.2900 1799.5n 0.2900 1800.0n 0.2900 2399.5n 0.2900)
Vyp_bh3 yp_bh3 0 PWL(0.0n 0.4582 599.5n 0.4582 600.0n 0.4027 1199.5n 0.4027 1200.0n 0.5851 1799.5n 0.5851 1800.0n 0.4486 2399.5n 0.4486)
Vyn_bh3 yn_bh3 0 PWL(0.0n 0.5418 599.5n 0.5418 600.0n 0.5973 1199.5n 0.5973 1200.0n 0.4149 1799.5n 0.4149 1800.0n 0.5514 2399.5n 0.5514)
Cwp_bh3 wp_bh3 0 400p
Cwn_bh3 wn_bh3 0 400p
Xu_bh3 xp_bh3 xn_bh3 yp_bh3 yn_bh3 wp_bh3 wn_bh3 vdd gbn gprod
Vxp_w14 xp_w14 0 PWL(0.0n 0.2900 599.5n 0.2900 600.0n 0.2900 1199.5n 0.2900 1200.0n 0.7100 1799.5n 0.7100 1800.0n 0.7100 2399.5n 0.7100)
Vxn_w14 xn_w14 0 PWL(0.0n 0.7100 599.5n 0.7100 600.0n 0.7100 1199.5n 0.7100 1200.0n 0.2900 1799.5n 0.2900 1800.0n 0.2900 2399.5n 0.2900)
Vyp_w14 yp_w14 0 PWL(0.0n 0.4160 599.5n 0.4160 600.0n 0.5873 1199.5n 0.5873 1200.0n 0.5882 1799.5n 0.5882 1800.0n 0.6069 2399.5n 0.6069)
Vyn_w14 yn_w14 0 PWL(0.0n 0.5840 599.5n 0.5840 600.0n 0.4127 1199.5n 0.4127 1200.0n 0.4118 1799.5n 0.4118 1800.0n 0.3931 2399.5n 0.3931)
Cwp_w14 wp_w14 0 400p
Cwn_w14 wn_w14 0 400p
Xu_w14 xp_w14 xn_w14 yp_w14 yn_w14 wp_w14 wn_w14 vdd gbn gprod
Vxp_w24 xp_w24 0 PWL(0.0n 0.2900 599.5n 0.2900 600.0n 0.7100 1199.5n 0.7100 1200.0n 0.2900 1799.5n 0.2900 1800.0n 0.7100 2399.5n 0.7100)
Vxn_w24 xn_w24 0 PWL(0.0n 0.7100 599.5n 0.7100 600.0n 0.2900 1199.5n 0.2900 1200.0n 0.7100 1799.5n 0.7100 1800.0n 0.2900 2399.5n 0.2900)
Vyp_w24 yp_w24 0 PWL(0.0n 0.4160 599.5n 0.4160 600.0n 0.5873 1199.5n 0.5873 1200.0n 0.5882 1799.5n 0.5882 1800.0n 0.6069 2399.5n 0.6069)
Vyn_w24 yn_w24 0 PWL(0.0n 0.5840 599.5n 0.5840 600.0n 0.4127 1199.5n 0.4127 1200.0n 0.4118 1799.5n 0.4118 1800.0n 0.3931 2399.5n 0.3931)
Cwp_w24 wp_w24 0 400p
Cwn_w24 wn_w24 0 400p
Xu_w24 xp_w24 xn_w24 yp_w24 yn_w24 wp_w24 wn_w24 vdd gbn gprod
Vxp_o4 xp_o4 0 PWL(0.0n 0.4160 599.5n 0.4160 600.0n 0.5873 1199.5n 0.5873 1200.0n 0.5882 1799.5n 0.5882 1800.0n 0.6069 2399.5n 0.6069)
Vxn_o4 xn_o4 0 PWL(0.0n 0.5840 599.5n 0.5840 600.0n 0.4127 1199.5n 0.4127 1200.0n 0.4118 1799.5n 0.4118 1800.0n 0.3931 2399.5n 0.3931)
Vyp_o4 yp_o4 0 PWL(0.0n 0.4689 599.5n 0.4689 600.0n 0.5070 1199.5n 0.5070 1200.0n 0.5147 1799.5n 0.5147 1800.0n 0.4865 2399.5n 0.4865)
Vyn_o4 yn_o4 0 PWL(0.0n 0.5311 599.5n 0.5311 600.0n 0.4930 1199.5n 0.4930 1200.0n 0.4853 1799.5n 0.4853 1800.0n 0.5135 2399.5n 0.5135)
Cwp_o4 wp_o4 0 400p
Cwn_o4 wn_o4 0 400p
Xu_o4 xp_o4 xn_o4 yp_o4 yn_o4 wp_o4 wn_o4 vdd gbn gprod
Vxp_bh4 xp_bh4 0 PWL(0.0n 0.7100 599.5n 0.7100 600.0n 0.7100 1199.5n 0.7100 1200.0n 0.7100 1799.5n 0.7100 1800.0n 0.7100 2399.5n 0.7100)
Vxn_bh4 xn_bh4 0 PWL(0.0n 0.2900 599.5n 0.2900 600.0n 0.2900 1199.5n 0.2900 1200.0n 0.2900 1799.5n 0.2900 1800.0n 0.2900 2399.5n 0.2900)
Vyp_bh4 yp_bh4 0 PWL(0.0n 0.4160 599.5n 0.4160 600.0n 0.5873 1199.5n 0.5873 1200.0n 0.5882 1799.5n 0.5882 1800.0n 0.6069 2399.5n 0.6069)
Vyn_bh4 yn_bh4 0 PWL(0.0n 0.5840 599.5n 0.5840 600.0n 0.4127 1199.5n 0.4127 1200.0n 0.4118 1799.5n 0.4118 1800.0n 0.3931 2399.5n 0.3931)
Cwp_bh4 wp_bh4 0 400p
Cwn_bh4 wn_bh4 0 400p
Xu_bh4 xp_bh4 xn_bh4 yp_bh4 yn_bh4 wp_bh4 wn_bh4 vdd gbn gprod
Vxp_w15 xp_w15 0 PWL(0.0n 0.2900 599.5n 0.2900 600.0n 0.2900 1199.5n 0.2900 1200.0n 0.7100 1799.5n 0.7100 1800.0n 0.7100 2399.5n 0.7100)
Vxn_w15 xn_w15 0 PWL(0.0n 0.7100 599.5n 0.7100 600.0n 0.7100 1199.5n 0.7100 1200.0n 0.2900 1799.5n 0.2900 1800.0n 0.2900 2399.5n 0.2900)
Vyp_w15 yp_w15 0 PWL(0.0n 0.5957 599.5n 0.5957 600.0n 0.5743 1199.5n 0.5743 1200.0n 0.5745 1799.5n 0.5745 1800.0n 0.4253 2399.5n 0.4253)
Vyn_w15 yn_w15 0 PWL(0.0n 0.4043 599.5n 0.4043 600.0n 0.4257 1199.5n 0.4257 1200.0n 0.4255 1799.5n 0.4255 1800.0n 0.5747 2399.5n 0.5747)
Cwp_w15 wp_w15 0 400p
Cwn_w15 wn_w15 0 400p
Xu_w15 xp_w15 xn_w15 yp_w15 yn_w15 wp_w15 wn_w15 vdd gbn gprod
Vxp_w25 xp_w25 0 PWL(0.0n 0.2900 599.5n 0.2900 600.0n 0.7100 1199.5n 0.7100 1200.0n 0.2900 1799.5n 0.2900 1800.0n 0.7100 2399.5n 0.7100)
Vxn_w25 xn_w25 0 PWL(0.0n 0.7100 599.5n 0.7100 600.0n 0.2900 1199.5n 0.2900 1200.0n 0.7100 1799.5n 0.7100 1800.0n 0.2900 2399.5n 0.2900)
Vyp_w25 yp_w25 0 PWL(0.0n 0.5957 599.5n 0.5957 600.0n 0.5743 1199.5n 0.5743 1200.0n 0.5745 1799.5n 0.5745 1800.0n 0.4253 2399.5n 0.4253)
Vyn_w25 yn_w25 0 PWL(0.0n 0.4043 599.5n 0.4043 600.0n 0.4257 1199.5n 0.4257 1200.0n 0.4255 1799.5n 0.4255 1800.0n 0.5747 2399.5n 0.5747)
Cwp_w25 wp_w25 0 400p
Cwn_w25 wn_w25 0 400p
Xu_w25 xp_w25 xn_w25 yp_w25 yn_w25 wp_w25 wn_w25 vdd gbn gprod
Vxp_o5 xp_o5 0 PWL(0.0n 0.5957 599.5n 0.5957 600.0n 0.5743 1199.5n 0.5743 1200.0n 0.5745 1799.5n 0.5745 1800.0n 0.4253 2399.5n 0.4253)
Vxn_o5 xn_o5 0 PWL(0.0n 0.4043 599.5n 0.4043 600.0n 0.4257 1199.5n 0.4257 1200.0n 0.4255 1799.5n 0.4255 1800.0n 0.5747 2399.5n 0.5747)
Vyp_o5 yp_o5 0 PWL(0.0n 0.4689 599.5n 0.4689 600.0n 0.5070 1199.5n 0.5070 1200.0n 0.5147 1799.5n 0.5147 1800.0n 0.4865 2399.5n 0.4865)
Vyn_o5 yn_o5 0 PWL(0.0n 0.5311 599.5n 0.5311 600.0n 0.4930 1199.5n 0.4930 1200.0n 0.4853 1799.5n 0.4853 1800.0n 0.5135 2399.5n 0.5135)
Cwp_o5 wp_o5 0 400p
Cwn_o5 wn_o5 0 400p
Xu_o5 xp_o5 xn_o5 yp_o5 yn_o5 wp_o5 wn_o5 vdd gbn gprod
Vxp_bh5 xp_bh5 0 PWL(0.0n 0.7100 599.5n 0.7100 600.0n 0.7100 1199.5n 0.7100 1200.0n 0.7100 1799.5n 0.7100 1800.0n 0.7100 2399.5n 0.7100)
Vxn_bh5 xn_bh5 0 PWL(0.0n 0.2900 599.5n 0.2900 600.0n 0.2900 1199.5n 0.2900 1200.0n 0.2900 1799.5n 0.2900 1800.0n 0.2900 2399.5n 0.2900)
Vyp_bh5 yp_bh5 0 PWL(0.0n 0.5957 599.5n 0.5957 600.0n 0.5743 1199.5n 0.5743 1200.0n 0.5745 1799.5n 0.5745 1800.0n 0.4253 2399.5n 0.4253)
Vyn_bh5 yn_bh5 0 PWL(0.0n 0.4043 599.5n 0.4043 600.0n 0.4257 1199.5n 0.4257 1200.0n 0.4255 1799.5n 0.4255 1800.0n 0.5747 2399.5n 0.5747)
Cwp_bh5 wp_bh5 0 400p
Cwn_bh5 wn_bh5 0 400p
Xu_bh5 xp_bh5 xn_bh5 yp_bh5 yn_bh5 wp_bh5 wn_bh5 vdd gbn gprod
Vxp_w16 xp_w16 0 PWL(0.0n 0.2900 599.5n 0.2900 600.0n 0.2900 1199.5n 0.2900 1200.0n 0.7100 1799.5n 0.7100 1800.0n 0.7100 2399.5n 0.7100)
Vxn_w16 xn_w16 0 PWL(0.0n 0.7100 599.5n 0.7100 600.0n 0.7100 1199.5n 0.7100 1200.0n 0.2900 1799.5n 0.2900 1800.0n 0.2900 2399.5n 0.2900)
Vyp_w16 yp_w16 0 PWL(0.0n 0.4142 599.5n 0.4142 600.0n 0.3882 1199.5n 0.3882 1200.0n 0.5930 1799.5n 0.5930 1800.0n 0.4094 2399.5n 0.4094)
Vyn_w16 yn_w16 0 PWL(0.0n 0.5858 599.5n 0.5858 600.0n 0.6118 1199.5n 0.6118 1200.0n 0.4070 1799.5n 0.4070 1800.0n 0.5906 2399.5n 0.5906)
Cwp_w16 wp_w16 0 400p
Cwn_w16 wn_w16 0 400p
Xu_w16 xp_w16 xn_w16 yp_w16 yn_w16 wp_w16 wn_w16 vdd gbn gprod
Vxp_w26 xp_w26 0 PWL(0.0n 0.2900 599.5n 0.2900 600.0n 0.7100 1199.5n 0.7100 1200.0n 0.2900 1799.5n 0.2900 1800.0n 0.7100 2399.5n 0.7100)
Vxn_w26 xn_w26 0 PWL(0.0n 0.7100 599.5n 0.7100 600.0n 0.2900 1199.5n 0.2900 1200.0n 0.7100 1799.5n 0.7100 1800.0n 0.2900 2399.5n 0.2900)
Vyp_w26 yp_w26 0 PWL(0.0n 0.4142 599.5n 0.4142 600.0n 0.3882 1199.5n 0.3882 1200.0n 0.5930 1799.5n 0.5930 1800.0n 0.4094 2399.5n 0.4094)
Vyn_w26 yn_w26 0 PWL(0.0n 0.5858 599.5n 0.5858 600.0n 0.6118 1199.5n 0.6118 1200.0n 0.4070 1799.5n 0.4070 1800.0n 0.5906 2399.5n 0.5906)
Cwp_w26 wp_w26 0 400p
Cwn_w26 wn_w26 0 400p
Xu_w26 xp_w26 xn_w26 yp_w26 yn_w26 wp_w26 wn_w26 vdd gbn gprod
Vxp_o6 xp_o6 0 PWL(0.0n 0.4142 599.5n 0.4142 600.0n 0.3882 1199.5n 0.3882 1200.0n 0.5930 1799.5n 0.5930 1800.0n 0.4094 2399.5n 0.4094)
Vxn_o6 xn_o6 0 PWL(0.0n 0.5858 599.5n 0.5858 600.0n 0.6118 1199.5n 0.6118 1200.0n 0.4070 1799.5n 0.4070 1800.0n 0.5906 2399.5n 0.5906)
Vyp_o6 yp_o6 0 PWL(0.0n 0.4689 599.5n 0.4689 600.0n 0.5070 1199.5n 0.5070 1200.0n 0.5147 1799.5n 0.5147 1800.0n 0.4865 2399.5n 0.4865)
Vyn_o6 yn_o6 0 PWL(0.0n 0.5311 599.5n 0.5311 600.0n 0.4930 1199.5n 0.4930 1200.0n 0.4853 1799.5n 0.4853 1800.0n 0.5135 2399.5n 0.5135)
Cwp_o6 wp_o6 0 400p
Cwn_o6 wn_o6 0 400p
Xu_o6 xp_o6 xn_o6 yp_o6 yn_o6 wp_o6 wn_o6 vdd gbn gprod
Vxp_bh6 xp_bh6 0 PWL(0.0n 0.7100 599.5n 0.7100 600.0n 0.7100 1199.5n 0.7100 1200.0n 0.7100 1799.5n 0.7100 1800.0n 0.7100 2399.5n 0.7100)
Vxn_bh6 xn_bh6 0 PWL(0.0n 0.2900 599.5n 0.2900 600.0n 0.2900 1199.5n 0.2900 1200.0n 0.2900 1799.5n 0.2900 1800.0n 0.2900 2399.5n 0.2900)
Vyp_bh6 yp_bh6 0 PWL(0.0n 0.4142 599.5n 0.4142 600.0n 0.3882 1199.5n 0.3882 1200.0n 0.5930 1799.5n 0.5930 1800.0n 0.4094 2399.5n 0.4094)
Vyn_bh6 yn_bh6 0 PWL(0.0n 0.5858 599.5n 0.5858 600.0n 0.6118 1199.5n 0.6118 1200.0n 0.4070 1799.5n 0.4070 1800.0n 0.5906 2399.5n 0.5906)
Cwp_bh6 wp_bh6 0 400p
Cwn_bh6 wn_bh6 0 400p
Xu_bh6 xp_bh6 xn_bh6 yp_bh6 yn_bh6 wp_bh6 wn_bh6 vdd gbn gprod
Vxp_bo xp_bo 0 PWL(0.0n 0.7100 599.5n 0.7100 600.0n 0.7100 1199.5n 0.7100 1200.0n 0.7100 1799.5n 0.7100 1800.0n 0.7100 2399.5n 0.7100)
Vxn_bo xn_bo 0 PWL(0.0n 0.2900 599.5n 0.2900 600.0n 0.2900 1199.5n 0.2900 1200.0n 0.2900 1799.5n 0.2900 1800.0n 0.2900 2399.5n 0.2900)
Vyp_bo yp_bo 0 PWL(0.0n 0.4689 599.5n 0.4689 600.0n 0.5070 1199.5n 0.5070 1200.0n 0.5147 1799.5n 0.5147 1800.0n 0.4865 2399.5n 0.4865)
Vyn_bo yn_bo 0 PWL(0.0n 0.5311 599.5n 0.5311 600.0n 0.4930 1199.5n 0.4930 1200.0n 0.4853 1799.5n 0.4853 1800.0n 0.5135 2399.5n 0.5135)
Cwp_bo wp_bo 0 400p
Cwn_bo wn_bo 0 400p
Xu_bo xp_bo xn_bo yp_bo yn_bo wp_bo wn_bo vdd gbn gprod
.ic v(wp_w11)=0.5 v(wn_w11)=0.5
.ic v(wp_w21)=0.5 v(wn_w21)=0.5
.ic v(wp_o1)=0.5 v(wn_o1)=0.5
.ic v(wp_bh1)=0.5 v(wn_bh1)=0.5
.ic v(wp_w12)=0.5 v(wn_w12)=0.5
.ic v(wp_w22)=0.5 v(wn_w22)=0.5
.ic v(wp_o2)=0.5 v(wn_o2)=0.5
.ic v(wp_bh2)=0.5 v(wn_bh2)=0.5
.ic v(wp_w13)=0.5 v(wn_w13)=0.5
.ic v(wp_w23)=0.5 v(wn_w23)=0.5
.ic v(wp_o3)=0.5 v(wn_o3)=0.5
.ic v(wp_bh3)=0.5 v(wn_bh3)=0.5
.ic v(wp_w14)=0.5 v(wn_w14)=0.5
.ic v(wp_w24)=0.5 v(wn_w24)=0.5
.ic v(wp_o4)=0.5 v(wn_o4)=0.5
.ic v(wp_bh4)=0.5 v(wn_bh4)=0.5
.ic v(wp_w15)=0.5 v(wn_w15)=0.5
.ic v(wp_w25)=0.5 v(wn_w25)=0.5
.ic v(wp_o5)=0.5 v(wn_o5)=0.5
.ic v(wp_bh5)=0.5 v(wn_bh5)=0.5
.ic v(wp_w16)=0.5 v(wn_w16)=0.5
.ic v(wp_w26)=0.5 v(wn_w26)=0.5
.ic v(wp_o6)=0.5 v(wn_o6)=0.5
.ic v(wp_bh6)=0.5 v(wn_bh6)=0.5
.ic v(wp_bo)=0.5 v(wn_bo)=0.5
.tran 1n 2400n uic
.control
run
wrdata puph20.dat v(wp_w11) v(wn_w11) v(wp_w21) v(wn_w21) v(wp_o1) v(wn_o1) v(wp_bh1) v(wn_bh1) v(wp_w12) v(wn_w12) v(wp_w22) v(wn_w22) v(wp_o2) v(wn_o2) v(wp_bh2) v(wn_bh2) v(wp_w13) v(wn_w13) v(wp_w23) v(wn_w23) v(wp_o3) v(wn_o3) v(wp_bh3) v(wn_bh3) v(wp_w14) v(wn_w14) v(wp_w24) v(wn_w24) v(wp_o4) v(wn_o4) v(wp_bh4) v(wn_bh4) v(wp_w15) v(wn_w15) v(wp_w25) v(wn_w25) v(wp_o5) v(wn_o5) v(wp_bh5) v(wn_bh5) v(wp_w16) v(wn_w16) v(wp_w26) v(wn_w26) v(wp_o6) v(wn_o6) v(wp_bh6) v(wn_bh6) v(wp_bo) v(wn_bo)
.endc
.end
