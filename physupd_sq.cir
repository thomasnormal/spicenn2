physical EP update cell bank
.model NNR NMOS (LEVEL=1 VTO=0.2  KP=120u LAMBDA=0.02 GAMMA=0 PHI=0.7)
.model PNR PMOS (LEVEL=1 VTO=-0.2 KP=40u  LAMBDA=0.02 GAMMA=0 PHI=0.7)
.subckt sqd dvp dvn wp wn psig psigb vdd vsref
Msq1 isum dvp vsref 0 NNR W=400u L=100u
Msq2 isum dvn vsref 0 NNR W=400u L=100u
Mld  isum isum vdd vdd PNR W=300u L=100u
Mpsrc psrc isum vdd vdd PNR W=300u L=100u
Mpref nref isum vdd vdd PNR W=300u L=100u
Mnref nref nref 0 0 NNR W=300u L=100u
Mpu_wp psrc psigb wp 0 NNR W=400u L=100u
Mpu_wn psrc psig  wn 0 NNR W=400u L=100u
Msk_wn wn nref ssn 0 NNR W=300u L=100u
Mss_wn ssn psigb 0 0 NNR W=400u L=100u
Msk_wp wp nref ssp 0 NNR W=300u L=100u
Mss_wp ssp psig 0 0 NNR W=400u L=100u
.ends
Vdd vdd 0 1.0
Vgbn gbn 0 0.85
Vvsref vsref 0 0.0500
Vpsig psig 0 PWL(0.0n 0.0 199.5n 0.0 200.5n 2.0 399.5n 2.0 400.5n 0.0 599.5n 0.0 600.5n 2.0 799.5n 2.0 800.5n 0.0 999.5n 0.0 1000.5n 2.0 1199.5n 2.0 1200.5n 0.0 1399.5n 0.0 1400.5n 2.0 1599.5n 2.0 1600.5n 0.0)
Vpsigb psigb 0 PWL(0.0n 2.0 199.5n 2.0 200.5n 0.0 399.5n 0.0 400.5n 2.0 599.5n 2.0 600.5n 0.0 799.5n 0.0 800.5n 2.0 999.5n 2.0 1000.5n 0.0 1199.5n 0.0 1200.5n 2.0 1399.5n 2.0 1400.5n 0.0 1599.5n 0.0 1600.5n 2.0)
Cwp_w11 wp_w11 0 120p
Cwn_w11 wn_w11 0 120p
Rcp_w11 wp_w11 cm_w11 2g
Rcn_w11 wn_w11 cm_w11 2g
Msp_w11 wp_w11 cm_w11 0 0 NNR W=120u L=100u
Msn_w11 wn_w11 cm_w11 0 0 NNR W=120u L=100u
Vdvp_w11 dvp_w11 0 PWL(0.0n 0.1855 199.5n 0.1855 200.5n 0.1854 400.0n 0.1854 400.0n 0.2775 599.5n 0.2775 600.5n 0.2773 800.0n 0.2773 800.0n 0.9200 999.5n 0.9200 1000.5n 0.9200 1200.0n 0.9200 1200.0n 0.9200 1399.5n 0.9200 1400.5n 0.9200 1600.0n 0.9200)
Vdvn_w11 dvn_w11 0 PWL(0.0n 0.8145 199.5n 0.8145 200.5n 0.8146 400.0n 0.8146 400.0n 0.7225 599.5n 0.7225 600.5n 0.7227 800.0n 0.7227 800.0n 0.0800 999.5n 0.0800 1000.5n 0.0800 1200.0n 0.0800 1200.0n 0.0800 1399.5n 0.0800 1400.5n 0.0800 1600.0n 0.0800)
Xu_w11 dvp_w11 dvn_w11 wp_w11 wn_w11 psig psigb vdd vsref sqd
Cwp_w21 wp_w21 0 120p
Cwn_w21 wn_w21 0 120p
Rcp_w21 wp_w21 cm_w21 2g
Rcn_w21 wn_w21 cm_w21 2g
Msp_w21 wp_w21 cm_w21 0 0 NNR W=120u L=100u
Msn_w21 wn_w21 cm_w21 0 0 NNR W=120u L=100u
Vdvp_w21 dvp_w21 0 PWL(0.0n 0.1855 199.5n 0.1855 200.5n 0.1854 400.0n 0.1854 400.0n 0.9200 599.5n 0.9200 600.5n 0.9200 800.0n 0.9200 800.0n 0.0850 999.5n 0.0850 1000.5n 0.0850 1200.0n 0.0850 1200.0n 0.9200 1399.5n 0.9200 1400.5n 0.9200 1600.0n 0.9200)
Vdvn_w21 dvn_w21 0 PWL(0.0n 0.8145 199.5n 0.8145 200.5n 0.8146 400.0n 0.8146 400.0n 0.0800 599.5n 0.0800 600.5n 0.0800 800.0n 0.0800 800.0n 0.9150 999.5n 0.9150 1000.5n 0.9150 1200.0n 0.9150 1200.0n 0.0800 1399.5n 0.0800 1400.5n 0.0800 1600.0n 0.0800)
Xu_w21 dvp_w21 dvn_w21 wp_w21 wn_w21 psig psigb vdd vsref sqd
Cwp_o1 wp_o1 0 120p
Cwn_o1 wn_o1 0 120p
Rcp_o1 wp_o1 cm_o1 2g
Rcn_o1 wn_o1 cm_o1 2g
Msp_o1 wp_o1 cm_o1 0 0 NNR W=120u L=100u
Msn_o1 wn_o1 cm_o1 0 0 NNR W=120u L=100u
Vdvp_o1 dvp_o1 0 PWL(0.0n 0.3904 199.5n 0.3904 200.5n 0.3916 400.0n 0.3916 400.0n 0.2756 599.5n 0.2756 600.5n 0.2747 800.0n 0.2747 800.0n 0.4912 999.5n 0.4912 1000.5n 0.4900 1200.0n 0.4900 1200.0n 0.3804 1399.5n 0.3804 1400.5n 0.3816 1600.0n 0.3816)
Vdvn_o1 dvn_o1 0 PWL(0.0n 0.6096 199.5n 0.6096 200.5n 0.6084 400.0n 0.6084 400.0n 0.7244 599.5n 0.7244 600.5n 0.7253 800.0n 0.7253 800.0n 0.5088 999.5n 0.5088 1000.5n 0.5100 1200.0n 0.5100 1200.0n 0.6196 1399.5n 0.6196 1400.5n 0.6184 1600.0n 0.6184)
Xu_o1 dvp_o1 dvn_o1 wp_o1 wn_o1 psig psigb vdd vsref sqd
Cwp_bh1 wp_bh1 0 120p
Cwn_bh1 wn_bh1 0 120p
Rcp_bh1 wp_bh1 cm_bh1 2g
Rcn_bh1 wn_bh1 cm_bh1 2g
Msp_bh1 wp_bh1 cm_bh1 0 0 NNR W=120u L=100u
Msn_bh1 wn_bh1 cm_bh1 0 0 NNR W=120u L=100u
Vdvp_bh1 dvp_bh1 0 PWL(0.0n 0.9200 199.5n 0.9200 200.5n 0.9200 400.0n 0.9200 400.0n 0.9200 599.5n 0.9200 600.5n 0.9200 800.0n 0.9200 800.0n 0.9200 999.5n 0.9200 1000.5n 0.9200 1200.0n 0.9200 1200.0n 0.9200 1399.5n 0.9200 1400.5n 0.9200 1600.0n 0.9200)
Vdvn_bh1 dvn_bh1 0 PWL(0.0n 0.0800 199.5n 0.0800 200.5n 0.0800 400.0n 0.0800 400.0n 0.0800 599.5n 0.0800 600.5n 0.0800 800.0n 0.0800 800.0n 0.0800 999.5n 0.0800 1000.5n 0.0800 1200.0n 0.0800 1200.0n 0.0800 1399.5n 0.0800 1400.5n 0.0800 1600.0n 0.0800)
Xu_bh1 dvp_bh1 dvn_bh1 wp_bh1 wn_bh1 psig psigb vdd vsref sqd
Cwp_w12 wp_w12 0 120p
Cwn_w12 wn_w12 0 120p
Rcp_w12 wp_w12 cm_w12 2g
Rcn_w12 wn_w12 cm_w12 2g
Msp_w12 wp_w12 cm_w12 0 0 NNR W=120u L=100u
Msn_w12 wn_w12 cm_w12 0 0 NNR W=120u L=100u
Vdvp_w12 dvp_w12 0 PWL(0.0n 0.2419 199.5n 0.2419 200.5n 0.2418 400.0n 0.2418 400.0n 0.2843 599.5n 0.2843 600.5n 0.2841 800.0n 0.2841 800.0n 0.8886 999.5n 0.8886 1000.5n 0.8886 1200.0n 0.8886 1200.0n 0.9200 1399.5n 0.9200 1400.5n 0.9200 1600.0n 0.9200)
Vdvn_w12 dvn_w12 0 PWL(0.0n 0.7581 199.5n 0.7581 200.5n 0.7582 400.0n 0.7582 400.0n 0.7157 599.5n 0.7157 600.5n 0.7159 800.0n 0.7159 800.0n 0.1114 999.5n 0.1114 1000.5n 0.1114 1200.0n 0.1114 1200.0n 0.0800 1399.5n 0.0800 1400.5n 0.0800 1600.0n 0.0800)
Xu_w12 dvp_w12 dvn_w12 wp_w12 wn_w12 psig psigb vdd vsref sqd
Cwp_w22 wp_w22 0 120p
Cwn_w22 wn_w22 0 120p
Rcp_w22 wp_w22 cm_w22 2g
Rcn_w22 wn_w22 cm_w22 2g
Msp_w22 wp_w22 cm_w22 0 0 NNR W=120u L=100u
Msn_w22 wn_w22 cm_w22 0 0 NNR W=120u L=100u
Vdvp_w22 dvp_w22 0 PWL(0.0n 0.2419 199.5n 0.2419 200.5n 0.2418 400.0n 0.2418 400.0n 0.9200 599.5n 0.9200 600.5n 0.9200 800.0n 0.9200 800.0n 0.0800 999.5n 0.0800 1000.5n 0.0800 1200.0n 0.0800 1200.0n 0.9200 1399.5n 0.9200 1400.5n 0.9200 1600.0n 0.9200)
Vdvn_w22 dvn_w22 0 PWL(0.0n 0.7581 199.5n 0.7581 200.5n 0.7582 400.0n 0.7582 400.0n 0.0800 599.5n 0.0800 600.5n 0.0800 800.0n 0.0800 800.0n 0.9200 999.5n 0.9200 1000.5n 0.9200 1200.0n 0.9200 1200.0n 0.0800 1399.5n 0.0800 1400.5n 0.0800 1600.0n 0.0800)
Xu_w22 dvp_w22 dvn_w22 wp_w22 wn_w22 psig psigb vdd vsref sqd
Cwp_o2 wp_o2 0 120p
Cwn_o2 wn_o2 0 120p
Rcp_o2 wp_o2 cm_o2 2g
Rcn_o2 wn_o2 cm_o2 2g
Msp_o2 wp_o2 cm_o2 0 0 NNR W=120u L=100u
Msn_o2 wn_o2 cm_o2 0 0 NNR W=120u L=100u
Vdvp_o2 dvp_o2 0 PWL(0.0n 0.3340 199.5n 0.3340 200.5n 0.3352 400.0n 0.3352 400.0n 0.2688 599.5n 0.2688 600.5n 0.2679 800.0n 0.2679 800.0n 0.5876 999.5n 0.5876 1000.5n 0.5863 1200.0n 0.5863 1200.0n 0.5279 1399.5n 0.5279 1400.5n 0.5289 1600.0n 0.5289)
Vdvn_o2 dvn_o2 0 PWL(0.0n 0.6660 199.5n 0.6660 200.5n 0.6648 400.0n 0.6648 400.0n 0.7312 599.5n 0.7312 600.5n 0.7321 800.0n 0.7321 800.0n 0.4124 999.5n 0.4124 1000.5n 0.4137 1200.0n 0.4137 1200.0n 0.4721 1399.5n 0.4721 1400.5n 0.4711 1600.0n 0.4711)
Xu_o2 dvp_o2 dvn_o2 wp_o2 wn_o2 psig psigb vdd vsref sqd
Cwp_bh2 wp_bh2 0 120p
Cwn_bh2 wn_bh2 0 120p
Rcp_bh2 wp_bh2 cm_bh2 2g
Rcn_bh2 wn_bh2 cm_bh2 2g
Msp_bh2 wp_bh2 cm_bh2 0 0 NNR W=120u L=100u
Msn_bh2 wn_bh2 cm_bh2 0 0 NNR W=120u L=100u
Vdvp_bh2 dvp_bh2 0 PWL(0.0n 0.9200 199.5n 0.9200 200.5n 0.9200 400.0n 0.9200 400.0n 0.9200 599.5n 0.9200 600.5n 0.9200 800.0n 0.9200 800.0n 0.8886 999.5n 0.8886 1000.5n 0.8886 1200.0n 0.8886 1200.0n 0.9200 1399.5n 0.9200 1400.5n 0.9200 1600.0n 0.9200)
Vdvn_bh2 dvn_bh2 0 PWL(0.0n 0.0800 199.5n 0.0800 200.5n 0.0800 400.0n 0.0800 400.0n 0.0800 599.5n 0.0800 600.5n 0.0800 800.0n 0.0800 800.0n 0.1114 999.5n 0.1114 1000.5n 0.1114 1200.0n 0.1114 1200.0n 0.0800 1399.5n 0.0800 1400.5n 0.0800 1600.0n 0.0800)
Xu_bh2 dvp_bh2 dvn_bh2 wp_bh2 wn_bh2 psig psigb vdd vsref sqd
Cwp_w13 wp_w13 0 120p
Cwn_w13 wn_w13 0 120p
Rcp_w13 wp_w13 cm_w13 2g
Rcn_w13 wn_w13 cm_w13 2g
Msp_w13 wp_w13 cm_w13 0 0 NNR W=120u L=100u
Msn_w13 wn_w13 cm_w13 0 0 NNR W=120u L=100u
Vdvp_w13 dvp_w13 0 PWL(0.0n 0.0800 199.5n 0.0800 200.5n 0.0800 400.0n 0.0800 400.0n 0.4577 599.5n 0.4577 600.5n 0.4578 800.0n 0.4578 800.0n 0.8110 999.5n 0.8110 1000.5n 0.8113 1200.0n 0.8113 1200.0n 0.9200 1399.5n 0.9200 1400.5n 0.9200 1600.0n 0.9200)
Vdvn_w13 dvn_w13 0 PWL(0.0n 0.9200 199.5n 0.9200 200.5n 0.9200 400.0n 0.9200 400.0n 0.5423 599.5n 0.5423 600.5n 0.5422 800.0n 0.5422 800.0n 0.1890 999.5n 0.1890 1000.5n 0.1887 1200.0n 0.1887 1200.0n 0.0800 1399.5n 0.0800 1400.5n 0.0800 1600.0n 0.0800)
Xu_w13 dvp_w13 dvn_w13 wp_w13 wn_w13 psig psigb vdd vsref sqd
Cwp_w23 wp_w23 0 120p
Cwn_w23 wn_w23 0 120p
Rcp_w23 wp_w23 cm_w23 2g
Rcn_w23 wn_w23 cm_w23 2g
Msp_w23 wp_w23 cm_w23 0 0 NNR W=120u L=100u
Msn_w23 wn_w23 cm_w23 0 0 NNR W=120u L=100u
Vdvp_w23 dvp_w23 0 PWL(0.0n 0.0800 199.5n 0.0800 200.5n 0.0800 400.0n 0.0800 400.0n 0.9200 599.5n 0.9200 600.5n 0.9200 800.0n 0.9200 800.0n 0.0800 999.5n 0.0800 1000.5n 0.0800 1200.0n 0.0800 1200.0n 0.9200 1399.5n 0.9200 1400.5n 0.9200 1600.0n 0.9200)
Vdvn_w23 dvn_w23 0 PWL(0.0n 0.9200 199.5n 0.9200 200.5n 0.9200 400.0n 0.9200 400.0n 0.0800 599.5n 0.0800 600.5n 0.0800 800.0n 0.0800 800.0n 0.9200 999.5n 0.9200 1000.5n 0.9200 1200.0n 0.9200 1200.0n 0.0800 1399.5n 0.0800 1400.5n 0.0800 1600.0n 0.0800)
Xu_w23 dvp_w23 dvn_w23 wp_w23 wn_w23 psig psigb vdd vsref sqd
Cwp_o3 wp_o3 0 120p
Cwn_o3 wn_o3 0 120p
Rcp_o3 wp_o3 cm_o3 2g
Rcn_o3 wn_o3 cm_o3 2g
Msp_o3 wp_o3 cm_o3 0 0 NNR W=120u L=100u
Msn_o3 wn_o3 cm_o3 0 0 NNR W=120u L=100u
Vdvp_o3 dvp_o3 0 PWL(0.0n 0.7375 199.5n 0.7375 200.5n 0.7386 400.0n 0.7386 400.0n 0.0954 599.5n 0.0954 600.5n 0.0942 800.0n 0.0942 800.0n 0.6653 999.5n 0.6653 1000.5n 0.6637 1200.0n 0.6637 1200.0n 0.0913 1399.5n 0.0913 1400.5n 0.0922 1600.0n 0.0922)
Vdvn_o3 dvn_o3 0 PWL(0.0n 0.2625 199.5n 0.2625 200.5n 0.2614 400.0n 0.2614 400.0n 0.9046 599.5n 0.9046 600.5n 0.9058 800.0n 0.9058 800.0n 0.3347 999.5n 0.3347 1000.5n 0.3363 1200.0n 0.3363 1200.0n 0.9087 1399.5n 0.9087 1400.5n 0.9078 1600.0n 0.9078)
Xu_o3 dvp_o3 dvn_o3 wp_o3 wn_o3 psig psigb vdd vsref sqd
Cwp_bh3 wp_bh3 0 120p
Cwn_bh3 wn_bh3 0 120p
Rcp_bh3 wp_bh3 cm_bh3 2g
Rcn_bh3 wn_bh3 cm_bh3 2g
Msp_bh3 wp_bh3 cm_bh3 0 0 NNR W=120u L=100u
Msn_bh3 wn_bh3 cm_bh3 0 0 NNR W=120u L=100u
Vdvp_bh3 dvp_bh3 0 PWL(0.0n 0.7384 199.5n 0.7384 200.5n 0.7384 400.0n 0.7384 400.0n 0.9200 599.5n 0.9200 600.5n 0.9200 800.0n 0.9200 800.0n 0.8110 999.5n 0.8110 1000.5n 0.8113 1200.0n 0.8113 1200.0n 0.9200 1399.5n 0.9200 1400.5n 0.9200 1600.0n 0.9200)
Vdvn_bh3 dvn_bh3 0 PWL(0.0n 0.2616 199.5n 0.2616 200.5n 0.2616 400.0n 0.2616 400.0n 0.0800 599.5n 0.0800 600.5n 0.0800 800.0n 0.0800 800.0n 0.1890 999.5n 0.1890 1000.5n 0.1887 1200.0n 0.1887 1200.0n 0.0800 1399.5n 0.0800 1400.5n 0.0800 1600.0n 0.0800)
Xu_bh3 dvp_bh3 dvn_bh3 wp_bh3 wn_bh3 psig psigb vdd vsref sqd
Cwp_w14 wp_w14 0 120p
Cwn_w14 wn_w14 0 120p
Rcp_w14 wp_w14 cm_w14 2g
Rcn_w14 wn_w14 cm_w14 2g
Msp_w14 wp_w14 cm_w14 0 0 NNR W=120u L=100u
Msn_w14 wn_w14 cm_w14 0 0 NNR W=120u L=100u
Vdvp_w14 dvp_w14 0 PWL(0.0n 0.4370 199.5n 0.4370 200.5n 0.4371 400.0n 0.4371 400.0n 0.4064 599.5n 0.4064 600.5n 0.4064 800.0n 0.4064 800.0n 0.7496 999.5n 0.7496 1000.5n 0.7496 1200.0n 0.7496 1200.0n 0.6414 1399.5n 0.6414 1400.5n 0.6418 1600.0n 0.6418)
Vdvn_w14 dvn_w14 0 PWL(0.0n 0.5630 199.5n 0.5630 200.5n 0.5629 400.0n 0.5629 400.0n 0.5936 599.5n 0.5936 600.5n 0.5936 800.0n 0.5936 800.0n 0.2504 999.5n 0.2504 1000.5n 0.2504 1200.0n 0.2504 1200.0n 0.3586 1399.5n 0.3586 1400.5n 0.3582 1600.0n 0.3582)
Xu_w14 dvp_w14 dvn_w14 wp_w14 wn_w14 psig psigb vdd vsref sqd
Cwp_w24 wp_w24 0 120p
Cwn_w24 wn_w24 0 120p
Rcp_w24 wp_w24 cm_w24 2g
Rcn_w24 wn_w24 cm_w24 2g
Msp_w24 wp_w24 cm_w24 0 0 NNR W=120u L=100u
Msn_w24 wn_w24 cm_w24 0 0 NNR W=120u L=100u
Vdvp_w24 dvp_w24 0 PWL(0.0n 0.4370 199.5n 0.4370 200.5n 0.4371 400.0n 0.4371 400.0n 0.9200 599.5n 0.9200 600.5n 0.9200 800.0n 0.9200 800.0n 0.0800 999.5n 0.0800 1000.5n 0.0800 1200.0n 0.0800 1200.0n 0.6414 1399.5n 0.6414 1400.5n 0.6418 1600.0n 0.6418)
Vdvn_w24 dvn_w24 0 PWL(0.0n 0.5630 199.5n 0.5630 200.5n 0.5629 400.0n 0.5629 400.0n 0.0800 599.5n 0.0800 600.5n 0.0800 800.0n 0.0800 800.0n 0.9200 999.5n 0.9200 1000.5n 0.9200 1200.0n 0.9200 1200.0n 0.3586 1399.5n 0.3586 1400.5n 0.3582 1600.0n 0.3582)
Xu_w24 dvp_w24 dvn_w24 wp_w24 wn_w24 psig psigb vdd vsref sqd
Cwp_o4 wp_o4 0 120p
Cwn_o4 wn_o4 0 120p
Rcp_o4 wp_o4 cm_o4 2g
Rcn_o4 wn_o4 cm_o4 2g
Msp_o4 wp_o4 cm_o4 0 0 NNR W=120u L=100u
Msn_o4 wn_o4 cm_o4 0 0 NNR W=120u L=100u
Vdvp_o4 dvp_o4 0 PWL(0.0n 0.1389 199.5n 0.1389 200.5n 0.1398 400.0n 0.1398 400.0n 0.1466 599.5n 0.1466 600.5n 0.1456 800.0n 0.1456 800.0n 0.7267 999.5n 0.7267 1000.5n 0.7253 1200.0n 0.7253 1200.0n 0.8168 1399.5n 0.8168 1400.5n 0.8175 1600.0n 0.8175)
Vdvn_o4 dvn_o4 0 PWL(0.0n 0.8611 199.5n 0.8611 200.5n 0.8602 400.0n 0.8602 400.0n 0.8534 599.5n 0.8534 600.5n 0.8544 800.0n 0.8544 800.0n 0.2733 999.5n 0.2733 1000.5n 0.2747 1200.0n 0.2747 1200.0n 0.1832 1399.5n 0.1832 1400.5n 0.1825 1600.0n 0.1825)
Xu_o4 dvp_o4 dvn_o4 wp_o4 wn_o4 psig psigb vdd vsref sqd
Cwp_bh4 wp_bh4 0 120p
Cwn_bh4 wn_bh4 0 120p
Rcp_bh4 wp_bh4 cm_bh4 2g
Rcn_bh4 wn_bh4 cm_bh4 2g
Msp_bh4 wp_bh4 cm_bh4 0 0 NNR W=120u L=100u
Msn_bh4 wn_bh4 cm_bh4 0 0 NNR W=120u L=100u
Vdvp_bh4 dvp_bh4 0 PWL(0.0n 0.9200 199.5n 0.9200 200.5n 0.9200 400.0n 0.9200 400.0n 0.9200 599.5n 0.9200 600.5n 0.9200 800.0n 0.9200 800.0n 0.7496 999.5n 0.7496 1000.5n 0.7496 1200.0n 0.7496 1200.0n 0.6414 1399.5n 0.6414 1400.5n 0.6418 1600.0n 0.6418)
Vdvn_bh4 dvn_bh4 0 PWL(0.0n 0.0800 199.5n 0.0800 200.5n 0.0800 400.0n 0.0800 400.0n 0.0800 599.5n 0.0800 600.5n 0.0800 800.0n 0.0800 800.0n 0.2504 999.5n 0.2504 1000.5n 0.2504 1200.0n 0.2504 1200.0n 0.3586 1399.5n 0.3586 1400.5n 0.3582 1600.0n 0.3582)
Xu_bh4 dvp_bh4 dvn_bh4 wp_bh4 wn_bh4 psig psigb vdd vsref sqd
Cwp_w15 wp_w15 0 120p
Cwn_w15 wn_w15 0 120p
Rcp_w15 wp_w15 cm_w15 2g
Rcn_w15 wn_w15 cm_w15 2g
Msp_w15 wp_w15 cm_w15 0 0 NNR W=120u L=100u
Msn_w15 wn_w15 cm_w15 0 0 NNR W=120u L=100u
Vdvp_w15 dvp_w15 0 PWL(0.0n 0.0800 199.5n 0.0800 200.5n 0.0800 400.0n 0.0800 400.0n 0.4003 599.5n 0.4003 600.5n 0.4004 800.0n 0.4004 800.0n 0.5217 999.5n 0.5217 1000.5n 0.5216 1200.0n 0.5216 1200.0n 0.5832 1399.5n 0.5832 1400.5n 0.5831 1600.0n 0.5831)
Vdvn_w15 dvn_w15 0 PWL(0.0n 0.9200 199.5n 0.9200 200.5n 0.9200 400.0n 0.9200 400.0n 0.5997 599.5n 0.5997 600.5n 0.5996 800.0n 0.5996 800.0n 0.4783 999.5n 0.4783 1000.5n 0.4784 1200.0n 0.4784 1200.0n 0.4168 1399.5n 0.4168 1400.5n 0.4169 1600.0n 0.4169)
Xu_w15 dvp_w15 dvn_w15 wp_w15 wn_w15 psig psigb vdd vsref sqd
Cwp_w25 wp_w25 0 120p
Cwn_w25 wn_w25 0 120p
Rcp_w25 wp_w25 cm_w25 2g
Rcn_w25 wn_w25 cm_w25 2g
Msp_w25 wp_w25 cm_w25 0 0 NNR W=120u L=100u
Msn_w25 wn_w25 cm_w25 0 0 NNR W=120u L=100u
Vdvp_w25 dvp_w25 0 PWL(0.0n 0.0800 199.5n 0.0800 200.5n 0.0800 400.0n 0.0800 400.0n 0.9200 599.5n 0.9200 600.5n 0.9200 800.0n 0.9200 800.0n 0.0800 999.5n 0.0800 1000.5n 0.0800 1200.0n 0.0800 1200.0n 0.5832 1399.5n 0.5832 1400.5n 0.5831 1600.0n 0.5831)
Vdvn_w25 dvn_w25 0 PWL(0.0n 0.9200 199.5n 0.9200 200.5n 0.9200 400.0n 0.9200 400.0n 0.0800 599.5n 0.0800 600.5n 0.0800 800.0n 0.0800 800.0n 0.9200 999.5n 0.9200 1000.5n 0.9200 1200.0n 0.9200 1200.0n 0.4168 1399.5n 0.4168 1400.5n 0.4169 1600.0n 0.4169)
Xu_w25 dvp_w25 dvn_w25 wp_w25 wn_w25 psig psigb vdd vsref sqd
Cwp_o5 wp_o5 0 120p
Cwn_o5 wn_o5 0 120p
Rcp_o5 wp_o5 cm_o5 2g
Rcn_o5 wn_o5 cm_o5 2g
Msp_o5 wp_o5 cm_o5 0 0 NNR W=120u L=100u
Msn_o5 wn_o5 cm_o5 0 0 NNR W=120u L=100u
Vdvp_o5 dvp_o5 0 PWL(0.0n 0.5627 199.5n 0.5627 200.5n 0.5639 400.0n 0.5639 400.0n 0.1527 599.5n 0.1527 600.5n 0.1516 800.0n 0.1516 800.0n 0.9200 999.5n 0.9200 1000.5n 0.9200 1200.0n 0.9200 1200.0n 0.8750 1399.5n 0.8750 1400.5n 0.8762 1600.0n 0.8762)
Vdvn_o5 dvn_o5 0 PWL(0.0n 0.4373 199.5n 0.4373 200.5n 0.4361 400.0n 0.4361 400.0n 0.8473 599.5n 0.8473 600.5n 0.8484 800.0n 0.8484 800.0n 0.0800 999.5n 0.0800 1000.5n 0.0800 1200.0n 0.0800 1200.0n 0.1250 1399.5n 0.1250 1400.5n 0.1238 1600.0n 0.1238)
Xu_o5 dvp_o5 dvn_o5 wp_o5 wn_o5 psig psigb vdd vsref sqd
Cwp_bh5 wp_bh5 0 120p
Cwn_bh5 wn_bh5 0 120p
Rcp_bh5 wp_bh5 cm_bh5 2g
Rcn_bh5 wn_bh5 cm_bh5 2g
Msp_bh5 wp_bh5 cm_bh5 0 0 NNR W=120u L=100u
Msn_bh5 wn_bh5 cm_bh5 0 0 NNR W=120u L=100u
Vdvp_bh5 dvp_bh5 0 PWL(0.0n 0.9132 199.5n 0.9132 200.5n 0.9131 400.0n 0.9131 400.0n 0.9200 599.5n 0.9200 600.5n 0.9200 800.0n 0.9200 800.0n 0.5217 999.5n 0.5217 1000.5n 0.5216 1200.0n 0.5216 1200.0n 0.5832 1399.5n 0.5832 1400.5n 0.5831 1600.0n 0.5831)
Vdvn_bh5 dvn_bh5 0 PWL(0.0n 0.0868 199.5n 0.0868 200.5n 0.0869 400.0n 0.0869 400.0n 0.0800 599.5n 0.0800 600.5n 0.0800 800.0n 0.0800 800.0n 0.4783 999.5n 0.4783 1000.5n 0.4784 1200.0n 0.4784 1200.0n 0.4168 1399.5n 0.4168 1400.5n 0.4169 1600.0n 0.4169)
Xu_bh5 dvp_bh5 dvn_bh5 wp_bh5 wn_bh5 psig psigb vdd vsref sqd
Cwp_w16 wp_w16 0 120p
Cwn_w16 wn_w16 0 120p
Rcp_w16 wp_w16 cm_w16 2g
Rcn_w16 wn_w16 cm_w16 2g
Msp_w16 wp_w16 cm_w16 0 0 NNR W=120u L=100u
Msn_w16 wn_w16 cm_w16 0 0 NNR W=120u L=100u
Vdvp_w16 dvp_w16 0 PWL(0.0n 0.4144 199.5n 0.4144 200.5n 0.4144 400.0n 0.4144 400.0n 0.1835 599.5n 0.1835 600.5n 0.1834 800.0n 0.1834 800.0n 0.9200 999.5n 0.9200 1000.5n 0.9200 1200.0n 0.9200 1200.0n 0.7638 1399.5n 0.7638 1400.5n 0.7640 1600.0n 0.7640)
Vdvn_w16 dvn_w16 0 PWL(0.0n 0.5856 199.5n 0.5856 200.5n 0.5856 400.0n 0.5856 400.0n 0.8165 599.5n 0.8165 600.5n 0.8166 800.0n 0.8166 800.0n 0.0800 999.5n 0.0800 1000.5n 0.0800 1200.0n 0.0800 1200.0n 0.2362 1399.5n 0.2362 1400.5n 0.2360 1600.0n 0.2360)
Xu_w16 dvp_w16 dvn_w16 wp_w16 wn_w16 psig psigb vdd vsref sqd
Cwp_w26 wp_w26 0 120p
Cwn_w26 wn_w26 0 120p
Rcp_w26 wp_w26 cm_w26 2g
Rcn_w26 wn_w26 cm_w26 2g
Msp_w26 wp_w26 cm_w26 0 0 NNR W=120u L=100u
Msn_w26 wn_w26 cm_w26 0 0 NNR W=120u L=100u
Vdvp_w26 dvp_w26 0 PWL(0.0n 0.4144 199.5n 0.4144 200.5n 0.4144 400.0n 0.4144 400.0n 0.9200 599.5n 0.9200 600.5n 0.9200 800.0n 0.9200 800.0n 0.1227 999.5n 0.1227 1000.5n 0.1227 1200.0n 0.1227 1200.0n 0.7638 1399.5n 0.7638 1400.5n 0.7640 1600.0n 0.7640)
Vdvn_w26 dvn_w26 0 PWL(0.0n 0.5856 199.5n 0.5856 200.5n 0.5856 400.0n 0.5856 400.0n 0.0800 599.5n 0.0800 600.5n 0.0800 800.0n 0.0800 800.0n 0.8773 999.5n 0.8773 1000.5n 0.8773 1200.0n 0.8773 1200.0n 0.2362 1399.5n 0.2362 1400.5n 0.2360 1600.0n 0.2360)
Xu_w26 dvp_w26 dvn_w26 wp_w26 wn_w26 psig psigb vdd vsref sqd
Cwp_o6 wp_o6 0 120p
Cwn_o6 wn_o6 0 120p
Rcp_o6 wp_o6 cm_o6 2g
Rcn_o6 wn_o6 cm_o6 2g
Msp_o6 wp_o6 cm_o6 0 0 NNR W=120u L=100u
Msn_o6 wn_o6 cm_o6 0 0 NNR W=120u L=100u
Vdvp_o6 dvp_o6 0 PWL(0.0n 0.1616 199.5n 0.1616 200.5n 0.1626 400.0n 0.1626 400.0n 0.3695 599.5n 0.3695 600.5n 0.3686 800.0n 0.3686 800.0n 0.4535 999.5n 0.4535 1000.5n 0.4522 1200.0n 0.4522 1200.0n 0.6944 1399.5n 0.6944 1400.5n 0.6953 1600.0n 0.6953)
Vdvn_o6 dvn_o6 0 PWL(0.0n 0.8384 199.5n 0.8384 200.5n 0.8374 400.0n 0.8374 400.0n 0.6305 599.5n 0.6305 600.5n 0.6314 800.0n 0.6314 800.0n 0.5465 999.5n 0.5465 1000.5n 0.5478 1200.0n 0.5478 1200.0n 0.3056 1399.5n 0.3056 1400.5n 0.3047 1600.0n 0.3047)
Xu_o6 dvp_o6 dvn_o6 wp_o6 wn_o6 psig psigb vdd vsref sqd
Cwp_bh6 wp_bh6 0 120p
Cwn_bh6 wn_bh6 0 120p
Rcp_bh6 wp_bh6 cm_bh6 2g
Rcn_bh6 wn_bh6 cm_bh6 2g
Msp_bh6 wp_bh6 cm_bh6 0 0 NNR W=120u L=100u
Msn_bh6 wn_bh6 cm_bh6 0 0 NNR W=120u L=100u
Vdvp_bh6 dvp_bh6 0 PWL(0.0n 0.9200 199.5n 0.9200 200.5n 0.9200 400.0n 0.9200 400.0n 0.9200 599.5n 0.9200 600.5n 0.9200 800.0n 0.9200 800.0n 0.9200 999.5n 0.9200 1000.5n 0.9200 1200.0n 0.9200 1200.0n 0.7638 1399.5n 0.7638 1400.5n 0.7640 1600.0n 0.7640)
Vdvn_bh6 dvn_bh6 0 PWL(0.0n 0.0800 199.5n 0.0800 200.5n 0.0800 400.0n 0.0800 400.0n 0.0800 599.5n 0.0800 600.5n 0.0800 800.0n 0.0800 800.0n 0.0800 999.5n 0.0800 1000.5n 0.0800 1200.0n 0.0800 1200.0n 0.2362 1399.5n 0.2362 1400.5n 0.2360 1600.0n 0.2360)
Xu_bh6 dvp_bh6 dvn_bh6 wp_bh6 wn_bh6 psig psigb vdd vsref sqd
Cwp_bo wp_bo 0 120p
Cwn_bo wn_bo 0 120p
Rcp_bo wp_bo cm_bo 2g
Rcn_bo wn_bo cm_bo 2g
Msp_bo wp_bo cm_bo 0 0 NNR W=120u L=100u
Msn_bo wn_bo cm_bo 0 0 NNR W=120u L=100u
Vdvp_bo dvp_bo 0 PWL(0.0n 0.9200 199.5n 0.9200 200.5n 0.9200 400.0n 0.9200 400.0n 0.9200 599.5n 0.9200 600.5n 0.9200 800.0n 0.9200 800.0n 0.9200 999.5n 0.9200 1000.5n 0.9200 1200.0n 0.9200 1200.0n 0.9200 1399.5n 0.9200 1400.5n 0.9200 1600.0n 0.9200)
Vdvn_bo dvn_bo 0 PWL(0.0n 0.0800 199.5n 0.0800 200.5n 0.0800 400.0n 0.0800 400.0n 0.0800 599.5n 0.0800 600.5n 0.0800 800.0n 0.0800 800.0n 0.0800 999.5n 0.0800 1000.5n 0.0800 1200.0n 0.0800 1200.0n 0.0800 1399.5n 0.0800 1400.5n 0.0800 1600.0n 0.0800)
Xu_bo dvp_bo dvn_bo wp_bo wn_bo psig psigb vdd vsref sqd
.ic v(wp_w11)=0.5 v(wn_w11)=0.5 v(cm_w11)=0.5
.ic v(wp_w21)=0.5 v(wn_w21)=0.5 v(cm_w21)=0.5
.ic v(wp_o1)=0.5 v(wn_o1)=0.5 v(cm_o1)=0.5
.ic v(wp_bh1)=0.5 v(wn_bh1)=0.5 v(cm_bh1)=0.5
.ic v(wp_w12)=0.5 v(wn_w12)=0.5 v(cm_w12)=0.5
.ic v(wp_w22)=0.5 v(wn_w22)=0.5 v(cm_w22)=0.5
.ic v(wp_o2)=0.5 v(wn_o2)=0.5 v(cm_o2)=0.5
.ic v(wp_bh2)=0.5 v(wn_bh2)=0.5 v(cm_bh2)=0.5
.ic v(wp_w13)=0.5 v(wn_w13)=0.5 v(cm_w13)=0.5
.ic v(wp_w23)=0.5 v(wn_w23)=0.5 v(cm_w23)=0.5
.ic v(wp_o3)=0.5 v(wn_o3)=0.5 v(cm_o3)=0.5
.ic v(wp_bh3)=0.5 v(wn_bh3)=0.5 v(cm_bh3)=0.5
.ic v(wp_w14)=0.5 v(wn_w14)=0.5 v(cm_w14)=0.5
.ic v(wp_w24)=0.5 v(wn_w24)=0.5 v(cm_w24)=0.5
.ic v(wp_o4)=0.5 v(wn_o4)=0.5 v(cm_o4)=0.5
.ic v(wp_bh4)=0.5 v(wn_bh4)=0.5 v(cm_bh4)=0.5
.ic v(wp_w15)=0.5 v(wn_w15)=0.5 v(cm_w15)=0.5
.ic v(wp_w25)=0.5 v(wn_w25)=0.5 v(cm_w25)=0.5
.ic v(wp_o5)=0.5 v(wn_o5)=0.5 v(cm_o5)=0.5
.ic v(wp_bh5)=0.5 v(wn_bh5)=0.5 v(cm_bh5)=0.5
.ic v(wp_w16)=0.5 v(wn_w16)=0.5 v(cm_w16)=0.5
.ic v(wp_w26)=0.5 v(wn_w26)=0.5 v(cm_w26)=0.5
.ic v(wp_o6)=0.5 v(wn_o6)=0.5 v(cm_o6)=0.5
.ic v(wp_bh6)=0.5 v(wn_bh6)=0.5 v(cm_bh6)=0.5
.ic v(wp_bo)=0.5 v(wn_bo)=0.5 v(cm_bo)=0.5
.tran 1n 1600n uic
.control
run
wrdata pusq.dat v(wp_w11) v(wn_w11) v(wp_w21) v(wn_w21) v(wp_o1) v(wn_o1) v(wp_bh1) v(wn_bh1) v(wp_w12) v(wn_w12) v(wp_w22) v(wn_w22) v(wp_o2) v(wn_o2) v(wp_bh2) v(wn_bh2) v(wp_w13) v(wn_w13) v(wp_w23) v(wn_w23) v(wp_o3) v(wn_o3) v(wp_bh3) v(wn_bh3) v(wp_w14) v(wn_w14) v(wp_w24) v(wn_w24) v(wp_o4) v(wn_o4) v(wp_bh4) v(wn_bh4) v(wp_w15) v(wn_w15) v(wp_w25) v(wn_w25) v(wp_o5) v(wn_o5) v(wp_bh5) v(wn_bh5) v(wp_w16) v(wn_w16) v(wp_w26) v(wn_w26) v(wp_o6) v(wn_o6) v(wp_bh6) v(wn_bh6) v(wp_bo) v(wn_bo)
.endc
.end
