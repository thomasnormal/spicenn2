batched
.model NNR NMOS (LEVEL=1 VTO=0.2 KP=120u LAMBDA=0.02 GAMMA=0 PHI=0.7)
.model PNR PMOS (LEVEL=1 VTO=-0.2 KP=40u LAMBDA=0.02 GAMMA=0 PHI=0.7)
.subckt gsyn inp inn wp wn outp outn vdd vbn
Mtail nt vbn 0 0 NNR W=400u L=100u
M5 na wp s5 0 NNR W=200u L=100u
Rd5 s5 nt 12k
M6 nb wn s6 0 NNR W=200u L=100u
Rd6 s6 nt 12k
M1 outp inp s1 0 NNR W=200u L=100u
Rd1 s1 na 12k
M2 outn inn s2 0 NNR W=200u L=100u
Rd2 s2 na 12k
M3 outn inp s3 0 NNR W=200u L=100u
Rd3 s3 nb 12k
M4 outp inn s4 0 NNR W=200u L=100u
Rd4 s4 nb 12k
.ends
.subckt cmld p n vdd
Rcs1 p cmx 300k
Rcs2 n cmx 300k
MLp p cmx vdd vdd PNR W=46000u L=100u
MLn n cmx vdd vdd PNR W=46000u L=100u
.ends
.subckt dneuron up un ap an vdd vbn
M1 an up tn 0 NNR W=200u L=100u
M2 ap un tn 0 NNR W=200u L=100u
Mt tn vbn 0 0 NNR W=200u L=100u
Xcm ap an vdd cmld
.ends

Vdd vdd 0 1.0
Vbsyn vbsyn 0 0.6
Vbbk vbbk 0 0.30
Vbneu vbneu 0 0.35
Vgm gm 0 0.6
Vxp0 a_xp0 0 PWL(0.01n 0.4792 18.00n 0.4792 18.01n 0.4366 36.00n 0.4366 36.01n 0.4779 54.00n 0.4779 54.01n 0.3998 72.00n 0.3998 72.01n 0.3319 90.00n 0.3319 90.01n 0.6119 108.00n 0.6119 108.01n 0.3749 126.00n 0.3749 126.01n 0.5255 144.00n 0.5255 144.01n 0.3687 162.00n 0.3687 162.01n 0.4407 180.00n 0.4407 180.01n 0.3404 198.00n 0.3404 198.01n 0.4101 216.00n 0.4101 216.01n 0.4483 234.00n 0.4483 234.01n 0.4133 252.00n 0.4133 252.01n 0.3892 270.00n 0.3892 270.01n 0.3247 288.00n 0.3247 288.01n 0.6238 306.00n 0.6238 306.01n 0.3711 324.00n 0.3711 324.01n 0.4438 342.00n 0.4438 342.01n 0.3569 360.00n 0.3569 360.01n 0.6252 378.00n 0.6252 378.01n 0.5318 396.00n 0.5318 396.01n 0.5533 414.00n 0.5533 414.01n 0.4092 432.00n 0.4092 432.01n 0.6226 450.00n 0.6226 450.01n 0.4243 468.00n 0.4243 468.01n 0.4539 486.00n 0.4539 486.01n 0.6093 504.00n 0.6093 504.01n 0.4242 522.00n 0.4242 522.01n 0.4187)
Vxn0 a_xn0 0 PWL(0.01n 0.5208 18.00n 0.5208 18.01n 0.5634 36.00n 0.5634 36.01n 0.5221 54.00n 0.5221 54.01n 0.6002 72.00n 0.6002 72.01n 0.6681 90.00n 0.6681 90.01n 0.3881 108.00n 0.3881 108.01n 0.6251 126.00n 0.6251 126.01n 0.4745 144.00n 0.4745 144.01n 0.6313 162.00n 0.6313 162.01n 0.5593 180.00n 0.5593 180.01n 0.6596 198.00n 0.6596 198.01n 0.5899 216.00n 0.5899 216.01n 0.5517 234.00n 0.5517 234.01n 0.5867 252.00n 0.5867 252.01n 0.6108 270.00n 0.6108 270.01n 0.6753 288.00n 0.6753 288.01n 0.3762 306.00n 0.3762 306.01n 0.6289 324.00n 0.6289 324.01n 0.5562 342.00n 0.5562 342.01n 0.6431 360.00n 0.6431 360.01n 0.3748 378.00n 0.3748 378.01n 0.4682 396.00n 0.4682 396.01n 0.4467 414.00n 0.4467 414.01n 0.5908 432.00n 0.5908 432.01n 0.3774 450.00n 0.3774 450.01n 0.5757 468.00n 0.5757 468.01n 0.5461 486.00n 0.5461 486.01n 0.3907 504.00n 0.3907 504.01n 0.5758 522.00n 0.5758 522.01n 0.5813)
Vxp1 a_xp1 0 PWL(0.01n 0.6507 18.00n 0.6507 18.01n 0.6445 36.00n 0.6445 36.01n 0.3582 54.00n 0.3582 54.01n 0.6058 72.00n 0.6058 72.01n 0.4350 90.00n 0.4350 90.01n 0.5927 108.00n 0.5927 108.01n 0.3869 126.00n 0.3869 126.01n 0.3537 144.00n 0.3537 144.01n 0.3854 162.00n 0.3854 162.01n 0.3613 180.00n 0.3613 180.01n 0.5359 198.00n 0.5359 198.01n 0.3946 216.00n 0.3946 216.01n 0.6379 234.00n 0.6379 234.01n 0.6468 252.00n 0.6468 252.01n 0.5913 270.00n 0.5913 270.01n 0.5227 288.00n 0.5227 288.01n 0.5437 306.00n 0.5437 306.01n 0.4271 324.00n 0.4271 324.01n 0.3360 342.00n 0.3360 342.01n 0.4950 360.00n 0.4950 360.01n 0.5455 378.00n 0.5455 378.01n 0.6343 396.00n 0.6343 396.01n 0.3658 414.00n 0.3658 414.01n 0.3696 432.00n 0.3696 432.01n 0.4307 450.00n 0.4307 450.01n 0.6490 468.00n 0.6490 468.01n 0.6289 486.00n 0.6289 486.01n 0.5738 504.00n 0.5738 504.01n 0.6164 522.00n 0.6164 522.01n 0.6409)
Vxn1 a_xn1 0 PWL(0.01n 0.3493 18.00n 0.3493 18.01n 0.3555 36.00n 0.3555 36.01n 0.6418 54.00n 0.6418 54.01n 0.3942 72.00n 0.3942 72.01n 0.5650 90.00n 0.5650 90.01n 0.4073 108.00n 0.4073 108.01n 0.6131 126.00n 0.6131 126.01n 0.6463 144.00n 0.6463 144.01n 0.6146 162.00n 0.6146 162.01n 0.6387 180.00n 0.6387 180.01n 0.4641 198.00n 0.4641 198.01n 0.6054 216.00n 0.6054 216.01n 0.3621 234.00n 0.3621 234.01n 0.3532 252.00n 0.3532 252.01n 0.4087 270.00n 0.4087 270.01n 0.4773 288.00n 0.4773 288.01n 0.4563 306.00n 0.4563 306.01n 0.5729 324.00n 0.5729 324.01n 0.6640 342.00n 0.6640 342.01n 0.5050 360.00n 0.5050 360.01n 0.4545 378.00n 0.4545 378.01n 0.3657 396.00n 0.3657 396.01n 0.6342 414.00n 0.6342 414.01n 0.6304 432.00n 0.6304 432.01n 0.5693 450.00n 0.5693 450.01n 0.3510 468.00n 0.3510 468.01n 0.3711 486.00n 0.3711 486.01n 0.4262 504.00n 0.4262 504.01n 0.3836 522.00n 0.3836 522.01n 0.3591)
Vxp2 a_xp2 0 PWL(0.01n 0.8000 18.00n 0.8000 18.01n 0.8000 36.00n 0.8000 36.01n 0.8000 54.00n 0.8000 54.01n 0.8000 72.00n 0.8000 72.01n 0.8000 90.00n 0.8000 90.01n 0.8000 108.00n 0.8000 108.01n 0.8000 126.00n 0.8000 126.01n 0.8000 144.00n 0.8000 144.01n 0.8000 162.00n 0.8000 162.01n 0.8000 180.00n 0.8000 180.01n 0.8000 198.00n 0.8000 198.01n 0.8000 216.00n 0.8000 216.01n 0.8000 234.00n 0.8000 234.01n 0.8000 252.00n 0.8000 252.01n 0.8000 270.00n 0.8000 270.01n 0.8000 288.00n 0.8000 288.01n 0.8000 306.00n 0.8000 306.01n 0.8000 324.00n 0.8000 324.01n 0.8000 342.00n 0.8000 342.01n 0.8000 360.00n 0.8000 360.01n 0.8000 378.00n 0.8000 378.01n 0.8000 396.00n 0.8000 396.01n 0.8000 414.00n 0.8000 414.01n 0.8000 432.00n 0.8000 432.01n 0.8000 450.00n 0.8000 450.01n 0.8000 468.00n 0.8000 468.01n 0.8000 486.00n 0.8000 486.01n 0.8000 504.00n 0.8000 504.01n 0.8000 522.00n 0.8000 522.01n 0.8000)
Vxn2 a_xn2 0 PWL(0.01n 0.2000 18.00n 0.2000 18.01n 0.2000 36.00n 0.2000 36.01n 0.2000 54.00n 0.2000 54.01n 0.2000 72.00n 0.2000 72.01n 0.2000 90.00n 0.2000 90.01n 0.2000 108.00n 0.2000 108.01n 0.2000 126.00n 0.2000 126.01n 0.2000 144.00n 0.2000 144.01n 0.2000 162.00n 0.2000 162.01n 0.2000 180.00n 0.2000 180.01n 0.2000 198.00n 0.2000 198.01n 0.2000 216.00n 0.2000 216.01n 0.2000 234.00n 0.2000 234.01n 0.2000 252.00n 0.2000 252.01n 0.2000 270.00n 0.2000 270.01n 0.2000 288.00n 0.2000 288.01n 0.2000 306.00n 0.2000 306.01n 0.2000 324.00n 0.2000 324.01n 0.2000 342.00n 0.2000 342.01n 0.2000 360.00n 0.2000 360.01n 0.2000 378.00n 0.2000 378.01n 0.2000 396.00n 0.2000 396.01n 0.2000 414.00n 0.2000 414.01n 0.2000 432.00n 0.2000 432.01n 0.2000 450.00n 0.2000 450.01n 0.2000 468.00n 0.2000 468.01n 0.2000 486.00n 0.2000 486.01n 0.2000 504.00n 0.2000 504.01n 0.2000 522.00n 0.2000 522.01n 0.2000)
Vwp_ih_0_0 wp_ih_0_0 0 0.5002104965524697
Vwn_ih_0_0 wn_ih_0_0 0 0.4997895034475303
Vwp_ih_1_0 wp_ih_1_0 0 0.5000266080997136
Vwn_ih_1_0 wn_ih_1_0 0 0.4999733919002865
Vwp_ih_2_0 wp_ih_2_0 0 0.5004285527342491
Vwn_ih_2_0 wn_ih_2_0 0 0.4995714472657508
Vwp_ih_0_1 wp_ih_0_1 0 0.5021967360325404
Vwn_ih_0_1 wn_ih_0_1 0 0.49780326396745955
Vwp_ih_1_1 wp_ih_1_1 0 0.5013540680311133
Vwn_ih_1_1 wn_ih_1_1 0 0.49864593196888674
Vwp_ih_2_1 wp_ih_2_1 0 0.8827280690839617
Vwn_ih_2_1 wn_ih_2_1 0 0.3
Vwp_ih_0_2 wp_ih_0_2 0 0.49634660860273894
Vwn_ih_0_2 wn_ih_0_2 0 0.5036533913972611
Vwp_ih_1_2 wp_ih_1_2 0 0.48870000032105504
Vwn_ih_1_2 wn_ih_1_2 0 0.511299999678945
Vwp_ih_2_2 wp_ih_2_2 0 0.5088694070403547
Vwn_ih_2_2 wn_ih_2_2 0 0.4911305929596454
Vwp_ih_0_3 wp_ih_0_3 0 0.4999996162341904
Vwn_ih_0_3 wn_ih_0_3 0 0.5000003837658096
Vwp_ih_1_3 wp_ih_1_3 0 0.5000344483057277
Vwn_ih_1_3 wn_ih_1_3 0 0.49996555169427226
Vwp_ih_2_3 wp_ih_2_3 0 0.4999486876794772
Vwn_ih_2_3 wn_ih_2_3 0 0.5000513123205228
Vwp_ih_0_4 wp_ih_0_4 0 0.5000926196094605
Vwn_ih_0_4 wn_ih_0_4 0 0.49990738039053945
Vwp_ih_1_4 wp_ih_1_4 0 0.49989392654422554
Vwn_ih_1_4 wn_ih_1_4 0 0.5001060734557745
Vwp_ih_2_4 wp_ih_2_4 0 0.5003317811700312
Vwn_ih_2_4 wn_ih_2_4 0 0.49966821882996887
Vwp_ih_0_5 wp_ih_0_5 0 0.4945168116766853
Vwn_ih_0_5 wn_ih_0_5 0 0.5054831883233146
Vwp_ih_1_5 wp_ih_1_5 0 0.4986043216977183
Vwn_ih_1_5 wn_ih_1_5 0 0.5013956783022817
Vwp_ih_2_5 wp_ih_2_5 0 0.511606361854494
Vwn_ih_2_5 wn_ih_2_5 0 0.48839363814550596
Vwp_ih_0_6 wp_ih_0_6 0 0.5019292308146548
Vwn_ih_0_6 wn_ih_0_6 0 0.4980707691853452
Vwp_ih_1_6 wp_ih_1_6 0 0.500829445985324
Vwn_ih_1_6 wn_ih_1_6 0 0.499170554014676
Vwp_ih_2_6 wp_ih_2_6 0 0.899
Vwn_ih_2_6 wn_ih_2_6 0 0.3
Vwp_ih_0_7 wp_ih_0_7 0 0.8971223431314417
Vwn_ih_0_7 wn_ih_0_7 0 0.3
Vwp_ih_1_7 wp_ih_1_7 0 0.3
Vwn_ih_1_7 wn_ih_1_7 0 0.8982102661374118
Vwp_ih_2_7 wp_ih_2_7 0 0.7827293204551208
Vwn_ih_2_7 wn_ih_2_7 0 0.3
Vwp_ih_0_8 wp_ih_0_8 0 0.5030033559705315
Vwn_ih_0_8 wn_ih_0_8 0 0.4969966440294686
Vwp_ih_1_8 wp_ih_1_8 0 0.5015611688440482
Vwn_ih_1_8 wn_ih_1_8 0 0.49843883115595183
Vwp_ih_2_8 wp_ih_2_8 0 0.7838372611023077
Vwn_ih_2_8 wn_ih_2_8 0 0.3
Vwp_ih_0_9 wp_ih_0_9 0 0.6639513781871638
Vwn_ih_0_9 wn_ih_0_9 0 0.33604862181283623
Vwp_ih_1_9 wp_ih_1_9 0 0.3
Vwn_ih_1_9 wn_ih_1_9 0 0.7220548133244384
Vwp_ih_2_9 wp_ih_2_9 0 0.8051822936175852
Vwn_ih_2_9 wn_ih_2_9 0 0.3
Vwp_ih_0_10 wp_ih_0_10 0 0.3
Vwn_ih_0_10 wn_ih_0_10 0 0.899
Vwp_ih_1_10 wp_ih_1_10 0 0.34666486263836876
Vwn_ih_1_10 wn_ih_1_10 0 0.6533351373616312
Vwp_ih_2_10 wp_ih_2_10 0 0.334745770109765
Vwn_ih_2_10 wn_ih_2_10 0 0.6652542298902351
Vwp_ih_0_11 wp_ih_0_11 0 0.35018828897223864
Vwn_ih_0_11 wn_ih_0_11 0 0.6498117110277614
Vwp_ih_1_11 wp_ih_1_11 0 0.6157492718930095
Vwn_ih_1_11 wn_ih_1_11 0 0.38425072810699046
Vwp_ih_2_11 wp_ih_2_11 0 0.6124314307712717
Vwn_ih_2_11 wn_ih_2_11 0 0.3875685692287283
Vwp_ih_0_12 wp_ih_0_12 0 0.5065590249379798
Vwn_ih_0_12 wn_ih_0_12 0 0.4934409750620203
Vwp_ih_1_12 wp_ih_1_12 0 0.5052524931133103
Vwn_ih_1_12 wn_ih_1_12 0 0.4947475068866897
Vwp_ih_2_12 wp_ih_2_12 0 0.5181074606885842
Vwn_ih_2_12 wn_ih_2_12 0 0.48189253931141585
Vwp_ih_0_13 wp_ih_0_13 0 0.3540120554633714
Vwn_ih_0_13 wn_ih_0_13 0 0.6459879445366286
Vwp_ih_1_13 wp_ih_1_13 0 0.8319206740311624
Vwn_ih_1_13 wn_ih_1_13 0 0.3
Vwp_ih_2_13 wp_ih_2_13 0 0.899
Vwn_ih_2_13 wn_ih_2_13 0 0.3
Vwp_ih_0_14 wp_ih_0_14 0 0.5026438928584138
Vwn_ih_0_14 wn_ih_0_14 0 0.4973561071415861
Vwp_ih_1_14 wp_ih_1_14 0 0.5008974921021012
Vwn_ih_1_14 wn_ih_1_14 0 0.4991025078978988
Vwp_ih_2_14 wp_ih_2_14 0 0.833354998607899
Vwn_ih_2_14 wn_ih_2_14 0 0.3
Vwp_ih_0_15 wp_ih_0_15 0 0.3
Vwn_ih_0_15 wn_ih_0_15 0 0.8933576262972265
Vwp_ih_1_15 wp_ih_1_15 0 0.899
Vwn_ih_1_15 wn_ih_1_15 0 0.3
Vwp_ih_2_15 wp_ih_2_15 0 0.7489685686487848
Vwn_ih_2_15 wn_ih_2_15 0 0.3
Vwp_ih_0_16 wp_ih_0_16 0 0.4792690293475397
Vwn_ih_0_16 wn_ih_0_16 0 0.5207309706524603
Vwp_ih_1_16 wp_ih_1_16 0 0.4900530568066182
Vwn_ih_1_16 wn_ih_1_16 0 0.5099469431933819
Vwp_ih_2_16 wp_ih_2_16 0 0.49527325026921076
Vwn_ih_2_16 wn_ih_2_16 0 0.5047267497307892
Vwp_ih_0_17 wp_ih_0_17 0 0.5058689264533746
Vwn_ih_0_17 wn_ih_0_17 0 0.49413107354662544
Vwp_ih_1_17 wp_ih_1_17 0 0.5018705393369971
Vwn_ih_1_17 wn_ih_1_17 0 0.4981294606630029
Vwp_ih_2_17 wp_ih_2_17 0 0.5162398277902625
Vwn_ih_2_17 wn_ih_2_17 0 0.48376017220973755
Vwp_ih_0_18 wp_ih_0_18 0 0.5013604372300947
Vwn_ih_0_18 wn_ih_0_18 0 0.4986395627699053
Vwp_ih_1_18 wp_ih_1_18 0 0.500773995838193
Vwn_ih_1_18 wn_ih_1_18 0 0.4992260041618069
Vwp_ih_2_18 wp_ih_2_18 0 0.5028412638428396
Vwn_ih_2_18 wn_ih_2_18 0 0.4971587361571605
Vwp_ih_0_19 wp_ih_0_19 0 0.4935811528259965
Vwn_ih_0_19 wn_ih_0_19 0 0.5064188471740035
Vwp_ih_1_19 wp_ih_1_19 0 0.49522943228314553
Vwn_ih_1_19 wn_ih_1_19 0 0.5047705677168545
Vwp_ih_2_19 wp_ih_2_19 0 0.3576301197874894
Vwn_ih_2_19 wn_ih_2_19 0 0.6423698802125106
Vwp_ih_0_20 wp_ih_0_20 0 0.4999081053758191
Vwn_ih_0_20 wn_ih_0_20 0 0.5000918946241809
Vwp_ih_1_20 wp_ih_1_20 0 0.4999886832192056
Vwn_ih_1_20 wn_ih_1_20 0 0.5000113167807945
Vwp_ih_2_20 wp_ih_2_20 0 0.49987019799708776
Vwn_ih_2_20 wn_ih_2_20 0 0.5001298020029122
Vwp_ih_0_21 wp_ih_0_21 0 0.4617010776082343
Vwn_ih_0_21 wn_ih_0_21 0 0.5382989223917657
Vwp_ih_1_21 wp_ih_1_21 0 0.3575888850540726
Vwn_ih_1_21 wn_ih_1_21 0 0.6424111149459274
Vwp_ih_2_21 wp_ih_2_21 0 0.38114525996556625
Vwn_ih_2_21 wn_ih_2_21 0 0.6188547400344337
Vwp_ih_0_22 wp_ih_0_22 0 0.49880741936873724
Vwn_ih_0_22 wn_ih_0_22 0 0.5011925806312627
Vwp_ih_1_22 wp_ih_1_22 0 0.4992606747573026
Vwn_ih_1_22 wn_ih_1_22 0 0.5007393252426974
Vwp_ih_2_22 wp_ih_2_22 0 0.4975597529342651
Vwn_ih_2_22 wn_ih_2_22 0 0.5024402470657349
Vwp_ih_0_23 wp_ih_0_23 0 0.6027064012173908
Vwn_ih_0_23 wn_ih_0_23 0 0.39729359878260917
Vwp_ih_1_23 wp_ih_1_23 0 0.3
Vwn_ih_1_23 wn_ih_1_23 0 0.8166375284439726
Vwp_ih_2_23 wp_ih_2_23 0 0.8976166231961299
Vwn_ih_2_23 wn_ih_2_23 0 0.3
Vwp_ih_0_24 wp_ih_0_24 0 0.49858686372133976
Vwn_ih_0_24 wn_ih_0_24 0 0.5014131362786602
Vwp_ih_1_24 wp_ih_1_24 0 0.49898269845820514
Vwn_ih_1_24 wn_ih_1_24 0 0.5010173015417948
Vwp_ih_2_24 wp_ih_2_24 0 0.49624114354445575
Vwn_ih_2_24 wn_ih_2_24 0 0.5037588564555442
Vwp_ih_0_25 wp_ih_0_25 0 0.5052248897445595
Vwn_ih_0_25 wn_ih_0_25 0 0.4947751102554405
Vwp_ih_1_25 wp_ih_1_25 0 0.5040548025476388
Vwn_ih_1_25 wn_ih_1_25 0 0.4959451974523612
Vwp_ih_2_25 wp_ih_2_25 0 0.6702469991828188
Vwn_ih_2_25 wn_ih_2_25 0 0.3297530008171812
Vwp_ih_0_26 wp_ih_0_26 0 0.3
Vwn_ih_0_26 wn_ih_0_26 0 0.7542623722423002
Vwp_ih_1_26 wp_ih_1_26 0 0.4626727339613322
Vwn_ih_1_26 wn_ih_1_26 0 0.5373272660386679
Vwp_ih_2_26 wp_ih_2_26 0 0.75750744914196
Vwn_ih_2_26 wn_ih_2_26 0 0.3
Vwp_ih_0_27 wp_ih_0_27 0 0.4999970775439725
Vwn_ih_0_27 wn_ih_0_27 0 0.5000029224560275
Vwp_ih_1_27 wp_ih_1_27 0 0.499997790658592
Vwn_ih_1_27 wn_ih_1_27 0 0.500002209341408
Vwp_ih_2_27 wp_ih_2_27 0 0.5000025259853184
Vwn_ih_2_27 wn_ih_2_27 0 0.4999974740146816
Vwp_ih_0_28 wp_ih_0_28 0 0.899
Vwn_ih_0_28 wn_ih_0_28 0 0.3
Vwp_ih_1_28 wp_ih_1_28 0 0.3
Vwn_ih_1_28 wn_ih_1_28 0 0.7345725731642201
Vwp_ih_2_28 wp_ih_2_28 0 0.7015929982730491
Vwn_ih_2_28 wn_ih_2_28 0 0.3
Vwp_ih_0_29 wp_ih_0_29 0 0.4937674017226543
Vwn_ih_0_29 wn_ih_0_29 0 0.5062325982773457
Vwp_ih_1_29 wp_ih_1_29 0 0.4946215774585639
Vwn_ih_1_29 wn_ih_1_29 0 0.5053784225414361
Vwp_ih_2_29 wp_ih_2_29 0 0.35616052290728595
Vwn_ih_2_29 wn_ih_2_29 0 0.643839477092714
Vwp_ih_0_30 wp_ih_0_30 0 0.7795432798614347
Vwn_ih_0_30 wn_ih_0_30 0 0.3
Vwp_ih_1_30 wp_ih_1_30 0 0.7302359213894862
Vwn_ih_1_30 wn_ih_1_30 0 0.3
Vwp_ih_2_30 wp_ih_2_30 0 0.899
Vwn_ih_2_30 wn_ih_2_30 0 0.3
Vwp_ih_0_31 wp_ih_0_31 0 0.4979379495688374
Vwn_ih_0_31 wn_ih_0_31 0 0.5020620504311626
Vwp_ih_1_31 wp_ih_1_31 0 0.49883534699838433
Vwn_ih_1_31 wn_ih_1_31 0 0.5011646530016156
Vwp_ih_2_31 wp_ih_2_31 0 0.3
Vwn_ih_2_31 wn_ih_2_31 0 0.899
Vwp_ih_0_32 wp_ih_0_32 0 0.3
Vwn_ih_0_32 wn_ih_0_32 0 0.7398487218923385
Vwp_ih_1_32 wp_ih_1_32 0 0.3
Vwn_ih_1_32 wn_ih_1_32 0 0.7712545445151867
Vwp_ih_2_32 wp_ih_2_32 0 0.3
Vwn_ih_2_32 wn_ih_2_32 0 0.899
Vwp_ih_0_33 wp_ih_0_33 0 0.497041028372196
Vwn_ih_0_33 wn_ih_0_33 0 0.502958971627804
Vwp_ih_1_33 wp_ih_1_33 0 0.49810767249413546
Vwn_ih_1_33 wn_ih_1_33 0 0.5018923275058645
Vwp_ih_2_33 wp_ih_2_33 0 0.49178360030085494
Vwn_ih_2_33 wn_ih_2_33 0 0.5082163996991451
Vwp_ih_0_34 wp_ih_0_34 0 0.899
Vwn_ih_0_34 wn_ih_0_34 0 0.3
Vwp_ih_1_34 wp_ih_1_34 0 0.7586380256248464
Vwn_ih_1_34 wn_ih_1_34 0 0.3
Vwp_ih_2_34 wp_ih_2_34 0 0.3229014375366618
Vwn_ih_2_34 wn_ih_2_34 0 0.6770985624633382
Vwp_ih_0_35 wp_ih_0_35 0 0.5001239409433703
Vwn_ih_0_35 wn_ih_0_35 0 0.49987605905662963
Vwp_ih_1_35 wp_ih_1_35 0 0.5000078902556296
Vwn_ih_1_35 wn_ih_1_35 0 0.49999210974437036
Vwp_ih_2_35 wp_ih_2_35 0 0.5002870798867206
Vwn_ih_2_35 wn_ih_2_35 0 0.49971292011327945
Vwp_ih_0_36 wp_ih_0_36 0 0.5022256745551219
Vwn_ih_0_36 wn_ih_0_36 0 0.4977743254448781
Vwp_ih_1_36 wp_ih_1_36 0 0.5011252904177617
Vwn_ih_1_36 wn_ih_1_36 0 0.4988747095822384
Vwp_ih_2_36 wp_ih_2_36 0 0.899
Vwn_ih_2_36 wn_ih_2_36 0 0.3
Vwp_ih_0_37 wp_ih_0_37 0 0.8009312584447161
Vwn_ih_0_37 wn_ih_0_37 0 0.3
Vwp_ih_1_37 wp_ih_1_37 0 0.3
Vwn_ih_1_37 wn_ih_1_37 0 0.7161322191692969
Vwp_ih_2_37 wp_ih_2_37 0 0.3
Vwn_ih_2_37 wn_ih_2_37 0 0.8983179477192919
Vwp_ih_0_38 wp_ih_0_38 0 0.5496011936621709
Vwn_ih_0_38 wn_ih_0_38 0 0.4503988063378291
Vwp_ih_1_38 wp_ih_1_38 0 0.6792011886603964
Vwn_ih_1_38 wn_ih_1_38 0 0.3207988113396036
Vwp_ih_2_38 wp_ih_2_38 0 0.3595027590547287
Vwn_ih_2_38 wn_ih_2_38 0 0.6404972409452713
Vwp_ih_0_39 wp_ih_0_39 0 0.3631687681761308
Vwn_ih_0_39 wn_ih_0_39 0 0.6368312318238691
Vwp_ih_1_39 wp_ih_1_39 0 0.6835773826421434
Vwn_ih_1_39 wn_ih_1_39 0 0.31642261735785665
Vwp_ih_2_39 wp_ih_2_39 0 0.44790693411927757
Vwn_ih_2_39 wn_ih_2_39 0 0.5520930658807224
Vwp_ih_0_40 wp_ih_0_40 0 0.4965833552501491
Vwn_ih_0_40 wn_ih_0_40 0 0.5034166447498508
Vwp_ih_1_40 wp_ih_1_40 0 0.49917308908851593
Vwn_ih_1_40 wn_ih_1_40 0 0.5008269109114841
Vwp_ih_2_40 wp_ih_2_40 0 0.5127594580909036
Vwn_ih_2_40 wn_ih_2_40 0 0.4872405419090963
Vwp_ih_0_41 wp_ih_0_41 0 0.3
Vwn_ih_0_41 wn_ih_0_41 0 0.757028836161806
Vwp_ih_1_41 wp_ih_1_41 0 0.6475673208690133
Vwn_ih_1_41 wn_ih_1_41 0 0.35243267913098675
Vwp_ih_2_41 wp_ih_2_41 0 0.3
Vwn_ih_2_41 wn_ih_2_41 0 0.8318453065255447
Vwp_ih_0_42 wp_ih_0_42 0 0.32901064403400426
Vwn_ih_0_42 wn_ih_0_42 0 0.6709893559659957
Vwp_ih_1_42 wp_ih_1_42 0 0.6374201864431066
Vwn_ih_1_42 wn_ih_1_42 0 0.3625798135568934
Vwp_ih_2_42 wp_ih_2_42 0 0.3125160720396388
Vwn_ih_2_42 wn_ih_2_42 0 0.6874839279603612
Vwp_ih_0_43 wp_ih_0_43 0 0.503801029364831
Vwn_ih_0_43 wn_ih_0_43 0 0.49619897063516905
Vwp_ih_1_43 wp_ih_1_43 0 0.49746236553941064
Vwn_ih_1_43 wn_ih_1_43 0 0.5025376344605893
Vwp_ih_2_43 wp_ih_2_43 0 0.4940341356973575
Vwn_ih_2_43 wn_ih_2_43 0 0.5059658643026426
Vwp_ih_0_44 wp_ih_0_44 0 0.3
Vwn_ih_0_44 wn_ih_0_44 0 0.7357654098857116
Vwp_ih_1_44 wp_ih_1_44 0 0.3
Vwn_ih_1_44 wn_ih_1_44 0 0.7803448024715536
Vwp_ih_2_44 wp_ih_2_44 0 0.8982022195981704
Vwn_ih_2_44 wn_ih_2_44 0 0.3
Vwp_ih_0_45 wp_ih_0_45 0 0.5064067691089598
Vwn_ih_0_45 wn_ih_0_45 0 0.4935932308910403
Vwp_ih_1_45 wp_ih_1_45 0 0.5029885498925244
Vwn_ih_1_45 wn_ih_1_45 0 0.49701145010747566
Vwp_ih_2_45 wp_ih_2_45 0 0.5101295472632996
Vwn_ih_2_45 wn_ih_2_45 0 0.4898704527367003
Vwp_ih_0_46 wp_ih_0_46 0 0.49055003449855167
Vwn_ih_0_46 wn_ih_0_46 0 0.5094499655014484
Vwp_ih_1_46 wp_ih_1_46 0 0.4913728548354385
Vwn_ih_1_46 wn_ih_1_46 0 0.5086271451645615
Vwp_ih_2_46 wp_ih_2_46 0 0.43722504517801175
Vwn_ih_2_46 wn_ih_2_46 0 0.5627749548219882
Vwp_ih_0_47 wp_ih_0_47 0 0.5001981741030012
Vwn_ih_0_47 wn_ih_0_47 0 0.49980182589699884
Vwp_ih_1_47 wp_ih_1_47 0 0.4999719414669071
Vwn_ih_1_47 wn_ih_1_47 0 0.5000280585330928
Vwp_ih_2_47 wp_ih_2_47 0 0.5003218871168544
Vwn_ih_2_47 wn_ih_2_47 0 0.49967811288314556
Vwp_ih_0_48 wp_ih_0_48 0 0.899
Vwn_ih_0_48 wn_ih_0_48 0 0.3
Vwp_ih_1_48 wp_ih_1_48 0 0.545321010219799
Vwn_ih_1_48 wn_ih_1_48 0 0.45467898978020105
Vwp_ih_2_48 wp_ih_2_48 0 0.3409884311414497
Vwn_ih_2_48 wn_ih_2_48 0 0.6590115688585503
Vwp_ih_0_49 wp_ih_0_49 0 0.8926847263896354
Vwn_ih_0_49 wn_ih_0_49 0 0.3
Vwp_ih_1_49 wp_ih_1_49 0 0.3
Vwn_ih_1_49 wn_ih_1_49 0 0.899
Vwp_ih_2_49 wp_ih_2_49 0 0.3
Vwn_ih_2_49 wn_ih_2_49 0 0.7434978183157154
Vwp_ih_0_50 wp_ih_0_50 0 0.5018898361618731
Vwn_ih_0_50 wn_ih_0_50 0 0.4981101638381269
Vwp_ih_1_50 wp_ih_1_50 0 0.5011570576825747
Vwn_ih_1_50 wn_ih_1_50 0 0.4988429423174253
Vwp_ih_2_50 wp_ih_2_50 0 0.49930540407088997
Vwn_ih_2_50 wn_ih_2_50 0 0.50069459592911
Vwp_ih_0_51 wp_ih_0_51 0 0.5024414778638996
Vwn_ih_0_51 wn_ih_0_51 0 0.4975585221361004
Vwp_ih_1_51 wp_ih_1_51 0 0.5053847981447264
Vwn_ih_1_51 wn_ih_1_51 0 0.49461520185527363
Vwp_ih_2_51 wp_ih_2_51 0 0.4925046547439082
Vwn_ih_2_51 wn_ih_2_51 0 0.5074953452560919
Vwp_ih_0_52 wp_ih_0_52 0 0.5024025251153297
Vwn_ih_0_52 wn_ih_0_52 0 0.4975974748846703
Vwp_ih_1_52 wp_ih_1_52 0 0.501658059791028
Vwn_ih_1_52 wn_ih_1_52 0 0.4983419402089721
Vwp_ih_2_52 wp_ih_2_52 0 0.5009688419573677
Vwn_ih_2_52 wn_ih_2_52 0 0.4990311580426323
Vwp_ih_0_53 wp_ih_0_53 0 0.4972160917221375
Vwn_ih_0_53 wn_ih_0_53 0 0.5027839082778625
Vwp_ih_1_53 wp_ih_1_53 0 0.49828767617275604
Vwn_ih_1_53 wn_ih_1_53 0 0.501712323827244
Vwp_ih_2_53 wp_ih_2_53 0 0.4909067178514617
Vwn_ih_2_53 wn_ih_2_53 0 0.5090932821485382
Vwp_ih_0_54 wp_ih_0_54 0 0.45322793121117777
Vwn_ih_0_54 wn_ih_0_54 0 0.5467720687888222
Vwp_ih_1_54 wp_ih_1_54 0 0.899
Vwn_ih_1_54 wn_ih_1_54 0 0.3
Vwp_ih_2_54 wp_ih_2_54 0 0.6376705566024309
Vwn_ih_2_54 wn_ih_2_54 0 0.3623294433975691
Vwp_ih_0_55 wp_ih_0_55 0 0.5003858240029578
Vwn_ih_0_55 wn_ih_0_55 0 0.49961417599704216
Vwp_ih_1_55 wp_ih_1_55 0 0.49998727945086197
Vwn_ih_1_55 wn_ih_1_55 0 0.500012720549138
Vwp_ih_2_55 wp_ih_2_55 0 0.500913329954382
Vwn_ih_2_55 wn_ih_2_55 0 0.499086670045618
Vwp_ih_0_56 wp_ih_0_56 0 0.3
Vwn_ih_0_56 wn_ih_0_56 0 0.899
Vwp_ih_1_56 wp_ih_1_56 0 0.5541162051724515
Vwn_ih_1_56 wn_ih_1_56 0 0.4458837948275485
Vwp_ih_2_56 wp_ih_2_56 0 0.6515697846450959
Vwn_ih_2_56 wn_ih_2_56 0 0.34843021535490415
Vwp_ih_0_57 wp_ih_0_57 0 0.6757707441702673
Vwn_ih_0_57 wn_ih_0_57 0 0.3242292558297327
Vwp_ih_1_57 wp_ih_1_57 0 0.6761056283872832
Vwn_ih_1_57 wn_ih_1_57 0 0.32389437161271684
Vwp_ih_2_57 wp_ih_2_57 0 0.7327247200837104
Vwn_ih_2_57 wn_ih_2_57 0 0.3
Vwp_ih_0_58 wp_ih_0_58 0 0.8933851147954879
Vwn_ih_0_58 wn_ih_0_58 0 0.3
Vwp_ih_1_58 wp_ih_1_58 0 0.3
Vwn_ih_1_58 wn_ih_1_58 0 0.899
Vwp_ih_2_58 wp_ih_2_58 0 0.3
Vwn_ih_2_58 wn_ih_2_58 0 0.7488017824435895
Vwp_ih_0_59 wp_ih_0_59 0 0.4986735320614541
Vwn_ih_0_59 wn_ih_0_59 0 0.5013264679385458
Vwp_ih_1_59 wp_ih_1_59 0 0.4994762180461091
Vwn_ih_1_59 wn_ih_1_59 0 0.5005237819538909
Vwp_ih_2_59 wp_ih_2_59 0 0.4972954127404279
Vwn_ih_2_59 wn_ih_2_59 0 0.5027045872595721
Vwp_ih_0_60 wp_ih_0_60 0 0.3
Vwn_ih_0_60 wn_ih_0_60 0 0.8982317744845401
Vwp_ih_1_60 wp_ih_1_60 0 0.8497389948639148
Vwn_ih_1_60 wn_ih_1_60 0 0.3
Vwp_ih_2_60 wp_ih_2_60 0 0.3
Vwn_ih_2_60 wn_ih_2_60 0 0.7398230242225448
Vwp_ih_0_61 wp_ih_0_61 0 0.4734934102782823
Vwn_ih_0_61 wn_ih_0_61 0 0.5265065897217177
Vwp_ih_1_61 wp_ih_1_61 0 0.481764537340946
Vwn_ih_1_61 wn_ih_1_61 0 0.5182354626590541
Vwp_ih_2_61 wp_ih_2_61 0 0.4666506641619656
Vwn_ih_2_61 wn_ih_2_61 0 0.5333493358380343
Vwp_ih_0_62 wp_ih_0_62 0 0.5411904979965552
Vwn_ih_0_62 wn_ih_0_62 0 0.4588095020034448
Vwp_ih_1_62 wp_ih_1_62 0 0.3
Vwn_ih_1_62 wn_ih_1_62 0 0.899
Vwp_ih_2_62 wp_ih_2_62 0 0.6752683188869035
Vwn_ih_2_62 wn_ih_2_62 0 0.32473168111309647
Vwp_ih_0_63 wp_ih_0_63 0 0.3
Vwn_ih_0_63 wn_ih_0_63 0 0.7115951725175784
Vwp_ih_1_63 wp_ih_1_63 0 0.779828692160788
Vwn_ih_1_63 wn_ih_1_63 0 0.3
Vwp_ih_2_63 wp_ih_2_63 0 0.3
Vwn_ih_2_63 wn_ih_2_63 0 0.8973803029516072
Vwp_ih_0_64 wp_ih_0_64 0 0.5110560576994103
Vwn_ih_0_64 wn_ih_0_64 0 0.48894394230058974
Vwp_ih_1_64 wp_ih_1_64 0 0.5078398331389936
Vwn_ih_1_64 wn_ih_1_64 0 0.49216016686100644
Vwp_ih_2_64 wp_ih_2_64 0 0.5144226601325442
Vwn_ih_2_64 wn_ih_2_64 0 0.48557733986745577
Vwp_ih_0_65 wp_ih_0_65 0 0.3
Vwn_ih_0_65 wn_ih_0_65 0 0.7351925681411815
Vwp_ih_1_65 wp_ih_1_65 0 0.3598637694402155
Vwn_ih_1_65 wn_ih_1_65 0 0.6401362305597845
Vwp_ih_2_65 wp_ih_2_65 0 0.7736391769497937
Vwn_ih_2_65 wn_ih_2_65 0 0.3
Vwp_ih_0_66 wp_ih_0_66 0 0.8977150939930953
Vwn_ih_0_66 wn_ih_0_66 0 0.3
Vwp_ih_1_66 wp_ih_1_66 0 0.8977756311074252
Vwn_ih_1_66 wn_ih_1_66 0 0.3
Vwp_ih_2_66 wp_ih_2_66 0 0.7434747083344584
Vwn_ih_2_66 wn_ih_2_66 0 0.3
Vwp_ih_0_67 wp_ih_0_67 0 0.5039137402921755
Vwn_ih_0_67 wn_ih_0_67 0 0.49608625970782455
Vwp_ih_1_67 wp_ih_1_67 0 0.5022418085951742
Vwn_ih_1_67 wn_ih_1_67 0 0.49775819140482586
Vwp_ih_2_67 wp_ih_2_67 0 0.7225605635670743
Vwn_ih_2_67 wn_ih_2_67 0 0.3
Vwp_ih_0_68 wp_ih_0_68 0 0.5024163979885345
Vwn_ih_0_68 wn_ih_0_68 0 0.49758360201146545
Vwp_ih_1_68 wp_ih_1_68 0 0.5008207307047375
Vwn_ih_1_68 wn_ih_1_68 0 0.49917926929526246
Vwp_ih_2_68 wp_ih_2_68 0 0.5058587226043114
Vwn_ih_2_68 wn_ih_2_68 0 0.4941412773956886
Vwp_ih_0_69 wp_ih_0_69 0 0.5058854852585859
Vwn_ih_0_69 wn_ih_0_69 0 0.49411451474141405
Vwp_ih_1_69 wp_ih_1_69 0 0.5040561288609634
Vwn_ih_1_69 wn_ih_1_69 0 0.4959438711390366
Vwp_ih_2_69 wp_ih_2_69 0 0.5074639464775087
Vwn_ih_2_69 wn_ih_2_69 0 0.4925360535224913
Vwp_ih_0_70 wp_ih_0_70 0 0.4995876524945427
Vwn_ih_0_70 wn_ih_0_70 0 0.5004123475054573
Vwp_ih_1_70 wp_ih_1_70 0 0.4999276192449031
Vwn_ih_1_70 wn_ih_1_70 0 0.5000723807550969
Vwp_ih_2_70 wp_ih_2_70 0 0.4990817280119597
Vwn_ih_2_70 wn_ih_2_70 0 0.5009182719880403
Vwp_ih_0_71 wp_ih_0_71 0 0.512751866855599
Vwn_ih_0_71 wn_ih_0_71 0 0.4872481331444009
Vwp_ih_1_71 wp_ih_1_71 0 0.5065694882452271
Vwn_ih_1_71 wn_ih_1_71 0 0.493430511754773
Vwp_ih_2_71 wp_ih_2_71 0 0.5013420542241092
Vwn_ih_2_71 wn_ih_2_71 0 0.49865794577589084
Vwp_ih_0_72 wp_ih_0_72 0 0.4917861847553495
Vwn_ih_0_72 wn_ih_0_72 0 0.5082138152446505
Vwp_ih_1_72 wp_ih_1_72 0 0.49263301319142466
Vwn_ih_1_72 wn_ih_1_72 0 0.5073669868085754
Vwp_ih_2_72 wp_ih_2_72 0 0.39782886260763795
Vwn_ih_2_72 wn_ih_2_72 0 0.602171137392362
Vwp_ih_0_73 wp_ih_0_73 0 0.5736642071335482
Vwn_ih_0_73 wn_ih_0_73 0 0.42633579286645185
Vwp_ih_1_73 wp_ih_1_73 0 0.43911103835201876
Vwn_ih_1_73 wn_ih_1_73 0 0.5608889616479813
Vwp_ih_2_73 wp_ih_2_73 0 0.5628393583431431
Vwn_ih_2_73 wn_ih_2_73 0 0.43716064165685686
Vwp_ih_0_74 wp_ih_0_74 0 0.4911353312926564
Vwn_ih_0_74 wn_ih_0_74 0 0.5088646687073436
Vwp_ih_1_74 wp_ih_1_74 0 0.492177660291895
Vwn_ih_1_74 wn_ih_1_74 0 0.507822339708105
Vwp_ih_2_74 wp_ih_2_74 0 0.45215581964201246
Vwn_ih_2_74 wn_ih_2_74 0 0.5478441803579875
Vwp_ih_0_75 wp_ih_0_75 0 0.5060681252029554
Vwn_ih_0_75 wn_ih_0_75 0 0.49393187479704453
Vwp_ih_1_75 wp_ih_1_75 0 0.5047163428424785
Vwn_ih_1_75 wn_ih_1_75 0 0.4952836571575216
Vwp_ih_2_75 wp_ih_2_75 0 0.6475371155634027
Vwn_ih_2_75 wn_ih_2_75 0 0.35246288443659735
Vwp_ih_0_76 wp_ih_0_76 0 0.3209769744036799
Vwn_ih_0_76 wn_ih_0_76 0 0.6790230255963201
Vwp_ih_1_76 wp_ih_1_76 0 0.5369927481193162
Vwn_ih_1_76 wn_ih_1_76 0 0.4630072518806838
Vwp_ih_2_76 wp_ih_2_76 0 0.3692463928110672
Vwn_ih_2_76 wn_ih_2_76 0 0.6307536071889328
Vwp_ih_0_77 wp_ih_0_77 0 0.32770205994690804
Vwn_ih_0_77 wn_ih_0_77 0 0.672297940053092
Vwp_ih_1_77 wp_ih_1_77 0 0.8005718336305907
Vwn_ih_1_77 wn_ih_1_77 0 0.3
Vwp_ih_2_77 wp_ih_2_77 0 0.3
Vwn_ih_2_77 wn_ih_2_77 0 0.8976921868475932
Vwp_ih_0_78 wp_ih_0_78 0 0.33630683422161745
Vwn_ih_0_78 wn_ih_0_78 0 0.6636931657783826
Vwp_ih_1_78 wp_ih_1_78 0 0.3
Vwn_ih_1_78 wn_ih_1_78 0 0.8158403953411013
Vwp_ih_2_78 wp_ih_2_78 0 0.3
Vwn_ih_2_78 wn_ih_2_78 0 0.899
Vwp_ih_0_79 wp_ih_0_79 0 0.4577810379134101
Vwn_ih_0_79 wn_ih_0_79 0 0.5422189620865899
Vwp_ih_1_79 wp_ih_1_79 0 0.4191791486599938
Vwn_ih_1_79 wn_ih_1_79 0 0.5808208513400063
Vwp_ih_2_79 wp_ih_2_79 0 0.531365188457818
Vwn_ih_2_79 wn_ih_2_79 0 0.468634811542182
Vwp_ih_0_80 wp_ih_0_80 0 0.5020753374702088
Vwn_ih_0_80 wn_ih_0_80 0 0.4979246625297911
Vwp_ih_1_80 wp_ih_1_80 0 0.5012588461379329
Vwn_ih_1_80 wn_ih_1_80 0 0.4987411538620671
Vwp_ih_2_80 wp_ih_2_80 0 0.899
Vwn_ih_2_80 wn_ih_2_80 0 0.3
Vwp_ih_0_81 wp_ih_0_81 0 0.5089826704394302
Vwn_ih_0_81 wn_ih_0_81 0 0.49101732956056976
Vwp_ih_1_81 wp_ih_1_81 0 0.5080890428845273
Vwn_ih_1_81 wn_ih_1_81 0 0.4919109571154728
Vwp_ih_2_81 wp_ih_2_81 0 0.5886366917759274
Vwn_ih_2_81 wn_ih_2_81 0 0.41136330822407263
Vwp_ih_0_82 wp_ih_0_82 0 0.899
Vwn_ih_0_82 wn_ih_0_82 0 0.3
Vwp_ih_1_82 wp_ih_1_82 0 0.5440597953350697
Vwn_ih_1_82 wn_ih_1_82 0 0.45594020466493035
Vwp_ih_2_82 wp_ih_2_82 0 0.34180174763776805
Vwn_ih_2_82 wn_ih_2_82 0 0.658198252362232
Vwp_ih_0_83 wp_ih_0_83 0 0.49999973401666836
Vwn_ih_0_83 wn_ih_0_83 0 0.5000002659833316
Vwp_ih_1_83 wp_ih_1_83 0 0.4999990119052275
Vwn_ih_1_83 wn_ih_1_83 0 0.5000009880947724
Vwp_ih_2_83 wp_ih_2_83 0 0.5000024925245562
Vwn_ih_2_83 wn_ih_2_83 0 0.4999975074754438
Vwp_ih_0_84 wp_ih_0_84 0 0.4979387751674263
Vwn_ih_0_84 wn_ih_0_84 0 0.5020612248325738
Vwp_ih_1_84 wp_ih_1_84 0 0.49882223111593355
Vwn_ih_1_84 wn_ih_1_84 0 0.5011777688840664
Vwp_ih_2_84 wp_ih_2_84 0 0.3
Vwn_ih_2_84 wn_ih_2_84 0 0.899
Vwp_ih_0_85 wp_ih_0_85 0 0.5001205495080536
Vwn_ih_0_85 wn_ih_0_85 0 0.4998794504919464
Vwp_ih_1_85 wp_ih_1_85 0 0.5001394102963986
Vwn_ih_1_85 wn_ih_1_85 0 0.4998605897036013
Vwp_ih_2_85 wp_ih_2_85 0 0.5000377143898032
Vwn_ih_2_85 wn_ih_2_85 0 0.49996228561019684
Vwp_ih_0_86 wp_ih_0_86 0 0.49708585244248016
Vwn_ih_0_86 wn_ih_0_86 0 0.5029141475575198
Vwp_ih_1_86 wp_ih_1_86 0 0.49782712323011696
Vwn_ih_1_86 wn_ih_1_86 0 0.5021728767698831
Vwp_ih_2_86 wp_ih_2_86 0 0.49247122745601163
Vwn_ih_2_86 wn_ih_2_86 0 0.5075287725439884
Vwp_ih_0_87 wp_ih_0_87 0 0.4979909183787483
Vwn_ih_0_87 wn_ih_0_87 0 0.5020090816212517
Vwp_ih_1_87 wp_ih_1_87 0 0.4990121878104417
Vwn_ih_1_87 wn_ih_1_87 0 0.5009878121895583
Vwp_ih_2_87 wp_ih_2_87 0 0.4972296262279479
Vwn_ih_2_87 wn_ih_2_87 0 0.5027703737720521
Vwp_ih_0_88 wp_ih_0_88 0 0.42316143962723785
Vwn_ih_0_88 wn_ih_0_88 0 0.5768385603727622
Vwp_ih_1_88 wp_ih_1_88 0 0.3
Vwn_ih_1_88 wn_ih_1_88 0 0.899
Vwp_ih_2_88 wp_ih_2_88 0 0.3236861533679263
Vwn_ih_2_88 wn_ih_2_88 0 0.6763138466320737
Vwp_ih_0_89 wp_ih_0_89 0 0.3
Vwn_ih_0_89 wn_ih_0_89 0 0.899
Vwp_ih_1_89 wp_ih_1_89 0 0.43858502826107715
Vwn_ih_1_89 wn_ih_1_89 0 0.5614149717389229
Vwp_ih_2_89 wp_ih_2_89 0 0.34744245896564135
Vwn_ih_2_89 wn_ih_2_89 0 0.6525575410343587
Vwp_ih_0_90 wp_ih_0_90 0 0.5012771264095699
Vwn_ih_0_90 wn_ih_0_90 0 0.4987228735904301
Vwp_ih_1_90 wp_ih_1_90 0 0.5006292923905948
Vwn_ih_1_90 wn_ih_1_90 0 0.49937070760940516
Vwp_ih_2_90 wp_ih_2_90 0 0.5028949509429592
Vwn_ih_2_90 wn_ih_2_90 0 0.49710504905704084
Vwp_ih_0_91 wp_ih_0_91 0 0.4997241143435749
Vwn_ih_0_91 wn_ih_0_91 0 0.5002758856564251
Vwp_ih_1_91 wp_ih_1_91 0 0.49993903073064594
Vwn_ih_1_91 wn_ih_1_91 0 0.5000609692693541
Vwp_ih_2_91 wp_ih_2_91 0 0.49945947924263
Vwn_ih_2_91 wn_ih_2_91 0 0.50054052075737
Vwp_ih_0_92 wp_ih_0_92 0 0.5027443205243788
Vwn_ih_0_92 wn_ih_0_92 0 0.4972556794756212
Vwp_ih_1_92 wp_ih_1_92 0 0.5018759991295186
Vwn_ih_1_92 wn_ih_1_92 0 0.49812400087048136
Vwp_ih_2_92 wp_ih_2_92 0 0.7937991111986746
Vwn_ih_2_92 wn_ih_2_92 0 0.3
Vwp_ih_0_93 wp_ih_0_93 0 0.5086833422653118
Vwn_ih_0_93 wn_ih_0_93 0 0.49131665773468824
Vwp_ih_1_93 wp_ih_1_93 0 0.5081446670692833
Vwn_ih_1_93 wn_ih_1_93 0 0.4918553329307167
Vwp_ih_2_93 wp_ih_2_93 0 0.5483479924243038
Vwn_ih_2_93 wn_ih_2_93 0 0.4516520075756963
Vwp_ih_0_94 wp_ih_0_94 0 0.5000033711918693
Vwn_ih_0_94 wn_ih_0_94 0 0.4999966288081306
Vwp_ih_1_94 wp_ih_1_94 0 0.500004263569557
Vwn_ih_1_94 wn_ih_1_94 0 0.49999573643044304
Vwp_ih_2_94 wp_ih_2_94 0 0.49999647520883916
Vwn_ih_2_94 wn_ih_2_94 0 0.5000035247911608
Vwp_ih_0_95 wp_ih_0_95 0 0.4839244303629845
Vwn_ih_0_95 wn_ih_0_95 0 0.5160755696370155
Vwp_ih_1_95 wp_ih_1_95 0 0.49775026430417585
Vwn_ih_1_95 wn_ih_1_95 0 0.5022497356958242
Vwp_ih_2_95 wp_ih_2_95 0 0.48730897010820073
Vwn_ih_2_95 wn_ih_2_95 0 0.5126910298917993
Vwp_ih_0_96 wp_ih_0_96 0 0.5355985994656008
Vwn_ih_0_96 wn_ih_0_96 0 0.4644014005343992
Vwp_ih_1_96 wp_ih_1_96 0 0.5157280776816433
Vwn_ih_1_96 wn_ih_1_96 0 0.48427192231835664
Vwp_ih_2_96 wp_ih_2_96 0 0.5390679960391902
Vwn_ih_2_96 wn_ih_2_96 0 0.4609320039608098
Vwp_ih_0_97 wp_ih_0_97 0 0.4882371617481834
Vwn_ih_0_97 wn_ih_0_97 0 0.5117628382518166
Vwp_ih_1_97 wp_ih_1_97 0 0.4959052212277185
Vwn_ih_1_97 wn_ih_1_97 0 0.5040947787722815
Vwp_ih_2_97 wp_ih_2_97 0 0.4717770920511711
Vwn_ih_2_97 wn_ih_2_97 0 0.528222907948829
Vwp_ih_0_98 wp_ih_0_98 0 0.5022069979360354
Vwn_ih_0_98 wn_ih_0_98 0 0.49779300206396465
Vwp_ih_1_98 wp_ih_1_98 0 0.5013221018498961
Vwn_ih_1_98 wn_ih_1_98 0 0.49867789815010394
Vwp_ih_2_98 wp_ih_2_98 0 0.899
Vwn_ih_2_98 wn_ih_2_98 0 0.3
Vwp_ih_0_99 wp_ih_0_99 0 0.899
Vwn_ih_0_99 wn_ih_0_99 0 0.3
Vwp_ih_1_99 wp_ih_1_99 0 0.4328098213515172
Vwn_ih_1_99 wn_ih_1_99 0 0.5671901786484828
Vwp_ih_2_99 wp_ih_2_99 0 0.34785260433147586
Vwn_ih_2_99 wn_ih_2_99 0 0.6521473956685242
Vwp_ih_0_100 wp_ih_0_100 0 0.4903611050668931
Vwn_ih_0_100 wn_ih_0_100 0 0.5096388949331069
Vwp_ih_1_100 wp_ih_1_100 0 0.4932724612525851
Vwn_ih_1_100 wn_ih_1_100 0 0.5067275387474149
Vwp_ih_2_100 wp_ih_2_100 0 0.4811919529384036
Vwn_ih_2_100 wn_ih_2_100 0 0.5188080470615963
Vwp_ih_0_101 wp_ih_0_101 0 0.3911178771900363
Vwn_ih_0_101 wn_ih_0_101 0 0.6088821228099637
Vwp_ih_1_101 wp_ih_1_101 0 0.5131900313413695
Vwn_ih_1_101 wn_ih_1_101 0 0.4868099686586304
Vwp_ih_2_101 wp_ih_2_101 0 0.4241055792701757
Vwn_ih_2_101 wn_ih_2_101 0 0.5758944207298242
Vwp_ih_0_102 wp_ih_0_102 0 0.4349381723476699
Vwn_ih_0_102 wn_ih_0_102 0 0.56506182765233
Vwp_ih_1_102 wp_ih_1_102 0 0.32274151719523136
Vwn_ih_1_102 wn_ih_1_102 0 0.6772584828047686
Vwp_ih_2_102 wp_ih_2_102 0 0.6336275321975026
Vwn_ih_2_102 wn_ih_2_102 0 0.36637246780249744
Vwp_ih_0_103 wp_ih_0_103 0 0.5090573197007927
Vwn_ih_0_103 wn_ih_0_103 0 0.49094268029920735
Vwp_ih_1_103 wp_ih_1_103 0 0.5035699531383202
Vwn_ih_1_103 wn_ih_1_103 0 0.4964300468616798
Vwp_ih_2_103 wp_ih_2_103 0 0.5117604688233719
Vwn_ih_2_103 wn_ih_2_103 0 0.4882395311766281
Vwp_ih_0_104 wp_ih_0_104 0 0.48291867360198787
Vwn_ih_0_104 wn_ih_0_104 0 0.5170813263980121
Vwp_ih_1_104 wp_ih_1_104 0 0.48848759598003066
Vwn_ih_1_104 wn_ih_1_104 0 0.5115124040199693
Vwp_ih_2_104 wp_ih_2_104 0 0.48813591062900186
Vwn_ih_2_104 wn_ih_2_104 0 0.5118640893709981
Vwp_ih_0_105 wp_ih_0_105 0 0.508377283160751
Vwn_ih_0_105 wn_ih_0_105 0 0.49162271683924896
Vwp_ih_1_105 wp_ih_1_105 0 0.5080456504101227
Vwn_ih_1_105 wn_ih_1_105 0 0.4919543495898773
Vwp_ih_2_105 wp_ih_2_105 0 0.5568176668252104
Vwn_ih_2_105 wn_ih_2_105 0 0.4431823331747896
Vwp_ih_0_106 wp_ih_0_106 0 0.899
Vwn_ih_0_106 wn_ih_0_106 0 0.3
Vwp_ih_1_106 wp_ih_1_106 0 0.4858572665765994
Vwn_ih_1_106 wn_ih_1_106 0 0.5141427334234007
Vwp_ih_2_106 wp_ih_2_106 0 0.6544624835600757
Vwn_ih_2_106 wn_ih_2_106 0 0.34553751643992425
Vwp_ih_0_107 wp_ih_0_107 0 0.4412046268543916
Vwn_ih_0_107 wn_ih_0_107 0 0.5587953731456083
Vwp_ih_1_107 wp_ih_1_107 0 0.42852081159275024
Vwn_ih_1_107 wn_ih_1_107 0 0.5714791884072498
Vwp_ih_2_107 wp_ih_2_107 0 0.4479927741030509
Vwn_ih_2_107 wn_ih_2_107 0 0.5520072258969492
Vwp_ih_0_108 wp_ih_0_108 0 0.509082598375345
Vwn_ih_0_108 wn_ih_0_108 0 0.49091740162465497
Vwp_ih_1_108 wp_ih_1_108 0 0.507760678744155
Vwn_ih_1_108 wn_ih_1_108 0 0.492239321255845
Vwp_ih_2_108 wp_ih_2_108 0 0.5651102129267835
Vwn_ih_2_108 wn_ih_2_108 0 0.43488978707321646
Vwp_ih_0_109 wp_ih_0_109 0 0.4445806105910916
Vwn_ih_0_109 wn_ih_0_109 0 0.5554193894089084
Vwp_ih_1_109 wp_ih_1_109 0 0.3
Vwn_ih_1_109 wn_ih_1_109 0 0.899
Vwp_ih_2_109 wp_ih_2_109 0 0.6584075961164759
Vwn_ih_2_109 wn_ih_2_109 0 0.3415924038835241
Vwp_ih_0_110 wp_ih_0_110 0 0.5255750529836601
Vwn_ih_0_110 wn_ih_0_110 0 0.47442494701633986
Vwp_ih_1_110 wp_ih_1_110 0 0.43364339254473805
Vwn_ih_1_110 wn_ih_1_110 0 0.566356607455262
Vwp_ih_2_110 wp_ih_2_110 0 0.430457758459755
Vwn_ih_2_110 wn_ih_2_110 0 0.569542241540245
Vwp_ih_0_111 wp_ih_0_111 0 0.5000065279994232
Vwn_ih_0_111 wn_ih_0_111 0 0.49999347200057676
Vwp_ih_1_111 wp_ih_1_111 0 0.4999612305984504
Vwn_ih_1_111 wn_ih_1_111 0 0.5000387694015496
Vwp_ih_2_111 wp_ih_2_111 0 0.5000265039836687
Vwn_ih_2_111 wn_ih_2_111 0 0.4999734960163314
Vwp_ih_0_112 wp_ih_0_112 0 0.5051782298958316
Vwn_ih_0_112 wn_ih_0_112 0 0.4948217701041684
Vwp_ih_1_112 wp_ih_1_112 0 0.5040516756038854
Vwn_ih_1_112 wn_ih_1_112 0 0.4959483243961146
Vwp_ih_2_112 wp_ih_2_112 0 0.5165544179545272
Vwn_ih_2_112 wn_ih_2_112 0 0.48344558204547283
Vwp_ih_0_113 wp_ih_0_113 0 0.5054197152530222
Vwn_ih_0_113 wn_ih_0_113 0 0.49458028474697774
Vwp_ih_1_113 wp_ih_1_113 0 0.5026912760602033
Vwn_ih_1_113 wn_ih_1_113 0 0.4973087239397967
Vwp_ih_2_113 wp_ih_2_113 0 0.6711829731234571
Vwn_ih_2_113 wn_ih_2_113 0 0.32881702687654285
Vwp_ih_0_114 wp_ih_0_114 0 0.5000009139085965
Vwn_ih_0_114 wn_ih_0_114 0 0.4999990860914035
Vwp_ih_1_114 wp_ih_1_114 0 0.4999995925648645
Vwn_ih_1_114 wn_ih_1_114 0 0.5000004074351355
Vwp_ih_2_114 wp_ih_2_114 0 0.5000024672445988
Vwn_ih_2_114 wn_ih_2_114 0 0.49999753275540115
Vwp_ih_0_115 wp_ih_0_115 0 0.5922374779723337
Vwn_ih_0_115 wn_ih_0_115 0 0.40776252202766633
Vwp_ih_1_115 wp_ih_1_115 0 0.5753119380831354
Vwn_ih_1_115 wn_ih_1_115 0 0.4246880619168646
Vwp_ih_2_115 wp_ih_2_115 0 0.45458562642790207
Vwn_ih_2_115 wn_ih_2_115 0 0.545414373572098
Vwp_ih_0_116 wp_ih_0_116 0 0.49767306793849286
Vwn_ih_0_116 wn_ih_0_116 0 0.5023269320615071
Vwp_ih_1_116 wp_ih_1_116 0 0.49868026262655496
Vwn_ih_1_116 wn_ih_1_116 0 0.501319737373445
Vwp_ih_2_116 wp_ih_2_116 0 0.4922588073487938
Vwn_ih_2_116 wn_ih_2_116 0 0.5077411926512062
Vwp_ih_0_117 wp_ih_0_117 0 0.5007518100880404
Vwn_ih_0_117 wn_ih_0_117 0 0.49924818991195963
Vwp_ih_1_117 wp_ih_1_117 0 0.49968375716119573
Vwn_ih_1_117 wn_ih_1_117 0 0.5003162428388043
Vwp_ih_2_117 wp_ih_2_117 0 0.5052411583860695
Vwn_ih_2_117 wn_ih_2_117 0 0.4947588416139305
Vwp_ih_0_118 wp_ih_0_118 0 0.525577522139488
Vwn_ih_0_118 wn_ih_0_118 0 0.4744224778605119
Vwp_ih_1_118 wp_ih_1_118 0 0.5704467434197814
Vwn_ih_1_118 wn_ih_1_118 0 0.4295532565802186
Vwp_ih_2_118 wp_ih_2_118 0 0.4807961223253601
Vwn_ih_2_118 wn_ih_2_118 0 0.5192038776746399
Vwp_ih_0_119 wp_ih_0_119 0 0.3
Vwn_ih_0_119 wn_ih_0_119 0 0.899
Vwp_ih_1_119 wp_ih_1_119 0 0.44918743187751375
Vwn_ih_1_119 wn_ih_1_119 0 0.5508125681224862
Vwp_ih_2_119 wp_ih_2_119 0 0.6585512171389478
Vwn_ih_2_119 wn_ih_2_119 0 0.3414487828610521
Vwp_ih_0_120 wp_ih_0_120 0 0.5027762132656838
Vwn_ih_0_120 wn_ih_0_120 0 0.49722378673431616
Vwp_ih_1_120 wp_ih_1_120 0 0.503276663730262
Vwn_ih_1_120 wn_ih_1_120 0 0.4967233362697379
Vwp_ih_2_120 wp_ih_2_120 0 0.7712256588257236
Vwn_ih_2_120 wn_ih_2_120 0 0.3
Vwp_ih_0_121 wp_ih_0_121 0 0.5009598397736809
Vwn_ih_0_121 wn_ih_0_121 0 0.4990401602263191
Vwp_ih_1_121 wp_ih_1_121 0 0.3
Vwn_ih_1_121 wn_ih_1_121 0 0.899
Vwp_ih_2_121 wp_ih_2_121 0 0.33143438944386644
Vwn_ih_2_121 wn_ih_2_121 0 0.6685656105561335
Vwp_ih_0_122 wp_ih_0_122 0 0.5001627102626572
Vwn_ih_0_122 wn_ih_0_122 0 0.4998372897373427
Vwp_ih_1_122 wp_ih_1_122 0 0.5000674476698638
Vwn_ih_1_122 wn_ih_1_122 0 0.49993255233013617
Vwp_ih_2_122 wp_ih_2_122 0 0.5002698295773061
Vwn_ih_2_122 wn_ih_2_122 0 0.4997301704226939
Vwp_ih_0_123 wp_ih_0_123 0 0.5606558997378926
Vwn_ih_0_123 wn_ih_0_123 0 0.43934410026210735
Vwp_ih_1_123 wp_ih_1_123 0 0.899
Vwn_ih_1_123 wn_ih_1_123 0 0.3
Vwp_ih_2_123 wp_ih_2_123 0 0.34325200348521767
Vwn_ih_2_123 wn_ih_2_123 0 0.6567479965147823
Vwp_ih_0_124 wp_ih_0_124 0 0.34977159117063206
Vwn_ih_0_124 wn_ih_0_124 0 0.6502284088293679
Vwp_ih_1_124 wp_ih_1_124 0 0.37430413285103403
Vwn_ih_1_124 wn_ih_1_124 0 0.625695867148966
Vwp_ih_2_124 wp_ih_2_124 0 0.36577261978326053
Vwn_ih_2_124 wn_ih_2_124 0 0.6342273802167395
Vwp_ih_0_125 wp_ih_0_125 0 0.6578352135483259
Vwn_ih_0_125 wn_ih_0_125 0 0.34216478645167414
Vwp_ih_1_125 wp_ih_1_125 0 0.46281836250242075
Vwn_ih_1_125 wn_ih_1_125 0 0.5371816374975792
Vwp_ih_2_125 wp_ih_2_125 0 0.4224463664429981
Vwn_ih_2_125 wn_ih_2_125 0 0.577553633557002
Vwp_ih_0_126 wp_ih_0_126 0 0.45257449590189985
Vwn_ih_0_126 wn_ih_0_126 0 0.5474255040981001
Vwp_ih_1_126 wp_ih_1_126 0 0.48028533871902473
Vwn_ih_1_126 wn_ih_1_126 0 0.5197146612809753
Vwp_ih_2_126 wp_ih_2_126 0 0.5094708678525808
Vwn_ih_2_126 wn_ih_2_126 0 0.4905291321474193
Vwp_ih_0_127 wp_ih_0_127 0 0.6564771454835612
Vwn_ih_0_127 wn_ih_0_127 0 0.3435228545164388
Vwp_ih_1_127 wp_ih_1_127 0 0.6338928839776371
Vwn_ih_1_127 wn_ih_1_127 0 0.3661071160223629
Vwp_ih_2_127 wp_ih_2_127 0 0.6479533757328202
Vwn_ih_2_127 wn_ih_2_127 0 0.3520466242671798
Vwp_ih_0_128 wp_ih_0_128 0 0.5040021047260639
Vwn_ih_0_128 wn_ih_0_128 0 0.49599789527393606
Vwp_ih_1_128 wp_ih_1_128 0 0.5011615359176711
Vwn_ih_1_128 wn_ih_1_128 0 0.49883846408232896
Vwp_ih_2_128 wp_ih_2_128 0 0.5069244465712874
Vwn_ih_2_128 wn_ih_2_128 0 0.49307555342871257
Vwp_ih_0_129 wp_ih_0_129 0 0.899
Vwn_ih_0_129 wn_ih_0_129 0 0.3
Vwp_ih_1_129 wp_ih_1_129 0 0.564136190599719
Vwn_ih_1_129 wn_ih_1_129 0 0.435863809400281
Vwp_ih_2_129 wp_ih_2_129 0 0.6529895668738787
Vwn_ih_2_129 wn_ih_2_129 0 0.34701043312612134
Vwp_ih_0_130 wp_ih_0_130 0 0.4972554697358949
Vwn_ih_0_130 wn_ih_0_130 0 0.5027445302641051
Vwp_ih_1_130 wp_ih_1_130 0 0.49831339750884285
Vwn_ih_1_130 wn_ih_1_130 0 0.5016866024911572
Vwp_ih_2_130 wp_ih_2_130 0 0.3
Vwn_ih_2_130 wn_ih_2_130 0 0.7994004482010467
Vwp_ih_0_131 wp_ih_0_131 0 0.3
Vwn_ih_0_131 wn_ih_0_131 0 0.7804011428676266
Vwp_ih_1_131 wp_ih_1_131 0 0.3
Vwn_ih_1_131 wn_ih_1_131 0 0.7300930758654323
Vwp_ih_2_131 wp_ih_2_131 0 0.3
Vwn_ih_2_131 wn_ih_2_131 0 0.899
Vwp_ih_0_132 wp_ih_0_132 0 0.8947184741283052
Vwn_ih_0_132 wn_ih_0_132 0 0.3
Vwp_ih_1_132 wp_ih_1_132 0 0.8976348694978222
Vwn_ih_1_132 wn_ih_1_132 0 0.3
Vwp_ih_2_132 wp_ih_2_132 0 0.3
Vwn_ih_2_132 wn_ih_2_132 0 0.7294533600178897
Vwp_ih_0_133 wp_ih_0_133 0 0.5020851310115105
Vwn_ih_0_133 wn_ih_0_133 0 0.4979148689884894
Vwp_ih_1_133 wp_ih_1_133 0 0.5009368125649711
Vwn_ih_1_133 wn_ih_1_133 0 0.4990631874350288
Vwp_ih_2_133 wp_ih_2_133 0 0.899
Vwn_ih_2_133 wn_ih_2_133 0 0.3
Vwp_ih_0_134 wp_ih_0_134 0 0.5000001775293972
Vwn_ih_0_134 wn_ih_0_134 0 0.49999982247060276
Vwp_ih_1_134 wp_ih_1_134 0 0.5000002921895816
Vwn_ih_1_134 wn_ih_1_134 0 0.49999970781041836
Vwp_ih_2_134 wp_ih_2_134 0 0.4999991451740548
Vwn_ih_2_134 wn_ih_2_134 0 0.5000008548259453
Vwp_ih_0_135 wp_ih_0_135 0 0.5012517010431291
Vwn_ih_0_135 wn_ih_0_135 0 0.49874829895687095
Vwp_ih_1_135 wp_ih_1_135 0 0.5007228048325474
Vwn_ih_1_135 wn_ih_1_135 0 0.4992771951674526
Vwp_ih_2_135 wp_ih_2_135 0 0.5021690568830321
Vwn_ih_2_135 wn_ih_2_135 0 0.49783094311696785
Vwp_ih_0_136 wp_ih_0_136 0 0.44318733971683943
Vwn_ih_0_136 wn_ih_0_136 0 0.5568126602831606
Vwp_ih_1_136 wp_ih_1_136 0 0.4675171078534602
Vwn_ih_1_136 wn_ih_1_136 0 0.5324828921465398
Vwp_ih_2_136 wp_ih_2_136 0 0.45263510013774405
Vwn_ih_2_136 wn_ih_2_136 0 0.547364899862256
Vwp_ih_0_137 wp_ih_0_137 0 0.6398663650053844
Vwn_ih_0_137 wn_ih_0_137 0 0.36013363499461554
Vwp_ih_1_137 wp_ih_1_137 0 0.899
Vwn_ih_1_137 wn_ih_1_137 0 0.3
Vwp_ih_2_137 wp_ih_2_137 0 0.3468614681347668
Vwn_ih_2_137 wn_ih_2_137 0 0.6531385318652332
Vwp_ih_0_138 wp_ih_0_138 0 0.5002748740260662
Vwn_ih_0_138 wn_ih_0_138 0 0.49972512597393387
Vwp_ih_1_138 wp_ih_1_138 0 0.5000671676265841
Vwn_ih_1_138 wn_ih_1_138 0 0.49993283237341585
Vwp_ih_2_138 wp_ih_2_138 0 0.5004515822278606
Vwn_ih_2_138 wn_ih_2_138 0 0.4995484177721395
Vwp_ih_0_139 wp_ih_0_139 0 0.5065544613291584
Vwn_ih_0_139 wn_ih_0_139 0 0.4934455386708417
Vwp_ih_1_139 wp_ih_1_139 0 0.5041967771569289
Vwn_ih_1_139 wn_ih_1_139 0 0.4958032228430711
Vwp_ih_2_139 wp_ih_2_139 0 0.5070881527171112
Vwn_ih_2_139 wn_ih_2_139 0 0.4929118472828889
Vwp_ih_0_140 wp_ih_0_140 0 0.49988818352278114
Vwn_ih_0_140 wn_ih_0_140 0 0.5001118164772188
Vwp_ih_1_140 wp_ih_1_140 0 0.49998309096963117
Vwn_ih_1_140 wn_ih_1_140 0 0.5000169090303689
Vwp_ih_2_140 wp_ih_2_140 0 0.4997888784130203
Vwn_ih_2_140 wn_ih_2_140 0 0.5002111215869798
Vwp_ih_0_141 wp_ih_0_141 0 0.3
Vwn_ih_0_141 wn_ih_0_141 0 0.7642786985685937
Vwp_ih_1_141 wp_ih_1_141 0 0.3
Vwn_ih_1_141 wn_ih_1_141 0 0.7470795967288163
Vwp_ih_2_141 wp_ih_2_141 0 0.3
Vwn_ih_2_141 wn_ih_2_141 0 0.8988082028295953
Vwp_ih_0_142 wp_ih_0_142 0 0.5002030521164905
Vwn_ih_0_142 wn_ih_0_142 0 0.4997969478835095
Vwp_ih_1_142 wp_ih_1_142 0 0.5000282364555229
Vwn_ih_1_142 wn_ih_1_142 0 0.49997176354447714
Vwp_ih_2_142 wp_ih_2_142 0 0.5005330972963461
Vwn_ih_2_142 wn_ih_2_142 0 0.4994669027036539
Vwp_ih_0_143 wp_ih_0_143 0 0.49994451104209686
Vwn_ih_0_143 wn_ih_0_143 0 0.5000554889579032
Vwp_ih_1_143 wp_ih_1_143 0 0.5000322872835327
Vwn_ih_1_143 wn_ih_1_143 0 0.4999677127164674
Vwp_ih_2_143 wp_ih_2_143 0 0.499894238256401
Vwn_ih_2_143 wn_ih_2_143 0 0.500105761743599
Vwp_ih_0_144 wp_ih_0_144 0 0.5004381828929192
Vwn_ih_0_144 wn_ih_0_144 0 0.49956181710708075
Vwp_ih_1_144 wp_ih_1_144 0 0.5001538884838572
Vwn_ih_1_144 wn_ih_1_144 0 0.4998461115161428
Vwp_ih_2_144 wp_ih_2_144 0 0.5009565620880122
Vwn_ih_2_144 wn_ih_2_144 0 0.4990434379119878
Vwp_ih_0_145 wp_ih_0_145 0 0.5000011317003241
Vwn_ih_0_145 wn_ih_0_145 0 0.49999886829967594
Vwp_ih_1_145 wp_ih_1_145 0 0.49999744838637666
Vwn_ih_1_145 wn_ih_1_145 0 0.5000025516136234
Vwp_ih_2_145 wp_ih_2_145 0 0.5000006742591401
Vwn_ih_2_145 wn_ih_2_145 0 0.4999993257408599
Vwp_ih_0_146 wp_ih_0_146 0 0.5134893713779427
Vwn_ih_0_146 wn_ih_0_146 0 0.48651062862205724
Vwp_ih_1_146 wp_ih_1_146 0 0.5109191425023499
Vwn_ih_1_146 wn_ih_1_146 0 0.4890808574976501
Vwp_ih_2_146 wp_ih_2_146 0 0.5699307481348537
Vwn_ih_2_146 wn_ih_2_146 0 0.43006925186514633
Vwp_ih_0_147 wp_ih_0_147 0 0.48152178370608323
Vwn_ih_0_147 wn_ih_0_147 0 0.5184782162939168
Vwp_ih_1_147 wp_ih_1_147 0 0.4977906635131395
Vwn_ih_1_147 wn_ih_1_147 0 0.5022093364868605
Vwp_ih_2_147 wp_ih_2_147 0 0.4372632940151642
Vwn_ih_2_147 wn_ih_2_147 0 0.5627367059848358
Vwp_ih_0_148 wp_ih_0_148 0 0.6489933404752496
Vwn_ih_0_148 wn_ih_0_148 0 0.3510066595247504
Vwp_ih_1_148 wp_ih_1_148 0 0.5462041522307639
Vwn_ih_1_148 wn_ih_1_148 0 0.45379584776923615
Vwp_ih_2_148 wp_ih_2_148 0 0.5958859769939413
Vwn_ih_2_148 wn_ih_2_148 0 0.40411402300605864
Vwp_ih_0_149 wp_ih_0_149 0 0.5066771431779852
Vwn_ih_0_149 wn_ih_0_149 0 0.4933228568220148
Vwp_ih_1_149 wp_ih_1_149 0 0.5068562744066707
Vwn_ih_1_149 wn_ih_1_149 0 0.49314372559332925
Vwp_ih_2_149 wp_ih_2_149 0 0.5983929404847839
Vwn_ih_2_149 wn_ih_2_149 0 0.4016070595152162
Vwp_ih_0_150 wp_ih_0_150 0 0.3
Vwn_ih_0_150 wn_ih_0_150 0 0.899
Vwp_ih_1_150 wp_ih_1_150 0 0.40961723765768043
Vwn_ih_1_150 wn_ih_1_150 0 0.5903827623423196
Vwp_ih_2_150 wp_ih_2_150 0 0.34502356393039846
Vwn_ih_2_150 wn_ih_2_150 0 0.6549764360696015
Vwp_ih_0_151 wp_ih_0_151 0 0.49772878571863205
Vwn_ih_0_151 wn_ih_0_151 0 0.502271214281368
Vwp_ih_1_151 wp_ih_1_151 0 0.4982470408409935
Vwn_ih_1_151 wn_ih_1_151 0 0.5017529591590064
Vwp_ih_2_151 wp_ih_2_151 0 0.49451262581541705
Vwn_ih_2_151 wn_ih_2_151 0 0.5054873741845829
Vwp_ih_0_152 wp_ih_0_152 0 0.3
Vwn_ih_0_152 wn_ih_0_152 0 0.7297025073375629
Vwp_ih_1_152 wp_ih_1_152 0 0.7670806965918548
Vwn_ih_1_152 wn_ih_1_152 0 0.3
Vwp_ih_2_152 wp_ih_2_152 0 0.3
Vwn_ih_2_152 wn_ih_2_152 0 0.8970929933267713
Vwp_ih_0_153 wp_ih_0_153 0 0.7249011155778824
Vwn_ih_0_153 wn_ih_0_153 0 0.3
Vwp_ih_1_153 wp_ih_1_153 0 0.7890583578209472
Vwn_ih_1_153 wn_ih_1_153 0 0.3
Vwp_ih_2_153 wp_ih_2_153 0 0.3
Vwn_ih_2_153 wn_ih_2_153 0 0.8981334711457848
Vwp_ih_0_154 wp_ih_0_154 0 0.5044062941822025
Vwn_ih_0_154 wn_ih_0_154 0 0.49559370581779755
Vwp_ih_1_154 wp_ih_1_154 0 0.5037704477677648
Vwn_ih_1_154 wn_ih_1_154 0 0.4962295522322352
Vwp_ih_2_154 wp_ih_2_154 0 0.6951378419692615
Vwn_ih_2_154 wn_ih_2_154 0 0.30486215803073846
Vwp_ih_0_155 wp_ih_0_155 0 0.5059744987051634
Vwn_ih_0_155 wn_ih_0_155 0 0.4940255012948365
Vwp_ih_1_155 wp_ih_1_155 0 0.5050940991323094
Vwn_ih_1_155 wn_ih_1_155 0 0.4949059008676906
Vwp_ih_2_155 wp_ih_2_155 0 0.648203158132657
Vwn_ih_2_155 wn_ih_2_155 0 0.3517968418673429
Vwp_ih_0_156 wp_ih_0_156 0 0.3
Vwn_ih_0_156 wn_ih_0_156 0 0.7070366362330816
Vwp_ih_1_156 wp_ih_1_156 0 0.6371507453568925
Vwn_ih_1_156 wn_ih_1_156 0 0.3628492546431075
Vwp_ih_2_156 wp_ih_2_156 0 0.7137054561538942
Vwn_ih_2_156 wn_ih_2_156 0 0.3
Vwp_ih_0_157 wp_ih_0_157 0 0.49999783206705495
Vwn_ih_0_157 wn_ih_0_157 0 0.500002167932945
Vwp_ih_1_157 wp_ih_1_157 0 0.4999985095678897
Vwn_ih_1_157 wn_ih_1_157 0 0.5000014904321103
Vwp_ih_2_157 wp_ih_2_157 0 0.500002810505793
Vwn_ih_2_157 wn_ih_2_157 0 0.49999718949420696
Vwp_ih_0_158 wp_ih_0_158 0 0.49655944921636797
Vwn_ih_0_158 wn_ih_0_158 0 0.503440550783632
Vwp_ih_1_158 wp_ih_1_158 0 0.49804439040105014
Vwn_ih_1_158 wn_ih_1_158 0 0.5019556095989499
Vwp_ih_2_158 wp_ih_2_158 0 0.4897477770439098
Vwn_ih_2_158 wn_ih_2_158 0 0.5102522229560902
Vwp_ih_0_159 wp_ih_0_159 0 0.49503933424118257
Vwn_ih_0_159 wn_ih_0_159 0 0.5049606657588174
Vwp_ih_1_159 wp_ih_1_159 0 0.4962722802460539
Vwn_ih_1_159 wn_ih_1_159 0 0.503727719753946
Vwp_ih_2_159 wp_ih_2_159 0 0.32096009740293807
Vwn_ih_2_159 wn_ih_2_159 0 0.6790399025970619
Vwp_ih_0_160 wp_ih_0_160 0 0.5081972264706169
Vwn_ih_0_160 wn_ih_0_160 0 0.49180277352938306
Vwp_ih_1_160 wp_ih_1_160 0 0.5076984273664822
Vwn_ih_1_160 wn_ih_1_160 0 0.4923015726335178
Vwp_ih_2_160 wp_ih_2_160 0 0.6157298438914112
Vwn_ih_2_160 wn_ih_2_160 0 0.3842701561085888
Vwp_ih_0_161 wp_ih_0_161 0 0.4995768775379808
Vwn_ih_0_161 wn_ih_0_161 0 0.5004231224620191
Vwp_ih_1_161 wp_ih_1_161 0 0.49983049131870283
Vwn_ih_1_161 wn_ih_1_161 0 0.5001695086812972
Vwp_ih_2_161 wp_ih_2_161 0 0.4993014202082636
Vwn_ih_2_161 wn_ih_2_161 0 0.5006985797917364
Vwp_ih_0_162 wp_ih_0_162 0 0.5019410170019545
Vwn_ih_0_162 wn_ih_0_162 0 0.4980589829980455
Vwp_ih_1_162 wp_ih_1_162 0 0.5009347361741856
Vwn_ih_1_162 wn_ih_1_162 0 0.49906526382581445
Vwp_ih_2_162 wp_ih_2_162 0 0.5039651486422557
Vwn_ih_2_162 wn_ih_2_162 0 0.4960348513577443
Vwp_ih_0_163 wp_ih_0_163 0 0.5001934897385045
Vwn_ih_0_163 wn_ih_0_163 0 0.4998065102614955
Vwp_ih_1_163 wp_ih_1_163 0 0.5000329197431767
Vwn_ih_1_163 wn_ih_1_163 0 0.49996708025682335
Vwp_ih_2_163 wp_ih_2_163 0 0.500271724145247
Vwn_ih_2_163 wn_ih_2_163 0 0.49972827585475293
Vwp_ih_0_164 wp_ih_0_164 0 0.6300502276516048
Vwn_ih_0_164 wn_ih_0_164 0 0.3699497723483952
Vwp_ih_1_164 wp_ih_1_164 0 0.5925639586091976
Vwn_ih_1_164 wn_ih_1_164 0 0.4074360413908023
Vwp_ih_2_164 wp_ih_2_164 0 0.42880158438547256
Vwn_ih_2_164 wn_ih_2_164 0 0.5711984156145274
Vwp_ih_0_165 wp_ih_0_165 0 0.35496706381221727
Vwn_ih_0_165 wn_ih_0_165 0 0.6450329361877827
Vwp_ih_1_165 wp_ih_1_165 0 0.3754164505026809
Vwn_ih_1_165 wn_ih_1_165 0 0.6245835494973191
Vwp_ih_2_165 wp_ih_2_165 0 0.5993936468165816
Vwn_ih_2_165 wn_ih_2_165 0 0.4006063531834185
Vwp_ih_0_166 wp_ih_0_166 0 0.4957461970395723
Vwn_ih_0_166 wn_ih_0_166 0 0.5042538029604277
Vwp_ih_1_166 wp_ih_1_166 0 0.3
Vwn_ih_1_166 wn_ih_1_166 0 0.899
Vwp_ih_2_166 wp_ih_2_166 0 0.3308344625559144
Vwn_ih_2_166 wn_ih_2_166 0 0.6691655374440856
Vwp_ih_0_167 wp_ih_0_167 0 0.4999995863951273
Vwn_ih_0_167 wn_ih_0_167 0 0.5000004136048727
Vwp_ih_1_167 wp_ih_1_167 0 0.4999992088542932
Vwn_ih_1_167 wn_ih_1_167 0 0.5000007911457067
Vwp_ih_2_167 wp_ih_2_167 0 0.5000006630625194
Vwn_ih_2_167 wn_ih_2_167 0 0.49999933693748055
Vwp_ih_0_168 wp_ih_0_168 0 0.3
Vwn_ih_0_168 wn_ih_0_168 0 0.7056339055825724
Vwp_ih_1_168 wp_ih_1_168 0 0.6888240453829065
Vwn_ih_1_168 wn_ih_1_168 0 0.31117595461709346
Vwp_ih_2_168 wp_ih_2_168 0 0.3
Vwn_ih_2_168 wn_ih_2_168 0 0.8016326395318321
Vwp_ih_0_169 wp_ih_0_169 0 0.3
Vwn_ih_0_169 wn_ih_0_169 0 0.7098082435043527
Vwp_ih_1_169 wp_ih_1_169 0 0.7797241830896298
Vwn_ih_1_169 wn_ih_1_169 0 0.3
Vwp_ih_2_169 wp_ih_2_169 0 0.3
Vwn_ih_2_169 wn_ih_2_169 0 0.8974443274389288
Vwp_ih_0_170 wp_ih_0_170 0 0.506863832844387
Vwn_ih_0_170 wn_ih_0_170 0 0.4931361671556131
Vwp_ih_1_170 wp_ih_1_170 0 0.5062221507582505
Vwn_ih_1_170 wn_ih_1_170 0 0.49377784924174944
Vwp_ih_2_170 wp_ih_2_170 0 0.527097333293608
Vwn_ih_2_170 wn_ih_2_170 0 0.472902666706392
Vwp_ih_0_171 wp_ih_0_171 0 0.5000000014945262
Vwn_ih_0_171 wn_ih_0_171 0 0.49999999850547383
Vwp_ih_1_171 wp_ih_1_171 0 0.5000000262705994
Vwn_ih_1_171 wn_ih_1_171 0 0.4999999737294007
Vwp_ih_2_171 wp_ih_2_171 0 0.5000018692699847
Vwn_ih_2_171 wn_ih_2_171 0 0.49999813073001526
Vwp_ih_0_172 wp_ih_0_172 0 0.4243443692370605
Vwn_ih_0_172 wn_ih_0_172 0 0.5756556307629396
Vwp_ih_1_172 wp_ih_1_172 0 0.3
Vwn_ih_1_172 wn_ih_1_172 0 0.899
Vwp_ih_2_172 wp_ih_2_172 0 0.6555397685191653
Vwn_ih_2_172 wn_ih_2_172 0 0.3444602314808347
Vwp_ih_0_173 wp_ih_0_173 0 0.7163899798652051
Vwn_ih_0_173 wn_ih_0_173 0 0.3
Vwp_ih_1_173 wp_ih_1_173 0 0.7938652290757717
Vwn_ih_1_173 wn_ih_1_173 0 0.3
Vwp_ih_2_173 wp_ih_2_173 0 0.3
Vwn_ih_2_173 wn_ih_2_173 0 0.8982860918705282
Vwp_ih_0_174 wp_ih_0_174 0 0.5286930599469897
Vwn_ih_0_174 wn_ih_0_174 0 0.4713069400530103
Vwp_ih_1_174 wp_ih_1_174 0 0.899
Vwn_ih_1_174 wn_ih_1_174 0 0.3
Vwp_ih_2_174 wp_ih_2_174 0 0.673835008247065
Vwn_ih_2_174 wn_ih_2_174 0 0.326164991752935
Vwp_ih_0_175 wp_ih_0_175 0 0.4962503584891255
Vwn_ih_0_175 wn_ih_0_175 0 0.5037496415108744
Vwp_ih_1_175 wp_ih_1_175 0 0.4980566548316127
Vwn_ih_1_175 wn_ih_1_175 0 0.5019433451683872
Vwp_ih_2_175 wp_ih_2_175 0 0.3
Vwn_ih_2_175 wn_ih_2_175 0 0.732881785487483
Vwp_ih_0_176 wp_ih_0_176 0 0.485027797332804
Vwn_ih_0_176 wn_ih_0_176 0 0.514972202667196
Vwp_ih_1_176 wp_ih_1_176 0 0.3330176675002915
Vwn_ih_1_176 wn_ih_1_176 0 0.6669823324997085
Vwp_ih_2_176 wp_ih_2_176 0 0.6235327973232043
Vwn_ih_2_176 wn_ih_2_176 0 0.37646720267679573
Vwp_ih_0_177 wp_ih_0_177 0 0.38109065021517746
Vwn_ih_0_177 wn_ih_0_177 0 0.6189093497848226
Vwp_ih_1_177 wp_ih_1_177 0 0.45606847488110464
Vwn_ih_1_177 wn_ih_1_177 0 0.5439315251188953
Vwp_ih_2_177 wp_ih_2_177 0 0.5637737790141697
Vwn_ih_2_177 wn_ih_2_177 0 0.43622622098583036
Vwp_ih_0_178 wp_ih_0_178 0 0.49904509460944213
Vwn_ih_0_178 wn_ih_0_178 0 0.5009549053905579
Vwp_ih_1_178 wp_ih_1_178 0 0.49984337830597303
Vwn_ih_1_178 wn_ih_1_178 0 0.500156621694027
Vwp_ih_2_178 wp_ih_2_178 0 0.49680776276017663
Vwn_ih_2_178 wn_ih_2_178 0 0.5031922372398234
Vwp_ih_0_179 wp_ih_0_179 0 0.499811518247783
Vwn_ih_0_179 wn_ih_0_179 0 0.500188481752217
Vwp_ih_1_179 wp_ih_1_179 0 0.4999142133697947
Vwn_ih_1_179 wn_ih_1_179 0 0.5000857866302053
Vwp_ih_2_179 wp_ih_2_179 0 0.49953389311683016
Vwn_ih_2_179 wn_ih_2_179 0 0.5004661068831698
Vwp_ih_0_180 wp_ih_0_180 0 0.44407461352623157
Vwn_ih_0_180 wn_ih_0_180 0 0.5559253864737684
Vwp_ih_1_180 wp_ih_1_180 0 0.4721056694942512
Vwn_ih_1_180 wn_ih_1_180 0 0.5278943305057489
Vwp_ih_2_180 wp_ih_2_180 0 0.4536902783828177
Vwn_ih_2_180 wn_ih_2_180 0 0.5463097216171823
Vwp_ih_0_181 wp_ih_0_181 0 0.8972280406902581
Vwn_ih_0_181 wn_ih_0_181 0 0.3
Vwp_ih_1_181 wp_ih_1_181 0 0.3
Vwn_ih_1_181 wn_ih_1_181 0 0.8982549419710323
Vwp_ih_2_181 wp_ih_2_181 0 0.7837294333235859
Vwn_ih_2_181 wn_ih_2_181 0 0.3
Vwp_ih_0_182 wp_ih_0_182 0 0.5011091685488069
Vwn_ih_0_182 wn_ih_0_182 0 0.4988908314511931
Vwp_ih_1_182 wp_ih_1_182 0 0.5002790637253454
Vwn_ih_1_182 wn_ih_1_182 0 0.49972093627465464
Vwp_ih_2_182 wp_ih_2_182 0 0.5002745487331024
Vwn_ih_2_182 wn_ih_2_182 0 0.4997254512668976
Vwp_ih_0_183 wp_ih_0_183 0 0.7723703067244763
Vwn_ih_0_183 wn_ih_0_183 0 0.3
Vwp_ih_1_183 wp_ih_1_183 0 0.899
Vwn_ih_1_183 wn_ih_1_183 0 0.3
Vwp_ih_2_183 wp_ih_2_183 0 0.7003534856870447
Vwn_ih_2_183 wn_ih_2_183 0 0.3
Vwp_ih_0_184 wp_ih_0_184 0 0.5016888978101257
Vwn_ih_0_184 wn_ih_0_184 0 0.4983111021898743
Vwp_ih_1_184 wp_ih_1_184 0 0.5011764489170735
Vwn_ih_1_184 wn_ih_1_184 0 0.4988235510829265
Vwp_ih_2_184 wp_ih_2_184 0 0.5039379199886097
Vwn_ih_2_184 wn_ih_2_184 0 0.4960620800113903
Vwp_ih_0_185 wp_ih_0_185 0 0.5016826072198785
Vwn_ih_0_185 wn_ih_0_185 0 0.49831739278012155
Vwp_ih_1_185 wp_ih_1_185 0 0.5011829923484376
Vwn_ih_1_185 wn_ih_1_185 0 0.49881700765156245
Vwp_ih_2_185 wp_ih_2_185 0 0.5038569626418631
Vwn_ih_2_185 wn_ih_2_185 0 0.49614303735813686
Vwp_ih_0_186 wp_ih_0_186 0 0.5018286359686491
Vwn_ih_0_186 wn_ih_0_186 0 0.49817136403135087
Vwp_ih_1_186 wp_ih_1_186 0 0.5010511126535281
Vwn_ih_1_186 wn_ih_1_186 0 0.4989488873464719
Vwp_ih_2_186 wp_ih_2_186 0 0.899
Vwn_ih_2_186 wn_ih_2_186 0 0.3
Vwp_ih_0_187 wp_ih_0_187 0 0.49997842271445386
Vwn_ih_0_187 wn_ih_0_187 0 0.5000215772855462
Vwp_ih_1_187 wp_ih_1_187 0 0.5000129333974688
Vwn_ih_1_187 wn_ih_1_187 0 0.4999870666025313
Vwp_ih_2_187 wp_ih_2_187 0 0.499969214599746
Vwn_ih_2_187 wn_ih_2_187 0 0.5000307854002539
Vwp_ih_0_188 wp_ih_0_188 0 0.7445202656664347
Vwn_ih_0_188 wn_ih_0_188 0 0.3
Vwp_ih_1_188 wp_ih_1_188 0 0.3
Vwn_ih_1_188 wn_ih_1_188 0 0.7552938468008373
Vwp_ih_2_188 wp_ih_2_188 0 0.8973315449016338
Vwn_ih_2_188 wn_ih_2_188 0 0.3
Vwp_ih_0_189 wp_ih_0_189 0 0.5000081181983943
Vwn_ih_0_189 wn_ih_0_189 0 0.4999918818016057
Vwp_ih_1_189 wp_ih_1_189 0 0.49993839969220427
Vwn_ih_1_189 wn_ih_1_189 0 0.5000616003077958
Vwp_ih_2_189 wp_ih_2_189 0 0.5000633571993932
Vwn_ih_2_189 wn_ih_2_189 0 0.49993664280060673
Vwp_ih_0_190 wp_ih_0_190 0 0.899
Vwn_ih_0_190 wn_ih_0_190 0 0.3
Vwp_ih_1_190 wp_ih_1_190 0 0.5155109773655407
Vwn_ih_1_190 wn_ih_1_190 0 0.48448902263445925
Vwp_ih_2_190 wp_ih_2_190 0 0.34296446803460945
Vwn_ih_2_190 wn_ih_2_190 0 0.6570355319653906
Vwp_ih_0_191 wp_ih_0_191 0 0.3321639959404526
Vwn_ih_0_191 wn_ih_0_191 0 0.6678360040595475
Vwp_ih_1_191 wp_ih_1_191 0 0.6866910086689055
Vwn_ih_1_191 wn_ih_1_191 0 0.31330899133109447
Vwp_ih_2_191 wp_ih_2_191 0 0.7439064906785963
Vwn_ih_2_191 wn_ih_2_191 0 0.3
Vwp_ih_0_192 wp_ih_0_192 0 0.49967894022062165
Vwn_ih_0_192 wn_ih_0_192 0 0.5003210597793784
Vwp_ih_1_192 wp_ih_1_192 0 0.4999943336649514
Vwn_ih_1_192 wn_ih_1_192 0 0.5000056663350486
Vwp_ih_2_192 wp_ih_2_192 0 0.4994594025320695
Vwn_ih_2_192 wn_ih_2_192 0 0.5005405974679304
Vwp_ih_0_193 wp_ih_0_193 0 0.37848300978986327
Vwn_ih_0_193 wn_ih_0_193 0 0.6215169902101367
Vwp_ih_1_193 wp_ih_1_193 0 0.7052933306817933
Vwn_ih_1_193 wn_ih_1_193 0 0.3
Vwp_ih_2_193 wp_ih_2_193 0 0.7235836835680794
Vwn_ih_2_193 wn_ih_2_193 0 0.3
Vwp_ih_0_194 wp_ih_0_194 0 0.899
Vwn_ih_0_194 wn_ih_0_194 0 0.3
Vwp_ih_1_194 wp_ih_1_194 0 0.44234391266547907
Vwn_ih_1_194 wn_ih_1_194 0 0.557656087334521
Vwp_ih_2_194 wp_ih_2_194 0 0.3481060522972479
Vwn_ih_2_194 wn_ih_2_194 0 0.6518939477027521
Vwp_ih_0_195 wp_ih_0_195 0 0.49952507845238064
Vwn_ih_0_195 wn_ih_0_195 0 0.5004749215476193
Vwp_ih_1_195 wp_ih_1_195 0 0.49980871893158385
Vwn_ih_1_195 wn_ih_1_195 0 0.5001912810684161
Vwp_ih_2_195 wp_ih_2_195 0 0.4988918509279924
Vwn_ih_2_195 wn_ih_2_195 0 0.5011081490720076
Vwp_ih_0_196 wp_ih_0_196 0 0.5023081388779937
Vwn_ih_0_196 wn_ih_0_196 0 0.4976918611220062
Vwp_ih_1_196 wp_ih_1_196 0 0.5003798364236816
Vwn_ih_1_196 wn_ih_1_196 0 0.49962016357631844
Vwp_ih_2_196 wp_ih_2_196 0 0.5040931771068816
Vwn_ih_2_196 wn_ih_2_196 0 0.49590682289311844
Vwp_ih_0_197 wp_ih_0_197 0 0.6802984367284745
Vwn_ih_0_197 wn_ih_0_197 0 0.31970156327152555
Vwp_ih_1_197 wp_ih_1_197 0 0.35797107536724226
Vwn_ih_1_197 wn_ih_1_197 0 0.6420289246327577
Vwp_ih_2_197 wp_ih_2_197 0 0.7147440042690469
Vwn_ih_2_197 wn_ih_2_197 0 0.3
Vwp_ih_0_198 wp_ih_0_198 0 0.4999875652822158
Vwn_ih_0_198 wn_ih_0_198 0 0.5000124347177842
Vwp_ih_1_198 wp_ih_1_198 0 0.4999985060540213
Vwn_ih_1_198 wn_ih_1_198 0 0.5000014939459787
Vwp_ih_2_198 wp_ih_2_198 0 0.49998185892109354
Vwn_ih_2_198 wn_ih_2_198 0 0.5000181410789064
Vwp_ih_0_199 wp_ih_0_199 0 0.899
Vwn_ih_0_199 wn_ih_0_199 0 0.3
Vwp_ih_1_199 wp_ih_1_199 0 0.6601783282935383
Vwn_ih_1_199 wn_ih_1_199 0 0.3398216717064617
Vwp_ih_2_199 wp_ih_2_199 0 0.3393992456596314
Vwn_ih_2_199 wn_ih_2_199 0 0.6606007543403686
Vwp_ih_0_200 wp_ih_0_200 0 0.6263408842439061
Vwn_ih_0_200 wn_ih_0_200 0 0.3736591157560939
Vwp_ih_1_200 wp_ih_1_200 0 0.3
Vwn_ih_1_200 wn_ih_1_200 0 0.899
Vwp_ih_2_200 wp_ih_2_200 0 0.33259051454792515
Vwn_ih_2_200 wn_ih_2_200 0 0.6674094854520749
Vwp_ih_0_201 wp_ih_0_201 0 0.49123308465996773
Vwn_ih_0_201 wn_ih_0_201 0 0.5087669153400323
Vwp_ih_1_201 wp_ih_1_201 0 0.49358477738169493
Vwn_ih_1_201 wn_ih_1_201 0 0.5064152226183051
Vwp_ih_2_201 wp_ih_2_201 0 0.4119811091216142
Vwn_ih_2_201 wn_ih_2_201 0 0.5880188908783859
Vwp_ih_0_202 wp_ih_0_202 0 0.36432084608609516
Vwn_ih_0_202 wn_ih_0_202 0 0.6356791539139048
Vwp_ih_1_202 wp_ih_1_202 0 0.349163333158115
Vwn_ih_1_202 wn_ih_1_202 0 0.650836666841885
Vwp_ih_2_202 wp_ih_2_202 0 0.6299338772334753
Vwn_ih_2_202 wn_ih_2_202 0 0.37006612276652473
Vwp_ih_0_203 wp_ih_0_203 0 0.5628633469668711
Vwn_ih_0_203 wn_ih_0_203 0 0.4371366530331289
Vwp_ih_1_203 wp_ih_1_203 0 0.44389393741408056
Vwn_ih_1_203 wn_ih_1_203 0 0.5561060625859194
Vwp_ih_2_203 wp_ih_2_203 0 0.5542720670867894
Vwn_ih_2_203 wn_ih_2_203 0 0.4457279329132105
Vwp_ih_0_204 wp_ih_0_204 0 0.496062971017533
Vwn_ih_0_204 wn_ih_0_204 0 0.503937028982467
Vwp_ih_1_204 wp_ih_1_204 0 0.49727727328728527
Vwn_ih_1_204 wn_ih_1_204 0 0.5027227267127147
Vwp_ih_2_204 wp_ih_2_204 0 0.3
Vwn_ih_2_204 wn_ih_2_204 0 0.7188112585295958
Vwp_ih_0_205 wp_ih_0_205 0 0.4994454083423292
Vwn_ih_0_205 wn_ih_0_205 0 0.5005545916576708
Vwp_ih_1_205 wp_ih_1_205 0 0.49986583970802206
Vwn_ih_1_205 wn_ih_1_205 0 0.500134160291978
Vwp_ih_2_205 wp_ih_2_205 0 0.49886606065764566
Vwn_ih_2_205 wn_ih_2_205 0 0.5011339393423543
Vwp_ih_0_206 wp_ih_0_206 0 0.6995993414856911
Vwn_ih_0_206 wn_ih_0_206 0 0.30040065851430886
Vwp_ih_1_206 wp_ih_1_206 0 0.8075103320029342
Vwn_ih_1_206 wn_ih_1_206 0 0.3
Vwp_ih_2_206 wp_ih_2_206 0 0.3
Vwn_ih_2_206 wn_ih_2_206 0 0.8980023654488337
Vwp_ih_0_207 wp_ih_0_207 0 0.3
Vwn_ih_0_207 wn_ih_0_207 0 0.7865323137116612
Vwp_ih_1_207 wp_ih_1_207 0 0.73454333760823
Vwn_ih_1_207 wn_ih_1_207 0 0.3
Vwp_ih_2_207 wp_ih_2_207 0 0.8981827700391813
Vwn_ih_2_207 wn_ih_2_207 0 0.3
Vwp_ih_0_208 wp_ih_0_208 0 0.49639941544185423
Vwn_ih_0_208 wn_ih_0_208 0 0.5036005845581458
Vwp_ih_1_208 wp_ih_1_208 0 0.49751634718515336
Vwn_ih_1_208 wn_ih_1_208 0 0.5024836528148466
Vwp_ih_2_208 wp_ih_2_208 0 0.48986280221928447
Vwn_ih_2_208 wn_ih_2_208 0 0.5101371977807155
Vwp_ih_0_209 wp_ih_0_209 0 0.5047055222770273
Vwn_ih_0_209 wn_ih_0_209 0 0.49529447772297275
Vwp_ih_1_209 wp_ih_1_209 0 0.503299727945021
Vwn_ih_1_209 wn_ih_1_209 0 0.49670027205497896
Vwp_ih_2_209 wp_ih_2_209 0 0.68785353320957
Vwn_ih_2_209 wn_ih_2_209 0 0.31214646679043
Vwp_ih_0_210 wp_ih_0_210 0 0.8177630833937735
Vwn_ih_0_210 wn_ih_0_210 0 0.3
Vwp_ih_1_210 wp_ih_1_210 0 0.8981698218915326
Vwn_ih_1_210 wn_ih_1_210 0 0.3
Vwp_ih_2_210 wp_ih_2_210 0 0.3009137362822105
Vwn_ih_2_210 wn_ih_2_210 0 0.6990862637177895
Vwp_ih_0_211 wp_ih_0_211 0 0.5001299413903783
Vwn_ih_0_211 wn_ih_0_211 0 0.49987005860962175
Vwp_ih_1_211 wp_ih_1_211 0 0.49996916469550895
Vwn_ih_1_211 wn_ih_1_211 0 0.500030835304491
Vwp_ih_2_211 wp_ih_2_211 0 0.5002594802627817
Vwn_ih_2_211 wn_ih_2_211 0 0.4997405197372184
Vwp_ih_0_212 wp_ih_0_212 0 0.5227757789915404
Vwn_ih_0_212 wn_ih_0_212 0 0.4772242210084596
Vwp_ih_1_212 wp_ih_1_212 0 0.5132837061135167
Vwn_ih_1_212 wn_ih_1_212 0 0.48671629388648335
Vwp_ih_2_212 wp_ih_2_212 0 0.5218855923419354
Vwn_ih_2_212 wn_ih_2_212 0 0.47811440765806457
Vwp_ih_0_213 wp_ih_0_213 0 0.899
Vwn_ih_0_213 wn_ih_0_213 0 0.3
Vwp_ih_1_213 wp_ih_1_213 0 0.3561872330106832
Vwn_ih_1_213 wn_ih_1_213 0 0.6438127669893168
Vwp_ih_2_213 wp_ih_2_213 0 0.6818710039060085
Vwn_ih_2_213 wn_ih_2_213 0 0.3181289960939914
Vwp_ih_0_214 wp_ih_0_214 0 0.3
Vwn_ih_0_214 wn_ih_0_214 0 0.7398851483100854
Vwp_ih_1_214 wp_ih_1_214 0 0.6619393201380149
Vwn_ih_1_214 wn_ih_1_214 0 0.33806067986198507
Vwp_ih_2_214 wp_ih_2_214 0 0.7901588395674025
Vwn_ih_2_214 wn_ih_2_214 0 0.3
Vwp_ih_0_215 wp_ih_0_215 0 0.6452361598180585
Vwn_ih_0_215 wn_ih_0_215 0 0.3547638401819415
Vwp_ih_1_215 wp_ih_1_215 0 0.6549879213153287
Vwn_ih_1_215 wn_ih_1_215 0 0.3450120786846714
Vwp_ih_2_215 wp_ih_2_215 0 0.3521488851715869
Vwn_ih_2_215 wn_ih_2_215 0 0.6478511148284132
Vwp_ih_0_216 wp_ih_0_216 0 0.4396888743574232
Vwn_ih_0_216 wn_ih_0_216 0 0.5603111256425768
Vwp_ih_1_216 wp_ih_1_216 0 0.507271732193388
Vwn_ih_1_216 wn_ih_1_216 0 0.49272826780661205
Vwp_ih_2_216 wp_ih_2_216 0 0.5190824134271039
Vwn_ih_2_216 wn_ih_2_216 0 0.4809175865728961
Vwp_ih_0_217 wp_ih_0_217 0 0.5039663053980077
Vwn_ih_0_217 wn_ih_0_217 0 0.4960336946019923
Vwp_ih_1_217 wp_ih_1_217 0 0.5063453904964228
Vwn_ih_1_217 wn_ih_1_217 0 0.49365460950357726
Vwp_ih_2_217 wp_ih_2_217 0 0.49520609110099234
Vwn_ih_2_217 wn_ih_2_217 0 0.5047939088990077
Vwp_ih_0_218 wp_ih_0_218 0 0.3279563362561514
Vwn_ih_0_218 wn_ih_0_218 0 0.6720436637438486
Vwp_ih_1_218 wp_ih_1_218 0 0.3447071922892976
Vwn_ih_1_218 wn_ih_1_218 0 0.6552928077107024
Vwp_ih_2_218 wp_ih_2_218 0 0.6867148125157065
Vwn_ih_2_218 wn_ih_2_218 0 0.3132851874842935
Vwp_ih_0_219 wp_ih_0_219 0 0.3
Vwn_ih_0_219 wn_ih_0_219 0 0.70563908915184
Vwp_ih_1_219 wp_ih_1_219 0 0.7107615058687715
Vwn_ih_1_219 wn_ih_1_219 0 0.3
Vwp_ih_2_219 wp_ih_2_219 0 0.8029844813058107
Vwn_ih_2_219 wn_ih_2_219 0 0.3
Vwp_ih_0_220 wp_ih_0_220 0 0.5797749894051079
Vwn_ih_0_220 wn_ih_0_220 0 0.42022501059489215
Vwp_ih_1_220 wp_ih_1_220 0 0.5499003969239883
Vwn_ih_1_220 wn_ih_1_220 0 0.4500996030760117
Vwp_ih_2_220 wp_ih_2_220 0 0.5595992342045323
Vwn_ih_2_220 wn_ih_2_220 0 0.4404007657954678
Vwp_ih_0_221 wp_ih_0_221 0 0.3
Vwn_ih_0_221 wn_ih_0_221 0 0.7261863222301723
Vwp_ih_1_221 wp_ih_1_221 0 0.7910523331128397
Vwn_ih_1_221 wn_ih_1_221 0 0.3
Vwp_ih_2_221 wp_ih_2_221 0 0.8982746946383015
Vwn_ih_2_221 wn_ih_2_221 0 0.3
Vwp_ih_0_222 wp_ih_0_222 0 0.5001509461168028
Vwn_ih_0_222 wn_ih_0_222 0 0.4998490538831973
Vwp_ih_1_222 wp_ih_1_222 0 0.5001657030142983
Vwn_ih_1_222 wn_ih_1_222 0 0.49983429698570175
Vwp_ih_2_222 wp_ih_2_222 0 0.5002689769969818
Vwn_ih_2_222 wn_ih_2_222 0 0.49973102300301825
Vwp_ih_0_223 wp_ih_0_223 0 0.67610791752437
Vwn_ih_0_223 wn_ih_0_223 0 0.32389208247562995
Vwp_ih_1_223 wp_ih_1_223 0 0.5706588096695706
Vwn_ih_1_223 wn_ih_1_223 0 0.4293411903304294
Vwp_ih_2_223 wp_ih_2_223 0 0.6342858939647199
Vwn_ih_2_223 wn_ih_2_223 0 0.3657141060352801
Vwp_ih_0_224 wp_ih_0_224 0 0.49969156352770755
Vwn_ih_0_224 wn_ih_0_224 0 0.5003084364722924
Vwp_ih_1_224 wp_ih_1_224 0 0.5000272655654364
Vwn_ih_1_224 wn_ih_1_224 0 0.4999727344345636
Vwp_ih_2_224 wp_ih_2_224 0 0.4994370411756291
Vwn_ih_2_224 wn_ih_2_224 0 0.5005629588243709
Vwp_ih_0_225 wp_ih_0_225 0 0.4929108857371982
Vwn_ih_0_225 wn_ih_0_225 0 0.5070891142628018
Vwp_ih_1_225 wp_ih_1_225 0 0.49732506822296463
Vwn_ih_1_225 wn_ih_1_225 0 0.5026749317770354
Vwp_ih_2_225 wp_ih_2_225 0 0.48653826898007146
Vwn_ih_2_225 wn_ih_2_225 0 0.5134617310199285
Vwp_ih_0_226 wp_ih_0_226 0 0.3943728083574953
Vwn_ih_0_226 wn_ih_0_226 0 0.6056271916425047
Vwp_ih_1_226 wp_ih_1_226 0 0.548745038717886
Vwn_ih_1_226 wn_ih_1_226 0 0.45125496128211395
Vwp_ih_2_226 wp_ih_2_226 0 0.42666840653819393
Vwn_ih_2_226 wn_ih_2_226 0 0.5733315934618061
Vwp_ih_0_227 wp_ih_0_227 0 0.47081712625153216
Vwn_ih_0_227 wn_ih_0_227 0 0.5291828737484678
Vwp_ih_1_227 wp_ih_1_227 0 0.6643021502129842
Vwn_ih_1_227 wn_ih_1_227 0 0.3356978497870158
Vwp_ih_2_227 wp_ih_2_227 0 0.37873576826900074
Vwn_ih_2_227 wn_ih_2_227 0 0.6212642317309992
Vwp_ih_0_228 wp_ih_0_228 0 0.504436179568347
Vwn_ih_0_228 wn_ih_0_228 0 0.4955638204316531
Vwp_ih_1_228 wp_ih_1_228 0 0.5028968280968612
Vwn_ih_1_228 wn_ih_1_228 0 0.4971031719031388
Vwp_ih_2_228 wp_ih_2_228 0 0.5005932483234466
Vwn_ih_2_228 wn_ih_2_228 0 0.49940675167655335
Vwp_ih_0_229 wp_ih_0_229 0 0.4999997078308954
Vwn_ih_0_229 wn_ih_0_229 0 0.5000002921691046
Vwp_ih_1_229 wp_ih_1_229 0 0.5000002024262855
Vwn_ih_1_229 wn_ih_1_229 0 0.4999997975737145
Vwp_ih_2_229 wp_ih_2_229 0 0.49999941171602713
Vwn_ih_2_229 wn_ih_2_229 0 0.5000005882839729
Vwp_ih_0_230 wp_ih_0_230 0 0.3420250913743918
Vwn_ih_0_230 wn_ih_0_230 0 0.6579749086256081
Vwp_ih_1_230 wp_ih_1_230 0 0.3602862110801517
Vwn_ih_1_230 wn_ih_1_230 0 0.6397137889198483
Vwp_ih_2_230 wp_ih_2_230 0 0.3466956409191263
Vwn_ih_2_230 wn_ih_2_230 0 0.6533043590808737
Vwp_ih_0_231 wp_ih_0_231 0 0.4973267228644794
Vwn_ih_0_231 wn_ih_0_231 0 0.5026732771355207
Vwp_ih_1_231 wp_ih_1_231 0 0.49883090430966204
Vwn_ih_1_231 wn_ih_1_231 0 0.501169095690338
Vwp_ih_2_231 wp_ih_2_231 0 0.3
Vwn_ih_2_231 wn_ih_2_231 0 0.8271564865058745
Vwp_ih_0_232 wp_ih_0_232 0 0.4936763699550937
Vwn_ih_0_232 wn_ih_0_232 0 0.5063236300449063
Vwp_ih_1_232 wp_ih_1_232 0 0.49499467200552133
Vwn_ih_1_232 wn_ih_1_232 0 0.5050053279944787
Vwp_ih_2_232 wp_ih_2_232 0 0.35392867144499707
Vwn_ih_2_232 wn_ih_2_232 0 0.6460713285550029
Vwp_ih_0_233 wp_ih_0_233 0 0.8098957302011338
Vwn_ih_0_233 wn_ih_0_233 0 0.3
Vwp_ih_1_233 wp_ih_1_233 0 0.6847101969380197
Vwn_ih_1_233 wn_ih_1_233 0 0.3152898030619803
Vwp_ih_2_233 wp_ih_2_233 0 0.899
Vwn_ih_2_233 wn_ih_2_233 0 0.3
Vwp_ih_0_234 wp_ih_0_234 0 0.688830208883693
Vwn_ih_0_234 wn_ih_0_234 0 0.31116979111630705
Vwp_ih_1_234 wp_ih_1_234 0 0.5717432198324569
Vwn_ih_1_234 wn_ih_1_234 0 0.4282567801675431
Vwp_ih_2_234 wp_ih_2_234 0 0.6552483583667446
Vwn_ih_2_234 wn_ih_2_234 0 0.34475164163325545
Vwp_ih_0_235 wp_ih_0_235 0 0.7557725778936182
Vwn_ih_0_235 wn_ih_0_235 0 0.3
Vwp_ih_1_235 wp_ih_1_235 0 0.30831558543698323
Vwn_ih_1_235 wn_ih_1_235 0 0.6916844145630168
Vwp_ih_2_235 wp_ih_2_235 0 0.3
Vwn_ih_2_235 wn_ih_2_235 0 0.8423565905315182
Vwp_ih_0_236 wp_ih_0_236 0 0.49999455642667956
Vwn_ih_0_236 wn_ih_0_236 0 0.5000054435733204
Vwp_ih_1_236 wp_ih_1_236 0 0.49999276022214006
Vwn_ih_1_236 wn_ih_1_236 0 0.50000723977786
Vwp_ih_2_236 wp_ih_2_236 0 0.50001358784162
Vwn_ih_2_236 wn_ih_2_236 0 0.49998641215837997
Vwp_ih_0_237 wp_ih_0_237 0 0.5012310206661428
Vwn_ih_0_237 wn_ih_0_237 0 0.49876897933385717
Vwp_ih_1_237 wp_ih_1_237 0 0.504217916175261
Vwn_ih_1_237 wn_ih_1_237 0 0.495782083824739
Vwp_ih_2_237 wp_ih_2_237 0 0.5103989645829943
Vwn_ih_2_237 wn_ih_2_237 0 0.4896010354170058
Vwp_ih_0_238 wp_ih_0_238 0 0.3
Vwn_ih_0_238 wn_ih_0_238 0 0.8551009284066574
Vwp_ih_1_238 wp_ih_1_238 0 0.3
Vwn_ih_1_238 wn_ih_1_238 0 0.8979740145703734
Vwp_ih_2_238 wp_ih_2_238 0 0.7145999388558737
Vwn_ih_2_238 wn_ih_2_238 0 0.3
Vwp_ih_0_239 wp_ih_0_239 0 0.3
Vwn_ih_0_239 wn_ih_0_239 0 0.7498855177843902
Vwp_ih_1_239 wp_ih_1_239 0 0.6921651299882694
Vwn_ih_1_239 wn_ih_1_239 0 0.3078348700117306
Vwp_ih_2_239 wp_ih_2_239 0 0.8362124918395903
Vwn_ih_2_239 wn_ih_2_239 0 0.3
Vwp_ih_0_240 wp_ih_0_240 0 0.499471955009483
Vwn_ih_0_240 wn_ih_0_240 0 0.500528044990517
Vwp_ih_1_240 wp_ih_1_240 0 0.5001406705929703
Vwn_ih_1_240 wn_ih_1_240 0 0.49985932940702965
Vwp_ih_2_240 wp_ih_2_240 0 0.4958798729080628
Vwn_ih_2_240 wn_ih_2_240 0 0.5041201270919372
Vwp_ih_0_241 wp_ih_0_241 0 0.3
Vwn_ih_0_241 wn_ih_0_241 0 0.7923124816987868
Vwp_ih_1_241 wp_ih_1_241 0 0.3
Vwn_ih_1_241 wn_ih_1_241 0 0.7125343061692302
Vwp_ih_2_241 wp_ih_2_241 0 0.3
Vwn_ih_2_241 wn_ih_2_241 0 0.8988903315917524
Vwp_ih_0_242 wp_ih_0_242 0 0.5021135058018105
Vwn_ih_0_242 wn_ih_0_242 0 0.4978864941981895
Vwp_ih_1_242 wp_ih_1_242 0 0.5015147122159636
Vwn_ih_1_242 wn_ih_1_242 0 0.49848528778403645
Vwp_ih_2_242 wp_ih_2_242 0 0.504631797299643
Vwn_ih_2_242 wn_ih_2_242 0 0.495368202700357
Vwp_ih_0_243 wp_ih_0_243 0 0.3
Vwn_ih_0_243 wn_ih_0_243 0 0.8971347381999226
Vwp_ih_1_243 wp_ih_1_243 0 0.8981982845361063
Vwn_ih_1_243 wn_ih_1_243 0 0.3
Vwp_ih_2_243 wp_ih_2_243 0 0.3
Vwn_ih_2_243 wn_ih_2_243 0 0.7825713058588158
Vwp_ih_0_244 wp_ih_0_244 0 0.3
Vwn_ih_0_244 wn_ih_0_244 0 0.8975628564477037
Vwp_ih_1_244 wp_ih_1_244 0 0.3
Vwn_ih_1_244 wn_ih_1_244 0 0.8982502177561389
Vwp_ih_2_244 wp_ih_2_244 0 0.3
Vwn_ih_2_244 wn_ih_2_244 0 0.7507416668612672
Vwp_ih_0_245 wp_ih_0_245 0 0.551067672749137
Vwn_ih_0_245 wn_ih_0_245 0 0.448932327250863
Vwp_ih_1_245 wp_ih_1_245 0 0.4662570447960813
Vwn_ih_1_245 wn_ih_1_245 0 0.5337429552039187
Vwp_ih_2_245 wp_ih_2_245 0 0.5378550661336527
Vwn_ih_2_245 wn_ih_2_245 0 0.46214493386634725
Vwp_ih_0_246 wp_ih_0_246 0 0.4996557128965071
Vwn_ih_0_246 wn_ih_0_246 0 0.5003442871034929
Vwp_ih_1_246 wp_ih_1_246 0 0.49975873411630034
Vwn_ih_1_246 wn_ih_1_246 0 0.5002412658836997
Vwp_ih_2_246 wp_ih_2_246 0 0.4994000980684645
Vwn_ih_2_246 wn_ih_2_246 0 0.5005999019315355
Vwp_ih_0_247 wp_ih_0_247 0 0.5000808050515535
Vwn_ih_0_247 wn_ih_0_247 0 0.49991919494844644
Vwp_ih_1_247 wp_ih_1_247 0 0.4999981010546484
Vwn_ih_1_247 wn_ih_1_247 0 0.5000018989453515
Vwp_ih_2_247 wp_ih_2_247 0 0.5001471824939916
Vwn_ih_2_247 wn_ih_2_247 0 0.4998528175060084
Vwp_ih_0_248 wp_ih_0_248 0 0.49621009387158044
Vwn_ih_0_248 wn_ih_0_248 0 0.5037899061284196
Vwp_ih_1_248 wp_ih_1_248 0 0.4971936522126364
Vwn_ih_1_248 wn_ih_1_248 0 0.5028063477873637
Vwp_ih_2_248 wp_ih_2_248 0 0.3
Vwn_ih_2_248 wn_ih_2_248 0 0.726747559180554
Vwp_ih_0_249 wp_ih_0_249 0 0.5210285707096421
Vwn_ih_0_249 wn_ih_0_249 0 0.47897142929035785
Vwp_ih_1_249 wp_ih_1_249 0 0.5188326919996726
Vwn_ih_1_249 wn_ih_1_249 0 0.48116730800032737
Vwp_ih_2_249 wp_ih_2_249 0 0.49350429885366526
Vwn_ih_2_249 wn_ih_2_249 0 0.5064957011463347
Vwp_ih_0_250 wp_ih_0_250 0 0.7484732349384091
Vwn_ih_0_250 wn_ih_0_250 0 0.3
Vwp_ih_1_250 wp_ih_1_250 0 0.6785398511819528
Vwn_ih_1_250 wn_ih_1_250 0 0.3214601488180472
Vwp_ih_2_250 wp_ih_2_250 0 0.5511842274408062
Vwn_ih_2_250 wn_ih_2_250 0 0.4488157725591938
Vwp_ih_0_251 wp_ih_0_251 0 0.4999695208877589
Vwn_ih_0_251 wn_ih_0_251 0 0.5000304791122411
Vwp_ih_1_251 wp_ih_1_251 0 0.5000020682614772
Vwn_ih_1_251 wn_ih_1_251 0 0.4999979317385228
Vwp_ih_2_251 wp_ih_2_251 0 0.4998938015160382
Vwn_ih_2_251 wn_ih_2_251 0 0.5001061984839619
Vwp_ih_0_252 wp_ih_0_252 0 0.4429832818024571
Vwn_ih_0_252 wn_ih_0_252 0 0.5570167181975428
Vwp_ih_1_252 wp_ih_1_252 0 0.899
Vwn_ih_1_252 wn_ih_1_252 0 0.3
Vwp_ih_2_252 wp_ih_2_252 0 0.3224675267905976
Vwn_ih_2_252 wn_ih_2_252 0 0.6775324732094024
Vwp_ih_0_253 wp_ih_0_253 0 0.506010051103286
Vwn_ih_0_253 wn_ih_0_253 0 0.493989948896714
Vwp_ih_1_253 wp_ih_1_253 0 0.5050055739397324
Vwn_ih_1_253 wn_ih_1_253 0 0.4949944260602675
Vwp_ih_2_253 wp_ih_2_253 0 0.6479496681178953
Vwn_ih_2_253 wn_ih_2_253 0 0.3520503318821047
Vwp_ih_0_254 wp_ih_0_254 0 0.5000006352557044
Vwn_ih_0_254 wn_ih_0_254 0 0.4999993647442956
Vwp_ih_1_254 wp_ih_1_254 0 0.4999998151918096
Vwn_ih_1_254 wn_ih_1_254 0 0.5000001848081904
Vwp_ih_2_254 wp_ih_2_254 0 0.5000035459005592
Vwn_ih_2_254 wn_ih_2_254 0 0.4999964540994409
Vwp_ih_0_255 wp_ih_0_255 0 0.5006996886108446
Vwn_ih_0_255 wn_ih_0_255 0 0.4993003113891554
Vwp_ih_1_255 wp_ih_1_255 0 0.5001125477394655
Vwn_ih_1_255 wn_ih_1_255 0 0.4998874522605345
Vwp_ih_2_255 wp_ih_2_255 0 0.5016178648140552
Vwn_ih_2_255 wn_ih_2_255 0 0.4983821351859448
Vwp_ih_0_256 wp_ih_0_256 0 0.49851743480529925
Vwn_ih_0_256 wn_ih_0_256 0 0.5014825651947007
Vwp_ih_1_256 wp_ih_1_256 0 0.49915032551357247
Vwn_ih_1_256 wn_ih_1_256 0 0.5008496744864276
Vwp_ih_2_256 wp_ih_2_256 0 0.49673197933645313
Vwn_ih_2_256 wn_ih_2_256 0 0.5032680206635468
Vwp_ih_0_257 wp_ih_0_257 0 0.5275710828950753
Vwn_ih_0_257 wn_ih_0_257 0 0.47242891710492474
Vwp_ih_1_257 wp_ih_1_257 0 0.899
Vwn_ih_1_257 wn_ih_1_257 0 0.3
Vwp_ih_2_257 wp_ih_2_257 0 0.671490650928408
Vwn_ih_2_257 wn_ih_2_257 0 0.328509349071592
Vwp_ih_0_258 wp_ih_0_258 0 0.5000046303709874
Vwn_ih_0_258 wn_ih_0_258 0 0.4999953696290126
Vwp_ih_1_258 wp_ih_1_258 0 0.4999976765824962
Vwn_ih_1_258 wn_ih_1_258 0 0.5000023234175038
Vwp_ih_2_258 wp_ih_2_258 0 0.50000963896846
Vwn_ih_2_258 wn_ih_2_258 0 0.49999036103154004
Vwp_ih_0_259 wp_ih_0_259 0 0.5712405158941958
Vwn_ih_0_259 wn_ih_0_259 0 0.4287594841058042
Vwp_ih_1_259 wp_ih_1_259 0 0.5289735746380051
Vwn_ih_1_259 wn_ih_1_259 0 0.47102642536199485
Vwp_ih_2_259 wp_ih_2_259 0 0.5467001713454668
Vwn_ih_2_259 wn_ih_2_259 0 0.4532998286545332
Vwp_ih_0_260 wp_ih_0_260 0 0.899
Vwn_ih_0_260 wn_ih_0_260 0 0.3
Vwp_ih_1_260 wp_ih_1_260 0 0.524647098114225
Vwn_ih_1_260 wn_ih_1_260 0 0.47535290188577495
Vwp_ih_2_260 wp_ih_2_260 0 0.6521585782519531
Vwn_ih_2_260 wn_ih_2_260 0 0.3478414217480469
Vwp_ih_0_261 wp_ih_0_261 0 0.5001283644292613
Vwn_ih_0_261 wn_ih_0_261 0 0.49987163557073866
Vwp_ih_1_261 wp_ih_1_261 0 0.49990614172475023
Vwn_ih_1_261 wn_ih_1_261 0 0.5000938582752498
Vwp_ih_2_261 wp_ih_2_261 0 0.500256502215471
Vwn_ih_2_261 wn_ih_2_261 0 0.4997434977845289
Vwp_ih_0_262 wp_ih_0_262 0 0.4999999344017286
Vwn_ih_0_262 wn_ih_0_262 0 0.5000000655982714
Vwp_ih_1_262 wp_ih_1_262 0 0.5000000696964517
Vwn_ih_1_262 wn_ih_1_262 0 0.49999993030354833
Vwp_ih_2_262 wp_ih_2_262 0 0.4999996341437702
Vwn_ih_2_262 wn_ih_2_262 0 0.5000003658562298
Vwp_ih_0_263 wp_ih_0_263 0 0.7249673198600928
Vwn_ih_0_263 wn_ih_0_263 0 0.3
Vwp_ih_1_263 wp_ih_1_263 0 0.33314601626156815
Vwn_ih_1_263 wn_ih_1_263 0 0.6668539837384319
Vwp_ih_2_263 wp_ih_2_263 0 0.3
Vwn_ih_2_263 wn_ih_2_263 0 0.7740420470079497
Vwp_ih_0_264 wp_ih_0_264 0 0.7007936239104421
Vwn_ih_0_264 wn_ih_0_264 0 0.3
Vwp_ih_1_264 wp_ih_1_264 0 0.3
Vwn_ih_1_264 wn_ih_1_264 0 0.7859798478341145
Vwp_ih_2_264 wp_ih_2_264 0 0.897416655642244
Vwn_ih_2_264 wn_ih_2_264 0 0.3
Vwp_ih_0_265 wp_ih_0_265 0 0.47389296745831505
Vwn_ih_0_265 wn_ih_0_265 0 0.526107032541685
Vwp_ih_1_265 wp_ih_1_265 0 0.899
Vwn_ih_1_265 wn_ih_1_265 0 0.3
Vwp_ih_2_265 wp_ih_2_265 0 0.32538670891178767
Vwn_ih_2_265 wn_ih_2_265 0 0.6746132910882123
Vwp_ih_0_266 wp_ih_0_266 0 0.5331818814608941
Vwn_ih_0_266 wn_ih_0_266 0 0.4668181185391059
Vwp_ih_1_266 wp_ih_1_266 0 0.48646265191670385
Vwn_ih_1_266 wn_ih_1_266 0 0.5135373480832961
Vwp_ih_2_266 wp_ih_2_266 0 0.5261951969212889
Vwn_ih_2_266 wn_ih_2_266 0 0.4738048030787111
Vwp_ih_0_267 wp_ih_0_267 0 0.3
Vwn_ih_0_267 wn_ih_0_267 0 0.7647420535496663
Vwp_ih_1_267 wp_ih_1_267 0 0.3
Vwn_ih_1_267 wn_ih_1_267 0 0.74778932376298
Vwp_ih_2_267 wp_ih_2_267 0 0.3
Vwn_ih_2_267 wn_ih_2_267 0 0.899
Vwp_ih_0_268 wp_ih_0_268 0 0.3
Vwn_ih_0_268 wn_ih_0_268 0 0.8603867889541823
Vwp_ih_1_268 wp_ih_1_268 0 0.5788060098738149
Vwn_ih_1_268 wn_ih_1_268 0 0.42119399012618514
Vwp_ih_2_268 wp_ih_2_268 0 0.899
Vwn_ih_2_268 wn_ih_2_268 0 0.3
Vwp_ih_0_269 wp_ih_0_269 0 0.4999941391473974
Vwn_ih_0_269 wn_ih_0_269 0 0.5000058608526026
Vwp_ih_1_269 wp_ih_1_269 0 0.4999914166682869
Vwn_ih_1_269 wn_ih_1_269 0 0.500008583331713
Vwp_ih_2_269 wp_ih_2_269 0 0.4999993874424975
Vwn_ih_2_269 wn_ih_2_269 0 0.5000006125575025
Vwp_ih_0_270 wp_ih_0_270 0 0.4924735231467934
Vwn_ih_0_270 wn_ih_0_270 0 0.5075264768532066
Vwp_ih_1_270 wp_ih_1_270 0 0.4964949530761913
Vwn_ih_1_270 wn_ih_1_270 0 0.5035050469238087
Vwp_ih_2_270 wp_ih_2_270 0 0.4791805456587546
Vwn_ih_2_270 wn_ih_2_270 0 0.5208194543412454
Vwp_ih_0_271 wp_ih_0_271 0 0.31044742137165415
Vwn_ih_0_271 wn_ih_0_271 0 0.6895525786283458
Vwp_ih_1_271 wp_ih_1_271 0 0.6946141582977142
Vwn_ih_1_271 wn_ih_1_271 0 0.3053858417022858
Vwp_ih_2_271 wp_ih_2_271 0 0.3
Vwn_ih_2_271 wn_ih_2_271 0 0.7909509866834918
Vwp_ih_0_272 wp_ih_0_272 0 0.49301740652868575
Vwn_ih_0_272 wn_ih_0_272 0 0.5069825934713142
Vwp_ih_1_272 wp_ih_1_272 0 0.4949198559564706
Vwn_ih_1_272 wn_ih_1_272 0 0.5050801440435294
Vwp_ih_2_272 wp_ih_2_272 0 0.3694370765230996
Vwn_ih_2_272 wn_ih_2_272 0 0.6305629234769003
Vwp_ih_0_273 wp_ih_0_273 0 0.6410843618214828
Vwn_ih_0_273 wn_ih_0_273 0 0.3589156381785172
Vwp_ih_1_273 wp_ih_1_273 0 0.7622061803591301
Vwn_ih_1_273 wn_ih_1_273 0 0.3
Vwp_ih_2_273 wp_ih_2_273 0 0.3
Vwn_ih_2_273 wn_ih_2_273 0 0.826684750735886
Vwp_ih_0_274 wp_ih_0_274 0 0.49999333743526564
Vwn_ih_0_274 wn_ih_0_274 0 0.5000066625647344
Vwp_ih_1_274 wp_ih_1_274 0 0.5000012385563063
Vwn_ih_1_274 wn_ih_1_274 0 0.49999876144369365
Vwp_ih_2_274 wp_ih_2_274 0 0.4999874620451248
Vwn_ih_2_274 wn_ih_2_274 0 0.5000125379548752
Vwp_ih_0_275 wp_ih_0_275 0 0.49999668900434013
Vwn_ih_0_275 wn_ih_0_275 0 0.5000033109956599
Vwp_ih_1_275 wp_ih_1_275 0 0.5000002303427933
Vwn_ih_1_275 wn_ih_1_275 0 0.49999976965720666
Vwp_ih_2_275 wp_ih_2_275 0 0.5000087588527461
Vwn_ih_2_275 wn_ih_2_275 0 0.49999124114725385
Vwp_ih_0_276 wp_ih_0_276 0 0.5000525774276702
Vwn_ih_0_276 wn_ih_0_276 0 0.49994742257232977
Vwp_ih_1_276 wp_ih_1_276 0 0.5007031294087092
Vwn_ih_1_276 wn_ih_1_276 0 0.4992968705912908
Vwp_ih_2_276 wp_ih_2_276 0 0.5013476913472886
Vwn_ih_2_276 wn_ih_2_276 0 0.49865230865271143
Vwp_ih_0_277 wp_ih_0_277 0 0.4996813006601651
Vwn_ih_0_277 wn_ih_0_277 0 0.500318699339835
Vwp_ih_1_277 wp_ih_1_277 0 0.49998403833507804
Vwn_ih_1_277 wn_ih_1_277 0 0.5000159616649219
Vwp_ih_2_277 wp_ih_2_277 0 0.49946314560558197
Vwn_ih_2_277 wn_ih_2_277 0 0.5005368543944181
Vwp_ih_0_278 wp_ih_0_278 0 0.5028860615646579
Vwn_ih_0_278 wn_ih_0_278 0 0.49711393843534213
Vwp_ih_1_278 wp_ih_1_278 0 0.5015169443445305
Vwn_ih_1_278 wn_ih_1_278 0 0.4984830556554694
Vwp_ih_2_278 wp_ih_2_278 0 0.7935314615029809
Vwn_ih_2_278 wn_ih_2_278 0 0.3
Vwp_ih_0_279 wp_ih_0_279 0 0.49946613000504403
Vwn_ih_0_279 wn_ih_0_279 0 0.500533869994956
Vwp_ih_1_279 wp_ih_1_279 0 0.4999867627800278
Vwn_ih_1_279 wn_ih_1_279 0 0.5000132372199723
Vwp_ih_2_279 wp_ih_2_279 0 0.49878651083838904
Vwn_ih_2_279 wn_ih_2_279 0 0.501213489161611
Vwp_ih_0_280 wp_ih_0_280 0 0.3
Vwn_ih_0_280 wn_ih_0_280 0 0.7778016418867905
Vwp_ih_1_280 wp_ih_1_280 0 0.3
Vwn_ih_1_280 wn_ih_1_280 0 0.7323597629102895
Vwp_ih_2_280 wp_ih_2_280 0 0.3
Vwn_ih_2_280 wn_ih_2_280 0 0.899
Vwp_ih_0_281 wp_ih_0_281 0 0.3
Vwn_ih_0_281 wn_ih_0_281 0 0.899
Vwp_ih_1_281 wp_ih_1_281 0 0.5146519960595903
Vwn_ih_1_281 wn_ih_1_281 0 0.4853480039404097
Vwp_ih_2_281 wp_ih_2_281 0 0.6547773522586079
Vwn_ih_2_281 wn_ih_2_281 0 0.3452226477413921
Vwp_ih_0_282 wp_ih_0_282 0 0.899
Vwn_ih_0_282 wn_ih_0_282 0 0.3
Vwp_ih_1_282 wp_ih_1_282 0 0.5337308028604768
Vwn_ih_1_282 wn_ih_1_282 0 0.4662691971395232
Vwp_ih_2_282 wp_ih_2_282 0 0.6516256205150853
Vwn_ih_2_282 wn_ih_2_282 0 0.3483743794849147
Vwp_ih_0_283 wp_ih_0_283 0 0.4999858528744012
Vwn_ih_0_283 wn_ih_0_283 0 0.5000141471255988
Vwp_ih_1_283 wp_ih_1_283 0 0.49998241958133366
Vwn_ih_1_283 wn_ih_1_283 0 0.5000175804186664
Vwp_ih_2_283 wp_ih_2_283 0 0.4999984399377091
Vwn_ih_2_283 wn_ih_2_283 0 0.5000015600622909
Vwp_ih_0_284 wp_ih_0_284 0 0.5038351342053168
Vwn_ih_0_284 wn_ih_0_284 0 0.4961648657946832
Vwp_ih_1_284 wp_ih_1_284 0 0.5029109348172068
Vwn_ih_1_284 wn_ih_1_284 0 0.49708906518279317
Vwp_ih_2_284 wp_ih_2_284 0 0.5121849342563982
Vwn_ih_2_284 wn_ih_2_284 0 0.4878150657436018
Vwp_ih_0_285 wp_ih_0_285 0 0.4891617636401787
Vwn_ih_0_285 wn_ih_0_285 0 0.5108382363598213
Vwp_ih_1_285 wp_ih_1_285 0 0.49095427178839046
Vwn_ih_1_285 wn_ih_1_285 0 0.5090457282116095
Vwp_ih_2_285 wp_ih_2_285 0 0.4381018601230044
Vwn_ih_2_285 wn_ih_2_285 0 0.5618981398769956
Vwp_ih_0_286 wp_ih_0_286 0 0.49868245532445477
Vwn_ih_0_286 wn_ih_0_286 0 0.5013175446755452
Vwp_ih_1_286 wp_ih_1_286 0 0.4996596492335797
Vwn_ih_1_286 wn_ih_1_286 0 0.5003403507664204
Vwp_ih_2_286 wp_ih_2_286 0 0.49749252282708656
Vwn_ih_2_286 wn_ih_2_286 0 0.5025074771729134
Vwp_ih_0_287 wp_ih_0_287 0 0.5183314638709074
Vwn_ih_0_287 wn_ih_0_287 0 0.48166853612909255
Vwp_ih_1_287 wp_ih_1_287 0 0.5144657047367466
Vwn_ih_1_287 wn_ih_1_287 0 0.48553429526325337
Vwp_ih_2_287 wp_ih_2_287 0 0.5146428680658326
Vwn_ih_2_287 wn_ih_2_287 0 0.4853571319341674
Vwp_ho_0_0 wp_ho_0_0 0 0.4973949935501266
Vwn_ho_0_0 wn_ho_0_0 0 0.5026050064498734
Vwp_ho_1_0 wp_ho_1_0 0 0.4849836140766032
Vwn_ho_1_0 wn_ho_1_0 0 0.5150163859233968
Vwp_ho_2_0 wp_ho_2_0 0 0.5049083077763966
Vwn_ho_2_0 wn_ho_2_0 0 0.4950916922236034
Vwp_ho_3_0 wp_ho_3_0 0 0.5008984957891119
Vwn_ho_3_0 wn_ho_3_0 0 0.499101504210888
Vwp_ho_4_0 wp_ho_4_0 0 0.5012618159215269
Vwn_ho_4_0 wn_ho_4_0 0 0.49873818407847315
Vwp_ho_5_0 wp_ho_5_0 0 0.5004971376227891
Vwn_ho_5_0 wn_ho_5_0 0 0.4995028623772108
Vwp_ho_6_0 wp_ho_6_0 0 0.5077851396152612
Vwn_ho_6_0 wn_ho_6_0 0 0.4922148603847389
Vwp_ho_7_0 wp_ho_7_0 0 0.6123572496565319
Vwn_ho_7_0 wn_ho_7_0 0 0.387642750343468
Vwp_ho_8_0 wp_ho_8_0 0 0.5232946931144797
Vwn_ho_8_0 wn_ho_8_0 0 0.4767053068855203
Vwp_ho_9_0 wp_ho_9_0 0 0.46638755118772673
Vwn_ho_9_0 wn_ho_9_0 0 0.5336124488122733
Vwp_ho_10_0 wp_ho_10_0 0 0.46834089616223173
Vwn_ho_10_0 wn_ho_10_0 0 0.5316591038377683
Vwp_ho_11_0 wp_ho_11_0 0 0.504781068055488
Vwn_ho_11_0 wn_ho_11_0 0 0.49521893194451205
Vwp_ho_12_0 wp_ho_12_0 0 0.4865908372986
Vwn_ho_12_0 wn_ho_12_0 0 0.5134091627014
Vwp_ho_13_0 wp_ho_13_0 0 0.4316213495828001
Vwn_ho_13_0 wn_ho_13_0 0 0.5683786504171999
Vwp_ho_14_0 wp_ho_14_0 0 0.5149079821628412
Vwn_ho_14_0 wn_ho_14_0 0 0.4850920178371589
Vwp_ho_15_0 wp_ho_15_0 0 0.629588311087657
Vwn_ho_15_0 wn_ho_15_0 0 0.370411688912343
Vwp_ho_16_0 wp_ho_16_0 0 0.5088988062681049
Vwn_ho_16_0 wn_ho_16_0 0 0.49110119373189504
Vwp_ho_17_0 wp_ho_17_0 0 0.5002169984651808
Vwn_ho_17_0 wn_ho_17_0 0 0.4997830015348192
Vwp_ho_18_0 wp_ho_18_0 0 0.491205502619761
Vwn_ho_18_0 wn_ho_18_0 0 0.5087944973802391
Vwp_ho_19_0 wp_ho_19_0 0 0.5118287499785994
Vwn_ho_19_0 wn_ho_19_0 0 0.48817125002140066
Vwp_ho_20_0 wp_ho_20_0 0 0.5012005273521957
Vwn_ho_20_0 wn_ho_20_0 0 0.49879947264780433
Vwp_ho_21_0 wp_ho_21_0 0 0.5058920702579629
Vwn_ho_21_0 wn_ho_21_0 0 0.4941079297420371
Vwp_ho_22_0 wp_ho_22_0 0 0.5082293696988566
Vwn_ho_22_0 wn_ho_22_0 0 0.49177063030114343
Vwp_ho_23_0 wp_ho_23_0 0 0.4897974607458549
Vwn_ho_23_0 wn_ho_23_0 0 0.5102025392541452
Vwp_ho_24_0 wp_ho_24_0 0 0.505884967191718
Vwn_ho_24_0 wn_ho_24_0 0 0.49411503280828195
Vwp_ho_25_0 wp_ho_25_0 0 0.4747939787453235
Vwn_ho_25_0 wn_ho_25_0 0 0.5252060212546765
Vwp_ho_26_0 wp_ho_26_0 0 0.494089218347604
Vwn_ho_26_0 wn_ho_26_0 0 0.505910781652396
Vwp_ho_27_0 wp_ho_27_0 0 0.49998109442414707
Vwn_ho_27_0 wn_ho_27_0 0 0.5000189055758529
Vwp_ho_28_0 wp_ho_28_0 0 0.5294095521326125
Vwn_ho_28_0 wn_ho_28_0 0 0.47059044786738746
Vwp_ho_29_0 wp_ho_29_0 0 0.5145772580718226
Vwn_ho_29_0 wn_ho_29_0 0 0.4854227419281774
Vwp_ho_30_0 wp_ho_30_0 0 0.42815746874372523
Vwn_ho_30_0 wn_ho_30_0 0 0.5718425312562747
Vwp_ho_31_0 wp_ho_31_0 0 0.5011537211878757
Vwn_ho_31_0 wn_ho_31_0 0 0.4988462788121243
Vwp_ho_32_0 wp_ho_32_0 0 0.5560705115495286
Vwn_ho_32_0 wn_ho_32_0 0 0.4439294884504714
Vwp_ho_33_0 wp_ho_33_0 0 0.511333145010588
Vwn_ho_33_0 wn_ho_33_0 0 0.488666854989412
Vwp_ho_34_0 wp_ho_34_0 0 0.4254075888304282
Vwn_ho_34_0 wn_ho_34_0 0 0.5745924111695718
Vwp_ho_35_0 wp_ho_35_0 0 0.4989912492983663
Vwn_ho_35_0 wn_ho_35_0 0 0.5010087507016336
Vwp_ho_36_0 wp_ho_36_0 0 0.502958452038108
Vwn_ho_36_0 wn_ho_36_0 0 0.49704154796189204
Vwp_ho_37_0 wp_ho_37_0 0 0.6252138255005171
Vwn_ho_37_0 wn_ho_37_0 0 0.3747861744994829
Vwp_ho_38_0 wp_ho_38_0 0 0.5293514767683967
Vwn_ho_38_0 wn_ho_38_0 0 0.4706485232316034
Vwp_ho_39_0 wp_ho_39_0 0 0.5038106072836198
Vwn_ho_39_0 wn_ho_39_0 0 0.49618939271638013
Vwp_ho_40_0 wp_ho_40_0 0 0.510169092276055
Vwn_ho_40_0 wn_ho_40_0 0 0.489830907723945
Vwp_ho_41_0 wp_ho_41_0 0 0.527806838264684
Vwn_ho_41_0 wn_ho_41_0 0 0.47219316173531606
Vwp_ho_42_0 wp_ho_42_0 0 0.5185114037977059
Vwn_ho_42_0 wn_ho_42_0 0 0.4814885962022941
Vwp_ho_43_0 wp_ho_43_0 0 0.5075400380708535
Vwn_ho_43_0 wn_ho_43_0 0 0.49245996192914654
Vwp_ho_44_0 wp_ho_44_0 0 0.4305084182695283
Vwn_ho_44_0 wn_ho_44_0 0 0.5694915817304717
Vwp_ho_45_0 wp_ho_45_0 0 0.49574068257224196
Vwn_ho_45_0 wn_ho_45_0 0 0.5042593174277581
Vwp_ho_46_0 wp_ho_46_0 0 0.5316652752816513
Vwn_ho_46_0 wn_ho_46_0 0 0.4683347247183487
Vwp_ho_47_0 wp_ho_47_0 0 0.4969316623346625
Vwn_ho_47_0 wn_ho_47_0 0 0.5030683376653374
Vwp_ho_48_0 wp_ho_48_0 0 0.4100298173886709
Vwn_ho_48_0 wn_ho_48_0 0 0.589970182611329
Vwp_ho_49_0 wp_ho_49_0 0 0.41113338465292776
Vwn_ho_49_0 wn_ho_49_0 0 0.5888666153470723
Vwp_ho_50_0 wp_ho_50_0 0 0.49485244543495066
Vwn_ho_50_0 wn_ho_50_0 0 0.5051475545650493
Vwp_ho_51_0 wp_ho_51_0 0 0.49659745466489025
Vwn_ho_51_0 wn_ho_51_0 0 0.5034025453351098
Vwp_ho_52_0 wp_ho_52_0 0 0.49485398959862875
Vwn_ho_52_0 wn_ho_52_0 0 0.5051460104013713
Vwp_ho_53_0 wp_ho_53_0 0 0.4979125764121915
Vwn_ho_53_0 wn_ho_53_0 0 0.5020874235878084
Vwp_ho_54_0 wp_ho_54_0 0 0.5540302499735281
Vwn_ho_54_0 wn_ho_54_0 0 0.44596975002647193
Vwp_ho_55_0 wp_ho_55_0 0 0.49527345745606355
Vwn_ho_55_0 wn_ho_55_0 0 0.5047265425439365
Vwp_ho_56_0 wp_ho_56_0 0 0.5927366675110424
Vwn_ho_56_0 wn_ho_56_0 0 0.40726333248895763
Vwp_ho_57_0 wp_ho_57_0 0 0.5098536441453204
Vwn_ho_57_0 wn_ho_57_0 0 0.4901463558546796
Vwp_ho_58_0 wp_ho_58_0 0 0.3765767343190153
Vwn_ho_58_0 wn_ho_58_0 0 0.6234232656809847
Vwp_ho_59_0 wp_ho_59_0 0 0.502282458014255
Vwn_ho_59_0 wn_ho_59_0 0 0.49771754198574497
Vwp_ho_60_0 wp_ho_60_0 0 0.40970048652326096
Vwn_ho_60_0 wn_ho_60_0 0 0.590299513476739
Vwp_ho_61_0 wp_ho_61_0 0 0.5037566007005166
Vwn_ho_61_0 wn_ho_61_0 0 0.49624339929948336
Vwp_ho_62_0 wp_ho_62_0 0 0.6226998279951822
Vwn_ho_62_0 wn_ho_62_0 0 0.3773001720048178
Vwp_ho_63_0 wp_ho_63_0 0 0.5574309969053894
Vwn_ho_63_0 wn_ho_63_0 0 0.44256900309461056
Vwp_ho_64_0 wp_ho_64_0 0 0.4889471401507799
Vwn_ho_64_0 wn_ho_64_0 0 0.5110528598492201
Vwp_ho_65_0 wp_ho_65_0 0 0.45152948225960393
Vwn_ho_65_0 wn_ho_65_0 0 0.5484705177403961
Vwp_ho_66_0 wp_ho_66_0 0 0.6216896122547992
Vwn_ho_66_0 wn_ho_66_0 0 0.3783103877452008
Vwp_ho_67_0 wp_ho_67_0 0 0.4827804091875395
Vwn_ho_67_0 wn_ho_67_0 0 0.5172195908124605
Vwp_ho_68_0 wp_ho_68_0 0 0.4969531464732592
Vwn_ho_68_0 wn_ho_68_0 0 0.5030468535267408
Vwp_ho_69_0 wp_ho_69_0 0 0.4928532891577329
Vwn_ho_69_0 wn_ho_69_0 0 0.507146710842267
Vwp_ho_70_0 wp_ho_70_0 0 0.5019695348717752
Vwn_ho_70_0 wn_ho_70_0 0 0.49803046512822474
Vwp_ho_71_0 wp_ho_71_0 0 0.49905085869456633
Vwn_ho_71_0 wn_ho_71_0 0 0.5009491413054337
Vwp_ho_72_0 wp_ho_72_0 0 0.5178214120639512
Vwn_ho_72_0 wn_ho_72_0 0 0.48217858793604884
Vwp_ho_73_0 wp_ho_73_0 0 0.4909083789482491
Vwn_ho_73_0 wn_ho_73_0 0 0.5090916210517509
Vwp_ho_74_0 wp_ho_74_0 0 0.5281462308009777
Vwn_ho_74_0 wn_ho_74_0 0 0.4718537691990224
Vwp_ho_75_0 wp_ho_75_0 0 0.4845198383954011
Vwn_ho_75_0 wn_ho_75_0 0 0.5154801616045989
Vwp_ho_76_0 wp_ho_76_0 0 0.4946603539344754
Vwn_ho_76_0 wn_ho_76_0 0 0.5053396460655246
Vwp_ho_77_0 wp_ho_77_0 0 0.5671628049858134
Vwn_ho_77_0 wn_ho_77_0 0 0.4328371950141866
Vwp_ho_78_0 wp_ho_78_0 0 0.6198417064277346
Vwn_ho_78_0 wn_ho_78_0 0 0.3801582935722654
Vwp_ho_79_0 wp_ho_79_0 0 0.5065095249779663
Vwn_ho_79_0 wn_ho_79_0 0 0.4934904750220337
Vwp_ho_80_0 wp_ho_80_0 0 0.4992437547112548
Vwn_ho_80_0 wn_ho_80_0 0 0.5007562452887452
Vwp_ho_81_0 wp_ho_81_0 0 0.48162735975269677
Vwn_ho_81_0 wn_ho_81_0 0 0.5183726402473032
Vwp_ho_82_0 wp_ho_82_0 0 0.4070919214817061
Vwn_ho_82_0 wn_ho_82_0 0 0.5929080785182939
Vwp_ho_83_0 wp_ho_83_0 0 0.4999864888204065
Vwn_ho_83_0 wn_ho_83_0 0 0.5000135111795935
Vwp_ho_84_0 wp_ho_84_0 0 0.4751403453246564
Vwn_ho_84_0 wn_ho_84_0 0 0.5248596546753436
Vwp_ho_85_0 wp_ho_85_0 0 0.49833468417744037
Vwn_ho_85_0 wn_ho_85_0 0 0.5016653158225597
Vwp_ho_86_0 wp_ho_86_0 0 0.5134668473181137
Vwn_ho_86_0 wn_ho_86_0 0 0.48653315268188635
Vwp_ho_87_0 wp_ho_87_0 0 0.5079646593238896
Vwn_ho_87_0 wn_ho_87_0 0 0.49203534067611043
Vwp_ho_88_0 wp_ho_88_0 0 0.36510174312929006
Vwn_ho_88_0 wn_ho_88_0 0 0.63489825687071
Vwp_ho_89_0 wp_ho_89_0 0 0.42686746884136484
Vwn_ho_89_0 wn_ho_89_0 0 0.5731325311586352
Vwp_ho_90_0 wp_ho_90_0 0 0.49719200680625214
Vwn_ho_90_0 wn_ho_90_0 0 0.5028079931937478
Vwp_ho_91_0 wp_ho_91_0 0 0.5014243130471082
Vwn_ho_91_0 wn_ho_91_0 0 0.49857568695289173
Vwp_ho_92_0 wp_ho_92_0 0 0.4953505223220765
Vwn_ho_92_0 wn_ho_92_0 0 0.5046494776779236
Vwp_ho_93_0 wp_ho_93_0 0 0.47712592715391344
Vwn_ho_93_0 wn_ho_93_0 0 0.5228740728460866
Vwp_ho_94_0 wp_ho_94_0 0 0.500017255814474
Vwn_ho_94_0 wn_ho_94_0 0 0.4999827441855261
Vwp_ho_95_0 wp_ho_95_0 0 0.5123072955959601
Vwn_ho_95_0 wn_ho_95_0 0 0.4876927044040399
Vwp_ho_96_0 wp_ho_96_0 0 0.5072170498319062
Vwn_ho_96_0 wn_ho_96_0 0 0.4927829501680938
Vwp_ho_97_0 wp_ho_97_0 0 0.5026663267165377
Vwn_ho_97_0 wn_ho_97_0 0 0.4973336732834624
Vwp_ho_98_0 wp_ho_98_0 0 0.5217400036054384
Vwn_ho_98_0 wn_ho_98_0 0 0.4782599963945616
Vwp_ho_99_0 wp_ho_99_0 0 0.4441281994150491
Vwn_ho_99_0 wn_ho_99_0 0 0.5558718005849509
Vwp_ho_100_0 wp_ho_100_0 0 0.5118321247604856
Vwn_ho_100_0 wn_ho_100_0 0 0.4881678752395144
Vwp_ho_101_0 wp_ho_101_0 0 0.4922609126162381
Vwn_ho_101_0 wn_ho_101_0 0 0.5077390873837618
Vwp_ho_102_0 wp_ho_102_0 0 0.47148385920058355
Vwn_ho_102_0 wn_ho_102_0 0 0.5285161407994164
Vwp_ho_103_0 wp_ho_103_0 0 0.4980113248838551
Vwn_ho_103_0 wn_ho_103_0 0 0.5019886751161449
Vwp_ho_104_0 wp_ho_104_0 0 0.5031176986631224
Vwn_ho_104_0 wn_ho_104_0 0 0.4968823013368776
Vwp_ho_105_0 wp_ho_105_0 0 0.4824437920916429
Vwn_ho_105_0 wn_ho_105_0 0 0.5175562079083571
Vwp_ho_106_0 wp_ho_106_0 0 0.561454583067739
Vwn_ho_106_0 wn_ho_106_0 0 0.438545416932261
Vwp_ho_107_0 wp_ho_107_0 0 0.47900392732317765
Vwn_ho_107_0 wn_ho_107_0 0 0.5209960726768224
Vwp_ho_108_0 wp_ho_108_0 0 0.4704500653717603
Vwn_ho_108_0 wn_ho_108_0 0 0.5295499346282397
Vwp_ho_109_0 wp_ho_109_0 0 0.5736709711358281
Vwn_ho_109_0 wn_ho_109_0 0 0.4263290288641719
Vwp_ho_110_0 wp_ho_110_0 0 0.4868752496965428
Vwn_ho_110_0 wn_ho_110_0 0 0.5131247503034573
Vwp_ho_111_0 wp_ho_111_0 0 0.49951422280610824
Vwn_ho_111_0 wn_ho_111_0 0 0.5004857771938918
Vwp_ho_112_0 wp_ho_112_0 0 0.4873983532144214
Vwn_ho_112_0 wn_ho_112_0 0 0.5126016467855786
Vwp_ho_113_0 wp_ho_113_0 0 0.48144924187804833
Vwn_ho_113_0 wn_ho_113_0 0 0.5185507581219516
Vwp_ho_114_0 wp_ho_114_0 0 0.4999909233450736
Vwn_ho_114_0 wn_ho_114_0 0 0.5000090766549264
Vwp_ho_115_0 wp_ho_115_0 0 0.48585732049808583
Vwn_ho_115_0 wn_ho_115_0 0 0.5141426795019142
Vwp_ho_116_0 wp_ho_116_0 0 0.5041670535946696
Vwn_ho_116_0 wn_ho_116_0 0 0.4958329464053303
Vwp_ho_117_0 wp_ho_117_0 0 0.5044902773659939
Vwn_ho_117_0 wn_ho_117_0 0 0.495509722634006
Vwp_ho_118_0 wp_ho_118_0 0 0.49864024417687913
Vwn_ho_118_0 wn_ho_118_0 0 0.5013597558231209
Vwp_ho_119_0 wp_ho_119_0 0 0.5935928435857809
Vwn_ho_119_0 wn_ho_119_0 0 0.4064071564142191
Vwp_ho_120_0 wp_ho_120_0 0 0.5092543490827128
Vwn_ho_120_0 wn_ho_120_0 0 0.49074565091728717
Vwp_ho_121_0 wp_ho_121_0 0 0.3792693226887441
Vwn_ho_121_0 wn_ho_121_0 0 0.620730677311256
Vwp_ho_122_0 wp_ho_122_0 0 0.49877468051215607
Vwn_ho_122_0 wn_ho_122_0 0 0.501225319487844
Vwp_ho_123_0 wp_ho_123_0 0 0.40667862746505823
Vwn_ho_123_0 wn_ho_123_0 0 0.5933213725349418
Vwp_ho_124_0 wp_ho_124_0 0 0.4880690254155004
Vwn_ho_124_0 wn_ho_124_0 0 0.5119309745844997
Vwp_ho_125_0 wp_ho_125_0 0 0.5042793748988791
Vwn_ho_125_0 wn_ho_125_0 0 0.4957206251011209
Vwp_ho_126_0 wp_ho_126_0 0 0.5157650546806924
Vwn_ho_126_0 wn_ho_126_0 0 0.48423494531930755
Vwp_ho_127_0 wp_ho_127_0 0 0.48769290713218594
Vwn_ho_127_0 wn_ho_127_0 0 0.5123070928678141
Vwp_ho_128_0 wp_ho_128_0 0 0.4952169262638386
Vwn_ho_128_0 wn_ho_128_0 0 0.5047830737361614
Vwp_ho_129_0 wp_ho_129_0 0 0.6109727702602558
Vwn_ho_129_0 wn_ho_129_0 0 0.38902722973974424
Vwp_ho_130_0 wp_ho_130_0 0 0.5092819158022749
Vwn_ho_130_0 wn_ho_130_0 0 0.4907180841977251
Vwp_ho_131_0 wp_ho_131_0 0 0.605242589084692
Vwn_ho_131_0 wn_ho_131_0 0 0.39475741091530797
Vwp_ho_132_0 wp_ho_132_0 0 0.38977704116850376
Vwn_ho_132_0 wn_ho_132_0 0 0.6102229588314962
Vwp_ho_133_0 wp_ho_133_0 0 0.49081478969670367
Vwn_ho_133_0 wn_ho_133_0 0 0.5091852103032963
Vwp_ho_134_0 wp_ho_134_0 0 0.5000019268599525
Vwn_ho_134_0 wn_ho_134_0 0 0.4999980731400475
Vwp_ho_135_0 wp_ho_135_0 0 0.4964608787257471
Vwn_ho_135_0 wn_ho_135_0 0 0.5035391212742528
Vwp_ho_136_0 wp_ho_136_0 0 0.5080157550396669
Vwn_ho_136_0 wn_ho_136_0 0 0.49198424496033305
Vwp_ho_137_0 wp_ho_137_0 0 0.4029620270017198
Vwn_ho_137_0 wn_ho_137_0 0 0.5970379729982802
Vwp_ho_138_0 wp_ho_138_0 0 0.4960978852635976
Vwn_ho_138_0 wn_ho_138_0 0 0.5039021147364025
Vwp_ho_139_0 wp_ho_139_0 0 0.4844041956563632
Vwn_ho_139_0 wn_ho_139_0 0 0.5155958043436367
Vwp_ho_140_0 wp_ho_140_0 0 0.5005188786008269
Vwn_ho_140_0 wn_ho_140_0 0 0.4994811213991731
Vwp_ho_141_0 wp_ho_141_0 0 0.4849797511333132
Vwn_ho_141_0 wn_ho_141_0 0 0.5150202488666867
Vwp_ho_142_0 wp_ho_142_0 0 0.4999153461683899
Vwn_ho_142_0 wn_ho_142_0 0 0.5000846538316102
Vwp_ho_143_0 wp_ho_143_0 0 0.5002898876841311
Vwn_ho_143_0 wn_ho_143_0 0 0.4997101123158689
Vwp_ho_144_0 wp_ho_144_0 0 0.49629979320853274
Vwn_ho_144_0 wn_ho_144_0 0 0.5037002067914673
Vwp_ho_145_0 wp_ho_145_0 0 0.4999999061862324
Vwn_ho_145_0 wn_ho_145_0 0 0.5000000938137676
Vwp_ho_146_0 wp_ho_146_0 0 0.4704657214987079
Vwn_ho_146_0 wn_ho_146_0 0 0.5295342785012921
Vwp_ho_147_0 wp_ho_147_0 0 0.5256232244149002
Vwn_ho_147_0 wn_ho_147_0 0 0.4743767755850999
Vwp_ho_148_0 wp_ho_148_0 0 0.5187957269906214
Vwn_ho_148_0 wn_ho_148_0 0 0.4812042730093786
Vwp_ho_149_0 wp_ho_149_0 0 0.5041734501510725
Vwn_ho_149_0 wn_ho_149_0 0 0.4958265498489275
Vwp_ho_150_0 wp_ho_150_0 0 0.39899293727346746
Vwn_ho_150_0 wn_ho_150_0 0 0.6010070627265325
Vwp_ho_151_0 wp_ho_151_0 0 0.507153196691201
Vwn_ho_151_0 wn_ho_151_0 0 0.49284680330879904
Vwp_ho_152_0 wp_ho_152_0 0 0.5353786305056707
Vwn_ho_152_0 wn_ho_152_0 0 0.46462136949432936
Vwp_ho_153_0 wp_ho_153_0 0 0.559641929221108
Vwn_ho_153_0 wn_ho_153_0 0 0.440358070778892
Vwp_ho_154_0 wp_ho_154_0 0 0.5124091541039678
Vwn_ho_154_0 wn_ho_154_0 0 0.4875908458960322
Vwp_ho_155_0 wp_ho_155_0 0 0.4785869057767189
Vwn_ho_155_0 wn_ho_155_0 0 0.5214130942232811
Vwp_ho_156_0 wp_ho_156_0 0 0.49706138440364467
Vwn_ho_156_0 wn_ho_156_0 0 0.5029386155963553
Vwp_ho_157_0 wp_ho_157_0 0 0.49998024604357094
Vwn_ho_157_0 wn_ho_157_0 0 0.5000197539564291
Vwp_ho_158_0 wp_ho_158_0 0 0.5088992405556142
Vwn_ho_158_0 wn_ho_158_0 0 0.49110075944438586
Vwp_ho_159_0 wp_ho_159_0 0 0.5072110093897089
Vwn_ho_159_0 wn_ho_159_0 0 0.49278899061029113
Vwp_ho_160_0 wp_ho_160_0 0 0.47779992002318933
Vwn_ho_160_0 wn_ho_160_0 0 0.5222000799768107
Vwp_ho_161_0 wp_ho_161_0 0 0.5045938273088796
Vwn_ho_161_0 wn_ho_161_0 0 0.49540617269112036
Vwp_ho_162_0 wp_ho_162_0 0 0.4958986997100405
Vwn_ho_162_0 wn_ho_162_0 0 0.5041013002899595
Vwp_ho_163_0 wp_ho_163_0 0 0.49820862176033237
Vwn_ho_163_0 wn_ho_163_0 0 0.5017913782396676
Vwp_ho_164_0 wp_ho_164_0 0 0.49428317154593315
Vwn_ho_164_0 wn_ho_164_0 0 0.5057168284540668
Vwp_ho_165_0 wp_ho_165_0 0 0.5029839227275571
Vwn_ho_165_0 wn_ho_165_0 0 0.49701607727244285
Vwp_ho_166_0 wp_ho_166_0 0 0.398526692112292
Vwn_ho_166_0 wn_ho_166_0 0 0.601473307887708
Vwp_ho_167_0 wp_ho_167_0 0 0.49999728988107933
Vwn_ho_167_0 wn_ho_167_0 0 0.5000027101189207
Vwp_ho_168_0 wp_ho_168_0 0 0.5355255529479364
Vwn_ho_168_0 wn_ho_168_0 0 0.4644744470520636
Vwp_ho_169_0 wp_ho_169_0 0 0.553668811070191
Vwn_ho_169_0 wn_ho_169_0 0 0.44633118892980905
Vwp_ho_170_0 wp_ho_170_0 0 0.4726680976474635
Vwn_ho_170_0 wn_ho_170_0 0 0.5273319023525365
Vwp_ho_171_0 wp_ho_171_0 0 0.49999645618169103
Vwn_ho_171_0 wn_ho_171_0 0 0.500003543818309
Vwp_ho_172_0 wp_ho_172_0 0 0.6181141360513511
Vwn_ho_172_0 wn_ho_172_0 0 0.3818858639486489
Vwp_ho_173_0 wp_ho_173_0 0 0.6156721460435124
Vwn_ho_173_0 wn_ho_173_0 0 0.3843278539564876
Vwp_ho_174_0 wp_ho_174_0 0 0.5755900394964583
Vwn_ho_174_0 wn_ho_174_0 0 0.4244099605035417
Vwp_ho_175_0 wp_ho_175_0 0 0.5046871338069484
Vwn_ho_175_0 wn_ho_175_0 0 0.49531286619305154
Vwp_ho_176_0 wp_ho_176_0 0 0.4553659752292759
Vwn_ho_176_0 wn_ho_176_0 0 0.5446340247707241
Vwp_ho_177_0 wp_ho_177_0 0 0.46022611498749594
Vwn_ho_177_0 wn_ho_177_0 0 0.539773885012504
Vwp_ho_178_0 wp_ho_178_0 0 0.5027829935661134
Vwn_ho_178_0 wn_ho_178_0 0 0.4972170064338865
Vwp_ho_179_0 wp_ho_179_0 0 0.5037212444762964
Vwn_ho_179_0 wn_ho_179_0 0 0.4962787555237036
Vwp_ho_180_0 wp_ho_180_0 0 0.5023378918137988
Vwn_ho_180_0 wn_ho_180_0 0 0.49766210818620116
Vwp_ho_181_0 wp_ho_181_0 0 0.6597225666796297
Vwn_ho_181_0 wn_ho_181_0 0 0.3402774333203703
Vwp_ho_182_0 wp_ho_182_0 0 0.5009221766973675
Vwn_ho_182_0 wn_ho_182_0 0 0.4990778233026325
Vwp_ho_183_0 wp_ho_183_0 0 0.6222732418416065
Vwn_ho_183_0 wn_ho_183_0 0 0.3777267581583935
Vwp_ho_184_0 wp_ho_184_0 0 0.49306328479620654
Vwn_ho_184_0 wn_ho_184_0 0 0.5069367152037935
Vwp_ho_185_0 wp_ho_185_0 0 0.49270206386210014
Vwn_ho_185_0 wn_ho_185_0 0 0.5072979361378999
Vwp_ho_186_0 wp_ho_186_0 0 0.4983567774860532
Vwn_ho_186_0 wn_ho_186_0 0 0.5016432225139468
Vwp_ho_187_0 wp_ho_187_0 0 0.5005270059897677
Vwn_ho_187_0 wn_ho_187_0 0 0.49947299401023226
Vwp_ho_188_0 wp_ho_188_0 0 0.3726199576631607
Vwn_ho_188_0 wn_ho_188_0 0 0.6273800423368393
Vwp_ho_189_0 wp_ho_189_0 0 0.4988622281870193
Vwn_ho_189_0 wn_ho_189_0 0 0.5011377718129807
Vwp_ho_190_0 wp_ho_190_0 0 0.3935859581941179
Vwn_ho_190_0 wn_ho_190_0 0 0.6064140418058821
Vwp_ho_191_0 wp_ho_191_0 0 0.4559757214184653
Vwn_ho_191_0 wn_ho_191_0 0 0.5440242785815347
Vwp_ho_192_0 wp_ho_192_0 0 0.5022271995840155
Vwn_ho_192_0 wn_ho_192_0 0 0.4977728004159845
Vwp_ho_193_0 wp_ho_193_0 0 0.5333010174788878
Vwn_ho_193_0 wn_ho_193_0 0 0.4666989825211122
Vwp_ho_194_0 wp_ho_194_0 0 0.41490924463247014
Vwn_ho_194_0 wn_ho_194_0 0 0.5850907553675299
Vwp_ho_195_0 wp_ho_195_0 0 0.5006913759626496
Vwn_ho_195_0 wn_ho_195_0 0 0.4993086240373505
Vwp_ho_196_0 wp_ho_196_0 0 0.49781408423096024
Vwn_ho_196_0 wn_ho_196_0 0 0.5021859157690398
Vwp_ho_197_0 wp_ho_197_0 0 0.507504964269322
Vwn_ho_197_0 wn_ho_197_0 0 0.49249503573067804
Vwp_ho_198_0 wp_ho_198_0 0 0.5000042268678765
Vwn_ho_198_0 wn_ho_198_0 0 0.4999957731321235
Vwp_ho_199_0 wp_ho_199_0 0 0.44572332635167594
Vwn_ho_199_0 wn_ho_199_0 0 0.554276673648324
Vwp_ho_200_0 wp_ho_200_0 0 0.3833327216077
Vwn_ho_200_0 wn_ho_200_0 0 0.6166672783923
Vwp_ho_201_0 wp_ho_201_0 0 0.5242449580132265
Vwn_ho_201_0 wn_ho_201_0 0 0.47575504198677354
Vwp_ho_202_0 wp_ho_202_0 0 0.47241702823913917
Vwn_ho_202_0 wn_ho_202_0 0 0.5275829717608609
Vwp_ho_203_0 wp_ho_203_0 0 0.4815545697272471
Vwn_ho_203_0 wn_ho_203_0 0 0.5184454302727529
Vwp_ho_204_0 wp_ho_204_0 0 0.5033682528197823
Vwn_ho_204_0 wn_ho_204_0 0 0.4966317471802177
Vwp_ho_205_0 wp_ho_205_0 0 0.5026457602205162
Vwn_ho_205_0 wn_ho_205_0 0 0.4973542397794838
Vwp_ho_206_0 wp_ho_206_0 0 0.5514468298857704
Vwn_ho_206_0 wn_ho_206_0 0 0.4485531701142296
Vwp_ho_207_0 wp_ho_207_0 0 0.42422687570885775
Vwn_ho_207_0 wn_ho_207_0 0 0.5757731242911422
Vwp_ho_208_0 wp_ho_208_0 0 0.5130842055693056
Vwn_ho_208_0 wn_ho_208_0 0 0.48691579443069444
Vwp_ho_209_0 wp_ho_209_0 0 0.47504070782822183
Vwn_ho_209_0 wn_ho_209_0 0 0.5249592921717782
Vwp_ho_210_0 wp_ho_210_0 0 0.378132954064571
Vwn_ho_210_0 wn_ho_210_0 0 0.621867045935429
Vwp_ho_211_0 wp_ho_211_0 0 0.499325202310266
Vwn_ho_211_0 wn_ho_211_0 0 0.500674797689734
Vwp_ho_212_0 wp_ho_212_0 0 0.480770517792808
Vwn_ho_212_0 wn_ho_212_0 0 0.519229482207192
Vwp_ho_213_0 wp_ho_213_0 0 0.6103535276069493
Vwn_ho_213_0 wn_ho_213_0 0 0.38964647239305067
Vwp_ho_214_0 wp_ho_214_0 0 0.4826087968429933
Vwn_ho_214_0 wn_ho_214_0 0 0.5173912031570067
Vwp_ho_215_0 wp_ho_215_0 0 0.5167555097683406
Vwn_ho_215_0 wn_ho_215_0 0 0.48324449023165933
Vwp_ho_216_0 wp_ho_216_0 0 0.481774252547065
Vwn_ho_216_0 wn_ho_216_0 0 0.5182257474529349
Vwp_ho_217_0 wp_ho_217_0 0 0.4937428341613389
Vwn_ho_217_0 wn_ho_217_0 0 0.5062571658386611
Vwp_ho_218_0 wp_ho_218_0 0 0.48735560438951475
Vwn_ho_218_0 wn_ho_218_0 0 0.5126443956104852
Vwp_ho_219_0 wp_ho_219_0 0 0.49655626894269606
Vwn_ho_219_0 wn_ho_219_0 0 0.5034437310573039
Vwp_ho_220_0 wp_ho_220_0 0 0.5140119848158906
Vwn_ho_220_0 wn_ho_220_0 0 0.4859880151841094
Vwp_ho_221_0 wp_ho_221_0 0 0.46141622831112983
Vwn_ho_221_0 wn_ho_221_0 0 0.5385837716888702
Vwp_ho_222_0 wp_ho_222_0 0 0.4994110641053068
Vwn_ho_222_0 wn_ho_222_0 0 0.5005889358946932
Vwp_ho_223_0 wp_ho_223_0 0 0.5024507393136959
Vwn_ho_223_0 wn_ho_223_0 0 0.4975492606863042
Vwp_ho_224_0 wp_ho_224_0 0 0.5013450274838027
Vwn_ho_224_0 wn_ho_224_0 0 0.4986549725161973
Vwp_ho_225_0 wp_ho_225_0 0 0.49897207894859963
Vwn_ho_225_0 wn_ho_225_0 0 0.5010279210514004
Vwp_ho_226_0 wp_ho_226_0 0 0.5004985263053354
Vwn_ho_226_0 wn_ho_226_0 0 0.4995014736946646
Vwp_ho_227_0 wp_ho_227_0 0 0.5074282575292995
Vwn_ho_227_0 wn_ho_227_0 0 0.49257174247070046
Vwp_ho_228_0 wp_ho_228_0 0 0.49376097770414096
Vwn_ho_228_0 wn_ho_228_0 0 0.506239022295859
Vwp_ho_229_0 wp_ho_229_0 0 0.5000006282505955
Vwn_ho_229_0 wn_ho_229_0 0 0.4999993717494044
Vwp_ho_230_0 wp_ho_230_0 0 0.49160157191338755
Vwn_ho_230_0 wn_ho_230_0 0 0.5083984280866124
Vwp_ho_231_0 wp_ho_231_0 0 0.4892591518750099
Vwn_ho_231_0 wn_ho_231_0 0 0.5107408481249901
Vwp_ho_232_0 wp_ho_232_0 0 0.5138413291561853
Vwn_ho_232_0 wn_ho_232_0 0 0.48615867084381464
Vwp_ho_233_0 wp_ho_233_0 0 0.4504022273255055
Vwn_ho_233_0 wn_ho_233_0 0 0.5495977726744945
Vwp_ho_234_0 wp_ho_234_0 0 0.4959216693113319
Vwn_ho_234_0 wn_ho_234_0 0 0.504078330688668
Vwp_ho_235_0 wp_ho_235_0 0 0.5271331756645721
Vwn_ho_235_0 wn_ho_235_0 0 0.4728668243354279
Vwp_ho_236_0 wp_ho_236_0 0 0.49982662978813885
Vwn_ho_236_0 wn_ho_236_0 0 0.5001733702118611
Vwp_ho_237_0 wp_ho_237_0 0 0.4884335848252187
Vwn_ho_237_0 wn_ho_237_0 0 0.5115664151747813
Vwp_ho_238_0 wp_ho_238_0 0 0.6271142376030729
Vwn_ho_238_0 wn_ho_238_0 0 0.372885762396927
Vwp_ho_239_0 wp_ho_239_0 0 0.4381792355725417
Vwn_ho_239_0 wn_ho_239_0 0 0.5618207644274583
Vwp_ho_240_0 wp_ho_240_0 0 0.4954313890679591
Vwn_ho_240_0 wn_ho_240_0 0 0.5045686109320409
Vwp_ho_241_0 wp_ho_241_0 0 0.5097464422654825
Vwn_ho_241_0 wn_ho_241_0 0 0.49025355773451745
Vwp_ho_242_0 wp_ho_242_0 0 0.49540097789059995
Vwn_ho_242_0 wn_ho_242_0 0 0.5045990221094
Vwp_ho_243_0 wp_ho_243_0 0 0.3909142417600757
Vwn_ho_243_0 wn_ho_243_0 0 0.6090857582399243
Vwp_ho_244_0 wp_ho_244_0 0 0.3585925156978417
Vwn_ho_244_0 wn_ho_244_0 0 0.6414074843021583
Vwp_ho_245_0 wp_ho_245_0 0 0.5071905786003984
Vwn_ho_245_0 wn_ho_245_0 0 0.4928094213996016
Vwp_ho_246_0 wp_ho_246_0 0 0.5031550362385457
Vwn_ho_246_0 wn_ho_246_0 0 0.4968449637614543
Vwp_ho_247_0 wp_ho_247_0 0 0.4997565316009653
Vwn_ho_247_0 wn_ho_247_0 0 0.5002434683990347
Vwp_ho_248_0 wp_ho_248_0 0 0.47974085465882643
Vwn_ho_248_0 wn_ho_248_0 0 0.5202591453411736
Vwp_ho_249_0 wp_ho_249_0 0 0.49081628734673594
Vwn_ho_249_0 wn_ho_249_0 0 0.5091837126532641
Vwp_ho_250_0 wp_ho_250_0 0 0.5035294454742558
Vwn_ho_250_0 wn_ho_250_0 0 0.4964705545257442
Vwp_ho_251_0 wp_ho_251_0 0 0.49974577686400656
Vwn_ho_251_0 wn_ho_251_0 0 0.5002542231359934
Vwp_ho_252_0 wp_ho_252_0 0 0.4139607384470777
Vwn_ho_252_0 wn_ho_252_0 0 0.5860392615529223
Vwp_ho_253_0 wp_ho_253_0 0 0.4776085430927606
Vwn_ho_253_0 wn_ho_253_0 0 0.5223914569072394
Vwp_ho_254_0 wp_ho_254_0 0 0.49997468264457434
Vwn_ho_254_0 wn_ho_254_0 0 0.5000253173554257
Vwp_ho_255_0 wp_ho_255_0 0 0.49542490907325326
Vwn_ho_255_0 wn_ho_255_0 0 0.5045750909267468
Vwp_ho_256_0 wp_ho_256_0 0 0.5072759955784545
Vwn_ho_256_0 wn_ho_256_0 0 0.49272400442154557
Vwp_ho_257_0 wp_ho_257_0 0 0.6020097751218996
Vwn_ho_257_0 wn_ho_257_0 0 0.3979902248781004
Vwp_ho_258_0 wp_ho_258_0 0 0.4999468595357426
Vwn_ho_258_0 wn_ho_258_0 0 0.5000531404642574
Vwp_ho_259_0 wp_ho_259_0 0 0.5149349031133423
Vwn_ho_259_0 wn_ho_259_0 0 0.4850650968866577
Vwp_ho_260_0 wp_ho_260_0 0 0.6128249815832849
Vwn_ho_260_0 wn_ho_260_0 0 0.3871750184167151
Vwp_ho_261_0 wp_ho_261_0 0 0.49853236350401364
Vwn_ho_261_0 wn_ho_261_0 0 0.5014676364959864
Vwp_ho_262_0 wp_ho_262_0 0 0.5000008830148464
Vwn_ho_262_0 wn_ho_262_0 0 0.4999991169851537
Vwp_ho_263_0 wp_ho_263_0 0 0.5345457116436985
Vwn_ho_263_0 wn_ho_263_0 0 0.4654542883563015
Vwp_ho_264_0 wp_ho_264_0 0 0.47465278315154835
Vwn_ho_264_0 wn_ho_264_0 0 0.5253472168484516
Vwp_ho_265_0 wp_ho_265_0 0 0.37726829685747715
Vwn_ho_265_0 wn_ho_265_0 0 0.6227317031425228
Vwp_ho_266_0 wp_ho_266_0 0 0.49499505873000993
Vwn_ho_266_0 wn_ho_266_0 0 0.5050049412699901
Vwp_ho_267_0 wp_ho_267_0 0 0.5676906319322881
Vwn_ho_267_0 wn_ho_267_0 0 0.4323093680677119
Vwp_ho_268_0 wp_ho_268_0 0 0.38095079701711215
Vwn_ho_268_0 wn_ho_268_0 0 0.6190492029828879
Vwp_ho_269_0 wp_ho_269_0 0 0.49991124123516206
Vwn_ho_269_0 wn_ho_269_0 0 0.5000887587648379
Vwp_ho_270_0 wp_ho_270_0 0 0.5019048836774559
Vwn_ho_270_0 wn_ho_270_0 0 0.49809511632254416
Vwp_ho_271_0 wp_ho_271_0 0 0.5230488239980451
Vwn_ho_271_0 wn_ho_271_0 0 0.4769511760019549
Vwp_ho_272_0 wp_ho_272_0 0 0.4905747475609841
Vwn_ho_272_0 wn_ho_272_0 0 0.5094252524390159
Vwp_ho_273_0 wp_ho_273_0 0 0.5567120983786744
Vwn_ho_273_0 wn_ho_273_0 0 0.44328790162132553
Vwp_ho_274_0 wp_ho_274_0 0 0.5000331333128027
Vwn_ho_274_0 wn_ho_274_0 0 0.4999668666871972
Vwp_ho_275_0 wp_ho_275_0 0 0.5000047738660363
Vwn_ho_275_0 wn_ho_275_0 0 0.49999522613396374
Vwp_ho_276_0 wp_ho_276_0 0 0.4953735840208239
Vwn_ho_276_0 wn_ho_276_0 0 0.5046264159791761
Vwp_ho_277_0 wp_ho_277_0 0 0.5035641649236278
Vwn_ho_277_0 wn_ho_277_0 0 0.49643583507637223
Vwp_ho_278_0 wp_ho_278_0 0 0.5187680039571687
Vwn_ho_278_0 wn_ho_278_0 0 0.4812319960428313
Vwp_ho_279_0 wp_ho_279_0 0 0.5027646159045507
Vwn_ho_279_0 wn_ho_279_0 0 0.49723538409544926
Vwp_ho_280_0 wp_ho_280_0 0 0.5424003915015762
Vwn_ho_280_0 wn_ho_280_0 0 0.45759960849842385
Vwp_ho_281_0 wp_ho_281_0 0 0.5951866464061344
Vwn_ho_281_0 wn_ho_281_0 0 0.40481335359386567
Vwp_ho_282_0 wp_ho_282_0 0 0.5761615150827037
Vwn_ho_282_0 wn_ho_282_0 0 0.42383848491729625
Vwp_ho_283_0 wp_ho_283_0 0 0.4999190914049331
Vwn_ho_283_0 wn_ho_283_0 0 0.5000809085950668
Vwp_ho_284_0 wp_ho_284_0 0 0.4878725406557295
Vwn_ho_284_0 wn_ho_284_0 0 0.5121274593442705
Vwp_ho_285_0 wp_ho_285_0 0 0.5142051841883999
Vwn_ho_285_0 wn_ho_285_0 0 0.48579481581160017
Vwp_ho_286_0 wp_ho_286_0 0 0.5003056698702055
Vwn_ho_286_0 wn_ho_286_0 0 0.4996943301297944
Vwp_ho_287_0 wp_ho_287_0 0 0.5148655285492434
Vwn_ho_287_0 wn_ho_287_0 0 0.48513447145075655
Vwp_ho_0_1 wp_ho_0_1 0 0.4993885442950095
Vwn_ho_0_1 wn_ho_0_1 0 0.5006114557049904
Vwp_ho_1_1 wp_ho_1_1 0 0.3982452414993707
Vwn_ho_1_1 wn_ho_1_1 0 0.6017547585006293
Vwp_ho_2_1 wp_ho_2_1 0 0.5020236373959147
Vwn_ho_2_1 wn_ho_2_1 0 0.4979763626040853
Vwp_ho_3_1 wp_ho_3_1 0 0.5001259348182682
Vwn_ho_3_1 wn_ho_3_1 0 0.49987406518173183
Vwp_ho_4_1 wp_ho_4_1 0 0.4994467330247396
Vwn_ho_4_1 wn_ho_4_1 0 0.5005532669752605
Vwp_ho_5_1 wp_ho_5_1 0 0.4979255379141124
Vwn_ho_5_1 wn_ho_5_1 0 0.5020744620858876
Vwp_ho_6_1 wp_ho_6_1 0 0.39937146721063943
Vwn_ho_6_1 wn_ho_6_1 0 0.6006285327893606
Vwp_ho_7_1 wp_ho_7_1 0 0.30877723795177336
Vwn_ho_7_1 wn_ho_7_1 0 0.6912227620482266
Vwp_ho_8_1 wp_ho_8_1 0 0.42741045561603774
Vwn_ho_8_1 wn_ho_8_1 0 0.5725895443839623
Vwp_ho_9_1 wp_ho_9_1 0 0.6036297173701155
Vwn_ho_9_1 wn_ho_9_1 0 0.39637028262988455
Vwp_ho_10_1 wp_ho_10_1 0 0.5597880930401017
Vwn_ho_10_1 wn_ho_10_1 0 0.44021190695989837
Vwp_ho_11_1 wp_ho_11_1 0 0.5230269875214657
Vwn_ho_11_1 wn_ho_11_1 0 0.47697301247853435
Vwp_ho_12_1 wp_ho_12_1 0 0.49576501254436095
Vwn_ho_12_1 wn_ho_12_1 0 0.5042349874556391
Vwp_ho_13_1 wp_ho_13_1 0 0.6591136161642704
Vwn_ho_13_1 wn_ho_13_1 0 0.34088638383572956
Vwp_ho_14_1 wp_ho_14_1 0 0.41484976891860426
Vwn_ho_14_1 wn_ho_14_1 0 0.5851502310813957
Vwp_ho_15_1 wp_ho_15_1 0 0.33506384720401644
Vwn_ho_15_1 wn_ho_15_1 0 0.6649361527959836
Vwp_ho_16_1 wp_ho_16_1 0 0.5048401432917199
Vwn_ho_16_1 wn_ho_16_1 0 0.49515985670828006
Vwp_ho_17_1 wp_ho_17_1 0 0.49525908052851636
Vwn_ho_17_1 wn_ho_17_1 0 0.5047409194714836
Vwp_ho_18_1 wp_ho_18_1 0 0.4975516046763936
Vwn_ho_18_1 wn_ho_18_1 0 0.5024483953236064
Vwp_ho_19_1 wp_ho_19_1 0 0.548435213707954
Vwn_ho_19_1 wn_ho_19_1 0 0.451564786292046
Vwp_ho_20_1 wp_ho_20_1 0 0.5002997228935442
Vwn_ho_20_1 wn_ho_20_1 0 0.49970027710645587
Vwp_ho_21_1 wp_ho_21_1 0 0.48654355280480727
Vwn_ho_21_1 wn_ho_21_1 0 0.5134564471951928
Vwp_ho_22_1 wp_ho_22_1 0 0.5021222445738558
Vwn_ho_22_1 wn_ho_22_1 0 0.4978777554261442
Vwp_ho_23_1 wp_ho_23_1 0 0.5952847515571612
Vwn_ho_23_1 wn_ho_23_1 0 0.4047152484428388
Vwp_ho_24_1 wp_ho_24_1 0 0.5014177192998535
Vwn_ho_24_1 wn_ho_24_1 0 0.4985822807001466
Vwp_ho_25_1 wp_ho_25_1 0 0.4313479115536263
Vwn_ho_25_1 wn_ho_25_1 0 0.5686520884463737
Vwp_ho_26_1 wp_ho_26_1 0 0.581519737476513
Vwn_ho_26_1 wn_ho_26_1 0 0.4184802625234871
Vwp_ho_27_1 wp_ho_27_1 0 0.5000021839084975
Vwn_ho_27_1 wn_ho_27_1 0 0.49999781609150246
Vwp_ho_28_1 wp_ho_28_1 0 0.4078318150421092
Vwn_ho_28_1 wn_ho_28_1 0 0.5921681849578908
Vwp_ho_29_1 wp_ho_29_1 0 0.5334322694928862
Vwn_ho_29_1 wn_ho_29_1 0 0.46656773050711375
Vwp_ho_30_1 wp_ho_30_1 0 0.6746104064700472
Vwn_ho_30_1 wn_ho_30_1 0 0.3253895935299528
Vwp_ho_31_1 wp_ho_31_1 0 0.6010210547062151
Vwn_ho_31_1 wn_ho_31_1 0 0.3989789452937848
Vwp_ho_32_1 wp_ho_32_1 0 0.3807797401193633
Vwn_ho_32_1 wn_ho_32_1 0 0.6192202598806367
Vwp_ho_33_1 wp_ho_33_1 0 0.5043373134968635
Vwn_ho_33_1 wn_ho_33_1 0 0.49566268650313655
Vwp_ho_34_1 wp_ho_34_1 0 0.6004245835350677
Vwn_ho_34_1 wn_ho_34_1 0 0.3995754164649323
Vwp_ho_35_1 wp_ho_35_1 0 0.4995704935224094
Vwn_ho_35_1 wn_ho_35_1 0 0.5004295064775905
Vwp_ho_36_1 wp_ho_36_1 0 0.38776964127736185
Vwn_ho_36_1 wn_ho_36_1 0 0.6122303587226382
Vwp_ho_37_1 wp_ho_37_1 0 0.3013115643704787
Vwn_ho_37_1 wn_ho_37_1 0 0.6986884356295213
Vwp_ho_38_1 wp_ho_38_1 0 0.48511655538377046
Vwn_ho_38_1 wn_ho_38_1 0 0.5148834446162295
Vwp_ho_39_1 wp_ho_39_1 0 0.5038002781109198
Vwn_ho_39_1 wn_ho_39_1 0 0.4961997218890803
Vwp_ho_40_1 wp_ho_40_1 0 0.4991424976753063
Vwn_ho_40_1 wn_ho_40_1 0 0.5008575023246937
Vwp_ho_41_1 wp_ho_41_1 0 0.4213445925833288
Vwn_ho_41_1 wn_ho_41_1 0 0.5786554074166712
Vwp_ho_42_1 wp_ho_42_1 0 0.46323073355341027
Vwn_ho_42_1 wn_ho_42_1 0 0.5367692664465897
Vwp_ho_43_1 wp_ho_43_1 0 0.4984287350535684
Vwn_ho_43_1 wn_ho_43_1 0 0.5015712649464316
Vwp_ho_44_1 wp_ho_44_1 0 0.7004860362251233
Vwn_ho_44_1 wn_ho_44_1 0 0.3
Vwp_ho_45_1 wp_ho_45_1 0 0.49475085478171776
Vwn_ho_45_1 wn_ho_45_1 0 0.5052491452182822
Vwp_ho_46_1 wp_ho_46_1 0 0.5277759300709532
Vwn_ho_46_1 wn_ho_46_1 0 0.4722240699290467
Vwp_ho_47_1 wp_ho_47_1 0 0.4992008369367411
Vwn_ho_47_1 wn_ho_47_1 0 0.5007991630632589
Vwp_ho_48_1 wp_ho_48_1 0 0.6190697099457945
Vwn_ho_48_1 wn_ho_48_1 0 0.38093029005420553
Vwp_ho_49_1 wp_ho_49_1 0 0.6633433136705054
Vwn_ho_49_1 wn_ho_49_1 0 0.33665668632949464
Vwp_ho_50_1 wp_ho_50_1 0 0.4988275746298398
Vwn_ho_50_1 wn_ho_50_1 0 0.5011724253701603
Vwp_ho_51_1 wp_ho_51_1 0 0.5001115771982213
Vwn_ho_51_1 wn_ho_51_1 0 0.49988842280177864
Vwp_ho_52_1 wp_ho_52_1 0 0.4985883834486339
Vwn_ho_52_1 wn_ho_52_1 0 0.5014116165513661
Vwp_ho_53_1 wp_ho_53_1 0 0.5004715434813637
Vwn_ho_53_1 wn_ho_53_1 0 0.4995284565186363
Vwp_ho_54_1 wp_ho_54_1 0 0.45225728812561583
Vwn_ho_54_1 wn_ho_54_1 0 0.5477427118743842
Vwp_ho_55_1 wp_ho_55_1 0 0.4983220208535462
Vwn_ho_55_1 wn_ho_55_1 0 0.5016779791464537
Vwp_ho_56_1 wp_ho_56_1 0 0.3784889451473714
Vwn_ho_56_1 wn_ho_56_1 0 0.6215110548526286
Vwp_ho_57_1 wp_ho_57_1 0 0.5507298942987461
Vwn_ho_57_1 wn_ho_57_1 0 0.44927010570125386
Vwp_ho_58_1 wp_ho_58_1 0 0.6823694980638482
Vwn_ho_58_1 wn_ho_58_1 0 0.3176305019361518
Vwp_ho_59_1 wp_ho_59_1 0 0.5017057411268633
Vwn_ho_59_1 wn_ho_59_1 0 0.49829425887313666
Vwp_ho_60_1 wp_ho_60_1 0 0.6156951546344503
Vwn_ho_60_1 wn_ho_60_1 0 0.38430484536554965
Vwp_ho_61_1 wp_ho_61_1 0 0.5142540424824551
Vwn_ho_61_1 wn_ho_61_1 0 0.4857459575175449
Vwp_ho_62_1 wp_ho_62_1 0 0.3720657414431293
Vwn_ho_62_1 wn_ho_62_1 0 0.6279342585568707
Vwp_ho_63_1 wp_ho_63_1 0 0.3295809201092821
Vwn_ho_63_1 wn_ho_63_1 0 0.6704190798907179
Vwp_ho_64_1 wp_ho_64_1 0 0.49247941613324164
Vwn_ho_64_1 wn_ho_64_1 0 0.5075205838667584
Vwp_ho_65_1 wp_ho_65_1 0 0.5707928608455145
Vwn_ho_65_1 wn_ho_65_1 0 0.4292071391544855
Vwp_ho_66_1 wp_ho_66_1 0 0.342619192627585
Vwn_ho_66_1 wn_ho_66_1 0 0.657380807372415
Vwp_ho_67_1 wp_ho_67_1 0 0.41214180973844095
Vwn_ho_67_1 wn_ho_67_1 0 0.587858190261559
Vwp_ho_68_1 wp_ho_68_1 0 0.49767884992159955
Vwn_ho_68_1 wn_ho_68_1 0 0.5023211500784004
Vwp_ho_69_1 wp_ho_69_1 0 0.496965002675619
Vwn_ho_69_1 wn_ho_69_1 0 0.5030349973243811
Vwp_ho_70_1 wp_ho_70_1 0 0.5009179142118863
Vwn_ho_70_1 wn_ho_70_1 0 0.4990820857881137
Vwp_ho_71_1 wp_ho_71_1 0 0.49796946850009366
Vwn_ho_71_1 wn_ho_71_1 0 0.5020305314999064
Vwp_ho_72_1 wp_ho_72_1 0 0.5445053837452232
Vwn_ho_72_1 wn_ho_72_1 0 0.45549461625477683
Vwp_ho_73_1 wp_ho_73_1 0 0.50198565021534
Vwn_ho_73_1 wn_ho_73_1 0 0.49801434978465997
Vwp_ho_74_1 wp_ho_74_1 0 0.521107234222129
Vwn_ho_74_1 wn_ho_74_1 0 0.47889276577787093
Vwp_ho_75_1 wp_ho_75_1 0 0.450214386552463
Vwn_ho_75_1 wn_ho_75_1 0 0.5497856134475371
Vwp_ho_76_1 wp_ho_76_1 0 0.475311502108388
Vwn_ho_76_1 wn_ho_76_1 0 0.524688497891612
Vwp_ho_77_1 wp_ho_77_1 0 0.32805059988458507
Vwn_ho_77_1 wn_ho_77_1 0 0.6719494001154149
Vwp_ho_78_1 wp_ho_78_1 0 0.36004585094596825
Vwn_ho_78_1 wn_ho_78_1 0 0.6399541490540317
Vwp_ho_79_1 wp_ho_79_1 0 0.5099998971478732
Vwn_ho_79_1 wn_ho_79_1 0 0.4900001028521268
Vwp_ho_80_1 wp_ho_80_1 0 0.3618592428356076
Vwn_ho_80_1 wn_ho_80_1 0 0.6381407571643924
Vwp_ho_81_1 wp_ho_81_1 0 0.47619006265320507
Vwn_ho_81_1 wn_ho_81_1 0 0.5238099373467949
Vwp_ho_82_1 wp_ho_82_1 0 0.6076091157924473
Vwn_ho_82_1 wn_ho_82_1 0 0.39239088420755275
Vwp_ho_83_1 wp_ho_83_1 0 0.4999988723236908
Vwn_ho_83_1 wn_ho_83_1 0 0.5000011276763092
Vwp_ho_84_1 wp_ho_84_1 0 0.6127178113856332
Vwn_ho_84_1 wn_ho_84_1 0 0.38728218861436675
Vwp_ho_85_1 wp_ho_85_1 0 0.5000004814244424
Vwn_ho_85_1 wn_ho_85_1 0 0.4999995185755576
Vwp_ho_86_1 wp_ho_86_1 0 0.504418472321463
Vwn_ho_86_1 wn_ho_86_1 0 0.49558152767853697
Vwp_ho_87_1 wp_ho_87_1 0 0.5023470811994866
Vwn_ho_87_1 wn_ho_87_1 0 0.4976529188005135
Vwp_ho_88_1 wp_ho_88_1 0 0.6523957315198323
Vwn_ho_88_1 wn_ho_88_1 0 0.3476042684801677
Vwp_ho_89_1 wp_ho_89_1 0 0.6004781035183733
Vwn_ho_89_1 wn_ho_89_1 0 0.3995218964816267
Vwp_ho_90_1 wp_ho_90_1 0 0.49865178477832767
Vwn_ho_90_1 wn_ho_90_1 0 0.5013482152216723
Vwp_ho_91_1 wp_ho_91_1 0 0.5005840690073077
Vwn_ho_91_1 wn_ho_91_1 0 0.4994159309926923
Vwp_ho_92_1 wp_ho_92_1 0 0.4156146719225182
Vwn_ho_92_1 wn_ho_92_1 0 0.5843853280774818
Vwp_ho_93_1 wp_ho_93_1 0 0.4813703325435449
Vwn_ho_93_1 wn_ho_93_1 0 0.5186296674564551
Vwp_ho_94_1 wp_ho_94_1 0 0.4999983740509147
Vwn_ho_94_1 wn_ho_94_1 0 0.5000016259490853
Vwp_ho_95_1 wp_ho_95_1 0 0.5049214852514321
Vwn_ho_95_1 wn_ho_95_1 0 0.49507851474856795
Vwp_ho_96_1 wp_ho_96_1 0 0.4905407616293769
Vwn_ho_96_1 wn_ho_96_1 0 0.5094592383706231
Vwp_ho_97_1 wp_ho_97_1 0 0.5099444748821077
Vwn_ho_97_1 wn_ho_97_1 0 0.49005552511789235
Vwp_ho_98_1 wp_ho_98_1 0 0.3884112899101538
Vwn_ho_98_1 wn_ho_98_1 0 0.6115887100898463
Vwp_ho_99_1 wp_ho_99_1 0 0.5827442546864408
Vwn_ho_99_1 wn_ho_99_1 0 0.4172557453135592
Vwp_ho_100_1 wp_ho_100_1 0 0.5086213859638644
Vwn_ho_100_1 wn_ho_100_1 0 0.49137861403613553
Vwp_ho_101_1 wp_ho_101_1 0 0.49775586924438364
Vwn_ho_101_1 wn_ho_101_1 0 0.5022441307556164
Vwp_ho_102_1 wp_ho_102_1 0 0.5450113216038308
Vwn_ho_102_1 wn_ho_102_1 0 0.45498867839616924
Vwp_ho_103_1 wp_ho_103_1 0 0.49257403970951824
Vwn_ho_103_1 wn_ho_103_1 0 0.5074259602904818
Vwp_ho_104_1 wp_ho_104_1 0 0.5008877873091148
Vwn_ho_104_1 wn_ho_104_1 0 0.49911221269088524
Vwp_ho_105_1 wp_ho_105_1 0 0.47862983852204477
Vwn_ho_105_1 wn_ho_105_1 0 0.5213701614779552
Vwp_ho_106_1 wp_ho_106_1 0 0.407386151036691
Vwn_ho_106_1 wn_ho_106_1 0 0.5926138489633089
Vwp_ho_107_1 wp_ho_107_1 0 0.4888527061218415
Vwn_ho_107_1 wn_ho_107_1 0 0.5111472938781585
Vwp_ho_108_1 wp_ho_108_1 0 0.4723859133130091
Vwn_ho_108_1 wn_ho_108_1 0 0.527614086686991
Vwp_ho_109_1 wp_ho_109_1 0 0.3573249754456506
Vwn_ho_109_1 wn_ho_109_1 0 0.6426750245543493
Vwp_ho_110_1 wp_ho_110_1 0 0.5037526295860518
Vwn_ho_110_1 wn_ho_110_1 0 0.4962473704139482
Vwp_ho_111_1 wp_ho_111_1 0 0.4999220217862779
Vwn_ho_111_1 wn_ho_111_1 0 0.5000779782137221
Vwp_ho_112_1 wp_ho_112_1 0 0.49467395916293677
Vwn_ho_112_1 wn_ho_112_1 0 0.5053260408370632
Vwp_ho_113_1 wp_ho_113_1 0 0.42255117566001826
Vwn_ho_113_1 wn_ho_113_1 0 0.5774488243399818
Vwp_ho_114_1 wp_ho_114_1 0 0.4999974427918322
Vwn_ho_114_1 wn_ho_114_1 0 0.5000025572081678
Vwp_ho_115_1 wp_ho_115_1 0 0.49450224914868934
Vwn_ho_115_1 wn_ho_115_1 0 0.5054977508513107
Vwp_ho_116_1 wp_ho_116_1 0 0.5020411897606243
Vwn_ho_116_1 wn_ho_116_1 0 0.4979588102393757
Vwp_ho_117_1 wp_ho_117_1 0 0.5012150968351176
Vwn_ho_117_1 wn_ho_117_1 0 0.4987849031648825
Vwp_ho_118_1 wp_ho_118_1 0 0.4943603686720282
Vwn_ho_118_1 wn_ho_118_1 0 0.5056396313279717
Vwp_ho_119_1 wp_ho_119_1 0 0.38928800041937567
Vwn_ho_119_1 wn_ho_119_1 0 0.6107119995806243
Vwp_ho_120_1 wp_ho_120_1 0 0.449268110853543
Vwn_ho_120_1 wn_ho_120_1 0 0.550731889146457
Vwp_ho_121_1 wp_ho_121_1 0 0.6656630308343118
Vwn_ho_121_1 wn_ho_121_1 0 0.3343369691656882
Vwp_ho_122_1 wp_ho_122_1 0 0.4997484214101646
Vwn_ho_122_1 wn_ho_122_1 0 0.5002515785898354
Vwp_ho_123_1 wp_ho_123_1 0 0.5791977044410708
Vwn_ho_123_1 wn_ho_123_1 0 0.42080229555892923
Vwp_ho_124_1 wp_ho_124_1 0 0.4765544143212989
Vwn_ho_124_1 wn_ho_124_1 0 0.523445585678701
Vwp_ho_125_1 wp_ho_125_1 0 0.4665948682641573
Vwn_ho_125_1 wn_ho_125_1 0 0.5334051317358427
Vwp_ho_126_1 wp_ho_126_1 0 0.5097591251890707
Vwn_ho_126_1 wn_ho_126_1 0 0.49024087481092926
Vwp_ho_127_1 wp_ho_127_1 0 0.517748056226311
Vwn_ho_127_1 wn_ho_127_1 0 0.482251943773689
Vwp_ho_128_1 wp_ho_128_1 0 0.49716119659990565
Vwn_ho_128_1 wn_ho_128_1 0 0.5028388034000943
Vwp_ho_129_1 wp_ho_129_1 0 0.39409480329623775
Vwn_ho_129_1 wn_ho_129_1 0 0.6059051967037623
Vwp_ho_130_1 wp_ho_130_1 0 0.6019216486690538
Vwn_ho_130_1 wn_ho_130_1 0 0.39807835133094616
Vwp_ho_131_1 wp_ho_131_1 0 0.3594968089182266
Vwn_ho_131_1 wn_ho_131_1 0 0.6405031910817733
Vwp_ho_132_1 wp_ho_132_1 0 0.6581558973584108
Vwn_ho_132_1 wn_ho_132_1 0 0.34184410264158915
Vwp_ho_133_1 wp_ho_133_1 0 0.360703580341163
Vwn_ho_133_1 wn_ho_133_1 0 0.639296419658837
Vwp_ho_134_1 wp_ho_134_1 0 0.49999999779000176
Vwn_ho_134_1 wn_ho_134_1 0 0.5000000022099982
Vwp_ho_135_1 wp_ho_135_1 0 0.49933865013042894
Vwn_ho_135_1 wn_ho_135_1 0 0.500661349869571
Vwp_ho_136_1 wp_ho_136_1 0 0.5003313072864505
Vwn_ho_136_1 wn_ho_136_1 0 0.49966869271354947
Vwp_ho_137_1 wp_ho_137_1 0 0.646096768962017
Vwn_ho_137_1 wn_ho_137_1 0 0.353903231037983
Vwp_ho_138_1 wp_ho_138_1 0 0.49939918301492
Vwn_ho_138_1 wn_ho_138_1 0 0.5006008169850801
Vwp_ho_139_1 wp_ho_139_1 0 0.4965658158440014
Vwn_ho_139_1 wn_ho_139_1 0 0.5034341841559986
Vwp_ho_140_1 wp_ho_140_1 0 0.5001527307670831
Vwn_ho_140_1 wn_ho_140_1 0 0.4998472692329169
Vwp_ho_141_1 wp_ho_141_1 0 0.35676706884029685
Vwn_ho_141_1 wn_ho_141_1 0 0.6432329311597031
Vwp_ho_142_1 wp_ho_142_1 0 0.49975722786712073
Vwn_ho_142_1 wn_ho_142_1 0 0.5002427721328793
Vwp_ho_143_1 wp_ho_143_1 0 0.5000955044200214
Vwn_ho_143_1 wn_ho_143_1 0 0.4999044955799787
Vwp_ho_144_1 wp_ho_144_1 0 0.49863596440653984
Vwn_ho_144_1 wn_ho_144_1 0 0.5013640355934601
Vwp_ho_145_1 wp_ho_145_1 0 0.4999997243789925
Vwn_ho_145_1 wn_ho_145_1 0 0.5000002756210076
Vwp_ho_146_1 wp_ho_146_1 0 0.4615832147757162
Vwn_ho_146_1 wn_ho_146_1 0 0.5384167852242838
Vwp_ho_147_1 wp_ho_147_1 0 0.5247668987585872
Vwn_ho_147_1 wn_ho_147_1 0 0.4752331012414128
Vwp_ho_148_1 wp_ho_148_1 0 0.5139602996620306
Vwn_ho_148_1 wn_ho_148_1 0 0.4860397003379694
Vwp_ho_149_1 wp_ho_149_1 0 0.47448146528637564
Vwn_ho_149_1 wn_ho_149_1 0 0.5255185347136244
Vwp_ho_150_1 wp_ho_150_1 0 0.5868265118525305
Vwn_ho_150_1 wn_ho_150_1 0 0.4131734881474694
Vwp_ho_151_1 wp_ho_151_1 0 0.502290919714938
Vwn_ho_151_1 wn_ho_151_1 0 0.497709080285062
Vwp_ho_152_1 wp_ho_152_1 0 0.38728545131641307
Vwn_ho_152_1 wn_ho_152_1 0 0.612714548683587
Vwp_ho_153_1 wp_ho_153_1 0 0.31353250636423674
Vwn_ho_153_1 wn_ho_153_1 0 0.6864674936357633
Vwp_ho_154_1 wp_ho_154_1 0 0.44532149599391946
Vwn_ho_154_1 wn_ho_154_1 0 0.5546785040060805
Vwp_ho_155_1 wp_ho_155_1 0 0.4481787632889866
Vwn_ho_155_1 wn_ho_155_1 0 0.5518212367110134
Vwp_ho_156_1 wp_ho_156_1 0 0.5559005811454062
Vwn_ho_156_1 wn_ho_156_1 0 0.44409941885459375
Vwp_ho_157_1 wp_ho_157_1 0 0.5000002496622382
Vwn_ho_157_1 wn_ho_157_1 0 0.49999975033776184
Vwp_ho_158_1 wp_ho_158_1 0 0.5063376676123565
Vwn_ho_158_1 wn_ho_158_1 0 0.49366233238764345
Vwp_ho_159_1 wp_ho_159_1 0 0.5578556433674231
Vwn_ho_159_1 wn_ho_159_1 0 0.44214435663257695
Vwp_ho_160_1 wp_ho_160_1 0 0.46489846141739327
Vwn_ho_160_1 wn_ho_160_1 0 0.5351015385826068
Vwp_ho_161_1 wp_ho_161_1 0 0.500742356780296
Vwn_ho_161_1 wn_ho_161_1 0 0.499257643219704
Vwp_ho_162_1 wp_ho_162_1 0 0.49823535227088744
Vwn_ho_162_1 wn_ho_162_1 0 0.5017646477291126
Vwp_ho_163_1 wp_ho_163_1 0 0.49968969012835224
Vwn_ho_163_1 wn_ho_163_1 0 0.5003103098716477
Vwp_ho_164_1 wp_ho_164_1 0 0.47915589423482663
Vwn_ho_164_1 wn_ho_164_1 0 0.5208441057651734
Vwp_ho_165_1 wp_ho_165_1 0 0.5383863995062363
Vwn_ho_165_1 wn_ho_165_1 0 0.4616136004937637
Vwp_ho_166_1 wp_ho_166_1 0 0.6582034480479094
Vwn_ho_166_1 wn_ho_166_1 0 0.3417965519520906
Vwp_ho_167_1 wp_ho_167_1 0 0.49999998740389806
Vwn_ho_167_1 wn_ho_167_1 0 0.5000000125961019
Vwp_ho_168_1 wp_ho_168_1 0 0.4260099875793343
Vwn_ho_168_1 wn_ho_168_1 0 0.5739900124206657
Vwp_ho_169_1 wp_ho_169_1 0 0.3603277961815742
Vwn_ho_169_1 wn_ho_169_1 0 0.6396722038184258
Vwp_ho_170_1 wp_ho_170_1 0 0.48512187096815246
Vwn_ho_170_1 wn_ho_170_1 0 0.5148781290318475
Vwp_ho_171_1 wp_ho_171_1 0 0.49999982847928987
Vwn_ho_171_1 wn_ho_171_1 0 0.5000001715207102
Vwp_ho_172_1 wp_ho_172_1 0 0.3631651816610456
Vwn_ho_172_1 wn_ho_172_1 0 0.6368348183389544
Vwp_ho_173_1 wp_ho_173_1 0 0.3189264682811747
Vwn_ho_173_1 wn_ho_173_1 0 0.6810735317188252
Vwp_ho_174_1 wp_ho_174_1 0 0.4362608584828582
Vwn_ho_174_1 wn_ho_174_1 0 0.5637391415171418
Vwp_ho_175_1 wp_ho_175_1 0 0.5897994258540362
Vwn_ho_175_1 wn_ho_175_1 0 0.4102005741459638
Vwp_ho_176_1 wp_ho_176_1 0 0.5201875895299792
Vwn_ho_176_1 wn_ho_176_1 0 0.4798124104700208
Vwp_ho_177_1 wp_ho_177_1 0 0.5019522345108024
Vwn_ho_177_1 wn_ho_177_1 0 0.49804776548919755
Vwp_ho_178_1 wp_ho_178_1 0 0.5024813124210729
Vwn_ho_178_1 wn_ho_178_1 0 0.49751868757892714
Vwp_ho_179_1 wp_ho_179_1 0 0.5004949073914287
Vwn_ho_179_1 wn_ho_179_1 0 0.49950509260857134
Vwp_ho_180_1 wp_ho_180_1 0 0.5057447823533062
Vwn_ho_180_1 wn_ho_180_1 0 0.4942552176466938
Vwp_ho_181_1 wp_ho_181_1 0 0.3
Vwn_ho_181_1 wn_ho_181_1 0 0.7122552497157074
Vwp_ho_182_1 wp_ho_182_1 0 0.499564810976388
Vwn_ho_182_1 wn_ho_182_1 0 0.5004351890236121
Vwp_ho_183_1 wp_ho_183_1 0 0.31332070975348514
Vwn_ho_183_1 wn_ho_183_1 0 0.6866792902465149
Vwp_ho_184_1 wp_ho_184_1 0 0.49784307121506755
Vwn_ho_184_1 wn_ho_184_1 0 0.5021569287849325
Vwp_ho_185_1 wp_ho_185_1 0 0.49809231971321893
Vwn_ho_185_1 wn_ho_185_1 0 0.501907680286781
Vwp_ho_186_1 wp_ho_186_1 0 0.3938542065633392
Vwn_ho_186_1 wn_ho_186_1 0 0.6061457934366608
Vwp_ho_187_1 wp_ho_187_1 0 0.5000954538048121
Vwn_ho_187_1 wn_ho_187_1 0 0.49990454619518787
Vwp_ho_188_1 wp_ho_188_1 0 0.6316698662816422
Vwn_ho_188_1 wn_ho_188_1 0 0.3683301337183578
Vwp_ho_189_1 wp_ho_189_1 0 0.4998170733120355
Vwn_ho_189_1 wn_ho_189_1 0 0.5001829266879645
Vwp_ho_190_1 wp_ho_190_1 0 0.6166237250446113
Vwn_ho_190_1 wn_ho_190_1 0 0.38337627495538873
Vwp_ho_191_1 wp_ho_191_1 0 0.5420483391145736
Vwn_ho_191_1 wn_ho_191_1 0 0.45795166088542644
Vwp_ho_192_1 wp_ho_192_1 0 0.5007910209562438
Vwn_ho_192_1 wn_ho_192_1 0 0.4992089790437562
Vwp_ho_193_1 wp_ho_193_1 0 0.528001323159792
Vwn_ho_193_1 wn_ho_193_1 0 0.47199867684020796
Vwp_ho_194_1 wp_ho_194_1 0 0.5919908860566824
Vwn_ho_194_1 wn_ho_194_1 0 0.4080091139433176
Vwp_ho_195_1 wp_ho_195_1 0 0.5008423438892504
Vwn_ho_195_1 wn_ho_195_1 0 0.4991576561107496
Vwp_ho_196_1 wp_ho_196_1 0 0.4980797416940985
Vwn_ho_196_1 wn_ho_196_1 0 0.5019202583059015
Vwp_ho_197_1 wp_ho_197_1 0 0.5301308898632712
Vwn_ho_197_1 wn_ho_197_1 0 0.46986911013672883
Vwp_ho_198_1 wp_ho_198_1 0 0.50001537450759
Vwn_ho_198_1 wn_ho_198_1 0 0.49998462549241
Vwp_ho_199_1 wp_ho_199_1 0 0.5664809161966168
Vwn_ho_199_1 wn_ho_199_1 0 0.4335190838033833
Vwp_ho_200_1 wp_ho_200_1 0 0.6410661649884908
Vwn_ho_200_1 wn_ho_200_1 0 0.3589338350115093
Vwp_ho_201_1 wp_ho_201_1 0 0.5312221025440647
Vwn_ho_201_1 wn_ho_201_1 0 0.46877789745593534
Vwp_ho_202_1 wp_ho_202_1 0 0.5353530885006598
Vwn_ho_202_1 wn_ho_202_1 0 0.4646469114993403
Vwp_ho_203_1 wp_ho_203_1 0 0.5044281507607314
Vwn_ho_203_1 wn_ho_203_1 0 0.49557184923926856
Vwp_ho_204_1 wp_ho_204_1 0 0.591051506664528
Vwn_ho_204_1 wn_ho_204_1 0 0.40894849333547206
Vwp_ho_205_1 wp_ho_205_1 0 0.5007034860611939
Vwn_ho_205_1 wn_ho_205_1 0 0.49929651393880614
Vwp_ho_206_1 wp_ho_206_1 0 0.3527413743367558
Vwn_ho_206_1 wn_ho_206_1 0 0.6472586256632442
Vwp_ho_207_1 wp_ho_207_1 0 0.704674952484883
Vwn_ho_207_1 wn_ho_207_1 0 0.3
Vwp_ho_208_1 wp_ho_208_1 0 0.5051123711163639
Vwn_ho_208_1 wn_ho_208_1 0 0.4948876288836362
Vwp_ho_209_1 wp_ho_209_1 0 0.42659336095131684
Vwn_ho_209_1 wn_ho_209_1 0 0.5734066390486832
Vwp_ho_210_1 wp_ho_210_1 0 0.6776664911716025
Vwn_ho_210_1 wn_ho_210_1 0 0.3223335088283975
Vwp_ho_211_1 wp_ho_211_1 0 0.49969155580864993
Vwn_ho_211_1 wn_ho_211_1 0 0.50030844419135
Vwp_ho_212_1 wp_ho_212_1 0 0.48856387308676946
Vwn_ho_212_1 wn_ho_212_1 0 0.5114361269132305
Vwp_ho_213_1 wp_ho_213_1 0 0.4013777433494904
Vwn_ho_213_1 wn_ho_213_1 0 0.5986222566505096
Vwp_ho_214_1 wp_ho_214_1 0 0.6018069216331215
Vwn_ho_214_1 wn_ho_214_1 0 0.39819307836687845
Vwp_ho_215_1 wp_ho_215_1 0 0.44398715058509597
Vwn_ho_215_1 wn_ho_215_1 0 0.556012849414904
Vwp_ho_216_1 wp_ho_216_1 0 0.5040318250589483
Vwn_ho_216_1 wn_ho_216_1 0 0.49596817494105166
Vwp_ho_217_1 wp_ho_217_1 0 0.499349875516604
Vwn_ho_217_1 wn_ho_217_1 0 0.5006501244833961
Vwp_ho_218_1 wp_ho_218_1 0 0.5612651149200975
Vwn_ho_218_1 wn_ho_218_1 0 0.43873488507990255
Vwp_ho_219_1 wp_ho_219_1 0 0.5932026384476946
Vwn_ho_219_1 wn_ho_219_1 0 0.40679736155230545
Vwp_ho_220_1 wp_ho_220_1 0 0.50133470080443
Vwn_ho_220_1 wn_ho_220_1 0 0.49866529919557007
Vwp_ho_221_1 wp_ho_221_1 0 0.6520394137158487
Vwn_ho_221_1 wn_ho_221_1 0 0.3479605862841512
Vwp_ho_222_1 wp_ho_222_1 0 0.5000943970100141
Vwn_ho_222_1 wn_ho_222_1 0 0.4999056029899859
Vwp_ho_223_1 wp_ho_223_1 0 0.5060316455115005
Vwn_ho_223_1 wn_ho_223_1 0 0.4939683544884995
Vwp_ho_224_1 wp_ho_224_1 0 0.5004684508869792
Vwn_ho_224_1 wn_ho_224_1 0 0.4995315491130208
Vwp_ho_225_1 wp_ho_225_1 0 0.5039599436695125
Vwn_ho_225_1 wn_ho_225_1 0 0.4960400563304875
Vwp_ho_226_1 wp_ho_226_1 0 0.4909444148916476
Vwn_ho_226_1 wn_ho_226_1 0 0.5090555851083524
Vwp_ho_227_1 wp_ho_227_1 0 0.4783215073442941
Vwn_ho_227_1 wn_ho_227_1 0 0.521678492655706
Vwp_ho_228_1 wp_ho_228_1 0 0.4994542909171026
Vwn_ho_228_1 wn_ho_228_1 0 0.5005457090828974
Vwp_ho_229_1 wp_ho_229_1 0 0.5000002253368442
Vwn_ho_229_1 wn_ho_229_1 0 0.49999977466315587
Vwp_ho_230_1 wp_ho_230_1 0 0.48626713593453347
Vwn_ho_230_1 wn_ho_230_1 0 0.5137328640654666
Vwp_ho_231_1 wp_ho_231_1 0 0.6255654408930003
Vwn_ho_231_1 wn_ho_231_1 0 0.3744345591069998
Vwp_ho_232_1 wp_ho_232_1 0 0.558132758427673
Vwn_ho_232_1 wn_ho_232_1 0 0.44186724157232704
Vwp_ho_233_1 wp_ho_233_1 0 0.6370964215687329
Vwn_ho_233_1 wn_ho_233_1 0 0.36290357843126714
Vwp_ho_234_1 wp_ho_234_1 0 0.5234237614465281
Vwn_ho_234_1 wn_ho_234_1 0 0.47657623855347186
Vwp_ho_235_1 wp_ho_235_1 0 0.40379871655686306
Vwn_ho_235_1 wn_ho_235_1 0 0.5962012834431369
Vwp_ho_236_1 wp_ho_236_1 0 0.4999959181886286
Vwn_ho_236_1 wn_ho_236_1 0 0.5000040818113715
Vwp_ho_237_1 wp_ho_237_1 0 0.49945796692311406
Vwn_ho_237_1 wn_ho_237_1 0 0.5005420330768859
Vwp_ho_238_1 wp_ho_238_1 0 0.3281959130650414
Vwn_ho_238_1 wn_ho_238_1 0 0.6718040869349586
Vwp_ho_239_1 wp_ho_239_1 0 0.6211894025451332
Vwn_ho_239_1 wn_ho_239_1 0 0.37881059745486684
Vwp_ho_240_1 wp_ho_240_1 0 0.5005694922122437
Vwn_ho_240_1 wn_ho_240_1 0 0.4994305077877563
Vwp_ho_241_1 wp_ho_241_1 0 0.38517627215037525
Vwn_ho_241_1 wn_ho_241_1 0 0.6148237278496247
Vwp_ho_242_1 wp_ho_242_1 0 0.49882668355338344
Vwn_ho_242_1 wn_ho_242_1 0 0.5011733164466166
Vwp_ho_243_1 wp_ho_243_1 0 0.6920056629466426
Vwn_ho_243_1 wn_ho_243_1 0 0.30799433705335744
Vwp_ho_244_1 wp_ho_244_1 0 0.635522371290802
Vwn_ho_244_1 wn_ho_244_1 0 0.36447762870919803
Vwp_ho_245_1 wp_ho_245_1 0 0.4884124049620967
Vwn_ho_245_1 wn_ho_245_1 0 0.5115875950379033
Vwp_ho_246_1 wp_ho_246_1 0 0.5004777516620104
Vwn_ho_246_1 wn_ho_246_1 0 0.49952224833798964
Vwp_ho_247_1 wp_ho_247_1 0 0.49987515650382613
Vwn_ho_247_1 wn_ho_247_1 0 0.5001248434961739
Vwp_ho_248_1 wp_ho_248_1 0 0.587914109154777
Vwn_ho_248_1 wn_ho_248_1 0 0.412085890845223
Vwp_ho_249_1 wp_ho_249_1 0 0.4980965962747508
Vwn_ho_249_1 wn_ho_249_1 0 0.5019034037252492
Vwp_ho_250_1 wp_ho_250_1 0 0.49625470150562906
Vwn_ho_250_1 wn_ho_250_1 0 0.5037452984943709
Vwp_ho_251_1 wp_ho_251_1 0 0.5000505406957151
Vwn_ho_251_1 wn_ho_251_1 0 0.4999494593042849
Vwp_ho_252_1 wp_ho_252_1 0 0.5838516287188715
Vwn_ho_252_1 wn_ho_252_1 0 0.41614837128112847
Vwp_ho_253_1 wp_ho_253_1 0 0.44826121321779755
Vwn_ho_253_1 wn_ho_253_1 0 0.5517387867822025
Vwp_ho_254_1 wp_ho_254_1 0 0.49999715904688286
Vwn_ho_254_1 wn_ho_254_1 0 0.5000028409531172
Vwp_ho_255_1 wp_ho_255_1 0 0.49849426764964294
Vwn_ho_255_1 wn_ho_255_1 0 0.5015057323503571
Vwp_ho_256_1 wp_ho_256_1 0 0.5022211120260243
Vwn_ho_256_1 wn_ho_256_1 0 0.49777888797397574
Vwp_ho_257_1 wp_ho_257_1 0 0.3609686471425639
Vwn_ho_257_1 wn_ho_257_1 0 0.6390313528574361
Vwp_ho_258_1 wp_ho_258_1 0 0.49998316938513804
Vwn_ho_258_1 wn_ho_258_1 0 0.500016830614862
Vwp_ho_259_1 wp_ho_259_1 0 0.5044604141629915
Vwn_ho_259_1 wn_ho_259_1 0 0.4955395858370085
Vwp_ho_260_1 wp_ho_260_1 0 0.382602801973891
Vwn_ho_260_1 wn_ho_260_1 0 0.617397198026109
Vwp_ho_261_1 wp_ho_261_1 0 0.49966630179791205
Vwn_ho_261_1 wn_ho_261_1 0 0.500333698202088
Vwp_ho_262_1 wp_ho_262_1 0 0.5000001376923177
Vwn_ho_262_1 wn_ho_262_1 0 0.49999986230768234
Vwp_ho_263_1 wp_ho_263_1 0 0.3938017162772065
Vwn_ho_263_1 wn_ho_263_1 0 0.6061982837227935
Vwp_ho_264_1 wp_ho_264_1 0 0.6639426244637376
Vwn_ho_264_1 wn_ho_264_1 0 0.3360573755362624
Vwp_ho_265_1 wp_ho_265_1 0 0.5978741178885352
Vwn_ho_265_1 wn_ho_265_1 0 0.4021258821114649
Vwp_ho_266_1 wp_ho_266_1 0 0.4935936760780358
Vwn_ho_266_1 wn_ho_266_1 0 0.5064063239219643
Vwp_ho_267_1 wp_ho_267_1 0 0.37818636495733443
Vwn_ho_267_1 wn_ho_267_1 0 0.6218136350426655
Vwp_ho_268_1 wp_ho_268_1 0 0.733248857149323
Vwn_ho_268_1 wn_ho_268_1 0 0.3
Vwp_ho_269_1 wp_ho_269_1 0 0.5000050752606333
Vwn_ho_269_1 wn_ho_269_1 0 0.4999949247393667
Vwp_ho_270_1 wp_ho_270_1 0 0.5038709432727895
Vwn_ho_270_1 wn_ho_270_1 0 0.4961290567272106
Vwp_ho_271_1 wp_ho_271_1 0 0.42381727697829374
Vwn_ho_271_1 wn_ho_271_1 0 0.5761827230217063
Vwp_ho_272_1 wp_ho_272_1 0 0.5516900905243255
Vwn_ho_272_1 wn_ho_272_1 0 0.4483099094756745
Vwp_ho_273_1 wp_ho_273_1 0 0.39303642251150067
Vwn_ho_273_1 wn_ho_273_1 0 0.6069635774884993
Vwp_ho_274_1 wp_ho_274_1 0 0.5000199008576997
Vwn_ho_274_1 wn_ho_274_1 0 0.4999800991423004
Vwp_ho_275_1 wp_ho_275_1 0 0.49999132251252554
Vwn_ho_275_1 wn_ho_275_1 0 0.5000086774874745
Vwp_ho_276_1 wp_ho_276_1 0 0.5004302433604217
Vwn_ho_276_1 wn_ho_276_1 0 0.4995697566395783
Vwp_ho_277_1 wp_ho_277_1 0 0.5010460540359576
Vwn_ho_277_1 wn_ho_277_1 0 0.4989539459640424
Vwp_ho_278_1 wp_ho_278_1 0 0.4068257332326084
Vwn_ho_278_1 wn_ho_278_1 0 0.5931742667673916
Vwp_ho_279_1 wp_ho_279_1 0 0.5012108092466477
Vwn_ho_279_1 wn_ho_279_1 0 0.49878919075335226
Vwp_ho_280_1 wp_ho_280_1 0 0.38620104046032633
Vwn_ho_280_1 wn_ho_280_1 0 0.6137989595396737
Vwp_ho_281_1 wp_ho_281_1 0 0.3843762944142675
Vwn_ho_281_1 wn_ho_281_1 0 0.6156237055857325
Vwp_ho_282_1 wp_ho_282_1 0 0.39059162986030327
Vwn_ho_282_1 wn_ho_282_1 0 0.6094083701396967
Vwp_ho_283_1 wp_ho_283_1 0 0.5000106539112923
Vwn_ho_283_1 wn_ho_283_1 0 0.4999893460887077
Vwp_ho_284_1 wp_ho_284_1 0 0.4926401429865819
Vwn_ho_284_1 wn_ho_284_1 0 0.5073598570134181
Vwp_ho_285_1 wp_ho_285_1 0 0.5124528935849572
Vwn_ho_285_1 wn_ho_285_1 0 0.48754710641504284
Vwp_ho_286_1 wp_ho_286_1 0 0.5015173964671188
Vwn_ho_286_1 wn_ho_286_1 0 0.4984826035328812
Vwp_ho_287_1 wp_ho_287_1 0 0.5034365660452538
Vwn_ho_287_1 wn_ho_287_1 0 0.4965634339547462
Vwp_ho_0_2 wp_ho_0_2 0 0.5009326510131181
Vwn_ho_0_2 wn_ho_0_2 0 0.4990673489868818
Vwp_ho_1_2 wp_ho_1_2 0 0.6215415365610738
Vwn_ho_1_2 wn_ho_1_2 0 0.3784584634389262
Vwp_ho_2_2 wp_ho_2_2 0 0.5013886975313621
Vwn_ho_2_2 wn_ho_2_2 0 0.49861130246863794
Vwp_ho_3_2 wp_ho_3_2 0 0.49961945514562983
Vwn_ho_3_2 wn_ho_3_2 0 0.5003805448543701
Vwp_ho_4_2 wp_ho_4_2 0 0.49850251921705263
Vwn_ho_4_2 wn_ho_4_2 0 0.5014974807829473
Vwp_ho_5_2 wp_ho_5_2 0 0.49895913445849605
Vwn_ho_5_2 wn_ho_5_2 0 0.501040865541504
Vwp_ho_6_2 wp_ho_6_2 0 0.5851213752696641
Vwn_ho_6_2 wn_ho_6_2 0 0.4148786247303359
Vwp_ho_7_2 wp_ho_7_2 0 0.5901107199326678
Vwn_ho_7_2 wn_ho_7_2 0 0.40988928006733216
Vwp_ho_8_2 wp_ho_8_2 0 0.5661438392687318
Vwn_ho_8_2 wn_ho_8_2 0 0.4338561607312682
Vwp_ho_9_2 wp_ho_9_2 0 0.4331121046338005
Vwn_ho_9_2 wn_ho_9_2 0 0.5668878953661995
Vwp_ho_10_2 wp_ho_10_2 0 0.46649696473320235
Vwn_ho_10_2 wn_ho_10_2 0 0.5335030352667977
Vwp_ho_11_2 wp_ho_11_2 0 0.4686621723170036
Vwn_ho_11_2 wn_ho_11_2 0 0.5313378276829964
Vwp_ho_12_2 wp_ho_12_2 0 0.5089705246063148
Vwn_ho_12_2 wn_ho_12_2 0 0.49102947539368524
Vwp_ho_13_2 wp_ho_13_2 0 0.389281191941385
Vwn_ho_13_2 wn_ho_13_2 0 0.610718808058615
Vwp_ho_14_2 wp_ho_14_2 0 0.5650864423005406
Vwn_ho_14_2 wn_ho_14_2 0 0.43491355769945933
Vwp_ho_15_2 wp_ho_15_2 0 0.5823456941127629
Vwn_ho_15_2 wn_ho_15_2 0 0.41765430588723707
Vwp_ho_16_2 wp_ho_16_2 0 0.49967106174214426
Vwn_ho_16_2 wn_ho_16_2 0 0.5003289382578557
Vwp_ho_17_2 wp_ho_17_2 0 0.49631263113933544
Vwn_ho_17_2 wn_ho_17_2 0 0.5036873688606646
Vwp_ho_18_2 wp_ho_18_2 0 0.5033405363388795
Vwn_ho_18_2 wn_ho_18_2 0 0.4966594636611205
Vwp_ho_19_2 wp_ho_19_2 0 0.4612103864651694
Vwn_ho_19_2 wn_ho_19_2 0 0.5387896135348307
Vwp_ho_20_2 wp_ho_20_2 0 0.49957076800729344
Vwn_ho_20_2 wn_ho_20_2 0 0.5004292319927065
Vwp_ho_21_2 wp_ho_21_2 0 0.493850760382578
Vwn_ho_21_2 wn_ho_21_2 0 0.506149239617422
Vwp_ho_22_2 wp_ho_22_2 0 0.49675287411975544
Vwn_ho_22_2 wn_ho_22_2 0 0.5032471258802446
Vwp_ho_23_2 wp_ho_23_2 0 0.43229535635112926
Vwn_ho_23_2 wn_ho_23_2 0 0.5677046436488707
Vwp_ho_24_2 wp_ho_24_2 0 0.49709739885756565
Vwn_ho_24_2 wn_ho_24_2 0 0.5029026011424343
Vwp_ho_25_2 wp_ho_25_2 0 0.5681842394039777
Vwn_ho_25_2 wn_ho_25_2 0 0.43181576059602234
Vwp_ho_26_2 wp_ho_26_2 0 0.4526440588895735
Vwn_ho_26_2 wn_ho_26_2 0 0.5473559411104265
Vwp_ho_27_2 wp_ho_27_2 0 0.5000139212861874
Vwn_ho_27_2 wn_ho_27_2 0 0.4999860787138126
Vwp_ho_28_2 wp_ho_28_2 0 0.5229498357413692
Vwn_ho_28_2 wn_ho_28_2 0 0.4770501642586308
Vwp_ho_29_2 wp_ho_29_2 0 0.4585535034582499
Vwn_ho_29_2 wn_ho_29_2 0 0.54144649654175
Vwp_ho_30_2 wp_ho_30_2 0 0.3776117041143558
Vwn_ho_30_2 wn_ho_30_2 0 0.6223882958856441
Vwp_ho_31_2 wp_ho_31_2 0 0.40004271655723594
Vwn_ho_31_2 wn_ho_31_2 0 0.599957283442764
Vwp_ho_32_2 wp_ho_32_2 0 0.5862354952921609
Vwn_ho_32_2 wn_ho_32_2 0 0.4137645047078391
Vwp_ho_33_2 wp_ho_33_2 0 0.49593269759166486
Vwn_ho_33_2 wn_ho_33_2 0 0.5040673024083352
Vwp_ho_34_2 wp_ho_34_2 0 0.45456107968337933
Vwn_ho_34_2 wn_ho_34_2 0 0.5454389203166207
Vwp_ho_35_2 wp_ho_35_2 0 0.5001089169417554
Vwn_ho_35_2 wn_ho_35_2 0 0.4998910830582446
Vwp_ho_36_2 wp_ho_36_2 0 0.6077975363839169
Vwn_ho_36_2 wn_ho_36_2 0 0.39220246361608313
Vwp_ho_37_2 wp_ho_37_2 0 0.6314253969231274
Vwn_ho_37_2 wn_ho_37_2 0 0.3685746030768726
Vwp_ho_38_2 wp_ho_38_2 0 0.5321027430346671
Vwn_ho_38_2 wn_ho_38_2 0 0.4678972569653329
Vwp_ho_39_2 wp_ho_39_2 0 0.4932200497364382
Vwn_ho_39_2 wn_ho_39_2 0 0.5067799502635618
Vwp_ho_40_2 wp_ho_40_2 0 0.4937405287067014
Vwn_ho_40_2 wn_ho_40_2 0 0.5062594712932986
Vwp_ho_41_2 wp_ho_41_2 0 0.5370474584203488
Vwn_ho_41_2 wn_ho_41_2 0 0.4629525415796511
Vwp_ho_42_2 wp_ho_42_2 0 0.5274354843038681
Vwn_ho_42_2 wn_ho_42_2 0 0.47256451569613184
Vwp_ho_43_2 wp_ho_43_2 0 0.49155288815319276
Vwn_ho_43_2 wn_ho_43_2 0 0.5084471118468072
Vwp_ho_44_2 wp_ho_44_2 0 0.37770214734738183
Vwn_ho_44_2 wn_ho_44_2 0 0.6222978526526182
Vwp_ho_45_2 wp_ho_45_2 0 0.49935725135719145
Vwn_ho_45_2 wn_ho_45_2 0 0.5006427486428086
Vwp_ho_46_2 wp_ho_46_2 0 0.4715778657018736
Vwn_ho_46_2 wn_ho_46_2 0 0.5284221342981265
Vwp_ho_47_2 wp_ho_47_2 0 0.5010680765958857
Vwn_ho_47_2 wn_ho_47_2 0 0.4989319234041143
Vwp_ho_48_2 wp_ho_48_2 0 0.4854522540912839
Vwn_ho_48_2 wn_ho_48_2 0 0.5145477459087161
Vwp_ho_49_2 wp_ho_49_2 0 0.4616531858863747
Vwn_ho_49_2 wn_ho_49_2 0 0.5383468141136253
Vwp_ho_50_2 wp_ho_50_2 0 0.5016010700066221
Vwn_ho_50_2 wn_ho_50_2 0 0.4983989299933779
Vwp_ho_51_2 wp_ho_51_2 0 0.5010187068286498
Vwn_ho_51_2 wn_ho_51_2 0 0.4989812931713502
Vwp_ho_52_2 wp_ho_52_2 0 0.5015766857860877
Vwn_ho_52_2 wn_ho_52_2 0 0.4984233142139123
Vwp_ho_53_2 wp_ho_53_2 0 0.5004069986504164
Vwn_ho_53_2 wn_ho_53_2 0 0.4995930013495836
Vwp_ho_54_2 wp_ho_54_2 0 0.520791599618745
Vwn_ho_54_2 wn_ho_54_2 0 0.479208400381255
Vwp_ho_55_2 wp_ho_55_2 0 0.5010620461182027
Vwn_ho_55_2 wn_ho_55_2 0 0.4989379538817973
Vwp_ho_56_2 wp_ho_56_2 0 0.5476634101110467
Vwn_ho_56_2 wn_ho_56_2 0 0.45233658988895326
Vwp_ho_57_2 wp_ho_57_2 0 0.4611252509207532
Vwn_ho_57_2 wn_ho_57_2 0 0.5388747490792468
Vwp_ho_58_2 wp_ho_58_2 0 0.40436190394855753
Vwn_ho_58_2 wn_ho_58_2 0 0.5956380960514425
Vwp_ho_59_2 wp_ho_59_2 0 0.5002574088523136
Vwn_ho_59_2 wn_ho_59_2 0 0.49974259114768643
Vwp_ho_60_2 wp_ho_60_2 0 0.45136178229194535
Vwn_ho_60_2 wn_ho_60_2 0 0.5486382177080547
Vwp_ho_61_2 wp_ho_61_2 0 0.5077365344762546
Vwn_ho_61_2 wn_ho_61_2 0 0.4922634655237455
Vwp_ho_62_2 wp_ho_62_2 0 0.5262226313521021
Vwn_ho_62_2 wn_ho_62_2 0 0.4737773686478978
Vwp_ho_63_2 wp_ho_63_2 0 0.6410263787335175
Vwn_ho_63_2 wn_ho_63_2 0 0.35897362126648247
Vwp_ho_64_2 wp_ho_64_2 0 0.5031876281916409
Vwn_ho_64_2 wn_ho_64_2 0 0.49681237180835913
Vwp_ho_65_2 wp_ho_65_2 0 0.47487913178457636
Vwn_ho_65_2 wn_ho_65_2 0 0.5251208682154237
Vwp_ho_66_2 wp_ho_66_2 0 0.5733889303337992
Vwn_ho_66_2 wn_ho_66_2 0 0.42661106966620077
Vwp_ho_67_2 wp_ho_67_2 0 0.5739732771230872
Vwn_ho_67_2 wn_ho_67_2 0 0.42602672287691284
Vwp_ho_68_2 wp_ho_68_2 0 0.49971455051305846
Vwn_ho_68_2 wn_ho_68_2 0 0.5002854494869415
Vwp_ho_69_2 wp_ho_69_2 0 0.5027558374070213
Vwn_ho_69_2 wn_ho_69_2 0 0.49724416259297866
Vwp_ho_70_2 wp_ho_70_2 0 0.4997912874695303
Vwn_ho_70_2 wn_ho_70_2 0 0.5002087125304697
Vwp_ho_71_2 wp_ho_71_2 0 0.4987135376379833
Vwn_ho_71_2 wn_ho_71_2 0 0.5012864623620167
Vwp_ho_72_2 wp_ho_72_2 0 0.45575373785968093
Vwn_ho_72_2 wn_ho_72_2 0 0.544246262140319
Vwp_ho_73_2 wp_ho_73_2 0 0.5038058672756996
Vwn_ho_73_2 wn_ho_73_2 0 0.4961941327243003
Vwp_ho_74_2 wp_ho_74_2 0 0.4811618833973022
Vwn_ho_74_2 wn_ho_74_2 0 0.5188381166026979
Vwp_ho_75_2 wp_ho_75_2 0 0.5433634335439204
Vwn_ho_75_2 wn_ho_75_2 0 0.4566365664560797
Vwp_ho_76_2 wp_ho_76_2 0 0.5125168939279161
Vwn_ho_76_2 wn_ho_76_2 0 0.48748310607208395
Vwp_ho_77_2 wp_ho_77_2 0 0.6409661644019031
Vwn_ho_77_2 wn_ho_77_2 0 0.3590338355980969
Vwp_ho_78_2 wp_ho_78_2 0 0.56957068929244
Vwn_ho_78_2 wn_ho_78_2 0 0.43042931070755996
Vwp_ho_79_2 wp_ho_79_2 0 0.4937864592265756
Vwn_ho_79_2 wn_ho_79_2 0 0.5062135407734244
Vwp_ho_80_2 wp_ho_80_2 0 0.6395874475030037
Vwn_ho_80_2 wn_ho_80_2 0 0.36041255249699633
Vwp_ho_81_2 wp_ho_81_2 0 0.530021565723738
Vwn_ho_81_2 wn_ho_81_2 0 0.46997843427626196
Vwp_ho_82_2 wp_ho_82_2 0 0.4625851911372183
Vwn_ho_82_2 wn_ho_82_2 0 0.5374148088627817
Vwp_ho_83_2 wp_ho_83_2 0 0.5000084829084394
Vwn_ho_83_2 wn_ho_83_2 0 0.4999915170915606
Vwp_ho_84_2 wp_ho_84_2 0 0.3883071258964561
Vwn_ho_84_2 wn_ho_84_2 0 0.6116928741035439
Vwp_ho_85_2 wp_ho_85_2 0 0.5011251782787451
Vwn_ho_85_2 wn_ho_85_2 0 0.49887482172125486
Vwp_ho_86_2 wp_ho_86_2 0 0.494637099613309
Vwn_ho_86_2 wn_ho_86_2 0 0.5053629003866911
Vwp_ho_87_2 wp_ho_87_2 0 0.4976460272604254
Vwn_ho_87_2 wn_ho_87_2 0 0.5023539727395746
Vwp_ho_88_2 wp_ho_88_2 0 0.45553773346174664
Vwn_ho_88_2 wn_ho_88_2 0 0.5444622665382534
Vwp_ho_89_2 wp_ho_89_2 0 0.47308713396438123
Vwn_ho_89_2 wn_ho_89_2 0 0.5269128660356187
Vwp_ho_90_2 wp_ho_90_2 0 0.5005711445323616
Vwn_ho_90_2 wn_ho_90_2 0 0.4994288554676384
Vwp_ho_91_2 wp_ho_91_2 0 0.4997521122051691
Vwn_ho_91_2 wn_ho_91_2 0 0.5002478877948309
Vwp_ho_92_2 wp_ho_92_2 0 0.6019434133331303
Vwn_ho_92_2 wn_ho_92_2 0 0.3980565866668697
Vwp_ho_93_2 wp_ho_93_2 0 0.5177425549987282
Vwn_ho_93_2 wn_ho_93_2 0 0.4822574450012717
Vwp_ho_94_2 wp_ho_94_2 0 0.4999872644714903
Vwn_ho_94_2 wn_ho_94_2 0 0.5000127355285098
Vwp_ho_95_2 wp_ho_95_2 0 0.4929599622063655
Vwn_ho_95_2 wn_ho_95_2 0 0.5070400377936345
Vwp_ho_96_2 wp_ho_96_2 0 0.49103591614292635
Vwn_ho_96_2 wn_ho_96_2 0 0.5089640838570736
Vwp_ho_97_2 wp_ho_97_2 0 0.5038307765046434
Vwn_ho_97_2 wn_ho_97_2 0 0.49616922349535664
Vwp_ho_98_2 wp_ho_98_2 0 0.6302250549972087
Vwn_ho_98_2 wn_ho_98_2 0 0.3697749450027913
Vwp_ho_99_2 wp_ho_99_2 0 0.47141030819688123
Vwn_ho_99_2 wn_ho_99_2 0 0.5285896918031188
Vwp_ho_100_2 wp_ho_100_2 0 0.4965270049900712
Vwn_ho_100_2 wn_ho_100_2 0 0.5034729950099288
Vwp_ho_101_2 wp_ho_101_2 0 0.5047836967752777
Vwn_ho_101_2 wn_ho_101_2 0 0.49521630322472227
Vwp_ho_102_2 wp_ho_102_2 0 0.474100722332096
Vwn_ho_102_2 wn_ho_102_2 0 0.525899277667904
Vwp_ho_103_2 wp_ho_103_2 0 0.4961863834948338
Vwn_ho_103_2 wn_ho_103_2 0 0.5038136165051662
Vwp_ho_104_2 wp_ho_104_2 0 0.4966552060037969
Vwn_ho_104_2 wn_ho_104_2 0 0.5033447939962031
Vwp_ho_105_2 wp_ho_105_2 0 0.5189742771915464
Vwn_ho_105_2 wn_ho_105_2 0 0.4810257228084536
Vwp_ho_106_2 wp_ho_106_2 0 0.5053782487033475
Vwn_ho_106_2 wn_ho_106_2 0 0.49462175129665253
Vwp_ho_107_2 wp_ho_107_2 0 0.4974000561136307
Vwn_ho_107_2 wn_ho_107_2 0 0.5025999438863693
Vwp_ho_108_2 wp_ho_108_2 0 0.5239378719675458
Vwn_ho_108_2 wn_ho_108_2 0 0.4760621280324542
Vwp_ho_109_2 wp_ho_109_2 0 0.5271021627262581
Vwn_ho_109_2 wn_ho_109_2 0 0.4728978372737419
Vwp_ho_110_2 wp_ho_110_2 0 0.5148253989678301
Vwn_ho_110_2 wn_ho_110_2 0 0.4851746010321699
Vwp_ho_111_2 wp_ho_111_2 0 0.5002331964940679
Vwn_ho_111_2 wn_ho_111_2 0 0.49976680350593206
Vwp_ho_112_2 wp_ho_112_2 0 0.5053222969610983
Vwn_ho_112_2 wn_ho_112_2 0 0.4946777030389017
Vwp_ho_113_2 wp_ho_113_2 0 0.5411585491719513
Vwn_ho_113_2 wn_ho_113_2 0 0.4588414508280488
Vwp_ho_114_2 wp_ho_114_2 0 0.5000019144261746
Vwn_ho_114_2 wn_ho_114_2 0 0.49999808557382547
Vwp_ho_115_2 wp_ho_115_2 0 0.5191575075448627
Vwn_ho_115_2 wn_ho_115_2 0 0.4808424924551373
Vwp_ho_116_2 wp_ho_116_2 0 0.49900023181788605
Vwn_ho_116_2 wn_ho_116_2 0 0.5009997681821139
Vwp_ho_117_2 wp_ho_117_2 0 0.49974155074286924
Vwn_ho_117_2 wn_ho_117_2 0 0.5002584492571307
Vwp_ho_118_2 wp_ho_118_2 0 0.5043662486534084
Vwn_ho_118_2 wn_ho_118_2 0 0.4956337513465916
Vwp_ho_119_2 wp_ho_119_2 0 0.5320505074038367
Vwn_ho_119_2 wn_ho_119_2 0 0.46794949259616325
Vwp_ho_120_2 wp_ho_120_2 0 0.6088369078583512
Vwn_ho_120_2 wn_ho_120_2 0 0.3911630921416488
Vwp_ho_121_2 wp_ho_121_2 0 0.46987849572673984
Vwn_ho_121_2 wn_ho_121_2 0 0.5301215042732602
Vwp_ho_122_2 wp_ho_122_2 0 0.500526164247781
Vwn_ho_122_2 wn_ho_122_2 0 0.49947383575221904
Vwp_ho_123_2 wp_ho_123_2 0 0.4591441693618344
Vwn_ho_123_2 wn_ho_123_2 0 0.5408558306381657
Vwp_ho_124_2 wp_ho_124_2 0 0.5193148485348291
Vwn_ho_124_2 wn_ho_124_2 0 0.4806851514651708
Vwp_ho_125_2 wp_ho_125_2 0 0.5178326589818363
Vwn_ho_125_2 wn_ho_125_2 0 0.4821673410181638
Vwp_ho_126_2 wp_ho_126_2 0 0.4997042973465705
Vwn_ho_126_2 wn_ho_126_2 0 0.5002957026534295
Vwp_ho_127_2 wp_ho_127_2 0 0.47548939513915983
Vwn_ho_127_2 wn_ho_127_2 0 0.5245106048608401
Vwp_ho_128_2 wp_ho_128_2 0 0.5019209064489959
Vwn_ho_128_2 wn_ho_128_2 0 0.49807909355100405
Vwp_ho_129_2 wp_ho_129_2 0 0.5367492220091923
Vwn_ho_129_2 wn_ho_129_2 0 0.4632507779908077
Vwp_ho_130_2 wp_ho_130_2 0 0.3873473380453568
Vwn_ho_130_2 wn_ho_130_2 0 0.6126526619546432
Vwp_ho_131_2 wp_ho_131_2 0 0.5815766484815104
Vwn_ho_131_2 wn_ho_131_2 0 0.4184233515184896
Vwp_ho_132_2 wp_ho_132_2 0 0.41876625652409305
Vwn_ho_132_2 wn_ho_132_2 0 0.581233743475907
Vwp_ho_133_2 wp_ho_133_2 0 0.6162758533050714
Vwn_ho_133_2 wn_ho_133_2 0 0.38372414669492866
Vwp_ho_134_2 wp_ho_134_2 0 0.49999862056469146
Vwn_ho_134_2 wn_ho_134_2 0 0.5000013794353085
Vwp_ho_135_2 wp_ho_135_2 0 0.5017688128716549
Vwn_ho_135_2 wn_ho_135_2 0 0.49823118712834513
Vwp_ho_136_2 wp_ho_136_2 0 0.49120462760577405
Vwn_ho_136_2 wn_ho_136_2 0 0.508795372394226
Vwp_ho_137_2 wp_ho_137_2 0 0.4689158759301989
Vwn_ho_137_2 wn_ho_137_2 0 0.5310841240698011
Vwp_ho_138_2 wp_ho_138_2 0 0.5019086066107962
Vwn_ho_138_2 wn_ho_138_2 0 0.49809139338920383
Vwp_ho_139_2 wp_ho_139_2 0 0.5075631235954701
Vwn_ho_139_2 wn_ho_139_2 0 0.4924368764045299
Vwp_ho_140_2 wp_ho_140_2 0 0.4998497067633949
Vwn_ho_140_2 wn_ho_140_2 0 0.5001502932366051
Vwp_ho_141_2 wp_ho_141_2 0 0.6415275450279866
Vwn_ho_141_2 wn_ho_141_2 0 0.3584724549720134
Vwp_ho_142_2 wp_ho_142_2 0 0.49978383725590825
Vwn_ho_142_2 wn_ho_142_2 0 0.5002161627440918
Vwp_ho_143_2 wp_ho_143_2 0 0.4999333826840986
Vwn_ho_143_2 wn_ho_143_2 0 0.5000666173159014
Vwp_ho_144_2 wp_ho_144_2 0 0.5007280421745246
Vwn_ho_144_2 wn_ho_144_2 0 0.4992719578254754
Vwp_ho_145_2 wp_ho_145_2 0 0.49999957649583954
Vwn_ho_145_2 wn_ho_145_2 0 0.5000004235041605
Vwp_ho_146_2 wp_ho_146_2 0 0.5374274189017247
Vwn_ho_146_2 wn_ho_146_2 0 0.4625725810982752
Vwp_ho_147_2 wp_ho_147_2 0 0.4826793827967303
Vwn_ho_147_2 wn_ho_147_2 0 0.5173206172032697
Vwp_ho_148_2 wp_ho_148_2 0 0.4892613687729643
Vwn_ho_148_2 wn_ho_148_2 0 0.5107386312270358
Vwp_ho_149_2 wp_ho_149_2 0 0.5358425387921583
Vwn_ho_149_2 wn_ho_149_2 0 0.4641574612078417
Vwp_ho_150_2 wp_ho_150_2 0 0.4889565488348077
Vwn_ho_150_2 wn_ho_150_2 0 0.5110434511651922
Vwp_ho_151_2 wp_ho_151_2 0 0.49729012053902616
Vwn_ho_151_2 wn_ho_151_2 0 0.5027098794609738
Vwp_ho_152_2 wp_ho_152_2 0 0.5941076008465335
Vwn_ho_152_2 wn_ho_152_2 0 0.40589239915346653
Vwp_ho_153_2 wp_ho_153_2 0 0.6562209986603748
Vwn_ho_153_2 wn_ho_153_2 0 0.34377900133962525
Vwp_ho_154_2 wp_ho_154_2 0 0.5700785507143061
Vwn_ho_154_2 wn_ho_154_2 0 0.4299214492856938
Vwp_ho_155_2 wp_ho_155_2 0 0.5505830126344354
Vwn_ho_155_2 wn_ho_155_2 0 0.4494169873655646
Vwp_ho_156_2 wp_ho_156_2 0 0.4585073694678799
Vwn_ho_156_2 wn_ho_156_2 0 0.5414926305321202
Vwp_ho_157_2 wp_ho_157_2 0 0.5000121150286869
Vwn_ho_157_2 wn_ho_157_2 0 0.4999878849713131
Vwp_ho_158_2 wp_ho_158_2 0 0.4995820159713206
Vwn_ho_158_2 wn_ho_158_2 0 0.5004179840286794
Vwp_ho_159_2 wp_ho_159_2 0 0.44167150651278586
Vwn_ho_159_2 wn_ho_159_2 0 0.5583284934872141
Vwp_ho_160_2 wp_ho_160_2 0 0.5505909887683617
Vwn_ho_160_2 wn_ho_160_2 0 0.4494090112316383
Vwp_ho_161_2 wp_ho_161_2 0 0.4977822494832232
Vwn_ho_161_2 wn_ho_161_2 0 0.5022177505167768
Vwp_ho_162_2 wp_ho_162_2 0 0.5010737320199957
Vwn_ho_162_2 wn_ho_162_2 0 0.4989262679800042
Vwp_ho_163_2 wp_ho_163_2 0 0.5008378272227438
Vwn_ho_163_2 wn_ho_163_2 0 0.4991621727772561
Vwp_ho_164_2 wp_ho_164_2 0 0.5177997694822088
Vwn_ho_164_2 wn_ho_164_2 0 0.4822002305177912
Vwp_ho_165_2 wp_ho_165_2 0 0.4771098609107925
Vwn_ho_165_2 wn_ho_165_2 0 0.5228901390892076
Vwp_ho_166_2 wp_ho_166_2 0 0.4472705026360778
Vwn_ho_166_2 wn_ho_166_2 0 0.5527294973639222
Vwp_ho_167_2 wp_ho_167_2 0 0.5000022575429879
Vwn_ho_167_2 wn_ho_167_2 0 0.49999774245701206
Vwp_ho_168_2 wp_ho_168_2 0 0.5476120730971517
Vwn_ho_168_2 wn_ho_168_2 0 0.4523879269028483
Vwp_ho_169_2 wp_ho_169_2 0 0.5970031434817664
Vwn_ho_169_2 wn_ho_169_2 0 0.4029968565182336
Vwp_ho_170_2 wp_ho_170_2 0 0.5121117924233141
Vwn_ho_170_2 wn_ho_170_2 0 0.4878882075766859
Vwp_ho_171_2 wp_ho_171_2 0 0.5000016323281348
Vwn_ho_171_2 wn_ho_171_2 0 0.49999836767186523
Vwp_ho_172_2 wp_ho_172_2 0 0.5495915608016728
Vwn_ho_172_2 wn_ho_172_2 0 0.4504084391983272
Vwp_ho_173_2 wp_ho_173_2 0 0.6199371579916968
Vwn_ho_173_2 wn_ho_173_2 0 0.3800628420083032
Vwp_ho_174_2 wp_ho_174_2 0 0.5367783196946774
Vwn_ho_174_2 wn_ho_174_2 0 0.4632216803053226
Vwp_ho_175_2 wp_ho_175_2 0 0.42860494810027344
Vwn_ho_175_2 wn_ho_175_2 0 0.5713950518997266
Vwp_ho_176_2 wp_ho_176_2 0 0.5071063076265372
Vwn_ho_176_2 wn_ho_176_2 0 0.4928936923734628
Vwp_ho_177_2 wp_ho_177_2 0 0.4980350392675474
Vwn_ho_177_2 wn_ho_177_2 0 0.5019649607324526
Vwp_ho_178_2 wp_ho_178_2 0 0.5008501581519921
Vwn_ho_178_2 wn_ho_178_2 0 0.49914984184800787
Vwp_ho_179_2 wp_ho_179_2 0 0.4981502338817126
Vwn_ho_179_2 wn_ho_179_2 0 0.5018497661182874
Vwp_ho_180_2 wp_ho_180_2 0 0.49876298344308834
Vwn_ho_180_2 wn_ho_180_2 0 0.5012370165569117
Vwp_ho_181_2 wp_ho_181_2 0 0.6013225628617169
Vwn_ho_181_2 wn_ho_181_2 0 0.3986774371382831
Vwp_ho_182_2 wp_ho_182_2 0 0.4988822717538533
Vwn_ho_182_2 wn_ho_182_2 0 0.5011177282461468
Vwp_ho_183_2 wp_ho_183_2 0 0.5537739175926735
Vwn_ho_183_2 wn_ho_183_2 0 0.4462260824073266
Vwp_ho_184_2 wp_ho_184_2 0 0.502550079289345
Vwn_ho_184_2 wn_ho_184_2 0 0.4974499207106549
Vwp_ho_185_2 wp_ho_185_2 0 0.5029914938114891
Vwn_ho_185_2 wn_ho_185_2 0 0.4970085061885109
Vwp_ho_186_2 wp_ho_186_2 0 0.6102062265885099
Vwn_ho_186_2 wn_ho_186_2 0 0.38979377341149013
Vwp_ho_187_2 wp_ho_187_2 0 0.4997861579438085
Vwn_ho_187_2 wn_ho_187_2 0 0.5002138420561915
Vwp_ho_188_2 wp_ho_188_2 0 0.39565961194754146
Vwn_ho_188_2 wn_ho_188_2 0 0.6043403880524586
Vwp_ho_189_2 wp_ho_189_2 0 0.5004860255737916
Vwn_ho_189_2 wn_ho_189_2 0 0.4995139744262084
Vwp_ho_190_2 wp_ho_190_2 0 0.4696280617795054
Vwn_ho_190_2 wn_ho_190_2 0 0.5303719382204946
Vwp_ho_191_2 wp_ho_191_2 0 0.5280262722038254
Vwn_ho_191_2 wn_ho_191_2 0 0.4719737277961747
Vwp_ho_192_2 wp_ho_192_2 0 0.4994801663064728
Vwn_ho_192_2 wn_ho_192_2 0 0.5005198336935271
Vwp_ho_193_2 wp_ho_193_2 0 0.4495013182009126
Vwn_ho_193_2 wn_ho_193_2 0 0.5504986817990873
Vwp_ho_194_2 wp_ho_194_2 0 0.4924325251141396
Vwn_ho_194_2 wn_ho_194_2 0 0.5075674748858604
Vwp_ho_195_2 wp_ho_195_2 0 0.5003843848967043
Vwn_ho_195_2 wn_ho_195_2 0 0.4996156151032957
Vwp_ho_196_2 wp_ho_196_2 0 0.49919511524331245
Vwn_ho_196_2 wn_ho_196_2 0 0.5008048847566876
Vwp_ho_197_2 wp_ho_197_2 0 0.46659472605807367
Vwn_ho_197_2 wn_ho_197_2 0 0.5334052739419263
Vwp_ho_198_2 wp_ho_198_2 0 0.5000188586885712
Vwn_ho_198_2 wn_ho_198_2 0 0.49998114131142884
Vwp_ho_199_2 wp_ho_199_2 0 0.47428845699943245
Vwn_ho_199_2 wn_ho_199_2 0 0.5257115430005675
Vwp_ho_200_2 wp_ho_200_2 0 0.4522538027319293
Vwn_ho_200_2 wn_ho_200_2 0 0.5477461972680707
Vwp_ho_201_2 wp_ho_201_2 0 0.4765869569915531
Vwn_ho_201_2 wn_ho_201_2 0 0.5234130430084469
Vwp_ho_202_2 wp_ho_202_2 0 0.4600067349774916
Vwn_ho_202_2 wn_ho_202_2 0 0.5399932650225083
Vwp_ho_203_2 wp_ho_203_2 0 0.5162109413611459
Vwn_ho_203_2 wn_ho_203_2 0 0.48378905863885413
Vwp_ho_204_2 wp_ho_204_2 0 0.40432335794746566
Vwn_ho_204_2 wn_ho_204_2 0 0.5956766420525343
Vwp_ho_205_2 wp_ho_205_2 0 0.499119449213256
Vwn_ho_205_2 wn_ho_205_2 0 0.500880550786744
Vwp_ho_206_2 wp_ho_206_2 0 0.6327037297836723
Vwn_ho_206_2 wn_ho_206_2 0 0.3672962702163277
Vwp_ho_207_2 wp_ho_207_2 0 0.3168189778758045
Vwn_ho_207_2 wn_ho_207_2 0 0.6831810221241955
Vwp_ho_208_2 wp_ho_208_2 0 0.49525925271153737
Vwn_ho_208_2 wn_ho_208_2 0 0.5047407472884626
Vwp_ho_209_2 wp_ho_209_2 0 0.5682755712326293
Vwn_ho_209_2 wn_ho_209_2 0 0.4317244287673707
Vwp_ho_210_2 wp_ho_210_2 0 0.38922051550345316
Vwn_ho_210_2 wn_ho_210_2 0 0.6107794844965468
Vwp_ho_211_2 wp_ho_211_2 0 0.5000608633599612
Vwn_ho_211_2 wn_ho_211_2 0 0.49993913664003875
Vwp_ho_212_2 wp_ho_212_2 0 0.5053771796368237
Vwn_ho_212_2 wn_ho_212_2 0 0.49462282036317623
Vwp_ho_213_2 wp_ho_213_2 0 0.5316040031102315
Vwn_ho_213_2 wn_ho_213_2 0 0.4683959968897685
Vwp_ho_214_2 wp_ho_214_2 0 0.40230695171862585
Vwn_ho_214_2 wn_ho_214_2 0 0.5976930482813742
Vwp_ho_215_2 wp_ho_215_2 0 0.5209610431479609
Vwn_ho_215_2 wn_ho_215_2 0 0.4790389568520392
Vwp_ho_216_2 wp_ho_216_2 0 0.5128759868230338
Vwn_ho_216_2 wn_ho_216_2 0 0.48712401317696613
Vwp_ho_217_2 wp_ho_217_2 0 0.5023892444890073
Vwn_ho_217_2 wn_ho_217_2 0 0.49761075551099265
Vwp_ho_218_2 wp_ho_218_2 0 0.4392973584630051
Vwn_ho_218_2 wn_ho_218_2 0 0.5607026415369949
Vwp_ho_219_2 wp_ho_219_2 0 0.4237419066994472
Vwn_ho_219_2 wn_ho_219_2 0 0.5762580933005528
Vwp_ho_220_2 wp_ho_220_2 0 0.4940591729004245
Vwn_ho_220_2 wn_ho_220_2 0 0.5059408270995756
Vwp_ho_221_2 wp_ho_221_2 0 0.37956542796949455
Vwn_ho_221_2 wn_ho_221_2 0 0.6204345720305054
Vwp_ho_222_2 wp_ho_222_2 0 0.500543488050999
Vwn_ho_222_2 wn_ho_222_2 0 0.499456511949001
Vwp_ho_223_2 wp_ho_223_2 0 0.47423460020390845
Vwn_ho_223_2 wn_ho_223_2 0 0.5257653997960916
Vwp_ho_224_2 wp_ho_224_2 0 0.49968985878643496
Vwn_ho_224_2 wn_ho_224_2 0 0.5003101412135651
Vwp_ho_225_2 wp_ho_225_2 0 0.5013418483076975
Vwn_ho_225_2 wn_ho_225_2 0 0.4986581516923025
Vwp_ho_226_2 wp_ho_226_2 0 0.4969502161936636
Vwn_ho_226_2 wn_ho_226_2 0 0.5030497838063364
Vwp_ho_227_2 wp_ho_227_2 0 0.5222999963770301
Vwn_ho_227_2 wn_ho_227_2 0 0.47770000362296994
Vwp_ho_228_2 wp_ho_228_2 0 0.5033649899598127
Vwn_ho_228_2 wn_ho_228_2 0 0.49663501004018723
Vwp_ho_229_2 wp_ho_229_2 0 0.4999997428836459
Vwn_ho_229_2 wn_ho_229_2 0 0.5000002571163541
Vwp_ho_230_2 wp_ho_230_2 0 0.5433793843339481
Vwn_ho_230_2 wn_ho_230_2 0 0.45662061566605194
Vwp_ho_231_2 wp_ho_231_2 0 0.3891730679551874
Vwn_ho_231_2 wn_ho_231_2 0 0.6108269320448125
Vwp_ho_232_2 wp_ho_232_2 0 0.44575594826970405
Vwn_ho_232_2 wn_ho_232_2 0 0.554244051730296
Vwp_ho_233_2 wp_ho_233_2 0 0.389005205099192
Vwn_ho_233_2 wn_ho_233_2 0 0.610994794900808
Vwp_ho_234_2 wp_ho_234_2 0 0.49304125232506735
Vwn_ho_234_2 wn_ho_234_2 0 0.5069587476749327
Vwp_ho_235_2 wp_ho_235_2 0 0.5719230983763501
Vwn_ho_235_2 wn_ho_235_2 0 0.42807690162364986
Vwp_ho_236_2 wp_ho_236_2 0 0.5000971750301723
Vwn_ho_236_2 wn_ho_236_2 0 0.4999028249698278
Vwp_ho_237_2 wp_ho_237_2 0 0.5091677316280344
Vwn_ho_237_2 wn_ho_237_2 0 0.4908322683719656
Vwp_ho_238_2 wp_ho_238_2 0 0.561812538237816
Vwn_ho_238_2 wn_ho_238_2 0 0.43818746176218404
Vwp_ho_239_2 wp_ho_239_2 0 0.43375535265152443
Vwn_ho_239_2 wn_ho_239_2 0 0.5662446473484756
Vwp_ho_240_2 wp_ho_240_2 0 0.5033381677346271
Vwn_ho_240_2 wn_ho_240_2 0 0.4966618322653729
Vwp_ho_241_2 wp_ho_241_2 0 0.609995489848882
Vwn_ho_241_2 wn_ho_241_2 0 0.39000451015111803
Vwp_ho_242_2 wp_ho_242_2 0 0.502093361444207
Vwn_ho_242_2 wn_ho_242_2 0 0.497906638555793
Vwp_ho_243_2 wp_ho_243_2 0 0.4082102534367191
Vwn_ho_243_2 wn_ho_243_2 0 0.591789746563281
Vwp_ho_244_2 wp_ho_244_2 0 0.4697719286980342
Vwn_ho_244_2 wn_ho_244_2 0 0.5302280713019658
Vwp_ho_245_2 wp_ho_245_2 0 0.48207993999688725
Vwn_ho_245_2 wn_ho_245_2 0 0.5179200600031127
Vwp_ho_246_2 wp_ho_246_2 0 0.4985397957619781
Vwn_ho_246_2 wn_ho_246_2 0 0.501460204238022
Vwp_ho_247_2 wp_ho_247_2 0 0.4999970963889334
Vwn_ho_247_2 wn_ho_247_2 0 0.5000029036110666
Vwp_ho_248_2 wp_ho_248_2 0 0.3902232196924404
Vwn_ho_248_2 wn_ho_248_2 0 0.6097767803075597
Vwp_ho_249_2 wp_ho_249_2 0 0.5031428130611844
Vwn_ho_249_2 wn_ho_249_2 0 0.4968571869388157
Vwp_ho_250_2 wp_ho_250_2 0 0.5131815323085276
Vwn_ho_250_2 wn_ho_250_2 0 0.48681846769147236
Vwp_ho_251_2 wp_ho_251_2 0 0.5002405892325315
Vwn_ho_251_2 wn_ho_251_2 0 0.4997594107674685
Vwp_ho_252_2 wp_ho_252_2 0 0.46969493278409097
Vwn_ho_252_2 wn_ho_252_2 0 0.530305067215909
Vwp_ho_253_2 wp_ho_253_2 0 0.5502589788350402
Vwn_ho_253_2 wn_ho_253_2 0 0.4497410211649598
Vwp_ho_254_2 wp_ho_254_2 0 0.5000127364381542
Vwn_ho_254_2 wn_ho_254_2 0 0.4999872635618457
Vwp_ho_255_2 wp_ho_255_2 0 0.5011360338311032
Vwn_ho_255_2 wn_ho_255_2 0 0.49886396616889683
Vwp_ho_256_2 wp_ho_256_2 0 0.4978513397445501
Vwn_ho_256_2 wn_ho_256_2 0 0.5021486602554499
Vwp_ho_257_2 wp_ho_257_2 0 0.5624390390736974
Vwn_ho_257_2 wn_ho_257_2 0 0.43756096092630264
Vwp_ho_258_2 wp_ho_258_2 0 0.5000102167993344
Vwn_ho_258_2 wn_ho_258_2 0 0.49998978320066556
Vwp_ho_259_2 wp_ho_259_2 0 0.5012753136190331
Vwn_ho_259_2 wn_ho_259_2 0 0.49872468638096695
Vwp_ho_260_2 wp_ho_260_2 0 0.5466004924474968
Vwn_ho_260_2 wn_ho_260_2 0 0.45339950755250324
Vwp_ho_261_2 wp_ho_261_2 0 0.5005383222554499
Vwn_ho_261_2 wn_ho_261_2 0 0.4994616777445501
Vwp_ho_262_2 wp_ho_262_2 0 0.4999994830744346
Vwn_ho_262_2 wn_ho_262_2 0 0.5000005169255655
Vwp_ho_263_2 wp_ho_263_2 0 0.5805659426764068
Vwn_ho_263_2 wn_ho_263_2 0 0.4194340573235931
Vwp_ho_264_2 wp_ho_264_2 0 0.38364896035907736
Vwn_ho_264_2 wn_ho_264_2 0 0.6163510396409226
Vwp_ho_265_2 wp_ho_265_2 0 0.5121766187717305
Vwn_ho_265_2 wn_ho_265_2 0 0.4878233812282695
Vwp_ho_266_2 wp_ho_266_2 0 0.5034179707375995
Vwn_ho_266_2 wn_ho_266_2 0 0.49658202926240047
Vwp_ho_267_2 wp_ho_267_2 0 0.5908971035883724
Vwn_ho_267_2 wn_ho_267_2 0 0.40910289641162756
Vwp_ho_268_2 wp_ho_268_2 0 0.31739804820073503
Vwn_ho_268_2 wn_ho_268_2 0 0.682601951799265
Vwp_ho_269_2 wp_ho_269_2 0 0.5000651118152014
Vwn_ho_269_2 wn_ho_269_2 0 0.4999348881847986
Vwp_ho_270_2 wp_ho_270_2 0 0.5010352993836885
Vwn_ho_270_2 wn_ho_270_2 0 0.4989647006163115
Vwp_ho_271_2 wp_ho_271_2 0 0.5366113320415058
Vwn_ho_271_2 wn_ho_271_2 0 0.46338866795849415
Vwp_ho_272_2 wp_ho_272_2 0 0.4659046581457835
Vwn_ho_272_2 wn_ho_272_2 0 0.5340953418542165
Vwp_ho_273_2 wp_ho_273_2 0 0.5649390436939865
Vwn_ho_273_2 wn_ho_273_2 0 0.4350609563060135
Vwp_ho_274_2 wp_ho_274_2 0 0.5000040135722095
Vwn_ho_274_2 wn_ho_274_2 0 0.4999959864277906
Vwp_ho_275_2 wp_ho_275_2 0 0.5000036538038536
Vwn_ho_275_2 wn_ho_275_2 0 0.49999634619614647
Vwp_ho_276_2 wp_ho_276_2 0 0.5037990915714835
Vwn_ho_276_2 wn_ho_276_2 0 0.4962009084285165
Vwp_ho_277_2 wp_ho_277_2 0 0.49890737696479215
Vwn_ho_277_2 wn_ho_277_2 0 0.5010926230352079
Vwp_ho_278_2 wp_ho_278_2 0 0.5891051010060997
Vwn_ho_278_2 wn_ho_278_2 0 0.41089489899390025
Vwp_ho_279_2 wp_ho_279_2 0 0.4995649718745062
Vwn_ho_279_2 wn_ho_279_2 0 0.5004350281254938
Vwp_ho_280_2 wp_ho_280_2 0 0.6125251187548091
Vwn_ho_280_2 wn_ho_280_2 0 0.3874748812451909
Vwp_ho_281_2 wp_ho_281_2 0 0.5443375880719536
Vwn_ho_281_2 wn_ho_281_2 0 0.45566241192804635
Vwp_ho_282_2 wp_ho_282_2 0 0.5395392276510917
Vwn_ho_282_2 wn_ho_282_2 0 0.4604607723489083
Vwp_ho_283_2 wp_ho_283_2 0 0.500066202109511
Vwn_ho_283_2 wn_ho_283_2 0 0.499933797890489
Vwp_ho_284_2 wp_ho_284_2 0 0.5023147390995211
Vwn_ho_284_2 wn_ho_284_2 0 0.4976852609004789
Vwp_ho_285_2 wp_ho_285_2 0 0.4882437415924823
Vwn_ho_285_2 wn_ho_285_2 0 0.5117562584075177
Vwp_ho_286_2 wp_ho_286_2 0 0.5013035956351867
Vwn_ho_286_2 wn_ho_286_2 0 0.49869640436481333
Vwp_ho_287_2 wp_ho_287_2 0 0.5005123694693199
Vwn_ho_287_2 wn_ho_287_2 0 0.4994876305306801
Xcm_xh0 xhp0 xhn0 vdd cmld
Rnd_xh0 xhp0 xhn0 20k
Cxh0p xhp0 0 1e-13
Cxh0n xhn0 0 1e-13
Xihx_0_0 a_xp0 a_xn0 wp_ih_0_0 wn_ih_0_0 xhp0 xhn0 vdd vbsyn gsyn
Xihx_1_0 a_xp1 a_xn1 wp_ih_1_0 wn_ih_1_0 xhp0 xhn0 vdd vbsyn gsyn
Xihx_2_0 a_xp2 a_xn2 wp_ih_2_0 wn_ih_2_0 xhp0 xhn0 vdd vbsyn gsyn
Xn0 xhp0 xhn0 ahp0 ahn0 vdd vbneu dneuron
Xcm_xh1 xhp1 xhn1 vdd cmld
Rnd_xh1 xhp1 xhn1 20k
Cxh1p xhp1 0 1e-13
Cxh1n xhn1 0 1e-13
Xihx_0_1 a_xp0 a_xn0 wp_ih_0_1 wn_ih_0_1 xhp1 xhn1 vdd vbsyn gsyn
Xihx_1_1 a_xp1 a_xn1 wp_ih_1_1 wn_ih_1_1 xhp1 xhn1 vdd vbsyn gsyn
Xihx_2_1 a_xp2 a_xn2 wp_ih_2_1 wn_ih_2_1 xhp1 xhn1 vdd vbsyn gsyn
Xn1 xhp1 xhn1 ahp1 ahn1 vdd vbneu dneuron
Xcm_xh2 xhp2 xhn2 vdd cmld
Rnd_xh2 xhp2 xhn2 20k
Cxh2p xhp2 0 1e-13
Cxh2n xhn2 0 1e-13
Xihx_0_2 a_xp0 a_xn0 wp_ih_0_2 wn_ih_0_2 xhp2 xhn2 vdd vbsyn gsyn
Xihx_1_2 a_xp1 a_xn1 wp_ih_1_2 wn_ih_1_2 xhp2 xhn2 vdd vbsyn gsyn
Xihx_2_2 a_xp2 a_xn2 wp_ih_2_2 wn_ih_2_2 xhp2 xhn2 vdd vbsyn gsyn
Xn2 xhp2 xhn2 ahp2 ahn2 vdd vbneu dneuron
Xcm_xh3 xhp3 xhn3 vdd cmld
Rnd_xh3 xhp3 xhn3 20k
Cxh3p xhp3 0 1e-13
Cxh3n xhn3 0 1e-13
Xihx_0_3 a_xp0 a_xn0 wp_ih_0_3 wn_ih_0_3 xhp3 xhn3 vdd vbsyn gsyn
Xihx_1_3 a_xp1 a_xn1 wp_ih_1_3 wn_ih_1_3 xhp3 xhn3 vdd vbsyn gsyn
Xihx_2_3 a_xp2 a_xn2 wp_ih_2_3 wn_ih_2_3 xhp3 xhn3 vdd vbsyn gsyn
Xn3 xhp3 xhn3 ahp3 ahn3 vdd vbneu dneuron
Xcm_xh4 xhp4 xhn4 vdd cmld
Rnd_xh4 xhp4 xhn4 20k
Cxh4p xhp4 0 1e-13
Cxh4n xhn4 0 1e-13
Xihx_0_4 a_xp0 a_xn0 wp_ih_0_4 wn_ih_0_4 xhp4 xhn4 vdd vbsyn gsyn
Xihx_1_4 a_xp1 a_xn1 wp_ih_1_4 wn_ih_1_4 xhp4 xhn4 vdd vbsyn gsyn
Xihx_2_4 a_xp2 a_xn2 wp_ih_2_4 wn_ih_2_4 xhp4 xhn4 vdd vbsyn gsyn
Xn4 xhp4 xhn4 ahp4 ahn4 vdd vbneu dneuron
Xcm_xh5 xhp5 xhn5 vdd cmld
Rnd_xh5 xhp5 xhn5 20k
Cxh5p xhp5 0 1e-13
Cxh5n xhn5 0 1e-13
Xihx_0_5 a_xp0 a_xn0 wp_ih_0_5 wn_ih_0_5 xhp5 xhn5 vdd vbsyn gsyn
Xihx_1_5 a_xp1 a_xn1 wp_ih_1_5 wn_ih_1_5 xhp5 xhn5 vdd vbsyn gsyn
Xihx_2_5 a_xp2 a_xn2 wp_ih_2_5 wn_ih_2_5 xhp5 xhn5 vdd vbsyn gsyn
Xn5 xhp5 xhn5 ahp5 ahn5 vdd vbneu dneuron
Xcm_xh6 xhp6 xhn6 vdd cmld
Rnd_xh6 xhp6 xhn6 20k
Cxh6p xhp6 0 1e-13
Cxh6n xhn6 0 1e-13
Xihx_0_6 a_xp0 a_xn0 wp_ih_0_6 wn_ih_0_6 xhp6 xhn6 vdd vbsyn gsyn
Xihx_1_6 a_xp1 a_xn1 wp_ih_1_6 wn_ih_1_6 xhp6 xhn6 vdd vbsyn gsyn
Xihx_2_6 a_xp2 a_xn2 wp_ih_2_6 wn_ih_2_6 xhp6 xhn6 vdd vbsyn gsyn
Xn6 xhp6 xhn6 ahp6 ahn6 vdd vbneu dneuron
Xcm_xh7 xhp7 xhn7 vdd cmld
Rnd_xh7 xhp7 xhn7 20k
Cxh7p xhp7 0 1e-13
Cxh7n xhn7 0 1e-13
Xihx_0_7 a_xp0 a_xn0 wp_ih_0_7 wn_ih_0_7 xhp7 xhn7 vdd vbsyn gsyn
Xihx_1_7 a_xp1 a_xn1 wp_ih_1_7 wn_ih_1_7 xhp7 xhn7 vdd vbsyn gsyn
Xihx_2_7 a_xp2 a_xn2 wp_ih_2_7 wn_ih_2_7 xhp7 xhn7 vdd vbsyn gsyn
Xn7 xhp7 xhn7 ahp7 ahn7 vdd vbneu dneuron
Xcm_xh8 xhp8 xhn8 vdd cmld
Rnd_xh8 xhp8 xhn8 20k
Cxh8p xhp8 0 1e-13
Cxh8n xhn8 0 1e-13
Xihx_0_8 a_xp0 a_xn0 wp_ih_0_8 wn_ih_0_8 xhp8 xhn8 vdd vbsyn gsyn
Xihx_1_8 a_xp1 a_xn1 wp_ih_1_8 wn_ih_1_8 xhp8 xhn8 vdd vbsyn gsyn
Xihx_2_8 a_xp2 a_xn2 wp_ih_2_8 wn_ih_2_8 xhp8 xhn8 vdd vbsyn gsyn
Xn8 xhp8 xhn8 ahp8 ahn8 vdd vbneu dneuron
Xcm_xh9 xhp9 xhn9 vdd cmld
Rnd_xh9 xhp9 xhn9 20k
Cxh9p xhp9 0 1e-13
Cxh9n xhn9 0 1e-13
Xihx_0_9 a_xp0 a_xn0 wp_ih_0_9 wn_ih_0_9 xhp9 xhn9 vdd vbsyn gsyn
Xihx_1_9 a_xp1 a_xn1 wp_ih_1_9 wn_ih_1_9 xhp9 xhn9 vdd vbsyn gsyn
Xihx_2_9 a_xp2 a_xn2 wp_ih_2_9 wn_ih_2_9 xhp9 xhn9 vdd vbsyn gsyn
Xn9 xhp9 xhn9 ahp9 ahn9 vdd vbneu dneuron
Xcm_xh10 xhp10 xhn10 vdd cmld
Rnd_xh10 xhp10 xhn10 20k
Cxh10p xhp10 0 1e-13
Cxh10n xhn10 0 1e-13
Xihx_0_10 a_xp0 a_xn0 wp_ih_0_10 wn_ih_0_10 xhp10 xhn10 vdd vbsyn gsyn
Xihx_1_10 a_xp1 a_xn1 wp_ih_1_10 wn_ih_1_10 xhp10 xhn10 vdd vbsyn gsyn
Xihx_2_10 a_xp2 a_xn2 wp_ih_2_10 wn_ih_2_10 xhp10 xhn10 vdd vbsyn gsyn
Xn10 xhp10 xhn10 ahp10 ahn10 vdd vbneu dneuron
Xcm_xh11 xhp11 xhn11 vdd cmld
Rnd_xh11 xhp11 xhn11 20k
Cxh11p xhp11 0 1e-13
Cxh11n xhn11 0 1e-13
Xihx_0_11 a_xp0 a_xn0 wp_ih_0_11 wn_ih_0_11 xhp11 xhn11 vdd vbsyn gsyn
Xihx_1_11 a_xp1 a_xn1 wp_ih_1_11 wn_ih_1_11 xhp11 xhn11 vdd vbsyn gsyn
Xihx_2_11 a_xp2 a_xn2 wp_ih_2_11 wn_ih_2_11 xhp11 xhn11 vdd vbsyn gsyn
Xn11 xhp11 xhn11 ahp11 ahn11 vdd vbneu dneuron
Xcm_xh12 xhp12 xhn12 vdd cmld
Rnd_xh12 xhp12 xhn12 20k
Cxh12p xhp12 0 1e-13
Cxh12n xhn12 0 1e-13
Xihx_0_12 a_xp0 a_xn0 wp_ih_0_12 wn_ih_0_12 xhp12 xhn12 vdd vbsyn gsyn
Xihx_1_12 a_xp1 a_xn1 wp_ih_1_12 wn_ih_1_12 xhp12 xhn12 vdd vbsyn gsyn
Xihx_2_12 a_xp2 a_xn2 wp_ih_2_12 wn_ih_2_12 xhp12 xhn12 vdd vbsyn gsyn
Xn12 xhp12 xhn12 ahp12 ahn12 vdd vbneu dneuron
Xcm_xh13 xhp13 xhn13 vdd cmld
Rnd_xh13 xhp13 xhn13 20k
Cxh13p xhp13 0 1e-13
Cxh13n xhn13 0 1e-13
Xihx_0_13 a_xp0 a_xn0 wp_ih_0_13 wn_ih_0_13 xhp13 xhn13 vdd vbsyn gsyn
Xihx_1_13 a_xp1 a_xn1 wp_ih_1_13 wn_ih_1_13 xhp13 xhn13 vdd vbsyn gsyn
Xihx_2_13 a_xp2 a_xn2 wp_ih_2_13 wn_ih_2_13 xhp13 xhn13 vdd vbsyn gsyn
Xn13 xhp13 xhn13 ahp13 ahn13 vdd vbneu dneuron
Xcm_xh14 xhp14 xhn14 vdd cmld
Rnd_xh14 xhp14 xhn14 20k
Cxh14p xhp14 0 1e-13
Cxh14n xhn14 0 1e-13
Xihx_0_14 a_xp0 a_xn0 wp_ih_0_14 wn_ih_0_14 xhp14 xhn14 vdd vbsyn gsyn
Xihx_1_14 a_xp1 a_xn1 wp_ih_1_14 wn_ih_1_14 xhp14 xhn14 vdd vbsyn gsyn
Xihx_2_14 a_xp2 a_xn2 wp_ih_2_14 wn_ih_2_14 xhp14 xhn14 vdd vbsyn gsyn
Xn14 xhp14 xhn14 ahp14 ahn14 vdd vbneu dneuron
Xcm_xh15 xhp15 xhn15 vdd cmld
Rnd_xh15 xhp15 xhn15 20k
Cxh15p xhp15 0 1e-13
Cxh15n xhn15 0 1e-13
Xihx_0_15 a_xp0 a_xn0 wp_ih_0_15 wn_ih_0_15 xhp15 xhn15 vdd vbsyn gsyn
Xihx_1_15 a_xp1 a_xn1 wp_ih_1_15 wn_ih_1_15 xhp15 xhn15 vdd vbsyn gsyn
Xihx_2_15 a_xp2 a_xn2 wp_ih_2_15 wn_ih_2_15 xhp15 xhn15 vdd vbsyn gsyn
Xn15 xhp15 xhn15 ahp15 ahn15 vdd vbneu dneuron
Xcm_xh16 xhp16 xhn16 vdd cmld
Rnd_xh16 xhp16 xhn16 20k
Cxh16p xhp16 0 1e-13
Cxh16n xhn16 0 1e-13
Xihx_0_16 a_xp0 a_xn0 wp_ih_0_16 wn_ih_0_16 xhp16 xhn16 vdd vbsyn gsyn
Xihx_1_16 a_xp1 a_xn1 wp_ih_1_16 wn_ih_1_16 xhp16 xhn16 vdd vbsyn gsyn
Xihx_2_16 a_xp2 a_xn2 wp_ih_2_16 wn_ih_2_16 xhp16 xhn16 vdd vbsyn gsyn
Xn16 xhp16 xhn16 ahp16 ahn16 vdd vbneu dneuron
Xcm_xh17 xhp17 xhn17 vdd cmld
Rnd_xh17 xhp17 xhn17 20k
Cxh17p xhp17 0 1e-13
Cxh17n xhn17 0 1e-13
Xihx_0_17 a_xp0 a_xn0 wp_ih_0_17 wn_ih_0_17 xhp17 xhn17 vdd vbsyn gsyn
Xihx_1_17 a_xp1 a_xn1 wp_ih_1_17 wn_ih_1_17 xhp17 xhn17 vdd vbsyn gsyn
Xihx_2_17 a_xp2 a_xn2 wp_ih_2_17 wn_ih_2_17 xhp17 xhn17 vdd vbsyn gsyn
Xn17 xhp17 xhn17 ahp17 ahn17 vdd vbneu dneuron
Xcm_xh18 xhp18 xhn18 vdd cmld
Rnd_xh18 xhp18 xhn18 20k
Cxh18p xhp18 0 1e-13
Cxh18n xhn18 0 1e-13
Xihx_0_18 a_xp0 a_xn0 wp_ih_0_18 wn_ih_0_18 xhp18 xhn18 vdd vbsyn gsyn
Xihx_1_18 a_xp1 a_xn1 wp_ih_1_18 wn_ih_1_18 xhp18 xhn18 vdd vbsyn gsyn
Xihx_2_18 a_xp2 a_xn2 wp_ih_2_18 wn_ih_2_18 xhp18 xhn18 vdd vbsyn gsyn
Xn18 xhp18 xhn18 ahp18 ahn18 vdd vbneu dneuron
Xcm_xh19 xhp19 xhn19 vdd cmld
Rnd_xh19 xhp19 xhn19 20k
Cxh19p xhp19 0 1e-13
Cxh19n xhn19 0 1e-13
Xihx_0_19 a_xp0 a_xn0 wp_ih_0_19 wn_ih_0_19 xhp19 xhn19 vdd vbsyn gsyn
Xihx_1_19 a_xp1 a_xn1 wp_ih_1_19 wn_ih_1_19 xhp19 xhn19 vdd vbsyn gsyn
Xihx_2_19 a_xp2 a_xn2 wp_ih_2_19 wn_ih_2_19 xhp19 xhn19 vdd vbsyn gsyn
Xn19 xhp19 xhn19 ahp19 ahn19 vdd vbneu dneuron
Xcm_xh20 xhp20 xhn20 vdd cmld
Rnd_xh20 xhp20 xhn20 20k
Cxh20p xhp20 0 1e-13
Cxh20n xhn20 0 1e-13
Xihx_0_20 a_xp0 a_xn0 wp_ih_0_20 wn_ih_0_20 xhp20 xhn20 vdd vbsyn gsyn
Xihx_1_20 a_xp1 a_xn1 wp_ih_1_20 wn_ih_1_20 xhp20 xhn20 vdd vbsyn gsyn
Xihx_2_20 a_xp2 a_xn2 wp_ih_2_20 wn_ih_2_20 xhp20 xhn20 vdd vbsyn gsyn
Xn20 xhp20 xhn20 ahp20 ahn20 vdd vbneu dneuron
Xcm_xh21 xhp21 xhn21 vdd cmld
Rnd_xh21 xhp21 xhn21 20k
Cxh21p xhp21 0 1e-13
Cxh21n xhn21 0 1e-13
Xihx_0_21 a_xp0 a_xn0 wp_ih_0_21 wn_ih_0_21 xhp21 xhn21 vdd vbsyn gsyn
Xihx_1_21 a_xp1 a_xn1 wp_ih_1_21 wn_ih_1_21 xhp21 xhn21 vdd vbsyn gsyn
Xihx_2_21 a_xp2 a_xn2 wp_ih_2_21 wn_ih_2_21 xhp21 xhn21 vdd vbsyn gsyn
Xn21 xhp21 xhn21 ahp21 ahn21 vdd vbneu dneuron
Xcm_xh22 xhp22 xhn22 vdd cmld
Rnd_xh22 xhp22 xhn22 20k
Cxh22p xhp22 0 1e-13
Cxh22n xhn22 0 1e-13
Xihx_0_22 a_xp0 a_xn0 wp_ih_0_22 wn_ih_0_22 xhp22 xhn22 vdd vbsyn gsyn
Xihx_1_22 a_xp1 a_xn1 wp_ih_1_22 wn_ih_1_22 xhp22 xhn22 vdd vbsyn gsyn
Xihx_2_22 a_xp2 a_xn2 wp_ih_2_22 wn_ih_2_22 xhp22 xhn22 vdd vbsyn gsyn
Xn22 xhp22 xhn22 ahp22 ahn22 vdd vbneu dneuron
Xcm_xh23 xhp23 xhn23 vdd cmld
Rnd_xh23 xhp23 xhn23 20k
Cxh23p xhp23 0 1e-13
Cxh23n xhn23 0 1e-13
Xihx_0_23 a_xp0 a_xn0 wp_ih_0_23 wn_ih_0_23 xhp23 xhn23 vdd vbsyn gsyn
Xihx_1_23 a_xp1 a_xn1 wp_ih_1_23 wn_ih_1_23 xhp23 xhn23 vdd vbsyn gsyn
Xihx_2_23 a_xp2 a_xn2 wp_ih_2_23 wn_ih_2_23 xhp23 xhn23 vdd vbsyn gsyn
Xn23 xhp23 xhn23 ahp23 ahn23 vdd vbneu dneuron
Xcm_xh24 xhp24 xhn24 vdd cmld
Rnd_xh24 xhp24 xhn24 20k
Cxh24p xhp24 0 1e-13
Cxh24n xhn24 0 1e-13
Xihx_0_24 a_xp0 a_xn0 wp_ih_0_24 wn_ih_0_24 xhp24 xhn24 vdd vbsyn gsyn
Xihx_1_24 a_xp1 a_xn1 wp_ih_1_24 wn_ih_1_24 xhp24 xhn24 vdd vbsyn gsyn
Xihx_2_24 a_xp2 a_xn2 wp_ih_2_24 wn_ih_2_24 xhp24 xhn24 vdd vbsyn gsyn
Xn24 xhp24 xhn24 ahp24 ahn24 vdd vbneu dneuron
Xcm_xh25 xhp25 xhn25 vdd cmld
Rnd_xh25 xhp25 xhn25 20k
Cxh25p xhp25 0 1e-13
Cxh25n xhn25 0 1e-13
Xihx_0_25 a_xp0 a_xn0 wp_ih_0_25 wn_ih_0_25 xhp25 xhn25 vdd vbsyn gsyn
Xihx_1_25 a_xp1 a_xn1 wp_ih_1_25 wn_ih_1_25 xhp25 xhn25 vdd vbsyn gsyn
Xihx_2_25 a_xp2 a_xn2 wp_ih_2_25 wn_ih_2_25 xhp25 xhn25 vdd vbsyn gsyn
Xn25 xhp25 xhn25 ahp25 ahn25 vdd vbneu dneuron
Xcm_xh26 xhp26 xhn26 vdd cmld
Rnd_xh26 xhp26 xhn26 20k
Cxh26p xhp26 0 1e-13
Cxh26n xhn26 0 1e-13
Xihx_0_26 a_xp0 a_xn0 wp_ih_0_26 wn_ih_0_26 xhp26 xhn26 vdd vbsyn gsyn
Xihx_1_26 a_xp1 a_xn1 wp_ih_1_26 wn_ih_1_26 xhp26 xhn26 vdd vbsyn gsyn
Xihx_2_26 a_xp2 a_xn2 wp_ih_2_26 wn_ih_2_26 xhp26 xhn26 vdd vbsyn gsyn
Xn26 xhp26 xhn26 ahp26 ahn26 vdd vbneu dneuron
Xcm_xh27 xhp27 xhn27 vdd cmld
Rnd_xh27 xhp27 xhn27 20k
Cxh27p xhp27 0 1e-13
Cxh27n xhn27 0 1e-13
Xihx_0_27 a_xp0 a_xn0 wp_ih_0_27 wn_ih_0_27 xhp27 xhn27 vdd vbsyn gsyn
Xihx_1_27 a_xp1 a_xn1 wp_ih_1_27 wn_ih_1_27 xhp27 xhn27 vdd vbsyn gsyn
Xihx_2_27 a_xp2 a_xn2 wp_ih_2_27 wn_ih_2_27 xhp27 xhn27 vdd vbsyn gsyn
Xn27 xhp27 xhn27 ahp27 ahn27 vdd vbneu dneuron
Xcm_xh28 xhp28 xhn28 vdd cmld
Rnd_xh28 xhp28 xhn28 20k
Cxh28p xhp28 0 1e-13
Cxh28n xhn28 0 1e-13
Xihx_0_28 a_xp0 a_xn0 wp_ih_0_28 wn_ih_0_28 xhp28 xhn28 vdd vbsyn gsyn
Xihx_1_28 a_xp1 a_xn1 wp_ih_1_28 wn_ih_1_28 xhp28 xhn28 vdd vbsyn gsyn
Xihx_2_28 a_xp2 a_xn2 wp_ih_2_28 wn_ih_2_28 xhp28 xhn28 vdd vbsyn gsyn
Xn28 xhp28 xhn28 ahp28 ahn28 vdd vbneu dneuron
Xcm_xh29 xhp29 xhn29 vdd cmld
Rnd_xh29 xhp29 xhn29 20k
Cxh29p xhp29 0 1e-13
Cxh29n xhn29 0 1e-13
Xihx_0_29 a_xp0 a_xn0 wp_ih_0_29 wn_ih_0_29 xhp29 xhn29 vdd vbsyn gsyn
Xihx_1_29 a_xp1 a_xn1 wp_ih_1_29 wn_ih_1_29 xhp29 xhn29 vdd vbsyn gsyn
Xihx_2_29 a_xp2 a_xn2 wp_ih_2_29 wn_ih_2_29 xhp29 xhn29 vdd vbsyn gsyn
Xn29 xhp29 xhn29 ahp29 ahn29 vdd vbneu dneuron
Xcm_xh30 xhp30 xhn30 vdd cmld
Rnd_xh30 xhp30 xhn30 20k
Cxh30p xhp30 0 1e-13
Cxh30n xhn30 0 1e-13
Xihx_0_30 a_xp0 a_xn0 wp_ih_0_30 wn_ih_0_30 xhp30 xhn30 vdd vbsyn gsyn
Xihx_1_30 a_xp1 a_xn1 wp_ih_1_30 wn_ih_1_30 xhp30 xhn30 vdd vbsyn gsyn
Xihx_2_30 a_xp2 a_xn2 wp_ih_2_30 wn_ih_2_30 xhp30 xhn30 vdd vbsyn gsyn
Xn30 xhp30 xhn30 ahp30 ahn30 vdd vbneu dneuron
Xcm_xh31 xhp31 xhn31 vdd cmld
Rnd_xh31 xhp31 xhn31 20k
Cxh31p xhp31 0 1e-13
Cxh31n xhn31 0 1e-13
Xihx_0_31 a_xp0 a_xn0 wp_ih_0_31 wn_ih_0_31 xhp31 xhn31 vdd vbsyn gsyn
Xihx_1_31 a_xp1 a_xn1 wp_ih_1_31 wn_ih_1_31 xhp31 xhn31 vdd vbsyn gsyn
Xihx_2_31 a_xp2 a_xn2 wp_ih_2_31 wn_ih_2_31 xhp31 xhn31 vdd vbsyn gsyn
Xn31 xhp31 xhn31 ahp31 ahn31 vdd vbneu dneuron
Xcm_xh32 xhp32 xhn32 vdd cmld
Rnd_xh32 xhp32 xhn32 20k
Cxh32p xhp32 0 1e-13
Cxh32n xhn32 0 1e-13
Xihx_0_32 a_xp0 a_xn0 wp_ih_0_32 wn_ih_0_32 xhp32 xhn32 vdd vbsyn gsyn
Xihx_1_32 a_xp1 a_xn1 wp_ih_1_32 wn_ih_1_32 xhp32 xhn32 vdd vbsyn gsyn
Xihx_2_32 a_xp2 a_xn2 wp_ih_2_32 wn_ih_2_32 xhp32 xhn32 vdd vbsyn gsyn
Xn32 xhp32 xhn32 ahp32 ahn32 vdd vbneu dneuron
Xcm_xh33 xhp33 xhn33 vdd cmld
Rnd_xh33 xhp33 xhn33 20k
Cxh33p xhp33 0 1e-13
Cxh33n xhn33 0 1e-13
Xihx_0_33 a_xp0 a_xn0 wp_ih_0_33 wn_ih_0_33 xhp33 xhn33 vdd vbsyn gsyn
Xihx_1_33 a_xp1 a_xn1 wp_ih_1_33 wn_ih_1_33 xhp33 xhn33 vdd vbsyn gsyn
Xihx_2_33 a_xp2 a_xn2 wp_ih_2_33 wn_ih_2_33 xhp33 xhn33 vdd vbsyn gsyn
Xn33 xhp33 xhn33 ahp33 ahn33 vdd vbneu dneuron
Xcm_xh34 xhp34 xhn34 vdd cmld
Rnd_xh34 xhp34 xhn34 20k
Cxh34p xhp34 0 1e-13
Cxh34n xhn34 0 1e-13
Xihx_0_34 a_xp0 a_xn0 wp_ih_0_34 wn_ih_0_34 xhp34 xhn34 vdd vbsyn gsyn
Xihx_1_34 a_xp1 a_xn1 wp_ih_1_34 wn_ih_1_34 xhp34 xhn34 vdd vbsyn gsyn
Xihx_2_34 a_xp2 a_xn2 wp_ih_2_34 wn_ih_2_34 xhp34 xhn34 vdd vbsyn gsyn
Xn34 xhp34 xhn34 ahp34 ahn34 vdd vbneu dneuron
Xcm_xh35 xhp35 xhn35 vdd cmld
Rnd_xh35 xhp35 xhn35 20k
Cxh35p xhp35 0 1e-13
Cxh35n xhn35 0 1e-13
Xihx_0_35 a_xp0 a_xn0 wp_ih_0_35 wn_ih_0_35 xhp35 xhn35 vdd vbsyn gsyn
Xihx_1_35 a_xp1 a_xn1 wp_ih_1_35 wn_ih_1_35 xhp35 xhn35 vdd vbsyn gsyn
Xihx_2_35 a_xp2 a_xn2 wp_ih_2_35 wn_ih_2_35 xhp35 xhn35 vdd vbsyn gsyn
Xn35 xhp35 xhn35 ahp35 ahn35 vdd vbneu dneuron
Xcm_xh36 xhp36 xhn36 vdd cmld
Rnd_xh36 xhp36 xhn36 20k
Cxh36p xhp36 0 1e-13
Cxh36n xhn36 0 1e-13
Xihx_0_36 a_xp0 a_xn0 wp_ih_0_36 wn_ih_0_36 xhp36 xhn36 vdd vbsyn gsyn
Xihx_1_36 a_xp1 a_xn1 wp_ih_1_36 wn_ih_1_36 xhp36 xhn36 vdd vbsyn gsyn
Xihx_2_36 a_xp2 a_xn2 wp_ih_2_36 wn_ih_2_36 xhp36 xhn36 vdd vbsyn gsyn
Xn36 xhp36 xhn36 ahp36 ahn36 vdd vbneu dneuron
Xcm_xh37 xhp37 xhn37 vdd cmld
Rnd_xh37 xhp37 xhn37 20k
Cxh37p xhp37 0 1e-13
Cxh37n xhn37 0 1e-13
Xihx_0_37 a_xp0 a_xn0 wp_ih_0_37 wn_ih_0_37 xhp37 xhn37 vdd vbsyn gsyn
Xihx_1_37 a_xp1 a_xn1 wp_ih_1_37 wn_ih_1_37 xhp37 xhn37 vdd vbsyn gsyn
Xihx_2_37 a_xp2 a_xn2 wp_ih_2_37 wn_ih_2_37 xhp37 xhn37 vdd vbsyn gsyn
Xn37 xhp37 xhn37 ahp37 ahn37 vdd vbneu dneuron
Xcm_xh38 xhp38 xhn38 vdd cmld
Rnd_xh38 xhp38 xhn38 20k
Cxh38p xhp38 0 1e-13
Cxh38n xhn38 0 1e-13
Xihx_0_38 a_xp0 a_xn0 wp_ih_0_38 wn_ih_0_38 xhp38 xhn38 vdd vbsyn gsyn
Xihx_1_38 a_xp1 a_xn1 wp_ih_1_38 wn_ih_1_38 xhp38 xhn38 vdd vbsyn gsyn
Xihx_2_38 a_xp2 a_xn2 wp_ih_2_38 wn_ih_2_38 xhp38 xhn38 vdd vbsyn gsyn
Xn38 xhp38 xhn38 ahp38 ahn38 vdd vbneu dneuron
Xcm_xh39 xhp39 xhn39 vdd cmld
Rnd_xh39 xhp39 xhn39 20k
Cxh39p xhp39 0 1e-13
Cxh39n xhn39 0 1e-13
Xihx_0_39 a_xp0 a_xn0 wp_ih_0_39 wn_ih_0_39 xhp39 xhn39 vdd vbsyn gsyn
Xihx_1_39 a_xp1 a_xn1 wp_ih_1_39 wn_ih_1_39 xhp39 xhn39 vdd vbsyn gsyn
Xihx_2_39 a_xp2 a_xn2 wp_ih_2_39 wn_ih_2_39 xhp39 xhn39 vdd vbsyn gsyn
Xn39 xhp39 xhn39 ahp39 ahn39 vdd vbneu dneuron
Xcm_xh40 xhp40 xhn40 vdd cmld
Rnd_xh40 xhp40 xhn40 20k
Cxh40p xhp40 0 1e-13
Cxh40n xhn40 0 1e-13
Xihx_0_40 a_xp0 a_xn0 wp_ih_0_40 wn_ih_0_40 xhp40 xhn40 vdd vbsyn gsyn
Xihx_1_40 a_xp1 a_xn1 wp_ih_1_40 wn_ih_1_40 xhp40 xhn40 vdd vbsyn gsyn
Xihx_2_40 a_xp2 a_xn2 wp_ih_2_40 wn_ih_2_40 xhp40 xhn40 vdd vbsyn gsyn
Xn40 xhp40 xhn40 ahp40 ahn40 vdd vbneu dneuron
Xcm_xh41 xhp41 xhn41 vdd cmld
Rnd_xh41 xhp41 xhn41 20k
Cxh41p xhp41 0 1e-13
Cxh41n xhn41 0 1e-13
Xihx_0_41 a_xp0 a_xn0 wp_ih_0_41 wn_ih_0_41 xhp41 xhn41 vdd vbsyn gsyn
Xihx_1_41 a_xp1 a_xn1 wp_ih_1_41 wn_ih_1_41 xhp41 xhn41 vdd vbsyn gsyn
Xihx_2_41 a_xp2 a_xn2 wp_ih_2_41 wn_ih_2_41 xhp41 xhn41 vdd vbsyn gsyn
Xn41 xhp41 xhn41 ahp41 ahn41 vdd vbneu dneuron
Xcm_xh42 xhp42 xhn42 vdd cmld
Rnd_xh42 xhp42 xhn42 20k
Cxh42p xhp42 0 1e-13
Cxh42n xhn42 0 1e-13
Xihx_0_42 a_xp0 a_xn0 wp_ih_0_42 wn_ih_0_42 xhp42 xhn42 vdd vbsyn gsyn
Xihx_1_42 a_xp1 a_xn1 wp_ih_1_42 wn_ih_1_42 xhp42 xhn42 vdd vbsyn gsyn
Xihx_2_42 a_xp2 a_xn2 wp_ih_2_42 wn_ih_2_42 xhp42 xhn42 vdd vbsyn gsyn
Xn42 xhp42 xhn42 ahp42 ahn42 vdd vbneu dneuron
Xcm_xh43 xhp43 xhn43 vdd cmld
Rnd_xh43 xhp43 xhn43 20k
Cxh43p xhp43 0 1e-13
Cxh43n xhn43 0 1e-13
Xihx_0_43 a_xp0 a_xn0 wp_ih_0_43 wn_ih_0_43 xhp43 xhn43 vdd vbsyn gsyn
Xihx_1_43 a_xp1 a_xn1 wp_ih_1_43 wn_ih_1_43 xhp43 xhn43 vdd vbsyn gsyn
Xihx_2_43 a_xp2 a_xn2 wp_ih_2_43 wn_ih_2_43 xhp43 xhn43 vdd vbsyn gsyn
Xn43 xhp43 xhn43 ahp43 ahn43 vdd vbneu dneuron
Xcm_xh44 xhp44 xhn44 vdd cmld
Rnd_xh44 xhp44 xhn44 20k
Cxh44p xhp44 0 1e-13
Cxh44n xhn44 0 1e-13
Xihx_0_44 a_xp0 a_xn0 wp_ih_0_44 wn_ih_0_44 xhp44 xhn44 vdd vbsyn gsyn
Xihx_1_44 a_xp1 a_xn1 wp_ih_1_44 wn_ih_1_44 xhp44 xhn44 vdd vbsyn gsyn
Xihx_2_44 a_xp2 a_xn2 wp_ih_2_44 wn_ih_2_44 xhp44 xhn44 vdd vbsyn gsyn
Xn44 xhp44 xhn44 ahp44 ahn44 vdd vbneu dneuron
Xcm_xh45 xhp45 xhn45 vdd cmld
Rnd_xh45 xhp45 xhn45 20k
Cxh45p xhp45 0 1e-13
Cxh45n xhn45 0 1e-13
Xihx_0_45 a_xp0 a_xn0 wp_ih_0_45 wn_ih_0_45 xhp45 xhn45 vdd vbsyn gsyn
Xihx_1_45 a_xp1 a_xn1 wp_ih_1_45 wn_ih_1_45 xhp45 xhn45 vdd vbsyn gsyn
Xihx_2_45 a_xp2 a_xn2 wp_ih_2_45 wn_ih_2_45 xhp45 xhn45 vdd vbsyn gsyn
Xn45 xhp45 xhn45 ahp45 ahn45 vdd vbneu dneuron
Xcm_xh46 xhp46 xhn46 vdd cmld
Rnd_xh46 xhp46 xhn46 20k
Cxh46p xhp46 0 1e-13
Cxh46n xhn46 0 1e-13
Xihx_0_46 a_xp0 a_xn0 wp_ih_0_46 wn_ih_0_46 xhp46 xhn46 vdd vbsyn gsyn
Xihx_1_46 a_xp1 a_xn1 wp_ih_1_46 wn_ih_1_46 xhp46 xhn46 vdd vbsyn gsyn
Xihx_2_46 a_xp2 a_xn2 wp_ih_2_46 wn_ih_2_46 xhp46 xhn46 vdd vbsyn gsyn
Xn46 xhp46 xhn46 ahp46 ahn46 vdd vbneu dneuron
Xcm_xh47 xhp47 xhn47 vdd cmld
Rnd_xh47 xhp47 xhn47 20k
Cxh47p xhp47 0 1e-13
Cxh47n xhn47 0 1e-13
Xihx_0_47 a_xp0 a_xn0 wp_ih_0_47 wn_ih_0_47 xhp47 xhn47 vdd vbsyn gsyn
Xihx_1_47 a_xp1 a_xn1 wp_ih_1_47 wn_ih_1_47 xhp47 xhn47 vdd vbsyn gsyn
Xihx_2_47 a_xp2 a_xn2 wp_ih_2_47 wn_ih_2_47 xhp47 xhn47 vdd vbsyn gsyn
Xn47 xhp47 xhn47 ahp47 ahn47 vdd vbneu dneuron
Xcm_xh48 xhp48 xhn48 vdd cmld
Rnd_xh48 xhp48 xhn48 20k
Cxh48p xhp48 0 1e-13
Cxh48n xhn48 0 1e-13
Xihx_0_48 a_xp0 a_xn0 wp_ih_0_48 wn_ih_0_48 xhp48 xhn48 vdd vbsyn gsyn
Xihx_1_48 a_xp1 a_xn1 wp_ih_1_48 wn_ih_1_48 xhp48 xhn48 vdd vbsyn gsyn
Xihx_2_48 a_xp2 a_xn2 wp_ih_2_48 wn_ih_2_48 xhp48 xhn48 vdd vbsyn gsyn
Xn48 xhp48 xhn48 ahp48 ahn48 vdd vbneu dneuron
Xcm_xh49 xhp49 xhn49 vdd cmld
Rnd_xh49 xhp49 xhn49 20k
Cxh49p xhp49 0 1e-13
Cxh49n xhn49 0 1e-13
Xihx_0_49 a_xp0 a_xn0 wp_ih_0_49 wn_ih_0_49 xhp49 xhn49 vdd vbsyn gsyn
Xihx_1_49 a_xp1 a_xn1 wp_ih_1_49 wn_ih_1_49 xhp49 xhn49 vdd vbsyn gsyn
Xihx_2_49 a_xp2 a_xn2 wp_ih_2_49 wn_ih_2_49 xhp49 xhn49 vdd vbsyn gsyn
Xn49 xhp49 xhn49 ahp49 ahn49 vdd vbneu dneuron
Xcm_xh50 xhp50 xhn50 vdd cmld
Rnd_xh50 xhp50 xhn50 20k
Cxh50p xhp50 0 1e-13
Cxh50n xhn50 0 1e-13
Xihx_0_50 a_xp0 a_xn0 wp_ih_0_50 wn_ih_0_50 xhp50 xhn50 vdd vbsyn gsyn
Xihx_1_50 a_xp1 a_xn1 wp_ih_1_50 wn_ih_1_50 xhp50 xhn50 vdd vbsyn gsyn
Xihx_2_50 a_xp2 a_xn2 wp_ih_2_50 wn_ih_2_50 xhp50 xhn50 vdd vbsyn gsyn
Xn50 xhp50 xhn50 ahp50 ahn50 vdd vbneu dneuron
Xcm_xh51 xhp51 xhn51 vdd cmld
Rnd_xh51 xhp51 xhn51 20k
Cxh51p xhp51 0 1e-13
Cxh51n xhn51 0 1e-13
Xihx_0_51 a_xp0 a_xn0 wp_ih_0_51 wn_ih_0_51 xhp51 xhn51 vdd vbsyn gsyn
Xihx_1_51 a_xp1 a_xn1 wp_ih_1_51 wn_ih_1_51 xhp51 xhn51 vdd vbsyn gsyn
Xihx_2_51 a_xp2 a_xn2 wp_ih_2_51 wn_ih_2_51 xhp51 xhn51 vdd vbsyn gsyn
Xn51 xhp51 xhn51 ahp51 ahn51 vdd vbneu dneuron
Xcm_xh52 xhp52 xhn52 vdd cmld
Rnd_xh52 xhp52 xhn52 20k
Cxh52p xhp52 0 1e-13
Cxh52n xhn52 0 1e-13
Xihx_0_52 a_xp0 a_xn0 wp_ih_0_52 wn_ih_0_52 xhp52 xhn52 vdd vbsyn gsyn
Xihx_1_52 a_xp1 a_xn1 wp_ih_1_52 wn_ih_1_52 xhp52 xhn52 vdd vbsyn gsyn
Xihx_2_52 a_xp2 a_xn2 wp_ih_2_52 wn_ih_2_52 xhp52 xhn52 vdd vbsyn gsyn
Xn52 xhp52 xhn52 ahp52 ahn52 vdd vbneu dneuron
Xcm_xh53 xhp53 xhn53 vdd cmld
Rnd_xh53 xhp53 xhn53 20k
Cxh53p xhp53 0 1e-13
Cxh53n xhn53 0 1e-13
Xihx_0_53 a_xp0 a_xn0 wp_ih_0_53 wn_ih_0_53 xhp53 xhn53 vdd vbsyn gsyn
Xihx_1_53 a_xp1 a_xn1 wp_ih_1_53 wn_ih_1_53 xhp53 xhn53 vdd vbsyn gsyn
Xihx_2_53 a_xp2 a_xn2 wp_ih_2_53 wn_ih_2_53 xhp53 xhn53 vdd vbsyn gsyn
Xn53 xhp53 xhn53 ahp53 ahn53 vdd vbneu dneuron
Xcm_xh54 xhp54 xhn54 vdd cmld
Rnd_xh54 xhp54 xhn54 20k
Cxh54p xhp54 0 1e-13
Cxh54n xhn54 0 1e-13
Xihx_0_54 a_xp0 a_xn0 wp_ih_0_54 wn_ih_0_54 xhp54 xhn54 vdd vbsyn gsyn
Xihx_1_54 a_xp1 a_xn1 wp_ih_1_54 wn_ih_1_54 xhp54 xhn54 vdd vbsyn gsyn
Xihx_2_54 a_xp2 a_xn2 wp_ih_2_54 wn_ih_2_54 xhp54 xhn54 vdd vbsyn gsyn
Xn54 xhp54 xhn54 ahp54 ahn54 vdd vbneu dneuron
Xcm_xh55 xhp55 xhn55 vdd cmld
Rnd_xh55 xhp55 xhn55 20k
Cxh55p xhp55 0 1e-13
Cxh55n xhn55 0 1e-13
Xihx_0_55 a_xp0 a_xn0 wp_ih_0_55 wn_ih_0_55 xhp55 xhn55 vdd vbsyn gsyn
Xihx_1_55 a_xp1 a_xn1 wp_ih_1_55 wn_ih_1_55 xhp55 xhn55 vdd vbsyn gsyn
Xihx_2_55 a_xp2 a_xn2 wp_ih_2_55 wn_ih_2_55 xhp55 xhn55 vdd vbsyn gsyn
Xn55 xhp55 xhn55 ahp55 ahn55 vdd vbneu dneuron
Xcm_xh56 xhp56 xhn56 vdd cmld
Rnd_xh56 xhp56 xhn56 20k
Cxh56p xhp56 0 1e-13
Cxh56n xhn56 0 1e-13
Xihx_0_56 a_xp0 a_xn0 wp_ih_0_56 wn_ih_0_56 xhp56 xhn56 vdd vbsyn gsyn
Xihx_1_56 a_xp1 a_xn1 wp_ih_1_56 wn_ih_1_56 xhp56 xhn56 vdd vbsyn gsyn
Xihx_2_56 a_xp2 a_xn2 wp_ih_2_56 wn_ih_2_56 xhp56 xhn56 vdd vbsyn gsyn
Xn56 xhp56 xhn56 ahp56 ahn56 vdd vbneu dneuron
Xcm_xh57 xhp57 xhn57 vdd cmld
Rnd_xh57 xhp57 xhn57 20k
Cxh57p xhp57 0 1e-13
Cxh57n xhn57 0 1e-13
Xihx_0_57 a_xp0 a_xn0 wp_ih_0_57 wn_ih_0_57 xhp57 xhn57 vdd vbsyn gsyn
Xihx_1_57 a_xp1 a_xn1 wp_ih_1_57 wn_ih_1_57 xhp57 xhn57 vdd vbsyn gsyn
Xihx_2_57 a_xp2 a_xn2 wp_ih_2_57 wn_ih_2_57 xhp57 xhn57 vdd vbsyn gsyn
Xn57 xhp57 xhn57 ahp57 ahn57 vdd vbneu dneuron
Xcm_xh58 xhp58 xhn58 vdd cmld
Rnd_xh58 xhp58 xhn58 20k
Cxh58p xhp58 0 1e-13
Cxh58n xhn58 0 1e-13
Xihx_0_58 a_xp0 a_xn0 wp_ih_0_58 wn_ih_0_58 xhp58 xhn58 vdd vbsyn gsyn
Xihx_1_58 a_xp1 a_xn1 wp_ih_1_58 wn_ih_1_58 xhp58 xhn58 vdd vbsyn gsyn
Xihx_2_58 a_xp2 a_xn2 wp_ih_2_58 wn_ih_2_58 xhp58 xhn58 vdd vbsyn gsyn
Xn58 xhp58 xhn58 ahp58 ahn58 vdd vbneu dneuron
Xcm_xh59 xhp59 xhn59 vdd cmld
Rnd_xh59 xhp59 xhn59 20k
Cxh59p xhp59 0 1e-13
Cxh59n xhn59 0 1e-13
Xihx_0_59 a_xp0 a_xn0 wp_ih_0_59 wn_ih_0_59 xhp59 xhn59 vdd vbsyn gsyn
Xihx_1_59 a_xp1 a_xn1 wp_ih_1_59 wn_ih_1_59 xhp59 xhn59 vdd vbsyn gsyn
Xihx_2_59 a_xp2 a_xn2 wp_ih_2_59 wn_ih_2_59 xhp59 xhn59 vdd vbsyn gsyn
Xn59 xhp59 xhn59 ahp59 ahn59 vdd vbneu dneuron
Xcm_xh60 xhp60 xhn60 vdd cmld
Rnd_xh60 xhp60 xhn60 20k
Cxh60p xhp60 0 1e-13
Cxh60n xhn60 0 1e-13
Xihx_0_60 a_xp0 a_xn0 wp_ih_0_60 wn_ih_0_60 xhp60 xhn60 vdd vbsyn gsyn
Xihx_1_60 a_xp1 a_xn1 wp_ih_1_60 wn_ih_1_60 xhp60 xhn60 vdd vbsyn gsyn
Xihx_2_60 a_xp2 a_xn2 wp_ih_2_60 wn_ih_2_60 xhp60 xhn60 vdd vbsyn gsyn
Xn60 xhp60 xhn60 ahp60 ahn60 vdd vbneu dneuron
Xcm_xh61 xhp61 xhn61 vdd cmld
Rnd_xh61 xhp61 xhn61 20k
Cxh61p xhp61 0 1e-13
Cxh61n xhn61 0 1e-13
Xihx_0_61 a_xp0 a_xn0 wp_ih_0_61 wn_ih_0_61 xhp61 xhn61 vdd vbsyn gsyn
Xihx_1_61 a_xp1 a_xn1 wp_ih_1_61 wn_ih_1_61 xhp61 xhn61 vdd vbsyn gsyn
Xihx_2_61 a_xp2 a_xn2 wp_ih_2_61 wn_ih_2_61 xhp61 xhn61 vdd vbsyn gsyn
Xn61 xhp61 xhn61 ahp61 ahn61 vdd vbneu dneuron
Xcm_xh62 xhp62 xhn62 vdd cmld
Rnd_xh62 xhp62 xhn62 20k
Cxh62p xhp62 0 1e-13
Cxh62n xhn62 0 1e-13
Xihx_0_62 a_xp0 a_xn0 wp_ih_0_62 wn_ih_0_62 xhp62 xhn62 vdd vbsyn gsyn
Xihx_1_62 a_xp1 a_xn1 wp_ih_1_62 wn_ih_1_62 xhp62 xhn62 vdd vbsyn gsyn
Xihx_2_62 a_xp2 a_xn2 wp_ih_2_62 wn_ih_2_62 xhp62 xhn62 vdd vbsyn gsyn
Xn62 xhp62 xhn62 ahp62 ahn62 vdd vbneu dneuron
Xcm_xh63 xhp63 xhn63 vdd cmld
Rnd_xh63 xhp63 xhn63 20k
Cxh63p xhp63 0 1e-13
Cxh63n xhn63 0 1e-13
Xihx_0_63 a_xp0 a_xn0 wp_ih_0_63 wn_ih_0_63 xhp63 xhn63 vdd vbsyn gsyn
Xihx_1_63 a_xp1 a_xn1 wp_ih_1_63 wn_ih_1_63 xhp63 xhn63 vdd vbsyn gsyn
Xihx_2_63 a_xp2 a_xn2 wp_ih_2_63 wn_ih_2_63 xhp63 xhn63 vdd vbsyn gsyn
Xn63 xhp63 xhn63 ahp63 ahn63 vdd vbneu dneuron
Xcm_xh64 xhp64 xhn64 vdd cmld
Rnd_xh64 xhp64 xhn64 20k
Cxh64p xhp64 0 1e-13
Cxh64n xhn64 0 1e-13
Xihx_0_64 a_xp0 a_xn0 wp_ih_0_64 wn_ih_0_64 xhp64 xhn64 vdd vbsyn gsyn
Xihx_1_64 a_xp1 a_xn1 wp_ih_1_64 wn_ih_1_64 xhp64 xhn64 vdd vbsyn gsyn
Xihx_2_64 a_xp2 a_xn2 wp_ih_2_64 wn_ih_2_64 xhp64 xhn64 vdd vbsyn gsyn
Xn64 xhp64 xhn64 ahp64 ahn64 vdd vbneu dneuron
Xcm_xh65 xhp65 xhn65 vdd cmld
Rnd_xh65 xhp65 xhn65 20k
Cxh65p xhp65 0 1e-13
Cxh65n xhn65 0 1e-13
Xihx_0_65 a_xp0 a_xn0 wp_ih_0_65 wn_ih_0_65 xhp65 xhn65 vdd vbsyn gsyn
Xihx_1_65 a_xp1 a_xn1 wp_ih_1_65 wn_ih_1_65 xhp65 xhn65 vdd vbsyn gsyn
Xihx_2_65 a_xp2 a_xn2 wp_ih_2_65 wn_ih_2_65 xhp65 xhn65 vdd vbsyn gsyn
Xn65 xhp65 xhn65 ahp65 ahn65 vdd vbneu dneuron
Xcm_xh66 xhp66 xhn66 vdd cmld
Rnd_xh66 xhp66 xhn66 20k
Cxh66p xhp66 0 1e-13
Cxh66n xhn66 0 1e-13
Xihx_0_66 a_xp0 a_xn0 wp_ih_0_66 wn_ih_0_66 xhp66 xhn66 vdd vbsyn gsyn
Xihx_1_66 a_xp1 a_xn1 wp_ih_1_66 wn_ih_1_66 xhp66 xhn66 vdd vbsyn gsyn
Xihx_2_66 a_xp2 a_xn2 wp_ih_2_66 wn_ih_2_66 xhp66 xhn66 vdd vbsyn gsyn
Xn66 xhp66 xhn66 ahp66 ahn66 vdd vbneu dneuron
Xcm_xh67 xhp67 xhn67 vdd cmld
Rnd_xh67 xhp67 xhn67 20k
Cxh67p xhp67 0 1e-13
Cxh67n xhn67 0 1e-13
Xihx_0_67 a_xp0 a_xn0 wp_ih_0_67 wn_ih_0_67 xhp67 xhn67 vdd vbsyn gsyn
Xihx_1_67 a_xp1 a_xn1 wp_ih_1_67 wn_ih_1_67 xhp67 xhn67 vdd vbsyn gsyn
Xihx_2_67 a_xp2 a_xn2 wp_ih_2_67 wn_ih_2_67 xhp67 xhn67 vdd vbsyn gsyn
Xn67 xhp67 xhn67 ahp67 ahn67 vdd vbneu dneuron
Xcm_xh68 xhp68 xhn68 vdd cmld
Rnd_xh68 xhp68 xhn68 20k
Cxh68p xhp68 0 1e-13
Cxh68n xhn68 0 1e-13
Xihx_0_68 a_xp0 a_xn0 wp_ih_0_68 wn_ih_0_68 xhp68 xhn68 vdd vbsyn gsyn
Xihx_1_68 a_xp1 a_xn1 wp_ih_1_68 wn_ih_1_68 xhp68 xhn68 vdd vbsyn gsyn
Xihx_2_68 a_xp2 a_xn2 wp_ih_2_68 wn_ih_2_68 xhp68 xhn68 vdd vbsyn gsyn
Xn68 xhp68 xhn68 ahp68 ahn68 vdd vbneu dneuron
Xcm_xh69 xhp69 xhn69 vdd cmld
Rnd_xh69 xhp69 xhn69 20k
Cxh69p xhp69 0 1e-13
Cxh69n xhn69 0 1e-13
Xihx_0_69 a_xp0 a_xn0 wp_ih_0_69 wn_ih_0_69 xhp69 xhn69 vdd vbsyn gsyn
Xihx_1_69 a_xp1 a_xn1 wp_ih_1_69 wn_ih_1_69 xhp69 xhn69 vdd vbsyn gsyn
Xihx_2_69 a_xp2 a_xn2 wp_ih_2_69 wn_ih_2_69 xhp69 xhn69 vdd vbsyn gsyn
Xn69 xhp69 xhn69 ahp69 ahn69 vdd vbneu dneuron
Xcm_xh70 xhp70 xhn70 vdd cmld
Rnd_xh70 xhp70 xhn70 20k
Cxh70p xhp70 0 1e-13
Cxh70n xhn70 0 1e-13
Xihx_0_70 a_xp0 a_xn0 wp_ih_0_70 wn_ih_0_70 xhp70 xhn70 vdd vbsyn gsyn
Xihx_1_70 a_xp1 a_xn1 wp_ih_1_70 wn_ih_1_70 xhp70 xhn70 vdd vbsyn gsyn
Xihx_2_70 a_xp2 a_xn2 wp_ih_2_70 wn_ih_2_70 xhp70 xhn70 vdd vbsyn gsyn
Xn70 xhp70 xhn70 ahp70 ahn70 vdd vbneu dneuron
Xcm_xh71 xhp71 xhn71 vdd cmld
Rnd_xh71 xhp71 xhn71 20k
Cxh71p xhp71 0 1e-13
Cxh71n xhn71 0 1e-13
Xihx_0_71 a_xp0 a_xn0 wp_ih_0_71 wn_ih_0_71 xhp71 xhn71 vdd vbsyn gsyn
Xihx_1_71 a_xp1 a_xn1 wp_ih_1_71 wn_ih_1_71 xhp71 xhn71 vdd vbsyn gsyn
Xihx_2_71 a_xp2 a_xn2 wp_ih_2_71 wn_ih_2_71 xhp71 xhn71 vdd vbsyn gsyn
Xn71 xhp71 xhn71 ahp71 ahn71 vdd vbneu dneuron
Xcm_xh72 xhp72 xhn72 vdd cmld
Rnd_xh72 xhp72 xhn72 20k
Cxh72p xhp72 0 1e-13
Cxh72n xhn72 0 1e-13
Xihx_0_72 a_xp0 a_xn0 wp_ih_0_72 wn_ih_0_72 xhp72 xhn72 vdd vbsyn gsyn
Xihx_1_72 a_xp1 a_xn1 wp_ih_1_72 wn_ih_1_72 xhp72 xhn72 vdd vbsyn gsyn
Xihx_2_72 a_xp2 a_xn2 wp_ih_2_72 wn_ih_2_72 xhp72 xhn72 vdd vbsyn gsyn
Xn72 xhp72 xhn72 ahp72 ahn72 vdd vbneu dneuron
Xcm_xh73 xhp73 xhn73 vdd cmld
Rnd_xh73 xhp73 xhn73 20k
Cxh73p xhp73 0 1e-13
Cxh73n xhn73 0 1e-13
Xihx_0_73 a_xp0 a_xn0 wp_ih_0_73 wn_ih_0_73 xhp73 xhn73 vdd vbsyn gsyn
Xihx_1_73 a_xp1 a_xn1 wp_ih_1_73 wn_ih_1_73 xhp73 xhn73 vdd vbsyn gsyn
Xihx_2_73 a_xp2 a_xn2 wp_ih_2_73 wn_ih_2_73 xhp73 xhn73 vdd vbsyn gsyn
Xn73 xhp73 xhn73 ahp73 ahn73 vdd vbneu dneuron
Xcm_xh74 xhp74 xhn74 vdd cmld
Rnd_xh74 xhp74 xhn74 20k
Cxh74p xhp74 0 1e-13
Cxh74n xhn74 0 1e-13
Xihx_0_74 a_xp0 a_xn0 wp_ih_0_74 wn_ih_0_74 xhp74 xhn74 vdd vbsyn gsyn
Xihx_1_74 a_xp1 a_xn1 wp_ih_1_74 wn_ih_1_74 xhp74 xhn74 vdd vbsyn gsyn
Xihx_2_74 a_xp2 a_xn2 wp_ih_2_74 wn_ih_2_74 xhp74 xhn74 vdd vbsyn gsyn
Xn74 xhp74 xhn74 ahp74 ahn74 vdd vbneu dneuron
Xcm_xh75 xhp75 xhn75 vdd cmld
Rnd_xh75 xhp75 xhn75 20k
Cxh75p xhp75 0 1e-13
Cxh75n xhn75 0 1e-13
Xihx_0_75 a_xp0 a_xn0 wp_ih_0_75 wn_ih_0_75 xhp75 xhn75 vdd vbsyn gsyn
Xihx_1_75 a_xp1 a_xn1 wp_ih_1_75 wn_ih_1_75 xhp75 xhn75 vdd vbsyn gsyn
Xihx_2_75 a_xp2 a_xn2 wp_ih_2_75 wn_ih_2_75 xhp75 xhn75 vdd vbsyn gsyn
Xn75 xhp75 xhn75 ahp75 ahn75 vdd vbneu dneuron
Xcm_xh76 xhp76 xhn76 vdd cmld
Rnd_xh76 xhp76 xhn76 20k
Cxh76p xhp76 0 1e-13
Cxh76n xhn76 0 1e-13
Xihx_0_76 a_xp0 a_xn0 wp_ih_0_76 wn_ih_0_76 xhp76 xhn76 vdd vbsyn gsyn
Xihx_1_76 a_xp1 a_xn1 wp_ih_1_76 wn_ih_1_76 xhp76 xhn76 vdd vbsyn gsyn
Xihx_2_76 a_xp2 a_xn2 wp_ih_2_76 wn_ih_2_76 xhp76 xhn76 vdd vbsyn gsyn
Xn76 xhp76 xhn76 ahp76 ahn76 vdd vbneu dneuron
Xcm_xh77 xhp77 xhn77 vdd cmld
Rnd_xh77 xhp77 xhn77 20k
Cxh77p xhp77 0 1e-13
Cxh77n xhn77 0 1e-13
Xihx_0_77 a_xp0 a_xn0 wp_ih_0_77 wn_ih_0_77 xhp77 xhn77 vdd vbsyn gsyn
Xihx_1_77 a_xp1 a_xn1 wp_ih_1_77 wn_ih_1_77 xhp77 xhn77 vdd vbsyn gsyn
Xihx_2_77 a_xp2 a_xn2 wp_ih_2_77 wn_ih_2_77 xhp77 xhn77 vdd vbsyn gsyn
Xn77 xhp77 xhn77 ahp77 ahn77 vdd vbneu dneuron
Xcm_xh78 xhp78 xhn78 vdd cmld
Rnd_xh78 xhp78 xhn78 20k
Cxh78p xhp78 0 1e-13
Cxh78n xhn78 0 1e-13
Xihx_0_78 a_xp0 a_xn0 wp_ih_0_78 wn_ih_0_78 xhp78 xhn78 vdd vbsyn gsyn
Xihx_1_78 a_xp1 a_xn1 wp_ih_1_78 wn_ih_1_78 xhp78 xhn78 vdd vbsyn gsyn
Xihx_2_78 a_xp2 a_xn2 wp_ih_2_78 wn_ih_2_78 xhp78 xhn78 vdd vbsyn gsyn
Xn78 xhp78 xhn78 ahp78 ahn78 vdd vbneu dneuron
Xcm_xh79 xhp79 xhn79 vdd cmld
Rnd_xh79 xhp79 xhn79 20k
Cxh79p xhp79 0 1e-13
Cxh79n xhn79 0 1e-13
Xihx_0_79 a_xp0 a_xn0 wp_ih_0_79 wn_ih_0_79 xhp79 xhn79 vdd vbsyn gsyn
Xihx_1_79 a_xp1 a_xn1 wp_ih_1_79 wn_ih_1_79 xhp79 xhn79 vdd vbsyn gsyn
Xihx_2_79 a_xp2 a_xn2 wp_ih_2_79 wn_ih_2_79 xhp79 xhn79 vdd vbsyn gsyn
Xn79 xhp79 xhn79 ahp79 ahn79 vdd vbneu dneuron
Xcm_xh80 xhp80 xhn80 vdd cmld
Rnd_xh80 xhp80 xhn80 20k
Cxh80p xhp80 0 1e-13
Cxh80n xhn80 0 1e-13
Xihx_0_80 a_xp0 a_xn0 wp_ih_0_80 wn_ih_0_80 xhp80 xhn80 vdd vbsyn gsyn
Xihx_1_80 a_xp1 a_xn1 wp_ih_1_80 wn_ih_1_80 xhp80 xhn80 vdd vbsyn gsyn
Xihx_2_80 a_xp2 a_xn2 wp_ih_2_80 wn_ih_2_80 xhp80 xhn80 vdd vbsyn gsyn
Xn80 xhp80 xhn80 ahp80 ahn80 vdd vbneu dneuron
Xcm_xh81 xhp81 xhn81 vdd cmld
Rnd_xh81 xhp81 xhn81 20k
Cxh81p xhp81 0 1e-13
Cxh81n xhn81 0 1e-13
Xihx_0_81 a_xp0 a_xn0 wp_ih_0_81 wn_ih_0_81 xhp81 xhn81 vdd vbsyn gsyn
Xihx_1_81 a_xp1 a_xn1 wp_ih_1_81 wn_ih_1_81 xhp81 xhn81 vdd vbsyn gsyn
Xihx_2_81 a_xp2 a_xn2 wp_ih_2_81 wn_ih_2_81 xhp81 xhn81 vdd vbsyn gsyn
Xn81 xhp81 xhn81 ahp81 ahn81 vdd vbneu dneuron
Xcm_xh82 xhp82 xhn82 vdd cmld
Rnd_xh82 xhp82 xhn82 20k
Cxh82p xhp82 0 1e-13
Cxh82n xhn82 0 1e-13
Xihx_0_82 a_xp0 a_xn0 wp_ih_0_82 wn_ih_0_82 xhp82 xhn82 vdd vbsyn gsyn
Xihx_1_82 a_xp1 a_xn1 wp_ih_1_82 wn_ih_1_82 xhp82 xhn82 vdd vbsyn gsyn
Xihx_2_82 a_xp2 a_xn2 wp_ih_2_82 wn_ih_2_82 xhp82 xhn82 vdd vbsyn gsyn
Xn82 xhp82 xhn82 ahp82 ahn82 vdd vbneu dneuron
Xcm_xh83 xhp83 xhn83 vdd cmld
Rnd_xh83 xhp83 xhn83 20k
Cxh83p xhp83 0 1e-13
Cxh83n xhn83 0 1e-13
Xihx_0_83 a_xp0 a_xn0 wp_ih_0_83 wn_ih_0_83 xhp83 xhn83 vdd vbsyn gsyn
Xihx_1_83 a_xp1 a_xn1 wp_ih_1_83 wn_ih_1_83 xhp83 xhn83 vdd vbsyn gsyn
Xihx_2_83 a_xp2 a_xn2 wp_ih_2_83 wn_ih_2_83 xhp83 xhn83 vdd vbsyn gsyn
Xn83 xhp83 xhn83 ahp83 ahn83 vdd vbneu dneuron
Xcm_xh84 xhp84 xhn84 vdd cmld
Rnd_xh84 xhp84 xhn84 20k
Cxh84p xhp84 0 1e-13
Cxh84n xhn84 0 1e-13
Xihx_0_84 a_xp0 a_xn0 wp_ih_0_84 wn_ih_0_84 xhp84 xhn84 vdd vbsyn gsyn
Xihx_1_84 a_xp1 a_xn1 wp_ih_1_84 wn_ih_1_84 xhp84 xhn84 vdd vbsyn gsyn
Xihx_2_84 a_xp2 a_xn2 wp_ih_2_84 wn_ih_2_84 xhp84 xhn84 vdd vbsyn gsyn
Xn84 xhp84 xhn84 ahp84 ahn84 vdd vbneu dneuron
Xcm_xh85 xhp85 xhn85 vdd cmld
Rnd_xh85 xhp85 xhn85 20k
Cxh85p xhp85 0 1e-13
Cxh85n xhn85 0 1e-13
Xihx_0_85 a_xp0 a_xn0 wp_ih_0_85 wn_ih_0_85 xhp85 xhn85 vdd vbsyn gsyn
Xihx_1_85 a_xp1 a_xn1 wp_ih_1_85 wn_ih_1_85 xhp85 xhn85 vdd vbsyn gsyn
Xihx_2_85 a_xp2 a_xn2 wp_ih_2_85 wn_ih_2_85 xhp85 xhn85 vdd vbsyn gsyn
Xn85 xhp85 xhn85 ahp85 ahn85 vdd vbneu dneuron
Xcm_xh86 xhp86 xhn86 vdd cmld
Rnd_xh86 xhp86 xhn86 20k
Cxh86p xhp86 0 1e-13
Cxh86n xhn86 0 1e-13
Xihx_0_86 a_xp0 a_xn0 wp_ih_0_86 wn_ih_0_86 xhp86 xhn86 vdd vbsyn gsyn
Xihx_1_86 a_xp1 a_xn1 wp_ih_1_86 wn_ih_1_86 xhp86 xhn86 vdd vbsyn gsyn
Xihx_2_86 a_xp2 a_xn2 wp_ih_2_86 wn_ih_2_86 xhp86 xhn86 vdd vbsyn gsyn
Xn86 xhp86 xhn86 ahp86 ahn86 vdd vbneu dneuron
Xcm_xh87 xhp87 xhn87 vdd cmld
Rnd_xh87 xhp87 xhn87 20k
Cxh87p xhp87 0 1e-13
Cxh87n xhn87 0 1e-13
Xihx_0_87 a_xp0 a_xn0 wp_ih_0_87 wn_ih_0_87 xhp87 xhn87 vdd vbsyn gsyn
Xihx_1_87 a_xp1 a_xn1 wp_ih_1_87 wn_ih_1_87 xhp87 xhn87 vdd vbsyn gsyn
Xihx_2_87 a_xp2 a_xn2 wp_ih_2_87 wn_ih_2_87 xhp87 xhn87 vdd vbsyn gsyn
Xn87 xhp87 xhn87 ahp87 ahn87 vdd vbneu dneuron
Xcm_xh88 xhp88 xhn88 vdd cmld
Rnd_xh88 xhp88 xhn88 20k
Cxh88p xhp88 0 1e-13
Cxh88n xhn88 0 1e-13
Xihx_0_88 a_xp0 a_xn0 wp_ih_0_88 wn_ih_0_88 xhp88 xhn88 vdd vbsyn gsyn
Xihx_1_88 a_xp1 a_xn1 wp_ih_1_88 wn_ih_1_88 xhp88 xhn88 vdd vbsyn gsyn
Xihx_2_88 a_xp2 a_xn2 wp_ih_2_88 wn_ih_2_88 xhp88 xhn88 vdd vbsyn gsyn
Xn88 xhp88 xhn88 ahp88 ahn88 vdd vbneu dneuron
Xcm_xh89 xhp89 xhn89 vdd cmld
Rnd_xh89 xhp89 xhn89 20k
Cxh89p xhp89 0 1e-13
Cxh89n xhn89 0 1e-13
Xihx_0_89 a_xp0 a_xn0 wp_ih_0_89 wn_ih_0_89 xhp89 xhn89 vdd vbsyn gsyn
Xihx_1_89 a_xp1 a_xn1 wp_ih_1_89 wn_ih_1_89 xhp89 xhn89 vdd vbsyn gsyn
Xihx_2_89 a_xp2 a_xn2 wp_ih_2_89 wn_ih_2_89 xhp89 xhn89 vdd vbsyn gsyn
Xn89 xhp89 xhn89 ahp89 ahn89 vdd vbneu dneuron
Xcm_xh90 xhp90 xhn90 vdd cmld
Rnd_xh90 xhp90 xhn90 20k
Cxh90p xhp90 0 1e-13
Cxh90n xhn90 0 1e-13
Xihx_0_90 a_xp0 a_xn0 wp_ih_0_90 wn_ih_0_90 xhp90 xhn90 vdd vbsyn gsyn
Xihx_1_90 a_xp1 a_xn1 wp_ih_1_90 wn_ih_1_90 xhp90 xhn90 vdd vbsyn gsyn
Xihx_2_90 a_xp2 a_xn2 wp_ih_2_90 wn_ih_2_90 xhp90 xhn90 vdd vbsyn gsyn
Xn90 xhp90 xhn90 ahp90 ahn90 vdd vbneu dneuron
Xcm_xh91 xhp91 xhn91 vdd cmld
Rnd_xh91 xhp91 xhn91 20k
Cxh91p xhp91 0 1e-13
Cxh91n xhn91 0 1e-13
Xihx_0_91 a_xp0 a_xn0 wp_ih_0_91 wn_ih_0_91 xhp91 xhn91 vdd vbsyn gsyn
Xihx_1_91 a_xp1 a_xn1 wp_ih_1_91 wn_ih_1_91 xhp91 xhn91 vdd vbsyn gsyn
Xihx_2_91 a_xp2 a_xn2 wp_ih_2_91 wn_ih_2_91 xhp91 xhn91 vdd vbsyn gsyn
Xn91 xhp91 xhn91 ahp91 ahn91 vdd vbneu dneuron
Xcm_xh92 xhp92 xhn92 vdd cmld
Rnd_xh92 xhp92 xhn92 20k
Cxh92p xhp92 0 1e-13
Cxh92n xhn92 0 1e-13
Xihx_0_92 a_xp0 a_xn0 wp_ih_0_92 wn_ih_0_92 xhp92 xhn92 vdd vbsyn gsyn
Xihx_1_92 a_xp1 a_xn1 wp_ih_1_92 wn_ih_1_92 xhp92 xhn92 vdd vbsyn gsyn
Xihx_2_92 a_xp2 a_xn2 wp_ih_2_92 wn_ih_2_92 xhp92 xhn92 vdd vbsyn gsyn
Xn92 xhp92 xhn92 ahp92 ahn92 vdd vbneu dneuron
Xcm_xh93 xhp93 xhn93 vdd cmld
Rnd_xh93 xhp93 xhn93 20k
Cxh93p xhp93 0 1e-13
Cxh93n xhn93 0 1e-13
Xihx_0_93 a_xp0 a_xn0 wp_ih_0_93 wn_ih_0_93 xhp93 xhn93 vdd vbsyn gsyn
Xihx_1_93 a_xp1 a_xn1 wp_ih_1_93 wn_ih_1_93 xhp93 xhn93 vdd vbsyn gsyn
Xihx_2_93 a_xp2 a_xn2 wp_ih_2_93 wn_ih_2_93 xhp93 xhn93 vdd vbsyn gsyn
Xn93 xhp93 xhn93 ahp93 ahn93 vdd vbneu dneuron
Xcm_xh94 xhp94 xhn94 vdd cmld
Rnd_xh94 xhp94 xhn94 20k
Cxh94p xhp94 0 1e-13
Cxh94n xhn94 0 1e-13
Xihx_0_94 a_xp0 a_xn0 wp_ih_0_94 wn_ih_0_94 xhp94 xhn94 vdd vbsyn gsyn
Xihx_1_94 a_xp1 a_xn1 wp_ih_1_94 wn_ih_1_94 xhp94 xhn94 vdd vbsyn gsyn
Xihx_2_94 a_xp2 a_xn2 wp_ih_2_94 wn_ih_2_94 xhp94 xhn94 vdd vbsyn gsyn
Xn94 xhp94 xhn94 ahp94 ahn94 vdd vbneu dneuron
Xcm_xh95 xhp95 xhn95 vdd cmld
Rnd_xh95 xhp95 xhn95 20k
Cxh95p xhp95 0 1e-13
Cxh95n xhn95 0 1e-13
Xihx_0_95 a_xp0 a_xn0 wp_ih_0_95 wn_ih_0_95 xhp95 xhn95 vdd vbsyn gsyn
Xihx_1_95 a_xp1 a_xn1 wp_ih_1_95 wn_ih_1_95 xhp95 xhn95 vdd vbsyn gsyn
Xihx_2_95 a_xp2 a_xn2 wp_ih_2_95 wn_ih_2_95 xhp95 xhn95 vdd vbsyn gsyn
Xn95 xhp95 xhn95 ahp95 ahn95 vdd vbneu dneuron
Xcm_xh96 xhp96 xhn96 vdd cmld
Rnd_xh96 xhp96 xhn96 20k
Cxh96p xhp96 0 1e-13
Cxh96n xhn96 0 1e-13
Xihx_0_96 a_xp0 a_xn0 wp_ih_0_96 wn_ih_0_96 xhp96 xhn96 vdd vbsyn gsyn
Xihx_1_96 a_xp1 a_xn1 wp_ih_1_96 wn_ih_1_96 xhp96 xhn96 vdd vbsyn gsyn
Xihx_2_96 a_xp2 a_xn2 wp_ih_2_96 wn_ih_2_96 xhp96 xhn96 vdd vbsyn gsyn
Xn96 xhp96 xhn96 ahp96 ahn96 vdd vbneu dneuron
Xcm_xh97 xhp97 xhn97 vdd cmld
Rnd_xh97 xhp97 xhn97 20k
Cxh97p xhp97 0 1e-13
Cxh97n xhn97 0 1e-13
Xihx_0_97 a_xp0 a_xn0 wp_ih_0_97 wn_ih_0_97 xhp97 xhn97 vdd vbsyn gsyn
Xihx_1_97 a_xp1 a_xn1 wp_ih_1_97 wn_ih_1_97 xhp97 xhn97 vdd vbsyn gsyn
Xihx_2_97 a_xp2 a_xn2 wp_ih_2_97 wn_ih_2_97 xhp97 xhn97 vdd vbsyn gsyn
Xn97 xhp97 xhn97 ahp97 ahn97 vdd vbneu dneuron
Xcm_xh98 xhp98 xhn98 vdd cmld
Rnd_xh98 xhp98 xhn98 20k
Cxh98p xhp98 0 1e-13
Cxh98n xhn98 0 1e-13
Xihx_0_98 a_xp0 a_xn0 wp_ih_0_98 wn_ih_0_98 xhp98 xhn98 vdd vbsyn gsyn
Xihx_1_98 a_xp1 a_xn1 wp_ih_1_98 wn_ih_1_98 xhp98 xhn98 vdd vbsyn gsyn
Xihx_2_98 a_xp2 a_xn2 wp_ih_2_98 wn_ih_2_98 xhp98 xhn98 vdd vbsyn gsyn
Xn98 xhp98 xhn98 ahp98 ahn98 vdd vbneu dneuron
Xcm_xh99 xhp99 xhn99 vdd cmld
Rnd_xh99 xhp99 xhn99 20k
Cxh99p xhp99 0 1e-13
Cxh99n xhn99 0 1e-13
Xihx_0_99 a_xp0 a_xn0 wp_ih_0_99 wn_ih_0_99 xhp99 xhn99 vdd vbsyn gsyn
Xihx_1_99 a_xp1 a_xn1 wp_ih_1_99 wn_ih_1_99 xhp99 xhn99 vdd vbsyn gsyn
Xihx_2_99 a_xp2 a_xn2 wp_ih_2_99 wn_ih_2_99 xhp99 xhn99 vdd vbsyn gsyn
Xn99 xhp99 xhn99 ahp99 ahn99 vdd vbneu dneuron
Xcm_xh100 xhp100 xhn100 vdd cmld
Rnd_xh100 xhp100 xhn100 20k
Cxh100p xhp100 0 1e-13
Cxh100n xhn100 0 1e-13
Xihx_0_100 a_xp0 a_xn0 wp_ih_0_100 wn_ih_0_100 xhp100 xhn100 vdd vbsyn gsyn
Xihx_1_100 a_xp1 a_xn1 wp_ih_1_100 wn_ih_1_100 xhp100 xhn100 vdd vbsyn gsyn
Xihx_2_100 a_xp2 a_xn2 wp_ih_2_100 wn_ih_2_100 xhp100 xhn100 vdd vbsyn gsyn
Xn100 xhp100 xhn100 ahp100 ahn100 vdd vbneu dneuron
Xcm_xh101 xhp101 xhn101 vdd cmld
Rnd_xh101 xhp101 xhn101 20k
Cxh101p xhp101 0 1e-13
Cxh101n xhn101 0 1e-13
Xihx_0_101 a_xp0 a_xn0 wp_ih_0_101 wn_ih_0_101 xhp101 xhn101 vdd vbsyn gsyn
Xihx_1_101 a_xp1 a_xn1 wp_ih_1_101 wn_ih_1_101 xhp101 xhn101 vdd vbsyn gsyn
Xihx_2_101 a_xp2 a_xn2 wp_ih_2_101 wn_ih_2_101 xhp101 xhn101 vdd vbsyn gsyn
Xn101 xhp101 xhn101 ahp101 ahn101 vdd vbneu dneuron
Xcm_xh102 xhp102 xhn102 vdd cmld
Rnd_xh102 xhp102 xhn102 20k
Cxh102p xhp102 0 1e-13
Cxh102n xhn102 0 1e-13
Xihx_0_102 a_xp0 a_xn0 wp_ih_0_102 wn_ih_0_102 xhp102 xhn102 vdd vbsyn gsyn
Xihx_1_102 a_xp1 a_xn1 wp_ih_1_102 wn_ih_1_102 xhp102 xhn102 vdd vbsyn gsyn
Xihx_2_102 a_xp2 a_xn2 wp_ih_2_102 wn_ih_2_102 xhp102 xhn102 vdd vbsyn gsyn
Xn102 xhp102 xhn102 ahp102 ahn102 vdd vbneu dneuron
Xcm_xh103 xhp103 xhn103 vdd cmld
Rnd_xh103 xhp103 xhn103 20k
Cxh103p xhp103 0 1e-13
Cxh103n xhn103 0 1e-13
Xihx_0_103 a_xp0 a_xn0 wp_ih_0_103 wn_ih_0_103 xhp103 xhn103 vdd vbsyn gsyn
Xihx_1_103 a_xp1 a_xn1 wp_ih_1_103 wn_ih_1_103 xhp103 xhn103 vdd vbsyn gsyn
Xihx_2_103 a_xp2 a_xn2 wp_ih_2_103 wn_ih_2_103 xhp103 xhn103 vdd vbsyn gsyn
Xn103 xhp103 xhn103 ahp103 ahn103 vdd vbneu dneuron
Xcm_xh104 xhp104 xhn104 vdd cmld
Rnd_xh104 xhp104 xhn104 20k
Cxh104p xhp104 0 1e-13
Cxh104n xhn104 0 1e-13
Xihx_0_104 a_xp0 a_xn0 wp_ih_0_104 wn_ih_0_104 xhp104 xhn104 vdd vbsyn gsyn
Xihx_1_104 a_xp1 a_xn1 wp_ih_1_104 wn_ih_1_104 xhp104 xhn104 vdd vbsyn gsyn
Xihx_2_104 a_xp2 a_xn2 wp_ih_2_104 wn_ih_2_104 xhp104 xhn104 vdd vbsyn gsyn
Xn104 xhp104 xhn104 ahp104 ahn104 vdd vbneu dneuron
Xcm_xh105 xhp105 xhn105 vdd cmld
Rnd_xh105 xhp105 xhn105 20k
Cxh105p xhp105 0 1e-13
Cxh105n xhn105 0 1e-13
Xihx_0_105 a_xp0 a_xn0 wp_ih_0_105 wn_ih_0_105 xhp105 xhn105 vdd vbsyn gsyn
Xihx_1_105 a_xp1 a_xn1 wp_ih_1_105 wn_ih_1_105 xhp105 xhn105 vdd vbsyn gsyn
Xihx_2_105 a_xp2 a_xn2 wp_ih_2_105 wn_ih_2_105 xhp105 xhn105 vdd vbsyn gsyn
Xn105 xhp105 xhn105 ahp105 ahn105 vdd vbneu dneuron
Xcm_xh106 xhp106 xhn106 vdd cmld
Rnd_xh106 xhp106 xhn106 20k
Cxh106p xhp106 0 1e-13
Cxh106n xhn106 0 1e-13
Xihx_0_106 a_xp0 a_xn0 wp_ih_0_106 wn_ih_0_106 xhp106 xhn106 vdd vbsyn gsyn
Xihx_1_106 a_xp1 a_xn1 wp_ih_1_106 wn_ih_1_106 xhp106 xhn106 vdd vbsyn gsyn
Xihx_2_106 a_xp2 a_xn2 wp_ih_2_106 wn_ih_2_106 xhp106 xhn106 vdd vbsyn gsyn
Xn106 xhp106 xhn106 ahp106 ahn106 vdd vbneu dneuron
Xcm_xh107 xhp107 xhn107 vdd cmld
Rnd_xh107 xhp107 xhn107 20k
Cxh107p xhp107 0 1e-13
Cxh107n xhn107 0 1e-13
Xihx_0_107 a_xp0 a_xn0 wp_ih_0_107 wn_ih_0_107 xhp107 xhn107 vdd vbsyn gsyn
Xihx_1_107 a_xp1 a_xn1 wp_ih_1_107 wn_ih_1_107 xhp107 xhn107 vdd vbsyn gsyn
Xihx_2_107 a_xp2 a_xn2 wp_ih_2_107 wn_ih_2_107 xhp107 xhn107 vdd vbsyn gsyn
Xn107 xhp107 xhn107 ahp107 ahn107 vdd vbneu dneuron
Xcm_xh108 xhp108 xhn108 vdd cmld
Rnd_xh108 xhp108 xhn108 20k
Cxh108p xhp108 0 1e-13
Cxh108n xhn108 0 1e-13
Xihx_0_108 a_xp0 a_xn0 wp_ih_0_108 wn_ih_0_108 xhp108 xhn108 vdd vbsyn gsyn
Xihx_1_108 a_xp1 a_xn1 wp_ih_1_108 wn_ih_1_108 xhp108 xhn108 vdd vbsyn gsyn
Xihx_2_108 a_xp2 a_xn2 wp_ih_2_108 wn_ih_2_108 xhp108 xhn108 vdd vbsyn gsyn
Xn108 xhp108 xhn108 ahp108 ahn108 vdd vbneu dneuron
Xcm_xh109 xhp109 xhn109 vdd cmld
Rnd_xh109 xhp109 xhn109 20k
Cxh109p xhp109 0 1e-13
Cxh109n xhn109 0 1e-13
Xihx_0_109 a_xp0 a_xn0 wp_ih_0_109 wn_ih_0_109 xhp109 xhn109 vdd vbsyn gsyn
Xihx_1_109 a_xp1 a_xn1 wp_ih_1_109 wn_ih_1_109 xhp109 xhn109 vdd vbsyn gsyn
Xihx_2_109 a_xp2 a_xn2 wp_ih_2_109 wn_ih_2_109 xhp109 xhn109 vdd vbsyn gsyn
Xn109 xhp109 xhn109 ahp109 ahn109 vdd vbneu dneuron
Xcm_xh110 xhp110 xhn110 vdd cmld
Rnd_xh110 xhp110 xhn110 20k
Cxh110p xhp110 0 1e-13
Cxh110n xhn110 0 1e-13
Xihx_0_110 a_xp0 a_xn0 wp_ih_0_110 wn_ih_0_110 xhp110 xhn110 vdd vbsyn gsyn
Xihx_1_110 a_xp1 a_xn1 wp_ih_1_110 wn_ih_1_110 xhp110 xhn110 vdd vbsyn gsyn
Xihx_2_110 a_xp2 a_xn2 wp_ih_2_110 wn_ih_2_110 xhp110 xhn110 vdd vbsyn gsyn
Xn110 xhp110 xhn110 ahp110 ahn110 vdd vbneu dneuron
Xcm_xh111 xhp111 xhn111 vdd cmld
Rnd_xh111 xhp111 xhn111 20k
Cxh111p xhp111 0 1e-13
Cxh111n xhn111 0 1e-13
Xihx_0_111 a_xp0 a_xn0 wp_ih_0_111 wn_ih_0_111 xhp111 xhn111 vdd vbsyn gsyn
Xihx_1_111 a_xp1 a_xn1 wp_ih_1_111 wn_ih_1_111 xhp111 xhn111 vdd vbsyn gsyn
Xihx_2_111 a_xp2 a_xn2 wp_ih_2_111 wn_ih_2_111 xhp111 xhn111 vdd vbsyn gsyn
Xn111 xhp111 xhn111 ahp111 ahn111 vdd vbneu dneuron
Xcm_xh112 xhp112 xhn112 vdd cmld
Rnd_xh112 xhp112 xhn112 20k
Cxh112p xhp112 0 1e-13
Cxh112n xhn112 0 1e-13
Xihx_0_112 a_xp0 a_xn0 wp_ih_0_112 wn_ih_0_112 xhp112 xhn112 vdd vbsyn gsyn
Xihx_1_112 a_xp1 a_xn1 wp_ih_1_112 wn_ih_1_112 xhp112 xhn112 vdd vbsyn gsyn
Xihx_2_112 a_xp2 a_xn2 wp_ih_2_112 wn_ih_2_112 xhp112 xhn112 vdd vbsyn gsyn
Xn112 xhp112 xhn112 ahp112 ahn112 vdd vbneu dneuron
Xcm_xh113 xhp113 xhn113 vdd cmld
Rnd_xh113 xhp113 xhn113 20k
Cxh113p xhp113 0 1e-13
Cxh113n xhn113 0 1e-13
Xihx_0_113 a_xp0 a_xn0 wp_ih_0_113 wn_ih_0_113 xhp113 xhn113 vdd vbsyn gsyn
Xihx_1_113 a_xp1 a_xn1 wp_ih_1_113 wn_ih_1_113 xhp113 xhn113 vdd vbsyn gsyn
Xihx_2_113 a_xp2 a_xn2 wp_ih_2_113 wn_ih_2_113 xhp113 xhn113 vdd vbsyn gsyn
Xn113 xhp113 xhn113 ahp113 ahn113 vdd vbneu dneuron
Xcm_xh114 xhp114 xhn114 vdd cmld
Rnd_xh114 xhp114 xhn114 20k
Cxh114p xhp114 0 1e-13
Cxh114n xhn114 0 1e-13
Xihx_0_114 a_xp0 a_xn0 wp_ih_0_114 wn_ih_0_114 xhp114 xhn114 vdd vbsyn gsyn
Xihx_1_114 a_xp1 a_xn1 wp_ih_1_114 wn_ih_1_114 xhp114 xhn114 vdd vbsyn gsyn
Xihx_2_114 a_xp2 a_xn2 wp_ih_2_114 wn_ih_2_114 xhp114 xhn114 vdd vbsyn gsyn
Xn114 xhp114 xhn114 ahp114 ahn114 vdd vbneu dneuron
Xcm_xh115 xhp115 xhn115 vdd cmld
Rnd_xh115 xhp115 xhn115 20k
Cxh115p xhp115 0 1e-13
Cxh115n xhn115 0 1e-13
Xihx_0_115 a_xp0 a_xn0 wp_ih_0_115 wn_ih_0_115 xhp115 xhn115 vdd vbsyn gsyn
Xihx_1_115 a_xp1 a_xn1 wp_ih_1_115 wn_ih_1_115 xhp115 xhn115 vdd vbsyn gsyn
Xihx_2_115 a_xp2 a_xn2 wp_ih_2_115 wn_ih_2_115 xhp115 xhn115 vdd vbsyn gsyn
Xn115 xhp115 xhn115 ahp115 ahn115 vdd vbneu dneuron
Xcm_xh116 xhp116 xhn116 vdd cmld
Rnd_xh116 xhp116 xhn116 20k
Cxh116p xhp116 0 1e-13
Cxh116n xhn116 0 1e-13
Xihx_0_116 a_xp0 a_xn0 wp_ih_0_116 wn_ih_0_116 xhp116 xhn116 vdd vbsyn gsyn
Xihx_1_116 a_xp1 a_xn1 wp_ih_1_116 wn_ih_1_116 xhp116 xhn116 vdd vbsyn gsyn
Xihx_2_116 a_xp2 a_xn2 wp_ih_2_116 wn_ih_2_116 xhp116 xhn116 vdd vbsyn gsyn
Xn116 xhp116 xhn116 ahp116 ahn116 vdd vbneu dneuron
Xcm_xh117 xhp117 xhn117 vdd cmld
Rnd_xh117 xhp117 xhn117 20k
Cxh117p xhp117 0 1e-13
Cxh117n xhn117 0 1e-13
Xihx_0_117 a_xp0 a_xn0 wp_ih_0_117 wn_ih_0_117 xhp117 xhn117 vdd vbsyn gsyn
Xihx_1_117 a_xp1 a_xn1 wp_ih_1_117 wn_ih_1_117 xhp117 xhn117 vdd vbsyn gsyn
Xihx_2_117 a_xp2 a_xn2 wp_ih_2_117 wn_ih_2_117 xhp117 xhn117 vdd vbsyn gsyn
Xn117 xhp117 xhn117 ahp117 ahn117 vdd vbneu dneuron
Xcm_xh118 xhp118 xhn118 vdd cmld
Rnd_xh118 xhp118 xhn118 20k
Cxh118p xhp118 0 1e-13
Cxh118n xhn118 0 1e-13
Xihx_0_118 a_xp0 a_xn0 wp_ih_0_118 wn_ih_0_118 xhp118 xhn118 vdd vbsyn gsyn
Xihx_1_118 a_xp1 a_xn1 wp_ih_1_118 wn_ih_1_118 xhp118 xhn118 vdd vbsyn gsyn
Xihx_2_118 a_xp2 a_xn2 wp_ih_2_118 wn_ih_2_118 xhp118 xhn118 vdd vbsyn gsyn
Xn118 xhp118 xhn118 ahp118 ahn118 vdd vbneu dneuron
Xcm_xh119 xhp119 xhn119 vdd cmld
Rnd_xh119 xhp119 xhn119 20k
Cxh119p xhp119 0 1e-13
Cxh119n xhn119 0 1e-13
Xihx_0_119 a_xp0 a_xn0 wp_ih_0_119 wn_ih_0_119 xhp119 xhn119 vdd vbsyn gsyn
Xihx_1_119 a_xp1 a_xn1 wp_ih_1_119 wn_ih_1_119 xhp119 xhn119 vdd vbsyn gsyn
Xihx_2_119 a_xp2 a_xn2 wp_ih_2_119 wn_ih_2_119 xhp119 xhn119 vdd vbsyn gsyn
Xn119 xhp119 xhn119 ahp119 ahn119 vdd vbneu dneuron
Xcm_xh120 xhp120 xhn120 vdd cmld
Rnd_xh120 xhp120 xhn120 20k
Cxh120p xhp120 0 1e-13
Cxh120n xhn120 0 1e-13
Xihx_0_120 a_xp0 a_xn0 wp_ih_0_120 wn_ih_0_120 xhp120 xhn120 vdd vbsyn gsyn
Xihx_1_120 a_xp1 a_xn1 wp_ih_1_120 wn_ih_1_120 xhp120 xhn120 vdd vbsyn gsyn
Xihx_2_120 a_xp2 a_xn2 wp_ih_2_120 wn_ih_2_120 xhp120 xhn120 vdd vbsyn gsyn
Xn120 xhp120 xhn120 ahp120 ahn120 vdd vbneu dneuron
Xcm_xh121 xhp121 xhn121 vdd cmld
Rnd_xh121 xhp121 xhn121 20k
Cxh121p xhp121 0 1e-13
Cxh121n xhn121 0 1e-13
Xihx_0_121 a_xp0 a_xn0 wp_ih_0_121 wn_ih_0_121 xhp121 xhn121 vdd vbsyn gsyn
Xihx_1_121 a_xp1 a_xn1 wp_ih_1_121 wn_ih_1_121 xhp121 xhn121 vdd vbsyn gsyn
Xihx_2_121 a_xp2 a_xn2 wp_ih_2_121 wn_ih_2_121 xhp121 xhn121 vdd vbsyn gsyn
Xn121 xhp121 xhn121 ahp121 ahn121 vdd vbneu dneuron
Xcm_xh122 xhp122 xhn122 vdd cmld
Rnd_xh122 xhp122 xhn122 20k
Cxh122p xhp122 0 1e-13
Cxh122n xhn122 0 1e-13
Xihx_0_122 a_xp0 a_xn0 wp_ih_0_122 wn_ih_0_122 xhp122 xhn122 vdd vbsyn gsyn
Xihx_1_122 a_xp1 a_xn1 wp_ih_1_122 wn_ih_1_122 xhp122 xhn122 vdd vbsyn gsyn
Xihx_2_122 a_xp2 a_xn2 wp_ih_2_122 wn_ih_2_122 xhp122 xhn122 vdd vbsyn gsyn
Xn122 xhp122 xhn122 ahp122 ahn122 vdd vbneu dneuron
Xcm_xh123 xhp123 xhn123 vdd cmld
Rnd_xh123 xhp123 xhn123 20k
Cxh123p xhp123 0 1e-13
Cxh123n xhn123 0 1e-13
Xihx_0_123 a_xp0 a_xn0 wp_ih_0_123 wn_ih_0_123 xhp123 xhn123 vdd vbsyn gsyn
Xihx_1_123 a_xp1 a_xn1 wp_ih_1_123 wn_ih_1_123 xhp123 xhn123 vdd vbsyn gsyn
Xihx_2_123 a_xp2 a_xn2 wp_ih_2_123 wn_ih_2_123 xhp123 xhn123 vdd vbsyn gsyn
Xn123 xhp123 xhn123 ahp123 ahn123 vdd vbneu dneuron
Xcm_xh124 xhp124 xhn124 vdd cmld
Rnd_xh124 xhp124 xhn124 20k
Cxh124p xhp124 0 1e-13
Cxh124n xhn124 0 1e-13
Xihx_0_124 a_xp0 a_xn0 wp_ih_0_124 wn_ih_0_124 xhp124 xhn124 vdd vbsyn gsyn
Xihx_1_124 a_xp1 a_xn1 wp_ih_1_124 wn_ih_1_124 xhp124 xhn124 vdd vbsyn gsyn
Xihx_2_124 a_xp2 a_xn2 wp_ih_2_124 wn_ih_2_124 xhp124 xhn124 vdd vbsyn gsyn
Xn124 xhp124 xhn124 ahp124 ahn124 vdd vbneu dneuron
Xcm_xh125 xhp125 xhn125 vdd cmld
Rnd_xh125 xhp125 xhn125 20k
Cxh125p xhp125 0 1e-13
Cxh125n xhn125 0 1e-13
Xihx_0_125 a_xp0 a_xn0 wp_ih_0_125 wn_ih_0_125 xhp125 xhn125 vdd vbsyn gsyn
Xihx_1_125 a_xp1 a_xn1 wp_ih_1_125 wn_ih_1_125 xhp125 xhn125 vdd vbsyn gsyn
Xihx_2_125 a_xp2 a_xn2 wp_ih_2_125 wn_ih_2_125 xhp125 xhn125 vdd vbsyn gsyn
Xn125 xhp125 xhn125 ahp125 ahn125 vdd vbneu dneuron
Xcm_xh126 xhp126 xhn126 vdd cmld
Rnd_xh126 xhp126 xhn126 20k
Cxh126p xhp126 0 1e-13
Cxh126n xhn126 0 1e-13
Xihx_0_126 a_xp0 a_xn0 wp_ih_0_126 wn_ih_0_126 xhp126 xhn126 vdd vbsyn gsyn
Xihx_1_126 a_xp1 a_xn1 wp_ih_1_126 wn_ih_1_126 xhp126 xhn126 vdd vbsyn gsyn
Xihx_2_126 a_xp2 a_xn2 wp_ih_2_126 wn_ih_2_126 xhp126 xhn126 vdd vbsyn gsyn
Xn126 xhp126 xhn126 ahp126 ahn126 vdd vbneu dneuron
Xcm_xh127 xhp127 xhn127 vdd cmld
Rnd_xh127 xhp127 xhn127 20k
Cxh127p xhp127 0 1e-13
Cxh127n xhn127 0 1e-13
Xihx_0_127 a_xp0 a_xn0 wp_ih_0_127 wn_ih_0_127 xhp127 xhn127 vdd vbsyn gsyn
Xihx_1_127 a_xp1 a_xn1 wp_ih_1_127 wn_ih_1_127 xhp127 xhn127 vdd vbsyn gsyn
Xihx_2_127 a_xp2 a_xn2 wp_ih_2_127 wn_ih_2_127 xhp127 xhn127 vdd vbsyn gsyn
Xn127 xhp127 xhn127 ahp127 ahn127 vdd vbneu dneuron
Xcm_xh128 xhp128 xhn128 vdd cmld
Rnd_xh128 xhp128 xhn128 20k
Cxh128p xhp128 0 1e-13
Cxh128n xhn128 0 1e-13
Xihx_0_128 a_xp0 a_xn0 wp_ih_0_128 wn_ih_0_128 xhp128 xhn128 vdd vbsyn gsyn
Xihx_1_128 a_xp1 a_xn1 wp_ih_1_128 wn_ih_1_128 xhp128 xhn128 vdd vbsyn gsyn
Xihx_2_128 a_xp2 a_xn2 wp_ih_2_128 wn_ih_2_128 xhp128 xhn128 vdd vbsyn gsyn
Xn128 xhp128 xhn128 ahp128 ahn128 vdd vbneu dneuron
Xcm_xh129 xhp129 xhn129 vdd cmld
Rnd_xh129 xhp129 xhn129 20k
Cxh129p xhp129 0 1e-13
Cxh129n xhn129 0 1e-13
Xihx_0_129 a_xp0 a_xn0 wp_ih_0_129 wn_ih_0_129 xhp129 xhn129 vdd vbsyn gsyn
Xihx_1_129 a_xp1 a_xn1 wp_ih_1_129 wn_ih_1_129 xhp129 xhn129 vdd vbsyn gsyn
Xihx_2_129 a_xp2 a_xn2 wp_ih_2_129 wn_ih_2_129 xhp129 xhn129 vdd vbsyn gsyn
Xn129 xhp129 xhn129 ahp129 ahn129 vdd vbneu dneuron
Xcm_xh130 xhp130 xhn130 vdd cmld
Rnd_xh130 xhp130 xhn130 20k
Cxh130p xhp130 0 1e-13
Cxh130n xhn130 0 1e-13
Xihx_0_130 a_xp0 a_xn0 wp_ih_0_130 wn_ih_0_130 xhp130 xhn130 vdd vbsyn gsyn
Xihx_1_130 a_xp1 a_xn1 wp_ih_1_130 wn_ih_1_130 xhp130 xhn130 vdd vbsyn gsyn
Xihx_2_130 a_xp2 a_xn2 wp_ih_2_130 wn_ih_2_130 xhp130 xhn130 vdd vbsyn gsyn
Xn130 xhp130 xhn130 ahp130 ahn130 vdd vbneu dneuron
Xcm_xh131 xhp131 xhn131 vdd cmld
Rnd_xh131 xhp131 xhn131 20k
Cxh131p xhp131 0 1e-13
Cxh131n xhn131 0 1e-13
Xihx_0_131 a_xp0 a_xn0 wp_ih_0_131 wn_ih_0_131 xhp131 xhn131 vdd vbsyn gsyn
Xihx_1_131 a_xp1 a_xn1 wp_ih_1_131 wn_ih_1_131 xhp131 xhn131 vdd vbsyn gsyn
Xihx_2_131 a_xp2 a_xn2 wp_ih_2_131 wn_ih_2_131 xhp131 xhn131 vdd vbsyn gsyn
Xn131 xhp131 xhn131 ahp131 ahn131 vdd vbneu dneuron
Xcm_xh132 xhp132 xhn132 vdd cmld
Rnd_xh132 xhp132 xhn132 20k
Cxh132p xhp132 0 1e-13
Cxh132n xhn132 0 1e-13
Xihx_0_132 a_xp0 a_xn0 wp_ih_0_132 wn_ih_0_132 xhp132 xhn132 vdd vbsyn gsyn
Xihx_1_132 a_xp1 a_xn1 wp_ih_1_132 wn_ih_1_132 xhp132 xhn132 vdd vbsyn gsyn
Xihx_2_132 a_xp2 a_xn2 wp_ih_2_132 wn_ih_2_132 xhp132 xhn132 vdd vbsyn gsyn
Xn132 xhp132 xhn132 ahp132 ahn132 vdd vbneu dneuron
Xcm_xh133 xhp133 xhn133 vdd cmld
Rnd_xh133 xhp133 xhn133 20k
Cxh133p xhp133 0 1e-13
Cxh133n xhn133 0 1e-13
Xihx_0_133 a_xp0 a_xn0 wp_ih_0_133 wn_ih_0_133 xhp133 xhn133 vdd vbsyn gsyn
Xihx_1_133 a_xp1 a_xn1 wp_ih_1_133 wn_ih_1_133 xhp133 xhn133 vdd vbsyn gsyn
Xihx_2_133 a_xp2 a_xn2 wp_ih_2_133 wn_ih_2_133 xhp133 xhn133 vdd vbsyn gsyn
Xn133 xhp133 xhn133 ahp133 ahn133 vdd vbneu dneuron
Xcm_xh134 xhp134 xhn134 vdd cmld
Rnd_xh134 xhp134 xhn134 20k
Cxh134p xhp134 0 1e-13
Cxh134n xhn134 0 1e-13
Xihx_0_134 a_xp0 a_xn0 wp_ih_0_134 wn_ih_0_134 xhp134 xhn134 vdd vbsyn gsyn
Xihx_1_134 a_xp1 a_xn1 wp_ih_1_134 wn_ih_1_134 xhp134 xhn134 vdd vbsyn gsyn
Xihx_2_134 a_xp2 a_xn2 wp_ih_2_134 wn_ih_2_134 xhp134 xhn134 vdd vbsyn gsyn
Xn134 xhp134 xhn134 ahp134 ahn134 vdd vbneu dneuron
Xcm_xh135 xhp135 xhn135 vdd cmld
Rnd_xh135 xhp135 xhn135 20k
Cxh135p xhp135 0 1e-13
Cxh135n xhn135 0 1e-13
Xihx_0_135 a_xp0 a_xn0 wp_ih_0_135 wn_ih_0_135 xhp135 xhn135 vdd vbsyn gsyn
Xihx_1_135 a_xp1 a_xn1 wp_ih_1_135 wn_ih_1_135 xhp135 xhn135 vdd vbsyn gsyn
Xihx_2_135 a_xp2 a_xn2 wp_ih_2_135 wn_ih_2_135 xhp135 xhn135 vdd vbsyn gsyn
Xn135 xhp135 xhn135 ahp135 ahn135 vdd vbneu dneuron
Xcm_xh136 xhp136 xhn136 vdd cmld
Rnd_xh136 xhp136 xhn136 20k
Cxh136p xhp136 0 1e-13
Cxh136n xhn136 0 1e-13
Xihx_0_136 a_xp0 a_xn0 wp_ih_0_136 wn_ih_0_136 xhp136 xhn136 vdd vbsyn gsyn
Xihx_1_136 a_xp1 a_xn1 wp_ih_1_136 wn_ih_1_136 xhp136 xhn136 vdd vbsyn gsyn
Xihx_2_136 a_xp2 a_xn2 wp_ih_2_136 wn_ih_2_136 xhp136 xhn136 vdd vbsyn gsyn
Xn136 xhp136 xhn136 ahp136 ahn136 vdd vbneu dneuron
Xcm_xh137 xhp137 xhn137 vdd cmld
Rnd_xh137 xhp137 xhn137 20k
Cxh137p xhp137 0 1e-13
Cxh137n xhn137 0 1e-13
Xihx_0_137 a_xp0 a_xn0 wp_ih_0_137 wn_ih_0_137 xhp137 xhn137 vdd vbsyn gsyn
Xihx_1_137 a_xp1 a_xn1 wp_ih_1_137 wn_ih_1_137 xhp137 xhn137 vdd vbsyn gsyn
Xihx_2_137 a_xp2 a_xn2 wp_ih_2_137 wn_ih_2_137 xhp137 xhn137 vdd vbsyn gsyn
Xn137 xhp137 xhn137 ahp137 ahn137 vdd vbneu dneuron
Xcm_xh138 xhp138 xhn138 vdd cmld
Rnd_xh138 xhp138 xhn138 20k
Cxh138p xhp138 0 1e-13
Cxh138n xhn138 0 1e-13
Xihx_0_138 a_xp0 a_xn0 wp_ih_0_138 wn_ih_0_138 xhp138 xhn138 vdd vbsyn gsyn
Xihx_1_138 a_xp1 a_xn1 wp_ih_1_138 wn_ih_1_138 xhp138 xhn138 vdd vbsyn gsyn
Xihx_2_138 a_xp2 a_xn2 wp_ih_2_138 wn_ih_2_138 xhp138 xhn138 vdd vbsyn gsyn
Xn138 xhp138 xhn138 ahp138 ahn138 vdd vbneu dneuron
Xcm_xh139 xhp139 xhn139 vdd cmld
Rnd_xh139 xhp139 xhn139 20k
Cxh139p xhp139 0 1e-13
Cxh139n xhn139 0 1e-13
Xihx_0_139 a_xp0 a_xn0 wp_ih_0_139 wn_ih_0_139 xhp139 xhn139 vdd vbsyn gsyn
Xihx_1_139 a_xp1 a_xn1 wp_ih_1_139 wn_ih_1_139 xhp139 xhn139 vdd vbsyn gsyn
Xihx_2_139 a_xp2 a_xn2 wp_ih_2_139 wn_ih_2_139 xhp139 xhn139 vdd vbsyn gsyn
Xn139 xhp139 xhn139 ahp139 ahn139 vdd vbneu dneuron
Xcm_xh140 xhp140 xhn140 vdd cmld
Rnd_xh140 xhp140 xhn140 20k
Cxh140p xhp140 0 1e-13
Cxh140n xhn140 0 1e-13
Xihx_0_140 a_xp0 a_xn0 wp_ih_0_140 wn_ih_0_140 xhp140 xhn140 vdd vbsyn gsyn
Xihx_1_140 a_xp1 a_xn1 wp_ih_1_140 wn_ih_1_140 xhp140 xhn140 vdd vbsyn gsyn
Xihx_2_140 a_xp2 a_xn2 wp_ih_2_140 wn_ih_2_140 xhp140 xhn140 vdd vbsyn gsyn
Xn140 xhp140 xhn140 ahp140 ahn140 vdd vbneu dneuron
Xcm_xh141 xhp141 xhn141 vdd cmld
Rnd_xh141 xhp141 xhn141 20k
Cxh141p xhp141 0 1e-13
Cxh141n xhn141 0 1e-13
Xihx_0_141 a_xp0 a_xn0 wp_ih_0_141 wn_ih_0_141 xhp141 xhn141 vdd vbsyn gsyn
Xihx_1_141 a_xp1 a_xn1 wp_ih_1_141 wn_ih_1_141 xhp141 xhn141 vdd vbsyn gsyn
Xihx_2_141 a_xp2 a_xn2 wp_ih_2_141 wn_ih_2_141 xhp141 xhn141 vdd vbsyn gsyn
Xn141 xhp141 xhn141 ahp141 ahn141 vdd vbneu dneuron
Xcm_xh142 xhp142 xhn142 vdd cmld
Rnd_xh142 xhp142 xhn142 20k
Cxh142p xhp142 0 1e-13
Cxh142n xhn142 0 1e-13
Xihx_0_142 a_xp0 a_xn0 wp_ih_0_142 wn_ih_0_142 xhp142 xhn142 vdd vbsyn gsyn
Xihx_1_142 a_xp1 a_xn1 wp_ih_1_142 wn_ih_1_142 xhp142 xhn142 vdd vbsyn gsyn
Xihx_2_142 a_xp2 a_xn2 wp_ih_2_142 wn_ih_2_142 xhp142 xhn142 vdd vbsyn gsyn
Xn142 xhp142 xhn142 ahp142 ahn142 vdd vbneu dneuron
Xcm_xh143 xhp143 xhn143 vdd cmld
Rnd_xh143 xhp143 xhn143 20k
Cxh143p xhp143 0 1e-13
Cxh143n xhn143 0 1e-13
Xihx_0_143 a_xp0 a_xn0 wp_ih_0_143 wn_ih_0_143 xhp143 xhn143 vdd vbsyn gsyn
Xihx_1_143 a_xp1 a_xn1 wp_ih_1_143 wn_ih_1_143 xhp143 xhn143 vdd vbsyn gsyn
Xihx_2_143 a_xp2 a_xn2 wp_ih_2_143 wn_ih_2_143 xhp143 xhn143 vdd vbsyn gsyn
Xn143 xhp143 xhn143 ahp143 ahn143 vdd vbneu dneuron
Xcm_xh144 xhp144 xhn144 vdd cmld
Rnd_xh144 xhp144 xhn144 20k
Cxh144p xhp144 0 1e-13
Cxh144n xhn144 0 1e-13
Xihx_0_144 a_xp0 a_xn0 wp_ih_0_144 wn_ih_0_144 xhp144 xhn144 vdd vbsyn gsyn
Xihx_1_144 a_xp1 a_xn1 wp_ih_1_144 wn_ih_1_144 xhp144 xhn144 vdd vbsyn gsyn
Xihx_2_144 a_xp2 a_xn2 wp_ih_2_144 wn_ih_2_144 xhp144 xhn144 vdd vbsyn gsyn
Xn144 xhp144 xhn144 ahp144 ahn144 vdd vbneu dneuron
Xcm_xh145 xhp145 xhn145 vdd cmld
Rnd_xh145 xhp145 xhn145 20k
Cxh145p xhp145 0 1e-13
Cxh145n xhn145 0 1e-13
Xihx_0_145 a_xp0 a_xn0 wp_ih_0_145 wn_ih_0_145 xhp145 xhn145 vdd vbsyn gsyn
Xihx_1_145 a_xp1 a_xn1 wp_ih_1_145 wn_ih_1_145 xhp145 xhn145 vdd vbsyn gsyn
Xihx_2_145 a_xp2 a_xn2 wp_ih_2_145 wn_ih_2_145 xhp145 xhn145 vdd vbsyn gsyn
Xn145 xhp145 xhn145 ahp145 ahn145 vdd vbneu dneuron
Xcm_xh146 xhp146 xhn146 vdd cmld
Rnd_xh146 xhp146 xhn146 20k
Cxh146p xhp146 0 1e-13
Cxh146n xhn146 0 1e-13
Xihx_0_146 a_xp0 a_xn0 wp_ih_0_146 wn_ih_0_146 xhp146 xhn146 vdd vbsyn gsyn
Xihx_1_146 a_xp1 a_xn1 wp_ih_1_146 wn_ih_1_146 xhp146 xhn146 vdd vbsyn gsyn
Xihx_2_146 a_xp2 a_xn2 wp_ih_2_146 wn_ih_2_146 xhp146 xhn146 vdd vbsyn gsyn
Xn146 xhp146 xhn146 ahp146 ahn146 vdd vbneu dneuron
Xcm_xh147 xhp147 xhn147 vdd cmld
Rnd_xh147 xhp147 xhn147 20k
Cxh147p xhp147 0 1e-13
Cxh147n xhn147 0 1e-13
Xihx_0_147 a_xp0 a_xn0 wp_ih_0_147 wn_ih_0_147 xhp147 xhn147 vdd vbsyn gsyn
Xihx_1_147 a_xp1 a_xn1 wp_ih_1_147 wn_ih_1_147 xhp147 xhn147 vdd vbsyn gsyn
Xihx_2_147 a_xp2 a_xn2 wp_ih_2_147 wn_ih_2_147 xhp147 xhn147 vdd vbsyn gsyn
Xn147 xhp147 xhn147 ahp147 ahn147 vdd vbneu dneuron
Xcm_xh148 xhp148 xhn148 vdd cmld
Rnd_xh148 xhp148 xhn148 20k
Cxh148p xhp148 0 1e-13
Cxh148n xhn148 0 1e-13
Xihx_0_148 a_xp0 a_xn0 wp_ih_0_148 wn_ih_0_148 xhp148 xhn148 vdd vbsyn gsyn
Xihx_1_148 a_xp1 a_xn1 wp_ih_1_148 wn_ih_1_148 xhp148 xhn148 vdd vbsyn gsyn
Xihx_2_148 a_xp2 a_xn2 wp_ih_2_148 wn_ih_2_148 xhp148 xhn148 vdd vbsyn gsyn
Xn148 xhp148 xhn148 ahp148 ahn148 vdd vbneu dneuron
Xcm_xh149 xhp149 xhn149 vdd cmld
Rnd_xh149 xhp149 xhn149 20k
Cxh149p xhp149 0 1e-13
Cxh149n xhn149 0 1e-13
Xihx_0_149 a_xp0 a_xn0 wp_ih_0_149 wn_ih_0_149 xhp149 xhn149 vdd vbsyn gsyn
Xihx_1_149 a_xp1 a_xn1 wp_ih_1_149 wn_ih_1_149 xhp149 xhn149 vdd vbsyn gsyn
Xihx_2_149 a_xp2 a_xn2 wp_ih_2_149 wn_ih_2_149 xhp149 xhn149 vdd vbsyn gsyn
Xn149 xhp149 xhn149 ahp149 ahn149 vdd vbneu dneuron
Xcm_xh150 xhp150 xhn150 vdd cmld
Rnd_xh150 xhp150 xhn150 20k
Cxh150p xhp150 0 1e-13
Cxh150n xhn150 0 1e-13
Xihx_0_150 a_xp0 a_xn0 wp_ih_0_150 wn_ih_0_150 xhp150 xhn150 vdd vbsyn gsyn
Xihx_1_150 a_xp1 a_xn1 wp_ih_1_150 wn_ih_1_150 xhp150 xhn150 vdd vbsyn gsyn
Xihx_2_150 a_xp2 a_xn2 wp_ih_2_150 wn_ih_2_150 xhp150 xhn150 vdd vbsyn gsyn
Xn150 xhp150 xhn150 ahp150 ahn150 vdd vbneu dneuron
Xcm_xh151 xhp151 xhn151 vdd cmld
Rnd_xh151 xhp151 xhn151 20k
Cxh151p xhp151 0 1e-13
Cxh151n xhn151 0 1e-13
Xihx_0_151 a_xp0 a_xn0 wp_ih_0_151 wn_ih_0_151 xhp151 xhn151 vdd vbsyn gsyn
Xihx_1_151 a_xp1 a_xn1 wp_ih_1_151 wn_ih_1_151 xhp151 xhn151 vdd vbsyn gsyn
Xihx_2_151 a_xp2 a_xn2 wp_ih_2_151 wn_ih_2_151 xhp151 xhn151 vdd vbsyn gsyn
Xn151 xhp151 xhn151 ahp151 ahn151 vdd vbneu dneuron
Xcm_xh152 xhp152 xhn152 vdd cmld
Rnd_xh152 xhp152 xhn152 20k
Cxh152p xhp152 0 1e-13
Cxh152n xhn152 0 1e-13
Xihx_0_152 a_xp0 a_xn0 wp_ih_0_152 wn_ih_0_152 xhp152 xhn152 vdd vbsyn gsyn
Xihx_1_152 a_xp1 a_xn1 wp_ih_1_152 wn_ih_1_152 xhp152 xhn152 vdd vbsyn gsyn
Xihx_2_152 a_xp2 a_xn2 wp_ih_2_152 wn_ih_2_152 xhp152 xhn152 vdd vbsyn gsyn
Xn152 xhp152 xhn152 ahp152 ahn152 vdd vbneu dneuron
Xcm_xh153 xhp153 xhn153 vdd cmld
Rnd_xh153 xhp153 xhn153 20k
Cxh153p xhp153 0 1e-13
Cxh153n xhn153 0 1e-13
Xihx_0_153 a_xp0 a_xn0 wp_ih_0_153 wn_ih_0_153 xhp153 xhn153 vdd vbsyn gsyn
Xihx_1_153 a_xp1 a_xn1 wp_ih_1_153 wn_ih_1_153 xhp153 xhn153 vdd vbsyn gsyn
Xihx_2_153 a_xp2 a_xn2 wp_ih_2_153 wn_ih_2_153 xhp153 xhn153 vdd vbsyn gsyn
Xn153 xhp153 xhn153 ahp153 ahn153 vdd vbneu dneuron
Xcm_xh154 xhp154 xhn154 vdd cmld
Rnd_xh154 xhp154 xhn154 20k
Cxh154p xhp154 0 1e-13
Cxh154n xhn154 0 1e-13
Xihx_0_154 a_xp0 a_xn0 wp_ih_0_154 wn_ih_0_154 xhp154 xhn154 vdd vbsyn gsyn
Xihx_1_154 a_xp1 a_xn1 wp_ih_1_154 wn_ih_1_154 xhp154 xhn154 vdd vbsyn gsyn
Xihx_2_154 a_xp2 a_xn2 wp_ih_2_154 wn_ih_2_154 xhp154 xhn154 vdd vbsyn gsyn
Xn154 xhp154 xhn154 ahp154 ahn154 vdd vbneu dneuron
Xcm_xh155 xhp155 xhn155 vdd cmld
Rnd_xh155 xhp155 xhn155 20k
Cxh155p xhp155 0 1e-13
Cxh155n xhn155 0 1e-13
Xihx_0_155 a_xp0 a_xn0 wp_ih_0_155 wn_ih_0_155 xhp155 xhn155 vdd vbsyn gsyn
Xihx_1_155 a_xp1 a_xn1 wp_ih_1_155 wn_ih_1_155 xhp155 xhn155 vdd vbsyn gsyn
Xihx_2_155 a_xp2 a_xn2 wp_ih_2_155 wn_ih_2_155 xhp155 xhn155 vdd vbsyn gsyn
Xn155 xhp155 xhn155 ahp155 ahn155 vdd vbneu dneuron
Xcm_xh156 xhp156 xhn156 vdd cmld
Rnd_xh156 xhp156 xhn156 20k
Cxh156p xhp156 0 1e-13
Cxh156n xhn156 0 1e-13
Xihx_0_156 a_xp0 a_xn0 wp_ih_0_156 wn_ih_0_156 xhp156 xhn156 vdd vbsyn gsyn
Xihx_1_156 a_xp1 a_xn1 wp_ih_1_156 wn_ih_1_156 xhp156 xhn156 vdd vbsyn gsyn
Xihx_2_156 a_xp2 a_xn2 wp_ih_2_156 wn_ih_2_156 xhp156 xhn156 vdd vbsyn gsyn
Xn156 xhp156 xhn156 ahp156 ahn156 vdd vbneu dneuron
Xcm_xh157 xhp157 xhn157 vdd cmld
Rnd_xh157 xhp157 xhn157 20k
Cxh157p xhp157 0 1e-13
Cxh157n xhn157 0 1e-13
Xihx_0_157 a_xp0 a_xn0 wp_ih_0_157 wn_ih_0_157 xhp157 xhn157 vdd vbsyn gsyn
Xihx_1_157 a_xp1 a_xn1 wp_ih_1_157 wn_ih_1_157 xhp157 xhn157 vdd vbsyn gsyn
Xihx_2_157 a_xp2 a_xn2 wp_ih_2_157 wn_ih_2_157 xhp157 xhn157 vdd vbsyn gsyn
Xn157 xhp157 xhn157 ahp157 ahn157 vdd vbneu dneuron
Xcm_xh158 xhp158 xhn158 vdd cmld
Rnd_xh158 xhp158 xhn158 20k
Cxh158p xhp158 0 1e-13
Cxh158n xhn158 0 1e-13
Xihx_0_158 a_xp0 a_xn0 wp_ih_0_158 wn_ih_0_158 xhp158 xhn158 vdd vbsyn gsyn
Xihx_1_158 a_xp1 a_xn1 wp_ih_1_158 wn_ih_1_158 xhp158 xhn158 vdd vbsyn gsyn
Xihx_2_158 a_xp2 a_xn2 wp_ih_2_158 wn_ih_2_158 xhp158 xhn158 vdd vbsyn gsyn
Xn158 xhp158 xhn158 ahp158 ahn158 vdd vbneu dneuron
Xcm_xh159 xhp159 xhn159 vdd cmld
Rnd_xh159 xhp159 xhn159 20k
Cxh159p xhp159 0 1e-13
Cxh159n xhn159 0 1e-13
Xihx_0_159 a_xp0 a_xn0 wp_ih_0_159 wn_ih_0_159 xhp159 xhn159 vdd vbsyn gsyn
Xihx_1_159 a_xp1 a_xn1 wp_ih_1_159 wn_ih_1_159 xhp159 xhn159 vdd vbsyn gsyn
Xihx_2_159 a_xp2 a_xn2 wp_ih_2_159 wn_ih_2_159 xhp159 xhn159 vdd vbsyn gsyn
Xn159 xhp159 xhn159 ahp159 ahn159 vdd vbneu dneuron
Xcm_xh160 xhp160 xhn160 vdd cmld
Rnd_xh160 xhp160 xhn160 20k
Cxh160p xhp160 0 1e-13
Cxh160n xhn160 0 1e-13
Xihx_0_160 a_xp0 a_xn0 wp_ih_0_160 wn_ih_0_160 xhp160 xhn160 vdd vbsyn gsyn
Xihx_1_160 a_xp1 a_xn1 wp_ih_1_160 wn_ih_1_160 xhp160 xhn160 vdd vbsyn gsyn
Xihx_2_160 a_xp2 a_xn2 wp_ih_2_160 wn_ih_2_160 xhp160 xhn160 vdd vbsyn gsyn
Xn160 xhp160 xhn160 ahp160 ahn160 vdd vbneu dneuron
Xcm_xh161 xhp161 xhn161 vdd cmld
Rnd_xh161 xhp161 xhn161 20k
Cxh161p xhp161 0 1e-13
Cxh161n xhn161 0 1e-13
Xihx_0_161 a_xp0 a_xn0 wp_ih_0_161 wn_ih_0_161 xhp161 xhn161 vdd vbsyn gsyn
Xihx_1_161 a_xp1 a_xn1 wp_ih_1_161 wn_ih_1_161 xhp161 xhn161 vdd vbsyn gsyn
Xihx_2_161 a_xp2 a_xn2 wp_ih_2_161 wn_ih_2_161 xhp161 xhn161 vdd vbsyn gsyn
Xn161 xhp161 xhn161 ahp161 ahn161 vdd vbneu dneuron
Xcm_xh162 xhp162 xhn162 vdd cmld
Rnd_xh162 xhp162 xhn162 20k
Cxh162p xhp162 0 1e-13
Cxh162n xhn162 0 1e-13
Xihx_0_162 a_xp0 a_xn0 wp_ih_0_162 wn_ih_0_162 xhp162 xhn162 vdd vbsyn gsyn
Xihx_1_162 a_xp1 a_xn1 wp_ih_1_162 wn_ih_1_162 xhp162 xhn162 vdd vbsyn gsyn
Xihx_2_162 a_xp2 a_xn2 wp_ih_2_162 wn_ih_2_162 xhp162 xhn162 vdd vbsyn gsyn
Xn162 xhp162 xhn162 ahp162 ahn162 vdd vbneu dneuron
Xcm_xh163 xhp163 xhn163 vdd cmld
Rnd_xh163 xhp163 xhn163 20k
Cxh163p xhp163 0 1e-13
Cxh163n xhn163 0 1e-13
Xihx_0_163 a_xp0 a_xn0 wp_ih_0_163 wn_ih_0_163 xhp163 xhn163 vdd vbsyn gsyn
Xihx_1_163 a_xp1 a_xn1 wp_ih_1_163 wn_ih_1_163 xhp163 xhn163 vdd vbsyn gsyn
Xihx_2_163 a_xp2 a_xn2 wp_ih_2_163 wn_ih_2_163 xhp163 xhn163 vdd vbsyn gsyn
Xn163 xhp163 xhn163 ahp163 ahn163 vdd vbneu dneuron
Xcm_xh164 xhp164 xhn164 vdd cmld
Rnd_xh164 xhp164 xhn164 20k
Cxh164p xhp164 0 1e-13
Cxh164n xhn164 0 1e-13
Xihx_0_164 a_xp0 a_xn0 wp_ih_0_164 wn_ih_0_164 xhp164 xhn164 vdd vbsyn gsyn
Xihx_1_164 a_xp1 a_xn1 wp_ih_1_164 wn_ih_1_164 xhp164 xhn164 vdd vbsyn gsyn
Xihx_2_164 a_xp2 a_xn2 wp_ih_2_164 wn_ih_2_164 xhp164 xhn164 vdd vbsyn gsyn
Xn164 xhp164 xhn164 ahp164 ahn164 vdd vbneu dneuron
Xcm_xh165 xhp165 xhn165 vdd cmld
Rnd_xh165 xhp165 xhn165 20k
Cxh165p xhp165 0 1e-13
Cxh165n xhn165 0 1e-13
Xihx_0_165 a_xp0 a_xn0 wp_ih_0_165 wn_ih_0_165 xhp165 xhn165 vdd vbsyn gsyn
Xihx_1_165 a_xp1 a_xn1 wp_ih_1_165 wn_ih_1_165 xhp165 xhn165 vdd vbsyn gsyn
Xihx_2_165 a_xp2 a_xn2 wp_ih_2_165 wn_ih_2_165 xhp165 xhn165 vdd vbsyn gsyn
Xn165 xhp165 xhn165 ahp165 ahn165 vdd vbneu dneuron
Xcm_xh166 xhp166 xhn166 vdd cmld
Rnd_xh166 xhp166 xhn166 20k
Cxh166p xhp166 0 1e-13
Cxh166n xhn166 0 1e-13
Xihx_0_166 a_xp0 a_xn0 wp_ih_0_166 wn_ih_0_166 xhp166 xhn166 vdd vbsyn gsyn
Xihx_1_166 a_xp1 a_xn1 wp_ih_1_166 wn_ih_1_166 xhp166 xhn166 vdd vbsyn gsyn
Xihx_2_166 a_xp2 a_xn2 wp_ih_2_166 wn_ih_2_166 xhp166 xhn166 vdd vbsyn gsyn
Xn166 xhp166 xhn166 ahp166 ahn166 vdd vbneu dneuron
Xcm_xh167 xhp167 xhn167 vdd cmld
Rnd_xh167 xhp167 xhn167 20k
Cxh167p xhp167 0 1e-13
Cxh167n xhn167 0 1e-13
Xihx_0_167 a_xp0 a_xn0 wp_ih_0_167 wn_ih_0_167 xhp167 xhn167 vdd vbsyn gsyn
Xihx_1_167 a_xp1 a_xn1 wp_ih_1_167 wn_ih_1_167 xhp167 xhn167 vdd vbsyn gsyn
Xihx_2_167 a_xp2 a_xn2 wp_ih_2_167 wn_ih_2_167 xhp167 xhn167 vdd vbsyn gsyn
Xn167 xhp167 xhn167 ahp167 ahn167 vdd vbneu dneuron
Xcm_xh168 xhp168 xhn168 vdd cmld
Rnd_xh168 xhp168 xhn168 20k
Cxh168p xhp168 0 1e-13
Cxh168n xhn168 0 1e-13
Xihx_0_168 a_xp0 a_xn0 wp_ih_0_168 wn_ih_0_168 xhp168 xhn168 vdd vbsyn gsyn
Xihx_1_168 a_xp1 a_xn1 wp_ih_1_168 wn_ih_1_168 xhp168 xhn168 vdd vbsyn gsyn
Xihx_2_168 a_xp2 a_xn2 wp_ih_2_168 wn_ih_2_168 xhp168 xhn168 vdd vbsyn gsyn
Xn168 xhp168 xhn168 ahp168 ahn168 vdd vbneu dneuron
Xcm_xh169 xhp169 xhn169 vdd cmld
Rnd_xh169 xhp169 xhn169 20k
Cxh169p xhp169 0 1e-13
Cxh169n xhn169 0 1e-13
Xihx_0_169 a_xp0 a_xn0 wp_ih_0_169 wn_ih_0_169 xhp169 xhn169 vdd vbsyn gsyn
Xihx_1_169 a_xp1 a_xn1 wp_ih_1_169 wn_ih_1_169 xhp169 xhn169 vdd vbsyn gsyn
Xihx_2_169 a_xp2 a_xn2 wp_ih_2_169 wn_ih_2_169 xhp169 xhn169 vdd vbsyn gsyn
Xn169 xhp169 xhn169 ahp169 ahn169 vdd vbneu dneuron
Xcm_xh170 xhp170 xhn170 vdd cmld
Rnd_xh170 xhp170 xhn170 20k
Cxh170p xhp170 0 1e-13
Cxh170n xhn170 0 1e-13
Xihx_0_170 a_xp0 a_xn0 wp_ih_0_170 wn_ih_0_170 xhp170 xhn170 vdd vbsyn gsyn
Xihx_1_170 a_xp1 a_xn1 wp_ih_1_170 wn_ih_1_170 xhp170 xhn170 vdd vbsyn gsyn
Xihx_2_170 a_xp2 a_xn2 wp_ih_2_170 wn_ih_2_170 xhp170 xhn170 vdd vbsyn gsyn
Xn170 xhp170 xhn170 ahp170 ahn170 vdd vbneu dneuron
Xcm_xh171 xhp171 xhn171 vdd cmld
Rnd_xh171 xhp171 xhn171 20k
Cxh171p xhp171 0 1e-13
Cxh171n xhn171 0 1e-13
Xihx_0_171 a_xp0 a_xn0 wp_ih_0_171 wn_ih_0_171 xhp171 xhn171 vdd vbsyn gsyn
Xihx_1_171 a_xp1 a_xn1 wp_ih_1_171 wn_ih_1_171 xhp171 xhn171 vdd vbsyn gsyn
Xihx_2_171 a_xp2 a_xn2 wp_ih_2_171 wn_ih_2_171 xhp171 xhn171 vdd vbsyn gsyn
Xn171 xhp171 xhn171 ahp171 ahn171 vdd vbneu dneuron
Xcm_xh172 xhp172 xhn172 vdd cmld
Rnd_xh172 xhp172 xhn172 20k
Cxh172p xhp172 0 1e-13
Cxh172n xhn172 0 1e-13
Xihx_0_172 a_xp0 a_xn0 wp_ih_0_172 wn_ih_0_172 xhp172 xhn172 vdd vbsyn gsyn
Xihx_1_172 a_xp1 a_xn1 wp_ih_1_172 wn_ih_1_172 xhp172 xhn172 vdd vbsyn gsyn
Xihx_2_172 a_xp2 a_xn2 wp_ih_2_172 wn_ih_2_172 xhp172 xhn172 vdd vbsyn gsyn
Xn172 xhp172 xhn172 ahp172 ahn172 vdd vbneu dneuron
Xcm_xh173 xhp173 xhn173 vdd cmld
Rnd_xh173 xhp173 xhn173 20k
Cxh173p xhp173 0 1e-13
Cxh173n xhn173 0 1e-13
Xihx_0_173 a_xp0 a_xn0 wp_ih_0_173 wn_ih_0_173 xhp173 xhn173 vdd vbsyn gsyn
Xihx_1_173 a_xp1 a_xn1 wp_ih_1_173 wn_ih_1_173 xhp173 xhn173 vdd vbsyn gsyn
Xihx_2_173 a_xp2 a_xn2 wp_ih_2_173 wn_ih_2_173 xhp173 xhn173 vdd vbsyn gsyn
Xn173 xhp173 xhn173 ahp173 ahn173 vdd vbneu dneuron
Xcm_xh174 xhp174 xhn174 vdd cmld
Rnd_xh174 xhp174 xhn174 20k
Cxh174p xhp174 0 1e-13
Cxh174n xhn174 0 1e-13
Xihx_0_174 a_xp0 a_xn0 wp_ih_0_174 wn_ih_0_174 xhp174 xhn174 vdd vbsyn gsyn
Xihx_1_174 a_xp1 a_xn1 wp_ih_1_174 wn_ih_1_174 xhp174 xhn174 vdd vbsyn gsyn
Xihx_2_174 a_xp2 a_xn2 wp_ih_2_174 wn_ih_2_174 xhp174 xhn174 vdd vbsyn gsyn
Xn174 xhp174 xhn174 ahp174 ahn174 vdd vbneu dneuron
Xcm_xh175 xhp175 xhn175 vdd cmld
Rnd_xh175 xhp175 xhn175 20k
Cxh175p xhp175 0 1e-13
Cxh175n xhn175 0 1e-13
Xihx_0_175 a_xp0 a_xn0 wp_ih_0_175 wn_ih_0_175 xhp175 xhn175 vdd vbsyn gsyn
Xihx_1_175 a_xp1 a_xn1 wp_ih_1_175 wn_ih_1_175 xhp175 xhn175 vdd vbsyn gsyn
Xihx_2_175 a_xp2 a_xn2 wp_ih_2_175 wn_ih_2_175 xhp175 xhn175 vdd vbsyn gsyn
Xn175 xhp175 xhn175 ahp175 ahn175 vdd vbneu dneuron
Xcm_xh176 xhp176 xhn176 vdd cmld
Rnd_xh176 xhp176 xhn176 20k
Cxh176p xhp176 0 1e-13
Cxh176n xhn176 0 1e-13
Xihx_0_176 a_xp0 a_xn0 wp_ih_0_176 wn_ih_0_176 xhp176 xhn176 vdd vbsyn gsyn
Xihx_1_176 a_xp1 a_xn1 wp_ih_1_176 wn_ih_1_176 xhp176 xhn176 vdd vbsyn gsyn
Xihx_2_176 a_xp2 a_xn2 wp_ih_2_176 wn_ih_2_176 xhp176 xhn176 vdd vbsyn gsyn
Xn176 xhp176 xhn176 ahp176 ahn176 vdd vbneu dneuron
Xcm_xh177 xhp177 xhn177 vdd cmld
Rnd_xh177 xhp177 xhn177 20k
Cxh177p xhp177 0 1e-13
Cxh177n xhn177 0 1e-13
Xihx_0_177 a_xp0 a_xn0 wp_ih_0_177 wn_ih_0_177 xhp177 xhn177 vdd vbsyn gsyn
Xihx_1_177 a_xp1 a_xn1 wp_ih_1_177 wn_ih_1_177 xhp177 xhn177 vdd vbsyn gsyn
Xihx_2_177 a_xp2 a_xn2 wp_ih_2_177 wn_ih_2_177 xhp177 xhn177 vdd vbsyn gsyn
Xn177 xhp177 xhn177 ahp177 ahn177 vdd vbneu dneuron
Xcm_xh178 xhp178 xhn178 vdd cmld
Rnd_xh178 xhp178 xhn178 20k
Cxh178p xhp178 0 1e-13
Cxh178n xhn178 0 1e-13
Xihx_0_178 a_xp0 a_xn0 wp_ih_0_178 wn_ih_0_178 xhp178 xhn178 vdd vbsyn gsyn
Xihx_1_178 a_xp1 a_xn1 wp_ih_1_178 wn_ih_1_178 xhp178 xhn178 vdd vbsyn gsyn
Xihx_2_178 a_xp2 a_xn2 wp_ih_2_178 wn_ih_2_178 xhp178 xhn178 vdd vbsyn gsyn
Xn178 xhp178 xhn178 ahp178 ahn178 vdd vbneu dneuron
Xcm_xh179 xhp179 xhn179 vdd cmld
Rnd_xh179 xhp179 xhn179 20k
Cxh179p xhp179 0 1e-13
Cxh179n xhn179 0 1e-13
Xihx_0_179 a_xp0 a_xn0 wp_ih_0_179 wn_ih_0_179 xhp179 xhn179 vdd vbsyn gsyn
Xihx_1_179 a_xp1 a_xn1 wp_ih_1_179 wn_ih_1_179 xhp179 xhn179 vdd vbsyn gsyn
Xihx_2_179 a_xp2 a_xn2 wp_ih_2_179 wn_ih_2_179 xhp179 xhn179 vdd vbsyn gsyn
Xn179 xhp179 xhn179 ahp179 ahn179 vdd vbneu dneuron
Xcm_xh180 xhp180 xhn180 vdd cmld
Rnd_xh180 xhp180 xhn180 20k
Cxh180p xhp180 0 1e-13
Cxh180n xhn180 0 1e-13
Xihx_0_180 a_xp0 a_xn0 wp_ih_0_180 wn_ih_0_180 xhp180 xhn180 vdd vbsyn gsyn
Xihx_1_180 a_xp1 a_xn1 wp_ih_1_180 wn_ih_1_180 xhp180 xhn180 vdd vbsyn gsyn
Xihx_2_180 a_xp2 a_xn2 wp_ih_2_180 wn_ih_2_180 xhp180 xhn180 vdd vbsyn gsyn
Xn180 xhp180 xhn180 ahp180 ahn180 vdd vbneu dneuron
Xcm_xh181 xhp181 xhn181 vdd cmld
Rnd_xh181 xhp181 xhn181 20k
Cxh181p xhp181 0 1e-13
Cxh181n xhn181 0 1e-13
Xihx_0_181 a_xp0 a_xn0 wp_ih_0_181 wn_ih_0_181 xhp181 xhn181 vdd vbsyn gsyn
Xihx_1_181 a_xp1 a_xn1 wp_ih_1_181 wn_ih_1_181 xhp181 xhn181 vdd vbsyn gsyn
Xihx_2_181 a_xp2 a_xn2 wp_ih_2_181 wn_ih_2_181 xhp181 xhn181 vdd vbsyn gsyn
Xn181 xhp181 xhn181 ahp181 ahn181 vdd vbneu dneuron
Xcm_xh182 xhp182 xhn182 vdd cmld
Rnd_xh182 xhp182 xhn182 20k
Cxh182p xhp182 0 1e-13
Cxh182n xhn182 0 1e-13
Xihx_0_182 a_xp0 a_xn0 wp_ih_0_182 wn_ih_0_182 xhp182 xhn182 vdd vbsyn gsyn
Xihx_1_182 a_xp1 a_xn1 wp_ih_1_182 wn_ih_1_182 xhp182 xhn182 vdd vbsyn gsyn
Xihx_2_182 a_xp2 a_xn2 wp_ih_2_182 wn_ih_2_182 xhp182 xhn182 vdd vbsyn gsyn
Xn182 xhp182 xhn182 ahp182 ahn182 vdd vbneu dneuron
Xcm_xh183 xhp183 xhn183 vdd cmld
Rnd_xh183 xhp183 xhn183 20k
Cxh183p xhp183 0 1e-13
Cxh183n xhn183 0 1e-13
Xihx_0_183 a_xp0 a_xn0 wp_ih_0_183 wn_ih_0_183 xhp183 xhn183 vdd vbsyn gsyn
Xihx_1_183 a_xp1 a_xn1 wp_ih_1_183 wn_ih_1_183 xhp183 xhn183 vdd vbsyn gsyn
Xihx_2_183 a_xp2 a_xn2 wp_ih_2_183 wn_ih_2_183 xhp183 xhn183 vdd vbsyn gsyn
Xn183 xhp183 xhn183 ahp183 ahn183 vdd vbneu dneuron
Xcm_xh184 xhp184 xhn184 vdd cmld
Rnd_xh184 xhp184 xhn184 20k
Cxh184p xhp184 0 1e-13
Cxh184n xhn184 0 1e-13
Xihx_0_184 a_xp0 a_xn0 wp_ih_0_184 wn_ih_0_184 xhp184 xhn184 vdd vbsyn gsyn
Xihx_1_184 a_xp1 a_xn1 wp_ih_1_184 wn_ih_1_184 xhp184 xhn184 vdd vbsyn gsyn
Xihx_2_184 a_xp2 a_xn2 wp_ih_2_184 wn_ih_2_184 xhp184 xhn184 vdd vbsyn gsyn
Xn184 xhp184 xhn184 ahp184 ahn184 vdd vbneu dneuron
Xcm_xh185 xhp185 xhn185 vdd cmld
Rnd_xh185 xhp185 xhn185 20k
Cxh185p xhp185 0 1e-13
Cxh185n xhn185 0 1e-13
Xihx_0_185 a_xp0 a_xn0 wp_ih_0_185 wn_ih_0_185 xhp185 xhn185 vdd vbsyn gsyn
Xihx_1_185 a_xp1 a_xn1 wp_ih_1_185 wn_ih_1_185 xhp185 xhn185 vdd vbsyn gsyn
Xihx_2_185 a_xp2 a_xn2 wp_ih_2_185 wn_ih_2_185 xhp185 xhn185 vdd vbsyn gsyn
Xn185 xhp185 xhn185 ahp185 ahn185 vdd vbneu dneuron
Xcm_xh186 xhp186 xhn186 vdd cmld
Rnd_xh186 xhp186 xhn186 20k
Cxh186p xhp186 0 1e-13
Cxh186n xhn186 0 1e-13
Xihx_0_186 a_xp0 a_xn0 wp_ih_0_186 wn_ih_0_186 xhp186 xhn186 vdd vbsyn gsyn
Xihx_1_186 a_xp1 a_xn1 wp_ih_1_186 wn_ih_1_186 xhp186 xhn186 vdd vbsyn gsyn
Xihx_2_186 a_xp2 a_xn2 wp_ih_2_186 wn_ih_2_186 xhp186 xhn186 vdd vbsyn gsyn
Xn186 xhp186 xhn186 ahp186 ahn186 vdd vbneu dneuron
Xcm_xh187 xhp187 xhn187 vdd cmld
Rnd_xh187 xhp187 xhn187 20k
Cxh187p xhp187 0 1e-13
Cxh187n xhn187 0 1e-13
Xihx_0_187 a_xp0 a_xn0 wp_ih_0_187 wn_ih_0_187 xhp187 xhn187 vdd vbsyn gsyn
Xihx_1_187 a_xp1 a_xn1 wp_ih_1_187 wn_ih_1_187 xhp187 xhn187 vdd vbsyn gsyn
Xihx_2_187 a_xp2 a_xn2 wp_ih_2_187 wn_ih_2_187 xhp187 xhn187 vdd vbsyn gsyn
Xn187 xhp187 xhn187 ahp187 ahn187 vdd vbneu dneuron
Xcm_xh188 xhp188 xhn188 vdd cmld
Rnd_xh188 xhp188 xhn188 20k
Cxh188p xhp188 0 1e-13
Cxh188n xhn188 0 1e-13
Xihx_0_188 a_xp0 a_xn0 wp_ih_0_188 wn_ih_0_188 xhp188 xhn188 vdd vbsyn gsyn
Xihx_1_188 a_xp1 a_xn1 wp_ih_1_188 wn_ih_1_188 xhp188 xhn188 vdd vbsyn gsyn
Xihx_2_188 a_xp2 a_xn2 wp_ih_2_188 wn_ih_2_188 xhp188 xhn188 vdd vbsyn gsyn
Xn188 xhp188 xhn188 ahp188 ahn188 vdd vbneu dneuron
Xcm_xh189 xhp189 xhn189 vdd cmld
Rnd_xh189 xhp189 xhn189 20k
Cxh189p xhp189 0 1e-13
Cxh189n xhn189 0 1e-13
Xihx_0_189 a_xp0 a_xn0 wp_ih_0_189 wn_ih_0_189 xhp189 xhn189 vdd vbsyn gsyn
Xihx_1_189 a_xp1 a_xn1 wp_ih_1_189 wn_ih_1_189 xhp189 xhn189 vdd vbsyn gsyn
Xihx_2_189 a_xp2 a_xn2 wp_ih_2_189 wn_ih_2_189 xhp189 xhn189 vdd vbsyn gsyn
Xn189 xhp189 xhn189 ahp189 ahn189 vdd vbneu dneuron
Xcm_xh190 xhp190 xhn190 vdd cmld
Rnd_xh190 xhp190 xhn190 20k
Cxh190p xhp190 0 1e-13
Cxh190n xhn190 0 1e-13
Xihx_0_190 a_xp0 a_xn0 wp_ih_0_190 wn_ih_0_190 xhp190 xhn190 vdd vbsyn gsyn
Xihx_1_190 a_xp1 a_xn1 wp_ih_1_190 wn_ih_1_190 xhp190 xhn190 vdd vbsyn gsyn
Xihx_2_190 a_xp2 a_xn2 wp_ih_2_190 wn_ih_2_190 xhp190 xhn190 vdd vbsyn gsyn
Xn190 xhp190 xhn190 ahp190 ahn190 vdd vbneu dneuron
Xcm_xh191 xhp191 xhn191 vdd cmld
Rnd_xh191 xhp191 xhn191 20k
Cxh191p xhp191 0 1e-13
Cxh191n xhn191 0 1e-13
Xihx_0_191 a_xp0 a_xn0 wp_ih_0_191 wn_ih_0_191 xhp191 xhn191 vdd vbsyn gsyn
Xihx_1_191 a_xp1 a_xn1 wp_ih_1_191 wn_ih_1_191 xhp191 xhn191 vdd vbsyn gsyn
Xihx_2_191 a_xp2 a_xn2 wp_ih_2_191 wn_ih_2_191 xhp191 xhn191 vdd vbsyn gsyn
Xn191 xhp191 xhn191 ahp191 ahn191 vdd vbneu dneuron
Xcm_xh192 xhp192 xhn192 vdd cmld
Rnd_xh192 xhp192 xhn192 20k
Cxh192p xhp192 0 1e-13
Cxh192n xhn192 0 1e-13
Xihx_0_192 a_xp0 a_xn0 wp_ih_0_192 wn_ih_0_192 xhp192 xhn192 vdd vbsyn gsyn
Xihx_1_192 a_xp1 a_xn1 wp_ih_1_192 wn_ih_1_192 xhp192 xhn192 vdd vbsyn gsyn
Xihx_2_192 a_xp2 a_xn2 wp_ih_2_192 wn_ih_2_192 xhp192 xhn192 vdd vbsyn gsyn
Xn192 xhp192 xhn192 ahp192 ahn192 vdd vbneu dneuron
Xcm_xh193 xhp193 xhn193 vdd cmld
Rnd_xh193 xhp193 xhn193 20k
Cxh193p xhp193 0 1e-13
Cxh193n xhn193 0 1e-13
Xihx_0_193 a_xp0 a_xn0 wp_ih_0_193 wn_ih_0_193 xhp193 xhn193 vdd vbsyn gsyn
Xihx_1_193 a_xp1 a_xn1 wp_ih_1_193 wn_ih_1_193 xhp193 xhn193 vdd vbsyn gsyn
Xihx_2_193 a_xp2 a_xn2 wp_ih_2_193 wn_ih_2_193 xhp193 xhn193 vdd vbsyn gsyn
Xn193 xhp193 xhn193 ahp193 ahn193 vdd vbneu dneuron
Xcm_xh194 xhp194 xhn194 vdd cmld
Rnd_xh194 xhp194 xhn194 20k
Cxh194p xhp194 0 1e-13
Cxh194n xhn194 0 1e-13
Xihx_0_194 a_xp0 a_xn0 wp_ih_0_194 wn_ih_0_194 xhp194 xhn194 vdd vbsyn gsyn
Xihx_1_194 a_xp1 a_xn1 wp_ih_1_194 wn_ih_1_194 xhp194 xhn194 vdd vbsyn gsyn
Xihx_2_194 a_xp2 a_xn2 wp_ih_2_194 wn_ih_2_194 xhp194 xhn194 vdd vbsyn gsyn
Xn194 xhp194 xhn194 ahp194 ahn194 vdd vbneu dneuron
Xcm_xh195 xhp195 xhn195 vdd cmld
Rnd_xh195 xhp195 xhn195 20k
Cxh195p xhp195 0 1e-13
Cxh195n xhn195 0 1e-13
Xihx_0_195 a_xp0 a_xn0 wp_ih_0_195 wn_ih_0_195 xhp195 xhn195 vdd vbsyn gsyn
Xihx_1_195 a_xp1 a_xn1 wp_ih_1_195 wn_ih_1_195 xhp195 xhn195 vdd vbsyn gsyn
Xihx_2_195 a_xp2 a_xn2 wp_ih_2_195 wn_ih_2_195 xhp195 xhn195 vdd vbsyn gsyn
Xn195 xhp195 xhn195 ahp195 ahn195 vdd vbneu dneuron
Xcm_xh196 xhp196 xhn196 vdd cmld
Rnd_xh196 xhp196 xhn196 20k
Cxh196p xhp196 0 1e-13
Cxh196n xhn196 0 1e-13
Xihx_0_196 a_xp0 a_xn0 wp_ih_0_196 wn_ih_0_196 xhp196 xhn196 vdd vbsyn gsyn
Xihx_1_196 a_xp1 a_xn1 wp_ih_1_196 wn_ih_1_196 xhp196 xhn196 vdd vbsyn gsyn
Xihx_2_196 a_xp2 a_xn2 wp_ih_2_196 wn_ih_2_196 xhp196 xhn196 vdd vbsyn gsyn
Xn196 xhp196 xhn196 ahp196 ahn196 vdd vbneu dneuron
Xcm_xh197 xhp197 xhn197 vdd cmld
Rnd_xh197 xhp197 xhn197 20k
Cxh197p xhp197 0 1e-13
Cxh197n xhn197 0 1e-13
Xihx_0_197 a_xp0 a_xn0 wp_ih_0_197 wn_ih_0_197 xhp197 xhn197 vdd vbsyn gsyn
Xihx_1_197 a_xp1 a_xn1 wp_ih_1_197 wn_ih_1_197 xhp197 xhn197 vdd vbsyn gsyn
Xihx_2_197 a_xp2 a_xn2 wp_ih_2_197 wn_ih_2_197 xhp197 xhn197 vdd vbsyn gsyn
Xn197 xhp197 xhn197 ahp197 ahn197 vdd vbneu dneuron
Xcm_xh198 xhp198 xhn198 vdd cmld
Rnd_xh198 xhp198 xhn198 20k
Cxh198p xhp198 0 1e-13
Cxh198n xhn198 0 1e-13
Xihx_0_198 a_xp0 a_xn0 wp_ih_0_198 wn_ih_0_198 xhp198 xhn198 vdd vbsyn gsyn
Xihx_1_198 a_xp1 a_xn1 wp_ih_1_198 wn_ih_1_198 xhp198 xhn198 vdd vbsyn gsyn
Xihx_2_198 a_xp2 a_xn2 wp_ih_2_198 wn_ih_2_198 xhp198 xhn198 vdd vbsyn gsyn
Xn198 xhp198 xhn198 ahp198 ahn198 vdd vbneu dneuron
Xcm_xh199 xhp199 xhn199 vdd cmld
Rnd_xh199 xhp199 xhn199 20k
Cxh199p xhp199 0 1e-13
Cxh199n xhn199 0 1e-13
Xihx_0_199 a_xp0 a_xn0 wp_ih_0_199 wn_ih_0_199 xhp199 xhn199 vdd vbsyn gsyn
Xihx_1_199 a_xp1 a_xn1 wp_ih_1_199 wn_ih_1_199 xhp199 xhn199 vdd vbsyn gsyn
Xihx_2_199 a_xp2 a_xn2 wp_ih_2_199 wn_ih_2_199 xhp199 xhn199 vdd vbsyn gsyn
Xn199 xhp199 xhn199 ahp199 ahn199 vdd vbneu dneuron
Xcm_xh200 xhp200 xhn200 vdd cmld
Rnd_xh200 xhp200 xhn200 20k
Cxh200p xhp200 0 1e-13
Cxh200n xhn200 0 1e-13
Xihx_0_200 a_xp0 a_xn0 wp_ih_0_200 wn_ih_0_200 xhp200 xhn200 vdd vbsyn gsyn
Xihx_1_200 a_xp1 a_xn1 wp_ih_1_200 wn_ih_1_200 xhp200 xhn200 vdd vbsyn gsyn
Xihx_2_200 a_xp2 a_xn2 wp_ih_2_200 wn_ih_2_200 xhp200 xhn200 vdd vbsyn gsyn
Xn200 xhp200 xhn200 ahp200 ahn200 vdd vbneu dneuron
Xcm_xh201 xhp201 xhn201 vdd cmld
Rnd_xh201 xhp201 xhn201 20k
Cxh201p xhp201 0 1e-13
Cxh201n xhn201 0 1e-13
Xihx_0_201 a_xp0 a_xn0 wp_ih_0_201 wn_ih_0_201 xhp201 xhn201 vdd vbsyn gsyn
Xihx_1_201 a_xp1 a_xn1 wp_ih_1_201 wn_ih_1_201 xhp201 xhn201 vdd vbsyn gsyn
Xihx_2_201 a_xp2 a_xn2 wp_ih_2_201 wn_ih_2_201 xhp201 xhn201 vdd vbsyn gsyn
Xn201 xhp201 xhn201 ahp201 ahn201 vdd vbneu dneuron
Xcm_xh202 xhp202 xhn202 vdd cmld
Rnd_xh202 xhp202 xhn202 20k
Cxh202p xhp202 0 1e-13
Cxh202n xhn202 0 1e-13
Xihx_0_202 a_xp0 a_xn0 wp_ih_0_202 wn_ih_0_202 xhp202 xhn202 vdd vbsyn gsyn
Xihx_1_202 a_xp1 a_xn1 wp_ih_1_202 wn_ih_1_202 xhp202 xhn202 vdd vbsyn gsyn
Xihx_2_202 a_xp2 a_xn2 wp_ih_2_202 wn_ih_2_202 xhp202 xhn202 vdd vbsyn gsyn
Xn202 xhp202 xhn202 ahp202 ahn202 vdd vbneu dneuron
Xcm_xh203 xhp203 xhn203 vdd cmld
Rnd_xh203 xhp203 xhn203 20k
Cxh203p xhp203 0 1e-13
Cxh203n xhn203 0 1e-13
Xihx_0_203 a_xp0 a_xn0 wp_ih_0_203 wn_ih_0_203 xhp203 xhn203 vdd vbsyn gsyn
Xihx_1_203 a_xp1 a_xn1 wp_ih_1_203 wn_ih_1_203 xhp203 xhn203 vdd vbsyn gsyn
Xihx_2_203 a_xp2 a_xn2 wp_ih_2_203 wn_ih_2_203 xhp203 xhn203 vdd vbsyn gsyn
Xn203 xhp203 xhn203 ahp203 ahn203 vdd vbneu dneuron
Xcm_xh204 xhp204 xhn204 vdd cmld
Rnd_xh204 xhp204 xhn204 20k
Cxh204p xhp204 0 1e-13
Cxh204n xhn204 0 1e-13
Xihx_0_204 a_xp0 a_xn0 wp_ih_0_204 wn_ih_0_204 xhp204 xhn204 vdd vbsyn gsyn
Xihx_1_204 a_xp1 a_xn1 wp_ih_1_204 wn_ih_1_204 xhp204 xhn204 vdd vbsyn gsyn
Xihx_2_204 a_xp2 a_xn2 wp_ih_2_204 wn_ih_2_204 xhp204 xhn204 vdd vbsyn gsyn
Xn204 xhp204 xhn204 ahp204 ahn204 vdd vbneu dneuron
Xcm_xh205 xhp205 xhn205 vdd cmld
Rnd_xh205 xhp205 xhn205 20k
Cxh205p xhp205 0 1e-13
Cxh205n xhn205 0 1e-13
Xihx_0_205 a_xp0 a_xn0 wp_ih_0_205 wn_ih_0_205 xhp205 xhn205 vdd vbsyn gsyn
Xihx_1_205 a_xp1 a_xn1 wp_ih_1_205 wn_ih_1_205 xhp205 xhn205 vdd vbsyn gsyn
Xihx_2_205 a_xp2 a_xn2 wp_ih_2_205 wn_ih_2_205 xhp205 xhn205 vdd vbsyn gsyn
Xn205 xhp205 xhn205 ahp205 ahn205 vdd vbneu dneuron
Xcm_xh206 xhp206 xhn206 vdd cmld
Rnd_xh206 xhp206 xhn206 20k
Cxh206p xhp206 0 1e-13
Cxh206n xhn206 0 1e-13
Xihx_0_206 a_xp0 a_xn0 wp_ih_0_206 wn_ih_0_206 xhp206 xhn206 vdd vbsyn gsyn
Xihx_1_206 a_xp1 a_xn1 wp_ih_1_206 wn_ih_1_206 xhp206 xhn206 vdd vbsyn gsyn
Xihx_2_206 a_xp2 a_xn2 wp_ih_2_206 wn_ih_2_206 xhp206 xhn206 vdd vbsyn gsyn
Xn206 xhp206 xhn206 ahp206 ahn206 vdd vbneu dneuron
Xcm_xh207 xhp207 xhn207 vdd cmld
Rnd_xh207 xhp207 xhn207 20k
Cxh207p xhp207 0 1e-13
Cxh207n xhn207 0 1e-13
Xihx_0_207 a_xp0 a_xn0 wp_ih_0_207 wn_ih_0_207 xhp207 xhn207 vdd vbsyn gsyn
Xihx_1_207 a_xp1 a_xn1 wp_ih_1_207 wn_ih_1_207 xhp207 xhn207 vdd vbsyn gsyn
Xihx_2_207 a_xp2 a_xn2 wp_ih_2_207 wn_ih_2_207 xhp207 xhn207 vdd vbsyn gsyn
Xn207 xhp207 xhn207 ahp207 ahn207 vdd vbneu dneuron
Xcm_xh208 xhp208 xhn208 vdd cmld
Rnd_xh208 xhp208 xhn208 20k
Cxh208p xhp208 0 1e-13
Cxh208n xhn208 0 1e-13
Xihx_0_208 a_xp0 a_xn0 wp_ih_0_208 wn_ih_0_208 xhp208 xhn208 vdd vbsyn gsyn
Xihx_1_208 a_xp1 a_xn1 wp_ih_1_208 wn_ih_1_208 xhp208 xhn208 vdd vbsyn gsyn
Xihx_2_208 a_xp2 a_xn2 wp_ih_2_208 wn_ih_2_208 xhp208 xhn208 vdd vbsyn gsyn
Xn208 xhp208 xhn208 ahp208 ahn208 vdd vbneu dneuron
Xcm_xh209 xhp209 xhn209 vdd cmld
Rnd_xh209 xhp209 xhn209 20k
Cxh209p xhp209 0 1e-13
Cxh209n xhn209 0 1e-13
Xihx_0_209 a_xp0 a_xn0 wp_ih_0_209 wn_ih_0_209 xhp209 xhn209 vdd vbsyn gsyn
Xihx_1_209 a_xp1 a_xn1 wp_ih_1_209 wn_ih_1_209 xhp209 xhn209 vdd vbsyn gsyn
Xihx_2_209 a_xp2 a_xn2 wp_ih_2_209 wn_ih_2_209 xhp209 xhn209 vdd vbsyn gsyn
Xn209 xhp209 xhn209 ahp209 ahn209 vdd vbneu dneuron
Xcm_xh210 xhp210 xhn210 vdd cmld
Rnd_xh210 xhp210 xhn210 20k
Cxh210p xhp210 0 1e-13
Cxh210n xhn210 0 1e-13
Xihx_0_210 a_xp0 a_xn0 wp_ih_0_210 wn_ih_0_210 xhp210 xhn210 vdd vbsyn gsyn
Xihx_1_210 a_xp1 a_xn1 wp_ih_1_210 wn_ih_1_210 xhp210 xhn210 vdd vbsyn gsyn
Xihx_2_210 a_xp2 a_xn2 wp_ih_2_210 wn_ih_2_210 xhp210 xhn210 vdd vbsyn gsyn
Xn210 xhp210 xhn210 ahp210 ahn210 vdd vbneu dneuron
Xcm_xh211 xhp211 xhn211 vdd cmld
Rnd_xh211 xhp211 xhn211 20k
Cxh211p xhp211 0 1e-13
Cxh211n xhn211 0 1e-13
Xihx_0_211 a_xp0 a_xn0 wp_ih_0_211 wn_ih_0_211 xhp211 xhn211 vdd vbsyn gsyn
Xihx_1_211 a_xp1 a_xn1 wp_ih_1_211 wn_ih_1_211 xhp211 xhn211 vdd vbsyn gsyn
Xihx_2_211 a_xp2 a_xn2 wp_ih_2_211 wn_ih_2_211 xhp211 xhn211 vdd vbsyn gsyn
Xn211 xhp211 xhn211 ahp211 ahn211 vdd vbneu dneuron
Xcm_xh212 xhp212 xhn212 vdd cmld
Rnd_xh212 xhp212 xhn212 20k
Cxh212p xhp212 0 1e-13
Cxh212n xhn212 0 1e-13
Xihx_0_212 a_xp0 a_xn0 wp_ih_0_212 wn_ih_0_212 xhp212 xhn212 vdd vbsyn gsyn
Xihx_1_212 a_xp1 a_xn1 wp_ih_1_212 wn_ih_1_212 xhp212 xhn212 vdd vbsyn gsyn
Xihx_2_212 a_xp2 a_xn2 wp_ih_2_212 wn_ih_2_212 xhp212 xhn212 vdd vbsyn gsyn
Xn212 xhp212 xhn212 ahp212 ahn212 vdd vbneu dneuron
Xcm_xh213 xhp213 xhn213 vdd cmld
Rnd_xh213 xhp213 xhn213 20k
Cxh213p xhp213 0 1e-13
Cxh213n xhn213 0 1e-13
Xihx_0_213 a_xp0 a_xn0 wp_ih_0_213 wn_ih_0_213 xhp213 xhn213 vdd vbsyn gsyn
Xihx_1_213 a_xp1 a_xn1 wp_ih_1_213 wn_ih_1_213 xhp213 xhn213 vdd vbsyn gsyn
Xihx_2_213 a_xp2 a_xn2 wp_ih_2_213 wn_ih_2_213 xhp213 xhn213 vdd vbsyn gsyn
Xn213 xhp213 xhn213 ahp213 ahn213 vdd vbneu dneuron
Xcm_xh214 xhp214 xhn214 vdd cmld
Rnd_xh214 xhp214 xhn214 20k
Cxh214p xhp214 0 1e-13
Cxh214n xhn214 0 1e-13
Xihx_0_214 a_xp0 a_xn0 wp_ih_0_214 wn_ih_0_214 xhp214 xhn214 vdd vbsyn gsyn
Xihx_1_214 a_xp1 a_xn1 wp_ih_1_214 wn_ih_1_214 xhp214 xhn214 vdd vbsyn gsyn
Xihx_2_214 a_xp2 a_xn2 wp_ih_2_214 wn_ih_2_214 xhp214 xhn214 vdd vbsyn gsyn
Xn214 xhp214 xhn214 ahp214 ahn214 vdd vbneu dneuron
Xcm_xh215 xhp215 xhn215 vdd cmld
Rnd_xh215 xhp215 xhn215 20k
Cxh215p xhp215 0 1e-13
Cxh215n xhn215 0 1e-13
Xihx_0_215 a_xp0 a_xn0 wp_ih_0_215 wn_ih_0_215 xhp215 xhn215 vdd vbsyn gsyn
Xihx_1_215 a_xp1 a_xn1 wp_ih_1_215 wn_ih_1_215 xhp215 xhn215 vdd vbsyn gsyn
Xihx_2_215 a_xp2 a_xn2 wp_ih_2_215 wn_ih_2_215 xhp215 xhn215 vdd vbsyn gsyn
Xn215 xhp215 xhn215 ahp215 ahn215 vdd vbneu dneuron
Xcm_xh216 xhp216 xhn216 vdd cmld
Rnd_xh216 xhp216 xhn216 20k
Cxh216p xhp216 0 1e-13
Cxh216n xhn216 0 1e-13
Xihx_0_216 a_xp0 a_xn0 wp_ih_0_216 wn_ih_0_216 xhp216 xhn216 vdd vbsyn gsyn
Xihx_1_216 a_xp1 a_xn1 wp_ih_1_216 wn_ih_1_216 xhp216 xhn216 vdd vbsyn gsyn
Xihx_2_216 a_xp2 a_xn2 wp_ih_2_216 wn_ih_2_216 xhp216 xhn216 vdd vbsyn gsyn
Xn216 xhp216 xhn216 ahp216 ahn216 vdd vbneu dneuron
Xcm_xh217 xhp217 xhn217 vdd cmld
Rnd_xh217 xhp217 xhn217 20k
Cxh217p xhp217 0 1e-13
Cxh217n xhn217 0 1e-13
Xihx_0_217 a_xp0 a_xn0 wp_ih_0_217 wn_ih_0_217 xhp217 xhn217 vdd vbsyn gsyn
Xihx_1_217 a_xp1 a_xn1 wp_ih_1_217 wn_ih_1_217 xhp217 xhn217 vdd vbsyn gsyn
Xihx_2_217 a_xp2 a_xn2 wp_ih_2_217 wn_ih_2_217 xhp217 xhn217 vdd vbsyn gsyn
Xn217 xhp217 xhn217 ahp217 ahn217 vdd vbneu dneuron
Xcm_xh218 xhp218 xhn218 vdd cmld
Rnd_xh218 xhp218 xhn218 20k
Cxh218p xhp218 0 1e-13
Cxh218n xhn218 0 1e-13
Xihx_0_218 a_xp0 a_xn0 wp_ih_0_218 wn_ih_0_218 xhp218 xhn218 vdd vbsyn gsyn
Xihx_1_218 a_xp1 a_xn1 wp_ih_1_218 wn_ih_1_218 xhp218 xhn218 vdd vbsyn gsyn
Xihx_2_218 a_xp2 a_xn2 wp_ih_2_218 wn_ih_2_218 xhp218 xhn218 vdd vbsyn gsyn
Xn218 xhp218 xhn218 ahp218 ahn218 vdd vbneu dneuron
Xcm_xh219 xhp219 xhn219 vdd cmld
Rnd_xh219 xhp219 xhn219 20k
Cxh219p xhp219 0 1e-13
Cxh219n xhn219 0 1e-13
Xihx_0_219 a_xp0 a_xn0 wp_ih_0_219 wn_ih_0_219 xhp219 xhn219 vdd vbsyn gsyn
Xihx_1_219 a_xp1 a_xn1 wp_ih_1_219 wn_ih_1_219 xhp219 xhn219 vdd vbsyn gsyn
Xihx_2_219 a_xp2 a_xn2 wp_ih_2_219 wn_ih_2_219 xhp219 xhn219 vdd vbsyn gsyn
Xn219 xhp219 xhn219 ahp219 ahn219 vdd vbneu dneuron
Xcm_xh220 xhp220 xhn220 vdd cmld
Rnd_xh220 xhp220 xhn220 20k
Cxh220p xhp220 0 1e-13
Cxh220n xhn220 0 1e-13
Xihx_0_220 a_xp0 a_xn0 wp_ih_0_220 wn_ih_0_220 xhp220 xhn220 vdd vbsyn gsyn
Xihx_1_220 a_xp1 a_xn1 wp_ih_1_220 wn_ih_1_220 xhp220 xhn220 vdd vbsyn gsyn
Xihx_2_220 a_xp2 a_xn2 wp_ih_2_220 wn_ih_2_220 xhp220 xhn220 vdd vbsyn gsyn
Xn220 xhp220 xhn220 ahp220 ahn220 vdd vbneu dneuron
Xcm_xh221 xhp221 xhn221 vdd cmld
Rnd_xh221 xhp221 xhn221 20k
Cxh221p xhp221 0 1e-13
Cxh221n xhn221 0 1e-13
Xihx_0_221 a_xp0 a_xn0 wp_ih_0_221 wn_ih_0_221 xhp221 xhn221 vdd vbsyn gsyn
Xihx_1_221 a_xp1 a_xn1 wp_ih_1_221 wn_ih_1_221 xhp221 xhn221 vdd vbsyn gsyn
Xihx_2_221 a_xp2 a_xn2 wp_ih_2_221 wn_ih_2_221 xhp221 xhn221 vdd vbsyn gsyn
Xn221 xhp221 xhn221 ahp221 ahn221 vdd vbneu dneuron
Xcm_xh222 xhp222 xhn222 vdd cmld
Rnd_xh222 xhp222 xhn222 20k
Cxh222p xhp222 0 1e-13
Cxh222n xhn222 0 1e-13
Xihx_0_222 a_xp0 a_xn0 wp_ih_0_222 wn_ih_0_222 xhp222 xhn222 vdd vbsyn gsyn
Xihx_1_222 a_xp1 a_xn1 wp_ih_1_222 wn_ih_1_222 xhp222 xhn222 vdd vbsyn gsyn
Xihx_2_222 a_xp2 a_xn2 wp_ih_2_222 wn_ih_2_222 xhp222 xhn222 vdd vbsyn gsyn
Xn222 xhp222 xhn222 ahp222 ahn222 vdd vbneu dneuron
Xcm_xh223 xhp223 xhn223 vdd cmld
Rnd_xh223 xhp223 xhn223 20k
Cxh223p xhp223 0 1e-13
Cxh223n xhn223 0 1e-13
Xihx_0_223 a_xp0 a_xn0 wp_ih_0_223 wn_ih_0_223 xhp223 xhn223 vdd vbsyn gsyn
Xihx_1_223 a_xp1 a_xn1 wp_ih_1_223 wn_ih_1_223 xhp223 xhn223 vdd vbsyn gsyn
Xihx_2_223 a_xp2 a_xn2 wp_ih_2_223 wn_ih_2_223 xhp223 xhn223 vdd vbsyn gsyn
Xn223 xhp223 xhn223 ahp223 ahn223 vdd vbneu dneuron
Xcm_xh224 xhp224 xhn224 vdd cmld
Rnd_xh224 xhp224 xhn224 20k
Cxh224p xhp224 0 1e-13
Cxh224n xhn224 0 1e-13
Xihx_0_224 a_xp0 a_xn0 wp_ih_0_224 wn_ih_0_224 xhp224 xhn224 vdd vbsyn gsyn
Xihx_1_224 a_xp1 a_xn1 wp_ih_1_224 wn_ih_1_224 xhp224 xhn224 vdd vbsyn gsyn
Xihx_2_224 a_xp2 a_xn2 wp_ih_2_224 wn_ih_2_224 xhp224 xhn224 vdd vbsyn gsyn
Xn224 xhp224 xhn224 ahp224 ahn224 vdd vbneu dneuron
Xcm_xh225 xhp225 xhn225 vdd cmld
Rnd_xh225 xhp225 xhn225 20k
Cxh225p xhp225 0 1e-13
Cxh225n xhn225 0 1e-13
Xihx_0_225 a_xp0 a_xn0 wp_ih_0_225 wn_ih_0_225 xhp225 xhn225 vdd vbsyn gsyn
Xihx_1_225 a_xp1 a_xn1 wp_ih_1_225 wn_ih_1_225 xhp225 xhn225 vdd vbsyn gsyn
Xihx_2_225 a_xp2 a_xn2 wp_ih_2_225 wn_ih_2_225 xhp225 xhn225 vdd vbsyn gsyn
Xn225 xhp225 xhn225 ahp225 ahn225 vdd vbneu dneuron
Xcm_xh226 xhp226 xhn226 vdd cmld
Rnd_xh226 xhp226 xhn226 20k
Cxh226p xhp226 0 1e-13
Cxh226n xhn226 0 1e-13
Xihx_0_226 a_xp0 a_xn0 wp_ih_0_226 wn_ih_0_226 xhp226 xhn226 vdd vbsyn gsyn
Xihx_1_226 a_xp1 a_xn1 wp_ih_1_226 wn_ih_1_226 xhp226 xhn226 vdd vbsyn gsyn
Xihx_2_226 a_xp2 a_xn2 wp_ih_2_226 wn_ih_2_226 xhp226 xhn226 vdd vbsyn gsyn
Xn226 xhp226 xhn226 ahp226 ahn226 vdd vbneu dneuron
Xcm_xh227 xhp227 xhn227 vdd cmld
Rnd_xh227 xhp227 xhn227 20k
Cxh227p xhp227 0 1e-13
Cxh227n xhn227 0 1e-13
Xihx_0_227 a_xp0 a_xn0 wp_ih_0_227 wn_ih_0_227 xhp227 xhn227 vdd vbsyn gsyn
Xihx_1_227 a_xp1 a_xn1 wp_ih_1_227 wn_ih_1_227 xhp227 xhn227 vdd vbsyn gsyn
Xihx_2_227 a_xp2 a_xn2 wp_ih_2_227 wn_ih_2_227 xhp227 xhn227 vdd vbsyn gsyn
Xn227 xhp227 xhn227 ahp227 ahn227 vdd vbneu dneuron
Xcm_xh228 xhp228 xhn228 vdd cmld
Rnd_xh228 xhp228 xhn228 20k
Cxh228p xhp228 0 1e-13
Cxh228n xhn228 0 1e-13
Xihx_0_228 a_xp0 a_xn0 wp_ih_0_228 wn_ih_0_228 xhp228 xhn228 vdd vbsyn gsyn
Xihx_1_228 a_xp1 a_xn1 wp_ih_1_228 wn_ih_1_228 xhp228 xhn228 vdd vbsyn gsyn
Xihx_2_228 a_xp2 a_xn2 wp_ih_2_228 wn_ih_2_228 xhp228 xhn228 vdd vbsyn gsyn
Xn228 xhp228 xhn228 ahp228 ahn228 vdd vbneu dneuron
Xcm_xh229 xhp229 xhn229 vdd cmld
Rnd_xh229 xhp229 xhn229 20k
Cxh229p xhp229 0 1e-13
Cxh229n xhn229 0 1e-13
Xihx_0_229 a_xp0 a_xn0 wp_ih_0_229 wn_ih_0_229 xhp229 xhn229 vdd vbsyn gsyn
Xihx_1_229 a_xp1 a_xn1 wp_ih_1_229 wn_ih_1_229 xhp229 xhn229 vdd vbsyn gsyn
Xihx_2_229 a_xp2 a_xn2 wp_ih_2_229 wn_ih_2_229 xhp229 xhn229 vdd vbsyn gsyn
Xn229 xhp229 xhn229 ahp229 ahn229 vdd vbneu dneuron
Xcm_xh230 xhp230 xhn230 vdd cmld
Rnd_xh230 xhp230 xhn230 20k
Cxh230p xhp230 0 1e-13
Cxh230n xhn230 0 1e-13
Xihx_0_230 a_xp0 a_xn0 wp_ih_0_230 wn_ih_0_230 xhp230 xhn230 vdd vbsyn gsyn
Xihx_1_230 a_xp1 a_xn1 wp_ih_1_230 wn_ih_1_230 xhp230 xhn230 vdd vbsyn gsyn
Xihx_2_230 a_xp2 a_xn2 wp_ih_2_230 wn_ih_2_230 xhp230 xhn230 vdd vbsyn gsyn
Xn230 xhp230 xhn230 ahp230 ahn230 vdd vbneu dneuron
Xcm_xh231 xhp231 xhn231 vdd cmld
Rnd_xh231 xhp231 xhn231 20k
Cxh231p xhp231 0 1e-13
Cxh231n xhn231 0 1e-13
Xihx_0_231 a_xp0 a_xn0 wp_ih_0_231 wn_ih_0_231 xhp231 xhn231 vdd vbsyn gsyn
Xihx_1_231 a_xp1 a_xn1 wp_ih_1_231 wn_ih_1_231 xhp231 xhn231 vdd vbsyn gsyn
Xihx_2_231 a_xp2 a_xn2 wp_ih_2_231 wn_ih_2_231 xhp231 xhn231 vdd vbsyn gsyn
Xn231 xhp231 xhn231 ahp231 ahn231 vdd vbneu dneuron
Xcm_xh232 xhp232 xhn232 vdd cmld
Rnd_xh232 xhp232 xhn232 20k
Cxh232p xhp232 0 1e-13
Cxh232n xhn232 0 1e-13
Xihx_0_232 a_xp0 a_xn0 wp_ih_0_232 wn_ih_0_232 xhp232 xhn232 vdd vbsyn gsyn
Xihx_1_232 a_xp1 a_xn1 wp_ih_1_232 wn_ih_1_232 xhp232 xhn232 vdd vbsyn gsyn
Xihx_2_232 a_xp2 a_xn2 wp_ih_2_232 wn_ih_2_232 xhp232 xhn232 vdd vbsyn gsyn
Xn232 xhp232 xhn232 ahp232 ahn232 vdd vbneu dneuron
Xcm_xh233 xhp233 xhn233 vdd cmld
Rnd_xh233 xhp233 xhn233 20k
Cxh233p xhp233 0 1e-13
Cxh233n xhn233 0 1e-13
Xihx_0_233 a_xp0 a_xn0 wp_ih_0_233 wn_ih_0_233 xhp233 xhn233 vdd vbsyn gsyn
Xihx_1_233 a_xp1 a_xn1 wp_ih_1_233 wn_ih_1_233 xhp233 xhn233 vdd vbsyn gsyn
Xihx_2_233 a_xp2 a_xn2 wp_ih_2_233 wn_ih_2_233 xhp233 xhn233 vdd vbsyn gsyn
Xn233 xhp233 xhn233 ahp233 ahn233 vdd vbneu dneuron
Xcm_xh234 xhp234 xhn234 vdd cmld
Rnd_xh234 xhp234 xhn234 20k
Cxh234p xhp234 0 1e-13
Cxh234n xhn234 0 1e-13
Xihx_0_234 a_xp0 a_xn0 wp_ih_0_234 wn_ih_0_234 xhp234 xhn234 vdd vbsyn gsyn
Xihx_1_234 a_xp1 a_xn1 wp_ih_1_234 wn_ih_1_234 xhp234 xhn234 vdd vbsyn gsyn
Xihx_2_234 a_xp2 a_xn2 wp_ih_2_234 wn_ih_2_234 xhp234 xhn234 vdd vbsyn gsyn
Xn234 xhp234 xhn234 ahp234 ahn234 vdd vbneu dneuron
Xcm_xh235 xhp235 xhn235 vdd cmld
Rnd_xh235 xhp235 xhn235 20k
Cxh235p xhp235 0 1e-13
Cxh235n xhn235 0 1e-13
Xihx_0_235 a_xp0 a_xn0 wp_ih_0_235 wn_ih_0_235 xhp235 xhn235 vdd vbsyn gsyn
Xihx_1_235 a_xp1 a_xn1 wp_ih_1_235 wn_ih_1_235 xhp235 xhn235 vdd vbsyn gsyn
Xihx_2_235 a_xp2 a_xn2 wp_ih_2_235 wn_ih_2_235 xhp235 xhn235 vdd vbsyn gsyn
Xn235 xhp235 xhn235 ahp235 ahn235 vdd vbneu dneuron
Xcm_xh236 xhp236 xhn236 vdd cmld
Rnd_xh236 xhp236 xhn236 20k
Cxh236p xhp236 0 1e-13
Cxh236n xhn236 0 1e-13
Xihx_0_236 a_xp0 a_xn0 wp_ih_0_236 wn_ih_0_236 xhp236 xhn236 vdd vbsyn gsyn
Xihx_1_236 a_xp1 a_xn1 wp_ih_1_236 wn_ih_1_236 xhp236 xhn236 vdd vbsyn gsyn
Xihx_2_236 a_xp2 a_xn2 wp_ih_2_236 wn_ih_2_236 xhp236 xhn236 vdd vbsyn gsyn
Xn236 xhp236 xhn236 ahp236 ahn236 vdd vbneu dneuron
Xcm_xh237 xhp237 xhn237 vdd cmld
Rnd_xh237 xhp237 xhn237 20k
Cxh237p xhp237 0 1e-13
Cxh237n xhn237 0 1e-13
Xihx_0_237 a_xp0 a_xn0 wp_ih_0_237 wn_ih_0_237 xhp237 xhn237 vdd vbsyn gsyn
Xihx_1_237 a_xp1 a_xn1 wp_ih_1_237 wn_ih_1_237 xhp237 xhn237 vdd vbsyn gsyn
Xihx_2_237 a_xp2 a_xn2 wp_ih_2_237 wn_ih_2_237 xhp237 xhn237 vdd vbsyn gsyn
Xn237 xhp237 xhn237 ahp237 ahn237 vdd vbneu dneuron
Xcm_xh238 xhp238 xhn238 vdd cmld
Rnd_xh238 xhp238 xhn238 20k
Cxh238p xhp238 0 1e-13
Cxh238n xhn238 0 1e-13
Xihx_0_238 a_xp0 a_xn0 wp_ih_0_238 wn_ih_0_238 xhp238 xhn238 vdd vbsyn gsyn
Xihx_1_238 a_xp1 a_xn1 wp_ih_1_238 wn_ih_1_238 xhp238 xhn238 vdd vbsyn gsyn
Xihx_2_238 a_xp2 a_xn2 wp_ih_2_238 wn_ih_2_238 xhp238 xhn238 vdd vbsyn gsyn
Xn238 xhp238 xhn238 ahp238 ahn238 vdd vbneu dneuron
Xcm_xh239 xhp239 xhn239 vdd cmld
Rnd_xh239 xhp239 xhn239 20k
Cxh239p xhp239 0 1e-13
Cxh239n xhn239 0 1e-13
Xihx_0_239 a_xp0 a_xn0 wp_ih_0_239 wn_ih_0_239 xhp239 xhn239 vdd vbsyn gsyn
Xihx_1_239 a_xp1 a_xn1 wp_ih_1_239 wn_ih_1_239 xhp239 xhn239 vdd vbsyn gsyn
Xihx_2_239 a_xp2 a_xn2 wp_ih_2_239 wn_ih_2_239 xhp239 xhn239 vdd vbsyn gsyn
Xn239 xhp239 xhn239 ahp239 ahn239 vdd vbneu dneuron
Xcm_xh240 xhp240 xhn240 vdd cmld
Rnd_xh240 xhp240 xhn240 20k
Cxh240p xhp240 0 1e-13
Cxh240n xhn240 0 1e-13
Xihx_0_240 a_xp0 a_xn0 wp_ih_0_240 wn_ih_0_240 xhp240 xhn240 vdd vbsyn gsyn
Xihx_1_240 a_xp1 a_xn1 wp_ih_1_240 wn_ih_1_240 xhp240 xhn240 vdd vbsyn gsyn
Xihx_2_240 a_xp2 a_xn2 wp_ih_2_240 wn_ih_2_240 xhp240 xhn240 vdd vbsyn gsyn
Xn240 xhp240 xhn240 ahp240 ahn240 vdd vbneu dneuron
Xcm_xh241 xhp241 xhn241 vdd cmld
Rnd_xh241 xhp241 xhn241 20k
Cxh241p xhp241 0 1e-13
Cxh241n xhn241 0 1e-13
Xihx_0_241 a_xp0 a_xn0 wp_ih_0_241 wn_ih_0_241 xhp241 xhn241 vdd vbsyn gsyn
Xihx_1_241 a_xp1 a_xn1 wp_ih_1_241 wn_ih_1_241 xhp241 xhn241 vdd vbsyn gsyn
Xihx_2_241 a_xp2 a_xn2 wp_ih_2_241 wn_ih_2_241 xhp241 xhn241 vdd vbsyn gsyn
Xn241 xhp241 xhn241 ahp241 ahn241 vdd vbneu dneuron
Xcm_xh242 xhp242 xhn242 vdd cmld
Rnd_xh242 xhp242 xhn242 20k
Cxh242p xhp242 0 1e-13
Cxh242n xhn242 0 1e-13
Xihx_0_242 a_xp0 a_xn0 wp_ih_0_242 wn_ih_0_242 xhp242 xhn242 vdd vbsyn gsyn
Xihx_1_242 a_xp1 a_xn1 wp_ih_1_242 wn_ih_1_242 xhp242 xhn242 vdd vbsyn gsyn
Xihx_2_242 a_xp2 a_xn2 wp_ih_2_242 wn_ih_2_242 xhp242 xhn242 vdd vbsyn gsyn
Xn242 xhp242 xhn242 ahp242 ahn242 vdd vbneu dneuron
Xcm_xh243 xhp243 xhn243 vdd cmld
Rnd_xh243 xhp243 xhn243 20k
Cxh243p xhp243 0 1e-13
Cxh243n xhn243 0 1e-13
Xihx_0_243 a_xp0 a_xn0 wp_ih_0_243 wn_ih_0_243 xhp243 xhn243 vdd vbsyn gsyn
Xihx_1_243 a_xp1 a_xn1 wp_ih_1_243 wn_ih_1_243 xhp243 xhn243 vdd vbsyn gsyn
Xihx_2_243 a_xp2 a_xn2 wp_ih_2_243 wn_ih_2_243 xhp243 xhn243 vdd vbsyn gsyn
Xn243 xhp243 xhn243 ahp243 ahn243 vdd vbneu dneuron
Xcm_xh244 xhp244 xhn244 vdd cmld
Rnd_xh244 xhp244 xhn244 20k
Cxh244p xhp244 0 1e-13
Cxh244n xhn244 0 1e-13
Xihx_0_244 a_xp0 a_xn0 wp_ih_0_244 wn_ih_0_244 xhp244 xhn244 vdd vbsyn gsyn
Xihx_1_244 a_xp1 a_xn1 wp_ih_1_244 wn_ih_1_244 xhp244 xhn244 vdd vbsyn gsyn
Xihx_2_244 a_xp2 a_xn2 wp_ih_2_244 wn_ih_2_244 xhp244 xhn244 vdd vbsyn gsyn
Xn244 xhp244 xhn244 ahp244 ahn244 vdd vbneu dneuron
Xcm_xh245 xhp245 xhn245 vdd cmld
Rnd_xh245 xhp245 xhn245 20k
Cxh245p xhp245 0 1e-13
Cxh245n xhn245 0 1e-13
Xihx_0_245 a_xp0 a_xn0 wp_ih_0_245 wn_ih_0_245 xhp245 xhn245 vdd vbsyn gsyn
Xihx_1_245 a_xp1 a_xn1 wp_ih_1_245 wn_ih_1_245 xhp245 xhn245 vdd vbsyn gsyn
Xihx_2_245 a_xp2 a_xn2 wp_ih_2_245 wn_ih_2_245 xhp245 xhn245 vdd vbsyn gsyn
Xn245 xhp245 xhn245 ahp245 ahn245 vdd vbneu dneuron
Xcm_xh246 xhp246 xhn246 vdd cmld
Rnd_xh246 xhp246 xhn246 20k
Cxh246p xhp246 0 1e-13
Cxh246n xhn246 0 1e-13
Xihx_0_246 a_xp0 a_xn0 wp_ih_0_246 wn_ih_0_246 xhp246 xhn246 vdd vbsyn gsyn
Xihx_1_246 a_xp1 a_xn1 wp_ih_1_246 wn_ih_1_246 xhp246 xhn246 vdd vbsyn gsyn
Xihx_2_246 a_xp2 a_xn2 wp_ih_2_246 wn_ih_2_246 xhp246 xhn246 vdd vbsyn gsyn
Xn246 xhp246 xhn246 ahp246 ahn246 vdd vbneu dneuron
Xcm_xh247 xhp247 xhn247 vdd cmld
Rnd_xh247 xhp247 xhn247 20k
Cxh247p xhp247 0 1e-13
Cxh247n xhn247 0 1e-13
Xihx_0_247 a_xp0 a_xn0 wp_ih_0_247 wn_ih_0_247 xhp247 xhn247 vdd vbsyn gsyn
Xihx_1_247 a_xp1 a_xn1 wp_ih_1_247 wn_ih_1_247 xhp247 xhn247 vdd vbsyn gsyn
Xihx_2_247 a_xp2 a_xn2 wp_ih_2_247 wn_ih_2_247 xhp247 xhn247 vdd vbsyn gsyn
Xn247 xhp247 xhn247 ahp247 ahn247 vdd vbneu dneuron
Xcm_xh248 xhp248 xhn248 vdd cmld
Rnd_xh248 xhp248 xhn248 20k
Cxh248p xhp248 0 1e-13
Cxh248n xhn248 0 1e-13
Xihx_0_248 a_xp0 a_xn0 wp_ih_0_248 wn_ih_0_248 xhp248 xhn248 vdd vbsyn gsyn
Xihx_1_248 a_xp1 a_xn1 wp_ih_1_248 wn_ih_1_248 xhp248 xhn248 vdd vbsyn gsyn
Xihx_2_248 a_xp2 a_xn2 wp_ih_2_248 wn_ih_2_248 xhp248 xhn248 vdd vbsyn gsyn
Xn248 xhp248 xhn248 ahp248 ahn248 vdd vbneu dneuron
Xcm_xh249 xhp249 xhn249 vdd cmld
Rnd_xh249 xhp249 xhn249 20k
Cxh249p xhp249 0 1e-13
Cxh249n xhn249 0 1e-13
Xihx_0_249 a_xp0 a_xn0 wp_ih_0_249 wn_ih_0_249 xhp249 xhn249 vdd vbsyn gsyn
Xihx_1_249 a_xp1 a_xn1 wp_ih_1_249 wn_ih_1_249 xhp249 xhn249 vdd vbsyn gsyn
Xihx_2_249 a_xp2 a_xn2 wp_ih_2_249 wn_ih_2_249 xhp249 xhn249 vdd vbsyn gsyn
Xn249 xhp249 xhn249 ahp249 ahn249 vdd vbneu dneuron
Xcm_xh250 xhp250 xhn250 vdd cmld
Rnd_xh250 xhp250 xhn250 20k
Cxh250p xhp250 0 1e-13
Cxh250n xhn250 0 1e-13
Xihx_0_250 a_xp0 a_xn0 wp_ih_0_250 wn_ih_0_250 xhp250 xhn250 vdd vbsyn gsyn
Xihx_1_250 a_xp1 a_xn1 wp_ih_1_250 wn_ih_1_250 xhp250 xhn250 vdd vbsyn gsyn
Xihx_2_250 a_xp2 a_xn2 wp_ih_2_250 wn_ih_2_250 xhp250 xhn250 vdd vbsyn gsyn
Xn250 xhp250 xhn250 ahp250 ahn250 vdd vbneu dneuron
Xcm_xh251 xhp251 xhn251 vdd cmld
Rnd_xh251 xhp251 xhn251 20k
Cxh251p xhp251 0 1e-13
Cxh251n xhn251 0 1e-13
Xihx_0_251 a_xp0 a_xn0 wp_ih_0_251 wn_ih_0_251 xhp251 xhn251 vdd vbsyn gsyn
Xihx_1_251 a_xp1 a_xn1 wp_ih_1_251 wn_ih_1_251 xhp251 xhn251 vdd vbsyn gsyn
Xihx_2_251 a_xp2 a_xn2 wp_ih_2_251 wn_ih_2_251 xhp251 xhn251 vdd vbsyn gsyn
Xn251 xhp251 xhn251 ahp251 ahn251 vdd vbneu dneuron
Xcm_xh252 xhp252 xhn252 vdd cmld
Rnd_xh252 xhp252 xhn252 20k
Cxh252p xhp252 0 1e-13
Cxh252n xhn252 0 1e-13
Xihx_0_252 a_xp0 a_xn0 wp_ih_0_252 wn_ih_0_252 xhp252 xhn252 vdd vbsyn gsyn
Xihx_1_252 a_xp1 a_xn1 wp_ih_1_252 wn_ih_1_252 xhp252 xhn252 vdd vbsyn gsyn
Xihx_2_252 a_xp2 a_xn2 wp_ih_2_252 wn_ih_2_252 xhp252 xhn252 vdd vbsyn gsyn
Xn252 xhp252 xhn252 ahp252 ahn252 vdd vbneu dneuron
Xcm_xh253 xhp253 xhn253 vdd cmld
Rnd_xh253 xhp253 xhn253 20k
Cxh253p xhp253 0 1e-13
Cxh253n xhn253 0 1e-13
Xihx_0_253 a_xp0 a_xn0 wp_ih_0_253 wn_ih_0_253 xhp253 xhn253 vdd vbsyn gsyn
Xihx_1_253 a_xp1 a_xn1 wp_ih_1_253 wn_ih_1_253 xhp253 xhn253 vdd vbsyn gsyn
Xihx_2_253 a_xp2 a_xn2 wp_ih_2_253 wn_ih_2_253 xhp253 xhn253 vdd vbsyn gsyn
Xn253 xhp253 xhn253 ahp253 ahn253 vdd vbneu dneuron
Xcm_xh254 xhp254 xhn254 vdd cmld
Rnd_xh254 xhp254 xhn254 20k
Cxh254p xhp254 0 1e-13
Cxh254n xhn254 0 1e-13
Xihx_0_254 a_xp0 a_xn0 wp_ih_0_254 wn_ih_0_254 xhp254 xhn254 vdd vbsyn gsyn
Xihx_1_254 a_xp1 a_xn1 wp_ih_1_254 wn_ih_1_254 xhp254 xhn254 vdd vbsyn gsyn
Xihx_2_254 a_xp2 a_xn2 wp_ih_2_254 wn_ih_2_254 xhp254 xhn254 vdd vbsyn gsyn
Xn254 xhp254 xhn254 ahp254 ahn254 vdd vbneu dneuron
Xcm_xh255 xhp255 xhn255 vdd cmld
Rnd_xh255 xhp255 xhn255 20k
Cxh255p xhp255 0 1e-13
Cxh255n xhn255 0 1e-13
Xihx_0_255 a_xp0 a_xn0 wp_ih_0_255 wn_ih_0_255 xhp255 xhn255 vdd vbsyn gsyn
Xihx_1_255 a_xp1 a_xn1 wp_ih_1_255 wn_ih_1_255 xhp255 xhn255 vdd vbsyn gsyn
Xihx_2_255 a_xp2 a_xn2 wp_ih_2_255 wn_ih_2_255 xhp255 xhn255 vdd vbsyn gsyn
Xn255 xhp255 xhn255 ahp255 ahn255 vdd vbneu dneuron
Xcm_xh256 xhp256 xhn256 vdd cmld
Rnd_xh256 xhp256 xhn256 20k
Cxh256p xhp256 0 1e-13
Cxh256n xhn256 0 1e-13
Xihx_0_256 a_xp0 a_xn0 wp_ih_0_256 wn_ih_0_256 xhp256 xhn256 vdd vbsyn gsyn
Xihx_1_256 a_xp1 a_xn1 wp_ih_1_256 wn_ih_1_256 xhp256 xhn256 vdd vbsyn gsyn
Xihx_2_256 a_xp2 a_xn2 wp_ih_2_256 wn_ih_2_256 xhp256 xhn256 vdd vbsyn gsyn
Xn256 xhp256 xhn256 ahp256 ahn256 vdd vbneu dneuron
Xcm_xh257 xhp257 xhn257 vdd cmld
Rnd_xh257 xhp257 xhn257 20k
Cxh257p xhp257 0 1e-13
Cxh257n xhn257 0 1e-13
Xihx_0_257 a_xp0 a_xn0 wp_ih_0_257 wn_ih_0_257 xhp257 xhn257 vdd vbsyn gsyn
Xihx_1_257 a_xp1 a_xn1 wp_ih_1_257 wn_ih_1_257 xhp257 xhn257 vdd vbsyn gsyn
Xihx_2_257 a_xp2 a_xn2 wp_ih_2_257 wn_ih_2_257 xhp257 xhn257 vdd vbsyn gsyn
Xn257 xhp257 xhn257 ahp257 ahn257 vdd vbneu dneuron
Xcm_xh258 xhp258 xhn258 vdd cmld
Rnd_xh258 xhp258 xhn258 20k
Cxh258p xhp258 0 1e-13
Cxh258n xhn258 0 1e-13
Xihx_0_258 a_xp0 a_xn0 wp_ih_0_258 wn_ih_0_258 xhp258 xhn258 vdd vbsyn gsyn
Xihx_1_258 a_xp1 a_xn1 wp_ih_1_258 wn_ih_1_258 xhp258 xhn258 vdd vbsyn gsyn
Xihx_2_258 a_xp2 a_xn2 wp_ih_2_258 wn_ih_2_258 xhp258 xhn258 vdd vbsyn gsyn
Xn258 xhp258 xhn258 ahp258 ahn258 vdd vbneu dneuron
Xcm_xh259 xhp259 xhn259 vdd cmld
Rnd_xh259 xhp259 xhn259 20k
Cxh259p xhp259 0 1e-13
Cxh259n xhn259 0 1e-13
Xihx_0_259 a_xp0 a_xn0 wp_ih_0_259 wn_ih_0_259 xhp259 xhn259 vdd vbsyn gsyn
Xihx_1_259 a_xp1 a_xn1 wp_ih_1_259 wn_ih_1_259 xhp259 xhn259 vdd vbsyn gsyn
Xihx_2_259 a_xp2 a_xn2 wp_ih_2_259 wn_ih_2_259 xhp259 xhn259 vdd vbsyn gsyn
Xn259 xhp259 xhn259 ahp259 ahn259 vdd vbneu dneuron
Xcm_xh260 xhp260 xhn260 vdd cmld
Rnd_xh260 xhp260 xhn260 20k
Cxh260p xhp260 0 1e-13
Cxh260n xhn260 0 1e-13
Xihx_0_260 a_xp0 a_xn0 wp_ih_0_260 wn_ih_0_260 xhp260 xhn260 vdd vbsyn gsyn
Xihx_1_260 a_xp1 a_xn1 wp_ih_1_260 wn_ih_1_260 xhp260 xhn260 vdd vbsyn gsyn
Xihx_2_260 a_xp2 a_xn2 wp_ih_2_260 wn_ih_2_260 xhp260 xhn260 vdd vbsyn gsyn
Xn260 xhp260 xhn260 ahp260 ahn260 vdd vbneu dneuron
Xcm_xh261 xhp261 xhn261 vdd cmld
Rnd_xh261 xhp261 xhn261 20k
Cxh261p xhp261 0 1e-13
Cxh261n xhn261 0 1e-13
Xihx_0_261 a_xp0 a_xn0 wp_ih_0_261 wn_ih_0_261 xhp261 xhn261 vdd vbsyn gsyn
Xihx_1_261 a_xp1 a_xn1 wp_ih_1_261 wn_ih_1_261 xhp261 xhn261 vdd vbsyn gsyn
Xihx_2_261 a_xp2 a_xn2 wp_ih_2_261 wn_ih_2_261 xhp261 xhn261 vdd vbsyn gsyn
Xn261 xhp261 xhn261 ahp261 ahn261 vdd vbneu dneuron
Xcm_xh262 xhp262 xhn262 vdd cmld
Rnd_xh262 xhp262 xhn262 20k
Cxh262p xhp262 0 1e-13
Cxh262n xhn262 0 1e-13
Xihx_0_262 a_xp0 a_xn0 wp_ih_0_262 wn_ih_0_262 xhp262 xhn262 vdd vbsyn gsyn
Xihx_1_262 a_xp1 a_xn1 wp_ih_1_262 wn_ih_1_262 xhp262 xhn262 vdd vbsyn gsyn
Xihx_2_262 a_xp2 a_xn2 wp_ih_2_262 wn_ih_2_262 xhp262 xhn262 vdd vbsyn gsyn
Xn262 xhp262 xhn262 ahp262 ahn262 vdd vbneu dneuron
Xcm_xh263 xhp263 xhn263 vdd cmld
Rnd_xh263 xhp263 xhn263 20k
Cxh263p xhp263 0 1e-13
Cxh263n xhn263 0 1e-13
Xihx_0_263 a_xp0 a_xn0 wp_ih_0_263 wn_ih_0_263 xhp263 xhn263 vdd vbsyn gsyn
Xihx_1_263 a_xp1 a_xn1 wp_ih_1_263 wn_ih_1_263 xhp263 xhn263 vdd vbsyn gsyn
Xihx_2_263 a_xp2 a_xn2 wp_ih_2_263 wn_ih_2_263 xhp263 xhn263 vdd vbsyn gsyn
Xn263 xhp263 xhn263 ahp263 ahn263 vdd vbneu dneuron
Xcm_xh264 xhp264 xhn264 vdd cmld
Rnd_xh264 xhp264 xhn264 20k
Cxh264p xhp264 0 1e-13
Cxh264n xhn264 0 1e-13
Xihx_0_264 a_xp0 a_xn0 wp_ih_0_264 wn_ih_0_264 xhp264 xhn264 vdd vbsyn gsyn
Xihx_1_264 a_xp1 a_xn1 wp_ih_1_264 wn_ih_1_264 xhp264 xhn264 vdd vbsyn gsyn
Xihx_2_264 a_xp2 a_xn2 wp_ih_2_264 wn_ih_2_264 xhp264 xhn264 vdd vbsyn gsyn
Xn264 xhp264 xhn264 ahp264 ahn264 vdd vbneu dneuron
Xcm_xh265 xhp265 xhn265 vdd cmld
Rnd_xh265 xhp265 xhn265 20k
Cxh265p xhp265 0 1e-13
Cxh265n xhn265 0 1e-13
Xihx_0_265 a_xp0 a_xn0 wp_ih_0_265 wn_ih_0_265 xhp265 xhn265 vdd vbsyn gsyn
Xihx_1_265 a_xp1 a_xn1 wp_ih_1_265 wn_ih_1_265 xhp265 xhn265 vdd vbsyn gsyn
Xihx_2_265 a_xp2 a_xn2 wp_ih_2_265 wn_ih_2_265 xhp265 xhn265 vdd vbsyn gsyn
Xn265 xhp265 xhn265 ahp265 ahn265 vdd vbneu dneuron
Xcm_xh266 xhp266 xhn266 vdd cmld
Rnd_xh266 xhp266 xhn266 20k
Cxh266p xhp266 0 1e-13
Cxh266n xhn266 0 1e-13
Xihx_0_266 a_xp0 a_xn0 wp_ih_0_266 wn_ih_0_266 xhp266 xhn266 vdd vbsyn gsyn
Xihx_1_266 a_xp1 a_xn1 wp_ih_1_266 wn_ih_1_266 xhp266 xhn266 vdd vbsyn gsyn
Xihx_2_266 a_xp2 a_xn2 wp_ih_2_266 wn_ih_2_266 xhp266 xhn266 vdd vbsyn gsyn
Xn266 xhp266 xhn266 ahp266 ahn266 vdd vbneu dneuron
Xcm_xh267 xhp267 xhn267 vdd cmld
Rnd_xh267 xhp267 xhn267 20k
Cxh267p xhp267 0 1e-13
Cxh267n xhn267 0 1e-13
Xihx_0_267 a_xp0 a_xn0 wp_ih_0_267 wn_ih_0_267 xhp267 xhn267 vdd vbsyn gsyn
Xihx_1_267 a_xp1 a_xn1 wp_ih_1_267 wn_ih_1_267 xhp267 xhn267 vdd vbsyn gsyn
Xihx_2_267 a_xp2 a_xn2 wp_ih_2_267 wn_ih_2_267 xhp267 xhn267 vdd vbsyn gsyn
Xn267 xhp267 xhn267 ahp267 ahn267 vdd vbneu dneuron
Xcm_xh268 xhp268 xhn268 vdd cmld
Rnd_xh268 xhp268 xhn268 20k
Cxh268p xhp268 0 1e-13
Cxh268n xhn268 0 1e-13
Xihx_0_268 a_xp0 a_xn0 wp_ih_0_268 wn_ih_0_268 xhp268 xhn268 vdd vbsyn gsyn
Xihx_1_268 a_xp1 a_xn1 wp_ih_1_268 wn_ih_1_268 xhp268 xhn268 vdd vbsyn gsyn
Xihx_2_268 a_xp2 a_xn2 wp_ih_2_268 wn_ih_2_268 xhp268 xhn268 vdd vbsyn gsyn
Xn268 xhp268 xhn268 ahp268 ahn268 vdd vbneu dneuron
Xcm_xh269 xhp269 xhn269 vdd cmld
Rnd_xh269 xhp269 xhn269 20k
Cxh269p xhp269 0 1e-13
Cxh269n xhn269 0 1e-13
Xihx_0_269 a_xp0 a_xn0 wp_ih_0_269 wn_ih_0_269 xhp269 xhn269 vdd vbsyn gsyn
Xihx_1_269 a_xp1 a_xn1 wp_ih_1_269 wn_ih_1_269 xhp269 xhn269 vdd vbsyn gsyn
Xihx_2_269 a_xp2 a_xn2 wp_ih_2_269 wn_ih_2_269 xhp269 xhn269 vdd vbsyn gsyn
Xn269 xhp269 xhn269 ahp269 ahn269 vdd vbneu dneuron
Xcm_xh270 xhp270 xhn270 vdd cmld
Rnd_xh270 xhp270 xhn270 20k
Cxh270p xhp270 0 1e-13
Cxh270n xhn270 0 1e-13
Xihx_0_270 a_xp0 a_xn0 wp_ih_0_270 wn_ih_0_270 xhp270 xhn270 vdd vbsyn gsyn
Xihx_1_270 a_xp1 a_xn1 wp_ih_1_270 wn_ih_1_270 xhp270 xhn270 vdd vbsyn gsyn
Xihx_2_270 a_xp2 a_xn2 wp_ih_2_270 wn_ih_2_270 xhp270 xhn270 vdd vbsyn gsyn
Xn270 xhp270 xhn270 ahp270 ahn270 vdd vbneu dneuron
Xcm_xh271 xhp271 xhn271 vdd cmld
Rnd_xh271 xhp271 xhn271 20k
Cxh271p xhp271 0 1e-13
Cxh271n xhn271 0 1e-13
Xihx_0_271 a_xp0 a_xn0 wp_ih_0_271 wn_ih_0_271 xhp271 xhn271 vdd vbsyn gsyn
Xihx_1_271 a_xp1 a_xn1 wp_ih_1_271 wn_ih_1_271 xhp271 xhn271 vdd vbsyn gsyn
Xihx_2_271 a_xp2 a_xn2 wp_ih_2_271 wn_ih_2_271 xhp271 xhn271 vdd vbsyn gsyn
Xn271 xhp271 xhn271 ahp271 ahn271 vdd vbneu dneuron
Xcm_xh272 xhp272 xhn272 vdd cmld
Rnd_xh272 xhp272 xhn272 20k
Cxh272p xhp272 0 1e-13
Cxh272n xhn272 0 1e-13
Xihx_0_272 a_xp0 a_xn0 wp_ih_0_272 wn_ih_0_272 xhp272 xhn272 vdd vbsyn gsyn
Xihx_1_272 a_xp1 a_xn1 wp_ih_1_272 wn_ih_1_272 xhp272 xhn272 vdd vbsyn gsyn
Xihx_2_272 a_xp2 a_xn2 wp_ih_2_272 wn_ih_2_272 xhp272 xhn272 vdd vbsyn gsyn
Xn272 xhp272 xhn272 ahp272 ahn272 vdd vbneu dneuron
Xcm_xh273 xhp273 xhn273 vdd cmld
Rnd_xh273 xhp273 xhn273 20k
Cxh273p xhp273 0 1e-13
Cxh273n xhn273 0 1e-13
Xihx_0_273 a_xp0 a_xn0 wp_ih_0_273 wn_ih_0_273 xhp273 xhn273 vdd vbsyn gsyn
Xihx_1_273 a_xp1 a_xn1 wp_ih_1_273 wn_ih_1_273 xhp273 xhn273 vdd vbsyn gsyn
Xihx_2_273 a_xp2 a_xn2 wp_ih_2_273 wn_ih_2_273 xhp273 xhn273 vdd vbsyn gsyn
Xn273 xhp273 xhn273 ahp273 ahn273 vdd vbneu dneuron
Xcm_xh274 xhp274 xhn274 vdd cmld
Rnd_xh274 xhp274 xhn274 20k
Cxh274p xhp274 0 1e-13
Cxh274n xhn274 0 1e-13
Xihx_0_274 a_xp0 a_xn0 wp_ih_0_274 wn_ih_0_274 xhp274 xhn274 vdd vbsyn gsyn
Xihx_1_274 a_xp1 a_xn1 wp_ih_1_274 wn_ih_1_274 xhp274 xhn274 vdd vbsyn gsyn
Xihx_2_274 a_xp2 a_xn2 wp_ih_2_274 wn_ih_2_274 xhp274 xhn274 vdd vbsyn gsyn
Xn274 xhp274 xhn274 ahp274 ahn274 vdd vbneu dneuron
Xcm_xh275 xhp275 xhn275 vdd cmld
Rnd_xh275 xhp275 xhn275 20k
Cxh275p xhp275 0 1e-13
Cxh275n xhn275 0 1e-13
Xihx_0_275 a_xp0 a_xn0 wp_ih_0_275 wn_ih_0_275 xhp275 xhn275 vdd vbsyn gsyn
Xihx_1_275 a_xp1 a_xn1 wp_ih_1_275 wn_ih_1_275 xhp275 xhn275 vdd vbsyn gsyn
Xihx_2_275 a_xp2 a_xn2 wp_ih_2_275 wn_ih_2_275 xhp275 xhn275 vdd vbsyn gsyn
Xn275 xhp275 xhn275 ahp275 ahn275 vdd vbneu dneuron
Xcm_xh276 xhp276 xhn276 vdd cmld
Rnd_xh276 xhp276 xhn276 20k
Cxh276p xhp276 0 1e-13
Cxh276n xhn276 0 1e-13
Xihx_0_276 a_xp0 a_xn0 wp_ih_0_276 wn_ih_0_276 xhp276 xhn276 vdd vbsyn gsyn
Xihx_1_276 a_xp1 a_xn1 wp_ih_1_276 wn_ih_1_276 xhp276 xhn276 vdd vbsyn gsyn
Xihx_2_276 a_xp2 a_xn2 wp_ih_2_276 wn_ih_2_276 xhp276 xhn276 vdd vbsyn gsyn
Xn276 xhp276 xhn276 ahp276 ahn276 vdd vbneu dneuron
Xcm_xh277 xhp277 xhn277 vdd cmld
Rnd_xh277 xhp277 xhn277 20k
Cxh277p xhp277 0 1e-13
Cxh277n xhn277 0 1e-13
Xihx_0_277 a_xp0 a_xn0 wp_ih_0_277 wn_ih_0_277 xhp277 xhn277 vdd vbsyn gsyn
Xihx_1_277 a_xp1 a_xn1 wp_ih_1_277 wn_ih_1_277 xhp277 xhn277 vdd vbsyn gsyn
Xihx_2_277 a_xp2 a_xn2 wp_ih_2_277 wn_ih_2_277 xhp277 xhn277 vdd vbsyn gsyn
Xn277 xhp277 xhn277 ahp277 ahn277 vdd vbneu dneuron
Xcm_xh278 xhp278 xhn278 vdd cmld
Rnd_xh278 xhp278 xhn278 20k
Cxh278p xhp278 0 1e-13
Cxh278n xhn278 0 1e-13
Xihx_0_278 a_xp0 a_xn0 wp_ih_0_278 wn_ih_0_278 xhp278 xhn278 vdd vbsyn gsyn
Xihx_1_278 a_xp1 a_xn1 wp_ih_1_278 wn_ih_1_278 xhp278 xhn278 vdd vbsyn gsyn
Xihx_2_278 a_xp2 a_xn2 wp_ih_2_278 wn_ih_2_278 xhp278 xhn278 vdd vbsyn gsyn
Xn278 xhp278 xhn278 ahp278 ahn278 vdd vbneu dneuron
Xcm_xh279 xhp279 xhn279 vdd cmld
Rnd_xh279 xhp279 xhn279 20k
Cxh279p xhp279 0 1e-13
Cxh279n xhn279 0 1e-13
Xihx_0_279 a_xp0 a_xn0 wp_ih_0_279 wn_ih_0_279 xhp279 xhn279 vdd vbsyn gsyn
Xihx_1_279 a_xp1 a_xn1 wp_ih_1_279 wn_ih_1_279 xhp279 xhn279 vdd vbsyn gsyn
Xihx_2_279 a_xp2 a_xn2 wp_ih_2_279 wn_ih_2_279 xhp279 xhn279 vdd vbsyn gsyn
Xn279 xhp279 xhn279 ahp279 ahn279 vdd vbneu dneuron
Xcm_xh280 xhp280 xhn280 vdd cmld
Rnd_xh280 xhp280 xhn280 20k
Cxh280p xhp280 0 1e-13
Cxh280n xhn280 0 1e-13
Xihx_0_280 a_xp0 a_xn0 wp_ih_0_280 wn_ih_0_280 xhp280 xhn280 vdd vbsyn gsyn
Xihx_1_280 a_xp1 a_xn1 wp_ih_1_280 wn_ih_1_280 xhp280 xhn280 vdd vbsyn gsyn
Xihx_2_280 a_xp2 a_xn2 wp_ih_2_280 wn_ih_2_280 xhp280 xhn280 vdd vbsyn gsyn
Xn280 xhp280 xhn280 ahp280 ahn280 vdd vbneu dneuron
Xcm_xh281 xhp281 xhn281 vdd cmld
Rnd_xh281 xhp281 xhn281 20k
Cxh281p xhp281 0 1e-13
Cxh281n xhn281 0 1e-13
Xihx_0_281 a_xp0 a_xn0 wp_ih_0_281 wn_ih_0_281 xhp281 xhn281 vdd vbsyn gsyn
Xihx_1_281 a_xp1 a_xn1 wp_ih_1_281 wn_ih_1_281 xhp281 xhn281 vdd vbsyn gsyn
Xihx_2_281 a_xp2 a_xn2 wp_ih_2_281 wn_ih_2_281 xhp281 xhn281 vdd vbsyn gsyn
Xn281 xhp281 xhn281 ahp281 ahn281 vdd vbneu dneuron
Xcm_xh282 xhp282 xhn282 vdd cmld
Rnd_xh282 xhp282 xhn282 20k
Cxh282p xhp282 0 1e-13
Cxh282n xhn282 0 1e-13
Xihx_0_282 a_xp0 a_xn0 wp_ih_0_282 wn_ih_0_282 xhp282 xhn282 vdd vbsyn gsyn
Xihx_1_282 a_xp1 a_xn1 wp_ih_1_282 wn_ih_1_282 xhp282 xhn282 vdd vbsyn gsyn
Xihx_2_282 a_xp2 a_xn2 wp_ih_2_282 wn_ih_2_282 xhp282 xhn282 vdd vbsyn gsyn
Xn282 xhp282 xhn282 ahp282 ahn282 vdd vbneu dneuron
Xcm_xh283 xhp283 xhn283 vdd cmld
Rnd_xh283 xhp283 xhn283 20k
Cxh283p xhp283 0 1e-13
Cxh283n xhn283 0 1e-13
Xihx_0_283 a_xp0 a_xn0 wp_ih_0_283 wn_ih_0_283 xhp283 xhn283 vdd vbsyn gsyn
Xihx_1_283 a_xp1 a_xn1 wp_ih_1_283 wn_ih_1_283 xhp283 xhn283 vdd vbsyn gsyn
Xihx_2_283 a_xp2 a_xn2 wp_ih_2_283 wn_ih_2_283 xhp283 xhn283 vdd vbsyn gsyn
Xn283 xhp283 xhn283 ahp283 ahn283 vdd vbneu dneuron
Xcm_xh284 xhp284 xhn284 vdd cmld
Rnd_xh284 xhp284 xhn284 20k
Cxh284p xhp284 0 1e-13
Cxh284n xhn284 0 1e-13
Xihx_0_284 a_xp0 a_xn0 wp_ih_0_284 wn_ih_0_284 xhp284 xhn284 vdd vbsyn gsyn
Xihx_1_284 a_xp1 a_xn1 wp_ih_1_284 wn_ih_1_284 xhp284 xhn284 vdd vbsyn gsyn
Xihx_2_284 a_xp2 a_xn2 wp_ih_2_284 wn_ih_2_284 xhp284 xhn284 vdd vbsyn gsyn
Xn284 xhp284 xhn284 ahp284 ahn284 vdd vbneu dneuron
Xcm_xh285 xhp285 xhn285 vdd cmld
Rnd_xh285 xhp285 xhn285 20k
Cxh285p xhp285 0 1e-13
Cxh285n xhn285 0 1e-13
Xihx_0_285 a_xp0 a_xn0 wp_ih_0_285 wn_ih_0_285 xhp285 xhn285 vdd vbsyn gsyn
Xihx_1_285 a_xp1 a_xn1 wp_ih_1_285 wn_ih_1_285 xhp285 xhn285 vdd vbsyn gsyn
Xihx_2_285 a_xp2 a_xn2 wp_ih_2_285 wn_ih_2_285 xhp285 xhn285 vdd vbsyn gsyn
Xn285 xhp285 xhn285 ahp285 ahn285 vdd vbneu dneuron
Xcm_xh286 xhp286 xhn286 vdd cmld
Rnd_xh286 xhp286 xhn286 20k
Cxh286p xhp286 0 1e-13
Cxh286n xhn286 0 1e-13
Xihx_0_286 a_xp0 a_xn0 wp_ih_0_286 wn_ih_0_286 xhp286 xhn286 vdd vbsyn gsyn
Xihx_1_286 a_xp1 a_xn1 wp_ih_1_286 wn_ih_1_286 xhp286 xhn286 vdd vbsyn gsyn
Xihx_2_286 a_xp2 a_xn2 wp_ih_2_286 wn_ih_2_286 xhp286 xhn286 vdd vbsyn gsyn
Xn286 xhp286 xhn286 ahp286 ahn286 vdd vbneu dneuron
Xcm_xh287 xhp287 xhn287 vdd cmld
Rnd_xh287 xhp287 xhn287 20k
Cxh287p xhp287 0 1e-13
Cxh287n xhn287 0 1e-13
Xihx_0_287 a_xp0 a_xn0 wp_ih_0_287 wn_ih_0_287 xhp287 xhn287 vdd vbsyn gsyn
Xihx_1_287 a_xp1 a_xn1 wp_ih_1_287 wn_ih_1_287 xhp287 xhn287 vdd vbsyn gsyn
Xihx_2_287 a_xp2 a_xn2 wp_ih_2_287 wn_ih_2_287 xhp287 xhn287 vdd vbsyn gsyn
Xn287 xhp287 xhn287 ahp287 ahn287 vdd vbneu dneuron
Xcm_mo0 mop0 mon0 vdd cmld
Rnd_mo0 mop0 mon0 20k
Cmo0p mop0 0 1e-13
Cmo0n mon0 0 1e-13
Xho_0_0 ahp0 ahn0 wp_ho_0_0 wn_ho_0_0 mop0 mon0 vdd vbsyn gsyn
Xho_1_0 ahp1 ahn1 wp_ho_1_0 wn_ho_1_0 mop0 mon0 vdd vbsyn gsyn
Xho_2_0 ahp2 ahn2 wp_ho_2_0 wn_ho_2_0 mop0 mon0 vdd vbsyn gsyn
Xho_3_0 ahp3 ahn3 wp_ho_3_0 wn_ho_3_0 mop0 mon0 vdd vbsyn gsyn
Xho_4_0 ahp4 ahn4 wp_ho_4_0 wn_ho_4_0 mop0 mon0 vdd vbsyn gsyn
Xho_5_0 ahp5 ahn5 wp_ho_5_0 wn_ho_5_0 mop0 mon0 vdd vbsyn gsyn
Xho_6_0 ahp6 ahn6 wp_ho_6_0 wn_ho_6_0 mop0 mon0 vdd vbsyn gsyn
Xho_7_0 ahp7 ahn7 wp_ho_7_0 wn_ho_7_0 mop0 mon0 vdd vbsyn gsyn
Xho_8_0 ahp8 ahn8 wp_ho_8_0 wn_ho_8_0 mop0 mon0 vdd vbsyn gsyn
Xho_9_0 ahp9 ahn9 wp_ho_9_0 wn_ho_9_0 mop0 mon0 vdd vbsyn gsyn
Xho_10_0 ahp10 ahn10 wp_ho_10_0 wn_ho_10_0 mop0 mon0 vdd vbsyn gsyn
Xho_11_0 ahp11 ahn11 wp_ho_11_0 wn_ho_11_0 mop0 mon0 vdd vbsyn gsyn
Xho_12_0 ahp12 ahn12 wp_ho_12_0 wn_ho_12_0 mop0 mon0 vdd vbsyn gsyn
Xho_13_0 ahp13 ahn13 wp_ho_13_0 wn_ho_13_0 mop0 mon0 vdd vbsyn gsyn
Xho_14_0 ahp14 ahn14 wp_ho_14_0 wn_ho_14_0 mop0 mon0 vdd vbsyn gsyn
Xho_15_0 ahp15 ahn15 wp_ho_15_0 wn_ho_15_0 mop0 mon0 vdd vbsyn gsyn
Xho_16_0 ahp16 ahn16 wp_ho_16_0 wn_ho_16_0 mop0 mon0 vdd vbsyn gsyn
Xho_17_0 ahp17 ahn17 wp_ho_17_0 wn_ho_17_0 mop0 mon0 vdd vbsyn gsyn
Xho_18_0 ahp18 ahn18 wp_ho_18_0 wn_ho_18_0 mop0 mon0 vdd vbsyn gsyn
Xho_19_0 ahp19 ahn19 wp_ho_19_0 wn_ho_19_0 mop0 mon0 vdd vbsyn gsyn
Xho_20_0 ahp20 ahn20 wp_ho_20_0 wn_ho_20_0 mop0 mon0 vdd vbsyn gsyn
Xho_21_0 ahp21 ahn21 wp_ho_21_0 wn_ho_21_0 mop0 mon0 vdd vbsyn gsyn
Xho_22_0 ahp22 ahn22 wp_ho_22_0 wn_ho_22_0 mop0 mon0 vdd vbsyn gsyn
Xho_23_0 ahp23 ahn23 wp_ho_23_0 wn_ho_23_0 mop0 mon0 vdd vbsyn gsyn
Xho_24_0 ahp24 ahn24 wp_ho_24_0 wn_ho_24_0 mop0 mon0 vdd vbsyn gsyn
Xho_25_0 ahp25 ahn25 wp_ho_25_0 wn_ho_25_0 mop0 mon0 vdd vbsyn gsyn
Xho_26_0 ahp26 ahn26 wp_ho_26_0 wn_ho_26_0 mop0 mon0 vdd vbsyn gsyn
Xho_27_0 ahp27 ahn27 wp_ho_27_0 wn_ho_27_0 mop0 mon0 vdd vbsyn gsyn
Xho_28_0 ahp28 ahn28 wp_ho_28_0 wn_ho_28_0 mop0 mon0 vdd vbsyn gsyn
Xho_29_0 ahp29 ahn29 wp_ho_29_0 wn_ho_29_0 mop0 mon0 vdd vbsyn gsyn
Xho_30_0 ahp30 ahn30 wp_ho_30_0 wn_ho_30_0 mop0 mon0 vdd vbsyn gsyn
Xho_31_0 ahp31 ahn31 wp_ho_31_0 wn_ho_31_0 mop0 mon0 vdd vbsyn gsyn
Xho_32_0 ahp32 ahn32 wp_ho_32_0 wn_ho_32_0 mop0 mon0 vdd vbsyn gsyn
Xho_33_0 ahp33 ahn33 wp_ho_33_0 wn_ho_33_0 mop0 mon0 vdd vbsyn gsyn
Xho_34_0 ahp34 ahn34 wp_ho_34_0 wn_ho_34_0 mop0 mon0 vdd vbsyn gsyn
Xho_35_0 ahp35 ahn35 wp_ho_35_0 wn_ho_35_0 mop0 mon0 vdd vbsyn gsyn
Xho_36_0 ahp36 ahn36 wp_ho_36_0 wn_ho_36_0 mop0 mon0 vdd vbsyn gsyn
Xho_37_0 ahp37 ahn37 wp_ho_37_0 wn_ho_37_0 mop0 mon0 vdd vbsyn gsyn
Xho_38_0 ahp38 ahn38 wp_ho_38_0 wn_ho_38_0 mop0 mon0 vdd vbsyn gsyn
Xho_39_0 ahp39 ahn39 wp_ho_39_0 wn_ho_39_0 mop0 mon0 vdd vbsyn gsyn
Xho_40_0 ahp40 ahn40 wp_ho_40_0 wn_ho_40_0 mop0 mon0 vdd vbsyn gsyn
Xho_41_0 ahp41 ahn41 wp_ho_41_0 wn_ho_41_0 mop0 mon0 vdd vbsyn gsyn
Xho_42_0 ahp42 ahn42 wp_ho_42_0 wn_ho_42_0 mop0 mon0 vdd vbsyn gsyn
Xho_43_0 ahp43 ahn43 wp_ho_43_0 wn_ho_43_0 mop0 mon0 vdd vbsyn gsyn
Xho_44_0 ahp44 ahn44 wp_ho_44_0 wn_ho_44_0 mop0 mon0 vdd vbsyn gsyn
Xho_45_0 ahp45 ahn45 wp_ho_45_0 wn_ho_45_0 mop0 mon0 vdd vbsyn gsyn
Xho_46_0 ahp46 ahn46 wp_ho_46_0 wn_ho_46_0 mop0 mon0 vdd vbsyn gsyn
Xho_47_0 ahp47 ahn47 wp_ho_47_0 wn_ho_47_0 mop0 mon0 vdd vbsyn gsyn
Xho_48_0 ahp48 ahn48 wp_ho_48_0 wn_ho_48_0 mop0 mon0 vdd vbsyn gsyn
Xho_49_0 ahp49 ahn49 wp_ho_49_0 wn_ho_49_0 mop0 mon0 vdd vbsyn gsyn
Xho_50_0 ahp50 ahn50 wp_ho_50_0 wn_ho_50_0 mop0 mon0 vdd vbsyn gsyn
Xho_51_0 ahp51 ahn51 wp_ho_51_0 wn_ho_51_0 mop0 mon0 vdd vbsyn gsyn
Xho_52_0 ahp52 ahn52 wp_ho_52_0 wn_ho_52_0 mop0 mon0 vdd vbsyn gsyn
Xho_53_0 ahp53 ahn53 wp_ho_53_0 wn_ho_53_0 mop0 mon0 vdd vbsyn gsyn
Xho_54_0 ahp54 ahn54 wp_ho_54_0 wn_ho_54_0 mop0 mon0 vdd vbsyn gsyn
Xho_55_0 ahp55 ahn55 wp_ho_55_0 wn_ho_55_0 mop0 mon0 vdd vbsyn gsyn
Xho_56_0 ahp56 ahn56 wp_ho_56_0 wn_ho_56_0 mop0 mon0 vdd vbsyn gsyn
Xho_57_0 ahp57 ahn57 wp_ho_57_0 wn_ho_57_0 mop0 mon0 vdd vbsyn gsyn
Xho_58_0 ahp58 ahn58 wp_ho_58_0 wn_ho_58_0 mop0 mon0 vdd vbsyn gsyn
Xho_59_0 ahp59 ahn59 wp_ho_59_0 wn_ho_59_0 mop0 mon0 vdd vbsyn gsyn
Xho_60_0 ahp60 ahn60 wp_ho_60_0 wn_ho_60_0 mop0 mon0 vdd vbsyn gsyn
Xho_61_0 ahp61 ahn61 wp_ho_61_0 wn_ho_61_0 mop0 mon0 vdd vbsyn gsyn
Xho_62_0 ahp62 ahn62 wp_ho_62_0 wn_ho_62_0 mop0 mon0 vdd vbsyn gsyn
Xho_63_0 ahp63 ahn63 wp_ho_63_0 wn_ho_63_0 mop0 mon0 vdd vbsyn gsyn
Xho_64_0 ahp64 ahn64 wp_ho_64_0 wn_ho_64_0 mop0 mon0 vdd vbsyn gsyn
Xho_65_0 ahp65 ahn65 wp_ho_65_0 wn_ho_65_0 mop0 mon0 vdd vbsyn gsyn
Xho_66_0 ahp66 ahn66 wp_ho_66_0 wn_ho_66_0 mop0 mon0 vdd vbsyn gsyn
Xho_67_0 ahp67 ahn67 wp_ho_67_0 wn_ho_67_0 mop0 mon0 vdd vbsyn gsyn
Xho_68_0 ahp68 ahn68 wp_ho_68_0 wn_ho_68_0 mop0 mon0 vdd vbsyn gsyn
Xho_69_0 ahp69 ahn69 wp_ho_69_0 wn_ho_69_0 mop0 mon0 vdd vbsyn gsyn
Xho_70_0 ahp70 ahn70 wp_ho_70_0 wn_ho_70_0 mop0 mon0 vdd vbsyn gsyn
Xho_71_0 ahp71 ahn71 wp_ho_71_0 wn_ho_71_0 mop0 mon0 vdd vbsyn gsyn
Xho_72_0 ahp72 ahn72 wp_ho_72_0 wn_ho_72_0 mop0 mon0 vdd vbsyn gsyn
Xho_73_0 ahp73 ahn73 wp_ho_73_0 wn_ho_73_0 mop0 mon0 vdd vbsyn gsyn
Xho_74_0 ahp74 ahn74 wp_ho_74_0 wn_ho_74_0 mop0 mon0 vdd vbsyn gsyn
Xho_75_0 ahp75 ahn75 wp_ho_75_0 wn_ho_75_0 mop0 mon0 vdd vbsyn gsyn
Xho_76_0 ahp76 ahn76 wp_ho_76_0 wn_ho_76_0 mop0 mon0 vdd vbsyn gsyn
Xho_77_0 ahp77 ahn77 wp_ho_77_0 wn_ho_77_0 mop0 mon0 vdd vbsyn gsyn
Xho_78_0 ahp78 ahn78 wp_ho_78_0 wn_ho_78_0 mop0 mon0 vdd vbsyn gsyn
Xho_79_0 ahp79 ahn79 wp_ho_79_0 wn_ho_79_0 mop0 mon0 vdd vbsyn gsyn
Xho_80_0 ahp80 ahn80 wp_ho_80_0 wn_ho_80_0 mop0 mon0 vdd vbsyn gsyn
Xho_81_0 ahp81 ahn81 wp_ho_81_0 wn_ho_81_0 mop0 mon0 vdd vbsyn gsyn
Xho_82_0 ahp82 ahn82 wp_ho_82_0 wn_ho_82_0 mop0 mon0 vdd vbsyn gsyn
Xho_83_0 ahp83 ahn83 wp_ho_83_0 wn_ho_83_0 mop0 mon0 vdd vbsyn gsyn
Xho_84_0 ahp84 ahn84 wp_ho_84_0 wn_ho_84_0 mop0 mon0 vdd vbsyn gsyn
Xho_85_0 ahp85 ahn85 wp_ho_85_0 wn_ho_85_0 mop0 mon0 vdd vbsyn gsyn
Xho_86_0 ahp86 ahn86 wp_ho_86_0 wn_ho_86_0 mop0 mon0 vdd vbsyn gsyn
Xho_87_0 ahp87 ahn87 wp_ho_87_0 wn_ho_87_0 mop0 mon0 vdd vbsyn gsyn
Xho_88_0 ahp88 ahn88 wp_ho_88_0 wn_ho_88_0 mop0 mon0 vdd vbsyn gsyn
Xho_89_0 ahp89 ahn89 wp_ho_89_0 wn_ho_89_0 mop0 mon0 vdd vbsyn gsyn
Xho_90_0 ahp90 ahn90 wp_ho_90_0 wn_ho_90_0 mop0 mon0 vdd vbsyn gsyn
Xho_91_0 ahp91 ahn91 wp_ho_91_0 wn_ho_91_0 mop0 mon0 vdd vbsyn gsyn
Xho_92_0 ahp92 ahn92 wp_ho_92_0 wn_ho_92_0 mop0 mon0 vdd vbsyn gsyn
Xho_93_0 ahp93 ahn93 wp_ho_93_0 wn_ho_93_0 mop0 mon0 vdd vbsyn gsyn
Xho_94_0 ahp94 ahn94 wp_ho_94_0 wn_ho_94_0 mop0 mon0 vdd vbsyn gsyn
Xho_95_0 ahp95 ahn95 wp_ho_95_0 wn_ho_95_0 mop0 mon0 vdd vbsyn gsyn
Xho_96_0 ahp96 ahn96 wp_ho_96_0 wn_ho_96_0 mop0 mon0 vdd vbsyn gsyn
Xho_97_0 ahp97 ahn97 wp_ho_97_0 wn_ho_97_0 mop0 mon0 vdd vbsyn gsyn
Xho_98_0 ahp98 ahn98 wp_ho_98_0 wn_ho_98_0 mop0 mon0 vdd vbsyn gsyn
Xho_99_0 ahp99 ahn99 wp_ho_99_0 wn_ho_99_0 mop0 mon0 vdd vbsyn gsyn
Xho_100_0 ahp100 ahn100 wp_ho_100_0 wn_ho_100_0 mop0 mon0 vdd vbsyn gsyn
Xho_101_0 ahp101 ahn101 wp_ho_101_0 wn_ho_101_0 mop0 mon0 vdd vbsyn gsyn
Xho_102_0 ahp102 ahn102 wp_ho_102_0 wn_ho_102_0 mop0 mon0 vdd vbsyn gsyn
Xho_103_0 ahp103 ahn103 wp_ho_103_0 wn_ho_103_0 mop0 mon0 vdd vbsyn gsyn
Xho_104_0 ahp104 ahn104 wp_ho_104_0 wn_ho_104_0 mop0 mon0 vdd vbsyn gsyn
Xho_105_0 ahp105 ahn105 wp_ho_105_0 wn_ho_105_0 mop0 mon0 vdd vbsyn gsyn
Xho_106_0 ahp106 ahn106 wp_ho_106_0 wn_ho_106_0 mop0 mon0 vdd vbsyn gsyn
Xho_107_0 ahp107 ahn107 wp_ho_107_0 wn_ho_107_0 mop0 mon0 vdd vbsyn gsyn
Xho_108_0 ahp108 ahn108 wp_ho_108_0 wn_ho_108_0 mop0 mon0 vdd vbsyn gsyn
Xho_109_0 ahp109 ahn109 wp_ho_109_0 wn_ho_109_0 mop0 mon0 vdd vbsyn gsyn
Xho_110_0 ahp110 ahn110 wp_ho_110_0 wn_ho_110_0 mop0 mon0 vdd vbsyn gsyn
Xho_111_0 ahp111 ahn111 wp_ho_111_0 wn_ho_111_0 mop0 mon0 vdd vbsyn gsyn
Xho_112_0 ahp112 ahn112 wp_ho_112_0 wn_ho_112_0 mop0 mon0 vdd vbsyn gsyn
Xho_113_0 ahp113 ahn113 wp_ho_113_0 wn_ho_113_0 mop0 mon0 vdd vbsyn gsyn
Xho_114_0 ahp114 ahn114 wp_ho_114_0 wn_ho_114_0 mop0 mon0 vdd vbsyn gsyn
Xho_115_0 ahp115 ahn115 wp_ho_115_0 wn_ho_115_0 mop0 mon0 vdd vbsyn gsyn
Xho_116_0 ahp116 ahn116 wp_ho_116_0 wn_ho_116_0 mop0 mon0 vdd vbsyn gsyn
Xho_117_0 ahp117 ahn117 wp_ho_117_0 wn_ho_117_0 mop0 mon0 vdd vbsyn gsyn
Xho_118_0 ahp118 ahn118 wp_ho_118_0 wn_ho_118_0 mop0 mon0 vdd vbsyn gsyn
Xho_119_0 ahp119 ahn119 wp_ho_119_0 wn_ho_119_0 mop0 mon0 vdd vbsyn gsyn
Xho_120_0 ahp120 ahn120 wp_ho_120_0 wn_ho_120_0 mop0 mon0 vdd vbsyn gsyn
Xho_121_0 ahp121 ahn121 wp_ho_121_0 wn_ho_121_0 mop0 mon0 vdd vbsyn gsyn
Xho_122_0 ahp122 ahn122 wp_ho_122_0 wn_ho_122_0 mop0 mon0 vdd vbsyn gsyn
Xho_123_0 ahp123 ahn123 wp_ho_123_0 wn_ho_123_0 mop0 mon0 vdd vbsyn gsyn
Xho_124_0 ahp124 ahn124 wp_ho_124_0 wn_ho_124_0 mop0 mon0 vdd vbsyn gsyn
Xho_125_0 ahp125 ahn125 wp_ho_125_0 wn_ho_125_0 mop0 mon0 vdd vbsyn gsyn
Xho_126_0 ahp126 ahn126 wp_ho_126_0 wn_ho_126_0 mop0 mon0 vdd vbsyn gsyn
Xho_127_0 ahp127 ahn127 wp_ho_127_0 wn_ho_127_0 mop0 mon0 vdd vbsyn gsyn
Xho_128_0 ahp128 ahn128 wp_ho_128_0 wn_ho_128_0 mop0 mon0 vdd vbsyn gsyn
Xho_129_0 ahp129 ahn129 wp_ho_129_0 wn_ho_129_0 mop0 mon0 vdd vbsyn gsyn
Xho_130_0 ahp130 ahn130 wp_ho_130_0 wn_ho_130_0 mop0 mon0 vdd vbsyn gsyn
Xho_131_0 ahp131 ahn131 wp_ho_131_0 wn_ho_131_0 mop0 mon0 vdd vbsyn gsyn
Xho_132_0 ahp132 ahn132 wp_ho_132_0 wn_ho_132_0 mop0 mon0 vdd vbsyn gsyn
Xho_133_0 ahp133 ahn133 wp_ho_133_0 wn_ho_133_0 mop0 mon0 vdd vbsyn gsyn
Xho_134_0 ahp134 ahn134 wp_ho_134_0 wn_ho_134_0 mop0 mon0 vdd vbsyn gsyn
Xho_135_0 ahp135 ahn135 wp_ho_135_0 wn_ho_135_0 mop0 mon0 vdd vbsyn gsyn
Xho_136_0 ahp136 ahn136 wp_ho_136_0 wn_ho_136_0 mop0 mon0 vdd vbsyn gsyn
Xho_137_0 ahp137 ahn137 wp_ho_137_0 wn_ho_137_0 mop0 mon0 vdd vbsyn gsyn
Xho_138_0 ahp138 ahn138 wp_ho_138_0 wn_ho_138_0 mop0 mon0 vdd vbsyn gsyn
Xho_139_0 ahp139 ahn139 wp_ho_139_0 wn_ho_139_0 mop0 mon0 vdd vbsyn gsyn
Xho_140_0 ahp140 ahn140 wp_ho_140_0 wn_ho_140_0 mop0 mon0 vdd vbsyn gsyn
Xho_141_0 ahp141 ahn141 wp_ho_141_0 wn_ho_141_0 mop0 mon0 vdd vbsyn gsyn
Xho_142_0 ahp142 ahn142 wp_ho_142_0 wn_ho_142_0 mop0 mon0 vdd vbsyn gsyn
Xho_143_0 ahp143 ahn143 wp_ho_143_0 wn_ho_143_0 mop0 mon0 vdd vbsyn gsyn
Xho_144_0 ahp144 ahn144 wp_ho_144_0 wn_ho_144_0 mop0 mon0 vdd vbsyn gsyn
Xho_145_0 ahp145 ahn145 wp_ho_145_0 wn_ho_145_0 mop0 mon0 vdd vbsyn gsyn
Xho_146_0 ahp146 ahn146 wp_ho_146_0 wn_ho_146_0 mop0 mon0 vdd vbsyn gsyn
Xho_147_0 ahp147 ahn147 wp_ho_147_0 wn_ho_147_0 mop0 mon0 vdd vbsyn gsyn
Xho_148_0 ahp148 ahn148 wp_ho_148_0 wn_ho_148_0 mop0 mon0 vdd vbsyn gsyn
Xho_149_0 ahp149 ahn149 wp_ho_149_0 wn_ho_149_0 mop0 mon0 vdd vbsyn gsyn
Xho_150_0 ahp150 ahn150 wp_ho_150_0 wn_ho_150_0 mop0 mon0 vdd vbsyn gsyn
Xho_151_0 ahp151 ahn151 wp_ho_151_0 wn_ho_151_0 mop0 mon0 vdd vbsyn gsyn
Xho_152_0 ahp152 ahn152 wp_ho_152_0 wn_ho_152_0 mop0 mon0 vdd vbsyn gsyn
Xho_153_0 ahp153 ahn153 wp_ho_153_0 wn_ho_153_0 mop0 mon0 vdd vbsyn gsyn
Xho_154_0 ahp154 ahn154 wp_ho_154_0 wn_ho_154_0 mop0 mon0 vdd vbsyn gsyn
Xho_155_0 ahp155 ahn155 wp_ho_155_0 wn_ho_155_0 mop0 mon0 vdd vbsyn gsyn
Xho_156_0 ahp156 ahn156 wp_ho_156_0 wn_ho_156_0 mop0 mon0 vdd vbsyn gsyn
Xho_157_0 ahp157 ahn157 wp_ho_157_0 wn_ho_157_0 mop0 mon0 vdd vbsyn gsyn
Xho_158_0 ahp158 ahn158 wp_ho_158_0 wn_ho_158_0 mop0 mon0 vdd vbsyn gsyn
Xho_159_0 ahp159 ahn159 wp_ho_159_0 wn_ho_159_0 mop0 mon0 vdd vbsyn gsyn
Xho_160_0 ahp160 ahn160 wp_ho_160_0 wn_ho_160_0 mop0 mon0 vdd vbsyn gsyn
Xho_161_0 ahp161 ahn161 wp_ho_161_0 wn_ho_161_0 mop0 mon0 vdd vbsyn gsyn
Xho_162_0 ahp162 ahn162 wp_ho_162_0 wn_ho_162_0 mop0 mon0 vdd vbsyn gsyn
Xho_163_0 ahp163 ahn163 wp_ho_163_0 wn_ho_163_0 mop0 mon0 vdd vbsyn gsyn
Xho_164_0 ahp164 ahn164 wp_ho_164_0 wn_ho_164_0 mop0 mon0 vdd vbsyn gsyn
Xho_165_0 ahp165 ahn165 wp_ho_165_0 wn_ho_165_0 mop0 mon0 vdd vbsyn gsyn
Xho_166_0 ahp166 ahn166 wp_ho_166_0 wn_ho_166_0 mop0 mon0 vdd vbsyn gsyn
Xho_167_0 ahp167 ahn167 wp_ho_167_0 wn_ho_167_0 mop0 mon0 vdd vbsyn gsyn
Xho_168_0 ahp168 ahn168 wp_ho_168_0 wn_ho_168_0 mop0 mon0 vdd vbsyn gsyn
Xho_169_0 ahp169 ahn169 wp_ho_169_0 wn_ho_169_0 mop0 mon0 vdd vbsyn gsyn
Xho_170_0 ahp170 ahn170 wp_ho_170_0 wn_ho_170_0 mop0 mon0 vdd vbsyn gsyn
Xho_171_0 ahp171 ahn171 wp_ho_171_0 wn_ho_171_0 mop0 mon0 vdd vbsyn gsyn
Xho_172_0 ahp172 ahn172 wp_ho_172_0 wn_ho_172_0 mop0 mon0 vdd vbsyn gsyn
Xho_173_0 ahp173 ahn173 wp_ho_173_0 wn_ho_173_0 mop0 mon0 vdd vbsyn gsyn
Xho_174_0 ahp174 ahn174 wp_ho_174_0 wn_ho_174_0 mop0 mon0 vdd vbsyn gsyn
Xho_175_0 ahp175 ahn175 wp_ho_175_0 wn_ho_175_0 mop0 mon0 vdd vbsyn gsyn
Xho_176_0 ahp176 ahn176 wp_ho_176_0 wn_ho_176_0 mop0 mon0 vdd vbsyn gsyn
Xho_177_0 ahp177 ahn177 wp_ho_177_0 wn_ho_177_0 mop0 mon0 vdd vbsyn gsyn
Xho_178_0 ahp178 ahn178 wp_ho_178_0 wn_ho_178_0 mop0 mon0 vdd vbsyn gsyn
Xho_179_0 ahp179 ahn179 wp_ho_179_0 wn_ho_179_0 mop0 mon0 vdd vbsyn gsyn
Xho_180_0 ahp180 ahn180 wp_ho_180_0 wn_ho_180_0 mop0 mon0 vdd vbsyn gsyn
Xho_181_0 ahp181 ahn181 wp_ho_181_0 wn_ho_181_0 mop0 mon0 vdd vbsyn gsyn
Xho_182_0 ahp182 ahn182 wp_ho_182_0 wn_ho_182_0 mop0 mon0 vdd vbsyn gsyn
Xho_183_0 ahp183 ahn183 wp_ho_183_0 wn_ho_183_0 mop0 mon0 vdd vbsyn gsyn
Xho_184_0 ahp184 ahn184 wp_ho_184_0 wn_ho_184_0 mop0 mon0 vdd vbsyn gsyn
Xho_185_0 ahp185 ahn185 wp_ho_185_0 wn_ho_185_0 mop0 mon0 vdd vbsyn gsyn
Xho_186_0 ahp186 ahn186 wp_ho_186_0 wn_ho_186_0 mop0 mon0 vdd vbsyn gsyn
Xho_187_0 ahp187 ahn187 wp_ho_187_0 wn_ho_187_0 mop0 mon0 vdd vbsyn gsyn
Xho_188_0 ahp188 ahn188 wp_ho_188_0 wn_ho_188_0 mop0 mon0 vdd vbsyn gsyn
Xho_189_0 ahp189 ahn189 wp_ho_189_0 wn_ho_189_0 mop0 mon0 vdd vbsyn gsyn
Xho_190_0 ahp190 ahn190 wp_ho_190_0 wn_ho_190_0 mop0 mon0 vdd vbsyn gsyn
Xho_191_0 ahp191 ahn191 wp_ho_191_0 wn_ho_191_0 mop0 mon0 vdd vbsyn gsyn
Xho_192_0 ahp192 ahn192 wp_ho_192_0 wn_ho_192_0 mop0 mon0 vdd vbsyn gsyn
Xho_193_0 ahp193 ahn193 wp_ho_193_0 wn_ho_193_0 mop0 mon0 vdd vbsyn gsyn
Xho_194_0 ahp194 ahn194 wp_ho_194_0 wn_ho_194_0 mop0 mon0 vdd vbsyn gsyn
Xho_195_0 ahp195 ahn195 wp_ho_195_0 wn_ho_195_0 mop0 mon0 vdd vbsyn gsyn
Xho_196_0 ahp196 ahn196 wp_ho_196_0 wn_ho_196_0 mop0 mon0 vdd vbsyn gsyn
Xho_197_0 ahp197 ahn197 wp_ho_197_0 wn_ho_197_0 mop0 mon0 vdd vbsyn gsyn
Xho_198_0 ahp198 ahn198 wp_ho_198_0 wn_ho_198_0 mop0 mon0 vdd vbsyn gsyn
Xho_199_0 ahp199 ahn199 wp_ho_199_0 wn_ho_199_0 mop0 mon0 vdd vbsyn gsyn
Xho_200_0 ahp200 ahn200 wp_ho_200_0 wn_ho_200_0 mop0 mon0 vdd vbsyn gsyn
Xho_201_0 ahp201 ahn201 wp_ho_201_0 wn_ho_201_0 mop0 mon0 vdd vbsyn gsyn
Xho_202_0 ahp202 ahn202 wp_ho_202_0 wn_ho_202_0 mop0 mon0 vdd vbsyn gsyn
Xho_203_0 ahp203 ahn203 wp_ho_203_0 wn_ho_203_0 mop0 mon0 vdd vbsyn gsyn
Xho_204_0 ahp204 ahn204 wp_ho_204_0 wn_ho_204_0 mop0 mon0 vdd vbsyn gsyn
Xho_205_0 ahp205 ahn205 wp_ho_205_0 wn_ho_205_0 mop0 mon0 vdd vbsyn gsyn
Xho_206_0 ahp206 ahn206 wp_ho_206_0 wn_ho_206_0 mop0 mon0 vdd vbsyn gsyn
Xho_207_0 ahp207 ahn207 wp_ho_207_0 wn_ho_207_0 mop0 mon0 vdd vbsyn gsyn
Xho_208_0 ahp208 ahn208 wp_ho_208_0 wn_ho_208_0 mop0 mon0 vdd vbsyn gsyn
Xho_209_0 ahp209 ahn209 wp_ho_209_0 wn_ho_209_0 mop0 mon0 vdd vbsyn gsyn
Xho_210_0 ahp210 ahn210 wp_ho_210_0 wn_ho_210_0 mop0 mon0 vdd vbsyn gsyn
Xho_211_0 ahp211 ahn211 wp_ho_211_0 wn_ho_211_0 mop0 mon0 vdd vbsyn gsyn
Xho_212_0 ahp212 ahn212 wp_ho_212_0 wn_ho_212_0 mop0 mon0 vdd vbsyn gsyn
Xho_213_0 ahp213 ahn213 wp_ho_213_0 wn_ho_213_0 mop0 mon0 vdd vbsyn gsyn
Xho_214_0 ahp214 ahn214 wp_ho_214_0 wn_ho_214_0 mop0 mon0 vdd vbsyn gsyn
Xho_215_0 ahp215 ahn215 wp_ho_215_0 wn_ho_215_0 mop0 mon0 vdd vbsyn gsyn
Xho_216_0 ahp216 ahn216 wp_ho_216_0 wn_ho_216_0 mop0 mon0 vdd vbsyn gsyn
Xho_217_0 ahp217 ahn217 wp_ho_217_0 wn_ho_217_0 mop0 mon0 vdd vbsyn gsyn
Xho_218_0 ahp218 ahn218 wp_ho_218_0 wn_ho_218_0 mop0 mon0 vdd vbsyn gsyn
Xho_219_0 ahp219 ahn219 wp_ho_219_0 wn_ho_219_0 mop0 mon0 vdd vbsyn gsyn
Xho_220_0 ahp220 ahn220 wp_ho_220_0 wn_ho_220_0 mop0 mon0 vdd vbsyn gsyn
Xho_221_0 ahp221 ahn221 wp_ho_221_0 wn_ho_221_0 mop0 mon0 vdd vbsyn gsyn
Xho_222_0 ahp222 ahn222 wp_ho_222_0 wn_ho_222_0 mop0 mon0 vdd vbsyn gsyn
Xho_223_0 ahp223 ahn223 wp_ho_223_0 wn_ho_223_0 mop0 mon0 vdd vbsyn gsyn
Xho_224_0 ahp224 ahn224 wp_ho_224_0 wn_ho_224_0 mop0 mon0 vdd vbsyn gsyn
Xho_225_0 ahp225 ahn225 wp_ho_225_0 wn_ho_225_0 mop0 mon0 vdd vbsyn gsyn
Xho_226_0 ahp226 ahn226 wp_ho_226_0 wn_ho_226_0 mop0 mon0 vdd vbsyn gsyn
Xho_227_0 ahp227 ahn227 wp_ho_227_0 wn_ho_227_0 mop0 mon0 vdd vbsyn gsyn
Xho_228_0 ahp228 ahn228 wp_ho_228_0 wn_ho_228_0 mop0 mon0 vdd vbsyn gsyn
Xho_229_0 ahp229 ahn229 wp_ho_229_0 wn_ho_229_0 mop0 mon0 vdd vbsyn gsyn
Xho_230_0 ahp230 ahn230 wp_ho_230_0 wn_ho_230_0 mop0 mon0 vdd vbsyn gsyn
Xho_231_0 ahp231 ahn231 wp_ho_231_0 wn_ho_231_0 mop0 mon0 vdd vbsyn gsyn
Xho_232_0 ahp232 ahn232 wp_ho_232_0 wn_ho_232_0 mop0 mon0 vdd vbsyn gsyn
Xho_233_0 ahp233 ahn233 wp_ho_233_0 wn_ho_233_0 mop0 mon0 vdd vbsyn gsyn
Xho_234_0 ahp234 ahn234 wp_ho_234_0 wn_ho_234_0 mop0 mon0 vdd vbsyn gsyn
Xho_235_0 ahp235 ahn235 wp_ho_235_0 wn_ho_235_0 mop0 mon0 vdd vbsyn gsyn
Xho_236_0 ahp236 ahn236 wp_ho_236_0 wn_ho_236_0 mop0 mon0 vdd vbsyn gsyn
Xho_237_0 ahp237 ahn237 wp_ho_237_0 wn_ho_237_0 mop0 mon0 vdd vbsyn gsyn
Xho_238_0 ahp238 ahn238 wp_ho_238_0 wn_ho_238_0 mop0 mon0 vdd vbsyn gsyn
Xho_239_0 ahp239 ahn239 wp_ho_239_0 wn_ho_239_0 mop0 mon0 vdd vbsyn gsyn
Xho_240_0 ahp240 ahn240 wp_ho_240_0 wn_ho_240_0 mop0 mon0 vdd vbsyn gsyn
Xho_241_0 ahp241 ahn241 wp_ho_241_0 wn_ho_241_0 mop0 mon0 vdd vbsyn gsyn
Xho_242_0 ahp242 ahn242 wp_ho_242_0 wn_ho_242_0 mop0 mon0 vdd vbsyn gsyn
Xho_243_0 ahp243 ahn243 wp_ho_243_0 wn_ho_243_0 mop0 mon0 vdd vbsyn gsyn
Xho_244_0 ahp244 ahn244 wp_ho_244_0 wn_ho_244_0 mop0 mon0 vdd vbsyn gsyn
Xho_245_0 ahp245 ahn245 wp_ho_245_0 wn_ho_245_0 mop0 mon0 vdd vbsyn gsyn
Xho_246_0 ahp246 ahn246 wp_ho_246_0 wn_ho_246_0 mop0 mon0 vdd vbsyn gsyn
Xho_247_0 ahp247 ahn247 wp_ho_247_0 wn_ho_247_0 mop0 mon0 vdd vbsyn gsyn
Xho_248_0 ahp248 ahn248 wp_ho_248_0 wn_ho_248_0 mop0 mon0 vdd vbsyn gsyn
Xho_249_0 ahp249 ahn249 wp_ho_249_0 wn_ho_249_0 mop0 mon0 vdd vbsyn gsyn
Xho_250_0 ahp250 ahn250 wp_ho_250_0 wn_ho_250_0 mop0 mon0 vdd vbsyn gsyn
Xho_251_0 ahp251 ahn251 wp_ho_251_0 wn_ho_251_0 mop0 mon0 vdd vbsyn gsyn
Xho_252_0 ahp252 ahn252 wp_ho_252_0 wn_ho_252_0 mop0 mon0 vdd vbsyn gsyn
Xho_253_0 ahp253 ahn253 wp_ho_253_0 wn_ho_253_0 mop0 mon0 vdd vbsyn gsyn
Xho_254_0 ahp254 ahn254 wp_ho_254_0 wn_ho_254_0 mop0 mon0 vdd vbsyn gsyn
Xho_255_0 ahp255 ahn255 wp_ho_255_0 wn_ho_255_0 mop0 mon0 vdd vbsyn gsyn
Xho_256_0 ahp256 ahn256 wp_ho_256_0 wn_ho_256_0 mop0 mon0 vdd vbsyn gsyn
Xho_257_0 ahp257 ahn257 wp_ho_257_0 wn_ho_257_0 mop0 mon0 vdd vbsyn gsyn
Xho_258_0 ahp258 ahn258 wp_ho_258_0 wn_ho_258_0 mop0 mon0 vdd vbsyn gsyn
Xho_259_0 ahp259 ahn259 wp_ho_259_0 wn_ho_259_0 mop0 mon0 vdd vbsyn gsyn
Xho_260_0 ahp260 ahn260 wp_ho_260_0 wn_ho_260_0 mop0 mon0 vdd vbsyn gsyn
Xho_261_0 ahp261 ahn261 wp_ho_261_0 wn_ho_261_0 mop0 mon0 vdd vbsyn gsyn
Xho_262_0 ahp262 ahn262 wp_ho_262_0 wn_ho_262_0 mop0 mon0 vdd vbsyn gsyn
Xho_263_0 ahp263 ahn263 wp_ho_263_0 wn_ho_263_0 mop0 mon0 vdd vbsyn gsyn
Xho_264_0 ahp264 ahn264 wp_ho_264_0 wn_ho_264_0 mop0 mon0 vdd vbsyn gsyn
Xho_265_0 ahp265 ahn265 wp_ho_265_0 wn_ho_265_0 mop0 mon0 vdd vbsyn gsyn
Xho_266_0 ahp266 ahn266 wp_ho_266_0 wn_ho_266_0 mop0 mon0 vdd vbsyn gsyn
Xho_267_0 ahp267 ahn267 wp_ho_267_0 wn_ho_267_0 mop0 mon0 vdd vbsyn gsyn
Xho_268_0 ahp268 ahn268 wp_ho_268_0 wn_ho_268_0 mop0 mon0 vdd vbsyn gsyn
Xho_269_0 ahp269 ahn269 wp_ho_269_0 wn_ho_269_0 mop0 mon0 vdd vbsyn gsyn
Xho_270_0 ahp270 ahn270 wp_ho_270_0 wn_ho_270_0 mop0 mon0 vdd vbsyn gsyn
Xho_271_0 ahp271 ahn271 wp_ho_271_0 wn_ho_271_0 mop0 mon0 vdd vbsyn gsyn
Xho_272_0 ahp272 ahn272 wp_ho_272_0 wn_ho_272_0 mop0 mon0 vdd vbsyn gsyn
Xho_273_0 ahp273 ahn273 wp_ho_273_0 wn_ho_273_0 mop0 mon0 vdd vbsyn gsyn
Xho_274_0 ahp274 ahn274 wp_ho_274_0 wn_ho_274_0 mop0 mon0 vdd vbsyn gsyn
Xho_275_0 ahp275 ahn275 wp_ho_275_0 wn_ho_275_0 mop0 mon0 vdd vbsyn gsyn
Xho_276_0 ahp276 ahn276 wp_ho_276_0 wn_ho_276_0 mop0 mon0 vdd vbsyn gsyn
Xho_277_0 ahp277 ahn277 wp_ho_277_0 wn_ho_277_0 mop0 mon0 vdd vbsyn gsyn
Xho_278_0 ahp278 ahn278 wp_ho_278_0 wn_ho_278_0 mop0 mon0 vdd vbsyn gsyn
Xho_279_0 ahp279 ahn279 wp_ho_279_0 wn_ho_279_0 mop0 mon0 vdd vbsyn gsyn
Xho_280_0 ahp280 ahn280 wp_ho_280_0 wn_ho_280_0 mop0 mon0 vdd vbsyn gsyn
Xho_281_0 ahp281 ahn281 wp_ho_281_0 wn_ho_281_0 mop0 mon0 vdd vbsyn gsyn
Xho_282_0 ahp282 ahn282 wp_ho_282_0 wn_ho_282_0 mop0 mon0 vdd vbsyn gsyn
Xho_283_0 ahp283 ahn283 wp_ho_283_0 wn_ho_283_0 mop0 mon0 vdd vbsyn gsyn
Xho_284_0 ahp284 ahn284 wp_ho_284_0 wn_ho_284_0 mop0 mon0 vdd vbsyn gsyn
Xho_285_0 ahp285 ahn285 wp_ho_285_0 wn_ho_285_0 mop0 mon0 vdd vbsyn gsyn
Xho_286_0 ahp286 ahn286 wp_ho_286_0 wn_ho_286_0 mop0 mon0 vdd vbsyn gsyn
Xho_287_0 ahp287 ahn287 wp_ho_287_0 wn_ho_287_0 mop0 mon0 vdd vbsyn gsyn
Xcm_mo1 mop1 mon1 vdd cmld
Rnd_mo1 mop1 mon1 20k
Cmo1p mop1 0 1e-13
Cmo1n mon1 0 1e-13
Xho_0_1 ahp0 ahn0 wp_ho_0_1 wn_ho_0_1 mop1 mon1 vdd vbsyn gsyn
Xho_1_1 ahp1 ahn1 wp_ho_1_1 wn_ho_1_1 mop1 mon1 vdd vbsyn gsyn
Xho_2_1 ahp2 ahn2 wp_ho_2_1 wn_ho_2_1 mop1 mon1 vdd vbsyn gsyn
Xho_3_1 ahp3 ahn3 wp_ho_3_1 wn_ho_3_1 mop1 mon1 vdd vbsyn gsyn
Xho_4_1 ahp4 ahn4 wp_ho_4_1 wn_ho_4_1 mop1 mon1 vdd vbsyn gsyn
Xho_5_1 ahp5 ahn5 wp_ho_5_1 wn_ho_5_1 mop1 mon1 vdd vbsyn gsyn
Xho_6_1 ahp6 ahn6 wp_ho_6_1 wn_ho_6_1 mop1 mon1 vdd vbsyn gsyn
Xho_7_1 ahp7 ahn7 wp_ho_7_1 wn_ho_7_1 mop1 mon1 vdd vbsyn gsyn
Xho_8_1 ahp8 ahn8 wp_ho_8_1 wn_ho_8_1 mop1 mon1 vdd vbsyn gsyn
Xho_9_1 ahp9 ahn9 wp_ho_9_1 wn_ho_9_1 mop1 mon1 vdd vbsyn gsyn
Xho_10_1 ahp10 ahn10 wp_ho_10_1 wn_ho_10_1 mop1 mon1 vdd vbsyn gsyn
Xho_11_1 ahp11 ahn11 wp_ho_11_1 wn_ho_11_1 mop1 mon1 vdd vbsyn gsyn
Xho_12_1 ahp12 ahn12 wp_ho_12_1 wn_ho_12_1 mop1 mon1 vdd vbsyn gsyn
Xho_13_1 ahp13 ahn13 wp_ho_13_1 wn_ho_13_1 mop1 mon1 vdd vbsyn gsyn
Xho_14_1 ahp14 ahn14 wp_ho_14_1 wn_ho_14_1 mop1 mon1 vdd vbsyn gsyn
Xho_15_1 ahp15 ahn15 wp_ho_15_1 wn_ho_15_1 mop1 mon1 vdd vbsyn gsyn
Xho_16_1 ahp16 ahn16 wp_ho_16_1 wn_ho_16_1 mop1 mon1 vdd vbsyn gsyn
Xho_17_1 ahp17 ahn17 wp_ho_17_1 wn_ho_17_1 mop1 mon1 vdd vbsyn gsyn
Xho_18_1 ahp18 ahn18 wp_ho_18_1 wn_ho_18_1 mop1 mon1 vdd vbsyn gsyn
Xho_19_1 ahp19 ahn19 wp_ho_19_1 wn_ho_19_1 mop1 mon1 vdd vbsyn gsyn
Xho_20_1 ahp20 ahn20 wp_ho_20_1 wn_ho_20_1 mop1 mon1 vdd vbsyn gsyn
Xho_21_1 ahp21 ahn21 wp_ho_21_1 wn_ho_21_1 mop1 mon1 vdd vbsyn gsyn
Xho_22_1 ahp22 ahn22 wp_ho_22_1 wn_ho_22_1 mop1 mon1 vdd vbsyn gsyn
Xho_23_1 ahp23 ahn23 wp_ho_23_1 wn_ho_23_1 mop1 mon1 vdd vbsyn gsyn
Xho_24_1 ahp24 ahn24 wp_ho_24_1 wn_ho_24_1 mop1 mon1 vdd vbsyn gsyn
Xho_25_1 ahp25 ahn25 wp_ho_25_1 wn_ho_25_1 mop1 mon1 vdd vbsyn gsyn
Xho_26_1 ahp26 ahn26 wp_ho_26_1 wn_ho_26_1 mop1 mon1 vdd vbsyn gsyn
Xho_27_1 ahp27 ahn27 wp_ho_27_1 wn_ho_27_1 mop1 mon1 vdd vbsyn gsyn
Xho_28_1 ahp28 ahn28 wp_ho_28_1 wn_ho_28_1 mop1 mon1 vdd vbsyn gsyn
Xho_29_1 ahp29 ahn29 wp_ho_29_1 wn_ho_29_1 mop1 mon1 vdd vbsyn gsyn
Xho_30_1 ahp30 ahn30 wp_ho_30_1 wn_ho_30_1 mop1 mon1 vdd vbsyn gsyn
Xho_31_1 ahp31 ahn31 wp_ho_31_1 wn_ho_31_1 mop1 mon1 vdd vbsyn gsyn
Xho_32_1 ahp32 ahn32 wp_ho_32_1 wn_ho_32_1 mop1 mon1 vdd vbsyn gsyn
Xho_33_1 ahp33 ahn33 wp_ho_33_1 wn_ho_33_1 mop1 mon1 vdd vbsyn gsyn
Xho_34_1 ahp34 ahn34 wp_ho_34_1 wn_ho_34_1 mop1 mon1 vdd vbsyn gsyn
Xho_35_1 ahp35 ahn35 wp_ho_35_1 wn_ho_35_1 mop1 mon1 vdd vbsyn gsyn
Xho_36_1 ahp36 ahn36 wp_ho_36_1 wn_ho_36_1 mop1 mon1 vdd vbsyn gsyn
Xho_37_1 ahp37 ahn37 wp_ho_37_1 wn_ho_37_1 mop1 mon1 vdd vbsyn gsyn
Xho_38_1 ahp38 ahn38 wp_ho_38_1 wn_ho_38_1 mop1 mon1 vdd vbsyn gsyn
Xho_39_1 ahp39 ahn39 wp_ho_39_1 wn_ho_39_1 mop1 mon1 vdd vbsyn gsyn
Xho_40_1 ahp40 ahn40 wp_ho_40_1 wn_ho_40_1 mop1 mon1 vdd vbsyn gsyn
Xho_41_1 ahp41 ahn41 wp_ho_41_1 wn_ho_41_1 mop1 mon1 vdd vbsyn gsyn
Xho_42_1 ahp42 ahn42 wp_ho_42_1 wn_ho_42_1 mop1 mon1 vdd vbsyn gsyn
Xho_43_1 ahp43 ahn43 wp_ho_43_1 wn_ho_43_1 mop1 mon1 vdd vbsyn gsyn
Xho_44_1 ahp44 ahn44 wp_ho_44_1 wn_ho_44_1 mop1 mon1 vdd vbsyn gsyn
Xho_45_1 ahp45 ahn45 wp_ho_45_1 wn_ho_45_1 mop1 mon1 vdd vbsyn gsyn
Xho_46_1 ahp46 ahn46 wp_ho_46_1 wn_ho_46_1 mop1 mon1 vdd vbsyn gsyn
Xho_47_1 ahp47 ahn47 wp_ho_47_1 wn_ho_47_1 mop1 mon1 vdd vbsyn gsyn
Xho_48_1 ahp48 ahn48 wp_ho_48_1 wn_ho_48_1 mop1 mon1 vdd vbsyn gsyn
Xho_49_1 ahp49 ahn49 wp_ho_49_1 wn_ho_49_1 mop1 mon1 vdd vbsyn gsyn
Xho_50_1 ahp50 ahn50 wp_ho_50_1 wn_ho_50_1 mop1 mon1 vdd vbsyn gsyn
Xho_51_1 ahp51 ahn51 wp_ho_51_1 wn_ho_51_1 mop1 mon1 vdd vbsyn gsyn
Xho_52_1 ahp52 ahn52 wp_ho_52_1 wn_ho_52_1 mop1 mon1 vdd vbsyn gsyn
Xho_53_1 ahp53 ahn53 wp_ho_53_1 wn_ho_53_1 mop1 mon1 vdd vbsyn gsyn
Xho_54_1 ahp54 ahn54 wp_ho_54_1 wn_ho_54_1 mop1 mon1 vdd vbsyn gsyn
Xho_55_1 ahp55 ahn55 wp_ho_55_1 wn_ho_55_1 mop1 mon1 vdd vbsyn gsyn
Xho_56_1 ahp56 ahn56 wp_ho_56_1 wn_ho_56_1 mop1 mon1 vdd vbsyn gsyn
Xho_57_1 ahp57 ahn57 wp_ho_57_1 wn_ho_57_1 mop1 mon1 vdd vbsyn gsyn
Xho_58_1 ahp58 ahn58 wp_ho_58_1 wn_ho_58_1 mop1 mon1 vdd vbsyn gsyn
Xho_59_1 ahp59 ahn59 wp_ho_59_1 wn_ho_59_1 mop1 mon1 vdd vbsyn gsyn
Xho_60_1 ahp60 ahn60 wp_ho_60_1 wn_ho_60_1 mop1 mon1 vdd vbsyn gsyn
Xho_61_1 ahp61 ahn61 wp_ho_61_1 wn_ho_61_1 mop1 mon1 vdd vbsyn gsyn
Xho_62_1 ahp62 ahn62 wp_ho_62_1 wn_ho_62_1 mop1 mon1 vdd vbsyn gsyn
Xho_63_1 ahp63 ahn63 wp_ho_63_1 wn_ho_63_1 mop1 mon1 vdd vbsyn gsyn
Xho_64_1 ahp64 ahn64 wp_ho_64_1 wn_ho_64_1 mop1 mon1 vdd vbsyn gsyn
Xho_65_1 ahp65 ahn65 wp_ho_65_1 wn_ho_65_1 mop1 mon1 vdd vbsyn gsyn
Xho_66_1 ahp66 ahn66 wp_ho_66_1 wn_ho_66_1 mop1 mon1 vdd vbsyn gsyn
Xho_67_1 ahp67 ahn67 wp_ho_67_1 wn_ho_67_1 mop1 mon1 vdd vbsyn gsyn
Xho_68_1 ahp68 ahn68 wp_ho_68_1 wn_ho_68_1 mop1 mon1 vdd vbsyn gsyn
Xho_69_1 ahp69 ahn69 wp_ho_69_1 wn_ho_69_1 mop1 mon1 vdd vbsyn gsyn
Xho_70_1 ahp70 ahn70 wp_ho_70_1 wn_ho_70_1 mop1 mon1 vdd vbsyn gsyn
Xho_71_1 ahp71 ahn71 wp_ho_71_1 wn_ho_71_1 mop1 mon1 vdd vbsyn gsyn
Xho_72_1 ahp72 ahn72 wp_ho_72_1 wn_ho_72_1 mop1 mon1 vdd vbsyn gsyn
Xho_73_1 ahp73 ahn73 wp_ho_73_1 wn_ho_73_1 mop1 mon1 vdd vbsyn gsyn
Xho_74_1 ahp74 ahn74 wp_ho_74_1 wn_ho_74_1 mop1 mon1 vdd vbsyn gsyn
Xho_75_1 ahp75 ahn75 wp_ho_75_1 wn_ho_75_1 mop1 mon1 vdd vbsyn gsyn
Xho_76_1 ahp76 ahn76 wp_ho_76_1 wn_ho_76_1 mop1 mon1 vdd vbsyn gsyn
Xho_77_1 ahp77 ahn77 wp_ho_77_1 wn_ho_77_1 mop1 mon1 vdd vbsyn gsyn
Xho_78_1 ahp78 ahn78 wp_ho_78_1 wn_ho_78_1 mop1 mon1 vdd vbsyn gsyn
Xho_79_1 ahp79 ahn79 wp_ho_79_1 wn_ho_79_1 mop1 mon1 vdd vbsyn gsyn
Xho_80_1 ahp80 ahn80 wp_ho_80_1 wn_ho_80_1 mop1 mon1 vdd vbsyn gsyn
Xho_81_1 ahp81 ahn81 wp_ho_81_1 wn_ho_81_1 mop1 mon1 vdd vbsyn gsyn
Xho_82_1 ahp82 ahn82 wp_ho_82_1 wn_ho_82_1 mop1 mon1 vdd vbsyn gsyn
Xho_83_1 ahp83 ahn83 wp_ho_83_1 wn_ho_83_1 mop1 mon1 vdd vbsyn gsyn
Xho_84_1 ahp84 ahn84 wp_ho_84_1 wn_ho_84_1 mop1 mon1 vdd vbsyn gsyn
Xho_85_1 ahp85 ahn85 wp_ho_85_1 wn_ho_85_1 mop1 mon1 vdd vbsyn gsyn
Xho_86_1 ahp86 ahn86 wp_ho_86_1 wn_ho_86_1 mop1 mon1 vdd vbsyn gsyn
Xho_87_1 ahp87 ahn87 wp_ho_87_1 wn_ho_87_1 mop1 mon1 vdd vbsyn gsyn
Xho_88_1 ahp88 ahn88 wp_ho_88_1 wn_ho_88_1 mop1 mon1 vdd vbsyn gsyn
Xho_89_1 ahp89 ahn89 wp_ho_89_1 wn_ho_89_1 mop1 mon1 vdd vbsyn gsyn
Xho_90_1 ahp90 ahn90 wp_ho_90_1 wn_ho_90_1 mop1 mon1 vdd vbsyn gsyn
Xho_91_1 ahp91 ahn91 wp_ho_91_1 wn_ho_91_1 mop1 mon1 vdd vbsyn gsyn
Xho_92_1 ahp92 ahn92 wp_ho_92_1 wn_ho_92_1 mop1 mon1 vdd vbsyn gsyn
Xho_93_1 ahp93 ahn93 wp_ho_93_1 wn_ho_93_1 mop1 mon1 vdd vbsyn gsyn
Xho_94_1 ahp94 ahn94 wp_ho_94_1 wn_ho_94_1 mop1 mon1 vdd vbsyn gsyn
Xho_95_1 ahp95 ahn95 wp_ho_95_1 wn_ho_95_1 mop1 mon1 vdd vbsyn gsyn
Xho_96_1 ahp96 ahn96 wp_ho_96_1 wn_ho_96_1 mop1 mon1 vdd vbsyn gsyn
Xho_97_1 ahp97 ahn97 wp_ho_97_1 wn_ho_97_1 mop1 mon1 vdd vbsyn gsyn
Xho_98_1 ahp98 ahn98 wp_ho_98_1 wn_ho_98_1 mop1 mon1 vdd vbsyn gsyn
Xho_99_1 ahp99 ahn99 wp_ho_99_1 wn_ho_99_1 mop1 mon1 vdd vbsyn gsyn
Xho_100_1 ahp100 ahn100 wp_ho_100_1 wn_ho_100_1 mop1 mon1 vdd vbsyn gsyn
Xho_101_1 ahp101 ahn101 wp_ho_101_1 wn_ho_101_1 mop1 mon1 vdd vbsyn gsyn
Xho_102_1 ahp102 ahn102 wp_ho_102_1 wn_ho_102_1 mop1 mon1 vdd vbsyn gsyn
Xho_103_1 ahp103 ahn103 wp_ho_103_1 wn_ho_103_1 mop1 mon1 vdd vbsyn gsyn
Xho_104_1 ahp104 ahn104 wp_ho_104_1 wn_ho_104_1 mop1 mon1 vdd vbsyn gsyn
Xho_105_1 ahp105 ahn105 wp_ho_105_1 wn_ho_105_1 mop1 mon1 vdd vbsyn gsyn
Xho_106_1 ahp106 ahn106 wp_ho_106_1 wn_ho_106_1 mop1 mon1 vdd vbsyn gsyn
Xho_107_1 ahp107 ahn107 wp_ho_107_1 wn_ho_107_1 mop1 mon1 vdd vbsyn gsyn
Xho_108_1 ahp108 ahn108 wp_ho_108_1 wn_ho_108_1 mop1 mon1 vdd vbsyn gsyn
Xho_109_1 ahp109 ahn109 wp_ho_109_1 wn_ho_109_1 mop1 mon1 vdd vbsyn gsyn
Xho_110_1 ahp110 ahn110 wp_ho_110_1 wn_ho_110_1 mop1 mon1 vdd vbsyn gsyn
Xho_111_1 ahp111 ahn111 wp_ho_111_1 wn_ho_111_1 mop1 mon1 vdd vbsyn gsyn
Xho_112_1 ahp112 ahn112 wp_ho_112_1 wn_ho_112_1 mop1 mon1 vdd vbsyn gsyn
Xho_113_1 ahp113 ahn113 wp_ho_113_1 wn_ho_113_1 mop1 mon1 vdd vbsyn gsyn
Xho_114_1 ahp114 ahn114 wp_ho_114_1 wn_ho_114_1 mop1 mon1 vdd vbsyn gsyn
Xho_115_1 ahp115 ahn115 wp_ho_115_1 wn_ho_115_1 mop1 mon1 vdd vbsyn gsyn
Xho_116_1 ahp116 ahn116 wp_ho_116_1 wn_ho_116_1 mop1 mon1 vdd vbsyn gsyn
Xho_117_1 ahp117 ahn117 wp_ho_117_1 wn_ho_117_1 mop1 mon1 vdd vbsyn gsyn
Xho_118_1 ahp118 ahn118 wp_ho_118_1 wn_ho_118_1 mop1 mon1 vdd vbsyn gsyn
Xho_119_1 ahp119 ahn119 wp_ho_119_1 wn_ho_119_1 mop1 mon1 vdd vbsyn gsyn
Xho_120_1 ahp120 ahn120 wp_ho_120_1 wn_ho_120_1 mop1 mon1 vdd vbsyn gsyn
Xho_121_1 ahp121 ahn121 wp_ho_121_1 wn_ho_121_1 mop1 mon1 vdd vbsyn gsyn
Xho_122_1 ahp122 ahn122 wp_ho_122_1 wn_ho_122_1 mop1 mon1 vdd vbsyn gsyn
Xho_123_1 ahp123 ahn123 wp_ho_123_1 wn_ho_123_1 mop1 mon1 vdd vbsyn gsyn
Xho_124_1 ahp124 ahn124 wp_ho_124_1 wn_ho_124_1 mop1 mon1 vdd vbsyn gsyn
Xho_125_1 ahp125 ahn125 wp_ho_125_1 wn_ho_125_1 mop1 mon1 vdd vbsyn gsyn
Xho_126_1 ahp126 ahn126 wp_ho_126_1 wn_ho_126_1 mop1 mon1 vdd vbsyn gsyn
Xho_127_1 ahp127 ahn127 wp_ho_127_1 wn_ho_127_1 mop1 mon1 vdd vbsyn gsyn
Xho_128_1 ahp128 ahn128 wp_ho_128_1 wn_ho_128_1 mop1 mon1 vdd vbsyn gsyn
Xho_129_1 ahp129 ahn129 wp_ho_129_1 wn_ho_129_1 mop1 mon1 vdd vbsyn gsyn
Xho_130_1 ahp130 ahn130 wp_ho_130_1 wn_ho_130_1 mop1 mon1 vdd vbsyn gsyn
Xho_131_1 ahp131 ahn131 wp_ho_131_1 wn_ho_131_1 mop1 mon1 vdd vbsyn gsyn
Xho_132_1 ahp132 ahn132 wp_ho_132_1 wn_ho_132_1 mop1 mon1 vdd vbsyn gsyn
Xho_133_1 ahp133 ahn133 wp_ho_133_1 wn_ho_133_1 mop1 mon1 vdd vbsyn gsyn
Xho_134_1 ahp134 ahn134 wp_ho_134_1 wn_ho_134_1 mop1 mon1 vdd vbsyn gsyn
Xho_135_1 ahp135 ahn135 wp_ho_135_1 wn_ho_135_1 mop1 mon1 vdd vbsyn gsyn
Xho_136_1 ahp136 ahn136 wp_ho_136_1 wn_ho_136_1 mop1 mon1 vdd vbsyn gsyn
Xho_137_1 ahp137 ahn137 wp_ho_137_1 wn_ho_137_1 mop1 mon1 vdd vbsyn gsyn
Xho_138_1 ahp138 ahn138 wp_ho_138_1 wn_ho_138_1 mop1 mon1 vdd vbsyn gsyn
Xho_139_1 ahp139 ahn139 wp_ho_139_1 wn_ho_139_1 mop1 mon1 vdd vbsyn gsyn
Xho_140_1 ahp140 ahn140 wp_ho_140_1 wn_ho_140_1 mop1 mon1 vdd vbsyn gsyn
Xho_141_1 ahp141 ahn141 wp_ho_141_1 wn_ho_141_1 mop1 mon1 vdd vbsyn gsyn
Xho_142_1 ahp142 ahn142 wp_ho_142_1 wn_ho_142_1 mop1 mon1 vdd vbsyn gsyn
Xho_143_1 ahp143 ahn143 wp_ho_143_1 wn_ho_143_1 mop1 mon1 vdd vbsyn gsyn
Xho_144_1 ahp144 ahn144 wp_ho_144_1 wn_ho_144_1 mop1 mon1 vdd vbsyn gsyn
Xho_145_1 ahp145 ahn145 wp_ho_145_1 wn_ho_145_1 mop1 mon1 vdd vbsyn gsyn
Xho_146_1 ahp146 ahn146 wp_ho_146_1 wn_ho_146_1 mop1 mon1 vdd vbsyn gsyn
Xho_147_1 ahp147 ahn147 wp_ho_147_1 wn_ho_147_1 mop1 mon1 vdd vbsyn gsyn
Xho_148_1 ahp148 ahn148 wp_ho_148_1 wn_ho_148_1 mop1 mon1 vdd vbsyn gsyn
Xho_149_1 ahp149 ahn149 wp_ho_149_1 wn_ho_149_1 mop1 mon1 vdd vbsyn gsyn
Xho_150_1 ahp150 ahn150 wp_ho_150_1 wn_ho_150_1 mop1 mon1 vdd vbsyn gsyn
Xho_151_1 ahp151 ahn151 wp_ho_151_1 wn_ho_151_1 mop1 mon1 vdd vbsyn gsyn
Xho_152_1 ahp152 ahn152 wp_ho_152_1 wn_ho_152_1 mop1 mon1 vdd vbsyn gsyn
Xho_153_1 ahp153 ahn153 wp_ho_153_1 wn_ho_153_1 mop1 mon1 vdd vbsyn gsyn
Xho_154_1 ahp154 ahn154 wp_ho_154_1 wn_ho_154_1 mop1 mon1 vdd vbsyn gsyn
Xho_155_1 ahp155 ahn155 wp_ho_155_1 wn_ho_155_1 mop1 mon1 vdd vbsyn gsyn
Xho_156_1 ahp156 ahn156 wp_ho_156_1 wn_ho_156_1 mop1 mon1 vdd vbsyn gsyn
Xho_157_1 ahp157 ahn157 wp_ho_157_1 wn_ho_157_1 mop1 mon1 vdd vbsyn gsyn
Xho_158_1 ahp158 ahn158 wp_ho_158_1 wn_ho_158_1 mop1 mon1 vdd vbsyn gsyn
Xho_159_1 ahp159 ahn159 wp_ho_159_1 wn_ho_159_1 mop1 mon1 vdd vbsyn gsyn
Xho_160_1 ahp160 ahn160 wp_ho_160_1 wn_ho_160_1 mop1 mon1 vdd vbsyn gsyn
Xho_161_1 ahp161 ahn161 wp_ho_161_1 wn_ho_161_1 mop1 mon1 vdd vbsyn gsyn
Xho_162_1 ahp162 ahn162 wp_ho_162_1 wn_ho_162_1 mop1 mon1 vdd vbsyn gsyn
Xho_163_1 ahp163 ahn163 wp_ho_163_1 wn_ho_163_1 mop1 mon1 vdd vbsyn gsyn
Xho_164_1 ahp164 ahn164 wp_ho_164_1 wn_ho_164_1 mop1 mon1 vdd vbsyn gsyn
Xho_165_1 ahp165 ahn165 wp_ho_165_1 wn_ho_165_1 mop1 mon1 vdd vbsyn gsyn
Xho_166_1 ahp166 ahn166 wp_ho_166_1 wn_ho_166_1 mop1 mon1 vdd vbsyn gsyn
Xho_167_1 ahp167 ahn167 wp_ho_167_1 wn_ho_167_1 mop1 mon1 vdd vbsyn gsyn
Xho_168_1 ahp168 ahn168 wp_ho_168_1 wn_ho_168_1 mop1 mon1 vdd vbsyn gsyn
Xho_169_1 ahp169 ahn169 wp_ho_169_1 wn_ho_169_1 mop1 mon1 vdd vbsyn gsyn
Xho_170_1 ahp170 ahn170 wp_ho_170_1 wn_ho_170_1 mop1 mon1 vdd vbsyn gsyn
Xho_171_1 ahp171 ahn171 wp_ho_171_1 wn_ho_171_1 mop1 mon1 vdd vbsyn gsyn
Xho_172_1 ahp172 ahn172 wp_ho_172_1 wn_ho_172_1 mop1 mon1 vdd vbsyn gsyn
Xho_173_1 ahp173 ahn173 wp_ho_173_1 wn_ho_173_1 mop1 mon1 vdd vbsyn gsyn
Xho_174_1 ahp174 ahn174 wp_ho_174_1 wn_ho_174_1 mop1 mon1 vdd vbsyn gsyn
Xho_175_1 ahp175 ahn175 wp_ho_175_1 wn_ho_175_1 mop1 mon1 vdd vbsyn gsyn
Xho_176_1 ahp176 ahn176 wp_ho_176_1 wn_ho_176_1 mop1 mon1 vdd vbsyn gsyn
Xho_177_1 ahp177 ahn177 wp_ho_177_1 wn_ho_177_1 mop1 mon1 vdd vbsyn gsyn
Xho_178_1 ahp178 ahn178 wp_ho_178_1 wn_ho_178_1 mop1 mon1 vdd vbsyn gsyn
Xho_179_1 ahp179 ahn179 wp_ho_179_1 wn_ho_179_1 mop1 mon1 vdd vbsyn gsyn
Xho_180_1 ahp180 ahn180 wp_ho_180_1 wn_ho_180_1 mop1 mon1 vdd vbsyn gsyn
Xho_181_1 ahp181 ahn181 wp_ho_181_1 wn_ho_181_1 mop1 mon1 vdd vbsyn gsyn
Xho_182_1 ahp182 ahn182 wp_ho_182_1 wn_ho_182_1 mop1 mon1 vdd vbsyn gsyn
Xho_183_1 ahp183 ahn183 wp_ho_183_1 wn_ho_183_1 mop1 mon1 vdd vbsyn gsyn
Xho_184_1 ahp184 ahn184 wp_ho_184_1 wn_ho_184_1 mop1 mon1 vdd vbsyn gsyn
Xho_185_1 ahp185 ahn185 wp_ho_185_1 wn_ho_185_1 mop1 mon1 vdd vbsyn gsyn
Xho_186_1 ahp186 ahn186 wp_ho_186_1 wn_ho_186_1 mop1 mon1 vdd vbsyn gsyn
Xho_187_1 ahp187 ahn187 wp_ho_187_1 wn_ho_187_1 mop1 mon1 vdd vbsyn gsyn
Xho_188_1 ahp188 ahn188 wp_ho_188_1 wn_ho_188_1 mop1 mon1 vdd vbsyn gsyn
Xho_189_1 ahp189 ahn189 wp_ho_189_1 wn_ho_189_1 mop1 mon1 vdd vbsyn gsyn
Xho_190_1 ahp190 ahn190 wp_ho_190_1 wn_ho_190_1 mop1 mon1 vdd vbsyn gsyn
Xho_191_1 ahp191 ahn191 wp_ho_191_1 wn_ho_191_1 mop1 mon1 vdd vbsyn gsyn
Xho_192_1 ahp192 ahn192 wp_ho_192_1 wn_ho_192_1 mop1 mon1 vdd vbsyn gsyn
Xho_193_1 ahp193 ahn193 wp_ho_193_1 wn_ho_193_1 mop1 mon1 vdd vbsyn gsyn
Xho_194_1 ahp194 ahn194 wp_ho_194_1 wn_ho_194_1 mop1 mon1 vdd vbsyn gsyn
Xho_195_1 ahp195 ahn195 wp_ho_195_1 wn_ho_195_1 mop1 mon1 vdd vbsyn gsyn
Xho_196_1 ahp196 ahn196 wp_ho_196_1 wn_ho_196_1 mop1 mon1 vdd vbsyn gsyn
Xho_197_1 ahp197 ahn197 wp_ho_197_1 wn_ho_197_1 mop1 mon1 vdd vbsyn gsyn
Xho_198_1 ahp198 ahn198 wp_ho_198_1 wn_ho_198_1 mop1 mon1 vdd vbsyn gsyn
Xho_199_1 ahp199 ahn199 wp_ho_199_1 wn_ho_199_1 mop1 mon1 vdd vbsyn gsyn
Xho_200_1 ahp200 ahn200 wp_ho_200_1 wn_ho_200_1 mop1 mon1 vdd vbsyn gsyn
Xho_201_1 ahp201 ahn201 wp_ho_201_1 wn_ho_201_1 mop1 mon1 vdd vbsyn gsyn
Xho_202_1 ahp202 ahn202 wp_ho_202_1 wn_ho_202_1 mop1 mon1 vdd vbsyn gsyn
Xho_203_1 ahp203 ahn203 wp_ho_203_1 wn_ho_203_1 mop1 mon1 vdd vbsyn gsyn
Xho_204_1 ahp204 ahn204 wp_ho_204_1 wn_ho_204_1 mop1 mon1 vdd vbsyn gsyn
Xho_205_1 ahp205 ahn205 wp_ho_205_1 wn_ho_205_1 mop1 mon1 vdd vbsyn gsyn
Xho_206_1 ahp206 ahn206 wp_ho_206_1 wn_ho_206_1 mop1 mon1 vdd vbsyn gsyn
Xho_207_1 ahp207 ahn207 wp_ho_207_1 wn_ho_207_1 mop1 mon1 vdd vbsyn gsyn
Xho_208_1 ahp208 ahn208 wp_ho_208_1 wn_ho_208_1 mop1 mon1 vdd vbsyn gsyn
Xho_209_1 ahp209 ahn209 wp_ho_209_1 wn_ho_209_1 mop1 mon1 vdd vbsyn gsyn
Xho_210_1 ahp210 ahn210 wp_ho_210_1 wn_ho_210_1 mop1 mon1 vdd vbsyn gsyn
Xho_211_1 ahp211 ahn211 wp_ho_211_1 wn_ho_211_1 mop1 mon1 vdd vbsyn gsyn
Xho_212_1 ahp212 ahn212 wp_ho_212_1 wn_ho_212_1 mop1 mon1 vdd vbsyn gsyn
Xho_213_1 ahp213 ahn213 wp_ho_213_1 wn_ho_213_1 mop1 mon1 vdd vbsyn gsyn
Xho_214_1 ahp214 ahn214 wp_ho_214_1 wn_ho_214_1 mop1 mon1 vdd vbsyn gsyn
Xho_215_1 ahp215 ahn215 wp_ho_215_1 wn_ho_215_1 mop1 mon1 vdd vbsyn gsyn
Xho_216_1 ahp216 ahn216 wp_ho_216_1 wn_ho_216_1 mop1 mon1 vdd vbsyn gsyn
Xho_217_1 ahp217 ahn217 wp_ho_217_1 wn_ho_217_1 mop1 mon1 vdd vbsyn gsyn
Xho_218_1 ahp218 ahn218 wp_ho_218_1 wn_ho_218_1 mop1 mon1 vdd vbsyn gsyn
Xho_219_1 ahp219 ahn219 wp_ho_219_1 wn_ho_219_1 mop1 mon1 vdd vbsyn gsyn
Xho_220_1 ahp220 ahn220 wp_ho_220_1 wn_ho_220_1 mop1 mon1 vdd vbsyn gsyn
Xho_221_1 ahp221 ahn221 wp_ho_221_1 wn_ho_221_1 mop1 mon1 vdd vbsyn gsyn
Xho_222_1 ahp222 ahn222 wp_ho_222_1 wn_ho_222_1 mop1 mon1 vdd vbsyn gsyn
Xho_223_1 ahp223 ahn223 wp_ho_223_1 wn_ho_223_1 mop1 mon1 vdd vbsyn gsyn
Xho_224_1 ahp224 ahn224 wp_ho_224_1 wn_ho_224_1 mop1 mon1 vdd vbsyn gsyn
Xho_225_1 ahp225 ahn225 wp_ho_225_1 wn_ho_225_1 mop1 mon1 vdd vbsyn gsyn
Xho_226_1 ahp226 ahn226 wp_ho_226_1 wn_ho_226_1 mop1 mon1 vdd vbsyn gsyn
Xho_227_1 ahp227 ahn227 wp_ho_227_1 wn_ho_227_1 mop1 mon1 vdd vbsyn gsyn
Xho_228_1 ahp228 ahn228 wp_ho_228_1 wn_ho_228_1 mop1 mon1 vdd vbsyn gsyn
Xho_229_1 ahp229 ahn229 wp_ho_229_1 wn_ho_229_1 mop1 mon1 vdd vbsyn gsyn
Xho_230_1 ahp230 ahn230 wp_ho_230_1 wn_ho_230_1 mop1 mon1 vdd vbsyn gsyn
Xho_231_1 ahp231 ahn231 wp_ho_231_1 wn_ho_231_1 mop1 mon1 vdd vbsyn gsyn
Xho_232_1 ahp232 ahn232 wp_ho_232_1 wn_ho_232_1 mop1 mon1 vdd vbsyn gsyn
Xho_233_1 ahp233 ahn233 wp_ho_233_1 wn_ho_233_1 mop1 mon1 vdd vbsyn gsyn
Xho_234_1 ahp234 ahn234 wp_ho_234_1 wn_ho_234_1 mop1 mon1 vdd vbsyn gsyn
Xho_235_1 ahp235 ahn235 wp_ho_235_1 wn_ho_235_1 mop1 mon1 vdd vbsyn gsyn
Xho_236_1 ahp236 ahn236 wp_ho_236_1 wn_ho_236_1 mop1 mon1 vdd vbsyn gsyn
Xho_237_1 ahp237 ahn237 wp_ho_237_1 wn_ho_237_1 mop1 mon1 vdd vbsyn gsyn
Xho_238_1 ahp238 ahn238 wp_ho_238_1 wn_ho_238_1 mop1 mon1 vdd vbsyn gsyn
Xho_239_1 ahp239 ahn239 wp_ho_239_1 wn_ho_239_1 mop1 mon1 vdd vbsyn gsyn
Xho_240_1 ahp240 ahn240 wp_ho_240_1 wn_ho_240_1 mop1 mon1 vdd vbsyn gsyn
Xho_241_1 ahp241 ahn241 wp_ho_241_1 wn_ho_241_1 mop1 mon1 vdd vbsyn gsyn
Xho_242_1 ahp242 ahn242 wp_ho_242_1 wn_ho_242_1 mop1 mon1 vdd vbsyn gsyn
Xho_243_1 ahp243 ahn243 wp_ho_243_1 wn_ho_243_1 mop1 mon1 vdd vbsyn gsyn
Xho_244_1 ahp244 ahn244 wp_ho_244_1 wn_ho_244_1 mop1 mon1 vdd vbsyn gsyn
Xho_245_1 ahp245 ahn245 wp_ho_245_1 wn_ho_245_1 mop1 mon1 vdd vbsyn gsyn
Xho_246_1 ahp246 ahn246 wp_ho_246_1 wn_ho_246_1 mop1 mon1 vdd vbsyn gsyn
Xho_247_1 ahp247 ahn247 wp_ho_247_1 wn_ho_247_1 mop1 mon1 vdd vbsyn gsyn
Xho_248_1 ahp248 ahn248 wp_ho_248_1 wn_ho_248_1 mop1 mon1 vdd vbsyn gsyn
Xho_249_1 ahp249 ahn249 wp_ho_249_1 wn_ho_249_1 mop1 mon1 vdd vbsyn gsyn
Xho_250_1 ahp250 ahn250 wp_ho_250_1 wn_ho_250_1 mop1 mon1 vdd vbsyn gsyn
Xho_251_1 ahp251 ahn251 wp_ho_251_1 wn_ho_251_1 mop1 mon1 vdd vbsyn gsyn
Xho_252_1 ahp252 ahn252 wp_ho_252_1 wn_ho_252_1 mop1 mon1 vdd vbsyn gsyn
Xho_253_1 ahp253 ahn253 wp_ho_253_1 wn_ho_253_1 mop1 mon1 vdd vbsyn gsyn
Xho_254_1 ahp254 ahn254 wp_ho_254_1 wn_ho_254_1 mop1 mon1 vdd vbsyn gsyn
Xho_255_1 ahp255 ahn255 wp_ho_255_1 wn_ho_255_1 mop1 mon1 vdd vbsyn gsyn
Xho_256_1 ahp256 ahn256 wp_ho_256_1 wn_ho_256_1 mop1 mon1 vdd vbsyn gsyn
Xho_257_1 ahp257 ahn257 wp_ho_257_1 wn_ho_257_1 mop1 mon1 vdd vbsyn gsyn
Xho_258_1 ahp258 ahn258 wp_ho_258_1 wn_ho_258_1 mop1 mon1 vdd vbsyn gsyn
Xho_259_1 ahp259 ahn259 wp_ho_259_1 wn_ho_259_1 mop1 mon1 vdd vbsyn gsyn
Xho_260_1 ahp260 ahn260 wp_ho_260_1 wn_ho_260_1 mop1 mon1 vdd vbsyn gsyn
Xho_261_1 ahp261 ahn261 wp_ho_261_1 wn_ho_261_1 mop1 mon1 vdd vbsyn gsyn
Xho_262_1 ahp262 ahn262 wp_ho_262_1 wn_ho_262_1 mop1 mon1 vdd vbsyn gsyn
Xho_263_1 ahp263 ahn263 wp_ho_263_1 wn_ho_263_1 mop1 mon1 vdd vbsyn gsyn
Xho_264_1 ahp264 ahn264 wp_ho_264_1 wn_ho_264_1 mop1 mon1 vdd vbsyn gsyn
Xho_265_1 ahp265 ahn265 wp_ho_265_1 wn_ho_265_1 mop1 mon1 vdd vbsyn gsyn
Xho_266_1 ahp266 ahn266 wp_ho_266_1 wn_ho_266_1 mop1 mon1 vdd vbsyn gsyn
Xho_267_1 ahp267 ahn267 wp_ho_267_1 wn_ho_267_1 mop1 mon1 vdd vbsyn gsyn
Xho_268_1 ahp268 ahn268 wp_ho_268_1 wn_ho_268_1 mop1 mon1 vdd vbsyn gsyn
Xho_269_1 ahp269 ahn269 wp_ho_269_1 wn_ho_269_1 mop1 mon1 vdd vbsyn gsyn
Xho_270_1 ahp270 ahn270 wp_ho_270_1 wn_ho_270_1 mop1 mon1 vdd vbsyn gsyn
Xho_271_1 ahp271 ahn271 wp_ho_271_1 wn_ho_271_1 mop1 mon1 vdd vbsyn gsyn
Xho_272_1 ahp272 ahn272 wp_ho_272_1 wn_ho_272_1 mop1 mon1 vdd vbsyn gsyn
Xho_273_1 ahp273 ahn273 wp_ho_273_1 wn_ho_273_1 mop1 mon1 vdd vbsyn gsyn
Xho_274_1 ahp274 ahn274 wp_ho_274_1 wn_ho_274_1 mop1 mon1 vdd vbsyn gsyn
Xho_275_1 ahp275 ahn275 wp_ho_275_1 wn_ho_275_1 mop1 mon1 vdd vbsyn gsyn
Xho_276_1 ahp276 ahn276 wp_ho_276_1 wn_ho_276_1 mop1 mon1 vdd vbsyn gsyn
Xho_277_1 ahp277 ahn277 wp_ho_277_1 wn_ho_277_1 mop1 mon1 vdd vbsyn gsyn
Xho_278_1 ahp278 ahn278 wp_ho_278_1 wn_ho_278_1 mop1 mon1 vdd vbsyn gsyn
Xho_279_1 ahp279 ahn279 wp_ho_279_1 wn_ho_279_1 mop1 mon1 vdd vbsyn gsyn
Xho_280_1 ahp280 ahn280 wp_ho_280_1 wn_ho_280_1 mop1 mon1 vdd vbsyn gsyn
Xho_281_1 ahp281 ahn281 wp_ho_281_1 wn_ho_281_1 mop1 mon1 vdd vbsyn gsyn
Xho_282_1 ahp282 ahn282 wp_ho_282_1 wn_ho_282_1 mop1 mon1 vdd vbsyn gsyn
Xho_283_1 ahp283 ahn283 wp_ho_283_1 wn_ho_283_1 mop1 mon1 vdd vbsyn gsyn
Xho_284_1 ahp284 ahn284 wp_ho_284_1 wn_ho_284_1 mop1 mon1 vdd vbsyn gsyn
Xho_285_1 ahp285 ahn285 wp_ho_285_1 wn_ho_285_1 mop1 mon1 vdd vbsyn gsyn
Xho_286_1 ahp286 ahn286 wp_ho_286_1 wn_ho_286_1 mop1 mon1 vdd vbsyn gsyn
Xho_287_1 ahp287 ahn287 wp_ho_287_1 wn_ho_287_1 mop1 mon1 vdd vbsyn gsyn
Xcm_mo2 mop2 mon2 vdd cmld
Rnd_mo2 mop2 mon2 20k
Cmo2p mop2 0 1e-13
Cmo2n mon2 0 1e-13
Xho_0_2 ahp0 ahn0 wp_ho_0_2 wn_ho_0_2 mop2 mon2 vdd vbsyn gsyn
Xho_1_2 ahp1 ahn1 wp_ho_1_2 wn_ho_1_2 mop2 mon2 vdd vbsyn gsyn
Xho_2_2 ahp2 ahn2 wp_ho_2_2 wn_ho_2_2 mop2 mon2 vdd vbsyn gsyn
Xho_3_2 ahp3 ahn3 wp_ho_3_2 wn_ho_3_2 mop2 mon2 vdd vbsyn gsyn
Xho_4_2 ahp4 ahn4 wp_ho_4_2 wn_ho_4_2 mop2 mon2 vdd vbsyn gsyn
Xho_5_2 ahp5 ahn5 wp_ho_5_2 wn_ho_5_2 mop2 mon2 vdd vbsyn gsyn
Xho_6_2 ahp6 ahn6 wp_ho_6_2 wn_ho_6_2 mop2 mon2 vdd vbsyn gsyn
Xho_7_2 ahp7 ahn7 wp_ho_7_2 wn_ho_7_2 mop2 mon2 vdd vbsyn gsyn
Xho_8_2 ahp8 ahn8 wp_ho_8_2 wn_ho_8_2 mop2 mon2 vdd vbsyn gsyn
Xho_9_2 ahp9 ahn9 wp_ho_9_2 wn_ho_9_2 mop2 mon2 vdd vbsyn gsyn
Xho_10_2 ahp10 ahn10 wp_ho_10_2 wn_ho_10_2 mop2 mon2 vdd vbsyn gsyn
Xho_11_2 ahp11 ahn11 wp_ho_11_2 wn_ho_11_2 mop2 mon2 vdd vbsyn gsyn
Xho_12_2 ahp12 ahn12 wp_ho_12_2 wn_ho_12_2 mop2 mon2 vdd vbsyn gsyn
Xho_13_2 ahp13 ahn13 wp_ho_13_2 wn_ho_13_2 mop2 mon2 vdd vbsyn gsyn
Xho_14_2 ahp14 ahn14 wp_ho_14_2 wn_ho_14_2 mop2 mon2 vdd vbsyn gsyn
Xho_15_2 ahp15 ahn15 wp_ho_15_2 wn_ho_15_2 mop2 mon2 vdd vbsyn gsyn
Xho_16_2 ahp16 ahn16 wp_ho_16_2 wn_ho_16_2 mop2 mon2 vdd vbsyn gsyn
Xho_17_2 ahp17 ahn17 wp_ho_17_2 wn_ho_17_2 mop2 mon2 vdd vbsyn gsyn
Xho_18_2 ahp18 ahn18 wp_ho_18_2 wn_ho_18_2 mop2 mon2 vdd vbsyn gsyn
Xho_19_2 ahp19 ahn19 wp_ho_19_2 wn_ho_19_2 mop2 mon2 vdd vbsyn gsyn
Xho_20_2 ahp20 ahn20 wp_ho_20_2 wn_ho_20_2 mop2 mon2 vdd vbsyn gsyn
Xho_21_2 ahp21 ahn21 wp_ho_21_2 wn_ho_21_2 mop2 mon2 vdd vbsyn gsyn
Xho_22_2 ahp22 ahn22 wp_ho_22_2 wn_ho_22_2 mop2 mon2 vdd vbsyn gsyn
Xho_23_2 ahp23 ahn23 wp_ho_23_2 wn_ho_23_2 mop2 mon2 vdd vbsyn gsyn
Xho_24_2 ahp24 ahn24 wp_ho_24_2 wn_ho_24_2 mop2 mon2 vdd vbsyn gsyn
Xho_25_2 ahp25 ahn25 wp_ho_25_2 wn_ho_25_2 mop2 mon2 vdd vbsyn gsyn
Xho_26_2 ahp26 ahn26 wp_ho_26_2 wn_ho_26_2 mop2 mon2 vdd vbsyn gsyn
Xho_27_2 ahp27 ahn27 wp_ho_27_2 wn_ho_27_2 mop2 mon2 vdd vbsyn gsyn
Xho_28_2 ahp28 ahn28 wp_ho_28_2 wn_ho_28_2 mop2 mon2 vdd vbsyn gsyn
Xho_29_2 ahp29 ahn29 wp_ho_29_2 wn_ho_29_2 mop2 mon2 vdd vbsyn gsyn
Xho_30_2 ahp30 ahn30 wp_ho_30_2 wn_ho_30_2 mop2 mon2 vdd vbsyn gsyn
Xho_31_2 ahp31 ahn31 wp_ho_31_2 wn_ho_31_2 mop2 mon2 vdd vbsyn gsyn
Xho_32_2 ahp32 ahn32 wp_ho_32_2 wn_ho_32_2 mop2 mon2 vdd vbsyn gsyn
Xho_33_2 ahp33 ahn33 wp_ho_33_2 wn_ho_33_2 mop2 mon2 vdd vbsyn gsyn
Xho_34_2 ahp34 ahn34 wp_ho_34_2 wn_ho_34_2 mop2 mon2 vdd vbsyn gsyn
Xho_35_2 ahp35 ahn35 wp_ho_35_2 wn_ho_35_2 mop2 mon2 vdd vbsyn gsyn
Xho_36_2 ahp36 ahn36 wp_ho_36_2 wn_ho_36_2 mop2 mon2 vdd vbsyn gsyn
Xho_37_2 ahp37 ahn37 wp_ho_37_2 wn_ho_37_2 mop2 mon2 vdd vbsyn gsyn
Xho_38_2 ahp38 ahn38 wp_ho_38_2 wn_ho_38_2 mop2 mon2 vdd vbsyn gsyn
Xho_39_2 ahp39 ahn39 wp_ho_39_2 wn_ho_39_2 mop2 mon2 vdd vbsyn gsyn
Xho_40_2 ahp40 ahn40 wp_ho_40_2 wn_ho_40_2 mop2 mon2 vdd vbsyn gsyn
Xho_41_2 ahp41 ahn41 wp_ho_41_2 wn_ho_41_2 mop2 mon2 vdd vbsyn gsyn
Xho_42_2 ahp42 ahn42 wp_ho_42_2 wn_ho_42_2 mop2 mon2 vdd vbsyn gsyn
Xho_43_2 ahp43 ahn43 wp_ho_43_2 wn_ho_43_2 mop2 mon2 vdd vbsyn gsyn
Xho_44_2 ahp44 ahn44 wp_ho_44_2 wn_ho_44_2 mop2 mon2 vdd vbsyn gsyn
Xho_45_2 ahp45 ahn45 wp_ho_45_2 wn_ho_45_2 mop2 mon2 vdd vbsyn gsyn
Xho_46_2 ahp46 ahn46 wp_ho_46_2 wn_ho_46_2 mop2 mon2 vdd vbsyn gsyn
Xho_47_2 ahp47 ahn47 wp_ho_47_2 wn_ho_47_2 mop2 mon2 vdd vbsyn gsyn
Xho_48_2 ahp48 ahn48 wp_ho_48_2 wn_ho_48_2 mop2 mon2 vdd vbsyn gsyn
Xho_49_2 ahp49 ahn49 wp_ho_49_2 wn_ho_49_2 mop2 mon2 vdd vbsyn gsyn
Xho_50_2 ahp50 ahn50 wp_ho_50_2 wn_ho_50_2 mop2 mon2 vdd vbsyn gsyn
Xho_51_2 ahp51 ahn51 wp_ho_51_2 wn_ho_51_2 mop2 mon2 vdd vbsyn gsyn
Xho_52_2 ahp52 ahn52 wp_ho_52_2 wn_ho_52_2 mop2 mon2 vdd vbsyn gsyn
Xho_53_2 ahp53 ahn53 wp_ho_53_2 wn_ho_53_2 mop2 mon2 vdd vbsyn gsyn
Xho_54_2 ahp54 ahn54 wp_ho_54_2 wn_ho_54_2 mop2 mon2 vdd vbsyn gsyn
Xho_55_2 ahp55 ahn55 wp_ho_55_2 wn_ho_55_2 mop2 mon2 vdd vbsyn gsyn
Xho_56_2 ahp56 ahn56 wp_ho_56_2 wn_ho_56_2 mop2 mon2 vdd vbsyn gsyn
Xho_57_2 ahp57 ahn57 wp_ho_57_2 wn_ho_57_2 mop2 mon2 vdd vbsyn gsyn
Xho_58_2 ahp58 ahn58 wp_ho_58_2 wn_ho_58_2 mop2 mon2 vdd vbsyn gsyn
Xho_59_2 ahp59 ahn59 wp_ho_59_2 wn_ho_59_2 mop2 mon2 vdd vbsyn gsyn
Xho_60_2 ahp60 ahn60 wp_ho_60_2 wn_ho_60_2 mop2 mon2 vdd vbsyn gsyn
Xho_61_2 ahp61 ahn61 wp_ho_61_2 wn_ho_61_2 mop2 mon2 vdd vbsyn gsyn
Xho_62_2 ahp62 ahn62 wp_ho_62_2 wn_ho_62_2 mop2 mon2 vdd vbsyn gsyn
Xho_63_2 ahp63 ahn63 wp_ho_63_2 wn_ho_63_2 mop2 mon2 vdd vbsyn gsyn
Xho_64_2 ahp64 ahn64 wp_ho_64_2 wn_ho_64_2 mop2 mon2 vdd vbsyn gsyn
Xho_65_2 ahp65 ahn65 wp_ho_65_2 wn_ho_65_2 mop2 mon2 vdd vbsyn gsyn
Xho_66_2 ahp66 ahn66 wp_ho_66_2 wn_ho_66_2 mop2 mon2 vdd vbsyn gsyn
Xho_67_2 ahp67 ahn67 wp_ho_67_2 wn_ho_67_2 mop2 mon2 vdd vbsyn gsyn
Xho_68_2 ahp68 ahn68 wp_ho_68_2 wn_ho_68_2 mop2 mon2 vdd vbsyn gsyn
Xho_69_2 ahp69 ahn69 wp_ho_69_2 wn_ho_69_2 mop2 mon2 vdd vbsyn gsyn
Xho_70_2 ahp70 ahn70 wp_ho_70_2 wn_ho_70_2 mop2 mon2 vdd vbsyn gsyn
Xho_71_2 ahp71 ahn71 wp_ho_71_2 wn_ho_71_2 mop2 mon2 vdd vbsyn gsyn
Xho_72_2 ahp72 ahn72 wp_ho_72_2 wn_ho_72_2 mop2 mon2 vdd vbsyn gsyn
Xho_73_2 ahp73 ahn73 wp_ho_73_2 wn_ho_73_2 mop2 mon2 vdd vbsyn gsyn
Xho_74_2 ahp74 ahn74 wp_ho_74_2 wn_ho_74_2 mop2 mon2 vdd vbsyn gsyn
Xho_75_2 ahp75 ahn75 wp_ho_75_2 wn_ho_75_2 mop2 mon2 vdd vbsyn gsyn
Xho_76_2 ahp76 ahn76 wp_ho_76_2 wn_ho_76_2 mop2 mon2 vdd vbsyn gsyn
Xho_77_2 ahp77 ahn77 wp_ho_77_2 wn_ho_77_2 mop2 mon2 vdd vbsyn gsyn
Xho_78_2 ahp78 ahn78 wp_ho_78_2 wn_ho_78_2 mop2 mon2 vdd vbsyn gsyn
Xho_79_2 ahp79 ahn79 wp_ho_79_2 wn_ho_79_2 mop2 mon2 vdd vbsyn gsyn
Xho_80_2 ahp80 ahn80 wp_ho_80_2 wn_ho_80_2 mop2 mon2 vdd vbsyn gsyn
Xho_81_2 ahp81 ahn81 wp_ho_81_2 wn_ho_81_2 mop2 mon2 vdd vbsyn gsyn
Xho_82_2 ahp82 ahn82 wp_ho_82_2 wn_ho_82_2 mop2 mon2 vdd vbsyn gsyn
Xho_83_2 ahp83 ahn83 wp_ho_83_2 wn_ho_83_2 mop2 mon2 vdd vbsyn gsyn
Xho_84_2 ahp84 ahn84 wp_ho_84_2 wn_ho_84_2 mop2 mon2 vdd vbsyn gsyn
Xho_85_2 ahp85 ahn85 wp_ho_85_2 wn_ho_85_2 mop2 mon2 vdd vbsyn gsyn
Xho_86_2 ahp86 ahn86 wp_ho_86_2 wn_ho_86_2 mop2 mon2 vdd vbsyn gsyn
Xho_87_2 ahp87 ahn87 wp_ho_87_2 wn_ho_87_2 mop2 mon2 vdd vbsyn gsyn
Xho_88_2 ahp88 ahn88 wp_ho_88_2 wn_ho_88_2 mop2 mon2 vdd vbsyn gsyn
Xho_89_2 ahp89 ahn89 wp_ho_89_2 wn_ho_89_2 mop2 mon2 vdd vbsyn gsyn
Xho_90_2 ahp90 ahn90 wp_ho_90_2 wn_ho_90_2 mop2 mon2 vdd vbsyn gsyn
Xho_91_2 ahp91 ahn91 wp_ho_91_2 wn_ho_91_2 mop2 mon2 vdd vbsyn gsyn
Xho_92_2 ahp92 ahn92 wp_ho_92_2 wn_ho_92_2 mop2 mon2 vdd vbsyn gsyn
Xho_93_2 ahp93 ahn93 wp_ho_93_2 wn_ho_93_2 mop2 mon2 vdd vbsyn gsyn
Xho_94_2 ahp94 ahn94 wp_ho_94_2 wn_ho_94_2 mop2 mon2 vdd vbsyn gsyn
Xho_95_2 ahp95 ahn95 wp_ho_95_2 wn_ho_95_2 mop2 mon2 vdd vbsyn gsyn
Xho_96_2 ahp96 ahn96 wp_ho_96_2 wn_ho_96_2 mop2 mon2 vdd vbsyn gsyn
Xho_97_2 ahp97 ahn97 wp_ho_97_2 wn_ho_97_2 mop2 mon2 vdd vbsyn gsyn
Xho_98_2 ahp98 ahn98 wp_ho_98_2 wn_ho_98_2 mop2 mon2 vdd vbsyn gsyn
Xho_99_2 ahp99 ahn99 wp_ho_99_2 wn_ho_99_2 mop2 mon2 vdd vbsyn gsyn
Xho_100_2 ahp100 ahn100 wp_ho_100_2 wn_ho_100_2 mop2 mon2 vdd vbsyn gsyn
Xho_101_2 ahp101 ahn101 wp_ho_101_2 wn_ho_101_2 mop2 mon2 vdd vbsyn gsyn
Xho_102_2 ahp102 ahn102 wp_ho_102_2 wn_ho_102_2 mop2 mon2 vdd vbsyn gsyn
Xho_103_2 ahp103 ahn103 wp_ho_103_2 wn_ho_103_2 mop2 mon2 vdd vbsyn gsyn
Xho_104_2 ahp104 ahn104 wp_ho_104_2 wn_ho_104_2 mop2 mon2 vdd vbsyn gsyn
Xho_105_2 ahp105 ahn105 wp_ho_105_2 wn_ho_105_2 mop2 mon2 vdd vbsyn gsyn
Xho_106_2 ahp106 ahn106 wp_ho_106_2 wn_ho_106_2 mop2 mon2 vdd vbsyn gsyn
Xho_107_2 ahp107 ahn107 wp_ho_107_2 wn_ho_107_2 mop2 mon2 vdd vbsyn gsyn
Xho_108_2 ahp108 ahn108 wp_ho_108_2 wn_ho_108_2 mop2 mon2 vdd vbsyn gsyn
Xho_109_2 ahp109 ahn109 wp_ho_109_2 wn_ho_109_2 mop2 mon2 vdd vbsyn gsyn
Xho_110_2 ahp110 ahn110 wp_ho_110_2 wn_ho_110_2 mop2 mon2 vdd vbsyn gsyn
Xho_111_2 ahp111 ahn111 wp_ho_111_2 wn_ho_111_2 mop2 mon2 vdd vbsyn gsyn
Xho_112_2 ahp112 ahn112 wp_ho_112_2 wn_ho_112_2 mop2 mon2 vdd vbsyn gsyn
Xho_113_2 ahp113 ahn113 wp_ho_113_2 wn_ho_113_2 mop2 mon2 vdd vbsyn gsyn
Xho_114_2 ahp114 ahn114 wp_ho_114_2 wn_ho_114_2 mop2 mon2 vdd vbsyn gsyn
Xho_115_2 ahp115 ahn115 wp_ho_115_2 wn_ho_115_2 mop2 mon2 vdd vbsyn gsyn
Xho_116_2 ahp116 ahn116 wp_ho_116_2 wn_ho_116_2 mop2 mon2 vdd vbsyn gsyn
Xho_117_2 ahp117 ahn117 wp_ho_117_2 wn_ho_117_2 mop2 mon2 vdd vbsyn gsyn
Xho_118_2 ahp118 ahn118 wp_ho_118_2 wn_ho_118_2 mop2 mon2 vdd vbsyn gsyn
Xho_119_2 ahp119 ahn119 wp_ho_119_2 wn_ho_119_2 mop2 mon2 vdd vbsyn gsyn
Xho_120_2 ahp120 ahn120 wp_ho_120_2 wn_ho_120_2 mop2 mon2 vdd vbsyn gsyn
Xho_121_2 ahp121 ahn121 wp_ho_121_2 wn_ho_121_2 mop2 mon2 vdd vbsyn gsyn
Xho_122_2 ahp122 ahn122 wp_ho_122_2 wn_ho_122_2 mop2 mon2 vdd vbsyn gsyn
Xho_123_2 ahp123 ahn123 wp_ho_123_2 wn_ho_123_2 mop2 mon2 vdd vbsyn gsyn
Xho_124_2 ahp124 ahn124 wp_ho_124_2 wn_ho_124_2 mop2 mon2 vdd vbsyn gsyn
Xho_125_2 ahp125 ahn125 wp_ho_125_2 wn_ho_125_2 mop2 mon2 vdd vbsyn gsyn
Xho_126_2 ahp126 ahn126 wp_ho_126_2 wn_ho_126_2 mop2 mon2 vdd vbsyn gsyn
Xho_127_2 ahp127 ahn127 wp_ho_127_2 wn_ho_127_2 mop2 mon2 vdd vbsyn gsyn
Xho_128_2 ahp128 ahn128 wp_ho_128_2 wn_ho_128_2 mop2 mon2 vdd vbsyn gsyn
Xho_129_2 ahp129 ahn129 wp_ho_129_2 wn_ho_129_2 mop2 mon2 vdd vbsyn gsyn
Xho_130_2 ahp130 ahn130 wp_ho_130_2 wn_ho_130_2 mop2 mon2 vdd vbsyn gsyn
Xho_131_2 ahp131 ahn131 wp_ho_131_2 wn_ho_131_2 mop2 mon2 vdd vbsyn gsyn
Xho_132_2 ahp132 ahn132 wp_ho_132_2 wn_ho_132_2 mop2 mon2 vdd vbsyn gsyn
Xho_133_2 ahp133 ahn133 wp_ho_133_2 wn_ho_133_2 mop2 mon2 vdd vbsyn gsyn
Xho_134_2 ahp134 ahn134 wp_ho_134_2 wn_ho_134_2 mop2 mon2 vdd vbsyn gsyn
Xho_135_2 ahp135 ahn135 wp_ho_135_2 wn_ho_135_2 mop2 mon2 vdd vbsyn gsyn
Xho_136_2 ahp136 ahn136 wp_ho_136_2 wn_ho_136_2 mop2 mon2 vdd vbsyn gsyn
Xho_137_2 ahp137 ahn137 wp_ho_137_2 wn_ho_137_2 mop2 mon2 vdd vbsyn gsyn
Xho_138_2 ahp138 ahn138 wp_ho_138_2 wn_ho_138_2 mop2 mon2 vdd vbsyn gsyn
Xho_139_2 ahp139 ahn139 wp_ho_139_2 wn_ho_139_2 mop2 mon2 vdd vbsyn gsyn
Xho_140_2 ahp140 ahn140 wp_ho_140_2 wn_ho_140_2 mop2 mon2 vdd vbsyn gsyn
Xho_141_2 ahp141 ahn141 wp_ho_141_2 wn_ho_141_2 mop2 mon2 vdd vbsyn gsyn
Xho_142_2 ahp142 ahn142 wp_ho_142_2 wn_ho_142_2 mop2 mon2 vdd vbsyn gsyn
Xho_143_2 ahp143 ahn143 wp_ho_143_2 wn_ho_143_2 mop2 mon2 vdd vbsyn gsyn
Xho_144_2 ahp144 ahn144 wp_ho_144_2 wn_ho_144_2 mop2 mon2 vdd vbsyn gsyn
Xho_145_2 ahp145 ahn145 wp_ho_145_2 wn_ho_145_2 mop2 mon2 vdd vbsyn gsyn
Xho_146_2 ahp146 ahn146 wp_ho_146_2 wn_ho_146_2 mop2 mon2 vdd vbsyn gsyn
Xho_147_2 ahp147 ahn147 wp_ho_147_2 wn_ho_147_2 mop2 mon2 vdd vbsyn gsyn
Xho_148_2 ahp148 ahn148 wp_ho_148_2 wn_ho_148_2 mop2 mon2 vdd vbsyn gsyn
Xho_149_2 ahp149 ahn149 wp_ho_149_2 wn_ho_149_2 mop2 mon2 vdd vbsyn gsyn
Xho_150_2 ahp150 ahn150 wp_ho_150_2 wn_ho_150_2 mop2 mon2 vdd vbsyn gsyn
Xho_151_2 ahp151 ahn151 wp_ho_151_2 wn_ho_151_2 mop2 mon2 vdd vbsyn gsyn
Xho_152_2 ahp152 ahn152 wp_ho_152_2 wn_ho_152_2 mop2 mon2 vdd vbsyn gsyn
Xho_153_2 ahp153 ahn153 wp_ho_153_2 wn_ho_153_2 mop2 mon2 vdd vbsyn gsyn
Xho_154_2 ahp154 ahn154 wp_ho_154_2 wn_ho_154_2 mop2 mon2 vdd vbsyn gsyn
Xho_155_2 ahp155 ahn155 wp_ho_155_2 wn_ho_155_2 mop2 mon2 vdd vbsyn gsyn
Xho_156_2 ahp156 ahn156 wp_ho_156_2 wn_ho_156_2 mop2 mon2 vdd vbsyn gsyn
Xho_157_2 ahp157 ahn157 wp_ho_157_2 wn_ho_157_2 mop2 mon2 vdd vbsyn gsyn
Xho_158_2 ahp158 ahn158 wp_ho_158_2 wn_ho_158_2 mop2 mon2 vdd vbsyn gsyn
Xho_159_2 ahp159 ahn159 wp_ho_159_2 wn_ho_159_2 mop2 mon2 vdd vbsyn gsyn
Xho_160_2 ahp160 ahn160 wp_ho_160_2 wn_ho_160_2 mop2 mon2 vdd vbsyn gsyn
Xho_161_2 ahp161 ahn161 wp_ho_161_2 wn_ho_161_2 mop2 mon2 vdd vbsyn gsyn
Xho_162_2 ahp162 ahn162 wp_ho_162_2 wn_ho_162_2 mop2 mon2 vdd vbsyn gsyn
Xho_163_2 ahp163 ahn163 wp_ho_163_2 wn_ho_163_2 mop2 mon2 vdd vbsyn gsyn
Xho_164_2 ahp164 ahn164 wp_ho_164_2 wn_ho_164_2 mop2 mon2 vdd vbsyn gsyn
Xho_165_2 ahp165 ahn165 wp_ho_165_2 wn_ho_165_2 mop2 mon2 vdd vbsyn gsyn
Xho_166_2 ahp166 ahn166 wp_ho_166_2 wn_ho_166_2 mop2 mon2 vdd vbsyn gsyn
Xho_167_2 ahp167 ahn167 wp_ho_167_2 wn_ho_167_2 mop2 mon2 vdd vbsyn gsyn
Xho_168_2 ahp168 ahn168 wp_ho_168_2 wn_ho_168_2 mop2 mon2 vdd vbsyn gsyn
Xho_169_2 ahp169 ahn169 wp_ho_169_2 wn_ho_169_2 mop2 mon2 vdd vbsyn gsyn
Xho_170_2 ahp170 ahn170 wp_ho_170_2 wn_ho_170_2 mop2 mon2 vdd vbsyn gsyn
Xho_171_2 ahp171 ahn171 wp_ho_171_2 wn_ho_171_2 mop2 mon2 vdd vbsyn gsyn
Xho_172_2 ahp172 ahn172 wp_ho_172_2 wn_ho_172_2 mop2 mon2 vdd vbsyn gsyn
Xho_173_2 ahp173 ahn173 wp_ho_173_2 wn_ho_173_2 mop2 mon2 vdd vbsyn gsyn
Xho_174_2 ahp174 ahn174 wp_ho_174_2 wn_ho_174_2 mop2 mon2 vdd vbsyn gsyn
Xho_175_2 ahp175 ahn175 wp_ho_175_2 wn_ho_175_2 mop2 mon2 vdd vbsyn gsyn
Xho_176_2 ahp176 ahn176 wp_ho_176_2 wn_ho_176_2 mop2 mon2 vdd vbsyn gsyn
Xho_177_2 ahp177 ahn177 wp_ho_177_2 wn_ho_177_2 mop2 mon2 vdd vbsyn gsyn
Xho_178_2 ahp178 ahn178 wp_ho_178_2 wn_ho_178_2 mop2 mon2 vdd vbsyn gsyn
Xho_179_2 ahp179 ahn179 wp_ho_179_2 wn_ho_179_2 mop2 mon2 vdd vbsyn gsyn
Xho_180_2 ahp180 ahn180 wp_ho_180_2 wn_ho_180_2 mop2 mon2 vdd vbsyn gsyn
Xho_181_2 ahp181 ahn181 wp_ho_181_2 wn_ho_181_2 mop2 mon2 vdd vbsyn gsyn
Xho_182_2 ahp182 ahn182 wp_ho_182_2 wn_ho_182_2 mop2 mon2 vdd vbsyn gsyn
Xho_183_2 ahp183 ahn183 wp_ho_183_2 wn_ho_183_2 mop2 mon2 vdd vbsyn gsyn
Xho_184_2 ahp184 ahn184 wp_ho_184_2 wn_ho_184_2 mop2 mon2 vdd vbsyn gsyn
Xho_185_2 ahp185 ahn185 wp_ho_185_2 wn_ho_185_2 mop2 mon2 vdd vbsyn gsyn
Xho_186_2 ahp186 ahn186 wp_ho_186_2 wn_ho_186_2 mop2 mon2 vdd vbsyn gsyn
Xho_187_2 ahp187 ahn187 wp_ho_187_2 wn_ho_187_2 mop2 mon2 vdd vbsyn gsyn
Xho_188_2 ahp188 ahn188 wp_ho_188_2 wn_ho_188_2 mop2 mon2 vdd vbsyn gsyn
Xho_189_2 ahp189 ahn189 wp_ho_189_2 wn_ho_189_2 mop2 mon2 vdd vbsyn gsyn
Xho_190_2 ahp190 ahn190 wp_ho_190_2 wn_ho_190_2 mop2 mon2 vdd vbsyn gsyn
Xho_191_2 ahp191 ahn191 wp_ho_191_2 wn_ho_191_2 mop2 mon2 vdd vbsyn gsyn
Xho_192_2 ahp192 ahn192 wp_ho_192_2 wn_ho_192_2 mop2 mon2 vdd vbsyn gsyn
Xho_193_2 ahp193 ahn193 wp_ho_193_2 wn_ho_193_2 mop2 mon2 vdd vbsyn gsyn
Xho_194_2 ahp194 ahn194 wp_ho_194_2 wn_ho_194_2 mop2 mon2 vdd vbsyn gsyn
Xho_195_2 ahp195 ahn195 wp_ho_195_2 wn_ho_195_2 mop2 mon2 vdd vbsyn gsyn
Xho_196_2 ahp196 ahn196 wp_ho_196_2 wn_ho_196_2 mop2 mon2 vdd vbsyn gsyn
Xho_197_2 ahp197 ahn197 wp_ho_197_2 wn_ho_197_2 mop2 mon2 vdd vbsyn gsyn
Xho_198_2 ahp198 ahn198 wp_ho_198_2 wn_ho_198_2 mop2 mon2 vdd vbsyn gsyn
Xho_199_2 ahp199 ahn199 wp_ho_199_2 wn_ho_199_2 mop2 mon2 vdd vbsyn gsyn
Xho_200_2 ahp200 ahn200 wp_ho_200_2 wn_ho_200_2 mop2 mon2 vdd vbsyn gsyn
Xho_201_2 ahp201 ahn201 wp_ho_201_2 wn_ho_201_2 mop2 mon2 vdd vbsyn gsyn
Xho_202_2 ahp202 ahn202 wp_ho_202_2 wn_ho_202_2 mop2 mon2 vdd vbsyn gsyn
Xho_203_2 ahp203 ahn203 wp_ho_203_2 wn_ho_203_2 mop2 mon2 vdd vbsyn gsyn
Xho_204_2 ahp204 ahn204 wp_ho_204_2 wn_ho_204_2 mop2 mon2 vdd vbsyn gsyn
Xho_205_2 ahp205 ahn205 wp_ho_205_2 wn_ho_205_2 mop2 mon2 vdd vbsyn gsyn
Xho_206_2 ahp206 ahn206 wp_ho_206_2 wn_ho_206_2 mop2 mon2 vdd vbsyn gsyn
Xho_207_2 ahp207 ahn207 wp_ho_207_2 wn_ho_207_2 mop2 mon2 vdd vbsyn gsyn
Xho_208_2 ahp208 ahn208 wp_ho_208_2 wn_ho_208_2 mop2 mon2 vdd vbsyn gsyn
Xho_209_2 ahp209 ahn209 wp_ho_209_2 wn_ho_209_2 mop2 mon2 vdd vbsyn gsyn
Xho_210_2 ahp210 ahn210 wp_ho_210_2 wn_ho_210_2 mop2 mon2 vdd vbsyn gsyn
Xho_211_2 ahp211 ahn211 wp_ho_211_2 wn_ho_211_2 mop2 mon2 vdd vbsyn gsyn
Xho_212_2 ahp212 ahn212 wp_ho_212_2 wn_ho_212_2 mop2 mon2 vdd vbsyn gsyn
Xho_213_2 ahp213 ahn213 wp_ho_213_2 wn_ho_213_2 mop2 mon2 vdd vbsyn gsyn
Xho_214_2 ahp214 ahn214 wp_ho_214_2 wn_ho_214_2 mop2 mon2 vdd vbsyn gsyn
Xho_215_2 ahp215 ahn215 wp_ho_215_2 wn_ho_215_2 mop2 mon2 vdd vbsyn gsyn
Xho_216_2 ahp216 ahn216 wp_ho_216_2 wn_ho_216_2 mop2 mon2 vdd vbsyn gsyn
Xho_217_2 ahp217 ahn217 wp_ho_217_2 wn_ho_217_2 mop2 mon2 vdd vbsyn gsyn
Xho_218_2 ahp218 ahn218 wp_ho_218_2 wn_ho_218_2 mop2 mon2 vdd vbsyn gsyn
Xho_219_2 ahp219 ahn219 wp_ho_219_2 wn_ho_219_2 mop2 mon2 vdd vbsyn gsyn
Xho_220_2 ahp220 ahn220 wp_ho_220_2 wn_ho_220_2 mop2 mon2 vdd vbsyn gsyn
Xho_221_2 ahp221 ahn221 wp_ho_221_2 wn_ho_221_2 mop2 mon2 vdd vbsyn gsyn
Xho_222_2 ahp222 ahn222 wp_ho_222_2 wn_ho_222_2 mop2 mon2 vdd vbsyn gsyn
Xho_223_2 ahp223 ahn223 wp_ho_223_2 wn_ho_223_2 mop2 mon2 vdd vbsyn gsyn
Xho_224_2 ahp224 ahn224 wp_ho_224_2 wn_ho_224_2 mop2 mon2 vdd vbsyn gsyn
Xho_225_2 ahp225 ahn225 wp_ho_225_2 wn_ho_225_2 mop2 mon2 vdd vbsyn gsyn
Xho_226_2 ahp226 ahn226 wp_ho_226_2 wn_ho_226_2 mop2 mon2 vdd vbsyn gsyn
Xho_227_2 ahp227 ahn227 wp_ho_227_2 wn_ho_227_2 mop2 mon2 vdd vbsyn gsyn
Xho_228_2 ahp228 ahn228 wp_ho_228_2 wn_ho_228_2 mop2 mon2 vdd vbsyn gsyn
Xho_229_2 ahp229 ahn229 wp_ho_229_2 wn_ho_229_2 mop2 mon2 vdd vbsyn gsyn
Xho_230_2 ahp230 ahn230 wp_ho_230_2 wn_ho_230_2 mop2 mon2 vdd vbsyn gsyn
Xho_231_2 ahp231 ahn231 wp_ho_231_2 wn_ho_231_2 mop2 mon2 vdd vbsyn gsyn
Xho_232_2 ahp232 ahn232 wp_ho_232_2 wn_ho_232_2 mop2 mon2 vdd vbsyn gsyn
Xho_233_2 ahp233 ahn233 wp_ho_233_2 wn_ho_233_2 mop2 mon2 vdd vbsyn gsyn
Xho_234_2 ahp234 ahn234 wp_ho_234_2 wn_ho_234_2 mop2 mon2 vdd vbsyn gsyn
Xho_235_2 ahp235 ahn235 wp_ho_235_2 wn_ho_235_2 mop2 mon2 vdd vbsyn gsyn
Xho_236_2 ahp236 ahn236 wp_ho_236_2 wn_ho_236_2 mop2 mon2 vdd vbsyn gsyn
Xho_237_2 ahp237 ahn237 wp_ho_237_2 wn_ho_237_2 mop2 mon2 vdd vbsyn gsyn
Xho_238_2 ahp238 ahn238 wp_ho_238_2 wn_ho_238_2 mop2 mon2 vdd vbsyn gsyn
Xho_239_2 ahp239 ahn239 wp_ho_239_2 wn_ho_239_2 mop2 mon2 vdd vbsyn gsyn
Xho_240_2 ahp240 ahn240 wp_ho_240_2 wn_ho_240_2 mop2 mon2 vdd vbsyn gsyn
Xho_241_2 ahp241 ahn241 wp_ho_241_2 wn_ho_241_2 mop2 mon2 vdd vbsyn gsyn
Xho_242_2 ahp242 ahn242 wp_ho_242_2 wn_ho_242_2 mop2 mon2 vdd vbsyn gsyn
Xho_243_2 ahp243 ahn243 wp_ho_243_2 wn_ho_243_2 mop2 mon2 vdd vbsyn gsyn
Xho_244_2 ahp244 ahn244 wp_ho_244_2 wn_ho_244_2 mop2 mon2 vdd vbsyn gsyn
Xho_245_2 ahp245 ahn245 wp_ho_245_2 wn_ho_245_2 mop2 mon2 vdd vbsyn gsyn
Xho_246_2 ahp246 ahn246 wp_ho_246_2 wn_ho_246_2 mop2 mon2 vdd vbsyn gsyn
Xho_247_2 ahp247 ahn247 wp_ho_247_2 wn_ho_247_2 mop2 mon2 vdd vbsyn gsyn
Xho_248_2 ahp248 ahn248 wp_ho_248_2 wn_ho_248_2 mop2 mon2 vdd vbsyn gsyn
Xho_249_2 ahp249 ahn249 wp_ho_249_2 wn_ho_249_2 mop2 mon2 vdd vbsyn gsyn
Xho_250_2 ahp250 ahn250 wp_ho_250_2 wn_ho_250_2 mop2 mon2 vdd vbsyn gsyn
Xho_251_2 ahp251 ahn251 wp_ho_251_2 wn_ho_251_2 mop2 mon2 vdd vbsyn gsyn
Xho_252_2 ahp252 ahn252 wp_ho_252_2 wn_ho_252_2 mop2 mon2 vdd vbsyn gsyn
Xho_253_2 ahp253 ahn253 wp_ho_253_2 wn_ho_253_2 mop2 mon2 vdd vbsyn gsyn
Xho_254_2 ahp254 ahn254 wp_ho_254_2 wn_ho_254_2 mop2 mon2 vdd vbsyn gsyn
Xho_255_2 ahp255 ahn255 wp_ho_255_2 wn_ho_255_2 mop2 mon2 vdd vbsyn gsyn
Xho_256_2 ahp256 ahn256 wp_ho_256_2 wn_ho_256_2 mop2 mon2 vdd vbsyn gsyn
Xho_257_2 ahp257 ahn257 wp_ho_257_2 wn_ho_257_2 mop2 mon2 vdd vbsyn gsyn
Xho_258_2 ahp258 ahn258 wp_ho_258_2 wn_ho_258_2 mop2 mon2 vdd vbsyn gsyn
Xho_259_2 ahp259 ahn259 wp_ho_259_2 wn_ho_259_2 mop2 mon2 vdd vbsyn gsyn
Xho_260_2 ahp260 ahn260 wp_ho_260_2 wn_ho_260_2 mop2 mon2 vdd vbsyn gsyn
Xho_261_2 ahp261 ahn261 wp_ho_261_2 wn_ho_261_2 mop2 mon2 vdd vbsyn gsyn
Xho_262_2 ahp262 ahn262 wp_ho_262_2 wn_ho_262_2 mop2 mon2 vdd vbsyn gsyn
Xho_263_2 ahp263 ahn263 wp_ho_263_2 wn_ho_263_2 mop2 mon2 vdd vbsyn gsyn
Xho_264_2 ahp264 ahn264 wp_ho_264_2 wn_ho_264_2 mop2 mon2 vdd vbsyn gsyn
Xho_265_2 ahp265 ahn265 wp_ho_265_2 wn_ho_265_2 mop2 mon2 vdd vbsyn gsyn
Xho_266_2 ahp266 ahn266 wp_ho_266_2 wn_ho_266_2 mop2 mon2 vdd vbsyn gsyn
Xho_267_2 ahp267 ahn267 wp_ho_267_2 wn_ho_267_2 mop2 mon2 vdd vbsyn gsyn
Xho_268_2 ahp268 ahn268 wp_ho_268_2 wn_ho_268_2 mop2 mon2 vdd vbsyn gsyn
Xho_269_2 ahp269 ahn269 wp_ho_269_2 wn_ho_269_2 mop2 mon2 vdd vbsyn gsyn
Xho_270_2 ahp270 ahn270 wp_ho_270_2 wn_ho_270_2 mop2 mon2 vdd vbsyn gsyn
Xho_271_2 ahp271 ahn271 wp_ho_271_2 wn_ho_271_2 mop2 mon2 vdd vbsyn gsyn
Xho_272_2 ahp272 ahn272 wp_ho_272_2 wn_ho_272_2 mop2 mon2 vdd vbsyn gsyn
Xho_273_2 ahp273 ahn273 wp_ho_273_2 wn_ho_273_2 mop2 mon2 vdd vbsyn gsyn
Xho_274_2 ahp274 ahn274 wp_ho_274_2 wn_ho_274_2 mop2 mon2 vdd vbsyn gsyn
Xho_275_2 ahp275 ahn275 wp_ho_275_2 wn_ho_275_2 mop2 mon2 vdd vbsyn gsyn
Xho_276_2 ahp276 ahn276 wp_ho_276_2 wn_ho_276_2 mop2 mon2 vdd vbsyn gsyn
Xho_277_2 ahp277 ahn277 wp_ho_277_2 wn_ho_277_2 mop2 mon2 vdd vbsyn gsyn
Xho_278_2 ahp278 ahn278 wp_ho_278_2 wn_ho_278_2 mop2 mon2 vdd vbsyn gsyn
Xho_279_2 ahp279 ahn279 wp_ho_279_2 wn_ho_279_2 mop2 mon2 vdd vbsyn gsyn
Xho_280_2 ahp280 ahn280 wp_ho_280_2 wn_ho_280_2 mop2 mon2 vdd vbsyn gsyn
Xho_281_2 ahp281 ahn281 wp_ho_281_2 wn_ho_281_2 mop2 mon2 vdd vbsyn gsyn
Xho_282_2 ahp282 ahn282 wp_ho_282_2 wn_ho_282_2 mop2 mon2 vdd vbsyn gsyn
Xho_283_2 ahp283 ahn283 wp_ho_283_2 wn_ho_283_2 mop2 mon2 vdd vbsyn gsyn
Xho_284_2 ahp284 ahn284 wp_ho_284_2 wn_ho_284_2 mop2 mon2 vdd vbsyn gsyn
Xho_285_2 ahp285 ahn285 wp_ho_285_2 wn_ho_285_2 mop2 mon2 vdd vbsyn gsyn
Xho_286_2 ahp286 ahn286 wp_ho_286_2 wn_ho_286_2 mop2 mon2 vdd vbsyn gsyn
Xho_287_2 ahp287 ahn287 wp_ho_287_2 wn_ho_287_2 mop2 mon2 vdd vbsyn gsyn
.options gmin=1e-10 reltol=2e-3 cshunt=1e-15
.control
tran 1n 540.0n uic
wrdata pb_sp17827.dat v(ahp0) v(ahn0) v(ahp1) v(ahn1) v(ahp2) v(ahn2) v(ahp3) v(ahn3) v(ahp4) v(ahn4) v(ahp5) v(ahn5) v(ahp6) v(ahn6) v(ahp7) v(ahn7) v(ahp8) v(ahn8) v(ahp9) v(ahn9) v(ahp10) v(ahn10) v(ahp11) v(ahn11) v(ahp12) v(ahn12) v(ahp13) v(ahn13) v(ahp14) v(ahn14) v(ahp15) v(ahn15) v(ahp16) v(ahn16) v(ahp17) v(ahn17) v(ahp18) v(ahn18) v(ahp19) v(ahn19) v(ahp20) v(ahn20) v(ahp21) v(ahn21) v(ahp22) v(ahn22) v(ahp23) v(ahn23) v(ahp24) v(ahn24) v(ahp25) v(ahn25) v(ahp26) v(ahn26) v(ahp27) v(ahn27) v(ahp28) v(ahn28) v(ahp29) v(ahn29) v(ahp30) v(ahn30) v(ahp31) v(ahn31) v(ahp32) v(ahn32) v(ahp33) v(ahn33) v(ahp34) v(ahn34) v(ahp35) v(ahn35) v(ahp36) v(ahn36) v(ahp37) v(ahn37) v(ahp38) v(ahn38) v(ahp39) v(ahn39) v(ahp40) v(ahn40) v(ahp41) v(ahn41) v(ahp42) v(ahn42) v(ahp43) v(ahn43) v(ahp44) v(ahn44) v(ahp45) v(ahn45) v(ahp46) v(ahn46) v(ahp47) v(ahn47) v(ahp48) v(ahn48) v(ahp49) v(ahn49) v(ahp50) v(ahn50) v(ahp51) v(ahn51) v(ahp52) v(ahn52) v(ahp53) v(ahn53) v(ahp54) v(ahn54) v(ahp55) v(ahn55) v(ahp56) v(ahn56) v(ahp57) v(ahn57) v(ahp58) v(ahn58) v(ahp59) v(ahn59) v(ahp60) v(ahn60) v(ahp61) v(ahn61) v(ahp62) v(ahn62) v(ahp63) v(ahn63) v(ahp64) v(ahn64) v(ahp65) v(ahn65) v(ahp66) v(ahn66) v(ahp67) v(ahn67) v(ahp68) v(ahn68) v(ahp69) v(ahn69) v(ahp70) v(ahn70) v(ahp71) v(ahn71) v(ahp72) v(ahn72) v(ahp73) v(ahn73) v(ahp74) v(ahn74) v(ahp75) v(ahn75) v(ahp76) v(ahn76) v(ahp77) v(ahn77) v(ahp78) v(ahn78) v(ahp79) v(ahn79) v(ahp80) v(ahn80) v(ahp81) v(ahn81) v(ahp82) v(ahn82) v(ahp83) v(ahn83) v(ahp84) v(ahn84) v(ahp85) v(ahn85) v(ahp86) v(ahn86) v(ahp87) v(ahn87) v(ahp88) v(ahn88) v(ahp89) v(ahn89) v(ahp90) v(ahn90) v(ahp91) v(ahn91) v(ahp92) v(ahn92) v(ahp93) v(ahn93) v(ahp94) v(ahn94) v(ahp95) v(ahn95) v(ahp96) v(ahn96) v(ahp97) v(ahn97) v(ahp98) v(ahn98) v(ahp99) v(ahn99) v(ahp100) v(ahn100) v(ahp101) v(ahn101) v(ahp102) v(ahn102) v(ahp103) v(ahn103) v(ahp104) v(ahn104) v(ahp105) v(ahn105) v(ahp106) v(ahn106) v(ahp107) v(ahn107) v(ahp108) v(ahn108) v(ahp109) v(ahn109) v(ahp110) v(ahn110) v(ahp111) v(ahn111) v(ahp112) v(ahn112) v(ahp113) v(ahn113) v(ahp114) v(ahn114) v(ahp115) v(ahn115) v(ahp116) v(ahn116) v(ahp117) v(ahn117) v(ahp118) v(ahn118) v(ahp119) v(ahn119) v(ahp120) v(ahn120) v(ahp121) v(ahn121) v(ahp122) v(ahn122) v(ahp123) v(ahn123) v(ahp124) v(ahn124) v(ahp125) v(ahn125) v(ahp126) v(ahn126) v(ahp127) v(ahn127) v(ahp128) v(ahn128) v(ahp129) v(ahn129) v(ahp130) v(ahn130) v(ahp131) v(ahn131) v(ahp132) v(ahn132) v(ahp133) v(ahn133) v(ahp134) v(ahn134) v(ahp135) v(ahn135) v(ahp136) v(ahn136) v(ahp137) v(ahn137) v(ahp138) v(ahn138) v(ahp139) v(ahn139) v(ahp140) v(ahn140) v(ahp141) v(ahn141) v(ahp142) v(ahn142) v(ahp143) v(ahn143) v(ahp144) v(ahn144) v(ahp145) v(ahn145) v(ahp146) v(ahn146) v(ahp147) v(ahn147) v(ahp148) v(ahn148) v(ahp149) v(ahn149) v(ahp150) v(ahn150) v(ahp151) v(ahn151) v(ahp152) v(ahn152) v(ahp153) v(ahn153) v(ahp154) v(ahn154) v(ahp155) v(ahn155) v(ahp156) v(ahn156) v(ahp157) v(ahn157) v(ahp158) v(ahn158) v(ahp159) v(ahn159) v(ahp160) v(ahn160) v(ahp161) v(ahn161) v(ahp162) v(ahn162) v(ahp163) v(ahn163) v(ahp164) v(ahn164) v(ahp165) v(ahn165) v(ahp166) v(ahn166) v(ahp167) v(ahn167) v(ahp168) v(ahn168) v(ahp169) v(ahn169) v(ahp170) v(ahn170) v(ahp171) v(ahn171) v(ahp172) v(ahn172) v(ahp173) v(ahn173) v(ahp174) v(ahn174) v(ahp175) v(ahn175) v(ahp176) v(ahn176) v(ahp177) v(ahn177) v(ahp178) v(ahn178) v(ahp179) v(ahn179) v(ahp180) v(ahn180) v(ahp181) v(ahn181) v(ahp182) v(ahn182) v(ahp183) v(ahn183) v(ahp184) v(ahn184) v(ahp185) v(ahn185) v(ahp186) v(ahn186) v(ahp187) v(ahn187) v(ahp188) v(ahn188) v(ahp189) v(ahn189) v(ahp190) v(ahn190) v(ahp191) v(ahn191) v(ahp192) v(ahn192) v(ahp193) v(ahn193) v(ahp194) v(ahn194) v(ahp195) v(ahn195) v(ahp196) v(ahn196) v(ahp197) v(ahn197) v(ahp198) v(ahn198) v(ahp199) v(ahn199) v(ahp200) v(ahn200) v(ahp201) v(ahn201) v(ahp202) v(ahn202) v(ahp203) v(ahn203) v(ahp204) v(ahn204) v(ahp205) v(ahn205) v(ahp206) v(ahn206) v(ahp207) v(ahn207) v(ahp208) v(ahn208) v(ahp209) v(ahn209) v(ahp210) v(ahn210) v(ahp211) v(ahn211) v(ahp212) v(ahn212) v(ahp213) v(ahn213) v(ahp214) v(ahn214) v(ahp215) v(ahn215) v(ahp216) v(ahn216) v(ahp217) v(ahn217) v(ahp218) v(ahn218) v(ahp219) v(ahn219) v(ahp220) v(ahn220) v(ahp221) v(ahn221) v(ahp222) v(ahn222) v(ahp223) v(ahn223) v(ahp224) v(ahn224) v(ahp225) v(ahn225) v(ahp226) v(ahn226) v(ahp227) v(ahn227) v(ahp228) v(ahn228) v(ahp229) v(ahn229) v(ahp230) v(ahn230) v(ahp231) v(ahn231) v(ahp232) v(ahn232) v(ahp233) v(ahn233) v(ahp234) v(ahn234) v(ahp235) v(ahn235) v(ahp236) v(ahn236) v(ahp237) v(ahn237) v(ahp238) v(ahn238) v(ahp239) v(ahn239) v(ahp240) v(ahn240) v(ahp241) v(ahn241) v(ahp242) v(ahn242) v(ahp243) v(ahn243) v(ahp244) v(ahn244) v(ahp245) v(ahn245) v(ahp246) v(ahn246) v(ahp247) v(ahn247) v(ahp248) v(ahn248) v(ahp249) v(ahn249) v(ahp250) v(ahn250) v(ahp251) v(ahn251) v(ahp252) v(ahn252) v(ahp253) v(ahn253) v(ahp254) v(ahn254) v(ahp255) v(ahn255) v(ahp256) v(ahn256) v(ahp257) v(ahn257) v(ahp258) v(ahn258) v(ahp259) v(ahn259) v(ahp260) v(ahn260) v(ahp261) v(ahn261) v(ahp262) v(ahn262) v(ahp263) v(ahn263) v(ahp264) v(ahn264) v(ahp265) v(ahn265) v(ahp266) v(ahn266) v(ahp267) v(ahn267) v(ahp268) v(ahn268) v(ahp269) v(ahn269) v(ahp270) v(ahn270) v(ahp271) v(ahn271) v(ahp272) v(ahn272) v(ahp273) v(ahn273) v(ahp274) v(ahn274) v(ahp275) v(ahn275) v(ahp276) v(ahn276) v(ahp277) v(ahn277) v(ahp278) v(ahn278) v(ahp279) v(ahn279) v(ahp280) v(ahn280) v(ahp281) v(ahn281) v(ahp282) v(ahn282) v(ahp283) v(ahn283) v(ahp284) v(ahn284) v(ahp285) v(ahn285) v(ahp286) v(ahn286) v(ahp287) v(ahn287) v(mop0) v(mon0) v(mop1) v(mon1) v(mop2) v(mon2)
.endc
.end
