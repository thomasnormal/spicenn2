current-mode EP XOR
Vmid nmid 0 0.5
Vt vt 0 0.5
Va_x1 a_x1 0 0.5
Va_x2 a_x2 0 0.5
Blk_1 0 u_h1 I=(0.91511)*(V(a_x1)-0.5)+(-0.82900)*(V(a_x2)-0.5)+(0.59738)*(V(u_o)-0.5)+(-0.49788)*0.4
Rl_1 u_h1 nmid 1
Ba_1 a_h1 0 V=0.5+0.5*tanh(12.0*(V(u_h1)-0.5))
Blk_2 0 u_h2 I=(-0.49162)*(V(a_x1)-0.5)+(-0.23714)*(V(a_x2)-0.5)+(0.20211)*(V(u_o)-0.5)+(0.08598)*0.4
Rl_2 u_h2 nmid 1
Ba_2 a_h2 0 V=0.5+0.5*tanh(12.0*(V(u_h2)-0.5))
Blk_3 0 u_h3 I=(-0.27595)*(V(a_x1)-0.5)+(0.98058)*(V(a_x2)-0.5)+(0.31986)*(V(u_o)-0.5)+(-0.12253)*0.4
Rl_3 u_h3 nmid 1
Ba_3 a_h3 0 V=0.5+0.5*tanh(12.0*(V(u_h3)-0.5))
Blk_4 0 u_h4 I=(-0.46465)*(V(a_x1)-0.5)+(-0.33852)*(V(a_x2)-0.5)+(-0.19912)*(V(u_o)-0.5)+(-0.41124)*0.4
Rl_4 u_h4 nmid 1
Ba_4 a_h4 0 V=0.5+0.5*tanh(12.0*(V(u_h4)-0.5))
Blk_5 0 u_h5 I=(0.26684)*(V(a_x1)-0.5)+(0.39607)*(V(a_x2)-0.5)+(-0.44870)*(V(u_o)-0.5)+(-0.44896)*0.4
Rl_5 u_h5 nmid 1
Ba_5 a_h5 0 V=0.5+0.5*tanh(12.0*(V(u_h5)-0.5))
Blk_6 0 u_h6 I=(-0.07473)*(V(a_x1)-0.5)+(0.49471)*(V(a_x2)-0.5)+(0.18632)*(V(u_o)-0.5)+(-0.11835)*0.4
Rl_6 u_h6 nmid 1
Ba_6 a_h6 0 V=0.5+0.5*tanh(12.0*(V(u_h6)-0.5))
Blk_o 0 u_o I=(0.59738)*(V(a_h1)-0.5)+(0.20211)*(V(a_h2)-0.5)+(0.31986)*(V(a_h3)-0.5)+(-0.19912)*(V(a_h4)-0.5)+(-0.44870)*(V(a_h5)-0.5)+(0.18632)*(V(a_h6)-0.5)+(-0.06122)*0.4
Rl_o u_o nmid 1
Rb u_o vt 1e9
.control
alter Va_x1 0.1
alter Va_x2 0.1
alter Rb 1e9
op
wrdata cf0.dat v(u_h1) v(a_h1) v(u_h2) v(a_h2) v(u_h3) v(a_h3) v(u_h4) v(a_h4) v(u_h5) v(a_h5) v(u_h6) v(a_h6) v(u_o)
alter Vt 0.15
alter Rb 5.0
op
wrdata cn0.dat v(u_h1) v(a_h1) v(u_h2) v(a_h2) v(u_h3) v(a_h3) v(u_h4) v(a_h4) v(u_h5) v(a_h5) v(u_h6) v(a_h6) v(u_o)
alter Va_x1 0.1
alter Va_x2 0.9
alter Rb 1e9
op
wrdata cf1.dat v(u_h1) v(a_h1) v(u_h2) v(a_h2) v(u_h3) v(a_h3) v(u_h4) v(a_h4) v(u_h5) v(a_h5) v(u_h6) v(a_h6) v(u_o)
alter Vt 0.85
alter Rb 5.0
op
wrdata cn1.dat v(u_h1) v(a_h1) v(u_h2) v(a_h2) v(u_h3) v(a_h3) v(u_h4) v(a_h4) v(u_h5) v(a_h5) v(u_h6) v(a_h6) v(u_o)
alter Va_x1 0.9
alter Va_x2 0.1
alter Rb 1e9
op
wrdata cf2.dat v(u_h1) v(a_h1) v(u_h2) v(a_h2) v(u_h3) v(a_h3) v(u_h4) v(a_h4) v(u_h5) v(a_h5) v(u_h6) v(a_h6) v(u_o)
alter Vt 0.85
alter Rb 5.0
op
wrdata cn2.dat v(u_h1) v(a_h1) v(u_h2) v(a_h2) v(u_h3) v(a_h3) v(u_h4) v(a_h4) v(u_h5) v(a_h5) v(u_h6) v(a_h6) v(u_o)
alter Va_x1 0.9
alter Va_x2 0.9
alter Rb 1e9
op
wrdata cf3.dat v(u_h1) v(a_h1) v(u_h2) v(a_h2) v(u_h3) v(a_h3) v(u_h4) v(a_h4) v(u_h5) v(a_h5) v(u_h6) v(a_h6) v(u_o)
alter Vt 0.15
alter Rb 5.0
op
wrdata cn3.dat v(u_h1) v(a_h1) v(u_h2) v(a_h2) v(u_h3) v(a_h3) v(u_h4) v(a_h4) v(u_h5) v(a_h5) v(u_h6) v(a_h6) v(u_o)
.endc
.end
