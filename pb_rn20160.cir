batched
.model NNR NMOS (LEVEL=1 VTO=0.2 KP=120u LAMBDA=0.02 GAMMA=0 PHI=0.7)
.model PNR PMOS (LEVEL=1 VTO=-0.2 KP=40u LAMBDA=0.02 GAMMA=0 PHI=0.7)
.subckt gsyn inp inn wp wn outp outn vdd vbn
Mtail nt vbn 0 0 NNR W=400u L=100u
M5 na wp s5 0 NNR W=200u L=100u
Rd5 s5 nt 30k
M6 nb wn s6 0 NNR W=200u L=100u
Rd6 s6 nt 30k
M1 outp inp s1 0 NNR W=200u L=100u
Rd1 s1 na 30k
M2 outn inn s2 0 NNR W=200u L=100u
Rd2 s2 na 30k
M3 outn inp s3 0 NNR W=200u L=100u
Rd3 s3 nb 30k
M4 outp inn s4 0 NNR W=200u L=100u
Rd4 s4 nb 30k
.ends
.subckt cmld p n vdd
Rcs1 p cmx 300k
Rcs2 n cmx 300k
MLp p cmx vdd vdd PNR W=4000u L=100u
MLn n cmx vdd vdd PNR W=4000u L=100u
.ends
.subckt dneuron up un ap an vdd vbn
M1 an up s1 0 NNR W=200u L=100u
Rn1 s1 tn 20k
M2 ap un s2 0 NNR W=200u L=100u
Rn2 s2 tn 20k
Mt tn vbn 0 0 NNR W=200u L=100u
Xcm ap an vdd cmld
.ends

Vdd vdd 0 1.0
Vbsyn vbsyn 0 0.45
Vbbk vbbk 0 0.30
Vbneu vbneu 0 0.35
Vgm gm 0 0.6
Vxp0 a_xp0 0 PWL(0.01n 1.2342 20.00n 1.2342 20.01n 1.4237 40.00n 1.4237 40.01n 0.2019 60.00n 0.2019 60.01n 1.2793 80.00n 1.2793 80.01n 0.1401 100.00n 0.1401 100.01n 0.8493 120.00n 0.8493 120.01n 1.4477 140.00n 1.4477 140.01n 1.2772 160.00n 1.2772 160.01n 1.4191 180.00n 1.4191 180.01n -0.0028 200.00n -0.0028 200.01n 1.4378 220.00n 1.4378 220.01n 1.4432 240.00n 1.4432 240.01n -0.4097 260.00n -0.4097 260.01n 1.3066 280.00n 1.3066 280.01n 0.5880 300.00n 0.5880 300.01n 1.3920 320.00n 1.3920 320.01n 0.6368 340.00n 0.6368 340.01n 1.1784 360.00n 1.1784 360.01n 1.4447 380.00n 1.4447 380.01n -0.2077 400.00n -0.2077 400.01n 0.6827 420.00n 0.6827 420.01n -0.1466 440.00n -0.1466 440.01n -0.2822 460.00n -0.2822 460.01n 0.0011 480.00n 0.0011 480.01n 1.0670 500.00n 1.0670 500.01n 0.2628 520.00n 0.2628 520.01n -0.3768 540.00n -0.3768 540.01n 0.4433 560.00n 0.4433 560.01n 0.5095 580.00n 0.5095 580.01n 1.5153 600.00n 1.5153 600.01n 1.0624 620.00n 1.0624 620.01n -0.1458)
Vxn0 a_xn0 0 PWL(0.01n -0.2342 20.00n -0.2342 20.01n -0.4237 40.00n -0.4237 40.01n 0.7981 60.00n 0.7981 60.01n -0.2793 80.00n -0.2793 80.01n 0.8599 100.00n 0.8599 100.01n 0.1507 120.00n 0.1507 120.01n -0.4477 140.00n -0.4477 140.01n -0.2772 160.00n -0.2772 160.01n -0.4191 180.00n -0.4191 180.01n 1.0028 200.00n 1.0028 200.01n -0.4378 220.00n -0.4378 220.01n -0.4432 240.00n -0.4432 240.01n 1.4097 260.00n 1.4097 260.01n -0.3066 280.00n -0.3066 280.01n 0.4120 300.00n 0.4120 300.01n -0.3920 320.00n -0.3920 320.01n 0.3632 340.00n 0.3632 340.01n -0.1784 360.00n -0.1784 360.01n -0.4447 380.00n -0.4447 380.01n 1.2077 400.00n 1.2077 400.01n 0.3173 420.00n 0.3173 420.01n 1.1466 440.00n 1.1466 440.01n 1.2822 460.00n 1.2822 460.01n 0.9989 480.00n 0.9989 480.01n -0.0670 500.00n -0.0670 500.01n 0.7372 520.00n 0.7372 520.01n 1.3768 540.00n 1.3768 540.01n 0.5567 560.00n 0.5567 560.01n 0.4905 580.00n 0.4905 580.01n -0.5153 600.00n -0.5153 600.01n -0.0624 620.00n -0.0624 620.01n 1.1458)
Vxp1 a_xp1 0 PWL(0.01n 1.0869 20.00n 1.0869 20.01n 0.4457 40.00n 0.4457 40.01n 1.3763 60.00n 1.3763 60.01n 0.0843 80.00n 0.0843 80.01n 1.4271 100.00n 1.4271 100.01n 1.4191 120.00n 1.4191 120.01n 0.5716 140.00n 0.5716 140.01n -0.0810 160.00n -0.0810 160.01n 0.2781 180.00n 0.2781 180.01n -0.3188 200.00n -0.3188 200.01n 0.1853 220.00n 0.1853 220.01n 0.5202 240.00n 0.5202 240.01n 0.0987 260.00n 0.0987 260.01n -0.0130 280.00n -0.0130 280.01n 1.5032 300.00n 1.5032 300.01n 0.2070 320.00n 0.2070 320.01n -0.4554 340.00n -0.4554 340.01n 1.1862 360.00n 1.1862 360.01n 0.7108 380.00n 0.7108 380.01n 1.2170 400.00n 1.2170 400.01n -0.4069 420.00n -0.4069 420.01n -0.2180 440.00n -0.2180 440.01n -0.1711 460.00n -0.1711 460.01n 1.3881 480.00n 1.3881 480.01n -0.2965 500.00n -0.2965 500.01n 1.4596 520.00n 1.4596 520.01n 0.8121 540.00n 0.8121 540.01n -0.4755 560.00n -0.4755 560.01n 1.4710 580.00n 1.4710 580.01n 0.4897 600.00n 0.4897 600.01n -0.1796 620.00n -0.1796 620.01n 1.2997)
Vxn1 a_xn1 0 PWL(0.01n -0.0869 20.00n -0.0869 20.01n 0.5543 40.00n 0.5543 40.01n -0.3763 60.00n -0.3763 60.01n 0.9157 80.00n 0.9157 80.01n -0.4271 100.00n -0.4271 100.01n -0.4191 120.00n -0.4191 120.01n 0.4284 140.00n 0.4284 140.01n 1.0810 160.00n 1.0810 160.01n 0.7219 180.00n 0.7219 180.01n 1.3188 200.00n 1.3188 200.01n 0.8147 220.00n 0.8147 220.01n 0.4798 240.00n 0.4798 240.01n 0.9013 260.00n 0.9013 260.01n 1.0130 280.00n 1.0130 280.01n -0.5032 300.00n -0.5032 300.01n 0.7930 320.00n 0.7930 320.01n 1.4554 340.00n 1.4554 340.01n -0.1862 360.00n -0.1862 360.01n 0.2892 380.00n 0.2892 380.01n -0.2170 400.00n -0.2170 400.01n 1.4069 420.00n 1.4069 420.01n 1.2180 440.00n 1.2180 440.01n 1.1711 460.00n 1.1711 460.01n -0.3881 480.00n -0.3881 480.01n 1.2965 500.00n 1.2965 500.01n -0.4596 520.00n -0.4596 520.01n 0.1879 540.00n 0.1879 540.01n 1.4755 560.00n 1.4755 560.01n -0.4710 580.00n -0.4710 580.01n 0.5103 600.00n 0.5103 600.01n 1.1796 620.00n 1.1796 620.01n -0.2997)
Vxp2 a_xp2 0 PWL(0.01n 0.6800 20.00n 0.6800 20.01n 0.6800 40.00n 0.6800 40.01n 0.6800 60.00n 0.6800 60.01n 0.6800 80.00n 0.6800 80.01n 0.6800 100.00n 0.6800 100.01n 0.6800 120.00n 0.6800 120.01n 0.6800 140.00n 0.6800 140.01n 0.6800 160.00n 0.6800 160.01n 0.6800 180.00n 0.6800 180.01n 0.6800 200.00n 0.6800 200.01n 0.6800 220.00n 0.6800 220.01n 0.6800 240.00n 0.6800 240.01n 0.6800 260.00n 0.6800 260.01n 0.6800 280.00n 0.6800 280.01n 0.6800 300.00n 0.6800 300.01n 0.6800 320.00n 0.6800 320.01n 0.6800 340.00n 0.6800 340.01n 0.6800 360.00n 0.6800 360.01n 0.6800 380.00n 0.6800 380.01n 0.6800 400.00n 0.6800 400.01n 0.6800 420.00n 0.6800 420.01n 0.6800 440.00n 0.6800 440.01n 0.6800 460.00n 0.6800 460.01n 0.6800 480.00n 0.6800 480.01n 0.6800 500.00n 0.6800 500.01n 0.6800 520.00n 0.6800 520.01n 0.6800 540.00n 0.6800 540.01n 0.6800 560.00n 0.6800 560.01n 0.6800 580.00n 0.6800 580.01n 0.6800 600.00n 0.6800 600.01n 0.6800 620.00n 0.6800 620.01n 0.6800)
Vxn2 a_xn2 0 PWL(0.01n 0.3200 20.00n 0.3200 20.01n 0.3200 40.00n 0.3200 40.01n 0.3200 60.00n 0.3200 60.01n 0.3200 80.00n 0.3200 80.01n 0.3200 100.00n 0.3200 100.01n 0.3200 120.00n 0.3200 120.01n 0.3200 140.00n 0.3200 140.01n 0.3200 160.00n 0.3200 160.01n 0.3200 180.00n 0.3200 180.01n 0.3200 200.00n 0.3200 200.01n 0.3200 220.00n 0.3200 220.01n 0.3200 240.00n 0.3200 240.01n 0.3200 260.00n 0.3200 260.01n 0.3200 280.00n 0.3200 280.01n 0.3200 300.00n 0.3200 300.01n 0.3200 320.00n 0.3200 320.01n 0.3200 340.00n 0.3200 340.01n 0.3200 360.00n 0.3200 360.01n 0.3200 380.00n 0.3200 380.01n 0.3200 400.00n 0.3200 400.01n 0.3200 420.00n 0.3200 420.01n 0.3200 440.00n 0.3200 440.01n 0.3200 460.00n 0.3200 460.01n 0.3200 480.00n 0.3200 480.01n 0.3200 500.00n 0.3200 500.01n 0.3200 520.00n 0.3200 520.01n 0.3200 540.00n 0.3200 540.01n 0.3200 560.00n 0.3200 560.01n 0.3200 580.00n 0.3200 580.01n 0.3200 600.00n 0.3200 600.01n 0.3200 620.00n 0.3200 620.01n 0.3200)
Vwp_ih_0_0 wp_ih_0_0 0 0.6086025543478274
Vwn_ih_0_0 wn_ih_0_0 0 0.3913974456521726
Vwp_ih_1_0 wp_ih_1_0 0 0.5187066261309039
Vwn_ih_1_0 wn_ih_1_0 0 0.4812933738690961
Vwp_ih_2_0 wp_ih_2_0 0 0.3
Vwn_ih_2_0 wn_ih_2_0 0 0.8989311219070408
Vwp_ih_0_1 wp_ih_0_1 0 0.710114424915764
Vwn_ih_0_1 wn_ih_0_1 0 0.3
Vwp_ih_1_1 wp_ih_1_1 0 0.5388820732243326
Vwn_ih_1_1 wn_ih_1_1 0 0.46111792677566743
Vwp_ih_2_1 wp_ih_2_1 0 0.3
Vwn_ih_2_1 wn_ih_2_1 0 0.899
Vwp_ih_0_2 wp_ih_0_2 0 0.3
Vwn_ih_0_2 wn_ih_0_2 0 0.728859801824207
Vwp_ih_1_2 wp_ih_1_2 0 0.8318787208469782
Vwn_ih_1_2 wn_ih_1_2 0 0.3
Vwp_ih_2_2 wp_ih_2_2 0 0.8951993697159023
Vwn_ih_2_2 wn_ih_2_2 0 0.3
Vwp_ih_0_3 wp_ih_0_3 0 0.6964379651185657
Vwn_ih_0_3 wn_ih_0_3 0 0.30356203488143424
Vwp_ih_1_3 wp_ih_1_3 0 0.7703682091682973
Vwn_ih_1_3 wn_ih_1_3 0 0.3
Vwp_ih_2_3 wp_ih_2_3 0 0.8984108293688577
Vwn_ih_2_3 wn_ih_2_3 0 0.3
Vwp_ih_0_4 wp_ih_0_4 0 0.4996697631768254
Vwn_ih_0_4 wn_ih_0_4 0 0.5003302368231746
Vwp_ih_1_4 wp_ih_1_4 0 0.5003145581842176
Vwn_ih_1_4 wn_ih_1_4 0 0.49968544181578245
Vwp_ih_2_4 wp_ih_2_4 0 0.5002059394661573
Vwn_ih_2_4 wn_ih_2_4 0 0.4997940605338427
Vwp_ih_0_5 wp_ih_0_5 0 0.5264962329872255
Vwn_ih_0_5 wn_ih_0_5 0 0.4735037670127746
Vwp_ih_1_5 wp_ih_1_5 0 0.6870796157102369
Vwn_ih_1_5 wn_ih_1_5 0 0.3129203842897631
Vwp_ih_2_5 wp_ih_2_5 0 0.89780695230351
Vwn_ih_2_5 wn_ih_2_5 0 0.3
Vwp_ih_0_6 wp_ih_0_6 0 0.46401566045219866
Vwn_ih_0_6 wn_ih_0_6 0 0.5359843395478013
Vwp_ih_1_6 wp_ih_1_6 0 0.3
Vwn_ih_1_6 wn_ih_1_6 0 0.899
Vwp_ih_2_6 wp_ih_2_6 0 0.8787575326564745
Vwn_ih_2_6 wn_ih_2_6 0 0.3
Vwp_ih_0_7 wp_ih_0_7 0 0.32808493932683613
Vwn_ih_0_7 wn_ih_0_7 0 0.6719150606731639
Vwp_ih_1_7 wp_ih_1_7 0 0.6072784327270718
Vwn_ih_1_7 wn_ih_1_7 0 0.3927215672729282
Vwp_ih_2_7 wp_ih_2_7 0 0.3
Vwn_ih_2_7 wn_ih_2_7 0 0.899
Vwp_ih_0_8 wp_ih_0_8 0 0.3
Vwn_ih_0_8 wn_ih_0_8 0 0.7100017510290593
Vwp_ih_1_8 wp_ih_1_8 0 0.3
Vwn_ih_1_8 wn_ih_1_8 0 0.834390611603375
Vwp_ih_2_8 wp_ih_2_8 0 0.8978316444467633
Vwn_ih_2_8 wn_ih_2_8 0 0.3
Vwp_ih_0_9 wp_ih_0_9 0 0.4278319470457478
Vwn_ih_0_9 wn_ih_0_9 0 0.5721680529542522
Vwp_ih_1_9 wp_ih_1_9 0 0.6816505063356575
Vwn_ih_1_9 wn_ih_1_9 0 0.3183494936643425
Vwp_ih_2_9 wp_ih_2_9 0 0.3
Vwn_ih_2_9 wn_ih_2_9 0 0.8984391682637188
Vwp_ih_0_10 wp_ih_0_10 0 0.7296510901309055
Vwn_ih_0_10 wn_ih_0_10 0 0.3
Vwp_ih_1_10 wp_ih_1_10 0 0.5496015507534138
Vwn_ih_1_10 wn_ih_1_10 0 0.45039844924658623
Vwp_ih_2_10 wp_ih_2_10 0 0.8972201326151288
Vwn_ih_2_10 wn_ih_2_10 0 0.3
Vwp_ih_0_11 wp_ih_0_11 0 0.4089254516189393
Vwn_ih_0_11 wn_ih_0_11 0 0.5910745483810608
Vwp_ih_1_11 wp_ih_1_11 0 0.7872363193110066
Vwn_ih_1_11 wn_ih_1_11 0 0.3
Vwp_ih_2_11 wp_ih_2_11 0 0.3
Vwn_ih_2_11 wn_ih_2_11 0 0.8988790847275359
Vwp_ih_0_12 wp_ih_0_12 0 0.541674593703677
Vwn_ih_0_12 wn_ih_0_12 0 0.458325406296323
Vwp_ih_1_12 wp_ih_1_12 0 0.4036471760917353
Vwn_ih_1_12 wn_ih_1_12 0 0.5963528239082647
Vwp_ih_2_12 wp_ih_2_12 0 0.899
Vwn_ih_2_12 wn_ih_2_12 0 0.3
Vwp_ih_0_13 wp_ih_0_13 0 0.43559328904423644
Vwn_ih_0_13 wn_ih_0_13 0 0.5644067109557636
Vwp_ih_1_13 wp_ih_1_13 0 0.5915889677379413
Vwn_ih_1_13 wn_ih_1_13 0 0.40841103226205866
Vwp_ih_2_13 wp_ih_2_13 0 0.8958734359725686
Vwn_ih_2_13 wn_ih_2_13 0 0.3
Vwp_ih_0_14 wp_ih_0_14 0 0.50054062367984
Vwn_ih_0_14 wn_ih_0_14 0 0.49945937632016
Vwp_ih_1_14 wp_ih_1_14 0 0.5013978873965897
Vwn_ih_1_14 wn_ih_1_14 0 0.4986021126034102
Vwp_ih_2_14 wp_ih_2_14 0 0.899
Vwn_ih_2_14 wn_ih_2_14 0 0.3
Vwp_ih_0_15 wp_ih_0_15 0 0.39526673278834323
Vwn_ih_0_15 wn_ih_0_15 0 0.6047332672116568
Vwp_ih_1_15 wp_ih_1_15 0 0.4553875713347888
Vwn_ih_1_15 wn_ih_1_15 0 0.5446124286652112
Vwp_ih_2_15 wp_ih_2_15 0 0.3
Vwn_ih_2_15 wn_ih_2_15 0 0.8987405652415401
Vwp_ih_0_16 wp_ih_0_16 0 0.5005692056489166
Vwn_ih_0_16 wn_ih_0_16 0 0.49943079435108334
Vwp_ih_1_16 wp_ih_1_16 0 0.5008421671715413
Vwn_ih_1_16 wn_ih_1_16 0 0.49915783282845866
Vwp_ih_2_16 wp_ih_2_16 0 0.899
Vwn_ih_2_16 wn_ih_2_16 0 0.3
Vwp_ih_0_17 wp_ih_0_17 0 0.5004813622475356
Vwn_ih_0_17 wn_ih_0_17 0 0.4995186377524644
Vwp_ih_1_17 wp_ih_1_17 0 0.5011119865421096
Vwn_ih_1_17 wn_ih_1_17 0 0.49888801345789036
Vwp_ih_2_17 wp_ih_2_17 0 0.899
Vwn_ih_2_17 wn_ih_2_17 0 0.3
Vwp_ih_0_18 wp_ih_0_18 0 0.4716048871494503
Vwn_ih_0_18 wn_ih_0_18 0 0.5283951128505497
Vwp_ih_1_18 wp_ih_1_18 0 0.39966441957975246
Vwn_ih_1_18 wn_ih_1_18 0 0.6003355804202475
Vwp_ih_2_18 wp_ih_2_18 0 0.899
Vwn_ih_2_18 wn_ih_2_18 0 0.3
Vwp_ih_0_19 wp_ih_0_19 0 0.6035887221828617
Vwn_ih_0_19 wn_ih_0_19 0 0.3964112778171382
Vwp_ih_1_19 wp_ih_1_19 0 0.5419175029249971
Vwn_ih_1_19 wn_ih_1_19 0 0.458082497075003
Vwp_ih_2_19 wp_ih_2_19 0 0.8986452914372262
Vwn_ih_2_19 wn_ih_2_19 0 0.3
Vwp_ih_0_20 wp_ih_0_20 0 0.5848542147794855
Vwn_ih_0_20 wn_ih_0_20 0 0.41514578522051454
Vwp_ih_1_20 wp_ih_1_20 0 0.700978546945071
Vwn_ih_1_20 wn_ih_1_20 0 0.3
Vwp_ih_2_20 wp_ih_2_20 0 0.3
Vwn_ih_2_20 wn_ih_2_20 0 0.899
Vwp_ih_0_21 wp_ih_0_21 0 0.8095833876241947
Vwn_ih_0_21 wn_ih_0_21 0 0.3
Vwp_ih_1_21 wp_ih_1_21 0 0.753093495651691
Vwn_ih_1_21 wn_ih_1_21 0 0.3
Vwp_ih_2_21 wp_ih_2_21 0 0.3
Vwn_ih_2_21 wn_ih_2_21 0 0.895901599327926
Vwp_ih_0_22 wp_ih_0_22 0 0.35172656780338496
Vwn_ih_0_22 wn_ih_0_22 0 0.648273432196615
Vwp_ih_1_22 wp_ih_1_22 0 0.6562347896753051
Vwn_ih_1_22 wn_ih_1_22 0 0.34376521032469487
Vwp_ih_2_22 wp_ih_2_22 0 0.899
Vwn_ih_2_22 wn_ih_2_22 0 0.3
Vwp_ih_0_23 wp_ih_0_23 0 0.3
Vwn_ih_0_23 wn_ih_0_23 0 0.8818319673995165
Vwp_ih_1_23 wp_ih_1_23 0 0.3539729441747608
Vwn_ih_1_23 wn_ih_1_23 0 0.6460270558252392
Vwp_ih_2_23 wp_ih_2_23 0 0.8943574410170059
Vwn_ih_2_23 wn_ih_2_23 0 0.3
Vwp_ih_0_24 wp_ih_0_24 0 0.4994027017937994
Vwn_ih_0_24 wn_ih_0_24 0 0.5005972982062006
Vwp_ih_1_24 wp_ih_1_24 0 0.4994325724236005
Vwn_ih_1_24 wn_ih_1_24 0 0.5005674275763995
Vwp_ih_2_24 wp_ih_2_24 0 0.3
Vwn_ih_2_24 wn_ih_2_24 0 0.899
Vwp_ih_0_25 wp_ih_0_25 0 0.899
Vwn_ih_0_25 wn_ih_0_25 0 0.3
Vwp_ih_1_25 wp_ih_1_25 0 0.4234922591629204
Vwn_ih_1_25 wn_ih_1_25 0 0.5765077408370797
Vwp_ih_2_25 wp_ih_2_25 0 0.3
Vwn_ih_2_25 wn_ih_2_25 0 0.8874576457616121
Vwp_ih_0_26 wp_ih_0_26 0 0.5032365669868379
Vwn_ih_0_26 wn_ih_0_26 0 0.49676343301316206
Vwp_ih_1_26 wp_ih_1_26 0 0.8177096588261963
Vwn_ih_1_26 wn_ih_1_26 0 0.3
Vwp_ih_2_26 wp_ih_2_26 0 0.899
Vwn_ih_2_26 wn_ih_2_26 0 0.3
Vwp_ih_0_27 wp_ih_0_27 0 0.5801913176488162
Vwn_ih_0_27 wn_ih_0_27 0 0.41980868235118385
Vwp_ih_1_27 wp_ih_1_27 0 0.4190865340092228
Vwn_ih_1_27 wn_ih_1_27 0 0.5809134659907772
Vwp_ih_2_27 wp_ih_2_27 0 0.3
Vwn_ih_2_27 wn_ih_2_27 0 0.8966478208459489
Vwp_ih_0_28 wp_ih_0_28 0 0.3
Vwn_ih_0_28 wn_ih_0_28 0 0.7918895187875552
Vwp_ih_1_28 wp_ih_1_28 0 0.7033440203671325
Vwn_ih_1_28 wn_ih_1_28 0 0.3
Vwp_ih_2_28 wp_ih_2_28 0 0.3
Vwn_ih_2_28 wn_ih_2_28 0 0.8966822124973661
Vwp_ih_0_29 wp_ih_0_29 0 0.5002203122747333
Vwn_ih_0_29 wn_ih_0_29 0 0.4997796877252667
Vwp_ih_1_29 wp_ih_1_29 0 0.4998592673868484
Vwn_ih_1_29 wn_ih_1_29 0 0.5001407326131516
Vwp_ih_2_29 wp_ih_2_29 0 0.49980352609435186
Vwn_ih_2_29 wn_ih_2_29 0 0.5001964739056481
Vwp_ih_0_30 wp_ih_0_30 0 0.8988824000167832
Vwn_ih_0_30 wn_ih_0_30 0 0.3
Vwp_ih_1_30 wp_ih_1_30 0 0.5498713488096353
Vwn_ih_1_30 wn_ih_1_30 0 0.4501286511903647
Vwp_ih_2_30 wp_ih_2_30 0 0.8347464406711549
Vwn_ih_2_30 wn_ih_2_30 0 0.3
Vwp_ih_0_31 wp_ih_0_31 0 0.3626333926365898
Vwn_ih_0_31 wn_ih_0_31 0 0.6373666073634102
Vwp_ih_1_31 wp_ih_1_31 0 0.3
Vwn_ih_1_31 wn_ih_1_31 0 0.8616222623893818
Vwp_ih_2_31 wp_ih_2_31 0 0.3
Vwn_ih_2_31 wn_ih_2_31 0 0.8967738408693391
Vwp_ho_0_0 wp_ho_0_0 0 0.5826464981116675
Vwn_ho_0_0 wn_ho_0_0 0 0.41735350188833253
Vwp_ho_1_0 wp_ho_1_0 0 0.5508568730804403
Vwn_ho_1_0 wn_ho_1_0 0 0.4491431269195597
Vwp_ho_2_0 wp_ho_2_0 0 0.6537637660864933
Vwn_ho_2_0 wn_ho_2_0 0 0.34623623391350666
Vwp_ho_3_0 wp_ho_3_0 0 0.6333293697589513
Vwn_ho_3_0 wn_ho_3_0 0 0.36667063024104873
Vwp_ho_4_0 wp_ho_4_0 0 0.5003420308472886
Vwn_ho_4_0 wn_ho_4_0 0 0.49965796915271143
Vwp_ho_5_0 wp_ho_5_0 0 0.39863925690931923
Vwn_ho_5_0 wn_ho_5_0 0 0.6013607430906808
Vwp_ho_6_0 wp_ho_6_0 0 0.6325861171491214
Vwn_ho_6_0 wn_ho_6_0 0 0.3674138828508786
Vwp_ho_7_0 wp_ho_7_0 0 0.5045304666841848
Vwn_ho_7_0 wn_ho_7_0 0 0.4954695333158153
Vwp_ho_8_0 wp_ho_8_0 0 0.6158241394875988
Vwn_ho_8_0 wn_ho_8_0 0 0.38417586051240116
Vwp_ho_9_0 wp_ho_9_0 0 0.5513299759893273
Vwn_ho_9_0 wn_ho_9_0 0 0.4486700240106727
Vwp_ho_10_0 wp_ho_10_0 0 0.6418804203521726
Vwn_ho_10_0 wn_ho_10_0 0 0.3581195796478273
Vwp_ho_11_0 wp_ho_11_0 0 0.38392927600853
Vwn_ho_11_0 wn_ho_11_0 0 0.61607072399147
Vwp_ho_12_0 wp_ho_12_0 0 0.31844443972545383
Vwn_ho_12_0 wn_ho_12_0 0 0.6815555602745462
Vwp_ho_13_0 wp_ho_13_0 0 0.47847572290901774
Vwn_ho_13_0 wn_ho_13_0 0 0.5215242770909823
Vwp_ho_14_0 wp_ho_14_0 0 0.5357914886542197
Vwn_ho_14_0 wn_ho_14_0 0 0.46420851134578034
Vwp_ho_15_0 wp_ho_15_0 0 0.6564775290772826
Vwn_ho_15_0 wn_ho_15_0 0 0.3435224709227174
Vwp_ho_16_0 wp_ho_16_0 0 0.4453736330187317
Vwn_ho_16_0 wn_ho_16_0 0 0.5546263669812683
Vwp_ho_17_0 wp_ho_17_0 0 0.4846454012930727
Vwn_ho_17_0 wn_ho_17_0 0 0.5153545987069273
Vwp_ho_18_0 wp_ho_18_0 0 0.49751155299729494
Vwn_ho_18_0 wn_ho_18_0 0 0.5024884470027051
Vwp_ho_19_0 wp_ho_19_0 0 0.42200864109284436
Vwn_ho_19_0 wn_ho_19_0 0 0.5779913589071557
Vwp_ho_20_0 wp_ho_20_0 0 0.6061624128149176
Vwn_ho_20_0 wn_ho_20_0 0 0.3938375871850824
Vwp_ho_21_0 wp_ho_21_0 0 0.40311516840062
Vwn_ho_21_0 wn_ho_21_0 0 0.59688483159938
Vwp_ho_22_0 wp_ho_22_0 0 0.5168122744027346
Vwn_ho_22_0 wn_ho_22_0 0 0.48318772559726536
Vwp_ho_23_0 wp_ho_23_0 0 0.5983324836319531
Vwn_ho_23_0 wn_ho_23_0 0 0.4016675163680469
Vwp_ho_24_0 wp_ho_24_0 0 0.5783448302888881
Vwn_ho_24_0 wn_ho_24_0 0 0.421655169711112
Vwp_ho_25_0 wp_ho_25_0 0 0.33051388322994957
Vwn_ho_25_0 wn_ho_25_0 0 0.6694861167700504
Vwp_ho_26_0 wp_ho_26_0 0 0.6404887068741641
Vwn_ho_26_0 wn_ho_26_0 0 0.35951129312583585
Vwp_ho_27_0 wp_ho_27_0 0 0.6282016978037539
Vwn_ho_27_0 wn_ho_27_0 0 0.37179830219624604
Vwp_ho_28_0 wp_ho_28_0 0 0.3259585904042823
Vwn_ho_28_0 wn_ho_28_0 0 0.6740414095957177
Vwp_ho_29_0 wp_ho_29_0 0 0.4997090592563175
Vwn_ho_29_0 wn_ho_29_0 0 0.5002909407436825
Vwp_ho_30_0 wp_ho_30_0 0 0.5946116331879578
Vwn_ho_30_0 wn_ho_30_0 0 0.4053883668120422
Vwp_ho_31_0 wp_ho_31_0 0 0.4115017082481867
Vwn_ho_31_0 wn_ho_31_0 0 0.5884982917518133
Vwp_ho_0_1 wp_ho_0_1 0 0.3
Vwn_ho_0_1 wn_ho_0_1 0 0.7078440389492517
Vwp_ho_1_1 wp_ho_1_1 0 0.3
Vwn_ho_1_1 wn_ho_1_1 0 0.786762719705713
Vwp_ho_2_1 wp_ho_2_1 0 0.3
Vwn_ho_2_1 wn_ho_2_1 0 0.7140981078917112
Vwp_ho_3_1 wp_ho_3_1 0 0.3570747710588389
Vwn_ho_3_1 wn_ho_3_1 0 0.6429252289411611
Vwp_ho_4_1 wp_ho_4_1 0 0.500135914562535
Vwn_ho_4_1 wn_ho_4_1 0 0.49986408543746497
Vwp_ho_5_1 wp_ho_5_1 0 0.8943389369375006
Vwn_ho_5_1 wn_ho_5_1 0 0.3
Vwp_ho_6_1 wp_ho_6_1 0 0.3
Vwn_ho_6_1 wn_ho_6_1 0 0.7262237473971938
Vwp_ho_7_1 wp_ho_7_1 0 0.3
Vwn_ho_7_1 wn_ho_7_1 0 0.7464431920612027
Vwp_ho_8_1 wp_ho_8_1 0 0.32284585566602964
Vwn_ho_8_1 wn_ho_8_1 0 0.6771541443339704
Vwp_ho_9_1 wp_ho_9_1 0 0.3
Vwn_ho_9_1 wn_ho_9_1 0 0.8500895153159242
Vwp_ho_10_1 wp_ho_10_1 0 0.5726447046166787
Vwn_ho_10_1 wn_ho_10_1 0 0.42735529538332123
Vwp_ho_11_1 wp_ho_11_1 0 0.6769529760204893
Vwn_ho_11_1 wn_ho_11_1 0 0.32304702397951063
Vwp_ho_12_1 wp_ho_12_1 0 0.6039166516262353
Vwn_ho_12_1 wn_ho_12_1 0 0.39608334837376474
Vwp_ho_13_1 wp_ho_13_1 0 0.5918059855461466
Vwn_ho_13_1 wn_ho_13_1 0 0.4081940144538534
Vwp_ho_14_1 wp_ho_14_1 0 0.3
Vwn_ho_14_1 wn_ho_14_1 0 0.8323123077940957
Vwp_ho_15_1 wp_ho_15_1 0 0.31982382297879475
Vwn_ho_15_1 wn_ho_15_1 0 0.6801761770212053
Vwp_ho_16_1 wp_ho_16_1 0 0.3
Vwn_ho_16_1 wn_ho_16_1 0 0.81745811414995
Vwp_ho_17_1 wp_ho_17_1 0 0.3
Vwn_ho_17_1 wn_ho_17_1 0 0.806863487864395
Vwp_ho_18_1 wp_ho_18_1 0 0.5408935768447418
Vwn_ho_18_1 wn_ho_18_1 0 0.4591064231552581
Vwp_ho_19_1 wp_ho_19_1 0 0.6864186408555183
Vwn_ho_19_1 wn_ho_19_1 0 0.3135813591444817
Vwp_ho_20_1 wp_ho_20_1 0 0.3
Vwn_ho_20_1 wn_ho_20_1 0 0.8975260727312823
Vwp_ho_21_1 wp_ho_21_1 0 0.5963036767573955
Vwn_ho_21_1 wn_ho_21_1 0 0.4036963232426045
Vwp_ho_22_1 wp_ho_22_1 0 0.642282449829524
Vwn_ho_22_1 wn_ho_22_1 0 0.357717550170476
Vwp_ho_23_1 wp_ho_23_1 0 0.3201255846514531
Vwn_ho_23_1 wn_ho_23_1 0 0.679874415348547
Vwp_ho_24_1 wp_ho_24_1 0 0.7979112686065739
Vwn_ho_24_1 wn_ho_24_1 0 0.3
Vwp_ho_25_1 wp_ho_25_1 0 0.7316473487577785
Vwn_ho_25_1 wn_ho_25_1 0 0.3
Vwp_ho_26_1 wp_ho_26_1 0 0.3491560377134787
Vwn_ho_26_1 wn_ho_26_1 0 0.6508439622865213
Vwp_ho_27_1 wp_ho_27_1 0 0.3
Vwn_ho_27_1 wn_ho_27_1 0 0.7347086531019744
Vwp_ho_28_1 wp_ho_28_1 0 0.7772227088791124
Vwn_ho_28_1 wn_ho_28_1 0 0.3
Vwp_ho_29_1 wp_ho_29_1 0 0.4997489867779988
Vwn_ho_29_1 wn_ho_29_1 0 0.5002510132220012
Vwp_ho_30_1 wp_ho_30_1 0 0.3
Vwn_ho_30_1 wn_ho_30_1 0 0.7146262154756879
Vwp_ho_31_1 wp_ho_31_1 0 0.6574624316240605
Vwn_ho_31_1 wn_ho_31_1 0 0.3425375683759395
Vwp_ho_0_2 wp_ho_0_2 0 0.3
Vwn_ho_0_2 wn_ho_0_2 0 0.8131442630626463
Vwp_ho_1_2 wp_ho_1_2 0 0.7924562770027037
Vwn_ho_1_2 wn_ho_1_2 0 0.3
Vwp_ho_2_2 wp_ho_2_2 0 0.5273635025666796
Vwn_ho_2_2 wn_ho_2_2 0 0.47263649743332037
Vwp_ho_3_2 wp_ho_3_2 0 0.4712984459844971
Vwn_ho_3_2 wn_ho_3_2 0 0.5287015540155029
Vwp_ho_4_2 wp_ho_4_2 0 0.500896222291054
Vwn_ho_4_2 wn_ho_4_2 0 0.49910377770894593
Vwp_ho_5_2 wp_ho_5_2 0 0.37018495777291316
Vwn_ho_5_2 wn_ho_5_2 0 0.6298150422270868
Vwp_ho_6_2 wp_ho_6_2 0 0.6107650112891575
Vwn_ho_6_2 wn_ho_6_2 0 0.3892349887108425
Vwp_ho_7_2 wp_ho_7_2 0 0.6895380715795144
Vwn_ho_7_2 wn_ho_7_2 0 0.3104619284204856
Vwp_ho_8_2 wp_ho_8_2 0 0.5196726567000785
Vwn_ho_8_2 wn_ho_8_2 0 0.4803273432999215
Vwp_ho_9_2 wp_ho_9_2 0 0.6109024574783605
Vwn_ho_9_2 wn_ho_9_2 0 0.38909754252163953
Vwp_ho_10_2 wp_ho_10_2 0 0.3
Vwn_ho_10_2 wn_ho_10_2 0 0.8138000514829544
Vwp_ho_11_2 wp_ho_11_2 0 0.6064369415728208
Vwn_ho_11_2 wn_ho_11_2 0 0.3935630584271792
Vwp_ho_12_2 wp_ho_12_2 0 0.8405309541571699
Vwn_ho_12_2 wn_ho_12_2 0 0.3
Vwp_ho_13_2 wp_ho_13_2 0 0.6428874181257852
Vwn_ho_13_2 wn_ho_13_2 0 0.3571125818742148
Vwp_ho_14_2 wp_ho_14_2 0 0.3
Vwn_ho_14_2 wn_ho_14_2 0 0.7307866728435262
Vwp_ho_15_2 wp_ho_15_2 0 0.3
Vwn_ho_15_2 wn_ho_15_2 0 0.7388016114090894
Vwp_ho_16_2 wp_ho_16_2 0 0.3
Vwn_ho_16_2 wn_ho_16_2 0 0.7091787543773982
Vwp_ho_17_2 wp_ho_17_2 0 0.3
Vwn_ho_17_2 wn_ho_17_2 0 0.7057889200798249
Vwp_ho_18_2 wp_ho_18_2 0 0.7745722449669568
Vwn_ho_18_2 wn_ho_18_2 0 0.3
Vwp_ho_19_2 wp_ho_19_2 0 0.7960235306613942
Vwn_ho_19_2 wn_ho_19_2 0 0.3
Vwp_ho_20_2 wp_ho_20_2 0 0.7592570383479125
Vwn_ho_20_2 wn_ho_20_2 0 0.3
Vwp_ho_21_2 wp_ho_21_2 0 0.512223275193919
Vwn_ho_21_2 wn_ho_21_2 0 0.487776724806081
Vwp_ho_22_2 wp_ho_22_2 0 0.3
Vwn_ho_22_2 wn_ho_22_2 0 0.7528189307730437
Vwp_ho_23_2 wp_ho_23_2 0 0.5148131651880687
Vwn_ho_23_2 wn_ho_23_2 0 0.48518683481193126
Vwp_ho_24_2 wp_ho_24_2 0 0.6871572714492374
Vwn_ho_24_2 wn_ho_24_2 0 0.31284272855076256
Vwp_ho_25_2 wp_ho_25_2 0 0.45767706933903646
Vwn_ho_25_2 wn_ho_25_2 0 0.5423229306609636
Vwp_ho_26_2 wp_ho_26_2 0 0.416546708703999
Vwn_ho_26_2 wn_ho_26_2 0 0.583453291296001
Vwp_ho_27_2 wp_ho_27_2 0 0.3
Vwn_ho_27_2 wn_ho_27_2 0 0.7955011852068958
Vwp_ho_28_2 wp_ho_28_2 0 0.52848281593364
Vwn_ho_28_2 wn_ho_28_2 0 0.47151718406636
Vwp_ho_29_2 wp_ho_29_2 0 0.4991667809686281
Vwn_ho_29_2 wn_ho_29_2 0 0.5008332190313719
Vwp_ho_30_2 wp_ho_30_2 0 0.6125594593644459
Vwn_ho_30_2 wn_ho_30_2 0 0.38744054063555416
Vwp_ho_31_2 wp_ho_31_2 0 0.4766853983677257
Vwn_ho_31_2 wn_ho_31_2 0 0.5233146016322743
Vwp_ho_0_3 wp_ho_0_3 0 0.899
Vwn_ho_0_3 wn_ho_0_3 0 0.3
Vwp_ho_1_3 wp_ho_1_3 0 0.45312409020707034
Vwn_ho_1_3 wn_ho_1_3 0 0.5468759097929297
Vwp_ho_2_3 wp_ho_2_3 0 0.5475781819363656
Vwn_ho_2_3 wn_ho_2_3 0 0.45242181806363435
Vwp_ho_3_3 wp_ho_3_3 0 0.5492411429298084
Vwn_ho_3_3 wn_ho_3_3 0 0.4507588570701916
Vwp_ho_4_3 wp_ho_4_3 0 0.5002215963892541
Vwn_ho_4_3 wn_ho_4_3 0 0.4997784036107459
Vwp_ho_5_3 wp_ho_5_3 0 0.32771198461512796
Vwn_ho_5_3 wn_ho_5_3 0 0.672288015384872
Vwp_ho_6_3 wp_ho_6_3 0 0.48072008553291273
Vwn_ho_6_3 wn_ho_6_3 0 0.5192799144670872
Vwp_ho_7_3 wp_ho_7_3 0 0.5387613812010027
Vwn_ho_7_3 wn_ho_7_3 0 0.4612386187989973
Vwp_ho_8_3 wp_ho_8_3 0 0.5482403909848433
Vwn_ho_8_3 wn_ho_8_3 0 0.45175960901515666
Vwp_ho_9_3 wp_ho_9_3 0 0.6482421696441765
Vwn_ho_9_3 wn_ho_9_3 0 0.35175783035582353
Vwp_ho_10_3 wp_ho_10_3 0 0.6304904883202647
Vwn_ho_10_3 wn_ho_10_3 0 0.36950951167973534
Vwp_ho_11_3 wp_ho_11_3 0 0.34503255301932145
Vwn_ho_11_3 wn_ho_11_3 0 0.6549674469806785
Vwp_ho_12_3 wp_ho_12_3 0 0.3
Vwn_ho_12_3 wn_ho_12_3 0 0.833728358966052
Vwp_ho_13_3 wp_ho_13_3 0 0.33563495593531867
Vwn_ho_13_3 wn_ho_13_3 0 0.6643650440646813
Vwp_ho_14_3 wp_ho_14_3 0 0.8986020248405455
Vwn_ho_14_3 wn_ho_14_3 0 0.3
Vwp_ho_15_3 wp_ho_15_3 0 0.899
Vwn_ho_15_3 wn_ho_15_3 0 0.3
Vwp_ho_16_3 wp_ho_16_3 0 0.886614029726545
Vwn_ho_16_3 wn_ho_16_3 0 0.3
Vwp_ho_17_3 wp_ho_17_3 0 0.8513286707095271
Vwn_ho_17_3 wn_ho_17_3 0 0.3
Vwp_ho_18_3 wp_ho_18_3 0 0.3
Vwn_ho_18_3 wn_ho_18_3 0 0.8088203864783767
Vwp_ho_19_3 wp_ho_19_3 0 0.3
Vwn_ho_19_3 wn_ho_19_3 0 0.7862657762231321
Vwp_ho_20_3 wp_ho_20_3 0 0.5309241808073479
Vwn_ho_20_3 wn_ho_20_3 0 0.46907581919265207
Vwp_ho_21_3 wp_ho_21_3 0 0.475504156366389
Vwn_ho_21_3 wn_ho_21_3 0 0.524495843633611
Vwp_ho_22_3 wp_ho_22_3 0 0.5533827874258889
Vwn_ho_22_3 wn_ho_22_3 0 0.44661721257411113
Vwp_ho_23_3 wp_ho_23_3 0 0.5520141991593449
Vwn_ho_23_3 wn_ho_23_3 0 0.4479858008406551
Vwp_ho_24_3 wp_ho_24_3 0 0.3
Vwn_ho_24_3 wn_ho_24_3 0 0.8828417721153953
Vwp_ho_25_3 wp_ho_25_3 0 0.4768918658568773
Vwn_ho_25_3 wn_ho_25_3 0 0.5231081341431226
Vwp_ho_26_3 wp_ho_26_3 0 0.6097406757202939
Vwn_ho_26_3 wn_ho_26_3 0 0.39025932427970605
Vwp_ho_27_3 wp_ho_27_3 0 0.899
Vwn_ho_27_3 wn_ho_27_3 0 0.3
Vwp_ho_28_3 wp_ho_28_3 0 0.37252549190973183
Vwn_ho_28_3 wn_ho_28_3 0 0.6274745080902682
Vwp_ho_29_3 wp_ho_29_3 0 0.49968487487620694
Vwn_ho_29_3 wn_ho_29_3 0 0.5003151251237931
Vwp_ho_30_3 wp_ho_30_3 0 0.48979535430083687
Vwn_ho_30_3 wn_ho_30_3 0 0.5102046456991631
Vwp_ho_31_3 wp_ho_31_3 0 0.45931397165874344
Vwn_ho_31_3 wn_ho_31_3 0 0.5406860283412566
Xcm_xh0 xhp0 xhn0 vdd cmld
Rnd_xh0 xhp0 xhn0 20k
Cxh0p xhp0 0 1e-13
Cxh0n xhn0 0 1e-13
Xihx_0_0 a_xp0 a_xn0 wp_ih_0_0 wn_ih_0_0 xhp0 xhn0 vdd vbsyn gsyn
Xihx_1_0 a_xp1 a_xn1 wp_ih_1_0 wn_ih_1_0 xhp0 xhn0 vdd vbsyn gsyn
Xihx_2_0 a_xp2 a_xn2 wp_ih_2_0 wn_ih_2_0 xhp0 xhn0 vdd vbsyn gsyn
Xn0 xhp0 xhn0 ahp0 ahn0 vdd vbneu dneuron
Xcm_xh1 xhp1 xhn1 vdd cmld
Rnd_xh1 xhp1 xhn1 20k
Cxh1p xhp1 0 1e-13
Cxh1n xhn1 0 1e-13
Xihx_0_1 a_xp0 a_xn0 wp_ih_0_1 wn_ih_0_1 xhp1 xhn1 vdd vbsyn gsyn
Xihx_1_1 a_xp1 a_xn1 wp_ih_1_1 wn_ih_1_1 xhp1 xhn1 vdd vbsyn gsyn
Xihx_2_1 a_xp2 a_xn2 wp_ih_2_1 wn_ih_2_1 xhp1 xhn1 vdd vbsyn gsyn
Xn1 xhp1 xhn1 ahp1 ahn1 vdd vbneu dneuron
Xcm_xh2 xhp2 xhn2 vdd cmld
Rnd_xh2 xhp2 xhn2 20k
Cxh2p xhp2 0 1e-13
Cxh2n xhn2 0 1e-13
Xihx_0_2 a_xp0 a_xn0 wp_ih_0_2 wn_ih_0_2 xhp2 xhn2 vdd vbsyn gsyn
Xihx_1_2 a_xp1 a_xn1 wp_ih_1_2 wn_ih_1_2 xhp2 xhn2 vdd vbsyn gsyn
Xihx_2_2 a_xp2 a_xn2 wp_ih_2_2 wn_ih_2_2 xhp2 xhn2 vdd vbsyn gsyn
Xn2 xhp2 xhn2 ahp2 ahn2 vdd vbneu dneuron
Xcm_xh3 xhp3 xhn3 vdd cmld
Rnd_xh3 xhp3 xhn3 20k
Cxh3p xhp3 0 1e-13
Cxh3n xhn3 0 1e-13
Xihx_0_3 a_xp0 a_xn0 wp_ih_0_3 wn_ih_0_3 xhp3 xhn3 vdd vbsyn gsyn
Xihx_1_3 a_xp1 a_xn1 wp_ih_1_3 wn_ih_1_3 xhp3 xhn3 vdd vbsyn gsyn
Xihx_2_3 a_xp2 a_xn2 wp_ih_2_3 wn_ih_2_3 xhp3 xhn3 vdd vbsyn gsyn
Xn3 xhp3 xhn3 ahp3 ahn3 vdd vbneu dneuron
Xcm_xh4 xhp4 xhn4 vdd cmld
Rnd_xh4 xhp4 xhn4 20k
Cxh4p xhp4 0 1e-13
Cxh4n xhn4 0 1e-13
Xihx_0_4 a_xp0 a_xn0 wp_ih_0_4 wn_ih_0_4 xhp4 xhn4 vdd vbsyn gsyn
Xihx_1_4 a_xp1 a_xn1 wp_ih_1_4 wn_ih_1_4 xhp4 xhn4 vdd vbsyn gsyn
Xihx_2_4 a_xp2 a_xn2 wp_ih_2_4 wn_ih_2_4 xhp4 xhn4 vdd vbsyn gsyn
Xn4 xhp4 xhn4 ahp4 ahn4 vdd vbneu dneuron
Xcm_xh5 xhp5 xhn5 vdd cmld
Rnd_xh5 xhp5 xhn5 20k
Cxh5p xhp5 0 1e-13
Cxh5n xhn5 0 1e-13
Xihx_0_5 a_xp0 a_xn0 wp_ih_0_5 wn_ih_0_5 xhp5 xhn5 vdd vbsyn gsyn
Xihx_1_5 a_xp1 a_xn1 wp_ih_1_5 wn_ih_1_5 xhp5 xhn5 vdd vbsyn gsyn
Xihx_2_5 a_xp2 a_xn2 wp_ih_2_5 wn_ih_2_5 xhp5 xhn5 vdd vbsyn gsyn
Xn5 xhp5 xhn5 ahp5 ahn5 vdd vbneu dneuron
Xcm_xh6 xhp6 xhn6 vdd cmld
Rnd_xh6 xhp6 xhn6 20k
Cxh6p xhp6 0 1e-13
Cxh6n xhn6 0 1e-13
Xihx_0_6 a_xp0 a_xn0 wp_ih_0_6 wn_ih_0_6 xhp6 xhn6 vdd vbsyn gsyn
Xihx_1_6 a_xp1 a_xn1 wp_ih_1_6 wn_ih_1_6 xhp6 xhn6 vdd vbsyn gsyn
Xihx_2_6 a_xp2 a_xn2 wp_ih_2_6 wn_ih_2_6 xhp6 xhn6 vdd vbsyn gsyn
Xn6 xhp6 xhn6 ahp6 ahn6 vdd vbneu dneuron
Xcm_xh7 xhp7 xhn7 vdd cmld
Rnd_xh7 xhp7 xhn7 20k
Cxh7p xhp7 0 1e-13
Cxh7n xhn7 0 1e-13
Xihx_0_7 a_xp0 a_xn0 wp_ih_0_7 wn_ih_0_7 xhp7 xhn7 vdd vbsyn gsyn
Xihx_1_7 a_xp1 a_xn1 wp_ih_1_7 wn_ih_1_7 xhp7 xhn7 vdd vbsyn gsyn
Xihx_2_7 a_xp2 a_xn2 wp_ih_2_7 wn_ih_2_7 xhp7 xhn7 vdd vbsyn gsyn
Xn7 xhp7 xhn7 ahp7 ahn7 vdd vbneu dneuron
Xcm_xh8 xhp8 xhn8 vdd cmld
Rnd_xh8 xhp8 xhn8 20k
Cxh8p xhp8 0 1e-13
Cxh8n xhn8 0 1e-13
Xihx_0_8 a_xp0 a_xn0 wp_ih_0_8 wn_ih_0_8 xhp8 xhn8 vdd vbsyn gsyn
Xihx_1_8 a_xp1 a_xn1 wp_ih_1_8 wn_ih_1_8 xhp8 xhn8 vdd vbsyn gsyn
Xihx_2_8 a_xp2 a_xn2 wp_ih_2_8 wn_ih_2_8 xhp8 xhn8 vdd vbsyn gsyn
Xn8 xhp8 xhn8 ahp8 ahn8 vdd vbneu dneuron
Xcm_xh9 xhp9 xhn9 vdd cmld
Rnd_xh9 xhp9 xhn9 20k
Cxh9p xhp9 0 1e-13
Cxh9n xhn9 0 1e-13
Xihx_0_9 a_xp0 a_xn0 wp_ih_0_9 wn_ih_0_9 xhp9 xhn9 vdd vbsyn gsyn
Xihx_1_9 a_xp1 a_xn1 wp_ih_1_9 wn_ih_1_9 xhp9 xhn9 vdd vbsyn gsyn
Xihx_2_9 a_xp2 a_xn2 wp_ih_2_9 wn_ih_2_9 xhp9 xhn9 vdd vbsyn gsyn
Xn9 xhp9 xhn9 ahp9 ahn9 vdd vbneu dneuron
Xcm_xh10 xhp10 xhn10 vdd cmld
Rnd_xh10 xhp10 xhn10 20k
Cxh10p xhp10 0 1e-13
Cxh10n xhn10 0 1e-13
Xihx_0_10 a_xp0 a_xn0 wp_ih_0_10 wn_ih_0_10 xhp10 xhn10 vdd vbsyn gsyn
Xihx_1_10 a_xp1 a_xn1 wp_ih_1_10 wn_ih_1_10 xhp10 xhn10 vdd vbsyn gsyn
Xihx_2_10 a_xp2 a_xn2 wp_ih_2_10 wn_ih_2_10 xhp10 xhn10 vdd vbsyn gsyn
Xn10 xhp10 xhn10 ahp10 ahn10 vdd vbneu dneuron
Xcm_xh11 xhp11 xhn11 vdd cmld
Rnd_xh11 xhp11 xhn11 20k
Cxh11p xhp11 0 1e-13
Cxh11n xhn11 0 1e-13
Xihx_0_11 a_xp0 a_xn0 wp_ih_0_11 wn_ih_0_11 xhp11 xhn11 vdd vbsyn gsyn
Xihx_1_11 a_xp1 a_xn1 wp_ih_1_11 wn_ih_1_11 xhp11 xhn11 vdd vbsyn gsyn
Xihx_2_11 a_xp2 a_xn2 wp_ih_2_11 wn_ih_2_11 xhp11 xhn11 vdd vbsyn gsyn
Xn11 xhp11 xhn11 ahp11 ahn11 vdd vbneu dneuron
Xcm_xh12 xhp12 xhn12 vdd cmld
Rnd_xh12 xhp12 xhn12 20k
Cxh12p xhp12 0 1e-13
Cxh12n xhn12 0 1e-13
Xihx_0_12 a_xp0 a_xn0 wp_ih_0_12 wn_ih_0_12 xhp12 xhn12 vdd vbsyn gsyn
Xihx_1_12 a_xp1 a_xn1 wp_ih_1_12 wn_ih_1_12 xhp12 xhn12 vdd vbsyn gsyn
Xihx_2_12 a_xp2 a_xn2 wp_ih_2_12 wn_ih_2_12 xhp12 xhn12 vdd vbsyn gsyn
Xn12 xhp12 xhn12 ahp12 ahn12 vdd vbneu dneuron
Xcm_xh13 xhp13 xhn13 vdd cmld
Rnd_xh13 xhp13 xhn13 20k
Cxh13p xhp13 0 1e-13
Cxh13n xhn13 0 1e-13
Xihx_0_13 a_xp0 a_xn0 wp_ih_0_13 wn_ih_0_13 xhp13 xhn13 vdd vbsyn gsyn
Xihx_1_13 a_xp1 a_xn1 wp_ih_1_13 wn_ih_1_13 xhp13 xhn13 vdd vbsyn gsyn
Xihx_2_13 a_xp2 a_xn2 wp_ih_2_13 wn_ih_2_13 xhp13 xhn13 vdd vbsyn gsyn
Xn13 xhp13 xhn13 ahp13 ahn13 vdd vbneu dneuron
Xcm_xh14 xhp14 xhn14 vdd cmld
Rnd_xh14 xhp14 xhn14 20k
Cxh14p xhp14 0 1e-13
Cxh14n xhn14 0 1e-13
Xihx_0_14 a_xp0 a_xn0 wp_ih_0_14 wn_ih_0_14 xhp14 xhn14 vdd vbsyn gsyn
Xihx_1_14 a_xp1 a_xn1 wp_ih_1_14 wn_ih_1_14 xhp14 xhn14 vdd vbsyn gsyn
Xihx_2_14 a_xp2 a_xn2 wp_ih_2_14 wn_ih_2_14 xhp14 xhn14 vdd vbsyn gsyn
Xn14 xhp14 xhn14 ahp14 ahn14 vdd vbneu dneuron
Xcm_xh15 xhp15 xhn15 vdd cmld
Rnd_xh15 xhp15 xhn15 20k
Cxh15p xhp15 0 1e-13
Cxh15n xhn15 0 1e-13
Xihx_0_15 a_xp0 a_xn0 wp_ih_0_15 wn_ih_0_15 xhp15 xhn15 vdd vbsyn gsyn
Xihx_1_15 a_xp1 a_xn1 wp_ih_1_15 wn_ih_1_15 xhp15 xhn15 vdd vbsyn gsyn
Xihx_2_15 a_xp2 a_xn2 wp_ih_2_15 wn_ih_2_15 xhp15 xhn15 vdd vbsyn gsyn
Xn15 xhp15 xhn15 ahp15 ahn15 vdd vbneu dneuron
Xcm_xh16 xhp16 xhn16 vdd cmld
Rnd_xh16 xhp16 xhn16 20k
Cxh16p xhp16 0 1e-13
Cxh16n xhn16 0 1e-13
Xihx_0_16 a_xp0 a_xn0 wp_ih_0_16 wn_ih_0_16 xhp16 xhn16 vdd vbsyn gsyn
Xihx_1_16 a_xp1 a_xn1 wp_ih_1_16 wn_ih_1_16 xhp16 xhn16 vdd vbsyn gsyn
Xihx_2_16 a_xp2 a_xn2 wp_ih_2_16 wn_ih_2_16 xhp16 xhn16 vdd vbsyn gsyn
Xn16 xhp16 xhn16 ahp16 ahn16 vdd vbneu dneuron
Xcm_xh17 xhp17 xhn17 vdd cmld
Rnd_xh17 xhp17 xhn17 20k
Cxh17p xhp17 0 1e-13
Cxh17n xhn17 0 1e-13
Xihx_0_17 a_xp0 a_xn0 wp_ih_0_17 wn_ih_0_17 xhp17 xhn17 vdd vbsyn gsyn
Xihx_1_17 a_xp1 a_xn1 wp_ih_1_17 wn_ih_1_17 xhp17 xhn17 vdd vbsyn gsyn
Xihx_2_17 a_xp2 a_xn2 wp_ih_2_17 wn_ih_2_17 xhp17 xhn17 vdd vbsyn gsyn
Xn17 xhp17 xhn17 ahp17 ahn17 vdd vbneu dneuron
Xcm_xh18 xhp18 xhn18 vdd cmld
Rnd_xh18 xhp18 xhn18 20k
Cxh18p xhp18 0 1e-13
Cxh18n xhn18 0 1e-13
Xihx_0_18 a_xp0 a_xn0 wp_ih_0_18 wn_ih_0_18 xhp18 xhn18 vdd vbsyn gsyn
Xihx_1_18 a_xp1 a_xn1 wp_ih_1_18 wn_ih_1_18 xhp18 xhn18 vdd vbsyn gsyn
Xihx_2_18 a_xp2 a_xn2 wp_ih_2_18 wn_ih_2_18 xhp18 xhn18 vdd vbsyn gsyn
Xn18 xhp18 xhn18 ahp18 ahn18 vdd vbneu dneuron
Xcm_xh19 xhp19 xhn19 vdd cmld
Rnd_xh19 xhp19 xhn19 20k
Cxh19p xhp19 0 1e-13
Cxh19n xhn19 0 1e-13
Xihx_0_19 a_xp0 a_xn0 wp_ih_0_19 wn_ih_0_19 xhp19 xhn19 vdd vbsyn gsyn
Xihx_1_19 a_xp1 a_xn1 wp_ih_1_19 wn_ih_1_19 xhp19 xhn19 vdd vbsyn gsyn
Xihx_2_19 a_xp2 a_xn2 wp_ih_2_19 wn_ih_2_19 xhp19 xhn19 vdd vbsyn gsyn
Xn19 xhp19 xhn19 ahp19 ahn19 vdd vbneu dneuron
Xcm_xh20 xhp20 xhn20 vdd cmld
Rnd_xh20 xhp20 xhn20 20k
Cxh20p xhp20 0 1e-13
Cxh20n xhn20 0 1e-13
Xihx_0_20 a_xp0 a_xn0 wp_ih_0_20 wn_ih_0_20 xhp20 xhn20 vdd vbsyn gsyn
Xihx_1_20 a_xp1 a_xn1 wp_ih_1_20 wn_ih_1_20 xhp20 xhn20 vdd vbsyn gsyn
Xihx_2_20 a_xp2 a_xn2 wp_ih_2_20 wn_ih_2_20 xhp20 xhn20 vdd vbsyn gsyn
Xn20 xhp20 xhn20 ahp20 ahn20 vdd vbneu dneuron
Xcm_xh21 xhp21 xhn21 vdd cmld
Rnd_xh21 xhp21 xhn21 20k
Cxh21p xhp21 0 1e-13
Cxh21n xhn21 0 1e-13
Xihx_0_21 a_xp0 a_xn0 wp_ih_0_21 wn_ih_0_21 xhp21 xhn21 vdd vbsyn gsyn
Xihx_1_21 a_xp1 a_xn1 wp_ih_1_21 wn_ih_1_21 xhp21 xhn21 vdd vbsyn gsyn
Xihx_2_21 a_xp2 a_xn2 wp_ih_2_21 wn_ih_2_21 xhp21 xhn21 vdd vbsyn gsyn
Xn21 xhp21 xhn21 ahp21 ahn21 vdd vbneu dneuron
Xcm_xh22 xhp22 xhn22 vdd cmld
Rnd_xh22 xhp22 xhn22 20k
Cxh22p xhp22 0 1e-13
Cxh22n xhn22 0 1e-13
Xihx_0_22 a_xp0 a_xn0 wp_ih_0_22 wn_ih_0_22 xhp22 xhn22 vdd vbsyn gsyn
Xihx_1_22 a_xp1 a_xn1 wp_ih_1_22 wn_ih_1_22 xhp22 xhn22 vdd vbsyn gsyn
Xihx_2_22 a_xp2 a_xn2 wp_ih_2_22 wn_ih_2_22 xhp22 xhn22 vdd vbsyn gsyn
Xn22 xhp22 xhn22 ahp22 ahn22 vdd vbneu dneuron
Xcm_xh23 xhp23 xhn23 vdd cmld
Rnd_xh23 xhp23 xhn23 20k
Cxh23p xhp23 0 1e-13
Cxh23n xhn23 0 1e-13
Xihx_0_23 a_xp0 a_xn0 wp_ih_0_23 wn_ih_0_23 xhp23 xhn23 vdd vbsyn gsyn
Xihx_1_23 a_xp1 a_xn1 wp_ih_1_23 wn_ih_1_23 xhp23 xhn23 vdd vbsyn gsyn
Xihx_2_23 a_xp2 a_xn2 wp_ih_2_23 wn_ih_2_23 xhp23 xhn23 vdd vbsyn gsyn
Xn23 xhp23 xhn23 ahp23 ahn23 vdd vbneu dneuron
Xcm_xh24 xhp24 xhn24 vdd cmld
Rnd_xh24 xhp24 xhn24 20k
Cxh24p xhp24 0 1e-13
Cxh24n xhn24 0 1e-13
Xihx_0_24 a_xp0 a_xn0 wp_ih_0_24 wn_ih_0_24 xhp24 xhn24 vdd vbsyn gsyn
Xihx_1_24 a_xp1 a_xn1 wp_ih_1_24 wn_ih_1_24 xhp24 xhn24 vdd vbsyn gsyn
Xihx_2_24 a_xp2 a_xn2 wp_ih_2_24 wn_ih_2_24 xhp24 xhn24 vdd vbsyn gsyn
Xn24 xhp24 xhn24 ahp24 ahn24 vdd vbneu dneuron
Xcm_xh25 xhp25 xhn25 vdd cmld
Rnd_xh25 xhp25 xhn25 20k
Cxh25p xhp25 0 1e-13
Cxh25n xhn25 0 1e-13
Xihx_0_25 a_xp0 a_xn0 wp_ih_0_25 wn_ih_0_25 xhp25 xhn25 vdd vbsyn gsyn
Xihx_1_25 a_xp1 a_xn1 wp_ih_1_25 wn_ih_1_25 xhp25 xhn25 vdd vbsyn gsyn
Xihx_2_25 a_xp2 a_xn2 wp_ih_2_25 wn_ih_2_25 xhp25 xhn25 vdd vbsyn gsyn
Xn25 xhp25 xhn25 ahp25 ahn25 vdd vbneu dneuron
Xcm_xh26 xhp26 xhn26 vdd cmld
Rnd_xh26 xhp26 xhn26 20k
Cxh26p xhp26 0 1e-13
Cxh26n xhn26 0 1e-13
Xihx_0_26 a_xp0 a_xn0 wp_ih_0_26 wn_ih_0_26 xhp26 xhn26 vdd vbsyn gsyn
Xihx_1_26 a_xp1 a_xn1 wp_ih_1_26 wn_ih_1_26 xhp26 xhn26 vdd vbsyn gsyn
Xihx_2_26 a_xp2 a_xn2 wp_ih_2_26 wn_ih_2_26 xhp26 xhn26 vdd vbsyn gsyn
Xn26 xhp26 xhn26 ahp26 ahn26 vdd vbneu dneuron
Xcm_xh27 xhp27 xhn27 vdd cmld
Rnd_xh27 xhp27 xhn27 20k
Cxh27p xhp27 0 1e-13
Cxh27n xhn27 0 1e-13
Xihx_0_27 a_xp0 a_xn0 wp_ih_0_27 wn_ih_0_27 xhp27 xhn27 vdd vbsyn gsyn
Xihx_1_27 a_xp1 a_xn1 wp_ih_1_27 wn_ih_1_27 xhp27 xhn27 vdd vbsyn gsyn
Xihx_2_27 a_xp2 a_xn2 wp_ih_2_27 wn_ih_2_27 xhp27 xhn27 vdd vbsyn gsyn
Xn27 xhp27 xhn27 ahp27 ahn27 vdd vbneu dneuron
Xcm_xh28 xhp28 xhn28 vdd cmld
Rnd_xh28 xhp28 xhn28 20k
Cxh28p xhp28 0 1e-13
Cxh28n xhn28 0 1e-13
Xihx_0_28 a_xp0 a_xn0 wp_ih_0_28 wn_ih_0_28 xhp28 xhn28 vdd vbsyn gsyn
Xihx_1_28 a_xp1 a_xn1 wp_ih_1_28 wn_ih_1_28 xhp28 xhn28 vdd vbsyn gsyn
Xihx_2_28 a_xp2 a_xn2 wp_ih_2_28 wn_ih_2_28 xhp28 xhn28 vdd vbsyn gsyn
Xn28 xhp28 xhn28 ahp28 ahn28 vdd vbneu dneuron
Xcm_xh29 xhp29 xhn29 vdd cmld
Rnd_xh29 xhp29 xhn29 20k
Cxh29p xhp29 0 1e-13
Cxh29n xhn29 0 1e-13
Xihx_0_29 a_xp0 a_xn0 wp_ih_0_29 wn_ih_0_29 xhp29 xhn29 vdd vbsyn gsyn
Xihx_1_29 a_xp1 a_xn1 wp_ih_1_29 wn_ih_1_29 xhp29 xhn29 vdd vbsyn gsyn
Xihx_2_29 a_xp2 a_xn2 wp_ih_2_29 wn_ih_2_29 xhp29 xhn29 vdd vbsyn gsyn
Xn29 xhp29 xhn29 ahp29 ahn29 vdd vbneu dneuron
Xcm_xh30 xhp30 xhn30 vdd cmld
Rnd_xh30 xhp30 xhn30 20k
Cxh30p xhp30 0 1e-13
Cxh30n xhn30 0 1e-13
Xihx_0_30 a_xp0 a_xn0 wp_ih_0_30 wn_ih_0_30 xhp30 xhn30 vdd vbsyn gsyn
Xihx_1_30 a_xp1 a_xn1 wp_ih_1_30 wn_ih_1_30 xhp30 xhn30 vdd vbsyn gsyn
Xihx_2_30 a_xp2 a_xn2 wp_ih_2_30 wn_ih_2_30 xhp30 xhn30 vdd vbsyn gsyn
Xn30 xhp30 xhn30 ahp30 ahn30 vdd vbneu dneuron
Xcm_xh31 xhp31 xhn31 vdd cmld
Rnd_xh31 xhp31 xhn31 20k
Cxh31p xhp31 0 1e-13
Cxh31n xhn31 0 1e-13
Xihx_0_31 a_xp0 a_xn0 wp_ih_0_31 wn_ih_0_31 xhp31 xhn31 vdd vbsyn gsyn
Xihx_1_31 a_xp1 a_xn1 wp_ih_1_31 wn_ih_1_31 xhp31 xhn31 vdd vbsyn gsyn
Xihx_2_31 a_xp2 a_xn2 wp_ih_2_31 wn_ih_2_31 xhp31 xhn31 vdd vbsyn gsyn
Xn31 xhp31 xhn31 ahp31 ahn31 vdd vbneu dneuron
Xcm_mo0 mop0 mon0 vdd cmld
Rnd_mo0 mop0 mon0 20k
Cmo0p mop0 0 1e-13
Cmo0n mon0 0 1e-13
Xho_0_0 ahp0 ahn0 wp_ho_0_0 wn_ho_0_0 mop0 mon0 vdd vbsyn gsyn
Xho_1_0 ahp1 ahn1 wp_ho_1_0 wn_ho_1_0 mop0 mon0 vdd vbsyn gsyn
Xho_2_0 ahp2 ahn2 wp_ho_2_0 wn_ho_2_0 mop0 mon0 vdd vbsyn gsyn
Xho_3_0 ahp3 ahn3 wp_ho_3_0 wn_ho_3_0 mop0 mon0 vdd vbsyn gsyn
Xho_4_0 ahp4 ahn4 wp_ho_4_0 wn_ho_4_0 mop0 mon0 vdd vbsyn gsyn
Xho_5_0 ahp5 ahn5 wp_ho_5_0 wn_ho_5_0 mop0 mon0 vdd vbsyn gsyn
Xho_6_0 ahp6 ahn6 wp_ho_6_0 wn_ho_6_0 mop0 mon0 vdd vbsyn gsyn
Xho_7_0 ahp7 ahn7 wp_ho_7_0 wn_ho_7_0 mop0 mon0 vdd vbsyn gsyn
Xho_8_0 ahp8 ahn8 wp_ho_8_0 wn_ho_8_0 mop0 mon0 vdd vbsyn gsyn
Xho_9_0 ahp9 ahn9 wp_ho_9_0 wn_ho_9_0 mop0 mon0 vdd vbsyn gsyn
Xho_10_0 ahp10 ahn10 wp_ho_10_0 wn_ho_10_0 mop0 mon0 vdd vbsyn gsyn
Xho_11_0 ahp11 ahn11 wp_ho_11_0 wn_ho_11_0 mop0 mon0 vdd vbsyn gsyn
Xho_12_0 ahp12 ahn12 wp_ho_12_0 wn_ho_12_0 mop0 mon0 vdd vbsyn gsyn
Xho_13_0 ahp13 ahn13 wp_ho_13_0 wn_ho_13_0 mop0 mon0 vdd vbsyn gsyn
Xho_14_0 ahp14 ahn14 wp_ho_14_0 wn_ho_14_0 mop0 mon0 vdd vbsyn gsyn
Xho_15_0 ahp15 ahn15 wp_ho_15_0 wn_ho_15_0 mop0 mon0 vdd vbsyn gsyn
Xho_16_0 ahp16 ahn16 wp_ho_16_0 wn_ho_16_0 mop0 mon0 vdd vbsyn gsyn
Xho_17_0 ahp17 ahn17 wp_ho_17_0 wn_ho_17_0 mop0 mon0 vdd vbsyn gsyn
Xho_18_0 ahp18 ahn18 wp_ho_18_0 wn_ho_18_0 mop0 mon0 vdd vbsyn gsyn
Xho_19_0 ahp19 ahn19 wp_ho_19_0 wn_ho_19_0 mop0 mon0 vdd vbsyn gsyn
Xho_20_0 ahp20 ahn20 wp_ho_20_0 wn_ho_20_0 mop0 mon0 vdd vbsyn gsyn
Xho_21_0 ahp21 ahn21 wp_ho_21_0 wn_ho_21_0 mop0 mon0 vdd vbsyn gsyn
Xho_22_0 ahp22 ahn22 wp_ho_22_0 wn_ho_22_0 mop0 mon0 vdd vbsyn gsyn
Xho_23_0 ahp23 ahn23 wp_ho_23_0 wn_ho_23_0 mop0 mon0 vdd vbsyn gsyn
Xho_24_0 ahp24 ahn24 wp_ho_24_0 wn_ho_24_0 mop0 mon0 vdd vbsyn gsyn
Xho_25_0 ahp25 ahn25 wp_ho_25_0 wn_ho_25_0 mop0 mon0 vdd vbsyn gsyn
Xho_26_0 ahp26 ahn26 wp_ho_26_0 wn_ho_26_0 mop0 mon0 vdd vbsyn gsyn
Xho_27_0 ahp27 ahn27 wp_ho_27_0 wn_ho_27_0 mop0 mon0 vdd vbsyn gsyn
Xho_28_0 ahp28 ahn28 wp_ho_28_0 wn_ho_28_0 mop0 mon0 vdd vbsyn gsyn
Xho_29_0 ahp29 ahn29 wp_ho_29_0 wn_ho_29_0 mop0 mon0 vdd vbsyn gsyn
Xho_30_0 ahp30 ahn30 wp_ho_30_0 wn_ho_30_0 mop0 mon0 vdd vbsyn gsyn
Xho_31_0 ahp31 ahn31 wp_ho_31_0 wn_ho_31_0 mop0 mon0 vdd vbsyn gsyn
Xcm_mo1 mop1 mon1 vdd cmld
Rnd_mo1 mop1 mon1 20k
Cmo1p mop1 0 1e-13
Cmo1n mon1 0 1e-13
Xho_0_1 ahp0 ahn0 wp_ho_0_1 wn_ho_0_1 mop1 mon1 vdd vbsyn gsyn
Xho_1_1 ahp1 ahn1 wp_ho_1_1 wn_ho_1_1 mop1 mon1 vdd vbsyn gsyn
Xho_2_1 ahp2 ahn2 wp_ho_2_1 wn_ho_2_1 mop1 mon1 vdd vbsyn gsyn
Xho_3_1 ahp3 ahn3 wp_ho_3_1 wn_ho_3_1 mop1 mon1 vdd vbsyn gsyn
Xho_4_1 ahp4 ahn4 wp_ho_4_1 wn_ho_4_1 mop1 mon1 vdd vbsyn gsyn
Xho_5_1 ahp5 ahn5 wp_ho_5_1 wn_ho_5_1 mop1 mon1 vdd vbsyn gsyn
Xho_6_1 ahp6 ahn6 wp_ho_6_1 wn_ho_6_1 mop1 mon1 vdd vbsyn gsyn
Xho_7_1 ahp7 ahn7 wp_ho_7_1 wn_ho_7_1 mop1 mon1 vdd vbsyn gsyn
Xho_8_1 ahp8 ahn8 wp_ho_8_1 wn_ho_8_1 mop1 mon1 vdd vbsyn gsyn
Xho_9_1 ahp9 ahn9 wp_ho_9_1 wn_ho_9_1 mop1 mon1 vdd vbsyn gsyn
Xho_10_1 ahp10 ahn10 wp_ho_10_1 wn_ho_10_1 mop1 mon1 vdd vbsyn gsyn
Xho_11_1 ahp11 ahn11 wp_ho_11_1 wn_ho_11_1 mop1 mon1 vdd vbsyn gsyn
Xho_12_1 ahp12 ahn12 wp_ho_12_1 wn_ho_12_1 mop1 mon1 vdd vbsyn gsyn
Xho_13_1 ahp13 ahn13 wp_ho_13_1 wn_ho_13_1 mop1 mon1 vdd vbsyn gsyn
Xho_14_1 ahp14 ahn14 wp_ho_14_1 wn_ho_14_1 mop1 mon1 vdd vbsyn gsyn
Xho_15_1 ahp15 ahn15 wp_ho_15_1 wn_ho_15_1 mop1 mon1 vdd vbsyn gsyn
Xho_16_1 ahp16 ahn16 wp_ho_16_1 wn_ho_16_1 mop1 mon1 vdd vbsyn gsyn
Xho_17_1 ahp17 ahn17 wp_ho_17_1 wn_ho_17_1 mop1 mon1 vdd vbsyn gsyn
Xho_18_1 ahp18 ahn18 wp_ho_18_1 wn_ho_18_1 mop1 mon1 vdd vbsyn gsyn
Xho_19_1 ahp19 ahn19 wp_ho_19_1 wn_ho_19_1 mop1 mon1 vdd vbsyn gsyn
Xho_20_1 ahp20 ahn20 wp_ho_20_1 wn_ho_20_1 mop1 mon1 vdd vbsyn gsyn
Xho_21_1 ahp21 ahn21 wp_ho_21_1 wn_ho_21_1 mop1 mon1 vdd vbsyn gsyn
Xho_22_1 ahp22 ahn22 wp_ho_22_1 wn_ho_22_1 mop1 mon1 vdd vbsyn gsyn
Xho_23_1 ahp23 ahn23 wp_ho_23_1 wn_ho_23_1 mop1 mon1 vdd vbsyn gsyn
Xho_24_1 ahp24 ahn24 wp_ho_24_1 wn_ho_24_1 mop1 mon1 vdd vbsyn gsyn
Xho_25_1 ahp25 ahn25 wp_ho_25_1 wn_ho_25_1 mop1 mon1 vdd vbsyn gsyn
Xho_26_1 ahp26 ahn26 wp_ho_26_1 wn_ho_26_1 mop1 mon1 vdd vbsyn gsyn
Xho_27_1 ahp27 ahn27 wp_ho_27_1 wn_ho_27_1 mop1 mon1 vdd vbsyn gsyn
Xho_28_1 ahp28 ahn28 wp_ho_28_1 wn_ho_28_1 mop1 mon1 vdd vbsyn gsyn
Xho_29_1 ahp29 ahn29 wp_ho_29_1 wn_ho_29_1 mop1 mon1 vdd vbsyn gsyn
Xho_30_1 ahp30 ahn30 wp_ho_30_1 wn_ho_30_1 mop1 mon1 vdd vbsyn gsyn
Xho_31_1 ahp31 ahn31 wp_ho_31_1 wn_ho_31_1 mop1 mon1 vdd vbsyn gsyn
Xcm_mo2 mop2 mon2 vdd cmld
Rnd_mo2 mop2 mon2 20k
Cmo2p mop2 0 1e-13
Cmo2n mon2 0 1e-13
Xho_0_2 ahp0 ahn0 wp_ho_0_2 wn_ho_0_2 mop2 mon2 vdd vbsyn gsyn
Xho_1_2 ahp1 ahn1 wp_ho_1_2 wn_ho_1_2 mop2 mon2 vdd vbsyn gsyn
Xho_2_2 ahp2 ahn2 wp_ho_2_2 wn_ho_2_2 mop2 mon2 vdd vbsyn gsyn
Xho_3_2 ahp3 ahn3 wp_ho_3_2 wn_ho_3_2 mop2 mon2 vdd vbsyn gsyn
Xho_4_2 ahp4 ahn4 wp_ho_4_2 wn_ho_4_2 mop2 mon2 vdd vbsyn gsyn
Xho_5_2 ahp5 ahn5 wp_ho_5_2 wn_ho_5_2 mop2 mon2 vdd vbsyn gsyn
Xho_6_2 ahp6 ahn6 wp_ho_6_2 wn_ho_6_2 mop2 mon2 vdd vbsyn gsyn
Xho_7_2 ahp7 ahn7 wp_ho_7_2 wn_ho_7_2 mop2 mon2 vdd vbsyn gsyn
Xho_8_2 ahp8 ahn8 wp_ho_8_2 wn_ho_8_2 mop2 mon2 vdd vbsyn gsyn
Xho_9_2 ahp9 ahn9 wp_ho_9_2 wn_ho_9_2 mop2 mon2 vdd vbsyn gsyn
Xho_10_2 ahp10 ahn10 wp_ho_10_2 wn_ho_10_2 mop2 mon2 vdd vbsyn gsyn
Xho_11_2 ahp11 ahn11 wp_ho_11_2 wn_ho_11_2 mop2 mon2 vdd vbsyn gsyn
Xho_12_2 ahp12 ahn12 wp_ho_12_2 wn_ho_12_2 mop2 mon2 vdd vbsyn gsyn
Xho_13_2 ahp13 ahn13 wp_ho_13_2 wn_ho_13_2 mop2 mon2 vdd vbsyn gsyn
Xho_14_2 ahp14 ahn14 wp_ho_14_2 wn_ho_14_2 mop2 mon2 vdd vbsyn gsyn
Xho_15_2 ahp15 ahn15 wp_ho_15_2 wn_ho_15_2 mop2 mon2 vdd vbsyn gsyn
Xho_16_2 ahp16 ahn16 wp_ho_16_2 wn_ho_16_2 mop2 mon2 vdd vbsyn gsyn
Xho_17_2 ahp17 ahn17 wp_ho_17_2 wn_ho_17_2 mop2 mon2 vdd vbsyn gsyn
Xho_18_2 ahp18 ahn18 wp_ho_18_2 wn_ho_18_2 mop2 mon2 vdd vbsyn gsyn
Xho_19_2 ahp19 ahn19 wp_ho_19_2 wn_ho_19_2 mop2 mon2 vdd vbsyn gsyn
Xho_20_2 ahp20 ahn20 wp_ho_20_2 wn_ho_20_2 mop2 mon2 vdd vbsyn gsyn
Xho_21_2 ahp21 ahn21 wp_ho_21_2 wn_ho_21_2 mop2 mon2 vdd vbsyn gsyn
Xho_22_2 ahp22 ahn22 wp_ho_22_2 wn_ho_22_2 mop2 mon2 vdd vbsyn gsyn
Xho_23_2 ahp23 ahn23 wp_ho_23_2 wn_ho_23_2 mop2 mon2 vdd vbsyn gsyn
Xho_24_2 ahp24 ahn24 wp_ho_24_2 wn_ho_24_2 mop2 mon2 vdd vbsyn gsyn
Xho_25_2 ahp25 ahn25 wp_ho_25_2 wn_ho_25_2 mop2 mon2 vdd vbsyn gsyn
Xho_26_2 ahp26 ahn26 wp_ho_26_2 wn_ho_26_2 mop2 mon2 vdd vbsyn gsyn
Xho_27_2 ahp27 ahn27 wp_ho_27_2 wn_ho_27_2 mop2 mon2 vdd vbsyn gsyn
Xho_28_2 ahp28 ahn28 wp_ho_28_2 wn_ho_28_2 mop2 mon2 vdd vbsyn gsyn
Xho_29_2 ahp29 ahn29 wp_ho_29_2 wn_ho_29_2 mop2 mon2 vdd vbsyn gsyn
Xho_30_2 ahp30 ahn30 wp_ho_30_2 wn_ho_30_2 mop2 mon2 vdd vbsyn gsyn
Xho_31_2 ahp31 ahn31 wp_ho_31_2 wn_ho_31_2 mop2 mon2 vdd vbsyn gsyn
Xcm_mo3 mop3 mon3 vdd cmld
Rnd_mo3 mop3 mon3 20k
Cmo3p mop3 0 1e-13
Cmo3n mon3 0 1e-13
Xho_0_3 ahp0 ahn0 wp_ho_0_3 wn_ho_0_3 mop3 mon3 vdd vbsyn gsyn
Xho_1_3 ahp1 ahn1 wp_ho_1_3 wn_ho_1_3 mop3 mon3 vdd vbsyn gsyn
Xho_2_3 ahp2 ahn2 wp_ho_2_3 wn_ho_2_3 mop3 mon3 vdd vbsyn gsyn
Xho_3_3 ahp3 ahn3 wp_ho_3_3 wn_ho_3_3 mop3 mon3 vdd vbsyn gsyn
Xho_4_3 ahp4 ahn4 wp_ho_4_3 wn_ho_4_3 mop3 mon3 vdd vbsyn gsyn
Xho_5_3 ahp5 ahn5 wp_ho_5_3 wn_ho_5_3 mop3 mon3 vdd vbsyn gsyn
Xho_6_3 ahp6 ahn6 wp_ho_6_3 wn_ho_6_3 mop3 mon3 vdd vbsyn gsyn
Xho_7_3 ahp7 ahn7 wp_ho_7_3 wn_ho_7_3 mop3 mon3 vdd vbsyn gsyn
Xho_8_3 ahp8 ahn8 wp_ho_8_3 wn_ho_8_3 mop3 mon3 vdd vbsyn gsyn
Xho_9_3 ahp9 ahn9 wp_ho_9_3 wn_ho_9_3 mop3 mon3 vdd vbsyn gsyn
Xho_10_3 ahp10 ahn10 wp_ho_10_3 wn_ho_10_3 mop3 mon3 vdd vbsyn gsyn
Xho_11_3 ahp11 ahn11 wp_ho_11_3 wn_ho_11_3 mop3 mon3 vdd vbsyn gsyn
Xho_12_3 ahp12 ahn12 wp_ho_12_3 wn_ho_12_3 mop3 mon3 vdd vbsyn gsyn
Xho_13_3 ahp13 ahn13 wp_ho_13_3 wn_ho_13_3 mop3 mon3 vdd vbsyn gsyn
Xho_14_3 ahp14 ahn14 wp_ho_14_3 wn_ho_14_3 mop3 mon3 vdd vbsyn gsyn
Xho_15_3 ahp15 ahn15 wp_ho_15_3 wn_ho_15_3 mop3 mon3 vdd vbsyn gsyn
Xho_16_3 ahp16 ahn16 wp_ho_16_3 wn_ho_16_3 mop3 mon3 vdd vbsyn gsyn
Xho_17_3 ahp17 ahn17 wp_ho_17_3 wn_ho_17_3 mop3 mon3 vdd vbsyn gsyn
Xho_18_3 ahp18 ahn18 wp_ho_18_3 wn_ho_18_3 mop3 mon3 vdd vbsyn gsyn
Xho_19_3 ahp19 ahn19 wp_ho_19_3 wn_ho_19_3 mop3 mon3 vdd vbsyn gsyn
Xho_20_3 ahp20 ahn20 wp_ho_20_3 wn_ho_20_3 mop3 mon3 vdd vbsyn gsyn
Xho_21_3 ahp21 ahn21 wp_ho_21_3 wn_ho_21_3 mop3 mon3 vdd vbsyn gsyn
Xho_22_3 ahp22 ahn22 wp_ho_22_3 wn_ho_22_3 mop3 mon3 vdd vbsyn gsyn
Xho_23_3 ahp23 ahn23 wp_ho_23_3 wn_ho_23_3 mop3 mon3 vdd vbsyn gsyn
Xho_24_3 ahp24 ahn24 wp_ho_24_3 wn_ho_24_3 mop3 mon3 vdd vbsyn gsyn
Xho_25_3 ahp25 ahn25 wp_ho_25_3 wn_ho_25_3 mop3 mon3 vdd vbsyn gsyn
Xho_26_3 ahp26 ahn26 wp_ho_26_3 wn_ho_26_3 mop3 mon3 vdd vbsyn gsyn
Xho_27_3 ahp27 ahn27 wp_ho_27_3 wn_ho_27_3 mop3 mon3 vdd vbsyn gsyn
Xho_28_3 ahp28 ahn28 wp_ho_28_3 wn_ho_28_3 mop3 mon3 vdd vbsyn gsyn
Xho_29_3 ahp29 ahn29 wp_ho_29_3 wn_ho_29_3 mop3 mon3 vdd vbsyn gsyn
Xho_30_3 ahp30 ahn30 wp_ho_30_3 wn_ho_30_3 mop3 mon3 vdd vbsyn gsyn
Xho_31_3 ahp31 ahn31 wp_ho_31_3 wn_ho_31_3 mop3 mon3 vdd vbsyn gsyn
.options gmin=1e-10 reltol=2e-3 cshunt=1e-15
.control
tran 1n 640.0n uic
wrdata pb_rn20160.dat v(ahp0) v(ahn0) v(ahp1) v(ahn1) v(ahp2) v(ahn2) v(ahp3) v(ahn3) v(ahp4) v(ahn4) v(ahp5) v(ahn5) v(ahp6) v(ahn6) v(ahp7) v(ahn7) v(ahp8) v(ahn8) v(ahp9) v(ahn9) v(ahp10) v(ahn10) v(ahp11) v(ahn11) v(ahp12) v(ahn12) v(ahp13) v(ahn13) v(ahp14) v(ahn14) v(ahp15) v(ahn15) v(ahp16) v(ahn16) v(ahp17) v(ahn17) v(ahp18) v(ahn18) v(ahp19) v(ahn19) v(ahp20) v(ahn20) v(ahp21) v(ahn21) v(ahp22) v(ahn22) v(ahp23) v(ahn23) v(ahp24) v(ahn24) v(ahp25) v(ahn25) v(ahp26) v(ahn26) v(ahp27) v(ahn27) v(ahp28) v(ahn28) v(ahp29) v(ahn29) v(ahp30) v(ahn30) v(ahp31) v(ahn31) v(mop0) v(mon0) v(mop1) v(mon1) v(mop2) v(mon2) v(mop3) v(mon3)
.endc
.end
