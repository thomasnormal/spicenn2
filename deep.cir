* N-layer sparse in-circuit trainer (pyramid)
.param Cg=0.0005
.model NSYN NMOS (LEVEL=1 VTO=0.2 KP=50u LAMBDA=0 GAMMA=0 PHI=0.7)
.model NMIR NMOS (LEVEL=1 VTO=0.5 KP=120u LAMBDA=0.02 GAMMA=0 PHI=0.7)
.model PMIR PMOS (LEVEL=1 VTO=-0.5 KP=40u LAMBDA=0.02 GAMMA=0 PHI=0.7)
.model NREL NMOS (LEVEL=1 VTO=0.5 KP=120u LAMBDA=0.02 GAMMA=0 PHI=0.7)
Vvdd vdd 0 3
Vrefh vrefh 0 0.5
Vrefo vrefo 0 0.5
Vg0 vg0 0 0.7
Vvc vcn 0 1.8
Vrefd vrefd 0 1.2
Vboff boff 0 1.9
Vthr vthr 0 0.5
Vcbias vcbias 0 1.0
Vvmid vmid 0 0.5
Vvtb vtb 0 1.4
Vulk vulk 0 0.6
Vbx bx 0 dc 1.7
Va0 a0 0 PWL(0.0000 1.0201 0.1980 1.0201 0.3000 1.4313 0.4980 1.4313 0.6000 0.3270 0.7980 0.3270 0.9000 0.7637 1.0980 0.7637 1.2000 0.7107 1.3980 0.7107 1.5000 0.3557 1.6980 0.3557 1.8000 0.7996 1.9980 0.7996 2.1000 0.4325 2.2980 0.4325 2.4000 0.7906 2.5980 0.7906 2.7000 0.9582 2.8980 0.9582 3.0000 0.3708 3.1980 0.3708 3.3000 1.0501 3.4980 1.0501 3.6000 1.3743 3.7980 1.3743 3.9000 1.0101 4.0980 1.0101 4.2000 0.7818 4.3980 0.7818 4.5000 1.1661 4.6980 1.1661 4.8000 1.1712 4.9980 1.1712 5.1000 0.8264 5.2980 0.8264 5.4000 1.4400 5.5980 1.4400 5.7000 0.3474 5.8980 0.3474 6.0000 0.4668 6.1980 0.4668 6.3000 1.4516 6.4980 1.4516 6.6000 0.7918 6.7980 0.7918 6.9000 1.4473 7.0980 1.4473 7.2000 1.3647 7.3980 1.3647 7.5000 0.4843 7.6980 0.4843 7.8000 1.2512 7.9980 1.2512 8.1000 1.3011 8.2980 1.3011 8.4000 1.0394 8.5980 1.0394 8.7000 1.0718 8.8980 1.0718 9.0000 1.3329 9.1980 1.3329 9.3000 0.7845 9.4980 0.7845 9.6000 1.2044 9.7980 1.2044 9.9000 0.6489 10.0980 0.6489 10.2000 0.7431 10.3980 0.7431 10.5000 1.2366 10.6980 1.2366 10.8000 0.7871 10.9980 0.7871 11.1000 1.3979 11.2980 1.3979 11.4000 1.4302 11.5980 1.4302 11.7000 0.8064 11.8980 0.8064 12.0000 0.3378 12.1980 0.3378 12.3000 0.9475 12.4980 0.9475 12.6000 0.4443 12.7980 0.4443 12.9000 1.3374 13.0980 1.3374 13.2000 0.7487 13.3980 0.7487 13.5000 0.8053 13.6980 0.8053 13.8000 0.3130 13.9980 0.3130 14.1000 0.8947 14.2980 0.8947 14.4000 1.3768 14.5980 1.3768 14.7000 0.4759 14.8980 0.4759 15.0000 0.7923 15.1980 0.7923 15.3000 0.9750 15.4980 0.9750 15.6000 1.0073 15.7980 1.0073 15.9000 1.1701 16.0980 1.1701 16.2000 0.9572 16.3980 0.9572 16.5000 0.9732 16.6980 0.9732 16.8000 0.3956 16.9980 0.3956 17.1000 0.5333 17.2980 0.5333 17.4000 0.4544 17.5980 0.4544 17.7000 0.4863 17.8980 0.4863 18.0000 0.4863)
Va1 a1 0 PWL(0.0000 0.7160 0.1980 0.7160 0.3000 1.0171 0.4980 1.0171 0.6000 1.0628 0.7980 1.0628 0.9000 0.9957 1.0980 0.9957 1.2000 0.4156 1.3980 0.4156 1.5000 0.7570 1.6980 0.7570 1.8000 1.4662 1.9980 1.4662 2.1000 0.6659 2.2980 0.6659 2.4000 0.8453 2.5980 0.8453 2.7000 0.3622 2.8980 0.3622 3.0000 0.7387 3.1980 0.7387 3.3000 0.7071 3.4980 0.7071 3.6000 0.8427 3.7980 0.8427 3.9000 1.4946 4.0980 1.4946 4.2000 1.0857 4.3980 1.0857 4.5000 0.7165 4.6980 0.7165 4.8000 1.4218 4.9980 1.4218 5.1000 1.4945 5.2980 1.4945 5.4000 1.1466 5.5980 1.1466 5.7000 0.9907 5.8980 0.9907 6.0000 0.5832 6.1980 0.5832 6.3000 1.0878 6.4980 1.0878 6.6000 0.3890 6.7980 0.3890 6.9000 1.1461 7.0980 1.1461 7.2000 0.8551 7.3980 0.8551 7.5000 0.5883 7.6980 0.5883 7.8000 0.7485 7.9980 0.7485 8.1000 1.3788 8.2980 1.3788 8.4000 1.4600 8.5980 1.4600 8.7000 0.7111 8.8980 0.7111 9.0000 1.3776 9.1980 1.3776 9.3000 1.0336 9.4980 1.0336 9.6000 0.7360 9.7980 0.7360 9.9000 1.4503 10.0980 1.4503 10.2000 1.4781 10.3980 1.4781 10.5000 1.4094 10.6980 1.4094 10.8000 1.0272 10.9980 1.0272 11.1000 0.8848 11.2980 0.8848 11.4000 1.0704 11.5980 1.0704 11.7000 1.0041 11.8980 1.0041 12.0000 0.8863 12.1980 0.8863 12.3000 0.3339 12.4980 0.3339 12.6000 0.6312 12.7980 0.6312 12.9000 0.8539 13.0980 0.8539 13.2000 0.3731 13.3980 0.3731 13.5000 0.3699 13.6980 0.3699 13.8000 0.9946 13.9980 0.9946 14.1000 0.7767 14.2980 0.7767 14.4000 0.8618 14.5980 0.8618 14.7000 0.5740 14.8980 0.5740 15.0000 1.4659 15.1980 1.4659 15.3000 0.6978 15.4980 0.6978 15.6000 0.3149 15.7980 0.3149 15.9000 0.6981 16.0980 0.6981 16.2000 0.3233 16.3980 0.3233 16.5000 0.3236 16.6980 0.3236 16.8000 1.1742 16.9980 1.1742 17.1000 1.3647 17.2980 1.3647 17.4000 1.3000 17.5980 1.3000 17.7000 0.5863 17.8980 0.5863 18.0000 0.5863)
Vtg0 tg0 0 PWL(0.0000 1.0000 0.1980 1.0000 0.3000 1.0000 0.4980 1.0000 0.6000 1.0000 0.7980 1.0000 0.9000 1.0000 1.0980 1.0000 1.2000 1.0000 1.3980 1.0000 1.5000 1.0000 1.6980 1.0000 1.8000 1.0000 1.9980 1.0000 2.1000 1.0000 2.2980 1.0000 2.4000 1.0000 2.5980 1.0000 2.7000 1.0000 2.8980 1.0000 3.0000 1.0000 3.1980 1.0000 3.3000 1.0000 3.4980 1.0000 3.6000 1.0000 3.7980 1.0000 3.9000 1.0000 4.0980 1.0000 4.2000 1.0000 4.3980 1.0000 4.5000 1.0000 4.6980 1.0000 4.8000 1.0000 4.9980 1.0000 5.1000 1.0000 5.2980 1.0000 5.4000 1.0000 5.5980 1.0000 5.7000 1.0000 5.8980 1.0000 6.0000 1.0000 6.1980 1.0000 6.3000 1.0000 6.4980 1.0000 6.6000 1.0000 6.7980 1.0000 6.9000 1.0000 7.0980 1.0000 7.2000 1.0000 7.3980 1.0000 7.5000 1.0000 7.6980 1.0000 7.8000 1.0000 7.9980 1.0000 8.1000 1.0000 8.2980 1.0000 8.4000 1.0000 8.5980 1.0000 8.7000 1.0000 8.8980 1.0000 9.0000 1.0000 9.1980 1.0000 9.3000 1.0000 9.4980 1.0000 9.6000 1.0000 9.7980 1.0000 9.9000 1.0000 10.0980 1.0000 10.2000 1.0000 10.3980 1.0000 10.5000 1.0000 10.6980 1.0000 10.8000 1.0000 10.9980 1.0000 11.1000 1.0000 11.2980 1.0000 11.4000 1.0000 11.5980 1.0000 11.7000 1.0000 11.8980 1.0000 12.0000 1.0000 12.1980 1.0000 12.3000 1.0000 12.4980 1.0000 12.6000 1.0000 12.7980 1.0000 12.9000 1.0000 13.0980 1.0000 13.2000 1.0000 13.3980 1.0000 13.5000 1.0000 13.6980 1.0000 13.8000 1.0000 13.9980 1.0000 14.1000 1.0000 14.2980 1.0000 14.4000 1.0000 14.5980 1.0000 14.7000 1.0000 14.8980 1.0000 15.0000 1.0000 15.1980 1.0000 15.3000 1.0000 15.4980 1.0000 15.6000 1.0000 15.7980 1.0000 15.9000 1.0000 16.0980 1.0000 16.2000 1.0000 16.3980 1.0000 16.5000 1.0000 16.6980 1.0000 16.8000 1.0000 16.9980 1.0000 17.1000 1.0000 17.2980 1.0000 17.4000 1.0000 17.5980 1.0000 17.7000 1.0000 17.8980 1.0000 18.0000 1.0000)
Vtg1 tg1 0 PWL(0.0000 0.0000 0.1980 0.0000 0.3000 0.0000 0.4980 0.0000 0.6000 0.0000 0.7980 0.0000 0.9000 0.0000 1.0980 0.0000 1.2000 0.0000 1.3980 0.0000 1.5000 0.0000 1.6980 0.0000 1.8000 0.0000 1.9980 0.0000 2.1000 0.0000 2.2980 0.0000 2.4000 0.0000 2.5980 0.0000 2.7000 0.0000 2.8980 0.0000 3.0000 0.0000 3.1980 0.0000 3.3000 0.0000 3.4980 0.0000 3.6000 0.0000 3.7980 0.0000 3.9000 0.0000 4.0980 0.0000 4.2000 0.0000 4.3980 0.0000 4.5000 0.0000 4.6980 0.0000 4.8000 0.0000 4.9980 0.0000 5.1000 0.0000 5.2980 0.0000 5.4000 0.0000 5.5980 0.0000 5.7000 0.0000 5.8980 0.0000 6.0000 0.0000 6.1980 0.0000 6.3000 0.0000 6.4980 0.0000 6.6000 0.0000 6.7980 0.0000 6.9000 0.0000 7.0980 0.0000 7.2000 0.0000 7.3980 0.0000 7.5000 0.0000 7.6980 0.0000 7.8000 0.0000 7.9980 0.0000 8.1000 0.0000 8.2980 0.0000 8.4000 0.0000 8.5980 0.0000 8.7000 0.0000 8.8980 0.0000 9.0000 0.0000 9.1980 0.0000 9.3000 0.0000 9.4980 0.0000 9.6000 0.0000 9.7980 0.0000 9.9000 0.0000 10.0980 0.0000 10.2000 0.0000 10.3980 0.0000 10.5000 0.0000 10.6980 0.0000 10.8000 0.0000 10.9980 0.0000 11.1000 0.0000 11.2980 0.0000 11.4000 0.0000 11.5980 0.0000 11.7000 0.0000 11.8980 0.0000 12.0000 0.0000 12.1980 0.0000 12.3000 0.0000 12.4980 0.0000 12.6000 0.0000 12.7980 0.0000 12.9000 0.0000 13.0980 0.0000 13.2000 0.0000 13.3980 0.0000 13.5000 0.0000 13.6980 0.0000 13.8000 0.0000 13.9980 0.0000 14.1000 0.0000 14.2980 0.0000 14.4000 0.0000 14.5980 0.0000 14.7000 0.0000 14.8980 0.0000 15.0000 0.0000 15.1980 0.0000 15.3000 0.0000 15.4980 0.0000 15.6000 0.0000 15.7980 0.0000 15.9000 0.0000 16.0980 0.0000 16.2000 0.0000 16.3980 0.0000 16.5000 0.0000 16.6980 0.0000 16.8000 0.0000 16.9980 0.0000 17.1000 0.0000 17.2980 0.0000 17.4000 0.0000 17.5980 0.0000 17.7000 0.0000 17.8980 0.0000 18.0000 0.0000)
C_gp_1_0_0 gp_1_0_0 0 {Cg}
Mp_1_0_0 a0 gp_1_0_0 colp_L1_0 0 NSYN W=10u L=1u
Mn_1_0_0 a0 vcn coln_L1_0 0 NSYN W=10u L=1u
C_gp_1_0_1 gp_1_0_1 0 {Cg}
Mp_1_0_1 a1 gp_1_0_1 colp_L1_0 0 NSYN W=10u L=1u
Mn_1_0_1 a1 vcn coln_L1_0 0 NSYN W=10u L=1u
C_gp_1_0_b gp_1_0_b 0 {Cg}
Mp_1_0_b bx gp_1_0_b colp_L1_0 0 NSYN W=10u L=1u
Mn_1_0_b bx vcn coln_L1_0 0 NSYN W=10u L=1u
Msa_h_L1_0 coln_L1_0 coln_L1_0 0 0 NMIR W=20u L=1u
Msb_h_L1_0 z_L1_0 coln_L1_0 0 0 NMIR W=20u L=1u
Msc_h_L1_0 colp_L1_0 colp_L1_0 0 0 NMIR W=20u L=1u
Msd_h_L1_0 dpf_h_L1_0 colp_L1_0 0 0 NMIR W=20u L=1u
Mse_h_L1_0 dpf_h_L1_0 dpf_h_L1_0 vdd vdd PMIR W=60u L=1u
Msf_h_L1_0 z_L1_0 dpf_h_L1_0 vdd vdd PMIR W=60u L=1u
R_h_L1_0 z_L1_0 vrefh 8000.0
Mr_L1_0  hdd_L1_0 z_L1_0 tail_L1_0 0 NREL W=12u L=1u
Mr2_L1_0 dmp_L1_0  vmid  tail_L1_0 0 NREL W=12u L=1u
Mtl_L1_0 tail_L1_0 vtb 0 0 NREL W=32.0u L=1u
Mdm_L1_0 dmp_L1_0 dmp_L1_0 vdd vdd PMIR W=40u L=1u
Mrp1_L1_0 hdd_L1_0 hdd_L1_0 vdd vdd PMIR W=40u L=1u
Mrp2_L1_0 hv_L1_0 hdd_L1_0 vdd vdd PMIR W=40u L=1u
Rhv_L1_0 hv_L1_0 vg0 8000.0
C_gp_1_1_0 gp_1_1_0 0 {Cg}
Mp_1_1_0 a0 gp_1_1_0 colp_L1_1 0 NSYN W=10u L=1u
Mn_1_1_0 a0 vcn coln_L1_1 0 NSYN W=10u L=1u
C_gp_1_1_1 gp_1_1_1 0 {Cg}
Mp_1_1_1 a1 gp_1_1_1 colp_L1_1 0 NSYN W=10u L=1u
Mn_1_1_1 a1 vcn coln_L1_1 0 NSYN W=10u L=1u
C_gp_1_1_b gp_1_1_b 0 {Cg}
Mp_1_1_b bx gp_1_1_b colp_L1_1 0 NSYN W=10u L=1u
Mn_1_1_b bx vcn coln_L1_1 0 NSYN W=10u L=1u
Msa_h_L1_1 coln_L1_1 coln_L1_1 0 0 NMIR W=20u L=1u
Msb_h_L1_1 z_L1_1 coln_L1_1 0 0 NMIR W=20u L=1u
Msc_h_L1_1 colp_L1_1 colp_L1_1 0 0 NMIR W=20u L=1u
Msd_h_L1_1 dpf_h_L1_1 colp_L1_1 0 0 NMIR W=20u L=1u
Mse_h_L1_1 dpf_h_L1_1 dpf_h_L1_1 vdd vdd PMIR W=60u L=1u
Msf_h_L1_1 z_L1_1 dpf_h_L1_1 vdd vdd PMIR W=60u L=1u
R_h_L1_1 z_L1_1 vrefh 8000.0
Mr_L1_1  hdd_L1_1 z_L1_1 tail_L1_1 0 NREL W=12u L=1u
Mr2_L1_1 dmp_L1_1  vmid  tail_L1_1 0 NREL W=12u L=1u
Mtl_L1_1 tail_L1_1 vtb 0 0 NREL W=32.0u L=1u
Mdm_L1_1 dmp_L1_1 dmp_L1_1 vdd vdd PMIR W=40u L=1u
Mrp1_L1_1 hdd_L1_1 hdd_L1_1 vdd vdd PMIR W=40u L=1u
Mrp2_L1_1 hv_L1_1 hdd_L1_1 vdd vdd PMIR W=40u L=1u
Rhv_L1_1 hv_L1_1 vg0 8000.0
C_gp_1_2_0 gp_1_2_0 0 {Cg}
Mp_1_2_0 a0 gp_1_2_0 colp_L1_2 0 NSYN W=10u L=1u
Mn_1_2_0 a0 vcn coln_L1_2 0 NSYN W=10u L=1u
C_gp_1_2_1 gp_1_2_1 0 {Cg}
Mp_1_2_1 a1 gp_1_2_1 colp_L1_2 0 NSYN W=10u L=1u
Mn_1_2_1 a1 vcn coln_L1_2 0 NSYN W=10u L=1u
C_gp_1_2_b gp_1_2_b 0 {Cg}
Mp_1_2_b bx gp_1_2_b colp_L1_2 0 NSYN W=10u L=1u
Mn_1_2_b bx vcn coln_L1_2 0 NSYN W=10u L=1u
Msa_h_L1_2 coln_L1_2 coln_L1_2 0 0 NMIR W=20u L=1u
Msb_h_L1_2 z_L1_2 coln_L1_2 0 0 NMIR W=20u L=1u
Msc_h_L1_2 colp_L1_2 colp_L1_2 0 0 NMIR W=20u L=1u
Msd_h_L1_2 dpf_h_L1_2 colp_L1_2 0 0 NMIR W=20u L=1u
Mse_h_L1_2 dpf_h_L1_2 dpf_h_L1_2 vdd vdd PMIR W=60u L=1u
Msf_h_L1_2 z_L1_2 dpf_h_L1_2 vdd vdd PMIR W=60u L=1u
R_h_L1_2 z_L1_2 vrefh 8000.0
Mr_L1_2  hdd_L1_2 z_L1_2 tail_L1_2 0 NREL W=12u L=1u
Mr2_L1_2 dmp_L1_2  vmid  tail_L1_2 0 NREL W=12u L=1u
Mtl_L1_2 tail_L1_2 vtb 0 0 NREL W=32.0u L=1u
Mdm_L1_2 dmp_L1_2 dmp_L1_2 vdd vdd PMIR W=40u L=1u
Mrp1_L1_2 hdd_L1_2 hdd_L1_2 vdd vdd PMIR W=40u L=1u
Mrp2_L1_2 hv_L1_2 hdd_L1_2 vdd vdd PMIR W=40u L=1u
Rhv_L1_2 hv_L1_2 vg0 8000.0
C_gp_1_3_0 gp_1_3_0 0 {Cg}
Mp_1_3_0 a0 gp_1_3_0 colp_L1_3 0 NSYN W=10u L=1u
Mn_1_3_0 a0 vcn coln_L1_3 0 NSYN W=10u L=1u
C_gp_1_3_1 gp_1_3_1 0 {Cg}
Mp_1_3_1 a1 gp_1_3_1 colp_L1_3 0 NSYN W=10u L=1u
Mn_1_3_1 a1 vcn coln_L1_3 0 NSYN W=10u L=1u
C_gp_1_3_b gp_1_3_b 0 {Cg}
Mp_1_3_b bx gp_1_3_b colp_L1_3 0 NSYN W=10u L=1u
Mn_1_3_b bx vcn coln_L1_3 0 NSYN W=10u L=1u
Msa_h_L1_3 coln_L1_3 coln_L1_3 0 0 NMIR W=20u L=1u
Msb_h_L1_3 z_L1_3 coln_L1_3 0 0 NMIR W=20u L=1u
Msc_h_L1_3 colp_L1_3 colp_L1_3 0 0 NMIR W=20u L=1u
Msd_h_L1_3 dpf_h_L1_3 colp_L1_3 0 0 NMIR W=20u L=1u
Mse_h_L1_3 dpf_h_L1_3 dpf_h_L1_3 vdd vdd PMIR W=60u L=1u
Msf_h_L1_3 z_L1_3 dpf_h_L1_3 vdd vdd PMIR W=60u L=1u
R_h_L1_3 z_L1_3 vrefh 8000.0
Mr_L1_3  hdd_L1_3 z_L1_3 tail_L1_3 0 NREL W=12u L=1u
Mr2_L1_3 dmp_L1_3  vmid  tail_L1_3 0 NREL W=12u L=1u
Mtl_L1_3 tail_L1_3 vtb 0 0 NREL W=32.0u L=1u
Mdm_L1_3 dmp_L1_3 dmp_L1_3 vdd vdd PMIR W=40u L=1u
Mrp1_L1_3 hdd_L1_3 hdd_L1_3 vdd vdd PMIR W=40u L=1u
Mrp2_L1_3 hv_L1_3 hdd_L1_3 vdd vdd PMIR W=40u L=1u
Rhv_L1_3 hv_L1_3 vg0 8000.0
C_gp_1_4_0 gp_1_4_0 0 {Cg}
Mp_1_4_0 a0 gp_1_4_0 colp_L1_4 0 NSYN W=10u L=1u
Mn_1_4_0 a0 vcn coln_L1_4 0 NSYN W=10u L=1u
C_gp_1_4_1 gp_1_4_1 0 {Cg}
Mp_1_4_1 a1 gp_1_4_1 colp_L1_4 0 NSYN W=10u L=1u
Mn_1_4_1 a1 vcn coln_L1_4 0 NSYN W=10u L=1u
C_gp_1_4_b gp_1_4_b 0 {Cg}
Mp_1_4_b bx gp_1_4_b colp_L1_4 0 NSYN W=10u L=1u
Mn_1_4_b bx vcn coln_L1_4 0 NSYN W=10u L=1u
Msa_h_L1_4 coln_L1_4 coln_L1_4 0 0 NMIR W=20u L=1u
Msb_h_L1_4 z_L1_4 coln_L1_4 0 0 NMIR W=20u L=1u
Msc_h_L1_4 colp_L1_4 colp_L1_4 0 0 NMIR W=20u L=1u
Msd_h_L1_4 dpf_h_L1_4 colp_L1_4 0 0 NMIR W=20u L=1u
Mse_h_L1_4 dpf_h_L1_4 dpf_h_L1_4 vdd vdd PMIR W=60u L=1u
Msf_h_L1_4 z_L1_4 dpf_h_L1_4 vdd vdd PMIR W=60u L=1u
R_h_L1_4 z_L1_4 vrefh 8000.0
Mr_L1_4  hdd_L1_4 z_L1_4 tail_L1_4 0 NREL W=12u L=1u
Mr2_L1_4 dmp_L1_4  vmid  tail_L1_4 0 NREL W=12u L=1u
Mtl_L1_4 tail_L1_4 vtb 0 0 NREL W=32.0u L=1u
Mdm_L1_4 dmp_L1_4 dmp_L1_4 vdd vdd PMIR W=40u L=1u
Mrp1_L1_4 hdd_L1_4 hdd_L1_4 vdd vdd PMIR W=40u L=1u
Mrp2_L1_4 hv_L1_4 hdd_L1_4 vdd vdd PMIR W=40u L=1u
Rhv_L1_4 hv_L1_4 vg0 8000.0
C_gp_1_5_0 gp_1_5_0 0 {Cg}
Mp_1_5_0 a0 gp_1_5_0 colp_L1_5 0 NSYN W=10u L=1u
Mn_1_5_0 a0 vcn coln_L1_5 0 NSYN W=10u L=1u
C_gp_1_5_1 gp_1_5_1 0 {Cg}
Mp_1_5_1 a1 gp_1_5_1 colp_L1_5 0 NSYN W=10u L=1u
Mn_1_5_1 a1 vcn coln_L1_5 0 NSYN W=10u L=1u
C_gp_1_5_b gp_1_5_b 0 {Cg}
Mp_1_5_b bx gp_1_5_b colp_L1_5 0 NSYN W=10u L=1u
Mn_1_5_b bx vcn coln_L1_5 0 NSYN W=10u L=1u
Msa_h_L1_5 coln_L1_5 coln_L1_5 0 0 NMIR W=20u L=1u
Msb_h_L1_5 z_L1_5 coln_L1_5 0 0 NMIR W=20u L=1u
Msc_h_L1_5 colp_L1_5 colp_L1_5 0 0 NMIR W=20u L=1u
Msd_h_L1_5 dpf_h_L1_5 colp_L1_5 0 0 NMIR W=20u L=1u
Mse_h_L1_5 dpf_h_L1_5 dpf_h_L1_5 vdd vdd PMIR W=60u L=1u
Msf_h_L1_5 z_L1_5 dpf_h_L1_5 vdd vdd PMIR W=60u L=1u
R_h_L1_5 z_L1_5 vrefh 8000.0
Mr_L1_5  hdd_L1_5 z_L1_5 tail_L1_5 0 NREL W=12u L=1u
Mr2_L1_5 dmp_L1_5  vmid  tail_L1_5 0 NREL W=12u L=1u
Mtl_L1_5 tail_L1_5 vtb 0 0 NREL W=32.0u L=1u
Mdm_L1_5 dmp_L1_5 dmp_L1_5 vdd vdd PMIR W=40u L=1u
Mrp1_L1_5 hdd_L1_5 hdd_L1_5 vdd vdd PMIR W=40u L=1u
Mrp2_L1_5 hv_L1_5 hdd_L1_5 vdd vdd PMIR W=40u L=1u
Rhv_L1_5 hv_L1_5 vg0 8000.0
C_gp_1_6_0 gp_1_6_0 0 {Cg}
Mp_1_6_0 a0 gp_1_6_0 colp_L1_6 0 NSYN W=10u L=1u
Mn_1_6_0 a0 vcn coln_L1_6 0 NSYN W=10u L=1u
C_gp_1_6_1 gp_1_6_1 0 {Cg}
Mp_1_6_1 a1 gp_1_6_1 colp_L1_6 0 NSYN W=10u L=1u
Mn_1_6_1 a1 vcn coln_L1_6 0 NSYN W=10u L=1u
C_gp_1_6_b gp_1_6_b 0 {Cg}
Mp_1_6_b bx gp_1_6_b colp_L1_6 0 NSYN W=10u L=1u
Mn_1_6_b bx vcn coln_L1_6 0 NSYN W=10u L=1u
Msa_h_L1_6 coln_L1_6 coln_L1_6 0 0 NMIR W=20u L=1u
Msb_h_L1_6 z_L1_6 coln_L1_6 0 0 NMIR W=20u L=1u
Msc_h_L1_6 colp_L1_6 colp_L1_6 0 0 NMIR W=20u L=1u
Msd_h_L1_6 dpf_h_L1_6 colp_L1_6 0 0 NMIR W=20u L=1u
Mse_h_L1_6 dpf_h_L1_6 dpf_h_L1_6 vdd vdd PMIR W=60u L=1u
Msf_h_L1_6 z_L1_6 dpf_h_L1_6 vdd vdd PMIR W=60u L=1u
R_h_L1_6 z_L1_6 vrefh 8000.0
Mr_L1_6  hdd_L1_6 z_L1_6 tail_L1_6 0 NREL W=12u L=1u
Mr2_L1_6 dmp_L1_6  vmid  tail_L1_6 0 NREL W=12u L=1u
Mtl_L1_6 tail_L1_6 vtb 0 0 NREL W=32.0u L=1u
Mdm_L1_6 dmp_L1_6 dmp_L1_6 vdd vdd PMIR W=40u L=1u
Mrp1_L1_6 hdd_L1_6 hdd_L1_6 vdd vdd PMIR W=40u L=1u
Mrp2_L1_6 hv_L1_6 hdd_L1_6 vdd vdd PMIR W=40u L=1u
Rhv_L1_6 hv_L1_6 vg0 8000.0
C_gp_1_7_0 gp_1_7_0 0 {Cg}
Mp_1_7_0 a0 gp_1_7_0 colp_L1_7 0 NSYN W=10u L=1u
Mn_1_7_0 a0 vcn coln_L1_7 0 NSYN W=10u L=1u
C_gp_1_7_1 gp_1_7_1 0 {Cg}
Mp_1_7_1 a1 gp_1_7_1 colp_L1_7 0 NSYN W=10u L=1u
Mn_1_7_1 a1 vcn coln_L1_7 0 NSYN W=10u L=1u
C_gp_1_7_b gp_1_7_b 0 {Cg}
Mp_1_7_b bx gp_1_7_b colp_L1_7 0 NSYN W=10u L=1u
Mn_1_7_b bx vcn coln_L1_7 0 NSYN W=10u L=1u
Msa_h_L1_7 coln_L1_7 coln_L1_7 0 0 NMIR W=20u L=1u
Msb_h_L1_7 z_L1_7 coln_L1_7 0 0 NMIR W=20u L=1u
Msc_h_L1_7 colp_L1_7 colp_L1_7 0 0 NMIR W=20u L=1u
Msd_h_L1_7 dpf_h_L1_7 colp_L1_7 0 0 NMIR W=20u L=1u
Mse_h_L1_7 dpf_h_L1_7 dpf_h_L1_7 vdd vdd PMIR W=60u L=1u
Msf_h_L1_7 z_L1_7 dpf_h_L1_7 vdd vdd PMIR W=60u L=1u
R_h_L1_7 z_L1_7 vrefh 8000.0
Mr_L1_7  hdd_L1_7 z_L1_7 tail_L1_7 0 NREL W=12u L=1u
Mr2_L1_7 dmp_L1_7  vmid  tail_L1_7 0 NREL W=12u L=1u
Mtl_L1_7 tail_L1_7 vtb 0 0 NREL W=32.0u L=1u
Mdm_L1_7 dmp_L1_7 dmp_L1_7 vdd vdd PMIR W=40u L=1u
Mrp1_L1_7 hdd_L1_7 hdd_L1_7 vdd vdd PMIR W=40u L=1u
Mrp2_L1_7 hv_L1_7 hdd_L1_7 vdd vdd PMIR W=40u L=1u
Rhv_L1_7 hv_L1_7 vg0 8000.0
C_gp_1_8_0 gp_1_8_0 0 {Cg}
Mp_1_8_0 a0 gp_1_8_0 colp_L1_8 0 NSYN W=10u L=1u
Mn_1_8_0 a0 vcn coln_L1_8 0 NSYN W=10u L=1u
C_gp_1_8_1 gp_1_8_1 0 {Cg}
Mp_1_8_1 a1 gp_1_8_1 colp_L1_8 0 NSYN W=10u L=1u
Mn_1_8_1 a1 vcn coln_L1_8 0 NSYN W=10u L=1u
C_gp_1_8_b gp_1_8_b 0 {Cg}
Mp_1_8_b bx gp_1_8_b colp_L1_8 0 NSYN W=10u L=1u
Mn_1_8_b bx vcn coln_L1_8 0 NSYN W=10u L=1u
Msa_h_L1_8 coln_L1_8 coln_L1_8 0 0 NMIR W=20u L=1u
Msb_h_L1_8 z_L1_8 coln_L1_8 0 0 NMIR W=20u L=1u
Msc_h_L1_8 colp_L1_8 colp_L1_8 0 0 NMIR W=20u L=1u
Msd_h_L1_8 dpf_h_L1_8 colp_L1_8 0 0 NMIR W=20u L=1u
Mse_h_L1_8 dpf_h_L1_8 dpf_h_L1_8 vdd vdd PMIR W=60u L=1u
Msf_h_L1_8 z_L1_8 dpf_h_L1_8 vdd vdd PMIR W=60u L=1u
R_h_L1_8 z_L1_8 vrefh 8000.0
Mr_L1_8  hdd_L1_8 z_L1_8 tail_L1_8 0 NREL W=12u L=1u
Mr2_L1_8 dmp_L1_8  vmid  tail_L1_8 0 NREL W=12u L=1u
Mtl_L1_8 tail_L1_8 vtb 0 0 NREL W=32.0u L=1u
Mdm_L1_8 dmp_L1_8 dmp_L1_8 vdd vdd PMIR W=40u L=1u
Mrp1_L1_8 hdd_L1_8 hdd_L1_8 vdd vdd PMIR W=40u L=1u
Mrp2_L1_8 hv_L1_8 hdd_L1_8 vdd vdd PMIR W=40u L=1u
Rhv_L1_8 hv_L1_8 vg0 8000.0
C_gp_1_9_0 gp_1_9_0 0 {Cg}
Mp_1_9_0 a0 gp_1_9_0 colp_L1_9 0 NSYN W=10u L=1u
Mn_1_9_0 a0 vcn coln_L1_9 0 NSYN W=10u L=1u
C_gp_1_9_1 gp_1_9_1 0 {Cg}
Mp_1_9_1 a1 gp_1_9_1 colp_L1_9 0 NSYN W=10u L=1u
Mn_1_9_1 a1 vcn coln_L1_9 0 NSYN W=10u L=1u
C_gp_1_9_b gp_1_9_b 0 {Cg}
Mp_1_9_b bx gp_1_9_b colp_L1_9 0 NSYN W=10u L=1u
Mn_1_9_b bx vcn coln_L1_9 0 NSYN W=10u L=1u
Msa_h_L1_9 coln_L1_9 coln_L1_9 0 0 NMIR W=20u L=1u
Msb_h_L1_9 z_L1_9 coln_L1_9 0 0 NMIR W=20u L=1u
Msc_h_L1_9 colp_L1_9 colp_L1_9 0 0 NMIR W=20u L=1u
Msd_h_L1_9 dpf_h_L1_9 colp_L1_9 0 0 NMIR W=20u L=1u
Mse_h_L1_9 dpf_h_L1_9 dpf_h_L1_9 vdd vdd PMIR W=60u L=1u
Msf_h_L1_9 z_L1_9 dpf_h_L1_9 vdd vdd PMIR W=60u L=1u
R_h_L1_9 z_L1_9 vrefh 8000.0
Mr_L1_9  hdd_L1_9 z_L1_9 tail_L1_9 0 NREL W=12u L=1u
Mr2_L1_9 dmp_L1_9  vmid  tail_L1_9 0 NREL W=12u L=1u
Mtl_L1_9 tail_L1_9 vtb 0 0 NREL W=32.0u L=1u
Mdm_L1_9 dmp_L1_9 dmp_L1_9 vdd vdd PMIR W=40u L=1u
Mrp1_L1_9 hdd_L1_9 hdd_L1_9 vdd vdd PMIR W=40u L=1u
Mrp2_L1_9 hv_L1_9 hdd_L1_9 vdd vdd PMIR W=40u L=1u
Rhv_L1_9 hv_L1_9 vg0 8000.0
C_gp_1_10_0 gp_1_10_0 0 {Cg}
Mp_1_10_0 a0 gp_1_10_0 colp_L1_10 0 NSYN W=10u L=1u
Mn_1_10_0 a0 vcn coln_L1_10 0 NSYN W=10u L=1u
C_gp_1_10_1 gp_1_10_1 0 {Cg}
Mp_1_10_1 a1 gp_1_10_1 colp_L1_10 0 NSYN W=10u L=1u
Mn_1_10_1 a1 vcn coln_L1_10 0 NSYN W=10u L=1u
C_gp_1_10_b gp_1_10_b 0 {Cg}
Mp_1_10_b bx gp_1_10_b colp_L1_10 0 NSYN W=10u L=1u
Mn_1_10_b bx vcn coln_L1_10 0 NSYN W=10u L=1u
Msa_h_L1_10 coln_L1_10 coln_L1_10 0 0 NMIR W=20u L=1u
Msb_h_L1_10 z_L1_10 coln_L1_10 0 0 NMIR W=20u L=1u
Msc_h_L1_10 colp_L1_10 colp_L1_10 0 0 NMIR W=20u L=1u
Msd_h_L1_10 dpf_h_L1_10 colp_L1_10 0 0 NMIR W=20u L=1u
Mse_h_L1_10 dpf_h_L1_10 dpf_h_L1_10 vdd vdd PMIR W=60u L=1u
Msf_h_L1_10 z_L1_10 dpf_h_L1_10 vdd vdd PMIR W=60u L=1u
R_h_L1_10 z_L1_10 vrefh 8000.0
Mr_L1_10  hdd_L1_10 z_L1_10 tail_L1_10 0 NREL W=12u L=1u
Mr2_L1_10 dmp_L1_10  vmid  tail_L1_10 0 NREL W=12u L=1u
Mtl_L1_10 tail_L1_10 vtb 0 0 NREL W=32.0u L=1u
Mdm_L1_10 dmp_L1_10 dmp_L1_10 vdd vdd PMIR W=40u L=1u
Mrp1_L1_10 hdd_L1_10 hdd_L1_10 vdd vdd PMIR W=40u L=1u
Mrp2_L1_10 hv_L1_10 hdd_L1_10 vdd vdd PMIR W=40u L=1u
Rhv_L1_10 hv_L1_10 vg0 8000.0
C_gp_1_11_0 gp_1_11_0 0 {Cg}
Mp_1_11_0 a0 gp_1_11_0 colp_L1_11 0 NSYN W=10u L=1u
Mn_1_11_0 a0 vcn coln_L1_11 0 NSYN W=10u L=1u
C_gp_1_11_1 gp_1_11_1 0 {Cg}
Mp_1_11_1 a1 gp_1_11_1 colp_L1_11 0 NSYN W=10u L=1u
Mn_1_11_1 a1 vcn coln_L1_11 0 NSYN W=10u L=1u
C_gp_1_11_b gp_1_11_b 0 {Cg}
Mp_1_11_b bx gp_1_11_b colp_L1_11 0 NSYN W=10u L=1u
Mn_1_11_b bx vcn coln_L1_11 0 NSYN W=10u L=1u
Msa_h_L1_11 coln_L1_11 coln_L1_11 0 0 NMIR W=20u L=1u
Msb_h_L1_11 z_L1_11 coln_L1_11 0 0 NMIR W=20u L=1u
Msc_h_L1_11 colp_L1_11 colp_L1_11 0 0 NMIR W=20u L=1u
Msd_h_L1_11 dpf_h_L1_11 colp_L1_11 0 0 NMIR W=20u L=1u
Mse_h_L1_11 dpf_h_L1_11 dpf_h_L1_11 vdd vdd PMIR W=60u L=1u
Msf_h_L1_11 z_L1_11 dpf_h_L1_11 vdd vdd PMIR W=60u L=1u
R_h_L1_11 z_L1_11 vrefh 8000.0
Mr_L1_11  hdd_L1_11 z_L1_11 tail_L1_11 0 NREL W=12u L=1u
Mr2_L1_11 dmp_L1_11  vmid  tail_L1_11 0 NREL W=12u L=1u
Mtl_L1_11 tail_L1_11 vtb 0 0 NREL W=32.0u L=1u
Mdm_L1_11 dmp_L1_11 dmp_L1_11 vdd vdd PMIR W=40u L=1u
Mrp1_L1_11 hdd_L1_11 hdd_L1_11 vdd vdd PMIR W=40u L=1u
Mrp2_L1_11 hv_L1_11 hdd_L1_11 vdd vdd PMIR W=40u L=1u
Rhv_L1_11 hv_L1_11 vg0 8000.0
C_gp_1_12_0 gp_1_12_0 0 {Cg}
Mp_1_12_0 a0 gp_1_12_0 colp_L1_12 0 NSYN W=10u L=1u
Mn_1_12_0 a0 vcn coln_L1_12 0 NSYN W=10u L=1u
C_gp_1_12_1 gp_1_12_1 0 {Cg}
Mp_1_12_1 a1 gp_1_12_1 colp_L1_12 0 NSYN W=10u L=1u
Mn_1_12_1 a1 vcn coln_L1_12 0 NSYN W=10u L=1u
C_gp_1_12_b gp_1_12_b 0 {Cg}
Mp_1_12_b bx gp_1_12_b colp_L1_12 0 NSYN W=10u L=1u
Mn_1_12_b bx vcn coln_L1_12 0 NSYN W=10u L=1u
Msa_h_L1_12 coln_L1_12 coln_L1_12 0 0 NMIR W=20u L=1u
Msb_h_L1_12 z_L1_12 coln_L1_12 0 0 NMIR W=20u L=1u
Msc_h_L1_12 colp_L1_12 colp_L1_12 0 0 NMIR W=20u L=1u
Msd_h_L1_12 dpf_h_L1_12 colp_L1_12 0 0 NMIR W=20u L=1u
Mse_h_L1_12 dpf_h_L1_12 dpf_h_L1_12 vdd vdd PMIR W=60u L=1u
Msf_h_L1_12 z_L1_12 dpf_h_L1_12 vdd vdd PMIR W=60u L=1u
R_h_L1_12 z_L1_12 vrefh 8000.0
Mr_L1_12  hdd_L1_12 z_L1_12 tail_L1_12 0 NREL W=12u L=1u
Mr2_L1_12 dmp_L1_12  vmid  tail_L1_12 0 NREL W=12u L=1u
Mtl_L1_12 tail_L1_12 vtb 0 0 NREL W=32.0u L=1u
Mdm_L1_12 dmp_L1_12 dmp_L1_12 vdd vdd PMIR W=40u L=1u
Mrp1_L1_12 hdd_L1_12 hdd_L1_12 vdd vdd PMIR W=40u L=1u
Mrp2_L1_12 hv_L1_12 hdd_L1_12 vdd vdd PMIR W=40u L=1u
Rhv_L1_12 hv_L1_12 vg0 8000.0
C_gp_1_13_0 gp_1_13_0 0 {Cg}
Mp_1_13_0 a0 gp_1_13_0 colp_L1_13 0 NSYN W=10u L=1u
Mn_1_13_0 a0 vcn coln_L1_13 0 NSYN W=10u L=1u
C_gp_1_13_1 gp_1_13_1 0 {Cg}
Mp_1_13_1 a1 gp_1_13_1 colp_L1_13 0 NSYN W=10u L=1u
Mn_1_13_1 a1 vcn coln_L1_13 0 NSYN W=10u L=1u
C_gp_1_13_b gp_1_13_b 0 {Cg}
Mp_1_13_b bx gp_1_13_b colp_L1_13 0 NSYN W=10u L=1u
Mn_1_13_b bx vcn coln_L1_13 0 NSYN W=10u L=1u
Msa_h_L1_13 coln_L1_13 coln_L1_13 0 0 NMIR W=20u L=1u
Msb_h_L1_13 z_L1_13 coln_L1_13 0 0 NMIR W=20u L=1u
Msc_h_L1_13 colp_L1_13 colp_L1_13 0 0 NMIR W=20u L=1u
Msd_h_L1_13 dpf_h_L1_13 colp_L1_13 0 0 NMIR W=20u L=1u
Mse_h_L1_13 dpf_h_L1_13 dpf_h_L1_13 vdd vdd PMIR W=60u L=1u
Msf_h_L1_13 z_L1_13 dpf_h_L1_13 vdd vdd PMIR W=60u L=1u
R_h_L1_13 z_L1_13 vrefh 8000.0
Mr_L1_13  hdd_L1_13 z_L1_13 tail_L1_13 0 NREL W=12u L=1u
Mr2_L1_13 dmp_L1_13  vmid  tail_L1_13 0 NREL W=12u L=1u
Mtl_L1_13 tail_L1_13 vtb 0 0 NREL W=32.0u L=1u
Mdm_L1_13 dmp_L1_13 dmp_L1_13 vdd vdd PMIR W=40u L=1u
Mrp1_L1_13 hdd_L1_13 hdd_L1_13 vdd vdd PMIR W=40u L=1u
Mrp2_L1_13 hv_L1_13 hdd_L1_13 vdd vdd PMIR W=40u L=1u
Rhv_L1_13 hv_L1_13 vg0 8000.0
C_gp_1_14_0 gp_1_14_0 0 {Cg}
Mp_1_14_0 a0 gp_1_14_0 colp_L1_14 0 NSYN W=10u L=1u
Mn_1_14_0 a0 vcn coln_L1_14 0 NSYN W=10u L=1u
C_gp_1_14_1 gp_1_14_1 0 {Cg}
Mp_1_14_1 a1 gp_1_14_1 colp_L1_14 0 NSYN W=10u L=1u
Mn_1_14_1 a1 vcn coln_L1_14 0 NSYN W=10u L=1u
C_gp_1_14_b gp_1_14_b 0 {Cg}
Mp_1_14_b bx gp_1_14_b colp_L1_14 0 NSYN W=10u L=1u
Mn_1_14_b bx vcn coln_L1_14 0 NSYN W=10u L=1u
Msa_h_L1_14 coln_L1_14 coln_L1_14 0 0 NMIR W=20u L=1u
Msb_h_L1_14 z_L1_14 coln_L1_14 0 0 NMIR W=20u L=1u
Msc_h_L1_14 colp_L1_14 colp_L1_14 0 0 NMIR W=20u L=1u
Msd_h_L1_14 dpf_h_L1_14 colp_L1_14 0 0 NMIR W=20u L=1u
Mse_h_L1_14 dpf_h_L1_14 dpf_h_L1_14 vdd vdd PMIR W=60u L=1u
Msf_h_L1_14 z_L1_14 dpf_h_L1_14 vdd vdd PMIR W=60u L=1u
R_h_L1_14 z_L1_14 vrefh 8000.0
Mr_L1_14  hdd_L1_14 z_L1_14 tail_L1_14 0 NREL W=12u L=1u
Mr2_L1_14 dmp_L1_14  vmid  tail_L1_14 0 NREL W=12u L=1u
Mtl_L1_14 tail_L1_14 vtb 0 0 NREL W=32.0u L=1u
Mdm_L1_14 dmp_L1_14 dmp_L1_14 vdd vdd PMIR W=40u L=1u
Mrp1_L1_14 hdd_L1_14 hdd_L1_14 vdd vdd PMIR W=40u L=1u
Mrp2_L1_14 hv_L1_14 hdd_L1_14 vdd vdd PMIR W=40u L=1u
Rhv_L1_14 hv_L1_14 vg0 8000.0
C_gp_1_15_0 gp_1_15_0 0 {Cg}
Mp_1_15_0 a0 gp_1_15_0 colp_L1_15 0 NSYN W=10u L=1u
Mn_1_15_0 a0 vcn coln_L1_15 0 NSYN W=10u L=1u
C_gp_1_15_1 gp_1_15_1 0 {Cg}
Mp_1_15_1 a1 gp_1_15_1 colp_L1_15 0 NSYN W=10u L=1u
Mn_1_15_1 a1 vcn coln_L1_15 0 NSYN W=10u L=1u
C_gp_1_15_b gp_1_15_b 0 {Cg}
Mp_1_15_b bx gp_1_15_b colp_L1_15 0 NSYN W=10u L=1u
Mn_1_15_b bx vcn coln_L1_15 0 NSYN W=10u L=1u
Msa_h_L1_15 coln_L1_15 coln_L1_15 0 0 NMIR W=20u L=1u
Msb_h_L1_15 z_L1_15 coln_L1_15 0 0 NMIR W=20u L=1u
Msc_h_L1_15 colp_L1_15 colp_L1_15 0 0 NMIR W=20u L=1u
Msd_h_L1_15 dpf_h_L1_15 colp_L1_15 0 0 NMIR W=20u L=1u
Mse_h_L1_15 dpf_h_L1_15 dpf_h_L1_15 vdd vdd PMIR W=60u L=1u
Msf_h_L1_15 z_L1_15 dpf_h_L1_15 vdd vdd PMIR W=60u L=1u
R_h_L1_15 z_L1_15 vrefh 8000.0
Mr_L1_15  hdd_L1_15 z_L1_15 tail_L1_15 0 NREL W=12u L=1u
Mr2_L1_15 dmp_L1_15  vmid  tail_L1_15 0 NREL W=12u L=1u
Mtl_L1_15 tail_L1_15 vtb 0 0 NREL W=32.0u L=1u
Mdm_L1_15 dmp_L1_15 dmp_L1_15 vdd vdd PMIR W=40u L=1u
Mrp1_L1_15 hdd_L1_15 hdd_L1_15 vdd vdd PMIR W=40u L=1u
Mrp2_L1_15 hv_L1_15 hdd_L1_15 vdd vdd PMIR W=40u L=1u
Rhv_L1_15 hv_L1_15 vg0 8000.0
C_gp_1_16_0 gp_1_16_0 0 {Cg}
Mp_1_16_0 a0 gp_1_16_0 colp_L1_16 0 NSYN W=10u L=1u
Mn_1_16_0 a0 vcn coln_L1_16 0 NSYN W=10u L=1u
C_gp_1_16_1 gp_1_16_1 0 {Cg}
Mp_1_16_1 a1 gp_1_16_1 colp_L1_16 0 NSYN W=10u L=1u
Mn_1_16_1 a1 vcn coln_L1_16 0 NSYN W=10u L=1u
C_gp_1_16_b gp_1_16_b 0 {Cg}
Mp_1_16_b bx gp_1_16_b colp_L1_16 0 NSYN W=10u L=1u
Mn_1_16_b bx vcn coln_L1_16 0 NSYN W=10u L=1u
Msa_h_L1_16 coln_L1_16 coln_L1_16 0 0 NMIR W=20u L=1u
Msb_h_L1_16 z_L1_16 coln_L1_16 0 0 NMIR W=20u L=1u
Msc_h_L1_16 colp_L1_16 colp_L1_16 0 0 NMIR W=20u L=1u
Msd_h_L1_16 dpf_h_L1_16 colp_L1_16 0 0 NMIR W=20u L=1u
Mse_h_L1_16 dpf_h_L1_16 dpf_h_L1_16 vdd vdd PMIR W=60u L=1u
Msf_h_L1_16 z_L1_16 dpf_h_L1_16 vdd vdd PMIR W=60u L=1u
R_h_L1_16 z_L1_16 vrefh 8000.0
Mr_L1_16  hdd_L1_16 z_L1_16 tail_L1_16 0 NREL W=12u L=1u
Mr2_L1_16 dmp_L1_16  vmid  tail_L1_16 0 NREL W=12u L=1u
Mtl_L1_16 tail_L1_16 vtb 0 0 NREL W=32.0u L=1u
Mdm_L1_16 dmp_L1_16 dmp_L1_16 vdd vdd PMIR W=40u L=1u
Mrp1_L1_16 hdd_L1_16 hdd_L1_16 vdd vdd PMIR W=40u L=1u
Mrp2_L1_16 hv_L1_16 hdd_L1_16 vdd vdd PMIR W=40u L=1u
Rhv_L1_16 hv_L1_16 vg0 8000.0
C_gp_1_17_0 gp_1_17_0 0 {Cg}
Mp_1_17_0 a0 gp_1_17_0 colp_L1_17 0 NSYN W=10u L=1u
Mn_1_17_0 a0 vcn coln_L1_17 0 NSYN W=10u L=1u
C_gp_1_17_1 gp_1_17_1 0 {Cg}
Mp_1_17_1 a1 gp_1_17_1 colp_L1_17 0 NSYN W=10u L=1u
Mn_1_17_1 a1 vcn coln_L1_17 0 NSYN W=10u L=1u
C_gp_1_17_b gp_1_17_b 0 {Cg}
Mp_1_17_b bx gp_1_17_b colp_L1_17 0 NSYN W=10u L=1u
Mn_1_17_b bx vcn coln_L1_17 0 NSYN W=10u L=1u
Msa_h_L1_17 coln_L1_17 coln_L1_17 0 0 NMIR W=20u L=1u
Msb_h_L1_17 z_L1_17 coln_L1_17 0 0 NMIR W=20u L=1u
Msc_h_L1_17 colp_L1_17 colp_L1_17 0 0 NMIR W=20u L=1u
Msd_h_L1_17 dpf_h_L1_17 colp_L1_17 0 0 NMIR W=20u L=1u
Mse_h_L1_17 dpf_h_L1_17 dpf_h_L1_17 vdd vdd PMIR W=60u L=1u
Msf_h_L1_17 z_L1_17 dpf_h_L1_17 vdd vdd PMIR W=60u L=1u
R_h_L1_17 z_L1_17 vrefh 8000.0
Mr_L1_17  hdd_L1_17 z_L1_17 tail_L1_17 0 NREL W=12u L=1u
Mr2_L1_17 dmp_L1_17  vmid  tail_L1_17 0 NREL W=12u L=1u
Mtl_L1_17 tail_L1_17 vtb 0 0 NREL W=32.0u L=1u
Mdm_L1_17 dmp_L1_17 dmp_L1_17 vdd vdd PMIR W=40u L=1u
Mrp1_L1_17 hdd_L1_17 hdd_L1_17 vdd vdd PMIR W=40u L=1u
Mrp2_L1_17 hv_L1_17 hdd_L1_17 vdd vdd PMIR W=40u L=1u
Rhv_L1_17 hv_L1_17 vg0 8000.0
C_gp_1_18_0 gp_1_18_0 0 {Cg}
Mp_1_18_0 a0 gp_1_18_0 colp_L1_18 0 NSYN W=10u L=1u
Mn_1_18_0 a0 vcn coln_L1_18 0 NSYN W=10u L=1u
C_gp_1_18_1 gp_1_18_1 0 {Cg}
Mp_1_18_1 a1 gp_1_18_1 colp_L1_18 0 NSYN W=10u L=1u
Mn_1_18_1 a1 vcn coln_L1_18 0 NSYN W=10u L=1u
C_gp_1_18_b gp_1_18_b 0 {Cg}
Mp_1_18_b bx gp_1_18_b colp_L1_18 0 NSYN W=10u L=1u
Mn_1_18_b bx vcn coln_L1_18 0 NSYN W=10u L=1u
Msa_h_L1_18 coln_L1_18 coln_L1_18 0 0 NMIR W=20u L=1u
Msb_h_L1_18 z_L1_18 coln_L1_18 0 0 NMIR W=20u L=1u
Msc_h_L1_18 colp_L1_18 colp_L1_18 0 0 NMIR W=20u L=1u
Msd_h_L1_18 dpf_h_L1_18 colp_L1_18 0 0 NMIR W=20u L=1u
Mse_h_L1_18 dpf_h_L1_18 dpf_h_L1_18 vdd vdd PMIR W=60u L=1u
Msf_h_L1_18 z_L1_18 dpf_h_L1_18 vdd vdd PMIR W=60u L=1u
R_h_L1_18 z_L1_18 vrefh 8000.0
Mr_L1_18  hdd_L1_18 z_L1_18 tail_L1_18 0 NREL W=12u L=1u
Mr2_L1_18 dmp_L1_18  vmid  tail_L1_18 0 NREL W=12u L=1u
Mtl_L1_18 tail_L1_18 vtb 0 0 NREL W=32.0u L=1u
Mdm_L1_18 dmp_L1_18 dmp_L1_18 vdd vdd PMIR W=40u L=1u
Mrp1_L1_18 hdd_L1_18 hdd_L1_18 vdd vdd PMIR W=40u L=1u
Mrp2_L1_18 hv_L1_18 hdd_L1_18 vdd vdd PMIR W=40u L=1u
Rhv_L1_18 hv_L1_18 vg0 8000.0
C_gp_1_19_0 gp_1_19_0 0 {Cg}
Mp_1_19_0 a0 gp_1_19_0 colp_L1_19 0 NSYN W=10u L=1u
Mn_1_19_0 a0 vcn coln_L1_19 0 NSYN W=10u L=1u
C_gp_1_19_1 gp_1_19_1 0 {Cg}
Mp_1_19_1 a1 gp_1_19_1 colp_L1_19 0 NSYN W=10u L=1u
Mn_1_19_1 a1 vcn coln_L1_19 0 NSYN W=10u L=1u
C_gp_1_19_b gp_1_19_b 0 {Cg}
Mp_1_19_b bx gp_1_19_b colp_L1_19 0 NSYN W=10u L=1u
Mn_1_19_b bx vcn coln_L1_19 0 NSYN W=10u L=1u
Msa_h_L1_19 coln_L1_19 coln_L1_19 0 0 NMIR W=20u L=1u
Msb_h_L1_19 z_L1_19 coln_L1_19 0 0 NMIR W=20u L=1u
Msc_h_L1_19 colp_L1_19 colp_L1_19 0 0 NMIR W=20u L=1u
Msd_h_L1_19 dpf_h_L1_19 colp_L1_19 0 0 NMIR W=20u L=1u
Mse_h_L1_19 dpf_h_L1_19 dpf_h_L1_19 vdd vdd PMIR W=60u L=1u
Msf_h_L1_19 z_L1_19 dpf_h_L1_19 vdd vdd PMIR W=60u L=1u
R_h_L1_19 z_L1_19 vrefh 8000.0
Mr_L1_19  hdd_L1_19 z_L1_19 tail_L1_19 0 NREL W=12u L=1u
Mr2_L1_19 dmp_L1_19  vmid  tail_L1_19 0 NREL W=12u L=1u
Mtl_L1_19 tail_L1_19 vtb 0 0 NREL W=32.0u L=1u
Mdm_L1_19 dmp_L1_19 dmp_L1_19 vdd vdd PMIR W=40u L=1u
Mrp1_L1_19 hdd_L1_19 hdd_L1_19 vdd vdd PMIR W=40u L=1u
Mrp2_L1_19 hv_L1_19 hdd_L1_19 vdd vdd PMIR W=40u L=1u
Rhv_L1_19 hv_L1_19 vg0 8000.0
C_gp_1_20_0 gp_1_20_0 0 {Cg}
Mp_1_20_0 a0 gp_1_20_0 colp_L1_20 0 NSYN W=10u L=1u
Mn_1_20_0 a0 vcn coln_L1_20 0 NSYN W=10u L=1u
C_gp_1_20_1 gp_1_20_1 0 {Cg}
Mp_1_20_1 a1 gp_1_20_1 colp_L1_20 0 NSYN W=10u L=1u
Mn_1_20_1 a1 vcn coln_L1_20 0 NSYN W=10u L=1u
C_gp_1_20_b gp_1_20_b 0 {Cg}
Mp_1_20_b bx gp_1_20_b colp_L1_20 0 NSYN W=10u L=1u
Mn_1_20_b bx vcn coln_L1_20 0 NSYN W=10u L=1u
Msa_h_L1_20 coln_L1_20 coln_L1_20 0 0 NMIR W=20u L=1u
Msb_h_L1_20 z_L1_20 coln_L1_20 0 0 NMIR W=20u L=1u
Msc_h_L1_20 colp_L1_20 colp_L1_20 0 0 NMIR W=20u L=1u
Msd_h_L1_20 dpf_h_L1_20 colp_L1_20 0 0 NMIR W=20u L=1u
Mse_h_L1_20 dpf_h_L1_20 dpf_h_L1_20 vdd vdd PMIR W=60u L=1u
Msf_h_L1_20 z_L1_20 dpf_h_L1_20 vdd vdd PMIR W=60u L=1u
R_h_L1_20 z_L1_20 vrefh 8000.0
Mr_L1_20  hdd_L1_20 z_L1_20 tail_L1_20 0 NREL W=12u L=1u
Mr2_L1_20 dmp_L1_20  vmid  tail_L1_20 0 NREL W=12u L=1u
Mtl_L1_20 tail_L1_20 vtb 0 0 NREL W=32.0u L=1u
Mdm_L1_20 dmp_L1_20 dmp_L1_20 vdd vdd PMIR W=40u L=1u
Mrp1_L1_20 hdd_L1_20 hdd_L1_20 vdd vdd PMIR W=40u L=1u
Mrp2_L1_20 hv_L1_20 hdd_L1_20 vdd vdd PMIR W=40u L=1u
Rhv_L1_20 hv_L1_20 vg0 8000.0
C_gp_1_21_0 gp_1_21_0 0 {Cg}
Mp_1_21_0 a0 gp_1_21_0 colp_L1_21 0 NSYN W=10u L=1u
Mn_1_21_0 a0 vcn coln_L1_21 0 NSYN W=10u L=1u
C_gp_1_21_1 gp_1_21_1 0 {Cg}
Mp_1_21_1 a1 gp_1_21_1 colp_L1_21 0 NSYN W=10u L=1u
Mn_1_21_1 a1 vcn coln_L1_21 0 NSYN W=10u L=1u
C_gp_1_21_b gp_1_21_b 0 {Cg}
Mp_1_21_b bx gp_1_21_b colp_L1_21 0 NSYN W=10u L=1u
Mn_1_21_b bx vcn coln_L1_21 0 NSYN W=10u L=1u
Msa_h_L1_21 coln_L1_21 coln_L1_21 0 0 NMIR W=20u L=1u
Msb_h_L1_21 z_L1_21 coln_L1_21 0 0 NMIR W=20u L=1u
Msc_h_L1_21 colp_L1_21 colp_L1_21 0 0 NMIR W=20u L=1u
Msd_h_L1_21 dpf_h_L1_21 colp_L1_21 0 0 NMIR W=20u L=1u
Mse_h_L1_21 dpf_h_L1_21 dpf_h_L1_21 vdd vdd PMIR W=60u L=1u
Msf_h_L1_21 z_L1_21 dpf_h_L1_21 vdd vdd PMIR W=60u L=1u
R_h_L1_21 z_L1_21 vrefh 8000.0
Mr_L1_21  hdd_L1_21 z_L1_21 tail_L1_21 0 NREL W=12u L=1u
Mr2_L1_21 dmp_L1_21  vmid  tail_L1_21 0 NREL W=12u L=1u
Mtl_L1_21 tail_L1_21 vtb 0 0 NREL W=32.0u L=1u
Mdm_L1_21 dmp_L1_21 dmp_L1_21 vdd vdd PMIR W=40u L=1u
Mrp1_L1_21 hdd_L1_21 hdd_L1_21 vdd vdd PMIR W=40u L=1u
Mrp2_L1_21 hv_L1_21 hdd_L1_21 vdd vdd PMIR W=40u L=1u
Rhv_L1_21 hv_L1_21 vg0 8000.0
C_gp_1_22_0 gp_1_22_0 0 {Cg}
Mp_1_22_0 a0 gp_1_22_0 colp_L1_22 0 NSYN W=10u L=1u
Mn_1_22_0 a0 vcn coln_L1_22 0 NSYN W=10u L=1u
C_gp_1_22_1 gp_1_22_1 0 {Cg}
Mp_1_22_1 a1 gp_1_22_1 colp_L1_22 0 NSYN W=10u L=1u
Mn_1_22_1 a1 vcn coln_L1_22 0 NSYN W=10u L=1u
C_gp_1_22_b gp_1_22_b 0 {Cg}
Mp_1_22_b bx gp_1_22_b colp_L1_22 0 NSYN W=10u L=1u
Mn_1_22_b bx vcn coln_L1_22 0 NSYN W=10u L=1u
Msa_h_L1_22 coln_L1_22 coln_L1_22 0 0 NMIR W=20u L=1u
Msb_h_L1_22 z_L1_22 coln_L1_22 0 0 NMIR W=20u L=1u
Msc_h_L1_22 colp_L1_22 colp_L1_22 0 0 NMIR W=20u L=1u
Msd_h_L1_22 dpf_h_L1_22 colp_L1_22 0 0 NMIR W=20u L=1u
Mse_h_L1_22 dpf_h_L1_22 dpf_h_L1_22 vdd vdd PMIR W=60u L=1u
Msf_h_L1_22 z_L1_22 dpf_h_L1_22 vdd vdd PMIR W=60u L=1u
R_h_L1_22 z_L1_22 vrefh 8000.0
Mr_L1_22  hdd_L1_22 z_L1_22 tail_L1_22 0 NREL W=12u L=1u
Mr2_L1_22 dmp_L1_22  vmid  tail_L1_22 0 NREL W=12u L=1u
Mtl_L1_22 tail_L1_22 vtb 0 0 NREL W=32.0u L=1u
Mdm_L1_22 dmp_L1_22 dmp_L1_22 vdd vdd PMIR W=40u L=1u
Mrp1_L1_22 hdd_L1_22 hdd_L1_22 vdd vdd PMIR W=40u L=1u
Mrp2_L1_22 hv_L1_22 hdd_L1_22 vdd vdd PMIR W=40u L=1u
Rhv_L1_22 hv_L1_22 vg0 8000.0
C_gp_1_23_0 gp_1_23_0 0 {Cg}
Mp_1_23_0 a0 gp_1_23_0 colp_L1_23 0 NSYN W=10u L=1u
Mn_1_23_0 a0 vcn coln_L1_23 0 NSYN W=10u L=1u
C_gp_1_23_1 gp_1_23_1 0 {Cg}
Mp_1_23_1 a1 gp_1_23_1 colp_L1_23 0 NSYN W=10u L=1u
Mn_1_23_1 a1 vcn coln_L1_23 0 NSYN W=10u L=1u
C_gp_1_23_b gp_1_23_b 0 {Cg}
Mp_1_23_b bx gp_1_23_b colp_L1_23 0 NSYN W=10u L=1u
Mn_1_23_b bx vcn coln_L1_23 0 NSYN W=10u L=1u
Msa_h_L1_23 coln_L1_23 coln_L1_23 0 0 NMIR W=20u L=1u
Msb_h_L1_23 z_L1_23 coln_L1_23 0 0 NMIR W=20u L=1u
Msc_h_L1_23 colp_L1_23 colp_L1_23 0 0 NMIR W=20u L=1u
Msd_h_L1_23 dpf_h_L1_23 colp_L1_23 0 0 NMIR W=20u L=1u
Mse_h_L1_23 dpf_h_L1_23 dpf_h_L1_23 vdd vdd PMIR W=60u L=1u
Msf_h_L1_23 z_L1_23 dpf_h_L1_23 vdd vdd PMIR W=60u L=1u
R_h_L1_23 z_L1_23 vrefh 8000.0
Mr_L1_23  hdd_L1_23 z_L1_23 tail_L1_23 0 NREL W=12u L=1u
Mr2_L1_23 dmp_L1_23  vmid  tail_L1_23 0 NREL W=12u L=1u
Mtl_L1_23 tail_L1_23 vtb 0 0 NREL W=32.0u L=1u
Mdm_L1_23 dmp_L1_23 dmp_L1_23 vdd vdd PMIR W=40u L=1u
Mrp1_L1_23 hdd_L1_23 hdd_L1_23 vdd vdd PMIR W=40u L=1u
Mrp2_L1_23 hv_L1_23 hdd_L1_23 vdd vdd PMIR W=40u L=1u
Rhv_L1_23 hv_L1_23 vg0 8000.0
C_gp_1_24_0 gp_1_24_0 0 {Cg}
Mp_1_24_0 a0 gp_1_24_0 colp_L1_24 0 NSYN W=10u L=1u
Mn_1_24_0 a0 vcn coln_L1_24 0 NSYN W=10u L=1u
C_gp_1_24_1 gp_1_24_1 0 {Cg}
Mp_1_24_1 a1 gp_1_24_1 colp_L1_24 0 NSYN W=10u L=1u
Mn_1_24_1 a1 vcn coln_L1_24 0 NSYN W=10u L=1u
C_gp_1_24_b gp_1_24_b 0 {Cg}
Mp_1_24_b bx gp_1_24_b colp_L1_24 0 NSYN W=10u L=1u
Mn_1_24_b bx vcn coln_L1_24 0 NSYN W=10u L=1u
Msa_h_L1_24 coln_L1_24 coln_L1_24 0 0 NMIR W=20u L=1u
Msb_h_L1_24 z_L1_24 coln_L1_24 0 0 NMIR W=20u L=1u
Msc_h_L1_24 colp_L1_24 colp_L1_24 0 0 NMIR W=20u L=1u
Msd_h_L1_24 dpf_h_L1_24 colp_L1_24 0 0 NMIR W=20u L=1u
Mse_h_L1_24 dpf_h_L1_24 dpf_h_L1_24 vdd vdd PMIR W=60u L=1u
Msf_h_L1_24 z_L1_24 dpf_h_L1_24 vdd vdd PMIR W=60u L=1u
R_h_L1_24 z_L1_24 vrefh 8000.0
Mr_L1_24  hdd_L1_24 z_L1_24 tail_L1_24 0 NREL W=12u L=1u
Mr2_L1_24 dmp_L1_24  vmid  tail_L1_24 0 NREL W=12u L=1u
Mtl_L1_24 tail_L1_24 vtb 0 0 NREL W=32.0u L=1u
Mdm_L1_24 dmp_L1_24 dmp_L1_24 vdd vdd PMIR W=40u L=1u
Mrp1_L1_24 hdd_L1_24 hdd_L1_24 vdd vdd PMIR W=40u L=1u
Mrp2_L1_24 hv_L1_24 hdd_L1_24 vdd vdd PMIR W=40u L=1u
Rhv_L1_24 hv_L1_24 vg0 8000.0
C_gp_1_25_0 gp_1_25_0 0 {Cg}
Mp_1_25_0 a0 gp_1_25_0 colp_L1_25 0 NSYN W=10u L=1u
Mn_1_25_0 a0 vcn coln_L1_25 0 NSYN W=10u L=1u
C_gp_1_25_1 gp_1_25_1 0 {Cg}
Mp_1_25_1 a1 gp_1_25_1 colp_L1_25 0 NSYN W=10u L=1u
Mn_1_25_1 a1 vcn coln_L1_25 0 NSYN W=10u L=1u
C_gp_1_25_b gp_1_25_b 0 {Cg}
Mp_1_25_b bx gp_1_25_b colp_L1_25 0 NSYN W=10u L=1u
Mn_1_25_b bx vcn coln_L1_25 0 NSYN W=10u L=1u
Msa_h_L1_25 coln_L1_25 coln_L1_25 0 0 NMIR W=20u L=1u
Msb_h_L1_25 z_L1_25 coln_L1_25 0 0 NMIR W=20u L=1u
Msc_h_L1_25 colp_L1_25 colp_L1_25 0 0 NMIR W=20u L=1u
Msd_h_L1_25 dpf_h_L1_25 colp_L1_25 0 0 NMIR W=20u L=1u
Mse_h_L1_25 dpf_h_L1_25 dpf_h_L1_25 vdd vdd PMIR W=60u L=1u
Msf_h_L1_25 z_L1_25 dpf_h_L1_25 vdd vdd PMIR W=60u L=1u
R_h_L1_25 z_L1_25 vrefh 8000.0
Mr_L1_25  hdd_L1_25 z_L1_25 tail_L1_25 0 NREL W=12u L=1u
Mr2_L1_25 dmp_L1_25  vmid  tail_L1_25 0 NREL W=12u L=1u
Mtl_L1_25 tail_L1_25 vtb 0 0 NREL W=32.0u L=1u
Mdm_L1_25 dmp_L1_25 dmp_L1_25 vdd vdd PMIR W=40u L=1u
Mrp1_L1_25 hdd_L1_25 hdd_L1_25 vdd vdd PMIR W=40u L=1u
Mrp2_L1_25 hv_L1_25 hdd_L1_25 vdd vdd PMIR W=40u L=1u
Rhv_L1_25 hv_L1_25 vg0 8000.0
C_gp_1_26_0 gp_1_26_0 0 {Cg}
Mp_1_26_0 a0 gp_1_26_0 colp_L1_26 0 NSYN W=10u L=1u
Mn_1_26_0 a0 vcn coln_L1_26 0 NSYN W=10u L=1u
C_gp_1_26_1 gp_1_26_1 0 {Cg}
Mp_1_26_1 a1 gp_1_26_1 colp_L1_26 0 NSYN W=10u L=1u
Mn_1_26_1 a1 vcn coln_L1_26 0 NSYN W=10u L=1u
C_gp_1_26_b gp_1_26_b 0 {Cg}
Mp_1_26_b bx gp_1_26_b colp_L1_26 0 NSYN W=10u L=1u
Mn_1_26_b bx vcn coln_L1_26 0 NSYN W=10u L=1u
Msa_h_L1_26 coln_L1_26 coln_L1_26 0 0 NMIR W=20u L=1u
Msb_h_L1_26 z_L1_26 coln_L1_26 0 0 NMIR W=20u L=1u
Msc_h_L1_26 colp_L1_26 colp_L1_26 0 0 NMIR W=20u L=1u
Msd_h_L1_26 dpf_h_L1_26 colp_L1_26 0 0 NMIR W=20u L=1u
Mse_h_L1_26 dpf_h_L1_26 dpf_h_L1_26 vdd vdd PMIR W=60u L=1u
Msf_h_L1_26 z_L1_26 dpf_h_L1_26 vdd vdd PMIR W=60u L=1u
R_h_L1_26 z_L1_26 vrefh 8000.0
Mr_L1_26  hdd_L1_26 z_L1_26 tail_L1_26 0 NREL W=12u L=1u
Mr2_L1_26 dmp_L1_26  vmid  tail_L1_26 0 NREL W=12u L=1u
Mtl_L1_26 tail_L1_26 vtb 0 0 NREL W=32.0u L=1u
Mdm_L1_26 dmp_L1_26 dmp_L1_26 vdd vdd PMIR W=40u L=1u
Mrp1_L1_26 hdd_L1_26 hdd_L1_26 vdd vdd PMIR W=40u L=1u
Mrp2_L1_26 hv_L1_26 hdd_L1_26 vdd vdd PMIR W=40u L=1u
Rhv_L1_26 hv_L1_26 vg0 8000.0
C_gp_1_27_0 gp_1_27_0 0 {Cg}
Mp_1_27_0 a0 gp_1_27_0 colp_L1_27 0 NSYN W=10u L=1u
Mn_1_27_0 a0 vcn coln_L1_27 0 NSYN W=10u L=1u
C_gp_1_27_1 gp_1_27_1 0 {Cg}
Mp_1_27_1 a1 gp_1_27_1 colp_L1_27 0 NSYN W=10u L=1u
Mn_1_27_1 a1 vcn coln_L1_27 0 NSYN W=10u L=1u
C_gp_1_27_b gp_1_27_b 0 {Cg}
Mp_1_27_b bx gp_1_27_b colp_L1_27 0 NSYN W=10u L=1u
Mn_1_27_b bx vcn coln_L1_27 0 NSYN W=10u L=1u
Msa_h_L1_27 coln_L1_27 coln_L1_27 0 0 NMIR W=20u L=1u
Msb_h_L1_27 z_L1_27 coln_L1_27 0 0 NMIR W=20u L=1u
Msc_h_L1_27 colp_L1_27 colp_L1_27 0 0 NMIR W=20u L=1u
Msd_h_L1_27 dpf_h_L1_27 colp_L1_27 0 0 NMIR W=20u L=1u
Mse_h_L1_27 dpf_h_L1_27 dpf_h_L1_27 vdd vdd PMIR W=60u L=1u
Msf_h_L1_27 z_L1_27 dpf_h_L1_27 vdd vdd PMIR W=60u L=1u
R_h_L1_27 z_L1_27 vrefh 8000.0
Mr_L1_27  hdd_L1_27 z_L1_27 tail_L1_27 0 NREL W=12u L=1u
Mr2_L1_27 dmp_L1_27  vmid  tail_L1_27 0 NREL W=12u L=1u
Mtl_L1_27 tail_L1_27 vtb 0 0 NREL W=32.0u L=1u
Mdm_L1_27 dmp_L1_27 dmp_L1_27 vdd vdd PMIR W=40u L=1u
Mrp1_L1_27 hdd_L1_27 hdd_L1_27 vdd vdd PMIR W=40u L=1u
Mrp2_L1_27 hv_L1_27 hdd_L1_27 vdd vdd PMIR W=40u L=1u
Rhv_L1_27 hv_L1_27 vg0 8000.0
C_gp_1_28_0 gp_1_28_0 0 {Cg}
Mp_1_28_0 a0 gp_1_28_0 colp_L1_28 0 NSYN W=10u L=1u
Mn_1_28_0 a0 vcn coln_L1_28 0 NSYN W=10u L=1u
C_gp_1_28_1 gp_1_28_1 0 {Cg}
Mp_1_28_1 a1 gp_1_28_1 colp_L1_28 0 NSYN W=10u L=1u
Mn_1_28_1 a1 vcn coln_L1_28 0 NSYN W=10u L=1u
C_gp_1_28_b gp_1_28_b 0 {Cg}
Mp_1_28_b bx gp_1_28_b colp_L1_28 0 NSYN W=10u L=1u
Mn_1_28_b bx vcn coln_L1_28 0 NSYN W=10u L=1u
Msa_h_L1_28 coln_L1_28 coln_L1_28 0 0 NMIR W=20u L=1u
Msb_h_L1_28 z_L1_28 coln_L1_28 0 0 NMIR W=20u L=1u
Msc_h_L1_28 colp_L1_28 colp_L1_28 0 0 NMIR W=20u L=1u
Msd_h_L1_28 dpf_h_L1_28 colp_L1_28 0 0 NMIR W=20u L=1u
Mse_h_L1_28 dpf_h_L1_28 dpf_h_L1_28 vdd vdd PMIR W=60u L=1u
Msf_h_L1_28 z_L1_28 dpf_h_L1_28 vdd vdd PMIR W=60u L=1u
R_h_L1_28 z_L1_28 vrefh 8000.0
Mr_L1_28  hdd_L1_28 z_L1_28 tail_L1_28 0 NREL W=12u L=1u
Mr2_L1_28 dmp_L1_28  vmid  tail_L1_28 0 NREL W=12u L=1u
Mtl_L1_28 tail_L1_28 vtb 0 0 NREL W=32.0u L=1u
Mdm_L1_28 dmp_L1_28 dmp_L1_28 vdd vdd PMIR W=40u L=1u
Mrp1_L1_28 hdd_L1_28 hdd_L1_28 vdd vdd PMIR W=40u L=1u
Mrp2_L1_28 hv_L1_28 hdd_L1_28 vdd vdd PMIR W=40u L=1u
Rhv_L1_28 hv_L1_28 vg0 8000.0
C_gp_1_29_0 gp_1_29_0 0 {Cg}
Mp_1_29_0 a0 gp_1_29_0 colp_L1_29 0 NSYN W=10u L=1u
Mn_1_29_0 a0 vcn coln_L1_29 0 NSYN W=10u L=1u
C_gp_1_29_1 gp_1_29_1 0 {Cg}
Mp_1_29_1 a1 gp_1_29_1 colp_L1_29 0 NSYN W=10u L=1u
Mn_1_29_1 a1 vcn coln_L1_29 0 NSYN W=10u L=1u
C_gp_1_29_b gp_1_29_b 0 {Cg}
Mp_1_29_b bx gp_1_29_b colp_L1_29 0 NSYN W=10u L=1u
Mn_1_29_b bx vcn coln_L1_29 0 NSYN W=10u L=1u
Msa_h_L1_29 coln_L1_29 coln_L1_29 0 0 NMIR W=20u L=1u
Msb_h_L1_29 z_L1_29 coln_L1_29 0 0 NMIR W=20u L=1u
Msc_h_L1_29 colp_L1_29 colp_L1_29 0 0 NMIR W=20u L=1u
Msd_h_L1_29 dpf_h_L1_29 colp_L1_29 0 0 NMIR W=20u L=1u
Mse_h_L1_29 dpf_h_L1_29 dpf_h_L1_29 vdd vdd PMIR W=60u L=1u
Msf_h_L1_29 z_L1_29 dpf_h_L1_29 vdd vdd PMIR W=60u L=1u
R_h_L1_29 z_L1_29 vrefh 8000.0
Mr_L1_29  hdd_L1_29 z_L1_29 tail_L1_29 0 NREL W=12u L=1u
Mr2_L1_29 dmp_L1_29  vmid  tail_L1_29 0 NREL W=12u L=1u
Mtl_L1_29 tail_L1_29 vtb 0 0 NREL W=32.0u L=1u
Mdm_L1_29 dmp_L1_29 dmp_L1_29 vdd vdd PMIR W=40u L=1u
Mrp1_L1_29 hdd_L1_29 hdd_L1_29 vdd vdd PMIR W=40u L=1u
Mrp2_L1_29 hv_L1_29 hdd_L1_29 vdd vdd PMIR W=40u L=1u
Rhv_L1_29 hv_L1_29 vg0 8000.0
C_gp_1_30_0 gp_1_30_0 0 {Cg}
Mp_1_30_0 a0 gp_1_30_0 colp_L1_30 0 NSYN W=10u L=1u
Mn_1_30_0 a0 vcn coln_L1_30 0 NSYN W=10u L=1u
C_gp_1_30_1 gp_1_30_1 0 {Cg}
Mp_1_30_1 a1 gp_1_30_1 colp_L1_30 0 NSYN W=10u L=1u
Mn_1_30_1 a1 vcn coln_L1_30 0 NSYN W=10u L=1u
C_gp_1_30_b gp_1_30_b 0 {Cg}
Mp_1_30_b bx gp_1_30_b colp_L1_30 0 NSYN W=10u L=1u
Mn_1_30_b bx vcn coln_L1_30 0 NSYN W=10u L=1u
Msa_h_L1_30 coln_L1_30 coln_L1_30 0 0 NMIR W=20u L=1u
Msb_h_L1_30 z_L1_30 coln_L1_30 0 0 NMIR W=20u L=1u
Msc_h_L1_30 colp_L1_30 colp_L1_30 0 0 NMIR W=20u L=1u
Msd_h_L1_30 dpf_h_L1_30 colp_L1_30 0 0 NMIR W=20u L=1u
Mse_h_L1_30 dpf_h_L1_30 dpf_h_L1_30 vdd vdd PMIR W=60u L=1u
Msf_h_L1_30 z_L1_30 dpf_h_L1_30 vdd vdd PMIR W=60u L=1u
R_h_L1_30 z_L1_30 vrefh 8000.0
Mr_L1_30  hdd_L1_30 z_L1_30 tail_L1_30 0 NREL W=12u L=1u
Mr2_L1_30 dmp_L1_30  vmid  tail_L1_30 0 NREL W=12u L=1u
Mtl_L1_30 tail_L1_30 vtb 0 0 NREL W=32.0u L=1u
Mdm_L1_30 dmp_L1_30 dmp_L1_30 vdd vdd PMIR W=40u L=1u
Mrp1_L1_30 hdd_L1_30 hdd_L1_30 vdd vdd PMIR W=40u L=1u
Mrp2_L1_30 hv_L1_30 hdd_L1_30 vdd vdd PMIR W=40u L=1u
Rhv_L1_30 hv_L1_30 vg0 8000.0
C_gp_1_31_0 gp_1_31_0 0 {Cg}
Mp_1_31_0 a0 gp_1_31_0 colp_L1_31 0 NSYN W=10u L=1u
Mn_1_31_0 a0 vcn coln_L1_31 0 NSYN W=10u L=1u
C_gp_1_31_1 gp_1_31_1 0 {Cg}
Mp_1_31_1 a1 gp_1_31_1 colp_L1_31 0 NSYN W=10u L=1u
Mn_1_31_1 a1 vcn coln_L1_31 0 NSYN W=10u L=1u
C_gp_1_31_b gp_1_31_b 0 {Cg}
Mp_1_31_b bx gp_1_31_b colp_L1_31 0 NSYN W=10u L=1u
Mn_1_31_b bx vcn coln_L1_31 0 NSYN W=10u L=1u
Msa_h_L1_31 coln_L1_31 coln_L1_31 0 0 NMIR W=20u L=1u
Msb_h_L1_31 z_L1_31 coln_L1_31 0 0 NMIR W=20u L=1u
Msc_h_L1_31 colp_L1_31 colp_L1_31 0 0 NMIR W=20u L=1u
Msd_h_L1_31 dpf_h_L1_31 colp_L1_31 0 0 NMIR W=20u L=1u
Mse_h_L1_31 dpf_h_L1_31 dpf_h_L1_31 vdd vdd PMIR W=60u L=1u
Msf_h_L1_31 z_L1_31 dpf_h_L1_31 vdd vdd PMIR W=60u L=1u
R_h_L1_31 z_L1_31 vrefh 8000.0
Mr_L1_31  hdd_L1_31 z_L1_31 tail_L1_31 0 NREL W=12u L=1u
Mr2_L1_31 dmp_L1_31  vmid  tail_L1_31 0 NREL W=12u L=1u
Mtl_L1_31 tail_L1_31 vtb 0 0 NREL W=32.0u L=1u
Mdm_L1_31 dmp_L1_31 dmp_L1_31 vdd vdd PMIR W=40u L=1u
Mrp1_L1_31 hdd_L1_31 hdd_L1_31 vdd vdd PMIR W=40u L=1u
Mrp2_L1_31 hv_L1_31 hdd_L1_31 vdd vdd PMIR W=40u L=1u
Rhv_L1_31 hv_L1_31 vg0 8000.0
C_gp_1_32_0 gp_1_32_0 0 {Cg}
Mp_1_32_0 a0 gp_1_32_0 colp_L1_32 0 NSYN W=10u L=1u
Mn_1_32_0 a0 vcn coln_L1_32 0 NSYN W=10u L=1u
C_gp_1_32_1 gp_1_32_1 0 {Cg}
Mp_1_32_1 a1 gp_1_32_1 colp_L1_32 0 NSYN W=10u L=1u
Mn_1_32_1 a1 vcn coln_L1_32 0 NSYN W=10u L=1u
C_gp_1_32_b gp_1_32_b 0 {Cg}
Mp_1_32_b bx gp_1_32_b colp_L1_32 0 NSYN W=10u L=1u
Mn_1_32_b bx vcn coln_L1_32 0 NSYN W=10u L=1u
Msa_h_L1_32 coln_L1_32 coln_L1_32 0 0 NMIR W=20u L=1u
Msb_h_L1_32 z_L1_32 coln_L1_32 0 0 NMIR W=20u L=1u
Msc_h_L1_32 colp_L1_32 colp_L1_32 0 0 NMIR W=20u L=1u
Msd_h_L1_32 dpf_h_L1_32 colp_L1_32 0 0 NMIR W=20u L=1u
Mse_h_L1_32 dpf_h_L1_32 dpf_h_L1_32 vdd vdd PMIR W=60u L=1u
Msf_h_L1_32 z_L1_32 dpf_h_L1_32 vdd vdd PMIR W=60u L=1u
R_h_L1_32 z_L1_32 vrefh 8000.0
Mr_L1_32  hdd_L1_32 z_L1_32 tail_L1_32 0 NREL W=12u L=1u
Mr2_L1_32 dmp_L1_32  vmid  tail_L1_32 0 NREL W=12u L=1u
Mtl_L1_32 tail_L1_32 vtb 0 0 NREL W=32.0u L=1u
Mdm_L1_32 dmp_L1_32 dmp_L1_32 vdd vdd PMIR W=40u L=1u
Mrp1_L1_32 hdd_L1_32 hdd_L1_32 vdd vdd PMIR W=40u L=1u
Mrp2_L1_32 hv_L1_32 hdd_L1_32 vdd vdd PMIR W=40u L=1u
Rhv_L1_32 hv_L1_32 vg0 8000.0
C_gp_1_33_0 gp_1_33_0 0 {Cg}
Mp_1_33_0 a0 gp_1_33_0 colp_L1_33 0 NSYN W=10u L=1u
Mn_1_33_0 a0 vcn coln_L1_33 0 NSYN W=10u L=1u
C_gp_1_33_1 gp_1_33_1 0 {Cg}
Mp_1_33_1 a1 gp_1_33_1 colp_L1_33 0 NSYN W=10u L=1u
Mn_1_33_1 a1 vcn coln_L1_33 0 NSYN W=10u L=1u
C_gp_1_33_b gp_1_33_b 0 {Cg}
Mp_1_33_b bx gp_1_33_b colp_L1_33 0 NSYN W=10u L=1u
Mn_1_33_b bx vcn coln_L1_33 0 NSYN W=10u L=1u
Msa_h_L1_33 coln_L1_33 coln_L1_33 0 0 NMIR W=20u L=1u
Msb_h_L1_33 z_L1_33 coln_L1_33 0 0 NMIR W=20u L=1u
Msc_h_L1_33 colp_L1_33 colp_L1_33 0 0 NMIR W=20u L=1u
Msd_h_L1_33 dpf_h_L1_33 colp_L1_33 0 0 NMIR W=20u L=1u
Mse_h_L1_33 dpf_h_L1_33 dpf_h_L1_33 vdd vdd PMIR W=60u L=1u
Msf_h_L1_33 z_L1_33 dpf_h_L1_33 vdd vdd PMIR W=60u L=1u
R_h_L1_33 z_L1_33 vrefh 8000.0
Mr_L1_33  hdd_L1_33 z_L1_33 tail_L1_33 0 NREL W=12u L=1u
Mr2_L1_33 dmp_L1_33  vmid  tail_L1_33 0 NREL W=12u L=1u
Mtl_L1_33 tail_L1_33 vtb 0 0 NREL W=32.0u L=1u
Mdm_L1_33 dmp_L1_33 dmp_L1_33 vdd vdd PMIR W=40u L=1u
Mrp1_L1_33 hdd_L1_33 hdd_L1_33 vdd vdd PMIR W=40u L=1u
Mrp2_L1_33 hv_L1_33 hdd_L1_33 vdd vdd PMIR W=40u L=1u
Rhv_L1_33 hv_L1_33 vg0 8000.0
C_gp_1_34_0 gp_1_34_0 0 {Cg}
Mp_1_34_0 a0 gp_1_34_0 colp_L1_34 0 NSYN W=10u L=1u
Mn_1_34_0 a0 vcn coln_L1_34 0 NSYN W=10u L=1u
C_gp_1_34_1 gp_1_34_1 0 {Cg}
Mp_1_34_1 a1 gp_1_34_1 colp_L1_34 0 NSYN W=10u L=1u
Mn_1_34_1 a1 vcn coln_L1_34 0 NSYN W=10u L=1u
C_gp_1_34_b gp_1_34_b 0 {Cg}
Mp_1_34_b bx gp_1_34_b colp_L1_34 0 NSYN W=10u L=1u
Mn_1_34_b bx vcn coln_L1_34 0 NSYN W=10u L=1u
Msa_h_L1_34 coln_L1_34 coln_L1_34 0 0 NMIR W=20u L=1u
Msb_h_L1_34 z_L1_34 coln_L1_34 0 0 NMIR W=20u L=1u
Msc_h_L1_34 colp_L1_34 colp_L1_34 0 0 NMIR W=20u L=1u
Msd_h_L1_34 dpf_h_L1_34 colp_L1_34 0 0 NMIR W=20u L=1u
Mse_h_L1_34 dpf_h_L1_34 dpf_h_L1_34 vdd vdd PMIR W=60u L=1u
Msf_h_L1_34 z_L1_34 dpf_h_L1_34 vdd vdd PMIR W=60u L=1u
R_h_L1_34 z_L1_34 vrefh 8000.0
Mr_L1_34  hdd_L1_34 z_L1_34 tail_L1_34 0 NREL W=12u L=1u
Mr2_L1_34 dmp_L1_34  vmid  tail_L1_34 0 NREL W=12u L=1u
Mtl_L1_34 tail_L1_34 vtb 0 0 NREL W=32.0u L=1u
Mdm_L1_34 dmp_L1_34 dmp_L1_34 vdd vdd PMIR W=40u L=1u
Mrp1_L1_34 hdd_L1_34 hdd_L1_34 vdd vdd PMIR W=40u L=1u
Mrp2_L1_34 hv_L1_34 hdd_L1_34 vdd vdd PMIR W=40u L=1u
Rhv_L1_34 hv_L1_34 vg0 8000.0
C_gp_1_35_0 gp_1_35_0 0 {Cg}
Mp_1_35_0 a0 gp_1_35_0 colp_L1_35 0 NSYN W=10u L=1u
Mn_1_35_0 a0 vcn coln_L1_35 0 NSYN W=10u L=1u
C_gp_1_35_1 gp_1_35_1 0 {Cg}
Mp_1_35_1 a1 gp_1_35_1 colp_L1_35 0 NSYN W=10u L=1u
Mn_1_35_1 a1 vcn coln_L1_35 0 NSYN W=10u L=1u
C_gp_1_35_b gp_1_35_b 0 {Cg}
Mp_1_35_b bx gp_1_35_b colp_L1_35 0 NSYN W=10u L=1u
Mn_1_35_b bx vcn coln_L1_35 0 NSYN W=10u L=1u
Msa_h_L1_35 coln_L1_35 coln_L1_35 0 0 NMIR W=20u L=1u
Msb_h_L1_35 z_L1_35 coln_L1_35 0 0 NMIR W=20u L=1u
Msc_h_L1_35 colp_L1_35 colp_L1_35 0 0 NMIR W=20u L=1u
Msd_h_L1_35 dpf_h_L1_35 colp_L1_35 0 0 NMIR W=20u L=1u
Mse_h_L1_35 dpf_h_L1_35 dpf_h_L1_35 vdd vdd PMIR W=60u L=1u
Msf_h_L1_35 z_L1_35 dpf_h_L1_35 vdd vdd PMIR W=60u L=1u
R_h_L1_35 z_L1_35 vrefh 8000.0
Mr_L1_35  hdd_L1_35 z_L1_35 tail_L1_35 0 NREL W=12u L=1u
Mr2_L1_35 dmp_L1_35  vmid  tail_L1_35 0 NREL W=12u L=1u
Mtl_L1_35 tail_L1_35 vtb 0 0 NREL W=32.0u L=1u
Mdm_L1_35 dmp_L1_35 dmp_L1_35 vdd vdd PMIR W=40u L=1u
Mrp1_L1_35 hdd_L1_35 hdd_L1_35 vdd vdd PMIR W=40u L=1u
Mrp2_L1_35 hv_L1_35 hdd_L1_35 vdd vdd PMIR W=40u L=1u
Rhv_L1_35 hv_L1_35 vg0 8000.0
C_gp_1_36_0 gp_1_36_0 0 {Cg}
Mp_1_36_0 a0 gp_1_36_0 colp_L1_36 0 NSYN W=10u L=1u
Mn_1_36_0 a0 vcn coln_L1_36 0 NSYN W=10u L=1u
C_gp_1_36_1 gp_1_36_1 0 {Cg}
Mp_1_36_1 a1 gp_1_36_1 colp_L1_36 0 NSYN W=10u L=1u
Mn_1_36_1 a1 vcn coln_L1_36 0 NSYN W=10u L=1u
C_gp_1_36_b gp_1_36_b 0 {Cg}
Mp_1_36_b bx gp_1_36_b colp_L1_36 0 NSYN W=10u L=1u
Mn_1_36_b bx vcn coln_L1_36 0 NSYN W=10u L=1u
Msa_h_L1_36 coln_L1_36 coln_L1_36 0 0 NMIR W=20u L=1u
Msb_h_L1_36 z_L1_36 coln_L1_36 0 0 NMIR W=20u L=1u
Msc_h_L1_36 colp_L1_36 colp_L1_36 0 0 NMIR W=20u L=1u
Msd_h_L1_36 dpf_h_L1_36 colp_L1_36 0 0 NMIR W=20u L=1u
Mse_h_L1_36 dpf_h_L1_36 dpf_h_L1_36 vdd vdd PMIR W=60u L=1u
Msf_h_L1_36 z_L1_36 dpf_h_L1_36 vdd vdd PMIR W=60u L=1u
R_h_L1_36 z_L1_36 vrefh 8000.0
Mr_L1_36  hdd_L1_36 z_L1_36 tail_L1_36 0 NREL W=12u L=1u
Mr2_L1_36 dmp_L1_36  vmid  tail_L1_36 0 NREL W=12u L=1u
Mtl_L1_36 tail_L1_36 vtb 0 0 NREL W=32.0u L=1u
Mdm_L1_36 dmp_L1_36 dmp_L1_36 vdd vdd PMIR W=40u L=1u
Mrp1_L1_36 hdd_L1_36 hdd_L1_36 vdd vdd PMIR W=40u L=1u
Mrp2_L1_36 hv_L1_36 hdd_L1_36 vdd vdd PMIR W=40u L=1u
Rhv_L1_36 hv_L1_36 vg0 8000.0
C_gp_1_37_0 gp_1_37_0 0 {Cg}
Mp_1_37_0 a0 gp_1_37_0 colp_L1_37 0 NSYN W=10u L=1u
Mn_1_37_0 a0 vcn coln_L1_37 0 NSYN W=10u L=1u
C_gp_1_37_1 gp_1_37_1 0 {Cg}
Mp_1_37_1 a1 gp_1_37_1 colp_L1_37 0 NSYN W=10u L=1u
Mn_1_37_1 a1 vcn coln_L1_37 0 NSYN W=10u L=1u
C_gp_1_37_b gp_1_37_b 0 {Cg}
Mp_1_37_b bx gp_1_37_b colp_L1_37 0 NSYN W=10u L=1u
Mn_1_37_b bx vcn coln_L1_37 0 NSYN W=10u L=1u
Msa_h_L1_37 coln_L1_37 coln_L1_37 0 0 NMIR W=20u L=1u
Msb_h_L1_37 z_L1_37 coln_L1_37 0 0 NMIR W=20u L=1u
Msc_h_L1_37 colp_L1_37 colp_L1_37 0 0 NMIR W=20u L=1u
Msd_h_L1_37 dpf_h_L1_37 colp_L1_37 0 0 NMIR W=20u L=1u
Mse_h_L1_37 dpf_h_L1_37 dpf_h_L1_37 vdd vdd PMIR W=60u L=1u
Msf_h_L1_37 z_L1_37 dpf_h_L1_37 vdd vdd PMIR W=60u L=1u
R_h_L1_37 z_L1_37 vrefh 8000.0
Mr_L1_37  hdd_L1_37 z_L1_37 tail_L1_37 0 NREL W=12u L=1u
Mr2_L1_37 dmp_L1_37  vmid  tail_L1_37 0 NREL W=12u L=1u
Mtl_L1_37 tail_L1_37 vtb 0 0 NREL W=32.0u L=1u
Mdm_L1_37 dmp_L1_37 dmp_L1_37 vdd vdd PMIR W=40u L=1u
Mrp1_L1_37 hdd_L1_37 hdd_L1_37 vdd vdd PMIR W=40u L=1u
Mrp2_L1_37 hv_L1_37 hdd_L1_37 vdd vdd PMIR W=40u L=1u
Rhv_L1_37 hv_L1_37 vg0 8000.0
C_gp_1_38_0 gp_1_38_0 0 {Cg}
Mp_1_38_0 a0 gp_1_38_0 colp_L1_38 0 NSYN W=10u L=1u
Mn_1_38_0 a0 vcn coln_L1_38 0 NSYN W=10u L=1u
C_gp_1_38_1 gp_1_38_1 0 {Cg}
Mp_1_38_1 a1 gp_1_38_1 colp_L1_38 0 NSYN W=10u L=1u
Mn_1_38_1 a1 vcn coln_L1_38 0 NSYN W=10u L=1u
C_gp_1_38_b gp_1_38_b 0 {Cg}
Mp_1_38_b bx gp_1_38_b colp_L1_38 0 NSYN W=10u L=1u
Mn_1_38_b bx vcn coln_L1_38 0 NSYN W=10u L=1u
Msa_h_L1_38 coln_L1_38 coln_L1_38 0 0 NMIR W=20u L=1u
Msb_h_L1_38 z_L1_38 coln_L1_38 0 0 NMIR W=20u L=1u
Msc_h_L1_38 colp_L1_38 colp_L1_38 0 0 NMIR W=20u L=1u
Msd_h_L1_38 dpf_h_L1_38 colp_L1_38 0 0 NMIR W=20u L=1u
Mse_h_L1_38 dpf_h_L1_38 dpf_h_L1_38 vdd vdd PMIR W=60u L=1u
Msf_h_L1_38 z_L1_38 dpf_h_L1_38 vdd vdd PMIR W=60u L=1u
R_h_L1_38 z_L1_38 vrefh 8000.0
Mr_L1_38  hdd_L1_38 z_L1_38 tail_L1_38 0 NREL W=12u L=1u
Mr2_L1_38 dmp_L1_38  vmid  tail_L1_38 0 NREL W=12u L=1u
Mtl_L1_38 tail_L1_38 vtb 0 0 NREL W=32.0u L=1u
Mdm_L1_38 dmp_L1_38 dmp_L1_38 vdd vdd PMIR W=40u L=1u
Mrp1_L1_38 hdd_L1_38 hdd_L1_38 vdd vdd PMIR W=40u L=1u
Mrp2_L1_38 hv_L1_38 hdd_L1_38 vdd vdd PMIR W=40u L=1u
Rhv_L1_38 hv_L1_38 vg0 8000.0
C_gp_1_39_0 gp_1_39_0 0 {Cg}
Mp_1_39_0 a0 gp_1_39_0 colp_L1_39 0 NSYN W=10u L=1u
Mn_1_39_0 a0 vcn coln_L1_39 0 NSYN W=10u L=1u
C_gp_1_39_1 gp_1_39_1 0 {Cg}
Mp_1_39_1 a1 gp_1_39_1 colp_L1_39 0 NSYN W=10u L=1u
Mn_1_39_1 a1 vcn coln_L1_39 0 NSYN W=10u L=1u
C_gp_1_39_b gp_1_39_b 0 {Cg}
Mp_1_39_b bx gp_1_39_b colp_L1_39 0 NSYN W=10u L=1u
Mn_1_39_b bx vcn coln_L1_39 0 NSYN W=10u L=1u
Msa_h_L1_39 coln_L1_39 coln_L1_39 0 0 NMIR W=20u L=1u
Msb_h_L1_39 z_L1_39 coln_L1_39 0 0 NMIR W=20u L=1u
Msc_h_L1_39 colp_L1_39 colp_L1_39 0 0 NMIR W=20u L=1u
Msd_h_L1_39 dpf_h_L1_39 colp_L1_39 0 0 NMIR W=20u L=1u
Mse_h_L1_39 dpf_h_L1_39 dpf_h_L1_39 vdd vdd PMIR W=60u L=1u
Msf_h_L1_39 z_L1_39 dpf_h_L1_39 vdd vdd PMIR W=60u L=1u
R_h_L1_39 z_L1_39 vrefh 8000.0
Mr_L1_39  hdd_L1_39 z_L1_39 tail_L1_39 0 NREL W=12u L=1u
Mr2_L1_39 dmp_L1_39  vmid  tail_L1_39 0 NREL W=12u L=1u
Mtl_L1_39 tail_L1_39 vtb 0 0 NREL W=32.0u L=1u
Mdm_L1_39 dmp_L1_39 dmp_L1_39 vdd vdd PMIR W=40u L=1u
Mrp1_L1_39 hdd_L1_39 hdd_L1_39 vdd vdd PMIR W=40u L=1u
Mrp2_L1_39 hv_L1_39 hdd_L1_39 vdd vdd PMIR W=40u L=1u
Rhv_L1_39 hv_L1_39 vg0 8000.0
C_gp_1_40_0 gp_1_40_0 0 {Cg}
Mp_1_40_0 a0 gp_1_40_0 colp_L1_40 0 NSYN W=10u L=1u
Mn_1_40_0 a0 vcn coln_L1_40 0 NSYN W=10u L=1u
C_gp_1_40_1 gp_1_40_1 0 {Cg}
Mp_1_40_1 a1 gp_1_40_1 colp_L1_40 0 NSYN W=10u L=1u
Mn_1_40_1 a1 vcn coln_L1_40 0 NSYN W=10u L=1u
C_gp_1_40_b gp_1_40_b 0 {Cg}
Mp_1_40_b bx gp_1_40_b colp_L1_40 0 NSYN W=10u L=1u
Mn_1_40_b bx vcn coln_L1_40 0 NSYN W=10u L=1u
Msa_h_L1_40 coln_L1_40 coln_L1_40 0 0 NMIR W=20u L=1u
Msb_h_L1_40 z_L1_40 coln_L1_40 0 0 NMIR W=20u L=1u
Msc_h_L1_40 colp_L1_40 colp_L1_40 0 0 NMIR W=20u L=1u
Msd_h_L1_40 dpf_h_L1_40 colp_L1_40 0 0 NMIR W=20u L=1u
Mse_h_L1_40 dpf_h_L1_40 dpf_h_L1_40 vdd vdd PMIR W=60u L=1u
Msf_h_L1_40 z_L1_40 dpf_h_L1_40 vdd vdd PMIR W=60u L=1u
R_h_L1_40 z_L1_40 vrefh 8000.0
Mr_L1_40  hdd_L1_40 z_L1_40 tail_L1_40 0 NREL W=12u L=1u
Mr2_L1_40 dmp_L1_40  vmid  tail_L1_40 0 NREL W=12u L=1u
Mtl_L1_40 tail_L1_40 vtb 0 0 NREL W=32.0u L=1u
Mdm_L1_40 dmp_L1_40 dmp_L1_40 vdd vdd PMIR W=40u L=1u
Mrp1_L1_40 hdd_L1_40 hdd_L1_40 vdd vdd PMIR W=40u L=1u
Mrp2_L1_40 hv_L1_40 hdd_L1_40 vdd vdd PMIR W=40u L=1u
Rhv_L1_40 hv_L1_40 vg0 8000.0
C_gp_1_41_0 gp_1_41_0 0 {Cg}
Mp_1_41_0 a0 gp_1_41_0 colp_L1_41 0 NSYN W=10u L=1u
Mn_1_41_0 a0 vcn coln_L1_41 0 NSYN W=10u L=1u
C_gp_1_41_1 gp_1_41_1 0 {Cg}
Mp_1_41_1 a1 gp_1_41_1 colp_L1_41 0 NSYN W=10u L=1u
Mn_1_41_1 a1 vcn coln_L1_41 0 NSYN W=10u L=1u
C_gp_1_41_b gp_1_41_b 0 {Cg}
Mp_1_41_b bx gp_1_41_b colp_L1_41 0 NSYN W=10u L=1u
Mn_1_41_b bx vcn coln_L1_41 0 NSYN W=10u L=1u
Msa_h_L1_41 coln_L1_41 coln_L1_41 0 0 NMIR W=20u L=1u
Msb_h_L1_41 z_L1_41 coln_L1_41 0 0 NMIR W=20u L=1u
Msc_h_L1_41 colp_L1_41 colp_L1_41 0 0 NMIR W=20u L=1u
Msd_h_L1_41 dpf_h_L1_41 colp_L1_41 0 0 NMIR W=20u L=1u
Mse_h_L1_41 dpf_h_L1_41 dpf_h_L1_41 vdd vdd PMIR W=60u L=1u
Msf_h_L1_41 z_L1_41 dpf_h_L1_41 vdd vdd PMIR W=60u L=1u
R_h_L1_41 z_L1_41 vrefh 8000.0
Mr_L1_41  hdd_L1_41 z_L1_41 tail_L1_41 0 NREL W=12u L=1u
Mr2_L1_41 dmp_L1_41  vmid  tail_L1_41 0 NREL W=12u L=1u
Mtl_L1_41 tail_L1_41 vtb 0 0 NREL W=32.0u L=1u
Mdm_L1_41 dmp_L1_41 dmp_L1_41 vdd vdd PMIR W=40u L=1u
Mrp1_L1_41 hdd_L1_41 hdd_L1_41 vdd vdd PMIR W=40u L=1u
Mrp2_L1_41 hv_L1_41 hdd_L1_41 vdd vdd PMIR W=40u L=1u
Rhv_L1_41 hv_L1_41 vg0 8000.0
C_gp_1_42_0 gp_1_42_0 0 {Cg}
Mp_1_42_0 a0 gp_1_42_0 colp_L1_42 0 NSYN W=10u L=1u
Mn_1_42_0 a0 vcn coln_L1_42 0 NSYN W=10u L=1u
C_gp_1_42_1 gp_1_42_1 0 {Cg}
Mp_1_42_1 a1 gp_1_42_1 colp_L1_42 0 NSYN W=10u L=1u
Mn_1_42_1 a1 vcn coln_L1_42 0 NSYN W=10u L=1u
C_gp_1_42_b gp_1_42_b 0 {Cg}
Mp_1_42_b bx gp_1_42_b colp_L1_42 0 NSYN W=10u L=1u
Mn_1_42_b bx vcn coln_L1_42 0 NSYN W=10u L=1u
Msa_h_L1_42 coln_L1_42 coln_L1_42 0 0 NMIR W=20u L=1u
Msb_h_L1_42 z_L1_42 coln_L1_42 0 0 NMIR W=20u L=1u
Msc_h_L1_42 colp_L1_42 colp_L1_42 0 0 NMIR W=20u L=1u
Msd_h_L1_42 dpf_h_L1_42 colp_L1_42 0 0 NMIR W=20u L=1u
Mse_h_L1_42 dpf_h_L1_42 dpf_h_L1_42 vdd vdd PMIR W=60u L=1u
Msf_h_L1_42 z_L1_42 dpf_h_L1_42 vdd vdd PMIR W=60u L=1u
R_h_L1_42 z_L1_42 vrefh 8000.0
Mr_L1_42  hdd_L1_42 z_L1_42 tail_L1_42 0 NREL W=12u L=1u
Mr2_L1_42 dmp_L1_42  vmid  tail_L1_42 0 NREL W=12u L=1u
Mtl_L1_42 tail_L1_42 vtb 0 0 NREL W=32.0u L=1u
Mdm_L1_42 dmp_L1_42 dmp_L1_42 vdd vdd PMIR W=40u L=1u
Mrp1_L1_42 hdd_L1_42 hdd_L1_42 vdd vdd PMIR W=40u L=1u
Mrp2_L1_42 hv_L1_42 hdd_L1_42 vdd vdd PMIR W=40u L=1u
Rhv_L1_42 hv_L1_42 vg0 8000.0
C_gp_1_43_0 gp_1_43_0 0 {Cg}
Mp_1_43_0 a0 gp_1_43_0 colp_L1_43 0 NSYN W=10u L=1u
Mn_1_43_0 a0 vcn coln_L1_43 0 NSYN W=10u L=1u
C_gp_1_43_1 gp_1_43_1 0 {Cg}
Mp_1_43_1 a1 gp_1_43_1 colp_L1_43 0 NSYN W=10u L=1u
Mn_1_43_1 a1 vcn coln_L1_43 0 NSYN W=10u L=1u
C_gp_1_43_b gp_1_43_b 0 {Cg}
Mp_1_43_b bx gp_1_43_b colp_L1_43 0 NSYN W=10u L=1u
Mn_1_43_b bx vcn coln_L1_43 0 NSYN W=10u L=1u
Msa_h_L1_43 coln_L1_43 coln_L1_43 0 0 NMIR W=20u L=1u
Msb_h_L1_43 z_L1_43 coln_L1_43 0 0 NMIR W=20u L=1u
Msc_h_L1_43 colp_L1_43 colp_L1_43 0 0 NMIR W=20u L=1u
Msd_h_L1_43 dpf_h_L1_43 colp_L1_43 0 0 NMIR W=20u L=1u
Mse_h_L1_43 dpf_h_L1_43 dpf_h_L1_43 vdd vdd PMIR W=60u L=1u
Msf_h_L1_43 z_L1_43 dpf_h_L1_43 vdd vdd PMIR W=60u L=1u
R_h_L1_43 z_L1_43 vrefh 8000.0
Mr_L1_43  hdd_L1_43 z_L1_43 tail_L1_43 0 NREL W=12u L=1u
Mr2_L1_43 dmp_L1_43  vmid  tail_L1_43 0 NREL W=12u L=1u
Mtl_L1_43 tail_L1_43 vtb 0 0 NREL W=32.0u L=1u
Mdm_L1_43 dmp_L1_43 dmp_L1_43 vdd vdd PMIR W=40u L=1u
Mrp1_L1_43 hdd_L1_43 hdd_L1_43 vdd vdd PMIR W=40u L=1u
Mrp2_L1_43 hv_L1_43 hdd_L1_43 vdd vdd PMIR W=40u L=1u
Rhv_L1_43 hv_L1_43 vg0 8000.0
C_gp_1_44_0 gp_1_44_0 0 {Cg}
Mp_1_44_0 a0 gp_1_44_0 colp_L1_44 0 NSYN W=10u L=1u
Mn_1_44_0 a0 vcn coln_L1_44 0 NSYN W=10u L=1u
C_gp_1_44_1 gp_1_44_1 0 {Cg}
Mp_1_44_1 a1 gp_1_44_1 colp_L1_44 0 NSYN W=10u L=1u
Mn_1_44_1 a1 vcn coln_L1_44 0 NSYN W=10u L=1u
C_gp_1_44_b gp_1_44_b 0 {Cg}
Mp_1_44_b bx gp_1_44_b colp_L1_44 0 NSYN W=10u L=1u
Mn_1_44_b bx vcn coln_L1_44 0 NSYN W=10u L=1u
Msa_h_L1_44 coln_L1_44 coln_L1_44 0 0 NMIR W=20u L=1u
Msb_h_L1_44 z_L1_44 coln_L1_44 0 0 NMIR W=20u L=1u
Msc_h_L1_44 colp_L1_44 colp_L1_44 0 0 NMIR W=20u L=1u
Msd_h_L1_44 dpf_h_L1_44 colp_L1_44 0 0 NMIR W=20u L=1u
Mse_h_L1_44 dpf_h_L1_44 dpf_h_L1_44 vdd vdd PMIR W=60u L=1u
Msf_h_L1_44 z_L1_44 dpf_h_L1_44 vdd vdd PMIR W=60u L=1u
R_h_L1_44 z_L1_44 vrefh 8000.0
Mr_L1_44  hdd_L1_44 z_L1_44 tail_L1_44 0 NREL W=12u L=1u
Mr2_L1_44 dmp_L1_44  vmid  tail_L1_44 0 NREL W=12u L=1u
Mtl_L1_44 tail_L1_44 vtb 0 0 NREL W=32.0u L=1u
Mdm_L1_44 dmp_L1_44 dmp_L1_44 vdd vdd PMIR W=40u L=1u
Mrp1_L1_44 hdd_L1_44 hdd_L1_44 vdd vdd PMIR W=40u L=1u
Mrp2_L1_44 hv_L1_44 hdd_L1_44 vdd vdd PMIR W=40u L=1u
Rhv_L1_44 hv_L1_44 vg0 8000.0
C_gp_1_45_0 gp_1_45_0 0 {Cg}
Mp_1_45_0 a0 gp_1_45_0 colp_L1_45 0 NSYN W=10u L=1u
Mn_1_45_0 a0 vcn coln_L1_45 0 NSYN W=10u L=1u
C_gp_1_45_1 gp_1_45_1 0 {Cg}
Mp_1_45_1 a1 gp_1_45_1 colp_L1_45 0 NSYN W=10u L=1u
Mn_1_45_1 a1 vcn coln_L1_45 0 NSYN W=10u L=1u
C_gp_1_45_b gp_1_45_b 0 {Cg}
Mp_1_45_b bx gp_1_45_b colp_L1_45 0 NSYN W=10u L=1u
Mn_1_45_b bx vcn coln_L1_45 0 NSYN W=10u L=1u
Msa_h_L1_45 coln_L1_45 coln_L1_45 0 0 NMIR W=20u L=1u
Msb_h_L1_45 z_L1_45 coln_L1_45 0 0 NMIR W=20u L=1u
Msc_h_L1_45 colp_L1_45 colp_L1_45 0 0 NMIR W=20u L=1u
Msd_h_L1_45 dpf_h_L1_45 colp_L1_45 0 0 NMIR W=20u L=1u
Mse_h_L1_45 dpf_h_L1_45 dpf_h_L1_45 vdd vdd PMIR W=60u L=1u
Msf_h_L1_45 z_L1_45 dpf_h_L1_45 vdd vdd PMIR W=60u L=1u
R_h_L1_45 z_L1_45 vrefh 8000.0
Mr_L1_45  hdd_L1_45 z_L1_45 tail_L1_45 0 NREL W=12u L=1u
Mr2_L1_45 dmp_L1_45  vmid  tail_L1_45 0 NREL W=12u L=1u
Mtl_L1_45 tail_L1_45 vtb 0 0 NREL W=32.0u L=1u
Mdm_L1_45 dmp_L1_45 dmp_L1_45 vdd vdd PMIR W=40u L=1u
Mrp1_L1_45 hdd_L1_45 hdd_L1_45 vdd vdd PMIR W=40u L=1u
Mrp2_L1_45 hv_L1_45 hdd_L1_45 vdd vdd PMIR W=40u L=1u
Rhv_L1_45 hv_L1_45 vg0 8000.0
C_gp_1_46_0 gp_1_46_0 0 {Cg}
Mp_1_46_0 a0 gp_1_46_0 colp_L1_46 0 NSYN W=10u L=1u
Mn_1_46_0 a0 vcn coln_L1_46 0 NSYN W=10u L=1u
C_gp_1_46_1 gp_1_46_1 0 {Cg}
Mp_1_46_1 a1 gp_1_46_1 colp_L1_46 0 NSYN W=10u L=1u
Mn_1_46_1 a1 vcn coln_L1_46 0 NSYN W=10u L=1u
C_gp_1_46_b gp_1_46_b 0 {Cg}
Mp_1_46_b bx gp_1_46_b colp_L1_46 0 NSYN W=10u L=1u
Mn_1_46_b bx vcn coln_L1_46 0 NSYN W=10u L=1u
Msa_h_L1_46 coln_L1_46 coln_L1_46 0 0 NMIR W=20u L=1u
Msb_h_L1_46 z_L1_46 coln_L1_46 0 0 NMIR W=20u L=1u
Msc_h_L1_46 colp_L1_46 colp_L1_46 0 0 NMIR W=20u L=1u
Msd_h_L1_46 dpf_h_L1_46 colp_L1_46 0 0 NMIR W=20u L=1u
Mse_h_L1_46 dpf_h_L1_46 dpf_h_L1_46 vdd vdd PMIR W=60u L=1u
Msf_h_L1_46 z_L1_46 dpf_h_L1_46 vdd vdd PMIR W=60u L=1u
R_h_L1_46 z_L1_46 vrefh 8000.0
Mr_L1_46  hdd_L1_46 z_L1_46 tail_L1_46 0 NREL W=12u L=1u
Mr2_L1_46 dmp_L1_46  vmid  tail_L1_46 0 NREL W=12u L=1u
Mtl_L1_46 tail_L1_46 vtb 0 0 NREL W=32.0u L=1u
Mdm_L1_46 dmp_L1_46 dmp_L1_46 vdd vdd PMIR W=40u L=1u
Mrp1_L1_46 hdd_L1_46 hdd_L1_46 vdd vdd PMIR W=40u L=1u
Mrp2_L1_46 hv_L1_46 hdd_L1_46 vdd vdd PMIR W=40u L=1u
Rhv_L1_46 hv_L1_46 vg0 8000.0
C_gp_1_47_0 gp_1_47_0 0 {Cg}
Mp_1_47_0 a0 gp_1_47_0 colp_L1_47 0 NSYN W=10u L=1u
Mn_1_47_0 a0 vcn coln_L1_47 0 NSYN W=10u L=1u
C_gp_1_47_1 gp_1_47_1 0 {Cg}
Mp_1_47_1 a1 gp_1_47_1 colp_L1_47 0 NSYN W=10u L=1u
Mn_1_47_1 a1 vcn coln_L1_47 0 NSYN W=10u L=1u
C_gp_1_47_b gp_1_47_b 0 {Cg}
Mp_1_47_b bx gp_1_47_b colp_L1_47 0 NSYN W=10u L=1u
Mn_1_47_b bx vcn coln_L1_47 0 NSYN W=10u L=1u
Msa_h_L1_47 coln_L1_47 coln_L1_47 0 0 NMIR W=20u L=1u
Msb_h_L1_47 z_L1_47 coln_L1_47 0 0 NMIR W=20u L=1u
Msc_h_L1_47 colp_L1_47 colp_L1_47 0 0 NMIR W=20u L=1u
Msd_h_L1_47 dpf_h_L1_47 colp_L1_47 0 0 NMIR W=20u L=1u
Mse_h_L1_47 dpf_h_L1_47 dpf_h_L1_47 vdd vdd PMIR W=60u L=1u
Msf_h_L1_47 z_L1_47 dpf_h_L1_47 vdd vdd PMIR W=60u L=1u
R_h_L1_47 z_L1_47 vrefh 8000.0
Mr_L1_47  hdd_L1_47 z_L1_47 tail_L1_47 0 NREL W=12u L=1u
Mr2_L1_47 dmp_L1_47  vmid  tail_L1_47 0 NREL W=12u L=1u
Mtl_L1_47 tail_L1_47 vtb 0 0 NREL W=32.0u L=1u
Mdm_L1_47 dmp_L1_47 dmp_L1_47 vdd vdd PMIR W=40u L=1u
Mrp1_L1_47 hdd_L1_47 hdd_L1_47 vdd vdd PMIR W=40u L=1u
Mrp2_L1_47 hv_L1_47 hdd_L1_47 vdd vdd PMIR W=40u L=1u
Rhv_L1_47 hv_L1_47 vg0 8000.0
C_gp_2_0_0 gp_2_0_0 0 {Cg}
Mp_2_0_0 hv_L1_4 gp_2_0_0 colp_L2_0 0 NSYN W=10u L=1u
Mn_2_0_0 hv_L1_4 vcn coln_L2_0 0 NSYN W=10u L=1u
C_gp_2_0_1 gp_2_0_1 0 {Cg}
Mp_2_0_1 hv_L1_6 gp_2_0_1 colp_L2_0 0 NSYN W=10u L=1u
Mn_2_0_1 hv_L1_6 vcn coln_L2_0 0 NSYN W=10u L=1u
C_gp_2_0_2 gp_2_0_2 0 {Cg}
Mp_2_0_2 hv_L1_10 gp_2_0_2 colp_L2_0 0 NSYN W=10u L=1u
Mn_2_0_2 hv_L1_10 vcn coln_L2_0 0 NSYN W=10u L=1u
C_gp_2_0_3 gp_2_0_3 0 {Cg}
Mp_2_0_3 hv_L1_12 gp_2_0_3 colp_L2_0 0 NSYN W=10u L=1u
Mn_2_0_3 hv_L1_12 vcn coln_L2_0 0 NSYN W=10u L=1u
C_gp_2_0_4 gp_2_0_4 0 {Cg}
Mp_2_0_4 hv_L1_15 gp_2_0_4 colp_L2_0 0 NSYN W=10u L=1u
Mn_2_0_4 hv_L1_15 vcn coln_L2_0 0 NSYN W=10u L=1u
C_gp_2_0_5 gp_2_0_5 0 {Cg}
Mp_2_0_5 hv_L1_17 gp_2_0_5 colp_L2_0 0 NSYN W=10u L=1u
Mn_2_0_5 hv_L1_17 vcn coln_L2_0 0 NSYN W=10u L=1u
C_gp_2_0_6 gp_2_0_6 0 {Cg}
Mp_2_0_6 hv_L1_23 gp_2_0_6 colp_L2_0 0 NSYN W=10u L=1u
Mn_2_0_6 hv_L1_23 vcn coln_L2_0 0 NSYN W=10u L=1u
C_gp_2_0_7 gp_2_0_7 0 {Cg}
Mp_2_0_7 hv_L1_24 gp_2_0_7 colp_L2_0 0 NSYN W=10u L=1u
Mn_2_0_7 hv_L1_24 vcn coln_L2_0 0 NSYN W=10u L=1u
C_gp_2_0_8 gp_2_0_8 0 {Cg}
Mp_2_0_8 hv_L1_25 gp_2_0_8 colp_L2_0 0 NSYN W=10u L=1u
Mn_2_0_8 hv_L1_25 vcn coln_L2_0 0 NSYN W=10u L=1u
C_gp_2_0_9 gp_2_0_9 0 {Cg}
Mp_2_0_9 hv_L1_29 gp_2_0_9 colp_L2_0 0 NSYN W=10u L=1u
Mn_2_0_9 hv_L1_29 vcn coln_L2_0 0 NSYN W=10u L=1u
C_gp_2_0_10 gp_2_0_10 0 {Cg}
Mp_2_0_10 hv_L1_32 gp_2_0_10 colp_L2_0 0 NSYN W=10u L=1u
Mn_2_0_10 hv_L1_32 vcn coln_L2_0 0 NSYN W=10u L=1u
C_gp_2_0_11 gp_2_0_11 0 {Cg}
Mp_2_0_11 hv_L1_34 gp_2_0_11 colp_L2_0 0 NSYN W=10u L=1u
Mn_2_0_11 hv_L1_34 vcn coln_L2_0 0 NSYN W=10u L=1u
C_gp_2_0_12 gp_2_0_12 0 {Cg}
Mp_2_0_12 hv_L1_39 gp_2_0_12 colp_L2_0 0 NSYN W=10u L=1u
Mn_2_0_12 hv_L1_39 vcn coln_L2_0 0 NSYN W=10u L=1u
C_gp_2_0_13 gp_2_0_13 0 {Cg}
Mp_2_0_13 hv_L1_40 gp_2_0_13 colp_L2_0 0 NSYN W=10u L=1u
Mn_2_0_13 hv_L1_40 vcn coln_L2_0 0 NSYN W=10u L=1u
C_gp_2_0_14 gp_2_0_14 0 {Cg}
Mp_2_0_14 hv_L1_41 gp_2_0_14 colp_L2_0 0 NSYN W=10u L=1u
Mn_2_0_14 hv_L1_41 vcn coln_L2_0 0 NSYN W=10u L=1u
C_gp_2_0_15 gp_2_0_15 0 {Cg}
Mp_2_0_15 hv_L1_42 gp_2_0_15 colp_L2_0 0 NSYN W=10u L=1u
Mn_2_0_15 hv_L1_42 vcn coln_L2_0 0 NSYN W=10u L=1u
C_gp_2_0_b gp_2_0_b 0 {Cg}
Mp_2_0_b bx gp_2_0_b colp_L2_0 0 NSYN W=10u L=1u
Mn_2_0_b bx vcn coln_L2_0 0 NSYN W=10u L=1u
Msa_h_L2_0 coln_L2_0 coln_L2_0 0 0 NMIR W=20u L=1u
Msb_h_L2_0 z_L2_0 coln_L2_0 0 0 NMIR W=20u L=1u
Msc_h_L2_0 colp_L2_0 colp_L2_0 0 0 NMIR W=20u L=1u
Msd_h_L2_0 dpf_h_L2_0 colp_L2_0 0 0 NMIR W=20u L=1u
Mse_h_L2_0 dpf_h_L2_0 dpf_h_L2_0 vdd vdd PMIR W=60u L=1u
Msf_h_L2_0 z_L2_0 dpf_h_L2_0 vdd vdd PMIR W=60u L=1u
R_h_L2_0 z_L2_0 vrefh 8000.0
Mr_L2_0  hdd_L2_0 z_L2_0 tail_L2_0 0 NREL W=12u L=1u
Mr2_L2_0 dmp_L2_0  vmid  tail_L2_0 0 NREL W=12u L=1u
Mtl_L2_0 tail_L2_0 vtb 0 0 NREL W=32.0u L=1u
Mdm_L2_0 dmp_L2_0 dmp_L2_0 vdd vdd PMIR W=40u L=1u
Mrp1_L2_0 hdd_L2_0 hdd_L2_0 vdd vdd PMIR W=40u L=1u
Mrp2_L2_0 hv_L2_0 hdd_L2_0 vdd vdd PMIR W=40u L=1u
Rhv_L2_0 hv_L2_0 vg0 8000.0
C_gp_2_1_0 gp_2_1_0 0 {Cg}
Mp_2_1_0 hv_L1_1 gp_2_1_0 colp_L2_1 0 NSYN W=10u L=1u
Mn_2_1_0 hv_L1_1 vcn coln_L2_1 0 NSYN W=10u L=1u
C_gp_2_1_1 gp_2_1_1 0 {Cg}
Mp_2_1_1 hv_L1_2 gp_2_1_1 colp_L2_1 0 NSYN W=10u L=1u
Mn_2_1_1 hv_L1_2 vcn coln_L2_1 0 NSYN W=10u L=1u
C_gp_2_1_2 gp_2_1_2 0 {Cg}
Mp_2_1_2 hv_L1_13 gp_2_1_2 colp_L2_1 0 NSYN W=10u L=1u
Mn_2_1_2 hv_L1_13 vcn coln_L2_1 0 NSYN W=10u L=1u
C_gp_2_1_3 gp_2_1_3 0 {Cg}
Mp_2_1_3 hv_L1_14 gp_2_1_3 colp_L2_1 0 NSYN W=10u L=1u
Mn_2_1_3 hv_L1_14 vcn coln_L2_1 0 NSYN W=10u L=1u
C_gp_2_1_4 gp_2_1_4 0 {Cg}
Mp_2_1_4 hv_L1_16 gp_2_1_4 colp_L2_1 0 NSYN W=10u L=1u
Mn_2_1_4 hv_L1_16 vcn coln_L2_1 0 NSYN W=10u L=1u
C_gp_2_1_5 gp_2_1_5 0 {Cg}
Mp_2_1_5 hv_L1_17 gp_2_1_5 colp_L2_1 0 NSYN W=10u L=1u
Mn_2_1_5 hv_L1_17 vcn coln_L2_1 0 NSYN W=10u L=1u
C_gp_2_1_6 gp_2_1_6 0 {Cg}
Mp_2_1_6 hv_L1_18 gp_2_1_6 colp_L2_1 0 NSYN W=10u L=1u
Mn_2_1_6 hv_L1_18 vcn coln_L2_1 0 NSYN W=10u L=1u
C_gp_2_1_7 gp_2_1_7 0 {Cg}
Mp_2_1_7 hv_L1_19 gp_2_1_7 colp_L2_1 0 NSYN W=10u L=1u
Mn_2_1_7 hv_L1_19 vcn coln_L2_1 0 NSYN W=10u L=1u
C_gp_2_1_8 gp_2_1_8 0 {Cg}
Mp_2_1_8 hv_L1_21 gp_2_1_8 colp_L2_1 0 NSYN W=10u L=1u
Mn_2_1_8 hv_L1_21 vcn coln_L2_1 0 NSYN W=10u L=1u
C_gp_2_1_9 gp_2_1_9 0 {Cg}
Mp_2_1_9 hv_L1_25 gp_2_1_9 colp_L2_1 0 NSYN W=10u L=1u
Mn_2_1_9 hv_L1_25 vcn coln_L2_1 0 NSYN W=10u L=1u
C_gp_2_1_10 gp_2_1_10 0 {Cg}
Mp_2_1_10 hv_L1_33 gp_2_1_10 colp_L2_1 0 NSYN W=10u L=1u
Mn_2_1_10 hv_L1_33 vcn coln_L2_1 0 NSYN W=10u L=1u
C_gp_2_1_11 gp_2_1_11 0 {Cg}
Mp_2_1_11 hv_L1_36 gp_2_1_11 colp_L2_1 0 NSYN W=10u L=1u
Mn_2_1_11 hv_L1_36 vcn coln_L2_1 0 NSYN W=10u L=1u
C_gp_2_1_12 gp_2_1_12 0 {Cg}
Mp_2_1_12 hv_L1_40 gp_2_1_12 colp_L2_1 0 NSYN W=10u L=1u
Mn_2_1_12 hv_L1_40 vcn coln_L2_1 0 NSYN W=10u L=1u
C_gp_2_1_13 gp_2_1_13 0 {Cg}
Mp_2_1_13 hv_L1_41 gp_2_1_13 colp_L2_1 0 NSYN W=10u L=1u
Mn_2_1_13 hv_L1_41 vcn coln_L2_1 0 NSYN W=10u L=1u
C_gp_2_1_14 gp_2_1_14 0 {Cg}
Mp_2_1_14 hv_L1_45 gp_2_1_14 colp_L2_1 0 NSYN W=10u L=1u
Mn_2_1_14 hv_L1_45 vcn coln_L2_1 0 NSYN W=10u L=1u
C_gp_2_1_15 gp_2_1_15 0 {Cg}
Mp_2_1_15 hv_L1_46 gp_2_1_15 colp_L2_1 0 NSYN W=10u L=1u
Mn_2_1_15 hv_L1_46 vcn coln_L2_1 0 NSYN W=10u L=1u
C_gp_2_1_b gp_2_1_b 0 {Cg}
Mp_2_1_b bx gp_2_1_b colp_L2_1 0 NSYN W=10u L=1u
Mn_2_1_b bx vcn coln_L2_1 0 NSYN W=10u L=1u
Msa_h_L2_1 coln_L2_1 coln_L2_1 0 0 NMIR W=20u L=1u
Msb_h_L2_1 z_L2_1 coln_L2_1 0 0 NMIR W=20u L=1u
Msc_h_L2_1 colp_L2_1 colp_L2_1 0 0 NMIR W=20u L=1u
Msd_h_L2_1 dpf_h_L2_1 colp_L2_1 0 0 NMIR W=20u L=1u
Mse_h_L2_1 dpf_h_L2_1 dpf_h_L2_1 vdd vdd PMIR W=60u L=1u
Msf_h_L2_1 z_L2_1 dpf_h_L2_1 vdd vdd PMIR W=60u L=1u
R_h_L2_1 z_L2_1 vrefh 8000.0
Mr_L2_1  hdd_L2_1 z_L2_1 tail_L2_1 0 NREL W=12u L=1u
Mr2_L2_1 dmp_L2_1  vmid  tail_L2_1 0 NREL W=12u L=1u
Mtl_L2_1 tail_L2_1 vtb 0 0 NREL W=32.0u L=1u
Mdm_L2_1 dmp_L2_1 dmp_L2_1 vdd vdd PMIR W=40u L=1u
Mrp1_L2_1 hdd_L2_1 hdd_L2_1 vdd vdd PMIR W=40u L=1u
Mrp2_L2_1 hv_L2_1 hdd_L2_1 vdd vdd PMIR W=40u L=1u
Rhv_L2_1 hv_L2_1 vg0 8000.0
C_gp_2_2_0 gp_2_2_0 0 {Cg}
Mp_2_2_0 hv_L1_3 gp_2_2_0 colp_L2_2 0 NSYN W=10u L=1u
Mn_2_2_0 hv_L1_3 vcn coln_L2_2 0 NSYN W=10u L=1u
C_gp_2_2_1 gp_2_2_1 0 {Cg}
Mp_2_2_1 hv_L1_4 gp_2_2_1 colp_L2_2 0 NSYN W=10u L=1u
Mn_2_2_1 hv_L1_4 vcn coln_L2_2 0 NSYN W=10u L=1u
C_gp_2_2_2 gp_2_2_2 0 {Cg}
Mp_2_2_2 hv_L1_7 gp_2_2_2 colp_L2_2 0 NSYN W=10u L=1u
Mn_2_2_2 hv_L1_7 vcn coln_L2_2 0 NSYN W=10u L=1u
C_gp_2_2_3 gp_2_2_3 0 {Cg}
Mp_2_2_3 hv_L1_8 gp_2_2_3 colp_L2_2 0 NSYN W=10u L=1u
Mn_2_2_3 hv_L1_8 vcn coln_L2_2 0 NSYN W=10u L=1u
C_gp_2_2_4 gp_2_2_4 0 {Cg}
Mp_2_2_4 hv_L1_14 gp_2_2_4 colp_L2_2 0 NSYN W=10u L=1u
Mn_2_2_4 hv_L1_14 vcn coln_L2_2 0 NSYN W=10u L=1u
C_gp_2_2_5 gp_2_2_5 0 {Cg}
Mp_2_2_5 hv_L1_19 gp_2_2_5 colp_L2_2 0 NSYN W=10u L=1u
Mn_2_2_5 hv_L1_19 vcn coln_L2_2 0 NSYN W=10u L=1u
C_gp_2_2_6 gp_2_2_6 0 {Cg}
Mp_2_2_6 hv_L1_20 gp_2_2_6 colp_L2_2 0 NSYN W=10u L=1u
Mn_2_2_6 hv_L1_20 vcn coln_L2_2 0 NSYN W=10u L=1u
C_gp_2_2_7 gp_2_2_7 0 {Cg}
Mp_2_2_7 hv_L1_22 gp_2_2_7 colp_L2_2 0 NSYN W=10u L=1u
Mn_2_2_7 hv_L1_22 vcn coln_L2_2 0 NSYN W=10u L=1u
C_gp_2_2_8 gp_2_2_8 0 {Cg}
Mp_2_2_8 hv_L1_28 gp_2_2_8 colp_L2_2 0 NSYN W=10u L=1u
Mn_2_2_8 hv_L1_28 vcn coln_L2_2 0 NSYN W=10u L=1u
C_gp_2_2_9 gp_2_2_9 0 {Cg}
Mp_2_2_9 hv_L1_29 gp_2_2_9 colp_L2_2 0 NSYN W=10u L=1u
Mn_2_2_9 hv_L1_29 vcn coln_L2_2 0 NSYN W=10u L=1u
C_gp_2_2_10 gp_2_2_10 0 {Cg}
Mp_2_2_10 hv_L1_34 gp_2_2_10 colp_L2_2 0 NSYN W=10u L=1u
Mn_2_2_10 hv_L1_34 vcn coln_L2_2 0 NSYN W=10u L=1u
C_gp_2_2_11 gp_2_2_11 0 {Cg}
Mp_2_2_11 hv_L1_40 gp_2_2_11 colp_L2_2 0 NSYN W=10u L=1u
Mn_2_2_11 hv_L1_40 vcn coln_L2_2 0 NSYN W=10u L=1u
C_gp_2_2_12 gp_2_2_12 0 {Cg}
Mp_2_2_12 hv_L1_41 gp_2_2_12 colp_L2_2 0 NSYN W=10u L=1u
Mn_2_2_12 hv_L1_41 vcn coln_L2_2 0 NSYN W=10u L=1u
C_gp_2_2_13 gp_2_2_13 0 {Cg}
Mp_2_2_13 hv_L1_44 gp_2_2_13 colp_L2_2 0 NSYN W=10u L=1u
Mn_2_2_13 hv_L1_44 vcn coln_L2_2 0 NSYN W=10u L=1u
C_gp_2_2_14 gp_2_2_14 0 {Cg}
Mp_2_2_14 hv_L1_45 gp_2_2_14 colp_L2_2 0 NSYN W=10u L=1u
Mn_2_2_14 hv_L1_45 vcn coln_L2_2 0 NSYN W=10u L=1u
C_gp_2_2_15 gp_2_2_15 0 {Cg}
Mp_2_2_15 hv_L1_47 gp_2_2_15 colp_L2_2 0 NSYN W=10u L=1u
Mn_2_2_15 hv_L1_47 vcn coln_L2_2 0 NSYN W=10u L=1u
C_gp_2_2_b gp_2_2_b 0 {Cg}
Mp_2_2_b bx gp_2_2_b colp_L2_2 0 NSYN W=10u L=1u
Mn_2_2_b bx vcn coln_L2_2 0 NSYN W=10u L=1u
Msa_h_L2_2 coln_L2_2 coln_L2_2 0 0 NMIR W=20u L=1u
Msb_h_L2_2 z_L2_2 coln_L2_2 0 0 NMIR W=20u L=1u
Msc_h_L2_2 colp_L2_2 colp_L2_2 0 0 NMIR W=20u L=1u
Msd_h_L2_2 dpf_h_L2_2 colp_L2_2 0 0 NMIR W=20u L=1u
Mse_h_L2_2 dpf_h_L2_2 dpf_h_L2_2 vdd vdd PMIR W=60u L=1u
Msf_h_L2_2 z_L2_2 dpf_h_L2_2 vdd vdd PMIR W=60u L=1u
R_h_L2_2 z_L2_2 vrefh 8000.0
Mr_L2_2  hdd_L2_2 z_L2_2 tail_L2_2 0 NREL W=12u L=1u
Mr2_L2_2 dmp_L2_2  vmid  tail_L2_2 0 NREL W=12u L=1u
Mtl_L2_2 tail_L2_2 vtb 0 0 NREL W=32.0u L=1u
Mdm_L2_2 dmp_L2_2 dmp_L2_2 vdd vdd PMIR W=40u L=1u
Mrp1_L2_2 hdd_L2_2 hdd_L2_2 vdd vdd PMIR W=40u L=1u
Mrp2_L2_2 hv_L2_2 hdd_L2_2 vdd vdd PMIR W=40u L=1u
Rhv_L2_2 hv_L2_2 vg0 8000.0
C_gp_2_3_0 gp_2_3_0 0 {Cg}
Mp_2_3_0 hv_L1_0 gp_2_3_0 colp_L2_3 0 NSYN W=10u L=1u
Mn_2_3_0 hv_L1_0 vcn coln_L2_3 0 NSYN W=10u L=1u
C_gp_2_3_1 gp_2_3_1 0 {Cg}
Mp_2_3_1 hv_L1_1 gp_2_3_1 colp_L2_3 0 NSYN W=10u L=1u
Mn_2_3_1 hv_L1_1 vcn coln_L2_3 0 NSYN W=10u L=1u
C_gp_2_3_2 gp_2_3_2 0 {Cg}
Mp_2_3_2 hv_L1_6 gp_2_3_2 colp_L2_3 0 NSYN W=10u L=1u
Mn_2_3_2 hv_L1_6 vcn coln_L2_3 0 NSYN W=10u L=1u
C_gp_2_3_3 gp_2_3_3 0 {Cg}
Mp_2_3_3 hv_L1_7 gp_2_3_3 colp_L2_3 0 NSYN W=10u L=1u
Mn_2_3_3 hv_L1_7 vcn coln_L2_3 0 NSYN W=10u L=1u
C_gp_2_3_4 gp_2_3_4 0 {Cg}
Mp_2_3_4 hv_L1_13 gp_2_3_4 colp_L2_3 0 NSYN W=10u L=1u
Mn_2_3_4 hv_L1_13 vcn coln_L2_3 0 NSYN W=10u L=1u
C_gp_2_3_5 gp_2_3_5 0 {Cg}
Mp_2_3_5 hv_L1_14 gp_2_3_5 colp_L2_3 0 NSYN W=10u L=1u
Mn_2_3_5 hv_L1_14 vcn coln_L2_3 0 NSYN W=10u L=1u
C_gp_2_3_6 gp_2_3_6 0 {Cg}
Mp_2_3_6 hv_L1_18 gp_2_3_6 colp_L2_3 0 NSYN W=10u L=1u
Mn_2_3_6 hv_L1_18 vcn coln_L2_3 0 NSYN W=10u L=1u
C_gp_2_3_7 gp_2_3_7 0 {Cg}
Mp_2_3_7 hv_L1_20 gp_2_3_7 colp_L2_3 0 NSYN W=10u L=1u
Mn_2_3_7 hv_L1_20 vcn coln_L2_3 0 NSYN W=10u L=1u
C_gp_2_3_8 gp_2_3_8 0 {Cg}
Mp_2_3_8 hv_L1_22 gp_2_3_8 colp_L2_3 0 NSYN W=10u L=1u
Mn_2_3_8 hv_L1_22 vcn coln_L2_3 0 NSYN W=10u L=1u
C_gp_2_3_9 gp_2_3_9 0 {Cg}
Mp_2_3_9 hv_L1_24 gp_2_3_9 colp_L2_3 0 NSYN W=10u L=1u
Mn_2_3_9 hv_L1_24 vcn coln_L2_3 0 NSYN W=10u L=1u
C_gp_2_3_10 gp_2_3_10 0 {Cg}
Mp_2_3_10 hv_L1_32 gp_2_3_10 colp_L2_3 0 NSYN W=10u L=1u
Mn_2_3_10 hv_L1_32 vcn coln_L2_3 0 NSYN W=10u L=1u
C_gp_2_3_11 gp_2_3_11 0 {Cg}
Mp_2_3_11 hv_L1_35 gp_2_3_11 colp_L2_3 0 NSYN W=10u L=1u
Mn_2_3_11 hv_L1_35 vcn coln_L2_3 0 NSYN W=10u L=1u
C_gp_2_3_12 gp_2_3_12 0 {Cg}
Mp_2_3_12 hv_L1_36 gp_2_3_12 colp_L2_3 0 NSYN W=10u L=1u
Mn_2_3_12 hv_L1_36 vcn coln_L2_3 0 NSYN W=10u L=1u
C_gp_2_3_13 gp_2_3_13 0 {Cg}
Mp_2_3_13 hv_L1_39 gp_2_3_13 colp_L2_3 0 NSYN W=10u L=1u
Mn_2_3_13 hv_L1_39 vcn coln_L2_3 0 NSYN W=10u L=1u
C_gp_2_3_14 gp_2_3_14 0 {Cg}
Mp_2_3_14 hv_L1_40 gp_2_3_14 colp_L2_3 0 NSYN W=10u L=1u
Mn_2_3_14 hv_L1_40 vcn coln_L2_3 0 NSYN W=10u L=1u
C_gp_2_3_15 gp_2_3_15 0 {Cg}
Mp_2_3_15 hv_L1_41 gp_2_3_15 colp_L2_3 0 NSYN W=10u L=1u
Mn_2_3_15 hv_L1_41 vcn coln_L2_3 0 NSYN W=10u L=1u
C_gp_2_3_b gp_2_3_b 0 {Cg}
Mp_2_3_b bx gp_2_3_b colp_L2_3 0 NSYN W=10u L=1u
Mn_2_3_b bx vcn coln_L2_3 0 NSYN W=10u L=1u
Msa_h_L2_3 coln_L2_3 coln_L2_3 0 0 NMIR W=20u L=1u
Msb_h_L2_3 z_L2_3 coln_L2_3 0 0 NMIR W=20u L=1u
Msc_h_L2_3 colp_L2_3 colp_L2_3 0 0 NMIR W=20u L=1u
Msd_h_L2_3 dpf_h_L2_3 colp_L2_3 0 0 NMIR W=20u L=1u
Mse_h_L2_3 dpf_h_L2_3 dpf_h_L2_3 vdd vdd PMIR W=60u L=1u
Msf_h_L2_3 z_L2_3 dpf_h_L2_3 vdd vdd PMIR W=60u L=1u
R_h_L2_3 z_L2_3 vrefh 8000.0
Mr_L2_3  hdd_L2_3 z_L2_3 tail_L2_3 0 NREL W=12u L=1u
Mr2_L2_3 dmp_L2_3  vmid  tail_L2_3 0 NREL W=12u L=1u
Mtl_L2_3 tail_L2_3 vtb 0 0 NREL W=32.0u L=1u
Mdm_L2_3 dmp_L2_3 dmp_L2_3 vdd vdd PMIR W=40u L=1u
Mrp1_L2_3 hdd_L2_3 hdd_L2_3 vdd vdd PMIR W=40u L=1u
Mrp2_L2_3 hv_L2_3 hdd_L2_3 vdd vdd PMIR W=40u L=1u
Rhv_L2_3 hv_L2_3 vg0 8000.0
C_gp_2_4_0 gp_2_4_0 0 {Cg}
Mp_2_4_0 hv_L1_2 gp_2_4_0 colp_L2_4 0 NSYN W=10u L=1u
Mn_2_4_0 hv_L1_2 vcn coln_L2_4 0 NSYN W=10u L=1u
C_gp_2_4_1 gp_2_4_1 0 {Cg}
Mp_2_4_1 hv_L1_3 gp_2_4_1 colp_L2_4 0 NSYN W=10u L=1u
Mn_2_4_1 hv_L1_3 vcn coln_L2_4 0 NSYN W=10u L=1u
C_gp_2_4_2 gp_2_4_2 0 {Cg}
Mp_2_4_2 hv_L1_4 gp_2_4_2 colp_L2_4 0 NSYN W=10u L=1u
Mn_2_4_2 hv_L1_4 vcn coln_L2_4 0 NSYN W=10u L=1u
C_gp_2_4_3 gp_2_4_3 0 {Cg}
Mp_2_4_3 hv_L1_6 gp_2_4_3 colp_L2_4 0 NSYN W=10u L=1u
Mn_2_4_3 hv_L1_6 vcn coln_L2_4 0 NSYN W=10u L=1u
C_gp_2_4_4 gp_2_4_4 0 {Cg}
Mp_2_4_4 hv_L1_7 gp_2_4_4 colp_L2_4 0 NSYN W=10u L=1u
Mn_2_4_4 hv_L1_7 vcn coln_L2_4 0 NSYN W=10u L=1u
C_gp_2_4_5 gp_2_4_5 0 {Cg}
Mp_2_4_5 hv_L1_10 gp_2_4_5 colp_L2_4 0 NSYN W=10u L=1u
Mn_2_4_5 hv_L1_10 vcn coln_L2_4 0 NSYN W=10u L=1u
C_gp_2_4_6 gp_2_4_6 0 {Cg}
Mp_2_4_6 hv_L1_13 gp_2_4_6 colp_L2_4 0 NSYN W=10u L=1u
Mn_2_4_6 hv_L1_13 vcn coln_L2_4 0 NSYN W=10u L=1u
C_gp_2_4_7 gp_2_4_7 0 {Cg}
Mp_2_4_7 hv_L1_25 gp_2_4_7 colp_L2_4 0 NSYN W=10u L=1u
Mn_2_4_7 hv_L1_25 vcn coln_L2_4 0 NSYN W=10u L=1u
C_gp_2_4_8 gp_2_4_8 0 {Cg}
Mp_2_4_8 hv_L1_27 gp_2_4_8 colp_L2_4 0 NSYN W=10u L=1u
Mn_2_4_8 hv_L1_27 vcn coln_L2_4 0 NSYN W=10u L=1u
C_gp_2_4_9 gp_2_4_9 0 {Cg}
Mp_2_4_9 hv_L1_28 gp_2_4_9 colp_L2_4 0 NSYN W=10u L=1u
Mn_2_4_9 hv_L1_28 vcn coln_L2_4 0 NSYN W=10u L=1u
C_gp_2_4_10 gp_2_4_10 0 {Cg}
Mp_2_4_10 hv_L1_31 gp_2_4_10 colp_L2_4 0 NSYN W=10u L=1u
Mn_2_4_10 hv_L1_31 vcn coln_L2_4 0 NSYN W=10u L=1u
C_gp_2_4_11 gp_2_4_11 0 {Cg}
Mp_2_4_11 hv_L1_32 gp_2_4_11 colp_L2_4 0 NSYN W=10u L=1u
Mn_2_4_11 hv_L1_32 vcn coln_L2_4 0 NSYN W=10u L=1u
C_gp_2_4_12 gp_2_4_12 0 {Cg}
Mp_2_4_12 hv_L1_34 gp_2_4_12 colp_L2_4 0 NSYN W=10u L=1u
Mn_2_4_12 hv_L1_34 vcn coln_L2_4 0 NSYN W=10u L=1u
C_gp_2_4_13 gp_2_4_13 0 {Cg}
Mp_2_4_13 hv_L1_39 gp_2_4_13 colp_L2_4 0 NSYN W=10u L=1u
Mn_2_4_13 hv_L1_39 vcn coln_L2_4 0 NSYN W=10u L=1u
C_gp_2_4_14 gp_2_4_14 0 {Cg}
Mp_2_4_14 hv_L1_42 gp_2_4_14 colp_L2_4 0 NSYN W=10u L=1u
Mn_2_4_14 hv_L1_42 vcn coln_L2_4 0 NSYN W=10u L=1u
C_gp_2_4_15 gp_2_4_15 0 {Cg}
Mp_2_4_15 hv_L1_44 gp_2_4_15 colp_L2_4 0 NSYN W=10u L=1u
Mn_2_4_15 hv_L1_44 vcn coln_L2_4 0 NSYN W=10u L=1u
C_gp_2_4_b gp_2_4_b 0 {Cg}
Mp_2_4_b bx gp_2_4_b colp_L2_4 0 NSYN W=10u L=1u
Mn_2_4_b bx vcn coln_L2_4 0 NSYN W=10u L=1u
Msa_h_L2_4 coln_L2_4 coln_L2_4 0 0 NMIR W=20u L=1u
Msb_h_L2_4 z_L2_4 coln_L2_4 0 0 NMIR W=20u L=1u
Msc_h_L2_4 colp_L2_4 colp_L2_4 0 0 NMIR W=20u L=1u
Msd_h_L2_4 dpf_h_L2_4 colp_L2_4 0 0 NMIR W=20u L=1u
Mse_h_L2_4 dpf_h_L2_4 dpf_h_L2_4 vdd vdd PMIR W=60u L=1u
Msf_h_L2_4 z_L2_4 dpf_h_L2_4 vdd vdd PMIR W=60u L=1u
R_h_L2_4 z_L2_4 vrefh 8000.0
Mr_L2_4  hdd_L2_4 z_L2_4 tail_L2_4 0 NREL W=12u L=1u
Mr2_L2_4 dmp_L2_4  vmid  tail_L2_4 0 NREL W=12u L=1u
Mtl_L2_4 tail_L2_4 vtb 0 0 NREL W=32.0u L=1u
Mdm_L2_4 dmp_L2_4 dmp_L2_4 vdd vdd PMIR W=40u L=1u
Mrp1_L2_4 hdd_L2_4 hdd_L2_4 vdd vdd PMIR W=40u L=1u
Mrp2_L2_4 hv_L2_4 hdd_L2_4 vdd vdd PMIR W=40u L=1u
Rhv_L2_4 hv_L2_4 vg0 8000.0
C_gp_2_5_0 gp_2_5_0 0 {Cg}
Mp_2_5_0 hv_L1_4 gp_2_5_0 colp_L2_5 0 NSYN W=10u L=1u
Mn_2_5_0 hv_L1_4 vcn coln_L2_5 0 NSYN W=10u L=1u
C_gp_2_5_1 gp_2_5_1 0 {Cg}
Mp_2_5_1 hv_L1_7 gp_2_5_1 colp_L2_5 0 NSYN W=10u L=1u
Mn_2_5_1 hv_L1_7 vcn coln_L2_5 0 NSYN W=10u L=1u
C_gp_2_5_2 gp_2_5_2 0 {Cg}
Mp_2_5_2 hv_L1_11 gp_2_5_2 colp_L2_5 0 NSYN W=10u L=1u
Mn_2_5_2 hv_L1_11 vcn coln_L2_5 0 NSYN W=10u L=1u
C_gp_2_5_3 gp_2_5_3 0 {Cg}
Mp_2_5_3 hv_L1_12 gp_2_5_3 colp_L2_5 0 NSYN W=10u L=1u
Mn_2_5_3 hv_L1_12 vcn coln_L2_5 0 NSYN W=10u L=1u
C_gp_2_5_4 gp_2_5_4 0 {Cg}
Mp_2_5_4 hv_L1_18 gp_2_5_4 colp_L2_5 0 NSYN W=10u L=1u
Mn_2_5_4 hv_L1_18 vcn coln_L2_5 0 NSYN W=10u L=1u
C_gp_2_5_5 gp_2_5_5 0 {Cg}
Mp_2_5_5 hv_L1_20 gp_2_5_5 colp_L2_5 0 NSYN W=10u L=1u
Mn_2_5_5 hv_L1_20 vcn coln_L2_5 0 NSYN W=10u L=1u
C_gp_2_5_6 gp_2_5_6 0 {Cg}
Mp_2_5_6 hv_L1_21 gp_2_5_6 colp_L2_5 0 NSYN W=10u L=1u
Mn_2_5_6 hv_L1_21 vcn coln_L2_5 0 NSYN W=10u L=1u
C_gp_2_5_7 gp_2_5_7 0 {Cg}
Mp_2_5_7 hv_L1_23 gp_2_5_7 colp_L2_5 0 NSYN W=10u L=1u
Mn_2_5_7 hv_L1_23 vcn coln_L2_5 0 NSYN W=10u L=1u
C_gp_2_5_8 gp_2_5_8 0 {Cg}
Mp_2_5_8 hv_L1_26 gp_2_5_8 colp_L2_5 0 NSYN W=10u L=1u
Mn_2_5_8 hv_L1_26 vcn coln_L2_5 0 NSYN W=10u L=1u
C_gp_2_5_9 gp_2_5_9 0 {Cg}
Mp_2_5_9 hv_L1_29 gp_2_5_9 colp_L2_5 0 NSYN W=10u L=1u
Mn_2_5_9 hv_L1_29 vcn coln_L2_5 0 NSYN W=10u L=1u
C_gp_2_5_10 gp_2_5_10 0 {Cg}
Mp_2_5_10 hv_L1_32 gp_2_5_10 colp_L2_5 0 NSYN W=10u L=1u
Mn_2_5_10 hv_L1_32 vcn coln_L2_5 0 NSYN W=10u L=1u
C_gp_2_5_11 gp_2_5_11 0 {Cg}
Mp_2_5_11 hv_L1_35 gp_2_5_11 colp_L2_5 0 NSYN W=10u L=1u
Mn_2_5_11 hv_L1_35 vcn coln_L2_5 0 NSYN W=10u L=1u
C_gp_2_5_12 gp_2_5_12 0 {Cg}
Mp_2_5_12 hv_L1_36 gp_2_5_12 colp_L2_5 0 NSYN W=10u L=1u
Mn_2_5_12 hv_L1_36 vcn coln_L2_5 0 NSYN W=10u L=1u
C_gp_2_5_13 gp_2_5_13 0 {Cg}
Mp_2_5_13 hv_L1_39 gp_2_5_13 colp_L2_5 0 NSYN W=10u L=1u
Mn_2_5_13 hv_L1_39 vcn coln_L2_5 0 NSYN W=10u L=1u
C_gp_2_5_14 gp_2_5_14 0 {Cg}
Mp_2_5_14 hv_L1_41 gp_2_5_14 colp_L2_5 0 NSYN W=10u L=1u
Mn_2_5_14 hv_L1_41 vcn coln_L2_5 0 NSYN W=10u L=1u
C_gp_2_5_15 gp_2_5_15 0 {Cg}
Mp_2_5_15 hv_L1_43 gp_2_5_15 colp_L2_5 0 NSYN W=10u L=1u
Mn_2_5_15 hv_L1_43 vcn coln_L2_5 0 NSYN W=10u L=1u
C_gp_2_5_b gp_2_5_b 0 {Cg}
Mp_2_5_b bx gp_2_5_b colp_L2_5 0 NSYN W=10u L=1u
Mn_2_5_b bx vcn coln_L2_5 0 NSYN W=10u L=1u
Msa_h_L2_5 coln_L2_5 coln_L2_5 0 0 NMIR W=20u L=1u
Msb_h_L2_5 z_L2_5 coln_L2_5 0 0 NMIR W=20u L=1u
Msc_h_L2_5 colp_L2_5 colp_L2_5 0 0 NMIR W=20u L=1u
Msd_h_L2_5 dpf_h_L2_5 colp_L2_5 0 0 NMIR W=20u L=1u
Mse_h_L2_5 dpf_h_L2_5 dpf_h_L2_5 vdd vdd PMIR W=60u L=1u
Msf_h_L2_5 z_L2_5 dpf_h_L2_5 vdd vdd PMIR W=60u L=1u
R_h_L2_5 z_L2_5 vrefh 8000.0
Mr_L2_5  hdd_L2_5 z_L2_5 tail_L2_5 0 NREL W=12u L=1u
Mr2_L2_5 dmp_L2_5  vmid  tail_L2_5 0 NREL W=12u L=1u
Mtl_L2_5 tail_L2_5 vtb 0 0 NREL W=32.0u L=1u
Mdm_L2_5 dmp_L2_5 dmp_L2_5 vdd vdd PMIR W=40u L=1u
Mrp1_L2_5 hdd_L2_5 hdd_L2_5 vdd vdd PMIR W=40u L=1u
Mrp2_L2_5 hv_L2_5 hdd_L2_5 vdd vdd PMIR W=40u L=1u
Rhv_L2_5 hv_L2_5 vg0 8000.0
C_gp_2_6_0 gp_2_6_0 0 {Cg}
Mp_2_6_0 hv_L1_6 gp_2_6_0 colp_L2_6 0 NSYN W=10u L=1u
Mn_2_6_0 hv_L1_6 vcn coln_L2_6 0 NSYN W=10u L=1u
C_gp_2_6_1 gp_2_6_1 0 {Cg}
Mp_2_6_1 hv_L1_7 gp_2_6_1 colp_L2_6 0 NSYN W=10u L=1u
Mn_2_6_1 hv_L1_7 vcn coln_L2_6 0 NSYN W=10u L=1u
C_gp_2_6_2 gp_2_6_2 0 {Cg}
Mp_2_6_2 hv_L1_8 gp_2_6_2 colp_L2_6 0 NSYN W=10u L=1u
Mn_2_6_2 hv_L1_8 vcn coln_L2_6 0 NSYN W=10u L=1u
C_gp_2_6_3 gp_2_6_3 0 {Cg}
Mp_2_6_3 hv_L1_13 gp_2_6_3 colp_L2_6 0 NSYN W=10u L=1u
Mn_2_6_3 hv_L1_13 vcn coln_L2_6 0 NSYN W=10u L=1u
C_gp_2_6_4 gp_2_6_4 0 {Cg}
Mp_2_6_4 hv_L1_14 gp_2_6_4 colp_L2_6 0 NSYN W=10u L=1u
Mn_2_6_4 hv_L1_14 vcn coln_L2_6 0 NSYN W=10u L=1u
C_gp_2_6_5 gp_2_6_5 0 {Cg}
Mp_2_6_5 hv_L1_16 gp_2_6_5 colp_L2_6 0 NSYN W=10u L=1u
Mn_2_6_5 hv_L1_16 vcn coln_L2_6 0 NSYN W=10u L=1u
C_gp_2_6_6 gp_2_6_6 0 {Cg}
Mp_2_6_6 hv_L1_17 gp_2_6_6 colp_L2_6 0 NSYN W=10u L=1u
Mn_2_6_6 hv_L1_17 vcn coln_L2_6 0 NSYN W=10u L=1u
C_gp_2_6_7 gp_2_6_7 0 {Cg}
Mp_2_6_7 hv_L1_21 gp_2_6_7 colp_L2_6 0 NSYN W=10u L=1u
Mn_2_6_7 hv_L1_21 vcn coln_L2_6 0 NSYN W=10u L=1u
C_gp_2_6_8 gp_2_6_8 0 {Cg}
Mp_2_6_8 hv_L1_27 gp_2_6_8 colp_L2_6 0 NSYN W=10u L=1u
Mn_2_6_8 hv_L1_27 vcn coln_L2_6 0 NSYN W=10u L=1u
C_gp_2_6_9 gp_2_6_9 0 {Cg}
Mp_2_6_9 hv_L1_28 gp_2_6_9 colp_L2_6 0 NSYN W=10u L=1u
Mn_2_6_9 hv_L1_28 vcn coln_L2_6 0 NSYN W=10u L=1u
C_gp_2_6_10 gp_2_6_10 0 {Cg}
Mp_2_6_10 hv_L1_29 gp_2_6_10 colp_L2_6 0 NSYN W=10u L=1u
Mn_2_6_10 hv_L1_29 vcn coln_L2_6 0 NSYN W=10u L=1u
C_gp_2_6_11 gp_2_6_11 0 {Cg}
Mp_2_6_11 hv_L1_30 gp_2_6_11 colp_L2_6 0 NSYN W=10u L=1u
Mn_2_6_11 hv_L1_30 vcn coln_L2_6 0 NSYN W=10u L=1u
C_gp_2_6_12 gp_2_6_12 0 {Cg}
Mp_2_6_12 hv_L1_39 gp_2_6_12 colp_L2_6 0 NSYN W=10u L=1u
Mn_2_6_12 hv_L1_39 vcn coln_L2_6 0 NSYN W=10u L=1u
C_gp_2_6_13 gp_2_6_13 0 {Cg}
Mp_2_6_13 hv_L1_40 gp_2_6_13 colp_L2_6 0 NSYN W=10u L=1u
Mn_2_6_13 hv_L1_40 vcn coln_L2_6 0 NSYN W=10u L=1u
C_gp_2_6_14 gp_2_6_14 0 {Cg}
Mp_2_6_14 hv_L1_43 gp_2_6_14 colp_L2_6 0 NSYN W=10u L=1u
Mn_2_6_14 hv_L1_43 vcn coln_L2_6 0 NSYN W=10u L=1u
C_gp_2_6_15 gp_2_6_15 0 {Cg}
Mp_2_6_15 hv_L1_45 gp_2_6_15 colp_L2_6 0 NSYN W=10u L=1u
Mn_2_6_15 hv_L1_45 vcn coln_L2_6 0 NSYN W=10u L=1u
C_gp_2_6_b gp_2_6_b 0 {Cg}
Mp_2_6_b bx gp_2_6_b colp_L2_6 0 NSYN W=10u L=1u
Mn_2_6_b bx vcn coln_L2_6 0 NSYN W=10u L=1u
Msa_h_L2_6 coln_L2_6 coln_L2_6 0 0 NMIR W=20u L=1u
Msb_h_L2_6 z_L2_6 coln_L2_6 0 0 NMIR W=20u L=1u
Msc_h_L2_6 colp_L2_6 colp_L2_6 0 0 NMIR W=20u L=1u
Msd_h_L2_6 dpf_h_L2_6 colp_L2_6 0 0 NMIR W=20u L=1u
Mse_h_L2_6 dpf_h_L2_6 dpf_h_L2_6 vdd vdd PMIR W=60u L=1u
Msf_h_L2_6 z_L2_6 dpf_h_L2_6 vdd vdd PMIR W=60u L=1u
R_h_L2_6 z_L2_6 vrefh 8000.0
Mr_L2_6  hdd_L2_6 z_L2_6 tail_L2_6 0 NREL W=12u L=1u
Mr2_L2_6 dmp_L2_6  vmid  tail_L2_6 0 NREL W=12u L=1u
Mtl_L2_6 tail_L2_6 vtb 0 0 NREL W=32.0u L=1u
Mdm_L2_6 dmp_L2_6 dmp_L2_6 vdd vdd PMIR W=40u L=1u
Mrp1_L2_6 hdd_L2_6 hdd_L2_6 vdd vdd PMIR W=40u L=1u
Mrp2_L2_6 hv_L2_6 hdd_L2_6 vdd vdd PMIR W=40u L=1u
Rhv_L2_6 hv_L2_6 vg0 8000.0
C_gp_2_7_0 gp_2_7_0 0 {Cg}
Mp_2_7_0 hv_L1_1 gp_2_7_0 colp_L2_7 0 NSYN W=10u L=1u
Mn_2_7_0 hv_L1_1 vcn coln_L2_7 0 NSYN W=10u L=1u
C_gp_2_7_1 gp_2_7_1 0 {Cg}
Mp_2_7_1 hv_L1_2 gp_2_7_1 colp_L2_7 0 NSYN W=10u L=1u
Mn_2_7_1 hv_L1_2 vcn coln_L2_7 0 NSYN W=10u L=1u
C_gp_2_7_2 gp_2_7_2 0 {Cg}
Mp_2_7_2 hv_L1_5 gp_2_7_2 colp_L2_7 0 NSYN W=10u L=1u
Mn_2_7_2 hv_L1_5 vcn coln_L2_7 0 NSYN W=10u L=1u
C_gp_2_7_3 gp_2_7_3 0 {Cg}
Mp_2_7_3 hv_L1_7 gp_2_7_3 colp_L2_7 0 NSYN W=10u L=1u
Mn_2_7_3 hv_L1_7 vcn coln_L2_7 0 NSYN W=10u L=1u
C_gp_2_7_4 gp_2_7_4 0 {Cg}
Mp_2_7_4 hv_L1_11 gp_2_7_4 colp_L2_7 0 NSYN W=10u L=1u
Mn_2_7_4 hv_L1_11 vcn coln_L2_7 0 NSYN W=10u L=1u
C_gp_2_7_5 gp_2_7_5 0 {Cg}
Mp_2_7_5 hv_L1_13 gp_2_7_5 colp_L2_7 0 NSYN W=10u L=1u
Mn_2_7_5 hv_L1_13 vcn coln_L2_7 0 NSYN W=10u L=1u
C_gp_2_7_6 gp_2_7_6 0 {Cg}
Mp_2_7_6 hv_L1_14 gp_2_7_6 colp_L2_7 0 NSYN W=10u L=1u
Mn_2_7_6 hv_L1_14 vcn coln_L2_7 0 NSYN W=10u L=1u
C_gp_2_7_7 gp_2_7_7 0 {Cg}
Mp_2_7_7 hv_L1_15 gp_2_7_7 colp_L2_7 0 NSYN W=10u L=1u
Mn_2_7_7 hv_L1_15 vcn coln_L2_7 0 NSYN W=10u L=1u
C_gp_2_7_8 gp_2_7_8 0 {Cg}
Mp_2_7_8 hv_L1_16 gp_2_7_8 colp_L2_7 0 NSYN W=10u L=1u
Mn_2_7_8 hv_L1_16 vcn coln_L2_7 0 NSYN W=10u L=1u
C_gp_2_7_9 gp_2_7_9 0 {Cg}
Mp_2_7_9 hv_L1_19 gp_2_7_9 colp_L2_7 0 NSYN W=10u L=1u
Mn_2_7_9 hv_L1_19 vcn coln_L2_7 0 NSYN W=10u L=1u
C_gp_2_7_10 gp_2_7_10 0 {Cg}
Mp_2_7_10 hv_L1_24 gp_2_7_10 colp_L2_7 0 NSYN W=10u L=1u
Mn_2_7_10 hv_L1_24 vcn coln_L2_7 0 NSYN W=10u L=1u
C_gp_2_7_11 gp_2_7_11 0 {Cg}
Mp_2_7_11 hv_L1_25 gp_2_7_11 colp_L2_7 0 NSYN W=10u L=1u
Mn_2_7_11 hv_L1_25 vcn coln_L2_7 0 NSYN W=10u L=1u
C_gp_2_7_12 gp_2_7_12 0 {Cg}
Mp_2_7_12 hv_L1_29 gp_2_7_12 colp_L2_7 0 NSYN W=10u L=1u
Mn_2_7_12 hv_L1_29 vcn coln_L2_7 0 NSYN W=10u L=1u
C_gp_2_7_13 gp_2_7_13 0 {Cg}
Mp_2_7_13 hv_L1_31 gp_2_7_13 colp_L2_7 0 NSYN W=10u L=1u
Mn_2_7_13 hv_L1_31 vcn coln_L2_7 0 NSYN W=10u L=1u
C_gp_2_7_14 gp_2_7_14 0 {Cg}
Mp_2_7_14 hv_L1_33 gp_2_7_14 colp_L2_7 0 NSYN W=10u L=1u
Mn_2_7_14 hv_L1_33 vcn coln_L2_7 0 NSYN W=10u L=1u
C_gp_2_7_15 gp_2_7_15 0 {Cg}
Mp_2_7_15 hv_L1_35 gp_2_7_15 colp_L2_7 0 NSYN W=10u L=1u
Mn_2_7_15 hv_L1_35 vcn coln_L2_7 0 NSYN W=10u L=1u
C_gp_2_7_b gp_2_7_b 0 {Cg}
Mp_2_7_b bx gp_2_7_b colp_L2_7 0 NSYN W=10u L=1u
Mn_2_7_b bx vcn coln_L2_7 0 NSYN W=10u L=1u
Msa_h_L2_7 coln_L2_7 coln_L2_7 0 0 NMIR W=20u L=1u
Msb_h_L2_7 z_L2_7 coln_L2_7 0 0 NMIR W=20u L=1u
Msc_h_L2_7 colp_L2_7 colp_L2_7 0 0 NMIR W=20u L=1u
Msd_h_L2_7 dpf_h_L2_7 colp_L2_7 0 0 NMIR W=20u L=1u
Mse_h_L2_7 dpf_h_L2_7 dpf_h_L2_7 vdd vdd PMIR W=60u L=1u
Msf_h_L2_7 z_L2_7 dpf_h_L2_7 vdd vdd PMIR W=60u L=1u
R_h_L2_7 z_L2_7 vrefh 8000.0
Mr_L2_7  hdd_L2_7 z_L2_7 tail_L2_7 0 NREL W=12u L=1u
Mr2_L2_7 dmp_L2_7  vmid  tail_L2_7 0 NREL W=12u L=1u
Mtl_L2_7 tail_L2_7 vtb 0 0 NREL W=32.0u L=1u
Mdm_L2_7 dmp_L2_7 dmp_L2_7 vdd vdd PMIR W=40u L=1u
Mrp1_L2_7 hdd_L2_7 hdd_L2_7 vdd vdd PMIR W=40u L=1u
Mrp2_L2_7 hv_L2_7 hdd_L2_7 vdd vdd PMIR W=40u L=1u
Rhv_L2_7 hv_L2_7 vg0 8000.0
C_gp_2_8_0 gp_2_8_0 0 {Cg}
Mp_2_8_0 hv_L1_3 gp_2_8_0 colp_L2_8 0 NSYN W=10u L=1u
Mn_2_8_0 hv_L1_3 vcn coln_L2_8 0 NSYN W=10u L=1u
C_gp_2_8_1 gp_2_8_1 0 {Cg}
Mp_2_8_1 hv_L1_9 gp_2_8_1 colp_L2_8 0 NSYN W=10u L=1u
Mn_2_8_1 hv_L1_9 vcn coln_L2_8 0 NSYN W=10u L=1u
C_gp_2_8_2 gp_2_8_2 0 {Cg}
Mp_2_8_2 hv_L1_11 gp_2_8_2 colp_L2_8 0 NSYN W=10u L=1u
Mn_2_8_2 hv_L1_11 vcn coln_L2_8 0 NSYN W=10u L=1u
C_gp_2_8_3 gp_2_8_3 0 {Cg}
Mp_2_8_3 hv_L1_13 gp_2_8_3 colp_L2_8 0 NSYN W=10u L=1u
Mn_2_8_3 hv_L1_13 vcn coln_L2_8 0 NSYN W=10u L=1u
C_gp_2_8_4 gp_2_8_4 0 {Cg}
Mp_2_8_4 hv_L1_15 gp_2_8_4 colp_L2_8 0 NSYN W=10u L=1u
Mn_2_8_4 hv_L1_15 vcn coln_L2_8 0 NSYN W=10u L=1u
C_gp_2_8_5 gp_2_8_5 0 {Cg}
Mp_2_8_5 hv_L1_16 gp_2_8_5 colp_L2_8 0 NSYN W=10u L=1u
Mn_2_8_5 hv_L1_16 vcn coln_L2_8 0 NSYN W=10u L=1u
C_gp_2_8_6 gp_2_8_6 0 {Cg}
Mp_2_8_6 hv_L1_17 gp_2_8_6 colp_L2_8 0 NSYN W=10u L=1u
Mn_2_8_6 hv_L1_17 vcn coln_L2_8 0 NSYN W=10u L=1u
C_gp_2_8_7 gp_2_8_7 0 {Cg}
Mp_2_8_7 hv_L1_27 gp_2_8_7 colp_L2_8 0 NSYN W=10u L=1u
Mn_2_8_7 hv_L1_27 vcn coln_L2_8 0 NSYN W=10u L=1u
C_gp_2_8_8 gp_2_8_8 0 {Cg}
Mp_2_8_8 hv_L1_30 gp_2_8_8 colp_L2_8 0 NSYN W=10u L=1u
Mn_2_8_8 hv_L1_30 vcn coln_L2_8 0 NSYN W=10u L=1u
C_gp_2_8_9 gp_2_8_9 0 {Cg}
Mp_2_8_9 hv_L1_34 gp_2_8_9 colp_L2_8 0 NSYN W=10u L=1u
Mn_2_8_9 hv_L1_34 vcn coln_L2_8 0 NSYN W=10u L=1u
C_gp_2_8_10 gp_2_8_10 0 {Cg}
Mp_2_8_10 hv_L1_35 gp_2_8_10 colp_L2_8 0 NSYN W=10u L=1u
Mn_2_8_10 hv_L1_35 vcn coln_L2_8 0 NSYN W=10u L=1u
C_gp_2_8_11 gp_2_8_11 0 {Cg}
Mp_2_8_11 hv_L1_39 gp_2_8_11 colp_L2_8 0 NSYN W=10u L=1u
Mn_2_8_11 hv_L1_39 vcn coln_L2_8 0 NSYN W=10u L=1u
C_gp_2_8_12 gp_2_8_12 0 {Cg}
Mp_2_8_12 hv_L1_41 gp_2_8_12 colp_L2_8 0 NSYN W=10u L=1u
Mn_2_8_12 hv_L1_41 vcn coln_L2_8 0 NSYN W=10u L=1u
C_gp_2_8_13 gp_2_8_13 0 {Cg}
Mp_2_8_13 hv_L1_44 gp_2_8_13 colp_L2_8 0 NSYN W=10u L=1u
Mn_2_8_13 hv_L1_44 vcn coln_L2_8 0 NSYN W=10u L=1u
C_gp_2_8_14 gp_2_8_14 0 {Cg}
Mp_2_8_14 hv_L1_45 gp_2_8_14 colp_L2_8 0 NSYN W=10u L=1u
Mn_2_8_14 hv_L1_45 vcn coln_L2_8 0 NSYN W=10u L=1u
C_gp_2_8_15 gp_2_8_15 0 {Cg}
Mp_2_8_15 hv_L1_46 gp_2_8_15 colp_L2_8 0 NSYN W=10u L=1u
Mn_2_8_15 hv_L1_46 vcn coln_L2_8 0 NSYN W=10u L=1u
C_gp_2_8_b gp_2_8_b 0 {Cg}
Mp_2_8_b bx gp_2_8_b colp_L2_8 0 NSYN W=10u L=1u
Mn_2_8_b bx vcn coln_L2_8 0 NSYN W=10u L=1u
Msa_h_L2_8 coln_L2_8 coln_L2_8 0 0 NMIR W=20u L=1u
Msb_h_L2_8 z_L2_8 coln_L2_8 0 0 NMIR W=20u L=1u
Msc_h_L2_8 colp_L2_8 colp_L2_8 0 0 NMIR W=20u L=1u
Msd_h_L2_8 dpf_h_L2_8 colp_L2_8 0 0 NMIR W=20u L=1u
Mse_h_L2_8 dpf_h_L2_8 dpf_h_L2_8 vdd vdd PMIR W=60u L=1u
Msf_h_L2_8 z_L2_8 dpf_h_L2_8 vdd vdd PMIR W=60u L=1u
R_h_L2_8 z_L2_8 vrefh 8000.0
Mr_L2_8  hdd_L2_8 z_L2_8 tail_L2_8 0 NREL W=12u L=1u
Mr2_L2_8 dmp_L2_8  vmid  tail_L2_8 0 NREL W=12u L=1u
Mtl_L2_8 tail_L2_8 vtb 0 0 NREL W=32.0u L=1u
Mdm_L2_8 dmp_L2_8 dmp_L2_8 vdd vdd PMIR W=40u L=1u
Mrp1_L2_8 hdd_L2_8 hdd_L2_8 vdd vdd PMIR W=40u L=1u
Mrp2_L2_8 hv_L2_8 hdd_L2_8 vdd vdd PMIR W=40u L=1u
Rhv_L2_8 hv_L2_8 vg0 8000.0
C_gp_2_9_0 gp_2_9_0 0 {Cg}
Mp_2_9_0 hv_L1_3 gp_2_9_0 colp_L2_9 0 NSYN W=10u L=1u
Mn_2_9_0 hv_L1_3 vcn coln_L2_9 0 NSYN W=10u L=1u
C_gp_2_9_1 gp_2_9_1 0 {Cg}
Mp_2_9_1 hv_L1_4 gp_2_9_1 colp_L2_9 0 NSYN W=10u L=1u
Mn_2_9_1 hv_L1_4 vcn coln_L2_9 0 NSYN W=10u L=1u
C_gp_2_9_2 gp_2_9_2 0 {Cg}
Mp_2_9_2 hv_L1_7 gp_2_9_2 colp_L2_9 0 NSYN W=10u L=1u
Mn_2_9_2 hv_L1_7 vcn coln_L2_9 0 NSYN W=10u L=1u
C_gp_2_9_3 gp_2_9_3 0 {Cg}
Mp_2_9_3 hv_L1_10 gp_2_9_3 colp_L2_9 0 NSYN W=10u L=1u
Mn_2_9_3 hv_L1_10 vcn coln_L2_9 0 NSYN W=10u L=1u
C_gp_2_9_4 gp_2_9_4 0 {Cg}
Mp_2_9_4 hv_L1_11 gp_2_9_4 colp_L2_9 0 NSYN W=10u L=1u
Mn_2_9_4 hv_L1_11 vcn coln_L2_9 0 NSYN W=10u L=1u
C_gp_2_9_5 gp_2_9_5 0 {Cg}
Mp_2_9_5 hv_L1_12 gp_2_9_5 colp_L2_9 0 NSYN W=10u L=1u
Mn_2_9_5 hv_L1_12 vcn coln_L2_9 0 NSYN W=10u L=1u
C_gp_2_9_6 gp_2_9_6 0 {Cg}
Mp_2_9_6 hv_L1_16 gp_2_9_6 colp_L2_9 0 NSYN W=10u L=1u
Mn_2_9_6 hv_L1_16 vcn coln_L2_9 0 NSYN W=10u L=1u
C_gp_2_9_7 gp_2_9_7 0 {Cg}
Mp_2_9_7 hv_L1_19 gp_2_9_7 colp_L2_9 0 NSYN W=10u L=1u
Mn_2_9_7 hv_L1_19 vcn coln_L2_9 0 NSYN W=10u L=1u
C_gp_2_9_8 gp_2_9_8 0 {Cg}
Mp_2_9_8 hv_L1_22 gp_2_9_8 colp_L2_9 0 NSYN W=10u L=1u
Mn_2_9_8 hv_L1_22 vcn coln_L2_9 0 NSYN W=10u L=1u
C_gp_2_9_9 gp_2_9_9 0 {Cg}
Mp_2_9_9 hv_L1_30 gp_2_9_9 colp_L2_9 0 NSYN W=10u L=1u
Mn_2_9_9 hv_L1_30 vcn coln_L2_9 0 NSYN W=10u L=1u
C_gp_2_9_10 gp_2_9_10 0 {Cg}
Mp_2_9_10 hv_L1_31 gp_2_9_10 colp_L2_9 0 NSYN W=10u L=1u
Mn_2_9_10 hv_L1_31 vcn coln_L2_9 0 NSYN W=10u L=1u
C_gp_2_9_11 gp_2_9_11 0 {Cg}
Mp_2_9_11 hv_L1_39 gp_2_9_11 colp_L2_9 0 NSYN W=10u L=1u
Mn_2_9_11 hv_L1_39 vcn coln_L2_9 0 NSYN W=10u L=1u
C_gp_2_9_12 gp_2_9_12 0 {Cg}
Mp_2_9_12 hv_L1_41 gp_2_9_12 colp_L2_9 0 NSYN W=10u L=1u
Mn_2_9_12 hv_L1_41 vcn coln_L2_9 0 NSYN W=10u L=1u
C_gp_2_9_13 gp_2_9_13 0 {Cg}
Mp_2_9_13 hv_L1_42 gp_2_9_13 colp_L2_9 0 NSYN W=10u L=1u
Mn_2_9_13 hv_L1_42 vcn coln_L2_9 0 NSYN W=10u L=1u
C_gp_2_9_14 gp_2_9_14 0 {Cg}
Mp_2_9_14 hv_L1_43 gp_2_9_14 colp_L2_9 0 NSYN W=10u L=1u
Mn_2_9_14 hv_L1_43 vcn coln_L2_9 0 NSYN W=10u L=1u
C_gp_2_9_15 gp_2_9_15 0 {Cg}
Mp_2_9_15 hv_L1_45 gp_2_9_15 colp_L2_9 0 NSYN W=10u L=1u
Mn_2_9_15 hv_L1_45 vcn coln_L2_9 0 NSYN W=10u L=1u
C_gp_2_9_b gp_2_9_b 0 {Cg}
Mp_2_9_b bx gp_2_9_b colp_L2_9 0 NSYN W=10u L=1u
Mn_2_9_b bx vcn coln_L2_9 0 NSYN W=10u L=1u
Msa_h_L2_9 coln_L2_9 coln_L2_9 0 0 NMIR W=20u L=1u
Msb_h_L2_9 z_L2_9 coln_L2_9 0 0 NMIR W=20u L=1u
Msc_h_L2_9 colp_L2_9 colp_L2_9 0 0 NMIR W=20u L=1u
Msd_h_L2_9 dpf_h_L2_9 colp_L2_9 0 0 NMIR W=20u L=1u
Mse_h_L2_9 dpf_h_L2_9 dpf_h_L2_9 vdd vdd PMIR W=60u L=1u
Msf_h_L2_9 z_L2_9 dpf_h_L2_9 vdd vdd PMIR W=60u L=1u
R_h_L2_9 z_L2_9 vrefh 8000.0
Mr_L2_9  hdd_L2_9 z_L2_9 tail_L2_9 0 NREL W=12u L=1u
Mr2_L2_9 dmp_L2_9  vmid  tail_L2_9 0 NREL W=12u L=1u
Mtl_L2_9 tail_L2_9 vtb 0 0 NREL W=32.0u L=1u
Mdm_L2_9 dmp_L2_9 dmp_L2_9 vdd vdd PMIR W=40u L=1u
Mrp1_L2_9 hdd_L2_9 hdd_L2_9 vdd vdd PMIR W=40u L=1u
Mrp2_L2_9 hv_L2_9 hdd_L2_9 vdd vdd PMIR W=40u L=1u
Rhv_L2_9 hv_L2_9 vg0 8000.0
C_gp_2_10_0 gp_2_10_0 0 {Cg}
Mp_2_10_0 hv_L1_2 gp_2_10_0 colp_L2_10 0 NSYN W=10u L=1u
Mn_2_10_0 hv_L1_2 vcn coln_L2_10 0 NSYN W=10u L=1u
C_gp_2_10_1 gp_2_10_1 0 {Cg}
Mp_2_10_1 hv_L1_3 gp_2_10_1 colp_L2_10 0 NSYN W=10u L=1u
Mn_2_10_1 hv_L1_3 vcn coln_L2_10 0 NSYN W=10u L=1u
C_gp_2_10_2 gp_2_10_2 0 {Cg}
Mp_2_10_2 hv_L1_6 gp_2_10_2 colp_L2_10 0 NSYN W=10u L=1u
Mn_2_10_2 hv_L1_6 vcn coln_L2_10 0 NSYN W=10u L=1u
C_gp_2_10_3 gp_2_10_3 0 {Cg}
Mp_2_10_3 hv_L1_7 gp_2_10_3 colp_L2_10 0 NSYN W=10u L=1u
Mn_2_10_3 hv_L1_7 vcn coln_L2_10 0 NSYN W=10u L=1u
C_gp_2_10_4 gp_2_10_4 0 {Cg}
Mp_2_10_4 hv_L1_10 gp_2_10_4 colp_L2_10 0 NSYN W=10u L=1u
Mn_2_10_4 hv_L1_10 vcn coln_L2_10 0 NSYN W=10u L=1u
C_gp_2_10_5 gp_2_10_5 0 {Cg}
Mp_2_10_5 hv_L1_12 gp_2_10_5 colp_L2_10 0 NSYN W=10u L=1u
Mn_2_10_5 hv_L1_12 vcn coln_L2_10 0 NSYN W=10u L=1u
C_gp_2_10_6 gp_2_10_6 0 {Cg}
Mp_2_10_6 hv_L1_13 gp_2_10_6 colp_L2_10 0 NSYN W=10u L=1u
Mn_2_10_6 hv_L1_13 vcn coln_L2_10 0 NSYN W=10u L=1u
C_gp_2_10_7 gp_2_10_7 0 {Cg}
Mp_2_10_7 hv_L1_14 gp_2_10_7 colp_L2_10 0 NSYN W=10u L=1u
Mn_2_10_7 hv_L1_14 vcn coln_L2_10 0 NSYN W=10u L=1u
C_gp_2_10_8 gp_2_10_8 0 {Cg}
Mp_2_10_8 hv_L1_22 gp_2_10_8 colp_L2_10 0 NSYN W=10u L=1u
Mn_2_10_8 hv_L1_22 vcn coln_L2_10 0 NSYN W=10u L=1u
C_gp_2_10_9 gp_2_10_9 0 {Cg}
Mp_2_10_9 hv_L1_26 gp_2_10_9 colp_L2_10 0 NSYN W=10u L=1u
Mn_2_10_9 hv_L1_26 vcn coln_L2_10 0 NSYN W=10u L=1u
C_gp_2_10_10 gp_2_10_10 0 {Cg}
Mp_2_10_10 hv_L1_28 gp_2_10_10 colp_L2_10 0 NSYN W=10u L=1u
Mn_2_10_10 hv_L1_28 vcn coln_L2_10 0 NSYN W=10u L=1u
C_gp_2_10_11 gp_2_10_11 0 {Cg}
Mp_2_10_11 hv_L1_29 gp_2_10_11 colp_L2_10 0 NSYN W=10u L=1u
Mn_2_10_11 hv_L1_29 vcn coln_L2_10 0 NSYN W=10u L=1u
C_gp_2_10_12 gp_2_10_12 0 {Cg}
Mp_2_10_12 hv_L1_31 gp_2_10_12 colp_L2_10 0 NSYN W=10u L=1u
Mn_2_10_12 hv_L1_31 vcn coln_L2_10 0 NSYN W=10u L=1u
C_gp_2_10_13 gp_2_10_13 0 {Cg}
Mp_2_10_13 hv_L1_35 gp_2_10_13 colp_L2_10 0 NSYN W=10u L=1u
Mn_2_10_13 hv_L1_35 vcn coln_L2_10 0 NSYN W=10u L=1u
C_gp_2_10_14 gp_2_10_14 0 {Cg}
Mp_2_10_14 hv_L1_36 gp_2_10_14 colp_L2_10 0 NSYN W=10u L=1u
Mn_2_10_14 hv_L1_36 vcn coln_L2_10 0 NSYN W=10u L=1u
C_gp_2_10_15 gp_2_10_15 0 {Cg}
Mp_2_10_15 hv_L1_47 gp_2_10_15 colp_L2_10 0 NSYN W=10u L=1u
Mn_2_10_15 hv_L1_47 vcn coln_L2_10 0 NSYN W=10u L=1u
C_gp_2_10_b gp_2_10_b 0 {Cg}
Mp_2_10_b bx gp_2_10_b colp_L2_10 0 NSYN W=10u L=1u
Mn_2_10_b bx vcn coln_L2_10 0 NSYN W=10u L=1u
Msa_h_L2_10 coln_L2_10 coln_L2_10 0 0 NMIR W=20u L=1u
Msb_h_L2_10 z_L2_10 coln_L2_10 0 0 NMIR W=20u L=1u
Msc_h_L2_10 colp_L2_10 colp_L2_10 0 0 NMIR W=20u L=1u
Msd_h_L2_10 dpf_h_L2_10 colp_L2_10 0 0 NMIR W=20u L=1u
Mse_h_L2_10 dpf_h_L2_10 dpf_h_L2_10 vdd vdd PMIR W=60u L=1u
Msf_h_L2_10 z_L2_10 dpf_h_L2_10 vdd vdd PMIR W=60u L=1u
R_h_L2_10 z_L2_10 vrefh 8000.0
Mr_L2_10  hdd_L2_10 z_L2_10 tail_L2_10 0 NREL W=12u L=1u
Mr2_L2_10 dmp_L2_10  vmid  tail_L2_10 0 NREL W=12u L=1u
Mtl_L2_10 tail_L2_10 vtb 0 0 NREL W=32.0u L=1u
Mdm_L2_10 dmp_L2_10 dmp_L2_10 vdd vdd PMIR W=40u L=1u
Mrp1_L2_10 hdd_L2_10 hdd_L2_10 vdd vdd PMIR W=40u L=1u
Mrp2_L2_10 hv_L2_10 hdd_L2_10 vdd vdd PMIR W=40u L=1u
Rhv_L2_10 hv_L2_10 vg0 8000.0
C_gp_2_11_0 gp_2_11_0 0 {Cg}
Mp_2_11_0 hv_L1_2 gp_2_11_0 colp_L2_11 0 NSYN W=10u L=1u
Mn_2_11_0 hv_L1_2 vcn coln_L2_11 0 NSYN W=10u L=1u
C_gp_2_11_1 gp_2_11_1 0 {Cg}
Mp_2_11_1 hv_L1_3 gp_2_11_1 colp_L2_11 0 NSYN W=10u L=1u
Mn_2_11_1 hv_L1_3 vcn coln_L2_11 0 NSYN W=10u L=1u
C_gp_2_11_2 gp_2_11_2 0 {Cg}
Mp_2_11_2 hv_L1_7 gp_2_11_2 colp_L2_11 0 NSYN W=10u L=1u
Mn_2_11_2 hv_L1_7 vcn coln_L2_11 0 NSYN W=10u L=1u
C_gp_2_11_3 gp_2_11_3 0 {Cg}
Mp_2_11_3 hv_L1_9 gp_2_11_3 colp_L2_11 0 NSYN W=10u L=1u
Mn_2_11_3 hv_L1_9 vcn coln_L2_11 0 NSYN W=10u L=1u
C_gp_2_11_4 gp_2_11_4 0 {Cg}
Mp_2_11_4 hv_L1_10 gp_2_11_4 colp_L2_11 0 NSYN W=10u L=1u
Mn_2_11_4 hv_L1_10 vcn coln_L2_11 0 NSYN W=10u L=1u
C_gp_2_11_5 gp_2_11_5 0 {Cg}
Mp_2_11_5 hv_L1_13 gp_2_11_5 colp_L2_11 0 NSYN W=10u L=1u
Mn_2_11_5 hv_L1_13 vcn coln_L2_11 0 NSYN W=10u L=1u
C_gp_2_11_6 gp_2_11_6 0 {Cg}
Mp_2_11_6 hv_L1_15 gp_2_11_6 colp_L2_11 0 NSYN W=10u L=1u
Mn_2_11_6 hv_L1_15 vcn coln_L2_11 0 NSYN W=10u L=1u
C_gp_2_11_7 gp_2_11_7 0 {Cg}
Mp_2_11_7 hv_L1_16 gp_2_11_7 colp_L2_11 0 NSYN W=10u L=1u
Mn_2_11_7 hv_L1_16 vcn coln_L2_11 0 NSYN W=10u L=1u
C_gp_2_11_8 gp_2_11_8 0 {Cg}
Mp_2_11_8 hv_L1_22 gp_2_11_8 colp_L2_11 0 NSYN W=10u L=1u
Mn_2_11_8 hv_L1_22 vcn coln_L2_11 0 NSYN W=10u L=1u
C_gp_2_11_9 gp_2_11_9 0 {Cg}
Mp_2_11_9 hv_L1_23 gp_2_11_9 colp_L2_11 0 NSYN W=10u L=1u
Mn_2_11_9 hv_L1_23 vcn coln_L2_11 0 NSYN W=10u L=1u
C_gp_2_11_10 gp_2_11_10 0 {Cg}
Mp_2_11_10 hv_L1_24 gp_2_11_10 colp_L2_11 0 NSYN W=10u L=1u
Mn_2_11_10 hv_L1_24 vcn coln_L2_11 0 NSYN W=10u L=1u
C_gp_2_11_11 gp_2_11_11 0 {Cg}
Mp_2_11_11 hv_L1_26 gp_2_11_11 colp_L2_11 0 NSYN W=10u L=1u
Mn_2_11_11 hv_L1_26 vcn coln_L2_11 0 NSYN W=10u L=1u
C_gp_2_11_12 gp_2_11_12 0 {Cg}
Mp_2_11_12 hv_L1_33 gp_2_11_12 colp_L2_11 0 NSYN W=10u L=1u
Mn_2_11_12 hv_L1_33 vcn coln_L2_11 0 NSYN W=10u L=1u
C_gp_2_11_13 gp_2_11_13 0 {Cg}
Mp_2_11_13 hv_L1_34 gp_2_11_13 colp_L2_11 0 NSYN W=10u L=1u
Mn_2_11_13 hv_L1_34 vcn coln_L2_11 0 NSYN W=10u L=1u
C_gp_2_11_14 gp_2_11_14 0 {Cg}
Mp_2_11_14 hv_L1_37 gp_2_11_14 colp_L2_11 0 NSYN W=10u L=1u
Mn_2_11_14 hv_L1_37 vcn coln_L2_11 0 NSYN W=10u L=1u
C_gp_2_11_15 gp_2_11_15 0 {Cg}
Mp_2_11_15 hv_L1_40 gp_2_11_15 colp_L2_11 0 NSYN W=10u L=1u
Mn_2_11_15 hv_L1_40 vcn coln_L2_11 0 NSYN W=10u L=1u
C_gp_2_11_b gp_2_11_b 0 {Cg}
Mp_2_11_b bx gp_2_11_b colp_L2_11 0 NSYN W=10u L=1u
Mn_2_11_b bx vcn coln_L2_11 0 NSYN W=10u L=1u
Msa_h_L2_11 coln_L2_11 coln_L2_11 0 0 NMIR W=20u L=1u
Msb_h_L2_11 z_L2_11 coln_L2_11 0 0 NMIR W=20u L=1u
Msc_h_L2_11 colp_L2_11 colp_L2_11 0 0 NMIR W=20u L=1u
Msd_h_L2_11 dpf_h_L2_11 colp_L2_11 0 0 NMIR W=20u L=1u
Mse_h_L2_11 dpf_h_L2_11 dpf_h_L2_11 vdd vdd PMIR W=60u L=1u
Msf_h_L2_11 z_L2_11 dpf_h_L2_11 vdd vdd PMIR W=60u L=1u
R_h_L2_11 z_L2_11 vrefh 8000.0
Mr_L2_11  hdd_L2_11 z_L2_11 tail_L2_11 0 NREL W=12u L=1u
Mr2_L2_11 dmp_L2_11  vmid  tail_L2_11 0 NREL W=12u L=1u
Mtl_L2_11 tail_L2_11 vtb 0 0 NREL W=32.0u L=1u
Mdm_L2_11 dmp_L2_11 dmp_L2_11 vdd vdd PMIR W=40u L=1u
Mrp1_L2_11 hdd_L2_11 hdd_L2_11 vdd vdd PMIR W=40u L=1u
Mrp2_L2_11 hv_L2_11 hdd_L2_11 vdd vdd PMIR W=40u L=1u
Rhv_L2_11 hv_L2_11 vg0 8000.0
C_gp_2_12_0 gp_2_12_0 0 {Cg}
Mp_2_12_0 hv_L1_1 gp_2_12_0 colp_L2_12 0 NSYN W=10u L=1u
Mn_2_12_0 hv_L1_1 vcn coln_L2_12 0 NSYN W=10u L=1u
C_gp_2_12_1 gp_2_12_1 0 {Cg}
Mp_2_12_1 hv_L1_6 gp_2_12_1 colp_L2_12 0 NSYN W=10u L=1u
Mn_2_12_1 hv_L1_6 vcn coln_L2_12 0 NSYN W=10u L=1u
C_gp_2_12_2 gp_2_12_2 0 {Cg}
Mp_2_12_2 hv_L1_7 gp_2_12_2 colp_L2_12 0 NSYN W=10u L=1u
Mn_2_12_2 hv_L1_7 vcn coln_L2_12 0 NSYN W=10u L=1u
C_gp_2_12_3 gp_2_12_3 0 {Cg}
Mp_2_12_3 hv_L1_9 gp_2_12_3 colp_L2_12 0 NSYN W=10u L=1u
Mn_2_12_3 hv_L1_9 vcn coln_L2_12 0 NSYN W=10u L=1u
C_gp_2_12_4 gp_2_12_4 0 {Cg}
Mp_2_12_4 hv_L1_13 gp_2_12_4 colp_L2_12 0 NSYN W=10u L=1u
Mn_2_12_4 hv_L1_13 vcn coln_L2_12 0 NSYN W=10u L=1u
C_gp_2_12_5 gp_2_12_5 0 {Cg}
Mp_2_12_5 hv_L1_18 gp_2_12_5 colp_L2_12 0 NSYN W=10u L=1u
Mn_2_12_5 hv_L1_18 vcn coln_L2_12 0 NSYN W=10u L=1u
C_gp_2_12_6 gp_2_12_6 0 {Cg}
Mp_2_12_6 hv_L1_19 gp_2_12_6 colp_L2_12 0 NSYN W=10u L=1u
Mn_2_12_6 hv_L1_19 vcn coln_L2_12 0 NSYN W=10u L=1u
C_gp_2_12_7 gp_2_12_7 0 {Cg}
Mp_2_12_7 hv_L1_23 gp_2_12_7 colp_L2_12 0 NSYN W=10u L=1u
Mn_2_12_7 hv_L1_23 vcn coln_L2_12 0 NSYN W=10u L=1u
C_gp_2_12_8 gp_2_12_8 0 {Cg}
Mp_2_12_8 hv_L1_25 gp_2_12_8 colp_L2_12 0 NSYN W=10u L=1u
Mn_2_12_8 hv_L1_25 vcn coln_L2_12 0 NSYN W=10u L=1u
C_gp_2_12_9 gp_2_12_9 0 {Cg}
Mp_2_12_9 hv_L1_29 gp_2_12_9 colp_L2_12 0 NSYN W=10u L=1u
Mn_2_12_9 hv_L1_29 vcn coln_L2_12 0 NSYN W=10u L=1u
C_gp_2_12_10 gp_2_12_10 0 {Cg}
Mp_2_12_10 hv_L1_35 gp_2_12_10 colp_L2_12 0 NSYN W=10u L=1u
Mn_2_12_10 hv_L1_35 vcn coln_L2_12 0 NSYN W=10u L=1u
C_gp_2_12_11 gp_2_12_11 0 {Cg}
Mp_2_12_11 hv_L1_38 gp_2_12_11 colp_L2_12 0 NSYN W=10u L=1u
Mn_2_12_11 hv_L1_38 vcn coln_L2_12 0 NSYN W=10u L=1u
C_gp_2_12_12 gp_2_12_12 0 {Cg}
Mp_2_12_12 hv_L1_42 gp_2_12_12 colp_L2_12 0 NSYN W=10u L=1u
Mn_2_12_12 hv_L1_42 vcn coln_L2_12 0 NSYN W=10u L=1u
C_gp_2_12_13 gp_2_12_13 0 {Cg}
Mp_2_12_13 hv_L1_43 gp_2_12_13 colp_L2_12 0 NSYN W=10u L=1u
Mn_2_12_13 hv_L1_43 vcn coln_L2_12 0 NSYN W=10u L=1u
C_gp_2_12_14 gp_2_12_14 0 {Cg}
Mp_2_12_14 hv_L1_45 gp_2_12_14 colp_L2_12 0 NSYN W=10u L=1u
Mn_2_12_14 hv_L1_45 vcn coln_L2_12 0 NSYN W=10u L=1u
C_gp_2_12_15 gp_2_12_15 0 {Cg}
Mp_2_12_15 hv_L1_46 gp_2_12_15 colp_L2_12 0 NSYN W=10u L=1u
Mn_2_12_15 hv_L1_46 vcn coln_L2_12 0 NSYN W=10u L=1u
C_gp_2_12_b gp_2_12_b 0 {Cg}
Mp_2_12_b bx gp_2_12_b colp_L2_12 0 NSYN W=10u L=1u
Mn_2_12_b bx vcn coln_L2_12 0 NSYN W=10u L=1u
Msa_h_L2_12 coln_L2_12 coln_L2_12 0 0 NMIR W=20u L=1u
Msb_h_L2_12 z_L2_12 coln_L2_12 0 0 NMIR W=20u L=1u
Msc_h_L2_12 colp_L2_12 colp_L2_12 0 0 NMIR W=20u L=1u
Msd_h_L2_12 dpf_h_L2_12 colp_L2_12 0 0 NMIR W=20u L=1u
Mse_h_L2_12 dpf_h_L2_12 dpf_h_L2_12 vdd vdd PMIR W=60u L=1u
Msf_h_L2_12 z_L2_12 dpf_h_L2_12 vdd vdd PMIR W=60u L=1u
R_h_L2_12 z_L2_12 vrefh 8000.0
Mr_L2_12  hdd_L2_12 z_L2_12 tail_L2_12 0 NREL W=12u L=1u
Mr2_L2_12 dmp_L2_12  vmid  tail_L2_12 0 NREL W=12u L=1u
Mtl_L2_12 tail_L2_12 vtb 0 0 NREL W=32.0u L=1u
Mdm_L2_12 dmp_L2_12 dmp_L2_12 vdd vdd PMIR W=40u L=1u
Mrp1_L2_12 hdd_L2_12 hdd_L2_12 vdd vdd PMIR W=40u L=1u
Mrp2_L2_12 hv_L2_12 hdd_L2_12 vdd vdd PMIR W=40u L=1u
Rhv_L2_12 hv_L2_12 vg0 8000.0
C_gp_2_13_0 gp_2_13_0 0 {Cg}
Mp_2_13_0 hv_L1_0 gp_2_13_0 colp_L2_13 0 NSYN W=10u L=1u
Mn_2_13_0 hv_L1_0 vcn coln_L2_13 0 NSYN W=10u L=1u
C_gp_2_13_1 gp_2_13_1 0 {Cg}
Mp_2_13_1 hv_L1_3 gp_2_13_1 colp_L2_13 0 NSYN W=10u L=1u
Mn_2_13_1 hv_L1_3 vcn coln_L2_13 0 NSYN W=10u L=1u
C_gp_2_13_2 gp_2_13_2 0 {Cg}
Mp_2_13_2 hv_L1_6 gp_2_13_2 colp_L2_13 0 NSYN W=10u L=1u
Mn_2_13_2 hv_L1_6 vcn coln_L2_13 0 NSYN W=10u L=1u
C_gp_2_13_3 gp_2_13_3 0 {Cg}
Mp_2_13_3 hv_L1_9 gp_2_13_3 colp_L2_13 0 NSYN W=10u L=1u
Mn_2_13_3 hv_L1_9 vcn coln_L2_13 0 NSYN W=10u L=1u
C_gp_2_13_4 gp_2_13_4 0 {Cg}
Mp_2_13_4 hv_L1_10 gp_2_13_4 colp_L2_13 0 NSYN W=10u L=1u
Mn_2_13_4 hv_L1_10 vcn coln_L2_13 0 NSYN W=10u L=1u
C_gp_2_13_5 gp_2_13_5 0 {Cg}
Mp_2_13_5 hv_L1_11 gp_2_13_5 colp_L2_13 0 NSYN W=10u L=1u
Mn_2_13_5 hv_L1_11 vcn coln_L2_13 0 NSYN W=10u L=1u
C_gp_2_13_6 gp_2_13_6 0 {Cg}
Mp_2_13_6 hv_L1_12 gp_2_13_6 colp_L2_13 0 NSYN W=10u L=1u
Mn_2_13_6 hv_L1_12 vcn coln_L2_13 0 NSYN W=10u L=1u
C_gp_2_13_7 gp_2_13_7 0 {Cg}
Mp_2_13_7 hv_L1_19 gp_2_13_7 colp_L2_13 0 NSYN W=10u L=1u
Mn_2_13_7 hv_L1_19 vcn coln_L2_13 0 NSYN W=10u L=1u
C_gp_2_13_8 gp_2_13_8 0 {Cg}
Mp_2_13_8 hv_L1_25 gp_2_13_8 colp_L2_13 0 NSYN W=10u L=1u
Mn_2_13_8 hv_L1_25 vcn coln_L2_13 0 NSYN W=10u L=1u
C_gp_2_13_9 gp_2_13_9 0 {Cg}
Mp_2_13_9 hv_L1_31 gp_2_13_9 colp_L2_13 0 NSYN W=10u L=1u
Mn_2_13_9 hv_L1_31 vcn coln_L2_13 0 NSYN W=10u L=1u
C_gp_2_13_10 gp_2_13_10 0 {Cg}
Mp_2_13_10 hv_L1_34 gp_2_13_10 colp_L2_13 0 NSYN W=10u L=1u
Mn_2_13_10 hv_L1_34 vcn coln_L2_13 0 NSYN W=10u L=1u
C_gp_2_13_11 gp_2_13_11 0 {Cg}
Mp_2_13_11 hv_L1_38 gp_2_13_11 colp_L2_13 0 NSYN W=10u L=1u
Mn_2_13_11 hv_L1_38 vcn coln_L2_13 0 NSYN W=10u L=1u
C_gp_2_13_12 gp_2_13_12 0 {Cg}
Mp_2_13_12 hv_L1_39 gp_2_13_12 colp_L2_13 0 NSYN W=10u L=1u
Mn_2_13_12 hv_L1_39 vcn coln_L2_13 0 NSYN W=10u L=1u
C_gp_2_13_13 gp_2_13_13 0 {Cg}
Mp_2_13_13 hv_L1_41 gp_2_13_13 colp_L2_13 0 NSYN W=10u L=1u
Mn_2_13_13 hv_L1_41 vcn coln_L2_13 0 NSYN W=10u L=1u
C_gp_2_13_14 gp_2_13_14 0 {Cg}
Mp_2_13_14 hv_L1_43 gp_2_13_14 colp_L2_13 0 NSYN W=10u L=1u
Mn_2_13_14 hv_L1_43 vcn coln_L2_13 0 NSYN W=10u L=1u
C_gp_2_13_15 gp_2_13_15 0 {Cg}
Mp_2_13_15 hv_L1_44 gp_2_13_15 colp_L2_13 0 NSYN W=10u L=1u
Mn_2_13_15 hv_L1_44 vcn coln_L2_13 0 NSYN W=10u L=1u
C_gp_2_13_b gp_2_13_b 0 {Cg}
Mp_2_13_b bx gp_2_13_b colp_L2_13 0 NSYN W=10u L=1u
Mn_2_13_b bx vcn coln_L2_13 0 NSYN W=10u L=1u
Msa_h_L2_13 coln_L2_13 coln_L2_13 0 0 NMIR W=20u L=1u
Msb_h_L2_13 z_L2_13 coln_L2_13 0 0 NMIR W=20u L=1u
Msc_h_L2_13 colp_L2_13 colp_L2_13 0 0 NMIR W=20u L=1u
Msd_h_L2_13 dpf_h_L2_13 colp_L2_13 0 0 NMIR W=20u L=1u
Mse_h_L2_13 dpf_h_L2_13 dpf_h_L2_13 vdd vdd PMIR W=60u L=1u
Msf_h_L2_13 z_L2_13 dpf_h_L2_13 vdd vdd PMIR W=60u L=1u
R_h_L2_13 z_L2_13 vrefh 8000.0
Mr_L2_13  hdd_L2_13 z_L2_13 tail_L2_13 0 NREL W=12u L=1u
Mr2_L2_13 dmp_L2_13  vmid  tail_L2_13 0 NREL W=12u L=1u
Mtl_L2_13 tail_L2_13 vtb 0 0 NREL W=32.0u L=1u
Mdm_L2_13 dmp_L2_13 dmp_L2_13 vdd vdd PMIR W=40u L=1u
Mrp1_L2_13 hdd_L2_13 hdd_L2_13 vdd vdd PMIR W=40u L=1u
Mrp2_L2_13 hv_L2_13 hdd_L2_13 vdd vdd PMIR W=40u L=1u
Rhv_L2_13 hv_L2_13 vg0 8000.0
C_gp_2_14_0 gp_2_14_0 0 {Cg}
Mp_2_14_0 hv_L1_4 gp_2_14_0 colp_L2_14 0 NSYN W=10u L=1u
Mn_2_14_0 hv_L1_4 vcn coln_L2_14 0 NSYN W=10u L=1u
C_gp_2_14_1 gp_2_14_1 0 {Cg}
Mp_2_14_1 hv_L1_6 gp_2_14_1 colp_L2_14 0 NSYN W=10u L=1u
Mn_2_14_1 hv_L1_6 vcn coln_L2_14 0 NSYN W=10u L=1u
C_gp_2_14_2 gp_2_14_2 0 {Cg}
Mp_2_14_2 hv_L1_10 gp_2_14_2 colp_L2_14 0 NSYN W=10u L=1u
Mn_2_14_2 hv_L1_10 vcn coln_L2_14 0 NSYN W=10u L=1u
C_gp_2_14_3 gp_2_14_3 0 {Cg}
Mp_2_14_3 hv_L1_14 gp_2_14_3 colp_L2_14 0 NSYN W=10u L=1u
Mn_2_14_3 hv_L1_14 vcn coln_L2_14 0 NSYN W=10u L=1u
C_gp_2_14_4 gp_2_14_4 0 {Cg}
Mp_2_14_4 hv_L1_16 gp_2_14_4 colp_L2_14 0 NSYN W=10u L=1u
Mn_2_14_4 hv_L1_16 vcn coln_L2_14 0 NSYN W=10u L=1u
C_gp_2_14_5 gp_2_14_5 0 {Cg}
Mp_2_14_5 hv_L1_17 gp_2_14_5 colp_L2_14 0 NSYN W=10u L=1u
Mn_2_14_5 hv_L1_17 vcn coln_L2_14 0 NSYN W=10u L=1u
C_gp_2_14_6 gp_2_14_6 0 {Cg}
Mp_2_14_6 hv_L1_20 gp_2_14_6 colp_L2_14 0 NSYN W=10u L=1u
Mn_2_14_6 hv_L1_20 vcn coln_L2_14 0 NSYN W=10u L=1u
C_gp_2_14_7 gp_2_14_7 0 {Cg}
Mp_2_14_7 hv_L1_21 gp_2_14_7 colp_L2_14 0 NSYN W=10u L=1u
Mn_2_14_7 hv_L1_21 vcn coln_L2_14 0 NSYN W=10u L=1u
C_gp_2_14_8 gp_2_14_8 0 {Cg}
Mp_2_14_8 hv_L1_22 gp_2_14_8 colp_L2_14 0 NSYN W=10u L=1u
Mn_2_14_8 hv_L1_22 vcn coln_L2_14 0 NSYN W=10u L=1u
C_gp_2_14_9 gp_2_14_9 0 {Cg}
Mp_2_14_9 hv_L1_24 gp_2_14_9 colp_L2_14 0 NSYN W=10u L=1u
Mn_2_14_9 hv_L1_24 vcn coln_L2_14 0 NSYN W=10u L=1u
C_gp_2_14_10 gp_2_14_10 0 {Cg}
Mp_2_14_10 hv_L1_29 gp_2_14_10 colp_L2_14 0 NSYN W=10u L=1u
Mn_2_14_10 hv_L1_29 vcn coln_L2_14 0 NSYN W=10u L=1u
C_gp_2_14_11 gp_2_14_11 0 {Cg}
Mp_2_14_11 hv_L1_33 gp_2_14_11 colp_L2_14 0 NSYN W=10u L=1u
Mn_2_14_11 hv_L1_33 vcn coln_L2_14 0 NSYN W=10u L=1u
C_gp_2_14_12 gp_2_14_12 0 {Cg}
Mp_2_14_12 hv_L1_37 gp_2_14_12 colp_L2_14 0 NSYN W=10u L=1u
Mn_2_14_12 hv_L1_37 vcn coln_L2_14 0 NSYN W=10u L=1u
C_gp_2_14_13 gp_2_14_13 0 {Cg}
Mp_2_14_13 hv_L1_39 gp_2_14_13 colp_L2_14 0 NSYN W=10u L=1u
Mn_2_14_13 hv_L1_39 vcn coln_L2_14 0 NSYN W=10u L=1u
C_gp_2_14_14 gp_2_14_14 0 {Cg}
Mp_2_14_14 hv_L1_41 gp_2_14_14 colp_L2_14 0 NSYN W=10u L=1u
Mn_2_14_14 hv_L1_41 vcn coln_L2_14 0 NSYN W=10u L=1u
C_gp_2_14_15 gp_2_14_15 0 {Cg}
Mp_2_14_15 hv_L1_43 gp_2_14_15 colp_L2_14 0 NSYN W=10u L=1u
Mn_2_14_15 hv_L1_43 vcn coln_L2_14 0 NSYN W=10u L=1u
C_gp_2_14_b gp_2_14_b 0 {Cg}
Mp_2_14_b bx gp_2_14_b colp_L2_14 0 NSYN W=10u L=1u
Mn_2_14_b bx vcn coln_L2_14 0 NSYN W=10u L=1u
Msa_h_L2_14 coln_L2_14 coln_L2_14 0 0 NMIR W=20u L=1u
Msb_h_L2_14 z_L2_14 coln_L2_14 0 0 NMIR W=20u L=1u
Msc_h_L2_14 colp_L2_14 colp_L2_14 0 0 NMIR W=20u L=1u
Msd_h_L2_14 dpf_h_L2_14 colp_L2_14 0 0 NMIR W=20u L=1u
Mse_h_L2_14 dpf_h_L2_14 dpf_h_L2_14 vdd vdd PMIR W=60u L=1u
Msf_h_L2_14 z_L2_14 dpf_h_L2_14 vdd vdd PMIR W=60u L=1u
R_h_L2_14 z_L2_14 vrefh 8000.0
Mr_L2_14  hdd_L2_14 z_L2_14 tail_L2_14 0 NREL W=12u L=1u
Mr2_L2_14 dmp_L2_14  vmid  tail_L2_14 0 NREL W=12u L=1u
Mtl_L2_14 tail_L2_14 vtb 0 0 NREL W=32.0u L=1u
Mdm_L2_14 dmp_L2_14 dmp_L2_14 vdd vdd PMIR W=40u L=1u
Mrp1_L2_14 hdd_L2_14 hdd_L2_14 vdd vdd PMIR W=40u L=1u
Mrp2_L2_14 hv_L2_14 hdd_L2_14 vdd vdd PMIR W=40u L=1u
Rhv_L2_14 hv_L2_14 vg0 8000.0
C_gp_2_15_0 gp_2_15_0 0 {Cg}
Mp_2_15_0 hv_L1_1 gp_2_15_0 colp_L2_15 0 NSYN W=10u L=1u
Mn_2_15_0 hv_L1_1 vcn coln_L2_15 0 NSYN W=10u L=1u
C_gp_2_15_1 gp_2_15_1 0 {Cg}
Mp_2_15_1 hv_L1_2 gp_2_15_1 colp_L2_15 0 NSYN W=10u L=1u
Mn_2_15_1 hv_L1_2 vcn coln_L2_15 0 NSYN W=10u L=1u
C_gp_2_15_2 gp_2_15_2 0 {Cg}
Mp_2_15_2 hv_L1_3 gp_2_15_2 colp_L2_15 0 NSYN W=10u L=1u
Mn_2_15_2 hv_L1_3 vcn coln_L2_15 0 NSYN W=10u L=1u
C_gp_2_15_3 gp_2_15_3 0 {Cg}
Mp_2_15_3 hv_L1_5 gp_2_15_3 colp_L2_15 0 NSYN W=10u L=1u
Mn_2_15_3 hv_L1_5 vcn coln_L2_15 0 NSYN W=10u L=1u
C_gp_2_15_4 gp_2_15_4 0 {Cg}
Mp_2_15_4 hv_L1_11 gp_2_15_4 colp_L2_15 0 NSYN W=10u L=1u
Mn_2_15_4 hv_L1_11 vcn coln_L2_15 0 NSYN W=10u L=1u
C_gp_2_15_5 gp_2_15_5 0 {Cg}
Mp_2_15_5 hv_L1_16 gp_2_15_5 colp_L2_15 0 NSYN W=10u L=1u
Mn_2_15_5 hv_L1_16 vcn coln_L2_15 0 NSYN W=10u L=1u
C_gp_2_15_6 gp_2_15_6 0 {Cg}
Mp_2_15_6 hv_L1_26 gp_2_15_6 colp_L2_15 0 NSYN W=10u L=1u
Mn_2_15_6 hv_L1_26 vcn coln_L2_15 0 NSYN W=10u L=1u
C_gp_2_15_7 gp_2_15_7 0 {Cg}
Mp_2_15_7 hv_L1_27 gp_2_15_7 colp_L2_15 0 NSYN W=10u L=1u
Mn_2_15_7 hv_L1_27 vcn coln_L2_15 0 NSYN W=10u L=1u
C_gp_2_15_8 gp_2_15_8 0 {Cg}
Mp_2_15_8 hv_L1_30 gp_2_15_8 colp_L2_15 0 NSYN W=10u L=1u
Mn_2_15_8 hv_L1_30 vcn coln_L2_15 0 NSYN W=10u L=1u
C_gp_2_15_9 gp_2_15_9 0 {Cg}
Mp_2_15_9 hv_L1_33 gp_2_15_9 colp_L2_15 0 NSYN W=10u L=1u
Mn_2_15_9 hv_L1_33 vcn coln_L2_15 0 NSYN W=10u L=1u
C_gp_2_15_10 gp_2_15_10 0 {Cg}
Mp_2_15_10 hv_L1_34 gp_2_15_10 colp_L2_15 0 NSYN W=10u L=1u
Mn_2_15_10 hv_L1_34 vcn coln_L2_15 0 NSYN W=10u L=1u
C_gp_2_15_11 gp_2_15_11 0 {Cg}
Mp_2_15_11 hv_L1_35 gp_2_15_11 colp_L2_15 0 NSYN W=10u L=1u
Mn_2_15_11 hv_L1_35 vcn coln_L2_15 0 NSYN W=10u L=1u
C_gp_2_15_12 gp_2_15_12 0 {Cg}
Mp_2_15_12 hv_L1_36 gp_2_15_12 colp_L2_15 0 NSYN W=10u L=1u
Mn_2_15_12 hv_L1_36 vcn coln_L2_15 0 NSYN W=10u L=1u
C_gp_2_15_13 gp_2_15_13 0 {Cg}
Mp_2_15_13 hv_L1_41 gp_2_15_13 colp_L2_15 0 NSYN W=10u L=1u
Mn_2_15_13 hv_L1_41 vcn coln_L2_15 0 NSYN W=10u L=1u
C_gp_2_15_14 gp_2_15_14 0 {Cg}
Mp_2_15_14 hv_L1_43 gp_2_15_14 colp_L2_15 0 NSYN W=10u L=1u
Mn_2_15_14 hv_L1_43 vcn coln_L2_15 0 NSYN W=10u L=1u
C_gp_2_15_15 gp_2_15_15 0 {Cg}
Mp_2_15_15 hv_L1_46 gp_2_15_15 colp_L2_15 0 NSYN W=10u L=1u
Mn_2_15_15 hv_L1_46 vcn coln_L2_15 0 NSYN W=10u L=1u
C_gp_2_15_b gp_2_15_b 0 {Cg}
Mp_2_15_b bx gp_2_15_b colp_L2_15 0 NSYN W=10u L=1u
Mn_2_15_b bx vcn coln_L2_15 0 NSYN W=10u L=1u
Msa_h_L2_15 coln_L2_15 coln_L2_15 0 0 NMIR W=20u L=1u
Msb_h_L2_15 z_L2_15 coln_L2_15 0 0 NMIR W=20u L=1u
Msc_h_L2_15 colp_L2_15 colp_L2_15 0 0 NMIR W=20u L=1u
Msd_h_L2_15 dpf_h_L2_15 colp_L2_15 0 0 NMIR W=20u L=1u
Mse_h_L2_15 dpf_h_L2_15 dpf_h_L2_15 vdd vdd PMIR W=60u L=1u
Msf_h_L2_15 z_L2_15 dpf_h_L2_15 vdd vdd PMIR W=60u L=1u
R_h_L2_15 z_L2_15 vrefh 8000.0
Mr_L2_15  hdd_L2_15 z_L2_15 tail_L2_15 0 NREL W=12u L=1u
Mr2_L2_15 dmp_L2_15  vmid  tail_L2_15 0 NREL W=12u L=1u
Mtl_L2_15 tail_L2_15 vtb 0 0 NREL W=32.0u L=1u
Mdm_L2_15 dmp_L2_15 dmp_L2_15 vdd vdd PMIR W=40u L=1u
Mrp1_L2_15 hdd_L2_15 hdd_L2_15 vdd vdd PMIR W=40u L=1u
Mrp2_L2_15 hv_L2_15 hdd_L2_15 vdd vdd PMIR W=40u L=1u
Rhv_L2_15 hv_L2_15 vg0 8000.0
C_gp_2_16_0 gp_2_16_0 0 {Cg}
Mp_2_16_0 hv_L1_2 gp_2_16_0 colp_L2_16 0 NSYN W=10u L=1u
Mn_2_16_0 hv_L1_2 vcn coln_L2_16 0 NSYN W=10u L=1u
C_gp_2_16_1 gp_2_16_1 0 {Cg}
Mp_2_16_1 hv_L1_3 gp_2_16_1 colp_L2_16 0 NSYN W=10u L=1u
Mn_2_16_1 hv_L1_3 vcn coln_L2_16 0 NSYN W=10u L=1u
C_gp_2_16_2 gp_2_16_2 0 {Cg}
Mp_2_16_2 hv_L1_4 gp_2_16_2 colp_L2_16 0 NSYN W=10u L=1u
Mn_2_16_2 hv_L1_4 vcn coln_L2_16 0 NSYN W=10u L=1u
C_gp_2_16_3 gp_2_16_3 0 {Cg}
Mp_2_16_3 hv_L1_7 gp_2_16_3 colp_L2_16 0 NSYN W=10u L=1u
Mn_2_16_3 hv_L1_7 vcn coln_L2_16 0 NSYN W=10u L=1u
C_gp_2_16_4 gp_2_16_4 0 {Cg}
Mp_2_16_4 hv_L1_16 gp_2_16_4 colp_L2_16 0 NSYN W=10u L=1u
Mn_2_16_4 hv_L1_16 vcn coln_L2_16 0 NSYN W=10u L=1u
C_gp_2_16_5 gp_2_16_5 0 {Cg}
Mp_2_16_5 hv_L1_19 gp_2_16_5 colp_L2_16 0 NSYN W=10u L=1u
Mn_2_16_5 hv_L1_19 vcn coln_L2_16 0 NSYN W=10u L=1u
C_gp_2_16_6 gp_2_16_6 0 {Cg}
Mp_2_16_6 hv_L1_21 gp_2_16_6 colp_L2_16 0 NSYN W=10u L=1u
Mn_2_16_6 hv_L1_21 vcn coln_L2_16 0 NSYN W=10u L=1u
C_gp_2_16_7 gp_2_16_7 0 {Cg}
Mp_2_16_7 hv_L1_22 gp_2_16_7 colp_L2_16 0 NSYN W=10u L=1u
Mn_2_16_7 hv_L1_22 vcn coln_L2_16 0 NSYN W=10u L=1u
C_gp_2_16_8 gp_2_16_8 0 {Cg}
Mp_2_16_8 hv_L1_24 gp_2_16_8 colp_L2_16 0 NSYN W=10u L=1u
Mn_2_16_8 hv_L1_24 vcn coln_L2_16 0 NSYN W=10u L=1u
C_gp_2_16_9 gp_2_16_9 0 {Cg}
Mp_2_16_9 hv_L1_27 gp_2_16_9 colp_L2_16 0 NSYN W=10u L=1u
Mn_2_16_9 hv_L1_27 vcn coln_L2_16 0 NSYN W=10u L=1u
C_gp_2_16_10 gp_2_16_10 0 {Cg}
Mp_2_16_10 hv_L1_34 gp_2_16_10 colp_L2_16 0 NSYN W=10u L=1u
Mn_2_16_10 hv_L1_34 vcn coln_L2_16 0 NSYN W=10u L=1u
C_gp_2_16_11 gp_2_16_11 0 {Cg}
Mp_2_16_11 hv_L1_35 gp_2_16_11 colp_L2_16 0 NSYN W=10u L=1u
Mn_2_16_11 hv_L1_35 vcn coln_L2_16 0 NSYN W=10u L=1u
C_gp_2_16_12 gp_2_16_12 0 {Cg}
Mp_2_16_12 hv_L1_36 gp_2_16_12 colp_L2_16 0 NSYN W=10u L=1u
Mn_2_16_12 hv_L1_36 vcn coln_L2_16 0 NSYN W=10u L=1u
C_gp_2_16_13 gp_2_16_13 0 {Cg}
Mp_2_16_13 hv_L1_41 gp_2_16_13 colp_L2_16 0 NSYN W=10u L=1u
Mn_2_16_13 hv_L1_41 vcn coln_L2_16 0 NSYN W=10u L=1u
C_gp_2_16_14 gp_2_16_14 0 {Cg}
Mp_2_16_14 hv_L1_42 gp_2_16_14 colp_L2_16 0 NSYN W=10u L=1u
Mn_2_16_14 hv_L1_42 vcn coln_L2_16 0 NSYN W=10u L=1u
C_gp_2_16_15 gp_2_16_15 0 {Cg}
Mp_2_16_15 hv_L1_45 gp_2_16_15 colp_L2_16 0 NSYN W=10u L=1u
Mn_2_16_15 hv_L1_45 vcn coln_L2_16 0 NSYN W=10u L=1u
C_gp_2_16_b gp_2_16_b 0 {Cg}
Mp_2_16_b bx gp_2_16_b colp_L2_16 0 NSYN W=10u L=1u
Mn_2_16_b bx vcn coln_L2_16 0 NSYN W=10u L=1u
Msa_h_L2_16 coln_L2_16 coln_L2_16 0 0 NMIR W=20u L=1u
Msb_h_L2_16 z_L2_16 coln_L2_16 0 0 NMIR W=20u L=1u
Msc_h_L2_16 colp_L2_16 colp_L2_16 0 0 NMIR W=20u L=1u
Msd_h_L2_16 dpf_h_L2_16 colp_L2_16 0 0 NMIR W=20u L=1u
Mse_h_L2_16 dpf_h_L2_16 dpf_h_L2_16 vdd vdd PMIR W=60u L=1u
Msf_h_L2_16 z_L2_16 dpf_h_L2_16 vdd vdd PMIR W=60u L=1u
R_h_L2_16 z_L2_16 vrefh 8000.0
Mr_L2_16  hdd_L2_16 z_L2_16 tail_L2_16 0 NREL W=12u L=1u
Mr2_L2_16 dmp_L2_16  vmid  tail_L2_16 0 NREL W=12u L=1u
Mtl_L2_16 tail_L2_16 vtb 0 0 NREL W=32.0u L=1u
Mdm_L2_16 dmp_L2_16 dmp_L2_16 vdd vdd PMIR W=40u L=1u
Mrp1_L2_16 hdd_L2_16 hdd_L2_16 vdd vdd PMIR W=40u L=1u
Mrp2_L2_16 hv_L2_16 hdd_L2_16 vdd vdd PMIR W=40u L=1u
Rhv_L2_16 hv_L2_16 vg0 8000.0
C_gp_2_17_0 gp_2_17_0 0 {Cg}
Mp_2_17_0 hv_L1_0 gp_2_17_0 colp_L2_17 0 NSYN W=10u L=1u
Mn_2_17_0 hv_L1_0 vcn coln_L2_17 0 NSYN W=10u L=1u
C_gp_2_17_1 gp_2_17_1 0 {Cg}
Mp_2_17_1 hv_L1_1 gp_2_17_1 colp_L2_17 0 NSYN W=10u L=1u
Mn_2_17_1 hv_L1_1 vcn coln_L2_17 0 NSYN W=10u L=1u
C_gp_2_17_2 gp_2_17_2 0 {Cg}
Mp_2_17_2 hv_L1_3 gp_2_17_2 colp_L2_17 0 NSYN W=10u L=1u
Mn_2_17_2 hv_L1_3 vcn coln_L2_17 0 NSYN W=10u L=1u
C_gp_2_17_3 gp_2_17_3 0 {Cg}
Mp_2_17_3 hv_L1_4 gp_2_17_3 colp_L2_17 0 NSYN W=10u L=1u
Mn_2_17_3 hv_L1_4 vcn coln_L2_17 0 NSYN W=10u L=1u
C_gp_2_17_4 gp_2_17_4 0 {Cg}
Mp_2_17_4 hv_L1_8 gp_2_17_4 colp_L2_17 0 NSYN W=10u L=1u
Mn_2_17_4 hv_L1_8 vcn coln_L2_17 0 NSYN W=10u L=1u
C_gp_2_17_5 gp_2_17_5 0 {Cg}
Mp_2_17_5 hv_L1_10 gp_2_17_5 colp_L2_17 0 NSYN W=10u L=1u
Mn_2_17_5 hv_L1_10 vcn coln_L2_17 0 NSYN W=10u L=1u
C_gp_2_17_6 gp_2_17_6 0 {Cg}
Mp_2_17_6 hv_L1_12 gp_2_17_6 colp_L2_17 0 NSYN W=10u L=1u
Mn_2_17_6 hv_L1_12 vcn coln_L2_17 0 NSYN W=10u L=1u
C_gp_2_17_7 gp_2_17_7 0 {Cg}
Mp_2_17_7 hv_L1_13 gp_2_17_7 colp_L2_17 0 NSYN W=10u L=1u
Mn_2_17_7 hv_L1_13 vcn coln_L2_17 0 NSYN W=10u L=1u
C_gp_2_17_8 gp_2_17_8 0 {Cg}
Mp_2_17_8 hv_L1_15 gp_2_17_8 colp_L2_17 0 NSYN W=10u L=1u
Mn_2_17_8 hv_L1_15 vcn coln_L2_17 0 NSYN W=10u L=1u
C_gp_2_17_9 gp_2_17_9 0 {Cg}
Mp_2_17_9 hv_L1_19 gp_2_17_9 colp_L2_17 0 NSYN W=10u L=1u
Mn_2_17_9 hv_L1_19 vcn coln_L2_17 0 NSYN W=10u L=1u
C_gp_2_17_10 gp_2_17_10 0 {Cg}
Mp_2_17_10 hv_L1_26 gp_2_17_10 colp_L2_17 0 NSYN W=10u L=1u
Mn_2_17_10 hv_L1_26 vcn coln_L2_17 0 NSYN W=10u L=1u
C_gp_2_17_11 gp_2_17_11 0 {Cg}
Mp_2_17_11 hv_L1_35 gp_2_17_11 colp_L2_17 0 NSYN W=10u L=1u
Mn_2_17_11 hv_L1_35 vcn coln_L2_17 0 NSYN W=10u L=1u
C_gp_2_17_12 gp_2_17_12 0 {Cg}
Mp_2_17_12 hv_L1_37 gp_2_17_12 colp_L2_17 0 NSYN W=10u L=1u
Mn_2_17_12 hv_L1_37 vcn coln_L2_17 0 NSYN W=10u L=1u
C_gp_2_17_13 gp_2_17_13 0 {Cg}
Mp_2_17_13 hv_L1_38 gp_2_17_13 colp_L2_17 0 NSYN W=10u L=1u
Mn_2_17_13 hv_L1_38 vcn coln_L2_17 0 NSYN W=10u L=1u
C_gp_2_17_14 gp_2_17_14 0 {Cg}
Mp_2_17_14 hv_L1_39 gp_2_17_14 colp_L2_17 0 NSYN W=10u L=1u
Mn_2_17_14 hv_L1_39 vcn coln_L2_17 0 NSYN W=10u L=1u
C_gp_2_17_15 gp_2_17_15 0 {Cg}
Mp_2_17_15 hv_L1_46 gp_2_17_15 colp_L2_17 0 NSYN W=10u L=1u
Mn_2_17_15 hv_L1_46 vcn coln_L2_17 0 NSYN W=10u L=1u
C_gp_2_17_b gp_2_17_b 0 {Cg}
Mp_2_17_b bx gp_2_17_b colp_L2_17 0 NSYN W=10u L=1u
Mn_2_17_b bx vcn coln_L2_17 0 NSYN W=10u L=1u
Msa_h_L2_17 coln_L2_17 coln_L2_17 0 0 NMIR W=20u L=1u
Msb_h_L2_17 z_L2_17 coln_L2_17 0 0 NMIR W=20u L=1u
Msc_h_L2_17 colp_L2_17 colp_L2_17 0 0 NMIR W=20u L=1u
Msd_h_L2_17 dpf_h_L2_17 colp_L2_17 0 0 NMIR W=20u L=1u
Mse_h_L2_17 dpf_h_L2_17 dpf_h_L2_17 vdd vdd PMIR W=60u L=1u
Msf_h_L2_17 z_L2_17 dpf_h_L2_17 vdd vdd PMIR W=60u L=1u
R_h_L2_17 z_L2_17 vrefh 8000.0
Mr_L2_17  hdd_L2_17 z_L2_17 tail_L2_17 0 NREL W=12u L=1u
Mr2_L2_17 dmp_L2_17  vmid  tail_L2_17 0 NREL W=12u L=1u
Mtl_L2_17 tail_L2_17 vtb 0 0 NREL W=32.0u L=1u
Mdm_L2_17 dmp_L2_17 dmp_L2_17 vdd vdd PMIR W=40u L=1u
Mrp1_L2_17 hdd_L2_17 hdd_L2_17 vdd vdd PMIR W=40u L=1u
Mrp2_L2_17 hv_L2_17 hdd_L2_17 vdd vdd PMIR W=40u L=1u
Rhv_L2_17 hv_L2_17 vg0 8000.0
C_gp_2_18_0 gp_2_18_0 0 {Cg}
Mp_2_18_0 hv_L1_2 gp_2_18_0 colp_L2_18 0 NSYN W=10u L=1u
Mn_2_18_0 hv_L1_2 vcn coln_L2_18 0 NSYN W=10u L=1u
C_gp_2_18_1 gp_2_18_1 0 {Cg}
Mp_2_18_1 hv_L1_5 gp_2_18_1 colp_L2_18 0 NSYN W=10u L=1u
Mn_2_18_1 hv_L1_5 vcn coln_L2_18 0 NSYN W=10u L=1u
C_gp_2_18_2 gp_2_18_2 0 {Cg}
Mp_2_18_2 hv_L1_6 gp_2_18_2 colp_L2_18 0 NSYN W=10u L=1u
Mn_2_18_2 hv_L1_6 vcn coln_L2_18 0 NSYN W=10u L=1u
C_gp_2_18_3 gp_2_18_3 0 {Cg}
Mp_2_18_3 hv_L1_11 gp_2_18_3 colp_L2_18 0 NSYN W=10u L=1u
Mn_2_18_3 hv_L1_11 vcn coln_L2_18 0 NSYN W=10u L=1u
C_gp_2_18_4 gp_2_18_4 0 {Cg}
Mp_2_18_4 hv_L1_14 gp_2_18_4 colp_L2_18 0 NSYN W=10u L=1u
Mn_2_18_4 hv_L1_14 vcn coln_L2_18 0 NSYN W=10u L=1u
C_gp_2_18_5 gp_2_18_5 0 {Cg}
Mp_2_18_5 hv_L1_16 gp_2_18_5 colp_L2_18 0 NSYN W=10u L=1u
Mn_2_18_5 hv_L1_16 vcn coln_L2_18 0 NSYN W=10u L=1u
C_gp_2_18_6 gp_2_18_6 0 {Cg}
Mp_2_18_6 hv_L1_19 gp_2_18_6 colp_L2_18 0 NSYN W=10u L=1u
Mn_2_18_6 hv_L1_19 vcn coln_L2_18 0 NSYN W=10u L=1u
C_gp_2_18_7 gp_2_18_7 0 {Cg}
Mp_2_18_7 hv_L1_25 gp_2_18_7 colp_L2_18 0 NSYN W=10u L=1u
Mn_2_18_7 hv_L1_25 vcn coln_L2_18 0 NSYN W=10u L=1u
C_gp_2_18_8 gp_2_18_8 0 {Cg}
Mp_2_18_8 hv_L1_27 gp_2_18_8 colp_L2_18 0 NSYN W=10u L=1u
Mn_2_18_8 hv_L1_27 vcn coln_L2_18 0 NSYN W=10u L=1u
C_gp_2_18_9 gp_2_18_9 0 {Cg}
Mp_2_18_9 hv_L1_29 gp_2_18_9 colp_L2_18 0 NSYN W=10u L=1u
Mn_2_18_9 hv_L1_29 vcn coln_L2_18 0 NSYN W=10u L=1u
C_gp_2_18_10 gp_2_18_10 0 {Cg}
Mp_2_18_10 hv_L1_30 gp_2_18_10 colp_L2_18 0 NSYN W=10u L=1u
Mn_2_18_10 hv_L1_30 vcn coln_L2_18 0 NSYN W=10u L=1u
C_gp_2_18_11 gp_2_18_11 0 {Cg}
Mp_2_18_11 hv_L1_32 gp_2_18_11 colp_L2_18 0 NSYN W=10u L=1u
Mn_2_18_11 hv_L1_32 vcn coln_L2_18 0 NSYN W=10u L=1u
C_gp_2_18_12 gp_2_18_12 0 {Cg}
Mp_2_18_12 hv_L1_33 gp_2_18_12 colp_L2_18 0 NSYN W=10u L=1u
Mn_2_18_12 hv_L1_33 vcn coln_L2_18 0 NSYN W=10u L=1u
C_gp_2_18_13 gp_2_18_13 0 {Cg}
Mp_2_18_13 hv_L1_34 gp_2_18_13 colp_L2_18 0 NSYN W=10u L=1u
Mn_2_18_13 hv_L1_34 vcn coln_L2_18 0 NSYN W=10u L=1u
C_gp_2_18_14 gp_2_18_14 0 {Cg}
Mp_2_18_14 hv_L1_35 gp_2_18_14 colp_L2_18 0 NSYN W=10u L=1u
Mn_2_18_14 hv_L1_35 vcn coln_L2_18 0 NSYN W=10u L=1u
C_gp_2_18_15 gp_2_18_15 0 {Cg}
Mp_2_18_15 hv_L1_39 gp_2_18_15 colp_L2_18 0 NSYN W=10u L=1u
Mn_2_18_15 hv_L1_39 vcn coln_L2_18 0 NSYN W=10u L=1u
C_gp_2_18_b gp_2_18_b 0 {Cg}
Mp_2_18_b bx gp_2_18_b colp_L2_18 0 NSYN W=10u L=1u
Mn_2_18_b bx vcn coln_L2_18 0 NSYN W=10u L=1u
Msa_h_L2_18 coln_L2_18 coln_L2_18 0 0 NMIR W=20u L=1u
Msb_h_L2_18 z_L2_18 coln_L2_18 0 0 NMIR W=20u L=1u
Msc_h_L2_18 colp_L2_18 colp_L2_18 0 0 NMIR W=20u L=1u
Msd_h_L2_18 dpf_h_L2_18 colp_L2_18 0 0 NMIR W=20u L=1u
Mse_h_L2_18 dpf_h_L2_18 dpf_h_L2_18 vdd vdd PMIR W=60u L=1u
Msf_h_L2_18 z_L2_18 dpf_h_L2_18 vdd vdd PMIR W=60u L=1u
R_h_L2_18 z_L2_18 vrefh 8000.0
Mr_L2_18  hdd_L2_18 z_L2_18 tail_L2_18 0 NREL W=12u L=1u
Mr2_L2_18 dmp_L2_18  vmid  tail_L2_18 0 NREL W=12u L=1u
Mtl_L2_18 tail_L2_18 vtb 0 0 NREL W=32.0u L=1u
Mdm_L2_18 dmp_L2_18 dmp_L2_18 vdd vdd PMIR W=40u L=1u
Mrp1_L2_18 hdd_L2_18 hdd_L2_18 vdd vdd PMIR W=40u L=1u
Mrp2_L2_18 hv_L2_18 hdd_L2_18 vdd vdd PMIR W=40u L=1u
Rhv_L2_18 hv_L2_18 vg0 8000.0
C_gp_2_19_0 gp_2_19_0 0 {Cg}
Mp_2_19_0 hv_L1_0 gp_2_19_0 colp_L2_19 0 NSYN W=10u L=1u
Mn_2_19_0 hv_L1_0 vcn coln_L2_19 0 NSYN W=10u L=1u
C_gp_2_19_1 gp_2_19_1 0 {Cg}
Mp_2_19_1 hv_L1_5 gp_2_19_1 colp_L2_19 0 NSYN W=10u L=1u
Mn_2_19_1 hv_L1_5 vcn coln_L2_19 0 NSYN W=10u L=1u
C_gp_2_19_2 gp_2_19_2 0 {Cg}
Mp_2_19_2 hv_L1_10 gp_2_19_2 colp_L2_19 0 NSYN W=10u L=1u
Mn_2_19_2 hv_L1_10 vcn coln_L2_19 0 NSYN W=10u L=1u
C_gp_2_19_3 gp_2_19_3 0 {Cg}
Mp_2_19_3 hv_L1_12 gp_2_19_3 colp_L2_19 0 NSYN W=10u L=1u
Mn_2_19_3 hv_L1_12 vcn coln_L2_19 0 NSYN W=10u L=1u
C_gp_2_19_4 gp_2_19_4 0 {Cg}
Mp_2_19_4 hv_L1_13 gp_2_19_4 colp_L2_19 0 NSYN W=10u L=1u
Mn_2_19_4 hv_L1_13 vcn coln_L2_19 0 NSYN W=10u L=1u
C_gp_2_19_5 gp_2_19_5 0 {Cg}
Mp_2_19_5 hv_L1_14 gp_2_19_5 colp_L2_19 0 NSYN W=10u L=1u
Mn_2_19_5 hv_L1_14 vcn coln_L2_19 0 NSYN W=10u L=1u
C_gp_2_19_6 gp_2_19_6 0 {Cg}
Mp_2_19_6 hv_L1_23 gp_2_19_6 colp_L2_19 0 NSYN W=10u L=1u
Mn_2_19_6 hv_L1_23 vcn coln_L2_19 0 NSYN W=10u L=1u
C_gp_2_19_7 gp_2_19_7 0 {Cg}
Mp_2_19_7 hv_L1_25 gp_2_19_7 colp_L2_19 0 NSYN W=10u L=1u
Mn_2_19_7 hv_L1_25 vcn coln_L2_19 0 NSYN W=10u L=1u
C_gp_2_19_8 gp_2_19_8 0 {Cg}
Mp_2_19_8 hv_L1_27 gp_2_19_8 colp_L2_19 0 NSYN W=10u L=1u
Mn_2_19_8 hv_L1_27 vcn coln_L2_19 0 NSYN W=10u L=1u
C_gp_2_19_9 gp_2_19_9 0 {Cg}
Mp_2_19_9 hv_L1_29 gp_2_19_9 colp_L2_19 0 NSYN W=10u L=1u
Mn_2_19_9 hv_L1_29 vcn coln_L2_19 0 NSYN W=10u L=1u
C_gp_2_19_10 gp_2_19_10 0 {Cg}
Mp_2_19_10 hv_L1_31 gp_2_19_10 colp_L2_19 0 NSYN W=10u L=1u
Mn_2_19_10 hv_L1_31 vcn coln_L2_19 0 NSYN W=10u L=1u
C_gp_2_19_11 gp_2_19_11 0 {Cg}
Mp_2_19_11 hv_L1_38 gp_2_19_11 colp_L2_19 0 NSYN W=10u L=1u
Mn_2_19_11 hv_L1_38 vcn coln_L2_19 0 NSYN W=10u L=1u
C_gp_2_19_12 gp_2_19_12 0 {Cg}
Mp_2_19_12 hv_L1_40 gp_2_19_12 colp_L2_19 0 NSYN W=10u L=1u
Mn_2_19_12 hv_L1_40 vcn coln_L2_19 0 NSYN W=10u L=1u
C_gp_2_19_13 gp_2_19_13 0 {Cg}
Mp_2_19_13 hv_L1_42 gp_2_19_13 colp_L2_19 0 NSYN W=10u L=1u
Mn_2_19_13 hv_L1_42 vcn coln_L2_19 0 NSYN W=10u L=1u
C_gp_2_19_14 gp_2_19_14 0 {Cg}
Mp_2_19_14 hv_L1_44 gp_2_19_14 colp_L2_19 0 NSYN W=10u L=1u
Mn_2_19_14 hv_L1_44 vcn coln_L2_19 0 NSYN W=10u L=1u
C_gp_2_19_15 gp_2_19_15 0 {Cg}
Mp_2_19_15 hv_L1_45 gp_2_19_15 colp_L2_19 0 NSYN W=10u L=1u
Mn_2_19_15 hv_L1_45 vcn coln_L2_19 0 NSYN W=10u L=1u
C_gp_2_19_b gp_2_19_b 0 {Cg}
Mp_2_19_b bx gp_2_19_b colp_L2_19 0 NSYN W=10u L=1u
Mn_2_19_b bx vcn coln_L2_19 0 NSYN W=10u L=1u
Msa_h_L2_19 coln_L2_19 coln_L2_19 0 0 NMIR W=20u L=1u
Msb_h_L2_19 z_L2_19 coln_L2_19 0 0 NMIR W=20u L=1u
Msc_h_L2_19 colp_L2_19 colp_L2_19 0 0 NMIR W=20u L=1u
Msd_h_L2_19 dpf_h_L2_19 colp_L2_19 0 0 NMIR W=20u L=1u
Mse_h_L2_19 dpf_h_L2_19 dpf_h_L2_19 vdd vdd PMIR W=60u L=1u
Msf_h_L2_19 z_L2_19 dpf_h_L2_19 vdd vdd PMIR W=60u L=1u
R_h_L2_19 z_L2_19 vrefh 8000.0
Mr_L2_19  hdd_L2_19 z_L2_19 tail_L2_19 0 NREL W=12u L=1u
Mr2_L2_19 dmp_L2_19  vmid  tail_L2_19 0 NREL W=12u L=1u
Mtl_L2_19 tail_L2_19 vtb 0 0 NREL W=32.0u L=1u
Mdm_L2_19 dmp_L2_19 dmp_L2_19 vdd vdd PMIR W=40u L=1u
Mrp1_L2_19 hdd_L2_19 hdd_L2_19 vdd vdd PMIR W=40u L=1u
Mrp2_L2_19 hv_L2_19 hdd_L2_19 vdd vdd PMIR W=40u L=1u
Rhv_L2_19 hv_L2_19 vg0 8000.0
C_gp_2_20_0 gp_2_20_0 0 {Cg}
Mp_2_20_0 hv_L1_0 gp_2_20_0 colp_L2_20 0 NSYN W=10u L=1u
Mn_2_20_0 hv_L1_0 vcn coln_L2_20 0 NSYN W=10u L=1u
C_gp_2_20_1 gp_2_20_1 0 {Cg}
Mp_2_20_1 hv_L1_3 gp_2_20_1 colp_L2_20 0 NSYN W=10u L=1u
Mn_2_20_1 hv_L1_3 vcn coln_L2_20 0 NSYN W=10u L=1u
C_gp_2_20_2 gp_2_20_2 0 {Cg}
Mp_2_20_2 hv_L1_4 gp_2_20_2 colp_L2_20 0 NSYN W=10u L=1u
Mn_2_20_2 hv_L1_4 vcn coln_L2_20 0 NSYN W=10u L=1u
C_gp_2_20_3 gp_2_20_3 0 {Cg}
Mp_2_20_3 hv_L1_9 gp_2_20_3 colp_L2_20 0 NSYN W=10u L=1u
Mn_2_20_3 hv_L1_9 vcn coln_L2_20 0 NSYN W=10u L=1u
C_gp_2_20_4 gp_2_20_4 0 {Cg}
Mp_2_20_4 hv_L1_10 gp_2_20_4 colp_L2_20 0 NSYN W=10u L=1u
Mn_2_20_4 hv_L1_10 vcn coln_L2_20 0 NSYN W=10u L=1u
C_gp_2_20_5 gp_2_20_5 0 {Cg}
Mp_2_20_5 hv_L1_13 gp_2_20_5 colp_L2_20 0 NSYN W=10u L=1u
Mn_2_20_5 hv_L1_13 vcn coln_L2_20 0 NSYN W=10u L=1u
C_gp_2_20_6 gp_2_20_6 0 {Cg}
Mp_2_20_6 hv_L1_16 gp_2_20_6 colp_L2_20 0 NSYN W=10u L=1u
Mn_2_20_6 hv_L1_16 vcn coln_L2_20 0 NSYN W=10u L=1u
C_gp_2_20_7 gp_2_20_7 0 {Cg}
Mp_2_20_7 hv_L1_17 gp_2_20_7 colp_L2_20 0 NSYN W=10u L=1u
Mn_2_20_7 hv_L1_17 vcn coln_L2_20 0 NSYN W=10u L=1u
C_gp_2_20_8 gp_2_20_8 0 {Cg}
Mp_2_20_8 hv_L1_18 gp_2_20_8 colp_L2_20 0 NSYN W=10u L=1u
Mn_2_20_8 hv_L1_18 vcn coln_L2_20 0 NSYN W=10u L=1u
C_gp_2_20_9 gp_2_20_9 0 {Cg}
Mp_2_20_9 hv_L1_20 gp_2_20_9 colp_L2_20 0 NSYN W=10u L=1u
Mn_2_20_9 hv_L1_20 vcn coln_L2_20 0 NSYN W=10u L=1u
C_gp_2_20_10 gp_2_20_10 0 {Cg}
Mp_2_20_10 hv_L1_27 gp_2_20_10 colp_L2_20 0 NSYN W=10u L=1u
Mn_2_20_10 hv_L1_27 vcn coln_L2_20 0 NSYN W=10u L=1u
C_gp_2_20_11 gp_2_20_11 0 {Cg}
Mp_2_20_11 hv_L1_38 gp_2_20_11 colp_L2_20 0 NSYN W=10u L=1u
Mn_2_20_11 hv_L1_38 vcn coln_L2_20 0 NSYN W=10u L=1u
C_gp_2_20_12 gp_2_20_12 0 {Cg}
Mp_2_20_12 hv_L1_39 gp_2_20_12 colp_L2_20 0 NSYN W=10u L=1u
Mn_2_20_12 hv_L1_39 vcn coln_L2_20 0 NSYN W=10u L=1u
C_gp_2_20_13 gp_2_20_13 0 {Cg}
Mp_2_20_13 hv_L1_43 gp_2_20_13 colp_L2_20 0 NSYN W=10u L=1u
Mn_2_20_13 hv_L1_43 vcn coln_L2_20 0 NSYN W=10u L=1u
C_gp_2_20_14 gp_2_20_14 0 {Cg}
Mp_2_20_14 hv_L1_46 gp_2_20_14 colp_L2_20 0 NSYN W=10u L=1u
Mn_2_20_14 hv_L1_46 vcn coln_L2_20 0 NSYN W=10u L=1u
C_gp_2_20_15 gp_2_20_15 0 {Cg}
Mp_2_20_15 hv_L1_47 gp_2_20_15 colp_L2_20 0 NSYN W=10u L=1u
Mn_2_20_15 hv_L1_47 vcn coln_L2_20 0 NSYN W=10u L=1u
C_gp_2_20_b gp_2_20_b 0 {Cg}
Mp_2_20_b bx gp_2_20_b colp_L2_20 0 NSYN W=10u L=1u
Mn_2_20_b bx vcn coln_L2_20 0 NSYN W=10u L=1u
Msa_h_L2_20 coln_L2_20 coln_L2_20 0 0 NMIR W=20u L=1u
Msb_h_L2_20 z_L2_20 coln_L2_20 0 0 NMIR W=20u L=1u
Msc_h_L2_20 colp_L2_20 colp_L2_20 0 0 NMIR W=20u L=1u
Msd_h_L2_20 dpf_h_L2_20 colp_L2_20 0 0 NMIR W=20u L=1u
Mse_h_L2_20 dpf_h_L2_20 dpf_h_L2_20 vdd vdd PMIR W=60u L=1u
Msf_h_L2_20 z_L2_20 dpf_h_L2_20 vdd vdd PMIR W=60u L=1u
R_h_L2_20 z_L2_20 vrefh 8000.0
Mr_L2_20  hdd_L2_20 z_L2_20 tail_L2_20 0 NREL W=12u L=1u
Mr2_L2_20 dmp_L2_20  vmid  tail_L2_20 0 NREL W=12u L=1u
Mtl_L2_20 tail_L2_20 vtb 0 0 NREL W=32.0u L=1u
Mdm_L2_20 dmp_L2_20 dmp_L2_20 vdd vdd PMIR W=40u L=1u
Mrp1_L2_20 hdd_L2_20 hdd_L2_20 vdd vdd PMIR W=40u L=1u
Mrp2_L2_20 hv_L2_20 hdd_L2_20 vdd vdd PMIR W=40u L=1u
Rhv_L2_20 hv_L2_20 vg0 8000.0
C_gp_2_21_0 gp_2_21_0 0 {Cg}
Mp_2_21_0 hv_L1_0 gp_2_21_0 colp_L2_21 0 NSYN W=10u L=1u
Mn_2_21_0 hv_L1_0 vcn coln_L2_21 0 NSYN W=10u L=1u
C_gp_2_21_1 gp_2_21_1 0 {Cg}
Mp_2_21_1 hv_L1_2 gp_2_21_1 colp_L2_21 0 NSYN W=10u L=1u
Mn_2_21_1 hv_L1_2 vcn coln_L2_21 0 NSYN W=10u L=1u
C_gp_2_21_2 gp_2_21_2 0 {Cg}
Mp_2_21_2 hv_L1_9 gp_2_21_2 colp_L2_21 0 NSYN W=10u L=1u
Mn_2_21_2 hv_L1_9 vcn coln_L2_21 0 NSYN W=10u L=1u
C_gp_2_21_3 gp_2_21_3 0 {Cg}
Mp_2_21_3 hv_L1_12 gp_2_21_3 colp_L2_21 0 NSYN W=10u L=1u
Mn_2_21_3 hv_L1_12 vcn coln_L2_21 0 NSYN W=10u L=1u
C_gp_2_21_4 gp_2_21_4 0 {Cg}
Mp_2_21_4 hv_L1_14 gp_2_21_4 colp_L2_21 0 NSYN W=10u L=1u
Mn_2_21_4 hv_L1_14 vcn coln_L2_21 0 NSYN W=10u L=1u
C_gp_2_21_5 gp_2_21_5 0 {Cg}
Mp_2_21_5 hv_L1_17 gp_2_21_5 colp_L2_21 0 NSYN W=10u L=1u
Mn_2_21_5 hv_L1_17 vcn coln_L2_21 0 NSYN W=10u L=1u
C_gp_2_21_6 gp_2_21_6 0 {Cg}
Mp_2_21_6 hv_L1_18 gp_2_21_6 colp_L2_21 0 NSYN W=10u L=1u
Mn_2_21_6 hv_L1_18 vcn coln_L2_21 0 NSYN W=10u L=1u
C_gp_2_21_7 gp_2_21_7 0 {Cg}
Mp_2_21_7 hv_L1_20 gp_2_21_7 colp_L2_21 0 NSYN W=10u L=1u
Mn_2_21_7 hv_L1_20 vcn coln_L2_21 0 NSYN W=10u L=1u
C_gp_2_21_8 gp_2_21_8 0 {Cg}
Mp_2_21_8 hv_L1_26 gp_2_21_8 colp_L2_21 0 NSYN W=10u L=1u
Mn_2_21_8 hv_L1_26 vcn coln_L2_21 0 NSYN W=10u L=1u
C_gp_2_21_9 gp_2_21_9 0 {Cg}
Mp_2_21_9 hv_L1_29 gp_2_21_9 colp_L2_21 0 NSYN W=10u L=1u
Mn_2_21_9 hv_L1_29 vcn coln_L2_21 0 NSYN W=10u L=1u
C_gp_2_21_10 gp_2_21_10 0 {Cg}
Mp_2_21_10 hv_L1_33 gp_2_21_10 colp_L2_21 0 NSYN W=10u L=1u
Mn_2_21_10 hv_L1_33 vcn coln_L2_21 0 NSYN W=10u L=1u
C_gp_2_21_11 gp_2_21_11 0 {Cg}
Mp_2_21_11 hv_L1_34 gp_2_21_11 colp_L2_21 0 NSYN W=10u L=1u
Mn_2_21_11 hv_L1_34 vcn coln_L2_21 0 NSYN W=10u L=1u
C_gp_2_21_12 gp_2_21_12 0 {Cg}
Mp_2_21_12 hv_L1_37 gp_2_21_12 colp_L2_21 0 NSYN W=10u L=1u
Mn_2_21_12 hv_L1_37 vcn coln_L2_21 0 NSYN W=10u L=1u
C_gp_2_21_13 gp_2_21_13 0 {Cg}
Mp_2_21_13 hv_L1_39 gp_2_21_13 colp_L2_21 0 NSYN W=10u L=1u
Mn_2_21_13 hv_L1_39 vcn coln_L2_21 0 NSYN W=10u L=1u
C_gp_2_21_14 gp_2_21_14 0 {Cg}
Mp_2_21_14 hv_L1_45 gp_2_21_14 colp_L2_21 0 NSYN W=10u L=1u
Mn_2_21_14 hv_L1_45 vcn coln_L2_21 0 NSYN W=10u L=1u
C_gp_2_21_15 gp_2_21_15 0 {Cg}
Mp_2_21_15 hv_L1_47 gp_2_21_15 colp_L2_21 0 NSYN W=10u L=1u
Mn_2_21_15 hv_L1_47 vcn coln_L2_21 0 NSYN W=10u L=1u
C_gp_2_21_b gp_2_21_b 0 {Cg}
Mp_2_21_b bx gp_2_21_b colp_L2_21 0 NSYN W=10u L=1u
Mn_2_21_b bx vcn coln_L2_21 0 NSYN W=10u L=1u
Msa_h_L2_21 coln_L2_21 coln_L2_21 0 0 NMIR W=20u L=1u
Msb_h_L2_21 z_L2_21 coln_L2_21 0 0 NMIR W=20u L=1u
Msc_h_L2_21 colp_L2_21 colp_L2_21 0 0 NMIR W=20u L=1u
Msd_h_L2_21 dpf_h_L2_21 colp_L2_21 0 0 NMIR W=20u L=1u
Mse_h_L2_21 dpf_h_L2_21 dpf_h_L2_21 vdd vdd PMIR W=60u L=1u
Msf_h_L2_21 z_L2_21 dpf_h_L2_21 vdd vdd PMIR W=60u L=1u
R_h_L2_21 z_L2_21 vrefh 8000.0
Mr_L2_21  hdd_L2_21 z_L2_21 tail_L2_21 0 NREL W=12u L=1u
Mr2_L2_21 dmp_L2_21  vmid  tail_L2_21 0 NREL W=12u L=1u
Mtl_L2_21 tail_L2_21 vtb 0 0 NREL W=32.0u L=1u
Mdm_L2_21 dmp_L2_21 dmp_L2_21 vdd vdd PMIR W=40u L=1u
Mrp1_L2_21 hdd_L2_21 hdd_L2_21 vdd vdd PMIR W=40u L=1u
Mrp2_L2_21 hv_L2_21 hdd_L2_21 vdd vdd PMIR W=40u L=1u
Rhv_L2_21 hv_L2_21 vg0 8000.0
C_gp_2_22_0 gp_2_22_0 0 {Cg}
Mp_2_22_0 hv_L1_6 gp_2_22_0 colp_L2_22 0 NSYN W=10u L=1u
Mn_2_22_0 hv_L1_6 vcn coln_L2_22 0 NSYN W=10u L=1u
C_gp_2_22_1 gp_2_22_1 0 {Cg}
Mp_2_22_1 hv_L1_9 gp_2_22_1 colp_L2_22 0 NSYN W=10u L=1u
Mn_2_22_1 hv_L1_9 vcn coln_L2_22 0 NSYN W=10u L=1u
C_gp_2_22_2 gp_2_22_2 0 {Cg}
Mp_2_22_2 hv_L1_16 gp_2_22_2 colp_L2_22 0 NSYN W=10u L=1u
Mn_2_22_2 hv_L1_16 vcn coln_L2_22 0 NSYN W=10u L=1u
C_gp_2_22_3 gp_2_22_3 0 {Cg}
Mp_2_22_3 hv_L1_17 gp_2_22_3 colp_L2_22 0 NSYN W=10u L=1u
Mn_2_22_3 hv_L1_17 vcn coln_L2_22 0 NSYN W=10u L=1u
C_gp_2_22_4 gp_2_22_4 0 {Cg}
Mp_2_22_4 hv_L1_19 gp_2_22_4 colp_L2_22 0 NSYN W=10u L=1u
Mn_2_22_4 hv_L1_19 vcn coln_L2_22 0 NSYN W=10u L=1u
C_gp_2_22_5 gp_2_22_5 0 {Cg}
Mp_2_22_5 hv_L1_21 gp_2_22_5 colp_L2_22 0 NSYN W=10u L=1u
Mn_2_22_5 hv_L1_21 vcn coln_L2_22 0 NSYN W=10u L=1u
C_gp_2_22_6 gp_2_22_6 0 {Cg}
Mp_2_22_6 hv_L1_22 gp_2_22_6 colp_L2_22 0 NSYN W=10u L=1u
Mn_2_22_6 hv_L1_22 vcn coln_L2_22 0 NSYN W=10u L=1u
C_gp_2_22_7 gp_2_22_7 0 {Cg}
Mp_2_22_7 hv_L1_23 gp_2_22_7 colp_L2_22 0 NSYN W=10u L=1u
Mn_2_22_7 hv_L1_23 vcn coln_L2_22 0 NSYN W=10u L=1u
C_gp_2_22_8 gp_2_22_8 0 {Cg}
Mp_2_22_8 hv_L1_30 gp_2_22_8 colp_L2_22 0 NSYN W=10u L=1u
Mn_2_22_8 hv_L1_30 vcn coln_L2_22 0 NSYN W=10u L=1u
C_gp_2_22_9 gp_2_22_9 0 {Cg}
Mp_2_22_9 hv_L1_33 gp_2_22_9 colp_L2_22 0 NSYN W=10u L=1u
Mn_2_22_9 hv_L1_33 vcn coln_L2_22 0 NSYN W=10u L=1u
C_gp_2_22_10 gp_2_22_10 0 {Cg}
Mp_2_22_10 hv_L1_37 gp_2_22_10 colp_L2_22 0 NSYN W=10u L=1u
Mn_2_22_10 hv_L1_37 vcn coln_L2_22 0 NSYN W=10u L=1u
C_gp_2_22_11 gp_2_22_11 0 {Cg}
Mp_2_22_11 hv_L1_40 gp_2_22_11 colp_L2_22 0 NSYN W=10u L=1u
Mn_2_22_11 hv_L1_40 vcn coln_L2_22 0 NSYN W=10u L=1u
C_gp_2_22_12 gp_2_22_12 0 {Cg}
Mp_2_22_12 hv_L1_41 gp_2_22_12 colp_L2_22 0 NSYN W=10u L=1u
Mn_2_22_12 hv_L1_41 vcn coln_L2_22 0 NSYN W=10u L=1u
C_gp_2_22_13 gp_2_22_13 0 {Cg}
Mp_2_22_13 hv_L1_43 gp_2_22_13 colp_L2_22 0 NSYN W=10u L=1u
Mn_2_22_13 hv_L1_43 vcn coln_L2_22 0 NSYN W=10u L=1u
C_gp_2_22_14 gp_2_22_14 0 {Cg}
Mp_2_22_14 hv_L1_45 gp_2_22_14 colp_L2_22 0 NSYN W=10u L=1u
Mn_2_22_14 hv_L1_45 vcn coln_L2_22 0 NSYN W=10u L=1u
C_gp_2_22_15 gp_2_22_15 0 {Cg}
Mp_2_22_15 hv_L1_46 gp_2_22_15 colp_L2_22 0 NSYN W=10u L=1u
Mn_2_22_15 hv_L1_46 vcn coln_L2_22 0 NSYN W=10u L=1u
C_gp_2_22_b gp_2_22_b 0 {Cg}
Mp_2_22_b bx gp_2_22_b colp_L2_22 0 NSYN W=10u L=1u
Mn_2_22_b bx vcn coln_L2_22 0 NSYN W=10u L=1u
Msa_h_L2_22 coln_L2_22 coln_L2_22 0 0 NMIR W=20u L=1u
Msb_h_L2_22 z_L2_22 coln_L2_22 0 0 NMIR W=20u L=1u
Msc_h_L2_22 colp_L2_22 colp_L2_22 0 0 NMIR W=20u L=1u
Msd_h_L2_22 dpf_h_L2_22 colp_L2_22 0 0 NMIR W=20u L=1u
Mse_h_L2_22 dpf_h_L2_22 dpf_h_L2_22 vdd vdd PMIR W=60u L=1u
Msf_h_L2_22 z_L2_22 dpf_h_L2_22 vdd vdd PMIR W=60u L=1u
R_h_L2_22 z_L2_22 vrefh 8000.0
Mr_L2_22  hdd_L2_22 z_L2_22 tail_L2_22 0 NREL W=12u L=1u
Mr2_L2_22 dmp_L2_22  vmid  tail_L2_22 0 NREL W=12u L=1u
Mtl_L2_22 tail_L2_22 vtb 0 0 NREL W=32.0u L=1u
Mdm_L2_22 dmp_L2_22 dmp_L2_22 vdd vdd PMIR W=40u L=1u
Mrp1_L2_22 hdd_L2_22 hdd_L2_22 vdd vdd PMIR W=40u L=1u
Mrp2_L2_22 hv_L2_22 hdd_L2_22 vdd vdd PMIR W=40u L=1u
Rhv_L2_22 hv_L2_22 vg0 8000.0
C_gp_2_23_0 gp_2_23_0 0 {Cg}
Mp_2_23_0 hv_L1_0 gp_2_23_0 colp_L2_23 0 NSYN W=10u L=1u
Mn_2_23_0 hv_L1_0 vcn coln_L2_23 0 NSYN W=10u L=1u
C_gp_2_23_1 gp_2_23_1 0 {Cg}
Mp_2_23_1 hv_L1_1 gp_2_23_1 colp_L2_23 0 NSYN W=10u L=1u
Mn_2_23_1 hv_L1_1 vcn coln_L2_23 0 NSYN W=10u L=1u
C_gp_2_23_2 gp_2_23_2 0 {Cg}
Mp_2_23_2 hv_L1_2 gp_2_23_2 colp_L2_23 0 NSYN W=10u L=1u
Mn_2_23_2 hv_L1_2 vcn coln_L2_23 0 NSYN W=10u L=1u
C_gp_2_23_3 gp_2_23_3 0 {Cg}
Mp_2_23_3 hv_L1_3 gp_2_23_3 colp_L2_23 0 NSYN W=10u L=1u
Mn_2_23_3 hv_L1_3 vcn coln_L2_23 0 NSYN W=10u L=1u
C_gp_2_23_4 gp_2_23_4 0 {Cg}
Mp_2_23_4 hv_L1_12 gp_2_23_4 colp_L2_23 0 NSYN W=10u L=1u
Mn_2_23_4 hv_L1_12 vcn coln_L2_23 0 NSYN W=10u L=1u
C_gp_2_23_5 gp_2_23_5 0 {Cg}
Mp_2_23_5 hv_L1_15 gp_2_23_5 colp_L2_23 0 NSYN W=10u L=1u
Mn_2_23_5 hv_L1_15 vcn coln_L2_23 0 NSYN W=10u L=1u
C_gp_2_23_6 gp_2_23_6 0 {Cg}
Mp_2_23_6 hv_L1_16 gp_2_23_6 colp_L2_23 0 NSYN W=10u L=1u
Mn_2_23_6 hv_L1_16 vcn coln_L2_23 0 NSYN W=10u L=1u
C_gp_2_23_7 gp_2_23_7 0 {Cg}
Mp_2_23_7 hv_L1_18 gp_2_23_7 colp_L2_23 0 NSYN W=10u L=1u
Mn_2_23_7 hv_L1_18 vcn coln_L2_23 0 NSYN W=10u L=1u
C_gp_2_23_8 gp_2_23_8 0 {Cg}
Mp_2_23_8 hv_L1_26 gp_2_23_8 colp_L2_23 0 NSYN W=10u L=1u
Mn_2_23_8 hv_L1_26 vcn coln_L2_23 0 NSYN W=10u L=1u
C_gp_2_23_9 gp_2_23_9 0 {Cg}
Mp_2_23_9 hv_L1_33 gp_2_23_9 colp_L2_23 0 NSYN W=10u L=1u
Mn_2_23_9 hv_L1_33 vcn coln_L2_23 0 NSYN W=10u L=1u
C_gp_2_23_10 gp_2_23_10 0 {Cg}
Mp_2_23_10 hv_L1_35 gp_2_23_10 colp_L2_23 0 NSYN W=10u L=1u
Mn_2_23_10 hv_L1_35 vcn coln_L2_23 0 NSYN W=10u L=1u
C_gp_2_23_11 gp_2_23_11 0 {Cg}
Mp_2_23_11 hv_L1_39 gp_2_23_11 colp_L2_23 0 NSYN W=10u L=1u
Mn_2_23_11 hv_L1_39 vcn coln_L2_23 0 NSYN W=10u L=1u
C_gp_2_23_12 gp_2_23_12 0 {Cg}
Mp_2_23_12 hv_L1_41 gp_2_23_12 colp_L2_23 0 NSYN W=10u L=1u
Mn_2_23_12 hv_L1_41 vcn coln_L2_23 0 NSYN W=10u L=1u
C_gp_2_23_13 gp_2_23_13 0 {Cg}
Mp_2_23_13 hv_L1_42 gp_2_23_13 colp_L2_23 0 NSYN W=10u L=1u
Mn_2_23_13 hv_L1_42 vcn coln_L2_23 0 NSYN W=10u L=1u
C_gp_2_23_14 gp_2_23_14 0 {Cg}
Mp_2_23_14 hv_L1_45 gp_2_23_14 colp_L2_23 0 NSYN W=10u L=1u
Mn_2_23_14 hv_L1_45 vcn coln_L2_23 0 NSYN W=10u L=1u
C_gp_2_23_15 gp_2_23_15 0 {Cg}
Mp_2_23_15 hv_L1_46 gp_2_23_15 colp_L2_23 0 NSYN W=10u L=1u
Mn_2_23_15 hv_L1_46 vcn coln_L2_23 0 NSYN W=10u L=1u
C_gp_2_23_b gp_2_23_b 0 {Cg}
Mp_2_23_b bx gp_2_23_b colp_L2_23 0 NSYN W=10u L=1u
Mn_2_23_b bx vcn coln_L2_23 0 NSYN W=10u L=1u
Msa_h_L2_23 coln_L2_23 coln_L2_23 0 0 NMIR W=20u L=1u
Msb_h_L2_23 z_L2_23 coln_L2_23 0 0 NMIR W=20u L=1u
Msc_h_L2_23 colp_L2_23 colp_L2_23 0 0 NMIR W=20u L=1u
Msd_h_L2_23 dpf_h_L2_23 colp_L2_23 0 0 NMIR W=20u L=1u
Mse_h_L2_23 dpf_h_L2_23 dpf_h_L2_23 vdd vdd PMIR W=60u L=1u
Msf_h_L2_23 z_L2_23 dpf_h_L2_23 vdd vdd PMIR W=60u L=1u
R_h_L2_23 z_L2_23 vrefh 8000.0
Mr_L2_23  hdd_L2_23 z_L2_23 tail_L2_23 0 NREL W=12u L=1u
Mr2_L2_23 dmp_L2_23  vmid  tail_L2_23 0 NREL W=12u L=1u
Mtl_L2_23 tail_L2_23 vtb 0 0 NREL W=32.0u L=1u
Mdm_L2_23 dmp_L2_23 dmp_L2_23 vdd vdd PMIR W=40u L=1u
Mrp1_L2_23 hdd_L2_23 hdd_L2_23 vdd vdd PMIR W=40u L=1u
Mrp2_L2_23 hv_L2_23 hdd_L2_23 vdd vdd PMIR W=40u L=1u
Rhv_L2_23 hv_L2_23 vg0 8000.0
C_gp_2_24_0 gp_2_24_0 0 {Cg}
Mp_2_24_0 hv_L1_0 gp_2_24_0 colp_L2_24 0 NSYN W=10u L=1u
Mn_2_24_0 hv_L1_0 vcn coln_L2_24 0 NSYN W=10u L=1u
C_gp_2_24_1 gp_2_24_1 0 {Cg}
Mp_2_24_1 hv_L1_1 gp_2_24_1 colp_L2_24 0 NSYN W=10u L=1u
Mn_2_24_1 hv_L1_1 vcn coln_L2_24 0 NSYN W=10u L=1u
C_gp_2_24_2 gp_2_24_2 0 {Cg}
Mp_2_24_2 hv_L1_2 gp_2_24_2 colp_L2_24 0 NSYN W=10u L=1u
Mn_2_24_2 hv_L1_2 vcn coln_L2_24 0 NSYN W=10u L=1u
C_gp_2_24_3 gp_2_24_3 0 {Cg}
Mp_2_24_3 hv_L1_5 gp_2_24_3 colp_L2_24 0 NSYN W=10u L=1u
Mn_2_24_3 hv_L1_5 vcn coln_L2_24 0 NSYN W=10u L=1u
C_gp_2_24_4 gp_2_24_4 0 {Cg}
Mp_2_24_4 hv_L1_11 gp_2_24_4 colp_L2_24 0 NSYN W=10u L=1u
Mn_2_24_4 hv_L1_11 vcn coln_L2_24 0 NSYN W=10u L=1u
C_gp_2_24_5 gp_2_24_5 0 {Cg}
Mp_2_24_5 hv_L1_12 gp_2_24_5 colp_L2_24 0 NSYN W=10u L=1u
Mn_2_24_5 hv_L1_12 vcn coln_L2_24 0 NSYN W=10u L=1u
C_gp_2_24_6 gp_2_24_6 0 {Cg}
Mp_2_24_6 hv_L1_19 gp_2_24_6 colp_L2_24 0 NSYN W=10u L=1u
Mn_2_24_6 hv_L1_19 vcn coln_L2_24 0 NSYN W=10u L=1u
C_gp_2_24_7 gp_2_24_7 0 {Cg}
Mp_2_24_7 hv_L1_26 gp_2_24_7 colp_L2_24 0 NSYN W=10u L=1u
Mn_2_24_7 hv_L1_26 vcn coln_L2_24 0 NSYN W=10u L=1u
C_gp_2_24_8 gp_2_24_8 0 {Cg}
Mp_2_24_8 hv_L1_28 gp_2_24_8 colp_L2_24 0 NSYN W=10u L=1u
Mn_2_24_8 hv_L1_28 vcn coln_L2_24 0 NSYN W=10u L=1u
C_gp_2_24_9 gp_2_24_9 0 {Cg}
Mp_2_24_9 hv_L1_29 gp_2_24_9 colp_L2_24 0 NSYN W=10u L=1u
Mn_2_24_9 hv_L1_29 vcn coln_L2_24 0 NSYN W=10u L=1u
C_gp_2_24_10 gp_2_24_10 0 {Cg}
Mp_2_24_10 hv_L1_31 gp_2_24_10 colp_L2_24 0 NSYN W=10u L=1u
Mn_2_24_10 hv_L1_31 vcn coln_L2_24 0 NSYN W=10u L=1u
C_gp_2_24_11 gp_2_24_11 0 {Cg}
Mp_2_24_11 hv_L1_32 gp_2_24_11 colp_L2_24 0 NSYN W=10u L=1u
Mn_2_24_11 hv_L1_32 vcn coln_L2_24 0 NSYN W=10u L=1u
C_gp_2_24_12 gp_2_24_12 0 {Cg}
Mp_2_24_12 hv_L1_34 gp_2_24_12 colp_L2_24 0 NSYN W=10u L=1u
Mn_2_24_12 hv_L1_34 vcn coln_L2_24 0 NSYN W=10u L=1u
C_gp_2_24_13 gp_2_24_13 0 {Cg}
Mp_2_24_13 hv_L1_38 gp_2_24_13 colp_L2_24 0 NSYN W=10u L=1u
Mn_2_24_13 hv_L1_38 vcn coln_L2_24 0 NSYN W=10u L=1u
C_gp_2_24_14 gp_2_24_14 0 {Cg}
Mp_2_24_14 hv_L1_40 gp_2_24_14 colp_L2_24 0 NSYN W=10u L=1u
Mn_2_24_14 hv_L1_40 vcn coln_L2_24 0 NSYN W=10u L=1u
C_gp_2_24_15 gp_2_24_15 0 {Cg}
Mp_2_24_15 hv_L1_45 gp_2_24_15 colp_L2_24 0 NSYN W=10u L=1u
Mn_2_24_15 hv_L1_45 vcn coln_L2_24 0 NSYN W=10u L=1u
C_gp_2_24_b gp_2_24_b 0 {Cg}
Mp_2_24_b bx gp_2_24_b colp_L2_24 0 NSYN W=10u L=1u
Mn_2_24_b bx vcn coln_L2_24 0 NSYN W=10u L=1u
Msa_h_L2_24 coln_L2_24 coln_L2_24 0 0 NMIR W=20u L=1u
Msb_h_L2_24 z_L2_24 coln_L2_24 0 0 NMIR W=20u L=1u
Msc_h_L2_24 colp_L2_24 colp_L2_24 0 0 NMIR W=20u L=1u
Msd_h_L2_24 dpf_h_L2_24 colp_L2_24 0 0 NMIR W=20u L=1u
Mse_h_L2_24 dpf_h_L2_24 dpf_h_L2_24 vdd vdd PMIR W=60u L=1u
Msf_h_L2_24 z_L2_24 dpf_h_L2_24 vdd vdd PMIR W=60u L=1u
R_h_L2_24 z_L2_24 vrefh 8000.0
Mr_L2_24  hdd_L2_24 z_L2_24 tail_L2_24 0 NREL W=12u L=1u
Mr2_L2_24 dmp_L2_24  vmid  tail_L2_24 0 NREL W=12u L=1u
Mtl_L2_24 tail_L2_24 vtb 0 0 NREL W=32.0u L=1u
Mdm_L2_24 dmp_L2_24 dmp_L2_24 vdd vdd PMIR W=40u L=1u
Mrp1_L2_24 hdd_L2_24 hdd_L2_24 vdd vdd PMIR W=40u L=1u
Mrp2_L2_24 hv_L2_24 hdd_L2_24 vdd vdd PMIR W=40u L=1u
Rhv_L2_24 hv_L2_24 vg0 8000.0
C_gp_2_25_0 gp_2_25_0 0 {Cg}
Mp_2_25_0 hv_L1_0 gp_2_25_0 colp_L2_25 0 NSYN W=10u L=1u
Mn_2_25_0 hv_L1_0 vcn coln_L2_25 0 NSYN W=10u L=1u
C_gp_2_25_1 gp_2_25_1 0 {Cg}
Mp_2_25_1 hv_L1_1 gp_2_25_1 colp_L2_25 0 NSYN W=10u L=1u
Mn_2_25_1 hv_L1_1 vcn coln_L2_25 0 NSYN W=10u L=1u
C_gp_2_25_2 gp_2_25_2 0 {Cg}
Mp_2_25_2 hv_L1_2 gp_2_25_2 colp_L2_25 0 NSYN W=10u L=1u
Mn_2_25_2 hv_L1_2 vcn coln_L2_25 0 NSYN W=10u L=1u
C_gp_2_25_3 gp_2_25_3 0 {Cg}
Mp_2_25_3 hv_L1_4 gp_2_25_3 colp_L2_25 0 NSYN W=10u L=1u
Mn_2_25_3 hv_L1_4 vcn coln_L2_25 0 NSYN W=10u L=1u
C_gp_2_25_4 gp_2_25_4 0 {Cg}
Mp_2_25_4 hv_L1_7 gp_2_25_4 colp_L2_25 0 NSYN W=10u L=1u
Mn_2_25_4 hv_L1_7 vcn coln_L2_25 0 NSYN W=10u L=1u
C_gp_2_25_5 gp_2_25_5 0 {Cg}
Mp_2_25_5 hv_L1_12 gp_2_25_5 colp_L2_25 0 NSYN W=10u L=1u
Mn_2_25_5 hv_L1_12 vcn coln_L2_25 0 NSYN W=10u L=1u
C_gp_2_25_6 gp_2_25_6 0 {Cg}
Mp_2_25_6 hv_L1_16 gp_2_25_6 colp_L2_25 0 NSYN W=10u L=1u
Mn_2_25_6 hv_L1_16 vcn coln_L2_25 0 NSYN W=10u L=1u
C_gp_2_25_7 gp_2_25_7 0 {Cg}
Mp_2_25_7 hv_L1_23 gp_2_25_7 colp_L2_25 0 NSYN W=10u L=1u
Mn_2_25_7 hv_L1_23 vcn coln_L2_25 0 NSYN W=10u L=1u
C_gp_2_25_8 gp_2_25_8 0 {Cg}
Mp_2_25_8 hv_L1_25 gp_2_25_8 colp_L2_25 0 NSYN W=10u L=1u
Mn_2_25_8 hv_L1_25 vcn coln_L2_25 0 NSYN W=10u L=1u
C_gp_2_25_9 gp_2_25_9 0 {Cg}
Mp_2_25_9 hv_L1_28 gp_2_25_9 colp_L2_25 0 NSYN W=10u L=1u
Mn_2_25_9 hv_L1_28 vcn coln_L2_25 0 NSYN W=10u L=1u
C_gp_2_25_10 gp_2_25_10 0 {Cg}
Mp_2_25_10 hv_L1_30 gp_2_25_10 colp_L2_25 0 NSYN W=10u L=1u
Mn_2_25_10 hv_L1_30 vcn coln_L2_25 0 NSYN W=10u L=1u
C_gp_2_25_11 gp_2_25_11 0 {Cg}
Mp_2_25_11 hv_L1_31 gp_2_25_11 colp_L2_25 0 NSYN W=10u L=1u
Mn_2_25_11 hv_L1_31 vcn coln_L2_25 0 NSYN W=10u L=1u
C_gp_2_25_12 gp_2_25_12 0 {Cg}
Mp_2_25_12 hv_L1_32 gp_2_25_12 colp_L2_25 0 NSYN W=10u L=1u
Mn_2_25_12 hv_L1_32 vcn coln_L2_25 0 NSYN W=10u L=1u
C_gp_2_25_13 gp_2_25_13 0 {Cg}
Mp_2_25_13 hv_L1_33 gp_2_25_13 colp_L2_25 0 NSYN W=10u L=1u
Mn_2_25_13 hv_L1_33 vcn coln_L2_25 0 NSYN W=10u L=1u
C_gp_2_25_14 gp_2_25_14 0 {Cg}
Mp_2_25_14 hv_L1_36 gp_2_25_14 colp_L2_25 0 NSYN W=10u L=1u
Mn_2_25_14 hv_L1_36 vcn coln_L2_25 0 NSYN W=10u L=1u
C_gp_2_25_15 gp_2_25_15 0 {Cg}
Mp_2_25_15 hv_L1_42 gp_2_25_15 colp_L2_25 0 NSYN W=10u L=1u
Mn_2_25_15 hv_L1_42 vcn coln_L2_25 0 NSYN W=10u L=1u
C_gp_2_25_b gp_2_25_b 0 {Cg}
Mp_2_25_b bx gp_2_25_b colp_L2_25 0 NSYN W=10u L=1u
Mn_2_25_b bx vcn coln_L2_25 0 NSYN W=10u L=1u
Msa_h_L2_25 coln_L2_25 coln_L2_25 0 0 NMIR W=20u L=1u
Msb_h_L2_25 z_L2_25 coln_L2_25 0 0 NMIR W=20u L=1u
Msc_h_L2_25 colp_L2_25 colp_L2_25 0 0 NMIR W=20u L=1u
Msd_h_L2_25 dpf_h_L2_25 colp_L2_25 0 0 NMIR W=20u L=1u
Mse_h_L2_25 dpf_h_L2_25 dpf_h_L2_25 vdd vdd PMIR W=60u L=1u
Msf_h_L2_25 z_L2_25 dpf_h_L2_25 vdd vdd PMIR W=60u L=1u
R_h_L2_25 z_L2_25 vrefh 8000.0
Mr_L2_25  hdd_L2_25 z_L2_25 tail_L2_25 0 NREL W=12u L=1u
Mr2_L2_25 dmp_L2_25  vmid  tail_L2_25 0 NREL W=12u L=1u
Mtl_L2_25 tail_L2_25 vtb 0 0 NREL W=32.0u L=1u
Mdm_L2_25 dmp_L2_25 dmp_L2_25 vdd vdd PMIR W=40u L=1u
Mrp1_L2_25 hdd_L2_25 hdd_L2_25 vdd vdd PMIR W=40u L=1u
Mrp2_L2_25 hv_L2_25 hdd_L2_25 vdd vdd PMIR W=40u L=1u
Rhv_L2_25 hv_L2_25 vg0 8000.0
C_gp_2_26_0 gp_2_26_0 0 {Cg}
Mp_2_26_0 hv_L1_0 gp_2_26_0 colp_L2_26 0 NSYN W=10u L=1u
Mn_2_26_0 hv_L1_0 vcn coln_L2_26 0 NSYN W=10u L=1u
C_gp_2_26_1 gp_2_26_1 0 {Cg}
Mp_2_26_1 hv_L1_4 gp_2_26_1 colp_L2_26 0 NSYN W=10u L=1u
Mn_2_26_1 hv_L1_4 vcn coln_L2_26 0 NSYN W=10u L=1u
C_gp_2_26_2 gp_2_26_2 0 {Cg}
Mp_2_26_2 hv_L1_8 gp_2_26_2 colp_L2_26 0 NSYN W=10u L=1u
Mn_2_26_2 hv_L1_8 vcn coln_L2_26 0 NSYN W=10u L=1u
C_gp_2_26_3 gp_2_26_3 0 {Cg}
Mp_2_26_3 hv_L1_9 gp_2_26_3 colp_L2_26 0 NSYN W=10u L=1u
Mn_2_26_3 hv_L1_9 vcn coln_L2_26 0 NSYN W=10u L=1u
C_gp_2_26_4 gp_2_26_4 0 {Cg}
Mp_2_26_4 hv_L1_10 gp_2_26_4 colp_L2_26 0 NSYN W=10u L=1u
Mn_2_26_4 hv_L1_10 vcn coln_L2_26 0 NSYN W=10u L=1u
C_gp_2_26_5 gp_2_26_5 0 {Cg}
Mp_2_26_5 hv_L1_15 gp_2_26_5 colp_L2_26 0 NSYN W=10u L=1u
Mn_2_26_5 hv_L1_15 vcn coln_L2_26 0 NSYN W=10u L=1u
C_gp_2_26_6 gp_2_26_6 0 {Cg}
Mp_2_26_6 hv_L1_22 gp_2_26_6 colp_L2_26 0 NSYN W=10u L=1u
Mn_2_26_6 hv_L1_22 vcn coln_L2_26 0 NSYN W=10u L=1u
C_gp_2_26_7 gp_2_26_7 0 {Cg}
Mp_2_26_7 hv_L1_24 gp_2_26_7 colp_L2_26 0 NSYN W=10u L=1u
Mn_2_26_7 hv_L1_24 vcn coln_L2_26 0 NSYN W=10u L=1u
C_gp_2_26_8 gp_2_26_8 0 {Cg}
Mp_2_26_8 hv_L1_29 gp_2_26_8 colp_L2_26 0 NSYN W=10u L=1u
Mn_2_26_8 hv_L1_29 vcn coln_L2_26 0 NSYN W=10u L=1u
C_gp_2_26_9 gp_2_26_9 0 {Cg}
Mp_2_26_9 hv_L1_31 gp_2_26_9 colp_L2_26 0 NSYN W=10u L=1u
Mn_2_26_9 hv_L1_31 vcn coln_L2_26 0 NSYN W=10u L=1u
C_gp_2_26_10 gp_2_26_10 0 {Cg}
Mp_2_26_10 hv_L1_32 gp_2_26_10 colp_L2_26 0 NSYN W=10u L=1u
Mn_2_26_10 hv_L1_32 vcn coln_L2_26 0 NSYN W=10u L=1u
C_gp_2_26_11 gp_2_26_11 0 {Cg}
Mp_2_26_11 hv_L1_34 gp_2_26_11 colp_L2_26 0 NSYN W=10u L=1u
Mn_2_26_11 hv_L1_34 vcn coln_L2_26 0 NSYN W=10u L=1u
C_gp_2_26_12 gp_2_26_12 0 {Cg}
Mp_2_26_12 hv_L1_37 gp_2_26_12 colp_L2_26 0 NSYN W=10u L=1u
Mn_2_26_12 hv_L1_37 vcn coln_L2_26 0 NSYN W=10u L=1u
C_gp_2_26_13 gp_2_26_13 0 {Cg}
Mp_2_26_13 hv_L1_41 gp_2_26_13 colp_L2_26 0 NSYN W=10u L=1u
Mn_2_26_13 hv_L1_41 vcn coln_L2_26 0 NSYN W=10u L=1u
C_gp_2_26_14 gp_2_26_14 0 {Cg}
Mp_2_26_14 hv_L1_43 gp_2_26_14 colp_L2_26 0 NSYN W=10u L=1u
Mn_2_26_14 hv_L1_43 vcn coln_L2_26 0 NSYN W=10u L=1u
C_gp_2_26_15 gp_2_26_15 0 {Cg}
Mp_2_26_15 hv_L1_46 gp_2_26_15 colp_L2_26 0 NSYN W=10u L=1u
Mn_2_26_15 hv_L1_46 vcn coln_L2_26 0 NSYN W=10u L=1u
C_gp_2_26_b gp_2_26_b 0 {Cg}
Mp_2_26_b bx gp_2_26_b colp_L2_26 0 NSYN W=10u L=1u
Mn_2_26_b bx vcn coln_L2_26 0 NSYN W=10u L=1u
Msa_h_L2_26 coln_L2_26 coln_L2_26 0 0 NMIR W=20u L=1u
Msb_h_L2_26 z_L2_26 coln_L2_26 0 0 NMIR W=20u L=1u
Msc_h_L2_26 colp_L2_26 colp_L2_26 0 0 NMIR W=20u L=1u
Msd_h_L2_26 dpf_h_L2_26 colp_L2_26 0 0 NMIR W=20u L=1u
Mse_h_L2_26 dpf_h_L2_26 dpf_h_L2_26 vdd vdd PMIR W=60u L=1u
Msf_h_L2_26 z_L2_26 dpf_h_L2_26 vdd vdd PMIR W=60u L=1u
R_h_L2_26 z_L2_26 vrefh 8000.0
Mr_L2_26  hdd_L2_26 z_L2_26 tail_L2_26 0 NREL W=12u L=1u
Mr2_L2_26 dmp_L2_26  vmid  tail_L2_26 0 NREL W=12u L=1u
Mtl_L2_26 tail_L2_26 vtb 0 0 NREL W=32.0u L=1u
Mdm_L2_26 dmp_L2_26 dmp_L2_26 vdd vdd PMIR W=40u L=1u
Mrp1_L2_26 hdd_L2_26 hdd_L2_26 vdd vdd PMIR W=40u L=1u
Mrp2_L2_26 hv_L2_26 hdd_L2_26 vdd vdd PMIR W=40u L=1u
Rhv_L2_26 hv_L2_26 vg0 8000.0
C_gp_2_27_0 gp_2_27_0 0 {Cg}
Mp_2_27_0 hv_L1_0 gp_2_27_0 colp_L2_27 0 NSYN W=10u L=1u
Mn_2_27_0 hv_L1_0 vcn coln_L2_27 0 NSYN W=10u L=1u
C_gp_2_27_1 gp_2_27_1 0 {Cg}
Mp_2_27_1 hv_L1_5 gp_2_27_1 colp_L2_27 0 NSYN W=10u L=1u
Mn_2_27_1 hv_L1_5 vcn coln_L2_27 0 NSYN W=10u L=1u
C_gp_2_27_2 gp_2_27_2 0 {Cg}
Mp_2_27_2 hv_L1_6 gp_2_27_2 colp_L2_27 0 NSYN W=10u L=1u
Mn_2_27_2 hv_L1_6 vcn coln_L2_27 0 NSYN W=10u L=1u
C_gp_2_27_3 gp_2_27_3 0 {Cg}
Mp_2_27_3 hv_L1_9 gp_2_27_3 colp_L2_27 0 NSYN W=10u L=1u
Mn_2_27_3 hv_L1_9 vcn coln_L2_27 0 NSYN W=10u L=1u
C_gp_2_27_4 gp_2_27_4 0 {Cg}
Mp_2_27_4 hv_L1_15 gp_2_27_4 colp_L2_27 0 NSYN W=10u L=1u
Mn_2_27_4 hv_L1_15 vcn coln_L2_27 0 NSYN W=10u L=1u
C_gp_2_27_5 gp_2_27_5 0 {Cg}
Mp_2_27_5 hv_L1_16 gp_2_27_5 colp_L2_27 0 NSYN W=10u L=1u
Mn_2_27_5 hv_L1_16 vcn coln_L2_27 0 NSYN W=10u L=1u
C_gp_2_27_6 gp_2_27_6 0 {Cg}
Mp_2_27_6 hv_L1_18 gp_2_27_6 colp_L2_27 0 NSYN W=10u L=1u
Mn_2_27_6 hv_L1_18 vcn coln_L2_27 0 NSYN W=10u L=1u
C_gp_2_27_7 gp_2_27_7 0 {Cg}
Mp_2_27_7 hv_L1_21 gp_2_27_7 colp_L2_27 0 NSYN W=10u L=1u
Mn_2_27_7 hv_L1_21 vcn coln_L2_27 0 NSYN W=10u L=1u
C_gp_2_27_8 gp_2_27_8 0 {Cg}
Mp_2_27_8 hv_L1_22 gp_2_27_8 colp_L2_27 0 NSYN W=10u L=1u
Mn_2_27_8 hv_L1_22 vcn coln_L2_27 0 NSYN W=10u L=1u
C_gp_2_27_9 gp_2_27_9 0 {Cg}
Mp_2_27_9 hv_L1_23 gp_2_27_9 colp_L2_27 0 NSYN W=10u L=1u
Mn_2_27_9 hv_L1_23 vcn coln_L2_27 0 NSYN W=10u L=1u
C_gp_2_27_10 gp_2_27_10 0 {Cg}
Mp_2_27_10 hv_L1_25 gp_2_27_10 colp_L2_27 0 NSYN W=10u L=1u
Mn_2_27_10 hv_L1_25 vcn coln_L2_27 0 NSYN W=10u L=1u
C_gp_2_27_11 gp_2_27_11 0 {Cg}
Mp_2_27_11 hv_L1_26 gp_2_27_11 colp_L2_27 0 NSYN W=10u L=1u
Mn_2_27_11 hv_L1_26 vcn coln_L2_27 0 NSYN W=10u L=1u
C_gp_2_27_12 gp_2_27_12 0 {Cg}
Mp_2_27_12 hv_L1_27 gp_2_27_12 colp_L2_27 0 NSYN W=10u L=1u
Mn_2_27_12 hv_L1_27 vcn coln_L2_27 0 NSYN W=10u L=1u
C_gp_2_27_13 gp_2_27_13 0 {Cg}
Mp_2_27_13 hv_L1_34 gp_2_27_13 colp_L2_27 0 NSYN W=10u L=1u
Mn_2_27_13 hv_L1_34 vcn coln_L2_27 0 NSYN W=10u L=1u
C_gp_2_27_14 gp_2_27_14 0 {Cg}
Mp_2_27_14 hv_L1_36 gp_2_27_14 colp_L2_27 0 NSYN W=10u L=1u
Mn_2_27_14 hv_L1_36 vcn coln_L2_27 0 NSYN W=10u L=1u
C_gp_2_27_15 gp_2_27_15 0 {Cg}
Mp_2_27_15 hv_L1_44 gp_2_27_15 colp_L2_27 0 NSYN W=10u L=1u
Mn_2_27_15 hv_L1_44 vcn coln_L2_27 0 NSYN W=10u L=1u
C_gp_2_27_b gp_2_27_b 0 {Cg}
Mp_2_27_b bx gp_2_27_b colp_L2_27 0 NSYN W=10u L=1u
Mn_2_27_b bx vcn coln_L2_27 0 NSYN W=10u L=1u
Msa_h_L2_27 coln_L2_27 coln_L2_27 0 0 NMIR W=20u L=1u
Msb_h_L2_27 z_L2_27 coln_L2_27 0 0 NMIR W=20u L=1u
Msc_h_L2_27 colp_L2_27 colp_L2_27 0 0 NMIR W=20u L=1u
Msd_h_L2_27 dpf_h_L2_27 colp_L2_27 0 0 NMIR W=20u L=1u
Mse_h_L2_27 dpf_h_L2_27 dpf_h_L2_27 vdd vdd PMIR W=60u L=1u
Msf_h_L2_27 z_L2_27 dpf_h_L2_27 vdd vdd PMIR W=60u L=1u
R_h_L2_27 z_L2_27 vrefh 8000.0
Mr_L2_27  hdd_L2_27 z_L2_27 tail_L2_27 0 NREL W=12u L=1u
Mr2_L2_27 dmp_L2_27  vmid  tail_L2_27 0 NREL W=12u L=1u
Mtl_L2_27 tail_L2_27 vtb 0 0 NREL W=32.0u L=1u
Mdm_L2_27 dmp_L2_27 dmp_L2_27 vdd vdd PMIR W=40u L=1u
Mrp1_L2_27 hdd_L2_27 hdd_L2_27 vdd vdd PMIR W=40u L=1u
Mrp2_L2_27 hv_L2_27 hdd_L2_27 vdd vdd PMIR W=40u L=1u
Rhv_L2_27 hv_L2_27 vg0 8000.0
C_gp_2_28_0 gp_2_28_0 0 {Cg}
Mp_2_28_0 hv_L1_2 gp_2_28_0 colp_L2_28 0 NSYN W=10u L=1u
Mn_2_28_0 hv_L1_2 vcn coln_L2_28 0 NSYN W=10u L=1u
C_gp_2_28_1 gp_2_28_1 0 {Cg}
Mp_2_28_1 hv_L1_6 gp_2_28_1 colp_L2_28 0 NSYN W=10u L=1u
Mn_2_28_1 hv_L1_6 vcn coln_L2_28 0 NSYN W=10u L=1u
C_gp_2_28_2 gp_2_28_2 0 {Cg}
Mp_2_28_2 hv_L1_8 gp_2_28_2 colp_L2_28 0 NSYN W=10u L=1u
Mn_2_28_2 hv_L1_8 vcn coln_L2_28 0 NSYN W=10u L=1u
C_gp_2_28_3 gp_2_28_3 0 {Cg}
Mp_2_28_3 hv_L1_12 gp_2_28_3 colp_L2_28 0 NSYN W=10u L=1u
Mn_2_28_3 hv_L1_12 vcn coln_L2_28 0 NSYN W=10u L=1u
C_gp_2_28_4 gp_2_28_4 0 {Cg}
Mp_2_28_4 hv_L1_13 gp_2_28_4 colp_L2_28 0 NSYN W=10u L=1u
Mn_2_28_4 hv_L1_13 vcn coln_L2_28 0 NSYN W=10u L=1u
C_gp_2_28_5 gp_2_28_5 0 {Cg}
Mp_2_28_5 hv_L1_15 gp_2_28_5 colp_L2_28 0 NSYN W=10u L=1u
Mn_2_28_5 hv_L1_15 vcn coln_L2_28 0 NSYN W=10u L=1u
C_gp_2_28_6 gp_2_28_6 0 {Cg}
Mp_2_28_6 hv_L1_16 gp_2_28_6 colp_L2_28 0 NSYN W=10u L=1u
Mn_2_28_6 hv_L1_16 vcn coln_L2_28 0 NSYN W=10u L=1u
C_gp_2_28_7 gp_2_28_7 0 {Cg}
Mp_2_28_7 hv_L1_26 gp_2_28_7 colp_L2_28 0 NSYN W=10u L=1u
Mn_2_28_7 hv_L1_26 vcn coln_L2_28 0 NSYN W=10u L=1u
C_gp_2_28_8 gp_2_28_8 0 {Cg}
Mp_2_28_8 hv_L1_27 gp_2_28_8 colp_L2_28 0 NSYN W=10u L=1u
Mn_2_28_8 hv_L1_27 vcn coln_L2_28 0 NSYN W=10u L=1u
C_gp_2_28_9 gp_2_28_9 0 {Cg}
Mp_2_28_9 hv_L1_28 gp_2_28_9 colp_L2_28 0 NSYN W=10u L=1u
Mn_2_28_9 hv_L1_28 vcn coln_L2_28 0 NSYN W=10u L=1u
C_gp_2_28_10 gp_2_28_10 0 {Cg}
Mp_2_28_10 hv_L1_29 gp_2_28_10 colp_L2_28 0 NSYN W=10u L=1u
Mn_2_28_10 hv_L1_29 vcn coln_L2_28 0 NSYN W=10u L=1u
C_gp_2_28_11 gp_2_28_11 0 {Cg}
Mp_2_28_11 hv_L1_30 gp_2_28_11 colp_L2_28 0 NSYN W=10u L=1u
Mn_2_28_11 hv_L1_30 vcn coln_L2_28 0 NSYN W=10u L=1u
C_gp_2_28_12 gp_2_28_12 0 {Cg}
Mp_2_28_12 hv_L1_34 gp_2_28_12 colp_L2_28 0 NSYN W=10u L=1u
Mn_2_28_12 hv_L1_34 vcn coln_L2_28 0 NSYN W=10u L=1u
C_gp_2_28_13 gp_2_28_13 0 {Cg}
Mp_2_28_13 hv_L1_35 gp_2_28_13 colp_L2_28 0 NSYN W=10u L=1u
Mn_2_28_13 hv_L1_35 vcn coln_L2_28 0 NSYN W=10u L=1u
C_gp_2_28_14 gp_2_28_14 0 {Cg}
Mp_2_28_14 hv_L1_41 gp_2_28_14 colp_L2_28 0 NSYN W=10u L=1u
Mn_2_28_14 hv_L1_41 vcn coln_L2_28 0 NSYN W=10u L=1u
C_gp_2_28_15 gp_2_28_15 0 {Cg}
Mp_2_28_15 hv_L1_45 gp_2_28_15 colp_L2_28 0 NSYN W=10u L=1u
Mn_2_28_15 hv_L1_45 vcn coln_L2_28 0 NSYN W=10u L=1u
C_gp_2_28_b gp_2_28_b 0 {Cg}
Mp_2_28_b bx gp_2_28_b colp_L2_28 0 NSYN W=10u L=1u
Mn_2_28_b bx vcn coln_L2_28 0 NSYN W=10u L=1u
Msa_h_L2_28 coln_L2_28 coln_L2_28 0 0 NMIR W=20u L=1u
Msb_h_L2_28 z_L2_28 coln_L2_28 0 0 NMIR W=20u L=1u
Msc_h_L2_28 colp_L2_28 colp_L2_28 0 0 NMIR W=20u L=1u
Msd_h_L2_28 dpf_h_L2_28 colp_L2_28 0 0 NMIR W=20u L=1u
Mse_h_L2_28 dpf_h_L2_28 dpf_h_L2_28 vdd vdd PMIR W=60u L=1u
Msf_h_L2_28 z_L2_28 dpf_h_L2_28 vdd vdd PMIR W=60u L=1u
R_h_L2_28 z_L2_28 vrefh 8000.0
Mr_L2_28  hdd_L2_28 z_L2_28 tail_L2_28 0 NREL W=12u L=1u
Mr2_L2_28 dmp_L2_28  vmid  tail_L2_28 0 NREL W=12u L=1u
Mtl_L2_28 tail_L2_28 vtb 0 0 NREL W=32.0u L=1u
Mdm_L2_28 dmp_L2_28 dmp_L2_28 vdd vdd PMIR W=40u L=1u
Mrp1_L2_28 hdd_L2_28 hdd_L2_28 vdd vdd PMIR W=40u L=1u
Mrp2_L2_28 hv_L2_28 hdd_L2_28 vdd vdd PMIR W=40u L=1u
Rhv_L2_28 hv_L2_28 vg0 8000.0
C_gp_2_29_0 gp_2_29_0 0 {Cg}
Mp_2_29_0 hv_L1_3 gp_2_29_0 colp_L2_29 0 NSYN W=10u L=1u
Mn_2_29_0 hv_L1_3 vcn coln_L2_29 0 NSYN W=10u L=1u
C_gp_2_29_1 gp_2_29_1 0 {Cg}
Mp_2_29_1 hv_L1_4 gp_2_29_1 colp_L2_29 0 NSYN W=10u L=1u
Mn_2_29_1 hv_L1_4 vcn coln_L2_29 0 NSYN W=10u L=1u
C_gp_2_29_2 gp_2_29_2 0 {Cg}
Mp_2_29_2 hv_L1_12 gp_2_29_2 colp_L2_29 0 NSYN W=10u L=1u
Mn_2_29_2 hv_L1_12 vcn coln_L2_29 0 NSYN W=10u L=1u
C_gp_2_29_3 gp_2_29_3 0 {Cg}
Mp_2_29_3 hv_L1_17 gp_2_29_3 colp_L2_29 0 NSYN W=10u L=1u
Mn_2_29_3 hv_L1_17 vcn coln_L2_29 0 NSYN W=10u L=1u
C_gp_2_29_4 gp_2_29_4 0 {Cg}
Mp_2_29_4 hv_L1_22 gp_2_29_4 colp_L2_29 0 NSYN W=10u L=1u
Mn_2_29_4 hv_L1_22 vcn coln_L2_29 0 NSYN W=10u L=1u
C_gp_2_29_5 gp_2_29_5 0 {Cg}
Mp_2_29_5 hv_L1_23 gp_2_29_5 colp_L2_29 0 NSYN W=10u L=1u
Mn_2_29_5 hv_L1_23 vcn coln_L2_29 0 NSYN W=10u L=1u
C_gp_2_29_6 gp_2_29_6 0 {Cg}
Mp_2_29_6 hv_L1_31 gp_2_29_6 colp_L2_29 0 NSYN W=10u L=1u
Mn_2_29_6 hv_L1_31 vcn coln_L2_29 0 NSYN W=10u L=1u
C_gp_2_29_7 gp_2_29_7 0 {Cg}
Mp_2_29_7 hv_L1_32 gp_2_29_7 colp_L2_29 0 NSYN W=10u L=1u
Mn_2_29_7 hv_L1_32 vcn coln_L2_29 0 NSYN W=10u L=1u
C_gp_2_29_8 gp_2_29_8 0 {Cg}
Mp_2_29_8 hv_L1_36 gp_2_29_8 colp_L2_29 0 NSYN W=10u L=1u
Mn_2_29_8 hv_L1_36 vcn coln_L2_29 0 NSYN W=10u L=1u
C_gp_2_29_9 gp_2_29_9 0 {Cg}
Mp_2_29_9 hv_L1_38 gp_2_29_9 colp_L2_29 0 NSYN W=10u L=1u
Mn_2_29_9 hv_L1_38 vcn coln_L2_29 0 NSYN W=10u L=1u
C_gp_2_29_10 gp_2_29_10 0 {Cg}
Mp_2_29_10 hv_L1_39 gp_2_29_10 colp_L2_29 0 NSYN W=10u L=1u
Mn_2_29_10 hv_L1_39 vcn coln_L2_29 0 NSYN W=10u L=1u
C_gp_2_29_11 gp_2_29_11 0 {Cg}
Mp_2_29_11 hv_L1_40 gp_2_29_11 colp_L2_29 0 NSYN W=10u L=1u
Mn_2_29_11 hv_L1_40 vcn coln_L2_29 0 NSYN W=10u L=1u
C_gp_2_29_12 gp_2_29_12 0 {Cg}
Mp_2_29_12 hv_L1_42 gp_2_29_12 colp_L2_29 0 NSYN W=10u L=1u
Mn_2_29_12 hv_L1_42 vcn coln_L2_29 0 NSYN W=10u L=1u
C_gp_2_29_13 gp_2_29_13 0 {Cg}
Mp_2_29_13 hv_L1_43 gp_2_29_13 colp_L2_29 0 NSYN W=10u L=1u
Mn_2_29_13 hv_L1_43 vcn coln_L2_29 0 NSYN W=10u L=1u
C_gp_2_29_14 gp_2_29_14 0 {Cg}
Mp_2_29_14 hv_L1_45 gp_2_29_14 colp_L2_29 0 NSYN W=10u L=1u
Mn_2_29_14 hv_L1_45 vcn coln_L2_29 0 NSYN W=10u L=1u
C_gp_2_29_15 gp_2_29_15 0 {Cg}
Mp_2_29_15 hv_L1_46 gp_2_29_15 colp_L2_29 0 NSYN W=10u L=1u
Mn_2_29_15 hv_L1_46 vcn coln_L2_29 0 NSYN W=10u L=1u
C_gp_2_29_b gp_2_29_b 0 {Cg}
Mp_2_29_b bx gp_2_29_b colp_L2_29 0 NSYN W=10u L=1u
Mn_2_29_b bx vcn coln_L2_29 0 NSYN W=10u L=1u
Msa_h_L2_29 coln_L2_29 coln_L2_29 0 0 NMIR W=20u L=1u
Msb_h_L2_29 z_L2_29 coln_L2_29 0 0 NMIR W=20u L=1u
Msc_h_L2_29 colp_L2_29 colp_L2_29 0 0 NMIR W=20u L=1u
Msd_h_L2_29 dpf_h_L2_29 colp_L2_29 0 0 NMIR W=20u L=1u
Mse_h_L2_29 dpf_h_L2_29 dpf_h_L2_29 vdd vdd PMIR W=60u L=1u
Msf_h_L2_29 z_L2_29 dpf_h_L2_29 vdd vdd PMIR W=60u L=1u
R_h_L2_29 z_L2_29 vrefh 8000.0
Mr_L2_29  hdd_L2_29 z_L2_29 tail_L2_29 0 NREL W=12u L=1u
Mr2_L2_29 dmp_L2_29  vmid  tail_L2_29 0 NREL W=12u L=1u
Mtl_L2_29 tail_L2_29 vtb 0 0 NREL W=32.0u L=1u
Mdm_L2_29 dmp_L2_29 dmp_L2_29 vdd vdd PMIR W=40u L=1u
Mrp1_L2_29 hdd_L2_29 hdd_L2_29 vdd vdd PMIR W=40u L=1u
Mrp2_L2_29 hv_L2_29 hdd_L2_29 vdd vdd PMIR W=40u L=1u
Rhv_L2_29 hv_L2_29 vg0 8000.0
C_gp_2_30_0 gp_2_30_0 0 {Cg}
Mp_2_30_0 hv_L1_4 gp_2_30_0 colp_L2_30 0 NSYN W=10u L=1u
Mn_2_30_0 hv_L1_4 vcn coln_L2_30 0 NSYN W=10u L=1u
C_gp_2_30_1 gp_2_30_1 0 {Cg}
Mp_2_30_1 hv_L1_5 gp_2_30_1 colp_L2_30 0 NSYN W=10u L=1u
Mn_2_30_1 hv_L1_5 vcn coln_L2_30 0 NSYN W=10u L=1u
C_gp_2_30_2 gp_2_30_2 0 {Cg}
Mp_2_30_2 hv_L1_6 gp_2_30_2 colp_L2_30 0 NSYN W=10u L=1u
Mn_2_30_2 hv_L1_6 vcn coln_L2_30 0 NSYN W=10u L=1u
C_gp_2_30_3 gp_2_30_3 0 {Cg}
Mp_2_30_3 hv_L1_9 gp_2_30_3 colp_L2_30 0 NSYN W=10u L=1u
Mn_2_30_3 hv_L1_9 vcn coln_L2_30 0 NSYN W=10u L=1u
C_gp_2_30_4 gp_2_30_4 0 {Cg}
Mp_2_30_4 hv_L1_10 gp_2_30_4 colp_L2_30 0 NSYN W=10u L=1u
Mn_2_30_4 hv_L1_10 vcn coln_L2_30 0 NSYN W=10u L=1u
C_gp_2_30_5 gp_2_30_5 0 {Cg}
Mp_2_30_5 hv_L1_11 gp_2_30_5 colp_L2_30 0 NSYN W=10u L=1u
Mn_2_30_5 hv_L1_11 vcn coln_L2_30 0 NSYN W=10u L=1u
C_gp_2_30_6 gp_2_30_6 0 {Cg}
Mp_2_30_6 hv_L1_12 gp_2_30_6 colp_L2_30 0 NSYN W=10u L=1u
Mn_2_30_6 hv_L1_12 vcn coln_L2_30 0 NSYN W=10u L=1u
C_gp_2_30_7 gp_2_30_7 0 {Cg}
Mp_2_30_7 hv_L1_19 gp_2_30_7 colp_L2_30 0 NSYN W=10u L=1u
Mn_2_30_7 hv_L1_19 vcn coln_L2_30 0 NSYN W=10u L=1u
C_gp_2_30_8 gp_2_30_8 0 {Cg}
Mp_2_30_8 hv_L1_31 gp_2_30_8 colp_L2_30 0 NSYN W=10u L=1u
Mn_2_30_8 hv_L1_31 vcn coln_L2_30 0 NSYN W=10u L=1u
C_gp_2_30_9 gp_2_30_9 0 {Cg}
Mp_2_30_9 hv_L1_33 gp_2_30_9 colp_L2_30 0 NSYN W=10u L=1u
Mn_2_30_9 hv_L1_33 vcn coln_L2_30 0 NSYN W=10u L=1u
C_gp_2_30_10 gp_2_30_10 0 {Cg}
Mp_2_30_10 hv_L1_34 gp_2_30_10 colp_L2_30 0 NSYN W=10u L=1u
Mn_2_30_10 hv_L1_34 vcn coln_L2_30 0 NSYN W=10u L=1u
C_gp_2_30_11 gp_2_30_11 0 {Cg}
Mp_2_30_11 hv_L1_37 gp_2_30_11 colp_L2_30 0 NSYN W=10u L=1u
Mn_2_30_11 hv_L1_37 vcn coln_L2_30 0 NSYN W=10u L=1u
C_gp_2_30_12 gp_2_30_12 0 {Cg}
Mp_2_30_12 hv_L1_39 gp_2_30_12 colp_L2_30 0 NSYN W=10u L=1u
Mn_2_30_12 hv_L1_39 vcn coln_L2_30 0 NSYN W=10u L=1u
C_gp_2_30_13 gp_2_30_13 0 {Cg}
Mp_2_30_13 hv_L1_40 gp_2_30_13 colp_L2_30 0 NSYN W=10u L=1u
Mn_2_30_13 hv_L1_40 vcn coln_L2_30 0 NSYN W=10u L=1u
C_gp_2_30_14 gp_2_30_14 0 {Cg}
Mp_2_30_14 hv_L1_42 gp_2_30_14 colp_L2_30 0 NSYN W=10u L=1u
Mn_2_30_14 hv_L1_42 vcn coln_L2_30 0 NSYN W=10u L=1u
C_gp_2_30_15 gp_2_30_15 0 {Cg}
Mp_2_30_15 hv_L1_47 gp_2_30_15 colp_L2_30 0 NSYN W=10u L=1u
Mn_2_30_15 hv_L1_47 vcn coln_L2_30 0 NSYN W=10u L=1u
C_gp_2_30_b gp_2_30_b 0 {Cg}
Mp_2_30_b bx gp_2_30_b colp_L2_30 0 NSYN W=10u L=1u
Mn_2_30_b bx vcn coln_L2_30 0 NSYN W=10u L=1u
Msa_h_L2_30 coln_L2_30 coln_L2_30 0 0 NMIR W=20u L=1u
Msb_h_L2_30 z_L2_30 coln_L2_30 0 0 NMIR W=20u L=1u
Msc_h_L2_30 colp_L2_30 colp_L2_30 0 0 NMIR W=20u L=1u
Msd_h_L2_30 dpf_h_L2_30 colp_L2_30 0 0 NMIR W=20u L=1u
Mse_h_L2_30 dpf_h_L2_30 dpf_h_L2_30 vdd vdd PMIR W=60u L=1u
Msf_h_L2_30 z_L2_30 dpf_h_L2_30 vdd vdd PMIR W=60u L=1u
R_h_L2_30 z_L2_30 vrefh 8000.0
Mr_L2_30  hdd_L2_30 z_L2_30 tail_L2_30 0 NREL W=12u L=1u
Mr2_L2_30 dmp_L2_30  vmid  tail_L2_30 0 NREL W=12u L=1u
Mtl_L2_30 tail_L2_30 vtb 0 0 NREL W=32.0u L=1u
Mdm_L2_30 dmp_L2_30 dmp_L2_30 vdd vdd PMIR W=40u L=1u
Mrp1_L2_30 hdd_L2_30 hdd_L2_30 vdd vdd PMIR W=40u L=1u
Mrp2_L2_30 hv_L2_30 hdd_L2_30 vdd vdd PMIR W=40u L=1u
Rhv_L2_30 hv_L2_30 vg0 8000.0
C_gp_2_31_0 gp_2_31_0 0 {Cg}
Mp_2_31_0 hv_L1_1 gp_2_31_0 colp_L2_31 0 NSYN W=10u L=1u
Mn_2_31_0 hv_L1_1 vcn coln_L2_31 0 NSYN W=10u L=1u
C_gp_2_31_1 gp_2_31_1 0 {Cg}
Mp_2_31_1 hv_L1_2 gp_2_31_1 colp_L2_31 0 NSYN W=10u L=1u
Mn_2_31_1 hv_L1_2 vcn coln_L2_31 0 NSYN W=10u L=1u
C_gp_2_31_2 gp_2_31_2 0 {Cg}
Mp_2_31_2 hv_L1_4 gp_2_31_2 colp_L2_31 0 NSYN W=10u L=1u
Mn_2_31_2 hv_L1_4 vcn coln_L2_31 0 NSYN W=10u L=1u
C_gp_2_31_3 gp_2_31_3 0 {Cg}
Mp_2_31_3 hv_L1_7 gp_2_31_3 colp_L2_31 0 NSYN W=10u L=1u
Mn_2_31_3 hv_L1_7 vcn coln_L2_31 0 NSYN W=10u L=1u
C_gp_2_31_4 gp_2_31_4 0 {Cg}
Mp_2_31_4 hv_L1_11 gp_2_31_4 colp_L2_31 0 NSYN W=10u L=1u
Mn_2_31_4 hv_L1_11 vcn coln_L2_31 0 NSYN W=10u L=1u
C_gp_2_31_5 gp_2_31_5 0 {Cg}
Mp_2_31_5 hv_L1_12 gp_2_31_5 colp_L2_31 0 NSYN W=10u L=1u
Mn_2_31_5 hv_L1_12 vcn coln_L2_31 0 NSYN W=10u L=1u
C_gp_2_31_6 gp_2_31_6 0 {Cg}
Mp_2_31_6 hv_L1_13 gp_2_31_6 colp_L2_31 0 NSYN W=10u L=1u
Mn_2_31_6 hv_L1_13 vcn coln_L2_31 0 NSYN W=10u L=1u
C_gp_2_31_7 gp_2_31_7 0 {Cg}
Mp_2_31_7 hv_L1_18 gp_2_31_7 colp_L2_31 0 NSYN W=10u L=1u
Mn_2_31_7 hv_L1_18 vcn coln_L2_31 0 NSYN W=10u L=1u
C_gp_2_31_8 gp_2_31_8 0 {Cg}
Mp_2_31_8 hv_L1_27 gp_2_31_8 colp_L2_31 0 NSYN W=10u L=1u
Mn_2_31_8 hv_L1_27 vcn coln_L2_31 0 NSYN W=10u L=1u
C_gp_2_31_9 gp_2_31_9 0 {Cg}
Mp_2_31_9 hv_L1_28 gp_2_31_9 colp_L2_31 0 NSYN W=10u L=1u
Mn_2_31_9 hv_L1_28 vcn coln_L2_31 0 NSYN W=10u L=1u
C_gp_2_31_10 gp_2_31_10 0 {Cg}
Mp_2_31_10 hv_L1_29 gp_2_31_10 colp_L2_31 0 NSYN W=10u L=1u
Mn_2_31_10 hv_L1_29 vcn coln_L2_31 0 NSYN W=10u L=1u
C_gp_2_31_11 gp_2_31_11 0 {Cg}
Mp_2_31_11 hv_L1_30 gp_2_31_11 colp_L2_31 0 NSYN W=10u L=1u
Mn_2_31_11 hv_L1_30 vcn coln_L2_31 0 NSYN W=10u L=1u
C_gp_2_31_12 gp_2_31_12 0 {Cg}
Mp_2_31_12 hv_L1_33 gp_2_31_12 colp_L2_31 0 NSYN W=10u L=1u
Mn_2_31_12 hv_L1_33 vcn coln_L2_31 0 NSYN W=10u L=1u
C_gp_2_31_13 gp_2_31_13 0 {Cg}
Mp_2_31_13 hv_L1_38 gp_2_31_13 colp_L2_31 0 NSYN W=10u L=1u
Mn_2_31_13 hv_L1_38 vcn coln_L2_31 0 NSYN W=10u L=1u
C_gp_2_31_14 gp_2_31_14 0 {Cg}
Mp_2_31_14 hv_L1_45 gp_2_31_14 colp_L2_31 0 NSYN W=10u L=1u
Mn_2_31_14 hv_L1_45 vcn coln_L2_31 0 NSYN W=10u L=1u
C_gp_2_31_15 gp_2_31_15 0 {Cg}
Mp_2_31_15 hv_L1_46 gp_2_31_15 colp_L2_31 0 NSYN W=10u L=1u
Mn_2_31_15 hv_L1_46 vcn coln_L2_31 0 NSYN W=10u L=1u
C_gp_2_31_b gp_2_31_b 0 {Cg}
Mp_2_31_b bx gp_2_31_b colp_L2_31 0 NSYN W=10u L=1u
Mn_2_31_b bx vcn coln_L2_31 0 NSYN W=10u L=1u
Msa_h_L2_31 coln_L2_31 coln_L2_31 0 0 NMIR W=20u L=1u
Msb_h_L2_31 z_L2_31 coln_L2_31 0 0 NMIR W=20u L=1u
Msc_h_L2_31 colp_L2_31 colp_L2_31 0 0 NMIR W=20u L=1u
Msd_h_L2_31 dpf_h_L2_31 colp_L2_31 0 0 NMIR W=20u L=1u
Mse_h_L2_31 dpf_h_L2_31 dpf_h_L2_31 vdd vdd PMIR W=60u L=1u
Msf_h_L2_31 z_L2_31 dpf_h_L2_31 vdd vdd PMIR W=60u L=1u
R_h_L2_31 z_L2_31 vrefh 8000.0
Mr_L2_31  hdd_L2_31 z_L2_31 tail_L2_31 0 NREL W=12u L=1u
Mr2_L2_31 dmp_L2_31  vmid  tail_L2_31 0 NREL W=12u L=1u
Mtl_L2_31 tail_L2_31 vtb 0 0 NREL W=32.0u L=1u
Mdm_L2_31 dmp_L2_31 dmp_L2_31 vdd vdd PMIR W=40u L=1u
Mrp1_L2_31 hdd_L2_31 hdd_L2_31 vdd vdd PMIR W=40u L=1u
Mrp2_L2_31 hv_L2_31 hdd_L2_31 vdd vdd PMIR W=40u L=1u
Rhv_L2_31 hv_L2_31 vg0 8000.0
C_gp_2_32_0 gp_2_32_0 0 {Cg}
Mp_2_32_0 hv_L1_1 gp_2_32_0 colp_L2_32 0 NSYN W=10u L=1u
Mn_2_32_0 hv_L1_1 vcn coln_L2_32 0 NSYN W=10u L=1u
C_gp_2_32_1 gp_2_32_1 0 {Cg}
Mp_2_32_1 hv_L1_2 gp_2_32_1 colp_L2_32 0 NSYN W=10u L=1u
Mn_2_32_1 hv_L1_2 vcn coln_L2_32 0 NSYN W=10u L=1u
C_gp_2_32_2 gp_2_32_2 0 {Cg}
Mp_2_32_2 hv_L1_6 gp_2_32_2 colp_L2_32 0 NSYN W=10u L=1u
Mn_2_32_2 hv_L1_6 vcn coln_L2_32 0 NSYN W=10u L=1u
C_gp_2_32_3 gp_2_32_3 0 {Cg}
Mp_2_32_3 hv_L1_13 gp_2_32_3 colp_L2_32 0 NSYN W=10u L=1u
Mn_2_32_3 hv_L1_13 vcn coln_L2_32 0 NSYN W=10u L=1u
C_gp_2_32_4 gp_2_32_4 0 {Cg}
Mp_2_32_4 hv_L1_15 gp_2_32_4 colp_L2_32 0 NSYN W=10u L=1u
Mn_2_32_4 hv_L1_15 vcn coln_L2_32 0 NSYN W=10u L=1u
C_gp_2_32_5 gp_2_32_5 0 {Cg}
Mp_2_32_5 hv_L1_25 gp_2_32_5 colp_L2_32 0 NSYN W=10u L=1u
Mn_2_32_5 hv_L1_25 vcn coln_L2_32 0 NSYN W=10u L=1u
C_gp_2_32_6 gp_2_32_6 0 {Cg}
Mp_2_32_6 hv_L1_28 gp_2_32_6 colp_L2_32 0 NSYN W=10u L=1u
Mn_2_32_6 hv_L1_28 vcn coln_L2_32 0 NSYN W=10u L=1u
C_gp_2_32_7 gp_2_32_7 0 {Cg}
Mp_2_32_7 hv_L1_31 gp_2_32_7 colp_L2_32 0 NSYN W=10u L=1u
Mn_2_32_7 hv_L1_31 vcn coln_L2_32 0 NSYN W=10u L=1u
C_gp_2_32_8 gp_2_32_8 0 {Cg}
Mp_2_32_8 hv_L1_32 gp_2_32_8 colp_L2_32 0 NSYN W=10u L=1u
Mn_2_32_8 hv_L1_32 vcn coln_L2_32 0 NSYN W=10u L=1u
C_gp_2_32_9 gp_2_32_9 0 {Cg}
Mp_2_32_9 hv_L1_35 gp_2_32_9 colp_L2_32 0 NSYN W=10u L=1u
Mn_2_32_9 hv_L1_35 vcn coln_L2_32 0 NSYN W=10u L=1u
C_gp_2_32_10 gp_2_32_10 0 {Cg}
Mp_2_32_10 hv_L1_38 gp_2_32_10 colp_L2_32 0 NSYN W=10u L=1u
Mn_2_32_10 hv_L1_38 vcn coln_L2_32 0 NSYN W=10u L=1u
C_gp_2_32_11 gp_2_32_11 0 {Cg}
Mp_2_32_11 hv_L1_39 gp_2_32_11 colp_L2_32 0 NSYN W=10u L=1u
Mn_2_32_11 hv_L1_39 vcn coln_L2_32 0 NSYN W=10u L=1u
C_gp_2_32_12 gp_2_32_12 0 {Cg}
Mp_2_32_12 hv_L1_41 gp_2_32_12 colp_L2_32 0 NSYN W=10u L=1u
Mn_2_32_12 hv_L1_41 vcn coln_L2_32 0 NSYN W=10u L=1u
C_gp_2_32_13 gp_2_32_13 0 {Cg}
Mp_2_32_13 hv_L1_44 gp_2_32_13 colp_L2_32 0 NSYN W=10u L=1u
Mn_2_32_13 hv_L1_44 vcn coln_L2_32 0 NSYN W=10u L=1u
C_gp_2_32_14 gp_2_32_14 0 {Cg}
Mp_2_32_14 hv_L1_45 gp_2_32_14 colp_L2_32 0 NSYN W=10u L=1u
Mn_2_32_14 hv_L1_45 vcn coln_L2_32 0 NSYN W=10u L=1u
C_gp_2_32_15 gp_2_32_15 0 {Cg}
Mp_2_32_15 hv_L1_46 gp_2_32_15 colp_L2_32 0 NSYN W=10u L=1u
Mn_2_32_15 hv_L1_46 vcn coln_L2_32 0 NSYN W=10u L=1u
C_gp_2_32_b gp_2_32_b 0 {Cg}
Mp_2_32_b bx gp_2_32_b colp_L2_32 0 NSYN W=10u L=1u
Mn_2_32_b bx vcn coln_L2_32 0 NSYN W=10u L=1u
Msa_h_L2_32 coln_L2_32 coln_L2_32 0 0 NMIR W=20u L=1u
Msb_h_L2_32 z_L2_32 coln_L2_32 0 0 NMIR W=20u L=1u
Msc_h_L2_32 colp_L2_32 colp_L2_32 0 0 NMIR W=20u L=1u
Msd_h_L2_32 dpf_h_L2_32 colp_L2_32 0 0 NMIR W=20u L=1u
Mse_h_L2_32 dpf_h_L2_32 dpf_h_L2_32 vdd vdd PMIR W=60u L=1u
Msf_h_L2_32 z_L2_32 dpf_h_L2_32 vdd vdd PMIR W=60u L=1u
R_h_L2_32 z_L2_32 vrefh 8000.0
Mr_L2_32  hdd_L2_32 z_L2_32 tail_L2_32 0 NREL W=12u L=1u
Mr2_L2_32 dmp_L2_32  vmid  tail_L2_32 0 NREL W=12u L=1u
Mtl_L2_32 tail_L2_32 vtb 0 0 NREL W=32.0u L=1u
Mdm_L2_32 dmp_L2_32 dmp_L2_32 vdd vdd PMIR W=40u L=1u
Mrp1_L2_32 hdd_L2_32 hdd_L2_32 vdd vdd PMIR W=40u L=1u
Mrp2_L2_32 hv_L2_32 hdd_L2_32 vdd vdd PMIR W=40u L=1u
Rhv_L2_32 hv_L2_32 vg0 8000.0
C_gp_2_33_0 gp_2_33_0 0 {Cg}
Mp_2_33_0 hv_L1_4 gp_2_33_0 colp_L2_33 0 NSYN W=10u L=1u
Mn_2_33_0 hv_L1_4 vcn coln_L2_33 0 NSYN W=10u L=1u
C_gp_2_33_1 gp_2_33_1 0 {Cg}
Mp_2_33_1 hv_L1_6 gp_2_33_1 colp_L2_33 0 NSYN W=10u L=1u
Mn_2_33_1 hv_L1_6 vcn coln_L2_33 0 NSYN W=10u L=1u
C_gp_2_33_2 gp_2_33_2 0 {Cg}
Mp_2_33_2 hv_L1_9 gp_2_33_2 colp_L2_33 0 NSYN W=10u L=1u
Mn_2_33_2 hv_L1_9 vcn coln_L2_33 0 NSYN W=10u L=1u
C_gp_2_33_3 gp_2_33_3 0 {Cg}
Mp_2_33_3 hv_L1_12 gp_2_33_3 colp_L2_33 0 NSYN W=10u L=1u
Mn_2_33_3 hv_L1_12 vcn coln_L2_33 0 NSYN W=10u L=1u
C_gp_2_33_4 gp_2_33_4 0 {Cg}
Mp_2_33_4 hv_L1_13 gp_2_33_4 colp_L2_33 0 NSYN W=10u L=1u
Mn_2_33_4 hv_L1_13 vcn coln_L2_33 0 NSYN W=10u L=1u
C_gp_2_33_5 gp_2_33_5 0 {Cg}
Mp_2_33_5 hv_L1_18 gp_2_33_5 colp_L2_33 0 NSYN W=10u L=1u
Mn_2_33_5 hv_L1_18 vcn coln_L2_33 0 NSYN W=10u L=1u
C_gp_2_33_6 gp_2_33_6 0 {Cg}
Mp_2_33_6 hv_L1_20 gp_2_33_6 colp_L2_33 0 NSYN W=10u L=1u
Mn_2_33_6 hv_L1_20 vcn coln_L2_33 0 NSYN W=10u L=1u
C_gp_2_33_7 gp_2_33_7 0 {Cg}
Mp_2_33_7 hv_L1_25 gp_2_33_7 colp_L2_33 0 NSYN W=10u L=1u
Mn_2_33_7 hv_L1_25 vcn coln_L2_33 0 NSYN W=10u L=1u
C_gp_2_33_8 gp_2_33_8 0 {Cg}
Mp_2_33_8 hv_L1_30 gp_2_33_8 colp_L2_33 0 NSYN W=10u L=1u
Mn_2_33_8 hv_L1_30 vcn coln_L2_33 0 NSYN W=10u L=1u
C_gp_2_33_9 gp_2_33_9 0 {Cg}
Mp_2_33_9 hv_L1_32 gp_2_33_9 colp_L2_33 0 NSYN W=10u L=1u
Mn_2_33_9 hv_L1_32 vcn coln_L2_33 0 NSYN W=10u L=1u
C_gp_2_33_10 gp_2_33_10 0 {Cg}
Mp_2_33_10 hv_L1_34 gp_2_33_10 colp_L2_33 0 NSYN W=10u L=1u
Mn_2_33_10 hv_L1_34 vcn coln_L2_33 0 NSYN W=10u L=1u
C_gp_2_33_11 gp_2_33_11 0 {Cg}
Mp_2_33_11 hv_L1_37 gp_2_33_11 colp_L2_33 0 NSYN W=10u L=1u
Mn_2_33_11 hv_L1_37 vcn coln_L2_33 0 NSYN W=10u L=1u
C_gp_2_33_12 gp_2_33_12 0 {Cg}
Mp_2_33_12 hv_L1_39 gp_2_33_12 colp_L2_33 0 NSYN W=10u L=1u
Mn_2_33_12 hv_L1_39 vcn coln_L2_33 0 NSYN W=10u L=1u
C_gp_2_33_13 gp_2_33_13 0 {Cg}
Mp_2_33_13 hv_L1_43 gp_2_33_13 colp_L2_33 0 NSYN W=10u L=1u
Mn_2_33_13 hv_L1_43 vcn coln_L2_33 0 NSYN W=10u L=1u
C_gp_2_33_14 gp_2_33_14 0 {Cg}
Mp_2_33_14 hv_L1_44 gp_2_33_14 colp_L2_33 0 NSYN W=10u L=1u
Mn_2_33_14 hv_L1_44 vcn coln_L2_33 0 NSYN W=10u L=1u
C_gp_2_33_15 gp_2_33_15 0 {Cg}
Mp_2_33_15 hv_L1_47 gp_2_33_15 colp_L2_33 0 NSYN W=10u L=1u
Mn_2_33_15 hv_L1_47 vcn coln_L2_33 0 NSYN W=10u L=1u
C_gp_2_33_b gp_2_33_b 0 {Cg}
Mp_2_33_b bx gp_2_33_b colp_L2_33 0 NSYN W=10u L=1u
Mn_2_33_b bx vcn coln_L2_33 0 NSYN W=10u L=1u
Msa_h_L2_33 coln_L2_33 coln_L2_33 0 0 NMIR W=20u L=1u
Msb_h_L2_33 z_L2_33 coln_L2_33 0 0 NMIR W=20u L=1u
Msc_h_L2_33 colp_L2_33 colp_L2_33 0 0 NMIR W=20u L=1u
Msd_h_L2_33 dpf_h_L2_33 colp_L2_33 0 0 NMIR W=20u L=1u
Mse_h_L2_33 dpf_h_L2_33 dpf_h_L2_33 vdd vdd PMIR W=60u L=1u
Msf_h_L2_33 z_L2_33 dpf_h_L2_33 vdd vdd PMIR W=60u L=1u
R_h_L2_33 z_L2_33 vrefh 8000.0
Mr_L2_33  hdd_L2_33 z_L2_33 tail_L2_33 0 NREL W=12u L=1u
Mr2_L2_33 dmp_L2_33  vmid  tail_L2_33 0 NREL W=12u L=1u
Mtl_L2_33 tail_L2_33 vtb 0 0 NREL W=32.0u L=1u
Mdm_L2_33 dmp_L2_33 dmp_L2_33 vdd vdd PMIR W=40u L=1u
Mrp1_L2_33 hdd_L2_33 hdd_L2_33 vdd vdd PMIR W=40u L=1u
Mrp2_L2_33 hv_L2_33 hdd_L2_33 vdd vdd PMIR W=40u L=1u
Rhv_L2_33 hv_L2_33 vg0 8000.0
C_gp_2_34_0 gp_2_34_0 0 {Cg}
Mp_2_34_0 hv_L1_1 gp_2_34_0 colp_L2_34 0 NSYN W=10u L=1u
Mn_2_34_0 hv_L1_1 vcn coln_L2_34 0 NSYN W=10u L=1u
C_gp_2_34_1 gp_2_34_1 0 {Cg}
Mp_2_34_1 hv_L1_2 gp_2_34_1 colp_L2_34 0 NSYN W=10u L=1u
Mn_2_34_1 hv_L1_2 vcn coln_L2_34 0 NSYN W=10u L=1u
C_gp_2_34_2 gp_2_34_2 0 {Cg}
Mp_2_34_2 hv_L1_3 gp_2_34_2 colp_L2_34 0 NSYN W=10u L=1u
Mn_2_34_2 hv_L1_3 vcn coln_L2_34 0 NSYN W=10u L=1u
C_gp_2_34_3 gp_2_34_3 0 {Cg}
Mp_2_34_3 hv_L1_8 gp_2_34_3 colp_L2_34 0 NSYN W=10u L=1u
Mn_2_34_3 hv_L1_8 vcn coln_L2_34 0 NSYN W=10u L=1u
C_gp_2_34_4 gp_2_34_4 0 {Cg}
Mp_2_34_4 hv_L1_9 gp_2_34_4 colp_L2_34 0 NSYN W=10u L=1u
Mn_2_34_4 hv_L1_9 vcn coln_L2_34 0 NSYN W=10u L=1u
C_gp_2_34_5 gp_2_34_5 0 {Cg}
Mp_2_34_5 hv_L1_14 gp_2_34_5 colp_L2_34 0 NSYN W=10u L=1u
Mn_2_34_5 hv_L1_14 vcn coln_L2_34 0 NSYN W=10u L=1u
C_gp_2_34_6 gp_2_34_6 0 {Cg}
Mp_2_34_6 hv_L1_16 gp_2_34_6 colp_L2_34 0 NSYN W=10u L=1u
Mn_2_34_6 hv_L1_16 vcn coln_L2_34 0 NSYN W=10u L=1u
C_gp_2_34_7 gp_2_34_7 0 {Cg}
Mp_2_34_7 hv_L1_21 gp_2_34_7 colp_L2_34 0 NSYN W=10u L=1u
Mn_2_34_7 hv_L1_21 vcn coln_L2_34 0 NSYN W=10u L=1u
C_gp_2_34_8 gp_2_34_8 0 {Cg}
Mp_2_34_8 hv_L1_26 gp_2_34_8 colp_L2_34 0 NSYN W=10u L=1u
Mn_2_34_8 hv_L1_26 vcn coln_L2_34 0 NSYN W=10u L=1u
C_gp_2_34_9 gp_2_34_9 0 {Cg}
Mp_2_34_9 hv_L1_34 gp_2_34_9 colp_L2_34 0 NSYN W=10u L=1u
Mn_2_34_9 hv_L1_34 vcn coln_L2_34 0 NSYN W=10u L=1u
C_gp_2_34_10 gp_2_34_10 0 {Cg}
Mp_2_34_10 hv_L1_38 gp_2_34_10 colp_L2_34 0 NSYN W=10u L=1u
Mn_2_34_10 hv_L1_38 vcn coln_L2_34 0 NSYN W=10u L=1u
C_gp_2_34_11 gp_2_34_11 0 {Cg}
Mp_2_34_11 hv_L1_40 gp_2_34_11 colp_L2_34 0 NSYN W=10u L=1u
Mn_2_34_11 hv_L1_40 vcn coln_L2_34 0 NSYN W=10u L=1u
C_gp_2_34_12 gp_2_34_12 0 {Cg}
Mp_2_34_12 hv_L1_41 gp_2_34_12 colp_L2_34 0 NSYN W=10u L=1u
Mn_2_34_12 hv_L1_41 vcn coln_L2_34 0 NSYN W=10u L=1u
C_gp_2_34_13 gp_2_34_13 0 {Cg}
Mp_2_34_13 hv_L1_42 gp_2_34_13 colp_L2_34 0 NSYN W=10u L=1u
Mn_2_34_13 hv_L1_42 vcn coln_L2_34 0 NSYN W=10u L=1u
C_gp_2_34_14 gp_2_34_14 0 {Cg}
Mp_2_34_14 hv_L1_43 gp_2_34_14 colp_L2_34 0 NSYN W=10u L=1u
Mn_2_34_14 hv_L1_43 vcn coln_L2_34 0 NSYN W=10u L=1u
C_gp_2_34_15 gp_2_34_15 0 {Cg}
Mp_2_34_15 hv_L1_47 gp_2_34_15 colp_L2_34 0 NSYN W=10u L=1u
Mn_2_34_15 hv_L1_47 vcn coln_L2_34 0 NSYN W=10u L=1u
C_gp_2_34_b gp_2_34_b 0 {Cg}
Mp_2_34_b bx gp_2_34_b colp_L2_34 0 NSYN W=10u L=1u
Mn_2_34_b bx vcn coln_L2_34 0 NSYN W=10u L=1u
Msa_h_L2_34 coln_L2_34 coln_L2_34 0 0 NMIR W=20u L=1u
Msb_h_L2_34 z_L2_34 coln_L2_34 0 0 NMIR W=20u L=1u
Msc_h_L2_34 colp_L2_34 colp_L2_34 0 0 NMIR W=20u L=1u
Msd_h_L2_34 dpf_h_L2_34 colp_L2_34 0 0 NMIR W=20u L=1u
Mse_h_L2_34 dpf_h_L2_34 dpf_h_L2_34 vdd vdd PMIR W=60u L=1u
Msf_h_L2_34 z_L2_34 dpf_h_L2_34 vdd vdd PMIR W=60u L=1u
R_h_L2_34 z_L2_34 vrefh 8000.0
Mr_L2_34  hdd_L2_34 z_L2_34 tail_L2_34 0 NREL W=12u L=1u
Mr2_L2_34 dmp_L2_34  vmid  tail_L2_34 0 NREL W=12u L=1u
Mtl_L2_34 tail_L2_34 vtb 0 0 NREL W=32.0u L=1u
Mdm_L2_34 dmp_L2_34 dmp_L2_34 vdd vdd PMIR W=40u L=1u
Mrp1_L2_34 hdd_L2_34 hdd_L2_34 vdd vdd PMIR W=40u L=1u
Mrp2_L2_34 hv_L2_34 hdd_L2_34 vdd vdd PMIR W=40u L=1u
Rhv_L2_34 hv_L2_34 vg0 8000.0
C_gp_2_35_0 gp_2_35_0 0 {Cg}
Mp_2_35_0 hv_L1_1 gp_2_35_0 colp_L2_35 0 NSYN W=10u L=1u
Mn_2_35_0 hv_L1_1 vcn coln_L2_35 0 NSYN W=10u L=1u
C_gp_2_35_1 gp_2_35_1 0 {Cg}
Mp_2_35_1 hv_L1_6 gp_2_35_1 colp_L2_35 0 NSYN W=10u L=1u
Mn_2_35_1 hv_L1_6 vcn coln_L2_35 0 NSYN W=10u L=1u
C_gp_2_35_2 gp_2_35_2 0 {Cg}
Mp_2_35_2 hv_L1_8 gp_2_35_2 colp_L2_35 0 NSYN W=10u L=1u
Mn_2_35_2 hv_L1_8 vcn coln_L2_35 0 NSYN W=10u L=1u
C_gp_2_35_3 gp_2_35_3 0 {Cg}
Mp_2_35_3 hv_L1_12 gp_2_35_3 colp_L2_35 0 NSYN W=10u L=1u
Mn_2_35_3 hv_L1_12 vcn coln_L2_35 0 NSYN W=10u L=1u
C_gp_2_35_4 gp_2_35_4 0 {Cg}
Mp_2_35_4 hv_L1_18 gp_2_35_4 colp_L2_35 0 NSYN W=10u L=1u
Mn_2_35_4 hv_L1_18 vcn coln_L2_35 0 NSYN W=10u L=1u
C_gp_2_35_5 gp_2_35_5 0 {Cg}
Mp_2_35_5 hv_L1_21 gp_2_35_5 colp_L2_35 0 NSYN W=10u L=1u
Mn_2_35_5 hv_L1_21 vcn coln_L2_35 0 NSYN W=10u L=1u
C_gp_2_35_6 gp_2_35_6 0 {Cg}
Mp_2_35_6 hv_L1_24 gp_2_35_6 colp_L2_35 0 NSYN W=10u L=1u
Mn_2_35_6 hv_L1_24 vcn coln_L2_35 0 NSYN W=10u L=1u
C_gp_2_35_7 gp_2_35_7 0 {Cg}
Mp_2_35_7 hv_L1_25 gp_2_35_7 colp_L2_35 0 NSYN W=10u L=1u
Mn_2_35_7 hv_L1_25 vcn coln_L2_35 0 NSYN W=10u L=1u
C_gp_2_35_8 gp_2_35_8 0 {Cg}
Mp_2_35_8 hv_L1_26 gp_2_35_8 colp_L2_35 0 NSYN W=10u L=1u
Mn_2_35_8 hv_L1_26 vcn coln_L2_35 0 NSYN W=10u L=1u
C_gp_2_35_9 gp_2_35_9 0 {Cg}
Mp_2_35_9 hv_L1_31 gp_2_35_9 colp_L2_35 0 NSYN W=10u L=1u
Mn_2_35_9 hv_L1_31 vcn coln_L2_35 0 NSYN W=10u L=1u
C_gp_2_35_10 gp_2_35_10 0 {Cg}
Mp_2_35_10 hv_L1_36 gp_2_35_10 colp_L2_35 0 NSYN W=10u L=1u
Mn_2_35_10 hv_L1_36 vcn coln_L2_35 0 NSYN W=10u L=1u
C_gp_2_35_11 gp_2_35_11 0 {Cg}
Mp_2_35_11 hv_L1_38 gp_2_35_11 colp_L2_35 0 NSYN W=10u L=1u
Mn_2_35_11 hv_L1_38 vcn coln_L2_35 0 NSYN W=10u L=1u
C_gp_2_35_12 gp_2_35_12 0 {Cg}
Mp_2_35_12 hv_L1_39 gp_2_35_12 colp_L2_35 0 NSYN W=10u L=1u
Mn_2_35_12 hv_L1_39 vcn coln_L2_35 0 NSYN W=10u L=1u
C_gp_2_35_13 gp_2_35_13 0 {Cg}
Mp_2_35_13 hv_L1_41 gp_2_35_13 colp_L2_35 0 NSYN W=10u L=1u
Mn_2_35_13 hv_L1_41 vcn coln_L2_35 0 NSYN W=10u L=1u
C_gp_2_35_14 gp_2_35_14 0 {Cg}
Mp_2_35_14 hv_L1_42 gp_2_35_14 colp_L2_35 0 NSYN W=10u L=1u
Mn_2_35_14 hv_L1_42 vcn coln_L2_35 0 NSYN W=10u L=1u
C_gp_2_35_15 gp_2_35_15 0 {Cg}
Mp_2_35_15 hv_L1_46 gp_2_35_15 colp_L2_35 0 NSYN W=10u L=1u
Mn_2_35_15 hv_L1_46 vcn coln_L2_35 0 NSYN W=10u L=1u
C_gp_2_35_b gp_2_35_b 0 {Cg}
Mp_2_35_b bx gp_2_35_b colp_L2_35 0 NSYN W=10u L=1u
Mn_2_35_b bx vcn coln_L2_35 0 NSYN W=10u L=1u
Msa_h_L2_35 coln_L2_35 coln_L2_35 0 0 NMIR W=20u L=1u
Msb_h_L2_35 z_L2_35 coln_L2_35 0 0 NMIR W=20u L=1u
Msc_h_L2_35 colp_L2_35 colp_L2_35 0 0 NMIR W=20u L=1u
Msd_h_L2_35 dpf_h_L2_35 colp_L2_35 0 0 NMIR W=20u L=1u
Mse_h_L2_35 dpf_h_L2_35 dpf_h_L2_35 vdd vdd PMIR W=60u L=1u
Msf_h_L2_35 z_L2_35 dpf_h_L2_35 vdd vdd PMIR W=60u L=1u
R_h_L2_35 z_L2_35 vrefh 8000.0
Mr_L2_35  hdd_L2_35 z_L2_35 tail_L2_35 0 NREL W=12u L=1u
Mr2_L2_35 dmp_L2_35  vmid  tail_L2_35 0 NREL W=12u L=1u
Mtl_L2_35 tail_L2_35 vtb 0 0 NREL W=32.0u L=1u
Mdm_L2_35 dmp_L2_35 dmp_L2_35 vdd vdd PMIR W=40u L=1u
Mrp1_L2_35 hdd_L2_35 hdd_L2_35 vdd vdd PMIR W=40u L=1u
Mrp2_L2_35 hv_L2_35 hdd_L2_35 vdd vdd PMIR W=40u L=1u
Rhv_L2_35 hv_L2_35 vg0 8000.0
C_gp_2_36_0 gp_2_36_0 0 {Cg}
Mp_2_36_0 hv_L1_0 gp_2_36_0 colp_L2_36 0 NSYN W=10u L=1u
Mn_2_36_0 hv_L1_0 vcn coln_L2_36 0 NSYN W=10u L=1u
C_gp_2_36_1 gp_2_36_1 0 {Cg}
Mp_2_36_1 hv_L1_1 gp_2_36_1 colp_L2_36 0 NSYN W=10u L=1u
Mn_2_36_1 hv_L1_1 vcn coln_L2_36 0 NSYN W=10u L=1u
C_gp_2_36_2 gp_2_36_2 0 {Cg}
Mp_2_36_2 hv_L1_6 gp_2_36_2 colp_L2_36 0 NSYN W=10u L=1u
Mn_2_36_2 hv_L1_6 vcn coln_L2_36 0 NSYN W=10u L=1u
C_gp_2_36_3 gp_2_36_3 0 {Cg}
Mp_2_36_3 hv_L1_7 gp_2_36_3 colp_L2_36 0 NSYN W=10u L=1u
Mn_2_36_3 hv_L1_7 vcn coln_L2_36 0 NSYN W=10u L=1u
C_gp_2_36_4 gp_2_36_4 0 {Cg}
Mp_2_36_4 hv_L1_10 gp_2_36_4 colp_L2_36 0 NSYN W=10u L=1u
Mn_2_36_4 hv_L1_10 vcn coln_L2_36 0 NSYN W=10u L=1u
C_gp_2_36_5 gp_2_36_5 0 {Cg}
Mp_2_36_5 hv_L1_11 gp_2_36_5 colp_L2_36 0 NSYN W=10u L=1u
Mn_2_36_5 hv_L1_11 vcn coln_L2_36 0 NSYN W=10u L=1u
C_gp_2_36_6 gp_2_36_6 0 {Cg}
Mp_2_36_6 hv_L1_17 gp_2_36_6 colp_L2_36 0 NSYN W=10u L=1u
Mn_2_36_6 hv_L1_17 vcn coln_L2_36 0 NSYN W=10u L=1u
C_gp_2_36_7 gp_2_36_7 0 {Cg}
Mp_2_36_7 hv_L1_23 gp_2_36_7 colp_L2_36 0 NSYN W=10u L=1u
Mn_2_36_7 hv_L1_23 vcn coln_L2_36 0 NSYN W=10u L=1u
C_gp_2_36_8 gp_2_36_8 0 {Cg}
Mp_2_36_8 hv_L1_24 gp_2_36_8 colp_L2_36 0 NSYN W=10u L=1u
Mn_2_36_8 hv_L1_24 vcn coln_L2_36 0 NSYN W=10u L=1u
C_gp_2_36_9 gp_2_36_9 0 {Cg}
Mp_2_36_9 hv_L1_25 gp_2_36_9 colp_L2_36 0 NSYN W=10u L=1u
Mn_2_36_9 hv_L1_25 vcn coln_L2_36 0 NSYN W=10u L=1u
C_gp_2_36_10 gp_2_36_10 0 {Cg}
Mp_2_36_10 hv_L1_29 gp_2_36_10 colp_L2_36 0 NSYN W=10u L=1u
Mn_2_36_10 hv_L1_29 vcn coln_L2_36 0 NSYN W=10u L=1u
C_gp_2_36_11 gp_2_36_11 0 {Cg}
Mp_2_36_11 hv_L1_36 gp_2_36_11 colp_L2_36 0 NSYN W=10u L=1u
Mn_2_36_11 hv_L1_36 vcn coln_L2_36 0 NSYN W=10u L=1u
C_gp_2_36_12 gp_2_36_12 0 {Cg}
Mp_2_36_12 hv_L1_38 gp_2_36_12 colp_L2_36 0 NSYN W=10u L=1u
Mn_2_36_12 hv_L1_38 vcn coln_L2_36 0 NSYN W=10u L=1u
C_gp_2_36_13 gp_2_36_13 0 {Cg}
Mp_2_36_13 hv_L1_39 gp_2_36_13 colp_L2_36 0 NSYN W=10u L=1u
Mn_2_36_13 hv_L1_39 vcn coln_L2_36 0 NSYN W=10u L=1u
C_gp_2_36_14 gp_2_36_14 0 {Cg}
Mp_2_36_14 hv_L1_43 gp_2_36_14 colp_L2_36 0 NSYN W=10u L=1u
Mn_2_36_14 hv_L1_43 vcn coln_L2_36 0 NSYN W=10u L=1u
C_gp_2_36_15 gp_2_36_15 0 {Cg}
Mp_2_36_15 hv_L1_46 gp_2_36_15 colp_L2_36 0 NSYN W=10u L=1u
Mn_2_36_15 hv_L1_46 vcn coln_L2_36 0 NSYN W=10u L=1u
C_gp_2_36_b gp_2_36_b 0 {Cg}
Mp_2_36_b bx gp_2_36_b colp_L2_36 0 NSYN W=10u L=1u
Mn_2_36_b bx vcn coln_L2_36 0 NSYN W=10u L=1u
Msa_h_L2_36 coln_L2_36 coln_L2_36 0 0 NMIR W=20u L=1u
Msb_h_L2_36 z_L2_36 coln_L2_36 0 0 NMIR W=20u L=1u
Msc_h_L2_36 colp_L2_36 colp_L2_36 0 0 NMIR W=20u L=1u
Msd_h_L2_36 dpf_h_L2_36 colp_L2_36 0 0 NMIR W=20u L=1u
Mse_h_L2_36 dpf_h_L2_36 dpf_h_L2_36 vdd vdd PMIR W=60u L=1u
Msf_h_L2_36 z_L2_36 dpf_h_L2_36 vdd vdd PMIR W=60u L=1u
R_h_L2_36 z_L2_36 vrefh 8000.0
Mr_L2_36  hdd_L2_36 z_L2_36 tail_L2_36 0 NREL W=12u L=1u
Mr2_L2_36 dmp_L2_36  vmid  tail_L2_36 0 NREL W=12u L=1u
Mtl_L2_36 tail_L2_36 vtb 0 0 NREL W=32.0u L=1u
Mdm_L2_36 dmp_L2_36 dmp_L2_36 vdd vdd PMIR W=40u L=1u
Mrp1_L2_36 hdd_L2_36 hdd_L2_36 vdd vdd PMIR W=40u L=1u
Mrp2_L2_36 hv_L2_36 hdd_L2_36 vdd vdd PMIR W=40u L=1u
Rhv_L2_36 hv_L2_36 vg0 8000.0
C_gp_2_37_0 gp_2_37_0 0 {Cg}
Mp_2_37_0 hv_L1_4 gp_2_37_0 colp_L2_37 0 NSYN W=10u L=1u
Mn_2_37_0 hv_L1_4 vcn coln_L2_37 0 NSYN W=10u L=1u
C_gp_2_37_1 gp_2_37_1 0 {Cg}
Mp_2_37_1 hv_L1_5 gp_2_37_1 colp_L2_37 0 NSYN W=10u L=1u
Mn_2_37_1 hv_L1_5 vcn coln_L2_37 0 NSYN W=10u L=1u
C_gp_2_37_2 gp_2_37_2 0 {Cg}
Mp_2_37_2 hv_L1_7 gp_2_37_2 colp_L2_37 0 NSYN W=10u L=1u
Mn_2_37_2 hv_L1_7 vcn coln_L2_37 0 NSYN W=10u L=1u
C_gp_2_37_3 gp_2_37_3 0 {Cg}
Mp_2_37_3 hv_L1_12 gp_2_37_3 colp_L2_37 0 NSYN W=10u L=1u
Mn_2_37_3 hv_L1_12 vcn coln_L2_37 0 NSYN W=10u L=1u
C_gp_2_37_4 gp_2_37_4 0 {Cg}
Mp_2_37_4 hv_L1_15 gp_2_37_4 colp_L2_37 0 NSYN W=10u L=1u
Mn_2_37_4 hv_L1_15 vcn coln_L2_37 0 NSYN W=10u L=1u
C_gp_2_37_5 gp_2_37_5 0 {Cg}
Mp_2_37_5 hv_L1_16 gp_2_37_5 colp_L2_37 0 NSYN W=10u L=1u
Mn_2_37_5 hv_L1_16 vcn coln_L2_37 0 NSYN W=10u L=1u
C_gp_2_37_6 gp_2_37_6 0 {Cg}
Mp_2_37_6 hv_L1_17 gp_2_37_6 colp_L2_37 0 NSYN W=10u L=1u
Mn_2_37_6 hv_L1_17 vcn coln_L2_37 0 NSYN W=10u L=1u
C_gp_2_37_7 gp_2_37_7 0 {Cg}
Mp_2_37_7 hv_L1_18 gp_2_37_7 colp_L2_37 0 NSYN W=10u L=1u
Mn_2_37_7 hv_L1_18 vcn coln_L2_37 0 NSYN W=10u L=1u
C_gp_2_37_8 gp_2_37_8 0 {Cg}
Mp_2_37_8 hv_L1_27 gp_2_37_8 colp_L2_37 0 NSYN W=10u L=1u
Mn_2_37_8 hv_L1_27 vcn coln_L2_37 0 NSYN W=10u L=1u
C_gp_2_37_9 gp_2_37_9 0 {Cg}
Mp_2_37_9 hv_L1_31 gp_2_37_9 colp_L2_37 0 NSYN W=10u L=1u
Mn_2_37_9 hv_L1_31 vcn coln_L2_37 0 NSYN W=10u L=1u
C_gp_2_37_10 gp_2_37_10 0 {Cg}
Mp_2_37_10 hv_L1_36 gp_2_37_10 colp_L2_37 0 NSYN W=10u L=1u
Mn_2_37_10 hv_L1_36 vcn coln_L2_37 0 NSYN W=10u L=1u
C_gp_2_37_11 gp_2_37_11 0 {Cg}
Mp_2_37_11 hv_L1_42 gp_2_37_11 colp_L2_37 0 NSYN W=10u L=1u
Mn_2_37_11 hv_L1_42 vcn coln_L2_37 0 NSYN W=10u L=1u
C_gp_2_37_12 gp_2_37_12 0 {Cg}
Mp_2_37_12 hv_L1_43 gp_2_37_12 colp_L2_37 0 NSYN W=10u L=1u
Mn_2_37_12 hv_L1_43 vcn coln_L2_37 0 NSYN W=10u L=1u
C_gp_2_37_13 gp_2_37_13 0 {Cg}
Mp_2_37_13 hv_L1_44 gp_2_37_13 colp_L2_37 0 NSYN W=10u L=1u
Mn_2_37_13 hv_L1_44 vcn coln_L2_37 0 NSYN W=10u L=1u
C_gp_2_37_14 gp_2_37_14 0 {Cg}
Mp_2_37_14 hv_L1_45 gp_2_37_14 colp_L2_37 0 NSYN W=10u L=1u
Mn_2_37_14 hv_L1_45 vcn coln_L2_37 0 NSYN W=10u L=1u
C_gp_2_37_15 gp_2_37_15 0 {Cg}
Mp_2_37_15 hv_L1_47 gp_2_37_15 colp_L2_37 0 NSYN W=10u L=1u
Mn_2_37_15 hv_L1_47 vcn coln_L2_37 0 NSYN W=10u L=1u
C_gp_2_37_b gp_2_37_b 0 {Cg}
Mp_2_37_b bx gp_2_37_b colp_L2_37 0 NSYN W=10u L=1u
Mn_2_37_b bx vcn coln_L2_37 0 NSYN W=10u L=1u
Msa_h_L2_37 coln_L2_37 coln_L2_37 0 0 NMIR W=20u L=1u
Msb_h_L2_37 z_L2_37 coln_L2_37 0 0 NMIR W=20u L=1u
Msc_h_L2_37 colp_L2_37 colp_L2_37 0 0 NMIR W=20u L=1u
Msd_h_L2_37 dpf_h_L2_37 colp_L2_37 0 0 NMIR W=20u L=1u
Mse_h_L2_37 dpf_h_L2_37 dpf_h_L2_37 vdd vdd PMIR W=60u L=1u
Msf_h_L2_37 z_L2_37 dpf_h_L2_37 vdd vdd PMIR W=60u L=1u
R_h_L2_37 z_L2_37 vrefh 8000.0
Mr_L2_37  hdd_L2_37 z_L2_37 tail_L2_37 0 NREL W=12u L=1u
Mr2_L2_37 dmp_L2_37  vmid  tail_L2_37 0 NREL W=12u L=1u
Mtl_L2_37 tail_L2_37 vtb 0 0 NREL W=32.0u L=1u
Mdm_L2_37 dmp_L2_37 dmp_L2_37 vdd vdd PMIR W=40u L=1u
Mrp1_L2_37 hdd_L2_37 hdd_L2_37 vdd vdd PMIR W=40u L=1u
Mrp2_L2_37 hv_L2_37 hdd_L2_37 vdd vdd PMIR W=40u L=1u
Rhv_L2_37 hv_L2_37 vg0 8000.0
C_gp_2_38_0 gp_2_38_0 0 {Cg}
Mp_2_38_0 hv_L1_1 gp_2_38_0 colp_L2_38 0 NSYN W=10u L=1u
Mn_2_38_0 hv_L1_1 vcn coln_L2_38 0 NSYN W=10u L=1u
C_gp_2_38_1 gp_2_38_1 0 {Cg}
Mp_2_38_1 hv_L1_9 gp_2_38_1 colp_L2_38 0 NSYN W=10u L=1u
Mn_2_38_1 hv_L1_9 vcn coln_L2_38 0 NSYN W=10u L=1u
C_gp_2_38_2 gp_2_38_2 0 {Cg}
Mp_2_38_2 hv_L1_11 gp_2_38_2 colp_L2_38 0 NSYN W=10u L=1u
Mn_2_38_2 hv_L1_11 vcn coln_L2_38 0 NSYN W=10u L=1u
C_gp_2_38_3 gp_2_38_3 0 {Cg}
Mp_2_38_3 hv_L1_13 gp_2_38_3 colp_L2_38 0 NSYN W=10u L=1u
Mn_2_38_3 hv_L1_13 vcn coln_L2_38 0 NSYN W=10u L=1u
C_gp_2_38_4 gp_2_38_4 0 {Cg}
Mp_2_38_4 hv_L1_17 gp_2_38_4 colp_L2_38 0 NSYN W=10u L=1u
Mn_2_38_4 hv_L1_17 vcn coln_L2_38 0 NSYN W=10u L=1u
C_gp_2_38_5 gp_2_38_5 0 {Cg}
Mp_2_38_5 hv_L1_21 gp_2_38_5 colp_L2_38 0 NSYN W=10u L=1u
Mn_2_38_5 hv_L1_21 vcn coln_L2_38 0 NSYN W=10u L=1u
C_gp_2_38_6 gp_2_38_6 0 {Cg}
Mp_2_38_6 hv_L1_23 gp_2_38_6 colp_L2_38 0 NSYN W=10u L=1u
Mn_2_38_6 hv_L1_23 vcn coln_L2_38 0 NSYN W=10u L=1u
C_gp_2_38_7 gp_2_38_7 0 {Cg}
Mp_2_38_7 hv_L1_25 gp_2_38_7 colp_L2_38 0 NSYN W=10u L=1u
Mn_2_38_7 hv_L1_25 vcn coln_L2_38 0 NSYN W=10u L=1u
C_gp_2_38_8 gp_2_38_8 0 {Cg}
Mp_2_38_8 hv_L1_27 gp_2_38_8 colp_L2_38 0 NSYN W=10u L=1u
Mn_2_38_8 hv_L1_27 vcn coln_L2_38 0 NSYN W=10u L=1u
C_gp_2_38_9 gp_2_38_9 0 {Cg}
Mp_2_38_9 hv_L1_29 gp_2_38_9 colp_L2_38 0 NSYN W=10u L=1u
Mn_2_38_9 hv_L1_29 vcn coln_L2_38 0 NSYN W=10u L=1u
C_gp_2_38_10 gp_2_38_10 0 {Cg}
Mp_2_38_10 hv_L1_32 gp_2_38_10 colp_L2_38 0 NSYN W=10u L=1u
Mn_2_38_10 hv_L1_32 vcn coln_L2_38 0 NSYN W=10u L=1u
C_gp_2_38_11 gp_2_38_11 0 {Cg}
Mp_2_38_11 hv_L1_42 gp_2_38_11 colp_L2_38 0 NSYN W=10u L=1u
Mn_2_38_11 hv_L1_42 vcn coln_L2_38 0 NSYN W=10u L=1u
C_gp_2_38_12 gp_2_38_12 0 {Cg}
Mp_2_38_12 hv_L1_43 gp_2_38_12 colp_L2_38 0 NSYN W=10u L=1u
Mn_2_38_12 hv_L1_43 vcn coln_L2_38 0 NSYN W=10u L=1u
C_gp_2_38_13 gp_2_38_13 0 {Cg}
Mp_2_38_13 hv_L1_44 gp_2_38_13 colp_L2_38 0 NSYN W=10u L=1u
Mn_2_38_13 hv_L1_44 vcn coln_L2_38 0 NSYN W=10u L=1u
C_gp_2_38_14 gp_2_38_14 0 {Cg}
Mp_2_38_14 hv_L1_45 gp_2_38_14 colp_L2_38 0 NSYN W=10u L=1u
Mn_2_38_14 hv_L1_45 vcn coln_L2_38 0 NSYN W=10u L=1u
C_gp_2_38_15 gp_2_38_15 0 {Cg}
Mp_2_38_15 hv_L1_46 gp_2_38_15 colp_L2_38 0 NSYN W=10u L=1u
Mn_2_38_15 hv_L1_46 vcn coln_L2_38 0 NSYN W=10u L=1u
C_gp_2_38_b gp_2_38_b 0 {Cg}
Mp_2_38_b bx gp_2_38_b colp_L2_38 0 NSYN W=10u L=1u
Mn_2_38_b bx vcn coln_L2_38 0 NSYN W=10u L=1u
Msa_h_L2_38 coln_L2_38 coln_L2_38 0 0 NMIR W=20u L=1u
Msb_h_L2_38 z_L2_38 coln_L2_38 0 0 NMIR W=20u L=1u
Msc_h_L2_38 colp_L2_38 colp_L2_38 0 0 NMIR W=20u L=1u
Msd_h_L2_38 dpf_h_L2_38 colp_L2_38 0 0 NMIR W=20u L=1u
Mse_h_L2_38 dpf_h_L2_38 dpf_h_L2_38 vdd vdd PMIR W=60u L=1u
Msf_h_L2_38 z_L2_38 dpf_h_L2_38 vdd vdd PMIR W=60u L=1u
R_h_L2_38 z_L2_38 vrefh 8000.0
Mr_L2_38  hdd_L2_38 z_L2_38 tail_L2_38 0 NREL W=12u L=1u
Mr2_L2_38 dmp_L2_38  vmid  tail_L2_38 0 NREL W=12u L=1u
Mtl_L2_38 tail_L2_38 vtb 0 0 NREL W=32.0u L=1u
Mdm_L2_38 dmp_L2_38 dmp_L2_38 vdd vdd PMIR W=40u L=1u
Mrp1_L2_38 hdd_L2_38 hdd_L2_38 vdd vdd PMIR W=40u L=1u
Mrp2_L2_38 hv_L2_38 hdd_L2_38 vdd vdd PMIR W=40u L=1u
Rhv_L2_38 hv_L2_38 vg0 8000.0
C_gp_2_39_0 gp_2_39_0 0 {Cg}
Mp_2_39_0 hv_L1_3 gp_2_39_0 colp_L2_39 0 NSYN W=10u L=1u
Mn_2_39_0 hv_L1_3 vcn coln_L2_39 0 NSYN W=10u L=1u
C_gp_2_39_1 gp_2_39_1 0 {Cg}
Mp_2_39_1 hv_L1_4 gp_2_39_1 colp_L2_39 0 NSYN W=10u L=1u
Mn_2_39_1 hv_L1_4 vcn coln_L2_39 0 NSYN W=10u L=1u
C_gp_2_39_2 gp_2_39_2 0 {Cg}
Mp_2_39_2 hv_L1_9 gp_2_39_2 colp_L2_39 0 NSYN W=10u L=1u
Mn_2_39_2 hv_L1_9 vcn coln_L2_39 0 NSYN W=10u L=1u
C_gp_2_39_3 gp_2_39_3 0 {Cg}
Mp_2_39_3 hv_L1_11 gp_2_39_3 colp_L2_39 0 NSYN W=10u L=1u
Mn_2_39_3 hv_L1_11 vcn coln_L2_39 0 NSYN W=10u L=1u
C_gp_2_39_4 gp_2_39_4 0 {Cg}
Mp_2_39_4 hv_L1_13 gp_2_39_4 colp_L2_39 0 NSYN W=10u L=1u
Mn_2_39_4 hv_L1_13 vcn coln_L2_39 0 NSYN W=10u L=1u
C_gp_2_39_5 gp_2_39_5 0 {Cg}
Mp_2_39_5 hv_L1_14 gp_2_39_5 colp_L2_39 0 NSYN W=10u L=1u
Mn_2_39_5 hv_L1_14 vcn coln_L2_39 0 NSYN W=10u L=1u
C_gp_2_39_6 gp_2_39_6 0 {Cg}
Mp_2_39_6 hv_L1_16 gp_2_39_6 colp_L2_39 0 NSYN W=10u L=1u
Mn_2_39_6 hv_L1_16 vcn coln_L2_39 0 NSYN W=10u L=1u
C_gp_2_39_7 gp_2_39_7 0 {Cg}
Mp_2_39_7 hv_L1_17 gp_2_39_7 colp_L2_39 0 NSYN W=10u L=1u
Mn_2_39_7 hv_L1_17 vcn coln_L2_39 0 NSYN W=10u L=1u
C_gp_2_39_8 gp_2_39_8 0 {Cg}
Mp_2_39_8 hv_L1_19 gp_2_39_8 colp_L2_39 0 NSYN W=10u L=1u
Mn_2_39_8 hv_L1_19 vcn coln_L2_39 0 NSYN W=10u L=1u
C_gp_2_39_9 gp_2_39_9 0 {Cg}
Mp_2_39_9 hv_L1_22 gp_2_39_9 colp_L2_39 0 NSYN W=10u L=1u
Mn_2_39_9 hv_L1_22 vcn coln_L2_39 0 NSYN W=10u L=1u
C_gp_2_39_10 gp_2_39_10 0 {Cg}
Mp_2_39_10 hv_L1_24 gp_2_39_10 colp_L2_39 0 NSYN W=10u L=1u
Mn_2_39_10 hv_L1_24 vcn coln_L2_39 0 NSYN W=10u L=1u
C_gp_2_39_11 gp_2_39_11 0 {Cg}
Mp_2_39_11 hv_L1_30 gp_2_39_11 colp_L2_39 0 NSYN W=10u L=1u
Mn_2_39_11 hv_L1_30 vcn coln_L2_39 0 NSYN W=10u L=1u
C_gp_2_39_12 gp_2_39_12 0 {Cg}
Mp_2_39_12 hv_L1_39 gp_2_39_12 colp_L2_39 0 NSYN W=10u L=1u
Mn_2_39_12 hv_L1_39 vcn coln_L2_39 0 NSYN W=10u L=1u
C_gp_2_39_13 gp_2_39_13 0 {Cg}
Mp_2_39_13 hv_L1_41 gp_2_39_13 colp_L2_39 0 NSYN W=10u L=1u
Mn_2_39_13 hv_L1_41 vcn coln_L2_39 0 NSYN W=10u L=1u
C_gp_2_39_14 gp_2_39_14 0 {Cg}
Mp_2_39_14 hv_L1_44 gp_2_39_14 colp_L2_39 0 NSYN W=10u L=1u
Mn_2_39_14 hv_L1_44 vcn coln_L2_39 0 NSYN W=10u L=1u
C_gp_2_39_15 gp_2_39_15 0 {Cg}
Mp_2_39_15 hv_L1_45 gp_2_39_15 colp_L2_39 0 NSYN W=10u L=1u
Mn_2_39_15 hv_L1_45 vcn coln_L2_39 0 NSYN W=10u L=1u
C_gp_2_39_b gp_2_39_b 0 {Cg}
Mp_2_39_b bx gp_2_39_b colp_L2_39 0 NSYN W=10u L=1u
Mn_2_39_b bx vcn coln_L2_39 0 NSYN W=10u L=1u
Msa_h_L2_39 coln_L2_39 coln_L2_39 0 0 NMIR W=20u L=1u
Msb_h_L2_39 z_L2_39 coln_L2_39 0 0 NMIR W=20u L=1u
Msc_h_L2_39 colp_L2_39 colp_L2_39 0 0 NMIR W=20u L=1u
Msd_h_L2_39 dpf_h_L2_39 colp_L2_39 0 0 NMIR W=20u L=1u
Mse_h_L2_39 dpf_h_L2_39 dpf_h_L2_39 vdd vdd PMIR W=60u L=1u
Msf_h_L2_39 z_L2_39 dpf_h_L2_39 vdd vdd PMIR W=60u L=1u
R_h_L2_39 z_L2_39 vrefh 8000.0
Mr_L2_39  hdd_L2_39 z_L2_39 tail_L2_39 0 NREL W=12u L=1u
Mr2_L2_39 dmp_L2_39  vmid  tail_L2_39 0 NREL W=12u L=1u
Mtl_L2_39 tail_L2_39 vtb 0 0 NREL W=32.0u L=1u
Mdm_L2_39 dmp_L2_39 dmp_L2_39 vdd vdd PMIR W=40u L=1u
Mrp1_L2_39 hdd_L2_39 hdd_L2_39 vdd vdd PMIR W=40u L=1u
Mrp2_L2_39 hv_L2_39 hdd_L2_39 vdd vdd PMIR W=40u L=1u
Rhv_L2_39 hv_L2_39 vg0 8000.0
C_gp_2_40_0 gp_2_40_0 0 {Cg}
Mp_2_40_0 hv_L1_0 gp_2_40_0 colp_L2_40 0 NSYN W=10u L=1u
Mn_2_40_0 hv_L1_0 vcn coln_L2_40 0 NSYN W=10u L=1u
C_gp_2_40_1 gp_2_40_1 0 {Cg}
Mp_2_40_1 hv_L1_6 gp_2_40_1 colp_L2_40 0 NSYN W=10u L=1u
Mn_2_40_1 hv_L1_6 vcn coln_L2_40 0 NSYN W=10u L=1u
C_gp_2_40_2 gp_2_40_2 0 {Cg}
Mp_2_40_2 hv_L1_7 gp_2_40_2 colp_L2_40 0 NSYN W=10u L=1u
Mn_2_40_2 hv_L1_7 vcn coln_L2_40 0 NSYN W=10u L=1u
C_gp_2_40_3 gp_2_40_3 0 {Cg}
Mp_2_40_3 hv_L1_10 gp_2_40_3 colp_L2_40 0 NSYN W=10u L=1u
Mn_2_40_3 hv_L1_10 vcn coln_L2_40 0 NSYN W=10u L=1u
C_gp_2_40_4 gp_2_40_4 0 {Cg}
Mp_2_40_4 hv_L1_16 gp_2_40_4 colp_L2_40 0 NSYN W=10u L=1u
Mn_2_40_4 hv_L1_16 vcn coln_L2_40 0 NSYN W=10u L=1u
C_gp_2_40_5 gp_2_40_5 0 {Cg}
Mp_2_40_5 hv_L1_20 gp_2_40_5 colp_L2_40 0 NSYN W=10u L=1u
Mn_2_40_5 hv_L1_20 vcn coln_L2_40 0 NSYN W=10u L=1u
C_gp_2_40_6 gp_2_40_6 0 {Cg}
Mp_2_40_6 hv_L1_21 gp_2_40_6 colp_L2_40 0 NSYN W=10u L=1u
Mn_2_40_6 hv_L1_21 vcn coln_L2_40 0 NSYN W=10u L=1u
C_gp_2_40_7 gp_2_40_7 0 {Cg}
Mp_2_40_7 hv_L1_22 gp_2_40_7 colp_L2_40 0 NSYN W=10u L=1u
Mn_2_40_7 hv_L1_22 vcn coln_L2_40 0 NSYN W=10u L=1u
C_gp_2_40_8 gp_2_40_8 0 {Cg}
Mp_2_40_8 hv_L1_23 gp_2_40_8 colp_L2_40 0 NSYN W=10u L=1u
Mn_2_40_8 hv_L1_23 vcn coln_L2_40 0 NSYN W=10u L=1u
C_gp_2_40_9 gp_2_40_9 0 {Cg}
Mp_2_40_9 hv_L1_26 gp_2_40_9 colp_L2_40 0 NSYN W=10u L=1u
Mn_2_40_9 hv_L1_26 vcn coln_L2_40 0 NSYN W=10u L=1u
C_gp_2_40_10 gp_2_40_10 0 {Cg}
Mp_2_40_10 hv_L1_34 gp_2_40_10 colp_L2_40 0 NSYN W=10u L=1u
Mn_2_40_10 hv_L1_34 vcn coln_L2_40 0 NSYN W=10u L=1u
C_gp_2_40_11 gp_2_40_11 0 {Cg}
Mp_2_40_11 hv_L1_37 gp_2_40_11 colp_L2_40 0 NSYN W=10u L=1u
Mn_2_40_11 hv_L1_37 vcn coln_L2_40 0 NSYN W=10u L=1u
C_gp_2_40_12 gp_2_40_12 0 {Cg}
Mp_2_40_12 hv_L1_38 gp_2_40_12 colp_L2_40 0 NSYN W=10u L=1u
Mn_2_40_12 hv_L1_38 vcn coln_L2_40 0 NSYN W=10u L=1u
C_gp_2_40_13 gp_2_40_13 0 {Cg}
Mp_2_40_13 hv_L1_41 gp_2_40_13 colp_L2_40 0 NSYN W=10u L=1u
Mn_2_40_13 hv_L1_41 vcn coln_L2_40 0 NSYN W=10u L=1u
C_gp_2_40_14 gp_2_40_14 0 {Cg}
Mp_2_40_14 hv_L1_44 gp_2_40_14 colp_L2_40 0 NSYN W=10u L=1u
Mn_2_40_14 hv_L1_44 vcn coln_L2_40 0 NSYN W=10u L=1u
C_gp_2_40_15 gp_2_40_15 0 {Cg}
Mp_2_40_15 hv_L1_46 gp_2_40_15 colp_L2_40 0 NSYN W=10u L=1u
Mn_2_40_15 hv_L1_46 vcn coln_L2_40 0 NSYN W=10u L=1u
C_gp_2_40_b gp_2_40_b 0 {Cg}
Mp_2_40_b bx gp_2_40_b colp_L2_40 0 NSYN W=10u L=1u
Mn_2_40_b bx vcn coln_L2_40 0 NSYN W=10u L=1u
Msa_h_L2_40 coln_L2_40 coln_L2_40 0 0 NMIR W=20u L=1u
Msb_h_L2_40 z_L2_40 coln_L2_40 0 0 NMIR W=20u L=1u
Msc_h_L2_40 colp_L2_40 colp_L2_40 0 0 NMIR W=20u L=1u
Msd_h_L2_40 dpf_h_L2_40 colp_L2_40 0 0 NMIR W=20u L=1u
Mse_h_L2_40 dpf_h_L2_40 dpf_h_L2_40 vdd vdd PMIR W=60u L=1u
Msf_h_L2_40 z_L2_40 dpf_h_L2_40 vdd vdd PMIR W=60u L=1u
R_h_L2_40 z_L2_40 vrefh 8000.0
Mr_L2_40  hdd_L2_40 z_L2_40 tail_L2_40 0 NREL W=12u L=1u
Mr2_L2_40 dmp_L2_40  vmid  tail_L2_40 0 NREL W=12u L=1u
Mtl_L2_40 tail_L2_40 vtb 0 0 NREL W=32.0u L=1u
Mdm_L2_40 dmp_L2_40 dmp_L2_40 vdd vdd PMIR W=40u L=1u
Mrp1_L2_40 hdd_L2_40 hdd_L2_40 vdd vdd PMIR W=40u L=1u
Mrp2_L2_40 hv_L2_40 hdd_L2_40 vdd vdd PMIR W=40u L=1u
Rhv_L2_40 hv_L2_40 vg0 8000.0
C_gp_2_41_0 gp_2_41_0 0 {Cg}
Mp_2_41_0 hv_L1_0 gp_2_41_0 colp_L2_41 0 NSYN W=10u L=1u
Mn_2_41_0 hv_L1_0 vcn coln_L2_41 0 NSYN W=10u L=1u
C_gp_2_41_1 gp_2_41_1 0 {Cg}
Mp_2_41_1 hv_L1_2 gp_2_41_1 colp_L2_41 0 NSYN W=10u L=1u
Mn_2_41_1 hv_L1_2 vcn coln_L2_41 0 NSYN W=10u L=1u
C_gp_2_41_2 gp_2_41_2 0 {Cg}
Mp_2_41_2 hv_L1_3 gp_2_41_2 colp_L2_41 0 NSYN W=10u L=1u
Mn_2_41_2 hv_L1_3 vcn coln_L2_41 0 NSYN W=10u L=1u
C_gp_2_41_3 gp_2_41_3 0 {Cg}
Mp_2_41_3 hv_L1_9 gp_2_41_3 colp_L2_41 0 NSYN W=10u L=1u
Mn_2_41_3 hv_L1_9 vcn coln_L2_41 0 NSYN W=10u L=1u
C_gp_2_41_4 gp_2_41_4 0 {Cg}
Mp_2_41_4 hv_L1_16 gp_2_41_4 colp_L2_41 0 NSYN W=10u L=1u
Mn_2_41_4 hv_L1_16 vcn coln_L2_41 0 NSYN W=10u L=1u
C_gp_2_41_5 gp_2_41_5 0 {Cg}
Mp_2_41_5 hv_L1_17 gp_2_41_5 colp_L2_41 0 NSYN W=10u L=1u
Mn_2_41_5 hv_L1_17 vcn coln_L2_41 0 NSYN W=10u L=1u
C_gp_2_41_6 gp_2_41_6 0 {Cg}
Mp_2_41_6 hv_L1_19 gp_2_41_6 colp_L2_41 0 NSYN W=10u L=1u
Mn_2_41_6 hv_L1_19 vcn coln_L2_41 0 NSYN W=10u L=1u
C_gp_2_41_7 gp_2_41_7 0 {Cg}
Mp_2_41_7 hv_L1_20 gp_2_41_7 colp_L2_41 0 NSYN W=10u L=1u
Mn_2_41_7 hv_L1_20 vcn coln_L2_41 0 NSYN W=10u L=1u
C_gp_2_41_8 gp_2_41_8 0 {Cg}
Mp_2_41_8 hv_L1_21 gp_2_41_8 colp_L2_41 0 NSYN W=10u L=1u
Mn_2_41_8 hv_L1_21 vcn coln_L2_41 0 NSYN W=10u L=1u
C_gp_2_41_9 gp_2_41_9 0 {Cg}
Mp_2_41_9 hv_L1_22 gp_2_41_9 colp_L2_41 0 NSYN W=10u L=1u
Mn_2_41_9 hv_L1_22 vcn coln_L2_41 0 NSYN W=10u L=1u
C_gp_2_41_10 gp_2_41_10 0 {Cg}
Mp_2_41_10 hv_L1_23 gp_2_41_10 colp_L2_41 0 NSYN W=10u L=1u
Mn_2_41_10 hv_L1_23 vcn coln_L2_41 0 NSYN W=10u L=1u
C_gp_2_41_11 gp_2_41_11 0 {Cg}
Mp_2_41_11 hv_L1_36 gp_2_41_11 colp_L2_41 0 NSYN W=10u L=1u
Mn_2_41_11 hv_L1_36 vcn coln_L2_41 0 NSYN W=10u L=1u
C_gp_2_41_12 gp_2_41_12 0 {Cg}
Mp_2_41_12 hv_L1_41 gp_2_41_12 colp_L2_41 0 NSYN W=10u L=1u
Mn_2_41_12 hv_L1_41 vcn coln_L2_41 0 NSYN W=10u L=1u
C_gp_2_41_13 gp_2_41_13 0 {Cg}
Mp_2_41_13 hv_L1_44 gp_2_41_13 colp_L2_41 0 NSYN W=10u L=1u
Mn_2_41_13 hv_L1_44 vcn coln_L2_41 0 NSYN W=10u L=1u
C_gp_2_41_14 gp_2_41_14 0 {Cg}
Mp_2_41_14 hv_L1_45 gp_2_41_14 colp_L2_41 0 NSYN W=10u L=1u
Mn_2_41_14 hv_L1_45 vcn coln_L2_41 0 NSYN W=10u L=1u
C_gp_2_41_15 gp_2_41_15 0 {Cg}
Mp_2_41_15 hv_L1_46 gp_2_41_15 colp_L2_41 0 NSYN W=10u L=1u
Mn_2_41_15 hv_L1_46 vcn coln_L2_41 0 NSYN W=10u L=1u
C_gp_2_41_b gp_2_41_b 0 {Cg}
Mp_2_41_b bx gp_2_41_b colp_L2_41 0 NSYN W=10u L=1u
Mn_2_41_b bx vcn coln_L2_41 0 NSYN W=10u L=1u
Msa_h_L2_41 coln_L2_41 coln_L2_41 0 0 NMIR W=20u L=1u
Msb_h_L2_41 z_L2_41 coln_L2_41 0 0 NMIR W=20u L=1u
Msc_h_L2_41 colp_L2_41 colp_L2_41 0 0 NMIR W=20u L=1u
Msd_h_L2_41 dpf_h_L2_41 colp_L2_41 0 0 NMIR W=20u L=1u
Mse_h_L2_41 dpf_h_L2_41 dpf_h_L2_41 vdd vdd PMIR W=60u L=1u
Msf_h_L2_41 z_L2_41 dpf_h_L2_41 vdd vdd PMIR W=60u L=1u
R_h_L2_41 z_L2_41 vrefh 8000.0
Mr_L2_41  hdd_L2_41 z_L2_41 tail_L2_41 0 NREL W=12u L=1u
Mr2_L2_41 dmp_L2_41  vmid  tail_L2_41 0 NREL W=12u L=1u
Mtl_L2_41 tail_L2_41 vtb 0 0 NREL W=32.0u L=1u
Mdm_L2_41 dmp_L2_41 dmp_L2_41 vdd vdd PMIR W=40u L=1u
Mrp1_L2_41 hdd_L2_41 hdd_L2_41 vdd vdd PMIR W=40u L=1u
Mrp2_L2_41 hv_L2_41 hdd_L2_41 vdd vdd PMIR W=40u L=1u
Rhv_L2_41 hv_L2_41 vg0 8000.0
C_gp_2_42_0 gp_2_42_0 0 {Cg}
Mp_2_42_0 hv_L1_1 gp_2_42_0 colp_L2_42 0 NSYN W=10u L=1u
Mn_2_42_0 hv_L1_1 vcn coln_L2_42 0 NSYN W=10u L=1u
C_gp_2_42_1 gp_2_42_1 0 {Cg}
Mp_2_42_1 hv_L1_2 gp_2_42_1 colp_L2_42 0 NSYN W=10u L=1u
Mn_2_42_1 hv_L1_2 vcn coln_L2_42 0 NSYN W=10u L=1u
C_gp_2_42_2 gp_2_42_2 0 {Cg}
Mp_2_42_2 hv_L1_6 gp_2_42_2 colp_L2_42 0 NSYN W=10u L=1u
Mn_2_42_2 hv_L1_6 vcn coln_L2_42 0 NSYN W=10u L=1u
C_gp_2_42_3 gp_2_42_3 0 {Cg}
Mp_2_42_3 hv_L1_8 gp_2_42_3 colp_L2_42 0 NSYN W=10u L=1u
Mn_2_42_3 hv_L1_8 vcn coln_L2_42 0 NSYN W=10u L=1u
C_gp_2_42_4 gp_2_42_4 0 {Cg}
Mp_2_42_4 hv_L1_12 gp_2_42_4 colp_L2_42 0 NSYN W=10u L=1u
Mn_2_42_4 hv_L1_12 vcn coln_L2_42 0 NSYN W=10u L=1u
C_gp_2_42_5 gp_2_42_5 0 {Cg}
Mp_2_42_5 hv_L1_13 gp_2_42_5 colp_L2_42 0 NSYN W=10u L=1u
Mn_2_42_5 hv_L1_13 vcn coln_L2_42 0 NSYN W=10u L=1u
C_gp_2_42_6 gp_2_42_6 0 {Cg}
Mp_2_42_6 hv_L1_15 gp_2_42_6 colp_L2_42 0 NSYN W=10u L=1u
Mn_2_42_6 hv_L1_15 vcn coln_L2_42 0 NSYN W=10u L=1u
C_gp_2_42_7 gp_2_42_7 0 {Cg}
Mp_2_42_7 hv_L1_21 gp_2_42_7 colp_L2_42 0 NSYN W=10u L=1u
Mn_2_42_7 hv_L1_21 vcn coln_L2_42 0 NSYN W=10u L=1u
C_gp_2_42_8 gp_2_42_8 0 {Cg}
Mp_2_42_8 hv_L1_22 gp_2_42_8 colp_L2_42 0 NSYN W=10u L=1u
Mn_2_42_8 hv_L1_22 vcn coln_L2_42 0 NSYN W=10u L=1u
C_gp_2_42_9 gp_2_42_9 0 {Cg}
Mp_2_42_9 hv_L1_32 gp_2_42_9 colp_L2_42 0 NSYN W=10u L=1u
Mn_2_42_9 hv_L1_32 vcn coln_L2_42 0 NSYN W=10u L=1u
C_gp_2_42_10 gp_2_42_10 0 {Cg}
Mp_2_42_10 hv_L1_34 gp_2_42_10 colp_L2_42 0 NSYN W=10u L=1u
Mn_2_42_10 hv_L1_34 vcn coln_L2_42 0 NSYN W=10u L=1u
C_gp_2_42_11 gp_2_42_11 0 {Cg}
Mp_2_42_11 hv_L1_35 gp_2_42_11 colp_L2_42 0 NSYN W=10u L=1u
Mn_2_42_11 hv_L1_35 vcn coln_L2_42 0 NSYN W=10u L=1u
C_gp_2_42_12 gp_2_42_12 0 {Cg}
Mp_2_42_12 hv_L1_38 gp_2_42_12 colp_L2_42 0 NSYN W=10u L=1u
Mn_2_42_12 hv_L1_38 vcn coln_L2_42 0 NSYN W=10u L=1u
C_gp_2_42_13 gp_2_42_13 0 {Cg}
Mp_2_42_13 hv_L1_40 gp_2_42_13 colp_L2_42 0 NSYN W=10u L=1u
Mn_2_42_13 hv_L1_40 vcn coln_L2_42 0 NSYN W=10u L=1u
C_gp_2_42_14 gp_2_42_14 0 {Cg}
Mp_2_42_14 hv_L1_43 gp_2_42_14 colp_L2_42 0 NSYN W=10u L=1u
Mn_2_42_14 hv_L1_43 vcn coln_L2_42 0 NSYN W=10u L=1u
C_gp_2_42_15 gp_2_42_15 0 {Cg}
Mp_2_42_15 hv_L1_44 gp_2_42_15 colp_L2_42 0 NSYN W=10u L=1u
Mn_2_42_15 hv_L1_44 vcn coln_L2_42 0 NSYN W=10u L=1u
C_gp_2_42_b gp_2_42_b 0 {Cg}
Mp_2_42_b bx gp_2_42_b colp_L2_42 0 NSYN W=10u L=1u
Mn_2_42_b bx vcn coln_L2_42 0 NSYN W=10u L=1u
Msa_h_L2_42 coln_L2_42 coln_L2_42 0 0 NMIR W=20u L=1u
Msb_h_L2_42 z_L2_42 coln_L2_42 0 0 NMIR W=20u L=1u
Msc_h_L2_42 colp_L2_42 colp_L2_42 0 0 NMIR W=20u L=1u
Msd_h_L2_42 dpf_h_L2_42 colp_L2_42 0 0 NMIR W=20u L=1u
Mse_h_L2_42 dpf_h_L2_42 dpf_h_L2_42 vdd vdd PMIR W=60u L=1u
Msf_h_L2_42 z_L2_42 dpf_h_L2_42 vdd vdd PMIR W=60u L=1u
R_h_L2_42 z_L2_42 vrefh 8000.0
Mr_L2_42  hdd_L2_42 z_L2_42 tail_L2_42 0 NREL W=12u L=1u
Mr2_L2_42 dmp_L2_42  vmid  tail_L2_42 0 NREL W=12u L=1u
Mtl_L2_42 tail_L2_42 vtb 0 0 NREL W=32.0u L=1u
Mdm_L2_42 dmp_L2_42 dmp_L2_42 vdd vdd PMIR W=40u L=1u
Mrp1_L2_42 hdd_L2_42 hdd_L2_42 vdd vdd PMIR W=40u L=1u
Mrp2_L2_42 hv_L2_42 hdd_L2_42 vdd vdd PMIR W=40u L=1u
Rhv_L2_42 hv_L2_42 vg0 8000.0
C_gp_2_43_0 gp_2_43_0 0 {Cg}
Mp_2_43_0 hv_L1_2 gp_2_43_0 colp_L2_43 0 NSYN W=10u L=1u
Mn_2_43_0 hv_L1_2 vcn coln_L2_43 0 NSYN W=10u L=1u
C_gp_2_43_1 gp_2_43_1 0 {Cg}
Mp_2_43_1 hv_L1_5 gp_2_43_1 colp_L2_43 0 NSYN W=10u L=1u
Mn_2_43_1 hv_L1_5 vcn coln_L2_43 0 NSYN W=10u L=1u
C_gp_2_43_2 gp_2_43_2 0 {Cg}
Mp_2_43_2 hv_L1_7 gp_2_43_2 colp_L2_43 0 NSYN W=10u L=1u
Mn_2_43_2 hv_L1_7 vcn coln_L2_43 0 NSYN W=10u L=1u
C_gp_2_43_3 gp_2_43_3 0 {Cg}
Mp_2_43_3 hv_L1_8 gp_2_43_3 colp_L2_43 0 NSYN W=10u L=1u
Mn_2_43_3 hv_L1_8 vcn coln_L2_43 0 NSYN W=10u L=1u
C_gp_2_43_4 gp_2_43_4 0 {Cg}
Mp_2_43_4 hv_L1_11 gp_2_43_4 colp_L2_43 0 NSYN W=10u L=1u
Mn_2_43_4 hv_L1_11 vcn coln_L2_43 0 NSYN W=10u L=1u
C_gp_2_43_5 gp_2_43_5 0 {Cg}
Mp_2_43_5 hv_L1_12 gp_2_43_5 colp_L2_43 0 NSYN W=10u L=1u
Mn_2_43_5 hv_L1_12 vcn coln_L2_43 0 NSYN W=10u L=1u
C_gp_2_43_6 gp_2_43_6 0 {Cg}
Mp_2_43_6 hv_L1_15 gp_2_43_6 colp_L2_43 0 NSYN W=10u L=1u
Mn_2_43_6 hv_L1_15 vcn coln_L2_43 0 NSYN W=10u L=1u
C_gp_2_43_7 gp_2_43_7 0 {Cg}
Mp_2_43_7 hv_L1_18 gp_2_43_7 colp_L2_43 0 NSYN W=10u L=1u
Mn_2_43_7 hv_L1_18 vcn coln_L2_43 0 NSYN W=10u L=1u
C_gp_2_43_8 gp_2_43_8 0 {Cg}
Mp_2_43_8 hv_L1_23 gp_2_43_8 colp_L2_43 0 NSYN W=10u L=1u
Mn_2_43_8 hv_L1_23 vcn coln_L2_43 0 NSYN W=10u L=1u
C_gp_2_43_9 gp_2_43_9 0 {Cg}
Mp_2_43_9 hv_L1_27 gp_2_43_9 colp_L2_43 0 NSYN W=10u L=1u
Mn_2_43_9 hv_L1_27 vcn coln_L2_43 0 NSYN W=10u L=1u
C_gp_2_43_10 gp_2_43_10 0 {Cg}
Mp_2_43_10 hv_L1_31 gp_2_43_10 colp_L2_43 0 NSYN W=10u L=1u
Mn_2_43_10 hv_L1_31 vcn coln_L2_43 0 NSYN W=10u L=1u
C_gp_2_43_11 gp_2_43_11 0 {Cg}
Mp_2_43_11 hv_L1_32 gp_2_43_11 colp_L2_43 0 NSYN W=10u L=1u
Mn_2_43_11 hv_L1_32 vcn coln_L2_43 0 NSYN W=10u L=1u
C_gp_2_43_12 gp_2_43_12 0 {Cg}
Mp_2_43_12 hv_L1_37 gp_2_43_12 colp_L2_43 0 NSYN W=10u L=1u
Mn_2_43_12 hv_L1_37 vcn coln_L2_43 0 NSYN W=10u L=1u
C_gp_2_43_13 gp_2_43_13 0 {Cg}
Mp_2_43_13 hv_L1_38 gp_2_43_13 colp_L2_43 0 NSYN W=10u L=1u
Mn_2_43_13 hv_L1_38 vcn coln_L2_43 0 NSYN W=10u L=1u
C_gp_2_43_14 gp_2_43_14 0 {Cg}
Mp_2_43_14 hv_L1_39 gp_2_43_14 colp_L2_43 0 NSYN W=10u L=1u
Mn_2_43_14 hv_L1_39 vcn coln_L2_43 0 NSYN W=10u L=1u
C_gp_2_43_15 gp_2_43_15 0 {Cg}
Mp_2_43_15 hv_L1_47 gp_2_43_15 colp_L2_43 0 NSYN W=10u L=1u
Mn_2_43_15 hv_L1_47 vcn coln_L2_43 0 NSYN W=10u L=1u
C_gp_2_43_b gp_2_43_b 0 {Cg}
Mp_2_43_b bx gp_2_43_b colp_L2_43 0 NSYN W=10u L=1u
Mn_2_43_b bx vcn coln_L2_43 0 NSYN W=10u L=1u
Msa_h_L2_43 coln_L2_43 coln_L2_43 0 0 NMIR W=20u L=1u
Msb_h_L2_43 z_L2_43 coln_L2_43 0 0 NMIR W=20u L=1u
Msc_h_L2_43 colp_L2_43 colp_L2_43 0 0 NMIR W=20u L=1u
Msd_h_L2_43 dpf_h_L2_43 colp_L2_43 0 0 NMIR W=20u L=1u
Mse_h_L2_43 dpf_h_L2_43 dpf_h_L2_43 vdd vdd PMIR W=60u L=1u
Msf_h_L2_43 z_L2_43 dpf_h_L2_43 vdd vdd PMIR W=60u L=1u
R_h_L2_43 z_L2_43 vrefh 8000.0
Mr_L2_43  hdd_L2_43 z_L2_43 tail_L2_43 0 NREL W=12u L=1u
Mr2_L2_43 dmp_L2_43  vmid  tail_L2_43 0 NREL W=12u L=1u
Mtl_L2_43 tail_L2_43 vtb 0 0 NREL W=32.0u L=1u
Mdm_L2_43 dmp_L2_43 dmp_L2_43 vdd vdd PMIR W=40u L=1u
Mrp1_L2_43 hdd_L2_43 hdd_L2_43 vdd vdd PMIR W=40u L=1u
Mrp2_L2_43 hv_L2_43 hdd_L2_43 vdd vdd PMIR W=40u L=1u
Rhv_L2_43 hv_L2_43 vg0 8000.0
C_gp_2_44_0 gp_2_44_0 0 {Cg}
Mp_2_44_0 hv_L1_2 gp_2_44_0 colp_L2_44 0 NSYN W=10u L=1u
Mn_2_44_0 hv_L1_2 vcn coln_L2_44 0 NSYN W=10u L=1u
C_gp_2_44_1 gp_2_44_1 0 {Cg}
Mp_2_44_1 hv_L1_3 gp_2_44_1 colp_L2_44 0 NSYN W=10u L=1u
Mn_2_44_1 hv_L1_3 vcn coln_L2_44 0 NSYN W=10u L=1u
C_gp_2_44_2 gp_2_44_2 0 {Cg}
Mp_2_44_2 hv_L1_9 gp_2_44_2 colp_L2_44 0 NSYN W=10u L=1u
Mn_2_44_2 hv_L1_9 vcn coln_L2_44 0 NSYN W=10u L=1u
C_gp_2_44_3 gp_2_44_3 0 {Cg}
Mp_2_44_3 hv_L1_14 gp_2_44_3 colp_L2_44 0 NSYN W=10u L=1u
Mn_2_44_3 hv_L1_14 vcn coln_L2_44 0 NSYN W=10u L=1u
C_gp_2_44_4 gp_2_44_4 0 {Cg}
Mp_2_44_4 hv_L1_15 gp_2_44_4 colp_L2_44 0 NSYN W=10u L=1u
Mn_2_44_4 hv_L1_15 vcn coln_L2_44 0 NSYN W=10u L=1u
C_gp_2_44_5 gp_2_44_5 0 {Cg}
Mp_2_44_5 hv_L1_16 gp_2_44_5 colp_L2_44 0 NSYN W=10u L=1u
Mn_2_44_5 hv_L1_16 vcn coln_L2_44 0 NSYN W=10u L=1u
C_gp_2_44_6 gp_2_44_6 0 {Cg}
Mp_2_44_6 hv_L1_18 gp_2_44_6 colp_L2_44 0 NSYN W=10u L=1u
Mn_2_44_6 hv_L1_18 vcn coln_L2_44 0 NSYN W=10u L=1u
C_gp_2_44_7 gp_2_44_7 0 {Cg}
Mp_2_44_7 hv_L1_20 gp_2_44_7 colp_L2_44 0 NSYN W=10u L=1u
Mn_2_44_7 hv_L1_20 vcn coln_L2_44 0 NSYN W=10u L=1u
C_gp_2_44_8 gp_2_44_8 0 {Cg}
Mp_2_44_8 hv_L1_21 gp_2_44_8 colp_L2_44 0 NSYN W=10u L=1u
Mn_2_44_8 hv_L1_21 vcn coln_L2_44 0 NSYN W=10u L=1u
C_gp_2_44_9 gp_2_44_9 0 {Cg}
Mp_2_44_9 hv_L1_22 gp_2_44_9 colp_L2_44 0 NSYN W=10u L=1u
Mn_2_44_9 hv_L1_22 vcn coln_L2_44 0 NSYN W=10u L=1u
C_gp_2_44_10 gp_2_44_10 0 {Cg}
Mp_2_44_10 hv_L1_25 gp_2_44_10 colp_L2_44 0 NSYN W=10u L=1u
Mn_2_44_10 hv_L1_25 vcn coln_L2_44 0 NSYN W=10u L=1u
C_gp_2_44_11 gp_2_44_11 0 {Cg}
Mp_2_44_11 hv_L1_28 gp_2_44_11 colp_L2_44 0 NSYN W=10u L=1u
Mn_2_44_11 hv_L1_28 vcn coln_L2_44 0 NSYN W=10u L=1u
C_gp_2_44_12 gp_2_44_12 0 {Cg}
Mp_2_44_12 hv_L1_36 gp_2_44_12 colp_L2_44 0 NSYN W=10u L=1u
Mn_2_44_12 hv_L1_36 vcn coln_L2_44 0 NSYN W=10u L=1u
C_gp_2_44_13 gp_2_44_13 0 {Cg}
Mp_2_44_13 hv_L1_38 gp_2_44_13 colp_L2_44 0 NSYN W=10u L=1u
Mn_2_44_13 hv_L1_38 vcn coln_L2_44 0 NSYN W=10u L=1u
C_gp_2_44_14 gp_2_44_14 0 {Cg}
Mp_2_44_14 hv_L1_39 gp_2_44_14 colp_L2_44 0 NSYN W=10u L=1u
Mn_2_44_14 hv_L1_39 vcn coln_L2_44 0 NSYN W=10u L=1u
C_gp_2_44_15 gp_2_44_15 0 {Cg}
Mp_2_44_15 hv_L1_47 gp_2_44_15 colp_L2_44 0 NSYN W=10u L=1u
Mn_2_44_15 hv_L1_47 vcn coln_L2_44 0 NSYN W=10u L=1u
C_gp_2_44_b gp_2_44_b 0 {Cg}
Mp_2_44_b bx gp_2_44_b colp_L2_44 0 NSYN W=10u L=1u
Mn_2_44_b bx vcn coln_L2_44 0 NSYN W=10u L=1u
Msa_h_L2_44 coln_L2_44 coln_L2_44 0 0 NMIR W=20u L=1u
Msb_h_L2_44 z_L2_44 coln_L2_44 0 0 NMIR W=20u L=1u
Msc_h_L2_44 colp_L2_44 colp_L2_44 0 0 NMIR W=20u L=1u
Msd_h_L2_44 dpf_h_L2_44 colp_L2_44 0 0 NMIR W=20u L=1u
Mse_h_L2_44 dpf_h_L2_44 dpf_h_L2_44 vdd vdd PMIR W=60u L=1u
Msf_h_L2_44 z_L2_44 dpf_h_L2_44 vdd vdd PMIR W=60u L=1u
R_h_L2_44 z_L2_44 vrefh 8000.0
Mr_L2_44  hdd_L2_44 z_L2_44 tail_L2_44 0 NREL W=12u L=1u
Mr2_L2_44 dmp_L2_44  vmid  tail_L2_44 0 NREL W=12u L=1u
Mtl_L2_44 tail_L2_44 vtb 0 0 NREL W=32.0u L=1u
Mdm_L2_44 dmp_L2_44 dmp_L2_44 vdd vdd PMIR W=40u L=1u
Mrp1_L2_44 hdd_L2_44 hdd_L2_44 vdd vdd PMIR W=40u L=1u
Mrp2_L2_44 hv_L2_44 hdd_L2_44 vdd vdd PMIR W=40u L=1u
Rhv_L2_44 hv_L2_44 vg0 8000.0
C_gp_2_45_0 gp_2_45_0 0 {Cg}
Mp_2_45_0 hv_L1_2 gp_2_45_0 colp_L2_45 0 NSYN W=10u L=1u
Mn_2_45_0 hv_L1_2 vcn coln_L2_45 0 NSYN W=10u L=1u
C_gp_2_45_1 gp_2_45_1 0 {Cg}
Mp_2_45_1 hv_L1_7 gp_2_45_1 colp_L2_45 0 NSYN W=10u L=1u
Mn_2_45_1 hv_L1_7 vcn coln_L2_45 0 NSYN W=10u L=1u
C_gp_2_45_2 gp_2_45_2 0 {Cg}
Mp_2_45_2 hv_L1_10 gp_2_45_2 colp_L2_45 0 NSYN W=10u L=1u
Mn_2_45_2 hv_L1_10 vcn coln_L2_45 0 NSYN W=10u L=1u
C_gp_2_45_3 gp_2_45_3 0 {Cg}
Mp_2_45_3 hv_L1_11 gp_2_45_3 colp_L2_45 0 NSYN W=10u L=1u
Mn_2_45_3 hv_L1_11 vcn coln_L2_45 0 NSYN W=10u L=1u
C_gp_2_45_4 gp_2_45_4 0 {Cg}
Mp_2_45_4 hv_L1_12 gp_2_45_4 colp_L2_45 0 NSYN W=10u L=1u
Mn_2_45_4 hv_L1_12 vcn coln_L2_45 0 NSYN W=10u L=1u
C_gp_2_45_5 gp_2_45_5 0 {Cg}
Mp_2_45_5 hv_L1_13 gp_2_45_5 colp_L2_45 0 NSYN W=10u L=1u
Mn_2_45_5 hv_L1_13 vcn coln_L2_45 0 NSYN W=10u L=1u
C_gp_2_45_6 gp_2_45_6 0 {Cg}
Mp_2_45_6 hv_L1_14 gp_2_45_6 colp_L2_45 0 NSYN W=10u L=1u
Mn_2_45_6 hv_L1_14 vcn coln_L2_45 0 NSYN W=10u L=1u
C_gp_2_45_7 gp_2_45_7 0 {Cg}
Mp_2_45_7 hv_L1_19 gp_2_45_7 colp_L2_45 0 NSYN W=10u L=1u
Mn_2_45_7 hv_L1_19 vcn coln_L2_45 0 NSYN W=10u L=1u
C_gp_2_45_8 gp_2_45_8 0 {Cg}
Mp_2_45_8 hv_L1_26 gp_2_45_8 colp_L2_45 0 NSYN W=10u L=1u
Mn_2_45_8 hv_L1_26 vcn coln_L2_45 0 NSYN W=10u L=1u
C_gp_2_45_9 gp_2_45_9 0 {Cg}
Mp_2_45_9 hv_L1_32 gp_2_45_9 colp_L2_45 0 NSYN W=10u L=1u
Mn_2_45_9 hv_L1_32 vcn coln_L2_45 0 NSYN W=10u L=1u
C_gp_2_45_10 gp_2_45_10 0 {Cg}
Mp_2_45_10 hv_L1_33 gp_2_45_10 colp_L2_45 0 NSYN W=10u L=1u
Mn_2_45_10 hv_L1_33 vcn coln_L2_45 0 NSYN W=10u L=1u
C_gp_2_45_11 gp_2_45_11 0 {Cg}
Mp_2_45_11 hv_L1_34 gp_2_45_11 colp_L2_45 0 NSYN W=10u L=1u
Mn_2_45_11 hv_L1_34 vcn coln_L2_45 0 NSYN W=10u L=1u
C_gp_2_45_12 gp_2_45_12 0 {Cg}
Mp_2_45_12 hv_L1_37 gp_2_45_12 colp_L2_45 0 NSYN W=10u L=1u
Mn_2_45_12 hv_L1_37 vcn coln_L2_45 0 NSYN W=10u L=1u
C_gp_2_45_13 gp_2_45_13 0 {Cg}
Mp_2_45_13 hv_L1_40 gp_2_45_13 colp_L2_45 0 NSYN W=10u L=1u
Mn_2_45_13 hv_L1_40 vcn coln_L2_45 0 NSYN W=10u L=1u
C_gp_2_45_14 gp_2_45_14 0 {Cg}
Mp_2_45_14 hv_L1_41 gp_2_45_14 colp_L2_45 0 NSYN W=10u L=1u
Mn_2_45_14 hv_L1_41 vcn coln_L2_45 0 NSYN W=10u L=1u
C_gp_2_45_15 gp_2_45_15 0 {Cg}
Mp_2_45_15 hv_L1_47 gp_2_45_15 colp_L2_45 0 NSYN W=10u L=1u
Mn_2_45_15 hv_L1_47 vcn coln_L2_45 0 NSYN W=10u L=1u
C_gp_2_45_b gp_2_45_b 0 {Cg}
Mp_2_45_b bx gp_2_45_b colp_L2_45 0 NSYN W=10u L=1u
Mn_2_45_b bx vcn coln_L2_45 0 NSYN W=10u L=1u
Msa_h_L2_45 coln_L2_45 coln_L2_45 0 0 NMIR W=20u L=1u
Msb_h_L2_45 z_L2_45 coln_L2_45 0 0 NMIR W=20u L=1u
Msc_h_L2_45 colp_L2_45 colp_L2_45 0 0 NMIR W=20u L=1u
Msd_h_L2_45 dpf_h_L2_45 colp_L2_45 0 0 NMIR W=20u L=1u
Mse_h_L2_45 dpf_h_L2_45 dpf_h_L2_45 vdd vdd PMIR W=60u L=1u
Msf_h_L2_45 z_L2_45 dpf_h_L2_45 vdd vdd PMIR W=60u L=1u
R_h_L2_45 z_L2_45 vrefh 8000.0
Mr_L2_45  hdd_L2_45 z_L2_45 tail_L2_45 0 NREL W=12u L=1u
Mr2_L2_45 dmp_L2_45  vmid  tail_L2_45 0 NREL W=12u L=1u
Mtl_L2_45 tail_L2_45 vtb 0 0 NREL W=32.0u L=1u
Mdm_L2_45 dmp_L2_45 dmp_L2_45 vdd vdd PMIR W=40u L=1u
Mrp1_L2_45 hdd_L2_45 hdd_L2_45 vdd vdd PMIR W=40u L=1u
Mrp2_L2_45 hv_L2_45 hdd_L2_45 vdd vdd PMIR W=40u L=1u
Rhv_L2_45 hv_L2_45 vg0 8000.0
C_gp_2_46_0 gp_2_46_0 0 {Cg}
Mp_2_46_0 hv_L1_0 gp_2_46_0 colp_L2_46 0 NSYN W=10u L=1u
Mn_2_46_0 hv_L1_0 vcn coln_L2_46 0 NSYN W=10u L=1u
C_gp_2_46_1 gp_2_46_1 0 {Cg}
Mp_2_46_1 hv_L1_2 gp_2_46_1 colp_L2_46 0 NSYN W=10u L=1u
Mn_2_46_1 hv_L1_2 vcn coln_L2_46 0 NSYN W=10u L=1u
C_gp_2_46_2 gp_2_46_2 0 {Cg}
Mp_2_46_2 hv_L1_3 gp_2_46_2 colp_L2_46 0 NSYN W=10u L=1u
Mn_2_46_2 hv_L1_3 vcn coln_L2_46 0 NSYN W=10u L=1u
C_gp_2_46_3 gp_2_46_3 0 {Cg}
Mp_2_46_3 hv_L1_6 gp_2_46_3 colp_L2_46 0 NSYN W=10u L=1u
Mn_2_46_3 hv_L1_6 vcn coln_L2_46 0 NSYN W=10u L=1u
C_gp_2_46_4 gp_2_46_4 0 {Cg}
Mp_2_46_4 hv_L1_7 gp_2_46_4 colp_L2_46 0 NSYN W=10u L=1u
Mn_2_46_4 hv_L1_7 vcn coln_L2_46 0 NSYN W=10u L=1u
C_gp_2_46_5 gp_2_46_5 0 {Cg}
Mp_2_46_5 hv_L1_17 gp_2_46_5 colp_L2_46 0 NSYN W=10u L=1u
Mn_2_46_5 hv_L1_17 vcn coln_L2_46 0 NSYN W=10u L=1u
C_gp_2_46_6 gp_2_46_6 0 {Cg}
Mp_2_46_6 hv_L1_21 gp_2_46_6 colp_L2_46 0 NSYN W=10u L=1u
Mn_2_46_6 hv_L1_21 vcn coln_L2_46 0 NSYN W=10u L=1u
C_gp_2_46_7 gp_2_46_7 0 {Cg}
Mp_2_46_7 hv_L1_22 gp_2_46_7 colp_L2_46 0 NSYN W=10u L=1u
Mn_2_46_7 hv_L1_22 vcn coln_L2_46 0 NSYN W=10u L=1u
C_gp_2_46_8 gp_2_46_8 0 {Cg}
Mp_2_46_8 hv_L1_23 gp_2_46_8 colp_L2_46 0 NSYN W=10u L=1u
Mn_2_46_8 hv_L1_23 vcn coln_L2_46 0 NSYN W=10u L=1u
C_gp_2_46_9 gp_2_46_9 0 {Cg}
Mp_2_46_9 hv_L1_26 gp_2_46_9 colp_L2_46 0 NSYN W=10u L=1u
Mn_2_46_9 hv_L1_26 vcn coln_L2_46 0 NSYN W=10u L=1u
C_gp_2_46_10 gp_2_46_10 0 {Cg}
Mp_2_46_10 hv_L1_31 gp_2_46_10 colp_L2_46 0 NSYN W=10u L=1u
Mn_2_46_10 hv_L1_31 vcn coln_L2_46 0 NSYN W=10u L=1u
C_gp_2_46_11 gp_2_46_11 0 {Cg}
Mp_2_46_11 hv_L1_33 gp_2_46_11 colp_L2_46 0 NSYN W=10u L=1u
Mn_2_46_11 hv_L1_33 vcn coln_L2_46 0 NSYN W=10u L=1u
C_gp_2_46_12 gp_2_46_12 0 {Cg}
Mp_2_46_12 hv_L1_36 gp_2_46_12 colp_L2_46 0 NSYN W=10u L=1u
Mn_2_46_12 hv_L1_36 vcn coln_L2_46 0 NSYN W=10u L=1u
C_gp_2_46_13 gp_2_46_13 0 {Cg}
Mp_2_46_13 hv_L1_37 gp_2_46_13 colp_L2_46 0 NSYN W=10u L=1u
Mn_2_46_13 hv_L1_37 vcn coln_L2_46 0 NSYN W=10u L=1u
C_gp_2_46_14 gp_2_46_14 0 {Cg}
Mp_2_46_14 hv_L1_41 gp_2_46_14 colp_L2_46 0 NSYN W=10u L=1u
Mn_2_46_14 hv_L1_41 vcn coln_L2_46 0 NSYN W=10u L=1u
C_gp_2_46_15 gp_2_46_15 0 {Cg}
Mp_2_46_15 hv_L1_44 gp_2_46_15 colp_L2_46 0 NSYN W=10u L=1u
Mn_2_46_15 hv_L1_44 vcn coln_L2_46 0 NSYN W=10u L=1u
C_gp_2_46_b gp_2_46_b 0 {Cg}
Mp_2_46_b bx gp_2_46_b colp_L2_46 0 NSYN W=10u L=1u
Mn_2_46_b bx vcn coln_L2_46 0 NSYN W=10u L=1u
Msa_h_L2_46 coln_L2_46 coln_L2_46 0 0 NMIR W=20u L=1u
Msb_h_L2_46 z_L2_46 coln_L2_46 0 0 NMIR W=20u L=1u
Msc_h_L2_46 colp_L2_46 colp_L2_46 0 0 NMIR W=20u L=1u
Msd_h_L2_46 dpf_h_L2_46 colp_L2_46 0 0 NMIR W=20u L=1u
Mse_h_L2_46 dpf_h_L2_46 dpf_h_L2_46 vdd vdd PMIR W=60u L=1u
Msf_h_L2_46 z_L2_46 dpf_h_L2_46 vdd vdd PMIR W=60u L=1u
R_h_L2_46 z_L2_46 vrefh 8000.0
Mr_L2_46  hdd_L2_46 z_L2_46 tail_L2_46 0 NREL W=12u L=1u
Mr2_L2_46 dmp_L2_46  vmid  tail_L2_46 0 NREL W=12u L=1u
Mtl_L2_46 tail_L2_46 vtb 0 0 NREL W=32.0u L=1u
Mdm_L2_46 dmp_L2_46 dmp_L2_46 vdd vdd PMIR W=40u L=1u
Mrp1_L2_46 hdd_L2_46 hdd_L2_46 vdd vdd PMIR W=40u L=1u
Mrp2_L2_46 hv_L2_46 hdd_L2_46 vdd vdd PMIR W=40u L=1u
Rhv_L2_46 hv_L2_46 vg0 8000.0
C_gp_2_47_0 gp_2_47_0 0 {Cg}
Mp_2_47_0 hv_L1_0 gp_2_47_0 colp_L2_47 0 NSYN W=10u L=1u
Mn_2_47_0 hv_L1_0 vcn coln_L2_47 0 NSYN W=10u L=1u
C_gp_2_47_1 gp_2_47_1 0 {Cg}
Mp_2_47_1 hv_L1_2 gp_2_47_1 colp_L2_47 0 NSYN W=10u L=1u
Mn_2_47_1 hv_L1_2 vcn coln_L2_47 0 NSYN W=10u L=1u
C_gp_2_47_2 gp_2_47_2 0 {Cg}
Mp_2_47_2 hv_L1_5 gp_2_47_2 colp_L2_47 0 NSYN W=10u L=1u
Mn_2_47_2 hv_L1_5 vcn coln_L2_47 0 NSYN W=10u L=1u
C_gp_2_47_3 gp_2_47_3 0 {Cg}
Mp_2_47_3 hv_L1_6 gp_2_47_3 colp_L2_47 0 NSYN W=10u L=1u
Mn_2_47_3 hv_L1_6 vcn coln_L2_47 0 NSYN W=10u L=1u
C_gp_2_47_4 gp_2_47_4 0 {Cg}
Mp_2_47_4 hv_L1_9 gp_2_47_4 colp_L2_47 0 NSYN W=10u L=1u
Mn_2_47_4 hv_L1_9 vcn coln_L2_47 0 NSYN W=10u L=1u
C_gp_2_47_5 gp_2_47_5 0 {Cg}
Mp_2_47_5 hv_L1_16 gp_2_47_5 colp_L2_47 0 NSYN W=10u L=1u
Mn_2_47_5 hv_L1_16 vcn coln_L2_47 0 NSYN W=10u L=1u
C_gp_2_47_6 gp_2_47_6 0 {Cg}
Mp_2_47_6 hv_L1_17 gp_2_47_6 colp_L2_47 0 NSYN W=10u L=1u
Mn_2_47_6 hv_L1_17 vcn coln_L2_47 0 NSYN W=10u L=1u
C_gp_2_47_7 gp_2_47_7 0 {Cg}
Mp_2_47_7 hv_L1_18 gp_2_47_7 colp_L2_47 0 NSYN W=10u L=1u
Mn_2_47_7 hv_L1_18 vcn coln_L2_47 0 NSYN W=10u L=1u
C_gp_2_47_8 gp_2_47_8 0 {Cg}
Mp_2_47_8 hv_L1_20 gp_2_47_8 colp_L2_47 0 NSYN W=10u L=1u
Mn_2_47_8 hv_L1_20 vcn coln_L2_47 0 NSYN W=10u L=1u
C_gp_2_47_9 gp_2_47_9 0 {Cg}
Mp_2_47_9 hv_L1_25 gp_2_47_9 colp_L2_47 0 NSYN W=10u L=1u
Mn_2_47_9 hv_L1_25 vcn coln_L2_47 0 NSYN W=10u L=1u
C_gp_2_47_10 gp_2_47_10 0 {Cg}
Mp_2_47_10 hv_L1_29 gp_2_47_10 colp_L2_47 0 NSYN W=10u L=1u
Mn_2_47_10 hv_L1_29 vcn coln_L2_47 0 NSYN W=10u L=1u
C_gp_2_47_11 gp_2_47_11 0 {Cg}
Mp_2_47_11 hv_L1_32 gp_2_47_11 colp_L2_47 0 NSYN W=10u L=1u
Mn_2_47_11 hv_L1_32 vcn coln_L2_47 0 NSYN W=10u L=1u
C_gp_2_47_12 gp_2_47_12 0 {Cg}
Mp_2_47_12 hv_L1_33 gp_2_47_12 colp_L2_47 0 NSYN W=10u L=1u
Mn_2_47_12 hv_L1_33 vcn coln_L2_47 0 NSYN W=10u L=1u
C_gp_2_47_13 gp_2_47_13 0 {Cg}
Mp_2_47_13 hv_L1_36 gp_2_47_13 colp_L2_47 0 NSYN W=10u L=1u
Mn_2_47_13 hv_L1_36 vcn coln_L2_47 0 NSYN W=10u L=1u
C_gp_2_47_14 gp_2_47_14 0 {Cg}
Mp_2_47_14 hv_L1_43 gp_2_47_14 colp_L2_47 0 NSYN W=10u L=1u
Mn_2_47_14 hv_L1_43 vcn coln_L2_47 0 NSYN W=10u L=1u
C_gp_2_47_15 gp_2_47_15 0 {Cg}
Mp_2_47_15 hv_L1_46 gp_2_47_15 colp_L2_47 0 NSYN W=10u L=1u
Mn_2_47_15 hv_L1_46 vcn coln_L2_47 0 NSYN W=10u L=1u
C_gp_2_47_b gp_2_47_b 0 {Cg}
Mp_2_47_b bx gp_2_47_b colp_L2_47 0 NSYN W=10u L=1u
Mn_2_47_b bx vcn coln_L2_47 0 NSYN W=10u L=1u
Msa_h_L2_47 coln_L2_47 coln_L2_47 0 0 NMIR W=20u L=1u
Msb_h_L2_47 z_L2_47 coln_L2_47 0 0 NMIR W=20u L=1u
Msc_h_L2_47 colp_L2_47 colp_L2_47 0 0 NMIR W=20u L=1u
Msd_h_L2_47 dpf_h_L2_47 colp_L2_47 0 0 NMIR W=20u L=1u
Mse_h_L2_47 dpf_h_L2_47 dpf_h_L2_47 vdd vdd PMIR W=60u L=1u
Msf_h_L2_47 z_L2_47 dpf_h_L2_47 vdd vdd PMIR W=60u L=1u
R_h_L2_47 z_L2_47 vrefh 8000.0
Mr_L2_47  hdd_L2_47 z_L2_47 tail_L2_47 0 NREL W=12u L=1u
Mr2_L2_47 dmp_L2_47  vmid  tail_L2_47 0 NREL W=12u L=1u
Mtl_L2_47 tail_L2_47 vtb 0 0 NREL W=32.0u L=1u
Mdm_L2_47 dmp_L2_47 dmp_L2_47 vdd vdd PMIR W=40u L=1u
Mrp1_L2_47 hdd_L2_47 hdd_L2_47 vdd vdd PMIR W=40u L=1u
Mrp2_L2_47 hv_L2_47 hdd_L2_47 vdd vdd PMIR W=40u L=1u
Rhv_L2_47 hv_L2_47 vg0 8000.0
C_gp_3_0_0 gp_3_0_0 0 {Cg}
Mp_3_0_0 hv_L2_3 gp_3_0_0 colp_L3_0 0 NSYN W=10u L=1u
Mn_3_0_0 hv_L2_3 vcn coln_L3_0 0 NSYN W=10u L=1u
C_gp_3_0_1 gp_3_0_1 0 {Cg}
Mp_3_0_1 hv_L2_5 gp_3_0_1 colp_L3_0 0 NSYN W=10u L=1u
Mn_3_0_1 hv_L2_5 vcn coln_L3_0 0 NSYN W=10u L=1u
C_gp_3_0_2 gp_3_0_2 0 {Cg}
Mp_3_0_2 hv_L2_8 gp_3_0_2 colp_L3_0 0 NSYN W=10u L=1u
Mn_3_0_2 hv_L2_8 vcn coln_L3_0 0 NSYN W=10u L=1u
C_gp_3_0_3 gp_3_0_3 0 {Cg}
Mp_3_0_3 hv_L2_11 gp_3_0_3 colp_L3_0 0 NSYN W=10u L=1u
Mn_3_0_3 hv_L2_11 vcn coln_L3_0 0 NSYN W=10u L=1u
C_gp_3_0_4 gp_3_0_4 0 {Cg}
Mp_3_0_4 hv_L2_14 gp_3_0_4 colp_L3_0 0 NSYN W=10u L=1u
Mn_3_0_4 hv_L2_14 vcn coln_L3_0 0 NSYN W=10u L=1u
C_gp_3_0_5 gp_3_0_5 0 {Cg}
Mp_3_0_5 hv_L2_15 gp_3_0_5 colp_L3_0 0 NSYN W=10u L=1u
Mn_3_0_5 hv_L2_15 vcn coln_L3_0 0 NSYN W=10u L=1u
C_gp_3_0_6 gp_3_0_6 0 {Cg}
Mp_3_0_6 hv_L2_18 gp_3_0_6 colp_L3_0 0 NSYN W=10u L=1u
Mn_3_0_6 hv_L2_18 vcn coln_L3_0 0 NSYN W=10u L=1u
C_gp_3_0_7 gp_3_0_7 0 {Cg}
Mp_3_0_7 hv_L2_20 gp_3_0_7 colp_L3_0 0 NSYN W=10u L=1u
Mn_3_0_7 hv_L2_20 vcn coln_L3_0 0 NSYN W=10u L=1u
C_gp_3_0_8 gp_3_0_8 0 {Cg}
Mp_3_0_8 hv_L2_21 gp_3_0_8 colp_L3_0 0 NSYN W=10u L=1u
Mn_3_0_8 hv_L2_21 vcn coln_L3_0 0 NSYN W=10u L=1u
C_gp_3_0_9 gp_3_0_9 0 {Cg}
Mp_3_0_9 hv_L2_27 gp_3_0_9 colp_L3_0 0 NSYN W=10u L=1u
Mn_3_0_9 hv_L2_27 vcn coln_L3_0 0 NSYN W=10u L=1u
C_gp_3_0_10 gp_3_0_10 0 {Cg}
Mp_3_0_10 hv_L2_28 gp_3_0_10 colp_L3_0 0 NSYN W=10u L=1u
Mn_3_0_10 hv_L2_28 vcn coln_L3_0 0 NSYN W=10u L=1u
C_gp_3_0_11 gp_3_0_11 0 {Cg}
Mp_3_0_11 hv_L2_31 gp_3_0_11 colp_L3_0 0 NSYN W=10u L=1u
Mn_3_0_11 hv_L2_31 vcn coln_L3_0 0 NSYN W=10u L=1u
C_gp_3_0_12 gp_3_0_12 0 {Cg}
Mp_3_0_12 hv_L2_37 gp_3_0_12 colp_L3_0 0 NSYN W=10u L=1u
Mn_3_0_12 hv_L2_37 vcn coln_L3_0 0 NSYN W=10u L=1u
C_gp_3_0_13 gp_3_0_13 0 {Cg}
Mp_3_0_13 hv_L2_39 gp_3_0_13 colp_L3_0 0 NSYN W=10u L=1u
Mn_3_0_13 hv_L2_39 vcn coln_L3_0 0 NSYN W=10u L=1u
C_gp_3_0_14 gp_3_0_14 0 {Cg}
Mp_3_0_14 hv_L2_41 gp_3_0_14 colp_L3_0 0 NSYN W=10u L=1u
Mn_3_0_14 hv_L2_41 vcn coln_L3_0 0 NSYN W=10u L=1u
C_gp_3_0_15 gp_3_0_15 0 {Cg}
Mp_3_0_15 hv_L2_47 gp_3_0_15 colp_L3_0 0 NSYN W=10u L=1u
Mn_3_0_15 hv_L2_47 vcn coln_L3_0 0 NSYN W=10u L=1u
C_gp_3_0_b gp_3_0_b 0 {Cg}
Mp_3_0_b bx gp_3_0_b colp_L3_0 0 NSYN W=10u L=1u
Mn_3_0_b bx vcn coln_L3_0 0 NSYN W=10u L=1u
Msa_h_L3_0 coln_L3_0 coln_L3_0 0 0 NMIR W=20u L=1u
Msb_h_L3_0 z_L3_0 coln_L3_0 0 0 NMIR W=20u L=1u
Msc_h_L3_0 colp_L3_0 colp_L3_0 0 0 NMIR W=20u L=1u
Msd_h_L3_0 dpf_h_L3_0 colp_L3_0 0 0 NMIR W=20u L=1u
Mse_h_L3_0 dpf_h_L3_0 dpf_h_L3_0 vdd vdd PMIR W=60u L=1u
Msf_h_L3_0 z_L3_0 dpf_h_L3_0 vdd vdd PMIR W=60u L=1u
R_h_L3_0 z_L3_0 vrefh 8000.0
Mr_L3_0  hdd_L3_0 z_L3_0 tail_L3_0 0 NREL W=12u L=1u
Mr2_L3_0 dmp_L3_0  vmid  tail_L3_0 0 NREL W=12u L=1u
Mtl_L3_0 tail_L3_0 vtb 0 0 NREL W=32.0u L=1u
Mdm_L3_0 dmp_L3_0 dmp_L3_0 vdd vdd PMIR W=40u L=1u
Mrp1_L3_0 hdd_L3_0 hdd_L3_0 vdd vdd PMIR W=40u L=1u
Mrp2_L3_0 hv_L3_0 hdd_L3_0 vdd vdd PMIR W=40u L=1u
Rhv_L3_0 hv_L3_0 vg0 8000.0
C_gp_3_1_0 gp_3_1_0 0 {Cg}
Mp_3_1_0 hv_L2_5 gp_3_1_0 colp_L3_1 0 NSYN W=10u L=1u
Mn_3_1_0 hv_L2_5 vcn coln_L3_1 0 NSYN W=10u L=1u
C_gp_3_1_1 gp_3_1_1 0 {Cg}
Mp_3_1_1 hv_L2_6 gp_3_1_1 colp_L3_1 0 NSYN W=10u L=1u
Mn_3_1_1 hv_L2_6 vcn coln_L3_1 0 NSYN W=10u L=1u
C_gp_3_1_2 gp_3_1_2 0 {Cg}
Mp_3_1_2 hv_L2_11 gp_3_1_2 colp_L3_1 0 NSYN W=10u L=1u
Mn_3_1_2 hv_L2_11 vcn coln_L3_1 0 NSYN W=10u L=1u
C_gp_3_1_3 gp_3_1_3 0 {Cg}
Mp_3_1_3 hv_L2_15 gp_3_1_3 colp_L3_1 0 NSYN W=10u L=1u
Mn_3_1_3 hv_L2_15 vcn coln_L3_1 0 NSYN W=10u L=1u
C_gp_3_1_4 gp_3_1_4 0 {Cg}
Mp_3_1_4 hv_L2_19 gp_3_1_4 colp_L3_1 0 NSYN W=10u L=1u
Mn_3_1_4 hv_L2_19 vcn coln_L3_1 0 NSYN W=10u L=1u
C_gp_3_1_5 gp_3_1_5 0 {Cg}
Mp_3_1_5 hv_L2_21 gp_3_1_5 colp_L3_1 0 NSYN W=10u L=1u
Mn_3_1_5 hv_L2_21 vcn coln_L3_1 0 NSYN W=10u L=1u
C_gp_3_1_6 gp_3_1_6 0 {Cg}
Mp_3_1_6 hv_L2_23 gp_3_1_6 colp_L3_1 0 NSYN W=10u L=1u
Mn_3_1_6 hv_L2_23 vcn coln_L3_1 0 NSYN W=10u L=1u
C_gp_3_1_7 gp_3_1_7 0 {Cg}
Mp_3_1_7 hv_L2_28 gp_3_1_7 colp_L3_1 0 NSYN W=10u L=1u
Mn_3_1_7 hv_L2_28 vcn coln_L3_1 0 NSYN W=10u L=1u
C_gp_3_1_8 gp_3_1_8 0 {Cg}
Mp_3_1_8 hv_L2_29 gp_3_1_8 colp_L3_1 0 NSYN W=10u L=1u
Mn_3_1_8 hv_L2_29 vcn coln_L3_1 0 NSYN W=10u L=1u
C_gp_3_1_9 gp_3_1_9 0 {Cg}
Mp_3_1_9 hv_L2_32 gp_3_1_9 colp_L3_1 0 NSYN W=10u L=1u
Mn_3_1_9 hv_L2_32 vcn coln_L3_1 0 NSYN W=10u L=1u
C_gp_3_1_10 gp_3_1_10 0 {Cg}
Mp_3_1_10 hv_L2_34 gp_3_1_10 colp_L3_1 0 NSYN W=10u L=1u
Mn_3_1_10 hv_L2_34 vcn coln_L3_1 0 NSYN W=10u L=1u
C_gp_3_1_11 gp_3_1_11 0 {Cg}
Mp_3_1_11 hv_L2_38 gp_3_1_11 colp_L3_1 0 NSYN W=10u L=1u
Mn_3_1_11 hv_L2_38 vcn coln_L3_1 0 NSYN W=10u L=1u
C_gp_3_1_12 gp_3_1_12 0 {Cg}
Mp_3_1_12 hv_L2_39 gp_3_1_12 colp_L3_1 0 NSYN W=10u L=1u
Mn_3_1_12 hv_L2_39 vcn coln_L3_1 0 NSYN W=10u L=1u
C_gp_3_1_13 gp_3_1_13 0 {Cg}
Mp_3_1_13 hv_L2_43 gp_3_1_13 colp_L3_1 0 NSYN W=10u L=1u
Mn_3_1_13 hv_L2_43 vcn coln_L3_1 0 NSYN W=10u L=1u
C_gp_3_1_14 gp_3_1_14 0 {Cg}
Mp_3_1_14 hv_L2_44 gp_3_1_14 colp_L3_1 0 NSYN W=10u L=1u
Mn_3_1_14 hv_L2_44 vcn coln_L3_1 0 NSYN W=10u L=1u
C_gp_3_1_15 gp_3_1_15 0 {Cg}
Mp_3_1_15 hv_L2_47 gp_3_1_15 colp_L3_1 0 NSYN W=10u L=1u
Mn_3_1_15 hv_L2_47 vcn coln_L3_1 0 NSYN W=10u L=1u
C_gp_3_1_b gp_3_1_b 0 {Cg}
Mp_3_1_b bx gp_3_1_b colp_L3_1 0 NSYN W=10u L=1u
Mn_3_1_b bx vcn coln_L3_1 0 NSYN W=10u L=1u
Msa_h_L3_1 coln_L3_1 coln_L3_1 0 0 NMIR W=20u L=1u
Msb_h_L3_1 z_L3_1 coln_L3_1 0 0 NMIR W=20u L=1u
Msc_h_L3_1 colp_L3_1 colp_L3_1 0 0 NMIR W=20u L=1u
Msd_h_L3_1 dpf_h_L3_1 colp_L3_1 0 0 NMIR W=20u L=1u
Mse_h_L3_1 dpf_h_L3_1 dpf_h_L3_1 vdd vdd PMIR W=60u L=1u
Msf_h_L3_1 z_L3_1 dpf_h_L3_1 vdd vdd PMIR W=60u L=1u
R_h_L3_1 z_L3_1 vrefh 8000.0
Mr_L3_1  hdd_L3_1 z_L3_1 tail_L3_1 0 NREL W=12u L=1u
Mr2_L3_1 dmp_L3_1  vmid  tail_L3_1 0 NREL W=12u L=1u
Mtl_L3_1 tail_L3_1 vtb 0 0 NREL W=32.0u L=1u
Mdm_L3_1 dmp_L3_1 dmp_L3_1 vdd vdd PMIR W=40u L=1u
Mrp1_L3_1 hdd_L3_1 hdd_L3_1 vdd vdd PMIR W=40u L=1u
Mrp2_L3_1 hv_L3_1 hdd_L3_1 vdd vdd PMIR W=40u L=1u
Rhv_L3_1 hv_L3_1 vg0 8000.0
C_gp_3_2_0 gp_3_2_0 0 {Cg}
Mp_3_2_0 hv_L2_2 gp_3_2_0 colp_L3_2 0 NSYN W=10u L=1u
Mn_3_2_0 hv_L2_2 vcn coln_L3_2 0 NSYN W=10u L=1u
C_gp_3_2_1 gp_3_2_1 0 {Cg}
Mp_3_2_1 hv_L2_6 gp_3_2_1 colp_L3_2 0 NSYN W=10u L=1u
Mn_3_2_1 hv_L2_6 vcn coln_L3_2 0 NSYN W=10u L=1u
C_gp_3_2_2 gp_3_2_2 0 {Cg}
Mp_3_2_2 hv_L2_10 gp_3_2_2 colp_L3_2 0 NSYN W=10u L=1u
Mn_3_2_2 hv_L2_10 vcn coln_L3_2 0 NSYN W=10u L=1u
C_gp_3_2_3 gp_3_2_3 0 {Cg}
Mp_3_2_3 hv_L2_11 gp_3_2_3 colp_L3_2 0 NSYN W=10u L=1u
Mn_3_2_3 hv_L2_11 vcn coln_L3_2 0 NSYN W=10u L=1u
C_gp_3_2_4 gp_3_2_4 0 {Cg}
Mp_3_2_4 hv_L2_12 gp_3_2_4 colp_L3_2 0 NSYN W=10u L=1u
Mn_3_2_4 hv_L2_12 vcn coln_L3_2 0 NSYN W=10u L=1u
C_gp_3_2_5 gp_3_2_5 0 {Cg}
Mp_3_2_5 hv_L2_21 gp_3_2_5 colp_L3_2 0 NSYN W=10u L=1u
Mn_3_2_5 hv_L2_21 vcn coln_L3_2 0 NSYN W=10u L=1u
C_gp_3_2_6 gp_3_2_6 0 {Cg}
Mp_3_2_6 hv_L2_26 gp_3_2_6 colp_L3_2 0 NSYN W=10u L=1u
Mn_3_2_6 hv_L2_26 vcn coln_L3_2 0 NSYN W=10u L=1u
C_gp_3_2_7 gp_3_2_7 0 {Cg}
Mp_3_2_7 hv_L2_32 gp_3_2_7 colp_L3_2 0 NSYN W=10u L=1u
Mn_3_2_7 hv_L2_32 vcn coln_L3_2 0 NSYN W=10u L=1u
C_gp_3_2_8 gp_3_2_8 0 {Cg}
Mp_3_2_8 hv_L2_33 gp_3_2_8 colp_L3_2 0 NSYN W=10u L=1u
Mn_3_2_8 hv_L2_33 vcn coln_L3_2 0 NSYN W=10u L=1u
C_gp_3_2_9 gp_3_2_9 0 {Cg}
Mp_3_2_9 hv_L2_35 gp_3_2_9 colp_L3_2 0 NSYN W=10u L=1u
Mn_3_2_9 hv_L2_35 vcn coln_L3_2 0 NSYN W=10u L=1u
C_gp_3_2_10 gp_3_2_10 0 {Cg}
Mp_3_2_10 hv_L2_36 gp_3_2_10 colp_L3_2 0 NSYN W=10u L=1u
Mn_3_2_10 hv_L2_36 vcn coln_L3_2 0 NSYN W=10u L=1u
C_gp_3_2_11 gp_3_2_11 0 {Cg}
Mp_3_2_11 hv_L2_40 gp_3_2_11 colp_L3_2 0 NSYN W=10u L=1u
Mn_3_2_11 hv_L2_40 vcn coln_L3_2 0 NSYN W=10u L=1u
C_gp_3_2_12 gp_3_2_12 0 {Cg}
Mp_3_2_12 hv_L2_43 gp_3_2_12 colp_L3_2 0 NSYN W=10u L=1u
Mn_3_2_12 hv_L2_43 vcn coln_L3_2 0 NSYN W=10u L=1u
C_gp_3_2_13 gp_3_2_13 0 {Cg}
Mp_3_2_13 hv_L2_44 gp_3_2_13 colp_L3_2 0 NSYN W=10u L=1u
Mn_3_2_13 hv_L2_44 vcn coln_L3_2 0 NSYN W=10u L=1u
C_gp_3_2_14 gp_3_2_14 0 {Cg}
Mp_3_2_14 hv_L2_45 gp_3_2_14 colp_L3_2 0 NSYN W=10u L=1u
Mn_3_2_14 hv_L2_45 vcn coln_L3_2 0 NSYN W=10u L=1u
C_gp_3_2_15 gp_3_2_15 0 {Cg}
Mp_3_2_15 hv_L2_46 gp_3_2_15 colp_L3_2 0 NSYN W=10u L=1u
Mn_3_2_15 hv_L2_46 vcn coln_L3_2 0 NSYN W=10u L=1u
C_gp_3_2_b gp_3_2_b 0 {Cg}
Mp_3_2_b bx gp_3_2_b colp_L3_2 0 NSYN W=10u L=1u
Mn_3_2_b bx vcn coln_L3_2 0 NSYN W=10u L=1u
Msa_h_L3_2 coln_L3_2 coln_L3_2 0 0 NMIR W=20u L=1u
Msb_h_L3_2 z_L3_2 coln_L3_2 0 0 NMIR W=20u L=1u
Msc_h_L3_2 colp_L3_2 colp_L3_2 0 0 NMIR W=20u L=1u
Msd_h_L3_2 dpf_h_L3_2 colp_L3_2 0 0 NMIR W=20u L=1u
Mse_h_L3_2 dpf_h_L3_2 dpf_h_L3_2 vdd vdd PMIR W=60u L=1u
Msf_h_L3_2 z_L3_2 dpf_h_L3_2 vdd vdd PMIR W=60u L=1u
R_h_L3_2 z_L3_2 vrefh 8000.0
Mr_L3_2  hdd_L3_2 z_L3_2 tail_L3_2 0 NREL W=12u L=1u
Mr2_L3_2 dmp_L3_2  vmid  tail_L3_2 0 NREL W=12u L=1u
Mtl_L3_2 tail_L3_2 vtb 0 0 NREL W=32.0u L=1u
Mdm_L3_2 dmp_L3_2 dmp_L3_2 vdd vdd PMIR W=40u L=1u
Mrp1_L3_2 hdd_L3_2 hdd_L3_2 vdd vdd PMIR W=40u L=1u
Mrp2_L3_2 hv_L3_2 hdd_L3_2 vdd vdd PMIR W=40u L=1u
Rhv_L3_2 hv_L3_2 vg0 8000.0
C_gp_3_3_0 gp_3_3_0 0 {Cg}
Mp_3_3_0 hv_L2_6 gp_3_3_0 colp_L3_3 0 NSYN W=10u L=1u
Mn_3_3_0 hv_L2_6 vcn coln_L3_3 0 NSYN W=10u L=1u
C_gp_3_3_1 gp_3_3_1 0 {Cg}
Mp_3_3_1 hv_L2_12 gp_3_3_1 colp_L3_3 0 NSYN W=10u L=1u
Mn_3_3_1 hv_L2_12 vcn coln_L3_3 0 NSYN W=10u L=1u
C_gp_3_3_2 gp_3_3_2 0 {Cg}
Mp_3_3_2 hv_L2_18 gp_3_3_2 colp_L3_3 0 NSYN W=10u L=1u
Mn_3_3_2 hv_L2_18 vcn coln_L3_3 0 NSYN W=10u L=1u
C_gp_3_3_3 gp_3_3_3 0 {Cg}
Mp_3_3_3 hv_L2_20 gp_3_3_3 colp_L3_3 0 NSYN W=10u L=1u
Mn_3_3_3 hv_L2_20 vcn coln_L3_3 0 NSYN W=10u L=1u
C_gp_3_3_4 gp_3_3_4 0 {Cg}
Mp_3_3_4 hv_L2_24 gp_3_3_4 colp_L3_3 0 NSYN W=10u L=1u
Mn_3_3_4 hv_L2_24 vcn coln_L3_3 0 NSYN W=10u L=1u
C_gp_3_3_5 gp_3_3_5 0 {Cg}
Mp_3_3_5 hv_L2_27 gp_3_3_5 colp_L3_3 0 NSYN W=10u L=1u
Mn_3_3_5 hv_L2_27 vcn coln_L3_3 0 NSYN W=10u L=1u
C_gp_3_3_6 gp_3_3_6 0 {Cg}
Mp_3_3_6 hv_L2_31 gp_3_3_6 colp_L3_3 0 NSYN W=10u L=1u
Mn_3_3_6 hv_L2_31 vcn coln_L3_3 0 NSYN W=10u L=1u
C_gp_3_3_7 gp_3_3_7 0 {Cg}
Mp_3_3_7 hv_L2_32 gp_3_3_7 colp_L3_3 0 NSYN W=10u L=1u
Mn_3_3_7 hv_L2_32 vcn coln_L3_3 0 NSYN W=10u L=1u
C_gp_3_3_8 gp_3_3_8 0 {Cg}
Mp_3_3_8 hv_L2_34 gp_3_3_8 colp_L3_3 0 NSYN W=10u L=1u
Mn_3_3_8 hv_L2_34 vcn coln_L3_3 0 NSYN W=10u L=1u
C_gp_3_3_9 gp_3_3_9 0 {Cg}
Mp_3_3_9 hv_L2_36 gp_3_3_9 colp_L3_3 0 NSYN W=10u L=1u
Mn_3_3_9 hv_L2_36 vcn coln_L3_3 0 NSYN W=10u L=1u
C_gp_3_3_10 gp_3_3_10 0 {Cg}
Mp_3_3_10 hv_L2_40 gp_3_3_10 colp_L3_3 0 NSYN W=10u L=1u
Mn_3_3_10 hv_L2_40 vcn coln_L3_3 0 NSYN W=10u L=1u
C_gp_3_3_11 gp_3_3_11 0 {Cg}
Mp_3_3_11 hv_L2_41 gp_3_3_11 colp_L3_3 0 NSYN W=10u L=1u
Mn_3_3_11 hv_L2_41 vcn coln_L3_3 0 NSYN W=10u L=1u
C_gp_3_3_12 gp_3_3_12 0 {Cg}
Mp_3_3_12 hv_L2_42 gp_3_3_12 colp_L3_3 0 NSYN W=10u L=1u
Mn_3_3_12 hv_L2_42 vcn coln_L3_3 0 NSYN W=10u L=1u
C_gp_3_3_13 gp_3_3_13 0 {Cg}
Mp_3_3_13 hv_L2_44 gp_3_3_13 colp_L3_3 0 NSYN W=10u L=1u
Mn_3_3_13 hv_L2_44 vcn coln_L3_3 0 NSYN W=10u L=1u
C_gp_3_3_14 gp_3_3_14 0 {Cg}
Mp_3_3_14 hv_L2_45 gp_3_3_14 colp_L3_3 0 NSYN W=10u L=1u
Mn_3_3_14 hv_L2_45 vcn coln_L3_3 0 NSYN W=10u L=1u
C_gp_3_3_15 gp_3_3_15 0 {Cg}
Mp_3_3_15 hv_L2_46 gp_3_3_15 colp_L3_3 0 NSYN W=10u L=1u
Mn_3_3_15 hv_L2_46 vcn coln_L3_3 0 NSYN W=10u L=1u
C_gp_3_3_b gp_3_3_b 0 {Cg}
Mp_3_3_b bx gp_3_3_b colp_L3_3 0 NSYN W=10u L=1u
Mn_3_3_b bx vcn coln_L3_3 0 NSYN W=10u L=1u
Msa_h_L3_3 coln_L3_3 coln_L3_3 0 0 NMIR W=20u L=1u
Msb_h_L3_3 z_L3_3 coln_L3_3 0 0 NMIR W=20u L=1u
Msc_h_L3_3 colp_L3_3 colp_L3_3 0 0 NMIR W=20u L=1u
Msd_h_L3_3 dpf_h_L3_3 colp_L3_3 0 0 NMIR W=20u L=1u
Mse_h_L3_3 dpf_h_L3_3 dpf_h_L3_3 vdd vdd PMIR W=60u L=1u
Msf_h_L3_3 z_L3_3 dpf_h_L3_3 vdd vdd PMIR W=60u L=1u
R_h_L3_3 z_L3_3 vrefh 8000.0
Mr_L3_3  hdd_L3_3 z_L3_3 tail_L3_3 0 NREL W=12u L=1u
Mr2_L3_3 dmp_L3_3  vmid  tail_L3_3 0 NREL W=12u L=1u
Mtl_L3_3 tail_L3_3 vtb 0 0 NREL W=32.0u L=1u
Mdm_L3_3 dmp_L3_3 dmp_L3_3 vdd vdd PMIR W=40u L=1u
Mrp1_L3_3 hdd_L3_3 hdd_L3_3 vdd vdd PMIR W=40u L=1u
Mrp2_L3_3 hv_L3_3 hdd_L3_3 vdd vdd PMIR W=40u L=1u
Rhv_L3_3 hv_L3_3 vg0 8000.0
C_gp_3_4_0 gp_3_4_0 0 {Cg}
Mp_3_4_0 hv_L2_2 gp_3_4_0 colp_L3_4 0 NSYN W=10u L=1u
Mn_3_4_0 hv_L2_2 vcn coln_L3_4 0 NSYN W=10u L=1u
C_gp_3_4_1 gp_3_4_1 0 {Cg}
Mp_3_4_1 hv_L2_3 gp_3_4_1 colp_L3_4 0 NSYN W=10u L=1u
Mn_3_4_1 hv_L2_3 vcn coln_L3_4 0 NSYN W=10u L=1u
C_gp_3_4_2 gp_3_4_2 0 {Cg}
Mp_3_4_2 hv_L2_6 gp_3_4_2 colp_L3_4 0 NSYN W=10u L=1u
Mn_3_4_2 hv_L2_6 vcn coln_L3_4 0 NSYN W=10u L=1u
C_gp_3_4_3 gp_3_4_3 0 {Cg}
Mp_3_4_3 hv_L2_8 gp_3_4_3 colp_L3_4 0 NSYN W=10u L=1u
Mn_3_4_3 hv_L2_8 vcn coln_L3_4 0 NSYN W=10u L=1u
C_gp_3_4_4 gp_3_4_4 0 {Cg}
Mp_3_4_4 hv_L2_10 gp_3_4_4 colp_L3_4 0 NSYN W=10u L=1u
Mn_3_4_4 hv_L2_10 vcn coln_L3_4 0 NSYN W=10u L=1u
C_gp_3_4_5 gp_3_4_5 0 {Cg}
Mp_3_4_5 hv_L2_11 gp_3_4_5 colp_L3_4 0 NSYN W=10u L=1u
Mn_3_4_5 hv_L2_11 vcn coln_L3_4 0 NSYN W=10u L=1u
C_gp_3_4_6 gp_3_4_6 0 {Cg}
Mp_3_4_6 hv_L2_12 gp_3_4_6 colp_L3_4 0 NSYN W=10u L=1u
Mn_3_4_6 hv_L2_12 vcn coln_L3_4 0 NSYN W=10u L=1u
C_gp_3_4_7 gp_3_4_7 0 {Cg}
Mp_3_4_7 hv_L2_14 gp_3_4_7 colp_L3_4 0 NSYN W=10u L=1u
Mn_3_4_7 hv_L2_14 vcn coln_L3_4 0 NSYN W=10u L=1u
C_gp_3_4_8 gp_3_4_8 0 {Cg}
Mp_3_4_8 hv_L2_17 gp_3_4_8 colp_L3_4 0 NSYN W=10u L=1u
Mn_3_4_8 hv_L2_17 vcn coln_L3_4 0 NSYN W=10u L=1u
C_gp_3_4_9 gp_3_4_9 0 {Cg}
Mp_3_4_9 hv_L2_22 gp_3_4_9 colp_L3_4 0 NSYN W=10u L=1u
Mn_3_4_9 hv_L2_22 vcn coln_L3_4 0 NSYN W=10u L=1u
C_gp_3_4_10 gp_3_4_10 0 {Cg}
Mp_3_4_10 hv_L2_28 gp_3_4_10 colp_L3_4 0 NSYN W=10u L=1u
Mn_3_4_10 hv_L2_28 vcn coln_L3_4 0 NSYN W=10u L=1u
C_gp_3_4_11 gp_3_4_11 0 {Cg}
Mp_3_4_11 hv_L2_30 gp_3_4_11 colp_L3_4 0 NSYN W=10u L=1u
Mn_3_4_11 hv_L2_30 vcn coln_L3_4 0 NSYN W=10u L=1u
C_gp_3_4_12 gp_3_4_12 0 {Cg}
Mp_3_4_12 hv_L2_38 gp_3_4_12 colp_L3_4 0 NSYN W=10u L=1u
Mn_3_4_12 hv_L2_38 vcn coln_L3_4 0 NSYN W=10u L=1u
C_gp_3_4_13 gp_3_4_13 0 {Cg}
Mp_3_4_13 hv_L2_39 gp_3_4_13 colp_L3_4 0 NSYN W=10u L=1u
Mn_3_4_13 hv_L2_39 vcn coln_L3_4 0 NSYN W=10u L=1u
C_gp_3_4_14 gp_3_4_14 0 {Cg}
Mp_3_4_14 hv_L2_40 gp_3_4_14 colp_L3_4 0 NSYN W=10u L=1u
Mn_3_4_14 hv_L2_40 vcn coln_L3_4 0 NSYN W=10u L=1u
C_gp_3_4_15 gp_3_4_15 0 {Cg}
Mp_3_4_15 hv_L2_47 gp_3_4_15 colp_L3_4 0 NSYN W=10u L=1u
Mn_3_4_15 hv_L2_47 vcn coln_L3_4 0 NSYN W=10u L=1u
C_gp_3_4_b gp_3_4_b 0 {Cg}
Mp_3_4_b bx gp_3_4_b colp_L3_4 0 NSYN W=10u L=1u
Mn_3_4_b bx vcn coln_L3_4 0 NSYN W=10u L=1u
Msa_h_L3_4 coln_L3_4 coln_L3_4 0 0 NMIR W=20u L=1u
Msb_h_L3_4 z_L3_4 coln_L3_4 0 0 NMIR W=20u L=1u
Msc_h_L3_4 colp_L3_4 colp_L3_4 0 0 NMIR W=20u L=1u
Msd_h_L3_4 dpf_h_L3_4 colp_L3_4 0 0 NMIR W=20u L=1u
Mse_h_L3_4 dpf_h_L3_4 dpf_h_L3_4 vdd vdd PMIR W=60u L=1u
Msf_h_L3_4 z_L3_4 dpf_h_L3_4 vdd vdd PMIR W=60u L=1u
R_h_L3_4 z_L3_4 vrefh 8000.0
Mr_L3_4  hdd_L3_4 z_L3_4 tail_L3_4 0 NREL W=12u L=1u
Mr2_L3_4 dmp_L3_4  vmid  tail_L3_4 0 NREL W=12u L=1u
Mtl_L3_4 tail_L3_4 vtb 0 0 NREL W=32.0u L=1u
Mdm_L3_4 dmp_L3_4 dmp_L3_4 vdd vdd PMIR W=40u L=1u
Mrp1_L3_4 hdd_L3_4 hdd_L3_4 vdd vdd PMIR W=40u L=1u
Mrp2_L3_4 hv_L3_4 hdd_L3_4 vdd vdd PMIR W=40u L=1u
Rhv_L3_4 hv_L3_4 vg0 8000.0
C_gp_3_5_0 gp_3_5_0 0 {Cg}
Mp_3_5_0 hv_L2_2 gp_3_5_0 colp_L3_5 0 NSYN W=10u L=1u
Mn_3_5_0 hv_L2_2 vcn coln_L3_5 0 NSYN W=10u L=1u
C_gp_3_5_1 gp_3_5_1 0 {Cg}
Mp_3_5_1 hv_L2_4 gp_3_5_1 colp_L3_5 0 NSYN W=10u L=1u
Mn_3_5_1 hv_L2_4 vcn coln_L3_5 0 NSYN W=10u L=1u
C_gp_3_5_2 gp_3_5_2 0 {Cg}
Mp_3_5_2 hv_L2_8 gp_3_5_2 colp_L3_5 0 NSYN W=10u L=1u
Mn_3_5_2 hv_L2_8 vcn coln_L3_5 0 NSYN W=10u L=1u
C_gp_3_5_3 gp_3_5_3 0 {Cg}
Mp_3_5_3 hv_L2_11 gp_3_5_3 colp_L3_5 0 NSYN W=10u L=1u
Mn_3_5_3 hv_L2_11 vcn coln_L3_5 0 NSYN W=10u L=1u
C_gp_3_5_4 gp_3_5_4 0 {Cg}
Mp_3_5_4 hv_L2_13 gp_3_5_4 colp_L3_5 0 NSYN W=10u L=1u
Mn_3_5_4 hv_L2_13 vcn coln_L3_5 0 NSYN W=10u L=1u
C_gp_3_5_5 gp_3_5_5 0 {Cg}
Mp_3_5_5 hv_L2_17 gp_3_5_5 colp_L3_5 0 NSYN W=10u L=1u
Mn_3_5_5 hv_L2_17 vcn coln_L3_5 0 NSYN W=10u L=1u
C_gp_3_5_6 gp_3_5_6 0 {Cg}
Mp_3_5_6 hv_L2_26 gp_3_5_6 colp_L3_5 0 NSYN W=10u L=1u
Mn_3_5_6 hv_L2_26 vcn coln_L3_5 0 NSYN W=10u L=1u
C_gp_3_5_7 gp_3_5_7 0 {Cg}
Mp_3_5_7 hv_L2_28 gp_3_5_7 colp_L3_5 0 NSYN W=10u L=1u
Mn_3_5_7 hv_L2_28 vcn coln_L3_5 0 NSYN W=10u L=1u
C_gp_3_5_8 gp_3_5_8 0 {Cg}
Mp_3_5_8 hv_L2_30 gp_3_5_8 colp_L3_5 0 NSYN W=10u L=1u
Mn_3_5_8 hv_L2_30 vcn coln_L3_5 0 NSYN W=10u L=1u
C_gp_3_5_9 gp_3_5_9 0 {Cg}
Mp_3_5_9 hv_L2_34 gp_3_5_9 colp_L3_5 0 NSYN W=10u L=1u
Mn_3_5_9 hv_L2_34 vcn coln_L3_5 0 NSYN W=10u L=1u
C_gp_3_5_10 gp_3_5_10 0 {Cg}
Mp_3_5_10 hv_L2_35 gp_3_5_10 colp_L3_5 0 NSYN W=10u L=1u
Mn_3_5_10 hv_L2_35 vcn coln_L3_5 0 NSYN W=10u L=1u
C_gp_3_5_11 gp_3_5_11 0 {Cg}
Mp_3_5_11 hv_L2_38 gp_3_5_11 colp_L3_5 0 NSYN W=10u L=1u
Mn_3_5_11 hv_L2_38 vcn coln_L3_5 0 NSYN W=10u L=1u
C_gp_3_5_12 gp_3_5_12 0 {Cg}
Mp_3_5_12 hv_L2_42 gp_3_5_12 colp_L3_5 0 NSYN W=10u L=1u
Mn_3_5_12 hv_L2_42 vcn coln_L3_5 0 NSYN W=10u L=1u
C_gp_3_5_13 gp_3_5_13 0 {Cg}
Mp_3_5_13 hv_L2_44 gp_3_5_13 colp_L3_5 0 NSYN W=10u L=1u
Mn_3_5_13 hv_L2_44 vcn coln_L3_5 0 NSYN W=10u L=1u
C_gp_3_5_14 gp_3_5_14 0 {Cg}
Mp_3_5_14 hv_L2_45 gp_3_5_14 colp_L3_5 0 NSYN W=10u L=1u
Mn_3_5_14 hv_L2_45 vcn coln_L3_5 0 NSYN W=10u L=1u
C_gp_3_5_15 gp_3_5_15 0 {Cg}
Mp_3_5_15 hv_L2_47 gp_3_5_15 colp_L3_5 0 NSYN W=10u L=1u
Mn_3_5_15 hv_L2_47 vcn coln_L3_5 0 NSYN W=10u L=1u
C_gp_3_5_b gp_3_5_b 0 {Cg}
Mp_3_5_b bx gp_3_5_b colp_L3_5 0 NSYN W=10u L=1u
Mn_3_5_b bx vcn coln_L3_5 0 NSYN W=10u L=1u
Msa_h_L3_5 coln_L3_5 coln_L3_5 0 0 NMIR W=20u L=1u
Msb_h_L3_5 z_L3_5 coln_L3_5 0 0 NMIR W=20u L=1u
Msc_h_L3_5 colp_L3_5 colp_L3_5 0 0 NMIR W=20u L=1u
Msd_h_L3_5 dpf_h_L3_5 colp_L3_5 0 0 NMIR W=20u L=1u
Mse_h_L3_5 dpf_h_L3_5 dpf_h_L3_5 vdd vdd PMIR W=60u L=1u
Msf_h_L3_5 z_L3_5 dpf_h_L3_5 vdd vdd PMIR W=60u L=1u
R_h_L3_5 z_L3_5 vrefh 8000.0
Mr_L3_5  hdd_L3_5 z_L3_5 tail_L3_5 0 NREL W=12u L=1u
Mr2_L3_5 dmp_L3_5  vmid  tail_L3_5 0 NREL W=12u L=1u
Mtl_L3_5 tail_L3_5 vtb 0 0 NREL W=32.0u L=1u
Mdm_L3_5 dmp_L3_5 dmp_L3_5 vdd vdd PMIR W=40u L=1u
Mrp1_L3_5 hdd_L3_5 hdd_L3_5 vdd vdd PMIR W=40u L=1u
Mrp2_L3_5 hv_L3_5 hdd_L3_5 vdd vdd PMIR W=40u L=1u
Rhv_L3_5 hv_L3_5 vg0 8000.0
C_gp_3_6_0 gp_3_6_0 0 {Cg}
Mp_3_6_0 hv_L2_1 gp_3_6_0 colp_L3_6 0 NSYN W=10u L=1u
Mn_3_6_0 hv_L2_1 vcn coln_L3_6 0 NSYN W=10u L=1u
C_gp_3_6_1 gp_3_6_1 0 {Cg}
Mp_3_6_1 hv_L2_5 gp_3_6_1 colp_L3_6 0 NSYN W=10u L=1u
Mn_3_6_1 hv_L2_5 vcn coln_L3_6 0 NSYN W=10u L=1u
C_gp_3_6_2 gp_3_6_2 0 {Cg}
Mp_3_6_2 hv_L2_10 gp_3_6_2 colp_L3_6 0 NSYN W=10u L=1u
Mn_3_6_2 hv_L2_10 vcn coln_L3_6 0 NSYN W=10u L=1u
C_gp_3_6_3 gp_3_6_3 0 {Cg}
Mp_3_6_3 hv_L2_11 gp_3_6_3 colp_L3_6 0 NSYN W=10u L=1u
Mn_3_6_3 hv_L2_11 vcn coln_L3_6 0 NSYN W=10u L=1u
C_gp_3_6_4 gp_3_6_4 0 {Cg}
Mp_3_6_4 hv_L2_12 gp_3_6_4 colp_L3_6 0 NSYN W=10u L=1u
Mn_3_6_4 hv_L2_12 vcn coln_L3_6 0 NSYN W=10u L=1u
C_gp_3_6_5 gp_3_6_5 0 {Cg}
Mp_3_6_5 hv_L2_14 gp_3_6_5 colp_L3_6 0 NSYN W=10u L=1u
Mn_3_6_5 hv_L2_14 vcn coln_L3_6 0 NSYN W=10u L=1u
C_gp_3_6_6 gp_3_6_6 0 {Cg}
Mp_3_6_6 hv_L2_15 gp_3_6_6 colp_L3_6 0 NSYN W=10u L=1u
Mn_3_6_6 hv_L2_15 vcn coln_L3_6 0 NSYN W=10u L=1u
C_gp_3_6_7 gp_3_6_7 0 {Cg}
Mp_3_6_7 hv_L2_16 gp_3_6_7 colp_L3_6 0 NSYN W=10u L=1u
Mn_3_6_7 hv_L2_16 vcn coln_L3_6 0 NSYN W=10u L=1u
C_gp_3_6_8 gp_3_6_8 0 {Cg}
Mp_3_6_8 hv_L2_18 gp_3_6_8 colp_L3_6 0 NSYN W=10u L=1u
Mn_3_6_8 hv_L2_18 vcn coln_L3_6 0 NSYN W=10u L=1u
C_gp_3_6_9 gp_3_6_9 0 {Cg}
Mp_3_6_9 hv_L2_21 gp_3_6_9 colp_L3_6 0 NSYN W=10u L=1u
Mn_3_6_9 hv_L2_21 vcn coln_L3_6 0 NSYN W=10u L=1u
C_gp_3_6_10 gp_3_6_10 0 {Cg}
Mp_3_6_10 hv_L2_24 gp_3_6_10 colp_L3_6 0 NSYN W=10u L=1u
Mn_3_6_10 hv_L2_24 vcn coln_L3_6 0 NSYN W=10u L=1u
C_gp_3_6_11 gp_3_6_11 0 {Cg}
Mp_3_6_11 hv_L2_30 gp_3_6_11 colp_L3_6 0 NSYN W=10u L=1u
Mn_3_6_11 hv_L2_30 vcn coln_L3_6 0 NSYN W=10u L=1u
C_gp_3_6_12 gp_3_6_12 0 {Cg}
Mp_3_6_12 hv_L2_33 gp_3_6_12 colp_L3_6 0 NSYN W=10u L=1u
Mn_3_6_12 hv_L2_33 vcn coln_L3_6 0 NSYN W=10u L=1u
C_gp_3_6_13 gp_3_6_13 0 {Cg}
Mp_3_6_13 hv_L2_40 gp_3_6_13 colp_L3_6 0 NSYN W=10u L=1u
Mn_3_6_13 hv_L2_40 vcn coln_L3_6 0 NSYN W=10u L=1u
C_gp_3_6_14 gp_3_6_14 0 {Cg}
Mp_3_6_14 hv_L2_41 gp_3_6_14 colp_L3_6 0 NSYN W=10u L=1u
Mn_3_6_14 hv_L2_41 vcn coln_L3_6 0 NSYN W=10u L=1u
C_gp_3_6_15 gp_3_6_15 0 {Cg}
Mp_3_6_15 hv_L2_43 gp_3_6_15 colp_L3_6 0 NSYN W=10u L=1u
Mn_3_6_15 hv_L2_43 vcn coln_L3_6 0 NSYN W=10u L=1u
C_gp_3_6_b gp_3_6_b 0 {Cg}
Mp_3_6_b bx gp_3_6_b colp_L3_6 0 NSYN W=10u L=1u
Mn_3_6_b bx vcn coln_L3_6 0 NSYN W=10u L=1u
Msa_h_L3_6 coln_L3_6 coln_L3_6 0 0 NMIR W=20u L=1u
Msb_h_L3_6 z_L3_6 coln_L3_6 0 0 NMIR W=20u L=1u
Msc_h_L3_6 colp_L3_6 colp_L3_6 0 0 NMIR W=20u L=1u
Msd_h_L3_6 dpf_h_L3_6 colp_L3_6 0 0 NMIR W=20u L=1u
Mse_h_L3_6 dpf_h_L3_6 dpf_h_L3_6 vdd vdd PMIR W=60u L=1u
Msf_h_L3_6 z_L3_6 dpf_h_L3_6 vdd vdd PMIR W=60u L=1u
R_h_L3_6 z_L3_6 vrefh 8000.0
Mr_L3_6  hdd_L3_6 z_L3_6 tail_L3_6 0 NREL W=12u L=1u
Mr2_L3_6 dmp_L3_6  vmid  tail_L3_6 0 NREL W=12u L=1u
Mtl_L3_6 tail_L3_6 vtb 0 0 NREL W=32.0u L=1u
Mdm_L3_6 dmp_L3_6 dmp_L3_6 vdd vdd PMIR W=40u L=1u
Mrp1_L3_6 hdd_L3_6 hdd_L3_6 vdd vdd PMIR W=40u L=1u
Mrp2_L3_6 hv_L3_6 hdd_L3_6 vdd vdd PMIR W=40u L=1u
Rhv_L3_6 hv_L3_6 vg0 8000.0
C_gp_3_7_0 gp_3_7_0 0 {Cg}
Mp_3_7_0 hv_L2_0 gp_3_7_0 colp_L3_7 0 NSYN W=10u L=1u
Mn_3_7_0 hv_L2_0 vcn coln_L3_7 0 NSYN W=10u L=1u
C_gp_3_7_1 gp_3_7_1 0 {Cg}
Mp_3_7_1 hv_L2_4 gp_3_7_1 colp_L3_7 0 NSYN W=10u L=1u
Mn_3_7_1 hv_L2_4 vcn coln_L3_7 0 NSYN W=10u L=1u
C_gp_3_7_2 gp_3_7_2 0 {Cg}
Mp_3_7_2 hv_L2_7 gp_3_7_2 colp_L3_7 0 NSYN W=10u L=1u
Mn_3_7_2 hv_L2_7 vcn coln_L3_7 0 NSYN W=10u L=1u
C_gp_3_7_3 gp_3_7_3 0 {Cg}
Mp_3_7_3 hv_L2_9 gp_3_7_3 colp_L3_7 0 NSYN W=10u L=1u
Mn_3_7_3 hv_L2_9 vcn coln_L3_7 0 NSYN W=10u L=1u
C_gp_3_7_4 gp_3_7_4 0 {Cg}
Mp_3_7_4 hv_L2_10 gp_3_7_4 colp_L3_7 0 NSYN W=10u L=1u
Mn_3_7_4 hv_L2_10 vcn coln_L3_7 0 NSYN W=10u L=1u
C_gp_3_7_5 gp_3_7_5 0 {Cg}
Mp_3_7_5 hv_L2_11 gp_3_7_5 colp_L3_7 0 NSYN W=10u L=1u
Mn_3_7_5 hv_L2_11 vcn coln_L3_7 0 NSYN W=10u L=1u
C_gp_3_7_6 gp_3_7_6 0 {Cg}
Mp_3_7_6 hv_L2_13 gp_3_7_6 colp_L3_7 0 NSYN W=10u L=1u
Mn_3_7_6 hv_L2_13 vcn coln_L3_7 0 NSYN W=10u L=1u
C_gp_3_7_7 gp_3_7_7 0 {Cg}
Mp_3_7_7 hv_L2_17 gp_3_7_7 colp_L3_7 0 NSYN W=10u L=1u
Mn_3_7_7 hv_L2_17 vcn coln_L3_7 0 NSYN W=10u L=1u
C_gp_3_7_8 gp_3_7_8 0 {Cg}
Mp_3_7_8 hv_L2_18 gp_3_7_8 colp_L3_7 0 NSYN W=10u L=1u
Mn_3_7_8 hv_L2_18 vcn coln_L3_7 0 NSYN W=10u L=1u
C_gp_3_7_9 gp_3_7_9 0 {Cg}
Mp_3_7_9 hv_L2_21 gp_3_7_9 colp_L3_7 0 NSYN W=10u L=1u
Mn_3_7_9 hv_L2_21 vcn coln_L3_7 0 NSYN W=10u L=1u
C_gp_3_7_10 gp_3_7_10 0 {Cg}
Mp_3_7_10 hv_L2_24 gp_3_7_10 colp_L3_7 0 NSYN W=10u L=1u
Mn_3_7_10 hv_L2_24 vcn coln_L3_7 0 NSYN W=10u L=1u
C_gp_3_7_11 gp_3_7_11 0 {Cg}
Mp_3_7_11 hv_L2_26 gp_3_7_11 colp_L3_7 0 NSYN W=10u L=1u
Mn_3_7_11 hv_L2_26 vcn coln_L3_7 0 NSYN W=10u L=1u
C_gp_3_7_12 gp_3_7_12 0 {Cg}
Mp_3_7_12 hv_L2_34 gp_3_7_12 colp_L3_7 0 NSYN W=10u L=1u
Mn_3_7_12 hv_L2_34 vcn coln_L3_7 0 NSYN W=10u L=1u
C_gp_3_7_13 gp_3_7_13 0 {Cg}
Mp_3_7_13 hv_L2_39 gp_3_7_13 colp_L3_7 0 NSYN W=10u L=1u
Mn_3_7_13 hv_L2_39 vcn coln_L3_7 0 NSYN W=10u L=1u
C_gp_3_7_14 gp_3_7_14 0 {Cg}
Mp_3_7_14 hv_L2_45 gp_3_7_14 colp_L3_7 0 NSYN W=10u L=1u
Mn_3_7_14 hv_L2_45 vcn coln_L3_7 0 NSYN W=10u L=1u
C_gp_3_7_15 gp_3_7_15 0 {Cg}
Mp_3_7_15 hv_L2_46 gp_3_7_15 colp_L3_7 0 NSYN W=10u L=1u
Mn_3_7_15 hv_L2_46 vcn coln_L3_7 0 NSYN W=10u L=1u
C_gp_3_7_b gp_3_7_b 0 {Cg}
Mp_3_7_b bx gp_3_7_b colp_L3_7 0 NSYN W=10u L=1u
Mn_3_7_b bx vcn coln_L3_7 0 NSYN W=10u L=1u
Msa_h_L3_7 coln_L3_7 coln_L3_7 0 0 NMIR W=20u L=1u
Msb_h_L3_7 z_L3_7 coln_L3_7 0 0 NMIR W=20u L=1u
Msc_h_L3_7 colp_L3_7 colp_L3_7 0 0 NMIR W=20u L=1u
Msd_h_L3_7 dpf_h_L3_7 colp_L3_7 0 0 NMIR W=20u L=1u
Mse_h_L3_7 dpf_h_L3_7 dpf_h_L3_7 vdd vdd PMIR W=60u L=1u
Msf_h_L3_7 z_L3_7 dpf_h_L3_7 vdd vdd PMIR W=60u L=1u
R_h_L3_7 z_L3_7 vrefh 8000.0
Mr_L3_7  hdd_L3_7 z_L3_7 tail_L3_7 0 NREL W=12u L=1u
Mr2_L3_7 dmp_L3_7  vmid  tail_L3_7 0 NREL W=12u L=1u
Mtl_L3_7 tail_L3_7 vtb 0 0 NREL W=32.0u L=1u
Mdm_L3_7 dmp_L3_7 dmp_L3_7 vdd vdd PMIR W=40u L=1u
Mrp1_L3_7 hdd_L3_7 hdd_L3_7 vdd vdd PMIR W=40u L=1u
Mrp2_L3_7 hv_L3_7 hdd_L3_7 vdd vdd PMIR W=40u L=1u
Rhv_L3_7 hv_L3_7 vg0 8000.0
C_gp_3_8_0 gp_3_8_0 0 {Cg}
Mp_3_8_0 hv_L2_5 gp_3_8_0 colp_L3_8 0 NSYN W=10u L=1u
Mn_3_8_0 hv_L2_5 vcn coln_L3_8 0 NSYN W=10u L=1u
C_gp_3_8_1 gp_3_8_1 0 {Cg}
Mp_3_8_1 hv_L2_6 gp_3_8_1 colp_L3_8 0 NSYN W=10u L=1u
Mn_3_8_1 hv_L2_6 vcn coln_L3_8 0 NSYN W=10u L=1u
C_gp_3_8_2 gp_3_8_2 0 {Cg}
Mp_3_8_2 hv_L2_12 gp_3_8_2 colp_L3_8 0 NSYN W=10u L=1u
Mn_3_8_2 hv_L2_12 vcn coln_L3_8 0 NSYN W=10u L=1u
C_gp_3_8_3 gp_3_8_3 0 {Cg}
Mp_3_8_3 hv_L2_14 gp_3_8_3 colp_L3_8 0 NSYN W=10u L=1u
Mn_3_8_3 hv_L2_14 vcn coln_L3_8 0 NSYN W=10u L=1u
C_gp_3_8_4 gp_3_8_4 0 {Cg}
Mp_3_8_4 hv_L2_16 gp_3_8_4 colp_L3_8 0 NSYN W=10u L=1u
Mn_3_8_4 hv_L2_16 vcn coln_L3_8 0 NSYN W=10u L=1u
C_gp_3_8_5 gp_3_8_5 0 {Cg}
Mp_3_8_5 hv_L2_18 gp_3_8_5 colp_L3_8 0 NSYN W=10u L=1u
Mn_3_8_5 hv_L2_18 vcn coln_L3_8 0 NSYN W=10u L=1u
C_gp_3_8_6 gp_3_8_6 0 {Cg}
Mp_3_8_6 hv_L2_21 gp_3_8_6 colp_L3_8 0 NSYN W=10u L=1u
Mn_3_8_6 hv_L2_21 vcn coln_L3_8 0 NSYN W=10u L=1u
C_gp_3_8_7 gp_3_8_7 0 {Cg}
Mp_3_8_7 hv_L2_23 gp_3_8_7 colp_L3_8 0 NSYN W=10u L=1u
Mn_3_8_7 hv_L2_23 vcn coln_L3_8 0 NSYN W=10u L=1u
C_gp_3_8_8 gp_3_8_8 0 {Cg}
Mp_3_8_8 hv_L2_24 gp_3_8_8 colp_L3_8 0 NSYN W=10u L=1u
Mn_3_8_8 hv_L2_24 vcn coln_L3_8 0 NSYN W=10u L=1u
C_gp_3_8_9 gp_3_8_9 0 {Cg}
Mp_3_8_9 hv_L2_26 gp_3_8_9 colp_L3_8 0 NSYN W=10u L=1u
Mn_3_8_9 hv_L2_26 vcn coln_L3_8 0 NSYN W=10u L=1u
C_gp_3_8_10 gp_3_8_10 0 {Cg}
Mp_3_8_10 hv_L2_28 gp_3_8_10 colp_L3_8 0 NSYN W=10u L=1u
Mn_3_8_10 hv_L2_28 vcn coln_L3_8 0 NSYN W=10u L=1u
C_gp_3_8_11 gp_3_8_11 0 {Cg}
Mp_3_8_11 hv_L2_35 gp_3_8_11 colp_L3_8 0 NSYN W=10u L=1u
Mn_3_8_11 hv_L2_35 vcn coln_L3_8 0 NSYN W=10u L=1u
C_gp_3_8_12 gp_3_8_12 0 {Cg}
Mp_3_8_12 hv_L2_37 gp_3_8_12 colp_L3_8 0 NSYN W=10u L=1u
Mn_3_8_12 hv_L2_37 vcn coln_L3_8 0 NSYN W=10u L=1u
C_gp_3_8_13 gp_3_8_13 0 {Cg}
Mp_3_8_13 hv_L2_39 gp_3_8_13 colp_L3_8 0 NSYN W=10u L=1u
Mn_3_8_13 hv_L2_39 vcn coln_L3_8 0 NSYN W=10u L=1u
C_gp_3_8_14 gp_3_8_14 0 {Cg}
Mp_3_8_14 hv_L2_41 gp_3_8_14 colp_L3_8 0 NSYN W=10u L=1u
Mn_3_8_14 hv_L2_41 vcn coln_L3_8 0 NSYN W=10u L=1u
C_gp_3_8_15 gp_3_8_15 0 {Cg}
Mp_3_8_15 hv_L2_43 gp_3_8_15 colp_L3_8 0 NSYN W=10u L=1u
Mn_3_8_15 hv_L2_43 vcn coln_L3_8 0 NSYN W=10u L=1u
C_gp_3_8_b gp_3_8_b 0 {Cg}
Mp_3_8_b bx gp_3_8_b colp_L3_8 0 NSYN W=10u L=1u
Mn_3_8_b bx vcn coln_L3_8 0 NSYN W=10u L=1u
Msa_h_L3_8 coln_L3_8 coln_L3_8 0 0 NMIR W=20u L=1u
Msb_h_L3_8 z_L3_8 coln_L3_8 0 0 NMIR W=20u L=1u
Msc_h_L3_8 colp_L3_8 colp_L3_8 0 0 NMIR W=20u L=1u
Msd_h_L3_8 dpf_h_L3_8 colp_L3_8 0 0 NMIR W=20u L=1u
Mse_h_L3_8 dpf_h_L3_8 dpf_h_L3_8 vdd vdd PMIR W=60u L=1u
Msf_h_L3_8 z_L3_8 dpf_h_L3_8 vdd vdd PMIR W=60u L=1u
R_h_L3_8 z_L3_8 vrefh 8000.0
Mr_L3_8  hdd_L3_8 z_L3_8 tail_L3_8 0 NREL W=12u L=1u
Mr2_L3_8 dmp_L3_8  vmid  tail_L3_8 0 NREL W=12u L=1u
Mtl_L3_8 tail_L3_8 vtb 0 0 NREL W=32.0u L=1u
Mdm_L3_8 dmp_L3_8 dmp_L3_8 vdd vdd PMIR W=40u L=1u
Mrp1_L3_8 hdd_L3_8 hdd_L3_8 vdd vdd PMIR W=40u L=1u
Mrp2_L3_8 hv_L3_8 hdd_L3_8 vdd vdd PMIR W=40u L=1u
Rhv_L3_8 hv_L3_8 vg0 8000.0
C_gp_3_9_0 gp_3_9_0 0 {Cg}
Mp_3_9_0 hv_L2_1 gp_3_9_0 colp_L3_9 0 NSYN W=10u L=1u
Mn_3_9_0 hv_L2_1 vcn coln_L3_9 0 NSYN W=10u L=1u
C_gp_3_9_1 gp_3_9_1 0 {Cg}
Mp_3_9_1 hv_L2_5 gp_3_9_1 colp_L3_9 0 NSYN W=10u L=1u
Mn_3_9_1 hv_L2_5 vcn coln_L3_9 0 NSYN W=10u L=1u
C_gp_3_9_2 gp_3_9_2 0 {Cg}
Mp_3_9_2 hv_L2_6 gp_3_9_2 colp_L3_9 0 NSYN W=10u L=1u
Mn_3_9_2 hv_L2_6 vcn coln_L3_9 0 NSYN W=10u L=1u
C_gp_3_9_3 gp_3_9_3 0 {Cg}
Mp_3_9_3 hv_L2_11 gp_3_9_3 colp_L3_9 0 NSYN W=10u L=1u
Mn_3_9_3 hv_L2_11 vcn coln_L3_9 0 NSYN W=10u L=1u
C_gp_3_9_4 gp_3_9_4 0 {Cg}
Mp_3_9_4 hv_L2_17 gp_3_9_4 colp_L3_9 0 NSYN W=10u L=1u
Mn_3_9_4 hv_L2_17 vcn coln_L3_9 0 NSYN W=10u L=1u
C_gp_3_9_5 gp_3_9_5 0 {Cg}
Mp_3_9_5 hv_L2_18 gp_3_9_5 colp_L3_9 0 NSYN W=10u L=1u
Mn_3_9_5 hv_L2_18 vcn coln_L3_9 0 NSYN W=10u L=1u
C_gp_3_9_6 gp_3_9_6 0 {Cg}
Mp_3_9_6 hv_L2_24 gp_3_9_6 colp_L3_9 0 NSYN W=10u L=1u
Mn_3_9_6 hv_L2_24 vcn coln_L3_9 0 NSYN W=10u L=1u
C_gp_3_9_7 gp_3_9_7 0 {Cg}
Mp_3_9_7 hv_L2_26 gp_3_9_7 colp_L3_9 0 NSYN W=10u L=1u
Mn_3_9_7 hv_L2_26 vcn coln_L3_9 0 NSYN W=10u L=1u
C_gp_3_9_8 gp_3_9_8 0 {Cg}
Mp_3_9_8 hv_L2_28 gp_3_9_8 colp_L3_9 0 NSYN W=10u L=1u
Mn_3_9_8 hv_L2_28 vcn coln_L3_9 0 NSYN W=10u L=1u
C_gp_3_9_9 gp_3_9_9 0 {Cg}
Mp_3_9_9 hv_L2_32 gp_3_9_9 colp_L3_9 0 NSYN W=10u L=1u
Mn_3_9_9 hv_L2_32 vcn coln_L3_9 0 NSYN W=10u L=1u
C_gp_3_9_10 gp_3_9_10 0 {Cg}
Mp_3_9_10 hv_L2_37 gp_3_9_10 colp_L3_9 0 NSYN W=10u L=1u
Mn_3_9_10 hv_L2_37 vcn coln_L3_9 0 NSYN W=10u L=1u
C_gp_3_9_11 gp_3_9_11 0 {Cg}
Mp_3_9_11 hv_L2_39 gp_3_9_11 colp_L3_9 0 NSYN W=10u L=1u
Mn_3_9_11 hv_L2_39 vcn coln_L3_9 0 NSYN W=10u L=1u
C_gp_3_9_12 gp_3_9_12 0 {Cg}
Mp_3_9_12 hv_L2_41 gp_3_9_12 colp_L3_9 0 NSYN W=10u L=1u
Mn_3_9_12 hv_L2_41 vcn coln_L3_9 0 NSYN W=10u L=1u
C_gp_3_9_13 gp_3_9_13 0 {Cg}
Mp_3_9_13 hv_L2_42 gp_3_9_13 colp_L3_9 0 NSYN W=10u L=1u
Mn_3_9_13 hv_L2_42 vcn coln_L3_9 0 NSYN W=10u L=1u
C_gp_3_9_14 gp_3_9_14 0 {Cg}
Mp_3_9_14 hv_L2_44 gp_3_9_14 colp_L3_9 0 NSYN W=10u L=1u
Mn_3_9_14 hv_L2_44 vcn coln_L3_9 0 NSYN W=10u L=1u
C_gp_3_9_15 gp_3_9_15 0 {Cg}
Mp_3_9_15 hv_L2_47 gp_3_9_15 colp_L3_9 0 NSYN W=10u L=1u
Mn_3_9_15 hv_L2_47 vcn coln_L3_9 0 NSYN W=10u L=1u
C_gp_3_9_b gp_3_9_b 0 {Cg}
Mp_3_9_b bx gp_3_9_b colp_L3_9 0 NSYN W=10u L=1u
Mn_3_9_b bx vcn coln_L3_9 0 NSYN W=10u L=1u
Msa_h_L3_9 coln_L3_9 coln_L3_9 0 0 NMIR W=20u L=1u
Msb_h_L3_9 z_L3_9 coln_L3_9 0 0 NMIR W=20u L=1u
Msc_h_L3_9 colp_L3_9 colp_L3_9 0 0 NMIR W=20u L=1u
Msd_h_L3_9 dpf_h_L3_9 colp_L3_9 0 0 NMIR W=20u L=1u
Mse_h_L3_9 dpf_h_L3_9 dpf_h_L3_9 vdd vdd PMIR W=60u L=1u
Msf_h_L3_9 z_L3_9 dpf_h_L3_9 vdd vdd PMIR W=60u L=1u
R_h_L3_9 z_L3_9 vrefh 8000.0
Mr_L3_9  hdd_L3_9 z_L3_9 tail_L3_9 0 NREL W=12u L=1u
Mr2_L3_9 dmp_L3_9  vmid  tail_L3_9 0 NREL W=12u L=1u
Mtl_L3_9 tail_L3_9 vtb 0 0 NREL W=32.0u L=1u
Mdm_L3_9 dmp_L3_9 dmp_L3_9 vdd vdd PMIR W=40u L=1u
Mrp1_L3_9 hdd_L3_9 hdd_L3_9 vdd vdd PMIR W=40u L=1u
Mrp2_L3_9 hv_L3_9 hdd_L3_9 vdd vdd PMIR W=40u L=1u
Rhv_L3_9 hv_L3_9 vg0 8000.0
C_gp_3_10_0 gp_3_10_0 0 {Cg}
Mp_3_10_0 hv_L2_8 gp_3_10_0 colp_L3_10 0 NSYN W=10u L=1u
Mn_3_10_0 hv_L2_8 vcn coln_L3_10 0 NSYN W=10u L=1u
C_gp_3_10_1 gp_3_10_1 0 {Cg}
Mp_3_10_1 hv_L2_9 gp_3_10_1 colp_L3_10 0 NSYN W=10u L=1u
Mn_3_10_1 hv_L2_9 vcn coln_L3_10 0 NSYN W=10u L=1u
C_gp_3_10_2 gp_3_10_2 0 {Cg}
Mp_3_10_2 hv_L2_10 gp_3_10_2 colp_L3_10 0 NSYN W=10u L=1u
Mn_3_10_2 hv_L2_10 vcn coln_L3_10 0 NSYN W=10u L=1u
C_gp_3_10_3 gp_3_10_3 0 {Cg}
Mp_3_10_3 hv_L2_11 gp_3_10_3 colp_L3_10 0 NSYN W=10u L=1u
Mn_3_10_3 hv_L2_11 vcn coln_L3_10 0 NSYN W=10u L=1u
C_gp_3_10_4 gp_3_10_4 0 {Cg}
Mp_3_10_4 hv_L2_15 gp_3_10_4 colp_L3_10 0 NSYN W=10u L=1u
Mn_3_10_4 hv_L2_15 vcn coln_L3_10 0 NSYN W=10u L=1u
C_gp_3_10_5 gp_3_10_5 0 {Cg}
Mp_3_10_5 hv_L2_20 gp_3_10_5 colp_L3_10 0 NSYN W=10u L=1u
Mn_3_10_5 hv_L2_20 vcn coln_L3_10 0 NSYN W=10u L=1u
C_gp_3_10_6 gp_3_10_6 0 {Cg}
Mp_3_10_6 hv_L2_23 gp_3_10_6 colp_L3_10 0 NSYN W=10u L=1u
Mn_3_10_6 hv_L2_23 vcn coln_L3_10 0 NSYN W=10u L=1u
C_gp_3_10_7 gp_3_10_7 0 {Cg}
Mp_3_10_7 hv_L2_24 gp_3_10_7 colp_L3_10 0 NSYN W=10u L=1u
Mn_3_10_7 hv_L2_24 vcn coln_L3_10 0 NSYN W=10u L=1u
C_gp_3_10_8 gp_3_10_8 0 {Cg}
Mp_3_10_8 hv_L2_29 gp_3_10_8 colp_L3_10 0 NSYN W=10u L=1u
Mn_3_10_8 hv_L2_29 vcn coln_L3_10 0 NSYN W=10u L=1u
C_gp_3_10_9 gp_3_10_9 0 {Cg}
Mp_3_10_9 hv_L2_33 gp_3_10_9 colp_L3_10 0 NSYN W=10u L=1u
Mn_3_10_9 hv_L2_33 vcn coln_L3_10 0 NSYN W=10u L=1u
C_gp_3_10_10 gp_3_10_10 0 {Cg}
Mp_3_10_10 hv_L2_34 gp_3_10_10 colp_L3_10 0 NSYN W=10u L=1u
Mn_3_10_10 hv_L2_34 vcn coln_L3_10 0 NSYN W=10u L=1u
C_gp_3_10_11 gp_3_10_11 0 {Cg}
Mp_3_10_11 hv_L2_37 gp_3_10_11 colp_L3_10 0 NSYN W=10u L=1u
Mn_3_10_11 hv_L2_37 vcn coln_L3_10 0 NSYN W=10u L=1u
C_gp_3_10_12 gp_3_10_12 0 {Cg}
Mp_3_10_12 hv_L2_40 gp_3_10_12 colp_L3_10 0 NSYN W=10u L=1u
Mn_3_10_12 hv_L2_40 vcn coln_L3_10 0 NSYN W=10u L=1u
C_gp_3_10_13 gp_3_10_13 0 {Cg}
Mp_3_10_13 hv_L2_41 gp_3_10_13 colp_L3_10 0 NSYN W=10u L=1u
Mn_3_10_13 hv_L2_41 vcn coln_L3_10 0 NSYN W=10u L=1u
C_gp_3_10_14 gp_3_10_14 0 {Cg}
Mp_3_10_14 hv_L2_44 gp_3_10_14 colp_L3_10 0 NSYN W=10u L=1u
Mn_3_10_14 hv_L2_44 vcn coln_L3_10 0 NSYN W=10u L=1u
C_gp_3_10_15 gp_3_10_15 0 {Cg}
Mp_3_10_15 hv_L2_46 gp_3_10_15 colp_L3_10 0 NSYN W=10u L=1u
Mn_3_10_15 hv_L2_46 vcn coln_L3_10 0 NSYN W=10u L=1u
C_gp_3_10_b gp_3_10_b 0 {Cg}
Mp_3_10_b bx gp_3_10_b colp_L3_10 0 NSYN W=10u L=1u
Mn_3_10_b bx vcn coln_L3_10 0 NSYN W=10u L=1u
Msa_h_L3_10 coln_L3_10 coln_L3_10 0 0 NMIR W=20u L=1u
Msb_h_L3_10 z_L3_10 coln_L3_10 0 0 NMIR W=20u L=1u
Msc_h_L3_10 colp_L3_10 colp_L3_10 0 0 NMIR W=20u L=1u
Msd_h_L3_10 dpf_h_L3_10 colp_L3_10 0 0 NMIR W=20u L=1u
Mse_h_L3_10 dpf_h_L3_10 dpf_h_L3_10 vdd vdd PMIR W=60u L=1u
Msf_h_L3_10 z_L3_10 dpf_h_L3_10 vdd vdd PMIR W=60u L=1u
R_h_L3_10 z_L3_10 vrefh 8000.0
Mr_L3_10  hdd_L3_10 z_L3_10 tail_L3_10 0 NREL W=12u L=1u
Mr2_L3_10 dmp_L3_10  vmid  tail_L3_10 0 NREL W=12u L=1u
Mtl_L3_10 tail_L3_10 vtb 0 0 NREL W=32.0u L=1u
Mdm_L3_10 dmp_L3_10 dmp_L3_10 vdd vdd PMIR W=40u L=1u
Mrp1_L3_10 hdd_L3_10 hdd_L3_10 vdd vdd PMIR W=40u L=1u
Mrp2_L3_10 hv_L3_10 hdd_L3_10 vdd vdd PMIR W=40u L=1u
Rhv_L3_10 hv_L3_10 vg0 8000.0
C_gp_3_11_0 gp_3_11_0 0 {Cg}
Mp_3_11_0 hv_L2_1 gp_3_11_0 colp_L3_11 0 NSYN W=10u L=1u
Mn_3_11_0 hv_L2_1 vcn coln_L3_11 0 NSYN W=10u L=1u
C_gp_3_11_1 gp_3_11_1 0 {Cg}
Mp_3_11_1 hv_L2_2 gp_3_11_1 colp_L3_11 0 NSYN W=10u L=1u
Mn_3_11_1 hv_L2_2 vcn coln_L3_11 0 NSYN W=10u L=1u
C_gp_3_11_2 gp_3_11_2 0 {Cg}
Mp_3_11_2 hv_L2_5 gp_3_11_2 colp_L3_11 0 NSYN W=10u L=1u
Mn_3_11_2 hv_L2_5 vcn coln_L3_11 0 NSYN W=10u L=1u
C_gp_3_11_3 gp_3_11_3 0 {Cg}
Mp_3_11_3 hv_L2_9 gp_3_11_3 colp_L3_11 0 NSYN W=10u L=1u
Mn_3_11_3 hv_L2_9 vcn coln_L3_11 0 NSYN W=10u L=1u
C_gp_3_11_4 gp_3_11_4 0 {Cg}
Mp_3_11_4 hv_L2_13 gp_3_11_4 colp_L3_11 0 NSYN W=10u L=1u
Mn_3_11_4 hv_L2_13 vcn coln_L3_11 0 NSYN W=10u L=1u
C_gp_3_11_5 gp_3_11_5 0 {Cg}
Mp_3_11_5 hv_L2_25 gp_3_11_5 colp_L3_11 0 NSYN W=10u L=1u
Mn_3_11_5 hv_L2_25 vcn coln_L3_11 0 NSYN W=10u L=1u
C_gp_3_11_6 gp_3_11_6 0 {Cg}
Mp_3_11_6 hv_L2_26 gp_3_11_6 colp_L3_11 0 NSYN W=10u L=1u
Mn_3_11_6 hv_L2_26 vcn coln_L3_11 0 NSYN W=10u L=1u
C_gp_3_11_7 gp_3_11_7 0 {Cg}
Mp_3_11_7 hv_L2_27 gp_3_11_7 colp_L3_11 0 NSYN W=10u L=1u
Mn_3_11_7 hv_L2_27 vcn coln_L3_11 0 NSYN W=10u L=1u
C_gp_3_11_8 gp_3_11_8 0 {Cg}
Mp_3_11_8 hv_L2_28 gp_3_11_8 colp_L3_11 0 NSYN W=10u L=1u
Mn_3_11_8 hv_L2_28 vcn coln_L3_11 0 NSYN W=10u L=1u
C_gp_3_11_9 gp_3_11_9 0 {Cg}
Mp_3_11_9 hv_L2_29 gp_3_11_9 colp_L3_11 0 NSYN W=10u L=1u
Mn_3_11_9 hv_L2_29 vcn coln_L3_11 0 NSYN W=10u L=1u
C_gp_3_11_10 gp_3_11_10 0 {Cg}
Mp_3_11_10 hv_L2_30 gp_3_11_10 colp_L3_11 0 NSYN W=10u L=1u
Mn_3_11_10 hv_L2_30 vcn coln_L3_11 0 NSYN W=10u L=1u
C_gp_3_11_11 gp_3_11_11 0 {Cg}
Mp_3_11_11 hv_L2_39 gp_3_11_11 colp_L3_11 0 NSYN W=10u L=1u
Mn_3_11_11 hv_L2_39 vcn coln_L3_11 0 NSYN W=10u L=1u
C_gp_3_11_12 gp_3_11_12 0 {Cg}
Mp_3_11_12 hv_L2_41 gp_3_11_12 colp_L3_11 0 NSYN W=10u L=1u
Mn_3_11_12 hv_L2_41 vcn coln_L3_11 0 NSYN W=10u L=1u
C_gp_3_11_13 gp_3_11_13 0 {Cg}
Mp_3_11_13 hv_L2_42 gp_3_11_13 colp_L3_11 0 NSYN W=10u L=1u
Mn_3_11_13 hv_L2_42 vcn coln_L3_11 0 NSYN W=10u L=1u
C_gp_3_11_14 gp_3_11_14 0 {Cg}
Mp_3_11_14 hv_L2_44 gp_3_11_14 colp_L3_11 0 NSYN W=10u L=1u
Mn_3_11_14 hv_L2_44 vcn coln_L3_11 0 NSYN W=10u L=1u
C_gp_3_11_15 gp_3_11_15 0 {Cg}
Mp_3_11_15 hv_L2_45 gp_3_11_15 colp_L3_11 0 NSYN W=10u L=1u
Mn_3_11_15 hv_L2_45 vcn coln_L3_11 0 NSYN W=10u L=1u
C_gp_3_11_b gp_3_11_b 0 {Cg}
Mp_3_11_b bx gp_3_11_b colp_L3_11 0 NSYN W=10u L=1u
Mn_3_11_b bx vcn coln_L3_11 0 NSYN W=10u L=1u
Msa_h_L3_11 coln_L3_11 coln_L3_11 0 0 NMIR W=20u L=1u
Msb_h_L3_11 z_L3_11 coln_L3_11 0 0 NMIR W=20u L=1u
Msc_h_L3_11 colp_L3_11 colp_L3_11 0 0 NMIR W=20u L=1u
Msd_h_L3_11 dpf_h_L3_11 colp_L3_11 0 0 NMIR W=20u L=1u
Mse_h_L3_11 dpf_h_L3_11 dpf_h_L3_11 vdd vdd PMIR W=60u L=1u
Msf_h_L3_11 z_L3_11 dpf_h_L3_11 vdd vdd PMIR W=60u L=1u
R_h_L3_11 z_L3_11 vrefh 8000.0
Mr_L3_11  hdd_L3_11 z_L3_11 tail_L3_11 0 NREL W=12u L=1u
Mr2_L3_11 dmp_L3_11  vmid  tail_L3_11 0 NREL W=12u L=1u
Mtl_L3_11 tail_L3_11 vtb 0 0 NREL W=32.0u L=1u
Mdm_L3_11 dmp_L3_11 dmp_L3_11 vdd vdd PMIR W=40u L=1u
Mrp1_L3_11 hdd_L3_11 hdd_L3_11 vdd vdd PMIR W=40u L=1u
Mrp2_L3_11 hv_L3_11 hdd_L3_11 vdd vdd PMIR W=40u L=1u
Rhv_L3_11 hv_L3_11 vg0 8000.0
C_gp_3_12_0 gp_3_12_0 0 {Cg}
Mp_3_12_0 hv_L2_7 gp_3_12_0 colp_L3_12 0 NSYN W=10u L=1u
Mn_3_12_0 hv_L2_7 vcn coln_L3_12 0 NSYN W=10u L=1u
C_gp_3_12_1 gp_3_12_1 0 {Cg}
Mp_3_12_1 hv_L2_13 gp_3_12_1 colp_L3_12 0 NSYN W=10u L=1u
Mn_3_12_1 hv_L2_13 vcn coln_L3_12 0 NSYN W=10u L=1u
C_gp_3_12_2 gp_3_12_2 0 {Cg}
Mp_3_12_2 hv_L2_14 gp_3_12_2 colp_L3_12 0 NSYN W=10u L=1u
Mn_3_12_2 hv_L2_14 vcn coln_L3_12 0 NSYN W=10u L=1u
C_gp_3_12_3 gp_3_12_3 0 {Cg}
Mp_3_12_3 hv_L2_23 gp_3_12_3 colp_L3_12 0 NSYN W=10u L=1u
Mn_3_12_3 hv_L2_23 vcn coln_L3_12 0 NSYN W=10u L=1u
C_gp_3_12_4 gp_3_12_4 0 {Cg}
Mp_3_12_4 hv_L2_24 gp_3_12_4 colp_L3_12 0 NSYN W=10u L=1u
Mn_3_12_4 hv_L2_24 vcn coln_L3_12 0 NSYN W=10u L=1u
C_gp_3_12_5 gp_3_12_5 0 {Cg}
Mp_3_12_5 hv_L2_25 gp_3_12_5 colp_L3_12 0 NSYN W=10u L=1u
Mn_3_12_5 hv_L2_25 vcn coln_L3_12 0 NSYN W=10u L=1u
C_gp_3_12_6 gp_3_12_6 0 {Cg}
Mp_3_12_6 hv_L2_29 gp_3_12_6 colp_L3_12 0 NSYN W=10u L=1u
Mn_3_12_6 hv_L2_29 vcn coln_L3_12 0 NSYN W=10u L=1u
C_gp_3_12_7 gp_3_12_7 0 {Cg}
Mp_3_12_7 hv_L2_30 gp_3_12_7 colp_L3_12 0 NSYN W=10u L=1u
Mn_3_12_7 hv_L2_30 vcn coln_L3_12 0 NSYN W=10u L=1u
C_gp_3_12_8 gp_3_12_8 0 {Cg}
Mp_3_12_8 hv_L2_33 gp_3_12_8 colp_L3_12 0 NSYN W=10u L=1u
Mn_3_12_8 hv_L2_33 vcn coln_L3_12 0 NSYN W=10u L=1u
C_gp_3_12_9 gp_3_12_9 0 {Cg}
Mp_3_12_9 hv_L2_34 gp_3_12_9 colp_L3_12 0 NSYN W=10u L=1u
Mn_3_12_9 hv_L2_34 vcn coln_L3_12 0 NSYN W=10u L=1u
C_gp_3_12_10 gp_3_12_10 0 {Cg}
Mp_3_12_10 hv_L2_35 gp_3_12_10 colp_L3_12 0 NSYN W=10u L=1u
Mn_3_12_10 hv_L2_35 vcn coln_L3_12 0 NSYN W=10u L=1u
C_gp_3_12_11 gp_3_12_11 0 {Cg}
Mp_3_12_11 hv_L2_36 gp_3_12_11 colp_L3_12 0 NSYN W=10u L=1u
Mn_3_12_11 hv_L2_36 vcn coln_L3_12 0 NSYN W=10u L=1u
C_gp_3_12_12 gp_3_12_12 0 {Cg}
Mp_3_12_12 hv_L2_38 gp_3_12_12 colp_L3_12 0 NSYN W=10u L=1u
Mn_3_12_12 hv_L2_38 vcn coln_L3_12 0 NSYN W=10u L=1u
C_gp_3_12_13 gp_3_12_13 0 {Cg}
Mp_3_12_13 hv_L2_45 gp_3_12_13 colp_L3_12 0 NSYN W=10u L=1u
Mn_3_12_13 hv_L2_45 vcn coln_L3_12 0 NSYN W=10u L=1u
C_gp_3_12_14 gp_3_12_14 0 {Cg}
Mp_3_12_14 hv_L2_46 gp_3_12_14 colp_L3_12 0 NSYN W=10u L=1u
Mn_3_12_14 hv_L2_46 vcn coln_L3_12 0 NSYN W=10u L=1u
C_gp_3_12_15 gp_3_12_15 0 {Cg}
Mp_3_12_15 hv_L2_47 gp_3_12_15 colp_L3_12 0 NSYN W=10u L=1u
Mn_3_12_15 hv_L2_47 vcn coln_L3_12 0 NSYN W=10u L=1u
C_gp_3_12_b gp_3_12_b 0 {Cg}
Mp_3_12_b bx gp_3_12_b colp_L3_12 0 NSYN W=10u L=1u
Mn_3_12_b bx vcn coln_L3_12 0 NSYN W=10u L=1u
Msa_h_L3_12 coln_L3_12 coln_L3_12 0 0 NMIR W=20u L=1u
Msb_h_L3_12 z_L3_12 coln_L3_12 0 0 NMIR W=20u L=1u
Msc_h_L3_12 colp_L3_12 colp_L3_12 0 0 NMIR W=20u L=1u
Msd_h_L3_12 dpf_h_L3_12 colp_L3_12 0 0 NMIR W=20u L=1u
Mse_h_L3_12 dpf_h_L3_12 dpf_h_L3_12 vdd vdd PMIR W=60u L=1u
Msf_h_L3_12 z_L3_12 dpf_h_L3_12 vdd vdd PMIR W=60u L=1u
R_h_L3_12 z_L3_12 vrefh 8000.0
Mr_L3_12  hdd_L3_12 z_L3_12 tail_L3_12 0 NREL W=12u L=1u
Mr2_L3_12 dmp_L3_12  vmid  tail_L3_12 0 NREL W=12u L=1u
Mtl_L3_12 tail_L3_12 vtb 0 0 NREL W=32.0u L=1u
Mdm_L3_12 dmp_L3_12 dmp_L3_12 vdd vdd PMIR W=40u L=1u
Mrp1_L3_12 hdd_L3_12 hdd_L3_12 vdd vdd PMIR W=40u L=1u
Mrp2_L3_12 hv_L3_12 hdd_L3_12 vdd vdd PMIR W=40u L=1u
Rhv_L3_12 hv_L3_12 vg0 8000.0
C_gp_3_13_0 gp_3_13_0 0 {Cg}
Mp_3_13_0 hv_L2_0 gp_3_13_0 colp_L3_13 0 NSYN W=10u L=1u
Mn_3_13_0 hv_L2_0 vcn coln_L3_13 0 NSYN W=10u L=1u
C_gp_3_13_1 gp_3_13_1 0 {Cg}
Mp_3_13_1 hv_L2_1 gp_3_13_1 colp_L3_13 0 NSYN W=10u L=1u
Mn_3_13_1 hv_L2_1 vcn coln_L3_13 0 NSYN W=10u L=1u
C_gp_3_13_2 gp_3_13_2 0 {Cg}
Mp_3_13_2 hv_L2_3 gp_3_13_2 colp_L3_13 0 NSYN W=10u L=1u
Mn_3_13_2 hv_L2_3 vcn coln_L3_13 0 NSYN W=10u L=1u
C_gp_3_13_3 gp_3_13_3 0 {Cg}
Mp_3_13_3 hv_L2_8 gp_3_13_3 colp_L3_13 0 NSYN W=10u L=1u
Mn_3_13_3 hv_L2_8 vcn coln_L3_13 0 NSYN W=10u L=1u
C_gp_3_13_4 gp_3_13_4 0 {Cg}
Mp_3_13_4 hv_L2_9 gp_3_13_4 colp_L3_13 0 NSYN W=10u L=1u
Mn_3_13_4 hv_L2_9 vcn coln_L3_13 0 NSYN W=10u L=1u
C_gp_3_13_5 gp_3_13_5 0 {Cg}
Mp_3_13_5 hv_L2_16 gp_3_13_5 colp_L3_13 0 NSYN W=10u L=1u
Mn_3_13_5 hv_L2_16 vcn coln_L3_13 0 NSYN W=10u L=1u
C_gp_3_13_6 gp_3_13_6 0 {Cg}
Mp_3_13_6 hv_L2_19 gp_3_13_6 colp_L3_13 0 NSYN W=10u L=1u
Mn_3_13_6 hv_L2_19 vcn coln_L3_13 0 NSYN W=10u L=1u
C_gp_3_13_7 gp_3_13_7 0 {Cg}
Mp_3_13_7 hv_L2_20 gp_3_13_7 colp_L3_13 0 NSYN W=10u L=1u
Mn_3_13_7 hv_L2_20 vcn coln_L3_13 0 NSYN W=10u L=1u
C_gp_3_13_8 gp_3_13_8 0 {Cg}
Mp_3_13_8 hv_L2_22 gp_3_13_8 colp_L3_13 0 NSYN W=10u L=1u
Mn_3_13_8 hv_L2_22 vcn coln_L3_13 0 NSYN W=10u L=1u
C_gp_3_13_9 gp_3_13_9 0 {Cg}
Mp_3_13_9 hv_L2_24 gp_3_13_9 colp_L3_13 0 NSYN W=10u L=1u
Mn_3_13_9 hv_L2_24 vcn coln_L3_13 0 NSYN W=10u L=1u
C_gp_3_13_10 gp_3_13_10 0 {Cg}
Mp_3_13_10 hv_L2_25 gp_3_13_10 colp_L3_13 0 NSYN W=10u L=1u
Mn_3_13_10 hv_L2_25 vcn coln_L3_13 0 NSYN W=10u L=1u
C_gp_3_13_11 gp_3_13_11 0 {Cg}
Mp_3_13_11 hv_L2_32 gp_3_13_11 colp_L3_13 0 NSYN W=10u L=1u
Mn_3_13_11 hv_L2_32 vcn coln_L3_13 0 NSYN W=10u L=1u
C_gp_3_13_12 gp_3_13_12 0 {Cg}
Mp_3_13_12 hv_L2_38 gp_3_13_12 colp_L3_13 0 NSYN W=10u L=1u
Mn_3_13_12 hv_L2_38 vcn coln_L3_13 0 NSYN W=10u L=1u
C_gp_3_13_13 gp_3_13_13 0 {Cg}
Mp_3_13_13 hv_L2_39 gp_3_13_13 colp_L3_13 0 NSYN W=10u L=1u
Mn_3_13_13 hv_L2_39 vcn coln_L3_13 0 NSYN W=10u L=1u
C_gp_3_13_14 gp_3_13_14 0 {Cg}
Mp_3_13_14 hv_L2_41 gp_3_13_14 colp_L3_13 0 NSYN W=10u L=1u
Mn_3_13_14 hv_L2_41 vcn coln_L3_13 0 NSYN W=10u L=1u
C_gp_3_13_15 gp_3_13_15 0 {Cg}
Mp_3_13_15 hv_L2_43 gp_3_13_15 colp_L3_13 0 NSYN W=10u L=1u
Mn_3_13_15 hv_L2_43 vcn coln_L3_13 0 NSYN W=10u L=1u
C_gp_3_13_b gp_3_13_b 0 {Cg}
Mp_3_13_b bx gp_3_13_b colp_L3_13 0 NSYN W=10u L=1u
Mn_3_13_b bx vcn coln_L3_13 0 NSYN W=10u L=1u
Msa_h_L3_13 coln_L3_13 coln_L3_13 0 0 NMIR W=20u L=1u
Msb_h_L3_13 z_L3_13 coln_L3_13 0 0 NMIR W=20u L=1u
Msc_h_L3_13 colp_L3_13 colp_L3_13 0 0 NMIR W=20u L=1u
Msd_h_L3_13 dpf_h_L3_13 colp_L3_13 0 0 NMIR W=20u L=1u
Mse_h_L3_13 dpf_h_L3_13 dpf_h_L3_13 vdd vdd PMIR W=60u L=1u
Msf_h_L3_13 z_L3_13 dpf_h_L3_13 vdd vdd PMIR W=60u L=1u
R_h_L3_13 z_L3_13 vrefh 8000.0
Mr_L3_13  hdd_L3_13 z_L3_13 tail_L3_13 0 NREL W=12u L=1u
Mr2_L3_13 dmp_L3_13  vmid  tail_L3_13 0 NREL W=12u L=1u
Mtl_L3_13 tail_L3_13 vtb 0 0 NREL W=32.0u L=1u
Mdm_L3_13 dmp_L3_13 dmp_L3_13 vdd vdd PMIR W=40u L=1u
Mrp1_L3_13 hdd_L3_13 hdd_L3_13 vdd vdd PMIR W=40u L=1u
Mrp2_L3_13 hv_L3_13 hdd_L3_13 vdd vdd PMIR W=40u L=1u
Rhv_L3_13 hv_L3_13 vg0 8000.0
C_gp_3_14_0 gp_3_14_0 0 {Cg}
Mp_3_14_0 hv_L2_7 gp_3_14_0 colp_L3_14 0 NSYN W=10u L=1u
Mn_3_14_0 hv_L2_7 vcn coln_L3_14 0 NSYN W=10u L=1u
C_gp_3_14_1 gp_3_14_1 0 {Cg}
Mp_3_14_1 hv_L2_9 gp_3_14_1 colp_L3_14 0 NSYN W=10u L=1u
Mn_3_14_1 hv_L2_9 vcn coln_L3_14 0 NSYN W=10u L=1u
C_gp_3_14_2 gp_3_14_2 0 {Cg}
Mp_3_14_2 hv_L2_12 gp_3_14_2 colp_L3_14 0 NSYN W=10u L=1u
Mn_3_14_2 hv_L2_12 vcn coln_L3_14 0 NSYN W=10u L=1u
C_gp_3_14_3 gp_3_14_3 0 {Cg}
Mp_3_14_3 hv_L2_14 gp_3_14_3 colp_L3_14 0 NSYN W=10u L=1u
Mn_3_14_3 hv_L2_14 vcn coln_L3_14 0 NSYN W=10u L=1u
C_gp_3_14_4 gp_3_14_4 0 {Cg}
Mp_3_14_4 hv_L2_17 gp_3_14_4 colp_L3_14 0 NSYN W=10u L=1u
Mn_3_14_4 hv_L2_17 vcn coln_L3_14 0 NSYN W=10u L=1u
C_gp_3_14_5 gp_3_14_5 0 {Cg}
Mp_3_14_5 hv_L2_19 gp_3_14_5 colp_L3_14 0 NSYN W=10u L=1u
Mn_3_14_5 hv_L2_19 vcn coln_L3_14 0 NSYN W=10u L=1u
C_gp_3_14_6 gp_3_14_6 0 {Cg}
Mp_3_14_6 hv_L2_23 gp_3_14_6 colp_L3_14 0 NSYN W=10u L=1u
Mn_3_14_6 hv_L2_23 vcn coln_L3_14 0 NSYN W=10u L=1u
C_gp_3_14_7 gp_3_14_7 0 {Cg}
Mp_3_14_7 hv_L2_24 gp_3_14_7 colp_L3_14 0 NSYN W=10u L=1u
Mn_3_14_7 hv_L2_24 vcn coln_L3_14 0 NSYN W=10u L=1u
C_gp_3_14_8 gp_3_14_8 0 {Cg}
Mp_3_14_8 hv_L2_25 gp_3_14_8 colp_L3_14 0 NSYN W=10u L=1u
Mn_3_14_8 hv_L2_25 vcn coln_L3_14 0 NSYN W=10u L=1u
C_gp_3_14_9 gp_3_14_9 0 {Cg}
Mp_3_14_9 hv_L2_26 gp_3_14_9 colp_L3_14 0 NSYN W=10u L=1u
Mn_3_14_9 hv_L2_26 vcn coln_L3_14 0 NSYN W=10u L=1u
C_gp_3_14_10 gp_3_14_10 0 {Cg}
Mp_3_14_10 hv_L2_31 gp_3_14_10 colp_L3_14 0 NSYN W=10u L=1u
Mn_3_14_10 hv_L2_31 vcn coln_L3_14 0 NSYN W=10u L=1u
C_gp_3_14_11 gp_3_14_11 0 {Cg}
Mp_3_14_11 hv_L2_33 gp_3_14_11 colp_L3_14 0 NSYN W=10u L=1u
Mn_3_14_11 hv_L2_33 vcn coln_L3_14 0 NSYN W=10u L=1u
C_gp_3_14_12 gp_3_14_12 0 {Cg}
Mp_3_14_12 hv_L2_34 gp_3_14_12 colp_L3_14 0 NSYN W=10u L=1u
Mn_3_14_12 hv_L2_34 vcn coln_L3_14 0 NSYN W=10u L=1u
C_gp_3_14_13 gp_3_14_13 0 {Cg}
Mp_3_14_13 hv_L2_37 gp_3_14_13 colp_L3_14 0 NSYN W=10u L=1u
Mn_3_14_13 hv_L2_37 vcn coln_L3_14 0 NSYN W=10u L=1u
C_gp_3_14_14 gp_3_14_14 0 {Cg}
Mp_3_14_14 hv_L2_40 gp_3_14_14 colp_L3_14 0 NSYN W=10u L=1u
Mn_3_14_14 hv_L2_40 vcn coln_L3_14 0 NSYN W=10u L=1u
C_gp_3_14_15 gp_3_14_15 0 {Cg}
Mp_3_14_15 hv_L2_41 gp_3_14_15 colp_L3_14 0 NSYN W=10u L=1u
Mn_3_14_15 hv_L2_41 vcn coln_L3_14 0 NSYN W=10u L=1u
C_gp_3_14_b gp_3_14_b 0 {Cg}
Mp_3_14_b bx gp_3_14_b colp_L3_14 0 NSYN W=10u L=1u
Mn_3_14_b bx vcn coln_L3_14 0 NSYN W=10u L=1u
Msa_h_L3_14 coln_L3_14 coln_L3_14 0 0 NMIR W=20u L=1u
Msb_h_L3_14 z_L3_14 coln_L3_14 0 0 NMIR W=20u L=1u
Msc_h_L3_14 colp_L3_14 colp_L3_14 0 0 NMIR W=20u L=1u
Msd_h_L3_14 dpf_h_L3_14 colp_L3_14 0 0 NMIR W=20u L=1u
Mse_h_L3_14 dpf_h_L3_14 dpf_h_L3_14 vdd vdd PMIR W=60u L=1u
Msf_h_L3_14 z_L3_14 dpf_h_L3_14 vdd vdd PMIR W=60u L=1u
R_h_L3_14 z_L3_14 vrefh 8000.0
Mr_L3_14  hdd_L3_14 z_L3_14 tail_L3_14 0 NREL W=12u L=1u
Mr2_L3_14 dmp_L3_14  vmid  tail_L3_14 0 NREL W=12u L=1u
Mtl_L3_14 tail_L3_14 vtb 0 0 NREL W=32.0u L=1u
Mdm_L3_14 dmp_L3_14 dmp_L3_14 vdd vdd PMIR W=40u L=1u
Mrp1_L3_14 hdd_L3_14 hdd_L3_14 vdd vdd PMIR W=40u L=1u
Mrp2_L3_14 hv_L3_14 hdd_L3_14 vdd vdd PMIR W=40u L=1u
Rhv_L3_14 hv_L3_14 vg0 8000.0
C_gp_3_15_0 gp_3_15_0 0 {Cg}
Mp_3_15_0 hv_L2_0 gp_3_15_0 colp_L3_15 0 NSYN W=10u L=1u
Mn_3_15_0 hv_L2_0 vcn coln_L3_15 0 NSYN W=10u L=1u
C_gp_3_15_1 gp_3_15_1 0 {Cg}
Mp_3_15_1 hv_L2_1 gp_3_15_1 colp_L3_15 0 NSYN W=10u L=1u
Mn_3_15_1 hv_L2_1 vcn coln_L3_15 0 NSYN W=10u L=1u
C_gp_3_15_2 gp_3_15_2 0 {Cg}
Mp_3_15_2 hv_L2_2 gp_3_15_2 colp_L3_15 0 NSYN W=10u L=1u
Mn_3_15_2 hv_L2_2 vcn coln_L3_15 0 NSYN W=10u L=1u
C_gp_3_15_3 gp_3_15_3 0 {Cg}
Mp_3_15_3 hv_L2_4 gp_3_15_3 colp_L3_15 0 NSYN W=10u L=1u
Mn_3_15_3 hv_L2_4 vcn coln_L3_15 0 NSYN W=10u L=1u
C_gp_3_15_4 gp_3_15_4 0 {Cg}
Mp_3_15_4 hv_L2_8 gp_3_15_4 colp_L3_15 0 NSYN W=10u L=1u
Mn_3_15_4 hv_L2_8 vcn coln_L3_15 0 NSYN W=10u L=1u
C_gp_3_15_5 gp_3_15_5 0 {Cg}
Mp_3_15_5 hv_L2_12 gp_3_15_5 colp_L3_15 0 NSYN W=10u L=1u
Mn_3_15_5 hv_L2_12 vcn coln_L3_15 0 NSYN W=10u L=1u
C_gp_3_15_6 gp_3_15_6 0 {Cg}
Mp_3_15_6 hv_L2_13 gp_3_15_6 colp_L3_15 0 NSYN W=10u L=1u
Mn_3_15_6 hv_L2_13 vcn coln_L3_15 0 NSYN W=10u L=1u
C_gp_3_15_7 gp_3_15_7 0 {Cg}
Mp_3_15_7 hv_L2_15 gp_3_15_7 colp_L3_15 0 NSYN W=10u L=1u
Mn_3_15_7 hv_L2_15 vcn coln_L3_15 0 NSYN W=10u L=1u
C_gp_3_15_8 gp_3_15_8 0 {Cg}
Mp_3_15_8 hv_L2_16 gp_3_15_8 colp_L3_15 0 NSYN W=10u L=1u
Mn_3_15_8 hv_L2_16 vcn coln_L3_15 0 NSYN W=10u L=1u
C_gp_3_15_9 gp_3_15_9 0 {Cg}
Mp_3_15_9 hv_L2_28 gp_3_15_9 colp_L3_15 0 NSYN W=10u L=1u
Mn_3_15_9 hv_L2_28 vcn coln_L3_15 0 NSYN W=10u L=1u
C_gp_3_15_10 gp_3_15_10 0 {Cg}
Mp_3_15_10 hv_L2_31 gp_3_15_10 colp_L3_15 0 NSYN W=10u L=1u
Mn_3_15_10 hv_L2_31 vcn coln_L3_15 0 NSYN W=10u L=1u
C_gp_3_15_11 gp_3_15_11 0 {Cg}
Mp_3_15_11 hv_L2_35 gp_3_15_11 colp_L3_15 0 NSYN W=10u L=1u
Mn_3_15_11 hv_L2_35 vcn coln_L3_15 0 NSYN W=10u L=1u
C_gp_3_15_12 gp_3_15_12 0 {Cg}
Mp_3_15_12 hv_L2_36 gp_3_15_12 colp_L3_15 0 NSYN W=10u L=1u
Mn_3_15_12 hv_L2_36 vcn coln_L3_15 0 NSYN W=10u L=1u
C_gp_3_15_13 gp_3_15_13 0 {Cg}
Mp_3_15_13 hv_L2_39 gp_3_15_13 colp_L3_15 0 NSYN W=10u L=1u
Mn_3_15_13 hv_L2_39 vcn coln_L3_15 0 NSYN W=10u L=1u
C_gp_3_15_14 gp_3_15_14 0 {Cg}
Mp_3_15_14 hv_L2_42 gp_3_15_14 colp_L3_15 0 NSYN W=10u L=1u
Mn_3_15_14 hv_L2_42 vcn coln_L3_15 0 NSYN W=10u L=1u
C_gp_3_15_15 gp_3_15_15 0 {Cg}
Mp_3_15_15 hv_L2_46 gp_3_15_15 colp_L3_15 0 NSYN W=10u L=1u
Mn_3_15_15 hv_L2_46 vcn coln_L3_15 0 NSYN W=10u L=1u
C_gp_3_15_b gp_3_15_b 0 {Cg}
Mp_3_15_b bx gp_3_15_b colp_L3_15 0 NSYN W=10u L=1u
Mn_3_15_b bx vcn coln_L3_15 0 NSYN W=10u L=1u
Msa_h_L3_15 coln_L3_15 coln_L3_15 0 0 NMIR W=20u L=1u
Msb_h_L3_15 z_L3_15 coln_L3_15 0 0 NMIR W=20u L=1u
Msc_h_L3_15 colp_L3_15 colp_L3_15 0 0 NMIR W=20u L=1u
Msd_h_L3_15 dpf_h_L3_15 colp_L3_15 0 0 NMIR W=20u L=1u
Mse_h_L3_15 dpf_h_L3_15 dpf_h_L3_15 vdd vdd PMIR W=60u L=1u
Msf_h_L3_15 z_L3_15 dpf_h_L3_15 vdd vdd PMIR W=60u L=1u
R_h_L3_15 z_L3_15 vrefh 8000.0
Mr_L3_15  hdd_L3_15 z_L3_15 tail_L3_15 0 NREL W=12u L=1u
Mr2_L3_15 dmp_L3_15  vmid  tail_L3_15 0 NREL W=12u L=1u
Mtl_L3_15 tail_L3_15 vtb 0 0 NREL W=32.0u L=1u
Mdm_L3_15 dmp_L3_15 dmp_L3_15 vdd vdd PMIR W=40u L=1u
Mrp1_L3_15 hdd_L3_15 hdd_L3_15 vdd vdd PMIR W=40u L=1u
Mrp2_L3_15 hv_L3_15 hdd_L3_15 vdd vdd PMIR W=40u L=1u
Rhv_L3_15 hv_L3_15 vg0 8000.0
C_gp_3_16_0 gp_3_16_0 0 {Cg}
Mp_3_16_0 hv_L2_3 gp_3_16_0 colp_L3_16 0 NSYN W=10u L=1u
Mn_3_16_0 hv_L2_3 vcn coln_L3_16 0 NSYN W=10u L=1u
C_gp_3_16_1 gp_3_16_1 0 {Cg}
Mp_3_16_1 hv_L2_8 gp_3_16_1 colp_L3_16 0 NSYN W=10u L=1u
Mn_3_16_1 hv_L2_8 vcn coln_L3_16 0 NSYN W=10u L=1u
C_gp_3_16_2 gp_3_16_2 0 {Cg}
Mp_3_16_2 hv_L2_13 gp_3_16_2 colp_L3_16 0 NSYN W=10u L=1u
Mn_3_16_2 hv_L2_13 vcn coln_L3_16 0 NSYN W=10u L=1u
C_gp_3_16_3 gp_3_16_3 0 {Cg}
Mp_3_16_3 hv_L2_18 gp_3_16_3 colp_L3_16 0 NSYN W=10u L=1u
Mn_3_16_3 hv_L2_18 vcn coln_L3_16 0 NSYN W=10u L=1u
C_gp_3_16_4 gp_3_16_4 0 {Cg}
Mp_3_16_4 hv_L2_23 gp_3_16_4 colp_L3_16 0 NSYN W=10u L=1u
Mn_3_16_4 hv_L2_23 vcn coln_L3_16 0 NSYN W=10u L=1u
C_gp_3_16_5 gp_3_16_5 0 {Cg}
Mp_3_16_5 hv_L2_26 gp_3_16_5 colp_L3_16 0 NSYN W=10u L=1u
Mn_3_16_5 hv_L2_26 vcn coln_L3_16 0 NSYN W=10u L=1u
C_gp_3_16_6 gp_3_16_6 0 {Cg}
Mp_3_16_6 hv_L2_28 gp_3_16_6 colp_L3_16 0 NSYN W=10u L=1u
Mn_3_16_6 hv_L2_28 vcn coln_L3_16 0 NSYN W=10u L=1u
C_gp_3_16_7 gp_3_16_7 0 {Cg}
Mp_3_16_7 hv_L2_29 gp_3_16_7 colp_L3_16 0 NSYN W=10u L=1u
Mn_3_16_7 hv_L2_29 vcn coln_L3_16 0 NSYN W=10u L=1u
C_gp_3_16_8 gp_3_16_8 0 {Cg}
Mp_3_16_8 hv_L2_31 gp_3_16_8 colp_L3_16 0 NSYN W=10u L=1u
Mn_3_16_8 hv_L2_31 vcn coln_L3_16 0 NSYN W=10u L=1u
C_gp_3_16_9 gp_3_16_9 0 {Cg}
Mp_3_16_9 hv_L2_35 gp_3_16_9 colp_L3_16 0 NSYN W=10u L=1u
Mn_3_16_9 hv_L2_35 vcn coln_L3_16 0 NSYN W=10u L=1u
C_gp_3_16_10 gp_3_16_10 0 {Cg}
Mp_3_16_10 hv_L2_36 gp_3_16_10 colp_L3_16 0 NSYN W=10u L=1u
Mn_3_16_10 hv_L2_36 vcn coln_L3_16 0 NSYN W=10u L=1u
C_gp_3_16_11 gp_3_16_11 0 {Cg}
Mp_3_16_11 hv_L2_39 gp_3_16_11 colp_L3_16 0 NSYN W=10u L=1u
Mn_3_16_11 hv_L2_39 vcn coln_L3_16 0 NSYN W=10u L=1u
C_gp_3_16_12 gp_3_16_12 0 {Cg}
Mp_3_16_12 hv_L2_40 gp_3_16_12 colp_L3_16 0 NSYN W=10u L=1u
Mn_3_16_12 hv_L2_40 vcn coln_L3_16 0 NSYN W=10u L=1u
C_gp_3_16_13 gp_3_16_13 0 {Cg}
Mp_3_16_13 hv_L2_42 gp_3_16_13 colp_L3_16 0 NSYN W=10u L=1u
Mn_3_16_13 hv_L2_42 vcn coln_L3_16 0 NSYN W=10u L=1u
C_gp_3_16_14 gp_3_16_14 0 {Cg}
Mp_3_16_14 hv_L2_45 gp_3_16_14 colp_L3_16 0 NSYN W=10u L=1u
Mn_3_16_14 hv_L2_45 vcn coln_L3_16 0 NSYN W=10u L=1u
C_gp_3_16_15 gp_3_16_15 0 {Cg}
Mp_3_16_15 hv_L2_46 gp_3_16_15 colp_L3_16 0 NSYN W=10u L=1u
Mn_3_16_15 hv_L2_46 vcn coln_L3_16 0 NSYN W=10u L=1u
C_gp_3_16_b gp_3_16_b 0 {Cg}
Mp_3_16_b bx gp_3_16_b colp_L3_16 0 NSYN W=10u L=1u
Mn_3_16_b bx vcn coln_L3_16 0 NSYN W=10u L=1u
Msa_h_L3_16 coln_L3_16 coln_L3_16 0 0 NMIR W=20u L=1u
Msb_h_L3_16 z_L3_16 coln_L3_16 0 0 NMIR W=20u L=1u
Msc_h_L3_16 colp_L3_16 colp_L3_16 0 0 NMIR W=20u L=1u
Msd_h_L3_16 dpf_h_L3_16 colp_L3_16 0 0 NMIR W=20u L=1u
Mse_h_L3_16 dpf_h_L3_16 dpf_h_L3_16 vdd vdd PMIR W=60u L=1u
Msf_h_L3_16 z_L3_16 dpf_h_L3_16 vdd vdd PMIR W=60u L=1u
R_h_L3_16 z_L3_16 vrefh 8000.0
Mr_L3_16  hdd_L3_16 z_L3_16 tail_L3_16 0 NREL W=12u L=1u
Mr2_L3_16 dmp_L3_16  vmid  tail_L3_16 0 NREL W=12u L=1u
Mtl_L3_16 tail_L3_16 vtb 0 0 NREL W=32.0u L=1u
Mdm_L3_16 dmp_L3_16 dmp_L3_16 vdd vdd PMIR W=40u L=1u
Mrp1_L3_16 hdd_L3_16 hdd_L3_16 vdd vdd PMIR W=40u L=1u
Mrp2_L3_16 hv_L3_16 hdd_L3_16 vdd vdd PMIR W=40u L=1u
Rhv_L3_16 hv_L3_16 vg0 8000.0
C_gp_3_17_0 gp_3_17_0 0 {Cg}
Mp_3_17_0 hv_L2_3 gp_3_17_0 colp_L3_17 0 NSYN W=10u L=1u
Mn_3_17_0 hv_L2_3 vcn coln_L3_17 0 NSYN W=10u L=1u
C_gp_3_17_1 gp_3_17_1 0 {Cg}
Mp_3_17_1 hv_L2_4 gp_3_17_1 colp_L3_17 0 NSYN W=10u L=1u
Mn_3_17_1 hv_L2_4 vcn coln_L3_17 0 NSYN W=10u L=1u
C_gp_3_17_2 gp_3_17_2 0 {Cg}
Mp_3_17_2 hv_L2_6 gp_3_17_2 colp_L3_17 0 NSYN W=10u L=1u
Mn_3_17_2 hv_L2_6 vcn coln_L3_17 0 NSYN W=10u L=1u
C_gp_3_17_3 gp_3_17_3 0 {Cg}
Mp_3_17_3 hv_L2_7 gp_3_17_3 colp_L3_17 0 NSYN W=10u L=1u
Mn_3_17_3 hv_L2_7 vcn coln_L3_17 0 NSYN W=10u L=1u
C_gp_3_17_4 gp_3_17_4 0 {Cg}
Mp_3_17_4 hv_L2_8 gp_3_17_4 colp_L3_17 0 NSYN W=10u L=1u
Mn_3_17_4 hv_L2_8 vcn coln_L3_17 0 NSYN W=10u L=1u
C_gp_3_17_5 gp_3_17_5 0 {Cg}
Mp_3_17_5 hv_L2_15 gp_3_17_5 colp_L3_17 0 NSYN W=10u L=1u
Mn_3_17_5 hv_L2_15 vcn coln_L3_17 0 NSYN W=10u L=1u
C_gp_3_17_6 gp_3_17_6 0 {Cg}
Mp_3_17_6 hv_L2_16 gp_3_17_6 colp_L3_17 0 NSYN W=10u L=1u
Mn_3_17_6 hv_L2_16 vcn coln_L3_17 0 NSYN W=10u L=1u
C_gp_3_17_7 gp_3_17_7 0 {Cg}
Mp_3_17_7 hv_L2_21 gp_3_17_7 colp_L3_17 0 NSYN W=10u L=1u
Mn_3_17_7 hv_L2_21 vcn coln_L3_17 0 NSYN W=10u L=1u
C_gp_3_17_8 gp_3_17_8 0 {Cg}
Mp_3_17_8 hv_L2_23 gp_3_17_8 colp_L3_17 0 NSYN W=10u L=1u
Mn_3_17_8 hv_L2_23 vcn coln_L3_17 0 NSYN W=10u L=1u
C_gp_3_17_9 gp_3_17_9 0 {Cg}
Mp_3_17_9 hv_L2_30 gp_3_17_9 colp_L3_17 0 NSYN W=10u L=1u
Mn_3_17_9 hv_L2_30 vcn coln_L3_17 0 NSYN W=10u L=1u
C_gp_3_17_10 gp_3_17_10 0 {Cg}
Mp_3_17_10 hv_L2_34 gp_3_17_10 colp_L3_17 0 NSYN W=10u L=1u
Mn_3_17_10 hv_L2_34 vcn coln_L3_17 0 NSYN W=10u L=1u
C_gp_3_17_11 gp_3_17_11 0 {Cg}
Mp_3_17_11 hv_L2_35 gp_3_17_11 colp_L3_17 0 NSYN W=10u L=1u
Mn_3_17_11 hv_L2_35 vcn coln_L3_17 0 NSYN W=10u L=1u
C_gp_3_17_12 gp_3_17_12 0 {Cg}
Mp_3_17_12 hv_L2_38 gp_3_17_12 colp_L3_17 0 NSYN W=10u L=1u
Mn_3_17_12 hv_L2_38 vcn coln_L3_17 0 NSYN W=10u L=1u
C_gp_3_17_13 gp_3_17_13 0 {Cg}
Mp_3_17_13 hv_L2_39 gp_3_17_13 colp_L3_17 0 NSYN W=10u L=1u
Mn_3_17_13 hv_L2_39 vcn coln_L3_17 0 NSYN W=10u L=1u
C_gp_3_17_14 gp_3_17_14 0 {Cg}
Mp_3_17_14 hv_L2_41 gp_3_17_14 colp_L3_17 0 NSYN W=10u L=1u
Mn_3_17_14 hv_L2_41 vcn coln_L3_17 0 NSYN W=10u L=1u
C_gp_3_17_15 gp_3_17_15 0 {Cg}
Mp_3_17_15 hv_L2_45 gp_3_17_15 colp_L3_17 0 NSYN W=10u L=1u
Mn_3_17_15 hv_L2_45 vcn coln_L3_17 0 NSYN W=10u L=1u
C_gp_3_17_b gp_3_17_b 0 {Cg}
Mp_3_17_b bx gp_3_17_b colp_L3_17 0 NSYN W=10u L=1u
Mn_3_17_b bx vcn coln_L3_17 0 NSYN W=10u L=1u
Msa_h_L3_17 coln_L3_17 coln_L3_17 0 0 NMIR W=20u L=1u
Msb_h_L3_17 z_L3_17 coln_L3_17 0 0 NMIR W=20u L=1u
Msc_h_L3_17 colp_L3_17 colp_L3_17 0 0 NMIR W=20u L=1u
Msd_h_L3_17 dpf_h_L3_17 colp_L3_17 0 0 NMIR W=20u L=1u
Mse_h_L3_17 dpf_h_L3_17 dpf_h_L3_17 vdd vdd PMIR W=60u L=1u
Msf_h_L3_17 z_L3_17 dpf_h_L3_17 vdd vdd PMIR W=60u L=1u
R_h_L3_17 z_L3_17 vrefh 8000.0
Mr_L3_17  hdd_L3_17 z_L3_17 tail_L3_17 0 NREL W=12u L=1u
Mr2_L3_17 dmp_L3_17  vmid  tail_L3_17 0 NREL W=12u L=1u
Mtl_L3_17 tail_L3_17 vtb 0 0 NREL W=32.0u L=1u
Mdm_L3_17 dmp_L3_17 dmp_L3_17 vdd vdd PMIR W=40u L=1u
Mrp1_L3_17 hdd_L3_17 hdd_L3_17 vdd vdd PMIR W=40u L=1u
Mrp2_L3_17 hv_L3_17 hdd_L3_17 vdd vdd PMIR W=40u L=1u
Rhv_L3_17 hv_L3_17 vg0 8000.0
C_gp_3_18_0 gp_3_18_0 0 {Cg}
Mp_3_18_0 hv_L2_2 gp_3_18_0 colp_L3_18 0 NSYN W=10u L=1u
Mn_3_18_0 hv_L2_2 vcn coln_L3_18 0 NSYN W=10u L=1u
C_gp_3_18_1 gp_3_18_1 0 {Cg}
Mp_3_18_1 hv_L2_5 gp_3_18_1 colp_L3_18 0 NSYN W=10u L=1u
Mn_3_18_1 hv_L2_5 vcn coln_L3_18 0 NSYN W=10u L=1u
C_gp_3_18_2 gp_3_18_2 0 {Cg}
Mp_3_18_2 hv_L2_12 gp_3_18_2 colp_L3_18 0 NSYN W=10u L=1u
Mn_3_18_2 hv_L2_12 vcn coln_L3_18 0 NSYN W=10u L=1u
C_gp_3_18_3 gp_3_18_3 0 {Cg}
Mp_3_18_3 hv_L2_13 gp_3_18_3 colp_L3_18 0 NSYN W=10u L=1u
Mn_3_18_3 hv_L2_13 vcn coln_L3_18 0 NSYN W=10u L=1u
C_gp_3_18_4 gp_3_18_4 0 {Cg}
Mp_3_18_4 hv_L2_14 gp_3_18_4 colp_L3_18 0 NSYN W=10u L=1u
Mn_3_18_4 hv_L2_14 vcn coln_L3_18 0 NSYN W=10u L=1u
C_gp_3_18_5 gp_3_18_5 0 {Cg}
Mp_3_18_5 hv_L2_16 gp_3_18_5 colp_L3_18 0 NSYN W=10u L=1u
Mn_3_18_5 hv_L2_16 vcn coln_L3_18 0 NSYN W=10u L=1u
C_gp_3_18_6 gp_3_18_6 0 {Cg}
Mp_3_18_6 hv_L2_18 gp_3_18_6 colp_L3_18 0 NSYN W=10u L=1u
Mn_3_18_6 hv_L2_18 vcn coln_L3_18 0 NSYN W=10u L=1u
C_gp_3_18_7 gp_3_18_7 0 {Cg}
Mp_3_18_7 hv_L2_20 gp_3_18_7 colp_L3_18 0 NSYN W=10u L=1u
Mn_3_18_7 hv_L2_20 vcn coln_L3_18 0 NSYN W=10u L=1u
C_gp_3_18_8 gp_3_18_8 0 {Cg}
Mp_3_18_8 hv_L2_25 gp_3_18_8 colp_L3_18 0 NSYN W=10u L=1u
Mn_3_18_8 hv_L2_25 vcn coln_L3_18 0 NSYN W=10u L=1u
C_gp_3_18_9 gp_3_18_9 0 {Cg}
Mp_3_18_9 hv_L2_34 gp_3_18_9 colp_L3_18 0 NSYN W=10u L=1u
Mn_3_18_9 hv_L2_34 vcn coln_L3_18 0 NSYN W=10u L=1u
C_gp_3_18_10 gp_3_18_10 0 {Cg}
Mp_3_18_10 hv_L2_36 gp_3_18_10 colp_L3_18 0 NSYN W=10u L=1u
Mn_3_18_10 hv_L2_36 vcn coln_L3_18 0 NSYN W=10u L=1u
C_gp_3_18_11 gp_3_18_11 0 {Cg}
Mp_3_18_11 hv_L2_37 gp_3_18_11 colp_L3_18 0 NSYN W=10u L=1u
Mn_3_18_11 hv_L2_37 vcn coln_L3_18 0 NSYN W=10u L=1u
C_gp_3_18_12 gp_3_18_12 0 {Cg}
Mp_3_18_12 hv_L2_38 gp_3_18_12 colp_L3_18 0 NSYN W=10u L=1u
Mn_3_18_12 hv_L2_38 vcn coln_L3_18 0 NSYN W=10u L=1u
C_gp_3_18_13 gp_3_18_13 0 {Cg}
Mp_3_18_13 hv_L2_39 gp_3_18_13 colp_L3_18 0 NSYN W=10u L=1u
Mn_3_18_13 hv_L2_39 vcn coln_L3_18 0 NSYN W=10u L=1u
C_gp_3_18_14 gp_3_18_14 0 {Cg}
Mp_3_18_14 hv_L2_40 gp_3_18_14 colp_L3_18 0 NSYN W=10u L=1u
Mn_3_18_14 hv_L2_40 vcn coln_L3_18 0 NSYN W=10u L=1u
C_gp_3_18_15 gp_3_18_15 0 {Cg}
Mp_3_18_15 hv_L2_43 gp_3_18_15 colp_L3_18 0 NSYN W=10u L=1u
Mn_3_18_15 hv_L2_43 vcn coln_L3_18 0 NSYN W=10u L=1u
C_gp_3_18_b gp_3_18_b 0 {Cg}
Mp_3_18_b bx gp_3_18_b colp_L3_18 0 NSYN W=10u L=1u
Mn_3_18_b bx vcn coln_L3_18 0 NSYN W=10u L=1u
Msa_h_L3_18 coln_L3_18 coln_L3_18 0 0 NMIR W=20u L=1u
Msb_h_L3_18 z_L3_18 coln_L3_18 0 0 NMIR W=20u L=1u
Msc_h_L3_18 colp_L3_18 colp_L3_18 0 0 NMIR W=20u L=1u
Msd_h_L3_18 dpf_h_L3_18 colp_L3_18 0 0 NMIR W=20u L=1u
Mse_h_L3_18 dpf_h_L3_18 dpf_h_L3_18 vdd vdd PMIR W=60u L=1u
Msf_h_L3_18 z_L3_18 dpf_h_L3_18 vdd vdd PMIR W=60u L=1u
R_h_L3_18 z_L3_18 vrefh 8000.0
Mr_L3_18  hdd_L3_18 z_L3_18 tail_L3_18 0 NREL W=12u L=1u
Mr2_L3_18 dmp_L3_18  vmid  tail_L3_18 0 NREL W=12u L=1u
Mtl_L3_18 tail_L3_18 vtb 0 0 NREL W=32.0u L=1u
Mdm_L3_18 dmp_L3_18 dmp_L3_18 vdd vdd PMIR W=40u L=1u
Mrp1_L3_18 hdd_L3_18 hdd_L3_18 vdd vdd PMIR W=40u L=1u
Mrp2_L3_18 hv_L3_18 hdd_L3_18 vdd vdd PMIR W=40u L=1u
Rhv_L3_18 hv_L3_18 vg0 8000.0
C_gp_3_19_0 gp_3_19_0 0 {Cg}
Mp_3_19_0 hv_L2_2 gp_3_19_0 colp_L3_19 0 NSYN W=10u L=1u
Mn_3_19_0 hv_L2_2 vcn coln_L3_19 0 NSYN W=10u L=1u
C_gp_3_19_1 gp_3_19_1 0 {Cg}
Mp_3_19_1 hv_L2_9 gp_3_19_1 colp_L3_19 0 NSYN W=10u L=1u
Mn_3_19_1 hv_L2_9 vcn coln_L3_19 0 NSYN W=10u L=1u
C_gp_3_19_2 gp_3_19_2 0 {Cg}
Mp_3_19_2 hv_L2_12 gp_3_19_2 colp_L3_19 0 NSYN W=10u L=1u
Mn_3_19_2 hv_L2_12 vcn coln_L3_19 0 NSYN W=10u L=1u
C_gp_3_19_3 gp_3_19_3 0 {Cg}
Mp_3_19_3 hv_L2_13 gp_3_19_3 colp_L3_19 0 NSYN W=10u L=1u
Mn_3_19_3 hv_L2_13 vcn coln_L3_19 0 NSYN W=10u L=1u
C_gp_3_19_4 gp_3_19_4 0 {Cg}
Mp_3_19_4 hv_L2_18 gp_3_19_4 colp_L3_19 0 NSYN W=10u L=1u
Mn_3_19_4 hv_L2_18 vcn coln_L3_19 0 NSYN W=10u L=1u
C_gp_3_19_5 gp_3_19_5 0 {Cg}
Mp_3_19_5 hv_L2_19 gp_3_19_5 colp_L3_19 0 NSYN W=10u L=1u
Mn_3_19_5 hv_L2_19 vcn coln_L3_19 0 NSYN W=10u L=1u
C_gp_3_19_6 gp_3_19_6 0 {Cg}
Mp_3_19_6 hv_L2_22 gp_3_19_6 colp_L3_19 0 NSYN W=10u L=1u
Mn_3_19_6 hv_L2_22 vcn coln_L3_19 0 NSYN W=10u L=1u
C_gp_3_19_7 gp_3_19_7 0 {Cg}
Mp_3_19_7 hv_L2_27 gp_3_19_7 colp_L3_19 0 NSYN W=10u L=1u
Mn_3_19_7 hv_L2_27 vcn coln_L3_19 0 NSYN W=10u L=1u
C_gp_3_19_8 gp_3_19_8 0 {Cg}
Mp_3_19_8 hv_L2_28 gp_3_19_8 colp_L3_19 0 NSYN W=10u L=1u
Mn_3_19_8 hv_L2_28 vcn coln_L3_19 0 NSYN W=10u L=1u
C_gp_3_19_9 gp_3_19_9 0 {Cg}
Mp_3_19_9 hv_L2_31 gp_3_19_9 colp_L3_19 0 NSYN W=10u L=1u
Mn_3_19_9 hv_L2_31 vcn coln_L3_19 0 NSYN W=10u L=1u
C_gp_3_19_10 gp_3_19_10 0 {Cg}
Mp_3_19_10 hv_L2_32 gp_3_19_10 colp_L3_19 0 NSYN W=10u L=1u
Mn_3_19_10 hv_L2_32 vcn coln_L3_19 0 NSYN W=10u L=1u
C_gp_3_19_11 gp_3_19_11 0 {Cg}
Mp_3_19_11 hv_L2_39 gp_3_19_11 colp_L3_19 0 NSYN W=10u L=1u
Mn_3_19_11 hv_L2_39 vcn coln_L3_19 0 NSYN W=10u L=1u
C_gp_3_19_12 gp_3_19_12 0 {Cg}
Mp_3_19_12 hv_L2_41 gp_3_19_12 colp_L3_19 0 NSYN W=10u L=1u
Mn_3_19_12 hv_L2_41 vcn coln_L3_19 0 NSYN W=10u L=1u
C_gp_3_19_13 gp_3_19_13 0 {Cg}
Mp_3_19_13 hv_L2_43 gp_3_19_13 colp_L3_19 0 NSYN W=10u L=1u
Mn_3_19_13 hv_L2_43 vcn coln_L3_19 0 NSYN W=10u L=1u
C_gp_3_19_14 gp_3_19_14 0 {Cg}
Mp_3_19_14 hv_L2_44 gp_3_19_14 colp_L3_19 0 NSYN W=10u L=1u
Mn_3_19_14 hv_L2_44 vcn coln_L3_19 0 NSYN W=10u L=1u
C_gp_3_19_15 gp_3_19_15 0 {Cg}
Mp_3_19_15 hv_L2_47 gp_3_19_15 colp_L3_19 0 NSYN W=10u L=1u
Mn_3_19_15 hv_L2_47 vcn coln_L3_19 0 NSYN W=10u L=1u
C_gp_3_19_b gp_3_19_b 0 {Cg}
Mp_3_19_b bx gp_3_19_b colp_L3_19 0 NSYN W=10u L=1u
Mn_3_19_b bx vcn coln_L3_19 0 NSYN W=10u L=1u
Msa_h_L3_19 coln_L3_19 coln_L3_19 0 0 NMIR W=20u L=1u
Msb_h_L3_19 z_L3_19 coln_L3_19 0 0 NMIR W=20u L=1u
Msc_h_L3_19 colp_L3_19 colp_L3_19 0 0 NMIR W=20u L=1u
Msd_h_L3_19 dpf_h_L3_19 colp_L3_19 0 0 NMIR W=20u L=1u
Mse_h_L3_19 dpf_h_L3_19 dpf_h_L3_19 vdd vdd PMIR W=60u L=1u
Msf_h_L3_19 z_L3_19 dpf_h_L3_19 vdd vdd PMIR W=60u L=1u
R_h_L3_19 z_L3_19 vrefh 8000.0
Mr_L3_19  hdd_L3_19 z_L3_19 tail_L3_19 0 NREL W=12u L=1u
Mr2_L3_19 dmp_L3_19  vmid  tail_L3_19 0 NREL W=12u L=1u
Mtl_L3_19 tail_L3_19 vtb 0 0 NREL W=32.0u L=1u
Mdm_L3_19 dmp_L3_19 dmp_L3_19 vdd vdd PMIR W=40u L=1u
Mrp1_L3_19 hdd_L3_19 hdd_L3_19 vdd vdd PMIR W=40u L=1u
Mrp2_L3_19 hv_L3_19 hdd_L3_19 vdd vdd PMIR W=40u L=1u
Rhv_L3_19 hv_L3_19 vg0 8000.0
C_gp_3_20_0 gp_3_20_0 0 {Cg}
Mp_3_20_0 hv_L2_0 gp_3_20_0 colp_L3_20 0 NSYN W=10u L=1u
Mn_3_20_0 hv_L2_0 vcn coln_L3_20 0 NSYN W=10u L=1u
C_gp_3_20_1 gp_3_20_1 0 {Cg}
Mp_3_20_1 hv_L2_3 gp_3_20_1 colp_L3_20 0 NSYN W=10u L=1u
Mn_3_20_1 hv_L2_3 vcn coln_L3_20 0 NSYN W=10u L=1u
C_gp_3_20_2 gp_3_20_2 0 {Cg}
Mp_3_20_2 hv_L2_4 gp_3_20_2 colp_L3_20 0 NSYN W=10u L=1u
Mn_3_20_2 hv_L2_4 vcn coln_L3_20 0 NSYN W=10u L=1u
C_gp_3_20_3 gp_3_20_3 0 {Cg}
Mp_3_20_3 hv_L2_7 gp_3_20_3 colp_L3_20 0 NSYN W=10u L=1u
Mn_3_20_3 hv_L2_7 vcn coln_L3_20 0 NSYN W=10u L=1u
C_gp_3_20_4 gp_3_20_4 0 {Cg}
Mp_3_20_4 hv_L2_9 gp_3_20_4 colp_L3_20 0 NSYN W=10u L=1u
Mn_3_20_4 hv_L2_9 vcn coln_L3_20 0 NSYN W=10u L=1u
C_gp_3_20_5 gp_3_20_5 0 {Cg}
Mp_3_20_5 hv_L2_15 gp_3_20_5 colp_L3_20 0 NSYN W=10u L=1u
Mn_3_20_5 hv_L2_15 vcn coln_L3_20 0 NSYN W=10u L=1u
C_gp_3_20_6 gp_3_20_6 0 {Cg}
Mp_3_20_6 hv_L2_20 gp_3_20_6 colp_L3_20 0 NSYN W=10u L=1u
Mn_3_20_6 hv_L2_20 vcn coln_L3_20 0 NSYN W=10u L=1u
C_gp_3_20_7 gp_3_20_7 0 {Cg}
Mp_3_20_7 hv_L2_23 gp_3_20_7 colp_L3_20 0 NSYN W=10u L=1u
Mn_3_20_7 hv_L2_23 vcn coln_L3_20 0 NSYN W=10u L=1u
C_gp_3_20_8 gp_3_20_8 0 {Cg}
Mp_3_20_8 hv_L2_24 gp_3_20_8 colp_L3_20 0 NSYN W=10u L=1u
Mn_3_20_8 hv_L2_24 vcn coln_L3_20 0 NSYN W=10u L=1u
C_gp_3_20_9 gp_3_20_9 0 {Cg}
Mp_3_20_9 hv_L2_27 gp_3_20_9 colp_L3_20 0 NSYN W=10u L=1u
Mn_3_20_9 hv_L2_27 vcn coln_L3_20 0 NSYN W=10u L=1u
C_gp_3_20_10 gp_3_20_10 0 {Cg}
Mp_3_20_10 hv_L2_28 gp_3_20_10 colp_L3_20 0 NSYN W=10u L=1u
Mn_3_20_10 hv_L2_28 vcn coln_L3_20 0 NSYN W=10u L=1u
C_gp_3_20_11 gp_3_20_11 0 {Cg}
Mp_3_20_11 hv_L2_32 gp_3_20_11 colp_L3_20 0 NSYN W=10u L=1u
Mn_3_20_11 hv_L2_32 vcn coln_L3_20 0 NSYN W=10u L=1u
C_gp_3_20_12 gp_3_20_12 0 {Cg}
Mp_3_20_12 hv_L2_33 gp_3_20_12 colp_L3_20 0 NSYN W=10u L=1u
Mn_3_20_12 hv_L2_33 vcn coln_L3_20 0 NSYN W=10u L=1u
C_gp_3_20_13 gp_3_20_13 0 {Cg}
Mp_3_20_13 hv_L2_38 gp_3_20_13 colp_L3_20 0 NSYN W=10u L=1u
Mn_3_20_13 hv_L2_38 vcn coln_L3_20 0 NSYN W=10u L=1u
C_gp_3_20_14 gp_3_20_14 0 {Cg}
Mp_3_20_14 hv_L2_39 gp_3_20_14 colp_L3_20 0 NSYN W=10u L=1u
Mn_3_20_14 hv_L2_39 vcn coln_L3_20 0 NSYN W=10u L=1u
C_gp_3_20_15 gp_3_20_15 0 {Cg}
Mp_3_20_15 hv_L2_44 gp_3_20_15 colp_L3_20 0 NSYN W=10u L=1u
Mn_3_20_15 hv_L2_44 vcn coln_L3_20 0 NSYN W=10u L=1u
C_gp_3_20_b gp_3_20_b 0 {Cg}
Mp_3_20_b bx gp_3_20_b colp_L3_20 0 NSYN W=10u L=1u
Mn_3_20_b bx vcn coln_L3_20 0 NSYN W=10u L=1u
Msa_h_L3_20 coln_L3_20 coln_L3_20 0 0 NMIR W=20u L=1u
Msb_h_L3_20 z_L3_20 coln_L3_20 0 0 NMIR W=20u L=1u
Msc_h_L3_20 colp_L3_20 colp_L3_20 0 0 NMIR W=20u L=1u
Msd_h_L3_20 dpf_h_L3_20 colp_L3_20 0 0 NMIR W=20u L=1u
Mse_h_L3_20 dpf_h_L3_20 dpf_h_L3_20 vdd vdd PMIR W=60u L=1u
Msf_h_L3_20 z_L3_20 dpf_h_L3_20 vdd vdd PMIR W=60u L=1u
R_h_L3_20 z_L3_20 vrefh 8000.0
Mr_L3_20  hdd_L3_20 z_L3_20 tail_L3_20 0 NREL W=12u L=1u
Mr2_L3_20 dmp_L3_20  vmid  tail_L3_20 0 NREL W=12u L=1u
Mtl_L3_20 tail_L3_20 vtb 0 0 NREL W=32.0u L=1u
Mdm_L3_20 dmp_L3_20 dmp_L3_20 vdd vdd PMIR W=40u L=1u
Mrp1_L3_20 hdd_L3_20 hdd_L3_20 vdd vdd PMIR W=40u L=1u
Mrp2_L3_20 hv_L3_20 hdd_L3_20 vdd vdd PMIR W=40u L=1u
Rhv_L3_20 hv_L3_20 vg0 8000.0
C_gp_3_21_0 gp_3_21_0 0 {Cg}
Mp_3_21_0 hv_L2_3 gp_3_21_0 colp_L3_21 0 NSYN W=10u L=1u
Mn_3_21_0 hv_L2_3 vcn coln_L3_21 0 NSYN W=10u L=1u
C_gp_3_21_1 gp_3_21_1 0 {Cg}
Mp_3_21_1 hv_L2_7 gp_3_21_1 colp_L3_21 0 NSYN W=10u L=1u
Mn_3_21_1 hv_L2_7 vcn coln_L3_21 0 NSYN W=10u L=1u
C_gp_3_21_2 gp_3_21_2 0 {Cg}
Mp_3_21_2 hv_L2_9 gp_3_21_2 colp_L3_21 0 NSYN W=10u L=1u
Mn_3_21_2 hv_L2_9 vcn coln_L3_21 0 NSYN W=10u L=1u
C_gp_3_21_3 gp_3_21_3 0 {Cg}
Mp_3_21_3 hv_L2_11 gp_3_21_3 colp_L3_21 0 NSYN W=10u L=1u
Mn_3_21_3 hv_L2_11 vcn coln_L3_21 0 NSYN W=10u L=1u
C_gp_3_21_4 gp_3_21_4 0 {Cg}
Mp_3_21_4 hv_L2_12 gp_3_21_4 colp_L3_21 0 NSYN W=10u L=1u
Mn_3_21_4 hv_L2_12 vcn coln_L3_21 0 NSYN W=10u L=1u
C_gp_3_21_5 gp_3_21_5 0 {Cg}
Mp_3_21_5 hv_L2_15 gp_3_21_5 colp_L3_21 0 NSYN W=10u L=1u
Mn_3_21_5 hv_L2_15 vcn coln_L3_21 0 NSYN W=10u L=1u
C_gp_3_21_6 gp_3_21_6 0 {Cg}
Mp_3_21_6 hv_L2_16 gp_3_21_6 colp_L3_21 0 NSYN W=10u L=1u
Mn_3_21_6 hv_L2_16 vcn coln_L3_21 0 NSYN W=10u L=1u
C_gp_3_21_7 gp_3_21_7 0 {Cg}
Mp_3_21_7 hv_L2_19 gp_3_21_7 colp_L3_21 0 NSYN W=10u L=1u
Mn_3_21_7 hv_L2_19 vcn coln_L3_21 0 NSYN W=10u L=1u
C_gp_3_21_8 gp_3_21_8 0 {Cg}
Mp_3_21_8 hv_L2_23 gp_3_21_8 colp_L3_21 0 NSYN W=10u L=1u
Mn_3_21_8 hv_L2_23 vcn coln_L3_21 0 NSYN W=10u L=1u
C_gp_3_21_9 gp_3_21_9 0 {Cg}
Mp_3_21_9 hv_L2_29 gp_3_21_9 colp_L3_21 0 NSYN W=10u L=1u
Mn_3_21_9 hv_L2_29 vcn coln_L3_21 0 NSYN W=10u L=1u
C_gp_3_21_10 gp_3_21_10 0 {Cg}
Mp_3_21_10 hv_L2_31 gp_3_21_10 colp_L3_21 0 NSYN W=10u L=1u
Mn_3_21_10 hv_L2_31 vcn coln_L3_21 0 NSYN W=10u L=1u
C_gp_3_21_11 gp_3_21_11 0 {Cg}
Mp_3_21_11 hv_L2_33 gp_3_21_11 colp_L3_21 0 NSYN W=10u L=1u
Mn_3_21_11 hv_L2_33 vcn coln_L3_21 0 NSYN W=10u L=1u
C_gp_3_21_12 gp_3_21_12 0 {Cg}
Mp_3_21_12 hv_L2_36 gp_3_21_12 colp_L3_21 0 NSYN W=10u L=1u
Mn_3_21_12 hv_L2_36 vcn coln_L3_21 0 NSYN W=10u L=1u
C_gp_3_21_13 gp_3_21_13 0 {Cg}
Mp_3_21_13 hv_L2_38 gp_3_21_13 colp_L3_21 0 NSYN W=10u L=1u
Mn_3_21_13 hv_L2_38 vcn coln_L3_21 0 NSYN W=10u L=1u
C_gp_3_21_14 gp_3_21_14 0 {Cg}
Mp_3_21_14 hv_L2_39 gp_3_21_14 colp_L3_21 0 NSYN W=10u L=1u
Mn_3_21_14 hv_L2_39 vcn coln_L3_21 0 NSYN W=10u L=1u
C_gp_3_21_15 gp_3_21_15 0 {Cg}
Mp_3_21_15 hv_L2_47 gp_3_21_15 colp_L3_21 0 NSYN W=10u L=1u
Mn_3_21_15 hv_L2_47 vcn coln_L3_21 0 NSYN W=10u L=1u
C_gp_3_21_b gp_3_21_b 0 {Cg}
Mp_3_21_b bx gp_3_21_b colp_L3_21 0 NSYN W=10u L=1u
Mn_3_21_b bx vcn coln_L3_21 0 NSYN W=10u L=1u
Msa_h_L3_21 coln_L3_21 coln_L3_21 0 0 NMIR W=20u L=1u
Msb_h_L3_21 z_L3_21 coln_L3_21 0 0 NMIR W=20u L=1u
Msc_h_L3_21 colp_L3_21 colp_L3_21 0 0 NMIR W=20u L=1u
Msd_h_L3_21 dpf_h_L3_21 colp_L3_21 0 0 NMIR W=20u L=1u
Mse_h_L3_21 dpf_h_L3_21 dpf_h_L3_21 vdd vdd PMIR W=60u L=1u
Msf_h_L3_21 z_L3_21 dpf_h_L3_21 vdd vdd PMIR W=60u L=1u
R_h_L3_21 z_L3_21 vrefh 8000.0
Mr_L3_21  hdd_L3_21 z_L3_21 tail_L3_21 0 NREL W=12u L=1u
Mr2_L3_21 dmp_L3_21  vmid  tail_L3_21 0 NREL W=12u L=1u
Mtl_L3_21 tail_L3_21 vtb 0 0 NREL W=32.0u L=1u
Mdm_L3_21 dmp_L3_21 dmp_L3_21 vdd vdd PMIR W=40u L=1u
Mrp1_L3_21 hdd_L3_21 hdd_L3_21 vdd vdd PMIR W=40u L=1u
Mrp2_L3_21 hv_L3_21 hdd_L3_21 vdd vdd PMIR W=40u L=1u
Rhv_L3_21 hv_L3_21 vg0 8000.0
C_gp_3_22_0 gp_3_22_0 0 {Cg}
Mp_3_22_0 hv_L2_2 gp_3_22_0 colp_L3_22 0 NSYN W=10u L=1u
Mn_3_22_0 hv_L2_2 vcn coln_L3_22 0 NSYN W=10u L=1u
C_gp_3_22_1 gp_3_22_1 0 {Cg}
Mp_3_22_1 hv_L2_3 gp_3_22_1 colp_L3_22 0 NSYN W=10u L=1u
Mn_3_22_1 hv_L2_3 vcn coln_L3_22 0 NSYN W=10u L=1u
C_gp_3_22_2 gp_3_22_2 0 {Cg}
Mp_3_22_2 hv_L2_7 gp_3_22_2 colp_L3_22 0 NSYN W=10u L=1u
Mn_3_22_2 hv_L2_7 vcn coln_L3_22 0 NSYN W=10u L=1u
C_gp_3_22_3 gp_3_22_3 0 {Cg}
Mp_3_22_3 hv_L2_8 gp_3_22_3 colp_L3_22 0 NSYN W=10u L=1u
Mn_3_22_3 hv_L2_8 vcn coln_L3_22 0 NSYN W=10u L=1u
C_gp_3_22_4 gp_3_22_4 0 {Cg}
Mp_3_22_4 hv_L2_11 gp_3_22_4 colp_L3_22 0 NSYN W=10u L=1u
Mn_3_22_4 hv_L2_11 vcn coln_L3_22 0 NSYN W=10u L=1u
C_gp_3_22_5 gp_3_22_5 0 {Cg}
Mp_3_22_5 hv_L2_14 gp_3_22_5 colp_L3_22 0 NSYN W=10u L=1u
Mn_3_22_5 hv_L2_14 vcn coln_L3_22 0 NSYN W=10u L=1u
C_gp_3_22_6 gp_3_22_6 0 {Cg}
Mp_3_22_6 hv_L2_17 gp_3_22_6 colp_L3_22 0 NSYN W=10u L=1u
Mn_3_22_6 hv_L2_17 vcn coln_L3_22 0 NSYN W=10u L=1u
C_gp_3_22_7 gp_3_22_7 0 {Cg}
Mp_3_22_7 hv_L2_21 gp_3_22_7 colp_L3_22 0 NSYN W=10u L=1u
Mn_3_22_7 hv_L2_21 vcn coln_L3_22 0 NSYN W=10u L=1u
C_gp_3_22_8 gp_3_22_8 0 {Cg}
Mp_3_22_8 hv_L2_23 gp_3_22_8 colp_L3_22 0 NSYN W=10u L=1u
Mn_3_22_8 hv_L2_23 vcn coln_L3_22 0 NSYN W=10u L=1u
C_gp_3_22_9 gp_3_22_9 0 {Cg}
Mp_3_22_9 hv_L2_24 gp_3_22_9 colp_L3_22 0 NSYN W=10u L=1u
Mn_3_22_9 hv_L2_24 vcn coln_L3_22 0 NSYN W=10u L=1u
C_gp_3_22_10 gp_3_22_10 0 {Cg}
Mp_3_22_10 hv_L2_27 gp_3_22_10 colp_L3_22 0 NSYN W=10u L=1u
Mn_3_22_10 hv_L2_27 vcn coln_L3_22 0 NSYN W=10u L=1u
C_gp_3_22_11 gp_3_22_11 0 {Cg}
Mp_3_22_11 hv_L2_31 gp_3_22_11 colp_L3_22 0 NSYN W=10u L=1u
Mn_3_22_11 hv_L2_31 vcn coln_L3_22 0 NSYN W=10u L=1u
C_gp_3_22_12 gp_3_22_12 0 {Cg}
Mp_3_22_12 hv_L2_35 gp_3_22_12 colp_L3_22 0 NSYN W=10u L=1u
Mn_3_22_12 hv_L2_35 vcn coln_L3_22 0 NSYN W=10u L=1u
C_gp_3_22_13 gp_3_22_13 0 {Cg}
Mp_3_22_13 hv_L2_37 gp_3_22_13 colp_L3_22 0 NSYN W=10u L=1u
Mn_3_22_13 hv_L2_37 vcn coln_L3_22 0 NSYN W=10u L=1u
C_gp_3_22_14 gp_3_22_14 0 {Cg}
Mp_3_22_14 hv_L2_40 gp_3_22_14 colp_L3_22 0 NSYN W=10u L=1u
Mn_3_22_14 hv_L2_40 vcn coln_L3_22 0 NSYN W=10u L=1u
C_gp_3_22_15 gp_3_22_15 0 {Cg}
Mp_3_22_15 hv_L2_46 gp_3_22_15 colp_L3_22 0 NSYN W=10u L=1u
Mn_3_22_15 hv_L2_46 vcn coln_L3_22 0 NSYN W=10u L=1u
C_gp_3_22_b gp_3_22_b 0 {Cg}
Mp_3_22_b bx gp_3_22_b colp_L3_22 0 NSYN W=10u L=1u
Mn_3_22_b bx vcn coln_L3_22 0 NSYN W=10u L=1u
Msa_h_L3_22 coln_L3_22 coln_L3_22 0 0 NMIR W=20u L=1u
Msb_h_L3_22 z_L3_22 coln_L3_22 0 0 NMIR W=20u L=1u
Msc_h_L3_22 colp_L3_22 colp_L3_22 0 0 NMIR W=20u L=1u
Msd_h_L3_22 dpf_h_L3_22 colp_L3_22 0 0 NMIR W=20u L=1u
Mse_h_L3_22 dpf_h_L3_22 dpf_h_L3_22 vdd vdd PMIR W=60u L=1u
Msf_h_L3_22 z_L3_22 dpf_h_L3_22 vdd vdd PMIR W=60u L=1u
R_h_L3_22 z_L3_22 vrefh 8000.0
Mr_L3_22  hdd_L3_22 z_L3_22 tail_L3_22 0 NREL W=12u L=1u
Mr2_L3_22 dmp_L3_22  vmid  tail_L3_22 0 NREL W=12u L=1u
Mtl_L3_22 tail_L3_22 vtb 0 0 NREL W=32.0u L=1u
Mdm_L3_22 dmp_L3_22 dmp_L3_22 vdd vdd PMIR W=40u L=1u
Mrp1_L3_22 hdd_L3_22 hdd_L3_22 vdd vdd PMIR W=40u L=1u
Mrp2_L3_22 hv_L3_22 hdd_L3_22 vdd vdd PMIR W=40u L=1u
Rhv_L3_22 hv_L3_22 vg0 8000.0
C_gp_3_23_0 gp_3_23_0 0 {Cg}
Mp_3_23_0 hv_L2_6 gp_3_23_0 colp_L3_23 0 NSYN W=10u L=1u
Mn_3_23_0 hv_L2_6 vcn coln_L3_23 0 NSYN W=10u L=1u
C_gp_3_23_1 gp_3_23_1 0 {Cg}
Mp_3_23_1 hv_L2_7 gp_3_23_1 colp_L3_23 0 NSYN W=10u L=1u
Mn_3_23_1 hv_L2_7 vcn coln_L3_23 0 NSYN W=10u L=1u
C_gp_3_23_2 gp_3_23_2 0 {Cg}
Mp_3_23_2 hv_L2_12 gp_3_23_2 colp_L3_23 0 NSYN W=10u L=1u
Mn_3_23_2 hv_L2_12 vcn coln_L3_23 0 NSYN W=10u L=1u
C_gp_3_23_3 gp_3_23_3 0 {Cg}
Mp_3_23_3 hv_L2_13 gp_3_23_3 colp_L3_23 0 NSYN W=10u L=1u
Mn_3_23_3 hv_L2_13 vcn coln_L3_23 0 NSYN W=10u L=1u
C_gp_3_23_4 gp_3_23_4 0 {Cg}
Mp_3_23_4 hv_L2_17 gp_3_23_4 colp_L3_23 0 NSYN W=10u L=1u
Mn_3_23_4 hv_L2_17 vcn coln_L3_23 0 NSYN W=10u L=1u
C_gp_3_23_5 gp_3_23_5 0 {Cg}
Mp_3_23_5 hv_L2_18 gp_3_23_5 colp_L3_23 0 NSYN W=10u L=1u
Mn_3_23_5 hv_L2_18 vcn coln_L3_23 0 NSYN W=10u L=1u
C_gp_3_23_6 gp_3_23_6 0 {Cg}
Mp_3_23_6 hv_L2_24 gp_3_23_6 colp_L3_23 0 NSYN W=10u L=1u
Mn_3_23_6 hv_L2_24 vcn coln_L3_23 0 NSYN W=10u L=1u
C_gp_3_23_7 gp_3_23_7 0 {Cg}
Mp_3_23_7 hv_L2_29 gp_3_23_7 colp_L3_23 0 NSYN W=10u L=1u
Mn_3_23_7 hv_L2_29 vcn coln_L3_23 0 NSYN W=10u L=1u
C_gp_3_23_8 gp_3_23_8 0 {Cg}
Mp_3_23_8 hv_L2_33 gp_3_23_8 colp_L3_23 0 NSYN W=10u L=1u
Mn_3_23_8 hv_L2_33 vcn coln_L3_23 0 NSYN W=10u L=1u
C_gp_3_23_9 gp_3_23_9 0 {Cg}
Mp_3_23_9 hv_L2_35 gp_3_23_9 colp_L3_23 0 NSYN W=10u L=1u
Mn_3_23_9 hv_L2_35 vcn coln_L3_23 0 NSYN W=10u L=1u
C_gp_3_23_10 gp_3_23_10 0 {Cg}
Mp_3_23_10 hv_L2_39 gp_3_23_10 colp_L3_23 0 NSYN W=10u L=1u
Mn_3_23_10 hv_L2_39 vcn coln_L3_23 0 NSYN W=10u L=1u
C_gp_3_23_11 gp_3_23_11 0 {Cg}
Mp_3_23_11 hv_L2_40 gp_3_23_11 colp_L3_23 0 NSYN W=10u L=1u
Mn_3_23_11 hv_L2_40 vcn coln_L3_23 0 NSYN W=10u L=1u
C_gp_3_23_12 gp_3_23_12 0 {Cg}
Mp_3_23_12 hv_L2_41 gp_3_23_12 colp_L3_23 0 NSYN W=10u L=1u
Mn_3_23_12 hv_L2_41 vcn coln_L3_23 0 NSYN W=10u L=1u
C_gp_3_23_13 gp_3_23_13 0 {Cg}
Mp_3_23_13 hv_L2_42 gp_3_23_13 colp_L3_23 0 NSYN W=10u L=1u
Mn_3_23_13 hv_L2_42 vcn coln_L3_23 0 NSYN W=10u L=1u
C_gp_3_23_14 gp_3_23_14 0 {Cg}
Mp_3_23_14 hv_L2_45 gp_3_23_14 colp_L3_23 0 NSYN W=10u L=1u
Mn_3_23_14 hv_L2_45 vcn coln_L3_23 0 NSYN W=10u L=1u
C_gp_3_23_15 gp_3_23_15 0 {Cg}
Mp_3_23_15 hv_L2_47 gp_3_23_15 colp_L3_23 0 NSYN W=10u L=1u
Mn_3_23_15 hv_L2_47 vcn coln_L3_23 0 NSYN W=10u L=1u
C_gp_3_23_b gp_3_23_b 0 {Cg}
Mp_3_23_b bx gp_3_23_b colp_L3_23 0 NSYN W=10u L=1u
Mn_3_23_b bx vcn coln_L3_23 0 NSYN W=10u L=1u
Msa_h_L3_23 coln_L3_23 coln_L3_23 0 0 NMIR W=20u L=1u
Msb_h_L3_23 z_L3_23 coln_L3_23 0 0 NMIR W=20u L=1u
Msc_h_L3_23 colp_L3_23 colp_L3_23 0 0 NMIR W=20u L=1u
Msd_h_L3_23 dpf_h_L3_23 colp_L3_23 0 0 NMIR W=20u L=1u
Mse_h_L3_23 dpf_h_L3_23 dpf_h_L3_23 vdd vdd PMIR W=60u L=1u
Msf_h_L3_23 z_L3_23 dpf_h_L3_23 vdd vdd PMIR W=60u L=1u
R_h_L3_23 z_L3_23 vrefh 8000.0
Mr_L3_23  hdd_L3_23 z_L3_23 tail_L3_23 0 NREL W=12u L=1u
Mr2_L3_23 dmp_L3_23  vmid  tail_L3_23 0 NREL W=12u L=1u
Mtl_L3_23 tail_L3_23 vtb 0 0 NREL W=32.0u L=1u
Mdm_L3_23 dmp_L3_23 dmp_L3_23 vdd vdd PMIR W=40u L=1u
Mrp1_L3_23 hdd_L3_23 hdd_L3_23 vdd vdd PMIR W=40u L=1u
Mrp2_L3_23 hv_L3_23 hdd_L3_23 vdd vdd PMIR W=40u L=1u
Rhv_L3_23 hv_L3_23 vg0 8000.0
C_gp_3_24_0 gp_3_24_0 0 {Cg}
Mp_3_24_0 hv_L2_3 gp_3_24_0 colp_L3_24 0 NSYN W=10u L=1u
Mn_3_24_0 hv_L2_3 vcn coln_L3_24 0 NSYN W=10u L=1u
C_gp_3_24_1 gp_3_24_1 0 {Cg}
Mp_3_24_1 hv_L2_5 gp_3_24_1 colp_L3_24 0 NSYN W=10u L=1u
Mn_3_24_1 hv_L2_5 vcn coln_L3_24 0 NSYN W=10u L=1u
C_gp_3_24_2 gp_3_24_2 0 {Cg}
Mp_3_24_2 hv_L2_8 gp_3_24_2 colp_L3_24 0 NSYN W=10u L=1u
Mn_3_24_2 hv_L2_8 vcn coln_L3_24 0 NSYN W=10u L=1u
C_gp_3_24_3 gp_3_24_3 0 {Cg}
Mp_3_24_3 hv_L2_10 gp_3_24_3 colp_L3_24 0 NSYN W=10u L=1u
Mn_3_24_3 hv_L2_10 vcn coln_L3_24 0 NSYN W=10u L=1u
C_gp_3_24_4 gp_3_24_4 0 {Cg}
Mp_3_24_4 hv_L2_19 gp_3_24_4 colp_L3_24 0 NSYN W=10u L=1u
Mn_3_24_4 hv_L2_19 vcn coln_L3_24 0 NSYN W=10u L=1u
C_gp_3_24_5 gp_3_24_5 0 {Cg}
Mp_3_24_5 hv_L2_21 gp_3_24_5 colp_L3_24 0 NSYN W=10u L=1u
Mn_3_24_5 hv_L2_21 vcn coln_L3_24 0 NSYN W=10u L=1u
C_gp_3_24_6 gp_3_24_6 0 {Cg}
Mp_3_24_6 hv_L2_25 gp_3_24_6 colp_L3_24 0 NSYN W=10u L=1u
Mn_3_24_6 hv_L2_25 vcn coln_L3_24 0 NSYN W=10u L=1u
C_gp_3_24_7 gp_3_24_7 0 {Cg}
Mp_3_24_7 hv_L2_35 gp_3_24_7 colp_L3_24 0 NSYN W=10u L=1u
Mn_3_24_7 hv_L2_35 vcn coln_L3_24 0 NSYN W=10u L=1u
C_gp_3_24_8 gp_3_24_8 0 {Cg}
Mp_3_24_8 hv_L2_36 gp_3_24_8 colp_L3_24 0 NSYN W=10u L=1u
Mn_3_24_8 hv_L2_36 vcn coln_L3_24 0 NSYN W=10u L=1u
C_gp_3_24_9 gp_3_24_9 0 {Cg}
Mp_3_24_9 hv_L2_37 gp_3_24_9 colp_L3_24 0 NSYN W=10u L=1u
Mn_3_24_9 hv_L2_37 vcn coln_L3_24 0 NSYN W=10u L=1u
C_gp_3_24_10 gp_3_24_10 0 {Cg}
Mp_3_24_10 hv_L2_39 gp_3_24_10 colp_L3_24 0 NSYN W=10u L=1u
Mn_3_24_10 hv_L2_39 vcn coln_L3_24 0 NSYN W=10u L=1u
C_gp_3_24_11 gp_3_24_11 0 {Cg}
Mp_3_24_11 hv_L2_41 gp_3_24_11 colp_L3_24 0 NSYN W=10u L=1u
Mn_3_24_11 hv_L2_41 vcn coln_L3_24 0 NSYN W=10u L=1u
C_gp_3_24_12 gp_3_24_12 0 {Cg}
Mp_3_24_12 hv_L2_42 gp_3_24_12 colp_L3_24 0 NSYN W=10u L=1u
Mn_3_24_12 hv_L2_42 vcn coln_L3_24 0 NSYN W=10u L=1u
C_gp_3_24_13 gp_3_24_13 0 {Cg}
Mp_3_24_13 hv_L2_43 gp_3_24_13 colp_L3_24 0 NSYN W=10u L=1u
Mn_3_24_13 hv_L2_43 vcn coln_L3_24 0 NSYN W=10u L=1u
C_gp_3_24_14 gp_3_24_14 0 {Cg}
Mp_3_24_14 hv_L2_46 gp_3_24_14 colp_L3_24 0 NSYN W=10u L=1u
Mn_3_24_14 hv_L2_46 vcn coln_L3_24 0 NSYN W=10u L=1u
C_gp_3_24_15 gp_3_24_15 0 {Cg}
Mp_3_24_15 hv_L2_47 gp_3_24_15 colp_L3_24 0 NSYN W=10u L=1u
Mn_3_24_15 hv_L2_47 vcn coln_L3_24 0 NSYN W=10u L=1u
C_gp_3_24_b gp_3_24_b 0 {Cg}
Mp_3_24_b bx gp_3_24_b colp_L3_24 0 NSYN W=10u L=1u
Mn_3_24_b bx vcn coln_L3_24 0 NSYN W=10u L=1u
Msa_h_L3_24 coln_L3_24 coln_L3_24 0 0 NMIR W=20u L=1u
Msb_h_L3_24 z_L3_24 coln_L3_24 0 0 NMIR W=20u L=1u
Msc_h_L3_24 colp_L3_24 colp_L3_24 0 0 NMIR W=20u L=1u
Msd_h_L3_24 dpf_h_L3_24 colp_L3_24 0 0 NMIR W=20u L=1u
Mse_h_L3_24 dpf_h_L3_24 dpf_h_L3_24 vdd vdd PMIR W=60u L=1u
Msf_h_L3_24 z_L3_24 dpf_h_L3_24 vdd vdd PMIR W=60u L=1u
R_h_L3_24 z_L3_24 vrefh 8000.0
Mr_L3_24  hdd_L3_24 z_L3_24 tail_L3_24 0 NREL W=12u L=1u
Mr2_L3_24 dmp_L3_24  vmid  tail_L3_24 0 NREL W=12u L=1u
Mtl_L3_24 tail_L3_24 vtb 0 0 NREL W=32.0u L=1u
Mdm_L3_24 dmp_L3_24 dmp_L3_24 vdd vdd PMIR W=40u L=1u
Mrp1_L3_24 hdd_L3_24 hdd_L3_24 vdd vdd PMIR W=40u L=1u
Mrp2_L3_24 hv_L3_24 hdd_L3_24 vdd vdd PMIR W=40u L=1u
Rhv_L3_24 hv_L3_24 vg0 8000.0
C_gp_3_25_0 gp_3_25_0 0 {Cg}
Mp_3_25_0 hv_L2_1 gp_3_25_0 colp_L3_25 0 NSYN W=10u L=1u
Mn_3_25_0 hv_L2_1 vcn coln_L3_25 0 NSYN W=10u L=1u
C_gp_3_25_1 gp_3_25_1 0 {Cg}
Mp_3_25_1 hv_L2_5 gp_3_25_1 colp_L3_25 0 NSYN W=10u L=1u
Mn_3_25_1 hv_L2_5 vcn coln_L3_25 0 NSYN W=10u L=1u
C_gp_3_25_2 gp_3_25_2 0 {Cg}
Mp_3_25_2 hv_L2_7 gp_3_25_2 colp_L3_25 0 NSYN W=10u L=1u
Mn_3_25_2 hv_L2_7 vcn coln_L3_25 0 NSYN W=10u L=1u
C_gp_3_25_3 gp_3_25_3 0 {Cg}
Mp_3_25_3 hv_L2_8 gp_3_25_3 colp_L3_25 0 NSYN W=10u L=1u
Mn_3_25_3 hv_L2_8 vcn coln_L3_25 0 NSYN W=10u L=1u
C_gp_3_25_4 gp_3_25_4 0 {Cg}
Mp_3_25_4 hv_L2_15 gp_3_25_4 colp_L3_25 0 NSYN W=10u L=1u
Mn_3_25_4 hv_L2_15 vcn coln_L3_25 0 NSYN W=10u L=1u
C_gp_3_25_5 gp_3_25_5 0 {Cg}
Mp_3_25_5 hv_L2_17 gp_3_25_5 colp_L3_25 0 NSYN W=10u L=1u
Mn_3_25_5 hv_L2_17 vcn coln_L3_25 0 NSYN W=10u L=1u
C_gp_3_25_6 gp_3_25_6 0 {Cg}
Mp_3_25_6 hv_L2_19 gp_3_25_6 colp_L3_25 0 NSYN W=10u L=1u
Mn_3_25_6 hv_L2_19 vcn coln_L3_25 0 NSYN W=10u L=1u
C_gp_3_25_7 gp_3_25_7 0 {Cg}
Mp_3_25_7 hv_L2_23 gp_3_25_7 colp_L3_25 0 NSYN W=10u L=1u
Mn_3_25_7 hv_L2_23 vcn coln_L3_25 0 NSYN W=10u L=1u
C_gp_3_25_8 gp_3_25_8 0 {Cg}
Mp_3_25_8 hv_L2_25 gp_3_25_8 colp_L3_25 0 NSYN W=10u L=1u
Mn_3_25_8 hv_L2_25 vcn coln_L3_25 0 NSYN W=10u L=1u
C_gp_3_25_9 gp_3_25_9 0 {Cg}
Mp_3_25_9 hv_L2_26 gp_3_25_9 colp_L3_25 0 NSYN W=10u L=1u
Mn_3_25_9 hv_L2_26 vcn coln_L3_25 0 NSYN W=10u L=1u
C_gp_3_25_10 gp_3_25_10 0 {Cg}
Mp_3_25_10 hv_L2_27 gp_3_25_10 colp_L3_25 0 NSYN W=10u L=1u
Mn_3_25_10 hv_L2_27 vcn coln_L3_25 0 NSYN W=10u L=1u
C_gp_3_25_11 gp_3_25_11 0 {Cg}
Mp_3_25_11 hv_L2_38 gp_3_25_11 colp_L3_25 0 NSYN W=10u L=1u
Mn_3_25_11 hv_L2_38 vcn coln_L3_25 0 NSYN W=10u L=1u
C_gp_3_25_12 gp_3_25_12 0 {Cg}
Mp_3_25_12 hv_L2_42 gp_3_25_12 colp_L3_25 0 NSYN W=10u L=1u
Mn_3_25_12 hv_L2_42 vcn coln_L3_25 0 NSYN W=10u L=1u
C_gp_3_25_13 gp_3_25_13 0 {Cg}
Mp_3_25_13 hv_L2_44 gp_3_25_13 colp_L3_25 0 NSYN W=10u L=1u
Mn_3_25_13 hv_L2_44 vcn coln_L3_25 0 NSYN W=10u L=1u
C_gp_3_25_14 gp_3_25_14 0 {Cg}
Mp_3_25_14 hv_L2_45 gp_3_25_14 colp_L3_25 0 NSYN W=10u L=1u
Mn_3_25_14 hv_L2_45 vcn coln_L3_25 0 NSYN W=10u L=1u
C_gp_3_25_15 gp_3_25_15 0 {Cg}
Mp_3_25_15 hv_L2_47 gp_3_25_15 colp_L3_25 0 NSYN W=10u L=1u
Mn_3_25_15 hv_L2_47 vcn coln_L3_25 0 NSYN W=10u L=1u
C_gp_3_25_b gp_3_25_b 0 {Cg}
Mp_3_25_b bx gp_3_25_b colp_L3_25 0 NSYN W=10u L=1u
Mn_3_25_b bx vcn coln_L3_25 0 NSYN W=10u L=1u
Msa_h_L3_25 coln_L3_25 coln_L3_25 0 0 NMIR W=20u L=1u
Msb_h_L3_25 z_L3_25 coln_L3_25 0 0 NMIR W=20u L=1u
Msc_h_L3_25 colp_L3_25 colp_L3_25 0 0 NMIR W=20u L=1u
Msd_h_L3_25 dpf_h_L3_25 colp_L3_25 0 0 NMIR W=20u L=1u
Mse_h_L3_25 dpf_h_L3_25 dpf_h_L3_25 vdd vdd PMIR W=60u L=1u
Msf_h_L3_25 z_L3_25 dpf_h_L3_25 vdd vdd PMIR W=60u L=1u
R_h_L3_25 z_L3_25 vrefh 8000.0
Mr_L3_25  hdd_L3_25 z_L3_25 tail_L3_25 0 NREL W=12u L=1u
Mr2_L3_25 dmp_L3_25  vmid  tail_L3_25 0 NREL W=12u L=1u
Mtl_L3_25 tail_L3_25 vtb 0 0 NREL W=32.0u L=1u
Mdm_L3_25 dmp_L3_25 dmp_L3_25 vdd vdd PMIR W=40u L=1u
Mrp1_L3_25 hdd_L3_25 hdd_L3_25 vdd vdd PMIR W=40u L=1u
Mrp2_L3_25 hv_L3_25 hdd_L3_25 vdd vdd PMIR W=40u L=1u
Rhv_L3_25 hv_L3_25 vg0 8000.0
C_gp_3_26_0 gp_3_26_0 0 {Cg}
Mp_3_26_0 hv_L2_0 gp_3_26_0 colp_L3_26 0 NSYN W=10u L=1u
Mn_3_26_0 hv_L2_0 vcn coln_L3_26 0 NSYN W=10u L=1u
C_gp_3_26_1 gp_3_26_1 0 {Cg}
Mp_3_26_1 hv_L2_4 gp_3_26_1 colp_L3_26 0 NSYN W=10u L=1u
Mn_3_26_1 hv_L2_4 vcn coln_L3_26 0 NSYN W=10u L=1u
C_gp_3_26_2 gp_3_26_2 0 {Cg}
Mp_3_26_2 hv_L2_6 gp_3_26_2 colp_L3_26 0 NSYN W=10u L=1u
Mn_3_26_2 hv_L2_6 vcn coln_L3_26 0 NSYN W=10u L=1u
C_gp_3_26_3 gp_3_26_3 0 {Cg}
Mp_3_26_3 hv_L2_9 gp_3_26_3 colp_L3_26 0 NSYN W=10u L=1u
Mn_3_26_3 hv_L2_9 vcn coln_L3_26 0 NSYN W=10u L=1u
C_gp_3_26_4 gp_3_26_4 0 {Cg}
Mp_3_26_4 hv_L2_11 gp_3_26_4 colp_L3_26 0 NSYN W=10u L=1u
Mn_3_26_4 hv_L2_11 vcn coln_L3_26 0 NSYN W=10u L=1u
C_gp_3_26_5 gp_3_26_5 0 {Cg}
Mp_3_26_5 hv_L2_14 gp_3_26_5 colp_L3_26 0 NSYN W=10u L=1u
Mn_3_26_5 hv_L2_14 vcn coln_L3_26 0 NSYN W=10u L=1u
C_gp_3_26_6 gp_3_26_6 0 {Cg}
Mp_3_26_6 hv_L2_19 gp_3_26_6 colp_L3_26 0 NSYN W=10u L=1u
Mn_3_26_6 hv_L2_19 vcn coln_L3_26 0 NSYN W=10u L=1u
C_gp_3_26_7 gp_3_26_7 0 {Cg}
Mp_3_26_7 hv_L2_21 gp_3_26_7 colp_L3_26 0 NSYN W=10u L=1u
Mn_3_26_7 hv_L2_21 vcn coln_L3_26 0 NSYN W=10u L=1u
C_gp_3_26_8 gp_3_26_8 0 {Cg}
Mp_3_26_8 hv_L2_22 gp_3_26_8 colp_L3_26 0 NSYN W=10u L=1u
Mn_3_26_8 hv_L2_22 vcn coln_L3_26 0 NSYN W=10u L=1u
C_gp_3_26_9 gp_3_26_9 0 {Cg}
Mp_3_26_9 hv_L2_25 gp_3_26_9 colp_L3_26 0 NSYN W=10u L=1u
Mn_3_26_9 hv_L2_25 vcn coln_L3_26 0 NSYN W=10u L=1u
C_gp_3_26_10 gp_3_26_10 0 {Cg}
Mp_3_26_10 hv_L2_28 gp_3_26_10 colp_L3_26 0 NSYN W=10u L=1u
Mn_3_26_10 hv_L2_28 vcn coln_L3_26 0 NSYN W=10u L=1u
C_gp_3_26_11 gp_3_26_11 0 {Cg}
Mp_3_26_11 hv_L2_32 gp_3_26_11 colp_L3_26 0 NSYN W=10u L=1u
Mn_3_26_11 hv_L2_32 vcn coln_L3_26 0 NSYN W=10u L=1u
C_gp_3_26_12 gp_3_26_12 0 {Cg}
Mp_3_26_12 hv_L2_35 gp_3_26_12 colp_L3_26 0 NSYN W=10u L=1u
Mn_3_26_12 hv_L2_35 vcn coln_L3_26 0 NSYN W=10u L=1u
C_gp_3_26_13 gp_3_26_13 0 {Cg}
Mp_3_26_13 hv_L2_37 gp_3_26_13 colp_L3_26 0 NSYN W=10u L=1u
Mn_3_26_13 hv_L2_37 vcn coln_L3_26 0 NSYN W=10u L=1u
C_gp_3_26_14 gp_3_26_14 0 {Cg}
Mp_3_26_14 hv_L2_42 gp_3_26_14 colp_L3_26 0 NSYN W=10u L=1u
Mn_3_26_14 hv_L2_42 vcn coln_L3_26 0 NSYN W=10u L=1u
C_gp_3_26_15 gp_3_26_15 0 {Cg}
Mp_3_26_15 hv_L2_43 gp_3_26_15 colp_L3_26 0 NSYN W=10u L=1u
Mn_3_26_15 hv_L2_43 vcn coln_L3_26 0 NSYN W=10u L=1u
C_gp_3_26_b gp_3_26_b 0 {Cg}
Mp_3_26_b bx gp_3_26_b colp_L3_26 0 NSYN W=10u L=1u
Mn_3_26_b bx vcn coln_L3_26 0 NSYN W=10u L=1u
Msa_h_L3_26 coln_L3_26 coln_L3_26 0 0 NMIR W=20u L=1u
Msb_h_L3_26 z_L3_26 coln_L3_26 0 0 NMIR W=20u L=1u
Msc_h_L3_26 colp_L3_26 colp_L3_26 0 0 NMIR W=20u L=1u
Msd_h_L3_26 dpf_h_L3_26 colp_L3_26 0 0 NMIR W=20u L=1u
Mse_h_L3_26 dpf_h_L3_26 dpf_h_L3_26 vdd vdd PMIR W=60u L=1u
Msf_h_L3_26 z_L3_26 dpf_h_L3_26 vdd vdd PMIR W=60u L=1u
R_h_L3_26 z_L3_26 vrefh 8000.0
Mr_L3_26  hdd_L3_26 z_L3_26 tail_L3_26 0 NREL W=12u L=1u
Mr2_L3_26 dmp_L3_26  vmid  tail_L3_26 0 NREL W=12u L=1u
Mtl_L3_26 tail_L3_26 vtb 0 0 NREL W=32.0u L=1u
Mdm_L3_26 dmp_L3_26 dmp_L3_26 vdd vdd PMIR W=40u L=1u
Mrp1_L3_26 hdd_L3_26 hdd_L3_26 vdd vdd PMIR W=40u L=1u
Mrp2_L3_26 hv_L3_26 hdd_L3_26 vdd vdd PMIR W=40u L=1u
Rhv_L3_26 hv_L3_26 vg0 8000.0
C_gp_3_27_0 gp_3_27_0 0 {Cg}
Mp_3_27_0 hv_L2_1 gp_3_27_0 colp_L3_27 0 NSYN W=10u L=1u
Mn_3_27_0 hv_L2_1 vcn coln_L3_27 0 NSYN W=10u L=1u
C_gp_3_27_1 gp_3_27_1 0 {Cg}
Mp_3_27_1 hv_L2_2 gp_3_27_1 colp_L3_27 0 NSYN W=10u L=1u
Mn_3_27_1 hv_L2_2 vcn coln_L3_27 0 NSYN W=10u L=1u
C_gp_3_27_2 gp_3_27_2 0 {Cg}
Mp_3_27_2 hv_L2_13 gp_3_27_2 colp_L3_27 0 NSYN W=10u L=1u
Mn_3_27_2 hv_L2_13 vcn coln_L3_27 0 NSYN W=10u L=1u
C_gp_3_27_3 gp_3_27_3 0 {Cg}
Mp_3_27_3 hv_L2_14 gp_3_27_3 colp_L3_27 0 NSYN W=10u L=1u
Mn_3_27_3 hv_L2_14 vcn coln_L3_27 0 NSYN W=10u L=1u
C_gp_3_27_4 gp_3_27_4 0 {Cg}
Mp_3_27_4 hv_L2_16 gp_3_27_4 colp_L3_27 0 NSYN W=10u L=1u
Mn_3_27_4 hv_L2_16 vcn coln_L3_27 0 NSYN W=10u L=1u
C_gp_3_27_5 gp_3_27_5 0 {Cg}
Mp_3_27_5 hv_L2_22 gp_3_27_5 colp_L3_27 0 NSYN W=10u L=1u
Mn_3_27_5 hv_L2_22 vcn coln_L3_27 0 NSYN W=10u L=1u
C_gp_3_27_6 gp_3_27_6 0 {Cg}
Mp_3_27_6 hv_L2_25 gp_3_27_6 colp_L3_27 0 NSYN W=10u L=1u
Mn_3_27_6 hv_L2_25 vcn coln_L3_27 0 NSYN W=10u L=1u
C_gp_3_27_7 gp_3_27_7 0 {Cg}
Mp_3_27_7 hv_L2_26 gp_3_27_7 colp_L3_27 0 NSYN W=10u L=1u
Mn_3_27_7 hv_L2_26 vcn coln_L3_27 0 NSYN W=10u L=1u
C_gp_3_27_8 gp_3_27_8 0 {Cg}
Mp_3_27_8 hv_L2_28 gp_3_27_8 colp_L3_27 0 NSYN W=10u L=1u
Mn_3_27_8 hv_L2_28 vcn coln_L3_27 0 NSYN W=10u L=1u
C_gp_3_27_9 gp_3_27_9 0 {Cg}
Mp_3_27_9 hv_L2_30 gp_3_27_9 colp_L3_27 0 NSYN W=10u L=1u
Mn_3_27_9 hv_L2_30 vcn coln_L3_27 0 NSYN W=10u L=1u
C_gp_3_27_10 gp_3_27_10 0 {Cg}
Mp_3_27_10 hv_L2_31 gp_3_27_10 colp_L3_27 0 NSYN W=10u L=1u
Mn_3_27_10 hv_L2_31 vcn coln_L3_27 0 NSYN W=10u L=1u
C_gp_3_27_11 gp_3_27_11 0 {Cg}
Mp_3_27_11 hv_L2_32 gp_3_27_11 colp_L3_27 0 NSYN W=10u L=1u
Mn_3_27_11 hv_L2_32 vcn coln_L3_27 0 NSYN W=10u L=1u
C_gp_3_27_12 gp_3_27_12 0 {Cg}
Mp_3_27_12 hv_L2_33 gp_3_27_12 colp_L3_27 0 NSYN W=10u L=1u
Mn_3_27_12 hv_L2_33 vcn coln_L3_27 0 NSYN W=10u L=1u
C_gp_3_27_13 gp_3_27_13 0 {Cg}
Mp_3_27_13 hv_L2_34 gp_3_27_13 colp_L3_27 0 NSYN W=10u L=1u
Mn_3_27_13 hv_L2_34 vcn coln_L3_27 0 NSYN W=10u L=1u
C_gp_3_27_14 gp_3_27_14 0 {Cg}
Mp_3_27_14 hv_L2_39 gp_3_27_14 colp_L3_27 0 NSYN W=10u L=1u
Mn_3_27_14 hv_L2_39 vcn coln_L3_27 0 NSYN W=10u L=1u
C_gp_3_27_15 gp_3_27_15 0 {Cg}
Mp_3_27_15 hv_L2_45 gp_3_27_15 colp_L3_27 0 NSYN W=10u L=1u
Mn_3_27_15 hv_L2_45 vcn coln_L3_27 0 NSYN W=10u L=1u
C_gp_3_27_b gp_3_27_b 0 {Cg}
Mp_3_27_b bx gp_3_27_b colp_L3_27 0 NSYN W=10u L=1u
Mn_3_27_b bx vcn coln_L3_27 0 NSYN W=10u L=1u
Msa_h_L3_27 coln_L3_27 coln_L3_27 0 0 NMIR W=20u L=1u
Msb_h_L3_27 z_L3_27 coln_L3_27 0 0 NMIR W=20u L=1u
Msc_h_L3_27 colp_L3_27 colp_L3_27 0 0 NMIR W=20u L=1u
Msd_h_L3_27 dpf_h_L3_27 colp_L3_27 0 0 NMIR W=20u L=1u
Mse_h_L3_27 dpf_h_L3_27 dpf_h_L3_27 vdd vdd PMIR W=60u L=1u
Msf_h_L3_27 z_L3_27 dpf_h_L3_27 vdd vdd PMIR W=60u L=1u
R_h_L3_27 z_L3_27 vrefh 8000.0
Mr_L3_27  hdd_L3_27 z_L3_27 tail_L3_27 0 NREL W=12u L=1u
Mr2_L3_27 dmp_L3_27  vmid  tail_L3_27 0 NREL W=12u L=1u
Mtl_L3_27 tail_L3_27 vtb 0 0 NREL W=32.0u L=1u
Mdm_L3_27 dmp_L3_27 dmp_L3_27 vdd vdd PMIR W=40u L=1u
Mrp1_L3_27 hdd_L3_27 hdd_L3_27 vdd vdd PMIR W=40u L=1u
Mrp2_L3_27 hv_L3_27 hdd_L3_27 vdd vdd PMIR W=40u L=1u
Rhv_L3_27 hv_L3_27 vg0 8000.0
C_gp_3_28_0 gp_3_28_0 0 {Cg}
Mp_3_28_0 hv_L2_0 gp_3_28_0 colp_L3_28 0 NSYN W=10u L=1u
Mn_3_28_0 hv_L2_0 vcn coln_L3_28 0 NSYN W=10u L=1u
C_gp_3_28_1 gp_3_28_1 0 {Cg}
Mp_3_28_1 hv_L2_1 gp_3_28_1 colp_L3_28 0 NSYN W=10u L=1u
Mn_3_28_1 hv_L2_1 vcn coln_L3_28 0 NSYN W=10u L=1u
C_gp_3_28_2 gp_3_28_2 0 {Cg}
Mp_3_28_2 hv_L2_3 gp_3_28_2 colp_L3_28 0 NSYN W=10u L=1u
Mn_3_28_2 hv_L2_3 vcn coln_L3_28 0 NSYN W=10u L=1u
C_gp_3_28_3 gp_3_28_3 0 {Cg}
Mp_3_28_3 hv_L2_5 gp_3_28_3 colp_L3_28 0 NSYN W=10u L=1u
Mn_3_28_3 hv_L2_5 vcn coln_L3_28 0 NSYN W=10u L=1u
C_gp_3_28_4 gp_3_28_4 0 {Cg}
Mp_3_28_4 hv_L2_7 gp_3_28_4 colp_L3_28 0 NSYN W=10u L=1u
Mn_3_28_4 hv_L2_7 vcn coln_L3_28 0 NSYN W=10u L=1u
C_gp_3_28_5 gp_3_28_5 0 {Cg}
Mp_3_28_5 hv_L2_10 gp_3_28_5 colp_L3_28 0 NSYN W=10u L=1u
Mn_3_28_5 hv_L2_10 vcn coln_L3_28 0 NSYN W=10u L=1u
C_gp_3_28_6 gp_3_28_6 0 {Cg}
Mp_3_28_6 hv_L2_15 gp_3_28_6 colp_L3_28 0 NSYN W=10u L=1u
Mn_3_28_6 hv_L2_15 vcn coln_L3_28 0 NSYN W=10u L=1u
C_gp_3_28_7 gp_3_28_7 0 {Cg}
Mp_3_28_7 hv_L2_19 gp_3_28_7 colp_L3_28 0 NSYN W=10u L=1u
Mn_3_28_7 hv_L2_19 vcn coln_L3_28 0 NSYN W=10u L=1u
C_gp_3_28_8 gp_3_28_8 0 {Cg}
Mp_3_28_8 hv_L2_26 gp_3_28_8 colp_L3_28 0 NSYN W=10u L=1u
Mn_3_28_8 hv_L2_26 vcn coln_L3_28 0 NSYN W=10u L=1u
C_gp_3_28_9 gp_3_28_9 0 {Cg}
Mp_3_28_9 hv_L2_31 gp_3_28_9 colp_L3_28 0 NSYN W=10u L=1u
Mn_3_28_9 hv_L2_31 vcn coln_L3_28 0 NSYN W=10u L=1u
C_gp_3_28_10 gp_3_28_10 0 {Cg}
Mp_3_28_10 hv_L2_34 gp_3_28_10 colp_L3_28 0 NSYN W=10u L=1u
Mn_3_28_10 hv_L2_34 vcn coln_L3_28 0 NSYN W=10u L=1u
C_gp_3_28_11 gp_3_28_11 0 {Cg}
Mp_3_28_11 hv_L2_35 gp_3_28_11 colp_L3_28 0 NSYN W=10u L=1u
Mn_3_28_11 hv_L2_35 vcn coln_L3_28 0 NSYN W=10u L=1u
C_gp_3_28_12 gp_3_28_12 0 {Cg}
Mp_3_28_12 hv_L2_36 gp_3_28_12 colp_L3_28 0 NSYN W=10u L=1u
Mn_3_28_12 hv_L2_36 vcn coln_L3_28 0 NSYN W=10u L=1u
C_gp_3_28_13 gp_3_28_13 0 {Cg}
Mp_3_28_13 hv_L2_37 gp_3_28_13 colp_L3_28 0 NSYN W=10u L=1u
Mn_3_28_13 hv_L2_37 vcn coln_L3_28 0 NSYN W=10u L=1u
C_gp_3_28_14 gp_3_28_14 0 {Cg}
Mp_3_28_14 hv_L2_40 gp_3_28_14 colp_L3_28 0 NSYN W=10u L=1u
Mn_3_28_14 hv_L2_40 vcn coln_L3_28 0 NSYN W=10u L=1u
C_gp_3_28_15 gp_3_28_15 0 {Cg}
Mp_3_28_15 hv_L2_45 gp_3_28_15 colp_L3_28 0 NSYN W=10u L=1u
Mn_3_28_15 hv_L2_45 vcn coln_L3_28 0 NSYN W=10u L=1u
C_gp_3_28_b gp_3_28_b 0 {Cg}
Mp_3_28_b bx gp_3_28_b colp_L3_28 0 NSYN W=10u L=1u
Mn_3_28_b bx vcn coln_L3_28 0 NSYN W=10u L=1u
Msa_h_L3_28 coln_L3_28 coln_L3_28 0 0 NMIR W=20u L=1u
Msb_h_L3_28 z_L3_28 coln_L3_28 0 0 NMIR W=20u L=1u
Msc_h_L3_28 colp_L3_28 colp_L3_28 0 0 NMIR W=20u L=1u
Msd_h_L3_28 dpf_h_L3_28 colp_L3_28 0 0 NMIR W=20u L=1u
Mse_h_L3_28 dpf_h_L3_28 dpf_h_L3_28 vdd vdd PMIR W=60u L=1u
Msf_h_L3_28 z_L3_28 dpf_h_L3_28 vdd vdd PMIR W=60u L=1u
R_h_L3_28 z_L3_28 vrefh 8000.0
Mr_L3_28  hdd_L3_28 z_L3_28 tail_L3_28 0 NREL W=12u L=1u
Mr2_L3_28 dmp_L3_28  vmid  tail_L3_28 0 NREL W=12u L=1u
Mtl_L3_28 tail_L3_28 vtb 0 0 NREL W=32.0u L=1u
Mdm_L3_28 dmp_L3_28 dmp_L3_28 vdd vdd PMIR W=40u L=1u
Mrp1_L3_28 hdd_L3_28 hdd_L3_28 vdd vdd PMIR W=40u L=1u
Mrp2_L3_28 hv_L3_28 hdd_L3_28 vdd vdd PMIR W=40u L=1u
Rhv_L3_28 hv_L3_28 vg0 8000.0
C_gp_3_29_0 gp_3_29_0 0 {Cg}
Mp_3_29_0 hv_L2_1 gp_3_29_0 colp_L3_29 0 NSYN W=10u L=1u
Mn_3_29_0 hv_L2_1 vcn coln_L3_29 0 NSYN W=10u L=1u
C_gp_3_29_1 gp_3_29_1 0 {Cg}
Mp_3_29_1 hv_L2_4 gp_3_29_1 colp_L3_29 0 NSYN W=10u L=1u
Mn_3_29_1 hv_L2_4 vcn coln_L3_29 0 NSYN W=10u L=1u
C_gp_3_29_2 gp_3_29_2 0 {Cg}
Mp_3_29_2 hv_L2_9 gp_3_29_2 colp_L3_29 0 NSYN W=10u L=1u
Mn_3_29_2 hv_L2_9 vcn coln_L3_29 0 NSYN W=10u L=1u
C_gp_3_29_3 gp_3_29_3 0 {Cg}
Mp_3_29_3 hv_L2_11 gp_3_29_3 colp_L3_29 0 NSYN W=10u L=1u
Mn_3_29_3 hv_L2_11 vcn coln_L3_29 0 NSYN W=10u L=1u
C_gp_3_29_4 gp_3_29_4 0 {Cg}
Mp_3_29_4 hv_L2_12 gp_3_29_4 colp_L3_29 0 NSYN W=10u L=1u
Mn_3_29_4 hv_L2_12 vcn coln_L3_29 0 NSYN W=10u L=1u
C_gp_3_29_5 gp_3_29_5 0 {Cg}
Mp_3_29_5 hv_L2_16 gp_3_29_5 colp_L3_29 0 NSYN W=10u L=1u
Mn_3_29_5 hv_L2_16 vcn coln_L3_29 0 NSYN W=10u L=1u
C_gp_3_29_6 gp_3_29_6 0 {Cg}
Mp_3_29_6 hv_L2_18 gp_3_29_6 colp_L3_29 0 NSYN W=10u L=1u
Mn_3_29_6 hv_L2_18 vcn coln_L3_29 0 NSYN W=10u L=1u
C_gp_3_29_7 gp_3_29_7 0 {Cg}
Mp_3_29_7 hv_L2_20 gp_3_29_7 colp_L3_29 0 NSYN W=10u L=1u
Mn_3_29_7 hv_L2_20 vcn coln_L3_29 0 NSYN W=10u L=1u
C_gp_3_29_8 gp_3_29_8 0 {Cg}
Mp_3_29_8 hv_L2_21 gp_3_29_8 colp_L3_29 0 NSYN W=10u L=1u
Mn_3_29_8 hv_L2_21 vcn coln_L3_29 0 NSYN W=10u L=1u
C_gp_3_29_9 gp_3_29_9 0 {Cg}
Mp_3_29_9 hv_L2_23 gp_3_29_9 colp_L3_29 0 NSYN W=10u L=1u
Mn_3_29_9 hv_L2_23 vcn coln_L3_29 0 NSYN W=10u L=1u
C_gp_3_29_10 gp_3_29_10 0 {Cg}
Mp_3_29_10 hv_L2_33 gp_3_29_10 colp_L3_29 0 NSYN W=10u L=1u
Mn_3_29_10 hv_L2_33 vcn coln_L3_29 0 NSYN W=10u L=1u
C_gp_3_29_11 gp_3_29_11 0 {Cg}
Mp_3_29_11 hv_L2_36 gp_3_29_11 colp_L3_29 0 NSYN W=10u L=1u
Mn_3_29_11 hv_L2_36 vcn coln_L3_29 0 NSYN W=10u L=1u
C_gp_3_29_12 gp_3_29_12 0 {Cg}
Mp_3_29_12 hv_L2_37 gp_3_29_12 colp_L3_29 0 NSYN W=10u L=1u
Mn_3_29_12 hv_L2_37 vcn coln_L3_29 0 NSYN W=10u L=1u
C_gp_3_29_13 gp_3_29_13 0 {Cg}
Mp_3_29_13 hv_L2_39 gp_3_29_13 colp_L3_29 0 NSYN W=10u L=1u
Mn_3_29_13 hv_L2_39 vcn coln_L3_29 0 NSYN W=10u L=1u
C_gp_3_29_14 gp_3_29_14 0 {Cg}
Mp_3_29_14 hv_L2_40 gp_3_29_14 colp_L3_29 0 NSYN W=10u L=1u
Mn_3_29_14 hv_L2_40 vcn coln_L3_29 0 NSYN W=10u L=1u
C_gp_3_29_15 gp_3_29_15 0 {Cg}
Mp_3_29_15 hv_L2_41 gp_3_29_15 colp_L3_29 0 NSYN W=10u L=1u
Mn_3_29_15 hv_L2_41 vcn coln_L3_29 0 NSYN W=10u L=1u
C_gp_3_29_b gp_3_29_b 0 {Cg}
Mp_3_29_b bx gp_3_29_b colp_L3_29 0 NSYN W=10u L=1u
Mn_3_29_b bx vcn coln_L3_29 0 NSYN W=10u L=1u
Msa_h_L3_29 coln_L3_29 coln_L3_29 0 0 NMIR W=20u L=1u
Msb_h_L3_29 z_L3_29 coln_L3_29 0 0 NMIR W=20u L=1u
Msc_h_L3_29 colp_L3_29 colp_L3_29 0 0 NMIR W=20u L=1u
Msd_h_L3_29 dpf_h_L3_29 colp_L3_29 0 0 NMIR W=20u L=1u
Mse_h_L3_29 dpf_h_L3_29 dpf_h_L3_29 vdd vdd PMIR W=60u L=1u
Msf_h_L3_29 z_L3_29 dpf_h_L3_29 vdd vdd PMIR W=60u L=1u
R_h_L3_29 z_L3_29 vrefh 8000.0
Mr_L3_29  hdd_L3_29 z_L3_29 tail_L3_29 0 NREL W=12u L=1u
Mr2_L3_29 dmp_L3_29  vmid  tail_L3_29 0 NREL W=12u L=1u
Mtl_L3_29 tail_L3_29 vtb 0 0 NREL W=32.0u L=1u
Mdm_L3_29 dmp_L3_29 dmp_L3_29 vdd vdd PMIR W=40u L=1u
Mrp1_L3_29 hdd_L3_29 hdd_L3_29 vdd vdd PMIR W=40u L=1u
Mrp2_L3_29 hv_L3_29 hdd_L3_29 vdd vdd PMIR W=40u L=1u
Rhv_L3_29 hv_L3_29 vg0 8000.0
C_gp_3_30_0 gp_3_30_0 0 {Cg}
Mp_3_30_0 hv_L2_5 gp_3_30_0 colp_L3_30 0 NSYN W=10u L=1u
Mn_3_30_0 hv_L2_5 vcn coln_L3_30 0 NSYN W=10u L=1u
C_gp_3_30_1 gp_3_30_1 0 {Cg}
Mp_3_30_1 hv_L2_8 gp_3_30_1 colp_L3_30 0 NSYN W=10u L=1u
Mn_3_30_1 hv_L2_8 vcn coln_L3_30 0 NSYN W=10u L=1u
C_gp_3_30_2 gp_3_30_2 0 {Cg}
Mp_3_30_2 hv_L2_11 gp_3_30_2 colp_L3_30 0 NSYN W=10u L=1u
Mn_3_30_2 hv_L2_11 vcn coln_L3_30 0 NSYN W=10u L=1u
C_gp_3_30_3 gp_3_30_3 0 {Cg}
Mp_3_30_3 hv_L2_13 gp_3_30_3 colp_L3_30 0 NSYN W=10u L=1u
Mn_3_30_3 hv_L2_13 vcn coln_L3_30 0 NSYN W=10u L=1u
C_gp_3_30_4 gp_3_30_4 0 {Cg}
Mp_3_30_4 hv_L2_15 gp_3_30_4 colp_L3_30 0 NSYN W=10u L=1u
Mn_3_30_4 hv_L2_15 vcn coln_L3_30 0 NSYN W=10u L=1u
C_gp_3_30_5 gp_3_30_5 0 {Cg}
Mp_3_30_5 hv_L2_17 gp_3_30_5 colp_L3_30 0 NSYN W=10u L=1u
Mn_3_30_5 hv_L2_17 vcn coln_L3_30 0 NSYN W=10u L=1u
C_gp_3_30_6 gp_3_30_6 0 {Cg}
Mp_3_30_6 hv_L2_19 gp_3_30_6 colp_L3_30 0 NSYN W=10u L=1u
Mn_3_30_6 hv_L2_19 vcn coln_L3_30 0 NSYN W=10u L=1u
C_gp_3_30_7 gp_3_30_7 0 {Cg}
Mp_3_30_7 hv_L2_20 gp_3_30_7 colp_L3_30 0 NSYN W=10u L=1u
Mn_3_30_7 hv_L2_20 vcn coln_L3_30 0 NSYN W=10u L=1u
C_gp_3_30_8 gp_3_30_8 0 {Cg}
Mp_3_30_8 hv_L2_27 gp_3_30_8 colp_L3_30 0 NSYN W=10u L=1u
Mn_3_30_8 hv_L2_27 vcn coln_L3_30 0 NSYN W=10u L=1u
C_gp_3_30_9 gp_3_30_9 0 {Cg}
Mp_3_30_9 hv_L2_29 gp_3_30_9 colp_L3_30 0 NSYN W=10u L=1u
Mn_3_30_9 hv_L2_29 vcn coln_L3_30 0 NSYN W=10u L=1u
C_gp_3_30_10 gp_3_30_10 0 {Cg}
Mp_3_30_10 hv_L2_32 gp_3_30_10 colp_L3_30 0 NSYN W=10u L=1u
Mn_3_30_10 hv_L2_32 vcn coln_L3_30 0 NSYN W=10u L=1u
C_gp_3_30_11 gp_3_30_11 0 {Cg}
Mp_3_30_11 hv_L2_34 gp_3_30_11 colp_L3_30 0 NSYN W=10u L=1u
Mn_3_30_11 hv_L2_34 vcn coln_L3_30 0 NSYN W=10u L=1u
C_gp_3_30_12 gp_3_30_12 0 {Cg}
Mp_3_30_12 hv_L2_39 gp_3_30_12 colp_L3_30 0 NSYN W=10u L=1u
Mn_3_30_12 hv_L2_39 vcn coln_L3_30 0 NSYN W=10u L=1u
C_gp_3_30_13 gp_3_30_13 0 {Cg}
Mp_3_30_13 hv_L2_42 gp_3_30_13 colp_L3_30 0 NSYN W=10u L=1u
Mn_3_30_13 hv_L2_42 vcn coln_L3_30 0 NSYN W=10u L=1u
C_gp_3_30_14 gp_3_30_14 0 {Cg}
Mp_3_30_14 hv_L2_43 gp_3_30_14 colp_L3_30 0 NSYN W=10u L=1u
Mn_3_30_14 hv_L2_43 vcn coln_L3_30 0 NSYN W=10u L=1u
C_gp_3_30_15 gp_3_30_15 0 {Cg}
Mp_3_30_15 hv_L2_47 gp_3_30_15 colp_L3_30 0 NSYN W=10u L=1u
Mn_3_30_15 hv_L2_47 vcn coln_L3_30 0 NSYN W=10u L=1u
C_gp_3_30_b gp_3_30_b 0 {Cg}
Mp_3_30_b bx gp_3_30_b colp_L3_30 0 NSYN W=10u L=1u
Mn_3_30_b bx vcn coln_L3_30 0 NSYN W=10u L=1u
Msa_h_L3_30 coln_L3_30 coln_L3_30 0 0 NMIR W=20u L=1u
Msb_h_L3_30 z_L3_30 coln_L3_30 0 0 NMIR W=20u L=1u
Msc_h_L3_30 colp_L3_30 colp_L3_30 0 0 NMIR W=20u L=1u
Msd_h_L3_30 dpf_h_L3_30 colp_L3_30 0 0 NMIR W=20u L=1u
Mse_h_L3_30 dpf_h_L3_30 dpf_h_L3_30 vdd vdd PMIR W=60u L=1u
Msf_h_L3_30 z_L3_30 dpf_h_L3_30 vdd vdd PMIR W=60u L=1u
R_h_L3_30 z_L3_30 vrefh 8000.0
Mr_L3_30  hdd_L3_30 z_L3_30 tail_L3_30 0 NREL W=12u L=1u
Mr2_L3_30 dmp_L3_30  vmid  tail_L3_30 0 NREL W=12u L=1u
Mtl_L3_30 tail_L3_30 vtb 0 0 NREL W=32.0u L=1u
Mdm_L3_30 dmp_L3_30 dmp_L3_30 vdd vdd PMIR W=40u L=1u
Mrp1_L3_30 hdd_L3_30 hdd_L3_30 vdd vdd PMIR W=40u L=1u
Mrp2_L3_30 hv_L3_30 hdd_L3_30 vdd vdd PMIR W=40u L=1u
Rhv_L3_30 hv_L3_30 vg0 8000.0
C_gp_3_31_0 gp_3_31_0 0 {Cg}
Mp_3_31_0 hv_L2_1 gp_3_31_0 colp_L3_31 0 NSYN W=10u L=1u
Mn_3_31_0 hv_L2_1 vcn coln_L3_31 0 NSYN W=10u L=1u
C_gp_3_31_1 gp_3_31_1 0 {Cg}
Mp_3_31_1 hv_L2_5 gp_3_31_1 colp_L3_31 0 NSYN W=10u L=1u
Mn_3_31_1 hv_L2_5 vcn coln_L3_31 0 NSYN W=10u L=1u
C_gp_3_31_2 gp_3_31_2 0 {Cg}
Mp_3_31_2 hv_L2_10 gp_3_31_2 colp_L3_31 0 NSYN W=10u L=1u
Mn_3_31_2 hv_L2_10 vcn coln_L3_31 0 NSYN W=10u L=1u
C_gp_3_31_3 gp_3_31_3 0 {Cg}
Mp_3_31_3 hv_L2_13 gp_3_31_3 colp_L3_31 0 NSYN W=10u L=1u
Mn_3_31_3 hv_L2_13 vcn coln_L3_31 0 NSYN W=10u L=1u
C_gp_3_31_4 gp_3_31_4 0 {Cg}
Mp_3_31_4 hv_L2_14 gp_3_31_4 colp_L3_31 0 NSYN W=10u L=1u
Mn_3_31_4 hv_L2_14 vcn coln_L3_31 0 NSYN W=10u L=1u
C_gp_3_31_5 gp_3_31_5 0 {Cg}
Mp_3_31_5 hv_L2_15 gp_3_31_5 colp_L3_31 0 NSYN W=10u L=1u
Mn_3_31_5 hv_L2_15 vcn coln_L3_31 0 NSYN W=10u L=1u
C_gp_3_31_6 gp_3_31_6 0 {Cg}
Mp_3_31_6 hv_L2_16 gp_3_31_6 colp_L3_31 0 NSYN W=10u L=1u
Mn_3_31_6 hv_L2_16 vcn coln_L3_31 0 NSYN W=10u L=1u
C_gp_3_31_7 gp_3_31_7 0 {Cg}
Mp_3_31_7 hv_L2_24 gp_3_31_7 colp_L3_31 0 NSYN W=10u L=1u
Mn_3_31_7 hv_L2_24 vcn coln_L3_31 0 NSYN W=10u L=1u
C_gp_3_31_8 gp_3_31_8 0 {Cg}
Mp_3_31_8 hv_L2_26 gp_3_31_8 colp_L3_31 0 NSYN W=10u L=1u
Mn_3_31_8 hv_L2_26 vcn coln_L3_31 0 NSYN W=10u L=1u
C_gp_3_31_9 gp_3_31_9 0 {Cg}
Mp_3_31_9 hv_L2_33 gp_3_31_9 colp_L3_31 0 NSYN W=10u L=1u
Mn_3_31_9 hv_L2_33 vcn coln_L3_31 0 NSYN W=10u L=1u
C_gp_3_31_10 gp_3_31_10 0 {Cg}
Mp_3_31_10 hv_L2_34 gp_3_31_10 colp_L3_31 0 NSYN W=10u L=1u
Mn_3_31_10 hv_L2_34 vcn coln_L3_31 0 NSYN W=10u L=1u
C_gp_3_31_11 gp_3_31_11 0 {Cg}
Mp_3_31_11 hv_L2_35 gp_3_31_11 colp_L3_31 0 NSYN W=10u L=1u
Mn_3_31_11 hv_L2_35 vcn coln_L3_31 0 NSYN W=10u L=1u
C_gp_3_31_12 gp_3_31_12 0 {Cg}
Mp_3_31_12 hv_L2_38 gp_3_31_12 colp_L3_31 0 NSYN W=10u L=1u
Mn_3_31_12 hv_L2_38 vcn coln_L3_31 0 NSYN W=10u L=1u
C_gp_3_31_13 gp_3_31_13 0 {Cg}
Mp_3_31_13 hv_L2_42 gp_3_31_13 colp_L3_31 0 NSYN W=10u L=1u
Mn_3_31_13 hv_L2_42 vcn coln_L3_31 0 NSYN W=10u L=1u
C_gp_3_31_14 gp_3_31_14 0 {Cg}
Mp_3_31_14 hv_L2_43 gp_3_31_14 colp_L3_31 0 NSYN W=10u L=1u
Mn_3_31_14 hv_L2_43 vcn coln_L3_31 0 NSYN W=10u L=1u
C_gp_3_31_15 gp_3_31_15 0 {Cg}
Mp_3_31_15 hv_L2_45 gp_3_31_15 colp_L3_31 0 NSYN W=10u L=1u
Mn_3_31_15 hv_L2_45 vcn coln_L3_31 0 NSYN W=10u L=1u
C_gp_3_31_b gp_3_31_b 0 {Cg}
Mp_3_31_b bx gp_3_31_b colp_L3_31 0 NSYN W=10u L=1u
Mn_3_31_b bx vcn coln_L3_31 0 NSYN W=10u L=1u
Msa_h_L3_31 coln_L3_31 coln_L3_31 0 0 NMIR W=20u L=1u
Msb_h_L3_31 z_L3_31 coln_L3_31 0 0 NMIR W=20u L=1u
Msc_h_L3_31 colp_L3_31 colp_L3_31 0 0 NMIR W=20u L=1u
Msd_h_L3_31 dpf_h_L3_31 colp_L3_31 0 0 NMIR W=20u L=1u
Mse_h_L3_31 dpf_h_L3_31 dpf_h_L3_31 vdd vdd PMIR W=60u L=1u
Msf_h_L3_31 z_L3_31 dpf_h_L3_31 vdd vdd PMIR W=60u L=1u
R_h_L3_31 z_L3_31 vrefh 8000.0
Mr_L3_31  hdd_L3_31 z_L3_31 tail_L3_31 0 NREL W=12u L=1u
Mr2_L3_31 dmp_L3_31  vmid  tail_L3_31 0 NREL W=12u L=1u
Mtl_L3_31 tail_L3_31 vtb 0 0 NREL W=32.0u L=1u
Mdm_L3_31 dmp_L3_31 dmp_L3_31 vdd vdd PMIR W=40u L=1u
Mrp1_L3_31 hdd_L3_31 hdd_L3_31 vdd vdd PMIR W=40u L=1u
Mrp2_L3_31 hv_L3_31 hdd_L3_31 vdd vdd PMIR W=40u L=1u
Rhv_L3_31 hv_L3_31 vg0 8000.0
C_gp_3_32_0 gp_3_32_0 0 {Cg}
Mp_3_32_0 hv_L2_3 gp_3_32_0 colp_L3_32 0 NSYN W=10u L=1u
Mn_3_32_0 hv_L2_3 vcn coln_L3_32 0 NSYN W=10u L=1u
C_gp_3_32_1 gp_3_32_1 0 {Cg}
Mp_3_32_1 hv_L2_5 gp_3_32_1 colp_L3_32 0 NSYN W=10u L=1u
Mn_3_32_1 hv_L2_5 vcn coln_L3_32 0 NSYN W=10u L=1u
C_gp_3_32_2 gp_3_32_2 0 {Cg}
Mp_3_32_2 hv_L2_7 gp_3_32_2 colp_L3_32 0 NSYN W=10u L=1u
Mn_3_32_2 hv_L2_7 vcn coln_L3_32 0 NSYN W=10u L=1u
C_gp_3_32_3 gp_3_32_3 0 {Cg}
Mp_3_32_3 hv_L2_8 gp_3_32_3 colp_L3_32 0 NSYN W=10u L=1u
Mn_3_32_3 hv_L2_8 vcn coln_L3_32 0 NSYN W=10u L=1u
C_gp_3_32_4 gp_3_32_4 0 {Cg}
Mp_3_32_4 hv_L2_9 gp_3_32_4 colp_L3_32 0 NSYN W=10u L=1u
Mn_3_32_4 hv_L2_9 vcn coln_L3_32 0 NSYN W=10u L=1u
C_gp_3_32_5 gp_3_32_5 0 {Cg}
Mp_3_32_5 hv_L2_13 gp_3_32_5 colp_L3_32 0 NSYN W=10u L=1u
Mn_3_32_5 hv_L2_13 vcn coln_L3_32 0 NSYN W=10u L=1u
C_gp_3_32_6 gp_3_32_6 0 {Cg}
Mp_3_32_6 hv_L2_16 gp_3_32_6 colp_L3_32 0 NSYN W=10u L=1u
Mn_3_32_6 hv_L2_16 vcn coln_L3_32 0 NSYN W=10u L=1u
C_gp_3_32_7 gp_3_32_7 0 {Cg}
Mp_3_32_7 hv_L2_19 gp_3_32_7 colp_L3_32 0 NSYN W=10u L=1u
Mn_3_32_7 hv_L2_19 vcn coln_L3_32 0 NSYN W=10u L=1u
C_gp_3_32_8 gp_3_32_8 0 {Cg}
Mp_3_32_8 hv_L2_20 gp_3_32_8 colp_L3_32 0 NSYN W=10u L=1u
Mn_3_32_8 hv_L2_20 vcn coln_L3_32 0 NSYN W=10u L=1u
C_gp_3_32_9 gp_3_32_9 0 {Cg}
Mp_3_32_9 hv_L2_24 gp_3_32_9 colp_L3_32 0 NSYN W=10u L=1u
Mn_3_32_9 hv_L2_24 vcn coln_L3_32 0 NSYN W=10u L=1u
C_gp_3_32_10 gp_3_32_10 0 {Cg}
Mp_3_32_10 hv_L2_26 gp_3_32_10 colp_L3_32 0 NSYN W=10u L=1u
Mn_3_32_10 hv_L2_26 vcn coln_L3_32 0 NSYN W=10u L=1u
C_gp_3_32_11 gp_3_32_11 0 {Cg}
Mp_3_32_11 hv_L2_27 gp_3_32_11 colp_L3_32 0 NSYN W=10u L=1u
Mn_3_32_11 hv_L2_27 vcn coln_L3_32 0 NSYN W=10u L=1u
C_gp_3_32_12 gp_3_32_12 0 {Cg}
Mp_3_32_12 hv_L2_39 gp_3_32_12 colp_L3_32 0 NSYN W=10u L=1u
Mn_3_32_12 hv_L2_39 vcn coln_L3_32 0 NSYN W=10u L=1u
C_gp_3_32_13 gp_3_32_13 0 {Cg}
Mp_3_32_13 hv_L2_42 gp_3_32_13 colp_L3_32 0 NSYN W=10u L=1u
Mn_3_32_13 hv_L2_42 vcn coln_L3_32 0 NSYN W=10u L=1u
C_gp_3_32_14 gp_3_32_14 0 {Cg}
Mp_3_32_14 hv_L2_43 gp_3_32_14 colp_L3_32 0 NSYN W=10u L=1u
Mn_3_32_14 hv_L2_43 vcn coln_L3_32 0 NSYN W=10u L=1u
C_gp_3_32_15 gp_3_32_15 0 {Cg}
Mp_3_32_15 hv_L2_44 gp_3_32_15 colp_L3_32 0 NSYN W=10u L=1u
Mn_3_32_15 hv_L2_44 vcn coln_L3_32 0 NSYN W=10u L=1u
C_gp_3_32_b gp_3_32_b 0 {Cg}
Mp_3_32_b bx gp_3_32_b colp_L3_32 0 NSYN W=10u L=1u
Mn_3_32_b bx vcn coln_L3_32 0 NSYN W=10u L=1u
Msa_h_L3_32 coln_L3_32 coln_L3_32 0 0 NMIR W=20u L=1u
Msb_h_L3_32 z_L3_32 coln_L3_32 0 0 NMIR W=20u L=1u
Msc_h_L3_32 colp_L3_32 colp_L3_32 0 0 NMIR W=20u L=1u
Msd_h_L3_32 dpf_h_L3_32 colp_L3_32 0 0 NMIR W=20u L=1u
Mse_h_L3_32 dpf_h_L3_32 dpf_h_L3_32 vdd vdd PMIR W=60u L=1u
Msf_h_L3_32 z_L3_32 dpf_h_L3_32 vdd vdd PMIR W=60u L=1u
R_h_L3_32 z_L3_32 vrefh 8000.0
Mr_L3_32  hdd_L3_32 z_L3_32 tail_L3_32 0 NREL W=12u L=1u
Mr2_L3_32 dmp_L3_32  vmid  tail_L3_32 0 NREL W=12u L=1u
Mtl_L3_32 tail_L3_32 vtb 0 0 NREL W=32.0u L=1u
Mdm_L3_32 dmp_L3_32 dmp_L3_32 vdd vdd PMIR W=40u L=1u
Mrp1_L3_32 hdd_L3_32 hdd_L3_32 vdd vdd PMIR W=40u L=1u
Mrp2_L3_32 hv_L3_32 hdd_L3_32 vdd vdd PMIR W=40u L=1u
Rhv_L3_32 hv_L3_32 vg0 8000.0
C_gp_3_33_0 gp_3_33_0 0 {Cg}
Mp_3_33_0 hv_L2_0 gp_3_33_0 colp_L3_33 0 NSYN W=10u L=1u
Mn_3_33_0 hv_L2_0 vcn coln_L3_33 0 NSYN W=10u L=1u
C_gp_3_33_1 gp_3_33_1 0 {Cg}
Mp_3_33_1 hv_L2_2 gp_3_33_1 colp_L3_33 0 NSYN W=10u L=1u
Mn_3_33_1 hv_L2_2 vcn coln_L3_33 0 NSYN W=10u L=1u
C_gp_3_33_2 gp_3_33_2 0 {Cg}
Mp_3_33_2 hv_L2_5 gp_3_33_2 colp_L3_33 0 NSYN W=10u L=1u
Mn_3_33_2 hv_L2_5 vcn coln_L3_33 0 NSYN W=10u L=1u
C_gp_3_33_3 gp_3_33_3 0 {Cg}
Mp_3_33_3 hv_L2_10 gp_3_33_3 colp_L3_33 0 NSYN W=10u L=1u
Mn_3_33_3 hv_L2_10 vcn coln_L3_33 0 NSYN W=10u L=1u
C_gp_3_33_4 gp_3_33_4 0 {Cg}
Mp_3_33_4 hv_L2_11 gp_3_33_4 colp_L3_33 0 NSYN W=10u L=1u
Mn_3_33_4 hv_L2_11 vcn coln_L3_33 0 NSYN W=10u L=1u
C_gp_3_33_5 gp_3_33_5 0 {Cg}
Mp_3_33_5 hv_L2_14 gp_3_33_5 colp_L3_33 0 NSYN W=10u L=1u
Mn_3_33_5 hv_L2_14 vcn coln_L3_33 0 NSYN W=10u L=1u
C_gp_3_33_6 gp_3_33_6 0 {Cg}
Mp_3_33_6 hv_L2_17 gp_3_33_6 colp_L3_33 0 NSYN W=10u L=1u
Mn_3_33_6 hv_L2_17 vcn coln_L3_33 0 NSYN W=10u L=1u
C_gp_3_33_7 gp_3_33_7 0 {Cg}
Mp_3_33_7 hv_L2_18 gp_3_33_7 colp_L3_33 0 NSYN W=10u L=1u
Mn_3_33_7 hv_L2_18 vcn coln_L3_33 0 NSYN W=10u L=1u
C_gp_3_33_8 gp_3_33_8 0 {Cg}
Mp_3_33_8 hv_L2_22 gp_3_33_8 colp_L3_33 0 NSYN W=10u L=1u
Mn_3_33_8 hv_L2_22 vcn coln_L3_33 0 NSYN W=10u L=1u
C_gp_3_33_9 gp_3_33_9 0 {Cg}
Mp_3_33_9 hv_L2_25 gp_3_33_9 colp_L3_33 0 NSYN W=10u L=1u
Mn_3_33_9 hv_L2_25 vcn coln_L3_33 0 NSYN W=10u L=1u
C_gp_3_33_10 gp_3_33_10 0 {Cg}
Mp_3_33_10 hv_L2_26 gp_3_33_10 colp_L3_33 0 NSYN W=10u L=1u
Mn_3_33_10 hv_L2_26 vcn coln_L3_33 0 NSYN W=10u L=1u
C_gp_3_33_11 gp_3_33_11 0 {Cg}
Mp_3_33_11 hv_L2_29 gp_3_33_11 colp_L3_33 0 NSYN W=10u L=1u
Mn_3_33_11 hv_L2_29 vcn coln_L3_33 0 NSYN W=10u L=1u
C_gp_3_33_12 gp_3_33_12 0 {Cg}
Mp_3_33_12 hv_L2_30 gp_3_33_12 colp_L3_33 0 NSYN W=10u L=1u
Mn_3_33_12 hv_L2_30 vcn coln_L3_33 0 NSYN W=10u L=1u
C_gp_3_33_13 gp_3_33_13 0 {Cg}
Mp_3_33_13 hv_L2_44 gp_3_33_13 colp_L3_33 0 NSYN W=10u L=1u
Mn_3_33_13 hv_L2_44 vcn coln_L3_33 0 NSYN W=10u L=1u
C_gp_3_33_14 gp_3_33_14 0 {Cg}
Mp_3_33_14 hv_L2_46 gp_3_33_14 colp_L3_33 0 NSYN W=10u L=1u
Mn_3_33_14 hv_L2_46 vcn coln_L3_33 0 NSYN W=10u L=1u
C_gp_3_33_15 gp_3_33_15 0 {Cg}
Mp_3_33_15 hv_L2_47 gp_3_33_15 colp_L3_33 0 NSYN W=10u L=1u
Mn_3_33_15 hv_L2_47 vcn coln_L3_33 0 NSYN W=10u L=1u
C_gp_3_33_b gp_3_33_b 0 {Cg}
Mp_3_33_b bx gp_3_33_b colp_L3_33 0 NSYN W=10u L=1u
Mn_3_33_b bx vcn coln_L3_33 0 NSYN W=10u L=1u
Msa_h_L3_33 coln_L3_33 coln_L3_33 0 0 NMIR W=20u L=1u
Msb_h_L3_33 z_L3_33 coln_L3_33 0 0 NMIR W=20u L=1u
Msc_h_L3_33 colp_L3_33 colp_L3_33 0 0 NMIR W=20u L=1u
Msd_h_L3_33 dpf_h_L3_33 colp_L3_33 0 0 NMIR W=20u L=1u
Mse_h_L3_33 dpf_h_L3_33 dpf_h_L3_33 vdd vdd PMIR W=60u L=1u
Msf_h_L3_33 z_L3_33 dpf_h_L3_33 vdd vdd PMIR W=60u L=1u
R_h_L3_33 z_L3_33 vrefh 8000.0
Mr_L3_33  hdd_L3_33 z_L3_33 tail_L3_33 0 NREL W=12u L=1u
Mr2_L3_33 dmp_L3_33  vmid  tail_L3_33 0 NREL W=12u L=1u
Mtl_L3_33 tail_L3_33 vtb 0 0 NREL W=32.0u L=1u
Mdm_L3_33 dmp_L3_33 dmp_L3_33 vdd vdd PMIR W=40u L=1u
Mrp1_L3_33 hdd_L3_33 hdd_L3_33 vdd vdd PMIR W=40u L=1u
Mrp2_L3_33 hv_L3_33 hdd_L3_33 vdd vdd PMIR W=40u L=1u
Rhv_L3_33 hv_L3_33 vg0 8000.0
C_gp_3_34_0 gp_3_34_0 0 {Cg}
Mp_3_34_0 hv_L2_6 gp_3_34_0 colp_L3_34 0 NSYN W=10u L=1u
Mn_3_34_0 hv_L2_6 vcn coln_L3_34 0 NSYN W=10u L=1u
C_gp_3_34_1 gp_3_34_1 0 {Cg}
Mp_3_34_1 hv_L2_7 gp_3_34_1 colp_L3_34 0 NSYN W=10u L=1u
Mn_3_34_1 hv_L2_7 vcn coln_L3_34 0 NSYN W=10u L=1u
C_gp_3_34_2 gp_3_34_2 0 {Cg}
Mp_3_34_2 hv_L2_9 gp_3_34_2 colp_L3_34 0 NSYN W=10u L=1u
Mn_3_34_2 hv_L2_9 vcn coln_L3_34 0 NSYN W=10u L=1u
C_gp_3_34_3 gp_3_34_3 0 {Cg}
Mp_3_34_3 hv_L2_12 gp_3_34_3 colp_L3_34 0 NSYN W=10u L=1u
Mn_3_34_3 hv_L2_12 vcn coln_L3_34 0 NSYN W=10u L=1u
C_gp_3_34_4 gp_3_34_4 0 {Cg}
Mp_3_34_4 hv_L2_15 gp_3_34_4 colp_L3_34 0 NSYN W=10u L=1u
Mn_3_34_4 hv_L2_15 vcn coln_L3_34 0 NSYN W=10u L=1u
C_gp_3_34_5 gp_3_34_5 0 {Cg}
Mp_3_34_5 hv_L2_16 gp_3_34_5 colp_L3_34 0 NSYN W=10u L=1u
Mn_3_34_5 hv_L2_16 vcn coln_L3_34 0 NSYN W=10u L=1u
C_gp_3_34_6 gp_3_34_6 0 {Cg}
Mp_3_34_6 hv_L2_17 gp_3_34_6 colp_L3_34 0 NSYN W=10u L=1u
Mn_3_34_6 hv_L2_17 vcn coln_L3_34 0 NSYN W=10u L=1u
C_gp_3_34_7 gp_3_34_7 0 {Cg}
Mp_3_34_7 hv_L2_22 gp_3_34_7 colp_L3_34 0 NSYN W=10u L=1u
Mn_3_34_7 hv_L2_22 vcn coln_L3_34 0 NSYN W=10u L=1u
C_gp_3_34_8 gp_3_34_8 0 {Cg}
Mp_3_34_8 hv_L2_24 gp_3_34_8 colp_L3_34 0 NSYN W=10u L=1u
Mn_3_34_8 hv_L2_24 vcn coln_L3_34 0 NSYN W=10u L=1u
C_gp_3_34_9 gp_3_34_9 0 {Cg}
Mp_3_34_9 hv_L2_25 gp_3_34_9 colp_L3_34 0 NSYN W=10u L=1u
Mn_3_34_9 hv_L2_25 vcn coln_L3_34 0 NSYN W=10u L=1u
C_gp_3_34_10 gp_3_34_10 0 {Cg}
Mp_3_34_10 hv_L2_31 gp_3_34_10 colp_L3_34 0 NSYN W=10u L=1u
Mn_3_34_10 hv_L2_31 vcn coln_L3_34 0 NSYN W=10u L=1u
C_gp_3_34_11 gp_3_34_11 0 {Cg}
Mp_3_34_11 hv_L2_32 gp_3_34_11 colp_L3_34 0 NSYN W=10u L=1u
Mn_3_34_11 hv_L2_32 vcn coln_L3_34 0 NSYN W=10u L=1u
C_gp_3_34_12 gp_3_34_12 0 {Cg}
Mp_3_34_12 hv_L2_38 gp_3_34_12 colp_L3_34 0 NSYN W=10u L=1u
Mn_3_34_12 hv_L2_38 vcn coln_L3_34 0 NSYN W=10u L=1u
C_gp_3_34_13 gp_3_34_13 0 {Cg}
Mp_3_34_13 hv_L2_41 gp_3_34_13 colp_L3_34 0 NSYN W=10u L=1u
Mn_3_34_13 hv_L2_41 vcn coln_L3_34 0 NSYN W=10u L=1u
C_gp_3_34_14 gp_3_34_14 0 {Cg}
Mp_3_34_14 hv_L2_43 gp_3_34_14 colp_L3_34 0 NSYN W=10u L=1u
Mn_3_34_14 hv_L2_43 vcn coln_L3_34 0 NSYN W=10u L=1u
C_gp_3_34_15 gp_3_34_15 0 {Cg}
Mp_3_34_15 hv_L2_46 gp_3_34_15 colp_L3_34 0 NSYN W=10u L=1u
Mn_3_34_15 hv_L2_46 vcn coln_L3_34 0 NSYN W=10u L=1u
C_gp_3_34_b gp_3_34_b 0 {Cg}
Mp_3_34_b bx gp_3_34_b colp_L3_34 0 NSYN W=10u L=1u
Mn_3_34_b bx vcn coln_L3_34 0 NSYN W=10u L=1u
Msa_h_L3_34 coln_L3_34 coln_L3_34 0 0 NMIR W=20u L=1u
Msb_h_L3_34 z_L3_34 coln_L3_34 0 0 NMIR W=20u L=1u
Msc_h_L3_34 colp_L3_34 colp_L3_34 0 0 NMIR W=20u L=1u
Msd_h_L3_34 dpf_h_L3_34 colp_L3_34 0 0 NMIR W=20u L=1u
Mse_h_L3_34 dpf_h_L3_34 dpf_h_L3_34 vdd vdd PMIR W=60u L=1u
Msf_h_L3_34 z_L3_34 dpf_h_L3_34 vdd vdd PMIR W=60u L=1u
R_h_L3_34 z_L3_34 vrefh 8000.0
Mr_L3_34  hdd_L3_34 z_L3_34 tail_L3_34 0 NREL W=12u L=1u
Mr2_L3_34 dmp_L3_34  vmid  tail_L3_34 0 NREL W=12u L=1u
Mtl_L3_34 tail_L3_34 vtb 0 0 NREL W=32.0u L=1u
Mdm_L3_34 dmp_L3_34 dmp_L3_34 vdd vdd PMIR W=40u L=1u
Mrp1_L3_34 hdd_L3_34 hdd_L3_34 vdd vdd PMIR W=40u L=1u
Mrp2_L3_34 hv_L3_34 hdd_L3_34 vdd vdd PMIR W=40u L=1u
Rhv_L3_34 hv_L3_34 vg0 8000.0
C_gp_3_35_0 gp_3_35_0 0 {Cg}
Mp_3_35_0 hv_L2_5 gp_3_35_0 colp_L3_35 0 NSYN W=10u L=1u
Mn_3_35_0 hv_L2_5 vcn coln_L3_35 0 NSYN W=10u L=1u
C_gp_3_35_1 gp_3_35_1 0 {Cg}
Mp_3_35_1 hv_L2_14 gp_3_35_1 colp_L3_35 0 NSYN W=10u L=1u
Mn_3_35_1 hv_L2_14 vcn coln_L3_35 0 NSYN W=10u L=1u
C_gp_3_35_2 gp_3_35_2 0 {Cg}
Mp_3_35_2 hv_L2_15 gp_3_35_2 colp_L3_35 0 NSYN W=10u L=1u
Mn_3_35_2 hv_L2_15 vcn coln_L3_35 0 NSYN W=10u L=1u
C_gp_3_35_3 gp_3_35_3 0 {Cg}
Mp_3_35_3 hv_L2_16 gp_3_35_3 colp_L3_35 0 NSYN W=10u L=1u
Mn_3_35_3 hv_L2_16 vcn coln_L3_35 0 NSYN W=10u L=1u
C_gp_3_35_4 gp_3_35_4 0 {Cg}
Mp_3_35_4 hv_L2_17 gp_3_35_4 colp_L3_35 0 NSYN W=10u L=1u
Mn_3_35_4 hv_L2_17 vcn coln_L3_35 0 NSYN W=10u L=1u
C_gp_3_35_5 gp_3_35_5 0 {Cg}
Mp_3_35_5 hv_L2_21 gp_3_35_5 colp_L3_35 0 NSYN W=10u L=1u
Mn_3_35_5 hv_L2_21 vcn coln_L3_35 0 NSYN W=10u L=1u
C_gp_3_35_6 gp_3_35_6 0 {Cg}
Mp_3_35_6 hv_L2_23 gp_3_35_6 colp_L3_35 0 NSYN W=10u L=1u
Mn_3_35_6 hv_L2_23 vcn coln_L3_35 0 NSYN W=10u L=1u
C_gp_3_35_7 gp_3_35_7 0 {Cg}
Mp_3_35_7 hv_L2_32 gp_3_35_7 colp_L3_35 0 NSYN W=10u L=1u
Mn_3_35_7 hv_L2_32 vcn coln_L3_35 0 NSYN W=10u L=1u
C_gp_3_35_8 gp_3_35_8 0 {Cg}
Mp_3_35_8 hv_L2_34 gp_3_35_8 colp_L3_35 0 NSYN W=10u L=1u
Mn_3_35_8 hv_L2_34 vcn coln_L3_35 0 NSYN W=10u L=1u
C_gp_3_35_9 gp_3_35_9 0 {Cg}
Mp_3_35_9 hv_L2_35 gp_3_35_9 colp_L3_35 0 NSYN W=10u L=1u
Mn_3_35_9 hv_L2_35 vcn coln_L3_35 0 NSYN W=10u L=1u
C_gp_3_35_10 gp_3_35_10 0 {Cg}
Mp_3_35_10 hv_L2_36 gp_3_35_10 colp_L3_35 0 NSYN W=10u L=1u
Mn_3_35_10 hv_L2_36 vcn coln_L3_35 0 NSYN W=10u L=1u
C_gp_3_35_11 gp_3_35_11 0 {Cg}
Mp_3_35_11 hv_L2_38 gp_3_35_11 colp_L3_35 0 NSYN W=10u L=1u
Mn_3_35_11 hv_L2_38 vcn coln_L3_35 0 NSYN W=10u L=1u
C_gp_3_35_12 gp_3_35_12 0 {Cg}
Mp_3_35_12 hv_L2_39 gp_3_35_12 colp_L3_35 0 NSYN W=10u L=1u
Mn_3_35_12 hv_L2_39 vcn coln_L3_35 0 NSYN W=10u L=1u
C_gp_3_35_13 gp_3_35_13 0 {Cg}
Mp_3_35_13 hv_L2_40 gp_3_35_13 colp_L3_35 0 NSYN W=10u L=1u
Mn_3_35_13 hv_L2_40 vcn coln_L3_35 0 NSYN W=10u L=1u
C_gp_3_35_14 gp_3_35_14 0 {Cg}
Mp_3_35_14 hv_L2_42 gp_3_35_14 colp_L3_35 0 NSYN W=10u L=1u
Mn_3_35_14 hv_L2_42 vcn coln_L3_35 0 NSYN W=10u L=1u
C_gp_3_35_15 gp_3_35_15 0 {Cg}
Mp_3_35_15 hv_L2_46 gp_3_35_15 colp_L3_35 0 NSYN W=10u L=1u
Mn_3_35_15 hv_L2_46 vcn coln_L3_35 0 NSYN W=10u L=1u
C_gp_3_35_b gp_3_35_b 0 {Cg}
Mp_3_35_b bx gp_3_35_b colp_L3_35 0 NSYN W=10u L=1u
Mn_3_35_b bx vcn coln_L3_35 0 NSYN W=10u L=1u
Msa_h_L3_35 coln_L3_35 coln_L3_35 0 0 NMIR W=20u L=1u
Msb_h_L3_35 z_L3_35 coln_L3_35 0 0 NMIR W=20u L=1u
Msc_h_L3_35 colp_L3_35 colp_L3_35 0 0 NMIR W=20u L=1u
Msd_h_L3_35 dpf_h_L3_35 colp_L3_35 0 0 NMIR W=20u L=1u
Mse_h_L3_35 dpf_h_L3_35 dpf_h_L3_35 vdd vdd PMIR W=60u L=1u
Msf_h_L3_35 z_L3_35 dpf_h_L3_35 vdd vdd PMIR W=60u L=1u
R_h_L3_35 z_L3_35 vrefh 8000.0
Mr_L3_35  hdd_L3_35 z_L3_35 tail_L3_35 0 NREL W=12u L=1u
Mr2_L3_35 dmp_L3_35  vmid  tail_L3_35 0 NREL W=12u L=1u
Mtl_L3_35 tail_L3_35 vtb 0 0 NREL W=32.0u L=1u
Mdm_L3_35 dmp_L3_35 dmp_L3_35 vdd vdd PMIR W=40u L=1u
Mrp1_L3_35 hdd_L3_35 hdd_L3_35 vdd vdd PMIR W=40u L=1u
Mrp2_L3_35 hv_L3_35 hdd_L3_35 vdd vdd PMIR W=40u L=1u
Rhv_L3_35 hv_L3_35 vg0 8000.0
C_gp_3_36_0 gp_3_36_0 0 {Cg}
Mp_3_36_0 hv_L2_0 gp_3_36_0 colp_L3_36 0 NSYN W=10u L=1u
Mn_3_36_0 hv_L2_0 vcn coln_L3_36 0 NSYN W=10u L=1u
C_gp_3_36_1 gp_3_36_1 0 {Cg}
Mp_3_36_1 hv_L2_2 gp_3_36_1 colp_L3_36 0 NSYN W=10u L=1u
Mn_3_36_1 hv_L2_2 vcn coln_L3_36 0 NSYN W=10u L=1u
C_gp_3_36_2 gp_3_36_2 0 {Cg}
Mp_3_36_2 hv_L2_7 gp_3_36_2 colp_L3_36 0 NSYN W=10u L=1u
Mn_3_36_2 hv_L2_7 vcn coln_L3_36 0 NSYN W=10u L=1u
C_gp_3_36_3 gp_3_36_3 0 {Cg}
Mp_3_36_3 hv_L2_9 gp_3_36_3 colp_L3_36 0 NSYN W=10u L=1u
Mn_3_36_3 hv_L2_9 vcn coln_L3_36 0 NSYN W=10u L=1u
C_gp_3_36_4 gp_3_36_4 0 {Cg}
Mp_3_36_4 hv_L2_10 gp_3_36_4 colp_L3_36 0 NSYN W=10u L=1u
Mn_3_36_4 hv_L2_10 vcn coln_L3_36 0 NSYN W=10u L=1u
C_gp_3_36_5 gp_3_36_5 0 {Cg}
Mp_3_36_5 hv_L2_19 gp_3_36_5 colp_L3_36 0 NSYN W=10u L=1u
Mn_3_36_5 hv_L2_19 vcn coln_L3_36 0 NSYN W=10u L=1u
C_gp_3_36_6 gp_3_36_6 0 {Cg}
Mp_3_36_6 hv_L2_20 gp_3_36_6 colp_L3_36 0 NSYN W=10u L=1u
Mn_3_36_6 hv_L2_20 vcn coln_L3_36 0 NSYN W=10u L=1u
C_gp_3_36_7 gp_3_36_7 0 {Cg}
Mp_3_36_7 hv_L2_24 gp_3_36_7 colp_L3_36 0 NSYN W=10u L=1u
Mn_3_36_7 hv_L2_24 vcn coln_L3_36 0 NSYN W=10u L=1u
C_gp_3_36_8 gp_3_36_8 0 {Cg}
Mp_3_36_8 hv_L2_28 gp_3_36_8 colp_L3_36 0 NSYN W=10u L=1u
Mn_3_36_8 hv_L2_28 vcn coln_L3_36 0 NSYN W=10u L=1u
C_gp_3_36_9 gp_3_36_9 0 {Cg}
Mp_3_36_9 hv_L2_31 gp_3_36_9 colp_L3_36 0 NSYN W=10u L=1u
Mn_3_36_9 hv_L2_31 vcn coln_L3_36 0 NSYN W=10u L=1u
C_gp_3_36_10 gp_3_36_10 0 {Cg}
Mp_3_36_10 hv_L2_33 gp_3_36_10 colp_L3_36 0 NSYN W=10u L=1u
Mn_3_36_10 hv_L2_33 vcn coln_L3_36 0 NSYN W=10u L=1u
C_gp_3_36_11 gp_3_36_11 0 {Cg}
Mp_3_36_11 hv_L2_37 gp_3_36_11 colp_L3_36 0 NSYN W=10u L=1u
Mn_3_36_11 hv_L2_37 vcn coln_L3_36 0 NSYN W=10u L=1u
C_gp_3_36_12 gp_3_36_12 0 {Cg}
Mp_3_36_12 hv_L2_39 gp_3_36_12 colp_L3_36 0 NSYN W=10u L=1u
Mn_3_36_12 hv_L2_39 vcn coln_L3_36 0 NSYN W=10u L=1u
C_gp_3_36_13 gp_3_36_13 0 {Cg}
Mp_3_36_13 hv_L2_44 gp_3_36_13 colp_L3_36 0 NSYN W=10u L=1u
Mn_3_36_13 hv_L2_44 vcn coln_L3_36 0 NSYN W=10u L=1u
C_gp_3_36_14 gp_3_36_14 0 {Cg}
Mp_3_36_14 hv_L2_46 gp_3_36_14 colp_L3_36 0 NSYN W=10u L=1u
Mn_3_36_14 hv_L2_46 vcn coln_L3_36 0 NSYN W=10u L=1u
C_gp_3_36_15 gp_3_36_15 0 {Cg}
Mp_3_36_15 hv_L2_47 gp_3_36_15 colp_L3_36 0 NSYN W=10u L=1u
Mn_3_36_15 hv_L2_47 vcn coln_L3_36 0 NSYN W=10u L=1u
C_gp_3_36_b gp_3_36_b 0 {Cg}
Mp_3_36_b bx gp_3_36_b colp_L3_36 0 NSYN W=10u L=1u
Mn_3_36_b bx vcn coln_L3_36 0 NSYN W=10u L=1u
Msa_h_L3_36 coln_L3_36 coln_L3_36 0 0 NMIR W=20u L=1u
Msb_h_L3_36 z_L3_36 coln_L3_36 0 0 NMIR W=20u L=1u
Msc_h_L3_36 colp_L3_36 colp_L3_36 0 0 NMIR W=20u L=1u
Msd_h_L3_36 dpf_h_L3_36 colp_L3_36 0 0 NMIR W=20u L=1u
Mse_h_L3_36 dpf_h_L3_36 dpf_h_L3_36 vdd vdd PMIR W=60u L=1u
Msf_h_L3_36 z_L3_36 dpf_h_L3_36 vdd vdd PMIR W=60u L=1u
R_h_L3_36 z_L3_36 vrefh 8000.0
Mr_L3_36  hdd_L3_36 z_L3_36 tail_L3_36 0 NREL W=12u L=1u
Mr2_L3_36 dmp_L3_36  vmid  tail_L3_36 0 NREL W=12u L=1u
Mtl_L3_36 tail_L3_36 vtb 0 0 NREL W=32.0u L=1u
Mdm_L3_36 dmp_L3_36 dmp_L3_36 vdd vdd PMIR W=40u L=1u
Mrp1_L3_36 hdd_L3_36 hdd_L3_36 vdd vdd PMIR W=40u L=1u
Mrp2_L3_36 hv_L3_36 hdd_L3_36 vdd vdd PMIR W=40u L=1u
Rhv_L3_36 hv_L3_36 vg0 8000.0
C_gp_3_37_0 gp_3_37_0 0 {Cg}
Mp_3_37_0 hv_L2_1 gp_3_37_0 colp_L3_37 0 NSYN W=10u L=1u
Mn_3_37_0 hv_L2_1 vcn coln_L3_37 0 NSYN W=10u L=1u
C_gp_3_37_1 gp_3_37_1 0 {Cg}
Mp_3_37_1 hv_L2_4 gp_3_37_1 colp_L3_37 0 NSYN W=10u L=1u
Mn_3_37_1 hv_L2_4 vcn coln_L3_37 0 NSYN W=10u L=1u
C_gp_3_37_2 gp_3_37_2 0 {Cg}
Mp_3_37_2 hv_L2_11 gp_3_37_2 colp_L3_37 0 NSYN W=10u L=1u
Mn_3_37_2 hv_L2_11 vcn coln_L3_37 0 NSYN W=10u L=1u
C_gp_3_37_3 gp_3_37_3 0 {Cg}
Mp_3_37_3 hv_L2_12 gp_3_37_3 colp_L3_37 0 NSYN W=10u L=1u
Mn_3_37_3 hv_L2_12 vcn coln_L3_37 0 NSYN W=10u L=1u
C_gp_3_37_4 gp_3_37_4 0 {Cg}
Mp_3_37_4 hv_L2_13 gp_3_37_4 colp_L3_37 0 NSYN W=10u L=1u
Mn_3_37_4 hv_L2_13 vcn coln_L3_37 0 NSYN W=10u L=1u
C_gp_3_37_5 gp_3_37_5 0 {Cg}
Mp_3_37_5 hv_L2_17 gp_3_37_5 colp_L3_37 0 NSYN W=10u L=1u
Mn_3_37_5 hv_L2_17 vcn coln_L3_37 0 NSYN W=10u L=1u
C_gp_3_37_6 gp_3_37_6 0 {Cg}
Mp_3_37_6 hv_L2_20 gp_3_37_6 colp_L3_37 0 NSYN W=10u L=1u
Mn_3_37_6 hv_L2_20 vcn coln_L3_37 0 NSYN W=10u L=1u
C_gp_3_37_7 gp_3_37_7 0 {Cg}
Mp_3_37_7 hv_L2_22 gp_3_37_7 colp_L3_37 0 NSYN W=10u L=1u
Mn_3_37_7 hv_L2_22 vcn coln_L3_37 0 NSYN W=10u L=1u
C_gp_3_37_8 gp_3_37_8 0 {Cg}
Mp_3_37_8 hv_L2_23 gp_3_37_8 colp_L3_37 0 NSYN W=10u L=1u
Mn_3_37_8 hv_L2_23 vcn coln_L3_37 0 NSYN W=10u L=1u
C_gp_3_37_9 gp_3_37_9 0 {Cg}
Mp_3_37_9 hv_L2_24 gp_3_37_9 colp_L3_37 0 NSYN W=10u L=1u
Mn_3_37_9 hv_L2_24 vcn coln_L3_37 0 NSYN W=10u L=1u
C_gp_3_37_10 gp_3_37_10 0 {Cg}
Mp_3_37_10 hv_L2_25 gp_3_37_10 colp_L3_37 0 NSYN W=10u L=1u
Mn_3_37_10 hv_L2_25 vcn coln_L3_37 0 NSYN W=10u L=1u
C_gp_3_37_11 gp_3_37_11 0 {Cg}
Mp_3_37_11 hv_L2_38 gp_3_37_11 colp_L3_37 0 NSYN W=10u L=1u
Mn_3_37_11 hv_L2_38 vcn coln_L3_37 0 NSYN W=10u L=1u
C_gp_3_37_12 gp_3_37_12 0 {Cg}
Mp_3_37_12 hv_L2_39 gp_3_37_12 colp_L3_37 0 NSYN W=10u L=1u
Mn_3_37_12 hv_L2_39 vcn coln_L3_37 0 NSYN W=10u L=1u
C_gp_3_37_13 gp_3_37_13 0 {Cg}
Mp_3_37_13 hv_L2_43 gp_3_37_13 colp_L3_37 0 NSYN W=10u L=1u
Mn_3_37_13 hv_L2_43 vcn coln_L3_37 0 NSYN W=10u L=1u
C_gp_3_37_14 gp_3_37_14 0 {Cg}
Mp_3_37_14 hv_L2_45 gp_3_37_14 colp_L3_37 0 NSYN W=10u L=1u
Mn_3_37_14 hv_L2_45 vcn coln_L3_37 0 NSYN W=10u L=1u
C_gp_3_37_15 gp_3_37_15 0 {Cg}
Mp_3_37_15 hv_L2_46 gp_3_37_15 colp_L3_37 0 NSYN W=10u L=1u
Mn_3_37_15 hv_L2_46 vcn coln_L3_37 0 NSYN W=10u L=1u
C_gp_3_37_b gp_3_37_b 0 {Cg}
Mp_3_37_b bx gp_3_37_b colp_L3_37 0 NSYN W=10u L=1u
Mn_3_37_b bx vcn coln_L3_37 0 NSYN W=10u L=1u
Msa_h_L3_37 coln_L3_37 coln_L3_37 0 0 NMIR W=20u L=1u
Msb_h_L3_37 z_L3_37 coln_L3_37 0 0 NMIR W=20u L=1u
Msc_h_L3_37 colp_L3_37 colp_L3_37 0 0 NMIR W=20u L=1u
Msd_h_L3_37 dpf_h_L3_37 colp_L3_37 0 0 NMIR W=20u L=1u
Mse_h_L3_37 dpf_h_L3_37 dpf_h_L3_37 vdd vdd PMIR W=60u L=1u
Msf_h_L3_37 z_L3_37 dpf_h_L3_37 vdd vdd PMIR W=60u L=1u
R_h_L3_37 z_L3_37 vrefh 8000.0
Mr_L3_37  hdd_L3_37 z_L3_37 tail_L3_37 0 NREL W=12u L=1u
Mr2_L3_37 dmp_L3_37  vmid  tail_L3_37 0 NREL W=12u L=1u
Mtl_L3_37 tail_L3_37 vtb 0 0 NREL W=32.0u L=1u
Mdm_L3_37 dmp_L3_37 dmp_L3_37 vdd vdd PMIR W=40u L=1u
Mrp1_L3_37 hdd_L3_37 hdd_L3_37 vdd vdd PMIR W=40u L=1u
Mrp2_L3_37 hv_L3_37 hdd_L3_37 vdd vdd PMIR W=40u L=1u
Rhv_L3_37 hv_L3_37 vg0 8000.0
C_gp_3_38_0 gp_3_38_0 0 {Cg}
Mp_3_38_0 hv_L2_0 gp_3_38_0 colp_L3_38 0 NSYN W=10u L=1u
Mn_3_38_0 hv_L2_0 vcn coln_L3_38 0 NSYN W=10u L=1u
C_gp_3_38_1 gp_3_38_1 0 {Cg}
Mp_3_38_1 hv_L2_1 gp_3_38_1 colp_L3_38 0 NSYN W=10u L=1u
Mn_3_38_1 hv_L2_1 vcn coln_L3_38 0 NSYN W=10u L=1u
C_gp_3_38_2 gp_3_38_2 0 {Cg}
Mp_3_38_2 hv_L2_3 gp_3_38_2 colp_L3_38 0 NSYN W=10u L=1u
Mn_3_38_2 hv_L2_3 vcn coln_L3_38 0 NSYN W=10u L=1u
C_gp_3_38_3 gp_3_38_3 0 {Cg}
Mp_3_38_3 hv_L2_4 gp_3_38_3 colp_L3_38 0 NSYN W=10u L=1u
Mn_3_38_3 hv_L2_4 vcn coln_L3_38 0 NSYN W=10u L=1u
C_gp_3_38_4 gp_3_38_4 0 {Cg}
Mp_3_38_4 hv_L2_12 gp_3_38_4 colp_L3_38 0 NSYN W=10u L=1u
Mn_3_38_4 hv_L2_12 vcn coln_L3_38 0 NSYN W=10u L=1u
C_gp_3_38_5 gp_3_38_5 0 {Cg}
Mp_3_38_5 hv_L2_15 gp_3_38_5 colp_L3_38 0 NSYN W=10u L=1u
Mn_3_38_5 hv_L2_15 vcn coln_L3_38 0 NSYN W=10u L=1u
C_gp_3_38_6 gp_3_38_6 0 {Cg}
Mp_3_38_6 hv_L2_16 gp_3_38_6 colp_L3_38 0 NSYN W=10u L=1u
Mn_3_38_6 hv_L2_16 vcn coln_L3_38 0 NSYN W=10u L=1u
C_gp_3_38_7 gp_3_38_7 0 {Cg}
Mp_3_38_7 hv_L2_21 gp_3_38_7 colp_L3_38 0 NSYN W=10u L=1u
Mn_3_38_7 hv_L2_21 vcn coln_L3_38 0 NSYN W=10u L=1u
C_gp_3_38_8 gp_3_38_8 0 {Cg}
Mp_3_38_8 hv_L2_25 gp_3_38_8 colp_L3_38 0 NSYN W=10u L=1u
Mn_3_38_8 hv_L2_25 vcn coln_L3_38 0 NSYN W=10u L=1u
C_gp_3_38_9 gp_3_38_9 0 {Cg}
Mp_3_38_9 hv_L2_33 gp_3_38_9 colp_L3_38 0 NSYN W=10u L=1u
Mn_3_38_9 hv_L2_33 vcn coln_L3_38 0 NSYN W=10u L=1u
C_gp_3_38_10 gp_3_38_10 0 {Cg}
Mp_3_38_10 hv_L2_35 gp_3_38_10 colp_L3_38 0 NSYN W=10u L=1u
Mn_3_38_10 hv_L2_35 vcn coln_L3_38 0 NSYN W=10u L=1u
C_gp_3_38_11 gp_3_38_11 0 {Cg}
Mp_3_38_11 hv_L2_40 gp_3_38_11 colp_L3_38 0 NSYN W=10u L=1u
Mn_3_38_11 hv_L2_40 vcn coln_L3_38 0 NSYN W=10u L=1u
C_gp_3_38_12 gp_3_38_12 0 {Cg}
Mp_3_38_12 hv_L2_42 gp_3_38_12 colp_L3_38 0 NSYN W=10u L=1u
Mn_3_38_12 hv_L2_42 vcn coln_L3_38 0 NSYN W=10u L=1u
C_gp_3_38_13 gp_3_38_13 0 {Cg}
Mp_3_38_13 hv_L2_43 gp_3_38_13 colp_L3_38 0 NSYN W=10u L=1u
Mn_3_38_13 hv_L2_43 vcn coln_L3_38 0 NSYN W=10u L=1u
C_gp_3_38_14 gp_3_38_14 0 {Cg}
Mp_3_38_14 hv_L2_45 gp_3_38_14 colp_L3_38 0 NSYN W=10u L=1u
Mn_3_38_14 hv_L2_45 vcn coln_L3_38 0 NSYN W=10u L=1u
C_gp_3_38_15 gp_3_38_15 0 {Cg}
Mp_3_38_15 hv_L2_46 gp_3_38_15 colp_L3_38 0 NSYN W=10u L=1u
Mn_3_38_15 hv_L2_46 vcn coln_L3_38 0 NSYN W=10u L=1u
C_gp_3_38_b gp_3_38_b 0 {Cg}
Mp_3_38_b bx gp_3_38_b colp_L3_38 0 NSYN W=10u L=1u
Mn_3_38_b bx vcn coln_L3_38 0 NSYN W=10u L=1u
Msa_h_L3_38 coln_L3_38 coln_L3_38 0 0 NMIR W=20u L=1u
Msb_h_L3_38 z_L3_38 coln_L3_38 0 0 NMIR W=20u L=1u
Msc_h_L3_38 colp_L3_38 colp_L3_38 0 0 NMIR W=20u L=1u
Msd_h_L3_38 dpf_h_L3_38 colp_L3_38 0 0 NMIR W=20u L=1u
Mse_h_L3_38 dpf_h_L3_38 dpf_h_L3_38 vdd vdd PMIR W=60u L=1u
Msf_h_L3_38 z_L3_38 dpf_h_L3_38 vdd vdd PMIR W=60u L=1u
R_h_L3_38 z_L3_38 vrefh 8000.0
Mr_L3_38  hdd_L3_38 z_L3_38 tail_L3_38 0 NREL W=12u L=1u
Mr2_L3_38 dmp_L3_38  vmid  tail_L3_38 0 NREL W=12u L=1u
Mtl_L3_38 tail_L3_38 vtb 0 0 NREL W=32.0u L=1u
Mdm_L3_38 dmp_L3_38 dmp_L3_38 vdd vdd PMIR W=40u L=1u
Mrp1_L3_38 hdd_L3_38 hdd_L3_38 vdd vdd PMIR W=40u L=1u
Mrp2_L3_38 hv_L3_38 hdd_L3_38 vdd vdd PMIR W=40u L=1u
Rhv_L3_38 hv_L3_38 vg0 8000.0
C_gp_3_39_0 gp_3_39_0 0 {Cg}
Mp_3_39_0 hv_L2_4 gp_3_39_0 colp_L3_39 0 NSYN W=10u L=1u
Mn_3_39_0 hv_L2_4 vcn coln_L3_39 0 NSYN W=10u L=1u
C_gp_3_39_1 gp_3_39_1 0 {Cg}
Mp_3_39_1 hv_L2_6 gp_3_39_1 colp_L3_39 0 NSYN W=10u L=1u
Mn_3_39_1 hv_L2_6 vcn coln_L3_39 0 NSYN W=10u L=1u
C_gp_3_39_2 gp_3_39_2 0 {Cg}
Mp_3_39_2 hv_L2_7 gp_3_39_2 colp_L3_39 0 NSYN W=10u L=1u
Mn_3_39_2 hv_L2_7 vcn coln_L3_39 0 NSYN W=10u L=1u
C_gp_3_39_3 gp_3_39_3 0 {Cg}
Mp_3_39_3 hv_L2_11 gp_3_39_3 colp_L3_39 0 NSYN W=10u L=1u
Mn_3_39_3 hv_L2_11 vcn coln_L3_39 0 NSYN W=10u L=1u
C_gp_3_39_4 gp_3_39_4 0 {Cg}
Mp_3_39_4 hv_L2_23 gp_3_39_4 colp_L3_39 0 NSYN W=10u L=1u
Mn_3_39_4 hv_L2_23 vcn coln_L3_39 0 NSYN W=10u L=1u
C_gp_3_39_5 gp_3_39_5 0 {Cg}
Mp_3_39_5 hv_L2_25 gp_3_39_5 colp_L3_39 0 NSYN W=10u L=1u
Mn_3_39_5 hv_L2_25 vcn coln_L3_39 0 NSYN W=10u L=1u
C_gp_3_39_6 gp_3_39_6 0 {Cg}
Mp_3_39_6 hv_L2_27 gp_3_39_6 colp_L3_39 0 NSYN W=10u L=1u
Mn_3_39_6 hv_L2_27 vcn coln_L3_39 0 NSYN W=10u L=1u
C_gp_3_39_7 gp_3_39_7 0 {Cg}
Mp_3_39_7 hv_L2_32 gp_3_39_7 colp_L3_39 0 NSYN W=10u L=1u
Mn_3_39_7 hv_L2_32 vcn coln_L3_39 0 NSYN W=10u L=1u
C_gp_3_39_8 gp_3_39_8 0 {Cg}
Mp_3_39_8 hv_L2_37 gp_3_39_8 colp_L3_39 0 NSYN W=10u L=1u
Mn_3_39_8 hv_L2_37 vcn coln_L3_39 0 NSYN W=10u L=1u
C_gp_3_39_9 gp_3_39_9 0 {Cg}
Mp_3_39_9 hv_L2_38 gp_3_39_9 colp_L3_39 0 NSYN W=10u L=1u
Mn_3_39_9 hv_L2_38 vcn coln_L3_39 0 NSYN W=10u L=1u
C_gp_3_39_10 gp_3_39_10 0 {Cg}
Mp_3_39_10 hv_L2_39 gp_3_39_10 colp_L3_39 0 NSYN W=10u L=1u
Mn_3_39_10 hv_L2_39 vcn coln_L3_39 0 NSYN W=10u L=1u
C_gp_3_39_11 gp_3_39_11 0 {Cg}
Mp_3_39_11 hv_L2_40 gp_3_39_11 colp_L3_39 0 NSYN W=10u L=1u
Mn_3_39_11 hv_L2_40 vcn coln_L3_39 0 NSYN W=10u L=1u
C_gp_3_39_12 gp_3_39_12 0 {Cg}
Mp_3_39_12 hv_L2_43 gp_3_39_12 colp_L3_39 0 NSYN W=10u L=1u
Mn_3_39_12 hv_L2_43 vcn coln_L3_39 0 NSYN W=10u L=1u
C_gp_3_39_13 gp_3_39_13 0 {Cg}
Mp_3_39_13 hv_L2_44 gp_3_39_13 colp_L3_39 0 NSYN W=10u L=1u
Mn_3_39_13 hv_L2_44 vcn coln_L3_39 0 NSYN W=10u L=1u
C_gp_3_39_14 gp_3_39_14 0 {Cg}
Mp_3_39_14 hv_L2_46 gp_3_39_14 colp_L3_39 0 NSYN W=10u L=1u
Mn_3_39_14 hv_L2_46 vcn coln_L3_39 0 NSYN W=10u L=1u
C_gp_3_39_15 gp_3_39_15 0 {Cg}
Mp_3_39_15 hv_L2_47 gp_3_39_15 colp_L3_39 0 NSYN W=10u L=1u
Mn_3_39_15 hv_L2_47 vcn coln_L3_39 0 NSYN W=10u L=1u
C_gp_3_39_b gp_3_39_b 0 {Cg}
Mp_3_39_b bx gp_3_39_b colp_L3_39 0 NSYN W=10u L=1u
Mn_3_39_b bx vcn coln_L3_39 0 NSYN W=10u L=1u
Msa_h_L3_39 coln_L3_39 coln_L3_39 0 0 NMIR W=20u L=1u
Msb_h_L3_39 z_L3_39 coln_L3_39 0 0 NMIR W=20u L=1u
Msc_h_L3_39 colp_L3_39 colp_L3_39 0 0 NMIR W=20u L=1u
Msd_h_L3_39 dpf_h_L3_39 colp_L3_39 0 0 NMIR W=20u L=1u
Mse_h_L3_39 dpf_h_L3_39 dpf_h_L3_39 vdd vdd PMIR W=60u L=1u
Msf_h_L3_39 z_L3_39 dpf_h_L3_39 vdd vdd PMIR W=60u L=1u
R_h_L3_39 z_L3_39 vrefh 8000.0
Mr_L3_39  hdd_L3_39 z_L3_39 tail_L3_39 0 NREL W=12u L=1u
Mr2_L3_39 dmp_L3_39  vmid  tail_L3_39 0 NREL W=12u L=1u
Mtl_L3_39 tail_L3_39 vtb 0 0 NREL W=32.0u L=1u
Mdm_L3_39 dmp_L3_39 dmp_L3_39 vdd vdd PMIR W=40u L=1u
Mrp1_L3_39 hdd_L3_39 hdd_L3_39 vdd vdd PMIR W=40u L=1u
Mrp2_L3_39 hv_L3_39 hdd_L3_39 vdd vdd PMIR W=40u L=1u
Rhv_L3_39 hv_L3_39 vg0 8000.0
C_gp_3_40_0 gp_3_40_0 0 {Cg}
Mp_3_40_0 hv_L2_0 gp_3_40_0 colp_L3_40 0 NSYN W=10u L=1u
Mn_3_40_0 hv_L2_0 vcn coln_L3_40 0 NSYN W=10u L=1u
C_gp_3_40_1 gp_3_40_1 0 {Cg}
Mp_3_40_1 hv_L2_3 gp_3_40_1 colp_L3_40 0 NSYN W=10u L=1u
Mn_3_40_1 hv_L2_3 vcn coln_L3_40 0 NSYN W=10u L=1u
C_gp_3_40_2 gp_3_40_2 0 {Cg}
Mp_3_40_2 hv_L2_9 gp_3_40_2 colp_L3_40 0 NSYN W=10u L=1u
Mn_3_40_2 hv_L2_9 vcn coln_L3_40 0 NSYN W=10u L=1u
C_gp_3_40_3 gp_3_40_3 0 {Cg}
Mp_3_40_3 hv_L2_10 gp_3_40_3 colp_L3_40 0 NSYN W=10u L=1u
Mn_3_40_3 hv_L2_10 vcn coln_L3_40 0 NSYN W=10u L=1u
C_gp_3_40_4 gp_3_40_4 0 {Cg}
Mp_3_40_4 hv_L2_11 gp_3_40_4 colp_L3_40 0 NSYN W=10u L=1u
Mn_3_40_4 hv_L2_11 vcn coln_L3_40 0 NSYN W=10u L=1u
C_gp_3_40_5 gp_3_40_5 0 {Cg}
Mp_3_40_5 hv_L2_13 gp_3_40_5 colp_L3_40 0 NSYN W=10u L=1u
Mn_3_40_5 hv_L2_13 vcn coln_L3_40 0 NSYN W=10u L=1u
C_gp_3_40_6 gp_3_40_6 0 {Cg}
Mp_3_40_6 hv_L2_15 gp_3_40_6 colp_L3_40 0 NSYN W=10u L=1u
Mn_3_40_6 hv_L2_15 vcn coln_L3_40 0 NSYN W=10u L=1u
C_gp_3_40_7 gp_3_40_7 0 {Cg}
Mp_3_40_7 hv_L2_16 gp_3_40_7 colp_L3_40 0 NSYN W=10u L=1u
Mn_3_40_7 hv_L2_16 vcn coln_L3_40 0 NSYN W=10u L=1u
C_gp_3_40_8 gp_3_40_8 0 {Cg}
Mp_3_40_8 hv_L2_19 gp_3_40_8 colp_L3_40 0 NSYN W=10u L=1u
Mn_3_40_8 hv_L2_19 vcn coln_L3_40 0 NSYN W=10u L=1u
C_gp_3_40_9 gp_3_40_9 0 {Cg}
Mp_3_40_9 hv_L2_25 gp_3_40_9 colp_L3_40 0 NSYN W=10u L=1u
Mn_3_40_9 hv_L2_25 vcn coln_L3_40 0 NSYN W=10u L=1u
C_gp_3_40_10 gp_3_40_10 0 {Cg}
Mp_3_40_10 hv_L2_28 gp_3_40_10 colp_L3_40 0 NSYN W=10u L=1u
Mn_3_40_10 hv_L2_28 vcn coln_L3_40 0 NSYN W=10u L=1u
C_gp_3_40_11 gp_3_40_11 0 {Cg}
Mp_3_40_11 hv_L2_30 gp_3_40_11 colp_L3_40 0 NSYN W=10u L=1u
Mn_3_40_11 hv_L2_30 vcn coln_L3_40 0 NSYN W=10u L=1u
C_gp_3_40_12 gp_3_40_12 0 {Cg}
Mp_3_40_12 hv_L2_37 gp_3_40_12 colp_L3_40 0 NSYN W=10u L=1u
Mn_3_40_12 hv_L2_37 vcn coln_L3_40 0 NSYN W=10u L=1u
C_gp_3_40_13 gp_3_40_13 0 {Cg}
Mp_3_40_13 hv_L2_38 gp_3_40_13 colp_L3_40 0 NSYN W=10u L=1u
Mn_3_40_13 hv_L2_38 vcn coln_L3_40 0 NSYN W=10u L=1u
C_gp_3_40_14 gp_3_40_14 0 {Cg}
Mp_3_40_14 hv_L2_42 gp_3_40_14 colp_L3_40 0 NSYN W=10u L=1u
Mn_3_40_14 hv_L2_42 vcn coln_L3_40 0 NSYN W=10u L=1u
C_gp_3_40_15 gp_3_40_15 0 {Cg}
Mp_3_40_15 hv_L2_44 gp_3_40_15 colp_L3_40 0 NSYN W=10u L=1u
Mn_3_40_15 hv_L2_44 vcn coln_L3_40 0 NSYN W=10u L=1u
C_gp_3_40_b gp_3_40_b 0 {Cg}
Mp_3_40_b bx gp_3_40_b colp_L3_40 0 NSYN W=10u L=1u
Mn_3_40_b bx vcn coln_L3_40 0 NSYN W=10u L=1u
Msa_h_L3_40 coln_L3_40 coln_L3_40 0 0 NMIR W=20u L=1u
Msb_h_L3_40 z_L3_40 coln_L3_40 0 0 NMIR W=20u L=1u
Msc_h_L3_40 colp_L3_40 colp_L3_40 0 0 NMIR W=20u L=1u
Msd_h_L3_40 dpf_h_L3_40 colp_L3_40 0 0 NMIR W=20u L=1u
Mse_h_L3_40 dpf_h_L3_40 dpf_h_L3_40 vdd vdd PMIR W=60u L=1u
Msf_h_L3_40 z_L3_40 dpf_h_L3_40 vdd vdd PMIR W=60u L=1u
R_h_L3_40 z_L3_40 vrefh 8000.0
Mr_L3_40  hdd_L3_40 z_L3_40 tail_L3_40 0 NREL W=12u L=1u
Mr2_L3_40 dmp_L3_40  vmid  tail_L3_40 0 NREL W=12u L=1u
Mtl_L3_40 tail_L3_40 vtb 0 0 NREL W=32.0u L=1u
Mdm_L3_40 dmp_L3_40 dmp_L3_40 vdd vdd PMIR W=40u L=1u
Mrp1_L3_40 hdd_L3_40 hdd_L3_40 vdd vdd PMIR W=40u L=1u
Mrp2_L3_40 hv_L3_40 hdd_L3_40 vdd vdd PMIR W=40u L=1u
Rhv_L3_40 hv_L3_40 vg0 8000.0
C_gp_3_41_0 gp_3_41_0 0 {Cg}
Mp_3_41_0 hv_L2_0 gp_3_41_0 colp_L3_41 0 NSYN W=10u L=1u
Mn_3_41_0 hv_L2_0 vcn coln_L3_41 0 NSYN W=10u L=1u
C_gp_3_41_1 gp_3_41_1 0 {Cg}
Mp_3_41_1 hv_L2_7 gp_3_41_1 colp_L3_41 0 NSYN W=10u L=1u
Mn_3_41_1 hv_L2_7 vcn coln_L3_41 0 NSYN W=10u L=1u
C_gp_3_41_2 gp_3_41_2 0 {Cg}
Mp_3_41_2 hv_L2_8 gp_3_41_2 colp_L3_41 0 NSYN W=10u L=1u
Mn_3_41_2 hv_L2_8 vcn coln_L3_41 0 NSYN W=10u L=1u
C_gp_3_41_3 gp_3_41_3 0 {Cg}
Mp_3_41_3 hv_L2_9 gp_3_41_3 colp_L3_41 0 NSYN W=10u L=1u
Mn_3_41_3 hv_L2_9 vcn coln_L3_41 0 NSYN W=10u L=1u
C_gp_3_41_4 gp_3_41_4 0 {Cg}
Mp_3_41_4 hv_L2_12 gp_3_41_4 colp_L3_41 0 NSYN W=10u L=1u
Mn_3_41_4 hv_L2_12 vcn coln_L3_41 0 NSYN W=10u L=1u
C_gp_3_41_5 gp_3_41_5 0 {Cg}
Mp_3_41_5 hv_L2_15 gp_3_41_5 colp_L3_41 0 NSYN W=10u L=1u
Mn_3_41_5 hv_L2_15 vcn coln_L3_41 0 NSYN W=10u L=1u
C_gp_3_41_6 gp_3_41_6 0 {Cg}
Mp_3_41_6 hv_L2_17 gp_3_41_6 colp_L3_41 0 NSYN W=10u L=1u
Mn_3_41_6 hv_L2_17 vcn coln_L3_41 0 NSYN W=10u L=1u
C_gp_3_41_7 gp_3_41_7 0 {Cg}
Mp_3_41_7 hv_L2_22 gp_3_41_7 colp_L3_41 0 NSYN W=10u L=1u
Mn_3_41_7 hv_L2_22 vcn coln_L3_41 0 NSYN W=10u L=1u
C_gp_3_41_8 gp_3_41_8 0 {Cg}
Mp_3_41_8 hv_L2_25 gp_3_41_8 colp_L3_41 0 NSYN W=10u L=1u
Mn_3_41_8 hv_L2_25 vcn coln_L3_41 0 NSYN W=10u L=1u
C_gp_3_41_9 gp_3_41_9 0 {Cg}
Mp_3_41_9 hv_L2_28 gp_3_41_9 colp_L3_41 0 NSYN W=10u L=1u
Mn_3_41_9 hv_L2_28 vcn coln_L3_41 0 NSYN W=10u L=1u
C_gp_3_41_10 gp_3_41_10 0 {Cg}
Mp_3_41_10 hv_L2_33 gp_3_41_10 colp_L3_41 0 NSYN W=10u L=1u
Mn_3_41_10 hv_L2_33 vcn coln_L3_41 0 NSYN W=10u L=1u
C_gp_3_41_11 gp_3_41_11 0 {Cg}
Mp_3_41_11 hv_L2_35 gp_3_41_11 colp_L3_41 0 NSYN W=10u L=1u
Mn_3_41_11 hv_L2_35 vcn coln_L3_41 0 NSYN W=10u L=1u
C_gp_3_41_12 gp_3_41_12 0 {Cg}
Mp_3_41_12 hv_L2_37 gp_3_41_12 colp_L3_41 0 NSYN W=10u L=1u
Mn_3_41_12 hv_L2_37 vcn coln_L3_41 0 NSYN W=10u L=1u
C_gp_3_41_13 gp_3_41_13 0 {Cg}
Mp_3_41_13 hv_L2_38 gp_3_41_13 colp_L3_41 0 NSYN W=10u L=1u
Mn_3_41_13 hv_L2_38 vcn coln_L3_41 0 NSYN W=10u L=1u
C_gp_3_41_14 gp_3_41_14 0 {Cg}
Mp_3_41_14 hv_L2_42 gp_3_41_14 colp_L3_41 0 NSYN W=10u L=1u
Mn_3_41_14 hv_L2_42 vcn coln_L3_41 0 NSYN W=10u L=1u
C_gp_3_41_15 gp_3_41_15 0 {Cg}
Mp_3_41_15 hv_L2_46 gp_3_41_15 colp_L3_41 0 NSYN W=10u L=1u
Mn_3_41_15 hv_L2_46 vcn coln_L3_41 0 NSYN W=10u L=1u
C_gp_3_41_b gp_3_41_b 0 {Cg}
Mp_3_41_b bx gp_3_41_b colp_L3_41 0 NSYN W=10u L=1u
Mn_3_41_b bx vcn coln_L3_41 0 NSYN W=10u L=1u
Msa_h_L3_41 coln_L3_41 coln_L3_41 0 0 NMIR W=20u L=1u
Msb_h_L3_41 z_L3_41 coln_L3_41 0 0 NMIR W=20u L=1u
Msc_h_L3_41 colp_L3_41 colp_L3_41 0 0 NMIR W=20u L=1u
Msd_h_L3_41 dpf_h_L3_41 colp_L3_41 0 0 NMIR W=20u L=1u
Mse_h_L3_41 dpf_h_L3_41 dpf_h_L3_41 vdd vdd PMIR W=60u L=1u
Msf_h_L3_41 z_L3_41 dpf_h_L3_41 vdd vdd PMIR W=60u L=1u
R_h_L3_41 z_L3_41 vrefh 8000.0
Mr_L3_41  hdd_L3_41 z_L3_41 tail_L3_41 0 NREL W=12u L=1u
Mr2_L3_41 dmp_L3_41  vmid  tail_L3_41 0 NREL W=12u L=1u
Mtl_L3_41 tail_L3_41 vtb 0 0 NREL W=32.0u L=1u
Mdm_L3_41 dmp_L3_41 dmp_L3_41 vdd vdd PMIR W=40u L=1u
Mrp1_L3_41 hdd_L3_41 hdd_L3_41 vdd vdd PMIR W=40u L=1u
Mrp2_L3_41 hv_L3_41 hdd_L3_41 vdd vdd PMIR W=40u L=1u
Rhv_L3_41 hv_L3_41 vg0 8000.0
C_gp_3_42_0 gp_3_42_0 0 {Cg}
Mp_3_42_0 hv_L2_3 gp_3_42_0 colp_L3_42 0 NSYN W=10u L=1u
Mn_3_42_0 hv_L2_3 vcn coln_L3_42 0 NSYN W=10u L=1u
C_gp_3_42_1 gp_3_42_1 0 {Cg}
Mp_3_42_1 hv_L2_4 gp_3_42_1 colp_L3_42 0 NSYN W=10u L=1u
Mn_3_42_1 hv_L2_4 vcn coln_L3_42 0 NSYN W=10u L=1u
C_gp_3_42_2 gp_3_42_2 0 {Cg}
Mp_3_42_2 hv_L2_6 gp_3_42_2 colp_L3_42 0 NSYN W=10u L=1u
Mn_3_42_2 hv_L2_6 vcn coln_L3_42 0 NSYN W=10u L=1u
C_gp_3_42_3 gp_3_42_3 0 {Cg}
Mp_3_42_3 hv_L2_9 gp_3_42_3 colp_L3_42 0 NSYN W=10u L=1u
Mn_3_42_3 hv_L2_9 vcn coln_L3_42 0 NSYN W=10u L=1u
C_gp_3_42_4 gp_3_42_4 0 {Cg}
Mp_3_42_4 hv_L2_10 gp_3_42_4 colp_L3_42 0 NSYN W=10u L=1u
Mn_3_42_4 hv_L2_10 vcn coln_L3_42 0 NSYN W=10u L=1u
C_gp_3_42_5 gp_3_42_5 0 {Cg}
Mp_3_42_5 hv_L2_12 gp_3_42_5 colp_L3_42 0 NSYN W=10u L=1u
Mn_3_42_5 hv_L2_12 vcn coln_L3_42 0 NSYN W=10u L=1u
C_gp_3_42_6 gp_3_42_6 0 {Cg}
Mp_3_42_6 hv_L2_14 gp_3_42_6 colp_L3_42 0 NSYN W=10u L=1u
Mn_3_42_6 hv_L2_14 vcn coln_L3_42 0 NSYN W=10u L=1u
C_gp_3_42_7 gp_3_42_7 0 {Cg}
Mp_3_42_7 hv_L2_19 gp_3_42_7 colp_L3_42 0 NSYN W=10u L=1u
Mn_3_42_7 hv_L2_19 vcn coln_L3_42 0 NSYN W=10u L=1u
C_gp_3_42_8 gp_3_42_8 0 {Cg}
Mp_3_42_8 hv_L2_23 gp_3_42_8 colp_L3_42 0 NSYN W=10u L=1u
Mn_3_42_8 hv_L2_23 vcn coln_L3_42 0 NSYN W=10u L=1u
C_gp_3_42_9 gp_3_42_9 0 {Cg}
Mp_3_42_9 hv_L2_24 gp_3_42_9 colp_L3_42 0 NSYN W=10u L=1u
Mn_3_42_9 hv_L2_24 vcn coln_L3_42 0 NSYN W=10u L=1u
C_gp_3_42_10 gp_3_42_10 0 {Cg}
Mp_3_42_10 hv_L2_26 gp_3_42_10 colp_L3_42 0 NSYN W=10u L=1u
Mn_3_42_10 hv_L2_26 vcn coln_L3_42 0 NSYN W=10u L=1u
C_gp_3_42_11 gp_3_42_11 0 {Cg}
Mp_3_42_11 hv_L2_30 gp_3_42_11 colp_L3_42 0 NSYN W=10u L=1u
Mn_3_42_11 hv_L2_30 vcn coln_L3_42 0 NSYN W=10u L=1u
C_gp_3_42_12 gp_3_42_12 0 {Cg}
Mp_3_42_12 hv_L2_31 gp_3_42_12 colp_L3_42 0 NSYN W=10u L=1u
Mn_3_42_12 hv_L2_31 vcn coln_L3_42 0 NSYN W=10u L=1u
C_gp_3_42_13 gp_3_42_13 0 {Cg}
Mp_3_42_13 hv_L2_34 gp_3_42_13 colp_L3_42 0 NSYN W=10u L=1u
Mn_3_42_13 hv_L2_34 vcn coln_L3_42 0 NSYN W=10u L=1u
C_gp_3_42_14 gp_3_42_14 0 {Cg}
Mp_3_42_14 hv_L2_40 gp_3_42_14 colp_L3_42 0 NSYN W=10u L=1u
Mn_3_42_14 hv_L2_40 vcn coln_L3_42 0 NSYN W=10u L=1u
C_gp_3_42_15 gp_3_42_15 0 {Cg}
Mp_3_42_15 hv_L2_45 gp_3_42_15 colp_L3_42 0 NSYN W=10u L=1u
Mn_3_42_15 hv_L2_45 vcn coln_L3_42 0 NSYN W=10u L=1u
C_gp_3_42_b gp_3_42_b 0 {Cg}
Mp_3_42_b bx gp_3_42_b colp_L3_42 0 NSYN W=10u L=1u
Mn_3_42_b bx vcn coln_L3_42 0 NSYN W=10u L=1u
Msa_h_L3_42 coln_L3_42 coln_L3_42 0 0 NMIR W=20u L=1u
Msb_h_L3_42 z_L3_42 coln_L3_42 0 0 NMIR W=20u L=1u
Msc_h_L3_42 colp_L3_42 colp_L3_42 0 0 NMIR W=20u L=1u
Msd_h_L3_42 dpf_h_L3_42 colp_L3_42 0 0 NMIR W=20u L=1u
Mse_h_L3_42 dpf_h_L3_42 dpf_h_L3_42 vdd vdd PMIR W=60u L=1u
Msf_h_L3_42 z_L3_42 dpf_h_L3_42 vdd vdd PMIR W=60u L=1u
R_h_L3_42 z_L3_42 vrefh 8000.0
Mr_L3_42  hdd_L3_42 z_L3_42 tail_L3_42 0 NREL W=12u L=1u
Mr2_L3_42 dmp_L3_42  vmid  tail_L3_42 0 NREL W=12u L=1u
Mtl_L3_42 tail_L3_42 vtb 0 0 NREL W=32.0u L=1u
Mdm_L3_42 dmp_L3_42 dmp_L3_42 vdd vdd PMIR W=40u L=1u
Mrp1_L3_42 hdd_L3_42 hdd_L3_42 vdd vdd PMIR W=40u L=1u
Mrp2_L3_42 hv_L3_42 hdd_L3_42 vdd vdd PMIR W=40u L=1u
Rhv_L3_42 hv_L3_42 vg0 8000.0
C_gp_3_43_0 gp_3_43_0 0 {Cg}
Mp_3_43_0 hv_L2_0 gp_3_43_0 colp_L3_43 0 NSYN W=10u L=1u
Mn_3_43_0 hv_L2_0 vcn coln_L3_43 0 NSYN W=10u L=1u
C_gp_3_43_1 gp_3_43_1 0 {Cg}
Mp_3_43_1 hv_L2_2 gp_3_43_1 colp_L3_43 0 NSYN W=10u L=1u
Mn_3_43_1 hv_L2_2 vcn coln_L3_43 0 NSYN W=10u L=1u
C_gp_3_43_2 gp_3_43_2 0 {Cg}
Mp_3_43_2 hv_L2_4 gp_3_43_2 colp_L3_43 0 NSYN W=10u L=1u
Mn_3_43_2 hv_L2_4 vcn coln_L3_43 0 NSYN W=10u L=1u
C_gp_3_43_3 gp_3_43_3 0 {Cg}
Mp_3_43_3 hv_L2_6 gp_3_43_3 colp_L3_43 0 NSYN W=10u L=1u
Mn_3_43_3 hv_L2_6 vcn coln_L3_43 0 NSYN W=10u L=1u
C_gp_3_43_4 gp_3_43_4 0 {Cg}
Mp_3_43_4 hv_L2_8 gp_3_43_4 colp_L3_43 0 NSYN W=10u L=1u
Mn_3_43_4 hv_L2_8 vcn coln_L3_43 0 NSYN W=10u L=1u
C_gp_3_43_5 gp_3_43_5 0 {Cg}
Mp_3_43_5 hv_L2_10 gp_3_43_5 colp_L3_43 0 NSYN W=10u L=1u
Mn_3_43_5 hv_L2_10 vcn coln_L3_43 0 NSYN W=10u L=1u
C_gp_3_43_6 gp_3_43_6 0 {Cg}
Mp_3_43_6 hv_L2_11 gp_3_43_6 colp_L3_43 0 NSYN W=10u L=1u
Mn_3_43_6 hv_L2_11 vcn coln_L3_43 0 NSYN W=10u L=1u
C_gp_3_43_7 gp_3_43_7 0 {Cg}
Mp_3_43_7 hv_L2_12 gp_3_43_7 colp_L3_43 0 NSYN W=10u L=1u
Mn_3_43_7 hv_L2_12 vcn coln_L3_43 0 NSYN W=10u L=1u
C_gp_3_43_8 gp_3_43_8 0 {Cg}
Mp_3_43_8 hv_L2_15 gp_3_43_8 colp_L3_43 0 NSYN W=10u L=1u
Mn_3_43_8 hv_L2_15 vcn coln_L3_43 0 NSYN W=10u L=1u
C_gp_3_43_9 gp_3_43_9 0 {Cg}
Mp_3_43_9 hv_L2_18 gp_3_43_9 colp_L3_43 0 NSYN W=10u L=1u
Mn_3_43_9 hv_L2_18 vcn coln_L3_43 0 NSYN W=10u L=1u
C_gp_3_43_10 gp_3_43_10 0 {Cg}
Mp_3_43_10 hv_L2_27 gp_3_43_10 colp_L3_43 0 NSYN W=10u L=1u
Mn_3_43_10 hv_L2_27 vcn coln_L3_43 0 NSYN W=10u L=1u
C_gp_3_43_11 gp_3_43_11 0 {Cg}
Mp_3_43_11 hv_L2_30 gp_3_43_11 colp_L3_43 0 NSYN W=10u L=1u
Mn_3_43_11 hv_L2_30 vcn coln_L3_43 0 NSYN W=10u L=1u
C_gp_3_43_12 gp_3_43_12 0 {Cg}
Mp_3_43_12 hv_L2_35 gp_3_43_12 colp_L3_43 0 NSYN W=10u L=1u
Mn_3_43_12 hv_L2_35 vcn coln_L3_43 0 NSYN W=10u L=1u
C_gp_3_43_13 gp_3_43_13 0 {Cg}
Mp_3_43_13 hv_L2_37 gp_3_43_13 colp_L3_43 0 NSYN W=10u L=1u
Mn_3_43_13 hv_L2_37 vcn coln_L3_43 0 NSYN W=10u L=1u
C_gp_3_43_14 gp_3_43_14 0 {Cg}
Mp_3_43_14 hv_L2_40 gp_3_43_14 colp_L3_43 0 NSYN W=10u L=1u
Mn_3_43_14 hv_L2_40 vcn coln_L3_43 0 NSYN W=10u L=1u
C_gp_3_43_15 gp_3_43_15 0 {Cg}
Mp_3_43_15 hv_L2_43 gp_3_43_15 colp_L3_43 0 NSYN W=10u L=1u
Mn_3_43_15 hv_L2_43 vcn coln_L3_43 0 NSYN W=10u L=1u
C_gp_3_43_b gp_3_43_b 0 {Cg}
Mp_3_43_b bx gp_3_43_b colp_L3_43 0 NSYN W=10u L=1u
Mn_3_43_b bx vcn coln_L3_43 0 NSYN W=10u L=1u
Msa_h_L3_43 coln_L3_43 coln_L3_43 0 0 NMIR W=20u L=1u
Msb_h_L3_43 z_L3_43 coln_L3_43 0 0 NMIR W=20u L=1u
Msc_h_L3_43 colp_L3_43 colp_L3_43 0 0 NMIR W=20u L=1u
Msd_h_L3_43 dpf_h_L3_43 colp_L3_43 0 0 NMIR W=20u L=1u
Mse_h_L3_43 dpf_h_L3_43 dpf_h_L3_43 vdd vdd PMIR W=60u L=1u
Msf_h_L3_43 z_L3_43 dpf_h_L3_43 vdd vdd PMIR W=60u L=1u
R_h_L3_43 z_L3_43 vrefh 8000.0
Mr_L3_43  hdd_L3_43 z_L3_43 tail_L3_43 0 NREL W=12u L=1u
Mr2_L3_43 dmp_L3_43  vmid  tail_L3_43 0 NREL W=12u L=1u
Mtl_L3_43 tail_L3_43 vtb 0 0 NREL W=32.0u L=1u
Mdm_L3_43 dmp_L3_43 dmp_L3_43 vdd vdd PMIR W=40u L=1u
Mrp1_L3_43 hdd_L3_43 hdd_L3_43 vdd vdd PMIR W=40u L=1u
Mrp2_L3_43 hv_L3_43 hdd_L3_43 vdd vdd PMIR W=40u L=1u
Rhv_L3_43 hv_L3_43 vg0 8000.0
C_gp_3_44_0 gp_3_44_0 0 {Cg}
Mp_3_44_0 hv_L2_0 gp_3_44_0 colp_L3_44 0 NSYN W=10u L=1u
Mn_3_44_0 hv_L2_0 vcn coln_L3_44 0 NSYN W=10u L=1u
C_gp_3_44_1 gp_3_44_1 0 {Cg}
Mp_3_44_1 hv_L2_3 gp_3_44_1 colp_L3_44 0 NSYN W=10u L=1u
Mn_3_44_1 hv_L2_3 vcn coln_L3_44 0 NSYN W=10u L=1u
C_gp_3_44_2 gp_3_44_2 0 {Cg}
Mp_3_44_2 hv_L2_11 gp_3_44_2 colp_L3_44 0 NSYN W=10u L=1u
Mn_3_44_2 hv_L2_11 vcn coln_L3_44 0 NSYN W=10u L=1u
C_gp_3_44_3 gp_3_44_3 0 {Cg}
Mp_3_44_3 hv_L2_16 gp_3_44_3 colp_L3_44 0 NSYN W=10u L=1u
Mn_3_44_3 hv_L2_16 vcn coln_L3_44 0 NSYN W=10u L=1u
C_gp_3_44_4 gp_3_44_4 0 {Cg}
Mp_3_44_4 hv_L2_19 gp_3_44_4 colp_L3_44 0 NSYN W=10u L=1u
Mn_3_44_4 hv_L2_19 vcn coln_L3_44 0 NSYN W=10u L=1u
C_gp_3_44_5 gp_3_44_5 0 {Cg}
Mp_3_44_5 hv_L2_23 gp_3_44_5 colp_L3_44 0 NSYN W=10u L=1u
Mn_3_44_5 hv_L2_23 vcn coln_L3_44 0 NSYN W=10u L=1u
C_gp_3_44_6 gp_3_44_6 0 {Cg}
Mp_3_44_6 hv_L2_25 gp_3_44_6 colp_L3_44 0 NSYN W=10u L=1u
Mn_3_44_6 hv_L2_25 vcn coln_L3_44 0 NSYN W=10u L=1u
C_gp_3_44_7 gp_3_44_7 0 {Cg}
Mp_3_44_7 hv_L2_29 gp_3_44_7 colp_L3_44 0 NSYN W=10u L=1u
Mn_3_44_7 hv_L2_29 vcn coln_L3_44 0 NSYN W=10u L=1u
C_gp_3_44_8 gp_3_44_8 0 {Cg}
Mp_3_44_8 hv_L2_32 gp_3_44_8 colp_L3_44 0 NSYN W=10u L=1u
Mn_3_44_8 hv_L2_32 vcn coln_L3_44 0 NSYN W=10u L=1u
C_gp_3_44_9 gp_3_44_9 0 {Cg}
Mp_3_44_9 hv_L2_33 gp_3_44_9 colp_L3_44 0 NSYN W=10u L=1u
Mn_3_44_9 hv_L2_33 vcn coln_L3_44 0 NSYN W=10u L=1u
C_gp_3_44_10 gp_3_44_10 0 {Cg}
Mp_3_44_10 hv_L2_35 gp_3_44_10 colp_L3_44 0 NSYN W=10u L=1u
Mn_3_44_10 hv_L2_35 vcn coln_L3_44 0 NSYN W=10u L=1u
C_gp_3_44_11 gp_3_44_11 0 {Cg}
Mp_3_44_11 hv_L2_36 gp_3_44_11 colp_L3_44 0 NSYN W=10u L=1u
Mn_3_44_11 hv_L2_36 vcn coln_L3_44 0 NSYN W=10u L=1u
C_gp_3_44_12 gp_3_44_12 0 {Cg}
Mp_3_44_12 hv_L2_42 gp_3_44_12 colp_L3_44 0 NSYN W=10u L=1u
Mn_3_44_12 hv_L2_42 vcn coln_L3_44 0 NSYN W=10u L=1u
C_gp_3_44_13 gp_3_44_13 0 {Cg}
Mp_3_44_13 hv_L2_43 gp_3_44_13 colp_L3_44 0 NSYN W=10u L=1u
Mn_3_44_13 hv_L2_43 vcn coln_L3_44 0 NSYN W=10u L=1u
C_gp_3_44_14 gp_3_44_14 0 {Cg}
Mp_3_44_14 hv_L2_44 gp_3_44_14 colp_L3_44 0 NSYN W=10u L=1u
Mn_3_44_14 hv_L2_44 vcn coln_L3_44 0 NSYN W=10u L=1u
C_gp_3_44_15 gp_3_44_15 0 {Cg}
Mp_3_44_15 hv_L2_46 gp_3_44_15 colp_L3_44 0 NSYN W=10u L=1u
Mn_3_44_15 hv_L2_46 vcn coln_L3_44 0 NSYN W=10u L=1u
C_gp_3_44_b gp_3_44_b 0 {Cg}
Mp_3_44_b bx gp_3_44_b colp_L3_44 0 NSYN W=10u L=1u
Mn_3_44_b bx vcn coln_L3_44 0 NSYN W=10u L=1u
Msa_h_L3_44 coln_L3_44 coln_L3_44 0 0 NMIR W=20u L=1u
Msb_h_L3_44 z_L3_44 coln_L3_44 0 0 NMIR W=20u L=1u
Msc_h_L3_44 colp_L3_44 colp_L3_44 0 0 NMIR W=20u L=1u
Msd_h_L3_44 dpf_h_L3_44 colp_L3_44 0 0 NMIR W=20u L=1u
Mse_h_L3_44 dpf_h_L3_44 dpf_h_L3_44 vdd vdd PMIR W=60u L=1u
Msf_h_L3_44 z_L3_44 dpf_h_L3_44 vdd vdd PMIR W=60u L=1u
R_h_L3_44 z_L3_44 vrefh 8000.0
Mr_L3_44  hdd_L3_44 z_L3_44 tail_L3_44 0 NREL W=12u L=1u
Mr2_L3_44 dmp_L3_44  vmid  tail_L3_44 0 NREL W=12u L=1u
Mtl_L3_44 tail_L3_44 vtb 0 0 NREL W=32.0u L=1u
Mdm_L3_44 dmp_L3_44 dmp_L3_44 vdd vdd PMIR W=40u L=1u
Mrp1_L3_44 hdd_L3_44 hdd_L3_44 vdd vdd PMIR W=40u L=1u
Mrp2_L3_44 hv_L3_44 hdd_L3_44 vdd vdd PMIR W=40u L=1u
Rhv_L3_44 hv_L3_44 vg0 8000.0
C_gp_3_45_0 gp_3_45_0 0 {Cg}
Mp_3_45_0 hv_L2_0 gp_3_45_0 colp_L3_45 0 NSYN W=10u L=1u
Mn_3_45_0 hv_L2_0 vcn coln_L3_45 0 NSYN W=10u L=1u
C_gp_3_45_1 gp_3_45_1 0 {Cg}
Mp_3_45_1 hv_L2_2 gp_3_45_1 colp_L3_45 0 NSYN W=10u L=1u
Mn_3_45_1 hv_L2_2 vcn coln_L3_45 0 NSYN W=10u L=1u
C_gp_3_45_2 gp_3_45_2 0 {Cg}
Mp_3_45_2 hv_L2_4 gp_3_45_2 colp_L3_45 0 NSYN W=10u L=1u
Mn_3_45_2 hv_L2_4 vcn coln_L3_45 0 NSYN W=10u L=1u
C_gp_3_45_3 gp_3_45_3 0 {Cg}
Mp_3_45_3 hv_L2_5 gp_3_45_3 colp_L3_45 0 NSYN W=10u L=1u
Mn_3_45_3 hv_L2_5 vcn coln_L3_45 0 NSYN W=10u L=1u
C_gp_3_45_4 gp_3_45_4 0 {Cg}
Mp_3_45_4 hv_L2_7 gp_3_45_4 colp_L3_45 0 NSYN W=10u L=1u
Mn_3_45_4 hv_L2_7 vcn coln_L3_45 0 NSYN W=10u L=1u
C_gp_3_45_5 gp_3_45_5 0 {Cg}
Mp_3_45_5 hv_L2_12 gp_3_45_5 colp_L3_45 0 NSYN W=10u L=1u
Mn_3_45_5 hv_L2_12 vcn coln_L3_45 0 NSYN W=10u L=1u
C_gp_3_45_6 gp_3_45_6 0 {Cg}
Mp_3_45_6 hv_L2_16 gp_3_45_6 colp_L3_45 0 NSYN W=10u L=1u
Mn_3_45_6 hv_L2_16 vcn coln_L3_45 0 NSYN W=10u L=1u
C_gp_3_45_7 gp_3_45_7 0 {Cg}
Mp_3_45_7 hv_L2_23 gp_3_45_7 colp_L3_45 0 NSYN W=10u L=1u
Mn_3_45_7 hv_L2_23 vcn coln_L3_45 0 NSYN W=10u L=1u
C_gp_3_45_8 gp_3_45_8 0 {Cg}
Mp_3_45_8 hv_L2_26 gp_3_45_8 colp_L3_45 0 NSYN W=10u L=1u
Mn_3_45_8 hv_L2_26 vcn coln_L3_45 0 NSYN W=10u L=1u
C_gp_3_45_9 gp_3_45_9 0 {Cg}
Mp_3_45_9 hv_L2_35 gp_3_45_9 colp_L3_45 0 NSYN W=10u L=1u
Mn_3_45_9 hv_L2_35 vcn coln_L3_45 0 NSYN W=10u L=1u
C_gp_3_45_10 gp_3_45_10 0 {Cg}
Mp_3_45_10 hv_L2_36 gp_3_45_10 colp_L3_45 0 NSYN W=10u L=1u
Mn_3_45_10 hv_L2_36 vcn coln_L3_45 0 NSYN W=10u L=1u
C_gp_3_45_11 gp_3_45_11 0 {Cg}
Mp_3_45_11 hv_L2_40 gp_3_45_11 colp_L3_45 0 NSYN W=10u L=1u
Mn_3_45_11 hv_L2_40 vcn coln_L3_45 0 NSYN W=10u L=1u
C_gp_3_45_12 gp_3_45_12 0 {Cg}
Mp_3_45_12 hv_L2_41 gp_3_45_12 colp_L3_45 0 NSYN W=10u L=1u
Mn_3_45_12 hv_L2_41 vcn coln_L3_45 0 NSYN W=10u L=1u
C_gp_3_45_13 gp_3_45_13 0 {Cg}
Mp_3_45_13 hv_L2_44 gp_3_45_13 colp_L3_45 0 NSYN W=10u L=1u
Mn_3_45_13 hv_L2_44 vcn coln_L3_45 0 NSYN W=10u L=1u
C_gp_3_45_14 gp_3_45_14 0 {Cg}
Mp_3_45_14 hv_L2_46 gp_3_45_14 colp_L3_45 0 NSYN W=10u L=1u
Mn_3_45_14 hv_L2_46 vcn coln_L3_45 0 NSYN W=10u L=1u
C_gp_3_45_15 gp_3_45_15 0 {Cg}
Mp_3_45_15 hv_L2_47 gp_3_45_15 colp_L3_45 0 NSYN W=10u L=1u
Mn_3_45_15 hv_L2_47 vcn coln_L3_45 0 NSYN W=10u L=1u
C_gp_3_45_b gp_3_45_b 0 {Cg}
Mp_3_45_b bx gp_3_45_b colp_L3_45 0 NSYN W=10u L=1u
Mn_3_45_b bx vcn coln_L3_45 0 NSYN W=10u L=1u
Msa_h_L3_45 coln_L3_45 coln_L3_45 0 0 NMIR W=20u L=1u
Msb_h_L3_45 z_L3_45 coln_L3_45 0 0 NMIR W=20u L=1u
Msc_h_L3_45 colp_L3_45 colp_L3_45 0 0 NMIR W=20u L=1u
Msd_h_L3_45 dpf_h_L3_45 colp_L3_45 0 0 NMIR W=20u L=1u
Mse_h_L3_45 dpf_h_L3_45 dpf_h_L3_45 vdd vdd PMIR W=60u L=1u
Msf_h_L3_45 z_L3_45 dpf_h_L3_45 vdd vdd PMIR W=60u L=1u
R_h_L3_45 z_L3_45 vrefh 8000.0
Mr_L3_45  hdd_L3_45 z_L3_45 tail_L3_45 0 NREL W=12u L=1u
Mr2_L3_45 dmp_L3_45  vmid  tail_L3_45 0 NREL W=12u L=1u
Mtl_L3_45 tail_L3_45 vtb 0 0 NREL W=32.0u L=1u
Mdm_L3_45 dmp_L3_45 dmp_L3_45 vdd vdd PMIR W=40u L=1u
Mrp1_L3_45 hdd_L3_45 hdd_L3_45 vdd vdd PMIR W=40u L=1u
Mrp2_L3_45 hv_L3_45 hdd_L3_45 vdd vdd PMIR W=40u L=1u
Rhv_L3_45 hv_L3_45 vg0 8000.0
C_gp_3_46_0 gp_3_46_0 0 {Cg}
Mp_3_46_0 hv_L2_1 gp_3_46_0 colp_L3_46 0 NSYN W=10u L=1u
Mn_3_46_0 hv_L2_1 vcn coln_L3_46 0 NSYN W=10u L=1u
C_gp_3_46_1 gp_3_46_1 0 {Cg}
Mp_3_46_1 hv_L2_2 gp_3_46_1 colp_L3_46 0 NSYN W=10u L=1u
Mn_3_46_1 hv_L2_2 vcn coln_L3_46 0 NSYN W=10u L=1u
C_gp_3_46_2 gp_3_46_2 0 {Cg}
Mp_3_46_2 hv_L2_4 gp_3_46_2 colp_L3_46 0 NSYN W=10u L=1u
Mn_3_46_2 hv_L2_4 vcn coln_L3_46 0 NSYN W=10u L=1u
C_gp_3_46_3 gp_3_46_3 0 {Cg}
Mp_3_46_3 hv_L2_5 gp_3_46_3 colp_L3_46 0 NSYN W=10u L=1u
Mn_3_46_3 hv_L2_5 vcn coln_L3_46 0 NSYN W=10u L=1u
C_gp_3_46_4 gp_3_46_4 0 {Cg}
Mp_3_46_4 hv_L2_8 gp_3_46_4 colp_L3_46 0 NSYN W=10u L=1u
Mn_3_46_4 hv_L2_8 vcn coln_L3_46 0 NSYN W=10u L=1u
C_gp_3_46_5 gp_3_46_5 0 {Cg}
Mp_3_46_5 hv_L2_20 gp_3_46_5 colp_L3_46 0 NSYN W=10u L=1u
Mn_3_46_5 hv_L2_20 vcn coln_L3_46 0 NSYN W=10u L=1u
C_gp_3_46_6 gp_3_46_6 0 {Cg}
Mp_3_46_6 hv_L2_22 gp_3_46_6 colp_L3_46 0 NSYN W=10u L=1u
Mn_3_46_6 hv_L2_22 vcn coln_L3_46 0 NSYN W=10u L=1u
C_gp_3_46_7 gp_3_46_7 0 {Cg}
Mp_3_46_7 hv_L2_25 gp_3_46_7 colp_L3_46 0 NSYN W=10u L=1u
Mn_3_46_7 hv_L2_25 vcn coln_L3_46 0 NSYN W=10u L=1u
C_gp_3_46_8 gp_3_46_8 0 {Cg}
Mp_3_46_8 hv_L2_26 gp_3_46_8 colp_L3_46 0 NSYN W=10u L=1u
Mn_3_46_8 hv_L2_26 vcn coln_L3_46 0 NSYN W=10u L=1u
C_gp_3_46_9 gp_3_46_9 0 {Cg}
Mp_3_46_9 hv_L2_28 gp_3_46_9 colp_L3_46 0 NSYN W=10u L=1u
Mn_3_46_9 hv_L2_28 vcn coln_L3_46 0 NSYN W=10u L=1u
C_gp_3_46_10 gp_3_46_10 0 {Cg}
Mp_3_46_10 hv_L2_30 gp_3_46_10 colp_L3_46 0 NSYN W=10u L=1u
Mn_3_46_10 hv_L2_30 vcn coln_L3_46 0 NSYN W=10u L=1u
C_gp_3_46_11 gp_3_46_11 0 {Cg}
Mp_3_46_11 hv_L2_35 gp_3_46_11 colp_L3_46 0 NSYN W=10u L=1u
Mn_3_46_11 hv_L2_35 vcn coln_L3_46 0 NSYN W=10u L=1u
C_gp_3_46_12 gp_3_46_12 0 {Cg}
Mp_3_46_12 hv_L2_36 gp_3_46_12 colp_L3_46 0 NSYN W=10u L=1u
Mn_3_46_12 hv_L2_36 vcn coln_L3_46 0 NSYN W=10u L=1u
C_gp_3_46_13 gp_3_46_13 0 {Cg}
Mp_3_46_13 hv_L2_38 gp_3_46_13 colp_L3_46 0 NSYN W=10u L=1u
Mn_3_46_13 hv_L2_38 vcn coln_L3_46 0 NSYN W=10u L=1u
C_gp_3_46_14 gp_3_46_14 0 {Cg}
Mp_3_46_14 hv_L2_42 gp_3_46_14 colp_L3_46 0 NSYN W=10u L=1u
Mn_3_46_14 hv_L2_42 vcn coln_L3_46 0 NSYN W=10u L=1u
C_gp_3_46_15 gp_3_46_15 0 {Cg}
Mp_3_46_15 hv_L2_46 gp_3_46_15 colp_L3_46 0 NSYN W=10u L=1u
Mn_3_46_15 hv_L2_46 vcn coln_L3_46 0 NSYN W=10u L=1u
C_gp_3_46_b gp_3_46_b 0 {Cg}
Mp_3_46_b bx gp_3_46_b colp_L3_46 0 NSYN W=10u L=1u
Mn_3_46_b bx vcn coln_L3_46 0 NSYN W=10u L=1u
Msa_h_L3_46 coln_L3_46 coln_L3_46 0 0 NMIR W=20u L=1u
Msb_h_L3_46 z_L3_46 coln_L3_46 0 0 NMIR W=20u L=1u
Msc_h_L3_46 colp_L3_46 colp_L3_46 0 0 NMIR W=20u L=1u
Msd_h_L3_46 dpf_h_L3_46 colp_L3_46 0 0 NMIR W=20u L=1u
Mse_h_L3_46 dpf_h_L3_46 dpf_h_L3_46 vdd vdd PMIR W=60u L=1u
Msf_h_L3_46 z_L3_46 dpf_h_L3_46 vdd vdd PMIR W=60u L=1u
R_h_L3_46 z_L3_46 vrefh 8000.0
Mr_L3_46  hdd_L3_46 z_L3_46 tail_L3_46 0 NREL W=12u L=1u
Mr2_L3_46 dmp_L3_46  vmid  tail_L3_46 0 NREL W=12u L=1u
Mtl_L3_46 tail_L3_46 vtb 0 0 NREL W=32.0u L=1u
Mdm_L3_46 dmp_L3_46 dmp_L3_46 vdd vdd PMIR W=40u L=1u
Mrp1_L3_46 hdd_L3_46 hdd_L3_46 vdd vdd PMIR W=40u L=1u
Mrp2_L3_46 hv_L3_46 hdd_L3_46 vdd vdd PMIR W=40u L=1u
Rhv_L3_46 hv_L3_46 vg0 8000.0
C_gp_3_47_0 gp_3_47_0 0 {Cg}
Mp_3_47_0 hv_L2_1 gp_3_47_0 colp_L3_47 0 NSYN W=10u L=1u
Mn_3_47_0 hv_L2_1 vcn coln_L3_47 0 NSYN W=10u L=1u
C_gp_3_47_1 gp_3_47_1 0 {Cg}
Mp_3_47_1 hv_L2_4 gp_3_47_1 colp_L3_47 0 NSYN W=10u L=1u
Mn_3_47_1 hv_L2_4 vcn coln_L3_47 0 NSYN W=10u L=1u
C_gp_3_47_2 gp_3_47_2 0 {Cg}
Mp_3_47_2 hv_L2_5 gp_3_47_2 colp_L3_47 0 NSYN W=10u L=1u
Mn_3_47_2 hv_L2_5 vcn coln_L3_47 0 NSYN W=10u L=1u
C_gp_3_47_3 gp_3_47_3 0 {Cg}
Mp_3_47_3 hv_L2_13 gp_3_47_3 colp_L3_47 0 NSYN W=10u L=1u
Mn_3_47_3 hv_L2_13 vcn coln_L3_47 0 NSYN W=10u L=1u
C_gp_3_47_4 gp_3_47_4 0 {Cg}
Mp_3_47_4 hv_L2_14 gp_3_47_4 colp_L3_47 0 NSYN W=10u L=1u
Mn_3_47_4 hv_L2_14 vcn coln_L3_47 0 NSYN W=10u L=1u
C_gp_3_47_5 gp_3_47_5 0 {Cg}
Mp_3_47_5 hv_L2_15 gp_3_47_5 colp_L3_47 0 NSYN W=10u L=1u
Mn_3_47_5 hv_L2_15 vcn coln_L3_47 0 NSYN W=10u L=1u
C_gp_3_47_6 gp_3_47_6 0 {Cg}
Mp_3_47_6 hv_L2_16 gp_3_47_6 colp_L3_47 0 NSYN W=10u L=1u
Mn_3_47_6 hv_L2_16 vcn coln_L3_47 0 NSYN W=10u L=1u
C_gp_3_47_7 gp_3_47_7 0 {Cg}
Mp_3_47_7 hv_L2_19 gp_3_47_7 colp_L3_47 0 NSYN W=10u L=1u
Mn_3_47_7 hv_L2_19 vcn coln_L3_47 0 NSYN W=10u L=1u
C_gp_3_47_8 gp_3_47_8 0 {Cg}
Mp_3_47_8 hv_L2_23 gp_3_47_8 colp_L3_47 0 NSYN W=10u L=1u
Mn_3_47_8 hv_L2_23 vcn coln_L3_47 0 NSYN W=10u L=1u
C_gp_3_47_9 gp_3_47_9 0 {Cg}
Mp_3_47_9 hv_L2_31 gp_3_47_9 colp_L3_47 0 NSYN W=10u L=1u
Mn_3_47_9 hv_L2_31 vcn coln_L3_47 0 NSYN W=10u L=1u
C_gp_3_47_10 gp_3_47_10 0 {Cg}
Mp_3_47_10 hv_L2_32 gp_3_47_10 colp_L3_47 0 NSYN W=10u L=1u
Mn_3_47_10 hv_L2_32 vcn coln_L3_47 0 NSYN W=10u L=1u
C_gp_3_47_11 gp_3_47_11 0 {Cg}
Mp_3_47_11 hv_L2_33 gp_3_47_11 colp_L3_47 0 NSYN W=10u L=1u
Mn_3_47_11 hv_L2_33 vcn coln_L3_47 0 NSYN W=10u L=1u
C_gp_3_47_12 gp_3_47_12 0 {Cg}
Mp_3_47_12 hv_L2_36 gp_3_47_12 colp_L3_47 0 NSYN W=10u L=1u
Mn_3_47_12 hv_L2_36 vcn coln_L3_47 0 NSYN W=10u L=1u
C_gp_3_47_13 gp_3_47_13 0 {Cg}
Mp_3_47_13 hv_L2_37 gp_3_47_13 colp_L3_47 0 NSYN W=10u L=1u
Mn_3_47_13 hv_L2_37 vcn coln_L3_47 0 NSYN W=10u L=1u
C_gp_3_47_14 gp_3_47_14 0 {Cg}
Mp_3_47_14 hv_L2_39 gp_3_47_14 colp_L3_47 0 NSYN W=10u L=1u
Mn_3_47_14 hv_L2_39 vcn coln_L3_47 0 NSYN W=10u L=1u
C_gp_3_47_15 gp_3_47_15 0 {Cg}
Mp_3_47_15 hv_L2_44 gp_3_47_15 colp_L3_47 0 NSYN W=10u L=1u
Mn_3_47_15 hv_L2_44 vcn coln_L3_47 0 NSYN W=10u L=1u
C_gp_3_47_b gp_3_47_b 0 {Cg}
Mp_3_47_b bx gp_3_47_b colp_L3_47 0 NSYN W=10u L=1u
Mn_3_47_b bx vcn coln_L3_47 0 NSYN W=10u L=1u
Msa_h_L3_47 coln_L3_47 coln_L3_47 0 0 NMIR W=20u L=1u
Msb_h_L3_47 z_L3_47 coln_L3_47 0 0 NMIR W=20u L=1u
Msc_h_L3_47 colp_L3_47 colp_L3_47 0 0 NMIR W=20u L=1u
Msd_h_L3_47 dpf_h_L3_47 colp_L3_47 0 0 NMIR W=20u L=1u
Mse_h_L3_47 dpf_h_L3_47 dpf_h_L3_47 vdd vdd PMIR W=60u L=1u
Msf_h_L3_47 z_L3_47 dpf_h_L3_47 vdd vdd PMIR W=60u L=1u
R_h_L3_47 z_L3_47 vrefh 8000.0
Mr_L3_47  hdd_L3_47 z_L3_47 tail_L3_47 0 NREL W=12u L=1u
Mr2_L3_47 dmp_L3_47  vmid  tail_L3_47 0 NREL W=12u L=1u
Mtl_L3_47 tail_L3_47 vtb 0 0 NREL W=32.0u L=1u
Mdm_L3_47 dmp_L3_47 dmp_L3_47 vdd vdd PMIR W=40u L=1u
Mrp1_L3_47 hdd_L3_47 hdd_L3_47 vdd vdd PMIR W=40u L=1u
Mrp2_L3_47 hv_L3_47 hdd_L3_47 vdd vdd PMIR W=40u L=1u
Rhv_L3_47 hv_L3_47 vg0 8000.0
C_gp_o_0_0 gp_o_0_0 0 {Cg}
Mp_o_0_0 hv_L3_46 gp_o_0_0 colpo0 0 NSYN W=10u L=1u
Mn_o_0_0 hv_L3_46 vcn colno0 0 NSYN W=10u L=1u
C_gp_o_0_1 gp_o_0_1 0 {Cg}
Mp_o_0_1 hv_L3_30 gp_o_0_1 colpo0 0 NSYN W=10u L=1u
Mn_o_0_1 hv_L3_30 vcn colno0 0 NSYN W=10u L=1u
C_gp_o_0_2 gp_o_0_2 0 {Cg}
Mp_o_0_2 hv_L3_5 gp_o_0_2 colpo0 0 NSYN W=10u L=1u
Mn_o_0_2 hv_L3_5 vcn colno0 0 NSYN W=10u L=1u
C_gp_o_0_3 gp_o_0_3 0 {Cg}
Mp_o_0_3 hv_L3_45 gp_o_0_3 colpo0 0 NSYN W=10u L=1u
Mn_o_0_3 hv_L3_45 vcn colno0 0 NSYN W=10u L=1u
C_gp_o_0_4 gp_o_0_4 0 {Cg}
Mp_o_0_4 hv_L3_1 gp_o_0_4 colpo0 0 NSYN W=10u L=1u
Mn_o_0_4 hv_L3_1 vcn colno0 0 NSYN W=10u L=1u
C_gp_o_0_5 gp_o_0_5 0 {Cg}
Mp_o_0_5 hv_L3_10 gp_o_0_5 colpo0 0 NSYN W=10u L=1u
Mn_o_0_5 hv_L3_10 vcn colno0 0 NSYN W=10u L=1u
C_gp_o_0_6 gp_o_0_6 0 {Cg}
Mp_o_0_6 hv_L3_28 gp_o_0_6 colpo0 0 NSYN W=10u L=1u
Mn_o_0_6 hv_L3_28 vcn colno0 0 NSYN W=10u L=1u
C_gp_o_0_7 gp_o_0_7 0 {Cg}
Mp_o_0_7 hv_L3_21 gp_o_0_7 colpo0 0 NSYN W=10u L=1u
Mn_o_0_7 hv_L3_21 vcn colno0 0 NSYN W=10u L=1u
C_gp_o_0_8 gp_o_0_8 0 {Cg}
Mp_o_0_8 hv_L3_17 gp_o_0_8 colpo0 0 NSYN W=10u L=1u
Mn_o_0_8 hv_L3_17 vcn colno0 0 NSYN W=10u L=1u
C_gp_o_0_9 gp_o_0_9 0 {Cg}
Mp_o_0_9 hv_L3_19 gp_o_0_9 colpo0 0 NSYN W=10u L=1u
Mn_o_0_9 hv_L3_19 vcn colno0 0 NSYN W=10u L=1u
C_gp_o_0_10 gp_o_0_10 0 {Cg}
Mp_o_0_10 hv_L3_16 gp_o_0_10 colpo0 0 NSYN W=10u L=1u
Mn_o_0_10 hv_L3_16 vcn colno0 0 NSYN W=10u L=1u
C_gp_o_0_11 gp_o_0_11 0 {Cg}
Mp_o_0_11 hv_L3_25 gp_o_0_11 colpo0 0 NSYN W=10u L=1u
Mn_o_0_11 hv_L3_25 vcn colno0 0 NSYN W=10u L=1u
C_gp_o_0_12 gp_o_0_12 0 {Cg}
Mp_o_0_12 hv_L3_47 gp_o_0_12 colpo0 0 NSYN W=10u L=1u
Mn_o_0_12 hv_L3_47 vcn colno0 0 NSYN W=10u L=1u
C_gp_o_0_13 gp_o_0_13 0 {Cg}
Mp_o_0_13 hv_L3_4 gp_o_0_13 colpo0 0 NSYN W=10u L=1u
Mn_o_0_13 hv_L3_4 vcn colno0 0 NSYN W=10u L=1u
C_gp_o_0_14 gp_o_0_14 0 {Cg}
Mp_o_0_14 hv_L3_38 gp_o_0_14 colpo0 0 NSYN W=10u L=1u
Mn_o_0_14 hv_L3_38 vcn colno0 0 NSYN W=10u L=1u
C_gp_o_0_15 gp_o_0_15 0 {Cg}
Mp_o_0_15 hv_L3_15 gp_o_0_15 colpo0 0 NSYN W=10u L=1u
Mn_o_0_15 hv_L3_15 vcn colno0 0 NSYN W=10u L=1u
C_gp_o_0_16 gp_o_0_16 0 {Cg}
Mp_o_0_16 hv_L3_37 gp_o_0_16 colpo0 0 NSYN W=10u L=1u
Mn_o_0_16 hv_L3_37 vcn colno0 0 NSYN W=10u L=1u
C_gp_o_0_17 gp_o_0_17 0 {Cg}
Mp_o_0_17 hv_L3_14 gp_o_0_17 colpo0 0 NSYN W=10u L=1u
Mn_o_0_17 hv_L3_14 vcn colno0 0 NSYN W=10u L=1u
C_gp_o_0_18 gp_o_0_18 0 {Cg}
Mp_o_0_18 hv_L3_26 gp_o_0_18 colpo0 0 NSYN W=10u L=1u
Mn_o_0_18 hv_L3_26 vcn colno0 0 NSYN W=10u L=1u
C_gp_o_0_19 gp_o_0_19 0 {Cg}
Mp_o_0_19 hv_L3_39 gp_o_0_19 colpo0 0 NSYN W=10u L=1u
Mn_o_0_19 hv_L3_39 vcn colno0 0 NSYN W=10u L=1u
C_gp_o_0_20 gp_o_0_20 0 {Cg}
Mp_o_0_20 hv_L3_9 gp_o_0_20 colpo0 0 NSYN W=10u L=1u
Mn_o_0_20 hv_L3_9 vcn colno0 0 NSYN W=10u L=1u
C_gp_o_0_21 gp_o_0_21 0 {Cg}
Mp_o_0_21 hv_L3_44 gp_o_0_21 colpo0 0 NSYN W=10u L=1u
Mn_o_0_21 hv_L3_44 vcn colno0 0 NSYN W=10u L=1u
C_gp_o_0_22 gp_o_0_22 0 {Cg}
Mp_o_0_22 hv_L3_12 gp_o_0_22 colpo0 0 NSYN W=10u L=1u
Mn_o_0_22 hv_L3_12 vcn colno0 0 NSYN W=10u L=1u
C_gp_o_0_23 gp_o_0_23 0 {Cg}
Mp_o_0_23 hv_L3_33 gp_o_0_23 colpo0 0 NSYN W=10u L=1u
Mn_o_0_23 hv_L3_33 vcn colno0 0 NSYN W=10u L=1u
C_gp_o_0_24 gp_o_0_24 0 {Cg}
Mp_o_0_24 hv_L3_29 gp_o_0_24 colpo0 0 NSYN W=10u L=1u
Mn_o_0_24 hv_L3_29 vcn colno0 0 NSYN W=10u L=1u
C_gp_o_0_25 gp_o_0_25 0 {Cg}
Mp_o_0_25 hv_L3_43 gp_o_0_25 colpo0 0 NSYN W=10u L=1u
Mn_o_0_25 hv_L3_43 vcn colno0 0 NSYN W=10u L=1u
C_gp_o_0_26 gp_o_0_26 0 {Cg}
Mp_o_0_26 hv_L3_22 gp_o_0_26 colpo0 0 NSYN W=10u L=1u
Mn_o_0_26 hv_L3_22 vcn colno0 0 NSYN W=10u L=1u
C_gp_o_0_27 gp_o_0_27 0 {Cg}
Mp_o_0_27 hv_L3_34 gp_o_0_27 colpo0 0 NSYN W=10u L=1u
Mn_o_0_27 hv_L3_34 vcn colno0 0 NSYN W=10u L=1u
C_gp_o_0_28 gp_o_0_28 0 {Cg}
Mp_o_0_28 hv_L3_8 gp_o_0_28 colpo0 0 NSYN W=10u L=1u
Mn_o_0_28 hv_L3_8 vcn colno0 0 NSYN W=10u L=1u
C_gp_o_0_29 gp_o_0_29 0 {Cg}
Mp_o_0_29 hv_L3_7 gp_o_0_29 colpo0 0 NSYN W=10u L=1u
Mn_o_0_29 hv_L3_7 vcn colno0 0 NSYN W=10u L=1u
C_gp_o_0_30 gp_o_0_30 0 {Cg}
Mp_o_0_30 hv_L3_0 gp_o_0_30 colpo0 0 NSYN W=10u L=1u
Mn_o_0_30 hv_L3_0 vcn colno0 0 NSYN W=10u L=1u
C_gp_o_0_31 gp_o_0_31 0 {Cg}
Mp_o_0_31 hv_L3_32 gp_o_0_31 colpo0 0 NSYN W=10u L=1u
Mn_o_0_31 hv_L3_32 vcn colno0 0 NSYN W=10u L=1u
C_gp_o_0_32 gp_o_0_32 0 {Cg}
Mp_o_0_32 hv_L3_2 gp_o_0_32 colpo0 0 NSYN W=10u L=1u
Mn_o_0_32 hv_L3_2 vcn colno0 0 NSYN W=10u L=1u
C_gp_o_0_33 gp_o_0_33 0 {Cg}
Mp_o_0_33 hv_L3_36 gp_o_0_33 colpo0 0 NSYN W=10u L=1u
Mn_o_0_33 hv_L3_36 vcn colno0 0 NSYN W=10u L=1u
C_gp_o_0_34 gp_o_0_34 0 {Cg}
Mp_o_0_34 hv_L3_31 gp_o_0_34 colpo0 0 NSYN W=10u L=1u
Mn_o_0_34 hv_L3_31 vcn colno0 0 NSYN W=10u L=1u
C_gp_o_0_35 gp_o_0_35 0 {Cg}
Mp_o_0_35 hv_L3_18 gp_o_0_35 colpo0 0 NSYN W=10u L=1u
Mn_o_0_35 hv_L3_18 vcn colno0 0 NSYN W=10u L=1u
C_gp_o_0_36 gp_o_0_36 0 {Cg}
Mp_o_0_36 hv_L3_6 gp_o_0_36 colpo0 0 NSYN W=10u L=1u
Mn_o_0_36 hv_L3_6 vcn colno0 0 NSYN W=10u L=1u
C_gp_o_0_37 gp_o_0_37 0 {Cg}
Mp_o_0_37 hv_L3_40 gp_o_0_37 colpo0 0 NSYN W=10u L=1u
Mn_o_0_37 hv_L3_40 vcn colno0 0 NSYN W=10u L=1u
C_gp_o_0_38 gp_o_0_38 0 {Cg}
Mp_o_0_38 hv_L3_11 gp_o_0_38 colpo0 0 NSYN W=10u L=1u
Mn_o_0_38 hv_L3_11 vcn colno0 0 NSYN W=10u L=1u
C_gp_o_0_39 gp_o_0_39 0 {Cg}
Mp_o_0_39 hv_L3_23 gp_o_0_39 colpo0 0 NSYN W=10u L=1u
Mn_o_0_39 hv_L3_23 vcn colno0 0 NSYN W=10u L=1u
C_gp_o_0_40 gp_o_0_40 0 {Cg}
Mp_o_0_40 hv_L3_41 gp_o_0_40 colpo0 0 NSYN W=10u L=1u
Mn_o_0_40 hv_L3_41 vcn colno0 0 NSYN W=10u L=1u
C_gp_o_0_41 gp_o_0_41 0 {Cg}
Mp_o_0_41 hv_L3_24 gp_o_0_41 colpo0 0 NSYN W=10u L=1u
Mn_o_0_41 hv_L3_24 vcn colno0 0 NSYN W=10u L=1u
C_gp_o_0_42 gp_o_0_42 0 {Cg}
Mp_o_0_42 hv_L3_35 gp_o_0_42 colpo0 0 NSYN W=10u L=1u
Mn_o_0_42 hv_L3_35 vcn colno0 0 NSYN W=10u L=1u
C_gp_o_0_43 gp_o_0_43 0 {Cg}
Mp_o_0_43 hv_L3_27 gp_o_0_43 colpo0 0 NSYN W=10u L=1u
Mn_o_0_43 hv_L3_27 vcn colno0 0 NSYN W=10u L=1u
C_gp_o_0_44 gp_o_0_44 0 {Cg}
Mp_o_0_44 hv_L3_13 gp_o_0_44 colpo0 0 NSYN W=10u L=1u
Mn_o_0_44 hv_L3_13 vcn colno0 0 NSYN W=10u L=1u
C_gp_o_0_45 gp_o_0_45 0 {Cg}
Mp_o_0_45 hv_L3_20 gp_o_0_45 colpo0 0 NSYN W=10u L=1u
Mn_o_0_45 hv_L3_20 vcn colno0 0 NSYN W=10u L=1u
C_gp_o_0_46 gp_o_0_46 0 {Cg}
Mp_o_0_46 hv_L3_3 gp_o_0_46 colpo0 0 NSYN W=10u L=1u
Mn_o_0_46 hv_L3_3 vcn colno0 0 NSYN W=10u L=1u
C_gp_o_0_47 gp_o_0_47 0 {Cg}
Mp_o_0_47 hv_L3_42 gp_o_0_47 colpo0 0 NSYN W=10u L=1u
Mn_o_0_47 hv_L3_42 vcn colno0 0 NSYN W=10u L=1u
C_gp_o_0_b gp_o_0_b 0 {Cg}
Mp_o_0_b bx gp_o_0_b colpo0 0 NSYN W=10u L=1u
Mn_o_0_b bx vcn colno0 0 NSYN W=10u L=1u
Msa_o0 colno0 colno0 0 0 NMIR W=20u L=1u
Msb_o0 y_0 colno0 0 0 NMIR W=20u L=1u
Msc_o0 colpo0 colpo0 0 0 NMIR W=20u L=1u
Msd_o0 dpf_o0 colpo0 0 0 NMIR W=20u L=1u
Mse_o0 dpf_o0 dpf_o0 vdd vdd PMIR W=60u L=1u
Msf_o0 y_0 dpf_o0 vdd vdd PMIR W=60u L=1u
R_o0 y_0 vrefo 7000.0
C_gp_o_1_0 gp_o_1_0 0 {Cg}
Mp_o_1_0 hv_L3_41 gp_o_1_0 colpo1 0 NSYN W=10u L=1u
Mn_o_1_0 hv_L3_41 vcn colno1 0 NSYN W=10u L=1u
C_gp_o_1_1 gp_o_1_1 0 {Cg}
Mp_o_1_1 hv_L3_2 gp_o_1_1 colpo1 0 NSYN W=10u L=1u
Mn_o_1_1 hv_L3_2 vcn colno1 0 NSYN W=10u L=1u
C_gp_o_1_2 gp_o_1_2 0 {Cg}
Mp_o_1_2 hv_L3_31 gp_o_1_2 colpo1 0 NSYN W=10u L=1u
Mn_o_1_2 hv_L3_31 vcn colno1 0 NSYN W=10u L=1u
C_gp_o_1_3 gp_o_1_3 0 {Cg}
Mp_o_1_3 hv_L3_27 gp_o_1_3 colpo1 0 NSYN W=10u L=1u
Mn_o_1_3 hv_L3_27 vcn colno1 0 NSYN W=10u L=1u
C_gp_o_1_4 gp_o_1_4 0 {Cg}
Mp_o_1_4 hv_L3_12 gp_o_1_4 colpo1 0 NSYN W=10u L=1u
Mn_o_1_4 hv_L3_12 vcn colno1 0 NSYN W=10u L=1u
C_gp_o_1_5 gp_o_1_5 0 {Cg}
Mp_o_1_5 hv_L3_15 gp_o_1_5 colpo1 0 NSYN W=10u L=1u
Mn_o_1_5 hv_L3_15 vcn colno1 0 NSYN W=10u L=1u
C_gp_o_1_6 gp_o_1_6 0 {Cg}
Mp_o_1_6 hv_L3_13 gp_o_1_6 colpo1 0 NSYN W=10u L=1u
Mn_o_1_6 hv_L3_13 vcn colno1 0 NSYN W=10u L=1u
C_gp_o_1_7 gp_o_1_7 0 {Cg}
Mp_o_1_7 hv_L3_30 gp_o_1_7 colpo1 0 NSYN W=10u L=1u
Mn_o_1_7 hv_L3_30 vcn colno1 0 NSYN W=10u L=1u
C_gp_o_1_8 gp_o_1_8 0 {Cg}
Mp_o_1_8 hv_L3_39 gp_o_1_8 colpo1 0 NSYN W=10u L=1u
Mn_o_1_8 hv_L3_39 vcn colno1 0 NSYN W=10u L=1u
C_gp_o_1_9 gp_o_1_9 0 {Cg}
Mp_o_1_9 hv_L3_7 gp_o_1_9 colpo1 0 NSYN W=10u L=1u
Mn_o_1_9 hv_L3_7 vcn colno1 0 NSYN W=10u L=1u
C_gp_o_1_10 gp_o_1_10 0 {Cg}
Mp_o_1_10 hv_L3_29 gp_o_1_10 colpo1 0 NSYN W=10u L=1u
Mn_o_1_10 hv_L3_29 vcn colno1 0 NSYN W=10u L=1u
C_gp_o_1_11 gp_o_1_11 0 {Cg}
Mp_o_1_11 hv_L3_45 gp_o_1_11 colpo1 0 NSYN W=10u L=1u
Mn_o_1_11 hv_L3_45 vcn colno1 0 NSYN W=10u L=1u
C_gp_o_1_12 gp_o_1_12 0 {Cg}
Mp_o_1_12 hv_L3_36 gp_o_1_12 colpo1 0 NSYN W=10u L=1u
Mn_o_1_12 hv_L3_36 vcn colno1 0 NSYN W=10u L=1u
C_gp_o_1_13 gp_o_1_13 0 {Cg}
Mp_o_1_13 hv_L3_25 gp_o_1_13 colpo1 0 NSYN W=10u L=1u
Mn_o_1_13 hv_L3_25 vcn colno1 0 NSYN W=10u L=1u
C_gp_o_1_14 gp_o_1_14 0 {Cg}
Mp_o_1_14 hv_L3_33 gp_o_1_14 colpo1 0 NSYN W=10u L=1u
Mn_o_1_14 hv_L3_33 vcn colno1 0 NSYN W=10u L=1u
C_gp_o_1_15 gp_o_1_15 0 {Cg}
Mp_o_1_15 hv_L3_37 gp_o_1_15 colpo1 0 NSYN W=10u L=1u
Mn_o_1_15 hv_L3_37 vcn colno1 0 NSYN W=10u L=1u
C_gp_o_1_16 gp_o_1_16 0 {Cg}
Mp_o_1_16 hv_L3_34 gp_o_1_16 colpo1 0 NSYN W=10u L=1u
Mn_o_1_16 hv_L3_34 vcn colno1 0 NSYN W=10u L=1u
C_gp_o_1_17 gp_o_1_17 0 {Cg}
Mp_o_1_17 hv_L3_38 gp_o_1_17 colpo1 0 NSYN W=10u L=1u
Mn_o_1_17 hv_L3_38 vcn colno1 0 NSYN W=10u L=1u
C_gp_o_1_18 gp_o_1_18 0 {Cg}
Mp_o_1_18 hv_L3_21 gp_o_1_18 colpo1 0 NSYN W=10u L=1u
Mn_o_1_18 hv_L3_21 vcn colno1 0 NSYN W=10u L=1u
C_gp_o_1_19 gp_o_1_19 0 {Cg}
Mp_o_1_19 hv_L3_5 gp_o_1_19 colpo1 0 NSYN W=10u L=1u
Mn_o_1_19 hv_L3_5 vcn colno1 0 NSYN W=10u L=1u
C_gp_o_1_20 gp_o_1_20 0 {Cg}
Mp_o_1_20 hv_L3_8 gp_o_1_20 colpo1 0 NSYN W=10u L=1u
Mn_o_1_20 hv_L3_8 vcn colno1 0 NSYN W=10u L=1u
C_gp_o_1_21 gp_o_1_21 0 {Cg}
Mp_o_1_21 hv_L3_22 gp_o_1_21 colpo1 0 NSYN W=10u L=1u
Mn_o_1_21 hv_L3_22 vcn colno1 0 NSYN W=10u L=1u
C_gp_o_1_22 gp_o_1_22 0 {Cg}
Mp_o_1_22 hv_L3_19 gp_o_1_22 colpo1 0 NSYN W=10u L=1u
Mn_o_1_22 hv_L3_19 vcn colno1 0 NSYN W=10u L=1u
C_gp_o_1_23 gp_o_1_23 0 {Cg}
Mp_o_1_23 hv_L3_6 gp_o_1_23 colpo1 0 NSYN W=10u L=1u
Mn_o_1_23 hv_L3_6 vcn colno1 0 NSYN W=10u L=1u
C_gp_o_1_24 gp_o_1_24 0 {Cg}
Mp_o_1_24 hv_L3_46 gp_o_1_24 colpo1 0 NSYN W=10u L=1u
Mn_o_1_24 hv_L3_46 vcn colno1 0 NSYN W=10u L=1u
C_gp_o_1_25 gp_o_1_25 0 {Cg}
Mp_o_1_25 hv_L3_32 gp_o_1_25 colpo1 0 NSYN W=10u L=1u
Mn_o_1_25 hv_L3_32 vcn colno1 0 NSYN W=10u L=1u
C_gp_o_1_26 gp_o_1_26 0 {Cg}
Mp_o_1_26 hv_L3_44 gp_o_1_26 colpo1 0 NSYN W=10u L=1u
Mn_o_1_26 hv_L3_44 vcn colno1 0 NSYN W=10u L=1u
C_gp_o_1_27 gp_o_1_27 0 {Cg}
Mp_o_1_27 hv_L3_1 gp_o_1_27 colpo1 0 NSYN W=10u L=1u
Mn_o_1_27 hv_L3_1 vcn colno1 0 NSYN W=10u L=1u
C_gp_o_1_28 gp_o_1_28 0 {Cg}
Mp_o_1_28 hv_L3_24 gp_o_1_28 colpo1 0 NSYN W=10u L=1u
Mn_o_1_28 hv_L3_24 vcn colno1 0 NSYN W=10u L=1u
C_gp_o_1_29 gp_o_1_29 0 {Cg}
Mp_o_1_29 hv_L3_4 gp_o_1_29 colpo1 0 NSYN W=10u L=1u
Mn_o_1_29 hv_L3_4 vcn colno1 0 NSYN W=10u L=1u
C_gp_o_1_30 gp_o_1_30 0 {Cg}
Mp_o_1_30 hv_L3_9 gp_o_1_30 colpo1 0 NSYN W=10u L=1u
Mn_o_1_30 hv_L3_9 vcn colno1 0 NSYN W=10u L=1u
C_gp_o_1_31 gp_o_1_31 0 {Cg}
Mp_o_1_31 hv_L3_47 gp_o_1_31 colpo1 0 NSYN W=10u L=1u
Mn_o_1_31 hv_L3_47 vcn colno1 0 NSYN W=10u L=1u
C_gp_o_1_32 gp_o_1_32 0 {Cg}
Mp_o_1_32 hv_L3_11 gp_o_1_32 colpo1 0 NSYN W=10u L=1u
Mn_o_1_32 hv_L3_11 vcn colno1 0 NSYN W=10u L=1u
C_gp_o_1_33 gp_o_1_33 0 {Cg}
Mp_o_1_33 hv_L3_23 gp_o_1_33 colpo1 0 NSYN W=10u L=1u
Mn_o_1_33 hv_L3_23 vcn colno1 0 NSYN W=10u L=1u
C_gp_o_1_34 gp_o_1_34 0 {Cg}
Mp_o_1_34 hv_L3_17 gp_o_1_34 colpo1 0 NSYN W=10u L=1u
Mn_o_1_34 hv_L3_17 vcn colno1 0 NSYN W=10u L=1u
C_gp_o_1_35 gp_o_1_35 0 {Cg}
Mp_o_1_35 hv_L3_14 gp_o_1_35 colpo1 0 NSYN W=10u L=1u
Mn_o_1_35 hv_L3_14 vcn colno1 0 NSYN W=10u L=1u
C_gp_o_1_36 gp_o_1_36 0 {Cg}
Mp_o_1_36 hv_L3_3 gp_o_1_36 colpo1 0 NSYN W=10u L=1u
Mn_o_1_36 hv_L3_3 vcn colno1 0 NSYN W=10u L=1u
C_gp_o_1_37 gp_o_1_37 0 {Cg}
Mp_o_1_37 hv_L3_40 gp_o_1_37 colpo1 0 NSYN W=10u L=1u
Mn_o_1_37 hv_L3_40 vcn colno1 0 NSYN W=10u L=1u
C_gp_o_1_38 gp_o_1_38 0 {Cg}
Mp_o_1_38 hv_L3_16 gp_o_1_38 colpo1 0 NSYN W=10u L=1u
Mn_o_1_38 hv_L3_16 vcn colno1 0 NSYN W=10u L=1u
C_gp_o_1_39 gp_o_1_39 0 {Cg}
Mp_o_1_39 hv_L3_28 gp_o_1_39 colpo1 0 NSYN W=10u L=1u
Mn_o_1_39 hv_L3_28 vcn colno1 0 NSYN W=10u L=1u
C_gp_o_1_40 gp_o_1_40 0 {Cg}
Mp_o_1_40 hv_L3_20 gp_o_1_40 colpo1 0 NSYN W=10u L=1u
Mn_o_1_40 hv_L3_20 vcn colno1 0 NSYN W=10u L=1u
C_gp_o_1_41 gp_o_1_41 0 {Cg}
Mp_o_1_41 hv_L3_35 gp_o_1_41 colpo1 0 NSYN W=10u L=1u
Mn_o_1_41 hv_L3_35 vcn colno1 0 NSYN W=10u L=1u
C_gp_o_1_42 gp_o_1_42 0 {Cg}
Mp_o_1_42 hv_L3_42 gp_o_1_42 colpo1 0 NSYN W=10u L=1u
Mn_o_1_42 hv_L3_42 vcn colno1 0 NSYN W=10u L=1u
C_gp_o_1_43 gp_o_1_43 0 {Cg}
Mp_o_1_43 hv_L3_43 gp_o_1_43 colpo1 0 NSYN W=10u L=1u
Mn_o_1_43 hv_L3_43 vcn colno1 0 NSYN W=10u L=1u
C_gp_o_1_44 gp_o_1_44 0 {Cg}
Mp_o_1_44 hv_L3_10 gp_o_1_44 colpo1 0 NSYN W=10u L=1u
Mn_o_1_44 hv_L3_10 vcn colno1 0 NSYN W=10u L=1u
C_gp_o_1_45 gp_o_1_45 0 {Cg}
Mp_o_1_45 hv_L3_18 gp_o_1_45 colpo1 0 NSYN W=10u L=1u
Mn_o_1_45 hv_L3_18 vcn colno1 0 NSYN W=10u L=1u
C_gp_o_1_46 gp_o_1_46 0 {Cg}
Mp_o_1_46 hv_L3_0 gp_o_1_46 colpo1 0 NSYN W=10u L=1u
Mn_o_1_46 hv_L3_0 vcn colno1 0 NSYN W=10u L=1u
C_gp_o_1_47 gp_o_1_47 0 {Cg}
Mp_o_1_47 hv_L3_26 gp_o_1_47 colpo1 0 NSYN W=10u L=1u
Mn_o_1_47 hv_L3_26 vcn colno1 0 NSYN W=10u L=1u
C_gp_o_1_b gp_o_1_b 0 {Cg}
Mp_o_1_b bx gp_o_1_b colpo1 0 NSYN W=10u L=1u
Mn_o_1_b bx vcn colno1 0 NSYN W=10u L=1u
Msa_o1 colno1 colno1 0 0 NMIR W=20u L=1u
Msb_o1 y_1 colno1 0 0 NMIR W=20u L=1u
Msc_o1 colpo1 colpo1 0 0 NMIR W=20u L=1u
Msd_o1 dpf_o1 colpo1 0 0 NMIR W=20u L=1u
Mse_o1 dpf_o1 dpf_o1 vdd vdd PMIR W=60u L=1u
Msf_o1 y_1 dpf_o1 vdd vdd PMIR W=60u L=1u
R_o1 y_1 vrefo 7000.0
Rocm_0 d2e_0 d2ebar 10000.0
Rocm_1 d2e_1 d2ebar 10000.0
Cocm d2ebar 0 50f
Msf2_0 d2e_0 dpf_o0 vdd vdd PMIR W=60u L=1u
Msb2_0 d2e_0 colno0 0 0 NMIR W=20u L=1u
Moff_0 d2e_0 boff vdd vdd PMIR W=10u L=1u
Mtge_0 d2e_0 tg0 0 0 NMIR W=10u L=1u
Rde_0 d2e_0 vrefd 7000.0
Mqa_0 d2en_ps_0 colno0 0 0 NMIR W=20u L=1u
Mqb_0 d2en_ps_0 tg0 0 0 NMIR W=10u L=1u
Mpd_0 d2en_ps_0 d2en_ps_0 vdd vdd PMIR W=60u L=1u
Mpm_0 d2e_n_0 d2en_ps_0 vdd vdd PMIR W=60u L=1u
Mqc_0 d2en_ns_0 dpf_o0 vdd vdd PMIR W=60u L=1u
Mqd_0 d2en_ns_0 boff vdd vdd PMIR W=10u L=1u
Mnd_0 d2en_ns_0 d2en_ns_0 0 0 NMIR W=20u L=1u
Mnm_0 d2e_n_0 d2en_ns_0 0 0 NMIR W=20u L=1u
Rden_0 d2e_n_0 vrefd 7000.0
Mbep_0 vdd d2e_0 d2e_pb_0 0 NSYN W=200u L=1u
Rbep_0 d2e_pb_0 0 20e3
Mben_0 vdd d2e_n_0 d2e_nb_0 0 NSYN W=200u L=1u
Rben_0 d2e_nb_0 0 20e3
Msf2_1 d2e_1 dpf_o1 vdd vdd PMIR W=60u L=1u
Msb2_1 d2e_1 colno1 0 0 NMIR W=20u L=1u
Moff_1 d2e_1 boff vdd vdd PMIR W=10u L=1u
Mtge_1 d2e_1 tg1 0 0 NMIR W=10u L=1u
Rde_1 d2e_1 vrefd 7000.0
Mqa_1 d2en_ps_1 colno1 0 0 NMIR W=20u L=1u
Mqb_1 d2en_ps_1 tg1 0 0 NMIR W=10u L=1u
Mpd_1 d2en_ps_1 d2en_ps_1 vdd vdd PMIR W=60u L=1u
Mpm_1 d2e_n_1 d2en_ps_1 vdd vdd PMIR W=60u L=1u
Mqc_1 d2en_ns_1 dpf_o1 vdd vdd PMIR W=60u L=1u
Mqd_1 d2en_ns_1 boff vdd vdd PMIR W=10u L=1u
Mnd_1 d2en_ns_1 d2en_ns_1 0 0 NMIR W=20u L=1u
Mnm_1 d2e_n_1 d2en_ns_1 0 0 NMIR W=20u L=1u
Rden_1 d2e_n_1 vrefd 7000.0
Mbep_1 vdd d2e_1 d2e_pb_1 0 NSYN W=200u L=1u
Rbep_1 d2e_pb_1 0 20e3
Mben_1 vdd d2e_n_1 d2e_nb_1 0 NSYN W=200u L=1u
Rben_1 d2e_nb_1 0 20e3
Mt_oU_0_0 ts_oU_0_0 hv_L3_46 0 0 NMIR W=20.0u L=1u
Mo1_oU_0_0 da_oU_0_0 d2ebar ts_oU_0_0 0 NMIR W=20u L=1u
Mo2_oU_0_0 gp_o_0_0 d2e_0 ts_oU_0_0 0 NMIR W=20u L=1u
Mo3_oU_0_0 da_oU_0_0 da_oU_0_0 vdd vdd PMIR W=60u L=1u
Mo4_oU_0_0 gp_o_0_0 da_oU_0_0 vdd vdd PMIR W=60u L=1u
Mt_oU_0_1 ts_oU_0_1 hv_L3_30 0 0 NMIR W=20.0u L=1u
Mo1_oU_0_1 da_oU_0_1 d2ebar ts_oU_0_1 0 NMIR W=20u L=1u
Mo2_oU_0_1 gp_o_0_1 d2e_0 ts_oU_0_1 0 NMIR W=20u L=1u
Mo3_oU_0_1 da_oU_0_1 da_oU_0_1 vdd vdd PMIR W=60u L=1u
Mo4_oU_0_1 gp_o_0_1 da_oU_0_1 vdd vdd PMIR W=60u L=1u
Mt_oU_0_2 ts_oU_0_2 hv_L3_5 0 0 NMIR W=20.0u L=1u
Mo1_oU_0_2 da_oU_0_2 d2ebar ts_oU_0_2 0 NMIR W=20u L=1u
Mo2_oU_0_2 gp_o_0_2 d2e_0 ts_oU_0_2 0 NMIR W=20u L=1u
Mo3_oU_0_2 da_oU_0_2 da_oU_0_2 vdd vdd PMIR W=60u L=1u
Mo4_oU_0_2 gp_o_0_2 da_oU_0_2 vdd vdd PMIR W=60u L=1u
Mt_oU_0_3 ts_oU_0_3 hv_L3_45 0 0 NMIR W=20.0u L=1u
Mo1_oU_0_3 da_oU_0_3 d2ebar ts_oU_0_3 0 NMIR W=20u L=1u
Mo2_oU_0_3 gp_o_0_3 d2e_0 ts_oU_0_3 0 NMIR W=20u L=1u
Mo3_oU_0_3 da_oU_0_3 da_oU_0_3 vdd vdd PMIR W=60u L=1u
Mo4_oU_0_3 gp_o_0_3 da_oU_0_3 vdd vdd PMIR W=60u L=1u
Mt_oU_0_4 ts_oU_0_4 hv_L3_1 0 0 NMIR W=20.0u L=1u
Mo1_oU_0_4 da_oU_0_4 d2ebar ts_oU_0_4 0 NMIR W=20u L=1u
Mo2_oU_0_4 gp_o_0_4 d2e_0 ts_oU_0_4 0 NMIR W=20u L=1u
Mo3_oU_0_4 da_oU_0_4 da_oU_0_4 vdd vdd PMIR W=60u L=1u
Mo4_oU_0_4 gp_o_0_4 da_oU_0_4 vdd vdd PMIR W=60u L=1u
Mt_oU_0_5 ts_oU_0_5 hv_L3_10 0 0 NMIR W=20.0u L=1u
Mo1_oU_0_5 da_oU_0_5 d2ebar ts_oU_0_5 0 NMIR W=20u L=1u
Mo2_oU_0_5 gp_o_0_5 d2e_0 ts_oU_0_5 0 NMIR W=20u L=1u
Mo3_oU_0_5 da_oU_0_5 da_oU_0_5 vdd vdd PMIR W=60u L=1u
Mo4_oU_0_5 gp_o_0_5 da_oU_0_5 vdd vdd PMIR W=60u L=1u
Mt_oU_0_6 ts_oU_0_6 hv_L3_28 0 0 NMIR W=20.0u L=1u
Mo1_oU_0_6 da_oU_0_6 d2ebar ts_oU_0_6 0 NMIR W=20u L=1u
Mo2_oU_0_6 gp_o_0_6 d2e_0 ts_oU_0_6 0 NMIR W=20u L=1u
Mo3_oU_0_6 da_oU_0_6 da_oU_0_6 vdd vdd PMIR W=60u L=1u
Mo4_oU_0_6 gp_o_0_6 da_oU_0_6 vdd vdd PMIR W=60u L=1u
Mt_oU_0_7 ts_oU_0_7 hv_L3_21 0 0 NMIR W=20.0u L=1u
Mo1_oU_0_7 da_oU_0_7 d2ebar ts_oU_0_7 0 NMIR W=20u L=1u
Mo2_oU_0_7 gp_o_0_7 d2e_0 ts_oU_0_7 0 NMIR W=20u L=1u
Mo3_oU_0_7 da_oU_0_7 da_oU_0_7 vdd vdd PMIR W=60u L=1u
Mo4_oU_0_7 gp_o_0_7 da_oU_0_7 vdd vdd PMIR W=60u L=1u
Mt_oU_0_8 ts_oU_0_8 hv_L3_17 0 0 NMIR W=20.0u L=1u
Mo1_oU_0_8 da_oU_0_8 d2ebar ts_oU_0_8 0 NMIR W=20u L=1u
Mo2_oU_0_8 gp_o_0_8 d2e_0 ts_oU_0_8 0 NMIR W=20u L=1u
Mo3_oU_0_8 da_oU_0_8 da_oU_0_8 vdd vdd PMIR W=60u L=1u
Mo4_oU_0_8 gp_o_0_8 da_oU_0_8 vdd vdd PMIR W=60u L=1u
Mt_oU_0_9 ts_oU_0_9 hv_L3_19 0 0 NMIR W=20.0u L=1u
Mo1_oU_0_9 da_oU_0_9 d2ebar ts_oU_0_9 0 NMIR W=20u L=1u
Mo2_oU_0_9 gp_o_0_9 d2e_0 ts_oU_0_9 0 NMIR W=20u L=1u
Mo3_oU_0_9 da_oU_0_9 da_oU_0_9 vdd vdd PMIR W=60u L=1u
Mo4_oU_0_9 gp_o_0_9 da_oU_0_9 vdd vdd PMIR W=60u L=1u
Mt_oU_0_10 ts_oU_0_10 hv_L3_16 0 0 NMIR W=20.0u L=1u
Mo1_oU_0_10 da_oU_0_10 d2ebar ts_oU_0_10 0 NMIR W=20u L=1u
Mo2_oU_0_10 gp_o_0_10 d2e_0 ts_oU_0_10 0 NMIR W=20u L=1u
Mo3_oU_0_10 da_oU_0_10 da_oU_0_10 vdd vdd PMIR W=60u L=1u
Mo4_oU_0_10 gp_o_0_10 da_oU_0_10 vdd vdd PMIR W=60u L=1u
Mt_oU_0_11 ts_oU_0_11 hv_L3_25 0 0 NMIR W=20.0u L=1u
Mo1_oU_0_11 da_oU_0_11 d2ebar ts_oU_0_11 0 NMIR W=20u L=1u
Mo2_oU_0_11 gp_o_0_11 d2e_0 ts_oU_0_11 0 NMIR W=20u L=1u
Mo3_oU_0_11 da_oU_0_11 da_oU_0_11 vdd vdd PMIR W=60u L=1u
Mo4_oU_0_11 gp_o_0_11 da_oU_0_11 vdd vdd PMIR W=60u L=1u
Mt_oU_0_12 ts_oU_0_12 hv_L3_47 0 0 NMIR W=20.0u L=1u
Mo1_oU_0_12 da_oU_0_12 d2ebar ts_oU_0_12 0 NMIR W=20u L=1u
Mo2_oU_0_12 gp_o_0_12 d2e_0 ts_oU_0_12 0 NMIR W=20u L=1u
Mo3_oU_0_12 da_oU_0_12 da_oU_0_12 vdd vdd PMIR W=60u L=1u
Mo4_oU_0_12 gp_o_0_12 da_oU_0_12 vdd vdd PMIR W=60u L=1u
Mt_oU_0_13 ts_oU_0_13 hv_L3_4 0 0 NMIR W=20.0u L=1u
Mo1_oU_0_13 da_oU_0_13 d2ebar ts_oU_0_13 0 NMIR W=20u L=1u
Mo2_oU_0_13 gp_o_0_13 d2e_0 ts_oU_0_13 0 NMIR W=20u L=1u
Mo3_oU_0_13 da_oU_0_13 da_oU_0_13 vdd vdd PMIR W=60u L=1u
Mo4_oU_0_13 gp_o_0_13 da_oU_0_13 vdd vdd PMIR W=60u L=1u
Mt_oU_0_14 ts_oU_0_14 hv_L3_38 0 0 NMIR W=20.0u L=1u
Mo1_oU_0_14 da_oU_0_14 d2ebar ts_oU_0_14 0 NMIR W=20u L=1u
Mo2_oU_0_14 gp_o_0_14 d2e_0 ts_oU_0_14 0 NMIR W=20u L=1u
Mo3_oU_0_14 da_oU_0_14 da_oU_0_14 vdd vdd PMIR W=60u L=1u
Mo4_oU_0_14 gp_o_0_14 da_oU_0_14 vdd vdd PMIR W=60u L=1u
Mt_oU_0_15 ts_oU_0_15 hv_L3_15 0 0 NMIR W=20.0u L=1u
Mo1_oU_0_15 da_oU_0_15 d2ebar ts_oU_0_15 0 NMIR W=20u L=1u
Mo2_oU_0_15 gp_o_0_15 d2e_0 ts_oU_0_15 0 NMIR W=20u L=1u
Mo3_oU_0_15 da_oU_0_15 da_oU_0_15 vdd vdd PMIR W=60u L=1u
Mo4_oU_0_15 gp_o_0_15 da_oU_0_15 vdd vdd PMIR W=60u L=1u
Mt_oU_0_16 ts_oU_0_16 hv_L3_37 0 0 NMIR W=20.0u L=1u
Mo1_oU_0_16 da_oU_0_16 d2ebar ts_oU_0_16 0 NMIR W=20u L=1u
Mo2_oU_0_16 gp_o_0_16 d2e_0 ts_oU_0_16 0 NMIR W=20u L=1u
Mo3_oU_0_16 da_oU_0_16 da_oU_0_16 vdd vdd PMIR W=60u L=1u
Mo4_oU_0_16 gp_o_0_16 da_oU_0_16 vdd vdd PMIR W=60u L=1u
Mt_oU_0_17 ts_oU_0_17 hv_L3_14 0 0 NMIR W=20.0u L=1u
Mo1_oU_0_17 da_oU_0_17 d2ebar ts_oU_0_17 0 NMIR W=20u L=1u
Mo2_oU_0_17 gp_o_0_17 d2e_0 ts_oU_0_17 0 NMIR W=20u L=1u
Mo3_oU_0_17 da_oU_0_17 da_oU_0_17 vdd vdd PMIR W=60u L=1u
Mo4_oU_0_17 gp_o_0_17 da_oU_0_17 vdd vdd PMIR W=60u L=1u
Mt_oU_0_18 ts_oU_0_18 hv_L3_26 0 0 NMIR W=20.0u L=1u
Mo1_oU_0_18 da_oU_0_18 d2ebar ts_oU_0_18 0 NMIR W=20u L=1u
Mo2_oU_0_18 gp_o_0_18 d2e_0 ts_oU_0_18 0 NMIR W=20u L=1u
Mo3_oU_0_18 da_oU_0_18 da_oU_0_18 vdd vdd PMIR W=60u L=1u
Mo4_oU_0_18 gp_o_0_18 da_oU_0_18 vdd vdd PMIR W=60u L=1u
Mt_oU_0_19 ts_oU_0_19 hv_L3_39 0 0 NMIR W=20.0u L=1u
Mo1_oU_0_19 da_oU_0_19 d2ebar ts_oU_0_19 0 NMIR W=20u L=1u
Mo2_oU_0_19 gp_o_0_19 d2e_0 ts_oU_0_19 0 NMIR W=20u L=1u
Mo3_oU_0_19 da_oU_0_19 da_oU_0_19 vdd vdd PMIR W=60u L=1u
Mo4_oU_0_19 gp_o_0_19 da_oU_0_19 vdd vdd PMIR W=60u L=1u
Mt_oU_0_20 ts_oU_0_20 hv_L3_9 0 0 NMIR W=20.0u L=1u
Mo1_oU_0_20 da_oU_0_20 d2ebar ts_oU_0_20 0 NMIR W=20u L=1u
Mo2_oU_0_20 gp_o_0_20 d2e_0 ts_oU_0_20 0 NMIR W=20u L=1u
Mo3_oU_0_20 da_oU_0_20 da_oU_0_20 vdd vdd PMIR W=60u L=1u
Mo4_oU_0_20 gp_o_0_20 da_oU_0_20 vdd vdd PMIR W=60u L=1u
Mt_oU_0_21 ts_oU_0_21 hv_L3_44 0 0 NMIR W=20.0u L=1u
Mo1_oU_0_21 da_oU_0_21 d2ebar ts_oU_0_21 0 NMIR W=20u L=1u
Mo2_oU_0_21 gp_o_0_21 d2e_0 ts_oU_0_21 0 NMIR W=20u L=1u
Mo3_oU_0_21 da_oU_0_21 da_oU_0_21 vdd vdd PMIR W=60u L=1u
Mo4_oU_0_21 gp_o_0_21 da_oU_0_21 vdd vdd PMIR W=60u L=1u
Mt_oU_0_22 ts_oU_0_22 hv_L3_12 0 0 NMIR W=20.0u L=1u
Mo1_oU_0_22 da_oU_0_22 d2ebar ts_oU_0_22 0 NMIR W=20u L=1u
Mo2_oU_0_22 gp_o_0_22 d2e_0 ts_oU_0_22 0 NMIR W=20u L=1u
Mo3_oU_0_22 da_oU_0_22 da_oU_0_22 vdd vdd PMIR W=60u L=1u
Mo4_oU_0_22 gp_o_0_22 da_oU_0_22 vdd vdd PMIR W=60u L=1u
Mt_oU_0_23 ts_oU_0_23 hv_L3_33 0 0 NMIR W=20.0u L=1u
Mo1_oU_0_23 da_oU_0_23 d2ebar ts_oU_0_23 0 NMIR W=20u L=1u
Mo2_oU_0_23 gp_o_0_23 d2e_0 ts_oU_0_23 0 NMIR W=20u L=1u
Mo3_oU_0_23 da_oU_0_23 da_oU_0_23 vdd vdd PMIR W=60u L=1u
Mo4_oU_0_23 gp_o_0_23 da_oU_0_23 vdd vdd PMIR W=60u L=1u
Mt_oU_0_24 ts_oU_0_24 hv_L3_29 0 0 NMIR W=20.0u L=1u
Mo1_oU_0_24 da_oU_0_24 d2ebar ts_oU_0_24 0 NMIR W=20u L=1u
Mo2_oU_0_24 gp_o_0_24 d2e_0 ts_oU_0_24 0 NMIR W=20u L=1u
Mo3_oU_0_24 da_oU_0_24 da_oU_0_24 vdd vdd PMIR W=60u L=1u
Mo4_oU_0_24 gp_o_0_24 da_oU_0_24 vdd vdd PMIR W=60u L=1u
Mt_oU_0_25 ts_oU_0_25 hv_L3_43 0 0 NMIR W=20.0u L=1u
Mo1_oU_0_25 da_oU_0_25 d2ebar ts_oU_0_25 0 NMIR W=20u L=1u
Mo2_oU_0_25 gp_o_0_25 d2e_0 ts_oU_0_25 0 NMIR W=20u L=1u
Mo3_oU_0_25 da_oU_0_25 da_oU_0_25 vdd vdd PMIR W=60u L=1u
Mo4_oU_0_25 gp_o_0_25 da_oU_0_25 vdd vdd PMIR W=60u L=1u
Mt_oU_0_26 ts_oU_0_26 hv_L3_22 0 0 NMIR W=20.0u L=1u
Mo1_oU_0_26 da_oU_0_26 d2ebar ts_oU_0_26 0 NMIR W=20u L=1u
Mo2_oU_0_26 gp_o_0_26 d2e_0 ts_oU_0_26 0 NMIR W=20u L=1u
Mo3_oU_0_26 da_oU_0_26 da_oU_0_26 vdd vdd PMIR W=60u L=1u
Mo4_oU_0_26 gp_o_0_26 da_oU_0_26 vdd vdd PMIR W=60u L=1u
Mt_oU_0_27 ts_oU_0_27 hv_L3_34 0 0 NMIR W=20.0u L=1u
Mo1_oU_0_27 da_oU_0_27 d2ebar ts_oU_0_27 0 NMIR W=20u L=1u
Mo2_oU_0_27 gp_o_0_27 d2e_0 ts_oU_0_27 0 NMIR W=20u L=1u
Mo3_oU_0_27 da_oU_0_27 da_oU_0_27 vdd vdd PMIR W=60u L=1u
Mo4_oU_0_27 gp_o_0_27 da_oU_0_27 vdd vdd PMIR W=60u L=1u
Mt_oU_0_28 ts_oU_0_28 hv_L3_8 0 0 NMIR W=20.0u L=1u
Mo1_oU_0_28 da_oU_0_28 d2ebar ts_oU_0_28 0 NMIR W=20u L=1u
Mo2_oU_0_28 gp_o_0_28 d2e_0 ts_oU_0_28 0 NMIR W=20u L=1u
Mo3_oU_0_28 da_oU_0_28 da_oU_0_28 vdd vdd PMIR W=60u L=1u
Mo4_oU_0_28 gp_o_0_28 da_oU_0_28 vdd vdd PMIR W=60u L=1u
Mt_oU_0_29 ts_oU_0_29 hv_L3_7 0 0 NMIR W=20.0u L=1u
Mo1_oU_0_29 da_oU_0_29 d2ebar ts_oU_0_29 0 NMIR W=20u L=1u
Mo2_oU_0_29 gp_o_0_29 d2e_0 ts_oU_0_29 0 NMIR W=20u L=1u
Mo3_oU_0_29 da_oU_0_29 da_oU_0_29 vdd vdd PMIR W=60u L=1u
Mo4_oU_0_29 gp_o_0_29 da_oU_0_29 vdd vdd PMIR W=60u L=1u
Mt_oU_0_30 ts_oU_0_30 hv_L3_0 0 0 NMIR W=20.0u L=1u
Mo1_oU_0_30 da_oU_0_30 d2ebar ts_oU_0_30 0 NMIR W=20u L=1u
Mo2_oU_0_30 gp_o_0_30 d2e_0 ts_oU_0_30 0 NMIR W=20u L=1u
Mo3_oU_0_30 da_oU_0_30 da_oU_0_30 vdd vdd PMIR W=60u L=1u
Mo4_oU_0_30 gp_o_0_30 da_oU_0_30 vdd vdd PMIR W=60u L=1u
Mt_oU_0_31 ts_oU_0_31 hv_L3_32 0 0 NMIR W=20.0u L=1u
Mo1_oU_0_31 da_oU_0_31 d2ebar ts_oU_0_31 0 NMIR W=20u L=1u
Mo2_oU_0_31 gp_o_0_31 d2e_0 ts_oU_0_31 0 NMIR W=20u L=1u
Mo3_oU_0_31 da_oU_0_31 da_oU_0_31 vdd vdd PMIR W=60u L=1u
Mo4_oU_0_31 gp_o_0_31 da_oU_0_31 vdd vdd PMIR W=60u L=1u
Mt_oU_0_32 ts_oU_0_32 hv_L3_2 0 0 NMIR W=20.0u L=1u
Mo1_oU_0_32 da_oU_0_32 d2ebar ts_oU_0_32 0 NMIR W=20u L=1u
Mo2_oU_0_32 gp_o_0_32 d2e_0 ts_oU_0_32 0 NMIR W=20u L=1u
Mo3_oU_0_32 da_oU_0_32 da_oU_0_32 vdd vdd PMIR W=60u L=1u
Mo4_oU_0_32 gp_o_0_32 da_oU_0_32 vdd vdd PMIR W=60u L=1u
Mt_oU_0_33 ts_oU_0_33 hv_L3_36 0 0 NMIR W=20.0u L=1u
Mo1_oU_0_33 da_oU_0_33 d2ebar ts_oU_0_33 0 NMIR W=20u L=1u
Mo2_oU_0_33 gp_o_0_33 d2e_0 ts_oU_0_33 0 NMIR W=20u L=1u
Mo3_oU_0_33 da_oU_0_33 da_oU_0_33 vdd vdd PMIR W=60u L=1u
Mo4_oU_0_33 gp_o_0_33 da_oU_0_33 vdd vdd PMIR W=60u L=1u
Mt_oU_0_34 ts_oU_0_34 hv_L3_31 0 0 NMIR W=20.0u L=1u
Mo1_oU_0_34 da_oU_0_34 d2ebar ts_oU_0_34 0 NMIR W=20u L=1u
Mo2_oU_0_34 gp_o_0_34 d2e_0 ts_oU_0_34 0 NMIR W=20u L=1u
Mo3_oU_0_34 da_oU_0_34 da_oU_0_34 vdd vdd PMIR W=60u L=1u
Mo4_oU_0_34 gp_o_0_34 da_oU_0_34 vdd vdd PMIR W=60u L=1u
Mt_oU_0_35 ts_oU_0_35 hv_L3_18 0 0 NMIR W=20.0u L=1u
Mo1_oU_0_35 da_oU_0_35 d2ebar ts_oU_0_35 0 NMIR W=20u L=1u
Mo2_oU_0_35 gp_o_0_35 d2e_0 ts_oU_0_35 0 NMIR W=20u L=1u
Mo3_oU_0_35 da_oU_0_35 da_oU_0_35 vdd vdd PMIR W=60u L=1u
Mo4_oU_0_35 gp_o_0_35 da_oU_0_35 vdd vdd PMIR W=60u L=1u
Mt_oU_0_36 ts_oU_0_36 hv_L3_6 0 0 NMIR W=20.0u L=1u
Mo1_oU_0_36 da_oU_0_36 d2ebar ts_oU_0_36 0 NMIR W=20u L=1u
Mo2_oU_0_36 gp_o_0_36 d2e_0 ts_oU_0_36 0 NMIR W=20u L=1u
Mo3_oU_0_36 da_oU_0_36 da_oU_0_36 vdd vdd PMIR W=60u L=1u
Mo4_oU_0_36 gp_o_0_36 da_oU_0_36 vdd vdd PMIR W=60u L=1u
Mt_oU_0_37 ts_oU_0_37 hv_L3_40 0 0 NMIR W=20.0u L=1u
Mo1_oU_0_37 da_oU_0_37 d2ebar ts_oU_0_37 0 NMIR W=20u L=1u
Mo2_oU_0_37 gp_o_0_37 d2e_0 ts_oU_0_37 0 NMIR W=20u L=1u
Mo3_oU_0_37 da_oU_0_37 da_oU_0_37 vdd vdd PMIR W=60u L=1u
Mo4_oU_0_37 gp_o_0_37 da_oU_0_37 vdd vdd PMIR W=60u L=1u
Mt_oU_0_38 ts_oU_0_38 hv_L3_11 0 0 NMIR W=20.0u L=1u
Mo1_oU_0_38 da_oU_0_38 d2ebar ts_oU_0_38 0 NMIR W=20u L=1u
Mo2_oU_0_38 gp_o_0_38 d2e_0 ts_oU_0_38 0 NMIR W=20u L=1u
Mo3_oU_0_38 da_oU_0_38 da_oU_0_38 vdd vdd PMIR W=60u L=1u
Mo4_oU_0_38 gp_o_0_38 da_oU_0_38 vdd vdd PMIR W=60u L=1u
Mt_oU_0_39 ts_oU_0_39 hv_L3_23 0 0 NMIR W=20.0u L=1u
Mo1_oU_0_39 da_oU_0_39 d2ebar ts_oU_0_39 0 NMIR W=20u L=1u
Mo2_oU_0_39 gp_o_0_39 d2e_0 ts_oU_0_39 0 NMIR W=20u L=1u
Mo3_oU_0_39 da_oU_0_39 da_oU_0_39 vdd vdd PMIR W=60u L=1u
Mo4_oU_0_39 gp_o_0_39 da_oU_0_39 vdd vdd PMIR W=60u L=1u
Mt_oU_0_40 ts_oU_0_40 hv_L3_41 0 0 NMIR W=20.0u L=1u
Mo1_oU_0_40 da_oU_0_40 d2ebar ts_oU_0_40 0 NMIR W=20u L=1u
Mo2_oU_0_40 gp_o_0_40 d2e_0 ts_oU_0_40 0 NMIR W=20u L=1u
Mo3_oU_0_40 da_oU_0_40 da_oU_0_40 vdd vdd PMIR W=60u L=1u
Mo4_oU_0_40 gp_o_0_40 da_oU_0_40 vdd vdd PMIR W=60u L=1u
Mt_oU_0_41 ts_oU_0_41 hv_L3_24 0 0 NMIR W=20.0u L=1u
Mo1_oU_0_41 da_oU_0_41 d2ebar ts_oU_0_41 0 NMIR W=20u L=1u
Mo2_oU_0_41 gp_o_0_41 d2e_0 ts_oU_0_41 0 NMIR W=20u L=1u
Mo3_oU_0_41 da_oU_0_41 da_oU_0_41 vdd vdd PMIR W=60u L=1u
Mo4_oU_0_41 gp_o_0_41 da_oU_0_41 vdd vdd PMIR W=60u L=1u
Mt_oU_0_42 ts_oU_0_42 hv_L3_35 0 0 NMIR W=20.0u L=1u
Mo1_oU_0_42 da_oU_0_42 d2ebar ts_oU_0_42 0 NMIR W=20u L=1u
Mo2_oU_0_42 gp_o_0_42 d2e_0 ts_oU_0_42 0 NMIR W=20u L=1u
Mo3_oU_0_42 da_oU_0_42 da_oU_0_42 vdd vdd PMIR W=60u L=1u
Mo4_oU_0_42 gp_o_0_42 da_oU_0_42 vdd vdd PMIR W=60u L=1u
Mt_oU_0_43 ts_oU_0_43 hv_L3_27 0 0 NMIR W=20.0u L=1u
Mo1_oU_0_43 da_oU_0_43 d2ebar ts_oU_0_43 0 NMIR W=20u L=1u
Mo2_oU_0_43 gp_o_0_43 d2e_0 ts_oU_0_43 0 NMIR W=20u L=1u
Mo3_oU_0_43 da_oU_0_43 da_oU_0_43 vdd vdd PMIR W=60u L=1u
Mo4_oU_0_43 gp_o_0_43 da_oU_0_43 vdd vdd PMIR W=60u L=1u
Mt_oU_0_44 ts_oU_0_44 hv_L3_13 0 0 NMIR W=20.0u L=1u
Mo1_oU_0_44 da_oU_0_44 d2ebar ts_oU_0_44 0 NMIR W=20u L=1u
Mo2_oU_0_44 gp_o_0_44 d2e_0 ts_oU_0_44 0 NMIR W=20u L=1u
Mo3_oU_0_44 da_oU_0_44 da_oU_0_44 vdd vdd PMIR W=60u L=1u
Mo4_oU_0_44 gp_o_0_44 da_oU_0_44 vdd vdd PMIR W=60u L=1u
Mt_oU_0_45 ts_oU_0_45 hv_L3_20 0 0 NMIR W=20.0u L=1u
Mo1_oU_0_45 da_oU_0_45 d2ebar ts_oU_0_45 0 NMIR W=20u L=1u
Mo2_oU_0_45 gp_o_0_45 d2e_0 ts_oU_0_45 0 NMIR W=20u L=1u
Mo3_oU_0_45 da_oU_0_45 da_oU_0_45 vdd vdd PMIR W=60u L=1u
Mo4_oU_0_45 gp_o_0_45 da_oU_0_45 vdd vdd PMIR W=60u L=1u
Mt_oU_0_46 ts_oU_0_46 hv_L3_3 0 0 NMIR W=20.0u L=1u
Mo1_oU_0_46 da_oU_0_46 d2ebar ts_oU_0_46 0 NMIR W=20u L=1u
Mo2_oU_0_46 gp_o_0_46 d2e_0 ts_oU_0_46 0 NMIR W=20u L=1u
Mo3_oU_0_46 da_oU_0_46 da_oU_0_46 vdd vdd PMIR W=60u L=1u
Mo4_oU_0_46 gp_o_0_46 da_oU_0_46 vdd vdd PMIR W=60u L=1u
Mt_oU_0_47 ts_oU_0_47 hv_L3_42 0 0 NMIR W=20.0u L=1u
Mo1_oU_0_47 da_oU_0_47 d2ebar ts_oU_0_47 0 NMIR W=20u L=1u
Mo2_oU_0_47 gp_o_0_47 d2e_0 ts_oU_0_47 0 NMIR W=20u L=1u
Mo3_oU_0_47 da_oU_0_47 da_oU_0_47 vdd vdd PMIR W=60u L=1u
Mo4_oU_0_47 gp_o_0_47 da_oU_0_47 vdd vdd PMIR W=60u L=1u
Mt_oU_1_0 ts_oU_1_0 hv_L3_41 0 0 NMIR W=20.0u L=1u
Mo1_oU_1_0 da_oU_1_0 d2ebar ts_oU_1_0 0 NMIR W=20u L=1u
Mo2_oU_1_0 gp_o_1_0 d2e_1 ts_oU_1_0 0 NMIR W=20u L=1u
Mo3_oU_1_0 da_oU_1_0 da_oU_1_0 vdd vdd PMIR W=60u L=1u
Mo4_oU_1_0 gp_o_1_0 da_oU_1_0 vdd vdd PMIR W=60u L=1u
Mt_oU_1_1 ts_oU_1_1 hv_L3_2 0 0 NMIR W=20.0u L=1u
Mo1_oU_1_1 da_oU_1_1 d2ebar ts_oU_1_1 0 NMIR W=20u L=1u
Mo2_oU_1_1 gp_o_1_1 d2e_1 ts_oU_1_1 0 NMIR W=20u L=1u
Mo3_oU_1_1 da_oU_1_1 da_oU_1_1 vdd vdd PMIR W=60u L=1u
Mo4_oU_1_1 gp_o_1_1 da_oU_1_1 vdd vdd PMIR W=60u L=1u
Mt_oU_1_2 ts_oU_1_2 hv_L3_31 0 0 NMIR W=20.0u L=1u
Mo1_oU_1_2 da_oU_1_2 d2ebar ts_oU_1_2 0 NMIR W=20u L=1u
Mo2_oU_1_2 gp_o_1_2 d2e_1 ts_oU_1_2 0 NMIR W=20u L=1u
Mo3_oU_1_2 da_oU_1_2 da_oU_1_2 vdd vdd PMIR W=60u L=1u
Mo4_oU_1_2 gp_o_1_2 da_oU_1_2 vdd vdd PMIR W=60u L=1u
Mt_oU_1_3 ts_oU_1_3 hv_L3_27 0 0 NMIR W=20.0u L=1u
Mo1_oU_1_3 da_oU_1_3 d2ebar ts_oU_1_3 0 NMIR W=20u L=1u
Mo2_oU_1_3 gp_o_1_3 d2e_1 ts_oU_1_3 0 NMIR W=20u L=1u
Mo3_oU_1_3 da_oU_1_3 da_oU_1_3 vdd vdd PMIR W=60u L=1u
Mo4_oU_1_3 gp_o_1_3 da_oU_1_3 vdd vdd PMIR W=60u L=1u
Mt_oU_1_4 ts_oU_1_4 hv_L3_12 0 0 NMIR W=20.0u L=1u
Mo1_oU_1_4 da_oU_1_4 d2ebar ts_oU_1_4 0 NMIR W=20u L=1u
Mo2_oU_1_4 gp_o_1_4 d2e_1 ts_oU_1_4 0 NMIR W=20u L=1u
Mo3_oU_1_4 da_oU_1_4 da_oU_1_4 vdd vdd PMIR W=60u L=1u
Mo4_oU_1_4 gp_o_1_4 da_oU_1_4 vdd vdd PMIR W=60u L=1u
Mt_oU_1_5 ts_oU_1_5 hv_L3_15 0 0 NMIR W=20.0u L=1u
Mo1_oU_1_5 da_oU_1_5 d2ebar ts_oU_1_5 0 NMIR W=20u L=1u
Mo2_oU_1_5 gp_o_1_5 d2e_1 ts_oU_1_5 0 NMIR W=20u L=1u
Mo3_oU_1_5 da_oU_1_5 da_oU_1_5 vdd vdd PMIR W=60u L=1u
Mo4_oU_1_5 gp_o_1_5 da_oU_1_5 vdd vdd PMIR W=60u L=1u
Mt_oU_1_6 ts_oU_1_6 hv_L3_13 0 0 NMIR W=20.0u L=1u
Mo1_oU_1_6 da_oU_1_6 d2ebar ts_oU_1_6 0 NMIR W=20u L=1u
Mo2_oU_1_6 gp_o_1_6 d2e_1 ts_oU_1_6 0 NMIR W=20u L=1u
Mo3_oU_1_6 da_oU_1_6 da_oU_1_6 vdd vdd PMIR W=60u L=1u
Mo4_oU_1_6 gp_o_1_6 da_oU_1_6 vdd vdd PMIR W=60u L=1u
Mt_oU_1_7 ts_oU_1_7 hv_L3_30 0 0 NMIR W=20.0u L=1u
Mo1_oU_1_7 da_oU_1_7 d2ebar ts_oU_1_7 0 NMIR W=20u L=1u
Mo2_oU_1_7 gp_o_1_7 d2e_1 ts_oU_1_7 0 NMIR W=20u L=1u
Mo3_oU_1_7 da_oU_1_7 da_oU_1_7 vdd vdd PMIR W=60u L=1u
Mo4_oU_1_7 gp_o_1_7 da_oU_1_7 vdd vdd PMIR W=60u L=1u
Mt_oU_1_8 ts_oU_1_8 hv_L3_39 0 0 NMIR W=20.0u L=1u
Mo1_oU_1_8 da_oU_1_8 d2ebar ts_oU_1_8 0 NMIR W=20u L=1u
Mo2_oU_1_8 gp_o_1_8 d2e_1 ts_oU_1_8 0 NMIR W=20u L=1u
Mo3_oU_1_8 da_oU_1_8 da_oU_1_8 vdd vdd PMIR W=60u L=1u
Mo4_oU_1_8 gp_o_1_8 da_oU_1_8 vdd vdd PMIR W=60u L=1u
Mt_oU_1_9 ts_oU_1_9 hv_L3_7 0 0 NMIR W=20.0u L=1u
Mo1_oU_1_9 da_oU_1_9 d2ebar ts_oU_1_9 0 NMIR W=20u L=1u
Mo2_oU_1_9 gp_o_1_9 d2e_1 ts_oU_1_9 0 NMIR W=20u L=1u
Mo3_oU_1_9 da_oU_1_9 da_oU_1_9 vdd vdd PMIR W=60u L=1u
Mo4_oU_1_9 gp_o_1_9 da_oU_1_9 vdd vdd PMIR W=60u L=1u
Mt_oU_1_10 ts_oU_1_10 hv_L3_29 0 0 NMIR W=20.0u L=1u
Mo1_oU_1_10 da_oU_1_10 d2ebar ts_oU_1_10 0 NMIR W=20u L=1u
Mo2_oU_1_10 gp_o_1_10 d2e_1 ts_oU_1_10 0 NMIR W=20u L=1u
Mo3_oU_1_10 da_oU_1_10 da_oU_1_10 vdd vdd PMIR W=60u L=1u
Mo4_oU_1_10 gp_o_1_10 da_oU_1_10 vdd vdd PMIR W=60u L=1u
Mt_oU_1_11 ts_oU_1_11 hv_L3_45 0 0 NMIR W=20.0u L=1u
Mo1_oU_1_11 da_oU_1_11 d2ebar ts_oU_1_11 0 NMIR W=20u L=1u
Mo2_oU_1_11 gp_o_1_11 d2e_1 ts_oU_1_11 0 NMIR W=20u L=1u
Mo3_oU_1_11 da_oU_1_11 da_oU_1_11 vdd vdd PMIR W=60u L=1u
Mo4_oU_1_11 gp_o_1_11 da_oU_1_11 vdd vdd PMIR W=60u L=1u
Mt_oU_1_12 ts_oU_1_12 hv_L3_36 0 0 NMIR W=20.0u L=1u
Mo1_oU_1_12 da_oU_1_12 d2ebar ts_oU_1_12 0 NMIR W=20u L=1u
Mo2_oU_1_12 gp_o_1_12 d2e_1 ts_oU_1_12 0 NMIR W=20u L=1u
Mo3_oU_1_12 da_oU_1_12 da_oU_1_12 vdd vdd PMIR W=60u L=1u
Mo4_oU_1_12 gp_o_1_12 da_oU_1_12 vdd vdd PMIR W=60u L=1u
Mt_oU_1_13 ts_oU_1_13 hv_L3_25 0 0 NMIR W=20.0u L=1u
Mo1_oU_1_13 da_oU_1_13 d2ebar ts_oU_1_13 0 NMIR W=20u L=1u
Mo2_oU_1_13 gp_o_1_13 d2e_1 ts_oU_1_13 0 NMIR W=20u L=1u
Mo3_oU_1_13 da_oU_1_13 da_oU_1_13 vdd vdd PMIR W=60u L=1u
Mo4_oU_1_13 gp_o_1_13 da_oU_1_13 vdd vdd PMIR W=60u L=1u
Mt_oU_1_14 ts_oU_1_14 hv_L3_33 0 0 NMIR W=20.0u L=1u
Mo1_oU_1_14 da_oU_1_14 d2ebar ts_oU_1_14 0 NMIR W=20u L=1u
Mo2_oU_1_14 gp_o_1_14 d2e_1 ts_oU_1_14 0 NMIR W=20u L=1u
Mo3_oU_1_14 da_oU_1_14 da_oU_1_14 vdd vdd PMIR W=60u L=1u
Mo4_oU_1_14 gp_o_1_14 da_oU_1_14 vdd vdd PMIR W=60u L=1u
Mt_oU_1_15 ts_oU_1_15 hv_L3_37 0 0 NMIR W=20.0u L=1u
Mo1_oU_1_15 da_oU_1_15 d2ebar ts_oU_1_15 0 NMIR W=20u L=1u
Mo2_oU_1_15 gp_o_1_15 d2e_1 ts_oU_1_15 0 NMIR W=20u L=1u
Mo3_oU_1_15 da_oU_1_15 da_oU_1_15 vdd vdd PMIR W=60u L=1u
Mo4_oU_1_15 gp_o_1_15 da_oU_1_15 vdd vdd PMIR W=60u L=1u
Mt_oU_1_16 ts_oU_1_16 hv_L3_34 0 0 NMIR W=20.0u L=1u
Mo1_oU_1_16 da_oU_1_16 d2ebar ts_oU_1_16 0 NMIR W=20u L=1u
Mo2_oU_1_16 gp_o_1_16 d2e_1 ts_oU_1_16 0 NMIR W=20u L=1u
Mo3_oU_1_16 da_oU_1_16 da_oU_1_16 vdd vdd PMIR W=60u L=1u
Mo4_oU_1_16 gp_o_1_16 da_oU_1_16 vdd vdd PMIR W=60u L=1u
Mt_oU_1_17 ts_oU_1_17 hv_L3_38 0 0 NMIR W=20.0u L=1u
Mo1_oU_1_17 da_oU_1_17 d2ebar ts_oU_1_17 0 NMIR W=20u L=1u
Mo2_oU_1_17 gp_o_1_17 d2e_1 ts_oU_1_17 0 NMIR W=20u L=1u
Mo3_oU_1_17 da_oU_1_17 da_oU_1_17 vdd vdd PMIR W=60u L=1u
Mo4_oU_1_17 gp_o_1_17 da_oU_1_17 vdd vdd PMIR W=60u L=1u
Mt_oU_1_18 ts_oU_1_18 hv_L3_21 0 0 NMIR W=20.0u L=1u
Mo1_oU_1_18 da_oU_1_18 d2ebar ts_oU_1_18 0 NMIR W=20u L=1u
Mo2_oU_1_18 gp_o_1_18 d2e_1 ts_oU_1_18 0 NMIR W=20u L=1u
Mo3_oU_1_18 da_oU_1_18 da_oU_1_18 vdd vdd PMIR W=60u L=1u
Mo4_oU_1_18 gp_o_1_18 da_oU_1_18 vdd vdd PMIR W=60u L=1u
Mt_oU_1_19 ts_oU_1_19 hv_L3_5 0 0 NMIR W=20.0u L=1u
Mo1_oU_1_19 da_oU_1_19 d2ebar ts_oU_1_19 0 NMIR W=20u L=1u
Mo2_oU_1_19 gp_o_1_19 d2e_1 ts_oU_1_19 0 NMIR W=20u L=1u
Mo3_oU_1_19 da_oU_1_19 da_oU_1_19 vdd vdd PMIR W=60u L=1u
Mo4_oU_1_19 gp_o_1_19 da_oU_1_19 vdd vdd PMIR W=60u L=1u
Mt_oU_1_20 ts_oU_1_20 hv_L3_8 0 0 NMIR W=20.0u L=1u
Mo1_oU_1_20 da_oU_1_20 d2ebar ts_oU_1_20 0 NMIR W=20u L=1u
Mo2_oU_1_20 gp_o_1_20 d2e_1 ts_oU_1_20 0 NMIR W=20u L=1u
Mo3_oU_1_20 da_oU_1_20 da_oU_1_20 vdd vdd PMIR W=60u L=1u
Mo4_oU_1_20 gp_o_1_20 da_oU_1_20 vdd vdd PMIR W=60u L=1u
Mt_oU_1_21 ts_oU_1_21 hv_L3_22 0 0 NMIR W=20.0u L=1u
Mo1_oU_1_21 da_oU_1_21 d2ebar ts_oU_1_21 0 NMIR W=20u L=1u
Mo2_oU_1_21 gp_o_1_21 d2e_1 ts_oU_1_21 0 NMIR W=20u L=1u
Mo3_oU_1_21 da_oU_1_21 da_oU_1_21 vdd vdd PMIR W=60u L=1u
Mo4_oU_1_21 gp_o_1_21 da_oU_1_21 vdd vdd PMIR W=60u L=1u
Mt_oU_1_22 ts_oU_1_22 hv_L3_19 0 0 NMIR W=20.0u L=1u
Mo1_oU_1_22 da_oU_1_22 d2ebar ts_oU_1_22 0 NMIR W=20u L=1u
Mo2_oU_1_22 gp_o_1_22 d2e_1 ts_oU_1_22 0 NMIR W=20u L=1u
Mo3_oU_1_22 da_oU_1_22 da_oU_1_22 vdd vdd PMIR W=60u L=1u
Mo4_oU_1_22 gp_o_1_22 da_oU_1_22 vdd vdd PMIR W=60u L=1u
Mt_oU_1_23 ts_oU_1_23 hv_L3_6 0 0 NMIR W=20.0u L=1u
Mo1_oU_1_23 da_oU_1_23 d2ebar ts_oU_1_23 0 NMIR W=20u L=1u
Mo2_oU_1_23 gp_o_1_23 d2e_1 ts_oU_1_23 0 NMIR W=20u L=1u
Mo3_oU_1_23 da_oU_1_23 da_oU_1_23 vdd vdd PMIR W=60u L=1u
Mo4_oU_1_23 gp_o_1_23 da_oU_1_23 vdd vdd PMIR W=60u L=1u
Mt_oU_1_24 ts_oU_1_24 hv_L3_46 0 0 NMIR W=20.0u L=1u
Mo1_oU_1_24 da_oU_1_24 d2ebar ts_oU_1_24 0 NMIR W=20u L=1u
Mo2_oU_1_24 gp_o_1_24 d2e_1 ts_oU_1_24 0 NMIR W=20u L=1u
Mo3_oU_1_24 da_oU_1_24 da_oU_1_24 vdd vdd PMIR W=60u L=1u
Mo4_oU_1_24 gp_o_1_24 da_oU_1_24 vdd vdd PMIR W=60u L=1u
Mt_oU_1_25 ts_oU_1_25 hv_L3_32 0 0 NMIR W=20.0u L=1u
Mo1_oU_1_25 da_oU_1_25 d2ebar ts_oU_1_25 0 NMIR W=20u L=1u
Mo2_oU_1_25 gp_o_1_25 d2e_1 ts_oU_1_25 0 NMIR W=20u L=1u
Mo3_oU_1_25 da_oU_1_25 da_oU_1_25 vdd vdd PMIR W=60u L=1u
Mo4_oU_1_25 gp_o_1_25 da_oU_1_25 vdd vdd PMIR W=60u L=1u
Mt_oU_1_26 ts_oU_1_26 hv_L3_44 0 0 NMIR W=20.0u L=1u
Mo1_oU_1_26 da_oU_1_26 d2ebar ts_oU_1_26 0 NMIR W=20u L=1u
Mo2_oU_1_26 gp_o_1_26 d2e_1 ts_oU_1_26 0 NMIR W=20u L=1u
Mo3_oU_1_26 da_oU_1_26 da_oU_1_26 vdd vdd PMIR W=60u L=1u
Mo4_oU_1_26 gp_o_1_26 da_oU_1_26 vdd vdd PMIR W=60u L=1u
Mt_oU_1_27 ts_oU_1_27 hv_L3_1 0 0 NMIR W=20.0u L=1u
Mo1_oU_1_27 da_oU_1_27 d2ebar ts_oU_1_27 0 NMIR W=20u L=1u
Mo2_oU_1_27 gp_o_1_27 d2e_1 ts_oU_1_27 0 NMIR W=20u L=1u
Mo3_oU_1_27 da_oU_1_27 da_oU_1_27 vdd vdd PMIR W=60u L=1u
Mo4_oU_1_27 gp_o_1_27 da_oU_1_27 vdd vdd PMIR W=60u L=1u
Mt_oU_1_28 ts_oU_1_28 hv_L3_24 0 0 NMIR W=20.0u L=1u
Mo1_oU_1_28 da_oU_1_28 d2ebar ts_oU_1_28 0 NMIR W=20u L=1u
Mo2_oU_1_28 gp_o_1_28 d2e_1 ts_oU_1_28 0 NMIR W=20u L=1u
Mo3_oU_1_28 da_oU_1_28 da_oU_1_28 vdd vdd PMIR W=60u L=1u
Mo4_oU_1_28 gp_o_1_28 da_oU_1_28 vdd vdd PMIR W=60u L=1u
Mt_oU_1_29 ts_oU_1_29 hv_L3_4 0 0 NMIR W=20.0u L=1u
Mo1_oU_1_29 da_oU_1_29 d2ebar ts_oU_1_29 0 NMIR W=20u L=1u
Mo2_oU_1_29 gp_o_1_29 d2e_1 ts_oU_1_29 0 NMIR W=20u L=1u
Mo3_oU_1_29 da_oU_1_29 da_oU_1_29 vdd vdd PMIR W=60u L=1u
Mo4_oU_1_29 gp_o_1_29 da_oU_1_29 vdd vdd PMIR W=60u L=1u
Mt_oU_1_30 ts_oU_1_30 hv_L3_9 0 0 NMIR W=20.0u L=1u
Mo1_oU_1_30 da_oU_1_30 d2ebar ts_oU_1_30 0 NMIR W=20u L=1u
Mo2_oU_1_30 gp_o_1_30 d2e_1 ts_oU_1_30 0 NMIR W=20u L=1u
Mo3_oU_1_30 da_oU_1_30 da_oU_1_30 vdd vdd PMIR W=60u L=1u
Mo4_oU_1_30 gp_o_1_30 da_oU_1_30 vdd vdd PMIR W=60u L=1u
Mt_oU_1_31 ts_oU_1_31 hv_L3_47 0 0 NMIR W=20.0u L=1u
Mo1_oU_1_31 da_oU_1_31 d2ebar ts_oU_1_31 0 NMIR W=20u L=1u
Mo2_oU_1_31 gp_o_1_31 d2e_1 ts_oU_1_31 0 NMIR W=20u L=1u
Mo3_oU_1_31 da_oU_1_31 da_oU_1_31 vdd vdd PMIR W=60u L=1u
Mo4_oU_1_31 gp_o_1_31 da_oU_1_31 vdd vdd PMIR W=60u L=1u
Mt_oU_1_32 ts_oU_1_32 hv_L3_11 0 0 NMIR W=20.0u L=1u
Mo1_oU_1_32 da_oU_1_32 d2ebar ts_oU_1_32 0 NMIR W=20u L=1u
Mo2_oU_1_32 gp_o_1_32 d2e_1 ts_oU_1_32 0 NMIR W=20u L=1u
Mo3_oU_1_32 da_oU_1_32 da_oU_1_32 vdd vdd PMIR W=60u L=1u
Mo4_oU_1_32 gp_o_1_32 da_oU_1_32 vdd vdd PMIR W=60u L=1u
Mt_oU_1_33 ts_oU_1_33 hv_L3_23 0 0 NMIR W=20.0u L=1u
Mo1_oU_1_33 da_oU_1_33 d2ebar ts_oU_1_33 0 NMIR W=20u L=1u
Mo2_oU_1_33 gp_o_1_33 d2e_1 ts_oU_1_33 0 NMIR W=20u L=1u
Mo3_oU_1_33 da_oU_1_33 da_oU_1_33 vdd vdd PMIR W=60u L=1u
Mo4_oU_1_33 gp_o_1_33 da_oU_1_33 vdd vdd PMIR W=60u L=1u
Mt_oU_1_34 ts_oU_1_34 hv_L3_17 0 0 NMIR W=20.0u L=1u
Mo1_oU_1_34 da_oU_1_34 d2ebar ts_oU_1_34 0 NMIR W=20u L=1u
Mo2_oU_1_34 gp_o_1_34 d2e_1 ts_oU_1_34 0 NMIR W=20u L=1u
Mo3_oU_1_34 da_oU_1_34 da_oU_1_34 vdd vdd PMIR W=60u L=1u
Mo4_oU_1_34 gp_o_1_34 da_oU_1_34 vdd vdd PMIR W=60u L=1u
Mt_oU_1_35 ts_oU_1_35 hv_L3_14 0 0 NMIR W=20.0u L=1u
Mo1_oU_1_35 da_oU_1_35 d2ebar ts_oU_1_35 0 NMIR W=20u L=1u
Mo2_oU_1_35 gp_o_1_35 d2e_1 ts_oU_1_35 0 NMIR W=20u L=1u
Mo3_oU_1_35 da_oU_1_35 da_oU_1_35 vdd vdd PMIR W=60u L=1u
Mo4_oU_1_35 gp_o_1_35 da_oU_1_35 vdd vdd PMIR W=60u L=1u
Mt_oU_1_36 ts_oU_1_36 hv_L3_3 0 0 NMIR W=20.0u L=1u
Mo1_oU_1_36 da_oU_1_36 d2ebar ts_oU_1_36 0 NMIR W=20u L=1u
Mo2_oU_1_36 gp_o_1_36 d2e_1 ts_oU_1_36 0 NMIR W=20u L=1u
Mo3_oU_1_36 da_oU_1_36 da_oU_1_36 vdd vdd PMIR W=60u L=1u
Mo4_oU_1_36 gp_o_1_36 da_oU_1_36 vdd vdd PMIR W=60u L=1u
Mt_oU_1_37 ts_oU_1_37 hv_L3_40 0 0 NMIR W=20.0u L=1u
Mo1_oU_1_37 da_oU_1_37 d2ebar ts_oU_1_37 0 NMIR W=20u L=1u
Mo2_oU_1_37 gp_o_1_37 d2e_1 ts_oU_1_37 0 NMIR W=20u L=1u
Mo3_oU_1_37 da_oU_1_37 da_oU_1_37 vdd vdd PMIR W=60u L=1u
Mo4_oU_1_37 gp_o_1_37 da_oU_1_37 vdd vdd PMIR W=60u L=1u
Mt_oU_1_38 ts_oU_1_38 hv_L3_16 0 0 NMIR W=20.0u L=1u
Mo1_oU_1_38 da_oU_1_38 d2ebar ts_oU_1_38 0 NMIR W=20u L=1u
Mo2_oU_1_38 gp_o_1_38 d2e_1 ts_oU_1_38 0 NMIR W=20u L=1u
Mo3_oU_1_38 da_oU_1_38 da_oU_1_38 vdd vdd PMIR W=60u L=1u
Mo4_oU_1_38 gp_o_1_38 da_oU_1_38 vdd vdd PMIR W=60u L=1u
Mt_oU_1_39 ts_oU_1_39 hv_L3_28 0 0 NMIR W=20.0u L=1u
Mo1_oU_1_39 da_oU_1_39 d2ebar ts_oU_1_39 0 NMIR W=20u L=1u
Mo2_oU_1_39 gp_o_1_39 d2e_1 ts_oU_1_39 0 NMIR W=20u L=1u
Mo3_oU_1_39 da_oU_1_39 da_oU_1_39 vdd vdd PMIR W=60u L=1u
Mo4_oU_1_39 gp_o_1_39 da_oU_1_39 vdd vdd PMIR W=60u L=1u
Mt_oU_1_40 ts_oU_1_40 hv_L3_20 0 0 NMIR W=20.0u L=1u
Mo1_oU_1_40 da_oU_1_40 d2ebar ts_oU_1_40 0 NMIR W=20u L=1u
Mo2_oU_1_40 gp_o_1_40 d2e_1 ts_oU_1_40 0 NMIR W=20u L=1u
Mo3_oU_1_40 da_oU_1_40 da_oU_1_40 vdd vdd PMIR W=60u L=1u
Mo4_oU_1_40 gp_o_1_40 da_oU_1_40 vdd vdd PMIR W=60u L=1u
Mt_oU_1_41 ts_oU_1_41 hv_L3_35 0 0 NMIR W=20.0u L=1u
Mo1_oU_1_41 da_oU_1_41 d2ebar ts_oU_1_41 0 NMIR W=20u L=1u
Mo2_oU_1_41 gp_o_1_41 d2e_1 ts_oU_1_41 0 NMIR W=20u L=1u
Mo3_oU_1_41 da_oU_1_41 da_oU_1_41 vdd vdd PMIR W=60u L=1u
Mo4_oU_1_41 gp_o_1_41 da_oU_1_41 vdd vdd PMIR W=60u L=1u
Mt_oU_1_42 ts_oU_1_42 hv_L3_42 0 0 NMIR W=20.0u L=1u
Mo1_oU_1_42 da_oU_1_42 d2ebar ts_oU_1_42 0 NMIR W=20u L=1u
Mo2_oU_1_42 gp_o_1_42 d2e_1 ts_oU_1_42 0 NMIR W=20u L=1u
Mo3_oU_1_42 da_oU_1_42 da_oU_1_42 vdd vdd PMIR W=60u L=1u
Mo4_oU_1_42 gp_o_1_42 da_oU_1_42 vdd vdd PMIR W=60u L=1u
Mt_oU_1_43 ts_oU_1_43 hv_L3_43 0 0 NMIR W=20.0u L=1u
Mo1_oU_1_43 da_oU_1_43 d2ebar ts_oU_1_43 0 NMIR W=20u L=1u
Mo2_oU_1_43 gp_o_1_43 d2e_1 ts_oU_1_43 0 NMIR W=20u L=1u
Mo3_oU_1_43 da_oU_1_43 da_oU_1_43 vdd vdd PMIR W=60u L=1u
Mo4_oU_1_43 gp_o_1_43 da_oU_1_43 vdd vdd PMIR W=60u L=1u
Mt_oU_1_44 ts_oU_1_44 hv_L3_10 0 0 NMIR W=20.0u L=1u
Mo1_oU_1_44 da_oU_1_44 d2ebar ts_oU_1_44 0 NMIR W=20u L=1u
Mo2_oU_1_44 gp_o_1_44 d2e_1 ts_oU_1_44 0 NMIR W=20u L=1u
Mo3_oU_1_44 da_oU_1_44 da_oU_1_44 vdd vdd PMIR W=60u L=1u
Mo4_oU_1_44 gp_o_1_44 da_oU_1_44 vdd vdd PMIR W=60u L=1u
Mt_oU_1_45 ts_oU_1_45 hv_L3_18 0 0 NMIR W=20.0u L=1u
Mo1_oU_1_45 da_oU_1_45 d2ebar ts_oU_1_45 0 NMIR W=20u L=1u
Mo2_oU_1_45 gp_o_1_45 d2e_1 ts_oU_1_45 0 NMIR W=20u L=1u
Mo3_oU_1_45 da_oU_1_45 da_oU_1_45 vdd vdd PMIR W=60u L=1u
Mo4_oU_1_45 gp_o_1_45 da_oU_1_45 vdd vdd PMIR W=60u L=1u
Mt_oU_1_46 ts_oU_1_46 hv_L3_0 0 0 NMIR W=20.0u L=1u
Mo1_oU_1_46 da_oU_1_46 d2ebar ts_oU_1_46 0 NMIR W=20u L=1u
Mo2_oU_1_46 gp_o_1_46 d2e_1 ts_oU_1_46 0 NMIR W=20u L=1u
Mo3_oU_1_46 da_oU_1_46 da_oU_1_46 vdd vdd PMIR W=60u L=1u
Mo4_oU_1_46 gp_o_1_46 da_oU_1_46 vdd vdd PMIR W=60u L=1u
Mt_oU_1_47 ts_oU_1_47 hv_L3_26 0 0 NMIR W=20.0u L=1u
Mo1_oU_1_47 da_oU_1_47 d2ebar ts_oU_1_47 0 NMIR W=20u L=1u
Mo2_oU_1_47 gp_o_1_47 d2e_1 ts_oU_1_47 0 NMIR W=20u L=1u
Mo3_oU_1_47 da_oU_1_47 da_oU_1_47 vdd vdd PMIR W=60u L=1u
Mo4_oU_1_47 gp_o_1_47 da_oU_1_47 vdd vdd PMIR W=60u L=1u
MpTa_L3_0_0 d2e_pb_0 gp_o_0_30 ctp_L3_0 0 NSYN W=10u L=1u
MnTb_L3_0_0 d2e_nb_0 vcn ctp_L3_0 0 NSYN W=10u L=1u
MnTa_L3_0_0 d2e_pb_0 vcn ctn_L3_0 0 NSYN W=10u L=1u
MpTb_L3_0_0 d2e_nb_0 gp_o_0_30 ctn_L3_0 0 NSYN W=10u L=1u
MpTa_L3_0_1 d2e_pb_1 gp_o_1_46 ctp_L3_0 0 NSYN W=10u L=1u
MnTb_L3_0_1 d2e_nb_1 vcn ctp_L3_0 0 NSYN W=10u L=1u
MnTa_L3_0_1 d2e_pb_1 vcn ctn_L3_0 0 NSYN W=10u L=1u
MpTb_L3_0_1 d2e_nb_1 gp_o_1_46 ctn_L3_0 0 NSYN W=10u L=1u
Msa_bk_L3_0 ctn_L3_0 ctn_L3_0 0 0 NMIR W=20u L=1u
Msb_bk_L3_0 dpre_L3_0 ctn_L3_0 0 0 NMIR W=20u L=1u
Msc_bk_L3_0 ctp_L3_0 ctp_L3_0 0 0 NMIR W=20u L=1u
Msd_bk_L3_0 dpf_bk_L3_0 ctp_L3_0 0 0 NMIR W=20u L=1u
Mse_bk_L3_0 dpf_bk_L3_0 dpf_bk_L3_0 vdd vdd PMIR W=60u L=1u
Msf_bk_L3_0 dpre_L3_0 dpf_bk_L3_0 vdd vdd PMIR W=60u L=1u
R_bk_L3_0 dpre_L3_0 vrefd 16000.0
MpTa_L3_1_0 d2e_pb_0 gp_o_0_4 ctp_L3_1 0 NSYN W=10u L=1u
MnTb_L3_1_0 d2e_nb_0 vcn ctp_L3_1 0 NSYN W=10u L=1u
MnTa_L3_1_0 d2e_pb_0 vcn ctn_L3_1 0 NSYN W=10u L=1u
MpTb_L3_1_0 d2e_nb_0 gp_o_0_4 ctn_L3_1 0 NSYN W=10u L=1u
MpTa_L3_1_1 d2e_pb_1 gp_o_1_27 ctp_L3_1 0 NSYN W=10u L=1u
MnTb_L3_1_1 d2e_nb_1 vcn ctp_L3_1 0 NSYN W=10u L=1u
MnTa_L3_1_1 d2e_pb_1 vcn ctn_L3_1 0 NSYN W=10u L=1u
MpTb_L3_1_1 d2e_nb_1 gp_o_1_27 ctn_L3_1 0 NSYN W=10u L=1u
Msa_bk_L3_1 ctn_L3_1 ctn_L3_1 0 0 NMIR W=20u L=1u
Msb_bk_L3_1 dpre_L3_1 ctn_L3_1 0 0 NMIR W=20u L=1u
Msc_bk_L3_1 ctp_L3_1 ctp_L3_1 0 0 NMIR W=20u L=1u
Msd_bk_L3_1 dpf_bk_L3_1 ctp_L3_1 0 0 NMIR W=20u L=1u
Mse_bk_L3_1 dpf_bk_L3_1 dpf_bk_L3_1 vdd vdd PMIR W=60u L=1u
Msf_bk_L3_1 dpre_L3_1 dpf_bk_L3_1 vdd vdd PMIR W=60u L=1u
R_bk_L3_1 dpre_L3_1 vrefd 16000.0
MpTa_L3_2_0 d2e_pb_0 gp_o_0_32 ctp_L3_2 0 NSYN W=10u L=1u
MnTb_L3_2_0 d2e_nb_0 vcn ctp_L3_2 0 NSYN W=10u L=1u
MnTa_L3_2_0 d2e_pb_0 vcn ctn_L3_2 0 NSYN W=10u L=1u
MpTb_L3_2_0 d2e_nb_0 gp_o_0_32 ctn_L3_2 0 NSYN W=10u L=1u
MpTa_L3_2_1 d2e_pb_1 gp_o_1_1 ctp_L3_2 0 NSYN W=10u L=1u
MnTb_L3_2_1 d2e_nb_1 vcn ctp_L3_2 0 NSYN W=10u L=1u
MnTa_L3_2_1 d2e_pb_1 vcn ctn_L3_2 0 NSYN W=10u L=1u
MpTb_L3_2_1 d2e_nb_1 gp_o_1_1 ctn_L3_2 0 NSYN W=10u L=1u
Msa_bk_L3_2 ctn_L3_2 ctn_L3_2 0 0 NMIR W=20u L=1u
Msb_bk_L3_2 dpre_L3_2 ctn_L3_2 0 0 NMIR W=20u L=1u
Msc_bk_L3_2 ctp_L3_2 ctp_L3_2 0 0 NMIR W=20u L=1u
Msd_bk_L3_2 dpf_bk_L3_2 ctp_L3_2 0 0 NMIR W=20u L=1u
Mse_bk_L3_2 dpf_bk_L3_2 dpf_bk_L3_2 vdd vdd PMIR W=60u L=1u
Msf_bk_L3_2 dpre_L3_2 dpf_bk_L3_2 vdd vdd PMIR W=60u L=1u
R_bk_L3_2 dpre_L3_2 vrefd 16000.0
MpTa_L3_3_0 d2e_pb_0 gp_o_0_46 ctp_L3_3 0 NSYN W=10u L=1u
MnTb_L3_3_0 d2e_nb_0 vcn ctp_L3_3 0 NSYN W=10u L=1u
MnTa_L3_3_0 d2e_pb_0 vcn ctn_L3_3 0 NSYN W=10u L=1u
MpTb_L3_3_0 d2e_nb_0 gp_o_0_46 ctn_L3_3 0 NSYN W=10u L=1u
MpTa_L3_3_1 d2e_pb_1 gp_o_1_36 ctp_L3_3 0 NSYN W=10u L=1u
MnTb_L3_3_1 d2e_nb_1 vcn ctp_L3_3 0 NSYN W=10u L=1u
MnTa_L3_3_1 d2e_pb_1 vcn ctn_L3_3 0 NSYN W=10u L=1u
MpTb_L3_3_1 d2e_nb_1 gp_o_1_36 ctn_L3_3 0 NSYN W=10u L=1u
Msa_bk_L3_3 ctn_L3_3 ctn_L3_3 0 0 NMIR W=20u L=1u
Msb_bk_L3_3 dpre_L3_3 ctn_L3_3 0 0 NMIR W=20u L=1u
Msc_bk_L3_3 ctp_L3_3 ctp_L3_3 0 0 NMIR W=20u L=1u
Msd_bk_L3_3 dpf_bk_L3_3 ctp_L3_3 0 0 NMIR W=20u L=1u
Mse_bk_L3_3 dpf_bk_L3_3 dpf_bk_L3_3 vdd vdd PMIR W=60u L=1u
Msf_bk_L3_3 dpre_L3_3 dpf_bk_L3_3 vdd vdd PMIR W=60u L=1u
R_bk_L3_3 dpre_L3_3 vrefd 16000.0
MpTa_L3_4_0 d2e_pb_0 gp_o_0_13 ctp_L3_4 0 NSYN W=10u L=1u
MnTb_L3_4_0 d2e_nb_0 vcn ctp_L3_4 0 NSYN W=10u L=1u
MnTa_L3_4_0 d2e_pb_0 vcn ctn_L3_4 0 NSYN W=10u L=1u
MpTb_L3_4_0 d2e_nb_0 gp_o_0_13 ctn_L3_4 0 NSYN W=10u L=1u
MpTa_L3_4_1 d2e_pb_1 gp_o_1_29 ctp_L3_4 0 NSYN W=10u L=1u
MnTb_L3_4_1 d2e_nb_1 vcn ctp_L3_4 0 NSYN W=10u L=1u
MnTa_L3_4_1 d2e_pb_1 vcn ctn_L3_4 0 NSYN W=10u L=1u
MpTb_L3_4_1 d2e_nb_1 gp_o_1_29 ctn_L3_4 0 NSYN W=10u L=1u
Msa_bk_L3_4 ctn_L3_4 ctn_L3_4 0 0 NMIR W=20u L=1u
Msb_bk_L3_4 dpre_L3_4 ctn_L3_4 0 0 NMIR W=20u L=1u
Msc_bk_L3_4 ctp_L3_4 ctp_L3_4 0 0 NMIR W=20u L=1u
Msd_bk_L3_4 dpf_bk_L3_4 ctp_L3_4 0 0 NMIR W=20u L=1u
Mse_bk_L3_4 dpf_bk_L3_4 dpf_bk_L3_4 vdd vdd PMIR W=60u L=1u
Msf_bk_L3_4 dpre_L3_4 dpf_bk_L3_4 vdd vdd PMIR W=60u L=1u
R_bk_L3_4 dpre_L3_4 vrefd 16000.0
MpTa_L3_5_0 d2e_pb_0 gp_o_0_2 ctp_L3_5 0 NSYN W=10u L=1u
MnTb_L3_5_0 d2e_nb_0 vcn ctp_L3_5 0 NSYN W=10u L=1u
MnTa_L3_5_0 d2e_pb_0 vcn ctn_L3_5 0 NSYN W=10u L=1u
MpTb_L3_5_0 d2e_nb_0 gp_o_0_2 ctn_L3_5 0 NSYN W=10u L=1u
MpTa_L3_5_1 d2e_pb_1 gp_o_1_19 ctp_L3_5 0 NSYN W=10u L=1u
MnTb_L3_5_1 d2e_nb_1 vcn ctp_L3_5 0 NSYN W=10u L=1u
MnTa_L3_5_1 d2e_pb_1 vcn ctn_L3_5 0 NSYN W=10u L=1u
MpTb_L3_5_1 d2e_nb_1 gp_o_1_19 ctn_L3_5 0 NSYN W=10u L=1u
Msa_bk_L3_5 ctn_L3_5 ctn_L3_5 0 0 NMIR W=20u L=1u
Msb_bk_L3_5 dpre_L3_5 ctn_L3_5 0 0 NMIR W=20u L=1u
Msc_bk_L3_5 ctp_L3_5 ctp_L3_5 0 0 NMIR W=20u L=1u
Msd_bk_L3_5 dpf_bk_L3_5 ctp_L3_5 0 0 NMIR W=20u L=1u
Mse_bk_L3_5 dpf_bk_L3_5 dpf_bk_L3_5 vdd vdd PMIR W=60u L=1u
Msf_bk_L3_5 dpre_L3_5 dpf_bk_L3_5 vdd vdd PMIR W=60u L=1u
R_bk_L3_5 dpre_L3_5 vrefd 16000.0
MpTa_L3_6_0 d2e_pb_0 gp_o_0_36 ctp_L3_6 0 NSYN W=10u L=1u
MnTb_L3_6_0 d2e_nb_0 vcn ctp_L3_6 0 NSYN W=10u L=1u
MnTa_L3_6_0 d2e_pb_0 vcn ctn_L3_6 0 NSYN W=10u L=1u
MpTb_L3_6_0 d2e_nb_0 gp_o_0_36 ctn_L3_6 0 NSYN W=10u L=1u
MpTa_L3_6_1 d2e_pb_1 gp_o_1_23 ctp_L3_6 0 NSYN W=10u L=1u
MnTb_L3_6_1 d2e_nb_1 vcn ctp_L3_6 0 NSYN W=10u L=1u
MnTa_L3_6_1 d2e_pb_1 vcn ctn_L3_6 0 NSYN W=10u L=1u
MpTb_L3_6_1 d2e_nb_1 gp_o_1_23 ctn_L3_6 0 NSYN W=10u L=1u
Msa_bk_L3_6 ctn_L3_6 ctn_L3_6 0 0 NMIR W=20u L=1u
Msb_bk_L3_6 dpre_L3_6 ctn_L3_6 0 0 NMIR W=20u L=1u
Msc_bk_L3_6 ctp_L3_6 ctp_L3_6 0 0 NMIR W=20u L=1u
Msd_bk_L3_6 dpf_bk_L3_6 ctp_L3_6 0 0 NMIR W=20u L=1u
Mse_bk_L3_6 dpf_bk_L3_6 dpf_bk_L3_6 vdd vdd PMIR W=60u L=1u
Msf_bk_L3_6 dpre_L3_6 dpf_bk_L3_6 vdd vdd PMIR W=60u L=1u
R_bk_L3_6 dpre_L3_6 vrefd 16000.0
MpTa_L3_7_0 d2e_pb_0 gp_o_0_29 ctp_L3_7 0 NSYN W=10u L=1u
MnTb_L3_7_0 d2e_nb_0 vcn ctp_L3_7 0 NSYN W=10u L=1u
MnTa_L3_7_0 d2e_pb_0 vcn ctn_L3_7 0 NSYN W=10u L=1u
MpTb_L3_7_0 d2e_nb_0 gp_o_0_29 ctn_L3_7 0 NSYN W=10u L=1u
MpTa_L3_7_1 d2e_pb_1 gp_o_1_9 ctp_L3_7 0 NSYN W=10u L=1u
MnTb_L3_7_1 d2e_nb_1 vcn ctp_L3_7 0 NSYN W=10u L=1u
MnTa_L3_7_1 d2e_pb_1 vcn ctn_L3_7 0 NSYN W=10u L=1u
MpTb_L3_7_1 d2e_nb_1 gp_o_1_9 ctn_L3_7 0 NSYN W=10u L=1u
Msa_bk_L3_7 ctn_L3_7 ctn_L3_7 0 0 NMIR W=20u L=1u
Msb_bk_L3_7 dpre_L3_7 ctn_L3_7 0 0 NMIR W=20u L=1u
Msc_bk_L3_7 ctp_L3_7 ctp_L3_7 0 0 NMIR W=20u L=1u
Msd_bk_L3_7 dpf_bk_L3_7 ctp_L3_7 0 0 NMIR W=20u L=1u
Mse_bk_L3_7 dpf_bk_L3_7 dpf_bk_L3_7 vdd vdd PMIR W=60u L=1u
Msf_bk_L3_7 dpre_L3_7 dpf_bk_L3_7 vdd vdd PMIR W=60u L=1u
R_bk_L3_7 dpre_L3_7 vrefd 16000.0
MpTa_L3_8_0 d2e_pb_0 gp_o_0_28 ctp_L3_8 0 NSYN W=10u L=1u
MnTb_L3_8_0 d2e_nb_0 vcn ctp_L3_8 0 NSYN W=10u L=1u
MnTa_L3_8_0 d2e_pb_0 vcn ctn_L3_8 0 NSYN W=10u L=1u
MpTb_L3_8_0 d2e_nb_0 gp_o_0_28 ctn_L3_8 0 NSYN W=10u L=1u
MpTa_L3_8_1 d2e_pb_1 gp_o_1_20 ctp_L3_8 0 NSYN W=10u L=1u
MnTb_L3_8_1 d2e_nb_1 vcn ctp_L3_8 0 NSYN W=10u L=1u
MnTa_L3_8_1 d2e_pb_1 vcn ctn_L3_8 0 NSYN W=10u L=1u
MpTb_L3_8_1 d2e_nb_1 gp_o_1_20 ctn_L3_8 0 NSYN W=10u L=1u
Msa_bk_L3_8 ctn_L3_8 ctn_L3_8 0 0 NMIR W=20u L=1u
Msb_bk_L3_8 dpre_L3_8 ctn_L3_8 0 0 NMIR W=20u L=1u
Msc_bk_L3_8 ctp_L3_8 ctp_L3_8 0 0 NMIR W=20u L=1u
Msd_bk_L3_8 dpf_bk_L3_8 ctp_L3_8 0 0 NMIR W=20u L=1u
Mse_bk_L3_8 dpf_bk_L3_8 dpf_bk_L3_8 vdd vdd PMIR W=60u L=1u
Msf_bk_L3_8 dpre_L3_8 dpf_bk_L3_8 vdd vdd PMIR W=60u L=1u
R_bk_L3_8 dpre_L3_8 vrefd 16000.0
MpTa_L3_9_0 d2e_pb_0 gp_o_0_20 ctp_L3_9 0 NSYN W=10u L=1u
MnTb_L3_9_0 d2e_nb_0 vcn ctp_L3_9 0 NSYN W=10u L=1u
MnTa_L3_9_0 d2e_pb_0 vcn ctn_L3_9 0 NSYN W=10u L=1u
MpTb_L3_9_0 d2e_nb_0 gp_o_0_20 ctn_L3_9 0 NSYN W=10u L=1u
MpTa_L3_9_1 d2e_pb_1 gp_o_1_30 ctp_L3_9 0 NSYN W=10u L=1u
MnTb_L3_9_1 d2e_nb_1 vcn ctp_L3_9 0 NSYN W=10u L=1u
MnTa_L3_9_1 d2e_pb_1 vcn ctn_L3_9 0 NSYN W=10u L=1u
MpTb_L3_9_1 d2e_nb_1 gp_o_1_30 ctn_L3_9 0 NSYN W=10u L=1u
Msa_bk_L3_9 ctn_L3_9 ctn_L3_9 0 0 NMIR W=20u L=1u
Msb_bk_L3_9 dpre_L3_9 ctn_L3_9 0 0 NMIR W=20u L=1u
Msc_bk_L3_9 ctp_L3_9 ctp_L3_9 0 0 NMIR W=20u L=1u
Msd_bk_L3_9 dpf_bk_L3_9 ctp_L3_9 0 0 NMIR W=20u L=1u
Mse_bk_L3_9 dpf_bk_L3_9 dpf_bk_L3_9 vdd vdd PMIR W=60u L=1u
Msf_bk_L3_9 dpre_L3_9 dpf_bk_L3_9 vdd vdd PMIR W=60u L=1u
R_bk_L3_9 dpre_L3_9 vrefd 16000.0
MpTa_L3_10_0 d2e_pb_0 gp_o_0_5 ctp_L3_10 0 NSYN W=10u L=1u
MnTb_L3_10_0 d2e_nb_0 vcn ctp_L3_10 0 NSYN W=10u L=1u
MnTa_L3_10_0 d2e_pb_0 vcn ctn_L3_10 0 NSYN W=10u L=1u
MpTb_L3_10_0 d2e_nb_0 gp_o_0_5 ctn_L3_10 0 NSYN W=10u L=1u
MpTa_L3_10_1 d2e_pb_1 gp_o_1_44 ctp_L3_10 0 NSYN W=10u L=1u
MnTb_L3_10_1 d2e_nb_1 vcn ctp_L3_10 0 NSYN W=10u L=1u
MnTa_L3_10_1 d2e_pb_1 vcn ctn_L3_10 0 NSYN W=10u L=1u
MpTb_L3_10_1 d2e_nb_1 gp_o_1_44 ctn_L3_10 0 NSYN W=10u L=1u
Msa_bk_L3_10 ctn_L3_10 ctn_L3_10 0 0 NMIR W=20u L=1u
Msb_bk_L3_10 dpre_L3_10 ctn_L3_10 0 0 NMIR W=20u L=1u
Msc_bk_L3_10 ctp_L3_10 ctp_L3_10 0 0 NMIR W=20u L=1u
Msd_bk_L3_10 dpf_bk_L3_10 ctp_L3_10 0 0 NMIR W=20u L=1u
Mse_bk_L3_10 dpf_bk_L3_10 dpf_bk_L3_10 vdd vdd PMIR W=60u L=1u
Msf_bk_L3_10 dpre_L3_10 dpf_bk_L3_10 vdd vdd PMIR W=60u L=1u
R_bk_L3_10 dpre_L3_10 vrefd 16000.0
MpTa_L3_11_0 d2e_pb_0 gp_o_0_38 ctp_L3_11 0 NSYN W=10u L=1u
MnTb_L3_11_0 d2e_nb_0 vcn ctp_L3_11 0 NSYN W=10u L=1u
MnTa_L3_11_0 d2e_pb_0 vcn ctn_L3_11 0 NSYN W=10u L=1u
MpTb_L3_11_0 d2e_nb_0 gp_o_0_38 ctn_L3_11 0 NSYN W=10u L=1u
MpTa_L3_11_1 d2e_pb_1 gp_o_1_32 ctp_L3_11 0 NSYN W=10u L=1u
MnTb_L3_11_1 d2e_nb_1 vcn ctp_L3_11 0 NSYN W=10u L=1u
MnTa_L3_11_1 d2e_pb_1 vcn ctn_L3_11 0 NSYN W=10u L=1u
MpTb_L3_11_1 d2e_nb_1 gp_o_1_32 ctn_L3_11 0 NSYN W=10u L=1u
Msa_bk_L3_11 ctn_L3_11 ctn_L3_11 0 0 NMIR W=20u L=1u
Msb_bk_L3_11 dpre_L3_11 ctn_L3_11 0 0 NMIR W=20u L=1u
Msc_bk_L3_11 ctp_L3_11 ctp_L3_11 0 0 NMIR W=20u L=1u
Msd_bk_L3_11 dpf_bk_L3_11 ctp_L3_11 0 0 NMIR W=20u L=1u
Mse_bk_L3_11 dpf_bk_L3_11 dpf_bk_L3_11 vdd vdd PMIR W=60u L=1u
Msf_bk_L3_11 dpre_L3_11 dpf_bk_L3_11 vdd vdd PMIR W=60u L=1u
R_bk_L3_11 dpre_L3_11 vrefd 16000.0
MpTa_L3_12_0 d2e_pb_0 gp_o_0_22 ctp_L3_12 0 NSYN W=10u L=1u
MnTb_L3_12_0 d2e_nb_0 vcn ctp_L3_12 0 NSYN W=10u L=1u
MnTa_L3_12_0 d2e_pb_0 vcn ctn_L3_12 0 NSYN W=10u L=1u
MpTb_L3_12_0 d2e_nb_0 gp_o_0_22 ctn_L3_12 0 NSYN W=10u L=1u
MpTa_L3_12_1 d2e_pb_1 gp_o_1_4 ctp_L3_12 0 NSYN W=10u L=1u
MnTb_L3_12_1 d2e_nb_1 vcn ctp_L3_12 0 NSYN W=10u L=1u
MnTa_L3_12_1 d2e_pb_1 vcn ctn_L3_12 0 NSYN W=10u L=1u
MpTb_L3_12_1 d2e_nb_1 gp_o_1_4 ctn_L3_12 0 NSYN W=10u L=1u
Msa_bk_L3_12 ctn_L3_12 ctn_L3_12 0 0 NMIR W=20u L=1u
Msb_bk_L3_12 dpre_L3_12 ctn_L3_12 0 0 NMIR W=20u L=1u
Msc_bk_L3_12 ctp_L3_12 ctp_L3_12 0 0 NMIR W=20u L=1u
Msd_bk_L3_12 dpf_bk_L3_12 ctp_L3_12 0 0 NMIR W=20u L=1u
Mse_bk_L3_12 dpf_bk_L3_12 dpf_bk_L3_12 vdd vdd PMIR W=60u L=1u
Msf_bk_L3_12 dpre_L3_12 dpf_bk_L3_12 vdd vdd PMIR W=60u L=1u
R_bk_L3_12 dpre_L3_12 vrefd 16000.0
MpTa_L3_13_0 d2e_pb_0 gp_o_0_44 ctp_L3_13 0 NSYN W=10u L=1u
MnTb_L3_13_0 d2e_nb_0 vcn ctp_L3_13 0 NSYN W=10u L=1u
MnTa_L3_13_0 d2e_pb_0 vcn ctn_L3_13 0 NSYN W=10u L=1u
MpTb_L3_13_0 d2e_nb_0 gp_o_0_44 ctn_L3_13 0 NSYN W=10u L=1u
MpTa_L3_13_1 d2e_pb_1 gp_o_1_6 ctp_L3_13 0 NSYN W=10u L=1u
MnTb_L3_13_1 d2e_nb_1 vcn ctp_L3_13 0 NSYN W=10u L=1u
MnTa_L3_13_1 d2e_pb_1 vcn ctn_L3_13 0 NSYN W=10u L=1u
MpTb_L3_13_1 d2e_nb_1 gp_o_1_6 ctn_L3_13 0 NSYN W=10u L=1u
Msa_bk_L3_13 ctn_L3_13 ctn_L3_13 0 0 NMIR W=20u L=1u
Msb_bk_L3_13 dpre_L3_13 ctn_L3_13 0 0 NMIR W=20u L=1u
Msc_bk_L3_13 ctp_L3_13 ctp_L3_13 0 0 NMIR W=20u L=1u
Msd_bk_L3_13 dpf_bk_L3_13 ctp_L3_13 0 0 NMIR W=20u L=1u
Mse_bk_L3_13 dpf_bk_L3_13 dpf_bk_L3_13 vdd vdd PMIR W=60u L=1u
Msf_bk_L3_13 dpre_L3_13 dpf_bk_L3_13 vdd vdd PMIR W=60u L=1u
R_bk_L3_13 dpre_L3_13 vrefd 16000.0
MpTa_L3_14_0 d2e_pb_0 gp_o_0_17 ctp_L3_14 0 NSYN W=10u L=1u
MnTb_L3_14_0 d2e_nb_0 vcn ctp_L3_14 0 NSYN W=10u L=1u
MnTa_L3_14_0 d2e_pb_0 vcn ctn_L3_14 0 NSYN W=10u L=1u
MpTb_L3_14_0 d2e_nb_0 gp_o_0_17 ctn_L3_14 0 NSYN W=10u L=1u
MpTa_L3_14_1 d2e_pb_1 gp_o_1_35 ctp_L3_14 0 NSYN W=10u L=1u
MnTb_L3_14_1 d2e_nb_1 vcn ctp_L3_14 0 NSYN W=10u L=1u
MnTa_L3_14_1 d2e_pb_1 vcn ctn_L3_14 0 NSYN W=10u L=1u
MpTb_L3_14_1 d2e_nb_1 gp_o_1_35 ctn_L3_14 0 NSYN W=10u L=1u
Msa_bk_L3_14 ctn_L3_14 ctn_L3_14 0 0 NMIR W=20u L=1u
Msb_bk_L3_14 dpre_L3_14 ctn_L3_14 0 0 NMIR W=20u L=1u
Msc_bk_L3_14 ctp_L3_14 ctp_L3_14 0 0 NMIR W=20u L=1u
Msd_bk_L3_14 dpf_bk_L3_14 ctp_L3_14 0 0 NMIR W=20u L=1u
Mse_bk_L3_14 dpf_bk_L3_14 dpf_bk_L3_14 vdd vdd PMIR W=60u L=1u
Msf_bk_L3_14 dpre_L3_14 dpf_bk_L3_14 vdd vdd PMIR W=60u L=1u
R_bk_L3_14 dpre_L3_14 vrefd 16000.0
MpTa_L3_15_0 d2e_pb_0 gp_o_0_15 ctp_L3_15 0 NSYN W=10u L=1u
MnTb_L3_15_0 d2e_nb_0 vcn ctp_L3_15 0 NSYN W=10u L=1u
MnTa_L3_15_0 d2e_pb_0 vcn ctn_L3_15 0 NSYN W=10u L=1u
MpTb_L3_15_0 d2e_nb_0 gp_o_0_15 ctn_L3_15 0 NSYN W=10u L=1u
MpTa_L3_15_1 d2e_pb_1 gp_o_1_5 ctp_L3_15 0 NSYN W=10u L=1u
MnTb_L3_15_1 d2e_nb_1 vcn ctp_L3_15 0 NSYN W=10u L=1u
MnTa_L3_15_1 d2e_pb_1 vcn ctn_L3_15 0 NSYN W=10u L=1u
MpTb_L3_15_1 d2e_nb_1 gp_o_1_5 ctn_L3_15 0 NSYN W=10u L=1u
Msa_bk_L3_15 ctn_L3_15 ctn_L3_15 0 0 NMIR W=20u L=1u
Msb_bk_L3_15 dpre_L3_15 ctn_L3_15 0 0 NMIR W=20u L=1u
Msc_bk_L3_15 ctp_L3_15 ctp_L3_15 0 0 NMIR W=20u L=1u
Msd_bk_L3_15 dpf_bk_L3_15 ctp_L3_15 0 0 NMIR W=20u L=1u
Mse_bk_L3_15 dpf_bk_L3_15 dpf_bk_L3_15 vdd vdd PMIR W=60u L=1u
Msf_bk_L3_15 dpre_L3_15 dpf_bk_L3_15 vdd vdd PMIR W=60u L=1u
R_bk_L3_15 dpre_L3_15 vrefd 16000.0
MpTa_L3_16_0 d2e_pb_0 gp_o_0_10 ctp_L3_16 0 NSYN W=10u L=1u
MnTb_L3_16_0 d2e_nb_0 vcn ctp_L3_16 0 NSYN W=10u L=1u
MnTa_L3_16_0 d2e_pb_0 vcn ctn_L3_16 0 NSYN W=10u L=1u
MpTb_L3_16_0 d2e_nb_0 gp_o_0_10 ctn_L3_16 0 NSYN W=10u L=1u
MpTa_L3_16_1 d2e_pb_1 gp_o_1_38 ctp_L3_16 0 NSYN W=10u L=1u
MnTb_L3_16_1 d2e_nb_1 vcn ctp_L3_16 0 NSYN W=10u L=1u
MnTa_L3_16_1 d2e_pb_1 vcn ctn_L3_16 0 NSYN W=10u L=1u
MpTb_L3_16_1 d2e_nb_1 gp_o_1_38 ctn_L3_16 0 NSYN W=10u L=1u
Msa_bk_L3_16 ctn_L3_16 ctn_L3_16 0 0 NMIR W=20u L=1u
Msb_bk_L3_16 dpre_L3_16 ctn_L3_16 0 0 NMIR W=20u L=1u
Msc_bk_L3_16 ctp_L3_16 ctp_L3_16 0 0 NMIR W=20u L=1u
Msd_bk_L3_16 dpf_bk_L3_16 ctp_L3_16 0 0 NMIR W=20u L=1u
Mse_bk_L3_16 dpf_bk_L3_16 dpf_bk_L3_16 vdd vdd PMIR W=60u L=1u
Msf_bk_L3_16 dpre_L3_16 dpf_bk_L3_16 vdd vdd PMIR W=60u L=1u
R_bk_L3_16 dpre_L3_16 vrefd 16000.0
MpTa_L3_17_0 d2e_pb_0 gp_o_0_8 ctp_L3_17 0 NSYN W=10u L=1u
MnTb_L3_17_0 d2e_nb_0 vcn ctp_L3_17 0 NSYN W=10u L=1u
MnTa_L3_17_0 d2e_pb_0 vcn ctn_L3_17 0 NSYN W=10u L=1u
MpTb_L3_17_0 d2e_nb_0 gp_o_0_8 ctn_L3_17 0 NSYN W=10u L=1u
MpTa_L3_17_1 d2e_pb_1 gp_o_1_34 ctp_L3_17 0 NSYN W=10u L=1u
MnTb_L3_17_1 d2e_nb_1 vcn ctp_L3_17 0 NSYN W=10u L=1u
MnTa_L3_17_1 d2e_pb_1 vcn ctn_L3_17 0 NSYN W=10u L=1u
MpTb_L3_17_1 d2e_nb_1 gp_o_1_34 ctn_L3_17 0 NSYN W=10u L=1u
Msa_bk_L3_17 ctn_L3_17 ctn_L3_17 0 0 NMIR W=20u L=1u
Msb_bk_L3_17 dpre_L3_17 ctn_L3_17 0 0 NMIR W=20u L=1u
Msc_bk_L3_17 ctp_L3_17 ctp_L3_17 0 0 NMIR W=20u L=1u
Msd_bk_L3_17 dpf_bk_L3_17 ctp_L3_17 0 0 NMIR W=20u L=1u
Mse_bk_L3_17 dpf_bk_L3_17 dpf_bk_L3_17 vdd vdd PMIR W=60u L=1u
Msf_bk_L3_17 dpre_L3_17 dpf_bk_L3_17 vdd vdd PMIR W=60u L=1u
R_bk_L3_17 dpre_L3_17 vrefd 16000.0
MpTa_L3_18_0 d2e_pb_0 gp_o_0_35 ctp_L3_18 0 NSYN W=10u L=1u
MnTb_L3_18_0 d2e_nb_0 vcn ctp_L3_18 0 NSYN W=10u L=1u
MnTa_L3_18_0 d2e_pb_0 vcn ctn_L3_18 0 NSYN W=10u L=1u
MpTb_L3_18_0 d2e_nb_0 gp_o_0_35 ctn_L3_18 0 NSYN W=10u L=1u
MpTa_L3_18_1 d2e_pb_1 gp_o_1_45 ctp_L3_18 0 NSYN W=10u L=1u
MnTb_L3_18_1 d2e_nb_1 vcn ctp_L3_18 0 NSYN W=10u L=1u
MnTa_L3_18_1 d2e_pb_1 vcn ctn_L3_18 0 NSYN W=10u L=1u
MpTb_L3_18_1 d2e_nb_1 gp_o_1_45 ctn_L3_18 0 NSYN W=10u L=1u
Msa_bk_L3_18 ctn_L3_18 ctn_L3_18 0 0 NMIR W=20u L=1u
Msb_bk_L3_18 dpre_L3_18 ctn_L3_18 0 0 NMIR W=20u L=1u
Msc_bk_L3_18 ctp_L3_18 ctp_L3_18 0 0 NMIR W=20u L=1u
Msd_bk_L3_18 dpf_bk_L3_18 ctp_L3_18 0 0 NMIR W=20u L=1u
Mse_bk_L3_18 dpf_bk_L3_18 dpf_bk_L3_18 vdd vdd PMIR W=60u L=1u
Msf_bk_L3_18 dpre_L3_18 dpf_bk_L3_18 vdd vdd PMIR W=60u L=1u
R_bk_L3_18 dpre_L3_18 vrefd 16000.0
MpTa_L3_19_0 d2e_pb_0 gp_o_0_9 ctp_L3_19 0 NSYN W=10u L=1u
MnTb_L3_19_0 d2e_nb_0 vcn ctp_L3_19 0 NSYN W=10u L=1u
MnTa_L3_19_0 d2e_pb_0 vcn ctn_L3_19 0 NSYN W=10u L=1u
MpTb_L3_19_0 d2e_nb_0 gp_o_0_9 ctn_L3_19 0 NSYN W=10u L=1u
MpTa_L3_19_1 d2e_pb_1 gp_o_1_22 ctp_L3_19 0 NSYN W=10u L=1u
MnTb_L3_19_1 d2e_nb_1 vcn ctp_L3_19 0 NSYN W=10u L=1u
MnTa_L3_19_1 d2e_pb_1 vcn ctn_L3_19 0 NSYN W=10u L=1u
MpTb_L3_19_1 d2e_nb_1 gp_o_1_22 ctn_L3_19 0 NSYN W=10u L=1u
Msa_bk_L3_19 ctn_L3_19 ctn_L3_19 0 0 NMIR W=20u L=1u
Msb_bk_L3_19 dpre_L3_19 ctn_L3_19 0 0 NMIR W=20u L=1u
Msc_bk_L3_19 ctp_L3_19 ctp_L3_19 0 0 NMIR W=20u L=1u
Msd_bk_L3_19 dpf_bk_L3_19 ctp_L3_19 0 0 NMIR W=20u L=1u
Mse_bk_L3_19 dpf_bk_L3_19 dpf_bk_L3_19 vdd vdd PMIR W=60u L=1u
Msf_bk_L3_19 dpre_L3_19 dpf_bk_L3_19 vdd vdd PMIR W=60u L=1u
R_bk_L3_19 dpre_L3_19 vrefd 16000.0
MpTa_L3_20_0 d2e_pb_0 gp_o_0_45 ctp_L3_20 0 NSYN W=10u L=1u
MnTb_L3_20_0 d2e_nb_0 vcn ctp_L3_20 0 NSYN W=10u L=1u
MnTa_L3_20_0 d2e_pb_0 vcn ctn_L3_20 0 NSYN W=10u L=1u
MpTb_L3_20_0 d2e_nb_0 gp_o_0_45 ctn_L3_20 0 NSYN W=10u L=1u
MpTa_L3_20_1 d2e_pb_1 gp_o_1_40 ctp_L3_20 0 NSYN W=10u L=1u
MnTb_L3_20_1 d2e_nb_1 vcn ctp_L3_20 0 NSYN W=10u L=1u
MnTa_L3_20_1 d2e_pb_1 vcn ctn_L3_20 0 NSYN W=10u L=1u
MpTb_L3_20_1 d2e_nb_1 gp_o_1_40 ctn_L3_20 0 NSYN W=10u L=1u
Msa_bk_L3_20 ctn_L3_20 ctn_L3_20 0 0 NMIR W=20u L=1u
Msb_bk_L3_20 dpre_L3_20 ctn_L3_20 0 0 NMIR W=20u L=1u
Msc_bk_L3_20 ctp_L3_20 ctp_L3_20 0 0 NMIR W=20u L=1u
Msd_bk_L3_20 dpf_bk_L3_20 ctp_L3_20 0 0 NMIR W=20u L=1u
Mse_bk_L3_20 dpf_bk_L3_20 dpf_bk_L3_20 vdd vdd PMIR W=60u L=1u
Msf_bk_L3_20 dpre_L3_20 dpf_bk_L3_20 vdd vdd PMIR W=60u L=1u
R_bk_L3_20 dpre_L3_20 vrefd 16000.0
MpTa_L3_21_0 d2e_pb_0 gp_o_0_7 ctp_L3_21 0 NSYN W=10u L=1u
MnTb_L3_21_0 d2e_nb_0 vcn ctp_L3_21 0 NSYN W=10u L=1u
MnTa_L3_21_0 d2e_pb_0 vcn ctn_L3_21 0 NSYN W=10u L=1u
MpTb_L3_21_0 d2e_nb_0 gp_o_0_7 ctn_L3_21 0 NSYN W=10u L=1u
MpTa_L3_21_1 d2e_pb_1 gp_o_1_18 ctp_L3_21 0 NSYN W=10u L=1u
MnTb_L3_21_1 d2e_nb_1 vcn ctp_L3_21 0 NSYN W=10u L=1u
MnTa_L3_21_1 d2e_pb_1 vcn ctn_L3_21 0 NSYN W=10u L=1u
MpTb_L3_21_1 d2e_nb_1 gp_o_1_18 ctn_L3_21 0 NSYN W=10u L=1u
Msa_bk_L3_21 ctn_L3_21 ctn_L3_21 0 0 NMIR W=20u L=1u
Msb_bk_L3_21 dpre_L3_21 ctn_L3_21 0 0 NMIR W=20u L=1u
Msc_bk_L3_21 ctp_L3_21 ctp_L3_21 0 0 NMIR W=20u L=1u
Msd_bk_L3_21 dpf_bk_L3_21 ctp_L3_21 0 0 NMIR W=20u L=1u
Mse_bk_L3_21 dpf_bk_L3_21 dpf_bk_L3_21 vdd vdd PMIR W=60u L=1u
Msf_bk_L3_21 dpre_L3_21 dpf_bk_L3_21 vdd vdd PMIR W=60u L=1u
R_bk_L3_21 dpre_L3_21 vrefd 16000.0
MpTa_L3_22_0 d2e_pb_0 gp_o_0_26 ctp_L3_22 0 NSYN W=10u L=1u
MnTb_L3_22_0 d2e_nb_0 vcn ctp_L3_22 0 NSYN W=10u L=1u
MnTa_L3_22_0 d2e_pb_0 vcn ctn_L3_22 0 NSYN W=10u L=1u
MpTb_L3_22_0 d2e_nb_0 gp_o_0_26 ctn_L3_22 0 NSYN W=10u L=1u
MpTa_L3_22_1 d2e_pb_1 gp_o_1_21 ctp_L3_22 0 NSYN W=10u L=1u
MnTb_L3_22_1 d2e_nb_1 vcn ctp_L3_22 0 NSYN W=10u L=1u
MnTa_L3_22_1 d2e_pb_1 vcn ctn_L3_22 0 NSYN W=10u L=1u
MpTb_L3_22_1 d2e_nb_1 gp_o_1_21 ctn_L3_22 0 NSYN W=10u L=1u
Msa_bk_L3_22 ctn_L3_22 ctn_L3_22 0 0 NMIR W=20u L=1u
Msb_bk_L3_22 dpre_L3_22 ctn_L3_22 0 0 NMIR W=20u L=1u
Msc_bk_L3_22 ctp_L3_22 ctp_L3_22 0 0 NMIR W=20u L=1u
Msd_bk_L3_22 dpf_bk_L3_22 ctp_L3_22 0 0 NMIR W=20u L=1u
Mse_bk_L3_22 dpf_bk_L3_22 dpf_bk_L3_22 vdd vdd PMIR W=60u L=1u
Msf_bk_L3_22 dpre_L3_22 dpf_bk_L3_22 vdd vdd PMIR W=60u L=1u
R_bk_L3_22 dpre_L3_22 vrefd 16000.0
MpTa_L3_23_0 d2e_pb_0 gp_o_0_39 ctp_L3_23 0 NSYN W=10u L=1u
MnTb_L3_23_0 d2e_nb_0 vcn ctp_L3_23 0 NSYN W=10u L=1u
MnTa_L3_23_0 d2e_pb_0 vcn ctn_L3_23 0 NSYN W=10u L=1u
MpTb_L3_23_0 d2e_nb_0 gp_o_0_39 ctn_L3_23 0 NSYN W=10u L=1u
MpTa_L3_23_1 d2e_pb_1 gp_o_1_33 ctp_L3_23 0 NSYN W=10u L=1u
MnTb_L3_23_1 d2e_nb_1 vcn ctp_L3_23 0 NSYN W=10u L=1u
MnTa_L3_23_1 d2e_pb_1 vcn ctn_L3_23 0 NSYN W=10u L=1u
MpTb_L3_23_1 d2e_nb_1 gp_o_1_33 ctn_L3_23 0 NSYN W=10u L=1u
Msa_bk_L3_23 ctn_L3_23 ctn_L3_23 0 0 NMIR W=20u L=1u
Msb_bk_L3_23 dpre_L3_23 ctn_L3_23 0 0 NMIR W=20u L=1u
Msc_bk_L3_23 ctp_L3_23 ctp_L3_23 0 0 NMIR W=20u L=1u
Msd_bk_L3_23 dpf_bk_L3_23 ctp_L3_23 0 0 NMIR W=20u L=1u
Mse_bk_L3_23 dpf_bk_L3_23 dpf_bk_L3_23 vdd vdd PMIR W=60u L=1u
Msf_bk_L3_23 dpre_L3_23 dpf_bk_L3_23 vdd vdd PMIR W=60u L=1u
R_bk_L3_23 dpre_L3_23 vrefd 16000.0
MpTa_L3_24_0 d2e_pb_0 gp_o_0_41 ctp_L3_24 0 NSYN W=10u L=1u
MnTb_L3_24_0 d2e_nb_0 vcn ctp_L3_24 0 NSYN W=10u L=1u
MnTa_L3_24_0 d2e_pb_0 vcn ctn_L3_24 0 NSYN W=10u L=1u
MpTb_L3_24_0 d2e_nb_0 gp_o_0_41 ctn_L3_24 0 NSYN W=10u L=1u
MpTa_L3_24_1 d2e_pb_1 gp_o_1_28 ctp_L3_24 0 NSYN W=10u L=1u
MnTb_L3_24_1 d2e_nb_1 vcn ctp_L3_24 0 NSYN W=10u L=1u
MnTa_L3_24_1 d2e_pb_1 vcn ctn_L3_24 0 NSYN W=10u L=1u
MpTb_L3_24_1 d2e_nb_1 gp_o_1_28 ctn_L3_24 0 NSYN W=10u L=1u
Msa_bk_L3_24 ctn_L3_24 ctn_L3_24 0 0 NMIR W=20u L=1u
Msb_bk_L3_24 dpre_L3_24 ctn_L3_24 0 0 NMIR W=20u L=1u
Msc_bk_L3_24 ctp_L3_24 ctp_L3_24 0 0 NMIR W=20u L=1u
Msd_bk_L3_24 dpf_bk_L3_24 ctp_L3_24 0 0 NMIR W=20u L=1u
Mse_bk_L3_24 dpf_bk_L3_24 dpf_bk_L3_24 vdd vdd PMIR W=60u L=1u
Msf_bk_L3_24 dpre_L3_24 dpf_bk_L3_24 vdd vdd PMIR W=60u L=1u
R_bk_L3_24 dpre_L3_24 vrefd 16000.0
MpTa_L3_25_0 d2e_pb_0 gp_o_0_11 ctp_L3_25 0 NSYN W=10u L=1u
MnTb_L3_25_0 d2e_nb_0 vcn ctp_L3_25 0 NSYN W=10u L=1u
MnTa_L3_25_0 d2e_pb_0 vcn ctn_L3_25 0 NSYN W=10u L=1u
MpTb_L3_25_0 d2e_nb_0 gp_o_0_11 ctn_L3_25 0 NSYN W=10u L=1u
MpTa_L3_25_1 d2e_pb_1 gp_o_1_13 ctp_L3_25 0 NSYN W=10u L=1u
MnTb_L3_25_1 d2e_nb_1 vcn ctp_L3_25 0 NSYN W=10u L=1u
MnTa_L3_25_1 d2e_pb_1 vcn ctn_L3_25 0 NSYN W=10u L=1u
MpTb_L3_25_1 d2e_nb_1 gp_o_1_13 ctn_L3_25 0 NSYN W=10u L=1u
Msa_bk_L3_25 ctn_L3_25 ctn_L3_25 0 0 NMIR W=20u L=1u
Msb_bk_L3_25 dpre_L3_25 ctn_L3_25 0 0 NMIR W=20u L=1u
Msc_bk_L3_25 ctp_L3_25 ctp_L3_25 0 0 NMIR W=20u L=1u
Msd_bk_L3_25 dpf_bk_L3_25 ctp_L3_25 0 0 NMIR W=20u L=1u
Mse_bk_L3_25 dpf_bk_L3_25 dpf_bk_L3_25 vdd vdd PMIR W=60u L=1u
Msf_bk_L3_25 dpre_L3_25 dpf_bk_L3_25 vdd vdd PMIR W=60u L=1u
R_bk_L3_25 dpre_L3_25 vrefd 16000.0
MpTa_L3_26_0 d2e_pb_0 gp_o_0_18 ctp_L3_26 0 NSYN W=10u L=1u
MnTb_L3_26_0 d2e_nb_0 vcn ctp_L3_26 0 NSYN W=10u L=1u
MnTa_L3_26_0 d2e_pb_0 vcn ctn_L3_26 0 NSYN W=10u L=1u
MpTb_L3_26_0 d2e_nb_0 gp_o_0_18 ctn_L3_26 0 NSYN W=10u L=1u
MpTa_L3_26_1 d2e_pb_1 gp_o_1_47 ctp_L3_26 0 NSYN W=10u L=1u
MnTb_L3_26_1 d2e_nb_1 vcn ctp_L3_26 0 NSYN W=10u L=1u
MnTa_L3_26_1 d2e_pb_1 vcn ctn_L3_26 0 NSYN W=10u L=1u
MpTb_L3_26_1 d2e_nb_1 gp_o_1_47 ctn_L3_26 0 NSYN W=10u L=1u
Msa_bk_L3_26 ctn_L3_26 ctn_L3_26 0 0 NMIR W=20u L=1u
Msb_bk_L3_26 dpre_L3_26 ctn_L3_26 0 0 NMIR W=20u L=1u
Msc_bk_L3_26 ctp_L3_26 ctp_L3_26 0 0 NMIR W=20u L=1u
Msd_bk_L3_26 dpf_bk_L3_26 ctp_L3_26 0 0 NMIR W=20u L=1u
Mse_bk_L3_26 dpf_bk_L3_26 dpf_bk_L3_26 vdd vdd PMIR W=60u L=1u
Msf_bk_L3_26 dpre_L3_26 dpf_bk_L3_26 vdd vdd PMIR W=60u L=1u
R_bk_L3_26 dpre_L3_26 vrefd 16000.0
MpTa_L3_27_0 d2e_pb_0 gp_o_0_43 ctp_L3_27 0 NSYN W=10u L=1u
MnTb_L3_27_0 d2e_nb_0 vcn ctp_L3_27 0 NSYN W=10u L=1u
MnTa_L3_27_0 d2e_pb_0 vcn ctn_L3_27 0 NSYN W=10u L=1u
MpTb_L3_27_0 d2e_nb_0 gp_o_0_43 ctn_L3_27 0 NSYN W=10u L=1u
MpTa_L3_27_1 d2e_pb_1 gp_o_1_3 ctp_L3_27 0 NSYN W=10u L=1u
MnTb_L3_27_1 d2e_nb_1 vcn ctp_L3_27 0 NSYN W=10u L=1u
MnTa_L3_27_1 d2e_pb_1 vcn ctn_L3_27 0 NSYN W=10u L=1u
MpTb_L3_27_1 d2e_nb_1 gp_o_1_3 ctn_L3_27 0 NSYN W=10u L=1u
Msa_bk_L3_27 ctn_L3_27 ctn_L3_27 0 0 NMIR W=20u L=1u
Msb_bk_L3_27 dpre_L3_27 ctn_L3_27 0 0 NMIR W=20u L=1u
Msc_bk_L3_27 ctp_L3_27 ctp_L3_27 0 0 NMIR W=20u L=1u
Msd_bk_L3_27 dpf_bk_L3_27 ctp_L3_27 0 0 NMIR W=20u L=1u
Mse_bk_L3_27 dpf_bk_L3_27 dpf_bk_L3_27 vdd vdd PMIR W=60u L=1u
Msf_bk_L3_27 dpre_L3_27 dpf_bk_L3_27 vdd vdd PMIR W=60u L=1u
R_bk_L3_27 dpre_L3_27 vrefd 16000.0
MpTa_L3_28_0 d2e_pb_0 gp_o_0_6 ctp_L3_28 0 NSYN W=10u L=1u
MnTb_L3_28_0 d2e_nb_0 vcn ctp_L3_28 0 NSYN W=10u L=1u
MnTa_L3_28_0 d2e_pb_0 vcn ctn_L3_28 0 NSYN W=10u L=1u
MpTb_L3_28_0 d2e_nb_0 gp_o_0_6 ctn_L3_28 0 NSYN W=10u L=1u
MpTa_L3_28_1 d2e_pb_1 gp_o_1_39 ctp_L3_28 0 NSYN W=10u L=1u
MnTb_L3_28_1 d2e_nb_1 vcn ctp_L3_28 0 NSYN W=10u L=1u
MnTa_L3_28_1 d2e_pb_1 vcn ctn_L3_28 0 NSYN W=10u L=1u
MpTb_L3_28_1 d2e_nb_1 gp_o_1_39 ctn_L3_28 0 NSYN W=10u L=1u
Msa_bk_L3_28 ctn_L3_28 ctn_L3_28 0 0 NMIR W=20u L=1u
Msb_bk_L3_28 dpre_L3_28 ctn_L3_28 0 0 NMIR W=20u L=1u
Msc_bk_L3_28 ctp_L3_28 ctp_L3_28 0 0 NMIR W=20u L=1u
Msd_bk_L3_28 dpf_bk_L3_28 ctp_L3_28 0 0 NMIR W=20u L=1u
Mse_bk_L3_28 dpf_bk_L3_28 dpf_bk_L3_28 vdd vdd PMIR W=60u L=1u
Msf_bk_L3_28 dpre_L3_28 dpf_bk_L3_28 vdd vdd PMIR W=60u L=1u
R_bk_L3_28 dpre_L3_28 vrefd 16000.0
MpTa_L3_29_0 d2e_pb_0 gp_o_0_24 ctp_L3_29 0 NSYN W=10u L=1u
MnTb_L3_29_0 d2e_nb_0 vcn ctp_L3_29 0 NSYN W=10u L=1u
MnTa_L3_29_0 d2e_pb_0 vcn ctn_L3_29 0 NSYN W=10u L=1u
MpTb_L3_29_0 d2e_nb_0 gp_o_0_24 ctn_L3_29 0 NSYN W=10u L=1u
MpTa_L3_29_1 d2e_pb_1 gp_o_1_10 ctp_L3_29 0 NSYN W=10u L=1u
MnTb_L3_29_1 d2e_nb_1 vcn ctp_L3_29 0 NSYN W=10u L=1u
MnTa_L3_29_1 d2e_pb_1 vcn ctn_L3_29 0 NSYN W=10u L=1u
MpTb_L3_29_1 d2e_nb_1 gp_o_1_10 ctn_L3_29 0 NSYN W=10u L=1u
Msa_bk_L3_29 ctn_L3_29 ctn_L3_29 0 0 NMIR W=20u L=1u
Msb_bk_L3_29 dpre_L3_29 ctn_L3_29 0 0 NMIR W=20u L=1u
Msc_bk_L3_29 ctp_L3_29 ctp_L3_29 0 0 NMIR W=20u L=1u
Msd_bk_L3_29 dpf_bk_L3_29 ctp_L3_29 0 0 NMIR W=20u L=1u
Mse_bk_L3_29 dpf_bk_L3_29 dpf_bk_L3_29 vdd vdd PMIR W=60u L=1u
Msf_bk_L3_29 dpre_L3_29 dpf_bk_L3_29 vdd vdd PMIR W=60u L=1u
R_bk_L3_29 dpre_L3_29 vrefd 16000.0
MpTa_L3_30_0 d2e_pb_0 gp_o_0_1 ctp_L3_30 0 NSYN W=10u L=1u
MnTb_L3_30_0 d2e_nb_0 vcn ctp_L3_30 0 NSYN W=10u L=1u
MnTa_L3_30_0 d2e_pb_0 vcn ctn_L3_30 0 NSYN W=10u L=1u
MpTb_L3_30_0 d2e_nb_0 gp_o_0_1 ctn_L3_30 0 NSYN W=10u L=1u
MpTa_L3_30_1 d2e_pb_1 gp_o_1_7 ctp_L3_30 0 NSYN W=10u L=1u
MnTb_L3_30_1 d2e_nb_1 vcn ctp_L3_30 0 NSYN W=10u L=1u
MnTa_L3_30_1 d2e_pb_1 vcn ctn_L3_30 0 NSYN W=10u L=1u
MpTb_L3_30_1 d2e_nb_1 gp_o_1_7 ctn_L3_30 0 NSYN W=10u L=1u
Msa_bk_L3_30 ctn_L3_30 ctn_L3_30 0 0 NMIR W=20u L=1u
Msb_bk_L3_30 dpre_L3_30 ctn_L3_30 0 0 NMIR W=20u L=1u
Msc_bk_L3_30 ctp_L3_30 ctp_L3_30 0 0 NMIR W=20u L=1u
Msd_bk_L3_30 dpf_bk_L3_30 ctp_L3_30 0 0 NMIR W=20u L=1u
Mse_bk_L3_30 dpf_bk_L3_30 dpf_bk_L3_30 vdd vdd PMIR W=60u L=1u
Msf_bk_L3_30 dpre_L3_30 dpf_bk_L3_30 vdd vdd PMIR W=60u L=1u
R_bk_L3_30 dpre_L3_30 vrefd 16000.0
MpTa_L3_31_0 d2e_pb_0 gp_o_0_34 ctp_L3_31 0 NSYN W=10u L=1u
MnTb_L3_31_0 d2e_nb_0 vcn ctp_L3_31 0 NSYN W=10u L=1u
MnTa_L3_31_0 d2e_pb_0 vcn ctn_L3_31 0 NSYN W=10u L=1u
MpTb_L3_31_0 d2e_nb_0 gp_o_0_34 ctn_L3_31 0 NSYN W=10u L=1u
MpTa_L3_31_1 d2e_pb_1 gp_o_1_2 ctp_L3_31 0 NSYN W=10u L=1u
MnTb_L3_31_1 d2e_nb_1 vcn ctp_L3_31 0 NSYN W=10u L=1u
MnTa_L3_31_1 d2e_pb_1 vcn ctn_L3_31 0 NSYN W=10u L=1u
MpTb_L3_31_1 d2e_nb_1 gp_o_1_2 ctn_L3_31 0 NSYN W=10u L=1u
Msa_bk_L3_31 ctn_L3_31 ctn_L3_31 0 0 NMIR W=20u L=1u
Msb_bk_L3_31 dpre_L3_31 ctn_L3_31 0 0 NMIR W=20u L=1u
Msc_bk_L3_31 ctp_L3_31 ctp_L3_31 0 0 NMIR W=20u L=1u
Msd_bk_L3_31 dpf_bk_L3_31 ctp_L3_31 0 0 NMIR W=20u L=1u
Mse_bk_L3_31 dpf_bk_L3_31 dpf_bk_L3_31 vdd vdd PMIR W=60u L=1u
Msf_bk_L3_31 dpre_L3_31 dpf_bk_L3_31 vdd vdd PMIR W=60u L=1u
R_bk_L3_31 dpre_L3_31 vrefd 16000.0
MpTa_L3_32_0 d2e_pb_0 gp_o_0_31 ctp_L3_32 0 NSYN W=10u L=1u
MnTb_L3_32_0 d2e_nb_0 vcn ctp_L3_32 0 NSYN W=10u L=1u
MnTa_L3_32_0 d2e_pb_0 vcn ctn_L3_32 0 NSYN W=10u L=1u
MpTb_L3_32_0 d2e_nb_0 gp_o_0_31 ctn_L3_32 0 NSYN W=10u L=1u
MpTa_L3_32_1 d2e_pb_1 gp_o_1_25 ctp_L3_32 0 NSYN W=10u L=1u
MnTb_L3_32_1 d2e_nb_1 vcn ctp_L3_32 0 NSYN W=10u L=1u
MnTa_L3_32_1 d2e_pb_1 vcn ctn_L3_32 0 NSYN W=10u L=1u
MpTb_L3_32_1 d2e_nb_1 gp_o_1_25 ctn_L3_32 0 NSYN W=10u L=1u
Msa_bk_L3_32 ctn_L3_32 ctn_L3_32 0 0 NMIR W=20u L=1u
Msb_bk_L3_32 dpre_L3_32 ctn_L3_32 0 0 NMIR W=20u L=1u
Msc_bk_L3_32 ctp_L3_32 ctp_L3_32 0 0 NMIR W=20u L=1u
Msd_bk_L3_32 dpf_bk_L3_32 ctp_L3_32 0 0 NMIR W=20u L=1u
Mse_bk_L3_32 dpf_bk_L3_32 dpf_bk_L3_32 vdd vdd PMIR W=60u L=1u
Msf_bk_L3_32 dpre_L3_32 dpf_bk_L3_32 vdd vdd PMIR W=60u L=1u
R_bk_L3_32 dpre_L3_32 vrefd 16000.0
MpTa_L3_33_0 d2e_pb_0 gp_o_0_23 ctp_L3_33 0 NSYN W=10u L=1u
MnTb_L3_33_0 d2e_nb_0 vcn ctp_L3_33 0 NSYN W=10u L=1u
MnTa_L3_33_0 d2e_pb_0 vcn ctn_L3_33 0 NSYN W=10u L=1u
MpTb_L3_33_0 d2e_nb_0 gp_o_0_23 ctn_L3_33 0 NSYN W=10u L=1u
MpTa_L3_33_1 d2e_pb_1 gp_o_1_14 ctp_L3_33 0 NSYN W=10u L=1u
MnTb_L3_33_1 d2e_nb_1 vcn ctp_L3_33 0 NSYN W=10u L=1u
MnTa_L3_33_1 d2e_pb_1 vcn ctn_L3_33 0 NSYN W=10u L=1u
MpTb_L3_33_1 d2e_nb_1 gp_o_1_14 ctn_L3_33 0 NSYN W=10u L=1u
Msa_bk_L3_33 ctn_L3_33 ctn_L3_33 0 0 NMIR W=20u L=1u
Msb_bk_L3_33 dpre_L3_33 ctn_L3_33 0 0 NMIR W=20u L=1u
Msc_bk_L3_33 ctp_L3_33 ctp_L3_33 0 0 NMIR W=20u L=1u
Msd_bk_L3_33 dpf_bk_L3_33 ctp_L3_33 0 0 NMIR W=20u L=1u
Mse_bk_L3_33 dpf_bk_L3_33 dpf_bk_L3_33 vdd vdd PMIR W=60u L=1u
Msf_bk_L3_33 dpre_L3_33 dpf_bk_L3_33 vdd vdd PMIR W=60u L=1u
R_bk_L3_33 dpre_L3_33 vrefd 16000.0
MpTa_L3_34_0 d2e_pb_0 gp_o_0_27 ctp_L3_34 0 NSYN W=10u L=1u
MnTb_L3_34_0 d2e_nb_0 vcn ctp_L3_34 0 NSYN W=10u L=1u
MnTa_L3_34_0 d2e_pb_0 vcn ctn_L3_34 0 NSYN W=10u L=1u
MpTb_L3_34_0 d2e_nb_0 gp_o_0_27 ctn_L3_34 0 NSYN W=10u L=1u
MpTa_L3_34_1 d2e_pb_1 gp_o_1_16 ctp_L3_34 0 NSYN W=10u L=1u
MnTb_L3_34_1 d2e_nb_1 vcn ctp_L3_34 0 NSYN W=10u L=1u
MnTa_L3_34_1 d2e_pb_1 vcn ctn_L3_34 0 NSYN W=10u L=1u
MpTb_L3_34_1 d2e_nb_1 gp_o_1_16 ctn_L3_34 0 NSYN W=10u L=1u
Msa_bk_L3_34 ctn_L3_34 ctn_L3_34 0 0 NMIR W=20u L=1u
Msb_bk_L3_34 dpre_L3_34 ctn_L3_34 0 0 NMIR W=20u L=1u
Msc_bk_L3_34 ctp_L3_34 ctp_L3_34 0 0 NMIR W=20u L=1u
Msd_bk_L3_34 dpf_bk_L3_34 ctp_L3_34 0 0 NMIR W=20u L=1u
Mse_bk_L3_34 dpf_bk_L3_34 dpf_bk_L3_34 vdd vdd PMIR W=60u L=1u
Msf_bk_L3_34 dpre_L3_34 dpf_bk_L3_34 vdd vdd PMIR W=60u L=1u
R_bk_L3_34 dpre_L3_34 vrefd 16000.0
MpTa_L3_35_0 d2e_pb_0 gp_o_0_42 ctp_L3_35 0 NSYN W=10u L=1u
MnTb_L3_35_0 d2e_nb_0 vcn ctp_L3_35 0 NSYN W=10u L=1u
MnTa_L3_35_0 d2e_pb_0 vcn ctn_L3_35 0 NSYN W=10u L=1u
MpTb_L3_35_0 d2e_nb_0 gp_o_0_42 ctn_L3_35 0 NSYN W=10u L=1u
MpTa_L3_35_1 d2e_pb_1 gp_o_1_41 ctp_L3_35 0 NSYN W=10u L=1u
MnTb_L3_35_1 d2e_nb_1 vcn ctp_L3_35 0 NSYN W=10u L=1u
MnTa_L3_35_1 d2e_pb_1 vcn ctn_L3_35 0 NSYN W=10u L=1u
MpTb_L3_35_1 d2e_nb_1 gp_o_1_41 ctn_L3_35 0 NSYN W=10u L=1u
Msa_bk_L3_35 ctn_L3_35 ctn_L3_35 0 0 NMIR W=20u L=1u
Msb_bk_L3_35 dpre_L3_35 ctn_L3_35 0 0 NMIR W=20u L=1u
Msc_bk_L3_35 ctp_L3_35 ctp_L3_35 0 0 NMIR W=20u L=1u
Msd_bk_L3_35 dpf_bk_L3_35 ctp_L3_35 0 0 NMIR W=20u L=1u
Mse_bk_L3_35 dpf_bk_L3_35 dpf_bk_L3_35 vdd vdd PMIR W=60u L=1u
Msf_bk_L3_35 dpre_L3_35 dpf_bk_L3_35 vdd vdd PMIR W=60u L=1u
R_bk_L3_35 dpre_L3_35 vrefd 16000.0
MpTa_L3_36_0 d2e_pb_0 gp_o_0_33 ctp_L3_36 0 NSYN W=10u L=1u
MnTb_L3_36_0 d2e_nb_0 vcn ctp_L3_36 0 NSYN W=10u L=1u
MnTa_L3_36_0 d2e_pb_0 vcn ctn_L3_36 0 NSYN W=10u L=1u
MpTb_L3_36_0 d2e_nb_0 gp_o_0_33 ctn_L3_36 0 NSYN W=10u L=1u
MpTa_L3_36_1 d2e_pb_1 gp_o_1_12 ctp_L3_36 0 NSYN W=10u L=1u
MnTb_L3_36_1 d2e_nb_1 vcn ctp_L3_36 0 NSYN W=10u L=1u
MnTa_L3_36_1 d2e_pb_1 vcn ctn_L3_36 0 NSYN W=10u L=1u
MpTb_L3_36_1 d2e_nb_1 gp_o_1_12 ctn_L3_36 0 NSYN W=10u L=1u
Msa_bk_L3_36 ctn_L3_36 ctn_L3_36 0 0 NMIR W=20u L=1u
Msb_bk_L3_36 dpre_L3_36 ctn_L3_36 0 0 NMIR W=20u L=1u
Msc_bk_L3_36 ctp_L3_36 ctp_L3_36 0 0 NMIR W=20u L=1u
Msd_bk_L3_36 dpf_bk_L3_36 ctp_L3_36 0 0 NMIR W=20u L=1u
Mse_bk_L3_36 dpf_bk_L3_36 dpf_bk_L3_36 vdd vdd PMIR W=60u L=1u
Msf_bk_L3_36 dpre_L3_36 dpf_bk_L3_36 vdd vdd PMIR W=60u L=1u
R_bk_L3_36 dpre_L3_36 vrefd 16000.0
MpTa_L3_37_0 d2e_pb_0 gp_o_0_16 ctp_L3_37 0 NSYN W=10u L=1u
MnTb_L3_37_0 d2e_nb_0 vcn ctp_L3_37 0 NSYN W=10u L=1u
MnTa_L3_37_0 d2e_pb_0 vcn ctn_L3_37 0 NSYN W=10u L=1u
MpTb_L3_37_0 d2e_nb_0 gp_o_0_16 ctn_L3_37 0 NSYN W=10u L=1u
MpTa_L3_37_1 d2e_pb_1 gp_o_1_15 ctp_L3_37 0 NSYN W=10u L=1u
MnTb_L3_37_1 d2e_nb_1 vcn ctp_L3_37 0 NSYN W=10u L=1u
MnTa_L3_37_1 d2e_pb_1 vcn ctn_L3_37 0 NSYN W=10u L=1u
MpTb_L3_37_1 d2e_nb_1 gp_o_1_15 ctn_L3_37 0 NSYN W=10u L=1u
Msa_bk_L3_37 ctn_L3_37 ctn_L3_37 0 0 NMIR W=20u L=1u
Msb_bk_L3_37 dpre_L3_37 ctn_L3_37 0 0 NMIR W=20u L=1u
Msc_bk_L3_37 ctp_L3_37 ctp_L3_37 0 0 NMIR W=20u L=1u
Msd_bk_L3_37 dpf_bk_L3_37 ctp_L3_37 0 0 NMIR W=20u L=1u
Mse_bk_L3_37 dpf_bk_L3_37 dpf_bk_L3_37 vdd vdd PMIR W=60u L=1u
Msf_bk_L3_37 dpre_L3_37 dpf_bk_L3_37 vdd vdd PMIR W=60u L=1u
R_bk_L3_37 dpre_L3_37 vrefd 16000.0
MpTa_L3_38_0 d2e_pb_0 gp_o_0_14 ctp_L3_38 0 NSYN W=10u L=1u
MnTb_L3_38_0 d2e_nb_0 vcn ctp_L3_38 0 NSYN W=10u L=1u
MnTa_L3_38_0 d2e_pb_0 vcn ctn_L3_38 0 NSYN W=10u L=1u
MpTb_L3_38_0 d2e_nb_0 gp_o_0_14 ctn_L3_38 0 NSYN W=10u L=1u
MpTa_L3_38_1 d2e_pb_1 gp_o_1_17 ctp_L3_38 0 NSYN W=10u L=1u
MnTb_L3_38_1 d2e_nb_1 vcn ctp_L3_38 0 NSYN W=10u L=1u
MnTa_L3_38_1 d2e_pb_1 vcn ctn_L3_38 0 NSYN W=10u L=1u
MpTb_L3_38_1 d2e_nb_1 gp_o_1_17 ctn_L3_38 0 NSYN W=10u L=1u
Msa_bk_L3_38 ctn_L3_38 ctn_L3_38 0 0 NMIR W=20u L=1u
Msb_bk_L3_38 dpre_L3_38 ctn_L3_38 0 0 NMIR W=20u L=1u
Msc_bk_L3_38 ctp_L3_38 ctp_L3_38 0 0 NMIR W=20u L=1u
Msd_bk_L3_38 dpf_bk_L3_38 ctp_L3_38 0 0 NMIR W=20u L=1u
Mse_bk_L3_38 dpf_bk_L3_38 dpf_bk_L3_38 vdd vdd PMIR W=60u L=1u
Msf_bk_L3_38 dpre_L3_38 dpf_bk_L3_38 vdd vdd PMIR W=60u L=1u
R_bk_L3_38 dpre_L3_38 vrefd 16000.0
MpTa_L3_39_0 d2e_pb_0 gp_o_0_19 ctp_L3_39 0 NSYN W=10u L=1u
MnTb_L3_39_0 d2e_nb_0 vcn ctp_L3_39 0 NSYN W=10u L=1u
MnTa_L3_39_0 d2e_pb_0 vcn ctn_L3_39 0 NSYN W=10u L=1u
MpTb_L3_39_0 d2e_nb_0 gp_o_0_19 ctn_L3_39 0 NSYN W=10u L=1u
MpTa_L3_39_1 d2e_pb_1 gp_o_1_8 ctp_L3_39 0 NSYN W=10u L=1u
MnTb_L3_39_1 d2e_nb_1 vcn ctp_L3_39 0 NSYN W=10u L=1u
MnTa_L3_39_1 d2e_pb_1 vcn ctn_L3_39 0 NSYN W=10u L=1u
MpTb_L3_39_1 d2e_nb_1 gp_o_1_8 ctn_L3_39 0 NSYN W=10u L=1u
Msa_bk_L3_39 ctn_L3_39 ctn_L3_39 0 0 NMIR W=20u L=1u
Msb_bk_L3_39 dpre_L3_39 ctn_L3_39 0 0 NMIR W=20u L=1u
Msc_bk_L3_39 ctp_L3_39 ctp_L3_39 0 0 NMIR W=20u L=1u
Msd_bk_L3_39 dpf_bk_L3_39 ctp_L3_39 0 0 NMIR W=20u L=1u
Mse_bk_L3_39 dpf_bk_L3_39 dpf_bk_L3_39 vdd vdd PMIR W=60u L=1u
Msf_bk_L3_39 dpre_L3_39 dpf_bk_L3_39 vdd vdd PMIR W=60u L=1u
R_bk_L3_39 dpre_L3_39 vrefd 16000.0
MpTa_L3_40_0 d2e_pb_0 gp_o_0_37 ctp_L3_40 0 NSYN W=10u L=1u
MnTb_L3_40_0 d2e_nb_0 vcn ctp_L3_40 0 NSYN W=10u L=1u
MnTa_L3_40_0 d2e_pb_0 vcn ctn_L3_40 0 NSYN W=10u L=1u
MpTb_L3_40_0 d2e_nb_0 gp_o_0_37 ctn_L3_40 0 NSYN W=10u L=1u
MpTa_L3_40_1 d2e_pb_1 gp_o_1_37 ctp_L3_40 0 NSYN W=10u L=1u
MnTb_L3_40_1 d2e_nb_1 vcn ctp_L3_40 0 NSYN W=10u L=1u
MnTa_L3_40_1 d2e_pb_1 vcn ctn_L3_40 0 NSYN W=10u L=1u
MpTb_L3_40_1 d2e_nb_1 gp_o_1_37 ctn_L3_40 0 NSYN W=10u L=1u
Msa_bk_L3_40 ctn_L3_40 ctn_L3_40 0 0 NMIR W=20u L=1u
Msb_bk_L3_40 dpre_L3_40 ctn_L3_40 0 0 NMIR W=20u L=1u
Msc_bk_L3_40 ctp_L3_40 ctp_L3_40 0 0 NMIR W=20u L=1u
Msd_bk_L3_40 dpf_bk_L3_40 ctp_L3_40 0 0 NMIR W=20u L=1u
Mse_bk_L3_40 dpf_bk_L3_40 dpf_bk_L3_40 vdd vdd PMIR W=60u L=1u
Msf_bk_L3_40 dpre_L3_40 dpf_bk_L3_40 vdd vdd PMIR W=60u L=1u
R_bk_L3_40 dpre_L3_40 vrefd 16000.0
MpTa_L3_41_0 d2e_pb_0 gp_o_0_40 ctp_L3_41 0 NSYN W=10u L=1u
MnTb_L3_41_0 d2e_nb_0 vcn ctp_L3_41 0 NSYN W=10u L=1u
MnTa_L3_41_0 d2e_pb_0 vcn ctn_L3_41 0 NSYN W=10u L=1u
MpTb_L3_41_0 d2e_nb_0 gp_o_0_40 ctn_L3_41 0 NSYN W=10u L=1u
MpTa_L3_41_1 d2e_pb_1 gp_o_1_0 ctp_L3_41 0 NSYN W=10u L=1u
MnTb_L3_41_1 d2e_nb_1 vcn ctp_L3_41 0 NSYN W=10u L=1u
MnTa_L3_41_1 d2e_pb_1 vcn ctn_L3_41 0 NSYN W=10u L=1u
MpTb_L3_41_1 d2e_nb_1 gp_o_1_0 ctn_L3_41 0 NSYN W=10u L=1u
Msa_bk_L3_41 ctn_L3_41 ctn_L3_41 0 0 NMIR W=20u L=1u
Msb_bk_L3_41 dpre_L3_41 ctn_L3_41 0 0 NMIR W=20u L=1u
Msc_bk_L3_41 ctp_L3_41 ctp_L3_41 0 0 NMIR W=20u L=1u
Msd_bk_L3_41 dpf_bk_L3_41 ctp_L3_41 0 0 NMIR W=20u L=1u
Mse_bk_L3_41 dpf_bk_L3_41 dpf_bk_L3_41 vdd vdd PMIR W=60u L=1u
Msf_bk_L3_41 dpre_L3_41 dpf_bk_L3_41 vdd vdd PMIR W=60u L=1u
R_bk_L3_41 dpre_L3_41 vrefd 16000.0
MpTa_L3_42_0 d2e_pb_0 gp_o_0_47 ctp_L3_42 0 NSYN W=10u L=1u
MnTb_L3_42_0 d2e_nb_0 vcn ctp_L3_42 0 NSYN W=10u L=1u
MnTa_L3_42_0 d2e_pb_0 vcn ctn_L3_42 0 NSYN W=10u L=1u
MpTb_L3_42_0 d2e_nb_0 gp_o_0_47 ctn_L3_42 0 NSYN W=10u L=1u
MpTa_L3_42_1 d2e_pb_1 gp_o_1_42 ctp_L3_42 0 NSYN W=10u L=1u
MnTb_L3_42_1 d2e_nb_1 vcn ctp_L3_42 0 NSYN W=10u L=1u
MnTa_L3_42_1 d2e_pb_1 vcn ctn_L3_42 0 NSYN W=10u L=1u
MpTb_L3_42_1 d2e_nb_1 gp_o_1_42 ctn_L3_42 0 NSYN W=10u L=1u
Msa_bk_L3_42 ctn_L3_42 ctn_L3_42 0 0 NMIR W=20u L=1u
Msb_bk_L3_42 dpre_L3_42 ctn_L3_42 0 0 NMIR W=20u L=1u
Msc_bk_L3_42 ctp_L3_42 ctp_L3_42 0 0 NMIR W=20u L=1u
Msd_bk_L3_42 dpf_bk_L3_42 ctp_L3_42 0 0 NMIR W=20u L=1u
Mse_bk_L3_42 dpf_bk_L3_42 dpf_bk_L3_42 vdd vdd PMIR W=60u L=1u
Msf_bk_L3_42 dpre_L3_42 dpf_bk_L3_42 vdd vdd PMIR W=60u L=1u
R_bk_L3_42 dpre_L3_42 vrefd 16000.0
MpTa_L3_43_0 d2e_pb_0 gp_o_0_25 ctp_L3_43 0 NSYN W=10u L=1u
MnTb_L3_43_0 d2e_nb_0 vcn ctp_L3_43 0 NSYN W=10u L=1u
MnTa_L3_43_0 d2e_pb_0 vcn ctn_L3_43 0 NSYN W=10u L=1u
MpTb_L3_43_0 d2e_nb_0 gp_o_0_25 ctn_L3_43 0 NSYN W=10u L=1u
MpTa_L3_43_1 d2e_pb_1 gp_o_1_43 ctp_L3_43 0 NSYN W=10u L=1u
MnTb_L3_43_1 d2e_nb_1 vcn ctp_L3_43 0 NSYN W=10u L=1u
MnTa_L3_43_1 d2e_pb_1 vcn ctn_L3_43 0 NSYN W=10u L=1u
MpTb_L3_43_1 d2e_nb_1 gp_o_1_43 ctn_L3_43 0 NSYN W=10u L=1u
Msa_bk_L3_43 ctn_L3_43 ctn_L3_43 0 0 NMIR W=20u L=1u
Msb_bk_L3_43 dpre_L3_43 ctn_L3_43 0 0 NMIR W=20u L=1u
Msc_bk_L3_43 ctp_L3_43 ctp_L3_43 0 0 NMIR W=20u L=1u
Msd_bk_L3_43 dpf_bk_L3_43 ctp_L3_43 0 0 NMIR W=20u L=1u
Mse_bk_L3_43 dpf_bk_L3_43 dpf_bk_L3_43 vdd vdd PMIR W=60u L=1u
Msf_bk_L3_43 dpre_L3_43 dpf_bk_L3_43 vdd vdd PMIR W=60u L=1u
R_bk_L3_43 dpre_L3_43 vrefd 16000.0
MpTa_L3_44_0 d2e_pb_0 gp_o_0_21 ctp_L3_44 0 NSYN W=10u L=1u
MnTb_L3_44_0 d2e_nb_0 vcn ctp_L3_44 0 NSYN W=10u L=1u
MnTa_L3_44_0 d2e_pb_0 vcn ctn_L3_44 0 NSYN W=10u L=1u
MpTb_L3_44_0 d2e_nb_0 gp_o_0_21 ctn_L3_44 0 NSYN W=10u L=1u
MpTa_L3_44_1 d2e_pb_1 gp_o_1_26 ctp_L3_44 0 NSYN W=10u L=1u
MnTb_L3_44_1 d2e_nb_1 vcn ctp_L3_44 0 NSYN W=10u L=1u
MnTa_L3_44_1 d2e_pb_1 vcn ctn_L3_44 0 NSYN W=10u L=1u
MpTb_L3_44_1 d2e_nb_1 gp_o_1_26 ctn_L3_44 0 NSYN W=10u L=1u
Msa_bk_L3_44 ctn_L3_44 ctn_L3_44 0 0 NMIR W=20u L=1u
Msb_bk_L3_44 dpre_L3_44 ctn_L3_44 0 0 NMIR W=20u L=1u
Msc_bk_L3_44 ctp_L3_44 ctp_L3_44 0 0 NMIR W=20u L=1u
Msd_bk_L3_44 dpf_bk_L3_44 ctp_L3_44 0 0 NMIR W=20u L=1u
Mse_bk_L3_44 dpf_bk_L3_44 dpf_bk_L3_44 vdd vdd PMIR W=60u L=1u
Msf_bk_L3_44 dpre_L3_44 dpf_bk_L3_44 vdd vdd PMIR W=60u L=1u
R_bk_L3_44 dpre_L3_44 vrefd 16000.0
MpTa_L3_45_0 d2e_pb_0 gp_o_0_3 ctp_L3_45 0 NSYN W=10u L=1u
MnTb_L3_45_0 d2e_nb_0 vcn ctp_L3_45 0 NSYN W=10u L=1u
MnTa_L3_45_0 d2e_pb_0 vcn ctn_L3_45 0 NSYN W=10u L=1u
MpTb_L3_45_0 d2e_nb_0 gp_o_0_3 ctn_L3_45 0 NSYN W=10u L=1u
MpTa_L3_45_1 d2e_pb_1 gp_o_1_11 ctp_L3_45 0 NSYN W=10u L=1u
MnTb_L3_45_1 d2e_nb_1 vcn ctp_L3_45 0 NSYN W=10u L=1u
MnTa_L3_45_1 d2e_pb_1 vcn ctn_L3_45 0 NSYN W=10u L=1u
MpTb_L3_45_1 d2e_nb_1 gp_o_1_11 ctn_L3_45 0 NSYN W=10u L=1u
Msa_bk_L3_45 ctn_L3_45 ctn_L3_45 0 0 NMIR W=20u L=1u
Msb_bk_L3_45 dpre_L3_45 ctn_L3_45 0 0 NMIR W=20u L=1u
Msc_bk_L3_45 ctp_L3_45 ctp_L3_45 0 0 NMIR W=20u L=1u
Msd_bk_L3_45 dpf_bk_L3_45 ctp_L3_45 0 0 NMIR W=20u L=1u
Mse_bk_L3_45 dpf_bk_L3_45 dpf_bk_L3_45 vdd vdd PMIR W=60u L=1u
Msf_bk_L3_45 dpre_L3_45 dpf_bk_L3_45 vdd vdd PMIR W=60u L=1u
R_bk_L3_45 dpre_L3_45 vrefd 16000.0
MpTa_L3_46_0 d2e_pb_0 gp_o_0_0 ctp_L3_46 0 NSYN W=10u L=1u
MnTb_L3_46_0 d2e_nb_0 vcn ctp_L3_46 0 NSYN W=10u L=1u
MnTa_L3_46_0 d2e_pb_0 vcn ctn_L3_46 0 NSYN W=10u L=1u
MpTb_L3_46_0 d2e_nb_0 gp_o_0_0 ctn_L3_46 0 NSYN W=10u L=1u
MpTa_L3_46_1 d2e_pb_1 gp_o_1_24 ctp_L3_46 0 NSYN W=10u L=1u
MnTb_L3_46_1 d2e_nb_1 vcn ctp_L3_46 0 NSYN W=10u L=1u
MnTa_L3_46_1 d2e_pb_1 vcn ctn_L3_46 0 NSYN W=10u L=1u
MpTb_L3_46_1 d2e_nb_1 gp_o_1_24 ctn_L3_46 0 NSYN W=10u L=1u
Msa_bk_L3_46 ctn_L3_46 ctn_L3_46 0 0 NMIR W=20u L=1u
Msb_bk_L3_46 dpre_L3_46 ctn_L3_46 0 0 NMIR W=20u L=1u
Msc_bk_L3_46 ctp_L3_46 ctp_L3_46 0 0 NMIR W=20u L=1u
Msd_bk_L3_46 dpf_bk_L3_46 ctp_L3_46 0 0 NMIR W=20u L=1u
Mse_bk_L3_46 dpf_bk_L3_46 dpf_bk_L3_46 vdd vdd PMIR W=60u L=1u
Msf_bk_L3_46 dpre_L3_46 dpf_bk_L3_46 vdd vdd PMIR W=60u L=1u
R_bk_L3_46 dpre_L3_46 vrefd 16000.0
MpTa_L3_47_0 d2e_pb_0 gp_o_0_12 ctp_L3_47 0 NSYN W=10u L=1u
MnTb_L3_47_0 d2e_nb_0 vcn ctp_L3_47 0 NSYN W=10u L=1u
MnTa_L3_47_0 d2e_pb_0 vcn ctn_L3_47 0 NSYN W=10u L=1u
MpTb_L3_47_0 d2e_nb_0 gp_o_0_12 ctn_L3_47 0 NSYN W=10u L=1u
MpTa_L3_47_1 d2e_pb_1 gp_o_1_31 ctp_L3_47 0 NSYN W=10u L=1u
MnTb_L3_47_1 d2e_nb_1 vcn ctp_L3_47 0 NSYN W=10u L=1u
MnTa_L3_47_1 d2e_pb_1 vcn ctn_L3_47 0 NSYN W=10u L=1u
MpTb_L3_47_1 d2e_nb_1 gp_o_1_31 ctn_L3_47 0 NSYN W=10u L=1u
Msa_bk_L3_47 ctn_L3_47 ctn_L3_47 0 0 NMIR W=20u L=1u
Msb_bk_L3_47 dpre_L3_47 ctn_L3_47 0 0 NMIR W=20u L=1u
Msc_bk_L3_47 ctp_L3_47 ctp_L3_47 0 0 NMIR W=20u L=1u
Msd_bk_L3_47 dpf_bk_L3_47 ctp_L3_47 0 0 NMIR W=20u L=1u
Mse_bk_L3_47 dpf_bk_L3_47 dpf_bk_L3_47 vdd vdd PMIR W=60u L=1u
Msf_bk_L3_47 dpre_L3_47 dpf_bk_L3_47 vdd vdd PMIR W=60u L=1u
R_bk_L3_47 dpre_L3_47 vrefd 16000.0
Rcm_L3_0 dpre_L3_0 d1bar_L3 10000.0
Rcm_L3_1 dpre_L3_1 d1bar_L3 10000.0
Rcm_L3_2 dpre_L3_2 d1bar_L3 10000.0
Rcm_L3_3 dpre_L3_3 d1bar_L3 10000.0
Rcm_L3_4 dpre_L3_4 d1bar_L3 10000.0
Rcm_L3_5 dpre_L3_5 d1bar_L3 10000.0
Rcm_L3_6 dpre_L3_6 d1bar_L3 10000.0
Rcm_L3_7 dpre_L3_7 d1bar_L3 10000.0
Rcm_L3_8 dpre_L3_8 d1bar_L3 10000.0
Rcm_L3_9 dpre_L3_9 d1bar_L3 10000.0
Rcm_L3_10 dpre_L3_10 d1bar_L3 10000.0
Rcm_L3_11 dpre_L3_11 d1bar_L3 10000.0
Rcm_L3_12 dpre_L3_12 d1bar_L3 10000.0
Rcm_L3_13 dpre_L3_13 d1bar_L3 10000.0
Rcm_L3_14 dpre_L3_14 d1bar_L3 10000.0
Rcm_L3_15 dpre_L3_15 d1bar_L3 10000.0
Rcm_L3_16 dpre_L3_16 d1bar_L3 10000.0
Rcm_L3_17 dpre_L3_17 d1bar_L3 10000.0
Rcm_L3_18 dpre_L3_18 d1bar_L3 10000.0
Rcm_L3_19 dpre_L3_19 d1bar_L3 10000.0
Rcm_L3_20 dpre_L3_20 d1bar_L3 10000.0
Rcm_L3_21 dpre_L3_21 d1bar_L3 10000.0
Rcm_L3_22 dpre_L3_22 d1bar_L3 10000.0
Rcm_L3_23 dpre_L3_23 d1bar_L3 10000.0
Rcm_L3_24 dpre_L3_24 d1bar_L3 10000.0
Rcm_L3_25 dpre_L3_25 d1bar_L3 10000.0
Rcm_L3_26 dpre_L3_26 d1bar_L3 10000.0
Rcm_L3_27 dpre_L3_27 d1bar_L3 10000.0
Rcm_L3_28 dpre_L3_28 d1bar_L3 10000.0
Rcm_L3_29 dpre_L3_29 d1bar_L3 10000.0
Rcm_L3_30 dpre_L3_30 d1bar_L3 10000.0
Rcm_L3_31 dpre_L3_31 d1bar_L3 10000.0
Rcm_L3_32 dpre_L3_32 d1bar_L3 10000.0
Rcm_L3_33 dpre_L3_33 d1bar_L3 10000.0
Rcm_L3_34 dpre_L3_34 d1bar_L3 10000.0
Rcm_L3_35 dpre_L3_35 d1bar_L3 10000.0
Rcm_L3_36 dpre_L3_36 d1bar_L3 10000.0
Rcm_L3_37 dpre_L3_37 d1bar_L3 10000.0
Rcm_L3_38 dpre_L3_38 d1bar_L3 10000.0
Rcm_L3_39 dpre_L3_39 d1bar_L3 10000.0
Rcm_L3_40 dpre_L3_40 d1bar_L3 10000.0
Rcm_L3_41 dpre_L3_41 d1bar_L3 10000.0
Rcm_L3_42 dpre_L3_42 d1bar_L3 10000.0
Rcm_L3_43 dpre_L3_43 d1bar_L3 10000.0
Rcm_L3_44 dpre_L3_44 d1bar_L3 10000.0
Rcm_L3_45 dpre_L3_45 d1bar_L3 10000.0
Rcm_L3_46 dpre_L3_46 d1bar_L3 10000.0
Rcm_L3_47 dpre_L3_47 d1bar_L3 10000.0
Ccm_L3 d1bar_L3 0 50f
Mt_uU_L3_0_0 ts_uU_L3_0_0 hv_L2_3 0 0 NMIR W=48.0u L=1u
Mo1_uU_L3_0_0 da_uU_L3_0_0 d1bar_L3 ts_uU_L3_0_0 0 NMIR W=20u L=1u
Mo2_uU_L3_0_0 gp_3_0_0 dpre_L3_0 ts_uU_L3_0_0 0 NMIR W=20u L=1u
Mo3_uU_L3_0_0 da_uU_L3_0_0 da_uU_L3_0_0 vdd vdd PMIR W=60u L=1u
Mo4_uU_L3_0_0 gp_3_0_0 da_uU_L3_0_0 vdd vdd PMIR W=60u L=1u
Mt_uU_L3_0_1 ts_uU_L3_0_1 hv_L2_5 0 0 NMIR W=48.0u L=1u
Mo1_uU_L3_0_1 da_uU_L3_0_1 d1bar_L3 ts_uU_L3_0_1 0 NMIR W=20u L=1u
Mo2_uU_L3_0_1 gp_3_0_1 dpre_L3_0 ts_uU_L3_0_1 0 NMIR W=20u L=1u
Mo3_uU_L3_0_1 da_uU_L3_0_1 da_uU_L3_0_1 vdd vdd PMIR W=60u L=1u
Mo4_uU_L3_0_1 gp_3_0_1 da_uU_L3_0_1 vdd vdd PMIR W=60u L=1u
Mt_uU_L3_0_2 ts_uU_L3_0_2 hv_L2_8 0 0 NMIR W=48.0u L=1u
Mo1_uU_L3_0_2 da_uU_L3_0_2 d1bar_L3 ts_uU_L3_0_2 0 NMIR W=20u L=1u
Mo2_uU_L3_0_2 gp_3_0_2 dpre_L3_0 ts_uU_L3_0_2 0 NMIR W=20u L=1u
Mo3_uU_L3_0_2 da_uU_L3_0_2 da_uU_L3_0_2 vdd vdd PMIR W=60u L=1u
Mo4_uU_L3_0_2 gp_3_0_2 da_uU_L3_0_2 vdd vdd PMIR W=60u L=1u
Mt_uU_L3_0_3 ts_uU_L3_0_3 hv_L2_11 0 0 NMIR W=48.0u L=1u
Mo1_uU_L3_0_3 da_uU_L3_0_3 d1bar_L3 ts_uU_L3_0_3 0 NMIR W=20u L=1u
Mo2_uU_L3_0_3 gp_3_0_3 dpre_L3_0 ts_uU_L3_0_3 0 NMIR W=20u L=1u
Mo3_uU_L3_0_3 da_uU_L3_0_3 da_uU_L3_0_3 vdd vdd PMIR W=60u L=1u
Mo4_uU_L3_0_3 gp_3_0_3 da_uU_L3_0_3 vdd vdd PMIR W=60u L=1u
Mt_uU_L3_0_4 ts_uU_L3_0_4 hv_L2_14 0 0 NMIR W=48.0u L=1u
Mo1_uU_L3_0_4 da_uU_L3_0_4 d1bar_L3 ts_uU_L3_0_4 0 NMIR W=20u L=1u
Mo2_uU_L3_0_4 gp_3_0_4 dpre_L3_0 ts_uU_L3_0_4 0 NMIR W=20u L=1u
Mo3_uU_L3_0_4 da_uU_L3_0_4 da_uU_L3_0_4 vdd vdd PMIR W=60u L=1u
Mo4_uU_L3_0_4 gp_3_0_4 da_uU_L3_0_4 vdd vdd PMIR W=60u L=1u
Mt_uU_L3_0_5 ts_uU_L3_0_5 hv_L2_15 0 0 NMIR W=48.0u L=1u
Mo1_uU_L3_0_5 da_uU_L3_0_5 d1bar_L3 ts_uU_L3_0_5 0 NMIR W=20u L=1u
Mo2_uU_L3_0_5 gp_3_0_5 dpre_L3_0 ts_uU_L3_0_5 0 NMIR W=20u L=1u
Mo3_uU_L3_0_5 da_uU_L3_0_5 da_uU_L3_0_5 vdd vdd PMIR W=60u L=1u
Mo4_uU_L3_0_5 gp_3_0_5 da_uU_L3_0_5 vdd vdd PMIR W=60u L=1u
Mt_uU_L3_0_6 ts_uU_L3_0_6 hv_L2_18 0 0 NMIR W=48.0u L=1u
Mo1_uU_L3_0_6 da_uU_L3_0_6 d1bar_L3 ts_uU_L3_0_6 0 NMIR W=20u L=1u
Mo2_uU_L3_0_6 gp_3_0_6 dpre_L3_0 ts_uU_L3_0_6 0 NMIR W=20u L=1u
Mo3_uU_L3_0_6 da_uU_L3_0_6 da_uU_L3_0_6 vdd vdd PMIR W=60u L=1u
Mo4_uU_L3_0_6 gp_3_0_6 da_uU_L3_0_6 vdd vdd PMIR W=60u L=1u
Mt_uU_L3_0_7 ts_uU_L3_0_7 hv_L2_20 0 0 NMIR W=48.0u L=1u
Mo1_uU_L3_0_7 da_uU_L3_0_7 d1bar_L3 ts_uU_L3_0_7 0 NMIR W=20u L=1u
Mo2_uU_L3_0_7 gp_3_0_7 dpre_L3_0 ts_uU_L3_0_7 0 NMIR W=20u L=1u
Mo3_uU_L3_0_7 da_uU_L3_0_7 da_uU_L3_0_7 vdd vdd PMIR W=60u L=1u
Mo4_uU_L3_0_7 gp_3_0_7 da_uU_L3_0_7 vdd vdd PMIR W=60u L=1u
Mt_uU_L3_0_8 ts_uU_L3_0_8 hv_L2_21 0 0 NMIR W=48.0u L=1u
Mo1_uU_L3_0_8 da_uU_L3_0_8 d1bar_L3 ts_uU_L3_0_8 0 NMIR W=20u L=1u
Mo2_uU_L3_0_8 gp_3_0_8 dpre_L3_0 ts_uU_L3_0_8 0 NMIR W=20u L=1u
Mo3_uU_L3_0_8 da_uU_L3_0_8 da_uU_L3_0_8 vdd vdd PMIR W=60u L=1u
Mo4_uU_L3_0_8 gp_3_0_8 da_uU_L3_0_8 vdd vdd PMIR W=60u L=1u
Mt_uU_L3_0_9 ts_uU_L3_0_9 hv_L2_27 0 0 NMIR W=48.0u L=1u
Mo1_uU_L3_0_9 da_uU_L3_0_9 d1bar_L3 ts_uU_L3_0_9 0 NMIR W=20u L=1u
Mo2_uU_L3_0_9 gp_3_0_9 dpre_L3_0 ts_uU_L3_0_9 0 NMIR W=20u L=1u
Mo3_uU_L3_0_9 da_uU_L3_0_9 da_uU_L3_0_9 vdd vdd PMIR W=60u L=1u
Mo4_uU_L3_0_9 gp_3_0_9 da_uU_L3_0_9 vdd vdd PMIR W=60u L=1u
Mt_uU_L3_0_10 ts_uU_L3_0_10 hv_L2_28 0 0 NMIR W=48.0u L=1u
Mo1_uU_L3_0_10 da_uU_L3_0_10 d1bar_L3 ts_uU_L3_0_10 0 NMIR W=20u L=1u
Mo2_uU_L3_0_10 gp_3_0_10 dpre_L3_0 ts_uU_L3_0_10 0 NMIR W=20u L=1u
Mo3_uU_L3_0_10 da_uU_L3_0_10 da_uU_L3_0_10 vdd vdd PMIR W=60u L=1u
Mo4_uU_L3_0_10 gp_3_0_10 da_uU_L3_0_10 vdd vdd PMIR W=60u L=1u
Mt_uU_L3_0_11 ts_uU_L3_0_11 hv_L2_31 0 0 NMIR W=48.0u L=1u
Mo1_uU_L3_0_11 da_uU_L3_0_11 d1bar_L3 ts_uU_L3_0_11 0 NMIR W=20u L=1u
Mo2_uU_L3_0_11 gp_3_0_11 dpre_L3_0 ts_uU_L3_0_11 0 NMIR W=20u L=1u
Mo3_uU_L3_0_11 da_uU_L3_0_11 da_uU_L3_0_11 vdd vdd PMIR W=60u L=1u
Mo4_uU_L3_0_11 gp_3_0_11 da_uU_L3_0_11 vdd vdd PMIR W=60u L=1u
Mt_uU_L3_0_12 ts_uU_L3_0_12 hv_L2_37 0 0 NMIR W=48.0u L=1u
Mo1_uU_L3_0_12 da_uU_L3_0_12 d1bar_L3 ts_uU_L3_0_12 0 NMIR W=20u L=1u
Mo2_uU_L3_0_12 gp_3_0_12 dpre_L3_0 ts_uU_L3_0_12 0 NMIR W=20u L=1u
Mo3_uU_L3_0_12 da_uU_L3_0_12 da_uU_L3_0_12 vdd vdd PMIR W=60u L=1u
Mo4_uU_L3_0_12 gp_3_0_12 da_uU_L3_0_12 vdd vdd PMIR W=60u L=1u
Mt_uU_L3_0_13 ts_uU_L3_0_13 hv_L2_39 0 0 NMIR W=48.0u L=1u
Mo1_uU_L3_0_13 da_uU_L3_0_13 d1bar_L3 ts_uU_L3_0_13 0 NMIR W=20u L=1u
Mo2_uU_L3_0_13 gp_3_0_13 dpre_L3_0 ts_uU_L3_0_13 0 NMIR W=20u L=1u
Mo3_uU_L3_0_13 da_uU_L3_0_13 da_uU_L3_0_13 vdd vdd PMIR W=60u L=1u
Mo4_uU_L3_0_13 gp_3_0_13 da_uU_L3_0_13 vdd vdd PMIR W=60u L=1u
Mt_uU_L3_0_14 ts_uU_L3_0_14 hv_L2_41 0 0 NMIR W=48.0u L=1u
Mo1_uU_L3_0_14 da_uU_L3_0_14 d1bar_L3 ts_uU_L3_0_14 0 NMIR W=20u L=1u
Mo2_uU_L3_0_14 gp_3_0_14 dpre_L3_0 ts_uU_L3_0_14 0 NMIR W=20u L=1u
Mo3_uU_L3_0_14 da_uU_L3_0_14 da_uU_L3_0_14 vdd vdd PMIR W=60u L=1u
Mo4_uU_L3_0_14 gp_3_0_14 da_uU_L3_0_14 vdd vdd PMIR W=60u L=1u
Mt_uU_L3_0_15 ts_uU_L3_0_15 hv_L2_47 0 0 NMIR W=48.0u L=1u
Mo1_uU_L3_0_15 da_uU_L3_0_15 d1bar_L3 ts_uU_L3_0_15 0 NMIR W=20u L=1u
Mo2_uU_L3_0_15 gp_3_0_15 dpre_L3_0 ts_uU_L3_0_15 0 NMIR W=20u L=1u
Mo3_uU_L3_0_15 da_uU_L3_0_15 da_uU_L3_0_15 vdd vdd PMIR W=60u L=1u
Mo4_uU_L3_0_15 gp_3_0_15 da_uU_L3_0_15 vdd vdd PMIR W=60u L=1u
Mt_uU_L3_1_0 ts_uU_L3_1_0 hv_L2_5 0 0 NMIR W=48.0u L=1u
Mo1_uU_L3_1_0 da_uU_L3_1_0 d1bar_L3 ts_uU_L3_1_0 0 NMIR W=20u L=1u
Mo2_uU_L3_1_0 gp_3_1_0 dpre_L3_1 ts_uU_L3_1_0 0 NMIR W=20u L=1u
Mo3_uU_L3_1_0 da_uU_L3_1_0 da_uU_L3_1_0 vdd vdd PMIR W=60u L=1u
Mo4_uU_L3_1_0 gp_3_1_0 da_uU_L3_1_0 vdd vdd PMIR W=60u L=1u
Mt_uU_L3_1_1 ts_uU_L3_1_1 hv_L2_6 0 0 NMIR W=48.0u L=1u
Mo1_uU_L3_1_1 da_uU_L3_1_1 d1bar_L3 ts_uU_L3_1_1 0 NMIR W=20u L=1u
Mo2_uU_L3_1_1 gp_3_1_1 dpre_L3_1 ts_uU_L3_1_1 0 NMIR W=20u L=1u
Mo3_uU_L3_1_1 da_uU_L3_1_1 da_uU_L3_1_1 vdd vdd PMIR W=60u L=1u
Mo4_uU_L3_1_1 gp_3_1_1 da_uU_L3_1_1 vdd vdd PMIR W=60u L=1u
Mt_uU_L3_1_2 ts_uU_L3_1_2 hv_L2_11 0 0 NMIR W=48.0u L=1u
Mo1_uU_L3_1_2 da_uU_L3_1_2 d1bar_L3 ts_uU_L3_1_2 0 NMIR W=20u L=1u
Mo2_uU_L3_1_2 gp_3_1_2 dpre_L3_1 ts_uU_L3_1_2 0 NMIR W=20u L=1u
Mo3_uU_L3_1_2 da_uU_L3_1_2 da_uU_L3_1_2 vdd vdd PMIR W=60u L=1u
Mo4_uU_L3_1_2 gp_3_1_2 da_uU_L3_1_2 vdd vdd PMIR W=60u L=1u
Mt_uU_L3_1_3 ts_uU_L3_1_3 hv_L2_15 0 0 NMIR W=48.0u L=1u
Mo1_uU_L3_1_3 da_uU_L3_1_3 d1bar_L3 ts_uU_L3_1_3 0 NMIR W=20u L=1u
Mo2_uU_L3_1_3 gp_3_1_3 dpre_L3_1 ts_uU_L3_1_3 0 NMIR W=20u L=1u
Mo3_uU_L3_1_3 da_uU_L3_1_3 da_uU_L3_1_3 vdd vdd PMIR W=60u L=1u
Mo4_uU_L3_1_3 gp_3_1_3 da_uU_L3_1_3 vdd vdd PMIR W=60u L=1u
Mt_uU_L3_1_4 ts_uU_L3_1_4 hv_L2_19 0 0 NMIR W=48.0u L=1u
Mo1_uU_L3_1_4 da_uU_L3_1_4 d1bar_L3 ts_uU_L3_1_4 0 NMIR W=20u L=1u
Mo2_uU_L3_1_4 gp_3_1_4 dpre_L3_1 ts_uU_L3_1_4 0 NMIR W=20u L=1u
Mo3_uU_L3_1_4 da_uU_L3_1_4 da_uU_L3_1_4 vdd vdd PMIR W=60u L=1u
Mo4_uU_L3_1_4 gp_3_1_4 da_uU_L3_1_4 vdd vdd PMIR W=60u L=1u
Mt_uU_L3_1_5 ts_uU_L3_1_5 hv_L2_21 0 0 NMIR W=48.0u L=1u
Mo1_uU_L3_1_5 da_uU_L3_1_5 d1bar_L3 ts_uU_L3_1_5 0 NMIR W=20u L=1u
Mo2_uU_L3_1_5 gp_3_1_5 dpre_L3_1 ts_uU_L3_1_5 0 NMIR W=20u L=1u
Mo3_uU_L3_1_5 da_uU_L3_1_5 da_uU_L3_1_5 vdd vdd PMIR W=60u L=1u
Mo4_uU_L3_1_5 gp_3_1_5 da_uU_L3_1_5 vdd vdd PMIR W=60u L=1u
Mt_uU_L3_1_6 ts_uU_L3_1_6 hv_L2_23 0 0 NMIR W=48.0u L=1u
Mo1_uU_L3_1_6 da_uU_L3_1_6 d1bar_L3 ts_uU_L3_1_6 0 NMIR W=20u L=1u
Mo2_uU_L3_1_6 gp_3_1_6 dpre_L3_1 ts_uU_L3_1_6 0 NMIR W=20u L=1u
Mo3_uU_L3_1_6 da_uU_L3_1_6 da_uU_L3_1_6 vdd vdd PMIR W=60u L=1u
Mo4_uU_L3_1_6 gp_3_1_6 da_uU_L3_1_6 vdd vdd PMIR W=60u L=1u
Mt_uU_L3_1_7 ts_uU_L3_1_7 hv_L2_28 0 0 NMIR W=48.0u L=1u
Mo1_uU_L3_1_7 da_uU_L3_1_7 d1bar_L3 ts_uU_L3_1_7 0 NMIR W=20u L=1u
Mo2_uU_L3_1_7 gp_3_1_7 dpre_L3_1 ts_uU_L3_1_7 0 NMIR W=20u L=1u
Mo3_uU_L3_1_7 da_uU_L3_1_7 da_uU_L3_1_7 vdd vdd PMIR W=60u L=1u
Mo4_uU_L3_1_7 gp_3_1_7 da_uU_L3_1_7 vdd vdd PMIR W=60u L=1u
Mt_uU_L3_1_8 ts_uU_L3_1_8 hv_L2_29 0 0 NMIR W=48.0u L=1u
Mo1_uU_L3_1_8 da_uU_L3_1_8 d1bar_L3 ts_uU_L3_1_8 0 NMIR W=20u L=1u
Mo2_uU_L3_1_8 gp_3_1_8 dpre_L3_1 ts_uU_L3_1_8 0 NMIR W=20u L=1u
Mo3_uU_L3_1_8 da_uU_L3_1_8 da_uU_L3_1_8 vdd vdd PMIR W=60u L=1u
Mo4_uU_L3_1_8 gp_3_1_8 da_uU_L3_1_8 vdd vdd PMIR W=60u L=1u
Mt_uU_L3_1_9 ts_uU_L3_1_9 hv_L2_32 0 0 NMIR W=48.0u L=1u
Mo1_uU_L3_1_9 da_uU_L3_1_9 d1bar_L3 ts_uU_L3_1_9 0 NMIR W=20u L=1u
Mo2_uU_L3_1_9 gp_3_1_9 dpre_L3_1 ts_uU_L3_1_9 0 NMIR W=20u L=1u
Mo3_uU_L3_1_9 da_uU_L3_1_9 da_uU_L3_1_9 vdd vdd PMIR W=60u L=1u
Mo4_uU_L3_1_9 gp_3_1_9 da_uU_L3_1_9 vdd vdd PMIR W=60u L=1u
Mt_uU_L3_1_10 ts_uU_L3_1_10 hv_L2_34 0 0 NMIR W=48.0u L=1u
Mo1_uU_L3_1_10 da_uU_L3_1_10 d1bar_L3 ts_uU_L3_1_10 0 NMIR W=20u L=1u
Mo2_uU_L3_1_10 gp_3_1_10 dpre_L3_1 ts_uU_L3_1_10 0 NMIR W=20u L=1u
Mo3_uU_L3_1_10 da_uU_L3_1_10 da_uU_L3_1_10 vdd vdd PMIR W=60u L=1u
Mo4_uU_L3_1_10 gp_3_1_10 da_uU_L3_1_10 vdd vdd PMIR W=60u L=1u
Mt_uU_L3_1_11 ts_uU_L3_1_11 hv_L2_38 0 0 NMIR W=48.0u L=1u
Mo1_uU_L3_1_11 da_uU_L3_1_11 d1bar_L3 ts_uU_L3_1_11 0 NMIR W=20u L=1u
Mo2_uU_L3_1_11 gp_3_1_11 dpre_L3_1 ts_uU_L3_1_11 0 NMIR W=20u L=1u
Mo3_uU_L3_1_11 da_uU_L3_1_11 da_uU_L3_1_11 vdd vdd PMIR W=60u L=1u
Mo4_uU_L3_1_11 gp_3_1_11 da_uU_L3_1_11 vdd vdd PMIR W=60u L=1u
Mt_uU_L3_1_12 ts_uU_L3_1_12 hv_L2_39 0 0 NMIR W=48.0u L=1u
Mo1_uU_L3_1_12 da_uU_L3_1_12 d1bar_L3 ts_uU_L3_1_12 0 NMIR W=20u L=1u
Mo2_uU_L3_1_12 gp_3_1_12 dpre_L3_1 ts_uU_L3_1_12 0 NMIR W=20u L=1u
Mo3_uU_L3_1_12 da_uU_L3_1_12 da_uU_L3_1_12 vdd vdd PMIR W=60u L=1u
Mo4_uU_L3_1_12 gp_3_1_12 da_uU_L3_1_12 vdd vdd PMIR W=60u L=1u
Mt_uU_L3_1_13 ts_uU_L3_1_13 hv_L2_43 0 0 NMIR W=48.0u L=1u
Mo1_uU_L3_1_13 da_uU_L3_1_13 d1bar_L3 ts_uU_L3_1_13 0 NMIR W=20u L=1u
Mo2_uU_L3_1_13 gp_3_1_13 dpre_L3_1 ts_uU_L3_1_13 0 NMIR W=20u L=1u
Mo3_uU_L3_1_13 da_uU_L3_1_13 da_uU_L3_1_13 vdd vdd PMIR W=60u L=1u
Mo4_uU_L3_1_13 gp_3_1_13 da_uU_L3_1_13 vdd vdd PMIR W=60u L=1u
Mt_uU_L3_1_14 ts_uU_L3_1_14 hv_L2_44 0 0 NMIR W=48.0u L=1u
Mo1_uU_L3_1_14 da_uU_L3_1_14 d1bar_L3 ts_uU_L3_1_14 0 NMIR W=20u L=1u
Mo2_uU_L3_1_14 gp_3_1_14 dpre_L3_1 ts_uU_L3_1_14 0 NMIR W=20u L=1u
Mo3_uU_L3_1_14 da_uU_L3_1_14 da_uU_L3_1_14 vdd vdd PMIR W=60u L=1u
Mo4_uU_L3_1_14 gp_3_1_14 da_uU_L3_1_14 vdd vdd PMIR W=60u L=1u
Mt_uU_L3_1_15 ts_uU_L3_1_15 hv_L2_47 0 0 NMIR W=48.0u L=1u
Mo1_uU_L3_1_15 da_uU_L3_1_15 d1bar_L3 ts_uU_L3_1_15 0 NMIR W=20u L=1u
Mo2_uU_L3_1_15 gp_3_1_15 dpre_L3_1 ts_uU_L3_1_15 0 NMIR W=20u L=1u
Mo3_uU_L3_1_15 da_uU_L3_1_15 da_uU_L3_1_15 vdd vdd PMIR W=60u L=1u
Mo4_uU_L3_1_15 gp_3_1_15 da_uU_L3_1_15 vdd vdd PMIR W=60u L=1u
Mt_uU_L3_2_0 ts_uU_L3_2_0 hv_L2_2 0 0 NMIR W=48.0u L=1u
Mo1_uU_L3_2_0 da_uU_L3_2_0 d1bar_L3 ts_uU_L3_2_0 0 NMIR W=20u L=1u
Mo2_uU_L3_2_0 gp_3_2_0 dpre_L3_2 ts_uU_L3_2_0 0 NMIR W=20u L=1u
Mo3_uU_L3_2_0 da_uU_L3_2_0 da_uU_L3_2_0 vdd vdd PMIR W=60u L=1u
Mo4_uU_L3_2_0 gp_3_2_0 da_uU_L3_2_0 vdd vdd PMIR W=60u L=1u
Mt_uU_L3_2_1 ts_uU_L3_2_1 hv_L2_6 0 0 NMIR W=48.0u L=1u
Mo1_uU_L3_2_1 da_uU_L3_2_1 d1bar_L3 ts_uU_L3_2_1 0 NMIR W=20u L=1u
Mo2_uU_L3_2_1 gp_3_2_1 dpre_L3_2 ts_uU_L3_2_1 0 NMIR W=20u L=1u
Mo3_uU_L3_2_1 da_uU_L3_2_1 da_uU_L3_2_1 vdd vdd PMIR W=60u L=1u
Mo4_uU_L3_2_1 gp_3_2_1 da_uU_L3_2_1 vdd vdd PMIR W=60u L=1u
Mt_uU_L3_2_2 ts_uU_L3_2_2 hv_L2_10 0 0 NMIR W=48.0u L=1u
Mo1_uU_L3_2_2 da_uU_L3_2_2 d1bar_L3 ts_uU_L3_2_2 0 NMIR W=20u L=1u
Mo2_uU_L3_2_2 gp_3_2_2 dpre_L3_2 ts_uU_L3_2_2 0 NMIR W=20u L=1u
Mo3_uU_L3_2_2 da_uU_L3_2_2 da_uU_L3_2_2 vdd vdd PMIR W=60u L=1u
Mo4_uU_L3_2_2 gp_3_2_2 da_uU_L3_2_2 vdd vdd PMIR W=60u L=1u
Mt_uU_L3_2_3 ts_uU_L3_2_3 hv_L2_11 0 0 NMIR W=48.0u L=1u
Mo1_uU_L3_2_3 da_uU_L3_2_3 d1bar_L3 ts_uU_L3_2_3 0 NMIR W=20u L=1u
Mo2_uU_L3_2_3 gp_3_2_3 dpre_L3_2 ts_uU_L3_2_3 0 NMIR W=20u L=1u
Mo3_uU_L3_2_3 da_uU_L3_2_3 da_uU_L3_2_3 vdd vdd PMIR W=60u L=1u
Mo4_uU_L3_2_3 gp_3_2_3 da_uU_L3_2_3 vdd vdd PMIR W=60u L=1u
Mt_uU_L3_2_4 ts_uU_L3_2_4 hv_L2_12 0 0 NMIR W=48.0u L=1u
Mo1_uU_L3_2_4 da_uU_L3_2_4 d1bar_L3 ts_uU_L3_2_4 0 NMIR W=20u L=1u
Mo2_uU_L3_2_4 gp_3_2_4 dpre_L3_2 ts_uU_L3_2_4 0 NMIR W=20u L=1u
Mo3_uU_L3_2_4 da_uU_L3_2_4 da_uU_L3_2_4 vdd vdd PMIR W=60u L=1u
Mo4_uU_L3_2_4 gp_3_2_4 da_uU_L3_2_4 vdd vdd PMIR W=60u L=1u
Mt_uU_L3_2_5 ts_uU_L3_2_5 hv_L2_21 0 0 NMIR W=48.0u L=1u
Mo1_uU_L3_2_5 da_uU_L3_2_5 d1bar_L3 ts_uU_L3_2_5 0 NMIR W=20u L=1u
Mo2_uU_L3_2_5 gp_3_2_5 dpre_L3_2 ts_uU_L3_2_5 0 NMIR W=20u L=1u
Mo3_uU_L3_2_5 da_uU_L3_2_5 da_uU_L3_2_5 vdd vdd PMIR W=60u L=1u
Mo4_uU_L3_2_5 gp_3_2_5 da_uU_L3_2_5 vdd vdd PMIR W=60u L=1u
Mt_uU_L3_2_6 ts_uU_L3_2_6 hv_L2_26 0 0 NMIR W=48.0u L=1u
Mo1_uU_L3_2_6 da_uU_L3_2_6 d1bar_L3 ts_uU_L3_2_6 0 NMIR W=20u L=1u
Mo2_uU_L3_2_6 gp_3_2_6 dpre_L3_2 ts_uU_L3_2_6 0 NMIR W=20u L=1u
Mo3_uU_L3_2_6 da_uU_L3_2_6 da_uU_L3_2_6 vdd vdd PMIR W=60u L=1u
Mo4_uU_L3_2_6 gp_3_2_6 da_uU_L3_2_6 vdd vdd PMIR W=60u L=1u
Mt_uU_L3_2_7 ts_uU_L3_2_7 hv_L2_32 0 0 NMIR W=48.0u L=1u
Mo1_uU_L3_2_7 da_uU_L3_2_7 d1bar_L3 ts_uU_L3_2_7 0 NMIR W=20u L=1u
Mo2_uU_L3_2_7 gp_3_2_7 dpre_L3_2 ts_uU_L3_2_7 0 NMIR W=20u L=1u
Mo3_uU_L3_2_7 da_uU_L3_2_7 da_uU_L3_2_7 vdd vdd PMIR W=60u L=1u
Mo4_uU_L3_2_7 gp_3_2_7 da_uU_L3_2_7 vdd vdd PMIR W=60u L=1u
Mt_uU_L3_2_8 ts_uU_L3_2_8 hv_L2_33 0 0 NMIR W=48.0u L=1u
Mo1_uU_L3_2_8 da_uU_L3_2_8 d1bar_L3 ts_uU_L3_2_8 0 NMIR W=20u L=1u
Mo2_uU_L3_2_8 gp_3_2_8 dpre_L3_2 ts_uU_L3_2_8 0 NMIR W=20u L=1u
Mo3_uU_L3_2_8 da_uU_L3_2_8 da_uU_L3_2_8 vdd vdd PMIR W=60u L=1u
Mo4_uU_L3_2_8 gp_3_2_8 da_uU_L3_2_8 vdd vdd PMIR W=60u L=1u
Mt_uU_L3_2_9 ts_uU_L3_2_9 hv_L2_35 0 0 NMIR W=48.0u L=1u
Mo1_uU_L3_2_9 da_uU_L3_2_9 d1bar_L3 ts_uU_L3_2_9 0 NMIR W=20u L=1u
Mo2_uU_L3_2_9 gp_3_2_9 dpre_L3_2 ts_uU_L3_2_9 0 NMIR W=20u L=1u
Mo3_uU_L3_2_9 da_uU_L3_2_9 da_uU_L3_2_9 vdd vdd PMIR W=60u L=1u
Mo4_uU_L3_2_9 gp_3_2_9 da_uU_L3_2_9 vdd vdd PMIR W=60u L=1u
Mt_uU_L3_2_10 ts_uU_L3_2_10 hv_L2_36 0 0 NMIR W=48.0u L=1u
Mo1_uU_L3_2_10 da_uU_L3_2_10 d1bar_L3 ts_uU_L3_2_10 0 NMIR W=20u L=1u
Mo2_uU_L3_2_10 gp_3_2_10 dpre_L3_2 ts_uU_L3_2_10 0 NMIR W=20u L=1u
Mo3_uU_L3_2_10 da_uU_L3_2_10 da_uU_L3_2_10 vdd vdd PMIR W=60u L=1u
Mo4_uU_L3_2_10 gp_3_2_10 da_uU_L3_2_10 vdd vdd PMIR W=60u L=1u
Mt_uU_L3_2_11 ts_uU_L3_2_11 hv_L2_40 0 0 NMIR W=48.0u L=1u
Mo1_uU_L3_2_11 da_uU_L3_2_11 d1bar_L3 ts_uU_L3_2_11 0 NMIR W=20u L=1u
Mo2_uU_L3_2_11 gp_3_2_11 dpre_L3_2 ts_uU_L3_2_11 0 NMIR W=20u L=1u
Mo3_uU_L3_2_11 da_uU_L3_2_11 da_uU_L3_2_11 vdd vdd PMIR W=60u L=1u
Mo4_uU_L3_2_11 gp_3_2_11 da_uU_L3_2_11 vdd vdd PMIR W=60u L=1u
Mt_uU_L3_2_12 ts_uU_L3_2_12 hv_L2_43 0 0 NMIR W=48.0u L=1u
Mo1_uU_L3_2_12 da_uU_L3_2_12 d1bar_L3 ts_uU_L3_2_12 0 NMIR W=20u L=1u
Mo2_uU_L3_2_12 gp_3_2_12 dpre_L3_2 ts_uU_L3_2_12 0 NMIR W=20u L=1u
Mo3_uU_L3_2_12 da_uU_L3_2_12 da_uU_L3_2_12 vdd vdd PMIR W=60u L=1u
Mo4_uU_L3_2_12 gp_3_2_12 da_uU_L3_2_12 vdd vdd PMIR W=60u L=1u
Mt_uU_L3_2_13 ts_uU_L3_2_13 hv_L2_44 0 0 NMIR W=48.0u L=1u
Mo1_uU_L3_2_13 da_uU_L3_2_13 d1bar_L3 ts_uU_L3_2_13 0 NMIR W=20u L=1u
Mo2_uU_L3_2_13 gp_3_2_13 dpre_L3_2 ts_uU_L3_2_13 0 NMIR W=20u L=1u
Mo3_uU_L3_2_13 da_uU_L3_2_13 da_uU_L3_2_13 vdd vdd PMIR W=60u L=1u
Mo4_uU_L3_2_13 gp_3_2_13 da_uU_L3_2_13 vdd vdd PMIR W=60u L=1u
Mt_uU_L3_2_14 ts_uU_L3_2_14 hv_L2_45 0 0 NMIR W=48.0u L=1u
Mo1_uU_L3_2_14 da_uU_L3_2_14 d1bar_L3 ts_uU_L3_2_14 0 NMIR W=20u L=1u
Mo2_uU_L3_2_14 gp_3_2_14 dpre_L3_2 ts_uU_L3_2_14 0 NMIR W=20u L=1u
Mo3_uU_L3_2_14 da_uU_L3_2_14 da_uU_L3_2_14 vdd vdd PMIR W=60u L=1u
Mo4_uU_L3_2_14 gp_3_2_14 da_uU_L3_2_14 vdd vdd PMIR W=60u L=1u
Mt_uU_L3_2_15 ts_uU_L3_2_15 hv_L2_46 0 0 NMIR W=48.0u L=1u
Mo1_uU_L3_2_15 da_uU_L3_2_15 d1bar_L3 ts_uU_L3_2_15 0 NMIR W=20u L=1u
Mo2_uU_L3_2_15 gp_3_2_15 dpre_L3_2 ts_uU_L3_2_15 0 NMIR W=20u L=1u
Mo3_uU_L3_2_15 da_uU_L3_2_15 da_uU_L3_2_15 vdd vdd PMIR W=60u L=1u
Mo4_uU_L3_2_15 gp_3_2_15 da_uU_L3_2_15 vdd vdd PMIR W=60u L=1u
Mt_uU_L3_3_0 ts_uU_L3_3_0 hv_L2_6 0 0 NMIR W=48.0u L=1u
Mo1_uU_L3_3_0 da_uU_L3_3_0 d1bar_L3 ts_uU_L3_3_0 0 NMIR W=20u L=1u
Mo2_uU_L3_3_0 gp_3_3_0 dpre_L3_3 ts_uU_L3_3_0 0 NMIR W=20u L=1u
Mo3_uU_L3_3_0 da_uU_L3_3_0 da_uU_L3_3_0 vdd vdd PMIR W=60u L=1u
Mo4_uU_L3_3_0 gp_3_3_0 da_uU_L3_3_0 vdd vdd PMIR W=60u L=1u
Mt_uU_L3_3_1 ts_uU_L3_3_1 hv_L2_12 0 0 NMIR W=48.0u L=1u
Mo1_uU_L3_3_1 da_uU_L3_3_1 d1bar_L3 ts_uU_L3_3_1 0 NMIR W=20u L=1u
Mo2_uU_L3_3_1 gp_3_3_1 dpre_L3_3 ts_uU_L3_3_1 0 NMIR W=20u L=1u
Mo3_uU_L3_3_1 da_uU_L3_3_1 da_uU_L3_3_1 vdd vdd PMIR W=60u L=1u
Mo4_uU_L3_3_1 gp_3_3_1 da_uU_L3_3_1 vdd vdd PMIR W=60u L=1u
Mt_uU_L3_3_2 ts_uU_L3_3_2 hv_L2_18 0 0 NMIR W=48.0u L=1u
Mo1_uU_L3_3_2 da_uU_L3_3_2 d1bar_L3 ts_uU_L3_3_2 0 NMIR W=20u L=1u
Mo2_uU_L3_3_2 gp_3_3_2 dpre_L3_3 ts_uU_L3_3_2 0 NMIR W=20u L=1u
Mo3_uU_L3_3_2 da_uU_L3_3_2 da_uU_L3_3_2 vdd vdd PMIR W=60u L=1u
Mo4_uU_L3_3_2 gp_3_3_2 da_uU_L3_3_2 vdd vdd PMIR W=60u L=1u
Mt_uU_L3_3_3 ts_uU_L3_3_3 hv_L2_20 0 0 NMIR W=48.0u L=1u
Mo1_uU_L3_3_3 da_uU_L3_3_3 d1bar_L3 ts_uU_L3_3_3 0 NMIR W=20u L=1u
Mo2_uU_L3_3_3 gp_3_3_3 dpre_L3_3 ts_uU_L3_3_3 0 NMIR W=20u L=1u
Mo3_uU_L3_3_3 da_uU_L3_3_3 da_uU_L3_3_3 vdd vdd PMIR W=60u L=1u
Mo4_uU_L3_3_3 gp_3_3_3 da_uU_L3_3_3 vdd vdd PMIR W=60u L=1u
Mt_uU_L3_3_4 ts_uU_L3_3_4 hv_L2_24 0 0 NMIR W=48.0u L=1u
Mo1_uU_L3_3_4 da_uU_L3_3_4 d1bar_L3 ts_uU_L3_3_4 0 NMIR W=20u L=1u
Mo2_uU_L3_3_4 gp_3_3_4 dpre_L3_3 ts_uU_L3_3_4 0 NMIR W=20u L=1u
Mo3_uU_L3_3_4 da_uU_L3_3_4 da_uU_L3_3_4 vdd vdd PMIR W=60u L=1u
Mo4_uU_L3_3_4 gp_3_3_4 da_uU_L3_3_4 vdd vdd PMIR W=60u L=1u
Mt_uU_L3_3_5 ts_uU_L3_3_5 hv_L2_27 0 0 NMIR W=48.0u L=1u
Mo1_uU_L3_3_5 da_uU_L3_3_5 d1bar_L3 ts_uU_L3_3_5 0 NMIR W=20u L=1u
Mo2_uU_L3_3_5 gp_3_3_5 dpre_L3_3 ts_uU_L3_3_5 0 NMIR W=20u L=1u
Mo3_uU_L3_3_5 da_uU_L3_3_5 da_uU_L3_3_5 vdd vdd PMIR W=60u L=1u
Mo4_uU_L3_3_5 gp_3_3_5 da_uU_L3_3_5 vdd vdd PMIR W=60u L=1u
Mt_uU_L3_3_6 ts_uU_L3_3_6 hv_L2_31 0 0 NMIR W=48.0u L=1u
Mo1_uU_L3_3_6 da_uU_L3_3_6 d1bar_L3 ts_uU_L3_3_6 0 NMIR W=20u L=1u
Mo2_uU_L3_3_6 gp_3_3_6 dpre_L3_3 ts_uU_L3_3_6 0 NMIR W=20u L=1u
Mo3_uU_L3_3_6 da_uU_L3_3_6 da_uU_L3_3_6 vdd vdd PMIR W=60u L=1u
Mo4_uU_L3_3_6 gp_3_3_6 da_uU_L3_3_6 vdd vdd PMIR W=60u L=1u
Mt_uU_L3_3_7 ts_uU_L3_3_7 hv_L2_32 0 0 NMIR W=48.0u L=1u
Mo1_uU_L3_3_7 da_uU_L3_3_7 d1bar_L3 ts_uU_L3_3_7 0 NMIR W=20u L=1u
Mo2_uU_L3_3_7 gp_3_3_7 dpre_L3_3 ts_uU_L3_3_7 0 NMIR W=20u L=1u
Mo3_uU_L3_3_7 da_uU_L3_3_7 da_uU_L3_3_7 vdd vdd PMIR W=60u L=1u
Mo4_uU_L3_3_7 gp_3_3_7 da_uU_L3_3_7 vdd vdd PMIR W=60u L=1u
Mt_uU_L3_3_8 ts_uU_L3_3_8 hv_L2_34 0 0 NMIR W=48.0u L=1u
Mo1_uU_L3_3_8 da_uU_L3_3_8 d1bar_L3 ts_uU_L3_3_8 0 NMIR W=20u L=1u
Mo2_uU_L3_3_8 gp_3_3_8 dpre_L3_3 ts_uU_L3_3_8 0 NMIR W=20u L=1u
Mo3_uU_L3_3_8 da_uU_L3_3_8 da_uU_L3_3_8 vdd vdd PMIR W=60u L=1u
Mo4_uU_L3_3_8 gp_3_3_8 da_uU_L3_3_8 vdd vdd PMIR W=60u L=1u
Mt_uU_L3_3_9 ts_uU_L3_3_9 hv_L2_36 0 0 NMIR W=48.0u L=1u
Mo1_uU_L3_3_9 da_uU_L3_3_9 d1bar_L3 ts_uU_L3_3_9 0 NMIR W=20u L=1u
Mo2_uU_L3_3_9 gp_3_3_9 dpre_L3_3 ts_uU_L3_3_9 0 NMIR W=20u L=1u
Mo3_uU_L3_3_9 da_uU_L3_3_9 da_uU_L3_3_9 vdd vdd PMIR W=60u L=1u
Mo4_uU_L3_3_9 gp_3_3_9 da_uU_L3_3_9 vdd vdd PMIR W=60u L=1u
Mt_uU_L3_3_10 ts_uU_L3_3_10 hv_L2_40 0 0 NMIR W=48.0u L=1u
Mo1_uU_L3_3_10 da_uU_L3_3_10 d1bar_L3 ts_uU_L3_3_10 0 NMIR W=20u L=1u
Mo2_uU_L3_3_10 gp_3_3_10 dpre_L3_3 ts_uU_L3_3_10 0 NMIR W=20u L=1u
Mo3_uU_L3_3_10 da_uU_L3_3_10 da_uU_L3_3_10 vdd vdd PMIR W=60u L=1u
Mo4_uU_L3_3_10 gp_3_3_10 da_uU_L3_3_10 vdd vdd PMIR W=60u L=1u
Mt_uU_L3_3_11 ts_uU_L3_3_11 hv_L2_41 0 0 NMIR W=48.0u L=1u
Mo1_uU_L3_3_11 da_uU_L3_3_11 d1bar_L3 ts_uU_L3_3_11 0 NMIR W=20u L=1u
Mo2_uU_L3_3_11 gp_3_3_11 dpre_L3_3 ts_uU_L3_3_11 0 NMIR W=20u L=1u
Mo3_uU_L3_3_11 da_uU_L3_3_11 da_uU_L3_3_11 vdd vdd PMIR W=60u L=1u
Mo4_uU_L3_3_11 gp_3_3_11 da_uU_L3_3_11 vdd vdd PMIR W=60u L=1u
Mt_uU_L3_3_12 ts_uU_L3_3_12 hv_L2_42 0 0 NMIR W=48.0u L=1u
Mo1_uU_L3_3_12 da_uU_L3_3_12 d1bar_L3 ts_uU_L3_3_12 0 NMIR W=20u L=1u
Mo2_uU_L3_3_12 gp_3_3_12 dpre_L3_3 ts_uU_L3_3_12 0 NMIR W=20u L=1u
Mo3_uU_L3_3_12 da_uU_L3_3_12 da_uU_L3_3_12 vdd vdd PMIR W=60u L=1u
Mo4_uU_L3_3_12 gp_3_3_12 da_uU_L3_3_12 vdd vdd PMIR W=60u L=1u
Mt_uU_L3_3_13 ts_uU_L3_3_13 hv_L2_44 0 0 NMIR W=48.0u L=1u
Mo1_uU_L3_3_13 da_uU_L3_3_13 d1bar_L3 ts_uU_L3_3_13 0 NMIR W=20u L=1u
Mo2_uU_L3_3_13 gp_3_3_13 dpre_L3_3 ts_uU_L3_3_13 0 NMIR W=20u L=1u
Mo3_uU_L3_3_13 da_uU_L3_3_13 da_uU_L3_3_13 vdd vdd PMIR W=60u L=1u
Mo4_uU_L3_3_13 gp_3_3_13 da_uU_L3_3_13 vdd vdd PMIR W=60u L=1u
Mt_uU_L3_3_14 ts_uU_L3_3_14 hv_L2_45 0 0 NMIR W=48.0u L=1u
Mo1_uU_L3_3_14 da_uU_L3_3_14 d1bar_L3 ts_uU_L3_3_14 0 NMIR W=20u L=1u
Mo2_uU_L3_3_14 gp_3_3_14 dpre_L3_3 ts_uU_L3_3_14 0 NMIR W=20u L=1u
Mo3_uU_L3_3_14 da_uU_L3_3_14 da_uU_L3_3_14 vdd vdd PMIR W=60u L=1u
Mo4_uU_L3_3_14 gp_3_3_14 da_uU_L3_3_14 vdd vdd PMIR W=60u L=1u
Mt_uU_L3_3_15 ts_uU_L3_3_15 hv_L2_46 0 0 NMIR W=48.0u L=1u
Mo1_uU_L3_3_15 da_uU_L3_3_15 d1bar_L3 ts_uU_L3_3_15 0 NMIR W=20u L=1u
Mo2_uU_L3_3_15 gp_3_3_15 dpre_L3_3 ts_uU_L3_3_15 0 NMIR W=20u L=1u
Mo3_uU_L3_3_15 da_uU_L3_3_15 da_uU_L3_3_15 vdd vdd PMIR W=60u L=1u
Mo4_uU_L3_3_15 gp_3_3_15 da_uU_L3_3_15 vdd vdd PMIR W=60u L=1u
Mt_uU_L3_4_0 ts_uU_L3_4_0 hv_L2_2 0 0 NMIR W=48.0u L=1u
Mo1_uU_L3_4_0 da_uU_L3_4_0 d1bar_L3 ts_uU_L3_4_0 0 NMIR W=20u L=1u
Mo2_uU_L3_4_0 gp_3_4_0 dpre_L3_4 ts_uU_L3_4_0 0 NMIR W=20u L=1u
Mo3_uU_L3_4_0 da_uU_L3_4_0 da_uU_L3_4_0 vdd vdd PMIR W=60u L=1u
Mo4_uU_L3_4_0 gp_3_4_0 da_uU_L3_4_0 vdd vdd PMIR W=60u L=1u
Mt_uU_L3_4_1 ts_uU_L3_4_1 hv_L2_3 0 0 NMIR W=48.0u L=1u
Mo1_uU_L3_4_1 da_uU_L3_4_1 d1bar_L3 ts_uU_L3_4_1 0 NMIR W=20u L=1u
Mo2_uU_L3_4_1 gp_3_4_1 dpre_L3_4 ts_uU_L3_4_1 0 NMIR W=20u L=1u
Mo3_uU_L3_4_1 da_uU_L3_4_1 da_uU_L3_4_1 vdd vdd PMIR W=60u L=1u
Mo4_uU_L3_4_1 gp_3_4_1 da_uU_L3_4_1 vdd vdd PMIR W=60u L=1u
Mt_uU_L3_4_2 ts_uU_L3_4_2 hv_L2_6 0 0 NMIR W=48.0u L=1u
Mo1_uU_L3_4_2 da_uU_L3_4_2 d1bar_L3 ts_uU_L3_4_2 0 NMIR W=20u L=1u
Mo2_uU_L3_4_2 gp_3_4_2 dpre_L3_4 ts_uU_L3_4_2 0 NMIR W=20u L=1u
Mo3_uU_L3_4_2 da_uU_L3_4_2 da_uU_L3_4_2 vdd vdd PMIR W=60u L=1u
Mo4_uU_L3_4_2 gp_3_4_2 da_uU_L3_4_2 vdd vdd PMIR W=60u L=1u
Mt_uU_L3_4_3 ts_uU_L3_4_3 hv_L2_8 0 0 NMIR W=48.0u L=1u
Mo1_uU_L3_4_3 da_uU_L3_4_3 d1bar_L3 ts_uU_L3_4_3 0 NMIR W=20u L=1u
Mo2_uU_L3_4_3 gp_3_4_3 dpre_L3_4 ts_uU_L3_4_3 0 NMIR W=20u L=1u
Mo3_uU_L3_4_3 da_uU_L3_4_3 da_uU_L3_4_3 vdd vdd PMIR W=60u L=1u
Mo4_uU_L3_4_3 gp_3_4_3 da_uU_L3_4_3 vdd vdd PMIR W=60u L=1u
Mt_uU_L3_4_4 ts_uU_L3_4_4 hv_L2_10 0 0 NMIR W=48.0u L=1u
Mo1_uU_L3_4_4 da_uU_L3_4_4 d1bar_L3 ts_uU_L3_4_4 0 NMIR W=20u L=1u
Mo2_uU_L3_4_4 gp_3_4_4 dpre_L3_4 ts_uU_L3_4_4 0 NMIR W=20u L=1u
Mo3_uU_L3_4_4 da_uU_L3_4_4 da_uU_L3_4_4 vdd vdd PMIR W=60u L=1u
Mo4_uU_L3_4_4 gp_3_4_4 da_uU_L3_4_4 vdd vdd PMIR W=60u L=1u
Mt_uU_L3_4_5 ts_uU_L3_4_5 hv_L2_11 0 0 NMIR W=48.0u L=1u
Mo1_uU_L3_4_5 da_uU_L3_4_5 d1bar_L3 ts_uU_L3_4_5 0 NMIR W=20u L=1u
Mo2_uU_L3_4_5 gp_3_4_5 dpre_L3_4 ts_uU_L3_4_5 0 NMIR W=20u L=1u
Mo3_uU_L3_4_5 da_uU_L3_4_5 da_uU_L3_4_5 vdd vdd PMIR W=60u L=1u
Mo4_uU_L3_4_5 gp_3_4_5 da_uU_L3_4_5 vdd vdd PMIR W=60u L=1u
Mt_uU_L3_4_6 ts_uU_L3_4_6 hv_L2_12 0 0 NMIR W=48.0u L=1u
Mo1_uU_L3_4_6 da_uU_L3_4_6 d1bar_L3 ts_uU_L3_4_6 0 NMIR W=20u L=1u
Mo2_uU_L3_4_6 gp_3_4_6 dpre_L3_4 ts_uU_L3_4_6 0 NMIR W=20u L=1u
Mo3_uU_L3_4_6 da_uU_L3_4_6 da_uU_L3_4_6 vdd vdd PMIR W=60u L=1u
Mo4_uU_L3_4_6 gp_3_4_6 da_uU_L3_4_6 vdd vdd PMIR W=60u L=1u
Mt_uU_L3_4_7 ts_uU_L3_4_7 hv_L2_14 0 0 NMIR W=48.0u L=1u
Mo1_uU_L3_4_7 da_uU_L3_4_7 d1bar_L3 ts_uU_L3_4_7 0 NMIR W=20u L=1u
Mo2_uU_L3_4_7 gp_3_4_7 dpre_L3_4 ts_uU_L3_4_7 0 NMIR W=20u L=1u
Mo3_uU_L3_4_7 da_uU_L3_4_7 da_uU_L3_4_7 vdd vdd PMIR W=60u L=1u
Mo4_uU_L3_4_7 gp_3_4_7 da_uU_L3_4_7 vdd vdd PMIR W=60u L=1u
Mt_uU_L3_4_8 ts_uU_L3_4_8 hv_L2_17 0 0 NMIR W=48.0u L=1u
Mo1_uU_L3_4_8 da_uU_L3_4_8 d1bar_L3 ts_uU_L3_4_8 0 NMIR W=20u L=1u
Mo2_uU_L3_4_8 gp_3_4_8 dpre_L3_4 ts_uU_L3_4_8 0 NMIR W=20u L=1u
Mo3_uU_L3_4_8 da_uU_L3_4_8 da_uU_L3_4_8 vdd vdd PMIR W=60u L=1u
Mo4_uU_L3_4_8 gp_3_4_8 da_uU_L3_4_8 vdd vdd PMIR W=60u L=1u
Mt_uU_L3_4_9 ts_uU_L3_4_9 hv_L2_22 0 0 NMIR W=48.0u L=1u
Mo1_uU_L3_4_9 da_uU_L3_4_9 d1bar_L3 ts_uU_L3_4_9 0 NMIR W=20u L=1u
Mo2_uU_L3_4_9 gp_3_4_9 dpre_L3_4 ts_uU_L3_4_9 0 NMIR W=20u L=1u
Mo3_uU_L3_4_9 da_uU_L3_4_9 da_uU_L3_4_9 vdd vdd PMIR W=60u L=1u
Mo4_uU_L3_4_9 gp_3_4_9 da_uU_L3_4_9 vdd vdd PMIR W=60u L=1u
Mt_uU_L3_4_10 ts_uU_L3_4_10 hv_L2_28 0 0 NMIR W=48.0u L=1u
Mo1_uU_L3_4_10 da_uU_L3_4_10 d1bar_L3 ts_uU_L3_4_10 0 NMIR W=20u L=1u
Mo2_uU_L3_4_10 gp_3_4_10 dpre_L3_4 ts_uU_L3_4_10 0 NMIR W=20u L=1u
Mo3_uU_L3_4_10 da_uU_L3_4_10 da_uU_L3_4_10 vdd vdd PMIR W=60u L=1u
Mo4_uU_L3_4_10 gp_3_4_10 da_uU_L3_4_10 vdd vdd PMIR W=60u L=1u
Mt_uU_L3_4_11 ts_uU_L3_4_11 hv_L2_30 0 0 NMIR W=48.0u L=1u
Mo1_uU_L3_4_11 da_uU_L3_4_11 d1bar_L3 ts_uU_L3_4_11 0 NMIR W=20u L=1u
Mo2_uU_L3_4_11 gp_3_4_11 dpre_L3_4 ts_uU_L3_4_11 0 NMIR W=20u L=1u
Mo3_uU_L3_4_11 da_uU_L3_4_11 da_uU_L3_4_11 vdd vdd PMIR W=60u L=1u
Mo4_uU_L3_4_11 gp_3_4_11 da_uU_L3_4_11 vdd vdd PMIR W=60u L=1u
Mt_uU_L3_4_12 ts_uU_L3_4_12 hv_L2_38 0 0 NMIR W=48.0u L=1u
Mo1_uU_L3_4_12 da_uU_L3_4_12 d1bar_L3 ts_uU_L3_4_12 0 NMIR W=20u L=1u
Mo2_uU_L3_4_12 gp_3_4_12 dpre_L3_4 ts_uU_L3_4_12 0 NMIR W=20u L=1u
Mo3_uU_L3_4_12 da_uU_L3_4_12 da_uU_L3_4_12 vdd vdd PMIR W=60u L=1u
Mo4_uU_L3_4_12 gp_3_4_12 da_uU_L3_4_12 vdd vdd PMIR W=60u L=1u
Mt_uU_L3_4_13 ts_uU_L3_4_13 hv_L2_39 0 0 NMIR W=48.0u L=1u
Mo1_uU_L3_4_13 da_uU_L3_4_13 d1bar_L3 ts_uU_L3_4_13 0 NMIR W=20u L=1u
Mo2_uU_L3_4_13 gp_3_4_13 dpre_L3_4 ts_uU_L3_4_13 0 NMIR W=20u L=1u
Mo3_uU_L3_4_13 da_uU_L3_4_13 da_uU_L3_4_13 vdd vdd PMIR W=60u L=1u
Mo4_uU_L3_4_13 gp_3_4_13 da_uU_L3_4_13 vdd vdd PMIR W=60u L=1u
Mt_uU_L3_4_14 ts_uU_L3_4_14 hv_L2_40 0 0 NMIR W=48.0u L=1u
Mo1_uU_L3_4_14 da_uU_L3_4_14 d1bar_L3 ts_uU_L3_4_14 0 NMIR W=20u L=1u
Mo2_uU_L3_4_14 gp_3_4_14 dpre_L3_4 ts_uU_L3_4_14 0 NMIR W=20u L=1u
Mo3_uU_L3_4_14 da_uU_L3_4_14 da_uU_L3_4_14 vdd vdd PMIR W=60u L=1u
Mo4_uU_L3_4_14 gp_3_4_14 da_uU_L3_4_14 vdd vdd PMIR W=60u L=1u
Mt_uU_L3_4_15 ts_uU_L3_4_15 hv_L2_47 0 0 NMIR W=48.0u L=1u
Mo1_uU_L3_4_15 da_uU_L3_4_15 d1bar_L3 ts_uU_L3_4_15 0 NMIR W=20u L=1u
Mo2_uU_L3_4_15 gp_3_4_15 dpre_L3_4 ts_uU_L3_4_15 0 NMIR W=20u L=1u
Mo3_uU_L3_4_15 da_uU_L3_4_15 da_uU_L3_4_15 vdd vdd PMIR W=60u L=1u
Mo4_uU_L3_4_15 gp_3_4_15 da_uU_L3_4_15 vdd vdd PMIR W=60u L=1u
Mt_uU_L3_5_0 ts_uU_L3_5_0 hv_L2_2 0 0 NMIR W=48.0u L=1u
Mo1_uU_L3_5_0 da_uU_L3_5_0 d1bar_L3 ts_uU_L3_5_0 0 NMIR W=20u L=1u
Mo2_uU_L3_5_0 gp_3_5_0 dpre_L3_5 ts_uU_L3_5_0 0 NMIR W=20u L=1u
Mo3_uU_L3_5_0 da_uU_L3_5_0 da_uU_L3_5_0 vdd vdd PMIR W=60u L=1u
Mo4_uU_L3_5_0 gp_3_5_0 da_uU_L3_5_0 vdd vdd PMIR W=60u L=1u
Mt_uU_L3_5_1 ts_uU_L3_5_1 hv_L2_4 0 0 NMIR W=48.0u L=1u
Mo1_uU_L3_5_1 da_uU_L3_5_1 d1bar_L3 ts_uU_L3_5_1 0 NMIR W=20u L=1u
Mo2_uU_L3_5_1 gp_3_5_1 dpre_L3_5 ts_uU_L3_5_1 0 NMIR W=20u L=1u
Mo3_uU_L3_5_1 da_uU_L3_5_1 da_uU_L3_5_1 vdd vdd PMIR W=60u L=1u
Mo4_uU_L3_5_1 gp_3_5_1 da_uU_L3_5_1 vdd vdd PMIR W=60u L=1u
Mt_uU_L3_5_2 ts_uU_L3_5_2 hv_L2_8 0 0 NMIR W=48.0u L=1u
Mo1_uU_L3_5_2 da_uU_L3_5_2 d1bar_L3 ts_uU_L3_5_2 0 NMIR W=20u L=1u
Mo2_uU_L3_5_2 gp_3_5_2 dpre_L3_5 ts_uU_L3_5_2 0 NMIR W=20u L=1u
Mo3_uU_L3_5_2 da_uU_L3_5_2 da_uU_L3_5_2 vdd vdd PMIR W=60u L=1u
Mo4_uU_L3_5_2 gp_3_5_2 da_uU_L3_5_2 vdd vdd PMIR W=60u L=1u
Mt_uU_L3_5_3 ts_uU_L3_5_3 hv_L2_11 0 0 NMIR W=48.0u L=1u
Mo1_uU_L3_5_3 da_uU_L3_5_3 d1bar_L3 ts_uU_L3_5_3 0 NMIR W=20u L=1u
Mo2_uU_L3_5_3 gp_3_5_3 dpre_L3_5 ts_uU_L3_5_3 0 NMIR W=20u L=1u
Mo3_uU_L3_5_3 da_uU_L3_5_3 da_uU_L3_5_3 vdd vdd PMIR W=60u L=1u
Mo4_uU_L3_5_3 gp_3_5_3 da_uU_L3_5_3 vdd vdd PMIR W=60u L=1u
Mt_uU_L3_5_4 ts_uU_L3_5_4 hv_L2_13 0 0 NMIR W=48.0u L=1u
Mo1_uU_L3_5_4 da_uU_L3_5_4 d1bar_L3 ts_uU_L3_5_4 0 NMIR W=20u L=1u
Mo2_uU_L3_5_4 gp_3_5_4 dpre_L3_5 ts_uU_L3_5_4 0 NMIR W=20u L=1u
Mo3_uU_L3_5_4 da_uU_L3_5_4 da_uU_L3_5_4 vdd vdd PMIR W=60u L=1u
Mo4_uU_L3_5_4 gp_3_5_4 da_uU_L3_5_4 vdd vdd PMIR W=60u L=1u
Mt_uU_L3_5_5 ts_uU_L3_5_5 hv_L2_17 0 0 NMIR W=48.0u L=1u
Mo1_uU_L3_5_5 da_uU_L3_5_5 d1bar_L3 ts_uU_L3_5_5 0 NMIR W=20u L=1u
Mo2_uU_L3_5_5 gp_3_5_5 dpre_L3_5 ts_uU_L3_5_5 0 NMIR W=20u L=1u
Mo3_uU_L3_5_5 da_uU_L3_5_5 da_uU_L3_5_5 vdd vdd PMIR W=60u L=1u
Mo4_uU_L3_5_5 gp_3_5_5 da_uU_L3_5_5 vdd vdd PMIR W=60u L=1u
Mt_uU_L3_5_6 ts_uU_L3_5_6 hv_L2_26 0 0 NMIR W=48.0u L=1u
Mo1_uU_L3_5_6 da_uU_L3_5_6 d1bar_L3 ts_uU_L3_5_6 0 NMIR W=20u L=1u
Mo2_uU_L3_5_6 gp_3_5_6 dpre_L3_5 ts_uU_L3_5_6 0 NMIR W=20u L=1u
Mo3_uU_L3_5_6 da_uU_L3_5_6 da_uU_L3_5_6 vdd vdd PMIR W=60u L=1u
Mo4_uU_L3_5_6 gp_3_5_6 da_uU_L3_5_6 vdd vdd PMIR W=60u L=1u
Mt_uU_L3_5_7 ts_uU_L3_5_7 hv_L2_28 0 0 NMIR W=48.0u L=1u
Mo1_uU_L3_5_7 da_uU_L3_5_7 d1bar_L3 ts_uU_L3_5_7 0 NMIR W=20u L=1u
Mo2_uU_L3_5_7 gp_3_5_7 dpre_L3_5 ts_uU_L3_5_7 0 NMIR W=20u L=1u
Mo3_uU_L3_5_7 da_uU_L3_5_7 da_uU_L3_5_7 vdd vdd PMIR W=60u L=1u
Mo4_uU_L3_5_7 gp_3_5_7 da_uU_L3_5_7 vdd vdd PMIR W=60u L=1u
Mt_uU_L3_5_8 ts_uU_L3_5_8 hv_L2_30 0 0 NMIR W=48.0u L=1u
Mo1_uU_L3_5_8 da_uU_L3_5_8 d1bar_L3 ts_uU_L3_5_8 0 NMIR W=20u L=1u
Mo2_uU_L3_5_8 gp_3_5_8 dpre_L3_5 ts_uU_L3_5_8 0 NMIR W=20u L=1u
Mo3_uU_L3_5_8 da_uU_L3_5_8 da_uU_L3_5_8 vdd vdd PMIR W=60u L=1u
Mo4_uU_L3_5_8 gp_3_5_8 da_uU_L3_5_8 vdd vdd PMIR W=60u L=1u
Mt_uU_L3_5_9 ts_uU_L3_5_9 hv_L2_34 0 0 NMIR W=48.0u L=1u
Mo1_uU_L3_5_9 da_uU_L3_5_9 d1bar_L3 ts_uU_L3_5_9 0 NMIR W=20u L=1u
Mo2_uU_L3_5_9 gp_3_5_9 dpre_L3_5 ts_uU_L3_5_9 0 NMIR W=20u L=1u
Mo3_uU_L3_5_9 da_uU_L3_5_9 da_uU_L3_5_9 vdd vdd PMIR W=60u L=1u
Mo4_uU_L3_5_9 gp_3_5_9 da_uU_L3_5_9 vdd vdd PMIR W=60u L=1u
Mt_uU_L3_5_10 ts_uU_L3_5_10 hv_L2_35 0 0 NMIR W=48.0u L=1u
Mo1_uU_L3_5_10 da_uU_L3_5_10 d1bar_L3 ts_uU_L3_5_10 0 NMIR W=20u L=1u
Mo2_uU_L3_5_10 gp_3_5_10 dpre_L3_5 ts_uU_L3_5_10 0 NMIR W=20u L=1u
Mo3_uU_L3_5_10 da_uU_L3_5_10 da_uU_L3_5_10 vdd vdd PMIR W=60u L=1u
Mo4_uU_L3_5_10 gp_3_5_10 da_uU_L3_5_10 vdd vdd PMIR W=60u L=1u
Mt_uU_L3_5_11 ts_uU_L3_5_11 hv_L2_38 0 0 NMIR W=48.0u L=1u
Mo1_uU_L3_5_11 da_uU_L3_5_11 d1bar_L3 ts_uU_L3_5_11 0 NMIR W=20u L=1u
Mo2_uU_L3_5_11 gp_3_5_11 dpre_L3_5 ts_uU_L3_5_11 0 NMIR W=20u L=1u
Mo3_uU_L3_5_11 da_uU_L3_5_11 da_uU_L3_5_11 vdd vdd PMIR W=60u L=1u
Mo4_uU_L3_5_11 gp_3_5_11 da_uU_L3_5_11 vdd vdd PMIR W=60u L=1u
Mt_uU_L3_5_12 ts_uU_L3_5_12 hv_L2_42 0 0 NMIR W=48.0u L=1u
Mo1_uU_L3_5_12 da_uU_L3_5_12 d1bar_L3 ts_uU_L3_5_12 0 NMIR W=20u L=1u
Mo2_uU_L3_5_12 gp_3_5_12 dpre_L3_5 ts_uU_L3_5_12 0 NMIR W=20u L=1u
Mo3_uU_L3_5_12 da_uU_L3_5_12 da_uU_L3_5_12 vdd vdd PMIR W=60u L=1u
Mo4_uU_L3_5_12 gp_3_5_12 da_uU_L3_5_12 vdd vdd PMIR W=60u L=1u
Mt_uU_L3_5_13 ts_uU_L3_5_13 hv_L2_44 0 0 NMIR W=48.0u L=1u
Mo1_uU_L3_5_13 da_uU_L3_5_13 d1bar_L3 ts_uU_L3_5_13 0 NMIR W=20u L=1u
Mo2_uU_L3_5_13 gp_3_5_13 dpre_L3_5 ts_uU_L3_5_13 0 NMIR W=20u L=1u
Mo3_uU_L3_5_13 da_uU_L3_5_13 da_uU_L3_5_13 vdd vdd PMIR W=60u L=1u
Mo4_uU_L3_5_13 gp_3_5_13 da_uU_L3_5_13 vdd vdd PMIR W=60u L=1u
Mt_uU_L3_5_14 ts_uU_L3_5_14 hv_L2_45 0 0 NMIR W=48.0u L=1u
Mo1_uU_L3_5_14 da_uU_L3_5_14 d1bar_L3 ts_uU_L3_5_14 0 NMIR W=20u L=1u
Mo2_uU_L3_5_14 gp_3_5_14 dpre_L3_5 ts_uU_L3_5_14 0 NMIR W=20u L=1u
Mo3_uU_L3_5_14 da_uU_L3_5_14 da_uU_L3_5_14 vdd vdd PMIR W=60u L=1u
Mo4_uU_L3_5_14 gp_3_5_14 da_uU_L3_5_14 vdd vdd PMIR W=60u L=1u
Mt_uU_L3_5_15 ts_uU_L3_5_15 hv_L2_47 0 0 NMIR W=48.0u L=1u
Mo1_uU_L3_5_15 da_uU_L3_5_15 d1bar_L3 ts_uU_L3_5_15 0 NMIR W=20u L=1u
Mo2_uU_L3_5_15 gp_3_5_15 dpre_L3_5 ts_uU_L3_5_15 0 NMIR W=20u L=1u
Mo3_uU_L3_5_15 da_uU_L3_5_15 da_uU_L3_5_15 vdd vdd PMIR W=60u L=1u
Mo4_uU_L3_5_15 gp_3_5_15 da_uU_L3_5_15 vdd vdd PMIR W=60u L=1u
Mt_uU_L3_6_0 ts_uU_L3_6_0 hv_L2_1 0 0 NMIR W=48.0u L=1u
Mo1_uU_L3_6_0 da_uU_L3_6_0 d1bar_L3 ts_uU_L3_6_0 0 NMIR W=20u L=1u
Mo2_uU_L3_6_0 gp_3_6_0 dpre_L3_6 ts_uU_L3_6_0 0 NMIR W=20u L=1u
Mo3_uU_L3_6_0 da_uU_L3_6_0 da_uU_L3_6_0 vdd vdd PMIR W=60u L=1u
Mo4_uU_L3_6_0 gp_3_6_0 da_uU_L3_6_0 vdd vdd PMIR W=60u L=1u
Mt_uU_L3_6_1 ts_uU_L3_6_1 hv_L2_5 0 0 NMIR W=48.0u L=1u
Mo1_uU_L3_6_1 da_uU_L3_6_1 d1bar_L3 ts_uU_L3_6_1 0 NMIR W=20u L=1u
Mo2_uU_L3_6_1 gp_3_6_1 dpre_L3_6 ts_uU_L3_6_1 0 NMIR W=20u L=1u
Mo3_uU_L3_6_1 da_uU_L3_6_1 da_uU_L3_6_1 vdd vdd PMIR W=60u L=1u
Mo4_uU_L3_6_1 gp_3_6_1 da_uU_L3_6_1 vdd vdd PMIR W=60u L=1u
Mt_uU_L3_6_2 ts_uU_L3_6_2 hv_L2_10 0 0 NMIR W=48.0u L=1u
Mo1_uU_L3_6_2 da_uU_L3_6_2 d1bar_L3 ts_uU_L3_6_2 0 NMIR W=20u L=1u
Mo2_uU_L3_6_2 gp_3_6_2 dpre_L3_6 ts_uU_L3_6_2 0 NMIR W=20u L=1u
Mo3_uU_L3_6_2 da_uU_L3_6_2 da_uU_L3_6_2 vdd vdd PMIR W=60u L=1u
Mo4_uU_L3_6_2 gp_3_6_2 da_uU_L3_6_2 vdd vdd PMIR W=60u L=1u
Mt_uU_L3_6_3 ts_uU_L3_6_3 hv_L2_11 0 0 NMIR W=48.0u L=1u
Mo1_uU_L3_6_3 da_uU_L3_6_3 d1bar_L3 ts_uU_L3_6_3 0 NMIR W=20u L=1u
Mo2_uU_L3_6_3 gp_3_6_3 dpre_L3_6 ts_uU_L3_6_3 0 NMIR W=20u L=1u
Mo3_uU_L3_6_3 da_uU_L3_6_3 da_uU_L3_6_3 vdd vdd PMIR W=60u L=1u
Mo4_uU_L3_6_3 gp_3_6_3 da_uU_L3_6_3 vdd vdd PMIR W=60u L=1u
Mt_uU_L3_6_4 ts_uU_L3_6_4 hv_L2_12 0 0 NMIR W=48.0u L=1u
Mo1_uU_L3_6_4 da_uU_L3_6_4 d1bar_L3 ts_uU_L3_6_4 0 NMIR W=20u L=1u
Mo2_uU_L3_6_4 gp_3_6_4 dpre_L3_6 ts_uU_L3_6_4 0 NMIR W=20u L=1u
Mo3_uU_L3_6_4 da_uU_L3_6_4 da_uU_L3_6_4 vdd vdd PMIR W=60u L=1u
Mo4_uU_L3_6_4 gp_3_6_4 da_uU_L3_6_4 vdd vdd PMIR W=60u L=1u
Mt_uU_L3_6_5 ts_uU_L3_6_5 hv_L2_14 0 0 NMIR W=48.0u L=1u
Mo1_uU_L3_6_5 da_uU_L3_6_5 d1bar_L3 ts_uU_L3_6_5 0 NMIR W=20u L=1u
Mo2_uU_L3_6_5 gp_3_6_5 dpre_L3_6 ts_uU_L3_6_5 0 NMIR W=20u L=1u
Mo3_uU_L3_6_5 da_uU_L3_6_5 da_uU_L3_6_5 vdd vdd PMIR W=60u L=1u
Mo4_uU_L3_6_5 gp_3_6_5 da_uU_L3_6_5 vdd vdd PMIR W=60u L=1u
Mt_uU_L3_6_6 ts_uU_L3_6_6 hv_L2_15 0 0 NMIR W=48.0u L=1u
Mo1_uU_L3_6_6 da_uU_L3_6_6 d1bar_L3 ts_uU_L3_6_6 0 NMIR W=20u L=1u
Mo2_uU_L3_6_6 gp_3_6_6 dpre_L3_6 ts_uU_L3_6_6 0 NMIR W=20u L=1u
Mo3_uU_L3_6_6 da_uU_L3_6_6 da_uU_L3_6_6 vdd vdd PMIR W=60u L=1u
Mo4_uU_L3_6_6 gp_3_6_6 da_uU_L3_6_6 vdd vdd PMIR W=60u L=1u
Mt_uU_L3_6_7 ts_uU_L3_6_7 hv_L2_16 0 0 NMIR W=48.0u L=1u
Mo1_uU_L3_6_7 da_uU_L3_6_7 d1bar_L3 ts_uU_L3_6_7 0 NMIR W=20u L=1u
Mo2_uU_L3_6_7 gp_3_6_7 dpre_L3_6 ts_uU_L3_6_7 0 NMIR W=20u L=1u
Mo3_uU_L3_6_7 da_uU_L3_6_7 da_uU_L3_6_7 vdd vdd PMIR W=60u L=1u
Mo4_uU_L3_6_7 gp_3_6_7 da_uU_L3_6_7 vdd vdd PMIR W=60u L=1u
Mt_uU_L3_6_8 ts_uU_L3_6_8 hv_L2_18 0 0 NMIR W=48.0u L=1u
Mo1_uU_L3_6_8 da_uU_L3_6_8 d1bar_L3 ts_uU_L3_6_8 0 NMIR W=20u L=1u
Mo2_uU_L3_6_8 gp_3_6_8 dpre_L3_6 ts_uU_L3_6_8 0 NMIR W=20u L=1u
Mo3_uU_L3_6_8 da_uU_L3_6_8 da_uU_L3_6_8 vdd vdd PMIR W=60u L=1u
Mo4_uU_L3_6_8 gp_3_6_8 da_uU_L3_6_8 vdd vdd PMIR W=60u L=1u
Mt_uU_L3_6_9 ts_uU_L3_6_9 hv_L2_21 0 0 NMIR W=48.0u L=1u
Mo1_uU_L3_6_9 da_uU_L3_6_9 d1bar_L3 ts_uU_L3_6_9 0 NMIR W=20u L=1u
Mo2_uU_L3_6_9 gp_3_6_9 dpre_L3_6 ts_uU_L3_6_9 0 NMIR W=20u L=1u
Mo3_uU_L3_6_9 da_uU_L3_6_9 da_uU_L3_6_9 vdd vdd PMIR W=60u L=1u
Mo4_uU_L3_6_9 gp_3_6_9 da_uU_L3_6_9 vdd vdd PMIR W=60u L=1u
Mt_uU_L3_6_10 ts_uU_L3_6_10 hv_L2_24 0 0 NMIR W=48.0u L=1u
Mo1_uU_L3_6_10 da_uU_L3_6_10 d1bar_L3 ts_uU_L3_6_10 0 NMIR W=20u L=1u
Mo2_uU_L3_6_10 gp_3_6_10 dpre_L3_6 ts_uU_L3_6_10 0 NMIR W=20u L=1u
Mo3_uU_L3_6_10 da_uU_L3_6_10 da_uU_L3_6_10 vdd vdd PMIR W=60u L=1u
Mo4_uU_L3_6_10 gp_3_6_10 da_uU_L3_6_10 vdd vdd PMIR W=60u L=1u
Mt_uU_L3_6_11 ts_uU_L3_6_11 hv_L2_30 0 0 NMIR W=48.0u L=1u
Mo1_uU_L3_6_11 da_uU_L3_6_11 d1bar_L3 ts_uU_L3_6_11 0 NMIR W=20u L=1u
Mo2_uU_L3_6_11 gp_3_6_11 dpre_L3_6 ts_uU_L3_6_11 0 NMIR W=20u L=1u
Mo3_uU_L3_6_11 da_uU_L3_6_11 da_uU_L3_6_11 vdd vdd PMIR W=60u L=1u
Mo4_uU_L3_6_11 gp_3_6_11 da_uU_L3_6_11 vdd vdd PMIR W=60u L=1u
Mt_uU_L3_6_12 ts_uU_L3_6_12 hv_L2_33 0 0 NMIR W=48.0u L=1u
Mo1_uU_L3_6_12 da_uU_L3_6_12 d1bar_L3 ts_uU_L3_6_12 0 NMIR W=20u L=1u
Mo2_uU_L3_6_12 gp_3_6_12 dpre_L3_6 ts_uU_L3_6_12 0 NMIR W=20u L=1u
Mo3_uU_L3_6_12 da_uU_L3_6_12 da_uU_L3_6_12 vdd vdd PMIR W=60u L=1u
Mo4_uU_L3_6_12 gp_3_6_12 da_uU_L3_6_12 vdd vdd PMIR W=60u L=1u
Mt_uU_L3_6_13 ts_uU_L3_6_13 hv_L2_40 0 0 NMIR W=48.0u L=1u
Mo1_uU_L3_6_13 da_uU_L3_6_13 d1bar_L3 ts_uU_L3_6_13 0 NMIR W=20u L=1u
Mo2_uU_L3_6_13 gp_3_6_13 dpre_L3_6 ts_uU_L3_6_13 0 NMIR W=20u L=1u
Mo3_uU_L3_6_13 da_uU_L3_6_13 da_uU_L3_6_13 vdd vdd PMIR W=60u L=1u
Mo4_uU_L3_6_13 gp_3_6_13 da_uU_L3_6_13 vdd vdd PMIR W=60u L=1u
Mt_uU_L3_6_14 ts_uU_L3_6_14 hv_L2_41 0 0 NMIR W=48.0u L=1u
Mo1_uU_L3_6_14 da_uU_L3_6_14 d1bar_L3 ts_uU_L3_6_14 0 NMIR W=20u L=1u
Mo2_uU_L3_6_14 gp_3_6_14 dpre_L3_6 ts_uU_L3_6_14 0 NMIR W=20u L=1u
Mo3_uU_L3_6_14 da_uU_L3_6_14 da_uU_L3_6_14 vdd vdd PMIR W=60u L=1u
Mo4_uU_L3_6_14 gp_3_6_14 da_uU_L3_6_14 vdd vdd PMIR W=60u L=1u
Mt_uU_L3_6_15 ts_uU_L3_6_15 hv_L2_43 0 0 NMIR W=48.0u L=1u
Mo1_uU_L3_6_15 da_uU_L3_6_15 d1bar_L3 ts_uU_L3_6_15 0 NMIR W=20u L=1u
Mo2_uU_L3_6_15 gp_3_6_15 dpre_L3_6 ts_uU_L3_6_15 0 NMIR W=20u L=1u
Mo3_uU_L3_6_15 da_uU_L3_6_15 da_uU_L3_6_15 vdd vdd PMIR W=60u L=1u
Mo4_uU_L3_6_15 gp_3_6_15 da_uU_L3_6_15 vdd vdd PMIR W=60u L=1u
Mt_uU_L3_7_0 ts_uU_L3_7_0 hv_L2_0 0 0 NMIR W=48.0u L=1u
Mo1_uU_L3_7_0 da_uU_L3_7_0 d1bar_L3 ts_uU_L3_7_0 0 NMIR W=20u L=1u
Mo2_uU_L3_7_0 gp_3_7_0 dpre_L3_7 ts_uU_L3_7_0 0 NMIR W=20u L=1u
Mo3_uU_L3_7_0 da_uU_L3_7_0 da_uU_L3_7_0 vdd vdd PMIR W=60u L=1u
Mo4_uU_L3_7_0 gp_3_7_0 da_uU_L3_7_0 vdd vdd PMIR W=60u L=1u
Mt_uU_L3_7_1 ts_uU_L3_7_1 hv_L2_4 0 0 NMIR W=48.0u L=1u
Mo1_uU_L3_7_1 da_uU_L3_7_1 d1bar_L3 ts_uU_L3_7_1 0 NMIR W=20u L=1u
Mo2_uU_L3_7_1 gp_3_7_1 dpre_L3_7 ts_uU_L3_7_1 0 NMIR W=20u L=1u
Mo3_uU_L3_7_1 da_uU_L3_7_1 da_uU_L3_7_1 vdd vdd PMIR W=60u L=1u
Mo4_uU_L3_7_1 gp_3_7_1 da_uU_L3_7_1 vdd vdd PMIR W=60u L=1u
Mt_uU_L3_7_2 ts_uU_L3_7_2 hv_L2_7 0 0 NMIR W=48.0u L=1u
Mo1_uU_L3_7_2 da_uU_L3_7_2 d1bar_L3 ts_uU_L3_7_2 0 NMIR W=20u L=1u
Mo2_uU_L3_7_2 gp_3_7_2 dpre_L3_7 ts_uU_L3_7_2 0 NMIR W=20u L=1u
Mo3_uU_L3_7_2 da_uU_L3_7_2 da_uU_L3_7_2 vdd vdd PMIR W=60u L=1u
Mo4_uU_L3_7_2 gp_3_7_2 da_uU_L3_7_2 vdd vdd PMIR W=60u L=1u
Mt_uU_L3_7_3 ts_uU_L3_7_3 hv_L2_9 0 0 NMIR W=48.0u L=1u
Mo1_uU_L3_7_3 da_uU_L3_7_3 d1bar_L3 ts_uU_L3_7_3 0 NMIR W=20u L=1u
Mo2_uU_L3_7_3 gp_3_7_3 dpre_L3_7 ts_uU_L3_7_3 0 NMIR W=20u L=1u
Mo3_uU_L3_7_3 da_uU_L3_7_3 da_uU_L3_7_3 vdd vdd PMIR W=60u L=1u
Mo4_uU_L3_7_3 gp_3_7_3 da_uU_L3_7_3 vdd vdd PMIR W=60u L=1u
Mt_uU_L3_7_4 ts_uU_L3_7_4 hv_L2_10 0 0 NMIR W=48.0u L=1u
Mo1_uU_L3_7_4 da_uU_L3_7_4 d1bar_L3 ts_uU_L3_7_4 0 NMIR W=20u L=1u
Mo2_uU_L3_7_4 gp_3_7_4 dpre_L3_7 ts_uU_L3_7_4 0 NMIR W=20u L=1u
Mo3_uU_L3_7_4 da_uU_L3_7_4 da_uU_L3_7_4 vdd vdd PMIR W=60u L=1u
Mo4_uU_L3_7_4 gp_3_7_4 da_uU_L3_7_4 vdd vdd PMIR W=60u L=1u
Mt_uU_L3_7_5 ts_uU_L3_7_5 hv_L2_11 0 0 NMIR W=48.0u L=1u
Mo1_uU_L3_7_5 da_uU_L3_7_5 d1bar_L3 ts_uU_L3_7_5 0 NMIR W=20u L=1u
Mo2_uU_L3_7_5 gp_3_7_5 dpre_L3_7 ts_uU_L3_7_5 0 NMIR W=20u L=1u
Mo3_uU_L3_7_5 da_uU_L3_7_5 da_uU_L3_7_5 vdd vdd PMIR W=60u L=1u
Mo4_uU_L3_7_5 gp_3_7_5 da_uU_L3_7_5 vdd vdd PMIR W=60u L=1u
Mt_uU_L3_7_6 ts_uU_L3_7_6 hv_L2_13 0 0 NMIR W=48.0u L=1u
Mo1_uU_L3_7_6 da_uU_L3_7_6 d1bar_L3 ts_uU_L3_7_6 0 NMIR W=20u L=1u
Mo2_uU_L3_7_6 gp_3_7_6 dpre_L3_7 ts_uU_L3_7_6 0 NMIR W=20u L=1u
Mo3_uU_L3_7_6 da_uU_L3_7_6 da_uU_L3_7_6 vdd vdd PMIR W=60u L=1u
Mo4_uU_L3_7_6 gp_3_7_6 da_uU_L3_7_6 vdd vdd PMIR W=60u L=1u
Mt_uU_L3_7_7 ts_uU_L3_7_7 hv_L2_17 0 0 NMIR W=48.0u L=1u
Mo1_uU_L3_7_7 da_uU_L3_7_7 d1bar_L3 ts_uU_L3_7_7 0 NMIR W=20u L=1u
Mo2_uU_L3_7_7 gp_3_7_7 dpre_L3_7 ts_uU_L3_7_7 0 NMIR W=20u L=1u
Mo3_uU_L3_7_7 da_uU_L3_7_7 da_uU_L3_7_7 vdd vdd PMIR W=60u L=1u
Mo4_uU_L3_7_7 gp_3_7_7 da_uU_L3_7_7 vdd vdd PMIR W=60u L=1u
Mt_uU_L3_7_8 ts_uU_L3_7_8 hv_L2_18 0 0 NMIR W=48.0u L=1u
Mo1_uU_L3_7_8 da_uU_L3_7_8 d1bar_L3 ts_uU_L3_7_8 0 NMIR W=20u L=1u
Mo2_uU_L3_7_8 gp_3_7_8 dpre_L3_7 ts_uU_L3_7_8 0 NMIR W=20u L=1u
Mo3_uU_L3_7_8 da_uU_L3_7_8 da_uU_L3_7_8 vdd vdd PMIR W=60u L=1u
Mo4_uU_L3_7_8 gp_3_7_8 da_uU_L3_7_8 vdd vdd PMIR W=60u L=1u
Mt_uU_L3_7_9 ts_uU_L3_7_9 hv_L2_21 0 0 NMIR W=48.0u L=1u
Mo1_uU_L3_7_9 da_uU_L3_7_9 d1bar_L3 ts_uU_L3_7_9 0 NMIR W=20u L=1u
Mo2_uU_L3_7_9 gp_3_7_9 dpre_L3_7 ts_uU_L3_7_9 0 NMIR W=20u L=1u
Mo3_uU_L3_7_9 da_uU_L3_7_9 da_uU_L3_7_9 vdd vdd PMIR W=60u L=1u
Mo4_uU_L3_7_9 gp_3_7_9 da_uU_L3_7_9 vdd vdd PMIR W=60u L=1u
Mt_uU_L3_7_10 ts_uU_L3_7_10 hv_L2_24 0 0 NMIR W=48.0u L=1u
Mo1_uU_L3_7_10 da_uU_L3_7_10 d1bar_L3 ts_uU_L3_7_10 0 NMIR W=20u L=1u
Mo2_uU_L3_7_10 gp_3_7_10 dpre_L3_7 ts_uU_L3_7_10 0 NMIR W=20u L=1u
Mo3_uU_L3_7_10 da_uU_L3_7_10 da_uU_L3_7_10 vdd vdd PMIR W=60u L=1u
Mo4_uU_L3_7_10 gp_3_7_10 da_uU_L3_7_10 vdd vdd PMIR W=60u L=1u
Mt_uU_L3_7_11 ts_uU_L3_7_11 hv_L2_26 0 0 NMIR W=48.0u L=1u
Mo1_uU_L3_7_11 da_uU_L3_7_11 d1bar_L3 ts_uU_L3_7_11 0 NMIR W=20u L=1u
Mo2_uU_L3_7_11 gp_3_7_11 dpre_L3_7 ts_uU_L3_7_11 0 NMIR W=20u L=1u
Mo3_uU_L3_7_11 da_uU_L3_7_11 da_uU_L3_7_11 vdd vdd PMIR W=60u L=1u
Mo4_uU_L3_7_11 gp_3_7_11 da_uU_L3_7_11 vdd vdd PMIR W=60u L=1u
Mt_uU_L3_7_12 ts_uU_L3_7_12 hv_L2_34 0 0 NMIR W=48.0u L=1u
Mo1_uU_L3_7_12 da_uU_L3_7_12 d1bar_L3 ts_uU_L3_7_12 0 NMIR W=20u L=1u
Mo2_uU_L3_7_12 gp_3_7_12 dpre_L3_7 ts_uU_L3_7_12 0 NMIR W=20u L=1u
Mo3_uU_L3_7_12 da_uU_L3_7_12 da_uU_L3_7_12 vdd vdd PMIR W=60u L=1u
Mo4_uU_L3_7_12 gp_3_7_12 da_uU_L3_7_12 vdd vdd PMIR W=60u L=1u
Mt_uU_L3_7_13 ts_uU_L3_7_13 hv_L2_39 0 0 NMIR W=48.0u L=1u
Mo1_uU_L3_7_13 da_uU_L3_7_13 d1bar_L3 ts_uU_L3_7_13 0 NMIR W=20u L=1u
Mo2_uU_L3_7_13 gp_3_7_13 dpre_L3_7 ts_uU_L3_7_13 0 NMIR W=20u L=1u
Mo3_uU_L3_7_13 da_uU_L3_7_13 da_uU_L3_7_13 vdd vdd PMIR W=60u L=1u
Mo4_uU_L3_7_13 gp_3_7_13 da_uU_L3_7_13 vdd vdd PMIR W=60u L=1u
Mt_uU_L3_7_14 ts_uU_L3_7_14 hv_L2_45 0 0 NMIR W=48.0u L=1u
Mo1_uU_L3_7_14 da_uU_L3_7_14 d1bar_L3 ts_uU_L3_7_14 0 NMIR W=20u L=1u
Mo2_uU_L3_7_14 gp_3_7_14 dpre_L3_7 ts_uU_L3_7_14 0 NMIR W=20u L=1u
Mo3_uU_L3_7_14 da_uU_L3_7_14 da_uU_L3_7_14 vdd vdd PMIR W=60u L=1u
Mo4_uU_L3_7_14 gp_3_7_14 da_uU_L3_7_14 vdd vdd PMIR W=60u L=1u
Mt_uU_L3_7_15 ts_uU_L3_7_15 hv_L2_46 0 0 NMIR W=48.0u L=1u
Mo1_uU_L3_7_15 da_uU_L3_7_15 d1bar_L3 ts_uU_L3_7_15 0 NMIR W=20u L=1u
Mo2_uU_L3_7_15 gp_3_7_15 dpre_L3_7 ts_uU_L3_7_15 0 NMIR W=20u L=1u
Mo3_uU_L3_7_15 da_uU_L3_7_15 da_uU_L3_7_15 vdd vdd PMIR W=60u L=1u
Mo4_uU_L3_7_15 gp_3_7_15 da_uU_L3_7_15 vdd vdd PMIR W=60u L=1u
Mt_uU_L3_8_0 ts_uU_L3_8_0 hv_L2_5 0 0 NMIR W=48.0u L=1u
Mo1_uU_L3_8_0 da_uU_L3_8_0 d1bar_L3 ts_uU_L3_8_0 0 NMIR W=20u L=1u
Mo2_uU_L3_8_0 gp_3_8_0 dpre_L3_8 ts_uU_L3_8_0 0 NMIR W=20u L=1u
Mo3_uU_L3_8_0 da_uU_L3_8_0 da_uU_L3_8_0 vdd vdd PMIR W=60u L=1u
Mo4_uU_L3_8_0 gp_3_8_0 da_uU_L3_8_0 vdd vdd PMIR W=60u L=1u
Mt_uU_L3_8_1 ts_uU_L3_8_1 hv_L2_6 0 0 NMIR W=48.0u L=1u
Mo1_uU_L3_8_1 da_uU_L3_8_1 d1bar_L3 ts_uU_L3_8_1 0 NMIR W=20u L=1u
Mo2_uU_L3_8_1 gp_3_8_1 dpre_L3_8 ts_uU_L3_8_1 0 NMIR W=20u L=1u
Mo3_uU_L3_8_1 da_uU_L3_8_1 da_uU_L3_8_1 vdd vdd PMIR W=60u L=1u
Mo4_uU_L3_8_1 gp_3_8_1 da_uU_L3_8_1 vdd vdd PMIR W=60u L=1u
Mt_uU_L3_8_2 ts_uU_L3_8_2 hv_L2_12 0 0 NMIR W=48.0u L=1u
Mo1_uU_L3_8_2 da_uU_L3_8_2 d1bar_L3 ts_uU_L3_8_2 0 NMIR W=20u L=1u
Mo2_uU_L3_8_2 gp_3_8_2 dpre_L3_8 ts_uU_L3_8_2 0 NMIR W=20u L=1u
Mo3_uU_L3_8_2 da_uU_L3_8_2 da_uU_L3_8_2 vdd vdd PMIR W=60u L=1u
Mo4_uU_L3_8_2 gp_3_8_2 da_uU_L3_8_2 vdd vdd PMIR W=60u L=1u
Mt_uU_L3_8_3 ts_uU_L3_8_3 hv_L2_14 0 0 NMIR W=48.0u L=1u
Mo1_uU_L3_8_3 da_uU_L3_8_3 d1bar_L3 ts_uU_L3_8_3 0 NMIR W=20u L=1u
Mo2_uU_L3_8_3 gp_3_8_3 dpre_L3_8 ts_uU_L3_8_3 0 NMIR W=20u L=1u
Mo3_uU_L3_8_3 da_uU_L3_8_3 da_uU_L3_8_3 vdd vdd PMIR W=60u L=1u
Mo4_uU_L3_8_3 gp_3_8_3 da_uU_L3_8_3 vdd vdd PMIR W=60u L=1u
Mt_uU_L3_8_4 ts_uU_L3_8_4 hv_L2_16 0 0 NMIR W=48.0u L=1u
Mo1_uU_L3_8_4 da_uU_L3_8_4 d1bar_L3 ts_uU_L3_8_4 0 NMIR W=20u L=1u
Mo2_uU_L3_8_4 gp_3_8_4 dpre_L3_8 ts_uU_L3_8_4 0 NMIR W=20u L=1u
Mo3_uU_L3_8_4 da_uU_L3_8_4 da_uU_L3_8_4 vdd vdd PMIR W=60u L=1u
Mo4_uU_L3_8_4 gp_3_8_4 da_uU_L3_8_4 vdd vdd PMIR W=60u L=1u
Mt_uU_L3_8_5 ts_uU_L3_8_5 hv_L2_18 0 0 NMIR W=48.0u L=1u
Mo1_uU_L3_8_5 da_uU_L3_8_5 d1bar_L3 ts_uU_L3_8_5 0 NMIR W=20u L=1u
Mo2_uU_L3_8_5 gp_3_8_5 dpre_L3_8 ts_uU_L3_8_5 0 NMIR W=20u L=1u
Mo3_uU_L3_8_5 da_uU_L3_8_5 da_uU_L3_8_5 vdd vdd PMIR W=60u L=1u
Mo4_uU_L3_8_5 gp_3_8_5 da_uU_L3_8_5 vdd vdd PMIR W=60u L=1u
Mt_uU_L3_8_6 ts_uU_L3_8_6 hv_L2_21 0 0 NMIR W=48.0u L=1u
Mo1_uU_L3_8_6 da_uU_L3_8_6 d1bar_L3 ts_uU_L3_8_6 0 NMIR W=20u L=1u
Mo2_uU_L3_8_6 gp_3_8_6 dpre_L3_8 ts_uU_L3_8_6 0 NMIR W=20u L=1u
Mo3_uU_L3_8_6 da_uU_L3_8_6 da_uU_L3_8_6 vdd vdd PMIR W=60u L=1u
Mo4_uU_L3_8_6 gp_3_8_6 da_uU_L3_8_6 vdd vdd PMIR W=60u L=1u
Mt_uU_L3_8_7 ts_uU_L3_8_7 hv_L2_23 0 0 NMIR W=48.0u L=1u
Mo1_uU_L3_8_7 da_uU_L3_8_7 d1bar_L3 ts_uU_L3_8_7 0 NMIR W=20u L=1u
Mo2_uU_L3_8_7 gp_3_8_7 dpre_L3_8 ts_uU_L3_8_7 0 NMIR W=20u L=1u
Mo3_uU_L3_8_7 da_uU_L3_8_7 da_uU_L3_8_7 vdd vdd PMIR W=60u L=1u
Mo4_uU_L3_8_7 gp_3_8_7 da_uU_L3_8_7 vdd vdd PMIR W=60u L=1u
Mt_uU_L3_8_8 ts_uU_L3_8_8 hv_L2_24 0 0 NMIR W=48.0u L=1u
Mo1_uU_L3_8_8 da_uU_L3_8_8 d1bar_L3 ts_uU_L3_8_8 0 NMIR W=20u L=1u
Mo2_uU_L3_8_8 gp_3_8_8 dpre_L3_8 ts_uU_L3_8_8 0 NMIR W=20u L=1u
Mo3_uU_L3_8_8 da_uU_L3_8_8 da_uU_L3_8_8 vdd vdd PMIR W=60u L=1u
Mo4_uU_L3_8_8 gp_3_8_8 da_uU_L3_8_8 vdd vdd PMIR W=60u L=1u
Mt_uU_L3_8_9 ts_uU_L3_8_9 hv_L2_26 0 0 NMIR W=48.0u L=1u
Mo1_uU_L3_8_9 da_uU_L3_8_9 d1bar_L3 ts_uU_L3_8_9 0 NMIR W=20u L=1u
Mo2_uU_L3_8_9 gp_3_8_9 dpre_L3_8 ts_uU_L3_8_9 0 NMIR W=20u L=1u
Mo3_uU_L3_8_9 da_uU_L3_8_9 da_uU_L3_8_9 vdd vdd PMIR W=60u L=1u
Mo4_uU_L3_8_9 gp_3_8_9 da_uU_L3_8_9 vdd vdd PMIR W=60u L=1u
Mt_uU_L3_8_10 ts_uU_L3_8_10 hv_L2_28 0 0 NMIR W=48.0u L=1u
Mo1_uU_L3_8_10 da_uU_L3_8_10 d1bar_L3 ts_uU_L3_8_10 0 NMIR W=20u L=1u
Mo2_uU_L3_8_10 gp_3_8_10 dpre_L3_8 ts_uU_L3_8_10 0 NMIR W=20u L=1u
Mo3_uU_L3_8_10 da_uU_L3_8_10 da_uU_L3_8_10 vdd vdd PMIR W=60u L=1u
Mo4_uU_L3_8_10 gp_3_8_10 da_uU_L3_8_10 vdd vdd PMIR W=60u L=1u
Mt_uU_L3_8_11 ts_uU_L3_8_11 hv_L2_35 0 0 NMIR W=48.0u L=1u
Mo1_uU_L3_8_11 da_uU_L3_8_11 d1bar_L3 ts_uU_L3_8_11 0 NMIR W=20u L=1u
Mo2_uU_L3_8_11 gp_3_8_11 dpre_L3_8 ts_uU_L3_8_11 0 NMIR W=20u L=1u
Mo3_uU_L3_8_11 da_uU_L3_8_11 da_uU_L3_8_11 vdd vdd PMIR W=60u L=1u
Mo4_uU_L3_8_11 gp_3_8_11 da_uU_L3_8_11 vdd vdd PMIR W=60u L=1u
Mt_uU_L3_8_12 ts_uU_L3_8_12 hv_L2_37 0 0 NMIR W=48.0u L=1u
Mo1_uU_L3_8_12 da_uU_L3_8_12 d1bar_L3 ts_uU_L3_8_12 0 NMIR W=20u L=1u
Mo2_uU_L3_8_12 gp_3_8_12 dpre_L3_8 ts_uU_L3_8_12 0 NMIR W=20u L=1u
Mo3_uU_L3_8_12 da_uU_L3_8_12 da_uU_L3_8_12 vdd vdd PMIR W=60u L=1u
Mo4_uU_L3_8_12 gp_3_8_12 da_uU_L3_8_12 vdd vdd PMIR W=60u L=1u
Mt_uU_L3_8_13 ts_uU_L3_8_13 hv_L2_39 0 0 NMIR W=48.0u L=1u
Mo1_uU_L3_8_13 da_uU_L3_8_13 d1bar_L3 ts_uU_L3_8_13 0 NMIR W=20u L=1u
Mo2_uU_L3_8_13 gp_3_8_13 dpre_L3_8 ts_uU_L3_8_13 0 NMIR W=20u L=1u
Mo3_uU_L3_8_13 da_uU_L3_8_13 da_uU_L3_8_13 vdd vdd PMIR W=60u L=1u
Mo4_uU_L3_8_13 gp_3_8_13 da_uU_L3_8_13 vdd vdd PMIR W=60u L=1u
Mt_uU_L3_8_14 ts_uU_L3_8_14 hv_L2_41 0 0 NMIR W=48.0u L=1u
Mo1_uU_L3_8_14 da_uU_L3_8_14 d1bar_L3 ts_uU_L3_8_14 0 NMIR W=20u L=1u
Mo2_uU_L3_8_14 gp_3_8_14 dpre_L3_8 ts_uU_L3_8_14 0 NMIR W=20u L=1u
Mo3_uU_L3_8_14 da_uU_L3_8_14 da_uU_L3_8_14 vdd vdd PMIR W=60u L=1u
Mo4_uU_L3_8_14 gp_3_8_14 da_uU_L3_8_14 vdd vdd PMIR W=60u L=1u
Mt_uU_L3_8_15 ts_uU_L3_8_15 hv_L2_43 0 0 NMIR W=48.0u L=1u
Mo1_uU_L3_8_15 da_uU_L3_8_15 d1bar_L3 ts_uU_L3_8_15 0 NMIR W=20u L=1u
Mo2_uU_L3_8_15 gp_3_8_15 dpre_L3_8 ts_uU_L3_8_15 0 NMIR W=20u L=1u
Mo3_uU_L3_8_15 da_uU_L3_8_15 da_uU_L3_8_15 vdd vdd PMIR W=60u L=1u
Mo4_uU_L3_8_15 gp_3_8_15 da_uU_L3_8_15 vdd vdd PMIR W=60u L=1u
Mt_uU_L3_9_0 ts_uU_L3_9_0 hv_L2_1 0 0 NMIR W=48.0u L=1u
Mo1_uU_L3_9_0 da_uU_L3_9_0 d1bar_L3 ts_uU_L3_9_0 0 NMIR W=20u L=1u
Mo2_uU_L3_9_0 gp_3_9_0 dpre_L3_9 ts_uU_L3_9_0 0 NMIR W=20u L=1u
Mo3_uU_L3_9_0 da_uU_L3_9_0 da_uU_L3_9_0 vdd vdd PMIR W=60u L=1u
Mo4_uU_L3_9_0 gp_3_9_0 da_uU_L3_9_0 vdd vdd PMIR W=60u L=1u
Mt_uU_L3_9_1 ts_uU_L3_9_1 hv_L2_5 0 0 NMIR W=48.0u L=1u
Mo1_uU_L3_9_1 da_uU_L3_9_1 d1bar_L3 ts_uU_L3_9_1 0 NMIR W=20u L=1u
Mo2_uU_L3_9_1 gp_3_9_1 dpre_L3_9 ts_uU_L3_9_1 0 NMIR W=20u L=1u
Mo3_uU_L3_9_1 da_uU_L3_9_1 da_uU_L3_9_1 vdd vdd PMIR W=60u L=1u
Mo4_uU_L3_9_1 gp_3_9_1 da_uU_L3_9_1 vdd vdd PMIR W=60u L=1u
Mt_uU_L3_9_2 ts_uU_L3_9_2 hv_L2_6 0 0 NMIR W=48.0u L=1u
Mo1_uU_L3_9_2 da_uU_L3_9_2 d1bar_L3 ts_uU_L3_9_2 0 NMIR W=20u L=1u
Mo2_uU_L3_9_2 gp_3_9_2 dpre_L3_9 ts_uU_L3_9_2 0 NMIR W=20u L=1u
Mo3_uU_L3_9_2 da_uU_L3_9_2 da_uU_L3_9_2 vdd vdd PMIR W=60u L=1u
Mo4_uU_L3_9_2 gp_3_9_2 da_uU_L3_9_2 vdd vdd PMIR W=60u L=1u
Mt_uU_L3_9_3 ts_uU_L3_9_3 hv_L2_11 0 0 NMIR W=48.0u L=1u
Mo1_uU_L3_9_3 da_uU_L3_9_3 d1bar_L3 ts_uU_L3_9_3 0 NMIR W=20u L=1u
Mo2_uU_L3_9_3 gp_3_9_3 dpre_L3_9 ts_uU_L3_9_3 0 NMIR W=20u L=1u
Mo3_uU_L3_9_3 da_uU_L3_9_3 da_uU_L3_9_3 vdd vdd PMIR W=60u L=1u
Mo4_uU_L3_9_3 gp_3_9_3 da_uU_L3_9_3 vdd vdd PMIR W=60u L=1u
Mt_uU_L3_9_4 ts_uU_L3_9_4 hv_L2_17 0 0 NMIR W=48.0u L=1u
Mo1_uU_L3_9_4 da_uU_L3_9_4 d1bar_L3 ts_uU_L3_9_4 0 NMIR W=20u L=1u
Mo2_uU_L3_9_4 gp_3_9_4 dpre_L3_9 ts_uU_L3_9_4 0 NMIR W=20u L=1u
Mo3_uU_L3_9_4 da_uU_L3_9_4 da_uU_L3_9_4 vdd vdd PMIR W=60u L=1u
Mo4_uU_L3_9_4 gp_3_9_4 da_uU_L3_9_4 vdd vdd PMIR W=60u L=1u
Mt_uU_L3_9_5 ts_uU_L3_9_5 hv_L2_18 0 0 NMIR W=48.0u L=1u
Mo1_uU_L3_9_5 da_uU_L3_9_5 d1bar_L3 ts_uU_L3_9_5 0 NMIR W=20u L=1u
Mo2_uU_L3_9_5 gp_3_9_5 dpre_L3_9 ts_uU_L3_9_5 0 NMIR W=20u L=1u
Mo3_uU_L3_9_5 da_uU_L3_9_5 da_uU_L3_9_5 vdd vdd PMIR W=60u L=1u
Mo4_uU_L3_9_5 gp_3_9_5 da_uU_L3_9_5 vdd vdd PMIR W=60u L=1u
Mt_uU_L3_9_6 ts_uU_L3_9_6 hv_L2_24 0 0 NMIR W=48.0u L=1u
Mo1_uU_L3_9_6 da_uU_L3_9_6 d1bar_L3 ts_uU_L3_9_6 0 NMIR W=20u L=1u
Mo2_uU_L3_9_6 gp_3_9_6 dpre_L3_9 ts_uU_L3_9_6 0 NMIR W=20u L=1u
Mo3_uU_L3_9_6 da_uU_L3_9_6 da_uU_L3_9_6 vdd vdd PMIR W=60u L=1u
Mo4_uU_L3_9_6 gp_3_9_6 da_uU_L3_9_6 vdd vdd PMIR W=60u L=1u
Mt_uU_L3_9_7 ts_uU_L3_9_7 hv_L2_26 0 0 NMIR W=48.0u L=1u
Mo1_uU_L3_9_7 da_uU_L3_9_7 d1bar_L3 ts_uU_L3_9_7 0 NMIR W=20u L=1u
Mo2_uU_L3_9_7 gp_3_9_7 dpre_L3_9 ts_uU_L3_9_7 0 NMIR W=20u L=1u
Mo3_uU_L3_9_7 da_uU_L3_9_7 da_uU_L3_9_7 vdd vdd PMIR W=60u L=1u
Mo4_uU_L3_9_7 gp_3_9_7 da_uU_L3_9_7 vdd vdd PMIR W=60u L=1u
Mt_uU_L3_9_8 ts_uU_L3_9_8 hv_L2_28 0 0 NMIR W=48.0u L=1u
Mo1_uU_L3_9_8 da_uU_L3_9_8 d1bar_L3 ts_uU_L3_9_8 0 NMIR W=20u L=1u
Mo2_uU_L3_9_8 gp_3_9_8 dpre_L3_9 ts_uU_L3_9_8 0 NMIR W=20u L=1u
Mo3_uU_L3_9_8 da_uU_L3_9_8 da_uU_L3_9_8 vdd vdd PMIR W=60u L=1u
Mo4_uU_L3_9_8 gp_3_9_8 da_uU_L3_9_8 vdd vdd PMIR W=60u L=1u
Mt_uU_L3_9_9 ts_uU_L3_9_9 hv_L2_32 0 0 NMIR W=48.0u L=1u
Mo1_uU_L3_9_9 da_uU_L3_9_9 d1bar_L3 ts_uU_L3_9_9 0 NMIR W=20u L=1u
Mo2_uU_L3_9_9 gp_3_9_9 dpre_L3_9 ts_uU_L3_9_9 0 NMIR W=20u L=1u
Mo3_uU_L3_9_9 da_uU_L3_9_9 da_uU_L3_9_9 vdd vdd PMIR W=60u L=1u
Mo4_uU_L3_9_9 gp_3_9_9 da_uU_L3_9_9 vdd vdd PMIR W=60u L=1u
Mt_uU_L3_9_10 ts_uU_L3_9_10 hv_L2_37 0 0 NMIR W=48.0u L=1u
Mo1_uU_L3_9_10 da_uU_L3_9_10 d1bar_L3 ts_uU_L3_9_10 0 NMIR W=20u L=1u
Mo2_uU_L3_9_10 gp_3_9_10 dpre_L3_9 ts_uU_L3_9_10 0 NMIR W=20u L=1u
Mo3_uU_L3_9_10 da_uU_L3_9_10 da_uU_L3_9_10 vdd vdd PMIR W=60u L=1u
Mo4_uU_L3_9_10 gp_3_9_10 da_uU_L3_9_10 vdd vdd PMIR W=60u L=1u
Mt_uU_L3_9_11 ts_uU_L3_9_11 hv_L2_39 0 0 NMIR W=48.0u L=1u
Mo1_uU_L3_9_11 da_uU_L3_9_11 d1bar_L3 ts_uU_L3_9_11 0 NMIR W=20u L=1u
Mo2_uU_L3_9_11 gp_3_9_11 dpre_L3_9 ts_uU_L3_9_11 0 NMIR W=20u L=1u
Mo3_uU_L3_9_11 da_uU_L3_9_11 da_uU_L3_9_11 vdd vdd PMIR W=60u L=1u
Mo4_uU_L3_9_11 gp_3_9_11 da_uU_L3_9_11 vdd vdd PMIR W=60u L=1u
Mt_uU_L3_9_12 ts_uU_L3_9_12 hv_L2_41 0 0 NMIR W=48.0u L=1u
Mo1_uU_L3_9_12 da_uU_L3_9_12 d1bar_L3 ts_uU_L3_9_12 0 NMIR W=20u L=1u
Mo2_uU_L3_9_12 gp_3_9_12 dpre_L3_9 ts_uU_L3_9_12 0 NMIR W=20u L=1u
Mo3_uU_L3_9_12 da_uU_L3_9_12 da_uU_L3_9_12 vdd vdd PMIR W=60u L=1u
Mo4_uU_L3_9_12 gp_3_9_12 da_uU_L3_9_12 vdd vdd PMIR W=60u L=1u
Mt_uU_L3_9_13 ts_uU_L3_9_13 hv_L2_42 0 0 NMIR W=48.0u L=1u
Mo1_uU_L3_9_13 da_uU_L3_9_13 d1bar_L3 ts_uU_L3_9_13 0 NMIR W=20u L=1u
Mo2_uU_L3_9_13 gp_3_9_13 dpre_L3_9 ts_uU_L3_9_13 0 NMIR W=20u L=1u
Mo3_uU_L3_9_13 da_uU_L3_9_13 da_uU_L3_9_13 vdd vdd PMIR W=60u L=1u
Mo4_uU_L3_9_13 gp_3_9_13 da_uU_L3_9_13 vdd vdd PMIR W=60u L=1u
Mt_uU_L3_9_14 ts_uU_L3_9_14 hv_L2_44 0 0 NMIR W=48.0u L=1u
Mo1_uU_L3_9_14 da_uU_L3_9_14 d1bar_L3 ts_uU_L3_9_14 0 NMIR W=20u L=1u
Mo2_uU_L3_9_14 gp_3_9_14 dpre_L3_9 ts_uU_L3_9_14 0 NMIR W=20u L=1u
Mo3_uU_L3_9_14 da_uU_L3_9_14 da_uU_L3_9_14 vdd vdd PMIR W=60u L=1u
Mo4_uU_L3_9_14 gp_3_9_14 da_uU_L3_9_14 vdd vdd PMIR W=60u L=1u
Mt_uU_L3_9_15 ts_uU_L3_9_15 hv_L2_47 0 0 NMIR W=48.0u L=1u
Mo1_uU_L3_9_15 da_uU_L3_9_15 d1bar_L3 ts_uU_L3_9_15 0 NMIR W=20u L=1u
Mo2_uU_L3_9_15 gp_3_9_15 dpre_L3_9 ts_uU_L3_9_15 0 NMIR W=20u L=1u
Mo3_uU_L3_9_15 da_uU_L3_9_15 da_uU_L3_9_15 vdd vdd PMIR W=60u L=1u
Mo4_uU_L3_9_15 gp_3_9_15 da_uU_L3_9_15 vdd vdd PMIR W=60u L=1u
Mt_uU_L3_10_0 ts_uU_L3_10_0 hv_L2_8 0 0 NMIR W=48.0u L=1u
Mo1_uU_L3_10_0 da_uU_L3_10_0 d1bar_L3 ts_uU_L3_10_0 0 NMIR W=20u L=1u
Mo2_uU_L3_10_0 gp_3_10_0 dpre_L3_10 ts_uU_L3_10_0 0 NMIR W=20u L=1u
Mo3_uU_L3_10_0 da_uU_L3_10_0 da_uU_L3_10_0 vdd vdd PMIR W=60u L=1u
Mo4_uU_L3_10_0 gp_3_10_0 da_uU_L3_10_0 vdd vdd PMIR W=60u L=1u
Mt_uU_L3_10_1 ts_uU_L3_10_1 hv_L2_9 0 0 NMIR W=48.0u L=1u
Mo1_uU_L3_10_1 da_uU_L3_10_1 d1bar_L3 ts_uU_L3_10_1 0 NMIR W=20u L=1u
Mo2_uU_L3_10_1 gp_3_10_1 dpre_L3_10 ts_uU_L3_10_1 0 NMIR W=20u L=1u
Mo3_uU_L3_10_1 da_uU_L3_10_1 da_uU_L3_10_1 vdd vdd PMIR W=60u L=1u
Mo4_uU_L3_10_1 gp_3_10_1 da_uU_L3_10_1 vdd vdd PMIR W=60u L=1u
Mt_uU_L3_10_2 ts_uU_L3_10_2 hv_L2_10 0 0 NMIR W=48.0u L=1u
Mo1_uU_L3_10_2 da_uU_L3_10_2 d1bar_L3 ts_uU_L3_10_2 0 NMIR W=20u L=1u
Mo2_uU_L3_10_2 gp_3_10_2 dpre_L3_10 ts_uU_L3_10_2 0 NMIR W=20u L=1u
Mo3_uU_L3_10_2 da_uU_L3_10_2 da_uU_L3_10_2 vdd vdd PMIR W=60u L=1u
Mo4_uU_L3_10_2 gp_3_10_2 da_uU_L3_10_2 vdd vdd PMIR W=60u L=1u
Mt_uU_L3_10_3 ts_uU_L3_10_3 hv_L2_11 0 0 NMIR W=48.0u L=1u
Mo1_uU_L3_10_3 da_uU_L3_10_3 d1bar_L3 ts_uU_L3_10_3 0 NMIR W=20u L=1u
Mo2_uU_L3_10_3 gp_3_10_3 dpre_L3_10 ts_uU_L3_10_3 0 NMIR W=20u L=1u
Mo3_uU_L3_10_3 da_uU_L3_10_3 da_uU_L3_10_3 vdd vdd PMIR W=60u L=1u
Mo4_uU_L3_10_3 gp_3_10_3 da_uU_L3_10_3 vdd vdd PMIR W=60u L=1u
Mt_uU_L3_10_4 ts_uU_L3_10_4 hv_L2_15 0 0 NMIR W=48.0u L=1u
Mo1_uU_L3_10_4 da_uU_L3_10_4 d1bar_L3 ts_uU_L3_10_4 0 NMIR W=20u L=1u
Mo2_uU_L3_10_4 gp_3_10_4 dpre_L3_10 ts_uU_L3_10_4 0 NMIR W=20u L=1u
Mo3_uU_L3_10_4 da_uU_L3_10_4 da_uU_L3_10_4 vdd vdd PMIR W=60u L=1u
Mo4_uU_L3_10_4 gp_3_10_4 da_uU_L3_10_4 vdd vdd PMIR W=60u L=1u
Mt_uU_L3_10_5 ts_uU_L3_10_5 hv_L2_20 0 0 NMIR W=48.0u L=1u
Mo1_uU_L3_10_5 da_uU_L3_10_5 d1bar_L3 ts_uU_L3_10_5 0 NMIR W=20u L=1u
Mo2_uU_L3_10_5 gp_3_10_5 dpre_L3_10 ts_uU_L3_10_5 0 NMIR W=20u L=1u
Mo3_uU_L3_10_5 da_uU_L3_10_5 da_uU_L3_10_5 vdd vdd PMIR W=60u L=1u
Mo4_uU_L3_10_5 gp_3_10_5 da_uU_L3_10_5 vdd vdd PMIR W=60u L=1u
Mt_uU_L3_10_6 ts_uU_L3_10_6 hv_L2_23 0 0 NMIR W=48.0u L=1u
Mo1_uU_L3_10_6 da_uU_L3_10_6 d1bar_L3 ts_uU_L3_10_6 0 NMIR W=20u L=1u
Mo2_uU_L3_10_6 gp_3_10_6 dpre_L3_10 ts_uU_L3_10_6 0 NMIR W=20u L=1u
Mo3_uU_L3_10_6 da_uU_L3_10_6 da_uU_L3_10_6 vdd vdd PMIR W=60u L=1u
Mo4_uU_L3_10_6 gp_3_10_6 da_uU_L3_10_6 vdd vdd PMIR W=60u L=1u
Mt_uU_L3_10_7 ts_uU_L3_10_7 hv_L2_24 0 0 NMIR W=48.0u L=1u
Mo1_uU_L3_10_7 da_uU_L3_10_7 d1bar_L3 ts_uU_L3_10_7 0 NMIR W=20u L=1u
Mo2_uU_L3_10_7 gp_3_10_7 dpre_L3_10 ts_uU_L3_10_7 0 NMIR W=20u L=1u
Mo3_uU_L3_10_7 da_uU_L3_10_7 da_uU_L3_10_7 vdd vdd PMIR W=60u L=1u
Mo4_uU_L3_10_7 gp_3_10_7 da_uU_L3_10_7 vdd vdd PMIR W=60u L=1u
Mt_uU_L3_10_8 ts_uU_L3_10_8 hv_L2_29 0 0 NMIR W=48.0u L=1u
Mo1_uU_L3_10_8 da_uU_L3_10_8 d1bar_L3 ts_uU_L3_10_8 0 NMIR W=20u L=1u
Mo2_uU_L3_10_8 gp_3_10_8 dpre_L3_10 ts_uU_L3_10_8 0 NMIR W=20u L=1u
Mo3_uU_L3_10_8 da_uU_L3_10_8 da_uU_L3_10_8 vdd vdd PMIR W=60u L=1u
Mo4_uU_L3_10_8 gp_3_10_8 da_uU_L3_10_8 vdd vdd PMIR W=60u L=1u
Mt_uU_L3_10_9 ts_uU_L3_10_9 hv_L2_33 0 0 NMIR W=48.0u L=1u
Mo1_uU_L3_10_9 da_uU_L3_10_9 d1bar_L3 ts_uU_L3_10_9 0 NMIR W=20u L=1u
Mo2_uU_L3_10_9 gp_3_10_9 dpre_L3_10 ts_uU_L3_10_9 0 NMIR W=20u L=1u
Mo3_uU_L3_10_9 da_uU_L3_10_9 da_uU_L3_10_9 vdd vdd PMIR W=60u L=1u
Mo4_uU_L3_10_9 gp_3_10_9 da_uU_L3_10_9 vdd vdd PMIR W=60u L=1u
Mt_uU_L3_10_10 ts_uU_L3_10_10 hv_L2_34 0 0 NMIR W=48.0u L=1u
Mo1_uU_L3_10_10 da_uU_L3_10_10 d1bar_L3 ts_uU_L3_10_10 0 NMIR W=20u L=1u
Mo2_uU_L3_10_10 gp_3_10_10 dpre_L3_10 ts_uU_L3_10_10 0 NMIR W=20u L=1u
Mo3_uU_L3_10_10 da_uU_L3_10_10 da_uU_L3_10_10 vdd vdd PMIR W=60u L=1u
Mo4_uU_L3_10_10 gp_3_10_10 da_uU_L3_10_10 vdd vdd PMIR W=60u L=1u
Mt_uU_L3_10_11 ts_uU_L3_10_11 hv_L2_37 0 0 NMIR W=48.0u L=1u
Mo1_uU_L3_10_11 da_uU_L3_10_11 d1bar_L3 ts_uU_L3_10_11 0 NMIR W=20u L=1u
Mo2_uU_L3_10_11 gp_3_10_11 dpre_L3_10 ts_uU_L3_10_11 0 NMIR W=20u L=1u
Mo3_uU_L3_10_11 da_uU_L3_10_11 da_uU_L3_10_11 vdd vdd PMIR W=60u L=1u
Mo4_uU_L3_10_11 gp_3_10_11 da_uU_L3_10_11 vdd vdd PMIR W=60u L=1u
Mt_uU_L3_10_12 ts_uU_L3_10_12 hv_L2_40 0 0 NMIR W=48.0u L=1u
Mo1_uU_L3_10_12 da_uU_L3_10_12 d1bar_L3 ts_uU_L3_10_12 0 NMIR W=20u L=1u
Mo2_uU_L3_10_12 gp_3_10_12 dpre_L3_10 ts_uU_L3_10_12 0 NMIR W=20u L=1u
Mo3_uU_L3_10_12 da_uU_L3_10_12 da_uU_L3_10_12 vdd vdd PMIR W=60u L=1u
Mo4_uU_L3_10_12 gp_3_10_12 da_uU_L3_10_12 vdd vdd PMIR W=60u L=1u
Mt_uU_L3_10_13 ts_uU_L3_10_13 hv_L2_41 0 0 NMIR W=48.0u L=1u
Mo1_uU_L3_10_13 da_uU_L3_10_13 d1bar_L3 ts_uU_L3_10_13 0 NMIR W=20u L=1u
Mo2_uU_L3_10_13 gp_3_10_13 dpre_L3_10 ts_uU_L3_10_13 0 NMIR W=20u L=1u
Mo3_uU_L3_10_13 da_uU_L3_10_13 da_uU_L3_10_13 vdd vdd PMIR W=60u L=1u
Mo4_uU_L3_10_13 gp_3_10_13 da_uU_L3_10_13 vdd vdd PMIR W=60u L=1u
Mt_uU_L3_10_14 ts_uU_L3_10_14 hv_L2_44 0 0 NMIR W=48.0u L=1u
Mo1_uU_L3_10_14 da_uU_L3_10_14 d1bar_L3 ts_uU_L3_10_14 0 NMIR W=20u L=1u
Mo2_uU_L3_10_14 gp_3_10_14 dpre_L3_10 ts_uU_L3_10_14 0 NMIR W=20u L=1u
Mo3_uU_L3_10_14 da_uU_L3_10_14 da_uU_L3_10_14 vdd vdd PMIR W=60u L=1u
Mo4_uU_L3_10_14 gp_3_10_14 da_uU_L3_10_14 vdd vdd PMIR W=60u L=1u
Mt_uU_L3_10_15 ts_uU_L3_10_15 hv_L2_46 0 0 NMIR W=48.0u L=1u
Mo1_uU_L3_10_15 da_uU_L3_10_15 d1bar_L3 ts_uU_L3_10_15 0 NMIR W=20u L=1u
Mo2_uU_L3_10_15 gp_3_10_15 dpre_L3_10 ts_uU_L3_10_15 0 NMIR W=20u L=1u
Mo3_uU_L3_10_15 da_uU_L3_10_15 da_uU_L3_10_15 vdd vdd PMIR W=60u L=1u
Mo4_uU_L3_10_15 gp_3_10_15 da_uU_L3_10_15 vdd vdd PMIR W=60u L=1u
Mt_uU_L3_11_0 ts_uU_L3_11_0 hv_L2_1 0 0 NMIR W=48.0u L=1u
Mo1_uU_L3_11_0 da_uU_L3_11_0 d1bar_L3 ts_uU_L3_11_0 0 NMIR W=20u L=1u
Mo2_uU_L3_11_0 gp_3_11_0 dpre_L3_11 ts_uU_L3_11_0 0 NMIR W=20u L=1u
Mo3_uU_L3_11_0 da_uU_L3_11_0 da_uU_L3_11_0 vdd vdd PMIR W=60u L=1u
Mo4_uU_L3_11_0 gp_3_11_0 da_uU_L3_11_0 vdd vdd PMIR W=60u L=1u
Mt_uU_L3_11_1 ts_uU_L3_11_1 hv_L2_2 0 0 NMIR W=48.0u L=1u
Mo1_uU_L3_11_1 da_uU_L3_11_1 d1bar_L3 ts_uU_L3_11_1 0 NMIR W=20u L=1u
Mo2_uU_L3_11_1 gp_3_11_1 dpre_L3_11 ts_uU_L3_11_1 0 NMIR W=20u L=1u
Mo3_uU_L3_11_1 da_uU_L3_11_1 da_uU_L3_11_1 vdd vdd PMIR W=60u L=1u
Mo4_uU_L3_11_1 gp_3_11_1 da_uU_L3_11_1 vdd vdd PMIR W=60u L=1u
Mt_uU_L3_11_2 ts_uU_L3_11_2 hv_L2_5 0 0 NMIR W=48.0u L=1u
Mo1_uU_L3_11_2 da_uU_L3_11_2 d1bar_L3 ts_uU_L3_11_2 0 NMIR W=20u L=1u
Mo2_uU_L3_11_2 gp_3_11_2 dpre_L3_11 ts_uU_L3_11_2 0 NMIR W=20u L=1u
Mo3_uU_L3_11_2 da_uU_L3_11_2 da_uU_L3_11_2 vdd vdd PMIR W=60u L=1u
Mo4_uU_L3_11_2 gp_3_11_2 da_uU_L3_11_2 vdd vdd PMIR W=60u L=1u
Mt_uU_L3_11_3 ts_uU_L3_11_3 hv_L2_9 0 0 NMIR W=48.0u L=1u
Mo1_uU_L3_11_3 da_uU_L3_11_3 d1bar_L3 ts_uU_L3_11_3 0 NMIR W=20u L=1u
Mo2_uU_L3_11_3 gp_3_11_3 dpre_L3_11 ts_uU_L3_11_3 0 NMIR W=20u L=1u
Mo3_uU_L3_11_3 da_uU_L3_11_3 da_uU_L3_11_3 vdd vdd PMIR W=60u L=1u
Mo4_uU_L3_11_3 gp_3_11_3 da_uU_L3_11_3 vdd vdd PMIR W=60u L=1u
Mt_uU_L3_11_4 ts_uU_L3_11_4 hv_L2_13 0 0 NMIR W=48.0u L=1u
Mo1_uU_L3_11_4 da_uU_L3_11_4 d1bar_L3 ts_uU_L3_11_4 0 NMIR W=20u L=1u
Mo2_uU_L3_11_4 gp_3_11_4 dpre_L3_11 ts_uU_L3_11_4 0 NMIR W=20u L=1u
Mo3_uU_L3_11_4 da_uU_L3_11_4 da_uU_L3_11_4 vdd vdd PMIR W=60u L=1u
Mo4_uU_L3_11_4 gp_3_11_4 da_uU_L3_11_4 vdd vdd PMIR W=60u L=1u
Mt_uU_L3_11_5 ts_uU_L3_11_5 hv_L2_25 0 0 NMIR W=48.0u L=1u
Mo1_uU_L3_11_5 da_uU_L3_11_5 d1bar_L3 ts_uU_L3_11_5 0 NMIR W=20u L=1u
Mo2_uU_L3_11_5 gp_3_11_5 dpre_L3_11 ts_uU_L3_11_5 0 NMIR W=20u L=1u
Mo3_uU_L3_11_5 da_uU_L3_11_5 da_uU_L3_11_5 vdd vdd PMIR W=60u L=1u
Mo4_uU_L3_11_5 gp_3_11_5 da_uU_L3_11_5 vdd vdd PMIR W=60u L=1u
Mt_uU_L3_11_6 ts_uU_L3_11_6 hv_L2_26 0 0 NMIR W=48.0u L=1u
Mo1_uU_L3_11_6 da_uU_L3_11_6 d1bar_L3 ts_uU_L3_11_6 0 NMIR W=20u L=1u
Mo2_uU_L3_11_6 gp_3_11_6 dpre_L3_11 ts_uU_L3_11_6 0 NMIR W=20u L=1u
Mo3_uU_L3_11_6 da_uU_L3_11_6 da_uU_L3_11_6 vdd vdd PMIR W=60u L=1u
Mo4_uU_L3_11_6 gp_3_11_6 da_uU_L3_11_6 vdd vdd PMIR W=60u L=1u
Mt_uU_L3_11_7 ts_uU_L3_11_7 hv_L2_27 0 0 NMIR W=48.0u L=1u
Mo1_uU_L3_11_7 da_uU_L3_11_7 d1bar_L3 ts_uU_L3_11_7 0 NMIR W=20u L=1u
Mo2_uU_L3_11_7 gp_3_11_7 dpre_L3_11 ts_uU_L3_11_7 0 NMIR W=20u L=1u
Mo3_uU_L3_11_7 da_uU_L3_11_7 da_uU_L3_11_7 vdd vdd PMIR W=60u L=1u
Mo4_uU_L3_11_7 gp_3_11_7 da_uU_L3_11_7 vdd vdd PMIR W=60u L=1u
Mt_uU_L3_11_8 ts_uU_L3_11_8 hv_L2_28 0 0 NMIR W=48.0u L=1u
Mo1_uU_L3_11_8 da_uU_L3_11_8 d1bar_L3 ts_uU_L3_11_8 0 NMIR W=20u L=1u
Mo2_uU_L3_11_8 gp_3_11_8 dpre_L3_11 ts_uU_L3_11_8 0 NMIR W=20u L=1u
Mo3_uU_L3_11_8 da_uU_L3_11_8 da_uU_L3_11_8 vdd vdd PMIR W=60u L=1u
Mo4_uU_L3_11_8 gp_3_11_8 da_uU_L3_11_8 vdd vdd PMIR W=60u L=1u
Mt_uU_L3_11_9 ts_uU_L3_11_9 hv_L2_29 0 0 NMIR W=48.0u L=1u
Mo1_uU_L3_11_9 da_uU_L3_11_9 d1bar_L3 ts_uU_L3_11_9 0 NMIR W=20u L=1u
Mo2_uU_L3_11_9 gp_3_11_9 dpre_L3_11 ts_uU_L3_11_9 0 NMIR W=20u L=1u
Mo3_uU_L3_11_9 da_uU_L3_11_9 da_uU_L3_11_9 vdd vdd PMIR W=60u L=1u
Mo4_uU_L3_11_9 gp_3_11_9 da_uU_L3_11_9 vdd vdd PMIR W=60u L=1u
Mt_uU_L3_11_10 ts_uU_L3_11_10 hv_L2_30 0 0 NMIR W=48.0u L=1u
Mo1_uU_L3_11_10 da_uU_L3_11_10 d1bar_L3 ts_uU_L3_11_10 0 NMIR W=20u L=1u
Mo2_uU_L3_11_10 gp_3_11_10 dpre_L3_11 ts_uU_L3_11_10 0 NMIR W=20u L=1u
Mo3_uU_L3_11_10 da_uU_L3_11_10 da_uU_L3_11_10 vdd vdd PMIR W=60u L=1u
Mo4_uU_L3_11_10 gp_3_11_10 da_uU_L3_11_10 vdd vdd PMIR W=60u L=1u
Mt_uU_L3_11_11 ts_uU_L3_11_11 hv_L2_39 0 0 NMIR W=48.0u L=1u
Mo1_uU_L3_11_11 da_uU_L3_11_11 d1bar_L3 ts_uU_L3_11_11 0 NMIR W=20u L=1u
Mo2_uU_L3_11_11 gp_3_11_11 dpre_L3_11 ts_uU_L3_11_11 0 NMIR W=20u L=1u
Mo3_uU_L3_11_11 da_uU_L3_11_11 da_uU_L3_11_11 vdd vdd PMIR W=60u L=1u
Mo4_uU_L3_11_11 gp_3_11_11 da_uU_L3_11_11 vdd vdd PMIR W=60u L=1u
Mt_uU_L3_11_12 ts_uU_L3_11_12 hv_L2_41 0 0 NMIR W=48.0u L=1u
Mo1_uU_L3_11_12 da_uU_L3_11_12 d1bar_L3 ts_uU_L3_11_12 0 NMIR W=20u L=1u
Mo2_uU_L3_11_12 gp_3_11_12 dpre_L3_11 ts_uU_L3_11_12 0 NMIR W=20u L=1u
Mo3_uU_L3_11_12 da_uU_L3_11_12 da_uU_L3_11_12 vdd vdd PMIR W=60u L=1u
Mo4_uU_L3_11_12 gp_3_11_12 da_uU_L3_11_12 vdd vdd PMIR W=60u L=1u
Mt_uU_L3_11_13 ts_uU_L3_11_13 hv_L2_42 0 0 NMIR W=48.0u L=1u
Mo1_uU_L3_11_13 da_uU_L3_11_13 d1bar_L3 ts_uU_L3_11_13 0 NMIR W=20u L=1u
Mo2_uU_L3_11_13 gp_3_11_13 dpre_L3_11 ts_uU_L3_11_13 0 NMIR W=20u L=1u
Mo3_uU_L3_11_13 da_uU_L3_11_13 da_uU_L3_11_13 vdd vdd PMIR W=60u L=1u
Mo4_uU_L3_11_13 gp_3_11_13 da_uU_L3_11_13 vdd vdd PMIR W=60u L=1u
Mt_uU_L3_11_14 ts_uU_L3_11_14 hv_L2_44 0 0 NMIR W=48.0u L=1u
Mo1_uU_L3_11_14 da_uU_L3_11_14 d1bar_L3 ts_uU_L3_11_14 0 NMIR W=20u L=1u
Mo2_uU_L3_11_14 gp_3_11_14 dpre_L3_11 ts_uU_L3_11_14 0 NMIR W=20u L=1u
Mo3_uU_L3_11_14 da_uU_L3_11_14 da_uU_L3_11_14 vdd vdd PMIR W=60u L=1u
Mo4_uU_L3_11_14 gp_3_11_14 da_uU_L3_11_14 vdd vdd PMIR W=60u L=1u
Mt_uU_L3_11_15 ts_uU_L3_11_15 hv_L2_45 0 0 NMIR W=48.0u L=1u
Mo1_uU_L3_11_15 da_uU_L3_11_15 d1bar_L3 ts_uU_L3_11_15 0 NMIR W=20u L=1u
Mo2_uU_L3_11_15 gp_3_11_15 dpre_L3_11 ts_uU_L3_11_15 0 NMIR W=20u L=1u
Mo3_uU_L3_11_15 da_uU_L3_11_15 da_uU_L3_11_15 vdd vdd PMIR W=60u L=1u
Mo4_uU_L3_11_15 gp_3_11_15 da_uU_L3_11_15 vdd vdd PMIR W=60u L=1u
Mt_uU_L3_12_0 ts_uU_L3_12_0 hv_L2_7 0 0 NMIR W=48.0u L=1u
Mo1_uU_L3_12_0 da_uU_L3_12_0 d1bar_L3 ts_uU_L3_12_0 0 NMIR W=20u L=1u
Mo2_uU_L3_12_0 gp_3_12_0 dpre_L3_12 ts_uU_L3_12_0 0 NMIR W=20u L=1u
Mo3_uU_L3_12_0 da_uU_L3_12_0 da_uU_L3_12_0 vdd vdd PMIR W=60u L=1u
Mo4_uU_L3_12_0 gp_3_12_0 da_uU_L3_12_0 vdd vdd PMIR W=60u L=1u
Mt_uU_L3_12_1 ts_uU_L3_12_1 hv_L2_13 0 0 NMIR W=48.0u L=1u
Mo1_uU_L3_12_1 da_uU_L3_12_1 d1bar_L3 ts_uU_L3_12_1 0 NMIR W=20u L=1u
Mo2_uU_L3_12_1 gp_3_12_1 dpre_L3_12 ts_uU_L3_12_1 0 NMIR W=20u L=1u
Mo3_uU_L3_12_1 da_uU_L3_12_1 da_uU_L3_12_1 vdd vdd PMIR W=60u L=1u
Mo4_uU_L3_12_1 gp_3_12_1 da_uU_L3_12_1 vdd vdd PMIR W=60u L=1u
Mt_uU_L3_12_2 ts_uU_L3_12_2 hv_L2_14 0 0 NMIR W=48.0u L=1u
Mo1_uU_L3_12_2 da_uU_L3_12_2 d1bar_L3 ts_uU_L3_12_2 0 NMIR W=20u L=1u
Mo2_uU_L3_12_2 gp_3_12_2 dpre_L3_12 ts_uU_L3_12_2 0 NMIR W=20u L=1u
Mo3_uU_L3_12_2 da_uU_L3_12_2 da_uU_L3_12_2 vdd vdd PMIR W=60u L=1u
Mo4_uU_L3_12_2 gp_3_12_2 da_uU_L3_12_2 vdd vdd PMIR W=60u L=1u
Mt_uU_L3_12_3 ts_uU_L3_12_3 hv_L2_23 0 0 NMIR W=48.0u L=1u
Mo1_uU_L3_12_3 da_uU_L3_12_3 d1bar_L3 ts_uU_L3_12_3 0 NMIR W=20u L=1u
Mo2_uU_L3_12_3 gp_3_12_3 dpre_L3_12 ts_uU_L3_12_3 0 NMIR W=20u L=1u
Mo3_uU_L3_12_3 da_uU_L3_12_3 da_uU_L3_12_3 vdd vdd PMIR W=60u L=1u
Mo4_uU_L3_12_3 gp_3_12_3 da_uU_L3_12_3 vdd vdd PMIR W=60u L=1u
Mt_uU_L3_12_4 ts_uU_L3_12_4 hv_L2_24 0 0 NMIR W=48.0u L=1u
Mo1_uU_L3_12_4 da_uU_L3_12_4 d1bar_L3 ts_uU_L3_12_4 0 NMIR W=20u L=1u
Mo2_uU_L3_12_4 gp_3_12_4 dpre_L3_12 ts_uU_L3_12_4 0 NMIR W=20u L=1u
Mo3_uU_L3_12_4 da_uU_L3_12_4 da_uU_L3_12_4 vdd vdd PMIR W=60u L=1u
Mo4_uU_L3_12_4 gp_3_12_4 da_uU_L3_12_4 vdd vdd PMIR W=60u L=1u
Mt_uU_L3_12_5 ts_uU_L3_12_5 hv_L2_25 0 0 NMIR W=48.0u L=1u
Mo1_uU_L3_12_5 da_uU_L3_12_5 d1bar_L3 ts_uU_L3_12_5 0 NMIR W=20u L=1u
Mo2_uU_L3_12_5 gp_3_12_5 dpre_L3_12 ts_uU_L3_12_5 0 NMIR W=20u L=1u
Mo3_uU_L3_12_5 da_uU_L3_12_5 da_uU_L3_12_5 vdd vdd PMIR W=60u L=1u
Mo4_uU_L3_12_5 gp_3_12_5 da_uU_L3_12_5 vdd vdd PMIR W=60u L=1u
Mt_uU_L3_12_6 ts_uU_L3_12_6 hv_L2_29 0 0 NMIR W=48.0u L=1u
Mo1_uU_L3_12_6 da_uU_L3_12_6 d1bar_L3 ts_uU_L3_12_6 0 NMIR W=20u L=1u
Mo2_uU_L3_12_6 gp_3_12_6 dpre_L3_12 ts_uU_L3_12_6 0 NMIR W=20u L=1u
Mo3_uU_L3_12_6 da_uU_L3_12_6 da_uU_L3_12_6 vdd vdd PMIR W=60u L=1u
Mo4_uU_L3_12_6 gp_3_12_6 da_uU_L3_12_6 vdd vdd PMIR W=60u L=1u
Mt_uU_L3_12_7 ts_uU_L3_12_7 hv_L2_30 0 0 NMIR W=48.0u L=1u
Mo1_uU_L3_12_7 da_uU_L3_12_7 d1bar_L3 ts_uU_L3_12_7 0 NMIR W=20u L=1u
Mo2_uU_L3_12_7 gp_3_12_7 dpre_L3_12 ts_uU_L3_12_7 0 NMIR W=20u L=1u
Mo3_uU_L3_12_7 da_uU_L3_12_7 da_uU_L3_12_7 vdd vdd PMIR W=60u L=1u
Mo4_uU_L3_12_7 gp_3_12_7 da_uU_L3_12_7 vdd vdd PMIR W=60u L=1u
Mt_uU_L3_12_8 ts_uU_L3_12_8 hv_L2_33 0 0 NMIR W=48.0u L=1u
Mo1_uU_L3_12_8 da_uU_L3_12_8 d1bar_L3 ts_uU_L3_12_8 0 NMIR W=20u L=1u
Mo2_uU_L3_12_8 gp_3_12_8 dpre_L3_12 ts_uU_L3_12_8 0 NMIR W=20u L=1u
Mo3_uU_L3_12_8 da_uU_L3_12_8 da_uU_L3_12_8 vdd vdd PMIR W=60u L=1u
Mo4_uU_L3_12_8 gp_3_12_8 da_uU_L3_12_8 vdd vdd PMIR W=60u L=1u
Mt_uU_L3_12_9 ts_uU_L3_12_9 hv_L2_34 0 0 NMIR W=48.0u L=1u
Mo1_uU_L3_12_9 da_uU_L3_12_9 d1bar_L3 ts_uU_L3_12_9 0 NMIR W=20u L=1u
Mo2_uU_L3_12_9 gp_3_12_9 dpre_L3_12 ts_uU_L3_12_9 0 NMIR W=20u L=1u
Mo3_uU_L3_12_9 da_uU_L3_12_9 da_uU_L3_12_9 vdd vdd PMIR W=60u L=1u
Mo4_uU_L3_12_9 gp_3_12_9 da_uU_L3_12_9 vdd vdd PMIR W=60u L=1u
Mt_uU_L3_12_10 ts_uU_L3_12_10 hv_L2_35 0 0 NMIR W=48.0u L=1u
Mo1_uU_L3_12_10 da_uU_L3_12_10 d1bar_L3 ts_uU_L3_12_10 0 NMIR W=20u L=1u
Mo2_uU_L3_12_10 gp_3_12_10 dpre_L3_12 ts_uU_L3_12_10 0 NMIR W=20u L=1u
Mo3_uU_L3_12_10 da_uU_L3_12_10 da_uU_L3_12_10 vdd vdd PMIR W=60u L=1u
Mo4_uU_L3_12_10 gp_3_12_10 da_uU_L3_12_10 vdd vdd PMIR W=60u L=1u
Mt_uU_L3_12_11 ts_uU_L3_12_11 hv_L2_36 0 0 NMIR W=48.0u L=1u
Mo1_uU_L3_12_11 da_uU_L3_12_11 d1bar_L3 ts_uU_L3_12_11 0 NMIR W=20u L=1u
Mo2_uU_L3_12_11 gp_3_12_11 dpre_L3_12 ts_uU_L3_12_11 0 NMIR W=20u L=1u
Mo3_uU_L3_12_11 da_uU_L3_12_11 da_uU_L3_12_11 vdd vdd PMIR W=60u L=1u
Mo4_uU_L3_12_11 gp_3_12_11 da_uU_L3_12_11 vdd vdd PMIR W=60u L=1u
Mt_uU_L3_12_12 ts_uU_L3_12_12 hv_L2_38 0 0 NMIR W=48.0u L=1u
Mo1_uU_L3_12_12 da_uU_L3_12_12 d1bar_L3 ts_uU_L3_12_12 0 NMIR W=20u L=1u
Mo2_uU_L3_12_12 gp_3_12_12 dpre_L3_12 ts_uU_L3_12_12 0 NMIR W=20u L=1u
Mo3_uU_L3_12_12 da_uU_L3_12_12 da_uU_L3_12_12 vdd vdd PMIR W=60u L=1u
Mo4_uU_L3_12_12 gp_3_12_12 da_uU_L3_12_12 vdd vdd PMIR W=60u L=1u
Mt_uU_L3_12_13 ts_uU_L3_12_13 hv_L2_45 0 0 NMIR W=48.0u L=1u
Mo1_uU_L3_12_13 da_uU_L3_12_13 d1bar_L3 ts_uU_L3_12_13 0 NMIR W=20u L=1u
Mo2_uU_L3_12_13 gp_3_12_13 dpre_L3_12 ts_uU_L3_12_13 0 NMIR W=20u L=1u
Mo3_uU_L3_12_13 da_uU_L3_12_13 da_uU_L3_12_13 vdd vdd PMIR W=60u L=1u
Mo4_uU_L3_12_13 gp_3_12_13 da_uU_L3_12_13 vdd vdd PMIR W=60u L=1u
Mt_uU_L3_12_14 ts_uU_L3_12_14 hv_L2_46 0 0 NMIR W=48.0u L=1u
Mo1_uU_L3_12_14 da_uU_L3_12_14 d1bar_L3 ts_uU_L3_12_14 0 NMIR W=20u L=1u
Mo2_uU_L3_12_14 gp_3_12_14 dpre_L3_12 ts_uU_L3_12_14 0 NMIR W=20u L=1u
Mo3_uU_L3_12_14 da_uU_L3_12_14 da_uU_L3_12_14 vdd vdd PMIR W=60u L=1u
Mo4_uU_L3_12_14 gp_3_12_14 da_uU_L3_12_14 vdd vdd PMIR W=60u L=1u
Mt_uU_L3_12_15 ts_uU_L3_12_15 hv_L2_47 0 0 NMIR W=48.0u L=1u
Mo1_uU_L3_12_15 da_uU_L3_12_15 d1bar_L3 ts_uU_L3_12_15 0 NMIR W=20u L=1u
Mo2_uU_L3_12_15 gp_3_12_15 dpre_L3_12 ts_uU_L3_12_15 0 NMIR W=20u L=1u
Mo3_uU_L3_12_15 da_uU_L3_12_15 da_uU_L3_12_15 vdd vdd PMIR W=60u L=1u
Mo4_uU_L3_12_15 gp_3_12_15 da_uU_L3_12_15 vdd vdd PMIR W=60u L=1u
Mt_uU_L3_13_0 ts_uU_L3_13_0 hv_L2_0 0 0 NMIR W=48.0u L=1u
Mo1_uU_L3_13_0 da_uU_L3_13_0 d1bar_L3 ts_uU_L3_13_0 0 NMIR W=20u L=1u
Mo2_uU_L3_13_0 gp_3_13_0 dpre_L3_13 ts_uU_L3_13_0 0 NMIR W=20u L=1u
Mo3_uU_L3_13_0 da_uU_L3_13_0 da_uU_L3_13_0 vdd vdd PMIR W=60u L=1u
Mo4_uU_L3_13_0 gp_3_13_0 da_uU_L3_13_0 vdd vdd PMIR W=60u L=1u
Mt_uU_L3_13_1 ts_uU_L3_13_1 hv_L2_1 0 0 NMIR W=48.0u L=1u
Mo1_uU_L3_13_1 da_uU_L3_13_1 d1bar_L3 ts_uU_L3_13_1 0 NMIR W=20u L=1u
Mo2_uU_L3_13_1 gp_3_13_1 dpre_L3_13 ts_uU_L3_13_1 0 NMIR W=20u L=1u
Mo3_uU_L3_13_1 da_uU_L3_13_1 da_uU_L3_13_1 vdd vdd PMIR W=60u L=1u
Mo4_uU_L3_13_1 gp_3_13_1 da_uU_L3_13_1 vdd vdd PMIR W=60u L=1u
Mt_uU_L3_13_2 ts_uU_L3_13_2 hv_L2_3 0 0 NMIR W=48.0u L=1u
Mo1_uU_L3_13_2 da_uU_L3_13_2 d1bar_L3 ts_uU_L3_13_2 0 NMIR W=20u L=1u
Mo2_uU_L3_13_2 gp_3_13_2 dpre_L3_13 ts_uU_L3_13_2 0 NMIR W=20u L=1u
Mo3_uU_L3_13_2 da_uU_L3_13_2 da_uU_L3_13_2 vdd vdd PMIR W=60u L=1u
Mo4_uU_L3_13_2 gp_3_13_2 da_uU_L3_13_2 vdd vdd PMIR W=60u L=1u
Mt_uU_L3_13_3 ts_uU_L3_13_3 hv_L2_8 0 0 NMIR W=48.0u L=1u
Mo1_uU_L3_13_3 da_uU_L3_13_3 d1bar_L3 ts_uU_L3_13_3 0 NMIR W=20u L=1u
Mo2_uU_L3_13_3 gp_3_13_3 dpre_L3_13 ts_uU_L3_13_3 0 NMIR W=20u L=1u
Mo3_uU_L3_13_3 da_uU_L3_13_3 da_uU_L3_13_3 vdd vdd PMIR W=60u L=1u
Mo4_uU_L3_13_3 gp_3_13_3 da_uU_L3_13_3 vdd vdd PMIR W=60u L=1u
Mt_uU_L3_13_4 ts_uU_L3_13_4 hv_L2_9 0 0 NMIR W=48.0u L=1u
Mo1_uU_L3_13_4 da_uU_L3_13_4 d1bar_L3 ts_uU_L3_13_4 0 NMIR W=20u L=1u
Mo2_uU_L3_13_4 gp_3_13_4 dpre_L3_13 ts_uU_L3_13_4 0 NMIR W=20u L=1u
Mo3_uU_L3_13_4 da_uU_L3_13_4 da_uU_L3_13_4 vdd vdd PMIR W=60u L=1u
Mo4_uU_L3_13_4 gp_3_13_4 da_uU_L3_13_4 vdd vdd PMIR W=60u L=1u
Mt_uU_L3_13_5 ts_uU_L3_13_5 hv_L2_16 0 0 NMIR W=48.0u L=1u
Mo1_uU_L3_13_5 da_uU_L3_13_5 d1bar_L3 ts_uU_L3_13_5 0 NMIR W=20u L=1u
Mo2_uU_L3_13_5 gp_3_13_5 dpre_L3_13 ts_uU_L3_13_5 0 NMIR W=20u L=1u
Mo3_uU_L3_13_5 da_uU_L3_13_5 da_uU_L3_13_5 vdd vdd PMIR W=60u L=1u
Mo4_uU_L3_13_5 gp_3_13_5 da_uU_L3_13_5 vdd vdd PMIR W=60u L=1u
Mt_uU_L3_13_6 ts_uU_L3_13_6 hv_L2_19 0 0 NMIR W=48.0u L=1u
Mo1_uU_L3_13_6 da_uU_L3_13_6 d1bar_L3 ts_uU_L3_13_6 0 NMIR W=20u L=1u
Mo2_uU_L3_13_6 gp_3_13_6 dpre_L3_13 ts_uU_L3_13_6 0 NMIR W=20u L=1u
Mo3_uU_L3_13_6 da_uU_L3_13_6 da_uU_L3_13_6 vdd vdd PMIR W=60u L=1u
Mo4_uU_L3_13_6 gp_3_13_6 da_uU_L3_13_6 vdd vdd PMIR W=60u L=1u
Mt_uU_L3_13_7 ts_uU_L3_13_7 hv_L2_20 0 0 NMIR W=48.0u L=1u
Mo1_uU_L3_13_7 da_uU_L3_13_7 d1bar_L3 ts_uU_L3_13_7 0 NMIR W=20u L=1u
Mo2_uU_L3_13_7 gp_3_13_7 dpre_L3_13 ts_uU_L3_13_7 0 NMIR W=20u L=1u
Mo3_uU_L3_13_7 da_uU_L3_13_7 da_uU_L3_13_7 vdd vdd PMIR W=60u L=1u
Mo4_uU_L3_13_7 gp_3_13_7 da_uU_L3_13_7 vdd vdd PMIR W=60u L=1u
Mt_uU_L3_13_8 ts_uU_L3_13_8 hv_L2_22 0 0 NMIR W=48.0u L=1u
Mo1_uU_L3_13_8 da_uU_L3_13_8 d1bar_L3 ts_uU_L3_13_8 0 NMIR W=20u L=1u
Mo2_uU_L3_13_8 gp_3_13_8 dpre_L3_13 ts_uU_L3_13_8 0 NMIR W=20u L=1u
Mo3_uU_L3_13_8 da_uU_L3_13_8 da_uU_L3_13_8 vdd vdd PMIR W=60u L=1u
Mo4_uU_L3_13_8 gp_3_13_8 da_uU_L3_13_8 vdd vdd PMIR W=60u L=1u
Mt_uU_L3_13_9 ts_uU_L3_13_9 hv_L2_24 0 0 NMIR W=48.0u L=1u
Mo1_uU_L3_13_9 da_uU_L3_13_9 d1bar_L3 ts_uU_L3_13_9 0 NMIR W=20u L=1u
Mo2_uU_L3_13_9 gp_3_13_9 dpre_L3_13 ts_uU_L3_13_9 0 NMIR W=20u L=1u
Mo3_uU_L3_13_9 da_uU_L3_13_9 da_uU_L3_13_9 vdd vdd PMIR W=60u L=1u
Mo4_uU_L3_13_9 gp_3_13_9 da_uU_L3_13_9 vdd vdd PMIR W=60u L=1u
Mt_uU_L3_13_10 ts_uU_L3_13_10 hv_L2_25 0 0 NMIR W=48.0u L=1u
Mo1_uU_L3_13_10 da_uU_L3_13_10 d1bar_L3 ts_uU_L3_13_10 0 NMIR W=20u L=1u
Mo2_uU_L3_13_10 gp_3_13_10 dpre_L3_13 ts_uU_L3_13_10 0 NMIR W=20u L=1u
Mo3_uU_L3_13_10 da_uU_L3_13_10 da_uU_L3_13_10 vdd vdd PMIR W=60u L=1u
Mo4_uU_L3_13_10 gp_3_13_10 da_uU_L3_13_10 vdd vdd PMIR W=60u L=1u
Mt_uU_L3_13_11 ts_uU_L3_13_11 hv_L2_32 0 0 NMIR W=48.0u L=1u
Mo1_uU_L3_13_11 da_uU_L3_13_11 d1bar_L3 ts_uU_L3_13_11 0 NMIR W=20u L=1u
Mo2_uU_L3_13_11 gp_3_13_11 dpre_L3_13 ts_uU_L3_13_11 0 NMIR W=20u L=1u
Mo3_uU_L3_13_11 da_uU_L3_13_11 da_uU_L3_13_11 vdd vdd PMIR W=60u L=1u
Mo4_uU_L3_13_11 gp_3_13_11 da_uU_L3_13_11 vdd vdd PMIR W=60u L=1u
Mt_uU_L3_13_12 ts_uU_L3_13_12 hv_L2_38 0 0 NMIR W=48.0u L=1u
Mo1_uU_L3_13_12 da_uU_L3_13_12 d1bar_L3 ts_uU_L3_13_12 0 NMIR W=20u L=1u
Mo2_uU_L3_13_12 gp_3_13_12 dpre_L3_13 ts_uU_L3_13_12 0 NMIR W=20u L=1u
Mo3_uU_L3_13_12 da_uU_L3_13_12 da_uU_L3_13_12 vdd vdd PMIR W=60u L=1u
Mo4_uU_L3_13_12 gp_3_13_12 da_uU_L3_13_12 vdd vdd PMIR W=60u L=1u
Mt_uU_L3_13_13 ts_uU_L3_13_13 hv_L2_39 0 0 NMIR W=48.0u L=1u
Mo1_uU_L3_13_13 da_uU_L3_13_13 d1bar_L3 ts_uU_L3_13_13 0 NMIR W=20u L=1u
Mo2_uU_L3_13_13 gp_3_13_13 dpre_L3_13 ts_uU_L3_13_13 0 NMIR W=20u L=1u
Mo3_uU_L3_13_13 da_uU_L3_13_13 da_uU_L3_13_13 vdd vdd PMIR W=60u L=1u
Mo4_uU_L3_13_13 gp_3_13_13 da_uU_L3_13_13 vdd vdd PMIR W=60u L=1u
Mt_uU_L3_13_14 ts_uU_L3_13_14 hv_L2_41 0 0 NMIR W=48.0u L=1u
Mo1_uU_L3_13_14 da_uU_L3_13_14 d1bar_L3 ts_uU_L3_13_14 0 NMIR W=20u L=1u
Mo2_uU_L3_13_14 gp_3_13_14 dpre_L3_13 ts_uU_L3_13_14 0 NMIR W=20u L=1u
Mo3_uU_L3_13_14 da_uU_L3_13_14 da_uU_L3_13_14 vdd vdd PMIR W=60u L=1u
Mo4_uU_L3_13_14 gp_3_13_14 da_uU_L3_13_14 vdd vdd PMIR W=60u L=1u
Mt_uU_L3_13_15 ts_uU_L3_13_15 hv_L2_43 0 0 NMIR W=48.0u L=1u
Mo1_uU_L3_13_15 da_uU_L3_13_15 d1bar_L3 ts_uU_L3_13_15 0 NMIR W=20u L=1u
Mo2_uU_L3_13_15 gp_3_13_15 dpre_L3_13 ts_uU_L3_13_15 0 NMIR W=20u L=1u
Mo3_uU_L3_13_15 da_uU_L3_13_15 da_uU_L3_13_15 vdd vdd PMIR W=60u L=1u
Mo4_uU_L3_13_15 gp_3_13_15 da_uU_L3_13_15 vdd vdd PMIR W=60u L=1u
Mt_uU_L3_14_0 ts_uU_L3_14_0 hv_L2_7 0 0 NMIR W=48.0u L=1u
Mo1_uU_L3_14_0 da_uU_L3_14_0 d1bar_L3 ts_uU_L3_14_0 0 NMIR W=20u L=1u
Mo2_uU_L3_14_0 gp_3_14_0 dpre_L3_14 ts_uU_L3_14_0 0 NMIR W=20u L=1u
Mo3_uU_L3_14_0 da_uU_L3_14_0 da_uU_L3_14_0 vdd vdd PMIR W=60u L=1u
Mo4_uU_L3_14_0 gp_3_14_0 da_uU_L3_14_0 vdd vdd PMIR W=60u L=1u
Mt_uU_L3_14_1 ts_uU_L3_14_1 hv_L2_9 0 0 NMIR W=48.0u L=1u
Mo1_uU_L3_14_1 da_uU_L3_14_1 d1bar_L3 ts_uU_L3_14_1 0 NMIR W=20u L=1u
Mo2_uU_L3_14_1 gp_3_14_1 dpre_L3_14 ts_uU_L3_14_1 0 NMIR W=20u L=1u
Mo3_uU_L3_14_1 da_uU_L3_14_1 da_uU_L3_14_1 vdd vdd PMIR W=60u L=1u
Mo4_uU_L3_14_1 gp_3_14_1 da_uU_L3_14_1 vdd vdd PMIR W=60u L=1u
Mt_uU_L3_14_2 ts_uU_L3_14_2 hv_L2_12 0 0 NMIR W=48.0u L=1u
Mo1_uU_L3_14_2 da_uU_L3_14_2 d1bar_L3 ts_uU_L3_14_2 0 NMIR W=20u L=1u
Mo2_uU_L3_14_2 gp_3_14_2 dpre_L3_14 ts_uU_L3_14_2 0 NMIR W=20u L=1u
Mo3_uU_L3_14_2 da_uU_L3_14_2 da_uU_L3_14_2 vdd vdd PMIR W=60u L=1u
Mo4_uU_L3_14_2 gp_3_14_2 da_uU_L3_14_2 vdd vdd PMIR W=60u L=1u
Mt_uU_L3_14_3 ts_uU_L3_14_3 hv_L2_14 0 0 NMIR W=48.0u L=1u
Mo1_uU_L3_14_3 da_uU_L3_14_3 d1bar_L3 ts_uU_L3_14_3 0 NMIR W=20u L=1u
Mo2_uU_L3_14_3 gp_3_14_3 dpre_L3_14 ts_uU_L3_14_3 0 NMIR W=20u L=1u
Mo3_uU_L3_14_3 da_uU_L3_14_3 da_uU_L3_14_3 vdd vdd PMIR W=60u L=1u
Mo4_uU_L3_14_3 gp_3_14_3 da_uU_L3_14_3 vdd vdd PMIR W=60u L=1u
Mt_uU_L3_14_4 ts_uU_L3_14_4 hv_L2_17 0 0 NMIR W=48.0u L=1u
Mo1_uU_L3_14_4 da_uU_L3_14_4 d1bar_L3 ts_uU_L3_14_4 0 NMIR W=20u L=1u
Mo2_uU_L3_14_4 gp_3_14_4 dpre_L3_14 ts_uU_L3_14_4 0 NMIR W=20u L=1u
Mo3_uU_L3_14_4 da_uU_L3_14_4 da_uU_L3_14_4 vdd vdd PMIR W=60u L=1u
Mo4_uU_L3_14_4 gp_3_14_4 da_uU_L3_14_4 vdd vdd PMIR W=60u L=1u
Mt_uU_L3_14_5 ts_uU_L3_14_5 hv_L2_19 0 0 NMIR W=48.0u L=1u
Mo1_uU_L3_14_5 da_uU_L3_14_5 d1bar_L3 ts_uU_L3_14_5 0 NMIR W=20u L=1u
Mo2_uU_L3_14_5 gp_3_14_5 dpre_L3_14 ts_uU_L3_14_5 0 NMIR W=20u L=1u
Mo3_uU_L3_14_5 da_uU_L3_14_5 da_uU_L3_14_5 vdd vdd PMIR W=60u L=1u
Mo4_uU_L3_14_5 gp_3_14_5 da_uU_L3_14_5 vdd vdd PMIR W=60u L=1u
Mt_uU_L3_14_6 ts_uU_L3_14_6 hv_L2_23 0 0 NMIR W=48.0u L=1u
Mo1_uU_L3_14_6 da_uU_L3_14_6 d1bar_L3 ts_uU_L3_14_6 0 NMIR W=20u L=1u
Mo2_uU_L3_14_6 gp_3_14_6 dpre_L3_14 ts_uU_L3_14_6 0 NMIR W=20u L=1u
Mo3_uU_L3_14_6 da_uU_L3_14_6 da_uU_L3_14_6 vdd vdd PMIR W=60u L=1u
Mo4_uU_L3_14_6 gp_3_14_6 da_uU_L3_14_6 vdd vdd PMIR W=60u L=1u
Mt_uU_L3_14_7 ts_uU_L3_14_7 hv_L2_24 0 0 NMIR W=48.0u L=1u
Mo1_uU_L3_14_7 da_uU_L3_14_7 d1bar_L3 ts_uU_L3_14_7 0 NMIR W=20u L=1u
Mo2_uU_L3_14_7 gp_3_14_7 dpre_L3_14 ts_uU_L3_14_7 0 NMIR W=20u L=1u
Mo3_uU_L3_14_7 da_uU_L3_14_7 da_uU_L3_14_7 vdd vdd PMIR W=60u L=1u
Mo4_uU_L3_14_7 gp_3_14_7 da_uU_L3_14_7 vdd vdd PMIR W=60u L=1u
Mt_uU_L3_14_8 ts_uU_L3_14_8 hv_L2_25 0 0 NMIR W=48.0u L=1u
Mo1_uU_L3_14_8 da_uU_L3_14_8 d1bar_L3 ts_uU_L3_14_8 0 NMIR W=20u L=1u
Mo2_uU_L3_14_8 gp_3_14_8 dpre_L3_14 ts_uU_L3_14_8 0 NMIR W=20u L=1u
Mo3_uU_L3_14_8 da_uU_L3_14_8 da_uU_L3_14_8 vdd vdd PMIR W=60u L=1u
Mo4_uU_L3_14_8 gp_3_14_8 da_uU_L3_14_8 vdd vdd PMIR W=60u L=1u
Mt_uU_L3_14_9 ts_uU_L3_14_9 hv_L2_26 0 0 NMIR W=48.0u L=1u
Mo1_uU_L3_14_9 da_uU_L3_14_9 d1bar_L3 ts_uU_L3_14_9 0 NMIR W=20u L=1u
Mo2_uU_L3_14_9 gp_3_14_9 dpre_L3_14 ts_uU_L3_14_9 0 NMIR W=20u L=1u
Mo3_uU_L3_14_9 da_uU_L3_14_9 da_uU_L3_14_9 vdd vdd PMIR W=60u L=1u
Mo4_uU_L3_14_9 gp_3_14_9 da_uU_L3_14_9 vdd vdd PMIR W=60u L=1u
Mt_uU_L3_14_10 ts_uU_L3_14_10 hv_L2_31 0 0 NMIR W=48.0u L=1u
Mo1_uU_L3_14_10 da_uU_L3_14_10 d1bar_L3 ts_uU_L3_14_10 0 NMIR W=20u L=1u
Mo2_uU_L3_14_10 gp_3_14_10 dpre_L3_14 ts_uU_L3_14_10 0 NMIR W=20u L=1u
Mo3_uU_L3_14_10 da_uU_L3_14_10 da_uU_L3_14_10 vdd vdd PMIR W=60u L=1u
Mo4_uU_L3_14_10 gp_3_14_10 da_uU_L3_14_10 vdd vdd PMIR W=60u L=1u
Mt_uU_L3_14_11 ts_uU_L3_14_11 hv_L2_33 0 0 NMIR W=48.0u L=1u
Mo1_uU_L3_14_11 da_uU_L3_14_11 d1bar_L3 ts_uU_L3_14_11 0 NMIR W=20u L=1u
Mo2_uU_L3_14_11 gp_3_14_11 dpre_L3_14 ts_uU_L3_14_11 0 NMIR W=20u L=1u
Mo3_uU_L3_14_11 da_uU_L3_14_11 da_uU_L3_14_11 vdd vdd PMIR W=60u L=1u
Mo4_uU_L3_14_11 gp_3_14_11 da_uU_L3_14_11 vdd vdd PMIR W=60u L=1u
Mt_uU_L3_14_12 ts_uU_L3_14_12 hv_L2_34 0 0 NMIR W=48.0u L=1u
Mo1_uU_L3_14_12 da_uU_L3_14_12 d1bar_L3 ts_uU_L3_14_12 0 NMIR W=20u L=1u
Mo2_uU_L3_14_12 gp_3_14_12 dpre_L3_14 ts_uU_L3_14_12 0 NMIR W=20u L=1u
Mo3_uU_L3_14_12 da_uU_L3_14_12 da_uU_L3_14_12 vdd vdd PMIR W=60u L=1u
Mo4_uU_L3_14_12 gp_3_14_12 da_uU_L3_14_12 vdd vdd PMIR W=60u L=1u
Mt_uU_L3_14_13 ts_uU_L3_14_13 hv_L2_37 0 0 NMIR W=48.0u L=1u
Mo1_uU_L3_14_13 da_uU_L3_14_13 d1bar_L3 ts_uU_L3_14_13 0 NMIR W=20u L=1u
Mo2_uU_L3_14_13 gp_3_14_13 dpre_L3_14 ts_uU_L3_14_13 0 NMIR W=20u L=1u
Mo3_uU_L3_14_13 da_uU_L3_14_13 da_uU_L3_14_13 vdd vdd PMIR W=60u L=1u
Mo4_uU_L3_14_13 gp_3_14_13 da_uU_L3_14_13 vdd vdd PMIR W=60u L=1u
Mt_uU_L3_14_14 ts_uU_L3_14_14 hv_L2_40 0 0 NMIR W=48.0u L=1u
Mo1_uU_L3_14_14 da_uU_L3_14_14 d1bar_L3 ts_uU_L3_14_14 0 NMIR W=20u L=1u
Mo2_uU_L3_14_14 gp_3_14_14 dpre_L3_14 ts_uU_L3_14_14 0 NMIR W=20u L=1u
Mo3_uU_L3_14_14 da_uU_L3_14_14 da_uU_L3_14_14 vdd vdd PMIR W=60u L=1u
Mo4_uU_L3_14_14 gp_3_14_14 da_uU_L3_14_14 vdd vdd PMIR W=60u L=1u
Mt_uU_L3_14_15 ts_uU_L3_14_15 hv_L2_41 0 0 NMIR W=48.0u L=1u
Mo1_uU_L3_14_15 da_uU_L3_14_15 d1bar_L3 ts_uU_L3_14_15 0 NMIR W=20u L=1u
Mo2_uU_L3_14_15 gp_3_14_15 dpre_L3_14 ts_uU_L3_14_15 0 NMIR W=20u L=1u
Mo3_uU_L3_14_15 da_uU_L3_14_15 da_uU_L3_14_15 vdd vdd PMIR W=60u L=1u
Mo4_uU_L3_14_15 gp_3_14_15 da_uU_L3_14_15 vdd vdd PMIR W=60u L=1u
Mt_uU_L3_15_0 ts_uU_L3_15_0 hv_L2_0 0 0 NMIR W=48.0u L=1u
Mo1_uU_L3_15_0 da_uU_L3_15_0 d1bar_L3 ts_uU_L3_15_0 0 NMIR W=20u L=1u
Mo2_uU_L3_15_0 gp_3_15_0 dpre_L3_15 ts_uU_L3_15_0 0 NMIR W=20u L=1u
Mo3_uU_L3_15_0 da_uU_L3_15_0 da_uU_L3_15_0 vdd vdd PMIR W=60u L=1u
Mo4_uU_L3_15_0 gp_3_15_0 da_uU_L3_15_0 vdd vdd PMIR W=60u L=1u
Mt_uU_L3_15_1 ts_uU_L3_15_1 hv_L2_1 0 0 NMIR W=48.0u L=1u
Mo1_uU_L3_15_1 da_uU_L3_15_1 d1bar_L3 ts_uU_L3_15_1 0 NMIR W=20u L=1u
Mo2_uU_L3_15_1 gp_3_15_1 dpre_L3_15 ts_uU_L3_15_1 0 NMIR W=20u L=1u
Mo3_uU_L3_15_1 da_uU_L3_15_1 da_uU_L3_15_1 vdd vdd PMIR W=60u L=1u
Mo4_uU_L3_15_1 gp_3_15_1 da_uU_L3_15_1 vdd vdd PMIR W=60u L=1u
Mt_uU_L3_15_2 ts_uU_L3_15_2 hv_L2_2 0 0 NMIR W=48.0u L=1u
Mo1_uU_L3_15_2 da_uU_L3_15_2 d1bar_L3 ts_uU_L3_15_2 0 NMIR W=20u L=1u
Mo2_uU_L3_15_2 gp_3_15_2 dpre_L3_15 ts_uU_L3_15_2 0 NMIR W=20u L=1u
Mo3_uU_L3_15_2 da_uU_L3_15_2 da_uU_L3_15_2 vdd vdd PMIR W=60u L=1u
Mo4_uU_L3_15_2 gp_3_15_2 da_uU_L3_15_2 vdd vdd PMIR W=60u L=1u
Mt_uU_L3_15_3 ts_uU_L3_15_3 hv_L2_4 0 0 NMIR W=48.0u L=1u
Mo1_uU_L3_15_3 da_uU_L3_15_3 d1bar_L3 ts_uU_L3_15_3 0 NMIR W=20u L=1u
Mo2_uU_L3_15_3 gp_3_15_3 dpre_L3_15 ts_uU_L3_15_3 0 NMIR W=20u L=1u
Mo3_uU_L3_15_3 da_uU_L3_15_3 da_uU_L3_15_3 vdd vdd PMIR W=60u L=1u
Mo4_uU_L3_15_3 gp_3_15_3 da_uU_L3_15_3 vdd vdd PMIR W=60u L=1u
Mt_uU_L3_15_4 ts_uU_L3_15_4 hv_L2_8 0 0 NMIR W=48.0u L=1u
Mo1_uU_L3_15_4 da_uU_L3_15_4 d1bar_L3 ts_uU_L3_15_4 0 NMIR W=20u L=1u
Mo2_uU_L3_15_4 gp_3_15_4 dpre_L3_15 ts_uU_L3_15_4 0 NMIR W=20u L=1u
Mo3_uU_L3_15_4 da_uU_L3_15_4 da_uU_L3_15_4 vdd vdd PMIR W=60u L=1u
Mo4_uU_L3_15_4 gp_3_15_4 da_uU_L3_15_4 vdd vdd PMIR W=60u L=1u
Mt_uU_L3_15_5 ts_uU_L3_15_5 hv_L2_12 0 0 NMIR W=48.0u L=1u
Mo1_uU_L3_15_5 da_uU_L3_15_5 d1bar_L3 ts_uU_L3_15_5 0 NMIR W=20u L=1u
Mo2_uU_L3_15_5 gp_3_15_5 dpre_L3_15 ts_uU_L3_15_5 0 NMIR W=20u L=1u
Mo3_uU_L3_15_5 da_uU_L3_15_5 da_uU_L3_15_5 vdd vdd PMIR W=60u L=1u
Mo4_uU_L3_15_5 gp_3_15_5 da_uU_L3_15_5 vdd vdd PMIR W=60u L=1u
Mt_uU_L3_15_6 ts_uU_L3_15_6 hv_L2_13 0 0 NMIR W=48.0u L=1u
Mo1_uU_L3_15_6 da_uU_L3_15_6 d1bar_L3 ts_uU_L3_15_6 0 NMIR W=20u L=1u
Mo2_uU_L3_15_6 gp_3_15_6 dpre_L3_15 ts_uU_L3_15_6 0 NMIR W=20u L=1u
Mo3_uU_L3_15_6 da_uU_L3_15_6 da_uU_L3_15_6 vdd vdd PMIR W=60u L=1u
Mo4_uU_L3_15_6 gp_3_15_6 da_uU_L3_15_6 vdd vdd PMIR W=60u L=1u
Mt_uU_L3_15_7 ts_uU_L3_15_7 hv_L2_15 0 0 NMIR W=48.0u L=1u
Mo1_uU_L3_15_7 da_uU_L3_15_7 d1bar_L3 ts_uU_L3_15_7 0 NMIR W=20u L=1u
Mo2_uU_L3_15_7 gp_3_15_7 dpre_L3_15 ts_uU_L3_15_7 0 NMIR W=20u L=1u
Mo3_uU_L3_15_7 da_uU_L3_15_7 da_uU_L3_15_7 vdd vdd PMIR W=60u L=1u
Mo4_uU_L3_15_7 gp_3_15_7 da_uU_L3_15_7 vdd vdd PMIR W=60u L=1u
Mt_uU_L3_15_8 ts_uU_L3_15_8 hv_L2_16 0 0 NMIR W=48.0u L=1u
Mo1_uU_L3_15_8 da_uU_L3_15_8 d1bar_L3 ts_uU_L3_15_8 0 NMIR W=20u L=1u
Mo2_uU_L3_15_8 gp_3_15_8 dpre_L3_15 ts_uU_L3_15_8 0 NMIR W=20u L=1u
Mo3_uU_L3_15_8 da_uU_L3_15_8 da_uU_L3_15_8 vdd vdd PMIR W=60u L=1u
Mo4_uU_L3_15_8 gp_3_15_8 da_uU_L3_15_8 vdd vdd PMIR W=60u L=1u
Mt_uU_L3_15_9 ts_uU_L3_15_9 hv_L2_28 0 0 NMIR W=48.0u L=1u
Mo1_uU_L3_15_9 da_uU_L3_15_9 d1bar_L3 ts_uU_L3_15_9 0 NMIR W=20u L=1u
Mo2_uU_L3_15_9 gp_3_15_9 dpre_L3_15 ts_uU_L3_15_9 0 NMIR W=20u L=1u
Mo3_uU_L3_15_9 da_uU_L3_15_9 da_uU_L3_15_9 vdd vdd PMIR W=60u L=1u
Mo4_uU_L3_15_9 gp_3_15_9 da_uU_L3_15_9 vdd vdd PMIR W=60u L=1u
Mt_uU_L3_15_10 ts_uU_L3_15_10 hv_L2_31 0 0 NMIR W=48.0u L=1u
Mo1_uU_L3_15_10 da_uU_L3_15_10 d1bar_L3 ts_uU_L3_15_10 0 NMIR W=20u L=1u
Mo2_uU_L3_15_10 gp_3_15_10 dpre_L3_15 ts_uU_L3_15_10 0 NMIR W=20u L=1u
Mo3_uU_L3_15_10 da_uU_L3_15_10 da_uU_L3_15_10 vdd vdd PMIR W=60u L=1u
Mo4_uU_L3_15_10 gp_3_15_10 da_uU_L3_15_10 vdd vdd PMIR W=60u L=1u
Mt_uU_L3_15_11 ts_uU_L3_15_11 hv_L2_35 0 0 NMIR W=48.0u L=1u
Mo1_uU_L3_15_11 da_uU_L3_15_11 d1bar_L3 ts_uU_L3_15_11 0 NMIR W=20u L=1u
Mo2_uU_L3_15_11 gp_3_15_11 dpre_L3_15 ts_uU_L3_15_11 0 NMIR W=20u L=1u
Mo3_uU_L3_15_11 da_uU_L3_15_11 da_uU_L3_15_11 vdd vdd PMIR W=60u L=1u
Mo4_uU_L3_15_11 gp_3_15_11 da_uU_L3_15_11 vdd vdd PMIR W=60u L=1u
Mt_uU_L3_15_12 ts_uU_L3_15_12 hv_L2_36 0 0 NMIR W=48.0u L=1u
Mo1_uU_L3_15_12 da_uU_L3_15_12 d1bar_L3 ts_uU_L3_15_12 0 NMIR W=20u L=1u
Mo2_uU_L3_15_12 gp_3_15_12 dpre_L3_15 ts_uU_L3_15_12 0 NMIR W=20u L=1u
Mo3_uU_L3_15_12 da_uU_L3_15_12 da_uU_L3_15_12 vdd vdd PMIR W=60u L=1u
Mo4_uU_L3_15_12 gp_3_15_12 da_uU_L3_15_12 vdd vdd PMIR W=60u L=1u
Mt_uU_L3_15_13 ts_uU_L3_15_13 hv_L2_39 0 0 NMIR W=48.0u L=1u
Mo1_uU_L3_15_13 da_uU_L3_15_13 d1bar_L3 ts_uU_L3_15_13 0 NMIR W=20u L=1u
Mo2_uU_L3_15_13 gp_3_15_13 dpre_L3_15 ts_uU_L3_15_13 0 NMIR W=20u L=1u
Mo3_uU_L3_15_13 da_uU_L3_15_13 da_uU_L3_15_13 vdd vdd PMIR W=60u L=1u
Mo4_uU_L3_15_13 gp_3_15_13 da_uU_L3_15_13 vdd vdd PMIR W=60u L=1u
Mt_uU_L3_15_14 ts_uU_L3_15_14 hv_L2_42 0 0 NMIR W=48.0u L=1u
Mo1_uU_L3_15_14 da_uU_L3_15_14 d1bar_L3 ts_uU_L3_15_14 0 NMIR W=20u L=1u
Mo2_uU_L3_15_14 gp_3_15_14 dpre_L3_15 ts_uU_L3_15_14 0 NMIR W=20u L=1u
Mo3_uU_L3_15_14 da_uU_L3_15_14 da_uU_L3_15_14 vdd vdd PMIR W=60u L=1u
Mo4_uU_L3_15_14 gp_3_15_14 da_uU_L3_15_14 vdd vdd PMIR W=60u L=1u
Mt_uU_L3_15_15 ts_uU_L3_15_15 hv_L2_46 0 0 NMIR W=48.0u L=1u
Mo1_uU_L3_15_15 da_uU_L3_15_15 d1bar_L3 ts_uU_L3_15_15 0 NMIR W=20u L=1u
Mo2_uU_L3_15_15 gp_3_15_15 dpre_L3_15 ts_uU_L3_15_15 0 NMIR W=20u L=1u
Mo3_uU_L3_15_15 da_uU_L3_15_15 da_uU_L3_15_15 vdd vdd PMIR W=60u L=1u
Mo4_uU_L3_15_15 gp_3_15_15 da_uU_L3_15_15 vdd vdd PMIR W=60u L=1u
Mt_uU_L3_16_0 ts_uU_L3_16_0 hv_L2_3 0 0 NMIR W=48.0u L=1u
Mo1_uU_L3_16_0 da_uU_L3_16_0 d1bar_L3 ts_uU_L3_16_0 0 NMIR W=20u L=1u
Mo2_uU_L3_16_0 gp_3_16_0 dpre_L3_16 ts_uU_L3_16_0 0 NMIR W=20u L=1u
Mo3_uU_L3_16_0 da_uU_L3_16_0 da_uU_L3_16_0 vdd vdd PMIR W=60u L=1u
Mo4_uU_L3_16_0 gp_3_16_0 da_uU_L3_16_0 vdd vdd PMIR W=60u L=1u
Mt_uU_L3_16_1 ts_uU_L3_16_1 hv_L2_8 0 0 NMIR W=48.0u L=1u
Mo1_uU_L3_16_1 da_uU_L3_16_1 d1bar_L3 ts_uU_L3_16_1 0 NMIR W=20u L=1u
Mo2_uU_L3_16_1 gp_3_16_1 dpre_L3_16 ts_uU_L3_16_1 0 NMIR W=20u L=1u
Mo3_uU_L3_16_1 da_uU_L3_16_1 da_uU_L3_16_1 vdd vdd PMIR W=60u L=1u
Mo4_uU_L3_16_1 gp_3_16_1 da_uU_L3_16_1 vdd vdd PMIR W=60u L=1u
Mt_uU_L3_16_2 ts_uU_L3_16_2 hv_L2_13 0 0 NMIR W=48.0u L=1u
Mo1_uU_L3_16_2 da_uU_L3_16_2 d1bar_L3 ts_uU_L3_16_2 0 NMIR W=20u L=1u
Mo2_uU_L3_16_2 gp_3_16_2 dpre_L3_16 ts_uU_L3_16_2 0 NMIR W=20u L=1u
Mo3_uU_L3_16_2 da_uU_L3_16_2 da_uU_L3_16_2 vdd vdd PMIR W=60u L=1u
Mo4_uU_L3_16_2 gp_3_16_2 da_uU_L3_16_2 vdd vdd PMIR W=60u L=1u
Mt_uU_L3_16_3 ts_uU_L3_16_3 hv_L2_18 0 0 NMIR W=48.0u L=1u
Mo1_uU_L3_16_3 da_uU_L3_16_3 d1bar_L3 ts_uU_L3_16_3 0 NMIR W=20u L=1u
Mo2_uU_L3_16_3 gp_3_16_3 dpre_L3_16 ts_uU_L3_16_3 0 NMIR W=20u L=1u
Mo3_uU_L3_16_3 da_uU_L3_16_3 da_uU_L3_16_3 vdd vdd PMIR W=60u L=1u
Mo4_uU_L3_16_3 gp_3_16_3 da_uU_L3_16_3 vdd vdd PMIR W=60u L=1u
Mt_uU_L3_16_4 ts_uU_L3_16_4 hv_L2_23 0 0 NMIR W=48.0u L=1u
Mo1_uU_L3_16_4 da_uU_L3_16_4 d1bar_L3 ts_uU_L3_16_4 0 NMIR W=20u L=1u
Mo2_uU_L3_16_4 gp_3_16_4 dpre_L3_16 ts_uU_L3_16_4 0 NMIR W=20u L=1u
Mo3_uU_L3_16_4 da_uU_L3_16_4 da_uU_L3_16_4 vdd vdd PMIR W=60u L=1u
Mo4_uU_L3_16_4 gp_3_16_4 da_uU_L3_16_4 vdd vdd PMIR W=60u L=1u
Mt_uU_L3_16_5 ts_uU_L3_16_5 hv_L2_26 0 0 NMIR W=48.0u L=1u
Mo1_uU_L3_16_5 da_uU_L3_16_5 d1bar_L3 ts_uU_L3_16_5 0 NMIR W=20u L=1u
Mo2_uU_L3_16_5 gp_3_16_5 dpre_L3_16 ts_uU_L3_16_5 0 NMIR W=20u L=1u
Mo3_uU_L3_16_5 da_uU_L3_16_5 da_uU_L3_16_5 vdd vdd PMIR W=60u L=1u
Mo4_uU_L3_16_5 gp_3_16_5 da_uU_L3_16_5 vdd vdd PMIR W=60u L=1u
Mt_uU_L3_16_6 ts_uU_L3_16_6 hv_L2_28 0 0 NMIR W=48.0u L=1u
Mo1_uU_L3_16_6 da_uU_L3_16_6 d1bar_L3 ts_uU_L3_16_6 0 NMIR W=20u L=1u
Mo2_uU_L3_16_6 gp_3_16_6 dpre_L3_16 ts_uU_L3_16_6 0 NMIR W=20u L=1u
Mo3_uU_L3_16_6 da_uU_L3_16_6 da_uU_L3_16_6 vdd vdd PMIR W=60u L=1u
Mo4_uU_L3_16_6 gp_3_16_6 da_uU_L3_16_6 vdd vdd PMIR W=60u L=1u
Mt_uU_L3_16_7 ts_uU_L3_16_7 hv_L2_29 0 0 NMIR W=48.0u L=1u
Mo1_uU_L3_16_7 da_uU_L3_16_7 d1bar_L3 ts_uU_L3_16_7 0 NMIR W=20u L=1u
Mo2_uU_L3_16_7 gp_3_16_7 dpre_L3_16 ts_uU_L3_16_7 0 NMIR W=20u L=1u
Mo3_uU_L3_16_7 da_uU_L3_16_7 da_uU_L3_16_7 vdd vdd PMIR W=60u L=1u
Mo4_uU_L3_16_7 gp_3_16_7 da_uU_L3_16_7 vdd vdd PMIR W=60u L=1u
Mt_uU_L3_16_8 ts_uU_L3_16_8 hv_L2_31 0 0 NMIR W=48.0u L=1u
Mo1_uU_L3_16_8 da_uU_L3_16_8 d1bar_L3 ts_uU_L3_16_8 0 NMIR W=20u L=1u
Mo2_uU_L3_16_8 gp_3_16_8 dpre_L3_16 ts_uU_L3_16_8 0 NMIR W=20u L=1u
Mo3_uU_L3_16_8 da_uU_L3_16_8 da_uU_L3_16_8 vdd vdd PMIR W=60u L=1u
Mo4_uU_L3_16_8 gp_3_16_8 da_uU_L3_16_8 vdd vdd PMIR W=60u L=1u
Mt_uU_L3_16_9 ts_uU_L3_16_9 hv_L2_35 0 0 NMIR W=48.0u L=1u
Mo1_uU_L3_16_9 da_uU_L3_16_9 d1bar_L3 ts_uU_L3_16_9 0 NMIR W=20u L=1u
Mo2_uU_L3_16_9 gp_3_16_9 dpre_L3_16 ts_uU_L3_16_9 0 NMIR W=20u L=1u
Mo3_uU_L3_16_9 da_uU_L3_16_9 da_uU_L3_16_9 vdd vdd PMIR W=60u L=1u
Mo4_uU_L3_16_9 gp_3_16_9 da_uU_L3_16_9 vdd vdd PMIR W=60u L=1u
Mt_uU_L3_16_10 ts_uU_L3_16_10 hv_L2_36 0 0 NMIR W=48.0u L=1u
Mo1_uU_L3_16_10 da_uU_L3_16_10 d1bar_L3 ts_uU_L3_16_10 0 NMIR W=20u L=1u
Mo2_uU_L3_16_10 gp_3_16_10 dpre_L3_16 ts_uU_L3_16_10 0 NMIR W=20u L=1u
Mo3_uU_L3_16_10 da_uU_L3_16_10 da_uU_L3_16_10 vdd vdd PMIR W=60u L=1u
Mo4_uU_L3_16_10 gp_3_16_10 da_uU_L3_16_10 vdd vdd PMIR W=60u L=1u
Mt_uU_L3_16_11 ts_uU_L3_16_11 hv_L2_39 0 0 NMIR W=48.0u L=1u
Mo1_uU_L3_16_11 da_uU_L3_16_11 d1bar_L3 ts_uU_L3_16_11 0 NMIR W=20u L=1u
Mo2_uU_L3_16_11 gp_3_16_11 dpre_L3_16 ts_uU_L3_16_11 0 NMIR W=20u L=1u
Mo3_uU_L3_16_11 da_uU_L3_16_11 da_uU_L3_16_11 vdd vdd PMIR W=60u L=1u
Mo4_uU_L3_16_11 gp_3_16_11 da_uU_L3_16_11 vdd vdd PMIR W=60u L=1u
Mt_uU_L3_16_12 ts_uU_L3_16_12 hv_L2_40 0 0 NMIR W=48.0u L=1u
Mo1_uU_L3_16_12 da_uU_L3_16_12 d1bar_L3 ts_uU_L3_16_12 0 NMIR W=20u L=1u
Mo2_uU_L3_16_12 gp_3_16_12 dpre_L3_16 ts_uU_L3_16_12 0 NMIR W=20u L=1u
Mo3_uU_L3_16_12 da_uU_L3_16_12 da_uU_L3_16_12 vdd vdd PMIR W=60u L=1u
Mo4_uU_L3_16_12 gp_3_16_12 da_uU_L3_16_12 vdd vdd PMIR W=60u L=1u
Mt_uU_L3_16_13 ts_uU_L3_16_13 hv_L2_42 0 0 NMIR W=48.0u L=1u
Mo1_uU_L3_16_13 da_uU_L3_16_13 d1bar_L3 ts_uU_L3_16_13 0 NMIR W=20u L=1u
Mo2_uU_L3_16_13 gp_3_16_13 dpre_L3_16 ts_uU_L3_16_13 0 NMIR W=20u L=1u
Mo3_uU_L3_16_13 da_uU_L3_16_13 da_uU_L3_16_13 vdd vdd PMIR W=60u L=1u
Mo4_uU_L3_16_13 gp_3_16_13 da_uU_L3_16_13 vdd vdd PMIR W=60u L=1u
Mt_uU_L3_16_14 ts_uU_L3_16_14 hv_L2_45 0 0 NMIR W=48.0u L=1u
Mo1_uU_L3_16_14 da_uU_L3_16_14 d1bar_L3 ts_uU_L3_16_14 0 NMIR W=20u L=1u
Mo2_uU_L3_16_14 gp_3_16_14 dpre_L3_16 ts_uU_L3_16_14 0 NMIR W=20u L=1u
Mo3_uU_L3_16_14 da_uU_L3_16_14 da_uU_L3_16_14 vdd vdd PMIR W=60u L=1u
Mo4_uU_L3_16_14 gp_3_16_14 da_uU_L3_16_14 vdd vdd PMIR W=60u L=1u
Mt_uU_L3_16_15 ts_uU_L3_16_15 hv_L2_46 0 0 NMIR W=48.0u L=1u
Mo1_uU_L3_16_15 da_uU_L3_16_15 d1bar_L3 ts_uU_L3_16_15 0 NMIR W=20u L=1u
Mo2_uU_L3_16_15 gp_3_16_15 dpre_L3_16 ts_uU_L3_16_15 0 NMIR W=20u L=1u
Mo3_uU_L3_16_15 da_uU_L3_16_15 da_uU_L3_16_15 vdd vdd PMIR W=60u L=1u
Mo4_uU_L3_16_15 gp_3_16_15 da_uU_L3_16_15 vdd vdd PMIR W=60u L=1u
Mt_uU_L3_17_0 ts_uU_L3_17_0 hv_L2_3 0 0 NMIR W=48.0u L=1u
Mo1_uU_L3_17_0 da_uU_L3_17_0 d1bar_L3 ts_uU_L3_17_0 0 NMIR W=20u L=1u
Mo2_uU_L3_17_0 gp_3_17_0 dpre_L3_17 ts_uU_L3_17_0 0 NMIR W=20u L=1u
Mo3_uU_L3_17_0 da_uU_L3_17_0 da_uU_L3_17_0 vdd vdd PMIR W=60u L=1u
Mo4_uU_L3_17_0 gp_3_17_0 da_uU_L3_17_0 vdd vdd PMIR W=60u L=1u
Mt_uU_L3_17_1 ts_uU_L3_17_1 hv_L2_4 0 0 NMIR W=48.0u L=1u
Mo1_uU_L3_17_1 da_uU_L3_17_1 d1bar_L3 ts_uU_L3_17_1 0 NMIR W=20u L=1u
Mo2_uU_L3_17_1 gp_3_17_1 dpre_L3_17 ts_uU_L3_17_1 0 NMIR W=20u L=1u
Mo3_uU_L3_17_1 da_uU_L3_17_1 da_uU_L3_17_1 vdd vdd PMIR W=60u L=1u
Mo4_uU_L3_17_1 gp_3_17_1 da_uU_L3_17_1 vdd vdd PMIR W=60u L=1u
Mt_uU_L3_17_2 ts_uU_L3_17_2 hv_L2_6 0 0 NMIR W=48.0u L=1u
Mo1_uU_L3_17_2 da_uU_L3_17_2 d1bar_L3 ts_uU_L3_17_2 0 NMIR W=20u L=1u
Mo2_uU_L3_17_2 gp_3_17_2 dpre_L3_17 ts_uU_L3_17_2 0 NMIR W=20u L=1u
Mo3_uU_L3_17_2 da_uU_L3_17_2 da_uU_L3_17_2 vdd vdd PMIR W=60u L=1u
Mo4_uU_L3_17_2 gp_3_17_2 da_uU_L3_17_2 vdd vdd PMIR W=60u L=1u
Mt_uU_L3_17_3 ts_uU_L3_17_3 hv_L2_7 0 0 NMIR W=48.0u L=1u
Mo1_uU_L3_17_3 da_uU_L3_17_3 d1bar_L3 ts_uU_L3_17_3 0 NMIR W=20u L=1u
Mo2_uU_L3_17_3 gp_3_17_3 dpre_L3_17 ts_uU_L3_17_3 0 NMIR W=20u L=1u
Mo3_uU_L3_17_3 da_uU_L3_17_3 da_uU_L3_17_3 vdd vdd PMIR W=60u L=1u
Mo4_uU_L3_17_3 gp_3_17_3 da_uU_L3_17_3 vdd vdd PMIR W=60u L=1u
Mt_uU_L3_17_4 ts_uU_L3_17_4 hv_L2_8 0 0 NMIR W=48.0u L=1u
Mo1_uU_L3_17_4 da_uU_L3_17_4 d1bar_L3 ts_uU_L3_17_4 0 NMIR W=20u L=1u
Mo2_uU_L3_17_4 gp_3_17_4 dpre_L3_17 ts_uU_L3_17_4 0 NMIR W=20u L=1u
Mo3_uU_L3_17_4 da_uU_L3_17_4 da_uU_L3_17_4 vdd vdd PMIR W=60u L=1u
Mo4_uU_L3_17_4 gp_3_17_4 da_uU_L3_17_4 vdd vdd PMIR W=60u L=1u
Mt_uU_L3_17_5 ts_uU_L3_17_5 hv_L2_15 0 0 NMIR W=48.0u L=1u
Mo1_uU_L3_17_5 da_uU_L3_17_5 d1bar_L3 ts_uU_L3_17_5 0 NMIR W=20u L=1u
Mo2_uU_L3_17_5 gp_3_17_5 dpre_L3_17 ts_uU_L3_17_5 0 NMIR W=20u L=1u
Mo3_uU_L3_17_5 da_uU_L3_17_5 da_uU_L3_17_5 vdd vdd PMIR W=60u L=1u
Mo4_uU_L3_17_5 gp_3_17_5 da_uU_L3_17_5 vdd vdd PMIR W=60u L=1u
Mt_uU_L3_17_6 ts_uU_L3_17_6 hv_L2_16 0 0 NMIR W=48.0u L=1u
Mo1_uU_L3_17_6 da_uU_L3_17_6 d1bar_L3 ts_uU_L3_17_6 0 NMIR W=20u L=1u
Mo2_uU_L3_17_6 gp_3_17_6 dpre_L3_17 ts_uU_L3_17_6 0 NMIR W=20u L=1u
Mo3_uU_L3_17_6 da_uU_L3_17_6 da_uU_L3_17_6 vdd vdd PMIR W=60u L=1u
Mo4_uU_L3_17_6 gp_3_17_6 da_uU_L3_17_6 vdd vdd PMIR W=60u L=1u
Mt_uU_L3_17_7 ts_uU_L3_17_7 hv_L2_21 0 0 NMIR W=48.0u L=1u
Mo1_uU_L3_17_7 da_uU_L3_17_7 d1bar_L3 ts_uU_L3_17_7 0 NMIR W=20u L=1u
Mo2_uU_L3_17_7 gp_3_17_7 dpre_L3_17 ts_uU_L3_17_7 0 NMIR W=20u L=1u
Mo3_uU_L3_17_7 da_uU_L3_17_7 da_uU_L3_17_7 vdd vdd PMIR W=60u L=1u
Mo4_uU_L3_17_7 gp_3_17_7 da_uU_L3_17_7 vdd vdd PMIR W=60u L=1u
Mt_uU_L3_17_8 ts_uU_L3_17_8 hv_L2_23 0 0 NMIR W=48.0u L=1u
Mo1_uU_L3_17_8 da_uU_L3_17_8 d1bar_L3 ts_uU_L3_17_8 0 NMIR W=20u L=1u
Mo2_uU_L3_17_8 gp_3_17_8 dpre_L3_17 ts_uU_L3_17_8 0 NMIR W=20u L=1u
Mo3_uU_L3_17_8 da_uU_L3_17_8 da_uU_L3_17_8 vdd vdd PMIR W=60u L=1u
Mo4_uU_L3_17_8 gp_3_17_8 da_uU_L3_17_8 vdd vdd PMIR W=60u L=1u
Mt_uU_L3_17_9 ts_uU_L3_17_9 hv_L2_30 0 0 NMIR W=48.0u L=1u
Mo1_uU_L3_17_9 da_uU_L3_17_9 d1bar_L3 ts_uU_L3_17_9 0 NMIR W=20u L=1u
Mo2_uU_L3_17_9 gp_3_17_9 dpre_L3_17 ts_uU_L3_17_9 0 NMIR W=20u L=1u
Mo3_uU_L3_17_9 da_uU_L3_17_9 da_uU_L3_17_9 vdd vdd PMIR W=60u L=1u
Mo4_uU_L3_17_9 gp_3_17_9 da_uU_L3_17_9 vdd vdd PMIR W=60u L=1u
Mt_uU_L3_17_10 ts_uU_L3_17_10 hv_L2_34 0 0 NMIR W=48.0u L=1u
Mo1_uU_L3_17_10 da_uU_L3_17_10 d1bar_L3 ts_uU_L3_17_10 0 NMIR W=20u L=1u
Mo2_uU_L3_17_10 gp_3_17_10 dpre_L3_17 ts_uU_L3_17_10 0 NMIR W=20u L=1u
Mo3_uU_L3_17_10 da_uU_L3_17_10 da_uU_L3_17_10 vdd vdd PMIR W=60u L=1u
Mo4_uU_L3_17_10 gp_3_17_10 da_uU_L3_17_10 vdd vdd PMIR W=60u L=1u
Mt_uU_L3_17_11 ts_uU_L3_17_11 hv_L2_35 0 0 NMIR W=48.0u L=1u
Mo1_uU_L3_17_11 da_uU_L3_17_11 d1bar_L3 ts_uU_L3_17_11 0 NMIR W=20u L=1u
Mo2_uU_L3_17_11 gp_3_17_11 dpre_L3_17 ts_uU_L3_17_11 0 NMIR W=20u L=1u
Mo3_uU_L3_17_11 da_uU_L3_17_11 da_uU_L3_17_11 vdd vdd PMIR W=60u L=1u
Mo4_uU_L3_17_11 gp_3_17_11 da_uU_L3_17_11 vdd vdd PMIR W=60u L=1u
Mt_uU_L3_17_12 ts_uU_L3_17_12 hv_L2_38 0 0 NMIR W=48.0u L=1u
Mo1_uU_L3_17_12 da_uU_L3_17_12 d1bar_L3 ts_uU_L3_17_12 0 NMIR W=20u L=1u
Mo2_uU_L3_17_12 gp_3_17_12 dpre_L3_17 ts_uU_L3_17_12 0 NMIR W=20u L=1u
Mo3_uU_L3_17_12 da_uU_L3_17_12 da_uU_L3_17_12 vdd vdd PMIR W=60u L=1u
Mo4_uU_L3_17_12 gp_3_17_12 da_uU_L3_17_12 vdd vdd PMIR W=60u L=1u
Mt_uU_L3_17_13 ts_uU_L3_17_13 hv_L2_39 0 0 NMIR W=48.0u L=1u
Mo1_uU_L3_17_13 da_uU_L3_17_13 d1bar_L3 ts_uU_L3_17_13 0 NMIR W=20u L=1u
Mo2_uU_L3_17_13 gp_3_17_13 dpre_L3_17 ts_uU_L3_17_13 0 NMIR W=20u L=1u
Mo3_uU_L3_17_13 da_uU_L3_17_13 da_uU_L3_17_13 vdd vdd PMIR W=60u L=1u
Mo4_uU_L3_17_13 gp_3_17_13 da_uU_L3_17_13 vdd vdd PMIR W=60u L=1u
Mt_uU_L3_17_14 ts_uU_L3_17_14 hv_L2_41 0 0 NMIR W=48.0u L=1u
Mo1_uU_L3_17_14 da_uU_L3_17_14 d1bar_L3 ts_uU_L3_17_14 0 NMIR W=20u L=1u
Mo2_uU_L3_17_14 gp_3_17_14 dpre_L3_17 ts_uU_L3_17_14 0 NMIR W=20u L=1u
Mo3_uU_L3_17_14 da_uU_L3_17_14 da_uU_L3_17_14 vdd vdd PMIR W=60u L=1u
Mo4_uU_L3_17_14 gp_3_17_14 da_uU_L3_17_14 vdd vdd PMIR W=60u L=1u
Mt_uU_L3_17_15 ts_uU_L3_17_15 hv_L2_45 0 0 NMIR W=48.0u L=1u
Mo1_uU_L3_17_15 da_uU_L3_17_15 d1bar_L3 ts_uU_L3_17_15 0 NMIR W=20u L=1u
Mo2_uU_L3_17_15 gp_3_17_15 dpre_L3_17 ts_uU_L3_17_15 0 NMIR W=20u L=1u
Mo3_uU_L3_17_15 da_uU_L3_17_15 da_uU_L3_17_15 vdd vdd PMIR W=60u L=1u
Mo4_uU_L3_17_15 gp_3_17_15 da_uU_L3_17_15 vdd vdd PMIR W=60u L=1u
Mt_uU_L3_18_0 ts_uU_L3_18_0 hv_L2_2 0 0 NMIR W=48.0u L=1u
Mo1_uU_L3_18_0 da_uU_L3_18_0 d1bar_L3 ts_uU_L3_18_0 0 NMIR W=20u L=1u
Mo2_uU_L3_18_0 gp_3_18_0 dpre_L3_18 ts_uU_L3_18_0 0 NMIR W=20u L=1u
Mo3_uU_L3_18_0 da_uU_L3_18_0 da_uU_L3_18_0 vdd vdd PMIR W=60u L=1u
Mo4_uU_L3_18_0 gp_3_18_0 da_uU_L3_18_0 vdd vdd PMIR W=60u L=1u
Mt_uU_L3_18_1 ts_uU_L3_18_1 hv_L2_5 0 0 NMIR W=48.0u L=1u
Mo1_uU_L3_18_1 da_uU_L3_18_1 d1bar_L3 ts_uU_L3_18_1 0 NMIR W=20u L=1u
Mo2_uU_L3_18_1 gp_3_18_1 dpre_L3_18 ts_uU_L3_18_1 0 NMIR W=20u L=1u
Mo3_uU_L3_18_1 da_uU_L3_18_1 da_uU_L3_18_1 vdd vdd PMIR W=60u L=1u
Mo4_uU_L3_18_1 gp_3_18_1 da_uU_L3_18_1 vdd vdd PMIR W=60u L=1u
Mt_uU_L3_18_2 ts_uU_L3_18_2 hv_L2_12 0 0 NMIR W=48.0u L=1u
Mo1_uU_L3_18_2 da_uU_L3_18_2 d1bar_L3 ts_uU_L3_18_2 0 NMIR W=20u L=1u
Mo2_uU_L3_18_2 gp_3_18_2 dpre_L3_18 ts_uU_L3_18_2 0 NMIR W=20u L=1u
Mo3_uU_L3_18_2 da_uU_L3_18_2 da_uU_L3_18_2 vdd vdd PMIR W=60u L=1u
Mo4_uU_L3_18_2 gp_3_18_2 da_uU_L3_18_2 vdd vdd PMIR W=60u L=1u
Mt_uU_L3_18_3 ts_uU_L3_18_3 hv_L2_13 0 0 NMIR W=48.0u L=1u
Mo1_uU_L3_18_3 da_uU_L3_18_3 d1bar_L3 ts_uU_L3_18_3 0 NMIR W=20u L=1u
Mo2_uU_L3_18_3 gp_3_18_3 dpre_L3_18 ts_uU_L3_18_3 0 NMIR W=20u L=1u
Mo3_uU_L3_18_3 da_uU_L3_18_3 da_uU_L3_18_3 vdd vdd PMIR W=60u L=1u
Mo4_uU_L3_18_3 gp_3_18_3 da_uU_L3_18_3 vdd vdd PMIR W=60u L=1u
Mt_uU_L3_18_4 ts_uU_L3_18_4 hv_L2_14 0 0 NMIR W=48.0u L=1u
Mo1_uU_L3_18_4 da_uU_L3_18_4 d1bar_L3 ts_uU_L3_18_4 0 NMIR W=20u L=1u
Mo2_uU_L3_18_4 gp_3_18_4 dpre_L3_18 ts_uU_L3_18_4 0 NMIR W=20u L=1u
Mo3_uU_L3_18_4 da_uU_L3_18_4 da_uU_L3_18_4 vdd vdd PMIR W=60u L=1u
Mo4_uU_L3_18_4 gp_3_18_4 da_uU_L3_18_4 vdd vdd PMIR W=60u L=1u
Mt_uU_L3_18_5 ts_uU_L3_18_5 hv_L2_16 0 0 NMIR W=48.0u L=1u
Mo1_uU_L3_18_5 da_uU_L3_18_5 d1bar_L3 ts_uU_L3_18_5 0 NMIR W=20u L=1u
Mo2_uU_L3_18_5 gp_3_18_5 dpre_L3_18 ts_uU_L3_18_5 0 NMIR W=20u L=1u
Mo3_uU_L3_18_5 da_uU_L3_18_5 da_uU_L3_18_5 vdd vdd PMIR W=60u L=1u
Mo4_uU_L3_18_5 gp_3_18_5 da_uU_L3_18_5 vdd vdd PMIR W=60u L=1u
Mt_uU_L3_18_6 ts_uU_L3_18_6 hv_L2_18 0 0 NMIR W=48.0u L=1u
Mo1_uU_L3_18_6 da_uU_L3_18_6 d1bar_L3 ts_uU_L3_18_6 0 NMIR W=20u L=1u
Mo2_uU_L3_18_6 gp_3_18_6 dpre_L3_18 ts_uU_L3_18_6 0 NMIR W=20u L=1u
Mo3_uU_L3_18_6 da_uU_L3_18_6 da_uU_L3_18_6 vdd vdd PMIR W=60u L=1u
Mo4_uU_L3_18_6 gp_3_18_6 da_uU_L3_18_6 vdd vdd PMIR W=60u L=1u
Mt_uU_L3_18_7 ts_uU_L3_18_7 hv_L2_20 0 0 NMIR W=48.0u L=1u
Mo1_uU_L3_18_7 da_uU_L3_18_7 d1bar_L3 ts_uU_L3_18_7 0 NMIR W=20u L=1u
Mo2_uU_L3_18_7 gp_3_18_7 dpre_L3_18 ts_uU_L3_18_7 0 NMIR W=20u L=1u
Mo3_uU_L3_18_7 da_uU_L3_18_7 da_uU_L3_18_7 vdd vdd PMIR W=60u L=1u
Mo4_uU_L3_18_7 gp_3_18_7 da_uU_L3_18_7 vdd vdd PMIR W=60u L=1u
Mt_uU_L3_18_8 ts_uU_L3_18_8 hv_L2_25 0 0 NMIR W=48.0u L=1u
Mo1_uU_L3_18_8 da_uU_L3_18_8 d1bar_L3 ts_uU_L3_18_8 0 NMIR W=20u L=1u
Mo2_uU_L3_18_8 gp_3_18_8 dpre_L3_18 ts_uU_L3_18_8 0 NMIR W=20u L=1u
Mo3_uU_L3_18_8 da_uU_L3_18_8 da_uU_L3_18_8 vdd vdd PMIR W=60u L=1u
Mo4_uU_L3_18_8 gp_3_18_8 da_uU_L3_18_8 vdd vdd PMIR W=60u L=1u
Mt_uU_L3_18_9 ts_uU_L3_18_9 hv_L2_34 0 0 NMIR W=48.0u L=1u
Mo1_uU_L3_18_9 da_uU_L3_18_9 d1bar_L3 ts_uU_L3_18_9 0 NMIR W=20u L=1u
Mo2_uU_L3_18_9 gp_3_18_9 dpre_L3_18 ts_uU_L3_18_9 0 NMIR W=20u L=1u
Mo3_uU_L3_18_9 da_uU_L3_18_9 da_uU_L3_18_9 vdd vdd PMIR W=60u L=1u
Mo4_uU_L3_18_9 gp_3_18_9 da_uU_L3_18_9 vdd vdd PMIR W=60u L=1u
Mt_uU_L3_18_10 ts_uU_L3_18_10 hv_L2_36 0 0 NMIR W=48.0u L=1u
Mo1_uU_L3_18_10 da_uU_L3_18_10 d1bar_L3 ts_uU_L3_18_10 0 NMIR W=20u L=1u
Mo2_uU_L3_18_10 gp_3_18_10 dpre_L3_18 ts_uU_L3_18_10 0 NMIR W=20u L=1u
Mo3_uU_L3_18_10 da_uU_L3_18_10 da_uU_L3_18_10 vdd vdd PMIR W=60u L=1u
Mo4_uU_L3_18_10 gp_3_18_10 da_uU_L3_18_10 vdd vdd PMIR W=60u L=1u
Mt_uU_L3_18_11 ts_uU_L3_18_11 hv_L2_37 0 0 NMIR W=48.0u L=1u
Mo1_uU_L3_18_11 da_uU_L3_18_11 d1bar_L3 ts_uU_L3_18_11 0 NMIR W=20u L=1u
Mo2_uU_L3_18_11 gp_3_18_11 dpre_L3_18 ts_uU_L3_18_11 0 NMIR W=20u L=1u
Mo3_uU_L3_18_11 da_uU_L3_18_11 da_uU_L3_18_11 vdd vdd PMIR W=60u L=1u
Mo4_uU_L3_18_11 gp_3_18_11 da_uU_L3_18_11 vdd vdd PMIR W=60u L=1u
Mt_uU_L3_18_12 ts_uU_L3_18_12 hv_L2_38 0 0 NMIR W=48.0u L=1u
Mo1_uU_L3_18_12 da_uU_L3_18_12 d1bar_L3 ts_uU_L3_18_12 0 NMIR W=20u L=1u
Mo2_uU_L3_18_12 gp_3_18_12 dpre_L3_18 ts_uU_L3_18_12 0 NMIR W=20u L=1u
Mo3_uU_L3_18_12 da_uU_L3_18_12 da_uU_L3_18_12 vdd vdd PMIR W=60u L=1u
Mo4_uU_L3_18_12 gp_3_18_12 da_uU_L3_18_12 vdd vdd PMIR W=60u L=1u
Mt_uU_L3_18_13 ts_uU_L3_18_13 hv_L2_39 0 0 NMIR W=48.0u L=1u
Mo1_uU_L3_18_13 da_uU_L3_18_13 d1bar_L3 ts_uU_L3_18_13 0 NMIR W=20u L=1u
Mo2_uU_L3_18_13 gp_3_18_13 dpre_L3_18 ts_uU_L3_18_13 0 NMIR W=20u L=1u
Mo3_uU_L3_18_13 da_uU_L3_18_13 da_uU_L3_18_13 vdd vdd PMIR W=60u L=1u
Mo4_uU_L3_18_13 gp_3_18_13 da_uU_L3_18_13 vdd vdd PMIR W=60u L=1u
Mt_uU_L3_18_14 ts_uU_L3_18_14 hv_L2_40 0 0 NMIR W=48.0u L=1u
Mo1_uU_L3_18_14 da_uU_L3_18_14 d1bar_L3 ts_uU_L3_18_14 0 NMIR W=20u L=1u
Mo2_uU_L3_18_14 gp_3_18_14 dpre_L3_18 ts_uU_L3_18_14 0 NMIR W=20u L=1u
Mo3_uU_L3_18_14 da_uU_L3_18_14 da_uU_L3_18_14 vdd vdd PMIR W=60u L=1u
Mo4_uU_L3_18_14 gp_3_18_14 da_uU_L3_18_14 vdd vdd PMIR W=60u L=1u
Mt_uU_L3_18_15 ts_uU_L3_18_15 hv_L2_43 0 0 NMIR W=48.0u L=1u
Mo1_uU_L3_18_15 da_uU_L3_18_15 d1bar_L3 ts_uU_L3_18_15 0 NMIR W=20u L=1u
Mo2_uU_L3_18_15 gp_3_18_15 dpre_L3_18 ts_uU_L3_18_15 0 NMIR W=20u L=1u
Mo3_uU_L3_18_15 da_uU_L3_18_15 da_uU_L3_18_15 vdd vdd PMIR W=60u L=1u
Mo4_uU_L3_18_15 gp_3_18_15 da_uU_L3_18_15 vdd vdd PMIR W=60u L=1u
Mt_uU_L3_19_0 ts_uU_L3_19_0 hv_L2_2 0 0 NMIR W=48.0u L=1u
Mo1_uU_L3_19_0 da_uU_L3_19_0 d1bar_L3 ts_uU_L3_19_0 0 NMIR W=20u L=1u
Mo2_uU_L3_19_0 gp_3_19_0 dpre_L3_19 ts_uU_L3_19_0 0 NMIR W=20u L=1u
Mo3_uU_L3_19_0 da_uU_L3_19_0 da_uU_L3_19_0 vdd vdd PMIR W=60u L=1u
Mo4_uU_L3_19_0 gp_3_19_0 da_uU_L3_19_0 vdd vdd PMIR W=60u L=1u
Mt_uU_L3_19_1 ts_uU_L3_19_1 hv_L2_9 0 0 NMIR W=48.0u L=1u
Mo1_uU_L3_19_1 da_uU_L3_19_1 d1bar_L3 ts_uU_L3_19_1 0 NMIR W=20u L=1u
Mo2_uU_L3_19_1 gp_3_19_1 dpre_L3_19 ts_uU_L3_19_1 0 NMIR W=20u L=1u
Mo3_uU_L3_19_1 da_uU_L3_19_1 da_uU_L3_19_1 vdd vdd PMIR W=60u L=1u
Mo4_uU_L3_19_1 gp_3_19_1 da_uU_L3_19_1 vdd vdd PMIR W=60u L=1u
Mt_uU_L3_19_2 ts_uU_L3_19_2 hv_L2_12 0 0 NMIR W=48.0u L=1u
Mo1_uU_L3_19_2 da_uU_L3_19_2 d1bar_L3 ts_uU_L3_19_2 0 NMIR W=20u L=1u
Mo2_uU_L3_19_2 gp_3_19_2 dpre_L3_19 ts_uU_L3_19_2 0 NMIR W=20u L=1u
Mo3_uU_L3_19_2 da_uU_L3_19_2 da_uU_L3_19_2 vdd vdd PMIR W=60u L=1u
Mo4_uU_L3_19_2 gp_3_19_2 da_uU_L3_19_2 vdd vdd PMIR W=60u L=1u
Mt_uU_L3_19_3 ts_uU_L3_19_3 hv_L2_13 0 0 NMIR W=48.0u L=1u
Mo1_uU_L3_19_3 da_uU_L3_19_3 d1bar_L3 ts_uU_L3_19_3 0 NMIR W=20u L=1u
Mo2_uU_L3_19_3 gp_3_19_3 dpre_L3_19 ts_uU_L3_19_3 0 NMIR W=20u L=1u
Mo3_uU_L3_19_3 da_uU_L3_19_3 da_uU_L3_19_3 vdd vdd PMIR W=60u L=1u
Mo4_uU_L3_19_3 gp_3_19_3 da_uU_L3_19_3 vdd vdd PMIR W=60u L=1u
Mt_uU_L3_19_4 ts_uU_L3_19_4 hv_L2_18 0 0 NMIR W=48.0u L=1u
Mo1_uU_L3_19_4 da_uU_L3_19_4 d1bar_L3 ts_uU_L3_19_4 0 NMIR W=20u L=1u
Mo2_uU_L3_19_4 gp_3_19_4 dpre_L3_19 ts_uU_L3_19_4 0 NMIR W=20u L=1u
Mo3_uU_L3_19_4 da_uU_L3_19_4 da_uU_L3_19_4 vdd vdd PMIR W=60u L=1u
Mo4_uU_L3_19_4 gp_3_19_4 da_uU_L3_19_4 vdd vdd PMIR W=60u L=1u
Mt_uU_L3_19_5 ts_uU_L3_19_5 hv_L2_19 0 0 NMIR W=48.0u L=1u
Mo1_uU_L3_19_5 da_uU_L3_19_5 d1bar_L3 ts_uU_L3_19_5 0 NMIR W=20u L=1u
Mo2_uU_L3_19_5 gp_3_19_5 dpre_L3_19 ts_uU_L3_19_5 0 NMIR W=20u L=1u
Mo3_uU_L3_19_5 da_uU_L3_19_5 da_uU_L3_19_5 vdd vdd PMIR W=60u L=1u
Mo4_uU_L3_19_5 gp_3_19_5 da_uU_L3_19_5 vdd vdd PMIR W=60u L=1u
Mt_uU_L3_19_6 ts_uU_L3_19_6 hv_L2_22 0 0 NMIR W=48.0u L=1u
Mo1_uU_L3_19_6 da_uU_L3_19_6 d1bar_L3 ts_uU_L3_19_6 0 NMIR W=20u L=1u
Mo2_uU_L3_19_6 gp_3_19_6 dpre_L3_19 ts_uU_L3_19_6 0 NMIR W=20u L=1u
Mo3_uU_L3_19_6 da_uU_L3_19_6 da_uU_L3_19_6 vdd vdd PMIR W=60u L=1u
Mo4_uU_L3_19_6 gp_3_19_6 da_uU_L3_19_6 vdd vdd PMIR W=60u L=1u
Mt_uU_L3_19_7 ts_uU_L3_19_7 hv_L2_27 0 0 NMIR W=48.0u L=1u
Mo1_uU_L3_19_7 da_uU_L3_19_7 d1bar_L3 ts_uU_L3_19_7 0 NMIR W=20u L=1u
Mo2_uU_L3_19_7 gp_3_19_7 dpre_L3_19 ts_uU_L3_19_7 0 NMIR W=20u L=1u
Mo3_uU_L3_19_7 da_uU_L3_19_7 da_uU_L3_19_7 vdd vdd PMIR W=60u L=1u
Mo4_uU_L3_19_7 gp_3_19_7 da_uU_L3_19_7 vdd vdd PMIR W=60u L=1u
Mt_uU_L3_19_8 ts_uU_L3_19_8 hv_L2_28 0 0 NMIR W=48.0u L=1u
Mo1_uU_L3_19_8 da_uU_L3_19_8 d1bar_L3 ts_uU_L3_19_8 0 NMIR W=20u L=1u
Mo2_uU_L3_19_8 gp_3_19_8 dpre_L3_19 ts_uU_L3_19_8 0 NMIR W=20u L=1u
Mo3_uU_L3_19_8 da_uU_L3_19_8 da_uU_L3_19_8 vdd vdd PMIR W=60u L=1u
Mo4_uU_L3_19_8 gp_3_19_8 da_uU_L3_19_8 vdd vdd PMIR W=60u L=1u
Mt_uU_L3_19_9 ts_uU_L3_19_9 hv_L2_31 0 0 NMIR W=48.0u L=1u
Mo1_uU_L3_19_9 da_uU_L3_19_9 d1bar_L3 ts_uU_L3_19_9 0 NMIR W=20u L=1u
Mo2_uU_L3_19_9 gp_3_19_9 dpre_L3_19 ts_uU_L3_19_9 0 NMIR W=20u L=1u
Mo3_uU_L3_19_9 da_uU_L3_19_9 da_uU_L3_19_9 vdd vdd PMIR W=60u L=1u
Mo4_uU_L3_19_9 gp_3_19_9 da_uU_L3_19_9 vdd vdd PMIR W=60u L=1u
Mt_uU_L3_19_10 ts_uU_L3_19_10 hv_L2_32 0 0 NMIR W=48.0u L=1u
Mo1_uU_L3_19_10 da_uU_L3_19_10 d1bar_L3 ts_uU_L3_19_10 0 NMIR W=20u L=1u
Mo2_uU_L3_19_10 gp_3_19_10 dpre_L3_19 ts_uU_L3_19_10 0 NMIR W=20u L=1u
Mo3_uU_L3_19_10 da_uU_L3_19_10 da_uU_L3_19_10 vdd vdd PMIR W=60u L=1u
Mo4_uU_L3_19_10 gp_3_19_10 da_uU_L3_19_10 vdd vdd PMIR W=60u L=1u
Mt_uU_L3_19_11 ts_uU_L3_19_11 hv_L2_39 0 0 NMIR W=48.0u L=1u
Mo1_uU_L3_19_11 da_uU_L3_19_11 d1bar_L3 ts_uU_L3_19_11 0 NMIR W=20u L=1u
Mo2_uU_L3_19_11 gp_3_19_11 dpre_L3_19 ts_uU_L3_19_11 0 NMIR W=20u L=1u
Mo3_uU_L3_19_11 da_uU_L3_19_11 da_uU_L3_19_11 vdd vdd PMIR W=60u L=1u
Mo4_uU_L3_19_11 gp_3_19_11 da_uU_L3_19_11 vdd vdd PMIR W=60u L=1u
Mt_uU_L3_19_12 ts_uU_L3_19_12 hv_L2_41 0 0 NMIR W=48.0u L=1u
Mo1_uU_L3_19_12 da_uU_L3_19_12 d1bar_L3 ts_uU_L3_19_12 0 NMIR W=20u L=1u
Mo2_uU_L3_19_12 gp_3_19_12 dpre_L3_19 ts_uU_L3_19_12 0 NMIR W=20u L=1u
Mo3_uU_L3_19_12 da_uU_L3_19_12 da_uU_L3_19_12 vdd vdd PMIR W=60u L=1u
Mo4_uU_L3_19_12 gp_3_19_12 da_uU_L3_19_12 vdd vdd PMIR W=60u L=1u
Mt_uU_L3_19_13 ts_uU_L3_19_13 hv_L2_43 0 0 NMIR W=48.0u L=1u
Mo1_uU_L3_19_13 da_uU_L3_19_13 d1bar_L3 ts_uU_L3_19_13 0 NMIR W=20u L=1u
Mo2_uU_L3_19_13 gp_3_19_13 dpre_L3_19 ts_uU_L3_19_13 0 NMIR W=20u L=1u
Mo3_uU_L3_19_13 da_uU_L3_19_13 da_uU_L3_19_13 vdd vdd PMIR W=60u L=1u
Mo4_uU_L3_19_13 gp_3_19_13 da_uU_L3_19_13 vdd vdd PMIR W=60u L=1u
Mt_uU_L3_19_14 ts_uU_L3_19_14 hv_L2_44 0 0 NMIR W=48.0u L=1u
Mo1_uU_L3_19_14 da_uU_L3_19_14 d1bar_L3 ts_uU_L3_19_14 0 NMIR W=20u L=1u
Mo2_uU_L3_19_14 gp_3_19_14 dpre_L3_19 ts_uU_L3_19_14 0 NMIR W=20u L=1u
Mo3_uU_L3_19_14 da_uU_L3_19_14 da_uU_L3_19_14 vdd vdd PMIR W=60u L=1u
Mo4_uU_L3_19_14 gp_3_19_14 da_uU_L3_19_14 vdd vdd PMIR W=60u L=1u
Mt_uU_L3_19_15 ts_uU_L3_19_15 hv_L2_47 0 0 NMIR W=48.0u L=1u
Mo1_uU_L3_19_15 da_uU_L3_19_15 d1bar_L3 ts_uU_L3_19_15 0 NMIR W=20u L=1u
Mo2_uU_L3_19_15 gp_3_19_15 dpre_L3_19 ts_uU_L3_19_15 0 NMIR W=20u L=1u
Mo3_uU_L3_19_15 da_uU_L3_19_15 da_uU_L3_19_15 vdd vdd PMIR W=60u L=1u
Mo4_uU_L3_19_15 gp_3_19_15 da_uU_L3_19_15 vdd vdd PMIR W=60u L=1u
Mt_uU_L3_20_0 ts_uU_L3_20_0 hv_L2_0 0 0 NMIR W=48.0u L=1u
Mo1_uU_L3_20_0 da_uU_L3_20_0 d1bar_L3 ts_uU_L3_20_0 0 NMIR W=20u L=1u
Mo2_uU_L3_20_0 gp_3_20_0 dpre_L3_20 ts_uU_L3_20_0 0 NMIR W=20u L=1u
Mo3_uU_L3_20_0 da_uU_L3_20_0 da_uU_L3_20_0 vdd vdd PMIR W=60u L=1u
Mo4_uU_L3_20_0 gp_3_20_0 da_uU_L3_20_0 vdd vdd PMIR W=60u L=1u
Mt_uU_L3_20_1 ts_uU_L3_20_1 hv_L2_3 0 0 NMIR W=48.0u L=1u
Mo1_uU_L3_20_1 da_uU_L3_20_1 d1bar_L3 ts_uU_L3_20_1 0 NMIR W=20u L=1u
Mo2_uU_L3_20_1 gp_3_20_1 dpre_L3_20 ts_uU_L3_20_1 0 NMIR W=20u L=1u
Mo3_uU_L3_20_1 da_uU_L3_20_1 da_uU_L3_20_1 vdd vdd PMIR W=60u L=1u
Mo4_uU_L3_20_1 gp_3_20_1 da_uU_L3_20_1 vdd vdd PMIR W=60u L=1u
Mt_uU_L3_20_2 ts_uU_L3_20_2 hv_L2_4 0 0 NMIR W=48.0u L=1u
Mo1_uU_L3_20_2 da_uU_L3_20_2 d1bar_L3 ts_uU_L3_20_2 0 NMIR W=20u L=1u
Mo2_uU_L3_20_2 gp_3_20_2 dpre_L3_20 ts_uU_L3_20_2 0 NMIR W=20u L=1u
Mo3_uU_L3_20_2 da_uU_L3_20_2 da_uU_L3_20_2 vdd vdd PMIR W=60u L=1u
Mo4_uU_L3_20_2 gp_3_20_2 da_uU_L3_20_2 vdd vdd PMIR W=60u L=1u
Mt_uU_L3_20_3 ts_uU_L3_20_3 hv_L2_7 0 0 NMIR W=48.0u L=1u
Mo1_uU_L3_20_3 da_uU_L3_20_3 d1bar_L3 ts_uU_L3_20_3 0 NMIR W=20u L=1u
Mo2_uU_L3_20_3 gp_3_20_3 dpre_L3_20 ts_uU_L3_20_3 0 NMIR W=20u L=1u
Mo3_uU_L3_20_3 da_uU_L3_20_3 da_uU_L3_20_3 vdd vdd PMIR W=60u L=1u
Mo4_uU_L3_20_3 gp_3_20_3 da_uU_L3_20_3 vdd vdd PMIR W=60u L=1u
Mt_uU_L3_20_4 ts_uU_L3_20_4 hv_L2_9 0 0 NMIR W=48.0u L=1u
Mo1_uU_L3_20_4 da_uU_L3_20_4 d1bar_L3 ts_uU_L3_20_4 0 NMIR W=20u L=1u
Mo2_uU_L3_20_4 gp_3_20_4 dpre_L3_20 ts_uU_L3_20_4 0 NMIR W=20u L=1u
Mo3_uU_L3_20_4 da_uU_L3_20_4 da_uU_L3_20_4 vdd vdd PMIR W=60u L=1u
Mo4_uU_L3_20_4 gp_3_20_4 da_uU_L3_20_4 vdd vdd PMIR W=60u L=1u
Mt_uU_L3_20_5 ts_uU_L3_20_5 hv_L2_15 0 0 NMIR W=48.0u L=1u
Mo1_uU_L3_20_5 da_uU_L3_20_5 d1bar_L3 ts_uU_L3_20_5 0 NMIR W=20u L=1u
Mo2_uU_L3_20_5 gp_3_20_5 dpre_L3_20 ts_uU_L3_20_5 0 NMIR W=20u L=1u
Mo3_uU_L3_20_5 da_uU_L3_20_5 da_uU_L3_20_5 vdd vdd PMIR W=60u L=1u
Mo4_uU_L3_20_5 gp_3_20_5 da_uU_L3_20_5 vdd vdd PMIR W=60u L=1u
Mt_uU_L3_20_6 ts_uU_L3_20_6 hv_L2_20 0 0 NMIR W=48.0u L=1u
Mo1_uU_L3_20_6 da_uU_L3_20_6 d1bar_L3 ts_uU_L3_20_6 0 NMIR W=20u L=1u
Mo2_uU_L3_20_6 gp_3_20_6 dpre_L3_20 ts_uU_L3_20_6 0 NMIR W=20u L=1u
Mo3_uU_L3_20_6 da_uU_L3_20_6 da_uU_L3_20_6 vdd vdd PMIR W=60u L=1u
Mo4_uU_L3_20_6 gp_3_20_6 da_uU_L3_20_6 vdd vdd PMIR W=60u L=1u
Mt_uU_L3_20_7 ts_uU_L3_20_7 hv_L2_23 0 0 NMIR W=48.0u L=1u
Mo1_uU_L3_20_7 da_uU_L3_20_7 d1bar_L3 ts_uU_L3_20_7 0 NMIR W=20u L=1u
Mo2_uU_L3_20_7 gp_3_20_7 dpre_L3_20 ts_uU_L3_20_7 0 NMIR W=20u L=1u
Mo3_uU_L3_20_7 da_uU_L3_20_7 da_uU_L3_20_7 vdd vdd PMIR W=60u L=1u
Mo4_uU_L3_20_7 gp_3_20_7 da_uU_L3_20_7 vdd vdd PMIR W=60u L=1u
Mt_uU_L3_20_8 ts_uU_L3_20_8 hv_L2_24 0 0 NMIR W=48.0u L=1u
Mo1_uU_L3_20_8 da_uU_L3_20_8 d1bar_L3 ts_uU_L3_20_8 0 NMIR W=20u L=1u
Mo2_uU_L3_20_8 gp_3_20_8 dpre_L3_20 ts_uU_L3_20_8 0 NMIR W=20u L=1u
Mo3_uU_L3_20_8 da_uU_L3_20_8 da_uU_L3_20_8 vdd vdd PMIR W=60u L=1u
Mo4_uU_L3_20_8 gp_3_20_8 da_uU_L3_20_8 vdd vdd PMIR W=60u L=1u
Mt_uU_L3_20_9 ts_uU_L3_20_9 hv_L2_27 0 0 NMIR W=48.0u L=1u
Mo1_uU_L3_20_9 da_uU_L3_20_9 d1bar_L3 ts_uU_L3_20_9 0 NMIR W=20u L=1u
Mo2_uU_L3_20_9 gp_3_20_9 dpre_L3_20 ts_uU_L3_20_9 0 NMIR W=20u L=1u
Mo3_uU_L3_20_9 da_uU_L3_20_9 da_uU_L3_20_9 vdd vdd PMIR W=60u L=1u
Mo4_uU_L3_20_9 gp_3_20_9 da_uU_L3_20_9 vdd vdd PMIR W=60u L=1u
Mt_uU_L3_20_10 ts_uU_L3_20_10 hv_L2_28 0 0 NMIR W=48.0u L=1u
Mo1_uU_L3_20_10 da_uU_L3_20_10 d1bar_L3 ts_uU_L3_20_10 0 NMIR W=20u L=1u
Mo2_uU_L3_20_10 gp_3_20_10 dpre_L3_20 ts_uU_L3_20_10 0 NMIR W=20u L=1u
Mo3_uU_L3_20_10 da_uU_L3_20_10 da_uU_L3_20_10 vdd vdd PMIR W=60u L=1u
Mo4_uU_L3_20_10 gp_3_20_10 da_uU_L3_20_10 vdd vdd PMIR W=60u L=1u
Mt_uU_L3_20_11 ts_uU_L3_20_11 hv_L2_32 0 0 NMIR W=48.0u L=1u
Mo1_uU_L3_20_11 da_uU_L3_20_11 d1bar_L3 ts_uU_L3_20_11 0 NMIR W=20u L=1u
Mo2_uU_L3_20_11 gp_3_20_11 dpre_L3_20 ts_uU_L3_20_11 0 NMIR W=20u L=1u
Mo3_uU_L3_20_11 da_uU_L3_20_11 da_uU_L3_20_11 vdd vdd PMIR W=60u L=1u
Mo4_uU_L3_20_11 gp_3_20_11 da_uU_L3_20_11 vdd vdd PMIR W=60u L=1u
Mt_uU_L3_20_12 ts_uU_L3_20_12 hv_L2_33 0 0 NMIR W=48.0u L=1u
Mo1_uU_L3_20_12 da_uU_L3_20_12 d1bar_L3 ts_uU_L3_20_12 0 NMIR W=20u L=1u
Mo2_uU_L3_20_12 gp_3_20_12 dpre_L3_20 ts_uU_L3_20_12 0 NMIR W=20u L=1u
Mo3_uU_L3_20_12 da_uU_L3_20_12 da_uU_L3_20_12 vdd vdd PMIR W=60u L=1u
Mo4_uU_L3_20_12 gp_3_20_12 da_uU_L3_20_12 vdd vdd PMIR W=60u L=1u
Mt_uU_L3_20_13 ts_uU_L3_20_13 hv_L2_38 0 0 NMIR W=48.0u L=1u
Mo1_uU_L3_20_13 da_uU_L3_20_13 d1bar_L3 ts_uU_L3_20_13 0 NMIR W=20u L=1u
Mo2_uU_L3_20_13 gp_3_20_13 dpre_L3_20 ts_uU_L3_20_13 0 NMIR W=20u L=1u
Mo3_uU_L3_20_13 da_uU_L3_20_13 da_uU_L3_20_13 vdd vdd PMIR W=60u L=1u
Mo4_uU_L3_20_13 gp_3_20_13 da_uU_L3_20_13 vdd vdd PMIR W=60u L=1u
Mt_uU_L3_20_14 ts_uU_L3_20_14 hv_L2_39 0 0 NMIR W=48.0u L=1u
Mo1_uU_L3_20_14 da_uU_L3_20_14 d1bar_L3 ts_uU_L3_20_14 0 NMIR W=20u L=1u
Mo2_uU_L3_20_14 gp_3_20_14 dpre_L3_20 ts_uU_L3_20_14 0 NMIR W=20u L=1u
Mo3_uU_L3_20_14 da_uU_L3_20_14 da_uU_L3_20_14 vdd vdd PMIR W=60u L=1u
Mo4_uU_L3_20_14 gp_3_20_14 da_uU_L3_20_14 vdd vdd PMIR W=60u L=1u
Mt_uU_L3_20_15 ts_uU_L3_20_15 hv_L2_44 0 0 NMIR W=48.0u L=1u
Mo1_uU_L3_20_15 da_uU_L3_20_15 d1bar_L3 ts_uU_L3_20_15 0 NMIR W=20u L=1u
Mo2_uU_L3_20_15 gp_3_20_15 dpre_L3_20 ts_uU_L3_20_15 0 NMIR W=20u L=1u
Mo3_uU_L3_20_15 da_uU_L3_20_15 da_uU_L3_20_15 vdd vdd PMIR W=60u L=1u
Mo4_uU_L3_20_15 gp_3_20_15 da_uU_L3_20_15 vdd vdd PMIR W=60u L=1u
Mt_uU_L3_21_0 ts_uU_L3_21_0 hv_L2_3 0 0 NMIR W=48.0u L=1u
Mo1_uU_L3_21_0 da_uU_L3_21_0 d1bar_L3 ts_uU_L3_21_0 0 NMIR W=20u L=1u
Mo2_uU_L3_21_0 gp_3_21_0 dpre_L3_21 ts_uU_L3_21_0 0 NMIR W=20u L=1u
Mo3_uU_L3_21_0 da_uU_L3_21_0 da_uU_L3_21_0 vdd vdd PMIR W=60u L=1u
Mo4_uU_L3_21_0 gp_3_21_0 da_uU_L3_21_0 vdd vdd PMIR W=60u L=1u
Mt_uU_L3_21_1 ts_uU_L3_21_1 hv_L2_7 0 0 NMIR W=48.0u L=1u
Mo1_uU_L3_21_1 da_uU_L3_21_1 d1bar_L3 ts_uU_L3_21_1 0 NMIR W=20u L=1u
Mo2_uU_L3_21_1 gp_3_21_1 dpre_L3_21 ts_uU_L3_21_1 0 NMIR W=20u L=1u
Mo3_uU_L3_21_1 da_uU_L3_21_1 da_uU_L3_21_1 vdd vdd PMIR W=60u L=1u
Mo4_uU_L3_21_1 gp_3_21_1 da_uU_L3_21_1 vdd vdd PMIR W=60u L=1u
Mt_uU_L3_21_2 ts_uU_L3_21_2 hv_L2_9 0 0 NMIR W=48.0u L=1u
Mo1_uU_L3_21_2 da_uU_L3_21_2 d1bar_L3 ts_uU_L3_21_2 0 NMIR W=20u L=1u
Mo2_uU_L3_21_2 gp_3_21_2 dpre_L3_21 ts_uU_L3_21_2 0 NMIR W=20u L=1u
Mo3_uU_L3_21_2 da_uU_L3_21_2 da_uU_L3_21_2 vdd vdd PMIR W=60u L=1u
Mo4_uU_L3_21_2 gp_3_21_2 da_uU_L3_21_2 vdd vdd PMIR W=60u L=1u
Mt_uU_L3_21_3 ts_uU_L3_21_3 hv_L2_11 0 0 NMIR W=48.0u L=1u
Mo1_uU_L3_21_3 da_uU_L3_21_3 d1bar_L3 ts_uU_L3_21_3 0 NMIR W=20u L=1u
Mo2_uU_L3_21_3 gp_3_21_3 dpre_L3_21 ts_uU_L3_21_3 0 NMIR W=20u L=1u
Mo3_uU_L3_21_3 da_uU_L3_21_3 da_uU_L3_21_3 vdd vdd PMIR W=60u L=1u
Mo4_uU_L3_21_3 gp_3_21_3 da_uU_L3_21_3 vdd vdd PMIR W=60u L=1u
Mt_uU_L3_21_4 ts_uU_L3_21_4 hv_L2_12 0 0 NMIR W=48.0u L=1u
Mo1_uU_L3_21_4 da_uU_L3_21_4 d1bar_L3 ts_uU_L3_21_4 0 NMIR W=20u L=1u
Mo2_uU_L3_21_4 gp_3_21_4 dpre_L3_21 ts_uU_L3_21_4 0 NMIR W=20u L=1u
Mo3_uU_L3_21_4 da_uU_L3_21_4 da_uU_L3_21_4 vdd vdd PMIR W=60u L=1u
Mo4_uU_L3_21_4 gp_3_21_4 da_uU_L3_21_4 vdd vdd PMIR W=60u L=1u
Mt_uU_L3_21_5 ts_uU_L3_21_5 hv_L2_15 0 0 NMIR W=48.0u L=1u
Mo1_uU_L3_21_5 da_uU_L3_21_5 d1bar_L3 ts_uU_L3_21_5 0 NMIR W=20u L=1u
Mo2_uU_L3_21_5 gp_3_21_5 dpre_L3_21 ts_uU_L3_21_5 0 NMIR W=20u L=1u
Mo3_uU_L3_21_5 da_uU_L3_21_5 da_uU_L3_21_5 vdd vdd PMIR W=60u L=1u
Mo4_uU_L3_21_5 gp_3_21_5 da_uU_L3_21_5 vdd vdd PMIR W=60u L=1u
Mt_uU_L3_21_6 ts_uU_L3_21_6 hv_L2_16 0 0 NMIR W=48.0u L=1u
Mo1_uU_L3_21_6 da_uU_L3_21_6 d1bar_L3 ts_uU_L3_21_6 0 NMIR W=20u L=1u
Mo2_uU_L3_21_6 gp_3_21_6 dpre_L3_21 ts_uU_L3_21_6 0 NMIR W=20u L=1u
Mo3_uU_L3_21_6 da_uU_L3_21_6 da_uU_L3_21_6 vdd vdd PMIR W=60u L=1u
Mo4_uU_L3_21_6 gp_3_21_6 da_uU_L3_21_6 vdd vdd PMIR W=60u L=1u
Mt_uU_L3_21_7 ts_uU_L3_21_7 hv_L2_19 0 0 NMIR W=48.0u L=1u
Mo1_uU_L3_21_7 da_uU_L3_21_7 d1bar_L3 ts_uU_L3_21_7 0 NMIR W=20u L=1u
Mo2_uU_L3_21_7 gp_3_21_7 dpre_L3_21 ts_uU_L3_21_7 0 NMIR W=20u L=1u
Mo3_uU_L3_21_7 da_uU_L3_21_7 da_uU_L3_21_7 vdd vdd PMIR W=60u L=1u
Mo4_uU_L3_21_7 gp_3_21_7 da_uU_L3_21_7 vdd vdd PMIR W=60u L=1u
Mt_uU_L3_21_8 ts_uU_L3_21_8 hv_L2_23 0 0 NMIR W=48.0u L=1u
Mo1_uU_L3_21_8 da_uU_L3_21_8 d1bar_L3 ts_uU_L3_21_8 0 NMIR W=20u L=1u
Mo2_uU_L3_21_8 gp_3_21_8 dpre_L3_21 ts_uU_L3_21_8 0 NMIR W=20u L=1u
Mo3_uU_L3_21_8 da_uU_L3_21_8 da_uU_L3_21_8 vdd vdd PMIR W=60u L=1u
Mo4_uU_L3_21_8 gp_3_21_8 da_uU_L3_21_8 vdd vdd PMIR W=60u L=1u
Mt_uU_L3_21_9 ts_uU_L3_21_9 hv_L2_29 0 0 NMIR W=48.0u L=1u
Mo1_uU_L3_21_9 da_uU_L3_21_9 d1bar_L3 ts_uU_L3_21_9 0 NMIR W=20u L=1u
Mo2_uU_L3_21_9 gp_3_21_9 dpre_L3_21 ts_uU_L3_21_9 0 NMIR W=20u L=1u
Mo3_uU_L3_21_9 da_uU_L3_21_9 da_uU_L3_21_9 vdd vdd PMIR W=60u L=1u
Mo4_uU_L3_21_9 gp_3_21_9 da_uU_L3_21_9 vdd vdd PMIR W=60u L=1u
Mt_uU_L3_21_10 ts_uU_L3_21_10 hv_L2_31 0 0 NMIR W=48.0u L=1u
Mo1_uU_L3_21_10 da_uU_L3_21_10 d1bar_L3 ts_uU_L3_21_10 0 NMIR W=20u L=1u
Mo2_uU_L3_21_10 gp_3_21_10 dpre_L3_21 ts_uU_L3_21_10 0 NMIR W=20u L=1u
Mo3_uU_L3_21_10 da_uU_L3_21_10 da_uU_L3_21_10 vdd vdd PMIR W=60u L=1u
Mo4_uU_L3_21_10 gp_3_21_10 da_uU_L3_21_10 vdd vdd PMIR W=60u L=1u
Mt_uU_L3_21_11 ts_uU_L3_21_11 hv_L2_33 0 0 NMIR W=48.0u L=1u
Mo1_uU_L3_21_11 da_uU_L3_21_11 d1bar_L3 ts_uU_L3_21_11 0 NMIR W=20u L=1u
Mo2_uU_L3_21_11 gp_3_21_11 dpre_L3_21 ts_uU_L3_21_11 0 NMIR W=20u L=1u
Mo3_uU_L3_21_11 da_uU_L3_21_11 da_uU_L3_21_11 vdd vdd PMIR W=60u L=1u
Mo4_uU_L3_21_11 gp_3_21_11 da_uU_L3_21_11 vdd vdd PMIR W=60u L=1u
Mt_uU_L3_21_12 ts_uU_L3_21_12 hv_L2_36 0 0 NMIR W=48.0u L=1u
Mo1_uU_L3_21_12 da_uU_L3_21_12 d1bar_L3 ts_uU_L3_21_12 0 NMIR W=20u L=1u
Mo2_uU_L3_21_12 gp_3_21_12 dpre_L3_21 ts_uU_L3_21_12 0 NMIR W=20u L=1u
Mo3_uU_L3_21_12 da_uU_L3_21_12 da_uU_L3_21_12 vdd vdd PMIR W=60u L=1u
Mo4_uU_L3_21_12 gp_3_21_12 da_uU_L3_21_12 vdd vdd PMIR W=60u L=1u
Mt_uU_L3_21_13 ts_uU_L3_21_13 hv_L2_38 0 0 NMIR W=48.0u L=1u
Mo1_uU_L3_21_13 da_uU_L3_21_13 d1bar_L3 ts_uU_L3_21_13 0 NMIR W=20u L=1u
Mo2_uU_L3_21_13 gp_3_21_13 dpre_L3_21 ts_uU_L3_21_13 0 NMIR W=20u L=1u
Mo3_uU_L3_21_13 da_uU_L3_21_13 da_uU_L3_21_13 vdd vdd PMIR W=60u L=1u
Mo4_uU_L3_21_13 gp_3_21_13 da_uU_L3_21_13 vdd vdd PMIR W=60u L=1u
Mt_uU_L3_21_14 ts_uU_L3_21_14 hv_L2_39 0 0 NMIR W=48.0u L=1u
Mo1_uU_L3_21_14 da_uU_L3_21_14 d1bar_L3 ts_uU_L3_21_14 0 NMIR W=20u L=1u
Mo2_uU_L3_21_14 gp_3_21_14 dpre_L3_21 ts_uU_L3_21_14 0 NMIR W=20u L=1u
Mo3_uU_L3_21_14 da_uU_L3_21_14 da_uU_L3_21_14 vdd vdd PMIR W=60u L=1u
Mo4_uU_L3_21_14 gp_3_21_14 da_uU_L3_21_14 vdd vdd PMIR W=60u L=1u
Mt_uU_L3_21_15 ts_uU_L3_21_15 hv_L2_47 0 0 NMIR W=48.0u L=1u
Mo1_uU_L3_21_15 da_uU_L3_21_15 d1bar_L3 ts_uU_L3_21_15 0 NMIR W=20u L=1u
Mo2_uU_L3_21_15 gp_3_21_15 dpre_L3_21 ts_uU_L3_21_15 0 NMIR W=20u L=1u
Mo3_uU_L3_21_15 da_uU_L3_21_15 da_uU_L3_21_15 vdd vdd PMIR W=60u L=1u
Mo4_uU_L3_21_15 gp_3_21_15 da_uU_L3_21_15 vdd vdd PMIR W=60u L=1u
Mt_uU_L3_22_0 ts_uU_L3_22_0 hv_L2_2 0 0 NMIR W=48.0u L=1u
Mo1_uU_L3_22_0 da_uU_L3_22_0 d1bar_L3 ts_uU_L3_22_0 0 NMIR W=20u L=1u
Mo2_uU_L3_22_0 gp_3_22_0 dpre_L3_22 ts_uU_L3_22_0 0 NMIR W=20u L=1u
Mo3_uU_L3_22_0 da_uU_L3_22_0 da_uU_L3_22_0 vdd vdd PMIR W=60u L=1u
Mo4_uU_L3_22_0 gp_3_22_0 da_uU_L3_22_0 vdd vdd PMIR W=60u L=1u
Mt_uU_L3_22_1 ts_uU_L3_22_1 hv_L2_3 0 0 NMIR W=48.0u L=1u
Mo1_uU_L3_22_1 da_uU_L3_22_1 d1bar_L3 ts_uU_L3_22_1 0 NMIR W=20u L=1u
Mo2_uU_L3_22_1 gp_3_22_1 dpre_L3_22 ts_uU_L3_22_1 0 NMIR W=20u L=1u
Mo3_uU_L3_22_1 da_uU_L3_22_1 da_uU_L3_22_1 vdd vdd PMIR W=60u L=1u
Mo4_uU_L3_22_1 gp_3_22_1 da_uU_L3_22_1 vdd vdd PMIR W=60u L=1u
Mt_uU_L3_22_2 ts_uU_L3_22_2 hv_L2_7 0 0 NMIR W=48.0u L=1u
Mo1_uU_L3_22_2 da_uU_L3_22_2 d1bar_L3 ts_uU_L3_22_2 0 NMIR W=20u L=1u
Mo2_uU_L3_22_2 gp_3_22_2 dpre_L3_22 ts_uU_L3_22_2 0 NMIR W=20u L=1u
Mo3_uU_L3_22_2 da_uU_L3_22_2 da_uU_L3_22_2 vdd vdd PMIR W=60u L=1u
Mo4_uU_L3_22_2 gp_3_22_2 da_uU_L3_22_2 vdd vdd PMIR W=60u L=1u
Mt_uU_L3_22_3 ts_uU_L3_22_3 hv_L2_8 0 0 NMIR W=48.0u L=1u
Mo1_uU_L3_22_3 da_uU_L3_22_3 d1bar_L3 ts_uU_L3_22_3 0 NMIR W=20u L=1u
Mo2_uU_L3_22_3 gp_3_22_3 dpre_L3_22 ts_uU_L3_22_3 0 NMIR W=20u L=1u
Mo3_uU_L3_22_3 da_uU_L3_22_3 da_uU_L3_22_3 vdd vdd PMIR W=60u L=1u
Mo4_uU_L3_22_3 gp_3_22_3 da_uU_L3_22_3 vdd vdd PMIR W=60u L=1u
Mt_uU_L3_22_4 ts_uU_L3_22_4 hv_L2_11 0 0 NMIR W=48.0u L=1u
Mo1_uU_L3_22_4 da_uU_L3_22_4 d1bar_L3 ts_uU_L3_22_4 0 NMIR W=20u L=1u
Mo2_uU_L3_22_4 gp_3_22_4 dpre_L3_22 ts_uU_L3_22_4 0 NMIR W=20u L=1u
Mo3_uU_L3_22_4 da_uU_L3_22_4 da_uU_L3_22_4 vdd vdd PMIR W=60u L=1u
Mo4_uU_L3_22_4 gp_3_22_4 da_uU_L3_22_4 vdd vdd PMIR W=60u L=1u
Mt_uU_L3_22_5 ts_uU_L3_22_5 hv_L2_14 0 0 NMIR W=48.0u L=1u
Mo1_uU_L3_22_5 da_uU_L3_22_5 d1bar_L3 ts_uU_L3_22_5 0 NMIR W=20u L=1u
Mo2_uU_L3_22_5 gp_3_22_5 dpre_L3_22 ts_uU_L3_22_5 0 NMIR W=20u L=1u
Mo3_uU_L3_22_5 da_uU_L3_22_5 da_uU_L3_22_5 vdd vdd PMIR W=60u L=1u
Mo4_uU_L3_22_5 gp_3_22_5 da_uU_L3_22_5 vdd vdd PMIR W=60u L=1u
Mt_uU_L3_22_6 ts_uU_L3_22_6 hv_L2_17 0 0 NMIR W=48.0u L=1u
Mo1_uU_L3_22_6 da_uU_L3_22_6 d1bar_L3 ts_uU_L3_22_6 0 NMIR W=20u L=1u
Mo2_uU_L3_22_6 gp_3_22_6 dpre_L3_22 ts_uU_L3_22_6 0 NMIR W=20u L=1u
Mo3_uU_L3_22_6 da_uU_L3_22_6 da_uU_L3_22_6 vdd vdd PMIR W=60u L=1u
Mo4_uU_L3_22_6 gp_3_22_6 da_uU_L3_22_6 vdd vdd PMIR W=60u L=1u
Mt_uU_L3_22_7 ts_uU_L3_22_7 hv_L2_21 0 0 NMIR W=48.0u L=1u
Mo1_uU_L3_22_7 da_uU_L3_22_7 d1bar_L3 ts_uU_L3_22_7 0 NMIR W=20u L=1u
Mo2_uU_L3_22_7 gp_3_22_7 dpre_L3_22 ts_uU_L3_22_7 0 NMIR W=20u L=1u
Mo3_uU_L3_22_7 da_uU_L3_22_7 da_uU_L3_22_7 vdd vdd PMIR W=60u L=1u
Mo4_uU_L3_22_7 gp_3_22_7 da_uU_L3_22_7 vdd vdd PMIR W=60u L=1u
Mt_uU_L3_22_8 ts_uU_L3_22_8 hv_L2_23 0 0 NMIR W=48.0u L=1u
Mo1_uU_L3_22_8 da_uU_L3_22_8 d1bar_L3 ts_uU_L3_22_8 0 NMIR W=20u L=1u
Mo2_uU_L3_22_8 gp_3_22_8 dpre_L3_22 ts_uU_L3_22_8 0 NMIR W=20u L=1u
Mo3_uU_L3_22_8 da_uU_L3_22_8 da_uU_L3_22_8 vdd vdd PMIR W=60u L=1u
Mo4_uU_L3_22_8 gp_3_22_8 da_uU_L3_22_8 vdd vdd PMIR W=60u L=1u
Mt_uU_L3_22_9 ts_uU_L3_22_9 hv_L2_24 0 0 NMIR W=48.0u L=1u
Mo1_uU_L3_22_9 da_uU_L3_22_9 d1bar_L3 ts_uU_L3_22_9 0 NMIR W=20u L=1u
Mo2_uU_L3_22_9 gp_3_22_9 dpre_L3_22 ts_uU_L3_22_9 0 NMIR W=20u L=1u
Mo3_uU_L3_22_9 da_uU_L3_22_9 da_uU_L3_22_9 vdd vdd PMIR W=60u L=1u
Mo4_uU_L3_22_9 gp_3_22_9 da_uU_L3_22_9 vdd vdd PMIR W=60u L=1u
Mt_uU_L3_22_10 ts_uU_L3_22_10 hv_L2_27 0 0 NMIR W=48.0u L=1u
Mo1_uU_L3_22_10 da_uU_L3_22_10 d1bar_L3 ts_uU_L3_22_10 0 NMIR W=20u L=1u
Mo2_uU_L3_22_10 gp_3_22_10 dpre_L3_22 ts_uU_L3_22_10 0 NMIR W=20u L=1u
Mo3_uU_L3_22_10 da_uU_L3_22_10 da_uU_L3_22_10 vdd vdd PMIR W=60u L=1u
Mo4_uU_L3_22_10 gp_3_22_10 da_uU_L3_22_10 vdd vdd PMIR W=60u L=1u
Mt_uU_L3_22_11 ts_uU_L3_22_11 hv_L2_31 0 0 NMIR W=48.0u L=1u
Mo1_uU_L3_22_11 da_uU_L3_22_11 d1bar_L3 ts_uU_L3_22_11 0 NMIR W=20u L=1u
Mo2_uU_L3_22_11 gp_3_22_11 dpre_L3_22 ts_uU_L3_22_11 0 NMIR W=20u L=1u
Mo3_uU_L3_22_11 da_uU_L3_22_11 da_uU_L3_22_11 vdd vdd PMIR W=60u L=1u
Mo4_uU_L3_22_11 gp_3_22_11 da_uU_L3_22_11 vdd vdd PMIR W=60u L=1u
Mt_uU_L3_22_12 ts_uU_L3_22_12 hv_L2_35 0 0 NMIR W=48.0u L=1u
Mo1_uU_L3_22_12 da_uU_L3_22_12 d1bar_L3 ts_uU_L3_22_12 0 NMIR W=20u L=1u
Mo2_uU_L3_22_12 gp_3_22_12 dpre_L3_22 ts_uU_L3_22_12 0 NMIR W=20u L=1u
Mo3_uU_L3_22_12 da_uU_L3_22_12 da_uU_L3_22_12 vdd vdd PMIR W=60u L=1u
Mo4_uU_L3_22_12 gp_3_22_12 da_uU_L3_22_12 vdd vdd PMIR W=60u L=1u
Mt_uU_L3_22_13 ts_uU_L3_22_13 hv_L2_37 0 0 NMIR W=48.0u L=1u
Mo1_uU_L3_22_13 da_uU_L3_22_13 d1bar_L3 ts_uU_L3_22_13 0 NMIR W=20u L=1u
Mo2_uU_L3_22_13 gp_3_22_13 dpre_L3_22 ts_uU_L3_22_13 0 NMIR W=20u L=1u
Mo3_uU_L3_22_13 da_uU_L3_22_13 da_uU_L3_22_13 vdd vdd PMIR W=60u L=1u
Mo4_uU_L3_22_13 gp_3_22_13 da_uU_L3_22_13 vdd vdd PMIR W=60u L=1u
Mt_uU_L3_22_14 ts_uU_L3_22_14 hv_L2_40 0 0 NMIR W=48.0u L=1u
Mo1_uU_L3_22_14 da_uU_L3_22_14 d1bar_L3 ts_uU_L3_22_14 0 NMIR W=20u L=1u
Mo2_uU_L3_22_14 gp_3_22_14 dpre_L3_22 ts_uU_L3_22_14 0 NMIR W=20u L=1u
Mo3_uU_L3_22_14 da_uU_L3_22_14 da_uU_L3_22_14 vdd vdd PMIR W=60u L=1u
Mo4_uU_L3_22_14 gp_3_22_14 da_uU_L3_22_14 vdd vdd PMIR W=60u L=1u
Mt_uU_L3_22_15 ts_uU_L3_22_15 hv_L2_46 0 0 NMIR W=48.0u L=1u
Mo1_uU_L3_22_15 da_uU_L3_22_15 d1bar_L3 ts_uU_L3_22_15 0 NMIR W=20u L=1u
Mo2_uU_L3_22_15 gp_3_22_15 dpre_L3_22 ts_uU_L3_22_15 0 NMIR W=20u L=1u
Mo3_uU_L3_22_15 da_uU_L3_22_15 da_uU_L3_22_15 vdd vdd PMIR W=60u L=1u
Mo4_uU_L3_22_15 gp_3_22_15 da_uU_L3_22_15 vdd vdd PMIR W=60u L=1u
Mt_uU_L3_23_0 ts_uU_L3_23_0 hv_L2_6 0 0 NMIR W=48.0u L=1u
Mo1_uU_L3_23_0 da_uU_L3_23_0 d1bar_L3 ts_uU_L3_23_0 0 NMIR W=20u L=1u
Mo2_uU_L3_23_0 gp_3_23_0 dpre_L3_23 ts_uU_L3_23_0 0 NMIR W=20u L=1u
Mo3_uU_L3_23_0 da_uU_L3_23_0 da_uU_L3_23_0 vdd vdd PMIR W=60u L=1u
Mo4_uU_L3_23_0 gp_3_23_0 da_uU_L3_23_0 vdd vdd PMIR W=60u L=1u
Mt_uU_L3_23_1 ts_uU_L3_23_1 hv_L2_7 0 0 NMIR W=48.0u L=1u
Mo1_uU_L3_23_1 da_uU_L3_23_1 d1bar_L3 ts_uU_L3_23_1 0 NMIR W=20u L=1u
Mo2_uU_L3_23_1 gp_3_23_1 dpre_L3_23 ts_uU_L3_23_1 0 NMIR W=20u L=1u
Mo3_uU_L3_23_1 da_uU_L3_23_1 da_uU_L3_23_1 vdd vdd PMIR W=60u L=1u
Mo4_uU_L3_23_1 gp_3_23_1 da_uU_L3_23_1 vdd vdd PMIR W=60u L=1u
Mt_uU_L3_23_2 ts_uU_L3_23_2 hv_L2_12 0 0 NMIR W=48.0u L=1u
Mo1_uU_L3_23_2 da_uU_L3_23_2 d1bar_L3 ts_uU_L3_23_2 0 NMIR W=20u L=1u
Mo2_uU_L3_23_2 gp_3_23_2 dpre_L3_23 ts_uU_L3_23_2 0 NMIR W=20u L=1u
Mo3_uU_L3_23_2 da_uU_L3_23_2 da_uU_L3_23_2 vdd vdd PMIR W=60u L=1u
Mo4_uU_L3_23_2 gp_3_23_2 da_uU_L3_23_2 vdd vdd PMIR W=60u L=1u
Mt_uU_L3_23_3 ts_uU_L3_23_3 hv_L2_13 0 0 NMIR W=48.0u L=1u
Mo1_uU_L3_23_3 da_uU_L3_23_3 d1bar_L3 ts_uU_L3_23_3 0 NMIR W=20u L=1u
Mo2_uU_L3_23_3 gp_3_23_3 dpre_L3_23 ts_uU_L3_23_3 0 NMIR W=20u L=1u
Mo3_uU_L3_23_3 da_uU_L3_23_3 da_uU_L3_23_3 vdd vdd PMIR W=60u L=1u
Mo4_uU_L3_23_3 gp_3_23_3 da_uU_L3_23_3 vdd vdd PMIR W=60u L=1u
Mt_uU_L3_23_4 ts_uU_L3_23_4 hv_L2_17 0 0 NMIR W=48.0u L=1u
Mo1_uU_L3_23_4 da_uU_L3_23_4 d1bar_L3 ts_uU_L3_23_4 0 NMIR W=20u L=1u
Mo2_uU_L3_23_4 gp_3_23_4 dpre_L3_23 ts_uU_L3_23_4 0 NMIR W=20u L=1u
Mo3_uU_L3_23_4 da_uU_L3_23_4 da_uU_L3_23_4 vdd vdd PMIR W=60u L=1u
Mo4_uU_L3_23_4 gp_3_23_4 da_uU_L3_23_4 vdd vdd PMIR W=60u L=1u
Mt_uU_L3_23_5 ts_uU_L3_23_5 hv_L2_18 0 0 NMIR W=48.0u L=1u
Mo1_uU_L3_23_5 da_uU_L3_23_5 d1bar_L3 ts_uU_L3_23_5 0 NMIR W=20u L=1u
Mo2_uU_L3_23_5 gp_3_23_5 dpre_L3_23 ts_uU_L3_23_5 0 NMIR W=20u L=1u
Mo3_uU_L3_23_5 da_uU_L3_23_5 da_uU_L3_23_5 vdd vdd PMIR W=60u L=1u
Mo4_uU_L3_23_5 gp_3_23_5 da_uU_L3_23_5 vdd vdd PMIR W=60u L=1u
Mt_uU_L3_23_6 ts_uU_L3_23_6 hv_L2_24 0 0 NMIR W=48.0u L=1u
Mo1_uU_L3_23_6 da_uU_L3_23_6 d1bar_L3 ts_uU_L3_23_6 0 NMIR W=20u L=1u
Mo2_uU_L3_23_6 gp_3_23_6 dpre_L3_23 ts_uU_L3_23_6 0 NMIR W=20u L=1u
Mo3_uU_L3_23_6 da_uU_L3_23_6 da_uU_L3_23_6 vdd vdd PMIR W=60u L=1u
Mo4_uU_L3_23_6 gp_3_23_6 da_uU_L3_23_6 vdd vdd PMIR W=60u L=1u
Mt_uU_L3_23_7 ts_uU_L3_23_7 hv_L2_29 0 0 NMIR W=48.0u L=1u
Mo1_uU_L3_23_7 da_uU_L3_23_7 d1bar_L3 ts_uU_L3_23_7 0 NMIR W=20u L=1u
Mo2_uU_L3_23_7 gp_3_23_7 dpre_L3_23 ts_uU_L3_23_7 0 NMIR W=20u L=1u
Mo3_uU_L3_23_7 da_uU_L3_23_7 da_uU_L3_23_7 vdd vdd PMIR W=60u L=1u
Mo4_uU_L3_23_7 gp_3_23_7 da_uU_L3_23_7 vdd vdd PMIR W=60u L=1u
Mt_uU_L3_23_8 ts_uU_L3_23_8 hv_L2_33 0 0 NMIR W=48.0u L=1u
Mo1_uU_L3_23_8 da_uU_L3_23_8 d1bar_L3 ts_uU_L3_23_8 0 NMIR W=20u L=1u
Mo2_uU_L3_23_8 gp_3_23_8 dpre_L3_23 ts_uU_L3_23_8 0 NMIR W=20u L=1u
Mo3_uU_L3_23_8 da_uU_L3_23_8 da_uU_L3_23_8 vdd vdd PMIR W=60u L=1u
Mo4_uU_L3_23_8 gp_3_23_8 da_uU_L3_23_8 vdd vdd PMIR W=60u L=1u
Mt_uU_L3_23_9 ts_uU_L3_23_9 hv_L2_35 0 0 NMIR W=48.0u L=1u
Mo1_uU_L3_23_9 da_uU_L3_23_9 d1bar_L3 ts_uU_L3_23_9 0 NMIR W=20u L=1u
Mo2_uU_L3_23_9 gp_3_23_9 dpre_L3_23 ts_uU_L3_23_9 0 NMIR W=20u L=1u
Mo3_uU_L3_23_9 da_uU_L3_23_9 da_uU_L3_23_9 vdd vdd PMIR W=60u L=1u
Mo4_uU_L3_23_9 gp_3_23_9 da_uU_L3_23_9 vdd vdd PMIR W=60u L=1u
Mt_uU_L3_23_10 ts_uU_L3_23_10 hv_L2_39 0 0 NMIR W=48.0u L=1u
Mo1_uU_L3_23_10 da_uU_L3_23_10 d1bar_L3 ts_uU_L3_23_10 0 NMIR W=20u L=1u
Mo2_uU_L3_23_10 gp_3_23_10 dpre_L3_23 ts_uU_L3_23_10 0 NMIR W=20u L=1u
Mo3_uU_L3_23_10 da_uU_L3_23_10 da_uU_L3_23_10 vdd vdd PMIR W=60u L=1u
Mo4_uU_L3_23_10 gp_3_23_10 da_uU_L3_23_10 vdd vdd PMIR W=60u L=1u
Mt_uU_L3_23_11 ts_uU_L3_23_11 hv_L2_40 0 0 NMIR W=48.0u L=1u
Mo1_uU_L3_23_11 da_uU_L3_23_11 d1bar_L3 ts_uU_L3_23_11 0 NMIR W=20u L=1u
Mo2_uU_L3_23_11 gp_3_23_11 dpre_L3_23 ts_uU_L3_23_11 0 NMIR W=20u L=1u
Mo3_uU_L3_23_11 da_uU_L3_23_11 da_uU_L3_23_11 vdd vdd PMIR W=60u L=1u
Mo4_uU_L3_23_11 gp_3_23_11 da_uU_L3_23_11 vdd vdd PMIR W=60u L=1u
Mt_uU_L3_23_12 ts_uU_L3_23_12 hv_L2_41 0 0 NMIR W=48.0u L=1u
Mo1_uU_L3_23_12 da_uU_L3_23_12 d1bar_L3 ts_uU_L3_23_12 0 NMIR W=20u L=1u
Mo2_uU_L3_23_12 gp_3_23_12 dpre_L3_23 ts_uU_L3_23_12 0 NMIR W=20u L=1u
Mo3_uU_L3_23_12 da_uU_L3_23_12 da_uU_L3_23_12 vdd vdd PMIR W=60u L=1u
Mo4_uU_L3_23_12 gp_3_23_12 da_uU_L3_23_12 vdd vdd PMIR W=60u L=1u
Mt_uU_L3_23_13 ts_uU_L3_23_13 hv_L2_42 0 0 NMIR W=48.0u L=1u
Mo1_uU_L3_23_13 da_uU_L3_23_13 d1bar_L3 ts_uU_L3_23_13 0 NMIR W=20u L=1u
Mo2_uU_L3_23_13 gp_3_23_13 dpre_L3_23 ts_uU_L3_23_13 0 NMIR W=20u L=1u
Mo3_uU_L3_23_13 da_uU_L3_23_13 da_uU_L3_23_13 vdd vdd PMIR W=60u L=1u
Mo4_uU_L3_23_13 gp_3_23_13 da_uU_L3_23_13 vdd vdd PMIR W=60u L=1u
Mt_uU_L3_23_14 ts_uU_L3_23_14 hv_L2_45 0 0 NMIR W=48.0u L=1u
Mo1_uU_L3_23_14 da_uU_L3_23_14 d1bar_L3 ts_uU_L3_23_14 0 NMIR W=20u L=1u
Mo2_uU_L3_23_14 gp_3_23_14 dpre_L3_23 ts_uU_L3_23_14 0 NMIR W=20u L=1u
Mo3_uU_L3_23_14 da_uU_L3_23_14 da_uU_L3_23_14 vdd vdd PMIR W=60u L=1u
Mo4_uU_L3_23_14 gp_3_23_14 da_uU_L3_23_14 vdd vdd PMIR W=60u L=1u
Mt_uU_L3_23_15 ts_uU_L3_23_15 hv_L2_47 0 0 NMIR W=48.0u L=1u
Mo1_uU_L3_23_15 da_uU_L3_23_15 d1bar_L3 ts_uU_L3_23_15 0 NMIR W=20u L=1u
Mo2_uU_L3_23_15 gp_3_23_15 dpre_L3_23 ts_uU_L3_23_15 0 NMIR W=20u L=1u
Mo3_uU_L3_23_15 da_uU_L3_23_15 da_uU_L3_23_15 vdd vdd PMIR W=60u L=1u
Mo4_uU_L3_23_15 gp_3_23_15 da_uU_L3_23_15 vdd vdd PMIR W=60u L=1u
Mt_uU_L3_24_0 ts_uU_L3_24_0 hv_L2_3 0 0 NMIR W=48.0u L=1u
Mo1_uU_L3_24_0 da_uU_L3_24_0 d1bar_L3 ts_uU_L3_24_0 0 NMIR W=20u L=1u
Mo2_uU_L3_24_0 gp_3_24_0 dpre_L3_24 ts_uU_L3_24_0 0 NMIR W=20u L=1u
Mo3_uU_L3_24_0 da_uU_L3_24_0 da_uU_L3_24_0 vdd vdd PMIR W=60u L=1u
Mo4_uU_L3_24_0 gp_3_24_0 da_uU_L3_24_0 vdd vdd PMIR W=60u L=1u
Mt_uU_L3_24_1 ts_uU_L3_24_1 hv_L2_5 0 0 NMIR W=48.0u L=1u
Mo1_uU_L3_24_1 da_uU_L3_24_1 d1bar_L3 ts_uU_L3_24_1 0 NMIR W=20u L=1u
Mo2_uU_L3_24_1 gp_3_24_1 dpre_L3_24 ts_uU_L3_24_1 0 NMIR W=20u L=1u
Mo3_uU_L3_24_1 da_uU_L3_24_1 da_uU_L3_24_1 vdd vdd PMIR W=60u L=1u
Mo4_uU_L3_24_1 gp_3_24_1 da_uU_L3_24_1 vdd vdd PMIR W=60u L=1u
Mt_uU_L3_24_2 ts_uU_L3_24_2 hv_L2_8 0 0 NMIR W=48.0u L=1u
Mo1_uU_L3_24_2 da_uU_L3_24_2 d1bar_L3 ts_uU_L3_24_2 0 NMIR W=20u L=1u
Mo2_uU_L3_24_2 gp_3_24_2 dpre_L3_24 ts_uU_L3_24_2 0 NMIR W=20u L=1u
Mo3_uU_L3_24_2 da_uU_L3_24_2 da_uU_L3_24_2 vdd vdd PMIR W=60u L=1u
Mo4_uU_L3_24_2 gp_3_24_2 da_uU_L3_24_2 vdd vdd PMIR W=60u L=1u
Mt_uU_L3_24_3 ts_uU_L3_24_3 hv_L2_10 0 0 NMIR W=48.0u L=1u
Mo1_uU_L3_24_3 da_uU_L3_24_3 d1bar_L3 ts_uU_L3_24_3 0 NMIR W=20u L=1u
Mo2_uU_L3_24_3 gp_3_24_3 dpre_L3_24 ts_uU_L3_24_3 0 NMIR W=20u L=1u
Mo3_uU_L3_24_3 da_uU_L3_24_3 da_uU_L3_24_3 vdd vdd PMIR W=60u L=1u
Mo4_uU_L3_24_3 gp_3_24_3 da_uU_L3_24_3 vdd vdd PMIR W=60u L=1u
Mt_uU_L3_24_4 ts_uU_L3_24_4 hv_L2_19 0 0 NMIR W=48.0u L=1u
Mo1_uU_L3_24_4 da_uU_L3_24_4 d1bar_L3 ts_uU_L3_24_4 0 NMIR W=20u L=1u
Mo2_uU_L3_24_4 gp_3_24_4 dpre_L3_24 ts_uU_L3_24_4 0 NMIR W=20u L=1u
Mo3_uU_L3_24_4 da_uU_L3_24_4 da_uU_L3_24_4 vdd vdd PMIR W=60u L=1u
Mo4_uU_L3_24_4 gp_3_24_4 da_uU_L3_24_4 vdd vdd PMIR W=60u L=1u
Mt_uU_L3_24_5 ts_uU_L3_24_5 hv_L2_21 0 0 NMIR W=48.0u L=1u
Mo1_uU_L3_24_5 da_uU_L3_24_5 d1bar_L3 ts_uU_L3_24_5 0 NMIR W=20u L=1u
Mo2_uU_L3_24_5 gp_3_24_5 dpre_L3_24 ts_uU_L3_24_5 0 NMIR W=20u L=1u
Mo3_uU_L3_24_5 da_uU_L3_24_5 da_uU_L3_24_5 vdd vdd PMIR W=60u L=1u
Mo4_uU_L3_24_5 gp_3_24_5 da_uU_L3_24_5 vdd vdd PMIR W=60u L=1u
Mt_uU_L3_24_6 ts_uU_L3_24_6 hv_L2_25 0 0 NMIR W=48.0u L=1u
Mo1_uU_L3_24_6 da_uU_L3_24_6 d1bar_L3 ts_uU_L3_24_6 0 NMIR W=20u L=1u
Mo2_uU_L3_24_6 gp_3_24_6 dpre_L3_24 ts_uU_L3_24_6 0 NMIR W=20u L=1u
Mo3_uU_L3_24_6 da_uU_L3_24_6 da_uU_L3_24_6 vdd vdd PMIR W=60u L=1u
Mo4_uU_L3_24_6 gp_3_24_6 da_uU_L3_24_6 vdd vdd PMIR W=60u L=1u
Mt_uU_L3_24_7 ts_uU_L3_24_7 hv_L2_35 0 0 NMIR W=48.0u L=1u
Mo1_uU_L3_24_7 da_uU_L3_24_7 d1bar_L3 ts_uU_L3_24_7 0 NMIR W=20u L=1u
Mo2_uU_L3_24_7 gp_3_24_7 dpre_L3_24 ts_uU_L3_24_7 0 NMIR W=20u L=1u
Mo3_uU_L3_24_7 da_uU_L3_24_7 da_uU_L3_24_7 vdd vdd PMIR W=60u L=1u
Mo4_uU_L3_24_7 gp_3_24_7 da_uU_L3_24_7 vdd vdd PMIR W=60u L=1u
Mt_uU_L3_24_8 ts_uU_L3_24_8 hv_L2_36 0 0 NMIR W=48.0u L=1u
Mo1_uU_L3_24_8 da_uU_L3_24_8 d1bar_L3 ts_uU_L3_24_8 0 NMIR W=20u L=1u
Mo2_uU_L3_24_8 gp_3_24_8 dpre_L3_24 ts_uU_L3_24_8 0 NMIR W=20u L=1u
Mo3_uU_L3_24_8 da_uU_L3_24_8 da_uU_L3_24_8 vdd vdd PMIR W=60u L=1u
Mo4_uU_L3_24_8 gp_3_24_8 da_uU_L3_24_8 vdd vdd PMIR W=60u L=1u
Mt_uU_L3_24_9 ts_uU_L3_24_9 hv_L2_37 0 0 NMIR W=48.0u L=1u
Mo1_uU_L3_24_9 da_uU_L3_24_9 d1bar_L3 ts_uU_L3_24_9 0 NMIR W=20u L=1u
Mo2_uU_L3_24_9 gp_3_24_9 dpre_L3_24 ts_uU_L3_24_9 0 NMIR W=20u L=1u
Mo3_uU_L3_24_9 da_uU_L3_24_9 da_uU_L3_24_9 vdd vdd PMIR W=60u L=1u
Mo4_uU_L3_24_9 gp_3_24_9 da_uU_L3_24_9 vdd vdd PMIR W=60u L=1u
Mt_uU_L3_24_10 ts_uU_L3_24_10 hv_L2_39 0 0 NMIR W=48.0u L=1u
Mo1_uU_L3_24_10 da_uU_L3_24_10 d1bar_L3 ts_uU_L3_24_10 0 NMIR W=20u L=1u
Mo2_uU_L3_24_10 gp_3_24_10 dpre_L3_24 ts_uU_L3_24_10 0 NMIR W=20u L=1u
Mo3_uU_L3_24_10 da_uU_L3_24_10 da_uU_L3_24_10 vdd vdd PMIR W=60u L=1u
Mo4_uU_L3_24_10 gp_3_24_10 da_uU_L3_24_10 vdd vdd PMIR W=60u L=1u
Mt_uU_L3_24_11 ts_uU_L3_24_11 hv_L2_41 0 0 NMIR W=48.0u L=1u
Mo1_uU_L3_24_11 da_uU_L3_24_11 d1bar_L3 ts_uU_L3_24_11 0 NMIR W=20u L=1u
Mo2_uU_L3_24_11 gp_3_24_11 dpre_L3_24 ts_uU_L3_24_11 0 NMIR W=20u L=1u
Mo3_uU_L3_24_11 da_uU_L3_24_11 da_uU_L3_24_11 vdd vdd PMIR W=60u L=1u
Mo4_uU_L3_24_11 gp_3_24_11 da_uU_L3_24_11 vdd vdd PMIR W=60u L=1u
Mt_uU_L3_24_12 ts_uU_L3_24_12 hv_L2_42 0 0 NMIR W=48.0u L=1u
Mo1_uU_L3_24_12 da_uU_L3_24_12 d1bar_L3 ts_uU_L3_24_12 0 NMIR W=20u L=1u
Mo2_uU_L3_24_12 gp_3_24_12 dpre_L3_24 ts_uU_L3_24_12 0 NMIR W=20u L=1u
Mo3_uU_L3_24_12 da_uU_L3_24_12 da_uU_L3_24_12 vdd vdd PMIR W=60u L=1u
Mo4_uU_L3_24_12 gp_3_24_12 da_uU_L3_24_12 vdd vdd PMIR W=60u L=1u
Mt_uU_L3_24_13 ts_uU_L3_24_13 hv_L2_43 0 0 NMIR W=48.0u L=1u
Mo1_uU_L3_24_13 da_uU_L3_24_13 d1bar_L3 ts_uU_L3_24_13 0 NMIR W=20u L=1u
Mo2_uU_L3_24_13 gp_3_24_13 dpre_L3_24 ts_uU_L3_24_13 0 NMIR W=20u L=1u
Mo3_uU_L3_24_13 da_uU_L3_24_13 da_uU_L3_24_13 vdd vdd PMIR W=60u L=1u
Mo4_uU_L3_24_13 gp_3_24_13 da_uU_L3_24_13 vdd vdd PMIR W=60u L=1u
Mt_uU_L3_24_14 ts_uU_L3_24_14 hv_L2_46 0 0 NMIR W=48.0u L=1u
Mo1_uU_L3_24_14 da_uU_L3_24_14 d1bar_L3 ts_uU_L3_24_14 0 NMIR W=20u L=1u
Mo2_uU_L3_24_14 gp_3_24_14 dpre_L3_24 ts_uU_L3_24_14 0 NMIR W=20u L=1u
Mo3_uU_L3_24_14 da_uU_L3_24_14 da_uU_L3_24_14 vdd vdd PMIR W=60u L=1u
Mo4_uU_L3_24_14 gp_3_24_14 da_uU_L3_24_14 vdd vdd PMIR W=60u L=1u
Mt_uU_L3_24_15 ts_uU_L3_24_15 hv_L2_47 0 0 NMIR W=48.0u L=1u
Mo1_uU_L3_24_15 da_uU_L3_24_15 d1bar_L3 ts_uU_L3_24_15 0 NMIR W=20u L=1u
Mo2_uU_L3_24_15 gp_3_24_15 dpre_L3_24 ts_uU_L3_24_15 0 NMIR W=20u L=1u
Mo3_uU_L3_24_15 da_uU_L3_24_15 da_uU_L3_24_15 vdd vdd PMIR W=60u L=1u
Mo4_uU_L3_24_15 gp_3_24_15 da_uU_L3_24_15 vdd vdd PMIR W=60u L=1u
Mt_uU_L3_25_0 ts_uU_L3_25_0 hv_L2_1 0 0 NMIR W=48.0u L=1u
Mo1_uU_L3_25_0 da_uU_L3_25_0 d1bar_L3 ts_uU_L3_25_0 0 NMIR W=20u L=1u
Mo2_uU_L3_25_0 gp_3_25_0 dpre_L3_25 ts_uU_L3_25_0 0 NMIR W=20u L=1u
Mo3_uU_L3_25_0 da_uU_L3_25_0 da_uU_L3_25_0 vdd vdd PMIR W=60u L=1u
Mo4_uU_L3_25_0 gp_3_25_0 da_uU_L3_25_0 vdd vdd PMIR W=60u L=1u
Mt_uU_L3_25_1 ts_uU_L3_25_1 hv_L2_5 0 0 NMIR W=48.0u L=1u
Mo1_uU_L3_25_1 da_uU_L3_25_1 d1bar_L3 ts_uU_L3_25_1 0 NMIR W=20u L=1u
Mo2_uU_L3_25_1 gp_3_25_1 dpre_L3_25 ts_uU_L3_25_1 0 NMIR W=20u L=1u
Mo3_uU_L3_25_1 da_uU_L3_25_1 da_uU_L3_25_1 vdd vdd PMIR W=60u L=1u
Mo4_uU_L3_25_1 gp_3_25_1 da_uU_L3_25_1 vdd vdd PMIR W=60u L=1u
Mt_uU_L3_25_2 ts_uU_L3_25_2 hv_L2_7 0 0 NMIR W=48.0u L=1u
Mo1_uU_L3_25_2 da_uU_L3_25_2 d1bar_L3 ts_uU_L3_25_2 0 NMIR W=20u L=1u
Mo2_uU_L3_25_2 gp_3_25_2 dpre_L3_25 ts_uU_L3_25_2 0 NMIR W=20u L=1u
Mo3_uU_L3_25_2 da_uU_L3_25_2 da_uU_L3_25_2 vdd vdd PMIR W=60u L=1u
Mo4_uU_L3_25_2 gp_3_25_2 da_uU_L3_25_2 vdd vdd PMIR W=60u L=1u
Mt_uU_L3_25_3 ts_uU_L3_25_3 hv_L2_8 0 0 NMIR W=48.0u L=1u
Mo1_uU_L3_25_3 da_uU_L3_25_3 d1bar_L3 ts_uU_L3_25_3 0 NMIR W=20u L=1u
Mo2_uU_L3_25_3 gp_3_25_3 dpre_L3_25 ts_uU_L3_25_3 0 NMIR W=20u L=1u
Mo3_uU_L3_25_3 da_uU_L3_25_3 da_uU_L3_25_3 vdd vdd PMIR W=60u L=1u
Mo4_uU_L3_25_3 gp_3_25_3 da_uU_L3_25_3 vdd vdd PMIR W=60u L=1u
Mt_uU_L3_25_4 ts_uU_L3_25_4 hv_L2_15 0 0 NMIR W=48.0u L=1u
Mo1_uU_L3_25_4 da_uU_L3_25_4 d1bar_L3 ts_uU_L3_25_4 0 NMIR W=20u L=1u
Mo2_uU_L3_25_4 gp_3_25_4 dpre_L3_25 ts_uU_L3_25_4 0 NMIR W=20u L=1u
Mo3_uU_L3_25_4 da_uU_L3_25_4 da_uU_L3_25_4 vdd vdd PMIR W=60u L=1u
Mo4_uU_L3_25_4 gp_3_25_4 da_uU_L3_25_4 vdd vdd PMIR W=60u L=1u
Mt_uU_L3_25_5 ts_uU_L3_25_5 hv_L2_17 0 0 NMIR W=48.0u L=1u
Mo1_uU_L3_25_5 da_uU_L3_25_5 d1bar_L3 ts_uU_L3_25_5 0 NMIR W=20u L=1u
Mo2_uU_L3_25_5 gp_3_25_5 dpre_L3_25 ts_uU_L3_25_5 0 NMIR W=20u L=1u
Mo3_uU_L3_25_5 da_uU_L3_25_5 da_uU_L3_25_5 vdd vdd PMIR W=60u L=1u
Mo4_uU_L3_25_5 gp_3_25_5 da_uU_L3_25_5 vdd vdd PMIR W=60u L=1u
Mt_uU_L3_25_6 ts_uU_L3_25_6 hv_L2_19 0 0 NMIR W=48.0u L=1u
Mo1_uU_L3_25_6 da_uU_L3_25_6 d1bar_L3 ts_uU_L3_25_6 0 NMIR W=20u L=1u
Mo2_uU_L3_25_6 gp_3_25_6 dpre_L3_25 ts_uU_L3_25_6 0 NMIR W=20u L=1u
Mo3_uU_L3_25_6 da_uU_L3_25_6 da_uU_L3_25_6 vdd vdd PMIR W=60u L=1u
Mo4_uU_L3_25_6 gp_3_25_6 da_uU_L3_25_6 vdd vdd PMIR W=60u L=1u
Mt_uU_L3_25_7 ts_uU_L3_25_7 hv_L2_23 0 0 NMIR W=48.0u L=1u
Mo1_uU_L3_25_7 da_uU_L3_25_7 d1bar_L3 ts_uU_L3_25_7 0 NMIR W=20u L=1u
Mo2_uU_L3_25_7 gp_3_25_7 dpre_L3_25 ts_uU_L3_25_7 0 NMIR W=20u L=1u
Mo3_uU_L3_25_7 da_uU_L3_25_7 da_uU_L3_25_7 vdd vdd PMIR W=60u L=1u
Mo4_uU_L3_25_7 gp_3_25_7 da_uU_L3_25_7 vdd vdd PMIR W=60u L=1u
Mt_uU_L3_25_8 ts_uU_L3_25_8 hv_L2_25 0 0 NMIR W=48.0u L=1u
Mo1_uU_L3_25_8 da_uU_L3_25_8 d1bar_L3 ts_uU_L3_25_8 0 NMIR W=20u L=1u
Mo2_uU_L3_25_8 gp_3_25_8 dpre_L3_25 ts_uU_L3_25_8 0 NMIR W=20u L=1u
Mo3_uU_L3_25_8 da_uU_L3_25_8 da_uU_L3_25_8 vdd vdd PMIR W=60u L=1u
Mo4_uU_L3_25_8 gp_3_25_8 da_uU_L3_25_8 vdd vdd PMIR W=60u L=1u
Mt_uU_L3_25_9 ts_uU_L3_25_9 hv_L2_26 0 0 NMIR W=48.0u L=1u
Mo1_uU_L3_25_9 da_uU_L3_25_9 d1bar_L3 ts_uU_L3_25_9 0 NMIR W=20u L=1u
Mo2_uU_L3_25_9 gp_3_25_9 dpre_L3_25 ts_uU_L3_25_9 0 NMIR W=20u L=1u
Mo3_uU_L3_25_9 da_uU_L3_25_9 da_uU_L3_25_9 vdd vdd PMIR W=60u L=1u
Mo4_uU_L3_25_9 gp_3_25_9 da_uU_L3_25_9 vdd vdd PMIR W=60u L=1u
Mt_uU_L3_25_10 ts_uU_L3_25_10 hv_L2_27 0 0 NMIR W=48.0u L=1u
Mo1_uU_L3_25_10 da_uU_L3_25_10 d1bar_L3 ts_uU_L3_25_10 0 NMIR W=20u L=1u
Mo2_uU_L3_25_10 gp_3_25_10 dpre_L3_25 ts_uU_L3_25_10 0 NMIR W=20u L=1u
Mo3_uU_L3_25_10 da_uU_L3_25_10 da_uU_L3_25_10 vdd vdd PMIR W=60u L=1u
Mo4_uU_L3_25_10 gp_3_25_10 da_uU_L3_25_10 vdd vdd PMIR W=60u L=1u
Mt_uU_L3_25_11 ts_uU_L3_25_11 hv_L2_38 0 0 NMIR W=48.0u L=1u
Mo1_uU_L3_25_11 da_uU_L3_25_11 d1bar_L3 ts_uU_L3_25_11 0 NMIR W=20u L=1u
Mo2_uU_L3_25_11 gp_3_25_11 dpre_L3_25 ts_uU_L3_25_11 0 NMIR W=20u L=1u
Mo3_uU_L3_25_11 da_uU_L3_25_11 da_uU_L3_25_11 vdd vdd PMIR W=60u L=1u
Mo4_uU_L3_25_11 gp_3_25_11 da_uU_L3_25_11 vdd vdd PMIR W=60u L=1u
Mt_uU_L3_25_12 ts_uU_L3_25_12 hv_L2_42 0 0 NMIR W=48.0u L=1u
Mo1_uU_L3_25_12 da_uU_L3_25_12 d1bar_L3 ts_uU_L3_25_12 0 NMIR W=20u L=1u
Mo2_uU_L3_25_12 gp_3_25_12 dpre_L3_25 ts_uU_L3_25_12 0 NMIR W=20u L=1u
Mo3_uU_L3_25_12 da_uU_L3_25_12 da_uU_L3_25_12 vdd vdd PMIR W=60u L=1u
Mo4_uU_L3_25_12 gp_3_25_12 da_uU_L3_25_12 vdd vdd PMIR W=60u L=1u
Mt_uU_L3_25_13 ts_uU_L3_25_13 hv_L2_44 0 0 NMIR W=48.0u L=1u
Mo1_uU_L3_25_13 da_uU_L3_25_13 d1bar_L3 ts_uU_L3_25_13 0 NMIR W=20u L=1u
Mo2_uU_L3_25_13 gp_3_25_13 dpre_L3_25 ts_uU_L3_25_13 0 NMIR W=20u L=1u
Mo3_uU_L3_25_13 da_uU_L3_25_13 da_uU_L3_25_13 vdd vdd PMIR W=60u L=1u
Mo4_uU_L3_25_13 gp_3_25_13 da_uU_L3_25_13 vdd vdd PMIR W=60u L=1u
Mt_uU_L3_25_14 ts_uU_L3_25_14 hv_L2_45 0 0 NMIR W=48.0u L=1u
Mo1_uU_L3_25_14 da_uU_L3_25_14 d1bar_L3 ts_uU_L3_25_14 0 NMIR W=20u L=1u
Mo2_uU_L3_25_14 gp_3_25_14 dpre_L3_25 ts_uU_L3_25_14 0 NMIR W=20u L=1u
Mo3_uU_L3_25_14 da_uU_L3_25_14 da_uU_L3_25_14 vdd vdd PMIR W=60u L=1u
Mo4_uU_L3_25_14 gp_3_25_14 da_uU_L3_25_14 vdd vdd PMIR W=60u L=1u
Mt_uU_L3_25_15 ts_uU_L3_25_15 hv_L2_47 0 0 NMIR W=48.0u L=1u
Mo1_uU_L3_25_15 da_uU_L3_25_15 d1bar_L3 ts_uU_L3_25_15 0 NMIR W=20u L=1u
Mo2_uU_L3_25_15 gp_3_25_15 dpre_L3_25 ts_uU_L3_25_15 0 NMIR W=20u L=1u
Mo3_uU_L3_25_15 da_uU_L3_25_15 da_uU_L3_25_15 vdd vdd PMIR W=60u L=1u
Mo4_uU_L3_25_15 gp_3_25_15 da_uU_L3_25_15 vdd vdd PMIR W=60u L=1u
Mt_uU_L3_26_0 ts_uU_L3_26_0 hv_L2_0 0 0 NMIR W=48.0u L=1u
Mo1_uU_L3_26_0 da_uU_L3_26_0 d1bar_L3 ts_uU_L3_26_0 0 NMIR W=20u L=1u
Mo2_uU_L3_26_0 gp_3_26_0 dpre_L3_26 ts_uU_L3_26_0 0 NMIR W=20u L=1u
Mo3_uU_L3_26_0 da_uU_L3_26_0 da_uU_L3_26_0 vdd vdd PMIR W=60u L=1u
Mo4_uU_L3_26_0 gp_3_26_0 da_uU_L3_26_0 vdd vdd PMIR W=60u L=1u
Mt_uU_L3_26_1 ts_uU_L3_26_1 hv_L2_4 0 0 NMIR W=48.0u L=1u
Mo1_uU_L3_26_1 da_uU_L3_26_1 d1bar_L3 ts_uU_L3_26_1 0 NMIR W=20u L=1u
Mo2_uU_L3_26_1 gp_3_26_1 dpre_L3_26 ts_uU_L3_26_1 0 NMIR W=20u L=1u
Mo3_uU_L3_26_1 da_uU_L3_26_1 da_uU_L3_26_1 vdd vdd PMIR W=60u L=1u
Mo4_uU_L3_26_1 gp_3_26_1 da_uU_L3_26_1 vdd vdd PMIR W=60u L=1u
Mt_uU_L3_26_2 ts_uU_L3_26_2 hv_L2_6 0 0 NMIR W=48.0u L=1u
Mo1_uU_L3_26_2 da_uU_L3_26_2 d1bar_L3 ts_uU_L3_26_2 0 NMIR W=20u L=1u
Mo2_uU_L3_26_2 gp_3_26_2 dpre_L3_26 ts_uU_L3_26_2 0 NMIR W=20u L=1u
Mo3_uU_L3_26_2 da_uU_L3_26_2 da_uU_L3_26_2 vdd vdd PMIR W=60u L=1u
Mo4_uU_L3_26_2 gp_3_26_2 da_uU_L3_26_2 vdd vdd PMIR W=60u L=1u
Mt_uU_L3_26_3 ts_uU_L3_26_3 hv_L2_9 0 0 NMIR W=48.0u L=1u
Mo1_uU_L3_26_3 da_uU_L3_26_3 d1bar_L3 ts_uU_L3_26_3 0 NMIR W=20u L=1u
Mo2_uU_L3_26_3 gp_3_26_3 dpre_L3_26 ts_uU_L3_26_3 0 NMIR W=20u L=1u
Mo3_uU_L3_26_3 da_uU_L3_26_3 da_uU_L3_26_3 vdd vdd PMIR W=60u L=1u
Mo4_uU_L3_26_3 gp_3_26_3 da_uU_L3_26_3 vdd vdd PMIR W=60u L=1u
Mt_uU_L3_26_4 ts_uU_L3_26_4 hv_L2_11 0 0 NMIR W=48.0u L=1u
Mo1_uU_L3_26_4 da_uU_L3_26_4 d1bar_L3 ts_uU_L3_26_4 0 NMIR W=20u L=1u
Mo2_uU_L3_26_4 gp_3_26_4 dpre_L3_26 ts_uU_L3_26_4 0 NMIR W=20u L=1u
Mo3_uU_L3_26_4 da_uU_L3_26_4 da_uU_L3_26_4 vdd vdd PMIR W=60u L=1u
Mo4_uU_L3_26_4 gp_3_26_4 da_uU_L3_26_4 vdd vdd PMIR W=60u L=1u
Mt_uU_L3_26_5 ts_uU_L3_26_5 hv_L2_14 0 0 NMIR W=48.0u L=1u
Mo1_uU_L3_26_5 da_uU_L3_26_5 d1bar_L3 ts_uU_L3_26_5 0 NMIR W=20u L=1u
Mo2_uU_L3_26_5 gp_3_26_5 dpre_L3_26 ts_uU_L3_26_5 0 NMIR W=20u L=1u
Mo3_uU_L3_26_5 da_uU_L3_26_5 da_uU_L3_26_5 vdd vdd PMIR W=60u L=1u
Mo4_uU_L3_26_5 gp_3_26_5 da_uU_L3_26_5 vdd vdd PMIR W=60u L=1u
Mt_uU_L3_26_6 ts_uU_L3_26_6 hv_L2_19 0 0 NMIR W=48.0u L=1u
Mo1_uU_L3_26_6 da_uU_L3_26_6 d1bar_L3 ts_uU_L3_26_6 0 NMIR W=20u L=1u
Mo2_uU_L3_26_6 gp_3_26_6 dpre_L3_26 ts_uU_L3_26_6 0 NMIR W=20u L=1u
Mo3_uU_L3_26_6 da_uU_L3_26_6 da_uU_L3_26_6 vdd vdd PMIR W=60u L=1u
Mo4_uU_L3_26_6 gp_3_26_6 da_uU_L3_26_6 vdd vdd PMIR W=60u L=1u
Mt_uU_L3_26_7 ts_uU_L3_26_7 hv_L2_21 0 0 NMIR W=48.0u L=1u
Mo1_uU_L3_26_7 da_uU_L3_26_7 d1bar_L3 ts_uU_L3_26_7 0 NMIR W=20u L=1u
Mo2_uU_L3_26_7 gp_3_26_7 dpre_L3_26 ts_uU_L3_26_7 0 NMIR W=20u L=1u
Mo3_uU_L3_26_7 da_uU_L3_26_7 da_uU_L3_26_7 vdd vdd PMIR W=60u L=1u
Mo4_uU_L3_26_7 gp_3_26_7 da_uU_L3_26_7 vdd vdd PMIR W=60u L=1u
Mt_uU_L3_26_8 ts_uU_L3_26_8 hv_L2_22 0 0 NMIR W=48.0u L=1u
Mo1_uU_L3_26_8 da_uU_L3_26_8 d1bar_L3 ts_uU_L3_26_8 0 NMIR W=20u L=1u
Mo2_uU_L3_26_8 gp_3_26_8 dpre_L3_26 ts_uU_L3_26_8 0 NMIR W=20u L=1u
Mo3_uU_L3_26_8 da_uU_L3_26_8 da_uU_L3_26_8 vdd vdd PMIR W=60u L=1u
Mo4_uU_L3_26_8 gp_3_26_8 da_uU_L3_26_8 vdd vdd PMIR W=60u L=1u
Mt_uU_L3_26_9 ts_uU_L3_26_9 hv_L2_25 0 0 NMIR W=48.0u L=1u
Mo1_uU_L3_26_9 da_uU_L3_26_9 d1bar_L3 ts_uU_L3_26_9 0 NMIR W=20u L=1u
Mo2_uU_L3_26_9 gp_3_26_9 dpre_L3_26 ts_uU_L3_26_9 0 NMIR W=20u L=1u
Mo3_uU_L3_26_9 da_uU_L3_26_9 da_uU_L3_26_9 vdd vdd PMIR W=60u L=1u
Mo4_uU_L3_26_9 gp_3_26_9 da_uU_L3_26_9 vdd vdd PMIR W=60u L=1u
Mt_uU_L3_26_10 ts_uU_L3_26_10 hv_L2_28 0 0 NMIR W=48.0u L=1u
Mo1_uU_L3_26_10 da_uU_L3_26_10 d1bar_L3 ts_uU_L3_26_10 0 NMIR W=20u L=1u
Mo2_uU_L3_26_10 gp_3_26_10 dpre_L3_26 ts_uU_L3_26_10 0 NMIR W=20u L=1u
Mo3_uU_L3_26_10 da_uU_L3_26_10 da_uU_L3_26_10 vdd vdd PMIR W=60u L=1u
Mo4_uU_L3_26_10 gp_3_26_10 da_uU_L3_26_10 vdd vdd PMIR W=60u L=1u
Mt_uU_L3_26_11 ts_uU_L3_26_11 hv_L2_32 0 0 NMIR W=48.0u L=1u
Mo1_uU_L3_26_11 da_uU_L3_26_11 d1bar_L3 ts_uU_L3_26_11 0 NMIR W=20u L=1u
Mo2_uU_L3_26_11 gp_3_26_11 dpre_L3_26 ts_uU_L3_26_11 0 NMIR W=20u L=1u
Mo3_uU_L3_26_11 da_uU_L3_26_11 da_uU_L3_26_11 vdd vdd PMIR W=60u L=1u
Mo4_uU_L3_26_11 gp_3_26_11 da_uU_L3_26_11 vdd vdd PMIR W=60u L=1u
Mt_uU_L3_26_12 ts_uU_L3_26_12 hv_L2_35 0 0 NMIR W=48.0u L=1u
Mo1_uU_L3_26_12 da_uU_L3_26_12 d1bar_L3 ts_uU_L3_26_12 0 NMIR W=20u L=1u
Mo2_uU_L3_26_12 gp_3_26_12 dpre_L3_26 ts_uU_L3_26_12 0 NMIR W=20u L=1u
Mo3_uU_L3_26_12 da_uU_L3_26_12 da_uU_L3_26_12 vdd vdd PMIR W=60u L=1u
Mo4_uU_L3_26_12 gp_3_26_12 da_uU_L3_26_12 vdd vdd PMIR W=60u L=1u
Mt_uU_L3_26_13 ts_uU_L3_26_13 hv_L2_37 0 0 NMIR W=48.0u L=1u
Mo1_uU_L3_26_13 da_uU_L3_26_13 d1bar_L3 ts_uU_L3_26_13 0 NMIR W=20u L=1u
Mo2_uU_L3_26_13 gp_3_26_13 dpre_L3_26 ts_uU_L3_26_13 0 NMIR W=20u L=1u
Mo3_uU_L3_26_13 da_uU_L3_26_13 da_uU_L3_26_13 vdd vdd PMIR W=60u L=1u
Mo4_uU_L3_26_13 gp_3_26_13 da_uU_L3_26_13 vdd vdd PMIR W=60u L=1u
Mt_uU_L3_26_14 ts_uU_L3_26_14 hv_L2_42 0 0 NMIR W=48.0u L=1u
Mo1_uU_L3_26_14 da_uU_L3_26_14 d1bar_L3 ts_uU_L3_26_14 0 NMIR W=20u L=1u
Mo2_uU_L3_26_14 gp_3_26_14 dpre_L3_26 ts_uU_L3_26_14 0 NMIR W=20u L=1u
Mo3_uU_L3_26_14 da_uU_L3_26_14 da_uU_L3_26_14 vdd vdd PMIR W=60u L=1u
Mo4_uU_L3_26_14 gp_3_26_14 da_uU_L3_26_14 vdd vdd PMIR W=60u L=1u
Mt_uU_L3_26_15 ts_uU_L3_26_15 hv_L2_43 0 0 NMIR W=48.0u L=1u
Mo1_uU_L3_26_15 da_uU_L3_26_15 d1bar_L3 ts_uU_L3_26_15 0 NMIR W=20u L=1u
Mo2_uU_L3_26_15 gp_3_26_15 dpre_L3_26 ts_uU_L3_26_15 0 NMIR W=20u L=1u
Mo3_uU_L3_26_15 da_uU_L3_26_15 da_uU_L3_26_15 vdd vdd PMIR W=60u L=1u
Mo4_uU_L3_26_15 gp_3_26_15 da_uU_L3_26_15 vdd vdd PMIR W=60u L=1u
Mt_uU_L3_27_0 ts_uU_L3_27_0 hv_L2_1 0 0 NMIR W=48.0u L=1u
Mo1_uU_L3_27_0 da_uU_L3_27_0 d1bar_L3 ts_uU_L3_27_0 0 NMIR W=20u L=1u
Mo2_uU_L3_27_0 gp_3_27_0 dpre_L3_27 ts_uU_L3_27_0 0 NMIR W=20u L=1u
Mo3_uU_L3_27_0 da_uU_L3_27_0 da_uU_L3_27_0 vdd vdd PMIR W=60u L=1u
Mo4_uU_L3_27_0 gp_3_27_0 da_uU_L3_27_0 vdd vdd PMIR W=60u L=1u
Mt_uU_L3_27_1 ts_uU_L3_27_1 hv_L2_2 0 0 NMIR W=48.0u L=1u
Mo1_uU_L3_27_1 da_uU_L3_27_1 d1bar_L3 ts_uU_L3_27_1 0 NMIR W=20u L=1u
Mo2_uU_L3_27_1 gp_3_27_1 dpre_L3_27 ts_uU_L3_27_1 0 NMIR W=20u L=1u
Mo3_uU_L3_27_1 da_uU_L3_27_1 da_uU_L3_27_1 vdd vdd PMIR W=60u L=1u
Mo4_uU_L3_27_1 gp_3_27_1 da_uU_L3_27_1 vdd vdd PMIR W=60u L=1u
Mt_uU_L3_27_2 ts_uU_L3_27_2 hv_L2_13 0 0 NMIR W=48.0u L=1u
Mo1_uU_L3_27_2 da_uU_L3_27_2 d1bar_L3 ts_uU_L3_27_2 0 NMIR W=20u L=1u
Mo2_uU_L3_27_2 gp_3_27_2 dpre_L3_27 ts_uU_L3_27_2 0 NMIR W=20u L=1u
Mo3_uU_L3_27_2 da_uU_L3_27_2 da_uU_L3_27_2 vdd vdd PMIR W=60u L=1u
Mo4_uU_L3_27_2 gp_3_27_2 da_uU_L3_27_2 vdd vdd PMIR W=60u L=1u
Mt_uU_L3_27_3 ts_uU_L3_27_3 hv_L2_14 0 0 NMIR W=48.0u L=1u
Mo1_uU_L3_27_3 da_uU_L3_27_3 d1bar_L3 ts_uU_L3_27_3 0 NMIR W=20u L=1u
Mo2_uU_L3_27_3 gp_3_27_3 dpre_L3_27 ts_uU_L3_27_3 0 NMIR W=20u L=1u
Mo3_uU_L3_27_3 da_uU_L3_27_3 da_uU_L3_27_3 vdd vdd PMIR W=60u L=1u
Mo4_uU_L3_27_3 gp_3_27_3 da_uU_L3_27_3 vdd vdd PMIR W=60u L=1u
Mt_uU_L3_27_4 ts_uU_L3_27_4 hv_L2_16 0 0 NMIR W=48.0u L=1u
Mo1_uU_L3_27_4 da_uU_L3_27_4 d1bar_L3 ts_uU_L3_27_4 0 NMIR W=20u L=1u
Mo2_uU_L3_27_4 gp_3_27_4 dpre_L3_27 ts_uU_L3_27_4 0 NMIR W=20u L=1u
Mo3_uU_L3_27_4 da_uU_L3_27_4 da_uU_L3_27_4 vdd vdd PMIR W=60u L=1u
Mo4_uU_L3_27_4 gp_3_27_4 da_uU_L3_27_4 vdd vdd PMIR W=60u L=1u
Mt_uU_L3_27_5 ts_uU_L3_27_5 hv_L2_22 0 0 NMIR W=48.0u L=1u
Mo1_uU_L3_27_5 da_uU_L3_27_5 d1bar_L3 ts_uU_L3_27_5 0 NMIR W=20u L=1u
Mo2_uU_L3_27_5 gp_3_27_5 dpre_L3_27 ts_uU_L3_27_5 0 NMIR W=20u L=1u
Mo3_uU_L3_27_5 da_uU_L3_27_5 da_uU_L3_27_5 vdd vdd PMIR W=60u L=1u
Mo4_uU_L3_27_5 gp_3_27_5 da_uU_L3_27_5 vdd vdd PMIR W=60u L=1u
Mt_uU_L3_27_6 ts_uU_L3_27_6 hv_L2_25 0 0 NMIR W=48.0u L=1u
Mo1_uU_L3_27_6 da_uU_L3_27_6 d1bar_L3 ts_uU_L3_27_6 0 NMIR W=20u L=1u
Mo2_uU_L3_27_6 gp_3_27_6 dpre_L3_27 ts_uU_L3_27_6 0 NMIR W=20u L=1u
Mo3_uU_L3_27_6 da_uU_L3_27_6 da_uU_L3_27_6 vdd vdd PMIR W=60u L=1u
Mo4_uU_L3_27_6 gp_3_27_6 da_uU_L3_27_6 vdd vdd PMIR W=60u L=1u
Mt_uU_L3_27_7 ts_uU_L3_27_7 hv_L2_26 0 0 NMIR W=48.0u L=1u
Mo1_uU_L3_27_7 da_uU_L3_27_7 d1bar_L3 ts_uU_L3_27_7 0 NMIR W=20u L=1u
Mo2_uU_L3_27_7 gp_3_27_7 dpre_L3_27 ts_uU_L3_27_7 0 NMIR W=20u L=1u
Mo3_uU_L3_27_7 da_uU_L3_27_7 da_uU_L3_27_7 vdd vdd PMIR W=60u L=1u
Mo4_uU_L3_27_7 gp_3_27_7 da_uU_L3_27_7 vdd vdd PMIR W=60u L=1u
Mt_uU_L3_27_8 ts_uU_L3_27_8 hv_L2_28 0 0 NMIR W=48.0u L=1u
Mo1_uU_L3_27_8 da_uU_L3_27_8 d1bar_L3 ts_uU_L3_27_8 0 NMIR W=20u L=1u
Mo2_uU_L3_27_8 gp_3_27_8 dpre_L3_27 ts_uU_L3_27_8 0 NMIR W=20u L=1u
Mo3_uU_L3_27_8 da_uU_L3_27_8 da_uU_L3_27_8 vdd vdd PMIR W=60u L=1u
Mo4_uU_L3_27_8 gp_3_27_8 da_uU_L3_27_8 vdd vdd PMIR W=60u L=1u
Mt_uU_L3_27_9 ts_uU_L3_27_9 hv_L2_30 0 0 NMIR W=48.0u L=1u
Mo1_uU_L3_27_9 da_uU_L3_27_9 d1bar_L3 ts_uU_L3_27_9 0 NMIR W=20u L=1u
Mo2_uU_L3_27_9 gp_3_27_9 dpre_L3_27 ts_uU_L3_27_9 0 NMIR W=20u L=1u
Mo3_uU_L3_27_9 da_uU_L3_27_9 da_uU_L3_27_9 vdd vdd PMIR W=60u L=1u
Mo4_uU_L3_27_9 gp_3_27_9 da_uU_L3_27_9 vdd vdd PMIR W=60u L=1u
Mt_uU_L3_27_10 ts_uU_L3_27_10 hv_L2_31 0 0 NMIR W=48.0u L=1u
Mo1_uU_L3_27_10 da_uU_L3_27_10 d1bar_L3 ts_uU_L3_27_10 0 NMIR W=20u L=1u
Mo2_uU_L3_27_10 gp_3_27_10 dpre_L3_27 ts_uU_L3_27_10 0 NMIR W=20u L=1u
Mo3_uU_L3_27_10 da_uU_L3_27_10 da_uU_L3_27_10 vdd vdd PMIR W=60u L=1u
Mo4_uU_L3_27_10 gp_3_27_10 da_uU_L3_27_10 vdd vdd PMIR W=60u L=1u
Mt_uU_L3_27_11 ts_uU_L3_27_11 hv_L2_32 0 0 NMIR W=48.0u L=1u
Mo1_uU_L3_27_11 da_uU_L3_27_11 d1bar_L3 ts_uU_L3_27_11 0 NMIR W=20u L=1u
Mo2_uU_L3_27_11 gp_3_27_11 dpre_L3_27 ts_uU_L3_27_11 0 NMIR W=20u L=1u
Mo3_uU_L3_27_11 da_uU_L3_27_11 da_uU_L3_27_11 vdd vdd PMIR W=60u L=1u
Mo4_uU_L3_27_11 gp_3_27_11 da_uU_L3_27_11 vdd vdd PMIR W=60u L=1u
Mt_uU_L3_27_12 ts_uU_L3_27_12 hv_L2_33 0 0 NMIR W=48.0u L=1u
Mo1_uU_L3_27_12 da_uU_L3_27_12 d1bar_L3 ts_uU_L3_27_12 0 NMIR W=20u L=1u
Mo2_uU_L3_27_12 gp_3_27_12 dpre_L3_27 ts_uU_L3_27_12 0 NMIR W=20u L=1u
Mo3_uU_L3_27_12 da_uU_L3_27_12 da_uU_L3_27_12 vdd vdd PMIR W=60u L=1u
Mo4_uU_L3_27_12 gp_3_27_12 da_uU_L3_27_12 vdd vdd PMIR W=60u L=1u
Mt_uU_L3_27_13 ts_uU_L3_27_13 hv_L2_34 0 0 NMIR W=48.0u L=1u
Mo1_uU_L3_27_13 da_uU_L3_27_13 d1bar_L3 ts_uU_L3_27_13 0 NMIR W=20u L=1u
Mo2_uU_L3_27_13 gp_3_27_13 dpre_L3_27 ts_uU_L3_27_13 0 NMIR W=20u L=1u
Mo3_uU_L3_27_13 da_uU_L3_27_13 da_uU_L3_27_13 vdd vdd PMIR W=60u L=1u
Mo4_uU_L3_27_13 gp_3_27_13 da_uU_L3_27_13 vdd vdd PMIR W=60u L=1u
Mt_uU_L3_27_14 ts_uU_L3_27_14 hv_L2_39 0 0 NMIR W=48.0u L=1u
Mo1_uU_L3_27_14 da_uU_L3_27_14 d1bar_L3 ts_uU_L3_27_14 0 NMIR W=20u L=1u
Mo2_uU_L3_27_14 gp_3_27_14 dpre_L3_27 ts_uU_L3_27_14 0 NMIR W=20u L=1u
Mo3_uU_L3_27_14 da_uU_L3_27_14 da_uU_L3_27_14 vdd vdd PMIR W=60u L=1u
Mo4_uU_L3_27_14 gp_3_27_14 da_uU_L3_27_14 vdd vdd PMIR W=60u L=1u
Mt_uU_L3_27_15 ts_uU_L3_27_15 hv_L2_45 0 0 NMIR W=48.0u L=1u
Mo1_uU_L3_27_15 da_uU_L3_27_15 d1bar_L3 ts_uU_L3_27_15 0 NMIR W=20u L=1u
Mo2_uU_L3_27_15 gp_3_27_15 dpre_L3_27 ts_uU_L3_27_15 0 NMIR W=20u L=1u
Mo3_uU_L3_27_15 da_uU_L3_27_15 da_uU_L3_27_15 vdd vdd PMIR W=60u L=1u
Mo4_uU_L3_27_15 gp_3_27_15 da_uU_L3_27_15 vdd vdd PMIR W=60u L=1u
Mt_uU_L3_28_0 ts_uU_L3_28_0 hv_L2_0 0 0 NMIR W=48.0u L=1u
Mo1_uU_L3_28_0 da_uU_L3_28_0 d1bar_L3 ts_uU_L3_28_0 0 NMIR W=20u L=1u
Mo2_uU_L3_28_0 gp_3_28_0 dpre_L3_28 ts_uU_L3_28_0 0 NMIR W=20u L=1u
Mo3_uU_L3_28_0 da_uU_L3_28_0 da_uU_L3_28_0 vdd vdd PMIR W=60u L=1u
Mo4_uU_L3_28_0 gp_3_28_0 da_uU_L3_28_0 vdd vdd PMIR W=60u L=1u
Mt_uU_L3_28_1 ts_uU_L3_28_1 hv_L2_1 0 0 NMIR W=48.0u L=1u
Mo1_uU_L3_28_1 da_uU_L3_28_1 d1bar_L3 ts_uU_L3_28_1 0 NMIR W=20u L=1u
Mo2_uU_L3_28_1 gp_3_28_1 dpre_L3_28 ts_uU_L3_28_1 0 NMIR W=20u L=1u
Mo3_uU_L3_28_1 da_uU_L3_28_1 da_uU_L3_28_1 vdd vdd PMIR W=60u L=1u
Mo4_uU_L3_28_1 gp_3_28_1 da_uU_L3_28_1 vdd vdd PMIR W=60u L=1u
Mt_uU_L3_28_2 ts_uU_L3_28_2 hv_L2_3 0 0 NMIR W=48.0u L=1u
Mo1_uU_L3_28_2 da_uU_L3_28_2 d1bar_L3 ts_uU_L3_28_2 0 NMIR W=20u L=1u
Mo2_uU_L3_28_2 gp_3_28_2 dpre_L3_28 ts_uU_L3_28_2 0 NMIR W=20u L=1u
Mo3_uU_L3_28_2 da_uU_L3_28_2 da_uU_L3_28_2 vdd vdd PMIR W=60u L=1u
Mo4_uU_L3_28_2 gp_3_28_2 da_uU_L3_28_2 vdd vdd PMIR W=60u L=1u
Mt_uU_L3_28_3 ts_uU_L3_28_3 hv_L2_5 0 0 NMIR W=48.0u L=1u
Mo1_uU_L3_28_3 da_uU_L3_28_3 d1bar_L3 ts_uU_L3_28_3 0 NMIR W=20u L=1u
Mo2_uU_L3_28_3 gp_3_28_3 dpre_L3_28 ts_uU_L3_28_3 0 NMIR W=20u L=1u
Mo3_uU_L3_28_3 da_uU_L3_28_3 da_uU_L3_28_3 vdd vdd PMIR W=60u L=1u
Mo4_uU_L3_28_3 gp_3_28_3 da_uU_L3_28_3 vdd vdd PMIR W=60u L=1u
Mt_uU_L3_28_4 ts_uU_L3_28_4 hv_L2_7 0 0 NMIR W=48.0u L=1u
Mo1_uU_L3_28_4 da_uU_L3_28_4 d1bar_L3 ts_uU_L3_28_4 0 NMIR W=20u L=1u
Mo2_uU_L3_28_4 gp_3_28_4 dpre_L3_28 ts_uU_L3_28_4 0 NMIR W=20u L=1u
Mo3_uU_L3_28_4 da_uU_L3_28_4 da_uU_L3_28_4 vdd vdd PMIR W=60u L=1u
Mo4_uU_L3_28_4 gp_3_28_4 da_uU_L3_28_4 vdd vdd PMIR W=60u L=1u
Mt_uU_L3_28_5 ts_uU_L3_28_5 hv_L2_10 0 0 NMIR W=48.0u L=1u
Mo1_uU_L3_28_5 da_uU_L3_28_5 d1bar_L3 ts_uU_L3_28_5 0 NMIR W=20u L=1u
Mo2_uU_L3_28_5 gp_3_28_5 dpre_L3_28 ts_uU_L3_28_5 0 NMIR W=20u L=1u
Mo3_uU_L3_28_5 da_uU_L3_28_5 da_uU_L3_28_5 vdd vdd PMIR W=60u L=1u
Mo4_uU_L3_28_5 gp_3_28_5 da_uU_L3_28_5 vdd vdd PMIR W=60u L=1u
Mt_uU_L3_28_6 ts_uU_L3_28_6 hv_L2_15 0 0 NMIR W=48.0u L=1u
Mo1_uU_L3_28_6 da_uU_L3_28_6 d1bar_L3 ts_uU_L3_28_6 0 NMIR W=20u L=1u
Mo2_uU_L3_28_6 gp_3_28_6 dpre_L3_28 ts_uU_L3_28_6 0 NMIR W=20u L=1u
Mo3_uU_L3_28_6 da_uU_L3_28_6 da_uU_L3_28_6 vdd vdd PMIR W=60u L=1u
Mo4_uU_L3_28_6 gp_3_28_6 da_uU_L3_28_6 vdd vdd PMIR W=60u L=1u
Mt_uU_L3_28_7 ts_uU_L3_28_7 hv_L2_19 0 0 NMIR W=48.0u L=1u
Mo1_uU_L3_28_7 da_uU_L3_28_7 d1bar_L3 ts_uU_L3_28_7 0 NMIR W=20u L=1u
Mo2_uU_L3_28_7 gp_3_28_7 dpre_L3_28 ts_uU_L3_28_7 0 NMIR W=20u L=1u
Mo3_uU_L3_28_7 da_uU_L3_28_7 da_uU_L3_28_7 vdd vdd PMIR W=60u L=1u
Mo4_uU_L3_28_7 gp_3_28_7 da_uU_L3_28_7 vdd vdd PMIR W=60u L=1u
Mt_uU_L3_28_8 ts_uU_L3_28_8 hv_L2_26 0 0 NMIR W=48.0u L=1u
Mo1_uU_L3_28_8 da_uU_L3_28_8 d1bar_L3 ts_uU_L3_28_8 0 NMIR W=20u L=1u
Mo2_uU_L3_28_8 gp_3_28_8 dpre_L3_28 ts_uU_L3_28_8 0 NMIR W=20u L=1u
Mo3_uU_L3_28_8 da_uU_L3_28_8 da_uU_L3_28_8 vdd vdd PMIR W=60u L=1u
Mo4_uU_L3_28_8 gp_3_28_8 da_uU_L3_28_8 vdd vdd PMIR W=60u L=1u
Mt_uU_L3_28_9 ts_uU_L3_28_9 hv_L2_31 0 0 NMIR W=48.0u L=1u
Mo1_uU_L3_28_9 da_uU_L3_28_9 d1bar_L3 ts_uU_L3_28_9 0 NMIR W=20u L=1u
Mo2_uU_L3_28_9 gp_3_28_9 dpre_L3_28 ts_uU_L3_28_9 0 NMIR W=20u L=1u
Mo3_uU_L3_28_9 da_uU_L3_28_9 da_uU_L3_28_9 vdd vdd PMIR W=60u L=1u
Mo4_uU_L3_28_9 gp_3_28_9 da_uU_L3_28_9 vdd vdd PMIR W=60u L=1u
Mt_uU_L3_28_10 ts_uU_L3_28_10 hv_L2_34 0 0 NMIR W=48.0u L=1u
Mo1_uU_L3_28_10 da_uU_L3_28_10 d1bar_L3 ts_uU_L3_28_10 0 NMIR W=20u L=1u
Mo2_uU_L3_28_10 gp_3_28_10 dpre_L3_28 ts_uU_L3_28_10 0 NMIR W=20u L=1u
Mo3_uU_L3_28_10 da_uU_L3_28_10 da_uU_L3_28_10 vdd vdd PMIR W=60u L=1u
Mo4_uU_L3_28_10 gp_3_28_10 da_uU_L3_28_10 vdd vdd PMIR W=60u L=1u
Mt_uU_L3_28_11 ts_uU_L3_28_11 hv_L2_35 0 0 NMIR W=48.0u L=1u
Mo1_uU_L3_28_11 da_uU_L3_28_11 d1bar_L3 ts_uU_L3_28_11 0 NMIR W=20u L=1u
Mo2_uU_L3_28_11 gp_3_28_11 dpre_L3_28 ts_uU_L3_28_11 0 NMIR W=20u L=1u
Mo3_uU_L3_28_11 da_uU_L3_28_11 da_uU_L3_28_11 vdd vdd PMIR W=60u L=1u
Mo4_uU_L3_28_11 gp_3_28_11 da_uU_L3_28_11 vdd vdd PMIR W=60u L=1u
Mt_uU_L3_28_12 ts_uU_L3_28_12 hv_L2_36 0 0 NMIR W=48.0u L=1u
Mo1_uU_L3_28_12 da_uU_L3_28_12 d1bar_L3 ts_uU_L3_28_12 0 NMIR W=20u L=1u
Mo2_uU_L3_28_12 gp_3_28_12 dpre_L3_28 ts_uU_L3_28_12 0 NMIR W=20u L=1u
Mo3_uU_L3_28_12 da_uU_L3_28_12 da_uU_L3_28_12 vdd vdd PMIR W=60u L=1u
Mo4_uU_L3_28_12 gp_3_28_12 da_uU_L3_28_12 vdd vdd PMIR W=60u L=1u
Mt_uU_L3_28_13 ts_uU_L3_28_13 hv_L2_37 0 0 NMIR W=48.0u L=1u
Mo1_uU_L3_28_13 da_uU_L3_28_13 d1bar_L3 ts_uU_L3_28_13 0 NMIR W=20u L=1u
Mo2_uU_L3_28_13 gp_3_28_13 dpre_L3_28 ts_uU_L3_28_13 0 NMIR W=20u L=1u
Mo3_uU_L3_28_13 da_uU_L3_28_13 da_uU_L3_28_13 vdd vdd PMIR W=60u L=1u
Mo4_uU_L3_28_13 gp_3_28_13 da_uU_L3_28_13 vdd vdd PMIR W=60u L=1u
Mt_uU_L3_28_14 ts_uU_L3_28_14 hv_L2_40 0 0 NMIR W=48.0u L=1u
Mo1_uU_L3_28_14 da_uU_L3_28_14 d1bar_L3 ts_uU_L3_28_14 0 NMIR W=20u L=1u
Mo2_uU_L3_28_14 gp_3_28_14 dpre_L3_28 ts_uU_L3_28_14 0 NMIR W=20u L=1u
Mo3_uU_L3_28_14 da_uU_L3_28_14 da_uU_L3_28_14 vdd vdd PMIR W=60u L=1u
Mo4_uU_L3_28_14 gp_3_28_14 da_uU_L3_28_14 vdd vdd PMIR W=60u L=1u
Mt_uU_L3_28_15 ts_uU_L3_28_15 hv_L2_45 0 0 NMIR W=48.0u L=1u
Mo1_uU_L3_28_15 da_uU_L3_28_15 d1bar_L3 ts_uU_L3_28_15 0 NMIR W=20u L=1u
Mo2_uU_L3_28_15 gp_3_28_15 dpre_L3_28 ts_uU_L3_28_15 0 NMIR W=20u L=1u
Mo3_uU_L3_28_15 da_uU_L3_28_15 da_uU_L3_28_15 vdd vdd PMIR W=60u L=1u
Mo4_uU_L3_28_15 gp_3_28_15 da_uU_L3_28_15 vdd vdd PMIR W=60u L=1u
Mt_uU_L3_29_0 ts_uU_L3_29_0 hv_L2_1 0 0 NMIR W=48.0u L=1u
Mo1_uU_L3_29_0 da_uU_L3_29_0 d1bar_L3 ts_uU_L3_29_0 0 NMIR W=20u L=1u
Mo2_uU_L3_29_0 gp_3_29_0 dpre_L3_29 ts_uU_L3_29_0 0 NMIR W=20u L=1u
Mo3_uU_L3_29_0 da_uU_L3_29_0 da_uU_L3_29_0 vdd vdd PMIR W=60u L=1u
Mo4_uU_L3_29_0 gp_3_29_0 da_uU_L3_29_0 vdd vdd PMIR W=60u L=1u
Mt_uU_L3_29_1 ts_uU_L3_29_1 hv_L2_4 0 0 NMIR W=48.0u L=1u
Mo1_uU_L3_29_1 da_uU_L3_29_1 d1bar_L3 ts_uU_L3_29_1 0 NMIR W=20u L=1u
Mo2_uU_L3_29_1 gp_3_29_1 dpre_L3_29 ts_uU_L3_29_1 0 NMIR W=20u L=1u
Mo3_uU_L3_29_1 da_uU_L3_29_1 da_uU_L3_29_1 vdd vdd PMIR W=60u L=1u
Mo4_uU_L3_29_1 gp_3_29_1 da_uU_L3_29_1 vdd vdd PMIR W=60u L=1u
Mt_uU_L3_29_2 ts_uU_L3_29_2 hv_L2_9 0 0 NMIR W=48.0u L=1u
Mo1_uU_L3_29_2 da_uU_L3_29_2 d1bar_L3 ts_uU_L3_29_2 0 NMIR W=20u L=1u
Mo2_uU_L3_29_2 gp_3_29_2 dpre_L3_29 ts_uU_L3_29_2 0 NMIR W=20u L=1u
Mo3_uU_L3_29_2 da_uU_L3_29_2 da_uU_L3_29_2 vdd vdd PMIR W=60u L=1u
Mo4_uU_L3_29_2 gp_3_29_2 da_uU_L3_29_2 vdd vdd PMIR W=60u L=1u
Mt_uU_L3_29_3 ts_uU_L3_29_3 hv_L2_11 0 0 NMIR W=48.0u L=1u
Mo1_uU_L3_29_3 da_uU_L3_29_3 d1bar_L3 ts_uU_L3_29_3 0 NMIR W=20u L=1u
Mo2_uU_L3_29_3 gp_3_29_3 dpre_L3_29 ts_uU_L3_29_3 0 NMIR W=20u L=1u
Mo3_uU_L3_29_3 da_uU_L3_29_3 da_uU_L3_29_3 vdd vdd PMIR W=60u L=1u
Mo4_uU_L3_29_3 gp_3_29_3 da_uU_L3_29_3 vdd vdd PMIR W=60u L=1u
Mt_uU_L3_29_4 ts_uU_L3_29_4 hv_L2_12 0 0 NMIR W=48.0u L=1u
Mo1_uU_L3_29_4 da_uU_L3_29_4 d1bar_L3 ts_uU_L3_29_4 0 NMIR W=20u L=1u
Mo2_uU_L3_29_4 gp_3_29_4 dpre_L3_29 ts_uU_L3_29_4 0 NMIR W=20u L=1u
Mo3_uU_L3_29_4 da_uU_L3_29_4 da_uU_L3_29_4 vdd vdd PMIR W=60u L=1u
Mo4_uU_L3_29_4 gp_3_29_4 da_uU_L3_29_4 vdd vdd PMIR W=60u L=1u
Mt_uU_L3_29_5 ts_uU_L3_29_5 hv_L2_16 0 0 NMIR W=48.0u L=1u
Mo1_uU_L3_29_5 da_uU_L3_29_5 d1bar_L3 ts_uU_L3_29_5 0 NMIR W=20u L=1u
Mo2_uU_L3_29_5 gp_3_29_5 dpre_L3_29 ts_uU_L3_29_5 0 NMIR W=20u L=1u
Mo3_uU_L3_29_5 da_uU_L3_29_5 da_uU_L3_29_5 vdd vdd PMIR W=60u L=1u
Mo4_uU_L3_29_5 gp_3_29_5 da_uU_L3_29_5 vdd vdd PMIR W=60u L=1u
Mt_uU_L3_29_6 ts_uU_L3_29_6 hv_L2_18 0 0 NMIR W=48.0u L=1u
Mo1_uU_L3_29_6 da_uU_L3_29_6 d1bar_L3 ts_uU_L3_29_6 0 NMIR W=20u L=1u
Mo2_uU_L3_29_6 gp_3_29_6 dpre_L3_29 ts_uU_L3_29_6 0 NMIR W=20u L=1u
Mo3_uU_L3_29_6 da_uU_L3_29_6 da_uU_L3_29_6 vdd vdd PMIR W=60u L=1u
Mo4_uU_L3_29_6 gp_3_29_6 da_uU_L3_29_6 vdd vdd PMIR W=60u L=1u
Mt_uU_L3_29_7 ts_uU_L3_29_7 hv_L2_20 0 0 NMIR W=48.0u L=1u
Mo1_uU_L3_29_7 da_uU_L3_29_7 d1bar_L3 ts_uU_L3_29_7 0 NMIR W=20u L=1u
Mo2_uU_L3_29_7 gp_3_29_7 dpre_L3_29 ts_uU_L3_29_7 0 NMIR W=20u L=1u
Mo3_uU_L3_29_7 da_uU_L3_29_7 da_uU_L3_29_7 vdd vdd PMIR W=60u L=1u
Mo4_uU_L3_29_7 gp_3_29_7 da_uU_L3_29_7 vdd vdd PMIR W=60u L=1u
Mt_uU_L3_29_8 ts_uU_L3_29_8 hv_L2_21 0 0 NMIR W=48.0u L=1u
Mo1_uU_L3_29_8 da_uU_L3_29_8 d1bar_L3 ts_uU_L3_29_8 0 NMIR W=20u L=1u
Mo2_uU_L3_29_8 gp_3_29_8 dpre_L3_29 ts_uU_L3_29_8 0 NMIR W=20u L=1u
Mo3_uU_L3_29_8 da_uU_L3_29_8 da_uU_L3_29_8 vdd vdd PMIR W=60u L=1u
Mo4_uU_L3_29_8 gp_3_29_8 da_uU_L3_29_8 vdd vdd PMIR W=60u L=1u
Mt_uU_L3_29_9 ts_uU_L3_29_9 hv_L2_23 0 0 NMIR W=48.0u L=1u
Mo1_uU_L3_29_9 da_uU_L3_29_9 d1bar_L3 ts_uU_L3_29_9 0 NMIR W=20u L=1u
Mo2_uU_L3_29_9 gp_3_29_9 dpre_L3_29 ts_uU_L3_29_9 0 NMIR W=20u L=1u
Mo3_uU_L3_29_9 da_uU_L3_29_9 da_uU_L3_29_9 vdd vdd PMIR W=60u L=1u
Mo4_uU_L3_29_9 gp_3_29_9 da_uU_L3_29_9 vdd vdd PMIR W=60u L=1u
Mt_uU_L3_29_10 ts_uU_L3_29_10 hv_L2_33 0 0 NMIR W=48.0u L=1u
Mo1_uU_L3_29_10 da_uU_L3_29_10 d1bar_L3 ts_uU_L3_29_10 0 NMIR W=20u L=1u
Mo2_uU_L3_29_10 gp_3_29_10 dpre_L3_29 ts_uU_L3_29_10 0 NMIR W=20u L=1u
Mo3_uU_L3_29_10 da_uU_L3_29_10 da_uU_L3_29_10 vdd vdd PMIR W=60u L=1u
Mo4_uU_L3_29_10 gp_3_29_10 da_uU_L3_29_10 vdd vdd PMIR W=60u L=1u
Mt_uU_L3_29_11 ts_uU_L3_29_11 hv_L2_36 0 0 NMIR W=48.0u L=1u
Mo1_uU_L3_29_11 da_uU_L3_29_11 d1bar_L3 ts_uU_L3_29_11 0 NMIR W=20u L=1u
Mo2_uU_L3_29_11 gp_3_29_11 dpre_L3_29 ts_uU_L3_29_11 0 NMIR W=20u L=1u
Mo3_uU_L3_29_11 da_uU_L3_29_11 da_uU_L3_29_11 vdd vdd PMIR W=60u L=1u
Mo4_uU_L3_29_11 gp_3_29_11 da_uU_L3_29_11 vdd vdd PMIR W=60u L=1u
Mt_uU_L3_29_12 ts_uU_L3_29_12 hv_L2_37 0 0 NMIR W=48.0u L=1u
Mo1_uU_L3_29_12 da_uU_L3_29_12 d1bar_L3 ts_uU_L3_29_12 0 NMIR W=20u L=1u
Mo2_uU_L3_29_12 gp_3_29_12 dpre_L3_29 ts_uU_L3_29_12 0 NMIR W=20u L=1u
Mo3_uU_L3_29_12 da_uU_L3_29_12 da_uU_L3_29_12 vdd vdd PMIR W=60u L=1u
Mo4_uU_L3_29_12 gp_3_29_12 da_uU_L3_29_12 vdd vdd PMIR W=60u L=1u
Mt_uU_L3_29_13 ts_uU_L3_29_13 hv_L2_39 0 0 NMIR W=48.0u L=1u
Mo1_uU_L3_29_13 da_uU_L3_29_13 d1bar_L3 ts_uU_L3_29_13 0 NMIR W=20u L=1u
Mo2_uU_L3_29_13 gp_3_29_13 dpre_L3_29 ts_uU_L3_29_13 0 NMIR W=20u L=1u
Mo3_uU_L3_29_13 da_uU_L3_29_13 da_uU_L3_29_13 vdd vdd PMIR W=60u L=1u
Mo4_uU_L3_29_13 gp_3_29_13 da_uU_L3_29_13 vdd vdd PMIR W=60u L=1u
Mt_uU_L3_29_14 ts_uU_L3_29_14 hv_L2_40 0 0 NMIR W=48.0u L=1u
Mo1_uU_L3_29_14 da_uU_L3_29_14 d1bar_L3 ts_uU_L3_29_14 0 NMIR W=20u L=1u
Mo2_uU_L3_29_14 gp_3_29_14 dpre_L3_29 ts_uU_L3_29_14 0 NMIR W=20u L=1u
Mo3_uU_L3_29_14 da_uU_L3_29_14 da_uU_L3_29_14 vdd vdd PMIR W=60u L=1u
Mo4_uU_L3_29_14 gp_3_29_14 da_uU_L3_29_14 vdd vdd PMIR W=60u L=1u
Mt_uU_L3_29_15 ts_uU_L3_29_15 hv_L2_41 0 0 NMIR W=48.0u L=1u
Mo1_uU_L3_29_15 da_uU_L3_29_15 d1bar_L3 ts_uU_L3_29_15 0 NMIR W=20u L=1u
Mo2_uU_L3_29_15 gp_3_29_15 dpre_L3_29 ts_uU_L3_29_15 0 NMIR W=20u L=1u
Mo3_uU_L3_29_15 da_uU_L3_29_15 da_uU_L3_29_15 vdd vdd PMIR W=60u L=1u
Mo4_uU_L3_29_15 gp_3_29_15 da_uU_L3_29_15 vdd vdd PMIR W=60u L=1u
Mt_uU_L3_30_0 ts_uU_L3_30_0 hv_L2_5 0 0 NMIR W=48.0u L=1u
Mo1_uU_L3_30_0 da_uU_L3_30_0 d1bar_L3 ts_uU_L3_30_0 0 NMIR W=20u L=1u
Mo2_uU_L3_30_0 gp_3_30_0 dpre_L3_30 ts_uU_L3_30_0 0 NMIR W=20u L=1u
Mo3_uU_L3_30_0 da_uU_L3_30_0 da_uU_L3_30_0 vdd vdd PMIR W=60u L=1u
Mo4_uU_L3_30_0 gp_3_30_0 da_uU_L3_30_0 vdd vdd PMIR W=60u L=1u
Mt_uU_L3_30_1 ts_uU_L3_30_1 hv_L2_8 0 0 NMIR W=48.0u L=1u
Mo1_uU_L3_30_1 da_uU_L3_30_1 d1bar_L3 ts_uU_L3_30_1 0 NMIR W=20u L=1u
Mo2_uU_L3_30_1 gp_3_30_1 dpre_L3_30 ts_uU_L3_30_1 0 NMIR W=20u L=1u
Mo3_uU_L3_30_1 da_uU_L3_30_1 da_uU_L3_30_1 vdd vdd PMIR W=60u L=1u
Mo4_uU_L3_30_1 gp_3_30_1 da_uU_L3_30_1 vdd vdd PMIR W=60u L=1u
Mt_uU_L3_30_2 ts_uU_L3_30_2 hv_L2_11 0 0 NMIR W=48.0u L=1u
Mo1_uU_L3_30_2 da_uU_L3_30_2 d1bar_L3 ts_uU_L3_30_2 0 NMIR W=20u L=1u
Mo2_uU_L3_30_2 gp_3_30_2 dpre_L3_30 ts_uU_L3_30_2 0 NMIR W=20u L=1u
Mo3_uU_L3_30_2 da_uU_L3_30_2 da_uU_L3_30_2 vdd vdd PMIR W=60u L=1u
Mo4_uU_L3_30_2 gp_3_30_2 da_uU_L3_30_2 vdd vdd PMIR W=60u L=1u
Mt_uU_L3_30_3 ts_uU_L3_30_3 hv_L2_13 0 0 NMIR W=48.0u L=1u
Mo1_uU_L3_30_3 da_uU_L3_30_3 d1bar_L3 ts_uU_L3_30_3 0 NMIR W=20u L=1u
Mo2_uU_L3_30_3 gp_3_30_3 dpre_L3_30 ts_uU_L3_30_3 0 NMIR W=20u L=1u
Mo3_uU_L3_30_3 da_uU_L3_30_3 da_uU_L3_30_3 vdd vdd PMIR W=60u L=1u
Mo4_uU_L3_30_3 gp_3_30_3 da_uU_L3_30_3 vdd vdd PMIR W=60u L=1u
Mt_uU_L3_30_4 ts_uU_L3_30_4 hv_L2_15 0 0 NMIR W=48.0u L=1u
Mo1_uU_L3_30_4 da_uU_L3_30_4 d1bar_L3 ts_uU_L3_30_4 0 NMIR W=20u L=1u
Mo2_uU_L3_30_4 gp_3_30_4 dpre_L3_30 ts_uU_L3_30_4 0 NMIR W=20u L=1u
Mo3_uU_L3_30_4 da_uU_L3_30_4 da_uU_L3_30_4 vdd vdd PMIR W=60u L=1u
Mo4_uU_L3_30_4 gp_3_30_4 da_uU_L3_30_4 vdd vdd PMIR W=60u L=1u
Mt_uU_L3_30_5 ts_uU_L3_30_5 hv_L2_17 0 0 NMIR W=48.0u L=1u
Mo1_uU_L3_30_5 da_uU_L3_30_5 d1bar_L3 ts_uU_L3_30_5 0 NMIR W=20u L=1u
Mo2_uU_L3_30_5 gp_3_30_5 dpre_L3_30 ts_uU_L3_30_5 0 NMIR W=20u L=1u
Mo3_uU_L3_30_5 da_uU_L3_30_5 da_uU_L3_30_5 vdd vdd PMIR W=60u L=1u
Mo4_uU_L3_30_5 gp_3_30_5 da_uU_L3_30_5 vdd vdd PMIR W=60u L=1u
Mt_uU_L3_30_6 ts_uU_L3_30_6 hv_L2_19 0 0 NMIR W=48.0u L=1u
Mo1_uU_L3_30_6 da_uU_L3_30_6 d1bar_L3 ts_uU_L3_30_6 0 NMIR W=20u L=1u
Mo2_uU_L3_30_6 gp_3_30_6 dpre_L3_30 ts_uU_L3_30_6 0 NMIR W=20u L=1u
Mo3_uU_L3_30_6 da_uU_L3_30_6 da_uU_L3_30_6 vdd vdd PMIR W=60u L=1u
Mo4_uU_L3_30_6 gp_3_30_6 da_uU_L3_30_6 vdd vdd PMIR W=60u L=1u
Mt_uU_L3_30_7 ts_uU_L3_30_7 hv_L2_20 0 0 NMIR W=48.0u L=1u
Mo1_uU_L3_30_7 da_uU_L3_30_7 d1bar_L3 ts_uU_L3_30_7 0 NMIR W=20u L=1u
Mo2_uU_L3_30_7 gp_3_30_7 dpre_L3_30 ts_uU_L3_30_7 0 NMIR W=20u L=1u
Mo3_uU_L3_30_7 da_uU_L3_30_7 da_uU_L3_30_7 vdd vdd PMIR W=60u L=1u
Mo4_uU_L3_30_7 gp_3_30_7 da_uU_L3_30_7 vdd vdd PMIR W=60u L=1u
Mt_uU_L3_30_8 ts_uU_L3_30_8 hv_L2_27 0 0 NMIR W=48.0u L=1u
Mo1_uU_L3_30_8 da_uU_L3_30_8 d1bar_L3 ts_uU_L3_30_8 0 NMIR W=20u L=1u
Mo2_uU_L3_30_8 gp_3_30_8 dpre_L3_30 ts_uU_L3_30_8 0 NMIR W=20u L=1u
Mo3_uU_L3_30_8 da_uU_L3_30_8 da_uU_L3_30_8 vdd vdd PMIR W=60u L=1u
Mo4_uU_L3_30_8 gp_3_30_8 da_uU_L3_30_8 vdd vdd PMIR W=60u L=1u
Mt_uU_L3_30_9 ts_uU_L3_30_9 hv_L2_29 0 0 NMIR W=48.0u L=1u
Mo1_uU_L3_30_9 da_uU_L3_30_9 d1bar_L3 ts_uU_L3_30_9 0 NMIR W=20u L=1u
Mo2_uU_L3_30_9 gp_3_30_9 dpre_L3_30 ts_uU_L3_30_9 0 NMIR W=20u L=1u
Mo3_uU_L3_30_9 da_uU_L3_30_9 da_uU_L3_30_9 vdd vdd PMIR W=60u L=1u
Mo4_uU_L3_30_9 gp_3_30_9 da_uU_L3_30_9 vdd vdd PMIR W=60u L=1u
Mt_uU_L3_30_10 ts_uU_L3_30_10 hv_L2_32 0 0 NMIR W=48.0u L=1u
Mo1_uU_L3_30_10 da_uU_L3_30_10 d1bar_L3 ts_uU_L3_30_10 0 NMIR W=20u L=1u
Mo2_uU_L3_30_10 gp_3_30_10 dpre_L3_30 ts_uU_L3_30_10 0 NMIR W=20u L=1u
Mo3_uU_L3_30_10 da_uU_L3_30_10 da_uU_L3_30_10 vdd vdd PMIR W=60u L=1u
Mo4_uU_L3_30_10 gp_3_30_10 da_uU_L3_30_10 vdd vdd PMIR W=60u L=1u
Mt_uU_L3_30_11 ts_uU_L3_30_11 hv_L2_34 0 0 NMIR W=48.0u L=1u
Mo1_uU_L3_30_11 da_uU_L3_30_11 d1bar_L3 ts_uU_L3_30_11 0 NMIR W=20u L=1u
Mo2_uU_L3_30_11 gp_3_30_11 dpre_L3_30 ts_uU_L3_30_11 0 NMIR W=20u L=1u
Mo3_uU_L3_30_11 da_uU_L3_30_11 da_uU_L3_30_11 vdd vdd PMIR W=60u L=1u
Mo4_uU_L3_30_11 gp_3_30_11 da_uU_L3_30_11 vdd vdd PMIR W=60u L=1u
Mt_uU_L3_30_12 ts_uU_L3_30_12 hv_L2_39 0 0 NMIR W=48.0u L=1u
Mo1_uU_L3_30_12 da_uU_L3_30_12 d1bar_L3 ts_uU_L3_30_12 0 NMIR W=20u L=1u
Mo2_uU_L3_30_12 gp_3_30_12 dpre_L3_30 ts_uU_L3_30_12 0 NMIR W=20u L=1u
Mo3_uU_L3_30_12 da_uU_L3_30_12 da_uU_L3_30_12 vdd vdd PMIR W=60u L=1u
Mo4_uU_L3_30_12 gp_3_30_12 da_uU_L3_30_12 vdd vdd PMIR W=60u L=1u
Mt_uU_L3_30_13 ts_uU_L3_30_13 hv_L2_42 0 0 NMIR W=48.0u L=1u
Mo1_uU_L3_30_13 da_uU_L3_30_13 d1bar_L3 ts_uU_L3_30_13 0 NMIR W=20u L=1u
Mo2_uU_L3_30_13 gp_3_30_13 dpre_L3_30 ts_uU_L3_30_13 0 NMIR W=20u L=1u
Mo3_uU_L3_30_13 da_uU_L3_30_13 da_uU_L3_30_13 vdd vdd PMIR W=60u L=1u
Mo4_uU_L3_30_13 gp_3_30_13 da_uU_L3_30_13 vdd vdd PMIR W=60u L=1u
Mt_uU_L3_30_14 ts_uU_L3_30_14 hv_L2_43 0 0 NMIR W=48.0u L=1u
Mo1_uU_L3_30_14 da_uU_L3_30_14 d1bar_L3 ts_uU_L3_30_14 0 NMIR W=20u L=1u
Mo2_uU_L3_30_14 gp_3_30_14 dpre_L3_30 ts_uU_L3_30_14 0 NMIR W=20u L=1u
Mo3_uU_L3_30_14 da_uU_L3_30_14 da_uU_L3_30_14 vdd vdd PMIR W=60u L=1u
Mo4_uU_L3_30_14 gp_3_30_14 da_uU_L3_30_14 vdd vdd PMIR W=60u L=1u
Mt_uU_L3_30_15 ts_uU_L3_30_15 hv_L2_47 0 0 NMIR W=48.0u L=1u
Mo1_uU_L3_30_15 da_uU_L3_30_15 d1bar_L3 ts_uU_L3_30_15 0 NMIR W=20u L=1u
Mo2_uU_L3_30_15 gp_3_30_15 dpre_L3_30 ts_uU_L3_30_15 0 NMIR W=20u L=1u
Mo3_uU_L3_30_15 da_uU_L3_30_15 da_uU_L3_30_15 vdd vdd PMIR W=60u L=1u
Mo4_uU_L3_30_15 gp_3_30_15 da_uU_L3_30_15 vdd vdd PMIR W=60u L=1u
Mt_uU_L3_31_0 ts_uU_L3_31_0 hv_L2_1 0 0 NMIR W=48.0u L=1u
Mo1_uU_L3_31_0 da_uU_L3_31_0 d1bar_L3 ts_uU_L3_31_0 0 NMIR W=20u L=1u
Mo2_uU_L3_31_0 gp_3_31_0 dpre_L3_31 ts_uU_L3_31_0 0 NMIR W=20u L=1u
Mo3_uU_L3_31_0 da_uU_L3_31_0 da_uU_L3_31_0 vdd vdd PMIR W=60u L=1u
Mo4_uU_L3_31_0 gp_3_31_0 da_uU_L3_31_0 vdd vdd PMIR W=60u L=1u
Mt_uU_L3_31_1 ts_uU_L3_31_1 hv_L2_5 0 0 NMIR W=48.0u L=1u
Mo1_uU_L3_31_1 da_uU_L3_31_1 d1bar_L3 ts_uU_L3_31_1 0 NMIR W=20u L=1u
Mo2_uU_L3_31_1 gp_3_31_1 dpre_L3_31 ts_uU_L3_31_1 0 NMIR W=20u L=1u
Mo3_uU_L3_31_1 da_uU_L3_31_1 da_uU_L3_31_1 vdd vdd PMIR W=60u L=1u
Mo4_uU_L3_31_1 gp_3_31_1 da_uU_L3_31_1 vdd vdd PMIR W=60u L=1u
Mt_uU_L3_31_2 ts_uU_L3_31_2 hv_L2_10 0 0 NMIR W=48.0u L=1u
Mo1_uU_L3_31_2 da_uU_L3_31_2 d1bar_L3 ts_uU_L3_31_2 0 NMIR W=20u L=1u
Mo2_uU_L3_31_2 gp_3_31_2 dpre_L3_31 ts_uU_L3_31_2 0 NMIR W=20u L=1u
Mo3_uU_L3_31_2 da_uU_L3_31_2 da_uU_L3_31_2 vdd vdd PMIR W=60u L=1u
Mo4_uU_L3_31_2 gp_3_31_2 da_uU_L3_31_2 vdd vdd PMIR W=60u L=1u
Mt_uU_L3_31_3 ts_uU_L3_31_3 hv_L2_13 0 0 NMIR W=48.0u L=1u
Mo1_uU_L3_31_3 da_uU_L3_31_3 d1bar_L3 ts_uU_L3_31_3 0 NMIR W=20u L=1u
Mo2_uU_L3_31_3 gp_3_31_3 dpre_L3_31 ts_uU_L3_31_3 0 NMIR W=20u L=1u
Mo3_uU_L3_31_3 da_uU_L3_31_3 da_uU_L3_31_3 vdd vdd PMIR W=60u L=1u
Mo4_uU_L3_31_3 gp_3_31_3 da_uU_L3_31_3 vdd vdd PMIR W=60u L=1u
Mt_uU_L3_31_4 ts_uU_L3_31_4 hv_L2_14 0 0 NMIR W=48.0u L=1u
Mo1_uU_L3_31_4 da_uU_L3_31_4 d1bar_L3 ts_uU_L3_31_4 0 NMIR W=20u L=1u
Mo2_uU_L3_31_4 gp_3_31_4 dpre_L3_31 ts_uU_L3_31_4 0 NMIR W=20u L=1u
Mo3_uU_L3_31_4 da_uU_L3_31_4 da_uU_L3_31_4 vdd vdd PMIR W=60u L=1u
Mo4_uU_L3_31_4 gp_3_31_4 da_uU_L3_31_4 vdd vdd PMIR W=60u L=1u
Mt_uU_L3_31_5 ts_uU_L3_31_5 hv_L2_15 0 0 NMIR W=48.0u L=1u
Mo1_uU_L3_31_5 da_uU_L3_31_5 d1bar_L3 ts_uU_L3_31_5 0 NMIR W=20u L=1u
Mo2_uU_L3_31_5 gp_3_31_5 dpre_L3_31 ts_uU_L3_31_5 0 NMIR W=20u L=1u
Mo3_uU_L3_31_5 da_uU_L3_31_5 da_uU_L3_31_5 vdd vdd PMIR W=60u L=1u
Mo4_uU_L3_31_5 gp_3_31_5 da_uU_L3_31_5 vdd vdd PMIR W=60u L=1u
Mt_uU_L3_31_6 ts_uU_L3_31_6 hv_L2_16 0 0 NMIR W=48.0u L=1u
Mo1_uU_L3_31_6 da_uU_L3_31_6 d1bar_L3 ts_uU_L3_31_6 0 NMIR W=20u L=1u
Mo2_uU_L3_31_6 gp_3_31_6 dpre_L3_31 ts_uU_L3_31_6 0 NMIR W=20u L=1u
Mo3_uU_L3_31_6 da_uU_L3_31_6 da_uU_L3_31_6 vdd vdd PMIR W=60u L=1u
Mo4_uU_L3_31_6 gp_3_31_6 da_uU_L3_31_6 vdd vdd PMIR W=60u L=1u
Mt_uU_L3_31_7 ts_uU_L3_31_7 hv_L2_24 0 0 NMIR W=48.0u L=1u
Mo1_uU_L3_31_7 da_uU_L3_31_7 d1bar_L3 ts_uU_L3_31_7 0 NMIR W=20u L=1u
Mo2_uU_L3_31_7 gp_3_31_7 dpre_L3_31 ts_uU_L3_31_7 0 NMIR W=20u L=1u
Mo3_uU_L3_31_7 da_uU_L3_31_7 da_uU_L3_31_7 vdd vdd PMIR W=60u L=1u
Mo4_uU_L3_31_7 gp_3_31_7 da_uU_L3_31_7 vdd vdd PMIR W=60u L=1u
Mt_uU_L3_31_8 ts_uU_L3_31_8 hv_L2_26 0 0 NMIR W=48.0u L=1u
Mo1_uU_L3_31_8 da_uU_L3_31_8 d1bar_L3 ts_uU_L3_31_8 0 NMIR W=20u L=1u
Mo2_uU_L3_31_8 gp_3_31_8 dpre_L3_31 ts_uU_L3_31_8 0 NMIR W=20u L=1u
Mo3_uU_L3_31_8 da_uU_L3_31_8 da_uU_L3_31_8 vdd vdd PMIR W=60u L=1u
Mo4_uU_L3_31_8 gp_3_31_8 da_uU_L3_31_8 vdd vdd PMIR W=60u L=1u
Mt_uU_L3_31_9 ts_uU_L3_31_9 hv_L2_33 0 0 NMIR W=48.0u L=1u
Mo1_uU_L3_31_9 da_uU_L3_31_9 d1bar_L3 ts_uU_L3_31_9 0 NMIR W=20u L=1u
Mo2_uU_L3_31_9 gp_3_31_9 dpre_L3_31 ts_uU_L3_31_9 0 NMIR W=20u L=1u
Mo3_uU_L3_31_9 da_uU_L3_31_9 da_uU_L3_31_9 vdd vdd PMIR W=60u L=1u
Mo4_uU_L3_31_9 gp_3_31_9 da_uU_L3_31_9 vdd vdd PMIR W=60u L=1u
Mt_uU_L3_31_10 ts_uU_L3_31_10 hv_L2_34 0 0 NMIR W=48.0u L=1u
Mo1_uU_L3_31_10 da_uU_L3_31_10 d1bar_L3 ts_uU_L3_31_10 0 NMIR W=20u L=1u
Mo2_uU_L3_31_10 gp_3_31_10 dpre_L3_31 ts_uU_L3_31_10 0 NMIR W=20u L=1u
Mo3_uU_L3_31_10 da_uU_L3_31_10 da_uU_L3_31_10 vdd vdd PMIR W=60u L=1u
Mo4_uU_L3_31_10 gp_3_31_10 da_uU_L3_31_10 vdd vdd PMIR W=60u L=1u
Mt_uU_L3_31_11 ts_uU_L3_31_11 hv_L2_35 0 0 NMIR W=48.0u L=1u
Mo1_uU_L3_31_11 da_uU_L3_31_11 d1bar_L3 ts_uU_L3_31_11 0 NMIR W=20u L=1u
Mo2_uU_L3_31_11 gp_3_31_11 dpre_L3_31 ts_uU_L3_31_11 0 NMIR W=20u L=1u
Mo3_uU_L3_31_11 da_uU_L3_31_11 da_uU_L3_31_11 vdd vdd PMIR W=60u L=1u
Mo4_uU_L3_31_11 gp_3_31_11 da_uU_L3_31_11 vdd vdd PMIR W=60u L=1u
Mt_uU_L3_31_12 ts_uU_L3_31_12 hv_L2_38 0 0 NMIR W=48.0u L=1u
Mo1_uU_L3_31_12 da_uU_L3_31_12 d1bar_L3 ts_uU_L3_31_12 0 NMIR W=20u L=1u
Mo2_uU_L3_31_12 gp_3_31_12 dpre_L3_31 ts_uU_L3_31_12 0 NMIR W=20u L=1u
Mo3_uU_L3_31_12 da_uU_L3_31_12 da_uU_L3_31_12 vdd vdd PMIR W=60u L=1u
Mo4_uU_L3_31_12 gp_3_31_12 da_uU_L3_31_12 vdd vdd PMIR W=60u L=1u
Mt_uU_L3_31_13 ts_uU_L3_31_13 hv_L2_42 0 0 NMIR W=48.0u L=1u
Mo1_uU_L3_31_13 da_uU_L3_31_13 d1bar_L3 ts_uU_L3_31_13 0 NMIR W=20u L=1u
Mo2_uU_L3_31_13 gp_3_31_13 dpre_L3_31 ts_uU_L3_31_13 0 NMIR W=20u L=1u
Mo3_uU_L3_31_13 da_uU_L3_31_13 da_uU_L3_31_13 vdd vdd PMIR W=60u L=1u
Mo4_uU_L3_31_13 gp_3_31_13 da_uU_L3_31_13 vdd vdd PMIR W=60u L=1u
Mt_uU_L3_31_14 ts_uU_L3_31_14 hv_L2_43 0 0 NMIR W=48.0u L=1u
Mo1_uU_L3_31_14 da_uU_L3_31_14 d1bar_L3 ts_uU_L3_31_14 0 NMIR W=20u L=1u
Mo2_uU_L3_31_14 gp_3_31_14 dpre_L3_31 ts_uU_L3_31_14 0 NMIR W=20u L=1u
Mo3_uU_L3_31_14 da_uU_L3_31_14 da_uU_L3_31_14 vdd vdd PMIR W=60u L=1u
Mo4_uU_L3_31_14 gp_3_31_14 da_uU_L3_31_14 vdd vdd PMIR W=60u L=1u
Mt_uU_L3_31_15 ts_uU_L3_31_15 hv_L2_45 0 0 NMIR W=48.0u L=1u
Mo1_uU_L3_31_15 da_uU_L3_31_15 d1bar_L3 ts_uU_L3_31_15 0 NMIR W=20u L=1u
Mo2_uU_L3_31_15 gp_3_31_15 dpre_L3_31 ts_uU_L3_31_15 0 NMIR W=20u L=1u
Mo3_uU_L3_31_15 da_uU_L3_31_15 da_uU_L3_31_15 vdd vdd PMIR W=60u L=1u
Mo4_uU_L3_31_15 gp_3_31_15 da_uU_L3_31_15 vdd vdd PMIR W=60u L=1u
Mt_uU_L3_32_0 ts_uU_L3_32_0 hv_L2_3 0 0 NMIR W=48.0u L=1u
Mo1_uU_L3_32_0 da_uU_L3_32_0 d1bar_L3 ts_uU_L3_32_0 0 NMIR W=20u L=1u
Mo2_uU_L3_32_0 gp_3_32_0 dpre_L3_32 ts_uU_L3_32_0 0 NMIR W=20u L=1u
Mo3_uU_L3_32_0 da_uU_L3_32_0 da_uU_L3_32_0 vdd vdd PMIR W=60u L=1u
Mo4_uU_L3_32_0 gp_3_32_0 da_uU_L3_32_0 vdd vdd PMIR W=60u L=1u
Mt_uU_L3_32_1 ts_uU_L3_32_1 hv_L2_5 0 0 NMIR W=48.0u L=1u
Mo1_uU_L3_32_1 da_uU_L3_32_1 d1bar_L3 ts_uU_L3_32_1 0 NMIR W=20u L=1u
Mo2_uU_L3_32_1 gp_3_32_1 dpre_L3_32 ts_uU_L3_32_1 0 NMIR W=20u L=1u
Mo3_uU_L3_32_1 da_uU_L3_32_1 da_uU_L3_32_1 vdd vdd PMIR W=60u L=1u
Mo4_uU_L3_32_1 gp_3_32_1 da_uU_L3_32_1 vdd vdd PMIR W=60u L=1u
Mt_uU_L3_32_2 ts_uU_L3_32_2 hv_L2_7 0 0 NMIR W=48.0u L=1u
Mo1_uU_L3_32_2 da_uU_L3_32_2 d1bar_L3 ts_uU_L3_32_2 0 NMIR W=20u L=1u
Mo2_uU_L3_32_2 gp_3_32_2 dpre_L3_32 ts_uU_L3_32_2 0 NMIR W=20u L=1u
Mo3_uU_L3_32_2 da_uU_L3_32_2 da_uU_L3_32_2 vdd vdd PMIR W=60u L=1u
Mo4_uU_L3_32_2 gp_3_32_2 da_uU_L3_32_2 vdd vdd PMIR W=60u L=1u
Mt_uU_L3_32_3 ts_uU_L3_32_3 hv_L2_8 0 0 NMIR W=48.0u L=1u
Mo1_uU_L3_32_3 da_uU_L3_32_3 d1bar_L3 ts_uU_L3_32_3 0 NMIR W=20u L=1u
Mo2_uU_L3_32_3 gp_3_32_3 dpre_L3_32 ts_uU_L3_32_3 0 NMIR W=20u L=1u
Mo3_uU_L3_32_3 da_uU_L3_32_3 da_uU_L3_32_3 vdd vdd PMIR W=60u L=1u
Mo4_uU_L3_32_3 gp_3_32_3 da_uU_L3_32_3 vdd vdd PMIR W=60u L=1u
Mt_uU_L3_32_4 ts_uU_L3_32_4 hv_L2_9 0 0 NMIR W=48.0u L=1u
Mo1_uU_L3_32_4 da_uU_L3_32_4 d1bar_L3 ts_uU_L3_32_4 0 NMIR W=20u L=1u
Mo2_uU_L3_32_4 gp_3_32_4 dpre_L3_32 ts_uU_L3_32_4 0 NMIR W=20u L=1u
Mo3_uU_L3_32_4 da_uU_L3_32_4 da_uU_L3_32_4 vdd vdd PMIR W=60u L=1u
Mo4_uU_L3_32_4 gp_3_32_4 da_uU_L3_32_4 vdd vdd PMIR W=60u L=1u
Mt_uU_L3_32_5 ts_uU_L3_32_5 hv_L2_13 0 0 NMIR W=48.0u L=1u
Mo1_uU_L3_32_5 da_uU_L3_32_5 d1bar_L3 ts_uU_L3_32_5 0 NMIR W=20u L=1u
Mo2_uU_L3_32_5 gp_3_32_5 dpre_L3_32 ts_uU_L3_32_5 0 NMIR W=20u L=1u
Mo3_uU_L3_32_5 da_uU_L3_32_5 da_uU_L3_32_5 vdd vdd PMIR W=60u L=1u
Mo4_uU_L3_32_5 gp_3_32_5 da_uU_L3_32_5 vdd vdd PMIR W=60u L=1u
Mt_uU_L3_32_6 ts_uU_L3_32_6 hv_L2_16 0 0 NMIR W=48.0u L=1u
Mo1_uU_L3_32_6 da_uU_L3_32_6 d1bar_L3 ts_uU_L3_32_6 0 NMIR W=20u L=1u
Mo2_uU_L3_32_6 gp_3_32_6 dpre_L3_32 ts_uU_L3_32_6 0 NMIR W=20u L=1u
Mo3_uU_L3_32_6 da_uU_L3_32_6 da_uU_L3_32_6 vdd vdd PMIR W=60u L=1u
Mo4_uU_L3_32_6 gp_3_32_6 da_uU_L3_32_6 vdd vdd PMIR W=60u L=1u
Mt_uU_L3_32_7 ts_uU_L3_32_7 hv_L2_19 0 0 NMIR W=48.0u L=1u
Mo1_uU_L3_32_7 da_uU_L3_32_7 d1bar_L3 ts_uU_L3_32_7 0 NMIR W=20u L=1u
Mo2_uU_L3_32_7 gp_3_32_7 dpre_L3_32 ts_uU_L3_32_7 0 NMIR W=20u L=1u
Mo3_uU_L3_32_7 da_uU_L3_32_7 da_uU_L3_32_7 vdd vdd PMIR W=60u L=1u
Mo4_uU_L3_32_7 gp_3_32_7 da_uU_L3_32_7 vdd vdd PMIR W=60u L=1u
Mt_uU_L3_32_8 ts_uU_L3_32_8 hv_L2_20 0 0 NMIR W=48.0u L=1u
Mo1_uU_L3_32_8 da_uU_L3_32_8 d1bar_L3 ts_uU_L3_32_8 0 NMIR W=20u L=1u
Mo2_uU_L3_32_8 gp_3_32_8 dpre_L3_32 ts_uU_L3_32_8 0 NMIR W=20u L=1u
Mo3_uU_L3_32_8 da_uU_L3_32_8 da_uU_L3_32_8 vdd vdd PMIR W=60u L=1u
Mo4_uU_L3_32_8 gp_3_32_8 da_uU_L3_32_8 vdd vdd PMIR W=60u L=1u
Mt_uU_L3_32_9 ts_uU_L3_32_9 hv_L2_24 0 0 NMIR W=48.0u L=1u
Mo1_uU_L3_32_9 da_uU_L3_32_9 d1bar_L3 ts_uU_L3_32_9 0 NMIR W=20u L=1u
Mo2_uU_L3_32_9 gp_3_32_9 dpre_L3_32 ts_uU_L3_32_9 0 NMIR W=20u L=1u
Mo3_uU_L3_32_9 da_uU_L3_32_9 da_uU_L3_32_9 vdd vdd PMIR W=60u L=1u
Mo4_uU_L3_32_9 gp_3_32_9 da_uU_L3_32_9 vdd vdd PMIR W=60u L=1u
Mt_uU_L3_32_10 ts_uU_L3_32_10 hv_L2_26 0 0 NMIR W=48.0u L=1u
Mo1_uU_L3_32_10 da_uU_L3_32_10 d1bar_L3 ts_uU_L3_32_10 0 NMIR W=20u L=1u
Mo2_uU_L3_32_10 gp_3_32_10 dpre_L3_32 ts_uU_L3_32_10 0 NMIR W=20u L=1u
Mo3_uU_L3_32_10 da_uU_L3_32_10 da_uU_L3_32_10 vdd vdd PMIR W=60u L=1u
Mo4_uU_L3_32_10 gp_3_32_10 da_uU_L3_32_10 vdd vdd PMIR W=60u L=1u
Mt_uU_L3_32_11 ts_uU_L3_32_11 hv_L2_27 0 0 NMIR W=48.0u L=1u
Mo1_uU_L3_32_11 da_uU_L3_32_11 d1bar_L3 ts_uU_L3_32_11 0 NMIR W=20u L=1u
Mo2_uU_L3_32_11 gp_3_32_11 dpre_L3_32 ts_uU_L3_32_11 0 NMIR W=20u L=1u
Mo3_uU_L3_32_11 da_uU_L3_32_11 da_uU_L3_32_11 vdd vdd PMIR W=60u L=1u
Mo4_uU_L3_32_11 gp_3_32_11 da_uU_L3_32_11 vdd vdd PMIR W=60u L=1u
Mt_uU_L3_32_12 ts_uU_L3_32_12 hv_L2_39 0 0 NMIR W=48.0u L=1u
Mo1_uU_L3_32_12 da_uU_L3_32_12 d1bar_L3 ts_uU_L3_32_12 0 NMIR W=20u L=1u
Mo2_uU_L3_32_12 gp_3_32_12 dpre_L3_32 ts_uU_L3_32_12 0 NMIR W=20u L=1u
Mo3_uU_L3_32_12 da_uU_L3_32_12 da_uU_L3_32_12 vdd vdd PMIR W=60u L=1u
Mo4_uU_L3_32_12 gp_3_32_12 da_uU_L3_32_12 vdd vdd PMIR W=60u L=1u
Mt_uU_L3_32_13 ts_uU_L3_32_13 hv_L2_42 0 0 NMIR W=48.0u L=1u
Mo1_uU_L3_32_13 da_uU_L3_32_13 d1bar_L3 ts_uU_L3_32_13 0 NMIR W=20u L=1u
Mo2_uU_L3_32_13 gp_3_32_13 dpre_L3_32 ts_uU_L3_32_13 0 NMIR W=20u L=1u
Mo3_uU_L3_32_13 da_uU_L3_32_13 da_uU_L3_32_13 vdd vdd PMIR W=60u L=1u
Mo4_uU_L3_32_13 gp_3_32_13 da_uU_L3_32_13 vdd vdd PMIR W=60u L=1u
Mt_uU_L3_32_14 ts_uU_L3_32_14 hv_L2_43 0 0 NMIR W=48.0u L=1u
Mo1_uU_L3_32_14 da_uU_L3_32_14 d1bar_L3 ts_uU_L3_32_14 0 NMIR W=20u L=1u
Mo2_uU_L3_32_14 gp_3_32_14 dpre_L3_32 ts_uU_L3_32_14 0 NMIR W=20u L=1u
Mo3_uU_L3_32_14 da_uU_L3_32_14 da_uU_L3_32_14 vdd vdd PMIR W=60u L=1u
Mo4_uU_L3_32_14 gp_3_32_14 da_uU_L3_32_14 vdd vdd PMIR W=60u L=1u
Mt_uU_L3_32_15 ts_uU_L3_32_15 hv_L2_44 0 0 NMIR W=48.0u L=1u
Mo1_uU_L3_32_15 da_uU_L3_32_15 d1bar_L3 ts_uU_L3_32_15 0 NMIR W=20u L=1u
Mo2_uU_L3_32_15 gp_3_32_15 dpre_L3_32 ts_uU_L3_32_15 0 NMIR W=20u L=1u
Mo3_uU_L3_32_15 da_uU_L3_32_15 da_uU_L3_32_15 vdd vdd PMIR W=60u L=1u
Mo4_uU_L3_32_15 gp_3_32_15 da_uU_L3_32_15 vdd vdd PMIR W=60u L=1u
Mt_uU_L3_33_0 ts_uU_L3_33_0 hv_L2_0 0 0 NMIR W=48.0u L=1u
Mo1_uU_L3_33_0 da_uU_L3_33_0 d1bar_L3 ts_uU_L3_33_0 0 NMIR W=20u L=1u
Mo2_uU_L3_33_0 gp_3_33_0 dpre_L3_33 ts_uU_L3_33_0 0 NMIR W=20u L=1u
Mo3_uU_L3_33_0 da_uU_L3_33_0 da_uU_L3_33_0 vdd vdd PMIR W=60u L=1u
Mo4_uU_L3_33_0 gp_3_33_0 da_uU_L3_33_0 vdd vdd PMIR W=60u L=1u
Mt_uU_L3_33_1 ts_uU_L3_33_1 hv_L2_2 0 0 NMIR W=48.0u L=1u
Mo1_uU_L3_33_1 da_uU_L3_33_1 d1bar_L3 ts_uU_L3_33_1 0 NMIR W=20u L=1u
Mo2_uU_L3_33_1 gp_3_33_1 dpre_L3_33 ts_uU_L3_33_1 0 NMIR W=20u L=1u
Mo3_uU_L3_33_1 da_uU_L3_33_1 da_uU_L3_33_1 vdd vdd PMIR W=60u L=1u
Mo4_uU_L3_33_1 gp_3_33_1 da_uU_L3_33_1 vdd vdd PMIR W=60u L=1u
Mt_uU_L3_33_2 ts_uU_L3_33_2 hv_L2_5 0 0 NMIR W=48.0u L=1u
Mo1_uU_L3_33_2 da_uU_L3_33_2 d1bar_L3 ts_uU_L3_33_2 0 NMIR W=20u L=1u
Mo2_uU_L3_33_2 gp_3_33_2 dpre_L3_33 ts_uU_L3_33_2 0 NMIR W=20u L=1u
Mo3_uU_L3_33_2 da_uU_L3_33_2 da_uU_L3_33_2 vdd vdd PMIR W=60u L=1u
Mo4_uU_L3_33_2 gp_3_33_2 da_uU_L3_33_2 vdd vdd PMIR W=60u L=1u
Mt_uU_L3_33_3 ts_uU_L3_33_3 hv_L2_10 0 0 NMIR W=48.0u L=1u
Mo1_uU_L3_33_3 da_uU_L3_33_3 d1bar_L3 ts_uU_L3_33_3 0 NMIR W=20u L=1u
Mo2_uU_L3_33_3 gp_3_33_3 dpre_L3_33 ts_uU_L3_33_3 0 NMIR W=20u L=1u
Mo3_uU_L3_33_3 da_uU_L3_33_3 da_uU_L3_33_3 vdd vdd PMIR W=60u L=1u
Mo4_uU_L3_33_3 gp_3_33_3 da_uU_L3_33_3 vdd vdd PMIR W=60u L=1u
Mt_uU_L3_33_4 ts_uU_L3_33_4 hv_L2_11 0 0 NMIR W=48.0u L=1u
Mo1_uU_L3_33_4 da_uU_L3_33_4 d1bar_L3 ts_uU_L3_33_4 0 NMIR W=20u L=1u
Mo2_uU_L3_33_4 gp_3_33_4 dpre_L3_33 ts_uU_L3_33_4 0 NMIR W=20u L=1u
Mo3_uU_L3_33_4 da_uU_L3_33_4 da_uU_L3_33_4 vdd vdd PMIR W=60u L=1u
Mo4_uU_L3_33_4 gp_3_33_4 da_uU_L3_33_4 vdd vdd PMIR W=60u L=1u
Mt_uU_L3_33_5 ts_uU_L3_33_5 hv_L2_14 0 0 NMIR W=48.0u L=1u
Mo1_uU_L3_33_5 da_uU_L3_33_5 d1bar_L3 ts_uU_L3_33_5 0 NMIR W=20u L=1u
Mo2_uU_L3_33_5 gp_3_33_5 dpre_L3_33 ts_uU_L3_33_5 0 NMIR W=20u L=1u
Mo3_uU_L3_33_5 da_uU_L3_33_5 da_uU_L3_33_5 vdd vdd PMIR W=60u L=1u
Mo4_uU_L3_33_5 gp_3_33_5 da_uU_L3_33_5 vdd vdd PMIR W=60u L=1u
Mt_uU_L3_33_6 ts_uU_L3_33_6 hv_L2_17 0 0 NMIR W=48.0u L=1u
Mo1_uU_L3_33_6 da_uU_L3_33_6 d1bar_L3 ts_uU_L3_33_6 0 NMIR W=20u L=1u
Mo2_uU_L3_33_6 gp_3_33_6 dpre_L3_33 ts_uU_L3_33_6 0 NMIR W=20u L=1u
Mo3_uU_L3_33_6 da_uU_L3_33_6 da_uU_L3_33_6 vdd vdd PMIR W=60u L=1u
Mo4_uU_L3_33_6 gp_3_33_6 da_uU_L3_33_6 vdd vdd PMIR W=60u L=1u
Mt_uU_L3_33_7 ts_uU_L3_33_7 hv_L2_18 0 0 NMIR W=48.0u L=1u
Mo1_uU_L3_33_7 da_uU_L3_33_7 d1bar_L3 ts_uU_L3_33_7 0 NMIR W=20u L=1u
Mo2_uU_L3_33_7 gp_3_33_7 dpre_L3_33 ts_uU_L3_33_7 0 NMIR W=20u L=1u
Mo3_uU_L3_33_7 da_uU_L3_33_7 da_uU_L3_33_7 vdd vdd PMIR W=60u L=1u
Mo4_uU_L3_33_7 gp_3_33_7 da_uU_L3_33_7 vdd vdd PMIR W=60u L=1u
Mt_uU_L3_33_8 ts_uU_L3_33_8 hv_L2_22 0 0 NMIR W=48.0u L=1u
Mo1_uU_L3_33_8 da_uU_L3_33_8 d1bar_L3 ts_uU_L3_33_8 0 NMIR W=20u L=1u
Mo2_uU_L3_33_8 gp_3_33_8 dpre_L3_33 ts_uU_L3_33_8 0 NMIR W=20u L=1u
Mo3_uU_L3_33_8 da_uU_L3_33_8 da_uU_L3_33_8 vdd vdd PMIR W=60u L=1u
Mo4_uU_L3_33_8 gp_3_33_8 da_uU_L3_33_8 vdd vdd PMIR W=60u L=1u
Mt_uU_L3_33_9 ts_uU_L3_33_9 hv_L2_25 0 0 NMIR W=48.0u L=1u
Mo1_uU_L3_33_9 da_uU_L3_33_9 d1bar_L3 ts_uU_L3_33_9 0 NMIR W=20u L=1u
Mo2_uU_L3_33_9 gp_3_33_9 dpre_L3_33 ts_uU_L3_33_9 0 NMIR W=20u L=1u
Mo3_uU_L3_33_9 da_uU_L3_33_9 da_uU_L3_33_9 vdd vdd PMIR W=60u L=1u
Mo4_uU_L3_33_9 gp_3_33_9 da_uU_L3_33_9 vdd vdd PMIR W=60u L=1u
Mt_uU_L3_33_10 ts_uU_L3_33_10 hv_L2_26 0 0 NMIR W=48.0u L=1u
Mo1_uU_L3_33_10 da_uU_L3_33_10 d1bar_L3 ts_uU_L3_33_10 0 NMIR W=20u L=1u
Mo2_uU_L3_33_10 gp_3_33_10 dpre_L3_33 ts_uU_L3_33_10 0 NMIR W=20u L=1u
Mo3_uU_L3_33_10 da_uU_L3_33_10 da_uU_L3_33_10 vdd vdd PMIR W=60u L=1u
Mo4_uU_L3_33_10 gp_3_33_10 da_uU_L3_33_10 vdd vdd PMIR W=60u L=1u
Mt_uU_L3_33_11 ts_uU_L3_33_11 hv_L2_29 0 0 NMIR W=48.0u L=1u
Mo1_uU_L3_33_11 da_uU_L3_33_11 d1bar_L3 ts_uU_L3_33_11 0 NMIR W=20u L=1u
Mo2_uU_L3_33_11 gp_3_33_11 dpre_L3_33 ts_uU_L3_33_11 0 NMIR W=20u L=1u
Mo3_uU_L3_33_11 da_uU_L3_33_11 da_uU_L3_33_11 vdd vdd PMIR W=60u L=1u
Mo4_uU_L3_33_11 gp_3_33_11 da_uU_L3_33_11 vdd vdd PMIR W=60u L=1u
Mt_uU_L3_33_12 ts_uU_L3_33_12 hv_L2_30 0 0 NMIR W=48.0u L=1u
Mo1_uU_L3_33_12 da_uU_L3_33_12 d1bar_L3 ts_uU_L3_33_12 0 NMIR W=20u L=1u
Mo2_uU_L3_33_12 gp_3_33_12 dpre_L3_33 ts_uU_L3_33_12 0 NMIR W=20u L=1u
Mo3_uU_L3_33_12 da_uU_L3_33_12 da_uU_L3_33_12 vdd vdd PMIR W=60u L=1u
Mo4_uU_L3_33_12 gp_3_33_12 da_uU_L3_33_12 vdd vdd PMIR W=60u L=1u
Mt_uU_L3_33_13 ts_uU_L3_33_13 hv_L2_44 0 0 NMIR W=48.0u L=1u
Mo1_uU_L3_33_13 da_uU_L3_33_13 d1bar_L3 ts_uU_L3_33_13 0 NMIR W=20u L=1u
Mo2_uU_L3_33_13 gp_3_33_13 dpre_L3_33 ts_uU_L3_33_13 0 NMIR W=20u L=1u
Mo3_uU_L3_33_13 da_uU_L3_33_13 da_uU_L3_33_13 vdd vdd PMIR W=60u L=1u
Mo4_uU_L3_33_13 gp_3_33_13 da_uU_L3_33_13 vdd vdd PMIR W=60u L=1u
Mt_uU_L3_33_14 ts_uU_L3_33_14 hv_L2_46 0 0 NMIR W=48.0u L=1u
Mo1_uU_L3_33_14 da_uU_L3_33_14 d1bar_L3 ts_uU_L3_33_14 0 NMIR W=20u L=1u
Mo2_uU_L3_33_14 gp_3_33_14 dpre_L3_33 ts_uU_L3_33_14 0 NMIR W=20u L=1u
Mo3_uU_L3_33_14 da_uU_L3_33_14 da_uU_L3_33_14 vdd vdd PMIR W=60u L=1u
Mo4_uU_L3_33_14 gp_3_33_14 da_uU_L3_33_14 vdd vdd PMIR W=60u L=1u
Mt_uU_L3_33_15 ts_uU_L3_33_15 hv_L2_47 0 0 NMIR W=48.0u L=1u
Mo1_uU_L3_33_15 da_uU_L3_33_15 d1bar_L3 ts_uU_L3_33_15 0 NMIR W=20u L=1u
Mo2_uU_L3_33_15 gp_3_33_15 dpre_L3_33 ts_uU_L3_33_15 0 NMIR W=20u L=1u
Mo3_uU_L3_33_15 da_uU_L3_33_15 da_uU_L3_33_15 vdd vdd PMIR W=60u L=1u
Mo4_uU_L3_33_15 gp_3_33_15 da_uU_L3_33_15 vdd vdd PMIR W=60u L=1u
Mt_uU_L3_34_0 ts_uU_L3_34_0 hv_L2_6 0 0 NMIR W=48.0u L=1u
Mo1_uU_L3_34_0 da_uU_L3_34_0 d1bar_L3 ts_uU_L3_34_0 0 NMIR W=20u L=1u
Mo2_uU_L3_34_0 gp_3_34_0 dpre_L3_34 ts_uU_L3_34_0 0 NMIR W=20u L=1u
Mo3_uU_L3_34_0 da_uU_L3_34_0 da_uU_L3_34_0 vdd vdd PMIR W=60u L=1u
Mo4_uU_L3_34_0 gp_3_34_0 da_uU_L3_34_0 vdd vdd PMIR W=60u L=1u
Mt_uU_L3_34_1 ts_uU_L3_34_1 hv_L2_7 0 0 NMIR W=48.0u L=1u
Mo1_uU_L3_34_1 da_uU_L3_34_1 d1bar_L3 ts_uU_L3_34_1 0 NMIR W=20u L=1u
Mo2_uU_L3_34_1 gp_3_34_1 dpre_L3_34 ts_uU_L3_34_1 0 NMIR W=20u L=1u
Mo3_uU_L3_34_1 da_uU_L3_34_1 da_uU_L3_34_1 vdd vdd PMIR W=60u L=1u
Mo4_uU_L3_34_1 gp_3_34_1 da_uU_L3_34_1 vdd vdd PMIR W=60u L=1u
Mt_uU_L3_34_2 ts_uU_L3_34_2 hv_L2_9 0 0 NMIR W=48.0u L=1u
Mo1_uU_L3_34_2 da_uU_L3_34_2 d1bar_L3 ts_uU_L3_34_2 0 NMIR W=20u L=1u
Mo2_uU_L3_34_2 gp_3_34_2 dpre_L3_34 ts_uU_L3_34_2 0 NMIR W=20u L=1u
Mo3_uU_L3_34_2 da_uU_L3_34_2 da_uU_L3_34_2 vdd vdd PMIR W=60u L=1u
Mo4_uU_L3_34_2 gp_3_34_2 da_uU_L3_34_2 vdd vdd PMIR W=60u L=1u
Mt_uU_L3_34_3 ts_uU_L3_34_3 hv_L2_12 0 0 NMIR W=48.0u L=1u
Mo1_uU_L3_34_3 da_uU_L3_34_3 d1bar_L3 ts_uU_L3_34_3 0 NMIR W=20u L=1u
Mo2_uU_L3_34_3 gp_3_34_3 dpre_L3_34 ts_uU_L3_34_3 0 NMIR W=20u L=1u
Mo3_uU_L3_34_3 da_uU_L3_34_3 da_uU_L3_34_3 vdd vdd PMIR W=60u L=1u
Mo4_uU_L3_34_3 gp_3_34_3 da_uU_L3_34_3 vdd vdd PMIR W=60u L=1u
Mt_uU_L3_34_4 ts_uU_L3_34_4 hv_L2_15 0 0 NMIR W=48.0u L=1u
Mo1_uU_L3_34_4 da_uU_L3_34_4 d1bar_L3 ts_uU_L3_34_4 0 NMIR W=20u L=1u
Mo2_uU_L3_34_4 gp_3_34_4 dpre_L3_34 ts_uU_L3_34_4 0 NMIR W=20u L=1u
Mo3_uU_L3_34_4 da_uU_L3_34_4 da_uU_L3_34_4 vdd vdd PMIR W=60u L=1u
Mo4_uU_L3_34_4 gp_3_34_4 da_uU_L3_34_4 vdd vdd PMIR W=60u L=1u
Mt_uU_L3_34_5 ts_uU_L3_34_5 hv_L2_16 0 0 NMIR W=48.0u L=1u
Mo1_uU_L3_34_5 da_uU_L3_34_5 d1bar_L3 ts_uU_L3_34_5 0 NMIR W=20u L=1u
Mo2_uU_L3_34_5 gp_3_34_5 dpre_L3_34 ts_uU_L3_34_5 0 NMIR W=20u L=1u
Mo3_uU_L3_34_5 da_uU_L3_34_5 da_uU_L3_34_5 vdd vdd PMIR W=60u L=1u
Mo4_uU_L3_34_5 gp_3_34_5 da_uU_L3_34_5 vdd vdd PMIR W=60u L=1u
Mt_uU_L3_34_6 ts_uU_L3_34_6 hv_L2_17 0 0 NMIR W=48.0u L=1u
Mo1_uU_L3_34_6 da_uU_L3_34_6 d1bar_L3 ts_uU_L3_34_6 0 NMIR W=20u L=1u
Mo2_uU_L3_34_6 gp_3_34_6 dpre_L3_34 ts_uU_L3_34_6 0 NMIR W=20u L=1u
Mo3_uU_L3_34_6 da_uU_L3_34_6 da_uU_L3_34_6 vdd vdd PMIR W=60u L=1u
Mo4_uU_L3_34_6 gp_3_34_6 da_uU_L3_34_6 vdd vdd PMIR W=60u L=1u
Mt_uU_L3_34_7 ts_uU_L3_34_7 hv_L2_22 0 0 NMIR W=48.0u L=1u
Mo1_uU_L3_34_7 da_uU_L3_34_7 d1bar_L3 ts_uU_L3_34_7 0 NMIR W=20u L=1u
Mo2_uU_L3_34_7 gp_3_34_7 dpre_L3_34 ts_uU_L3_34_7 0 NMIR W=20u L=1u
Mo3_uU_L3_34_7 da_uU_L3_34_7 da_uU_L3_34_7 vdd vdd PMIR W=60u L=1u
Mo4_uU_L3_34_7 gp_3_34_7 da_uU_L3_34_7 vdd vdd PMIR W=60u L=1u
Mt_uU_L3_34_8 ts_uU_L3_34_8 hv_L2_24 0 0 NMIR W=48.0u L=1u
Mo1_uU_L3_34_8 da_uU_L3_34_8 d1bar_L3 ts_uU_L3_34_8 0 NMIR W=20u L=1u
Mo2_uU_L3_34_8 gp_3_34_8 dpre_L3_34 ts_uU_L3_34_8 0 NMIR W=20u L=1u
Mo3_uU_L3_34_8 da_uU_L3_34_8 da_uU_L3_34_8 vdd vdd PMIR W=60u L=1u
Mo4_uU_L3_34_8 gp_3_34_8 da_uU_L3_34_8 vdd vdd PMIR W=60u L=1u
Mt_uU_L3_34_9 ts_uU_L3_34_9 hv_L2_25 0 0 NMIR W=48.0u L=1u
Mo1_uU_L3_34_9 da_uU_L3_34_9 d1bar_L3 ts_uU_L3_34_9 0 NMIR W=20u L=1u
Mo2_uU_L3_34_9 gp_3_34_9 dpre_L3_34 ts_uU_L3_34_9 0 NMIR W=20u L=1u
Mo3_uU_L3_34_9 da_uU_L3_34_9 da_uU_L3_34_9 vdd vdd PMIR W=60u L=1u
Mo4_uU_L3_34_9 gp_3_34_9 da_uU_L3_34_9 vdd vdd PMIR W=60u L=1u
Mt_uU_L3_34_10 ts_uU_L3_34_10 hv_L2_31 0 0 NMIR W=48.0u L=1u
Mo1_uU_L3_34_10 da_uU_L3_34_10 d1bar_L3 ts_uU_L3_34_10 0 NMIR W=20u L=1u
Mo2_uU_L3_34_10 gp_3_34_10 dpre_L3_34 ts_uU_L3_34_10 0 NMIR W=20u L=1u
Mo3_uU_L3_34_10 da_uU_L3_34_10 da_uU_L3_34_10 vdd vdd PMIR W=60u L=1u
Mo4_uU_L3_34_10 gp_3_34_10 da_uU_L3_34_10 vdd vdd PMIR W=60u L=1u
Mt_uU_L3_34_11 ts_uU_L3_34_11 hv_L2_32 0 0 NMIR W=48.0u L=1u
Mo1_uU_L3_34_11 da_uU_L3_34_11 d1bar_L3 ts_uU_L3_34_11 0 NMIR W=20u L=1u
Mo2_uU_L3_34_11 gp_3_34_11 dpre_L3_34 ts_uU_L3_34_11 0 NMIR W=20u L=1u
Mo3_uU_L3_34_11 da_uU_L3_34_11 da_uU_L3_34_11 vdd vdd PMIR W=60u L=1u
Mo4_uU_L3_34_11 gp_3_34_11 da_uU_L3_34_11 vdd vdd PMIR W=60u L=1u
Mt_uU_L3_34_12 ts_uU_L3_34_12 hv_L2_38 0 0 NMIR W=48.0u L=1u
Mo1_uU_L3_34_12 da_uU_L3_34_12 d1bar_L3 ts_uU_L3_34_12 0 NMIR W=20u L=1u
Mo2_uU_L3_34_12 gp_3_34_12 dpre_L3_34 ts_uU_L3_34_12 0 NMIR W=20u L=1u
Mo3_uU_L3_34_12 da_uU_L3_34_12 da_uU_L3_34_12 vdd vdd PMIR W=60u L=1u
Mo4_uU_L3_34_12 gp_3_34_12 da_uU_L3_34_12 vdd vdd PMIR W=60u L=1u
Mt_uU_L3_34_13 ts_uU_L3_34_13 hv_L2_41 0 0 NMIR W=48.0u L=1u
Mo1_uU_L3_34_13 da_uU_L3_34_13 d1bar_L3 ts_uU_L3_34_13 0 NMIR W=20u L=1u
Mo2_uU_L3_34_13 gp_3_34_13 dpre_L3_34 ts_uU_L3_34_13 0 NMIR W=20u L=1u
Mo3_uU_L3_34_13 da_uU_L3_34_13 da_uU_L3_34_13 vdd vdd PMIR W=60u L=1u
Mo4_uU_L3_34_13 gp_3_34_13 da_uU_L3_34_13 vdd vdd PMIR W=60u L=1u
Mt_uU_L3_34_14 ts_uU_L3_34_14 hv_L2_43 0 0 NMIR W=48.0u L=1u
Mo1_uU_L3_34_14 da_uU_L3_34_14 d1bar_L3 ts_uU_L3_34_14 0 NMIR W=20u L=1u
Mo2_uU_L3_34_14 gp_3_34_14 dpre_L3_34 ts_uU_L3_34_14 0 NMIR W=20u L=1u
Mo3_uU_L3_34_14 da_uU_L3_34_14 da_uU_L3_34_14 vdd vdd PMIR W=60u L=1u
Mo4_uU_L3_34_14 gp_3_34_14 da_uU_L3_34_14 vdd vdd PMIR W=60u L=1u
Mt_uU_L3_34_15 ts_uU_L3_34_15 hv_L2_46 0 0 NMIR W=48.0u L=1u
Mo1_uU_L3_34_15 da_uU_L3_34_15 d1bar_L3 ts_uU_L3_34_15 0 NMIR W=20u L=1u
Mo2_uU_L3_34_15 gp_3_34_15 dpre_L3_34 ts_uU_L3_34_15 0 NMIR W=20u L=1u
Mo3_uU_L3_34_15 da_uU_L3_34_15 da_uU_L3_34_15 vdd vdd PMIR W=60u L=1u
Mo4_uU_L3_34_15 gp_3_34_15 da_uU_L3_34_15 vdd vdd PMIR W=60u L=1u
Mt_uU_L3_35_0 ts_uU_L3_35_0 hv_L2_5 0 0 NMIR W=48.0u L=1u
Mo1_uU_L3_35_0 da_uU_L3_35_0 d1bar_L3 ts_uU_L3_35_0 0 NMIR W=20u L=1u
Mo2_uU_L3_35_0 gp_3_35_0 dpre_L3_35 ts_uU_L3_35_0 0 NMIR W=20u L=1u
Mo3_uU_L3_35_0 da_uU_L3_35_0 da_uU_L3_35_0 vdd vdd PMIR W=60u L=1u
Mo4_uU_L3_35_0 gp_3_35_0 da_uU_L3_35_0 vdd vdd PMIR W=60u L=1u
Mt_uU_L3_35_1 ts_uU_L3_35_1 hv_L2_14 0 0 NMIR W=48.0u L=1u
Mo1_uU_L3_35_1 da_uU_L3_35_1 d1bar_L3 ts_uU_L3_35_1 0 NMIR W=20u L=1u
Mo2_uU_L3_35_1 gp_3_35_1 dpre_L3_35 ts_uU_L3_35_1 0 NMIR W=20u L=1u
Mo3_uU_L3_35_1 da_uU_L3_35_1 da_uU_L3_35_1 vdd vdd PMIR W=60u L=1u
Mo4_uU_L3_35_1 gp_3_35_1 da_uU_L3_35_1 vdd vdd PMIR W=60u L=1u
Mt_uU_L3_35_2 ts_uU_L3_35_2 hv_L2_15 0 0 NMIR W=48.0u L=1u
Mo1_uU_L3_35_2 da_uU_L3_35_2 d1bar_L3 ts_uU_L3_35_2 0 NMIR W=20u L=1u
Mo2_uU_L3_35_2 gp_3_35_2 dpre_L3_35 ts_uU_L3_35_2 0 NMIR W=20u L=1u
Mo3_uU_L3_35_2 da_uU_L3_35_2 da_uU_L3_35_2 vdd vdd PMIR W=60u L=1u
Mo4_uU_L3_35_2 gp_3_35_2 da_uU_L3_35_2 vdd vdd PMIR W=60u L=1u
Mt_uU_L3_35_3 ts_uU_L3_35_3 hv_L2_16 0 0 NMIR W=48.0u L=1u
Mo1_uU_L3_35_3 da_uU_L3_35_3 d1bar_L3 ts_uU_L3_35_3 0 NMIR W=20u L=1u
Mo2_uU_L3_35_3 gp_3_35_3 dpre_L3_35 ts_uU_L3_35_3 0 NMIR W=20u L=1u
Mo3_uU_L3_35_3 da_uU_L3_35_3 da_uU_L3_35_3 vdd vdd PMIR W=60u L=1u
Mo4_uU_L3_35_3 gp_3_35_3 da_uU_L3_35_3 vdd vdd PMIR W=60u L=1u
Mt_uU_L3_35_4 ts_uU_L3_35_4 hv_L2_17 0 0 NMIR W=48.0u L=1u
Mo1_uU_L3_35_4 da_uU_L3_35_4 d1bar_L3 ts_uU_L3_35_4 0 NMIR W=20u L=1u
Mo2_uU_L3_35_4 gp_3_35_4 dpre_L3_35 ts_uU_L3_35_4 0 NMIR W=20u L=1u
Mo3_uU_L3_35_4 da_uU_L3_35_4 da_uU_L3_35_4 vdd vdd PMIR W=60u L=1u
Mo4_uU_L3_35_4 gp_3_35_4 da_uU_L3_35_4 vdd vdd PMIR W=60u L=1u
Mt_uU_L3_35_5 ts_uU_L3_35_5 hv_L2_21 0 0 NMIR W=48.0u L=1u
Mo1_uU_L3_35_5 da_uU_L3_35_5 d1bar_L3 ts_uU_L3_35_5 0 NMIR W=20u L=1u
Mo2_uU_L3_35_5 gp_3_35_5 dpre_L3_35 ts_uU_L3_35_5 0 NMIR W=20u L=1u
Mo3_uU_L3_35_5 da_uU_L3_35_5 da_uU_L3_35_5 vdd vdd PMIR W=60u L=1u
Mo4_uU_L3_35_5 gp_3_35_5 da_uU_L3_35_5 vdd vdd PMIR W=60u L=1u
Mt_uU_L3_35_6 ts_uU_L3_35_6 hv_L2_23 0 0 NMIR W=48.0u L=1u
Mo1_uU_L3_35_6 da_uU_L3_35_6 d1bar_L3 ts_uU_L3_35_6 0 NMIR W=20u L=1u
Mo2_uU_L3_35_6 gp_3_35_6 dpre_L3_35 ts_uU_L3_35_6 0 NMIR W=20u L=1u
Mo3_uU_L3_35_6 da_uU_L3_35_6 da_uU_L3_35_6 vdd vdd PMIR W=60u L=1u
Mo4_uU_L3_35_6 gp_3_35_6 da_uU_L3_35_6 vdd vdd PMIR W=60u L=1u
Mt_uU_L3_35_7 ts_uU_L3_35_7 hv_L2_32 0 0 NMIR W=48.0u L=1u
Mo1_uU_L3_35_7 da_uU_L3_35_7 d1bar_L3 ts_uU_L3_35_7 0 NMIR W=20u L=1u
Mo2_uU_L3_35_7 gp_3_35_7 dpre_L3_35 ts_uU_L3_35_7 0 NMIR W=20u L=1u
Mo3_uU_L3_35_7 da_uU_L3_35_7 da_uU_L3_35_7 vdd vdd PMIR W=60u L=1u
Mo4_uU_L3_35_7 gp_3_35_7 da_uU_L3_35_7 vdd vdd PMIR W=60u L=1u
Mt_uU_L3_35_8 ts_uU_L3_35_8 hv_L2_34 0 0 NMIR W=48.0u L=1u
Mo1_uU_L3_35_8 da_uU_L3_35_8 d1bar_L3 ts_uU_L3_35_8 0 NMIR W=20u L=1u
Mo2_uU_L3_35_8 gp_3_35_8 dpre_L3_35 ts_uU_L3_35_8 0 NMIR W=20u L=1u
Mo3_uU_L3_35_8 da_uU_L3_35_8 da_uU_L3_35_8 vdd vdd PMIR W=60u L=1u
Mo4_uU_L3_35_8 gp_3_35_8 da_uU_L3_35_8 vdd vdd PMIR W=60u L=1u
Mt_uU_L3_35_9 ts_uU_L3_35_9 hv_L2_35 0 0 NMIR W=48.0u L=1u
Mo1_uU_L3_35_9 da_uU_L3_35_9 d1bar_L3 ts_uU_L3_35_9 0 NMIR W=20u L=1u
Mo2_uU_L3_35_9 gp_3_35_9 dpre_L3_35 ts_uU_L3_35_9 0 NMIR W=20u L=1u
Mo3_uU_L3_35_9 da_uU_L3_35_9 da_uU_L3_35_9 vdd vdd PMIR W=60u L=1u
Mo4_uU_L3_35_9 gp_3_35_9 da_uU_L3_35_9 vdd vdd PMIR W=60u L=1u
Mt_uU_L3_35_10 ts_uU_L3_35_10 hv_L2_36 0 0 NMIR W=48.0u L=1u
Mo1_uU_L3_35_10 da_uU_L3_35_10 d1bar_L3 ts_uU_L3_35_10 0 NMIR W=20u L=1u
Mo2_uU_L3_35_10 gp_3_35_10 dpre_L3_35 ts_uU_L3_35_10 0 NMIR W=20u L=1u
Mo3_uU_L3_35_10 da_uU_L3_35_10 da_uU_L3_35_10 vdd vdd PMIR W=60u L=1u
Mo4_uU_L3_35_10 gp_3_35_10 da_uU_L3_35_10 vdd vdd PMIR W=60u L=1u
Mt_uU_L3_35_11 ts_uU_L3_35_11 hv_L2_38 0 0 NMIR W=48.0u L=1u
Mo1_uU_L3_35_11 da_uU_L3_35_11 d1bar_L3 ts_uU_L3_35_11 0 NMIR W=20u L=1u
Mo2_uU_L3_35_11 gp_3_35_11 dpre_L3_35 ts_uU_L3_35_11 0 NMIR W=20u L=1u
Mo3_uU_L3_35_11 da_uU_L3_35_11 da_uU_L3_35_11 vdd vdd PMIR W=60u L=1u
Mo4_uU_L3_35_11 gp_3_35_11 da_uU_L3_35_11 vdd vdd PMIR W=60u L=1u
Mt_uU_L3_35_12 ts_uU_L3_35_12 hv_L2_39 0 0 NMIR W=48.0u L=1u
Mo1_uU_L3_35_12 da_uU_L3_35_12 d1bar_L3 ts_uU_L3_35_12 0 NMIR W=20u L=1u
Mo2_uU_L3_35_12 gp_3_35_12 dpre_L3_35 ts_uU_L3_35_12 0 NMIR W=20u L=1u
Mo3_uU_L3_35_12 da_uU_L3_35_12 da_uU_L3_35_12 vdd vdd PMIR W=60u L=1u
Mo4_uU_L3_35_12 gp_3_35_12 da_uU_L3_35_12 vdd vdd PMIR W=60u L=1u
Mt_uU_L3_35_13 ts_uU_L3_35_13 hv_L2_40 0 0 NMIR W=48.0u L=1u
Mo1_uU_L3_35_13 da_uU_L3_35_13 d1bar_L3 ts_uU_L3_35_13 0 NMIR W=20u L=1u
Mo2_uU_L3_35_13 gp_3_35_13 dpre_L3_35 ts_uU_L3_35_13 0 NMIR W=20u L=1u
Mo3_uU_L3_35_13 da_uU_L3_35_13 da_uU_L3_35_13 vdd vdd PMIR W=60u L=1u
Mo4_uU_L3_35_13 gp_3_35_13 da_uU_L3_35_13 vdd vdd PMIR W=60u L=1u
Mt_uU_L3_35_14 ts_uU_L3_35_14 hv_L2_42 0 0 NMIR W=48.0u L=1u
Mo1_uU_L3_35_14 da_uU_L3_35_14 d1bar_L3 ts_uU_L3_35_14 0 NMIR W=20u L=1u
Mo2_uU_L3_35_14 gp_3_35_14 dpre_L3_35 ts_uU_L3_35_14 0 NMIR W=20u L=1u
Mo3_uU_L3_35_14 da_uU_L3_35_14 da_uU_L3_35_14 vdd vdd PMIR W=60u L=1u
Mo4_uU_L3_35_14 gp_3_35_14 da_uU_L3_35_14 vdd vdd PMIR W=60u L=1u
Mt_uU_L3_35_15 ts_uU_L3_35_15 hv_L2_46 0 0 NMIR W=48.0u L=1u
Mo1_uU_L3_35_15 da_uU_L3_35_15 d1bar_L3 ts_uU_L3_35_15 0 NMIR W=20u L=1u
Mo2_uU_L3_35_15 gp_3_35_15 dpre_L3_35 ts_uU_L3_35_15 0 NMIR W=20u L=1u
Mo3_uU_L3_35_15 da_uU_L3_35_15 da_uU_L3_35_15 vdd vdd PMIR W=60u L=1u
Mo4_uU_L3_35_15 gp_3_35_15 da_uU_L3_35_15 vdd vdd PMIR W=60u L=1u
Mt_uU_L3_36_0 ts_uU_L3_36_0 hv_L2_0 0 0 NMIR W=48.0u L=1u
Mo1_uU_L3_36_0 da_uU_L3_36_0 d1bar_L3 ts_uU_L3_36_0 0 NMIR W=20u L=1u
Mo2_uU_L3_36_0 gp_3_36_0 dpre_L3_36 ts_uU_L3_36_0 0 NMIR W=20u L=1u
Mo3_uU_L3_36_0 da_uU_L3_36_0 da_uU_L3_36_0 vdd vdd PMIR W=60u L=1u
Mo4_uU_L3_36_0 gp_3_36_0 da_uU_L3_36_0 vdd vdd PMIR W=60u L=1u
Mt_uU_L3_36_1 ts_uU_L3_36_1 hv_L2_2 0 0 NMIR W=48.0u L=1u
Mo1_uU_L3_36_1 da_uU_L3_36_1 d1bar_L3 ts_uU_L3_36_1 0 NMIR W=20u L=1u
Mo2_uU_L3_36_1 gp_3_36_1 dpre_L3_36 ts_uU_L3_36_1 0 NMIR W=20u L=1u
Mo3_uU_L3_36_1 da_uU_L3_36_1 da_uU_L3_36_1 vdd vdd PMIR W=60u L=1u
Mo4_uU_L3_36_1 gp_3_36_1 da_uU_L3_36_1 vdd vdd PMIR W=60u L=1u
Mt_uU_L3_36_2 ts_uU_L3_36_2 hv_L2_7 0 0 NMIR W=48.0u L=1u
Mo1_uU_L3_36_2 da_uU_L3_36_2 d1bar_L3 ts_uU_L3_36_2 0 NMIR W=20u L=1u
Mo2_uU_L3_36_2 gp_3_36_2 dpre_L3_36 ts_uU_L3_36_2 0 NMIR W=20u L=1u
Mo3_uU_L3_36_2 da_uU_L3_36_2 da_uU_L3_36_2 vdd vdd PMIR W=60u L=1u
Mo4_uU_L3_36_2 gp_3_36_2 da_uU_L3_36_2 vdd vdd PMIR W=60u L=1u
Mt_uU_L3_36_3 ts_uU_L3_36_3 hv_L2_9 0 0 NMIR W=48.0u L=1u
Mo1_uU_L3_36_3 da_uU_L3_36_3 d1bar_L3 ts_uU_L3_36_3 0 NMIR W=20u L=1u
Mo2_uU_L3_36_3 gp_3_36_3 dpre_L3_36 ts_uU_L3_36_3 0 NMIR W=20u L=1u
Mo3_uU_L3_36_3 da_uU_L3_36_3 da_uU_L3_36_3 vdd vdd PMIR W=60u L=1u
Mo4_uU_L3_36_3 gp_3_36_3 da_uU_L3_36_3 vdd vdd PMIR W=60u L=1u
Mt_uU_L3_36_4 ts_uU_L3_36_4 hv_L2_10 0 0 NMIR W=48.0u L=1u
Mo1_uU_L3_36_4 da_uU_L3_36_4 d1bar_L3 ts_uU_L3_36_4 0 NMIR W=20u L=1u
Mo2_uU_L3_36_4 gp_3_36_4 dpre_L3_36 ts_uU_L3_36_4 0 NMIR W=20u L=1u
Mo3_uU_L3_36_4 da_uU_L3_36_4 da_uU_L3_36_4 vdd vdd PMIR W=60u L=1u
Mo4_uU_L3_36_4 gp_3_36_4 da_uU_L3_36_4 vdd vdd PMIR W=60u L=1u
Mt_uU_L3_36_5 ts_uU_L3_36_5 hv_L2_19 0 0 NMIR W=48.0u L=1u
Mo1_uU_L3_36_5 da_uU_L3_36_5 d1bar_L3 ts_uU_L3_36_5 0 NMIR W=20u L=1u
Mo2_uU_L3_36_5 gp_3_36_5 dpre_L3_36 ts_uU_L3_36_5 0 NMIR W=20u L=1u
Mo3_uU_L3_36_5 da_uU_L3_36_5 da_uU_L3_36_5 vdd vdd PMIR W=60u L=1u
Mo4_uU_L3_36_5 gp_3_36_5 da_uU_L3_36_5 vdd vdd PMIR W=60u L=1u
Mt_uU_L3_36_6 ts_uU_L3_36_6 hv_L2_20 0 0 NMIR W=48.0u L=1u
Mo1_uU_L3_36_6 da_uU_L3_36_6 d1bar_L3 ts_uU_L3_36_6 0 NMIR W=20u L=1u
Mo2_uU_L3_36_6 gp_3_36_6 dpre_L3_36 ts_uU_L3_36_6 0 NMIR W=20u L=1u
Mo3_uU_L3_36_6 da_uU_L3_36_6 da_uU_L3_36_6 vdd vdd PMIR W=60u L=1u
Mo4_uU_L3_36_6 gp_3_36_6 da_uU_L3_36_6 vdd vdd PMIR W=60u L=1u
Mt_uU_L3_36_7 ts_uU_L3_36_7 hv_L2_24 0 0 NMIR W=48.0u L=1u
Mo1_uU_L3_36_7 da_uU_L3_36_7 d1bar_L3 ts_uU_L3_36_7 0 NMIR W=20u L=1u
Mo2_uU_L3_36_7 gp_3_36_7 dpre_L3_36 ts_uU_L3_36_7 0 NMIR W=20u L=1u
Mo3_uU_L3_36_7 da_uU_L3_36_7 da_uU_L3_36_7 vdd vdd PMIR W=60u L=1u
Mo4_uU_L3_36_7 gp_3_36_7 da_uU_L3_36_7 vdd vdd PMIR W=60u L=1u
Mt_uU_L3_36_8 ts_uU_L3_36_8 hv_L2_28 0 0 NMIR W=48.0u L=1u
Mo1_uU_L3_36_8 da_uU_L3_36_8 d1bar_L3 ts_uU_L3_36_8 0 NMIR W=20u L=1u
Mo2_uU_L3_36_8 gp_3_36_8 dpre_L3_36 ts_uU_L3_36_8 0 NMIR W=20u L=1u
Mo3_uU_L3_36_8 da_uU_L3_36_8 da_uU_L3_36_8 vdd vdd PMIR W=60u L=1u
Mo4_uU_L3_36_8 gp_3_36_8 da_uU_L3_36_8 vdd vdd PMIR W=60u L=1u
Mt_uU_L3_36_9 ts_uU_L3_36_9 hv_L2_31 0 0 NMIR W=48.0u L=1u
Mo1_uU_L3_36_9 da_uU_L3_36_9 d1bar_L3 ts_uU_L3_36_9 0 NMIR W=20u L=1u
Mo2_uU_L3_36_9 gp_3_36_9 dpre_L3_36 ts_uU_L3_36_9 0 NMIR W=20u L=1u
Mo3_uU_L3_36_9 da_uU_L3_36_9 da_uU_L3_36_9 vdd vdd PMIR W=60u L=1u
Mo4_uU_L3_36_9 gp_3_36_9 da_uU_L3_36_9 vdd vdd PMIR W=60u L=1u
Mt_uU_L3_36_10 ts_uU_L3_36_10 hv_L2_33 0 0 NMIR W=48.0u L=1u
Mo1_uU_L3_36_10 da_uU_L3_36_10 d1bar_L3 ts_uU_L3_36_10 0 NMIR W=20u L=1u
Mo2_uU_L3_36_10 gp_3_36_10 dpre_L3_36 ts_uU_L3_36_10 0 NMIR W=20u L=1u
Mo3_uU_L3_36_10 da_uU_L3_36_10 da_uU_L3_36_10 vdd vdd PMIR W=60u L=1u
Mo4_uU_L3_36_10 gp_3_36_10 da_uU_L3_36_10 vdd vdd PMIR W=60u L=1u
Mt_uU_L3_36_11 ts_uU_L3_36_11 hv_L2_37 0 0 NMIR W=48.0u L=1u
Mo1_uU_L3_36_11 da_uU_L3_36_11 d1bar_L3 ts_uU_L3_36_11 0 NMIR W=20u L=1u
Mo2_uU_L3_36_11 gp_3_36_11 dpre_L3_36 ts_uU_L3_36_11 0 NMIR W=20u L=1u
Mo3_uU_L3_36_11 da_uU_L3_36_11 da_uU_L3_36_11 vdd vdd PMIR W=60u L=1u
Mo4_uU_L3_36_11 gp_3_36_11 da_uU_L3_36_11 vdd vdd PMIR W=60u L=1u
Mt_uU_L3_36_12 ts_uU_L3_36_12 hv_L2_39 0 0 NMIR W=48.0u L=1u
Mo1_uU_L3_36_12 da_uU_L3_36_12 d1bar_L3 ts_uU_L3_36_12 0 NMIR W=20u L=1u
Mo2_uU_L3_36_12 gp_3_36_12 dpre_L3_36 ts_uU_L3_36_12 0 NMIR W=20u L=1u
Mo3_uU_L3_36_12 da_uU_L3_36_12 da_uU_L3_36_12 vdd vdd PMIR W=60u L=1u
Mo4_uU_L3_36_12 gp_3_36_12 da_uU_L3_36_12 vdd vdd PMIR W=60u L=1u
Mt_uU_L3_36_13 ts_uU_L3_36_13 hv_L2_44 0 0 NMIR W=48.0u L=1u
Mo1_uU_L3_36_13 da_uU_L3_36_13 d1bar_L3 ts_uU_L3_36_13 0 NMIR W=20u L=1u
Mo2_uU_L3_36_13 gp_3_36_13 dpre_L3_36 ts_uU_L3_36_13 0 NMIR W=20u L=1u
Mo3_uU_L3_36_13 da_uU_L3_36_13 da_uU_L3_36_13 vdd vdd PMIR W=60u L=1u
Mo4_uU_L3_36_13 gp_3_36_13 da_uU_L3_36_13 vdd vdd PMIR W=60u L=1u
Mt_uU_L3_36_14 ts_uU_L3_36_14 hv_L2_46 0 0 NMIR W=48.0u L=1u
Mo1_uU_L3_36_14 da_uU_L3_36_14 d1bar_L3 ts_uU_L3_36_14 0 NMIR W=20u L=1u
Mo2_uU_L3_36_14 gp_3_36_14 dpre_L3_36 ts_uU_L3_36_14 0 NMIR W=20u L=1u
Mo3_uU_L3_36_14 da_uU_L3_36_14 da_uU_L3_36_14 vdd vdd PMIR W=60u L=1u
Mo4_uU_L3_36_14 gp_3_36_14 da_uU_L3_36_14 vdd vdd PMIR W=60u L=1u
Mt_uU_L3_36_15 ts_uU_L3_36_15 hv_L2_47 0 0 NMIR W=48.0u L=1u
Mo1_uU_L3_36_15 da_uU_L3_36_15 d1bar_L3 ts_uU_L3_36_15 0 NMIR W=20u L=1u
Mo2_uU_L3_36_15 gp_3_36_15 dpre_L3_36 ts_uU_L3_36_15 0 NMIR W=20u L=1u
Mo3_uU_L3_36_15 da_uU_L3_36_15 da_uU_L3_36_15 vdd vdd PMIR W=60u L=1u
Mo4_uU_L3_36_15 gp_3_36_15 da_uU_L3_36_15 vdd vdd PMIR W=60u L=1u
Mt_uU_L3_37_0 ts_uU_L3_37_0 hv_L2_1 0 0 NMIR W=48.0u L=1u
Mo1_uU_L3_37_0 da_uU_L3_37_0 d1bar_L3 ts_uU_L3_37_0 0 NMIR W=20u L=1u
Mo2_uU_L3_37_0 gp_3_37_0 dpre_L3_37 ts_uU_L3_37_0 0 NMIR W=20u L=1u
Mo3_uU_L3_37_0 da_uU_L3_37_0 da_uU_L3_37_0 vdd vdd PMIR W=60u L=1u
Mo4_uU_L3_37_0 gp_3_37_0 da_uU_L3_37_0 vdd vdd PMIR W=60u L=1u
Mt_uU_L3_37_1 ts_uU_L3_37_1 hv_L2_4 0 0 NMIR W=48.0u L=1u
Mo1_uU_L3_37_1 da_uU_L3_37_1 d1bar_L3 ts_uU_L3_37_1 0 NMIR W=20u L=1u
Mo2_uU_L3_37_1 gp_3_37_1 dpre_L3_37 ts_uU_L3_37_1 0 NMIR W=20u L=1u
Mo3_uU_L3_37_1 da_uU_L3_37_1 da_uU_L3_37_1 vdd vdd PMIR W=60u L=1u
Mo4_uU_L3_37_1 gp_3_37_1 da_uU_L3_37_1 vdd vdd PMIR W=60u L=1u
Mt_uU_L3_37_2 ts_uU_L3_37_2 hv_L2_11 0 0 NMIR W=48.0u L=1u
Mo1_uU_L3_37_2 da_uU_L3_37_2 d1bar_L3 ts_uU_L3_37_2 0 NMIR W=20u L=1u
Mo2_uU_L3_37_2 gp_3_37_2 dpre_L3_37 ts_uU_L3_37_2 0 NMIR W=20u L=1u
Mo3_uU_L3_37_2 da_uU_L3_37_2 da_uU_L3_37_2 vdd vdd PMIR W=60u L=1u
Mo4_uU_L3_37_2 gp_3_37_2 da_uU_L3_37_2 vdd vdd PMIR W=60u L=1u
Mt_uU_L3_37_3 ts_uU_L3_37_3 hv_L2_12 0 0 NMIR W=48.0u L=1u
Mo1_uU_L3_37_3 da_uU_L3_37_3 d1bar_L3 ts_uU_L3_37_3 0 NMIR W=20u L=1u
Mo2_uU_L3_37_3 gp_3_37_3 dpre_L3_37 ts_uU_L3_37_3 0 NMIR W=20u L=1u
Mo3_uU_L3_37_3 da_uU_L3_37_3 da_uU_L3_37_3 vdd vdd PMIR W=60u L=1u
Mo4_uU_L3_37_3 gp_3_37_3 da_uU_L3_37_3 vdd vdd PMIR W=60u L=1u
Mt_uU_L3_37_4 ts_uU_L3_37_4 hv_L2_13 0 0 NMIR W=48.0u L=1u
Mo1_uU_L3_37_4 da_uU_L3_37_4 d1bar_L3 ts_uU_L3_37_4 0 NMIR W=20u L=1u
Mo2_uU_L3_37_4 gp_3_37_4 dpre_L3_37 ts_uU_L3_37_4 0 NMIR W=20u L=1u
Mo3_uU_L3_37_4 da_uU_L3_37_4 da_uU_L3_37_4 vdd vdd PMIR W=60u L=1u
Mo4_uU_L3_37_4 gp_3_37_4 da_uU_L3_37_4 vdd vdd PMIR W=60u L=1u
Mt_uU_L3_37_5 ts_uU_L3_37_5 hv_L2_17 0 0 NMIR W=48.0u L=1u
Mo1_uU_L3_37_5 da_uU_L3_37_5 d1bar_L3 ts_uU_L3_37_5 0 NMIR W=20u L=1u
Mo2_uU_L3_37_5 gp_3_37_5 dpre_L3_37 ts_uU_L3_37_5 0 NMIR W=20u L=1u
Mo3_uU_L3_37_5 da_uU_L3_37_5 da_uU_L3_37_5 vdd vdd PMIR W=60u L=1u
Mo4_uU_L3_37_5 gp_3_37_5 da_uU_L3_37_5 vdd vdd PMIR W=60u L=1u
Mt_uU_L3_37_6 ts_uU_L3_37_6 hv_L2_20 0 0 NMIR W=48.0u L=1u
Mo1_uU_L3_37_6 da_uU_L3_37_6 d1bar_L3 ts_uU_L3_37_6 0 NMIR W=20u L=1u
Mo2_uU_L3_37_6 gp_3_37_6 dpre_L3_37 ts_uU_L3_37_6 0 NMIR W=20u L=1u
Mo3_uU_L3_37_6 da_uU_L3_37_6 da_uU_L3_37_6 vdd vdd PMIR W=60u L=1u
Mo4_uU_L3_37_6 gp_3_37_6 da_uU_L3_37_6 vdd vdd PMIR W=60u L=1u
Mt_uU_L3_37_7 ts_uU_L3_37_7 hv_L2_22 0 0 NMIR W=48.0u L=1u
Mo1_uU_L3_37_7 da_uU_L3_37_7 d1bar_L3 ts_uU_L3_37_7 0 NMIR W=20u L=1u
Mo2_uU_L3_37_7 gp_3_37_7 dpre_L3_37 ts_uU_L3_37_7 0 NMIR W=20u L=1u
Mo3_uU_L3_37_7 da_uU_L3_37_7 da_uU_L3_37_7 vdd vdd PMIR W=60u L=1u
Mo4_uU_L3_37_7 gp_3_37_7 da_uU_L3_37_7 vdd vdd PMIR W=60u L=1u
Mt_uU_L3_37_8 ts_uU_L3_37_8 hv_L2_23 0 0 NMIR W=48.0u L=1u
Mo1_uU_L3_37_8 da_uU_L3_37_8 d1bar_L3 ts_uU_L3_37_8 0 NMIR W=20u L=1u
Mo2_uU_L3_37_8 gp_3_37_8 dpre_L3_37 ts_uU_L3_37_8 0 NMIR W=20u L=1u
Mo3_uU_L3_37_8 da_uU_L3_37_8 da_uU_L3_37_8 vdd vdd PMIR W=60u L=1u
Mo4_uU_L3_37_8 gp_3_37_8 da_uU_L3_37_8 vdd vdd PMIR W=60u L=1u
Mt_uU_L3_37_9 ts_uU_L3_37_9 hv_L2_24 0 0 NMIR W=48.0u L=1u
Mo1_uU_L3_37_9 da_uU_L3_37_9 d1bar_L3 ts_uU_L3_37_9 0 NMIR W=20u L=1u
Mo2_uU_L3_37_9 gp_3_37_9 dpre_L3_37 ts_uU_L3_37_9 0 NMIR W=20u L=1u
Mo3_uU_L3_37_9 da_uU_L3_37_9 da_uU_L3_37_9 vdd vdd PMIR W=60u L=1u
Mo4_uU_L3_37_9 gp_3_37_9 da_uU_L3_37_9 vdd vdd PMIR W=60u L=1u
Mt_uU_L3_37_10 ts_uU_L3_37_10 hv_L2_25 0 0 NMIR W=48.0u L=1u
Mo1_uU_L3_37_10 da_uU_L3_37_10 d1bar_L3 ts_uU_L3_37_10 0 NMIR W=20u L=1u
Mo2_uU_L3_37_10 gp_3_37_10 dpre_L3_37 ts_uU_L3_37_10 0 NMIR W=20u L=1u
Mo3_uU_L3_37_10 da_uU_L3_37_10 da_uU_L3_37_10 vdd vdd PMIR W=60u L=1u
Mo4_uU_L3_37_10 gp_3_37_10 da_uU_L3_37_10 vdd vdd PMIR W=60u L=1u
Mt_uU_L3_37_11 ts_uU_L3_37_11 hv_L2_38 0 0 NMIR W=48.0u L=1u
Mo1_uU_L3_37_11 da_uU_L3_37_11 d1bar_L3 ts_uU_L3_37_11 0 NMIR W=20u L=1u
Mo2_uU_L3_37_11 gp_3_37_11 dpre_L3_37 ts_uU_L3_37_11 0 NMIR W=20u L=1u
Mo3_uU_L3_37_11 da_uU_L3_37_11 da_uU_L3_37_11 vdd vdd PMIR W=60u L=1u
Mo4_uU_L3_37_11 gp_3_37_11 da_uU_L3_37_11 vdd vdd PMIR W=60u L=1u
Mt_uU_L3_37_12 ts_uU_L3_37_12 hv_L2_39 0 0 NMIR W=48.0u L=1u
Mo1_uU_L3_37_12 da_uU_L3_37_12 d1bar_L3 ts_uU_L3_37_12 0 NMIR W=20u L=1u
Mo2_uU_L3_37_12 gp_3_37_12 dpre_L3_37 ts_uU_L3_37_12 0 NMIR W=20u L=1u
Mo3_uU_L3_37_12 da_uU_L3_37_12 da_uU_L3_37_12 vdd vdd PMIR W=60u L=1u
Mo4_uU_L3_37_12 gp_3_37_12 da_uU_L3_37_12 vdd vdd PMIR W=60u L=1u
Mt_uU_L3_37_13 ts_uU_L3_37_13 hv_L2_43 0 0 NMIR W=48.0u L=1u
Mo1_uU_L3_37_13 da_uU_L3_37_13 d1bar_L3 ts_uU_L3_37_13 0 NMIR W=20u L=1u
Mo2_uU_L3_37_13 gp_3_37_13 dpre_L3_37 ts_uU_L3_37_13 0 NMIR W=20u L=1u
Mo3_uU_L3_37_13 da_uU_L3_37_13 da_uU_L3_37_13 vdd vdd PMIR W=60u L=1u
Mo4_uU_L3_37_13 gp_3_37_13 da_uU_L3_37_13 vdd vdd PMIR W=60u L=1u
Mt_uU_L3_37_14 ts_uU_L3_37_14 hv_L2_45 0 0 NMIR W=48.0u L=1u
Mo1_uU_L3_37_14 da_uU_L3_37_14 d1bar_L3 ts_uU_L3_37_14 0 NMIR W=20u L=1u
Mo2_uU_L3_37_14 gp_3_37_14 dpre_L3_37 ts_uU_L3_37_14 0 NMIR W=20u L=1u
Mo3_uU_L3_37_14 da_uU_L3_37_14 da_uU_L3_37_14 vdd vdd PMIR W=60u L=1u
Mo4_uU_L3_37_14 gp_3_37_14 da_uU_L3_37_14 vdd vdd PMIR W=60u L=1u
Mt_uU_L3_37_15 ts_uU_L3_37_15 hv_L2_46 0 0 NMIR W=48.0u L=1u
Mo1_uU_L3_37_15 da_uU_L3_37_15 d1bar_L3 ts_uU_L3_37_15 0 NMIR W=20u L=1u
Mo2_uU_L3_37_15 gp_3_37_15 dpre_L3_37 ts_uU_L3_37_15 0 NMIR W=20u L=1u
Mo3_uU_L3_37_15 da_uU_L3_37_15 da_uU_L3_37_15 vdd vdd PMIR W=60u L=1u
Mo4_uU_L3_37_15 gp_3_37_15 da_uU_L3_37_15 vdd vdd PMIR W=60u L=1u
Mt_uU_L3_38_0 ts_uU_L3_38_0 hv_L2_0 0 0 NMIR W=48.0u L=1u
Mo1_uU_L3_38_0 da_uU_L3_38_0 d1bar_L3 ts_uU_L3_38_0 0 NMIR W=20u L=1u
Mo2_uU_L3_38_0 gp_3_38_0 dpre_L3_38 ts_uU_L3_38_0 0 NMIR W=20u L=1u
Mo3_uU_L3_38_0 da_uU_L3_38_0 da_uU_L3_38_0 vdd vdd PMIR W=60u L=1u
Mo4_uU_L3_38_0 gp_3_38_0 da_uU_L3_38_0 vdd vdd PMIR W=60u L=1u
Mt_uU_L3_38_1 ts_uU_L3_38_1 hv_L2_1 0 0 NMIR W=48.0u L=1u
Mo1_uU_L3_38_1 da_uU_L3_38_1 d1bar_L3 ts_uU_L3_38_1 0 NMIR W=20u L=1u
Mo2_uU_L3_38_1 gp_3_38_1 dpre_L3_38 ts_uU_L3_38_1 0 NMIR W=20u L=1u
Mo3_uU_L3_38_1 da_uU_L3_38_1 da_uU_L3_38_1 vdd vdd PMIR W=60u L=1u
Mo4_uU_L3_38_1 gp_3_38_1 da_uU_L3_38_1 vdd vdd PMIR W=60u L=1u
Mt_uU_L3_38_2 ts_uU_L3_38_2 hv_L2_3 0 0 NMIR W=48.0u L=1u
Mo1_uU_L3_38_2 da_uU_L3_38_2 d1bar_L3 ts_uU_L3_38_2 0 NMIR W=20u L=1u
Mo2_uU_L3_38_2 gp_3_38_2 dpre_L3_38 ts_uU_L3_38_2 0 NMIR W=20u L=1u
Mo3_uU_L3_38_2 da_uU_L3_38_2 da_uU_L3_38_2 vdd vdd PMIR W=60u L=1u
Mo4_uU_L3_38_2 gp_3_38_2 da_uU_L3_38_2 vdd vdd PMIR W=60u L=1u
Mt_uU_L3_38_3 ts_uU_L3_38_3 hv_L2_4 0 0 NMIR W=48.0u L=1u
Mo1_uU_L3_38_3 da_uU_L3_38_3 d1bar_L3 ts_uU_L3_38_3 0 NMIR W=20u L=1u
Mo2_uU_L3_38_3 gp_3_38_3 dpre_L3_38 ts_uU_L3_38_3 0 NMIR W=20u L=1u
Mo3_uU_L3_38_3 da_uU_L3_38_3 da_uU_L3_38_3 vdd vdd PMIR W=60u L=1u
Mo4_uU_L3_38_3 gp_3_38_3 da_uU_L3_38_3 vdd vdd PMIR W=60u L=1u
Mt_uU_L3_38_4 ts_uU_L3_38_4 hv_L2_12 0 0 NMIR W=48.0u L=1u
Mo1_uU_L3_38_4 da_uU_L3_38_4 d1bar_L3 ts_uU_L3_38_4 0 NMIR W=20u L=1u
Mo2_uU_L3_38_4 gp_3_38_4 dpre_L3_38 ts_uU_L3_38_4 0 NMIR W=20u L=1u
Mo3_uU_L3_38_4 da_uU_L3_38_4 da_uU_L3_38_4 vdd vdd PMIR W=60u L=1u
Mo4_uU_L3_38_4 gp_3_38_4 da_uU_L3_38_4 vdd vdd PMIR W=60u L=1u
Mt_uU_L3_38_5 ts_uU_L3_38_5 hv_L2_15 0 0 NMIR W=48.0u L=1u
Mo1_uU_L3_38_5 da_uU_L3_38_5 d1bar_L3 ts_uU_L3_38_5 0 NMIR W=20u L=1u
Mo2_uU_L3_38_5 gp_3_38_5 dpre_L3_38 ts_uU_L3_38_5 0 NMIR W=20u L=1u
Mo3_uU_L3_38_5 da_uU_L3_38_5 da_uU_L3_38_5 vdd vdd PMIR W=60u L=1u
Mo4_uU_L3_38_5 gp_3_38_5 da_uU_L3_38_5 vdd vdd PMIR W=60u L=1u
Mt_uU_L3_38_6 ts_uU_L3_38_6 hv_L2_16 0 0 NMIR W=48.0u L=1u
Mo1_uU_L3_38_6 da_uU_L3_38_6 d1bar_L3 ts_uU_L3_38_6 0 NMIR W=20u L=1u
Mo2_uU_L3_38_6 gp_3_38_6 dpre_L3_38 ts_uU_L3_38_6 0 NMIR W=20u L=1u
Mo3_uU_L3_38_6 da_uU_L3_38_6 da_uU_L3_38_6 vdd vdd PMIR W=60u L=1u
Mo4_uU_L3_38_6 gp_3_38_6 da_uU_L3_38_6 vdd vdd PMIR W=60u L=1u
Mt_uU_L3_38_7 ts_uU_L3_38_7 hv_L2_21 0 0 NMIR W=48.0u L=1u
Mo1_uU_L3_38_7 da_uU_L3_38_7 d1bar_L3 ts_uU_L3_38_7 0 NMIR W=20u L=1u
Mo2_uU_L3_38_7 gp_3_38_7 dpre_L3_38 ts_uU_L3_38_7 0 NMIR W=20u L=1u
Mo3_uU_L3_38_7 da_uU_L3_38_7 da_uU_L3_38_7 vdd vdd PMIR W=60u L=1u
Mo4_uU_L3_38_7 gp_3_38_7 da_uU_L3_38_7 vdd vdd PMIR W=60u L=1u
Mt_uU_L3_38_8 ts_uU_L3_38_8 hv_L2_25 0 0 NMIR W=48.0u L=1u
Mo1_uU_L3_38_8 da_uU_L3_38_8 d1bar_L3 ts_uU_L3_38_8 0 NMIR W=20u L=1u
Mo2_uU_L3_38_8 gp_3_38_8 dpre_L3_38 ts_uU_L3_38_8 0 NMIR W=20u L=1u
Mo3_uU_L3_38_8 da_uU_L3_38_8 da_uU_L3_38_8 vdd vdd PMIR W=60u L=1u
Mo4_uU_L3_38_8 gp_3_38_8 da_uU_L3_38_8 vdd vdd PMIR W=60u L=1u
Mt_uU_L3_38_9 ts_uU_L3_38_9 hv_L2_33 0 0 NMIR W=48.0u L=1u
Mo1_uU_L3_38_9 da_uU_L3_38_9 d1bar_L3 ts_uU_L3_38_9 0 NMIR W=20u L=1u
Mo2_uU_L3_38_9 gp_3_38_9 dpre_L3_38 ts_uU_L3_38_9 0 NMIR W=20u L=1u
Mo3_uU_L3_38_9 da_uU_L3_38_9 da_uU_L3_38_9 vdd vdd PMIR W=60u L=1u
Mo4_uU_L3_38_9 gp_3_38_9 da_uU_L3_38_9 vdd vdd PMIR W=60u L=1u
Mt_uU_L3_38_10 ts_uU_L3_38_10 hv_L2_35 0 0 NMIR W=48.0u L=1u
Mo1_uU_L3_38_10 da_uU_L3_38_10 d1bar_L3 ts_uU_L3_38_10 0 NMIR W=20u L=1u
Mo2_uU_L3_38_10 gp_3_38_10 dpre_L3_38 ts_uU_L3_38_10 0 NMIR W=20u L=1u
Mo3_uU_L3_38_10 da_uU_L3_38_10 da_uU_L3_38_10 vdd vdd PMIR W=60u L=1u
Mo4_uU_L3_38_10 gp_3_38_10 da_uU_L3_38_10 vdd vdd PMIR W=60u L=1u
Mt_uU_L3_38_11 ts_uU_L3_38_11 hv_L2_40 0 0 NMIR W=48.0u L=1u
Mo1_uU_L3_38_11 da_uU_L3_38_11 d1bar_L3 ts_uU_L3_38_11 0 NMIR W=20u L=1u
Mo2_uU_L3_38_11 gp_3_38_11 dpre_L3_38 ts_uU_L3_38_11 0 NMIR W=20u L=1u
Mo3_uU_L3_38_11 da_uU_L3_38_11 da_uU_L3_38_11 vdd vdd PMIR W=60u L=1u
Mo4_uU_L3_38_11 gp_3_38_11 da_uU_L3_38_11 vdd vdd PMIR W=60u L=1u
Mt_uU_L3_38_12 ts_uU_L3_38_12 hv_L2_42 0 0 NMIR W=48.0u L=1u
Mo1_uU_L3_38_12 da_uU_L3_38_12 d1bar_L3 ts_uU_L3_38_12 0 NMIR W=20u L=1u
Mo2_uU_L3_38_12 gp_3_38_12 dpre_L3_38 ts_uU_L3_38_12 0 NMIR W=20u L=1u
Mo3_uU_L3_38_12 da_uU_L3_38_12 da_uU_L3_38_12 vdd vdd PMIR W=60u L=1u
Mo4_uU_L3_38_12 gp_3_38_12 da_uU_L3_38_12 vdd vdd PMIR W=60u L=1u
Mt_uU_L3_38_13 ts_uU_L3_38_13 hv_L2_43 0 0 NMIR W=48.0u L=1u
Mo1_uU_L3_38_13 da_uU_L3_38_13 d1bar_L3 ts_uU_L3_38_13 0 NMIR W=20u L=1u
Mo2_uU_L3_38_13 gp_3_38_13 dpre_L3_38 ts_uU_L3_38_13 0 NMIR W=20u L=1u
Mo3_uU_L3_38_13 da_uU_L3_38_13 da_uU_L3_38_13 vdd vdd PMIR W=60u L=1u
Mo4_uU_L3_38_13 gp_3_38_13 da_uU_L3_38_13 vdd vdd PMIR W=60u L=1u
Mt_uU_L3_38_14 ts_uU_L3_38_14 hv_L2_45 0 0 NMIR W=48.0u L=1u
Mo1_uU_L3_38_14 da_uU_L3_38_14 d1bar_L3 ts_uU_L3_38_14 0 NMIR W=20u L=1u
Mo2_uU_L3_38_14 gp_3_38_14 dpre_L3_38 ts_uU_L3_38_14 0 NMIR W=20u L=1u
Mo3_uU_L3_38_14 da_uU_L3_38_14 da_uU_L3_38_14 vdd vdd PMIR W=60u L=1u
Mo4_uU_L3_38_14 gp_3_38_14 da_uU_L3_38_14 vdd vdd PMIR W=60u L=1u
Mt_uU_L3_38_15 ts_uU_L3_38_15 hv_L2_46 0 0 NMIR W=48.0u L=1u
Mo1_uU_L3_38_15 da_uU_L3_38_15 d1bar_L3 ts_uU_L3_38_15 0 NMIR W=20u L=1u
Mo2_uU_L3_38_15 gp_3_38_15 dpre_L3_38 ts_uU_L3_38_15 0 NMIR W=20u L=1u
Mo3_uU_L3_38_15 da_uU_L3_38_15 da_uU_L3_38_15 vdd vdd PMIR W=60u L=1u
Mo4_uU_L3_38_15 gp_3_38_15 da_uU_L3_38_15 vdd vdd PMIR W=60u L=1u
Mt_uU_L3_39_0 ts_uU_L3_39_0 hv_L2_4 0 0 NMIR W=48.0u L=1u
Mo1_uU_L3_39_0 da_uU_L3_39_0 d1bar_L3 ts_uU_L3_39_0 0 NMIR W=20u L=1u
Mo2_uU_L3_39_0 gp_3_39_0 dpre_L3_39 ts_uU_L3_39_0 0 NMIR W=20u L=1u
Mo3_uU_L3_39_0 da_uU_L3_39_0 da_uU_L3_39_0 vdd vdd PMIR W=60u L=1u
Mo4_uU_L3_39_0 gp_3_39_0 da_uU_L3_39_0 vdd vdd PMIR W=60u L=1u
Mt_uU_L3_39_1 ts_uU_L3_39_1 hv_L2_6 0 0 NMIR W=48.0u L=1u
Mo1_uU_L3_39_1 da_uU_L3_39_1 d1bar_L3 ts_uU_L3_39_1 0 NMIR W=20u L=1u
Mo2_uU_L3_39_1 gp_3_39_1 dpre_L3_39 ts_uU_L3_39_1 0 NMIR W=20u L=1u
Mo3_uU_L3_39_1 da_uU_L3_39_1 da_uU_L3_39_1 vdd vdd PMIR W=60u L=1u
Mo4_uU_L3_39_1 gp_3_39_1 da_uU_L3_39_1 vdd vdd PMIR W=60u L=1u
Mt_uU_L3_39_2 ts_uU_L3_39_2 hv_L2_7 0 0 NMIR W=48.0u L=1u
Mo1_uU_L3_39_2 da_uU_L3_39_2 d1bar_L3 ts_uU_L3_39_2 0 NMIR W=20u L=1u
Mo2_uU_L3_39_2 gp_3_39_2 dpre_L3_39 ts_uU_L3_39_2 0 NMIR W=20u L=1u
Mo3_uU_L3_39_2 da_uU_L3_39_2 da_uU_L3_39_2 vdd vdd PMIR W=60u L=1u
Mo4_uU_L3_39_2 gp_3_39_2 da_uU_L3_39_2 vdd vdd PMIR W=60u L=1u
Mt_uU_L3_39_3 ts_uU_L3_39_3 hv_L2_11 0 0 NMIR W=48.0u L=1u
Mo1_uU_L3_39_3 da_uU_L3_39_3 d1bar_L3 ts_uU_L3_39_3 0 NMIR W=20u L=1u
Mo2_uU_L3_39_3 gp_3_39_3 dpre_L3_39 ts_uU_L3_39_3 0 NMIR W=20u L=1u
Mo3_uU_L3_39_3 da_uU_L3_39_3 da_uU_L3_39_3 vdd vdd PMIR W=60u L=1u
Mo4_uU_L3_39_3 gp_3_39_3 da_uU_L3_39_3 vdd vdd PMIR W=60u L=1u
Mt_uU_L3_39_4 ts_uU_L3_39_4 hv_L2_23 0 0 NMIR W=48.0u L=1u
Mo1_uU_L3_39_4 da_uU_L3_39_4 d1bar_L3 ts_uU_L3_39_4 0 NMIR W=20u L=1u
Mo2_uU_L3_39_4 gp_3_39_4 dpre_L3_39 ts_uU_L3_39_4 0 NMIR W=20u L=1u
Mo3_uU_L3_39_4 da_uU_L3_39_4 da_uU_L3_39_4 vdd vdd PMIR W=60u L=1u
Mo4_uU_L3_39_4 gp_3_39_4 da_uU_L3_39_4 vdd vdd PMIR W=60u L=1u
Mt_uU_L3_39_5 ts_uU_L3_39_5 hv_L2_25 0 0 NMIR W=48.0u L=1u
Mo1_uU_L3_39_5 da_uU_L3_39_5 d1bar_L3 ts_uU_L3_39_5 0 NMIR W=20u L=1u
Mo2_uU_L3_39_5 gp_3_39_5 dpre_L3_39 ts_uU_L3_39_5 0 NMIR W=20u L=1u
Mo3_uU_L3_39_5 da_uU_L3_39_5 da_uU_L3_39_5 vdd vdd PMIR W=60u L=1u
Mo4_uU_L3_39_5 gp_3_39_5 da_uU_L3_39_5 vdd vdd PMIR W=60u L=1u
Mt_uU_L3_39_6 ts_uU_L3_39_6 hv_L2_27 0 0 NMIR W=48.0u L=1u
Mo1_uU_L3_39_6 da_uU_L3_39_6 d1bar_L3 ts_uU_L3_39_6 0 NMIR W=20u L=1u
Mo2_uU_L3_39_6 gp_3_39_6 dpre_L3_39 ts_uU_L3_39_6 0 NMIR W=20u L=1u
Mo3_uU_L3_39_6 da_uU_L3_39_6 da_uU_L3_39_6 vdd vdd PMIR W=60u L=1u
Mo4_uU_L3_39_6 gp_3_39_6 da_uU_L3_39_6 vdd vdd PMIR W=60u L=1u
Mt_uU_L3_39_7 ts_uU_L3_39_7 hv_L2_32 0 0 NMIR W=48.0u L=1u
Mo1_uU_L3_39_7 da_uU_L3_39_7 d1bar_L3 ts_uU_L3_39_7 0 NMIR W=20u L=1u
Mo2_uU_L3_39_7 gp_3_39_7 dpre_L3_39 ts_uU_L3_39_7 0 NMIR W=20u L=1u
Mo3_uU_L3_39_7 da_uU_L3_39_7 da_uU_L3_39_7 vdd vdd PMIR W=60u L=1u
Mo4_uU_L3_39_7 gp_3_39_7 da_uU_L3_39_7 vdd vdd PMIR W=60u L=1u
Mt_uU_L3_39_8 ts_uU_L3_39_8 hv_L2_37 0 0 NMIR W=48.0u L=1u
Mo1_uU_L3_39_8 da_uU_L3_39_8 d1bar_L3 ts_uU_L3_39_8 0 NMIR W=20u L=1u
Mo2_uU_L3_39_8 gp_3_39_8 dpre_L3_39 ts_uU_L3_39_8 0 NMIR W=20u L=1u
Mo3_uU_L3_39_8 da_uU_L3_39_8 da_uU_L3_39_8 vdd vdd PMIR W=60u L=1u
Mo4_uU_L3_39_8 gp_3_39_8 da_uU_L3_39_8 vdd vdd PMIR W=60u L=1u
Mt_uU_L3_39_9 ts_uU_L3_39_9 hv_L2_38 0 0 NMIR W=48.0u L=1u
Mo1_uU_L3_39_9 da_uU_L3_39_9 d1bar_L3 ts_uU_L3_39_9 0 NMIR W=20u L=1u
Mo2_uU_L3_39_9 gp_3_39_9 dpre_L3_39 ts_uU_L3_39_9 0 NMIR W=20u L=1u
Mo3_uU_L3_39_9 da_uU_L3_39_9 da_uU_L3_39_9 vdd vdd PMIR W=60u L=1u
Mo4_uU_L3_39_9 gp_3_39_9 da_uU_L3_39_9 vdd vdd PMIR W=60u L=1u
Mt_uU_L3_39_10 ts_uU_L3_39_10 hv_L2_39 0 0 NMIR W=48.0u L=1u
Mo1_uU_L3_39_10 da_uU_L3_39_10 d1bar_L3 ts_uU_L3_39_10 0 NMIR W=20u L=1u
Mo2_uU_L3_39_10 gp_3_39_10 dpre_L3_39 ts_uU_L3_39_10 0 NMIR W=20u L=1u
Mo3_uU_L3_39_10 da_uU_L3_39_10 da_uU_L3_39_10 vdd vdd PMIR W=60u L=1u
Mo4_uU_L3_39_10 gp_3_39_10 da_uU_L3_39_10 vdd vdd PMIR W=60u L=1u
Mt_uU_L3_39_11 ts_uU_L3_39_11 hv_L2_40 0 0 NMIR W=48.0u L=1u
Mo1_uU_L3_39_11 da_uU_L3_39_11 d1bar_L3 ts_uU_L3_39_11 0 NMIR W=20u L=1u
Mo2_uU_L3_39_11 gp_3_39_11 dpre_L3_39 ts_uU_L3_39_11 0 NMIR W=20u L=1u
Mo3_uU_L3_39_11 da_uU_L3_39_11 da_uU_L3_39_11 vdd vdd PMIR W=60u L=1u
Mo4_uU_L3_39_11 gp_3_39_11 da_uU_L3_39_11 vdd vdd PMIR W=60u L=1u
Mt_uU_L3_39_12 ts_uU_L3_39_12 hv_L2_43 0 0 NMIR W=48.0u L=1u
Mo1_uU_L3_39_12 da_uU_L3_39_12 d1bar_L3 ts_uU_L3_39_12 0 NMIR W=20u L=1u
Mo2_uU_L3_39_12 gp_3_39_12 dpre_L3_39 ts_uU_L3_39_12 0 NMIR W=20u L=1u
Mo3_uU_L3_39_12 da_uU_L3_39_12 da_uU_L3_39_12 vdd vdd PMIR W=60u L=1u
Mo4_uU_L3_39_12 gp_3_39_12 da_uU_L3_39_12 vdd vdd PMIR W=60u L=1u
Mt_uU_L3_39_13 ts_uU_L3_39_13 hv_L2_44 0 0 NMIR W=48.0u L=1u
Mo1_uU_L3_39_13 da_uU_L3_39_13 d1bar_L3 ts_uU_L3_39_13 0 NMIR W=20u L=1u
Mo2_uU_L3_39_13 gp_3_39_13 dpre_L3_39 ts_uU_L3_39_13 0 NMIR W=20u L=1u
Mo3_uU_L3_39_13 da_uU_L3_39_13 da_uU_L3_39_13 vdd vdd PMIR W=60u L=1u
Mo4_uU_L3_39_13 gp_3_39_13 da_uU_L3_39_13 vdd vdd PMIR W=60u L=1u
Mt_uU_L3_39_14 ts_uU_L3_39_14 hv_L2_46 0 0 NMIR W=48.0u L=1u
Mo1_uU_L3_39_14 da_uU_L3_39_14 d1bar_L3 ts_uU_L3_39_14 0 NMIR W=20u L=1u
Mo2_uU_L3_39_14 gp_3_39_14 dpre_L3_39 ts_uU_L3_39_14 0 NMIR W=20u L=1u
Mo3_uU_L3_39_14 da_uU_L3_39_14 da_uU_L3_39_14 vdd vdd PMIR W=60u L=1u
Mo4_uU_L3_39_14 gp_3_39_14 da_uU_L3_39_14 vdd vdd PMIR W=60u L=1u
Mt_uU_L3_39_15 ts_uU_L3_39_15 hv_L2_47 0 0 NMIR W=48.0u L=1u
Mo1_uU_L3_39_15 da_uU_L3_39_15 d1bar_L3 ts_uU_L3_39_15 0 NMIR W=20u L=1u
Mo2_uU_L3_39_15 gp_3_39_15 dpre_L3_39 ts_uU_L3_39_15 0 NMIR W=20u L=1u
Mo3_uU_L3_39_15 da_uU_L3_39_15 da_uU_L3_39_15 vdd vdd PMIR W=60u L=1u
Mo4_uU_L3_39_15 gp_3_39_15 da_uU_L3_39_15 vdd vdd PMIR W=60u L=1u
Mt_uU_L3_40_0 ts_uU_L3_40_0 hv_L2_0 0 0 NMIR W=48.0u L=1u
Mo1_uU_L3_40_0 da_uU_L3_40_0 d1bar_L3 ts_uU_L3_40_0 0 NMIR W=20u L=1u
Mo2_uU_L3_40_0 gp_3_40_0 dpre_L3_40 ts_uU_L3_40_0 0 NMIR W=20u L=1u
Mo3_uU_L3_40_0 da_uU_L3_40_0 da_uU_L3_40_0 vdd vdd PMIR W=60u L=1u
Mo4_uU_L3_40_0 gp_3_40_0 da_uU_L3_40_0 vdd vdd PMIR W=60u L=1u
Mt_uU_L3_40_1 ts_uU_L3_40_1 hv_L2_3 0 0 NMIR W=48.0u L=1u
Mo1_uU_L3_40_1 da_uU_L3_40_1 d1bar_L3 ts_uU_L3_40_1 0 NMIR W=20u L=1u
Mo2_uU_L3_40_1 gp_3_40_1 dpre_L3_40 ts_uU_L3_40_1 0 NMIR W=20u L=1u
Mo3_uU_L3_40_1 da_uU_L3_40_1 da_uU_L3_40_1 vdd vdd PMIR W=60u L=1u
Mo4_uU_L3_40_1 gp_3_40_1 da_uU_L3_40_1 vdd vdd PMIR W=60u L=1u
Mt_uU_L3_40_2 ts_uU_L3_40_2 hv_L2_9 0 0 NMIR W=48.0u L=1u
Mo1_uU_L3_40_2 da_uU_L3_40_2 d1bar_L3 ts_uU_L3_40_2 0 NMIR W=20u L=1u
Mo2_uU_L3_40_2 gp_3_40_2 dpre_L3_40 ts_uU_L3_40_2 0 NMIR W=20u L=1u
Mo3_uU_L3_40_2 da_uU_L3_40_2 da_uU_L3_40_2 vdd vdd PMIR W=60u L=1u
Mo4_uU_L3_40_2 gp_3_40_2 da_uU_L3_40_2 vdd vdd PMIR W=60u L=1u
Mt_uU_L3_40_3 ts_uU_L3_40_3 hv_L2_10 0 0 NMIR W=48.0u L=1u
Mo1_uU_L3_40_3 da_uU_L3_40_3 d1bar_L3 ts_uU_L3_40_3 0 NMIR W=20u L=1u
Mo2_uU_L3_40_3 gp_3_40_3 dpre_L3_40 ts_uU_L3_40_3 0 NMIR W=20u L=1u
Mo3_uU_L3_40_3 da_uU_L3_40_3 da_uU_L3_40_3 vdd vdd PMIR W=60u L=1u
Mo4_uU_L3_40_3 gp_3_40_3 da_uU_L3_40_3 vdd vdd PMIR W=60u L=1u
Mt_uU_L3_40_4 ts_uU_L3_40_4 hv_L2_11 0 0 NMIR W=48.0u L=1u
Mo1_uU_L3_40_4 da_uU_L3_40_4 d1bar_L3 ts_uU_L3_40_4 0 NMIR W=20u L=1u
Mo2_uU_L3_40_4 gp_3_40_4 dpre_L3_40 ts_uU_L3_40_4 0 NMIR W=20u L=1u
Mo3_uU_L3_40_4 da_uU_L3_40_4 da_uU_L3_40_4 vdd vdd PMIR W=60u L=1u
Mo4_uU_L3_40_4 gp_3_40_4 da_uU_L3_40_4 vdd vdd PMIR W=60u L=1u
Mt_uU_L3_40_5 ts_uU_L3_40_5 hv_L2_13 0 0 NMIR W=48.0u L=1u
Mo1_uU_L3_40_5 da_uU_L3_40_5 d1bar_L3 ts_uU_L3_40_5 0 NMIR W=20u L=1u
Mo2_uU_L3_40_5 gp_3_40_5 dpre_L3_40 ts_uU_L3_40_5 0 NMIR W=20u L=1u
Mo3_uU_L3_40_5 da_uU_L3_40_5 da_uU_L3_40_5 vdd vdd PMIR W=60u L=1u
Mo4_uU_L3_40_5 gp_3_40_5 da_uU_L3_40_5 vdd vdd PMIR W=60u L=1u
Mt_uU_L3_40_6 ts_uU_L3_40_6 hv_L2_15 0 0 NMIR W=48.0u L=1u
Mo1_uU_L3_40_6 da_uU_L3_40_6 d1bar_L3 ts_uU_L3_40_6 0 NMIR W=20u L=1u
Mo2_uU_L3_40_6 gp_3_40_6 dpre_L3_40 ts_uU_L3_40_6 0 NMIR W=20u L=1u
Mo3_uU_L3_40_6 da_uU_L3_40_6 da_uU_L3_40_6 vdd vdd PMIR W=60u L=1u
Mo4_uU_L3_40_6 gp_3_40_6 da_uU_L3_40_6 vdd vdd PMIR W=60u L=1u
Mt_uU_L3_40_7 ts_uU_L3_40_7 hv_L2_16 0 0 NMIR W=48.0u L=1u
Mo1_uU_L3_40_7 da_uU_L3_40_7 d1bar_L3 ts_uU_L3_40_7 0 NMIR W=20u L=1u
Mo2_uU_L3_40_7 gp_3_40_7 dpre_L3_40 ts_uU_L3_40_7 0 NMIR W=20u L=1u
Mo3_uU_L3_40_7 da_uU_L3_40_7 da_uU_L3_40_7 vdd vdd PMIR W=60u L=1u
Mo4_uU_L3_40_7 gp_3_40_7 da_uU_L3_40_7 vdd vdd PMIR W=60u L=1u
Mt_uU_L3_40_8 ts_uU_L3_40_8 hv_L2_19 0 0 NMIR W=48.0u L=1u
Mo1_uU_L3_40_8 da_uU_L3_40_8 d1bar_L3 ts_uU_L3_40_8 0 NMIR W=20u L=1u
Mo2_uU_L3_40_8 gp_3_40_8 dpre_L3_40 ts_uU_L3_40_8 0 NMIR W=20u L=1u
Mo3_uU_L3_40_8 da_uU_L3_40_8 da_uU_L3_40_8 vdd vdd PMIR W=60u L=1u
Mo4_uU_L3_40_8 gp_3_40_8 da_uU_L3_40_8 vdd vdd PMIR W=60u L=1u
Mt_uU_L3_40_9 ts_uU_L3_40_9 hv_L2_25 0 0 NMIR W=48.0u L=1u
Mo1_uU_L3_40_9 da_uU_L3_40_9 d1bar_L3 ts_uU_L3_40_9 0 NMIR W=20u L=1u
Mo2_uU_L3_40_9 gp_3_40_9 dpre_L3_40 ts_uU_L3_40_9 0 NMIR W=20u L=1u
Mo3_uU_L3_40_9 da_uU_L3_40_9 da_uU_L3_40_9 vdd vdd PMIR W=60u L=1u
Mo4_uU_L3_40_9 gp_3_40_9 da_uU_L3_40_9 vdd vdd PMIR W=60u L=1u
Mt_uU_L3_40_10 ts_uU_L3_40_10 hv_L2_28 0 0 NMIR W=48.0u L=1u
Mo1_uU_L3_40_10 da_uU_L3_40_10 d1bar_L3 ts_uU_L3_40_10 0 NMIR W=20u L=1u
Mo2_uU_L3_40_10 gp_3_40_10 dpre_L3_40 ts_uU_L3_40_10 0 NMIR W=20u L=1u
Mo3_uU_L3_40_10 da_uU_L3_40_10 da_uU_L3_40_10 vdd vdd PMIR W=60u L=1u
Mo4_uU_L3_40_10 gp_3_40_10 da_uU_L3_40_10 vdd vdd PMIR W=60u L=1u
Mt_uU_L3_40_11 ts_uU_L3_40_11 hv_L2_30 0 0 NMIR W=48.0u L=1u
Mo1_uU_L3_40_11 da_uU_L3_40_11 d1bar_L3 ts_uU_L3_40_11 0 NMIR W=20u L=1u
Mo2_uU_L3_40_11 gp_3_40_11 dpre_L3_40 ts_uU_L3_40_11 0 NMIR W=20u L=1u
Mo3_uU_L3_40_11 da_uU_L3_40_11 da_uU_L3_40_11 vdd vdd PMIR W=60u L=1u
Mo4_uU_L3_40_11 gp_3_40_11 da_uU_L3_40_11 vdd vdd PMIR W=60u L=1u
Mt_uU_L3_40_12 ts_uU_L3_40_12 hv_L2_37 0 0 NMIR W=48.0u L=1u
Mo1_uU_L3_40_12 da_uU_L3_40_12 d1bar_L3 ts_uU_L3_40_12 0 NMIR W=20u L=1u
Mo2_uU_L3_40_12 gp_3_40_12 dpre_L3_40 ts_uU_L3_40_12 0 NMIR W=20u L=1u
Mo3_uU_L3_40_12 da_uU_L3_40_12 da_uU_L3_40_12 vdd vdd PMIR W=60u L=1u
Mo4_uU_L3_40_12 gp_3_40_12 da_uU_L3_40_12 vdd vdd PMIR W=60u L=1u
Mt_uU_L3_40_13 ts_uU_L3_40_13 hv_L2_38 0 0 NMIR W=48.0u L=1u
Mo1_uU_L3_40_13 da_uU_L3_40_13 d1bar_L3 ts_uU_L3_40_13 0 NMIR W=20u L=1u
Mo2_uU_L3_40_13 gp_3_40_13 dpre_L3_40 ts_uU_L3_40_13 0 NMIR W=20u L=1u
Mo3_uU_L3_40_13 da_uU_L3_40_13 da_uU_L3_40_13 vdd vdd PMIR W=60u L=1u
Mo4_uU_L3_40_13 gp_3_40_13 da_uU_L3_40_13 vdd vdd PMIR W=60u L=1u
Mt_uU_L3_40_14 ts_uU_L3_40_14 hv_L2_42 0 0 NMIR W=48.0u L=1u
Mo1_uU_L3_40_14 da_uU_L3_40_14 d1bar_L3 ts_uU_L3_40_14 0 NMIR W=20u L=1u
Mo2_uU_L3_40_14 gp_3_40_14 dpre_L3_40 ts_uU_L3_40_14 0 NMIR W=20u L=1u
Mo3_uU_L3_40_14 da_uU_L3_40_14 da_uU_L3_40_14 vdd vdd PMIR W=60u L=1u
Mo4_uU_L3_40_14 gp_3_40_14 da_uU_L3_40_14 vdd vdd PMIR W=60u L=1u
Mt_uU_L3_40_15 ts_uU_L3_40_15 hv_L2_44 0 0 NMIR W=48.0u L=1u
Mo1_uU_L3_40_15 da_uU_L3_40_15 d1bar_L3 ts_uU_L3_40_15 0 NMIR W=20u L=1u
Mo2_uU_L3_40_15 gp_3_40_15 dpre_L3_40 ts_uU_L3_40_15 0 NMIR W=20u L=1u
Mo3_uU_L3_40_15 da_uU_L3_40_15 da_uU_L3_40_15 vdd vdd PMIR W=60u L=1u
Mo4_uU_L3_40_15 gp_3_40_15 da_uU_L3_40_15 vdd vdd PMIR W=60u L=1u
Mt_uU_L3_41_0 ts_uU_L3_41_0 hv_L2_0 0 0 NMIR W=48.0u L=1u
Mo1_uU_L3_41_0 da_uU_L3_41_0 d1bar_L3 ts_uU_L3_41_0 0 NMIR W=20u L=1u
Mo2_uU_L3_41_0 gp_3_41_0 dpre_L3_41 ts_uU_L3_41_0 0 NMIR W=20u L=1u
Mo3_uU_L3_41_0 da_uU_L3_41_0 da_uU_L3_41_0 vdd vdd PMIR W=60u L=1u
Mo4_uU_L3_41_0 gp_3_41_0 da_uU_L3_41_0 vdd vdd PMIR W=60u L=1u
Mt_uU_L3_41_1 ts_uU_L3_41_1 hv_L2_7 0 0 NMIR W=48.0u L=1u
Mo1_uU_L3_41_1 da_uU_L3_41_1 d1bar_L3 ts_uU_L3_41_1 0 NMIR W=20u L=1u
Mo2_uU_L3_41_1 gp_3_41_1 dpre_L3_41 ts_uU_L3_41_1 0 NMIR W=20u L=1u
Mo3_uU_L3_41_1 da_uU_L3_41_1 da_uU_L3_41_1 vdd vdd PMIR W=60u L=1u
Mo4_uU_L3_41_1 gp_3_41_1 da_uU_L3_41_1 vdd vdd PMIR W=60u L=1u
Mt_uU_L3_41_2 ts_uU_L3_41_2 hv_L2_8 0 0 NMIR W=48.0u L=1u
Mo1_uU_L3_41_2 da_uU_L3_41_2 d1bar_L3 ts_uU_L3_41_2 0 NMIR W=20u L=1u
Mo2_uU_L3_41_2 gp_3_41_2 dpre_L3_41 ts_uU_L3_41_2 0 NMIR W=20u L=1u
Mo3_uU_L3_41_2 da_uU_L3_41_2 da_uU_L3_41_2 vdd vdd PMIR W=60u L=1u
Mo4_uU_L3_41_2 gp_3_41_2 da_uU_L3_41_2 vdd vdd PMIR W=60u L=1u
Mt_uU_L3_41_3 ts_uU_L3_41_3 hv_L2_9 0 0 NMIR W=48.0u L=1u
Mo1_uU_L3_41_3 da_uU_L3_41_3 d1bar_L3 ts_uU_L3_41_3 0 NMIR W=20u L=1u
Mo2_uU_L3_41_3 gp_3_41_3 dpre_L3_41 ts_uU_L3_41_3 0 NMIR W=20u L=1u
Mo3_uU_L3_41_3 da_uU_L3_41_3 da_uU_L3_41_3 vdd vdd PMIR W=60u L=1u
Mo4_uU_L3_41_3 gp_3_41_3 da_uU_L3_41_3 vdd vdd PMIR W=60u L=1u
Mt_uU_L3_41_4 ts_uU_L3_41_4 hv_L2_12 0 0 NMIR W=48.0u L=1u
Mo1_uU_L3_41_4 da_uU_L3_41_4 d1bar_L3 ts_uU_L3_41_4 0 NMIR W=20u L=1u
Mo2_uU_L3_41_4 gp_3_41_4 dpre_L3_41 ts_uU_L3_41_4 0 NMIR W=20u L=1u
Mo3_uU_L3_41_4 da_uU_L3_41_4 da_uU_L3_41_4 vdd vdd PMIR W=60u L=1u
Mo4_uU_L3_41_4 gp_3_41_4 da_uU_L3_41_4 vdd vdd PMIR W=60u L=1u
Mt_uU_L3_41_5 ts_uU_L3_41_5 hv_L2_15 0 0 NMIR W=48.0u L=1u
Mo1_uU_L3_41_5 da_uU_L3_41_5 d1bar_L3 ts_uU_L3_41_5 0 NMIR W=20u L=1u
Mo2_uU_L3_41_5 gp_3_41_5 dpre_L3_41 ts_uU_L3_41_5 0 NMIR W=20u L=1u
Mo3_uU_L3_41_5 da_uU_L3_41_5 da_uU_L3_41_5 vdd vdd PMIR W=60u L=1u
Mo4_uU_L3_41_5 gp_3_41_5 da_uU_L3_41_5 vdd vdd PMIR W=60u L=1u
Mt_uU_L3_41_6 ts_uU_L3_41_6 hv_L2_17 0 0 NMIR W=48.0u L=1u
Mo1_uU_L3_41_6 da_uU_L3_41_6 d1bar_L3 ts_uU_L3_41_6 0 NMIR W=20u L=1u
Mo2_uU_L3_41_6 gp_3_41_6 dpre_L3_41 ts_uU_L3_41_6 0 NMIR W=20u L=1u
Mo3_uU_L3_41_6 da_uU_L3_41_6 da_uU_L3_41_6 vdd vdd PMIR W=60u L=1u
Mo4_uU_L3_41_6 gp_3_41_6 da_uU_L3_41_6 vdd vdd PMIR W=60u L=1u
Mt_uU_L3_41_7 ts_uU_L3_41_7 hv_L2_22 0 0 NMIR W=48.0u L=1u
Mo1_uU_L3_41_7 da_uU_L3_41_7 d1bar_L3 ts_uU_L3_41_7 0 NMIR W=20u L=1u
Mo2_uU_L3_41_7 gp_3_41_7 dpre_L3_41 ts_uU_L3_41_7 0 NMIR W=20u L=1u
Mo3_uU_L3_41_7 da_uU_L3_41_7 da_uU_L3_41_7 vdd vdd PMIR W=60u L=1u
Mo4_uU_L3_41_7 gp_3_41_7 da_uU_L3_41_7 vdd vdd PMIR W=60u L=1u
Mt_uU_L3_41_8 ts_uU_L3_41_8 hv_L2_25 0 0 NMIR W=48.0u L=1u
Mo1_uU_L3_41_8 da_uU_L3_41_8 d1bar_L3 ts_uU_L3_41_8 0 NMIR W=20u L=1u
Mo2_uU_L3_41_8 gp_3_41_8 dpre_L3_41 ts_uU_L3_41_8 0 NMIR W=20u L=1u
Mo3_uU_L3_41_8 da_uU_L3_41_8 da_uU_L3_41_8 vdd vdd PMIR W=60u L=1u
Mo4_uU_L3_41_8 gp_3_41_8 da_uU_L3_41_8 vdd vdd PMIR W=60u L=1u
Mt_uU_L3_41_9 ts_uU_L3_41_9 hv_L2_28 0 0 NMIR W=48.0u L=1u
Mo1_uU_L3_41_9 da_uU_L3_41_9 d1bar_L3 ts_uU_L3_41_9 0 NMIR W=20u L=1u
Mo2_uU_L3_41_9 gp_3_41_9 dpre_L3_41 ts_uU_L3_41_9 0 NMIR W=20u L=1u
Mo3_uU_L3_41_9 da_uU_L3_41_9 da_uU_L3_41_9 vdd vdd PMIR W=60u L=1u
Mo4_uU_L3_41_9 gp_3_41_9 da_uU_L3_41_9 vdd vdd PMIR W=60u L=1u
Mt_uU_L3_41_10 ts_uU_L3_41_10 hv_L2_33 0 0 NMIR W=48.0u L=1u
Mo1_uU_L3_41_10 da_uU_L3_41_10 d1bar_L3 ts_uU_L3_41_10 0 NMIR W=20u L=1u
Mo2_uU_L3_41_10 gp_3_41_10 dpre_L3_41 ts_uU_L3_41_10 0 NMIR W=20u L=1u
Mo3_uU_L3_41_10 da_uU_L3_41_10 da_uU_L3_41_10 vdd vdd PMIR W=60u L=1u
Mo4_uU_L3_41_10 gp_3_41_10 da_uU_L3_41_10 vdd vdd PMIR W=60u L=1u
Mt_uU_L3_41_11 ts_uU_L3_41_11 hv_L2_35 0 0 NMIR W=48.0u L=1u
Mo1_uU_L3_41_11 da_uU_L3_41_11 d1bar_L3 ts_uU_L3_41_11 0 NMIR W=20u L=1u
Mo2_uU_L3_41_11 gp_3_41_11 dpre_L3_41 ts_uU_L3_41_11 0 NMIR W=20u L=1u
Mo3_uU_L3_41_11 da_uU_L3_41_11 da_uU_L3_41_11 vdd vdd PMIR W=60u L=1u
Mo4_uU_L3_41_11 gp_3_41_11 da_uU_L3_41_11 vdd vdd PMIR W=60u L=1u
Mt_uU_L3_41_12 ts_uU_L3_41_12 hv_L2_37 0 0 NMIR W=48.0u L=1u
Mo1_uU_L3_41_12 da_uU_L3_41_12 d1bar_L3 ts_uU_L3_41_12 0 NMIR W=20u L=1u
Mo2_uU_L3_41_12 gp_3_41_12 dpre_L3_41 ts_uU_L3_41_12 0 NMIR W=20u L=1u
Mo3_uU_L3_41_12 da_uU_L3_41_12 da_uU_L3_41_12 vdd vdd PMIR W=60u L=1u
Mo4_uU_L3_41_12 gp_3_41_12 da_uU_L3_41_12 vdd vdd PMIR W=60u L=1u
Mt_uU_L3_41_13 ts_uU_L3_41_13 hv_L2_38 0 0 NMIR W=48.0u L=1u
Mo1_uU_L3_41_13 da_uU_L3_41_13 d1bar_L3 ts_uU_L3_41_13 0 NMIR W=20u L=1u
Mo2_uU_L3_41_13 gp_3_41_13 dpre_L3_41 ts_uU_L3_41_13 0 NMIR W=20u L=1u
Mo3_uU_L3_41_13 da_uU_L3_41_13 da_uU_L3_41_13 vdd vdd PMIR W=60u L=1u
Mo4_uU_L3_41_13 gp_3_41_13 da_uU_L3_41_13 vdd vdd PMIR W=60u L=1u
Mt_uU_L3_41_14 ts_uU_L3_41_14 hv_L2_42 0 0 NMIR W=48.0u L=1u
Mo1_uU_L3_41_14 da_uU_L3_41_14 d1bar_L3 ts_uU_L3_41_14 0 NMIR W=20u L=1u
Mo2_uU_L3_41_14 gp_3_41_14 dpre_L3_41 ts_uU_L3_41_14 0 NMIR W=20u L=1u
Mo3_uU_L3_41_14 da_uU_L3_41_14 da_uU_L3_41_14 vdd vdd PMIR W=60u L=1u
Mo4_uU_L3_41_14 gp_3_41_14 da_uU_L3_41_14 vdd vdd PMIR W=60u L=1u
Mt_uU_L3_41_15 ts_uU_L3_41_15 hv_L2_46 0 0 NMIR W=48.0u L=1u
Mo1_uU_L3_41_15 da_uU_L3_41_15 d1bar_L3 ts_uU_L3_41_15 0 NMIR W=20u L=1u
Mo2_uU_L3_41_15 gp_3_41_15 dpre_L3_41 ts_uU_L3_41_15 0 NMIR W=20u L=1u
Mo3_uU_L3_41_15 da_uU_L3_41_15 da_uU_L3_41_15 vdd vdd PMIR W=60u L=1u
Mo4_uU_L3_41_15 gp_3_41_15 da_uU_L3_41_15 vdd vdd PMIR W=60u L=1u
Mt_uU_L3_42_0 ts_uU_L3_42_0 hv_L2_3 0 0 NMIR W=48.0u L=1u
Mo1_uU_L3_42_0 da_uU_L3_42_0 d1bar_L3 ts_uU_L3_42_0 0 NMIR W=20u L=1u
Mo2_uU_L3_42_0 gp_3_42_0 dpre_L3_42 ts_uU_L3_42_0 0 NMIR W=20u L=1u
Mo3_uU_L3_42_0 da_uU_L3_42_0 da_uU_L3_42_0 vdd vdd PMIR W=60u L=1u
Mo4_uU_L3_42_0 gp_3_42_0 da_uU_L3_42_0 vdd vdd PMIR W=60u L=1u
Mt_uU_L3_42_1 ts_uU_L3_42_1 hv_L2_4 0 0 NMIR W=48.0u L=1u
Mo1_uU_L3_42_1 da_uU_L3_42_1 d1bar_L3 ts_uU_L3_42_1 0 NMIR W=20u L=1u
Mo2_uU_L3_42_1 gp_3_42_1 dpre_L3_42 ts_uU_L3_42_1 0 NMIR W=20u L=1u
Mo3_uU_L3_42_1 da_uU_L3_42_1 da_uU_L3_42_1 vdd vdd PMIR W=60u L=1u
Mo4_uU_L3_42_1 gp_3_42_1 da_uU_L3_42_1 vdd vdd PMIR W=60u L=1u
Mt_uU_L3_42_2 ts_uU_L3_42_2 hv_L2_6 0 0 NMIR W=48.0u L=1u
Mo1_uU_L3_42_2 da_uU_L3_42_2 d1bar_L3 ts_uU_L3_42_2 0 NMIR W=20u L=1u
Mo2_uU_L3_42_2 gp_3_42_2 dpre_L3_42 ts_uU_L3_42_2 0 NMIR W=20u L=1u
Mo3_uU_L3_42_2 da_uU_L3_42_2 da_uU_L3_42_2 vdd vdd PMIR W=60u L=1u
Mo4_uU_L3_42_2 gp_3_42_2 da_uU_L3_42_2 vdd vdd PMIR W=60u L=1u
Mt_uU_L3_42_3 ts_uU_L3_42_3 hv_L2_9 0 0 NMIR W=48.0u L=1u
Mo1_uU_L3_42_3 da_uU_L3_42_3 d1bar_L3 ts_uU_L3_42_3 0 NMIR W=20u L=1u
Mo2_uU_L3_42_3 gp_3_42_3 dpre_L3_42 ts_uU_L3_42_3 0 NMIR W=20u L=1u
Mo3_uU_L3_42_3 da_uU_L3_42_3 da_uU_L3_42_3 vdd vdd PMIR W=60u L=1u
Mo4_uU_L3_42_3 gp_3_42_3 da_uU_L3_42_3 vdd vdd PMIR W=60u L=1u
Mt_uU_L3_42_4 ts_uU_L3_42_4 hv_L2_10 0 0 NMIR W=48.0u L=1u
Mo1_uU_L3_42_4 da_uU_L3_42_4 d1bar_L3 ts_uU_L3_42_4 0 NMIR W=20u L=1u
Mo2_uU_L3_42_4 gp_3_42_4 dpre_L3_42 ts_uU_L3_42_4 0 NMIR W=20u L=1u
Mo3_uU_L3_42_4 da_uU_L3_42_4 da_uU_L3_42_4 vdd vdd PMIR W=60u L=1u
Mo4_uU_L3_42_4 gp_3_42_4 da_uU_L3_42_4 vdd vdd PMIR W=60u L=1u
Mt_uU_L3_42_5 ts_uU_L3_42_5 hv_L2_12 0 0 NMIR W=48.0u L=1u
Mo1_uU_L3_42_5 da_uU_L3_42_5 d1bar_L3 ts_uU_L3_42_5 0 NMIR W=20u L=1u
Mo2_uU_L3_42_5 gp_3_42_5 dpre_L3_42 ts_uU_L3_42_5 0 NMIR W=20u L=1u
Mo3_uU_L3_42_5 da_uU_L3_42_5 da_uU_L3_42_5 vdd vdd PMIR W=60u L=1u
Mo4_uU_L3_42_5 gp_3_42_5 da_uU_L3_42_5 vdd vdd PMIR W=60u L=1u
Mt_uU_L3_42_6 ts_uU_L3_42_6 hv_L2_14 0 0 NMIR W=48.0u L=1u
Mo1_uU_L3_42_6 da_uU_L3_42_6 d1bar_L3 ts_uU_L3_42_6 0 NMIR W=20u L=1u
Mo2_uU_L3_42_6 gp_3_42_6 dpre_L3_42 ts_uU_L3_42_6 0 NMIR W=20u L=1u
Mo3_uU_L3_42_6 da_uU_L3_42_6 da_uU_L3_42_6 vdd vdd PMIR W=60u L=1u
Mo4_uU_L3_42_6 gp_3_42_6 da_uU_L3_42_6 vdd vdd PMIR W=60u L=1u
Mt_uU_L3_42_7 ts_uU_L3_42_7 hv_L2_19 0 0 NMIR W=48.0u L=1u
Mo1_uU_L3_42_7 da_uU_L3_42_7 d1bar_L3 ts_uU_L3_42_7 0 NMIR W=20u L=1u
Mo2_uU_L3_42_7 gp_3_42_7 dpre_L3_42 ts_uU_L3_42_7 0 NMIR W=20u L=1u
Mo3_uU_L3_42_7 da_uU_L3_42_7 da_uU_L3_42_7 vdd vdd PMIR W=60u L=1u
Mo4_uU_L3_42_7 gp_3_42_7 da_uU_L3_42_7 vdd vdd PMIR W=60u L=1u
Mt_uU_L3_42_8 ts_uU_L3_42_8 hv_L2_23 0 0 NMIR W=48.0u L=1u
Mo1_uU_L3_42_8 da_uU_L3_42_8 d1bar_L3 ts_uU_L3_42_8 0 NMIR W=20u L=1u
Mo2_uU_L3_42_8 gp_3_42_8 dpre_L3_42 ts_uU_L3_42_8 0 NMIR W=20u L=1u
Mo3_uU_L3_42_8 da_uU_L3_42_8 da_uU_L3_42_8 vdd vdd PMIR W=60u L=1u
Mo4_uU_L3_42_8 gp_3_42_8 da_uU_L3_42_8 vdd vdd PMIR W=60u L=1u
Mt_uU_L3_42_9 ts_uU_L3_42_9 hv_L2_24 0 0 NMIR W=48.0u L=1u
Mo1_uU_L3_42_9 da_uU_L3_42_9 d1bar_L3 ts_uU_L3_42_9 0 NMIR W=20u L=1u
Mo2_uU_L3_42_9 gp_3_42_9 dpre_L3_42 ts_uU_L3_42_9 0 NMIR W=20u L=1u
Mo3_uU_L3_42_9 da_uU_L3_42_9 da_uU_L3_42_9 vdd vdd PMIR W=60u L=1u
Mo4_uU_L3_42_9 gp_3_42_9 da_uU_L3_42_9 vdd vdd PMIR W=60u L=1u
Mt_uU_L3_42_10 ts_uU_L3_42_10 hv_L2_26 0 0 NMIR W=48.0u L=1u
Mo1_uU_L3_42_10 da_uU_L3_42_10 d1bar_L3 ts_uU_L3_42_10 0 NMIR W=20u L=1u
Mo2_uU_L3_42_10 gp_3_42_10 dpre_L3_42 ts_uU_L3_42_10 0 NMIR W=20u L=1u
Mo3_uU_L3_42_10 da_uU_L3_42_10 da_uU_L3_42_10 vdd vdd PMIR W=60u L=1u
Mo4_uU_L3_42_10 gp_3_42_10 da_uU_L3_42_10 vdd vdd PMIR W=60u L=1u
Mt_uU_L3_42_11 ts_uU_L3_42_11 hv_L2_30 0 0 NMIR W=48.0u L=1u
Mo1_uU_L3_42_11 da_uU_L3_42_11 d1bar_L3 ts_uU_L3_42_11 0 NMIR W=20u L=1u
Mo2_uU_L3_42_11 gp_3_42_11 dpre_L3_42 ts_uU_L3_42_11 0 NMIR W=20u L=1u
Mo3_uU_L3_42_11 da_uU_L3_42_11 da_uU_L3_42_11 vdd vdd PMIR W=60u L=1u
Mo4_uU_L3_42_11 gp_3_42_11 da_uU_L3_42_11 vdd vdd PMIR W=60u L=1u
Mt_uU_L3_42_12 ts_uU_L3_42_12 hv_L2_31 0 0 NMIR W=48.0u L=1u
Mo1_uU_L3_42_12 da_uU_L3_42_12 d1bar_L3 ts_uU_L3_42_12 0 NMIR W=20u L=1u
Mo2_uU_L3_42_12 gp_3_42_12 dpre_L3_42 ts_uU_L3_42_12 0 NMIR W=20u L=1u
Mo3_uU_L3_42_12 da_uU_L3_42_12 da_uU_L3_42_12 vdd vdd PMIR W=60u L=1u
Mo4_uU_L3_42_12 gp_3_42_12 da_uU_L3_42_12 vdd vdd PMIR W=60u L=1u
Mt_uU_L3_42_13 ts_uU_L3_42_13 hv_L2_34 0 0 NMIR W=48.0u L=1u
Mo1_uU_L3_42_13 da_uU_L3_42_13 d1bar_L3 ts_uU_L3_42_13 0 NMIR W=20u L=1u
Mo2_uU_L3_42_13 gp_3_42_13 dpre_L3_42 ts_uU_L3_42_13 0 NMIR W=20u L=1u
Mo3_uU_L3_42_13 da_uU_L3_42_13 da_uU_L3_42_13 vdd vdd PMIR W=60u L=1u
Mo4_uU_L3_42_13 gp_3_42_13 da_uU_L3_42_13 vdd vdd PMIR W=60u L=1u
Mt_uU_L3_42_14 ts_uU_L3_42_14 hv_L2_40 0 0 NMIR W=48.0u L=1u
Mo1_uU_L3_42_14 da_uU_L3_42_14 d1bar_L3 ts_uU_L3_42_14 0 NMIR W=20u L=1u
Mo2_uU_L3_42_14 gp_3_42_14 dpre_L3_42 ts_uU_L3_42_14 0 NMIR W=20u L=1u
Mo3_uU_L3_42_14 da_uU_L3_42_14 da_uU_L3_42_14 vdd vdd PMIR W=60u L=1u
Mo4_uU_L3_42_14 gp_3_42_14 da_uU_L3_42_14 vdd vdd PMIR W=60u L=1u
Mt_uU_L3_42_15 ts_uU_L3_42_15 hv_L2_45 0 0 NMIR W=48.0u L=1u
Mo1_uU_L3_42_15 da_uU_L3_42_15 d1bar_L3 ts_uU_L3_42_15 0 NMIR W=20u L=1u
Mo2_uU_L3_42_15 gp_3_42_15 dpre_L3_42 ts_uU_L3_42_15 0 NMIR W=20u L=1u
Mo3_uU_L3_42_15 da_uU_L3_42_15 da_uU_L3_42_15 vdd vdd PMIR W=60u L=1u
Mo4_uU_L3_42_15 gp_3_42_15 da_uU_L3_42_15 vdd vdd PMIR W=60u L=1u
Mt_uU_L3_43_0 ts_uU_L3_43_0 hv_L2_0 0 0 NMIR W=48.0u L=1u
Mo1_uU_L3_43_0 da_uU_L3_43_0 d1bar_L3 ts_uU_L3_43_0 0 NMIR W=20u L=1u
Mo2_uU_L3_43_0 gp_3_43_0 dpre_L3_43 ts_uU_L3_43_0 0 NMIR W=20u L=1u
Mo3_uU_L3_43_0 da_uU_L3_43_0 da_uU_L3_43_0 vdd vdd PMIR W=60u L=1u
Mo4_uU_L3_43_0 gp_3_43_0 da_uU_L3_43_0 vdd vdd PMIR W=60u L=1u
Mt_uU_L3_43_1 ts_uU_L3_43_1 hv_L2_2 0 0 NMIR W=48.0u L=1u
Mo1_uU_L3_43_1 da_uU_L3_43_1 d1bar_L3 ts_uU_L3_43_1 0 NMIR W=20u L=1u
Mo2_uU_L3_43_1 gp_3_43_1 dpre_L3_43 ts_uU_L3_43_1 0 NMIR W=20u L=1u
Mo3_uU_L3_43_1 da_uU_L3_43_1 da_uU_L3_43_1 vdd vdd PMIR W=60u L=1u
Mo4_uU_L3_43_1 gp_3_43_1 da_uU_L3_43_1 vdd vdd PMIR W=60u L=1u
Mt_uU_L3_43_2 ts_uU_L3_43_2 hv_L2_4 0 0 NMIR W=48.0u L=1u
Mo1_uU_L3_43_2 da_uU_L3_43_2 d1bar_L3 ts_uU_L3_43_2 0 NMIR W=20u L=1u
Mo2_uU_L3_43_2 gp_3_43_2 dpre_L3_43 ts_uU_L3_43_2 0 NMIR W=20u L=1u
Mo3_uU_L3_43_2 da_uU_L3_43_2 da_uU_L3_43_2 vdd vdd PMIR W=60u L=1u
Mo4_uU_L3_43_2 gp_3_43_2 da_uU_L3_43_2 vdd vdd PMIR W=60u L=1u
Mt_uU_L3_43_3 ts_uU_L3_43_3 hv_L2_6 0 0 NMIR W=48.0u L=1u
Mo1_uU_L3_43_3 da_uU_L3_43_3 d1bar_L3 ts_uU_L3_43_3 0 NMIR W=20u L=1u
Mo2_uU_L3_43_3 gp_3_43_3 dpre_L3_43 ts_uU_L3_43_3 0 NMIR W=20u L=1u
Mo3_uU_L3_43_3 da_uU_L3_43_3 da_uU_L3_43_3 vdd vdd PMIR W=60u L=1u
Mo4_uU_L3_43_3 gp_3_43_3 da_uU_L3_43_3 vdd vdd PMIR W=60u L=1u
Mt_uU_L3_43_4 ts_uU_L3_43_4 hv_L2_8 0 0 NMIR W=48.0u L=1u
Mo1_uU_L3_43_4 da_uU_L3_43_4 d1bar_L3 ts_uU_L3_43_4 0 NMIR W=20u L=1u
Mo2_uU_L3_43_4 gp_3_43_4 dpre_L3_43 ts_uU_L3_43_4 0 NMIR W=20u L=1u
Mo3_uU_L3_43_4 da_uU_L3_43_4 da_uU_L3_43_4 vdd vdd PMIR W=60u L=1u
Mo4_uU_L3_43_4 gp_3_43_4 da_uU_L3_43_4 vdd vdd PMIR W=60u L=1u
Mt_uU_L3_43_5 ts_uU_L3_43_5 hv_L2_10 0 0 NMIR W=48.0u L=1u
Mo1_uU_L3_43_5 da_uU_L3_43_5 d1bar_L3 ts_uU_L3_43_5 0 NMIR W=20u L=1u
Mo2_uU_L3_43_5 gp_3_43_5 dpre_L3_43 ts_uU_L3_43_5 0 NMIR W=20u L=1u
Mo3_uU_L3_43_5 da_uU_L3_43_5 da_uU_L3_43_5 vdd vdd PMIR W=60u L=1u
Mo4_uU_L3_43_5 gp_3_43_5 da_uU_L3_43_5 vdd vdd PMIR W=60u L=1u
Mt_uU_L3_43_6 ts_uU_L3_43_6 hv_L2_11 0 0 NMIR W=48.0u L=1u
Mo1_uU_L3_43_6 da_uU_L3_43_6 d1bar_L3 ts_uU_L3_43_6 0 NMIR W=20u L=1u
Mo2_uU_L3_43_6 gp_3_43_6 dpre_L3_43 ts_uU_L3_43_6 0 NMIR W=20u L=1u
Mo3_uU_L3_43_6 da_uU_L3_43_6 da_uU_L3_43_6 vdd vdd PMIR W=60u L=1u
Mo4_uU_L3_43_6 gp_3_43_6 da_uU_L3_43_6 vdd vdd PMIR W=60u L=1u
Mt_uU_L3_43_7 ts_uU_L3_43_7 hv_L2_12 0 0 NMIR W=48.0u L=1u
Mo1_uU_L3_43_7 da_uU_L3_43_7 d1bar_L3 ts_uU_L3_43_7 0 NMIR W=20u L=1u
Mo2_uU_L3_43_7 gp_3_43_7 dpre_L3_43 ts_uU_L3_43_7 0 NMIR W=20u L=1u
Mo3_uU_L3_43_7 da_uU_L3_43_7 da_uU_L3_43_7 vdd vdd PMIR W=60u L=1u
Mo4_uU_L3_43_7 gp_3_43_7 da_uU_L3_43_7 vdd vdd PMIR W=60u L=1u
Mt_uU_L3_43_8 ts_uU_L3_43_8 hv_L2_15 0 0 NMIR W=48.0u L=1u
Mo1_uU_L3_43_8 da_uU_L3_43_8 d1bar_L3 ts_uU_L3_43_8 0 NMIR W=20u L=1u
Mo2_uU_L3_43_8 gp_3_43_8 dpre_L3_43 ts_uU_L3_43_8 0 NMIR W=20u L=1u
Mo3_uU_L3_43_8 da_uU_L3_43_8 da_uU_L3_43_8 vdd vdd PMIR W=60u L=1u
Mo4_uU_L3_43_8 gp_3_43_8 da_uU_L3_43_8 vdd vdd PMIR W=60u L=1u
Mt_uU_L3_43_9 ts_uU_L3_43_9 hv_L2_18 0 0 NMIR W=48.0u L=1u
Mo1_uU_L3_43_9 da_uU_L3_43_9 d1bar_L3 ts_uU_L3_43_9 0 NMIR W=20u L=1u
Mo2_uU_L3_43_9 gp_3_43_9 dpre_L3_43 ts_uU_L3_43_9 0 NMIR W=20u L=1u
Mo3_uU_L3_43_9 da_uU_L3_43_9 da_uU_L3_43_9 vdd vdd PMIR W=60u L=1u
Mo4_uU_L3_43_9 gp_3_43_9 da_uU_L3_43_9 vdd vdd PMIR W=60u L=1u
Mt_uU_L3_43_10 ts_uU_L3_43_10 hv_L2_27 0 0 NMIR W=48.0u L=1u
Mo1_uU_L3_43_10 da_uU_L3_43_10 d1bar_L3 ts_uU_L3_43_10 0 NMIR W=20u L=1u
Mo2_uU_L3_43_10 gp_3_43_10 dpre_L3_43 ts_uU_L3_43_10 0 NMIR W=20u L=1u
Mo3_uU_L3_43_10 da_uU_L3_43_10 da_uU_L3_43_10 vdd vdd PMIR W=60u L=1u
Mo4_uU_L3_43_10 gp_3_43_10 da_uU_L3_43_10 vdd vdd PMIR W=60u L=1u
Mt_uU_L3_43_11 ts_uU_L3_43_11 hv_L2_30 0 0 NMIR W=48.0u L=1u
Mo1_uU_L3_43_11 da_uU_L3_43_11 d1bar_L3 ts_uU_L3_43_11 0 NMIR W=20u L=1u
Mo2_uU_L3_43_11 gp_3_43_11 dpre_L3_43 ts_uU_L3_43_11 0 NMIR W=20u L=1u
Mo3_uU_L3_43_11 da_uU_L3_43_11 da_uU_L3_43_11 vdd vdd PMIR W=60u L=1u
Mo4_uU_L3_43_11 gp_3_43_11 da_uU_L3_43_11 vdd vdd PMIR W=60u L=1u
Mt_uU_L3_43_12 ts_uU_L3_43_12 hv_L2_35 0 0 NMIR W=48.0u L=1u
Mo1_uU_L3_43_12 da_uU_L3_43_12 d1bar_L3 ts_uU_L3_43_12 0 NMIR W=20u L=1u
Mo2_uU_L3_43_12 gp_3_43_12 dpre_L3_43 ts_uU_L3_43_12 0 NMIR W=20u L=1u
Mo3_uU_L3_43_12 da_uU_L3_43_12 da_uU_L3_43_12 vdd vdd PMIR W=60u L=1u
Mo4_uU_L3_43_12 gp_3_43_12 da_uU_L3_43_12 vdd vdd PMIR W=60u L=1u
Mt_uU_L3_43_13 ts_uU_L3_43_13 hv_L2_37 0 0 NMIR W=48.0u L=1u
Mo1_uU_L3_43_13 da_uU_L3_43_13 d1bar_L3 ts_uU_L3_43_13 0 NMIR W=20u L=1u
Mo2_uU_L3_43_13 gp_3_43_13 dpre_L3_43 ts_uU_L3_43_13 0 NMIR W=20u L=1u
Mo3_uU_L3_43_13 da_uU_L3_43_13 da_uU_L3_43_13 vdd vdd PMIR W=60u L=1u
Mo4_uU_L3_43_13 gp_3_43_13 da_uU_L3_43_13 vdd vdd PMIR W=60u L=1u
Mt_uU_L3_43_14 ts_uU_L3_43_14 hv_L2_40 0 0 NMIR W=48.0u L=1u
Mo1_uU_L3_43_14 da_uU_L3_43_14 d1bar_L3 ts_uU_L3_43_14 0 NMIR W=20u L=1u
Mo2_uU_L3_43_14 gp_3_43_14 dpre_L3_43 ts_uU_L3_43_14 0 NMIR W=20u L=1u
Mo3_uU_L3_43_14 da_uU_L3_43_14 da_uU_L3_43_14 vdd vdd PMIR W=60u L=1u
Mo4_uU_L3_43_14 gp_3_43_14 da_uU_L3_43_14 vdd vdd PMIR W=60u L=1u
Mt_uU_L3_43_15 ts_uU_L3_43_15 hv_L2_43 0 0 NMIR W=48.0u L=1u
Mo1_uU_L3_43_15 da_uU_L3_43_15 d1bar_L3 ts_uU_L3_43_15 0 NMIR W=20u L=1u
Mo2_uU_L3_43_15 gp_3_43_15 dpre_L3_43 ts_uU_L3_43_15 0 NMIR W=20u L=1u
Mo3_uU_L3_43_15 da_uU_L3_43_15 da_uU_L3_43_15 vdd vdd PMIR W=60u L=1u
Mo4_uU_L3_43_15 gp_3_43_15 da_uU_L3_43_15 vdd vdd PMIR W=60u L=1u
Mt_uU_L3_44_0 ts_uU_L3_44_0 hv_L2_0 0 0 NMIR W=48.0u L=1u
Mo1_uU_L3_44_0 da_uU_L3_44_0 d1bar_L3 ts_uU_L3_44_0 0 NMIR W=20u L=1u
Mo2_uU_L3_44_0 gp_3_44_0 dpre_L3_44 ts_uU_L3_44_0 0 NMIR W=20u L=1u
Mo3_uU_L3_44_0 da_uU_L3_44_0 da_uU_L3_44_0 vdd vdd PMIR W=60u L=1u
Mo4_uU_L3_44_0 gp_3_44_0 da_uU_L3_44_0 vdd vdd PMIR W=60u L=1u
Mt_uU_L3_44_1 ts_uU_L3_44_1 hv_L2_3 0 0 NMIR W=48.0u L=1u
Mo1_uU_L3_44_1 da_uU_L3_44_1 d1bar_L3 ts_uU_L3_44_1 0 NMIR W=20u L=1u
Mo2_uU_L3_44_1 gp_3_44_1 dpre_L3_44 ts_uU_L3_44_1 0 NMIR W=20u L=1u
Mo3_uU_L3_44_1 da_uU_L3_44_1 da_uU_L3_44_1 vdd vdd PMIR W=60u L=1u
Mo4_uU_L3_44_1 gp_3_44_1 da_uU_L3_44_1 vdd vdd PMIR W=60u L=1u
Mt_uU_L3_44_2 ts_uU_L3_44_2 hv_L2_11 0 0 NMIR W=48.0u L=1u
Mo1_uU_L3_44_2 da_uU_L3_44_2 d1bar_L3 ts_uU_L3_44_2 0 NMIR W=20u L=1u
Mo2_uU_L3_44_2 gp_3_44_2 dpre_L3_44 ts_uU_L3_44_2 0 NMIR W=20u L=1u
Mo3_uU_L3_44_2 da_uU_L3_44_2 da_uU_L3_44_2 vdd vdd PMIR W=60u L=1u
Mo4_uU_L3_44_2 gp_3_44_2 da_uU_L3_44_2 vdd vdd PMIR W=60u L=1u
Mt_uU_L3_44_3 ts_uU_L3_44_3 hv_L2_16 0 0 NMIR W=48.0u L=1u
Mo1_uU_L3_44_3 da_uU_L3_44_3 d1bar_L3 ts_uU_L3_44_3 0 NMIR W=20u L=1u
Mo2_uU_L3_44_3 gp_3_44_3 dpre_L3_44 ts_uU_L3_44_3 0 NMIR W=20u L=1u
Mo3_uU_L3_44_3 da_uU_L3_44_3 da_uU_L3_44_3 vdd vdd PMIR W=60u L=1u
Mo4_uU_L3_44_3 gp_3_44_3 da_uU_L3_44_3 vdd vdd PMIR W=60u L=1u
Mt_uU_L3_44_4 ts_uU_L3_44_4 hv_L2_19 0 0 NMIR W=48.0u L=1u
Mo1_uU_L3_44_4 da_uU_L3_44_4 d1bar_L3 ts_uU_L3_44_4 0 NMIR W=20u L=1u
Mo2_uU_L3_44_4 gp_3_44_4 dpre_L3_44 ts_uU_L3_44_4 0 NMIR W=20u L=1u
Mo3_uU_L3_44_4 da_uU_L3_44_4 da_uU_L3_44_4 vdd vdd PMIR W=60u L=1u
Mo4_uU_L3_44_4 gp_3_44_4 da_uU_L3_44_4 vdd vdd PMIR W=60u L=1u
Mt_uU_L3_44_5 ts_uU_L3_44_5 hv_L2_23 0 0 NMIR W=48.0u L=1u
Mo1_uU_L3_44_5 da_uU_L3_44_5 d1bar_L3 ts_uU_L3_44_5 0 NMIR W=20u L=1u
Mo2_uU_L3_44_5 gp_3_44_5 dpre_L3_44 ts_uU_L3_44_5 0 NMIR W=20u L=1u
Mo3_uU_L3_44_5 da_uU_L3_44_5 da_uU_L3_44_5 vdd vdd PMIR W=60u L=1u
Mo4_uU_L3_44_5 gp_3_44_5 da_uU_L3_44_5 vdd vdd PMIR W=60u L=1u
Mt_uU_L3_44_6 ts_uU_L3_44_6 hv_L2_25 0 0 NMIR W=48.0u L=1u
Mo1_uU_L3_44_6 da_uU_L3_44_6 d1bar_L3 ts_uU_L3_44_6 0 NMIR W=20u L=1u
Mo2_uU_L3_44_6 gp_3_44_6 dpre_L3_44 ts_uU_L3_44_6 0 NMIR W=20u L=1u
Mo3_uU_L3_44_6 da_uU_L3_44_6 da_uU_L3_44_6 vdd vdd PMIR W=60u L=1u
Mo4_uU_L3_44_6 gp_3_44_6 da_uU_L3_44_6 vdd vdd PMIR W=60u L=1u
Mt_uU_L3_44_7 ts_uU_L3_44_7 hv_L2_29 0 0 NMIR W=48.0u L=1u
Mo1_uU_L3_44_7 da_uU_L3_44_7 d1bar_L3 ts_uU_L3_44_7 0 NMIR W=20u L=1u
Mo2_uU_L3_44_7 gp_3_44_7 dpre_L3_44 ts_uU_L3_44_7 0 NMIR W=20u L=1u
Mo3_uU_L3_44_7 da_uU_L3_44_7 da_uU_L3_44_7 vdd vdd PMIR W=60u L=1u
Mo4_uU_L3_44_7 gp_3_44_7 da_uU_L3_44_7 vdd vdd PMIR W=60u L=1u
Mt_uU_L3_44_8 ts_uU_L3_44_8 hv_L2_32 0 0 NMIR W=48.0u L=1u
Mo1_uU_L3_44_8 da_uU_L3_44_8 d1bar_L3 ts_uU_L3_44_8 0 NMIR W=20u L=1u
Mo2_uU_L3_44_8 gp_3_44_8 dpre_L3_44 ts_uU_L3_44_8 0 NMIR W=20u L=1u
Mo3_uU_L3_44_8 da_uU_L3_44_8 da_uU_L3_44_8 vdd vdd PMIR W=60u L=1u
Mo4_uU_L3_44_8 gp_3_44_8 da_uU_L3_44_8 vdd vdd PMIR W=60u L=1u
Mt_uU_L3_44_9 ts_uU_L3_44_9 hv_L2_33 0 0 NMIR W=48.0u L=1u
Mo1_uU_L3_44_9 da_uU_L3_44_9 d1bar_L3 ts_uU_L3_44_9 0 NMIR W=20u L=1u
Mo2_uU_L3_44_9 gp_3_44_9 dpre_L3_44 ts_uU_L3_44_9 0 NMIR W=20u L=1u
Mo3_uU_L3_44_9 da_uU_L3_44_9 da_uU_L3_44_9 vdd vdd PMIR W=60u L=1u
Mo4_uU_L3_44_9 gp_3_44_9 da_uU_L3_44_9 vdd vdd PMIR W=60u L=1u
Mt_uU_L3_44_10 ts_uU_L3_44_10 hv_L2_35 0 0 NMIR W=48.0u L=1u
Mo1_uU_L3_44_10 da_uU_L3_44_10 d1bar_L3 ts_uU_L3_44_10 0 NMIR W=20u L=1u
Mo2_uU_L3_44_10 gp_3_44_10 dpre_L3_44 ts_uU_L3_44_10 0 NMIR W=20u L=1u
Mo3_uU_L3_44_10 da_uU_L3_44_10 da_uU_L3_44_10 vdd vdd PMIR W=60u L=1u
Mo4_uU_L3_44_10 gp_3_44_10 da_uU_L3_44_10 vdd vdd PMIR W=60u L=1u
Mt_uU_L3_44_11 ts_uU_L3_44_11 hv_L2_36 0 0 NMIR W=48.0u L=1u
Mo1_uU_L3_44_11 da_uU_L3_44_11 d1bar_L3 ts_uU_L3_44_11 0 NMIR W=20u L=1u
Mo2_uU_L3_44_11 gp_3_44_11 dpre_L3_44 ts_uU_L3_44_11 0 NMIR W=20u L=1u
Mo3_uU_L3_44_11 da_uU_L3_44_11 da_uU_L3_44_11 vdd vdd PMIR W=60u L=1u
Mo4_uU_L3_44_11 gp_3_44_11 da_uU_L3_44_11 vdd vdd PMIR W=60u L=1u
Mt_uU_L3_44_12 ts_uU_L3_44_12 hv_L2_42 0 0 NMIR W=48.0u L=1u
Mo1_uU_L3_44_12 da_uU_L3_44_12 d1bar_L3 ts_uU_L3_44_12 0 NMIR W=20u L=1u
Mo2_uU_L3_44_12 gp_3_44_12 dpre_L3_44 ts_uU_L3_44_12 0 NMIR W=20u L=1u
Mo3_uU_L3_44_12 da_uU_L3_44_12 da_uU_L3_44_12 vdd vdd PMIR W=60u L=1u
Mo4_uU_L3_44_12 gp_3_44_12 da_uU_L3_44_12 vdd vdd PMIR W=60u L=1u
Mt_uU_L3_44_13 ts_uU_L3_44_13 hv_L2_43 0 0 NMIR W=48.0u L=1u
Mo1_uU_L3_44_13 da_uU_L3_44_13 d1bar_L3 ts_uU_L3_44_13 0 NMIR W=20u L=1u
Mo2_uU_L3_44_13 gp_3_44_13 dpre_L3_44 ts_uU_L3_44_13 0 NMIR W=20u L=1u
Mo3_uU_L3_44_13 da_uU_L3_44_13 da_uU_L3_44_13 vdd vdd PMIR W=60u L=1u
Mo4_uU_L3_44_13 gp_3_44_13 da_uU_L3_44_13 vdd vdd PMIR W=60u L=1u
Mt_uU_L3_44_14 ts_uU_L3_44_14 hv_L2_44 0 0 NMIR W=48.0u L=1u
Mo1_uU_L3_44_14 da_uU_L3_44_14 d1bar_L3 ts_uU_L3_44_14 0 NMIR W=20u L=1u
Mo2_uU_L3_44_14 gp_3_44_14 dpre_L3_44 ts_uU_L3_44_14 0 NMIR W=20u L=1u
Mo3_uU_L3_44_14 da_uU_L3_44_14 da_uU_L3_44_14 vdd vdd PMIR W=60u L=1u
Mo4_uU_L3_44_14 gp_3_44_14 da_uU_L3_44_14 vdd vdd PMIR W=60u L=1u
Mt_uU_L3_44_15 ts_uU_L3_44_15 hv_L2_46 0 0 NMIR W=48.0u L=1u
Mo1_uU_L3_44_15 da_uU_L3_44_15 d1bar_L3 ts_uU_L3_44_15 0 NMIR W=20u L=1u
Mo2_uU_L3_44_15 gp_3_44_15 dpre_L3_44 ts_uU_L3_44_15 0 NMIR W=20u L=1u
Mo3_uU_L3_44_15 da_uU_L3_44_15 da_uU_L3_44_15 vdd vdd PMIR W=60u L=1u
Mo4_uU_L3_44_15 gp_3_44_15 da_uU_L3_44_15 vdd vdd PMIR W=60u L=1u
Mt_uU_L3_45_0 ts_uU_L3_45_0 hv_L2_0 0 0 NMIR W=48.0u L=1u
Mo1_uU_L3_45_0 da_uU_L3_45_0 d1bar_L3 ts_uU_L3_45_0 0 NMIR W=20u L=1u
Mo2_uU_L3_45_0 gp_3_45_0 dpre_L3_45 ts_uU_L3_45_0 0 NMIR W=20u L=1u
Mo3_uU_L3_45_0 da_uU_L3_45_0 da_uU_L3_45_0 vdd vdd PMIR W=60u L=1u
Mo4_uU_L3_45_0 gp_3_45_0 da_uU_L3_45_0 vdd vdd PMIR W=60u L=1u
Mt_uU_L3_45_1 ts_uU_L3_45_1 hv_L2_2 0 0 NMIR W=48.0u L=1u
Mo1_uU_L3_45_1 da_uU_L3_45_1 d1bar_L3 ts_uU_L3_45_1 0 NMIR W=20u L=1u
Mo2_uU_L3_45_1 gp_3_45_1 dpre_L3_45 ts_uU_L3_45_1 0 NMIR W=20u L=1u
Mo3_uU_L3_45_1 da_uU_L3_45_1 da_uU_L3_45_1 vdd vdd PMIR W=60u L=1u
Mo4_uU_L3_45_1 gp_3_45_1 da_uU_L3_45_1 vdd vdd PMIR W=60u L=1u
Mt_uU_L3_45_2 ts_uU_L3_45_2 hv_L2_4 0 0 NMIR W=48.0u L=1u
Mo1_uU_L3_45_2 da_uU_L3_45_2 d1bar_L3 ts_uU_L3_45_2 0 NMIR W=20u L=1u
Mo2_uU_L3_45_2 gp_3_45_2 dpre_L3_45 ts_uU_L3_45_2 0 NMIR W=20u L=1u
Mo3_uU_L3_45_2 da_uU_L3_45_2 da_uU_L3_45_2 vdd vdd PMIR W=60u L=1u
Mo4_uU_L3_45_2 gp_3_45_2 da_uU_L3_45_2 vdd vdd PMIR W=60u L=1u
Mt_uU_L3_45_3 ts_uU_L3_45_3 hv_L2_5 0 0 NMIR W=48.0u L=1u
Mo1_uU_L3_45_3 da_uU_L3_45_3 d1bar_L3 ts_uU_L3_45_3 0 NMIR W=20u L=1u
Mo2_uU_L3_45_3 gp_3_45_3 dpre_L3_45 ts_uU_L3_45_3 0 NMIR W=20u L=1u
Mo3_uU_L3_45_3 da_uU_L3_45_3 da_uU_L3_45_3 vdd vdd PMIR W=60u L=1u
Mo4_uU_L3_45_3 gp_3_45_3 da_uU_L3_45_3 vdd vdd PMIR W=60u L=1u
Mt_uU_L3_45_4 ts_uU_L3_45_4 hv_L2_7 0 0 NMIR W=48.0u L=1u
Mo1_uU_L3_45_4 da_uU_L3_45_4 d1bar_L3 ts_uU_L3_45_4 0 NMIR W=20u L=1u
Mo2_uU_L3_45_4 gp_3_45_4 dpre_L3_45 ts_uU_L3_45_4 0 NMIR W=20u L=1u
Mo3_uU_L3_45_4 da_uU_L3_45_4 da_uU_L3_45_4 vdd vdd PMIR W=60u L=1u
Mo4_uU_L3_45_4 gp_3_45_4 da_uU_L3_45_4 vdd vdd PMIR W=60u L=1u
Mt_uU_L3_45_5 ts_uU_L3_45_5 hv_L2_12 0 0 NMIR W=48.0u L=1u
Mo1_uU_L3_45_5 da_uU_L3_45_5 d1bar_L3 ts_uU_L3_45_5 0 NMIR W=20u L=1u
Mo2_uU_L3_45_5 gp_3_45_5 dpre_L3_45 ts_uU_L3_45_5 0 NMIR W=20u L=1u
Mo3_uU_L3_45_5 da_uU_L3_45_5 da_uU_L3_45_5 vdd vdd PMIR W=60u L=1u
Mo4_uU_L3_45_5 gp_3_45_5 da_uU_L3_45_5 vdd vdd PMIR W=60u L=1u
Mt_uU_L3_45_6 ts_uU_L3_45_6 hv_L2_16 0 0 NMIR W=48.0u L=1u
Mo1_uU_L3_45_6 da_uU_L3_45_6 d1bar_L3 ts_uU_L3_45_6 0 NMIR W=20u L=1u
Mo2_uU_L3_45_6 gp_3_45_6 dpre_L3_45 ts_uU_L3_45_6 0 NMIR W=20u L=1u
Mo3_uU_L3_45_6 da_uU_L3_45_6 da_uU_L3_45_6 vdd vdd PMIR W=60u L=1u
Mo4_uU_L3_45_6 gp_3_45_6 da_uU_L3_45_6 vdd vdd PMIR W=60u L=1u
Mt_uU_L3_45_7 ts_uU_L3_45_7 hv_L2_23 0 0 NMIR W=48.0u L=1u
Mo1_uU_L3_45_7 da_uU_L3_45_7 d1bar_L3 ts_uU_L3_45_7 0 NMIR W=20u L=1u
Mo2_uU_L3_45_7 gp_3_45_7 dpre_L3_45 ts_uU_L3_45_7 0 NMIR W=20u L=1u
Mo3_uU_L3_45_7 da_uU_L3_45_7 da_uU_L3_45_7 vdd vdd PMIR W=60u L=1u
Mo4_uU_L3_45_7 gp_3_45_7 da_uU_L3_45_7 vdd vdd PMIR W=60u L=1u
Mt_uU_L3_45_8 ts_uU_L3_45_8 hv_L2_26 0 0 NMIR W=48.0u L=1u
Mo1_uU_L3_45_8 da_uU_L3_45_8 d1bar_L3 ts_uU_L3_45_8 0 NMIR W=20u L=1u
Mo2_uU_L3_45_8 gp_3_45_8 dpre_L3_45 ts_uU_L3_45_8 0 NMIR W=20u L=1u
Mo3_uU_L3_45_8 da_uU_L3_45_8 da_uU_L3_45_8 vdd vdd PMIR W=60u L=1u
Mo4_uU_L3_45_8 gp_3_45_8 da_uU_L3_45_8 vdd vdd PMIR W=60u L=1u
Mt_uU_L3_45_9 ts_uU_L3_45_9 hv_L2_35 0 0 NMIR W=48.0u L=1u
Mo1_uU_L3_45_9 da_uU_L3_45_9 d1bar_L3 ts_uU_L3_45_9 0 NMIR W=20u L=1u
Mo2_uU_L3_45_9 gp_3_45_9 dpre_L3_45 ts_uU_L3_45_9 0 NMIR W=20u L=1u
Mo3_uU_L3_45_9 da_uU_L3_45_9 da_uU_L3_45_9 vdd vdd PMIR W=60u L=1u
Mo4_uU_L3_45_9 gp_3_45_9 da_uU_L3_45_9 vdd vdd PMIR W=60u L=1u
Mt_uU_L3_45_10 ts_uU_L3_45_10 hv_L2_36 0 0 NMIR W=48.0u L=1u
Mo1_uU_L3_45_10 da_uU_L3_45_10 d1bar_L3 ts_uU_L3_45_10 0 NMIR W=20u L=1u
Mo2_uU_L3_45_10 gp_3_45_10 dpre_L3_45 ts_uU_L3_45_10 0 NMIR W=20u L=1u
Mo3_uU_L3_45_10 da_uU_L3_45_10 da_uU_L3_45_10 vdd vdd PMIR W=60u L=1u
Mo4_uU_L3_45_10 gp_3_45_10 da_uU_L3_45_10 vdd vdd PMIR W=60u L=1u
Mt_uU_L3_45_11 ts_uU_L3_45_11 hv_L2_40 0 0 NMIR W=48.0u L=1u
Mo1_uU_L3_45_11 da_uU_L3_45_11 d1bar_L3 ts_uU_L3_45_11 0 NMIR W=20u L=1u
Mo2_uU_L3_45_11 gp_3_45_11 dpre_L3_45 ts_uU_L3_45_11 0 NMIR W=20u L=1u
Mo3_uU_L3_45_11 da_uU_L3_45_11 da_uU_L3_45_11 vdd vdd PMIR W=60u L=1u
Mo4_uU_L3_45_11 gp_3_45_11 da_uU_L3_45_11 vdd vdd PMIR W=60u L=1u
Mt_uU_L3_45_12 ts_uU_L3_45_12 hv_L2_41 0 0 NMIR W=48.0u L=1u
Mo1_uU_L3_45_12 da_uU_L3_45_12 d1bar_L3 ts_uU_L3_45_12 0 NMIR W=20u L=1u
Mo2_uU_L3_45_12 gp_3_45_12 dpre_L3_45 ts_uU_L3_45_12 0 NMIR W=20u L=1u
Mo3_uU_L3_45_12 da_uU_L3_45_12 da_uU_L3_45_12 vdd vdd PMIR W=60u L=1u
Mo4_uU_L3_45_12 gp_3_45_12 da_uU_L3_45_12 vdd vdd PMIR W=60u L=1u
Mt_uU_L3_45_13 ts_uU_L3_45_13 hv_L2_44 0 0 NMIR W=48.0u L=1u
Mo1_uU_L3_45_13 da_uU_L3_45_13 d1bar_L3 ts_uU_L3_45_13 0 NMIR W=20u L=1u
Mo2_uU_L3_45_13 gp_3_45_13 dpre_L3_45 ts_uU_L3_45_13 0 NMIR W=20u L=1u
Mo3_uU_L3_45_13 da_uU_L3_45_13 da_uU_L3_45_13 vdd vdd PMIR W=60u L=1u
Mo4_uU_L3_45_13 gp_3_45_13 da_uU_L3_45_13 vdd vdd PMIR W=60u L=1u
Mt_uU_L3_45_14 ts_uU_L3_45_14 hv_L2_46 0 0 NMIR W=48.0u L=1u
Mo1_uU_L3_45_14 da_uU_L3_45_14 d1bar_L3 ts_uU_L3_45_14 0 NMIR W=20u L=1u
Mo2_uU_L3_45_14 gp_3_45_14 dpre_L3_45 ts_uU_L3_45_14 0 NMIR W=20u L=1u
Mo3_uU_L3_45_14 da_uU_L3_45_14 da_uU_L3_45_14 vdd vdd PMIR W=60u L=1u
Mo4_uU_L3_45_14 gp_3_45_14 da_uU_L3_45_14 vdd vdd PMIR W=60u L=1u
Mt_uU_L3_45_15 ts_uU_L3_45_15 hv_L2_47 0 0 NMIR W=48.0u L=1u
Mo1_uU_L3_45_15 da_uU_L3_45_15 d1bar_L3 ts_uU_L3_45_15 0 NMIR W=20u L=1u
Mo2_uU_L3_45_15 gp_3_45_15 dpre_L3_45 ts_uU_L3_45_15 0 NMIR W=20u L=1u
Mo3_uU_L3_45_15 da_uU_L3_45_15 da_uU_L3_45_15 vdd vdd PMIR W=60u L=1u
Mo4_uU_L3_45_15 gp_3_45_15 da_uU_L3_45_15 vdd vdd PMIR W=60u L=1u
Mt_uU_L3_46_0 ts_uU_L3_46_0 hv_L2_1 0 0 NMIR W=48.0u L=1u
Mo1_uU_L3_46_0 da_uU_L3_46_0 d1bar_L3 ts_uU_L3_46_0 0 NMIR W=20u L=1u
Mo2_uU_L3_46_0 gp_3_46_0 dpre_L3_46 ts_uU_L3_46_0 0 NMIR W=20u L=1u
Mo3_uU_L3_46_0 da_uU_L3_46_0 da_uU_L3_46_0 vdd vdd PMIR W=60u L=1u
Mo4_uU_L3_46_0 gp_3_46_0 da_uU_L3_46_0 vdd vdd PMIR W=60u L=1u
Mt_uU_L3_46_1 ts_uU_L3_46_1 hv_L2_2 0 0 NMIR W=48.0u L=1u
Mo1_uU_L3_46_1 da_uU_L3_46_1 d1bar_L3 ts_uU_L3_46_1 0 NMIR W=20u L=1u
Mo2_uU_L3_46_1 gp_3_46_1 dpre_L3_46 ts_uU_L3_46_1 0 NMIR W=20u L=1u
Mo3_uU_L3_46_1 da_uU_L3_46_1 da_uU_L3_46_1 vdd vdd PMIR W=60u L=1u
Mo4_uU_L3_46_1 gp_3_46_1 da_uU_L3_46_1 vdd vdd PMIR W=60u L=1u
Mt_uU_L3_46_2 ts_uU_L3_46_2 hv_L2_4 0 0 NMIR W=48.0u L=1u
Mo1_uU_L3_46_2 da_uU_L3_46_2 d1bar_L3 ts_uU_L3_46_2 0 NMIR W=20u L=1u
Mo2_uU_L3_46_2 gp_3_46_2 dpre_L3_46 ts_uU_L3_46_2 0 NMIR W=20u L=1u
Mo3_uU_L3_46_2 da_uU_L3_46_2 da_uU_L3_46_2 vdd vdd PMIR W=60u L=1u
Mo4_uU_L3_46_2 gp_3_46_2 da_uU_L3_46_2 vdd vdd PMIR W=60u L=1u
Mt_uU_L3_46_3 ts_uU_L3_46_3 hv_L2_5 0 0 NMIR W=48.0u L=1u
Mo1_uU_L3_46_3 da_uU_L3_46_3 d1bar_L3 ts_uU_L3_46_3 0 NMIR W=20u L=1u
Mo2_uU_L3_46_3 gp_3_46_3 dpre_L3_46 ts_uU_L3_46_3 0 NMIR W=20u L=1u
Mo3_uU_L3_46_3 da_uU_L3_46_3 da_uU_L3_46_3 vdd vdd PMIR W=60u L=1u
Mo4_uU_L3_46_3 gp_3_46_3 da_uU_L3_46_3 vdd vdd PMIR W=60u L=1u
Mt_uU_L3_46_4 ts_uU_L3_46_4 hv_L2_8 0 0 NMIR W=48.0u L=1u
Mo1_uU_L3_46_4 da_uU_L3_46_4 d1bar_L3 ts_uU_L3_46_4 0 NMIR W=20u L=1u
Mo2_uU_L3_46_4 gp_3_46_4 dpre_L3_46 ts_uU_L3_46_4 0 NMIR W=20u L=1u
Mo3_uU_L3_46_4 da_uU_L3_46_4 da_uU_L3_46_4 vdd vdd PMIR W=60u L=1u
Mo4_uU_L3_46_4 gp_3_46_4 da_uU_L3_46_4 vdd vdd PMIR W=60u L=1u
Mt_uU_L3_46_5 ts_uU_L3_46_5 hv_L2_20 0 0 NMIR W=48.0u L=1u
Mo1_uU_L3_46_5 da_uU_L3_46_5 d1bar_L3 ts_uU_L3_46_5 0 NMIR W=20u L=1u
Mo2_uU_L3_46_5 gp_3_46_5 dpre_L3_46 ts_uU_L3_46_5 0 NMIR W=20u L=1u
Mo3_uU_L3_46_5 da_uU_L3_46_5 da_uU_L3_46_5 vdd vdd PMIR W=60u L=1u
Mo4_uU_L3_46_5 gp_3_46_5 da_uU_L3_46_5 vdd vdd PMIR W=60u L=1u
Mt_uU_L3_46_6 ts_uU_L3_46_6 hv_L2_22 0 0 NMIR W=48.0u L=1u
Mo1_uU_L3_46_6 da_uU_L3_46_6 d1bar_L3 ts_uU_L3_46_6 0 NMIR W=20u L=1u
Mo2_uU_L3_46_6 gp_3_46_6 dpre_L3_46 ts_uU_L3_46_6 0 NMIR W=20u L=1u
Mo3_uU_L3_46_6 da_uU_L3_46_6 da_uU_L3_46_6 vdd vdd PMIR W=60u L=1u
Mo4_uU_L3_46_6 gp_3_46_6 da_uU_L3_46_6 vdd vdd PMIR W=60u L=1u
Mt_uU_L3_46_7 ts_uU_L3_46_7 hv_L2_25 0 0 NMIR W=48.0u L=1u
Mo1_uU_L3_46_7 da_uU_L3_46_7 d1bar_L3 ts_uU_L3_46_7 0 NMIR W=20u L=1u
Mo2_uU_L3_46_7 gp_3_46_7 dpre_L3_46 ts_uU_L3_46_7 0 NMIR W=20u L=1u
Mo3_uU_L3_46_7 da_uU_L3_46_7 da_uU_L3_46_7 vdd vdd PMIR W=60u L=1u
Mo4_uU_L3_46_7 gp_3_46_7 da_uU_L3_46_7 vdd vdd PMIR W=60u L=1u
Mt_uU_L3_46_8 ts_uU_L3_46_8 hv_L2_26 0 0 NMIR W=48.0u L=1u
Mo1_uU_L3_46_8 da_uU_L3_46_8 d1bar_L3 ts_uU_L3_46_8 0 NMIR W=20u L=1u
Mo2_uU_L3_46_8 gp_3_46_8 dpre_L3_46 ts_uU_L3_46_8 0 NMIR W=20u L=1u
Mo3_uU_L3_46_8 da_uU_L3_46_8 da_uU_L3_46_8 vdd vdd PMIR W=60u L=1u
Mo4_uU_L3_46_8 gp_3_46_8 da_uU_L3_46_8 vdd vdd PMIR W=60u L=1u
Mt_uU_L3_46_9 ts_uU_L3_46_9 hv_L2_28 0 0 NMIR W=48.0u L=1u
Mo1_uU_L3_46_9 da_uU_L3_46_9 d1bar_L3 ts_uU_L3_46_9 0 NMIR W=20u L=1u
Mo2_uU_L3_46_9 gp_3_46_9 dpre_L3_46 ts_uU_L3_46_9 0 NMIR W=20u L=1u
Mo3_uU_L3_46_9 da_uU_L3_46_9 da_uU_L3_46_9 vdd vdd PMIR W=60u L=1u
Mo4_uU_L3_46_9 gp_3_46_9 da_uU_L3_46_9 vdd vdd PMIR W=60u L=1u
Mt_uU_L3_46_10 ts_uU_L3_46_10 hv_L2_30 0 0 NMIR W=48.0u L=1u
Mo1_uU_L3_46_10 da_uU_L3_46_10 d1bar_L3 ts_uU_L3_46_10 0 NMIR W=20u L=1u
Mo2_uU_L3_46_10 gp_3_46_10 dpre_L3_46 ts_uU_L3_46_10 0 NMIR W=20u L=1u
Mo3_uU_L3_46_10 da_uU_L3_46_10 da_uU_L3_46_10 vdd vdd PMIR W=60u L=1u
Mo4_uU_L3_46_10 gp_3_46_10 da_uU_L3_46_10 vdd vdd PMIR W=60u L=1u
Mt_uU_L3_46_11 ts_uU_L3_46_11 hv_L2_35 0 0 NMIR W=48.0u L=1u
Mo1_uU_L3_46_11 da_uU_L3_46_11 d1bar_L3 ts_uU_L3_46_11 0 NMIR W=20u L=1u
Mo2_uU_L3_46_11 gp_3_46_11 dpre_L3_46 ts_uU_L3_46_11 0 NMIR W=20u L=1u
Mo3_uU_L3_46_11 da_uU_L3_46_11 da_uU_L3_46_11 vdd vdd PMIR W=60u L=1u
Mo4_uU_L3_46_11 gp_3_46_11 da_uU_L3_46_11 vdd vdd PMIR W=60u L=1u
Mt_uU_L3_46_12 ts_uU_L3_46_12 hv_L2_36 0 0 NMIR W=48.0u L=1u
Mo1_uU_L3_46_12 da_uU_L3_46_12 d1bar_L3 ts_uU_L3_46_12 0 NMIR W=20u L=1u
Mo2_uU_L3_46_12 gp_3_46_12 dpre_L3_46 ts_uU_L3_46_12 0 NMIR W=20u L=1u
Mo3_uU_L3_46_12 da_uU_L3_46_12 da_uU_L3_46_12 vdd vdd PMIR W=60u L=1u
Mo4_uU_L3_46_12 gp_3_46_12 da_uU_L3_46_12 vdd vdd PMIR W=60u L=1u
Mt_uU_L3_46_13 ts_uU_L3_46_13 hv_L2_38 0 0 NMIR W=48.0u L=1u
Mo1_uU_L3_46_13 da_uU_L3_46_13 d1bar_L3 ts_uU_L3_46_13 0 NMIR W=20u L=1u
Mo2_uU_L3_46_13 gp_3_46_13 dpre_L3_46 ts_uU_L3_46_13 0 NMIR W=20u L=1u
Mo3_uU_L3_46_13 da_uU_L3_46_13 da_uU_L3_46_13 vdd vdd PMIR W=60u L=1u
Mo4_uU_L3_46_13 gp_3_46_13 da_uU_L3_46_13 vdd vdd PMIR W=60u L=1u
Mt_uU_L3_46_14 ts_uU_L3_46_14 hv_L2_42 0 0 NMIR W=48.0u L=1u
Mo1_uU_L3_46_14 da_uU_L3_46_14 d1bar_L3 ts_uU_L3_46_14 0 NMIR W=20u L=1u
Mo2_uU_L3_46_14 gp_3_46_14 dpre_L3_46 ts_uU_L3_46_14 0 NMIR W=20u L=1u
Mo3_uU_L3_46_14 da_uU_L3_46_14 da_uU_L3_46_14 vdd vdd PMIR W=60u L=1u
Mo4_uU_L3_46_14 gp_3_46_14 da_uU_L3_46_14 vdd vdd PMIR W=60u L=1u
Mt_uU_L3_46_15 ts_uU_L3_46_15 hv_L2_46 0 0 NMIR W=48.0u L=1u
Mo1_uU_L3_46_15 da_uU_L3_46_15 d1bar_L3 ts_uU_L3_46_15 0 NMIR W=20u L=1u
Mo2_uU_L3_46_15 gp_3_46_15 dpre_L3_46 ts_uU_L3_46_15 0 NMIR W=20u L=1u
Mo3_uU_L3_46_15 da_uU_L3_46_15 da_uU_L3_46_15 vdd vdd PMIR W=60u L=1u
Mo4_uU_L3_46_15 gp_3_46_15 da_uU_L3_46_15 vdd vdd PMIR W=60u L=1u
Mt_uU_L3_47_0 ts_uU_L3_47_0 hv_L2_1 0 0 NMIR W=48.0u L=1u
Mo1_uU_L3_47_0 da_uU_L3_47_0 d1bar_L3 ts_uU_L3_47_0 0 NMIR W=20u L=1u
Mo2_uU_L3_47_0 gp_3_47_0 dpre_L3_47 ts_uU_L3_47_0 0 NMIR W=20u L=1u
Mo3_uU_L3_47_0 da_uU_L3_47_0 da_uU_L3_47_0 vdd vdd PMIR W=60u L=1u
Mo4_uU_L3_47_0 gp_3_47_0 da_uU_L3_47_0 vdd vdd PMIR W=60u L=1u
Mt_uU_L3_47_1 ts_uU_L3_47_1 hv_L2_4 0 0 NMIR W=48.0u L=1u
Mo1_uU_L3_47_1 da_uU_L3_47_1 d1bar_L3 ts_uU_L3_47_1 0 NMIR W=20u L=1u
Mo2_uU_L3_47_1 gp_3_47_1 dpre_L3_47 ts_uU_L3_47_1 0 NMIR W=20u L=1u
Mo3_uU_L3_47_1 da_uU_L3_47_1 da_uU_L3_47_1 vdd vdd PMIR W=60u L=1u
Mo4_uU_L3_47_1 gp_3_47_1 da_uU_L3_47_1 vdd vdd PMIR W=60u L=1u
Mt_uU_L3_47_2 ts_uU_L3_47_2 hv_L2_5 0 0 NMIR W=48.0u L=1u
Mo1_uU_L3_47_2 da_uU_L3_47_2 d1bar_L3 ts_uU_L3_47_2 0 NMIR W=20u L=1u
Mo2_uU_L3_47_2 gp_3_47_2 dpre_L3_47 ts_uU_L3_47_2 0 NMIR W=20u L=1u
Mo3_uU_L3_47_2 da_uU_L3_47_2 da_uU_L3_47_2 vdd vdd PMIR W=60u L=1u
Mo4_uU_L3_47_2 gp_3_47_2 da_uU_L3_47_2 vdd vdd PMIR W=60u L=1u
Mt_uU_L3_47_3 ts_uU_L3_47_3 hv_L2_13 0 0 NMIR W=48.0u L=1u
Mo1_uU_L3_47_3 da_uU_L3_47_3 d1bar_L3 ts_uU_L3_47_3 0 NMIR W=20u L=1u
Mo2_uU_L3_47_3 gp_3_47_3 dpre_L3_47 ts_uU_L3_47_3 0 NMIR W=20u L=1u
Mo3_uU_L3_47_3 da_uU_L3_47_3 da_uU_L3_47_3 vdd vdd PMIR W=60u L=1u
Mo4_uU_L3_47_3 gp_3_47_3 da_uU_L3_47_3 vdd vdd PMIR W=60u L=1u
Mt_uU_L3_47_4 ts_uU_L3_47_4 hv_L2_14 0 0 NMIR W=48.0u L=1u
Mo1_uU_L3_47_4 da_uU_L3_47_4 d1bar_L3 ts_uU_L3_47_4 0 NMIR W=20u L=1u
Mo2_uU_L3_47_4 gp_3_47_4 dpre_L3_47 ts_uU_L3_47_4 0 NMIR W=20u L=1u
Mo3_uU_L3_47_4 da_uU_L3_47_4 da_uU_L3_47_4 vdd vdd PMIR W=60u L=1u
Mo4_uU_L3_47_4 gp_3_47_4 da_uU_L3_47_4 vdd vdd PMIR W=60u L=1u
Mt_uU_L3_47_5 ts_uU_L3_47_5 hv_L2_15 0 0 NMIR W=48.0u L=1u
Mo1_uU_L3_47_5 da_uU_L3_47_5 d1bar_L3 ts_uU_L3_47_5 0 NMIR W=20u L=1u
Mo2_uU_L3_47_5 gp_3_47_5 dpre_L3_47 ts_uU_L3_47_5 0 NMIR W=20u L=1u
Mo3_uU_L3_47_5 da_uU_L3_47_5 da_uU_L3_47_5 vdd vdd PMIR W=60u L=1u
Mo4_uU_L3_47_5 gp_3_47_5 da_uU_L3_47_5 vdd vdd PMIR W=60u L=1u
Mt_uU_L3_47_6 ts_uU_L3_47_6 hv_L2_16 0 0 NMIR W=48.0u L=1u
Mo1_uU_L3_47_6 da_uU_L3_47_6 d1bar_L3 ts_uU_L3_47_6 0 NMIR W=20u L=1u
Mo2_uU_L3_47_6 gp_3_47_6 dpre_L3_47 ts_uU_L3_47_6 0 NMIR W=20u L=1u
Mo3_uU_L3_47_6 da_uU_L3_47_6 da_uU_L3_47_6 vdd vdd PMIR W=60u L=1u
Mo4_uU_L3_47_6 gp_3_47_6 da_uU_L3_47_6 vdd vdd PMIR W=60u L=1u
Mt_uU_L3_47_7 ts_uU_L3_47_7 hv_L2_19 0 0 NMIR W=48.0u L=1u
Mo1_uU_L3_47_7 da_uU_L3_47_7 d1bar_L3 ts_uU_L3_47_7 0 NMIR W=20u L=1u
Mo2_uU_L3_47_7 gp_3_47_7 dpre_L3_47 ts_uU_L3_47_7 0 NMIR W=20u L=1u
Mo3_uU_L3_47_7 da_uU_L3_47_7 da_uU_L3_47_7 vdd vdd PMIR W=60u L=1u
Mo4_uU_L3_47_7 gp_3_47_7 da_uU_L3_47_7 vdd vdd PMIR W=60u L=1u
Mt_uU_L3_47_8 ts_uU_L3_47_8 hv_L2_23 0 0 NMIR W=48.0u L=1u
Mo1_uU_L3_47_8 da_uU_L3_47_8 d1bar_L3 ts_uU_L3_47_8 0 NMIR W=20u L=1u
Mo2_uU_L3_47_8 gp_3_47_8 dpre_L3_47 ts_uU_L3_47_8 0 NMIR W=20u L=1u
Mo3_uU_L3_47_8 da_uU_L3_47_8 da_uU_L3_47_8 vdd vdd PMIR W=60u L=1u
Mo4_uU_L3_47_8 gp_3_47_8 da_uU_L3_47_8 vdd vdd PMIR W=60u L=1u
Mt_uU_L3_47_9 ts_uU_L3_47_9 hv_L2_31 0 0 NMIR W=48.0u L=1u
Mo1_uU_L3_47_9 da_uU_L3_47_9 d1bar_L3 ts_uU_L3_47_9 0 NMIR W=20u L=1u
Mo2_uU_L3_47_9 gp_3_47_9 dpre_L3_47 ts_uU_L3_47_9 0 NMIR W=20u L=1u
Mo3_uU_L3_47_9 da_uU_L3_47_9 da_uU_L3_47_9 vdd vdd PMIR W=60u L=1u
Mo4_uU_L3_47_9 gp_3_47_9 da_uU_L3_47_9 vdd vdd PMIR W=60u L=1u
Mt_uU_L3_47_10 ts_uU_L3_47_10 hv_L2_32 0 0 NMIR W=48.0u L=1u
Mo1_uU_L3_47_10 da_uU_L3_47_10 d1bar_L3 ts_uU_L3_47_10 0 NMIR W=20u L=1u
Mo2_uU_L3_47_10 gp_3_47_10 dpre_L3_47 ts_uU_L3_47_10 0 NMIR W=20u L=1u
Mo3_uU_L3_47_10 da_uU_L3_47_10 da_uU_L3_47_10 vdd vdd PMIR W=60u L=1u
Mo4_uU_L3_47_10 gp_3_47_10 da_uU_L3_47_10 vdd vdd PMIR W=60u L=1u
Mt_uU_L3_47_11 ts_uU_L3_47_11 hv_L2_33 0 0 NMIR W=48.0u L=1u
Mo1_uU_L3_47_11 da_uU_L3_47_11 d1bar_L3 ts_uU_L3_47_11 0 NMIR W=20u L=1u
Mo2_uU_L3_47_11 gp_3_47_11 dpre_L3_47 ts_uU_L3_47_11 0 NMIR W=20u L=1u
Mo3_uU_L3_47_11 da_uU_L3_47_11 da_uU_L3_47_11 vdd vdd PMIR W=60u L=1u
Mo4_uU_L3_47_11 gp_3_47_11 da_uU_L3_47_11 vdd vdd PMIR W=60u L=1u
Mt_uU_L3_47_12 ts_uU_L3_47_12 hv_L2_36 0 0 NMIR W=48.0u L=1u
Mo1_uU_L3_47_12 da_uU_L3_47_12 d1bar_L3 ts_uU_L3_47_12 0 NMIR W=20u L=1u
Mo2_uU_L3_47_12 gp_3_47_12 dpre_L3_47 ts_uU_L3_47_12 0 NMIR W=20u L=1u
Mo3_uU_L3_47_12 da_uU_L3_47_12 da_uU_L3_47_12 vdd vdd PMIR W=60u L=1u
Mo4_uU_L3_47_12 gp_3_47_12 da_uU_L3_47_12 vdd vdd PMIR W=60u L=1u
Mt_uU_L3_47_13 ts_uU_L3_47_13 hv_L2_37 0 0 NMIR W=48.0u L=1u
Mo1_uU_L3_47_13 da_uU_L3_47_13 d1bar_L3 ts_uU_L3_47_13 0 NMIR W=20u L=1u
Mo2_uU_L3_47_13 gp_3_47_13 dpre_L3_47 ts_uU_L3_47_13 0 NMIR W=20u L=1u
Mo3_uU_L3_47_13 da_uU_L3_47_13 da_uU_L3_47_13 vdd vdd PMIR W=60u L=1u
Mo4_uU_L3_47_13 gp_3_47_13 da_uU_L3_47_13 vdd vdd PMIR W=60u L=1u
Mt_uU_L3_47_14 ts_uU_L3_47_14 hv_L2_39 0 0 NMIR W=48.0u L=1u
Mo1_uU_L3_47_14 da_uU_L3_47_14 d1bar_L3 ts_uU_L3_47_14 0 NMIR W=20u L=1u
Mo2_uU_L3_47_14 gp_3_47_14 dpre_L3_47 ts_uU_L3_47_14 0 NMIR W=20u L=1u
Mo3_uU_L3_47_14 da_uU_L3_47_14 da_uU_L3_47_14 vdd vdd PMIR W=60u L=1u
Mo4_uU_L3_47_14 gp_3_47_14 da_uU_L3_47_14 vdd vdd PMIR W=60u L=1u
Mt_uU_L3_47_15 ts_uU_L3_47_15 hv_L2_44 0 0 NMIR W=48.0u L=1u
Mo1_uU_L3_47_15 da_uU_L3_47_15 d1bar_L3 ts_uU_L3_47_15 0 NMIR W=20u L=1u
Mo2_uU_L3_47_15 gp_3_47_15 dpre_L3_47 ts_uU_L3_47_15 0 NMIR W=20u L=1u
Mo3_uU_L3_47_15 da_uU_L3_47_15 da_uU_L3_47_15 vdd vdd PMIR W=60u L=1u
Mo4_uU_L3_47_15 gp_3_47_15 da_uU_L3_47_15 vdd vdd PMIR W=60u L=1u
MpTa_L2_0_0 dpre_L3_7 gp_3_7_0 ctp_L2_0 0 NSYN W=10u L=1u
MnTb_L2_0_0 d1bar_L3 vcn ctp_L2_0 0 NSYN W=10u L=1u
MnTa_L2_0_0 dpre_L3_7 vcn ctn_L2_0 0 NSYN W=10u L=1u
MpTb_L2_0_0 d1bar_L3 gp_3_7_0 ctn_L2_0 0 NSYN W=10u L=1u
MpTa_L2_0_1 dpre_L3_13 gp_3_13_0 ctp_L2_0 0 NSYN W=10u L=1u
MnTb_L2_0_1 d1bar_L3 vcn ctp_L2_0 0 NSYN W=10u L=1u
MnTa_L2_0_1 dpre_L3_13 vcn ctn_L2_0 0 NSYN W=10u L=1u
MpTb_L2_0_1 d1bar_L3 gp_3_13_0 ctn_L2_0 0 NSYN W=10u L=1u
MpTa_L2_0_2 dpre_L3_15 gp_3_15_0 ctp_L2_0 0 NSYN W=10u L=1u
MnTb_L2_0_2 d1bar_L3 vcn ctp_L2_0 0 NSYN W=10u L=1u
MnTa_L2_0_2 dpre_L3_15 vcn ctn_L2_0 0 NSYN W=10u L=1u
MpTb_L2_0_2 d1bar_L3 gp_3_15_0 ctn_L2_0 0 NSYN W=10u L=1u
MpTa_L2_0_3 dpre_L3_20 gp_3_20_0 ctp_L2_0 0 NSYN W=10u L=1u
MnTb_L2_0_3 d1bar_L3 vcn ctp_L2_0 0 NSYN W=10u L=1u
MnTa_L2_0_3 dpre_L3_20 vcn ctn_L2_0 0 NSYN W=10u L=1u
MpTb_L2_0_3 d1bar_L3 gp_3_20_0 ctn_L2_0 0 NSYN W=10u L=1u
MpTa_L2_0_4 dpre_L3_26 gp_3_26_0 ctp_L2_0 0 NSYN W=10u L=1u
MnTb_L2_0_4 d1bar_L3 vcn ctp_L2_0 0 NSYN W=10u L=1u
MnTa_L2_0_4 dpre_L3_26 vcn ctn_L2_0 0 NSYN W=10u L=1u
MpTb_L2_0_4 d1bar_L3 gp_3_26_0 ctn_L2_0 0 NSYN W=10u L=1u
MpTa_L2_0_5 dpre_L3_28 gp_3_28_0 ctp_L2_0 0 NSYN W=10u L=1u
MnTb_L2_0_5 d1bar_L3 vcn ctp_L2_0 0 NSYN W=10u L=1u
MnTa_L2_0_5 dpre_L3_28 vcn ctn_L2_0 0 NSYN W=10u L=1u
MpTb_L2_0_5 d1bar_L3 gp_3_28_0 ctn_L2_0 0 NSYN W=10u L=1u
MpTa_L2_0_6 dpre_L3_33 gp_3_33_0 ctp_L2_0 0 NSYN W=10u L=1u
MnTb_L2_0_6 d1bar_L3 vcn ctp_L2_0 0 NSYN W=10u L=1u
MnTa_L2_0_6 dpre_L3_33 vcn ctn_L2_0 0 NSYN W=10u L=1u
MpTb_L2_0_6 d1bar_L3 gp_3_33_0 ctn_L2_0 0 NSYN W=10u L=1u
MpTa_L2_0_7 dpre_L3_36 gp_3_36_0 ctp_L2_0 0 NSYN W=10u L=1u
MnTb_L2_0_7 d1bar_L3 vcn ctp_L2_0 0 NSYN W=10u L=1u
MnTa_L2_0_7 dpre_L3_36 vcn ctn_L2_0 0 NSYN W=10u L=1u
MpTb_L2_0_7 d1bar_L3 gp_3_36_0 ctn_L2_0 0 NSYN W=10u L=1u
MpTa_L2_0_8 dpre_L3_38 gp_3_38_0 ctp_L2_0 0 NSYN W=10u L=1u
MnTb_L2_0_8 d1bar_L3 vcn ctp_L2_0 0 NSYN W=10u L=1u
MnTa_L2_0_8 dpre_L3_38 vcn ctn_L2_0 0 NSYN W=10u L=1u
MpTb_L2_0_8 d1bar_L3 gp_3_38_0 ctn_L2_0 0 NSYN W=10u L=1u
MpTa_L2_0_9 dpre_L3_40 gp_3_40_0 ctp_L2_0 0 NSYN W=10u L=1u
MnTb_L2_0_9 d1bar_L3 vcn ctp_L2_0 0 NSYN W=10u L=1u
MnTa_L2_0_9 dpre_L3_40 vcn ctn_L2_0 0 NSYN W=10u L=1u
MpTb_L2_0_9 d1bar_L3 gp_3_40_0 ctn_L2_0 0 NSYN W=10u L=1u
MpTa_L2_0_10 dpre_L3_41 gp_3_41_0 ctp_L2_0 0 NSYN W=10u L=1u
MnTb_L2_0_10 d1bar_L3 vcn ctp_L2_0 0 NSYN W=10u L=1u
MnTa_L2_0_10 dpre_L3_41 vcn ctn_L2_0 0 NSYN W=10u L=1u
MpTb_L2_0_10 d1bar_L3 gp_3_41_0 ctn_L2_0 0 NSYN W=10u L=1u
MpTa_L2_0_11 dpre_L3_43 gp_3_43_0 ctp_L2_0 0 NSYN W=10u L=1u
MnTb_L2_0_11 d1bar_L3 vcn ctp_L2_0 0 NSYN W=10u L=1u
MnTa_L2_0_11 dpre_L3_43 vcn ctn_L2_0 0 NSYN W=10u L=1u
MpTb_L2_0_11 d1bar_L3 gp_3_43_0 ctn_L2_0 0 NSYN W=10u L=1u
MpTa_L2_0_12 dpre_L3_44 gp_3_44_0 ctp_L2_0 0 NSYN W=10u L=1u
MnTb_L2_0_12 d1bar_L3 vcn ctp_L2_0 0 NSYN W=10u L=1u
MnTa_L2_0_12 dpre_L3_44 vcn ctn_L2_0 0 NSYN W=10u L=1u
MpTb_L2_0_12 d1bar_L3 gp_3_44_0 ctn_L2_0 0 NSYN W=10u L=1u
MpTa_L2_0_13 dpre_L3_45 gp_3_45_0 ctp_L2_0 0 NSYN W=10u L=1u
MnTb_L2_0_13 d1bar_L3 vcn ctp_L2_0 0 NSYN W=10u L=1u
MnTa_L2_0_13 dpre_L3_45 vcn ctn_L2_0 0 NSYN W=10u L=1u
MpTb_L2_0_13 d1bar_L3 gp_3_45_0 ctn_L2_0 0 NSYN W=10u L=1u
Msa_bk_L2_0 ctn_L2_0 ctn_L2_0 0 0 NMIR W=20u L=1u
Msb_bk_L2_0 dpre_L2_0 ctn_L2_0 0 0 NMIR W=20u L=1u
Msc_bk_L2_0 ctp_L2_0 ctp_L2_0 0 0 NMIR W=20u L=1u
Msd_bk_L2_0 dpf_bk_L2_0 ctp_L2_0 0 0 NMIR W=20u L=1u
Mse_bk_L2_0 dpf_bk_L2_0 dpf_bk_L2_0 vdd vdd PMIR W=60u L=1u
Msf_bk_L2_0 dpre_L2_0 dpf_bk_L2_0 vdd vdd PMIR W=60u L=1u
R_bk_L2_0 dpre_L2_0 vrefd 16000.0
MpTa_L2_1_0 dpre_L3_6 gp_3_6_0 ctp_L2_1 0 NSYN W=10u L=1u
MnTb_L2_1_0 d1bar_L3 vcn ctp_L2_1 0 NSYN W=10u L=1u
MnTa_L2_1_0 dpre_L3_6 vcn ctn_L2_1 0 NSYN W=10u L=1u
MpTb_L2_1_0 d1bar_L3 gp_3_6_0 ctn_L2_1 0 NSYN W=10u L=1u
MpTa_L2_1_1 dpre_L3_9 gp_3_9_0 ctp_L2_1 0 NSYN W=10u L=1u
MnTb_L2_1_1 d1bar_L3 vcn ctp_L2_1 0 NSYN W=10u L=1u
MnTa_L2_1_1 dpre_L3_9 vcn ctn_L2_1 0 NSYN W=10u L=1u
MpTb_L2_1_1 d1bar_L3 gp_3_9_0 ctn_L2_1 0 NSYN W=10u L=1u
MpTa_L2_1_2 dpre_L3_11 gp_3_11_0 ctp_L2_1 0 NSYN W=10u L=1u
MnTb_L2_1_2 d1bar_L3 vcn ctp_L2_1 0 NSYN W=10u L=1u
MnTa_L2_1_2 dpre_L3_11 vcn ctn_L2_1 0 NSYN W=10u L=1u
MpTb_L2_1_2 d1bar_L3 gp_3_11_0 ctn_L2_1 0 NSYN W=10u L=1u
MpTa_L2_1_3 dpre_L3_13 gp_3_13_1 ctp_L2_1 0 NSYN W=10u L=1u
MnTb_L2_1_3 d1bar_L3 vcn ctp_L2_1 0 NSYN W=10u L=1u
MnTa_L2_1_3 dpre_L3_13 vcn ctn_L2_1 0 NSYN W=10u L=1u
MpTb_L2_1_3 d1bar_L3 gp_3_13_1 ctn_L2_1 0 NSYN W=10u L=1u
MpTa_L2_1_4 dpre_L3_15 gp_3_15_1 ctp_L2_1 0 NSYN W=10u L=1u
MnTb_L2_1_4 d1bar_L3 vcn ctp_L2_1 0 NSYN W=10u L=1u
MnTa_L2_1_4 dpre_L3_15 vcn ctn_L2_1 0 NSYN W=10u L=1u
MpTb_L2_1_4 d1bar_L3 gp_3_15_1 ctn_L2_1 0 NSYN W=10u L=1u
MpTa_L2_1_5 dpre_L3_25 gp_3_25_0 ctp_L2_1 0 NSYN W=10u L=1u
MnTb_L2_1_5 d1bar_L3 vcn ctp_L2_1 0 NSYN W=10u L=1u
MnTa_L2_1_5 dpre_L3_25 vcn ctn_L2_1 0 NSYN W=10u L=1u
MpTb_L2_1_5 d1bar_L3 gp_3_25_0 ctn_L2_1 0 NSYN W=10u L=1u
MpTa_L2_1_6 dpre_L3_27 gp_3_27_0 ctp_L2_1 0 NSYN W=10u L=1u
MnTb_L2_1_6 d1bar_L3 vcn ctp_L2_1 0 NSYN W=10u L=1u
MnTa_L2_1_6 dpre_L3_27 vcn ctn_L2_1 0 NSYN W=10u L=1u
MpTb_L2_1_6 d1bar_L3 gp_3_27_0 ctn_L2_1 0 NSYN W=10u L=1u
MpTa_L2_1_7 dpre_L3_28 gp_3_28_1 ctp_L2_1 0 NSYN W=10u L=1u
MnTb_L2_1_7 d1bar_L3 vcn ctp_L2_1 0 NSYN W=10u L=1u
MnTa_L2_1_7 dpre_L3_28 vcn ctn_L2_1 0 NSYN W=10u L=1u
MpTb_L2_1_7 d1bar_L3 gp_3_28_1 ctn_L2_1 0 NSYN W=10u L=1u
MpTa_L2_1_8 dpre_L3_29 gp_3_29_0 ctp_L2_1 0 NSYN W=10u L=1u
MnTb_L2_1_8 d1bar_L3 vcn ctp_L2_1 0 NSYN W=10u L=1u
MnTa_L2_1_8 dpre_L3_29 vcn ctn_L2_1 0 NSYN W=10u L=1u
MpTb_L2_1_8 d1bar_L3 gp_3_29_0 ctn_L2_1 0 NSYN W=10u L=1u
MpTa_L2_1_9 dpre_L3_31 gp_3_31_0 ctp_L2_1 0 NSYN W=10u L=1u
MnTb_L2_1_9 d1bar_L3 vcn ctp_L2_1 0 NSYN W=10u L=1u
MnTa_L2_1_9 dpre_L3_31 vcn ctn_L2_1 0 NSYN W=10u L=1u
MpTb_L2_1_9 d1bar_L3 gp_3_31_0 ctn_L2_1 0 NSYN W=10u L=1u
MpTa_L2_1_10 dpre_L3_37 gp_3_37_0 ctp_L2_1 0 NSYN W=10u L=1u
MnTb_L2_1_10 d1bar_L3 vcn ctp_L2_1 0 NSYN W=10u L=1u
MnTa_L2_1_10 dpre_L3_37 vcn ctn_L2_1 0 NSYN W=10u L=1u
MpTb_L2_1_10 d1bar_L3 gp_3_37_0 ctn_L2_1 0 NSYN W=10u L=1u
MpTa_L2_1_11 dpre_L3_38 gp_3_38_1 ctp_L2_1 0 NSYN W=10u L=1u
MnTb_L2_1_11 d1bar_L3 vcn ctp_L2_1 0 NSYN W=10u L=1u
MnTa_L2_1_11 dpre_L3_38 vcn ctn_L2_1 0 NSYN W=10u L=1u
MpTb_L2_1_11 d1bar_L3 gp_3_38_1 ctn_L2_1 0 NSYN W=10u L=1u
MpTa_L2_1_12 dpre_L3_46 gp_3_46_0 ctp_L2_1 0 NSYN W=10u L=1u
MnTb_L2_1_12 d1bar_L3 vcn ctp_L2_1 0 NSYN W=10u L=1u
MnTa_L2_1_12 dpre_L3_46 vcn ctn_L2_1 0 NSYN W=10u L=1u
MpTb_L2_1_12 d1bar_L3 gp_3_46_0 ctn_L2_1 0 NSYN W=10u L=1u
MpTa_L2_1_13 dpre_L3_47 gp_3_47_0 ctp_L2_1 0 NSYN W=10u L=1u
MnTb_L2_1_13 d1bar_L3 vcn ctp_L2_1 0 NSYN W=10u L=1u
MnTa_L2_1_13 dpre_L3_47 vcn ctn_L2_1 0 NSYN W=10u L=1u
MpTb_L2_1_13 d1bar_L3 gp_3_47_0 ctn_L2_1 0 NSYN W=10u L=1u
Msa_bk_L2_1 ctn_L2_1 ctn_L2_1 0 0 NMIR W=20u L=1u
Msb_bk_L2_1 dpre_L2_1 ctn_L2_1 0 0 NMIR W=20u L=1u
Msc_bk_L2_1 ctp_L2_1 ctp_L2_1 0 0 NMIR W=20u L=1u
Msd_bk_L2_1 dpf_bk_L2_1 ctp_L2_1 0 0 NMIR W=20u L=1u
Mse_bk_L2_1 dpf_bk_L2_1 dpf_bk_L2_1 vdd vdd PMIR W=60u L=1u
Msf_bk_L2_1 dpre_L2_1 dpf_bk_L2_1 vdd vdd PMIR W=60u L=1u
R_bk_L2_1 dpre_L2_1 vrefd 16000.0
MpTa_L2_2_0 dpre_L3_2 gp_3_2_0 ctp_L2_2 0 NSYN W=10u L=1u
MnTb_L2_2_0 d1bar_L3 vcn ctp_L2_2 0 NSYN W=10u L=1u
MnTa_L2_2_0 dpre_L3_2 vcn ctn_L2_2 0 NSYN W=10u L=1u
MpTb_L2_2_0 d1bar_L3 gp_3_2_0 ctn_L2_2 0 NSYN W=10u L=1u
MpTa_L2_2_1 dpre_L3_4 gp_3_4_0 ctp_L2_2 0 NSYN W=10u L=1u
MnTb_L2_2_1 d1bar_L3 vcn ctp_L2_2 0 NSYN W=10u L=1u
MnTa_L2_2_1 dpre_L3_4 vcn ctn_L2_2 0 NSYN W=10u L=1u
MpTb_L2_2_1 d1bar_L3 gp_3_4_0 ctn_L2_2 0 NSYN W=10u L=1u
MpTa_L2_2_2 dpre_L3_5 gp_3_5_0 ctp_L2_2 0 NSYN W=10u L=1u
MnTb_L2_2_2 d1bar_L3 vcn ctp_L2_2 0 NSYN W=10u L=1u
MnTa_L2_2_2 dpre_L3_5 vcn ctn_L2_2 0 NSYN W=10u L=1u
MpTb_L2_2_2 d1bar_L3 gp_3_5_0 ctn_L2_2 0 NSYN W=10u L=1u
MpTa_L2_2_3 dpre_L3_11 gp_3_11_1 ctp_L2_2 0 NSYN W=10u L=1u
MnTb_L2_2_3 d1bar_L3 vcn ctp_L2_2 0 NSYN W=10u L=1u
MnTa_L2_2_3 dpre_L3_11 vcn ctn_L2_2 0 NSYN W=10u L=1u
MpTb_L2_2_3 d1bar_L3 gp_3_11_1 ctn_L2_2 0 NSYN W=10u L=1u
MpTa_L2_2_4 dpre_L3_15 gp_3_15_2 ctp_L2_2 0 NSYN W=10u L=1u
MnTb_L2_2_4 d1bar_L3 vcn ctp_L2_2 0 NSYN W=10u L=1u
MnTa_L2_2_4 dpre_L3_15 vcn ctn_L2_2 0 NSYN W=10u L=1u
MpTb_L2_2_4 d1bar_L3 gp_3_15_2 ctn_L2_2 0 NSYN W=10u L=1u
MpTa_L2_2_5 dpre_L3_18 gp_3_18_0 ctp_L2_2 0 NSYN W=10u L=1u
MnTb_L2_2_5 d1bar_L3 vcn ctp_L2_2 0 NSYN W=10u L=1u
MnTa_L2_2_5 dpre_L3_18 vcn ctn_L2_2 0 NSYN W=10u L=1u
MpTb_L2_2_5 d1bar_L3 gp_3_18_0 ctn_L2_2 0 NSYN W=10u L=1u
MpTa_L2_2_6 dpre_L3_19 gp_3_19_0 ctp_L2_2 0 NSYN W=10u L=1u
MnTb_L2_2_6 d1bar_L3 vcn ctp_L2_2 0 NSYN W=10u L=1u
MnTa_L2_2_6 dpre_L3_19 vcn ctn_L2_2 0 NSYN W=10u L=1u
MpTb_L2_2_6 d1bar_L3 gp_3_19_0 ctn_L2_2 0 NSYN W=10u L=1u
MpTa_L2_2_7 dpre_L3_22 gp_3_22_0 ctp_L2_2 0 NSYN W=10u L=1u
MnTb_L2_2_7 d1bar_L3 vcn ctp_L2_2 0 NSYN W=10u L=1u
MnTa_L2_2_7 dpre_L3_22 vcn ctn_L2_2 0 NSYN W=10u L=1u
MpTb_L2_2_7 d1bar_L3 gp_3_22_0 ctn_L2_2 0 NSYN W=10u L=1u
MpTa_L2_2_8 dpre_L3_27 gp_3_27_1 ctp_L2_2 0 NSYN W=10u L=1u
MnTb_L2_2_8 d1bar_L3 vcn ctp_L2_2 0 NSYN W=10u L=1u
MnTa_L2_2_8 dpre_L3_27 vcn ctn_L2_2 0 NSYN W=10u L=1u
MpTb_L2_2_8 d1bar_L3 gp_3_27_1 ctn_L2_2 0 NSYN W=10u L=1u
MpTa_L2_2_9 dpre_L3_33 gp_3_33_1 ctp_L2_2 0 NSYN W=10u L=1u
MnTb_L2_2_9 d1bar_L3 vcn ctp_L2_2 0 NSYN W=10u L=1u
MnTa_L2_2_9 dpre_L3_33 vcn ctn_L2_2 0 NSYN W=10u L=1u
MpTb_L2_2_9 d1bar_L3 gp_3_33_1 ctn_L2_2 0 NSYN W=10u L=1u
MpTa_L2_2_10 dpre_L3_36 gp_3_36_1 ctp_L2_2 0 NSYN W=10u L=1u
MnTb_L2_2_10 d1bar_L3 vcn ctp_L2_2 0 NSYN W=10u L=1u
MnTa_L2_2_10 dpre_L3_36 vcn ctn_L2_2 0 NSYN W=10u L=1u
MpTb_L2_2_10 d1bar_L3 gp_3_36_1 ctn_L2_2 0 NSYN W=10u L=1u
MpTa_L2_2_11 dpre_L3_43 gp_3_43_1 ctp_L2_2 0 NSYN W=10u L=1u
MnTb_L2_2_11 d1bar_L3 vcn ctp_L2_2 0 NSYN W=10u L=1u
MnTa_L2_2_11 dpre_L3_43 vcn ctn_L2_2 0 NSYN W=10u L=1u
MpTb_L2_2_11 d1bar_L3 gp_3_43_1 ctn_L2_2 0 NSYN W=10u L=1u
MpTa_L2_2_12 dpre_L3_45 gp_3_45_1 ctp_L2_2 0 NSYN W=10u L=1u
MnTb_L2_2_12 d1bar_L3 vcn ctp_L2_2 0 NSYN W=10u L=1u
MnTa_L2_2_12 dpre_L3_45 vcn ctn_L2_2 0 NSYN W=10u L=1u
MpTb_L2_2_12 d1bar_L3 gp_3_45_1 ctn_L2_2 0 NSYN W=10u L=1u
MpTa_L2_2_13 dpre_L3_46 gp_3_46_1 ctp_L2_2 0 NSYN W=10u L=1u
MnTb_L2_2_13 d1bar_L3 vcn ctp_L2_2 0 NSYN W=10u L=1u
MnTa_L2_2_13 dpre_L3_46 vcn ctn_L2_2 0 NSYN W=10u L=1u
MpTb_L2_2_13 d1bar_L3 gp_3_46_1 ctn_L2_2 0 NSYN W=10u L=1u
Msa_bk_L2_2 ctn_L2_2 ctn_L2_2 0 0 NMIR W=20u L=1u
Msb_bk_L2_2 dpre_L2_2 ctn_L2_2 0 0 NMIR W=20u L=1u
Msc_bk_L2_2 ctp_L2_2 ctp_L2_2 0 0 NMIR W=20u L=1u
Msd_bk_L2_2 dpf_bk_L2_2 ctp_L2_2 0 0 NMIR W=20u L=1u
Mse_bk_L2_2 dpf_bk_L2_2 dpf_bk_L2_2 vdd vdd PMIR W=60u L=1u
Msf_bk_L2_2 dpre_L2_2 dpf_bk_L2_2 vdd vdd PMIR W=60u L=1u
R_bk_L2_2 dpre_L2_2 vrefd 16000.0
MpTa_L2_3_0 dpre_L3_0 gp_3_0_0 ctp_L2_3 0 NSYN W=10u L=1u
MnTb_L2_3_0 d1bar_L3 vcn ctp_L2_3 0 NSYN W=10u L=1u
MnTa_L2_3_0 dpre_L3_0 vcn ctn_L2_3 0 NSYN W=10u L=1u
MpTb_L2_3_0 d1bar_L3 gp_3_0_0 ctn_L2_3 0 NSYN W=10u L=1u
MpTa_L2_3_1 dpre_L3_4 gp_3_4_1 ctp_L2_3 0 NSYN W=10u L=1u
MnTb_L2_3_1 d1bar_L3 vcn ctp_L2_3 0 NSYN W=10u L=1u
MnTa_L2_3_1 dpre_L3_4 vcn ctn_L2_3 0 NSYN W=10u L=1u
MpTb_L2_3_1 d1bar_L3 gp_3_4_1 ctn_L2_3 0 NSYN W=10u L=1u
MpTa_L2_3_2 dpre_L3_13 gp_3_13_2 ctp_L2_3 0 NSYN W=10u L=1u
MnTb_L2_3_2 d1bar_L3 vcn ctp_L2_3 0 NSYN W=10u L=1u
MnTa_L2_3_2 dpre_L3_13 vcn ctn_L2_3 0 NSYN W=10u L=1u
MpTb_L2_3_2 d1bar_L3 gp_3_13_2 ctn_L2_3 0 NSYN W=10u L=1u
MpTa_L2_3_3 dpre_L3_16 gp_3_16_0 ctp_L2_3 0 NSYN W=10u L=1u
MnTb_L2_3_3 d1bar_L3 vcn ctp_L2_3 0 NSYN W=10u L=1u
MnTa_L2_3_3 dpre_L3_16 vcn ctn_L2_3 0 NSYN W=10u L=1u
MpTb_L2_3_3 d1bar_L3 gp_3_16_0 ctn_L2_3 0 NSYN W=10u L=1u
MpTa_L2_3_4 dpre_L3_17 gp_3_17_0 ctp_L2_3 0 NSYN W=10u L=1u
MnTb_L2_3_4 d1bar_L3 vcn ctp_L2_3 0 NSYN W=10u L=1u
MnTa_L2_3_4 dpre_L3_17 vcn ctn_L2_3 0 NSYN W=10u L=1u
MpTb_L2_3_4 d1bar_L3 gp_3_17_0 ctn_L2_3 0 NSYN W=10u L=1u
MpTa_L2_3_5 dpre_L3_20 gp_3_20_1 ctp_L2_3 0 NSYN W=10u L=1u
MnTb_L2_3_5 d1bar_L3 vcn ctp_L2_3 0 NSYN W=10u L=1u
MnTa_L2_3_5 dpre_L3_20 vcn ctn_L2_3 0 NSYN W=10u L=1u
MpTb_L2_3_5 d1bar_L3 gp_3_20_1 ctn_L2_3 0 NSYN W=10u L=1u
MpTa_L2_3_6 dpre_L3_21 gp_3_21_0 ctp_L2_3 0 NSYN W=10u L=1u
MnTb_L2_3_6 d1bar_L3 vcn ctp_L2_3 0 NSYN W=10u L=1u
MnTa_L2_3_6 dpre_L3_21 vcn ctn_L2_3 0 NSYN W=10u L=1u
MpTb_L2_3_6 d1bar_L3 gp_3_21_0 ctn_L2_3 0 NSYN W=10u L=1u
MpTa_L2_3_7 dpre_L3_22 gp_3_22_1 ctp_L2_3 0 NSYN W=10u L=1u
MnTb_L2_3_7 d1bar_L3 vcn ctp_L2_3 0 NSYN W=10u L=1u
MnTa_L2_3_7 dpre_L3_22 vcn ctn_L2_3 0 NSYN W=10u L=1u
MpTb_L2_3_7 d1bar_L3 gp_3_22_1 ctn_L2_3 0 NSYN W=10u L=1u
MpTa_L2_3_8 dpre_L3_24 gp_3_24_0 ctp_L2_3 0 NSYN W=10u L=1u
MnTb_L2_3_8 d1bar_L3 vcn ctp_L2_3 0 NSYN W=10u L=1u
MnTa_L2_3_8 dpre_L3_24 vcn ctn_L2_3 0 NSYN W=10u L=1u
MpTb_L2_3_8 d1bar_L3 gp_3_24_0 ctn_L2_3 0 NSYN W=10u L=1u
MpTa_L2_3_9 dpre_L3_28 gp_3_28_2 ctp_L2_3 0 NSYN W=10u L=1u
MnTb_L2_3_9 d1bar_L3 vcn ctp_L2_3 0 NSYN W=10u L=1u
MnTa_L2_3_9 dpre_L3_28 vcn ctn_L2_3 0 NSYN W=10u L=1u
MpTb_L2_3_9 d1bar_L3 gp_3_28_2 ctn_L2_3 0 NSYN W=10u L=1u
MpTa_L2_3_10 dpre_L3_32 gp_3_32_0 ctp_L2_3 0 NSYN W=10u L=1u
MnTb_L2_3_10 d1bar_L3 vcn ctp_L2_3 0 NSYN W=10u L=1u
MnTa_L2_3_10 dpre_L3_32 vcn ctn_L2_3 0 NSYN W=10u L=1u
MpTb_L2_3_10 d1bar_L3 gp_3_32_0 ctn_L2_3 0 NSYN W=10u L=1u
MpTa_L2_3_11 dpre_L3_38 gp_3_38_2 ctp_L2_3 0 NSYN W=10u L=1u
MnTb_L2_3_11 d1bar_L3 vcn ctp_L2_3 0 NSYN W=10u L=1u
MnTa_L2_3_11 dpre_L3_38 vcn ctn_L2_3 0 NSYN W=10u L=1u
MpTb_L2_3_11 d1bar_L3 gp_3_38_2 ctn_L2_3 0 NSYN W=10u L=1u
MpTa_L2_3_12 dpre_L3_40 gp_3_40_1 ctp_L2_3 0 NSYN W=10u L=1u
MnTb_L2_3_12 d1bar_L3 vcn ctp_L2_3 0 NSYN W=10u L=1u
MnTa_L2_3_12 dpre_L3_40 vcn ctn_L2_3 0 NSYN W=10u L=1u
MpTb_L2_3_12 d1bar_L3 gp_3_40_1 ctn_L2_3 0 NSYN W=10u L=1u
MpTa_L2_3_13 dpre_L3_42 gp_3_42_0 ctp_L2_3 0 NSYN W=10u L=1u
MnTb_L2_3_13 d1bar_L3 vcn ctp_L2_3 0 NSYN W=10u L=1u
MnTa_L2_3_13 dpre_L3_42 vcn ctn_L2_3 0 NSYN W=10u L=1u
MpTb_L2_3_13 d1bar_L3 gp_3_42_0 ctn_L2_3 0 NSYN W=10u L=1u
MpTa_L2_3_14 dpre_L3_44 gp_3_44_1 ctp_L2_3 0 NSYN W=10u L=1u
MnTb_L2_3_14 d1bar_L3 vcn ctp_L2_3 0 NSYN W=10u L=1u
MnTa_L2_3_14 dpre_L3_44 vcn ctn_L2_3 0 NSYN W=10u L=1u
MpTb_L2_3_14 d1bar_L3 gp_3_44_1 ctn_L2_3 0 NSYN W=10u L=1u
Msa_bk_L2_3 ctn_L2_3 ctn_L2_3 0 0 NMIR W=20u L=1u
Msb_bk_L2_3 dpre_L2_3 ctn_L2_3 0 0 NMIR W=20u L=1u
Msc_bk_L2_3 ctp_L2_3 ctp_L2_3 0 0 NMIR W=20u L=1u
Msd_bk_L2_3 dpf_bk_L2_3 ctp_L2_3 0 0 NMIR W=20u L=1u
Mse_bk_L2_3 dpf_bk_L2_3 dpf_bk_L2_3 vdd vdd PMIR W=60u L=1u
Msf_bk_L2_3 dpre_L2_3 dpf_bk_L2_3 vdd vdd PMIR W=60u L=1u
R_bk_L2_3 dpre_L2_3 vrefd 16000.0
MpTa_L2_4_0 dpre_L3_5 gp_3_5_1 ctp_L2_4 0 NSYN W=10u L=1u
MnTb_L2_4_0 d1bar_L3 vcn ctp_L2_4 0 NSYN W=10u L=1u
MnTa_L2_4_0 dpre_L3_5 vcn ctn_L2_4 0 NSYN W=10u L=1u
MpTb_L2_4_0 d1bar_L3 gp_3_5_1 ctn_L2_4 0 NSYN W=10u L=1u
MpTa_L2_4_1 dpre_L3_7 gp_3_7_1 ctp_L2_4 0 NSYN W=10u L=1u
MnTb_L2_4_1 d1bar_L3 vcn ctp_L2_4 0 NSYN W=10u L=1u
MnTa_L2_4_1 dpre_L3_7 vcn ctn_L2_4 0 NSYN W=10u L=1u
MpTb_L2_4_1 d1bar_L3 gp_3_7_1 ctn_L2_4 0 NSYN W=10u L=1u
MpTa_L2_4_2 dpre_L3_15 gp_3_15_3 ctp_L2_4 0 NSYN W=10u L=1u
MnTb_L2_4_2 d1bar_L3 vcn ctp_L2_4 0 NSYN W=10u L=1u
MnTa_L2_4_2 dpre_L3_15 vcn ctn_L2_4 0 NSYN W=10u L=1u
MpTb_L2_4_2 d1bar_L3 gp_3_15_3 ctn_L2_4 0 NSYN W=10u L=1u
MpTa_L2_4_3 dpre_L3_17 gp_3_17_1 ctp_L2_4 0 NSYN W=10u L=1u
MnTb_L2_4_3 d1bar_L3 vcn ctp_L2_4 0 NSYN W=10u L=1u
MnTa_L2_4_3 dpre_L3_17 vcn ctn_L2_4 0 NSYN W=10u L=1u
MpTb_L2_4_3 d1bar_L3 gp_3_17_1 ctn_L2_4 0 NSYN W=10u L=1u
MpTa_L2_4_4 dpre_L3_20 gp_3_20_2 ctp_L2_4 0 NSYN W=10u L=1u
MnTb_L2_4_4 d1bar_L3 vcn ctp_L2_4 0 NSYN W=10u L=1u
MnTa_L2_4_4 dpre_L3_20 vcn ctn_L2_4 0 NSYN W=10u L=1u
MpTb_L2_4_4 d1bar_L3 gp_3_20_2 ctn_L2_4 0 NSYN W=10u L=1u
MpTa_L2_4_5 dpre_L3_26 gp_3_26_1 ctp_L2_4 0 NSYN W=10u L=1u
MnTb_L2_4_5 d1bar_L3 vcn ctp_L2_4 0 NSYN W=10u L=1u
MnTa_L2_4_5 dpre_L3_26 vcn ctn_L2_4 0 NSYN W=10u L=1u
MpTb_L2_4_5 d1bar_L3 gp_3_26_1 ctn_L2_4 0 NSYN W=10u L=1u
MpTa_L2_4_6 dpre_L3_29 gp_3_29_1 ctp_L2_4 0 NSYN W=10u L=1u
MnTb_L2_4_6 d1bar_L3 vcn ctp_L2_4 0 NSYN W=10u L=1u
MnTa_L2_4_6 dpre_L3_29 vcn ctn_L2_4 0 NSYN W=10u L=1u
MpTb_L2_4_6 d1bar_L3 gp_3_29_1 ctn_L2_4 0 NSYN W=10u L=1u
MpTa_L2_4_7 dpre_L3_37 gp_3_37_1 ctp_L2_4 0 NSYN W=10u L=1u
MnTb_L2_4_7 d1bar_L3 vcn ctp_L2_4 0 NSYN W=10u L=1u
MnTa_L2_4_7 dpre_L3_37 vcn ctn_L2_4 0 NSYN W=10u L=1u
MpTb_L2_4_7 d1bar_L3 gp_3_37_1 ctn_L2_4 0 NSYN W=10u L=1u
MpTa_L2_4_8 dpre_L3_38 gp_3_38_3 ctp_L2_4 0 NSYN W=10u L=1u
MnTb_L2_4_8 d1bar_L3 vcn ctp_L2_4 0 NSYN W=10u L=1u
MnTa_L2_4_8 dpre_L3_38 vcn ctn_L2_4 0 NSYN W=10u L=1u
MpTb_L2_4_8 d1bar_L3 gp_3_38_3 ctn_L2_4 0 NSYN W=10u L=1u
MpTa_L2_4_9 dpre_L3_39 gp_3_39_0 ctp_L2_4 0 NSYN W=10u L=1u
MnTb_L2_4_9 d1bar_L3 vcn ctp_L2_4 0 NSYN W=10u L=1u
MnTa_L2_4_9 dpre_L3_39 vcn ctn_L2_4 0 NSYN W=10u L=1u
MpTb_L2_4_9 d1bar_L3 gp_3_39_0 ctn_L2_4 0 NSYN W=10u L=1u
MpTa_L2_4_10 dpre_L3_42 gp_3_42_1 ctp_L2_4 0 NSYN W=10u L=1u
MnTb_L2_4_10 d1bar_L3 vcn ctp_L2_4 0 NSYN W=10u L=1u
MnTa_L2_4_10 dpre_L3_42 vcn ctn_L2_4 0 NSYN W=10u L=1u
MpTb_L2_4_10 d1bar_L3 gp_3_42_1 ctn_L2_4 0 NSYN W=10u L=1u
MpTa_L2_4_11 dpre_L3_43 gp_3_43_2 ctp_L2_4 0 NSYN W=10u L=1u
MnTb_L2_4_11 d1bar_L3 vcn ctp_L2_4 0 NSYN W=10u L=1u
MnTa_L2_4_11 dpre_L3_43 vcn ctn_L2_4 0 NSYN W=10u L=1u
MpTb_L2_4_11 d1bar_L3 gp_3_43_2 ctn_L2_4 0 NSYN W=10u L=1u
MpTa_L2_4_12 dpre_L3_45 gp_3_45_2 ctp_L2_4 0 NSYN W=10u L=1u
MnTb_L2_4_12 d1bar_L3 vcn ctp_L2_4 0 NSYN W=10u L=1u
MnTa_L2_4_12 dpre_L3_45 vcn ctn_L2_4 0 NSYN W=10u L=1u
MpTb_L2_4_12 d1bar_L3 gp_3_45_2 ctn_L2_4 0 NSYN W=10u L=1u
MpTa_L2_4_13 dpre_L3_46 gp_3_46_2 ctp_L2_4 0 NSYN W=10u L=1u
MnTb_L2_4_13 d1bar_L3 vcn ctp_L2_4 0 NSYN W=10u L=1u
MnTa_L2_4_13 dpre_L3_46 vcn ctn_L2_4 0 NSYN W=10u L=1u
MpTb_L2_4_13 d1bar_L3 gp_3_46_2 ctn_L2_4 0 NSYN W=10u L=1u
MpTa_L2_4_14 dpre_L3_47 gp_3_47_1 ctp_L2_4 0 NSYN W=10u L=1u
MnTb_L2_4_14 d1bar_L3 vcn ctp_L2_4 0 NSYN W=10u L=1u
MnTa_L2_4_14 dpre_L3_47 vcn ctn_L2_4 0 NSYN W=10u L=1u
MpTb_L2_4_14 d1bar_L3 gp_3_47_1 ctn_L2_4 0 NSYN W=10u L=1u
Msa_bk_L2_4 ctn_L2_4 ctn_L2_4 0 0 NMIR W=20u L=1u
Msb_bk_L2_4 dpre_L2_4 ctn_L2_4 0 0 NMIR W=20u L=1u
Msc_bk_L2_4 ctp_L2_4 ctp_L2_4 0 0 NMIR W=20u L=1u
Msd_bk_L2_4 dpf_bk_L2_4 ctp_L2_4 0 0 NMIR W=20u L=1u
Mse_bk_L2_4 dpf_bk_L2_4 dpf_bk_L2_4 vdd vdd PMIR W=60u L=1u
Msf_bk_L2_4 dpre_L2_4 dpf_bk_L2_4 vdd vdd PMIR W=60u L=1u
R_bk_L2_4 dpre_L2_4 vrefd 16000.0
MpTa_L2_5_0 dpre_L3_0 gp_3_0_1 ctp_L2_5 0 NSYN W=10u L=1u
MnTb_L2_5_0 d1bar_L3 vcn ctp_L2_5 0 NSYN W=10u L=1u
MnTa_L2_5_0 dpre_L3_0 vcn ctn_L2_5 0 NSYN W=10u L=1u
MpTb_L2_5_0 d1bar_L3 gp_3_0_1 ctn_L2_5 0 NSYN W=10u L=1u
MpTa_L2_5_1 dpre_L3_1 gp_3_1_0 ctp_L2_5 0 NSYN W=10u L=1u
MnTb_L2_5_1 d1bar_L3 vcn ctp_L2_5 0 NSYN W=10u L=1u
MnTa_L2_5_1 dpre_L3_1 vcn ctn_L2_5 0 NSYN W=10u L=1u
MpTb_L2_5_1 d1bar_L3 gp_3_1_0 ctn_L2_5 0 NSYN W=10u L=1u
MpTa_L2_5_2 dpre_L3_6 gp_3_6_1 ctp_L2_5 0 NSYN W=10u L=1u
MnTb_L2_5_2 d1bar_L3 vcn ctp_L2_5 0 NSYN W=10u L=1u
MnTa_L2_5_2 dpre_L3_6 vcn ctn_L2_5 0 NSYN W=10u L=1u
MpTb_L2_5_2 d1bar_L3 gp_3_6_1 ctn_L2_5 0 NSYN W=10u L=1u
MpTa_L2_5_3 dpre_L3_8 gp_3_8_0 ctp_L2_5 0 NSYN W=10u L=1u
MnTb_L2_5_3 d1bar_L3 vcn ctp_L2_5 0 NSYN W=10u L=1u
MnTa_L2_5_3 dpre_L3_8 vcn ctn_L2_5 0 NSYN W=10u L=1u
MpTb_L2_5_3 d1bar_L3 gp_3_8_0 ctn_L2_5 0 NSYN W=10u L=1u
MpTa_L2_5_4 dpre_L3_9 gp_3_9_1 ctp_L2_5 0 NSYN W=10u L=1u
MnTb_L2_5_4 d1bar_L3 vcn ctp_L2_5 0 NSYN W=10u L=1u
MnTa_L2_5_4 dpre_L3_9 vcn ctn_L2_5 0 NSYN W=10u L=1u
MpTb_L2_5_4 d1bar_L3 gp_3_9_1 ctn_L2_5 0 NSYN W=10u L=1u
MpTa_L2_5_5 dpre_L3_11 gp_3_11_2 ctp_L2_5 0 NSYN W=10u L=1u
MnTb_L2_5_5 d1bar_L3 vcn ctp_L2_5 0 NSYN W=10u L=1u
MnTa_L2_5_5 dpre_L3_11 vcn ctn_L2_5 0 NSYN W=10u L=1u
MpTb_L2_5_5 d1bar_L3 gp_3_11_2 ctn_L2_5 0 NSYN W=10u L=1u
MpTa_L2_5_6 dpre_L3_18 gp_3_18_1 ctp_L2_5 0 NSYN W=10u L=1u
MnTb_L2_5_6 d1bar_L3 vcn ctp_L2_5 0 NSYN W=10u L=1u
MnTa_L2_5_6 dpre_L3_18 vcn ctn_L2_5 0 NSYN W=10u L=1u
MpTb_L2_5_6 d1bar_L3 gp_3_18_1 ctn_L2_5 0 NSYN W=10u L=1u
MpTa_L2_5_7 dpre_L3_24 gp_3_24_1 ctp_L2_5 0 NSYN W=10u L=1u
MnTb_L2_5_7 d1bar_L3 vcn ctp_L2_5 0 NSYN W=10u L=1u
MnTa_L2_5_7 dpre_L3_24 vcn ctn_L2_5 0 NSYN W=10u L=1u
MpTb_L2_5_7 d1bar_L3 gp_3_24_1 ctn_L2_5 0 NSYN W=10u L=1u
MpTa_L2_5_8 dpre_L3_25 gp_3_25_1 ctp_L2_5 0 NSYN W=10u L=1u
MnTb_L2_5_8 d1bar_L3 vcn ctp_L2_5 0 NSYN W=10u L=1u
MnTa_L2_5_8 dpre_L3_25 vcn ctn_L2_5 0 NSYN W=10u L=1u
MpTb_L2_5_8 d1bar_L3 gp_3_25_1 ctn_L2_5 0 NSYN W=10u L=1u
MpTa_L2_5_9 dpre_L3_28 gp_3_28_3 ctp_L2_5 0 NSYN W=10u L=1u
MnTb_L2_5_9 d1bar_L3 vcn ctp_L2_5 0 NSYN W=10u L=1u
MnTa_L2_5_9 dpre_L3_28 vcn ctn_L2_5 0 NSYN W=10u L=1u
MpTb_L2_5_9 d1bar_L3 gp_3_28_3 ctn_L2_5 0 NSYN W=10u L=1u
MpTa_L2_5_10 dpre_L3_30 gp_3_30_0 ctp_L2_5 0 NSYN W=10u L=1u
MnTb_L2_5_10 d1bar_L3 vcn ctp_L2_5 0 NSYN W=10u L=1u
MnTa_L2_5_10 dpre_L3_30 vcn ctn_L2_5 0 NSYN W=10u L=1u
MpTb_L2_5_10 d1bar_L3 gp_3_30_0 ctn_L2_5 0 NSYN W=10u L=1u
MpTa_L2_5_11 dpre_L3_31 gp_3_31_1 ctp_L2_5 0 NSYN W=10u L=1u
MnTb_L2_5_11 d1bar_L3 vcn ctp_L2_5 0 NSYN W=10u L=1u
MnTa_L2_5_11 dpre_L3_31 vcn ctn_L2_5 0 NSYN W=10u L=1u
MpTb_L2_5_11 d1bar_L3 gp_3_31_1 ctn_L2_5 0 NSYN W=10u L=1u
MpTa_L2_5_12 dpre_L3_32 gp_3_32_1 ctp_L2_5 0 NSYN W=10u L=1u
MnTb_L2_5_12 d1bar_L3 vcn ctp_L2_5 0 NSYN W=10u L=1u
MnTa_L2_5_12 dpre_L3_32 vcn ctn_L2_5 0 NSYN W=10u L=1u
MpTb_L2_5_12 d1bar_L3 gp_3_32_1 ctn_L2_5 0 NSYN W=10u L=1u
MpTa_L2_5_13 dpre_L3_33 gp_3_33_2 ctp_L2_5 0 NSYN W=10u L=1u
MnTb_L2_5_13 d1bar_L3 vcn ctp_L2_5 0 NSYN W=10u L=1u
MnTa_L2_5_13 dpre_L3_33 vcn ctn_L2_5 0 NSYN W=10u L=1u
MpTb_L2_5_13 d1bar_L3 gp_3_33_2 ctn_L2_5 0 NSYN W=10u L=1u
MpTa_L2_5_14 dpre_L3_35 gp_3_35_0 ctp_L2_5 0 NSYN W=10u L=1u
MnTb_L2_5_14 d1bar_L3 vcn ctp_L2_5 0 NSYN W=10u L=1u
MnTa_L2_5_14 dpre_L3_35 vcn ctn_L2_5 0 NSYN W=10u L=1u
MpTb_L2_5_14 d1bar_L3 gp_3_35_0 ctn_L2_5 0 NSYN W=10u L=1u
MpTa_L2_5_15 dpre_L3_45 gp_3_45_3 ctp_L2_5 0 NSYN W=10u L=1u
MnTb_L2_5_15 d1bar_L3 vcn ctp_L2_5 0 NSYN W=10u L=1u
MnTa_L2_5_15 dpre_L3_45 vcn ctn_L2_5 0 NSYN W=10u L=1u
MpTb_L2_5_15 d1bar_L3 gp_3_45_3 ctn_L2_5 0 NSYN W=10u L=1u
MpTa_L2_5_16 dpre_L3_46 gp_3_46_3 ctp_L2_5 0 NSYN W=10u L=1u
MnTb_L2_5_16 d1bar_L3 vcn ctp_L2_5 0 NSYN W=10u L=1u
MnTa_L2_5_16 dpre_L3_46 vcn ctn_L2_5 0 NSYN W=10u L=1u
MpTb_L2_5_16 d1bar_L3 gp_3_46_3 ctn_L2_5 0 NSYN W=10u L=1u
MpTa_L2_5_17 dpre_L3_47 gp_3_47_2 ctp_L2_5 0 NSYN W=10u L=1u
MnTb_L2_5_17 d1bar_L3 vcn ctp_L2_5 0 NSYN W=10u L=1u
MnTa_L2_5_17 dpre_L3_47 vcn ctn_L2_5 0 NSYN W=10u L=1u
MpTb_L2_5_17 d1bar_L3 gp_3_47_2 ctn_L2_5 0 NSYN W=10u L=1u
Msa_bk_L2_5 ctn_L2_5 ctn_L2_5 0 0 NMIR W=20u L=1u
Msb_bk_L2_5 dpre_L2_5 ctn_L2_5 0 0 NMIR W=20u L=1u
Msc_bk_L2_5 ctp_L2_5 ctp_L2_5 0 0 NMIR W=20u L=1u
Msd_bk_L2_5 dpf_bk_L2_5 ctp_L2_5 0 0 NMIR W=20u L=1u
Mse_bk_L2_5 dpf_bk_L2_5 dpf_bk_L2_5 vdd vdd PMIR W=60u L=1u
Msf_bk_L2_5 dpre_L2_5 dpf_bk_L2_5 vdd vdd PMIR W=60u L=1u
R_bk_L2_5 dpre_L2_5 vrefd 16000.0
MpTa_L2_6_0 dpre_L3_1 gp_3_1_1 ctp_L2_6 0 NSYN W=10u L=1u
MnTb_L2_6_0 d1bar_L3 vcn ctp_L2_6 0 NSYN W=10u L=1u
MnTa_L2_6_0 dpre_L3_1 vcn ctn_L2_6 0 NSYN W=10u L=1u
MpTb_L2_6_0 d1bar_L3 gp_3_1_1 ctn_L2_6 0 NSYN W=10u L=1u
MpTa_L2_6_1 dpre_L3_2 gp_3_2_1 ctp_L2_6 0 NSYN W=10u L=1u
MnTb_L2_6_1 d1bar_L3 vcn ctp_L2_6 0 NSYN W=10u L=1u
MnTa_L2_6_1 dpre_L3_2 vcn ctn_L2_6 0 NSYN W=10u L=1u
MpTb_L2_6_1 d1bar_L3 gp_3_2_1 ctn_L2_6 0 NSYN W=10u L=1u
MpTa_L2_6_2 dpre_L3_3 gp_3_3_0 ctp_L2_6 0 NSYN W=10u L=1u
MnTb_L2_6_2 d1bar_L3 vcn ctp_L2_6 0 NSYN W=10u L=1u
MnTa_L2_6_2 dpre_L3_3 vcn ctn_L2_6 0 NSYN W=10u L=1u
MpTb_L2_6_2 d1bar_L3 gp_3_3_0 ctn_L2_6 0 NSYN W=10u L=1u
MpTa_L2_6_3 dpre_L3_4 gp_3_4_2 ctp_L2_6 0 NSYN W=10u L=1u
MnTb_L2_6_3 d1bar_L3 vcn ctp_L2_6 0 NSYN W=10u L=1u
MnTa_L2_6_3 dpre_L3_4 vcn ctn_L2_6 0 NSYN W=10u L=1u
MpTb_L2_6_3 d1bar_L3 gp_3_4_2 ctn_L2_6 0 NSYN W=10u L=1u
MpTa_L2_6_4 dpre_L3_8 gp_3_8_1 ctp_L2_6 0 NSYN W=10u L=1u
MnTb_L2_6_4 d1bar_L3 vcn ctp_L2_6 0 NSYN W=10u L=1u
MnTa_L2_6_4 dpre_L3_8 vcn ctn_L2_6 0 NSYN W=10u L=1u
MpTb_L2_6_4 d1bar_L3 gp_3_8_1 ctn_L2_6 0 NSYN W=10u L=1u
MpTa_L2_6_5 dpre_L3_9 gp_3_9_2 ctp_L2_6 0 NSYN W=10u L=1u
MnTb_L2_6_5 d1bar_L3 vcn ctp_L2_6 0 NSYN W=10u L=1u
MnTa_L2_6_5 dpre_L3_9 vcn ctn_L2_6 0 NSYN W=10u L=1u
MpTb_L2_6_5 d1bar_L3 gp_3_9_2 ctn_L2_6 0 NSYN W=10u L=1u
MpTa_L2_6_6 dpre_L3_17 gp_3_17_2 ctp_L2_6 0 NSYN W=10u L=1u
MnTb_L2_6_6 d1bar_L3 vcn ctp_L2_6 0 NSYN W=10u L=1u
MnTa_L2_6_6 dpre_L3_17 vcn ctn_L2_6 0 NSYN W=10u L=1u
MpTb_L2_6_6 d1bar_L3 gp_3_17_2 ctn_L2_6 0 NSYN W=10u L=1u
MpTa_L2_6_7 dpre_L3_23 gp_3_23_0 ctp_L2_6 0 NSYN W=10u L=1u
MnTb_L2_6_7 d1bar_L3 vcn ctp_L2_6 0 NSYN W=10u L=1u
MnTa_L2_6_7 dpre_L3_23 vcn ctn_L2_6 0 NSYN W=10u L=1u
MpTb_L2_6_7 d1bar_L3 gp_3_23_0 ctn_L2_6 0 NSYN W=10u L=1u
MpTa_L2_6_8 dpre_L3_26 gp_3_26_2 ctp_L2_6 0 NSYN W=10u L=1u
MnTb_L2_6_8 d1bar_L3 vcn ctp_L2_6 0 NSYN W=10u L=1u
MnTa_L2_6_8 dpre_L3_26 vcn ctn_L2_6 0 NSYN W=10u L=1u
MpTb_L2_6_8 d1bar_L3 gp_3_26_2 ctn_L2_6 0 NSYN W=10u L=1u
MpTa_L2_6_9 dpre_L3_34 gp_3_34_0 ctp_L2_6 0 NSYN W=10u L=1u
MnTb_L2_6_9 d1bar_L3 vcn ctp_L2_6 0 NSYN W=10u L=1u
MnTa_L2_6_9 dpre_L3_34 vcn ctn_L2_6 0 NSYN W=10u L=1u
MpTb_L2_6_9 d1bar_L3 gp_3_34_0 ctn_L2_6 0 NSYN W=10u L=1u
MpTa_L2_6_10 dpre_L3_39 gp_3_39_1 ctp_L2_6 0 NSYN W=10u L=1u
MnTb_L2_6_10 d1bar_L3 vcn ctp_L2_6 0 NSYN W=10u L=1u
MnTa_L2_6_10 dpre_L3_39 vcn ctn_L2_6 0 NSYN W=10u L=1u
MpTb_L2_6_10 d1bar_L3 gp_3_39_1 ctn_L2_6 0 NSYN W=10u L=1u
MpTa_L2_6_11 dpre_L3_42 gp_3_42_2 ctp_L2_6 0 NSYN W=10u L=1u
MnTb_L2_6_11 d1bar_L3 vcn ctp_L2_6 0 NSYN W=10u L=1u
MnTa_L2_6_11 dpre_L3_42 vcn ctn_L2_6 0 NSYN W=10u L=1u
MpTb_L2_6_11 d1bar_L3 gp_3_42_2 ctn_L2_6 0 NSYN W=10u L=1u
MpTa_L2_6_12 dpre_L3_43 gp_3_43_3 ctp_L2_6 0 NSYN W=10u L=1u
MnTb_L2_6_12 d1bar_L3 vcn ctp_L2_6 0 NSYN W=10u L=1u
MnTa_L2_6_12 dpre_L3_43 vcn ctn_L2_6 0 NSYN W=10u L=1u
MpTb_L2_6_12 d1bar_L3 gp_3_43_3 ctn_L2_6 0 NSYN W=10u L=1u
Msa_bk_L2_6 ctn_L2_6 ctn_L2_6 0 0 NMIR W=20u L=1u
Msb_bk_L2_6 dpre_L2_6 ctn_L2_6 0 0 NMIR W=20u L=1u
Msc_bk_L2_6 ctp_L2_6 ctp_L2_6 0 0 NMIR W=20u L=1u
Msd_bk_L2_6 dpf_bk_L2_6 ctp_L2_6 0 0 NMIR W=20u L=1u
Mse_bk_L2_6 dpf_bk_L2_6 dpf_bk_L2_6 vdd vdd PMIR W=60u L=1u
Msf_bk_L2_6 dpre_L2_6 dpf_bk_L2_6 vdd vdd PMIR W=60u L=1u
R_bk_L2_6 dpre_L2_6 vrefd 16000.0
MpTa_L2_7_0 dpre_L3_7 gp_3_7_2 ctp_L2_7 0 NSYN W=10u L=1u
MnTb_L2_7_0 d1bar_L3 vcn ctp_L2_7 0 NSYN W=10u L=1u
MnTa_L2_7_0 dpre_L3_7 vcn ctn_L2_7 0 NSYN W=10u L=1u
MpTb_L2_7_0 d1bar_L3 gp_3_7_2 ctn_L2_7 0 NSYN W=10u L=1u
MpTa_L2_7_1 dpre_L3_12 gp_3_12_0 ctp_L2_7 0 NSYN W=10u L=1u
MnTb_L2_7_1 d1bar_L3 vcn ctp_L2_7 0 NSYN W=10u L=1u
MnTa_L2_7_1 dpre_L3_12 vcn ctn_L2_7 0 NSYN W=10u L=1u
MpTb_L2_7_1 d1bar_L3 gp_3_12_0 ctn_L2_7 0 NSYN W=10u L=1u
MpTa_L2_7_2 dpre_L3_14 gp_3_14_0 ctp_L2_7 0 NSYN W=10u L=1u
MnTb_L2_7_2 d1bar_L3 vcn ctp_L2_7 0 NSYN W=10u L=1u
MnTa_L2_7_2 dpre_L3_14 vcn ctn_L2_7 0 NSYN W=10u L=1u
MpTb_L2_7_2 d1bar_L3 gp_3_14_0 ctn_L2_7 0 NSYN W=10u L=1u
MpTa_L2_7_3 dpre_L3_17 gp_3_17_3 ctp_L2_7 0 NSYN W=10u L=1u
MnTb_L2_7_3 d1bar_L3 vcn ctp_L2_7 0 NSYN W=10u L=1u
MnTa_L2_7_3 dpre_L3_17 vcn ctn_L2_7 0 NSYN W=10u L=1u
MpTb_L2_7_3 d1bar_L3 gp_3_17_3 ctn_L2_7 0 NSYN W=10u L=1u
MpTa_L2_7_4 dpre_L3_20 gp_3_20_3 ctp_L2_7 0 NSYN W=10u L=1u
MnTb_L2_7_4 d1bar_L3 vcn ctp_L2_7 0 NSYN W=10u L=1u
MnTa_L2_7_4 dpre_L3_20 vcn ctn_L2_7 0 NSYN W=10u L=1u
MpTb_L2_7_4 d1bar_L3 gp_3_20_3 ctn_L2_7 0 NSYN W=10u L=1u
MpTa_L2_7_5 dpre_L3_21 gp_3_21_1 ctp_L2_7 0 NSYN W=10u L=1u
MnTb_L2_7_5 d1bar_L3 vcn ctp_L2_7 0 NSYN W=10u L=1u
MnTa_L2_7_5 dpre_L3_21 vcn ctn_L2_7 0 NSYN W=10u L=1u
MpTb_L2_7_5 d1bar_L3 gp_3_21_1 ctn_L2_7 0 NSYN W=10u L=1u
MpTa_L2_7_6 dpre_L3_22 gp_3_22_2 ctp_L2_7 0 NSYN W=10u L=1u
MnTb_L2_7_6 d1bar_L3 vcn ctp_L2_7 0 NSYN W=10u L=1u
MnTa_L2_7_6 dpre_L3_22 vcn ctn_L2_7 0 NSYN W=10u L=1u
MpTb_L2_7_6 d1bar_L3 gp_3_22_2 ctn_L2_7 0 NSYN W=10u L=1u
MpTa_L2_7_7 dpre_L3_23 gp_3_23_1 ctp_L2_7 0 NSYN W=10u L=1u
MnTb_L2_7_7 d1bar_L3 vcn ctp_L2_7 0 NSYN W=10u L=1u
MnTa_L2_7_7 dpre_L3_23 vcn ctn_L2_7 0 NSYN W=10u L=1u
MpTb_L2_7_7 d1bar_L3 gp_3_23_1 ctn_L2_7 0 NSYN W=10u L=1u
MpTa_L2_7_8 dpre_L3_25 gp_3_25_2 ctp_L2_7 0 NSYN W=10u L=1u
MnTb_L2_7_8 d1bar_L3 vcn ctp_L2_7 0 NSYN W=10u L=1u
MnTa_L2_7_8 dpre_L3_25 vcn ctn_L2_7 0 NSYN W=10u L=1u
MpTb_L2_7_8 d1bar_L3 gp_3_25_2 ctn_L2_7 0 NSYN W=10u L=1u
MpTa_L2_7_9 dpre_L3_28 gp_3_28_4 ctp_L2_7 0 NSYN W=10u L=1u
MnTb_L2_7_9 d1bar_L3 vcn ctp_L2_7 0 NSYN W=10u L=1u
MnTa_L2_7_9 dpre_L3_28 vcn ctn_L2_7 0 NSYN W=10u L=1u
MpTb_L2_7_9 d1bar_L3 gp_3_28_4 ctn_L2_7 0 NSYN W=10u L=1u
MpTa_L2_7_10 dpre_L3_32 gp_3_32_2 ctp_L2_7 0 NSYN W=10u L=1u
MnTb_L2_7_10 d1bar_L3 vcn ctp_L2_7 0 NSYN W=10u L=1u
MnTa_L2_7_10 dpre_L3_32 vcn ctn_L2_7 0 NSYN W=10u L=1u
MpTb_L2_7_10 d1bar_L3 gp_3_32_2 ctn_L2_7 0 NSYN W=10u L=1u
MpTa_L2_7_11 dpre_L3_34 gp_3_34_1 ctp_L2_7 0 NSYN W=10u L=1u
MnTb_L2_7_11 d1bar_L3 vcn ctp_L2_7 0 NSYN W=10u L=1u
MnTa_L2_7_11 dpre_L3_34 vcn ctn_L2_7 0 NSYN W=10u L=1u
MpTb_L2_7_11 d1bar_L3 gp_3_34_1 ctn_L2_7 0 NSYN W=10u L=1u
MpTa_L2_7_12 dpre_L3_36 gp_3_36_2 ctp_L2_7 0 NSYN W=10u L=1u
MnTb_L2_7_12 d1bar_L3 vcn ctp_L2_7 0 NSYN W=10u L=1u
MnTa_L2_7_12 dpre_L3_36 vcn ctn_L2_7 0 NSYN W=10u L=1u
MpTb_L2_7_12 d1bar_L3 gp_3_36_2 ctn_L2_7 0 NSYN W=10u L=1u
MpTa_L2_7_13 dpre_L3_39 gp_3_39_2 ctp_L2_7 0 NSYN W=10u L=1u
MnTb_L2_7_13 d1bar_L3 vcn ctp_L2_7 0 NSYN W=10u L=1u
MnTa_L2_7_13 dpre_L3_39 vcn ctn_L2_7 0 NSYN W=10u L=1u
MpTb_L2_7_13 d1bar_L3 gp_3_39_2 ctn_L2_7 0 NSYN W=10u L=1u
MpTa_L2_7_14 dpre_L3_41 gp_3_41_1 ctp_L2_7 0 NSYN W=10u L=1u
MnTb_L2_7_14 d1bar_L3 vcn ctp_L2_7 0 NSYN W=10u L=1u
MnTa_L2_7_14 dpre_L3_41 vcn ctn_L2_7 0 NSYN W=10u L=1u
MpTb_L2_7_14 d1bar_L3 gp_3_41_1 ctn_L2_7 0 NSYN W=10u L=1u
MpTa_L2_7_15 dpre_L3_45 gp_3_45_4 ctp_L2_7 0 NSYN W=10u L=1u
MnTb_L2_7_15 d1bar_L3 vcn ctp_L2_7 0 NSYN W=10u L=1u
MnTa_L2_7_15 dpre_L3_45 vcn ctn_L2_7 0 NSYN W=10u L=1u
MpTb_L2_7_15 d1bar_L3 gp_3_45_4 ctn_L2_7 0 NSYN W=10u L=1u
Msa_bk_L2_7 ctn_L2_7 ctn_L2_7 0 0 NMIR W=20u L=1u
Msb_bk_L2_7 dpre_L2_7 ctn_L2_7 0 0 NMIR W=20u L=1u
Msc_bk_L2_7 ctp_L2_7 ctp_L2_7 0 0 NMIR W=20u L=1u
Msd_bk_L2_7 dpf_bk_L2_7 ctp_L2_7 0 0 NMIR W=20u L=1u
Mse_bk_L2_7 dpf_bk_L2_7 dpf_bk_L2_7 vdd vdd PMIR W=60u L=1u
Msf_bk_L2_7 dpre_L2_7 dpf_bk_L2_7 vdd vdd PMIR W=60u L=1u
R_bk_L2_7 dpre_L2_7 vrefd 16000.0
MpTa_L2_8_0 dpre_L3_0 gp_3_0_2 ctp_L2_8 0 NSYN W=10u L=1u
MnTb_L2_8_0 d1bar_L3 vcn ctp_L2_8 0 NSYN W=10u L=1u
MnTa_L2_8_0 dpre_L3_0 vcn ctn_L2_8 0 NSYN W=10u L=1u
MpTb_L2_8_0 d1bar_L3 gp_3_0_2 ctn_L2_8 0 NSYN W=10u L=1u
MpTa_L2_8_1 dpre_L3_4 gp_3_4_3 ctp_L2_8 0 NSYN W=10u L=1u
MnTb_L2_8_1 d1bar_L3 vcn ctp_L2_8 0 NSYN W=10u L=1u
MnTa_L2_8_1 dpre_L3_4 vcn ctn_L2_8 0 NSYN W=10u L=1u
MpTb_L2_8_1 d1bar_L3 gp_3_4_3 ctn_L2_8 0 NSYN W=10u L=1u
MpTa_L2_8_2 dpre_L3_5 gp_3_5_2 ctp_L2_8 0 NSYN W=10u L=1u
MnTb_L2_8_2 d1bar_L3 vcn ctp_L2_8 0 NSYN W=10u L=1u
MnTa_L2_8_2 dpre_L3_5 vcn ctn_L2_8 0 NSYN W=10u L=1u
MpTb_L2_8_2 d1bar_L3 gp_3_5_2 ctn_L2_8 0 NSYN W=10u L=1u
MpTa_L2_8_3 dpre_L3_10 gp_3_10_0 ctp_L2_8 0 NSYN W=10u L=1u
MnTb_L2_8_3 d1bar_L3 vcn ctp_L2_8 0 NSYN W=10u L=1u
MnTa_L2_8_3 dpre_L3_10 vcn ctn_L2_8 0 NSYN W=10u L=1u
MpTb_L2_8_3 d1bar_L3 gp_3_10_0 ctn_L2_8 0 NSYN W=10u L=1u
MpTa_L2_8_4 dpre_L3_13 gp_3_13_3 ctp_L2_8 0 NSYN W=10u L=1u
MnTb_L2_8_4 d1bar_L3 vcn ctp_L2_8 0 NSYN W=10u L=1u
MnTa_L2_8_4 dpre_L3_13 vcn ctn_L2_8 0 NSYN W=10u L=1u
MpTb_L2_8_4 d1bar_L3 gp_3_13_3 ctn_L2_8 0 NSYN W=10u L=1u
MpTa_L2_8_5 dpre_L3_15 gp_3_15_4 ctp_L2_8 0 NSYN W=10u L=1u
MnTb_L2_8_5 d1bar_L3 vcn ctp_L2_8 0 NSYN W=10u L=1u
MnTa_L2_8_5 dpre_L3_15 vcn ctn_L2_8 0 NSYN W=10u L=1u
MpTb_L2_8_5 d1bar_L3 gp_3_15_4 ctn_L2_8 0 NSYN W=10u L=1u
MpTa_L2_8_6 dpre_L3_16 gp_3_16_1 ctp_L2_8 0 NSYN W=10u L=1u
MnTb_L2_8_6 d1bar_L3 vcn ctp_L2_8 0 NSYN W=10u L=1u
MnTa_L2_8_6 dpre_L3_16 vcn ctn_L2_8 0 NSYN W=10u L=1u
MpTb_L2_8_6 d1bar_L3 gp_3_16_1 ctn_L2_8 0 NSYN W=10u L=1u
MpTa_L2_8_7 dpre_L3_17 gp_3_17_4 ctp_L2_8 0 NSYN W=10u L=1u
MnTb_L2_8_7 d1bar_L3 vcn ctp_L2_8 0 NSYN W=10u L=1u
MnTa_L2_8_7 dpre_L3_17 vcn ctn_L2_8 0 NSYN W=10u L=1u
MpTb_L2_8_7 d1bar_L3 gp_3_17_4 ctn_L2_8 0 NSYN W=10u L=1u
MpTa_L2_8_8 dpre_L3_22 gp_3_22_3 ctp_L2_8 0 NSYN W=10u L=1u
MnTb_L2_8_8 d1bar_L3 vcn ctp_L2_8 0 NSYN W=10u L=1u
MnTa_L2_8_8 dpre_L3_22 vcn ctn_L2_8 0 NSYN W=10u L=1u
MpTb_L2_8_8 d1bar_L3 gp_3_22_3 ctn_L2_8 0 NSYN W=10u L=1u
MpTa_L2_8_9 dpre_L3_24 gp_3_24_2 ctp_L2_8 0 NSYN W=10u L=1u
MnTb_L2_8_9 d1bar_L3 vcn ctp_L2_8 0 NSYN W=10u L=1u
MnTa_L2_8_9 dpre_L3_24 vcn ctn_L2_8 0 NSYN W=10u L=1u
MpTb_L2_8_9 d1bar_L3 gp_3_24_2 ctn_L2_8 0 NSYN W=10u L=1u
MpTa_L2_8_10 dpre_L3_25 gp_3_25_3 ctp_L2_8 0 NSYN W=10u L=1u
MnTb_L2_8_10 d1bar_L3 vcn ctp_L2_8 0 NSYN W=10u L=1u
MnTa_L2_8_10 dpre_L3_25 vcn ctn_L2_8 0 NSYN W=10u L=1u
MpTb_L2_8_10 d1bar_L3 gp_3_25_3 ctn_L2_8 0 NSYN W=10u L=1u
MpTa_L2_8_11 dpre_L3_30 gp_3_30_1 ctp_L2_8 0 NSYN W=10u L=1u
MnTb_L2_8_11 d1bar_L3 vcn ctp_L2_8 0 NSYN W=10u L=1u
MnTa_L2_8_11 dpre_L3_30 vcn ctn_L2_8 0 NSYN W=10u L=1u
MpTb_L2_8_11 d1bar_L3 gp_3_30_1 ctn_L2_8 0 NSYN W=10u L=1u
MpTa_L2_8_12 dpre_L3_32 gp_3_32_3 ctp_L2_8 0 NSYN W=10u L=1u
MnTb_L2_8_12 d1bar_L3 vcn ctp_L2_8 0 NSYN W=10u L=1u
MnTa_L2_8_12 dpre_L3_32 vcn ctn_L2_8 0 NSYN W=10u L=1u
MpTb_L2_8_12 d1bar_L3 gp_3_32_3 ctn_L2_8 0 NSYN W=10u L=1u
MpTa_L2_8_13 dpre_L3_41 gp_3_41_2 ctp_L2_8 0 NSYN W=10u L=1u
MnTb_L2_8_13 d1bar_L3 vcn ctp_L2_8 0 NSYN W=10u L=1u
MnTa_L2_8_13 dpre_L3_41 vcn ctn_L2_8 0 NSYN W=10u L=1u
MpTb_L2_8_13 d1bar_L3 gp_3_41_2 ctn_L2_8 0 NSYN W=10u L=1u
MpTa_L2_8_14 dpre_L3_43 gp_3_43_4 ctp_L2_8 0 NSYN W=10u L=1u
MnTb_L2_8_14 d1bar_L3 vcn ctp_L2_8 0 NSYN W=10u L=1u
MnTa_L2_8_14 dpre_L3_43 vcn ctn_L2_8 0 NSYN W=10u L=1u
MpTb_L2_8_14 d1bar_L3 gp_3_43_4 ctn_L2_8 0 NSYN W=10u L=1u
MpTa_L2_8_15 dpre_L3_46 gp_3_46_4 ctp_L2_8 0 NSYN W=10u L=1u
MnTb_L2_8_15 d1bar_L3 vcn ctp_L2_8 0 NSYN W=10u L=1u
MnTa_L2_8_15 dpre_L3_46 vcn ctn_L2_8 0 NSYN W=10u L=1u
MpTb_L2_8_15 d1bar_L3 gp_3_46_4 ctn_L2_8 0 NSYN W=10u L=1u
Msa_bk_L2_8 ctn_L2_8 ctn_L2_8 0 0 NMIR W=20u L=1u
Msb_bk_L2_8 dpre_L2_8 ctn_L2_8 0 0 NMIR W=20u L=1u
Msc_bk_L2_8 ctp_L2_8 ctp_L2_8 0 0 NMIR W=20u L=1u
Msd_bk_L2_8 dpf_bk_L2_8 ctp_L2_8 0 0 NMIR W=20u L=1u
Mse_bk_L2_8 dpf_bk_L2_8 dpf_bk_L2_8 vdd vdd PMIR W=60u L=1u
Msf_bk_L2_8 dpre_L2_8 dpf_bk_L2_8 vdd vdd PMIR W=60u L=1u
R_bk_L2_8 dpre_L2_8 vrefd 16000.0
MpTa_L2_9_0 dpre_L3_7 gp_3_7_3 ctp_L2_9 0 NSYN W=10u L=1u
MnTb_L2_9_0 d1bar_L3 vcn ctp_L2_9 0 NSYN W=10u L=1u
MnTa_L2_9_0 dpre_L3_7 vcn ctn_L2_9 0 NSYN W=10u L=1u
MpTb_L2_9_0 d1bar_L3 gp_3_7_3 ctn_L2_9 0 NSYN W=10u L=1u
MpTa_L2_9_1 dpre_L3_10 gp_3_10_1 ctp_L2_9 0 NSYN W=10u L=1u
MnTb_L2_9_1 d1bar_L3 vcn ctp_L2_9 0 NSYN W=10u L=1u
MnTa_L2_9_1 dpre_L3_10 vcn ctn_L2_9 0 NSYN W=10u L=1u
MpTb_L2_9_1 d1bar_L3 gp_3_10_1 ctn_L2_9 0 NSYN W=10u L=1u
MpTa_L2_9_2 dpre_L3_11 gp_3_11_3 ctp_L2_9 0 NSYN W=10u L=1u
MnTb_L2_9_2 d1bar_L3 vcn ctp_L2_9 0 NSYN W=10u L=1u
MnTa_L2_9_2 dpre_L3_11 vcn ctn_L2_9 0 NSYN W=10u L=1u
MpTb_L2_9_2 d1bar_L3 gp_3_11_3 ctn_L2_9 0 NSYN W=10u L=1u
MpTa_L2_9_3 dpre_L3_13 gp_3_13_4 ctp_L2_9 0 NSYN W=10u L=1u
MnTb_L2_9_3 d1bar_L3 vcn ctp_L2_9 0 NSYN W=10u L=1u
MnTa_L2_9_3 dpre_L3_13 vcn ctn_L2_9 0 NSYN W=10u L=1u
MpTb_L2_9_3 d1bar_L3 gp_3_13_4 ctn_L2_9 0 NSYN W=10u L=1u
MpTa_L2_9_4 dpre_L3_14 gp_3_14_1 ctp_L2_9 0 NSYN W=10u L=1u
MnTb_L2_9_4 d1bar_L3 vcn ctp_L2_9 0 NSYN W=10u L=1u
MnTa_L2_9_4 dpre_L3_14 vcn ctn_L2_9 0 NSYN W=10u L=1u
MpTb_L2_9_4 d1bar_L3 gp_3_14_1 ctn_L2_9 0 NSYN W=10u L=1u
MpTa_L2_9_5 dpre_L3_19 gp_3_19_1 ctp_L2_9 0 NSYN W=10u L=1u
MnTb_L2_9_5 d1bar_L3 vcn ctp_L2_9 0 NSYN W=10u L=1u
MnTa_L2_9_5 dpre_L3_19 vcn ctn_L2_9 0 NSYN W=10u L=1u
MpTb_L2_9_5 d1bar_L3 gp_3_19_1 ctn_L2_9 0 NSYN W=10u L=1u
MpTa_L2_9_6 dpre_L3_20 gp_3_20_4 ctp_L2_9 0 NSYN W=10u L=1u
MnTb_L2_9_6 d1bar_L3 vcn ctp_L2_9 0 NSYN W=10u L=1u
MnTa_L2_9_6 dpre_L3_20 vcn ctn_L2_9 0 NSYN W=10u L=1u
MpTb_L2_9_6 d1bar_L3 gp_3_20_4 ctn_L2_9 0 NSYN W=10u L=1u
MpTa_L2_9_7 dpre_L3_21 gp_3_21_2 ctp_L2_9 0 NSYN W=10u L=1u
MnTb_L2_9_7 d1bar_L3 vcn ctp_L2_9 0 NSYN W=10u L=1u
MnTa_L2_9_7 dpre_L3_21 vcn ctn_L2_9 0 NSYN W=10u L=1u
MpTb_L2_9_7 d1bar_L3 gp_3_21_2 ctn_L2_9 0 NSYN W=10u L=1u
MpTa_L2_9_8 dpre_L3_26 gp_3_26_3 ctp_L2_9 0 NSYN W=10u L=1u
MnTb_L2_9_8 d1bar_L3 vcn ctp_L2_9 0 NSYN W=10u L=1u
MnTa_L2_9_8 dpre_L3_26 vcn ctn_L2_9 0 NSYN W=10u L=1u
MpTb_L2_9_8 d1bar_L3 gp_3_26_3 ctn_L2_9 0 NSYN W=10u L=1u
MpTa_L2_9_9 dpre_L3_29 gp_3_29_2 ctp_L2_9 0 NSYN W=10u L=1u
MnTb_L2_9_9 d1bar_L3 vcn ctp_L2_9 0 NSYN W=10u L=1u
MnTa_L2_9_9 dpre_L3_29 vcn ctn_L2_9 0 NSYN W=10u L=1u
MpTb_L2_9_9 d1bar_L3 gp_3_29_2 ctn_L2_9 0 NSYN W=10u L=1u
MpTa_L2_9_10 dpre_L3_32 gp_3_32_4 ctp_L2_9 0 NSYN W=10u L=1u
MnTb_L2_9_10 d1bar_L3 vcn ctp_L2_9 0 NSYN W=10u L=1u
MnTa_L2_9_10 dpre_L3_32 vcn ctn_L2_9 0 NSYN W=10u L=1u
MpTb_L2_9_10 d1bar_L3 gp_3_32_4 ctn_L2_9 0 NSYN W=10u L=1u
MpTa_L2_9_11 dpre_L3_34 gp_3_34_2 ctp_L2_9 0 NSYN W=10u L=1u
MnTb_L2_9_11 d1bar_L3 vcn ctp_L2_9 0 NSYN W=10u L=1u
MnTa_L2_9_11 dpre_L3_34 vcn ctn_L2_9 0 NSYN W=10u L=1u
MpTb_L2_9_11 d1bar_L3 gp_3_34_2 ctn_L2_9 0 NSYN W=10u L=1u
MpTa_L2_9_12 dpre_L3_36 gp_3_36_3 ctp_L2_9 0 NSYN W=10u L=1u
MnTb_L2_9_12 d1bar_L3 vcn ctp_L2_9 0 NSYN W=10u L=1u
MnTa_L2_9_12 dpre_L3_36 vcn ctn_L2_9 0 NSYN W=10u L=1u
MpTb_L2_9_12 d1bar_L3 gp_3_36_3 ctn_L2_9 0 NSYN W=10u L=1u
MpTa_L2_9_13 dpre_L3_40 gp_3_40_2 ctp_L2_9 0 NSYN W=10u L=1u
MnTb_L2_9_13 d1bar_L3 vcn ctp_L2_9 0 NSYN W=10u L=1u
MnTa_L2_9_13 dpre_L3_40 vcn ctn_L2_9 0 NSYN W=10u L=1u
MpTb_L2_9_13 d1bar_L3 gp_3_40_2 ctn_L2_9 0 NSYN W=10u L=1u
MpTa_L2_9_14 dpre_L3_41 gp_3_41_3 ctp_L2_9 0 NSYN W=10u L=1u
MnTb_L2_9_14 d1bar_L3 vcn ctp_L2_9 0 NSYN W=10u L=1u
MnTa_L2_9_14 dpre_L3_41 vcn ctn_L2_9 0 NSYN W=10u L=1u
MpTb_L2_9_14 d1bar_L3 gp_3_41_3 ctn_L2_9 0 NSYN W=10u L=1u
MpTa_L2_9_15 dpre_L3_42 gp_3_42_3 ctp_L2_9 0 NSYN W=10u L=1u
MnTb_L2_9_15 d1bar_L3 vcn ctp_L2_9 0 NSYN W=10u L=1u
MnTa_L2_9_15 dpre_L3_42 vcn ctn_L2_9 0 NSYN W=10u L=1u
MpTb_L2_9_15 d1bar_L3 gp_3_42_3 ctn_L2_9 0 NSYN W=10u L=1u
Msa_bk_L2_9 ctn_L2_9 ctn_L2_9 0 0 NMIR W=20u L=1u
Msb_bk_L2_9 dpre_L2_9 ctn_L2_9 0 0 NMIR W=20u L=1u
Msc_bk_L2_9 ctp_L2_9 ctp_L2_9 0 0 NMIR W=20u L=1u
Msd_bk_L2_9 dpf_bk_L2_9 ctp_L2_9 0 0 NMIR W=20u L=1u
Mse_bk_L2_9 dpf_bk_L2_9 dpf_bk_L2_9 vdd vdd PMIR W=60u L=1u
Msf_bk_L2_9 dpre_L2_9 dpf_bk_L2_9 vdd vdd PMIR W=60u L=1u
R_bk_L2_9 dpre_L2_9 vrefd 16000.0
MpTa_L2_10_0 dpre_L3_2 gp_3_2_2 ctp_L2_10 0 NSYN W=10u L=1u
MnTb_L2_10_0 d1bar_L3 vcn ctp_L2_10 0 NSYN W=10u L=1u
MnTa_L2_10_0 dpre_L3_2 vcn ctn_L2_10 0 NSYN W=10u L=1u
MpTb_L2_10_0 d1bar_L3 gp_3_2_2 ctn_L2_10 0 NSYN W=10u L=1u
MpTa_L2_10_1 dpre_L3_4 gp_3_4_4 ctp_L2_10 0 NSYN W=10u L=1u
MnTb_L2_10_1 d1bar_L3 vcn ctp_L2_10 0 NSYN W=10u L=1u
MnTa_L2_10_1 dpre_L3_4 vcn ctn_L2_10 0 NSYN W=10u L=1u
MpTb_L2_10_1 d1bar_L3 gp_3_4_4 ctn_L2_10 0 NSYN W=10u L=1u
MpTa_L2_10_2 dpre_L3_6 gp_3_6_2 ctp_L2_10 0 NSYN W=10u L=1u
MnTb_L2_10_2 d1bar_L3 vcn ctp_L2_10 0 NSYN W=10u L=1u
MnTa_L2_10_2 dpre_L3_6 vcn ctn_L2_10 0 NSYN W=10u L=1u
MpTb_L2_10_2 d1bar_L3 gp_3_6_2 ctn_L2_10 0 NSYN W=10u L=1u
MpTa_L2_10_3 dpre_L3_7 gp_3_7_4 ctp_L2_10 0 NSYN W=10u L=1u
MnTb_L2_10_3 d1bar_L3 vcn ctp_L2_10 0 NSYN W=10u L=1u
MnTa_L2_10_3 dpre_L3_7 vcn ctn_L2_10 0 NSYN W=10u L=1u
MpTb_L2_10_3 d1bar_L3 gp_3_7_4 ctn_L2_10 0 NSYN W=10u L=1u
MpTa_L2_10_4 dpre_L3_10 gp_3_10_2 ctp_L2_10 0 NSYN W=10u L=1u
MnTb_L2_10_4 d1bar_L3 vcn ctp_L2_10 0 NSYN W=10u L=1u
MnTa_L2_10_4 dpre_L3_10 vcn ctn_L2_10 0 NSYN W=10u L=1u
MpTb_L2_10_4 d1bar_L3 gp_3_10_2 ctn_L2_10 0 NSYN W=10u L=1u
MpTa_L2_10_5 dpre_L3_24 gp_3_24_3 ctp_L2_10 0 NSYN W=10u L=1u
MnTb_L2_10_5 d1bar_L3 vcn ctp_L2_10 0 NSYN W=10u L=1u
MnTa_L2_10_5 dpre_L3_24 vcn ctn_L2_10 0 NSYN W=10u L=1u
MpTb_L2_10_5 d1bar_L3 gp_3_24_3 ctn_L2_10 0 NSYN W=10u L=1u
MpTa_L2_10_6 dpre_L3_28 gp_3_28_5 ctp_L2_10 0 NSYN W=10u L=1u
MnTb_L2_10_6 d1bar_L3 vcn ctp_L2_10 0 NSYN W=10u L=1u
MnTa_L2_10_6 dpre_L3_28 vcn ctn_L2_10 0 NSYN W=10u L=1u
MpTb_L2_10_6 d1bar_L3 gp_3_28_5 ctn_L2_10 0 NSYN W=10u L=1u
MpTa_L2_10_7 dpre_L3_31 gp_3_31_2 ctp_L2_10 0 NSYN W=10u L=1u
MnTb_L2_10_7 d1bar_L3 vcn ctp_L2_10 0 NSYN W=10u L=1u
MnTa_L2_10_7 dpre_L3_31 vcn ctn_L2_10 0 NSYN W=10u L=1u
MpTb_L2_10_7 d1bar_L3 gp_3_31_2 ctn_L2_10 0 NSYN W=10u L=1u
MpTa_L2_10_8 dpre_L3_33 gp_3_33_3 ctp_L2_10 0 NSYN W=10u L=1u
MnTb_L2_10_8 d1bar_L3 vcn ctp_L2_10 0 NSYN W=10u L=1u
MnTa_L2_10_8 dpre_L3_33 vcn ctn_L2_10 0 NSYN W=10u L=1u
MpTb_L2_10_8 d1bar_L3 gp_3_33_3 ctn_L2_10 0 NSYN W=10u L=1u
MpTa_L2_10_9 dpre_L3_36 gp_3_36_4 ctp_L2_10 0 NSYN W=10u L=1u
MnTb_L2_10_9 d1bar_L3 vcn ctp_L2_10 0 NSYN W=10u L=1u
MnTa_L2_10_9 dpre_L3_36 vcn ctn_L2_10 0 NSYN W=10u L=1u
MpTb_L2_10_9 d1bar_L3 gp_3_36_4 ctn_L2_10 0 NSYN W=10u L=1u
MpTa_L2_10_10 dpre_L3_40 gp_3_40_3 ctp_L2_10 0 NSYN W=10u L=1u
MnTb_L2_10_10 d1bar_L3 vcn ctp_L2_10 0 NSYN W=10u L=1u
MnTa_L2_10_10 dpre_L3_40 vcn ctn_L2_10 0 NSYN W=10u L=1u
MpTb_L2_10_10 d1bar_L3 gp_3_40_3 ctn_L2_10 0 NSYN W=10u L=1u
MpTa_L2_10_11 dpre_L3_42 gp_3_42_4 ctp_L2_10 0 NSYN W=10u L=1u
MnTb_L2_10_11 d1bar_L3 vcn ctp_L2_10 0 NSYN W=10u L=1u
MnTa_L2_10_11 dpre_L3_42 vcn ctn_L2_10 0 NSYN W=10u L=1u
MpTb_L2_10_11 d1bar_L3 gp_3_42_4 ctn_L2_10 0 NSYN W=10u L=1u
MpTa_L2_10_12 dpre_L3_43 gp_3_43_5 ctp_L2_10 0 NSYN W=10u L=1u
MnTb_L2_10_12 d1bar_L3 vcn ctp_L2_10 0 NSYN W=10u L=1u
MnTa_L2_10_12 dpre_L3_43 vcn ctn_L2_10 0 NSYN W=10u L=1u
MpTb_L2_10_12 d1bar_L3 gp_3_43_5 ctn_L2_10 0 NSYN W=10u L=1u
Msa_bk_L2_10 ctn_L2_10 ctn_L2_10 0 0 NMIR W=20u L=1u
Msb_bk_L2_10 dpre_L2_10 ctn_L2_10 0 0 NMIR W=20u L=1u
Msc_bk_L2_10 ctp_L2_10 ctp_L2_10 0 0 NMIR W=20u L=1u
Msd_bk_L2_10 dpf_bk_L2_10 ctp_L2_10 0 0 NMIR W=20u L=1u
Mse_bk_L2_10 dpf_bk_L2_10 dpf_bk_L2_10 vdd vdd PMIR W=60u L=1u
Msf_bk_L2_10 dpre_L2_10 dpf_bk_L2_10 vdd vdd PMIR W=60u L=1u
R_bk_L2_10 dpre_L2_10 vrefd 16000.0
MpTa_L2_11_0 dpre_L3_0 gp_3_0_3 ctp_L2_11 0 NSYN W=10u L=1u
MnTb_L2_11_0 d1bar_L3 vcn ctp_L2_11 0 NSYN W=10u L=1u
MnTa_L2_11_0 dpre_L3_0 vcn ctn_L2_11 0 NSYN W=10u L=1u
MpTb_L2_11_0 d1bar_L3 gp_3_0_3 ctn_L2_11 0 NSYN W=10u L=1u
MpTa_L2_11_1 dpre_L3_1 gp_3_1_2 ctp_L2_11 0 NSYN W=10u L=1u
MnTb_L2_11_1 d1bar_L3 vcn ctp_L2_11 0 NSYN W=10u L=1u
MnTa_L2_11_1 dpre_L3_1 vcn ctn_L2_11 0 NSYN W=10u L=1u
MpTb_L2_11_1 d1bar_L3 gp_3_1_2 ctn_L2_11 0 NSYN W=10u L=1u
MpTa_L2_11_2 dpre_L3_2 gp_3_2_3 ctp_L2_11 0 NSYN W=10u L=1u
MnTb_L2_11_2 d1bar_L3 vcn ctp_L2_11 0 NSYN W=10u L=1u
MnTa_L2_11_2 dpre_L3_2 vcn ctn_L2_11 0 NSYN W=10u L=1u
MpTb_L2_11_2 d1bar_L3 gp_3_2_3 ctn_L2_11 0 NSYN W=10u L=1u
MpTa_L2_11_3 dpre_L3_4 gp_3_4_5 ctp_L2_11 0 NSYN W=10u L=1u
MnTb_L2_11_3 d1bar_L3 vcn ctp_L2_11 0 NSYN W=10u L=1u
MnTa_L2_11_3 dpre_L3_4 vcn ctn_L2_11 0 NSYN W=10u L=1u
MpTb_L2_11_3 d1bar_L3 gp_3_4_5 ctn_L2_11 0 NSYN W=10u L=1u
MpTa_L2_11_4 dpre_L3_5 gp_3_5_3 ctp_L2_11 0 NSYN W=10u L=1u
MnTb_L2_11_4 d1bar_L3 vcn ctp_L2_11 0 NSYN W=10u L=1u
MnTa_L2_11_4 dpre_L3_5 vcn ctn_L2_11 0 NSYN W=10u L=1u
MpTb_L2_11_4 d1bar_L3 gp_3_5_3 ctn_L2_11 0 NSYN W=10u L=1u
MpTa_L2_11_5 dpre_L3_6 gp_3_6_3 ctp_L2_11 0 NSYN W=10u L=1u
MnTb_L2_11_5 d1bar_L3 vcn ctp_L2_11 0 NSYN W=10u L=1u
MnTa_L2_11_5 dpre_L3_6 vcn ctn_L2_11 0 NSYN W=10u L=1u
MpTb_L2_11_5 d1bar_L3 gp_3_6_3 ctn_L2_11 0 NSYN W=10u L=1u
MpTa_L2_11_6 dpre_L3_7 gp_3_7_5 ctp_L2_11 0 NSYN W=10u L=1u
MnTb_L2_11_6 d1bar_L3 vcn ctp_L2_11 0 NSYN W=10u L=1u
MnTa_L2_11_6 dpre_L3_7 vcn ctn_L2_11 0 NSYN W=10u L=1u
MpTb_L2_11_6 d1bar_L3 gp_3_7_5 ctn_L2_11 0 NSYN W=10u L=1u
MpTa_L2_11_7 dpre_L3_9 gp_3_9_3 ctp_L2_11 0 NSYN W=10u L=1u
MnTb_L2_11_7 d1bar_L3 vcn ctp_L2_11 0 NSYN W=10u L=1u
MnTa_L2_11_7 dpre_L3_9 vcn ctn_L2_11 0 NSYN W=10u L=1u
MpTb_L2_11_7 d1bar_L3 gp_3_9_3 ctn_L2_11 0 NSYN W=10u L=1u
MpTa_L2_11_8 dpre_L3_10 gp_3_10_3 ctp_L2_11 0 NSYN W=10u L=1u
MnTb_L2_11_8 d1bar_L3 vcn ctp_L2_11 0 NSYN W=10u L=1u
MnTa_L2_11_8 dpre_L3_10 vcn ctn_L2_11 0 NSYN W=10u L=1u
MpTb_L2_11_8 d1bar_L3 gp_3_10_3 ctn_L2_11 0 NSYN W=10u L=1u
MpTa_L2_11_9 dpre_L3_21 gp_3_21_3 ctp_L2_11 0 NSYN W=10u L=1u
MnTb_L2_11_9 d1bar_L3 vcn ctp_L2_11 0 NSYN W=10u L=1u
MnTa_L2_11_9 dpre_L3_21 vcn ctn_L2_11 0 NSYN W=10u L=1u
MpTb_L2_11_9 d1bar_L3 gp_3_21_3 ctn_L2_11 0 NSYN W=10u L=1u
MpTa_L2_11_10 dpre_L3_22 gp_3_22_4 ctp_L2_11 0 NSYN W=10u L=1u
MnTb_L2_11_10 d1bar_L3 vcn ctp_L2_11 0 NSYN W=10u L=1u
MnTa_L2_11_10 dpre_L3_22 vcn ctn_L2_11 0 NSYN W=10u L=1u
MpTb_L2_11_10 d1bar_L3 gp_3_22_4 ctn_L2_11 0 NSYN W=10u L=1u
MpTa_L2_11_11 dpre_L3_26 gp_3_26_4 ctp_L2_11 0 NSYN W=10u L=1u
MnTb_L2_11_11 d1bar_L3 vcn ctp_L2_11 0 NSYN W=10u L=1u
MnTa_L2_11_11 dpre_L3_26 vcn ctn_L2_11 0 NSYN W=10u L=1u
MpTb_L2_11_11 d1bar_L3 gp_3_26_4 ctn_L2_11 0 NSYN W=10u L=1u
MpTa_L2_11_12 dpre_L3_29 gp_3_29_3 ctp_L2_11 0 NSYN W=10u L=1u
MnTb_L2_11_12 d1bar_L3 vcn ctp_L2_11 0 NSYN W=10u L=1u
MnTa_L2_11_12 dpre_L3_29 vcn ctn_L2_11 0 NSYN W=10u L=1u
MpTb_L2_11_12 d1bar_L3 gp_3_29_3 ctn_L2_11 0 NSYN W=10u L=1u
MpTa_L2_11_13 dpre_L3_30 gp_3_30_2 ctp_L2_11 0 NSYN W=10u L=1u
MnTb_L2_11_13 d1bar_L3 vcn ctp_L2_11 0 NSYN W=10u L=1u
MnTa_L2_11_13 dpre_L3_30 vcn ctn_L2_11 0 NSYN W=10u L=1u
MpTb_L2_11_13 d1bar_L3 gp_3_30_2 ctn_L2_11 0 NSYN W=10u L=1u
MpTa_L2_11_14 dpre_L3_33 gp_3_33_4 ctp_L2_11 0 NSYN W=10u L=1u
MnTb_L2_11_14 d1bar_L3 vcn ctp_L2_11 0 NSYN W=10u L=1u
MnTa_L2_11_14 dpre_L3_33 vcn ctn_L2_11 0 NSYN W=10u L=1u
MpTb_L2_11_14 d1bar_L3 gp_3_33_4 ctn_L2_11 0 NSYN W=10u L=1u
MpTa_L2_11_15 dpre_L3_37 gp_3_37_2 ctp_L2_11 0 NSYN W=10u L=1u
MnTb_L2_11_15 d1bar_L3 vcn ctp_L2_11 0 NSYN W=10u L=1u
MnTa_L2_11_15 dpre_L3_37 vcn ctn_L2_11 0 NSYN W=10u L=1u
MpTb_L2_11_15 d1bar_L3 gp_3_37_2 ctn_L2_11 0 NSYN W=10u L=1u
MpTa_L2_11_16 dpre_L3_39 gp_3_39_3 ctp_L2_11 0 NSYN W=10u L=1u
MnTb_L2_11_16 d1bar_L3 vcn ctp_L2_11 0 NSYN W=10u L=1u
MnTa_L2_11_16 dpre_L3_39 vcn ctn_L2_11 0 NSYN W=10u L=1u
MpTb_L2_11_16 d1bar_L3 gp_3_39_3 ctn_L2_11 0 NSYN W=10u L=1u
MpTa_L2_11_17 dpre_L3_40 gp_3_40_4 ctp_L2_11 0 NSYN W=10u L=1u
MnTb_L2_11_17 d1bar_L3 vcn ctp_L2_11 0 NSYN W=10u L=1u
MnTa_L2_11_17 dpre_L3_40 vcn ctn_L2_11 0 NSYN W=10u L=1u
MpTb_L2_11_17 d1bar_L3 gp_3_40_4 ctn_L2_11 0 NSYN W=10u L=1u
MpTa_L2_11_18 dpre_L3_43 gp_3_43_6 ctp_L2_11 0 NSYN W=10u L=1u
MnTb_L2_11_18 d1bar_L3 vcn ctp_L2_11 0 NSYN W=10u L=1u
MnTa_L2_11_18 dpre_L3_43 vcn ctn_L2_11 0 NSYN W=10u L=1u
MpTb_L2_11_18 d1bar_L3 gp_3_43_6 ctn_L2_11 0 NSYN W=10u L=1u
MpTa_L2_11_19 dpre_L3_44 gp_3_44_2 ctp_L2_11 0 NSYN W=10u L=1u
MnTb_L2_11_19 d1bar_L3 vcn ctp_L2_11 0 NSYN W=10u L=1u
MnTa_L2_11_19 dpre_L3_44 vcn ctn_L2_11 0 NSYN W=10u L=1u
MpTb_L2_11_19 d1bar_L3 gp_3_44_2 ctn_L2_11 0 NSYN W=10u L=1u
Msa_bk_L2_11 ctn_L2_11 ctn_L2_11 0 0 NMIR W=20u L=1u
Msb_bk_L2_11 dpre_L2_11 ctn_L2_11 0 0 NMIR W=20u L=1u
Msc_bk_L2_11 ctp_L2_11 ctp_L2_11 0 0 NMIR W=20u L=1u
Msd_bk_L2_11 dpf_bk_L2_11 ctp_L2_11 0 0 NMIR W=20u L=1u
Mse_bk_L2_11 dpf_bk_L2_11 dpf_bk_L2_11 vdd vdd PMIR W=60u L=1u
Msf_bk_L2_11 dpre_L2_11 dpf_bk_L2_11 vdd vdd PMIR W=60u L=1u
R_bk_L2_11 dpre_L2_11 vrefd 16000.0
MpTa_L2_12_0 dpre_L3_2 gp_3_2_4 ctp_L2_12 0 NSYN W=10u L=1u
MnTb_L2_12_0 d1bar_L3 vcn ctp_L2_12 0 NSYN W=10u L=1u
MnTa_L2_12_0 dpre_L3_2 vcn ctn_L2_12 0 NSYN W=10u L=1u
MpTb_L2_12_0 d1bar_L3 gp_3_2_4 ctn_L2_12 0 NSYN W=10u L=1u
MpTa_L2_12_1 dpre_L3_3 gp_3_3_1 ctp_L2_12 0 NSYN W=10u L=1u
MnTb_L2_12_1 d1bar_L3 vcn ctp_L2_12 0 NSYN W=10u L=1u
MnTa_L2_12_1 dpre_L3_3 vcn ctn_L2_12 0 NSYN W=10u L=1u
MpTb_L2_12_1 d1bar_L3 gp_3_3_1 ctn_L2_12 0 NSYN W=10u L=1u
MpTa_L2_12_2 dpre_L3_4 gp_3_4_6 ctp_L2_12 0 NSYN W=10u L=1u
MnTb_L2_12_2 d1bar_L3 vcn ctp_L2_12 0 NSYN W=10u L=1u
MnTa_L2_12_2 dpre_L3_4 vcn ctn_L2_12 0 NSYN W=10u L=1u
MpTb_L2_12_2 d1bar_L3 gp_3_4_6 ctn_L2_12 0 NSYN W=10u L=1u
MpTa_L2_12_3 dpre_L3_6 gp_3_6_4 ctp_L2_12 0 NSYN W=10u L=1u
MnTb_L2_12_3 d1bar_L3 vcn ctp_L2_12 0 NSYN W=10u L=1u
MnTa_L2_12_3 dpre_L3_6 vcn ctn_L2_12 0 NSYN W=10u L=1u
MpTb_L2_12_3 d1bar_L3 gp_3_6_4 ctn_L2_12 0 NSYN W=10u L=1u
MpTa_L2_12_4 dpre_L3_8 gp_3_8_2 ctp_L2_12 0 NSYN W=10u L=1u
MnTb_L2_12_4 d1bar_L3 vcn ctp_L2_12 0 NSYN W=10u L=1u
MnTa_L2_12_4 dpre_L3_8 vcn ctn_L2_12 0 NSYN W=10u L=1u
MpTb_L2_12_4 d1bar_L3 gp_3_8_2 ctn_L2_12 0 NSYN W=10u L=1u
MpTa_L2_12_5 dpre_L3_14 gp_3_14_2 ctp_L2_12 0 NSYN W=10u L=1u
MnTb_L2_12_5 d1bar_L3 vcn ctp_L2_12 0 NSYN W=10u L=1u
MnTa_L2_12_5 dpre_L3_14 vcn ctn_L2_12 0 NSYN W=10u L=1u
MpTb_L2_12_5 d1bar_L3 gp_3_14_2 ctn_L2_12 0 NSYN W=10u L=1u
MpTa_L2_12_6 dpre_L3_15 gp_3_15_5 ctp_L2_12 0 NSYN W=10u L=1u
MnTb_L2_12_6 d1bar_L3 vcn ctp_L2_12 0 NSYN W=10u L=1u
MnTa_L2_12_6 dpre_L3_15 vcn ctn_L2_12 0 NSYN W=10u L=1u
MpTb_L2_12_6 d1bar_L3 gp_3_15_5 ctn_L2_12 0 NSYN W=10u L=1u
MpTa_L2_12_7 dpre_L3_18 gp_3_18_2 ctp_L2_12 0 NSYN W=10u L=1u
MnTb_L2_12_7 d1bar_L3 vcn ctp_L2_12 0 NSYN W=10u L=1u
MnTa_L2_12_7 dpre_L3_18 vcn ctn_L2_12 0 NSYN W=10u L=1u
MpTb_L2_12_7 d1bar_L3 gp_3_18_2 ctn_L2_12 0 NSYN W=10u L=1u
MpTa_L2_12_8 dpre_L3_19 gp_3_19_2 ctp_L2_12 0 NSYN W=10u L=1u
MnTb_L2_12_8 d1bar_L3 vcn ctp_L2_12 0 NSYN W=10u L=1u
MnTa_L2_12_8 dpre_L3_19 vcn ctn_L2_12 0 NSYN W=10u L=1u
MpTb_L2_12_8 d1bar_L3 gp_3_19_2 ctn_L2_12 0 NSYN W=10u L=1u
MpTa_L2_12_9 dpre_L3_21 gp_3_21_4 ctp_L2_12 0 NSYN W=10u L=1u
MnTb_L2_12_9 d1bar_L3 vcn ctp_L2_12 0 NSYN W=10u L=1u
MnTa_L2_12_9 dpre_L3_21 vcn ctn_L2_12 0 NSYN W=10u L=1u
MpTb_L2_12_9 d1bar_L3 gp_3_21_4 ctn_L2_12 0 NSYN W=10u L=1u
MpTa_L2_12_10 dpre_L3_23 gp_3_23_2 ctp_L2_12 0 NSYN W=10u L=1u
MnTb_L2_12_10 d1bar_L3 vcn ctp_L2_12 0 NSYN W=10u L=1u
MnTa_L2_12_10 dpre_L3_23 vcn ctn_L2_12 0 NSYN W=10u L=1u
MpTb_L2_12_10 d1bar_L3 gp_3_23_2 ctn_L2_12 0 NSYN W=10u L=1u
MpTa_L2_12_11 dpre_L3_29 gp_3_29_4 ctp_L2_12 0 NSYN W=10u L=1u
MnTb_L2_12_11 d1bar_L3 vcn ctp_L2_12 0 NSYN W=10u L=1u
MnTa_L2_12_11 dpre_L3_29 vcn ctn_L2_12 0 NSYN W=10u L=1u
MpTb_L2_12_11 d1bar_L3 gp_3_29_4 ctn_L2_12 0 NSYN W=10u L=1u
MpTa_L2_12_12 dpre_L3_34 gp_3_34_3 ctp_L2_12 0 NSYN W=10u L=1u
MnTb_L2_12_12 d1bar_L3 vcn ctp_L2_12 0 NSYN W=10u L=1u
MnTa_L2_12_12 dpre_L3_34 vcn ctn_L2_12 0 NSYN W=10u L=1u
MpTb_L2_12_12 d1bar_L3 gp_3_34_3 ctn_L2_12 0 NSYN W=10u L=1u
MpTa_L2_12_13 dpre_L3_37 gp_3_37_3 ctp_L2_12 0 NSYN W=10u L=1u
MnTb_L2_12_13 d1bar_L3 vcn ctp_L2_12 0 NSYN W=10u L=1u
MnTa_L2_12_13 dpre_L3_37 vcn ctn_L2_12 0 NSYN W=10u L=1u
MpTb_L2_12_13 d1bar_L3 gp_3_37_3 ctn_L2_12 0 NSYN W=10u L=1u
MpTa_L2_12_14 dpre_L3_38 gp_3_38_4 ctp_L2_12 0 NSYN W=10u L=1u
MnTb_L2_12_14 d1bar_L3 vcn ctp_L2_12 0 NSYN W=10u L=1u
MnTa_L2_12_14 dpre_L3_38 vcn ctn_L2_12 0 NSYN W=10u L=1u
MpTb_L2_12_14 d1bar_L3 gp_3_38_4 ctn_L2_12 0 NSYN W=10u L=1u
MpTa_L2_12_15 dpre_L3_41 gp_3_41_4 ctp_L2_12 0 NSYN W=10u L=1u
MnTb_L2_12_15 d1bar_L3 vcn ctp_L2_12 0 NSYN W=10u L=1u
MnTa_L2_12_15 dpre_L3_41 vcn ctn_L2_12 0 NSYN W=10u L=1u
MpTb_L2_12_15 d1bar_L3 gp_3_41_4 ctn_L2_12 0 NSYN W=10u L=1u
MpTa_L2_12_16 dpre_L3_42 gp_3_42_5 ctp_L2_12 0 NSYN W=10u L=1u
MnTb_L2_12_16 d1bar_L3 vcn ctp_L2_12 0 NSYN W=10u L=1u
MnTa_L2_12_16 dpre_L3_42 vcn ctn_L2_12 0 NSYN W=10u L=1u
MpTb_L2_12_16 d1bar_L3 gp_3_42_5 ctn_L2_12 0 NSYN W=10u L=1u
MpTa_L2_12_17 dpre_L3_43 gp_3_43_7 ctp_L2_12 0 NSYN W=10u L=1u
MnTb_L2_12_17 d1bar_L3 vcn ctp_L2_12 0 NSYN W=10u L=1u
MnTa_L2_12_17 dpre_L3_43 vcn ctn_L2_12 0 NSYN W=10u L=1u
MpTb_L2_12_17 d1bar_L3 gp_3_43_7 ctn_L2_12 0 NSYN W=10u L=1u
MpTa_L2_12_18 dpre_L3_45 gp_3_45_5 ctp_L2_12 0 NSYN W=10u L=1u
MnTb_L2_12_18 d1bar_L3 vcn ctp_L2_12 0 NSYN W=10u L=1u
MnTa_L2_12_18 dpre_L3_45 vcn ctn_L2_12 0 NSYN W=10u L=1u
MpTb_L2_12_18 d1bar_L3 gp_3_45_5 ctn_L2_12 0 NSYN W=10u L=1u
Msa_bk_L2_12 ctn_L2_12 ctn_L2_12 0 0 NMIR W=20u L=1u
Msb_bk_L2_12 dpre_L2_12 ctn_L2_12 0 0 NMIR W=20u L=1u
Msc_bk_L2_12 ctp_L2_12 ctp_L2_12 0 0 NMIR W=20u L=1u
Msd_bk_L2_12 dpf_bk_L2_12 ctp_L2_12 0 0 NMIR W=20u L=1u
Mse_bk_L2_12 dpf_bk_L2_12 dpf_bk_L2_12 vdd vdd PMIR W=60u L=1u
Msf_bk_L2_12 dpre_L2_12 dpf_bk_L2_12 vdd vdd PMIR W=60u L=1u
R_bk_L2_12 dpre_L2_12 vrefd 16000.0
MpTa_L2_13_0 dpre_L3_5 gp_3_5_4 ctp_L2_13 0 NSYN W=10u L=1u
MnTb_L2_13_0 d1bar_L3 vcn ctp_L2_13 0 NSYN W=10u L=1u
MnTa_L2_13_0 dpre_L3_5 vcn ctn_L2_13 0 NSYN W=10u L=1u
MpTb_L2_13_0 d1bar_L3 gp_3_5_4 ctn_L2_13 0 NSYN W=10u L=1u
MpTa_L2_13_1 dpre_L3_7 gp_3_7_6 ctp_L2_13 0 NSYN W=10u L=1u
MnTb_L2_13_1 d1bar_L3 vcn ctp_L2_13 0 NSYN W=10u L=1u
MnTa_L2_13_1 dpre_L3_7 vcn ctn_L2_13 0 NSYN W=10u L=1u
MpTb_L2_13_1 d1bar_L3 gp_3_7_6 ctn_L2_13 0 NSYN W=10u L=1u
MpTa_L2_13_2 dpre_L3_11 gp_3_11_4 ctp_L2_13 0 NSYN W=10u L=1u
MnTb_L2_13_2 d1bar_L3 vcn ctp_L2_13 0 NSYN W=10u L=1u
MnTa_L2_13_2 dpre_L3_11 vcn ctn_L2_13 0 NSYN W=10u L=1u
MpTb_L2_13_2 d1bar_L3 gp_3_11_4 ctn_L2_13 0 NSYN W=10u L=1u
MpTa_L2_13_3 dpre_L3_12 gp_3_12_1 ctp_L2_13 0 NSYN W=10u L=1u
MnTb_L2_13_3 d1bar_L3 vcn ctp_L2_13 0 NSYN W=10u L=1u
MnTa_L2_13_3 dpre_L3_12 vcn ctn_L2_13 0 NSYN W=10u L=1u
MpTb_L2_13_3 d1bar_L3 gp_3_12_1 ctn_L2_13 0 NSYN W=10u L=1u
MpTa_L2_13_4 dpre_L3_15 gp_3_15_6 ctp_L2_13 0 NSYN W=10u L=1u
MnTb_L2_13_4 d1bar_L3 vcn ctp_L2_13 0 NSYN W=10u L=1u
MnTa_L2_13_4 dpre_L3_15 vcn ctn_L2_13 0 NSYN W=10u L=1u
MpTb_L2_13_4 d1bar_L3 gp_3_15_6 ctn_L2_13 0 NSYN W=10u L=1u
MpTa_L2_13_5 dpre_L3_16 gp_3_16_2 ctp_L2_13 0 NSYN W=10u L=1u
MnTb_L2_13_5 d1bar_L3 vcn ctp_L2_13 0 NSYN W=10u L=1u
MnTa_L2_13_5 dpre_L3_16 vcn ctn_L2_13 0 NSYN W=10u L=1u
MpTb_L2_13_5 d1bar_L3 gp_3_16_2 ctn_L2_13 0 NSYN W=10u L=1u
MpTa_L2_13_6 dpre_L3_18 gp_3_18_3 ctp_L2_13 0 NSYN W=10u L=1u
MnTb_L2_13_6 d1bar_L3 vcn ctp_L2_13 0 NSYN W=10u L=1u
MnTa_L2_13_6 dpre_L3_18 vcn ctn_L2_13 0 NSYN W=10u L=1u
MpTb_L2_13_6 d1bar_L3 gp_3_18_3 ctn_L2_13 0 NSYN W=10u L=1u
MpTa_L2_13_7 dpre_L3_19 gp_3_19_3 ctp_L2_13 0 NSYN W=10u L=1u
MnTb_L2_13_7 d1bar_L3 vcn ctp_L2_13 0 NSYN W=10u L=1u
MnTa_L2_13_7 dpre_L3_19 vcn ctn_L2_13 0 NSYN W=10u L=1u
MpTb_L2_13_7 d1bar_L3 gp_3_19_3 ctn_L2_13 0 NSYN W=10u L=1u
MpTa_L2_13_8 dpre_L3_23 gp_3_23_3 ctp_L2_13 0 NSYN W=10u L=1u
MnTb_L2_13_8 d1bar_L3 vcn ctp_L2_13 0 NSYN W=10u L=1u
MnTa_L2_13_8 dpre_L3_23 vcn ctn_L2_13 0 NSYN W=10u L=1u
MpTb_L2_13_8 d1bar_L3 gp_3_23_3 ctn_L2_13 0 NSYN W=10u L=1u
MpTa_L2_13_9 dpre_L3_27 gp_3_27_2 ctp_L2_13 0 NSYN W=10u L=1u
MnTb_L2_13_9 d1bar_L3 vcn ctp_L2_13 0 NSYN W=10u L=1u
MnTa_L2_13_9 dpre_L3_27 vcn ctn_L2_13 0 NSYN W=10u L=1u
MpTb_L2_13_9 d1bar_L3 gp_3_27_2 ctn_L2_13 0 NSYN W=10u L=1u
MpTa_L2_13_10 dpre_L3_30 gp_3_30_3 ctp_L2_13 0 NSYN W=10u L=1u
MnTb_L2_13_10 d1bar_L3 vcn ctp_L2_13 0 NSYN W=10u L=1u
MnTa_L2_13_10 dpre_L3_30 vcn ctn_L2_13 0 NSYN W=10u L=1u
MpTb_L2_13_10 d1bar_L3 gp_3_30_3 ctn_L2_13 0 NSYN W=10u L=1u
MpTa_L2_13_11 dpre_L3_31 gp_3_31_3 ctp_L2_13 0 NSYN W=10u L=1u
MnTb_L2_13_11 d1bar_L3 vcn ctp_L2_13 0 NSYN W=10u L=1u
MnTa_L2_13_11 dpre_L3_31 vcn ctn_L2_13 0 NSYN W=10u L=1u
MpTb_L2_13_11 d1bar_L3 gp_3_31_3 ctn_L2_13 0 NSYN W=10u L=1u
MpTa_L2_13_12 dpre_L3_32 gp_3_32_5 ctp_L2_13 0 NSYN W=10u L=1u
MnTb_L2_13_12 d1bar_L3 vcn ctp_L2_13 0 NSYN W=10u L=1u
MnTa_L2_13_12 dpre_L3_32 vcn ctn_L2_13 0 NSYN W=10u L=1u
MpTb_L2_13_12 d1bar_L3 gp_3_32_5 ctn_L2_13 0 NSYN W=10u L=1u
MpTa_L2_13_13 dpre_L3_37 gp_3_37_4 ctp_L2_13 0 NSYN W=10u L=1u
MnTb_L2_13_13 d1bar_L3 vcn ctp_L2_13 0 NSYN W=10u L=1u
MnTa_L2_13_13 dpre_L3_37 vcn ctn_L2_13 0 NSYN W=10u L=1u
MpTb_L2_13_13 d1bar_L3 gp_3_37_4 ctn_L2_13 0 NSYN W=10u L=1u
MpTa_L2_13_14 dpre_L3_40 gp_3_40_5 ctp_L2_13 0 NSYN W=10u L=1u
MnTb_L2_13_14 d1bar_L3 vcn ctp_L2_13 0 NSYN W=10u L=1u
MnTa_L2_13_14 dpre_L3_40 vcn ctn_L2_13 0 NSYN W=10u L=1u
MpTb_L2_13_14 d1bar_L3 gp_3_40_5 ctn_L2_13 0 NSYN W=10u L=1u
MpTa_L2_13_15 dpre_L3_47 gp_3_47_3 ctp_L2_13 0 NSYN W=10u L=1u
MnTb_L2_13_15 d1bar_L3 vcn ctp_L2_13 0 NSYN W=10u L=1u
MnTa_L2_13_15 dpre_L3_47 vcn ctn_L2_13 0 NSYN W=10u L=1u
MpTb_L2_13_15 d1bar_L3 gp_3_47_3 ctn_L2_13 0 NSYN W=10u L=1u
Msa_bk_L2_13 ctn_L2_13 ctn_L2_13 0 0 NMIR W=20u L=1u
Msb_bk_L2_13 dpre_L2_13 ctn_L2_13 0 0 NMIR W=20u L=1u
Msc_bk_L2_13 ctp_L2_13 ctp_L2_13 0 0 NMIR W=20u L=1u
Msd_bk_L2_13 dpf_bk_L2_13 ctp_L2_13 0 0 NMIR W=20u L=1u
Mse_bk_L2_13 dpf_bk_L2_13 dpf_bk_L2_13 vdd vdd PMIR W=60u L=1u
Msf_bk_L2_13 dpre_L2_13 dpf_bk_L2_13 vdd vdd PMIR W=60u L=1u
R_bk_L2_13 dpre_L2_13 vrefd 16000.0
MpTa_L2_14_0 dpre_L3_0 gp_3_0_4 ctp_L2_14 0 NSYN W=10u L=1u
MnTb_L2_14_0 d1bar_L3 vcn ctp_L2_14 0 NSYN W=10u L=1u
MnTa_L2_14_0 dpre_L3_0 vcn ctn_L2_14 0 NSYN W=10u L=1u
MpTb_L2_14_0 d1bar_L3 gp_3_0_4 ctn_L2_14 0 NSYN W=10u L=1u
MpTa_L2_14_1 dpre_L3_4 gp_3_4_7 ctp_L2_14 0 NSYN W=10u L=1u
MnTb_L2_14_1 d1bar_L3 vcn ctp_L2_14 0 NSYN W=10u L=1u
MnTa_L2_14_1 dpre_L3_4 vcn ctn_L2_14 0 NSYN W=10u L=1u
MpTb_L2_14_1 d1bar_L3 gp_3_4_7 ctn_L2_14 0 NSYN W=10u L=1u
MpTa_L2_14_2 dpre_L3_6 gp_3_6_5 ctp_L2_14 0 NSYN W=10u L=1u
MnTb_L2_14_2 d1bar_L3 vcn ctp_L2_14 0 NSYN W=10u L=1u
MnTa_L2_14_2 dpre_L3_6 vcn ctn_L2_14 0 NSYN W=10u L=1u
MpTb_L2_14_2 d1bar_L3 gp_3_6_5 ctn_L2_14 0 NSYN W=10u L=1u
MpTa_L2_14_3 dpre_L3_8 gp_3_8_3 ctp_L2_14 0 NSYN W=10u L=1u
MnTb_L2_14_3 d1bar_L3 vcn ctp_L2_14 0 NSYN W=10u L=1u
MnTa_L2_14_3 dpre_L3_8 vcn ctn_L2_14 0 NSYN W=10u L=1u
MpTb_L2_14_3 d1bar_L3 gp_3_8_3 ctn_L2_14 0 NSYN W=10u L=1u
MpTa_L2_14_4 dpre_L3_12 gp_3_12_2 ctp_L2_14 0 NSYN W=10u L=1u
MnTb_L2_14_4 d1bar_L3 vcn ctp_L2_14 0 NSYN W=10u L=1u
MnTa_L2_14_4 dpre_L3_12 vcn ctn_L2_14 0 NSYN W=10u L=1u
MpTb_L2_14_4 d1bar_L3 gp_3_12_2 ctn_L2_14 0 NSYN W=10u L=1u
MpTa_L2_14_5 dpre_L3_14 gp_3_14_3 ctp_L2_14 0 NSYN W=10u L=1u
MnTb_L2_14_5 d1bar_L3 vcn ctp_L2_14 0 NSYN W=10u L=1u
MnTa_L2_14_5 dpre_L3_14 vcn ctn_L2_14 0 NSYN W=10u L=1u
MpTb_L2_14_5 d1bar_L3 gp_3_14_3 ctn_L2_14 0 NSYN W=10u L=1u
MpTa_L2_14_6 dpre_L3_18 gp_3_18_4 ctp_L2_14 0 NSYN W=10u L=1u
MnTb_L2_14_6 d1bar_L3 vcn ctp_L2_14 0 NSYN W=10u L=1u
MnTa_L2_14_6 dpre_L3_18 vcn ctn_L2_14 0 NSYN W=10u L=1u
MpTb_L2_14_6 d1bar_L3 gp_3_18_4 ctn_L2_14 0 NSYN W=10u L=1u
MpTa_L2_14_7 dpre_L3_22 gp_3_22_5 ctp_L2_14 0 NSYN W=10u L=1u
MnTb_L2_14_7 d1bar_L3 vcn ctp_L2_14 0 NSYN W=10u L=1u
MnTa_L2_14_7 dpre_L3_22 vcn ctn_L2_14 0 NSYN W=10u L=1u
MpTb_L2_14_7 d1bar_L3 gp_3_22_5 ctn_L2_14 0 NSYN W=10u L=1u
MpTa_L2_14_8 dpre_L3_26 gp_3_26_5 ctp_L2_14 0 NSYN W=10u L=1u
MnTb_L2_14_8 d1bar_L3 vcn ctp_L2_14 0 NSYN W=10u L=1u
MnTa_L2_14_8 dpre_L3_26 vcn ctn_L2_14 0 NSYN W=10u L=1u
MpTb_L2_14_8 d1bar_L3 gp_3_26_5 ctn_L2_14 0 NSYN W=10u L=1u
MpTa_L2_14_9 dpre_L3_27 gp_3_27_3 ctp_L2_14 0 NSYN W=10u L=1u
MnTb_L2_14_9 d1bar_L3 vcn ctp_L2_14 0 NSYN W=10u L=1u
MnTa_L2_14_9 dpre_L3_27 vcn ctn_L2_14 0 NSYN W=10u L=1u
MpTb_L2_14_9 d1bar_L3 gp_3_27_3 ctn_L2_14 0 NSYN W=10u L=1u
MpTa_L2_14_10 dpre_L3_31 gp_3_31_4 ctp_L2_14 0 NSYN W=10u L=1u
MnTb_L2_14_10 d1bar_L3 vcn ctp_L2_14 0 NSYN W=10u L=1u
MnTa_L2_14_10 dpre_L3_31 vcn ctn_L2_14 0 NSYN W=10u L=1u
MpTb_L2_14_10 d1bar_L3 gp_3_31_4 ctn_L2_14 0 NSYN W=10u L=1u
MpTa_L2_14_11 dpre_L3_33 gp_3_33_5 ctp_L2_14 0 NSYN W=10u L=1u
MnTb_L2_14_11 d1bar_L3 vcn ctp_L2_14 0 NSYN W=10u L=1u
MnTa_L2_14_11 dpre_L3_33 vcn ctn_L2_14 0 NSYN W=10u L=1u
MpTb_L2_14_11 d1bar_L3 gp_3_33_5 ctn_L2_14 0 NSYN W=10u L=1u
MpTa_L2_14_12 dpre_L3_35 gp_3_35_1 ctp_L2_14 0 NSYN W=10u L=1u
MnTb_L2_14_12 d1bar_L3 vcn ctp_L2_14 0 NSYN W=10u L=1u
MnTa_L2_14_12 dpre_L3_35 vcn ctn_L2_14 0 NSYN W=10u L=1u
MpTb_L2_14_12 d1bar_L3 gp_3_35_1 ctn_L2_14 0 NSYN W=10u L=1u
MpTa_L2_14_13 dpre_L3_42 gp_3_42_6 ctp_L2_14 0 NSYN W=10u L=1u
MnTb_L2_14_13 d1bar_L3 vcn ctp_L2_14 0 NSYN W=10u L=1u
MnTa_L2_14_13 dpre_L3_42 vcn ctn_L2_14 0 NSYN W=10u L=1u
MpTb_L2_14_13 d1bar_L3 gp_3_42_6 ctn_L2_14 0 NSYN W=10u L=1u
MpTa_L2_14_14 dpre_L3_47 gp_3_47_4 ctp_L2_14 0 NSYN W=10u L=1u
MnTb_L2_14_14 d1bar_L3 vcn ctp_L2_14 0 NSYN W=10u L=1u
MnTa_L2_14_14 dpre_L3_47 vcn ctn_L2_14 0 NSYN W=10u L=1u
MpTb_L2_14_14 d1bar_L3 gp_3_47_4 ctn_L2_14 0 NSYN W=10u L=1u
Msa_bk_L2_14 ctn_L2_14 ctn_L2_14 0 0 NMIR W=20u L=1u
Msb_bk_L2_14 dpre_L2_14 ctn_L2_14 0 0 NMIR W=20u L=1u
Msc_bk_L2_14 ctp_L2_14 ctp_L2_14 0 0 NMIR W=20u L=1u
Msd_bk_L2_14 dpf_bk_L2_14 ctp_L2_14 0 0 NMIR W=20u L=1u
Mse_bk_L2_14 dpf_bk_L2_14 dpf_bk_L2_14 vdd vdd PMIR W=60u L=1u
Msf_bk_L2_14 dpre_L2_14 dpf_bk_L2_14 vdd vdd PMIR W=60u L=1u
R_bk_L2_14 dpre_L2_14 vrefd 16000.0
MpTa_L2_15_0 dpre_L3_0 gp_3_0_5 ctp_L2_15 0 NSYN W=10u L=1u
MnTb_L2_15_0 d1bar_L3 vcn ctp_L2_15 0 NSYN W=10u L=1u
MnTa_L2_15_0 dpre_L3_0 vcn ctn_L2_15 0 NSYN W=10u L=1u
MpTb_L2_15_0 d1bar_L3 gp_3_0_5 ctn_L2_15 0 NSYN W=10u L=1u
MpTa_L2_15_1 dpre_L3_1 gp_3_1_3 ctp_L2_15 0 NSYN W=10u L=1u
MnTb_L2_15_1 d1bar_L3 vcn ctp_L2_15 0 NSYN W=10u L=1u
MnTa_L2_15_1 dpre_L3_1 vcn ctn_L2_15 0 NSYN W=10u L=1u
MpTb_L2_15_1 d1bar_L3 gp_3_1_3 ctn_L2_15 0 NSYN W=10u L=1u
MpTa_L2_15_2 dpre_L3_6 gp_3_6_6 ctp_L2_15 0 NSYN W=10u L=1u
MnTb_L2_15_2 d1bar_L3 vcn ctp_L2_15 0 NSYN W=10u L=1u
MnTa_L2_15_2 dpre_L3_6 vcn ctn_L2_15 0 NSYN W=10u L=1u
MpTb_L2_15_2 d1bar_L3 gp_3_6_6 ctn_L2_15 0 NSYN W=10u L=1u
MpTa_L2_15_3 dpre_L3_10 gp_3_10_4 ctp_L2_15 0 NSYN W=10u L=1u
MnTb_L2_15_3 d1bar_L3 vcn ctp_L2_15 0 NSYN W=10u L=1u
MnTa_L2_15_3 dpre_L3_10 vcn ctn_L2_15 0 NSYN W=10u L=1u
MpTb_L2_15_3 d1bar_L3 gp_3_10_4 ctn_L2_15 0 NSYN W=10u L=1u
MpTa_L2_15_4 dpre_L3_15 gp_3_15_7 ctp_L2_15 0 NSYN W=10u L=1u
MnTb_L2_15_4 d1bar_L3 vcn ctp_L2_15 0 NSYN W=10u L=1u
MnTa_L2_15_4 dpre_L3_15 vcn ctn_L2_15 0 NSYN W=10u L=1u
MpTb_L2_15_4 d1bar_L3 gp_3_15_7 ctn_L2_15 0 NSYN W=10u L=1u
MpTa_L2_15_5 dpre_L3_17 gp_3_17_5 ctp_L2_15 0 NSYN W=10u L=1u
MnTb_L2_15_5 d1bar_L3 vcn ctp_L2_15 0 NSYN W=10u L=1u
MnTa_L2_15_5 dpre_L3_17 vcn ctn_L2_15 0 NSYN W=10u L=1u
MpTb_L2_15_5 d1bar_L3 gp_3_17_5 ctn_L2_15 0 NSYN W=10u L=1u
MpTa_L2_15_6 dpre_L3_20 gp_3_20_5 ctp_L2_15 0 NSYN W=10u L=1u
MnTb_L2_15_6 d1bar_L3 vcn ctp_L2_15 0 NSYN W=10u L=1u
MnTa_L2_15_6 dpre_L3_20 vcn ctn_L2_15 0 NSYN W=10u L=1u
MpTb_L2_15_6 d1bar_L3 gp_3_20_5 ctn_L2_15 0 NSYN W=10u L=1u
MpTa_L2_15_7 dpre_L3_21 gp_3_21_5 ctp_L2_15 0 NSYN W=10u L=1u
MnTb_L2_15_7 d1bar_L3 vcn ctp_L2_15 0 NSYN W=10u L=1u
MnTa_L2_15_7 dpre_L3_21 vcn ctn_L2_15 0 NSYN W=10u L=1u
MpTb_L2_15_7 d1bar_L3 gp_3_21_5 ctn_L2_15 0 NSYN W=10u L=1u
MpTa_L2_15_8 dpre_L3_25 gp_3_25_4 ctp_L2_15 0 NSYN W=10u L=1u
MnTb_L2_15_8 d1bar_L3 vcn ctp_L2_15 0 NSYN W=10u L=1u
MnTa_L2_15_8 dpre_L3_25 vcn ctn_L2_15 0 NSYN W=10u L=1u
MpTb_L2_15_8 d1bar_L3 gp_3_25_4 ctn_L2_15 0 NSYN W=10u L=1u
MpTa_L2_15_9 dpre_L3_28 gp_3_28_6 ctp_L2_15 0 NSYN W=10u L=1u
MnTb_L2_15_9 d1bar_L3 vcn ctp_L2_15 0 NSYN W=10u L=1u
MnTa_L2_15_9 dpre_L3_28 vcn ctn_L2_15 0 NSYN W=10u L=1u
MpTb_L2_15_9 d1bar_L3 gp_3_28_6 ctn_L2_15 0 NSYN W=10u L=1u
MpTa_L2_15_10 dpre_L3_30 gp_3_30_4 ctp_L2_15 0 NSYN W=10u L=1u
MnTb_L2_15_10 d1bar_L3 vcn ctp_L2_15 0 NSYN W=10u L=1u
MnTa_L2_15_10 dpre_L3_30 vcn ctn_L2_15 0 NSYN W=10u L=1u
MpTb_L2_15_10 d1bar_L3 gp_3_30_4 ctn_L2_15 0 NSYN W=10u L=1u
MpTa_L2_15_11 dpre_L3_31 gp_3_31_5 ctp_L2_15 0 NSYN W=10u L=1u
MnTb_L2_15_11 d1bar_L3 vcn ctp_L2_15 0 NSYN W=10u L=1u
MnTa_L2_15_11 dpre_L3_31 vcn ctn_L2_15 0 NSYN W=10u L=1u
MpTb_L2_15_11 d1bar_L3 gp_3_31_5 ctn_L2_15 0 NSYN W=10u L=1u
MpTa_L2_15_12 dpre_L3_34 gp_3_34_4 ctp_L2_15 0 NSYN W=10u L=1u
MnTb_L2_15_12 d1bar_L3 vcn ctp_L2_15 0 NSYN W=10u L=1u
MnTa_L2_15_12 dpre_L3_34 vcn ctn_L2_15 0 NSYN W=10u L=1u
MpTb_L2_15_12 d1bar_L3 gp_3_34_4 ctn_L2_15 0 NSYN W=10u L=1u
MpTa_L2_15_13 dpre_L3_35 gp_3_35_2 ctp_L2_15 0 NSYN W=10u L=1u
MnTb_L2_15_13 d1bar_L3 vcn ctp_L2_15 0 NSYN W=10u L=1u
MnTa_L2_15_13 dpre_L3_35 vcn ctn_L2_15 0 NSYN W=10u L=1u
MpTb_L2_15_13 d1bar_L3 gp_3_35_2 ctn_L2_15 0 NSYN W=10u L=1u
MpTa_L2_15_14 dpre_L3_38 gp_3_38_5 ctp_L2_15 0 NSYN W=10u L=1u
MnTb_L2_15_14 d1bar_L3 vcn ctp_L2_15 0 NSYN W=10u L=1u
MnTa_L2_15_14 dpre_L3_38 vcn ctn_L2_15 0 NSYN W=10u L=1u
MpTb_L2_15_14 d1bar_L3 gp_3_38_5 ctn_L2_15 0 NSYN W=10u L=1u
MpTa_L2_15_15 dpre_L3_40 gp_3_40_6 ctp_L2_15 0 NSYN W=10u L=1u
MnTb_L2_15_15 d1bar_L3 vcn ctp_L2_15 0 NSYN W=10u L=1u
MnTa_L2_15_15 dpre_L3_40 vcn ctn_L2_15 0 NSYN W=10u L=1u
MpTb_L2_15_15 d1bar_L3 gp_3_40_6 ctn_L2_15 0 NSYN W=10u L=1u
MpTa_L2_15_16 dpre_L3_41 gp_3_41_5 ctp_L2_15 0 NSYN W=10u L=1u
MnTb_L2_15_16 d1bar_L3 vcn ctp_L2_15 0 NSYN W=10u L=1u
MnTa_L2_15_16 dpre_L3_41 vcn ctn_L2_15 0 NSYN W=10u L=1u
MpTb_L2_15_16 d1bar_L3 gp_3_41_5 ctn_L2_15 0 NSYN W=10u L=1u
MpTa_L2_15_17 dpre_L3_43 gp_3_43_8 ctp_L2_15 0 NSYN W=10u L=1u
MnTb_L2_15_17 d1bar_L3 vcn ctp_L2_15 0 NSYN W=10u L=1u
MnTa_L2_15_17 dpre_L3_43 vcn ctn_L2_15 0 NSYN W=10u L=1u
MpTb_L2_15_17 d1bar_L3 gp_3_43_8 ctn_L2_15 0 NSYN W=10u L=1u
MpTa_L2_15_18 dpre_L3_47 gp_3_47_5 ctp_L2_15 0 NSYN W=10u L=1u
MnTb_L2_15_18 d1bar_L3 vcn ctp_L2_15 0 NSYN W=10u L=1u
MnTa_L2_15_18 dpre_L3_47 vcn ctn_L2_15 0 NSYN W=10u L=1u
MpTb_L2_15_18 d1bar_L3 gp_3_47_5 ctn_L2_15 0 NSYN W=10u L=1u
Msa_bk_L2_15 ctn_L2_15 ctn_L2_15 0 0 NMIR W=20u L=1u
Msb_bk_L2_15 dpre_L2_15 ctn_L2_15 0 0 NMIR W=20u L=1u
Msc_bk_L2_15 ctp_L2_15 ctp_L2_15 0 0 NMIR W=20u L=1u
Msd_bk_L2_15 dpf_bk_L2_15 ctp_L2_15 0 0 NMIR W=20u L=1u
Mse_bk_L2_15 dpf_bk_L2_15 dpf_bk_L2_15 vdd vdd PMIR W=60u L=1u
Msf_bk_L2_15 dpre_L2_15 dpf_bk_L2_15 vdd vdd PMIR W=60u L=1u
R_bk_L2_15 dpre_L2_15 vrefd 16000.0
MpTa_L2_16_0 dpre_L3_6 gp_3_6_7 ctp_L2_16 0 NSYN W=10u L=1u
MnTb_L2_16_0 d1bar_L3 vcn ctp_L2_16 0 NSYN W=10u L=1u
MnTa_L2_16_0 dpre_L3_6 vcn ctn_L2_16 0 NSYN W=10u L=1u
MpTb_L2_16_0 d1bar_L3 gp_3_6_7 ctn_L2_16 0 NSYN W=10u L=1u
MpTa_L2_16_1 dpre_L3_8 gp_3_8_4 ctp_L2_16 0 NSYN W=10u L=1u
MnTb_L2_16_1 d1bar_L3 vcn ctp_L2_16 0 NSYN W=10u L=1u
MnTa_L2_16_1 dpre_L3_8 vcn ctn_L2_16 0 NSYN W=10u L=1u
MpTb_L2_16_1 d1bar_L3 gp_3_8_4 ctn_L2_16 0 NSYN W=10u L=1u
MpTa_L2_16_2 dpre_L3_13 gp_3_13_5 ctp_L2_16 0 NSYN W=10u L=1u
MnTb_L2_16_2 d1bar_L3 vcn ctp_L2_16 0 NSYN W=10u L=1u
MnTa_L2_16_2 dpre_L3_13 vcn ctn_L2_16 0 NSYN W=10u L=1u
MpTb_L2_16_2 d1bar_L3 gp_3_13_5 ctn_L2_16 0 NSYN W=10u L=1u
MpTa_L2_16_3 dpre_L3_15 gp_3_15_8 ctp_L2_16 0 NSYN W=10u L=1u
MnTb_L2_16_3 d1bar_L3 vcn ctp_L2_16 0 NSYN W=10u L=1u
MnTa_L2_16_3 dpre_L3_15 vcn ctn_L2_16 0 NSYN W=10u L=1u
MpTb_L2_16_3 d1bar_L3 gp_3_15_8 ctn_L2_16 0 NSYN W=10u L=1u
MpTa_L2_16_4 dpre_L3_17 gp_3_17_6 ctp_L2_16 0 NSYN W=10u L=1u
MnTb_L2_16_4 d1bar_L3 vcn ctp_L2_16 0 NSYN W=10u L=1u
MnTa_L2_16_4 dpre_L3_17 vcn ctn_L2_16 0 NSYN W=10u L=1u
MpTb_L2_16_4 d1bar_L3 gp_3_17_6 ctn_L2_16 0 NSYN W=10u L=1u
MpTa_L2_16_5 dpre_L3_18 gp_3_18_5 ctp_L2_16 0 NSYN W=10u L=1u
MnTb_L2_16_5 d1bar_L3 vcn ctp_L2_16 0 NSYN W=10u L=1u
MnTa_L2_16_5 dpre_L3_18 vcn ctn_L2_16 0 NSYN W=10u L=1u
MpTb_L2_16_5 d1bar_L3 gp_3_18_5 ctn_L2_16 0 NSYN W=10u L=1u
MpTa_L2_16_6 dpre_L3_21 gp_3_21_6 ctp_L2_16 0 NSYN W=10u L=1u
MnTb_L2_16_6 d1bar_L3 vcn ctp_L2_16 0 NSYN W=10u L=1u
MnTa_L2_16_6 dpre_L3_21 vcn ctn_L2_16 0 NSYN W=10u L=1u
MpTb_L2_16_6 d1bar_L3 gp_3_21_6 ctn_L2_16 0 NSYN W=10u L=1u
MpTa_L2_16_7 dpre_L3_27 gp_3_27_4 ctp_L2_16 0 NSYN W=10u L=1u
MnTb_L2_16_7 d1bar_L3 vcn ctp_L2_16 0 NSYN W=10u L=1u
MnTa_L2_16_7 dpre_L3_27 vcn ctn_L2_16 0 NSYN W=10u L=1u
MpTb_L2_16_7 d1bar_L3 gp_3_27_4 ctn_L2_16 0 NSYN W=10u L=1u
MpTa_L2_16_8 dpre_L3_29 gp_3_29_5 ctp_L2_16 0 NSYN W=10u L=1u
MnTb_L2_16_8 d1bar_L3 vcn ctp_L2_16 0 NSYN W=10u L=1u
MnTa_L2_16_8 dpre_L3_29 vcn ctn_L2_16 0 NSYN W=10u L=1u
MpTb_L2_16_8 d1bar_L3 gp_3_29_5 ctn_L2_16 0 NSYN W=10u L=1u
MpTa_L2_16_9 dpre_L3_31 gp_3_31_6 ctp_L2_16 0 NSYN W=10u L=1u
MnTb_L2_16_9 d1bar_L3 vcn ctp_L2_16 0 NSYN W=10u L=1u
MnTa_L2_16_9 dpre_L3_31 vcn ctn_L2_16 0 NSYN W=10u L=1u
MpTb_L2_16_9 d1bar_L3 gp_3_31_6 ctn_L2_16 0 NSYN W=10u L=1u
MpTa_L2_16_10 dpre_L3_32 gp_3_32_6 ctp_L2_16 0 NSYN W=10u L=1u
MnTb_L2_16_10 d1bar_L3 vcn ctp_L2_16 0 NSYN W=10u L=1u
MnTa_L2_16_10 dpre_L3_32 vcn ctn_L2_16 0 NSYN W=10u L=1u
MpTb_L2_16_10 d1bar_L3 gp_3_32_6 ctn_L2_16 0 NSYN W=10u L=1u
MpTa_L2_16_11 dpre_L3_34 gp_3_34_5 ctp_L2_16 0 NSYN W=10u L=1u
MnTb_L2_16_11 d1bar_L3 vcn ctp_L2_16 0 NSYN W=10u L=1u
MnTa_L2_16_11 dpre_L3_34 vcn ctn_L2_16 0 NSYN W=10u L=1u
MpTb_L2_16_11 d1bar_L3 gp_3_34_5 ctn_L2_16 0 NSYN W=10u L=1u
MpTa_L2_16_12 dpre_L3_35 gp_3_35_3 ctp_L2_16 0 NSYN W=10u L=1u
MnTb_L2_16_12 d1bar_L3 vcn ctp_L2_16 0 NSYN W=10u L=1u
MnTa_L2_16_12 dpre_L3_35 vcn ctn_L2_16 0 NSYN W=10u L=1u
MpTb_L2_16_12 d1bar_L3 gp_3_35_3 ctn_L2_16 0 NSYN W=10u L=1u
MpTa_L2_16_13 dpre_L3_38 gp_3_38_6 ctp_L2_16 0 NSYN W=10u L=1u
MnTb_L2_16_13 d1bar_L3 vcn ctp_L2_16 0 NSYN W=10u L=1u
MnTa_L2_16_13 dpre_L3_38 vcn ctn_L2_16 0 NSYN W=10u L=1u
MpTb_L2_16_13 d1bar_L3 gp_3_38_6 ctn_L2_16 0 NSYN W=10u L=1u
MpTa_L2_16_14 dpre_L3_40 gp_3_40_7 ctp_L2_16 0 NSYN W=10u L=1u
MnTb_L2_16_14 d1bar_L3 vcn ctp_L2_16 0 NSYN W=10u L=1u
MnTa_L2_16_14 dpre_L3_40 vcn ctn_L2_16 0 NSYN W=10u L=1u
MpTb_L2_16_14 d1bar_L3 gp_3_40_7 ctn_L2_16 0 NSYN W=10u L=1u
MpTa_L2_16_15 dpre_L3_44 gp_3_44_3 ctp_L2_16 0 NSYN W=10u L=1u
MnTb_L2_16_15 d1bar_L3 vcn ctp_L2_16 0 NSYN W=10u L=1u
MnTa_L2_16_15 dpre_L3_44 vcn ctn_L2_16 0 NSYN W=10u L=1u
MpTb_L2_16_15 d1bar_L3 gp_3_44_3 ctn_L2_16 0 NSYN W=10u L=1u
MpTa_L2_16_16 dpre_L3_45 gp_3_45_6 ctp_L2_16 0 NSYN W=10u L=1u
MnTb_L2_16_16 d1bar_L3 vcn ctp_L2_16 0 NSYN W=10u L=1u
MnTa_L2_16_16 dpre_L3_45 vcn ctn_L2_16 0 NSYN W=10u L=1u
MpTb_L2_16_16 d1bar_L3 gp_3_45_6 ctn_L2_16 0 NSYN W=10u L=1u
MpTa_L2_16_17 dpre_L3_47 gp_3_47_6 ctp_L2_16 0 NSYN W=10u L=1u
MnTb_L2_16_17 d1bar_L3 vcn ctp_L2_16 0 NSYN W=10u L=1u
MnTa_L2_16_17 dpre_L3_47 vcn ctn_L2_16 0 NSYN W=10u L=1u
MpTb_L2_16_17 d1bar_L3 gp_3_47_6 ctn_L2_16 0 NSYN W=10u L=1u
Msa_bk_L2_16 ctn_L2_16 ctn_L2_16 0 0 NMIR W=20u L=1u
Msb_bk_L2_16 dpre_L2_16 ctn_L2_16 0 0 NMIR W=20u L=1u
Msc_bk_L2_16 ctp_L2_16 ctp_L2_16 0 0 NMIR W=20u L=1u
Msd_bk_L2_16 dpf_bk_L2_16 ctp_L2_16 0 0 NMIR W=20u L=1u
Mse_bk_L2_16 dpf_bk_L2_16 dpf_bk_L2_16 vdd vdd PMIR W=60u L=1u
Msf_bk_L2_16 dpre_L2_16 dpf_bk_L2_16 vdd vdd PMIR W=60u L=1u
R_bk_L2_16 dpre_L2_16 vrefd 16000.0
MpTa_L2_17_0 dpre_L3_4 gp_3_4_8 ctp_L2_17 0 NSYN W=10u L=1u
MnTb_L2_17_0 d1bar_L3 vcn ctp_L2_17 0 NSYN W=10u L=1u
MnTa_L2_17_0 dpre_L3_4 vcn ctn_L2_17 0 NSYN W=10u L=1u
MpTb_L2_17_0 d1bar_L3 gp_3_4_8 ctn_L2_17 0 NSYN W=10u L=1u
MpTa_L2_17_1 dpre_L3_5 gp_3_5_5 ctp_L2_17 0 NSYN W=10u L=1u
MnTb_L2_17_1 d1bar_L3 vcn ctp_L2_17 0 NSYN W=10u L=1u
MnTa_L2_17_1 dpre_L3_5 vcn ctn_L2_17 0 NSYN W=10u L=1u
MpTb_L2_17_1 d1bar_L3 gp_3_5_5 ctn_L2_17 0 NSYN W=10u L=1u
MpTa_L2_17_2 dpre_L3_7 gp_3_7_7 ctp_L2_17 0 NSYN W=10u L=1u
MnTb_L2_17_2 d1bar_L3 vcn ctp_L2_17 0 NSYN W=10u L=1u
MnTa_L2_17_2 dpre_L3_7 vcn ctn_L2_17 0 NSYN W=10u L=1u
MpTb_L2_17_2 d1bar_L3 gp_3_7_7 ctn_L2_17 0 NSYN W=10u L=1u
MpTa_L2_17_3 dpre_L3_9 gp_3_9_4 ctp_L2_17 0 NSYN W=10u L=1u
MnTb_L2_17_3 d1bar_L3 vcn ctp_L2_17 0 NSYN W=10u L=1u
MnTa_L2_17_3 dpre_L3_9 vcn ctn_L2_17 0 NSYN W=10u L=1u
MpTb_L2_17_3 d1bar_L3 gp_3_9_4 ctn_L2_17 0 NSYN W=10u L=1u
MpTa_L2_17_4 dpre_L3_14 gp_3_14_4 ctp_L2_17 0 NSYN W=10u L=1u
MnTb_L2_17_4 d1bar_L3 vcn ctp_L2_17 0 NSYN W=10u L=1u
MnTa_L2_17_4 dpre_L3_14 vcn ctn_L2_17 0 NSYN W=10u L=1u
MpTb_L2_17_4 d1bar_L3 gp_3_14_4 ctn_L2_17 0 NSYN W=10u L=1u
MpTa_L2_17_5 dpre_L3_22 gp_3_22_6 ctp_L2_17 0 NSYN W=10u L=1u
MnTb_L2_17_5 d1bar_L3 vcn ctp_L2_17 0 NSYN W=10u L=1u
MnTa_L2_17_5 dpre_L3_22 vcn ctn_L2_17 0 NSYN W=10u L=1u
MpTb_L2_17_5 d1bar_L3 gp_3_22_6 ctn_L2_17 0 NSYN W=10u L=1u
MpTa_L2_17_6 dpre_L3_23 gp_3_23_4 ctp_L2_17 0 NSYN W=10u L=1u
MnTb_L2_17_6 d1bar_L3 vcn ctp_L2_17 0 NSYN W=10u L=1u
MnTa_L2_17_6 dpre_L3_23 vcn ctn_L2_17 0 NSYN W=10u L=1u
MpTb_L2_17_6 d1bar_L3 gp_3_23_4 ctn_L2_17 0 NSYN W=10u L=1u
MpTa_L2_17_7 dpre_L3_25 gp_3_25_5 ctp_L2_17 0 NSYN W=10u L=1u
MnTb_L2_17_7 d1bar_L3 vcn ctp_L2_17 0 NSYN W=10u L=1u
MnTa_L2_17_7 dpre_L3_25 vcn ctn_L2_17 0 NSYN W=10u L=1u
MpTb_L2_17_7 d1bar_L3 gp_3_25_5 ctn_L2_17 0 NSYN W=10u L=1u
MpTa_L2_17_8 dpre_L3_30 gp_3_30_5 ctp_L2_17 0 NSYN W=10u L=1u
MnTb_L2_17_8 d1bar_L3 vcn ctp_L2_17 0 NSYN W=10u L=1u
MnTa_L2_17_8 dpre_L3_30 vcn ctn_L2_17 0 NSYN W=10u L=1u
MpTb_L2_17_8 d1bar_L3 gp_3_30_5 ctn_L2_17 0 NSYN W=10u L=1u
MpTa_L2_17_9 dpre_L3_33 gp_3_33_6 ctp_L2_17 0 NSYN W=10u L=1u
MnTb_L2_17_9 d1bar_L3 vcn ctp_L2_17 0 NSYN W=10u L=1u
MnTa_L2_17_9 dpre_L3_33 vcn ctn_L2_17 0 NSYN W=10u L=1u
MpTb_L2_17_9 d1bar_L3 gp_3_33_6 ctn_L2_17 0 NSYN W=10u L=1u
MpTa_L2_17_10 dpre_L3_34 gp_3_34_6 ctp_L2_17 0 NSYN W=10u L=1u
MnTb_L2_17_10 d1bar_L3 vcn ctp_L2_17 0 NSYN W=10u L=1u
MnTa_L2_17_10 dpre_L3_34 vcn ctn_L2_17 0 NSYN W=10u L=1u
MpTb_L2_17_10 d1bar_L3 gp_3_34_6 ctn_L2_17 0 NSYN W=10u L=1u
MpTa_L2_17_11 dpre_L3_35 gp_3_35_4 ctp_L2_17 0 NSYN W=10u L=1u
MnTb_L2_17_11 d1bar_L3 vcn ctp_L2_17 0 NSYN W=10u L=1u
MnTa_L2_17_11 dpre_L3_35 vcn ctn_L2_17 0 NSYN W=10u L=1u
MpTb_L2_17_11 d1bar_L3 gp_3_35_4 ctn_L2_17 0 NSYN W=10u L=1u
MpTa_L2_17_12 dpre_L3_37 gp_3_37_5 ctp_L2_17 0 NSYN W=10u L=1u
MnTb_L2_17_12 d1bar_L3 vcn ctp_L2_17 0 NSYN W=10u L=1u
MnTa_L2_17_12 dpre_L3_37 vcn ctn_L2_17 0 NSYN W=10u L=1u
MpTb_L2_17_12 d1bar_L3 gp_3_37_5 ctn_L2_17 0 NSYN W=10u L=1u
MpTa_L2_17_13 dpre_L3_41 gp_3_41_6 ctp_L2_17 0 NSYN W=10u L=1u
MnTb_L2_17_13 d1bar_L3 vcn ctp_L2_17 0 NSYN W=10u L=1u
MnTa_L2_17_13 dpre_L3_41 vcn ctn_L2_17 0 NSYN W=10u L=1u
MpTb_L2_17_13 d1bar_L3 gp_3_41_6 ctn_L2_17 0 NSYN W=10u L=1u
Msa_bk_L2_17 ctn_L2_17 ctn_L2_17 0 0 NMIR W=20u L=1u
Msb_bk_L2_17 dpre_L2_17 ctn_L2_17 0 0 NMIR W=20u L=1u
Msc_bk_L2_17 ctp_L2_17 ctp_L2_17 0 0 NMIR W=20u L=1u
Msd_bk_L2_17 dpf_bk_L2_17 ctp_L2_17 0 0 NMIR W=20u L=1u
Mse_bk_L2_17 dpf_bk_L2_17 dpf_bk_L2_17 vdd vdd PMIR W=60u L=1u
Msf_bk_L2_17 dpre_L2_17 dpf_bk_L2_17 vdd vdd PMIR W=60u L=1u
R_bk_L2_17 dpre_L2_17 vrefd 16000.0
MpTa_L2_18_0 dpre_L3_0 gp_3_0_6 ctp_L2_18 0 NSYN W=10u L=1u
MnTb_L2_18_0 d1bar_L3 vcn ctp_L2_18 0 NSYN W=10u L=1u
MnTa_L2_18_0 dpre_L3_0 vcn ctn_L2_18 0 NSYN W=10u L=1u
MpTb_L2_18_0 d1bar_L3 gp_3_0_6 ctn_L2_18 0 NSYN W=10u L=1u
MpTa_L2_18_1 dpre_L3_3 gp_3_3_2 ctp_L2_18 0 NSYN W=10u L=1u
MnTb_L2_18_1 d1bar_L3 vcn ctp_L2_18 0 NSYN W=10u L=1u
MnTa_L2_18_1 dpre_L3_3 vcn ctn_L2_18 0 NSYN W=10u L=1u
MpTb_L2_18_1 d1bar_L3 gp_3_3_2 ctn_L2_18 0 NSYN W=10u L=1u
MpTa_L2_18_2 dpre_L3_6 gp_3_6_8 ctp_L2_18 0 NSYN W=10u L=1u
MnTb_L2_18_2 d1bar_L3 vcn ctp_L2_18 0 NSYN W=10u L=1u
MnTa_L2_18_2 dpre_L3_6 vcn ctn_L2_18 0 NSYN W=10u L=1u
MpTb_L2_18_2 d1bar_L3 gp_3_6_8 ctn_L2_18 0 NSYN W=10u L=1u
MpTa_L2_18_3 dpre_L3_7 gp_3_7_8 ctp_L2_18 0 NSYN W=10u L=1u
MnTb_L2_18_3 d1bar_L3 vcn ctp_L2_18 0 NSYN W=10u L=1u
MnTa_L2_18_3 dpre_L3_7 vcn ctn_L2_18 0 NSYN W=10u L=1u
MpTb_L2_18_3 d1bar_L3 gp_3_7_8 ctn_L2_18 0 NSYN W=10u L=1u
MpTa_L2_18_4 dpre_L3_8 gp_3_8_5 ctp_L2_18 0 NSYN W=10u L=1u
MnTb_L2_18_4 d1bar_L3 vcn ctp_L2_18 0 NSYN W=10u L=1u
MnTa_L2_18_4 dpre_L3_8 vcn ctn_L2_18 0 NSYN W=10u L=1u
MpTb_L2_18_4 d1bar_L3 gp_3_8_5 ctn_L2_18 0 NSYN W=10u L=1u
MpTa_L2_18_5 dpre_L3_9 gp_3_9_5 ctp_L2_18 0 NSYN W=10u L=1u
MnTb_L2_18_5 d1bar_L3 vcn ctp_L2_18 0 NSYN W=10u L=1u
MnTa_L2_18_5 dpre_L3_9 vcn ctn_L2_18 0 NSYN W=10u L=1u
MpTb_L2_18_5 d1bar_L3 gp_3_9_5 ctn_L2_18 0 NSYN W=10u L=1u
MpTa_L2_18_6 dpre_L3_16 gp_3_16_3 ctp_L2_18 0 NSYN W=10u L=1u
MnTb_L2_18_6 d1bar_L3 vcn ctp_L2_18 0 NSYN W=10u L=1u
MnTa_L2_18_6 dpre_L3_16 vcn ctn_L2_18 0 NSYN W=10u L=1u
MpTb_L2_18_6 d1bar_L3 gp_3_16_3 ctn_L2_18 0 NSYN W=10u L=1u
MpTa_L2_18_7 dpre_L3_18 gp_3_18_6 ctp_L2_18 0 NSYN W=10u L=1u
MnTb_L2_18_7 d1bar_L3 vcn ctp_L2_18 0 NSYN W=10u L=1u
MnTa_L2_18_7 dpre_L3_18 vcn ctn_L2_18 0 NSYN W=10u L=1u
MpTb_L2_18_7 d1bar_L3 gp_3_18_6 ctn_L2_18 0 NSYN W=10u L=1u
MpTa_L2_18_8 dpre_L3_19 gp_3_19_4 ctp_L2_18 0 NSYN W=10u L=1u
MnTb_L2_18_8 d1bar_L3 vcn ctp_L2_18 0 NSYN W=10u L=1u
MnTa_L2_18_8 dpre_L3_19 vcn ctn_L2_18 0 NSYN W=10u L=1u
MpTb_L2_18_8 d1bar_L3 gp_3_19_4 ctn_L2_18 0 NSYN W=10u L=1u
MpTa_L2_18_9 dpre_L3_23 gp_3_23_5 ctp_L2_18 0 NSYN W=10u L=1u
MnTb_L2_18_9 d1bar_L3 vcn ctp_L2_18 0 NSYN W=10u L=1u
MnTa_L2_18_9 dpre_L3_23 vcn ctn_L2_18 0 NSYN W=10u L=1u
MpTb_L2_18_9 d1bar_L3 gp_3_23_5 ctn_L2_18 0 NSYN W=10u L=1u
MpTa_L2_18_10 dpre_L3_29 gp_3_29_6 ctp_L2_18 0 NSYN W=10u L=1u
MnTb_L2_18_10 d1bar_L3 vcn ctp_L2_18 0 NSYN W=10u L=1u
MnTa_L2_18_10 dpre_L3_29 vcn ctn_L2_18 0 NSYN W=10u L=1u
MpTb_L2_18_10 d1bar_L3 gp_3_29_6 ctn_L2_18 0 NSYN W=10u L=1u
MpTa_L2_18_11 dpre_L3_33 gp_3_33_7 ctp_L2_18 0 NSYN W=10u L=1u
MnTb_L2_18_11 d1bar_L3 vcn ctp_L2_18 0 NSYN W=10u L=1u
MnTa_L2_18_11 dpre_L3_33 vcn ctn_L2_18 0 NSYN W=10u L=1u
MpTb_L2_18_11 d1bar_L3 gp_3_33_7 ctn_L2_18 0 NSYN W=10u L=1u
MpTa_L2_18_12 dpre_L3_43 gp_3_43_9 ctp_L2_18 0 NSYN W=10u L=1u
MnTb_L2_18_12 d1bar_L3 vcn ctp_L2_18 0 NSYN W=10u L=1u
MnTa_L2_18_12 dpre_L3_43 vcn ctn_L2_18 0 NSYN W=10u L=1u
MpTb_L2_18_12 d1bar_L3 gp_3_43_9 ctn_L2_18 0 NSYN W=10u L=1u
Msa_bk_L2_18 ctn_L2_18 ctn_L2_18 0 0 NMIR W=20u L=1u
Msb_bk_L2_18 dpre_L2_18 ctn_L2_18 0 0 NMIR W=20u L=1u
Msc_bk_L2_18 ctp_L2_18 ctp_L2_18 0 0 NMIR W=20u L=1u
Msd_bk_L2_18 dpf_bk_L2_18 ctp_L2_18 0 0 NMIR W=20u L=1u
Mse_bk_L2_18 dpf_bk_L2_18 dpf_bk_L2_18 vdd vdd PMIR W=60u L=1u
Msf_bk_L2_18 dpre_L2_18 dpf_bk_L2_18 vdd vdd PMIR W=60u L=1u
R_bk_L2_18 dpre_L2_18 vrefd 16000.0
MpTa_L2_19_0 dpre_L3_1 gp_3_1_4 ctp_L2_19 0 NSYN W=10u L=1u
MnTb_L2_19_0 d1bar_L3 vcn ctp_L2_19 0 NSYN W=10u L=1u
MnTa_L2_19_0 dpre_L3_1 vcn ctn_L2_19 0 NSYN W=10u L=1u
MpTb_L2_19_0 d1bar_L3 gp_3_1_4 ctn_L2_19 0 NSYN W=10u L=1u
MpTa_L2_19_1 dpre_L3_13 gp_3_13_6 ctp_L2_19 0 NSYN W=10u L=1u
MnTb_L2_19_1 d1bar_L3 vcn ctp_L2_19 0 NSYN W=10u L=1u
MnTa_L2_19_1 dpre_L3_13 vcn ctn_L2_19 0 NSYN W=10u L=1u
MpTb_L2_19_1 d1bar_L3 gp_3_13_6 ctn_L2_19 0 NSYN W=10u L=1u
MpTa_L2_19_2 dpre_L3_14 gp_3_14_5 ctp_L2_19 0 NSYN W=10u L=1u
MnTb_L2_19_2 d1bar_L3 vcn ctp_L2_19 0 NSYN W=10u L=1u
MnTa_L2_19_2 dpre_L3_14 vcn ctn_L2_19 0 NSYN W=10u L=1u
MpTb_L2_19_2 d1bar_L3 gp_3_14_5 ctn_L2_19 0 NSYN W=10u L=1u
MpTa_L2_19_3 dpre_L3_19 gp_3_19_5 ctp_L2_19 0 NSYN W=10u L=1u
MnTb_L2_19_3 d1bar_L3 vcn ctp_L2_19 0 NSYN W=10u L=1u
MnTa_L2_19_3 dpre_L3_19 vcn ctn_L2_19 0 NSYN W=10u L=1u
MpTb_L2_19_3 d1bar_L3 gp_3_19_5 ctn_L2_19 0 NSYN W=10u L=1u
MpTa_L2_19_4 dpre_L3_21 gp_3_21_7 ctp_L2_19 0 NSYN W=10u L=1u
MnTb_L2_19_4 d1bar_L3 vcn ctp_L2_19 0 NSYN W=10u L=1u
MnTa_L2_19_4 dpre_L3_21 vcn ctn_L2_19 0 NSYN W=10u L=1u
MpTb_L2_19_4 d1bar_L3 gp_3_21_7 ctn_L2_19 0 NSYN W=10u L=1u
MpTa_L2_19_5 dpre_L3_24 gp_3_24_4 ctp_L2_19 0 NSYN W=10u L=1u
MnTb_L2_19_5 d1bar_L3 vcn ctp_L2_19 0 NSYN W=10u L=1u
MnTa_L2_19_5 dpre_L3_24 vcn ctn_L2_19 0 NSYN W=10u L=1u
MpTb_L2_19_5 d1bar_L3 gp_3_24_4 ctn_L2_19 0 NSYN W=10u L=1u
MpTa_L2_19_6 dpre_L3_25 gp_3_25_6 ctp_L2_19 0 NSYN W=10u L=1u
MnTb_L2_19_6 d1bar_L3 vcn ctp_L2_19 0 NSYN W=10u L=1u
MnTa_L2_19_6 dpre_L3_25 vcn ctn_L2_19 0 NSYN W=10u L=1u
MpTb_L2_19_6 d1bar_L3 gp_3_25_6 ctn_L2_19 0 NSYN W=10u L=1u
MpTa_L2_19_7 dpre_L3_26 gp_3_26_6 ctp_L2_19 0 NSYN W=10u L=1u
MnTb_L2_19_7 d1bar_L3 vcn ctp_L2_19 0 NSYN W=10u L=1u
MnTa_L2_19_7 dpre_L3_26 vcn ctn_L2_19 0 NSYN W=10u L=1u
MpTb_L2_19_7 d1bar_L3 gp_3_26_6 ctn_L2_19 0 NSYN W=10u L=1u
MpTa_L2_19_8 dpre_L3_28 gp_3_28_7 ctp_L2_19 0 NSYN W=10u L=1u
MnTb_L2_19_8 d1bar_L3 vcn ctp_L2_19 0 NSYN W=10u L=1u
MnTa_L2_19_8 dpre_L3_28 vcn ctn_L2_19 0 NSYN W=10u L=1u
MpTb_L2_19_8 d1bar_L3 gp_3_28_7 ctn_L2_19 0 NSYN W=10u L=1u
MpTa_L2_19_9 dpre_L3_30 gp_3_30_6 ctp_L2_19 0 NSYN W=10u L=1u
MnTb_L2_19_9 d1bar_L3 vcn ctp_L2_19 0 NSYN W=10u L=1u
MnTa_L2_19_9 dpre_L3_30 vcn ctn_L2_19 0 NSYN W=10u L=1u
MpTb_L2_19_9 d1bar_L3 gp_3_30_6 ctn_L2_19 0 NSYN W=10u L=1u
MpTa_L2_19_10 dpre_L3_32 gp_3_32_7 ctp_L2_19 0 NSYN W=10u L=1u
MnTb_L2_19_10 d1bar_L3 vcn ctp_L2_19 0 NSYN W=10u L=1u
MnTa_L2_19_10 dpre_L3_32 vcn ctn_L2_19 0 NSYN W=10u L=1u
MpTb_L2_19_10 d1bar_L3 gp_3_32_7 ctn_L2_19 0 NSYN W=10u L=1u
MpTa_L2_19_11 dpre_L3_36 gp_3_36_5 ctp_L2_19 0 NSYN W=10u L=1u
MnTb_L2_19_11 d1bar_L3 vcn ctp_L2_19 0 NSYN W=10u L=1u
MnTa_L2_19_11 dpre_L3_36 vcn ctn_L2_19 0 NSYN W=10u L=1u
MpTb_L2_19_11 d1bar_L3 gp_3_36_5 ctn_L2_19 0 NSYN W=10u L=1u
MpTa_L2_19_12 dpre_L3_40 gp_3_40_8 ctp_L2_19 0 NSYN W=10u L=1u
MnTb_L2_19_12 d1bar_L3 vcn ctp_L2_19 0 NSYN W=10u L=1u
MnTa_L2_19_12 dpre_L3_40 vcn ctn_L2_19 0 NSYN W=10u L=1u
MpTb_L2_19_12 d1bar_L3 gp_3_40_8 ctn_L2_19 0 NSYN W=10u L=1u
MpTa_L2_19_13 dpre_L3_42 gp_3_42_7 ctp_L2_19 0 NSYN W=10u L=1u
MnTb_L2_19_13 d1bar_L3 vcn ctp_L2_19 0 NSYN W=10u L=1u
MnTa_L2_19_13 dpre_L3_42 vcn ctn_L2_19 0 NSYN W=10u L=1u
MpTb_L2_19_13 d1bar_L3 gp_3_42_7 ctn_L2_19 0 NSYN W=10u L=1u
MpTa_L2_19_14 dpre_L3_44 gp_3_44_4 ctp_L2_19 0 NSYN W=10u L=1u
MnTb_L2_19_14 d1bar_L3 vcn ctp_L2_19 0 NSYN W=10u L=1u
MnTa_L2_19_14 dpre_L3_44 vcn ctn_L2_19 0 NSYN W=10u L=1u
MpTb_L2_19_14 d1bar_L3 gp_3_44_4 ctn_L2_19 0 NSYN W=10u L=1u
MpTa_L2_19_15 dpre_L3_47 gp_3_47_7 ctp_L2_19 0 NSYN W=10u L=1u
MnTb_L2_19_15 d1bar_L3 vcn ctp_L2_19 0 NSYN W=10u L=1u
MnTa_L2_19_15 dpre_L3_47 vcn ctn_L2_19 0 NSYN W=10u L=1u
MpTb_L2_19_15 d1bar_L3 gp_3_47_7 ctn_L2_19 0 NSYN W=10u L=1u
Msa_bk_L2_19 ctn_L2_19 ctn_L2_19 0 0 NMIR W=20u L=1u
Msb_bk_L2_19 dpre_L2_19 ctn_L2_19 0 0 NMIR W=20u L=1u
Msc_bk_L2_19 ctp_L2_19 ctp_L2_19 0 0 NMIR W=20u L=1u
Msd_bk_L2_19 dpf_bk_L2_19 ctp_L2_19 0 0 NMIR W=20u L=1u
Mse_bk_L2_19 dpf_bk_L2_19 dpf_bk_L2_19 vdd vdd PMIR W=60u L=1u
Msf_bk_L2_19 dpre_L2_19 dpf_bk_L2_19 vdd vdd PMIR W=60u L=1u
R_bk_L2_19 dpre_L2_19 vrefd 16000.0
MpTa_L2_20_0 dpre_L3_0 gp_3_0_7 ctp_L2_20 0 NSYN W=10u L=1u
MnTb_L2_20_0 d1bar_L3 vcn ctp_L2_20 0 NSYN W=10u L=1u
MnTa_L2_20_0 dpre_L3_0 vcn ctn_L2_20 0 NSYN W=10u L=1u
MpTb_L2_20_0 d1bar_L3 gp_3_0_7 ctn_L2_20 0 NSYN W=10u L=1u
MpTa_L2_20_1 dpre_L3_3 gp_3_3_3 ctp_L2_20 0 NSYN W=10u L=1u
MnTb_L2_20_1 d1bar_L3 vcn ctp_L2_20 0 NSYN W=10u L=1u
MnTa_L2_20_1 dpre_L3_3 vcn ctn_L2_20 0 NSYN W=10u L=1u
MpTb_L2_20_1 d1bar_L3 gp_3_3_3 ctn_L2_20 0 NSYN W=10u L=1u
MpTa_L2_20_2 dpre_L3_10 gp_3_10_5 ctp_L2_20 0 NSYN W=10u L=1u
MnTb_L2_20_2 d1bar_L3 vcn ctp_L2_20 0 NSYN W=10u L=1u
MnTa_L2_20_2 dpre_L3_10 vcn ctn_L2_20 0 NSYN W=10u L=1u
MpTb_L2_20_2 d1bar_L3 gp_3_10_5 ctn_L2_20 0 NSYN W=10u L=1u
MpTa_L2_20_3 dpre_L3_13 gp_3_13_7 ctp_L2_20 0 NSYN W=10u L=1u
MnTb_L2_20_3 d1bar_L3 vcn ctp_L2_20 0 NSYN W=10u L=1u
MnTa_L2_20_3 dpre_L3_13 vcn ctn_L2_20 0 NSYN W=10u L=1u
MpTb_L2_20_3 d1bar_L3 gp_3_13_7 ctn_L2_20 0 NSYN W=10u L=1u
MpTa_L2_20_4 dpre_L3_18 gp_3_18_7 ctp_L2_20 0 NSYN W=10u L=1u
MnTb_L2_20_4 d1bar_L3 vcn ctp_L2_20 0 NSYN W=10u L=1u
MnTa_L2_20_4 dpre_L3_18 vcn ctn_L2_20 0 NSYN W=10u L=1u
MpTb_L2_20_4 d1bar_L3 gp_3_18_7 ctn_L2_20 0 NSYN W=10u L=1u
MpTa_L2_20_5 dpre_L3_20 gp_3_20_6 ctp_L2_20 0 NSYN W=10u L=1u
MnTb_L2_20_5 d1bar_L3 vcn ctp_L2_20 0 NSYN W=10u L=1u
MnTa_L2_20_5 dpre_L3_20 vcn ctn_L2_20 0 NSYN W=10u L=1u
MpTb_L2_20_5 d1bar_L3 gp_3_20_6 ctn_L2_20 0 NSYN W=10u L=1u
MpTa_L2_20_6 dpre_L3_29 gp_3_29_7 ctp_L2_20 0 NSYN W=10u L=1u
MnTb_L2_20_6 d1bar_L3 vcn ctp_L2_20 0 NSYN W=10u L=1u
MnTa_L2_20_6 dpre_L3_29 vcn ctn_L2_20 0 NSYN W=10u L=1u
MpTb_L2_20_6 d1bar_L3 gp_3_29_7 ctn_L2_20 0 NSYN W=10u L=1u
MpTa_L2_20_7 dpre_L3_30 gp_3_30_7 ctp_L2_20 0 NSYN W=10u L=1u
MnTb_L2_20_7 d1bar_L3 vcn ctp_L2_20 0 NSYN W=10u L=1u
MnTa_L2_20_7 dpre_L3_30 vcn ctn_L2_20 0 NSYN W=10u L=1u
MpTb_L2_20_7 d1bar_L3 gp_3_30_7 ctn_L2_20 0 NSYN W=10u L=1u
MpTa_L2_20_8 dpre_L3_32 gp_3_32_8 ctp_L2_20 0 NSYN W=10u L=1u
MnTb_L2_20_8 d1bar_L3 vcn ctp_L2_20 0 NSYN W=10u L=1u
MnTa_L2_20_8 dpre_L3_32 vcn ctn_L2_20 0 NSYN W=10u L=1u
MpTb_L2_20_8 d1bar_L3 gp_3_32_8 ctn_L2_20 0 NSYN W=10u L=1u
MpTa_L2_20_9 dpre_L3_36 gp_3_36_6 ctp_L2_20 0 NSYN W=10u L=1u
MnTb_L2_20_9 d1bar_L3 vcn ctp_L2_20 0 NSYN W=10u L=1u
MnTa_L2_20_9 dpre_L3_36 vcn ctn_L2_20 0 NSYN W=10u L=1u
MpTb_L2_20_9 d1bar_L3 gp_3_36_6 ctn_L2_20 0 NSYN W=10u L=1u
MpTa_L2_20_10 dpre_L3_37 gp_3_37_6 ctp_L2_20 0 NSYN W=10u L=1u
MnTb_L2_20_10 d1bar_L3 vcn ctp_L2_20 0 NSYN W=10u L=1u
MnTa_L2_20_10 dpre_L3_37 vcn ctn_L2_20 0 NSYN W=10u L=1u
MpTb_L2_20_10 d1bar_L3 gp_3_37_6 ctn_L2_20 0 NSYN W=10u L=1u
MpTa_L2_20_11 dpre_L3_46 gp_3_46_5 ctp_L2_20 0 NSYN W=10u L=1u
MnTb_L2_20_11 d1bar_L3 vcn ctp_L2_20 0 NSYN W=10u L=1u
MnTa_L2_20_11 dpre_L3_46 vcn ctn_L2_20 0 NSYN W=10u L=1u
MpTb_L2_20_11 d1bar_L3 gp_3_46_5 ctn_L2_20 0 NSYN W=10u L=1u
Msa_bk_L2_20 ctn_L2_20 ctn_L2_20 0 0 NMIR W=20u L=1u
Msb_bk_L2_20 dpre_L2_20 ctn_L2_20 0 0 NMIR W=20u L=1u
Msc_bk_L2_20 ctp_L2_20 ctp_L2_20 0 0 NMIR W=20u L=1u
Msd_bk_L2_20 dpf_bk_L2_20 ctp_L2_20 0 0 NMIR W=20u L=1u
Mse_bk_L2_20 dpf_bk_L2_20 dpf_bk_L2_20 vdd vdd PMIR W=60u L=1u
Msf_bk_L2_20 dpre_L2_20 dpf_bk_L2_20 vdd vdd PMIR W=60u L=1u
R_bk_L2_20 dpre_L2_20 vrefd 16000.0
MpTa_L2_21_0 dpre_L3_0 gp_3_0_8 ctp_L2_21 0 NSYN W=10u L=1u
MnTb_L2_21_0 d1bar_L3 vcn ctp_L2_21 0 NSYN W=10u L=1u
MnTa_L2_21_0 dpre_L3_0 vcn ctn_L2_21 0 NSYN W=10u L=1u
MpTb_L2_21_0 d1bar_L3 gp_3_0_8 ctn_L2_21 0 NSYN W=10u L=1u
MpTa_L2_21_1 dpre_L3_1 gp_3_1_5 ctp_L2_21 0 NSYN W=10u L=1u
MnTb_L2_21_1 d1bar_L3 vcn ctp_L2_21 0 NSYN W=10u L=1u
MnTa_L2_21_1 dpre_L3_1 vcn ctn_L2_21 0 NSYN W=10u L=1u
MpTb_L2_21_1 d1bar_L3 gp_3_1_5 ctn_L2_21 0 NSYN W=10u L=1u
MpTa_L2_21_2 dpre_L3_2 gp_3_2_5 ctp_L2_21 0 NSYN W=10u L=1u
MnTb_L2_21_2 d1bar_L3 vcn ctp_L2_21 0 NSYN W=10u L=1u
MnTa_L2_21_2 dpre_L3_2 vcn ctn_L2_21 0 NSYN W=10u L=1u
MpTb_L2_21_2 d1bar_L3 gp_3_2_5 ctn_L2_21 0 NSYN W=10u L=1u
MpTa_L2_21_3 dpre_L3_6 gp_3_6_9 ctp_L2_21 0 NSYN W=10u L=1u
MnTb_L2_21_3 d1bar_L3 vcn ctp_L2_21 0 NSYN W=10u L=1u
MnTa_L2_21_3 dpre_L3_6 vcn ctn_L2_21 0 NSYN W=10u L=1u
MpTb_L2_21_3 d1bar_L3 gp_3_6_9 ctn_L2_21 0 NSYN W=10u L=1u
MpTa_L2_21_4 dpre_L3_7 gp_3_7_9 ctp_L2_21 0 NSYN W=10u L=1u
MnTb_L2_21_4 d1bar_L3 vcn ctp_L2_21 0 NSYN W=10u L=1u
MnTa_L2_21_4 dpre_L3_7 vcn ctn_L2_21 0 NSYN W=10u L=1u
MpTb_L2_21_4 d1bar_L3 gp_3_7_9 ctn_L2_21 0 NSYN W=10u L=1u
MpTa_L2_21_5 dpre_L3_8 gp_3_8_6 ctp_L2_21 0 NSYN W=10u L=1u
MnTb_L2_21_5 d1bar_L3 vcn ctp_L2_21 0 NSYN W=10u L=1u
MnTa_L2_21_5 dpre_L3_8 vcn ctn_L2_21 0 NSYN W=10u L=1u
MpTb_L2_21_5 d1bar_L3 gp_3_8_6 ctn_L2_21 0 NSYN W=10u L=1u
MpTa_L2_21_6 dpre_L3_17 gp_3_17_7 ctp_L2_21 0 NSYN W=10u L=1u
MnTb_L2_21_6 d1bar_L3 vcn ctp_L2_21 0 NSYN W=10u L=1u
MnTa_L2_21_6 dpre_L3_17 vcn ctn_L2_21 0 NSYN W=10u L=1u
MpTb_L2_21_6 d1bar_L3 gp_3_17_7 ctn_L2_21 0 NSYN W=10u L=1u
MpTa_L2_21_7 dpre_L3_22 gp_3_22_7 ctp_L2_21 0 NSYN W=10u L=1u
MnTb_L2_21_7 d1bar_L3 vcn ctp_L2_21 0 NSYN W=10u L=1u
MnTa_L2_21_7 dpre_L3_22 vcn ctn_L2_21 0 NSYN W=10u L=1u
MpTb_L2_21_7 d1bar_L3 gp_3_22_7 ctn_L2_21 0 NSYN W=10u L=1u
MpTa_L2_21_8 dpre_L3_24 gp_3_24_5 ctp_L2_21 0 NSYN W=10u L=1u
MnTb_L2_21_8 d1bar_L3 vcn ctp_L2_21 0 NSYN W=10u L=1u
MnTa_L2_21_8 dpre_L3_24 vcn ctn_L2_21 0 NSYN W=10u L=1u
MpTb_L2_21_8 d1bar_L3 gp_3_24_5 ctn_L2_21 0 NSYN W=10u L=1u
MpTa_L2_21_9 dpre_L3_26 gp_3_26_7 ctp_L2_21 0 NSYN W=10u L=1u
MnTb_L2_21_9 d1bar_L3 vcn ctp_L2_21 0 NSYN W=10u L=1u
MnTa_L2_21_9 dpre_L3_26 vcn ctn_L2_21 0 NSYN W=10u L=1u
MpTb_L2_21_9 d1bar_L3 gp_3_26_7 ctn_L2_21 0 NSYN W=10u L=1u
MpTa_L2_21_10 dpre_L3_29 gp_3_29_8 ctp_L2_21 0 NSYN W=10u L=1u
MnTb_L2_21_10 d1bar_L3 vcn ctp_L2_21 0 NSYN W=10u L=1u
MnTa_L2_21_10 dpre_L3_29 vcn ctn_L2_21 0 NSYN W=10u L=1u
MpTb_L2_21_10 d1bar_L3 gp_3_29_8 ctn_L2_21 0 NSYN W=10u L=1u
MpTa_L2_21_11 dpre_L3_35 gp_3_35_5 ctp_L2_21 0 NSYN W=10u L=1u
MnTb_L2_21_11 d1bar_L3 vcn ctp_L2_21 0 NSYN W=10u L=1u
MnTa_L2_21_11 dpre_L3_35 vcn ctn_L2_21 0 NSYN W=10u L=1u
MpTb_L2_21_11 d1bar_L3 gp_3_35_5 ctn_L2_21 0 NSYN W=10u L=1u
MpTa_L2_21_12 dpre_L3_38 gp_3_38_7 ctp_L2_21 0 NSYN W=10u L=1u
MnTb_L2_21_12 d1bar_L3 vcn ctp_L2_21 0 NSYN W=10u L=1u
MnTa_L2_21_12 dpre_L3_38 vcn ctn_L2_21 0 NSYN W=10u L=1u
MpTb_L2_21_12 d1bar_L3 gp_3_38_7 ctn_L2_21 0 NSYN W=10u L=1u
Msa_bk_L2_21 ctn_L2_21 ctn_L2_21 0 0 NMIR W=20u L=1u
Msb_bk_L2_21 dpre_L2_21 ctn_L2_21 0 0 NMIR W=20u L=1u
Msc_bk_L2_21 ctp_L2_21 ctp_L2_21 0 0 NMIR W=20u L=1u
Msd_bk_L2_21 dpf_bk_L2_21 ctp_L2_21 0 0 NMIR W=20u L=1u
Mse_bk_L2_21 dpf_bk_L2_21 dpf_bk_L2_21 vdd vdd PMIR W=60u L=1u
Msf_bk_L2_21 dpre_L2_21 dpf_bk_L2_21 vdd vdd PMIR W=60u L=1u
R_bk_L2_21 dpre_L2_21 vrefd 16000.0
MpTa_L2_22_0 dpre_L3_4 gp_3_4_9 ctp_L2_22 0 NSYN W=10u L=1u
MnTb_L2_22_0 d1bar_L3 vcn ctp_L2_22 0 NSYN W=10u L=1u
MnTa_L2_22_0 dpre_L3_4 vcn ctn_L2_22 0 NSYN W=10u L=1u
MpTb_L2_22_0 d1bar_L3 gp_3_4_9 ctn_L2_22 0 NSYN W=10u L=1u
MpTa_L2_22_1 dpre_L3_13 gp_3_13_8 ctp_L2_22 0 NSYN W=10u L=1u
MnTb_L2_22_1 d1bar_L3 vcn ctp_L2_22 0 NSYN W=10u L=1u
MnTa_L2_22_1 dpre_L3_13 vcn ctn_L2_22 0 NSYN W=10u L=1u
MpTb_L2_22_1 d1bar_L3 gp_3_13_8 ctn_L2_22 0 NSYN W=10u L=1u
MpTa_L2_22_2 dpre_L3_19 gp_3_19_6 ctp_L2_22 0 NSYN W=10u L=1u
MnTb_L2_22_2 d1bar_L3 vcn ctp_L2_22 0 NSYN W=10u L=1u
MnTa_L2_22_2 dpre_L3_19 vcn ctn_L2_22 0 NSYN W=10u L=1u
MpTb_L2_22_2 d1bar_L3 gp_3_19_6 ctn_L2_22 0 NSYN W=10u L=1u
MpTa_L2_22_3 dpre_L3_26 gp_3_26_8 ctp_L2_22 0 NSYN W=10u L=1u
MnTb_L2_22_3 d1bar_L3 vcn ctp_L2_22 0 NSYN W=10u L=1u
MnTa_L2_22_3 dpre_L3_26 vcn ctn_L2_22 0 NSYN W=10u L=1u
MpTb_L2_22_3 d1bar_L3 gp_3_26_8 ctn_L2_22 0 NSYN W=10u L=1u
MpTa_L2_22_4 dpre_L3_27 gp_3_27_5 ctp_L2_22 0 NSYN W=10u L=1u
MnTb_L2_22_4 d1bar_L3 vcn ctp_L2_22 0 NSYN W=10u L=1u
MnTa_L2_22_4 dpre_L3_27 vcn ctn_L2_22 0 NSYN W=10u L=1u
MpTb_L2_22_4 d1bar_L3 gp_3_27_5 ctn_L2_22 0 NSYN W=10u L=1u
MpTa_L2_22_5 dpre_L3_33 gp_3_33_8 ctp_L2_22 0 NSYN W=10u L=1u
MnTb_L2_22_5 d1bar_L3 vcn ctp_L2_22 0 NSYN W=10u L=1u
MnTa_L2_22_5 dpre_L3_33 vcn ctn_L2_22 0 NSYN W=10u L=1u
MpTb_L2_22_5 d1bar_L3 gp_3_33_8 ctn_L2_22 0 NSYN W=10u L=1u
MpTa_L2_22_6 dpre_L3_34 gp_3_34_7 ctp_L2_22 0 NSYN W=10u L=1u
MnTb_L2_22_6 d1bar_L3 vcn ctp_L2_22 0 NSYN W=10u L=1u
MnTa_L2_22_6 dpre_L3_34 vcn ctn_L2_22 0 NSYN W=10u L=1u
MpTb_L2_22_6 d1bar_L3 gp_3_34_7 ctn_L2_22 0 NSYN W=10u L=1u
MpTa_L2_22_7 dpre_L3_37 gp_3_37_7 ctp_L2_22 0 NSYN W=10u L=1u
MnTb_L2_22_7 d1bar_L3 vcn ctp_L2_22 0 NSYN W=10u L=1u
MnTa_L2_22_7 dpre_L3_37 vcn ctn_L2_22 0 NSYN W=10u L=1u
MpTb_L2_22_7 d1bar_L3 gp_3_37_7 ctn_L2_22 0 NSYN W=10u L=1u
MpTa_L2_22_8 dpre_L3_41 gp_3_41_7 ctp_L2_22 0 NSYN W=10u L=1u
MnTb_L2_22_8 d1bar_L3 vcn ctp_L2_22 0 NSYN W=10u L=1u
MnTa_L2_22_8 dpre_L3_41 vcn ctn_L2_22 0 NSYN W=10u L=1u
MpTb_L2_22_8 d1bar_L3 gp_3_41_7 ctn_L2_22 0 NSYN W=10u L=1u
MpTa_L2_22_9 dpre_L3_46 gp_3_46_6 ctp_L2_22 0 NSYN W=10u L=1u
MnTb_L2_22_9 d1bar_L3 vcn ctp_L2_22 0 NSYN W=10u L=1u
MnTa_L2_22_9 dpre_L3_46 vcn ctn_L2_22 0 NSYN W=10u L=1u
MpTb_L2_22_9 d1bar_L3 gp_3_46_6 ctn_L2_22 0 NSYN W=10u L=1u
Msa_bk_L2_22 ctn_L2_22 ctn_L2_22 0 0 NMIR W=20u L=1u
Msb_bk_L2_22 dpre_L2_22 ctn_L2_22 0 0 NMIR W=20u L=1u
Msc_bk_L2_22 ctp_L2_22 ctp_L2_22 0 0 NMIR W=20u L=1u
Msd_bk_L2_22 dpf_bk_L2_22 ctp_L2_22 0 0 NMIR W=20u L=1u
Mse_bk_L2_22 dpf_bk_L2_22 dpf_bk_L2_22 vdd vdd PMIR W=60u L=1u
Msf_bk_L2_22 dpre_L2_22 dpf_bk_L2_22 vdd vdd PMIR W=60u L=1u
R_bk_L2_22 dpre_L2_22 vrefd 16000.0
MpTa_L2_23_0 dpre_L3_1 gp_3_1_6 ctp_L2_23 0 NSYN W=10u L=1u
MnTb_L2_23_0 d1bar_L3 vcn ctp_L2_23 0 NSYN W=10u L=1u
MnTa_L2_23_0 dpre_L3_1 vcn ctn_L2_23 0 NSYN W=10u L=1u
MpTb_L2_23_0 d1bar_L3 gp_3_1_6 ctn_L2_23 0 NSYN W=10u L=1u
MpTa_L2_23_1 dpre_L3_8 gp_3_8_7 ctp_L2_23 0 NSYN W=10u L=1u
MnTb_L2_23_1 d1bar_L3 vcn ctp_L2_23 0 NSYN W=10u L=1u
MnTa_L2_23_1 dpre_L3_8 vcn ctn_L2_23 0 NSYN W=10u L=1u
MpTb_L2_23_1 d1bar_L3 gp_3_8_7 ctn_L2_23 0 NSYN W=10u L=1u
MpTa_L2_23_2 dpre_L3_10 gp_3_10_6 ctp_L2_23 0 NSYN W=10u L=1u
MnTb_L2_23_2 d1bar_L3 vcn ctp_L2_23 0 NSYN W=10u L=1u
MnTa_L2_23_2 dpre_L3_10 vcn ctn_L2_23 0 NSYN W=10u L=1u
MpTb_L2_23_2 d1bar_L3 gp_3_10_6 ctn_L2_23 0 NSYN W=10u L=1u
MpTa_L2_23_3 dpre_L3_12 gp_3_12_3 ctp_L2_23 0 NSYN W=10u L=1u
MnTb_L2_23_3 d1bar_L3 vcn ctp_L2_23 0 NSYN W=10u L=1u
MnTa_L2_23_3 dpre_L3_12 vcn ctn_L2_23 0 NSYN W=10u L=1u
MpTb_L2_23_3 d1bar_L3 gp_3_12_3 ctn_L2_23 0 NSYN W=10u L=1u
MpTa_L2_23_4 dpre_L3_14 gp_3_14_6 ctp_L2_23 0 NSYN W=10u L=1u
MnTb_L2_23_4 d1bar_L3 vcn ctp_L2_23 0 NSYN W=10u L=1u
MnTa_L2_23_4 dpre_L3_14 vcn ctn_L2_23 0 NSYN W=10u L=1u
MpTb_L2_23_4 d1bar_L3 gp_3_14_6 ctn_L2_23 0 NSYN W=10u L=1u
MpTa_L2_23_5 dpre_L3_16 gp_3_16_4 ctp_L2_23 0 NSYN W=10u L=1u
MnTb_L2_23_5 d1bar_L3 vcn ctp_L2_23 0 NSYN W=10u L=1u
MnTa_L2_23_5 dpre_L3_16 vcn ctn_L2_23 0 NSYN W=10u L=1u
MpTb_L2_23_5 d1bar_L3 gp_3_16_4 ctn_L2_23 0 NSYN W=10u L=1u
MpTa_L2_23_6 dpre_L3_17 gp_3_17_8 ctp_L2_23 0 NSYN W=10u L=1u
MnTb_L2_23_6 d1bar_L3 vcn ctp_L2_23 0 NSYN W=10u L=1u
MnTa_L2_23_6 dpre_L3_17 vcn ctn_L2_23 0 NSYN W=10u L=1u
MpTb_L2_23_6 d1bar_L3 gp_3_17_8 ctn_L2_23 0 NSYN W=10u L=1u
MpTa_L2_23_7 dpre_L3_20 gp_3_20_7 ctp_L2_23 0 NSYN W=10u L=1u
MnTb_L2_23_7 d1bar_L3 vcn ctp_L2_23 0 NSYN W=10u L=1u
MnTa_L2_23_7 dpre_L3_20 vcn ctn_L2_23 0 NSYN W=10u L=1u
MpTb_L2_23_7 d1bar_L3 gp_3_20_7 ctn_L2_23 0 NSYN W=10u L=1u
MpTa_L2_23_8 dpre_L3_21 gp_3_21_8 ctp_L2_23 0 NSYN W=10u L=1u
MnTb_L2_23_8 d1bar_L3 vcn ctp_L2_23 0 NSYN W=10u L=1u
MnTa_L2_23_8 dpre_L3_21 vcn ctn_L2_23 0 NSYN W=10u L=1u
MpTb_L2_23_8 d1bar_L3 gp_3_21_8 ctn_L2_23 0 NSYN W=10u L=1u
MpTa_L2_23_9 dpre_L3_22 gp_3_22_8 ctp_L2_23 0 NSYN W=10u L=1u
MnTb_L2_23_9 d1bar_L3 vcn ctp_L2_23 0 NSYN W=10u L=1u
MnTa_L2_23_9 dpre_L3_22 vcn ctn_L2_23 0 NSYN W=10u L=1u
MpTb_L2_23_9 d1bar_L3 gp_3_22_8 ctn_L2_23 0 NSYN W=10u L=1u
MpTa_L2_23_10 dpre_L3_25 gp_3_25_7 ctp_L2_23 0 NSYN W=10u L=1u
MnTb_L2_23_10 d1bar_L3 vcn ctp_L2_23 0 NSYN W=10u L=1u
MnTa_L2_23_10 dpre_L3_25 vcn ctn_L2_23 0 NSYN W=10u L=1u
MpTb_L2_23_10 d1bar_L3 gp_3_25_7 ctn_L2_23 0 NSYN W=10u L=1u
MpTa_L2_23_11 dpre_L3_29 gp_3_29_9 ctp_L2_23 0 NSYN W=10u L=1u
MnTb_L2_23_11 d1bar_L3 vcn ctp_L2_23 0 NSYN W=10u L=1u
MnTa_L2_23_11 dpre_L3_29 vcn ctn_L2_23 0 NSYN W=10u L=1u
MpTb_L2_23_11 d1bar_L3 gp_3_29_9 ctn_L2_23 0 NSYN W=10u L=1u
MpTa_L2_23_12 dpre_L3_35 gp_3_35_6 ctp_L2_23 0 NSYN W=10u L=1u
MnTb_L2_23_12 d1bar_L3 vcn ctp_L2_23 0 NSYN W=10u L=1u
MnTa_L2_23_12 dpre_L3_35 vcn ctn_L2_23 0 NSYN W=10u L=1u
MpTb_L2_23_12 d1bar_L3 gp_3_35_6 ctn_L2_23 0 NSYN W=10u L=1u
MpTa_L2_23_13 dpre_L3_37 gp_3_37_8 ctp_L2_23 0 NSYN W=10u L=1u
MnTb_L2_23_13 d1bar_L3 vcn ctp_L2_23 0 NSYN W=10u L=1u
MnTa_L2_23_13 dpre_L3_37 vcn ctn_L2_23 0 NSYN W=10u L=1u
MpTb_L2_23_13 d1bar_L3 gp_3_37_8 ctn_L2_23 0 NSYN W=10u L=1u
MpTa_L2_23_14 dpre_L3_39 gp_3_39_4 ctp_L2_23 0 NSYN W=10u L=1u
MnTb_L2_23_14 d1bar_L3 vcn ctp_L2_23 0 NSYN W=10u L=1u
MnTa_L2_23_14 dpre_L3_39 vcn ctn_L2_23 0 NSYN W=10u L=1u
MpTb_L2_23_14 d1bar_L3 gp_3_39_4 ctn_L2_23 0 NSYN W=10u L=1u
MpTa_L2_23_15 dpre_L3_42 gp_3_42_8 ctp_L2_23 0 NSYN W=10u L=1u
MnTb_L2_23_15 d1bar_L3 vcn ctp_L2_23 0 NSYN W=10u L=1u
MnTa_L2_23_15 dpre_L3_42 vcn ctn_L2_23 0 NSYN W=10u L=1u
MpTb_L2_23_15 d1bar_L3 gp_3_42_8 ctn_L2_23 0 NSYN W=10u L=1u
MpTa_L2_23_16 dpre_L3_44 gp_3_44_5 ctp_L2_23 0 NSYN W=10u L=1u
MnTb_L2_23_16 d1bar_L3 vcn ctp_L2_23 0 NSYN W=10u L=1u
MnTa_L2_23_16 dpre_L3_44 vcn ctn_L2_23 0 NSYN W=10u L=1u
MpTb_L2_23_16 d1bar_L3 gp_3_44_5 ctn_L2_23 0 NSYN W=10u L=1u
MpTa_L2_23_17 dpre_L3_45 gp_3_45_7 ctp_L2_23 0 NSYN W=10u L=1u
MnTb_L2_23_17 d1bar_L3 vcn ctp_L2_23 0 NSYN W=10u L=1u
MnTa_L2_23_17 dpre_L3_45 vcn ctn_L2_23 0 NSYN W=10u L=1u
MpTb_L2_23_17 d1bar_L3 gp_3_45_7 ctn_L2_23 0 NSYN W=10u L=1u
MpTa_L2_23_18 dpre_L3_47 gp_3_47_8 ctp_L2_23 0 NSYN W=10u L=1u
MnTb_L2_23_18 d1bar_L3 vcn ctp_L2_23 0 NSYN W=10u L=1u
MnTa_L2_23_18 dpre_L3_47 vcn ctn_L2_23 0 NSYN W=10u L=1u
MpTb_L2_23_18 d1bar_L3 gp_3_47_8 ctn_L2_23 0 NSYN W=10u L=1u
Msa_bk_L2_23 ctn_L2_23 ctn_L2_23 0 0 NMIR W=20u L=1u
Msb_bk_L2_23 dpre_L2_23 ctn_L2_23 0 0 NMIR W=20u L=1u
Msc_bk_L2_23 ctp_L2_23 ctp_L2_23 0 0 NMIR W=20u L=1u
Msd_bk_L2_23 dpf_bk_L2_23 ctp_L2_23 0 0 NMIR W=20u L=1u
Mse_bk_L2_23 dpf_bk_L2_23 dpf_bk_L2_23 vdd vdd PMIR W=60u L=1u
Msf_bk_L2_23 dpre_L2_23 dpf_bk_L2_23 vdd vdd PMIR W=60u L=1u
R_bk_L2_23 dpre_L2_23 vrefd 16000.0
MpTa_L2_24_0 dpre_L3_3 gp_3_3_4 ctp_L2_24 0 NSYN W=10u L=1u
MnTb_L2_24_0 d1bar_L3 vcn ctp_L2_24 0 NSYN W=10u L=1u
MnTa_L2_24_0 dpre_L3_3 vcn ctn_L2_24 0 NSYN W=10u L=1u
MpTb_L2_24_0 d1bar_L3 gp_3_3_4 ctn_L2_24 0 NSYN W=10u L=1u
MpTa_L2_24_1 dpre_L3_6 gp_3_6_10 ctp_L2_24 0 NSYN W=10u L=1u
MnTb_L2_24_1 d1bar_L3 vcn ctp_L2_24 0 NSYN W=10u L=1u
MnTa_L2_24_1 dpre_L3_6 vcn ctn_L2_24 0 NSYN W=10u L=1u
MpTb_L2_24_1 d1bar_L3 gp_3_6_10 ctn_L2_24 0 NSYN W=10u L=1u
MpTa_L2_24_2 dpre_L3_7 gp_3_7_10 ctp_L2_24 0 NSYN W=10u L=1u
MnTb_L2_24_2 d1bar_L3 vcn ctp_L2_24 0 NSYN W=10u L=1u
MnTa_L2_24_2 dpre_L3_7 vcn ctn_L2_24 0 NSYN W=10u L=1u
MpTb_L2_24_2 d1bar_L3 gp_3_7_10 ctn_L2_24 0 NSYN W=10u L=1u
MpTa_L2_24_3 dpre_L3_8 gp_3_8_8 ctp_L2_24 0 NSYN W=10u L=1u
MnTb_L2_24_3 d1bar_L3 vcn ctp_L2_24 0 NSYN W=10u L=1u
MnTa_L2_24_3 dpre_L3_8 vcn ctn_L2_24 0 NSYN W=10u L=1u
MpTb_L2_24_3 d1bar_L3 gp_3_8_8 ctn_L2_24 0 NSYN W=10u L=1u
MpTa_L2_24_4 dpre_L3_9 gp_3_9_6 ctp_L2_24 0 NSYN W=10u L=1u
MnTb_L2_24_4 d1bar_L3 vcn ctp_L2_24 0 NSYN W=10u L=1u
MnTa_L2_24_4 dpre_L3_9 vcn ctn_L2_24 0 NSYN W=10u L=1u
MpTb_L2_24_4 d1bar_L3 gp_3_9_6 ctn_L2_24 0 NSYN W=10u L=1u
MpTa_L2_24_5 dpre_L3_10 gp_3_10_7 ctp_L2_24 0 NSYN W=10u L=1u
MnTb_L2_24_5 d1bar_L3 vcn ctp_L2_24 0 NSYN W=10u L=1u
MnTa_L2_24_5 dpre_L3_10 vcn ctn_L2_24 0 NSYN W=10u L=1u
MpTb_L2_24_5 d1bar_L3 gp_3_10_7 ctn_L2_24 0 NSYN W=10u L=1u
MpTa_L2_24_6 dpre_L3_12 gp_3_12_4 ctp_L2_24 0 NSYN W=10u L=1u
MnTb_L2_24_6 d1bar_L3 vcn ctp_L2_24 0 NSYN W=10u L=1u
MnTa_L2_24_6 dpre_L3_12 vcn ctn_L2_24 0 NSYN W=10u L=1u
MpTb_L2_24_6 d1bar_L3 gp_3_12_4 ctn_L2_24 0 NSYN W=10u L=1u
MpTa_L2_24_7 dpre_L3_13 gp_3_13_9 ctp_L2_24 0 NSYN W=10u L=1u
MnTb_L2_24_7 d1bar_L3 vcn ctp_L2_24 0 NSYN W=10u L=1u
MnTa_L2_24_7 dpre_L3_13 vcn ctn_L2_24 0 NSYN W=10u L=1u
MpTb_L2_24_7 d1bar_L3 gp_3_13_9 ctn_L2_24 0 NSYN W=10u L=1u
MpTa_L2_24_8 dpre_L3_14 gp_3_14_7 ctp_L2_24 0 NSYN W=10u L=1u
MnTb_L2_24_8 d1bar_L3 vcn ctp_L2_24 0 NSYN W=10u L=1u
MnTa_L2_24_8 dpre_L3_14 vcn ctn_L2_24 0 NSYN W=10u L=1u
MpTb_L2_24_8 d1bar_L3 gp_3_14_7 ctn_L2_24 0 NSYN W=10u L=1u
MpTa_L2_24_9 dpre_L3_20 gp_3_20_8 ctp_L2_24 0 NSYN W=10u L=1u
MnTb_L2_24_9 d1bar_L3 vcn ctp_L2_24 0 NSYN W=10u L=1u
MnTa_L2_24_9 dpre_L3_20 vcn ctn_L2_24 0 NSYN W=10u L=1u
MpTb_L2_24_9 d1bar_L3 gp_3_20_8 ctn_L2_24 0 NSYN W=10u L=1u
MpTa_L2_24_10 dpre_L3_22 gp_3_22_9 ctp_L2_24 0 NSYN W=10u L=1u
MnTb_L2_24_10 d1bar_L3 vcn ctp_L2_24 0 NSYN W=10u L=1u
MnTa_L2_24_10 dpre_L3_22 vcn ctn_L2_24 0 NSYN W=10u L=1u
MpTb_L2_24_10 d1bar_L3 gp_3_22_9 ctn_L2_24 0 NSYN W=10u L=1u
MpTa_L2_24_11 dpre_L3_23 gp_3_23_6 ctp_L2_24 0 NSYN W=10u L=1u
MnTb_L2_24_11 d1bar_L3 vcn ctp_L2_24 0 NSYN W=10u L=1u
MnTa_L2_24_11 dpre_L3_23 vcn ctn_L2_24 0 NSYN W=10u L=1u
MpTb_L2_24_11 d1bar_L3 gp_3_23_6 ctn_L2_24 0 NSYN W=10u L=1u
MpTa_L2_24_12 dpre_L3_31 gp_3_31_7 ctp_L2_24 0 NSYN W=10u L=1u
MnTb_L2_24_12 d1bar_L3 vcn ctp_L2_24 0 NSYN W=10u L=1u
MnTa_L2_24_12 dpre_L3_31 vcn ctn_L2_24 0 NSYN W=10u L=1u
MpTb_L2_24_12 d1bar_L3 gp_3_31_7 ctn_L2_24 0 NSYN W=10u L=1u
MpTa_L2_24_13 dpre_L3_32 gp_3_32_9 ctp_L2_24 0 NSYN W=10u L=1u
MnTb_L2_24_13 d1bar_L3 vcn ctp_L2_24 0 NSYN W=10u L=1u
MnTa_L2_24_13 dpre_L3_32 vcn ctn_L2_24 0 NSYN W=10u L=1u
MpTb_L2_24_13 d1bar_L3 gp_3_32_9 ctn_L2_24 0 NSYN W=10u L=1u
MpTa_L2_24_14 dpre_L3_34 gp_3_34_8 ctp_L2_24 0 NSYN W=10u L=1u
MnTb_L2_24_14 d1bar_L3 vcn ctp_L2_24 0 NSYN W=10u L=1u
MnTa_L2_24_14 dpre_L3_34 vcn ctn_L2_24 0 NSYN W=10u L=1u
MpTb_L2_24_14 d1bar_L3 gp_3_34_8 ctn_L2_24 0 NSYN W=10u L=1u
MpTa_L2_24_15 dpre_L3_36 gp_3_36_7 ctp_L2_24 0 NSYN W=10u L=1u
MnTb_L2_24_15 d1bar_L3 vcn ctp_L2_24 0 NSYN W=10u L=1u
MnTa_L2_24_15 dpre_L3_36 vcn ctn_L2_24 0 NSYN W=10u L=1u
MpTb_L2_24_15 d1bar_L3 gp_3_36_7 ctn_L2_24 0 NSYN W=10u L=1u
MpTa_L2_24_16 dpre_L3_37 gp_3_37_9 ctp_L2_24 0 NSYN W=10u L=1u
MnTb_L2_24_16 d1bar_L3 vcn ctp_L2_24 0 NSYN W=10u L=1u
MnTa_L2_24_16 dpre_L3_37 vcn ctn_L2_24 0 NSYN W=10u L=1u
MpTb_L2_24_16 d1bar_L3 gp_3_37_9 ctn_L2_24 0 NSYN W=10u L=1u
MpTa_L2_24_17 dpre_L3_42 gp_3_42_9 ctp_L2_24 0 NSYN W=10u L=1u
MnTb_L2_24_17 d1bar_L3 vcn ctp_L2_24 0 NSYN W=10u L=1u
MnTa_L2_24_17 dpre_L3_42 vcn ctn_L2_24 0 NSYN W=10u L=1u
MpTb_L2_24_17 d1bar_L3 gp_3_42_9 ctn_L2_24 0 NSYN W=10u L=1u
Msa_bk_L2_24 ctn_L2_24 ctn_L2_24 0 0 NMIR W=20u L=1u
Msb_bk_L2_24 dpre_L2_24 ctn_L2_24 0 0 NMIR W=20u L=1u
Msc_bk_L2_24 ctp_L2_24 ctp_L2_24 0 0 NMIR W=20u L=1u
Msd_bk_L2_24 dpf_bk_L2_24 ctp_L2_24 0 0 NMIR W=20u L=1u
Mse_bk_L2_24 dpf_bk_L2_24 dpf_bk_L2_24 vdd vdd PMIR W=60u L=1u
Msf_bk_L2_24 dpre_L2_24 dpf_bk_L2_24 vdd vdd PMIR W=60u L=1u
R_bk_L2_24 dpre_L2_24 vrefd 16000.0
MpTa_L2_25_0 dpre_L3_11 gp_3_11_5 ctp_L2_25 0 NSYN W=10u L=1u
MnTb_L2_25_0 d1bar_L3 vcn ctp_L2_25 0 NSYN W=10u L=1u
MnTa_L2_25_0 dpre_L3_11 vcn ctn_L2_25 0 NSYN W=10u L=1u
MpTb_L2_25_0 d1bar_L3 gp_3_11_5 ctn_L2_25 0 NSYN W=10u L=1u
MpTa_L2_25_1 dpre_L3_12 gp_3_12_5 ctp_L2_25 0 NSYN W=10u L=1u
MnTb_L2_25_1 d1bar_L3 vcn ctp_L2_25 0 NSYN W=10u L=1u
MnTa_L2_25_1 dpre_L3_12 vcn ctn_L2_25 0 NSYN W=10u L=1u
MpTb_L2_25_1 d1bar_L3 gp_3_12_5 ctn_L2_25 0 NSYN W=10u L=1u
MpTa_L2_25_2 dpre_L3_13 gp_3_13_10 ctp_L2_25 0 NSYN W=10u L=1u
MnTb_L2_25_2 d1bar_L3 vcn ctp_L2_25 0 NSYN W=10u L=1u
MnTa_L2_25_2 dpre_L3_13 vcn ctn_L2_25 0 NSYN W=10u L=1u
MpTb_L2_25_2 d1bar_L3 gp_3_13_10 ctn_L2_25 0 NSYN W=10u L=1u
MpTa_L2_25_3 dpre_L3_14 gp_3_14_8 ctp_L2_25 0 NSYN W=10u L=1u
MnTb_L2_25_3 d1bar_L3 vcn ctp_L2_25 0 NSYN W=10u L=1u
MnTa_L2_25_3 dpre_L3_14 vcn ctn_L2_25 0 NSYN W=10u L=1u
MpTb_L2_25_3 d1bar_L3 gp_3_14_8 ctn_L2_25 0 NSYN W=10u L=1u
MpTa_L2_25_4 dpre_L3_18 gp_3_18_8 ctp_L2_25 0 NSYN W=10u L=1u
MnTb_L2_25_4 d1bar_L3 vcn ctp_L2_25 0 NSYN W=10u L=1u
MnTa_L2_25_4 dpre_L3_18 vcn ctn_L2_25 0 NSYN W=10u L=1u
MpTb_L2_25_4 d1bar_L3 gp_3_18_8 ctn_L2_25 0 NSYN W=10u L=1u
MpTa_L2_25_5 dpre_L3_24 gp_3_24_6 ctp_L2_25 0 NSYN W=10u L=1u
MnTb_L2_25_5 d1bar_L3 vcn ctp_L2_25 0 NSYN W=10u L=1u
MnTa_L2_25_5 dpre_L3_24 vcn ctn_L2_25 0 NSYN W=10u L=1u
MpTb_L2_25_5 d1bar_L3 gp_3_24_6 ctn_L2_25 0 NSYN W=10u L=1u
MpTa_L2_25_6 dpre_L3_25 gp_3_25_8 ctp_L2_25 0 NSYN W=10u L=1u
MnTb_L2_25_6 d1bar_L3 vcn ctp_L2_25 0 NSYN W=10u L=1u
MnTa_L2_25_6 dpre_L3_25 vcn ctn_L2_25 0 NSYN W=10u L=1u
MpTb_L2_25_6 d1bar_L3 gp_3_25_8 ctn_L2_25 0 NSYN W=10u L=1u
MpTa_L2_25_7 dpre_L3_26 gp_3_26_9 ctp_L2_25 0 NSYN W=10u L=1u
MnTb_L2_25_7 d1bar_L3 vcn ctp_L2_25 0 NSYN W=10u L=1u
MnTa_L2_25_7 dpre_L3_26 vcn ctn_L2_25 0 NSYN W=10u L=1u
MpTb_L2_25_7 d1bar_L3 gp_3_26_9 ctn_L2_25 0 NSYN W=10u L=1u
MpTa_L2_25_8 dpre_L3_27 gp_3_27_6 ctp_L2_25 0 NSYN W=10u L=1u
MnTb_L2_25_8 d1bar_L3 vcn ctp_L2_25 0 NSYN W=10u L=1u
MnTa_L2_25_8 dpre_L3_27 vcn ctn_L2_25 0 NSYN W=10u L=1u
MpTb_L2_25_8 d1bar_L3 gp_3_27_6 ctn_L2_25 0 NSYN W=10u L=1u
MpTa_L2_25_9 dpre_L3_33 gp_3_33_9 ctp_L2_25 0 NSYN W=10u L=1u
MnTb_L2_25_9 d1bar_L3 vcn ctp_L2_25 0 NSYN W=10u L=1u
MnTa_L2_25_9 dpre_L3_33 vcn ctn_L2_25 0 NSYN W=10u L=1u
MpTb_L2_25_9 d1bar_L3 gp_3_33_9 ctn_L2_25 0 NSYN W=10u L=1u
MpTa_L2_25_10 dpre_L3_34 gp_3_34_9 ctp_L2_25 0 NSYN W=10u L=1u
MnTb_L2_25_10 d1bar_L3 vcn ctp_L2_25 0 NSYN W=10u L=1u
MnTa_L2_25_10 dpre_L3_34 vcn ctn_L2_25 0 NSYN W=10u L=1u
MpTb_L2_25_10 d1bar_L3 gp_3_34_9 ctn_L2_25 0 NSYN W=10u L=1u
MpTa_L2_25_11 dpre_L3_37 gp_3_37_10 ctp_L2_25 0 NSYN W=10u L=1u
MnTb_L2_25_11 d1bar_L3 vcn ctp_L2_25 0 NSYN W=10u L=1u
MnTa_L2_25_11 dpre_L3_37 vcn ctn_L2_25 0 NSYN W=10u L=1u
MpTb_L2_25_11 d1bar_L3 gp_3_37_10 ctn_L2_25 0 NSYN W=10u L=1u
MpTa_L2_25_12 dpre_L3_38 gp_3_38_8 ctp_L2_25 0 NSYN W=10u L=1u
MnTb_L2_25_12 d1bar_L3 vcn ctp_L2_25 0 NSYN W=10u L=1u
MnTa_L2_25_12 dpre_L3_38 vcn ctn_L2_25 0 NSYN W=10u L=1u
MpTb_L2_25_12 d1bar_L3 gp_3_38_8 ctn_L2_25 0 NSYN W=10u L=1u
MpTa_L2_25_13 dpre_L3_39 gp_3_39_5 ctp_L2_25 0 NSYN W=10u L=1u
MnTb_L2_25_13 d1bar_L3 vcn ctp_L2_25 0 NSYN W=10u L=1u
MnTa_L2_25_13 dpre_L3_39 vcn ctn_L2_25 0 NSYN W=10u L=1u
MpTb_L2_25_13 d1bar_L3 gp_3_39_5 ctn_L2_25 0 NSYN W=10u L=1u
MpTa_L2_25_14 dpre_L3_40 gp_3_40_9 ctp_L2_25 0 NSYN W=10u L=1u
MnTb_L2_25_14 d1bar_L3 vcn ctp_L2_25 0 NSYN W=10u L=1u
MnTa_L2_25_14 dpre_L3_40 vcn ctn_L2_25 0 NSYN W=10u L=1u
MpTb_L2_25_14 d1bar_L3 gp_3_40_9 ctn_L2_25 0 NSYN W=10u L=1u
MpTa_L2_25_15 dpre_L3_41 gp_3_41_8 ctp_L2_25 0 NSYN W=10u L=1u
MnTb_L2_25_15 d1bar_L3 vcn ctp_L2_25 0 NSYN W=10u L=1u
MnTa_L2_25_15 dpre_L3_41 vcn ctn_L2_25 0 NSYN W=10u L=1u
MpTb_L2_25_15 d1bar_L3 gp_3_41_8 ctn_L2_25 0 NSYN W=10u L=1u
MpTa_L2_25_16 dpre_L3_44 gp_3_44_6 ctp_L2_25 0 NSYN W=10u L=1u
MnTb_L2_25_16 d1bar_L3 vcn ctp_L2_25 0 NSYN W=10u L=1u
MnTa_L2_25_16 dpre_L3_44 vcn ctn_L2_25 0 NSYN W=10u L=1u
MpTb_L2_25_16 d1bar_L3 gp_3_44_6 ctn_L2_25 0 NSYN W=10u L=1u
MpTa_L2_25_17 dpre_L3_46 gp_3_46_7 ctp_L2_25 0 NSYN W=10u L=1u
MnTb_L2_25_17 d1bar_L3 vcn ctp_L2_25 0 NSYN W=10u L=1u
MnTa_L2_25_17 dpre_L3_46 vcn ctn_L2_25 0 NSYN W=10u L=1u
MpTb_L2_25_17 d1bar_L3 gp_3_46_7 ctn_L2_25 0 NSYN W=10u L=1u
Msa_bk_L2_25 ctn_L2_25 ctn_L2_25 0 0 NMIR W=20u L=1u
Msb_bk_L2_25 dpre_L2_25 ctn_L2_25 0 0 NMIR W=20u L=1u
Msc_bk_L2_25 ctp_L2_25 ctp_L2_25 0 0 NMIR W=20u L=1u
Msd_bk_L2_25 dpf_bk_L2_25 ctp_L2_25 0 0 NMIR W=20u L=1u
Mse_bk_L2_25 dpf_bk_L2_25 dpf_bk_L2_25 vdd vdd PMIR W=60u L=1u
Msf_bk_L2_25 dpre_L2_25 dpf_bk_L2_25 vdd vdd PMIR W=60u L=1u
R_bk_L2_25 dpre_L2_25 vrefd 16000.0
MpTa_L2_26_0 dpre_L3_2 gp_3_2_6 ctp_L2_26 0 NSYN W=10u L=1u
MnTb_L2_26_0 d1bar_L3 vcn ctp_L2_26 0 NSYN W=10u L=1u
MnTa_L2_26_0 dpre_L3_2 vcn ctn_L2_26 0 NSYN W=10u L=1u
MpTb_L2_26_0 d1bar_L3 gp_3_2_6 ctn_L2_26 0 NSYN W=10u L=1u
MpTa_L2_26_1 dpre_L3_5 gp_3_5_6 ctp_L2_26 0 NSYN W=10u L=1u
MnTb_L2_26_1 d1bar_L3 vcn ctp_L2_26 0 NSYN W=10u L=1u
MnTa_L2_26_1 dpre_L3_5 vcn ctn_L2_26 0 NSYN W=10u L=1u
MpTb_L2_26_1 d1bar_L3 gp_3_5_6 ctn_L2_26 0 NSYN W=10u L=1u
MpTa_L2_26_2 dpre_L3_7 gp_3_7_11 ctp_L2_26 0 NSYN W=10u L=1u
MnTb_L2_26_2 d1bar_L3 vcn ctp_L2_26 0 NSYN W=10u L=1u
MnTa_L2_26_2 dpre_L3_7 vcn ctn_L2_26 0 NSYN W=10u L=1u
MpTb_L2_26_2 d1bar_L3 gp_3_7_11 ctn_L2_26 0 NSYN W=10u L=1u
MpTa_L2_26_3 dpre_L3_8 gp_3_8_9 ctp_L2_26 0 NSYN W=10u L=1u
MnTb_L2_26_3 d1bar_L3 vcn ctp_L2_26 0 NSYN W=10u L=1u
MnTa_L2_26_3 dpre_L3_8 vcn ctn_L2_26 0 NSYN W=10u L=1u
MpTb_L2_26_3 d1bar_L3 gp_3_8_9 ctn_L2_26 0 NSYN W=10u L=1u
MpTa_L2_26_4 dpre_L3_9 gp_3_9_7 ctp_L2_26 0 NSYN W=10u L=1u
MnTb_L2_26_4 d1bar_L3 vcn ctp_L2_26 0 NSYN W=10u L=1u
MnTa_L2_26_4 dpre_L3_9 vcn ctn_L2_26 0 NSYN W=10u L=1u
MpTb_L2_26_4 d1bar_L3 gp_3_9_7 ctn_L2_26 0 NSYN W=10u L=1u
MpTa_L2_26_5 dpre_L3_11 gp_3_11_6 ctp_L2_26 0 NSYN W=10u L=1u
MnTb_L2_26_5 d1bar_L3 vcn ctp_L2_26 0 NSYN W=10u L=1u
MnTa_L2_26_5 dpre_L3_11 vcn ctn_L2_26 0 NSYN W=10u L=1u
MpTb_L2_26_5 d1bar_L3 gp_3_11_6 ctn_L2_26 0 NSYN W=10u L=1u
MpTa_L2_26_6 dpre_L3_14 gp_3_14_9 ctp_L2_26 0 NSYN W=10u L=1u
MnTb_L2_26_6 d1bar_L3 vcn ctp_L2_26 0 NSYN W=10u L=1u
MnTa_L2_26_6 dpre_L3_14 vcn ctn_L2_26 0 NSYN W=10u L=1u
MpTb_L2_26_6 d1bar_L3 gp_3_14_9 ctn_L2_26 0 NSYN W=10u L=1u
MpTa_L2_26_7 dpre_L3_16 gp_3_16_5 ctp_L2_26 0 NSYN W=10u L=1u
MnTb_L2_26_7 d1bar_L3 vcn ctp_L2_26 0 NSYN W=10u L=1u
MnTa_L2_26_7 dpre_L3_16 vcn ctn_L2_26 0 NSYN W=10u L=1u
MpTb_L2_26_7 d1bar_L3 gp_3_16_5 ctn_L2_26 0 NSYN W=10u L=1u
MpTa_L2_26_8 dpre_L3_25 gp_3_25_9 ctp_L2_26 0 NSYN W=10u L=1u
MnTb_L2_26_8 d1bar_L3 vcn ctp_L2_26 0 NSYN W=10u L=1u
MnTa_L2_26_8 dpre_L3_25 vcn ctn_L2_26 0 NSYN W=10u L=1u
MpTb_L2_26_8 d1bar_L3 gp_3_25_9 ctn_L2_26 0 NSYN W=10u L=1u
MpTa_L2_26_9 dpre_L3_27 gp_3_27_7 ctp_L2_26 0 NSYN W=10u L=1u
MnTb_L2_26_9 d1bar_L3 vcn ctp_L2_26 0 NSYN W=10u L=1u
MnTa_L2_26_9 dpre_L3_27 vcn ctn_L2_26 0 NSYN W=10u L=1u
MpTb_L2_26_9 d1bar_L3 gp_3_27_7 ctn_L2_26 0 NSYN W=10u L=1u
MpTa_L2_26_10 dpre_L3_28 gp_3_28_8 ctp_L2_26 0 NSYN W=10u L=1u
MnTb_L2_26_10 d1bar_L3 vcn ctp_L2_26 0 NSYN W=10u L=1u
MnTa_L2_26_10 dpre_L3_28 vcn ctn_L2_26 0 NSYN W=10u L=1u
MpTb_L2_26_10 d1bar_L3 gp_3_28_8 ctn_L2_26 0 NSYN W=10u L=1u
MpTa_L2_26_11 dpre_L3_31 gp_3_31_8 ctp_L2_26 0 NSYN W=10u L=1u
MnTb_L2_26_11 d1bar_L3 vcn ctp_L2_26 0 NSYN W=10u L=1u
MnTa_L2_26_11 dpre_L3_31 vcn ctn_L2_26 0 NSYN W=10u L=1u
MpTb_L2_26_11 d1bar_L3 gp_3_31_8 ctn_L2_26 0 NSYN W=10u L=1u
MpTa_L2_26_12 dpre_L3_32 gp_3_32_10 ctp_L2_26 0 NSYN W=10u L=1u
MnTb_L2_26_12 d1bar_L3 vcn ctp_L2_26 0 NSYN W=10u L=1u
MnTa_L2_26_12 dpre_L3_32 vcn ctn_L2_26 0 NSYN W=10u L=1u
MpTb_L2_26_12 d1bar_L3 gp_3_32_10 ctn_L2_26 0 NSYN W=10u L=1u
MpTa_L2_26_13 dpre_L3_33 gp_3_33_10 ctp_L2_26 0 NSYN W=10u L=1u
MnTb_L2_26_13 d1bar_L3 vcn ctp_L2_26 0 NSYN W=10u L=1u
MnTa_L2_26_13 dpre_L3_33 vcn ctn_L2_26 0 NSYN W=10u L=1u
MpTb_L2_26_13 d1bar_L3 gp_3_33_10 ctn_L2_26 0 NSYN W=10u L=1u
MpTa_L2_26_14 dpre_L3_42 gp_3_42_10 ctp_L2_26 0 NSYN W=10u L=1u
MnTb_L2_26_14 d1bar_L3 vcn ctp_L2_26 0 NSYN W=10u L=1u
MnTa_L2_26_14 dpre_L3_42 vcn ctn_L2_26 0 NSYN W=10u L=1u
MpTb_L2_26_14 d1bar_L3 gp_3_42_10 ctn_L2_26 0 NSYN W=10u L=1u
MpTa_L2_26_15 dpre_L3_45 gp_3_45_8 ctp_L2_26 0 NSYN W=10u L=1u
MnTb_L2_26_15 d1bar_L3 vcn ctp_L2_26 0 NSYN W=10u L=1u
MnTa_L2_26_15 dpre_L3_45 vcn ctn_L2_26 0 NSYN W=10u L=1u
MpTb_L2_26_15 d1bar_L3 gp_3_45_8 ctn_L2_26 0 NSYN W=10u L=1u
MpTa_L2_26_16 dpre_L3_46 gp_3_46_8 ctp_L2_26 0 NSYN W=10u L=1u
MnTb_L2_26_16 d1bar_L3 vcn ctp_L2_26 0 NSYN W=10u L=1u
MnTa_L2_26_16 dpre_L3_46 vcn ctn_L2_26 0 NSYN W=10u L=1u
MpTb_L2_26_16 d1bar_L3 gp_3_46_8 ctn_L2_26 0 NSYN W=10u L=1u
Msa_bk_L2_26 ctn_L2_26 ctn_L2_26 0 0 NMIR W=20u L=1u
Msb_bk_L2_26 dpre_L2_26 ctn_L2_26 0 0 NMIR W=20u L=1u
Msc_bk_L2_26 ctp_L2_26 ctp_L2_26 0 0 NMIR W=20u L=1u
Msd_bk_L2_26 dpf_bk_L2_26 ctp_L2_26 0 0 NMIR W=20u L=1u
Mse_bk_L2_26 dpf_bk_L2_26 dpf_bk_L2_26 vdd vdd PMIR W=60u L=1u
Msf_bk_L2_26 dpre_L2_26 dpf_bk_L2_26 vdd vdd PMIR W=60u L=1u
R_bk_L2_26 dpre_L2_26 vrefd 16000.0
MpTa_L2_27_0 dpre_L3_0 gp_3_0_9 ctp_L2_27 0 NSYN W=10u L=1u
MnTb_L2_27_0 d1bar_L3 vcn ctp_L2_27 0 NSYN W=10u L=1u
MnTa_L2_27_0 dpre_L3_0 vcn ctn_L2_27 0 NSYN W=10u L=1u
MpTb_L2_27_0 d1bar_L3 gp_3_0_9 ctn_L2_27 0 NSYN W=10u L=1u
MpTa_L2_27_1 dpre_L3_3 gp_3_3_5 ctp_L2_27 0 NSYN W=10u L=1u
MnTb_L2_27_1 d1bar_L3 vcn ctp_L2_27 0 NSYN W=10u L=1u
MnTa_L2_27_1 dpre_L3_3 vcn ctn_L2_27 0 NSYN W=10u L=1u
MpTb_L2_27_1 d1bar_L3 gp_3_3_5 ctn_L2_27 0 NSYN W=10u L=1u
MpTa_L2_27_2 dpre_L3_11 gp_3_11_7 ctp_L2_27 0 NSYN W=10u L=1u
MnTb_L2_27_2 d1bar_L3 vcn ctp_L2_27 0 NSYN W=10u L=1u
MnTa_L2_27_2 dpre_L3_11 vcn ctn_L2_27 0 NSYN W=10u L=1u
MpTb_L2_27_2 d1bar_L3 gp_3_11_7 ctn_L2_27 0 NSYN W=10u L=1u
MpTa_L2_27_3 dpre_L3_19 gp_3_19_7 ctp_L2_27 0 NSYN W=10u L=1u
MnTb_L2_27_3 d1bar_L3 vcn ctp_L2_27 0 NSYN W=10u L=1u
MnTa_L2_27_3 dpre_L3_19 vcn ctn_L2_27 0 NSYN W=10u L=1u
MpTb_L2_27_3 d1bar_L3 gp_3_19_7 ctn_L2_27 0 NSYN W=10u L=1u
MpTa_L2_27_4 dpre_L3_20 gp_3_20_9 ctp_L2_27 0 NSYN W=10u L=1u
MnTb_L2_27_4 d1bar_L3 vcn ctp_L2_27 0 NSYN W=10u L=1u
MnTa_L2_27_4 dpre_L3_20 vcn ctn_L2_27 0 NSYN W=10u L=1u
MpTb_L2_27_4 d1bar_L3 gp_3_20_9 ctn_L2_27 0 NSYN W=10u L=1u
MpTa_L2_27_5 dpre_L3_22 gp_3_22_10 ctp_L2_27 0 NSYN W=10u L=1u
MnTb_L2_27_5 d1bar_L3 vcn ctp_L2_27 0 NSYN W=10u L=1u
MnTa_L2_27_5 dpre_L3_22 vcn ctn_L2_27 0 NSYN W=10u L=1u
MpTb_L2_27_5 d1bar_L3 gp_3_22_10 ctn_L2_27 0 NSYN W=10u L=1u
MpTa_L2_27_6 dpre_L3_25 gp_3_25_10 ctp_L2_27 0 NSYN W=10u L=1u
MnTb_L2_27_6 d1bar_L3 vcn ctp_L2_27 0 NSYN W=10u L=1u
MnTa_L2_27_6 dpre_L3_25 vcn ctn_L2_27 0 NSYN W=10u L=1u
MpTb_L2_27_6 d1bar_L3 gp_3_25_10 ctn_L2_27 0 NSYN W=10u L=1u
MpTa_L2_27_7 dpre_L3_30 gp_3_30_8 ctp_L2_27 0 NSYN W=10u L=1u
MnTb_L2_27_7 d1bar_L3 vcn ctp_L2_27 0 NSYN W=10u L=1u
MnTa_L2_27_7 dpre_L3_30 vcn ctn_L2_27 0 NSYN W=10u L=1u
MpTb_L2_27_7 d1bar_L3 gp_3_30_8 ctn_L2_27 0 NSYN W=10u L=1u
MpTa_L2_27_8 dpre_L3_32 gp_3_32_11 ctp_L2_27 0 NSYN W=10u L=1u
MnTb_L2_27_8 d1bar_L3 vcn ctp_L2_27 0 NSYN W=10u L=1u
MnTa_L2_27_8 dpre_L3_32 vcn ctn_L2_27 0 NSYN W=10u L=1u
MpTb_L2_27_8 d1bar_L3 gp_3_32_11 ctn_L2_27 0 NSYN W=10u L=1u
MpTa_L2_27_9 dpre_L3_39 gp_3_39_6 ctp_L2_27 0 NSYN W=10u L=1u
MnTb_L2_27_9 d1bar_L3 vcn ctp_L2_27 0 NSYN W=10u L=1u
MnTa_L2_27_9 dpre_L3_39 vcn ctn_L2_27 0 NSYN W=10u L=1u
MpTb_L2_27_9 d1bar_L3 gp_3_39_6 ctn_L2_27 0 NSYN W=10u L=1u
MpTa_L2_27_10 dpre_L3_43 gp_3_43_10 ctp_L2_27 0 NSYN W=10u L=1u
MnTb_L2_27_10 d1bar_L3 vcn ctp_L2_27 0 NSYN W=10u L=1u
MnTa_L2_27_10 dpre_L3_43 vcn ctn_L2_27 0 NSYN W=10u L=1u
MpTb_L2_27_10 d1bar_L3 gp_3_43_10 ctn_L2_27 0 NSYN W=10u L=1u
Msa_bk_L2_27 ctn_L2_27 ctn_L2_27 0 0 NMIR W=20u L=1u
Msb_bk_L2_27 dpre_L2_27 ctn_L2_27 0 0 NMIR W=20u L=1u
Msc_bk_L2_27 ctp_L2_27 ctp_L2_27 0 0 NMIR W=20u L=1u
Msd_bk_L2_27 dpf_bk_L2_27 ctp_L2_27 0 0 NMIR W=20u L=1u
Mse_bk_L2_27 dpf_bk_L2_27 dpf_bk_L2_27 vdd vdd PMIR W=60u L=1u
Msf_bk_L2_27 dpre_L2_27 dpf_bk_L2_27 vdd vdd PMIR W=60u L=1u
R_bk_L2_27 dpre_L2_27 vrefd 16000.0
MpTa_L2_28_0 dpre_L3_0 gp_3_0_10 ctp_L2_28 0 NSYN W=10u L=1u
MnTb_L2_28_0 d1bar_L3 vcn ctp_L2_28 0 NSYN W=10u L=1u
MnTa_L2_28_0 dpre_L3_0 vcn ctn_L2_28 0 NSYN W=10u L=1u
MpTb_L2_28_0 d1bar_L3 gp_3_0_10 ctn_L2_28 0 NSYN W=10u L=1u
MpTa_L2_28_1 dpre_L3_1 gp_3_1_7 ctp_L2_28 0 NSYN W=10u L=1u
MnTb_L2_28_1 d1bar_L3 vcn ctp_L2_28 0 NSYN W=10u L=1u
MnTa_L2_28_1 dpre_L3_1 vcn ctn_L2_28 0 NSYN W=10u L=1u
MpTb_L2_28_1 d1bar_L3 gp_3_1_7 ctn_L2_28 0 NSYN W=10u L=1u
MpTa_L2_28_2 dpre_L3_4 gp_3_4_10 ctp_L2_28 0 NSYN W=10u L=1u
MnTb_L2_28_2 d1bar_L3 vcn ctp_L2_28 0 NSYN W=10u L=1u
MnTa_L2_28_2 dpre_L3_4 vcn ctn_L2_28 0 NSYN W=10u L=1u
MpTb_L2_28_2 d1bar_L3 gp_3_4_10 ctn_L2_28 0 NSYN W=10u L=1u
MpTa_L2_28_3 dpre_L3_5 gp_3_5_7 ctp_L2_28 0 NSYN W=10u L=1u
MnTb_L2_28_3 d1bar_L3 vcn ctp_L2_28 0 NSYN W=10u L=1u
MnTa_L2_28_3 dpre_L3_5 vcn ctn_L2_28 0 NSYN W=10u L=1u
MpTb_L2_28_3 d1bar_L3 gp_3_5_7 ctn_L2_28 0 NSYN W=10u L=1u
MpTa_L2_28_4 dpre_L3_8 gp_3_8_10 ctp_L2_28 0 NSYN W=10u L=1u
MnTb_L2_28_4 d1bar_L3 vcn ctp_L2_28 0 NSYN W=10u L=1u
MnTa_L2_28_4 dpre_L3_8 vcn ctn_L2_28 0 NSYN W=10u L=1u
MpTb_L2_28_4 d1bar_L3 gp_3_8_10 ctn_L2_28 0 NSYN W=10u L=1u
MpTa_L2_28_5 dpre_L3_9 gp_3_9_8 ctp_L2_28 0 NSYN W=10u L=1u
MnTb_L2_28_5 d1bar_L3 vcn ctp_L2_28 0 NSYN W=10u L=1u
MnTa_L2_28_5 dpre_L3_9 vcn ctn_L2_28 0 NSYN W=10u L=1u
MpTb_L2_28_5 d1bar_L3 gp_3_9_8 ctn_L2_28 0 NSYN W=10u L=1u
MpTa_L2_28_6 dpre_L3_11 gp_3_11_8 ctp_L2_28 0 NSYN W=10u L=1u
MnTb_L2_28_6 d1bar_L3 vcn ctp_L2_28 0 NSYN W=10u L=1u
MnTa_L2_28_6 dpre_L3_11 vcn ctn_L2_28 0 NSYN W=10u L=1u
MpTb_L2_28_6 d1bar_L3 gp_3_11_8 ctn_L2_28 0 NSYN W=10u L=1u
MpTa_L2_28_7 dpre_L3_15 gp_3_15_9 ctp_L2_28 0 NSYN W=10u L=1u
MnTb_L2_28_7 d1bar_L3 vcn ctp_L2_28 0 NSYN W=10u L=1u
MnTa_L2_28_7 dpre_L3_15 vcn ctn_L2_28 0 NSYN W=10u L=1u
MpTb_L2_28_7 d1bar_L3 gp_3_15_9 ctn_L2_28 0 NSYN W=10u L=1u
MpTa_L2_28_8 dpre_L3_16 gp_3_16_6 ctp_L2_28 0 NSYN W=10u L=1u
MnTb_L2_28_8 d1bar_L3 vcn ctp_L2_28 0 NSYN W=10u L=1u
MnTa_L2_28_8 dpre_L3_16 vcn ctn_L2_28 0 NSYN W=10u L=1u
MpTb_L2_28_8 d1bar_L3 gp_3_16_6 ctn_L2_28 0 NSYN W=10u L=1u
MpTa_L2_28_9 dpre_L3_19 gp_3_19_8 ctp_L2_28 0 NSYN W=10u L=1u
MnTb_L2_28_9 d1bar_L3 vcn ctp_L2_28 0 NSYN W=10u L=1u
MnTa_L2_28_9 dpre_L3_19 vcn ctn_L2_28 0 NSYN W=10u L=1u
MpTb_L2_28_9 d1bar_L3 gp_3_19_8 ctn_L2_28 0 NSYN W=10u L=1u
MpTa_L2_28_10 dpre_L3_20 gp_3_20_10 ctp_L2_28 0 NSYN W=10u L=1u
MnTb_L2_28_10 d1bar_L3 vcn ctp_L2_28 0 NSYN W=10u L=1u
MnTa_L2_28_10 dpre_L3_20 vcn ctn_L2_28 0 NSYN W=10u L=1u
MpTb_L2_28_10 d1bar_L3 gp_3_20_10 ctn_L2_28 0 NSYN W=10u L=1u
MpTa_L2_28_11 dpre_L3_26 gp_3_26_10 ctp_L2_28 0 NSYN W=10u L=1u
MnTb_L2_28_11 d1bar_L3 vcn ctp_L2_28 0 NSYN W=10u L=1u
MnTa_L2_28_11 dpre_L3_26 vcn ctn_L2_28 0 NSYN W=10u L=1u
MpTb_L2_28_11 d1bar_L3 gp_3_26_10 ctn_L2_28 0 NSYN W=10u L=1u
MpTa_L2_28_12 dpre_L3_27 gp_3_27_8 ctp_L2_28 0 NSYN W=10u L=1u
MnTb_L2_28_12 d1bar_L3 vcn ctp_L2_28 0 NSYN W=10u L=1u
MnTa_L2_28_12 dpre_L3_27 vcn ctn_L2_28 0 NSYN W=10u L=1u
MpTb_L2_28_12 d1bar_L3 gp_3_27_8 ctn_L2_28 0 NSYN W=10u L=1u
MpTa_L2_28_13 dpre_L3_36 gp_3_36_8 ctp_L2_28 0 NSYN W=10u L=1u
MnTb_L2_28_13 d1bar_L3 vcn ctp_L2_28 0 NSYN W=10u L=1u
MnTa_L2_28_13 dpre_L3_36 vcn ctn_L2_28 0 NSYN W=10u L=1u
MpTb_L2_28_13 d1bar_L3 gp_3_36_8 ctn_L2_28 0 NSYN W=10u L=1u
MpTa_L2_28_14 dpre_L3_40 gp_3_40_10 ctp_L2_28 0 NSYN W=10u L=1u
MnTb_L2_28_14 d1bar_L3 vcn ctp_L2_28 0 NSYN W=10u L=1u
MnTa_L2_28_14 dpre_L3_40 vcn ctn_L2_28 0 NSYN W=10u L=1u
MpTb_L2_28_14 d1bar_L3 gp_3_40_10 ctn_L2_28 0 NSYN W=10u L=1u
MpTa_L2_28_15 dpre_L3_41 gp_3_41_9 ctp_L2_28 0 NSYN W=10u L=1u
MnTb_L2_28_15 d1bar_L3 vcn ctp_L2_28 0 NSYN W=10u L=1u
MnTa_L2_28_15 dpre_L3_41 vcn ctn_L2_28 0 NSYN W=10u L=1u
MpTb_L2_28_15 d1bar_L3 gp_3_41_9 ctn_L2_28 0 NSYN W=10u L=1u
MpTa_L2_28_16 dpre_L3_46 gp_3_46_9 ctp_L2_28 0 NSYN W=10u L=1u
MnTb_L2_28_16 d1bar_L3 vcn ctp_L2_28 0 NSYN W=10u L=1u
MnTa_L2_28_16 dpre_L3_46 vcn ctn_L2_28 0 NSYN W=10u L=1u
MpTb_L2_28_16 d1bar_L3 gp_3_46_9 ctn_L2_28 0 NSYN W=10u L=1u
Msa_bk_L2_28 ctn_L2_28 ctn_L2_28 0 0 NMIR W=20u L=1u
Msb_bk_L2_28 dpre_L2_28 ctn_L2_28 0 0 NMIR W=20u L=1u
Msc_bk_L2_28 ctp_L2_28 ctp_L2_28 0 0 NMIR W=20u L=1u
Msd_bk_L2_28 dpf_bk_L2_28 ctp_L2_28 0 0 NMIR W=20u L=1u
Mse_bk_L2_28 dpf_bk_L2_28 dpf_bk_L2_28 vdd vdd PMIR W=60u L=1u
Msf_bk_L2_28 dpre_L2_28 dpf_bk_L2_28 vdd vdd PMIR W=60u L=1u
R_bk_L2_28 dpre_L2_28 vrefd 16000.0
MpTa_L2_29_0 dpre_L3_1 gp_3_1_8 ctp_L2_29 0 NSYN W=10u L=1u
MnTb_L2_29_0 d1bar_L3 vcn ctp_L2_29 0 NSYN W=10u L=1u
MnTa_L2_29_0 dpre_L3_1 vcn ctn_L2_29 0 NSYN W=10u L=1u
MpTb_L2_29_0 d1bar_L3 gp_3_1_8 ctn_L2_29 0 NSYN W=10u L=1u
MpTa_L2_29_1 dpre_L3_10 gp_3_10_8 ctp_L2_29 0 NSYN W=10u L=1u
MnTb_L2_29_1 d1bar_L3 vcn ctp_L2_29 0 NSYN W=10u L=1u
MnTa_L2_29_1 dpre_L3_10 vcn ctn_L2_29 0 NSYN W=10u L=1u
MpTb_L2_29_1 d1bar_L3 gp_3_10_8 ctn_L2_29 0 NSYN W=10u L=1u
MpTa_L2_29_2 dpre_L3_11 gp_3_11_9 ctp_L2_29 0 NSYN W=10u L=1u
MnTb_L2_29_2 d1bar_L3 vcn ctp_L2_29 0 NSYN W=10u L=1u
MnTa_L2_29_2 dpre_L3_11 vcn ctn_L2_29 0 NSYN W=10u L=1u
MpTb_L2_29_2 d1bar_L3 gp_3_11_9 ctn_L2_29 0 NSYN W=10u L=1u
MpTa_L2_29_3 dpre_L3_12 gp_3_12_6 ctp_L2_29 0 NSYN W=10u L=1u
MnTb_L2_29_3 d1bar_L3 vcn ctp_L2_29 0 NSYN W=10u L=1u
MnTa_L2_29_3 dpre_L3_12 vcn ctn_L2_29 0 NSYN W=10u L=1u
MpTb_L2_29_3 d1bar_L3 gp_3_12_6 ctn_L2_29 0 NSYN W=10u L=1u
MpTa_L2_29_4 dpre_L3_16 gp_3_16_7 ctp_L2_29 0 NSYN W=10u L=1u
MnTb_L2_29_4 d1bar_L3 vcn ctp_L2_29 0 NSYN W=10u L=1u
MnTa_L2_29_4 dpre_L3_16 vcn ctn_L2_29 0 NSYN W=10u L=1u
MpTb_L2_29_4 d1bar_L3 gp_3_16_7 ctn_L2_29 0 NSYN W=10u L=1u
MpTa_L2_29_5 dpre_L3_21 gp_3_21_9 ctp_L2_29 0 NSYN W=10u L=1u
MnTb_L2_29_5 d1bar_L3 vcn ctp_L2_29 0 NSYN W=10u L=1u
MnTa_L2_29_5 dpre_L3_21 vcn ctn_L2_29 0 NSYN W=10u L=1u
MpTb_L2_29_5 d1bar_L3 gp_3_21_9 ctn_L2_29 0 NSYN W=10u L=1u
MpTa_L2_29_6 dpre_L3_23 gp_3_23_7 ctp_L2_29 0 NSYN W=10u L=1u
MnTb_L2_29_6 d1bar_L3 vcn ctp_L2_29 0 NSYN W=10u L=1u
MnTa_L2_29_6 dpre_L3_23 vcn ctn_L2_29 0 NSYN W=10u L=1u
MpTb_L2_29_6 d1bar_L3 gp_3_23_7 ctn_L2_29 0 NSYN W=10u L=1u
MpTa_L2_29_7 dpre_L3_30 gp_3_30_9 ctp_L2_29 0 NSYN W=10u L=1u
MnTb_L2_29_7 d1bar_L3 vcn ctp_L2_29 0 NSYN W=10u L=1u
MnTa_L2_29_7 dpre_L3_30 vcn ctn_L2_29 0 NSYN W=10u L=1u
MpTb_L2_29_7 d1bar_L3 gp_3_30_9 ctn_L2_29 0 NSYN W=10u L=1u
MpTa_L2_29_8 dpre_L3_33 gp_3_33_11 ctp_L2_29 0 NSYN W=10u L=1u
MnTb_L2_29_8 d1bar_L3 vcn ctp_L2_29 0 NSYN W=10u L=1u
MnTa_L2_29_8 dpre_L3_33 vcn ctn_L2_29 0 NSYN W=10u L=1u
MpTb_L2_29_8 d1bar_L3 gp_3_33_11 ctn_L2_29 0 NSYN W=10u L=1u
MpTa_L2_29_9 dpre_L3_44 gp_3_44_7 ctp_L2_29 0 NSYN W=10u L=1u
MnTb_L2_29_9 d1bar_L3 vcn ctp_L2_29 0 NSYN W=10u L=1u
MnTa_L2_29_9 dpre_L3_44 vcn ctn_L2_29 0 NSYN W=10u L=1u
MpTb_L2_29_9 d1bar_L3 gp_3_44_7 ctn_L2_29 0 NSYN W=10u L=1u
Msa_bk_L2_29 ctn_L2_29 ctn_L2_29 0 0 NMIR W=20u L=1u
Msb_bk_L2_29 dpre_L2_29 ctn_L2_29 0 0 NMIR W=20u L=1u
Msc_bk_L2_29 ctp_L2_29 ctp_L2_29 0 0 NMIR W=20u L=1u
Msd_bk_L2_29 dpf_bk_L2_29 ctp_L2_29 0 0 NMIR W=20u L=1u
Mse_bk_L2_29 dpf_bk_L2_29 dpf_bk_L2_29 vdd vdd PMIR W=60u L=1u
Msf_bk_L2_29 dpre_L2_29 dpf_bk_L2_29 vdd vdd PMIR W=60u L=1u
R_bk_L2_29 dpre_L2_29 vrefd 16000.0
MpTa_L2_30_0 dpre_L3_4 gp_3_4_11 ctp_L2_30 0 NSYN W=10u L=1u
MnTb_L2_30_0 d1bar_L3 vcn ctp_L2_30 0 NSYN W=10u L=1u
MnTa_L2_30_0 dpre_L3_4 vcn ctn_L2_30 0 NSYN W=10u L=1u
MpTb_L2_30_0 d1bar_L3 gp_3_4_11 ctn_L2_30 0 NSYN W=10u L=1u
MpTa_L2_30_1 dpre_L3_5 gp_3_5_8 ctp_L2_30 0 NSYN W=10u L=1u
MnTb_L2_30_1 d1bar_L3 vcn ctp_L2_30 0 NSYN W=10u L=1u
MnTa_L2_30_1 dpre_L3_5 vcn ctn_L2_30 0 NSYN W=10u L=1u
MpTb_L2_30_1 d1bar_L3 gp_3_5_8 ctn_L2_30 0 NSYN W=10u L=1u
MpTa_L2_30_2 dpre_L3_6 gp_3_6_11 ctp_L2_30 0 NSYN W=10u L=1u
MnTb_L2_30_2 d1bar_L3 vcn ctp_L2_30 0 NSYN W=10u L=1u
MnTa_L2_30_2 dpre_L3_6 vcn ctn_L2_30 0 NSYN W=10u L=1u
MpTb_L2_30_2 d1bar_L3 gp_3_6_11 ctn_L2_30 0 NSYN W=10u L=1u
MpTa_L2_30_3 dpre_L3_11 gp_3_11_10 ctp_L2_30 0 NSYN W=10u L=1u
MnTb_L2_30_3 d1bar_L3 vcn ctp_L2_30 0 NSYN W=10u L=1u
MnTa_L2_30_3 dpre_L3_11 vcn ctn_L2_30 0 NSYN W=10u L=1u
MpTb_L2_30_3 d1bar_L3 gp_3_11_10 ctn_L2_30 0 NSYN W=10u L=1u
MpTa_L2_30_4 dpre_L3_12 gp_3_12_7 ctp_L2_30 0 NSYN W=10u L=1u
MnTb_L2_30_4 d1bar_L3 vcn ctp_L2_30 0 NSYN W=10u L=1u
MnTa_L2_30_4 dpre_L3_12 vcn ctn_L2_30 0 NSYN W=10u L=1u
MpTb_L2_30_4 d1bar_L3 gp_3_12_7 ctn_L2_30 0 NSYN W=10u L=1u
MpTa_L2_30_5 dpre_L3_17 gp_3_17_9 ctp_L2_30 0 NSYN W=10u L=1u
MnTb_L2_30_5 d1bar_L3 vcn ctp_L2_30 0 NSYN W=10u L=1u
MnTa_L2_30_5 dpre_L3_17 vcn ctn_L2_30 0 NSYN W=10u L=1u
MpTb_L2_30_5 d1bar_L3 gp_3_17_9 ctn_L2_30 0 NSYN W=10u L=1u
MpTa_L2_30_6 dpre_L3_27 gp_3_27_9 ctp_L2_30 0 NSYN W=10u L=1u
MnTb_L2_30_6 d1bar_L3 vcn ctp_L2_30 0 NSYN W=10u L=1u
MnTa_L2_30_6 dpre_L3_27 vcn ctn_L2_30 0 NSYN W=10u L=1u
MpTb_L2_30_6 d1bar_L3 gp_3_27_9 ctn_L2_30 0 NSYN W=10u L=1u
MpTa_L2_30_7 dpre_L3_33 gp_3_33_12 ctp_L2_30 0 NSYN W=10u L=1u
MnTb_L2_30_7 d1bar_L3 vcn ctp_L2_30 0 NSYN W=10u L=1u
MnTa_L2_30_7 dpre_L3_33 vcn ctn_L2_30 0 NSYN W=10u L=1u
MpTb_L2_30_7 d1bar_L3 gp_3_33_12 ctn_L2_30 0 NSYN W=10u L=1u
MpTa_L2_30_8 dpre_L3_40 gp_3_40_11 ctp_L2_30 0 NSYN W=10u L=1u
MnTb_L2_30_8 d1bar_L3 vcn ctp_L2_30 0 NSYN W=10u L=1u
MnTa_L2_30_8 dpre_L3_40 vcn ctn_L2_30 0 NSYN W=10u L=1u
MpTb_L2_30_8 d1bar_L3 gp_3_40_11 ctn_L2_30 0 NSYN W=10u L=1u
MpTa_L2_30_9 dpre_L3_42 gp_3_42_11 ctp_L2_30 0 NSYN W=10u L=1u
MnTb_L2_30_9 d1bar_L3 vcn ctp_L2_30 0 NSYN W=10u L=1u
MnTa_L2_30_9 dpre_L3_42 vcn ctn_L2_30 0 NSYN W=10u L=1u
MpTb_L2_30_9 d1bar_L3 gp_3_42_11 ctn_L2_30 0 NSYN W=10u L=1u
MpTa_L2_30_10 dpre_L3_43 gp_3_43_11 ctp_L2_30 0 NSYN W=10u L=1u
MnTb_L2_30_10 d1bar_L3 vcn ctp_L2_30 0 NSYN W=10u L=1u
MnTa_L2_30_10 dpre_L3_43 vcn ctn_L2_30 0 NSYN W=10u L=1u
MpTb_L2_30_10 d1bar_L3 gp_3_43_11 ctn_L2_30 0 NSYN W=10u L=1u
MpTa_L2_30_11 dpre_L3_46 gp_3_46_10 ctp_L2_30 0 NSYN W=10u L=1u
MnTb_L2_30_11 d1bar_L3 vcn ctp_L2_30 0 NSYN W=10u L=1u
MnTa_L2_30_11 dpre_L3_46 vcn ctn_L2_30 0 NSYN W=10u L=1u
MpTb_L2_30_11 d1bar_L3 gp_3_46_10 ctn_L2_30 0 NSYN W=10u L=1u
Msa_bk_L2_30 ctn_L2_30 ctn_L2_30 0 0 NMIR W=20u L=1u
Msb_bk_L2_30 dpre_L2_30 ctn_L2_30 0 0 NMIR W=20u L=1u
Msc_bk_L2_30 ctp_L2_30 ctp_L2_30 0 0 NMIR W=20u L=1u
Msd_bk_L2_30 dpf_bk_L2_30 ctp_L2_30 0 0 NMIR W=20u L=1u
Mse_bk_L2_30 dpf_bk_L2_30 dpf_bk_L2_30 vdd vdd PMIR W=60u L=1u
Msf_bk_L2_30 dpre_L2_30 dpf_bk_L2_30 vdd vdd PMIR W=60u L=1u
R_bk_L2_30 dpre_L2_30 vrefd 16000.0
MpTa_L2_31_0 dpre_L3_0 gp_3_0_11 ctp_L2_31 0 NSYN W=10u L=1u
MnTb_L2_31_0 d1bar_L3 vcn ctp_L2_31 0 NSYN W=10u L=1u
MnTa_L2_31_0 dpre_L3_0 vcn ctn_L2_31 0 NSYN W=10u L=1u
MpTb_L2_31_0 d1bar_L3 gp_3_0_11 ctn_L2_31 0 NSYN W=10u L=1u
MpTa_L2_31_1 dpre_L3_3 gp_3_3_6 ctp_L2_31 0 NSYN W=10u L=1u
MnTb_L2_31_1 d1bar_L3 vcn ctp_L2_31 0 NSYN W=10u L=1u
MnTa_L2_31_1 dpre_L3_3 vcn ctn_L2_31 0 NSYN W=10u L=1u
MpTb_L2_31_1 d1bar_L3 gp_3_3_6 ctn_L2_31 0 NSYN W=10u L=1u
MpTa_L2_31_2 dpre_L3_14 gp_3_14_10 ctp_L2_31 0 NSYN W=10u L=1u
MnTb_L2_31_2 d1bar_L3 vcn ctp_L2_31 0 NSYN W=10u L=1u
MnTa_L2_31_2 dpre_L3_14 vcn ctn_L2_31 0 NSYN W=10u L=1u
MpTb_L2_31_2 d1bar_L3 gp_3_14_10 ctn_L2_31 0 NSYN W=10u L=1u
MpTa_L2_31_3 dpre_L3_15 gp_3_15_10 ctp_L2_31 0 NSYN W=10u L=1u
MnTb_L2_31_3 d1bar_L3 vcn ctp_L2_31 0 NSYN W=10u L=1u
MnTa_L2_31_3 dpre_L3_15 vcn ctn_L2_31 0 NSYN W=10u L=1u
MpTb_L2_31_3 d1bar_L3 gp_3_15_10 ctn_L2_31 0 NSYN W=10u L=1u
MpTa_L2_31_4 dpre_L3_16 gp_3_16_8 ctp_L2_31 0 NSYN W=10u L=1u
MnTb_L2_31_4 d1bar_L3 vcn ctp_L2_31 0 NSYN W=10u L=1u
MnTa_L2_31_4 dpre_L3_16 vcn ctn_L2_31 0 NSYN W=10u L=1u
MpTb_L2_31_4 d1bar_L3 gp_3_16_8 ctn_L2_31 0 NSYN W=10u L=1u
MpTa_L2_31_5 dpre_L3_19 gp_3_19_9 ctp_L2_31 0 NSYN W=10u L=1u
MnTb_L2_31_5 d1bar_L3 vcn ctp_L2_31 0 NSYN W=10u L=1u
MnTa_L2_31_5 dpre_L3_19 vcn ctn_L2_31 0 NSYN W=10u L=1u
MpTb_L2_31_5 d1bar_L3 gp_3_19_9 ctn_L2_31 0 NSYN W=10u L=1u
MpTa_L2_31_6 dpre_L3_21 gp_3_21_10 ctp_L2_31 0 NSYN W=10u L=1u
MnTb_L2_31_6 d1bar_L3 vcn ctp_L2_31 0 NSYN W=10u L=1u
MnTa_L2_31_6 dpre_L3_21 vcn ctn_L2_31 0 NSYN W=10u L=1u
MpTb_L2_31_6 d1bar_L3 gp_3_21_10 ctn_L2_31 0 NSYN W=10u L=1u
MpTa_L2_31_7 dpre_L3_22 gp_3_22_11 ctp_L2_31 0 NSYN W=10u L=1u
MnTb_L2_31_7 d1bar_L3 vcn ctp_L2_31 0 NSYN W=10u L=1u
MnTa_L2_31_7 dpre_L3_22 vcn ctn_L2_31 0 NSYN W=10u L=1u
MpTb_L2_31_7 d1bar_L3 gp_3_22_11 ctn_L2_31 0 NSYN W=10u L=1u
MpTa_L2_31_8 dpre_L3_27 gp_3_27_10 ctp_L2_31 0 NSYN W=10u L=1u
MnTb_L2_31_8 d1bar_L3 vcn ctp_L2_31 0 NSYN W=10u L=1u
MnTa_L2_31_8 dpre_L3_27 vcn ctn_L2_31 0 NSYN W=10u L=1u
MpTb_L2_31_8 d1bar_L3 gp_3_27_10 ctn_L2_31 0 NSYN W=10u L=1u
MpTa_L2_31_9 dpre_L3_28 gp_3_28_9 ctp_L2_31 0 NSYN W=10u L=1u
MnTb_L2_31_9 d1bar_L3 vcn ctp_L2_31 0 NSYN W=10u L=1u
MnTa_L2_31_9 dpre_L3_28 vcn ctn_L2_31 0 NSYN W=10u L=1u
MpTb_L2_31_9 d1bar_L3 gp_3_28_9 ctn_L2_31 0 NSYN W=10u L=1u
MpTa_L2_31_10 dpre_L3_34 gp_3_34_10 ctp_L2_31 0 NSYN W=10u L=1u
MnTb_L2_31_10 d1bar_L3 vcn ctp_L2_31 0 NSYN W=10u L=1u
MnTa_L2_31_10 dpre_L3_34 vcn ctn_L2_31 0 NSYN W=10u L=1u
MpTb_L2_31_10 d1bar_L3 gp_3_34_10 ctn_L2_31 0 NSYN W=10u L=1u
MpTa_L2_31_11 dpre_L3_36 gp_3_36_9 ctp_L2_31 0 NSYN W=10u L=1u
MnTb_L2_31_11 d1bar_L3 vcn ctp_L2_31 0 NSYN W=10u L=1u
MnTa_L2_31_11 dpre_L3_36 vcn ctn_L2_31 0 NSYN W=10u L=1u
MpTb_L2_31_11 d1bar_L3 gp_3_36_9 ctn_L2_31 0 NSYN W=10u L=1u
MpTa_L2_31_12 dpre_L3_42 gp_3_42_12 ctp_L2_31 0 NSYN W=10u L=1u
MnTb_L2_31_12 d1bar_L3 vcn ctp_L2_31 0 NSYN W=10u L=1u
MnTa_L2_31_12 dpre_L3_42 vcn ctn_L2_31 0 NSYN W=10u L=1u
MpTb_L2_31_12 d1bar_L3 gp_3_42_12 ctn_L2_31 0 NSYN W=10u L=1u
MpTa_L2_31_13 dpre_L3_47 gp_3_47_9 ctp_L2_31 0 NSYN W=10u L=1u
MnTb_L2_31_13 d1bar_L3 vcn ctp_L2_31 0 NSYN W=10u L=1u
MnTa_L2_31_13 dpre_L3_47 vcn ctn_L2_31 0 NSYN W=10u L=1u
MpTb_L2_31_13 d1bar_L3 gp_3_47_9 ctn_L2_31 0 NSYN W=10u L=1u
Msa_bk_L2_31 ctn_L2_31 ctn_L2_31 0 0 NMIR W=20u L=1u
Msb_bk_L2_31 dpre_L2_31 ctn_L2_31 0 0 NMIR W=20u L=1u
Msc_bk_L2_31 ctp_L2_31 ctp_L2_31 0 0 NMIR W=20u L=1u
Msd_bk_L2_31 dpf_bk_L2_31 ctp_L2_31 0 0 NMIR W=20u L=1u
Mse_bk_L2_31 dpf_bk_L2_31 dpf_bk_L2_31 vdd vdd PMIR W=60u L=1u
Msf_bk_L2_31 dpre_L2_31 dpf_bk_L2_31 vdd vdd PMIR W=60u L=1u
R_bk_L2_31 dpre_L2_31 vrefd 16000.0
MpTa_L2_32_0 dpre_L3_1 gp_3_1_9 ctp_L2_32 0 NSYN W=10u L=1u
MnTb_L2_32_0 d1bar_L3 vcn ctp_L2_32 0 NSYN W=10u L=1u
MnTa_L2_32_0 dpre_L3_1 vcn ctn_L2_32 0 NSYN W=10u L=1u
MpTb_L2_32_0 d1bar_L3 gp_3_1_9 ctn_L2_32 0 NSYN W=10u L=1u
MpTa_L2_32_1 dpre_L3_2 gp_3_2_7 ctp_L2_32 0 NSYN W=10u L=1u
MnTb_L2_32_1 d1bar_L3 vcn ctp_L2_32 0 NSYN W=10u L=1u
MnTa_L2_32_1 dpre_L3_2 vcn ctn_L2_32 0 NSYN W=10u L=1u
MpTb_L2_32_1 d1bar_L3 gp_3_2_7 ctn_L2_32 0 NSYN W=10u L=1u
MpTa_L2_32_2 dpre_L3_3 gp_3_3_7 ctp_L2_32 0 NSYN W=10u L=1u
MnTb_L2_32_2 d1bar_L3 vcn ctp_L2_32 0 NSYN W=10u L=1u
MnTa_L2_32_2 dpre_L3_3 vcn ctn_L2_32 0 NSYN W=10u L=1u
MpTb_L2_32_2 d1bar_L3 gp_3_3_7 ctn_L2_32 0 NSYN W=10u L=1u
MpTa_L2_32_3 dpre_L3_9 gp_3_9_9 ctp_L2_32 0 NSYN W=10u L=1u
MnTb_L2_32_3 d1bar_L3 vcn ctp_L2_32 0 NSYN W=10u L=1u
MnTa_L2_32_3 dpre_L3_9 vcn ctn_L2_32 0 NSYN W=10u L=1u
MpTb_L2_32_3 d1bar_L3 gp_3_9_9 ctn_L2_32 0 NSYN W=10u L=1u
MpTa_L2_32_4 dpre_L3_13 gp_3_13_11 ctp_L2_32 0 NSYN W=10u L=1u
MnTb_L2_32_4 d1bar_L3 vcn ctp_L2_32 0 NSYN W=10u L=1u
MnTa_L2_32_4 dpre_L3_13 vcn ctn_L2_32 0 NSYN W=10u L=1u
MpTb_L2_32_4 d1bar_L3 gp_3_13_11 ctn_L2_32 0 NSYN W=10u L=1u
MpTa_L2_32_5 dpre_L3_19 gp_3_19_10 ctp_L2_32 0 NSYN W=10u L=1u
MnTb_L2_32_5 d1bar_L3 vcn ctp_L2_32 0 NSYN W=10u L=1u
MnTa_L2_32_5 dpre_L3_19 vcn ctn_L2_32 0 NSYN W=10u L=1u
MpTb_L2_32_5 d1bar_L3 gp_3_19_10 ctn_L2_32 0 NSYN W=10u L=1u
MpTa_L2_32_6 dpre_L3_20 gp_3_20_11 ctp_L2_32 0 NSYN W=10u L=1u
MnTb_L2_32_6 d1bar_L3 vcn ctp_L2_32 0 NSYN W=10u L=1u
MnTa_L2_32_6 dpre_L3_20 vcn ctn_L2_32 0 NSYN W=10u L=1u
MpTb_L2_32_6 d1bar_L3 gp_3_20_11 ctn_L2_32 0 NSYN W=10u L=1u
MpTa_L2_32_7 dpre_L3_26 gp_3_26_11 ctp_L2_32 0 NSYN W=10u L=1u
MnTb_L2_32_7 d1bar_L3 vcn ctp_L2_32 0 NSYN W=10u L=1u
MnTa_L2_32_7 dpre_L3_26 vcn ctn_L2_32 0 NSYN W=10u L=1u
MpTb_L2_32_7 d1bar_L3 gp_3_26_11 ctn_L2_32 0 NSYN W=10u L=1u
MpTa_L2_32_8 dpre_L3_27 gp_3_27_11 ctp_L2_32 0 NSYN W=10u L=1u
MnTb_L2_32_8 d1bar_L3 vcn ctp_L2_32 0 NSYN W=10u L=1u
MnTa_L2_32_8 dpre_L3_27 vcn ctn_L2_32 0 NSYN W=10u L=1u
MpTb_L2_32_8 d1bar_L3 gp_3_27_11 ctn_L2_32 0 NSYN W=10u L=1u
MpTa_L2_32_9 dpre_L3_30 gp_3_30_10 ctp_L2_32 0 NSYN W=10u L=1u
MnTb_L2_32_9 d1bar_L3 vcn ctp_L2_32 0 NSYN W=10u L=1u
MnTa_L2_32_9 dpre_L3_30 vcn ctn_L2_32 0 NSYN W=10u L=1u
MpTb_L2_32_9 d1bar_L3 gp_3_30_10 ctn_L2_32 0 NSYN W=10u L=1u
MpTa_L2_32_10 dpre_L3_34 gp_3_34_11 ctp_L2_32 0 NSYN W=10u L=1u
MnTb_L2_32_10 d1bar_L3 vcn ctp_L2_32 0 NSYN W=10u L=1u
MnTa_L2_32_10 dpre_L3_34 vcn ctn_L2_32 0 NSYN W=10u L=1u
MpTb_L2_32_10 d1bar_L3 gp_3_34_11 ctn_L2_32 0 NSYN W=10u L=1u
MpTa_L2_32_11 dpre_L3_35 gp_3_35_7 ctp_L2_32 0 NSYN W=10u L=1u
MnTb_L2_32_11 d1bar_L3 vcn ctp_L2_32 0 NSYN W=10u L=1u
MnTa_L2_32_11 dpre_L3_35 vcn ctn_L2_32 0 NSYN W=10u L=1u
MpTb_L2_32_11 d1bar_L3 gp_3_35_7 ctn_L2_32 0 NSYN W=10u L=1u
MpTa_L2_32_12 dpre_L3_39 gp_3_39_7 ctp_L2_32 0 NSYN W=10u L=1u
MnTb_L2_32_12 d1bar_L3 vcn ctp_L2_32 0 NSYN W=10u L=1u
MnTa_L2_32_12 dpre_L3_39 vcn ctn_L2_32 0 NSYN W=10u L=1u
MpTb_L2_32_12 d1bar_L3 gp_3_39_7 ctn_L2_32 0 NSYN W=10u L=1u
MpTa_L2_32_13 dpre_L3_44 gp_3_44_8 ctp_L2_32 0 NSYN W=10u L=1u
MnTb_L2_32_13 d1bar_L3 vcn ctp_L2_32 0 NSYN W=10u L=1u
MnTa_L2_32_13 dpre_L3_44 vcn ctn_L2_32 0 NSYN W=10u L=1u
MpTb_L2_32_13 d1bar_L3 gp_3_44_8 ctn_L2_32 0 NSYN W=10u L=1u
MpTa_L2_32_14 dpre_L3_47 gp_3_47_10 ctp_L2_32 0 NSYN W=10u L=1u
MnTb_L2_32_14 d1bar_L3 vcn ctp_L2_32 0 NSYN W=10u L=1u
MnTa_L2_32_14 dpre_L3_47 vcn ctn_L2_32 0 NSYN W=10u L=1u
MpTb_L2_32_14 d1bar_L3 gp_3_47_10 ctn_L2_32 0 NSYN W=10u L=1u
Msa_bk_L2_32 ctn_L2_32 ctn_L2_32 0 0 NMIR W=20u L=1u
Msb_bk_L2_32 dpre_L2_32 ctn_L2_32 0 0 NMIR W=20u L=1u
Msc_bk_L2_32 ctp_L2_32 ctp_L2_32 0 0 NMIR W=20u L=1u
Msd_bk_L2_32 dpf_bk_L2_32 ctp_L2_32 0 0 NMIR W=20u L=1u
Mse_bk_L2_32 dpf_bk_L2_32 dpf_bk_L2_32 vdd vdd PMIR W=60u L=1u
Msf_bk_L2_32 dpre_L2_32 dpf_bk_L2_32 vdd vdd PMIR W=60u L=1u
R_bk_L2_32 dpre_L2_32 vrefd 16000.0
MpTa_L2_33_0 dpre_L3_2 gp_3_2_8 ctp_L2_33 0 NSYN W=10u L=1u
MnTb_L2_33_0 d1bar_L3 vcn ctp_L2_33 0 NSYN W=10u L=1u
MnTa_L2_33_0 dpre_L3_2 vcn ctn_L2_33 0 NSYN W=10u L=1u
MpTb_L2_33_0 d1bar_L3 gp_3_2_8 ctn_L2_33 0 NSYN W=10u L=1u
MpTa_L2_33_1 dpre_L3_6 gp_3_6_12 ctp_L2_33 0 NSYN W=10u L=1u
MnTb_L2_33_1 d1bar_L3 vcn ctp_L2_33 0 NSYN W=10u L=1u
MnTa_L2_33_1 dpre_L3_6 vcn ctn_L2_33 0 NSYN W=10u L=1u
MpTb_L2_33_1 d1bar_L3 gp_3_6_12 ctn_L2_33 0 NSYN W=10u L=1u
MpTa_L2_33_2 dpre_L3_10 gp_3_10_9 ctp_L2_33 0 NSYN W=10u L=1u
MnTb_L2_33_2 d1bar_L3 vcn ctp_L2_33 0 NSYN W=10u L=1u
MnTa_L2_33_2 dpre_L3_10 vcn ctn_L2_33 0 NSYN W=10u L=1u
MpTb_L2_33_2 d1bar_L3 gp_3_10_9 ctn_L2_33 0 NSYN W=10u L=1u
MpTa_L2_33_3 dpre_L3_12 gp_3_12_8 ctp_L2_33 0 NSYN W=10u L=1u
MnTb_L2_33_3 d1bar_L3 vcn ctp_L2_33 0 NSYN W=10u L=1u
MnTa_L2_33_3 dpre_L3_12 vcn ctn_L2_33 0 NSYN W=10u L=1u
MpTb_L2_33_3 d1bar_L3 gp_3_12_8 ctn_L2_33 0 NSYN W=10u L=1u
MpTa_L2_33_4 dpre_L3_14 gp_3_14_11 ctp_L2_33 0 NSYN W=10u L=1u
MnTb_L2_33_4 d1bar_L3 vcn ctp_L2_33 0 NSYN W=10u L=1u
MnTa_L2_33_4 dpre_L3_14 vcn ctn_L2_33 0 NSYN W=10u L=1u
MpTb_L2_33_4 d1bar_L3 gp_3_14_11 ctn_L2_33 0 NSYN W=10u L=1u
MpTa_L2_33_5 dpre_L3_20 gp_3_20_12 ctp_L2_33 0 NSYN W=10u L=1u
MnTb_L2_33_5 d1bar_L3 vcn ctp_L2_33 0 NSYN W=10u L=1u
MnTa_L2_33_5 dpre_L3_20 vcn ctn_L2_33 0 NSYN W=10u L=1u
MpTb_L2_33_5 d1bar_L3 gp_3_20_12 ctn_L2_33 0 NSYN W=10u L=1u
MpTa_L2_33_6 dpre_L3_21 gp_3_21_11 ctp_L2_33 0 NSYN W=10u L=1u
MnTb_L2_33_6 d1bar_L3 vcn ctp_L2_33 0 NSYN W=10u L=1u
MnTa_L2_33_6 dpre_L3_21 vcn ctn_L2_33 0 NSYN W=10u L=1u
MpTb_L2_33_6 d1bar_L3 gp_3_21_11 ctn_L2_33 0 NSYN W=10u L=1u
MpTa_L2_33_7 dpre_L3_23 gp_3_23_8 ctp_L2_33 0 NSYN W=10u L=1u
MnTb_L2_33_7 d1bar_L3 vcn ctp_L2_33 0 NSYN W=10u L=1u
MnTa_L2_33_7 dpre_L3_23 vcn ctn_L2_33 0 NSYN W=10u L=1u
MpTb_L2_33_7 d1bar_L3 gp_3_23_8 ctn_L2_33 0 NSYN W=10u L=1u
MpTa_L2_33_8 dpre_L3_27 gp_3_27_12 ctp_L2_33 0 NSYN W=10u L=1u
MnTb_L2_33_8 d1bar_L3 vcn ctp_L2_33 0 NSYN W=10u L=1u
MnTa_L2_33_8 dpre_L3_27 vcn ctn_L2_33 0 NSYN W=10u L=1u
MpTb_L2_33_8 d1bar_L3 gp_3_27_12 ctn_L2_33 0 NSYN W=10u L=1u
MpTa_L2_33_9 dpre_L3_29 gp_3_29_10 ctp_L2_33 0 NSYN W=10u L=1u
MnTb_L2_33_9 d1bar_L3 vcn ctp_L2_33 0 NSYN W=10u L=1u
MnTa_L2_33_9 dpre_L3_29 vcn ctn_L2_33 0 NSYN W=10u L=1u
MpTb_L2_33_9 d1bar_L3 gp_3_29_10 ctn_L2_33 0 NSYN W=10u L=1u
MpTa_L2_33_10 dpre_L3_31 gp_3_31_9 ctp_L2_33 0 NSYN W=10u L=1u
MnTb_L2_33_10 d1bar_L3 vcn ctp_L2_33 0 NSYN W=10u L=1u
MnTa_L2_33_10 dpre_L3_31 vcn ctn_L2_33 0 NSYN W=10u L=1u
MpTb_L2_33_10 d1bar_L3 gp_3_31_9 ctn_L2_33 0 NSYN W=10u L=1u
MpTa_L2_33_11 dpre_L3_36 gp_3_36_10 ctp_L2_33 0 NSYN W=10u L=1u
MnTb_L2_33_11 d1bar_L3 vcn ctp_L2_33 0 NSYN W=10u L=1u
MnTa_L2_33_11 dpre_L3_36 vcn ctn_L2_33 0 NSYN W=10u L=1u
MpTb_L2_33_11 d1bar_L3 gp_3_36_10 ctn_L2_33 0 NSYN W=10u L=1u
MpTa_L2_33_12 dpre_L3_38 gp_3_38_9 ctp_L2_33 0 NSYN W=10u L=1u
MnTb_L2_33_12 d1bar_L3 vcn ctp_L2_33 0 NSYN W=10u L=1u
MnTa_L2_33_12 dpre_L3_38 vcn ctn_L2_33 0 NSYN W=10u L=1u
MpTb_L2_33_12 d1bar_L3 gp_3_38_9 ctn_L2_33 0 NSYN W=10u L=1u
MpTa_L2_33_13 dpre_L3_41 gp_3_41_10 ctp_L2_33 0 NSYN W=10u L=1u
MnTb_L2_33_13 d1bar_L3 vcn ctp_L2_33 0 NSYN W=10u L=1u
MnTa_L2_33_13 dpre_L3_41 vcn ctn_L2_33 0 NSYN W=10u L=1u
MpTb_L2_33_13 d1bar_L3 gp_3_41_10 ctn_L2_33 0 NSYN W=10u L=1u
MpTa_L2_33_14 dpre_L3_44 gp_3_44_9 ctp_L2_33 0 NSYN W=10u L=1u
MnTb_L2_33_14 d1bar_L3 vcn ctp_L2_33 0 NSYN W=10u L=1u
MnTa_L2_33_14 dpre_L3_44 vcn ctn_L2_33 0 NSYN W=10u L=1u
MpTb_L2_33_14 d1bar_L3 gp_3_44_9 ctn_L2_33 0 NSYN W=10u L=1u
MpTa_L2_33_15 dpre_L3_47 gp_3_47_11 ctp_L2_33 0 NSYN W=10u L=1u
MnTb_L2_33_15 d1bar_L3 vcn ctp_L2_33 0 NSYN W=10u L=1u
MnTa_L2_33_15 dpre_L3_47 vcn ctn_L2_33 0 NSYN W=10u L=1u
MpTb_L2_33_15 d1bar_L3 gp_3_47_11 ctn_L2_33 0 NSYN W=10u L=1u
Msa_bk_L2_33 ctn_L2_33 ctn_L2_33 0 0 NMIR W=20u L=1u
Msb_bk_L2_33 dpre_L2_33 ctn_L2_33 0 0 NMIR W=20u L=1u
Msc_bk_L2_33 ctp_L2_33 ctp_L2_33 0 0 NMIR W=20u L=1u
Msd_bk_L2_33 dpf_bk_L2_33 ctp_L2_33 0 0 NMIR W=20u L=1u
Mse_bk_L2_33 dpf_bk_L2_33 dpf_bk_L2_33 vdd vdd PMIR W=60u L=1u
Msf_bk_L2_33 dpre_L2_33 dpf_bk_L2_33 vdd vdd PMIR W=60u L=1u
R_bk_L2_33 dpre_L2_33 vrefd 16000.0
MpTa_L2_34_0 dpre_L3_1 gp_3_1_10 ctp_L2_34 0 NSYN W=10u L=1u
MnTb_L2_34_0 d1bar_L3 vcn ctp_L2_34 0 NSYN W=10u L=1u
MnTa_L2_34_0 dpre_L3_1 vcn ctn_L2_34 0 NSYN W=10u L=1u
MpTb_L2_34_0 d1bar_L3 gp_3_1_10 ctn_L2_34 0 NSYN W=10u L=1u
MpTa_L2_34_1 dpre_L3_3 gp_3_3_8 ctp_L2_34 0 NSYN W=10u L=1u
MnTb_L2_34_1 d1bar_L3 vcn ctp_L2_34 0 NSYN W=10u L=1u
MnTa_L2_34_1 dpre_L3_3 vcn ctn_L2_34 0 NSYN W=10u L=1u
MpTb_L2_34_1 d1bar_L3 gp_3_3_8 ctn_L2_34 0 NSYN W=10u L=1u
MpTa_L2_34_2 dpre_L3_5 gp_3_5_9 ctp_L2_34 0 NSYN W=10u L=1u
MnTb_L2_34_2 d1bar_L3 vcn ctp_L2_34 0 NSYN W=10u L=1u
MnTa_L2_34_2 dpre_L3_5 vcn ctn_L2_34 0 NSYN W=10u L=1u
MpTb_L2_34_2 d1bar_L3 gp_3_5_9 ctn_L2_34 0 NSYN W=10u L=1u
MpTa_L2_34_3 dpre_L3_7 gp_3_7_12 ctp_L2_34 0 NSYN W=10u L=1u
MnTb_L2_34_3 d1bar_L3 vcn ctp_L2_34 0 NSYN W=10u L=1u
MnTa_L2_34_3 dpre_L3_7 vcn ctn_L2_34 0 NSYN W=10u L=1u
MpTb_L2_34_3 d1bar_L3 gp_3_7_12 ctn_L2_34 0 NSYN W=10u L=1u
MpTa_L2_34_4 dpre_L3_10 gp_3_10_10 ctp_L2_34 0 NSYN W=10u L=1u
MnTb_L2_34_4 d1bar_L3 vcn ctp_L2_34 0 NSYN W=10u L=1u
MnTa_L2_34_4 dpre_L3_10 vcn ctn_L2_34 0 NSYN W=10u L=1u
MpTb_L2_34_4 d1bar_L3 gp_3_10_10 ctn_L2_34 0 NSYN W=10u L=1u
MpTa_L2_34_5 dpre_L3_12 gp_3_12_9 ctp_L2_34 0 NSYN W=10u L=1u
MnTb_L2_34_5 d1bar_L3 vcn ctp_L2_34 0 NSYN W=10u L=1u
MnTa_L2_34_5 dpre_L3_12 vcn ctn_L2_34 0 NSYN W=10u L=1u
MpTb_L2_34_5 d1bar_L3 gp_3_12_9 ctn_L2_34 0 NSYN W=10u L=1u
MpTa_L2_34_6 dpre_L3_14 gp_3_14_12 ctp_L2_34 0 NSYN W=10u L=1u
MnTb_L2_34_6 d1bar_L3 vcn ctp_L2_34 0 NSYN W=10u L=1u
MnTa_L2_34_6 dpre_L3_14 vcn ctn_L2_34 0 NSYN W=10u L=1u
MpTb_L2_34_6 d1bar_L3 gp_3_14_12 ctn_L2_34 0 NSYN W=10u L=1u
MpTa_L2_34_7 dpre_L3_17 gp_3_17_10 ctp_L2_34 0 NSYN W=10u L=1u
MnTb_L2_34_7 d1bar_L3 vcn ctp_L2_34 0 NSYN W=10u L=1u
MnTa_L2_34_7 dpre_L3_17 vcn ctn_L2_34 0 NSYN W=10u L=1u
MpTb_L2_34_7 d1bar_L3 gp_3_17_10 ctn_L2_34 0 NSYN W=10u L=1u
MpTa_L2_34_8 dpre_L3_18 gp_3_18_9 ctp_L2_34 0 NSYN W=10u L=1u
MnTb_L2_34_8 d1bar_L3 vcn ctp_L2_34 0 NSYN W=10u L=1u
MnTa_L2_34_8 dpre_L3_18 vcn ctn_L2_34 0 NSYN W=10u L=1u
MpTb_L2_34_8 d1bar_L3 gp_3_18_9 ctn_L2_34 0 NSYN W=10u L=1u
MpTa_L2_34_9 dpre_L3_27 gp_3_27_13 ctp_L2_34 0 NSYN W=10u L=1u
MnTb_L2_34_9 d1bar_L3 vcn ctp_L2_34 0 NSYN W=10u L=1u
MnTa_L2_34_9 dpre_L3_27 vcn ctn_L2_34 0 NSYN W=10u L=1u
MpTb_L2_34_9 d1bar_L3 gp_3_27_13 ctn_L2_34 0 NSYN W=10u L=1u
MpTa_L2_34_10 dpre_L3_28 gp_3_28_10 ctp_L2_34 0 NSYN W=10u L=1u
MnTb_L2_34_10 d1bar_L3 vcn ctp_L2_34 0 NSYN W=10u L=1u
MnTa_L2_34_10 dpre_L3_28 vcn ctn_L2_34 0 NSYN W=10u L=1u
MpTb_L2_34_10 d1bar_L3 gp_3_28_10 ctn_L2_34 0 NSYN W=10u L=1u
MpTa_L2_34_11 dpre_L3_30 gp_3_30_11 ctp_L2_34 0 NSYN W=10u L=1u
MnTb_L2_34_11 d1bar_L3 vcn ctp_L2_34 0 NSYN W=10u L=1u
MnTa_L2_34_11 dpre_L3_30 vcn ctn_L2_34 0 NSYN W=10u L=1u
MpTb_L2_34_11 d1bar_L3 gp_3_30_11 ctn_L2_34 0 NSYN W=10u L=1u
MpTa_L2_34_12 dpre_L3_31 gp_3_31_10 ctp_L2_34 0 NSYN W=10u L=1u
MnTb_L2_34_12 d1bar_L3 vcn ctp_L2_34 0 NSYN W=10u L=1u
MnTa_L2_34_12 dpre_L3_31 vcn ctn_L2_34 0 NSYN W=10u L=1u
MpTb_L2_34_12 d1bar_L3 gp_3_31_10 ctn_L2_34 0 NSYN W=10u L=1u
MpTa_L2_34_13 dpre_L3_35 gp_3_35_8 ctp_L2_34 0 NSYN W=10u L=1u
MnTb_L2_34_13 d1bar_L3 vcn ctp_L2_34 0 NSYN W=10u L=1u
MnTa_L2_34_13 dpre_L3_35 vcn ctn_L2_34 0 NSYN W=10u L=1u
MpTb_L2_34_13 d1bar_L3 gp_3_35_8 ctn_L2_34 0 NSYN W=10u L=1u
MpTa_L2_34_14 dpre_L3_42 gp_3_42_13 ctp_L2_34 0 NSYN W=10u L=1u
MnTb_L2_34_14 d1bar_L3 vcn ctp_L2_34 0 NSYN W=10u L=1u
MnTa_L2_34_14 dpre_L3_42 vcn ctn_L2_34 0 NSYN W=10u L=1u
MpTb_L2_34_14 d1bar_L3 gp_3_42_13 ctn_L2_34 0 NSYN W=10u L=1u
Msa_bk_L2_34 ctn_L2_34 ctn_L2_34 0 0 NMIR W=20u L=1u
Msb_bk_L2_34 dpre_L2_34 ctn_L2_34 0 0 NMIR W=20u L=1u
Msc_bk_L2_34 ctp_L2_34 ctp_L2_34 0 0 NMIR W=20u L=1u
Msd_bk_L2_34 dpf_bk_L2_34 ctp_L2_34 0 0 NMIR W=20u L=1u
Mse_bk_L2_34 dpf_bk_L2_34 dpf_bk_L2_34 vdd vdd PMIR W=60u L=1u
Msf_bk_L2_34 dpre_L2_34 dpf_bk_L2_34 vdd vdd PMIR W=60u L=1u
R_bk_L2_34 dpre_L2_34 vrefd 16000.0
MpTa_L2_35_0 dpre_L3_2 gp_3_2_9 ctp_L2_35 0 NSYN W=10u L=1u
MnTb_L2_35_0 d1bar_L3 vcn ctp_L2_35 0 NSYN W=10u L=1u
MnTa_L2_35_0 dpre_L3_2 vcn ctn_L2_35 0 NSYN W=10u L=1u
MpTb_L2_35_0 d1bar_L3 gp_3_2_9 ctn_L2_35 0 NSYN W=10u L=1u
MpTa_L2_35_1 dpre_L3_5 gp_3_5_10 ctp_L2_35 0 NSYN W=10u L=1u
MnTb_L2_35_1 d1bar_L3 vcn ctp_L2_35 0 NSYN W=10u L=1u
MnTa_L2_35_1 dpre_L3_5 vcn ctn_L2_35 0 NSYN W=10u L=1u
MpTb_L2_35_1 d1bar_L3 gp_3_5_10 ctn_L2_35 0 NSYN W=10u L=1u
MpTa_L2_35_2 dpre_L3_8 gp_3_8_11 ctp_L2_35 0 NSYN W=10u L=1u
MnTb_L2_35_2 d1bar_L3 vcn ctp_L2_35 0 NSYN W=10u L=1u
MnTa_L2_35_2 dpre_L3_8 vcn ctn_L2_35 0 NSYN W=10u L=1u
MpTb_L2_35_2 d1bar_L3 gp_3_8_11 ctn_L2_35 0 NSYN W=10u L=1u
MpTa_L2_35_3 dpre_L3_12 gp_3_12_10 ctp_L2_35 0 NSYN W=10u L=1u
MnTb_L2_35_3 d1bar_L3 vcn ctp_L2_35 0 NSYN W=10u L=1u
MnTa_L2_35_3 dpre_L3_12 vcn ctn_L2_35 0 NSYN W=10u L=1u
MpTb_L2_35_3 d1bar_L3 gp_3_12_10 ctn_L2_35 0 NSYN W=10u L=1u
MpTa_L2_35_4 dpre_L3_15 gp_3_15_11 ctp_L2_35 0 NSYN W=10u L=1u
MnTb_L2_35_4 d1bar_L3 vcn ctp_L2_35 0 NSYN W=10u L=1u
MnTa_L2_35_4 dpre_L3_15 vcn ctn_L2_35 0 NSYN W=10u L=1u
MpTb_L2_35_4 d1bar_L3 gp_3_15_11 ctn_L2_35 0 NSYN W=10u L=1u
MpTa_L2_35_5 dpre_L3_16 gp_3_16_9 ctp_L2_35 0 NSYN W=10u L=1u
MnTb_L2_35_5 d1bar_L3 vcn ctp_L2_35 0 NSYN W=10u L=1u
MnTa_L2_35_5 dpre_L3_16 vcn ctn_L2_35 0 NSYN W=10u L=1u
MpTb_L2_35_5 d1bar_L3 gp_3_16_9 ctn_L2_35 0 NSYN W=10u L=1u
MpTa_L2_35_6 dpre_L3_17 gp_3_17_11 ctp_L2_35 0 NSYN W=10u L=1u
MnTb_L2_35_6 d1bar_L3 vcn ctp_L2_35 0 NSYN W=10u L=1u
MnTa_L2_35_6 dpre_L3_17 vcn ctn_L2_35 0 NSYN W=10u L=1u
MpTb_L2_35_6 d1bar_L3 gp_3_17_11 ctn_L2_35 0 NSYN W=10u L=1u
MpTa_L2_35_7 dpre_L3_22 gp_3_22_12 ctp_L2_35 0 NSYN W=10u L=1u
MnTb_L2_35_7 d1bar_L3 vcn ctp_L2_35 0 NSYN W=10u L=1u
MnTa_L2_35_7 dpre_L3_22 vcn ctn_L2_35 0 NSYN W=10u L=1u
MpTb_L2_35_7 d1bar_L3 gp_3_22_12 ctn_L2_35 0 NSYN W=10u L=1u
MpTa_L2_35_8 dpre_L3_23 gp_3_23_9 ctp_L2_35 0 NSYN W=10u L=1u
MnTb_L2_35_8 d1bar_L3 vcn ctp_L2_35 0 NSYN W=10u L=1u
MnTa_L2_35_8 dpre_L3_23 vcn ctn_L2_35 0 NSYN W=10u L=1u
MpTb_L2_35_8 d1bar_L3 gp_3_23_9 ctn_L2_35 0 NSYN W=10u L=1u
MpTa_L2_35_9 dpre_L3_24 gp_3_24_7 ctp_L2_35 0 NSYN W=10u L=1u
MnTb_L2_35_9 d1bar_L3 vcn ctp_L2_35 0 NSYN W=10u L=1u
MnTa_L2_35_9 dpre_L3_24 vcn ctn_L2_35 0 NSYN W=10u L=1u
MpTb_L2_35_9 d1bar_L3 gp_3_24_7 ctn_L2_35 0 NSYN W=10u L=1u
MpTa_L2_35_10 dpre_L3_26 gp_3_26_12 ctp_L2_35 0 NSYN W=10u L=1u
MnTb_L2_35_10 d1bar_L3 vcn ctp_L2_35 0 NSYN W=10u L=1u
MnTa_L2_35_10 dpre_L3_26 vcn ctn_L2_35 0 NSYN W=10u L=1u
MpTb_L2_35_10 d1bar_L3 gp_3_26_12 ctn_L2_35 0 NSYN W=10u L=1u
MpTa_L2_35_11 dpre_L3_28 gp_3_28_11 ctp_L2_35 0 NSYN W=10u L=1u
MnTb_L2_35_11 d1bar_L3 vcn ctp_L2_35 0 NSYN W=10u L=1u
MnTa_L2_35_11 dpre_L3_28 vcn ctn_L2_35 0 NSYN W=10u L=1u
MpTb_L2_35_11 d1bar_L3 gp_3_28_11 ctn_L2_35 0 NSYN W=10u L=1u
MpTa_L2_35_12 dpre_L3_31 gp_3_31_11 ctp_L2_35 0 NSYN W=10u L=1u
MnTb_L2_35_12 d1bar_L3 vcn ctp_L2_35 0 NSYN W=10u L=1u
MnTa_L2_35_12 dpre_L3_31 vcn ctn_L2_35 0 NSYN W=10u L=1u
MpTb_L2_35_12 d1bar_L3 gp_3_31_11 ctn_L2_35 0 NSYN W=10u L=1u
MpTa_L2_35_13 dpre_L3_35 gp_3_35_9 ctp_L2_35 0 NSYN W=10u L=1u
MnTb_L2_35_13 d1bar_L3 vcn ctp_L2_35 0 NSYN W=10u L=1u
MnTa_L2_35_13 dpre_L3_35 vcn ctn_L2_35 0 NSYN W=10u L=1u
MpTb_L2_35_13 d1bar_L3 gp_3_35_9 ctn_L2_35 0 NSYN W=10u L=1u
MpTa_L2_35_14 dpre_L3_38 gp_3_38_10 ctp_L2_35 0 NSYN W=10u L=1u
MnTb_L2_35_14 d1bar_L3 vcn ctp_L2_35 0 NSYN W=10u L=1u
MnTa_L2_35_14 dpre_L3_38 vcn ctn_L2_35 0 NSYN W=10u L=1u
MpTb_L2_35_14 d1bar_L3 gp_3_38_10 ctn_L2_35 0 NSYN W=10u L=1u
MpTa_L2_35_15 dpre_L3_41 gp_3_41_11 ctp_L2_35 0 NSYN W=10u L=1u
MnTb_L2_35_15 d1bar_L3 vcn ctp_L2_35 0 NSYN W=10u L=1u
MnTa_L2_35_15 dpre_L3_41 vcn ctn_L2_35 0 NSYN W=10u L=1u
MpTb_L2_35_15 d1bar_L3 gp_3_41_11 ctn_L2_35 0 NSYN W=10u L=1u
MpTa_L2_35_16 dpre_L3_43 gp_3_43_12 ctp_L2_35 0 NSYN W=10u L=1u
MnTb_L2_35_16 d1bar_L3 vcn ctp_L2_35 0 NSYN W=10u L=1u
MnTa_L2_35_16 dpre_L3_43 vcn ctn_L2_35 0 NSYN W=10u L=1u
MpTb_L2_35_16 d1bar_L3 gp_3_43_12 ctn_L2_35 0 NSYN W=10u L=1u
MpTa_L2_35_17 dpre_L3_44 gp_3_44_10 ctp_L2_35 0 NSYN W=10u L=1u
MnTb_L2_35_17 d1bar_L3 vcn ctp_L2_35 0 NSYN W=10u L=1u
MnTa_L2_35_17 dpre_L3_44 vcn ctn_L2_35 0 NSYN W=10u L=1u
MpTb_L2_35_17 d1bar_L3 gp_3_44_10 ctn_L2_35 0 NSYN W=10u L=1u
MpTa_L2_35_18 dpre_L3_45 gp_3_45_9 ctp_L2_35 0 NSYN W=10u L=1u
MnTb_L2_35_18 d1bar_L3 vcn ctp_L2_35 0 NSYN W=10u L=1u
MnTa_L2_35_18 dpre_L3_45 vcn ctn_L2_35 0 NSYN W=10u L=1u
MpTb_L2_35_18 d1bar_L3 gp_3_45_9 ctn_L2_35 0 NSYN W=10u L=1u
MpTa_L2_35_19 dpre_L3_46 gp_3_46_11 ctp_L2_35 0 NSYN W=10u L=1u
MnTb_L2_35_19 d1bar_L3 vcn ctp_L2_35 0 NSYN W=10u L=1u
MnTa_L2_35_19 dpre_L3_46 vcn ctn_L2_35 0 NSYN W=10u L=1u
MpTb_L2_35_19 d1bar_L3 gp_3_46_11 ctn_L2_35 0 NSYN W=10u L=1u
Msa_bk_L2_35 ctn_L2_35 ctn_L2_35 0 0 NMIR W=20u L=1u
Msb_bk_L2_35 dpre_L2_35 ctn_L2_35 0 0 NMIR W=20u L=1u
Msc_bk_L2_35 ctp_L2_35 ctp_L2_35 0 0 NMIR W=20u L=1u
Msd_bk_L2_35 dpf_bk_L2_35 ctp_L2_35 0 0 NMIR W=20u L=1u
Mse_bk_L2_35 dpf_bk_L2_35 dpf_bk_L2_35 vdd vdd PMIR W=60u L=1u
Msf_bk_L2_35 dpre_L2_35 dpf_bk_L2_35 vdd vdd PMIR W=60u L=1u
R_bk_L2_35 dpre_L2_35 vrefd 16000.0
MpTa_L2_36_0 dpre_L3_2 gp_3_2_10 ctp_L2_36 0 NSYN W=10u L=1u
MnTb_L2_36_0 d1bar_L3 vcn ctp_L2_36 0 NSYN W=10u L=1u
MnTa_L2_36_0 dpre_L3_2 vcn ctn_L2_36 0 NSYN W=10u L=1u
MpTb_L2_36_0 d1bar_L3 gp_3_2_10 ctn_L2_36 0 NSYN W=10u L=1u
MpTa_L2_36_1 dpre_L3_3 gp_3_3_9 ctp_L2_36 0 NSYN W=10u L=1u
MnTb_L2_36_1 d1bar_L3 vcn ctp_L2_36 0 NSYN W=10u L=1u
MnTa_L2_36_1 dpre_L3_3 vcn ctn_L2_36 0 NSYN W=10u L=1u
MpTb_L2_36_1 d1bar_L3 gp_3_3_9 ctn_L2_36 0 NSYN W=10u L=1u
MpTa_L2_36_2 dpre_L3_12 gp_3_12_11 ctp_L2_36 0 NSYN W=10u L=1u
MnTb_L2_36_2 d1bar_L3 vcn ctp_L2_36 0 NSYN W=10u L=1u
MnTa_L2_36_2 dpre_L3_12 vcn ctn_L2_36 0 NSYN W=10u L=1u
MpTb_L2_36_2 d1bar_L3 gp_3_12_11 ctn_L2_36 0 NSYN W=10u L=1u
MpTa_L2_36_3 dpre_L3_15 gp_3_15_12 ctp_L2_36 0 NSYN W=10u L=1u
MnTb_L2_36_3 d1bar_L3 vcn ctp_L2_36 0 NSYN W=10u L=1u
MnTa_L2_36_3 dpre_L3_15 vcn ctn_L2_36 0 NSYN W=10u L=1u
MpTb_L2_36_3 d1bar_L3 gp_3_15_12 ctn_L2_36 0 NSYN W=10u L=1u
MpTa_L2_36_4 dpre_L3_16 gp_3_16_10 ctp_L2_36 0 NSYN W=10u L=1u
MnTb_L2_36_4 d1bar_L3 vcn ctp_L2_36 0 NSYN W=10u L=1u
MnTa_L2_36_4 dpre_L3_16 vcn ctn_L2_36 0 NSYN W=10u L=1u
MpTb_L2_36_4 d1bar_L3 gp_3_16_10 ctn_L2_36 0 NSYN W=10u L=1u
MpTa_L2_36_5 dpre_L3_18 gp_3_18_10 ctp_L2_36 0 NSYN W=10u L=1u
MnTb_L2_36_5 d1bar_L3 vcn ctp_L2_36 0 NSYN W=10u L=1u
MnTa_L2_36_5 dpre_L3_18 vcn ctn_L2_36 0 NSYN W=10u L=1u
MpTb_L2_36_5 d1bar_L3 gp_3_18_10 ctn_L2_36 0 NSYN W=10u L=1u
MpTa_L2_36_6 dpre_L3_21 gp_3_21_12 ctp_L2_36 0 NSYN W=10u L=1u
MnTb_L2_36_6 d1bar_L3 vcn ctp_L2_36 0 NSYN W=10u L=1u
MnTa_L2_36_6 dpre_L3_21 vcn ctn_L2_36 0 NSYN W=10u L=1u
MpTb_L2_36_6 d1bar_L3 gp_3_21_12 ctn_L2_36 0 NSYN W=10u L=1u
MpTa_L2_36_7 dpre_L3_24 gp_3_24_8 ctp_L2_36 0 NSYN W=10u L=1u
MnTb_L2_36_7 d1bar_L3 vcn ctp_L2_36 0 NSYN W=10u L=1u
MnTa_L2_36_7 dpre_L3_24 vcn ctn_L2_36 0 NSYN W=10u L=1u
MpTb_L2_36_7 d1bar_L3 gp_3_24_8 ctn_L2_36 0 NSYN W=10u L=1u
MpTa_L2_36_8 dpre_L3_28 gp_3_28_12 ctp_L2_36 0 NSYN W=10u L=1u
MnTb_L2_36_8 d1bar_L3 vcn ctp_L2_36 0 NSYN W=10u L=1u
MnTa_L2_36_8 dpre_L3_28 vcn ctn_L2_36 0 NSYN W=10u L=1u
MpTb_L2_36_8 d1bar_L3 gp_3_28_12 ctn_L2_36 0 NSYN W=10u L=1u
MpTa_L2_36_9 dpre_L3_29 gp_3_29_11 ctp_L2_36 0 NSYN W=10u L=1u
MnTb_L2_36_9 d1bar_L3 vcn ctp_L2_36 0 NSYN W=10u L=1u
MnTa_L2_36_9 dpre_L3_29 vcn ctn_L2_36 0 NSYN W=10u L=1u
MpTb_L2_36_9 d1bar_L3 gp_3_29_11 ctn_L2_36 0 NSYN W=10u L=1u
MpTa_L2_36_10 dpre_L3_35 gp_3_35_10 ctp_L2_36 0 NSYN W=10u L=1u
MnTb_L2_36_10 d1bar_L3 vcn ctp_L2_36 0 NSYN W=10u L=1u
MnTa_L2_36_10 dpre_L3_35 vcn ctn_L2_36 0 NSYN W=10u L=1u
MpTb_L2_36_10 d1bar_L3 gp_3_35_10 ctn_L2_36 0 NSYN W=10u L=1u
MpTa_L2_36_11 dpre_L3_44 gp_3_44_11 ctp_L2_36 0 NSYN W=10u L=1u
MnTb_L2_36_11 d1bar_L3 vcn ctp_L2_36 0 NSYN W=10u L=1u
MnTa_L2_36_11 dpre_L3_44 vcn ctn_L2_36 0 NSYN W=10u L=1u
MpTb_L2_36_11 d1bar_L3 gp_3_44_11 ctn_L2_36 0 NSYN W=10u L=1u
MpTa_L2_36_12 dpre_L3_45 gp_3_45_10 ctp_L2_36 0 NSYN W=10u L=1u
MnTb_L2_36_12 d1bar_L3 vcn ctp_L2_36 0 NSYN W=10u L=1u
MnTa_L2_36_12 dpre_L3_45 vcn ctn_L2_36 0 NSYN W=10u L=1u
MpTb_L2_36_12 d1bar_L3 gp_3_45_10 ctn_L2_36 0 NSYN W=10u L=1u
MpTa_L2_36_13 dpre_L3_46 gp_3_46_12 ctp_L2_36 0 NSYN W=10u L=1u
MnTb_L2_36_13 d1bar_L3 vcn ctp_L2_36 0 NSYN W=10u L=1u
MnTa_L2_36_13 dpre_L3_46 vcn ctn_L2_36 0 NSYN W=10u L=1u
MpTb_L2_36_13 d1bar_L3 gp_3_46_12 ctn_L2_36 0 NSYN W=10u L=1u
MpTa_L2_36_14 dpre_L3_47 gp_3_47_12 ctp_L2_36 0 NSYN W=10u L=1u
MnTb_L2_36_14 d1bar_L3 vcn ctp_L2_36 0 NSYN W=10u L=1u
MnTa_L2_36_14 dpre_L3_47 vcn ctn_L2_36 0 NSYN W=10u L=1u
MpTb_L2_36_14 d1bar_L3 gp_3_47_12 ctn_L2_36 0 NSYN W=10u L=1u
Msa_bk_L2_36 ctn_L2_36 ctn_L2_36 0 0 NMIR W=20u L=1u
Msb_bk_L2_36 dpre_L2_36 ctn_L2_36 0 0 NMIR W=20u L=1u
Msc_bk_L2_36 ctp_L2_36 ctp_L2_36 0 0 NMIR W=20u L=1u
Msd_bk_L2_36 dpf_bk_L2_36 ctp_L2_36 0 0 NMIR W=20u L=1u
Mse_bk_L2_36 dpf_bk_L2_36 dpf_bk_L2_36 vdd vdd PMIR W=60u L=1u
Msf_bk_L2_36 dpre_L2_36 dpf_bk_L2_36 vdd vdd PMIR W=60u L=1u
R_bk_L2_36 dpre_L2_36 vrefd 16000.0
MpTa_L2_37_0 dpre_L3_0 gp_3_0_12 ctp_L2_37 0 NSYN W=10u L=1u
MnTb_L2_37_0 d1bar_L3 vcn ctp_L2_37 0 NSYN W=10u L=1u
MnTa_L2_37_0 dpre_L3_0 vcn ctn_L2_37 0 NSYN W=10u L=1u
MpTb_L2_37_0 d1bar_L3 gp_3_0_12 ctn_L2_37 0 NSYN W=10u L=1u
MpTa_L2_37_1 dpre_L3_8 gp_3_8_12 ctp_L2_37 0 NSYN W=10u L=1u
MnTb_L2_37_1 d1bar_L3 vcn ctp_L2_37 0 NSYN W=10u L=1u
MnTa_L2_37_1 dpre_L3_8 vcn ctn_L2_37 0 NSYN W=10u L=1u
MpTb_L2_37_1 d1bar_L3 gp_3_8_12 ctn_L2_37 0 NSYN W=10u L=1u
MpTa_L2_37_2 dpre_L3_9 gp_3_9_10 ctp_L2_37 0 NSYN W=10u L=1u
MnTb_L2_37_2 d1bar_L3 vcn ctp_L2_37 0 NSYN W=10u L=1u
MnTa_L2_37_2 dpre_L3_9 vcn ctn_L2_37 0 NSYN W=10u L=1u
MpTb_L2_37_2 d1bar_L3 gp_3_9_10 ctn_L2_37 0 NSYN W=10u L=1u
MpTa_L2_37_3 dpre_L3_10 gp_3_10_11 ctp_L2_37 0 NSYN W=10u L=1u
MnTb_L2_37_3 d1bar_L3 vcn ctp_L2_37 0 NSYN W=10u L=1u
MnTa_L2_37_3 dpre_L3_10 vcn ctn_L2_37 0 NSYN W=10u L=1u
MpTb_L2_37_3 d1bar_L3 gp_3_10_11 ctn_L2_37 0 NSYN W=10u L=1u
MpTa_L2_37_4 dpre_L3_14 gp_3_14_13 ctp_L2_37 0 NSYN W=10u L=1u
MnTb_L2_37_4 d1bar_L3 vcn ctp_L2_37 0 NSYN W=10u L=1u
MnTa_L2_37_4 dpre_L3_14 vcn ctn_L2_37 0 NSYN W=10u L=1u
MpTb_L2_37_4 d1bar_L3 gp_3_14_13 ctn_L2_37 0 NSYN W=10u L=1u
MpTa_L2_37_5 dpre_L3_18 gp_3_18_11 ctp_L2_37 0 NSYN W=10u L=1u
MnTb_L2_37_5 d1bar_L3 vcn ctp_L2_37 0 NSYN W=10u L=1u
MnTa_L2_37_5 dpre_L3_18 vcn ctn_L2_37 0 NSYN W=10u L=1u
MpTb_L2_37_5 d1bar_L3 gp_3_18_11 ctn_L2_37 0 NSYN W=10u L=1u
MpTa_L2_37_6 dpre_L3_22 gp_3_22_13 ctp_L2_37 0 NSYN W=10u L=1u
MnTb_L2_37_6 d1bar_L3 vcn ctp_L2_37 0 NSYN W=10u L=1u
MnTa_L2_37_6 dpre_L3_22 vcn ctn_L2_37 0 NSYN W=10u L=1u
MpTb_L2_37_6 d1bar_L3 gp_3_22_13 ctn_L2_37 0 NSYN W=10u L=1u
MpTa_L2_37_7 dpre_L3_24 gp_3_24_9 ctp_L2_37 0 NSYN W=10u L=1u
MnTb_L2_37_7 d1bar_L3 vcn ctp_L2_37 0 NSYN W=10u L=1u
MnTa_L2_37_7 dpre_L3_24 vcn ctn_L2_37 0 NSYN W=10u L=1u
MpTb_L2_37_7 d1bar_L3 gp_3_24_9 ctn_L2_37 0 NSYN W=10u L=1u
MpTa_L2_37_8 dpre_L3_26 gp_3_26_13 ctp_L2_37 0 NSYN W=10u L=1u
MnTb_L2_37_8 d1bar_L3 vcn ctp_L2_37 0 NSYN W=10u L=1u
MnTa_L2_37_8 dpre_L3_26 vcn ctn_L2_37 0 NSYN W=10u L=1u
MpTb_L2_37_8 d1bar_L3 gp_3_26_13 ctn_L2_37 0 NSYN W=10u L=1u
MpTa_L2_37_9 dpre_L3_28 gp_3_28_13 ctp_L2_37 0 NSYN W=10u L=1u
MnTb_L2_37_9 d1bar_L3 vcn ctp_L2_37 0 NSYN W=10u L=1u
MnTa_L2_37_9 dpre_L3_28 vcn ctn_L2_37 0 NSYN W=10u L=1u
MpTb_L2_37_9 d1bar_L3 gp_3_28_13 ctn_L2_37 0 NSYN W=10u L=1u
MpTa_L2_37_10 dpre_L3_29 gp_3_29_12 ctp_L2_37 0 NSYN W=10u L=1u
MnTb_L2_37_10 d1bar_L3 vcn ctp_L2_37 0 NSYN W=10u L=1u
MnTa_L2_37_10 dpre_L3_29 vcn ctn_L2_37 0 NSYN W=10u L=1u
MpTb_L2_37_10 d1bar_L3 gp_3_29_12 ctn_L2_37 0 NSYN W=10u L=1u
MpTa_L2_37_11 dpre_L3_36 gp_3_36_11 ctp_L2_37 0 NSYN W=10u L=1u
MnTb_L2_37_11 d1bar_L3 vcn ctp_L2_37 0 NSYN W=10u L=1u
MnTa_L2_37_11 dpre_L3_36 vcn ctn_L2_37 0 NSYN W=10u L=1u
MpTb_L2_37_11 d1bar_L3 gp_3_36_11 ctn_L2_37 0 NSYN W=10u L=1u
MpTa_L2_37_12 dpre_L3_39 gp_3_39_8 ctp_L2_37 0 NSYN W=10u L=1u
MnTb_L2_37_12 d1bar_L3 vcn ctp_L2_37 0 NSYN W=10u L=1u
MnTa_L2_37_12 dpre_L3_39 vcn ctn_L2_37 0 NSYN W=10u L=1u
MpTb_L2_37_12 d1bar_L3 gp_3_39_8 ctn_L2_37 0 NSYN W=10u L=1u
MpTa_L2_37_13 dpre_L3_40 gp_3_40_12 ctp_L2_37 0 NSYN W=10u L=1u
MnTb_L2_37_13 d1bar_L3 vcn ctp_L2_37 0 NSYN W=10u L=1u
MnTa_L2_37_13 dpre_L3_40 vcn ctn_L2_37 0 NSYN W=10u L=1u
MpTb_L2_37_13 d1bar_L3 gp_3_40_12 ctn_L2_37 0 NSYN W=10u L=1u
MpTa_L2_37_14 dpre_L3_41 gp_3_41_12 ctp_L2_37 0 NSYN W=10u L=1u
MnTb_L2_37_14 d1bar_L3 vcn ctp_L2_37 0 NSYN W=10u L=1u
MnTa_L2_37_14 dpre_L3_41 vcn ctn_L2_37 0 NSYN W=10u L=1u
MpTb_L2_37_14 d1bar_L3 gp_3_41_12 ctn_L2_37 0 NSYN W=10u L=1u
MpTa_L2_37_15 dpre_L3_43 gp_3_43_13 ctp_L2_37 0 NSYN W=10u L=1u
MnTb_L2_37_15 d1bar_L3 vcn ctp_L2_37 0 NSYN W=10u L=1u
MnTa_L2_37_15 dpre_L3_43 vcn ctn_L2_37 0 NSYN W=10u L=1u
MpTb_L2_37_15 d1bar_L3 gp_3_43_13 ctn_L2_37 0 NSYN W=10u L=1u
MpTa_L2_37_16 dpre_L3_47 gp_3_47_13 ctp_L2_37 0 NSYN W=10u L=1u
MnTb_L2_37_16 d1bar_L3 vcn ctp_L2_37 0 NSYN W=10u L=1u
MnTa_L2_37_16 dpre_L3_47 vcn ctn_L2_37 0 NSYN W=10u L=1u
MpTb_L2_37_16 d1bar_L3 gp_3_47_13 ctn_L2_37 0 NSYN W=10u L=1u
Msa_bk_L2_37 ctn_L2_37 ctn_L2_37 0 0 NMIR W=20u L=1u
Msb_bk_L2_37 dpre_L2_37 ctn_L2_37 0 0 NMIR W=20u L=1u
Msc_bk_L2_37 ctp_L2_37 ctp_L2_37 0 0 NMIR W=20u L=1u
Msd_bk_L2_37 dpf_bk_L2_37 ctp_L2_37 0 0 NMIR W=20u L=1u
Mse_bk_L2_37 dpf_bk_L2_37 dpf_bk_L2_37 vdd vdd PMIR W=60u L=1u
Msf_bk_L2_37 dpre_L2_37 dpf_bk_L2_37 vdd vdd PMIR W=60u L=1u
R_bk_L2_37 dpre_L2_37 vrefd 16000.0
MpTa_L2_38_0 dpre_L3_1 gp_3_1_11 ctp_L2_38 0 NSYN W=10u L=1u
MnTb_L2_38_0 d1bar_L3 vcn ctp_L2_38 0 NSYN W=10u L=1u
MnTa_L2_38_0 dpre_L3_1 vcn ctn_L2_38 0 NSYN W=10u L=1u
MpTb_L2_38_0 d1bar_L3 gp_3_1_11 ctn_L2_38 0 NSYN W=10u L=1u
MpTa_L2_38_1 dpre_L3_4 gp_3_4_12 ctp_L2_38 0 NSYN W=10u L=1u
MnTb_L2_38_1 d1bar_L3 vcn ctp_L2_38 0 NSYN W=10u L=1u
MnTa_L2_38_1 dpre_L3_4 vcn ctn_L2_38 0 NSYN W=10u L=1u
MpTb_L2_38_1 d1bar_L3 gp_3_4_12 ctn_L2_38 0 NSYN W=10u L=1u
MpTa_L2_38_2 dpre_L3_5 gp_3_5_11 ctp_L2_38 0 NSYN W=10u L=1u
MnTb_L2_38_2 d1bar_L3 vcn ctp_L2_38 0 NSYN W=10u L=1u
MnTa_L2_38_2 dpre_L3_5 vcn ctn_L2_38 0 NSYN W=10u L=1u
MpTb_L2_38_2 d1bar_L3 gp_3_5_11 ctn_L2_38 0 NSYN W=10u L=1u
MpTa_L2_38_3 dpre_L3_12 gp_3_12_12 ctp_L2_38 0 NSYN W=10u L=1u
MnTb_L2_38_3 d1bar_L3 vcn ctp_L2_38 0 NSYN W=10u L=1u
MnTa_L2_38_3 dpre_L3_12 vcn ctn_L2_38 0 NSYN W=10u L=1u
MpTb_L2_38_3 d1bar_L3 gp_3_12_12 ctn_L2_38 0 NSYN W=10u L=1u
MpTa_L2_38_4 dpre_L3_13 gp_3_13_12 ctp_L2_38 0 NSYN W=10u L=1u
MnTb_L2_38_4 d1bar_L3 vcn ctp_L2_38 0 NSYN W=10u L=1u
MnTa_L2_38_4 dpre_L3_13 vcn ctn_L2_38 0 NSYN W=10u L=1u
MpTb_L2_38_4 d1bar_L3 gp_3_13_12 ctn_L2_38 0 NSYN W=10u L=1u
MpTa_L2_38_5 dpre_L3_17 gp_3_17_12 ctp_L2_38 0 NSYN W=10u L=1u
MnTb_L2_38_5 d1bar_L3 vcn ctp_L2_38 0 NSYN W=10u L=1u
MnTa_L2_38_5 dpre_L3_17 vcn ctn_L2_38 0 NSYN W=10u L=1u
MpTb_L2_38_5 d1bar_L3 gp_3_17_12 ctn_L2_38 0 NSYN W=10u L=1u
MpTa_L2_38_6 dpre_L3_18 gp_3_18_12 ctp_L2_38 0 NSYN W=10u L=1u
MnTb_L2_38_6 d1bar_L3 vcn ctp_L2_38 0 NSYN W=10u L=1u
MnTa_L2_38_6 dpre_L3_18 vcn ctn_L2_38 0 NSYN W=10u L=1u
MpTb_L2_38_6 d1bar_L3 gp_3_18_12 ctn_L2_38 0 NSYN W=10u L=1u
MpTa_L2_38_7 dpre_L3_20 gp_3_20_13 ctp_L2_38 0 NSYN W=10u L=1u
MnTb_L2_38_7 d1bar_L3 vcn ctp_L2_38 0 NSYN W=10u L=1u
MnTa_L2_38_7 dpre_L3_20 vcn ctn_L2_38 0 NSYN W=10u L=1u
MpTb_L2_38_7 d1bar_L3 gp_3_20_13 ctn_L2_38 0 NSYN W=10u L=1u
MpTa_L2_38_8 dpre_L3_21 gp_3_21_13 ctp_L2_38 0 NSYN W=10u L=1u
MnTb_L2_38_8 d1bar_L3 vcn ctp_L2_38 0 NSYN W=10u L=1u
MnTa_L2_38_8 dpre_L3_21 vcn ctn_L2_38 0 NSYN W=10u L=1u
MpTb_L2_38_8 d1bar_L3 gp_3_21_13 ctn_L2_38 0 NSYN W=10u L=1u
MpTa_L2_38_9 dpre_L3_25 gp_3_25_11 ctp_L2_38 0 NSYN W=10u L=1u
MnTb_L2_38_9 d1bar_L3 vcn ctp_L2_38 0 NSYN W=10u L=1u
MnTa_L2_38_9 dpre_L3_25 vcn ctn_L2_38 0 NSYN W=10u L=1u
MpTb_L2_38_9 d1bar_L3 gp_3_25_11 ctn_L2_38 0 NSYN W=10u L=1u
MpTa_L2_38_10 dpre_L3_31 gp_3_31_12 ctp_L2_38 0 NSYN W=10u L=1u
MnTb_L2_38_10 d1bar_L3 vcn ctp_L2_38 0 NSYN W=10u L=1u
MnTa_L2_38_10 dpre_L3_31 vcn ctn_L2_38 0 NSYN W=10u L=1u
MpTb_L2_38_10 d1bar_L3 gp_3_31_12 ctn_L2_38 0 NSYN W=10u L=1u
MpTa_L2_38_11 dpre_L3_34 gp_3_34_12 ctp_L2_38 0 NSYN W=10u L=1u
MnTb_L2_38_11 d1bar_L3 vcn ctp_L2_38 0 NSYN W=10u L=1u
MnTa_L2_38_11 dpre_L3_34 vcn ctn_L2_38 0 NSYN W=10u L=1u
MpTb_L2_38_11 d1bar_L3 gp_3_34_12 ctn_L2_38 0 NSYN W=10u L=1u
MpTa_L2_38_12 dpre_L3_35 gp_3_35_11 ctp_L2_38 0 NSYN W=10u L=1u
MnTb_L2_38_12 d1bar_L3 vcn ctp_L2_38 0 NSYN W=10u L=1u
MnTa_L2_38_12 dpre_L3_35 vcn ctn_L2_38 0 NSYN W=10u L=1u
MpTb_L2_38_12 d1bar_L3 gp_3_35_11 ctn_L2_38 0 NSYN W=10u L=1u
MpTa_L2_38_13 dpre_L3_37 gp_3_37_11 ctp_L2_38 0 NSYN W=10u L=1u
MnTb_L2_38_13 d1bar_L3 vcn ctp_L2_38 0 NSYN W=10u L=1u
MnTa_L2_38_13 dpre_L3_37 vcn ctn_L2_38 0 NSYN W=10u L=1u
MpTb_L2_38_13 d1bar_L3 gp_3_37_11 ctn_L2_38 0 NSYN W=10u L=1u
MpTa_L2_38_14 dpre_L3_39 gp_3_39_9 ctp_L2_38 0 NSYN W=10u L=1u
MnTb_L2_38_14 d1bar_L3 vcn ctp_L2_38 0 NSYN W=10u L=1u
MnTa_L2_38_14 dpre_L3_39 vcn ctn_L2_38 0 NSYN W=10u L=1u
MpTb_L2_38_14 d1bar_L3 gp_3_39_9 ctn_L2_38 0 NSYN W=10u L=1u
MpTa_L2_38_15 dpre_L3_40 gp_3_40_13 ctp_L2_38 0 NSYN W=10u L=1u
MnTb_L2_38_15 d1bar_L3 vcn ctp_L2_38 0 NSYN W=10u L=1u
MnTa_L2_38_15 dpre_L3_40 vcn ctn_L2_38 0 NSYN W=10u L=1u
MpTb_L2_38_15 d1bar_L3 gp_3_40_13 ctn_L2_38 0 NSYN W=10u L=1u
MpTa_L2_38_16 dpre_L3_41 gp_3_41_13 ctp_L2_38 0 NSYN W=10u L=1u
MnTb_L2_38_16 d1bar_L3 vcn ctp_L2_38 0 NSYN W=10u L=1u
MnTa_L2_38_16 dpre_L3_41 vcn ctn_L2_38 0 NSYN W=10u L=1u
MpTb_L2_38_16 d1bar_L3 gp_3_41_13 ctn_L2_38 0 NSYN W=10u L=1u
MpTa_L2_38_17 dpre_L3_46 gp_3_46_13 ctp_L2_38 0 NSYN W=10u L=1u
MnTb_L2_38_17 d1bar_L3 vcn ctp_L2_38 0 NSYN W=10u L=1u
MnTa_L2_38_17 dpre_L3_46 vcn ctn_L2_38 0 NSYN W=10u L=1u
MpTb_L2_38_17 d1bar_L3 gp_3_46_13 ctn_L2_38 0 NSYN W=10u L=1u
Msa_bk_L2_38 ctn_L2_38 ctn_L2_38 0 0 NMIR W=20u L=1u
Msb_bk_L2_38 dpre_L2_38 ctn_L2_38 0 0 NMIR W=20u L=1u
Msc_bk_L2_38 ctp_L2_38 ctp_L2_38 0 0 NMIR W=20u L=1u
Msd_bk_L2_38 dpf_bk_L2_38 ctp_L2_38 0 0 NMIR W=20u L=1u
Mse_bk_L2_38 dpf_bk_L2_38 dpf_bk_L2_38 vdd vdd PMIR W=60u L=1u
Msf_bk_L2_38 dpre_L2_38 dpf_bk_L2_38 vdd vdd PMIR W=60u L=1u
R_bk_L2_38 dpre_L2_38 vrefd 16000.0
MpTa_L2_39_0 dpre_L3_0 gp_3_0_13 ctp_L2_39 0 NSYN W=10u L=1u
MnTb_L2_39_0 d1bar_L3 vcn ctp_L2_39 0 NSYN W=10u L=1u
MnTa_L2_39_0 dpre_L3_0 vcn ctn_L2_39 0 NSYN W=10u L=1u
MpTb_L2_39_0 d1bar_L3 gp_3_0_13 ctn_L2_39 0 NSYN W=10u L=1u
MpTa_L2_39_1 dpre_L3_1 gp_3_1_12 ctp_L2_39 0 NSYN W=10u L=1u
MnTb_L2_39_1 d1bar_L3 vcn ctp_L2_39 0 NSYN W=10u L=1u
MnTa_L2_39_1 dpre_L3_1 vcn ctn_L2_39 0 NSYN W=10u L=1u
MpTb_L2_39_1 d1bar_L3 gp_3_1_12 ctn_L2_39 0 NSYN W=10u L=1u
MpTa_L2_39_2 dpre_L3_4 gp_3_4_13 ctp_L2_39 0 NSYN W=10u L=1u
MnTb_L2_39_2 d1bar_L3 vcn ctp_L2_39 0 NSYN W=10u L=1u
MnTa_L2_39_2 dpre_L3_4 vcn ctn_L2_39 0 NSYN W=10u L=1u
MpTb_L2_39_2 d1bar_L3 gp_3_4_13 ctn_L2_39 0 NSYN W=10u L=1u
MpTa_L2_39_3 dpre_L3_7 gp_3_7_13 ctp_L2_39 0 NSYN W=10u L=1u
MnTb_L2_39_3 d1bar_L3 vcn ctp_L2_39 0 NSYN W=10u L=1u
MnTa_L2_39_3 dpre_L3_7 vcn ctn_L2_39 0 NSYN W=10u L=1u
MpTb_L2_39_3 d1bar_L3 gp_3_7_13 ctn_L2_39 0 NSYN W=10u L=1u
MpTa_L2_39_4 dpre_L3_8 gp_3_8_13 ctp_L2_39 0 NSYN W=10u L=1u
MnTb_L2_39_4 d1bar_L3 vcn ctp_L2_39 0 NSYN W=10u L=1u
MnTa_L2_39_4 dpre_L3_8 vcn ctn_L2_39 0 NSYN W=10u L=1u
MpTb_L2_39_4 d1bar_L3 gp_3_8_13 ctn_L2_39 0 NSYN W=10u L=1u
MpTa_L2_39_5 dpre_L3_9 gp_3_9_11 ctp_L2_39 0 NSYN W=10u L=1u
MnTb_L2_39_5 d1bar_L3 vcn ctp_L2_39 0 NSYN W=10u L=1u
MnTa_L2_39_5 dpre_L3_9 vcn ctn_L2_39 0 NSYN W=10u L=1u
MpTb_L2_39_5 d1bar_L3 gp_3_9_11 ctn_L2_39 0 NSYN W=10u L=1u
MpTa_L2_39_6 dpre_L3_11 gp_3_11_11 ctp_L2_39 0 NSYN W=10u L=1u
MnTb_L2_39_6 d1bar_L3 vcn ctp_L2_39 0 NSYN W=10u L=1u
MnTa_L2_39_6 dpre_L3_11 vcn ctn_L2_39 0 NSYN W=10u L=1u
MpTb_L2_39_6 d1bar_L3 gp_3_11_11 ctn_L2_39 0 NSYN W=10u L=1u
MpTa_L2_39_7 dpre_L3_13 gp_3_13_13 ctp_L2_39 0 NSYN W=10u L=1u
MnTb_L2_39_7 d1bar_L3 vcn ctp_L2_39 0 NSYN W=10u L=1u
MnTa_L2_39_7 dpre_L3_13 vcn ctn_L2_39 0 NSYN W=10u L=1u
MpTb_L2_39_7 d1bar_L3 gp_3_13_13 ctn_L2_39 0 NSYN W=10u L=1u
MpTa_L2_39_8 dpre_L3_15 gp_3_15_13 ctp_L2_39 0 NSYN W=10u L=1u
MnTb_L2_39_8 d1bar_L3 vcn ctp_L2_39 0 NSYN W=10u L=1u
MnTa_L2_39_8 dpre_L3_15 vcn ctn_L2_39 0 NSYN W=10u L=1u
MpTb_L2_39_8 d1bar_L3 gp_3_15_13 ctn_L2_39 0 NSYN W=10u L=1u
MpTa_L2_39_9 dpre_L3_16 gp_3_16_11 ctp_L2_39 0 NSYN W=10u L=1u
MnTb_L2_39_9 d1bar_L3 vcn ctp_L2_39 0 NSYN W=10u L=1u
MnTa_L2_39_9 dpre_L3_16 vcn ctn_L2_39 0 NSYN W=10u L=1u
MpTb_L2_39_9 d1bar_L3 gp_3_16_11 ctn_L2_39 0 NSYN W=10u L=1u
MpTa_L2_39_10 dpre_L3_17 gp_3_17_13 ctp_L2_39 0 NSYN W=10u L=1u
MnTb_L2_39_10 d1bar_L3 vcn ctp_L2_39 0 NSYN W=10u L=1u
MnTa_L2_39_10 dpre_L3_17 vcn ctn_L2_39 0 NSYN W=10u L=1u
MpTb_L2_39_10 d1bar_L3 gp_3_17_13 ctn_L2_39 0 NSYN W=10u L=1u
MpTa_L2_39_11 dpre_L3_18 gp_3_18_13 ctp_L2_39 0 NSYN W=10u L=1u
MnTb_L2_39_11 d1bar_L3 vcn ctp_L2_39 0 NSYN W=10u L=1u
MnTa_L2_39_11 dpre_L3_18 vcn ctn_L2_39 0 NSYN W=10u L=1u
MpTb_L2_39_11 d1bar_L3 gp_3_18_13 ctn_L2_39 0 NSYN W=10u L=1u
MpTa_L2_39_12 dpre_L3_19 gp_3_19_11 ctp_L2_39 0 NSYN W=10u L=1u
MnTb_L2_39_12 d1bar_L3 vcn ctp_L2_39 0 NSYN W=10u L=1u
MnTa_L2_39_12 dpre_L3_19 vcn ctn_L2_39 0 NSYN W=10u L=1u
MpTb_L2_39_12 d1bar_L3 gp_3_19_11 ctn_L2_39 0 NSYN W=10u L=1u
MpTa_L2_39_13 dpre_L3_20 gp_3_20_14 ctp_L2_39 0 NSYN W=10u L=1u
MnTb_L2_39_13 d1bar_L3 vcn ctp_L2_39 0 NSYN W=10u L=1u
MnTa_L2_39_13 dpre_L3_20 vcn ctn_L2_39 0 NSYN W=10u L=1u
MpTb_L2_39_13 d1bar_L3 gp_3_20_14 ctn_L2_39 0 NSYN W=10u L=1u
MpTa_L2_39_14 dpre_L3_21 gp_3_21_14 ctp_L2_39 0 NSYN W=10u L=1u
MnTb_L2_39_14 d1bar_L3 vcn ctp_L2_39 0 NSYN W=10u L=1u
MnTa_L2_39_14 dpre_L3_21 vcn ctn_L2_39 0 NSYN W=10u L=1u
MpTb_L2_39_14 d1bar_L3 gp_3_21_14 ctn_L2_39 0 NSYN W=10u L=1u
MpTa_L2_39_15 dpre_L3_23 gp_3_23_10 ctp_L2_39 0 NSYN W=10u L=1u
MnTb_L2_39_15 d1bar_L3 vcn ctp_L2_39 0 NSYN W=10u L=1u
MnTa_L2_39_15 dpre_L3_23 vcn ctn_L2_39 0 NSYN W=10u L=1u
MpTb_L2_39_15 d1bar_L3 gp_3_23_10 ctn_L2_39 0 NSYN W=10u L=1u
MpTa_L2_39_16 dpre_L3_24 gp_3_24_10 ctp_L2_39 0 NSYN W=10u L=1u
MnTb_L2_39_16 d1bar_L3 vcn ctp_L2_39 0 NSYN W=10u L=1u
MnTa_L2_39_16 dpre_L3_24 vcn ctn_L2_39 0 NSYN W=10u L=1u
MpTb_L2_39_16 d1bar_L3 gp_3_24_10 ctn_L2_39 0 NSYN W=10u L=1u
MpTa_L2_39_17 dpre_L3_27 gp_3_27_14 ctp_L2_39 0 NSYN W=10u L=1u
MnTb_L2_39_17 d1bar_L3 vcn ctp_L2_39 0 NSYN W=10u L=1u
MnTa_L2_39_17 dpre_L3_27 vcn ctn_L2_39 0 NSYN W=10u L=1u
MpTb_L2_39_17 d1bar_L3 gp_3_27_14 ctn_L2_39 0 NSYN W=10u L=1u
MpTa_L2_39_18 dpre_L3_29 gp_3_29_13 ctp_L2_39 0 NSYN W=10u L=1u
MnTb_L2_39_18 d1bar_L3 vcn ctp_L2_39 0 NSYN W=10u L=1u
MnTa_L2_39_18 dpre_L3_29 vcn ctn_L2_39 0 NSYN W=10u L=1u
MpTb_L2_39_18 d1bar_L3 gp_3_29_13 ctn_L2_39 0 NSYN W=10u L=1u
MpTa_L2_39_19 dpre_L3_30 gp_3_30_12 ctp_L2_39 0 NSYN W=10u L=1u
MnTb_L2_39_19 d1bar_L3 vcn ctp_L2_39 0 NSYN W=10u L=1u
MnTa_L2_39_19 dpre_L3_30 vcn ctn_L2_39 0 NSYN W=10u L=1u
MpTb_L2_39_19 d1bar_L3 gp_3_30_12 ctn_L2_39 0 NSYN W=10u L=1u
MpTa_L2_39_20 dpre_L3_32 gp_3_32_12 ctp_L2_39 0 NSYN W=10u L=1u
MnTb_L2_39_20 d1bar_L3 vcn ctp_L2_39 0 NSYN W=10u L=1u
MnTa_L2_39_20 dpre_L3_32 vcn ctn_L2_39 0 NSYN W=10u L=1u
MpTb_L2_39_20 d1bar_L3 gp_3_32_12 ctn_L2_39 0 NSYN W=10u L=1u
MpTa_L2_39_21 dpre_L3_35 gp_3_35_12 ctp_L2_39 0 NSYN W=10u L=1u
MnTb_L2_39_21 d1bar_L3 vcn ctp_L2_39 0 NSYN W=10u L=1u
MnTa_L2_39_21 dpre_L3_35 vcn ctn_L2_39 0 NSYN W=10u L=1u
MpTb_L2_39_21 d1bar_L3 gp_3_35_12 ctn_L2_39 0 NSYN W=10u L=1u
MpTa_L2_39_22 dpre_L3_36 gp_3_36_12 ctp_L2_39 0 NSYN W=10u L=1u
MnTb_L2_39_22 d1bar_L3 vcn ctp_L2_39 0 NSYN W=10u L=1u
MnTa_L2_39_22 dpre_L3_36 vcn ctn_L2_39 0 NSYN W=10u L=1u
MpTb_L2_39_22 d1bar_L3 gp_3_36_12 ctn_L2_39 0 NSYN W=10u L=1u
MpTa_L2_39_23 dpre_L3_37 gp_3_37_12 ctp_L2_39 0 NSYN W=10u L=1u
MnTb_L2_39_23 d1bar_L3 vcn ctp_L2_39 0 NSYN W=10u L=1u
MnTa_L2_39_23 dpre_L3_37 vcn ctn_L2_39 0 NSYN W=10u L=1u
MpTb_L2_39_23 d1bar_L3 gp_3_37_12 ctn_L2_39 0 NSYN W=10u L=1u
MpTa_L2_39_24 dpre_L3_39 gp_3_39_10 ctp_L2_39 0 NSYN W=10u L=1u
MnTb_L2_39_24 d1bar_L3 vcn ctp_L2_39 0 NSYN W=10u L=1u
MnTa_L2_39_24 dpre_L3_39 vcn ctn_L2_39 0 NSYN W=10u L=1u
MpTb_L2_39_24 d1bar_L3 gp_3_39_10 ctn_L2_39 0 NSYN W=10u L=1u
MpTa_L2_39_25 dpre_L3_47 gp_3_47_14 ctp_L2_39 0 NSYN W=10u L=1u
MnTb_L2_39_25 d1bar_L3 vcn ctp_L2_39 0 NSYN W=10u L=1u
MnTa_L2_39_25 dpre_L3_47 vcn ctn_L2_39 0 NSYN W=10u L=1u
MpTb_L2_39_25 d1bar_L3 gp_3_47_14 ctn_L2_39 0 NSYN W=10u L=1u
Msa_bk_L2_39 ctn_L2_39 ctn_L2_39 0 0 NMIR W=20u L=1u
Msb_bk_L2_39 dpre_L2_39 ctn_L2_39 0 0 NMIR W=20u L=1u
Msc_bk_L2_39 ctp_L2_39 ctp_L2_39 0 0 NMIR W=20u L=1u
Msd_bk_L2_39 dpf_bk_L2_39 ctp_L2_39 0 0 NMIR W=20u L=1u
Mse_bk_L2_39 dpf_bk_L2_39 dpf_bk_L2_39 vdd vdd PMIR W=60u L=1u
Msf_bk_L2_39 dpre_L2_39 dpf_bk_L2_39 vdd vdd PMIR W=60u L=1u
R_bk_L2_39 dpre_L2_39 vrefd 16000.0
MpTa_L2_40_0 dpre_L3_2 gp_3_2_11 ctp_L2_40 0 NSYN W=10u L=1u
MnTb_L2_40_0 d1bar_L3 vcn ctp_L2_40 0 NSYN W=10u L=1u
MnTa_L2_40_0 dpre_L3_2 vcn ctn_L2_40 0 NSYN W=10u L=1u
MpTb_L2_40_0 d1bar_L3 gp_3_2_11 ctn_L2_40 0 NSYN W=10u L=1u
MpTa_L2_40_1 dpre_L3_3 gp_3_3_10 ctp_L2_40 0 NSYN W=10u L=1u
MnTb_L2_40_1 d1bar_L3 vcn ctp_L2_40 0 NSYN W=10u L=1u
MnTa_L2_40_1 dpre_L3_3 vcn ctn_L2_40 0 NSYN W=10u L=1u
MpTb_L2_40_1 d1bar_L3 gp_3_3_10 ctn_L2_40 0 NSYN W=10u L=1u
MpTa_L2_40_2 dpre_L3_4 gp_3_4_14 ctp_L2_40 0 NSYN W=10u L=1u
MnTb_L2_40_2 d1bar_L3 vcn ctp_L2_40 0 NSYN W=10u L=1u
MnTa_L2_40_2 dpre_L3_4 vcn ctn_L2_40 0 NSYN W=10u L=1u
MpTb_L2_40_2 d1bar_L3 gp_3_4_14 ctn_L2_40 0 NSYN W=10u L=1u
MpTa_L2_40_3 dpre_L3_6 gp_3_6_13 ctp_L2_40 0 NSYN W=10u L=1u
MnTb_L2_40_3 d1bar_L3 vcn ctp_L2_40 0 NSYN W=10u L=1u
MnTa_L2_40_3 dpre_L3_6 vcn ctn_L2_40 0 NSYN W=10u L=1u
MpTb_L2_40_3 d1bar_L3 gp_3_6_13 ctn_L2_40 0 NSYN W=10u L=1u
MpTa_L2_40_4 dpre_L3_10 gp_3_10_12 ctp_L2_40 0 NSYN W=10u L=1u
MnTb_L2_40_4 d1bar_L3 vcn ctp_L2_40 0 NSYN W=10u L=1u
MnTa_L2_40_4 dpre_L3_10 vcn ctn_L2_40 0 NSYN W=10u L=1u
MpTb_L2_40_4 d1bar_L3 gp_3_10_12 ctn_L2_40 0 NSYN W=10u L=1u
MpTa_L2_40_5 dpre_L3_14 gp_3_14_14 ctp_L2_40 0 NSYN W=10u L=1u
MnTb_L2_40_5 d1bar_L3 vcn ctp_L2_40 0 NSYN W=10u L=1u
MnTa_L2_40_5 dpre_L3_14 vcn ctn_L2_40 0 NSYN W=10u L=1u
MpTb_L2_40_5 d1bar_L3 gp_3_14_14 ctn_L2_40 0 NSYN W=10u L=1u
MpTa_L2_40_6 dpre_L3_16 gp_3_16_12 ctp_L2_40 0 NSYN W=10u L=1u
MnTb_L2_40_6 d1bar_L3 vcn ctp_L2_40 0 NSYN W=10u L=1u
MnTa_L2_40_6 dpre_L3_16 vcn ctn_L2_40 0 NSYN W=10u L=1u
MpTb_L2_40_6 d1bar_L3 gp_3_16_12 ctn_L2_40 0 NSYN W=10u L=1u
MpTa_L2_40_7 dpre_L3_18 gp_3_18_14 ctp_L2_40 0 NSYN W=10u L=1u
MnTb_L2_40_7 d1bar_L3 vcn ctp_L2_40 0 NSYN W=10u L=1u
MnTa_L2_40_7 dpre_L3_18 vcn ctn_L2_40 0 NSYN W=10u L=1u
MpTb_L2_40_7 d1bar_L3 gp_3_18_14 ctn_L2_40 0 NSYN W=10u L=1u
MpTa_L2_40_8 dpre_L3_22 gp_3_22_14 ctp_L2_40 0 NSYN W=10u L=1u
MnTb_L2_40_8 d1bar_L3 vcn ctp_L2_40 0 NSYN W=10u L=1u
MnTa_L2_40_8 dpre_L3_22 vcn ctn_L2_40 0 NSYN W=10u L=1u
MpTb_L2_40_8 d1bar_L3 gp_3_22_14 ctn_L2_40 0 NSYN W=10u L=1u
MpTa_L2_40_9 dpre_L3_23 gp_3_23_11 ctp_L2_40 0 NSYN W=10u L=1u
MnTb_L2_40_9 d1bar_L3 vcn ctp_L2_40 0 NSYN W=10u L=1u
MnTa_L2_40_9 dpre_L3_23 vcn ctn_L2_40 0 NSYN W=10u L=1u
MpTb_L2_40_9 d1bar_L3 gp_3_23_11 ctn_L2_40 0 NSYN W=10u L=1u
MpTa_L2_40_10 dpre_L3_28 gp_3_28_14 ctp_L2_40 0 NSYN W=10u L=1u
MnTb_L2_40_10 d1bar_L3 vcn ctp_L2_40 0 NSYN W=10u L=1u
MnTa_L2_40_10 dpre_L3_28 vcn ctn_L2_40 0 NSYN W=10u L=1u
MpTb_L2_40_10 d1bar_L3 gp_3_28_14 ctn_L2_40 0 NSYN W=10u L=1u
MpTa_L2_40_11 dpre_L3_29 gp_3_29_14 ctp_L2_40 0 NSYN W=10u L=1u
MnTb_L2_40_11 d1bar_L3 vcn ctp_L2_40 0 NSYN W=10u L=1u
MnTa_L2_40_11 dpre_L3_29 vcn ctn_L2_40 0 NSYN W=10u L=1u
MpTb_L2_40_11 d1bar_L3 gp_3_29_14 ctn_L2_40 0 NSYN W=10u L=1u
MpTa_L2_40_12 dpre_L3_35 gp_3_35_13 ctp_L2_40 0 NSYN W=10u L=1u
MnTb_L2_40_12 d1bar_L3 vcn ctp_L2_40 0 NSYN W=10u L=1u
MnTa_L2_40_12 dpre_L3_35 vcn ctn_L2_40 0 NSYN W=10u L=1u
MpTb_L2_40_12 d1bar_L3 gp_3_35_13 ctn_L2_40 0 NSYN W=10u L=1u
MpTa_L2_40_13 dpre_L3_38 gp_3_38_11 ctp_L2_40 0 NSYN W=10u L=1u
MnTb_L2_40_13 d1bar_L3 vcn ctp_L2_40 0 NSYN W=10u L=1u
MnTa_L2_40_13 dpre_L3_38 vcn ctn_L2_40 0 NSYN W=10u L=1u
MpTb_L2_40_13 d1bar_L3 gp_3_38_11 ctn_L2_40 0 NSYN W=10u L=1u
MpTa_L2_40_14 dpre_L3_39 gp_3_39_11 ctp_L2_40 0 NSYN W=10u L=1u
MnTb_L2_40_14 d1bar_L3 vcn ctp_L2_40 0 NSYN W=10u L=1u
MnTa_L2_40_14 dpre_L3_39 vcn ctn_L2_40 0 NSYN W=10u L=1u
MpTb_L2_40_14 d1bar_L3 gp_3_39_11 ctn_L2_40 0 NSYN W=10u L=1u
MpTa_L2_40_15 dpre_L3_42 gp_3_42_14 ctp_L2_40 0 NSYN W=10u L=1u
MnTb_L2_40_15 d1bar_L3 vcn ctp_L2_40 0 NSYN W=10u L=1u
MnTa_L2_40_15 dpre_L3_42 vcn ctn_L2_40 0 NSYN W=10u L=1u
MpTb_L2_40_15 d1bar_L3 gp_3_42_14 ctn_L2_40 0 NSYN W=10u L=1u
MpTa_L2_40_16 dpre_L3_43 gp_3_43_14 ctp_L2_40 0 NSYN W=10u L=1u
MnTb_L2_40_16 d1bar_L3 vcn ctp_L2_40 0 NSYN W=10u L=1u
MnTa_L2_40_16 dpre_L3_43 vcn ctn_L2_40 0 NSYN W=10u L=1u
MpTb_L2_40_16 d1bar_L3 gp_3_43_14 ctn_L2_40 0 NSYN W=10u L=1u
MpTa_L2_40_17 dpre_L3_45 gp_3_45_11 ctp_L2_40 0 NSYN W=10u L=1u
MnTb_L2_40_17 d1bar_L3 vcn ctp_L2_40 0 NSYN W=10u L=1u
MnTa_L2_40_17 dpre_L3_45 vcn ctn_L2_40 0 NSYN W=10u L=1u
MpTb_L2_40_17 d1bar_L3 gp_3_45_11 ctn_L2_40 0 NSYN W=10u L=1u
Msa_bk_L2_40 ctn_L2_40 ctn_L2_40 0 0 NMIR W=20u L=1u
Msb_bk_L2_40 dpre_L2_40 ctn_L2_40 0 0 NMIR W=20u L=1u
Msc_bk_L2_40 ctp_L2_40 ctp_L2_40 0 0 NMIR W=20u L=1u
Msd_bk_L2_40 dpf_bk_L2_40 ctp_L2_40 0 0 NMIR W=20u L=1u
Mse_bk_L2_40 dpf_bk_L2_40 dpf_bk_L2_40 vdd vdd PMIR W=60u L=1u
Msf_bk_L2_40 dpre_L2_40 dpf_bk_L2_40 vdd vdd PMIR W=60u L=1u
R_bk_L2_40 dpre_L2_40 vrefd 16000.0
MpTa_L2_41_0 dpre_L3_0 gp_3_0_14 ctp_L2_41 0 NSYN W=10u L=1u
MnTb_L2_41_0 d1bar_L3 vcn ctp_L2_41 0 NSYN W=10u L=1u
MnTa_L2_41_0 dpre_L3_0 vcn ctn_L2_41 0 NSYN W=10u L=1u
MpTb_L2_41_0 d1bar_L3 gp_3_0_14 ctn_L2_41 0 NSYN W=10u L=1u
MpTa_L2_41_1 dpre_L3_3 gp_3_3_11 ctp_L2_41 0 NSYN W=10u L=1u
MnTb_L2_41_1 d1bar_L3 vcn ctp_L2_41 0 NSYN W=10u L=1u
MnTa_L2_41_1 dpre_L3_3 vcn ctn_L2_41 0 NSYN W=10u L=1u
MpTb_L2_41_1 d1bar_L3 gp_3_3_11 ctn_L2_41 0 NSYN W=10u L=1u
MpTa_L2_41_2 dpre_L3_6 gp_3_6_14 ctp_L2_41 0 NSYN W=10u L=1u
MnTb_L2_41_2 d1bar_L3 vcn ctp_L2_41 0 NSYN W=10u L=1u
MnTa_L2_41_2 dpre_L3_6 vcn ctn_L2_41 0 NSYN W=10u L=1u
MpTb_L2_41_2 d1bar_L3 gp_3_6_14 ctn_L2_41 0 NSYN W=10u L=1u
MpTa_L2_41_3 dpre_L3_8 gp_3_8_14 ctp_L2_41 0 NSYN W=10u L=1u
MnTb_L2_41_3 d1bar_L3 vcn ctp_L2_41 0 NSYN W=10u L=1u
MnTa_L2_41_3 dpre_L3_8 vcn ctn_L2_41 0 NSYN W=10u L=1u
MpTb_L2_41_3 d1bar_L3 gp_3_8_14 ctn_L2_41 0 NSYN W=10u L=1u
MpTa_L2_41_4 dpre_L3_9 gp_3_9_12 ctp_L2_41 0 NSYN W=10u L=1u
MnTb_L2_41_4 d1bar_L3 vcn ctp_L2_41 0 NSYN W=10u L=1u
MnTa_L2_41_4 dpre_L3_9 vcn ctn_L2_41 0 NSYN W=10u L=1u
MpTb_L2_41_4 d1bar_L3 gp_3_9_12 ctn_L2_41 0 NSYN W=10u L=1u
MpTa_L2_41_5 dpre_L3_10 gp_3_10_13 ctp_L2_41 0 NSYN W=10u L=1u
MnTb_L2_41_5 d1bar_L3 vcn ctp_L2_41 0 NSYN W=10u L=1u
MnTa_L2_41_5 dpre_L3_10 vcn ctn_L2_41 0 NSYN W=10u L=1u
MpTb_L2_41_5 d1bar_L3 gp_3_10_13 ctn_L2_41 0 NSYN W=10u L=1u
MpTa_L2_41_6 dpre_L3_11 gp_3_11_12 ctp_L2_41 0 NSYN W=10u L=1u
MnTb_L2_41_6 d1bar_L3 vcn ctp_L2_41 0 NSYN W=10u L=1u
MnTa_L2_41_6 dpre_L3_11 vcn ctn_L2_41 0 NSYN W=10u L=1u
MpTb_L2_41_6 d1bar_L3 gp_3_11_12 ctn_L2_41 0 NSYN W=10u L=1u
MpTa_L2_41_7 dpre_L3_13 gp_3_13_14 ctp_L2_41 0 NSYN W=10u L=1u
MnTb_L2_41_7 d1bar_L3 vcn ctp_L2_41 0 NSYN W=10u L=1u
MnTa_L2_41_7 dpre_L3_13 vcn ctn_L2_41 0 NSYN W=10u L=1u
MpTb_L2_41_7 d1bar_L3 gp_3_13_14 ctn_L2_41 0 NSYN W=10u L=1u
MpTa_L2_41_8 dpre_L3_14 gp_3_14_15 ctp_L2_41 0 NSYN W=10u L=1u
MnTb_L2_41_8 d1bar_L3 vcn ctp_L2_41 0 NSYN W=10u L=1u
MnTa_L2_41_8 dpre_L3_14 vcn ctn_L2_41 0 NSYN W=10u L=1u
MpTb_L2_41_8 d1bar_L3 gp_3_14_15 ctn_L2_41 0 NSYN W=10u L=1u
MpTa_L2_41_9 dpre_L3_17 gp_3_17_14 ctp_L2_41 0 NSYN W=10u L=1u
MnTb_L2_41_9 d1bar_L3 vcn ctp_L2_41 0 NSYN W=10u L=1u
MnTa_L2_41_9 dpre_L3_17 vcn ctn_L2_41 0 NSYN W=10u L=1u
MpTb_L2_41_9 d1bar_L3 gp_3_17_14 ctn_L2_41 0 NSYN W=10u L=1u
MpTa_L2_41_10 dpre_L3_19 gp_3_19_12 ctp_L2_41 0 NSYN W=10u L=1u
MnTb_L2_41_10 d1bar_L3 vcn ctp_L2_41 0 NSYN W=10u L=1u
MnTa_L2_41_10 dpre_L3_19 vcn ctn_L2_41 0 NSYN W=10u L=1u
MpTb_L2_41_10 d1bar_L3 gp_3_19_12 ctn_L2_41 0 NSYN W=10u L=1u
MpTa_L2_41_11 dpre_L3_23 gp_3_23_12 ctp_L2_41 0 NSYN W=10u L=1u
MnTb_L2_41_11 d1bar_L3 vcn ctp_L2_41 0 NSYN W=10u L=1u
MnTa_L2_41_11 dpre_L3_23 vcn ctn_L2_41 0 NSYN W=10u L=1u
MpTb_L2_41_11 d1bar_L3 gp_3_23_12 ctn_L2_41 0 NSYN W=10u L=1u
MpTa_L2_41_12 dpre_L3_24 gp_3_24_11 ctp_L2_41 0 NSYN W=10u L=1u
MnTb_L2_41_12 d1bar_L3 vcn ctp_L2_41 0 NSYN W=10u L=1u
MnTa_L2_41_12 dpre_L3_24 vcn ctn_L2_41 0 NSYN W=10u L=1u
MpTb_L2_41_12 d1bar_L3 gp_3_24_11 ctn_L2_41 0 NSYN W=10u L=1u
MpTa_L2_41_13 dpre_L3_29 gp_3_29_15 ctp_L2_41 0 NSYN W=10u L=1u
MnTb_L2_41_13 d1bar_L3 vcn ctp_L2_41 0 NSYN W=10u L=1u
MnTa_L2_41_13 dpre_L3_29 vcn ctn_L2_41 0 NSYN W=10u L=1u
MpTb_L2_41_13 d1bar_L3 gp_3_29_15 ctn_L2_41 0 NSYN W=10u L=1u
MpTa_L2_41_14 dpre_L3_34 gp_3_34_13 ctp_L2_41 0 NSYN W=10u L=1u
MnTb_L2_41_14 d1bar_L3 vcn ctp_L2_41 0 NSYN W=10u L=1u
MnTa_L2_41_14 dpre_L3_34 vcn ctn_L2_41 0 NSYN W=10u L=1u
MpTb_L2_41_14 d1bar_L3 gp_3_34_13 ctn_L2_41 0 NSYN W=10u L=1u
MpTa_L2_41_15 dpre_L3_45 gp_3_45_12 ctp_L2_41 0 NSYN W=10u L=1u
MnTb_L2_41_15 d1bar_L3 vcn ctp_L2_41 0 NSYN W=10u L=1u
MnTa_L2_41_15 dpre_L3_45 vcn ctn_L2_41 0 NSYN W=10u L=1u
MpTb_L2_41_15 d1bar_L3 gp_3_45_12 ctn_L2_41 0 NSYN W=10u L=1u
Msa_bk_L2_41 ctn_L2_41 ctn_L2_41 0 0 NMIR W=20u L=1u
Msb_bk_L2_41 dpre_L2_41 ctn_L2_41 0 0 NMIR W=20u L=1u
Msc_bk_L2_41 ctp_L2_41 ctp_L2_41 0 0 NMIR W=20u L=1u
Msd_bk_L2_41 dpf_bk_L2_41 ctp_L2_41 0 0 NMIR W=20u L=1u
Mse_bk_L2_41 dpf_bk_L2_41 dpf_bk_L2_41 vdd vdd PMIR W=60u L=1u
Msf_bk_L2_41 dpre_L2_41 dpf_bk_L2_41 vdd vdd PMIR W=60u L=1u
R_bk_L2_41 dpre_L2_41 vrefd 16000.0
MpTa_L2_42_0 dpre_L3_3 gp_3_3_12 ctp_L2_42 0 NSYN W=10u L=1u
MnTb_L2_42_0 d1bar_L3 vcn ctp_L2_42 0 NSYN W=10u L=1u
MnTa_L2_42_0 dpre_L3_3 vcn ctn_L2_42 0 NSYN W=10u L=1u
MpTb_L2_42_0 d1bar_L3 gp_3_3_12 ctn_L2_42 0 NSYN W=10u L=1u
MpTa_L2_42_1 dpre_L3_5 gp_3_5_12 ctp_L2_42 0 NSYN W=10u L=1u
MnTb_L2_42_1 d1bar_L3 vcn ctp_L2_42 0 NSYN W=10u L=1u
MnTa_L2_42_1 dpre_L3_5 vcn ctn_L2_42 0 NSYN W=10u L=1u
MpTb_L2_42_1 d1bar_L3 gp_3_5_12 ctn_L2_42 0 NSYN W=10u L=1u
MpTa_L2_42_2 dpre_L3_9 gp_3_9_13 ctp_L2_42 0 NSYN W=10u L=1u
MnTb_L2_42_2 d1bar_L3 vcn ctp_L2_42 0 NSYN W=10u L=1u
MnTa_L2_42_2 dpre_L3_9 vcn ctn_L2_42 0 NSYN W=10u L=1u
MpTb_L2_42_2 d1bar_L3 gp_3_9_13 ctn_L2_42 0 NSYN W=10u L=1u
MpTa_L2_42_3 dpre_L3_11 gp_3_11_13 ctp_L2_42 0 NSYN W=10u L=1u
MnTb_L2_42_3 d1bar_L3 vcn ctp_L2_42 0 NSYN W=10u L=1u
MnTa_L2_42_3 dpre_L3_11 vcn ctn_L2_42 0 NSYN W=10u L=1u
MpTb_L2_42_3 d1bar_L3 gp_3_11_13 ctn_L2_42 0 NSYN W=10u L=1u
MpTa_L2_42_4 dpre_L3_15 gp_3_15_14 ctp_L2_42 0 NSYN W=10u L=1u
MnTb_L2_42_4 d1bar_L3 vcn ctp_L2_42 0 NSYN W=10u L=1u
MnTa_L2_42_4 dpre_L3_15 vcn ctn_L2_42 0 NSYN W=10u L=1u
MpTb_L2_42_4 d1bar_L3 gp_3_15_14 ctn_L2_42 0 NSYN W=10u L=1u
MpTa_L2_42_5 dpre_L3_16 gp_3_16_13 ctp_L2_42 0 NSYN W=10u L=1u
MnTb_L2_42_5 d1bar_L3 vcn ctp_L2_42 0 NSYN W=10u L=1u
MnTa_L2_42_5 dpre_L3_16 vcn ctn_L2_42 0 NSYN W=10u L=1u
MpTb_L2_42_5 d1bar_L3 gp_3_16_13 ctn_L2_42 0 NSYN W=10u L=1u
MpTa_L2_42_6 dpre_L3_23 gp_3_23_13 ctp_L2_42 0 NSYN W=10u L=1u
MnTb_L2_42_6 d1bar_L3 vcn ctp_L2_42 0 NSYN W=10u L=1u
MnTa_L2_42_6 dpre_L3_23 vcn ctn_L2_42 0 NSYN W=10u L=1u
MpTb_L2_42_6 d1bar_L3 gp_3_23_13 ctn_L2_42 0 NSYN W=10u L=1u
MpTa_L2_42_7 dpre_L3_24 gp_3_24_12 ctp_L2_42 0 NSYN W=10u L=1u
MnTb_L2_42_7 d1bar_L3 vcn ctp_L2_42 0 NSYN W=10u L=1u
MnTa_L2_42_7 dpre_L3_24 vcn ctn_L2_42 0 NSYN W=10u L=1u
MpTb_L2_42_7 d1bar_L3 gp_3_24_12 ctn_L2_42 0 NSYN W=10u L=1u
MpTa_L2_42_8 dpre_L3_25 gp_3_25_12 ctp_L2_42 0 NSYN W=10u L=1u
MnTb_L2_42_8 d1bar_L3 vcn ctp_L2_42 0 NSYN W=10u L=1u
MnTa_L2_42_8 dpre_L3_25 vcn ctn_L2_42 0 NSYN W=10u L=1u
MpTb_L2_42_8 d1bar_L3 gp_3_25_12 ctn_L2_42 0 NSYN W=10u L=1u
MpTa_L2_42_9 dpre_L3_26 gp_3_26_14 ctp_L2_42 0 NSYN W=10u L=1u
MnTb_L2_42_9 d1bar_L3 vcn ctp_L2_42 0 NSYN W=10u L=1u
MnTa_L2_42_9 dpre_L3_26 vcn ctn_L2_42 0 NSYN W=10u L=1u
MpTb_L2_42_9 d1bar_L3 gp_3_26_14 ctn_L2_42 0 NSYN W=10u L=1u
MpTa_L2_42_10 dpre_L3_30 gp_3_30_13 ctp_L2_42 0 NSYN W=10u L=1u
MnTb_L2_42_10 d1bar_L3 vcn ctp_L2_42 0 NSYN W=10u L=1u
MnTa_L2_42_10 dpre_L3_30 vcn ctn_L2_42 0 NSYN W=10u L=1u
MpTb_L2_42_10 d1bar_L3 gp_3_30_13 ctn_L2_42 0 NSYN W=10u L=1u
MpTa_L2_42_11 dpre_L3_31 gp_3_31_13 ctp_L2_42 0 NSYN W=10u L=1u
MnTb_L2_42_11 d1bar_L3 vcn ctp_L2_42 0 NSYN W=10u L=1u
MnTa_L2_42_11 dpre_L3_31 vcn ctn_L2_42 0 NSYN W=10u L=1u
MpTb_L2_42_11 d1bar_L3 gp_3_31_13 ctn_L2_42 0 NSYN W=10u L=1u
MpTa_L2_42_12 dpre_L3_32 gp_3_32_13 ctp_L2_42 0 NSYN W=10u L=1u
MnTb_L2_42_12 d1bar_L3 vcn ctp_L2_42 0 NSYN W=10u L=1u
MnTa_L2_42_12 dpre_L3_32 vcn ctn_L2_42 0 NSYN W=10u L=1u
MpTb_L2_42_12 d1bar_L3 gp_3_32_13 ctn_L2_42 0 NSYN W=10u L=1u
MpTa_L2_42_13 dpre_L3_35 gp_3_35_14 ctp_L2_42 0 NSYN W=10u L=1u
MnTb_L2_42_13 d1bar_L3 vcn ctp_L2_42 0 NSYN W=10u L=1u
MnTa_L2_42_13 dpre_L3_35 vcn ctn_L2_42 0 NSYN W=10u L=1u
MpTb_L2_42_13 d1bar_L3 gp_3_35_14 ctn_L2_42 0 NSYN W=10u L=1u
MpTa_L2_42_14 dpre_L3_38 gp_3_38_12 ctp_L2_42 0 NSYN W=10u L=1u
MnTb_L2_42_14 d1bar_L3 vcn ctp_L2_42 0 NSYN W=10u L=1u
MnTa_L2_42_14 dpre_L3_38 vcn ctn_L2_42 0 NSYN W=10u L=1u
MpTb_L2_42_14 d1bar_L3 gp_3_38_12 ctn_L2_42 0 NSYN W=10u L=1u
MpTa_L2_42_15 dpre_L3_40 gp_3_40_14 ctp_L2_42 0 NSYN W=10u L=1u
MnTb_L2_42_15 d1bar_L3 vcn ctp_L2_42 0 NSYN W=10u L=1u
MnTa_L2_42_15 dpre_L3_40 vcn ctn_L2_42 0 NSYN W=10u L=1u
MpTb_L2_42_15 d1bar_L3 gp_3_40_14 ctn_L2_42 0 NSYN W=10u L=1u
MpTa_L2_42_16 dpre_L3_41 gp_3_41_14 ctp_L2_42 0 NSYN W=10u L=1u
MnTb_L2_42_16 d1bar_L3 vcn ctp_L2_42 0 NSYN W=10u L=1u
MnTa_L2_42_16 dpre_L3_41 vcn ctn_L2_42 0 NSYN W=10u L=1u
MpTb_L2_42_16 d1bar_L3 gp_3_41_14 ctn_L2_42 0 NSYN W=10u L=1u
MpTa_L2_42_17 dpre_L3_44 gp_3_44_12 ctp_L2_42 0 NSYN W=10u L=1u
MnTb_L2_42_17 d1bar_L3 vcn ctp_L2_42 0 NSYN W=10u L=1u
MnTa_L2_42_17 dpre_L3_44 vcn ctn_L2_42 0 NSYN W=10u L=1u
MpTb_L2_42_17 d1bar_L3 gp_3_44_12 ctn_L2_42 0 NSYN W=10u L=1u
MpTa_L2_42_18 dpre_L3_46 gp_3_46_14 ctp_L2_42 0 NSYN W=10u L=1u
MnTb_L2_42_18 d1bar_L3 vcn ctp_L2_42 0 NSYN W=10u L=1u
MnTa_L2_42_18 dpre_L3_46 vcn ctn_L2_42 0 NSYN W=10u L=1u
MpTb_L2_42_18 d1bar_L3 gp_3_46_14 ctn_L2_42 0 NSYN W=10u L=1u
Msa_bk_L2_42 ctn_L2_42 ctn_L2_42 0 0 NMIR W=20u L=1u
Msb_bk_L2_42 dpre_L2_42 ctn_L2_42 0 0 NMIR W=20u L=1u
Msc_bk_L2_42 ctp_L2_42 ctp_L2_42 0 0 NMIR W=20u L=1u
Msd_bk_L2_42 dpf_bk_L2_42 ctp_L2_42 0 0 NMIR W=20u L=1u
Mse_bk_L2_42 dpf_bk_L2_42 dpf_bk_L2_42 vdd vdd PMIR W=60u L=1u
Msf_bk_L2_42 dpre_L2_42 dpf_bk_L2_42 vdd vdd PMIR W=60u L=1u
R_bk_L2_42 dpre_L2_42 vrefd 16000.0
MpTa_L2_43_0 dpre_L3_1 gp_3_1_13 ctp_L2_43 0 NSYN W=10u L=1u
MnTb_L2_43_0 d1bar_L3 vcn ctp_L2_43 0 NSYN W=10u L=1u
MnTa_L2_43_0 dpre_L3_1 vcn ctn_L2_43 0 NSYN W=10u L=1u
MpTb_L2_43_0 d1bar_L3 gp_3_1_13 ctn_L2_43 0 NSYN W=10u L=1u
MpTa_L2_43_1 dpre_L3_2 gp_3_2_12 ctp_L2_43 0 NSYN W=10u L=1u
MnTb_L2_43_1 d1bar_L3 vcn ctp_L2_43 0 NSYN W=10u L=1u
MnTa_L2_43_1 dpre_L3_2 vcn ctn_L2_43 0 NSYN W=10u L=1u
MpTb_L2_43_1 d1bar_L3 gp_3_2_12 ctn_L2_43 0 NSYN W=10u L=1u
MpTa_L2_43_2 dpre_L3_6 gp_3_6_15 ctp_L2_43 0 NSYN W=10u L=1u
MnTb_L2_43_2 d1bar_L3 vcn ctp_L2_43 0 NSYN W=10u L=1u
MnTa_L2_43_2 dpre_L3_6 vcn ctn_L2_43 0 NSYN W=10u L=1u
MpTb_L2_43_2 d1bar_L3 gp_3_6_15 ctn_L2_43 0 NSYN W=10u L=1u
MpTa_L2_43_3 dpre_L3_8 gp_3_8_15 ctp_L2_43 0 NSYN W=10u L=1u
MnTb_L2_43_3 d1bar_L3 vcn ctp_L2_43 0 NSYN W=10u L=1u
MnTa_L2_43_3 dpre_L3_8 vcn ctn_L2_43 0 NSYN W=10u L=1u
MpTb_L2_43_3 d1bar_L3 gp_3_8_15 ctn_L2_43 0 NSYN W=10u L=1u
MpTa_L2_43_4 dpre_L3_13 gp_3_13_15 ctp_L2_43 0 NSYN W=10u L=1u
MnTb_L2_43_4 d1bar_L3 vcn ctp_L2_43 0 NSYN W=10u L=1u
MnTa_L2_43_4 dpre_L3_13 vcn ctn_L2_43 0 NSYN W=10u L=1u
MpTb_L2_43_4 d1bar_L3 gp_3_13_15 ctn_L2_43 0 NSYN W=10u L=1u
MpTa_L2_43_5 dpre_L3_18 gp_3_18_15 ctp_L2_43 0 NSYN W=10u L=1u
MnTb_L2_43_5 d1bar_L3 vcn ctp_L2_43 0 NSYN W=10u L=1u
MnTa_L2_43_5 dpre_L3_18 vcn ctn_L2_43 0 NSYN W=10u L=1u
MpTb_L2_43_5 d1bar_L3 gp_3_18_15 ctn_L2_43 0 NSYN W=10u L=1u
MpTa_L2_43_6 dpre_L3_19 gp_3_19_13 ctp_L2_43 0 NSYN W=10u L=1u
MnTb_L2_43_6 d1bar_L3 vcn ctp_L2_43 0 NSYN W=10u L=1u
MnTa_L2_43_6 dpre_L3_19 vcn ctn_L2_43 0 NSYN W=10u L=1u
MpTb_L2_43_6 d1bar_L3 gp_3_19_13 ctn_L2_43 0 NSYN W=10u L=1u
MpTa_L2_43_7 dpre_L3_24 gp_3_24_13 ctp_L2_43 0 NSYN W=10u L=1u
MnTb_L2_43_7 d1bar_L3 vcn ctp_L2_43 0 NSYN W=10u L=1u
MnTa_L2_43_7 dpre_L3_24 vcn ctn_L2_43 0 NSYN W=10u L=1u
MpTb_L2_43_7 d1bar_L3 gp_3_24_13 ctn_L2_43 0 NSYN W=10u L=1u
MpTa_L2_43_8 dpre_L3_26 gp_3_26_15 ctp_L2_43 0 NSYN W=10u L=1u
MnTb_L2_43_8 d1bar_L3 vcn ctp_L2_43 0 NSYN W=10u L=1u
MnTa_L2_43_8 dpre_L3_26 vcn ctn_L2_43 0 NSYN W=10u L=1u
MpTb_L2_43_8 d1bar_L3 gp_3_26_15 ctn_L2_43 0 NSYN W=10u L=1u
MpTa_L2_43_9 dpre_L3_30 gp_3_30_14 ctp_L2_43 0 NSYN W=10u L=1u
MnTb_L2_43_9 d1bar_L3 vcn ctp_L2_43 0 NSYN W=10u L=1u
MnTa_L2_43_9 dpre_L3_30 vcn ctn_L2_43 0 NSYN W=10u L=1u
MpTb_L2_43_9 d1bar_L3 gp_3_30_14 ctn_L2_43 0 NSYN W=10u L=1u
MpTa_L2_43_10 dpre_L3_31 gp_3_31_14 ctp_L2_43 0 NSYN W=10u L=1u
MnTb_L2_43_10 d1bar_L3 vcn ctp_L2_43 0 NSYN W=10u L=1u
MnTa_L2_43_10 dpre_L3_31 vcn ctn_L2_43 0 NSYN W=10u L=1u
MpTb_L2_43_10 d1bar_L3 gp_3_31_14 ctn_L2_43 0 NSYN W=10u L=1u
MpTa_L2_43_11 dpre_L3_32 gp_3_32_14 ctp_L2_43 0 NSYN W=10u L=1u
MnTb_L2_43_11 d1bar_L3 vcn ctp_L2_43 0 NSYN W=10u L=1u
MnTa_L2_43_11 dpre_L3_32 vcn ctn_L2_43 0 NSYN W=10u L=1u
MpTb_L2_43_11 d1bar_L3 gp_3_32_14 ctn_L2_43 0 NSYN W=10u L=1u
MpTa_L2_43_12 dpre_L3_34 gp_3_34_14 ctp_L2_43 0 NSYN W=10u L=1u
MnTb_L2_43_12 d1bar_L3 vcn ctp_L2_43 0 NSYN W=10u L=1u
MnTa_L2_43_12 dpre_L3_34 vcn ctn_L2_43 0 NSYN W=10u L=1u
MpTb_L2_43_12 d1bar_L3 gp_3_34_14 ctn_L2_43 0 NSYN W=10u L=1u
MpTa_L2_43_13 dpre_L3_37 gp_3_37_13 ctp_L2_43 0 NSYN W=10u L=1u
MnTb_L2_43_13 d1bar_L3 vcn ctp_L2_43 0 NSYN W=10u L=1u
MnTa_L2_43_13 dpre_L3_37 vcn ctn_L2_43 0 NSYN W=10u L=1u
MpTb_L2_43_13 d1bar_L3 gp_3_37_13 ctn_L2_43 0 NSYN W=10u L=1u
MpTa_L2_43_14 dpre_L3_38 gp_3_38_13 ctp_L2_43 0 NSYN W=10u L=1u
MnTb_L2_43_14 d1bar_L3 vcn ctp_L2_43 0 NSYN W=10u L=1u
MnTa_L2_43_14 dpre_L3_38 vcn ctn_L2_43 0 NSYN W=10u L=1u
MpTb_L2_43_14 d1bar_L3 gp_3_38_13 ctn_L2_43 0 NSYN W=10u L=1u
MpTa_L2_43_15 dpre_L3_39 gp_3_39_12 ctp_L2_43 0 NSYN W=10u L=1u
MnTb_L2_43_15 d1bar_L3 vcn ctp_L2_43 0 NSYN W=10u L=1u
MnTa_L2_43_15 dpre_L3_39 vcn ctn_L2_43 0 NSYN W=10u L=1u
MpTb_L2_43_15 d1bar_L3 gp_3_39_12 ctn_L2_43 0 NSYN W=10u L=1u
MpTa_L2_43_16 dpre_L3_43 gp_3_43_15 ctp_L2_43 0 NSYN W=10u L=1u
MnTb_L2_43_16 d1bar_L3 vcn ctp_L2_43 0 NSYN W=10u L=1u
MnTa_L2_43_16 dpre_L3_43 vcn ctn_L2_43 0 NSYN W=10u L=1u
MpTb_L2_43_16 d1bar_L3 gp_3_43_15 ctn_L2_43 0 NSYN W=10u L=1u
MpTa_L2_43_17 dpre_L3_44 gp_3_44_13 ctp_L2_43 0 NSYN W=10u L=1u
MnTb_L2_43_17 d1bar_L3 vcn ctp_L2_43 0 NSYN W=10u L=1u
MnTa_L2_43_17 dpre_L3_44 vcn ctn_L2_43 0 NSYN W=10u L=1u
MpTb_L2_43_17 d1bar_L3 gp_3_44_13 ctn_L2_43 0 NSYN W=10u L=1u
Msa_bk_L2_43 ctn_L2_43 ctn_L2_43 0 0 NMIR W=20u L=1u
Msb_bk_L2_43 dpre_L2_43 ctn_L2_43 0 0 NMIR W=20u L=1u
Msc_bk_L2_43 ctp_L2_43 ctp_L2_43 0 0 NMIR W=20u L=1u
Msd_bk_L2_43 dpf_bk_L2_43 ctp_L2_43 0 0 NMIR W=20u L=1u
Mse_bk_L2_43 dpf_bk_L2_43 dpf_bk_L2_43 vdd vdd PMIR W=60u L=1u
Msf_bk_L2_43 dpre_L2_43 dpf_bk_L2_43 vdd vdd PMIR W=60u L=1u
R_bk_L2_43 dpre_L2_43 vrefd 16000.0
MpTa_L2_44_0 dpre_L3_1 gp_3_1_14 ctp_L2_44 0 NSYN W=10u L=1u
MnTb_L2_44_0 d1bar_L3 vcn ctp_L2_44 0 NSYN W=10u L=1u
MnTa_L2_44_0 dpre_L3_1 vcn ctn_L2_44 0 NSYN W=10u L=1u
MpTb_L2_44_0 d1bar_L3 gp_3_1_14 ctn_L2_44 0 NSYN W=10u L=1u
MpTa_L2_44_1 dpre_L3_2 gp_3_2_13 ctp_L2_44 0 NSYN W=10u L=1u
MnTb_L2_44_1 d1bar_L3 vcn ctp_L2_44 0 NSYN W=10u L=1u
MnTa_L2_44_1 dpre_L3_2 vcn ctn_L2_44 0 NSYN W=10u L=1u
MpTb_L2_44_1 d1bar_L3 gp_3_2_13 ctn_L2_44 0 NSYN W=10u L=1u
MpTa_L2_44_2 dpre_L3_3 gp_3_3_13 ctp_L2_44 0 NSYN W=10u L=1u
MnTb_L2_44_2 d1bar_L3 vcn ctp_L2_44 0 NSYN W=10u L=1u
MnTa_L2_44_2 dpre_L3_3 vcn ctn_L2_44 0 NSYN W=10u L=1u
MpTb_L2_44_2 d1bar_L3 gp_3_3_13 ctn_L2_44 0 NSYN W=10u L=1u
MpTa_L2_44_3 dpre_L3_5 gp_3_5_13 ctp_L2_44 0 NSYN W=10u L=1u
MnTb_L2_44_3 d1bar_L3 vcn ctp_L2_44 0 NSYN W=10u L=1u
MnTa_L2_44_3 dpre_L3_5 vcn ctn_L2_44 0 NSYN W=10u L=1u
MpTb_L2_44_3 d1bar_L3 gp_3_5_13 ctn_L2_44 0 NSYN W=10u L=1u
MpTa_L2_44_4 dpre_L3_9 gp_3_9_14 ctp_L2_44 0 NSYN W=10u L=1u
MnTb_L2_44_4 d1bar_L3 vcn ctp_L2_44 0 NSYN W=10u L=1u
MnTa_L2_44_4 dpre_L3_9 vcn ctn_L2_44 0 NSYN W=10u L=1u
MpTb_L2_44_4 d1bar_L3 gp_3_9_14 ctn_L2_44 0 NSYN W=10u L=1u
MpTa_L2_44_5 dpre_L3_10 gp_3_10_14 ctp_L2_44 0 NSYN W=10u L=1u
MnTb_L2_44_5 d1bar_L3 vcn ctp_L2_44 0 NSYN W=10u L=1u
MnTa_L2_44_5 dpre_L3_10 vcn ctn_L2_44 0 NSYN W=10u L=1u
MpTb_L2_44_5 d1bar_L3 gp_3_10_14 ctn_L2_44 0 NSYN W=10u L=1u
MpTa_L2_44_6 dpre_L3_11 gp_3_11_14 ctp_L2_44 0 NSYN W=10u L=1u
MnTb_L2_44_6 d1bar_L3 vcn ctp_L2_44 0 NSYN W=10u L=1u
MnTa_L2_44_6 dpre_L3_11 vcn ctn_L2_44 0 NSYN W=10u L=1u
MpTb_L2_44_6 d1bar_L3 gp_3_11_14 ctn_L2_44 0 NSYN W=10u L=1u
MpTa_L2_44_7 dpre_L3_19 gp_3_19_14 ctp_L2_44 0 NSYN W=10u L=1u
MnTb_L2_44_7 d1bar_L3 vcn ctp_L2_44 0 NSYN W=10u L=1u
MnTa_L2_44_7 dpre_L3_19 vcn ctn_L2_44 0 NSYN W=10u L=1u
MpTb_L2_44_7 d1bar_L3 gp_3_19_14 ctn_L2_44 0 NSYN W=10u L=1u
MpTa_L2_44_8 dpre_L3_20 gp_3_20_15 ctp_L2_44 0 NSYN W=10u L=1u
MnTb_L2_44_8 d1bar_L3 vcn ctp_L2_44 0 NSYN W=10u L=1u
MnTa_L2_44_8 dpre_L3_20 vcn ctn_L2_44 0 NSYN W=10u L=1u
MpTb_L2_44_8 d1bar_L3 gp_3_20_15 ctn_L2_44 0 NSYN W=10u L=1u
MpTa_L2_44_9 dpre_L3_25 gp_3_25_13 ctp_L2_44 0 NSYN W=10u L=1u
MnTb_L2_44_9 d1bar_L3 vcn ctp_L2_44 0 NSYN W=10u L=1u
MnTa_L2_44_9 dpre_L3_25 vcn ctn_L2_44 0 NSYN W=10u L=1u
MpTb_L2_44_9 d1bar_L3 gp_3_25_13 ctn_L2_44 0 NSYN W=10u L=1u
MpTa_L2_44_10 dpre_L3_32 gp_3_32_15 ctp_L2_44 0 NSYN W=10u L=1u
MnTb_L2_44_10 d1bar_L3 vcn ctp_L2_44 0 NSYN W=10u L=1u
MnTa_L2_44_10 dpre_L3_32 vcn ctn_L2_44 0 NSYN W=10u L=1u
MpTb_L2_44_10 d1bar_L3 gp_3_32_15 ctn_L2_44 0 NSYN W=10u L=1u
MpTa_L2_44_11 dpre_L3_33 gp_3_33_13 ctp_L2_44 0 NSYN W=10u L=1u
MnTb_L2_44_11 d1bar_L3 vcn ctp_L2_44 0 NSYN W=10u L=1u
MnTa_L2_44_11 dpre_L3_33 vcn ctn_L2_44 0 NSYN W=10u L=1u
MpTb_L2_44_11 d1bar_L3 gp_3_33_13 ctn_L2_44 0 NSYN W=10u L=1u
MpTa_L2_44_12 dpre_L3_36 gp_3_36_13 ctp_L2_44 0 NSYN W=10u L=1u
MnTb_L2_44_12 d1bar_L3 vcn ctp_L2_44 0 NSYN W=10u L=1u
MnTa_L2_44_12 dpre_L3_36 vcn ctn_L2_44 0 NSYN W=10u L=1u
MpTb_L2_44_12 d1bar_L3 gp_3_36_13 ctn_L2_44 0 NSYN W=10u L=1u
MpTa_L2_44_13 dpre_L3_39 gp_3_39_13 ctp_L2_44 0 NSYN W=10u L=1u
MnTb_L2_44_13 d1bar_L3 vcn ctp_L2_44 0 NSYN W=10u L=1u
MnTa_L2_44_13 dpre_L3_39 vcn ctn_L2_44 0 NSYN W=10u L=1u
MpTb_L2_44_13 d1bar_L3 gp_3_39_13 ctn_L2_44 0 NSYN W=10u L=1u
MpTa_L2_44_14 dpre_L3_40 gp_3_40_15 ctp_L2_44 0 NSYN W=10u L=1u
MnTb_L2_44_14 d1bar_L3 vcn ctp_L2_44 0 NSYN W=10u L=1u
MnTa_L2_44_14 dpre_L3_40 vcn ctn_L2_44 0 NSYN W=10u L=1u
MpTb_L2_44_14 d1bar_L3 gp_3_40_15 ctn_L2_44 0 NSYN W=10u L=1u
MpTa_L2_44_15 dpre_L3_44 gp_3_44_14 ctp_L2_44 0 NSYN W=10u L=1u
MnTb_L2_44_15 d1bar_L3 vcn ctp_L2_44 0 NSYN W=10u L=1u
MnTa_L2_44_15 dpre_L3_44 vcn ctn_L2_44 0 NSYN W=10u L=1u
MpTb_L2_44_15 d1bar_L3 gp_3_44_14 ctn_L2_44 0 NSYN W=10u L=1u
MpTa_L2_44_16 dpre_L3_45 gp_3_45_13 ctp_L2_44 0 NSYN W=10u L=1u
MnTb_L2_44_16 d1bar_L3 vcn ctp_L2_44 0 NSYN W=10u L=1u
MnTa_L2_44_16 dpre_L3_45 vcn ctn_L2_44 0 NSYN W=10u L=1u
MpTb_L2_44_16 d1bar_L3 gp_3_45_13 ctn_L2_44 0 NSYN W=10u L=1u
MpTa_L2_44_17 dpre_L3_47 gp_3_47_15 ctp_L2_44 0 NSYN W=10u L=1u
MnTb_L2_44_17 d1bar_L3 vcn ctp_L2_44 0 NSYN W=10u L=1u
MnTa_L2_44_17 dpre_L3_47 vcn ctn_L2_44 0 NSYN W=10u L=1u
MpTb_L2_44_17 d1bar_L3 gp_3_47_15 ctn_L2_44 0 NSYN W=10u L=1u
Msa_bk_L2_44 ctn_L2_44 ctn_L2_44 0 0 NMIR W=20u L=1u
Msb_bk_L2_44 dpre_L2_44 ctn_L2_44 0 0 NMIR W=20u L=1u
Msc_bk_L2_44 ctp_L2_44 ctp_L2_44 0 0 NMIR W=20u L=1u
Msd_bk_L2_44 dpf_bk_L2_44 ctp_L2_44 0 0 NMIR W=20u L=1u
Mse_bk_L2_44 dpf_bk_L2_44 dpf_bk_L2_44 vdd vdd PMIR W=60u L=1u
Msf_bk_L2_44 dpre_L2_44 dpf_bk_L2_44 vdd vdd PMIR W=60u L=1u
R_bk_L2_44 dpre_L2_44 vrefd 16000.0
MpTa_L2_45_0 dpre_L3_2 gp_3_2_14 ctp_L2_45 0 NSYN W=10u L=1u
MnTb_L2_45_0 d1bar_L3 vcn ctp_L2_45 0 NSYN W=10u L=1u
MnTa_L2_45_0 dpre_L3_2 vcn ctn_L2_45 0 NSYN W=10u L=1u
MpTb_L2_45_0 d1bar_L3 gp_3_2_14 ctn_L2_45 0 NSYN W=10u L=1u
MpTa_L2_45_1 dpre_L3_3 gp_3_3_14 ctp_L2_45 0 NSYN W=10u L=1u
MnTb_L2_45_1 d1bar_L3 vcn ctp_L2_45 0 NSYN W=10u L=1u
MnTa_L2_45_1 dpre_L3_3 vcn ctn_L2_45 0 NSYN W=10u L=1u
MpTb_L2_45_1 d1bar_L3 gp_3_3_14 ctn_L2_45 0 NSYN W=10u L=1u
MpTa_L2_45_2 dpre_L3_5 gp_3_5_14 ctp_L2_45 0 NSYN W=10u L=1u
MnTb_L2_45_2 d1bar_L3 vcn ctp_L2_45 0 NSYN W=10u L=1u
MnTa_L2_45_2 dpre_L3_5 vcn ctn_L2_45 0 NSYN W=10u L=1u
MpTb_L2_45_2 d1bar_L3 gp_3_5_14 ctn_L2_45 0 NSYN W=10u L=1u
MpTa_L2_45_3 dpre_L3_7 gp_3_7_14 ctp_L2_45 0 NSYN W=10u L=1u
MnTb_L2_45_3 d1bar_L3 vcn ctp_L2_45 0 NSYN W=10u L=1u
MnTa_L2_45_3 dpre_L3_7 vcn ctn_L2_45 0 NSYN W=10u L=1u
MpTb_L2_45_3 d1bar_L3 gp_3_7_14 ctn_L2_45 0 NSYN W=10u L=1u
MpTa_L2_45_4 dpre_L3_11 gp_3_11_15 ctp_L2_45 0 NSYN W=10u L=1u
MnTb_L2_45_4 d1bar_L3 vcn ctp_L2_45 0 NSYN W=10u L=1u
MnTa_L2_45_4 dpre_L3_11 vcn ctn_L2_45 0 NSYN W=10u L=1u
MpTb_L2_45_4 d1bar_L3 gp_3_11_15 ctn_L2_45 0 NSYN W=10u L=1u
MpTa_L2_45_5 dpre_L3_12 gp_3_12_13 ctp_L2_45 0 NSYN W=10u L=1u
MnTb_L2_45_5 d1bar_L3 vcn ctp_L2_45 0 NSYN W=10u L=1u
MnTa_L2_45_5 dpre_L3_12 vcn ctn_L2_45 0 NSYN W=10u L=1u
MpTb_L2_45_5 d1bar_L3 gp_3_12_13 ctn_L2_45 0 NSYN W=10u L=1u
MpTa_L2_45_6 dpre_L3_16 gp_3_16_14 ctp_L2_45 0 NSYN W=10u L=1u
MnTb_L2_45_6 d1bar_L3 vcn ctp_L2_45 0 NSYN W=10u L=1u
MnTa_L2_45_6 dpre_L3_16 vcn ctn_L2_45 0 NSYN W=10u L=1u
MpTb_L2_45_6 d1bar_L3 gp_3_16_14 ctn_L2_45 0 NSYN W=10u L=1u
MpTa_L2_45_7 dpre_L3_17 gp_3_17_15 ctp_L2_45 0 NSYN W=10u L=1u
MnTb_L2_45_7 d1bar_L3 vcn ctp_L2_45 0 NSYN W=10u L=1u
MnTa_L2_45_7 dpre_L3_17 vcn ctn_L2_45 0 NSYN W=10u L=1u
MpTb_L2_45_7 d1bar_L3 gp_3_17_15 ctn_L2_45 0 NSYN W=10u L=1u
MpTa_L2_45_8 dpre_L3_23 gp_3_23_14 ctp_L2_45 0 NSYN W=10u L=1u
MnTb_L2_45_8 d1bar_L3 vcn ctp_L2_45 0 NSYN W=10u L=1u
MnTa_L2_45_8 dpre_L3_23 vcn ctn_L2_45 0 NSYN W=10u L=1u
MpTb_L2_45_8 d1bar_L3 gp_3_23_14 ctn_L2_45 0 NSYN W=10u L=1u
MpTa_L2_45_9 dpre_L3_25 gp_3_25_14 ctp_L2_45 0 NSYN W=10u L=1u
MnTb_L2_45_9 d1bar_L3 vcn ctp_L2_45 0 NSYN W=10u L=1u
MnTa_L2_45_9 dpre_L3_25 vcn ctn_L2_45 0 NSYN W=10u L=1u
MpTb_L2_45_9 d1bar_L3 gp_3_25_14 ctn_L2_45 0 NSYN W=10u L=1u
MpTa_L2_45_10 dpre_L3_27 gp_3_27_15 ctp_L2_45 0 NSYN W=10u L=1u
MnTb_L2_45_10 d1bar_L3 vcn ctp_L2_45 0 NSYN W=10u L=1u
MnTa_L2_45_10 dpre_L3_27 vcn ctn_L2_45 0 NSYN W=10u L=1u
MpTb_L2_45_10 d1bar_L3 gp_3_27_15 ctn_L2_45 0 NSYN W=10u L=1u
MpTa_L2_45_11 dpre_L3_28 gp_3_28_15 ctp_L2_45 0 NSYN W=10u L=1u
MnTb_L2_45_11 d1bar_L3 vcn ctp_L2_45 0 NSYN W=10u L=1u
MnTa_L2_45_11 dpre_L3_28 vcn ctn_L2_45 0 NSYN W=10u L=1u
MpTb_L2_45_11 d1bar_L3 gp_3_28_15 ctn_L2_45 0 NSYN W=10u L=1u
MpTa_L2_45_12 dpre_L3_31 gp_3_31_15 ctp_L2_45 0 NSYN W=10u L=1u
MnTb_L2_45_12 d1bar_L3 vcn ctp_L2_45 0 NSYN W=10u L=1u
MnTa_L2_45_12 dpre_L3_31 vcn ctn_L2_45 0 NSYN W=10u L=1u
MpTb_L2_45_12 d1bar_L3 gp_3_31_15 ctn_L2_45 0 NSYN W=10u L=1u
MpTa_L2_45_13 dpre_L3_37 gp_3_37_14 ctp_L2_45 0 NSYN W=10u L=1u
MnTb_L2_45_13 d1bar_L3 vcn ctp_L2_45 0 NSYN W=10u L=1u
MnTa_L2_45_13 dpre_L3_37 vcn ctn_L2_45 0 NSYN W=10u L=1u
MpTb_L2_45_13 d1bar_L3 gp_3_37_14 ctn_L2_45 0 NSYN W=10u L=1u
MpTa_L2_45_14 dpre_L3_38 gp_3_38_14 ctp_L2_45 0 NSYN W=10u L=1u
MnTb_L2_45_14 d1bar_L3 vcn ctp_L2_45 0 NSYN W=10u L=1u
MnTa_L2_45_14 dpre_L3_38 vcn ctn_L2_45 0 NSYN W=10u L=1u
MpTb_L2_45_14 d1bar_L3 gp_3_38_14 ctn_L2_45 0 NSYN W=10u L=1u
MpTa_L2_45_15 dpre_L3_42 gp_3_42_15 ctp_L2_45 0 NSYN W=10u L=1u
MnTb_L2_45_15 d1bar_L3 vcn ctp_L2_45 0 NSYN W=10u L=1u
MnTa_L2_45_15 dpre_L3_42 vcn ctn_L2_45 0 NSYN W=10u L=1u
MpTb_L2_45_15 d1bar_L3 gp_3_42_15 ctn_L2_45 0 NSYN W=10u L=1u
Msa_bk_L2_45 ctn_L2_45 ctn_L2_45 0 0 NMIR W=20u L=1u
Msb_bk_L2_45 dpre_L2_45 ctn_L2_45 0 0 NMIR W=20u L=1u
Msc_bk_L2_45 ctp_L2_45 ctp_L2_45 0 0 NMIR W=20u L=1u
Msd_bk_L2_45 dpf_bk_L2_45 ctp_L2_45 0 0 NMIR W=20u L=1u
Mse_bk_L2_45 dpf_bk_L2_45 dpf_bk_L2_45 vdd vdd PMIR W=60u L=1u
Msf_bk_L2_45 dpre_L2_45 dpf_bk_L2_45 vdd vdd PMIR W=60u L=1u
R_bk_L2_45 dpre_L2_45 vrefd 16000.0
MpTa_L2_46_0 dpre_L3_2 gp_3_2_15 ctp_L2_46 0 NSYN W=10u L=1u
MnTb_L2_46_0 d1bar_L3 vcn ctp_L2_46 0 NSYN W=10u L=1u
MnTa_L2_46_0 dpre_L3_2 vcn ctn_L2_46 0 NSYN W=10u L=1u
MpTb_L2_46_0 d1bar_L3 gp_3_2_15 ctn_L2_46 0 NSYN W=10u L=1u
MpTa_L2_46_1 dpre_L3_3 gp_3_3_15 ctp_L2_46 0 NSYN W=10u L=1u
MnTb_L2_46_1 d1bar_L3 vcn ctp_L2_46 0 NSYN W=10u L=1u
MnTa_L2_46_1 dpre_L3_3 vcn ctn_L2_46 0 NSYN W=10u L=1u
MpTb_L2_46_1 d1bar_L3 gp_3_3_15 ctn_L2_46 0 NSYN W=10u L=1u
MpTa_L2_46_2 dpre_L3_7 gp_3_7_15 ctp_L2_46 0 NSYN W=10u L=1u
MnTb_L2_46_2 d1bar_L3 vcn ctp_L2_46 0 NSYN W=10u L=1u
MnTa_L2_46_2 dpre_L3_7 vcn ctn_L2_46 0 NSYN W=10u L=1u
MpTb_L2_46_2 d1bar_L3 gp_3_7_15 ctn_L2_46 0 NSYN W=10u L=1u
MpTa_L2_46_3 dpre_L3_10 gp_3_10_15 ctp_L2_46 0 NSYN W=10u L=1u
MnTb_L2_46_3 d1bar_L3 vcn ctp_L2_46 0 NSYN W=10u L=1u
MnTa_L2_46_3 dpre_L3_10 vcn ctn_L2_46 0 NSYN W=10u L=1u
MpTb_L2_46_3 d1bar_L3 gp_3_10_15 ctn_L2_46 0 NSYN W=10u L=1u
MpTa_L2_46_4 dpre_L3_12 gp_3_12_14 ctp_L2_46 0 NSYN W=10u L=1u
MnTb_L2_46_4 d1bar_L3 vcn ctp_L2_46 0 NSYN W=10u L=1u
MnTa_L2_46_4 dpre_L3_12 vcn ctn_L2_46 0 NSYN W=10u L=1u
MpTb_L2_46_4 d1bar_L3 gp_3_12_14 ctn_L2_46 0 NSYN W=10u L=1u
MpTa_L2_46_5 dpre_L3_15 gp_3_15_15 ctp_L2_46 0 NSYN W=10u L=1u
MnTb_L2_46_5 d1bar_L3 vcn ctp_L2_46 0 NSYN W=10u L=1u
MnTa_L2_46_5 dpre_L3_15 vcn ctn_L2_46 0 NSYN W=10u L=1u
MpTb_L2_46_5 d1bar_L3 gp_3_15_15 ctn_L2_46 0 NSYN W=10u L=1u
MpTa_L2_46_6 dpre_L3_16 gp_3_16_15 ctp_L2_46 0 NSYN W=10u L=1u
MnTb_L2_46_6 d1bar_L3 vcn ctp_L2_46 0 NSYN W=10u L=1u
MnTa_L2_46_6 dpre_L3_16 vcn ctn_L2_46 0 NSYN W=10u L=1u
MpTb_L2_46_6 d1bar_L3 gp_3_16_15 ctn_L2_46 0 NSYN W=10u L=1u
MpTa_L2_46_7 dpre_L3_22 gp_3_22_15 ctp_L2_46 0 NSYN W=10u L=1u
MnTb_L2_46_7 d1bar_L3 vcn ctp_L2_46 0 NSYN W=10u L=1u
MnTa_L2_46_7 dpre_L3_22 vcn ctn_L2_46 0 NSYN W=10u L=1u
MpTb_L2_46_7 d1bar_L3 gp_3_22_15 ctn_L2_46 0 NSYN W=10u L=1u
MpTa_L2_46_8 dpre_L3_24 gp_3_24_14 ctp_L2_46 0 NSYN W=10u L=1u
MnTb_L2_46_8 d1bar_L3 vcn ctp_L2_46 0 NSYN W=10u L=1u
MnTa_L2_46_8 dpre_L3_24 vcn ctn_L2_46 0 NSYN W=10u L=1u
MpTb_L2_46_8 d1bar_L3 gp_3_24_14 ctn_L2_46 0 NSYN W=10u L=1u
MpTa_L2_46_9 dpre_L3_33 gp_3_33_14 ctp_L2_46 0 NSYN W=10u L=1u
MnTb_L2_46_9 d1bar_L3 vcn ctp_L2_46 0 NSYN W=10u L=1u
MnTa_L2_46_9 dpre_L3_33 vcn ctn_L2_46 0 NSYN W=10u L=1u
MpTb_L2_46_9 d1bar_L3 gp_3_33_14 ctn_L2_46 0 NSYN W=10u L=1u
MpTa_L2_46_10 dpre_L3_34 gp_3_34_15 ctp_L2_46 0 NSYN W=10u L=1u
MnTb_L2_46_10 d1bar_L3 vcn ctp_L2_46 0 NSYN W=10u L=1u
MnTa_L2_46_10 dpre_L3_34 vcn ctn_L2_46 0 NSYN W=10u L=1u
MpTb_L2_46_10 d1bar_L3 gp_3_34_15 ctn_L2_46 0 NSYN W=10u L=1u
MpTa_L2_46_11 dpre_L3_35 gp_3_35_15 ctp_L2_46 0 NSYN W=10u L=1u
MnTb_L2_46_11 d1bar_L3 vcn ctp_L2_46 0 NSYN W=10u L=1u
MnTa_L2_46_11 dpre_L3_35 vcn ctn_L2_46 0 NSYN W=10u L=1u
MpTb_L2_46_11 d1bar_L3 gp_3_35_15 ctn_L2_46 0 NSYN W=10u L=1u
MpTa_L2_46_12 dpre_L3_36 gp_3_36_14 ctp_L2_46 0 NSYN W=10u L=1u
MnTb_L2_46_12 d1bar_L3 vcn ctp_L2_46 0 NSYN W=10u L=1u
MnTa_L2_46_12 dpre_L3_36 vcn ctn_L2_46 0 NSYN W=10u L=1u
MpTb_L2_46_12 d1bar_L3 gp_3_36_14 ctn_L2_46 0 NSYN W=10u L=1u
MpTa_L2_46_13 dpre_L3_37 gp_3_37_15 ctp_L2_46 0 NSYN W=10u L=1u
MnTb_L2_46_13 d1bar_L3 vcn ctp_L2_46 0 NSYN W=10u L=1u
MnTa_L2_46_13 dpre_L3_37 vcn ctn_L2_46 0 NSYN W=10u L=1u
MpTb_L2_46_13 d1bar_L3 gp_3_37_15 ctn_L2_46 0 NSYN W=10u L=1u
MpTa_L2_46_14 dpre_L3_38 gp_3_38_15 ctp_L2_46 0 NSYN W=10u L=1u
MnTb_L2_46_14 d1bar_L3 vcn ctp_L2_46 0 NSYN W=10u L=1u
MnTa_L2_46_14 dpre_L3_38 vcn ctn_L2_46 0 NSYN W=10u L=1u
MpTb_L2_46_14 d1bar_L3 gp_3_38_15 ctn_L2_46 0 NSYN W=10u L=1u
MpTa_L2_46_15 dpre_L3_39 gp_3_39_14 ctp_L2_46 0 NSYN W=10u L=1u
MnTb_L2_46_15 d1bar_L3 vcn ctp_L2_46 0 NSYN W=10u L=1u
MnTa_L2_46_15 dpre_L3_39 vcn ctn_L2_46 0 NSYN W=10u L=1u
MpTb_L2_46_15 d1bar_L3 gp_3_39_14 ctn_L2_46 0 NSYN W=10u L=1u
MpTa_L2_46_16 dpre_L3_41 gp_3_41_15 ctp_L2_46 0 NSYN W=10u L=1u
MnTb_L2_46_16 d1bar_L3 vcn ctp_L2_46 0 NSYN W=10u L=1u
MnTa_L2_46_16 dpre_L3_41 vcn ctn_L2_46 0 NSYN W=10u L=1u
MpTb_L2_46_16 d1bar_L3 gp_3_41_15 ctn_L2_46 0 NSYN W=10u L=1u
MpTa_L2_46_17 dpre_L3_44 gp_3_44_15 ctp_L2_46 0 NSYN W=10u L=1u
MnTb_L2_46_17 d1bar_L3 vcn ctp_L2_46 0 NSYN W=10u L=1u
MnTa_L2_46_17 dpre_L3_44 vcn ctn_L2_46 0 NSYN W=10u L=1u
MpTb_L2_46_17 d1bar_L3 gp_3_44_15 ctn_L2_46 0 NSYN W=10u L=1u
MpTa_L2_46_18 dpre_L3_45 gp_3_45_14 ctp_L2_46 0 NSYN W=10u L=1u
MnTb_L2_46_18 d1bar_L3 vcn ctp_L2_46 0 NSYN W=10u L=1u
MnTa_L2_46_18 dpre_L3_45 vcn ctn_L2_46 0 NSYN W=10u L=1u
MpTb_L2_46_18 d1bar_L3 gp_3_45_14 ctn_L2_46 0 NSYN W=10u L=1u
MpTa_L2_46_19 dpre_L3_46 gp_3_46_15 ctp_L2_46 0 NSYN W=10u L=1u
MnTb_L2_46_19 d1bar_L3 vcn ctp_L2_46 0 NSYN W=10u L=1u
MnTa_L2_46_19 dpre_L3_46 vcn ctn_L2_46 0 NSYN W=10u L=1u
MpTb_L2_46_19 d1bar_L3 gp_3_46_15 ctn_L2_46 0 NSYN W=10u L=1u
Msa_bk_L2_46 ctn_L2_46 ctn_L2_46 0 0 NMIR W=20u L=1u
Msb_bk_L2_46 dpre_L2_46 ctn_L2_46 0 0 NMIR W=20u L=1u
Msc_bk_L2_46 ctp_L2_46 ctp_L2_46 0 0 NMIR W=20u L=1u
Msd_bk_L2_46 dpf_bk_L2_46 ctp_L2_46 0 0 NMIR W=20u L=1u
Mse_bk_L2_46 dpf_bk_L2_46 dpf_bk_L2_46 vdd vdd PMIR W=60u L=1u
Msf_bk_L2_46 dpre_L2_46 dpf_bk_L2_46 vdd vdd PMIR W=60u L=1u
R_bk_L2_46 dpre_L2_46 vrefd 16000.0
MpTa_L2_47_0 dpre_L3_0 gp_3_0_15 ctp_L2_47 0 NSYN W=10u L=1u
MnTb_L2_47_0 d1bar_L3 vcn ctp_L2_47 0 NSYN W=10u L=1u
MnTa_L2_47_0 dpre_L3_0 vcn ctn_L2_47 0 NSYN W=10u L=1u
MpTb_L2_47_0 d1bar_L3 gp_3_0_15 ctn_L2_47 0 NSYN W=10u L=1u
MpTa_L2_47_1 dpre_L3_1 gp_3_1_15 ctp_L2_47 0 NSYN W=10u L=1u
MnTb_L2_47_1 d1bar_L3 vcn ctp_L2_47 0 NSYN W=10u L=1u
MnTa_L2_47_1 dpre_L3_1 vcn ctn_L2_47 0 NSYN W=10u L=1u
MpTb_L2_47_1 d1bar_L3 gp_3_1_15 ctn_L2_47 0 NSYN W=10u L=1u
MpTa_L2_47_2 dpre_L3_4 gp_3_4_15 ctp_L2_47 0 NSYN W=10u L=1u
MnTb_L2_47_2 d1bar_L3 vcn ctp_L2_47 0 NSYN W=10u L=1u
MnTa_L2_47_2 dpre_L3_4 vcn ctn_L2_47 0 NSYN W=10u L=1u
MpTb_L2_47_2 d1bar_L3 gp_3_4_15 ctn_L2_47 0 NSYN W=10u L=1u
MpTa_L2_47_3 dpre_L3_5 gp_3_5_15 ctp_L2_47 0 NSYN W=10u L=1u
MnTb_L2_47_3 d1bar_L3 vcn ctp_L2_47 0 NSYN W=10u L=1u
MnTa_L2_47_3 dpre_L3_5 vcn ctn_L2_47 0 NSYN W=10u L=1u
MpTb_L2_47_3 d1bar_L3 gp_3_5_15 ctn_L2_47 0 NSYN W=10u L=1u
MpTa_L2_47_4 dpre_L3_9 gp_3_9_15 ctp_L2_47 0 NSYN W=10u L=1u
MnTb_L2_47_4 d1bar_L3 vcn ctp_L2_47 0 NSYN W=10u L=1u
MnTa_L2_47_4 dpre_L3_9 vcn ctn_L2_47 0 NSYN W=10u L=1u
MpTb_L2_47_4 d1bar_L3 gp_3_9_15 ctn_L2_47 0 NSYN W=10u L=1u
MpTa_L2_47_5 dpre_L3_12 gp_3_12_15 ctp_L2_47 0 NSYN W=10u L=1u
MnTb_L2_47_5 d1bar_L3 vcn ctp_L2_47 0 NSYN W=10u L=1u
MnTa_L2_47_5 dpre_L3_12 vcn ctn_L2_47 0 NSYN W=10u L=1u
MpTb_L2_47_5 d1bar_L3 gp_3_12_15 ctn_L2_47 0 NSYN W=10u L=1u
MpTa_L2_47_6 dpre_L3_19 gp_3_19_15 ctp_L2_47 0 NSYN W=10u L=1u
MnTb_L2_47_6 d1bar_L3 vcn ctp_L2_47 0 NSYN W=10u L=1u
MnTa_L2_47_6 dpre_L3_19 vcn ctn_L2_47 0 NSYN W=10u L=1u
MpTb_L2_47_6 d1bar_L3 gp_3_19_15 ctn_L2_47 0 NSYN W=10u L=1u
MpTa_L2_47_7 dpre_L3_21 gp_3_21_15 ctp_L2_47 0 NSYN W=10u L=1u
MnTb_L2_47_7 d1bar_L3 vcn ctp_L2_47 0 NSYN W=10u L=1u
MnTa_L2_47_7 dpre_L3_21 vcn ctn_L2_47 0 NSYN W=10u L=1u
MpTb_L2_47_7 d1bar_L3 gp_3_21_15 ctn_L2_47 0 NSYN W=10u L=1u
MpTa_L2_47_8 dpre_L3_23 gp_3_23_15 ctp_L2_47 0 NSYN W=10u L=1u
MnTb_L2_47_8 d1bar_L3 vcn ctp_L2_47 0 NSYN W=10u L=1u
MnTa_L2_47_8 dpre_L3_23 vcn ctn_L2_47 0 NSYN W=10u L=1u
MpTb_L2_47_8 d1bar_L3 gp_3_23_15 ctn_L2_47 0 NSYN W=10u L=1u
MpTa_L2_47_9 dpre_L3_24 gp_3_24_15 ctp_L2_47 0 NSYN W=10u L=1u
MnTb_L2_47_9 d1bar_L3 vcn ctp_L2_47 0 NSYN W=10u L=1u
MnTa_L2_47_9 dpre_L3_24 vcn ctn_L2_47 0 NSYN W=10u L=1u
MpTb_L2_47_9 d1bar_L3 gp_3_24_15 ctn_L2_47 0 NSYN W=10u L=1u
MpTa_L2_47_10 dpre_L3_25 gp_3_25_15 ctp_L2_47 0 NSYN W=10u L=1u
MnTb_L2_47_10 d1bar_L3 vcn ctp_L2_47 0 NSYN W=10u L=1u
MnTa_L2_47_10 dpre_L3_25 vcn ctn_L2_47 0 NSYN W=10u L=1u
MpTb_L2_47_10 d1bar_L3 gp_3_25_15 ctn_L2_47 0 NSYN W=10u L=1u
MpTa_L2_47_11 dpre_L3_30 gp_3_30_15 ctp_L2_47 0 NSYN W=10u L=1u
MnTb_L2_47_11 d1bar_L3 vcn ctp_L2_47 0 NSYN W=10u L=1u
MnTa_L2_47_11 dpre_L3_30 vcn ctn_L2_47 0 NSYN W=10u L=1u
MpTb_L2_47_11 d1bar_L3 gp_3_30_15 ctn_L2_47 0 NSYN W=10u L=1u
MpTa_L2_47_12 dpre_L3_33 gp_3_33_15 ctp_L2_47 0 NSYN W=10u L=1u
MnTb_L2_47_12 d1bar_L3 vcn ctp_L2_47 0 NSYN W=10u L=1u
MnTa_L2_47_12 dpre_L3_33 vcn ctn_L2_47 0 NSYN W=10u L=1u
MpTb_L2_47_12 d1bar_L3 gp_3_33_15 ctn_L2_47 0 NSYN W=10u L=1u
MpTa_L2_47_13 dpre_L3_36 gp_3_36_15 ctp_L2_47 0 NSYN W=10u L=1u
MnTb_L2_47_13 d1bar_L3 vcn ctp_L2_47 0 NSYN W=10u L=1u
MnTa_L2_47_13 dpre_L3_36 vcn ctn_L2_47 0 NSYN W=10u L=1u
MpTb_L2_47_13 d1bar_L3 gp_3_36_15 ctn_L2_47 0 NSYN W=10u L=1u
MpTa_L2_47_14 dpre_L3_39 gp_3_39_15 ctp_L2_47 0 NSYN W=10u L=1u
MnTb_L2_47_14 d1bar_L3 vcn ctp_L2_47 0 NSYN W=10u L=1u
MnTa_L2_47_14 dpre_L3_39 vcn ctn_L2_47 0 NSYN W=10u L=1u
MpTb_L2_47_14 d1bar_L3 gp_3_39_15 ctn_L2_47 0 NSYN W=10u L=1u
MpTa_L2_47_15 dpre_L3_45 gp_3_45_15 ctp_L2_47 0 NSYN W=10u L=1u
MnTb_L2_47_15 d1bar_L3 vcn ctp_L2_47 0 NSYN W=10u L=1u
MnTa_L2_47_15 dpre_L3_45 vcn ctn_L2_47 0 NSYN W=10u L=1u
MpTb_L2_47_15 d1bar_L3 gp_3_45_15 ctn_L2_47 0 NSYN W=10u L=1u
Msa_bk_L2_47 ctn_L2_47 ctn_L2_47 0 0 NMIR W=20u L=1u
Msb_bk_L2_47 dpre_L2_47 ctn_L2_47 0 0 NMIR W=20u L=1u
Msc_bk_L2_47 ctp_L2_47 ctp_L2_47 0 0 NMIR W=20u L=1u
Msd_bk_L2_47 dpf_bk_L2_47 ctp_L2_47 0 0 NMIR W=20u L=1u
Mse_bk_L2_47 dpf_bk_L2_47 dpf_bk_L2_47 vdd vdd PMIR W=60u L=1u
Msf_bk_L2_47 dpre_L2_47 dpf_bk_L2_47 vdd vdd PMIR W=60u L=1u
R_bk_L2_47 dpre_L2_47 vrefd 16000.0
Rcm_L2_0 dpre_L2_0 d1bar_L2 10000.0
Rcm_L2_1 dpre_L2_1 d1bar_L2 10000.0
Rcm_L2_2 dpre_L2_2 d1bar_L2 10000.0
Rcm_L2_3 dpre_L2_3 d1bar_L2 10000.0
Rcm_L2_4 dpre_L2_4 d1bar_L2 10000.0
Rcm_L2_5 dpre_L2_5 d1bar_L2 10000.0
Rcm_L2_6 dpre_L2_6 d1bar_L2 10000.0
Rcm_L2_7 dpre_L2_7 d1bar_L2 10000.0
Rcm_L2_8 dpre_L2_8 d1bar_L2 10000.0
Rcm_L2_9 dpre_L2_9 d1bar_L2 10000.0
Rcm_L2_10 dpre_L2_10 d1bar_L2 10000.0
Rcm_L2_11 dpre_L2_11 d1bar_L2 10000.0
Rcm_L2_12 dpre_L2_12 d1bar_L2 10000.0
Rcm_L2_13 dpre_L2_13 d1bar_L2 10000.0
Rcm_L2_14 dpre_L2_14 d1bar_L2 10000.0
Rcm_L2_15 dpre_L2_15 d1bar_L2 10000.0
Rcm_L2_16 dpre_L2_16 d1bar_L2 10000.0
Rcm_L2_17 dpre_L2_17 d1bar_L2 10000.0
Rcm_L2_18 dpre_L2_18 d1bar_L2 10000.0
Rcm_L2_19 dpre_L2_19 d1bar_L2 10000.0
Rcm_L2_20 dpre_L2_20 d1bar_L2 10000.0
Rcm_L2_21 dpre_L2_21 d1bar_L2 10000.0
Rcm_L2_22 dpre_L2_22 d1bar_L2 10000.0
Rcm_L2_23 dpre_L2_23 d1bar_L2 10000.0
Rcm_L2_24 dpre_L2_24 d1bar_L2 10000.0
Rcm_L2_25 dpre_L2_25 d1bar_L2 10000.0
Rcm_L2_26 dpre_L2_26 d1bar_L2 10000.0
Rcm_L2_27 dpre_L2_27 d1bar_L2 10000.0
Rcm_L2_28 dpre_L2_28 d1bar_L2 10000.0
Rcm_L2_29 dpre_L2_29 d1bar_L2 10000.0
Rcm_L2_30 dpre_L2_30 d1bar_L2 10000.0
Rcm_L2_31 dpre_L2_31 d1bar_L2 10000.0
Rcm_L2_32 dpre_L2_32 d1bar_L2 10000.0
Rcm_L2_33 dpre_L2_33 d1bar_L2 10000.0
Rcm_L2_34 dpre_L2_34 d1bar_L2 10000.0
Rcm_L2_35 dpre_L2_35 d1bar_L2 10000.0
Rcm_L2_36 dpre_L2_36 d1bar_L2 10000.0
Rcm_L2_37 dpre_L2_37 d1bar_L2 10000.0
Rcm_L2_38 dpre_L2_38 d1bar_L2 10000.0
Rcm_L2_39 dpre_L2_39 d1bar_L2 10000.0
Rcm_L2_40 dpre_L2_40 d1bar_L2 10000.0
Rcm_L2_41 dpre_L2_41 d1bar_L2 10000.0
Rcm_L2_42 dpre_L2_42 d1bar_L2 10000.0
Rcm_L2_43 dpre_L2_43 d1bar_L2 10000.0
Rcm_L2_44 dpre_L2_44 d1bar_L2 10000.0
Rcm_L2_45 dpre_L2_45 d1bar_L2 10000.0
Rcm_L2_46 dpre_L2_46 d1bar_L2 10000.0
Rcm_L2_47 dpre_L2_47 d1bar_L2 10000.0
Ccm_L2 d1bar_L2 0 50f
Mt_uU_L2_0_0 ts_uU_L2_0_0 hv_L1_4 0 0 NMIR W=48.0u L=1u
Mo1_uU_L2_0_0 da_uU_L2_0_0 d1bar_L2 ts_uU_L2_0_0 0 NMIR W=20u L=1u
Mo2_uU_L2_0_0 gp_2_0_0 dpre_L2_0 ts_uU_L2_0_0 0 NMIR W=20u L=1u
Mo3_uU_L2_0_0 da_uU_L2_0_0 da_uU_L2_0_0 vdd vdd PMIR W=60u L=1u
Mo4_uU_L2_0_0 gp_2_0_0 da_uU_L2_0_0 vdd vdd PMIR W=60u L=1u
Mt_uU_L2_0_1 ts_uU_L2_0_1 hv_L1_6 0 0 NMIR W=48.0u L=1u
Mo1_uU_L2_0_1 da_uU_L2_0_1 d1bar_L2 ts_uU_L2_0_1 0 NMIR W=20u L=1u
Mo2_uU_L2_0_1 gp_2_0_1 dpre_L2_0 ts_uU_L2_0_1 0 NMIR W=20u L=1u
Mo3_uU_L2_0_1 da_uU_L2_0_1 da_uU_L2_0_1 vdd vdd PMIR W=60u L=1u
Mo4_uU_L2_0_1 gp_2_0_1 da_uU_L2_0_1 vdd vdd PMIR W=60u L=1u
Mt_uU_L2_0_2 ts_uU_L2_0_2 hv_L1_10 0 0 NMIR W=48.0u L=1u
Mo1_uU_L2_0_2 da_uU_L2_0_2 d1bar_L2 ts_uU_L2_0_2 0 NMIR W=20u L=1u
Mo2_uU_L2_0_2 gp_2_0_2 dpre_L2_0 ts_uU_L2_0_2 0 NMIR W=20u L=1u
Mo3_uU_L2_0_2 da_uU_L2_0_2 da_uU_L2_0_2 vdd vdd PMIR W=60u L=1u
Mo4_uU_L2_0_2 gp_2_0_2 da_uU_L2_0_2 vdd vdd PMIR W=60u L=1u
Mt_uU_L2_0_3 ts_uU_L2_0_3 hv_L1_12 0 0 NMIR W=48.0u L=1u
Mo1_uU_L2_0_3 da_uU_L2_0_3 d1bar_L2 ts_uU_L2_0_3 0 NMIR W=20u L=1u
Mo2_uU_L2_0_3 gp_2_0_3 dpre_L2_0 ts_uU_L2_0_3 0 NMIR W=20u L=1u
Mo3_uU_L2_0_3 da_uU_L2_0_3 da_uU_L2_0_3 vdd vdd PMIR W=60u L=1u
Mo4_uU_L2_0_3 gp_2_0_3 da_uU_L2_0_3 vdd vdd PMIR W=60u L=1u
Mt_uU_L2_0_4 ts_uU_L2_0_4 hv_L1_15 0 0 NMIR W=48.0u L=1u
Mo1_uU_L2_0_4 da_uU_L2_0_4 d1bar_L2 ts_uU_L2_0_4 0 NMIR W=20u L=1u
Mo2_uU_L2_0_4 gp_2_0_4 dpre_L2_0 ts_uU_L2_0_4 0 NMIR W=20u L=1u
Mo3_uU_L2_0_4 da_uU_L2_0_4 da_uU_L2_0_4 vdd vdd PMIR W=60u L=1u
Mo4_uU_L2_0_4 gp_2_0_4 da_uU_L2_0_4 vdd vdd PMIR W=60u L=1u
Mt_uU_L2_0_5 ts_uU_L2_0_5 hv_L1_17 0 0 NMIR W=48.0u L=1u
Mo1_uU_L2_0_5 da_uU_L2_0_5 d1bar_L2 ts_uU_L2_0_5 0 NMIR W=20u L=1u
Mo2_uU_L2_0_5 gp_2_0_5 dpre_L2_0 ts_uU_L2_0_5 0 NMIR W=20u L=1u
Mo3_uU_L2_0_5 da_uU_L2_0_5 da_uU_L2_0_5 vdd vdd PMIR W=60u L=1u
Mo4_uU_L2_0_5 gp_2_0_5 da_uU_L2_0_5 vdd vdd PMIR W=60u L=1u
Mt_uU_L2_0_6 ts_uU_L2_0_6 hv_L1_23 0 0 NMIR W=48.0u L=1u
Mo1_uU_L2_0_6 da_uU_L2_0_6 d1bar_L2 ts_uU_L2_0_6 0 NMIR W=20u L=1u
Mo2_uU_L2_0_6 gp_2_0_6 dpre_L2_0 ts_uU_L2_0_6 0 NMIR W=20u L=1u
Mo3_uU_L2_0_6 da_uU_L2_0_6 da_uU_L2_0_6 vdd vdd PMIR W=60u L=1u
Mo4_uU_L2_0_6 gp_2_0_6 da_uU_L2_0_6 vdd vdd PMIR W=60u L=1u
Mt_uU_L2_0_7 ts_uU_L2_0_7 hv_L1_24 0 0 NMIR W=48.0u L=1u
Mo1_uU_L2_0_7 da_uU_L2_0_7 d1bar_L2 ts_uU_L2_0_7 0 NMIR W=20u L=1u
Mo2_uU_L2_0_7 gp_2_0_7 dpre_L2_0 ts_uU_L2_0_7 0 NMIR W=20u L=1u
Mo3_uU_L2_0_7 da_uU_L2_0_7 da_uU_L2_0_7 vdd vdd PMIR W=60u L=1u
Mo4_uU_L2_0_7 gp_2_0_7 da_uU_L2_0_7 vdd vdd PMIR W=60u L=1u
Mt_uU_L2_0_8 ts_uU_L2_0_8 hv_L1_25 0 0 NMIR W=48.0u L=1u
Mo1_uU_L2_0_8 da_uU_L2_0_8 d1bar_L2 ts_uU_L2_0_8 0 NMIR W=20u L=1u
Mo2_uU_L2_0_8 gp_2_0_8 dpre_L2_0 ts_uU_L2_0_8 0 NMIR W=20u L=1u
Mo3_uU_L2_0_8 da_uU_L2_0_8 da_uU_L2_0_8 vdd vdd PMIR W=60u L=1u
Mo4_uU_L2_0_8 gp_2_0_8 da_uU_L2_0_8 vdd vdd PMIR W=60u L=1u
Mt_uU_L2_0_9 ts_uU_L2_0_9 hv_L1_29 0 0 NMIR W=48.0u L=1u
Mo1_uU_L2_0_9 da_uU_L2_0_9 d1bar_L2 ts_uU_L2_0_9 0 NMIR W=20u L=1u
Mo2_uU_L2_0_9 gp_2_0_9 dpre_L2_0 ts_uU_L2_0_9 0 NMIR W=20u L=1u
Mo3_uU_L2_0_9 da_uU_L2_0_9 da_uU_L2_0_9 vdd vdd PMIR W=60u L=1u
Mo4_uU_L2_0_9 gp_2_0_9 da_uU_L2_0_9 vdd vdd PMIR W=60u L=1u
Mt_uU_L2_0_10 ts_uU_L2_0_10 hv_L1_32 0 0 NMIR W=48.0u L=1u
Mo1_uU_L2_0_10 da_uU_L2_0_10 d1bar_L2 ts_uU_L2_0_10 0 NMIR W=20u L=1u
Mo2_uU_L2_0_10 gp_2_0_10 dpre_L2_0 ts_uU_L2_0_10 0 NMIR W=20u L=1u
Mo3_uU_L2_0_10 da_uU_L2_0_10 da_uU_L2_0_10 vdd vdd PMIR W=60u L=1u
Mo4_uU_L2_0_10 gp_2_0_10 da_uU_L2_0_10 vdd vdd PMIR W=60u L=1u
Mt_uU_L2_0_11 ts_uU_L2_0_11 hv_L1_34 0 0 NMIR W=48.0u L=1u
Mo1_uU_L2_0_11 da_uU_L2_0_11 d1bar_L2 ts_uU_L2_0_11 0 NMIR W=20u L=1u
Mo2_uU_L2_0_11 gp_2_0_11 dpre_L2_0 ts_uU_L2_0_11 0 NMIR W=20u L=1u
Mo3_uU_L2_0_11 da_uU_L2_0_11 da_uU_L2_0_11 vdd vdd PMIR W=60u L=1u
Mo4_uU_L2_0_11 gp_2_0_11 da_uU_L2_0_11 vdd vdd PMIR W=60u L=1u
Mt_uU_L2_0_12 ts_uU_L2_0_12 hv_L1_39 0 0 NMIR W=48.0u L=1u
Mo1_uU_L2_0_12 da_uU_L2_0_12 d1bar_L2 ts_uU_L2_0_12 0 NMIR W=20u L=1u
Mo2_uU_L2_0_12 gp_2_0_12 dpre_L2_0 ts_uU_L2_0_12 0 NMIR W=20u L=1u
Mo3_uU_L2_0_12 da_uU_L2_0_12 da_uU_L2_0_12 vdd vdd PMIR W=60u L=1u
Mo4_uU_L2_0_12 gp_2_0_12 da_uU_L2_0_12 vdd vdd PMIR W=60u L=1u
Mt_uU_L2_0_13 ts_uU_L2_0_13 hv_L1_40 0 0 NMIR W=48.0u L=1u
Mo1_uU_L2_0_13 da_uU_L2_0_13 d1bar_L2 ts_uU_L2_0_13 0 NMIR W=20u L=1u
Mo2_uU_L2_0_13 gp_2_0_13 dpre_L2_0 ts_uU_L2_0_13 0 NMIR W=20u L=1u
Mo3_uU_L2_0_13 da_uU_L2_0_13 da_uU_L2_0_13 vdd vdd PMIR W=60u L=1u
Mo4_uU_L2_0_13 gp_2_0_13 da_uU_L2_0_13 vdd vdd PMIR W=60u L=1u
Mt_uU_L2_0_14 ts_uU_L2_0_14 hv_L1_41 0 0 NMIR W=48.0u L=1u
Mo1_uU_L2_0_14 da_uU_L2_0_14 d1bar_L2 ts_uU_L2_0_14 0 NMIR W=20u L=1u
Mo2_uU_L2_0_14 gp_2_0_14 dpre_L2_0 ts_uU_L2_0_14 0 NMIR W=20u L=1u
Mo3_uU_L2_0_14 da_uU_L2_0_14 da_uU_L2_0_14 vdd vdd PMIR W=60u L=1u
Mo4_uU_L2_0_14 gp_2_0_14 da_uU_L2_0_14 vdd vdd PMIR W=60u L=1u
Mt_uU_L2_0_15 ts_uU_L2_0_15 hv_L1_42 0 0 NMIR W=48.0u L=1u
Mo1_uU_L2_0_15 da_uU_L2_0_15 d1bar_L2 ts_uU_L2_0_15 0 NMIR W=20u L=1u
Mo2_uU_L2_0_15 gp_2_0_15 dpre_L2_0 ts_uU_L2_0_15 0 NMIR W=20u L=1u
Mo3_uU_L2_0_15 da_uU_L2_0_15 da_uU_L2_0_15 vdd vdd PMIR W=60u L=1u
Mo4_uU_L2_0_15 gp_2_0_15 da_uU_L2_0_15 vdd vdd PMIR W=60u L=1u
Mt_uU_L2_1_0 ts_uU_L2_1_0 hv_L1_1 0 0 NMIR W=48.0u L=1u
Mo1_uU_L2_1_0 da_uU_L2_1_0 d1bar_L2 ts_uU_L2_1_0 0 NMIR W=20u L=1u
Mo2_uU_L2_1_0 gp_2_1_0 dpre_L2_1 ts_uU_L2_1_0 0 NMIR W=20u L=1u
Mo3_uU_L2_1_0 da_uU_L2_1_0 da_uU_L2_1_0 vdd vdd PMIR W=60u L=1u
Mo4_uU_L2_1_0 gp_2_1_0 da_uU_L2_1_0 vdd vdd PMIR W=60u L=1u
Mt_uU_L2_1_1 ts_uU_L2_1_1 hv_L1_2 0 0 NMIR W=48.0u L=1u
Mo1_uU_L2_1_1 da_uU_L2_1_1 d1bar_L2 ts_uU_L2_1_1 0 NMIR W=20u L=1u
Mo2_uU_L2_1_1 gp_2_1_1 dpre_L2_1 ts_uU_L2_1_1 0 NMIR W=20u L=1u
Mo3_uU_L2_1_1 da_uU_L2_1_1 da_uU_L2_1_1 vdd vdd PMIR W=60u L=1u
Mo4_uU_L2_1_1 gp_2_1_1 da_uU_L2_1_1 vdd vdd PMIR W=60u L=1u
Mt_uU_L2_1_2 ts_uU_L2_1_2 hv_L1_13 0 0 NMIR W=48.0u L=1u
Mo1_uU_L2_1_2 da_uU_L2_1_2 d1bar_L2 ts_uU_L2_1_2 0 NMIR W=20u L=1u
Mo2_uU_L2_1_2 gp_2_1_2 dpre_L2_1 ts_uU_L2_1_2 0 NMIR W=20u L=1u
Mo3_uU_L2_1_2 da_uU_L2_1_2 da_uU_L2_1_2 vdd vdd PMIR W=60u L=1u
Mo4_uU_L2_1_2 gp_2_1_2 da_uU_L2_1_2 vdd vdd PMIR W=60u L=1u
Mt_uU_L2_1_3 ts_uU_L2_1_3 hv_L1_14 0 0 NMIR W=48.0u L=1u
Mo1_uU_L2_1_3 da_uU_L2_1_3 d1bar_L2 ts_uU_L2_1_3 0 NMIR W=20u L=1u
Mo2_uU_L2_1_3 gp_2_1_3 dpre_L2_1 ts_uU_L2_1_3 0 NMIR W=20u L=1u
Mo3_uU_L2_1_3 da_uU_L2_1_3 da_uU_L2_1_3 vdd vdd PMIR W=60u L=1u
Mo4_uU_L2_1_3 gp_2_1_3 da_uU_L2_1_3 vdd vdd PMIR W=60u L=1u
Mt_uU_L2_1_4 ts_uU_L2_1_4 hv_L1_16 0 0 NMIR W=48.0u L=1u
Mo1_uU_L2_1_4 da_uU_L2_1_4 d1bar_L2 ts_uU_L2_1_4 0 NMIR W=20u L=1u
Mo2_uU_L2_1_4 gp_2_1_4 dpre_L2_1 ts_uU_L2_1_4 0 NMIR W=20u L=1u
Mo3_uU_L2_1_4 da_uU_L2_1_4 da_uU_L2_1_4 vdd vdd PMIR W=60u L=1u
Mo4_uU_L2_1_4 gp_2_1_4 da_uU_L2_1_4 vdd vdd PMIR W=60u L=1u
Mt_uU_L2_1_5 ts_uU_L2_1_5 hv_L1_17 0 0 NMIR W=48.0u L=1u
Mo1_uU_L2_1_5 da_uU_L2_1_5 d1bar_L2 ts_uU_L2_1_5 0 NMIR W=20u L=1u
Mo2_uU_L2_1_5 gp_2_1_5 dpre_L2_1 ts_uU_L2_1_5 0 NMIR W=20u L=1u
Mo3_uU_L2_1_5 da_uU_L2_1_5 da_uU_L2_1_5 vdd vdd PMIR W=60u L=1u
Mo4_uU_L2_1_5 gp_2_1_5 da_uU_L2_1_5 vdd vdd PMIR W=60u L=1u
Mt_uU_L2_1_6 ts_uU_L2_1_6 hv_L1_18 0 0 NMIR W=48.0u L=1u
Mo1_uU_L2_1_6 da_uU_L2_1_6 d1bar_L2 ts_uU_L2_1_6 0 NMIR W=20u L=1u
Mo2_uU_L2_1_6 gp_2_1_6 dpre_L2_1 ts_uU_L2_1_6 0 NMIR W=20u L=1u
Mo3_uU_L2_1_6 da_uU_L2_1_6 da_uU_L2_1_6 vdd vdd PMIR W=60u L=1u
Mo4_uU_L2_1_6 gp_2_1_6 da_uU_L2_1_6 vdd vdd PMIR W=60u L=1u
Mt_uU_L2_1_7 ts_uU_L2_1_7 hv_L1_19 0 0 NMIR W=48.0u L=1u
Mo1_uU_L2_1_7 da_uU_L2_1_7 d1bar_L2 ts_uU_L2_1_7 0 NMIR W=20u L=1u
Mo2_uU_L2_1_7 gp_2_1_7 dpre_L2_1 ts_uU_L2_1_7 0 NMIR W=20u L=1u
Mo3_uU_L2_1_7 da_uU_L2_1_7 da_uU_L2_1_7 vdd vdd PMIR W=60u L=1u
Mo4_uU_L2_1_7 gp_2_1_7 da_uU_L2_1_7 vdd vdd PMIR W=60u L=1u
Mt_uU_L2_1_8 ts_uU_L2_1_8 hv_L1_21 0 0 NMIR W=48.0u L=1u
Mo1_uU_L2_1_8 da_uU_L2_1_8 d1bar_L2 ts_uU_L2_1_8 0 NMIR W=20u L=1u
Mo2_uU_L2_1_8 gp_2_1_8 dpre_L2_1 ts_uU_L2_1_8 0 NMIR W=20u L=1u
Mo3_uU_L2_1_8 da_uU_L2_1_8 da_uU_L2_1_8 vdd vdd PMIR W=60u L=1u
Mo4_uU_L2_1_8 gp_2_1_8 da_uU_L2_1_8 vdd vdd PMIR W=60u L=1u
Mt_uU_L2_1_9 ts_uU_L2_1_9 hv_L1_25 0 0 NMIR W=48.0u L=1u
Mo1_uU_L2_1_9 da_uU_L2_1_9 d1bar_L2 ts_uU_L2_1_9 0 NMIR W=20u L=1u
Mo2_uU_L2_1_9 gp_2_1_9 dpre_L2_1 ts_uU_L2_1_9 0 NMIR W=20u L=1u
Mo3_uU_L2_1_9 da_uU_L2_1_9 da_uU_L2_1_9 vdd vdd PMIR W=60u L=1u
Mo4_uU_L2_1_9 gp_2_1_9 da_uU_L2_1_9 vdd vdd PMIR W=60u L=1u
Mt_uU_L2_1_10 ts_uU_L2_1_10 hv_L1_33 0 0 NMIR W=48.0u L=1u
Mo1_uU_L2_1_10 da_uU_L2_1_10 d1bar_L2 ts_uU_L2_1_10 0 NMIR W=20u L=1u
Mo2_uU_L2_1_10 gp_2_1_10 dpre_L2_1 ts_uU_L2_1_10 0 NMIR W=20u L=1u
Mo3_uU_L2_1_10 da_uU_L2_1_10 da_uU_L2_1_10 vdd vdd PMIR W=60u L=1u
Mo4_uU_L2_1_10 gp_2_1_10 da_uU_L2_1_10 vdd vdd PMIR W=60u L=1u
Mt_uU_L2_1_11 ts_uU_L2_1_11 hv_L1_36 0 0 NMIR W=48.0u L=1u
Mo1_uU_L2_1_11 da_uU_L2_1_11 d1bar_L2 ts_uU_L2_1_11 0 NMIR W=20u L=1u
Mo2_uU_L2_1_11 gp_2_1_11 dpre_L2_1 ts_uU_L2_1_11 0 NMIR W=20u L=1u
Mo3_uU_L2_1_11 da_uU_L2_1_11 da_uU_L2_1_11 vdd vdd PMIR W=60u L=1u
Mo4_uU_L2_1_11 gp_2_1_11 da_uU_L2_1_11 vdd vdd PMIR W=60u L=1u
Mt_uU_L2_1_12 ts_uU_L2_1_12 hv_L1_40 0 0 NMIR W=48.0u L=1u
Mo1_uU_L2_1_12 da_uU_L2_1_12 d1bar_L2 ts_uU_L2_1_12 0 NMIR W=20u L=1u
Mo2_uU_L2_1_12 gp_2_1_12 dpre_L2_1 ts_uU_L2_1_12 0 NMIR W=20u L=1u
Mo3_uU_L2_1_12 da_uU_L2_1_12 da_uU_L2_1_12 vdd vdd PMIR W=60u L=1u
Mo4_uU_L2_1_12 gp_2_1_12 da_uU_L2_1_12 vdd vdd PMIR W=60u L=1u
Mt_uU_L2_1_13 ts_uU_L2_1_13 hv_L1_41 0 0 NMIR W=48.0u L=1u
Mo1_uU_L2_1_13 da_uU_L2_1_13 d1bar_L2 ts_uU_L2_1_13 0 NMIR W=20u L=1u
Mo2_uU_L2_1_13 gp_2_1_13 dpre_L2_1 ts_uU_L2_1_13 0 NMIR W=20u L=1u
Mo3_uU_L2_1_13 da_uU_L2_1_13 da_uU_L2_1_13 vdd vdd PMIR W=60u L=1u
Mo4_uU_L2_1_13 gp_2_1_13 da_uU_L2_1_13 vdd vdd PMIR W=60u L=1u
Mt_uU_L2_1_14 ts_uU_L2_1_14 hv_L1_45 0 0 NMIR W=48.0u L=1u
Mo1_uU_L2_1_14 da_uU_L2_1_14 d1bar_L2 ts_uU_L2_1_14 0 NMIR W=20u L=1u
Mo2_uU_L2_1_14 gp_2_1_14 dpre_L2_1 ts_uU_L2_1_14 0 NMIR W=20u L=1u
Mo3_uU_L2_1_14 da_uU_L2_1_14 da_uU_L2_1_14 vdd vdd PMIR W=60u L=1u
Mo4_uU_L2_1_14 gp_2_1_14 da_uU_L2_1_14 vdd vdd PMIR W=60u L=1u
Mt_uU_L2_1_15 ts_uU_L2_1_15 hv_L1_46 0 0 NMIR W=48.0u L=1u
Mo1_uU_L2_1_15 da_uU_L2_1_15 d1bar_L2 ts_uU_L2_1_15 0 NMIR W=20u L=1u
Mo2_uU_L2_1_15 gp_2_1_15 dpre_L2_1 ts_uU_L2_1_15 0 NMIR W=20u L=1u
Mo3_uU_L2_1_15 da_uU_L2_1_15 da_uU_L2_1_15 vdd vdd PMIR W=60u L=1u
Mo4_uU_L2_1_15 gp_2_1_15 da_uU_L2_1_15 vdd vdd PMIR W=60u L=1u
Mt_uU_L2_2_0 ts_uU_L2_2_0 hv_L1_3 0 0 NMIR W=48.0u L=1u
Mo1_uU_L2_2_0 da_uU_L2_2_0 d1bar_L2 ts_uU_L2_2_0 0 NMIR W=20u L=1u
Mo2_uU_L2_2_0 gp_2_2_0 dpre_L2_2 ts_uU_L2_2_0 0 NMIR W=20u L=1u
Mo3_uU_L2_2_0 da_uU_L2_2_0 da_uU_L2_2_0 vdd vdd PMIR W=60u L=1u
Mo4_uU_L2_2_0 gp_2_2_0 da_uU_L2_2_0 vdd vdd PMIR W=60u L=1u
Mt_uU_L2_2_1 ts_uU_L2_2_1 hv_L1_4 0 0 NMIR W=48.0u L=1u
Mo1_uU_L2_2_1 da_uU_L2_2_1 d1bar_L2 ts_uU_L2_2_1 0 NMIR W=20u L=1u
Mo2_uU_L2_2_1 gp_2_2_1 dpre_L2_2 ts_uU_L2_2_1 0 NMIR W=20u L=1u
Mo3_uU_L2_2_1 da_uU_L2_2_1 da_uU_L2_2_1 vdd vdd PMIR W=60u L=1u
Mo4_uU_L2_2_1 gp_2_2_1 da_uU_L2_2_1 vdd vdd PMIR W=60u L=1u
Mt_uU_L2_2_2 ts_uU_L2_2_2 hv_L1_7 0 0 NMIR W=48.0u L=1u
Mo1_uU_L2_2_2 da_uU_L2_2_2 d1bar_L2 ts_uU_L2_2_2 0 NMIR W=20u L=1u
Mo2_uU_L2_2_2 gp_2_2_2 dpre_L2_2 ts_uU_L2_2_2 0 NMIR W=20u L=1u
Mo3_uU_L2_2_2 da_uU_L2_2_2 da_uU_L2_2_2 vdd vdd PMIR W=60u L=1u
Mo4_uU_L2_2_2 gp_2_2_2 da_uU_L2_2_2 vdd vdd PMIR W=60u L=1u
Mt_uU_L2_2_3 ts_uU_L2_2_3 hv_L1_8 0 0 NMIR W=48.0u L=1u
Mo1_uU_L2_2_3 da_uU_L2_2_3 d1bar_L2 ts_uU_L2_2_3 0 NMIR W=20u L=1u
Mo2_uU_L2_2_3 gp_2_2_3 dpre_L2_2 ts_uU_L2_2_3 0 NMIR W=20u L=1u
Mo3_uU_L2_2_3 da_uU_L2_2_3 da_uU_L2_2_3 vdd vdd PMIR W=60u L=1u
Mo4_uU_L2_2_3 gp_2_2_3 da_uU_L2_2_3 vdd vdd PMIR W=60u L=1u
Mt_uU_L2_2_4 ts_uU_L2_2_4 hv_L1_14 0 0 NMIR W=48.0u L=1u
Mo1_uU_L2_2_4 da_uU_L2_2_4 d1bar_L2 ts_uU_L2_2_4 0 NMIR W=20u L=1u
Mo2_uU_L2_2_4 gp_2_2_4 dpre_L2_2 ts_uU_L2_2_4 0 NMIR W=20u L=1u
Mo3_uU_L2_2_4 da_uU_L2_2_4 da_uU_L2_2_4 vdd vdd PMIR W=60u L=1u
Mo4_uU_L2_2_4 gp_2_2_4 da_uU_L2_2_4 vdd vdd PMIR W=60u L=1u
Mt_uU_L2_2_5 ts_uU_L2_2_5 hv_L1_19 0 0 NMIR W=48.0u L=1u
Mo1_uU_L2_2_5 da_uU_L2_2_5 d1bar_L2 ts_uU_L2_2_5 0 NMIR W=20u L=1u
Mo2_uU_L2_2_5 gp_2_2_5 dpre_L2_2 ts_uU_L2_2_5 0 NMIR W=20u L=1u
Mo3_uU_L2_2_5 da_uU_L2_2_5 da_uU_L2_2_5 vdd vdd PMIR W=60u L=1u
Mo4_uU_L2_2_5 gp_2_2_5 da_uU_L2_2_5 vdd vdd PMIR W=60u L=1u
Mt_uU_L2_2_6 ts_uU_L2_2_6 hv_L1_20 0 0 NMIR W=48.0u L=1u
Mo1_uU_L2_2_6 da_uU_L2_2_6 d1bar_L2 ts_uU_L2_2_6 0 NMIR W=20u L=1u
Mo2_uU_L2_2_6 gp_2_2_6 dpre_L2_2 ts_uU_L2_2_6 0 NMIR W=20u L=1u
Mo3_uU_L2_2_6 da_uU_L2_2_6 da_uU_L2_2_6 vdd vdd PMIR W=60u L=1u
Mo4_uU_L2_2_6 gp_2_2_6 da_uU_L2_2_6 vdd vdd PMIR W=60u L=1u
Mt_uU_L2_2_7 ts_uU_L2_2_7 hv_L1_22 0 0 NMIR W=48.0u L=1u
Mo1_uU_L2_2_7 da_uU_L2_2_7 d1bar_L2 ts_uU_L2_2_7 0 NMIR W=20u L=1u
Mo2_uU_L2_2_7 gp_2_2_7 dpre_L2_2 ts_uU_L2_2_7 0 NMIR W=20u L=1u
Mo3_uU_L2_2_7 da_uU_L2_2_7 da_uU_L2_2_7 vdd vdd PMIR W=60u L=1u
Mo4_uU_L2_2_7 gp_2_2_7 da_uU_L2_2_7 vdd vdd PMIR W=60u L=1u
Mt_uU_L2_2_8 ts_uU_L2_2_8 hv_L1_28 0 0 NMIR W=48.0u L=1u
Mo1_uU_L2_2_8 da_uU_L2_2_8 d1bar_L2 ts_uU_L2_2_8 0 NMIR W=20u L=1u
Mo2_uU_L2_2_8 gp_2_2_8 dpre_L2_2 ts_uU_L2_2_8 0 NMIR W=20u L=1u
Mo3_uU_L2_2_8 da_uU_L2_2_8 da_uU_L2_2_8 vdd vdd PMIR W=60u L=1u
Mo4_uU_L2_2_8 gp_2_2_8 da_uU_L2_2_8 vdd vdd PMIR W=60u L=1u
Mt_uU_L2_2_9 ts_uU_L2_2_9 hv_L1_29 0 0 NMIR W=48.0u L=1u
Mo1_uU_L2_2_9 da_uU_L2_2_9 d1bar_L2 ts_uU_L2_2_9 0 NMIR W=20u L=1u
Mo2_uU_L2_2_9 gp_2_2_9 dpre_L2_2 ts_uU_L2_2_9 0 NMIR W=20u L=1u
Mo3_uU_L2_2_9 da_uU_L2_2_9 da_uU_L2_2_9 vdd vdd PMIR W=60u L=1u
Mo4_uU_L2_2_9 gp_2_2_9 da_uU_L2_2_9 vdd vdd PMIR W=60u L=1u
Mt_uU_L2_2_10 ts_uU_L2_2_10 hv_L1_34 0 0 NMIR W=48.0u L=1u
Mo1_uU_L2_2_10 da_uU_L2_2_10 d1bar_L2 ts_uU_L2_2_10 0 NMIR W=20u L=1u
Mo2_uU_L2_2_10 gp_2_2_10 dpre_L2_2 ts_uU_L2_2_10 0 NMIR W=20u L=1u
Mo3_uU_L2_2_10 da_uU_L2_2_10 da_uU_L2_2_10 vdd vdd PMIR W=60u L=1u
Mo4_uU_L2_2_10 gp_2_2_10 da_uU_L2_2_10 vdd vdd PMIR W=60u L=1u
Mt_uU_L2_2_11 ts_uU_L2_2_11 hv_L1_40 0 0 NMIR W=48.0u L=1u
Mo1_uU_L2_2_11 da_uU_L2_2_11 d1bar_L2 ts_uU_L2_2_11 0 NMIR W=20u L=1u
Mo2_uU_L2_2_11 gp_2_2_11 dpre_L2_2 ts_uU_L2_2_11 0 NMIR W=20u L=1u
Mo3_uU_L2_2_11 da_uU_L2_2_11 da_uU_L2_2_11 vdd vdd PMIR W=60u L=1u
Mo4_uU_L2_2_11 gp_2_2_11 da_uU_L2_2_11 vdd vdd PMIR W=60u L=1u
Mt_uU_L2_2_12 ts_uU_L2_2_12 hv_L1_41 0 0 NMIR W=48.0u L=1u
Mo1_uU_L2_2_12 da_uU_L2_2_12 d1bar_L2 ts_uU_L2_2_12 0 NMIR W=20u L=1u
Mo2_uU_L2_2_12 gp_2_2_12 dpre_L2_2 ts_uU_L2_2_12 0 NMIR W=20u L=1u
Mo3_uU_L2_2_12 da_uU_L2_2_12 da_uU_L2_2_12 vdd vdd PMIR W=60u L=1u
Mo4_uU_L2_2_12 gp_2_2_12 da_uU_L2_2_12 vdd vdd PMIR W=60u L=1u
Mt_uU_L2_2_13 ts_uU_L2_2_13 hv_L1_44 0 0 NMIR W=48.0u L=1u
Mo1_uU_L2_2_13 da_uU_L2_2_13 d1bar_L2 ts_uU_L2_2_13 0 NMIR W=20u L=1u
Mo2_uU_L2_2_13 gp_2_2_13 dpre_L2_2 ts_uU_L2_2_13 0 NMIR W=20u L=1u
Mo3_uU_L2_2_13 da_uU_L2_2_13 da_uU_L2_2_13 vdd vdd PMIR W=60u L=1u
Mo4_uU_L2_2_13 gp_2_2_13 da_uU_L2_2_13 vdd vdd PMIR W=60u L=1u
Mt_uU_L2_2_14 ts_uU_L2_2_14 hv_L1_45 0 0 NMIR W=48.0u L=1u
Mo1_uU_L2_2_14 da_uU_L2_2_14 d1bar_L2 ts_uU_L2_2_14 0 NMIR W=20u L=1u
Mo2_uU_L2_2_14 gp_2_2_14 dpre_L2_2 ts_uU_L2_2_14 0 NMIR W=20u L=1u
Mo3_uU_L2_2_14 da_uU_L2_2_14 da_uU_L2_2_14 vdd vdd PMIR W=60u L=1u
Mo4_uU_L2_2_14 gp_2_2_14 da_uU_L2_2_14 vdd vdd PMIR W=60u L=1u
Mt_uU_L2_2_15 ts_uU_L2_2_15 hv_L1_47 0 0 NMIR W=48.0u L=1u
Mo1_uU_L2_2_15 da_uU_L2_2_15 d1bar_L2 ts_uU_L2_2_15 0 NMIR W=20u L=1u
Mo2_uU_L2_2_15 gp_2_2_15 dpre_L2_2 ts_uU_L2_2_15 0 NMIR W=20u L=1u
Mo3_uU_L2_2_15 da_uU_L2_2_15 da_uU_L2_2_15 vdd vdd PMIR W=60u L=1u
Mo4_uU_L2_2_15 gp_2_2_15 da_uU_L2_2_15 vdd vdd PMIR W=60u L=1u
Mt_uU_L2_3_0 ts_uU_L2_3_0 hv_L1_0 0 0 NMIR W=48.0u L=1u
Mo1_uU_L2_3_0 da_uU_L2_3_0 d1bar_L2 ts_uU_L2_3_0 0 NMIR W=20u L=1u
Mo2_uU_L2_3_0 gp_2_3_0 dpre_L2_3 ts_uU_L2_3_0 0 NMIR W=20u L=1u
Mo3_uU_L2_3_0 da_uU_L2_3_0 da_uU_L2_3_0 vdd vdd PMIR W=60u L=1u
Mo4_uU_L2_3_0 gp_2_3_0 da_uU_L2_3_0 vdd vdd PMIR W=60u L=1u
Mt_uU_L2_3_1 ts_uU_L2_3_1 hv_L1_1 0 0 NMIR W=48.0u L=1u
Mo1_uU_L2_3_1 da_uU_L2_3_1 d1bar_L2 ts_uU_L2_3_1 0 NMIR W=20u L=1u
Mo2_uU_L2_3_1 gp_2_3_1 dpre_L2_3 ts_uU_L2_3_1 0 NMIR W=20u L=1u
Mo3_uU_L2_3_1 da_uU_L2_3_1 da_uU_L2_3_1 vdd vdd PMIR W=60u L=1u
Mo4_uU_L2_3_1 gp_2_3_1 da_uU_L2_3_1 vdd vdd PMIR W=60u L=1u
Mt_uU_L2_3_2 ts_uU_L2_3_2 hv_L1_6 0 0 NMIR W=48.0u L=1u
Mo1_uU_L2_3_2 da_uU_L2_3_2 d1bar_L2 ts_uU_L2_3_2 0 NMIR W=20u L=1u
Mo2_uU_L2_3_2 gp_2_3_2 dpre_L2_3 ts_uU_L2_3_2 0 NMIR W=20u L=1u
Mo3_uU_L2_3_2 da_uU_L2_3_2 da_uU_L2_3_2 vdd vdd PMIR W=60u L=1u
Mo4_uU_L2_3_2 gp_2_3_2 da_uU_L2_3_2 vdd vdd PMIR W=60u L=1u
Mt_uU_L2_3_3 ts_uU_L2_3_3 hv_L1_7 0 0 NMIR W=48.0u L=1u
Mo1_uU_L2_3_3 da_uU_L2_3_3 d1bar_L2 ts_uU_L2_3_3 0 NMIR W=20u L=1u
Mo2_uU_L2_3_3 gp_2_3_3 dpre_L2_3 ts_uU_L2_3_3 0 NMIR W=20u L=1u
Mo3_uU_L2_3_3 da_uU_L2_3_3 da_uU_L2_3_3 vdd vdd PMIR W=60u L=1u
Mo4_uU_L2_3_3 gp_2_3_3 da_uU_L2_3_3 vdd vdd PMIR W=60u L=1u
Mt_uU_L2_3_4 ts_uU_L2_3_4 hv_L1_13 0 0 NMIR W=48.0u L=1u
Mo1_uU_L2_3_4 da_uU_L2_3_4 d1bar_L2 ts_uU_L2_3_4 0 NMIR W=20u L=1u
Mo2_uU_L2_3_4 gp_2_3_4 dpre_L2_3 ts_uU_L2_3_4 0 NMIR W=20u L=1u
Mo3_uU_L2_3_4 da_uU_L2_3_4 da_uU_L2_3_4 vdd vdd PMIR W=60u L=1u
Mo4_uU_L2_3_4 gp_2_3_4 da_uU_L2_3_4 vdd vdd PMIR W=60u L=1u
Mt_uU_L2_3_5 ts_uU_L2_3_5 hv_L1_14 0 0 NMIR W=48.0u L=1u
Mo1_uU_L2_3_5 da_uU_L2_3_5 d1bar_L2 ts_uU_L2_3_5 0 NMIR W=20u L=1u
Mo2_uU_L2_3_5 gp_2_3_5 dpre_L2_3 ts_uU_L2_3_5 0 NMIR W=20u L=1u
Mo3_uU_L2_3_5 da_uU_L2_3_5 da_uU_L2_3_5 vdd vdd PMIR W=60u L=1u
Mo4_uU_L2_3_5 gp_2_3_5 da_uU_L2_3_5 vdd vdd PMIR W=60u L=1u
Mt_uU_L2_3_6 ts_uU_L2_3_6 hv_L1_18 0 0 NMIR W=48.0u L=1u
Mo1_uU_L2_3_6 da_uU_L2_3_6 d1bar_L2 ts_uU_L2_3_6 0 NMIR W=20u L=1u
Mo2_uU_L2_3_6 gp_2_3_6 dpre_L2_3 ts_uU_L2_3_6 0 NMIR W=20u L=1u
Mo3_uU_L2_3_6 da_uU_L2_3_6 da_uU_L2_3_6 vdd vdd PMIR W=60u L=1u
Mo4_uU_L2_3_6 gp_2_3_6 da_uU_L2_3_6 vdd vdd PMIR W=60u L=1u
Mt_uU_L2_3_7 ts_uU_L2_3_7 hv_L1_20 0 0 NMIR W=48.0u L=1u
Mo1_uU_L2_3_7 da_uU_L2_3_7 d1bar_L2 ts_uU_L2_3_7 0 NMIR W=20u L=1u
Mo2_uU_L2_3_7 gp_2_3_7 dpre_L2_3 ts_uU_L2_3_7 0 NMIR W=20u L=1u
Mo3_uU_L2_3_7 da_uU_L2_3_7 da_uU_L2_3_7 vdd vdd PMIR W=60u L=1u
Mo4_uU_L2_3_7 gp_2_3_7 da_uU_L2_3_7 vdd vdd PMIR W=60u L=1u
Mt_uU_L2_3_8 ts_uU_L2_3_8 hv_L1_22 0 0 NMIR W=48.0u L=1u
Mo1_uU_L2_3_8 da_uU_L2_3_8 d1bar_L2 ts_uU_L2_3_8 0 NMIR W=20u L=1u
Mo2_uU_L2_3_8 gp_2_3_8 dpre_L2_3 ts_uU_L2_3_8 0 NMIR W=20u L=1u
Mo3_uU_L2_3_8 da_uU_L2_3_8 da_uU_L2_3_8 vdd vdd PMIR W=60u L=1u
Mo4_uU_L2_3_8 gp_2_3_8 da_uU_L2_3_8 vdd vdd PMIR W=60u L=1u
Mt_uU_L2_3_9 ts_uU_L2_3_9 hv_L1_24 0 0 NMIR W=48.0u L=1u
Mo1_uU_L2_3_9 da_uU_L2_3_9 d1bar_L2 ts_uU_L2_3_9 0 NMIR W=20u L=1u
Mo2_uU_L2_3_9 gp_2_3_9 dpre_L2_3 ts_uU_L2_3_9 0 NMIR W=20u L=1u
Mo3_uU_L2_3_9 da_uU_L2_3_9 da_uU_L2_3_9 vdd vdd PMIR W=60u L=1u
Mo4_uU_L2_3_9 gp_2_3_9 da_uU_L2_3_9 vdd vdd PMIR W=60u L=1u
Mt_uU_L2_3_10 ts_uU_L2_3_10 hv_L1_32 0 0 NMIR W=48.0u L=1u
Mo1_uU_L2_3_10 da_uU_L2_3_10 d1bar_L2 ts_uU_L2_3_10 0 NMIR W=20u L=1u
Mo2_uU_L2_3_10 gp_2_3_10 dpre_L2_3 ts_uU_L2_3_10 0 NMIR W=20u L=1u
Mo3_uU_L2_3_10 da_uU_L2_3_10 da_uU_L2_3_10 vdd vdd PMIR W=60u L=1u
Mo4_uU_L2_3_10 gp_2_3_10 da_uU_L2_3_10 vdd vdd PMIR W=60u L=1u
Mt_uU_L2_3_11 ts_uU_L2_3_11 hv_L1_35 0 0 NMIR W=48.0u L=1u
Mo1_uU_L2_3_11 da_uU_L2_3_11 d1bar_L2 ts_uU_L2_3_11 0 NMIR W=20u L=1u
Mo2_uU_L2_3_11 gp_2_3_11 dpre_L2_3 ts_uU_L2_3_11 0 NMIR W=20u L=1u
Mo3_uU_L2_3_11 da_uU_L2_3_11 da_uU_L2_3_11 vdd vdd PMIR W=60u L=1u
Mo4_uU_L2_3_11 gp_2_3_11 da_uU_L2_3_11 vdd vdd PMIR W=60u L=1u
Mt_uU_L2_3_12 ts_uU_L2_3_12 hv_L1_36 0 0 NMIR W=48.0u L=1u
Mo1_uU_L2_3_12 da_uU_L2_3_12 d1bar_L2 ts_uU_L2_3_12 0 NMIR W=20u L=1u
Mo2_uU_L2_3_12 gp_2_3_12 dpre_L2_3 ts_uU_L2_3_12 0 NMIR W=20u L=1u
Mo3_uU_L2_3_12 da_uU_L2_3_12 da_uU_L2_3_12 vdd vdd PMIR W=60u L=1u
Mo4_uU_L2_3_12 gp_2_3_12 da_uU_L2_3_12 vdd vdd PMIR W=60u L=1u
Mt_uU_L2_3_13 ts_uU_L2_3_13 hv_L1_39 0 0 NMIR W=48.0u L=1u
Mo1_uU_L2_3_13 da_uU_L2_3_13 d1bar_L2 ts_uU_L2_3_13 0 NMIR W=20u L=1u
Mo2_uU_L2_3_13 gp_2_3_13 dpre_L2_3 ts_uU_L2_3_13 0 NMIR W=20u L=1u
Mo3_uU_L2_3_13 da_uU_L2_3_13 da_uU_L2_3_13 vdd vdd PMIR W=60u L=1u
Mo4_uU_L2_3_13 gp_2_3_13 da_uU_L2_3_13 vdd vdd PMIR W=60u L=1u
Mt_uU_L2_3_14 ts_uU_L2_3_14 hv_L1_40 0 0 NMIR W=48.0u L=1u
Mo1_uU_L2_3_14 da_uU_L2_3_14 d1bar_L2 ts_uU_L2_3_14 0 NMIR W=20u L=1u
Mo2_uU_L2_3_14 gp_2_3_14 dpre_L2_3 ts_uU_L2_3_14 0 NMIR W=20u L=1u
Mo3_uU_L2_3_14 da_uU_L2_3_14 da_uU_L2_3_14 vdd vdd PMIR W=60u L=1u
Mo4_uU_L2_3_14 gp_2_3_14 da_uU_L2_3_14 vdd vdd PMIR W=60u L=1u
Mt_uU_L2_3_15 ts_uU_L2_3_15 hv_L1_41 0 0 NMIR W=48.0u L=1u
Mo1_uU_L2_3_15 da_uU_L2_3_15 d1bar_L2 ts_uU_L2_3_15 0 NMIR W=20u L=1u
Mo2_uU_L2_3_15 gp_2_3_15 dpre_L2_3 ts_uU_L2_3_15 0 NMIR W=20u L=1u
Mo3_uU_L2_3_15 da_uU_L2_3_15 da_uU_L2_3_15 vdd vdd PMIR W=60u L=1u
Mo4_uU_L2_3_15 gp_2_3_15 da_uU_L2_3_15 vdd vdd PMIR W=60u L=1u
Mt_uU_L2_4_0 ts_uU_L2_4_0 hv_L1_2 0 0 NMIR W=48.0u L=1u
Mo1_uU_L2_4_0 da_uU_L2_4_0 d1bar_L2 ts_uU_L2_4_0 0 NMIR W=20u L=1u
Mo2_uU_L2_4_0 gp_2_4_0 dpre_L2_4 ts_uU_L2_4_0 0 NMIR W=20u L=1u
Mo3_uU_L2_4_0 da_uU_L2_4_0 da_uU_L2_4_0 vdd vdd PMIR W=60u L=1u
Mo4_uU_L2_4_0 gp_2_4_0 da_uU_L2_4_0 vdd vdd PMIR W=60u L=1u
Mt_uU_L2_4_1 ts_uU_L2_4_1 hv_L1_3 0 0 NMIR W=48.0u L=1u
Mo1_uU_L2_4_1 da_uU_L2_4_1 d1bar_L2 ts_uU_L2_4_1 0 NMIR W=20u L=1u
Mo2_uU_L2_4_1 gp_2_4_1 dpre_L2_4 ts_uU_L2_4_1 0 NMIR W=20u L=1u
Mo3_uU_L2_4_1 da_uU_L2_4_1 da_uU_L2_4_1 vdd vdd PMIR W=60u L=1u
Mo4_uU_L2_4_1 gp_2_4_1 da_uU_L2_4_1 vdd vdd PMIR W=60u L=1u
Mt_uU_L2_4_2 ts_uU_L2_4_2 hv_L1_4 0 0 NMIR W=48.0u L=1u
Mo1_uU_L2_4_2 da_uU_L2_4_2 d1bar_L2 ts_uU_L2_4_2 0 NMIR W=20u L=1u
Mo2_uU_L2_4_2 gp_2_4_2 dpre_L2_4 ts_uU_L2_4_2 0 NMIR W=20u L=1u
Mo3_uU_L2_4_2 da_uU_L2_4_2 da_uU_L2_4_2 vdd vdd PMIR W=60u L=1u
Mo4_uU_L2_4_2 gp_2_4_2 da_uU_L2_4_2 vdd vdd PMIR W=60u L=1u
Mt_uU_L2_4_3 ts_uU_L2_4_3 hv_L1_6 0 0 NMIR W=48.0u L=1u
Mo1_uU_L2_4_3 da_uU_L2_4_3 d1bar_L2 ts_uU_L2_4_3 0 NMIR W=20u L=1u
Mo2_uU_L2_4_3 gp_2_4_3 dpre_L2_4 ts_uU_L2_4_3 0 NMIR W=20u L=1u
Mo3_uU_L2_4_3 da_uU_L2_4_3 da_uU_L2_4_3 vdd vdd PMIR W=60u L=1u
Mo4_uU_L2_4_3 gp_2_4_3 da_uU_L2_4_3 vdd vdd PMIR W=60u L=1u
Mt_uU_L2_4_4 ts_uU_L2_4_4 hv_L1_7 0 0 NMIR W=48.0u L=1u
Mo1_uU_L2_4_4 da_uU_L2_4_4 d1bar_L2 ts_uU_L2_4_4 0 NMIR W=20u L=1u
Mo2_uU_L2_4_4 gp_2_4_4 dpre_L2_4 ts_uU_L2_4_4 0 NMIR W=20u L=1u
Mo3_uU_L2_4_4 da_uU_L2_4_4 da_uU_L2_4_4 vdd vdd PMIR W=60u L=1u
Mo4_uU_L2_4_4 gp_2_4_4 da_uU_L2_4_4 vdd vdd PMIR W=60u L=1u
Mt_uU_L2_4_5 ts_uU_L2_4_5 hv_L1_10 0 0 NMIR W=48.0u L=1u
Mo1_uU_L2_4_5 da_uU_L2_4_5 d1bar_L2 ts_uU_L2_4_5 0 NMIR W=20u L=1u
Mo2_uU_L2_4_5 gp_2_4_5 dpre_L2_4 ts_uU_L2_4_5 0 NMIR W=20u L=1u
Mo3_uU_L2_4_5 da_uU_L2_4_5 da_uU_L2_4_5 vdd vdd PMIR W=60u L=1u
Mo4_uU_L2_4_5 gp_2_4_5 da_uU_L2_4_5 vdd vdd PMIR W=60u L=1u
Mt_uU_L2_4_6 ts_uU_L2_4_6 hv_L1_13 0 0 NMIR W=48.0u L=1u
Mo1_uU_L2_4_6 da_uU_L2_4_6 d1bar_L2 ts_uU_L2_4_6 0 NMIR W=20u L=1u
Mo2_uU_L2_4_6 gp_2_4_6 dpre_L2_4 ts_uU_L2_4_6 0 NMIR W=20u L=1u
Mo3_uU_L2_4_6 da_uU_L2_4_6 da_uU_L2_4_6 vdd vdd PMIR W=60u L=1u
Mo4_uU_L2_4_6 gp_2_4_6 da_uU_L2_4_6 vdd vdd PMIR W=60u L=1u
Mt_uU_L2_4_7 ts_uU_L2_4_7 hv_L1_25 0 0 NMIR W=48.0u L=1u
Mo1_uU_L2_4_7 da_uU_L2_4_7 d1bar_L2 ts_uU_L2_4_7 0 NMIR W=20u L=1u
Mo2_uU_L2_4_7 gp_2_4_7 dpre_L2_4 ts_uU_L2_4_7 0 NMIR W=20u L=1u
Mo3_uU_L2_4_7 da_uU_L2_4_7 da_uU_L2_4_7 vdd vdd PMIR W=60u L=1u
Mo4_uU_L2_4_7 gp_2_4_7 da_uU_L2_4_7 vdd vdd PMIR W=60u L=1u
Mt_uU_L2_4_8 ts_uU_L2_4_8 hv_L1_27 0 0 NMIR W=48.0u L=1u
Mo1_uU_L2_4_8 da_uU_L2_4_8 d1bar_L2 ts_uU_L2_4_8 0 NMIR W=20u L=1u
Mo2_uU_L2_4_8 gp_2_4_8 dpre_L2_4 ts_uU_L2_4_8 0 NMIR W=20u L=1u
Mo3_uU_L2_4_8 da_uU_L2_4_8 da_uU_L2_4_8 vdd vdd PMIR W=60u L=1u
Mo4_uU_L2_4_8 gp_2_4_8 da_uU_L2_4_8 vdd vdd PMIR W=60u L=1u
Mt_uU_L2_4_9 ts_uU_L2_4_9 hv_L1_28 0 0 NMIR W=48.0u L=1u
Mo1_uU_L2_4_9 da_uU_L2_4_9 d1bar_L2 ts_uU_L2_4_9 0 NMIR W=20u L=1u
Mo2_uU_L2_4_9 gp_2_4_9 dpre_L2_4 ts_uU_L2_4_9 0 NMIR W=20u L=1u
Mo3_uU_L2_4_9 da_uU_L2_4_9 da_uU_L2_4_9 vdd vdd PMIR W=60u L=1u
Mo4_uU_L2_4_9 gp_2_4_9 da_uU_L2_4_9 vdd vdd PMIR W=60u L=1u
Mt_uU_L2_4_10 ts_uU_L2_4_10 hv_L1_31 0 0 NMIR W=48.0u L=1u
Mo1_uU_L2_4_10 da_uU_L2_4_10 d1bar_L2 ts_uU_L2_4_10 0 NMIR W=20u L=1u
Mo2_uU_L2_4_10 gp_2_4_10 dpre_L2_4 ts_uU_L2_4_10 0 NMIR W=20u L=1u
Mo3_uU_L2_4_10 da_uU_L2_4_10 da_uU_L2_4_10 vdd vdd PMIR W=60u L=1u
Mo4_uU_L2_4_10 gp_2_4_10 da_uU_L2_4_10 vdd vdd PMIR W=60u L=1u
Mt_uU_L2_4_11 ts_uU_L2_4_11 hv_L1_32 0 0 NMIR W=48.0u L=1u
Mo1_uU_L2_4_11 da_uU_L2_4_11 d1bar_L2 ts_uU_L2_4_11 0 NMIR W=20u L=1u
Mo2_uU_L2_4_11 gp_2_4_11 dpre_L2_4 ts_uU_L2_4_11 0 NMIR W=20u L=1u
Mo3_uU_L2_4_11 da_uU_L2_4_11 da_uU_L2_4_11 vdd vdd PMIR W=60u L=1u
Mo4_uU_L2_4_11 gp_2_4_11 da_uU_L2_4_11 vdd vdd PMIR W=60u L=1u
Mt_uU_L2_4_12 ts_uU_L2_4_12 hv_L1_34 0 0 NMIR W=48.0u L=1u
Mo1_uU_L2_4_12 da_uU_L2_4_12 d1bar_L2 ts_uU_L2_4_12 0 NMIR W=20u L=1u
Mo2_uU_L2_4_12 gp_2_4_12 dpre_L2_4 ts_uU_L2_4_12 0 NMIR W=20u L=1u
Mo3_uU_L2_4_12 da_uU_L2_4_12 da_uU_L2_4_12 vdd vdd PMIR W=60u L=1u
Mo4_uU_L2_4_12 gp_2_4_12 da_uU_L2_4_12 vdd vdd PMIR W=60u L=1u
Mt_uU_L2_4_13 ts_uU_L2_4_13 hv_L1_39 0 0 NMIR W=48.0u L=1u
Mo1_uU_L2_4_13 da_uU_L2_4_13 d1bar_L2 ts_uU_L2_4_13 0 NMIR W=20u L=1u
Mo2_uU_L2_4_13 gp_2_4_13 dpre_L2_4 ts_uU_L2_4_13 0 NMIR W=20u L=1u
Mo3_uU_L2_4_13 da_uU_L2_4_13 da_uU_L2_4_13 vdd vdd PMIR W=60u L=1u
Mo4_uU_L2_4_13 gp_2_4_13 da_uU_L2_4_13 vdd vdd PMIR W=60u L=1u
Mt_uU_L2_4_14 ts_uU_L2_4_14 hv_L1_42 0 0 NMIR W=48.0u L=1u
Mo1_uU_L2_4_14 da_uU_L2_4_14 d1bar_L2 ts_uU_L2_4_14 0 NMIR W=20u L=1u
Mo2_uU_L2_4_14 gp_2_4_14 dpre_L2_4 ts_uU_L2_4_14 0 NMIR W=20u L=1u
Mo3_uU_L2_4_14 da_uU_L2_4_14 da_uU_L2_4_14 vdd vdd PMIR W=60u L=1u
Mo4_uU_L2_4_14 gp_2_4_14 da_uU_L2_4_14 vdd vdd PMIR W=60u L=1u
Mt_uU_L2_4_15 ts_uU_L2_4_15 hv_L1_44 0 0 NMIR W=48.0u L=1u
Mo1_uU_L2_4_15 da_uU_L2_4_15 d1bar_L2 ts_uU_L2_4_15 0 NMIR W=20u L=1u
Mo2_uU_L2_4_15 gp_2_4_15 dpre_L2_4 ts_uU_L2_4_15 0 NMIR W=20u L=1u
Mo3_uU_L2_4_15 da_uU_L2_4_15 da_uU_L2_4_15 vdd vdd PMIR W=60u L=1u
Mo4_uU_L2_4_15 gp_2_4_15 da_uU_L2_4_15 vdd vdd PMIR W=60u L=1u
Mt_uU_L2_5_0 ts_uU_L2_5_0 hv_L1_4 0 0 NMIR W=48.0u L=1u
Mo1_uU_L2_5_0 da_uU_L2_5_0 d1bar_L2 ts_uU_L2_5_0 0 NMIR W=20u L=1u
Mo2_uU_L2_5_0 gp_2_5_0 dpre_L2_5 ts_uU_L2_5_0 0 NMIR W=20u L=1u
Mo3_uU_L2_5_0 da_uU_L2_5_0 da_uU_L2_5_0 vdd vdd PMIR W=60u L=1u
Mo4_uU_L2_5_0 gp_2_5_0 da_uU_L2_5_0 vdd vdd PMIR W=60u L=1u
Mt_uU_L2_5_1 ts_uU_L2_5_1 hv_L1_7 0 0 NMIR W=48.0u L=1u
Mo1_uU_L2_5_1 da_uU_L2_5_1 d1bar_L2 ts_uU_L2_5_1 0 NMIR W=20u L=1u
Mo2_uU_L2_5_1 gp_2_5_1 dpre_L2_5 ts_uU_L2_5_1 0 NMIR W=20u L=1u
Mo3_uU_L2_5_1 da_uU_L2_5_1 da_uU_L2_5_1 vdd vdd PMIR W=60u L=1u
Mo4_uU_L2_5_1 gp_2_5_1 da_uU_L2_5_1 vdd vdd PMIR W=60u L=1u
Mt_uU_L2_5_2 ts_uU_L2_5_2 hv_L1_11 0 0 NMIR W=48.0u L=1u
Mo1_uU_L2_5_2 da_uU_L2_5_2 d1bar_L2 ts_uU_L2_5_2 0 NMIR W=20u L=1u
Mo2_uU_L2_5_2 gp_2_5_2 dpre_L2_5 ts_uU_L2_5_2 0 NMIR W=20u L=1u
Mo3_uU_L2_5_2 da_uU_L2_5_2 da_uU_L2_5_2 vdd vdd PMIR W=60u L=1u
Mo4_uU_L2_5_2 gp_2_5_2 da_uU_L2_5_2 vdd vdd PMIR W=60u L=1u
Mt_uU_L2_5_3 ts_uU_L2_5_3 hv_L1_12 0 0 NMIR W=48.0u L=1u
Mo1_uU_L2_5_3 da_uU_L2_5_3 d1bar_L2 ts_uU_L2_5_3 0 NMIR W=20u L=1u
Mo2_uU_L2_5_3 gp_2_5_3 dpre_L2_5 ts_uU_L2_5_3 0 NMIR W=20u L=1u
Mo3_uU_L2_5_3 da_uU_L2_5_3 da_uU_L2_5_3 vdd vdd PMIR W=60u L=1u
Mo4_uU_L2_5_3 gp_2_5_3 da_uU_L2_5_3 vdd vdd PMIR W=60u L=1u
Mt_uU_L2_5_4 ts_uU_L2_5_4 hv_L1_18 0 0 NMIR W=48.0u L=1u
Mo1_uU_L2_5_4 da_uU_L2_5_4 d1bar_L2 ts_uU_L2_5_4 0 NMIR W=20u L=1u
Mo2_uU_L2_5_4 gp_2_5_4 dpre_L2_5 ts_uU_L2_5_4 0 NMIR W=20u L=1u
Mo3_uU_L2_5_4 da_uU_L2_5_4 da_uU_L2_5_4 vdd vdd PMIR W=60u L=1u
Mo4_uU_L2_5_4 gp_2_5_4 da_uU_L2_5_4 vdd vdd PMIR W=60u L=1u
Mt_uU_L2_5_5 ts_uU_L2_5_5 hv_L1_20 0 0 NMIR W=48.0u L=1u
Mo1_uU_L2_5_5 da_uU_L2_5_5 d1bar_L2 ts_uU_L2_5_5 0 NMIR W=20u L=1u
Mo2_uU_L2_5_5 gp_2_5_5 dpre_L2_5 ts_uU_L2_5_5 0 NMIR W=20u L=1u
Mo3_uU_L2_5_5 da_uU_L2_5_5 da_uU_L2_5_5 vdd vdd PMIR W=60u L=1u
Mo4_uU_L2_5_5 gp_2_5_5 da_uU_L2_5_5 vdd vdd PMIR W=60u L=1u
Mt_uU_L2_5_6 ts_uU_L2_5_6 hv_L1_21 0 0 NMIR W=48.0u L=1u
Mo1_uU_L2_5_6 da_uU_L2_5_6 d1bar_L2 ts_uU_L2_5_6 0 NMIR W=20u L=1u
Mo2_uU_L2_5_6 gp_2_5_6 dpre_L2_5 ts_uU_L2_5_6 0 NMIR W=20u L=1u
Mo3_uU_L2_5_6 da_uU_L2_5_6 da_uU_L2_5_6 vdd vdd PMIR W=60u L=1u
Mo4_uU_L2_5_6 gp_2_5_6 da_uU_L2_5_6 vdd vdd PMIR W=60u L=1u
Mt_uU_L2_5_7 ts_uU_L2_5_7 hv_L1_23 0 0 NMIR W=48.0u L=1u
Mo1_uU_L2_5_7 da_uU_L2_5_7 d1bar_L2 ts_uU_L2_5_7 0 NMIR W=20u L=1u
Mo2_uU_L2_5_7 gp_2_5_7 dpre_L2_5 ts_uU_L2_5_7 0 NMIR W=20u L=1u
Mo3_uU_L2_5_7 da_uU_L2_5_7 da_uU_L2_5_7 vdd vdd PMIR W=60u L=1u
Mo4_uU_L2_5_7 gp_2_5_7 da_uU_L2_5_7 vdd vdd PMIR W=60u L=1u
Mt_uU_L2_5_8 ts_uU_L2_5_8 hv_L1_26 0 0 NMIR W=48.0u L=1u
Mo1_uU_L2_5_8 da_uU_L2_5_8 d1bar_L2 ts_uU_L2_5_8 0 NMIR W=20u L=1u
Mo2_uU_L2_5_8 gp_2_5_8 dpre_L2_5 ts_uU_L2_5_8 0 NMIR W=20u L=1u
Mo3_uU_L2_5_8 da_uU_L2_5_8 da_uU_L2_5_8 vdd vdd PMIR W=60u L=1u
Mo4_uU_L2_5_8 gp_2_5_8 da_uU_L2_5_8 vdd vdd PMIR W=60u L=1u
Mt_uU_L2_5_9 ts_uU_L2_5_9 hv_L1_29 0 0 NMIR W=48.0u L=1u
Mo1_uU_L2_5_9 da_uU_L2_5_9 d1bar_L2 ts_uU_L2_5_9 0 NMIR W=20u L=1u
Mo2_uU_L2_5_9 gp_2_5_9 dpre_L2_5 ts_uU_L2_5_9 0 NMIR W=20u L=1u
Mo3_uU_L2_5_9 da_uU_L2_5_9 da_uU_L2_5_9 vdd vdd PMIR W=60u L=1u
Mo4_uU_L2_5_9 gp_2_5_9 da_uU_L2_5_9 vdd vdd PMIR W=60u L=1u
Mt_uU_L2_5_10 ts_uU_L2_5_10 hv_L1_32 0 0 NMIR W=48.0u L=1u
Mo1_uU_L2_5_10 da_uU_L2_5_10 d1bar_L2 ts_uU_L2_5_10 0 NMIR W=20u L=1u
Mo2_uU_L2_5_10 gp_2_5_10 dpre_L2_5 ts_uU_L2_5_10 0 NMIR W=20u L=1u
Mo3_uU_L2_5_10 da_uU_L2_5_10 da_uU_L2_5_10 vdd vdd PMIR W=60u L=1u
Mo4_uU_L2_5_10 gp_2_5_10 da_uU_L2_5_10 vdd vdd PMIR W=60u L=1u
Mt_uU_L2_5_11 ts_uU_L2_5_11 hv_L1_35 0 0 NMIR W=48.0u L=1u
Mo1_uU_L2_5_11 da_uU_L2_5_11 d1bar_L2 ts_uU_L2_5_11 0 NMIR W=20u L=1u
Mo2_uU_L2_5_11 gp_2_5_11 dpre_L2_5 ts_uU_L2_5_11 0 NMIR W=20u L=1u
Mo3_uU_L2_5_11 da_uU_L2_5_11 da_uU_L2_5_11 vdd vdd PMIR W=60u L=1u
Mo4_uU_L2_5_11 gp_2_5_11 da_uU_L2_5_11 vdd vdd PMIR W=60u L=1u
Mt_uU_L2_5_12 ts_uU_L2_5_12 hv_L1_36 0 0 NMIR W=48.0u L=1u
Mo1_uU_L2_5_12 da_uU_L2_5_12 d1bar_L2 ts_uU_L2_5_12 0 NMIR W=20u L=1u
Mo2_uU_L2_5_12 gp_2_5_12 dpre_L2_5 ts_uU_L2_5_12 0 NMIR W=20u L=1u
Mo3_uU_L2_5_12 da_uU_L2_5_12 da_uU_L2_5_12 vdd vdd PMIR W=60u L=1u
Mo4_uU_L2_5_12 gp_2_5_12 da_uU_L2_5_12 vdd vdd PMIR W=60u L=1u
Mt_uU_L2_5_13 ts_uU_L2_5_13 hv_L1_39 0 0 NMIR W=48.0u L=1u
Mo1_uU_L2_5_13 da_uU_L2_5_13 d1bar_L2 ts_uU_L2_5_13 0 NMIR W=20u L=1u
Mo2_uU_L2_5_13 gp_2_5_13 dpre_L2_5 ts_uU_L2_5_13 0 NMIR W=20u L=1u
Mo3_uU_L2_5_13 da_uU_L2_5_13 da_uU_L2_5_13 vdd vdd PMIR W=60u L=1u
Mo4_uU_L2_5_13 gp_2_5_13 da_uU_L2_5_13 vdd vdd PMIR W=60u L=1u
Mt_uU_L2_5_14 ts_uU_L2_5_14 hv_L1_41 0 0 NMIR W=48.0u L=1u
Mo1_uU_L2_5_14 da_uU_L2_5_14 d1bar_L2 ts_uU_L2_5_14 0 NMIR W=20u L=1u
Mo2_uU_L2_5_14 gp_2_5_14 dpre_L2_5 ts_uU_L2_5_14 0 NMIR W=20u L=1u
Mo3_uU_L2_5_14 da_uU_L2_5_14 da_uU_L2_5_14 vdd vdd PMIR W=60u L=1u
Mo4_uU_L2_5_14 gp_2_5_14 da_uU_L2_5_14 vdd vdd PMIR W=60u L=1u
Mt_uU_L2_5_15 ts_uU_L2_5_15 hv_L1_43 0 0 NMIR W=48.0u L=1u
Mo1_uU_L2_5_15 da_uU_L2_5_15 d1bar_L2 ts_uU_L2_5_15 0 NMIR W=20u L=1u
Mo2_uU_L2_5_15 gp_2_5_15 dpre_L2_5 ts_uU_L2_5_15 0 NMIR W=20u L=1u
Mo3_uU_L2_5_15 da_uU_L2_5_15 da_uU_L2_5_15 vdd vdd PMIR W=60u L=1u
Mo4_uU_L2_5_15 gp_2_5_15 da_uU_L2_5_15 vdd vdd PMIR W=60u L=1u
Mt_uU_L2_6_0 ts_uU_L2_6_0 hv_L1_6 0 0 NMIR W=48.0u L=1u
Mo1_uU_L2_6_0 da_uU_L2_6_0 d1bar_L2 ts_uU_L2_6_0 0 NMIR W=20u L=1u
Mo2_uU_L2_6_0 gp_2_6_0 dpre_L2_6 ts_uU_L2_6_0 0 NMIR W=20u L=1u
Mo3_uU_L2_6_0 da_uU_L2_6_0 da_uU_L2_6_0 vdd vdd PMIR W=60u L=1u
Mo4_uU_L2_6_0 gp_2_6_0 da_uU_L2_6_0 vdd vdd PMIR W=60u L=1u
Mt_uU_L2_6_1 ts_uU_L2_6_1 hv_L1_7 0 0 NMIR W=48.0u L=1u
Mo1_uU_L2_6_1 da_uU_L2_6_1 d1bar_L2 ts_uU_L2_6_1 0 NMIR W=20u L=1u
Mo2_uU_L2_6_1 gp_2_6_1 dpre_L2_6 ts_uU_L2_6_1 0 NMIR W=20u L=1u
Mo3_uU_L2_6_1 da_uU_L2_6_1 da_uU_L2_6_1 vdd vdd PMIR W=60u L=1u
Mo4_uU_L2_6_1 gp_2_6_1 da_uU_L2_6_1 vdd vdd PMIR W=60u L=1u
Mt_uU_L2_6_2 ts_uU_L2_6_2 hv_L1_8 0 0 NMIR W=48.0u L=1u
Mo1_uU_L2_6_2 da_uU_L2_6_2 d1bar_L2 ts_uU_L2_6_2 0 NMIR W=20u L=1u
Mo2_uU_L2_6_2 gp_2_6_2 dpre_L2_6 ts_uU_L2_6_2 0 NMIR W=20u L=1u
Mo3_uU_L2_6_2 da_uU_L2_6_2 da_uU_L2_6_2 vdd vdd PMIR W=60u L=1u
Mo4_uU_L2_6_2 gp_2_6_2 da_uU_L2_6_2 vdd vdd PMIR W=60u L=1u
Mt_uU_L2_6_3 ts_uU_L2_6_3 hv_L1_13 0 0 NMIR W=48.0u L=1u
Mo1_uU_L2_6_3 da_uU_L2_6_3 d1bar_L2 ts_uU_L2_6_3 0 NMIR W=20u L=1u
Mo2_uU_L2_6_3 gp_2_6_3 dpre_L2_6 ts_uU_L2_6_3 0 NMIR W=20u L=1u
Mo3_uU_L2_6_3 da_uU_L2_6_3 da_uU_L2_6_3 vdd vdd PMIR W=60u L=1u
Mo4_uU_L2_6_3 gp_2_6_3 da_uU_L2_6_3 vdd vdd PMIR W=60u L=1u
Mt_uU_L2_6_4 ts_uU_L2_6_4 hv_L1_14 0 0 NMIR W=48.0u L=1u
Mo1_uU_L2_6_4 da_uU_L2_6_4 d1bar_L2 ts_uU_L2_6_4 0 NMIR W=20u L=1u
Mo2_uU_L2_6_4 gp_2_6_4 dpre_L2_6 ts_uU_L2_6_4 0 NMIR W=20u L=1u
Mo3_uU_L2_6_4 da_uU_L2_6_4 da_uU_L2_6_4 vdd vdd PMIR W=60u L=1u
Mo4_uU_L2_6_4 gp_2_6_4 da_uU_L2_6_4 vdd vdd PMIR W=60u L=1u
Mt_uU_L2_6_5 ts_uU_L2_6_5 hv_L1_16 0 0 NMIR W=48.0u L=1u
Mo1_uU_L2_6_5 da_uU_L2_6_5 d1bar_L2 ts_uU_L2_6_5 0 NMIR W=20u L=1u
Mo2_uU_L2_6_5 gp_2_6_5 dpre_L2_6 ts_uU_L2_6_5 0 NMIR W=20u L=1u
Mo3_uU_L2_6_5 da_uU_L2_6_5 da_uU_L2_6_5 vdd vdd PMIR W=60u L=1u
Mo4_uU_L2_6_5 gp_2_6_5 da_uU_L2_6_5 vdd vdd PMIR W=60u L=1u
Mt_uU_L2_6_6 ts_uU_L2_6_6 hv_L1_17 0 0 NMIR W=48.0u L=1u
Mo1_uU_L2_6_6 da_uU_L2_6_6 d1bar_L2 ts_uU_L2_6_6 0 NMIR W=20u L=1u
Mo2_uU_L2_6_6 gp_2_6_6 dpre_L2_6 ts_uU_L2_6_6 0 NMIR W=20u L=1u
Mo3_uU_L2_6_6 da_uU_L2_6_6 da_uU_L2_6_6 vdd vdd PMIR W=60u L=1u
Mo4_uU_L2_6_6 gp_2_6_6 da_uU_L2_6_6 vdd vdd PMIR W=60u L=1u
Mt_uU_L2_6_7 ts_uU_L2_6_7 hv_L1_21 0 0 NMIR W=48.0u L=1u
Mo1_uU_L2_6_7 da_uU_L2_6_7 d1bar_L2 ts_uU_L2_6_7 0 NMIR W=20u L=1u
Mo2_uU_L2_6_7 gp_2_6_7 dpre_L2_6 ts_uU_L2_6_7 0 NMIR W=20u L=1u
Mo3_uU_L2_6_7 da_uU_L2_6_7 da_uU_L2_6_7 vdd vdd PMIR W=60u L=1u
Mo4_uU_L2_6_7 gp_2_6_7 da_uU_L2_6_7 vdd vdd PMIR W=60u L=1u
Mt_uU_L2_6_8 ts_uU_L2_6_8 hv_L1_27 0 0 NMIR W=48.0u L=1u
Mo1_uU_L2_6_8 da_uU_L2_6_8 d1bar_L2 ts_uU_L2_6_8 0 NMIR W=20u L=1u
Mo2_uU_L2_6_8 gp_2_6_8 dpre_L2_6 ts_uU_L2_6_8 0 NMIR W=20u L=1u
Mo3_uU_L2_6_8 da_uU_L2_6_8 da_uU_L2_6_8 vdd vdd PMIR W=60u L=1u
Mo4_uU_L2_6_8 gp_2_6_8 da_uU_L2_6_8 vdd vdd PMIR W=60u L=1u
Mt_uU_L2_6_9 ts_uU_L2_6_9 hv_L1_28 0 0 NMIR W=48.0u L=1u
Mo1_uU_L2_6_9 da_uU_L2_6_9 d1bar_L2 ts_uU_L2_6_9 0 NMIR W=20u L=1u
Mo2_uU_L2_6_9 gp_2_6_9 dpre_L2_6 ts_uU_L2_6_9 0 NMIR W=20u L=1u
Mo3_uU_L2_6_9 da_uU_L2_6_9 da_uU_L2_6_9 vdd vdd PMIR W=60u L=1u
Mo4_uU_L2_6_9 gp_2_6_9 da_uU_L2_6_9 vdd vdd PMIR W=60u L=1u
Mt_uU_L2_6_10 ts_uU_L2_6_10 hv_L1_29 0 0 NMIR W=48.0u L=1u
Mo1_uU_L2_6_10 da_uU_L2_6_10 d1bar_L2 ts_uU_L2_6_10 0 NMIR W=20u L=1u
Mo2_uU_L2_6_10 gp_2_6_10 dpre_L2_6 ts_uU_L2_6_10 0 NMIR W=20u L=1u
Mo3_uU_L2_6_10 da_uU_L2_6_10 da_uU_L2_6_10 vdd vdd PMIR W=60u L=1u
Mo4_uU_L2_6_10 gp_2_6_10 da_uU_L2_6_10 vdd vdd PMIR W=60u L=1u
Mt_uU_L2_6_11 ts_uU_L2_6_11 hv_L1_30 0 0 NMIR W=48.0u L=1u
Mo1_uU_L2_6_11 da_uU_L2_6_11 d1bar_L2 ts_uU_L2_6_11 0 NMIR W=20u L=1u
Mo2_uU_L2_6_11 gp_2_6_11 dpre_L2_6 ts_uU_L2_6_11 0 NMIR W=20u L=1u
Mo3_uU_L2_6_11 da_uU_L2_6_11 da_uU_L2_6_11 vdd vdd PMIR W=60u L=1u
Mo4_uU_L2_6_11 gp_2_6_11 da_uU_L2_6_11 vdd vdd PMIR W=60u L=1u
Mt_uU_L2_6_12 ts_uU_L2_6_12 hv_L1_39 0 0 NMIR W=48.0u L=1u
Mo1_uU_L2_6_12 da_uU_L2_6_12 d1bar_L2 ts_uU_L2_6_12 0 NMIR W=20u L=1u
Mo2_uU_L2_6_12 gp_2_6_12 dpre_L2_6 ts_uU_L2_6_12 0 NMIR W=20u L=1u
Mo3_uU_L2_6_12 da_uU_L2_6_12 da_uU_L2_6_12 vdd vdd PMIR W=60u L=1u
Mo4_uU_L2_6_12 gp_2_6_12 da_uU_L2_6_12 vdd vdd PMIR W=60u L=1u
Mt_uU_L2_6_13 ts_uU_L2_6_13 hv_L1_40 0 0 NMIR W=48.0u L=1u
Mo1_uU_L2_6_13 da_uU_L2_6_13 d1bar_L2 ts_uU_L2_6_13 0 NMIR W=20u L=1u
Mo2_uU_L2_6_13 gp_2_6_13 dpre_L2_6 ts_uU_L2_6_13 0 NMIR W=20u L=1u
Mo3_uU_L2_6_13 da_uU_L2_6_13 da_uU_L2_6_13 vdd vdd PMIR W=60u L=1u
Mo4_uU_L2_6_13 gp_2_6_13 da_uU_L2_6_13 vdd vdd PMIR W=60u L=1u
Mt_uU_L2_6_14 ts_uU_L2_6_14 hv_L1_43 0 0 NMIR W=48.0u L=1u
Mo1_uU_L2_6_14 da_uU_L2_6_14 d1bar_L2 ts_uU_L2_6_14 0 NMIR W=20u L=1u
Mo2_uU_L2_6_14 gp_2_6_14 dpre_L2_6 ts_uU_L2_6_14 0 NMIR W=20u L=1u
Mo3_uU_L2_6_14 da_uU_L2_6_14 da_uU_L2_6_14 vdd vdd PMIR W=60u L=1u
Mo4_uU_L2_6_14 gp_2_6_14 da_uU_L2_6_14 vdd vdd PMIR W=60u L=1u
Mt_uU_L2_6_15 ts_uU_L2_6_15 hv_L1_45 0 0 NMIR W=48.0u L=1u
Mo1_uU_L2_6_15 da_uU_L2_6_15 d1bar_L2 ts_uU_L2_6_15 0 NMIR W=20u L=1u
Mo2_uU_L2_6_15 gp_2_6_15 dpre_L2_6 ts_uU_L2_6_15 0 NMIR W=20u L=1u
Mo3_uU_L2_6_15 da_uU_L2_6_15 da_uU_L2_6_15 vdd vdd PMIR W=60u L=1u
Mo4_uU_L2_6_15 gp_2_6_15 da_uU_L2_6_15 vdd vdd PMIR W=60u L=1u
Mt_uU_L2_7_0 ts_uU_L2_7_0 hv_L1_1 0 0 NMIR W=48.0u L=1u
Mo1_uU_L2_7_0 da_uU_L2_7_0 d1bar_L2 ts_uU_L2_7_0 0 NMIR W=20u L=1u
Mo2_uU_L2_7_0 gp_2_7_0 dpre_L2_7 ts_uU_L2_7_0 0 NMIR W=20u L=1u
Mo3_uU_L2_7_0 da_uU_L2_7_0 da_uU_L2_7_0 vdd vdd PMIR W=60u L=1u
Mo4_uU_L2_7_0 gp_2_7_0 da_uU_L2_7_0 vdd vdd PMIR W=60u L=1u
Mt_uU_L2_7_1 ts_uU_L2_7_1 hv_L1_2 0 0 NMIR W=48.0u L=1u
Mo1_uU_L2_7_1 da_uU_L2_7_1 d1bar_L2 ts_uU_L2_7_1 0 NMIR W=20u L=1u
Mo2_uU_L2_7_1 gp_2_7_1 dpre_L2_7 ts_uU_L2_7_1 0 NMIR W=20u L=1u
Mo3_uU_L2_7_1 da_uU_L2_7_1 da_uU_L2_7_1 vdd vdd PMIR W=60u L=1u
Mo4_uU_L2_7_1 gp_2_7_1 da_uU_L2_7_1 vdd vdd PMIR W=60u L=1u
Mt_uU_L2_7_2 ts_uU_L2_7_2 hv_L1_5 0 0 NMIR W=48.0u L=1u
Mo1_uU_L2_7_2 da_uU_L2_7_2 d1bar_L2 ts_uU_L2_7_2 0 NMIR W=20u L=1u
Mo2_uU_L2_7_2 gp_2_7_2 dpre_L2_7 ts_uU_L2_7_2 0 NMIR W=20u L=1u
Mo3_uU_L2_7_2 da_uU_L2_7_2 da_uU_L2_7_2 vdd vdd PMIR W=60u L=1u
Mo4_uU_L2_7_2 gp_2_7_2 da_uU_L2_7_2 vdd vdd PMIR W=60u L=1u
Mt_uU_L2_7_3 ts_uU_L2_7_3 hv_L1_7 0 0 NMIR W=48.0u L=1u
Mo1_uU_L2_7_3 da_uU_L2_7_3 d1bar_L2 ts_uU_L2_7_3 0 NMIR W=20u L=1u
Mo2_uU_L2_7_3 gp_2_7_3 dpre_L2_7 ts_uU_L2_7_3 0 NMIR W=20u L=1u
Mo3_uU_L2_7_3 da_uU_L2_7_3 da_uU_L2_7_3 vdd vdd PMIR W=60u L=1u
Mo4_uU_L2_7_3 gp_2_7_3 da_uU_L2_7_3 vdd vdd PMIR W=60u L=1u
Mt_uU_L2_7_4 ts_uU_L2_7_4 hv_L1_11 0 0 NMIR W=48.0u L=1u
Mo1_uU_L2_7_4 da_uU_L2_7_4 d1bar_L2 ts_uU_L2_7_4 0 NMIR W=20u L=1u
Mo2_uU_L2_7_4 gp_2_7_4 dpre_L2_7 ts_uU_L2_7_4 0 NMIR W=20u L=1u
Mo3_uU_L2_7_4 da_uU_L2_7_4 da_uU_L2_7_4 vdd vdd PMIR W=60u L=1u
Mo4_uU_L2_7_4 gp_2_7_4 da_uU_L2_7_4 vdd vdd PMIR W=60u L=1u
Mt_uU_L2_7_5 ts_uU_L2_7_5 hv_L1_13 0 0 NMIR W=48.0u L=1u
Mo1_uU_L2_7_5 da_uU_L2_7_5 d1bar_L2 ts_uU_L2_7_5 0 NMIR W=20u L=1u
Mo2_uU_L2_7_5 gp_2_7_5 dpre_L2_7 ts_uU_L2_7_5 0 NMIR W=20u L=1u
Mo3_uU_L2_7_5 da_uU_L2_7_5 da_uU_L2_7_5 vdd vdd PMIR W=60u L=1u
Mo4_uU_L2_7_5 gp_2_7_5 da_uU_L2_7_5 vdd vdd PMIR W=60u L=1u
Mt_uU_L2_7_6 ts_uU_L2_7_6 hv_L1_14 0 0 NMIR W=48.0u L=1u
Mo1_uU_L2_7_6 da_uU_L2_7_6 d1bar_L2 ts_uU_L2_7_6 0 NMIR W=20u L=1u
Mo2_uU_L2_7_6 gp_2_7_6 dpre_L2_7 ts_uU_L2_7_6 0 NMIR W=20u L=1u
Mo3_uU_L2_7_6 da_uU_L2_7_6 da_uU_L2_7_6 vdd vdd PMIR W=60u L=1u
Mo4_uU_L2_7_6 gp_2_7_6 da_uU_L2_7_6 vdd vdd PMIR W=60u L=1u
Mt_uU_L2_7_7 ts_uU_L2_7_7 hv_L1_15 0 0 NMIR W=48.0u L=1u
Mo1_uU_L2_7_7 da_uU_L2_7_7 d1bar_L2 ts_uU_L2_7_7 0 NMIR W=20u L=1u
Mo2_uU_L2_7_7 gp_2_7_7 dpre_L2_7 ts_uU_L2_7_7 0 NMIR W=20u L=1u
Mo3_uU_L2_7_7 da_uU_L2_7_7 da_uU_L2_7_7 vdd vdd PMIR W=60u L=1u
Mo4_uU_L2_7_7 gp_2_7_7 da_uU_L2_7_7 vdd vdd PMIR W=60u L=1u
Mt_uU_L2_7_8 ts_uU_L2_7_8 hv_L1_16 0 0 NMIR W=48.0u L=1u
Mo1_uU_L2_7_8 da_uU_L2_7_8 d1bar_L2 ts_uU_L2_7_8 0 NMIR W=20u L=1u
Mo2_uU_L2_7_8 gp_2_7_8 dpre_L2_7 ts_uU_L2_7_8 0 NMIR W=20u L=1u
Mo3_uU_L2_7_8 da_uU_L2_7_8 da_uU_L2_7_8 vdd vdd PMIR W=60u L=1u
Mo4_uU_L2_7_8 gp_2_7_8 da_uU_L2_7_8 vdd vdd PMIR W=60u L=1u
Mt_uU_L2_7_9 ts_uU_L2_7_9 hv_L1_19 0 0 NMIR W=48.0u L=1u
Mo1_uU_L2_7_9 da_uU_L2_7_9 d1bar_L2 ts_uU_L2_7_9 0 NMIR W=20u L=1u
Mo2_uU_L2_7_9 gp_2_7_9 dpre_L2_7 ts_uU_L2_7_9 0 NMIR W=20u L=1u
Mo3_uU_L2_7_9 da_uU_L2_7_9 da_uU_L2_7_9 vdd vdd PMIR W=60u L=1u
Mo4_uU_L2_7_9 gp_2_7_9 da_uU_L2_7_9 vdd vdd PMIR W=60u L=1u
Mt_uU_L2_7_10 ts_uU_L2_7_10 hv_L1_24 0 0 NMIR W=48.0u L=1u
Mo1_uU_L2_7_10 da_uU_L2_7_10 d1bar_L2 ts_uU_L2_7_10 0 NMIR W=20u L=1u
Mo2_uU_L2_7_10 gp_2_7_10 dpre_L2_7 ts_uU_L2_7_10 0 NMIR W=20u L=1u
Mo3_uU_L2_7_10 da_uU_L2_7_10 da_uU_L2_7_10 vdd vdd PMIR W=60u L=1u
Mo4_uU_L2_7_10 gp_2_7_10 da_uU_L2_7_10 vdd vdd PMIR W=60u L=1u
Mt_uU_L2_7_11 ts_uU_L2_7_11 hv_L1_25 0 0 NMIR W=48.0u L=1u
Mo1_uU_L2_7_11 da_uU_L2_7_11 d1bar_L2 ts_uU_L2_7_11 0 NMIR W=20u L=1u
Mo2_uU_L2_7_11 gp_2_7_11 dpre_L2_7 ts_uU_L2_7_11 0 NMIR W=20u L=1u
Mo3_uU_L2_7_11 da_uU_L2_7_11 da_uU_L2_7_11 vdd vdd PMIR W=60u L=1u
Mo4_uU_L2_7_11 gp_2_7_11 da_uU_L2_7_11 vdd vdd PMIR W=60u L=1u
Mt_uU_L2_7_12 ts_uU_L2_7_12 hv_L1_29 0 0 NMIR W=48.0u L=1u
Mo1_uU_L2_7_12 da_uU_L2_7_12 d1bar_L2 ts_uU_L2_7_12 0 NMIR W=20u L=1u
Mo2_uU_L2_7_12 gp_2_7_12 dpre_L2_7 ts_uU_L2_7_12 0 NMIR W=20u L=1u
Mo3_uU_L2_7_12 da_uU_L2_7_12 da_uU_L2_7_12 vdd vdd PMIR W=60u L=1u
Mo4_uU_L2_7_12 gp_2_7_12 da_uU_L2_7_12 vdd vdd PMIR W=60u L=1u
Mt_uU_L2_7_13 ts_uU_L2_7_13 hv_L1_31 0 0 NMIR W=48.0u L=1u
Mo1_uU_L2_7_13 da_uU_L2_7_13 d1bar_L2 ts_uU_L2_7_13 0 NMIR W=20u L=1u
Mo2_uU_L2_7_13 gp_2_7_13 dpre_L2_7 ts_uU_L2_7_13 0 NMIR W=20u L=1u
Mo3_uU_L2_7_13 da_uU_L2_7_13 da_uU_L2_7_13 vdd vdd PMIR W=60u L=1u
Mo4_uU_L2_7_13 gp_2_7_13 da_uU_L2_7_13 vdd vdd PMIR W=60u L=1u
Mt_uU_L2_7_14 ts_uU_L2_7_14 hv_L1_33 0 0 NMIR W=48.0u L=1u
Mo1_uU_L2_7_14 da_uU_L2_7_14 d1bar_L2 ts_uU_L2_7_14 0 NMIR W=20u L=1u
Mo2_uU_L2_7_14 gp_2_7_14 dpre_L2_7 ts_uU_L2_7_14 0 NMIR W=20u L=1u
Mo3_uU_L2_7_14 da_uU_L2_7_14 da_uU_L2_7_14 vdd vdd PMIR W=60u L=1u
Mo4_uU_L2_7_14 gp_2_7_14 da_uU_L2_7_14 vdd vdd PMIR W=60u L=1u
Mt_uU_L2_7_15 ts_uU_L2_7_15 hv_L1_35 0 0 NMIR W=48.0u L=1u
Mo1_uU_L2_7_15 da_uU_L2_7_15 d1bar_L2 ts_uU_L2_7_15 0 NMIR W=20u L=1u
Mo2_uU_L2_7_15 gp_2_7_15 dpre_L2_7 ts_uU_L2_7_15 0 NMIR W=20u L=1u
Mo3_uU_L2_7_15 da_uU_L2_7_15 da_uU_L2_7_15 vdd vdd PMIR W=60u L=1u
Mo4_uU_L2_7_15 gp_2_7_15 da_uU_L2_7_15 vdd vdd PMIR W=60u L=1u
Mt_uU_L2_8_0 ts_uU_L2_8_0 hv_L1_3 0 0 NMIR W=48.0u L=1u
Mo1_uU_L2_8_0 da_uU_L2_8_0 d1bar_L2 ts_uU_L2_8_0 0 NMIR W=20u L=1u
Mo2_uU_L2_8_0 gp_2_8_0 dpre_L2_8 ts_uU_L2_8_0 0 NMIR W=20u L=1u
Mo3_uU_L2_8_0 da_uU_L2_8_0 da_uU_L2_8_0 vdd vdd PMIR W=60u L=1u
Mo4_uU_L2_8_0 gp_2_8_0 da_uU_L2_8_0 vdd vdd PMIR W=60u L=1u
Mt_uU_L2_8_1 ts_uU_L2_8_1 hv_L1_9 0 0 NMIR W=48.0u L=1u
Mo1_uU_L2_8_1 da_uU_L2_8_1 d1bar_L2 ts_uU_L2_8_1 0 NMIR W=20u L=1u
Mo2_uU_L2_8_1 gp_2_8_1 dpre_L2_8 ts_uU_L2_8_1 0 NMIR W=20u L=1u
Mo3_uU_L2_8_1 da_uU_L2_8_1 da_uU_L2_8_1 vdd vdd PMIR W=60u L=1u
Mo4_uU_L2_8_1 gp_2_8_1 da_uU_L2_8_1 vdd vdd PMIR W=60u L=1u
Mt_uU_L2_8_2 ts_uU_L2_8_2 hv_L1_11 0 0 NMIR W=48.0u L=1u
Mo1_uU_L2_8_2 da_uU_L2_8_2 d1bar_L2 ts_uU_L2_8_2 0 NMIR W=20u L=1u
Mo2_uU_L2_8_2 gp_2_8_2 dpre_L2_8 ts_uU_L2_8_2 0 NMIR W=20u L=1u
Mo3_uU_L2_8_2 da_uU_L2_8_2 da_uU_L2_8_2 vdd vdd PMIR W=60u L=1u
Mo4_uU_L2_8_2 gp_2_8_2 da_uU_L2_8_2 vdd vdd PMIR W=60u L=1u
Mt_uU_L2_8_3 ts_uU_L2_8_3 hv_L1_13 0 0 NMIR W=48.0u L=1u
Mo1_uU_L2_8_3 da_uU_L2_8_3 d1bar_L2 ts_uU_L2_8_3 0 NMIR W=20u L=1u
Mo2_uU_L2_8_3 gp_2_8_3 dpre_L2_8 ts_uU_L2_8_3 0 NMIR W=20u L=1u
Mo3_uU_L2_8_3 da_uU_L2_8_3 da_uU_L2_8_3 vdd vdd PMIR W=60u L=1u
Mo4_uU_L2_8_3 gp_2_8_3 da_uU_L2_8_3 vdd vdd PMIR W=60u L=1u
Mt_uU_L2_8_4 ts_uU_L2_8_4 hv_L1_15 0 0 NMIR W=48.0u L=1u
Mo1_uU_L2_8_4 da_uU_L2_8_4 d1bar_L2 ts_uU_L2_8_4 0 NMIR W=20u L=1u
Mo2_uU_L2_8_4 gp_2_8_4 dpre_L2_8 ts_uU_L2_8_4 0 NMIR W=20u L=1u
Mo3_uU_L2_8_4 da_uU_L2_8_4 da_uU_L2_8_4 vdd vdd PMIR W=60u L=1u
Mo4_uU_L2_8_4 gp_2_8_4 da_uU_L2_8_4 vdd vdd PMIR W=60u L=1u
Mt_uU_L2_8_5 ts_uU_L2_8_5 hv_L1_16 0 0 NMIR W=48.0u L=1u
Mo1_uU_L2_8_5 da_uU_L2_8_5 d1bar_L2 ts_uU_L2_8_5 0 NMIR W=20u L=1u
Mo2_uU_L2_8_5 gp_2_8_5 dpre_L2_8 ts_uU_L2_8_5 0 NMIR W=20u L=1u
Mo3_uU_L2_8_5 da_uU_L2_8_5 da_uU_L2_8_5 vdd vdd PMIR W=60u L=1u
Mo4_uU_L2_8_5 gp_2_8_5 da_uU_L2_8_5 vdd vdd PMIR W=60u L=1u
Mt_uU_L2_8_6 ts_uU_L2_8_6 hv_L1_17 0 0 NMIR W=48.0u L=1u
Mo1_uU_L2_8_6 da_uU_L2_8_6 d1bar_L2 ts_uU_L2_8_6 0 NMIR W=20u L=1u
Mo2_uU_L2_8_6 gp_2_8_6 dpre_L2_8 ts_uU_L2_8_6 0 NMIR W=20u L=1u
Mo3_uU_L2_8_6 da_uU_L2_8_6 da_uU_L2_8_6 vdd vdd PMIR W=60u L=1u
Mo4_uU_L2_8_6 gp_2_8_6 da_uU_L2_8_6 vdd vdd PMIR W=60u L=1u
Mt_uU_L2_8_7 ts_uU_L2_8_7 hv_L1_27 0 0 NMIR W=48.0u L=1u
Mo1_uU_L2_8_7 da_uU_L2_8_7 d1bar_L2 ts_uU_L2_8_7 0 NMIR W=20u L=1u
Mo2_uU_L2_8_7 gp_2_8_7 dpre_L2_8 ts_uU_L2_8_7 0 NMIR W=20u L=1u
Mo3_uU_L2_8_7 da_uU_L2_8_7 da_uU_L2_8_7 vdd vdd PMIR W=60u L=1u
Mo4_uU_L2_8_7 gp_2_8_7 da_uU_L2_8_7 vdd vdd PMIR W=60u L=1u
Mt_uU_L2_8_8 ts_uU_L2_8_8 hv_L1_30 0 0 NMIR W=48.0u L=1u
Mo1_uU_L2_8_8 da_uU_L2_8_8 d1bar_L2 ts_uU_L2_8_8 0 NMIR W=20u L=1u
Mo2_uU_L2_8_8 gp_2_8_8 dpre_L2_8 ts_uU_L2_8_8 0 NMIR W=20u L=1u
Mo3_uU_L2_8_8 da_uU_L2_8_8 da_uU_L2_8_8 vdd vdd PMIR W=60u L=1u
Mo4_uU_L2_8_8 gp_2_8_8 da_uU_L2_8_8 vdd vdd PMIR W=60u L=1u
Mt_uU_L2_8_9 ts_uU_L2_8_9 hv_L1_34 0 0 NMIR W=48.0u L=1u
Mo1_uU_L2_8_9 da_uU_L2_8_9 d1bar_L2 ts_uU_L2_8_9 0 NMIR W=20u L=1u
Mo2_uU_L2_8_9 gp_2_8_9 dpre_L2_8 ts_uU_L2_8_9 0 NMIR W=20u L=1u
Mo3_uU_L2_8_9 da_uU_L2_8_9 da_uU_L2_8_9 vdd vdd PMIR W=60u L=1u
Mo4_uU_L2_8_9 gp_2_8_9 da_uU_L2_8_9 vdd vdd PMIR W=60u L=1u
Mt_uU_L2_8_10 ts_uU_L2_8_10 hv_L1_35 0 0 NMIR W=48.0u L=1u
Mo1_uU_L2_8_10 da_uU_L2_8_10 d1bar_L2 ts_uU_L2_8_10 0 NMIR W=20u L=1u
Mo2_uU_L2_8_10 gp_2_8_10 dpre_L2_8 ts_uU_L2_8_10 0 NMIR W=20u L=1u
Mo3_uU_L2_8_10 da_uU_L2_8_10 da_uU_L2_8_10 vdd vdd PMIR W=60u L=1u
Mo4_uU_L2_8_10 gp_2_8_10 da_uU_L2_8_10 vdd vdd PMIR W=60u L=1u
Mt_uU_L2_8_11 ts_uU_L2_8_11 hv_L1_39 0 0 NMIR W=48.0u L=1u
Mo1_uU_L2_8_11 da_uU_L2_8_11 d1bar_L2 ts_uU_L2_8_11 0 NMIR W=20u L=1u
Mo2_uU_L2_8_11 gp_2_8_11 dpre_L2_8 ts_uU_L2_8_11 0 NMIR W=20u L=1u
Mo3_uU_L2_8_11 da_uU_L2_8_11 da_uU_L2_8_11 vdd vdd PMIR W=60u L=1u
Mo4_uU_L2_8_11 gp_2_8_11 da_uU_L2_8_11 vdd vdd PMIR W=60u L=1u
Mt_uU_L2_8_12 ts_uU_L2_8_12 hv_L1_41 0 0 NMIR W=48.0u L=1u
Mo1_uU_L2_8_12 da_uU_L2_8_12 d1bar_L2 ts_uU_L2_8_12 0 NMIR W=20u L=1u
Mo2_uU_L2_8_12 gp_2_8_12 dpre_L2_8 ts_uU_L2_8_12 0 NMIR W=20u L=1u
Mo3_uU_L2_8_12 da_uU_L2_8_12 da_uU_L2_8_12 vdd vdd PMIR W=60u L=1u
Mo4_uU_L2_8_12 gp_2_8_12 da_uU_L2_8_12 vdd vdd PMIR W=60u L=1u
Mt_uU_L2_8_13 ts_uU_L2_8_13 hv_L1_44 0 0 NMIR W=48.0u L=1u
Mo1_uU_L2_8_13 da_uU_L2_8_13 d1bar_L2 ts_uU_L2_8_13 0 NMIR W=20u L=1u
Mo2_uU_L2_8_13 gp_2_8_13 dpre_L2_8 ts_uU_L2_8_13 0 NMIR W=20u L=1u
Mo3_uU_L2_8_13 da_uU_L2_8_13 da_uU_L2_8_13 vdd vdd PMIR W=60u L=1u
Mo4_uU_L2_8_13 gp_2_8_13 da_uU_L2_8_13 vdd vdd PMIR W=60u L=1u
Mt_uU_L2_8_14 ts_uU_L2_8_14 hv_L1_45 0 0 NMIR W=48.0u L=1u
Mo1_uU_L2_8_14 da_uU_L2_8_14 d1bar_L2 ts_uU_L2_8_14 0 NMIR W=20u L=1u
Mo2_uU_L2_8_14 gp_2_8_14 dpre_L2_8 ts_uU_L2_8_14 0 NMIR W=20u L=1u
Mo3_uU_L2_8_14 da_uU_L2_8_14 da_uU_L2_8_14 vdd vdd PMIR W=60u L=1u
Mo4_uU_L2_8_14 gp_2_8_14 da_uU_L2_8_14 vdd vdd PMIR W=60u L=1u
Mt_uU_L2_8_15 ts_uU_L2_8_15 hv_L1_46 0 0 NMIR W=48.0u L=1u
Mo1_uU_L2_8_15 da_uU_L2_8_15 d1bar_L2 ts_uU_L2_8_15 0 NMIR W=20u L=1u
Mo2_uU_L2_8_15 gp_2_8_15 dpre_L2_8 ts_uU_L2_8_15 0 NMIR W=20u L=1u
Mo3_uU_L2_8_15 da_uU_L2_8_15 da_uU_L2_8_15 vdd vdd PMIR W=60u L=1u
Mo4_uU_L2_8_15 gp_2_8_15 da_uU_L2_8_15 vdd vdd PMIR W=60u L=1u
Mt_uU_L2_9_0 ts_uU_L2_9_0 hv_L1_3 0 0 NMIR W=48.0u L=1u
Mo1_uU_L2_9_0 da_uU_L2_9_0 d1bar_L2 ts_uU_L2_9_0 0 NMIR W=20u L=1u
Mo2_uU_L2_9_0 gp_2_9_0 dpre_L2_9 ts_uU_L2_9_0 0 NMIR W=20u L=1u
Mo3_uU_L2_9_0 da_uU_L2_9_0 da_uU_L2_9_0 vdd vdd PMIR W=60u L=1u
Mo4_uU_L2_9_0 gp_2_9_0 da_uU_L2_9_0 vdd vdd PMIR W=60u L=1u
Mt_uU_L2_9_1 ts_uU_L2_9_1 hv_L1_4 0 0 NMIR W=48.0u L=1u
Mo1_uU_L2_9_1 da_uU_L2_9_1 d1bar_L2 ts_uU_L2_9_1 0 NMIR W=20u L=1u
Mo2_uU_L2_9_1 gp_2_9_1 dpre_L2_9 ts_uU_L2_9_1 0 NMIR W=20u L=1u
Mo3_uU_L2_9_1 da_uU_L2_9_1 da_uU_L2_9_1 vdd vdd PMIR W=60u L=1u
Mo4_uU_L2_9_1 gp_2_9_1 da_uU_L2_9_1 vdd vdd PMIR W=60u L=1u
Mt_uU_L2_9_2 ts_uU_L2_9_2 hv_L1_7 0 0 NMIR W=48.0u L=1u
Mo1_uU_L2_9_2 da_uU_L2_9_2 d1bar_L2 ts_uU_L2_9_2 0 NMIR W=20u L=1u
Mo2_uU_L2_9_2 gp_2_9_2 dpre_L2_9 ts_uU_L2_9_2 0 NMIR W=20u L=1u
Mo3_uU_L2_9_2 da_uU_L2_9_2 da_uU_L2_9_2 vdd vdd PMIR W=60u L=1u
Mo4_uU_L2_9_2 gp_2_9_2 da_uU_L2_9_2 vdd vdd PMIR W=60u L=1u
Mt_uU_L2_9_3 ts_uU_L2_9_3 hv_L1_10 0 0 NMIR W=48.0u L=1u
Mo1_uU_L2_9_3 da_uU_L2_9_3 d1bar_L2 ts_uU_L2_9_3 0 NMIR W=20u L=1u
Mo2_uU_L2_9_3 gp_2_9_3 dpre_L2_9 ts_uU_L2_9_3 0 NMIR W=20u L=1u
Mo3_uU_L2_9_3 da_uU_L2_9_3 da_uU_L2_9_3 vdd vdd PMIR W=60u L=1u
Mo4_uU_L2_9_3 gp_2_9_3 da_uU_L2_9_3 vdd vdd PMIR W=60u L=1u
Mt_uU_L2_9_4 ts_uU_L2_9_4 hv_L1_11 0 0 NMIR W=48.0u L=1u
Mo1_uU_L2_9_4 da_uU_L2_9_4 d1bar_L2 ts_uU_L2_9_4 0 NMIR W=20u L=1u
Mo2_uU_L2_9_4 gp_2_9_4 dpre_L2_9 ts_uU_L2_9_4 0 NMIR W=20u L=1u
Mo3_uU_L2_9_4 da_uU_L2_9_4 da_uU_L2_9_4 vdd vdd PMIR W=60u L=1u
Mo4_uU_L2_9_4 gp_2_9_4 da_uU_L2_9_4 vdd vdd PMIR W=60u L=1u
Mt_uU_L2_9_5 ts_uU_L2_9_5 hv_L1_12 0 0 NMIR W=48.0u L=1u
Mo1_uU_L2_9_5 da_uU_L2_9_5 d1bar_L2 ts_uU_L2_9_5 0 NMIR W=20u L=1u
Mo2_uU_L2_9_5 gp_2_9_5 dpre_L2_9 ts_uU_L2_9_5 0 NMIR W=20u L=1u
Mo3_uU_L2_9_5 da_uU_L2_9_5 da_uU_L2_9_5 vdd vdd PMIR W=60u L=1u
Mo4_uU_L2_9_5 gp_2_9_5 da_uU_L2_9_5 vdd vdd PMIR W=60u L=1u
Mt_uU_L2_9_6 ts_uU_L2_9_6 hv_L1_16 0 0 NMIR W=48.0u L=1u
Mo1_uU_L2_9_6 da_uU_L2_9_6 d1bar_L2 ts_uU_L2_9_6 0 NMIR W=20u L=1u
Mo2_uU_L2_9_6 gp_2_9_6 dpre_L2_9 ts_uU_L2_9_6 0 NMIR W=20u L=1u
Mo3_uU_L2_9_6 da_uU_L2_9_6 da_uU_L2_9_6 vdd vdd PMIR W=60u L=1u
Mo4_uU_L2_9_6 gp_2_9_6 da_uU_L2_9_6 vdd vdd PMIR W=60u L=1u
Mt_uU_L2_9_7 ts_uU_L2_9_7 hv_L1_19 0 0 NMIR W=48.0u L=1u
Mo1_uU_L2_9_7 da_uU_L2_9_7 d1bar_L2 ts_uU_L2_9_7 0 NMIR W=20u L=1u
Mo2_uU_L2_9_7 gp_2_9_7 dpre_L2_9 ts_uU_L2_9_7 0 NMIR W=20u L=1u
Mo3_uU_L2_9_7 da_uU_L2_9_7 da_uU_L2_9_7 vdd vdd PMIR W=60u L=1u
Mo4_uU_L2_9_7 gp_2_9_7 da_uU_L2_9_7 vdd vdd PMIR W=60u L=1u
Mt_uU_L2_9_8 ts_uU_L2_9_8 hv_L1_22 0 0 NMIR W=48.0u L=1u
Mo1_uU_L2_9_8 da_uU_L2_9_8 d1bar_L2 ts_uU_L2_9_8 0 NMIR W=20u L=1u
Mo2_uU_L2_9_8 gp_2_9_8 dpre_L2_9 ts_uU_L2_9_8 0 NMIR W=20u L=1u
Mo3_uU_L2_9_8 da_uU_L2_9_8 da_uU_L2_9_8 vdd vdd PMIR W=60u L=1u
Mo4_uU_L2_9_8 gp_2_9_8 da_uU_L2_9_8 vdd vdd PMIR W=60u L=1u
Mt_uU_L2_9_9 ts_uU_L2_9_9 hv_L1_30 0 0 NMIR W=48.0u L=1u
Mo1_uU_L2_9_9 da_uU_L2_9_9 d1bar_L2 ts_uU_L2_9_9 0 NMIR W=20u L=1u
Mo2_uU_L2_9_9 gp_2_9_9 dpre_L2_9 ts_uU_L2_9_9 0 NMIR W=20u L=1u
Mo3_uU_L2_9_9 da_uU_L2_9_9 da_uU_L2_9_9 vdd vdd PMIR W=60u L=1u
Mo4_uU_L2_9_9 gp_2_9_9 da_uU_L2_9_9 vdd vdd PMIR W=60u L=1u
Mt_uU_L2_9_10 ts_uU_L2_9_10 hv_L1_31 0 0 NMIR W=48.0u L=1u
Mo1_uU_L2_9_10 da_uU_L2_9_10 d1bar_L2 ts_uU_L2_9_10 0 NMIR W=20u L=1u
Mo2_uU_L2_9_10 gp_2_9_10 dpre_L2_9 ts_uU_L2_9_10 0 NMIR W=20u L=1u
Mo3_uU_L2_9_10 da_uU_L2_9_10 da_uU_L2_9_10 vdd vdd PMIR W=60u L=1u
Mo4_uU_L2_9_10 gp_2_9_10 da_uU_L2_9_10 vdd vdd PMIR W=60u L=1u
Mt_uU_L2_9_11 ts_uU_L2_9_11 hv_L1_39 0 0 NMIR W=48.0u L=1u
Mo1_uU_L2_9_11 da_uU_L2_9_11 d1bar_L2 ts_uU_L2_9_11 0 NMIR W=20u L=1u
Mo2_uU_L2_9_11 gp_2_9_11 dpre_L2_9 ts_uU_L2_9_11 0 NMIR W=20u L=1u
Mo3_uU_L2_9_11 da_uU_L2_9_11 da_uU_L2_9_11 vdd vdd PMIR W=60u L=1u
Mo4_uU_L2_9_11 gp_2_9_11 da_uU_L2_9_11 vdd vdd PMIR W=60u L=1u
Mt_uU_L2_9_12 ts_uU_L2_9_12 hv_L1_41 0 0 NMIR W=48.0u L=1u
Mo1_uU_L2_9_12 da_uU_L2_9_12 d1bar_L2 ts_uU_L2_9_12 0 NMIR W=20u L=1u
Mo2_uU_L2_9_12 gp_2_9_12 dpre_L2_9 ts_uU_L2_9_12 0 NMIR W=20u L=1u
Mo3_uU_L2_9_12 da_uU_L2_9_12 da_uU_L2_9_12 vdd vdd PMIR W=60u L=1u
Mo4_uU_L2_9_12 gp_2_9_12 da_uU_L2_9_12 vdd vdd PMIR W=60u L=1u
Mt_uU_L2_9_13 ts_uU_L2_9_13 hv_L1_42 0 0 NMIR W=48.0u L=1u
Mo1_uU_L2_9_13 da_uU_L2_9_13 d1bar_L2 ts_uU_L2_9_13 0 NMIR W=20u L=1u
Mo2_uU_L2_9_13 gp_2_9_13 dpre_L2_9 ts_uU_L2_9_13 0 NMIR W=20u L=1u
Mo3_uU_L2_9_13 da_uU_L2_9_13 da_uU_L2_9_13 vdd vdd PMIR W=60u L=1u
Mo4_uU_L2_9_13 gp_2_9_13 da_uU_L2_9_13 vdd vdd PMIR W=60u L=1u
Mt_uU_L2_9_14 ts_uU_L2_9_14 hv_L1_43 0 0 NMIR W=48.0u L=1u
Mo1_uU_L2_9_14 da_uU_L2_9_14 d1bar_L2 ts_uU_L2_9_14 0 NMIR W=20u L=1u
Mo2_uU_L2_9_14 gp_2_9_14 dpre_L2_9 ts_uU_L2_9_14 0 NMIR W=20u L=1u
Mo3_uU_L2_9_14 da_uU_L2_9_14 da_uU_L2_9_14 vdd vdd PMIR W=60u L=1u
Mo4_uU_L2_9_14 gp_2_9_14 da_uU_L2_9_14 vdd vdd PMIR W=60u L=1u
Mt_uU_L2_9_15 ts_uU_L2_9_15 hv_L1_45 0 0 NMIR W=48.0u L=1u
Mo1_uU_L2_9_15 da_uU_L2_9_15 d1bar_L2 ts_uU_L2_9_15 0 NMIR W=20u L=1u
Mo2_uU_L2_9_15 gp_2_9_15 dpre_L2_9 ts_uU_L2_9_15 0 NMIR W=20u L=1u
Mo3_uU_L2_9_15 da_uU_L2_9_15 da_uU_L2_9_15 vdd vdd PMIR W=60u L=1u
Mo4_uU_L2_9_15 gp_2_9_15 da_uU_L2_9_15 vdd vdd PMIR W=60u L=1u
Mt_uU_L2_10_0 ts_uU_L2_10_0 hv_L1_2 0 0 NMIR W=48.0u L=1u
Mo1_uU_L2_10_0 da_uU_L2_10_0 d1bar_L2 ts_uU_L2_10_0 0 NMIR W=20u L=1u
Mo2_uU_L2_10_0 gp_2_10_0 dpre_L2_10 ts_uU_L2_10_0 0 NMIR W=20u L=1u
Mo3_uU_L2_10_0 da_uU_L2_10_0 da_uU_L2_10_0 vdd vdd PMIR W=60u L=1u
Mo4_uU_L2_10_0 gp_2_10_0 da_uU_L2_10_0 vdd vdd PMIR W=60u L=1u
Mt_uU_L2_10_1 ts_uU_L2_10_1 hv_L1_3 0 0 NMIR W=48.0u L=1u
Mo1_uU_L2_10_1 da_uU_L2_10_1 d1bar_L2 ts_uU_L2_10_1 0 NMIR W=20u L=1u
Mo2_uU_L2_10_1 gp_2_10_1 dpre_L2_10 ts_uU_L2_10_1 0 NMIR W=20u L=1u
Mo3_uU_L2_10_1 da_uU_L2_10_1 da_uU_L2_10_1 vdd vdd PMIR W=60u L=1u
Mo4_uU_L2_10_1 gp_2_10_1 da_uU_L2_10_1 vdd vdd PMIR W=60u L=1u
Mt_uU_L2_10_2 ts_uU_L2_10_2 hv_L1_6 0 0 NMIR W=48.0u L=1u
Mo1_uU_L2_10_2 da_uU_L2_10_2 d1bar_L2 ts_uU_L2_10_2 0 NMIR W=20u L=1u
Mo2_uU_L2_10_2 gp_2_10_2 dpre_L2_10 ts_uU_L2_10_2 0 NMIR W=20u L=1u
Mo3_uU_L2_10_2 da_uU_L2_10_2 da_uU_L2_10_2 vdd vdd PMIR W=60u L=1u
Mo4_uU_L2_10_2 gp_2_10_2 da_uU_L2_10_2 vdd vdd PMIR W=60u L=1u
Mt_uU_L2_10_3 ts_uU_L2_10_3 hv_L1_7 0 0 NMIR W=48.0u L=1u
Mo1_uU_L2_10_3 da_uU_L2_10_3 d1bar_L2 ts_uU_L2_10_3 0 NMIR W=20u L=1u
Mo2_uU_L2_10_3 gp_2_10_3 dpre_L2_10 ts_uU_L2_10_3 0 NMIR W=20u L=1u
Mo3_uU_L2_10_3 da_uU_L2_10_3 da_uU_L2_10_3 vdd vdd PMIR W=60u L=1u
Mo4_uU_L2_10_3 gp_2_10_3 da_uU_L2_10_3 vdd vdd PMIR W=60u L=1u
Mt_uU_L2_10_4 ts_uU_L2_10_4 hv_L1_10 0 0 NMIR W=48.0u L=1u
Mo1_uU_L2_10_4 da_uU_L2_10_4 d1bar_L2 ts_uU_L2_10_4 0 NMIR W=20u L=1u
Mo2_uU_L2_10_4 gp_2_10_4 dpre_L2_10 ts_uU_L2_10_4 0 NMIR W=20u L=1u
Mo3_uU_L2_10_4 da_uU_L2_10_4 da_uU_L2_10_4 vdd vdd PMIR W=60u L=1u
Mo4_uU_L2_10_4 gp_2_10_4 da_uU_L2_10_4 vdd vdd PMIR W=60u L=1u
Mt_uU_L2_10_5 ts_uU_L2_10_5 hv_L1_12 0 0 NMIR W=48.0u L=1u
Mo1_uU_L2_10_5 da_uU_L2_10_5 d1bar_L2 ts_uU_L2_10_5 0 NMIR W=20u L=1u
Mo2_uU_L2_10_5 gp_2_10_5 dpre_L2_10 ts_uU_L2_10_5 0 NMIR W=20u L=1u
Mo3_uU_L2_10_5 da_uU_L2_10_5 da_uU_L2_10_5 vdd vdd PMIR W=60u L=1u
Mo4_uU_L2_10_5 gp_2_10_5 da_uU_L2_10_5 vdd vdd PMIR W=60u L=1u
Mt_uU_L2_10_6 ts_uU_L2_10_6 hv_L1_13 0 0 NMIR W=48.0u L=1u
Mo1_uU_L2_10_6 da_uU_L2_10_6 d1bar_L2 ts_uU_L2_10_6 0 NMIR W=20u L=1u
Mo2_uU_L2_10_6 gp_2_10_6 dpre_L2_10 ts_uU_L2_10_6 0 NMIR W=20u L=1u
Mo3_uU_L2_10_6 da_uU_L2_10_6 da_uU_L2_10_6 vdd vdd PMIR W=60u L=1u
Mo4_uU_L2_10_6 gp_2_10_6 da_uU_L2_10_6 vdd vdd PMIR W=60u L=1u
Mt_uU_L2_10_7 ts_uU_L2_10_7 hv_L1_14 0 0 NMIR W=48.0u L=1u
Mo1_uU_L2_10_7 da_uU_L2_10_7 d1bar_L2 ts_uU_L2_10_7 0 NMIR W=20u L=1u
Mo2_uU_L2_10_7 gp_2_10_7 dpre_L2_10 ts_uU_L2_10_7 0 NMIR W=20u L=1u
Mo3_uU_L2_10_7 da_uU_L2_10_7 da_uU_L2_10_7 vdd vdd PMIR W=60u L=1u
Mo4_uU_L2_10_7 gp_2_10_7 da_uU_L2_10_7 vdd vdd PMIR W=60u L=1u
Mt_uU_L2_10_8 ts_uU_L2_10_8 hv_L1_22 0 0 NMIR W=48.0u L=1u
Mo1_uU_L2_10_8 da_uU_L2_10_8 d1bar_L2 ts_uU_L2_10_8 0 NMIR W=20u L=1u
Mo2_uU_L2_10_8 gp_2_10_8 dpre_L2_10 ts_uU_L2_10_8 0 NMIR W=20u L=1u
Mo3_uU_L2_10_8 da_uU_L2_10_8 da_uU_L2_10_8 vdd vdd PMIR W=60u L=1u
Mo4_uU_L2_10_8 gp_2_10_8 da_uU_L2_10_8 vdd vdd PMIR W=60u L=1u
Mt_uU_L2_10_9 ts_uU_L2_10_9 hv_L1_26 0 0 NMIR W=48.0u L=1u
Mo1_uU_L2_10_9 da_uU_L2_10_9 d1bar_L2 ts_uU_L2_10_9 0 NMIR W=20u L=1u
Mo2_uU_L2_10_9 gp_2_10_9 dpre_L2_10 ts_uU_L2_10_9 0 NMIR W=20u L=1u
Mo3_uU_L2_10_9 da_uU_L2_10_9 da_uU_L2_10_9 vdd vdd PMIR W=60u L=1u
Mo4_uU_L2_10_9 gp_2_10_9 da_uU_L2_10_9 vdd vdd PMIR W=60u L=1u
Mt_uU_L2_10_10 ts_uU_L2_10_10 hv_L1_28 0 0 NMIR W=48.0u L=1u
Mo1_uU_L2_10_10 da_uU_L2_10_10 d1bar_L2 ts_uU_L2_10_10 0 NMIR W=20u L=1u
Mo2_uU_L2_10_10 gp_2_10_10 dpre_L2_10 ts_uU_L2_10_10 0 NMIR W=20u L=1u
Mo3_uU_L2_10_10 da_uU_L2_10_10 da_uU_L2_10_10 vdd vdd PMIR W=60u L=1u
Mo4_uU_L2_10_10 gp_2_10_10 da_uU_L2_10_10 vdd vdd PMIR W=60u L=1u
Mt_uU_L2_10_11 ts_uU_L2_10_11 hv_L1_29 0 0 NMIR W=48.0u L=1u
Mo1_uU_L2_10_11 da_uU_L2_10_11 d1bar_L2 ts_uU_L2_10_11 0 NMIR W=20u L=1u
Mo2_uU_L2_10_11 gp_2_10_11 dpre_L2_10 ts_uU_L2_10_11 0 NMIR W=20u L=1u
Mo3_uU_L2_10_11 da_uU_L2_10_11 da_uU_L2_10_11 vdd vdd PMIR W=60u L=1u
Mo4_uU_L2_10_11 gp_2_10_11 da_uU_L2_10_11 vdd vdd PMIR W=60u L=1u
Mt_uU_L2_10_12 ts_uU_L2_10_12 hv_L1_31 0 0 NMIR W=48.0u L=1u
Mo1_uU_L2_10_12 da_uU_L2_10_12 d1bar_L2 ts_uU_L2_10_12 0 NMIR W=20u L=1u
Mo2_uU_L2_10_12 gp_2_10_12 dpre_L2_10 ts_uU_L2_10_12 0 NMIR W=20u L=1u
Mo3_uU_L2_10_12 da_uU_L2_10_12 da_uU_L2_10_12 vdd vdd PMIR W=60u L=1u
Mo4_uU_L2_10_12 gp_2_10_12 da_uU_L2_10_12 vdd vdd PMIR W=60u L=1u
Mt_uU_L2_10_13 ts_uU_L2_10_13 hv_L1_35 0 0 NMIR W=48.0u L=1u
Mo1_uU_L2_10_13 da_uU_L2_10_13 d1bar_L2 ts_uU_L2_10_13 0 NMIR W=20u L=1u
Mo2_uU_L2_10_13 gp_2_10_13 dpre_L2_10 ts_uU_L2_10_13 0 NMIR W=20u L=1u
Mo3_uU_L2_10_13 da_uU_L2_10_13 da_uU_L2_10_13 vdd vdd PMIR W=60u L=1u
Mo4_uU_L2_10_13 gp_2_10_13 da_uU_L2_10_13 vdd vdd PMIR W=60u L=1u
Mt_uU_L2_10_14 ts_uU_L2_10_14 hv_L1_36 0 0 NMIR W=48.0u L=1u
Mo1_uU_L2_10_14 da_uU_L2_10_14 d1bar_L2 ts_uU_L2_10_14 0 NMIR W=20u L=1u
Mo2_uU_L2_10_14 gp_2_10_14 dpre_L2_10 ts_uU_L2_10_14 0 NMIR W=20u L=1u
Mo3_uU_L2_10_14 da_uU_L2_10_14 da_uU_L2_10_14 vdd vdd PMIR W=60u L=1u
Mo4_uU_L2_10_14 gp_2_10_14 da_uU_L2_10_14 vdd vdd PMIR W=60u L=1u
Mt_uU_L2_10_15 ts_uU_L2_10_15 hv_L1_47 0 0 NMIR W=48.0u L=1u
Mo1_uU_L2_10_15 da_uU_L2_10_15 d1bar_L2 ts_uU_L2_10_15 0 NMIR W=20u L=1u
Mo2_uU_L2_10_15 gp_2_10_15 dpre_L2_10 ts_uU_L2_10_15 0 NMIR W=20u L=1u
Mo3_uU_L2_10_15 da_uU_L2_10_15 da_uU_L2_10_15 vdd vdd PMIR W=60u L=1u
Mo4_uU_L2_10_15 gp_2_10_15 da_uU_L2_10_15 vdd vdd PMIR W=60u L=1u
Mt_uU_L2_11_0 ts_uU_L2_11_0 hv_L1_2 0 0 NMIR W=48.0u L=1u
Mo1_uU_L2_11_0 da_uU_L2_11_0 d1bar_L2 ts_uU_L2_11_0 0 NMIR W=20u L=1u
Mo2_uU_L2_11_0 gp_2_11_0 dpre_L2_11 ts_uU_L2_11_0 0 NMIR W=20u L=1u
Mo3_uU_L2_11_0 da_uU_L2_11_0 da_uU_L2_11_0 vdd vdd PMIR W=60u L=1u
Mo4_uU_L2_11_0 gp_2_11_0 da_uU_L2_11_0 vdd vdd PMIR W=60u L=1u
Mt_uU_L2_11_1 ts_uU_L2_11_1 hv_L1_3 0 0 NMIR W=48.0u L=1u
Mo1_uU_L2_11_1 da_uU_L2_11_1 d1bar_L2 ts_uU_L2_11_1 0 NMIR W=20u L=1u
Mo2_uU_L2_11_1 gp_2_11_1 dpre_L2_11 ts_uU_L2_11_1 0 NMIR W=20u L=1u
Mo3_uU_L2_11_1 da_uU_L2_11_1 da_uU_L2_11_1 vdd vdd PMIR W=60u L=1u
Mo4_uU_L2_11_1 gp_2_11_1 da_uU_L2_11_1 vdd vdd PMIR W=60u L=1u
Mt_uU_L2_11_2 ts_uU_L2_11_2 hv_L1_7 0 0 NMIR W=48.0u L=1u
Mo1_uU_L2_11_2 da_uU_L2_11_2 d1bar_L2 ts_uU_L2_11_2 0 NMIR W=20u L=1u
Mo2_uU_L2_11_2 gp_2_11_2 dpre_L2_11 ts_uU_L2_11_2 0 NMIR W=20u L=1u
Mo3_uU_L2_11_2 da_uU_L2_11_2 da_uU_L2_11_2 vdd vdd PMIR W=60u L=1u
Mo4_uU_L2_11_2 gp_2_11_2 da_uU_L2_11_2 vdd vdd PMIR W=60u L=1u
Mt_uU_L2_11_3 ts_uU_L2_11_3 hv_L1_9 0 0 NMIR W=48.0u L=1u
Mo1_uU_L2_11_3 da_uU_L2_11_3 d1bar_L2 ts_uU_L2_11_3 0 NMIR W=20u L=1u
Mo2_uU_L2_11_3 gp_2_11_3 dpre_L2_11 ts_uU_L2_11_3 0 NMIR W=20u L=1u
Mo3_uU_L2_11_3 da_uU_L2_11_3 da_uU_L2_11_3 vdd vdd PMIR W=60u L=1u
Mo4_uU_L2_11_3 gp_2_11_3 da_uU_L2_11_3 vdd vdd PMIR W=60u L=1u
Mt_uU_L2_11_4 ts_uU_L2_11_4 hv_L1_10 0 0 NMIR W=48.0u L=1u
Mo1_uU_L2_11_4 da_uU_L2_11_4 d1bar_L2 ts_uU_L2_11_4 0 NMIR W=20u L=1u
Mo2_uU_L2_11_4 gp_2_11_4 dpre_L2_11 ts_uU_L2_11_4 0 NMIR W=20u L=1u
Mo3_uU_L2_11_4 da_uU_L2_11_4 da_uU_L2_11_4 vdd vdd PMIR W=60u L=1u
Mo4_uU_L2_11_4 gp_2_11_4 da_uU_L2_11_4 vdd vdd PMIR W=60u L=1u
Mt_uU_L2_11_5 ts_uU_L2_11_5 hv_L1_13 0 0 NMIR W=48.0u L=1u
Mo1_uU_L2_11_5 da_uU_L2_11_5 d1bar_L2 ts_uU_L2_11_5 0 NMIR W=20u L=1u
Mo2_uU_L2_11_5 gp_2_11_5 dpre_L2_11 ts_uU_L2_11_5 0 NMIR W=20u L=1u
Mo3_uU_L2_11_5 da_uU_L2_11_5 da_uU_L2_11_5 vdd vdd PMIR W=60u L=1u
Mo4_uU_L2_11_5 gp_2_11_5 da_uU_L2_11_5 vdd vdd PMIR W=60u L=1u
Mt_uU_L2_11_6 ts_uU_L2_11_6 hv_L1_15 0 0 NMIR W=48.0u L=1u
Mo1_uU_L2_11_6 da_uU_L2_11_6 d1bar_L2 ts_uU_L2_11_6 0 NMIR W=20u L=1u
Mo2_uU_L2_11_6 gp_2_11_6 dpre_L2_11 ts_uU_L2_11_6 0 NMIR W=20u L=1u
Mo3_uU_L2_11_6 da_uU_L2_11_6 da_uU_L2_11_6 vdd vdd PMIR W=60u L=1u
Mo4_uU_L2_11_6 gp_2_11_6 da_uU_L2_11_6 vdd vdd PMIR W=60u L=1u
Mt_uU_L2_11_7 ts_uU_L2_11_7 hv_L1_16 0 0 NMIR W=48.0u L=1u
Mo1_uU_L2_11_7 da_uU_L2_11_7 d1bar_L2 ts_uU_L2_11_7 0 NMIR W=20u L=1u
Mo2_uU_L2_11_7 gp_2_11_7 dpre_L2_11 ts_uU_L2_11_7 0 NMIR W=20u L=1u
Mo3_uU_L2_11_7 da_uU_L2_11_7 da_uU_L2_11_7 vdd vdd PMIR W=60u L=1u
Mo4_uU_L2_11_7 gp_2_11_7 da_uU_L2_11_7 vdd vdd PMIR W=60u L=1u
Mt_uU_L2_11_8 ts_uU_L2_11_8 hv_L1_22 0 0 NMIR W=48.0u L=1u
Mo1_uU_L2_11_8 da_uU_L2_11_8 d1bar_L2 ts_uU_L2_11_8 0 NMIR W=20u L=1u
Mo2_uU_L2_11_8 gp_2_11_8 dpre_L2_11 ts_uU_L2_11_8 0 NMIR W=20u L=1u
Mo3_uU_L2_11_8 da_uU_L2_11_8 da_uU_L2_11_8 vdd vdd PMIR W=60u L=1u
Mo4_uU_L2_11_8 gp_2_11_8 da_uU_L2_11_8 vdd vdd PMIR W=60u L=1u
Mt_uU_L2_11_9 ts_uU_L2_11_9 hv_L1_23 0 0 NMIR W=48.0u L=1u
Mo1_uU_L2_11_9 da_uU_L2_11_9 d1bar_L2 ts_uU_L2_11_9 0 NMIR W=20u L=1u
Mo2_uU_L2_11_9 gp_2_11_9 dpre_L2_11 ts_uU_L2_11_9 0 NMIR W=20u L=1u
Mo3_uU_L2_11_9 da_uU_L2_11_9 da_uU_L2_11_9 vdd vdd PMIR W=60u L=1u
Mo4_uU_L2_11_9 gp_2_11_9 da_uU_L2_11_9 vdd vdd PMIR W=60u L=1u
Mt_uU_L2_11_10 ts_uU_L2_11_10 hv_L1_24 0 0 NMIR W=48.0u L=1u
Mo1_uU_L2_11_10 da_uU_L2_11_10 d1bar_L2 ts_uU_L2_11_10 0 NMIR W=20u L=1u
Mo2_uU_L2_11_10 gp_2_11_10 dpre_L2_11 ts_uU_L2_11_10 0 NMIR W=20u L=1u
Mo3_uU_L2_11_10 da_uU_L2_11_10 da_uU_L2_11_10 vdd vdd PMIR W=60u L=1u
Mo4_uU_L2_11_10 gp_2_11_10 da_uU_L2_11_10 vdd vdd PMIR W=60u L=1u
Mt_uU_L2_11_11 ts_uU_L2_11_11 hv_L1_26 0 0 NMIR W=48.0u L=1u
Mo1_uU_L2_11_11 da_uU_L2_11_11 d1bar_L2 ts_uU_L2_11_11 0 NMIR W=20u L=1u
Mo2_uU_L2_11_11 gp_2_11_11 dpre_L2_11 ts_uU_L2_11_11 0 NMIR W=20u L=1u
Mo3_uU_L2_11_11 da_uU_L2_11_11 da_uU_L2_11_11 vdd vdd PMIR W=60u L=1u
Mo4_uU_L2_11_11 gp_2_11_11 da_uU_L2_11_11 vdd vdd PMIR W=60u L=1u
Mt_uU_L2_11_12 ts_uU_L2_11_12 hv_L1_33 0 0 NMIR W=48.0u L=1u
Mo1_uU_L2_11_12 da_uU_L2_11_12 d1bar_L2 ts_uU_L2_11_12 0 NMIR W=20u L=1u
Mo2_uU_L2_11_12 gp_2_11_12 dpre_L2_11 ts_uU_L2_11_12 0 NMIR W=20u L=1u
Mo3_uU_L2_11_12 da_uU_L2_11_12 da_uU_L2_11_12 vdd vdd PMIR W=60u L=1u
Mo4_uU_L2_11_12 gp_2_11_12 da_uU_L2_11_12 vdd vdd PMIR W=60u L=1u
Mt_uU_L2_11_13 ts_uU_L2_11_13 hv_L1_34 0 0 NMIR W=48.0u L=1u
Mo1_uU_L2_11_13 da_uU_L2_11_13 d1bar_L2 ts_uU_L2_11_13 0 NMIR W=20u L=1u
Mo2_uU_L2_11_13 gp_2_11_13 dpre_L2_11 ts_uU_L2_11_13 0 NMIR W=20u L=1u
Mo3_uU_L2_11_13 da_uU_L2_11_13 da_uU_L2_11_13 vdd vdd PMIR W=60u L=1u
Mo4_uU_L2_11_13 gp_2_11_13 da_uU_L2_11_13 vdd vdd PMIR W=60u L=1u
Mt_uU_L2_11_14 ts_uU_L2_11_14 hv_L1_37 0 0 NMIR W=48.0u L=1u
Mo1_uU_L2_11_14 da_uU_L2_11_14 d1bar_L2 ts_uU_L2_11_14 0 NMIR W=20u L=1u
Mo2_uU_L2_11_14 gp_2_11_14 dpre_L2_11 ts_uU_L2_11_14 0 NMIR W=20u L=1u
Mo3_uU_L2_11_14 da_uU_L2_11_14 da_uU_L2_11_14 vdd vdd PMIR W=60u L=1u
Mo4_uU_L2_11_14 gp_2_11_14 da_uU_L2_11_14 vdd vdd PMIR W=60u L=1u
Mt_uU_L2_11_15 ts_uU_L2_11_15 hv_L1_40 0 0 NMIR W=48.0u L=1u
Mo1_uU_L2_11_15 da_uU_L2_11_15 d1bar_L2 ts_uU_L2_11_15 0 NMIR W=20u L=1u
Mo2_uU_L2_11_15 gp_2_11_15 dpre_L2_11 ts_uU_L2_11_15 0 NMIR W=20u L=1u
Mo3_uU_L2_11_15 da_uU_L2_11_15 da_uU_L2_11_15 vdd vdd PMIR W=60u L=1u
Mo4_uU_L2_11_15 gp_2_11_15 da_uU_L2_11_15 vdd vdd PMIR W=60u L=1u
Mt_uU_L2_12_0 ts_uU_L2_12_0 hv_L1_1 0 0 NMIR W=48.0u L=1u
Mo1_uU_L2_12_0 da_uU_L2_12_0 d1bar_L2 ts_uU_L2_12_0 0 NMIR W=20u L=1u
Mo2_uU_L2_12_0 gp_2_12_0 dpre_L2_12 ts_uU_L2_12_0 0 NMIR W=20u L=1u
Mo3_uU_L2_12_0 da_uU_L2_12_0 da_uU_L2_12_0 vdd vdd PMIR W=60u L=1u
Mo4_uU_L2_12_0 gp_2_12_0 da_uU_L2_12_0 vdd vdd PMIR W=60u L=1u
Mt_uU_L2_12_1 ts_uU_L2_12_1 hv_L1_6 0 0 NMIR W=48.0u L=1u
Mo1_uU_L2_12_1 da_uU_L2_12_1 d1bar_L2 ts_uU_L2_12_1 0 NMIR W=20u L=1u
Mo2_uU_L2_12_1 gp_2_12_1 dpre_L2_12 ts_uU_L2_12_1 0 NMIR W=20u L=1u
Mo3_uU_L2_12_1 da_uU_L2_12_1 da_uU_L2_12_1 vdd vdd PMIR W=60u L=1u
Mo4_uU_L2_12_1 gp_2_12_1 da_uU_L2_12_1 vdd vdd PMIR W=60u L=1u
Mt_uU_L2_12_2 ts_uU_L2_12_2 hv_L1_7 0 0 NMIR W=48.0u L=1u
Mo1_uU_L2_12_2 da_uU_L2_12_2 d1bar_L2 ts_uU_L2_12_2 0 NMIR W=20u L=1u
Mo2_uU_L2_12_2 gp_2_12_2 dpre_L2_12 ts_uU_L2_12_2 0 NMIR W=20u L=1u
Mo3_uU_L2_12_2 da_uU_L2_12_2 da_uU_L2_12_2 vdd vdd PMIR W=60u L=1u
Mo4_uU_L2_12_2 gp_2_12_2 da_uU_L2_12_2 vdd vdd PMIR W=60u L=1u
Mt_uU_L2_12_3 ts_uU_L2_12_3 hv_L1_9 0 0 NMIR W=48.0u L=1u
Mo1_uU_L2_12_3 da_uU_L2_12_3 d1bar_L2 ts_uU_L2_12_3 0 NMIR W=20u L=1u
Mo2_uU_L2_12_3 gp_2_12_3 dpre_L2_12 ts_uU_L2_12_3 0 NMIR W=20u L=1u
Mo3_uU_L2_12_3 da_uU_L2_12_3 da_uU_L2_12_3 vdd vdd PMIR W=60u L=1u
Mo4_uU_L2_12_3 gp_2_12_3 da_uU_L2_12_3 vdd vdd PMIR W=60u L=1u
Mt_uU_L2_12_4 ts_uU_L2_12_4 hv_L1_13 0 0 NMIR W=48.0u L=1u
Mo1_uU_L2_12_4 da_uU_L2_12_4 d1bar_L2 ts_uU_L2_12_4 0 NMIR W=20u L=1u
Mo2_uU_L2_12_4 gp_2_12_4 dpre_L2_12 ts_uU_L2_12_4 0 NMIR W=20u L=1u
Mo3_uU_L2_12_4 da_uU_L2_12_4 da_uU_L2_12_4 vdd vdd PMIR W=60u L=1u
Mo4_uU_L2_12_4 gp_2_12_4 da_uU_L2_12_4 vdd vdd PMIR W=60u L=1u
Mt_uU_L2_12_5 ts_uU_L2_12_5 hv_L1_18 0 0 NMIR W=48.0u L=1u
Mo1_uU_L2_12_5 da_uU_L2_12_5 d1bar_L2 ts_uU_L2_12_5 0 NMIR W=20u L=1u
Mo2_uU_L2_12_5 gp_2_12_5 dpre_L2_12 ts_uU_L2_12_5 0 NMIR W=20u L=1u
Mo3_uU_L2_12_5 da_uU_L2_12_5 da_uU_L2_12_5 vdd vdd PMIR W=60u L=1u
Mo4_uU_L2_12_5 gp_2_12_5 da_uU_L2_12_5 vdd vdd PMIR W=60u L=1u
Mt_uU_L2_12_6 ts_uU_L2_12_6 hv_L1_19 0 0 NMIR W=48.0u L=1u
Mo1_uU_L2_12_6 da_uU_L2_12_6 d1bar_L2 ts_uU_L2_12_6 0 NMIR W=20u L=1u
Mo2_uU_L2_12_6 gp_2_12_6 dpre_L2_12 ts_uU_L2_12_6 0 NMIR W=20u L=1u
Mo3_uU_L2_12_6 da_uU_L2_12_6 da_uU_L2_12_6 vdd vdd PMIR W=60u L=1u
Mo4_uU_L2_12_6 gp_2_12_6 da_uU_L2_12_6 vdd vdd PMIR W=60u L=1u
Mt_uU_L2_12_7 ts_uU_L2_12_7 hv_L1_23 0 0 NMIR W=48.0u L=1u
Mo1_uU_L2_12_7 da_uU_L2_12_7 d1bar_L2 ts_uU_L2_12_7 0 NMIR W=20u L=1u
Mo2_uU_L2_12_7 gp_2_12_7 dpre_L2_12 ts_uU_L2_12_7 0 NMIR W=20u L=1u
Mo3_uU_L2_12_7 da_uU_L2_12_7 da_uU_L2_12_7 vdd vdd PMIR W=60u L=1u
Mo4_uU_L2_12_7 gp_2_12_7 da_uU_L2_12_7 vdd vdd PMIR W=60u L=1u
Mt_uU_L2_12_8 ts_uU_L2_12_8 hv_L1_25 0 0 NMIR W=48.0u L=1u
Mo1_uU_L2_12_8 da_uU_L2_12_8 d1bar_L2 ts_uU_L2_12_8 0 NMIR W=20u L=1u
Mo2_uU_L2_12_8 gp_2_12_8 dpre_L2_12 ts_uU_L2_12_8 0 NMIR W=20u L=1u
Mo3_uU_L2_12_8 da_uU_L2_12_8 da_uU_L2_12_8 vdd vdd PMIR W=60u L=1u
Mo4_uU_L2_12_8 gp_2_12_8 da_uU_L2_12_8 vdd vdd PMIR W=60u L=1u
Mt_uU_L2_12_9 ts_uU_L2_12_9 hv_L1_29 0 0 NMIR W=48.0u L=1u
Mo1_uU_L2_12_9 da_uU_L2_12_9 d1bar_L2 ts_uU_L2_12_9 0 NMIR W=20u L=1u
Mo2_uU_L2_12_9 gp_2_12_9 dpre_L2_12 ts_uU_L2_12_9 0 NMIR W=20u L=1u
Mo3_uU_L2_12_9 da_uU_L2_12_9 da_uU_L2_12_9 vdd vdd PMIR W=60u L=1u
Mo4_uU_L2_12_9 gp_2_12_9 da_uU_L2_12_9 vdd vdd PMIR W=60u L=1u
Mt_uU_L2_12_10 ts_uU_L2_12_10 hv_L1_35 0 0 NMIR W=48.0u L=1u
Mo1_uU_L2_12_10 da_uU_L2_12_10 d1bar_L2 ts_uU_L2_12_10 0 NMIR W=20u L=1u
Mo2_uU_L2_12_10 gp_2_12_10 dpre_L2_12 ts_uU_L2_12_10 0 NMIR W=20u L=1u
Mo3_uU_L2_12_10 da_uU_L2_12_10 da_uU_L2_12_10 vdd vdd PMIR W=60u L=1u
Mo4_uU_L2_12_10 gp_2_12_10 da_uU_L2_12_10 vdd vdd PMIR W=60u L=1u
Mt_uU_L2_12_11 ts_uU_L2_12_11 hv_L1_38 0 0 NMIR W=48.0u L=1u
Mo1_uU_L2_12_11 da_uU_L2_12_11 d1bar_L2 ts_uU_L2_12_11 0 NMIR W=20u L=1u
Mo2_uU_L2_12_11 gp_2_12_11 dpre_L2_12 ts_uU_L2_12_11 0 NMIR W=20u L=1u
Mo3_uU_L2_12_11 da_uU_L2_12_11 da_uU_L2_12_11 vdd vdd PMIR W=60u L=1u
Mo4_uU_L2_12_11 gp_2_12_11 da_uU_L2_12_11 vdd vdd PMIR W=60u L=1u
Mt_uU_L2_12_12 ts_uU_L2_12_12 hv_L1_42 0 0 NMIR W=48.0u L=1u
Mo1_uU_L2_12_12 da_uU_L2_12_12 d1bar_L2 ts_uU_L2_12_12 0 NMIR W=20u L=1u
Mo2_uU_L2_12_12 gp_2_12_12 dpre_L2_12 ts_uU_L2_12_12 0 NMIR W=20u L=1u
Mo3_uU_L2_12_12 da_uU_L2_12_12 da_uU_L2_12_12 vdd vdd PMIR W=60u L=1u
Mo4_uU_L2_12_12 gp_2_12_12 da_uU_L2_12_12 vdd vdd PMIR W=60u L=1u
Mt_uU_L2_12_13 ts_uU_L2_12_13 hv_L1_43 0 0 NMIR W=48.0u L=1u
Mo1_uU_L2_12_13 da_uU_L2_12_13 d1bar_L2 ts_uU_L2_12_13 0 NMIR W=20u L=1u
Mo2_uU_L2_12_13 gp_2_12_13 dpre_L2_12 ts_uU_L2_12_13 0 NMIR W=20u L=1u
Mo3_uU_L2_12_13 da_uU_L2_12_13 da_uU_L2_12_13 vdd vdd PMIR W=60u L=1u
Mo4_uU_L2_12_13 gp_2_12_13 da_uU_L2_12_13 vdd vdd PMIR W=60u L=1u
Mt_uU_L2_12_14 ts_uU_L2_12_14 hv_L1_45 0 0 NMIR W=48.0u L=1u
Mo1_uU_L2_12_14 da_uU_L2_12_14 d1bar_L2 ts_uU_L2_12_14 0 NMIR W=20u L=1u
Mo2_uU_L2_12_14 gp_2_12_14 dpre_L2_12 ts_uU_L2_12_14 0 NMIR W=20u L=1u
Mo3_uU_L2_12_14 da_uU_L2_12_14 da_uU_L2_12_14 vdd vdd PMIR W=60u L=1u
Mo4_uU_L2_12_14 gp_2_12_14 da_uU_L2_12_14 vdd vdd PMIR W=60u L=1u
Mt_uU_L2_12_15 ts_uU_L2_12_15 hv_L1_46 0 0 NMIR W=48.0u L=1u
Mo1_uU_L2_12_15 da_uU_L2_12_15 d1bar_L2 ts_uU_L2_12_15 0 NMIR W=20u L=1u
Mo2_uU_L2_12_15 gp_2_12_15 dpre_L2_12 ts_uU_L2_12_15 0 NMIR W=20u L=1u
Mo3_uU_L2_12_15 da_uU_L2_12_15 da_uU_L2_12_15 vdd vdd PMIR W=60u L=1u
Mo4_uU_L2_12_15 gp_2_12_15 da_uU_L2_12_15 vdd vdd PMIR W=60u L=1u
Mt_uU_L2_13_0 ts_uU_L2_13_0 hv_L1_0 0 0 NMIR W=48.0u L=1u
Mo1_uU_L2_13_0 da_uU_L2_13_0 d1bar_L2 ts_uU_L2_13_0 0 NMIR W=20u L=1u
Mo2_uU_L2_13_0 gp_2_13_0 dpre_L2_13 ts_uU_L2_13_0 0 NMIR W=20u L=1u
Mo3_uU_L2_13_0 da_uU_L2_13_0 da_uU_L2_13_0 vdd vdd PMIR W=60u L=1u
Mo4_uU_L2_13_0 gp_2_13_0 da_uU_L2_13_0 vdd vdd PMIR W=60u L=1u
Mt_uU_L2_13_1 ts_uU_L2_13_1 hv_L1_3 0 0 NMIR W=48.0u L=1u
Mo1_uU_L2_13_1 da_uU_L2_13_1 d1bar_L2 ts_uU_L2_13_1 0 NMIR W=20u L=1u
Mo2_uU_L2_13_1 gp_2_13_1 dpre_L2_13 ts_uU_L2_13_1 0 NMIR W=20u L=1u
Mo3_uU_L2_13_1 da_uU_L2_13_1 da_uU_L2_13_1 vdd vdd PMIR W=60u L=1u
Mo4_uU_L2_13_1 gp_2_13_1 da_uU_L2_13_1 vdd vdd PMIR W=60u L=1u
Mt_uU_L2_13_2 ts_uU_L2_13_2 hv_L1_6 0 0 NMIR W=48.0u L=1u
Mo1_uU_L2_13_2 da_uU_L2_13_2 d1bar_L2 ts_uU_L2_13_2 0 NMIR W=20u L=1u
Mo2_uU_L2_13_2 gp_2_13_2 dpre_L2_13 ts_uU_L2_13_2 0 NMIR W=20u L=1u
Mo3_uU_L2_13_2 da_uU_L2_13_2 da_uU_L2_13_2 vdd vdd PMIR W=60u L=1u
Mo4_uU_L2_13_2 gp_2_13_2 da_uU_L2_13_2 vdd vdd PMIR W=60u L=1u
Mt_uU_L2_13_3 ts_uU_L2_13_3 hv_L1_9 0 0 NMIR W=48.0u L=1u
Mo1_uU_L2_13_3 da_uU_L2_13_3 d1bar_L2 ts_uU_L2_13_3 0 NMIR W=20u L=1u
Mo2_uU_L2_13_3 gp_2_13_3 dpre_L2_13 ts_uU_L2_13_3 0 NMIR W=20u L=1u
Mo3_uU_L2_13_3 da_uU_L2_13_3 da_uU_L2_13_3 vdd vdd PMIR W=60u L=1u
Mo4_uU_L2_13_3 gp_2_13_3 da_uU_L2_13_3 vdd vdd PMIR W=60u L=1u
Mt_uU_L2_13_4 ts_uU_L2_13_4 hv_L1_10 0 0 NMIR W=48.0u L=1u
Mo1_uU_L2_13_4 da_uU_L2_13_4 d1bar_L2 ts_uU_L2_13_4 0 NMIR W=20u L=1u
Mo2_uU_L2_13_4 gp_2_13_4 dpre_L2_13 ts_uU_L2_13_4 0 NMIR W=20u L=1u
Mo3_uU_L2_13_4 da_uU_L2_13_4 da_uU_L2_13_4 vdd vdd PMIR W=60u L=1u
Mo4_uU_L2_13_4 gp_2_13_4 da_uU_L2_13_4 vdd vdd PMIR W=60u L=1u
Mt_uU_L2_13_5 ts_uU_L2_13_5 hv_L1_11 0 0 NMIR W=48.0u L=1u
Mo1_uU_L2_13_5 da_uU_L2_13_5 d1bar_L2 ts_uU_L2_13_5 0 NMIR W=20u L=1u
Mo2_uU_L2_13_5 gp_2_13_5 dpre_L2_13 ts_uU_L2_13_5 0 NMIR W=20u L=1u
Mo3_uU_L2_13_5 da_uU_L2_13_5 da_uU_L2_13_5 vdd vdd PMIR W=60u L=1u
Mo4_uU_L2_13_5 gp_2_13_5 da_uU_L2_13_5 vdd vdd PMIR W=60u L=1u
Mt_uU_L2_13_6 ts_uU_L2_13_6 hv_L1_12 0 0 NMIR W=48.0u L=1u
Mo1_uU_L2_13_6 da_uU_L2_13_6 d1bar_L2 ts_uU_L2_13_6 0 NMIR W=20u L=1u
Mo2_uU_L2_13_6 gp_2_13_6 dpre_L2_13 ts_uU_L2_13_6 0 NMIR W=20u L=1u
Mo3_uU_L2_13_6 da_uU_L2_13_6 da_uU_L2_13_6 vdd vdd PMIR W=60u L=1u
Mo4_uU_L2_13_6 gp_2_13_6 da_uU_L2_13_6 vdd vdd PMIR W=60u L=1u
Mt_uU_L2_13_7 ts_uU_L2_13_7 hv_L1_19 0 0 NMIR W=48.0u L=1u
Mo1_uU_L2_13_7 da_uU_L2_13_7 d1bar_L2 ts_uU_L2_13_7 0 NMIR W=20u L=1u
Mo2_uU_L2_13_7 gp_2_13_7 dpre_L2_13 ts_uU_L2_13_7 0 NMIR W=20u L=1u
Mo3_uU_L2_13_7 da_uU_L2_13_7 da_uU_L2_13_7 vdd vdd PMIR W=60u L=1u
Mo4_uU_L2_13_7 gp_2_13_7 da_uU_L2_13_7 vdd vdd PMIR W=60u L=1u
Mt_uU_L2_13_8 ts_uU_L2_13_8 hv_L1_25 0 0 NMIR W=48.0u L=1u
Mo1_uU_L2_13_8 da_uU_L2_13_8 d1bar_L2 ts_uU_L2_13_8 0 NMIR W=20u L=1u
Mo2_uU_L2_13_8 gp_2_13_8 dpre_L2_13 ts_uU_L2_13_8 0 NMIR W=20u L=1u
Mo3_uU_L2_13_8 da_uU_L2_13_8 da_uU_L2_13_8 vdd vdd PMIR W=60u L=1u
Mo4_uU_L2_13_8 gp_2_13_8 da_uU_L2_13_8 vdd vdd PMIR W=60u L=1u
Mt_uU_L2_13_9 ts_uU_L2_13_9 hv_L1_31 0 0 NMIR W=48.0u L=1u
Mo1_uU_L2_13_9 da_uU_L2_13_9 d1bar_L2 ts_uU_L2_13_9 0 NMIR W=20u L=1u
Mo2_uU_L2_13_9 gp_2_13_9 dpre_L2_13 ts_uU_L2_13_9 0 NMIR W=20u L=1u
Mo3_uU_L2_13_9 da_uU_L2_13_9 da_uU_L2_13_9 vdd vdd PMIR W=60u L=1u
Mo4_uU_L2_13_9 gp_2_13_9 da_uU_L2_13_9 vdd vdd PMIR W=60u L=1u
Mt_uU_L2_13_10 ts_uU_L2_13_10 hv_L1_34 0 0 NMIR W=48.0u L=1u
Mo1_uU_L2_13_10 da_uU_L2_13_10 d1bar_L2 ts_uU_L2_13_10 0 NMIR W=20u L=1u
Mo2_uU_L2_13_10 gp_2_13_10 dpre_L2_13 ts_uU_L2_13_10 0 NMIR W=20u L=1u
Mo3_uU_L2_13_10 da_uU_L2_13_10 da_uU_L2_13_10 vdd vdd PMIR W=60u L=1u
Mo4_uU_L2_13_10 gp_2_13_10 da_uU_L2_13_10 vdd vdd PMIR W=60u L=1u
Mt_uU_L2_13_11 ts_uU_L2_13_11 hv_L1_38 0 0 NMIR W=48.0u L=1u
Mo1_uU_L2_13_11 da_uU_L2_13_11 d1bar_L2 ts_uU_L2_13_11 0 NMIR W=20u L=1u
Mo2_uU_L2_13_11 gp_2_13_11 dpre_L2_13 ts_uU_L2_13_11 0 NMIR W=20u L=1u
Mo3_uU_L2_13_11 da_uU_L2_13_11 da_uU_L2_13_11 vdd vdd PMIR W=60u L=1u
Mo4_uU_L2_13_11 gp_2_13_11 da_uU_L2_13_11 vdd vdd PMIR W=60u L=1u
Mt_uU_L2_13_12 ts_uU_L2_13_12 hv_L1_39 0 0 NMIR W=48.0u L=1u
Mo1_uU_L2_13_12 da_uU_L2_13_12 d1bar_L2 ts_uU_L2_13_12 0 NMIR W=20u L=1u
Mo2_uU_L2_13_12 gp_2_13_12 dpre_L2_13 ts_uU_L2_13_12 0 NMIR W=20u L=1u
Mo3_uU_L2_13_12 da_uU_L2_13_12 da_uU_L2_13_12 vdd vdd PMIR W=60u L=1u
Mo4_uU_L2_13_12 gp_2_13_12 da_uU_L2_13_12 vdd vdd PMIR W=60u L=1u
Mt_uU_L2_13_13 ts_uU_L2_13_13 hv_L1_41 0 0 NMIR W=48.0u L=1u
Mo1_uU_L2_13_13 da_uU_L2_13_13 d1bar_L2 ts_uU_L2_13_13 0 NMIR W=20u L=1u
Mo2_uU_L2_13_13 gp_2_13_13 dpre_L2_13 ts_uU_L2_13_13 0 NMIR W=20u L=1u
Mo3_uU_L2_13_13 da_uU_L2_13_13 da_uU_L2_13_13 vdd vdd PMIR W=60u L=1u
Mo4_uU_L2_13_13 gp_2_13_13 da_uU_L2_13_13 vdd vdd PMIR W=60u L=1u
Mt_uU_L2_13_14 ts_uU_L2_13_14 hv_L1_43 0 0 NMIR W=48.0u L=1u
Mo1_uU_L2_13_14 da_uU_L2_13_14 d1bar_L2 ts_uU_L2_13_14 0 NMIR W=20u L=1u
Mo2_uU_L2_13_14 gp_2_13_14 dpre_L2_13 ts_uU_L2_13_14 0 NMIR W=20u L=1u
Mo3_uU_L2_13_14 da_uU_L2_13_14 da_uU_L2_13_14 vdd vdd PMIR W=60u L=1u
Mo4_uU_L2_13_14 gp_2_13_14 da_uU_L2_13_14 vdd vdd PMIR W=60u L=1u
Mt_uU_L2_13_15 ts_uU_L2_13_15 hv_L1_44 0 0 NMIR W=48.0u L=1u
Mo1_uU_L2_13_15 da_uU_L2_13_15 d1bar_L2 ts_uU_L2_13_15 0 NMIR W=20u L=1u
Mo2_uU_L2_13_15 gp_2_13_15 dpre_L2_13 ts_uU_L2_13_15 0 NMIR W=20u L=1u
Mo3_uU_L2_13_15 da_uU_L2_13_15 da_uU_L2_13_15 vdd vdd PMIR W=60u L=1u
Mo4_uU_L2_13_15 gp_2_13_15 da_uU_L2_13_15 vdd vdd PMIR W=60u L=1u
Mt_uU_L2_14_0 ts_uU_L2_14_0 hv_L1_4 0 0 NMIR W=48.0u L=1u
Mo1_uU_L2_14_0 da_uU_L2_14_0 d1bar_L2 ts_uU_L2_14_0 0 NMIR W=20u L=1u
Mo2_uU_L2_14_0 gp_2_14_0 dpre_L2_14 ts_uU_L2_14_0 0 NMIR W=20u L=1u
Mo3_uU_L2_14_0 da_uU_L2_14_0 da_uU_L2_14_0 vdd vdd PMIR W=60u L=1u
Mo4_uU_L2_14_0 gp_2_14_0 da_uU_L2_14_0 vdd vdd PMIR W=60u L=1u
Mt_uU_L2_14_1 ts_uU_L2_14_1 hv_L1_6 0 0 NMIR W=48.0u L=1u
Mo1_uU_L2_14_1 da_uU_L2_14_1 d1bar_L2 ts_uU_L2_14_1 0 NMIR W=20u L=1u
Mo2_uU_L2_14_1 gp_2_14_1 dpre_L2_14 ts_uU_L2_14_1 0 NMIR W=20u L=1u
Mo3_uU_L2_14_1 da_uU_L2_14_1 da_uU_L2_14_1 vdd vdd PMIR W=60u L=1u
Mo4_uU_L2_14_1 gp_2_14_1 da_uU_L2_14_1 vdd vdd PMIR W=60u L=1u
Mt_uU_L2_14_2 ts_uU_L2_14_2 hv_L1_10 0 0 NMIR W=48.0u L=1u
Mo1_uU_L2_14_2 da_uU_L2_14_2 d1bar_L2 ts_uU_L2_14_2 0 NMIR W=20u L=1u
Mo2_uU_L2_14_2 gp_2_14_2 dpre_L2_14 ts_uU_L2_14_2 0 NMIR W=20u L=1u
Mo3_uU_L2_14_2 da_uU_L2_14_2 da_uU_L2_14_2 vdd vdd PMIR W=60u L=1u
Mo4_uU_L2_14_2 gp_2_14_2 da_uU_L2_14_2 vdd vdd PMIR W=60u L=1u
Mt_uU_L2_14_3 ts_uU_L2_14_3 hv_L1_14 0 0 NMIR W=48.0u L=1u
Mo1_uU_L2_14_3 da_uU_L2_14_3 d1bar_L2 ts_uU_L2_14_3 0 NMIR W=20u L=1u
Mo2_uU_L2_14_3 gp_2_14_3 dpre_L2_14 ts_uU_L2_14_3 0 NMIR W=20u L=1u
Mo3_uU_L2_14_3 da_uU_L2_14_3 da_uU_L2_14_3 vdd vdd PMIR W=60u L=1u
Mo4_uU_L2_14_3 gp_2_14_3 da_uU_L2_14_3 vdd vdd PMIR W=60u L=1u
Mt_uU_L2_14_4 ts_uU_L2_14_4 hv_L1_16 0 0 NMIR W=48.0u L=1u
Mo1_uU_L2_14_4 da_uU_L2_14_4 d1bar_L2 ts_uU_L2_14_4 0 NMIR W=20u L=1u
Mo2_uU_L2_14_4 gp_2_14_4 dpre_L2_14 ts_uU_L2_14_4 0 NMIR W=20u L=1u
Mo3_uU_L2_14_4 da_uU_L2_14_4 da_uU_L2_14_4 vdd vdd PMIR W=60u L=1u
Mo4_uU_L2_14_4 gp_2_14_4 da_uU_L2_14_4 vdd vdd PMIR W=60u L=1u
Mt_uU_L2_14_5 ts_uU_L2_14_5 hv_L1_17 0 0 NMIR W=48.0u L=1u
Mo1_uU_L2_14_5 da_uU_L2_14_5 d1bar_L2 ts_uU_L2_14_5 0 NMIR W=20u L=1u
Mo2_uU_L2_14_5 gp_2_14_5 dpre_L2_14 ts_uU_L2_14_5 0 NMIR W=20u L=1u
Mo3_uU_L2_14_5 da_uU_L2_14_5 da_uU_L2_14_5 vdd vdd PMIR W=60u L=1u
Mo4_uU_L2_14_5 gp_2_14_5 da_uU_L2_14_5 vdd vdd PMIR W=60u L=1u
Mt_uU_L2_14_6 ts_uU_L2_14_6 hv_L1_20 0 0 NMIR W=48.0u L=1u
Mo1_uU_L2_14_6 da_uU_L2_14_6 d1bar_L2 ts_uU_L2_14_6 0 NMIR W=20u L=1u
Mo2_uU_L2_14_6 gp_2_14_6 dpre_L2_14 ts_uU_L2_14_6 0 NMIR W=20u L=1u
Mo3_uU_L2_14_6 da_uU_L2_14_6 da_uU_L2_14_6 vdd vdd PMIR W=60u L=1u
Mo4_uU_L2_14_6 gp_2_14_6 da_uU_L2_14_6 vdd vdd PMIR W=60u L=1u
Mt_uU_L2_14_7 ts_uU_L2_14_7 hv_L1_21 0 0 NMIR W=48.0u L=1u
Mo1_uU_L2_14_7 da_uU_L2_14_7 d1bar_L2 ts_uU_L2_14_7 0 NMIR W=20u L=1u
Mo2_uU_L2_14_7 gp_2_14_7 dpre_L2_14 ts_uU_L2_14_7 0 NMIR W=20u L=1u
Mo3_uU_L2_14_7 da_uU_L2_14_7 da_uU_L2_14_7 vdd vdd PMIR W=60u L=1u
Mo4_uU_L2_14_7 gp_2_14_7 da_uU_L2_14_7 vdd vdd PMIR W=60u L=1u
Mt_uU_L2_14_8 ts_uU_L2_14_8 hv_L1_22 0 0 NMIR W=48.0u L=1u
Mo1_uU_L2_14_8 da_uU_L2_14_8 d1bar_L2 ts_uU_L2_14_8 0 NMIR W=20u L=1u
Mo2_uU_L2_14_8 gp_2_14_8 dpre_L2_14 ts_uU_L2_14_8 0 NMIR W=20u L=1u
Mo3_uU_L2_14_8 da_uU_L2_14_8 da_uU_L2_14_8 vdd vdd PMIR W=60u L=1u
Mo4_uU_L2_14_8 gp_2_14_8 da_uU_L2_14_8 vdd vdd PMIR W=60u L=1u
Mt_uU_L2_14_9 ts_uU_L2_14_9 hv_L1_24 0 0 NMIR W=48.0u L=1u
Mo1_uU_L2_14_9 da_uU_L2_14_9 d1bar_L2 ts_uU_L2_14_9 0 NMIR W=20u L=1u
Mo2_uU_L2_14_9 gp_2_14_9 dpre_L2_14 ts_uU_L2_14_9 0 NMIR W=20u L=1u
Mo3_uU_L2_14_9 da_uU_L2_14_9 da_uU_L2_14_9 vdd vdd PMIR W=60u L=1u
Mo4_uU_L2_14_9 gp_2_14_9 da_uU_L2_14_9 vdd vdd PMIR W=60u L=1u
Mt_uU_L2_14_10 ts_uU_L2_14_10 hv_L1_29 0 0 NMIR W=48.0u L=1u
Mo1_uU_L2_14_10 da_uU_L2_14_10 d1bar_L2 ts_uU_L2_14_10 0 NMIR W=20u L=1u
Mo2_uU_L2_14_10 gp_2_14_10 dpre_L2_14 ts_uU_L2_14_10 0 NMIR W=20u L=1u
Mo3_uU_L2_14_10 da_uU_L2_14_10 da_uU_L2_14_10 vdd vdd PMIR W=60u L=1u
Mo4_uU_L2_14_10 gp_2_14_10 da_uU_L2_14_10 vdd vdd PMIR W=60u L=1u
Mt_uU_L2_14_11 ts_uU_L2_14_11 hv_L1_33 0 0 NMIR W=48.0u L=1u
Mo1_uU_L2_14_11 da_uU_L2_14_11 d1bar_L2 ts_uU_L2_14_11 0 NMIR W=20u L=1u
Mo2_uU_L2_14_11 gp_2_14_11 dpre_L2_14 ts_uU_L2_14_11 0 NMIR W=20u L=1u
Mo3_uU_L2_14_11 da_uU_L2_14_11 da_uU_L2_14_11 vdd vdd PMIR W=60u L=1u
Mo4_uU_L2_14_11 gp_2_14_11 da_uU_L2_14_11 vdd vdd PMIR W=60u L=1u
Mt_uU_L2_14_12 ts_uU_L2_14_12 hv_L1_37 0 0 NMIR W=48.0u L=1u
Mo1_uU_L2_14_12 da_uU_L2_14_12 d1bar_L2 ts_uU_L2_14_12 0 NMIR W=20u L=1u
Mo2_uU_L2_14_12 gp_2_14_12 dpre_L2_14 ts_uU_L2_14_12 0 NMIR W=20u L=1u
Mo3_uU_L2_14_12 da_uU_L2_14_12 da_uU_L2_14_12 vdd vdd PMIR W=60u L=1u
Mo4_uU_L2_14_12 gp_2_14_12 da_uU_L2_14_12 vdd vdd PMIR W=60u L=1u
Mt_uU_L2_14_13 ts_uU_L2_14_13 hv_L1_39 0 0 NMIR W=48.0u L=1u
Mo1_uU_L2_14_13 da_uU_L2_14_13 d1bar_L2 ts_uU_L2_14_13 0 NMIR W=20u L=1u
Mo2_uU_L2_14_13 gp_2_14_13 dpre_L2_14 ts_uU_L2_14_13 0 NMIR W=20u L=1u
Mo3_uU_L2_14_13 da_uU_L2_14_13 da_uU_L2_14_13 vdd vdd PMIR W=60u L=1u
Mo4_uU_L2_14_13 gp_2_14_13 da_uU_L2_14_13 vdd vdd PMIR W=60u L=1u
Mt_uU_L2_14_14 ts_uU_L2_14_14 hv_L1_41 0 0 NMIR W=48.0u L=1u
Mo1_uU_L2_14_14 da_uU_L2_14_14 d1bar_L2 ts_uU_L2_14_14 0 NMIR W=20u L=1u
Mo2_uU_L2_14_14 gp_2_14_14 dpre_L2_14 ts_uU_L2_14_14 0 NMIR W=20u L=1u
Mo3_uU_L2_14_14 da_uU_L2_14_14 da_uU_L2_14_14 vdd vdd PMIR W=60u L=1u
Mo4_uU_L2_14_14 gp_2_14_14 da_uU_L2_14_14 vdd vdd PMIR W=60u L=1u
Mt_uU_L2_14_15 ts_uU_L2_14_15 hv_L1_43 0 0 NMIR W=48.0u L=1u
Mo1_uU_L2_14_15 da_uU_L2_14_15 d1bar_L2 ts_uU_L2_14_15 0 NMIR W=20u L=1u
Mo2_uU_L2_14_15 gp_2_14_15 dpre_L2_14 ts_uU_L2_14_15 0 NMIR W=20u L=1u
Mo3_uU_L2_14_15 da_uU_L2_14_15 da_uU_L2_14_15 vdd vdd PMIR W=60u L=1u
Mo4_uU_L2_14_15 gp_2_14_15 da_uU_L2_14_15 vdd vdd PMIR W=60u L=1u
Mt_uU_L2_15_0 ts_uU_L2_15_0 hv_L1_1 0 0 NMIR W=48.0u L=1u
Mo1_uU_L2_15_0 da_uU_L2_15_0 d1bar_L2 ts_uU_L2_15_0 0 NMIR W=20u L=1u
Mo2_uU_L2_15_0 gp_2_15_0 dpre_L2_15 ts_uU_L2_15_0 0 NMIR W=20u L=1u
Mo3_uU_L2_15_0 da_uU_L2_15_0 da_uU_L2_15_0 vdd vdd PMIR W=60u L=1u
Mo4_uU_L2_15_0 gp_2_15_0 da_uU_L2_15_0 vdd vdd PMIR W=60u L=1u
Mt_uU_L2_15_1 ts_uU_L2_15_1 hv_L1_2 0 0 NMIR W=48.0u L=1u
Mo1_uU_L2_15_1 da_uU_L2_15_1 d1bar_L2 ts_uU_L2_15_1 0 NMIR W=20u L=1u
Mo2_uU_L2_15_1 gp_2_15_1 dpre_L2_15 ts_uU_L2_15_1 0 NMIR W=20u L=1u
Mo3_uU_L2_15_1 da_uU_L2_15_1 da_uU_L2_15_1 vdd vdd PMIR W=60u L=1u
Mo4_uU_L2_15_1 gp_2_15_1 da_uU_L2_15_1 vdd vdd PMIR W=60u L=1u
Mt_uU_L2_15_2 ts_uU_L2_15_2 hv_L1_3 0 0 NMIR W=48.0u L=1u
Mo1_uU_L2_15_2 da_uU_L2_15_2 d1bar_L2 ts_uU_L2_15_2 0 NMIR W=20u L=1u
Mo2_uU_L2_15_2 gp_2_15_2 dpre_L2_15 ts_uU_L2_15_2 0 NMIR W=20u L=1u
Mo3_uU_L2_15_2 da_uU_L2_15_2 da_uU_L2_15_2 vdd vdd PMIR W=60u L=1u
Mo4_uU_L2_15_2 gp_2_15_2 da_uU_L2_15_2 vdd vdd PMIR W=60u L=1u
Mt_uU_L2_15_3 ts_uU_L2_15_3 hv_L1_5 0 0 NMIR W=48.0u L=1u
Mo1_uU_L2_15_3 da_uU_L2_15_3 d1bar_L2 ts_uU_L2_15_3 0 NMIR W=20u L=1u
Mo2_uU_L2_15_3 gp_2_15_3 dpre_L2_15 ts_uU_L2_15_3 0 NMIR W=20u L=1u
Mo3_uU_L2_15_3 da_uU_L2_15_3 da_uU_L2_15_3 vdd vdd PMIR W=60u L=1u
Mo4_uU_L2_15_3 gp_2_15_3 da_uU_L2_15_3 vdd vdd PMIR W=60u L=1u
Mt_uU_L2_15_4 ts_uU_L2_15_4 hv_L1_11 0 0 NMIR W=48.0u L=1u
Mo1_uU_L2_15_4 da_uU_L2_15_4 d1bar_L2 ts_uU_L2_15_4 0 NMIR W=20u L=1u
Mo2_uU_L2_15_4 gp_2_15_4 dpre_L2_15 ts_uU_L2_15_4 0 NMIR W=20u L=1u
Mo3_uU_L2_15_4 da_uU_L2_15_4 da_uU_L2_15_4 vdd vdd PMIR W=60u L=1u
Mo4_uU_L2_15_4 gp_2_15_4 da_uU_L2_15_4 vdd vdd PMIR W=60u L=1u
Mt_uU_L2_15_5 ts_uU_L2_15_5 hv_L1_16 0 0 NMIR W=48.0u L=1u
Mo1_uU_L2_15_5 da_uU_L2_15_5 d1bar_L2 ts_uU_L2_15_5 0 NMIR W=20u L=1u
Mo2_uU_L2_15_5 gp_2_15_5 dpre_L2_15 ts_uU_L2_15_5 0 NMIR W=20u L=1u
Mo3_uU_L2_15_5 da_uU_L2_15_5 da_uU_L2_15_5 vdd vdd PMIR W=60u L=1u
Mo4_uU_L2_15_5 gp_2_15_5 da_uU_L2_15_5 vdd vdd PMIR W=60u L=1u
Mt_uU_L2_15_6 ts_uU_L2_15_6 hv_L1_26 0 0 NMIR W=48.0u L=1u
Mo1_uU_L2_15_6 da_uU_L2_15_6 d1bar_L2 ts_uU_L2_15_6 0 NMIR W=20u L=1u
Mo2_uU_L2_15_6 gp_2_15_6 dpre_L2_15 ts_uU_L2_15_6 0 NMIR W=20u L=1u
Mo3_uU_L2_15_6 da_uU_L2_15_6 da_uU_L2_15_6 vdd vdd PMIR W=60u L=1u
Mo4_uU_L2_15_6 gp_2_15_6 da_uU_L2_15_6 vdd vdd PMIR W=60u L=1u
Mt_uU_L2_15_7 ts_uU_L2_15_7 hv_L1_27 0 0 NMIR W=48.0u L=1u
Mo1_uU_L2_15_7 da_uU_L2_15_7 d1bar_L2 ts_uU_L2_15_7 0 NMIR W=20u L=1u
Mo2_uU_L2_15_7 gp_2_15_7 dpre_L2_15 ts_uU_L2_15_7 0 NMIR W=20u L=1u
Mo3_uU_L2_15_7 da_uU_L2_15_7 da_uU_L2_15_7 vdd vdd PMIR W=60u L=1u
Mo4_uU_L2_15_7 gp_2_15_7 da_uU_L2_15_7 vdd vdd PMIR W=60u L=1u
Mt_uU_L2_15_8 ts_uU_L2_15_8 hv_L1_30 0 0 NMIR W=48.0u L=1u
Mo1_uU_L2_15_8 da_uU_L2_15_8 d1bar_L2 ts_uU_L2_15_8 0 NMIR W=20u L=1u
Mo2_uU_L2_15_8 gp_2_15_8 dpre_L2_15 ts_uU_L2_15_8 0 NMIR W=20u L=1u
Mo3_uU_L2_15_8 da_uU_L2_15_8 da_uU_L2_15_8 vdd vdd PMIR W=60u L=1u
Mo4_uU_L2_15_8 gp_2_15_8 da_uU_L2_15_8 vdd vdd PMIR W=60u L=1u
Mt_uU_L2_15_9 ts_uU_L2_15_9 hv_L1_33 0 0 NMIR W=48.0u L=1u
Mo1_uU_L2_15_9 da_uU_L2_15_9 d1bar_L2 ts_uU_L2_15_9 0 NMIR W=20u L=1u
Mo2_uU_L2_15_9 gp_2_15_9 dpre_L2_15 ts_uU_L2_15_9 0 NMIR W=20u L=1u
Mo3_uU_L2_15_9 da_uU_L2_15_9 da_uU_L2_15_9 vdd vdd PMIR W=60u L=1u
Mo4_uU_L2_15_9 gp_2_15_9 da_uU_L2_15_9 vdd vdd PMIR W=60u L=1u
Mt_uU_L2_15_10 ts_uU_L2_15_10 hv_L1_34 0 0 NMIR W=48.0u L=1u
Mo1_uU_L2_15_10 da_uU_L2_15_10 d1bar_L2 ts_uU_L2_15_10 0 NMIR W=20u L=1u
Mo2_uU_L2_15_10 gp_2_15_10 dpre_L2_15 ts_uU_L2_15_10 0 NMIR W=20u L=1u
Mo3_uU_L2_15_10 da_uU_L2_15_10 da_uU_L2_15_10 vdd vdd PMIR W=60u L=1u
Mo4_uU_L2_15_10 gp_2_15_10 da_uU_L2_15_10 vdd vdd PMIR W=60u L=1u
Mt_uU_L2_15_11 ts_uU_L2_15_11 hv_L1_35 0 0 NMIR W=48.0u L=1u
Mo1_uU_L2_15_11 da_uU_L2_15_11 d1bar_L2 ts_uU_L2_15_11 0 NMIR W=20u L=1u
Mo2_uU_L2_15_11 gp_2_15_11 dpre_L2_15 ts_uU_L2_15_11 0 NMIR W=20u L=1u
Mo3_uU_L2_15_11 da_uU_L2_15_11 da_uU_L2_15_11 vdd vdd PMIR W=60u L=1u
Mo4_uU_L2_15_11 gp_2_15_11 da_uU_L2_15_11 vdd vdd PMIR W=60u L=1u
Mt_uU_L2_15_12 ts_uU_L2_15_12 hv_L1_36 0 0 NMIR W=48.0u L=1u
Mo1_uU_L2_15_12 da_uU_L2_15_12 d1bar_L2 ts_uU_L2_15_12 0 NMIR W=20u L=1u
Mo2_uU_L2_15_12 gp_2_15_12 dpre_L2_15 ts_uU_L2_15_12 0 NMIR W=20u L=1u
Mo3_uU_L2_15_12 da_uU_L2_15_12 da_uU_L2_15_12 vdd vdd PMIR W=60u L=1u
Mo4_uU_L2_15_12 gp_2_15_12 da_uU_L2_15_12 vdd vdd PMIR W=60u L=1u
Mt_uU_L2_15_13 ts_uU_L2_15_13 hv_L1_41 0 0 NMIR W=48.0u L=1u
Mo1_uU_L2_15_13 da_uU_L2_15_13 d1bar_L2 ts_uU_L2_15_13 0 NMIR W=20u L=1u
Mo2_uU_L2_15_13 gp_2_15_13 dpre_L2_15 ts_uU_L2_15_13 0 NMIR W=20u L=1u
Mo3_uU_L2_15_13 da_uU_L2_15_13 da_uU_L2_15_13 vdd vdd PMIR W=60u L=1u
Mo4_uU_L2_15_13 gp_2_15_13 da_uU_L2_15_13 vdd vdd PMIR W=60u L=1u
Mt_uU_L2_15_14 ts_uU_L2_15_14 hv_L1_43 0 0 NMIR W=48.0u L=1u
Mo1_uU_L2_15_14 da_uU_L2_15_14 d1bar_L2 ts_uU_L2_15_14 0 NMIR W=20u L=1u
Mo2_uU_L2_15_14 gp_2_15_14 dpre_L2_15 ts_uU_L2_15_14 0 NMIR W=20u L=1u
Mo3_uU_L2_15_14 da_uU_L2_15_14 da_uU_L2_15_14 vdd vdd PMIR W=60u L=1u
Mo4_uU_L2_15_14 gp_2_15_14 da_uU_L2_15_14 vdd vdd PMIR W=60u L=1u
Mt_uU_L2_15_15 ts_uU_L2_15_15 hv_L1_46 0 0 NMIR W=48.0u L=1u
Mo1_uU_L2_15_15 da_uU_L2_15_15 d1bar_L2 ts_uU_L2_15_15 0 NMIR W=20u L=1u
Mo2_uU_L2_15_15 gp_2_15_15 dpre_L2_15 ts_uU_L2_15_15 0 NMIR W=20u L=1u
Mo3_uU_L2_15_15 da_uU_L2_15_15 da_uU_L2_15_15 vdd vdd PMIR W=60u L=1u
Mo4_uU_L2_15_15 gp_2_15_15 da_uU_L2_15_15 vdd vdd PMIR W=60u L=1u
Mt_uU_L2_16_0 ts_uU_L2_16_0 hv_L1_2 0 0 NMIR W=48.0u L=1u
Mo1_uU_L2_16_0 da_uU_L2_16_0 d1bar_L2 ts_uU_L2_16_0 0 NMIR W=20u L=1u
Mo2_uU_L2_16_0 gp_2_16_0 dpre_L2_16 ts_uU_L2_16_0 0 NMIR W=20u L=1u
Mo3_uU_L2_16_0 da_uU_L2_16_0 da_uU_L2_16_0 vdd vdd PMIR W=60u L=1u
Mo4_uU_L2_16_0 gp_2_16_0 da_uU_L2_16_0 vdd vdd PMIR W=60u L=1u
Mt_uU_L2_16_1 ts_uU_L2_16_1 hv_L1_3 0 0 NMIR W=48.0u L=1u
Mo1_uU_L2_16_1 da_uU_L2_16_1 d1bar_L2 ts_uU_L2_16_1 0 NMIR W=20u L=1u
Mo2_uU_L2_16_1 gp_2_16_1 dpre_L2_16 ts_uU_L2_16_1 0 NMIR W=20u L=1u
Mo3_uU_L2_16_1 da_uU_L2_16_1 da_uU_L2_16_1 vdd vdd PMIR W=60u L=1u
Mo4_uU_L2_16_1 gp_2_16_1 da_uU_L2_16_1 vdd vdd PMIR W=60u L=1u
Mt_uU_L2_16_2 ts_uU_L2_16_2 hv_L1_4 0 0 NMIR W=48.0u L=1u
Mo1_uU_L2_16_2 da_uU_L2_16_2 d1bar_L2 ts_uU_L2_16_2 0 NMIR W=20u L=1u
Mo2_uU_L2_16_2 gp_2_16_2 dpre_L2_16 ts_uU_L2_16_2 0 NMIR W=20u L=1u
Mo3_uU_L2_16_2 da_uU_L2_16_2 da_uU_L2_16_2 vdd vdd PMIR W=60u L=1u
Mo4_uU_L2_16_2 gp_2_16_2 da_uU_L2_16_2 vdd vdd PMIR W=60u L=1u
Mt_uU_L2_16_3 ts_uU_L2_16_3 hv_L1_7 0 0 NMIR W=48.0u L=1u
Mo1_uU_L2_16_3 da_uU_L2_16_3 d1bar_L2 ts_uU_L2_16_3 0 NMIR W=20u L=1u
Mo2_uU_L2_16_3 gp_2_16_3 dpre_L2_16 ts_uU_L2_16_3 0 NMIR W=20u L=1u
Mo3_uU_L2_16_3 da_uU_L2_16_3 da_uU_L2_16_3 vdd vdd PMIR W=60u L=1u
Mo4_uU_L2_16_3 gp_2_16_3 da_uU_L2_16_3 vdd vdd PMIR W=60u L=1u
Mt_uU_L2_16_4 ts_uU_L2_16_4 hv_L1_16 0 0 NMIR W=48.0u L=1u
Mo1_uU_L2_16_4 da_uU_L2_16_4 d1bar_L2 ts_uU_L2_16_4 0 NMIR W=20u L=1u
Mo2_uU_L2_16_4 gp_2_16_4 dpre_L2_16 ts_uU_L2_16_4 0 NMIR W=20u L=1u
Mo3_uU_L2_16_4 da_uU_L2_16_4 da_uU_L2_16_4 vdd vdd PMIR W=60u L=1u
Mo4_uU_L2_16_4 gp_2_16_4 da_uU_L2_16_4 vdd vdd PMIR W=60u L=1u
Mt_uU_L2_16_5 ts_uU_L2_16_5 hv_L1_19 0 0 NMIR W=48.0u L=1u
Mo1_uU_L2_16_5 da_uU_L2_16_5 d1bar_L2 ts_uU_L2_16_5 0 NMIR W=20u L=1u
Mo2_uU_L2_16_5 gp_2_16_5 dpre_L2_16 ts_uU_L2_16_5 0 NMIR W=20u L=1u
Mo3_uU_L2_16_5 da_uU_L2_16_5 da_uU_L2_16_5 vdd vdd PMIR W=60u L=1u
Mo4_uU_L2_16_5 gp_2_16_5 da_uU_L2_16_5 vdd vdd PMIR W=60u L=1u
Mt_uU_L2_16_6 ts_uU_L2_16_6 hv_L1_21 0 0 NMIR W=48.0u L=1u
Mo1_uU_L2_16_6 da_uU_L2_16_6 d1bar_L2 ts_uU_L2_16_6 0 NMIR W=20u L=1u
Mo2_uU_L2_16_6 gp_2_16_6 dpre_L2_16 ts_uU_L2_16_6 0 NMIR W=20u L=1u
Mo3_uU_L2_16_6 da_uU_L2_16_6 da_uU_L2_16_6 vdd vdd PMIR W=60u L=1u
Mo4_uU_L2_16_6 gp_2_16_6 da_uU_L2_16_6 vdd vdd PMIR W=60u L=1u
Mt_uU_L2_16_7 ts_uU_L2_16_7 hv_L1_22 0 0 NMIR W=48.0u L=1u
Mo1_uU_L2_16_7 da_uU_L2_16_7 d1bar_L2 ts_uU_L2_16_7 0 NMIR W=20u L=1u
Mo2_uU_L2_16_7 gp_2_16_7 dpre_L2_16 ts_uU_L2_16_7 0 NMIR W=20u L=1u
Mo3_uU_L2_16_7 da_uU_L2_16_7 da_uU_L2_16_7 vdd vdd PMIR W=60u L=1u
Mo4_uU_L2_16_7 gp_2_16_7 da_uU_L2_16_7 vdd vdd PMIR W=60u L=1u
Mt_uU_L2_16_8 ts_uU_L2_16_8 hv_L1_24 0 0 NMIR W=48.0u L=1u
Mo1_uU_L2_16_8 da_uU_L2_16_8 d1bar_L2 ts_uU_L2_16_8 0 NMIR W=20u L=1u
Mo2_uU_L2_16_8 gp_2_16_8 dpre_L2_16 ts_uU_L2_16_8 0 NMIR W=20u L=1u
Mo3_uU_L2_16_8 da_uU_L2_16_8 da_uU_L2_16_8 vdd vdd PMIR W=60u L=1u
Mo4_uU_L2_16_8 gp_2_16_8 da_uU_L2_16_8 vdd vdd PMIR W=60u L=1u
Mt_uU_L2_16_9 ts_uU_L2_16_9 hv_L1_27 0 0 NMIR W=48.0u L=1u
Mo1_uU_L2_16_9 da_uU_L2_16_9 d1bar_L2 ts_uU_L2_16_9 0 NMIR W=20u L=1u
Mo2_uU_L2_16_9 gp_2_16_9 dpre_L2_16 ts_uU_L2_16_9 0 NMIR W=20u L=1u
Mo3_uU_L2_16_9 da_uU_L2_16_9 da_uU_L2_16_9 vdd vdd PMIR W=60u L=1u
Mo4_uU_L2_16_9 gp_2_16_9 da_uU_L2_16_9 vdd vdd PMIR W=60u L=1u
Mt_uU_L2_16_10 ts_uU_L2_16_10 hv_L1_34 0 0 NMIR W=48.0u L=1u
Mo1_uU_L2_16_10 da_uU_L2_16_10 d1bar_L2 ts_uU_L2_16_10 0 NMIR W=20u L=1u
Mo2_uU_L2_16_10 gp_2_16_10 dpre_L2_16 ts_uU_L2_16_10 0 NMIR W=20u L=1u
Mo3_uU_L2_16_10 da_uU_L2_16_10 da_uU_L2_16_10 vdd vdd PMIR W=60u L=1u
Mo4_uU_L2_16_10 gp_2_16_10 da_uU_L2_16_10 vdd vdd PMIR W=60u L=1u
Mt_uU_L2_16_11 ts_uU_L2_16_11 hv_L1_35 0 0 NMIR W=48.0u L=1u
Mo1_uU_L2_16_11 da_uU_L2_16_11 d1bar_L2 ts_uU_L2_16_11 0 NMIR W=20u L=1u
Mo2_uU_L2_16_11 gp_2_16_11 dpre_L2_16 ts_uU_L2_16_11 0 NMIR W=20u L=1u
Mo3_uU_L2_16_11 da_uU_L2_16_11 da_uU_L2_16_11 vdd vdd PMIR W=60u L=1u
Mo4_uU_L2_16_11 gp_2_16_11 da_uU_L2_16_11 vdd vdd PMIR W=60u L=1u
Mt_uU_L2_16_12 ts_uU_L2_16_12 hv_L1_36 0 0 NMIR W=48.0u L=1u
Mo1_uU_L2_16_12 da_uU_L2_16_12 d1bar_L2 ts_uU_L2_16_12 0 NMIR W=20u L=1u
Mo2_uU_L2_16_12 gp_2_16_12 dpre_L2_16 ts_uU_L2_16_12 0 NMIR W=20u L=1u
Mo3_uU_L2_16_12 da_uU_L2_16_12 da_uU_L2_16_12 vdd vdd PMIR W=60u L=1u
Mo4_uU_L2_16_12 gp_2_16_12 da_uU_L2_16_12 vdd vdd PMIR W=60u L=1u
Mt_uU_L2_16_13 ts_uU_L2_16_13 hv_L1_41 0 0 NMIR W=48.0u L=1u
Mo1_uU_L2_16_13 da_uU_L2_16_13 d1bar_L2 ts_uU_L2_16_13 0 NMIR W=20u L=1u
Mo2_uU_L2_16_13 gp_2_16_13 dpre_L2_16 ts_uU_L2_16_13 0 NMIR W=20u L=1u
Mo3_uU_L2_16_13 da_uU_L2_16_13 da_uU_L2_16_13 vdd vdd PMIR W=60u L=1u
Mo4_uU_L2_16_13 gp_2_16_13 da_uU_L2_16_13 vdd vdd PMIR W=60u L=1u
Mt_uU_L2_16_14 ts_uU_L2_16_14 hv_L1_42 0 0 NMIR W=48.0u L=1u
Mo1_uU_L2_16_14 da_uU_L2_16_14 d1bar_L2 ts_uU_L2_16_14 0 NMIR W=20u L=1u
Mo2_uU_L2_16_14 gp_2_16_14 dpre_L2_16 ts_uU_L2_16_14 0 NMIR W=20u L=1u
Mo3_uU_L2_16_14 da_uU_L2_16_14 da_uU_L2_16_14 vdd vdd PMIR W=60u L=1u
Mo4_uU_L2_16_14 gp_2_16_14 da_uU_L2_16_14 vdd vdd PMIR W=60u L=1u
Mt_uU_L2_16_15 ts_uU_L2_16_15 hv_L1_45 0 0 NMIR W=48.0u L=1u
Mo1_uU_L2_16_15 da_uU_L2_16_15 d1bar_L2 ts_uU_L2_16_15 0 NMIR W=20u L=1u
Mo2_uU_L2_16_15 gp_2_16_15 dpre_L2_16 ts_uU_L2_16_15 0 NMIR W=20u L=1u
Mo3_uU_L2_16_15 da_uU_L2_16_15 da_uU_L2_16_15 vdd vdd PMIR W=60u L=1u
Mo4_uU_L2_16_15 gp_2_16_15 da_uU_L2_16_15 vdd vdd PMIR W=60u L=1u
Mt_uU_L2_17_0 ts_uU_L2_17_0 hv_L1_0 0 0 NMIR W=48.0u L=1u
Mo1_uU_L2_17_0 da_uU_L2_17_0 d1bar_L2 ts_uU_L2_17_0 0 NMIR W=20u L=1u
Mo2_uU_L2_17_0 gp_2_17_0 dpre_L2_17 ts_uU_L2_17_0 0 NMIR W=20u L=1u
Mo3_uU_L2_17_0 da_uU_L2_17_0 da_uU_L2_17_0 vdd vdd PMIR W=60u L=1u
Mo4_uU_L2_17_0 gp_2_17_0 da_uU_L2_17_0 vdd vdd PMIR W=60u L=1u
Mt_uU_L2_17_1 ts_uU_L2_17_1 hv_L1_1 0 0 NMIR W=48.0u L=1u
Mo1_uU_L2_17_1 da_uU_L2_17_1 d1bar_L2 ts_uU_L2_17_1 0 NMIR W=20u L=1u
Mo2_uU_L2_17_1 gp_2_17_1 dpre_L2_17 ts_uU_L2_17_1 0 NMIR W=20u L=1u
Mo3_uU_L2_17_1 da_uU_L2_17_1 da_uU_L2_17_1 vdd vdd PMIR W=60u L=1u
Mo4_uU_L2_17_1 gp_2_17_1 da_uU_L2_17_1 vdd vdd PMIR W=60u L=1u
Mt_uU_L2_17_2 ts_uU_L2_17_2 hv_L1_3 0 0 NMIR W=48.0u L=1u
Mo1_uU_L2_17_2 da_uU_L2_17_2 d1bar_L2 ts_uU_L2_17_2 0 NMIR W=20u L=1u
Mo2_uU_L2_17_2 gp_2_17_2 dpre_L2_17 ts_uU_L2_17_2 0 NMIR W=20u L=1u
Mo3_uU_L2_17_2 da_uU_L2_17_2 da_uU_L2_17_2 vdd vdd PMIR W=60u L=1u
Mo4_uU_L2_17_2 gp_2_17_2 da_uU_L2_17_2 vdd vdd PMIR W=60u L=1u
Mt_uU_L2_17_3 ts_uU_L2_17_3 hv_L1_4 0 0 NMIR W=48.0u L=1u
Mo1_uU_L2_17_3 da_uU_L2_17_3 d1bar_L2 ts_uU_L2_17_3 0 NMIR W=20u L=1u
Mo2_uU_L2_17_3 gp_2_17_3 dpre_L2_17 ts_uU_L2_17_3 0 NMIR W=20u L=1u
Mo3_uU_L2_17_3 da_uU_L2_17_3 da_uU_L2_17_3 vdd vdd PMIR W=60u L=1u
Mo4_uU_L2_17_3 gp_2_17_3 da_uU_L2_17_3 vdd vdd PMIR W=60u L=1u
Mt_uU_L2_17_4 ts_uU_L2_17_4 hv_L1_8 0 0 NMIR W=48.0u L=1u
Mo1_uU_L2_17_4 da_uU_L2_17_4 d1bar_L2 ts_uU_L2_17_4 0 NMIR W=20u L=1u
Mo2_uU_L2_17_4 gp_2_17_4 dpre_L2_17 ts_uU_L2_17_4 0 NMIR W=20u L=1u
Mo3_uU_L2_17_4 da_uU_L2_17_4 da_uU_L2_17_4 vdd vdd PMIR W=60u L=1u
Mo4_uU_L2_17_4 gp_2_17_4 da_uU_L2_17_4 vdd vdd PMIR W=60u L=1u
Mt_uU_L2_17_5 ts_uU_L2_17_5 hv_L1_10 0 0 NMIR W=48.0u L=1u
Mo1_uU_L2_17_5 da_uU_L2_17_5 d1bar_L2 ts_uU_L2_17_5 0 NMIR W=20u L=1u
Mo2_uU_L2_17_5 gp_2_17_5 dpre_L2_17 ts_uU_L2_17_5 0 NMIR W=20u L=1u
Mo3_uU_L2_17_5 da_uU_L2_17_5 da_uU_L2_17_5 vdd vdd PMIR W=60u L=1u
Mo4_uU_L2_17_5 gp_2_17_5 da_uU_L2_17_5 vdd vdd PMIR W=60u L=1u
Mt_uU_L2_17_6 ts_uU_L2_17_6 hv_L1_12 0 0 NMIR W=48.0u L=1u
Mo1_uU_L2_17_6 da_uU_L2_17_6 d1bar_L2 ts_uU_L2_17_6 0 NMIR W=20u L=1u
Mo2_uU_L2_17_6 gp_2_17_6 dpre_L2_17 ts_uU_L2_17_6 0 NMIR W=20u L=1u
Mo3_uU_L2_17_6 da_uU_L2_17_6 da_uU_L2_17_6 vdd vdd PMIR W=60u L=1u
Mo4_uU_L2_17_6 gp_2_17_6 da_uU_L2_17_6 vdd vdd PMIR W=60u L=1u
Mt_uU_L2_17_7 ts_uU_L2_17_7 hv_L1_13 0 0 NMIR W=48.0u L=1u
Mo1_uU_L2_17_7 da_uU_L2_17_7 d1bar_L2 ts_uU_L2_17_7 0 NMIR W=20u L=1u
Mo2_uU_L2_17_7 gp_2_17_7 dpre_L2_17 ts_uU_L2_17_7 0 NMIR W=20u L=1u
Mo3_uU_L2_17_7 da_uU_L2_17_7 da_uU_L2_17_7 vdd vdd PMIR W=60u L=1u
Mo4_uU_L2_17_7 gp_2_17_7 da_uU_L2_17_7 vdd vdd PMIR W=60u L=1u
Mt_uU_L2_17_8 ts_uU_L2_17_8 hv_L1_15 0 0 NMIR W=48.0u L=1u
Mo1_uU_L2_17_8 da_uU_L2_17_8 d1bar_L2 ts_uU_L2_17_8 0 NMIR W=20u L=1u
Mo2_uU_L2_17_8 gp_2_17_8 dpre_L2_17 ts_uU_L2_17_8 0 NMIR W=20u L=1u
Mo3_uU_L2_17_8 da_uU_L2_17_8 da_uU_L2_17_8 vdd vdd PMIR W=60u L=1u
Mo4_uU_L2_17_8 gp_2_17_8 da_uU_L2_17_8 vdd vdd PMIR W=60u L=1u
Mt_uU_L2_17_9 ts_uU_L2_17_9 hv_L1_19 0 0 NMIR W=48.0u L=1u
Mo1_uU_L2_17_9 da_uU_L2_17_9 d1bar_L2 ts_uU_L2_17_9 0 NMIR W=20u L=1u
Mo2_uU_L2_17_9 gp_2_17_9 dpre_L2_17 ts_uU_L2_17_9 0 NMIR W=20u L=1u
Mo3_uU_L2_17_9 da_uU_L2_17_9 da_uU_L2_17_9 vdd vdd PMIR W=60u L=1u
Mo4_uU_L2_17_9 gp_2_17_9 da_uU_L2_17_9 vdd vdd PMIR W=60u L=1u
Mt_uU_L2_17_10 ts_uU_L2_17_10 hv_L1_26 0 0 NMIR W=48.0u L=1u
Mo1_uU_L2_17_10 da_uU_L2_17_10 d1bar_L2 ts_uU_L2_17_10 0 NMIR W=20u L=1u
Mo2_uU_L2_17_10 gp_2_17_10 dpre_L2_17 ts_uU_L2_17_10 0 NMIR W=20u L=1u
Mo3_uU_L2_17_10 da_uU_L2_17_10 da_uU_L2_17_10 vdd vdd PMIR W=60u L=1u
Mo4_uU_L2_17_10 gp_2_17_10 da_uU_L2_17_10 vdd vdd PMIR W=60u L=1u
Mt_uU_L2_17_11 ts_uU_L2_17_11 hv_L1_35 0 0 NMIR W=48.0u L=1u
Mo1_uU_L2_17_11 da_uU_L2_17_11 d1bar_L2 ts_uU_L2_17_11 0 NMIR W=20u L=1u
Mo2_uU_L2_17_11 gp_2_17_11 dpre_L2_17 ts_uU_L2_17_11 0 NMIR W=20u L=1u
Mo3_uU_L2_17_11 da_uU_L2_17_11 da_uU_L2_17_11 vdd vdd PMIR W=60u L=1u
Mo4_uU_L2_17_11 gp_2_17_11 da_uU_L2_17_11 vdd vdd PMIR W=60u L=1u
Mt_uU_L2_17_12 ts_uU_L2_17_12 hv_L1_37 0 0 NMIR W=48.0u L=1u
Mo1_uU_L2_17_12 da_uU_L2_17_12 d1bar_L2 ts_uU_L2_17_12 0 NMIR W=20u L=1u
Mo2_uU_L2_17_12 gp_2_17_12 dpre_L2_17 ts_uU_L2_17_12 0 NMIR W=20u L=1u
Mo3_uU_L2_17_12 da_uU_L2_17_12 da_uU_L2_17_12 vdd vdd PMIR W=60u L=1u
Mo4_uU_L2_17_12 gp_2_17_12 da_uU_L2_17_12 vdd vdd PMIR W=60u L=1u
Mt_uU_L2_17_13 ts_uU_L2_17_13 hv_L1_38 0 0 NMIR W=48.0u L=1u
Mo1_uU_L2_17_13 da_uU_L2_17_13 d1bar_L2 ts_uU_L2_17_13 0 NMIR W=20u L=1u
Mo2_uU_L2_17_13 gp_2_17_13 dpre_L2_17 ts_uU_L2_17_13 0 NMIR W=20u L=1u
Mo3_uU_L2_17_13 da_uU_L2_17_13 da_uU_L2_17_13 vdd vdd PMIR W=60u L=1u
Mo4_uU_L2_17_13 gp_2_17_13 da_uU_L2_17_13 vdd vdd PMIR W=60u L=1u
Mt_uU_L2_17_14 ts_uU_L2_17_14 hv_L1_39 0 0 NMIR W=48.0u L=1u
Mo1_uU_L2_17_14 da_uU_L2_17_14 d1bar_L2 ts_uU_L2_17_14 0 NMIR W=20u L=1u
Mo2_uU_L2_17_14 gp_2_17_14 dpre_L2_17 ts_uU_L2_17_14 0 NMIR W=20u L=1u
Mo3_uU_L2_17_14 da_uU_L2_17_14 da_uU_L2_17_14 vdd vdd PMIR W=60u L=1u
Mo4_uU_L2_17_14 gp_2_17_14 da_uU_L2_17_14 vdd vdd PMIR W=60u L=1u
Mt_uU_L2_17_15 ts_uU_L2_17_15 hv_L1_46 0 0 NMIR W=48.0u L=1u
Mo1_uU_L2_17_15 da_uU_L2_17_15 d1bar_L2 ts_uU_L2_17_15 0 NMIR W=20u L=1u
Mo2_uU_L2_17_15 gp_2_17_15 dpre_L2_17 ts_uU_L2_17_15 0 NMIR W=20u L=1u
Mo3_uU_L2_17_15 da_uU_L2_17_15 da_uU_L2_17_15 vdd vdd PMIR W=60u L=1u
Mo4_uU_L2_17_15 gp_2_17_15 da_uU_L2_17_15 vdd vdd PMIR W=60u L=1u
Mt_uU_L2_18_0 ts_uU_L2_18_0 hv_L1_2 0 0 NMIR W=48.0u L=1u
Mo1_uU_L2_18_0 da_uU_L2_18_0 d1bar_L2 ts_uU_L2_18_0 0 NMIR W=20u L=1u
Mo2_uU_L2_18_0 gp_2_18_0 dpre_L2_18 ts_uU_L2_18_0 0 NMIR W=20u L=1u
Mo3_uU_L2_18_0 da_uU_L2_18_0 da_uU_L2_18_0 vdd vdd PMIR W=60u L=1u
Mo4_uU_L2_18_0 gp_2_18_0 da_uU_L2_18_0 vdd vdd PMIR W=60u L=1u
Mt_uU_L2_18_1 ts_uU_L2_18_1 hv_L1_5 0 0 NMIR W=48.0u L=1u
Mo1_uU_L2_18_1 da_uU_L2_18_1 d1bar_L2 ts_uU_L2_18_1 0 NMIR W=20u L=1u
Mo2_uU_L2_18_1 gp_2_18_1 dpre_L2_18 ts_uU_L2_18_1 0 NMIR W=20u L=1u
Mo3_uU_L2_18_1 da_uU_L2_18_1 da_uU_L2_18_1 vdd vdd PMIR W=60u L=1u
Mo4_uU_L2_18_1 gp_2_18_1 da_uU_L2_18_1 vdd vdd PMIR W=60u L=1u
Mt_uU_L2_18_2 ts_uU_L2_18_2 hv_L1_6 0 0 NMIR W=48.0u L=1u
Mo1_uU_L2_18_2 da_uU_L2_18_2 d1bar_L2 ts_uU_L2_18_2 0 NMIR W=20u L=1u
Mo2_uU_L2_18_2 gp_2_18_2 dpre_L2_18 ts_uU_L2_18_2 0 NMIR W=20u L=1u
Mo3_uU_L2_18_2 da_uU_L2_18_2 da_uU_L2_18_2 vdd vdd PMIR W=60u L=1u
Mo4_uU_L2_18_2 gp_2_18_2 da_uU_L2_18_2 vdd vdd PMIR W=60u L=1u
Mt_uU_L2_18_3 ts_uU_L2_18_3 hv_L1_11 0 0 NMIR W=48.0u L=1u
Mo1_uU_L2_18_3 da_uU_L2_18_3 d1bar_L2 ts_uU_L2_18_3 0 NMIR W=20u L=1u
Mo2_uU_L2_18_3 gp_2_18_3 dpre_L2_18 ts_uU_L2_18_3 0 NMIR W=20u L=1u
Mo3_uU_L2_18_3 da_uU_L2_18_3 da_uU_L2_18_3 vdd vdd PMIR W=60u L=1u
Mo4_uU_L2_18_3 gp_2_18_3 da_uU_L2_18_3 vdd vdd PMIR W=60u L=1u
Mt_uU_L2_18_4 ts_uU_L2_18_4 hv_L1_14 0 0 NMIR W=48.0u L=1u
Mo1_uU_L2_18_4 da_uU_L2_18_4 d1bar_L2 ts_uU_L2_18_4 0 NMIR W=20u L=1u
Mo2_uU_L2_18_4 gp_2_18_4 dpre_L2_18 ts_uU_L2_18_4 0 NMIR W=20u L=1u
Mo3_uU_L2_18_4 da_uU_L2_18_4 da_uU_L2_18_4 vdd vdd PMIR W=60u L=1u
Mo4_uU_L2_18_4 gp_2_18_4 da_uU_L2_18_4 vdd vdd PMIR W=60u L=1u
Mt_uU_L2_18_5 ts_uU_L2_18_5 hv_L1_16 0 0 NMIR W=48.0u L=1u
Mo1_uU_L2_18_5 da_uU_L2_18_5 d1bar_L2 ts_uU_L2_18_5 0 NMIR W=20u L=1u
Mo2_uU_L2_18_5 gp_2_18_5 dpre_L2_18 ts_uU_L2_18_5 0 NMIR W=20u L=1u
Mo3_uU_L2_18_5 da_uU_L2_18_5 da_uU_L2_18_5 vdd vdd PMIR W=60u L=1u
Mo4_uU_L2_18_5 gp_2_18_5 da_uU_L2_18_5 vdd vdd PMIR W=60u L=1u
Mt_uU_L2_18_6 ts_uU_L2_18_6 hv_L1_19 0 0 NMIR W=48.0u L=1u
Mo1_uU_L2_18_6 da_uU_L2_18_6 d1bar_L2 ts_uU_L2_18_6 0 NMIR W=20u L=1u
Mo2_uU_L2_18_6 gp_2_18_6 dpre_L2_18 ts_uU_L2_18_6 0 NMIR W=20u L=1u
Mo3_uU_L2_18_6 da_uU_L2_18_6 da_uU_L2_18_6 vdd vdd PMIR W=60u L=1u
Mo4_uU_L2_18_6 gp_2_18_6 da_uU_L2_18_6 vdd vdd PMIR W=60u L=1u
Mt_uU_L2_18_7 ts_uU_L2_18_7 hv_L1_25 0 0 NMIR W=48.0u L=1u
Mo1_uU_L2_18_7 da_uU_L2_18_7 d1bar_L2 ts_uU_L2_18_7 0 NMIR W=20u L=1u
Mo2_uU_L2_18_7 gp_2_18_7 dpre_L2_18 ts_uU_L2_18_7 0 NMIR W=20u L=1u
Mo3_uU_L2_18_7 da_uU_L2_18_7 da_uU_L2_18_7 vdd vdd PMIR W=60u L=1u
Mo4_uU_L2_18_7 gp_2_18_7 da_uU_L2_18_7 vdd vdd PMIR W=60u L=1u
Mt_uU_L2_18_8 ts_uU_L2_18_8 hv_L1_27 0 0 NMIR W=48.0u L=1u
Mo1_uU_L2_18_8 da_uU_L2_18_8 d1bar_L2 ts_uU_L2_18_8 0 NMIR W=20u L=1u
Mo2_uU_L2_18_8 gp_2_18_8 dpre_L2_18 ts_uU_L2_18_8 0 NMIR W=20u L=1u
Mo3_uU_L2_18_8 da_uU_L2_18_8 da_uU_L2_18_8 vdd vdd PMIR W=60u L=1u
Mo4_uU_L2_18_8 gp_2_18_8 da_uU_L2_18_8 vdd vdd PMIR W=60u L=1u
Mt_uU_L2_18_9 ts_uU_L2_18_9 hv_L1_29 0 0 NMIR W=48.0u L=1u
Mo1_uU_L2_18_9 da_uU_L2_18_9 d1bar_L2 ts_uU_L2_18_9 0 NMIR W=20u L=1u
Mo2_uU_L2_18_9 gp_2_18_9 dpre_L2_18 ts_uU_L2_18_9 0 NMIR W=20u L=1u
Mo3_uU_L2_18_9 da_uU_L2_18_9 da_uU_L2_18_9 vdd vdd PMIR W=60u L=1u
Mo4_uU_L2_18_9 gp_2_18_9 da_uU_L2_18_9 vdd vdd PMIR W=60u L=1u
Mt_uU_L2_18_10 ts_uU_L2_18_10 hv_L1_30 0 0 NMIR W=48.0u L=1u
Mo1_uU_L2_18_10 da_uU_L2_18_10 d1bar_L2 ts_uU_L2_18_10 0 NMIR W=20u L=1u
Mo2_uU_L2_18_10 gp_2_18_10 dpre_L2_18 ts_uU_L2_18_10 0 NMIR W=20u L=1u
Mo3_uU_L2_18_10 da_uU_L2_18_10 da_uU_L2_18_10 vdd vdd PMIR W=60u L=1u
Mo4_uU_L2_18_10 gp_2_18_10 da_uU_L2_18_10 vdd vdd PMIR W=60u L=1u
Mt_uU_L2_18_11 ts_uU_L2_18_11 hv_L1_32 0 0 NMIR W=48.0u L=1u
Mo1_uU_L2_18_11 da_uU_L2_18_11 d1bar_L2 ts_uU_L2_18_11 0 NMIR W=20u L=1u
Mo2_uU_L2_18_11 gp_2_18_11 dpre_L2_18 ts_uU_L2_18_11 0 NMIR W=20u L=1u
Mo3_uU_L2_18_11 da_uU_L2_18_11 da_uU_L2_18_11 vdd vdd PMIR W=60u L=1u
Mo4_uU_L2_18_11 gp_2_18_11 da_uU_L2_18_11 vdd vdd PMIR W=60u L=1u
Mt_uU_L2_18_12 ts_uU_L2_18_12 hv_L1_33 0 0 NMIR W=48.0u L=1u
Mo1_uU_L2_18_12 da_uU_L2_18_12 d1bar_L2 ts_uU_L2_18_12 0 NMIR W=20u L=1u
Mo2_uU_L2_18_12 gp_2_18_12 dpre_L2_18 ts_uU_L2_18_12 0 NMIR W=20u L=1u
Mo3_uU_L2_18_12 da_uU_L2_18_12 da_uU_L2_18_12 vdd vdd PMIR W=60u L=1u
Mo4_uU_L2_18_12 gp_2_18_12 da_uU_L2_18_12 vdd vdd PMIR W=60u L=1u
Mt_uU_L2_18_13 ts_uU_L2_18_13 hv_L1_34 0 0 NMIR W=48.0u L=1u
Mo1_uU_L2_18_13 da_uU_L2_18_13 d1bar_L2 ts_uU_L2_18_13 0 NMIR W=20u L=1u
Mo2_uU_L2_18_13 gp_2_18_13 dpre_L2_18 ts_uU_L2_18_13 0 NMIR W=20u L=1u
Mo3_uU_L2_18_13 da_uU_L2_18_13 da_uU_L2_18_13 vdd vdd PMIR W=60u L=1u
Mo4_uU_L2_18_13 gp_2_18_13 da_uU_L2_18_13 vdd vdd PMIR W=60u L=1u
Mt_uU_L2_18_14 ts_uU_L2_18_14 hv_L1_35 0 0 NMIR W=48.0u L=1u
Mo1_uU_L2_18_14 da_uU_L2_18_14 d1bar_L2 ts_uU_L2_18_14 0 NMIR W=20u L=1u
Mo2_uU_L2_18_14 gp_2_18_14 dpre_L2_18 ts_uU_L2_18_14 0 NMIR W=20u L=1u
Mo3_uU_L2_18_14 da_uU_L2_18_14 da_uU_L2_18_14 vdd vdd PMIR W=60u L=1u
Mo4_uU_L2_18_14 gp_2_18_14 da_uU_L2_18_14 vdd vdd PMIR W=60u L=1u
Mt_uU_L2_18_15 ts_uU_L2_18_15 hv_L1_39 0 0 NMIR W=48.0u L=1u
Mo1_uU_L2_18_15 da_uU_L2_18_15 d1bar_L2 ts_uU_L2_18_15 0 NMIR W=20u L=1u
Mo2_uU_L2_18_15 gp_2_18_15 dpre_L2_18 ts_uU_L2_18_15 0 NMIR W=20u L=1u
Mo3_uU_L2_18_15 da_uU_L2_18_15 da_uU_L2_18_15 vdd vdd PMIR W=60u L=1u
Mo4_uU_L2_18_15 gp_2_18_15 da_uU_L2_18_15 vdd vdd PMIR W=60u L=1u
Mt_uU_L2_19_0 ts_uU_L2_19_0 hv_L1_0 0 0 NMIR W=48.0u L=1u
Mo1_uU_L2_19_0 da_uU_L2_19_0 d1bar_L2 ts_uU_L2_19_0 0 NMIR W=20u L=1u
Mo2_uU_L2_19_0 gp_2_19_0 dpre_L2_19 ts_uU_L2_19_0 0 NMIR W=20u L=1u
Mo3_uU_L2_19_0 da_uU_L2_19_0 da_uU_L2_19_0 vdd vdd PMIR W=60u L=1u
Mo4_uU_L2_19_0 gp_2_19_0 da_uU_L2_19_0 vdd vdd PMIR W=60u L=1u
Mt_uU_L2_19_1 ts_uU_L2_19_1 hv_L1_5 0 0 NMIR W=48.0u L=1u
Mo1_uU_L2_19_1 da_uU_L2_19_1 d1bar_L2 ts_uU_L2_19_1 0 NMIR W=20u L=1u
Mo2_uU_L2_19_1 gp_2_19_1 dpre_L2_19 ts_uU_L2_19_1 0 NMIR W=20u L=1u
Mo3_uU_L2_19_1 da_uU_L2_19_1 da_uU_L2_19_1 vdd vdd PMIR W=60u L=1u
Mo4_uU_L2_19_1 gp_2_19_1 da_uU_L2_19_1 vdd vdd PMIR W=60u L=1u
Mt_uU_L2_19_2 ts_uU_L2_19_2 hv_L1_10 0 0 NMIR W=48.0u L=1u
Mo1_uU_L2_19_2 da_uU_L2_19_2 d1bar_L2 ts_uU_L2_19_2 0 NMIR W=20u L=1u
Mo2_uU_L2_19_2 gp_2_19_2 dpre_L2_19 ts_uU_L2_19_2 0 NMIR W=20u L=1u
Mo3_uU_L2_19_2 da_uU_L2_19_2 da_uU_L2_19_2 vdd vdd PMIR W=60u L=1u
Mo4_uU_L2_19_2 gp_2_19_2 da_uU_L2_19_2 vdd vdd PMIR W=60u L=1u
Mt_uU_L2_19_3 ts_uU_L2_19_3 hv_L1_12 0 0 NMIR W=48.0u L=1u
Mo1_uU_L2_19_3 da_uU_L2_19_3 d1bar_L2 ts_uU_L2_19_3 0 NMIR W=20u L=1u
Mo2_uU_L2_19_3 gp_2_19_3 dpre_L2_19 ts_uU_L2_19_3 0 NMIR W=20u L=1u
Mo3_uU_L2_19_3 da_uU_L2_19_3 da_uU_L2_19_3 vdd vdd PMIR W=60u L=1u
Mo4_uU_L2_19_3 gp_2_19_3 da_uU_L2_19_3 vdd vdd PMIR W=60u L=1u
Mt_uU_L2_19_4 ts_uU_L2_19_4 hv_L1_13 0 0 NMIR W=48.0u L=1u
Mo1_uU_L2_19_4 da_uU_L2_19_4 d1bar_L2 ts_uU_L2_19_4 0 NMIR W=20u L=1u
Mo2_uU_L2_19_4 gp_2_19_4 dpre_L2_19 ts_uU_L2_19_4 0 NMIR W=20u L=1u
Mo3_uU_L2_19_4 da_uU_L2_19_4 da_uU_L2_19_4 vdd vdd PMIR W=60u L=1u
Mo4_uU_L2_19_4 gp_2_19_4 da_uU_L2_19_4 vdd vdd PMIR W=60u L=1u
Mt_uU_L2_19_5 ts_uU_L2_19_5 hv_L1_14 0 0 NMIR W=48.0u L=1u
Mo1_uU_L2_19_5 da_uU_L2_19_5 d1bar_L2 ts_uU_L2_19_5 0 NMIR W=20u L=1u
Mo2_uU_L2_19_5 gp_2_19_5 dpre_L2_19 ts_uU_L2_19_5 0 NMIR W=20u L=1u
Mo3_uU_L2_19_5 da_uU_L2_19_5 da_uU_L2_19_5 vdd vdd PMIR W=60u L=1u
Mo4_uU_L2_19_5 gp_2_19_5 da_uU_L2_19_5 vdd vdd PMIR W=60u L=1u
Mt_uU_L2_19_6 ts_uU_L2_19_6 hv_L1_23 0 0 NMIR W=48.0u L=1u
Mo1_uU_L2_19_6 da_uU_L2_19_6 d1bar_L2 ts_uU_L2_19_6 0 NMIR W=20u L=1u
Mo2_uU_L2_19_6 gp_2_19_6 dpre_L2_19 ts_uU_L2_19_6 0 NMIR W=20u L=1u
Mo3_uU_L2_19_6 da_uU_L2_19_6 da_uU_L2_19_6 vdd vdd PMIR W=60u L=1u
Mo4_uU_L2_19_6 gp_2_19_6 da_uU_L2_19_6 vdd vdd PMIR W=60u L=1u
Mt_uU_L2_19_7 ts_uU_L2_19_7 hv_L1_25 0 0 NMIR W=48.0u L=1u
Mo1_uU_L2_19_7 da_uU_L2_19_7 d1bar_L2 ts_uU_L2_19_7 0 NMIR W=20u L=1u
Mo2_uU_L2_19_7 gp_2_19_7 dpre_L2_19 ts_uU_L2_19_7 0 NMIR W=20u L=1u
Mo3_uU_L2_19_7 da_uU_L2_19_7 da_uU_L2_19_7 vdd vdd PMIR W=60u L=1u
Mo4_uU_L2_19_7 gp_2_19_7 da_uU_L2_19_7 vdd vdd PMIR W=60u L=1u
Mt_uU_L2_19_8 ts_uU_L2_19_8 hv_L1_27 0 0 NMIR W=48.0u L=1u
Mo1_uU_L2_19_8 da_uU_L2_19_8 d1bar_L2 ts_uU_L2_19_8 0 NMIR W=20u L=1u
Mo2_uU_L2_19_8 gp_2_19_8 dpre_L2_19 ts_uU_L2_19_8 0 NMIR W=20u L=1u
Mo3_uU_L2_19_8 da_uU_L2_19_8 da_uU_L2_19_8 vdd vdd PMIR W=60u L=1u
Mo4_uU_L2_19_8 gp_2_19_8 da_uU_L2_19_8 vdd vdd PMIR W=60u L=1u
Mt_uU_L2_19_9 ts_uU_L2_19_9 hv_L1_29 0 0 NMIR W=48.0u L=1u
Mo1_uU_L2_19_9 da_uU_L2_19_9 d1bar_L2 ts_uU_L2_19_9 0 NMIR W=20u L=1u
Mo2_uU_L2_19_9 gp_2_19_9 dpre_L2_19 ts_uU_L2_19_9 0 NMIR W=20u L=1u
Mo3_uU_L2_19_9 da_uU_L2_19_9 da_uU_L2_19_9 vdd vdd PMIR W=60u L=1u
Mo4_uU_L2_19_9 gp_2_19_9 da_uU_L2_19_9 vdd vdd PMIR W=60u L=1u
Mt_uU_L2_19_10 ts_uU_L2_19_10 hv_L1_31 0 0 NMIR W=48.0u L=1u
Mo1_uU_L2_19_10 da_uU_L2_19_10 d1bar_L2 ts_uU_L2_19_10 0 NMIR W=20u L=1u
Mo2_uU_L2_19_10 gp_2_19_10 dpre_L2_19 ts_uU_L2_19_10 0 NMIR W=20u L=1u
Mo3_uU_L2_19_10 da_uU_L2_19_10 da_uU_L2_19_10 vdd vdd PMIR W=60u L=1u
Mo4_uU_L2_19_10 gp_2_19_10 da_uU_L2_19_10 vdd vdd PMIR W=60u L=1u
Mt_uU_L2_19_11 ts_uU_L2_19_11 hv_L1_38 0 0 NMIR W=48.0u L=1u
Mo1_uU_L2_19_11 da_uU_L2_19_11 d1bar_L2 ts_uU_L2_19_11 0 NMIR W=20u L=1u
Mo2_uU_L2_19_11 gp_2_19_11 dpre_L2_19 ts_uU_L2_19_11 0 NMIR W=20u L=1u
Mo3_uU_L2_19_11 da_uU_L2_19_11 da_uU_L2_19_11 vdd vdd PMIR W=60u L=1u
Mo4_uU_L2_19_11 gp_2_19_11 da_uU_L2_19_11 vdd vdd PMIR W=60u L=1u
Mt_uU_L2_19_12 ts_uU_L2_19_12 hv_L1_40 0 0 NMIR W=48.0u L=1u
Mo1_uU_L2_19_12 da_uU_L2_19_12 d1bar_L2 ts_uU_L2_19_12 0 NMIR W=20u L=1u
Mo2_uU_L2_19_12 gp_2_19_12 dpre_L2_19 ts_uU_L2_19_12 0 NMIR W=20u L=1u
Mo3_uU_L2_19_12 da_uU_L2_19_12 da_uU_L2_19_12 vdd vdd PMIR W=60u L=1u
Mo4_uU_L2_19_12 gp_2_19_12 da_uU_L2_19_12 vdd vdd PMIR W=60u L=1u
Mt_uU_L2_19_13 ts_uU_L2_19_13 hv_L1_42 0 0 NMIR W=48.0u L=1u
Mo1_uU_L2_19_13 da_uU_L2_19_13 d1bar_L2 ts_uU_L2_19_13 0 NMIR W=20u L=1u
Mo2_uU_L2_19_13 gp_2_19_13 dpre_L2_19 ts_uU_L2_19_13 0 NMIR W=20u L=1u
Mo3_uU_L2_19_13 da_uU_L2_19_13 da_uU_L2_19_13 vdd vdd PMIR W=60u L=1u
Mo4_uU_L2_19_13 gp_2_19_13 da_uU_L2_19_13 vdd vdd PMIR W=60u L=1u
Mt_uU_L2_19_14 ts_uU_L2_19_14 hv_L1_44 0 0 NMIR W=48.0u L=1u
Mo1_uU_L2_19_14 da_uU_L2_19_14 d1bar_L2 ts_uU_L2_19_14 0 NMIR W=20u L=1u
Mo2_uU_L2_19_14 gp_2_19_14 dpre_L2_19 ts_uU_L2_19_14 0 NMIR W=20u L=1u
Mo3_uU_L2_19_14 da_uU_L2_19_14 da_uU_L2_19_14 vdd vdd PMIR W=60u L=1u
Mo4_uU_L2_19_14 gp_2_19_14 da_uU_L2_19_14 vdd vdd PMIR W=60u L=1u
Mt_uU_L2_19_15 ts_uU_L2_19_15 hv_L1_45 0 0 NMIR W=48.0u L=1u
Mo1_uU_L2_19_15 da_uU_L2_19_15 d1bar_L2 ts_uU_L2_19_15 0 NMIR W=20u L=1u
Mo2_uU_L2_19_15 gp_2_19_15 dpre_L2_19 ts_uU_L2_19_15 0 NMIR W=20u L=1u
Mo3_uU_L2_19_15 da_uU_L2_19_15 da_uU_L2_19_15 vdd vdd PMIR W=60u L=1u
Mo4_uU_L2_19_15 gp_2_19_15 da_uU_L2_19_15 vdd vdd PMIR W=60u L=1u
Mt_uU_L2_20_0 ts_uU_L2_20_0 hv_L1_0 0 0 NMIR W=48.0u L=1u
Mo1_uU_L2_20_0 da_uU_L2_20_0 d1bar_L2 ts_uU_L2_20_0 0 NMIR W=20u L=1u
Mo2_uU_L2_20_0 gp_2_20_0 dpre_L2_20 ts_uU_L2_20_0 0 NMIR W=20u L=1u
Mo3_uU_L2_20_0 da_uU_L2_20_0 da_uU_L2_20_0 vdd vdd PMIR W=60u L=1u
Mo4_uU_L2_20_0 gp_2_20_0 da_uU_L2_20_0 vdd vdd PMIR W=60u L=1u
Mt_uU_L2_20_1 ts_uU_L2_20_1 hv_L1_3 0 0 NMIR W=48.0u L=1u
Mo1_uU_L2_20_1 da_uU_L2_20_1 d1bar_L2 ts_uU_L2_20_1 0 NMIR W=20u L=1u
Mo2_uU_L2_20_1 gp_2_20_1 dpre_L2_20 ts_uU_L2_20_1 0 NMIR W=20u L=1u
Mo3_uU_L2_20_1 da_uU_L2_20_1 da_uU_L2_20_1 vdd vdd PMIR W=60u L=1u
Mo4_uU_L2_20_1 gp_2_20_1 da_uU_L2_20_1 vdd vdd PMIR W=60u L=1u
Mt_uU_L2_20_2 ts_uU_L2_20_2 hv_L1_4 0 0 NMIR W=48.0u L=1u
Mo1_uU_L2_20_2 da_uU_L2_20_2 d1bar_L2 ts_uU_L2_20_2 0 NMIR W=20u L=1u
Mo2_uU_L2_20_2 gp_2_20_2 dpre_L2_20 ts_uU_L2_20_2 0 NMIR W=20u L=1u
Mo3_uU_L2_20_2 da_uU_L2_20_2 da_uU_L2_20_2 vdd vdd PMIR W=60u L=1u
Mo4_uU_L2_20_2 gp_2_20_2 da_uU_L2_20_2 vdd vdd PMIR W=60u L=1u
Mt_uU_L2_20_3 ts_uU_L2_20_3 hv_L1_9 0 0 NMIR W=48.0u L=1u
Mo1_uU_L2_20_3 da_uU_L2_20_3 d1bar_L2 ts_uU_L2_20_3 0 NMIR W=20u L=1u
Mo2_uU_L2_20_3 gp_2_20_3 dpre_L2_20 ts_uU_L2_20_3 0 NMIR W=20u L=1u
Mo3_uU_L2_20_3 da_uU_L2_20_3 da_uU_L2_20_3 vdd vdd PMIR W=60u L=1u
Mo4_uU_L2_20_3 gp_2_20_3 da_uU_L2_20_3 vdd vdd PMIR W=60u L=1u
Mt_uU_L2_20_4 ts_uU_L2_20_4 hv_L1_10 0 0 NMIR W=48.0u L=1u
Mo1_uU_L2_20_4 da_uU_L2_20_4 d1bar_L2 ts_uU_L2_20_4 0 NMIR W=20u L=1u
Mo2_uU_L2_20_4 gp_2_20_4 dpre_L2_20 ts_uU_L2_20_4 0 NMIR W=20u L=1u
Mo3_uU_L2_20_4 da_uU_L2_20_4 da_uU_L2_20_4 vdd vdd PMIR W=60u L=1u
Mo4_uU_L2_20_4 gp_2_20_4 da_uU_L2_20_4 vdd vdd PMIR W=60u L=1u
Mt_uU_L2_20_5 ts_uU_L2_20_5 hv_L1_13 0 0 NMIR W=48.0u L=1u
Mo1_uU_L2_20_5 da_uU_L2_20_5 d1bar_L2 ts_uU_L2_20_5 0 NMIR W=20u L=1u
Mo2_uU_L2_20_5 gp_2_20_5 dpre_L2_20 ts_uU_L2_20_5 0 NMIR W=20u L=1u
Mo3_uU_L2_20_5 da_uU_L2_20_5 da_uU_L2_20_5 vdd vdd PMIR W=60u L=1u
Mo4_uU_L2_20_5 gp_2_20_5 da_uU_L2_20_5 vdd vdd PMIR W=60u L=1u
Mt_uU_L2_20_6 ts_uU_L2_20_6 hv_L1_16 0 0 NMIR W=48.0u L=1u
Mo1_uU_L2_20_6 da_uU_L2_20_6 d1bar_L2 ts_uU_L2_20_6 0 NMIR W=20u L=1u
Mo2_uU_L2_20_6 gp_2_20_6 dpre_L2_20 ts_uU_L2_20_6 0 NMIR W=20u L=1u
Mo3_uU_L2_20_6 da_uU_L2_20_6 da_uU_L2_20_6 vdd vdd PMIR W=60u L=1u
Mo4_uU_L2_20_6 gp_2_20_6 da_uU_L2_20_6 vdd vdd PMIR W=60u L=1u
Mt_uU_L2_20_7 ts_uU_L2_20_7 hv_L1_17 0 0 NMIR W=48.0u L=1u
Mo1_uU_L2_20_7 da_uU_L2_20_7 d1bar_L2 ts_uU_L2_20_7 0 NMIR W=20u L=1u
Mo2_uU_L2_20_7 gp_2_20_7 dpre_L2_20 ts_uU_L2_20_7 0 NMIR W=20u L=1u
Mo3_uU_L2_20_7 da_uU_L2_20_7 da_uU_L2_20_7 vdd vdd PMIR W=60u L=1u
Mo4_uU_L2_20_7 gp_2_20_7 da_uU_L2_20_7 vdd vdd PMIR W=60u L=1u
Mt_uU_L2_20_8 ts_uU_L2_20_8 hv_L1_18 0 0 NMIR W=48.0u L=1u
Mo1_uU_L2_20_8 da_uU_L2_20_8 d1bar_L2 ts_uU_L2_20_8 0 NMIR W=20u L=1u
Mo2_uU_L2_20_8 gp_2_20_8 dpre_L2_20 ts_uU_L2_20_8 0 NMIR W=20u L=1u
Mo3_uU_L2_20_8 da_uU_L2_20_8 da_uU_L2_20_8 vdd vdd PMIR W=60u L=1u
Mo4_uU_L2_20_8 gp_2_20_8 da_uU_L2_20_8 vdd vdd PMIR W=60u L=1u
Mt_uU_L2_20_9 ts_uU_L2_20_9 hv_L1_20 0 0 NMIR W=48.0u L=1u
Mo1_uU_L2_20_9 da_uU_L2_20_9 d1bar_L2 ts_uU_L2_20_9 0 NMIR W=20u L=1u
Mo2_uU_L2_20_9 gp_2_20_9 dpre_L2_20 ts_uU_L2_20_9 0 NMIR W=20u L=1u
Mo3_uU_L2_20_9 da_uU_L2_20_9 da_uU_L2_20_9 vdd vdd PMIR W=60u L=1u
Mo4_uU_L2_20_9 gp_2_20_9 da_uU_L2_20_9 vdd vdd PMIR W=60u L=1u
Mt_uU_L2_20_10 ts_uU_L2_20_10 hv_L1_27 0 0 NMIR W=48.0u L=1u
Mo1_uU_L2_20_10 da_uU_L2_20_10 d1bar_L2 ts_uU_L2_20_10 0 NMIR W=20u L=1u
Mo2_uU_L2_20_10 gp_2_20_10 dpre_L2_20 ts_uU_L2_20_10 0 NMIR W=20u L=1u
Mo3_uU_L2_20_10 da_uU_L2_20_10 da_uU_L2_20_10 vdd vdd PMIR W=60u L=1u
Mo4_uU_L2_20_10 gp_2_20_10 da_uU_L2_20_10 vdd vdd PMIR W=60u L=1u
Mt_uU_L2_20_11 ts_uU_L2_20_11 hv_L1_38 0 0 NMIR W=48.0u L=1u
Mo1_uU_L2_20_11 da_uU_L2_20_11 d1bar_L2 ts_uU_L2_20_11 0 NMIR W=20u L=1u
Mo2_uU_L2_20_11 gp_2_20_11 dpre_L2_20 ts_uU_L2_20_11 0 NMIR W=20u L=1u
Mo3_uU_L2_20_11 da_uU_L2_20_11 da_uU_L2_20_11 vdd vdd PMIR W=60u L=1u
Mo4_uU_L2_20_11 gp_2_20_11 da_uU_L2_20_11 vdd vdd PMIR W=60u L=1u
Mt_uU_L2_20_12 ts_uU_L2_20_12 hv_L1_39 0 0 NMIR W=48.0u L=1u
Mo1_uU_L2_20_12 da_uU_L2_20_12 d1bar_L2 ts_uU_L2_20_12 0 NMIR W=20u L=1u
Mo2_uU_L2_20_12 gp_2_20_12 dpre_L2_20 ts_uU_L2_20_12 0 NMIR W=20u L=1u
Mo3_uU_L2_20_12 da_uU_L2_20_12 da_uU_L2_20_12 vdd vdd PMIR W=60u L=1u
Mo4_uU_L2_20_12 gp_2_20_12 da_uU_L2_20_12 vdd vdd PMIR W=60u L=1u
Mt_uU_L2_20_13 ts_uU_L2_20_13 hv_L1_43 0 0 NMIR W=48.0u L=1u
Mo1_uU_L2_20_13 da_uU_L2_20_13 d1bar_L2 ts_uU_L2_20_13 0 NMIR W=20u L=1u
Mo2_uU_L2_20_13 gp_2_20_13 dpre_L2_20 ts_uU_L2_20_13 0 NMIR W=20u L=1u
Mo3_uU_L2_20_13 da_uU_L2_20_13 da_uU_L2_20_13 vdd vdd PMIR W=60u L=1u
Mo4_uU_L2_20_13 gp_2_20_13 da_uU_L2_20_13 vdd vdd PMIR W=60u L=1u
Mt_uU_L2_20_14 ts_uU_L2_20_14 hv_L1_46 0 0 NMIR W=48.0u L=1u
Mo1_uU_L2_20_14 da_uU_L2_20_14 d1bar_L2 ts_uU_L2_20_14 0 NMIR W=20u L=1u
Mo2_uU_L2_20_14 gp_2_20_14 dpre_L2_20 ts_uU_L2_20_14 0 NMIR W=20u L=1u
Mo3_uU_L2_20_14 da_uU_L2_20_14 da_uU_L2_20_14 vdd vdd PMIR W=60u L=1u
Mo4_uU_L2_20_14 gp_2_20_14 da_uU_L2_20_14 vdd vdd PMIR W=60u L=1u
Mt_uU_L2_20_15 ts_uU_L2_20_15 hv_L1_47 0 0 NMIR W=48.0u L=1u
Mo1_uU_L2_20_15 da_uU_L2_20_15 d1bar_L2 ts_uU_L2_20_15 0 NMIR W=20u L=1u
Mo2_uU_L2_20_15 gp_2_20_15 dpre_L2_20 ts_uU_L2_20_15 0 NMIR W=20u L=1u
Mo3_uU_L2_20_15 da_uU_L2_20_15 da_uU_L2_20_15 vdd vdd PMIR W=60u L=1u
Mo4_uU_L2_20_15 gp_2_20_15 da_uU_L2_20_15 vdd vdd PMIR W=60u L=1u
Mt_uU_L2_21_0 ts_uU_L2_21_0 hv_L1_0 0 0 NMIR W=48.0u L=1u
Mo1_uU_L2_21_0 da_uU_L2_21_0 d1bar_L2 ts_uU_L2_21_0 0 NMIR W=20u L=1u
Mo2_uU_L2_21_0 gp_2_21_0 dpre_L2_21 ts_uU_L2_21_0 0 NMIR W=20u L=1u
Mo3_uU_L2_21_0 da_uU_L2_21_0 da_uU_L2_21_0 vdd vdd PMIR W=60u L=1u
Mo4_uU_L2_21_0 gp_2_21_0 da_uU_L2_21_0 vdd vdd PMIR W=60u L=1u
Mt_uU_L2_21_1 ts_uU_L2_21_1 hv_L1_2 0 0 NMIR W=48.0u L=1u
Mo1_uU_L2_21_1 da_uU_L2_21_1 d1bar_L2 ts_uU_L2_21_1 0 NMIR W=20u L=1u
Mo2_uU_L2_21_1 gp_2_21_1 dpre_L2_21 ts_uU_L2_21_1 0 NMIR W=20u L=1u
Mo3_uU_L2_21_1 da_uU_L2_21_1 da_uU_L2_21_1 vdd vdd PMIR W=60u L=1u
Mo4_uU_L2_21_1 gp_2_21_1 da_uU_L2_21_1 vdd vdd PMIR W=60u L=1u
Mt_uU_L2_21_2 ts_uU_L2_21_2 hv_L1_9 0 0 NMIR W=48.0u L=1u
Mo1_uU_L2_21_2 da_uU_L2_21_2 d1bar_L2 ts_uU_L2_21_2 0 NMIR W=20u L=1u
Mo2_uU_L2_21_2 gp_2_21_2 dpre_L2_21 ts_uU_L2_21_2 0 NMIR W=20u L=1u
Mo3_uU_L2_21_2 da_uU_L2_21_2 da_uU_L2_21_2 vdd vdd PMIR W=60u L=1u
Mo4_uU_L2_21_2 gp_2_21_2 da_uU_L2_21_2 vdd vdd PMIR W=60u L=1u
Mt_uU_L2_21_3 ts_uU_L2_21_3 hv_L1_12 0 0 NMIR W=48.0u L=1u
Mo1_uU_L2_21_3 da_uU_L2_21_3 d1bar_L2 ts_uU_L2_21_3 0 NMIR W=20u L=1u
Mo2_uU_L2_21_3 gp_2_21_3 dpre_L2_21 ts_uU_L2_21_3 0 NMIR W=20u L=1u
Mo3_uU_L2_21_3 da_uU_L2_21_3 da_uU_L2_21_3 vdd vdd PMIR W=60u L=1u
Mo4_uU_L2_21_3 gp_2_21_3 da_uU_L2_21_3 vdd vdd PMIR W=60u L=1u
Mt_uU_L2_21_4 ts_uU_L2_21_4 hv_L1_14 0 0 NMIR W=48.0u L=1u
Mo1_uU_L2_21_4 da_uU_L2_21_4 d1bar_L2 ts_uU_L2_21_4 0 NMIR W=20u L=1u
Mo2_uU_L2_21_4 gp_2_21_4 dpre_L2_21 ts_uU_L2_21_4 0 NMIR W=20u L=1u
Mo3_uU_L2_21_4 da_uU_L2_21_4 da_uU_L2_21_4 vdd vdd PMIR W=60u L=1u
Mo4_uU_L2_21_4 gp_2_21_4 da_uU_L2_21_4 vdd vdd PMIR W=60u L=1u
Mt_uU_L2_21_5 ts_uU_L2_21_5 hv_L1_17 0 0 NMIR W=48.0u L=1u
Mo1_uU_L2_21_5 da_uU_L2_21_5 d1bar_L2 ts_uU_L2_21_5 0 NMIR W=20u L=1u
Mo2_uU_L2_21_5 gp_2_21_5 dpre_L2_21 ts_uU_L2_21_5 0 NMIR W=20u L=1u
Mo3_uU_L2_21_5 da_uU_L2_21_5 da_uU_L2_21_5 vdd vdd PMIR W=60u L=1u
Mo4_uU_L2_21_5 gp_2_21_5 da_uU_L2_21_5 vdd vdd PMIR W=60u L=1u
Mt_uU_L2_21_6 ts_uU_L2_21_6 hv_L1_18 0 0 NMIR W=48.0u L=1u
Mo1_uU_L2_21_6 da_uU_L2_21_6 d1bar_L2 ts_uU_L2_21_6 0 NMIR W=20u L=1u
Mo2_uU_L2_21_6 gp_2_21_6 dpre_L2_21 ts_uU_L2_21_6 0 NMIR W=20u L=1u
Mo3_uU_L2_21_6 da_uU_L2_21_6 da_uU_L2_21_6 vdd vdd PMIR W=60u L=1u
Mo4_uU_L2_21_6 gp_2_21_6 da_uU_L2_21_6 vdd vdd PMIR W=60u L=1u
Mt_uU_L2_21_7 ts_uU_L2_21_7 hv_L1_20 0 0 NMIR W=48.0u L=1u
Mo1_uU_L2_21_7 da_uU_L2_21_7 d1bar_L2 ts_uU_L2_21_7 0 NMIR W=20u L=1u
Mo2_uU_L2_21_7 gp_2_21_7 dpre_L2_21 ts_uU_L2_21_7 0 NMIR W=20u L=1u
Mo3_uU_L2_21_7 da_uU_L2_21_7 da_uU_L2_21_7 vdd vdd PMIR W=60u L=1u
Mo4_uU_L2_21_7 gp_2_21_7 da_uU_L2_21_7 vdd vdd PMIR W=60u L=1u
Mt_uU_L2_21_8 ts_uU_L2_21_8 hv_L1_26 0 0 NMIR W=48.0u L=1u
Mo1_uU_L2_21_8 da_uU_L2_21_8 d1bar_L2 ts_uU_L2_21_8 0 NMIR W=20u L=1u
Mo2_uU_L2_21_8 gp_2_21_8 dpre_L2_21 ts_uU_L2_21_8 0 NMIR W=20u L=1u
Mo3_uU_L2_21_8 da_uU_L2_21_8 da_uU_L2_21_8 vdd vdd PMIR W=60u L=1u
Mo4_uU_L2_21_8 gp_2_21_8 da_uU_L2_21_8 vdd vdd PMIR W=60u L=1u
Mt_uU_L2_21_9 ts_uU_L2_21_9 hv_L1_29 0 0 NMIR W=48.0u L=1u
Mo1_uU_L2_21_9 da_uU_L2_21_9 d1bar_L2 ts_uU_L2_21_9 0 NMIR W=20u L=1u
Mo2_uU_L2_21_9 gp_2_21_9 dpre_L2_21 ts_uU_L2_21_9 0 NMIR W=20u L=1u
Mo3_uU_L2_21_9 da_uU_L2_21_9 da_uU_L2_21_9 vdd vdd PMIR W=60u L=1u
Mo4_uU_L2_21_9 gp_2_21_9 da_uU_L2_21_9 vdd vdd PMIR W=60u L=1u
Mt_uU_L2_21_10 ts_uU_L2_21_10 hv_L1_33 0 0 NMIR W=48.0u L=1u
Mo1_uU_L2_21_10 da_uU_L2_21_10 d1bar_L2 ts_uU_L2_21_10 0 NMIR W=20u L=1u
Mo2_uU_L2_21_10 gp_2_21_10 dpre_L2_21 ts_uU_L2_21_10 0 NMIR W=20u L=1u
Mo3_uU_L2_21_10 da_uU_L2_21_10 da_uU_L2_21_10 vdd vdd PMIR W=60u L=1u
Mo4_uU_L2_21_10 gp_2_21_10 da_uU_L2_21_10 vdd vdd PMIR W=60u L=1u
Mt_uU_L2_21_11 ts_uU_L2_21_11 hv_L1_34 0 0 NMIR W=48.0u L=1u
Mo1_uU_L2_21_11 da_uU_L2_21_11 d1bar_L2 ts_uU_L2_21_11 0 NMIR W=20u L=1u
Mo2_uU_L2_21_11 gp_2_21_11 dpre_L2_21 ts_uU_L2_21_11 0 NMIR W=20u L=1u
Mo3_uU_L2_21_11 da_uU_L2_21_11 da_uU_L2_21_11 vdd vdd PMIR W=60u L=1u
Mo4_uU_L2_21_11 gp_2_21_11 da_uU_L2_21_11 vdd vdd PMIR W=60u L=1u
Mt_uU_L2_21_12 ts_uU_L2_21_12 hv_L1_37 0 0 NMIR W=48.0u L=1u
Mo1_uU_L2_21_12 da_uU_L2_21_12 d1bar_L2 ts_uU_L2_21_12 0 NMIR W=20u L=1u
Mo2_uU_L2_21_12 gp_2_21_12 dpre_L2_21 ts_uU_L2_21_12 0 NMIR W=20u L=1u
Mo3_uU_L2_21_12 da_uU_L2_21_12 da_uU_L2_21_12 vdd vdd PMIR W=60u L=1u
Mo4_uU_L2_21_12 gp_2_21_12 da_uU_L2_21_12 vdd vdd PMIR W=60u L=1u
Mt_uU_L2_21_13 ts_uU_L2_21_13 hv_L1_39 0 0 NMIR W=48.0u L=1u
Mo1_uU_L2_21_13 da_uU_L2_21_13 d1bar_L2 ts_uU_L2_21_13 0 NMIR W=20u L=1u
Mo2_uU_L2_21_13 gp_2_21_13 dpre_L2_21 ts_uU_L2_21_13 0 NMIR W=20u L=1u
Mo3_uU_L2_21_13 da_uU_L2_21_13 da_uU_L2_21_13 vdd vdd PMIR W=60u L=1u
Mo4_uU_L2_21_13 gp_2_21_13 da_uU_L2_21_13 vdd vdd PMIR W=60u L=1u
Mt_uU_L2_21_14 ts_uU_L2_21_14 hv_L1_45 0 0 NMIR W=48.0u L=1u
Mo1_uU_L2_21_14 da_uU_L2_21_14 d1bar_L2 ts_uU_L2_21_14 0 NMIR W=20u L=1u
Mo2_uU_L2_21_14 gp_2_21_14 dpre_L2_21 ts_uU_L2_21_14 0 NMIR W=20u L=1u
Mo3_uU_L2_21_14 da_uU_L2_21_14 da_uU_L2_21_14 vdd vdd PMIR W=60u L=1u
Mo4_uU_L2_21_14 gp_2_21_14 da_uU_L2_21_14 vdd vdd PMIR W=60u L=1u
Mt_uU_L2_21_15 ts_uU_L2_21_15 hv_L1_47 0 0 NMIR W=48.0u L=1u
Mo1_uU_L2_21_15 da_uU_L2_21_15 d1bar_L2 ts_uU_L2_21_15 0 NMIR W=20u L=1u
Mo2_uU_L2_21_15 gp_2_21_15 dpre_L2_21 ts_uU_L2_21_15 0 NMIR W=20u L=1u
Mo3_uU_L2_21_15 da_uU_L2_21_15 da_uU_L2_21_15 vdd vdd PMIR W=60u L=1u
Mo4_uU_L2_21_15 gp_2_21_15 da_uU_L2_21_15 vdd vdd PMIR W=60u L=1u
Mt_uU_L2_22_0 ts_uU_L2_22_0 hv_L1_6 0 0 NMIR W=48.0u L=1u
Mo1_uU_L2_22_0 da_uU_L2_22_0 d1bar_L2 ts_uU_L2_22_0 0 NMIR W=20u L=1u
Mo2_uU_L2_22_0 gp_2_22_0 dpre_L2_22 ts_uU_L2_22_0 0 NMIR W=20u L=1u
Mo3_uU_L2_22_0 da_uU_L2_22_0 da_uU_L2_22_0 vdd vdd PMIR W=60u L=1u
Mo4_uU_L2_22_0 gp_2_22_0 da_uU_L2_22_0 vdd vdd PMIR W=60u L=1u
Mt_uU_L2_22_1 ts_uU_L2_22_1 hv_L1_9 0 0 NMIR W=48.0u L=1u
Mo1_uU_L2_22_1 da_uU_L2_22_1 d1bar_L2 ts_uU_L2_22_1 0 NMIR W=20u L=1u
Mo2_uU_L2_22_1 gp_2_22_1 dpre_L2_22 ts_uU_L2_22_1 0 NMIR W=20u L=1u
Mo3_uU_L2_22_1 da_uU_L2_22_1 da_uU_L2_22_1 vdd vdd PMIR W=60u L=1u
Mo4_uU_L2_22_1 gp_2_22_1 da_uU_L2_22_1 vdd vdd PMIR W=60u L=1u
Mt_uU_L2_22_2 ts_uU_L2_22_2 hv_L1_16 0 0 NMIR W=48.0u L=1u
Mo1_uU_L2_22_2 da_uU_L2_22_2 d1bar_L2 ts_uU_L2_22_2 0 NMIR W=20u L=1u
Mo2_uU_L2_22_2 gp_2_22_2 dpre_L2_22 ts_uU_L2_22_2 0 NMIR W=20u L=1u
Mo3_uU_L2_22_2 da_uU_L2_22_2 da_uU_L2_22_2 vdd vdd PMIR W=60u L=1u
Mo4_uU_L2_22_2 gp_2_22_2 da_uU_L2_22_2 vdd vdd PMIR W=60u L=1u
Mt_uU_L2_22_3 ts_uU_L2_22_3 hv_L1_17 0 0 NMIR W=48.0u L=1u
Mo1_uU_L2_22_3 da_uU_L2_22_3 d1bar_L2 ts_uU_L2_22_3 0 NMIR W=20u L=1u
Mo2_uU_L2_22_3 gp_2_22_3 dpre_L2_22 ts_uU_L2_22_3 0 NMIR W=20u L=1u
Mo3_uU_L2_22_3 da_uU_L2_22_3 da_uU_L2_22_3 vdd vdd PMIR W=60u L=1u
Mo4_uU_L2_22_3 gp_2_22_3 da_uU_L2_22_3 vdd vdd PMIR W=60u L=1u
Mt_uU_L2_22_4 ts_uU_L2_22_4 hv_L1_19 0 0 NMIR W=48.0u L=1u
Mo1_uU_L2_22_4 da_uU_L2_22_4 d1bar_L2 ts_uU_L2_22_4 0 NMIR W=20u L=1u
Mo2_uU_L2_22_4 gp_2_22_4 dpre_L2_22 ts_uU_L2_22_4 0 NMIR W=20u L=1u
Mo3_uU_L2_22_4 da_uU_L2_22_4 da_uU_L2_22_4 vdd vdd PMIR W=60u L=1u
Mo4_uU_L2_22_4 gp_2_22_4 da_uU_L2_22_4 vdd vdd PMIR W=60u L=1u
Mt_uU_L2_22_5 ts_uU_L2_22_5 hv_L1_21 0 0 NMIR W=48.0u L=1u
Mo1_uU_L2_22_5 da_uU_L2_22_5 d1bar_L2 ts_uU_L2_22_5 0 NMIR W=20u L=1u
Mo2_uU_L2_22_5 gp_2_22_5 dpre_L2_22 ts_uU_L2_22_5 0 NMIR W=20u L=1u
Mo3_uU_L2_22_5 da_uU_L2_22_5 da_uU_L2_22_5 vdd vdd PMIR W=60u L=1u
Mo4_uU_L2_22_5 gp_2_22_5 da_uU_L2_22_5 vdd vdd PMIR W=60u L=1u
Mt_uU_L2_22_6 ts_uU_L2_22_6 hv_L1_22 0 0 NMIR W=48.0u L=1u
Mo1_uU_L2_22_6 da_uU_L2_22_6 d1bar_L2 ts_uU_L2_22_6 0 NMIR W=20u L=1u
Mo2_uU_L2_22_6 gp_2_22_6 dpre_L2_22 ts_uU_L2_22_6 0 NMIR W=20u L=1u
Mo3_uU_L2_22_6 da_uU_L2_22_6 da_uU_L2_22_6 vdd vdd PMIR W=60u L=1u
Mo4_uU_L2_22_6 gp_2_22_6 da_uU_L2_22_6 vdd vdd PMIR W=60u L=1u
Mt_uU_L2_22_7 ts_uU_L2_22_7 hv_L1_23 0 0 NMIR W=48.0u L=1u
Mo1_uU_L2_22_7 da_uU_L2_22_7 d1bar_L2 ts_uU_L2_22_7 0 NMIR W=20u L=1u
Mo2_uU_L2_22_7 gp_2_22_7 dpre_L2_22 ts_uU_L2_22_7 0 NMIR W=20u L=1u
Mo3_uU_L2_22_7 da_uU_L2_22_7 da_uU_L2_22_7 vdd vdd PMIR W=60u L=1u
Mo4_uU_L2_22_7 gp_2_22_7 da_uU_L2_22_7 vdd vdd PMIR W=60u L=1u
Mt_uU_L2_22_8 ts_uU_L2_22_8 hv_L1_30 0 0 NMIR W=48.0u L=1u
Mo1_uU_L2_22_8 da_uU_L2_22_8 d1bar_L2 ts_uU_L2_22_8 0 NMIR W=20u L=1u
Mo2_uU_L2_22_8 gp_2_22_8 dpre_L2_22 ts_uU_L2_22_8 0 NMIR W=20u L=1u
Mo3_uU_L2_22_8 da_uU_L2_22_8 da_uU_L2_22_8 vdd vdd PMIR W=60u L=1u
Mo4_uU_L2_22_8 gp_2_22_8 da_uU_L2_22_8 vdd vdd PMIR W=60u L=1u
Mt_uU_L2_22_9 ts_uU_L2_22_9 hv_L1_33 0 0 NMIR W=48.0u L=1u
Mo1_uU_L2_22_9 da_uU_L2_22_9 d1bar_L2 ts_uU_L2_22_9 0 NMIR W=20u L=1u
Mo2_uU_L2_22_9 gp_2_22_9 dpre_L2_22 ts_uU_L2_22_9 0 NMIR W=20u L=1u
Mo3_uU_L2_22_9 da_uU_L2_22_9 da_uU_L2_22_9 vdd vdd PMIR W=60u L=1u
Mo4_uU_L2_22_9 gp_2_22_9 da_uU_L2_22_9 vdd vdd PMIR W=60u L=1u
Mt_uU_L2_22_10 ts_uU_L2_22_10 hv_L1_37 0 0 NMIR W=48.0u L=1u
Mo1_uU_L2_22_10 da_uU_L2_22_10 d1bar_L2 ts_uU_L2_22_10 0 NMIR W=20u L=1u
Mo2_uU_L2_22_10 gp_2_22_10 dpre_L2_22 ts_uU_L2_22_10 0 NMIR W=20u L=1u
Mo3_uU_L2_22_10 da_uU_L2_22_10 da_uU_L2_22_10 vdd vdd PMIR W=60u L=1u
Mo4_uU_L2_22_10 gp_2_22_10 da_uU_L2_22_10 vdd vdd PMIR W=60u L=1u
Mt_uU_L2_22_11 ts_uU_L2_22_11 hv_L1_40 0 0 NMIR W=48.0u L=1u
Mo1_uU_L2_22_11 da_uU_L2_22_11 d1bar_L2 ts_uU_L2_22_11 0 NMIR W=20u L=1u
Mo2_uU_L2_22_11 gp_2_22_11 dpre_L2_22 ts_uU_L2_22_11 0 NMIR W=20u L=1u
Mo3_uU_L2_22_11 da_uU_L2_22_11 da_uU_L2_22_11 vdd vdd PMIR W=60u L=1u
Mo4_uU_L2_22_11 gp_2_22_11 da_uU_L2_22_11 vdd vdd PMIR W=60u L=1u
Mt_uU_L2_22_12 ts_uU_L2_22_12 hv_L1_41 0 0 NMIR W=48.0u L=1u
Mo1_uU_L2_22_12 da_uU_L2_22_12 d1bar_L2 ts_uU_L2_22_12 0 NMIR W=20u L=1u
Mo2_uU_L2_22_12 gp_2_22_12 dpre_L2_22 ts_uU_L2_22_12 0 NMIR W=20u L=1u
Mo3_uU_L2_22_12 da_uU_L2_22_12 da_uU_L2_22_12 vdd vdd PMIR W=60u L=1u
Mo4_uU_L2_22_12 gp_2_22_12 da_uU_L2_22_12 vdd vdd PMIR W=60u L=1u
Mt_uU_L2_22_13 ts_uU_L2_22_13 hv_L1_43 0 0 NMIR W=48.0u L=1u
Mo1_uU_L2_22_13 da_uU_L2_22_13 d1bar_L2 ts_uU_L2_22_13 0 NMIR W=20u L=1u
Mo2_uU_L2_22_13 gp_2_22_13 dpre_L2_22 ts_uU_L2_22_13 0 NMIR W=20u L=1u
Mo3_uU_L2_22_13 da_uU_L2_22_13 da_uU_L2_22_13 vdd vdd PMIR W=60u L=1u
Mo4_uU_L2_22_13 gp_2_22_13 da_uU_L2_22_13 vdd vdd PMIR W=60u L=1u
Mt_uU_L2_22_14 ts_uU_L2_22_14 hv_L1_45 0 0 NMIR W=48.0u L=1u
Mo1_uU_L2_22_14 da_uU_L2_22_14 d1bar_L2 ts_uU_L2_22_14 0 NMIR W=20u L=1u
Mo2_uU_L2_22_14 gp_2_22_14 dpre_L2_22 ts_uU_L2_22_14 0 NMIR W=20u L=1u
Mo3_uU_L2_22_14 da_uU_L2_22_14 da_uU_L2_22_14 vdd vdd PMIR W=60u L=1u
Mo4_uU_L2_22_14 gp_2_22_14 da_uU_L2_22_14 vdd vdd PMIR W=60u L=1u
Mt_uU_L2_22_15 ts_uU_L2_22_15 hv_L1_46 0 0 NMIR W=48.0u L=1u
Mo1_uU_L2_22_15 da_uU_L2_22_15 d1bar_L2 ts_uU_L2_22_15 0 NMIR W=20u L=1u
Mo2_uU_L2_22_15 gp_2_22_15 dpre_L2_22 ts_uU_L2_22_15 0 NMIR W=20u L=1u
Mo3_uU_L2_22_15 da_uU_L2_22_15 da_uU_L2_22_15 vdd vdd PMIR W=60u L=1u
Mo4_uU_L2_22_15 gp_2_22_15 da_uU_L2_22_15 vdd vdd PMIR W=60u L=1u
Mt_uU_L2_23_0 ts_uU_L2_23_0 hv_L1_0 0 0 NMIR W=48.0u L=1u
Mo1_uU_L2_23_0 da_uU_L2_23_0 d1bar_L2 ts_uU_L2_23_0 0 NMIR W=20u L=1u
Mo2_uU_L2_23_0 gp_2_23_0 dpre_L2_23 ts_uU_L2_23_0 0 NMIR W=20u L=1u
Mo3_uU_L2_23_0 da_uU_L2_23_0 da_uU_L2_23_0 vdd vdd PMIR W=60u L=1u
Mo4_uU_L2_23_0 gp_2_23_0 da_uU_L2_23_0 vdd vdd PMIR W=60u L=1u
Mt_uU_L2_23_1 ts_uU_L2_23_1 hv_L1_1 0 0 NMIR W=48.0u L=1u
Mo1_uU_L2_23_1 da_uU_L2_23_1 d1bar_L2 ts_uU_L2_23_1 0 NMIR W=20u L=1u
Mo2_uU_L2_23_1 gp_2_23_1 dpre_L2_23 ts_uU_L2_23_1 0 NMIR W=20u L=1u
Mo3_uU_L2_23_1 da_uU_L2_23_1 da_uU_L2_23_1 vdd vdd PMIR W=60u L=1u
Mo4_uU_L2_23_1 gp_2_23_1 da_uU_L2_23_1 vdd vdd PMIR W=60u L=1u
Mt_uU_L2_23_2 ts_uU_L2_23_2 hv_L1_2 0 0 NMIR W=48.0u L=1u
Mo1_uU_L2_23_2 da_uU_L2_23_2 d1bar_L2 ts_uU_L2_23_2 0 NMIR W=20u L=1u
Mo2_uU_L2_23_2 gp_2_23_2 dpre_L2_23 ts_uU_L2_23_2 0 NMIR W=20u L=1u
Mo3_uU_L2_23_2 da_uU_L2_23_2 da_uU_L2_23_2 vdd vdd PMIR W=60u L=1u
Mo4_uU_L2_23_2 gp_2_23_2 da_uU_L2_23_2 vdd vdd PMIR W=60u L=1u
Mt_uU_L2_23_3 ts_uU_L2_23_3 hv_L1_3 0 0 NMIR W=48.0u L=1u
Mo1_uU_L2_23_3 da_uU_L2_23_3 d1bar_L2 ts_uU_L2_23_3 0 NMIR W=20u L=1u
Mo2_uU_L2_23_3 gp_2_23_3 dpre_L2_23 ts_uU_L2_23_3 0 NMIR W=20u L=1u
Mo3_uU_L2_23_3 da_uU_L2_23_3 da_uU_L2_23_3 vdd vdd PMIR W=60u L=1u
Mo4_uU_L2_23_3 gp_2_23_3 da_uU_L2_23_3 vdd vdd PMIR W=60u L=1u
Mt_uU_L2_23_4 ts_uU_L2_23_4 hv_L1_12 0 0 NMIR W=48.0u L=1u
Mo1_uU_L2_23_4 da_uU_L2_23_4 d1bar_L2 ts_uU_L2_23_4 0 NMIR W=20u L=1u
Mo2_uU_L2_23_4 gp_2_23_4 dpre_L2_23 ts_uU_L2_23_4 0 NMIR W=20u L=1u
Mo3_uU_L2_23_4 da_uU_L2_23_4 da_uU_L2_23_4 vdd vdd PMIR W=60u L=1u
Mo4_uU_L2_23_4 gp_2_23_4 da_uU_L2_23_4 vdd vdd PMIR W=60u L=1u
Mt_uU_L2_23_5 ts_uU_L2_23_5 hv_L1_15 0 0 NMIR W=48.0u L=1u
Mo1_uU_L2_23_5 da_uU_L2_23_5 d1bar_L2 ts_uU_L2_23_5 0 NMIR W=20u L=1u
Mo2_uU_L2_23_5 gp_2_23_5 dpre_L2_23 ts_uU_L2_23_5 0 NMIR W=20u L=1u
Mo3_uU_L2_23_5 da_uU_L2_23_5 da_uU_L2_23_5 vdd vdd PMIR W=60u L=1u
Mo4_uU_L2_23_5 gp_2_23_5 da_uU_L2_23_5 vdd vdd PMIR W=60u L=1u
Mt_uU_L2_23_6 ts_uU_L2_23_6 hv_L1_16 0 0 NMIR W=48.0u L=1u
Mo1_uU_L2_23_6 da_uU_L2_23_6 d1bar_L2 ts_uU_L2_23_6 0 NMIR W=20u L=1u
Mo2_uU_L2_23_6 gp_2_23_6 dpre_L2_23 ts_uU_L2_23_6 0 NMIR W=20u L=1u
Mo3_uU_L2_23_6 da_uU_L2_23_6 da_uU_L2_23_6 vdd vdd PMIR W=60u L=1u
Mo4_uU_L2_23_6 gp_2_23_6 da_uU_L2_23_6 vdd vdd PMIR W=60u L=1u
Mt_uU_L2_23_7 ts_uU_L2_23_7 hv_L1_18 0 0 NMIR W=48.0u L=1u
Mo1_uU_L2_23_7 da_uU_L2_23_7 d1bar_L2 ts_uU_L2_23_7 0 NMIR W=20u L=1u
Mo2_uU_L2_23_7 gp_2_23_7 dpre_L2_23 ts_uU_L2_23_7 0 NMIR W=20u L=1u
Mo3_uU_L2_23_7 da_uU_L2_23_7 da_uU_L2_23_7 vdd vdd PMIR W=60u L=1u
Mo4_uU_L2_23_7 gp_2_23_7 da_uU_L2_23_7 vdd vdd PMIR W=60u L=1u
Mt_uU_L2_23_8 ts_uU_L2_23_8 hv_L1_26 0 0 NMIR W=48.0u L=1u
Mo1_uU_L2_23_8 da_uU_L2_23_8 d1bar_L2 ts_uU_L2_23_8 0 NMIR W=20u L=1u
Mo2_uU_L2_23_8 gp_2_23_8 dpre_L2_23 ts_uU_L2_23_8 0 NMIR W=20u L=1u
Mo3_uU_L2_23_8 da_uU_L2_23_8 da_uU_L2_23_8 vdd vdd PMIR W=60u L=1u
Mo4_uU_L2_23_8 gp_2_23_8 da_uU_L2_23_8 vdd vdd PMIR W=60u L=1u
Mt_uU_L2_23_9 ts_uU_L2_23_9 hv_L1_33 0 0 NMIR W=48.0u L=1u
Mo1_uU_L2_23_9 da_uU_L2_23_9 d1bar_L2 ts_uU_L2_23_9 0 NMIR W=20u L=1u
Mo2_uU_L2_23_9 gp_2_23_9 dpre_L2_23 ts_uU_L2_23_9 0 NMIR W=20u L=1u
Mo3_uU_L2_23_9 da_uU_L2_23_9 da_uU_L2_23_9 vdd vdd PMIR W=60u L=1u
Mo4_uU_L2_23_9 gp_2_23_9 da_uU_L2_23_9 vdd vdd PMIR W=60u L=1u
Mt_uU_L2_23_10 ts_uU_L2_23_10 hv_L1_35 0 0 NMIR W=48.0u L=1u
Mo1_uU_L2_23_10 da_uU_L2_23_10 d1bar_L2 ts_uU_L2_23_10 0 NMIR W=20u L=1u
Mo2_uU_L2_23_10 gp_2_23_10 dpre_L2_23 ts_uU_L2_23_10 0 NMIR W=20u L=1u
Mo3_uU_L2_23_10 da_uU_L2_23_10 da_uU_L2_23_10 vdd vdd PMIR W=60u L=1u
Mo4_uU_L2_23_10 gp_2_23_10 da_uU_L2_23_10 vdd vdd PMIR W=60u L=1u
Mt_uU_L2_23_11 ts_uU_L2_23_11 hv_L1_39 0 0 NMIR W=48.0u L=1u
Mo1_uU_L2_23_11 da_uU_L2_23_11 d1bar_L2 ts_uU_L2_23_11 0 NMIR W=20u L=1u
Mo2_uU_L2_23_11 gp_2_23_11 dpre_L2_23 ts_uU_L2_23_11 0 NMIR W=20u L=1u
Mo3_uU_L2_23_11 da_uU_L2_23_11 da_uU_L2_23_11 vdd vdd PMIR W=60u L=1u
Mo4_uU_L2_23_11 gp_2_23_11 da_uU_L2_23_11 vdd vdd PMIR W=60u L=1u
Mt_uU_L2_23_12 ts_uU_L2_23_12 hv_L1_41 0 0 NMIR W=48.0u L=1u
Mo1_uU_L2_23_12 da_uU_L2_23_12 d1bar_L2 ts_uU_L2_23_12 0 NMIR W=20u L=1u
Mo2_uU_L2_23_12 gp_2_23_12 dpre_L2_23 ts_uU_L2_23_12 0 NMIR W=20u L=1u
Mo3_uU_L2_23_12 da_uU_L2_23_12 da_uU_L2_23_12 vdd vdd PMIR W=60u L=1u
Mo4_uU_L2_23_12 gp_2_23_12 da_uU_L2_23_12 vdd vdd PMIR W=60u L=1u
Mt_uU_L2_23_13 ts_uU_L2_23_13 hv_L1_42 0 0 NMIR W=48.0u L=1u
Mo1_uU_L2_23_13 da_uU_L2_23_13 d1bar_L2 ts_uU_L2_23_13 0 NMIR W=20u L=1u
Mo2_uU_L2_23_13 gp_2_23_13 dpre_L2_23 ts_uU_L2_23_13 0 NMIR W=20u L=1u
Mo3_uU_L2_23_13 da_uU_L2_23_13 da_uU_L2_23_13 vdd vdd PMIR W=60u L=1u
Mo4_uU_L2_23_13 gp_2_23_13 da_uU_L2_23_13 vdd vdd PMIR W=60u L=1u
Mt_uU_L2_23_14 ts_uU_L2_23_14 hv_L1_45 0 0 NMIR W=48.0u L=1u
Mo1_uU_L2_23_14 da_uU_L2_23_14 d1bar_L2 ts_uU_L2_23_14 0 NMIR W=20u L=1u
Mo2_uU_L2_23_14 gp_2_23_14 dpre_L2_23 ts_uU_L2_23_14 0 NMIR W=20u L=1u
Mo3_uU_L2_23_14 da_uU_L2_23_14 da_uU_L2_23_14 vdd vdd PMIR W=60u L=1u
Mo4_uU_L2_23_14 gp_2_23_14 da_uU_L2_23_14 vdd vdd PMIR W=60u L=1u
Mt_uU_L2_23_15 ts_uU_L2_23_15 hv_L1_46 0 0 NMIR W=48.0u L=1u
Mo1_uU_L2_23_15 da_uU_L2_23_15 d1bar_L2 ts_uU_L2_23_15 0 NMIR W=20u L=1u
Mo2_uU_L2_23_15 gp_2_23_15 dpre_L2_23 ts_uU_L2_23_15 0 NMIR W=20u L=1u
Mo3_uU_L2_23_15 da_uU_L2_23_15 da_uU_L2_23_15 vdd vdd PMIR W=60u L=1u
Mo4_uU_L2_23_15 gp_2_23_15 da_uU_L2_23_15 vdd vdd PMIR W=60u L=1u
Mt_uU_L2_24_0 ts_uU_L2_24_0 hv_L1_0 0 0 NMIR W=48.0u L=1u
Mo1_uU_L2_24_0 da_uU_L2_24_0 d1bar_L2 ts_uU_L2_24_0 0 NMIR W=20u L=1u
Mo2_uU_L2_24_0 gp_2_24_0 dpre_L2_24 ts_uU_L2_24_0 0 NMIR W=20u L=1u
Mo3_uU_L2_24_0 da_uU_L2_24_0 da_uU_L2_24_0 vdd vdd PMIR W=60u L=1u
Mo4_uU_L2_24_0 gp_2_24_0 da_uU_L2_24_0 vdd vdd PMIR W=60u L=1u
Mt_uU_L2_24_1 ts_uU_L2_24_1 hv_L1_1 0 0 NMIR W=48.0u L=1u
Mo1_uU_L2_24_1 da_uU_L2_24_1 d1bar_L2 ts_uU_L2_24_1 0 NMIR W=20u L=1u
Mo2_uU_L2_24_1 gp_2_24_1 dpre_L2_24 ts_uU_L2_24_1 0 NMIR W=20u L=1u
Mo3_uU_L2_24_1 da_uU_L2_24_1 da_uU_L2_24_1 vdd vdd PMIR W=60u L=1u
Mo4_uU_L2_24_1 gp_2_24_1 da_uU_L2_24_1 vdd vdd PMIR W=60u L=1u
Mt_uU_L2_24_2 ts_uU_L2_24_2 hv_L1_2 0 0 NMIR W=48.0u L=1u
Mo1_uU_L2_24_2 da_uU_L2_24_2 d1bar_L2 ts_uU_L2_24_2 0 NMIR W=20u L=1u
Mo2_uU_L2_24_2 gp_2_24_2 dpre_L2_24 ts_uU_L2_24_2 0 NMIR W=20u L=1u
Mo3_uU_L2_24_2 da_uU_L2_24_2 da_uU_L2_24_2 vdd vdd PMIR W=60u L=1u
Mo4_uU_L2_24_2 gp_2_24_2 da_uU_L2_24_2 vdd vdd PMIR W=60u L=1u
Mt_uU_L2_24_3 ts_uU_L2_24_3 hv_L1_5 0 0 NMIR W=48.0u L=1u
Mo1_uU_L2_24_3 da_uU_L2_24_3 d1bar_L2 ts_uU_L2_24_3 0 NMIR W=20u L=1u
Mo2_uU_L2_24_3 gp_2_24_3 dpre_L2_24 ts_uU_L2_24_3 0 NMIR W=20u L=1u
Mo3_uU_L2_24_3 da_uU_L2_24_3 da_uU_L2_24_3 vdd vdd PMIR W=60u L=1u
Mo4_uU_L2_24_3 gp_2_24_3 da_uU_L2_24_3 vdd vdd PMIR W=60u L=1u
Mt_uU_L2_24_4 ts_uU_L2_24_4 hv_L1_11 0 0 NMIR W=48.0u L=1u
Mo1_uU_L2_24_4 da_uU_L2_24_4 d1bar_L2 ts_uU_L2_24_4 0 NMIR W=20u L=1u
Mo2_uU_L2_24_4 gp_2_24_4 dpre_L2_24 ts_uU_L2_24_4 0 NMIR W=20u L=1u
Mo3_uU_L2_24_4 da_uU_L2_24_4 da_uU_L2_24_4 vdd vdd PMIR W=60u L=1u
Mo4_uU_L2_24_4 gp_2_24_4 da_uU_L2_24_4 vdd vdd PMIR W=60u L=1u
Mt_uU_L2_24_5 ts_uU_L2_24_5 hv_L1_12 0 0 NMIR W=48.0u L=1u
Mo1_uU_L2_24_5 da_uU_L2_24_5 d1bar_L2 ts_uU_L2_24_5 0 NMIR W=20u L=1u
Mo2_uU_L2_24_5 gp_2_24_5 dpre_L2_24 ts_uU_L2_24_5 0 NMIR W=20u L=1u
Mo3_uU_L2_24_5 da_uU_L2_24_5 da_uU_L2_24_5 vdd vdd PMIR W=60u L=1u
Mo4_uU_L2_24_5 gp_2_24_5 da_uU_L2_24_5 vdd vdd PMIR W=60u L=1u
Mt_uU_L2_24_6 ts_uU_L2_24_6 hv_L1_19 0 0 NMIR W=48.0u L=1u
Mo1_uU_L2_24_6 da_uU_L2_24_6 d1bar_L2 ts_uU_L2_24_6 0 NMIR W=20u L=1u
Mo2_uU_L2_24_6 gp_2_24_6 dpre_L2_24 ts_uU_L2_24_6 0 NMIR W=20u L=1u
Mo3_uU_L2_24_6 da_uU_L2_24_6 da_uU_L2_24_6 vdd vdd PMIR W=60u L=1u
Mo4_uU_L2_24_6 gp_2_24_6 da_uU_L2_24_6 vdd vdd PMIR W=60u L=1u
Mt_uU_L2_24_7 ts_uU_L2_24_7 hv_L1_26 0 0 NMIR W=48.0u L=1u
Mo1_uU_L2_24_7 da_uU_L2_24_7 d1bar_L2 ts_uU_L2_24_7 0 NMIR W=20u L=1u
Mo2_uU_L2_24_7 gp_2_24_7 dpre_L2_24 ts_uU_L2_24_7 0 NMIR W=20u L=1u
Mo3_uU_L2_24_7 da_uU_L2_24_7 da_uU_L2_24_7 vdd vdd PMIR W=60u L=1u
Mo4_uU_L2_24_7 gp_2_24_7 da_uU_L2_24_7 vdd vdd PMIR W=60u L=1u
Mt_uU_L2_24_8 ts_uU_L2_24_8 hv_L1_28 0 0 NMIR W=48.0u L=1u
Mo1_uU_L2_24_8 da_uU_L2_24_8 d1bar_L2 ts_uU_L2_24_8 0 NMIR W=20u L=1u
Mo2_uU_L2_24_8 gp_2_24_8 dpre_L2_24 ts_uU_L2_24_8 0 NMIR W=20u L=1u
Mo3_uU_L2_24_8 da_uU_L2_24_8 da_uU_L2_24_8 vdd vdd PMIR W=60u L=1u
Mo4_uU_L2_24_8 gp_2_24_8 da_uU_L2_24_8 vdd vdd PMIR W=60u L=1u
Mt_uU_L2_24_9 ts_uU_L2_24_9 hv_L1_29 0 0 NMIR W=48.0u L=1u
Mo1_uU_L2_24_9 da_uU_L2_24_9 d1bar_L2 ts_uU_L2_24_9 0 NMIR W=20u L=1u
Mo2_uU_L2_24_9 gp_2_24_9 dpre_L2_24 ts_uU_L2_24_9 0 NMIR W=20u L=1u
Mo3_uU_L2_24_9 da_uU_L2_24_9 da_uU_L2_24_9 vdd vdd PMIR W=60u L=1u
Mo4_uU_L2_24_9 gp_2_24_9 da_uU_L2_24_9 vdd vdd PMIR W=60u L=1u
Mt_uU_L2_24_10 ts_uU_L2_24_10 hv_L1_31 0 0 NMIR W=48.0u L=1u
Mo1_uU_L2_24_10 da_uU_L2_24_10 d1bar_L2 ts_uU_L2_24_10 0 NMIR W=20u L=1u
Mo2_uU_L2_24_10 gp_2_24_10 dpre_L2_24 ts_uU_L2_24_10 0 NMIR W=20u L=1u
Mo3_uU_L2_24_10 da_uU_L2_24_10 da_uU_L2_24_10 vdd vdd PMIR W=60u L=1u
Mo4_uU_L2_24_10 gp_2_24_10 da_uU_L2_24_10 vdd vdd PMIR W=60u L=1u
Mt_uU_L2_24_11 ts_uU_L2_24_11 hv_L1_32 0 0 NMIR W=48.0u L=1u
Mo1_uU_L2_24_11 da_uU_L2_24_11 d1bar_L2 ts_uU_L2_24_11 0 NMIR W=20u L=1u
Mo2_uU_L2_24_11 gp_2_24_11 dpre_L2_24 ts_uU_L2_24_11 0 NMIR W=20u L=1u
Mo3_uU_L2_24_11 da_uU_L2_24_11 da_uU_L2_24_11 vdd vdd PMIR W=60u L=1u
Mo4_uU_L2_24_11 gp_2_24_11 da_uU_L2_24_11 vdd vdd PMIR W=60u L=1u
Mt_uU_L2_24_12 ts_uU_L2_24_12 hv_L1_34 0 0 NMIR W=48.0u L=1u
Mo1_uU_L2_24_12 da_uU_L2_24_12 d1bar_L2 ts_uU_L2_24_12 0 NMIR W=20u L=1u
Mo2_uU_L2_24_12 gp_2_24_12 dpre_L2_24 ts_uU_L2_24_12 0 NMIR W=20u L=1u
Mo3_uU_L2_24_12 da_uU_L2_24_12 da_uU_L2_24_12 vdd vdd PMIR W=60u L=1u
Mo4_uU_L2_24_12 gp_2_24_12 da_uU_L2_24_12 vdd vdd PMIR W=60u L=1u
Mt_uU_L2_24_13 ts_uU_L2_24_13 hv_L1_38 0 0 NMIR W=48.0u L=1u
Mo1_uU_L2_24_13 da_uU_L2_24_13 d1bar_L2 ts_uU_L2_24_13 0 NMIR W=20u L=1u
Mo2_uU_L2_24_13 gp_2_24_13 dpre_L2_24 ts_uU_L2_24_13 0 NMIR W=20u L=1u
Mo3_uU_L2_24_13 da_uU_L2_24_13 da_uU_L2_24_13 vdd vdd PMIR W=60u L=1u
Mo4_uU_L2_24_13 gp_2_24_13 da_uU_L2_24_13 vdd vdd PMIR W=60u L=1u
Mt_uU_L2_24_14 ts_uU_L2_24_14 hv_L1_40 0 0 NMIR W=48.0u L=1u
Mo1_uU_L2_24_14 da_uU_L2_24_14 d1bar_L2 ts_uU_L2_24_14 0 NMIR W=20u L=1u
Mo2_uU_L2_24_14 gp_2_24_14 dpre_L2_24 ts_uU_L2_24_14 0 NMIR W=20u L=1u
Mo3_uU_L2_24_14 da_uU_L2_24_14 da_uU_L2_24_14 vdd vdd PMIR W=60u L=1u
Mo4_uU_L2_24_14 gp_2_24_14 da_uU_L2_24_14 vdd vdd PMIR W=60u L=1u
Mt_uU_L2_24_15 ts_uU_L2_24_15 hv_L1_45 0 0 NMIR W=48.0u L=1u
Mo1_uU_L2_24_15 da_uU_L2_24_15 d1bar_L2 ts_uU_L2_24_15 0 NMIR W=20u L=1u
Mo2_uU_L2_24_15 gp_2_24_15 dpre_L2_24 ts_uU_L2_24_15 0 NMIR W=20u L=1u
Mo3_uU_L2_24_15 da_uU_L2_24_15 da_uU_L2_24_15 vdd vdd PMIR W=60u L=1u
Mo4_uU_L2_24_15 gp_2_24_15 da_uU_L2_24_15 vdd vdd PMIR W=60u L=1u
Mt_uU_L2_25_0 ts_uU_L2_25_0 hv_L1_0 0 0 NMIR W=48.0u L=1u
Mo1_uU_L2_25_0 da_uU_L2_25_0 d1bar_L2 ts_uU_L2_25_0 0 NMIR W=20u L=1u
Mo2_uU_L2_25_0 gp_2_25_0 dpre_L2_25 ts_uU_L2_25_0 0 NMIR W=20u L=1u
Mo3_uU_L2_25_0 da_uU_L2_25_0 da_uU_L2_25_0 vdd vdd PMIR W=60u L=1u
Mo4_uU_L2_25_0 gp_2_25_0 da_uU_L2_25_0 vdd vdd PMIR W=60u L=1u
Mt_uU_L2_25_1 ts_uU_L2_25_1 hv_L1_1 0 0 NMIR W=48.0u L=1u
Mo1_uU_L2_25_1 da_uU_L2_25_1 d1bar_L2 ts_uU_L2_25_1 0 NMIR W=20u L=1u
Mo2_uU_L2_25_1 gp_2_25_1 dpre_L2_25 ts_uU_L2_25_1 0 NMIR W=20u L=1u
Mo3_uU_L2_25_1 da_uU_L2_25_1 da_uU_L2_25_1 vdd vdd PMIR W=60u L=1u
Mo4_uU_L2_25_1 gp_2_25_1 da_uU_L2_25_1 vdd vdd PMIR W=60u L=1u
Mt_uU_L2_25_2 ts_uU_L2_25_2 hv_L1_2 0 0 NMIR W=48.0u L=1u
Mo1_uU_L2_25_2 da_uU_L2_25_2 d1bar_L2 ts_uU_L2_25_2 0 NMIR W=20u L=1u
Mo2_uU_L2_25_2 gp_2_25_2 dpre_L2_25 ts_uU_L2_25_2 0 NMIR W=20u L=1u
Mo3_uU_L2_25_2 da_uU_L2_25_2 da_uU_L2_25_2 vdd vdd PMIR W=60u L=1u
Mo4_uU_L2_25_2 gp_2_25_2 da_uU_L2_25_2 vdd vdd PMIR W=60u L=1u
Mt_uU_L2_25_3 ts_uU_L2_25_3 hv_L1_4 0 0 NMIR W=48.0u L=1u
Mo1_uU_L2_25_3 da_uU_L2_25_3 d1bar_L2 ts_uU_L2_25_3 0 NMIR W=20u L=1u
Mo2_uU_L2_25_3 gp_2_25_3 dpre_L2_25 ts_uU_L2_25_3 0 NMIR W=20u L=1u
Mo3_uU_L2_25_3 da_uU_L2_25_3 da_uU_L2_25_3 vdd vdd PMIR W=60u L=1u
Mo4_uU_L2_25_3 gp_2_25_3 da_uU_L2_25_3 vdd vdd PMIR W=60u L=1u
Mt_uU_L2_25_4 ts_uU_L2_25_4 hv_L1_7 0 0 NMIR W=48.0u L=1u
Mo1_uU_L2_25_4 da_uU_L2_25_4 d1bar_L2 ts_uU_L2_25_4 0 NMIR W=20u L=1u
Mo2_uU_L2_25_4 gp_2_25_4 dpre_L2_25 ts_uU_L2_25_4 0 NMIR W=20u L=1u
Mo3_uU_L2_25_4 da_uU_L2_25_4 da_uU_L2_25_4 vdd vdd PMIR W=60u L=1u
Mo4_uU_L2_25_4 gp_2_25_4 da_uU_L2_25_4 vdd vdd PMIR W=60u L=1u
Mt_uU_L2_25_5 ts_uU_L2_25_5 hv_L1_12 0 0 NMIR W=48.0u L=1u
Mo1_uU_L2_25_5 da_uU_L2_25_5 d1bar_L2 ts_uU_L2_25_5 0 NMIR W=20u L=1u
Mo2_uU_L2_25_5 gp_2_25_5 dpre_L2_25 ts_uU_L2_25_5 0 NMIR W=20u L=1u
Mo3_uU_L2_25_5 da_uU_L2_25_5 da_uU_L2_25_5 vdd vdd PMIR W=60u L=1u
Mo4_uU_L2_25_5 gp_2_25_5 da_uU_L2_25_5 vdd vdd PMIR W=60u L=1u
Mt_uU_L2_25_6 ts_uU_L2_25_6 hv_L1_16 0 0 NMIR W=48.0u L=1u
Mo1_uU_L2_25_6 da_uU_L2_25_6 d1bar_L2 ts_uU_L2_25_6 0 NMIR W=20u L=1u
Mo2_uU_L2_25_6 gp_2_25_6 dpre_L2_25 ts_uU_L2_25_6 0 NMIR W=20u L=1u
Mo3_uU_L2_25_6 da_uU_L2_25_6 da_uU_L2_25_6 vdd vdd PMIR W=60u L=1u
Mo4_uU_L2_25_6 gp_2_25_6 da_uU_L2_25_6 vdd vdd PMIR W=60u L=1u
Mt_uU_L2_25_7 ts_uU_L2_25_7 hv_L1_23 0 0 NMIR W=48.0u L=1u
Mo1_uU_L2_25_7 da_uU_L2_25_7 d1bar_L2 ts_uU_L2_25_7 0 NMIR W=20u L=1u
Mo2_uU_L2_25_7 gp_2_25_7 dpre_L2_25 ts_uU_L2_25_7 0 NMIR W=20u L=1u
Mo3_uU_L2_25_7 da_uU_L2_25_7 da_uU_L2_25_7 vdd vdd PMIR W=60u L=1u
Mo4_uU_L2_25_7 gp_2_25_7 da_uU_L2_25_7 vdd vdd PMIR W=60u L=1u
Mt_uU_L2_25_8 ts_uU_L2_25_8 hv_L1_25 0 0 NMIR W=48.0u L=1u
Mo1_uU_L2_25_8 da_uU_L2_25_8 d1bar_L2 ts_uU_L2_25_8 0 NMIR W=20u L=1u
Mo2_uU_L2_25_8 gp_2_25_8 dpre_L2_25 ts_uU_L2_25_8 0 NMIR W=20u L=1u
Mo3_uU_L2_25_8 da_uU_L2_25_8 da_uU_L2_25_8 vdd vdd PMIR W=60u L=1u
Mo4_uU_L2_25_8 gp_2_25_8 da_uU_L2_25_8 vdd vdd PMIR W=60u L=1u
Mt_uU_L2_25_9 ts_uU_L2_25_9 hv_L1_28 0 0 NMIR W=48.0u L=1u
Mo1_uU_L2_25_9 da_uU_L2_25_9 d1bar_L2 ts_uU_L2_25_9 0 NMIR W=20u L=1u
Mo2_uU_L2_25_9 gp_2_25_9 dpre_L2_25 ts_uU_L2_25_9 0 NMIR W=20u L=1u
Mo3_uU_L2_25_9 da_uU_L2_25_9 da_uU_L2_25_9 vdd vdd PMIR W=60u L=1u
Mo4_uU_L2_25_9 gp_2_25_9 da_uU_L2_25_9 vdd vdd PMIR W=60u L=1u
Mt_uU_L2_25_10 ts_uU_L2_25_10 hv_L1_30 0 0 NMIR W=48.0u L=1u
Mo1_uU_L2_25_10 da_uU_L2_25_10 d1bar_L2 ts_uU_L2_25_10 0 NMIR W=20u L=1u
Mo2_uU_L2_25_10 gp_2_25_10 dpre_L2_25 ts_uU_L2_25_10 0 NMIR W=20u L=1u
Mo3_uU_L2_25_10 da_uU_L2_25_10 da_uU_L2_25_10 vdd vdd PMIR W=60u L=1u
Mo4_uU_L2_25_10 gp_2_25_10 da_uU_L2_25_10 vdd vdd PMIR W=60u L=1u
Mt_uU_L2_25_11 ts_uU_L2_25_11 hv_L1_31 0 0 NMIR W=48.0u L=1u
Mo1_uU_L2_25_11 da_uU_L2_25_11 d1bar_L2 ts_uU_L2_25_11 0 NMIR W=20u L=1u
Mo2_uU_L2_25_11 gp_2_25_11 dpre_L2_25 ts_uU_L2_25_11 0 NMIR W=20u L=1u
Mo3_uU_L2_25_11 da_uU_L2_25_11 da_uU_L2_25_11 vdd vdd PMIR W=60u L=1u
Mo4_uU_L2_25_11 gp_2_25_11 da_uU_L2_25_11 vdd vdd PMIR W=60u L=1u
Mt_uU_L2_25_12 ts_uU_L2_25_12 hv_L1_32 0 0 NMIR W=48.0u L=1u
Mo1_uU_L2_25_12 da_uU_L2_25_12 d1bar_L2 ts_uU_L2_25_12 0 NMIR W=20u L=1u
Mo2_uU_L2_25_12 gp_2_25_12 dpre_L2_25 ts_uU_L2_25_12 0 NMIR W=20u L=1u
Mo3_uU_L2_25_12 da_uU_L2_25_12 da_uU_L2_25_12 vdd vdd PMIR W=60u L=1u
Mo4_uU_L2_25_12 gp_2_25_12 da_uU_L2_25_12 vdd vdd PMIR W=60u L=1u
Mt_uU_L2_25_13 ts_uU_L2_25_13 hv_L1_33 0 0 NMIR W=48.0u L=1u
Mo1_uU_L2_25_13 da_uU_L2_25_13 d1bar_L2 ts_uU_L2_25_13 0 NMIR W=20u L=1u
Mo2_uU_L2_25_13 gp_2_25_13 dpre_L2_25 ts_uU_L2_25_13 0 NMIR W=20u L=1u
Mo3_uU_L2_25_13 da_uU_L2_25_13 da_uU_L2_25_13 vdd vdd PMIR W=60u L=1u
Mo4_uU_L2_25_13 gp_2_25_13 da_uU_L2_25_13 vdd vdd PMIR W=60u L=1u
Mt_uU_L2_25_14 ts_uU_L2_25_14 hv_L1_36 0 0 NMIR W=48.0u L=1u
Mo1_uU_L2_25_14 da_uU_L2_25_14 d1bar_L2 ts_uU_L2_25_14 0 NMIR W=20u L=1u
Mo2_uU_L2_25_14 gp_2_25_14 dpre_L2_25 ts_uU_L2_25_14 0 NMIR W=20u L=1u
Mo3_uU_L2_25_14 da_uU_L2_25_14 da_uU_L2_25_14 vdd vdd PMIR W=60u L=1u
Mo4_uU_L2_25_14 gp_2_25_14 da_uU_L2_25_14 vdd vdd PMIR W=60u L=1u
Mt_uU_L2_25_15 ts_uU_L2_25_15 hv_L1_42 0 0 NMIR W=48.0u L=1u
Mo1_uU_L2_25_15 da_uU_L2_25_15 d1bar_L2 ts_uU_L2_25_15 0 NMIR W=20u L=1u
Mo2_uU_L2_25_15 gp_2_25_15 dpre_L2_25 ts_uU_L2_25_15 0 NMIR W=20u L=1u
Mo3_uU_L2_25_15 da_uU_L2_25_15 da_uU_L2_25_15 vdd vdd PMIR W=60u L=1u
Mo4_uU_L2_25_15 gp_2_25_15 da_uU_L2_25_15 vdd vdd PMIR W=60u L=1u
Mt_uU_L2_26_0 ts_uU_L2_26_0 hv_L1_0 0 0 NMIR W=48.0u L=1u
Mo1_uU_L2_26_0 da_uU_L2_26_0 d1bar_L2 ts_uU_L2_26_0 0 NMIR W=20u L=1u
Mo2_uU_L2_26_0 gp_2_26_0 dpre_L2_26 ts_uU_L2_26_0 0 NMIR W=20u L=1u
Mo3_uU_L2_26_0 da_uU_L2_26_0 da_uU_L2_26_0 vdd vdd PMIR W=60u L=1u
Mo4_uU_L2_26_0 gp_2_26_0 da_uU_L2_26_0 vdd vdd PMIR W=60u L=1u
Mt_uU_L2_26_1 ts_uU_L2_26_1 hv_L1_4 0 0 NMIR W=48.0u L=1u
Mo1_uU_L2_26_1 da_uU_L2_26_1 d1bar_L2 ts_uU_L2_26_1 0 NMIR W=20u L=1u
Mo2_uU_L2_26_1 gp_2_26_1 dpre_L2_26 ts_uU_L2_26_1 0 NMIR W=20u L=1u
Mo3_uU_L2_26_1 da_uU_L2_26_1 da_uU_L2_26_1 vdd vdd PMIR W=60u L=1u
Mo4_uU_L2_26_1 gp_2_26_1 da_uU_L2_26_1 vdd vdd PMIR W=60u L=1u
Mt_uU_L2_26_2 ts_uU_L2_26_2 hv_L1_8 0 0 NMIR W=48.0u L=1u
Mo1_uU_L2_26_2 da_uU_L2_26_2 d1bar_L2 ts_uU_L2_26_2 0 NMIR W=20u L=1u
Mo2_uU_L2_26_2 gp_2_26_2 dpre_L2_26 ts_uU_L2_26_2 0 NMIR W=20u L=1u
Mo3_uU_L2_26_2 da_uU_L2_26_2 da_uU_L2_26_2 vdd vdd PMIR W=60u L=1u
Mo4_uU_L2_26_2 gp_2_26_2 da_uU_L2_26_2 vdd vdd PMIR W=60u L=1u
Mt_uU_L2_26_3 ts_uU_L2_26_3 hv_L1_9 0 0 NMIR W=48.0u L=1u
Mo1_uU_L2_26_3 da_uU_L2_26_3 d1bar_L2 ts_uU_L2_26_3 0 NMIR W=20u L=1u
Mo2_uU_L2_26_3 gp_2_26_3 dpre_L2_26 ts_uU_L2_26_3 0 NMIR W=20u L=1u
Mo3_uU_L2_26_3 da_uU_L2_26_3 da_uU_L2_26_3 vdd vdd PMIR W=60u L=1u
Mo4_uU_L2_26_3 gp_2_26_3 da_uU_L2_26_3 vdd vdd PMIR W=60u L=1u
Mt_uU_L2_26_4 ts_uU_L2_26_4 hv_L1_10 0 0 NMIR W=48.0u L=1u
Mo1_uU_L2_26_4 da_uU_L2_26_4 d1bar_L2 ts_uU_L2_26_4 0 NMIR W=20u L=1u
Mo2_uU_L2_26_4 gp_2_26_4 dpre_L2_26 ts_uU_L2_26_4 0 NMIR W=20u L=1u
Mo3_uU_L2_26_4 da_uU_L2_26_4 da_uU_L2_26_4 vdd vdd PMIR W=60u L=1u
Mo4_uU_L2_26_4 gp_2_26_4 da_uU_L2_26_4 vdd vdd PMIR W=60u L=1u
Mt_uU_L2_26_5 ts_uU_L2_26_5 hv_L1_15 0 0 NMIR W=48.0u L=1u
Mo1_uU_L2_26_5 da_uU_L2_26_5 d1bar_L2 ts_uU_L2_26_5 0 NMIR W=20u L=1u
Mo2_uU_L2_26_5 gp_2_26_5 dpre_L2_26 ts_uU_L2_26_5 0 NMIR W=20u L=1u
Mo3_uU_L2_26_5 da_uU_L2_26_5 da_uU_L2_26_5 vdd vdd PMIR W=60u L=1u
Mo4_uU_L2_26_5 gp_2_26_5 da_uU_L2_26_5 vdd vdd PMIR W=60u L=1u
Mt_uU_L2_26_6 ts_uU_L2_26_6 hv_L1_22 0 0 NMIR W=48.0u L=1u
Mo1_uU_L2_26_6 da_uU_L2_26_6 d1bar_L2 ts_uU_L2_26_6 0 NMIR W=20u L=1u
Mo2_uU_L2_26_6 gp_2_26_6 dpre_L2_26 ts_uU_L2_26_6 0 NMIR W=20u L=1u
Mo3_uU_L2_26_6 da_uU_L2_26_6 da_uU_L2_26_6 vdd vdd PMIR W=60u L=1u
Mo4_uU_L2_26_6 gp_2_26_6 da_uU_L2_26_6 vdd vdd PMIR W=60u L=1u
Mt_uU_L2_26_7 ts_uU_L2_26_7 hv_L1_24 0 0 NMIR W=48.0u L=1u
Mo1_uU_L2_26_7 da_uU_L2_26_7 d1bar_L2 ts_uU_L2_26_7 0 NMIR W=20u L=1u
Mo2_uU_L2_26_7 gp_2_26_7 dpre_L2_26 ts_uU_L2_26_7 0 NMIR W=20u L=1u
Mo3_uU_L2_26_7 da_uU_L2_26_7 da_uU_L2_26_7 vdd vdd PMIR W=60u L=1u
Mo4_uU_L2_26_7 gp_2_26_7 da_uU_L2_26_7 vdd vdd PMIR W=60u L=1u
Mt_uU_L2_26_8 ts_uU_L2_26_8 hv_L1_29 0 0 NMIR W=48.0u L=1u
Mo1_uU_L2_26_8 da_uU_L2_26_8 d1bar_L2 ts_uU_L2_26_8 0 NMIR W=20u L=1u
Mo2_uU_L2_26_8 gp_2_26_8 dpre_L2_26 ts_uU_L2_26_8 0 NMIR W=20u L=1u
Mo3_uU_L2_26_8 da_uU_L2_26_8 da_uU_L2_26_8 vdd vdd PMIR W=60u L=1u
Mo4_uU_L2_26_8 gp_2_26_8 da_uU_L2_26_8 vdd vdd PMIR W=60u L=1u
Mt_uU_L2_26_9 ts_uU_L2_26_9 hv_L1_31 0 0 NMIR W=48.0u L=1u
Mo1_uU_L2_26_9 da_uU_L2_26_9 d1bar_L2 ts_uU_L2_26_9 0 NMIR W=20u L=1u
Mo2_uU_L2_26_9 gp_2_26_9 dpre_L2_26 ts_uU_L2_26_9 0 NMIR W=20u L=1u
Mo3_uU_L2_26_9 da_uU_L2_26_9 da_uU_L2_26_9 vdd vdd PMIR W=60u L=1u
Mo4_uU_L2_26_9 gp_2_26_9 da_uU_L2_26_9 vdd vdd PMIR W=60u L=1u
Mt_uU_L2_26_10 ts_uU_L2_26_10 hv_L1_32 0 0 NMIR W=48.0u L=1u
Mo1_uU_L2_26_10 da_uU_L2_26_10 d1bar_L2 ts_uU_L2_26_10 0 NMIR W=20u L=1u
Mo2_uU_L2_26_10 gp_2_26_10 dpre_L2_26 ts_uU_L2_26_10 0 NMIR W=20u L=1u
Mo3_uU_L2_26_10 da_uU_L2_26_10 da_uU_L2_26_10 vdd vdd PMIR W=60u L=1u
Mo4_uU_L2_26_10 gp_2_26_10 da_uU_L2_26_10 vdd vdd PMIR W=60u L=1u
Mt_uU_L2_26_11 ts_uU_L2_26_11 hv_L1_34 0 0 NMIR W=48.0u L=1u
Mo1_uU_L2_26_11 da_uU_L2_26_11 d1bar_L2 ts_uU_L2_26_11 0 NMIR W=20u L=1u
Mo2_uU_L2_26_11 gp_2_26_11 dpre_L2_26 ts_uU_L2_26_11 0 NMIR W=20u L=1u
Mo3_uU_L2_26_11 da_uU_L2_26_11 da_uU_L2_26_11 vdd vdd PMIR W=60u L=1u
Mo4_uU_L2_26_11 gp_2_26_11 da_uU_L2_26_11 vdd vdd PMIR W=60u L=1u
Mt_uU_L2_26_12 ts_uU_L2_26_12 hv_L1_37 0 0 NMIR W=48.0u L=1u
Mo1_uU_L2_26_12 da_uU_L2_26_12 d1bar_L2 ts_uU_L2_26_12 0 NMIR W=20u L=1u
Mo2_uU_L2_26_12 gp_2_26_12 dpre_L2_26 ts_uU_L2_26_12 0 NMIR W=20u L=1u
Mo3_uU_L2_26_12 da_uU_L2_26_12 da_uU_L2_26_12 vdd vdd PMIR W=60u L=1u
Mo4_uU_L2_26_12 gp_2_26_12 da_uU_L2_26_12 vdd vdd PMIR W=60u L=1u
Mt_uU_L2_26_13 ts_uU_L2_26_13 hv_L1_41 0 0 NMIR W=48.0u L=1u
Mo1_uU_L2_26_13 da_uU_L2_26_13 d1bar_L2 ts_uU_L2_26_13 0 NMIR W=20u L=1u
Mo2_uU_L2_26_13 gp_2_26_13 dpre_L2_26 ts_uU_L2_26_13 0 NMIR W=20u L=1u
Mo3_uU_L2_26_13 da_uU_L2_26_13 da_uU_L2_26_13 vdd vdd PMIR W=60u L=1u
Mo4_uU_L2_26_13 gp_2_26_13 da_uU_L2_26_13 vdd vdd PMIR W=60u L=1u
Mt_uU_L2_26_14 ts_uU_L2_26_14 hv_L1_43 0 0 NMIR W=48.0u L=1u
Mo1_uU_L2_26_14 da_uU_L2_26_14 d1bar_L2 ts_uU_L2_26_14 0 NMIR W=20u L=1u
Mo2_uU_L2_26_14 gp_2_26_14 dpre_L2_26 ts_uU_L2_26_14 0 NMIR W=20u L=1u
Mo3_uU_L2_26_14 da_uU_L2_26_14 da_uU_L2_26_14 vdd vdd PMIR W=60u L=1u
Mo4_uU_L2_26_14 gp_2_26_14 da_uU_L2_26_14 vdd vdd PMIR W=60u L=1u
Mt_uU_L2_26_15 ts_uU_L2_26_15 hv_L1_46 0 0 NMIR W=48.0u L=1u
Mo1_uU_L2_26_15 da_uU_L2_26_15 d1bar_L2 ts_uU_L2_26_15 0 NMIR W=20u L=1u
Mo2_uU_L2_26_15 gp_2_26_15 dpre_L2_26 ts_uU_L2_26_15 0 NMIR W=20u L=1u
Mo3_uU_L2_26_15 da_uU_L2_26_15 da_uU_L2_26_15 vdd vdd PMIR W=60u L=1u
Mo4_uU_L2_26_15 gp_2_26_15 da_uU_L2_26_15 vdd vdd PMIR W=60u L=1u
Mt_uU_L2_27_0 ts_uU_L2_27_0 hv_L1_0 0 0 NMIR W=48.0u L=1u
Mo1_uU_L2_27_0 da_uU_L2_27_0 d1bar_L2 ts_uU_L2_27_0 0 NMIR W=20u L=1u
Mo2_uU_L2_27_0 gp_2_27_0 dpre_L2_27 ts_uU_L2_27_0 0 NMIR W=20u L=1u
Mo3_uU_L2_27_0 da_uU_L2_27_0 da_uU_L2_27_0 vdd vdd PMIR W=60u L=1u
Mo4_uU_L2_27_0 gp_2_27_0 da_uU_L2_27_0 vdd vdd PMIR W=60u L=1u
Mt_uU_L2_27_1 ts_uU_L2_27_1 hv_L1_5 0 0 NMIR W=48.0u L=1u
Mo1_uU_L2_27_1 da_uU_L2_27_1 d1bar_L2 ts_uU_L2_27_1 0 NMIR W=20u L=1u
Mo2_uU_L2_27_1 gp_2_27_1 dpre_L2_27 ts_uU_L2_27_1 0 NMIR W=20u L=1u
Mo3_uU_L2_27_1 da_uU_L2_27_1 da_uU_L2_27_1 vdd vdd PMIR W=60u L=1u
Mo4_uU_L2_27_1 gp_2_27_1 da_uU_L2_27_1 vdd vdd PMIR W=60u L=1u
Mt_uU_L2_27_2 ts_uU_L2_27_2 hv_L1_6 0 0 NMIR W=48.0u L=1u
Mo1_uU_L2_27_2 da_uU_L2_27_2 d1bar_L2 ts_uU_L2_27_2 0 NMIR W=20u L=1u
Mo2_uU_L2_27_2 gp_2_27_2 dpre_L2_27 ts_uU_L2_27_2 0 NMIR W=20u L=1u
Mo3_uU_L2_27_2 da_uU_L2_27_2 da_uU_L2_27_2 vdd vdd PMIR W=60u L=1u
Mo4_uU_L2_27_2 gp_2_27_2 da_uU_L2_27_2 vdd vdd PMIR W=60u L=1u
Mt_uU_L2_27_3 ts_uU_L2_27_3 hv_L1_9 0 0 NMIR W=48.0u L=1u
Mo1_uU_L2_27_3 da_uU_L2_27_3 d1bar_L2 ts_uU_L2_27_3 0 NMIR W=20u L=1u
Mo2_uU_L2_27_3 gp_2_27_3 dpre_L2_27 ts_uU_L2_27_3 0 NMIR W=20u L=1u
Mo3_uU_L2_27_3 da_uU_L2_27_3 da_uU_L2_27_3 vdd vdd PMIR W=60u L=1u
Mo4_uU_L2_27_3 gp_2_27_3 da_uU_L2_27_3 vdd vdd PMIR W=60u L=1u
Mt_uU_L2_27_4 ts_uU_L2_27_4 hv_L1_15 0 0 NMIR W=48.0u L=1u
Mo1_uU_L2_27_4 da_uU_L2_27_4 d1bar_L2 ts_uU_L2_27_4 0 NMIR W=20u L=1u
Mo2_uU_L2_27_4 gp_2_27_4 dpre_L2_27 ts_uU_L2_27_4 0 NMIR W=20u L=1u
Mo3_uU_L2_27_4 da_uU_L2_27_4 da_uU_L2_27_4 vdd vdd PMIR W=60u L=1u
Mo4_uU_L2_27_4 gp_2_27_4 da_uU_L2_27_4 vdd vdd PMIR W=60u L=1u
Mt_uU_L2_27_5 ts_uU_L2_27_5 hv_L1_16 0 0 NMIR W=48.0u L=1u
Mo1_uU_L2_27_5 da_uU_L2_27_5 d1bar_L2 ts_uU_L2_27_5 0 NMIR W=20u L=1u
Mo2_uU_L2_27_5 gp_2_27_5 dpre_L2_27 ts_uU_L2_27_5 0 NMIR W=20u L=1u
Mo3_uU_L2_27_5 da_uU_L2_27_5 da_uU_L2_27_5 vdd vdd PMIR W=60u L=1u
Mo4_uU_L2_27_5 gp_2_27_5 da_uU_L2_27_5 vdd vdd PMIR W=60u L=1u
Mt_uU_L2_27_6 ts_uU_L2_27_6 hv_L1_18 0 0 NMIR W=48.0u L=1u
Mo1_uU_L2_27_6 da_uU_L2_27_6 d1bar_L2 ts_uU_L2_27_6 0 NMIR W=20u L=1u
Mo2_uU_L2_27_6 gp_2_27_6 dpre_L2_27 ts_uU_L2_27_6 0 NMIR W=20u L=1u
Mo3_uU_L2_27_6 da_uU_L2_27_6 da_uU_L2_27_6 vdd vdd PMIR W=60u L=1u
Mo4_uU_L2_27_6 gp_2_27_6 da_uU_L2_27_6 vdd vdd PMIR W=60u L=1u
Mt_uU_L2_27_7 ts_uU_L2_27_7 hv_L1_21 0 0 NMIR W=48.0u L=1u
Mo1_uU_L2_27_7 da_uU_L2_27_7 d1bar_L2 ts_uU_L2_27_7 0 NMIR W=20u L=1u
Mo2_uU_L2_27_7 gp_2_27_7 dpre_L2_27 ts_uU_L2_27_7 0 NMIR W=20u L=1u
Mo3_uU_L2_27_7 da_uU_L2_27_7 da_uU_L2_27_7 vdd vdd PMIR W=60u L=1u
Mo4_uU_L2_27_7 gp_2_27_7 da_uU_L2_27_7 vdd vdd PMIR W=60u L=1u
Mt_uU_L2_27_8 ts_uU_L2_27_8 hv_L1_22 0 0 NMIR W=48.0u L=1u
Mo1_uU_L2_27_8 da_uU_L2_27_8 d1bar_L2 ts_uU_L2_27_8 0 NMIR W=20u L=1u
Mo2_uU_L2_27_8 gp_2_27_8 dpre_L2_27 ts_uU_L2_27_8 0 NMIR W=20u L=1u
Mo3_uU_L2_27_8 da_uU_L2_27_8 da_uU_L2_27_8 vdd vdd PMIR W=60u L=1u
Mo4_uU_L2_27_8 gp_2_27_8 da_uU_L2_27_8 vdd vdd PMIR W=60u L=1u
Mt_uU_L2_27_9 ts_uU_L2_27_9 hv_L1_23 0 0 NMIR W=48.0u L=1u
Mo1_uU_L2_27_9 da_uU_L2_27_9 d1bar_L2 ts_uU_L2_27_9 0 NMIR W=20u L=1u
Mo2_uU_L2_27_9 gp_2_27_9 dpre_L2_27 ts_uU_L2_27_9 0 NMIR W=20u L=1u
Mo3_uU_L2_27_9 da_uU_L2_27_9 da_uU_L2_27_9 vdd vdd PMIR W=60u L=1u
Mo4_uU_L2_27_9 gp_2_27_9 da_uU_L2_27_9 vdd vdd PMIR W=60u L=1u
Mt_uU_L2_27_10 ts_uU_L2_27_10 hv_L1_25 0 0 NMIR W=48.0u L=1u
Mo1_uU_L2_27_10 da_uU_L2_27_10 d1bar_L2 ts_uU_L2_27_10 0 NMIR W=20u L=1u
Mo2_uU_L2_27_10 gp_2_27_10 dpre_L2_27 ts_uU_L2_27_10 0 NMIR W=20u L=1u
Mo3_uU_L2_27_10 da_uU_L2_27_10 da_uU_L2_27_10 vdd vdd PMIR W=60u L=1u
Mo4_uU_L2_27_10 gp_2_27_10 da_uU_L2_27_10 vdd vdd PMIR W=60u L=1u
Mt_uU_L2_27_11 ts_uU_L2_27_11 hv_L1_26 0 0 NMIR W=48.0u L=1u
Mo1_uU_L2_27_11 da_uU_L2_27_11 d1bar_L2 ts_uU_L2_27_11 0 NMIR W=20u L=1u
Mo2_uU_L2_27_11 gp_2_27_11 dpre_L2_27 ts_uU_L2_27_11 0 NMIR W=20u L=1u
Mo3_uU_L2_27_11 da_uU_L2_27_11 da_uU_L2_27_11 vdd vdd PMIR W=60u L=1u
Mo4_uU_L2_27_11 gp_2_27_11 da_uU_L2_27_11 vdd vdd PMIR W=60u L=1u
Mt_uU_L2_27_12 ts_uU_L2_27_12 hv_L1_27 0 0 NMIR W=48.0u L=1u
Mo1_uU_L2_27_12 da_uU_L2_27_12 d1bar_L2 ts_uU_L2_27_12 0 NMIR W=20u L=1u
Mo2_uU_L2_27_12 gp_2_27_12 dpre_L2_27 ts_uU_L2_27_12 0 NMIR W=20u L=1u
Mo3_uU_L2_27_12 da_uU_L2_27_12 da_uU_L2_27_12 vdd vdd PMIR W=60u L=1u
Mo4_uU_L2_27_12 gp_2_27_12 da_uU_L2_27_12 vdd vdd PMIR W=60u L=1u
Mt_uU_L2_27_13 ts_uU_L2_27_13 hv_L1_34 0 0 NMIR W=48.0u L=1u
Mo1_uU_L2_27_13 da_uU_L2_27_13 d1bar_L2 ts_uU_L2_27_13 0 NMIR W=20u L=1u
Mo2_uU_L2_27_13 gp_2_27_13 dpre_L2_27 ts_uU_L2_27_13 0 NMIR W=20u L=1u
Mo3_uU_L2_27_13 da_uU_L2_27_13 da_uU_L2_27_13 vdd vdd PMIR W=60u L=1u
Mo4_uU_L2_27_13 gp_2_27_13 da_uU_L2_27_13 vdd vdd PMIR W=60u L=1u
Mt_uU_L2_27_14 ts_uU_L2_27_14 hv_L1_36 0 0 NMIR W=48.0u L=1u
Mo1_uU_L2_27_14 da_uU_L2_27_14 d1bar_L2 ts_uU_L2_27_14 0 NMIR W=20u L=1u
Mo2_uU_L2_27_14 gp_2_27_14 dpre_L2_27 ts_uU_L2_27_14 0 NMIR W=20u L=1u
Mo3_uU_L2_27_14 da_uU_L2_27_14 da_uU_L2_27_14 vdd vdd PMIR W=60u L=1u
Mo4_uU_L2_27_14 gp_2_27_14 da_uU_L2_27_14 vdd vdd PMIR W=60u L=1u
Mt_uU_L2_27_15 ts_uU_L2_27_15 hv_L1_44 0 0 NMIR W=48.0u L=1u
Mo1_uU_L2_27_15 da_uU_L2_27_15 d1bar_L2 ts_uU_L2_27_15 0 NMIR W=20u L=1u
Mo2_uU_L2_27_15 gp_2_27_15 dpre_L2_27 ts_uU_L2_27_15 0 NMIR W=20u L=1u
Mo3_uU_L2_27_15 da_uU_L2_27_15 da_uU_L2_27_15 vdd vdd PMIR W=60u L=1u
Mo4_uU_L2_27_15 gp_2_27_15 da_uU_L2_27_15 vdd vdd PMIR W=60u L=1u
Mt_uU_L2_28_0 ts_uU_L2_28_0 hv_L1_2 0 0 NMIR W=48.0u L=1u
Mo1_uU_L2_28_0 da_uU_L2_28_0 d1bar_L2 ts_uU_L2_28_0 0 NMIR W=20u L=1u
Mo2_uU_L2_28_0 gp_2_28_0 dpre_L2_28 ts_uU_L2_28_0 0 NMIR W=20u L=1u
Mo3_uU_L2_28_0 da_uU_L2_28_0 da_uU_L2_28_0 vdd vdd PMIR W=60u L=1u
Mo4_uU_L2_28_0 gp_2_28_0 da_uU_L2_28_0 vdd vdd PMIR W=60u L=1u
Mt_uU_L2_28_1 ts_uU_L2_28_1 hv_L1_6 0 0 NMIR W=48.0u L=1u
Mo1_uU_L2_28_1 da_uU_L2_28_1 d1bar_L2 ts_uU_L2_28_1 0 NMIR W=20u L=1u
Mo2_uU_L2_28_1 gp_2_28_1 dpre_L2_28 ts_uU_L2_28_1 0 NMIR W=20u L=1u
Mo3_uU_L2_28_1 da_uU_L2_28_1 da_uU_L2_28_1 vdd vdd PMIR W=60u L=1u
Mo4_uU_L2_28_1 gp_2_28_1 da_uU_L2_28_1 vdd vdd PMIR W=60u L=1u
Mt_uU_L2_28_2 ts_uU_L2_28_2 hv_L1_8 0 0 NMIR W=48.0u L=1u
Mo1_uU_L2_28_2 da_uU_L2_28_2 d1bar_L2 ts_uU_L2_28_2 0 NMIR W=20u L=1u
Mo2_uU_L2_28_2 gp_2_28_2 dpre_L2_28 ts_uU_L2_28_2 0 NMIR W=20u L=1u
Mo3_uU_L2_28_2 da_uU_L2_28_2 da_uU_L2_28_2 vdd vdd PMIR W=60u L=1u
Mo4_uU_L2_28_2 gp_2_28_2 da_uU_L2_28_2 vdd vdd PMIR W=60u L=1u
Mt_uU_L2_28_3 ts_uU_L2_28_3 hv_L1_12 0 0 NMIR W=48.0u L=1u
Mo1_uU_L2_28_3 da_uU_L2_28_3 d1bar_L2 ts_uU_L2_28_3 0 NMIR W=20u L=1u
Mo2_uU_L2_28_3 gp_2_28_3 dpre_L2_28 ts_uU_L2_28_3 0 NMIR W=20u L=1u
Mo3_uU_L2_28_3 da_uU_L2_28_3 da_uU_L2_28_3 vdd vdd PMIR W=60u L=1u
Mo4_uU_L2_28_3 gp_2_28_3 da_uU_L2_28_3 vdd vdd PMIR W=60u L=1u
Mt_uU_L2_28_4 ts_uU_L2_28_4 hv_L1_13 0 0 NMIR W=48.0u L=1u
Mo1_uU_L2_28_4 da_uU_L2_28_4 d1bar_L2 ts_uU_L2_28_4 0 NMIR W=20u L=1u
Mo2_uU_L2_28_4 gp_2_28_4 dpre_L2_28 ts_uU_L2_28_4 0 NMIR W=20u L=1u
Mo3_uU_L2_28_4 da_uU_L2_28_4 da_uU_L2_28_4 vdd vdd PMIR W=60u L=1u
Mo4_uU_L2_28_4 gp_2_28_4 da_uU_L2_28_4 vdd vdd PMIR W=60u L=1u
Mt_uU_L2_28_5 ts_uU_L2_28_5 hv_L1_15 0 0 NMIR W=48.0u L=1u
Mo1_uU_L2_28_5 da_uU_L2_28_5 d1bar_L2 ts_uU_L2_28_5 0 NMIR W=20u L=1u
Mo2_uU_L2_28_5 gp_2_28_5 dpre_L2_28 ts_uU_L2_28_5 0 NMIR W=20u L=1u
Mo3_uU_L2_28_5 da_uU_L2_28_5 da_uU_L2_28_5 vdd vdd PMIR W=60u L=1u
Mo4_uU_L2_28_5 gp_2_28_5 da_uU_L2_28_5 vdd vdd PMIR W=60u L=1u
Mt_uU_L2_28_6 ts_uU_L2_28_6 hv_L1_16 0 0 NMIR W=48.0u L=1u
Mo1_uU_L2_28_6 da_uU_L2_28_6 d1bar_L2 ts_uU_L2_28_6 0 NMIR W=20u L=1u
Mo2_uU_L2_28_6 gp_2_28_6 dpre_L2_28 ts_uU_L2_28_6 0 NMIR W=20u L=1u
Mo3_uU_L2_28_6 da_uU_L2_28_6 da_uU_L2_28_6 vdd vdd PMIR W=60u L=1u
Mo4_uU_L2_28_6 gp_2_28_6 da_uU_L2_28_6 vdd vdd PMIR W=60u L=1u
Mt_uU_L2_28_7 ts_uU_L2_28_7 hv_L1_26 0 0 NMIR W=48.0u L=1u
Mo1_uU_L2_28_7 da_uU_L2_28_7 d1bar_L2 ts_uU_L2_28_7 0 NMIR W=20u L=1u
Mo2_uU_L2_28_7 gp_2_28_7 dpre_L2_28 ts_uU_L2_28_7 0 NMIR W=20u L=1u
Mo3_uU_L2_28_7 da_uU_L2_28_7 da_uU_L2_28_7 vdd vdd PMIR W=60u L=1u
Mo4_uU_L2_28_7 gp_2_28_7 da_uU_L2_28_7 vdd vdd PMIR W=60u L=1u
Mt_uU_L2_28_8 ts_uU_L2_28_8 hv_L1_27 0 0 NMIR W=48.0u L=1u
Mo1_uU_L2_28_8 da_uU_L2_28_8 d1bar_L2 ts_uU_L2_28_8 0 NMIR W=20u L=1u
Mo2_uU_L2_28_8 gp_2_28_8 dpre_L2_28 ts_uU_L2_28_8 0 NMIR W=20u L=1u
Mo3_uU_L2_28_8 da_uU_L2_28_8 da_uU_L2_28_8 vdd vdd PMIR W=60u L=1u
Mo4_uU_L2_28_8 gp_2_28_8 da_uU_L2_28_8 vdd vdd PMIR W=60u L=1u
Mt_uU_L2_28_9 ts_uU_L2_28_9 hv_L1_28 0 0 NMIR W=48.0u L=1u
Mo1_uU_L2_28_9 da_uU_L2_28_9 d1bar_L2 ts_uU_L2_28_9 0 NMIR W=20u L=1u
Mo2_uU_L2_28_9 gp_2_28_9 dpre_L2_28 ts_uU_L2_28_9 0 NMIR W=20u L=1u
Mo3_uU_L2_28_9 da_uU_L2_28_9 da_uU_L2_28_9 vdd vdd PMIR W=60u L=1u
Mo4_uU_L2_28_9 gp_2_28_9 da_uU_L2_28_9 vdd vdd PMIR W=60u L=1u
Mt_uU_L2_28_10 ts_uU_L2_28_10 hv_L1_29 0 0 NMIR W=48.0u L=1u
Mo1_uU_L2_28_10 da_uU_L2_28_10 d1bar_L2 ts_uU_L2_28_10 0 NMIR W=20u L=1u
Mo2_uU_L2_28_10 gp_2_28_10 dpre_L2_28 ts_uU_L2_28_10 0 NMIR W=20u L=1u
Mo3_uU_L2_28_10 da_uU_L2_28_10 da_uU_L2_28_10 vdd vdd PMIR W=60u L=1u
Mo4_uU_L2_28_10 gp_2_28_10 da_uU_L2_28_10 vdd vdd PMIR W=60u L=1u
Mt_uU_L2_28_11 ts_uU_L2_28_11 hv_L1_30 0 0 NMIR W=48.0u L=1u
Mo1_uU_L2_28_11 da_uU_L2_28_11 d1bar_L2 ts_uU_L2_28_11 0 NMIR W=20u L=1u
Mo2_uU_L2_28_11 gp_2_28_11 dpre_L2_28 ts_uU_L2_28_11 0 NMIR W=20u L=1u
Mo3_uU_L2_28_11 da_uU_L2_28_11 da_uU_L2_28_11 vdd vdd PMIR W=60u L=1u
Mo4_uU_L2_28_11 gp_2_28_11 da_uU_L2_28_11 vdd vdd PMIR W=60u L=1u
Mt_uU_L2_28_12 ts_uU_L2_28_12 hv_L1_34 0 0 NMIR W=48.0u L=1u
Mo1_uU_L2_28_12 da_uU_L2_28_12 d1bar_L2 ts_uU_L2_28_12 0 NMIR W=20u L=1u
Mo2_uU_L2_28_12 gp_2_28_12 dpre_L2_28 ts_uU_L2_28_12 0 NMIR W=20u L=1u
Mo3_uU_L2_28_12 da_uU_L2_28_12 da_uU_L2_28_12 vdd vdd PMIR W=60u L=1u
Mo4_uU_L2_28_12 gp_2_28_12 da_uU_L2_28_12 vdd vdd PMIR W=60u L=1u
Mt_uU_L2_28_13 ts_uU_L2_28_13 hv_L1_35 0 0 NMIR W=48.0u L=1u
Mo1_uU_L2_28_13 da_uU_L2_28_13 d1bar_L2 ts_uU_L2_28_13 0 NMIR W=20u L=1u
Mo2_uU_L2_28_13 gp_2_28_13 dpre_L2_28 ts_uU_L2_28_13 0 NMIR W=20u L=1u
Mo3_uU_L2_28_13 da_uU_L2_28_13 da_uU_L2_28_13 vdd vdd PMIR W=60u L=1u
Mo4_uU_L2_28_13 gp_2_28_13 da_uU_L2_28_13 vdd vdd PMIR W=60u L=1u
Mt_uU_L2_28_14 ts_uU_L2_28_14 hv_L1_41 0 0 NMIR W=48.0u L=1u
Mo1_uU_L2_28_14 da_uU_L2_28_14 d1bar_L2 ts_uU_L2_28_14 0 NMIR W=20u L=1u
Mo2_uU_L2_28_14 gp_2_28_14 dpre_L2_28 ts_uU_L2_28_14 0 NMIR W=20u L=1u
Mo3_uU_L2_28_14 da_uU_L2_28_14 da_uU_L2_28_14 vdd vdd PMIR W=60u L=1u
Mo4_uU_L2_28_14 gp_2_28_14 da_uU_L2_28_14 vdd vdd PMIR W=60u L=1u
Mt_uU_L2_28_15 ts_uU_L2_28_15 hv_L1_45 0 0 NMIR W=48.0u L=1u
Mo1_uU_L2_28_15 da_uU_L2_28_15 d1bar_L2 ts_uU_L2_28_15 0 NMIR W=20u L=1u
Mo2_uU_L2_28_15 gp_2_28_15 dpre_L2_28 ts_uU_L2_28_15 0 NMIR W=20u L=1u
Mo3_uU_L2_28_15 da_uU_L2_28_15 da_uU_L2_28_15 vdd vdd PMIR W=60u L=1u
Mo4_uU_L2_28_15 gp_2_28_15 da_uU_L2_28_15 vdd vdd PMIR W=60u L=1u
Mt_uU_L2_29_0 ts_uU_L2_29_0 hv_L1_3 0 0 NMIR W=48.0u L=1u
Mo1_uU_L2_29_0 da_uU_L2_29_0 d1bar_L2 ts_uU_L2_29_0 0 NMIR W=20u L=1u
Mo2_uU_L2_29_0 gp_2_29_0 dpre_L2_29 ts_uU_L2_29_0 0 NMIR W=20u L=1u
Mo3_uU_L2_29_0 da_uU_L2_29_0 da_uU_L2_29_0 vdd vdd PMIR W=60u L=1u
Mo4_uU_L2_29_0 gp_2_29_0 da_uU_L2_29_0 vdd vdd PMIR W=60u L=1u
Mt_uU_L2_29_1 ts_uU_L2_29_1 hv_L1_4 0 0 NMIR W=48.0u L=1u
Mo1_uU_L2_29_1 da_uU_L2_29_1 d1bar_L2 ts_uU_L2_29_1 0 NMIR W=20u L=1u
Mo2_uU_L2_29_1 gp_2_29_1 dpre_L2_29 ts_uU_L2_29_1 0 NMIR W=20u L=1u
Mo3_uU_L2_29_1 da_uU_L2_29_1 da_uU_L2_29_1 vdd vdd PMIR W=60u L=1u
Mo4_uU_L2_29_1 gp_2_29_1 da_uU_L2_29_1 vdd vdd PMIR W=60u L=1u
Mt_uU_L2_29_2 ts_uU_L2_29_2 hv_L1_12 0 0 NMIR W=48.0u L=1u
Mo1_uU_L2_29_2 da_uU_L2_29_2 d1bar_L2 ts_uU_L2_29_2 0 NMIR W=20u L=1u
Mo2_uU_L2_29_2 gp_2_29_2 dpre_L2_29 ts_uU_L2_29_2 0 NMIR W=20u L=1u
Mo3_uU_L2_29_2 da_uU_L2_29_2 da_uU_L2_29_2 vdd vdd PMIR W=60u L=1u
Mo4_uU_L2_29_2 gp_2_29_2 da_uU_L2_29_2 vdd vdd PMIR W=60u L=1u
Mt_uU_L2_29_3 ts_uU_L2_29_3 hv_L1_17 0 0 NMIR W=48.0u L=1u
Mo1_uU_L2_29_3 da_uU_L2_29_3 d1bar_L2 ts_uU_L2_29_3 0 NMIR W=20u L=1u
Mo2_uU_L2_29_3 gp_2_29_3 dpre_L2_29 ts_uU_L2_29_3 0 NMIR W=20u L=1u
Mo3_uU_L2_29_3 da_uU_L2_29_3 da_uU_L2_29_3 vdd vdd PMIR W=60u L=1u
Mo4_uU_L2_29_3 gp_2_29_3 da_uU_L2_29_3 vdd vdd PMIR W=60u L=1u
Mt_uU_L2_29_4 ts_uU_L2_29_4 hv_L1_22 0 0 NMIR W=48.0u L=1u
Mo1_uU_L2_29_4 da_uU_L2_29_4 d1bar_L2 ts_uU_L2_29_4 0 NMIR W=20u L=1u
Mo2_uU_L2_29_4 gp_2_29_4 dpre_L2_29 ts_uU_L2_29_4 0 NMIR W=20u L=1u
Mo3_uU_L2_29_4 da_uU_L2_29_4 da_uU_L2_29_4 vdd vdd PMIR W=60u L=1u
Mo4_uU_L2_29_4 gp_2_29_4 da_uU_L2_29_4 vdd vdd PMIR W=60u L=1u
Mt_uU_L2_29_5 ts_uU_L2_29_5 hv_L1_23 0 0 NMIR W=48.0u L=1u
Mo1_uU_L2_29_5 da_uU_L2_29_5 d1bar_L2 ts_uU_L2_29_5 0 NMIR W=20u L=1u
Mo2_uU_L2_29_5 gp_2_29_5 dpre_L2_29 ts_uU_L2_29_5 0 NMIR W=20u L=1u
Mo3_uU_L2_29_5 da_uU_L2_29_5 da_uU_L2_29_5 vdd vdd PMIR W=60u L=1u
Mo4_uU_L2_29_5 gp_2_29_5 da_uU_L2_29_5 vdd vdd PMIR W=60u L=1u
Mt_uU_L2_29_6 ts_uU_L2_29_6 hv_L1_31 0 0 NMIR W=48.0u L=1u
Mo1_uU_L2_29_6 da_uU_L2_29_6 d1bar_L2 ts_uU_L2_29_6 0 NMIR W=20u L=1u
Mo2_uU_L2_29_6 gp_2_29_6 dpre_L2_29 ts_uU_L2_29_6 0 NMIR W=20u L=1u
Mo3_uU_L2_29_6 da_uU_L2_29_6 da_uU_L2_29_6 vdd vdd PMIR W=60u L=1u
Mo4_uU_L2_29_6 gp_2_29_6 da_uU_L2_29_6 vdd vdd PMIR W=60u L=1u
Mt_uU_L2_29_7 ts_uU_L2_29_7 hv_L1_32 0 0 NMIR W=48.0u L=1u
Mo1_uU_L2_29_7 da_uU_L2_29_7 d1bar_L2 ts_uU_L2_29_7 0 NMIR W=20u L=1u
Mo2_uU_L2_29_7 gp_2_29_7 dpre_L2_29 ts_uU_L2_29_7 0 NMIR W=20u L=1u
Mo3_uU_L2_29_7 da_uU_L2_29_7 da_uU_L2_29_7 vdd vdd PMIR W=60u L=1u
Mo4_uU_L2_29_7 gp_2_29_7 da_uU_L2_29_7 vdd vdd PMIR W=60u L=1u
Mt_uU_L2_29_8 ts_uU_L2_29_8 hv_L1_36 0 0 NMIR W=48.0u L=1u
Mo1_uU_L2_29_8 da_uU_L2_29_8 d1bar_L2 ts_uU_L2_29_8 0 NMIR W=20u L=1u
Mo2_uU_L2_29_8 gp_2_29_8 dpre_L2_29 ts_uU_L2_29_8 0 NMIR W=20u L=1u
Mo3_uU_L2_29_8 da_uU_L2_29_8 da_uU_L2_29_8 vdd vdd PMIR W=60u L=1u
Mo4_uU_L2_29_8 gp_2_29_8 da_uU_L2_29_8 vdd vdd PMIR W=60u L=1u
Mt_uU_L2_29_9 ts_uU_L2_29_9 hv_L1_38 0 0 NMIR W=48.0u L=1u
Mo1_uU_L2_29_9 da_uU_L2_29_9 d1bar_L2 ts_uU_L2_29_9 0 NMIR W=20u L=1u
Mo2_uU_L2_29_9 gp_2_29_9 dpre_L2_29 ts_uU_L2_29_9 0 NMIR W=20u L=1u
Mo3_uU_L2_29_9 da_uU_L2_29_9 da_uU_L2_29_9 vdd vdd PMIR W=60u L=1u
Mo4_uU_L2_29_9 gp_2_29_9 da_uU_L2_29_9 vdd vdd PMIR W=60u L=1u
Mt_uU_L2_29_10 ts_uU_L2_29_10 hv_L1_39 0 0 NMIR W=48.0u L=1u
Mo1_uU_L2_29_10 da_uU_L2_29_10 d1bar_L2 ts_uU_L2_29_10 0 NMIR W=20u L=1u
Mo2_uU_L2_29_10 gp_2_29_10 dpre_L2_29 ts_uU_L2_29_10 0 NMIR W=20u L=1u
Mo3_uU_L2_29_10 da_uU_L2_29_10 da_uU_L2_29_10 vdd vdd PMIR W=60u L=1u
Mo4_uU_L2_29_10 gp_2_29_10 da_uU_L2_29_10 vdd vdd PMIR W=60u L=1u
Mt_uU_L2_29_11 ts_uU_L2_29_11 hv_L1_40 0 0 NMIR W=48.0u L=1u
Mo1_uU_L2_29_11 da_uU_L2_29_11 d1bar_L2 ts_uU_L2_29_11 0 NMIR W=20u L=1u
Mo2_uU_L2_29_11 gp_2_29_11 dpre_L2_29 ts_uU_L2_29_11 0 NMIR W=20u L=1u
Mo3_uU_L2_29_11 da_uU_L2_29_11 da_uU_L2_29_11 vdd vdd PMIR W=60u L=1u
Mo4_uU_L2_29_11 gp_2_29_11 da_uU_L2_29_11 vdd vdd PMIR W=60u L=1u
Mt_uU_L2_29_12 ts_uU_L2_29_12 hv_L1_42 0 0 NMIR W=48.0u L=1u
Mo1_uU_L2_29_12 da_uU_L2_29_12 d1bar_L2 ts_uU_L2_29_12 0 NMIR W=20u L=1u
Mo2_uU_L2_29_12 gp_2_29_12 dpre_L2_29 ts_uU_L2_29_12 0 NMIR W=20u L=1u
Mo3_uU_L2_29_12 da_uU_L2_29_12 da_uU_L2_29_12 vdd vdd PMIR W=60u L=1u
Mo4_uU_L2_29_12 gp_2_29_12 da_uU_L2_29_12 vdd vdd PMIR W=60u L=1u
Mt_uU_L2_29_13 ts_uU_L2_29_13 hv_L1_43 0 0 NMIR W=48.0u L=1u
Mo1_uU_L2_29_13 da_uU_L2_29_13 d1bar_L2 ts_uU_L2_29_13 0 NMIR W=20u L=1u
Mo2_uU_L2_29_13 gp_2_29_13 dpre_L2_29 ts_uU_L2_29_13 0 NMIR W=20u L=1u
Mo3_uU_L2_29_13 da_uU_L2_29_13 da_uU_L2_29_13 vdd vdd PMIR W=60u L=1u
Mo4_uU_L2_29_13 gp_2_29_13 da_uU_L2_29_13 vdd vdd PMIR W=60u L=1u
Mt_uU_L2_29_14 ts_uU_L2_29_14 hv_L1_45 0 0 NMIR W=48.0u L=1u
Mo1_uU_L2_29_14 da_uU_L2_29_14 d1bar_L2 ts_uU_L2_29_14 0 NMIR W=20u L=1u
Mo2_uU_L2_29_14 gp_2_29_14 dpre_L2_29 ts_uU_L2_29_14 0 NMIR W=20u L=1u
Mo3_uU_L2_29_14 da_uU_L2_29_14 da_uU_L2_29_14 vdd vdd PMIR W=60u L=1u
Mo4_uU_L2_29_14 gp_2_29_14 da_uU_L2_29_14 vdd vdd PMIR W=60u L=1u
Mt_uU_L2_29_15 ts_uU_L2_29_15 hv_L1_46 0 0 NMIR W=48.0u L=1u
Mo1_uU_L2_29_15 da_uU_L2_29_15 d1bar_L2 ts_uU_L2_29_15 0 NMIR W=20u L=1u
Mo2_uU_L2_29_15 gp_2_29_15 dpre_L2_29 ts_uU_L2_29_15 0 NMIR W=20u L=1u
Mo3_uU_L2_29_15 da_uU_L2_29_15 da_uU_L2_29_15 vdd vdd PMIR W=60u L=1u
Mo4_uU_L2_29_15 gp_2_29_15 da_uU_L2_29_15 vdd vdd PMIR W=60u L=1u
Mt_uU_L2_30_0 ts_uU_L2_30_0 hv_L1_4 0 0 NMIR W=48.0u L=1u
Mo1_uU_L2_30_0 da_uU_L2_30_0 d1bar_L2 ts_uU_L2_30_0 0 NMIR W=20u L=1u
Mo2_uU_L2_30_0 gp_2_30_0 dpre_L2_30 ts_uU_L2_30_0 0 NMIR W=20u L=1u
Mo3_uU_L2_30_0 da_uU_L2_30_0 da_uU_L2_30_0 vdd vdd PMIR W=60u L=1u
Mo4_uU_L2_30_0 gp_2_30_0 da_uU_L2_30_0 vdd vdd PMIR W=60u L=1u
Mt_uU_L2_30_1 ts_uU_L2_30_1 hv_L1_5 0 0 NMIR W=48.0u L=1u
Mo1_uU_L2_30_1 da_uU_L2_30_1 d1bar_L2 ts_uU_L2_30_1 0 NMIR W=20u L=1u
Mo2_uU_L2_30_1 gp_2_30_1 dpre_L2_30 ts_uU_L2_30_1 0 NMIR W=20u L=1u
Mo3_uU_L2_30_1 da_uU_L2_30_1 da_uU_L2_30_1 vdd vdd PMIR W=60u L=1u
Mo4_uU_L2_30_1 gp_2_30_1 da_uU_L2_30_1 vdd vdd PMIR W=60u L=1u
Mt_uU_L2_30_2 ts_uU_L2_30_2 hv_L1_6 0 0 NMIR W=48.0u L=1u
Mo1_uU_L2_30_2 da_uU_L2_30_2 d1bar_L2 ts_uU_L2_30_2 0 NMIR W=20u L=1u
Mo2_uU_L2_30_2 gp_2_30_2 dpre_L2_30 ts_uU_L2_30_2 0 NMIR W=20u L=1u
Mo3_uU_L2_30_2 da_uU_L2_30_2 da_uU_L2_30_2 vdd vdd PMIR W=60u L=1u
Mo4_uU_L2_30_2 gp_2_30_2 da_uU_L2_30_2 vdd vdd PMIR W=60u L=1u
Mt_uU_L2_30_3 ts_uU_L2_30_3 hv_L1_9 0 0 NMIR W=48.0u L=1u
Mo1_uU_L2_30_3 da_uU_L2_30_3 d1bar_L2 ts_uU_L2_30_3 0 NMIR W=20u L=1u
Mo2_uU_L2_30_3 gp_2_30_3 dpre_L2_30 ts_uU_L2_30_3 0 NMIR W=20u L=1u
Mo3_uU_L2_30_3 da_uU_L2_30_3 da_uU_L2_30_3 vdd vdd PMIR W=60u L=1u
Mo4_uU_L2_30_3 gp_2_30_3 da_uU_L2_30_3 vdd vdd PMIR W=60u L=1u
Mt_uU_L2_30_4 ts_uU_L2_30_4 hv_L1_10 0 0 NMIR W=48.0u L=1u
Mo1_uU_L2_30_4 da_uU_L2_30_4 d1bar_L2 ts_uU_L2_30_4 0 NMIR W=20u L=1u
Mo2_uU_L2_30_4 gp_2_30_4 dpre_L2_30 ts_uU_L2_30_4 0 NMIR W=20u L=1u
Mo3_uU_L2_30_4 da_uU_L2_30_4 da_uU_L2_30_4 vdd vdd PMIR W=60u L=1u
Mo4_uU_L2_30_4 gp_2_30_4 da_uU_L2_30_4 vdd vdd PMIR W=60u L=1u
Mt_uU_L2_30_5 ts_uU_L2_30_5 hv_L1_11 0 0 NMIR W=48.0u L=1u
Mo1_uU_L2_30_5 da_uU_L2_30_5 d1bar_L2 ts_uU_L2_30_5 0 NMIR W=20u L=1u
Mo2_uU_L2_30_5 gp_2_30_5 dpre_L2_30 ts_uU_L2_30_5 0 NMIR W=20u L=1u
Mo3_uU_L2_30_5 da_uU_L2_30_5 da_uU_L2_30_5 vdd vdd PMIR W=60u L=1u
Mo4_uU_L2_30_5 gp_2_30_5 da_uU_L2_30_5 vdd vdd PMIR W=60u L=1u
Mt_uU_L2_30_6 ts_uU_L2_30_6 hv_L1_12 0 0 NMIR W=48.0u L=1u
Mo1_uU_L2_30_6 da_uU_L2_30_6 d1bar_L2 ts_uU_L2_30_6 0 NMIR W=20u L=1u
Mo2_uU_L2_30_6 gp_2_30_6 dpre_L2_30 ts_uU_L2_30_6 0 NMIR W=20u L=1u
Mo3_uU_L2_30_6 da_uU_L2_30_6 da_uU_L2_30_6 vdd vdd PMIR W=60u L=1u
Mo4_uU_L2_30_6 gp_2_30_6 da_uU_L2_30_6 vdd vdd PMIR W=60u L=1u
Mt_uU_L2_30_7 ts_uU_L2_30_7 hv_L1_19 0 0 NMIR W=48.0u L=1u
Mo1_uU_L2_30_7 da_uU_L2_30_7 d1bar_L2 ts_uU_L2_30_7 0 NMIR W=20u L=1u
Mo2_uU_L2_30_7 gp_2_30_7 dpre_L2_30 ts_uU_L2_30_7 0 NMIR W=20u L=1u
Mo3_uU_L2_30_7 da_uU_L2_30_7 da_uU_L2_30_7 vdd vdd PMIR W=60u L=1u
Mo4_uU_L2_30_7 gp_2_30_7 da_uU_L2_30_7 vdd vdd PMIR W=60u L=1u
Mt_uU_L2_30_8 ts_uU_L2_30_8 hv_L1_31 0 0 NMIR W=48.0u L=1u
Mo1_uU_L2_30_8 da_uU_L2_30_8 d1bar_L2 ts_uU_L2_30_8 0 NMIR W=20u L=1u
Mo2_uU_L2_30_8 gp_2_30_8 dpre_L2_30 ts_uU_L2_30_8 0 NMIR W=20u L=1u
Mo3_uU_L2_30_8 da_uU_L2_30_8 da_uU_L2_30_8 vdd vdd PMIR W=60u L=1u
Mo4_uU_L2_30_8 gp_2_30_8 da_uU_L2_30_8 vdd vdd PMIR W=60u L=1u
Mt_uU_L2_30_9 ts_uU_L2_30_9 hv_L1_33 0 0 NMIR W=48.0u L=1u
Mo1_uU_L2_30_9 da_uU_L2_30_9 d1bar_L2 ts_uU_L2_30_9 0 NMIR W=20u L=1u
Mo2_uU_L2_30_9 gp_2_30_9 dpre_L2_30 ts_uU_L2_30_9 0 NMIR W=20u L=1u
Mo3_uU_L2_30_9 da_uU_L2_30_9 da_uU_L2_30_9 vdd vdd PMIR W=60u L=1u
Mo4_uU_L2_30_9 gp_2_30_9 da_uU_L2_30_9 vdd vdd PMIR W=60u L=1u
Mt_uU_L2_30_10 ts_uU_L2_30_10 hv_L1_34 0 0 NMIR W=48.0u L=1u
Mo1_uU_L2_30_10 da_uU_L2_30_10 d1bar_L2 ts_uU_L2_30_10 0 NMIR W=20u L=1u
Mo2_uU_L2_30_10 gp_2_30_10 dpre_L2_30 ts_uU_L2_30_10 0 NMIR W=20u L=1u
Mo3_uU_L2_30_10 da_uU_L2_30_10 da_uU_L2_30_10 vdd vdd PMIR W=60u L=1u
Mo4_uU_L2_30_10 gp_2_30_10 da_uU_L2_30_10 vdd vdd PMIR W=60u L=1u
Mt_uU_L2_30_11 ts_uU_L2_30_11 hv_L1_37 0 0 NMIR W=48.0u L=1u
Mo1_uU_L2_30_11 da_uU_L2_30_11 d1bar_L2 ts_uU_L2_30_11 0 NMIR W=20u L=1u
Mo2_uU_L2_30_11 gp_2_30_11 dpre_L2_30 ts_uU_L2_30_11 0 NMIR W=20u L=1u
Mo3_uU_L2_30_11 da_uU_L2_30_11 da_uU_L2_30_11 vdd vdd PMIR W=60u L=1u
Mo4_uU_L2_30_11 gp_2_30_11 da_uU_L2_30_11 vdd vdd PMIR W=60u L=1u
Mt_uU_L2_30_12 ts_uU_L2_30_12 hv_L1_39 0 0 NMIR W=48.0u L=1u
Mo1_uU_L2_30_12 da_uU_L2_30_12 d1bar_L2 ts_uU_L2_30_12 0 NMIR W=20u L=1u
Mo2_uU_L2_30_12 gp_2_30_12 dpre_L2_30 ts_uU_L2_30_12 0 NMIR W=20u L=1u
Mo3_uU_L2_30_12 da_uU_L2_30_12 da_uU_L2_30_12 vdd vdd PMIR W=60u L=1u
Mo4_uU_L2_30_12 gp_2_30_12 da_uU_L2_30_12 vdd vdd PMIR W=60u L=1u
Mt_uU_L2_30_13 ts_uU_L2_30_13 hv_L1_40 0 0 NMIR W=48.0u L=1u
Mo1_uU_L2_30_13 da_uU_L2_30_13 d1bar_L2 ts_uU_L2_30_13 0 NMIR W=20u L=1u
Mo2_uU_L2_30_13 gp_2_30_13 dpre_L2_30 ts_uU_L2_30_13 0 NMIR W=20u L=1u
Mo3_uU_L2_30_13 da_uU_L2_30_13 da_uU_L2_30_13 vdd vdd PMIR W=60u L=1u
Mo4_uU_L2_30_13 gp_2_30_13 da_uU_L2_30_13 vdd vdd PMIR W=60u L=1u
Mt_uU_L2_30_14 ts_uU_L2_30_14 hv_L1_42 0 0 NMIR W=48.0u L=1u
Mo1_uU_L2_30_14 da_uU_L2_30_14 d1bar_L2 ts_uU_L2_30_14 0 NMIR W=20u L=1u
Mo2_uU_L2_30_14 gp_2_30_14 dpre_L2_30 ts_uU_L2_30_14 0 NMIR W=20u L=1u
Mo3_uU_L2_30_14 da_uU_L2_30_14 da_uU_L2_30_14 vdd vdd PMIR W=60u L=1u
Mo4_uU_L2_30_14 gp_2_30_14 da_uU_L2_30_14 vdd vdd PMIR W=60u L=1u
Mt_uU_L2_30_15 ts_uU_L2_30_15 hv_L1_47 0 0 NMIR W=48.0u L=1u
Mo1_uU_L2_30_15 da_uU_L2_30_15 d1bar_L2 ts_uU_L2_30_15 0 NMIR W=20u L=1u
Mo2_uU_L2_30_15 gp_2_30_15 dpre_L2_30 ts_uU_L2_30_15 0 NMIR W=20u L=1u
Mo3_uU_L2_30_15 da_uU_L2_30_15 da_uU_L2_30_15 vdd vdd PMIR W=60u L=1u
Mo4_uU_L2_30_15 gp_2_30_15 da_uU_L2_30_15 vdd vdd PMIR W=60u L=1u
Mt_uU_L2_31_0 ts_uU_L2_31_0 hv_L1_1 0 0 NMIR W=48.0u L=1u
Mo1_uU_L2_31_0 da_uU_L2_31_0 d1bar_L2 ts_uU_L2_31_0 0 NMIR W=20u L=1u
Mo2_uU_L2_31_0 gp_2_31_0 dpre_L2_31 ts_uU_L2_31_0 0 NMIR W=20u L=1u
Mo3_uU_L2_31_0 da_uU_L2_31_0 da_uU_L2_31_0 vdd vdd PMIR W=60u L=1u
Mo4_uU_L2_31_0 gp_2_31_0 da_uU_L2_31_0 vdd vdd PMIR W=60u L=1u
Mt_uU_L2_31_1 ts_uU_L2_31_1 hv_L1_2 0 0 NMIR W=48.0u L=1u
Mo1_uU_L2_31_1 da_uU_L2_31_1 d1bar_L2 ts_uU_L2_31_1 0 NMIR W=20u L=1u
Mo2_uU_L2_31_1 gp_2_31_1 dpre_L2_31 ts_uU_L2_31_1 0 NMIR W=20u L=1u
Mo3_uU_L2_31_1 da_uU_L2_31_1 da_uU_L2_31_1 vdd vdd PMIR W=60u L=1u
Mo4_uU_L2_31_1 gp_2_31_1 da_uU_L2_31_1 vdd vdd PMIR W=60u L=1u
Mt_uU_L2_31_2 ts_uU_L2_31_2 hv_L1_4 0 0 NMIR W=48.0u L=1u
Mo1_uU_L2_31_2 da_uU_L2_31_2 d1bar_L2 ts_uU_L2_31_2 0 NMIR W=20u L=1u
Mo2_uU_L2_31_2 gp_2_31_2 dpre_L2_31 ts_uU_L2_31_2 0 NMIR W=20u L=1u
Mo3_uU_L2_31_2 da_uU_L2_31_2 da_uU_L2_31_2 vdd vdd PMIR W=60u L=1u
Mo4_uU_L2_31_2 gp_2_31_2 da_uU_L2_31_2 vdd vdd PMIR W=60u L=1u
Mt_uU_L2_31_3 ts_uU_L2_31_3 hv_L1_7 0 0 NMIR W=48.0u L=1u
Mo1_uU_L2_31_3 da_uU_L2_31_3 d1bar_L2 ts_uU_L2_31_3 0 NMIR W=20u L=1u
Mo2_uU_L2_31_3 gp_2_31_3 dpre_L2_31 ts_uU_L2_31_3 0 NMIR W=20u L=1u
Mo3_uU_L2_31_3 da_uU_L2_31_3 da_uU_L2_31_3 vdd vdd PMIR W=60u L=1u
Mo4_uU_L2_31_3 gp_2_31_3 da_uU_L2_31_3 vdd vdd PMIR W=60u L=1u
Mt_uU_L2_31_4 ts_uU_L2_31_4 hv_L1_11 0 0 NMIR W=48.0u L=1u
Mo1_uU_L2_31_4 da_uU_L2_31_4 d1bar_L2 ts_uU_L2_31_4 0 NMIR W=20u L=1u
Mo2_uU_L2_31_4 gp_2_31_4 dpre_L2_31 ts_uU_L2_31_4 0 NMIR W=20u L=1u
Mo3_uU_L2_31_4 da_uU_L2_31_4 da_uU_L2_31_4 vdd vdd PMIR W=60u L=1u
Mo4_uU_L2_31_4 gp_2_31_4 da_uU_L2_31_4 vdd vdd PMIR W=60u L=1u
Mt_uU_L2_31_5 ts_uU_L2_31_5 hv_L1_12 0 0 NMIR W=48.0u L=1u
Mo1_uU_L2_31_5 da_uU_L2_31_5 d1bar_L2 ts_uU_L2_31_5 0 NMIR W=20u L=1u
Mo2_uU_L2_31_5 gp_2_31_5 dpre_L2_31 ts_uU_L2_31_5 0 NMIR W=20u L=1u
Mo3_uU_L2_31_5 da_uU_L2_31_5 da_uU_L2_31_5 vdd vdd PMIR W=60u L=1u
Mo4_uU_L2_31_5 gp_2_31_5 da_uU_L2_31_5 vdd vdd PMIR W=60u L=1u
Mt_uU_L2_31_6 ts_uU_L2_31_6 hv_L1_13 0 0 NMIR W=48.0u L=1u
Mo1_uU_L2_31_6 da_uU_L2_31_6 d1bar_L2 ts_uU_L2_31_6 0 NMIR W=20u L=1u
Mo2_uU_L2_31_6 gp_2_31_6 dpre_L2_31 ts_uU_L2_31_6 0 NMIR W=20u L=1u
Mo3_uU_L2_31_6 da_uU_L2_31_6 da_uU_L2_31_6 vdd vdd PMIR W=60u L=1u
Mo4_uU_L2_31_6 gp_2_31_6 da_uU_L2_31_6 vdd vdd PMIR W=60u L=1u
Mt_uU_L2_31_7 ts_uU_L2_31_7 hv_L1_18 0 0 NMIR W=48.0u L=1u
Mo1_uU_L2_31_7 da_uU_L2_31_7 d1bar_L2 ts_uU_L2_31_7 0 NMIR W=20u L=1u
Mo2_uU_L2_31_7 gp_2_31_7 dpre_L2_31 ts_uU_L2_31_7 0 NMIR W=20u L=1u
Mo3_uU_L2_31_7 da_uU_L2_31_7 da_uU_L2_31_7 vdd vdd PMIR W=60u L=1u
Mo4_uU_L2_31_7 gp_2_31_7 da_uU_L2_31_7 vdd vdd PMIR W=60u L=1u
Mt_uU_L2_31_8 ts_uU_L2_31_8 hv_L1_27 0 0 NMIR W=48.0u L=1u
Mo1_uU_L2_31_8 da_uU_L2_31_8 d1bar_L2 ts_uU_L2_31_8 0 NMIR W=20u L=1u
Mo2_uU_L2_31_8 gp_2_31_8 dpre_L2_31 ts_uU_L2_31_8 0 NMIR W=20u L=1u
Mo3_uU_L2_31_8 da_uU_L2_31_8 da_uU_L2_31_8 vdd vdd PMIR W=60u L=1u
Mo4_uU_L2_31_8 gp_2_31_8 da_uU_L2_31_8 vdd vdd PMIR W=60u L=1u
Mt_uU_L2_31_9 ts_uU_L2_31_9 hv_L1_28 0 0 NMIR W=48.0u L=1u
Mo1_uU_L2_31_9 da_uU_L2_31_9 d1bar_L2 ts_uU_L2_31_9 0 NMIR W=20u L=1u
Mo2_uU_L2_31_9 gp_2_31_9 dpre_L2_31 ts_uU_L2_31_9 0 NMIR W=20u L=1u
Mo3_uU_L2_31_9 da_uU_L2_31_9 da_uU_L2_31_9 vdd vdd PMIR W=60u L=1u
Mo4_uU_L2_31_9 gp_2_31_9 da_uU_L2_31_9 vdd vdd PMIR W=60u L=1u
Mt_uU_L2_31_10 ts_uU_L2_31_10 hv_L1_29 0 0 NMIR W=48.0u L=1u
Mo1_uU_L2_31_10 da_uU_L2_31_10 d1bar_L2 ts_uU_L2_31_10 0 NMIR W=20u L=1u
Mo2_uU_L2_31_10 gp_2_31_10 dpre_L2_31 ts_uU_L2_31_10 0 NMIR W=20u L=1u
Mo3_uU_L2_31_10 da_uU_L2_31_10 da_uU_L2_31_10 vdd vdd PMIR W=60u L=1u
Mo4_uU_L2_31_10 gp_2_31_10 da_uU_L2_31_10 vdd vdd PMIR W=60u L=1u
Mt_uU_L2_31_11 ts_uU_L2_31_11 hv_L1_30 0 0 NMIR W=48.0u L=1u
Mo1_uU_L2_31_11 da_uU_L2_31_11 d1bar_L2 ts_uU_L2_31_11 0 NMIR W=20u L=1u
Mo2_uU_L2_31_11 gp_2_31_11 dpre_L2_31 ts_uU_L2_31_11 0 NMIR W=20u L=1u
Mo3_uU_L2_31_11 da_uU_L2_31_11 da_uU_L2_31_11 vdd vdd PMIR W=60u L=1u
Mo4_uU_L2_31_11 gp_2_31_11 da_uU_L2_31_11 vdd vdd PMIR W=60u L=1u
Mt_uU_L2_31_12 ts_uU_L2_31_12 hv_L1_33 0 0 NMIR W=48.0u L=1u
Mo1_uU_L2_31_12 da_uU_L2_31_12 d1bar_L2 ts_uU_L2_31_12 0 NMIR W=20u L=1u
Mo2_uU_L2_31_12 gp_2_31_12 dpre_L2_31 ts_uU_L2_31_12 0 NMIR W=20u L=1u
Mo3_uU_L2_31_12 da_uU_L2_31_12 da_uU_L2_31_12 vdd vdd PMIR W=60u L=1u
Mo4_uU_L2_31_12 gp_2_31_12 da_uU_L2_31_12 vdd vdd PMIR W=60u L=1u
Mt_uU_L2_31_13 ts_uU_L2_31_13 hv_L1_38 0 0 NMIR W=48.0u L=1u
Mo1_uU_L2_31_13 da_uU_L2_31_13 d1bar_L2 ts_uU_L2_31_13 0 NMIR W=20u L=1u
Mo2_uU_L2_31_13 gp_2_31_13 dpre_L2_31 ts_uU_L2_31_13 0 NMIR W=20u L=1u
Mo3_uU_L2_31_13 da_uU_L2_31_13 da_uU_L2_31_13 vdd vdd PMIR W=60u L=1u
Mo4_uU_L2_31_13 gp_2_31_13 da_uU_L2_31_13 vdd vdd PMIR W=60u L=1u
Mt_uU_L2_31_14 ts_uU_L2_31_14 hv_L1_45 0 0 NMIR W=48.0u L=1u
Mo1_uU_L2_31_14 da_uU_L2_31_14 d1bar_L2 ts_uU_L2_31_14 0 NMIR W=20u L=1u
Mo2_uU_L2_31_14 gp_2_31_14 dpre_L2_31 ts_uU_L2_31_14 0 NMIR W=20u L=1u
Mo3_uU_L2_31_14 da_uU_L2_31_14 da_uU_L2_31_14 vdd vdd PMIR W=60u L=1u
Mo4_uU_L2_31_14 gp_2_31_14 da_uU_L2_31_14 vdd vdd PMIR W=60u L=1u
Mt_uU_L2_31_15 ts_uU_L2_31_15 hv_L1_46 0 0 NMIR W=48.0u L=1u
Mo1_uU_L2_31_15 da_uU_L2_31_15 d1bar_L2 ts_uU_L2_31_15 0 NMIR W=20u L=1u
Mo2_uU_L2_31_15 gp_2_31_15 dpre_L2_31 ts_uU_L2_31_15 0 NMIR W=20u L=1u
Mo3_uU_L2_31_15 da_uU_L2_31_15 da_uU_L2_31_15 vdd vdd PMIR W=60u L=1u
Mo4_uU_L2_31_15 gp_2_31_15 da_uU_L2_31_15 vdd vdd PMIR W=60u L=1u
Mt_uU_L2_32_0 ts_uU_L2_32_0 hv_L1_1 0 0 NMIR W=48.0u L=1u
Mo1_uU_L2_32_0 da_uU_L2_32_0 d1bar_L2 ts_uU_L2_32_0 0 NMIR W=20u L=1u
Mo2_uU_L2_32_0 gp_2_32_0 dpre_L2_32 ts_uU_L2_32_0 0 NMIR W=20u L=1u
Mo3_uU_L2_32_0 da_uU_L2_32_0 da_uU_L2_32_0 vdd vdd PMIR W=60u L=1u
Mo4_uU_L2_32_0 gp_2_32_0 da_uU_L2_32_0 vdd vdd PMIR W=60u L=1u
Mt_uU_L2_32_1 ts_uU_L2_32_1 hv_L1_2 0 0 NMIR W=48.0u L=1u
Mo1_uU_L2_32_1 da_uU_L2_32_1 d1bar_L2 ts_uU_L2_32_1 0 NMIR W=20u L=1u
Mo2_uU_L2_32_1 gp_2_32_1 dpre_L2_32 ts_uU_L2_32_1 0 NMIR W=20u L=1u
Mo3_uU_L2_32_1 da_uU_L2_32_1 da_uU_L2_32_1 vdd vdd PMIR W=60u L=1u
Mo4_uU_L2_32_1 gp_2_32_1 da_uU_L2_32_1 vdd vdd PMIR W=60u L=1u
Mt_uU_L2_32_2 ts_uU_L2_32_2 hv_L1_6 0 0 NMIR W=48.0u L=1u
Mo1_uU_L2_32_2 da_uU_L2_32_2 d1bar_L2 ts_uU_L2_32_2 0 NMIR W=20u L=1u
Mo2_uU_L2_32_2 gp_2_32_2 dpre_L2_32 ts_uU_L2_32_2 0 NMIR W=20u L=1u
Mo3_uU_L2_32_2 da_uU_L2_32_2 da_uU_L2_32_2 vdd vdd PMIR W=60u L=1u
Mo4_uU_L2_32_2 gp_2_32_2 da_uU_L2_32_2 vdd vdd PMIR W=60u L=1u
Mt_uU_L2_32_3 ts_uU_L2_32_3 hv_L1_13 0 0 NMIR W=48.0u L=1u
Mo1_uU_L2_32_3 da_uU_L2_32_3 d1bar_L2 ts_uU_L2_32_3 0 NMIR W=20u L=1u
Mo2_uU_L2_32_3 gp_2_32_3 dpre_L2_32 ts_uU_L2_32_3 0 NMIR W=20u L=1u
Mo3_uU_L2_32_3 da_uU_L2_32_3 da_uU_L2_32_3 vdd vdd PMIR W=60u L=1u
Mo4_uU_L2_32_3 gp_2_32_3 da_uU_L2_32_3 vdd vdd PMIR W=60u L=1u
Mt_uU_L2_32_4 ts_uU_L2_32_4 hv_L1_15 0 0 NMIR W=48.0u L=1u
Mo1_uU_L2_32_4 da_uU_L2_32_4 d1bar_L2 ts_uU_L2_32_4 0 NMIR W=20u L=1u
Mo2_uU_L2_32_4 gp_2_32_4 dpre_L2_32 ts_uU_L2_32_4 0 NMIR W=20u L=1u
Mo3_uU_L2_32_4 da_uU_L2_32_4 da_uU_L2_32_4 vdd vdd PMIR W=60u L=1u
Mo4_uU_L2_32_4 gp_2_32_4 da_uU_L2_32_4 vdd vdd PMIR W=60u L=1u
Mt_uU_L2_32_5 ts_uU_L2_32_5 hv_L1_25 0 0 NMIR W=48.0u L=1u
Mo1_uU_L2_32_5 da_uU_L2_32_5 d1bar_L2 ts_uU_L2_32_5 0 NMIR W=20u L=1u
Mo2_uU_L2_32_5 gp_2_32_5 dpre_L2_32 ts_uU_L2_32_5 0 NMIR W=20u L=1u
Mo3_uU_L2_32_5 da_uU_L2_32_5 da_uU_L2_32_5 vdd vdd PMIR W=60u L=1u
Mo4_uU_L2_32_5 gp_2_32_5 da_uU_L2_32_5 vdd vdd PMIR W=60u L=1u
Mt_uU_L2_32_6 ts_uU_L2_32_6 hv_L1_28 0 0 NMIR W=48.0u L=1u
Mo1_uU_L2_32_6 da_uU_L2_32_6 d1bar_L2 ts_uU_L2_32_6 0 NMIR W=20u L=1u
Mo2_uU_L2_32_6 gp_2_32_6 dpre_L2_32 ts_uU_L2_32_6 0 NMIR W=20u L=1u
Mo3_uU_L2_32_6 da_uU_L2_32_6 da_uU_L2_32_6 vdd vdd PMIR W=60u L=1u
Mo4_uU_L2_32_6 gp_2_32_6 da_uU_L2_32_6 vdd vdd PMIR W=60u L=1u
Mt_uU_L2_32_7 ts_uU_L2_32_7 hv_L1_31 0 0 NMIR W=48.0u L=1u
Mo1_uU_L2_32_7 da_uU_L2_32_7 d1bar_L2 ts_uU_L2_32_7 0 NMIR W=20u L=1u
Mo2_uU_L2_32_7 gp_2_32_7 dpre_L2_32 ts_uU_L2_32_7 0 NMIR W=20u L=1u
Mo3_uU_L2_32_7 da_uU_L2_32_7 da_uU_L2_32_7 vdd vdd PMIR W=60u L=1u
Mo4_uU_L2_32_7 gp_2_32_7 da_uU_L2_32_7 vdd vdd PMIR W=60u L=1u
Mt_uU_L2_32_8 ts_uU_L2_32_8 hv_L1_32 0 0 NMIR W=48.0u L=1u
Mo1_uU_L2_32_8 da_uU_L2_32_8 d1bar_L2 ts_uU_L2_32_8 0 NMIR W=20u L=1u
Mo2_uU_L2_32_8 gp_2_32_8 dpre_L2_32 ts_uU_L2_32_8 0 NMIR W=20u L=1u
Mo3_uU_L2_32_8 da_uU_L2_32_8 da_uU_L2_32_8 vdd vdd PMIR W=60u L=1u
Mo4_uU_L2_32_8 gp_2_32_8 da_uU_L2_32_8 vdd vdd PMIR W=60u L=1u
Mt_uU_L2_32_9 ts_uU_L2_32_9 hv_L1_35 0 0 NMIR W=48.0u L=1u
Mo1_uU_L2_32_9 da_uU_L2_32_9 d1bar_L2 ts_uU_L2_32_9 0 NMIR W=20u L=1u
Mo2_uU_L2_32_9 gp_2_32_9 dpre_L2_32 ts_uU_L2_32_9 0 NMIR W=20u L=1u
Mo3_uU_L2_32_9 da_uU_L2_32_9 da_uU_L2_32_9 vdd vdd PMIR W=60u L=1u
Mo4_uU_L2_32_9 gp_2_32_9 da_uU_L2_32_9 vdd vdd PMIR W=60u L=1u
Mt_uU_L2_32_10 ts_uU_L2_32_10 hv_L1_38 0 0 NMIR W=48.0u L=1u
Mo1_uU_L2_32_10 da_uU_L2_32_10 d1bar_L2 ts_uU_L2_32_10 0 NMIR W=20u L=1u
Mo2_uU_L2_32_10 gp_2_32_10 dpre_L2_32 ts_uU_L2_32_10 0 NMIR W=20u L=1u
Mo3_uU_L2_32_10 da_uU_L2_32_10 da_uU_L2_32_10 vdd vdd PMIR W=60u L=1u
Mo4_uU_L2_32_10 gp_2_32_10 da_uU_L2_32_10 vdd vdd PMIR W=60u L=1u
Mt_uU_L2_32_11 ts_uU_L2_32_11 hv_L1_39 0 0 NMIR W=48.0u L=1u
Mo1_uU_L2_32_11 da_uU_L2_32_11 d1bar_L2 ts_uU_L2_32_11 0 NMIR W=20u L=1u
Mo2_uU_L2_32_11 gp_2_32_11 dpre_L2_32 ts_uU_L2_32_11 0 NMIR W=20u L=1u
Mo3_uU_L2_32_11 da_uU_L2_32_11 da_uU_L2_32_11 vdd vdd PMIR W=60u L=1u
Mo4_uU_L2_32_11 gp_2_32_11 da_uU_L2_32_11 vdd vdd PMIR W=60u L=1u
Mt_uU_L2_32_12 ts_uU_L2_32_12 hv_L1_41 0 0 NMIR W=48.0u L=1u
Mo1_uU_L2_32_12 da_uU_L2_32_12 d1bar_L2 ts_uU_L2_32_12 0 NMIR W=20u L=1u
Mo2_uU_L2_32_12 gp_2_32_12 dpre_L2_32 ts_uU_L2_32_12 0 NMIR W=20u L=1u
Mo3_uU_L2_32_12 da_uU_L2_32_12 da_uU_L2_32_12 vdd vdd PMIR W=60u L=1u
Mo4_uU_L2_32_12 gp_2_32_12 da_uU_L2_32_12 vdd vdd PMIR W=60u L=1u
Mt_uU_L2_32_13 ts_uU_L2_32_13 hv_L1_44 0 0 NMIR W=48.0u L=1u
Mo1_uU_L2_32_13 da_uU_L2_32_13 d1bar_L2 ts_uU_L2_32_13 0 NMIR W=20u L=1u
Mo2_uU_L2_32_13 gp_2_32_13 dpre_L2_32 ts_uU_L2_32_13 0 NMIR W=20u L=1u
Mo3_uU_L2_32_13 da_uU_L2_32_13 da_uU_L2_32_13 vdd vdd PMIR W=60u L=1u
Mo4_uU_L2_32_13 gp_2_32_13 da_uU_L2_32_13 vdd vdd PMIR W=60u L=1u
Mt_uU_L2_32_14 ts_uU_L2_32_14 hv_L1_45 0 0 NMIR W=48.0u L=1u
Mo1_uU_L2_32_14 da_uU_L2_32_14 d1bar_L2 ts_uU_L2_32_14 0 NMIR W=20u L=1u
Mo2_uU_L2_32_14 gp_2_32_14 dpre_L2_32 ts_uU_L2_32_14 0 NMIR W=20u L=1u
Mo3_uU_L2_32_14 da_uU_L2_32_14 da_uU_L2_32_14 vdd vdd PMIR W=60u L=1u
Mo4_uU_L2_32_14 gp_2_32_14 da_uU_L2_32_14 vdd vdd PMIR W=60u L=1u
Mt_uU_L2_32_15 ts_uU_L2_32_15 hv_L1_46 0 0 NMIR W=48.0u L=1u
Mo1_uU_L2_32_15 da_uU_L2_32_15 d1bar_L2 ts_uU_L2_32_15 0 NMIR W=20u L=1u
Mo2_uU_L2_32_15 gp_2_32_15 dpre_L2_32 ts_uU_L2_32_15 0 NMIR W=20u L=1u
Mo3_uU_L2_32_15 da_uU_L2_32_15 da_uU_L2_32_15 vdd vdd PMIR W=60u L=1u
Mo4_uU_L2_32_15 gp_2_32_15 da_uU_L2_32_15 vdd vdd PMIR W=60u L=1u
Mt_uU_L2_33_0 ts_uU_L2_33_0 hv_L1_4 0 0 NMIR W=48.0u L=1u
Mo1_uU_L2_33_0 da_uU_L2_33_0 d1bar_L2 ts_uU_L2_33_0 0 NMIR W=20u L=1u
Mo2_uU_L2_33_0 gp_2_33_0 dpre_L2_33 ts_uU_L2_33_0 0 NMIR W=20u L=1u
Mo3_uU_L2_33_0 da_uU_L2_33_0 da_uU_L2_33_0 vdd vdd PMIR W=60u L=1u
Mo4_uU_L2_33_0 gp_2_33_0 da_uU_L2_33_0 vdd vdd PMIR W=60u L=1u
Mt_uU_L2_33_1 ts_uU_L2_33_1 hv_L1_6 0 0 NMIR W=48.0u L=1u
Mo1_uU_L2_33_1 da_uU_L2_33_1 d1bar_L2 ts_uU_L2_33_1 0 NMIR W=20u L=1u
Mo2_uU_L2_33_1 gp_2_33_1 dpre_L2_33 ts_uU_L2_33_1 0 NMIR W=20u L=1u
Mo3_uU_L2_33_1 da_uU_L2_33_1 da_uU_L2_33_1 vdd vdd PMIR W=60u L=1u
Mo4_uU_L2_33_1 gp_2_33_1 da_uU_L2_33_1 vdd vdd PMIR W=60u L=1u
Mt_uU_L2_33_2 ts_uU_L2_33_2 hv_L1_9 0 0 NMIR W=48.0u L=1u
Mo1_uU_L2_33_2 da_uU_L2_33_2 d1bar_L2 ts_uU_L2_33_2 0 NMIR W=20u L=1u
Mo2_uU_L2_33_2 gp_2_33_2 dpre_L2_33 ts_uU_L2_33_2 0 NMIR W=20u L=1u
Mo3_uU_L2_33_2 da_uU_L2_33_2 da_uU_L2_33_2 vdd vdd PMIR W=60u L=1u
Mo4_uU_L2_33_2 gp_2_33_2 da_uU_L2_33_2 vdd vdd PMIR W=60u L=1u
Mt_uU_L2_33_3 ts_uU_L2_33_3 hv_L1_12 0 0 NMIR W=48.0u L=1u
Mo1_uU_L2_33_3 da_uU_L2_33_3 d1bar_L2 ts_uU_L2_33_3 0 NMIR W=20u L=1u
Mo2_uU_L2_33_3 gp_2_33_3 dpre_L2_33 ts_uU_L2_33_3 0 NMIR W=20u L=1u
Mo3_uU_L2_33_3 da_uU_L2_33_3 da_uU_L2_33_3 vdd vdd PMIR W=60u L=1u
Mo4_uU_L2_33_3 gp_2_33_3 da_uU_L2_33_3 vdd vdd PMIR W=60u L=1u
Mt_uU_L2_33_4 ts_uU_L2_33_4 hv_L1_13 0 0 NMIR W=48.0u L=1u
Mo1_uU_L2_33_4 da_uU_L2_33_4 d1bar_L2 ts_uU_L2_33_4 0 NMIR W=20u L=1u
Mo2_uU_L2_33_4 gp_2_33_4 dpre_L2_33 ts_uU_L2_33_4 0 NMIR W=20u L=1u
Mo3_uU_L2_33_4 da_uU_L2_33_4 da_uU_L2_33_4 vdd vdd PMIR W=60u L=1u
Mo4_uU_L2_33_4 gp_2_33_4 da_uU_L2_33_4 vdd vdd PMIR W=60u L=1u
Mt_uU_L2_33_5 ts_uU_L2_33_5 hv_L1_18 0 0 NMIR W=48.0u L=1u
Mo1_uU_L2_33_5 da_uU_L2_33_5 d1bar_L2 ts_uU_L2_33_5 0 NMIR W=20u L=1u
Mo2_uU_L2_33_5 gp_2_33_5 dpre_L2_33 ts_uU_L2_33_5 0 NMIR W=20u L=1u
Mo3_uU_L2_33_5 da_uU_L2_33_5 da_uU_L2_33_5 vdd vdd PMIR W=60u L=1u
Mo4_uU_L2_33_5 gp_2_33_5 da_uU_L2_33_5 vdd vdd PMIR W=60u L=1u
Mt_uU_L2_33_6 ts_uU_L2_33_6 hv_L1_20 0 0 NMIR W=48.0u L=1u
Mo1_uU_L2_33_6 da_uU_L2_33_6 d1bar_L2 ts_uU_L2_33_6 0 NMIR W=20u L=1u
Mo2_uU_L2_33_6 gp_2_33_6 dpre_L2_33 ts_uU_L2_33_6 0 NMIR W=20u L=1u
Mo3_uU_L2_33_6 da_uU_L2_33_6 da_uU_L2_33_6 vdd vdd PMIR W=60u L=1u
Mo4_uU_L2_33_6 gp_2_33_6 da_uU_L2_33_6 vdd vdd PMIR W=60u L=1u
Mt_uU_L2_33_7 ts_uU_L2_33_7 hv_L1_25 0 0 NMIR W=48.0u L=1u
Mo1_uU_L2_33_7 da_uU_L2_33_7 d1bar_L2 ts_uU_L2_33_7 0 NMIR W=20u L=1u
Mo2_uU_L2_33_7 gp_2_33_7 dpre_L2_33 ts_uU_L2_33_7 0 NMIR W=20u L=1u
Mo3_uU_L2_33_7 da_uU_L2_33_7 da_uU_L2_33_7 vdd vdd PMIR W=60u L=1u
Mo4_uU_L2_33_7 gp_2_33_7 da_uU_L2_33_7 vdd vdd PMIR W=60u L=1u
Mt_uU_L2_33_8 ts_uU_L2_33_8 hv_L1_30 0 0 NMIR W=48.0u L=1u
Mo1_uU_L2_33_8 da_uU_L2_33_8 d1bar_L2 ts_uU_L2_33_8 0 NMIR W=20u L=1u
Mo2_uU_L2_33_8 gp_2_33_8 dpre_L2_33 ts_uU_L2_33_8 0 NMIR W=20u L=1u
Mo3_uU_L2_33_8 da_uU_L2_33_8 da_uU_L2_33_8 vdd vdd PMIR W=60u L=1u
Mo4_uU_L2_33_8 gp_2_33_8 da_uU_L2_33_8 vdd vdd PMIR W=60u L=1u
Mt_uU_L2_33_9 ts_uU_L2_33_9 hv_L1_32 0 0 NMIR W=48.0u L=1u
Mo1_uU_L2_33_9 da_uU_L2_33_9 d1bar_L2 ts_uU_L2_33_9 0 NMIR W=20u L=1u
Mo2_uU_L2_33_9 gp_2_33_9 dpre_L2_33 ts_uU_L2_33_9 0 NMIR W=20u L=1u
Mo3_uU_L2_33_9 da_uU_L2_33_9 da_uU_L2_33_9 vdd vdd PMIR W=60u L=1u
Mo4_uU_L2_33_9 gp_2_33_9 da_uU_L2_33_9 vdd vdd PMIR W=60u L=1u
Mt_uU_L2_33_10 ts_uU_L2_33_10 hv_L1_34 0 0 NMIR W=48.0u L=1u
Mo1_uU_L2_33_10 da_uU_L2_33_10 d1bar_L2 ts_uU_L2_33_10 0 NMIR W=20u L=1u
Mo2_uU_L2_33_10 gp_2_33_10 dpre_L2_33 ts_uU_L2_33_10 0 NMIR W=20u L=1u
Mo3_uU_L2_33_10 da_uU_L2_33_10 da_uU_L2_33_10 vdd vdd PMIR W=60u L=1u
Mo4_uU_L2_33_10 gp_2_33_10 da_uU_L2_33_10 vdd vdd PMIR W=60u L=1u
Mt_uU_L2_33_11 ts_uU_L2_33_11 hv_L1_37 0 0 NMIR W=48.0u L=1u
Mo1_uU_L2_33_11 da_uU_L2_33_11 d1bar_L2 ts_uU_L2_33_11 0 NMIR W=20u L=1u
Mo2_uU_L2_33_11 gp_2_33_11 dpre_L2_33 ts_uU_L2_33_11 0 NMIR W=20u L=1u
Mo3_uU_L2_33_11 da_uU_L2_33_11 da_uU_L2_33_11 vdd vdd PMIR W=60u L=1u
Mo4_uU_L2_33_11 gp_2_33_11 da_uU_L2_33_11 vdd vdd PMIR W=60u L=1u
Mt_uU_L2_33_12 ts_uU_L2_33_12 hv_L1_39 0 0 NMIR W=48.0u L=1u
Mo1_uU_L2_33_12 da_uU_L2_33_12 d1bar_L2 ts_uU_L2_33_12 0 NMIR W=20u L=1u
Mo2_uU_L2_33_12 gp_2_33_12 dpre_L2_33 ts_uU_L2_33_12 0 NMIR W=20u L=1u
Mo3_uU_L2_33_12 da_uU_L2_33_12 da_uU_L2_33_12 vdd vdd PMIR W=60u L=1u
Mo4_uU_L2_33_12 gp_2_33_12 da_uU_L2_33_12 vdd vdd PMIR W=60u L=1u
Mt_uU_L2_33_13 ts_uU_L2_33_13 hv_L1_43 0 0 NMIR W=48.0u L=1u
Mo1_uU_L2_33_13 da_uU_L2_33_13 d1bar_L2 ts_uU_L2_33_13 0 NMIR W=20u L=1u
Mo2_uU_L2_33_13 gp_2_33_13 dpre_L2_33 ts_uU_L2_33_13 0 NMIR W=20u L=1u
Mo3_uU_L2_33_13 da_uU_L2_33_13 da_uU_L2_33_13 vdd vdd PMIR W=60u L=1u
Mo4_uU_L2_33_13 gp_2_33_13 da_uU_L2_33_13 vdd vdd PMIR W=60u L=1u
Mt_uU_L2_33_14 ts_uU_L2_33_14 hv_L1_44 0 0 NMIR W=48.0u L=1u
Mo1_uU_L2_33_14 da_uU_L2_33_14 d1bar_L2 ts_uU_L2_33_14 0 NMIR W=20u L=1u
Mo2_uU_L2_33_14 gp_2_33_14 dpre_L2_33 ts_uU_L2_33_14 0 NMIR W=20u L=1u
Mo3_uU_L2_33_14 da_uU_L2_33_14 da_uU_L2_33_14 vdd vdd PMIR W=60u L=1u
Mo4_uU_L2_33_14 gp_2_33_14 da_uU_L2_33_14 vdd vdd PMIR W=60u L=1u
Mt_uU_L2_33_15 ts_uU_L2_33_15 hv_L1_47 0 0 NMIR W=48.0u L=1u
Mo1_uU_L2_33_15 da_uU_L2_33_15 d1bar_L2 ts_uU_L2_33_15 0 NMIR W=20u L=1u
Mo2_uU_L2_33_15 gp_2_33_15 dpre_L2_33 ts_uU_L2_33_15 0 NMIR W=20u L=1u
Mo3_uU_L2_33_15 da_uU_L2_33_15 da_uU_L2_33_15 vdd vdd PMIR W=60u L=1u
Mo4_uU_L2_33_15 gp_2_33_15 da_uU_L2_33_15 vdd vdd PMIR W=60u L=1u
Mt_uU_L2_34_0 ts_uU_L2_34_0 hv_L1_1 0 0 NMIR W=48.0u L=1u
Mo1_uU_L2_34_0 da_uU_L2_34_0 d1bar_L2 ts_uU_L2_34_0 0 NMIR W=20u L=1u
Mo2_uU_L2_34_0 gp_2_34_0 dpre_L2_34 ts_uU_L2_34_0 0 NMIR W=20u L=1u
Mo3_uU_L2_34_0 da_uU_L2_34_0 da_uU_L2_34_0 vdd vdd PMIR W=60u L=1u
Mo4_uU_L2_34_0 gp_2_34_0 da_uU_L2_34_0 vdd vdd PMIR W=60u L=1u
Mt_uU_L2_34_1 ts_uU_L2_34_1 hv_L1_2 0 0 NMIR W=48.0u L=1u
Mo1_uU_L2_34_1 da_uU_L2_34_1 d1bar_L2 ts_uU_L2_34_1 0 NMIR W=20u L=1u
Mo2_uU_L2_34_1 gp_2_34_1 dpre_L2_34 ts_uU_L2_34_1 0 NMIR W=20u L=1u
Mo3_uU_L2_34_1 da_uU_L2_34_1 da_uU_L2_34_1 vdd vdd PMIR W=60u L=1u
Mo4_uU_L2_34_1 gp_2_34_1 da_uU_L2_34_1 vdd vdd PMIR W=60u L=1u
Mt_uU_L2_34_2 ts_uU_L2_34_2 hv_L1_3 0 0 NMIR W=48.0u L=1u
Mo1_uU_L2_34_2 da_uU_L2_34_2 d1bar_L2 ts_uU_L2_34_2 0 NMIR W=20u L=1u
Mo2_uU_L2_34_2 gp_2_34_2 dpre_L2_34 ts_uU_L2_34_2 0 NMIR W=20u L=1u
Mo3_uU_L2_34_2 da_uU_L2_34_2 da_uU_L2_34_2 vdd vdd PMIR W=60u L=1u
Mo4_uU_L2_34_2 gp_2_34_2 da_uU_L2_34_2 vdd vdd PMIR W=60u L=1u
Mt_uU_L2_34_3 ts_uU_L2_34_3 hv_L1_8 0 0 NMIR W=48.0u L=1u
Mo1_uU_L2_34_3 da_uU_L2_34_3 d1bar_L2 ts_uU_L2_34_3 0 NMIR W=20u L=1u
Mo2_uU_L2_34_3 gp_2_34_3 dpre_L2_34 ts_uU_L2_34_3 0 NMIR W=20u L=1u
Mo3_uU_L2_34_3 da_uU_L2_34_3 da_uU_L2_34_3 vdd vdd PMIR W=60u L=1u
Mo4_uU_L2_34_3 gp_2_34_3 da_uU_L2_34_3 vdd vdd PMIR W=60u L=1u
Mt_uU_L2_34_4 ts_uU_L2_34_4 hv_L1_9 0 0 NMIR W=48.0u L=1u
Mo1_uU_L2_34_4 da_uU_L2_34_4 d1bar_L2 ts_uU_L2_34_4 0 NMIR W=20u L=1u
Mo2_uU_L2_34_4 gp_2_34_4 dpre_L2_34 ts_uU_L2_34_4 0 NMIR W=20u L=1u
Mo3_uU_L2_34_4 da_uU_L2_34_4 da_uU_L2_34_4 vdd vdd PMIR W=60u L=1u
Mo4_uU_L2_34_4 gp_2_34_4 da_uU_L2_34_4 vdd vdd PMIR W=60u L=1u
Mt_uU_L2_34_5 ts_uU_L2_34_5 hv_L1_14 0 0 NMIR W=48.0u L=1u
Mo1_uU_L2_34_5 da_uU_L2_34_5 d1bar_L2 ts_uU_L2_34_5 0 NMIR W=20u L=1u
Mo2_uU_L2_34_5 gp_2_34_5 dpre_L2_34 ts_uU_L2_34_5 0 NMIR W=20u L=1u
Mo3_uU_L2_34_5 da_uU_L2_34_5 da_uU_L2_34_5 vdd vdd PMIR W=60u L=1u
Mo4_uU_L2_34_5 gp_2_34_5 da_uU_L2_34_5 vdd vdd PMIR W=60u L=1u
Mt_uU_L2_34_6 ts_uU_L2_34_6 hv_L1_16 0 0 NMIR W=48.0u L=1u
Mo1_uU_L2_34_6 da_uU_L2_34_6 d1bar_L2 ts_uU_L2_34_6 0 NMIR W=20u L=1u
Mo2_uU_L2_34_6 gp_2_34_6 dpre_L2_34 ts_uU_L2_34_6 0 NMIR W=20u L=1u
Mo3_uU_L2_34_6 da_uU_L2_34_6 da_uU_L2_34_6 vdd vdd PMIR W=60u L=1u
Mo4_uU_L2_34_6 gp_2_34_6 da_uU_L2_34_6 vdd vdd PMIR W=60u L=1u
Mt_uU_L2_34_7 ts_uU_L2_34_7 hv_L1_21 0 0 NMIR W=48.0u L=1u
Mo1_uU_L2_34_7 da_uU_L2_34_7 d1bar_L2 ts_uU_L2_34_7 0 NMIR W=20u L=1u
Mo2_uU_L2_34_7 gp_2_34_7 dpre_L2_34 ts_uU_L2_34_7 0 NMIR W=20u L=1u
Mo3_uU_L2_34_7 da_uU_L2_34_7 da_uU_L2_34_7 vdd vdd PMIR W=60u L=1u
Mo4_uU_L2_34_7 gp_2_34_7 da_uU_L2_34_7 vdd vdd PMIR W=60u L=1u
Mt_uU_L2_34_8 ts_uU_L2_34_8 hv_L1_26 0 0 NMIR W=48.0u L=1u
Mo1_uU_L2_34_8 da_uU_L2_34_8 d1bar_L2 ts_uU_L2_34_8 0 NMIR W=20u L=1u
Mo2_uU_L2_34_8 gp_2_34_8 dpre_L2_34 ts_uU_L2_34_8 0 NMIR W=20u L=1u
Mo3_uU_L2_34_8 da_uU_L2_34_8 da_uU_L2_34_8 vdd vdd PMIR W=60u L=1u
Mo4_uU_L2_34_8 gp_2_34_8 da_uU_L2_34_8 vdd vdd PMIR W=60u L=1u
Mt_uU_L2_34_9 ts_uU_L2_34_9 hv_L1_34 0 0 NMIR W=48.0u L=1u
Mo1_uU_L2_34_9 da_uU_L2_34_9 d1bar_L2 ts_uU_L2_34_9 0 NMIR W=20u L=1u
Mo2_uU_L2_34_9 gp_2_34_9 dpre_L2_34 ts_uU_L2_34_9 0 NMIR W=20u L=1u
Mo3_uU_L2_34_9 da_uU_L2_34_9 da_uU_L2_34_9 vdd vdd PMIR W=60u L=1u
Mo4_uU_L2_34_9 gp_2_34_9 da_uU_L2_34_9 vdd vdd PMIR W=60u L=1u
Mt_uU_L2_34_10 ts_uU_L2_34_10 hv_L1_38 0 0 NMIR W=48.0u L=1u
Mo1_uU_L2_34_10 da_uU_L2_34_10 d1bar_L2 ts_uU_L2_34_10 0 NMIR W=20u L=1u
Mo2_uU_L2_34_10 gp_2_34_10 dpre_L2_34 ts_uU_L2_34_10 0 NMIR W=20u L=1u
Mo3_uU_L2_34_10 da_uU_L2_34_10 da_uU_L2_34_10 vdd vdd PMIR W=60u L=1u
Mo4_uU_L2_34_10 gp_2_34_10 da_uU_L2_34_10 vdd vdd PMIR W=60u L=1u
Mt_uU_L2_34_11 ts_uU_L2_34_11 hv_L1_40 0 0 NMIR W=48.0u L=1u
Mo1_uU_L2_34_11 da_uU_L2_34_11 d1bar_L2 ts_uU_L2_34_11 0 NMIR W=20u L=1u
Mo2_uU_L2_34_11 gp_2_34_11 dpre_L2_34 ts_uU_L2_34_11 0 NMIR W=20u L=1u
Mo3_uU_L2_34_11 da_uU_L2_34_11 da_uU_L2_34_11 vdd vdd PMIR W=60u L=1u
Mo4_uU_L2_34_11 gp_2_34_11 da_uU_L2_34_11 vdd vdd PMIR W=60u L=1u
Mt_uU_L2_34_12 ts_uU_L2_34_12 hv_L1_41 0 0 NMIR W=48.0u L=1u
Mo1_uU_L2_34_12 da_uU_L2_34_12 d1bar_L2 ts_uU_L2_34_12 0 NMIR W=20u L=1u
Mo2_uU_L2_34_12 gp_2_34_12 dpre_L2_34 ts_uU_L2_34_12 0 NMIR W=20u L=1u
Mo3_uU_L2_34_12 da_uU_L2_34_12 da_uU_L2_34_12 vdd vdd PMIR W=60u L=1u
Mo4_uU_L2_34_12 gp_2_34_12 da_uU_L2_34_12 vdd vdd PMIR W=60u L=1u
Mt_uU_L2_34_13 ts_uU_L2_34_13 hv_L1_42 0 0 NMIR W=48.0u L=1u
Mo1_uU_L2_34_13 da_uU_L2_34_13 d1bar_L2 ts_uU_L2_34_13 0 NMIR W=20u L=1u
Mo2_uU_L2_34_13 gp_2_34_13 dpre_L2_34 ts_uU_L2_34_13 0 NMIR W=20u L=1u
Mo3_uU_L2_34_13 da_uU_L2_34_13 da_uU_L2_34_13 vdd vdd PMIR W=60u L=1u
Mo4_uU_L2_34_13 gp_2_34_13 da_uU_L2_34_13 vdd vdd PMIR W=60u L=1u
Mt_uU_L2_34_14 ts_uU_L2_34_14 hv_L1_43 0 0 NMIR W=48.0u L=1u
Mo1_uU_L2_34_14 da_uU_L2_34_14 d1bar_L2 ts_uU_L2_34_14 0 NMIR W=20u L=1u
Mo2_uU_L2_34_14 gp_2_34_14 dpre_L2_34 ts_uU_L2_34_14 0 NMIR W=20u L=1u
Mo3_uU_L2_34_14 da_uU_L2_34_14 da_uU_L2_34_14 vdd vdd PMIR W=60u L=1u
Mo4_uU_L2_34_14 gp_2_34_14 da_uU_L2_34_14 vdd vdd PMIR W=60u L=1u
Mt_uU_L2_34_15 ts_uU_L2_34_15 hv_L1_47 0 0 NMIR W=48.0u L=1u
Mo1_uU_L2_34_15 da_uU_L2_34_15 d1bar_L2 ts_uU_L2_34_15 0 NMIR W=20u L=1u
Mo2_uU_L2_34_15 gp_2_34_15 dpre_L2_34 ts_uU_L2_34_15 0 NMIR W=20u L=1u
Mo3_uU_L2_34_15 da_uU_L2_34_15 da_uU_L2_34_15 vdd vdd PMIR W=60u L=1u
Mo4_uU_L2_34_15 gp_2_34_15 da_uU_L2_34_15 vdd vdd PMIR W=60u L=1u
Mt_uU_L2_35_0 ts_uU_L2_35_0 hv_L1_1 0 0 NMIR W=48.0u L=1u
Mo1_uU_L2_35_0 da_uU_L2_35_0 d1bar_L2 ts_uU_L2_35_0 0 NMIR W=20u L=1u
Mo2_uU_L2_35_0 gp_2_35_0 dpre_L2_35 ts_uU_L2_35_0 0 NMIR W=20u L=1u
Mo3_uU_L2_35_0 da_uU_L2_35_0 da_uU_L2_35_0 vdd vdd PMIR W=60u L=1u
Mo4_uU_L2_35_0 gp_2_35_0 da_uU_L2_35_0 vdd vdd PMIR W=60u L=1u
Mt_uU_L2_35_1 ts_uU_L2_35_1 hv_L1_6 0 0 NMIR W=48.0u L=1u
Mo1_uU_L2_35_1 da_uU_L2_35_1 d1bar_L2 ts_uU_L2_35_1 0 NMIR W=20u L=1u
Mo2_uU_L2_35_1 gp_2_35_1 dpre_L2_35 ts_uU_L2_35_1 0 NMIR W=20u L=1u
Mo3_uU_L2_35_1 da_uU_L2_35_1 da_uU_L2_35_1 vdd vdd PMIR W=60u L=1u
Mo4_uU_L2_35_1 gp_2_35_1 da_uU_L2_35_1 vdd vdd PMIR W=60u L=1u
Mt_uU_L2_35_2 ts_uU_L2_35_2 hv_L1_8 0 0 NMIR W=48.0u L=1u
Mo1_uU_L2_35_2 da_uU_L2_35_2 d1bar_L2 ts_uU_L2_35_2 0 NMIR W=20u L=1u
Mo2_uU_L2_35_2 gp_2_35_2 dpre_L2_35 ts_uU_L2_35_2 0 NMIR W=20u L=1u
Mo3_uU_L2_35_2 da_uU_L2_35_2 da_uU_L2_35_2 vdd vdd PMIR W=60u L=1u
Mo4_uU_L2_35_2 gp_2_35_2 da_uU_L2_35_2 vdd vdd PMIR W=60u L=1u
Mt_uU_L2_35_3 ts_uU_L2_35_3 hv_L1_12 0 0 NMIR W=48.0u L=1u
Mo1_uU_L2_35_3 da_uU_L2_35_3 d1bar_L2 ts_uU_L2_35_3 0 NMIR W=20u L=1u
Mo2_uU_L2_35_3 gp_2_35_3 dpre_L2_35 ts_uU_L2_35_3 0 NMIR W=20u L=1u
Mo3_uU_L2_35_3 da_uU_L2_35_3 da_uU_L2_35_3 vdd vdd PMIR W=60u L=1u
Mo4_uU_L2_35_3 gp_2_35_3 da_uU_L2_35_3 vdd vdd PMIR W=60u L=1u
Mt_uU_L2_35_4 ts_uU_L2_35_4 hv_L1_18 0 0 NMIR W=48.0u L=1u
Mo1_uU_L2_35_4 da_uU_L2_35_4 d1bar_L2 ts_uU_L2_35_4 0 NMIR W=20u L=1u
Mo2_uU_L2_35_4 gp_2_35_4 dpre_L2_35 ts_uU_L2_35_4 0 NMIR W=20u L=1u
Mo3_uU_L2_35_4 da_uU_L2_35_4 da_uU_L2_35_4 vdd vdd PMIR W=60u L=1u
Mo4_uU_L2_35_4 gp_2_35_4 da_uU_L2_35_4 vdd vdd PMIR W=60u L=1u
Mt_uU_L2_35_5 ts_uU_L2_35_5 hv_L1_21 0 0 NMIR W=48.0u L=1u
Mo1_uU_L2_35_5 da_uU_L2_35_5 d1bar_L2 ts_uU_L2_35_5 0 NMIR W=20u L=1u
Mo2_uU_L2_35_5 gp_2_35_5 dpre_L2_35 ts_uU_L2_35_5 0 NMIR W=20u L=1u
Mo3_uU_L2_35_5 da_uU_L2_35_5 da_uU_L2_35_5 vdd vdd PMIR W=60u L=1u
Mo4_uU_L2_35_5 gp_2_35_5 da_uU_L2_35_5 vdd vdd PMIR W=60u L=1u
Mt_uU_L2_35_6 ts_uU_L2_35_6 hv_L1_24 0 0 NMIR W=48.0u L=1u
Mo1_uU_L2_35_6 da_uU_L2_35_6 d1bar_L2 ts_uU_L2_35_6 0 NMIR W=20u L=1u
Mo2_uU_L2_35_6 gp_2_35_6 dpre_L2_35 ts_uU_L2_35_6 0 NMIR W=20u L=1u
Mo3_uU_L2_35_6 da_uU_L2_35_6 da_uU_L2_35_6 vdd vdd PMIR W=60u L=1u
Mo4_uU_L2_35_6 gp_2_35_6 da_uU_L2_35_6 vdd vdd PMIR W=60u L=1u
Mt_uU_L2_35_7 ts_uU_L2_35_7 hv_L1_25 0 0 NMIR W=48.0u L=1u
Mo1_uU_L2_35_7 da_uU_L2_35_7 d1bar_L2 ts_uU_L2_35_7 0 NMIR W=20u L=1u
Mo2_uU_L2_35_7 gp_2_35_7 dpre_L2_35 ts_uU_L2_35_7 0 NMIR W=20u L=1u
Mo3_uU_L2_35_7 da_uU_L2_35_7 da_uU_L2_35_7 vdd vdd PMIR W=60u L=1u
Mo4_uU_L2_35_7 gp_2_35_7 da_uU_L2_35_7 vdd vdd PMIR W=60u L=1u
Mt_uU_L2_35_8 ts_uU_L2_35_8 hv_L1_26 0 0 NMIR W=48.0u L=1u
Mo1_uU_L2_35_8 da_uU_L2_35_8 d1bar_L2 ts_uU_L2_35_8 0 NMIR W=20u L=1u
Mo2_uU_L2_35_8 gp_2_35_8 dpre_L2_35 ts_uU_L2_35_8 0 NMIR W=20u L=1u
Mo3_uU_L2_35_8 da_uU_L2_35_8 da_uU_L2_35_8 vdd vdd PMIR W=60u L=1u
Mo4_uU_L2_35_8 gp_2_35_8 da_uU_L2_35_8 vdd vdd PMIR W=60u L=1u
Mt_uU_L2_35_9 ts_uU_L2_35_9 hv_L1_31 0 0 NMIR W=48.0u L=1u
Mo1_uU_L2_35_9 da_uU_L2_35_9 d1bar_L2 ts_uU_L2_35_9 0 NMIR W=20u L=1u
Mo2_uU_L2_35_9 gp_2_35_9 dpre_L2_35 ts_uU_L2_35_9 0 NMIR W=20u L=1u
Mo3_uU_L2_35_9 da_uU_L2_35_9 da_uU_L2_35_9 vdd vdd PMIR W=60u L=1u
Mo4_uU_L2_35_9 gp_2_35_9 da_uU_L2_35_9 vdd vdd PMIR W=60u L=1u
Mt_uU_L2_35_10 ts_uU_L2_35_10 hv_L1_36 0 0 NMIR W=48.0u L=1u
Mo1_uU_L2_35_10 da_uU_L2_35_10 d1bar_L2 ts_uU_L2_35_10 0 NMIR W=20u L=1u
Mo2_uU_L2_35_10 gp_2_35_10 dpre_L2_35 ts_uU_L2_35_10 0 NMIR W=20u L=1u
Mo3_uU_L2_35_10 da_uU_L2_35_10 da_uU_L2_35_10 vdd vdd PMIR W=60u L=1u
Mo4_uU_L2_35_10 gp_2_35_10 da_uU_L2_35_10 vdd vdd PMIR W=60u L=1u
Mt_uU_L2_35_11 ts_uU_L2_35_11 hv_L1_38 0 0 NMIR W=48.0u L=1u
Mo1_uU_L2_35_11 da_uU_L2_35_11 d1bar_L2 ts_uU_L2_35_11 0 NMIR W=20u L=1u
Mo2_uU_L2_35_11 gp_2_35_11 dpre_L2_35 ts_uU_L2_35_11 0 NMIR W=20u L=1u
Mo3_uU_L2_35_11 da_uU_L2_35_11 da_uU_L2_35_11 vdd vdd PMIR W=60u L=1u
Mo4_uU_L2_35_11 gp_2_35_11 da_uU_L2_35_11 vdd vdd PMIR W=60u L=1u
Mt_uU_L2_35_12 ts_uU_L2_35_12 hv_L1_39 0 0 NMIR W=48.0u L=1u
Mo1_uU_L2_35_12 da_uU_L2_35_12 d1bar_L2 ts_uU_L2_35_12 0 NMIR W=20u L=1u
Mo2_uU_L2_35_12 gp_2_35_12 dpre_L2_35 ts_uU_L2_35_12 0 NMIR W=20u L=1u
Mo3_uU_L2_35_12 da_uU_L2_35_12 da_uU_L2_35_12 vdd vdd PMIR W=60u L=1u
Mo4_uU_L2_35_12 gp_2_35_12 da_uU_L2_35_12 vdd vdd PMIR W=60u L=1u
Mt_uU_L2_35_13 ts_uU_L2_35_13 hv_L1_41 0 0 NMIR W=48.0u L=1u
Mo1_uU_L2_35_13 da_uU_L2_35_13 d1bar_L2 ts_uU_L2_35_13 0 NMIR W=20u L=1u
Mo2_uU_L2_35_13 gp_2_35_13 dpre_L2_35 ts_uU_L2_35_13 0 NMIR W=20u L=1u
Mo3_uU_L2_35_13 da_uU_L2_35_13 da_uU_L2_35_13 vdd vdd PMIR W=60u L=1u
Mo4_uU_L2_35_13 gp_2_35_13 da_uU_L2_35_13 vdd vdd PMIR W=60u L=1u
Mt_uU_L2_35_14 ts_uU_L2_35_14 hv_L1_42 0 0 NMIR W=48.0u L=1u
Mo1_uU_L2_35_14 da_uU_L2_35_14 d1bar_L2 ts_uU_L2_35_14 0 NMIR W=20u L=1u
Mo2_uU_L2_35_14 gp_2_35_14 dpre_L2_35 ts_uU_L2_35_14 0 NMIR W=20u L=1u
Mo3_uU_L2_35_14 da_uU_L2_35_14 da_uU_L2_35_14 vdd vdd PMIR W=60u L=1u
Mo4_uU_L2_35_14 gp_2_35_14 da_uU_L2_35_14 vdd vdd PMIR W=60u L=1u
Mt_uU_L2_35_15 ts_uU_L2_35_15 hv_L1_46 0 0 NMIR W=48.0u L=1u
Mo1_uU_L2_35_15 da_uU_L2_35_15 d1bar_L2 ts_uU_L2_35_15 0 NMIR W=20u L=1u
Mo2_uU_L2_35_15 gp_2_35_15 dpre_L2_35 ts_uU_L2_35_15 0 NMIR W=20u L=1u
Mo3_uU_L2_35_15 da_uU_L2_35_15 da_uU_L2_35_15 vdd vdd PMIR W=60u L=1u
Mo4_uU_L2_35_15 gp_2_35_15 da_uU_L2_35_15 vdd vdd PMIR W=60u L=1u
Mt_uU_L2_36_0 ts_uU_L2_36_0 hv_L1_0 0 0 NMIR W=48.0u L=1u
Mo1_uU_L2_36_0 da_uU_L2_36_0 d1bar_L2 ts_uU_L2_36_0 0 NMIR W=20u L=1u
Mo2_uU_L2_36_0 gp_2_36_0 dpre_L2_36 ts_uU_L2_36_0 0 NMIR W=20u L=1u
Mo3_uU_L2_36_0 da_uU_L2_36_0 da_uU_L2_36_0 vdd vdd PMIR W=60u L=1u
Mo4_uU_L2_36_0 gp_2_36_0 da_uU_L2_36_0 vdd vdd PMIR W=60u L=1u
Mt_uU_L2_36_1 ts_uU_L2_36_1 hv_L1_1 0 0 NMIR W=48.0u L=1u
Mo1_uU_L2_36_1 da_uU_L2_36_1 d1bar_L2 ts_uU_L2_36_1 0 NMIR W=20u L=1u
Mo2_uU_L2_36_1 gp_2_36_1 dpre_L2_36 ts_uU_L2_36_1 0 NMIR W=20u L=1u
Mo3_uU_L2_36_1 da_uU_L2_36_1 da_uU_L2_36_1 vdd vdd PMIR W=60u L=1u
Mo4_uU_L2_36_1 gp_2_36_1 da_uU_L2_36_1 vdd vdd PMIR W=60u L=1u
Mt_uU_L2_36_2 ts_uU_L2_36_2 hv_L1_6 0 0 NMIR W=48.0u L=1u
Mo1_uU_L2_36_2 da_uU_L2_36_2 d1bar_L2 ts_uU_L2_36_2 0 NMIR W=20u L=1u
Mo2_uU_L2_36_2 gp_2_36_2 dpre_L2_36 ts_uU_L2_36_2 0 NMIR W=20u L=1u
Mo3_uU_L2_36_2 da_uU_L2_36_2 da_uU_L2_36_2 vdd vdd PMIR W=60u L=1u
Mo4_uU_L2_36_2 gp_2_36_2 da_uU_L2_36_2 vdd vdd PMIR W=60u L=1u
Mt_uU_L2_36_3 ts_uU_L2_36_3 hv_L1_7 0 0 NMIR W=48.0u L=1u
Mo1_uU_L2_36_3 da_uU_L2_36_3 d1bar_L2 ts_uU_L2_36_3 0 NMIR W=20u L=1u
Mo2_uU_L2_36_3 gp_2_36_3 dpre_L2_36 ts_uU_L2_36_3 0 NMIR W=20u L=1u
Mo3_uU_L2_36_3 da_uU_L2_36_3 da_uU_L2_36_3 vdd vdd PMIR W=60u L=1u
Mo4_uU_L2_36_3 gp_2_36_3 da_uU_L2_36_3 vdd vdd PMIR W=60u L=1u
Mt_uU_L2_36_4 ts_uU_L2_36_4 hv_L1_10 0 0 NMIR W=48.0u L=1u
Mo1_uU_L2_36_4 da_uU_L2_36_4 d1bar_L2 ts_uU_L2_36_4 0 NMIR W=20u L=1u
Mo2_uU_L2_36_4 gp_2_36_4 dpre_L2_36 ts_uU_L2_36_4 0 NMIR W=20u L=1u
Mo3_uU_L2_36_4 da_uU_L2_36_4 da_uU_L2_36_4 vdd vdd PMIR W=60u L=1u
Mo4_uU_L2_36_4 gp_2_36_4 da_uU_L2_36_4 vdd vdd PMIR W=60u L=1u
Mt_uU_L2_36_5 ts_uU_L2_36_5 hv_L1_11 0 0 NMIR W=48.0u L=1u
Mo1_uU_L2_36_5 da_uU_L2_36_5 d1bar_L2 ts_uU_L2_36_5 0 NMIR W=20u L=1u
Mo2_uU_L2_36_5 gp_2_36_5 dpre_L2_36 ts_uU_L2_36_5 0 NMIR W=20u L=1u
Mo3_uU_L2_36_5 da_uU_L2_36_5 da_uU_L2_36_5 vdd vdd PMIR W=60u L=1u
Mo4_uU_L2_36_5 gp_2_36_5 da_uU_L2_36_5 vdd vdd PMIR W=60u L=1u
Mt_uU_L2_36_6 ts_uU_L2_36_6 hv_L1_17 0 0 NMIR W=48.0u L=1u
Mo1_uU_L2_36_6 da_uU_L2_36_6 d1bar_L2 ts_uU_L2_36_6 0 NMIR W=20u L=1u
Mo2_uU_L2_36_6 gp_2_36_6 dpre_L2_36 ts_uU_L2_36_6 0 NMIR W=20u L=1u
Mo3_uU_L2_36_6 da_uU_L2_36_6 da_uU_L2_36_6 vdd vdd PMIR W=60u L=1u
Mo4_uU_L2_36_6 gp_2_36_6 da_uU_L2_36_6 vdd vdd PMIR W=60u L=1u
Mt_uU_L2_36_7 ts_uU_L2_36_7 hv_L1_23 0 0 NMIR W=48.0u L=1u
Mo1_uU_L2_36_7 da_uU_L2_36_7 d1bar_L2 ts_uU_L2_36_7 0 NMIR W=20u L=1u
Mo2_uU_L2_36_7 gp_2_36_7 dpre_L2_36 ts_uU_L2_36_7 0 NMIR W=20u L=1u
Mo3_uU_L2_36_7 da_uU_L2_36_7 da_uU_L2_36_7 vdd vdd PMIR W=60u L=1u
Mo4_uU_L2_36_7 gp_2_36_7 da_uU_L2_36_7 vdd vdd PMIR W=60u L=1u
Mt_uU_L2_36_8 ts_uU_L2_36_8 hv_L1_24 0 0 NMIR W=48.0u L=1u
Mo1_uU_L2_36_8 da_uU_L2_36_8 d1bar_L2 ts_uU_L2_36_8 0 NMIR W=20u L=1u
Mo2_uU_L2_36_8 gp_2_36_8 dpre_L2_36 ts_uU_L2_36_8 0 NMIR W=20u L=1u
Mo3_uU_L2_36_8 da_uU_L2_36_8 da_uU_L2_36_8 vdd vdd PMIR W=60u L=1u
Mo4_uU_L2_36_8 gp_2_36_8 da_uU_L2_36_8 vdd vdd PMIR W=60u L=1u
Mt_uU_L2_36_9 ts_uU_L2_36_9 hv_L1_25 0 0 NMIR W=48.0u L=1u
Mo1_uU_L2_36_9 da_uU_L2_36_9 d1bar_L2 ts_uU_L2_36_9 0 NMIR W=20u L=1u
Mo2_uU_L2_36_9 gp_2_36_9 dpre_L2_36 ts_uU_L2_36_9 0 NMIR W=20u L=1u
Mo3_uU_L2_36_9 da_uU_L2_36_9 da_uU_L2_36_9 vdd vdd PMIR W=60u L=1u
Mo4_uU_L2_36_9 gp_2_36_9 da_uU_L2_36_9 vdd vdd PMIR W=60u L=1u
Mt_uU_L2_36_10 ts_uU_L2_36_10 hv_L1_29 0 0 NMIR W=48.0u L=1u
Mo1_uU_L2_36_10 da_uU_L2_36_10 d1bar_L2 ts_uU_L2_36_10 0 NMIR W=20u L=1u
Mo2_uU_L2_36_10 gp_2_36_10 dpre_L2_36 ts_uU_L2_36_10 0 NMIR W=20u L=1u
Mo3_uU_L2_36_10 da_uU_L2_36_10 da_uU_L2_36_10 vdd vdd PMIR W=60u L=1u
Mo4_uU_L2_36_10 gp_2_36_10 da_uU_L2_36_10 vdd vdd PMIR W=60u L=1u
Mt_uU_L2_36_11 ts_uU_L2_36_11 hv_L1_36 0 0 NMIR W=48.0u L=1u
Mo1_uU_L2_36_11 da_uU_L2_36_11 d1bar_L2 ts_uU_L2_36_11 0 NMIR W=20u L=1u
Mo2_uU_L2_36_11 gp_2_36_11 dpre_L2_36 ts_uU_L2_36_11 0 NMIR W=20u L=1u
Mo3_uU_L2_36_11 da_uU_L2_36_11 da_uU_L2_36_11 vdd vdd PMIR W=60u L=1u
Mo4_uU_L2_36_11 gp_2_36_11 da_uU_L2_36_11 vdd vdd PMIR W=60u L=1u
Mt_uU_L2_36_12 ts_uU_L2_36_12 hv_L1_38 0 0 NMIR W=48.0u L=1u
Mo1_uU_L2_36_12 da_uU_L2_36_12 d1bar_L2 ts_uU_L2_36_12 0 NMIR W=20u L=1u
Mo2_uU_L2_36_12 gp_2_36_12 dpre_L2_36 ts_uU_L2_36_12 0 NMIR W=20u L=1u
Mo3_uU_L2_36_12 da_uU_L2_36_12 da_uU_L2_36_12 vdd vdd PMIR W=60u L=1u
Mo4_uU_L2_36_12 gp_2_36_12 da_uU_L2_36_12 vdd vdd PMIR W=60u L=1u
Mt_uU_L2_36_13 ts_uU_L2_36_13 hv_L1_39 0 0 NMIR W=48.0u L=1u
Mo1_uU_L2_36_13 da_uU_L2_36_13 d1bar_L2 ts_uU_L2_36_13 0 NMIR W=20u L=1u
Mo2_uU_L2_36_13 gp_2_36_13 dpre_L2_36 ts_uU_L2_36_13 0 NMIR W=20u L=1u
Mo3_uU_L2_36_13 da_uU_L2_36_13 da_uU_L2_36_13 vdd vdd PMIR W=60u L=1u
Mo4_uU_L2_36_13 gp_2_36_13 da_uU_L2_36_13 vdd vdd PMIR W=60u L=1u
Mt_uU_L2_36_14 ts_uU_L2_36_14 hv_L1_43 0 0 NMIR W=48.0u L=1u
Mo1_uU_L2_36_14 da_uU_L2_36_14 d1bar_L2 ts_uU_L2_36_14 0 NMIR W=20u L=1u
Mo2_uU_L2_36_14 gp_2_36_14 dpre_L2_36 ts_uU_L2_36_14 0 NMIR W=20u L=1u
Mo3_uU_L2_36_14 da_uU_L2_36_14 da_uU_L2_36_14 vdd vdd PMIR W=60u L=1u
Mo4_uU_L2_36_14 gp_2_36_14 da_uU_L2_36_14 vdd vdd PMIR W=60u L=1u
Mt_uU_L2_36_15 ts_uU_L2_36_15 hv_L1_46 0 0 NMIR W=48.0u L=1u
Mo1_uU_L2_36_15 da_uU_L2_36_15 d1bar_L2 ts_uU_L2_36_15 0 NMIR W=20u L=1u
Mo2_uU_L2_36_15 gp_2_36_15 dpre_L2_36 ts_uU_L2_36_15 0 NMIR W=20u L=1u
Mo3_uU_L2_36_15 da_uU_L2_36_15 da_uU_L2_36_15 vdd vdd PMIR W=60u L=1u
Mo4_uU_L2_36_15 gp_2_36_15 da_uU_L2_36_15 vdd vdd PMIR W=60u L=1u
Mt_uU_L2_37_0 ts_uU_L2_37_0 hv_L1_4 0 0 NMIR W=48.0u L=1u
Mo1_uU_L2_37_0 da_uU_L2_37_0 d1bar_L2 ts_uU_L2_37_0 0 NMIR W=20u L=1u
Mo2_uU_L2_37_0 gp_2_37_0 dpre_L2_37 ts_uU_L2_37_0 0 NMIR W=20u L=1u
Mo3_uU_L2_37_0 da_uU_L2_37_0 da_uU_L2_37_0 vdd vdd PMIR W=60u L=1u
Mo4_uU_L2_37_0 gp_2_37_0 da_uU_L2_37_0 vdd vdd PMIR W=60u L=1u
Mt_uU_L2_37_1 ts_uU_L2_37_1 hv_L1_5 0 0 NMIR W=48.0u L=1u
Mo1_uU_L2_37_1 da_uU_L2_37_1 d1bar_L2 ts_uU_L2_37_1 0 NMIR W=20u L=1u
Mo2_uU_L2_37_1 gp_2_37_1 dpre_L2_37 ts_uU_L2_37_1 0 NMIR W=20u L=1u
Mo3_uU_L2_37_1 da_uU_L2_37_1 da_uU_L2_37_1 vdd vdd PMIR W=60u L=1u
Mo4_uU_L2_37_1 gp_2_37_1 da_uU_L2_37_1 vdd vdd PMIR W=60u L=1u
Mt_uU_L2_37_2 ts_uU_L2_37_2 hv_L1_7 0 0 NMIR W=48.0u L=1u
Mo1_uU_L2_37_2 da_uU_L2_37_2 d1bar_L2 ts_uU_L2_37_2 0 NMIR W=20u L=1u
Mo2_uU_L2_37_2 gp_2_37_2 dpre_L2_37 ts_uU_L2_37_2 0 NMIR W=20u L=1u
Mo3_uU_L2_37_2 da_uU_L2_37_2 da_uU_L2_37_2 vdd vdd PMIR W=60u L=1u
Mo4_uU_L2_37_2 gp_2_37_2 da_uU_L2_37_2 vdd vdd PMIR W=60u L=1u
Mt_uU_L2_37_3 ts_uU_L2_37_3 hv_L1_12 0 0 NMIR W=48.0u L=1u
Mo1_uU_L2_37_3 da_uU_L2_37_3 d1bar_L2 ts_uU_L2_37_3 0 NMIR W=20u L=1u
Mo2_uU_L2_37_3 gp_2_37_3 dpre_L2_37 ts_uU_L2_37_3 0 NMIR W=20u L=1u
Mo3_uU_L2_37_3 da_uU_L2_37_3 da_uU_L2_37_3 vdd vdd PMIR W=60u L=1u
Mo4_uU_L2_37_3 gp_2_37_3 da_uU_L2_37_3 vdd vdd PMIR W=60u L=1u
Mt_uU_L2_37_4 ts_uU_L2_37_4 hv_L1_15 0 0 NMIR W=48.0u L=1u
Mo1_uU_L2_37_4 da_uU_L2_37_4 d1bar_L2 ts_uU_L2_37_4 0 NMIR W=20u L=1u
Mo2_uU_L2_37_4 gp_2_37_4 dpre_L2_37 ts_uU_L2_37_4 0 NMIR W=20u L=1u
Mo3_uU_L2_37_4 da_uU_L2_37_4 da_uU_L2_37_4 vdd vdd PMIR W=60u L=1u
Mo4_uU_L2_37_4 gp_2_37_4 da_uU_L2_37_4 vdd vdd PMIR W=60u L=1u
Mt_uU_L2_37_5 ts_uU_L2_37_5 hv_L1_16 0 0 NMIR W=48.0u L=1u
Mo1_uU_L2_37_5 da_uU_L2_37_5 d1bar_L2 ts_uU_L2_37_5 0 NMIR W=20u L=1u
Mo2_uU_L2_37_5 gp_2_37_5 dpre_L2_37 ts_uU_L2_37_5 0 NMIR W=20u L=1u
Mo3_uU_L2_37_5 da_uU_L2_37_5 da_uU_L2_37_5 vdd vdd PMIR W=60u L=1u
Mo4_uU_L2_37_5 gp_2_37_5 da_uU_L2_37_5 vdd vdd PMIR W=60u L=1u
Mt_uU_L2_37_6 ts_uU_L2_37_6 hv_L1_17 0 0 NMIR W=48.0u L=1u
Mo1_uU_L2_37_6 da_uU_L2_37_6 d1bar_L2 ts_uU_L2_37_6 0 NMIR W=20u L=1u
Mo2_uU_L2_37_6 gp_2_37_6 dpre_L2_37 ts_uU_L2_37_6 0 NMIR W=20u L=1u
Mo3_uU_L2_37_6 da_uU_L2_37_6 da_uU_L2_37_6 vdd vdd PMIR W=60u L=1u
Mo4_uU_L2_37_6 gp_2_37_6 da_uU_L2_37_6 vdd vdd PMIR W=60u L=1u
Mt_uU_L2_37_7 ts_uU_L2_37_7 hv_L1_18 0 0 NMIR W=48.0u L=1u
Mo1_uU_L2_37_7 da_uU_L2_37_7 d1bar_L2 ts_uU_L2_37_7 0 NMIR W=20u L=1u
Mo2_uU_L2_37_7 gp_2_37_7 dpre_L2_37 ts_uU_L2_37_7 0 NMIR W=20u L=1u
Mo3_uU_L2_37_7 da_uU_L2_37_7 da_uU_L2_37_7 vdd vdd PMIR W=60u L=1u
Mo4_uU_L2_37_7 gp_2_37_7 da_uU_L2_37_7 vdd vdd PMIR W=60u L=1u
Mt_uU_L2_37_8 ts_uU_L2_37_8 hv_L1_27 0 0 NMIR W=48.0u L=1u
Mo1_uU_L2_37_8 da_uU_L2_37_8 d1bar_L2 ts_uU_L2_37_8 0 NMIR W=20u L=1u
Mo2_uU_L2_37_8 gp_2_37_8 dpre_L2_37 ts_uU_L2_37_8 0 NMIR W=20u L=1u
Mo3_uU_L2_37_8 da_uU_L2_37_8 da_uU_L2_37_8 vdd vdd PMIR W=60u L=1u
Mo4_uU_L2_37_8 gp_2_37_8 da_uU_L2_37_8 vdd vdd PMIR W=60u L=1u
Mt_uU_L2_37_9 ts_uU_L2_37_9 hv_L1_31 0 0 NMIR W=48.0u L=1u
Mo1_uU_L2_37_9 da_uU_L2_37_9 d1bar_L2 ts_uU_L2_37_9 0 NMIR W=20u L=1u
Mo2_uU_L2_37_9 gp_2_37_9 dpre_L2_37 ts_uU_L2_37_9 0 NMIR W=20u L=1u
Mo3_uU_L2_37_9 da_uU_L2_37_9 da_uU_L2_37_9 vdd vdd PMIR W=60u L=1u
Mo4_uU_L2_37_9 gp_2_37_9 da_uU_L2_37_9 vdd vdd PMIR W=60u L=1u
Mt_uU_L2_37_10 ts_uU_L2_37_10 hv_L1_36 0 0 NMIR W=48.0u L=1u
Mo1_uU_L2_37_10 da_uU_L2_37_10 d1bar_L2 ts_uU_L2_37_10 0 NMIR W=20u L=1u
Mo2_uU_L2_37_10 gp_2_37_10 dpre_L2_37 ts_uU_L2_37_10 0 NMIR W=20u L=1u
Mo3_uU_L2_37_10 da_uU_L2_37_10 da_uU_L2_37_10 vdd vdd PMIR W=60u L=1u
Mo4_uU_L2_37_10 gp_2_37_10 da_uU_L2_37_10 vdd vdd PMIR W=60u L=1u
Mt_uU_L2_37_11 ts_uU_L2_37_11 hv_L1_42 0 0 NMIR W=48.0u L=1u
Mo1_uU_L2_37_11 da_uU_L2_37_11 d1bar_L2 ts_uU_L2_37_11 0 NMIR W=20u L=1u
Mo2_uU_L2_37_11 gp_2_37_11 dpre_L2_37 ts_uU_L2_37_11 0 NMIR W=20u L=1u
Mo3_uU_L2_37_11 da_uU_L2_37_11 da_uU_L2_37_11 vdd vdd PMIR W=60u L=1u
Mo4_uU_L2_37_11 gp_2_37_11 da_uU_L2_37_11 vdd vdd PMIR W=60u L=1u
Mt_uU_L2_37_12 ts_uU_L2_37_12 hv_L1_43 0 0 NMIR W=48.0u L=1u
Mo1_uU_L2_37_12 da_uU_L2_37_12 d1bar_L2 ts_uU_L2_37_12 0 NMIR W=20u L=1u
Mo2_uU_L2_37_12 gp_2_37_12 dpre_L2_37 ts_uU_L2_37_12 0 NMIR W=20u L=1u
Mo3_uU_L2_37_12 da_uU_L2_37_12 da_uU_L2_37_12 vdd vdd PMIR W=60u L=1u
Mo4_uU_L2_37_12 gp_2_37_12 da_uU_L2_37_12 vdd vdd PMIR W=60u L=1u
Mt_uU_L2_37_13 ts_uU_L2_37_13 hv_L1_44 0 0 NMIR W=48.0u L=1u
Mo1_uU_L2_37_13 da_uU_L2_37_13 d1bar_L2 ts_uU_L2_37_13 0 NMIR W=20u L=1u
Mo2_uU_L2_37_13 gp_2_37_13 dpre_L2_37 ts_uU_L2_37_13 0 NMIR W=20u L=1u
Mo3_uU_L2_37_13 da_uU_L2_37_13 da_uU_L2_37_13 vdd vdd PMIR W=60u L=1u
Mo4_uU_L2_37_13 gp_2_37_13 da_uU_L2_37_13 vdd vdd PMIR W=60u L=1u
Mt_uU_L2_37_14 ts_uU_L2_37_14 hv_L1_45 0 0 NMIR W=48.0u L=1u
Mo1_uU_L2_37_14 da_uU_L2_37_14 d1bar_L2 ts_uU_L2_37_14 0 NMIR W=20u L=1u
Mo2_uU_L2_37_14 gp_2_37_14 dpre_L2_37 ts_uU_L2_37_14 0 NMIR W=20u L=1u
Mo3_uU_L2_37_14 da_uU_L2_37_14 da_uU_L2_37_14 vdd vdd PMIR W=60u L=1u
Mo4_uU_L2_37_14 gp_2_37_14 da_uU_L2_37_14 vdd vdd PMIR W=60u L=1u
Mt_uU_L2_37_15 ts_uU_L2_37_15 hv_L1_47 0 0 NMIR W=48.0u L=1u
Mo1_uU_L2_37_15 da_uU_L2_37_15 d1bar_L2 ts_uU_L2_37_15 0 NMIR W=20u L=1u
Mo2_uU_L2_37_15 gp_2_37_15 dpre_L2_37 ts_uU_L2_37_15 0 NMIR W=20u L=1u
Mo3_uU_L2_37_15 da_uU_L2_37_15 da_uU_L2_37_15 vdd vdd PMIR W=60u L=1u
Mo4_uU_L2_37_15 gp_2_37_15 da_uU_L2_37_15 vdd vdd PMIR W=60u L=1u
Mt_uU_L2_38_0 ts_uU_L2_38_0 hv_L1_1 0 0 NMIR W=48.0u L=1u
Mo1_uU_L2_38_0 da_uU_L2_38_0 d1bar_L2 ts_uU_L2_38_0 0 NMIR W=20u L=1u
Mo2_uU_L2_38_0 gp_2_38_0 dpre_L2_38 ts_uU_L2_38_0 0 NMIR W=20u L=1u
Mo3_uU_L2_38_0 da_uU_L2_38_0 da_uU_L2_38_0 vdd vdd PMIR W=60u L=1u
Mo4_uU_L2_38_0 gp_2_38_0 da_uU_L2_38_0 vdd vdd PMIR W=60u L=1u
Mt_uU_L2_38_1 ts_uU_L2_38_1 hv_L1_9 0 0 NMIR W=48.0u L=1u
Mo1_uU_L2_38_1 da_uU_L2_38_1 d1bar_L2 ts_uU_L2_38_1 0 NMIR W=20u L=1u
Mo2_uU_L2_38_1 gp_2_38_1 dpre_L2_38 ts_uU_L2_38_1 0 NMIR W=20u L=1u
Mo3_uU_L2_38_1 da_uU_L2_38_1 da_uU_L2_38_1 vdd vdd PMIR W=60u L=1u
Mo4_uU_L2_38_1 gp_2_38_1 da_uU_L2_38_1 vdd vdd PMIR W=60u L=1u
Mt_uU_L2_38_2 ts_uU_L2_38_2 hv_L1_11 0 0 NMIR W=48.0u L=1u
Mo1_uU_L2_38_2 da_uU_L2_38_2 d1bar_L2 ts_uU_L2_38_2 0 NMIR W=20u L=1u
Mo2_uU_L2_38_2 gp_2_38_2 dpre_L2_38 ts_uU_L2_38_2 0 NMIR W=20u L=1u
Mo3_uU_L2_38_2 da_uU_L2_38_2 da_uU_L2_38_2 vdd vdd PMIR W=60u L=1u
Mo4_uU_L2_38_2 gp_2_38_2 da_uU_L2_38_2 vdd vdd PMIR W=60u L=1u
Mt_uU_L2_38_3 ts_uU_L2_38_3 hv_L1_13 0 0 NMIR W=48.0u L=1u
Mo1_uU_L2_38_3 da_uU_L2_38_3 d1bar_L2 ts_uU_L2_38_3 0 NMIR W=20u L=1u
Mo2_uU_L2_38_3 gp_2_38_3 dpre_L2_38 ts_uU_L2_38_3 0 NMIR W=20u L=1u
Mo3_uU_L2_38_3 da_uU_L2_38_3 da_uU_L2_38_3 vdd vdd PMIR W=60u L=1u
Mo4_uU_L2_38_3 gp_2_38_3 da_uU_L2_38_3 vdd vdd PMIR W=60u L=1u
Mt_uU_L2_38_4 ts_uU_L2_38_4 hv_L1_17 0 0 NMIR W=48.0u L=1u
Mo1_uU_L2_38_4 da_uU_L2_38_4 d1bar_L2 ts_uU_L2_38_4 0 NMIR W=20u L=1u
Mo2_uU_L2_38_4 gp_2_38_4 dpre_L2_38 ts_uU_L2_38_4 0 NMIR W=20u L=1u
Mo3_uU_L2_38_4 da_uU_L2_38_4 da_uU_L2_38_4 vdd vdd PMIR W=60u L=1u
Mo4_uU_L2_38_4 gp_2_38_4 da_uU_L2_38_4 vdd vdd PMIR W=60u L=1u
Mt_uU_L2_38_5 ts_uU_L2_38_5 hv_L1_21 0 0 NMIR W=48.0u L=1u
Mo1_uU_L2_38_5 da_uU_L2_38_5 d1bar_L2 ts_uU_L2_38_5 0 NMIR W=20u L=1u
Mo2_uU_L2_38_5 gp_2_38_5 dpre_L2_38 ts_uU_L2_38_5 0 NMIR W=20u L=1u
Mo3_uU_L2_38_5 da_uU_L2_38_5 da_uU_L2_38_5 vdd vdd PMIR W=60u L=1u
Mo4_uU_L2_38_5 gp_2_38_5 da_uU_L2_38_5 vdd vdd PMIR W=60u L=1u
Mt_uU_L2_38_6 ts_uU_L2_38_6 hv_L1_23 0 0 NMIR W=48.0u L=1u
Mo1_uU_L2_38_6 da_uU_L2_38_6 d1bar_L2 ts_uU_L2_38_6 0 NMIR W=20u L=1u
Mo2_uU_L2_38_6 gp_2_38_6 dpre_L2_38 ts_uU_L2_38_6 0 NMIR W=20u L=1u
Mo3_uU_L2_38_6 da_uU_L2_38_6 da_uU_L2_38_6 vdd vdd PMIR W=60u L=1u
Mo4_uU_L2_38_6 gp_2_38_6 da_uU_L2_38_6 vdd vdd PMIR W=60u L=1u
Mt_uU_L2_38_7 ts_uU_L2_38_7 hv_L1_25 0 0 NMIR W=48.0u L=1u
Mo1_uU_L2_38_7 da_uU_L2_38_7 d1bar_L2 ts_uU_L2_38_7 0 NMIR W=20u L=1u
Mo2_uU_L2_38_7 gp_2_38_7 dpre_L2_38 ts_uU_L2_38_7 0 NMIR W=20u L=1u
Mo3_uU_L2_38_7 da_uU_L2_38_7 da_uU_L2_38_7 vdd vdd PMIR W=60u L=1u
Mo4_uU_L2_38_7 gp_2_38_7 da_uU_L2_38_7 vdd vdd PMIR W=60u L=1u
Mt_uU_L2_38_8 ts_uU_L2_38_8 hv_L1_27 0 0 NMIR W=48.0u L=1u
Mo1_uU_L2_38_8 da_uU_L2_38_8 d1bar_L2 ts_uU_L2_38_8 0 NMIR W=20u L=1u
Mo2_uU_L2_38_8 gp_2_38_8 dpre_L2_38 ts_uU_L2_38_8 0 NMIR W=20u L=1u
Mo3_uU_L2_38_8 da_uU_L2_38_8 da_uU_L2_38_8 vdd vdd PMIR W=60u L=1u
Mo4_uU_L2_38_8 gp_2_38_8 da_uU_L2_38_8 vdd vdd PMIR W=60u L=1u
Mt_uU_L2_38_9 ts_uU_L2_38_9 hv_L1_29 0 0 NMIR W=48.0u L=1u
Mo1_uU_L2_38_9 da_uU_L2_38_9 d1bar_L2 ts_uU_L2_38_9 0 NMIR W=20u L=1u
Mo2_uU_L2_38_9 gp_2_38_9 dpre_L2_38 ts_uU_L2_38_9 0 NMIR W=20u L=1u
Mo3_uU_L2_38_9 da_uU_L2_38_9 da_uU_L2_38_9 vdd vdd PMIR W=60u L=1u
Mo4_uU_L2_38_9 gp_2_38_9 da_uU_L2_38_9 vdd vdd PMIR W=60u L=1u
Mt_uU_L2_38_10 ts_uU_L2_38_10 hv_L1_32 0 0 NMIR W=48.0u L=1u
Mo1_uU_L2_38_10 da_uU_L2_38_10 d1bar_L2 ts_uU_L2_38_10 0 NMIR W=20u L=1u
Mo2_uU_L2_38_10 gp_2_38_10 dpre_L2_38 ts_uU_L2_38_10 0 NMIR W=20u L=1u
Mo3_uU_L2_38_10 da_uU_L2_38_10 da_uU_L2_38_10 vdd vdd PMIR W=60u L=1u
Mo4_uU_L2_38_10 gp_2_38_10 da_uU_L2_38_10 vdd vdd PMIR W=60u L=1u
Mt_uU_L2_38_11 ts_uU_L2_38_11 hv_L1_42 0 0 NMIR W=48.0u L=1u
Mo1_uU_L2_38_11 da_uU_L2_38_11 d1bar_L2 ts_uU_L2_38_11 0 NMIR W=20u L=1u
Mo2_uU_L2_38_11 gp_2_38_11 dpre_L2_38 ts_uU_L2_38_11 0 NMIR W=20u L=1u
Mo3_uU_L2_38_11 da_uU_L2_38_11 da_uU_L2_38_11 vdd vdd PMIR W=60u L=1u
Mo4_uU_L2_38_11 gp_2_38_11 da_uU_L2_38_11 vdd vdd PMIR W=60u L=1u
Mt_uU_L2_38_12 ts_uU_L2_38_12 hv_L1_43 0 0 NMIR W=48.0u L=1u
Mo1_uU_L2_38_12 da_uU_L2_38_12 d1bar_L2 ts_uU_L2_38_12 0 NMIR W=20u L=1u
Mo2_uU_L2_38_12 gp_2_38_12 dpre_L2_38 ts_uU_L2_38_12 0 NMIR W=20u L=1u
Mo3_uU_L2_38_12 da_uU_L2_38_12 da_uU_L2_38_12 vdd vdd PMIR W=60u L=1u
Mo4_uU_L2_38_12 gp_2_38_12 da_uU_L2_38_12 vdd vdd PMIR W=60u L=1u
Mt_uU_L2_38_13 ts_uU_L2_38_13 hv_L1_44 0 0 NMIR W=48.0u L=1u
Mo1_uU_L2_38_13 da_uU_L2_38_13 d1bar_L2 ts_uU_L2_38_13 0 NMIR W=20u L=1u
Mo2_uU_L2_38_13 gp_2_38_13 dpre_L2_38 ts_uU_L2_38_13 0 NMIR W=20u L=1u
Mo3_uU_L2_38_13 da_uU_L2_38_13 da_uU_L2_38_13 vdd vdd PMIR W=60u L=1u
Mo4_uU_L2_38_13 gp_2_38_13 da_uU_L2_38_13 vdd vdd PMIR W=60u L=1u
Mt_uU_L2_38_14 ts_uU_L2_38_14 hv_L1_45 0 0 NMIR W=48.0u L=1u
Mo1_uU_L2_38_14 da_uU_L2_38_14 d1bar_L2 ts_uU_L2_38_14 0 NMIR W=20u L=1u
Mo2_uU_L2_38_14 gp_2_38_14 dpre_L2_38 ts_uU_L2_38_14 0 NMIR W=20u L=1u
Mo3_uU_L2_38_14 da_uU_L2_38_14 da_uU_L2_38_14 vdd vdd PMIR W=60u L=1u
Mo4_uU_L2_38_14 gp_2_38_14 da_uU_L2_38_14 vdd vdd PMIR W=60u L=1u
Mt_uU_L2_38_15 ts_uU_L2_38_15 hv_L1_46 0 0 NMIR W=48.0u L=1u
Mo1_uU_L2_38_15 da_uU_L2_38_15 d1bar_L2 ts_uU_L2_38_15 0 NMIR W=20u L=1u
Mo2_uU_L2_38_15 gp_2_38_15 dpre_L2_38 ts_uU_L2_38_15 0 NMIR W=20u L=1u
Mo3_uU_L2_38_15 da_uU_L2_38_15 da_uU_L2_38_15 vdd vdd PMIR W=60u L=1u
Mo4_uU_L2_38_15 gp_2_38_15 da_uU_L2_38_15 vdd vdd PMIR W=60u L=1u
Mt_uU_L2_39_0 ts_uU_L2_39_0 hv_L1_3 0 0 NMIR W=48.0u L=1u
Mo1_uU_L2_39_0 da_uU_L2_39_0 d1bar_L2 ts_uU_L2_39_0 0 NMIR W=20u L=1u
Mo2_uU_L2_39_0 gp_2_39_0 dpre_L2_39 ts_uU_L2_39_0 0 NMIR W=20u L=1u
Mo3_uU_L2_39_0 da_uU_L2_39_0 da_uU_L2_39_0 vdd vdd PMIR W=60u L=1u
Mo4_uU_L2_39_0 gp_2_39_0 da_uU_L2_39_0 vdd vdd PMIR W=60u L=1u
Mt_uU_L2_39_1 ts_uU_L2_39_1 hv_L1_4 0 0 NMIR W=48.0u L=1u
Mo1_uU_L2_39_1 da_uU_L2_39_1 d1bar_L2 ts_uU_L2_39_1 0 NMIR W=20u L=1u
Mo2_uU_L2_39_1 gp_2_39_1 dpre_L2_39 ts_uU_L2_39_1 0 NMIR W=20u L=1u
Mo3_uU_L2_39_1 da_uU_L2_39_1 da_uU_L2_39_1 vdd vdd PMIR W=60u L=1u
Mo4_uU_L2_39_1 gp_2_39_1 da_uU_L2_39_1 vdd vdd PMIR W=60u L=1u
Mt_uU_L2_39_2 ts_uU_L2_39_2 hv_L1_9 0 0 NMIR W=48.0u L=1u
Mo1_uU_L2_39_2 da_uU_L2_39_2 d1bar_L2 ts_uU_L2_39_2 0 NMIR W=20u L=1u
Mo2_uU_L2_39_2 gp_2_39_2 dpre_L2_39 ts_uU_L2_39_2 0 NMIR W=20u L=1u
Mo3_uU_L2_39_2 da_uU_L2_39_2 da_uU_L2_39_2 vdd vdd PMIR W=60u L=1u
Mo4_uU_L2_39_2 gp_2_39_2 da_uU_L2_39_2 vdd vdd PMIR W=60u L=1u
Mt_uU_L2_39_3 ts_uU_L2_39_3 hv_L1_11 0 0 NMIR W=48.0u L=1u
Mo1_uU_L2_39_3 da_uU_L2_39_3 d1bar_L2 ts_uU_L2_39_3 0 NMIR W=20u L=1u
Mo2_uU_L2_39_3 gp_2_39_3 dpre_L2_39 ts_uU_L2_39_3 0 NMIR W=20u L=1u
Mo3_uU_L2_39_3 da_uU_L2_39_3 da_uU_L2_39_3 vdd vdd PMIR W=60u L=1u
Mo4_uU_L2_39_3 gp_2_39_3 da_uU_L2_39_3 vdd vdd PMIR W=60u L=1u
Mt_uU_L2_39_4 ts_uU_L2_39_4 hv_L1_13 0 0 NMIR W=48.0u L=1u
Mo1_uU_L2_39_4 da_uU_L2_39_4 d1bar_L2 ts_uU_L2_39_4 0 NMIR W=20u L=1u
Mo2_uU_L2_39_4 gp_2_39_4 dpre_L2_39 ts_uU_L2_39_4 0 NMIR W=20u L=1u
Mo3_uU_L2_39_4 da_uU_L2_39_4 da_uU_L2_39_4 vdd vdd PMIR W=60u L=1u
Mo4_uU_L2_39_4 gp_2_39_4 da_uU_L2_39_4 vdd vdd PMIR W=60u L=1u
Mt_uU_L2_39_5 ts_uU_L2_39_5 hv_L1_14 0 0 NMIR W=48.0u L=1u
Mo1_uU_L2_39_5 da_uU_L2_39_5 d1bar_L2 ts_uU_L2_39_5 0 NMIR W=20u L=1u
Mo2_uU_L2_39_5 gp_2_39_5 dpre_L2_39 ts_uU_L2_39_5 0 NMIR W=20u L=1u
Mo3_uU_L2_39_5 da_uU_L2_39_5 da_uU_L2_39_5 vdd vdd PMIR W=60u L=1u
Mo4_uU_L2_39_5 gp_2_39_5 da_uU_L2_39_5 vdd vdd PMIR W=60u L=1u
Mt_uU_L2_39_6 ts_uU_L2_39_6 hv_L1_16 0 0 NMIR W=48.0u L=1u
Mo1_uU_L2_39_6 da_uU_L2_39_6 d1bar_L2 ts_uU_L2_39_6 0 NMIR W=20u L=1u
Mo2_uU_L2_39_6 gp_2_39_6 dpre_L2_39 ts_uU_L2_39_6 0 NMIR W=20u L=1u
Mo3_uU_L2_39_6 da_uU_L2_39_6 da_uU_L2_39_6 vdd vdd PMIR W=60u L=1u
Mo4_uU_L2_39_6 gp_2_39_6 da_uU_L2_39_6 vdd vdd PMIR W=60u L=1u
Mt_uU_L2_39_7 ts_uU_L2_39_7 hv_L1_17 0 0 NMIR W=48.0u L=1u
Mo1_uU_L2_39_7 da_uU_L2_39_7 d1bar_L2 ts_uU_L2_39_7 0 NMIR W=20u L=1u
Mo2_uU_L2_39_7 gp_2_39_7 dpre_L2_39 ts_uU_L2_39_7 0 NMIR W=20u L=1u
Mo3_uU_L2_39_7 da_uU_L2_39_7 da_uU_L2_39_7 vdd vdd PMIR W=60u L=1u
Mo4_uU_L2_39_7 gp_2_39_7 da_uU_L2_39_7 vdd vdd PMIR W=60u L=1u
Mt_uU_L2_39_8 ts_uU_L2_39_8 hv_L1_19 0 0 NMIR W=48.0u L=1u
Mo1_uU_L2_39_8 da_uU_L2_39_8 d1bar_L2 ts_uU_L2_39_8 0 NMIR W=20u L=1u
Mo2_uU_L2_39_8 gp_2_39_8 dpre_L2_39 ts_uU_L2_39_8 0 NMIR W=20u L=1u
Mo3_uU_L2_39_8 da_uU_L2_39_8 da_uU_L2_39_8 vdd vdd PMIR W=60u L=1u
Mo4_uU_L2_39_8 gp_2_39_8 da_uU_L2_39_8 vdd vdd PMIR W=60u L=1u
Mt_uU_L2_39_9 ts_uU_L2_39_9 hv_L1_22 0 0 NMIR W=48.0u L=1u
Mo1_uU_L2_39_9 da_uU_L2_39_9 d1bar_L2 ts_uU_L2_39_9 0 NMIR W=20u L=1u
Mo2_uU_L2_39_9 gp_2_39_9 dpre_L2_39 ts_uU_L2_39_9 0 NMIR W=20u L=1u
Mo3_uU_L2_39_9 da_uU_L2_39_9 da_uU_L2_39_9 vdd vdd PMIR W=60u L=1u
Mo4_uU_L2_39_9 gp_2_39_9 da_uU_L2_39_9 vdd vdd PMIR W=60u L=1u
Mt_uU_L2_39_10 ts_uU_L2_39_10 hv_L1_24 0 0 NMIR W=48.0u L=1u
Mo1_uU_L2_39_10 da_uU_L2_39_10 d1bar_L2 ts_uU_L2_39_10 0 NMIR W=20u L=1u
Mo2_uU_L2_39_10 gp_2_39_10 dpre_L2_39 ts_uU_L2_39_10 0 NMIR W=20u L=1u
Mo3_uU_L2_39_10 da_uU_L2_39_10 da_uU_L2_39_10 vdd vdd PMIR W=60u L=1u
Mo4_uU_L2_39_10 gp_2_39_10 da_uU_L2_39_10 vdd vdd PMIR W=60u L=1u
Mt_uU_L2_39_11 ts_uU_L2_39_11 hv_L1_30 0 0 NMIR W=48.0u L=1u
Mo1_uU_L2_39_11 da_uU_L2_39_11 d1bar_L2 ts_uU_L2_39_11 0 NMIR W=20u L=1u
Mo2_uU_L2_39_11 gp_2_39_11 dpre_L2_39 ts_uU_L2_39_11 0 NMIR W=20u L=1u
Mo3_uU_L2_39_11 da_uU_L2_39_11 da_uU_L2_39_11 vdd vdd PMIR W=60u L=1u
Mo4_uU_L2_39_11 gp_2_39_11 da_uU_L2_39_11 vdd vdd PMIR W=60u L=1u
Mt_uU_L2_39_12 ts_uU_L2_39_12 hv_L1_39 0 0 NMIR W=48.0u L=1u
Mo1_uU_L2_39_12 da_uU_L2_39_12 d1bar_L2 ts_uU_L2_39_12 0 NMIR W=20u L=1u
Mo2_uU_L2_39_12 gp_2_39_12 dpre_L2_39 ts_uU_L2_39_12 0 NMIR W=20u L=1u
Mo3_uU_L2_39_12 da_uU_L2_39_12 da_uU_L2_39_12 vdd vdd PMIR W=60u L=1u
Mo4_uU_L2_39_12 gp_2_39_12 da_uU_L2_39_12 vdd vdd PMIR W=60u L=1u
Mt_uU_L2_39_13 ts_uU_L2_39_13 hv_L1_41 0 0 NMIR W=48.0u L=1u
Mo1_uU_L2_39_13 da_uU_L2_39_13 d1bar_L2 ts_uU_L2_39_13 0 NMIR W=20u L=1u
Mo2_uU_L2_39_13 gp_2_39_13 dpre_L2_39 ts_uU_L2_39_13 0 NMIR W=20u L=1u
Mo3_uU_L2_39_13 da_uU_L2_39_13 da_uU_L2_39_13 vdd vdd PMIR W=60u L=1u
Mo4_uU_L2_39_13 gp_2_39_13 da_uU_L2_39_13 vdd vdd PMIR W=60u L=1u
Mt_uU_L2_39_14 ts_uU_L2_39_14 hv_L1_44 0 0 NMIR W=48.0u L=1u
Mo1_uU_L2_39_14 da_uU_L2_39_14 d1bar_L2 ts_uU_L2_39_14 0 NMIR W=20u L=1u
Mo2_uU_L2_39_14 gp_2_39_14 dpre_L2_39 ts_uU_L2_39_14 0 NMIR W=20u L=1u
Mo3_uU_L2_39_14 da_uU_L2_39_14 da_uU_L2_39_14 vdd vdd PMIR W=60u L=1u
Mo4_uU_L2_39_14 gp_2_39_14 da_uU_L2_39_14 vdd vdd PMIR W=60u L=1u
Mt_uU_L2_39_15 ts_uU_L2_39_15 hv_L1_45 0 0 NMIR W=48.0u L=1u
Mo1_uU_L2_39_15 da_uU_L2_39_15 d1bar_L2 ts_uU_L2_39_15 0 NMIR W=20u L=1u
Mo2_uU_L2_39_15 gp_2_39_15 dpre_L2_39 ts_uU_L2_39_15 0 NMIR W=20u L=1u
Mo3_uU_L2_39_15 da_uU_L2_39_15 da_uU_L2_39_15 vdd vdd PMIR W=60u L=1u
Mo4_uU_L2_39_15 gp_2_39_15 da_uU_L2_39_15 vdd vdd PMIR W=60u L=1u
Mt_uU_L2_40_0 ts_uU_L2_40_0 hv_L1_0 0 0 NMIR W=48.0u L=1u
Mo1_uU_L2_40_0 da_uU_L2_40_0 d1bar_L2 ts_uU_L2_40_0 0 NMIR W=20u L=1u
Mo2_uU_L2_40_0 gp_2_40_0 dpre_L2_40 ts_uU_L2_40_0 0 NMIR W=20u L=1u
Mo3_uU_L2_40_0 da_uU_L2_40_0 da_uU_L2_40_0 vdd vdd PMIR W=60u L=1u
Mo4_uU_L2_40_0 gp_2_40_0 da_uU_L2_40_0 vdd vdd PMIR W=60u L=1u
Mt_uU_L2_40_1 ts_uU_L2_40_1 hv_L1_6 0 0 NMIR W=48.0u L=1u
Mo1_uU_L2_40_1 da_uU_L2_40_1 d1bar_L2 ts_uU_L2_40_1 0 NMIR W=20u L=1u
Mo2_uU_L2_40_1 gp_2_40_1 dpre_L2_40 ts_uU_L2_40_1 0 NMIR W=20u L=1u
Mo3_uU_L2_40_1 da_uU_L2_40_1 da_uU_L2_40_1 vdd vdd PMIR W=60u L=1u
Mo4_uU_L2_40_1 gp_2_40_1 da_uU_L2_40_1 vdd vdd PMIR W=60u L=1u
Mt_uU_L2_40_2 ts_uU_L2_40_2 hv_L1_7 0 0 NMIR W=48.0u L=1u
Mo1_uU_L2_40_2 da_uU_L2_40_2 d1bar_L2 ts_uU_L2_40_2 0 NMIR W=20u L=1u
Mo2_uU_L2_40_2 gp_2_40_2 dpre_L2_40 ts_uU_L2_40_2 0 NMIR W=20u L=1u
Mo3_uU_L2_40_2 da_uU_L2_40_2 da_uU_L2_40_2 vdd vdd PMIR W=60u L=1u
Mo4_uU_L2_40_2 gp_2_40_2 da_uU_L2_40_2 vdd vdd PMIR W=60u L=1u
Mt_uU_L2_40_3 ts_uU_L2_40_3 hv_L1_10 0 0 NMIR W=48.0u L=1u
Mo1_uU_L2_40_3 da_uU_L2_40_3 d1bar_L2 ts_uU_L2_40_3 0 NMIR W=20u L=1u
Mo2_uU_L2_40_3 gp_2_40_3 dpre_L2_40 ts_uU_L2_40_3 0 NMIR W=20u L=1u
Mo3_uU_L2_40_3 da_uU_L2_40_3 da_uU_L2_40_3 vdd vdd PMIR W=60u L=1u
Mo4_uU_L2_40_3 gp_2_40_3 da_uU_L2_40_3 vdd vdd PMIR W=60u L=1u
Mt_uU_L2_40_4 ts_uU_L2_40_4 hv_L1_16 0 0 NMIR W=48.0u L=1u
Mo1_uU_L2_40_4 da_uU_L2_40_4 d1bar_L2 ts_uU_L2_40_4 0 NMIR W=20u L=1u
Mo2_uU_L2_40_4 gp_2_40_4 dpre_L2_40 ts_uU_L2_40_4 0 NMIR W=20u L=1u
Mo3_uU_L2_40_4 da_uU_L2_40_4 da_uU_L2_40_4 vdd vdd PMIR W=60u L=1u
Mo4_uU_L2_40_4 gp_2_40_4 da_uU_L2_40_4 vdd vdd PMIR W=60u L=1u
Mt_uU_L2_40_5 ts_uU_L2_40_5 hv_L1_20 0 0 NMIR W=48.0u L=1u
Mo1_uU_L2_40_5 da_uU_L2_40_5 d1bar_L2 ts_uU_L2_40_5 0 NMIR W=20u L=1u
Mo2_uU_L2_40_5 gp_2_40_5 dpre_L2_40 ts_uU_L2_40_5 0 NMIR W=20u L=1u
Mo3_uU_L2_40_5 da_uU_L2_40_5 da_uU_L2_40_5 vdd vdd PMIR W=60u L=1u
Mo4_uU_L2_40_5 gp_2_40_5 da_uU_L2_40_5 vdd vdd PMIR W=60u L=1u
Mt_uU_L2_40_6 ts_uU_L2_40_6 hv_L1_21 0 0 NMIR W=48.0u L=1u
Mo1_uU_L2_40_6 da_uU_L2_40_6 d1bar_L2 ts_uU_L2_40_6 0 NMIR W=20u L=1u
Mo2_uU_L2_40_6 gp_2_40_6 dpre_L2_40 ts_uU_L2_40_6 0 NMIR W=20u L=1u
Mo3_uU_L2_40_6 da_uU_L2_40_6 da_uU_L2_40_6 vdd vdd PMIR W=60u L=1u
Mo4_uU_L2_40_6 gp_2_40_6 da_uU_L2_40_6 vdd vdd PMIR W=60u L=1u
Mt_uU_L2_40_7 ts_uU_L2_40_7 hv_L1_22 0 0 NMIR W=48.0u L=1u
Mo1_uU_L2_40_7 da_uU_L2_40_7 d1bar_L2 ts_uU_L2_40_7 0 NMIR W=20u L=1u
Mo2_uU_L2_40_7 gp_2_40_7 dpre_L2_40 ts_uU_L2_40_7 0 NMIR W=20u L=1u
Mo3_uU_L2_40_7 da_uU_L2_40_7 da_uU_L2_40_7 vdd vdd PMIR W=60u L=1u
Mo4_uU_L2_40_7 gp_2_40_7 da_uU_L2_40_7 vdd vdd PMIR W=60u L=1u
Mt_uU_L2_40_8 ts_uU_L2_40_8 hv_L1_23 0 0 NMIR W=48.0u L=1u
Mo1_uU_L2_40_8 da_uU_L2_40_8 d1bar_L2 ts_uU_L2_40_8 0 NMIR W=20u L=1u
Mo2_uU_L2_40_8 gp_2_40_8 dpre_L2_40 ts_uU_L2_40_8 0 NMIR W=20u L=1u
Mo3_uU_L2_40_8 da_uU_L2_40_8 da_uU_L2_40_8 vdd vdd PMIR W=60u L=1u
Mo4_uU_L2_40_8 gp_2_40_8 da_uU_L2_40_8 vdd vdd PMIR W=60u L=1u
Mt_uU_L2_40_9 ts_uU_L2_40_9 hv_L1_26 0 0 NMIR W=48.0u L=1u
Mo1_uU_L2_40_9 da_uU_L2_40_9 d1bar_L2 ts_uU_L2_40_9 0 NMIR W=20u L=1u
Mo2_uU_L2_40_9 gp_2_40_9 dpre_L2_40 ts_uU_L2_40_9 0 NMIR W=20u L=1u
Mo3_uU_L2_40_9 da_uU_L2_40_9 da_uU_L2_40_9 vdd vdd PMIR W=60u L=1u
Mo4_uU_L2_40_9 gp_2_40_9 da_uU_L2_40_9 vdd vdd PMIR W=60u L=1u
Mt_uU_L2_40_10 ts_uU_L2_40_10 hv_L1_34 0 0 NMIR W=48.0u L=1u
Mo1_uU_L2_40_10 da_uU_L2_40_10 d1bar_L2 ts_uU_L2_40_10 0 NMIR W=20u L=1u
Mo2_uU_L2_40_10 gp_2_40_10 dpre_L2_40 ts_uU_L2_40_10 0 NMIR W=20u L=1u
Mo3_uU_L2_40_10 da_uU_L2_40_10 da_uU_L2_40_10 vdd vdd PMIR W=60u L=1u
Mo4_uU_L2_40_10 gp_2_40_10 da_uU_L2_40_10 vdd vdd PMIR W=60u L=1u
Mt_uU_L2_40_11 ts_uU_L2_40_11 hv_L1_37 0 0 NMIR W=48.0u L=1u
Mo1_uU_L2_40_11 da_uU_L2_40_11 d1bar_L2 ts_uU_L2_40_11 0 NMIR W=20u L=1u
Mo2_uU_L2_40_11 gp_2_40_11 dpre_L2_40 ts_uU_L2_40_11 0 NMIR W=20u L=1u
Mo3_uU_L2_40_11 da_uU_L2_40_11 da_uU_L2_40_11 vdd vdd PMIR W=60u L=1u
Mo4_uU_L2_40_11 gp_2_40_11 da_uU_L2_40_11 vdd vdd PMIR W=60u L=1u
Mt_uU_L2_40_12 ts_uU_L2_40_12 hv_L1_38 0 0 NMIR W=48.0u L=1u
Mo1_uU_L2_40_12 da_uU_L2_40_12 d1bar_L2 ts_uU_L2_40_12 0 NMIR W=20u L=1u
Mo2_uU_L2_40_12 gp_2_40_12 dpre_L2_40 ts_uU_L2_40_12 0 NMIR W=20u L=1u
Mo3_uU_L2_40_12 da_uU_L2_40_12 da_uU_L2_40_12 vdd vdd PMIR W=60u L=1u
Mo4_uU_L2_40_12 gp_2_40_12 da_uU_L2_40_12 vdd vdd PMIR W=60u L=1u
Mt_uU_L2_40_13 ts_uU_L2_40_13 hv_L1_41 0 0 NMIR W=48.0u L=1u
Mo1_uU_L2_40_13 da_uU_L2_40_13 d1bar_L2 ts_uU_L2_40_13 0 NMIR W=20u L=1u
Mo2_uU_L2_40_13 gp_2_40_13 dpre_L2_40 ts_uU_L2_40_13 0 NMIR W=20u L=1u
Mo3_uU_L2_40_13 da_uU_L2_40_13 da_uU_L2_40_13 vdd vdd PMIR W=60u L=1u
Mo4_uU_L2_40_13 gp_2_40_13 da_uU_L2_40_13 vdd vdd PMIR W=60u L=1u
Mt_uU_L2_40_14 ts_uU_L2_40_14 hv_L1_44 0 0 NMIR W=48.0u L=1u
Mo1_uU_L2_40_14 da_uU_L2_40_14 d1bar_L2 ts_uU_L2_40_14 0 NMIR W=20u L=1u
Mo2_uU_L2_40_14 gp_2_40_14 dpre_L2_40 ts_uU_L2_40_14 0 NMIR W=20u L=1u
Mo3_uU_L2_40_14 da_uU_L2_40_14 da_uU_L2_40_14 vdd vdd PMIR W=60u L=1u
Mo4_uU_L2_40_14 gp_2_40_14 da_uU_L2_40_14 vdd vdd PMIR W=60u L=1u
Mt_uU_L2_40_15 ts_uU_L2_40_15 hv_L1_46 0 0 NMIR W=48.0u L=1u
Mo1_uU_L2_40_15 da_uU_L2_40_15 d1bar_L2 ts_uU_L2_40_15 0 NMIR W=20u L=1u
Mo2_uU_L2_40_15 gp_2_40_15 dpre_L2_40 ts_uU_L2_40_15 0 NMIR W=20u L=1u
Mo3_uU_L2_40_15 da_uU_L2_40_15 da_uU_L2_40_15 vdd vdd PMIR W=60u L=1u
Mo4_uU_L2_40_15 gp_2_40_15 da_uU_L2_40_15 vdd vdd PMIR W=60u L=1u
Mt_uU_L2_41_0 ts_uU_L2_41_0 hv_L1_0 0 0 NMIR W=48.0u L=1u
Mo1_uU_L2_41_0 da_uU_L2_41_0 d1bar_L2 ts_uU_L2_41_0 0 NMIR W=20u L=1u
Mo2_uU_L2_41_0 gp_2_41_0 dpre_L2_41 ts_uU_L2_41_0 0 NMIR W=20u L=1u
Mo3_uU_L2_41_0 da_uU_L2_41_0 da_uU_L2_41_0 vdd vdd PMIR W=60u L=1u
Mo4_uU_L2_41_0 gp_2_41_0 da_uU_L2_41_0 vdd vdd PMIR W=60u L=1u
Mt_uU_L2_41_1 ts_uU_L2_41_1 hv_L1_2 0 0 NMIR W=48.0u L=1u
Mo1_uU_L2_41_1 da_uU_L2_41_1 d1bar_L2 ts_uU_L2_41_1 0 NMIR W=20u L=1u
Mo2_uU_L2_41_1 gp_2_41_1 dpre_L2_41 ts_uU_L2_41_1 0 NMIR W=20u L=1u
Mo3_uU_L2_41_1 da_uU_L2_41_1 da_uU_L2_41_1 vdd vdd PMIR W=60u L=1u
Mo4_uU_L2_41_1 gp_2_41_1 da_uU_L2_41_1 vdd vdd PMIR W=60u L=1u
Mt_uU_L2_41_2 ts_uU_L2_41_2 hv_L1_3 0 0 NMIR W=48.0u L=1u
Mo1_uU_L2_41_2 da_uU_L2_41_2 d1bar_L2 ts_uU_L2_41_2 0 NMIR W=20u L=1u
Mo2_uU_L2_41_2 gp_2_41_2 dpre_L2_41 ts_uU_L2_41_2 0 NMIR W=20u L=1u
Mo3_uU_L2_41_2 da_uU_L2_41_2 da_uU_L2_41_2 vdd vdd PMIR W=60u L=1u
Mo4_uU_L2_41_2 gp_2_41_2 da_uU_L2_41_2 vdd vdd PMIR W=60u L=1u
Mt_uU_L2_41_3 ts_uU_L2_41_3 hv_L1_9 0 0 NMIR W=48.0u L=1u
Mo1_uU_L2_41_3 da_uU_L2_41_3 d1bar_L2 ts_uU_L2_41_3 0 NMIR W=20u L=1u
Mo2_uU_L2_41_3 gp_2_41_3 dpre_L2_41 ts_uU_L2_41_3 0 NMIR W=20u L=1u
Mo3_uU_L2_41_3 da_uU_L2_41_3 da_uU_L2_41_3 vdd vdd PMIR W=60u L=1u
Mo4_uU_L2_41_3 gp_2_41_3 da_uU_L2_41_3 vdd vdd PMIR W=60u L=1u
Mt_uU_L2_41_4 ts_uU_L2_41_4 hv_L1_16 0 0 NMIR W=48.0u L=1u
Mo1_uU_L2_41_4 da_uU_L2_41_4 d1bar_L2 ts_uU_L2_41_4 0 NMIR W=20u L=1u
Mo2_uU_L2_41_4 gp_2_41_4 dpre_L2_41 ts_uU_L2_41_4 0 NMIR W=20u L=1u
Mo3_uU_L2_41_4 da_uU_L2_41_4 da_uU_L2_41_4 vdd vdd PMIR W=60u L=1u
Mo4_uU_L2_41_4 gp_2_41_4 da_uU_L2_41_4 vdd vdd PMIR W=60u L=1u
Mt_uU_L2_41_5 ts_uU_L2_41_5 hv_L1_17 0 0 NMIR W=48.0u L=1u
Mo1_uU_L2_41_5 da_uU_L2_41_5 d1bar_L2 ts_uU_L2_41_5 0 NMIR W=20u L=1u
Mo2_uU_L2_41_5 gp_2_41_5 dpre_L2_41 ts_uU_L2_41_5 0 NMIR W=20u L=1u
Mo3_uU_L2_41_5 da_uU_L2_41_5 da_uU_L2_41_5 vdd vdd PMIR W=60u L=1u
Mo4_uU_L2_41_5 gp_2_41_5 da_uU_L2_41_5 vdd vdd PMIR W=60u L=1u
Mt_uU_L2_41_6 ts_uU_L2_41_6 hv_L1_19 0 0 NMIR W=48.0u L=1u
Mo1_uU_L2_41_6 da_uU_L2_41_6 d1bar_L2 ts_uU_L2_41_6 0 NMIR W=20u L=1u
Mo2_uU_L2_41_6 gp_2_41_6 dpre_L2_41 ts_uU_L2_41_6 0 NMIR W=20u L=1u
Mo3_uU_L2_41_6 da_uU_L2_41_6 da_uU_L2_41_6 vdd vdd PMIR W=60u L=1u
Mo4_uU_L2_41_6 gp_2_41_6 da_uU_L2_41_6 vdd vdd PMIR W=60u L=1u
Mt_uU_L2_41_7 ts_uU_L2_41_7 hv_L1_20 0 0 NMIR W=48.0u L=1u
Mo1_uU_L2_41_7 da_uU_L2_41_7 d1bar_L2 ts_uU_L2_41_7 0 NMIR W=20u L=1u
Mo2_uU_L2_41_7 gp_2_41_7 dpre_L2_41 ts_uU_L2_41_7 0 NMIR W=20u L=1u
Mo3_uU_L2_41_7 da_uU_L2_41_7 da_uU_L2_41_7 vdd vdd PMIR W=60u L=1u
Mo4_uU_L2_41_7 gp_2_41_7 da_uU_L2_41_7 vdd vdd PMIR W=60u L=1u
Mt_uU_L2_41_8 ts_uU_L2_41_8 hv_L1_21 0 0 NMIR W=48.0u L=1u
Mo1_uU_L2_41_8 da_uU_L2_41_8 d1bar_L2 ts_uU_L2_41_8 0 NMIR W=20u L=1u
Mo2_uU_L2_41_8 gp_2_41_8 dpre_L2_41 ts_uU_L2_41_8 0 NMIR W=20u L=1u
Mo3_uU_L2_41_8 da_uU_L2_41_8 da_uU_L2_41_8 vdd vdd PMIR W=60u L=1u
Mo4_uU_L2_41_8 gp_2_41_8 da_uU_L2_41_8 vdd vdd PMIR W=60u L=1u
Mt_uU_L2_41_9 ts_uU_L2_41_9 hv_L1_22 0 0 NMIR W=48.0u L=1u
Mo1_uU_L2_41_9 da_uU_L2_41_9 d1bar_L2 ts_uU_L2_41_9 0 NMIR W=20u L=1u
Mo2_uU_L2_41_9 gp_2_41_9 dpre_L2_41 ts_uU_L2_41_9 0 NMIR W=20u L=1u
Mo3_uU_L2_41_9 da_uU_L2_41_9 da_uU_L2_41_9 vdd vdd PMIR W=60u L=1u
Mo4_uU_L2_41_9 gp_2_41_9 da_uU_L2_41_9 vdd vdd PMIR W=60u L=1u
Mt_uU_L2_41_10 ts_uU_L2_41_10 hv_L1_23 0 0 NMIR W=48.0u L=1u
Mo1_uU_L2_41_10 da_uU_L2_41_10 d1bar_L2 ts_uU_L2_41_10 0 NMIR W=20u L=1u
Mo2_uU_L2_41_10 gp_2_41_10 dpre_L2_41 ts_uU_L2_41_10 0 NMIR W=20u L=1u
Mo3_uU_L2_41_10 da_uU_L2_41_10 da_uU_L2_41_10 vdd vdd PMIR W=60u L=1u
Mo4_uU_L2_41_10 gp_2_41_10 da_uU_L2_41_10 vdd vdd PMIR W=60u L=1u
Mt_uU_L2_41_11 ts_uU_L2_41_11 hv_L1_36 0 0 NMIR W=48.0u L=1u
Mo1_uU_L2_41_11 da_uU_L2_41_11 d1bar_L2 ts_uU_L2_41_11 0 NMIR W=20u L=1u
Mo2_uU_L2_41_11 gp_2_41_11 dpre_L2_41 ts_uU_L2_41_11 0 NMIR W=20u L=1u
Mo3_uU_L2_41_11 da_uU_L2_41_11 da_uU_L2_41_11 vdd vdd PMIR W=60u L=1u
Mo4_uU_L2_41_11 gp_2_41_11 da_uU_L2_41_11 vdd vdd PMIR W=60u L=1u
Mt_uU_L2_41_12 ts_uU_L2_41_12 hv_L1_41 0 0 NMIR W=48.0u L=1u
Mo1_uU_L2_41_12 da_uU_L2_41_12 d1bar_L2 ts_uU_L2_41_12 0 NMIR W=20u L=1u
Mo2_uU_L2_41_12 gp_2_41_12 dpre_L2_41 ts_uU_L2_41_12 0 NMIR W=20u L=1u
Mo3_uU_L2_41_12 da_uU_L2_41_12 da_uU_L2_41_12 vdd vdd PMIR W=60u L=1u
Mo4_uU_L2_41_12 gp_2_41_12 da_uU_L2_41_12 vdd vdd PMIR W=60u L=1u
Mt_uU_L2_41_13 ts_uU_L2_41_13 hv_L1_44 0 0 NMIR W=48.0u L=1u
Mo1_uU_L2_41_13 da_uU_L2_41_13 d1bar_L2 ts_uU_L2_41_13 0 NMIR W=20u L=1u
Mo2_uU_L2_41_13 gp_2_41_13 dpre_L2_41 ts_uU_L2_41_13 0 NMIR W=20u L=1u
Mo3_uU_L2_41_13 da_uU_L2_41_13 da_uU_L2_41_13 vdd vdd PMIR W=60u L=1u
Mo4_uU_L2_41_13 gp_2_41_13 da_uU_L2_41_13 vdd vdd PMIR W=60u L=1u
Mt_uU_L2_41_14 ts_uU_L2_41_14 hv_L1_45 0 0 NMIR W=48.0u L=1u
Mo1_uU_L2_41_14 da_uU_L2_41_14 d1bar_L2 ts_uU_L2_41_14 0 NMIR W=20u L=1u
Mo2_uU_L2_41_14 gp_2_41_14 dpre_L2_41 ts_uU_L2_41_14 0 NMIR W=20u L=1u
Mo3_uU_L2_41_14 da_uU_L2_41_14 da_uU_L2_41_14 vdd vdd PMIR W=60u L=1u
Mo4_uU_L2_41_14 gp_2_41_14 da_uU_L2_41_14 vdd vdd PMIR W=60u L=1u
Mt_uU_L2_41_15 ts_uU_L2_41_15 hv_L1_46 0 0 NMIR W=48.0u L=1u
Mo1_uU_L2_41_15 da_uU_L2_41_15 d1bar_L2 ts_uU_L2_41_15 0 NMIR W=20u L=1u
Mo2_uU_L2_41_15 gp_2_41_15 dpre_L2_41 ts_uU_L2_41_15 0 NMIR W=20u L=1u
Mo3_uU_L2_41_15 da_uU_L2_41_15 da_uU_L2_41_15 vdd vdd PMIR W=60u L=1u
Mo4_uU_L2_41_15 gp_2_41_15 da_uU_L2_41_15 vdd vdd PMIR W=60u L=1u
Mt_uU_L2_42_0 ts_uU_L2_42_0 hv_L1_1 0 0 NMIR W=48.0u L=1u
Mo1_uU_L2_42_0 da_uU_L2_42_0 d1bar_L2 ts_uU_L2_42_0 0 NMIR W=20u L=1u
Mo2_uU_L2_42_0 gp_2_42_0 dpre_L2_42 ts_uU_L2_42_0 0 NMIR W=20u L=1u
Mo3_uU_L2_42_0 da_uU_L2_42_0 da_uU_L2_42_0 vdd vdd PMIR W=60u L=1u
Mo4_uU_L2_42_0 gp_2_42_0 da_uU_L2_42_0 vdd vdd PMIR W=60u L=1u
Mt_uU_L2_42_1 ts_uU_L2_42_1 hv_L1_2 0 0 NMIR W=48.0u L=1u
Mo1_uU_L2_42_1 da_uU_L2_42_1 d1bar_L2 ts_uU_L2_42_1 0 NMIR W=20u L=1u
Mo2_uU_L2_42_1 gp_2_42_1 dpre_L2_42 ts_uU_L2_42_1 0 NMIR W=20u L=1u
Mo3_uU_L2_42_1 da_uU_L2_42_1 da_uU_L2_42_1 vdd vdd PMIR W=60u L=1u
Mo4_uU_L2_42_1 gp_2_42_1 da_uU_L2_42_1 vdd vdd PMIR W=60u L=1u
Mt_uU_L2_42_2 ts_uU_L2_42_2 hv_L1_6 0 0 NMIR W=48.0u L=1u
Mo1_uU_L2_42_2 da_uU_L2_42_2 d1bar_L2 ts_uU_L2_42_2 0 NMIR W=20u L=1u
Mo2_uU_L2_42_2 gp_2_42_2 dpre_L2_42 ts_uU_L2_42_2 0 NMIR W=20u L=1u
Mo3_uU_L2_42_2 da_uU_L2_42_2 da_uU_L2_42_2 vdd vdd PMIR W=60u L=1u
Mo4_uU_L2_42_2 gp_2_42_2 da_uU_L2_42_2 vdd vdd PMIR W=60u L=1u
Mt_uU_L2_42_3 ts_uU_L2_42_3 hv_L1_8 0 0 NMIR W=48.0u L=1u
Mo1_uU_L2_42_3 da_uU_L2_42_3 d1bar_L2 ts_uU_L2_42_3 0 NMIR W=20u L=1u
Mo2_uU_L2_42_3 gp_2_42_3 dpre_L2_42 ts_uU_L2_42_3 0 NMIR W=20u L=1u
Mo3_uU_L2_42_3 da_uU_L2_42_3 da_uU_L2_42_3 vdd vdd PMIR W=60u L=1u
Mo4_uU_L2_42_3 gp_2_42_3 da_uU_L2_42_3 vdd vdd PMIR W=60u L=1u
Mt_uU_L2_42_4 ts_uU_L2_42_4 hv_L1_12 0 0 NMIR W=48.0u L=1u
Mo1_uU_L2_42_4 da_uU_L2_42_4 d1bar_L2 ts_uU_L2_42_4 0 NMIR W=20u L=1u
Mo2_uU_L2_42_4 gp_2_42_4 dpre_L2_42 ts_uU_L2_42_4 0 NMIR W=20u L=1u
Mo3_uU_L2_42_4 da_uU_L2_42_4 da_uU_L2_42_4 vdd vdd PMIR W=60u L=1u
Mo4_uU_L2_42_4 gp_2_42_4 da_uU_L2_42_4 vdd vdd PMIR W=60u L=1u
Mt_uU_L2_42_5 ts_uU_L2_42_5 hv_L1_13 0 0 NMIR W=48.0u L=1u
Mo1_uU_L2_42_5 da_uU_L2_42_5 d1bar_L2 ts_uU_L2_42_5 0 NMIR W=20u L=1u
Mo2_uU_L2_42_5 gp_2_42_5 dpre_L2_42 ts_uU_L2_42_5 0 NMIR W=20u L=1u
Mo3_uU_L2_42_5 da_uU_L2_42_5 da_uU_L2_42_5 vdd vdd PMIR W=60u L=1u
Mo4_uU_L2_42_5 gp_2_42_5 da_uU_L2_42_5 vdd vdd PMIR W=60u L=1u
Mt_uU_L2_42_6 ts_uU_L2_42_6 hv_L1_15 0 0 NMIR W=48.0u L=1u
Mo1_uU_L2_42_6 da_uU_L2_42_6 d1bar_L2 ts_uU_L2_42_6 0 NMIR W=20u L=1u
Mo2_uU_L2_42_6 gp_2_42_6 dpre_L2_42 ts_uU_L2_42_6 0 NMIR W=20u L=1u
Mo3_uU_L2_42_6 da_uU_L2_42_6 da_uU_L2_42_6 vdd vdd PMIR W=60u L=1u
Mo4_uU_L2_42_6 gp_2_42_6 da_uU_L2_42_6 vdd vdd PMIR W=60u L=1u
Mt_uU_L2_42_7 ts_uU_L2_42_7 hv_L1_21 0 0 NMIR W=48.0u L=1u
Mo1_uU_L2_42_7 da_uU_L2_42_7 d1bar_L2 ts_uU_L2_42_7 0 NMIR W=20u L=1u
Mo2_uU_L2_42_7 gp_2_42_7 dpre_L2_42 ts_uU_L2_42_7 0 NMIR W=20u L=1u
Mo3_uU_L2_42_7 da_uU_L2_42_7 da_uU_L2_42_7 vdd vdd PMIR W=60u L=1u
Mo4_uU_L2_42_7 gp_2_42_7 da_uU_L2_42_7 vdd vdd PMIR W=60u L=1u
Mt_uU_L2_42_8 ts_uU_L2_42_8 hv_L1_22 0 0 NMIR W=48.0u L=1u
Mo1_uU_L2_42_8 da_uU_L2_42_8 d1bar_L2 ts_uU_L2_42_8 0 NMIR W=20u L=1u
Mo2_uU_L2_42_8 gp_2_42_8 dpre_L2_42 ts_uU_L2_42_8 0 NMIR W=20u L=1u
Mo3_uU_L2_42_8 da_uU_L2_42_8 da_uU_L2_42_8 vdd vdd PMIR W=60u L=1u
Mo4_uU_L2_42_8 gp_2_42_8 da_uU_L2_42_8 vdd vdd PMIR W=60u L=1u
Mt_uU_L2_42_9 ts_uU_L2_42_9 hv_L1_32 0 0 NMIR W=48.0u L=1u
Mo1_uU_L2_42_9 da_uU_L2_42_9 d1bar_L2 ts_uU_L2_42_9 0 NMIR W=20u L=1u
Mo2_uU_L2_42_9 gp_2_42_9 dpre_L2_42 ts_uU_L2_42_9 0 NMIR W=20u L=1u
Mo3_uU_L2_42_9 da_uU_L2_42_9 da_uU_L2_42_9 vdd vdd PMIR W=60u L=1u
Mo4_uU_L2_42_9 gp_2_42_9 da_uU_L2_42_9 vdd vdd PMIR W=60u L=1u
Mt_uU_L2_42_10 ts_uU_L2_42_10 hv_L1_34 0 0 NMIR W=48.0u L=1u
Mo1_uU_L2_42_10 da_uU_L2_42_10 d1bar_L2 ts_uU_L2_42_10 0 NMIR W=20u L=1u
Mo2_uU_L2_42_10 gp_2_42_10 dpre_L2_42 ts_uU_L2_42_10 0 NMIR W=20u L=1u
Mo3_uU_L2_42_10 da_uU_L2_42_10 da_uU_L2_42_10 vdd vdd PMIR W=60u L=1u
Mo4_uU_L2_42_10 gp_2_42_10 da_uU_L2_42_10 vdd vdd PMIR W=60u L=1u
Mt_uU_L2_42_11 ts_uU_L2_42_11 hv_L1_35 0 0 NMIR W=48.0u L=1u
Mo1_uU_L2_42_11 da_uU_L2_42_11 d1bar_L2 ts_uU_L2_42_11 0 NMIR W=20u L=1u
Mo2_uU_L2_42_11 gp_2_42_11 dpre_L2_42 ts_uU_L2_42_11 0 NMIR W=20u L=1u
Mo3_uU_L2_42_11 da_uU_L2_42_11 da_uU_L2_42_11 vdd vdd PMIR W=60u L=1u
Mo4_uU_L2_42_11 gp_2_42_11 da_uU_L2_42_11 vdd vdd PMIR W=60u L=1u
Mt_uU_L2_42_12 ts_uU_L2_42_12 hv_L1_38 0 0 NMIR W=48.0u L=1u
Mo1_uU_L2_42_12 da_uU_L2_42_12 d1bar_L2 ts_uU_L2_42_12 0 NMIR W=20u L=1u
Mo2_uU_L2_42_12 gp_2_42_12 dpre_L2_42 ts_uU_L2_42_12 0 NMIR W=20u L=1u
Mo3_uU_L2_42_12 da_uU_L2_42_12 da_uU_L2_42_12 vdd vdd PMIR W=60u L=1u
Mo4_uU_L2_42_12 gp_2_42_12 da_uU_L2_42_12 vdd vdd PMIR W=60u L=1u
Mt_uU_L2_42_13 ts_uU_L2_42_13 hv_L1_40 0 0 NMIR W=48.0u L=1u
Mo1_uU_L2_42_13 da_uU_L2_42_13 d1bar_L2 ts_uU_L2_42_13 0 NMIR W=20u L=1u
Mo2_uU_L2_42_13 gp_2_42_13 dpre_L2_42 ts_uU_L2_42_13 0 NMIR W=20u L=1u
Mo3_uU_L2_42_13 da_uU_L2_42_13 da_uU_L2_42_13 vdd vdd PMIR W=60u L=1u
Mo4_uU_L2_42_13 gp_2_42_13 da_uU_L2_42_13 vdd vdd PMIR W=60u L=1u
Mt_uU_L2_42_14 ts_uU_L2_42_14 hv_L1_43 0 0 NMIR W=48.0u L=1u
Mo1_uU_L2_42_14 da_uU_L2_42_14 d1bar_L2 ts_uU_L2_42_14 0 NMIR W=20u L=1u
Mo2_uU_L2_42_14 gp_2_42_14 dpre_L2_42 ts_uU_L2_42_14 0 NMIR W=20u L=1u
Mo3_uU_L2_42_14 da_uU_L2_42_14 da_uU_L2_42_14 vdd vdd PMIR W=60u L=1u
Mo4_uU_L2_42_14 gp_2_42_14 da_uU_L2_42_14 vdd vdd PMIR W=60u L=1u
Mt_uU_L2_42_15 ts_uU_L2_42_15 hv_L1_44 0 0 NMIR W=48.0u L=1u
Mo1_uU_L2_42_15 da_uU_L2_42_15 d1bar_L2 ts_uU_L2_42_15 0 NMIR W=20u L=1u
Mo2_uU_L2_42_15 gp_2_42_15 dpre_L2_42 ts_uU_L2_42_15 0 NMIR W=20u L=1u
Mo3_uU_L2_42_15 da_uU_L2_42_15 da_uU_L2_42_15 vdd vdd PMIR W=60u L=1u
Mo4_uU_L2_42_15 gp_2_42_15 da_uU_L2_42_15 vdd vdd PMIR W=60u L=1u
Mt_uU_L2_43_0 ts_uU_L2_43_0 hv_L1_2 0 0 NMIR W=48.0u L=1u
Mo1_uU_L2_43_0 da_uU_L2_43_0 d1bar_L2 ts_uU_L2_43_0 0 NMIR W=20u L=1u
Mo2_uU_L2_43_0 gp_2_43_0 dpre_L2_43 ts_uU_L2_43_0 0 NMIR W=20u L=1u
Mo3_uU_L2_43_0 da_uU_L2_43_0 da_uU_L2_43_0 vdd vdd PMIR W=60u L=1u
Mo4_uU_L2_43_0 gp_2_43_0 da_uU_L2_43_0 vdd vdd PMIR W=60u L=1u
Mt_uU_L2_43_1 ts_uU_L2_43_1 hv_L1_5 0 0 NMIR W=48.0u L=1u
Mo1_uU_L2_43_1 da_uU_L2_43_1 d1bar_L2 ts_uU_L2_43_1 0 NMIR W=20u L=1u
Mo2_uU_L2_43_1 gp_2_43_1 dpre_L2_43 ts_uU_L2_43_1 0 NMIR W=20u L=1u
Mo3_uU_L2_43_1 da_uU_L2_43_1 da_uU_L2_43_1 vdd vdd PMIR W=60u L=1u
Mo4_uU_L2_43_1 gp_2_43_1 da_uU_L2_43_1 vdd vdd PMIR W=60u L=1u
Mt_uU_L2_43_2 ts_uU_L2_43_2 hv_L1_7 0 0 NMIR W=48.0u L=1u
Mo1_uU_L2_43_2 da_uU_L2_43_2 d1bar_L2 ts_uU_L2_43_2 0 NMIR W=20u L=1u
Mo2_uU_L2_43_2 gp_2_43_2 dpre_L2_43 ts_uU_L2_43_2 0 NMIR W=20u L=1u
Mo3_uU_L2_43_2 da_uU_L2_43_2 da_uU_L2_43_2 vdd vdd PMIR W=60u L=1u
Mo4_uU_L2_43_2 gp_2_43_2 da_uU_L2_43_2 vdd vdd PMIR W=60u L=1u
Mt_uU_L2_43_3 ts_uU_L2_43_3 hv_L1_8 0 0 NMIR W=48.0u L=1u
Mo1_uU_L2_43_3 da_uU_L2_43_3 d1bar_L2 ts_uU_L2_43_3 0 NMIR W=20u L=1u
Mo2_uU_L2_43_3 gp_2_43_3 dpre_L2_43 ts_uU_L2_43_3 0 NMIR W=20u L=1u
Mo3_uU_L2_43_3 da_uU_L2_43_3 da_uU_L2_43_3 vdd vdd PMIR W=60u L=1u
Mo4_uU_L2_43_3 gp_2_43_3 da_uU_L2_43_3 vdd vdd PMIR W=60u L=1u
Mt_uU_L2_43_4 ts_uU_L2_43_4 hv_L1_11 0 0 NMIR W=48.0u L=1u
Mo1_uU_L2_43_4 da_uU_L2_43_4 d1bar_L2 ts_uU_L2_43_4 0 NMIR W=20u L=1u
Mo2_uU_L2_43_4 gp_2_43_4 dpre_L2_43 ts_uU_L2_43_4 0 NMIR W=20u L=1u
Mo3_uU_L2_43_4 da_uU_L2_43_4 da_uU_L2_43_4 vdd vdd PMIR W=60u L=1u
Mo4_uU_L2_43_4 gp_2_43_4 da_uU_L2_43_4 vdd vdd PMIR W=60u L=1u
Mt_uU_L2_43_5 ts_uU_L2_43_5 hv_L1_12 0 0 NMIR W=48.0u L=1u
Mo1_uU_L2_43_5 da_uU_L2_43_5 d1bar_L2 ts_uU_L2_43_5 0 NMIR W=20u L=1u
Mo2_uU_L2_43_5 gp_2_43_5 dpre_L2_43 ts_uU_L2_43_5 0 NMIR W=20u L=1u
Mo3_uU_L2_43_5 da_uU_L2_43_5 da_uU_L2_43_5 vdd vdd PMIR W=60u L=1u
Mo4_uU_L2_43_5 gp_2_43_5 da_uU_L2_43_5 vdd vdd PMIR W=60u L=1u
Mt_uU_L2_43_6 ts_uU_L2_43_6 hv_L1_15 0 0 NMIR W=48.0u L=1u
Mo1_uU_L2_43_6 da_uU_L2_43_6 d1bar_L2 ts_uU_L2_43_6 0 NMIR W=20u L=1u
Mo2_uU_L2_43_6 gp_2_43_6 dpre_L2_43 ts_uU_L2_43_6 0 NMIR W=20u L=1u
Mo3_uU_L2_43_6 da_uU_L2_43_6 da_uU_L2_43_6 vdd vdd PMIR W=60u L=1u
Mo4_uU_L2_43_6 gp_2_43_6 da_uU_L2_43_6 vdd vdd PMIR W=60u L=1u
Mt_uU_L2_43_7 ts_uU_L2_43_7 hv_L1_18 0 0 NMIR W=48.0u L=1u
Mo1_uU_L2_43_7 da_uU_L2_43_7 d1bar_L2 ts_uU_L2_43_7 0 NMIR W=20u L=1u
Mo2_uU_L2_43_7 gp_2_43_7 dpre_L2_43 ts_uU_L2_43_7 0 NMIR W=20u L=1u
Mo3_uU_L2_43_7 da_uU_L2_43_7 da_uU_L2_43_7 vdd vdd PMIR W=60u L=1u
Mo4_uU_L2_43_7 gp_2_43_7 da_uU_L2_43_7 vdd vdd PMIR W=60u L=1u
Mt_uU_L2_43_8 ts_uU_L2_43_8 hv_L1_23 0 0 NMIR W=48.0u L=1u
Mo1_uU_L2_43_8 da_uU_L2_43_8 d1bar_L2 ts_uU_L2_43_8 0 NMIR W=20u L=1u
Mo2_uU_L2_43_8 gp_2_43_8 dpre_L2_43 ts_uU_L2_43_8 0 NMIR W=20u L=1u
Mo3_uU_L2_43_8 da_uU_L2_43_8 da_uU_L2_43_8 vdd vdd PMIR W=60u L=1u
Mo4_uU_L2_43_8 gp_2_43_8 da_uU_L2_43_8 vdd vdd PMIR W=60u L=1u
Mt_uU_L2_43_9 ts_uU_L2_43_9 hv_L1_27 0 0 NMIR W=48.0u L=1u
Mo1_uU_L2_43_9 da_uU_L2_43_9 d1bar_L2 ts_uU_L2_43_9 0 NMIR W=20u L=1u
Mo2_uU_L2_43_9 gp_2_43_9 dpre_L2_43 ts_uU_L2_43_9 0 NMIR W=20u L=1u
Mo3_uU_L2_43_9 da_uU_L2_43_9 da_uU_L2_43_9 vdd vdd PMIR W=60u L=1u
Mo4_uU_L2_43_9 gp_2_43_9 da_uU_L2_43_9 vdd vdd PMIR W=60u L=1u
Mt_uU_L2_43_10 ts_uU_L2_43_10 hv_L1_31 0 0 NMIR W=48.0u L=1u
Mo1_uU_L2_43_10 da_uU_L2_43_10 d1bar_L2 ts_uU_L2_43_10 0 NMIR W=20u L=1u
Mo2_uU_L2_43_10 gp_2_43_10 dpre_L2_43 ts_uU_L2_43_10 0 NMIR W=20u L=1u
Mo3_uU_L2_43_10 da_uU_L2_43_10 da_uU_L2_43_10 vdd vdd PMIR W=60u L=1u
Mo4_uU_L2_43_10 gp_2_43_10 da_uU_L2_43_10 vdd vdd PMIR W=60u L=1u
Mt_uU_L2_43_11 ts_uU_L2_43_11 hv_L1_32 0 0 NMIR W=48.0u L=1u
Mo1_uU_L2_43_11 da_uU_L2_43_11 d1bar_L2 ts_uU_L2_43_11 0 NMIR W=20u L=1u
Mo2_uU_L2_43_11 gp_2_43_11 dpre_L2_43 ts_uU_L2_43_11 0 NMIR W=20u L=1u
Mo3_uU_L2_43_11 da_uU_L2_43_11 da_uU_L2_43_11 vdd vdd PMIR W=60u L=1u
Mo4_uU_L2_43_11 gp_2_43_11 da_uU_L2_43_11 vdd vdd PMIR W=60u L=1u
Mt_uU_L2_43_12 ts_uU_L2_43_12 hv_L1_37 0 0 NMIR W=48.0u L=1u
Mo1_uU_L2_43_12 da_uU_L2_43_12 d1bar_L2 ts_uU_L2_43_12 0 NMIR W=20u L=1u
Mo2_uU_L2_43_12 gp_2_43_12 dpre_L2_43 ts_uU_L2_43_12 0 NMIR W=20u L=1u
Mo3_uU_L2_43_12 da_uU_L2_43_12 da_uU_L2_43_12 vdd vdd PMIR W=60u L=1u
Mo4_uU_L2_43_12 gp_2_43_12 da_uU_L2_43_12 vdd vdd PMIR W=60u L=1u
Mt_uU_L2_43_13 ts_uU_L2_43_13 hv_L1_38 0 0 NMIR W=48.0u L=1u
Mo1_uU_L2_43_13 da_uU_L2_43_13 d1bar_L2 ts_uU_L2_43_13 0 NMIR W=20u L=1u
Mo2_uU_L2_43_13 gp_2_43_13 dpre_L2_43 ts_uU_L2_43_13 0 NMIR W=20u L=1u
Mo3_uU_L2_43_13 da_uU_L2_43_13 da_uU_L2_43_13 vdd vdd PMIR W=60u L=1u
Mo4_uU_L2_43_13 gp_2_43_13 da_uU_L2_43_13 vdd vdd PMIR W=60u L=1u
Mt_uU_L2_43_14 ts_uU_L2_43_14 hv_L1_39 0 0 NMIR W=48.0u L=1u
Mo1_uU_L2_43_14 da_uU_L2_43_14 d1bar_L2 ts_uU_L2_43_14 0 NMIR W=20u L=1u
Mo2_uU_L2_43_14 gp_2_43_14 dpre_L2_43 ts_uU_L2_43_14 0 NMIR W=20u L=1u
Mo3_uU_L2_43_14 da_uU_L2_43_14 da_uU_L2_43_14 vdd vdd PMIR W=60u L=1u
Mo4_uU_L2_43_14 gp_2_43_14 da_uU_L2_43_14 vdd vdd PMIR W=60u L=1u
Mt_uU_L2_43_15 ts_uU_L2_43_15 hv_L1_47 0 0 NMIR W=48.0u L=1u
Mo1_uU_L2_43_15 da_uU_L2_43_15 d1bar_L2 ts_uU_L2_43_15 0 NMIR W=20u L=1u
Mo2_uU_L2_43_15 gp_2_43_15 dpre_L2_43 ts_uU_L2_43_15 0 NMIR W=20u L=1u
Mo3_uU_L2_43_15 da_uU_L2_43_15 da_uU_L2_43_15 vdd vdd PMIR W=60u L=1u
Mo4_uU_L2_43_15 gp_2_43_15 da_uU_L2_43_15 vdd vdd PMIR W=60u L=1u
Mt_uU_L2_44_0 ts_uU_L2_44_0 hv_L1_2 0 0 NMIR W=48.0u L=1u
Mo1_uU_L2_44_0 da_uU_L2_44_0 d1bar_L2 ts_uU_L2_44_0 0 NMIR W=20u L=1u
Mo2_uU_L2_44_0 gp_2_44_0 dpre_L2_44 ts_uU_L2_44_0 0 NMIR W=20u L=1u
Mo3_uU_L2_44_0 da_uU_L2_44_0 da_uU_L2_44_0 vdd vdd PMIR W=60u L=1u
Mo4_uU_L2_44_0 gp_2_44_0 da_uU_L2_44_0 vdd vdd PMIR W=60u L=1u
Mt_uU_L2_44_1 ts_uU_L2_44_1 hv_L1_3 0 0 NMIR W=48.0u L=1u
Mo1_uU_L2_44_1 da_uU_L2_44_1 d1bar_L2 ts_uU_L2_44_1 0 NMIR W=20u L=1u
Mo2_uU_L2_44_1 gp_2_44_1 dpre_L2_44 ts_uU_L2_44_1 0 NMIR W=20u L=1u
Mo3_uU_L2_44_1 da_uU_L2_44_1 da_uU_L2_44_1 vdd vdd PMIR W=60u L=1u
Mo4_uU_L2_44_1 gp_2_44_1 da_uU_L2_44_1 vdd vdd PMIR W=60u L=1u
Mt_uU_L2_44_2 ts_uU_L2_44_2 hv_L1_9 0 0 NMIR W=48.0u L=1u
Mo1_uU_L2_44_2 da_uU_L2_44_2 d1bar_L2 ts_uU_L2_44_2 0 NMIR W=20u L=1u
Mo2_uU_L2_44_2 gp_2_44_2 dpre_L2_44 ts_uU_L2_44_2 0 NMIR W=20u L=1u
Mo3_uU_L2_44_2 da_uU_L2_44_2 da_uU_L2_44_2 vdd vdd PMIR W=60u L=1u
Mo4_uU_L2_44_2 gp_2_44_2 da_uU_L2_44_2 vdd vdd PMIR W=60u L=1u
Mt_uU_L2_44_3 ts_uU_L2_44_3 hv_L1_14 0 0 NMIR W=48.0u L=1u
Mo1_uU_L2_44_3 da_uU_L2_44_3 d1bar_L2 ts_uU_L2_44_3 0 NMIR W=20u L=1u
Mo2_uU_L2_44_3 gp_2_44_3 dpre_L2_44 ts_uU_L2_44_3 0 NMIR W=20u L=1u
Mo3_uU_L2_44_3 da_uU_L2_44_3 da_uU_L2_44_3 vdd vdd PMIR W=60u L=1u
Mo4_uU_L2_44_3 gp_2_44_3 da_uU_L2_44_3 vdd vdd PMIR W=60u L=1u
Mt_uU_L2_44_4 ts_uU_L2_44_4 hv_L1_15 0 0 NMIR W=48.0u L=1u
Mo1_uU_L2_44_4 da_uU_L2_44_4 d1bar_L2 ts_uU_L2_44_4 0 NMIR W=20u L=1u
Mo2_uU_L2_44_4 gp_2_44_4 dpre_L2_44 ts_uU_L2_44_4 0 NMIR W=20u L=1u
Mo3_uU_L2_44_4 da_uU_L2_44_4 da_uU_L2_44_4 vdd vdd PMIR W=60u L=1u
Mo4_uU_L2_44_4 gp_2_44_4 da_uU_L2_44_4 vdd vdd PMIR W=60u L=1u
Mt_uU_L2_44_5 ts_uU_L2_44_5 hv_L1_16 0 0 NMIR W=48.0u L=1u
Mo1_uU_L2_44_5 da_uU_L2_44_5 d1bar_L2 ts_uU_L2_44_5 0 NMIR W=20u L=1u
Mo2_uU_L2_44_5 gp_2_44_5 dpre_L2_44 ts_uU_L2_44_5 0 NMIR W=20u L=1u
Mo3_uU_L2_44_5 da_uU_L2_44_5 da_uU_L2_44_5 vdd vdd PMIR W=60u L=1u
Mo4_uU_L2_44_5 gp_2_44_5 da_uU_L2_44_5 vdd vdd PMIR W=60u L=1u
Mt_uU_L2_44_6 ts_uU_L2_44_6 hv_L1_18 0 0 NMIR W=48.0u L=1u
Mo1_uU_L2_44_6 da_uU_L2_44_6 d1bar_L2 ts_uU_L2_44_6 0 NMIR W=20u L=1u
Mo2_uU_L2_44_6 gp_2_44_6 dpre_L2_44 ts_uU_L2_44_6 0 NMIR W=20u L=1u
Mo3_uU_L2_44_6 da_uU_L2_44_6 da_uU_L2_44_6 vdd vdd PMIR W=60u L=1u
Mo4_uU_L2_44_6 gp_2_44_6 da_uU_L2_44_6 vdd vdd PMIR W=60u L=1u
Mt_uU_L2_44_7 ts_uU_L2_44_7 hv_L1_20 0 0 NMIR W=48.0u L=1u
Mo1_uU_L2_44_7 da_uU_L2_44_7 d1bar_L2 ts_uU_L2_44_7 0 NMIR W=20u L=1u
Mo2_uU_L2_44_7 gp_2_44_7 dpre_L2_44 ts_uU_L2_44_7 0 NMIR W=20u L=1u
Mo3_uU_L2_44_7 da_uU_L2_44_7 da_uU_L2_44_7 vdd vdd PMIR W=60u L=1u
Mo4_uU_L2_44_7 gp_2_44_7 da_uU_L2_44_7 vdd vdd PMIR W=60u L=1u
Mt_uU_L2_44_8 ts_uU_L2_44_8 hv_L1_21 0 0 NMIR W=48.0u L=1u
Mo1_uU_L2_44_8 da_uU_L2_44_8 d1bar_L2 ts_uU_L2_44_8 0 NMIR W=20u L=1u
Mo2_uU_L2_44_8 gp_2_44_8 dpre_L2_44 ts_uU_L2_44_8 0 NMIR W=20u L=1u
Mo3_uU_L2_44_8 da_uU_L2_44_8 da_uU_L2_44_8 vdd vdd PMIR W=60u L=1u
Mo4_uU_L2_44_8 gp_2_44_8 da_uU_L2_44_8 vdd vdd PMIR W=60u L=1u
Mt_uU_L2_44_9 ts_uU_L2_44_9 hv_L1_22 0 0 NMIR W=48.0u L=1u
Mo1_uU_L2_44_9 da_uU_L2_44_9 d1bar_L2 ts_uU_L2_44_9 0 NMIR W=20u L=1u
Mo2_uU_L2_44_9 gp_2_44_9 dpre_L2_44 ts_uU_L2_44_9 0 NMIR W=20u L=1u
Mo3_uU_L2_44_9 da_uU_L2_44_9 da_uU_L2_44_9 vdd vdd PMIR W=60u L=1u
Mo4_uU_L2_44_9 gp_2_44_9 da_uU_L2_44_9 vdd vdd PMIR W=60u L=1u
Mt_uU_L2_44_10 ts_uU_L2_44_10 hv_L1_25 0 0 NMIR W=48.0u L=1u
Mo1_uU_L2_44_10 da_uU_L2_44_10 d1bar_L2 ts_uU_L2_44_10 0 NMIR W=20u L=1u
Mo2_uU_L2_44_10 gp_2_44_10 dpre_L2_44 ts_uU_L2_44_10 0 NMIR W=20u L=1u
Mo3_uU_L2_44_10 da_uU_L2_44_10 da_uU_L2_44_10 vdd vdd PMIR W=60u L=1u
Mo4_uU_L2_44_10 gp_2_44_10 da_uU_L2_44_10 vdd vdd PMIR W=60u L=1u
Mt_uU_L2_44_11 ts_uU_L2_44_11 hv_L1_28 0 0 NMIR W=48.0u L=1u
Mo1_uU_L2_44_11 da_uU_L2_44_11 d1bar_L2 ts_uU_L2_44_11 0 NMIR W=20u L=1u
Mo2_uU_L2_44_11 gp_2_44_11 dpre_L2_44 ts_uU_L2_44_11 0 NMIR W=20u L=1u
Mo3_uU_L2_44_11 da_uU_L2_44_11 da_uU_L2_44_11 vdd vdd PMIR W=60u L=1u
Mo4_uU_L2_44_11 gp_2_44_11 da_uU_L2_44_11 vdd vdd PMIR W=60u L=1u
Mt_uU_L2_44_12 ts_uU_L2_44_12 hv_L1_36 0 0 NMIR W=48.0u L=1u
Mo1_uU_L2_44_12 da_uU_L2_44_12 d1bar_L2 ts_uU_L2_44_12 0 NMIR W=20u L=1u
Mo2_uU_L2_44_12 gp_2_44_12 dpre_L2_44 ts_uU_L2_44_12 0 NMIR W=20u L=1u
Mo3_uU_L2_44_12 da_uU_L2_44_12 da_uU_L2_44_12 vdd vdd PMIR W=60u L=1u
Mo4_uU_L2_44_12 gp_2_44_12 da_uU_L2_44_12 vdd vdd PMIR W=60u L=1u
Mt_uU_L2_44_13 ts_uU_L2_44_13 hv_L1_38 0 0 NMIR W=48.0u L=1u
Mo1_uU_L2_44_13 da_uU_L2_44_13 d1bar_L2 ts_uU_L2_44_13 0 NMIR W=20u L=1u
Mo2_uU_L2_44_13 gp_2_44_13 dpre_L2_44 ts_uU_L2_44_13 0 NMIR W=20u L=1u
Mo3_uU_L2_44_13 da_uU_L2_44_13 da_uU_L2_44_13 vdd vdd PMIR W=60u L=1u
Mo4_uU_L2_44_13 gp_2_44_13 da_uU_L2_44_13 vdd vdd PMIR W=60u L=1u
Mt_uU_L2_44_14 ts_uU_L2_44_14 hv_L1_39 0 0 NMIR W=48.0u L=1u
Mo1_uU_L2_44_14 da_uU_L2_44_14 d1bar_L2 ts_uU_L2_44_14 0 NMIR W=20u L=1u
Mo2_uU_L2_44_14 gp_2_44_14 dpre_L2_44 ts_uU_L2_44_14 0 NMIR W=20u L=1u
Mo3_uU_L2_44_14 da_uU_L2_44_14 da_uU_L2_44_14 vdd vdd PMIR W=60u L=1u
Mo4_uU_L2_44_14 gp_2_44_14 da_uU_L2_44_14 vdd vdd PMIR W=60u L=1u
Mt_uU_L2_44_15 ts_uU_L2_44_15 hv_L1_47 0 0 NMIR W=48.0u L=1u
Mo1_uU_L2_44_15 da_uU_L2_44_15 d1bar_L2 ts_uU_L2_44_15 0 NMIR W=20u L=1u
Mo2_uU_L2_44_15 gp_2_44_15 dpre_L2_44 ts_uU_L2_44_15 0 NMIR W=20u L=1u
Mo3_uU_L2_44_15 da_uU_L2_44_15 da_uU_L2_44_15 vdd vdd PMIR W=60u L=1u
Mo4_uU_L2_44_15 gp_2_44_15 da_uU_L2_44_15 vdd vdd PMIR W=60u L=1u
Mt_uU_L2_45_0 ts_uU_L2_45_0 hv_L1_2 0 0 NMIR W=48.0u L=1u
Mo1_uU_L2_45_0 da_uU_L2_45_0 d1bar_L2 ts_uU_L2_45_0 0 NMIR W=20u L=1u
Mo2_uU_L2_45_0 gp_2_45_0 dpre_L2_45 ts_uU_L2_45_0 0 NMIR W=20u L=1u
Mo3_uU_L2_45_0 da_uU_L2_45_0 da_uU_L2_45_0 vdd vdd PMIR W=60u L=1u
Mo4_uU_L2_45_0 gp_2_45_0 da_uU_L2_45_0 vdd vdd PMIR W=60u L=1u
Mt_uU_L2_45_1 ts_uU_L2_45_1 hv_L1_7 0 0 NMIR W=48.0u L=1u
Mo1_uU_L2_45_1 da_uU_L2_45_1 d1bar_L2 ts_uU_L2_45_1 0 NMIR W=20u L=1u
Mo2_uU_L2_45_1 gp_2_45_1 dpre_L2_45 ts_uU_L2_45_1 0 NMIR W=20u L=1u
Mo3_uU_L2_45_1 da_uU_L2_45_1 da_uU_L2_45_1 vdd vdd PMIR W=60u L=1u
Mo4_uU_L2_45_1 gp_2_45_1 da_uU_L2_45_1 vdd vdd PMIR W=60u L=1u
Mt_uU_L2_45_2 ts_uU_L2_45_2 hv_L1_10 0 0 NMIR W=48.0u L=1u
Mo1_uU_L2_45_2 da_uU_L2_45_2 d1bar_L2 ts_uU_L2_45_2 0 NMIR W=20u L=1u
Mo2_uU_L2_45_2 gp_2_45_2 dpre_L2_45 ts_uU_L2_45_2 0 NMIR W=20u L=1u
Mo3_uU_L2_45_2 da_uU_L2_45_2 da_uU_L2_45_2 vdd vdd PMIR W=60u L=1u
Mo4_uU_L2_45_2 gp_2_45_2 da_uU_L2_45_2 vdd vdd PMIR W=60u L=1u
Mt_uU_L2_45_3 ts_uU_L2_45_3 hv_L1_11 0 0 NMIR W=48.0u L=1u
Mo1_uU_L2_45_3 da_uU_L2_45_3 d1bar_L2 ts_uU_L2_45_3 0 NMIR W=20u L=1u
Mo2_uU_L2_45_3 gp_2_45_3 dpre_L2_45 ts_uU_L2_45_3 0 NMIR W=20u L=1u
Mo3_uU_L2_45_3 da_uU_L2_45_3 da_uU_L2_45_3 vdd vdd PMIR W=60u L=1u
Mo4_uU_L2_45_3 gp_2_45_3 da_uU_L2_45_3 vdd vdd PMIR W=60u L=1u
Mt_uU_L2_45_4 ts_uU_L2_45_4 hv_L1_12 0 0 NMIR W=48.0u L=1u
Mo1_uU_L2_45_4 da_uU_L2_45_4 d1bar_L2 ts_uU_L2_45_4 0 NMIR W=20u L=1u
Mo2_uU_L2_45_4 gp_2_45_4 dpre_L2_45 ts_uU_L2_45_4 0 NMIR W=20u L=1u
Mo3_uU_L2_45_4 da_uU_L2_45_4 da_uU_L2_45_4 vdd vdd PMIR W=60u L=1u
Mo4_uU_L2_45_4 gp_2_45_4 da_uU_L2_45_4 vdd vdd PMIR W=60u L=1u
Mt_uU_L2_45_5 ts_uU_L2_45_5 hv_L1_13 0 0 NMIR W=48.0u L=1u
Mo1_uU_L2_45_5 da_uU_L2_45_5 d1bar_L2 ts_uU_L2_45_5 0 NMIR W=20u L=1u
Mo2_uU_L2_45_5 gp_2_45_5 dpre_L2_45 ts_uU_L2_45_5 0 NMIR W=20u L=1u
Mo3_uU_L2_45_5 da_uU_L2_45_5 da_uU_L2_45_5 vdd vdd PMIR W=60u L=1u
Mo4_uU_L2_45_5 gp_2_45_5 da_uU_L2_45_5 vdd vdd PMIR W=60u L=1u
Mt_uU_L2_45_6 ts_uU_L2_45_6 hv_L1_14 0 0 NMIR W=48.0u L=1u
Mo1_uU_L2_45_6 da_uU_L2_45_6 d1bar_L2 ts_uU_L2_45_6 0 NMIR W=20u L=1u
Mo2_uU_L2_45_6 gp_2_45_6 dpre_L2_45 ts_uU_L2_45_6 0 NMIR W=20u L=1u
Mo3_uU_L2_45_6 da_uU_L2_45_6 da_uU_L2_45_6 vdd vdd PMIR W=60u L=1u
Mo4_uU_L2_45_6 gp_2_45_6 da_uU_L2_45_6 vdd vdd PMIR W=60u L=1u
Mt_uU_L2_45_7 ts_uU_L2_45_7 hv_L1_19 0 0 NMIR W=48.0u L=1u
Mo1_uU_L2_45_7 da_uU_L2_45_7 d1bar_L2 ts_uU_L2_45_7 0 NMIR W=20u L=1u
Mo2_uU_L2_45_7 gp_2_45_7 dpre_L2_45 ts_uU_L2_45_7 0 NMIR W=20u L=1u
Mo3_uU_L2_45_7 da_uU_L2_45_7 da_uU_L2_45_7 vdd vdd PMIR W=60u L=1u
Mo4_uU_L2_45_7 gp_2_45_7 da_uU_L2_45_7 vdd vdd PMIR W=60u L=1u
Mt_uU_L2_45_8 ts_uU_L2_45_8 hv_L1_26 0 0 NMIR W=48.0u L=1u
Mo1_uU_L2_45_8 da_uU_L2_45_8 d1bar_L2 ts_uU_L2_45_8 0 NMIR W=20u L=1u
Mo2_uU_L2_45_8 gp_2_45_8 dpre_L2_45 ts_uU_L2_45_8 0 NMIR W=20u L=1u
Mo3_uU_L2_45_8 da_uU_L2_45_8 da_uU_L2_45_8 vdd vdd PMIR W=60u L=1u
Mo4_uU_L2_45_8 gp_2_45_8 da_uU_L2_45_8 vdd vdd PMIR W=60u L=1u
Mt_uU_L2_45_9 ts_uU_L2_45_9 hv_L1_32 0 0 NMIR W=48.0u L=1u
Mo1_uU_L2_45_9 da_uU_L2_45_9 d1bar_L2 ts_uU_L2_45_9 0 NMIR W=20u L=1u
Mo2_uU_L2_45_9 gp_2_45_9 dpre_L2_45 ts_uU_L2_45_9 0 NMIR W=20u L=1u
Mo3_uU_L2_45_9 da_uU_L2_45_9 da_uU_L2_45_9 vdd vdd PMIR W=60u L=1u
Mo4_uU_L2_45_9 gp_2_45_9 da_uU_L2_45_9 vdd vdd PMIR W=60u L=1u
Mt_uU_L2_45_10 ts_uU_L2_45_10 hv_L1_33 0 0 NMIR W=48.0u L=1u
Mo1_uU_L2_45_10 da_uU_L2_45_10 d1bar_L2 ts_uU_L2_45_10 0 NMIR W=20u L=1u
Mo2_uU_L2_45_10 gp_2_45_10 dpre_L2_45 ts_uU_L2_45_10 0 NMIR W=20u L=1u
Mo3_uU_L2_45_10 da_uU_L2_45_10 da_uU_L2_45_10 vdd vdd PMIR W=60u L=1u
Mo4_uU_L2_45_10 gp_2_45_10 da_uU_L2_45_10 vdd vdd PMIR W=60u L=1u
Mt_uU_L2_45_11 ts_uU_L2_45_11 hv_L1_34 0 0 NMIR W=48.0u L=1u
Mo1_uU_L2_45_11 da_uU_L2_45_11 d1bar_L2 ts_uU_L2_45_11 0 NMIR W=20u L=1u
Mo2_uU_L2_45_11 gp_2_45_11 dpre_L2_45 ts_uU_L2_45_11 0 NMIR W=20u L=1u
Mo3_uU_L2_45_11 da_uU_L2_45_11 da_uU_L2_45_11 vdd vdd PMIR W=60u L=1u
Mo4_uU_L2_45_11 gp_2_45_11 da_uU_L2_45_11 vdd vdd PMIR W=60u L=1u
Mt_uU_L2_45_12 ts_uU_L2_45_12 hv_L1_37 0 0 NMIR W=48.0u L=1u
Mo1_uU_L2_45_12 da_uU_L2_45_12 d1bar_L2 ts_uU_L2_45_12 0 NMIR W=20u L=1u
Mo2_uU_L2_45_12 gp_2_45_12 dpre_L2_45 ts_uU_L2_45_12 0 NMIR W=20u L=1u
Mo3_uU_L2_45_12 da_uU_L2_45_12 da_uU_L2_45_12 vdd vdd PMIR W=60u L=1u
Mo4_uU_L2_45_12 gp_2_45_12 da_uU_L2_45_12 vdd vdd PMIR W=60u L=1u
Mt_uU_L2_45_13 ts_uU_L2_45_13 hv_L1_40 0 0 NMIR W=48.0u L=1u
Mo1_uU_L2_45_13 da_uU_L2_45_13 d1bar_L2 ts_uU_L2_45_13 0 NMIR W=20u L=1u
Mo2_uU_L2_45_13 gp_2_45_13 dpre_L2_45 ts_uU_L2_45_13 0 NMIR W=20u L=1u
Mo3_uU_L2_45_13 da_uU_L2_45_13 da_uU_L2_45_13 vdd vdd PMIR W=60u L=1u
Mo4_uU_L2_45_13 gp_2_45_13 da_uU_L2_45_13 vdd vdd PMIR W=60u L=1u
Mt_uU_L2_45_14 ts_uU_L2_45_14 hv_L1_41 0 0 NMIR W=48.0u L=1u
Mo1_uU_L2_45_14 da_uU_L2_45_14 d1bar_L2 ts_uU_L2_45_14 0 NMIR W=20u L=1u
Mo2_uU_L2_45_14 gp_2_45_14 dpre_L2_45 ts_uU_L2_45_14 0 NMIR W=20u L=1u
Mo3_uU_L2_45_14 da_uU_L2_45_14 da_uU_L2_45_14 vdd vdd PMIR W=60u L=1u
Mo4_uU_L2_45_14 gp_2_45_14 da_uU_L2_45_14 vdd vdd PMIR W=60u L=1u
Mt_uU_L2_45_15 ts_uU_L2_45_15 hv_L1_47 0 0 NMIR W=48.0u L=1u
Mo1_uU_L2_45_15 da_uU_L2_45_15 d1bar_L2 ts_uU_L2_45_15 0 NMIR W=20u L=1u
Mo2_uU_L2_45_15 gp_2_45_15 dpre_L2_45 ts_uU_L2_45_15 0 NMIR W=20u L=1u
Mo3_uU_L2_45_15 da_uU_L2_45_15 da_uU_L2_45_15 vdd vdd PMIR W=60u L=1u
Mo4_uU_L2_45_15 gp_2_45_15 da_uU_L2_45_15 vdd vdd PMIR W=60u L=1u
Mt_uU_L2_46_0 ts_uU_L2_46_0 hv_L1_0 0 0 NMIR W=48.0u L=1u
Mo1_uU_L2_46_0 da_uU_L2_46_0 d1bar_L2 ts_uU_L2_46_0 0 NMIR W=20u L=1u
Mo2_uU_L2_46_0 gp_2_46_0 dpre_L2_46 ts_uU_L2_46_0 0 NMIR W=20u L=1u
Mo3_uU_L2_46_0 da_uU_L2_46_0 da_uU_L2_46_0 vdd vdd PMIR W=60u L=1u
Mo4_uU_L2_46_0 gp_2_46_0 da_uU_L2_46_0 vdd vdd PMIR W=60u L=1u
Mt_uU_L2_46_1 ts_uU_L2_46_1 hv_L1_2 0 0 NMIR W=48.0u L=1u
Mo1_uU_L2_46_1 da_uU_L2_46_1 d1bar_L2 ts_uU_L2_46_1 0 NMIR W=20u L=1u
Mo2_uU_L2_46_1 gp_2_46_1 dpre_L2_46 ts_uU_L2_46_1 0 NMIR W=20u L=1u
Mo3_uU_L2_46_1 da_uU_L2_46_1 da_uU_L2_46_1 vdd vdd PMIR W=60u L=1u
Mo4_uU_L2_46_1 gp_2_46_1 da_uU_L2_46_1 vdd vdd PMIR W=60u L=1u
Mt_uU_L2_46_2 ts_uU_L2_46_2 hv_L1_3 0 0 NMIR W=48.0u L=1u
Mo1_uU_L2_46_2 da_uU_L2_46_2 d1bar_L2 ts_uU_L2_46_2 0 NMIR W=20u L=1u
Mo2_uU_L2_46_2 gp_2_46_2 dpre_L2_46 ts_uU_L2_46_2 0 NMIR W=20u L=1u
Mo3_uU_L2_46_2 da_uU_L2_46_2 da_uU_L2_46_2 vdd vdd PMIR W=60u L=1u
Mo4_uU_L2_46_2 gp_2_46_2 da_uU_L2_46_2 vdd vdd PMIR W=60u L=1u
Mt_uU_L2_46_3 ts_uU_L2_46_3 hv_L1_6 0 0 NMIR W=48.0u L=1u
Mo1_uU_L2_46_3 da_uU_L2_46_3 d1bar_L2 ts_uU_L2_46_3 0 NMIR W=20u L=1u
Mo2_uU_L2_46_3 gp_2_46_3 dpre_L2_46 ts_uU_L2_46_3 0 NMIR W=20u L=1u
Mo3_uU_L2_46_3 da_uU_L2_46_3 da_uU_L2_46_3 vdd vdd PMIR W=60u L=1u
Mo4_uU_L2_46_3 gp_2_46_3 da_uU_L2_46_3 vdd vdd PMIR W=60u L=1u
Mt_uU_L2_46_4 ts_uU_L2_46_4 hv_L1_7 0 0 NMIR W=48.0u L=1u
Mo1_uU_L2_46_4 da_uU_L2_46_4 d1bar_L2 ts_uU_L2_46_4 0 NMIR W=20u L=1u
Mo2_uU_L2_46_4 gp_2_46_4 dpre_L2_46 ts_uU_L2_46_4 0 NMIR W=20u L=1u
Mo3_uU_L2_46_4 da_uU_L2_46_4 da_uU_L2_46_4 vdd vdd PMIR W=60u L=1u
Mo4_uU_L2_46_4 gp_2_46_4 da_uU_L2_46_4 vdd vdd PMIR W=60u L=1u
Mt_uU_L2_46_5 ts_uU_L2_46_5 hv_L1_17 0 0 NMIR W=48.0u L=1u
Mo1_uU_L2_46_5 da_uU_L2_46_5 d1bar_L2 ts_uU_L2_46_5 0 NMIR W=20u L=1u
Mo2_uU_L2_46_5 gp_2_46_5 dpre_L2_46 ts_uU_L2_46_5 0 NMIR W=20u L=1u
Mo3_uU_L2_46_5 da_uU_L2_46_5 da_uU_L2_46_5 vdd vdd PMIR W=60u L=1u
Mo4_uU_L2_46_5 gp_2_46_5 da_uU_L2_46_5 vdd vdd PMIR W=60u L=1u
Mt_uU_L2_46_6 ts_uU_L2_46_6 hv_L1_21 0 0 NMIR W=48.0u L=1u
Mo1_uU_L2_46_6 da_uU_L2_46_6 d1bar_L2 ts_uU_L2_46_6 0 NMIR W=20u L=1u
Mo2_uU_L2_46_6 gp_2_46_6 dpre_L2_46 ts_uU_L2_46_6 0 NMIR W=20u L=1u
Mo3_uU_L2_46_6 da_uU_L2_46_6 da_uU_L2_46_6 vdd vdd PMIR W=60u L=1u
Mo4_uU_L2_46_6 gp_2_46_6 da_uU_L2_46_6 vdd vdd PMIR W=60u L=1u
Mt_uU_L2_46_7 ts_uU_L2_46_7 hv_L1_22 0 0 NMIR W=48.0u L=1u
Mo1_uU_L2_46_7 da_uU_L2_46_7 d1bar_L2 ts_uU_L2_46_7 0 NMIR W=20u L=1u
Mo2_uU_L2_46_7 gp_2_46_7 dpre_L2_46 ts_uU_L2_46_7 0 NMIR W=20u L=1u
Mo3_uU_L2_46_7 da_uU_L2_46_7 da_uU_L2_46_7 vdd vdd PMIR W=60u L=1u
Mo4_uU_L2_46_7 gp_2_46_7 da_uU_L2_46_7 vdd vdd PMIR W=60u L=1u
Mt_uU_L2_46_8 ts_uU_L2_46_8 hv_L1_23 0 0 NMIR W=48.0u L=1u
Mo1_uU_L2_46_8 da_uU_L2_46_8 d1bar_L2 ts_uU_L2_46_8 0 NMIR W=20u L=1u
Mo2_uU_L2_46_8 gp_2_46_8 dpre_L2_46 ts_uU_L2_46_8 0 NMIR W=20u L=1u
Mo3_uU_L2_46_8 da_uU_L2_46_8 da_uU_L2_46_8 vdd vdd PMIR W=60u L=1u
Mo4_uU_L2_46_8 gp_2_46_8 da_uU_L2_46_8 vdd vdd PMIR W=60u L=1u
Mt_uU_L2_46_9 ts_uU_L2_46_9 hv_L1_26 0 0 NMIR W=48.0u L=1u
Mo1_uU_L2_46_9 da_uU_L2_46_9 d1bar_L2 ts_uU_L2_46_9 0 NMIR W=20u L=1u
Mo2_uU_L2_46_9 gp_2_46_9 dpre_L2_46 ts_uU_L2_46_9 0 NMIR W=20u L=1u
Mo3_uU_L2_46_9 da_uU_L2_46_9 da_uU_L2_46_9 vdd vdd PMIR W=60u L=1u
Mo4_uU_L2_46_9 gp_2_46_9 da_uU_L2_46_9 vdd vdd PMIR W=60u L=1u
Mt_uU_L2_46_10 ts_uU_L2_46_10 hv_L1_31 0 0 NMIR W=48.0u L=1u
Mo1_uU_L2_46_10 da_uU_L2_46_10 d1bar_L2 ts_uU_L2_46_10 0 NMIR W=20u L=1u
Mo2_uU_L2_46_10 gp_2_46_10 dpre_L2_46 ts_uU_L2_46_10 0 NMIR W=20u L=1u
Mo3_uU_L2_46_10 da_uU_L2_46_10 da_uU_L2_46_10 vdd vdd PMIR W=60u L=1u
Mo4_uU_L2_46_10 gp_2_46_10 da_uU_L2_46_10 vdd vdd PMIR W=60u L=1u
Mt_uU_L2_46_11 ts_uU_L2_46_11 hv_L1_33 0 0 NMIR W=48.0u L=1u
Mo1_uU_L2_46_11 da_uU_L2_46_11 d1bar_L2 ts_uU_L2_46_11 0 NMIR W=20u L=1u
Mo2_uU_L2_46_11 gp_2_46_11 dpre_L2_46 ts_uU_L2_46_11 0 NMIR W=20u L=1u
Mo3_uU_L2_46_11 da_uU_L2_46_11 da_uU_L2_46_11 vdd vdd PMIR W=60u L=1u
Mo4_uU_L2_46_11 gp_2_46_11 da_uU_L2_46_11 vdd vdd PMIR W=60u L=1u
Mt_uU_L2_46_12 ts_uU_L2_46_12 hv_L1_36 0 0 NMIR W=48.0u L=1u
Mo1_uU_L2_46_12 da_uU_L2_46_12 d1bar_L2 ts_uU_L2_46_12 0 NMIR W=20u L=1u
Mo2_uU_L2_46_12 gp_2_46_12 dpre_L2_46 ts_uU_L2_46_12 0 NMIR W=20u L=1u
Mo3_uU_L2_46_12 da_uU_L2_46_12 da_uU_L2_46_12 vdd vdd PMIR W=60u L=1u
Mo4_uU_L2_46_12 gp_2_46_12 da_uU_L2_46_12 vdd vdd PMIR W=60u L=1u
Mt_uU_L2_46_13 ts_uU_L2_46_13 hv_L1_37 0 0 NMIR W=48.0u L=1u
Mo1_uU_L2_46_13 da_uU_L2_46_13 d1bar_L2 ts_uU_L2_46_13 0 NMIR W=20u L=1u
Mo2_uU_L2_46_13 gp_2_46_13 dpre_L2_46 ts_uU_L2_46_13 0 NMIR W=20u L=1u
Mo3_uU_L2_46_13 da_uU_L2_46_13 da_uU_L2_46_13 vdd vdd PMIR W=60u L=1u
Mo4_uU_L2_46_13 gp_2_46_13 da_uU_L2_46_13 vdd vdd PMIR W=60u L=1u
Mt_uU_L2_46_14 ts_uU_L2_46_14 hv_L1_41 0 0 NMIR W=48.0u L=1u
Mo1_uU_L2_46_14 da_uU_L2_46_14 d1bar_L2 ts_uU_L2_46_14 0 NMIR W=20u L=1u
Mo2_uU_L2_46_14 gp_2_46_14 dpre_L2_46 ts_uU_L2_46_14 0 NMIR W=20u L=1u
Mo3_uU_L2_46_14 da_uU_L2_46_14 da_uU_L2_46_14 vdd vdd PMIR W=60u L=1u
Mo4_uU_L2_46_14 gp_2_46_14 da_uU_L2_46_14 vdd vdd PMIR W=60u L=1u
Mt_uU_L2_46_15 ts_uU_L2_46_15 hv_L1_44 0 0 NMIR W=48.0u L=1u
Mo1_uU_L2_46_15 da_uU_L2_46_15 d1bar_L2 ts_uU_L2_46_15 0 NMIR W=20u L=1u
Mo2_uU_L2_46_15 gp_2_46_15 dpre_L2_46 ts_uU_L2_46_15 0 NMIR W=20u L=1u
Mo3_uU_L2_46_15 da_uU_L2_46_15 da_uU_L2_46_15 vdd vdd PMIR W=60u L=1u
Mo4_uU_L2_46_15 gp_2_46_15 da_uU_L2_46_15 vdd vdd PMIR W=60u L=1u
Mt_uU_L2_47_0 ts_uU_L2_47_0 hv_L1_0 0 0 NMIR W=48.0u L=1u
Mo1_uU_L2_47_0 da_uU_L2_47_0 d1bar_L2 ts_uU_L2_47_0 0 NMIR W=20u L=1u
Mo2_uU_L2_47_0 gp_2_47_0 dpre_L2_47 ts_uU_L2_47_0 0 NMIR W=20u L=1u
Mo3_uU_L2_47_0 da_uU_L2_47_0 da_uU_L2_47_0 vdd vdd PMIR W=60u L=1u
Mo4_uU_L2_47_0 gp_2_47_0 da_uU_L2_47_0 vdd vdd PMIR W=60u L=1u
Mt_uU_L2_47_1 ts_uU_L2_47_1 hv_L1_2 0 0 NMIR W=48.0u L=1u
Mo1_uU_L2_47_1 da_uU_L2_47_1 d1bar_L2 ts_uU_L2_47_1 0 NMIR W=20u L=1u
Mo2_uU_L2_47_1 gp_2_47_1 dpre_L2_47 ts_uU_L2_47_1 0 NMIR W=20u L=1u
Mo3_uU_L2_47_1 da_uU_L2_47_1 da_uU_L2_47_1 vdd vdd PMIR W=60u L=1u
Mo4_uU_L2_47_1 gp_2_47_1 da_uU_L2_47_1 vdd vdd PMIR W=60u L=1u
Mt_uU_L2_47_2 ts_uU_L2_47_2 hv_L1_5 0 0 NMIR W=48.0u L=1u
Mo1_uU_L2_47_2 da_uU_L2_47_2 d1bar_L2 ts_uU_L2_47_2 0 NMIR W=20u L=1u
Mo2_uU_L2_47_2 gp_2_47_2 dpre_L2_47 ts_uU_L2_47_2 0 NMIR W=20u L=1u
Mo3_uU_L2_47_2 da_uU_L2_47_2 da_uU_L2_47_2 vdd vdd PMIR W=60u L=1u
Mo4_uU_L2_47_2 gp_2_47_2 da_uU_L2_47_2 vdd vdd PMIR W=60u L=1u
Mt_uU_L2_47_3 ts_uU_L2_47_3 hv_L1_6 0 0 NMIR W=48.0u L=1u
Mo1_uU_L2_47_3 da_uU_L2_47_3 d1bar_L2 ts_uU_L2_47_3 0 NMIR W=20u L=1u
Mo2_uU_L2_47_3 gp_2_47_3 dpre_L2_47 ts_uU_L2_47_3 0 NMIR W=20u L=1u
Mo3_uU_L2_47_3 da_uU_L2_47_3 da_uU_L2_47_3 vdd vdd PMIR W=60u L=1u
Mo4_uU_L2_47_3 gp_2_47_3 da_uU_L2_47_3 vdd vdd PMIR W=60u L=1u
Mt_uU_L2_47_4 ts_uU_L2_47_4 hv_L1_9 0 0 NMIR W=48.0u L=1u
Mo1_uU_L2_47_4 da_uU_L2_47_4 d1bar_L2 ts_uU_L2_47_4 0 NMIR W=20u L=1u
Mo2_uU_L2_47_4 gp_2_47_4 dpre_L2_47 ts_uU_L2_47_4 0 NMIR W=20u L=1u
Mo3_uU_L2_47_4 da_uU_L2_47_4 da_uU_L2_47_4 vdd vdd PMIR W=60u L=1u
Mo4_uU_L2_47_4 gp_2_47_4 da_uU_L2_47_4 vdd vdd PMIR W=60u L=1u
Mt_uU_L2_47_5 ts_uU_L2_47_5 hv_L1_16 0 0 NMIR W=48.0u L=1u
Mo1_uU_L2_47_5 da_uU_L2_47_5 d1bar_L2 ts_uU_L2_47_5 0 NMIR W=20u L=1u
Mo2_uU_L2_47_5 gp_2_47_5 dpre_L2_47 ts_uU_L2_47_5 0 NMIR W=20u L=1u
Mo3_uU_L2_47_5 da_uU_L2_47_5 da_uU_L2_47_5 vdd vdd PMIR W=60u L=1u
Mo4_uU_L2_47_5 gp_2_47_5 da_uU_L2_47_5 vdd vdd PMIR W=60u L=1u
Mt_uU_L2_47_6 ts_uU_L2_47_6 hv_L1_17 0 0 NMIR W=48.0u L=1u
Mo1_uU_L2_47_6 da_uU_L2_47_6 d1bar_L2 ts_uU_L2_47_6 0 NMIR W=20u L=1u
Mo2_uU_L2_47_6 gp_2_47_6 dpre_L2_47 ts_uU_L2_47_6 0 NMIR W=20u L=1u
Mo3_uU_L2_47_6 da_uU_L2_47_6 da_uU_L2_47_6 vdd vdd PMIR W=60u L=1u
Mo4_uU_L2_47_6 gp_2_47_6 da_uU_L2_47_6 vdd vdd PMIR W=60u L=1u
Mt_uU_L2_47_7 ts_uU_L2_47_7 hv_L1_18 0 0 NMIR W=48.0u L=1u
Mo1_uU_L2_47_7 da_uU_L2_47_7 d1bar_L2 ts_uU_L2_47_7 0 NMIR W=20u L=1u
Mo2_uU_L2_47_7 gp_2_47_7 dpre_L2_47 ts_uU_L2_47_7 0 NMIR W=20u L=1u
Mo3_uU_L2_47_7 da_uU_L2_47_7 da_uU_L2_47_7 vdd vdd PMIR W=60u L=1u
Mo4_uU_L2_47_7 gp_2_47_7 da_uU_L2_47_7 vdd vdd PMIR W=60u L=1u
Mt_uU_L2_47_8 ts_uU_L2_47_8 hv_L1_20 0 0 NMIR W=48.0u L=1u
Mo1_uU_L2_47_8 da_uU_L2_47_8 d1bar_L2 ts_uU_L2_47_8 0 NMIR W=20u L=1u
Mo2_uU_L2_47_8 gp_2_47_8 dpre_L2_47 ts_uU_L2_47_8 0 NMIR W=20u L=1u
Mo3_uU_L2_47_8 da_uU_L2_47_8 da_uU_L2_47_8 vdd vdd PMIR W=60u L=1u
Mo4_uU_L2_47_8 gp_2_47_8 da_uU_L2_47_8 vdd vdd PMIR W=60u L=1u
Mt_uU_L2_47_9 ts_uU_L2_47_9 hv_L1_25 0 0 NMIR W=48.0u L=1u
Mo1_uU_L2_47_9 da_uU_L2_47_9 d1bar_L2 ts_uU_L2_47_9 0 NMIR W=20u L=1u
Mo2_uU_L2_47_9 gp_2_47_9 dpre_L2_47 ts_uU_L2_47_9 0 NMIR W=20u L=1u
Mo3_uU_L2_47_9 da_uU_L2_47_9 da_uU_L2_47_9 vdd vdd PMIR W=60u L=1u
Mo4_uU_L2_47_9 gp_2_47_9 da_uU_L2_47_9 vdd vdd PMIR W=60u L=1u
Mt_uU_L2_47_10 ts_uU_L2_47_10 hv_L1_29 0 0 NMIR W=48.0u L=1u
Mo1_uU_L2_47_10 da_uU_L2_47_10 d1bar_L2 ts_uU_L2_47_10 0 NMIR W=20u L=1u
Mo2_uU_L2_47_10 gp_2_47_10 dpre_L2_47 ts_uU_L2_47_10 0 NMIR W=20u L=1u
Mo3_uU_L2_47_10 da_uU_L2_47_10 da_uU_L2_47_10 vdd vdd PMIR W=60u L=1u
Mo4_uU_L2_47_10 gp_2_47_10 da_uU_L2_47_10 vdd vdd PMIR W=60u L=1u
Mt_uU_L2_47_11 ts_uU_L2_47_11 hv_L1_32 0 0 NMIR W=48.0u L=1u
Mo1_uU_L2_47_11 da_uU_L2_47_11 d1bar_L2 ts_uU_L2_47_11 0 NMIR W=20u L=1u
Mo2_uU_L2_47_11 gp_2_47_11 dpre_L2_47 ts_uU_L2_47_11 0 NMIR W=20u L=1u
Mo3_uU_L2_47_11 da_uU_L2_47_11 da_uU_L2_47_11 vdd vdd PMIR W=60u L=1u
Mo4_uU_L2_47_11 gp_2_47_11 da_uU_L2_47_11 vdd vdd PMIR W=60u L=1u
Mt_uU_L2_47_12 ts_uU_L2_47_12 hv_L1_33 0 0 NMIR W=48.0u L=1u
Mo1_uU_L2_47_12 da_uU_L2_47_12 d1bar_L2 ts_uU_L2_47_12 0 NMIR W=20u L=1u
Mo2_uU_L2_47_12 gp_2_47_12 dpre_L2_47 ts_uU_L2_47_12 0 NMIR W=20u L=1u
Mo3_uU_L2_47_12 da_uU_L2_47_12 da_uU_L2_47_12 vdd vdd PMIR W=60u L=1u
Mo4_uU_L2_47_12 gp_2_47_12 da_uU_L2_47_12 vdd vdd PMIR W=60u L=1u
Mt_uU_L2_47_13 ts_uU_L2_47_13 hv_L1_36 0 0 NMIR W=48.0u L=1u
Mo1_uU_L2_47_13 da_uU_L2_47_13 d1bar_L2 ts_uU_L2_47_13 0 NMIR W=20u L=1u
Mo2_uU_L2_47_13 gp_2_47_13 dpre_L2_47 ts_uU_L2_47_13 0 NMIR W=20u L=1u
Mo3_uU_L2_47_13 da_uU_L2_47_13 da_uU_L2_47_13 vdd vdd PMIR W=60u L=1u
Mo4_uU_L2_47_13 gp_2_47_13 da_uU_L2_47_13 vdd vdd PMIR W=60u L=1u
Mt_uU_L2_47_14 ts_uU_L2_47_14 hv_L1_43 0 0 NMIR W=48.0u L=1u
Mo1_uU_L2_47_14 da_uU_L2_47_14 d1bar_L2 ts_uU_L2_47_14 0 NMIR W=20u L=1u
Mo2_uU_L2_47_14 gp_2_47_14 dpre_L2_47 ts_uU_L2_47_14 0 NMIR W=20u L=1u
Mo3_uU_L2_47_14 da_uU_L2_47_14 da_uU_L2_47_14 vdd vdd PMIR W=60u L=1u
Mo4_uU_L2_47_14 gp_2_47_14 da_uU_L2_47_14 vdd vdd PMIR W=60u L=1u
Mt_uU_L2_47_15 ts_uU_L2_47_15 hv_L1_46 0 0 NMIR W=48.0u L=1u
Mo1_uU_L2_47_15 da_uU_L2_47_15 d1bar_L2 ts_uU_L2_47_15 0 NMIR W=20u L=1u
Mo2_uU_L2_47_15 gp_2_47_15 dpre_L2_47 ts_uU_L2_47_15 0 NMIR W=20u L=1u
Mo3_uU_L2_47_15 da_uU_L2_47_15 da_uU_L2_47_15 vdd vdd PMIR W=60u L=1u
Mo4_uU_L2_47_15 gp_2_47_15 da_uU_L2_47_15 vdd vdd PMIR W=60u L=1u
MpTa_L1_0_0 dpre_L2_3 gp_2_3_0 ctp_L1_0 0 NSYN W=10u L=1u
MnTb_L1_0_0 d1bar_L2 vcn ctp_L1_0 0 NSYN W=10u L=1u
MnTa_L1_0_0 dpre_L2_3 vcn ctn_L1_0 0 NSYN W=10u L=1u
MpTb_L1_0_0 d1bar_L2 gp_2_3_0 ctn_L1_0 0 NSYN W=10u L=1u
MpTa_L1_0_1 dpre_L2_13 gp_2_13_0 ctp_L1_0 0 NSYN W=10u L=1u
MnTb_L1_0_1 d1bar_L2 vcn ctp_L1_0 0 NSYN W=10u L=1u
MnTa_L1_0_1 dpre_L2_13 vcn ctn_L1_0 0 NSYN W=10u L=1u
MpTb_L1_0_1 d1bar_L2 gp_2_13_0 ctn_L1_0 0 NSYN W=10u L=1u
MpTa_L1_0_2 dpre_L2_17 gp_2_17_0 ctp_L1_0 0 NSYN W=10u L=1u
MnTb_L1_0_2 d1bar_L2 vcn ctp_L1_0 0 NSYN W=10u L=1u
MnTa_L1_0_2 dpre_L2_17 vcn ctn_L1_0 0 NSYN W=10u L=1u
MpTb_L1_0_2 d1bar_L2 gp_2_17_0 ctn_L1_0 0 NSYN W=10u L=1u
MpTa_L1_0_3 dpre_L2_19 gp_2_19_0 ctp_L1_0 0 NSYN W=10u L=1u
MnTb_L1_0_3 d1bar_L2 vcn ctp_L1_0 0 NSYN W=10u L=1u
MnTa_L1_0_3 dpre_L2_19 vcn ctn_L1_0 0 NSYN W=10u L=1u
MpTb_L1_0_3 d1bar_L2 gp_2_19_0 ctn_L1_0 0 NSYN W=10u L=1u
MpTa_L1_0_4 dpre_L2_20 gp_2_20_0 ctp_L1_0 0 NSYN W=10u L=1u
MnTb_L1_0_4 d1bar_L2 vcn ctp_L1_0 0 NSYN W=10u L=1u
MnTa_L1_0_4 dpre_L2_20 vcn ctn_L1_0 0 NSYN W=10u L=1u
MpTb_L1_0_4 d1bar_L2 gp_2_20_0 ctn_L1_0 0 NSYN W=10u L=1u
MpTa_L1_0_5 dpre_L2_21 gp_2_21_0 ctp_L1_0 0 NSYN W=10u L=1u
MnTb_L1_0_5 d1bar_L2 vcn ctp_L1_0 0 NSYN W=10u L=1u
MnTa_L1_0_5 dpre_L2_21 vcn ctn_L1_0 0 NSYN W=10u L=1u
MpTb_L1_0_5 d1bar_L2 gp_2_21_0 ctn_L1_0 0 NSYN W=10u L=1u
MpTa_L1_0_6 dpre_L2_23 gp_2_23_0 ctp_L1_0 0 NSYN W=10u L=1u
MnTb_L1_0_6 d1bar_L2 vcn ctp_L1_0 0 NSYN W=10u L=1u
MnTa_L1_0_6 dpre_L2_23 vcn ctn_L1_0 0 NSYN W=10u L=1u
MpTb_L1_0_6 d1bar_L2 gp_2_23_0 ctn_L1_0 0 NSYN W=10u L=1u
MpTa_L1_0_7 dpre_L2_24 gp_2_24_0 ctp_L1_0 0 NSYN W=10u L=1u
MnTb_L1_0_7 d1bar_L2 vcn ctp_L1_0 0 NSYN W=10u L=1u
MnTa_L1_0_7 dpre_L2_24 vcn ctn_L1_0 0 NSYN W=10u L=1u
MpTb_L1_0_7 d1bar_L2 gp_2_24_0 ctn_L1_0 0 NSYN W=10u L=1u
MpTa_L1_0_8 dpre_L2_25 gp_2_25_0 ctp_L1_0 0 NSYN W=10u L=1u
MnTb_L1_0_8 d1bar_L2 vcn ctp_L1_0 0 NSYN W=10u L=1u
MnTa_L1_0_8 dpre_L2_25 vcn ctn_L1_0 0 NSYN W=10u L=1u
MpTb_L1_0_8 d1bar_L2 gp_2_25_0 ctn_L1_0 0 NSYN W=10u L=1u
MpTa_L1_0_9 dpre_L2_26 gp_2_26_0 ctp_L1_0 0 NSYN W=10u L=1u
MnTb_L1_0_9 d1bar_L2 vcn ctp_L1_0 0 NSYN W=10u L=1u
MnTa_L1_0_9 dpre_L2_26 vcn ctn_L1_0 0 NSYN W=10u L=1u
MpTb_L1_0_9 d1bar_L2 gp_2_26_0 ctn_L1_0 0 NSYN W=10u L=1u
MpTa_L1_0_10 dpre_L2_27 gp_2_27_0 ctp_L1_0 0 NSYN W=10u L=1u
MnTb_L1_0_10 d1bar_L2 vcn ctp_L1_0 0 NSYN W=10u L=1u
MnTa_L1_0_10 dpre_L2_27 vcn ctn_L1_0 0 NSYN W=10u L=1u
MpTb_L1_0_10 d1bar_L2 gp_2_27_0 ctn_L1_0 0 NSYN W=10u L=1u
MpTa_L1_0_11 dpre_L2_36 gp_2_36_0 ctp_L1_0 0 NSYN W=10u L=1u
MnTb_L1_0_11 d1bar_L2 vcn ctp_L1_0 0 NSYN W=10u L=1u
MnTa_L1_0_11 dpre_L2_36 vcn ctn_L1_0 0 NSYN W=10u L=1u
MpTb_L1_0_11 d1bar_L2 gp_2_36_0 ctn_L1_0 0 NSYN W=10u L=1u
MpTa_L1_0_12 dpre_L2_40 gp_2_40_0 ctp_L1_0 0 NSYN W=10u L=1u
MnTb_L1_0_12 d1bar_L2 vcn ctp_L1_0 0 NSYN W=10u L=1u
MnTa_L1_0_12 dpre_L2_40 vcn ctn_L1_0 0 NSYN W=10u L=1u
MpTb_L1_0_12 d1bar_L2 gp_2_40_0 ctn_L1_0 0 NSYN W=10u L=1u
MpTa_L1_0_13 dpre_L2_41 gp_2_41_0 ctp_L1_0 0 NSYN W=10u L=1u
MnTb_L1_0_13 d1bar_L2 vcn ctp_L1_0 0 NSYN W=10u L=1u
MnTa_L1_0_13 dpre_L2_41 vcn ctn_L1_0 0 NSYN W=10u L=1u
MpTb_L1_0_13 d1bar_L2 gp_2_41_0 ctn_L1_0 0 NSYN W=10u L=1u
MpTa_L1_0_14 dpre_L2_46 gp_2_46_0 ctp_L1_0 0 NSYN W=10u L=1u
MnTb_L1_0_14 d1bar_L2 vcn ctp_L1_0 0 NSYN W=10u L=1u
MnTa_L1_0_14 dpre_L2_46 vcn ctn_L1_0 0 NSYN W=10u L=1u
MpTb_L1_0_14 d1bar_L2 gp_2_46_0 ctn_L1_0 0 NSYN W=10u L=1u
MpTa_L1_0_15 dpre_L2_47 gp_2_47_0 ctp_L1_0 0 NSYN W=10u L=1u
MnTb_L1_0_15 d1bar_L2 vcn ctp_L1_0 0 NSYN W=10u L=1u
MnTa_L1_0_15 dpre_L2_47 vcn ctn_L1_0 0 NSYN W=10u L=1u
MpTb_L1_0_15 d1bar_L2 gp_2_47_0 ctn_L1_0 0 NSYN W=10u L=1u
Msa_bk_L1_0 ctn_L1_0 ctn_L1_0 0 0 NMIR W=20u L=1u
Msb_bk_L1_0 dpre_L1_0 ctn_L1_0 0 0 NMIR W=20u L=1u
Msc_bk_L1_0 ctp_L1_0 ctp_L1_0 0 0 NMIR W=20u L=1u
Msd_bk_L1_0 dpf_bk_L1_0 ctp_L1_0 0 0 NMIR W=20u L=1u
Mse_bk_L1_0 dpf_bk_L1_0 dpf_bk_L1_0 vdd vdd PMIR W=60u L=1u
Msf_bk_L1_0 dpre_L1_0 dpf_bk_L1_0 vdd vdd PMIR W=60u L=1u
R_bk_L1_0 dpre_L1_0 vrefd 16000.0
MpTa_L1_1_0 dpre_L2_1 gp_2_1_0 ctp_L1_1 0 NSYN W=10u L=1u
MnTb_L1_1_0 d1bar_L2 vcn ctp_L1_1 0 NSYN W=10u L=1u
MnTa_L1_1_0 dpre_L2_1 vcn ctn_L1_1 0 NSYN W=10u L=1u
MpTb_L1_1_0 d1bar_L2 gp_2_1_0 ctn_L1_1 0 NSYN W=10u L=1u
MpTa_L1_1_1 dpre_L2_3 gp_2_3_1 ctp_L1_1 0 NSYN W=10u L=1u
MnTb_L1_1_1 d1bar_L2 vcn ctp_L1_1 0 NSYN W=10u L=1u
MnTa_L1_1_1 dpre_L2_3 vcn ctn_L1_1 0 NSYN W=10u L=1u
MpTb_L1_1_1 d1bar_L2 gp_2_3_1 ctn_L1_1 0 NSYN W=10u L=1u
MpTa_L1_1_2 dpre_L2_7 gp_2_7_0 ctp_L1_1 0 NSYN W=10u L=1u
MnTb_L1_1_2 d1bar_L2 vcn ctp_L1_1 0 NSYN W=10u L=1u
MnTa_L1_1_2 dpre_L2_7 vcn ctn_L1_1 0 NSYN W=10u L=1u
MpTb_L1_1_2 d1bar_L2 gp_2_7_0 ctn_L1_1 0 NSYN W=10u L=1u
MpTa_L1_1_3 dpre_L2_12 gp_2_12_0 ctp_L1_1 0 NSYN W=10u L=1u
MnTb_L1_1_3 d1bar_L2 vcn ctp_L1_1 0 NSYN W=10u L=1u
MnTa_L1_1_3 dpre_L2_12 vcn ctn_L1_1 0 NSYN W=10u L=1u
MpTb_L1_1_3 d1bar_L2 gp_2_12_0 ctn_L1_1 0 NSYN W=10u L=1u
MpTa_L1_1_4 dpre_L2_15 gp_2_15_0 ctp_L1_1 0 NSYN W=10u L=1u
MnTb_L1_1_4 d1bar_L2 vcn ctp_L1_1 0 NSYN W=10u L=1u
MnTa_L1_1_4 dpre_L2_15 vcn ctn_L1_1 0 NSYN W=10u L=1u
MpTb_L1_1_4 d1bar_L2 gp_2_15_0 ctn_L1_1 0 NSYN W=10u L=1u
MpTa_L1_1_5 dpre_L2_17 gp_2_17_1 ctp_L1_1 0 NSYN W=10u L=1u
MnTb_L1_1_5 d1bar_L2 vcn ctp_L1_1 0 NSYN W=10u L=1u
MnTa_L1_1_5 dpre_L2_17 vcn ctn_L1_1 0 NSYN W=10u L=1u
MpTb_L1_1_5 d1bar_L2 gp_2_17_1 ctn_L1_1 0 NSYN W=10u L=1u
MpTa_L1_1_6 dpre_L2_23 gp_2_23_1 ctp_L1_1 0 NSYN W=10u L=1u
MnTb_L1_1_6 d1bar_L2 vcn ctp_L1_1 0 NSYN W=10u L=1u
MnTa_L1_1_6 dpre_L2_23 vcn ctn_L1_1 0 NSYN W=10u L=1u
MpTb_L1_1_6 d1bar_L2 gp_2_23_1 ctn_L1_1 0 NSYN W=10u L=1u
MpTa_L1_1_7 dpre_L2_24 gp_2_24_1 ctp_L1_1 0 NSYN W=10u L=1u
MnTb_L1_1_7 d1bar_L2 vcn ctp_L1_1 0 NSYN W=10u L=1u
MnTa_L1_1_7 dpre_L2_24 vcn ctn_L1_1 0 NSYN W=10u L=1u
MpTb_L1_1_7 d1bar_L2 gp_2_24_1 ctn_L1_1 0 NSYN W=10u L=1u
MpTa_L1_1_8 dpre_L2_25 gp_2_25_1 ctp_L1_1 0 NSYN W=10u L=1u
MnTb_L1_1_8 d1bar_L2 vcn ctp_L1_1 0 NSYN W=10u L=1u
MnTa_L1_1_8 dpre_L2_25 vcn ctn_L1_1 0 NSYN W=10u L=1u
MpTb_L1_1_8 d1bar_L2 gp_2_25_1 ctn_L1_1 0 NSYN W=10u L=1u
MpTa_L1_1_9 dpre_L2_31 gp_2_31_0 ctp_L1_1 0 NSYN W=10u L=1u
MnTb_L1_1_9 d1bar_L2 vcn ctp_L1_1 0 NSYN W=10u L=1u
MnTa_L1_1_9 dpre_L2_31 vcn ctn_L1_1 0 NSYN W=10u L=1u
MpTb_L1_1_9 d1bar_L2 gp_2_31_0 ctn_L1_1 0 NSYN W=10u L=1u
MpTa_L1_1_10 dpre_L2_32 gp_2_32_0 ctp_L1_1 0 NSYN W=10u L=1u
MnTb_L1_1_10 d1bar_L2 vcn ctp_L1_1 0 NSYN W=10u L=1u
MnTa_L1_1_10 dpre_L2_32 vcn ctn_L1_1 0 NSYN W=10u L=1u
MpTb_L1_1_10 d1bar_L2 gp_2_32_0 ctn_L1_1 0 NSYN W=10u L=1u
MpTa_L1_1_11 dpre_L2_34 gp_2_34_0 ctp_L1_1 0 NSYN W=10u L=1u
MnTb_L1_1_11 d1bar_L2 vcn ctp_L1_1 0 NSYN W=10u L=1u
MnTa_L1_1_11 dpre_L2_34 vcn ctn_L1_1 0 NSYN W=10u L=1u
MpTb_L1_1_11 d1bar_L2 gp_2_34_0 ctn_L1_1 0 NSYN W=10u L=1u
MpTa_L1_1_12 dpre_L2_35 gp_2_35_0 ctp_L1_1 0 NSYN W=10u L=1u
MnTb_L1_1_12 d1bar_L2 vcn ctp_L1_1 0 NSYN W=10u L=1u
MnTa_L1_1_12 dpre_L2_35 vcn ctn_L1_1 0 NSYN W=10u L=1u
MpTb_L1_1_12 d1bar_L2 gp_2_35_0 ctn_L1_1 0 NSYN W=10u L=1u
MpTa_L1_1_13 dpre_L2_36 gp_2_36_1 ctp_L1_1 0 NSYN W=10u L=1u
MnTb_L1_1_13 d1bar_L2 vcn ctp_L1_1 0 NSYN W=10u L=1u
MnTa_L1_1_13 dpre_L2_36 vcn ctn_L1_1 0 NSYN W=10u L=1u
MpTb_L1_1_13 d1bar_L2 gp_2_36_1 ctn_L1_1 0 NSYN W=10u L=1u
MpTa_L1_1_14 dpre_L2_38 gp_2_38_0 ctp_L1_1 0 NSYN W=10u L=1u
MnTb_L1_1_14 d1bar_L2 vcn ctp_L1_1 0 NSYN W=10u L=1u
MnTa_L1_1_14 dpre_L2_38 vcn ctn_L1_1 0 NSYN W=10u L=1u
MpTb_L1_1_14 d1bar_L2 gp_2_38_0 ctn_L1_1 0 NSYN W=10u L=1u
MpTa_L1_1_15 dpre_L2_42 gp_2_42_0 ctp_L1_1 0 NSYN W=10u L=1u
MnTb_L1_1_15 d1bar_L2 vcn ctp_L1_1 0 NSYN W=10u L=1u
MnTa_L1_1_15 dpre_L2_42 vcn ctn_L1_1 0 NSYN W=10u L=1u
MpTb_L1_1_15 d1bar_L2 gp_2_42_0 ctn_L1_1 0 NSYN W=10u L=1u
Msa_bk_L1_1 ctn_L1_1 ctn_L1_1 0 0 NMIR W=20u L=1u
Msb_bk_L1_1 dpre_L1_1 ctn_L1_1 0 0 NMIR W=20u L=1u
Msc_bk_L1_1 ctp_L1_1 ctp_L1_1 0 0 NMIR W=20u L=1u
Msd_bk_L1_1 dpf_bk_L1_1 ctp_L1_1 0 0 NMIR W=20u L=1u
Mse_bk_L1_1 dpf_bk_L1_1 dpf_bk_L1_1 vdd vdd PMIR W=60u L=1u
Msf_bk_L1_1 dpre_L1_1 dpf_bk_L1_1 vdd vdd PMIR W=60u L=1u
R_bk_L1_1 dpre_L1_1 vrefd 16000.0
MpTa_L1_2_0 dpre_L2_1 gp_2_1_1 ctp_L1_2 0 NSYN W=10u L=1u
MnTb_L1_2_0 d1bar_L2 vcn ctp_L1_2 0 NSYN W=10u L=1u
MnTa_L1_2_0 dpre_L2_1 vcn ctn_L1_2 0 NSYN W=10u L=1u
MpTb_L1_2_0 d1bar_L2 gp_2_1_1 ctn_L1_2 0 NSYN W=10u L=1u
MpTa_L1_2_1 dpre_L2_4 gp_2_4_0 ctp_L1_2 0 NSYN W=10u L=1u
MnTb_L1_2_1 d1bar_L2 vcn ctp_L1_2 0 NSYN W=10u L=1u
MnTa_L1_2_1 dpre_L2_4 vcn ctn_L1_2 0 NSYN W=10u L=1u
MpTb_L1_2_1 d1bar_L2 gp_2_4_0 ctn_L1_2 0 NSYN W=10u L=1u
MpTa_L1_2_2 dpre_L2_7 gp_2_7_1 ctp_L1_2 0 NSYN W=10u L=1u
MnTb_L1_2_2 d1bar_L2 vcn ctp_L1_2 0 NSYN W=10u L=1u
MnTa_L1_2_2 dpre_L2_7 vcn ctn_L1_2 0 NSYN W=10u L=1u
MpTb_L1_2_2 d1bar_L2 gp_2_7_1 ctn_L1_2 0 NSYN W=10u L=1u
MpTa_L1_2_3 dpre_L2_10 gp_2_10_0 ctp_L1_2 0 NSYN W=10u L=1u
MnTb_L1_2_3 d1bar_L2 vcn ctp_L1_2 0 NSYN W=10u L=1u
MnTa_L1_2_3 dpre_L2_10 vcn ctn_L1_2 0 NSYN W=10u L=1u
MpTb_L1_2_3 d1bar_L2 gp_2_10_0 ctn_L1_2 0 NSYN W=10u L=1u
MpTa_L1_2_4 dpre_L2_11 gp_2_11_0 ctp_L1_2 0 NSYN W=10u L=1u
MnTb_L1_2_4 d1bar_L2 vcn ctp_L1_2 0 NSYN W=10u L=1u
MnTa_L1_2_4 dpre_L2_11 vcn ctn_L1_2 0 NSYN W=10u L=1u
MpTb_L1_2_4 d1bar_L2 gp_2_11_0 ctn_L1_2 0 NSYN W=10u L=1u
MpTa_L1_2_5 dpre_L2_15 gp_2_15_1 ctp_L1_2 0 NSYN W=10u L=1u
MnTb_L1_2_5 d1bar_L2 vcn ctp_L1_2 0 NSYN W=10u L=1u
MnTa_L1_2_5 dpre_L2_15 vcn ctn_L1_2 0 NSYN W=10u L=1u
MpTb_L1_2_5 d1bar_L2 gp_2_15_1 ctn_L1_2 0 NSYN W=10u L=1u
MpTa_L1_2_6 dpre_L2_16 gp_2_16_0 ctp_L1_2 0 NSYN W=10u L=1u
MnTb_L1_2_6 d1bar_L2 vcn ctp_L1_2 0 NSYN W=10u L=1u
MnTa_L1_2_6 dpre_L2_16 vcn ctn_L1_2 0 NSYN W=10u L=1u
MpTb_L1_2_6 d1bar_L2 gp_2_16_0 ctn_L1_2 0 NSYN W=10u L=1u
MpTa_L1_2_7 dpre_L2_18 gp_2_18_0 ctp_L1_2 0 NSYN W=10u L=1u
MnTb_L1_2_7 d1bar_L2 vcn ctp_L1_2 0 NSYN W=10u L=1u
MnTa_L1_2_7 dpre_L2_18 vcn ctn_L1_2 0 NSYN W=10u L=1u
MpTb_L1_2_7 d1bar_L2 gp_2_18_0 ctn_L1_2 0 NSYN W=10u L=1u
MpTa_L1_2_8 dpre_L2_21 gp_2_21_1 ctp_L1_2 0 NSYN W=10u L=1u
MnTb_L1_2_8 d1bar_L2 vcn ctp_L1_2 0 NSYN W=10u L=1u
MnTa_L1_2_8 dpre_L2_21 vcn ctn_L1_2 0 NSYN W=10u L=1u
MpTb_L1_2_8 d1bar_L2 gp_2_21_1 ctn_L1_2 0 NSYN W=10u L=1u
MpTa_L1_2_9 dpre_L2_23 gp_2_23_2 ctp_L1_2 0 NSYN W=10u L=1u
MnTb_L1_2_9 d1bar_L2 vcn ctp_L1_2 0 NSYN W=10u L=1u
MnTa_L1_2_9 dpre_L2_23 vcn ctn_L1_2 0 NSYN W=10u L=1u
MpTb_L1_2_9 d1bar_L2 gp_2_23_2 ctn_L1_2 0 NSYN W=10u L=1u
MpTa_L1_2_10 dpre_L2_24 gp_2_24_2 ctp_L1_2 0 NSYN W=10u L=1u
MnTb_L1_2_10 d1bar_L2 vcn ctp_L1_2 0 NSYN W=10u L=1u
MnTa_L1_2_10 dpre_L2_24 vcn ctn_L1_2 0 NSYN W=10u L=1u
MpTb_L1_2_10 d1bar_L2 gp_2_24_2 ctn_L1_2 0 NSYN W=10u L=1u
MpTa_L1_2_11 dpre_L2_25 gp_2_25_2 ctp_L1_2 0 NSYN W=10u L=1u
MnTb_L1_2_11 d1bar_L2 vcn ctp_L1_2 0 NSYN W=10u L=1u
MnTa_L1_2_11 dpre_L2_25 vcn ctn_L1_2 0 NSYN W=10u L=1u
MpTb_L1_2_11 d1bar_L2 gp_2_25_2 ctn_L1_2 0 NSYN W=10u L=1u
MpTa_L1_2_12 dpre_L2_28 gp_2_28_0 ctp_L1_2 0 NSYN W=10u L=1u
MnTb_L1_2_12 d1bar_L2 vcn ctp_L1_2 0 NSYN W=10u L=1u
MnTa_L1_2_12 dpre_L2_28 vcn ctn_L1_2 0 NSYN W=10u L=1u
MpTb_L1_2_12 d1bar_L2 gp_2_28_0 ctn_L1_2 0 NSYN W=10u L=1u
MpTa_L1_2_13 dpre_L2_31 gp_2_31_1 ctp_L1_2 0 NSYN W=10u L=1u
MnTb_L1_2_13 d1bar_L2 vcn ctp_L1_2 0 NSYN W=10u L=1u
MnTa_L1_2_13 dpre_L2_31 vcn ctn_L1_2 0 NSYN W=10u L=1u
MpTb_L1_2_13 d1bar_L2 gp_2_31_1 ctn_L1_2 0 NSYN W=10u L=1u
MpTa_L1_2_14 dpre_L2_32 gp_2_32_1 ctp_L1_2 0 NSYN W=10u L=1u
MnTb_L1_2_14 d1bar_L2 vcn ctp_L1_2 0 NSYN W=10u L=1u
MnTa_L1_2_14 dpre_L2_32 vcn ctn_L1_2 0 NSYN W=10u L=1u
MpTb_L1_2_14 d1bar_L2 gp_2_32_1 ctn_L1_2 0 NSYN W=10u L=1u
MpTa_L1_2_15 dpre_L2_34 gp_2_34_1 ctp_L1_2 0 NSYN W=10u L=1u
MnTb_L1_2_15 d1bar_L2 vcn ctp_L1_2 0 NSYN W=10u L=1u
MnTa_L1_2_15 dpre_L2_34 vcn ctn_L1_2 0 NSYN W=10u L=1u
MpTb_L1_2_15 d1bar_L2 gp_2_34_1 ctn_L1_2 0 NSYN W=10u L=1u
MpTa_L1_2_16 dpre_L2_41 gp_2_41_1 ctp_L1_2 0 NSYN W=10u L=1u
MnTb_L1_2_16 d1bar_L2 vcn ctp_L1_2 0 NSYN W=10u L=1u
MnTa_L1_2_16 dpre_L2_41 vcn ctn_L1_2 0 NSYN W=10u L=1u
MpTb_L1_2_16 d1bar_L2 gp_2_41_1 ctn_L1_2 0 NSYN W=10u L=1u
MpTa_L1_2_17 dpre_L2_42 gp_2_42_1 ctp_L1_2 0 NSYN W=10u L=1u
MnTb_L1_2_17 d1bar_L2 vcn ctp_L1_2 0 NSYN W=10u L=1u
MnTa_L1_2_17 dpre_L2_42 vcn ctn_L1_2 0 NSYN W=10u L=1u
MpTb_L1_2_17 d1bar_L2 gp_2_42_1 ctn_L1_2 0 NSYN W=10u L=1u
MpTa_L1_2_18 dpre_L2_43 gp_2_43_0 ctp_L1_2 0 NSYN W=10u L=1u
MnTb_L1_2_18 d1bar_L2 vcn ctp_L1_2 0 NSYN W=10u L=1u
MnTa_L1_2_18 dpre_L2_43 vcn ctn_L1_2 0 NSYN W=10u L=1u
MpTb_L1_2_18 d1bar_L2 gp_2_43_0 ctn_L1_2 0 NSYN W=10u L=1u
MpTa_L1_2_19 dpre_L2_44 gp_2_44_0 ctp_L1_2 0 NSYN W=10u L=1u
MnTb_L1_2_19 d1bar_L2 vcn ctp_L1_2 0 NSYN W=10u L=1u
MnTa_L1_2_19 dpre_L2_44 vcn ctn_L1_2 0 NSYN W=10u L=1u
MpTb_L1_2_19 d1bar_L2 gp_2_44_0 ctn_L1_2 0 NSYN W=10u L=1u
MpTa_L1_2_20 dpre_L2_45 gp_2_45_0 ctp_L1_2 0 NSYN W=10u L=1u
MnTb_L1_2_20 d1bar_L2 vcn ctp_L1_2 0 NSYN W=10u L=1u
MnTa_L1_2_20 dpre_L2_45 vcn ctn_L1_2 0 NSYN W=10u L=1u
MpTb_L1_2_20 d1bar_L2 gp_2_45_0 ctn_L1_2 0 NSYN W=10u L=1u
MpTa_L1_2_21 dpre_L2_46 gp_2_46_1 ctp_L1_2 0 NSYN W=10u L=1u
MnTb_L1_2_21 d1bar_L2 vcn ctp_L1_2 0 NSYN W=10u L=1u
MnTa_L1_2_21 dpre_L2_46 vcn ctn_L1_2 0 NSYN W=10u L=1u
MpTb_L1_2_21 d1bar_L2 gp_2_46_1 ctn_L1_2 0 NSYN W=10u L=1u
MpTa_L1_2_22 dpre_L2_47 gp_2_47_1 ctp_L1_2 0 NSYN W=10u L=1u
MnTb_L1_2_22 d1bar_L2 vcn ctp_L1_2 0 NSYN W=10u L=1u
MnTa_L1_2_22 dpre_L2_47 vcn ctn_L1_2 0 NSYN W=10u L=1u
MpTb_L1_2_22 d1bar_L2 gp_2_47_1 ctn_L1_2 0 NSYN W=10u L=1u
Msa_bk_L1_2 ctn_L1_2 ctn_L1_2 0 0 NMIR W=20u L=1u
Msb_bk_L1_2 dpre_L1_2 ctn_L1_2 0 0 NMIR W=20u L=1u
Msc_bk_L1_2 ctp_L1_2 ctp_L1_2 0 0 NMIR W=20u L=1u
Msd_bk_L1_2 dpf_bk_L1_2 ctp_L1_2 0 0 NMIR W=20u L=1u
Mse_bk_L1_2 dpf_bk_L1_2 dpf_bk_L1_2 vdd vdd PMIR W=60u L=1u
Msf_bk_L1_2 dpre_L1_2 dpf_bk_L1_2 vdd vdd PMIR W=60u L=1u
R_bk_L1_2 dpre_L1_2 vrefd 16000.0
MpTa_L1_3_0 dpre_L2_2 gp_2_2_0 ctp_L1_3 0 NSYN W=10u L=1u
MnTb_L1_3_0 d1bar_L2 vcn ctp_L1_3 0 NSYN W=10u L=1u
MnTa_L1_3_0 dpre_L2_2 vcn ctn_L1_3 0 NSYN W=10u L=1u
MpTb_L1_3_0 d1bar_L2 gp_2_2_0 ctn_L1_3 0 NSYN W=10u L=1u
MpTa_L1_3_1 dpre_L2_4 gp_2_4_1 ctp_L1_3 0 NSYN W=10u L=1u
MnTb_L1_3_1 d1bar_L2 vcn ctp_L1_3 0 NSYN W=10u L=1u
MnTa_L1_3_1 dpre_L2_4 vcn ctn_L1_3 0 NSYN W=10u L=1u
MpTb_L1_3_1 d1bar_L2 gp_2_4_1 ctn_L1_3 0 NSYN W=10u L=1u
MpTa_L1_3_2 dpre_L2_8 gp_2_8_0 ctp_L1_3 0 NSYN W=10u L=1u
MnTb_L1_3_2 d1bar_L2 vcn ctp_L1_3 0 NSYN W=10u L=1u
MnTa_L1_3_2 dpre_L2_8 vcn ctn_L1_3 0 NSYN W=10u L=1u
MpTb_L1_3_2 d1bar_L2 gp_2_8_0 ctn_L1_3 0 NSYN W=10u L=1u
MpTa_L1_3_3 dpre_L2_9 gp_2_9_0 ctp_L1_3 0 NSYN W=10u L=1u
MnTb_L1_3_3 d1bar_L2 vcn ctp_L1_3 0 NSYN W=10u L=1u
MnTa_L1_3_3 dpre_L2_9 vcn ctn_L1_3 0 NSYN W=10u L=1u
MpTb_L1_3_3 d1bar_L2 gp_2_9_0 ctn_L1_3 0 NSYN W=10u L=1u
MpTa_L1_3_4 dpre_L2_10 gp_2_10_1 ctp_L1_3 0 NSYN W=10u L=1u
MnTb_L1_3_4 d1bar_L2 vcn ctp_L1_3 0 NSYN W=10u L=1u
MnTa_L1_3_4 dpre_L2_10 vcn ctn_L1_3 0 NSYN W=10u L=1u
MpTb_L1_3_4 d1bar_L2 gp_2_10_1 ctn_L1_3 0 NSYN W=10u L=1u
MpTa_L1_3_5 dpre_L2_11 gp_2_11_1 ctp_L1_3 0 NSYN W=10u L=1u
MnTb_L1_3_5 d1bar_L2 vcn ctp_L1_3 0 NSYN W=10u L=1u
MnTa_L1_3_5 dpre_L2_11 vcn ctn_L1_3 0 NSYN W=10u L=1u
MpTb_L1_3_5 d1bar_L2 gp_2_11_1 ctn_L1_3 0 NSYN W=10u L=1u
MpTa_L1_3_6 dpre_L2_13 gp_2_13_1 ctp_L1_3 0 NSYN W=10u L=1u
MnTb_L1_3_6 d1bar_L2 vcn ctp_L1_3 0 NSYN W=10u L=1u
MnTa_L1_3_6 dpre_L2_13 vcn ctn_L1_3 0 NSYN W=10u L=1u
MpTb_L1_3_6 d1bar_L2 gp_2_13_1 ctn_L1_3 0 NSYN W=10u L=1u
MpTa_L1_3_7 dpre_L2_15 gp_2_15_2 ctp_L1_3 0 NSYN W=10u L=1u
MnTb_L1_3_7 d1bar_L2 vcn ctp_L1_3 0 NSYN W=10u L=1u
MnTa_L1_3_7 dpre_L2_15 vcn ctn_L1_3 0 NSYN W=10u L=1u
MpTb_L1_3_7 d1bar_L2 gp_2_15_2 ctn_L1_3 0 NSYN W=10u L=1u
MpTa_L1_3_8 dpre_L2_16 gp_2_16_1 ctp_L1_3 0 NSYN W=10u L=1u
MnTb_L1_3_8 d1bar_L2 vcn ctp_L1_3 0 NSYN W=10u L=1u
MnTa_L1_3_8 dpre_L2_16 vcn ctn_L1_3 0 NSYN W=10u L=1u
MpTb_L1_3_8 d1bar_L2 gp_2_16_1 ctn_L1_3 0 NSYN W=10u L=1u
MpTa_L1_3_9 dpre_L2_17 gp_2_17_2 ctp_L1_3 0 NSYN W=10u L=1u
MnTb_L1_3_9 d1bar_L2 vcn ctp_L1_3 0 NSYN W=10u L=1u
MnTa_L1_3_9 dpre_L2_17 vcn ctn_L1_3 0 NSYN W=10u L=1u
MpTb_L1_3_9 d1bar_L2 gp_2_17_2 ctn_L1_3 0 NSYN W=10u L=1u
MpTa_L1_3_10 dpre_L2_20 gp_2_20_1 ctp_L1_3 0 NSYN W=10u L=1u
MnTb_L1_3_10 d1bar_L2 vcn ctp_L1_3 0 NSYN W=10u L=1u
MnTa_L1_3_10 dpre_L2_20 vcn ctn_L1_3 0 NSYN W=10u L=1u
MpTb_L1_3_10 d1bar_L2 gp_2_20_1 ctn_L1_3 0 NSYN W=10u L=1u
MpTa_L1_3_11 dpre_L2_23 gp_2_23_3 ctp_L1_3 0 NSYN W=10u L=1u
MnTb_L1_3_11 d1bar_L2 vcn ctp_L1_3 0 NSYN W=10u L=1u
MnTa_L1_3_11 dpre_L2_23 vcn ctn_L1_3 0 NSYN W=10u L=1u
MpTb_L1_3_11 d1bar_L2 gp_2_23_3 ctn_L1_3 0 NSYN W=10u L=1u
MpTa_L1_3_12 dpre_L2_29 gp_2_29_0 ctp_L1_3 0 NSYN W=10u L=1u
MnTb_L1_3_12 d1bar_L2 vcn ctp_L1_3 0 NSYN W=10u L=1u
MnTa_L1_3_12 dpre_L2_29 vcn ctn_L1_3 0 NSYN W=10u L=1u
MpTb_L1_3_12 d1bar_L2 gp_2_29_0 ctn_L1_3 0 NSYN W=10u L=1u
MpTa_L1_3_13 dpre_L2_34 gp_2_34_2 ctp_L1_3 0 NSYN W=10u L=1u
MnTb_L1_3_13 d1bar_L2 vcn ctp_L1_3 0 NSYN W=10u L=1u
MnTa_L1_3_13 dpre_L2_34 vcn ctn_L1_3 0 NSYN W=10u L=1u
MpTb_L1_3_13 d1bar_L2 gp_2_34_2 ctn_L1_3 0 NSYN W=10u L=1u
MpTa_L1_3_14 dpre_L2_39 gp_2_39_0 ctp_L1_3 0 NSYN W=10u L=1u
MnTb_L1_3_14 d1bar_L2 vcn ctp_L1_3 0 NSYN W=10u L=1u
MnTa_L1_3_14 dpre_L2_39 vcn ctn_L1_3 0 NSYN W=10u L=1u
MpTb_L1_3_14 d1bar_L2 gp_2_39_0 ctn_L1_3 0 NSYN W=10u L=1u
MpTa_L1_3_15 dpre_L2_41 gp_2_41_2 ctp_L1_3 0 NSYN W=10u L=1u
MnTb_L1_3_15 d1bar_L2 vcn ctp_L1_3 0 NSYN W=10u L=1u
MnTa_L1_3_15 dpre_L2_41 vcn ctn_L1_3 0 NSYN W=10u L=1u
MpTb_L1_3_15 d1bar_L2 gp_2_41_2 ctn_L1_3 0 NSYN W=10u L=1u
MpTa_L1_3_16 dpre_L2_44 gp_2_44_1 ctp_L1_3 0 NSYN W=10u L=1u
MnTb_L1_3_16 d1bar_L2 vcn ctp_L1_3 0 NSYN W=10u L=1u
MnTa_L1_3_16 dpre_L2_44 vcn ctn_L1_3 0 NSYN W=10u L=1u
MpTb_L1_3_16 d1bar_L2 gp_2_44_1 ctn_L1_3 0 NSYN W=10u L=1u
MpTa_L1_3_17 dpre_L2_46 gp_2_46_2 ctp_L1_3 0 NSYN W=10u L=1u
MnTb_L1_3_17 d1bar_L2 vcn ctp_L1_3 0 NSYN W=10u L=1u
MnTa_L1_3_17 dpre_L2_46 vcn ctn_L1_3 0 NSYN W=10u L=1u
MpTb_L1_3_17 d1bar_L2 gp_2_46_2 ctn_L1_3 0 NSYN W=10u L=1u
Msa_bk_L1_3 ctn_L1_3 ctn_L1_3 0 0 NMIR W=20u L=1u
Msb_bk_L1_3 dpre_L1_3 ctn_L1_3 0 0 NMIR W=20u L=1u
Msc_bk_L1_3 ctp_L1_3 ctp_L1_3 0 0 NMIR W=20u L=1u
Msd_bk_L1_3 dpf_bk_L1_3 ctp_L1_3 0 0 NMIR W=20u L=1u
Mse_bk_L1_3 dpf_bk_L1_3 dpf_bk_L1_3 vdd vdd PMIR W=60u L=1u
Msf_bk_L1_3 dpre_L1_3 dpf_bk_L1_3 vdd vdd PMIR W=60u L=1u
R_bk_L1_3 dpre_L1_3 vrefd 16000.0
MpTa_L1_4_0 dpre_L2_0 gp_2_0_0 ctp_L1_4 0 NSYN W=10u L=1u
MnTb_L1_4_0 d1bar_L2 vcn ctp_L1_4 0 NSYN W=10u L=1u
MnTa_L1_4_0 dpre_L2_0 vcn ctn_L1_4 0 NSYN W=10u L=1u
MpTb_L1_4_0 d1bar_L2 gp_2_0_0 ctn_L1_4 0 NSYN W=10u L=1u
MpTa_L1_4_1 dpre_L2_2 gp_2_2_1 ctp_L1_4 0 NSYN W=10u L=1u
MnTb_L1_4_1 d1bar_L2 vcn ctp_L1_4 0 NSYN W=10u L=1u
MnTa_L1_4_1 dpre_L2_2 vcn ctn_L1_4 0 NSYN W=10u L=1u
MpTb_L1_4_1 d1bar_L2 gp_2_2_1 ctn_L1_4 0 NSYN W=10u L=1u
MpTa_L1_4_2 dpre_L2_4 gp_2_4_2 ctp_L1_4 0 NSYN W=10u L=1u
MnTb_L1_4_2 d1bar_L2 vcn ctp_L1_4 0 NSYN W=10u L=1u
MnTa_L1_4_2 dpre_L2_4 vcn ctn_L1_4 0 NSYN W=10u L=1u
MpTb_L1_4_2 d1bar_L2 gp_2_4_2 ctn_L1_4 0 NSYN W=10u L=1u
MpTa_L1_4_3 dpre_L2_5 gp_2_5_0 ctp_L1_4 0 NSYN W=10u L=1u
MnTb_L1_4_3 d1bar_L2 vcn ctp_L1_4 0 NSYN W=10u L=1u
MnTa_L1_4_3 dpre_L2_5 vcn ctn_L1_4 0 NSYN W=10u L=1u
MpTb_L1_4_3 d1bar_L2 gp_2_5_0 ctn_L1_4 0 NSYN W=10u L=1u
MpTa_L1_4_4 dpre_L2_9 gp_2_9_1 ctp_L1_4 0 NSYN W=10u L=1u
MnTb_L1_4_4 d1bar_L2 vcn ctp_L1_4 0 NSYN W=10u L=1u
MnTa_L1_4_4 dpre_L2_9 vcn ctn_L1_4 0 NSYN W=10u L=1u
MpTb_L1_4_4 d1bar_L2 gp_2_9_1 ctn_L1_4 0 NSYN W=10u L=1u
MpTa_L1_4_5 dpre_L2_14 gp_2_14_0 ctp_L1_4 0 NSYN W=10u L=1u
MnTb_L1_4_5 d1bar_L2 vcn ctp_L1_4 0 NSYN W=10u L=1u
MnTa_L1_4_5 dpre_L2_14 vcn ctn_L1_4 0 NSYN W=10u L=1u
MpTb_L1_4_5 d1bar_L2 gp_2_14_0 ctn_L1_4 0 NSYN W=10u L=1u
MpTa_L1_4_6 dpre_L2_16 gp_2_16_2 ctp_L1_4 0 NSYN W=10u L=1u
MnTb_L1_4_6 d1bar_L2 vcn ctp_L1_4 0 NSYN W=10u L=1u
MnTa_L1_4_6 dpre_L2_16 vcn ctn_L1_4 0 NSYN W=10u L=1u
MpTb_L1_4_6 d1bar_L2 gp_2_16_2 ctn_L1_4 0 NSYN W=10u L=1u
MpTa_L1_4_7 dpre_L2_17 gp_2_17_3 ctp_L1_4 0 NSYN W=10u L=1u
MnTb_L1_4_7 d1bar_L2 vcn ctp_L1_4 0 NSYN W=10u L=1u
MnTa_L1_4_7 dpre_L2_17 vcn ctn_L1_4 0 NSYN W=10u L=1u
MpTb_L1_4_7 d1bar_L2 gp_2_17_3 ctn_L1_4 0 NSYN W=10u L=1u
MpTa_L1_4_8 dpre_L2_20 gp_2_20_2 ctp_L1_4 0 NSYN W=10u L=1u
MnTb_L1_4_8 d1bar_L2 vcn ctp_L1_4 0 NSYN W=10u L=1u
MnTa_L1_4_8 dpre_L2_20 vcn ctn_L1_4 0 NSYN W=10u L=1u
MpTb_L1_4_8 d1bar_L2 gp_2_20_2 ctn_L1_4 0 NSYN W=10u L=1u
MpTa_L1_4_9 dpre_L2_25 gp_2_25_3 ctp_L1_4 0 NSYN W=10u L=1u
MnTb_L1_4_9 d1bar_L2 vcn ctp_L1_4 0 NSYN W=10u L=1u
MnTa_L1_4_9 dpre_L2_25 vcn ctn_L1_4 0 NSYN W=10u L=1u
MpTb_L1_4_9 d1bar_L2 gp_2_25_3 ctn_L1_4 0 NSYN W=10u L=1u
MpTa_L1_4_10 dpre_L2_26 gp_2_26_1 ctp_L1_4 0 NSYN W=10u L=1u
MnTb_L1_4_10 d1bar_L2 vcn ctp_L1_4 0 NSYN W=10u L=1u
MnTa_L1_4_10 dpre_L2_26 vcn ctn_L1_4 0 NSYN W=10u L=1u
MpTb_L1_4_10 d1bar_L2 gp_2_26_1 ctn_L1_4 0 NSYN W=10u L=1u
MpTa_L1_4_11 dpre_L2_29 gp_2_29_1 ctp_L1_4 0 NSYN W=10u L=1u
MnTb_L1_4_11 d1bar_L2 vcn ctp_L1_4 0 NSYN W=10u L=1u
MnTa_L1_4_11 dpre_L2_29 vcn ctn_L1_4 0 NSYN W=10u L=1u
MpTb_L1_4_11 d1bar_L2 gp_2_29_1 ctn_L1_4 0 NSYN W=10u L=1u
MpTa_L1_4_12 dpre_L2_30 gp_2_30_0 ctp_L1_4 0 NSYN W=10u L=1u
MnTb_L1_4_12 d1bar_L2 vcn ctp_L1_4 0 NSYN W=10u L=1u
MnTa_L1_4_12 dpre_L2_30 vcn ctn_L1_4 0 NSYN W=10u L=1u
MpTb_L1_4_12 d1bar_L2 gp_2_30_0 ctn_L1_4 0 NSYN W=10u L=1u
MpTa_L1_4_13 dpre_L2_31 gp_2_31_2 ctp_L1_4 0 NSYN W=10u L=1u
MnTb_L1_4_13 d1bar_L2 vcn ctp_L1_4 0 NSYN W=10u L=1u
MnTa_L1_4_13 dpre_L2_31 vcn ctn_L1_4 0 NSYN W=10u L=1u
MpTb_L1_4_13 d1bar_L2 gp_2_31_2 ctn_L1_4 0 NSYN W=10u L=1u
MpTa_L1_4_14 dpre_L2_33 gp_2_33_0 ctp_L1_4 0 NSYN W=10u L=1u
MnTb_L1_4_14 d1bar_L2 vcn ctp_L1_4 0 NSYN W=10u L=1u
MnTa_L1_4_14 dpre_L2_33 vcn ctn_L1_4 0 NSYN W=10u L=1u
MpTb_L1_4_14 d1bar_L2 gp_2_33_0 ctn_L1_4 0 NSYN W=10u L=1u
MpTa_L1_4_15 dpre_L2_37 gp_2_37_0 ctp_L1_4 0 NSYN W=10u L=1u
MnTb_L1_4_15 d1bar_L2 vcn ctp_L1_4 0 NSYN W=10u L=1u
MnTa_L1_4_15 dpre_L2_37 vcn ctn_L1_4 0 NSYN W=10u L=1u
MpTb_L1_4_15 d1bar_L2 gp_2_37_0 ctn_L1_4 0 NSYN W=10u L=1u
MpTa_L1_4_16 dpre_L2_39 gp_2_39_1 ctp_L1_4 0 NSYN W=10u L=1u
MnTb_L1_4_16 d1bar_L2 vcn ctp_L1_4 0 NSYN W=10u L=1u
MnTa_L1_4_16 dpre_L2_39 vcn ctn_L1_4 0 NSYN W=10u L=1u
MpTb_L1_4_16 d1bar_L2 gp_2_39_1 ctn_L1_4 0 NSYN W=10u L=1u
Msa_bk_L1_4 ctn_L1_4 ctn_L1_4 0 0 NMIR W=20u L=1u
Msb_bk_L1_4 dpre_L1_4 ctn_L1_4 0 0 NMIR W=20u L=1u
Msc_bk_L1_4 ctp_L1_4 ctp_L1_4 0 0 NMIR W=20u L=1u
Msd_bk_L1_4 dpf_bk_L1_4 ctp_L1_4 0 0 NMIR W=20u L=1u
Mse_bk_L1_4 dpf_bk_L1_4 dpf_bk_L1_4 vdd vdd PMIR W=60u L=1u
Msf_bk_L1_4 dpre_L1_4 dpf_bk_L1_4 vdd vdd PMIR W=60u L=1u
R_bk_L1_4 dpre_L1_4 vrefd 16000.0
MpTa_L1_5_0 dpre_L2_7 gp_2_7_2 ctp_L1_5 0 NSYN W=10u L=1u
MnTb_L1_5_0 d1bar_L2 vcn ctp_L1_5 0 NSYN W=10u L=1u
MnTa_L1_5_0 dpre_L2_7 vcn ctn_L1_5 0 NSYN W=10u L=1u
MpTb_L1_5_0 d1bar_L2 gp_2_7_2 ctn_L1_5 0 NSYN W=10u L=1u
MpTa_L1_5_1 dpre_L2_15 gp_2_15_3 ctp_L1_5 0 NSYN W=10u L=1u
MnTb_L1_5_1 d1bar_L2 vcn ctp_L1_5 0 NSYN W=10u L=1u
MnTa_L1_5_1 dpre_L2_15 vcn ctn_L1_5 0 NSYN W=10u L=1u
MpTb_L1_5_1 d1bar_L2 gp_2_15_3 ctn_L1_5 0 NSYN W=10u L=1u
MpTa_L1_5_2 dpre_L2_18 gp_2_18_1 ctp_L1_5 0 NSYN W=10u L=1u
MnTb_L1_5_2 d1bar_L2 vcn ctp_L1_5 0 NSYN W=10u L=1u
MnTa_L1_5_2 dpre_L2_18 vcn ctn_L1_5 0 NSYN W=10u L=1u
MpTb_L1_5_2 d1bar_L2 gp_2_18_1 ctn_L1_5 0 NSYN W=10u L=1u
MpTa_L1_5_3 dpre_L2_19 gp_2_19_1 ctp_L1_5 0 NSYN W=10u L=1u
MnTb_L1_5_3 d1bar_L2 vcn ctp_L1_5 0 NSYN W=10u L=1u
MnTa_L1_5_3 dpre_L2_19 vcn ctn_L1_5 0 NSYN W=10u L=1u
MpTb_L1_5_3 d1bar_L2 gp_2_19_1 ctn_L1_5 0 NSYN W=10u L=1u
MpTa_L1_5_4 dpre_L2_24 gp_2_24_3 ctp_L1_5 0 NSYN W=10u L=1u
MnTb_L1_5_4 d1bar_L2 vcn ctp_L1_5 0 NSYN W=10u L=1u
MnTa_L1_5_4 dpre_L2_24 vcn ctn_L1_5 0 NSYN W=10u L=1u
MpTb_L1_5_4 d1bar_L2 gp_2_24_3 ctn_L1_5 0 NSYN W=10u L=1u
MpTa_L1_5_5 dpre_L2_27 gp_2_27_1 ctp_L1_5 0 NSYN W=10u L=1u
MnTb_L1_5_5 d1bar_L2 vcn ctp_L1_5 0 NSYN W=10u L=1u
MnTa_L1_5_5 dpre_L2_27 vcn ctn_L1_5 0 NSYN W=10u L=1u
MpTb_L1_5_5 d1bar_L2 gp_2_27_1 ctn_L1_5 0 NSYN W=10u L=1u
MpTa_L1_5_6 dpre_L2_30 gp_2_30_1 ctp_L1_5 0 NSYN W=10u L=1u
MnTb_L1_5_6 d1bar_L2 vcn ctp_L1_5 0 NSYN W=10u L=1u
MnTa_L1_5_6 dpre_L2_30 vcn ctn_L1_5 0 NSYN W=10u L=1u
MpTb_L1_5_6 d1bar_L2 gp_2_30_1 ctn_L1_5 0 NSYN W=10u L=1u
MpTa_L1_5_7 dpre_L2_37 gp_2_37_1 ctp_L1_5 0 NSYN W=10u L=1u
MnTb_L1_5_7 d1bar_L2 vcn ctp_L1_5 0 NSYN W=10u L=1u
MnTa_L1_5_7 dpre_L2_37 vcn ctn_L1_5 0 NSYN W=10u L=1u
MpTb_L1_5_7 d1bar_L2 gp_2_37_1 ctn_L1_5 0 NSYN W=10u L=1u
MpTa_L1_5_8 dpre_L2_43 gp_2_43_1 ctp_L1_5 0 NSYN W=10u L=1u
MnTb_L1_5_8 d1bar_L2 vcn ctp_L1_5 0 NSYN W=10u L=1u
MnTa_L1_5_8 dpre_L2_43 vcn ctn_L1_5 0 NSYN W=10u L=1u
MpTb_L1_5_8 d1bar_L2 gp_2_43_1 ctn_L1_5 0 NSYN W=10u L=1u
MpTa_L1_5_9 dpre_L2_47 gp_2_47_2 ctp_L1_5 0 NSYN W=10u L=1u
MnTb_L1_5_9 d1bar_L2 vcn ctp_L1_5 0 NSYN W=10u L=1u
MnTa_L1_5_9 dpre_L2_47 vcn ctn_L1_5 0 NSYN W=10u L=1u
MpTb_L1_5_9 d1bar_L2 gp_2_47_2 ctn_L1_5 0 NSYN W=10u L=1u
Msa_bk_L1_5 ctn_L1_5 ctn_L1_5 0 0 NMIR W=20u L=1u
Msb_bk_L1_5 dpre_L1_5 ctn_L1_5 0 0 NMIR W=20u L=1u
Msc_bk_L1_5 ctp_L1_5 ctp_L1_5 0 0 NMIR W=20u L=1u
Msd_bk_L1_5 dpf_bk_L1_5 ctp_L1_5 0 0 NMIR W=20u L=1u
Mse_bk_L1_5 dpf_bk_L1_5 dpf_bk_L1_5 vdd vdd PMIR W=60u L=1u
Msf_bk_L1_5 dpre_L1_5 dpf_bk_L1_5 vdd vdd PMIR W=60u L=1u
R_bk_L1_5 dpre_L1_5 vrefd 16000.0
MpTa_L1_6_0 dpre_L2_0 gp_2_0_1 ctp_L1_6 0 NSYN W=10u L=1u
MnTb_L1_6_0 d1bar_L2 vcn ctp_L1_6 0 NSYN W=10u L=1u
MnTa_L1_6_0 dpre_L2_0 vcn ctn_L1_6 0 NSYN W=10u L=1u
MpTb_L1_6_0 d1bar_L2 gp_2_0_1 ctn_L1_6 0 NSYN W=10u L=1u
MpTa_L1_6_1 dpre_L2_3 gp_2_3_2 ctp_L1_6 0 NSYN W=10u L=1u
MnTb_L1_6_1 d1bar_L2 vcn ctp_L1_6 0 NSYN W=10u L=1u
MnTa_L1_6_1 dpre_L2_3 vcn ctn_L1_6 0 NSYN W=10u L=1u
MpTb_L1_6_1 d1bar_L2 gp_2_3_2 ctn_L1_6 0 NSYN W=10u L=1u
MpTa_L1_6_2 dpre_L2_4 gp_2_4_3 ctp_L1_6 0 NSYN W=10u L=1u
MnTb_L1_6_2 d1bar_L2 vcn ctp_L1_6 0 NSYN W=10u L=1u
MnTa_L1_6_2 dpre_L2_4 vcn ctn_L1_6 0 NSYN W=10u L=1u
MpTb_L1_6_2 d1bar_L2 gp_2_4_3 ctn_L1_6 0 NSYN W=10u L=1u
MpTa_L1_6_3 dpre_L2_6 gp_2_6_0 ctp_L1_6 0 NSYN W=10u L=1u
MnTb_L1_6_3 d1bar_L2 vcn ctp_L1_6 0 NSYN W=10u L=1u
MnTa_L1_6_3 dpre_L2_6 vcn ctn_L1_6 0 NSYN W=10u L=1u
MpTb_L1_6_3 d1bar_L2 gp_2_6_0 ctn_L1_6 0 NSYN W=10u L=1u
MpTa_L1_6_4 dpre_L2_10 gp_2_10_2 ctp_L1_6 0 NSYN W=10u L=1u
MnTb_L1_6_4 d1bar_L2 vcn ctp_L1_6 0 NSYN W=10u L=1u
MnTa_L1_6_4 dpre_L2_10 vcn ctn_L1_6 0 NSYN W=10u L=1u
MpTb_L1_6_4 d1bar_L2 gp_2_10_2 ctn_L1_6 0 NSYN W=10u L=1u
MpTa_L1_6_5 dpre_L2_12 gp_2_12_1 ctp_L1_6 0 NSYN W=10u L=1u
MnTb_L1_6_5 d1bar_L2 vcn ctp_L1_6 0 NSYN W=10u L=1u
MnTa_L1_6_5 dpre_L2_12 vcn ctn_L1_6 0 NSYN W=10u L=1u
MpTb_L1_6_5 d1bar_L2 gp_2_12_1 ctn_L1_6 0 NSYN W=10u L=1u
MpTa_L1_6_6 dpre_L2_13 gp_2_13_2 ctp_L1_6 0 NSYN W=10u L=1u
MnTb_L1_6_6 d1bar_L2 vcn ctp_L1_6 0 NSYN W=10u L=1u
MnTa_L1_6_6 dpre_L2_13 vcn ctn_L1_6 0 NSYN W=10u L=1u
MpTb_L1_6_6 d1bar_L2 gp_2_13_2 ctn_L1_6 0 NSYN W=10u L=1u
MpTa_L1_6_7 dpre_L2_14 gp_2_14_1 ctp_L1_6 0 NSYN W=10u L=1u
MnTb_L1_6_7 d1bar_L2 vcn ctp_L1_6 0 NSYN W=10u L=1u
MnTa_L1_6_7 dpre_L2_14 vcn ctn_L1_6 0 NSYN W=10u L=1u
MpTb_L1_6_7 d1bar_L2 gp_2_14_1 ctn_L1_6 0 NSYN W=10u L=1u
MpTa_L1_6_8 dpre_L2_18 gp_2_18_2 ctp_L1_6 0 NSYN W=10u L=1u
MnTb_L1_6_8 d1bar_L2 vcn ctp_L1_6 0 NSYN W=10u L=1u
MnTa_L1_6_8 dpre_L2_18 vcn ctn_L1_6 0 NSYN W=10u L=1u
MpTb_L1_6_8 d1bar_L2 gp_2_18_2 ctn_L1_6 0 NSYN W=10u L=1u
MpTa_L1_6_9 dpre_L2_22 gp_2_22_0 ctp_L1_6 0 NSYN W=10u L=1u
MnTb_L1_6_9 d1bar_L2 vcn ctp_L1_6 0 NSYN W=10u L=1u
MnTa_L1_6_9 dpre_L2_22 vcn ctn_L1_6 0 NSYN W=10u L=1u
MpTb_L1_6_9 d1bar_L2 gp_2_22_0 ctn_L1_6 0 NSYN W=10u L=1u
MpTa_L1_6_10 dpre_L2_27 gp_2_27_2 ctp_L1_6 0 NSYN W=10u L=1u
MnTb_L1_6_10 d1bar_L2 vcn ctp_L1_6 0 NSYN W=10u L=1u
MnTa_L1_6_10 dpre_L2_27 vcn ctn_L1_6 0 NSYN W=10u L=1u
MpTb_L1_6_10 d1bar_L2 gp_2_27_2 ctn_L1_6 0 NSYN W=10u L=1u
MpTa_L1_6_11 dpre_L2_28 gp_2_28_1 ctp_L1_6 0 NSYN W=10u L=1u
MnTb_L1_6_11 d1bar_L2 vcn ctp_L1_6 0 NSYN W=10u L=1u
MnTa_L1_6_11 dpre_L2_28 vcn ctn_L1_6 0 NSYN W=10u L=1u
MpTb_L1_6_11 d1bar_L2 gp_2_28_1 ctn_L1_6 0 NSYN W=10u L=1u
MpTa_L1_6_12 dpre_L2_30 gp_2_30_2 ctp_L1_6 0 NSYN W=10u L=1u
MnTb_L1_6_12 d1bar_L2 vcn ctp_L1_6 0 NSYN W=10u L=1u
MnTa_L1_6_12 dpre_L2_30 vcn ctn_L1_6 0 NSYN W=10u L=1u
MpTb_L1_6_12 d1bar_L2 gp_2_30_2 ctn_L1_6 0 NSYN W=10u L=1u
MpTa_L1_6_13 dpre_L2_32 gp_2_32_2 ctp_L1_6 0 NSYN W=10u L=1u
MnTb_L1_6_13 d1bar_L2 vcn ctp_L1_6 0 NSYN W=10u L=1u
MnTa_L1_6_13 dpre_L2_32 vcn ctn_L1_6 0 NSYN W=10u L=1u
MpTb_L1_6_13 d1bar_L2 gp_2_32_2 ctn_L1_6 0 NSYN W=10u L=1u
MpTa_L1_6_14 dpre_L2_33 gp_2_33_1 ctp_L1_6 0 NSYN W=10u L=1u
MnTb_L1_6_14 d1bar_L2 vcn ctp_L1_6 0 NSYN W=10u L=1u
MnTa_L1_6_14 dpre_L2_33 vcn ctn_L1_6 0 NSYN W=10u L=1u
MpTb_L1_6_14 d1bar_L2 gp_2_33_1 ctn_L1_6 0 NSYN W=10u L=1u
MpTa_L1_6_15 dpre_L2_35 gp_2_35_1 ctp_L1_6 0 NSYN W=10u L=1u
MnTb_L1_6_15 d1bar_L2 vcn ctp_L1_6 0 NSYN W=10u L=1u
MnTa_L1_6_15 dpre_L2_35 vcn ctn_L1_6 0 NSYN W=10u L=1u
MpTb_L1_6_15 d1bar_L2 gp_2_35_1 ctn_L1_6 0 NSYN W=10u L=1u
MpTa_L1_6_16 dpre_L2_36 gp_2_36_2 ctp_L1_6 0 NSYN W=10u L=1u
MnTb_L1_6_16 d1bar_L2 vcn ctp_L1_6 0 NSYN W=10u L=1u
MnTa_L1_6_16 dpre_L2_36 vcn ctn_L1_6 0 NSYN W=10u L=1u
MpTb_L1_6_16 d1bar_L2 gp_2_36_2 ctn_L1_6 0 NSYN W=10u L=1u
MpTa_L1_6_17 dpre_L2_40 gp_2_40_1 ctp_L1_6 0 NSYN W=10u L=1u
MnTb_L1_6_17 d1bar_L2 vcn ctp_L1_6 0 NSYN W=10u L=1u
MnTa_L1_6_17 dpre_L2_40 vcn ctn_L1_6 0 NSYN W=10u L=1u
MpTb_L1_6_17 d1bar_L2 gp_2_40_1 ctn_L1_6 0 NSYN W=10u L=1u
MpTa_L1_6_18 dpre_L2_42 gp_2_42_2 ctp_L1_6 0 NSYN W=10u L=1u
MnTb_L1_6_18 d1bar_L2 vcn ctp_L1_6 0 NSYN W=10u L=1u
MnTa_L1_6_18 dpre_L2_42 vcn ctn_L1_6 0 NSYN W=10u L=1u
MpTb_L1_6_18 d1bar_L2 gp_2_42_2 ctn_L1_6 0 NSYN W=10u L=1u
MpTa_L1_6_19 dpre_L2_46 gp_2_46_3 ctp_L1_6 0 NSYN W=10u L=1u
MnTb_L1_6_19 d1bar_L2 vcn ctp_L1_6 0 NSYN W=10u L=1u
MnTa_L1_6_19 dpre_L2_46 vcn ctn_L1_6 0 NSYN W=10u L=1u
MpTb_L1_6_19 d1bar_L2 gp_2_46_3 ctn_L1_6 0 NSYN W=10u L=1u
MpTa_L1_6_20 dpre_L2_47 gp_2_47_3 ctp_L1_6 0 NSYN W=10u L=1u
MnTb_L1_6_20 d1bar_L2 vcn ctp_L1_6 0 NSYN W=10u L=1u
MnTa_L1_6_20 dpre_L2_47 vcn ctn_L1_6 0 NSYN W=10u L=1u
MpTb_L1_6_20 d1bar_L2 gp_2_47_3 ctn_L1_6 0 NSYN W=10u L=1u
Msa_bk_L1_6 ctn_L1_6 ctn_L1_6 0 0 NMIR W=20u L=1u
Msb_bk_L1_6 dpre_L1_6 ctn_L1_6 0 0 NMIR W=20u L=1u
Msc_bk_L1_6 ctp_L1_6 ctp_L1_6 0 0 NMIR W=20u L=1u
Msd_bk_L1_6 dpf_bk_L1_6 ctp_L1_6 0 0 NMIR W=20u L=1u
Mse_bk_L1_6 dpf_bk_L1_6 dpf_bk_L1_6 vdd vdd PMIR W=60u L=1u
Msf_bk_L1_6 dpre_L1_6 dpf_bk_L1_6 vdd vdd PMIR W=60u L=1u
R_bk_L1_6 dpre_L1_6 vrefd 16000.0
MpTa_L1_7_0 dpre_L2_2 gp_2_2_2 ctp_L1_7 0 NSYN W=10u L=1u
MnTb_L1_7_0 d1bar_L2 vcn ctp_L1_7 0 NSYN W=10u L=1u
MnTa_L1_7_0 dpre_L2_2 vcn ctn_L1_7 0 NSYN W=10u L=1u
MpTb_L1_7_0 d1bar_L2 gp_2_2_2 ctn_L1_7 0 NSYN W=10u L=1u
MpTa_L1_7_1 dpre_L2_3 gp_2_3_3 ctp_L1_7 0 NSYN W=10u L=1u
MnTb_L1_7_1 d1bar_L2 vcn ctp_L1_7 0 NSYN W=10u L=1u
MnTa_L1_7_1 dpre_L2_3 vcn ctn_L1_7 0 NSYN W=10u L=1u
MpTb_L1_7_1 d1bar_L2 gp_2_3_3 ctn_L1_7 0 NSYN W=10u L=1u
MpTa_L1_7_2 dpre_L2_4 gp_2_4_4 ctp_L1_7 0 NSYN W=10u L=1u
MnTb_L1_7_2 d1bar_L2 vcn ctp_L1_7 0 NSYN W=10u L=1u
MnTa_L1_7_2 dpre_L2_4 vcn ctn_L1_7 0 NSYN W=10u L=1u
MpTb_L1_7_2 d1bar_L2 gp_2_4_4 ctn_L1_7 0 NSYN W=10u L=1u
MpTa_L1_7_3 dpre_L2_5 gp_2_5_1 ctp_L1_7 0 NSYN W=10u L=1u
MnTb_L1_7_3 d1bar_L2 vcn ctp_L1_7 0 NSYN W=10u L=1u
MnTa_L1_7_3 dpre_L2_5 vcn ctn_L1_7 0 NSYN W=10u L=1u
MpTb_L1_7_3 d1bar_L2 gp_2_5_1 ctn_L1_7 0 NSYN W=10u L=1u
MpTa_L1_7_4 dpre_L2_6 gp_2_6_1 ctp_L1_7 0 NSYN W=10u L=1u
MnTb_L1_7_4 d1bar_L2 vcn ctp_L1_7 0 NSYN W=10u L=1u
MnTa_L1_7_4 dpre_L2_6 vcn ctn_L1_7 0 NSYN W=10u L=1u
MpTb_L1_7_4 d1bar_L2 gp_2_6_1 ctn_L1_7 0 NSYN W=10u L=1u
MpTa_L1_7_5 dpre_L2_7 gp_2_7_3 ctp_L1_7 0 NSYN W=10u L=1u
MnTb_L1_7_5 d1bar_L2 vcn ctp_L1_7 0 NSYN W=10u L=1u
MnTa_L1_7_5 dpre_L2_7 vcn ctn_L1_7 0 NSYN W=10u L=1u
MpTb_L1_7_5 d1bar_L2 gp_2_7_3 ctn_L1_7 0 NSYN W=10u L=1u
MpTa_L1_7_6 dpre_L2_9 gp_2_9_2 ctp_L1_7 0 NSYN W=10u L=1u
MnTb_L1_7_6 d1bar_L2 vcn ctp_L1_7 0 NSYN W=10u L=1u
MnTa_L1_7_6 dpre_L2_9 vcn ctn_L1_7 0 NSYN W=10u L=1u
MpTb_L1_7_6 d1bar_L2 gp_2_9_2 ctn_L1_7 0 NSYN W=10u L=1u
MpTa_L1_7_7 dpre_L2_10 gp_2_10_3 ctp_L1_7 0 NSYN W=10u L=1u
MnTb_L1_7_7 d1bar_L2 vcn ctp_L1_7 0 NSYN W=10u L=1u
MnTa_L1_7_7 dpre_L2_10 vcn ctn_L1_7 0 NSYN W=10u L=1u
MpTb_L1_7_7 d1bar_L2 gp_2_10_3 ctn_L1_7 0 NSYN W=10u L=1u
MpTa_L1_7_8 dpre_L2_11 gp_2_11_2 ctp_L1_7 0 NSYN W=10u L=1u
MnTb_L1_7_8 d1bar_L2 vcn ctp_L1_7 0 NSYN W=10u L=1u
MnTa_L1_7_8 dpre_L2_11 vcn ctn_L1_7 0 NSYN W=10u L=1u
MpTb_L1_7_8 d1bar_L2 gp_2_11_2 ctn_L1_7 0 NSYN W=10u L=1u
MpTa_L1_7_9 dpre_L2_12 gp_2_12_2 ctp_L1_7 0 NSYN W=10u L=1u
MnTb_L1_7_9 d1bar_L2 vcn ctp_L1_7 0 NSYN W=10u L=1u
MnTa_L1_7_9 dpre_L2_12 vcn ctn_L1_7 0 NSYN W=10u L=1u
MpTb_L1_7_9 d1bar_L2 gp_2_12_2 ctn_L1_7 0 NSYN W=10u L=1u
MpTa_L1_7_10 dpre_L2_16 gp_2_16_3 ctp_L1_7 0 NSYN W=10u L=1u
MnTb_L1_7_10 d1bar_L2 vcn ctp_L1_7 0 NSYN W=10u L=1u
MnTa_L1_7_10 dpre_L2_16 vcn ctn_L1_7 0 NSYN W=10u L=1u
MpTb_L1_7_10 d1bar_L2 gp_2_16_3 ctn_L1_7 0 NSYN W=10u L=1u
MpTa_L1_7_11 dpre_L2_25 gp_2_25_4 ctp_L1_7 0 NSYN W=10u L=1u
MnTb_L1_7_11 d1bar_L2 vcn ctp_L1_7 0 NSYN W=10u L=1u
MnTa_L1_7_11 dpre_L2_25 vcn ctn_L1_7 0 NSYN W=10u L=1u
MpTb_L1_7_11 d1bar_L2 gp_2_25_4 ctn_L1_7 0 NSYN W=10u L=1u
MpTa_L1_7_12 dpre_L2_31 gp_2_31_3 ctp_L1_7 0 NSYN W=10u L=1u
MnTb_L1_7_12 d1bar_L2 vcn ctp_L1_7 0 NSYN W=10u L=1u
MnTa_L1_7_12 dpre_L2_31 vcn ctn_L1_7 0 NSYN W=10u L=1u
MpTb_L1_7_12 d1bar_L2 gp_2_31_3 ctn_L1_7 0 NSYN W=10u L=1u
MpTa_L1_7_13 dpre_L2_36 gp_2_36_3 ctp_L1_7 0 NSYN W=10u L=1u
MnTb_L1_7_13 d1bar_L2 vcn ctp_L1_7 0 NSYN W=10u L=1u
MnTa_L1_7_13 dpre_L2_36 vcn ctn_L1_7 0 NSYN W=10u L=1u
MpTb_L1_7_13 d1bar_L2 gp_2_36_3 ctn_L1_7 0 NSYN W=10u L=1u
MpTa_L1_7_14 dpre_L2_37 gp_2_37_2 ctp_L1_7 0 NSYN W=10u L=1u
MnTb_L1_7_14 d1bar_L2 vcn ctp_L1_7 0 NSYN W=10u L=1u
MnTa_L1_7_14 dpre_L2_37 vcn ctn_L1_7 0 NSYN W=10u L=1u
MpTb_L1_7_14 d1bar_L2 gp_2_37_2 ctn_L1_7 0 NSYN W=10u L=1u
MpTa_L1_7_15 dpre_L2_40 gp_2_40_2 ctp_L1_7 0 NSYN W=10u L=1u
MnTb_L1_7_15 d1bar_L2 vcn ctp_L1_7 0 NSYN W=10u L=1u
MnTa_L1_7_15 dpre_L2_40 vcn ctn_L1_7 0 NSYN W=10u L=1u
MpTb_L1_7_15 d1bar_L2 gp_2_40_2 ctn_L1_7 0 NSYN W=10u L=1u
MpTa_L1_7_16 dpre_L2_43 gp_2_43_2 ctp_L1_7 0 NSYN W=10u L=1u
MnTb_L1_7_16 d1bar_L2 vcn ctp_L1_7 0 NSYN W=10u L=1u
MnTa_L1_7_16 dpre_L2_43 vcn ctn_L1_7 0 NSYN W=10u L=1u
MpTb_L1_7_16 d1bar_L2 gp_2_43_2 ctn_L1_7 0 NSYN W=10u L=1u
MpTa_L1_7_17 dpre_L2_45 gp_2_45_1 ctp_L1_7 0 NSYN W=10u L=1u
MnTb_L1_7_17 d1bar_L2 vcn ctp_L1_7 0 NSYN W=10u L=1u
MnTa_L1_7_17 dpre_L2_45 vcn ctn_L1_7 0 NSYN W=10u L=1u
MpTb_L1_7_17 d1bar_L2 gp_2_45_1 ctn_L1_7 0 NSYN W=10u L=1u
MpTa_L1_7_18 dpre_L2_46 gp_2_46_4 ctp_L1_7 0 NSYN W=10u L=1u
MnTb_L1_7_18 d1bar_L2 vcn ctp_L1_7 0 NSYN W=10u L=1u
MnTa_L1_7_18 dpre_L2_46 vcn ctn_L1_7 0 NSYN W=10u L=1u
MpTb_L1_7_18 d1bar_L2 gp_2_46_4 ctn_L1_7 0 NSYN W=10u L=1u
Msa_bk_L1_7 ctn_L1_7 ctn_L1_7 0 0 NMIR W=20u L=1u
Msb_bk_L1_7 dpre_L1_7 ctn_L1_7 0 0 NMIR W=20u L=1u
Msc_bk_L1_7 ctp_L1_7 ctp_L1_7 0 0 NMIR W=20u L=1u
Msd_bk_L1_7 dpf_bk_L1_7 ctp_L1_7 0 0 NMIR W=20u L=1u
Mse_bk_L1_7 dpf_bk_L1_7 dpf_bk_L1_7 vdd vdd PMIR W=60u L=1u
Msf_bk_L1_7 dpre_L1_7 dpf_bk_L1_7 vdd vdd PMIR W=60u L=1u
R_bk_L1_7 dpre_L1_7 vrefd 16000.0
MpTa_L1_8_0 dpre_L2_2 gp_2_2_3 ctp_L1_8 0 NSYN W=10u L=1u
MnTb_L1_8_0 d1bar_L2 vcn ctp_L1_8 0 NSYN W=10u L=1u
MnTa_L1_8_0 dpre_L2_2 vcn ctn_L1_8 0 NSYN W=10u L=1u
MpTb_L1_8_0 d1bar_L2 gp_2_2_3 ctn_L1_8 0 NSYN W=10u L=1u
MpTa_L1_8_1 dpre_L2_6 gp_2_6_2 ctp_L1_8 0 NSYN W=10u L=1u
MnTb_L1_8_1 d1bar_L2 vcn ctp_L1_8 0 NSYN W=10u L=1u
MnTa_L1_8_1 dpre_L2_6 vcn ctn_L1_8 0 NSYN W=10u L=1u
MpTb_L1_8_1 d1bar_L2 gp_2_6_2 ctn_L1_8 0 NSYN W=10u L=1u
MpTa_L1_8_2 dpre_L2_17 gp_2_17_4 ctp_L1_8 0 NSYN W=10u L=1u
MnTb_L1_8_2 d1bar_L2 vcn ctp_L1_8 0 NSYN W=10u L=1u
MnTa_L1_8_2 dpre_L2_17 vcn ctn_L1_8 0 NSYN W=10u L=1u
MpTb_L1_8_2 d1bar_L2 gp_2_17_4 ctn_L1_8 0 NSYN W=10u L=1u
MpTa_L1_8_3 dpre_L2_26 gp_2_26_2 ctp_L1_8 0 NSYN W=10u L=1u
MnTb_L1_8_3 d1bar_L2 vcn ctp_L1_8 0 NSYN W=10u L=1u
MnTa_L1_8_3 dpre_L2_26 vcn ctn_L1_8 0 NSYN W=10u L=1u
MpTb_L1_8_3 d1bar_L2 gp_2_26_2 ctn_L1_8 0 NSYN W=10u L=1u
MpTa_L1_8_4 dpre_L2_28 gp_2_28_2 ctp_L1_8 0 NSYN W=10u L=1u
MnTb_L1_8_4 d1bar_L2 vcn ctp_L1_8 0 NSYN W=10u L=1u
MnTa_L1_8_4 dpre_L2_28 vcn ctn_L1_8 0 NSYN W=10u L=1u
MpTb_L1_8_4 d1bar_L2 gp_2_28_2 ctn_L1_8 0 NSYN W=10u L=1u
MpTa_L1_8_5 dpre_L2_34 gp_2_34_3 ctp_L1_8 0 NSYN W=10u L=1u
MnTb_L1_8_5 d1bar_L2 vcn ctp_L1_8 0 NSYN W=10u L=1u
MnTa_L1_8_5 dpre_L2_34 vcn ctn_L1_8 0 NSYN W=10u L=1u
MpTb_L1_8_5 d1bar_L2 gp_2_34_3 ctn_L1_8 0 NSYN W=10u L=1u
MpTa_L1_8_6 dpre_L2_35 gp_2_35_2 ctp_L1_8 0 NSYN W=10u L=1u
MnTb_L1_8_6 d1bar_L2 vcn ctp_L1_8 0 NSYN W=10u L=1u
MnTa_L1_8_6 dpre_L2_35 vcn ctn_L1_8 0 NSYN W=10u L=1u
MpTb_L1_8_6 d1bar_L2 gp_2_35_2 ctn_L1_8 0 NSYN W=10u L=1u
MpTa_L1_8_7 dpre_L2_42 gp_2_42_3 ctp_L1_8 0 NSYN W=10u L=1u
MnTb_L1_8_7 d1bar_L2 vcn ctp_L1_8 0 NSYN W=10u L=1u
MnTa_L1_8_7 dpre_L2_42 vcn ctn_L1_8 0 NSYN W=10u L=1u
MpTb_L1_8_7 d1bar_L2 gp_2_42_3 ctn_L1_8 0 NSYN W=10u L=1u
MpTa_L1_8_8 dpre_L2_43 gp_2_43_3 ctp_L1_8 0 NSYN W=10u L=1u
MnTb_L1_8_8 d1bar_L2 vcn ctp_L1_8 0 NSYN W=10u L=1u
MnTa_L1_8_8 dpre_L2_43 vcn ctn_L1_8 0 NSYN W=10u L=1u
MpTb_L1_8_8 d1bar_L2 gp_2_43_3 ctn_L1_8 0 NSYN W=10u L=1u
Msa_bk_L1_8 ctn_L1_8 ctn_L1_8 0 0 NMIR W=20u L=1u
Msb_bk_L1_8 dpre_L1_8 ctn_L1_8 0 0 NMIR W=20u L=1u
Msc_bk_L1_8 ctp_L1_8 ctp_L1_8 0 0 NMIR W=20u L=1u
Msd_bk_L1_8 dpf_bk_L1_8 ctp_L1_8 0 0 NMIR W=20u L=1u
Mse_bk_L1_8 dpf_bk_L1_8 dpf_bk_L1_8 vdd vdd PMIR W=60u L=1u
Msf_bk_L1_8 dpre_L1_8 dpf_bk_L1_8 vdd vdd PMIR W=60u L=1u
R_bk_L1_8 dpre_L1_8 vrefd 16000.0
MpTa_L1_9_0 dpre_L2_8 gp_2_8_1 ctp_L1_9 0 NSYN W=10u L=1u
MnTb_L1_9_0 d1bar_L2 vcn ctp_L1_9 0 NSYN W=10u L=1u
MnTa_L1_9_0 dpre_L2_8 vcn ctn_L1_9 0 NSYN W=10u L=1u
MpTb_L1_9_0 d1bar_L2 gp_2_8_1 ctn_L1_9 0 NSYN W=10u L=1u
MpTa_L1_9_1 dpre_L2_11 gp_2_11_3 ctp_L1_9 0 NSYN W=10u L=1u
MnTb_L1_9_1 d1bar_L2 vcn ctp_L1_9 0 NSYN W=10u L=1u
MnTa_L1_9_1 dpre_L2_11 vcn ctn_L1_9 0 NSYN W=10u L=1u
MpTb_L1_9_1 d1bar_L2 gp_2_11_3 ctn_L1_9 0 NSYN W=10u L=1u
MpTa_L1_9_2 dpre_L2_12 gp_2_12_3 ctp_L1_9 0 NSYN W=10u L=1u
MnTb_L1_9_2 d1bar_L2 vcn ctp_L1_9 0 NSYN W=10u L=1u
MnTa_L1_9_2 dpre_L2_12 vcn ctn_L1_9 0 NSYN W=10u L=1u
MpTb_L1_9_2 d1bar_L2 gp_2_12_3 ctn_L1_9 0 NSYN W=10u L=1u
MpTa_L1_9_3 dpre_L2_13 gp_2_13_3 ctp_L1_9 0 NSYN W=10u L=1u
MnTb_L1_9_3 d1bar_L2 vcn ctp_L1_9 0 NSYN W=10u L=1u
MnTa_L1_9_3 dpre_L2_13 vcn ctn_L1_9 0 NSYN W=10u L=1u
MpTb_L1_9_3 d1bar_L2 gp_2_13_3 ctn_L1_9 0 NSYN W=10u L=1u
MpTa_L1_9_4 dpre_L2_20 gp_2_20_3 ctp_L1_9 0 NSYN W=10u L=1u
MnTb_L1_9_4 d1bar_L2 vcn ctp_L1_9 0 NSYN W=10u L=1u
MnTa_L1_9_4 dpre_L2_20 vcn ctn_L1_9 0 NSYN W=10u L=1u
MpTb_L1_9_4 d1bar_L2 gp_2_20_3 ctn_L1_9 0 NSYN W=10u L=1u
MpTa_L1_9_5 dpre_L2_21 gp_2_21_2 ctp_L1_9 0 NSYN W=10u L=1u
MnTb_L1_9_5 d1bar_L2 vcn ctp_L1_9 0 NSYN W=10u L=1u
MnTa_L1_9_5 dpre_L2_21 vcn ctn_L1_9 0 NSYN W=10u L=1u
MpTb_L1_9_5 d1bar_L2 gp_2_21_2 ctn_L1_9 0 NSYN W=10u L=1u
MpTa_L1_9_6 dpre_L2_22 gp_2_22_1 ctp_L1_9 0 NSYN W=10u L=1u
MnTb_L1_9_6 d1bar_L2 vcn ctp_L1_9 0 NSYN W=10u L=1u
MnTa_L1_9_6 dpre_L2_22 vcn ctn_L1_9 0 NSYN W=10u L=1u
MpTb_L1_9_6 d1bar_L2 gp_2_22_1 ctn_L1_9 0 NSYN W=10u L=1u
MpTa_L1_9_7 dpre_L2_26 gp_2_26_3 ctp_L1_9 0 NSYN W=10u L=1u
MnTb_L1_9_7 d1bar_L2 vcn ctp_L1_9 0 NSYN W=10u L=1u
MnTa_L1_9_7 dpre_L2_26 vcn ctn_L1_9 0 NSYN W=10u L=1u
MpTb_L1_9_7 d1bar_L2 gp_2_26_3 ctn_L1_9 0 NSYN W=10u L=1u
MpTa_L1_9_8 dpre_L2_27 gp_2_27_3 ctp_L1_9 0 NSYN W=10u L=1u
MnTb_L1_9_8 d1bar_L2 vcn ctp_L1_9 0 NSYN W=10u L=1u
MnTa_L1_9_8 dpre_L2_27 vcn ctn_L1_9 0 NSYN W=10u L=1u
MpTb_L1_9_8 d1bar_L2 gp_2_27_3 ctn_L1_9 0 NSYN W=10u L=1u
MpTa_L1_9_9 dpre_L2_30 gp_2_30_3 ctp_L1_9 0 NSYN W=10u L=1u
MnTb_L1_9_9 d1bar_L2 vcn ctp_L1_9 0 NSYN W=10u L=1u
MnTa_L1_9_9 dpre_L2_30 vcn ctn_L1_9 0 NSYN W=10u L=1u
MpTb_L1_9_9 d1bar_L2 gp_2_30_3 ctn_L1_9 0 NSYN W=10u L=1u
MpTa_L1_9_10 dpre_L2_33 gp_2_33_2 ctp_L1_9 0 NSYN W=10u L=1u
MnTb_L1_9_10 d1bar_L2 vcn ctp_L1_9 0 NSYN W=10u L=1u
MnTa_L1_9_10 dpre_L2_33 vcn ctn_L1_9 0 NSYN W=10u L=1u
MpTb_L1_9_10 d1bar_L2 gp_2_33_2 ctn_L1_9 0 NSYN W=10u L=1u
MpTa_L1_9_11 dpre_L2_34 gp_2_34_4 ctp_L1_9 0 NSYN W=10u L=1u
MnTb_L1_9_11 d1bar_L2 vcn ctp_L1_9 0 NSYN W=10u L=1u
MnTa_L1_9_11 dpre_L2_34 vcn ctn_L1_9 0 NSYN W=10u L=1u
MpTb_L1_9_11 d1bar_L2 gp_2_34_4 ctn_L1_9 0 NSYN W=10u L=1u
MpTa_L1_9_12 dpre_L2_38 gp_2_38_1 ctp_L1_9 0 NSYN W=10u L=1u
MnTb_L1_9_12 d1bar_L2 vcn ctp_L1_9 0 NSYN W=10u L=1u
MnTa_L1_9_12 dpre_L2_38 vcn ctn_L1_9 0 NSYN W=10u L=1u
MpTb_L1_9_12 d1bar_L2 gp_2_38_1 ctn_L1_9 0 NSYN W=10u L=1u
MpTa_L1_9_13 dpre_L2_39 gp_2_39_2 ctp_L1_9 0 NSYN W=10u L=1u
MnTb_L1_9_13 d1bar_L2 vcn ctp_L1_9 0 NSYN W=10u L=1u
MnTa_L1_9_13 dpre_L2_39 vcn ctn_L1_9 0 NSYN W=10u L=1u
MpTb_L1_9_13 d1bar_L2 gp_2_39_2 ctn_L1_9 0 NSYN W=10u L=1u
MpTa_L1_9_14 dpre_L2_41 gp_2_41_3 ctp_L1_9 0 NSYN W=10u L=1u
MnTb_L1_9_14 d1bar_L2 vcn ctp_L1_9 0 NSYN W=10u L=1u
MnTa_L1_9_14 dpre_L2_41 vcn ctn_L1_9 0 NSYN W=10u L=1u
MpTb_L1_9_14 d1bar_L2 gp_2_41_3 ctn_L1_9 0 NSYN W=10u L=1u
MpTa_L1_9_15 dpre_L2_44 gp_2_44_2 ctp_L1_9 0 NSYN W=10u L=1u
MnTb_L1_9_15 d1bar_L2 vcn ctp_L1_9 0 NSYN W=10u L=1u
MnTa_L1_9_15 dpre_L2_44 vcn ctn_L1_9 0 NSYN W=10u L=1u
MpTb_L1_9_15 d1bar_L2 gp_2_44_2 ctn_L1_9 0 NSYN W=10u L=1u
MpTa_L1_9_16 dpre_L2_47 gp_2_47_4 ctp_L1_9 0 NSYN W=10u L=1u
MnTb_L1_9_16 d1bar_L2 vcn ctp_L1_9 0 NSYN W=10u L=1u
MnTa_L1_9_16 dpre_L2_47 vcn ctn_L1_9 0 NSYN W=10u L=1u
MpTb_L1_9_16 d1bar_L2 gp_2_47_4 ctn_L1_9 0 NSYN W=10u L=1u
Msa_bk_L1_9 ctn_L1_9 ctn_L1_9 0 0 NMIR W=20u L=1u
Msb_bk_L1_9 dpre_L1_9 ctn_L1_9 0 0 NMIR W=20u L=1u
Msc_bk_L1_9 ctp_L1_9 ctp_L1_9 0 0 NMIR W=20u L=1u
Msd_bk_L1_9 dpf_bk_L1_9 ctp_L1_9 0 0 NMIR W=20u L=1u
Mse_bk_L1_9 dpf_bk_L1_9 dpf_bk_L1_9 vdd vdd PMIR W=60u L=1u
Msf_bk_L1_9 dpre_L1_9 dpf_bk_L1_9 vdd vdd PMIR W=60u L=1u
R_bk_L1_9 dpre_L1_9 vrefd 16000.0
MpTa_L1_10_0 dpre_L2_0 gp_2_0_2 ctp_L1_10 0 NSYN W=10u L=1u
MnTb_L1_10_0 d1bar_L2 vcn ctp_L1_10 0 NSYN W=10u L=1u
MnTa_L1_10_0 dpre_L2_0 vcn ctn_L1_10 0 NSYN W=10u L=1u
MpTb_L1_10_0 d1bar_L2 gp_2_0_2 ctn_L1_10 0 NSYN W=10u L=1u
MpTa_L1_10_1 dpre_L2_4 gp_2_4_5 ctp_L1_10 0 NSYN W=10u L=1u
MnTb_L1_10_1 d1bar_L2 vcn ctp_L1_10 0 NSYN W=10u L=1u
MnTa_L1_10_1 dpre_L2_4 vcn ctn_L1_10 0 NSYN W=10u L=1u
MpTb_L1_10_1 d1bar_L2 gp_2_4_5 ctn_L1_10 0 NSYN W=10u L=1u
MpTa_L1_10_2 dpre_L2_9 gp_2_9_3 ctp_L1_10 0 NSYN W=10u L=1u
MnTb_L1_10_2 d1bar_L2 vcn ctp_L1_10 0 NSYN W=10u L=1u
MnTa_L1_10_2 dpre_L2_9 vcn ctn_L1_10 0 NSYN W=10u L=1u
MpTb_L1_10_2 d1bar_L2 gp_2_9_3 ctn_L1_10 0 NSYN W=10u L=1u
MpTa_L1_10_3 dpre_L2_10 gp_2_10_4 ctp_L1_10 0 NSYN W=10u L=1u
MnTb_L1_10_3 d1bar_L2 vcn ctp_L1_10 0 NSYN W=10u L=1u
MnTa_L1_10_3 dpre_L2_10 vcn ctn_L1_10 0 NSYN W=10u L=1u
MpTb_L1_10_3 d1bar_L2 gp_2_10_4 ctn_L1_10 0 NSYN W=10u L=1u
MpTa_L1_10_4 dpre_L2_11 gp_2_11_4 ctp_L1_10 0 NSYN W=10u L=1u
MnTb_L1_10_4 d1bar_L2 vcn ctp_L1_10 0 NSYN W=10u L=1u
MnTa_L1_10_4 dpre_L2_11 vcn ctn_L1_10 0 NSYN W=10u L=1u
MpTb_L1_10_4 d1bar_L2 gp_2_11_4 ctn_L1_10 0 NSYN W=10u L=1u
MpTa_L1_10_5 dpre_L2_13 gp_2_13_4 ctp_L1_10 0 NSYN W=10u L=1u
MnTb_L1_10_5 d1bar_L2 vcn ctp_L1_10 0 NSYN W=10u L=1u
MnTa_L1_10_5 dpre_L2_13 vcn ctn_L1_10 0 NSYN W=10u L=1u
MpTb_L1_10_5 d1bar_L2 gp_2_13_4 ctn_L1_10 0 NSYN W=10u L=1u
MpTa_L1_10_6 dpre_L2_14 gp_2_14_2 ctp_L1_10 0 NSYN W=10u L=1u
MnTb_L1_10_6 d1bar_L2 vcn ctp_L1_10 0 NSYN W=10u L=1u
MnTa_L1_10_6 dpre_L2_14 vcn ctn_L1_10 0 NSYN W=10u L=1u
MpTb_L1_10_6 d1bar_L2 gp_2_14_2 ctn_L1_10 0 NSYN W=10u L=1u
MpTa_L1_10_7 dpre_L2_17 gp_2_17_5 ctp_L1_10 0 NSYN W=10u L=1u
MnTb_L1_10_7 d1bar_L2 vcn ctp_L1_10 0 NSYN W=10u L=1u
MnTa_L1_10_7 dpre_L2_17 vcn ctn_L1_10 0 NSYN W=10u L=1u
MpTb_L1_10_7 d1bar_L2 gp_2_17_5 ctn_L1_10 0 NSYN W=10u L=1u
MpTa_L1_10_8 dpre_L2_19 gp_2_19_2 ctp_L1_10 0 NSYN W=10u L=1u
MnTb_L1_10_8 d1bar_L2 vcn ctp_L1_10 0 NSYN W=10u L=1u
MnTa_L1_10_8 dpre_L2_19 vcn ctn_L1_10 0 NSYN W=10u L=1u
MpTb_L1_10_8 d1bar_L2 gp_2_19_2 ctn_L1_10 0 NSYN W=10u L=1u
MpTa_L1_10_9 dpre_L2_20 gp_2_20_4 ctp_L1_10 0 NSYN W=10u L=1u
MnTb_L1_10_9 d1bar_L2 vcn ctp_L1_10 0 NSYN W=10u L=1u
MnTa_L1_10_9 dpre_L2_20 vcn ctn_L1_10 0 NSYN W=10u L=1u
MpTb_L1_10_9 d1bar_L2 gp_2_20_4 ctn_L1_10 0 NSYN W=10u L=1u
MpTa_L1_10_10 dpre_L2_26 gp_2_26_4 ctp_L1_10 0 NSYN W=10u L=1u
MnTb_L1_10_10 d1bar_L2 vcn ctp_L1_10 0 NSYN W=10u L=1u
MnTa_L1_10_10 dpre_L2_26 vcn ctn_L1_10 0 NSYN W=10u L=1u
MpTb_L1_10_10 d1bar_L2 gp_2_26_4 ctn_L1_10 0 NSYN W=10u L=1u
MpTa_L1_10_11 dpre_L2_30 gp_2_30_4 ctp_L1_10 0 NSYN W=10u L=1u
MnTb_L1_10_11 d1bar_L2 vcn ctp_L1_10 0 NSYN W=10u L=1u
MnTa_L1_10_11 dpre_L2_30 vcn ctn_L1_10 0 NSYN W=10u L=1u
MpTb_L1_10_11 d1bar_L2 gp_2_30_4 ctn_L1_10 0 NSYN W=10u L=1u
MpTa_L1_10_12 dpre_L2_36 gp_2_36_4 ctp_L1_10 0 NSYN W=10u L=1u
MnTb_L1_10_12 d1bar_L2 vcn ctp_L1_10 0 NSYN W=10u L=1u
MnTa_L1_10_12 dpre_L2_36 vcn ctn_L1_10 0 NSYN W=10u L=1u
MpTb_L1_10_12 d1bar_L2 gp_2_36_4 ctn_L1_10 0 NSYN W=10u L=1u
MpTa_L1_10_13 dpre_L2_40 gp_2_40_3 ctp_L1_10 0 NSYN W=10u L=1u
MnTb_L1_10_13 d1bar_L2 vcn ctp_L1_10 0 NSYN W=10u L=1u
MnTa_L1_10_13 dpre_L2_40 vcn ctn_L1_10 0 NSYN W=10u L=1u
MpTb_L1_10_13 d1bar_L2 gp_2_40_3 ctn_L1_10 0 NSYN W=10u L=1u
MpTa_L1_10_14 dpre_L2_45 gp_2_45_2 ctp_L1_10 0 NSYN W=10u L=1u
MnTb_L1_10_14 d1bar_L2 vcn ctp_L1_10 0 NSYN W=10u L=1u
MnTa_L1_10_14 dpre_L2_45 vcn ctn_L1_10 0 NSYN W=10u L=1u
MpTb_L1_10_14 d1bar_L2 gp_2_45_2 ctn_L1_10 0 NSYN W=10u L=1u
Msa_bk_L1_10 ctn_L1_10 ctn_L1_10 0 0 NMIR W=20u L=1u
Msb_bk_L1_10 dpre_L1_10 ctn_L1_10 0 0 NMIR W=20u L=1u
Msc_bk_L1_10 ctp_L1_10 ctp_L1_10 0 0 NMIR W=20u L=1u
Msd_bk_L1_10 dpf_bk_L1_10 ctp_L1_10 0 0 NMIR W=20u L=1u
Mse_bk_L1_10 dpf_bk_L1_10 dpf_bk_L1_10 vdd vdd PMIR W=60u L=1u
Msf_bk_L1_10 dpre_L1_10 dpf_bk_L1_10 vdd vdd PMIR W=60u L=1u
R_bk_L1_10 dpre_L1_10 vrefd 16000.0
MpTa_L1_11_0 dpre_L2_5 gp_2_5_2 ctp_L1_11 0 NSYN W=10u L=1u
MnTb_L1_11_0 d1bar_L2 vcn ctp_L1_11 0 NSYN W=10u L=1u
MnTa_L1_11_0 dpre_L2_5 vcn ctn_L1_11 0 NSYN W=10u L=1u
MpTb_L1_11_0 d1bar_L2 gp_2_5_2 ctn_L1_11 0 NSYN W=10u L=1u
MpTa_L1_11_1 dpre_L2_7 gp_2_7_4 ctp_L1_11 0 NSYN W=10u L=1u
MnTb_L1_11_1 d1bar_L2 vcn ctp_L1_11 0 NSYN W=10u L=1u
MnTa_L1_11_1 dpre_L2_7 vcn ctn_L1_11 0 NSYN W=10u L=1u
MpTb_L1_11_1 d1bar_L2 gp_2_7_4 ctn_L1_11 0 NSYN W=10u L=1u
MpTa_L1_11_2 dpre_L2_8 gp_2_8_2 ctp_L1_11 0 NSYN W=10u L=1u
MnTb_L1_11_2 d1bar_L2 vcn ctp_L1_11 0 NSYN W=10u L=1u
MnTa_L1_11_2 dpre_L2_8 vcn ctn_L1_11 0 NSYN W=10u L=1u
MpTb_L1_11_2 d1bar_L2 gp_2_8_2 ctn_L1_11 0 NSYN W=10u L=1u
MpTa_L1_11_3 dpre_L2_9 gp_2_9_4 ctp_L1_11 0 NSYN W=10u L=1u
MnTb_L1_11_3 d1bar_L2 vcn ctp_L1_11 0 NSYN W=10u L=1u
MnTa_L1_11_3 dpre_L2_9 vcn ctn_L1_11 0 NSYN W=10u L=1u
MpTb_L1_11_3 d1bar_L2 gp_2_9_4 ctn_L1_11 0 NSYN W=10u L=1u
MpTa_L1_11_4 dpre_L2_13 gp_2_13_5 ctp_L1_11 0 NSYN W=10u L=1u
MnTb_L1_11_4 d1bar_L2 vcn ctp_L1_11 0 NSYN W=10u L=1u
MnTa_L1_11_4 dpre_L2_13 vcn ctn_L1_11 0 NSYN W=10u L=1u
MpTb_L1_11_4 d1bar_L2 gp_2_13_5 ctn_L1_11 0 NSYN W=10u L=1u
MpTa_L1_11_5 dpre_L2_15 gp_2_15_4 ctp_L1_11 0 NSYN W=10u L=1u
MnTb_L1_11_5 d1bar_L2 vcn ctp_L1_11 0 NSYN W=10u L=1u
MnTa_L1_11_5 dpre_L2_15 vcn ctn_L1_11 0 NSYN W=10u L=1u
MpTb_L1_11_5 d1bar_L2 gp_2_15_4 ctn_L1_11 0 NSYN W=10u L=1u
MpTa_L1_11_6 dpre_L2_18 gp_2_18_3 ctp_L1_11 0 NSYN W=10u L=1u
MnTb_L1_11_6 d1bar_L2 vcn ctp_L1_11 0 NSYN W=10u L=1u
MnTa_L1_11_6 dpre_L2_18 vcn ctn_L1_11 0 NSYN W=10u L=1u
MpTb_L1_11_6 d1bar_L2 gp_2_18_3 ctn_L1_11 0 NSYN W=10u L=1u
MpTa_L1_11_7 dpre_L2_24 gp_2_24_4 ctp_L1_11 0 NSYN W=10u L=1u
MnTb_L1_11_7 d1bar_L2 vcn ctp_L1_11 0 NSYN W=10u L=1u
MnTa_L1_11_7 dpre_L2_24 vcn ctn_L1_11 0 NSYN W=10u L=1u
MpTb_L1_11_7 d1bar_L2 gp_2_24_4 ctn_L1_11 0 NSYN W=10u L=1u
MpTa_L1_11_8 dpre_L2_30 gp_2_30_5 ctp_L1_11 0 NSYN W=10u L=1u
MnTb_L1_11_8 d1bar_L2 vcn ctp_L1_11 0 NSYN W=10u L=1u
MnTa_L1_11_8 dpre_L2_30 vcn ctn_L1_11 0 NSYN W=10u L=1u
MpTb_L1_11_8 d1bar_L2 gp_2_30_5 ctn_L1_11 0 NSYN W=10u L=1u
MpTa_L1_11_9 dpre_L2_31 gp_2_31_4 ctp_L1_11 0 NSYN W=10u L=1u
MnTb_L1_11_9 d1bar_L2 vcn ctp_L1_11 0 NSYN W=10u L=1u
MnTa_L1_11_9 dpre_L2_31 vcn ctn_L1_11 0 NSYN W=10u L=1u
MpTb_L1_11_9 d1bar_L2 gp_2_31_4 ctn_L1_11 0 NSYN W=10u L=1u
MpTa_L1_11_10 dpre_L2_36 gp_2_36_5 ctp_L1_11 0 NSYN W=10u L=1u
MnTb_L1_11_10 d1bar_L2 vcn ctp_L1_11 0 NSYN W=10u L=1u
MnTa_L1_11_10 dpre_L2_36 vcn ctn_L1_11 0 NSYN W=10u L=1u
MpTb_L1_11_10 d1bar_L2 gp_2_36_5 ctn_L1_11 0 NSYN W=10u L=1u
MpTa_L1_11_11 dpre_L2_38 gp_2_38_2 ctp_L1_11 0 NSYN W=10u L=1u
MnTb_L1_11_11 d1bar_L2 vcn ctp_L1_11 0 NSYN W=10u L=1u
MnTa_L1_11_11 dpre_L2_38 vcn ctn_L1_11 0 NSYN W=10u L=1u
MpTb_L1_11_11 d1bar_L2 gp_2_38_2 ctn_L1_11 0 NSYN W=10u L=1u
MpTa_L1_11_12 dpre_L2_39 gp_2_39_3 ctp_L1_11 0 NSYN W=10u L=1u
MnTb_L1_11_12 d1bar_L2 vcn ctp_L1_11 0 NSYN W=10u L=1u
MnTa_L1_11_12 dpre_L2_39 vcn ctn_L1_11 0 NSYN W=10u L=1u
MpTb_L1_11_12 d1bar_L2 gp_2_39_3 ctn_L1_11 0 NSYN W=10u L=1u
MpTa_L1_11_13 dpre_L2_43 gp_2_43_4 ctp_L1_11 0 NSYN W=10u L=1u
MnTb_L1_11_13 d1bar_L2 vcn ctp_L1_11 0 NSYN W=10u L=1u
MnTa_L1_11_13 dpre_L2_43 vcn ctn_L1_11 0 NSYN W=10u L=1u
MpTb_L1_11_13 d1bar_L2 gp_2_43_4 ctn_L1_11 0 NSYN W=10u L=1u
MpTa_L1_11_14 dpre_L2_45 gp_2_45_3 ctp_L1_11 0 NSYN W=10u L=1u
MnTb_L1_11_14 d1bar_L2 vcn ctp_L1_11 0 NSYN W=10u L=1u
MnTa_L1_11_14 dpre_L2_45 vcn ctn_L1_11 0 NSYN W=10u L=1u
MpTb_L1_11_14 d1bar_L2 gp_2_45_3 ctn_L1_11 0 NSYN W=10u L=1u
Msa_bk_L1_11 ctn_L1_11 ctn_L1_11 0 0 NMIR W=20u L=1u
Msb_bk_L1_11 dpre_L1_11 ctn_L1_11 0 0 NMIR W=20u L=1u
Msc_bk_L1_11 ctp_L1_11 ctp_L1_11 0 0 NMIR W=20u L=1u
Msd_bk_L1_11 dpf_bk_L1_11 ctp_L1_11 0 0 NMIR W=20u L=1u
Mse_bk_L1_11 dpf_bk_L1_11 dpf_bk_L1_11 vdd vdd PMIR W=60u L=1u
Msf_bk_L1_11 dpre_L1_11 dpf_bk_L1_11 vdd vdd PMIR W=60u L=1u
R_bk_L1_11 dpre_L1_11 vrefd 16000.0
MpTa_L1_12_0 dpre_L2_0 gp_2_0_3 ctp_L1_12 0 NSYN W=10u L=1u
MnTb_L1_12_0 d1bar_L2 vcn ctp_L1_12 0 NSYN W=10u L=1u
MnTa_L1_12_0 dpre_L2_0 vcn ctn_L1_12 0 NSYN W=10u L=1u
MpTb_L1_12_0 d1bar_L2 gp_2_0_3 ctn_L1_12 0 NSYN W=10u L=1u
MpTa_L1_12_1 dpre_L2_5 gp_2_5_3 ctp_L1_12 0 NSYN W=10u L=1u
MnTb_L1_12_1 d1bar_L2 vcn ctp_L1_12 0 NSYN W=10u L=1u
MnTa_L1_12_1 dpre_L2_5 vcn ctn_L1_12 0 NSYN W=10u L=1u
MpTb_L1_12_1 d1bar_L2 gp_2_5_3 ctn_L1_12 0 NSYN W=10u L=1u
MpTa_L1_12_2 dpre_L2_9 gp_2_9_5 ctp_L1_12 0 NSYN W=10u L=1u
MnTb_L1_12_2 d1bar_L2 vcn ctp_L1_12 0 NSYN W=10u L=1u
MnTa_L1_12_2 dpre_L2_9 vcn ctn_L1_12 0 NSYN W=10u L=1u
MpTb_L1_12_2 d1bar_L2 gp_2_9_5 ctn_L1_12 0 NSYN W=10u L=1u
MpTa_L1_12_3 dpre_L2_10 gp_2_10_5 ctp_L1_12 0 NSYN W=10u L=1u
MnTb_L1_12_3 d1bar_L2 vcn ctp_L1_12 0 NSYN W=10u L=1u
MnTa_L1_12_3 dpre_L2_10 vcn ctn_L1_12 0 NSYN W=10u L=1u
MpTb_L1_12_3 d1bar_L2 gp_2_10_5 ctn_L1_12 0 NSYN W=10u L=1u
MpTa_L1_12_4 dpre_L2_13 gp_2_13_6 ctp_L1_12 0 NSYN W=10u L=1u
MnTb_L1_12_4 d1bar_L2 vcn ctp_L1_12 0 NSYN W=10u L=1u
MnTa_L1_12_4 dpre_L2_13 vcn ctn_L1_12 0 NSYN W=10u L=1u
MpTb_L1_12_4 d1bar_L2 gp_2_13_6 ctn_L1_12 0 NSYN W=10u L=1u
MpTa_L1_12_5 dpre_L2_17 gp_2_17_6 ctp_L1_12 0 NSYN W=10u L=1u
MnTb_L1_12_5 d1bar_L2 vcn ctp_L1_12 0 NSYN W=10u L=1u
MnTa_L1_12_5 dpre_L2_17 vcn ctn_L1_12 0 NSYN W=10u L=1u
MpTb_L1_12_5 d1bar_L2 gp_2_17_6 ctn_L1_12 0 NSYN W=10u L=1u
MpTa_L1_12_6 dpre_L2_19 gp_2_19_3 ctp_L1_12 0 NSYN W=10u L=1u
MnTb_L1_12_6 d1bar_L2 vcn ctp_L1_12 0 NSYN W=10u L=1u
MnTa_L1_12_6 dpre_L2_19 vcn ctn_L1_12 0 NSYN W=10u L=1u
MpTb_L1_12_6 d1bar_L2 gp_2_19_3 ctn_L1_12 0 NSYN W=10u L=1u
MpTa_L1_12_7 dpre_L2_21 gp_2_21_3 ctp_L1_12 0 NSYN W=10u L=1u
MnTb_L1_12_7 d1bar_L2 vcn ctp_L1_12 0 NSYN W=10u L=1u
MnTa_L1_12_7 dpre_L2_21 vcn ctn_L1_12 0 NSYN W=10u L=1u
MpTb_L1_12_7 d1bar_L2 gp_2_21_3 ctn_L1_12 0 NSYN W=10u L=1u
MpTa_L1_12_8 dpre_L2_23 gp_2_23_4 ctp_L1_12 0 NSYN W=10u L=1u
MnTb_L1_12_8 d1bar_L2 vcn ctp_L1_12 0 NSYN W=10u L=1u
MnTa_L1_12_8 dpre_L2_23 vcn ctn_L1_12 0 NSYN W=10u L=1u
MpTb_L1_12_8 d1bar_L2 gp_2_23_4 ctn_L1_12 0 NSYN W=10u L=1u
MpTa_L1_12_9 dpre_L2_24 gp_2_24_5 ctp_L1_12 0 NSYN W=10u L=1u
MnTb_L1_12_9 d1bar_L2 vcn ctp_L1_12 0 NSYN W=10u L=1u
MnTa_L1_12_9 dpre_L2_24 vcn ctn_L1_12 0 NSYN W=10u L=1u
MpTb_L1_12_9 d1bar_L2 gp_2_24_5 ctn_L1_12 0 NSYN W=10u L=1u
MpTa_L1_12_10 dpre_L2_25 gp_2_25_5 ctp_L1_12 0 NSYN W=10u L=1u
MnTb_L1_12_10 d1bar_L2 vcn ctp_L1_12 0 NSYN W=10u L=1u
MnTa_L1_12_10 dpre_L2_25 vcn ctn_L1_12 0 NSYN W=10u L=1u
MpTb_L1_12_10 d1bar_L2 gp_2_25_5 ctn_L1_12 0 NSYN W=10u L=1u
MpTa_L1_12_11 dpre_L2_28 gp_2_28_3 ctp_L1_12 0 NSYN W=10u L=1u
MnTb_L1_12_11 d1bar_L2 vcn ctp_L1_12 0 NSYN W=10u L=1u
MnTa_L1_12_11 dpre_L2_28 vcn ctn_L1_12 0 NSYN W=10u L=1u
MpTb_L1_12_11 d1bar_L2 gp_2_28_3 ctn_L1_12 0 NSYN W=10u L=1u
MpTa_L1_12_12 dpre_L2_29 gp_2_29_2 ctp_L1_12 0 NSYN W=10u L=1u
MnTb_L1_12_12 d1bar_L2 vcn ctp_L1_12 0 NSYN W=10u L=1u
MnTa_L1_12_12 dpre_L2_29 vcn ctn_L1_12 0 NSYN W=10u L=1u
MpTb_L1_12_12 d1bar_L2 gp_2_29_2 ctn_L1_12 0 NSYN W=10u L=1u
MpTa_L1_12_13 dpre_L2_30 gp_2_30_6 ctp_L1_12 0 NSYN W=10u L=1u
MnTb_L1_12_13 d1bar_L2 vcn ctp_L1_12 0 NSYN W=10u L=1u
MnTa_L1_12_13 dpre_L2_30 vcn ctn_L1_12 0 NSYN W=10u L=1u
MpTb_L1_12_13 d1bar_L2 gp_2_30_6 ctn_L1_12 0 NSYN W=10u L=1u
MpTa_L1_12_14 dpre_L2_31 gp_2_31_5 ctp_L1_12 0 NSYN W=10u L=1u
MnTb_L1_12_14 d1bar_L2 vcn ctp_L1_12 0 NSYN W=10u L=1u
MnTa_L1_12_14 dpre_L2_31 vcn ctn_L1_12 0 NSYN W=10u L=1u
MpTb_L1_12_14 d1bar_L2 gp_2_31_5 ctn_L1_12 0 NSYN W=10u L=1u
MpTa_L1_12_15 dpre_L2_33 gp_2_33_3 ctp_L1_12 0 NSYN W=10u L=1u
MnTb_L1_12_15 d1bar_L2 vcn ctp_L1_12 0 NSYN W=10u L=1u
MnTa_L1_12_15 dpre_L2_33 vcn ctn_L1_12 0 NSYN W=10u L=1u
MpTb_L1_12_15 d1bar_L2 gp_2_33_3 ctn_L1_12 0 NSYN W=10u L=1u
MpTa_L1_12_16 dpre_L2_35 gp_2_35_3 ctp_L1_12 0 NSYN W=10u L=1u
MnTb_L1_12_16 d1bar_L2 vcn ctp_L1_12 0 NSYN W=10u L=1u
MnTa_L1_12_16 dpre_L2_35 vcn ctn_L1_12 0 NSYN W=10u L=1u
MpTb_L1_12_16 d1bar_L2 gp_2_35_3 ctn_L1_12 0 NSYN W=10u L=1u
MpTa_L1_12_17 dpre_L2_37 gp_2_37_3 ctp_L1_12 0 NSYN W=10u L=1u
MnTb_L1_12_17 d1bar_L2 vcn ctp_L1_12 0 NSYN W=10u L=1u
MnTa_L1_12_17 dpre_L2_37 vcn ctn_L1_12 0 NSYN W=10u L=1u
MpTb_L1_12_17 d1bar_L2 gp_2_37_3 ctn_L1_12 0 NSYN W=10u L=1u
MpTa_L1_12_18 dpre_L2_42 gp_2_42_4 ctp_L1_12 0 NSYN W=10u L=1u
MnTb_L1_12_18 d1bar_L2 vcn ctp_L1_12 0 NSYN W=10u L=1u
MnTa_L1_12_18 dpre_L2_42 vcn ctn_L1_12 0 NSYN W=10u L=1u
MpTb_L1_12_18 d1bar_L2 gp_2_42_4 ctn_L1_12 0 NSYN W=10u L=1u
MpTa_L1_12_19 dpre_L2_43 gp_2_43_5 ctp_L1_12 0 NSYN W=10u L=1u
MnTb_L1_12_19 d1bar_L2 vcn ctp_L1_12 0 NSYN W=10u L=1u
MnTa_L1_12_19 dpre_L2_43 vcn ctn_L1_12 0 NSYN W=10u L=1u
MpTb_L1_12_19 d1bar_L2 gp_2_43_5 ctn_L1_12 0 NSYN W=10u L=1u
MpTa_L1_12_20 dpre_L2_45 gp_2_45_4 ctp_L1_12 0 NSYN W=10u L=1u
MnTb_L1_12_20 d1bar_L2 vcn ctp_L1_12 0 NSYN W=10u L=1u
MnTa_L1_12_20 dpre_L2_45 vcn ctn_L1_12 0 NSYN W=10u L=1u
MpTb_L1_12_20 d1bar_L2 gp_2_45_4 ctn_L1_12 0 NSYN W=10u L=1u
Msa_bk_L1_12 ctn_L1_12 ctn_L1_12 0 0 NMIR W=20u L=1u
Msb_bk_L1_12 dpre_L1_12 ctn_L1_12 0 0 NMIR W=20u L=1u
Msc_bk_L1_12 ctp_L1_12 ctp_L1_12 0 0 NMIR W=20u L=1u
Msd_bk_L1_12 dpf_bk_L1_12 ctp_L1_12 0 0 NMIR W=20u L=1u
Mse_bk_L1_12 dpf_bk_L1_12 dpf_bk_L1_12 vdd vdd PMIR W=60u L=1u
Msf_bk_L1_12 dpre_L1_12 dpf_bk_L1_12 vdd vdd PMIR W=60u L=1u
R_bk_L1_12 dpre_L1_12 vrefd 16000.0
MpTa_L1_13_0 dpre_L2_1 gp_2_1_2 ctp_L1_13 0 NSYN W=10u L=1u
MnTb_L1_13_0 d1bar_L2 vcn ctp_L1_13 0 NSYN W=10u L=1u
MnTa_L1_13_0 dpre_L2_1 vcn ctn_L1_13 0 NSYN W=10u L=1u
MpTb_L1_13_0 d1bar_L2 gp_2_1_2 ctn_L1_13 0 NSYN W=10u L=1u
MpTa_L1_13_1 dpre_L2_3 gp_2_3_4 ctp_L1_13 0 NSYN W=10u L=1u
MnTb_L1_13_1 d1bar_L2 vcn ctp_L1_13 0 NSYN W=10u L=1u
MnTa_L1_13_1 dpre_L2_3 vcn ctn_L1_13 0 NSYN W=10u L=1u
MpTb_L1_13_1 d1bar_L2 gp_2_3_4 ctn_L1_13 0 NSYN W=10u L=1u
MpTa_L1_13_2 dpre_L2_4 gp_2_4_6 ctp_L1_13 0 NSYN W=10u L=1u
MnTb_L1_13_2 d1bar_L2 vcn ctp_L1_13 0 NSYN W=10u L=1u
MnTa_L1_13_2 dpre_L2_4 vcn ctn_L1_13 0 NSYN W=10u L=1u
MpTb_L1_13_2 d1bar_L2 gp_2_4_6 ctn_L1_13 0 NSYN W=10u L=1u
MpTa_L1_13_3 dpre_L2_6 gp_2_6_3 ctp_L1_13 0 NSYN W=10u L=1u
MnTb_L1_13_3 d1bar_L2 vcn ctp_L1_13 0 NSYN W=10u L=1u
MnTa_L1_13_3 dpre_L2_6 vcn ctn_L1_13 0 NSYN W=10u L=1u
MpTb_L1_13_3 d1bar_L2 gp_2_6_3 ctn_L1_13 0 NSYN W=10u L=1u
MpTa_L1_13_4 dpre_L2_7 gp_2_7_5 ctp_L1_13 0 NSYN W=10u L=1u
MnTb_L1_13_4 d1bar_L2 vcn ctp_L1_13 0 NSYN W=10u L=1u
MnTa_L1_13_4 dpre_L2_7 vcn ctn_L1_13 0 NSYN W=10u L=1u
MpTb_L1_13_4 d1bar_L2 gp_2_7_5 ctn_L1_13 0 NSYN W=10u L=1u
MpTa_L1_13_5 dpre_L2_8 gp_2_8_3 ctp_L1_13 0 NSYN W=10u L=1u
MnTb_L1_13_5 d1bar_L2 vcn ctp_L1_13 0 NSYN W=10u L=1u
MnTa_L1_13_5 dpre_L2_8 vcn ctn_L1_13 0 NSYN W=10u L=1u
MpTb_L1_13_5 d1bar_L2 gp_2_8_3 ctn_L1_13 0 NSYN W=10u L=1u
MpTa_L1_13_6 dpre_L2_10 gp_2_10_6 ctp_L1_13 0 NSYN W=10u L=1u
MnTb_L1_13_6 d1bar_L2 vcn ctp_L1_13 0 NSYN W=10u L=1u
MnTa_L1_13_6 dpre_L2_10 vcn ctn_L1_13 0 NSYN W=10u L=1u
MpTb_L1_13_6 d1bar_L2 gp_2_10_6 ctn_L1_13 0 NSYN W=10u L=1u
MpTa_L1_13_7 dpre_L2_11 gp_2_11_5 ctp_L1_13 0 NSYN W=10u L=1u
MnTb_L1_13_7 d1bar_L2 vcn ctp_L1_13 0 NSYN W=10u L=1u
MnTa_L1_13_7 dpre_L2_11 vcn ctn_L1_13 0 NSYN W=10u L=1u
MpTb_L1_13_7 d1bar_L2 gp_2_11_5 ctn_L1_13 0 NSYN W=10u L=1u
MpTa_L1_13_8 dpre_L2_12 gp_2_12_4 ctp_L1_13 0 NSYN W=10u L=1u
MnTb_L1_13_8 d1bar_L2 vcn ctp_L1_13 0 NSYN W=10u L=1u
MnTa_L1_13_8 dpre_L2_12 vcn ctn_L1_13 0 NSYN W=10u L=1u
MpTb_L1_13_8 d1bar_L2 gp_2_12_4 ctn_L1_13 0 NSYN W=10u L=1u
MpTa_L1_13_9 dpre_L2_17 gp_2_17_7 ctp_L1_13 0 NSYN W=10u L=1u
MnTb_L1_13_9 d1bar_L2 vcn ctp_L1_13 0 NSYN W=10u L=1u
MnTa_L1_13_9 dpre_L2_17 vcn ctn_L1_13 0 NSYN W=10u L=1u
MpTb_L1_13_9 d1bar_L2 gp_2_17_7 ctn_L1_13 0 NSYN W=10u L=1u
MpTa_L1_13_10 dpre_L2_19 gp_2_19_4 ctp_L1_13 0 NSYN W=10u L=1u
MnTb_L1_13_10 d1bar_L2 vcn ctp_L1_13 0 NSYN W=10u L=1u
MnTa_L1_13_10 dpre_L2_19 vcn ctn_L1_13 0 NSYN W=10u L=1u
MpTb_L1_13_10 d1bar_L2 gp_2_19_4 ctn_L1_13 0 NSYN W=10u L=1u
MpTa_L1_13_11 dpre_L2_20 gp_2_20_5 ctp_L1_13 0 NSYN W=10u L=1u
MnTb_L1_13_11 d1bar_L2 vcn ctp_L1_13 0 NSYN W=10u L=1u
MnTa_L1_13_11 dpre_L2_20 vcn ctn_L1_13 0 NSYN W=10u L=1u
MpTb_L1_13_11 d1bar_L2 gp_2_20_5 ctn_L1_13 0 NSYN W=10u L=1u
MpTa_L1_13_12 dpre_L2_28 gp_2_28_4 ctp_L1_13 0 NSYN W=10u L=1u
MnTb_L1_13_12 d1bar_L2 vcn ctp_L1_13 0 NSYN W=10u L=1u
MnTa_L1_13_12 dpre_L2_28 vcn ctn_L1_13 0 NSYN W=10u L=1u
MpTb_L1_13_12 d1bar_L2 gp_2_28_4 ctn_L1_13 0 NSYN W=10u L=1u
MpTa_L1_13_13 dpre_L2_31 gp_2_31_6 ctp_L1_13 0 NSYN W=10u L=1u
MnTb_L1_13_13 d1bar_L2 vcn ctp_L1_13 0 NSYN W=10u L=1u
MnTa_L1_13_13 dpre_L2_31 vcn ctn_L1_13 0 NSYN W=10u L=1u
MpTb_L1_13_13 d1bar_L2 gp_2_31_6 ctn_L1_13 0 NSYN W=10u L=1u
MpTa_L1_13_14 dpre_L2_32 gp_2_32_3 ctp_L1_13 0 NSYN W=10u L=1u
MnTb_L1_13_14 d1bar_L2 vcn ctp_L1_13 0 NSYN W=10u L=1u
MnTa_L1_13_14 dpre_L2_32 vcn ctn_L1_13 0 NSYN W=10u L=1u
MpTb_L1_13_14 d1bar_L2 gp_2_32_3 ctn_L1_13 0 NSYN W=10u L=1u
MpTa_L1_13_15 dpre_L2_33 gp_2_33_4 ctp_L1_13 0 NSYN W=10u L=1u
MnTb_L1_13_15 d1bar_L2 vcn ctp_L1_13 0 NSYN W=10u L=1u
MnTa_L1_13_15 dpre_L2_33 vcn ctn_L1_13 0 NSYN W=10u L=1u
MpTb_L1_13_15 d1bar_L2 gp_2_33_4 ctn_L1_13 0 NSYN W=10u L=1u
MpTa_L1_13_16 dpre_L2_38 gp_2_38_3 ctp_L1_13 0 NSYN W=10u L=1u
MnTb_L1_13_16 d1bar_L2 vcn ctp_L1_13 0 NSYN W=10u L=1u
MnTa_L1_13_16 dpre_L2_38 vcn ctn_L1_13 0 NSYN W=10u L=1u
MpTb_L1_13_16 d1bar_L2 gp_2_38_3 ctn_L1_13 0 NSYN W=10u L=1u
MpTa_L1_13_17 dpre_L2_39 gp_2_39_4 ctp_L1_13 0 NSYN W=10u L=1u
MnTb_L1_13_17 d1bar_L2 vcn ctp_L1_13 0 NSYN W=10u L=1u
MnTa_L1_13_17 dpre_L2_39 vcn ctn_L1_13 0 NSYN W=10u L=1u
MpTb_L1_13_17 d1bar_L2 gp_2_39_4 ctn_L1_13 0 NSYN W=10u L=1u
MpTa_L1_13_18 dpre_L2_42 gp_2_42_5 ctp_L1_13 0 NSYN W=10u L=1u
MnTb_L1_13_18 d1bar_L2 vcn ctp_L1_13 0 NSYN W=10u L=1u
MnTa_L1_13_18 dpre_L2_42 vcn ctn_L1_13 0 NSYN W=10u L=1u
MpTb_L1_13_18 d1bar_L2 gp_2_42_5 ctn_L1_13 0 NSYN W=10u L=1u
MpTa_L1_13_19 dpre_L2_45 gp_2_45_5 ctp_L1_13 0 NSYN W=10u L=1u
MnTb_L1_13_19 d1bar_L2 vcn ctp_L1_13 0 NSYN W=10u L=1u
MnTa_L1_13_19 dpre_L2_45 vcn ctn_L1_13 0 NSYN W=10u L=1u
MpTb_L1_13_19 d1bar_L2 gp_2_45_5 ctn_L1_13 0 NSYN W=10u L=1u
Msa_bk_L1_13 ctn_L1_13 ctn_L1_13 0 0 NMIR W=20u L=1u
Msb_bk_L1_13 dpre_L1_13 ctn_L1_13 0 0 NMIR W=20u L=1u
Msc_bk_L1_13 ctp_L1_13 ctp_L1_13 0 0 NMIR W=20u L=1u
Msd_bk_L1_13 dpf_bk_L1_13 ctp_L1_13 0 0 NMIR W=20u L=1u
Mse_bk_L1_13 dpf_bk_L1_13 dpf_bk_L1_13 vdd vdd PMIR W=60u L=1u
Msf_bk_L1_13 dpre_L1_13 dpf_bk_L1_13 vdd vdd PMIR W=60u L=1u
R_bk_L1_13 dpre_L1_13 vrefd 16000.0
MpTa_L1_14_0 dpre_L2_1 gp_2_1_3 ctp_L1_14 0 NSYN W=10u L=1u
MnTb_L1_14_0 d1bar_L2 vcn ctp_L1_14 0 NSYN W=10u L=1u
MnTa_L1_14_0 dpre_L2_1 vcn ctn_L1_14 0 NSYN W=10u L=1u
MpTb_L1_14_0 d1bar_L2 gp_2_1_3 ctn_L1_14 0 NSYN W=10u L=1u
MpTa_L1_14_1 dpre_L2_2 gp_2_2_4 ctp_L1_14 0 NSYN W=10u L=1u
MnTb_L1_14_1 d1bar_L2 vcn ctp_L1_14 0 NSYN W=10u L=1u
MnTa_L1_14_1 dpre_L2_2 vcn ctn_L1_14 0 NSYN W=10u L=1u
MpTb_L1_14_1 d1bar_L2 gp_2_2_4 ctn_L1_14 0 NSYN W=10u L=1u
MpTa_L1_14_2 dpre_L2_3 gp_2_3_5 ctp_L1_14 0 NSYN W=10u L=1u
MnTb_L1_14_2 d1bar_L2 vcn ctp_L1_14 0 NSYN W=10u L=1u
MnTa_L1_14_2 dpre_L2_3 vcn ctn_L1_14 0 NSYN W=10u L=1u
MpTb_L1_14_2 d1bar_L2 gp_2_3_5 ctn_L1_14 0 NSYN W=10u L=1u
MpTa_L1_14_3 dpre_L2_6 gp_2_6_4 ctp_L1_14 0 NSYN W=10u L=1u
MnTb_L1_14_3 d1bar_L2 vcn ctp_L1_14 0 NSYN W=10u L=1u
MnTa_L1_14_3 dpre_L2_6 vcn ctn_L1_14 0 NSYN W=10u L=1u
MpTb_L1_14_3 d1bar_L2 gp_2_6_4 ctn_L1_14 0 NSYN W=10u L=1u
MpTa_L1_14_4 dpre_L2_7 gp_2_7_6 ctp_L1_14 0 NSYN W=10u L=1u
MnTb_L1_14_4 d1bar_L2 vcn ctp_L1_14 0 NSYN W=10u L=1u
MnTa_L1_14_4 dpre_L2_7 vcn ctn_L1_14 0 NSYN W=10u L=1u
MpTb_L1_14_4 d1bar_L2 gp_2_7_6 ctn_L1_14 0 NSYN W=10u L=1u
MpTa_L1_14_5 dpre_L2_10 gp_2_10_7 ctp_L1_14 0 NSYN W=10u L=1u
MnTb_L1_14_5 d1bar_L2 vcn ctp_L1_14 0 NSYN W=10u L=1u
MnTa_L1_14_5 dpre_L2_10 vcn ctn_L1_14 0 NSYN W=10u L=1u
MpTb_L1_14_5 d1bar_L2 gp_2_10_7 ctn_L1_14 0 NSYN W=10u L=1u
MpTa_L1_14_6 dpre_L2_14 gp_2_14_3 ctp_L1_14 0 NSYN W=10u L=1u
MnTb_L1_14_6 d1bar_L2 vcn ctp_L1_14 0 NSYN W=10u L=1u
MnTa_L1_14_6 dpre_L2_14 vcn ctn_L1_14 0 NSYN W=10u L=1u
MpTb_L1_14_6 d1bar_L2 gp_2_14_3 ctn_L1_14 0 NSYN W=10u L=1u
MpTa_L1_14_7 dpre_L2_18 gp_2_18_4 ctp_L1_14 0 NSYN W=10u L=1u
MnTb_L1_14_7 d1bar_L2 vcn ctp_L1_14 0 NSYN W=10u L=1u
MnTa_L1_14_7 dpre_L2_18 vcn ctn_L1_14 0 NSYN W=10u L=1u
MpTb_L1_14_7 d1bar_L2 gp_2_18_4 ctn_L1_14 0 NSYN W=10u L=1u
MpTa_L1_14_8 dpre_L2_19 gp_2_19_5 ctp_L1_14 0 NSYN W=10u L=1u
MnTb_L1_14_8 d1bar_L2 vcn ctp_L1_14 0 NSYN W=10u L=1u
MnTa_L1_14_8 dpre_L2_19 vcn ctn_L1_14 0 NSYN W=10u L=1u
MpTb_L1_14_8 d1bar_L2 gp_2_19_5 ctn_L1_14 0 NSYN W=10u L=1u
MpTa_L1_14_9 dpre_L2_21 gp_2_21_4 ctp_L1_14 0 NSYN W=10u L=1u
MnTb_L1_14_9 d1bar_L2 vcn ctp_L1_14 0 NSYN W=10u L=1u
MnTa_L1_14_9 dpre_L2_21 vcn ctn_L1_14 0 NSYN W=10u L=1u
MpTb_L1_14_9 d1bar_L2 gp_2_21_4 ctn_L1_14 0 NSYN W=10u L=1u
MpTa_L1_14_10 dpre_L2_34 gp_2_34_5 ctp_L1_14 0 NSYN W=10u L=1u
MnTb_L1_14_10 d1bar_L2 vcn ctp_L1_14 0 NSYN W=10u L=1u
MnTa_L1_14_10 dpre_L2_34 vcn ctn_L1_14 0 NSYN W=10u L=1u
MpTb_L1_14_10 d1bar_L2 gp_2_34_5 ctn_L1_14 0 NSYN W=10u L=1u
MpTa_L1_14_11 dpre_L2_39 gp_2_39_5 ctp_L1_14 0 NSYN W=10u L=1u
MnTb_L1_14_11 d1bar_L2 vcn ctp_L1_14 0 NSYN W=10u L=1u
MnTa_L1_14_11 dpre_L2_39 vcn ctn_L1_14 0 NSYN W=10u L=1u
MpTb_L1_14_11 d1bar_L2 gp_2_39_5 ctn_L1_14 0 NSYN W=10u L=1u
MpTa_L1_14_12 dpre_L2_44 gp_2_44_3 ctp_L1_14 0 NSYN W=10u L=1u
MnTb_L1_14_12 d1bar_L2 vcn ctp_L1_14 0 NSYN W=10u L=1u
MnTa_L1_14_12 dpre_L2_44 vcn ctn_L1_14 0 NSYN W=10u L=1u
MpTb_L1_14_12 d1bar_L2 gp_2_44_3 ctn_L1_14 0 NSYN W=10u L=1u
MpTa_L1_14_13 dpre_L2_45 gp_2_45_6 ctp_L1_14 0 NSYN W=10u L=1u
MnTb_L1_14_13 d1bar_L2 vcn ctp_L1_14 0 NSYN W=10u L=1u
MnTa_L1_14_13 dpre_L2_45 vcn ctn_L1_14 0 NSYN W=10u L=1u
MpTb_L1_14_13 d1bar_L2 gp_2_45_6 ctn_L1_14 0 NSYN W=10u L=1u
Msa_bk_L1_14 ctn_L1_14 ctn_L1_14 0 0 NMIR W=20u L=1u
Msb_bk_L1_14 dpre_L1_14 ctn_L1_14 0 0 NMIR W=20u L=1u
Msc_bk_L1_14 ctp_L1_14 ctp_L1_14 0 0 NMIR W=20u L=1u
Msd_bk_L1_14 dpf_bk_L1_14 ctp_L1_14 0 0 NMIR W=20u L=1u
Mse_bk_L1_14 dpf_bk_L1_14 dpf_bk_L1_14 vdd vdd PMIR W=60u L=1u
Msf_bk_L1_14 dpre_L1_14 dpf_bk_L1_14 vdd vdd PMIR W=60u L=1u
R_bk_L1_14 dpre_L1_14 vrefd 16000.0
MpTa_L1_15_0 dpre_L2_0 gp_2_0_4 ctp_L1_15 0 NSYN W=10u L=1u
MnTb_L1_15_0 d1bar_L2 vcn ctp_L1_15 0 NSYN W=10u L=1u
MnTa_L1_15_0 dpre_L2_0 vcn ctn_L1_15 0 NSYN W=10u L=1u
MpTb_L1_15_0 d1bar_L2 gp_2_0_4 ctn_L1_15 0 NSYN W=10u L=1u
MpTa_L1_15_1 dpre_L2_7 gp_2_7_7 ctp_L1_15 0 NSYN W=10u L=1u
MnTb_L1_15_1 d1bar_L2 vcn ctp_L1_15 0 NSYN W=10u L=1u
MnTa_L1_15_1 dpre_L2_7 vcn ctn_L1_15 0 NSYN W=10u L=1u
MpTb_L1_15_1 d1bar_L2 gp_2_7_7 ctn_L1_15 0 NSYN W=10u L=1u
MpTa_L1_15_2 dpre_L2_8 gp_2_8_4 ctp_L1_15 0 NSYN W=10u L=1u
MnTb_L1_15_2 d1bar_L2 vcn ctp_L1_15 0 NSYN W=10u L=1u
MnTa_L1_15_2 dpre_L2_8 vcn ctn_L1_15 0 NSYN W=10u L=1u
MpTb_L1_15_2 d1bar_L2 gp_2_8_4 ctn_L1_15 0 NSYN W=10u L=1u
MpTa_L1_15_3 dpre_L2_11 gp_2_11_6 ctp_L1_15 0 NSYN W=10u L=1u
MnTb_L1_15_3 d1bar_L2 vcn ctp_L1_15 0 NSYN W=10u L=1u
MnTa_L1_15_3 dpre_L2_11 vcn ctn_L1_15 0 NSYN W=10u L=1u
MpTb_L1_15_3 d1bar_L2 gp_2_11_6 ctn_L1_15 0 NSYN W=10u L=1u
MpTa_L1_15_4 dpre_L2_17 gp_2_17_8 ctp_L1_15 0 NSYN W=10u L=1u
MnTb_L1_15_4 d1bar_L2 vcn ctp_L1_15 0 NSYN W=10u L=1u
MnTa_L1_15_4 dpre_L2_17 vcn ctn_L1_15 0 NSYN W=10u L=1u
MpTb_L1_15_4 d1bar_L2 gp_2_17_8 ctn_L1_15 0 NSYN W=10u L=1u
MpTa_L1_15_5 dpre_L2_23 gp_2_23_5 ctp_L1_15 0 NSYN W=10u L=1u
MnTb_L1_15_5 d1bar_L2 vcn ctp_L1_15 0 NSYN W=10u L=1u
MnTa_L1_15_5 dpre_L2_23 vcn ctn_L1_15 0 NSYN W=10u L=1u
MpTb_L1_15_5 d1bar_L2 gp_2_23_5 ctn_L1_15 0 NSYN W=10u L=1u
MpTa_L1_15_6 dpre_L2_26 gp_2_26_5 ctp_L1_15 0 NSYN W=10u L=1u
MnTb_L1_15_6 d1bar_L2 vcn ctp_L1_15 0 NSYN W=10u L=1u
MnTa_L1_15_6 dpre_L2_26 vcn ctn_L1_15 0 NSYN W=10u L=1u
MpTb_L1_15_6 d1bar_L2 gp_2_26_5 ctn_L1_15 0 NSYN W=10u L=1u
MpTa_L1_15_7 dpre_L2_27 gp_2_27_4 ctp_L1_15 0 NSYN W=10u L=1u
MnTb_L1_15_7 d1bar_L2 vcn ctp_L1_15 0 NSYN W=10u L=1u
MnTa_L1_15_7 dpre_L2_27 vcn ctn_L1_15 0 NSYN W=10u L=1u
MpTb_L1_15_7 d1bar_L2 gp_2_27_4 ctn_L1_15 0 NSYN W=10u L=1u
MpTa_L1_15_8 dpre_L2_28 gp_2_28_5 ctp_L1_15 0 NSYN W=10u L=1u
MnTb_L1_15_8 d1bar_L2 vcn ctp_L1_15 0 NSYN W=10u L=1u
MnTa_L1_15_8 dpre_L2_28 vcn ctn_L1_15 0 NSYN W=10u L=1u
MpTb_L1_15_8 d1bar_L2 gp_2_28_5 ctn_L1_15 0 NSYN W=10u L=1u
MpTa_L1_15_9 dpre_L2_32 gp_2_32_4 ctp_L1_15 0 NSYN W=10u L=1u
MnTb_L1_15_9 d1bar_L2 vcn ctp_L1_15 0 NSYN W=10u L=1u
MnTa_L1_15_9 dpre_L2_32 vcn ctn_L1_15 0 NSYN W=10u L=1u
MpTb_L1_15_9 d1bar_L2 gp_2_32_4 ctn_L1_15 0 NSYN W=10u L=1u
MpTa_L1_15_10 dpre_L2_37 gp_2_37_4 ctp_L1_15 0 NSYN W=10u L=1u
MnTb_L1_15_10 d1bar_L2 vcn ctp_L1_15 0 NSYN W=10u L=1u
MnTa_L1_15_10 dpre_L2_37 vcn ctn_L1_15 0 NSYN W=10u L=1u
MpTb_L1_15_10 d1bar_L2 gp_2_37_4 ctn_L1_15 0 NSYN W=10u L=1u
MpTa_L1_15_11 dpre_L2_42 gp_2_42_6 ctp_L1_15 0 NSYN W=10u L=1u
MnTb_L1_15_11 d1bar_L2 vcn ctp_L1_15 0 NSYN W=10u L=1u
MnTa_L1_15_11 dpre_L2_42 vcn ctn_L1_15 0 NSYN W=10u L=1u
MpTb_L1_15_11 d1bar_L2 gp_2_42_6 ctn_L1_15 0 NSYN W=10u L=1u
MpTa_L1_15_12 dpre_L2_43 gp_2_43_6 ctp_L1_15 0 NSYN W=10u L=1u
MnTb_L1_15_12 d1bar_L2 vcn ctp_L1_15 0 NSYN W=10u L=1u
MnTa_L1_15_12 dpre_L2_43 vcn ctn_L1_15 0 NSYN W=10u L=1u
MpTb_L1_15_12 d1bar_L2 gp_2_43_6 ctn_L1_15 0 NSYN W=10u L=1u
MpTa_L1_15_13 dpre_L2_44 gp_2_44_4 ctp_L1_15 0 NSYN W=10u L=1u
MnTb_L1_15_13 d1bar_L2 vcn ctp_L1_15 0 NSYN W=10u L=1u
MnTa_L1_15_13 dpre_L2_44 vcn ctn_L1_15 0 NSYN W=10u L=1u
MpTb_L1_15_13 d1bar_L2 gp_2_44_4 ctn_L1_15 0 NSYN W=10u L=1u
Msa_bk_L1_15 ctn_L1_15 ctn_L1_15 0 0 NMIR W=20u L=1u
Msb_bk_L1_15 dpre_L1_15 ctn_L1_15 0 0 NMIR W=20u L=1u
Msc_bk_L1_15 ctp_L1_15 ctp_L1_15 0 0 NMIR W=20u L=1u
Msd_bk_L1_15 dpf_bk_L1_15 ctp_L1_15 0 0 NMIR W=20u L=1u
Mse_bk_L1_15 dpf_bk_L1_15 dpf_bk_L1_15 vdd vdd PMIR W=60u L=1u
Msf_bk_L1_15 dpre_L1_15 dpf_bk_L1_15 vdd vdd PMIR W=60u L=1u
R_bk_L1_15 dpre_L1_15 vrefd 16000.0
MpTa_L1_16_0 dpre_L2_1 gp_2_1_4 ctp_L1_16 0 NSYN W=10u L=1u
MnTb_L1_16_0 d1bar_L2 vcn ctp_L1_16 0 NSYN W=10u L=1u
MnTa_L1_16_0 dpre_L2_1 vcn ctn_L1_16 0 NSYN W=10u L=1u
MpTb_L1_16_0 d1bar_L2 gp_2_1_4 ctn_L1_16 0 NSYN W=10u L=1u
MpTa_L1_16_1 dpre_L2_6 gp_2_6_5 ctp_L1_16 0 NSYN W=10u L=1u
MnTb_L1_16_1 d1bar_L2 vcn ctp_L1_16 0 NSYN W=10u L=1u
MnTa_L1_16_1 dpre_L2_6 vcn ctn_L1_16 0 NSYN W=10u L=1u
MpTb_L1_16_1 d1bar_L2 gp_2_6_5 ctn_L1_16 0 NSYN W=10u L=1u
MpTa_L1_16_2 dpre_L2_7 gp_2_7_8 ctp_L1_16 0 NSYN W=10u L=1u
MnTb_L1_16_2 d1bar_L2 vcn ctp_L1_16 0 NSYN W=10u L=1u
MnTa_L1_16_2 dpre_L2_7 vcn ctn_L1_16 0 NSYN W=10u L=1u
MpTb_L1_16_2 d1bar_L2 gp_2_7_8 ctn_L1_16 0 NSYN W=10u L=1u
MpTa_L1_16_3 dpre_L2_8 gp_2_8_5 ctp_L1_16 0 NSYN W=10u L=1u
MnTb_L1_16_3 d1bar_L2 vcn ctp_L1_16 0 NSYN W=10u L=1u
MnTa_L1_16_3 dpre_L2_8 vcn ctn_L1_16 0 NSYN W=10u L=1u
MpTb_L1_16_3 d1bar_L2 gp_2_8_5 ctn_L1_16 0 NSYN W=10u L=1u
MpTa_L1_16_4 dpre_L2_9 gp_2_9_6 ctp_L1_16 0 NSYN W=10u L=1u
MnTb_L1_16_4 d1bar_L2 vcn ctp_L1_16 0 NSYN W=10u L=1u
MnTa_L1_16_4 dpre_L2_9 vcn ctn_L1_16 0 NSYN W=10u L=1u
MpTb_L1_16_4 d1bar_L2 gp_2_9_6 ctn_L1_16 0 NSYN W=10u L=1u
MpTa_L1_16_5 dpre_L2_11 gp_2_11_7 ctp_L1_16 0 NSYN W=10u L=1u
MnTb_L1_16_5 d1bar_L2 vcn ctp_L1_16 0 NSYN W=10u L=1u
MnTa_L1_16_5 dpre_L2_11 vcn ctn_L1_16 0 NSYN W=10u L=1u
MpTb_L1_16_5 d1bar_L2 gp_2_11_7 ctn_L1_16 0 NSYN W=10u L=1u
MpTa_L1_16_6 dpre_L2_14 gp_2_14_4 ctp_L1_16 0 NSYN W=10u L=1u
MnTb_L1_16_6 d1bar_L2 vcn ctp_L1_16 0 NSYN W=10u L=1u
MnTa_L1_16_6 dpre_L2_14 vcn ctn_L1_16 0 NSYN W=10u L=1u
MpTb_L1_16_6 d1bar_L2 gp_2_14_4 ctn_L1_16 0 NSYN W=10u L=1u
MpTa_L1_16_7 dpre_L2_15 gp_2_15_5 ctp_L1_16 0 NSYN W=10u L=1u
MnTb_L1_16_7 d1bar_L2 vcn ctp_L1_16 0 NSYN W=10u L=1u
MnTa_L1_16_7 dpre_L2_15 vcn ctn_L1_16 0 NSYN W=10u L=1u
MpTb_L1_16_7 d1bar_L2 gp_2_15_5 ctn_L1_16 0 NSYN W=10u L=1u
MpTa_L1_16_8 dpre_L2_16 gp_2_16_4 ctp_L1_16 0 NSYN W=10u L=1u
MnTb_L1_16_8 d1bar_L2 vcn ctp_L1_16 0 NSYN W=10u L=1u
MnTa_L1_16_8 dpre_L2_16 vcn ctn_L1_16 0 NSYN W=10u L=1u
MpTb_L1_16_8 d1bar_L2 gp_2_16_4 ctn_L1_16 0 NSYN W=10u L=1u
MpTa_L1_16_9 dpre_L2_18 gp_2_18_5 ctp_L1_16 0 NSYN W=10u L=1u
MnTb_L1_16_9 d1bar_L2 vcn ctp_L1_16 0 NSYN W=10u L=1u
MnTa_L1_16_9 dpre_L2_18 vcn ctn_L1_16 0 NSYN W=10u L=1u
MpTb_L1_16_9 d1bar_L2 gp_2_18_5 ctn_L1_16 0 NSYN W=10u L=1u
MpTa_L1_16_10 dpre_L2_20 gp_2_20_6 ctp_L1_16 0 NSYN W=10u L=1u
MnTb_L1_16_10 d1bar_L2 vcn ctp_L1_16 0 NSYN W=10u L=1u
MnTa_L1_16_10 dpre_L2_20 vcn ctn_L1_16 0 NSYN W=10u L=1u
MpTb_L1_16_10 d1bar_L2 gp_2_20_6 ctn_L1_16 0 NSYN W=10u L=1u
MpTa_L1_16_11 dpre_L2_22 gp_2_22_2 ctp_L1_16 0 NSYN W=10u L=1u
MnTb_L1_16_11 d1bar_L2 vcn ctp_L1_16 0 NSYN W=10u L=1u
MnTa_L1_16_11 dpre_L2_22 vcn ctn_L1_16 0 NSYN W=10u L=1u
MpTb_L1_16_11 d1bar_L2 gp_2_22_2 ctn_L1_16 0 NSYN W=10u L=1u
MpTa_L1_16_12 dpre_L2_23 gp_2_23_6 ctp_L1_16 0 NSYN W=10u L=1u
MnTb_L1_16_12 d1bar_L2 vcn ctp_L1_16 0 NSYN W=10u L=1u
MnTa_L1_16_12 dpre_L2_23 vcn ctn_L1_16 0 NSYN W=10u L=1u
MpTb_L1_16_12 d1bar_L2 gp_2_23_6 ctn_L1_16 0 NSYN W=10u L=1u
MpTa_L1_16_13 dpre_L2_25 gp_2_25_6 ctp_L1_16 0 NSYN W=10u L=1u
MnTb_L1_16_13 d1bar_L2 vcn ctp_L1_16 0 NSYN W=10u L=1u
MnTa_L1_16_13 dpre_L2_25 vcn ctn_L1_16 0 NSYN W=10u L=1u
MpTb_L1_16_13 d1bar_L2 gp_2_25_6 ctn_L1_16 0 NSYN W=10u L=1u
MpTa_L1_16_14 dpre_L2_27 gp_2_27_5 ctp_L1_16 0 NSYN W=10u L=1u
MnTb_L1_16_14 d1bar_L2 vcn ctp_L1_16 0 NSYN W=10u L=1u
MnTa_L1_16_14 dpre_L2_27 vcn ctn_L1_16 0 NSYN W=10u L=1u
MpTb_L1_16_14 d1bar_L2 gp_2_27_5 ctn_L1_16 0 NSYN W=10u L=1u
MpTa_L1_16_15 dpre_L2_28 gp_2_28_6 ctp_L1_16 0 NSYN W=10u L=1u
MnTb_L1_16_15 d1bar_L2 vcn ctp_L1_16 0 NSYN W=10u L=1u
MnTa_L1_16_15 dpre_L2_28 vcn ctn_L1_16 0 NSYN W=10u L=1u
MpTb_L1_16_15 d1bar_L2 gp_2_28_6 ctn_L1_16 0 NSYN W=10u L=1u
MpTa_L1_16_16 dpre_L2_34 gp_2_34_6 ctp_L1_16 0 NSYN W=10u L=1u
MnTb_L1_16_16 d1bar_L2 vcn ctp_L1_16 0 NSYN W=10u L=1u
MnTa_L1_16_16 dpre_L2_34 vcn ctn_L1_16 0 NSYN W=10u L=1u
MpTb_L1_16_16 d1bar_L2 gp_2_34_6 ctn_L1_16 0 NSYN W=10u L=1u
MpTa_L1_16_17 dpre_L2_37 gp_2_37_5 ctp_L1_16 0 NSYN W=10u L=1u
MnTb_L1_16_17 d1bar_L2 vcn ctp_L1_16 0 NSYN W=10u L=1u
MnTa_L1_16_17 dpre_L2_37 vcn ctn_L1_16 0 NSYN W=10u L=1u
MpTb_L1_16_17 d1bar_L2 gp_2_37_5 ctn_L1_16 0 NSYN W=10u L=1u
MpTa_L1_16_18 dpre_L2_39 gp_2_39_6 ctp_L1_16 0 NSYN W=10u L=1u
MnTb_L1_16_18 d1bar_L2 vcn ctp_L1_16 0 NSYN W=10u L=1u
MnTa_L1_16_18 dpre_L2_39 vcn ctn_L1_16 0 NSYN W=10u L=1u
MpTb_L1_16_18 d1bar_L2 gp_2_39_6 ctn_L1_16 0 NSYN W=10u L=1u
MpTa_L1_16_19 dpre_L2_40 gp_2_40_4 ctp_L1_16 0 NSYN W=10u L=1u
MnTb_L1_16_19 d1bar_L2 vcn ctp_L1_16 0 NSYN W=10u L=1u
MnTa_L1_16_19 dpre_L2_40 vcn ctn_L1_16 0 NSYN W=10u L=1u
MpTb_L1_16_19 d1bar_L2 gp_2_40_4 ctn_L1_16 0 NSYN W=10u L=1u
MpTa_L1_16_20 dpre_L2_41 gp_2_41_4 ctp_L1_16 0 NSYN W=10u L=1u
MnTb_L1_16_20 d1bar_L2 vcn ctp_L1_16 0 NSYN W=10u L=1u
MnTa_L1_16_20 dpre_L2_41 vcn ctn_L1_16 0 NSYN W=10u L=1u
MpTb_L1_16_20 d1bar_L2 gp_2_41_4 ctn_L1_16 0 NSYN W=10u L=1u
MpTa_L1_16_21 dpre_L2_44 gp_2_44_5 ctp_L1_16 0 NSYN W=10u L=1u
MnTb_L1_16_21 d1bar_L2 vcn ctp_L1_16 0 NSYN W=10u L=1u
MnTa_L1_16_21 dpre_L2_44 vcn ctn_L1_16 0 NSYN W=10u L=1u
MpTb_L1_16_21 d1bar_L2 gp_2_44_5 ctn_L1_16 0 NSYN W=10u L=1u
MpTa_L1_16_22 dpre_L2_47 gp_2_47_5 ctp_L1_16 0 NSYN W=10u L=1u
MnTb_L1_16_22 d1bar_L2 vcn ctp_L1_16 0 NSYN W=10u L=1u
MnTa_L1_16_22 dpre_L2_47 vcn ctn_L1_16 0 NSYN W=10u L=1u
MpTb_L1_16_22 d1bar_L2 gp_2_47_5 ctn_L1_16 0 NSYN W=10u L=1u
Msa_bk_L1_16 ctn_L1_16 ctn_L1_16 0 0 NMIR W=20u L=1u
Msb_bk_L1_16 dpre_L1_16 ctn_L1_16 0 0 NMIR W=20u L=1u
Msc_bk_L1_16 ctp_L1_16 ctp_L1_16 0 0 NMIR W=20u L=1u
Msd_bk_L1_16 dpf_bk_L1_16 ctp_L1_16 0 0 NMIR W=20u L=1u
Mse_bk_L1_16 dpf_bk_L1_16 dpf_bk_L1_16 vdd vdd PMIR W=60u L=1u
Msf_bk_L1_16 dpre_L1_16 dpf_bk_L1_16 vdd vdd PMIR W=60u L=1u
R_bk_L1_16 dpre_L1_16 vrefd 16000.0
MpTa_L1_17_0 dpre_L2_0 gp_2_0_5 ctp_L1_17 0 NSYN W=10u L=1u
MnTb_L1_17_0 d1bar_L2 vcn ctp_L1_17 0 NSYN W=10u L=1u
MnTa_L1_17_0 dpre_L2_0 vcn ctn_L1_17 0 NSYN W=10u L=1u
MpTb_L1_17_0 d1bar_L2 gp_2_0_5 ctn_L1_17 0 NSYN W=10u L=1u
MpTa_L1_17_1 dpre_L2_1 gp_2_1_5 ctp_L1_17 0 NSYN W=10u L=1u
MnTb_L1_17_1 d1bar_L2 vcn ctp_L1_17 0 NSYN W=10u L=1u
MnTa_L1_17_1 dpre_L2_1 vcn ctn_L1_17 0 NSYN W=10u L=1u
MpTb_L1_17_1 d1bar_L2 gp_2_1_5 ctn_L1_17 0 NSYN W=10u L=1u
MpTa_L1_17_2 dpre_L2_6 gp_2_6_6 ctp_L1_17 0 NSYN W=10u L=1u
MnTb_L1_17_2 d1bar_L2 vcn ctp_L1_17 0 NSYN W=10u L=1u
MnTa_L1_17_2 dpre_L2_6 vcn ctn_L1_17 0 NSYN W=10u L=1u
MpTb_L1_17_2 d1bar_L2 gp_2_6_6 ctn_L1_17 0 NSYN W=10u L=1u
MpTa_L1_17_3 dpre_L2_8 gp_2_8_6 ctp_L1_17 0 NSYN W=10u L=1u
MnTb_L1_17_3 d1bar_L2 vcn ctp_L1_17 0 NSYN W=10u L=1u
MnTa_L1_17_3 dpre_L2_8 vcn ctn_L1_17 0 NSYN W=10u L=1u
MpTb_L1_17_3 d1bar_L2 gp_2_8_6 ctn_L1_17 0 NSYN W=10u L=1u
MpTa_L1_17_4 dpre_L2_14 gp_2_14_5 ctp_L1_17 0 NSYN W=10u L=1u
MnTb_L1_17_4 d1bar_L2 vcn ctp_L1_17 0 NSYN W=10u L=1u
MnTa_L1_17_4 dpre_L2_14 vcn ctn_L1_17 0 NSYN W=10u L=1u
MpTb_L1_17_4 d1bar_L2 gp_2_14_5 ctn_L1_17 0 NSYN W=10u L=1u
MpTa_L1_17_5 dpre_L2_20 gp_2_20_7 ctp_L1_17 0 NSYN W=10u L=1u
MnTb_L1_17_5 d1bar_L2 vcn ctp_L1_17 0 NSYN W=10u L=1u
MnTa_L1_17_5 dpre_L2_20 vcn ctn_L1_17 0 NSYN W=10u L=1u
MpTb_L1_17_5 d1bar_L2 gp_2_20_7 ctn_L1_17 0 NSYN W=10u L=1u
MpTa_L1_17_6 dpre_L2_21 gp_2_21_5 ctp_L1_17 0 NSYN W=10u L=1u
MnTb_L1_17_6 d1bar_L2 vcn ctp_L1_17 0 NSYN W=10u L=1u
MnTa_L1_17_6 dpre_L2_21 vcn ctn_L1_17 0 NSYN W=10u L=1u
MpTb_L1_17_6 d1bar_L2 gp_2_21_5 ctn_L1_17 0 NSYN W=10u L=1u
MpTa_L1_17_7 dpre_L2_22 gp_2_22_3 ctp_L1_17 0 NSYN W=10u L=1u
MnTb_L1_17_7 d1bar_L2 vcn ctp_L1_17 0 NSYN W=10u L=1u
MnTa_L1_17_7 dpre_L2_22 vcn ctn_L1_17 0 NSYN W=10u L=1u
MpTb_L1_17_7 d1bar_L2 gp_2_22_3 ctn_L1_17 0 NSYN W=10u L=1u
MpTa_L1_17_8 dpre_L2_29 gp_2_29_3 ctp_L1_17 0 NSYN W=10u L=1u
MnTb_L1_17_8 d1bar_L2 vcn ctp_L1_17 0 NSYN W=10u L=1u
MnTa_L1_17_8 dpre_L2_29 vcn ctn_L1_17 0 NSYN W=10u L=1u
MpTb_L1_17_8 d1bar_L2 gp_2_29_3 ctn_L1_17 0 NSYN W=10u L=1u
MpTa_L1_17_9 dpre_L2_36 gp_2_36_6 ctp_L1_17 0 NSYN W=10u L=1u
MnTb_L1_17_9 d1bar_L2 vcn ctp_L1_17 0 NSYN W=10u L=1u
MnTa_L1_17_9 dpre_L2_36 vcn ctn_L1_17 0 NSYN W=10u L=1u
MpTb_L1_17_9 d1bar_L2 gp_2_36_6 ctn_L1_17 0 NSYN W=10u L=1u
MpTa_L1_17_10 dpre_L2_37 gp_2_37_6 ctp_L1_17 0 NSYN W=10u L=1u
MnTb_L1_17_10 d1bar_L2 vcn ctp_L1_17 0 NSYN W=10u L=1u
MnTa_L1_17_10 dpre_L2_37 vcn ctn_L1_17 0 NSYN W=10u L=1u
MpTb_L1_17_10 d1bar_L2 gp_2_37_6 ctn_L1_17 0 NSYN W=10u L=1u
MpTa_L1_17_11 dpre_L2_38 gp_2_38_4 ctp_L1_17 0 NSYN W=10u L=1u
MnTb_L1_17_11 d1bar_L2 vcn ctp_L1_17 0 NSYN W=10u L=1u
MnTa_L1_17_11 dpre_L2_38 vcn ctn_L1_17 0 NSYN W=10u L=1u
MpTb_L1_17_11 d1bar_L2 gp_2_38_4 ctn_L1_17 0 NSYN W=10u L=1u
MpTa_L1_17_12 dpre_L2_39 gp_2_39_7 ctp_L1_17 0 NSYN W=10u L=1u
MnTb_L1_17_12 d1bar_L2 vcn ctp_L1_17 0 NSYN W=10u L=1u
MnTa_L1_17_12 dpre_L2_39 vcn ctn_L1_17 0 NSYN W=10u L=1u
MpTb_L1_17_12 d1bar_L2 gp_2_39_7 ctn_L1_17 0 NSYN W=10u L=1u
MpTa_L1_17_13 dpre_L2_41 gp_2_41_5 ctp_L1_17 0 NSYN W=10u L=1u
MnTb_L1_17_13 d1bar_L2 vcn ctp_L1_17 0 NSYN W=10u L=1u
MnTa_L1_17_13 dpre_L2_41 vcn ctn_L1_17 0 NSYN W=10u L=1u
MpTb_L1_17_13 d1bar_L2 gp_2_41_5 ctn_L1_17 0 NSYN W=10u L=1u
MpTa_L1_17_14 dpre_L2_46 gp_2_46_5 ctp_L1_17 0 NSYN W=10u L=1u
MnTb_L1_17_14 d1bar_L2 vcn ctp_L1_17 0 NSYN W=10u L=1u
MnTa_L1_17_14 dpre_L2_46 vcn ctn_L1_17 0 NSYN W=10u L=1u
MpTb_L1_17_14 d1bar_L2 gp_2_46_5 ctn_L1_17 0 NSYN W=10u L=1u
MpTa_L1_17_15 dpre_L2_47 gp_2_47_6 ctp_L1_17 0 NSYN W=10u L=1u
MnTb_L1_17_15 d1bar_L2 vcn ctp_L1_17 0 NSYN W=10u L=1u
MnTa_L1_17_15 dpre_L2_47 vcn ctn_L1_17 0 NSYN W=10u L=1u
MpTb_L1_17_15 d1bar_L2 gp_2_47_6 ctn_L1_17 0 NSYN W=10u L=1u
Msa_bk_L1_17 ctn_L1_17 ctn_L1_17 0 0 NMIR W=20u L=1u
Msb_bk_L1_17 dpre_L1_17 ctn_L1_17 0 0 NMIR W=20u L=1u
Msc_bk_L1_17 ctp_L1_17 ctp_L1_17 0 0 NMIR W=20u L=1u
Msd_bk_L1_17 dpf_bk_L1_17 ctp_L1_17 0 0 NMIR W=20u L=1u
Mse_bk_L1_17 dpf_bk_L1_17 dpf_bk_L1_17 vdd vdd PMIR W=60u L=1u
Msf_bk_L1_17 dpre_L1_17 dpf_bk_L1_17 vdd vdd PMIR W=60u L=1u
R_bk_L1_17 dpre_L1_17 vrefd 16000.0
MpTa_L1_18_0 dpre_L2_1 gp_2_1_6 ctp_L1_18 0 NSYN W=10u L=1u
MnTb_L1_18_0 d1bar_L2 vcn ctp_L1_18 0 NSYN W=10u L=1u
MnTa_L1_18_0 dpre_L2_1 vcn ctn_L1_18 0 NSYN W=10u L=1u
MpTb_L1_18_0 d1bar_L2 gp_2_1_6 ctn_L1_18 0 NSYN W=10u L=1u
MpTa_L1_18_1 dpre_L2_3 gp_2_3_6 ctp_L1_18 0 NSYN W=10u L=1u
MnTb_L1_18_1 d1bar_L2 vcn ctp_L1_18 0 NSYN W=10u L=1u
MnTa_L1_18_1 dpre_L2_3 vcn ctn_L1_18 0 NSYN W=10u L=1u
MpTb_L1_18_1 d1bar_L2 gp_2_3_6 ctn_L1_18 0 NSYN W=10u L=1u
MpTa_L1_18_2 dpre_L2_5 gp_2_5_4 ctp_L1_18 0 NSYN W=10u L=1u
MnTb_L1_18_2 d1bar_L2 vcn ctp_L1_18 0 NSYN W=10u L=1u
MnTa_L1_18_2 dpre_L2_5 vcn ctn_L1_18 0 NSYN W=10u L=1u
MpTb_L1_18_2 d1bar_L2 gp_2_5_4 ctn_L1_18 0 NSYN W=10u L=1u
MpTa_L1_18_3 dpre_L2_12 gp_2_12_5 ctp_L1_18 0 NSYN W=10u L=1u
MnTb_L1_18_3 d1bar_L2 vcn ctp_L1_18 0 NSYN W=10u L=1u
MnTa_L1_18_3 dpre_L2_12 vcn ctn_L1_18 0 NSYN W=10u L=1u
MpTb_L1_18_3 d1bar_L2 gp_2_12_5 ctn_L1_18 0 NSYN W=10u L=1u
MpTa_L1_18_4 dpre_L2_20 gp_2_20_8 ctp_L1_18 0 NSYN W=10u L=1u
MnTb_L1_18_4 d1bar_L2 vcn ctp_L1_18 0 NSYN W=10u L=1u
MnTa_L1_18_4 dpre_L2_20 vcn ctn_L1_18 0 NSYN W=10u L=1u
MpTb_L1_18_4 d1bar_L2 gp_2_20_8 ctn_L1_18 0 NSYN W=10u L=1u
MpTa_L1_18_5 dpre_L2_21 gp_2_21_6 ctp_L1_18 0 NSYN W=10u L=1u
MnTb_L1_18_5 d1bar_L2 vcn ctp_L1_18 0 NSYN W=10u L=1u
MnTa_L1_18_5 dpre_L2_21 vcn ctn_L1_18 0 NSYN W=10u L=1u
MpTb_L1_18_5 d1bar_L2 gp_2_21_6 ctn_L1_18 0 NSYN W=10u L=1u
MpTa_L1_18_6 dpre_L2_23 gp_2_23_7 ctp_L1_18 0 NSYN W=10u L=1u
MnTb_L1_18_6 d1bar_L2 vcn ctp_L1_18 0 NSYN W=10u L=1u
MnTa_L1_18_6 dpre_L2_23 vcn ctn_L1_18 0 NSYN W=10u L=1u
MpTb_L1_18_6 d1bar_L2 gp_2_23_7 ctn_L1_18 0 NSYN W=10u L=1u
MpTa_L1_18_7 dpre_L2_27 gp_2_27_6 ctp_L1_18 0 NSYN W=10u L=1u
MnTb_L1_18_7 d1bar_L2 vcn ctp_L1_18 0 NSYN W=10u L=1u
MnTa_L1_18_7 dpre_L2_27 vcn ctn_L1_18 0 NSYN W=10u L=1u
MpTb_L1_18_7 d1bar_L2 gp_2_27_6 ctn_L1_18 0 NSYN W=10u L=1u
MpTa_L1_18_8 dpre_L2_31 gp_2_31_7 ctp_L1_18 0 NSYN W=10u L=1u
MnTb_L1_18_8 d1bar_L2 vcn ctp_L1_18 0 NSYN W=10u L=1u
MnTa_L1_18_8 dpre_L2_31 vcn ctn_L1_18 0 NSYN W=10u L=1u
MpTb_L1_18_8 d1bar_L2 gp_2_31_7 ctn_L1_18 0 NSYN W=10u L=1u
MpTa_L1_18_9 dpre_L2_33 gp_2_33_5 ctp_L1_18 0 NSYN W=10u L=1u
MnTb_L1_18_9 d1bar_L2 vcn ctp_L1_18 0 NSYN W=10u L=1u
MnTa_L1_18_9 dpre_L2_33 vcn ctn_L1_18 0 NSYN W=10u L=1u
MpTb_L1_18_9 d1bar_L2 gp_2_33_5 ctn_L1_18 0 NSYN W=10u L=1u
MpTa_L1_18_10 dpre_L2_35 gp_2_35_4 ctp_L1_18 0 NSYN W=10u L=1u
MnTb_L1_18_10 d1bar_L2 vcn ctp_L1_18 0 NSYN W=10u L=1u
MnTa_L1_18_10 dpre_L2_35 vcn ctn_L1_18 0 NSYN W=10u L=1u
MpTb_L1_18_10 d1bar_L2 gp_2_35_4 ctn_L1_18 0 NSYN W=10u L=1u
MpTa_L1_18_11 dpre_L2_37 gp_2_37_7 ctp_L1_18 0 NSYN W=10u L=1u
MnTb_L1_18_11 d1bar_L2 vcn ctp_L1_18 0 NSYN W=10u L=1u
MnTa_L1_18_11 dpre_L2_37 vcn ctn_L1_18 0 NSYN W=10u L=1u
MpTb_L1_18_11 d1bar_L2 gp_2_37_7 ctn_L1_18 0 NSYN W=10u L=1u
MpTa_L1_18_12 dpre_L2_43 gp_2_43_7 ctp_L1_18 0 NSYN W=10u L=1u
MnTb_L1_18_12 d1bar_L2 vcn ctp_L1_18 0 NSYN W=10u L=1u
MnTa_L1_18_12 dpre_L2_43 vcn ctn_L1_18 0 NSYN W=10u L=1u
MpTb_L1_18_12 d1bar_L2 gp_2_43_7 ctn_L1_18 0 NSYN W=10u L=1u
MpTa_L1_18_13 dpre_L2_44 gp_2_44_6 ctp_L1_18 0 NSYN W=10u L=1u
MnTb_L1_18_13 d1bar_L2 vcn ctp_L1_18 0 NSYN W=10u L=1u
MnTa_L1_18_13 dpre_L2_44 vcn ctn_L1_18 0 NSYN W=10u L=1u
MpTb_L1_18_13 d1bar_L2 gp_2_44_6 ctn_L1_18 0 NSYN W=10u L=1u
MpTa_L1_18_14 dpre_L2_47 gp_2_47_7 ctp_L1_18 0 NSYN W=10u L=1u
MnTb_L1_18_14 d1bar_L2 vcn ctp_L1_18 0 NSYN W=10u L=1u
MnTa_L1_18_14 dpre_L2_47 vcn ctn_L1_18 0 NSYN W=10u L=1u
MpTb_L1_18_14 d1bar_L2 gp_2_47_7 ctn_L1_18 0 NSYN W=10u L=1u
Msa_bk_L1_18 ctn_L1_18 ctn_L1_18 0 0 NMIR W=20u L=1u
Msb_bk_L1_18 dpre_L1_18 ctn_L1_18 0 0 NMIR W=20u L=1u
Msc_bk_L1_18 ctp_L1_18 ctp_L1_18 0 0 NMIR W=20u L=1u
Msd_bk_L1_18 dpf_bk_L1_18 ctp_L1_18 0 0 NMIR W=20u L=1u
Mse_bk_L1_18 dpf_bk_L1_18 dpf_bk_L1_18 vdd vdd PMIR W=60u L=1u
Msf_bk_L1_18 dpre_L1_18 dpf_bk_L1_18 vdd vdd PMIR W=60u L=1u
R_bk_L1_18 dpre_L1_18 vrefd 16000.0
MpTa_L1_19_0 dpre_L2_1 gp_2_1_7 ctp_L1_19 0 NSYN W=10u L=1u
MnTb_L1_19_0 d1bar_L2 vcn ctp_L1_19 0 NSYN W=10u L=1u
MnTa_L1_19_0 dpre_L2_1 vcn ctn_L1_19 0 NSYN W=10u L=1u
MpTb_L1_19_0 d1bar_L2 gp_2_1_7 ctn_L1_19 0 NSYN W=10u L=1u
MpTa_L1_19_1 dpre_L2_2 gp_2_2_5 ctp_L1_19 0 NSYN W=10u L=1u
MnTb_L1_19_1 d1bar_L2 vcn ctp_L1_19 0 NSYN W=10u L=1u
MnTa_L1_19_1 dpre_L2_2 vcn ctn_L1_19 0 NSYN W=10u L=1u
MpTb_L1_19_1 d1bar_L2 gp_2_2_5 ctn_L1_19 0 NSYN W=10u L=1u
MpTa_L1_19_2 dpre_L2_7 gp_2_7_9 ctp_L1_19 0 NSYN W=10u L=1u
MnTb_L1_19_2 d1bar_L2 vcn ctp_L1_19 0 NSYN W=10u L=1u
MnTa_L1_19_2 dpre_L2_7 vcn ctn_L1_19 0 NSYN W=10u L=1u
MpTb_L1_19_2 d1bar_L2 gp_2_7_9 ctn_L1_19 0 NSYN W=10u L=1u
MpTa_L1_19_3 dpre_L2_9 gp_2_9_7 ctp_L1_19 0 NSYN W=10u L=1u
MnTb_L1_19_3 d1bar_L2 vcn ctp_L1_19 0 NSYN W=10u L=1u
MnTa_L1_19_3 dpre_L2_9 vcn ctn_L1_19 0 NSYN W=10u L=1u
MpTb_L1_19_3 d1bar_L2 gp_2_9_7 ctn_L1_19 0 NSYN W=10u L=1u
MpTa_L1_19_4 dpre_L2_12 gp_2_12_6 ctp_L1_19 0 NSYN W=10u L=1u
MnTb_L1_19_4 d1bar_L2 vcn ctp_L1_19 0 NSYN W=10u L=1u
MnTa_L1_19_4 dpre_L2_12 vcn ctn_L1_19 0 NSYN W=10u L=1u
MpTb_L1_19_4 d1bar_L2 gp_2_12_6 ctn_L1_19 0 NSYN W=10u L=1u
MpTa_L1_19_5 dpre_L2_13 gp_2_13_7 ctp_L1_19 0 NSYN W=10u L=1u
MnTb_L1_19_5 d1bar_L2 vcn ctp_L1_19 0 NSYN W=10u L=1u
MnTa_L1_19_5 dpre_L2_13 vcn ctn_L1_19 0 NSYN W=10u L=1u
MpTb_L1_19_5 d1bar_L2 gp_2_13_7 ctn_L1_19 0 NSYN W=10u L=1u
MpTa_L1_19_6 dpre_L2_16 gp_2_16_5 ctp_L1_19 0 NSYN W=10u L=1u
MnTb_L1_19_6 d1bar_L2 vcn ctp_L1_19 0 NSYN W=10u L=1u
MnTa_L1_19_6 dpre_L2_16 vcn ctn_L1_19 0 NSYN W=10u L=1u
MpTb_L1_19_6 d1bar_L2 gp_2_16_5 ctn_L1_19 0 NSYN W=10u L=1u
MpTa_L1_19_7 dpre_L2_17 gp_2_17_9 ctp_L1_19 0 NSYN W=10u L=1u
MnTb_L1_19_7 d1bar_L2 vcn ctp_L1_19 0 NSYN W=10u L=1u
MnTa_L1_19_7 dpre_L2_17 vcn ctn_L1_19 0 NSYN W=10u L=1u
MpTb_L1_19_7 d1bar_L2 gp_2_17_9 ctn_L1_19 0 NSYN W=10u L=1u
MpTa_L1_19_8 dpre_L2_18 gp_2_18_6 ctp_L1_19 0 NSYN W=10u L=1u
MnTb_L1_19_8 d1bar_L2 vcn ctp_L1_19 0 NSYN W=10u L=1u
MnTa_L1_19_8 dpre_L2_18 vcn ctn_L1_19 0 NSYN W=10u L=1u
MpTb_L1_19_8 d1bar_L2 gp_2_18_6 ctn_L1_19 0 NSYN W=10u L=1u
MpTa_L1_19_9 dpre_L2_22 gp_2_22_4 ctp_L1_19 0 NSYN W=10u L=1u
MnTb_L1_19_9 d1bar_L2 vcn ctp_L1_19 0 NSYN W=10u L=1u
MnTa_L1_19_9 dpre_L2_22 vcn ctn_L1_19 0 NSYN W=10u L=1u
MpTb_L1_19_9 d1bar_L2 gp_2_22_4 ctn_L1_19 0 NSYN W=10u L=1u
MpTa_L1_19_10 dpre_L2_24 gp_2_24_6 ctp_L1_19 0 NSYN W=10u L=1u
MnTb_L1_19_10 d1bar_L2 vcn ctp_L1_19 0 NSYN W=10u L=1u
MnTa_L1_19_10 dpre_L2_24 vcn ctn_L1_19 0 NSYN W=10u L=1u
MpTb_L1_19_10 d1bar_L2 gp_2_24_6 ctn_L1_19 0 NSYN W=10u L=1u
MpTa_L1_19_11 dpre_L2_30 gp_2_30_7 ctp_L1_19 0 NSYN W=10u L=1u
MnTb_L1_19_11 d1bar_L2 vcn ctp_L1_19 0 NSYN W=10u L=1u
MnTa_L1_19_11 dpre_L2_30 vcn ctn_L1_19 0 NSYN W=10u L=1u
MpTb_L1_19_11 d1bar_L2 gp_2_30_7 ctn_L1_19 0 NSYN W=10u L=1u
MpTa_L1_19_12 dpre_L2_39 gp_2_39_8 ctp_L1_19 0 NSYN W=10u L=1u
MnTb_L1_19_12 d1bar_L2 vcn ctp_L1_19 0 NSYN W=10u L=1u
MnTa_L1_19_12 dpre_L2_39 vcn ctn_L1_19 0 NSYN W=10u L=1u
MpTb_L1_19_12 d1bar_L2 gp_2_39_8 ctn_L1_19 0 NSYN W=10u L=1u
MpTa_L1_19_13 dpre_L2_41 gp_2_41_6 ctp_L1_19 0 NSYN W=10u L=1u
MnTb_L1_19_13 d1bar_L2 vcn ctp_L1_19 0 NSYN W=10u L=1u
MnTa_L1_19_13 dpre_L2_41 vcn ctn_L1_19 0 NSYN W=10u L=1u
MpTb_L1_19_13 d1bar_L2 gp_2_41_6 ctn_L1_19 0 NSYN W=10u L=1u
MpTa_L1_19_14 dpre_L2_45 gp_2_45_7 ctp_L1_19 0 NSYN W=10u L=1u
MnTb_L1_19_14 d1bar_L2 vcn ctp_L1_19 0 NSYN W=10u L=1u
MnTa_L1_19_14 dpre_L2_45 vcn ctn_L1_19 0 NSYN W=10u L=1u
MpTb_L1_19_14 d1bar_L2 gp_2_45_7 ctn_L1_19 0 NSYN W=10u L=1u
Msa_bk_L1_19 ctn_L1_19 ctn_L1_19 0 0 NMIR W=20u L=1u
Msb_bk_L1_19 dpre_L1_19 ctn_L1_19 0 0 NMIR W=20u L=1u
Msc_bk_L1_19 ctp_L1_19 ctp_L1_19 0 0 NMIR W=20u L=1u
Msd_bk_L1_19 dpf_bk_L1_19 ctp_L1_19 0 0 NMIR W=20u L=1u
Mse_bk_L1_19 dpf_bk_L1_19 dpf_bk_L1_19 vdd vdd PMIR W=60u L=1u
Msf_bk_L1_19 dpre_L1_19 dpf_bk_L1_19 vdd vdd PMIR W=60u L=1u
R_bk_L1_19 dpre_L1_19 vrefd 16000.0
MpTa_L1_20_0 dpre_L2_2 gp_2_2_6 ctp_L1_20 0 NSYN W=10u L=1u
MnTb_L1_20_0 d1bar_L2 vcn ctp_L1_20 0 NSYN W=10u L=1u
MnTa_L1_20_0 dpre_L2_2 vcn ctn_L1_20 0 NSYN W=10u L=1u
MpTb_L1_20_0 d1bar_L2 gp_2_2_6 ctn_L1_20 0 NSYN W=10u L=1u
MpTa_L1_20_1 dpre_L2_3 gp_2_3_7 ctp_L1_20 0 NSYN W=10u L=1u
MnTb_L1_20_1 d1bar_L2 vcn ctp_L1_20 0 NSYN W=10u L=1u
MnTa_L1_20_1 dpre_L2_3 vcn ctn_L1_20 0 NSYN W=10u L=1u
MpTb_L1_20_1 d1bar_L2 gp_2_3_7 ctn_L1_20 0 NSYN W=10u L=1u
MpTa_L1_20_2 dpre_L2_5 gp_2_5_5 ctp_L1_20 0 NSYN W=10u L=1u
MnTb_L1_20_2 d1bar_L2 vcn ctp_L1_20 0 NSYN W=10u L=1u
MnTa_L1_20_2 dpre_L2_5 vcn ctn_L1_20 0 NSYN W=10u L=1u
MpTb_L1_20_2 d1bar_L2 gp_2_5_5 ctn_L1_20 0 NSYN W=10u L=1u
MpTa_L1_20_3 dpre_L2_14 gp_2_14_6 ctp_L1_20 0 NSYN W=10u L=1u
MnTb_L1_20_3 d1bar_L2 vcn ctp_L1_20 0 NSYN W=10u L=1u
MnTa_L1_20_3 dpre_L2_14 vcn ctn_L1_20 0 NSYN W=10u L=1u
MpTb_L1_20_3 d1bar_L2 gp_2_14_6 ctn_L1_20 0 NSYN W=10u L=1u
MpTa_L1_20_4 dpre_L2_20 gp_2_20_9 ctp_L1_20 0 NSYN W=10u L=1u
MnTb_L1_20_4 d1bar_L2 vcn ctp_L1_20 0 NSYN W=10u L=1u
MnTa_L1_20_4 dpre_L2_20 vcn ctn_L1_20 0 NSYN W=10u L=1u
MpTb_L1_20_4 d1bar_L2 gp_2_20_9 ctn_L1_20 0 NSYN W=10u L=1u
MpTa_L1_20_5 dpre_L2_21 gp_2_21_7 ctp_L1_20 0 NSYN W=10u L=1u
MnTb_L1_20_5 d1bar_L2 vcn ctp_L1_20 0 NSYN W=10u L=1u
MnTa_L1_20_5 dpre_L2_21 vcn ctn_L1_20 0 NSYN W=10u L=1u
MpTb_L1_20_5 d1bar_L2 gp_2_21_7 ctn_L1_20 0 NSYN W=10u L=1u
MpTa_L1_20_6 dpre_L2_33 gp_2_33_6 ctp_L1_20 0 NSYN W=10u L=1u
MnTb_L1_20_6 d1bar_L2 vcn ctp_L1_20 0 NSYN W=10u L=1u
MnTa_L1_20_6 dpre_L2_33 vcn ctn_L1_20 0 NSYN W=10u L=1u
MpTb_L1_20_6 d1bar_L2 gp_2_33_6 ctn_L1_20 0 NSYN W=10u L=1u
MpTa_L1_20_7 dpre_L2_40 gp_2_40_5 ctp_L1_20 0 NSYN W=10u L=1u
MnTb_L1_20_7 d1bar_L2 vcn ctp_L1_20 0 NSYN W=10u L=1u
MnTa_L1_20_7 dpre_L2_40 vcn ctn_L1_20 0 NSYN W=10u L=1u
MpTb_L1_20_7 d1bar_L2 gp_2_40_5 ctn_L1_20 0 NSYN W=10u L=1u
MpTa_L1_20_8 dpre_L2_41 gp_2_41_7 ctp_L1_20 0 NSYN W=10u L=1u
MnTb_L1_20_8 d1bar_L2 vcn ctp_L1_20 0 NSYN W=10u L=1u
MnTa_L1_20_8 dpre_L2_41 vcn ctn_L1_20 0 NSYN W=10u L=1u
MpTb_L1_20_8 d1bar_L2 gp_2_41_7 ctn_L1_20 0 NSYN W=10u L=1u
MpTa_L1_20_9 dpre_L2_44 gp_2_44_7 ctp_L1_20 0 NSYN W=10u L=1u
MnTb_L1_20_9 d1bar_L2 vcn ctp_L1_20 0 NSYN W=10u L=1u
MnTa_L1_20_9 dpre_L2_44 vcn ctn_L1_20 0 NSYN W=10u L=1u
MpTb_L1_20_9 d1bar_L2 gp_2_44_7 ctn_L1_20 0 NSYN W=10u L=1u
MpTa_L1_20_10 dpre_L2_47 gp_2_47_8 ctp_L1_20 0 NSYN W=10u L=1u
MnTb_L1_20_10 d1bar_L2 vcn ctp_L1_20 0 NSYN W=10u L=1u
MnTa_L1_20_10 dpre_L2_47 vcn ctn_L1_20 0 NSYN W=10u L=1u
MpTb_L1_20_10 d1bar_L2 gp_2_47_8 ctn_L1_20 0 NSYN W=10u L=1u
Msa_bk_L1_20 ctn_L1_20 ctn_L1_20 0 0 NMIR W=20u L=1u
Msb_bk_L1_20 dpre_L1_20 ctn_L1_20 0 0 NMIR W=20u L=1u
Msc_bk_L1_20 ctp_L1_20 ctp_L1_20 0 0 NMIR W=20u L=1u
Msd_bk_L1_20 dpf_bk_L1_20 ctp_L1_20 0 0 NMIR W=20u L=1u
Mse_bk_L1_20 dpf_bk_L1_20 dpf_bk_L1_20 vdd vdd PMIR W=60u L=1u
Msf_bk_L1_20 dpre_L1_20 dpf_bk_L1_20 vdd vdd PMIR W=60u L=1u
R_bk_L1_20 dpre_L1_20 vrefd 16000.0
MpTa_L1_21_0 dpre_L2_1 gp_2_1_8 ctp_L1_21 0 NSYN W=10u L=1u
MnTb_L1_21_0 d1bar_L2 vcn ctp_L1_21 0 NSYN W=10u L=1u
MnTa_L1_21_0 dpre_L2_1 vcn ctn_L1_21 0 NSYN W=10u L=1u
MpTb_L1_21_0 d1bar_L2 gp_2_1_8 ctn_L1_21 0 NSYN W=10u L=1u
MpTa_L1_21_1 dpre_L2_5 gp_2_5_6 ctp_L1_21 0 NSYN W=10u L=1u
MnTb_L1_21_1 d1bar_L2 vcn ctp_L1_21 0 NSYN W=10u L=1u
MnTa_L1_21_1 dpre_L2_5 vcn ctn_L1_21 0 NSYN W=10u L=1u
MpTb_L1_21_1 d1bar_L2 gp_2_5_6 ctn_L1_21 0 NSYN W=10u L=1u
MpTa_L1_21_2 dpre_L2_6 gp_2_6_7 ctp_L1_21 0 NSYN W=10u L=1u
MnTb_L1_21_2 d1bar_L2 vcn ctp_L1_21 0 NSYN W=10u L=1u
MnTa_L1_21_2 dpre_L2_6 vcn ctn_L1_21 0 NSYN W=10u L=1u
MpTb_L1_21_2 d1bar_L2 gp_2_6_7 ctn_L1_21 0 NSYN W=10u L=1u
MpTa_L1_21_3 dpre_L2_14 gp_2_14_7 ctp_L1_21 0 NSYN W=10u L=1u
MnTb_L1_21_3 d1bar_L2 vcn ctp_L1_21 0 NSYN W=10u L=1u
MnTa_L1_21_3 dpre_L2_14 vcn ctn_L1_21 0 NSYN W=10u L=1u
MpTb_L1_21_3 d1bar_L2 gp_2_14_7 ctn_L1_21 0 NSYN W=10u L=1u
MpTa_L1_21_4 dpre_L2_16 gp_2_16_6 ctp_L1_21 0 NSYN W=10u L=1u
MnTb_L1_21_4 d1bar_L2 vcn ctp_L1_21 0 NSYN W=10u L=1u
MnTa_L1_21_4 dpre_L2_16 vcn ctn_L1_21 0 NSYN W=10u L=1u
MpTb_L1_21_4 d1bar_L2 gp_2_16_6 ctn_L1_21 0 NSYN W=10u L=1u
MpTa_L1_21_5 dpre_L2_22 gp_2_22_5 ctp_L1_21 0 NSYN W=10u L=1u
MnTb_L1_21_5 d1bar_L2 vcn ctp_L1_21 0 NSYN W=10u L=1u
MnTa_L1_21_5 dpre_L2_22 vcn ctn_L1_21 0 NSYN W=10u L=1u
MpTb_L1_21_5 d1bar_L2 gp_2_22_5 ctn_L1_21 0 NSYN W=10u L=1u
MpTa_L1_21_6 dpre_L2_27 gp_2_27_7 ctp_L1_21 0 NSYN W=10u L=1u
MnTb_L1_21_6 d1bar_L2 vcn ctp_L1_21 0 NSYN W=10u L=1u
MnTa_L1_21_6 dpre_L2_27 vcn ctn_L1_21 0 NSYN W=10u L=1u
MpTb_L1_21_6 d1bar_L2 gp_2_27_7 ctn_L1_21 0 NSYN W=10u L=1u
MpTa_L1_21_7 dpre_L2_34 gp_2_34_7 ctp_L1_21 0 NSYN W=10u L=1u
MnTb_L1_21_7 d1bar_L2 vcn ctp_L1_21 0 NSYN W=10u L=1u
MnTa_L1_21_7 dpre_L2_34 vcn ctn_L1_21 0 NSYN W=10u L=1u
MpTb_L1_21_7 d1bar_L2 gp_2_34_7 ctn_L1_21 0 NSYN W=10u L=1u
MpTa_L1_21_8 dpre_L2_35 gp_2_35_5 ctp_L1_21 0 NSYN W=10u L=1u
MnTb_L1_21_8 d1bar_L2 vcn ctp_L1_21 0 NSYN W=10u L=1u
MnTa_L1_21_8 dpre_L2_35 vcn ctn_L1_21 0 NSYN W=10u L=1u
MpTb_L1_21_8 d1bar_L2 gp_2_35_5 ctn_L1_21 0 NSYN W=10u L=1u
MpTa_L1_21_9 dpre_L2_38 gp_2_38_5 ctp_L1_21 0 NSYN W=10u L=1u
MnTb_L1_21_9 d1bar_L2 vcn ctp_L1_21 0 NSYN W=10u L=1u
MnTa_L1_21_9 dpre_L2_38 vcn ctn_L1_21 0 NSYN W=10u L=1u
MpTb_L1_21_9 d1bar_L2 gp_2_38_5 ctn_L1_21 0 NSYN W=10u L=1u
MpTa_L1_21_10 dpre_L2_40 gp_2_40_6 ctp_L1_21 0 NSYN W=10u L=1u
MnTb_L1_21_10 d1bar_L2 vcn ctp_L1_21 0 NSYN W=10u L=1u
MnTa_L1_21_10 dpre_L2_40 vcn ctn_L1_21 0 NSYN W=10u L=1u
MpTb_L1_21_10 d1bar_L2 gp_2_40_6 ctn_L1_21 0 NSYN W=10u L=1u
MpTa_L1_21_11 dpre_L2_41 gp_2_41_8 ctp_L1_21 0 NSYN W=10u L=1u
MnTb_L1_21_11 d1bar_L2 vcn ctp_L1_21 0 NSYN W=10u L=1u
MnTa_L1_21_11 dpre_L2_41 vcn ctn_L1_21 0 NSYN W=10u L=1u
MpTb_L1_21_11 d1bar_L2 gp_2_41_8 ctn_L1_21 0 NSYN W=10u L=1u
MpTa_L1_21_12 dpre_L2_42 gp_2_42_7 ctp_L1_21 0 NSYN W=10u L=1u
MnTb_L1_21_12 d1bar_L2 vcn ctp_L1_21 0 NSYN W=10u L=1u
MnTa_L1_21_12 dpre_L2_42 vcn ctn_L1_21 0 NSYN W=10u L=1u
MpTb_L1_21_12 d1bar_L2 gp_2_42_7 ctn_L1_21 0 NSYN W=10u L=1u
MpTa_L1_21_13 dpre_L2_44 gp_2_44_8 ctp_L1_21 0 NSYN W=10u L=1u
MnTb_L1_21_13 d1bar_L2 vcn ctp_L1_21 0 NSYN W=10u L=1u
MnTa_L1_21_13 dpre_L2_44 vcn ctn_L1_21 0 NSYN W=10u L=1u
MpTb_L1_21_13 d1bar_L2 gp_2_44_8 ctn_L1_21 0 NSYN W=10u L=1u
MpTa_L1_21_14 dpre_L2_46 gp_2_46_6 ctp_L1_21 0 NSYN W=10u L=1u
MnTb_L1_21_14 d1bar_L2 vcn ctp_L1_21 0 NSYN W=10u L=1u
MnTa_L1_21_14 dpre_L2_46 vcn ctn_L1_21 0 NSYN W=10u L=1u
MpTb_L1_21_14 d1bar_L2 gp_2_46_6 ctn_L1_21 0 NSYN W=10u L=1u
Msa_bk_L1_21 ctn_L1_21 ctn_L1_21 0 0 NMIR W=20u L=1u
Msb_bk_L1_21 dpre_L1_21 ctn_L1_21 0 0 NMIR W=20u L=1u
Msc_bk_L1_21 ctp_L1_21 ctp_L1_21 0 0 NMIR W=20u L=1u
Msd_bk_L1_21 dpf_bk_L1_21 ctp_L1_21 0 0 NMIR W=20u L=1u
Mse_bk_L1_21 dpf_bk_L1_21 dpf_bk_L1_21 vdd vdd PMIR W=60u L=1u
Msf_bk_L1_21 dpre_L1_21 dpf_bk_L1_21 vdd vdd PMIR W=60u L=1u
R_bk_L1_21 dpre_L1_21 vrefd 16000.0
MpTa_L1_22_0 dpre_L2_2 gp_2_2_7 ctp_L1_22 0 NSYN W=10u L=1u
MnTb_L1_22_0 d1bar_L2 vcn ctp_L1_22 0 NSYN W=10u L=1u
MnTa_L1_22_0 dpre_L2_2 vcn ctn_L1_22 0 NSYN W=10u L=1u
MpTb_L1_22_0 d1bar_L2 gp_2_2_7 ctn_L1_22 0 NSYN W=10u L=1u
MpTa_L1_22_1 dpre_L2_3 gp_2_3_8 ctp_L1_22 0 NSYN W=10u L=1u
MnTb_L1_22_1 d1bar_L2 vcn ctp_L1_22 0 NSYN W=10u L=1u
MnTa_L1_22_1 dpre_L2_3 vcn ctn_L1_22 0 NSYN W=10u L=1u
MpTb_L1_22_1 d1bar_L2 gp_2_3_8 ctn_L1_22 0 NSYN W=10u L=1u
MpTa_L1_22_2 dpre_L2_9 gp_2_9_8 ctp_L1_22 0 NSYN W=10u L=1u
MnTb_L1_22_2 d1bar_L2 vcn ctp_L1_22 0 NSYN W=10u L=1u
MnTa_L1_22_2 dpre_L2_9 vcn ctn_L1_22 0 NSYN W=10u L=1u
MpTb_L1_22_2 d1bar_L2 gp_2_9_8 ctn_L1_22 0 NSYN W=10u L=1u
MpTa_L1_22_3 dpre_L2_10 gp_2_10_8 ctp_L1_22 0 NSYN W=10u L=1u
MnTb_L1_22_3 d1bar_L2 vcn ctp_L1_22 0 NSYN W=10u L=1u
MnTa_L1_22_3 dpre_L2_10 vcn ctn_L1_22 0 NSYN W=10u L=1u
MpTb_L1_22_3 d1bar_L2 gp_2_10_8 ctn_L1_22 0 NSYN W=10u L=1u
MpTa_L1_22_4 dpre_L2_11 gp_2_11_8 ctp_L1_22 0 NSYN W=10u L=1u
MnTb_L1_22_4 d1bar_L2 vcn ctp_L1_22 0 NSYN W=10u L=1u
MnTa_L1_22_4 dpre_L2_11 vcn ctn_L1_22 0 NSYN W=10u L=1u
MpTb_L1_22_4 d1bar_L2 gp_2_11_8 ctn_L1_22 0 NSYN W=10u L=1u
MpTa_L1_22_5 dpre_L2_14 gp_2_14_8 ctp_L1_22 0 NSYN W=10u L=1u
MnTb_L1_22_5 d1bar_L2 vcn ctp_L1_22 0 NSYN W=10u L=1u
MnTa_L1_22_5 dpre_L2_14 vcn ctn_L1_22 0 NSYN W=10u L=1u
MpTb_L1_22_5 d1bar_L2 gp_2_14_8 ctn_L1_22 0 NSYN W=10u L=1u
MpTa_L1_22_6 dpre_L2_16 gp_2_16_7 ctp_L1_22 0 NSYN W=10u L=1u
MnTb_L1_22_6 d1bar_L2 vcn ctp_L1_22 0 NSYN W=10u L=1u
MnTa_L1_22_6 dpre_L2_16 vcn ctn_L1_22 0 NSYN W=10u L=1u
MpTb_L1_22_6 d1bar_L2 gp_2_16_7 ctn_L1_22 0 NSYN W=10u L=1u
MpTa_L1_22_7 dpre_L2_22 gp_2_22_6 ctp_L1_22 0 NSYN W=10u L=1u
MnTb_L1_22_7 d1bar_L2 vcn ctp_L1_22 0 NSYN W=10u L=1u
MnTa_L1_22_7 dpre_L2_22 vcn ctn_L1_22 0 NSYN W=10u L=1u
MpTb_L1_22_7 d1bar_L2 gp_2_22_6 ctn_L1_22 0 NSYN W=10u L=1u
MpTa_L1_22_8 dpre_L2_26 gp_2_26_6 ctp_L1_22 0 NSYN W=10u L=1u
MnTb_L1_22_8 d1bar_L2 vcn ctp_L1_22 0 NSYN W=10u L=1u
MnTa_L1_22_8 dpre_L2_26 vcn ctn_L1_22 0 NSYN W=10u L=1u
MpTb_L1_22_8 d1bar_L2 gp_2_26_6 ctn_L1_22 0 NSYN W=10u L=1u
MpTa_L1_22_9 dpre_L2_27 gp_2_27_8 ctp_L1_22 0 NSYN W=10u L=1u
MnTb_L1_22_9 d1bar_L2 vcn ctp_L1_22 0 NSYN W=10u L=1u
MnTa_L1_22_9 dpre_L2_27 vcn ctn_L1_22 0 NSYN W=10u L=1u
MpTb_L1_22_9 d1bar_L2 gp_2_27_8 ctn_L1_22 0 NSYN W=10u L=1u
MpTa_L1_22_10 dpre_L2_29 gp_2_29_4 ctp_L1_22 0 NSYN W=10u L=1u
MnTb_L1_22_10 d1bar_L2 vcn ctp_L1_22 0 NSYN W=10u L=1u
MnTa_L1_22_10 dpre_L2_29 vcn ctn_L1_22 0 NSYN W=10u L=1u
MpTb_L1_22_10 d1bar_L2 gp_2_29_4 ctn_L1_22 0 NSYN W=10u L=1u
MpTa_L1_22_11 dpre_L2_39 gp_2_39_9 ctp_L1_22 0 NSYN W=10u L=1u
MnTb_L1_22_11 d1bar_L2 vcn ctp_L1_22 0 NSYN W=10u L=1u
MnTa_L1_22_11 dpre_L2_39 vcn ctn_L1_22 0 NSYN W=10u L=1u
MpTb_L1_22_11 d1bar_L2 gp_2_39_9 ctn_L1_22 0 NSYN W=10u L=1u
MpTa_L1_22_12 dpre_L2_40 gp_2_40_7 ctp_L1_22 0 NSYN W=10u L=1u
MnTb_L1_22_12 d1bar_L2 vcn ctp_L1_22 0 NSYN W=10u L=1u
MnTa_L1_22_12 dpre_L2_40 vcn ctn_L1_22 0 NSYN W=10u L=1u
MpTb_L1_22_12 d1bar_L2 gp_2_40_7 ctn_L1_22 0 NSYN W=10u L=1u
MpTa_L1_22_13 dpre_L2_41 gp_2_41_9 ctp_L1_22 0 NSYN W=10u L=1u
MnTb_L1_22_13 d1bar_L2 vcn ctp_L1_22 0 NSYN W=10u L=1u
MnTa_L1_22_13 dpre_L2_41 vcn ctn_L1_22 0 NSYN W=10u L=1u
MpTb_L1_22_13 d1bar_L2 gp_2_41_9 ctn_L1_22 0 NSYN W=10u L=1u
MpTa_L1_22_14 dpre_L2_42 gp_2_42_8 ctp_L1_22 0 NSYN W=10u L=1u
MnTb_L1_22_14 d1bar_L2 vcn ctp_L1_22 0 NSYN W=10u L=1u
MnTa_L1_22_14 dpre_L2_42 vcn ctn_L1_22 0 NSYN W=10u L=1u
MpTb_L1_22_14 d1bar_L2 gp_2_42_8 ctn_L1_22 0 NSYN W=10u L=1u
MpTa_L1_22_15 dpre_L2_44 gp_2_44_9 ctp_L1_22 0 NSYN W=10u L=1u
MnTb_L1_22_15 d1bar_L2 vcn ctp_L1_22 0 NSYN W=10u L=1u
MnTa_L1_22_15 dpre_L2_44 vcn ctn_L1_22 0 NSYN W=10u L=1u
MpTb_L1_22_15 d1bar_L2 gp_2_44_9 ctn_L1_22 0 NSYN W=10u L=1u
MpTa_L1_22_16 dpre_L2_46 gp_2_46_7 ctp_L1_22 0 NSYN W=10u L=1u
MnTb_L1_22_16 d1bar_L2 vcn ctp_L1_22 0 NSYN W=10u L=1u
MnTa_L1_22_16 dpre_L2_46 vcn ctn_L1_22 0 NSYN W=10u L=1u
MpTb_L1_22_16 d1bar_L2 gp_2_46_7 ctn_L1_22 0 NSYN W=10u L=1u
Msa_bk_L1_22 ctn_L1_22 ctn_L1_22 0 0 NMIR W=20u L=1u
Msb_bk_L1_22 dpre_L1_22 ctn_L1_22 0 0 NMIR W=20u L=1u
Msc_bk_L1_22 ctp_L1_22 ctp_L1_22 0 0 NMIR W=20u L=1u
Msd_bk_L1_22 dpf_bk_L1_22 ctp_L1_22 0 0 NMIR W=20u L=1u
Mse_bk_L1_22 dpf_bk_L1_22 dpf_bk_L1_22 vdd vdd PMIR W=60u L=1u
Msf_bk_L1_22 dpre_L1_22 dpf_bk_L1_22 vdd vdd PMIR W=60u L=1u
R_bk_L1_22 dpre_L1_22 vrefd 16000.0
MpTa_L1_23_0 dpre_L2_0 gp_2_0_6 ctp_L1_23 0 NSYN W=10u L=1u
MnTb_L1_23_0 d1bar_L2 vcn ctp_L1_23 0 NSYN W=10u L=1u
MnTa_L1_23_0 dpre_L2_0 vcn ctn_L1_23 0 NSYN W=10u L=1u
MpTb_L1_23_0 d1bar_L2 gp_2_0_6 ctn_L1_23 0 NSYN W=10u L=1u
MpTa_L1_23_1 dpre_L2_5 gp_2_5_7 ctp_L1_23 0 NSYN W=10u L=1u
MnTb_L1_23_1 d1bar_L2 vcn ctp_L1_23 0 NSYN W=10u L=1u
MnTa_L1_23_1 dpre_L2_5 vcn ctn_L1_23 0 NSYN W=10u L=1u
MpTb_L1_23_1 d1bar_L2 gp_2_5_7 ctn_L1_23 0 NSYN W=10u L=1u
MpTa_L1_23_2 dpre_L2_11 gp_2_11_9 ctp_L1_23 0 NSYN W=10u L=1u
MnTb_L1_23_2 d1bar_L2 vcn ctp_L1_23 0 NSYN W=10u L=1u
MnTa_L1_23_2 dpre_L2_11 vcn ctn_L1_23 0 NSYN W=10u L=1u
MpTb_L1_23_2 d1bar_L2 gp_2_11_9 ctn_L1_23 0 NSYN W=10u L=1u
MpTa_L1_23_3 dpre_L2_12 gp_2_12_7 ctp_L1_23 0 NSYN W=10u L=1u
MnTb_L1_23_3 d1bar_L2 vcn ctp_L1_23 0 NSYN W=10u L=1u
MnTa_L1_23_3 dpre_L2_12 vcn ctn_L1_23 0 NSYN W=10u L=1u
MpTb_L1_23_3 d1bar_L2 gp_2_12_7 ctn_L1_23 0 NSYN W=10u L=1u
MpTa_L1_23_4 dpre_L2_19 gp_2_19_6 ctp_L1_23 0 NSYN W=10u L=1u
MnTb_L1_23_4 d1bar_L2 vcn ctp_L1_23 0 NSYN W=10u L=1u
MnTa_L1_23_4 dpre_L2_19 vcn ctn_L1_23 0 NSYN W=10u L=1u
MpTb_L1_23_4 d1bar_L2 gp_2_19_6 ctn_L1_23 0 NSYN W=10u L=1u
MpTa_L1_23_5 dpre_L2_22 gp_2_22_7 ctp_L1_23 0 NSYN W=10u L=1u
MnTb_L1_23_5 d1bar_L2 vcn ctp_L1_23 0 NSYN W=10u L=1u
MnTa_L1_23_5 dpre_L2_22 vcn ctn_L1_23 0 NSYN W=10u L=1u
MpTb_L1_23_5 d1bar_L2 gp_2_22_7 ctn_L1_23 0 NSYN W=10u L=1u
MpTa_L1_23_6 dpre_L2_25 gp_2_25_7 ctp_L1_23 0 NSYN W=10u L=1u
MnTb_L1_23_6 d1bar_L2 vcn ctp_L1_23 0 NSYN W=10u L=1u
MnTa_L1_23_6 dpre_L2_25 vcn ctn_L1_23 0 NSYN W=10u L=1u
MpTb_L1_23_6 d1bar_L2 gp_2_25_7 ctn_L1_23 0 NSYN W=10u L=1u
MpTa_L1_23_7 dpre_L2_27 gp_2_27_9 ctp_L1_23 0 NSYN W=10u L=1u
MnTb_L1_23_7 d1bar_L2 vcn ctp_L1_23 0 NSYN W=10u L=1u
MnTa_L1_23_7 dpre_L2_27 vcn ctn_L1_23 0 NSYN W=10u L=1u
MpTb_L1_23_7 d1bar_L2 gp_2_27_9 ctn_L1_23 0 NSYN W=10u L=1u
MpTa_L1_23_8 dpre_L2_29 gp_2_29_5 ctp_L1_23 0 NSYN W=10u L=1u
MnTb_L1_23_8 d1bar_L2 vcn ctp_L1_23 0 NSYN W=10u L=1u
MnTa_L1_23_8 dpre_L2_29 vcn ctn_L1_23 0 NSYN W=10u L=1u
MpTb_L1_23_8 d1bar_L2 gp_2_29_5 ctn_L1_23 0 NSYN W=10u L=1u
MpTa_L1_23_9 dpre_L2_36 gp_2_36_7 ctp_L1_23 0 NSYN W=10u L=1u
MnTb_L1_23_9 d1bar_L2 vcn ctp_L1_23 0 NSYN W=10u L=1u
MnTa_L1_23_9 dpre_L2_36 vcn ctn_L1_23 0 NSYN W=10u L=1u
MpTb_L1_23_9 d1bar_L2 gp_2_36_7 ctn_L1_23 0 NSYN W=10u L=1u
MpTa_L1_23_10 dpre_L2_38 gp_2_38_6 ctp_L1_23 0 NSYN W=10u L=1u
MnTb_L1_23_10 d1bar_L2 vcn ctp_L1_23 0 NSYN W=10u L=1u
MnTa_L1_23_10 dpre_L2_38 vcn ctn_L1_23 0 NSYN W=10u L=1u
MpTb_L1_23_10 d1bar_L2 gp_2_38_6 ctn_L1_23 0 NSYN W=10u L=1u
MpTa_L1_23_11 dpre_L2_40 gp_2_40_8 ctp_L1_23 0 NSYN W=10u L=1u
MnTb_L1_23_11 d1bar_L2 vcn ctp_L1_23 0 NSYN W=10u L=1u
MnTa_L1_23_11 dpre_L2_40 vcn ctn_L1_23 0 NSYN W=10u L=1u
MpTb_L1_23_11 d1bar_L2 gp_2_40_8 ctn_L1_23 0 NSYN W=10u L=1u
MpTa_L1_23_12 dpre_L2_41 gp_2_41_10 ctp_L1_23 0 NSYN W=10u L=1u
MnTb_L1_23_12 d1bar_L2 vcn ctp_L1_23 0 NSYN W=10u L=1u
MnTa_L1_23_12 dpre_L2_41 vcn ctn_L1_23 0 NSYN W=10u L=1u
MpTb_L1_23_12 d1bar_L2 gp_2_41_10 ctn_L1_23 0 NSYN W=10u L=1u
MpTa_L1_23_13 dpre_L2_43 gp_2_43_8 ctp_L1_23 0 NSYN W=10u L=1u
MnTb_L1_23_13 d1bar_L2 vcn ctp_L1_23 0 NSYN W=10u L=1u
MnTa_L1_23_13 dpre_L2_43 vcn ctn_L1_23 0 NSYN W=10u L=1u
MpTb_L1_23_13 d1bar_L2 gp_2_43_8 ctn_L1_23 0 NSYN W=10u L=1u
MpTa_L1_23_14 dpre_L2_46 gp_2_46_8 ctp_L1_23 0 NSYN W=10u L=1u
MnTb_L1_23_14 d1bar_L2 vcn ctp_L1_23 0 NSYN W=10u L=1u
MnTa_L1_23_14 dpre_L2_46 vcn ctn_L1_23 0 NSYN W=10u L=1u
MpTb_L1_23_14 d1bar_L2 gp_2_46_8 ctn_L1_23 0 NSYN W=10u L=1u
Msa_bk_L1_23 ctn_L1_23 ctn_L1_23 0 0 NMIR W=20u L=1u
Msb_bk_L1_23 dpre_L1_23 ctn_L1_23 0 0 NMIR W=20u L=1u
Msc_bk_L1_23 ctp_L1_23 ctp_L1_23 0 0 NMIR W=20u L=1u
Msd_bk_L1_23 dpf_bk_L1_23 ctp_L1_23 0 0 NMIR W=20u L=1u
Mse_bk_L1_23 dpf_bk_L1_23 dpf_bk_L1_23 vdd vdd PMIR W=60u L=1u
Msf_bk_L1_23 dpre_L1_23 dpf_bk_L1_23 vdd vdd PMIR W=60u L=1u
R_bk_L1_23 dpre_L1_23 vrefd 16000.0
MpTa_L1_24_0 dpre_L2_0 gp_2_0_7 ctp_L1_24 0 NSYN W=10u L=1u
MnTb_L1_24_0 d1bar_L2 vcn ctp_L1_24 0 NSYN W=10u L=1u
MnTa_L1_24_0 dpre_L2_0 vcn ctn_L1_24 0 NSYN W=10u L=1u
MpTb_L1_24_0 d1bar_L2 gp_2_0_7 ctn_L1_24 0 NSYN W=10u L=1u
MpTa_L1_24_1 dpre_L2_3 gp_2_3_9 ctp_L1_24 0 NSYN W=10u L=1u
MnTb_L1_24_1 d1bar_L2 vcn ctp_L1_24 0 NSYN W=10u L=1u
MnTa_L1_24_1 dpre_L2_3 vcn ctn_L1_24 0 NSYN W=10u L=1u
MpTb_L1_24_1 d1bar_L2 gp_2_3_9 ctn_L1_24 0 NSYN W=10u L=1u
MpTa_L1_24_2 dpre_L2_7 gp_2_7_10 ctp_L1_24 0 NSYN W=10u L=1u
MnTb_L1_24_2 d1bar_L2 vcn ctp_L1_24 0 NSYN W=10u L=1u
MnTa_L1_24_2 dpre_L2_7 vcn ctn_L1_24 0 NSYN W=10u L=1u
MpTb_L1_24_2 d1bar_L2 gp_2_7_10 ctn_L1_24 0 NSYN W=10u L=1u
MpTa_L1_24_3 dpre_L2_11 gp_2_11_10 ctp_L1_24 0 NSYN W=10u L=1u
MnTb_L1_24_3 d1bar_L2 vcn ctp_L1_24 0 NSYN W=10u L=1u
MnTa_L1_24_3 dpre_L2_11 vcn ctn_L1_24 0 NSYN W=10u L=1u
MpTb_L1_24_3 d1bar_L2 gp_2_11_10 ctn_L1_24 0 NSYN W=10u L=1u
MpTa_L1_24_4 dpre_L2_14 gp_2_14_9 ctp_L1_24 0 NSYN W=10u L=1u
MnTb_L1_24_4 d1bar_L2 vcn ctp_L1_24 0 NSYN W=10u L=1u
MnTa_L1_24_4 dpre_L2_14 vcn ctn_L1_24 0 NSYN W=10u L=1u
MpTb_L1_24_4 d1bar_L2 gp_2_14_9 ctn_L1_24 0 NSYN W=10u L=1u
MpTa_L1_24_5 dpre_L2_16 gp_2_16_8 ctp_L1_24 0 NSYN W=10u L=1u
MnTb_L1_24_5 d1bar_L2 vcn ctp_L1_24 0 NSYN W=10u L=1u
MnTa_L1_24_5 dpre_L2_16 vcn ctn_L1_24 0 NSYN W=10u L=1u
MpTb_L1_24_5 d1bar_L2 gp_2_16_8 ctn_L1_24 0 NSYN W=10u L=1u
MpTa_L1_24_6 dpre_L2_26 gp_2_26_7 ctp_L1_24 0 NSYN W=10u L=1u
MnTb_L1_24_6 d1bar_L2 vcn ctp_L1_24 0 NSYN W=10u L=1u
MnTa_L1_24_6 dpre_L2_26 vcn ctn_L1_24 0 NSYN W=10u L=1u
MpTb_L1_24_6 d1bar_L2 gp_2_26_7 ctn_L1_24 0 NSYN W=10u L=1u
MpTa_L1_24_7 dpre_L2_35 gp_2_35_6 ctp_L1_24 0 NSYN W=10u L=1u
MnTb_L1_24_7 d1bar_L2 vcn ctp_L1_24 0 NSYN W=10u L=1u
MnTa_L1_24_7 dpre_L2_35 vcn ctn_L1_24 0 NSYN W=10u L=1u
MpTb_L1_24_7 d1bar_L2 gp_2_35_6 ctn_L1_24 0 NSYN W=10u L=1u
MpTa_L1_24_8 dpre_L2_36 gp_2_36_8 ctp_L1_24 0 NSYN W=10u L=1u
MnTb_L1_24_8 d1bar_L2 vcn ctp_L1_24 0 NSYN W=10u L=1u
MnTa_L1_24_8 dpre_L2_36 vcn ctn_L1_24 0 NSYN W=10u L=1u
MpTb_L1_24_8 d1bar_L2 gp_2_36_8 ctn_L1_24 0 NSYN W=10u L=1u
MpTa_L1_24_9 dpre_L2_39 gp_2_39_10 ctp_L1_24 0 NSYN W=10u L=1u
MnTb_L1_24_9 d1bar_L2 vcn ctp_L1_24 0 NSYN W=10u L=1u
MnTa_L1_24_9 dpre_L2_39 vcn ctn_L1_24 0 NSYN W=10u L=1u
MpTb_L1_24_9 d1bar_L2 gp_2_39_10 ctn_L1_24 0 NSYN W=10u L=1u
Msa_bk_L1_24 ctn_L1_24 ctn_L1_24 0 0 NMIR W=20u L=1u
Msb_bk_L1_24 dpre_L1_24 ctn_L1_24 0 0 NMIR W=20u L=1u
Msc_bk_L1_24 ctp_L1_24 ctp_L1_24 0 0 NMIR W=20u L=1u
Msd_bk_L1_24 dpf_bk_L1_24 ctp_L1_24 0 0 NMIR W=20u L=1u
Mse_bk_L1_24 dpf_bk_L1_24 dpf_bk_L1_24 vdd vdd PMIR W=60u L=1u
Msf_bk_L1_24 dpre_L1_24 dpf_bk_L1_24 vdd vdd PMIR W=60u L=1u
R_bk_L1_24 dpre_L1_24 vrefd 16000.0
MpTa_L1_25_0 dpre_L2_0 gp_2_0_8 ctp_L1_25 0 NSYN W=10u L=1u
MnTb_L1_25_0 d1bar_L2 vcn ctp_L1_25 0 NSYN W=10u L=1u
MnTa_L1_25_0 dpre_L2_0 vcn ctn_L1_25 0 NSYN W=10u L=1u
MpTb_L1_25_0 d1bar_L2 gp_2_0_8 ctn_L1_25 0 NSYN W=10u L=1u
MpTa_L1_25_1 dpre_L2_1 gp_2_1_9 ctp_L1_25 0 NSYN W=10u L=1u
MnTb_L1_25_1 d1bar_L2 vcn ctp_L1_25 0 NSYN W=10u L=1u
MnTa_L1_25_1 dpre_L2_1 vcn ctn_L1_25 0 NSYN W=10u L=1u
MpTb_L1_25_1 d1bar_L2 gp_2_1_9 ctn_L1_25 0 NSYN W=10u L=1u
MpTa_L1_25_2 dpre_L2_4 gp_2_4_7 ctp_L1_25 0 NSYN W=10u L=1u
MnTb_L1_25_2 d1bar_L2 vcn ctp_L1_25 0 NSYN W=10u L=1u
MnTa_L1_25_2 dpre_L2_4 vcn ctn_L1_25 0 NSYN W=10u L=1u
MpTb_L1_25_2 d1bar_L2 gp_2_4_7 ctn_L1_25 0 NSYN W=10u L=1u
MpTa_L1_25_3 dpre_L2_7 gp_2_7_11 ctp_L1_25 0 NSYN W=10u L=1u
MnTb_L1_25_3 d1bar_L2 vcn ctp_L1_25 0 NSYN W=10u L=1u
MnTa_L1_25_3 dpre_L2_7 vcn ctn_L1_25 0 NSYN W=10u L=1u
MpTb_L1_25_3 d1bar_L2 gp_2_7_11 ctn_L1_25 0 NSYN W=10u L=1u
MpTa_L1_25_4 dpre_L2_12 gp_2_12_8 ctp_L1_25 0 NSYN W=10u L=1u
MnTb_L1_25_4 d1bar_L2 vcn ctp_L1_25 0 NSYN W=10u L=1u
MnTa_L1_25_4 dpre_L2_12 vcn ctn_L1_25 0 NSYN W=10u L=1u
MpTb_L1_25_4 d1bar_L2 gp_2_12_8 ctn_L1_25 0 NSYN W=10u L=1u
MpTa_L1_25_5 dpre_L2_13 gp_2_13_8 ctp_L1_25 0 NSYN W=10u L=1u
MnTb_L1_25_5 d1bar_L2 vcn ctp_L1_25 0 NSYN W=10u L=1u
MnTa_L1_25_5 dpre_L2_13 vcn ctn_L1_25 0 NSYN W=10u L=1u
MpTb_L1_25_5 d1bar_L2 gp_2_13_8 ctn_L1_25 0 NSYN W=10u L=1u
MpTa_L1_25_6 dpre_L2_18 gp_2_18_7 ctp_L1_25 0 NSYN W=10u L=1u
MnTb_L1_25_6 d1bar_L2 vcn ctp_L1_25 0 NSYN W=10u L=1u
MnTa_L1_25_6 dpre_L2_18 vcn ctn_L1_25 0 NSYN W=10u L=1u
MpTb_L1_25_6 d1bar_L2 gp_2_18_7 ctn_L1_25 0 NSYN W=10u L=1u
MpTa_L1_25_7 dpre_L2_19 gp_2_19_7 ctp_L1_25 0 NSYN W=10u L=1u
MnTb_L1_25_7 d1bar_L2 vcn ctp_L1_25 0 NSYN W=10u L=1u
MnTa_L1_25_7 dpre_L2_19 vcn ctn_L1_25 0 NSYN W=10u L=1u
MpTb_L1_25_7 d1bar_L2 gp_2_19_7 ctn_L1_25 0 NSYN W=10u L=1u
MpTa_L1_25_8 dpre_L2_25 gp_2_25_8 ctp_L1_25 0 NSYN W=10u L=1u
MnTb_L1_25_8 d1bar_L2 vcn ctp_L1_25 0 NSYN W=10u L=1u
MnTa_L1_25_8 dpre_L2_25 vcn ctn_L1_25 0 NSYN W=10u L=1u
MpTb_L1_25_8 d1bar_L2 gp_2_25_8 ctn_L1_25 0 NSYN W=10u L=1u
MpTa_L1_25_9 dpre_L2_27 gp_2_27_10 ctp_L1_25 0 NSYN W=10u L=1u
MnTb_L1_25_9 d1bar_L2 vcn ctp_L1_25 0 NSYN W=10u L=1u
MnTa_L1_25_9 dpre_L2_27 vcn ctn_L1_25 0 NSYN W=10u L=1u
MpTb_L1_25_9 d1bar_L2 gp_2_27_10 ctn_L1_25 0 NSYN W=10u L=1u
MpTa_L1_25_10 dpre_L2_32 gp_2_32_5 ctp_L1_25 0 NSYN W=10u L=1u
MnTb_L1_25_10 d1bar_L2 vcn ctp_L1_25 0 NSYN W=10u L=1u
MnTa_L1_25_10 dpre_L2_32 vcn ctn_L1_25 0 NSYN W=10u L=1u
MpTb_L1_25_10 d1bar_L2 gp_2_32_5 ctn_L1_25 0 NSYN W=10u L=1u
MpTa_L1_25_11 dpre_L2_33 gp_2_33_7 ctp_L1_25 0 NSYN W=10u L=1u
MnTb_L1_25_11 d1bar_L2 vcn ctp_L1_25 0 NSYN W=10u L=1u
MnTa_L1_25_11 dpre_L2_33 vcn ctn_L1_25 0 NSYN W=10u L=1u
MpTb_L1_25_11 d1bar_L2 gp_2_33_7 ctn_L1_25 0 NSYN W=10u L=1u
MpTa_L1_25_12 dpre_L2_35 gp_2_35_7 ctp_L1_25 0 NSYN W=10u L=1u
MnTb_L1_25_12 d1bar_L2 vcn ctp_L1_25 0 NSYN W=10u L=1u
MnTa_L1_25_12 dpre_L2_35 vcn ctn_L1_25 0 NSYN W=10u L=1u
MpTb_L1_25_12 d1bar_L2 gp_2_35_7 ctn_L1_25 0 NSYN W=10u L=1u
MpTa_L1_25_13 dpre_L2_36 gp_2_36_9 ctp_L1_25 0 NSYN W=10u L=1u
MnTb_L1_25_13 d1bar_L2 vcn ctp_L1_25 0 NSYN W=10u L=1u
MnTa_L1_25_13 dpre_L2_36 vcn ctn_L1_25 0 NSYN W=10u L=1u
MpTb_L1_25_13 d1bar_L2 gp_2_36_9 ctn_L1_25 0 NSYN W=10u L=1u
MpTa_L1_25_14 dpre_L2_38 gp_2_38_7 ctp_L1_25 0 NSYN W=10u L=1u
MnTb_L1_25_14 d1bar_L2 vcn ctp_L1_25 0 NSYN W=10u L=1u
MnTa_L1_25_14 dpre_L2_38 vcn ctn_L1_25 0 NSYN W=10u L=1u
MpTb_L1_25_14 d1bar_L2 gp_2_38_7 ctn_L1_25 0 NSYN W=10u L=1u
MpTa_L1_25_15 dpre_L2_44 gp_2_44_10 ctp_L1_25 0 NSYN W=10u L=1u
MnTb_L1_25_15 d1bar_L2 vcn ctp_L1_25 0 NSYN W=10u L=1u
MnTa_L1_25_15 dpre_L2_44 vcn ctn_L1_25 0 NSYN W=10u L=1u
MpTb_L1_25_15 d1bar_L2 gp_2_44_10 ctn_L1_25 0 NSYN W=10u L=1u
MpTa_L1_25_16 dpre_L2_47 gp_2_47_9 ctp_L1_25 0 NSYN W=10u L=1u
MnTb_L1_25_16 d1bar_L2 vcn ctp_L1_25 0 NSYN W=10u L=1u
MnTa_L1_25_16 dpre_L2_47 vcn ctn_L1_25 0 NSYN W=10u L=1u
MpTb_L1_25_16 d1bar_L2 gp_2_47_9 ctn_L1_25 0 NSYN W=10u L=1u
Msa_bk_L1_25 ctn_L1_25 ctn_L1_25 0 0 NMIR W=20u L=1u
Msb_bk_L1_25 dpre_L1_25 ctn_L1_25 0 0 NMIR W=20u L=1u
Msc_bk_L1_25 ctp_L1_25 ctp_L1_25 0 0 NMIR W=20u L=1u
Msd_bk_L1_25 dpf_bk_L1_25 ctp_L1_25 0 0 NMIR W=20u L=1u
Mse_bk_L1_25 dpf_bk_L1_25 dpf_bk_L1_25 vdd vdd PMIR W=60u L=1u
Msf_bk_L1_25 dpre_L1_25 dpf_bk_L1_25 vdd vdd PMIR W=60u L=1u
R_bk_L1_25 dpre_L1_25 vrefd 16000.0
MpTa_L1_26_0 dpre_L2_5 gp_2_5_8 ctp_L1_26 0 NSYN W=10u L=1u
MnTb_L1_26_0 d1bar_L2 vcn ctp_L1_26 0 NSYN W=10u L=1u
MnTa_L1_26_0 dpre_L2_5 vcn ctn_L1_26 0 NSYN W=10u L=1u
MpTb_L1_26_0 d1bar_L2 gp_2_5_8 ctn_L1_26 0 NSYN W=10u L=1u
MpTa_L1_26_1 dpre_L2_10 gp_2_10_9 ctp_L1_26 0 NSYN W=10u L=1u
MnTb_L1_26_1 d1bar_L2 vcn ctp_L1_26 0 NSYN W=10u L=1u
MnTa_L1_26_1 dpre_L2_10 vcn ctn_L1_26 0 NSYN W=10u L=1u
MpTb_L1_26_1 d1bar_L2 gp_2_10_9 ctn_L1_26 0 NSYN W=10u L=1u
MpTa_L1_26_2 dpre_L2_11 gp_2_11_11 ctp_L1_26 0 NSYN W=10u L=1u
MnTb_L1_26_2 d1bar_L2 vcn ctp_L1_26 0 NSYN W=10u L=1u
MnTa_L1_26_2 dpre_L2_11 vcn ctn_L1_26 0 NSYN W=10u L=1u
MpTb_L1_26_2 d1bar_L2 gp_2_11_11 ctn_L1_26 0 NSYN W=10u L=1u
MpTa_L1_26_3 dpre_L2_15 gp_2_15_6 ctp_L1_26 0 NSYN W=10u L=1u
MnTb_L1_26_3 d1bar_L2 vcn ctp_L1_26 0 NSYN W=10u L=1u
MnTa_L1_26_3 dpre_L2_15 vcn ctn_L1_26 0 NSYN W=10u L=1u
MpTb_L1_26_3 d1bar_L2 gp_2_15_6 ctn_L1_26 0 NSYN W=10u L=1u
MpTa_L1_26_4 dpre_L2_17 gp_2_17_10 ctp_L1_26 0 NSYN W=10u L=1u
MnTb_L1_26_4 d1bar_L2 vcn ctp_L1_26 0 NSYN W=10u L=1u
MnTa_L1_26_4 dpre_L2_17 vcn ctn_L1_26 0 NSYN W=10u L=1u
MpTb_L1_26_4 d1bar_L2 gp_2_17_10 ctn_L1_26 0 NSYN W=10u L=1u
MpTa_L1_26_5 dpre_L2_21 gp_2_21_8 ctp_L1_26 0 NSYN W=10u L=1u
MnTb_L1_26_5 d1bar_L2 vcn ctp_L1_26 0 NSYN W=10u L=1u
MnTa_L1_26_5 dpre_L2_21 vcn ctn_L1_26 0 NSYN W=10u L=1u
MpTb_L1_26_5 d1bar_L2 gp_2_21_8 ctn_L1_26 0 NSYN W=10u L=1u
MpTa_L1_26_6 dpre_L2_23 gp_2_23_8 ctp_L1_26 0 NSYN W=10u L=1u
MnTb_L1_26_6 d1bar_L2 vcn ctp_L1_26 0 NSYN W=10u L=1u
MnTa_L1_26_6 dpre_L2_23 vcn ctn_L1_26 0 NSYN W=10u L=1u
MpTb_L1_26_6 d1bar_L2 gp_2_23_8 ctn_L1_26 0 NSYN W=10u L=1u
MpTa_L1_26_7 dpre_L2_24 gp_2_24_7 ctp_L1_26 0 NSYN W=10u L=1u
MnTb_L1_26_7 d1bar_L2 vcn ctp_L1_26 0 NSYN W=10u L=1u
MnTa_L1_26_7 dpre_L2_24 vcn ctn_L1_26 0 NSYN W=10u L=1u
MpTb_L1_26_7 d1bar_L2 gp_2_24_7 ctn_L1_26 0 NSYN W=10u L=1u
MpTa_L1_26_8 dpre_L2_27 gp_2_27_11 ctp_L1_26 0 NSYN W=10u L=1u
MnTb_L1_26_8 d1bar_L2 vcn ctp_L1_26 0 NSYN W=10u L=1u
MnTa_L1_26_8 dpre_L2_27 vcn ctn_L1_26 0 NSYN W=10u L=1u
MpTb_L1_26_8 d1bar_L2 gp_2_27_11 ctn_L1_26 0 NSYN W=10u L=1u
MpTa_L1_26_9 dpre_L2_28 gp_2_28_7 ctp_L1_26 0 NSYN W=10u L=1u
MnTb_L1_26_9 d1bar_L2 vcn ctp_L1_26 0 NSYN W=10u L=1u
MnTa_L1_26_9 dpre_L2_28 vcn ctn_L1_26 0 NSYN W=10u L=1u
MpTb_L1_26_9 d1bar_L2 gp_2_28_7 ctn_L1_26 0 NSYN W=10u L=1u
MpTa_L1_26_10 dpre_L2_34 gp_2_34_8 ctp_L1_26 0 NSYN W=10u L=1u
MnTb_L1_26_10 d1bar_L2 vcn ctp_L1_26 0 NSYN W=10u L=1u
MnTa_L1_26_10 dpre_L2_34 vcn ctn_L1_26 0 NSYN W=10u L=1u
MpTb_L1_26_10 d1bar_L2 gp_2_34_8 ctn_L1_26 0 NSYN W=10u L=1u
MpTa_L1_26_11 dpre_L2_35 gp_2_35_8 ctp_L1_26 0 NSYN W=10u L=1u
MnTb_L1_26_11 d1bar_L2 vcn ctp_L1_26 0 NSYN W=10u L=1u
MnTa_L1_26_11 dpre_L2_35 vcn ctn_L1_26 0 NSYN W=10u L=1u
MpTb_L1_26_11 d1bar_L2 gp_2_35_8 ctn_L1_26 0 NSYN W=10u L=1u
MpTa_L1_26_12 dpre_L2_40 gp_2_40_9 ctp_L1_26 0 NSYN W=10u L=1u
MnTb_L1_26_12 d1bar_L2 vcn ctp_L1_26 0 NSYN W=10u L=1u
MnTa_L1_26_12 dpre_L2_40 vcn ctn_L1_26 0 NSYN W=10u L=1u
MpTb_L1_26_12 d1bar_L2 gp_2_40_9 ctn_L1_26 0 NSYN W=10u L=1u
MpTa_L1_26_13 dpre_L2_45 gp_2_45_8 ctp_L1_26 0 NSYN W=10u L=1u
MnTb_L1_26_13 d1bar_L2 vcn ctp_L1_26 0 NSYN W=10u L=1u
MnTa_L1_26_13 dpre_L2_45 vcn ctn_L1_26 0 NSYN W=10u L=1u
MpTb_L1_26_13 d1bar_L2 gp_2_45_8 ctn_L1_26 0 NSYN W=10u L=1u
MpTa_L1_26_14 dpre_L2_46 gp_2_46_9 ctp_L1_26 0 NSYN W=10u L=1u
MnTb_L1_26_14 d1bar_L2 vcn ctp_L1_26 0 NSYN W=10u L=1u
MnTa_L1_26_14 dpre_L2_46 vcn ctn_L1_26 0 NSYN W=10u L=1u
MpTb_L1_26_14 d1bar_L2 gp_2_46_9 ctn_L1_26 0 NSYN W=10u L=1u
Msa_bk_L1_26 ctn_L1_26 ctn_L1_26 0 0 NMIR W=20u L=1u
Msb_bk_L1_26 dpre_L1_26 ctn_L1_26 0 0 NMIR W=20u L=1u
Msc_bk_L1_26 ctp_L1_26 ctp_L1_26 0 0 NMIR W=20u L=1u
Msd_bk_L1_26 dpf_bk_L1_26 ctp_L1_26 0 0 NMIR W=20u L=1u
Mse_bk_L1_26 dpf_bk_L1_26 dpf_bk_L1_26 vdd vdd PMIR W=60u L=1u
Msf_bk_L1_26 dpre_L1_26 dpf_bk_L1_26 vdd vdd PMIR W=60u L=1u
R_bk_L1_26 dpre_L1_26 vrefd 16000.0
MpTa_L1_27_0 dpre_L2_4 gp_2_4_8 ctp_L1_27 0 NSYN W=10u L=1u
MnTb_L1_27_0 d1bar_L2 vcn ctp_L1_27 0 NSYN W=10u L=1u
MnTa_L1_27_0 dpre_L2_4 vcn ctn_L1_27 0 NSYN W=10u L=1u
MpTb_L1_27_0 d1bar_L2 gp_2_4_8 ctn_L1_27 0 NSYN W=10u L=1u
MpTa_L1_27_1 dpre_L2_6 gp_2_6_8 ctp_L1_27 0 NSYN W=10u L=1u
MnTb_L1_27_1 d1bar_L2 vcn ctp_L1_27 0 NSYN W=10u L=1u
MnTa_L1_27_1 dpre_L2_6 vcn ctn_L1_27 0 NSYN W=10u L=1u
MpTb_L1_27_1 d1bar_L2 gp_2_6_8 ctn_L1_27 0 NSYN W=10u L=1u
MpTa_L1_27_2 dpre_L2_8 gp_2_8_7 ctp_L1_27 0 NSYN W=10u L=1u
MnTb_L1_27_2 d1bar_L2 vcn ctp_L1_27 0 NSYN W=10u L=1u
MnTa_L1_27_2 dpre_L2_8 vcn ctn_L1_27 0 NSYN W=10u L=1u
MpTb_L1_27_2 d1bar_L2 gp_2_8_7 ctn_L1_27 0 NSYN W=10u L=1u
MpTa_L1_27_3 dpre_L2_15 gp_2_15_7 ctp_L1_27 0 NSYN W=10u L=1u
MnTb_L1_27_3 d1bar_L2 vcn ctp_L1_27 0 NSYN W=10u L=1u
MnTa_L1_27_3 dpre_L2_15 vcn ctn_L1_27 0 NSYN W=10u L=1u
MpTb_L1_27_3 d1bar_L2 gp_2_15_7 ctn_L1_27 0 NSYN W=10u L=1u
MpTa_L1_27_4 dpre_L2_16 gp_2_16_9 ctp_L1_27 0 NSYN W=10u L=1u
MnTb_L1_27_4 d1bar_L2 vcn ctp_L1_27 0 NSYN W=10u L=1u
MnTa_L1_27_4 dpre_L2_16 vcn ctn_L1_27 0 NSYN W=10u L=1u
MpTb_L1_27_4 d1bar_L2 gp_2_16_9 ctn_L1_27 0 NSYN W=10u L=1u
MpTa_L1_27_5 dpre_L2_18 gp_2_18_8 ctp_L1_27 0 NSYN W=10u L=1u
MnTb_L1_27_5 d1bar_L2 vcn ctp_L1_27 0 NSYN W=10u L=1u
MnTa_L1_27_5 dpre_L2_18 vcn ctn_L1_27 0 NSYN W=10u L=1u
MpTb_L1_27_5 d1bar_L2 gp_2_18_8 ctn_L1_27 0 NSYN W=10u L=1u
MpTa_L1_27_6 dpre_L2_19 gp_2_19_8 ctp_L1_27 0 NSYN W=10u L=1u
MnTb_L1_27_6 d1bar_L2 vcn ctp_L1_27 0 NSYN W=10u L=1u
MnTa_L1_27_6 dpre_L2_19 vcn ctn_L1_27 0 NSYN W=10u L=1u
MpTb_L1_27_6 d1bar_L2 gp_2_19_8 ctn_L1_27 0 NSYN W=10u L=1u
MpTa_L1_27_7 dpre_L2_20 gp_2_20_10 ctp_L1_27 0 NSYN W=10u L=1u
MnTb_L1_27_7 d1bar_L2 vcn ctp_L1_27 0 NSYN W=10u L=1u
MnTa_L1_27_7 dpre_L2_20 vcn ctn_L1_27 0 NSYN W=10u L=1u
MpTb_L1_27_7 d1bar_L2 gp_2_20_10 ctn_L1_27 0 NSYN W=10u L=1u
MpTa_L1_27_8 dpre_L2_27 gp_2_27_12 ctp_L1_27 0 NSYN W=10u L=1u
MnTb_L1_27_8 d1bar_L2 vcn ctp_L1_27 0 NSYN W=10u L=1u
MnTa_L1_27_8 dpre_L2_27 vcn ctn_L1_27 0 NSYN W=10u L=1u
MpTb_L1_27_8 d1bar_L2 gp_2_27_12 ctn_L1_27 0 NSYN W=10u L=1u
MpTa_L1_27_9 dpre_L2_28 gp_2_28_8 ctp_L1_27 0 NSYN W=10u L=1u
MnTb_L1_27_9 d1bar_L2 vcn ctp_L1_27 0 NSYN W=10u L=1u
MnTa_L1_27_9 dpre_L2_28 vcn ctn_L1_27 0 NSYN W=10u L=1u
MpTb_L1_27_9 d1bar_L2 gp_2_28_8 ctn_L1_27 0 NSYN W=10u L=1u
MpTa_L1_27_10 dpre_L2_31 gp_2_31_8 ctp_L1_27 0 NSYN W=10u L=1u
MnTb_L1_27_10 d1bar_L2 vcn ctp_L1_27 0 NSYN W=10u L=1u
MnTa_L1_27_10 dpre_L2_31 vcn ctn_L1_27 0 NSYN W=10u L=1u
MpTb_L1_27_10 d1bar_L2 gp_2_31_8 ctn_L1_27 0 NSYN W=10u L=1u
MpTa_L1_27_11 dpre_L2_37 gp_2_37_8 ctp_L1_27 0 NSYN W=10u L=1u
MnTb_L1_27_11 d1bar_L2 vcn ctp_L1_27 0 NSYN W=10u L=1u
MnTa_L1_27_11 dpre_L2_37 vcn ctn_L1_27 0 NSYN W=10u L=1u
MpTb_L1_27_11 d1bar_L2 gp_2_37_8 ctn_L1_27 0 NSYN W=10u L=1u
MpTa_L1_27_12 dpre_L2_38 gp_2_38_8 ctp_L1_27 0 NSYN W=10u L=1u
MnTb_L1_27_12 d1bar_L2 vcn ctp_L1_27 0 NSYN W=10u L=1u
MnTa_L1_27_12 dpre_L2_38 vcn ctn_L1_27 0 NSYN W=10u L=1u
MpTb_L1_27_12 d1bar_L2 gp_2_38_8 ctn_L1_27 0 NSYN W=10u L=1u
MpTa_L1_27_13 dpre_L2_43 gp_2_43_9 ctp_L1_27 0 NSYN W=10u L=1u
MnTb_L1_27_13 d1bar_L2 vcn ctp_L1_27 0 NSYN W=10u L=1u
MnTa_L1_27_13 dpre_L2_43 vcn ctn_L1_27 0 NSYN W=10u L=1u
MpTb_L1_27_13 d1bar_L2 gp_2_43_9 ctn_L1_27 0 NSYN W=10u L=1u
Msa_bk_L1_27 ctn_L1_27 ctn_L1_27 0 0 NMIR W=20u L=1u
Msb_bk_L1_27 dpre_L1_27 ctn_L1_27 0 0 NMIR W=20u L=1u
Msc_bk_L1_27 ctp_L1_27 ctp_L1_27 0 0 NMIR W=20u L=1u
Msd_bk_L1_27 dpf_bk_L1_27 ctp_L1_27 0 0 NMIR W=20u L=1u
Mse_bk_L1_27 dpf_bk_L1_27 dpf_bk_L1_27 vdd vdd PMIR W=60u L=1u
Msf_bk_L1_27 dpre_L1_27 dpf_bk_L1_27 vdd vdd PMIR W=60u L=1u
R_bk_L1_27 dpre_L1_27 vrefd 16000.0
MpTa_L1_28_0 dpre_L2_2 gp_2_2_8 ctp_L1_28 0 NSYN W=10u L=1u
MnTb_L1_28_0 d1bar_L2 vcn ctp_L1_28 0 NSYN W=10u L=1u
MnTa_L1_28_0 dpre_L2_2 vcn ctn_L1_28 0 NSYN W=10u L=1u
MpTb_L1_28_0 d1bar_L2 gp_2_2_8 ctn_L1_28 0 NSYN W=10u L=1u
MpTa_L1_28_1 dpre_L2_4 gp_2_4_9 ctp_L1_28 0 NSYN W=10u L=1u
MnTb_L1_28_1 d1bar_L2 vcn ctp_L1_28 0 NSYN W=10u L=1u
MnTa_L1_28_1 dpre_L2_4 vcn ctn_L1_28 0 NSYN W=10u L=1u
MpTb_L1_28_1 d1bar_L2 gp_2_4_9 ctn_L1_28 0 NSYN W=10u L=1u
MpTa_L1_28_2 dpre_L2_6 gp_2_6_9 ctp_L1_28 0 NSYN W=10u L=1u
MnTb_L1_28_2 d1bar_L2 vcn ctp_L1_28 0 NSYN W=10u L=1u
MnTa_L1_28_2 dpre_L2_6 vcn ctn_L1_28 0 NSYN W=10u L=1u
MpTb_L1_28_2 d1bar_L2 gp_2_6_9 ctn_L1_28 0 NSYN W=10u L=1u
MpTa_L1_28_3 dpre_L2_10 gp_2_10_10 ctp_L1_28 0 NSYN W=10u L=1u
MnTb_L1_28_3 d1bar_L2 vcn ctp_L1_28 0 NSYN W=10u L=1u
MnTa_L1_28_3 dpre_L2_10 vcn ctn_L1_28 0 NSYN W=10u L=1u
MpTb_L1_28_3 d1bar_L2 gp_2_10_10 ctn_L1_28 0 NSYN W=10u L=1u
MpTa_L1_28_4 dpre_L2_24 gp_2_24_8 ctp_L1_28 0 NSYN W=10u L=1u
MnTb_L1_28_4 d1bar_L2 vcn ctp_L1_28 0 NSYN W=10u L=1u
MnTa_L1_28_4 dpre_L2_24 vcn ctn_L1_28 0 NSYN W=10u L=1u
MpTb_L1_28_4 d1bar_L2 gp_2_24_8 ctn_L1_28 0 NSYN W=10u L=1u
MpTa_L1_28_5 dpre_L2_25 gp_2_25_9 ctp_L1_28 0 NSYN W=10u L=1u
MnTb_L1_28_5 d1bar_L2 vcn ctp_L1_28 0 NSYN W=10u L=1u
MnTa_L1_28_5 dpre_L2_25 vcn ctn_L1_28 0 NSYN W=10u L=1u
MpTb_L1_28_5 d1bar_L2 gp_2_25_9 ctn_L1_28 0 NSYN W=10u L=1u
MpTa_L1_28_6 dpre_L2_28 gp_2_28_9 ctp_L1_28 0 NSYN W=10u L=1u
MnTb_L1_28_6 d1bar_L2 vcn ctp_L1_28 0 NSYN W=10u L=1u
MnTa_L1_28_6 dpre_L2_28 vcn ctn_L1_28 0 NSYN W=10u L=1u
MpTb_L1_28_6 d1bar_L2 gp_2_28_9 ctn_L1_28 0 NSYN W=10u L=1u
MpTa_L1_28_7 dpre_L2_31 gp_2_31_9 ctp_L1_28 0 NSYN W=10u L=1u
MnTb_L1_28_7 d1bar_L2 vcn ctp_L1_28 0 NSYN W=10u L=1u
MnTa_L1_28_7 dpre_L2_31 vcn ctn_L1_28 0 NSYN W=10u L=1u
MpTb_L1_28_7 d1bar_L2 gp_2_31_9 ctn_L1_28 0 NSYN W=10u L=1u
MpTa_L1_28_8 dpre_L2_32 gp_2_32_6 ctp_L1_28 0 NSYN W=10u L=1u
MnTb_L1_28_8 d1bar_L2 vcn ctp_L1_28 0 NSYN W=10u L=1u
MnTa_L1_28_8 dpre_L2_32 vcn ctn_L1_28 0 NSYN W=10u L=1u
MpTb_L1_28_8 d1bar_L2 gp_2_32_6 ctn_L1_28 0 NSYN W=10u L=1u
MpTa_L1_28_9 dpre_L2_44 gp_2_44_11 ctp_L1_28 0 NSYN W=10u L=1u
MnTb_L1_28_9 d1bar_L2 vcn ctp_L1_28 0 NSYN W=10u L=1u
MnTa_L1_28_9 dpre_L2_44 vcn ctn_L1_28 0 NSYN W=10u L=1u
MpTb_L1_28_9 d1bar_L2 gp_2_44_11 ctn_L1_28 0 NSYN W=10u L=1u
Msa_bk_L1_28 ctn_L1_28 ctn_L1_28 0 0 NMIR W=20u L=1u
Msb_bk_L1_28 dpre_L1_28 ctn_L1_28 0 0 NMIR W=20u L=1u
Msc_bk_L1_28 ctp_L1_28 ctp_L1_28 0 0 NMIR W=20u L=1u
Msd_bk_L1_28 dpf_bk_L1_28 ctp_L1_28 0 0 NMIR W=20u L=1u
Mse_bk_L1_28 dpf_bk_L1_28 dpf_bk_L1_28 vdd vdd PMIR W=60u L=1u
Msf_bk_L1_28 dpre_L1_28 dpf_bk_L1_28 vdd vdd PMIR W=60u L=1u
R_bk_L1_28 dpre_L1_28 vrefd 16000.0
MpTa_L1_29_0 dpre_L2_0 gp_2_0_9 ctp_L1_29 0 NSYN W=10u L=1u
MnTb_L1_29_0 d1bar_L2 vcn ctp_L1_29 0 NSYN W=10u L=1u
MnTa_L1_29_0 dpre_L2_0 vcn ctn_L1_29 0 NSYN W=10u L=1u
MpTb_L1_29_0 d1bar_L2 gp_2_0_9 ctn_L1_29 0 NSYN W=10u L=1u
MpTa_L1_29_1 dpre_L2_2 gp_2_2_9 ctp_L1_29 0 NSYN W=10u L=1u
MnTb_L1_29_1 d1bar_L2 vcn ctp_L1_29 0 NSYN W=10u L=1u
MnTa_L1_29_1 dpre_L2_2 vcn ctn_L1_29 0 NSYN W=10u L=1u
MpTb_L1_29_1 d1bar_L2 gp_2_2_9 ctn_L1_29 0 NSYN W=10u L=1u
MpTa_L1_29_2 dpre_L2_5 gp_2_5_9 ctp_L1_29 0 NSYN W=10u L=1u
MnTb_L1_29_2 d1bar_L2 vcn ctp_L1_29 0 NSYN W=10u L=1u
MnTa_L1_29_2 dpre_L2_5 vcn ctn_L1_29 0 NSYN W=10u L=1u
MpTb_L1_29_2 d1bar_L2 gp_2_5_9 ctn_L1_29 0 NSYN W=10u L=1u
MpTa_L1_29_3 dpre_L2_6 gp_2_6_10 ctp_L1_29 0 NSYN W=10u L=1u
MnTb_L1_29_3 d1bar_L2 vcn ctp_L1_29 0 NSYN W=10u L=1u
MnTa_L1_29_3 dpre_L2_6 vcn ctn_L1_29 0 NSYN W=10u L=1u
MpTb_L1_29_3 d1bar_L2 gp_2_6_10 ctn_L1_29 0 NSYN W=10u L=1u
MpTa_L1_29_4 dpre_L2_7 gp_2_7_12 ctp_L1_29 0 NSYN W=10u L=1u
MnTb_L1_29_4 d1bar_L2 vcn ctp_L1_29 0 NSYN W=10u L=1u
MnTa_L1_29_4 dpre_L2_7 vcn ctn_L1_29 0 NSYN W=10u L=1u
MpTb_L1_29_4 d1bar_L2 gp_2_7_12 ctn_L1_29 0 NSYN W=10u L=1u
MpTa_L1_29_5 dpre_L2_10 gp_2_10_11 ctp_L1_29 0 NSYN W=10u L=1u
MnTb_L1_29_5 d1bar_L2 vcn ctp_L1_29 0 NSYN W=10u L=1u
MnTa_L1_29_5 dpre_L2_10 vcn ctn_L1_29 0 NSYN W=10u L=1u
MpTb_L1_29_5 d1bar_L2 gp_2_10_11 ctn_L1_29 0 NSYN W=10u L=1u
MpTa_L1_29_6 dpre_L2_12 gp_2_12_9 ctp_L1_29 0 NSYN W=10u L=1u
MnTb_L1_29_6 d1bar_L2 vcn ctp_L1_29 0 NSYN W=10u L=1u
MnTa_L1_29_6 dpre_L2_12 vcn ctn_L1_29 0 NSYN W=10u L=1u
MpTb_L1_29_6 d1bar_L2 gp_2_12_9 ctn_L1_29 0 NSYN W=10u L=1u
MpTa_L1_29_7 dpre_L2_14 gp_2_14_10 ctp_L1_29 0 NSYN W=10u L=1u
MnTb_L1_29_7 d1bar_L2 vcn ctp_L1_29 0 NSYN W=10u L=1u
MnTa_L1_29_7 dpre_L2_14 vcn ctn_L1_29 0 NSYN W=10u L=1u
MpTb_L1_29_7 d1bar_L2 gp_2_14_10 ctn_L1_29 0 NSYN W=10u L=1u
MpTa_L1_29_8 dpre_L2_18 gp_2_18_9 ctp_L1_29 0 NSYN W=10u L=1u
MnTb_L1_29_8 d1bar_L2 vcn ctp_L1_29 0 NSYN W=10u L=1u
MnTa_L1_29_8 dpre_L2_18 vcn ctn_L1_29 0 NSYN W=10u L=1u
MpTb_L1_29_8 d1bar_L2 gp_2_18_9 ctn_L1_29 0 NSYN W=10u L=1u
MpTa_L1_29_9 dpre_L2_19 gp_2_19_9 ctp_L1_29 0 NSYN W=10u L=1u
MnTb_L1_29_9 d1bar_L2 vcn ctp_L1_29 0 NSYN W=10u L=1u
MnTa_L1_29_9 dpre_L2_19 vcn ctn_L1_29 0 NSYN W=10u L=1u
MpTb_L1_29_9 d1bar_L2 gp_2_19_9 ctn_L1_29 0 NSYN W=10u L=1u
MpTa_L1_29_10 dpre_L2_21 gp_2_21_9 ctp_L1_29 0 NSYN W=10u L=1u
MnTb_L1_29_10 d1bar_L2 vcn ctp_L1_29 0 NSYN W=10u L=1u
MnTa_L1_29_10 dpre_L2_21 vcn ctn_L1_29 0 NSYN W=10u L=1u
MpTb_L1_29_10 d1bar_L2 gp_2_21_9 ctn_L1_29 0 NSYN W=10u L=1u
MpTa_L1_29_11 dpre_L2_24 gp_2_24_9 ctp_L1_29 0 NSYN W=10u L=1u
MnTb_L1_29_11 d1bar_L2 vcn ctp_L1_29 0 NSYN W=10u L=1u
MnTa_L1_29_11 dpre_L2_24 vcn ctn_L1_29 0 NSYN W=10u L=1u
MpTb_L1_29_11 d1bar_L2 gp_2_24_9 ctn_L1_29 0 NSYN W=10u L=1u
MpTa_L1_29_12 dpre_L2_26 gp_2_26_8 ctp_L1_29 0 NSYN W=10u L=1u
MnTb_L1_29_12 d1bar_L2 vcn ctp_L1_29 0 NSYN W=10u L=1u
MnTa_L1_29_12 dpre_L2_26 vcn ctn_L1_29 0 NSYN W=10u L=1u
MpTb_L1_29_12 d1bar_L2 gp_2_26_8 ctn_L1_29 0 NSYN W=10u L=1u
MpTa_L1_29_13 dpre_L2_28 gp_2_28_10 ctp_L1_29 0 NSYN W=10u L=1u
MnTb_L1_29_13 d1bar_L2 vcn ctp_L1_29 0 NSYN W=10u L=1u
MnTa_L1_29_13 dpre_L2_28 vcn ctn_L1_29 0 NSYN W=10u L=1u
MpTb_L1_29_13 d1bar_L2 gp_2_28_10 ctn_L1_29 0 NSYN W=10u L=1u
MpTa_L1_29_14 dpre_L2_31 gp_2_31_10 ctp_L1_29 0 NSYN W=10u L=1u
MnTb_L1_29_14 d1bar_L2 vcn ctp_L1_29 0 NSYN W=10u L=1u
MnTa_L1_29_14 dpre_L2_31 vcn ctn_L1_29 0 NSYN W=10u L=1u
MpTb_L1_29_14 d1bar_L2 gp_2_31_10 ctn_L1_29 0 NSYN W=10u L=1u
MpTa_L1_29_15 dpre_L2_36 gp_2_36_10 ctp_L1_29 0 NSYN W=10u L=1u
MnTb_L1_29_15 d1bar_L2 vcn ctp_L1_29 0 NSYN W=10u L=1u
MnTa_L1_29_15 dpre_L2_36 vcn ctn_L1_29 0 NSYN W=10u L=1u
MpTb_L1_29_15 d1bar_L2 gp_2_36_10 ctn_L1_29 0 NSYN W=10u L=1u
MpTa_L1_29_16 dpre_L2_38 gp_2_38_9 ctp_L1_29 0 NSYN W=10u L=1u
MnTb_L1_29_16 d1bar_L2 vcn ctp_L1_29 0 NSYN W=10u L=1u
MnTa_L1_29_16 dpre_L2_38 vcn ctn_L1_29 0 NSYN W=10u L=1u
MpTb_L1_29_16 d1bar_L2 gp_2_38_9 ctn_L1_29 0 NSYN W=10u L=1u
MpTa_L1_29_17 dpre_L2_47 gp_2_47_10 ctp_L1_29 0 NSYN W=10u L=1u
MnTb_L1_29_17 d1bar_L2 vcn ctp_L1_29 0 NSYN W=10u L=1u
MnTa_L1_29_17 dpre_L2_47 vcn ctn_L1_29 0 NSYN W=10u L=1u
MpTb_L1_29_17 d1bar_L2 gp_2_47_10 ctn_L1_29 0 NSYN W=10u L=1u
Msa_bk_L1_29 ctn_L1_29 ctn_L1_29 0 0 NMIR W=20u L=1u
Msb_bk_L1_29 dpre_L1_29 ctn_L1_29 0 0 NMIR W=20u L=1u
Msc_bk_L1_29 ctp_L1_29 ctp_L1_29 0 0 NMIR W=20u L=1u
Msd_bk_L1_29 dpf_bk_L1_29 ctp_L1_29 0 0 NMIR W=20u L=1u
Mse_bk_L1_29 dpf_bk_L1_29 dpf_bk_L1_29 vdd vdd PMIR W=60u L=1u
Msf_bk_L1_29 dpre_L1_29 dpf_bk_L1_29 vdd vdd PMIR W=60u L=1u
R_bk_L1_29 dpre_L1_29 vrefd 16000.0
MpTa_L1_30_0 dpre_L2_6 gp_2_6_11 ctp_L1_30 0 NSYN W=10u L=1u
MnTb_L1_30_0 d1bar_L2 vcn ctp_L1_30 0 NSYN W=10u L=1u
MnTa_L1_30_0 dpre_L2_6 vcn ctn_L1_30 0 NSYN W=10u L=1u
MpTb_L1_30_0 d1bar_L2 gp_2_6_11 ctn_L1_30 0 NSYN W=10u L=1u
MpTa_L1_30_1 dpre_L2_8 gp_2_8_8 ctp_L1_30 0 NSYN W=10u L=1u
MnTb_L1_30_1 d1bar_L2 vcn ctp_L1_30 0 NSYN W=10u L=1u
MnTa_L1_30_1 dpre_L2_8 vcn ctn_L1_30 0 NSYN W=10u L=1u
MpTb_L1_30_1 d1bar_L2 gp_2_8_8 ctn_L1_30 0 NSYN W=10u L=1u
MpTa_L1_30_2 dpre_L2_9 gp_2_9_9 ctp_L1_30 0 NSYN W=10u L=1u
MnTb_L1_30_2 d1bar_L2 vcn ctp_L1_30 0 NSYN W=10u L=1u
MnTa_L1_30_2 dpre_L2_9 vcn ctn_L1_30 0 NSYN W=10u L=1u
MpTb_L1_30_2 d1bar_L2 gp_2_9_9 ctn_L1_30 0 NSYN W=10u L=1u
MpTa_L1_30_3 dpre_L2_15 gp_2_15_8 ctp_L1_30 0 NSYN W=10u L=1u
MnTb_L1_30_3 d1bar_L2 vcn ctp_L1_30 0 NSYN W=10u L=1u
MnTa_L1_30_3 dpre_L2_15 vcn ctn_L1_30 0 NSYN W=10u L=1u
MpTb_L1_30_3 d1bar_L2 gp_2_15_8 ctn_L1_30 0 NSYN W=10u L=1u
MpTa_L1_30_4 dpre_L2_18 gp_2_18_10 ctp_L1_30 0 NSYN W=10u L=1u
MnTb_L1_30_4 d1bar_L2 vcn ctp_L1_30 0 NSYN W=10u L=1u
MnTa_L1_30_4 dpre_L2_18 vcn ctn_L1_30 0 NSYN W=10u L=1u
MpTb_L1_30_4 d1bar_L2 gp_2_18_10 ctn_L1_30 0 NSYN W=10u L=1u
MpTa_L1_30_5 dpre_L2_22 gp_2_22_8 ctp_L1_30 0 NSYN W=10u L=1u
MnTb_L1_30_5 d1bar_L2 vcn ctp_L1_30 0 NSYN W=10u L=1u
MnTa_L1_30_5 dpre_L2_22 vcn ctn_L1_30 0 NSYN W=10u L=1u
MpTb_L1_30_5 d1bar_L2 gp_2_22_8 ctn_L1_30 0 NSYN W=10u L=1u
MpTa_L1_30_6 dpre_L2_25 gp_2_25_10 ctp_L1_30 0 NSYN W=10u L=1u
MnTb_L1_30_6 d1bar_L2 vcn ctp_L1_30 0 NSYN W=10u L=1u
MnTa_L1_30_6 dpre_L2_25 vcn ctn_L1_30 0 NSYN W=10u L=1u
MpTb_L1_30_6 d1bar_L2 gp_2_25_10 ctn_L1_30 0 NSYN W=10u L=1u
MpTa_L1_30_7 dpre_L2_28 gp_2_28_11 ctp_L1_30 0 NSYN W=10u L=1u
MnTb_L1_30_7 d1bar_L2 vcn ctp_L1_30 0 NSYN W=10u L=1u
MnTa_L1_30_7 dpre_L2_28 vcn ctn_L1_30 0 NSYN W=10u L=1u
MpTb_L1_30_7 d1bar_L2 gp_2_28_11 ctn_L1_30 0 NSYN W=10u L=1u
MpTa_L1_30_8 dpre_L2_31 gp_2_31_11 ctp_L1_30 0 NSYN W=10u L=1u
MnTb_L1_30_8 d1bar_L2 vcn ctp_L1_30 0 NSYN W=10u L=1u
MnTa_L1_30_8 dpre_L2_31 vcn ctn_L1_30 0 NSYN W=10u L=1u
MpTb_L1_30_8 d1bar_L2 gp_2_31_11 ctn_L1_30 0 NSYN W=10u L=1u
MpTa_L1_30_9 dpre_L2_33 gp_2_33_8 ctp_L1_30 0 NSYN W=10u L=1u
MnTb_L1_30_9 d1bar_L2 vcn ctp_L1_30 0 NSYN W=10u L=1u
MnTa_L1_30_9 dpre_L2_33 vcn ctn_L1_30 0 NSYN W=10u L=1u
MpTb_L1_30_9 d1bar_L2 gp_2_33_8 ctn_L1_30 0 NSYN W=10u L=1u
MpTa_L1_30_10 dpre_L2_39 gp_2_39_11 ctp_L1_30 0 NSYN W=10u L=1u
MnTb_L1_30_10 d1bar_L2 vcn ctp_L1_30 0 NSYN W=10u L=1u
MnTa_L1_30_10 dpre_L2_39 vcn ctn_L1_30 0 NSYN W=10u L=1u
MpTb_L1_30_10 d1bar_L2 gp_2_39_11 ctn_L1_30 0 NSYN W=10u L=1u
Msa_bk_L1_30 ctn_L1_30 ctn_L1_30 0 0 NMIR W=20u L=1u
Msb_bk_L1_30 dpre_L1_30 ctn_L1_30 0 0 NMIR W=20u L=1u
Msc_bk_L1_30 ctp_L1_30 ctp_L1_30 0 0 NMIR W=20u L=1u
Msd_bk_L1_30 dpf_bk_L1_30 ctp_L1_30 0 0 NMIR W=20u L=1u
Mse_bk_L1_30 dpf_bk_L1_30 dpf_bk_L1_30 vdd vdd PMIR W=60u L=1u
Msf_bk_L1_30 dpre_L1_30 dpf_bk_L1_30 vdd vdd PMIR W=60u L=1u
R_bk_L1_30 dpre_L1_30 vrefd 16000.0
MpTa_L1_31_0 dpre_L2_4 gp_2_4_10 ctp_L1_31 0 NSYN W=10u L=1u
MnTb_L1_31_0 d1bar_L2 vcn ctp_L1_31 0 NSYN W=10u L=1u
MnTa_L1_31_0 dpre_L2_4 vcn ctn_L1_31 0 NSYN W=10u L=1u
MpTb_L1_31_0 d1bar_L2 gp_2_4_10 ctn_L1_31 0 NSYN W=10u L=1u
MpTa_L1_31_1 dpre_L2_7 gp_2_7_13 ctp_L1_31 0 NSYN W=10u L=1u
MnTb_L1_31_1 d1bar_L2 vcn ctp_L1_31 0 NSYN W=10u L=1u
MnTa_L1_31_1 dpre_L2_7 vcn ctn_L1_31 0 NSYN W=10u L=1u
MpTb_L1_31_1 d1bar_L2 gp_2_7_13 ctn_L1_31 0 NSYN W=10u L=1u
MpTa_L1_31_2 dpre_L2_9 gp_2_9_10 ctp_L1_31 0 NSYN W=10u L=1u
MnTb_L1_31_2 d1bar_L2 vcn ctp_L1_31 0 NSYN W=10u L=1u
MnTa_L1_31_2 dpre_L2_9 vcn ctn_L1_31 0 NSYN W=10u L=1u
MpTb_L1_31_2 d1bar_L2 gp_2_9_10 ctn_L1_31 0 NSYN W=10u L=1u
MpTa_L1_31_3 dpre_L2_10 gp_2_10_12 ctp_L1_31 0 NSYN W=10u L=1u
MnTb_L1_31_3 d1bar_L2 vcn ctp_L1_31 0 NSYN W=10u L=1u
MnTa_L1_31_3 dpre_L2_10 vcn ctn_L1_31 0 NSYN W=10u L=1u
MpTb_L1_31_3 d1bar_L2 gp_2_10_12 ctn_L1_31 0 NSYN W=10u L=1u
MpTa_L1_31_4 dpre_L2_13 gp_2_13_9 ctp_L1_31 0 NSYN W=10u L=1u
MnTb_L1_31_4 d1bar_L2 vcn ctp_L1_31 0 NSYN W=10u L=1u
MnTa_L1_31_4 dpre_L2_13 vcn ctn_L1_31 0 NSYN W=10u L=1u
MpTb_L1_31_4 d1bar_L2 gp_2_13_9 ctn_L1_31 0 NSYN W=10u L=1u
MpTa_L1_31_5 dpre_L2_19 gp_2_19_10 ctp_L1_31 0 NSYN W=10u L=1u
MnTb_L1_31_5 d1bar_L2 vcn ctp_L1_31 0 NSYN W=10u L=1u
MnTa_L1_31_5 dpre_L2_19 vcn ctn_L1_31 0 NSYN W=10u L=1u
MpTb_L1_31_5 d1bar_L2 gp_2_19_10 ctn_L1_31 0 NSYN W=10u L=1u
MpTa_L1_31_6 dpre_L2_24 gp_2_24_10 ctp_L1_31 0 NSYN W=10u L=1u
MnTb_L1_31_6 d1bar_L2 vcn ctp_L1_31 0 NSYN W=10u L=1u
MnTa_L1_31_6 dpre_L2_24 vcn ctn_L1_31 0 NSYN W=10u L=1u
MpTb_L1_31_6 d1bar_L2 gp_2_24_10 ctn_L1_31 0 NSYN W=10u L=1u
MpTa_L1_31_7 dpre_L2_25 gp_2_25_11 ctp_L1_31 0 NSYN W=10u L=1u
MnTb_L1_31_7 d1bar_L2 vcn ctp_L1_31 0 NSYN W=10u L=1u
MnTa_L1_31_7 dpre_L2_25 vcn ctn_L1_31 0 NSYN W=10u L=1u
MpTb_L1_31_7 d1bar_L2 gp_2_25_11 ctn_L1_31 0 NSYN W=10u L=1u
MpTa_L1_31_8 dpre_L2_26 gp_2_26_9 ctp_L1_31 0 NSYN W=10u L=1u
MnTb_L1_31_8 d1bar_L2 vcn ctp_L1_31 0 NSYN W=10u L=1u
MnTa_L1_31_8 dpre_L2_26 vcn ctn_L1_31 0 NSYN W=10u L=1u
MpTb_L1_31_8 d1bar_L2 gp_2_26_9 ctn_L1_31 0 NSYN W=10u L=1u
MpTa_L1_31_9 dpre_L2_29 gp_2_29_6 ctp_L1_31 0 NSYN W=10u L=1u
MnTb_L1_31_9 d1bar_L2 vcn ctp_L1_31 0 NSYN W=10u L=1u
MnTa_L1_31_9 dpre_L2_29 vcn ctn_L1_31 0 NSYN W=10u L=1u
MpTb_L1_31_9 d1bar_L2 gp_2_29_6 ctn_L1_31 0 NSYN W=10u L=1u
MpTa_L1_31_10 dpre_L2_30 gp_2_30_8 ctp_L1_31 0 NSYN W=10u L=1u
MnTb_L1_31_10 d1bar_L2 vcn ctp_L1_31 0 NSYN W=10u L=1u
MnTa_L1_31_10 dpre_L2_30 vcn ctn_L1_31 0 NSYN W=10u L=1u
MpTb_L1_31_10 d1bar_L2 gp_2_30_8 ctn_L1_31 0 NSYN W=10u L=1u
MpTa_L1_31_11 dpre_L2_32 gp_2_32_7 ctp_L1_31 0 NSYN W=10u L=1u
MnTb_L1_31_11 d1bar_L2 vcn ctp_L1_31 0 NSYN W=10u L=1u
MnTa_L1_31_11 dpre_L2_32 vcn ctn_L1_31 0 NSYN W=10u L=1u
MpTb_L1_31_11 d1bar_L2 gp_2_32_7 ctn_L1_31 0 NSYN W=10u L=1u
MpTa_L1_31_12 dpre_L2_35 gp_2_35_9 ctp_L1_31 0 NSYN W=10u L=1u
MnTb_L1_31_12 d1bar_L2 vcn ctp_L1_31 0 NSYN W=10u L=1u
MnTa_L1_31_12 dpre_L2_35 vcn ctn_L1_31 0 NSYN W=10u L=1u
MpTb_L1_31_12 d1bar_L2 gp_2_35_9 ctn_L1_31 0 NSYN W=10u L=1u
MpTa_L1_31_13 dpre_L2_37 gp_2_37_9 ctp_L1_31 0 NSYN W=10u L=1u
MnTb_L1_31_13 d1bar_L2 vcn ctp_L1_31 0 NSYN W=10u L=1u
MnTa_L1_31_13 dpre_L2_37 vcn ctn_L1_31 0 NSYN W=10u L=1u
MpTb_L1_31_13 d1bar_L2 gp_2_37_9 ctn_L1_31 0 NSYN W=10u L=1u
MpTa_L1_31_14 dpre_L2_43 gp_2_43_10 ctp_L1_31 0 NSYN W=10u L=1u
MnTb_L1_31_14 d1bar_L2 vcn ctp_L1_31 0 NSYN W=10u L=1u
MnTa_L1_31_14 dpre_L2_43 vcn ctn_L1_31 0 NSYN W=10u L=1u
MpTb_L1_31_14 d1bar_L2 gp_2_43_10 ctn_L1_31 0 NSYN W=10u L=1u
MpTa_L1_31_15 dpre_L2_46 gp_2_46_10 ctp_L1_31 0 NSYN W=10u L=1u
MnTb_L1_31_15 d1bar_L2 vcn ctp_L1_31 0 NSYN W=10u L=1u
MnTa_L1_31_15 dpre_L2_46 vcn ctn_L1_31 0 NSYN W=10u L=1u
MpTb_L1_31_15 d1bar_L2 gp_2_46_10 ctn_L1_31 0 NSYN W=10u L=1u
Msa_bk_L1_31 ctn_L1_31 ctn_L1_31 0 0 NMIR W=20u L=1u
Msb_bk_L1_31 dpre_L1_31 ctn_L1_31 0 0 NMIR W=20u L=1u
Msc_bk_L1_31 ctp_L1_31 ctp_L1_31 0 0 NMIR W=20u L=1u
Msd_bk_L1_31 dpf_bk_L1_31 ctp_L1_31 0 0 NMIR W=20u L=1u
Mse_bk_L1_31 dpf_bk_L1_31 dpf_bk_L1_31 vdd vdd PMIR W=60u L=1u
Msf_bk_L1_31 dpre_L1_31 dpf_bk_L1_31 vdd vdd PMIR W=60u L=1u
R_bk_L1_31 dpre_L1_31 vrefd 16000.0
MpTa_L1_32_0 dpre_L2_0 gp_2_0_10 ctp_L1_32 0 NSYN W=10u L=1u
MnTb_L1_32_0 d1bar_L2 vcn ctp_L1_32 0 NSYN W=10u L=1u
MnTa_L1_32_0 dpre_L2_0 vcn ctn_L1_32 0 NSYN W=10u L=1u
MpTb_L1_32_0 d1bar_L2 gp_2_0_10 ctn_L1_32 0 NSYN W=10u L=1u
MpTa_L1_32_1 dpre_L2_3 gp_2_3_10 ctp_L1_32 0 NSYN W=10u L=1u
MnTb_L1_32_1 d1bar_L2 vcn ctp_L1_32 0 NSYN W=10u L=1u
MnTa_L1_32_1 dpre_L2_3 vcn ctn_L1_32 0 NSYN W=10u L=1u
MpTb_L1_32_1 d1bar_L2 gp_2_3_10 ctn_L1_32 0 NSYN W=10u L=1u
MpTa_L1_32_2 dpre_L2_4 gp_2_4_11 ctp_L1_32 0 NSYN W=10u L=1u
MnTb_L1_32_2 d1bar_L2 vcn ctp_L1_32 0 NSYN W=10u L=1u
MnTa_L1_32_2 dpre_L2_4 vcn ctn_L1_32 0 NSYN W=10u L=1u
MpTb_L1_32_2 d1bar_L2 gp_2_4_11 ctn_L1_32 0 NSYN W=10u L=1u
MpTa_L1_32_3 dpre_L2_5 gp_2_5_10 ctp_L1_32 0 NSYN W=10u L=1u
MnTb_L1_32_3 d1bar_L2 vcn ctp_L1_32 0 NSYN W=10u L=1u
MnTa_L1_32_3 dpre_L2_5 vcn ctn_L1_32 0 NSYN W=10u L=1u
MpTb_L1_32_3 d1bar_L2 gp_2_5_10 ctn_L1_32 0 NSYN W=10u L=1u
MpTa_L1_32_4 dpre_L2_18 gp_2_18_11 ctp_L1_32 0 NSYN W=10u L=1u
MnTb_L1_32_4 d1bar_L2 vcn ctp_L1_32 0 NSYN W=10u L=1u
MnTa_L1_32_4 dpre_L2_18 vcn ctn_L1_32 0 NSYN W=10u L=1u
MpTb_L1_32_4 d1bar_L2 gp_2_18_11 ctn_L1_32 0 NSYN W=10u L=1u
MpTa_L1_32_5 dpre_L2_24 gp_2_24_11 ctp_L1_32 0 NSYN W=10u L=1u
MnTb_L1_32_5 d1bar_L2 vcn ctp_L1_32 0 NSYN W=10u L=1u
MnTa_L1_32_5 dpre_L2_24 vcn ctn_L1_32 0 NSYN W=10u L=1u
MpTb_L1_32_5 d1bar_L2 gp_2_24_11 ctn_L1_32 0 NSYN W=10u L=1u
MpTa_L1_32_6 dpre_L2_25 gp_2_25_12 ctp_L1_32 0 NSYN W=10u L=1u
MnTb_L1_32_6 d1bar_L2 vcn ctp_L1_32 0 NSYN W=10u L=1u
MnTa_L1_32_6 dpre_L2_25 vcn ctn_L1_32 0 NSYN W=10u L=1u
MpTb_L1_32_6 d1bar_L2 gp_2_25_12 ctn_L1_32 0 NSYN W=10u L=1u
MpTa_L1_32_7 dpre_L2_26 gp_2_26_10 ctp_L1_32 0 NSYN W=10u L=1u
MnTb_L1_32_7 d1bar_L2 vcn ctp_L1_32 0 NSYN W=10u L=1u
MnTa_L1_32_7 dpre_L2_26 vcn ctn_L1_32 0 NSYN W=10u L=1u
MpTb_L1_32_7 d1bar_L2 gp_2_26_10 ctn_L1_32 0 NSYN W=10u L=1u
MpTa_L1_32_8 dpre_L2_29 gp_2_29_7 ctp_L1_32 0 NSYN W=10u L=1u
MnTb_L1_32_8 d1bar_L2 vcn ctp_L1_32 0 NSYN W=10u L=1u
MnTa_L1_32_8 dpre_L2_29 vcn ctn_L1_32 0 NSYN W=10u L=1u
MpTb_L1_32_8 d1bar_L2 gp_2_29_7 ctn_L1_32 0 NSYN W=10u L=1u
MpTa_L1_32_9 dpre_L2_32 gp_2_32_8 ctp_L1_32 0 NSYN W=10u L=1u
MnTb_L1_32_9 d1bar_L2 vcn ctp_L1_32 0 NSYN W=10u L=1u
MnTa_L1_32_9 dpre_L2_32 vcn ctn_L1_32 0 NSYN W=10u L=1u
MpTb_L1_32_9 d1bar_L2 gp_2_32_8 ctn_L1_32 0 NSYN W=10u L=1u
MpTa_L1_32_10 dpre_L2_33 gp_2_33_9 ctp_L1_32 0 NSYN W=10u L=1u
MnTb_L1_32_10 d1bar_L2 vcn ctp_L1_32 0 NSYN W=10u L=1u
MnTa_L1_32_10 dpre_L2_33 vcn ctn_L1_32 0 NSYN W=10u L=1u
MpTb_L1_32_10 d1bar_L2 gp_2_33_9 ctn_L1_32 0 NSYN W=10u L=1u
MpTa_L1_32_11 dpre_L2_38 gp_2_38_10 ctp_L1_32 0 NSYN W=10u L=1u
MnTb_L1_32_11 d1bar_L2 vcn ctp_L1_32 0 NSYN W=10u L=1u
MnTa_L1_32_11 dpre_L2_38 vcn ctn_L1_32 0 NSYN W=10u L=1u
MpTb_L1_32_11 d1bar_L2 gp_2_38_10 ctn_L1_32 0 NSYN W=10u L=1u
MpTa_L1_32_12 dpre_L2_42 gp_2_42_9 ctp_L1_32 0 NSYN W=10u L=1u
MnTb_L1_32_12 d1bar_L2 vcn ctp_L1_32 0 NSYN W=10u L=1u
MnTa_L1_32_12 dpre_L2_42 vcn ctn_L1_32 0 NSYN W=10u L=1u
MpTb_L1_32_12 d1bar_L2 gp_2_42_9 ctn_L1_32 0 NSYN W=10u L=1u
MpTa_L1_32_13 dpre_L2_43 gp_2_43_11 ctp_L1_32 0 NSYN W=10u L=1u
MnTb_L1_32_13 d1bar_L2 vcn ctp_L1_32 0 NSYN W=10u L=1u
MnTa_L1_32_13 dpre_L2_43 vcn ctn_L1_32 0 NSYN W=10u L=1u
MpTb_L1_32_13 d1bar_L2 gp_2_43_11 ctn_L1_32 0 NSYN W=10u L=1u
MpTa_L1_32_14 dpre_L2_45 gp_2_45_9 ctp_L1_32 0 NSYN W=10u L=1u
MnTb_L1_32_14 d1bar_L2 vcn ctp_L1_32 0 NSYN W=10u L=1u
MnTa_L1_32_14 dpre_L2_45 vcn ctn_L1_32 0 NSYN W=10u L=1u
MpTb_L1_32_14 d1bar_L2 gp_2_45_9 ctn_L1_32 0 NSYN W=10u L=1u
MpTa_L1_32_15 dpre_L2_47 gp_2_47_11 ctp_L1_32 0 NSYN W=10u L=1u
MnTb_L1_32_15 d1bar_L2 vcn ctp_L1_32 0 NSYN W=10u L=1u
MnTa_L1_32_15 dpre_L2_47 vcn ctn_L1_32 0 NSYN W=10u L=1u
MpTb_L1_32_15 d1bar_L2 gp_2_47_11 ctn_L1_32 0 NSYN W=10u L=1u
Msa_bk_L1_32 ctn_L1_32 ctn_L1_32 0 0 NMIR W=20u L=1u
Msb_bk_L1_32 dpre_L1_32 ctn_L1_32 0 0 NMIR W=20u L=1u
Msc_bk_L1_32 ctp_L1_32 ctp_L1_32 0 0 NMIR W=20u L=1u
Msd_bk_L1_32 dpf_bk_L1_32 ctp_L1_32 0 0 NMIR W=20u L=1u
Mse_bk_L1_32 dpf_bk_L1_32 dpf_bk_L1_32 vdd vdd PMIR W=60u L=1u
Msf_bk_L1_32 dpre_L1_32 dpf_bk_L1_32 vdd vdd PMIR W=60u L=1u
R_bk_L1_32 dpre_L1_32 vrefd 16000.0
MpTa_L1_33_0 dpre_L2_1 gp_2_1_10 ctp_L1_33 0 NSYN W=10u L=1u
MnTb_L1_33_0 d1bar_L2 vcn ctp_L1_33 0 NSYN W=10u L=1u
MnTa_L1_33_0 dpre_L2_1 vcn ctn_L1_33 0 NSYN W=10u L=1u
MpTb_L1_33_0 d1bar_L2 gp_2_1_10 ctn_L1_33 0 NSYN W=10u L=1u
MpTa_L1_33_1 dpre_L2_7 gp_2_7_14 ctp_L1_33 0 NSYN W=10u L=1u
MnTb_L1_33_1 d1bar_L2 vcn ctp_L1_33 0 NSYN W=10u L=1u
MnTa_L1_33_1 dpre_L2_7 vcn ctn_L1_33 0 NSYN W=10u L=1u
MpTb_L1_33_1 d1bar_L2 gp_2_7_14 ctn_L1_33 0 NSYN W=10u L=1u
MpTa_L1_33_2 dpre_L2_11 gp_2_11_12 ctp_L1_33 0 NSYN W=10u L=1u
MnTb_L1_33_2 d1bar_L2 vcn ctp_L1_33 0 NSYN W=10u L=1u
MnTa_L1_33_2 dpre_L2_11 vcn ctn_L1_33 0 NSYN W=10u L=1u
MpTb_L1_33_2 d1bar_L2 gp_2_11_12 ctn_L1_33 0 NSYN W=10u L=1u
MpTa_L1_33_3 dpre_L2_14 gp_2_14_11 ctp_L1_33 0 NSYN W=10u L=1u
MnTb_L1_33_3 d1bar_L2 vcn ctp_L1_33 0 NSYN W=10u L=1u
MnTa_L1_33_3 dpre_L2_14 vcn ctn_L1_33 0 NSYN W=10u L=1u
MpTb_L1_33_3 d1bar_L2 gp_2_14_11 ctn_L1_33 0 NSYN W=10u L=1u
MpTa_L1_33_4 dpre_L2_15 gp_2_15_9 ctp_L1_33 0 NSYN W=10u L=1u
MnTb_L1_33_4 d1bar_L2 vcn ctp_L1_33 0 NSYN W=10u L=1u
MnTa_L1_33_4 dpre_L2_15 vcn ctn_L1_33 0 NSYN W=10u L=1u
MpTb_L1_33_4 d1bar_L2 gp_2_15_9 ctn_L1_33 0 NSYN W=10u L=1u
MpTa_L1_33_5 dpre_L2_18 gp_2_18_12 ctp_L1_33 0 NSYN W=10u L=1u
MnTb_L1_33_5 d1bar_L2 vcn ctp_L1_33 0 NSYN W=10u L=1u
MnTa_L1_33_5 dpre_L2_18 vcn ctn_L1_33 0 NSYN W=10u L=1u
MpTb_L1_33_5 d1bar_L2 gp_2_18_12 ctn_L1_33 0 NSYN W=10u L=1u
MpTa_L1_33_6 dpre_L2_21 gp_2_21_10 ctp_L1_33 0 NSYN W=10u L=1u
MnTb_L1_33_6 d1bar_L2 vcn ctp_L1_33 0 NSYN W=10u L=1u
MnTa_L1_33_6 dpre_L2_21 vcn ctn_L1_33 0 NSYN W=10u L=1u
MpTb_L1_33_6 d1bar_L2 gp_2_21_10 ctn_L1_33 0 NSYN W=10u L=1u
MpTa_L1_33_7 dpre_L2_22 gp_2_22_9 ctp_L1_33 0 NSYN W=10u L=1u
MnTb_L1_33_7 d1bar_L2 vcn ctp_L1_33 0 NSYN W=10u L=1u
MnTa_L1_33_7 dpre_L2_22 vcn ctn_L1_33 0 NSYN W=10u L=1u
MpTb_L1_33_7 d1bar_L2 gp_2_22_9 ctn_L1_33 0 NSYN W=10u L=1u
MpTa_L1_33_8 dpre_L2_23 gp_2_23_9 ctp_L1_33 0 NSYN W=10u L=1u
MnTb_L1_33_8 d1bar_L2 vcn ctp_L1_33 0 NSYN W=10u L=1u
MnTa_L1_33_8 dpre_L2_23 vcn ctn_L1_33 0 NSYN W=10u L=1u
MpTb_L1_33_8 d1bar_L2 gp_2_23_9 ctn_L1_33 0 NSYN W=10u L=1u
MpTa_L1_33_9 dpre_L2_25 gp_2_25_13 ctp_L1_33 0 NSYN W=10u L=1u
MnTb_L1_33_9 d1bar_L2 vcn ctp_L1_33 0 NSYN W=10u L=1u
MnTa_L1_33_9 dpre_L2_25 vcn ctn_L1_33 0 NSYN W=10u L=1u
MpTb_L1_33_9 d1bar_L2 gp_2_25_13 ctn_L1_33 0 NSYN W=10u L=1u
MpTa_L1_33_10 dpre_L2_30 gp_2_30_9 ctp_L1_33 0 NSYN W=10u L=1u
MnTb_L1_33_10 d1bar_L2 vcn ctp_L1_33 0 NSYN W=10u L=1u
MnTa_L1_33_10 dpre_L2_30 vcn ctn_L1_33 0 NSYN W=10u L=1u
MpTb_L1_33_10 d1bar_L2 gp_2_30_9 ctn_L1_33 0 NSYN W=10u L=1u
MpTa_L1_33_11 dpre_L2_31 gp_2_31_12 ctp_L1_33 0 NSYN W=10u L=1u
MnTb_L1_33_11 d1bar_L2 vcn ctp_L1_33 0 NSYN W=10u L=1u
MnTa_L1_33_11 dpre_L2_31 vcn ctn_L1_33 0 NSYN W=10u L=1u
MpTb_L1_33_11 d1bar_L2 gp_2_31_12 ctn_L1_33 0 NSYN W=10u L=1u
MpTa_L1_33_12 dpre_L2_45 gp_2_45_10 ctp_L1_33 0 NSYN W=10u L=1u
MnTb_L1_33_12 d1bar_L2 vcn ctp_L1_33 0 NSYN W=10u L=1u
MnTa_L1_33_12 dpre_L2_45 vcn ctn_L1_33 0 NSYN W=10u L=1u
MpTb_L1_33_12 d1bar_L2 gp_2_45_10 ctn_L1_33 0 NSYN W=10u L=1u
MpTa_L1_33_13 dpre_L2_46 gp_2_46_11 ctp_L1_33 0 NSYN W=10u L=1u
MnTb_L1_33_13 d1bar_L2 vcn ctp_L1_33 0 NSYN W=10u L=1u
MnTa_L1_33_13 dpre_L2_46 vcn ctn_L1_33 0 NSYN W=10u L=1u
MpTb_L1_33_13 d1bar_L2 gp_2_46_11 ctn_L1_33 0 NSYN W=10u L=1u
MpTa_L1_33_14 dpre_L2_47 gp_2_47_12 ctp_L1_33 0 NSYN W=10u L=1u
MnTb_L1_33_14 d1bar_L2 vcn ctp_L1_33 0 NSYN W=10u L=1u
MnTa_L1_33_14 dpre_L2_47 vcn ctn_L1_33 0 NSYN W=10u L=1u
MpTb_L1_33_14 d1bar_L2 gp_2_47_12 ctn_L1_33 0 NSYN W=10u L=1u
Msa_bk_L1_33 ctn_L1_33 ctn_L1_33 0 0 NMIR W=20u L=1u
Msb_bk_L1_33 dpre_L1_33 ctn_L1_33 0 0 NMIR W=20u L=1u
Msc_bk_L1_33 ctp_L1_33 ctp_L1_33 0 0 NMIR W=20u L=1u
Msd_bk_L1_33 dpf_bk_L1_33 ctp_L1_33 0 0 NMIR W=20u L=1u
Mse_bk_L1_33 dpf_bk_L1_33 dpf_bk_L1_33 vdd vdd PMIR W=60u L=1u
Msf_bk_L1_33 dpre_L1_33 dpf_bk_L1_33 vdd vdd PMIR W=60u L=1u
R_bk_L1_33 dpre_L1_33 vrefd 16000.0
MpTa_L1_34_0 dpre_L2_0 gp_2_0_11 ctp_L1_34 0 NSYN W=10u L=1u
MnTb_L1_34_0 d1bar_L2 vcn ctp_L1_34 0 NSYN W=10u L=1u
MnTa_L1_34_0 dpre_L2_0 vcn ctn_L1_34 0 NSYN W=10u L=1u
MpTb_L1_34_0 d1bar_L2 gp_2_0_11 ctn_L1_34 0 NSYN W=10u L=1u
MpTa_L1_34_1 dpre_L2_2 gp_2_2_10 ctp_L1_34 0 NSYN W=10u L=1u
MnTb_L1_34_1 d1bar_L2 vcn ctp_L1_34 0 NSYN W=10u L=1u
MnTa_L1_34_1 dpre_L2_2 vcn ctn_L1_34 0 NSYN W=10u L=1u
MpTb_L1_34_1 d1bar_L2 gp_2_2_10 ctn_L1_34 0 NSYN W=10u L=1u
MpTa_L1_34_2 dpre_L2_4 gp_2_4_12 ctp_L1_34 0 NSYN W=10u L=1u
MnTb_L1_34_2 d1bar_L2 vcn ctp_L1_34 0 NSYN W=10u L=1u
MnTa_L1_34_2 dpre_L2_4 vcn ctn_L1_34 0 NSYN W=10u L=1u
MpTb_L1_34_2 d1bar_L2 gp_2_4_12 ctn_L1_34 0 NSYN W=10u L=1u
MpTa_L1_34_3 dpre_L2_8 gp_2_8_9 ctp_L1_34 0 NSYN W=10u L=1u
MnTb_L1_34_3 d1bar_L2 vcn ctp_L1_34 0 NSYN W=10u L=1u
MnTa_L1_34_3 dpre_L2_8 vcn ctn_L1_34 0 NSYN W=10u L=1u
MpTb_L1_34_3 d1bar_L2 gp_2_8_9 ctn_L1_34 0 NSYN W=10u L=1u
MpTa_L1_34_4 dpre_L2_11 gp_2_11_13 ctp_L1_34 0 NSYN W=10u L=1u
MnTb_L1_34_4 d1bar_L2 vcn ctp_L1_34 0 NSYN W=10u L=1u
MnTa_L1_34_4 dpre_L2_11 vcn ctn_L1_34 0 NSYN W=10u L=1u
MpTb_L1_34_4 d1bar_L2 gp_2_11_13 ctn_L1_34 0 NSYN W=10u L=1u
MpTa_L1_34_5 dpre_L2_13 gp_2_13_10 ctp_L1_34 0 NSYN W=10u L=1u
MnTb_L1_34_5 d1bar_L2 vcn ctp_L1_34 0 NSYN W=10u L=1u
MnTa_L1_34_5 dpre_L2_13 vcn ctn_L1_34 0 NSYN W=10u L=1u
MpTb_L1_34_5 d1bar_L2 gp_2_13_10 ctn_L1_34 0 NSYN W=10u L=1u
MpTa_L1_34_6 dpre_L2_15 gp_2_15_10 ctp_L1_34 0 NSYN W=10u L=1u
MnTb_L1_34_6 d1bar_L2 vcn ctp_L1_34 0 NSYN W=10u L=1u
MnTa_L1_34_6 dpre_L2_15 vcn ctn_L1_34 0 NSYN W=10u L=1u
MpTb_L1_34_6 d1bar_L2 gp_2_15_10 ctn_L1_34 0 NSYN W=10u L=1u
MpTa_L1_34_7 dpre_L2_16 gp_2_16_10 ctp_L1_34 0 NSYN W=10u L=1u
MnTb_L1_34_7 d1bar_L2 vcn ctp_L1_34 0 NSYN W=10u L=1u
MnTa_L1_34_7 dpre_L2_16 vcn ctn_L1_34 0 NSYN W=10u L=1u
MpTb_L1_34_7 d1bar_L2 gp_2_16_10 ctn_L1_34 0 NSYN W=10u L=1u
MpTa_L1_34_8 dpre_L2_18 gp_2_18_13 ctp_L1_34 0 NSYN W=10u L=1u
MnTb_L1_34_8 d1bar_L2 vcn ctp_L1_34 0 NSYN W=10u L=1u
MnTa_L1_34_8 dpre_L2_18 vcn ctn_L1_34 0 NSYN W=10u L=1u
MpTb_L1_34_8 d1bar_L2 gp_2_18_13 ctn_L1_34 0 NSYN W=10u L=1u
MpTa_L1_34_9 dpre_L2_21 gp_2_21_11 ctp_L1_34 0 NSYN W=10u L=1u
MnTb_L1_34_9 d1bar_L2 vcn ctp_L1_34 0 NSYN W=10u L=1u
MnTa_L1_34_9 dpre_L2_21 vcn ctn_L1_34 0 NSYN W=10u L=1u
MpTb_L1_34_9 d1bar_L2 gp_2_21_11 ctn_L1_34 0 NSYN W=10u L=1u
MpTa_L1_34_10 dpre_L2_24 gp_2_24_12 ctp_L1_34 0 NSYN W=10u L=1u
MnTb_L1_34_10 d1bar_L2 vcn ctp_L1_34 0 NSYN W=10u L=1u
MnTa_L1_34_10 dpre_L2_24 vcn ctn_L1_34 0 NSYN W=10u L=1u
MpTb_L1_34_10 d1bar_L2 gp_2_24_12 ctn_L1_34 0 NSYN W=10u L=1u
MpTa_L1_34_11 dpre_L2_26 gp_2_26_11 ctp_L1_34 0 NSYN W=10u L=1u
MnTb_L1_34_11 d1bar_L2 vcn ctp_L1_34 0 NSYN W=10u L=1u
MnTa_L1_34_11 dpre_L2_26 vcn ctn_L1_34 0 NSYN W=10u L=1u
MpTb_L1_34_11 d1bar_L2 gp_2_26_11 ctn_L1_34 0 NSYN W=10u L=1u
MpTa_L1_34_12 dpre_L2_27 gp_2_27_13 ctp_L1_34 0 NSYN W=10u L=1u
MnTb_L1_34_12 d1bar_L2 vcn ctp_L1_34 0 NSYN W=10u L=1u
MnTa_L1_34_12 dpre_L2_27 vcn ctn_L1_34 0 NSYN W=10u L=1u
MpTb_L1_34_12 d1bar_L2 gp_2_27_13 ctn_L1_34 0 NSYN W=10u L=1u
MpTa_L1_34_13 dpre_L2_28 gp_2_28_12 ctp_L1_34 0 NSYN W=10u L=1u
MnTb_L1_34_13 d1bar_L2 vcn ctp_L1_34 0 NSYN W=10u L=1u
MnTa_L1_34_13 dpre_L2_28 vcn ctn_L1_34 0 NSYN W=10u L=1u
MpTb_L1_34_13 d1bar_L2 gp_2_28_12 ctn_L1_34 0 NSYN W=10u L=1u
MpTa_L1_34_14 dpre_L2_30 gp_2_30_10 ctp_L1_34 0 NSYN W=10u L=1u
MnTb_L1_34_14 d1bar_L2 vcn ctp_L1_34 0 NSYN W=10u L=1u
MnTa_L1_34_14 dpre_L2_30 vcn ctn_L1_34 0 NSYN W=10u L=1u
MpTb_L1_34_14 d1bar_L2 gp_2_30_10 ctn_L1_34 0 NSYN W=10u L=1u
MpTa_L1_34_15 dpre_L2_33 gp_2_33_10 ctp_L1_34 0 NSYN W=10u L=1u
MnTb_L1_34_15 d1bar_L2 vcn ctp_L1_34 0 NSYN W=10u L=1u
MnTa_L1_34_15 dpre_L2_33 vcn ctn_L1_34 0 NSYN W=10u L=1u
MpTb_L1_34_15 d1bar_L2 gp_2_33_10 ctn_L1_34 0 NSYN W=10u L=1u
MpTa_L1_34_16 dpre_L2_34 gp_2_34_9 ctp_L1_34 0 NSYN W=10u L=1u
MnTb_L1_34_16 d1bar_L2 vcn ctp_L1_34 0 NSYN W=10u L=1u
MnTa_L1_34_16 dpre_L2_34 vcn ctn_L1_34 0 NSYN W=10u L=1u
MpTb_L1_34_16 d1bar_L2 gp_2_34_9 ctn_L1_34 0 NSYN W=10u L=1u
MpTa_L1_34_17 dpre_L2_40 gp_2_40_10 ctp_L1_34 0 NSYN W=10u L=1u
MnTb_L1_34_17 d1bar_L2 vcn ctp_L1_34 0 NSYN W=10u L=1u
MnTa_L1_34_17 dpre_L2_40 vcn ctn_L1_34 0 NSYN W=10u L=1u
MpTb_L1_34_17 d1bar_L2 gp_2_40_10 ctn_L1_34 0 NSYN W=10u L=1u
MpTa_L1_34_18 dpre_L2_42 gp_2_42_10 ctp_L1_34 0 NSYN W=10u L=1u
MnTb_L1_34_18 d1bar_L2 vcn ctp_L1_34 0 NSYN W=10u L=1u
MnTa_L1_34_18 dpre_L2_42 vcn ctn_L1_34 0 NSYN W=10u L=1u
MpTb_L1_34_18 d1bar_L2 gp_2_42_10 ctn_L1_34 0 NSYN W=10u L=1u
MpTa_L1_34_19 dpre_L2_45 gp_2_45_11 ctp_L1_34 0 NSYN W=10u L=1u
MnTb_L1_34_19 d1bar_L2 vcn ctp_L1_34 0 NSYN W=10u L=1u
MnTa_L1_34_19 dpre_L2_45 vcn ctn_L1_34 0 NSYN W=10u L=1u
MpTb_L1_34_19 d1bar_L2 gp_2_45_11 ctn_L1_34 0 NSYN W=10u L=1u
Msa_bk_L1_34 ctn_L1_34 ctn_L1_34 0 0 NMIR W=20u L=1u
Msb_bk_L1_34 dpre_L1_34 ctn_L1_34 0 0 NMIR W=20u L=1u
Msc_bk_L1_34 ctp_L1_34 ctp_L1_34 0 0 NMIR W=20u L=1u
Msd_bk_L1_34 dpf_bk_L1_34 ctp_L1_34 0 0 NMIR W=20u L=1u
Mse_bk_L1_34 dpf_bk_L1_34 dpf_bk_L1_34 vdd vdd PMIR W=60u L=1u
Msf_bk_L1_34 dpre_L1_34 dpf_bk_L1_34 vdd vdd PMIR W=60u L=1u
R_bk_L1_34 dpre_L1_34 vrefd 16000.0
MpTa_L1_35_0 dpre_L2_3 gp_2_3_11 ctp_L1_35 0 NSYN W=10u L=1u
MnTb_L1_35_0 d1bar_L2 vcn ctp_L1_35 0 NSYN W=10u L=1u
MnTa_L1_35_0 dpre_L2_3 vcn ctn_L1_35 0 NSYN W=10u L=1u
MpTb_L1_35_0 d1bar_L2 gp_2_3_11 ctn_L1_35 0 NSYN W=10u L=1u
MpTa_L1_35_1 dpre_L2_5 gp_2_5_11 ctp_L1_35 0 NSYN W=10u L=1u
MnTb_L1_35_1 d1bar_L2 vcn ctp_L1_35 0 NSYN W=10u L=1u
MnTa_L1_35_1 dpre_L2_5 vcn ctn_L1_35 0 NSYN W=10u L=1u
MpTb_L1_35_1 d1bar_L2 gp_2_5_11 ctn_L1_35 0 NSYN W=10u L=1u
MpTa_L1_35_2 dpre_L2_7 gp_2_7_15 ctp_L1_35 0 NSYN W=10u L=1u
MnTb_L1_35_2 d1bar_L2 vcn ctp_L1_35 0 NSYN W=10u L=1u
MnTa_L1_35_2 dpre_L2_7 vcn ctn_L1_35 0 NSYN W=10u L=1u
MpTb_L1_35_2 d1bar_L2 gp_2_7_15 ctn_L1_35 0 NSYN W=10u L=1u
MpTa_L1_35_3 dpre_L2_8 gp_2_8_10 ctp_L1_35 0 NSYN W=10u L=1u
MnTb_L1_35_3 d1bar_L2 vcn ctp_L1_35 0 NSYN W=10u L=1u
MnTa_L1_35_3 dpre_L2_8 vcn ctn_L1_35 0 NSYN W=10u L=1u
MpTb_L1_35_3 d1bar_L2 gp_2_8_10 ctn_L1_35 0 NSYN W=10u L=1u
MpTa_L1_35_4 dpre_L2_10 gp_2_10_13 ctp_L1_35 0 NSYN W=10u L=1u
MnTb_L1_35_4 d1bar_L2 vcn ctp_L1_35 0 NSYN W=10u L=1u
MnTa_L1_35_4 dpre_L2_10 vcn ctn_L1_35 0 NSYN W=10u L=1u
MpTb_L1_35_4 d1bar_L2 gp_2_10_13 ctn_L1_35 0 NSYN W=10u L=1u
MpTa_L1_35_5 dpre_L2_12 gp_2_12_10 ctp_L1_35 0 NSYN W=10u L=1u
MnTb_L1_35_5 d1bar_L2 vcn ctp_L1_35 0 NSYN W=10u L=1u
MnTa_L1_35_5 dpre_L2_12 vcn ctn_L1_35 0 NSYN W=10u L=1u
MpTb_L1_35_5 d1bar_L2 gp_2_12_10 ctn_L1_35 0 NSYN W=10u L=1u
MpTa_L1_35_6 dpre_L2_15 gp_2_15_11 ctp_L1_35 0 NSYN W=10u L=1u
MnTb_L1_35_6 d1bar_L2 vcn ctp_L1_35 0 NSYN W=10u L=1u
MnTa_L1_35_6 dpre_L2_15 vcn ctn_L1_35 0 NSYN W=10u L=1u
MpTb_L1_35_6 d1bar_L2 gp_2_15_11 ctn_L1_35 0 NSYN W=10u L=1u
MpTa_L1_35_7 dpre_L2_16 gp_2_16_11 ctp_L1_35 0 NSYN W=10u L=1u
MnTb_L1_35_7 d1bar_L2 vcn ctp_L1_35 0 NSYN W=10u L=1u
MnTa_L1_35_7 dpre_L2_16 vcn ctn_L1_35 0 NSYN W=10u L=1u
MpTb_L1_35_7 d1bar_L2 gp_2_16_11 ctn_L1_35 0 NSYN W=10u L=1u
MpTa_L1_35_8 dpre_L2_17 gp_2_17_11 ctp_L1_35 0 NSYN W=10u L=1u
MnTb_L1_35_8 d1bar_L2 vcn ctp_L1_35 0 NSYN W=10u L=1u
MnTa_L1_35_8 dpre_L2_17 vcn ctn_L1_35 0 NSYN W=10u L=1u
MpTb_L1_35_8 d1bar_L2 gp_2_17_11 ctn_L1_35 0 NSYN W=10u L=1u
MpTa_L1_35_9 dpre_L2_18 gp_2_18_14 ctp_L1_35 0 NSYN W=10u L=1u
MnTb_L1_35_9 d1bar_L2 vcn ctp_L1_35 0 NSYN W=10u L=1u
MnTa_L1_35_9 dpre_L2_18 vcn ctn_L1_35 0 NSYN W=10u L=1u
MpTb_L1_35_9 d1bar_L2 gp_2_18_14 ctn_L1_35 0 NSYN W=10u L=1u
MpTa_L1_35_10 dpre_L2_23 gp_2_23_10 ctp_L1_35 0 NSYN W=10u L=1u
MnTb_L1_35_10 d1bar_L2 vcn ctp_L1_35 0 NSYN W=10u L=1u
MnTa_L1_35_10 dpre_L2_23 vcn ctn_L1_35 0 NSYN W=10u L=1u
MpTb_L1_35_10 d1bar_L2 gp_2_23_10 ctn_L1_35 0 NSYN W=10u L=1u
MpTa_L1_35_11 dpre_L2_28 gp_2_28_13 ctp_L1_35 0 NSYN W=10u L=1u
MnTb_L1_35_11 d1bar_L2 vcn ctp_L1_35 0 NSYN W=10u L=1u
MnTa_L1_35_11 dpre_L2_28 vcn ctn_L1_35 0 NSYN W=10u L=1u
MpTb_L1_35_11 d1bar_L2 gp_2_28_13 ctn_L1_35 0 NSYN W=10u L=1u
MpTa_L1_35_12 dpre_L2_32 gp_2_32_9 ctp_L1_35 0 NSYN W=10u L=1u
MnTb_L1_35_12 d1bar_L2 vcn ctp_L1_35 0 NSYN W=10u L=1u
MnTa_L1_35_12 dpre_L2_32 vcn ctn_L1_35 0 NSYN W=10u L=1u
MpTb_L1_35_12 d1bar_L2 gp_2_32_9 ctn_L1_35 0 NSYN W=10u L=1u
MpTa_L1_35_13 dpre_L2_42 gp_2_42_11 ctp_L1_35 0 NSYN W=10u L=1u
MnTb_L1_35_13 d1bar_L2 vcn ctp_L1_35 0 NSYN W=10u L=1u
MnTa_L1_35_13 dpre_L2_42 vcn ctn_L1_35 0 NSYN W=10u L=1u
MpTb_L1_35_13 d1bar_L2 gp_2_42_11 ctn_L1_35 0 NSYN W=10u L=1u
Msa_bk_L1_35 ctn_L1_35 ctn_L1_35 0 0 NMIR W=20u L=1u
Msb_bk_L1_35 dpre_L1_35 ctn_L1_35 0 0 NMIR W=20u L=1u
Msc_bk_L1_35 ctp_L1_35 ctp_L1_35 0 0 NMIR W=20u L=1u
Msd_bk_L1_35 dpf_bk_L1_35 ctp_L1_35 0 0 NMIR W=20u L=1u
Mse_bk_L1_35 dpf_bk_L1_35 dpf_bk_L1_35 vdd vdd PMIR W=60u L=1u
Msf_bk_L1_35 dpre_L1_35 dpf_bk_L1_35 vdd vdd PMIR W=60u L=1u
R_bk_L1_35 dpre_L1_35 vrefd 16000.0
MpTa_L1_36_0 dpre_L2_1 gp_2_1_11 ctp_L1_36 0 NSYN W=10u L=1u
MnTb_L1_36_0 d1bar_L2 vcn ctp_L1_36 0 NSYN W=10u L=1u
MnTa_L1_36_0 dpre_L2_1 vcn ctn_L1_36 0 NSYN W=10u L=1u
MpTb_L1_36_0 d1bar_L2 gp_2_1_11 ctn_L1_36 0 NSYN W=10u L=1u
MpTa_L1_36_1 dpre_L2_3 gp_2_3_12 ctp_L1_36 0 NSYN W=10u L=1u
MnTb_L1_36_1 d1bar_L2 vcn ctp_L1_36 0 NSYN W=10u L=1u
MnTa_L1_36_1 dpre_L2_3 vcn ctn_L1_36 0 NSYN W=10u L=1u
MpTb_L1_36_1 d1bar_L2 gp_2_3_12 ctn_L1_36 0 NSYN W=10u L=1u
MpTa_L1_36_2 dpre_L2_5 gp_2_5_12 ctp_L1_36 0 NSYN W=10u L=1u
MnTb_L1_36_2 d1bar_L2 vcn ctp_L1_36 0 NSYN W=10u L=1u
MnTa_L1_36_2 dpre_L2_5 vcn ctn_L1_36 0 NSYN W=10u L=1u
MpTb_L1_36_2 d1bar_L2 gp_2_5_12 ctn_L1_36 0 NSYN W=10u L=1u
MpTa_L1_36_3 dpre_L2_10 gp_2_10_14 ctp_L1_36 0 NSYN W=10u L=1u
MnTb_L1_36_3 d1bar_L2 vcn ctp_L1_36 0 NSYN W=10u L=1u
MnTa_L1_36_3 dpre_L2_10 vcn ctn_L1_36 0 NSYN W=10u L=1u
MpTb_L1_36_3 d1bar_L2 gp_2_10_14 ctn_L1_36 0 NSYN W=10u L=1u
MpTa_L1_36_4 dpre_L2_15 gp_2_15_12 ctp_L1_36 0 NSYN W=10u L=1u
MnTb_L1_36_4 d1bar_L2 vcn ctp_L1_36 0 NSYN W=10u L=1u
MnTa_L1_36_4 dpre_L2_15 vcn ctn_L1_36 0 NSYN W=10u L=1u
MpTb_L1_36_4 d1bar_L2 gp_2_15_12 ctn_L1_36 0 NSYN W=10u L=1u
MpTa_L1_36_5 dpre_L2_16 gp_2_16_12 ctp_L1_36 0 NSYN W=10u L=1u
MnTb_L1_36_5 d1bar_L2 vcn ctp_L1_36 0 NSYN W=10u L=1u
MnTa_L1_36_5 dpre_L2_16 vcn ctn_L1_36 0 NSYN W=10u L=1u
MpTb_L1_36_5 d1bar_L2 gp_2_16_12 ctn_L1_36 0 NSYN W=10u L=1u
MpTa_L1_36_6 dpre_L2_25 gp_2_25_14 ctp_L1_36 0 NSYN W=10u L=1u
MnTb_L1_36_6 d1bar_L2 vcn ctp_L1_36 0 NSYN W=10u L=1u
MnTa_L1_36_6 dpre_L2_25 vcn ctn_L1_36 0 NSYN W=10u L=1u
MpTb_L1_36_6 d1bar_L2 gp_2_25_14 ctn_L1_36 0 NSYN W=10u L=1u
MpTa_L1_36_7 dpre_L2_27 gp_2_27_14 ctp_L1_36 0 NSYN W=10u L=1u
MnTb_L1_36_7 d1bar_L2 vcn ctp_L1_36 0 NSYN W=10u L=1u
MnTa_L1_36_7 dpre_L2_27 vcn ctn_L1_36 0 NSYN W=10u L=1u
MpTb_L1_36_7 d1bar_L2 gp_2_27_14 ctn_L1_36 0 NSYN W=10u L=1u
MpTa_L1_36_8 dpre_L2_29 gp_2_29_8 ctp_L1_36 0 NSYN W=10u L=1u
MnTb_L1_36_8 d1bar_L2 vcn ctp_L1_36 0 NSYN W=10u L=1u
MnTa_L1_36_8 dpre_L2_29 vcn ctn_L1_36 0 NSYN W=10u L=1u
MpTb_L1_36_8 d1bar_L2 gp_2_29_8 ctn_L1_36 0 NSYN W=10u L=1u
MpTa_L1_36_9 dpre_L2_35 gp_2_35_10 ctp_L1_36 0 NSYN W=10u L=1u
MnTb_L1_36_9 d1bar_L2 vcn ctp_L1_36 0 NSYN W=10u L=1u
MnTa_L1_36_9 dpre_L2_35 vcn ctn_L1_36 0 NSYN W=10u L=1u
MpTb_L1_36_9 d1bar_L2 gp_2_35_10 ctn_L1_36 0 NSYN W=10u L=1u
MpTa_L1_36_10 dpre_L2_36 gp_2_36_11 ctp_L1_36 0 NSYN W=10u L=1u
MnTb_L1_36_10 d1bar_L2 vcn ctp_L1_36 0 NSYN W=10u L=1u
MnTa_L1_36_10 dpre_L2_36 vcn ctn_L1_36 0 NSYN W=10u L=1u
MpTb_L1_36_10 d1bar_L2 gp_2_36_11 ctn_L1_36 0 NSYN W=10u L=1u
MpTa_L1_36_11 dpre_L2_37 gp_2_37_10 ctp_L1_36 0 NSYN W=10u L=1u
MnTb_L1_36_11 d1bar_L2 vcn ctp_L1_36 0 NSYN W=10u L=1u
MnTa_L1_36_11 dpre_L2_37 vcn ctn_L1_36 0 NSYN W=10u L=1u
MpTb_L1_36_11 d1bar_L2 gp_2_37_10 ctn_L1_36 0 NSYN W=10u L=1u
MpTa_L1_36_12 dpre_L2_41 gp_2_41_11 ctp_L1_36 0 NSYN W=10u L=1u
MnTb_L1_36_12 d1bar_L2 vcn ctp_L1_36 0 NSYN W=10u L=1u
MnTa_L1_36_12 dpre_L2_41 vcn ctn_L1_36 0 NSYN W=10u L=1u
MpTb_L1_36_12 d1bar_L2 gp_2_41_11 ctn_L1_36 0 NSYN W=10u L=1u
MpTa_L1_36_13 dpre_L2_44 gp_2_44_12 ctp_L1_36 0 NSYN W=10u L=1u
MnTb_L1_36_13 d1bar_L2 vcn ctp_L1_36 0 NSYN W=10u L=1u
MnTa_L1_36_13 dpre_L2_44 vcn ctn_L1_36 0 NSYN W=10u L=1u
MpTb_L1_36_13 d1bar_L2 gp_2_44_12 ctn_L1_36 0 NSYN W=10u L=1u
MpTa_L1_36_14 dpre_L2_46 gp_2_46_12 ctp_L1_36 0 NSYN W=10u L=1u
MnTb_L1_36_14 d1bar_L2 vcn ctp_L1_36 0 NSYN W=10u L=1u
MnTa_L1_36_14 dpre_L2_46 vcn ctn_L1_36 0 NSYN W=10u L=1u
MpTb_L1_36_14 d1bar_L2 gp_2_46_12 ctn_L1_36 0 NSYN W=10u L=1u
MpTa_L1_36_15 dpre_L2_47 gp_2_47_13 ctp_L1_36 0 NSYN W=10u L=1u
MnTb_L1_36_15 d1bar_L2 vcn ctp_L1_36 0 NSYN W=10u L=1u
MnTa_L1_36_15 dpre_L2_47 vcn ctn_L1_36 0 NSYN W=10u L=1u
MpTb_L1_36_15 d1bar_L2 gp_2_47_13 ctn_L1_36 0 NSYN W=10u L=1u
Msa_bk_L1_36 ctn_L1_36 ctn_L1_36 0 0 NMIR W=20u L=1u
Msb_bk_L1_36 dpre_L1_36 ctn_L1_36 0 0 NMIR W=20u L=1u
Msc_bk_L1_36 ctp_L1_36 ctp_L1_36 0 0 NMIR W=20u L=1u
Msd_bk_L1_36 dpf_bk_L1_36 ctp_L1_36 0 0 NMIR W=20u L=1u
Mse_bk_L1_36 dpf_bk_L1_36 dpf_bk_L1_36 vdd vdd PMIR W=60u L=1u
Msf_bk_L1_36 dpre_L1_36 dpf_bk_L1_36 vdd vdd PMIR W=60u L=1u
R_bk_L1_36 dpre_L1_36 vrefd 16000.0
MpTa_L1_37_0 dpre_L2_11 gp_2_11_14 ctp_L1_37 0 NSYN W=10u L=1u
MnTb_L1_37_0 d1bar_L2 vcn ctp_L1_37 0 NSYN W=10u L=1u
MnTa_L1_37_0 dpre_L2_11 vcn ctn_L1_37 0 NSYN W=10u L=1u
MpTb_L1_37_0 d1bar_L2 gp_2_11_14 ctn_L1_37 0 NSYN W=10u L=1u
MpTa_L1_37_1 dpre_L2_14 gp_2_14_12 ctp_L1_37 0 NSYN W=10u L=1u
MnTb_L1_37_1 d1bar_L2 vcn ctp_L1_37 0 NSYN W=10u L=1u
MnTa_L1_37_1 dpre_L2_14 vcn ctn_L1_37 0 NSYN W=10u L=1u
MpTb_L1_37_1 d1bar_L2 gp_2_14_12 ctn_L1_37 0 NSYN W=10u L=1u
MpTa_L1_37_2 dpre_L2_17 gp_2_17_12 ctp_L1_37 0 NSYN W=10u L=1u
MnTb_L1_37_2 d1bar_L2 vcn ctp_L1_37 0 NSYN W=10u L=1u
MnTa_L1_37_2 dpre_L2_17 vcn ctn_L1_37 0 NSYN W=10u L=1u
MpTb_L1_37_2 d1bar_L2 gp_2_17_12 ctn_L1_37 0 NSYN W=10u L=1u
MpTa_L1_37_3 dpre_L2_21 gp_2_21_12 ctp_L1_37 0 NSYN W=10u L=1u
MnTb_L1_37_3 d1bar_L2 vcn ctp_L1_37 0 NSYN W=10u L=1u
MnTa_L1_37_3 dpre_L2_21 vcn ctn_L1_37 0 NSYN W=10u L=1u
MpTb_L1_37_3 d1bar_L2 gp_2_21_12 ctn_L1_37 0 NSYN W=10u L=1u
MpTa_L1_37_4 dpre_L2_22 gp_2_22_10 ctp_L1_37 0 NSYN W=10u L=1u
MnTb_L1_37_4 d1bar_L2 vcn ctp_L1_37 0 NSYN W=10u L=1u
MnTa_L1_37_4 dpre_L2_22 vcn ctn_L1_37 0 NSYN W=10u L=1u
MpTb_L1_37_4 d1bar_L2 gp_2_22_10 ctn_L1_37 0 NSYN W=10u L=1u
MpTa_L1_37_5 dpre_L2_26 gp_2_26_12 ctp_L1_37 0 NSYN W=10u L=1u
MnTb_L1_37_5 d1bar_L2 vcn ctp_L1_37 0 NSYN W=10u L=1u
MnTa_L1_37_5 dpre_L2_26 vcn ctn_L1_37 0 NSYN W=10u L=1u
MpTb_L1_37_5 d1bar_L2 gp_2_26_12 ctn_L1_37 0 NSYN W=10u L=1u
MpTa_L1_37_6 dpre_L2_30 gp_2_30_11 ctp_L1_37 0 NSYN W=10u L=1u
MnTb_L1_37_6 d1bar_L2 vcn ctp_L1_37 0 NSYN W=10u L=1u
MnTa_L1_37_6 dpre_L2_30 vcn ctn_L1_37 0 NSYN W=10u L=1u
MpTb_L1_37_6 d1bar_L2 gp_2_30_11 ctn_L1_37 0 NSYN W=10u L=1u
MpTa_L1_37_7 dpre_L2_33 gp_2_33_11 ctp_L1_37 0 NSYN W=10u L=1u
MnTb_L1_37_7 d1bar_L2 vcn ctp_L1_37 0 NSYN W=10u L=1u
MnTa_L1_37_7 dpre_L2_33 vcn ctn_L1_37 0 NSYN W=10u L=1u
MpTb_L1_37_7 d1bar_L2 gp_2_33_11 ctn_L1_37 0 NSYN W=10u L=1u
MpTa_L1_37_8 dpre_L2_40 gp_2_40_11 ctp_L1_37 0 NSYN W=10u L=1u
MnTb_L1_37_8 d1bar_L2 vcn ctp_L1_37 0 NSYN W=10u L=1u
MnTa_L1_37_8 dpre_L2_40 vcn ctn_L1_37 0 NSYN W=10u L=1u
MpTb_L1_37_8 d1bar_L2 gp_2_40_11 ctn_L1_37 0 NSYN W=10u L=1u
MpTa_L1_37_9 dpre_L2_43 gp_2_43_12 ctp_L1_37 0 NSYN W=10u L=1u
MnTb_L1_37_9 d1bar_L2 vcn ctp_L1_37 0 NSYN W=10u L=1u
MnTa_L1_37_9 dpre_L2_43 vcn ctn_L1_37 0 NSYN W=10u L=1u
MpTb_L1_37_9 d1bar_L2 gp_2_43_12 ctn_L1_37 0 NSYN W=10u L=1u
MpTa_L1_37_10 dpre_L2_45 gp_2_45_12 ctp_L1_37 0 NSYN W=10u L=1u
MnTb_L1_37_10 d1bar_L2 vcn ctp_L1_37 0 NSYN W=10u L=1u
MnTa_L1_37_10 dpre_L2_45 vcn ctn_L1_37 0 NSYN W=10u L=1u
MpTb_L1_37_10 d1bar_L2 gp_2_45_12 ctn_L1_37 0 NSYN W=10u L=1u
MpTa_L1_37_11 dpre_L2_46 gp_2_46_13 ctp_L1_37 0 NSYN W=10u L=1u
MnTb_L1_37_11 d1bar_L2 vcn ctp_L1_37 0 NSYN W=10u L=1u
MnTa_L1_37_11 dpre_L2_46 vcn ctn_L1_37 0 NSYN W=10u L=1u
MpTb_L1_37_11 d1bar_L2 gp_2_46_13 ctn_L1_37 0 NSYN W=10u L=1u
Msa_bk_L1_37 ctn_L1_37 ctn_L1_37 0 0 NMIR W=20u L=1u
Msb_bk_L1_37 dpre_L1_37 ctn_L1_37 0 0 NMIR W=20u L=1u
Msc_bk_L1_37 ctp_L1_37 ctp_L1_37 0 0 NMIR W=20u L=1u
Msd_bk_L1_37 dpf_bk_L1_37 ctp_L1_37 0 0 NMIR W=20u L=1u
Mse_bk_L1_37 dpf_bk_L1_37 dpf_bk_L1_37 vdd vdd PMIR W=60u L=1u
Msf_bk_L1_37 dpre_L1_37 dpf_bk_L1_37 vdd vdd PMIR W=60u L=1u
R_bk_L1_37 dpre_L1_37 vrefd 16000.0
MpTa_L1_38_0 dpre_L2_12 gp_2_12_11 ctp_L1_38 0 NSYN W=10u L=1u
MnTb_L1_38_0 d1bar_L2 vcn ctp_L1_38 0 NSYN W=10u L=1u
MnTa_L1_38_0 dpre_L2_12 vcn ctn_L1_38 0 NSYN W=10u L=1u
MpTb_L1_38_0 d1bar_L2 gp_2_12_11 ctn_L1_38 0 NSYN W=10u L=1u
MpTa_L1_38_1 dpre_L2_13 gp_2_13_11 ctp_L1_38 0 NSYN W=10u L=1u
MnTb_L1_38_1 d1bar_L2 vcn ctp_L1_38 0 NSYN W=10u L=1u
MnTa_L1_38_1 dpre_L2_13 vcn ctn_L1_38 0 NSYN W=10u L=1u
MpTb_L1_38_1 d1bar_L2 gp_2_13_11 ctn_L1_38 0 NSYN W=10u L=1u
MpTa_L1_38_2 dpre_L2_17 gp_2_17_13 ctp_L1_38 0 NSYN W=10u L=1u
MnTb_L1_38_2 d1bar_L2 vcn ctp_L1_38 0 NSYN W=10u L=1u
MnTa_L1_38_2 dpre_L2_17 vcn ctn_L1_38 0 NSYN W=10u L=1u
MpTb_L1_38_2 d1bar_L2 gp_2_17_13 ctn_L1_38 0 NSYN W=10u L=1u
MpTa_L1_38_3 dpre_L2_19 gp_2_19_11 ctp_L1_38 0 NSYN W=10u L=1u
MnTb_L1_38_3 d1bar_L2 vcn ctp_L1_38 0 NSYN W=10u L=1u
MnTa_L1_38_3 dpre_L2_19 vcn ctn_L1_38 0 NSYN W=10u L=1u
MpTb_L1_38_3 d1bar_L2 gp_2_19_11 ctn_L1_38 0 NSYN W=10u L=1u
MpTa_L1_38_4 dpre_L2_20 gp_2_20_11 ctp_L1_38 0 NSYN W=10u L=1u
MnTb_L1_38_4 d1bar_L2 vcn ctp_L1_38 0 NSYN W=10u L=1u
MnTa_L1_38_4 dpre_L2_20 vcn ctn_L1_38 0 NSYN W=10u L=1u
MpTb_L1_38_4 d1bar_L2 gp_2_20_11 ctn_L1_38 0 NSYN W=10u L=1u
MpTa_L1_38_5 dpre_L2_24 gp_2_24_13 ctp_L1_38 0 NSYN W=10u L=1u
MnTb_L1_38_5 d1bar_L2 vcn ctp_L1_38 0 NSYN W=10u L=1u
MnTa_L1_38_5 dpre_L2_24 vcn ctn_L1_38 0 NSYN W=10u L=1u
MpTb_L1_38_5 d1bar_L2 gp_2_24_13 ctn_L1_38 0 NSYN W=10u L=1u
MpTa_L1_38_6 dpre_L2_29 gp_2_29_9 ctp_L1_38 0 NSYN W=10u L=1u
MnTb_L1_38_6 d1bar_L2 vcn ctp_L1_38 0 NSYN W=10u L=1u
MnTa_L1_38_6 dpre_L2_29 vcn ctn_L1_38 0 NSYN W=10u L=1u
MpTb_L1_38_6 d1bar_L2 gp_2_29_9 ctn_L1_38 0 NSYN W=10u L=1u
MpTa_L1_38_7 dpre_L2_31 gp_2_31_13 ctp_L1_38 0 NSYN W=10u L=1u
MnTb_L1_38_7 d1bar_L2 vcn ctp_L1_38 0 NSYN W=10u L=1u
MnTa_L1_38_7 dpre_L2_31 vcn ctn_L1_38 0 NSYN W=10u L=1u
MpTb_L1_38_7 d1bar_L2 gp_2_31_13 ctn_L1_38 0 NSYN W=10u L=1u
MpTa_L1_38_8 dpre_L2_32 gp_2_32_10 ctp_L1_38 0 NSYN W=10u L=1u
MnTb_L1_38_8 d1bar_L2 vcn ctp_L1_38 0 NSYN W=10u L=1u
MnTa_L1_38_8 dpre_L2_32 vcn ctn_L1_38 0 NSYN W=10u L=1u
MpTb_L1_38_8 d1bar_L2 gp_2_32_10 ctn_L1_38 0 NSYN W=10u L=1u
MpTa_L1_38_9 dpre_L2_34 gp_2_34_10 ctp_L1_38 0 NSYN W=10u L=1u
MnTb_L1_38_9 d1bar_L2 vcn ctp_L1_38 0 NSYN W=10u L=1u
MnTa_L1_38_9 dpre_L2_34 vcn ctn_L1_38 0 NSYN W=10u L=1u
MpTb_L1_38_9 d1bar_L2 gp_2_34_10 ctn_L1_38 0 NSYN W=10u L=1u
MpTa_L1_38_10 dpre_L2_35 gp_2_35_11 ctp_L1_38 0 NSYN W=10u L=1u
MnTb_L1_38_10 d1bar_L2 vcn ctp_L1_38 0 NSYN W=10u L=1u
MnTa_L1_38_10 dpre_L2_35 vcn ctn_L1_38 0 NSYN W=10u L=1u
MpTb_L1_38_10 d1bar_L2 gp_2_35_11 ctn_L1_38 0 NSYN W=10u L=1u
MpTa_L1_38_11 dpre_L2_36 gp_2_36_12 ctp_L1_38 0 NSYN W=10u L=1u
MnTb_L1_38_11 d1bar_L2 vcn ctp_L1_38 0 NSYN W=10u L=1u
MnTa_L1_38_11 dpre_L2_36 vcn ctn_L1_38 0 NSYN W=10u L=1u
MpTb_L1_38_11 d1bar_L2 gp_2_36_12 ctn_L1_38 0 NSYN W=10u L=1u
MpTa_L1_38_12 dpre_L2_40 gp_2_40_12 ctp_L1_38 0 NSYN W=10u L=1u
MnTb_L1_38_12 d1bar_L2 vcn ctp_L1_38 0 NSYN W=10u L=1u
MnTa_L1_38_12 dpre_L2_40 vcn ctn_L1_38 0 NSYN W=10u L=1u
MpTb_L1_38_12 d1bar_L2 gp_2_40_12 ctn_L1_38 0 NSYN W=10u L=1u
MpTa_L1_38_13 dpre_L2_42 gp_2_42_12 ctp_L1_38 0 NSYN W=10u L=1u
MnTb_L1_38_13 d1bar_L2 vcn ctp_L1_38 0 NSYN W=10u L=1u
MnTa_L1_38_13 dpre_L2_42 vcn ctn_L1_38 0 NSYN W=10u L=1u
MpTb_L1_38_13 d1bar_L2 gp_2_42_12 ctn_L1_38 0 NSYN W=10u L=1u
MpTa_L1_38_14 dpre_L2_43 gp_2_43_13 ctp_L1_38 0 NSYN W=10u L=1u
MnTb_L1_38_14 d1bar_L2 vcn ctp_L1_38 0 NSYN W=10u L=1u
MnTa_L1_38_14 dpre_L2_43 vcn ctn_L1_38 0 NSYN W=10u L=1u
MpTb_L1_38_14 d1bar_L2 gp_2_43_13 ctn_L1_38 0 NSYN W=10u L=1u
MpTa_L1_38_15 dpre_L2_44 gp_2_44_13 ctp_L1_38 0 NSYN W=10u L=1u
MnTb_L1_38_15 d1bar_L2 vcn ctp_L1_38 0 NSYN W=10u L=1u
MnTa_L1_38_15 dpre_L2_44 vcn ctn_L1_38 0 NSYN W=10u L=1u
MpTb_L1_38_15 d1bar_L2 gp_2_44_13 ctn_L1_38 0 NSYN W=10u L=1u
Msa_bk_L1_38 ctn_L1_38 ctn_L1_38 0 0 NMIR W=20u L=1u
Msb_bk_L1_38 dpre_L1_38 ctn_L1_38 0 0 NMIR W=20u L=1u
Msc_bk_L1_38 ctp_L1_38 ctp_L1_38 0 0 NMIR W=20u L=1u
Msd_bk_L1_38 dpf_bk_L1_38 ctp_L1_38 0 0 NMIR W=20u L=1u
Mse_bk_L1_38 dpf_bk_L1_38 dpf_bk_L1_38 vdd vdd PMIR W=60u L=1u
Msf_bk_L1_38 dpre_L1_38 dpf_bk_L1_38 vdd vdd PMIR W=60u L=1u
R_bk_L1_38 dpre_L1_38 vrefd 16000.0
MpTa_L1_39_0 dpre_L2_0 gp_2_0_12 ctp_L1_39 0 NSYN W=10u L=1u
MnTb_L1_39_0 d1bar_L2 vcn ctp_L1_39 0 NSYN W=10u L=1u
MnTa_L1_39_0 dpre_L2_0 vcn ctn_L1_39 0 NSYN W=10u L=1u
MpTb_L1_39_0 d1bar_L2 gp_2_0_12 ctn_L1_39 0 NSYN W=10u L=1u
MpTa_L1_39_1 dpre_L2_3 gp_2_3_13 ctp_L1_39 0 NSYN W=10u L=1u
MnTb_L1_39_1 d1bar_L2 vcn ctp_L1_39 0 NSYN W=10u L=1u
MnTa_L1_39_1 dpre_L2_3 vcn ctn_L1_39 0 NSYN W=10u L=1u
MpTb_L1_39_1 d1bar_L2 gp_2_3_13 ctn_L1_39 0 NSYN W=10u L=1u
MpTa_L1_39_2 dpre_L2_4 gp_2_4_13 ctp_L1_39 0 NSYN W=10u L=1u
MnTb_L1_39_2 d1bar_L2 vcn ctp_L1_39 0 NSYN W=10u L=1u
MnTa_L1_39_2 dpre_L2_4 vcn ctn_L1_39 0 NSYN W=10u L=1u
MpTb_L1_39_2 d1bar_L2 gp_2_4_13 ctn_L1_39 0 NSYN W=10u L=1u
MpTa_L1_39_3 dpre_L2_5 gp_2_5_13 ctp_L1_39 0 NSYN W=10u L=1u
MnTb_L1_39_3 d1bar_L2 vcn ctp_L1_39 0 NSYN W=10u L=1u
MnTa_L1_39_3 dpre_L2_5 vcn ctn_L1_39 0 NSYN W=10u L=1u
MpTb_L1_39_3 d1bar_L2 gp_2_5_13 ctn_L1_39 0 NSYN W=10u L=1u
MpTa_L1_39_4 dpre_L2_6 gp_2_6_12 ctp_L1_39 0 NSYN W=10u L=1u
MnTb_L1_39_4 d1bar_L2 vcn ctp_L1_39 0 NSYN W=10u L=1u
MnTa_L1_39_4 dpre_L2_6 vcn ctn_L1_39 0 NSYN W=10u L=1u
MpTb_L1_39_4 d1bar_L2 gp_2_6_12 ctn_L1_39 0 NSYN W=10u L=1u
MpTa_L1_39_5 dpre_L2_8 gp_2_8_11 ctp_L1_39 0 NSYN W=10u L=1u
MnTb_L1_39_5 d1bar_L2 vcn ctp_L1_39 0 NSYN W=10u L=1u
MnTa_L1_39_5 dpre_L2_8 vcn ctn_L1_39 0 NSYN W=10u L=1u
MpTb_L1_39_5 d1bar_L2 gp_2_8_11 ctn_L1_39 0 NSYN W=10u L=1u
MpTa_L1_39_6 dpre_L2_9 gp_2_9_11 ctp_L1_39 0 NSYN W=10u L=1u
MnTb_L1_39_6 d1bar_L2 vcn ctp_L1_39 0 NSYN W=10u L=1u
MnTa_L1_39_6 dpre_L2_9 vcn ctn_L1_39 0 NSYN W=10u L=1u
MpTb_L1_39_6 d1bar_L2 gp_2_9_11 ctn_L1_39 0 NSYN W=10u L=1u
MpTa_L1_39_7 dpre_L2_13 gp_2_13_12 ctp_L1_39 0 NSYN W=10u L=1u
MnTb_L1_39_7 d1bar_L2 vcn ctp_L1_39 0 NSYN W=10u L=1u
MnTa_L1_39_7 dpre_L2_13 vcn ctn_L1_39 0 NSYN W=10u L=1u
MpTb_L1_39_7 d1bar_L2 gp_2_13_12 ctn_L1_39 0 NSYN W=10u L=1u
MpTa_L1_39_8 dpre_L2_14 gp_2_14_13 ctp_L1_39 0 NSYN W=10u L=1u
MnTb_L1_39_8 d1bar_L2 vcn ctp_L1_39 0 NSYN W=10u L=1u
MnTa_L1_39_8 dpre_L2_14 vcn ctn_L1_39 0 NSYN W=10u L=1u
MpTb_L1_39_8 d1bar_L2 gp_2_14_13 ctn_L1_39 0 NSYN W=10u L=1u
MpTa_L1_39_9 dpre_L2_17 gp_2_17_14 ctp_L1_39 0 NSYN W=10u L=1u
MnTb_L1_39_9 d1bar_L2 vcn ctp_L1_39 0 NSYN W=10u L=1u
MnTa_L1_39_9 dpre_L2_17 vcn ctn_L1_39 0 NSYN W=10u L=1u
MpTb_L1_39_9 d1bar_L2 gp_2_17_14 ctn_L1_39 0 NSYN W=10u L=1u
MpTa_L1_39_10 dpre_L2_18 gp_2_18_15 ctp_L1_39 0 NSYN W=10u L=1u
MnTb_L1_39_10 d1bar_L2 vcn ctp_L1_39 0 NSYN W=10u L=1u
MnTa_L1_39_10 dpre_L2_18 vcn ctn_L1_39 0 NSYN W=10u L=1u
MpTb_L1_39_10 d1bar_L2 gp_2_18_15 ctn_L1_39 0 NSYN W=10u L=1u
MpTa_L1_39_11 dpre_L2_20 gp_2_20_12 ctp_L1_39 0 NSYN W=10u L=1u
MnTb_L1_39_11 d1bar_L2 vcn ctp_L1_39 0 NSYN W=10u L=1u
MnTa_L1_39_11 dpre_L2_20 vcn ctn_L1_39 0 NSYN W=10u L=1u
MpTb_L1_39_11 d1bar_L2 gp_2_20_12 ctn_L1_39 0 NSYN W=10u L=1u
MpTa_L1_39_12 dpre_L2_21 gp_2_21_13 ctp_L1_39 0 NSYN W=10u L=1u
MnTb_L1_39_12 d1bar_L2 vcn ctp_L1_39 0 NSYN W=10u L=1u
MnTa_L1_39_12 dpre_L2_21 vcn ctn_L1_39 0 NSYN W=10u L=1u
MpTb_L1_39_12 d1bar_L2 gp_2_21_13 ctn_L1_39 0 NSYN W=10u L=1u
MpTa_L1_39_13 dpre_L2_23 gp_2_23_11 ctp_L1_39 0 NSYN W=10u L=1u
MnTb_L1_39_13 d1bar_L2 vcn ctp_L1_39 0 NSYN W=10u L=1u
MnTa_L1_39_13 dpre_L2_23 vcn ctn_L1_39 0 NSYN W=10u L=1u
MpTb_L1_39_13 d1bar_L2 gp_2_23_11 ctn_L1_39 0 NSYN W=10u L=1u
MpTa_L1_39_14 dpre_L2_29 gp_2_29_10 ctp_L1_39 0 NSYN W=10u L=1u
MnTb_L1_39_14 d1bar_L2 vcn ctp_L1_39 0 NSYN W=10u L=1u
MnTa_L1_39_14 dpre_L2_29 vcn ctn_L1_39 0 NSYN W=10u L=1u
MpTb_L1_39_14 d1bar_L2 gp_2_29_10 ctn_L1_39 0 NSYN W=10u L=1u
MpTa_L1_39_15 dpre_L2_30 gp_2_30_12 ctp_L1_39 0 NSYN W=10u L=1u
MnTb_L1_39_15 d1bar_L2 vcn ctp_L1_39 0 NSYN W=10u L=1u
MnTa_L1_39_15 dpre_L2_30 vcn ctn_L1_39 0 NSYN W=10u L=1u
MpTb_L1_39_15 d1bar_L2 gp_2_30_12 ctn_L1_39 0 NSYN W=10u L=1u
MpTa_L1_39_16 dpre_L2_32 gp_2_32_11 ctp_L1_39 0 NSYN W=10u L=1u
MnTb_L1_39_16 d1bar_L2 vcn ctp_L1_39 0 NSYN W=10u L=1u
MnTa_L1_39_16 dpre_L2_32 vcn ctn_L1_39 0 NSYN W=10u L=1u
MpTb_L1_39_16 d1bar_L2 gp_2_32_11 ctn_L1_39 0 NSYN W=10u L=1u
MpTa_L1_39_17 dpre_L2_33 gp_2_33_12 ctp_L1_39 0 NSYN W=10u L=1u
MnTb_L1_39_17 d1bar_L2 vcn ctp_L1_39 0 NSYN W=10u L=1u
MnTa_L1_39_17 dpre_L2_33 vcn ctn_L1_39 0 NSYN W=10u L=1u
MpTb_L1_39_17 d1bar_L2 gp_2_33_12 ctn_L1_39 0 NSYN W=10u L=1u
MpTa_L1_39_18 dpre_L2_35 gp_2_35_12 ctp_L1_39 0 NSYN W=10u L=1u
MnTb_L1_39_18 d1bar_L2 vcn ctp_L1_39 0 NSYN W=10u L=1u
MnTa_L1_39_18 dpre_L2_35 vcn ctn_L1_39 0 NSYN W=10u L=1u
MpTb_L1_39_18 d1bar_L2 gp_2_35_12 ctn_L1_39 0 NSYN W=10u L=1u
MpTa_L1_39_19 dpre_L2_36 gp_2_36_13 ctp_L1_39 0 NSYN W=10u L=1u
MnTb_L1_39_19 d1bar_L2 vcn ctp_L1_39 0 NSYN W=10u L=1u
MnTa_L1_39_19 dpre_L2_36 vcn ctn_L1_39 0 NSYN W=10u L=1u
MpTb_L1_39_19 d1bar_L2 gp_2_36_13 ctn_L1_39 0 NSYN W=10u L=1u
MpTa_L1_39_20 dpre_L2_39 gp_2_39_12 ctp_L1_39 0 NSYN W=10u L=1u
MnTb_L1_39_20 d1bar_L2 vcn ctp_L1_39 0 NSYN W=10u L=1u
MnTa_L1_39_20 dpre_L2_39 vcn ctn_L1_39 0 NSYN W=10u L=1u
MpTb_L1_39_20 d1bar_L2 gp_2_39_12 ctn_L1_39 0 NSYN W=10u L=1u
MpTa_L1_39_21 dpre_L2_43 gp_2_43_14 ctp_L1_39 0 NSYN W=10u L=1u
MnTb_L1_39_21 d1bar_L2 vcn ctp_L1_39 0 NSYN W=10u L=1u
MnTa_L1_39_21 dpre_L2_43 vcn ctn_L1_39 0 NSYN W=10u L=1u
MpTb_L1_39_21 d1bar_L2 gp_2_43_14 ctn_L1_39 0 NSYN W=10u L=1u
MpTa_L1_39_22 dpre_L2_44 gp_2_44_14 ctp_L1_39 0 NSYN W=10u L=1u
MnTb_L1_39_22 d1bar_L2 vcn ctp_L1_39 0 NSYN W=10u L=1u
MnTa_L1_39_22 dpre_L2_44 vcn ctn_L1_39 0 NSYN W=10u L=1u
MpTb_L1_39_22 d1bar_L2 gp_2_44_14 ctn_L1_39 0 NSYN W=10u L=1u
Msa_bk_L1_39 ctn_L1_39 ctn_L1_39 0 0 NMIR W=20u L=1u
Msb_bk_L1_39 dpre_L1_39 ctn_L1_39 0 0 NMIR W=20u L=1u
Msc_bk_L1_39 ctp_L1_39 ctp_L1_39 0 0 NMIR W=20u L=1u
Msd_bk_L1_39 dpf_bk_L1_39 ctp_L1_39 0 0 NMIR W=20u L=1u
Mse_bk_L1_39 dpf_bk_L1_39 dpf_bk_L1_39 vdd vdd PMIR W=60u L=1u
Msf_bk_L1_39 dpre_L1_39 dpf_bk_L1_39 vdd vdd PMIR W=60u L=1u
R_bk_L1_39 dpre_L1_39 vrefd 16000.0
MpTa_L1_40_0 dpre_L2_0 gp_2_0_13 ctp_L1_40 0 NSYN W=10u L=1u
MnTb_L1_40_0 d1bar_L2 vcn ctp_L1_40 0 NSYN W=10u L=1u
MnTa_L1_40_0 dpre_L2_0 vcn ctn_L1_40 0 NSYN W=10u L=1u
MpTb_L1_40_0 d1bar_L2 gp_2_0_13 ctn_L1_40 0 NSYN W=10u L=1u
MpTa_L1_40_1 dpre_L2_1 gp_2_1_12 ctp_L1_40 0 NSYN W=10u L=1u
MnTb_L1_40_1 d1bar_L2 vcn ctp_L1_40 0 NSYN W=10u L=1u
MnTa_L1_40_1 dpre_L2_1 vcn ctn_L1_40 0 NSYN W=10u L=1u
MpTb_L1_40_1 d1bar_L2 gp_2_1_12 ctn_L1_40 0 NSYN W=10u L=1u
MpTa_L1_40_2 dpre_L2_2 gp_2_2_11 ctp_L1_40 0 NSYN W=10u L=1u
MnTb_L1_40_2 d1bar_L2 vcn ctp_L1_40 0 NSYN W=10u L=1u
MnTa_L1_40_2 dpre_L2_2 vcn ctn_L1_40 0 NSYN W=10u L=1u
MpTb_L1_40_2 d1bar_L2 gp_2_2_11 ctn_L1_40 0 NSYN W=10u L=1u
MpTa_L1_40_3 dpre_L2_3 gp_2_3_14 ctp_L1_40 0 NSYN W=10u L=1u
MnTb_L1_40_3 d1bar_L2 vcn ctp_L1_40 0 NSYN W=10u L=1u
MnTa_L1_40_3 dpre_L2_3 vcn ctn_L1_40 0 NSYN W=10u L=1u
MpTb_L1_40_3 d1bar_L2 gp_2_3_14 ctn_L1_40 0 NSYN W=10u L=1u
MpTa_L1_40_4 dpre_L2_6 gp_2_6_13 ctp_L1_40 0 NSYN W=10u L=1u
MnTb_L1_40_4 d1bar_L2 vcn ctp_L1_40 0 NSYN W=10u L=1u
MnTa_L1_40_4 dpre_L2_6 vcn ctn_L1_40 0 NSYN W=10u L=1u
MpTb_L1_40_4 d1bar_L2 gp_2_6_13 ctn_L1_40 0 NSYN W=10u L=1u
MpTa_L1_40_5 dpre_L2_11 gp_2_11_15 ctp_L1_40 0 NSYN W=10u L=1u
MnTb_L1_40_5 d1bar_L2 vcn ctp_L1_40 0 NSYN W=10u L=1u
MnTa_L1_40_5 dpre_L2_11 vcn ctn_L1_40 0 NSYN W=10u L=1u
MpTb_L1_40_5 d1bar_L2 gp_2_11_15 ctn_L1_40 0 NSYN W=10u L=1u
MpTa_L1_40_6 dpre_L2_19 gp_2_19_12 ctp_L1_40 0 NSYN W=10u L=1u
MnTb_L1_40_6 d1bar_L2 vcn ctp_L1_40 0 NSYN W=10u L=1u
MnTa_L1_40_6 dpre_L2_19 vcn ctn_L1_40 0 NSYN W=10u L=1u
MpTb_L1_40_6 d1bar_L2 gp_2_19_12 ctn_L1_40 0 NSYN W=10u L=1u
MpTa_L1_40_7 dpre_L2_22 gp_2_22_11 ctp_L1_40 0 NSYN W=10u L=1u
MnTb_L1_40_7 d1bar_L2 vcn ctp_L1_40 0 NSYN W=10u L=1u
MnTa_L1_40_7 dpre_L2_22 vcn ctn_L1_40 0 NSYN W=10u L=1u
MpTb_L1_40_7 d1bar_L2 gp_2_22_11 ctn_L1_40 0 NSYN W=10u L=1u
MpTa_L1_40_8 dpre_L2_24 gp_2_24_14 ctp_L1_40 0 NSYN W=10u L=1u
MnTb_L1_40_8 d1bar_L2 vcn ctp_L1_40 0 NSYN W=10u L=1u
MnTa_L1_40_8 dpre_L2_24 vcn ctn_L1_40 0 NSYN W=10u L=1u
MpTb_L1_40_8 d1bar_L2 gp_2_24_14 ctn_L1_40 0 NSYN W=10u L=1u
MpTa_L1_40_9 dpre_L2_29 gp_2_29_11 ctp_L1_40 0 NSYN W=10u L=1u
MnTb_L1_40_9 d1bar_L2 vcn ctp_L1_40 0 NSYN W=10u L=1u
MnTa_L1_40_9 dpre_L2_29 vcn ctn_L1_40 0 NSYN W=10u L=1u
MpTb_L1_40_9 d1bar_L2 gp_2_29_11 ctn_L1_40 0 NSYN W=10u L=1u
MpTa_L1_40_10 dpre_L2_30 gp_2_30_13 ctp_L1_40 0 NSYN W=10u L=1u
MnTb_L1_40_10 d1bar_L2 vcn ctp_L1_40 0 NSYN W=10u L=1u
MnTa_L1_40_10 dpre_L2_30 vcn ctn_L1_40 0 NSYN W=10u L=1u
MpTb_L1_40_10 d1bar_L2 gp_2_30_13 ctn_L1_40 0 NSYN W=10u L=1u
MpTa_L1_40_11 dpre_L2_34 gp_2_34_11 ctp_L1_40 0 NSYN W=10u L=1u
MnTb_L1_40_11 d1bar_L2 vcn ctp_L1_40 0 NSYN W=10u L=1u
MnTa_L1_40_11 dpre_L2_34 vcn ctn_L1_40 0 NSYN W=10u L=1u
MpTb_L1_40_11 d1bar_L2 gp_2_34_11 ctn_L1_40 0 NSYN W=10u L=1u
MpTa_L1_40_12 dpre_L2_42 gp_2_42_13 ctp_L1_40 0 NSYN W=10u L=1u
MnTb_L1_40_12 d1bar_L2 vcn ctp_L1_40 0 NSYN W=10u L=1u
MnTa_L1_40_12 dpre_L2_42 vcn ctn_L1_40 0 NSYN W=10u L=1u
MpTb_L1_40_12 d1bar_L2 gp_2_42_13 ctn_L1_40 0 NSYN W=10u L=1u
MpTa_L1_40_13 dpre_L2_45 gp_2_45_13 ctp_L1_40 0 NSYN W=10u L=1u
MnTb_L1_40_13 d1bar_L2 vcn ctp_L1_40 0 NSYN W=10u L=1u
MnTa_L1_40_13 dpre_L2_45 vcn ctn_L1_40 0 NSYN W=10u L=1u
MpTb_L1_40_13 d1bar_L2 gp_2_45_13 ctn_L1_40 0 NSYN W=10u L=1u
Msa_bk_L1_40 ctn_L1_40 ctn_L1_40 0 0 NMIR W=20u L=1u
Msb_bk_L1_40 dpre_L1_40 ctn_L1_40 0 0 NMIR W=20u L=1u
Msc_bk_L1_40 ctp_L1_40 ctp_L1_40 0 0 NMIR W=20u L=1u
Msd_bk_L1_40 dpf_bk_L1_40 ctp_L1_40 0 0 NMIR W=20u L=1u
Mse_bk_L1_40 dpf_bk_L1_40 dpf_bk_L1_40 vdd vdd PMIR W=60u L=1u
Msf_bk_L1_40 dpre_L1_40 dpf_bk_L1_40 vdd vdd PMIR W=60u L=1u
R_bk_L1_40 dpre_L1_40 vrefd 16000.0
MpTa_L1_41_0 dpre_L2_0 gp_2_0_14 ctp_L1_41 0 NSYN W=10u L=1u
MnTb_L1_41_0 d1bar_L2 vcn ctp_L1_41 0 NSYN W=10u L=1u
MnTa_L1_41_0 dpre_L2_0 vcn ctn_L1_41 0 NSYN W=10u L=1u
MpTb_L1_41_0 d1bar_L2 gp_2_0_14 ctn_L1_41 0 NSYN W=10u L=1u
MpTa_L1_41_1 dpre_L2_1 gp_2_1_13 ctp_L1_41 0 NSYN W=10u L=1u
MnTb_L1_41_1 d1bar_L2 vcn ctp_L1_41 0 NSYN W=10u L=1u
MnTa_L1_41_1 dpre_L2_1 vcn ctn_L1_41 0 NSYN W=10u L=1u
MpTb_L1_41_1 d1bar_L2 gp_2_1_13 ctn_L1_41 0 NSYN W=10u L=1u
MpTa_L1_41_2 dpre_L2_2 gp_2_2_12 ctp_L1_41 0 NSYN W=10u L=1u
MnTb_L1_41_2 d1bar_L2 vcn ctp_L1_41 0 NSYN W=10u L=1u
MnTa_L1_41_2 dpre_L2_2 vcn ctn_L1_41 0 NSYN W=10u L=1u
MpTb_L1_41_2 d1bar_L2 gp_2_2_12 ctn_L1_41 0 NSYN W=10u L=1u
MpTa_L1_41_3 dpre_L2_3 gp_2_3_15 ctp_L1_41 0 NSYN W=10u L=1u
MnTb_L1_41_3 d1bar_L2 vcn ctp_L1_41 0 NSYN W=10u L=1u
MnTa_L1_41_3 dpre_L2_3 vcn ctn_L1_41 0 NSYN W=10u L=1u
MpTb_L1_41_3 d1bar_L2 gp_2_3_15 ctn_L1_41 0 NSYN W=10u L=1u
MpTa_L1_41_4 dpre_L2_5 gp_2_5_14 ctp_L1_41 0 NSYN W=10u L=1u
MnTb_L1_41_4 d1bar_L2 vcn ctp_L1_41 0 NSYN W=10u L=1u
MnTa_L1_41_4 dpre_L2_5 vcn ctn_L1_41 0 NSYN W=10u L=1u
MpTb_L1_41_4 d1bar_L2 gp_2_5_14 ctn_L1_41 0 NSYN W=10u L=1u
MpTa_L1_41_5 dpre_L2_8 gp_2_8_12 ctp_L1_41 0 NSYN W=10u L=1u
MnTb_L1_41_5 d1bar_L2 vcn ctp_L1_41 0 NSYN W=10u L=1u
MnTa_L1_41_5 dpre_L2_8 vcn ctn_L1_41 0 NSYN W=10u L=1u
MpTb_L1_41_5 d1bar_L2 gp_2_8_12 ctn_L1_41 0 NSYN W=10u L=1u
MpTa_L1_41_6 dpre_L2_9 gp_2_9_12 ctp_L1_41 0 NSYN W=10u L=1u
MnTb_L1_41_6 d1bar_L2 vcn ctp_L1_41 0 NSYN W=10u L=1u
MnTa_L1_41_6 dpre_L2_9 vcn ctn_L1_41 0 NSYN W=10u L=1u
MpTb_L1_41_6 d1bar_L2 gp_2_9_12 ctn_L1_41 0 NSYN W=10u L=1u
MpTa_L1_41_7 dpre_L2_13 gp_2_13_13 ctp_L1_41 0 NSYN W=10u L=1u
MnTb_L1_41_7 d1bar_L2 vcn ctp_L1_41 0 NSYN W=10u L=1u
MnTa_L1_41_7 dpre_L2_13 vcn ctn_L1_41 0 NSYN W=10u L=1u
MpTb_L1_41_7 d1bar_L2 gp_2_13_13 ctn_L1_41 0 NSYN W=10u L=1u
MpTa_L1_41_8 dpre_L2_14 gp_2_14_14 ctp_L1_41 0 NSYN W=10u L=1u
MnTb_L1_41_8 d1bar_L2 vcn ctp_L1_41 0 NSYN W=10u L=1u
MnTa_L1_41_8 dpre_L2_14 vcn ctn_L1_41 0 NSYN W=10u L=1u
MpTb_L1_41_8 d1bar_L2 gp_2_14_14 ctn_L1_41 0 NSYN W=10u L=1u
MpTa_L1_41_9 dpre_L2_15 gp_2_15_13 ctp_L1_41 0 NSYN W=10u L=1u
MnTb_L1_41_9 d1bar_L2 vcn ctp_L1_41 0 NSYN W=10u L=1u
MnTa_L1_41_9 dpre_L2_15 vcn ctn_L1_41 0 NSYN W=10u L=1u
MpTb_L1_41_9 d1bar_L2 gp_2_15_13 ctn_L1_41 0 NSYN W=10u L=1u
MpTa_L1_41_10 dpre_L2_16 gp_2_16_13 ctp_L1_41 0 NSYN W=10u L=1u
MnTb_L1_41_10 d1bar_L2 vcn ctp_L1_41 0 NSYN W=10u L=1u
MnTa_L1_41_10 dpre_L2_16 vcn ctn_L1_41 0 NSYN W=10u L=1u
MpTb_L1_41_10 d1bar_L2 gp_2_16_13 ctn_L1_41 0 NSYN W=10u L=1u
MpTa_L1_41_11 dpre_L2_22 gp_2_22_12 ctp_L1_41 0 NSYN W=10u L=1u
MnTb_L1_41_11 d1bar_L2 vcn ctp_L1_41 0 NSYN W=10u L=1u
MnTa_L1_41_11 dpre_L2_22 vcn ctn_L1_41 0 NSYN W=10u L=1u
MpTb_L1_41_11 d1bar_L2 gp_2_22_12 ctn_L1_41 0 NSYN W=10u L=1u
MpTa_L1_41_12 dpre_L2_23 gp_2_23_12 ctp_L1_41 0 NSYN W=10u L=1u
MnTb_L1_41_12 d1bar_L2 vcn ctp_L1_41 0 NSYN W=10u L=1u
MnTa_L1_41_12 dpre_L2_23 vcn ctn_L1_41 0 NSYN W=10u L=1u
MpTb_L1_41_12 d1bar_L2 gp_2_23_12 ctn_L1_41 0 NSYN W=10u L=1u
MpTa_L1_41_13 dpre_L2_26 gp_2_26_13 ctp_L1_41 0 NSYN W=10u L=1u
MnTb_L1_41_13 d1bar_L2 vcn ctp_L1_41 0 NSYN W=10u L=1u
MnTa_L1_41_13 dpre_L2_26 vcn ctn_L1_41 0 NSYN W=10u L=1u
MpTb_L1_41_13 d1bar_L2 gp_2_26_13 ctn_L1_41 0 NSYN W=10u L=1u
MpTa_L1_41_14 dpre_L2_28 gp_2_28_14 ctp_L1_41 0 NSYN W=10u L=1u
MnTb_L1_41_14 d1bar_L2 vcn ctp_L1_41 0 NSYN W=10u L=1u
MnTa_L1_41_14 dpre_L2_28 vcn ctn_L1_41 0 NSYN W=10u L=1u
MpTb_L1_41_14 d1bar_L2 gp_2_28_14 ctn_L1_41 0 NSYN W=10u L=1u
MpTa_L1_41_15 dpre_L2_32 gp_2_32_12 ctp_L1_41 0 NSYN W=10u L=1u
MnTb_L1_41_15 d1bar_L2 vcn ctp_L1_41 0 NSYN W=10u L=1u
MnTa_L1_41_15 dpre_L2_32 vcn ctn_L1_41 0 NSYN W=10u L=1u
MpTb_L1_41_15 d1bar_L2 gp_2_32_12 ctn_L1_41 0 NSYN W=10u L=1u
MpTa_L1_41_16 dpre_L2_34 gp_2_34_12 ctp_L1_41 0 NSYN W=10u L=1u
MnTb_L1_41_16 d1bar_L2 vcn ctp_L1_41 0 NSYN W=10u L=1u
MnTa_L1_41_16 dpre_L2_34 vcn ctn_L1_41 0 NSYN W=10u L=1u
MpTb_L1_41_16 d1bar_L2 gp_2_34_12 ctn_L1_41 0 NSYN W=10u L=1u
MpTa_L1_41_17 dpre_L2_35 gp_2_35_13 ctp_L1_41 0 NSYN W=10u L=1u
MnTb_L1_41_17 d1bar_L2 vcn ctp_L1_41 0 NSYN W=10u L=1u
MnTa_L1_41_17 dpre_L2_35 vcn ctn_L1_41 0 NSYN W=10u L=1u
MpTb_L1_41_17 d1bar_L2 gp_2_35_13 ctn_L1_41 0 NSYN W=10u L=1u
MpTa_L1_41_18 dpre_L2_39 gp_2_39_13 ctp_L1_41 0 NSYN W=10u L=1u
MnTb_L1_41_18 d1bar_L2 vcn ctp_L1_41 0 NSYN W=10u L=1u
MnTa_L1_41_18 dpre_L2_39 vcn ctn_L1_41 0 NSYN W=10u L=1u
MpTb_L1_41_18 d1bar_L2 gp_2_39_13 ctn_L1_41 0 NSYN W=10u L=1u
MpTa_L1_41_19 dpre_L2_40 gp_2_40_13 ctp_L1_41 0 NSYN W=10u L=1u
MnTb_L1_41_19 d1bar_L2 vcn ctp_L1_41 0 NSYN W=10u L=1u
MnTa_L1_41_19 dpre_L2_40 vcn ctn_L1_41 0 NSYN W=10u L=1u
MpTb_L1_41_19 d1bar_L2 gp_2_40_13 ctn_L1_41 0 NSYN W=10u L=1u
MpTa_L1_41_20 dpre_L2_41 gp_2_41_12 ctp_L1_41 0 NSYN W=10u L=1u
MnTb_L1_41_20 d1bar_L2 vcn ctp_L1_41 0 NSYN W=10u L=1u
MnTa_L1_41_20 dpre_L2_41 vcn ctn_L1_41 0 NSYN W=10u L=1u
MpTb_L1_41_20 d1bar_L2 gp_2_41_12 ctn_L1_41 0 NSYN W=10u L=1u
MpTa_L1_41_21 dpre_L2_45 gp_2_45_14 ctp_L1_41 0 NSYN W=10u L=1u
MnTb_L1_41_21 d1bar_L2 vcn ctp_L1_41 0 NSYN W=10u L=1u
MnTa_L1_41_21 dpre_L2_45 vcn ctn_L1_41 0 NSYN W=10u L=1u
MpTb_L1_41_21 d1bar_L2 gp_2_45_14 ctn_L1_41 0 NSYN W=10u L=1u
MpTa_L1_41_22 dpre_L2_46 gp_2_46_14 ctp_L1_41 0 NSYN W=10u L=1u
MnTb_L1_41_22 d1bar_L2 vcn ctp_L1_41 0 NSYN W=10u L=1u
MnTa_L1_41_22 dpre_L2_46 vcn ctn_L1_41 0 NSYN W=10u L=1u
MpTb_L1_41_22 d1bar_L2 gp_2_46_14 ctn_L1_41 0 NSYN W=10u L=1u
Msa_bk_L1_41 ctn_L1_41 ctn_L1_41 0 0 NMIR W=20u L=1u
Msb_bk_L1_41 dpre_L1_41 ctn_L1_41 0 0 NMIR W=20u L=1u
Msc_bk_L1_41 ctp_L1_41 ctp_L1_41 0 0 NMIR W=20u L=1u
Msd_bk_L1_41 dpf_bk_L1_41 ctp_L1_41 0 0 NMIR W=20u L=1u
Mse_bk_L1_41 dpf_bk_L1_41 dpf_bk_L1_41 vdd vdd PMIR W=60u L=1u
Msf_bk_L1_41 dpre_L1_41 dpf_bk_L1_41 vdd vdd PMIR W=60u L=1u
R_bk_L1_41 dpre_L1_41 vrefd 16000.0
MpTa_L1_42_0 dpre_L2_0 gp_2_0_15 ctp_L1_42 0 NSYN W=10u L=1u
MnTb_L1_42_0 d1bar_L2 vcn ctp_L1_42 0 NSYN W=10u L=1u
MnTa_L1_42_0 dpre_L2_0 vcn ctn_L1_42 0 NSYN W=10u L=1u
MpTb_L1_42_0 d1bar_L2 gp_2_0_15 ctn_L1_42 0 NSYN W=10u L=1u
MpTa_L1_42_1 dpre_L2_4 gp_2_4_14 ctp_L1_42 0 NSYN W=10u L=1u
MnTb_L1_42_1 d1bar_L2 vcn ctp_L1_42 0 NSYN W=10u L=1u
MnTa_L1_42_1 dpre_L2_4 vcn ctn_L1_42 0 NSYN W=10u L=1u
MpTb_L1_42_1 d1bar_L2 gp_2_4_14 ctn_L1_42 0 NSYN W=10u L=1u
MpTa_L1_42_2 dpre_L2_9 gp_2_9_13 ctp_L1_42 0 NSYN W=10u L=1u
MnTb_L1_42_2 d1bar_L2 vcn ctp_L1_42 0 NSYN W=10u L=1u
MnTa_L1_42_2 dpre_L2_9 vcn ctn_L1_42 0 NSYN W=10u L=1u
MpTb_L1_42_2 d1bar_L2 gp_2_9_13 ctn_L1_42 0 NSYN W=10u L=1u
MpTa_L1_42_3 dpre_L2_12 gp_2_12_12 ctp_L1_42 0 NSYN W=10u L=1u
MnTb_L1_42_3 d1bar_L2 vcn ctp_L1_42 0 NSYN W=10u L=1u
MnTa_L1_42_3 dpre_L2_12 vcn ctn_L1_42 0 NSYN W=10u L=1u
MpTb_L1_42_3 d1bar_L2 gp_2_12_12 ctn_L1_42 0 NSYN W=10u L=1u
MpTa_L1_42_4 dpre_L2_16 gp_2_16_14 ctp_L1_42 0 NSYN W=10u L=1u
MnTb_L1_42_4 d1bar_L2 vcn ctp_L1_42 0 NSYN W=10u L=1u
MnTa_L1_42_4 dpre_L2_16 vcn ctn_L1_42 0 NSYN W=10u L=1u
MpTb_L1_42_4 d1bar_L2 gp_2_16_14 ctn_L1_42 0 NSYN W=10u L=1u
MpTa_L1_42_5 dpre_L2_19 gp_2_19_13 ctp_L1_42 0 NSYN W=10u L=1u
MnTb_L1_42_5 d1bar_L2 vcn ctp_L1_42 0 NSYN W=10u L=1u
MnTa_L1_42_5 dpre_L2_19 vcn ctn_L1_42 0 NSYN W=10u L=1u
MpTb_L1_42_5 d1bar_L2 gp_2_19_13 ctn_L1_42 0 NSYN W=10u L=1u
MpTa_L1_42_6 dpre_L2_23 gp_2_23_13 ctp_L1_42 0 NSYN W=10u L=1u
MnTb_L1_42_6 d1bar_L2 vcn ctp_L1_42 0 NSYN W=10u L=1u
MnTa_L1_42_6 dpre_L2_23 vcn ctn_L1_42 0 NSYN W=10u L=1u
MpTb_L1_42_6 d1bar_L2 gp_2_23_13 ctn_L1_42 0 NSYN W=10u L=1u
MpTa_L1_42_7 dpre_L2_25 gp_2_25_15 ctp_L1_42 0 NSYN W=10u L=1u
MnTb_L1_42_7 d1bar_L2 vcn ctp_L1_42 0 NSYN W=10u L=1u
MnTa_L1_42_7 dpre_L2_25 vcn ctn_L1_42 0 NSYN W=10u L=1u
MpTb_L1_42_7 d1bar_L2 gp_2_25_15 ctn_L1_42 0 NSYN W=10u L=1u
MpTa_L1_42_8 dpre_L2_29 gp_2_29_12 ctp_L1_42 0 NSYN W=10u L=1u
MnTb_L1_42_8 d1bar_L2 vcn ctp_L1_42 0 NSYN W=10u L=1u
MnTa_L1_42_8 dpre_L2_29 vcn ctn_L1_42 0 NSYN W=10u L=1u
MpTb_L1_42_8 d1bar_L2 gp_2_29_12 ctn_L1_42 0 NSYN W=10u L=1u
MpTa_L1_42_9 dpre_L2_30 gp_2_30_14 ctp_L1_42 0 NSYN W=10u L=1u
MnTb_L1_42_9 d1bar_L2 vcn ctp_L1_42 0 NSYN W=10u L=1u
MnTa_L1_42_9 dpre_L2_30 vcn ctn_L1_42 0 NSYN W=10u L=1u
MpTb_L1_42_9 d1bar_L2 gp_2_30_14 ctn_L1_42 0 NSYN W=10u L=1u
MpTa_L1_42_10 dpre_L2_34 gp_2_34_13 ctp_L1_42 0 NSYN W=10u L=1u
MnTb_L1_42_10 d1bar_L2 vcn ctp_L1_42 0 NSYN W=10u L=1u
MnTa_L1_42_10 dpre_L2_34 vcn ctn_L1_42 0 NSYN W=10u L=1u
MpTb_L1_42_10 d1bar_L2 gp_2_34_13 ctn_L1_42 0 NSYN W=10u L=1u
MpTa_L1_42_11 dpre_L2_35 gp_2_35_14 ctp_L1_42 0 NSYN W=10u L=1u
MnTb_L1_42_11 d1bar_L2 vcn ctp_L1_42 0 NSYN W=10u L=1u
MnTa_L1_42_11 dpre_L2_35 vcn ctn_L1_42 0 NSYN W=10u L=1u
MpTb_L1_42_11 d1bar_L2 gp_2_35_14 ctn_L1_42 0 NSYN W=10u L=1u
MpTa_L1_42_12 dpre_L2_37 gp_2_37_11 ctp_L1_42 0 NSYN W=10u L=1u
MnTb_L1_42_12 d1bar_L2 vcn ctp_L1_42 0 NSYN W=10u L=1u
MnTa_L1_42_12 dpre_L2_37 vcn ctn_L1_42 0 NSYN W=10u L=1u
MpTb_L1_42_12 d1bar_L2 gp_2_37_11 ctn_L1_42 0 NSYN W=10u L=1u
MpTa_L1_42_13 dpre_L2_38 gp_2_38_11 ctp_L1_42 0 NSYN W=10u L=1u
MnTb_L1_42_13 d1bar_L2 vcn ctp_L1_42 0 NSYN W=10u L=1u
MnTa_L1_42_13 dpre_L2_38 vcn ctn_L1_42 0 NSYN W=10u L=1u
MpTb_L1_42_13 d1bar_L2 gp_2_38_11 ctn_L1_42 0 NSYN W=10u L=1u
Msa_bk_L1_42 ctn_L1_42 ctn_L1_42 0 0 NMIR W=20u L=1u
Msb_bk_L1_42 dpre_L1_42 ctn_L1_42 0 0 NMIR W=20u L=1u
Msc_bk_L1_42 ctp_L1_42 ctp_L1_42 0 0 NMIR W=20u L=1u
Msd_bk_L1_42 dpf_bk_L1_42 ctp_L1_42 0 0 NMIR W=20u L=1u
Mse_bk_L1_42 dpf_bk_L1_42 dpf_bk_L1_42 vdd vdd PMIR W=60u L=1u
Msf_bk_L1_42 dpre_L1_42 dpf_bk_L1_42 vdd vdd PMIR W=60u L=1u
R_bk_L1_42 dpre_L1_42 vrefd 16000.0
MpTa_L1_43_0 dpre_L2_5 gp_2_5_15 ctp_L1_43 0 NSYN W=10u L=1u
MnTb_L1_43_0 d1bar_L2 vcn ctp_L1_43 0 NSYN W=10u L=1u
MnTa_L1_43_0 dpre_L2_5 vcn ctn_L1_43 0 NSYN W=10u L=1u
MpTb_L1_43_0 d1bar_L2 gp_2_5_15 ctn_L1_43 0 NSYN W=10u L=1u
MpTa_L1_43_1 dpre_L2_6 gp_2_6_14 ctp_L1_43 0 NSYN W=10u L=1u
MnTb_L1_43_1 d1bar_L2 vcn ctp_L1_43 0 NSYN W=10u L=1u
MnTa_L1_43_1 dpre_L2_6 vcn ctn_L1_43 0 NSYN W=10u L=1u
MpTb_L1_43_1 d1bar_L2 gp_2_6_14 ctn_L1_43 0 NSYN W=10u L=1u
MpTa_L1_43_2 dpre_L2_9 gp_2_9_14 ctp_L1_43 0 NSYN W=10u L=1u
MnTb_L1_43_2 d1bar_L2 vcn ctp_L1_43 0 NSYN W=10u L=1u
MnTa_L1_43_2 dpre_L2_9 vcn ctn_L1_43 0 NSYN W=10u L=1u
MpTb_L1_43_2 d1bar_L2 gp_2_9_14 ctn_L1_43 0 NSYN W=10u L=1u
MpTa_L1_43_3 dpre_L2_12 gp_2_12_13 ctp_L1_43 0 NSYN W=10u L=1u
MnTb_L1_43_3 d1bar_L2 vcn ctp_L1_43 0 NSYN W=10u L=1u
MnTa_L1_43_3 dpre_L2_12 vcn ctn_L1_43 0 NSYN W=10u L=1u
MpTb_L1_43_3 d1bar_L2 gp_2_12_13 ctn_L1_43 0 NSYN W=10u L=1u
MpTa_L1_43_4 dpre_L2_13 gp_2_13_14 ctp_L1_43 0 NSYN W=10u L=1u
MnTb_L1_43_4 d1bar_L2 vcn ctp_L1_43 0 NSYN W=10u L=1u
MnTa_L1_43_4 dpre_L2_13 vcn ctn_L1_43 0 NSYN W=10u L=1u
MpTb_L1_43_4 d1bar_L2 gp_2_13_14 ctn_L1_43 0 NSYN W=10u L=1u
MpTa_L1_43_5 dpre_L2_14 gp_2_14_15 ctp_L1_43 0 NSYN W=10u L=1u
MnTb_L1_43_5 d1bar_L2 vcn ctp_L1_43 0 NSYN W=10u L=1u
MnTa_L1_43_5 dpre_L2_14 vcn ctn_L1_43 0 NSYN W=10u L=1u
MpTb_L1_43_5 d1bar_L2 gp_2_14_15 ctn_L1_43 0 NSYN W=10u L=1u
MpTa_L1_43_6 dpre_L2_15 gp_2_15_14 ctp_L1_43 0 NSYN W=10u L=1u
MnTb_L1_43_6 d1bar_L2 vcn ctp_L1_43 0 NSYN W=10u L=1u
MnTa_L1_43_6 dpre_L2_15 vcn ctn_L1_43 0 NSYN W=10u L=1u
MpTb_L1_43_6 d1bar_L2 gp_2_15_14 ctn_L1_43 0 NSYN W=10u L=1u
MpTa_L1_43_7 dpre_L2_20 gp_2_20_13 ctp_L1_43 0 NSYN W=10u L=1u
MnTb_L1_43_7 d1bar_L2 vcn ctp_L1_43 0 NSYN W=10u L=1u
MnTa_L1_43_7 dpre_L2_20 vcn ctn_L1_43 0 NSYN W=10u L=1u
MpTb_L1_43_7 d1bar_L2 gp_2_20_13 ctn_L1_43 0 NSYN W=10u L=1u
MpTa_L1_43_8 dpre_L2_22 gp_2_22_13 ctp_L1_43 0 NSYN W=10u L=1u
MnTb_L1_43_8 d1bar_L2 vcn ctp_L1_43 0 NSYN W=10u L=1u
MnTa_L1_43_8 dpre_L2_22 vcn ctn_L1_43 0 NSYN W=10u L=1u
MpTb_L1_43_8 d1bar_L2 gp_2_22_13 ctn_L1_43 0 NSYN W=10u L=1u
MpTa_L1_43_9 dpre_L2_26 gp_2_26_14 ctp_L1_43 0 NSYN W=10u L=1u
MnTb_L1_43_9 d1bar_L2 vcn ctp_L1_43 0 NSYN W=10u L=1u
MnTa_L1_43_9 dpre_L2_26 vcn ctn_L1_43 0 NSYN W=10u L=1u
MpTb_L1_43_9 d1bar_L2 gp_2_26_14 ctn_L1_43 0 NSYN W=10u L=1u
MpTa_L1_43_10 dpre_L2_29 gp_2_29_13 ctp_L1_43 0 NSYN W=10u L=1u
MnTb_L1_43_10 d1bar_L2 vcn ctp_L1_43 0 NSYN W=10u L=1u
MnTa_L1_43_10 dpre_L2_29 vcn ctn_L1_43 0 NSYN W=10u L=1u
MpTb_L1_43_10 d1bar_L2 gp_2_29_13 ctn_L1_43 0 NSYN W=10u L=1u
MpTa_L1_43_11 dpre_L2_33 gp_2_33_13 ctp_L1_43 0 NSYN W=10u L=1u
MnTb_L1_43_11 d1bar_L2 vcn ctp_L1_43 0 NSYN W=10u L=1u
MnTa_L1_43_11 dpre_L2_33 vcn ctn_L1_43 0 NSYN W=10u L=1u
MpTb_L1_43_11 d1bar_L2 gp_2_33_13 ctn_L1_43 0 NSYN W=10u L=1u
MpTa_L1_43_12 dpre_L2_34 gp_2_34_14 ctp_L1_43 0 NSYN W=10u L=1u
MnTb_L1_43_12 d1bar_L2 vcn ctp_L1_43 0 NSYN W=10u L=1u
MnTa_L1_43_12 dpre_L2_34 vcn ctn_L1_43 0 NSYN W=10u L=1u
MpTb_L1_43_12 d1bar_L2 gp_2_34_14 ctn_L1_43 0 NSYN W=10u L=1u
MpTa_L1_43_13 dpre_L2_36 gp_2_36_14 ctp_L1_43 0 NSYN W=10u L=1u
MnTb_L1_43_13 d1bar_L2 vcn ctp_L1_43 0 NSYN W=10u L=1u
MnTa_L1_43_13 dpre_L2_36 vcn ctn_L1_43 0 NSYN W=10u L=1u
MpTb_L1_43_13 d1bar_L2 gp_2_36_14 ctn_L1_43 0 NSYN W=10u L=1u
MpTa_L1_43_14 dpre_L2_37 gp_2_37_12 ctp_L1_43 0 NSYN W=10u L=1u
MnTb_L1_43_14 d1bar_L2 vcn ctp_L1_43 0 NSYN W=10u L=1u
MnTa_L1_43_14 dpre_L2_37 vcn ctn_L1_43 0 NSYN W=10u L=1u
MpTb_L1_43_14 d1bar_L2 gp_2_37_12 ctn_L1_43 0 NSYN W=10u L=1u
MpTa_L1_43_15 dpre_L2_38 gp_2_38_12 ctp_L1_43 0 NSYN W=10u L=1u
MnTb_L1_43_15 d1bar_L2 vcn ctp_L1_43 0 NSYN W=10u L=1u
MnTa_L1_43_15 dpre_L2_38 vcn ctn_L1_43 0 NSYN W=10u L=1u
MpTb_L1_43_15 d1bar_L2 gp_2_38_12 ctn_L1_43 0 NSYN W=10u L=1u
MpTa_L1_43_16 dpre_L2_42 gp_2_42_14 ctp_L1_43 0 NSYN W=10u L=1u
MnTb_L1_43_16 d1bar_L2 vcn ctp_L1_43 0 NSYN W=10u L=1u
MnTa_L1_43_16 dpre_L2_42 vcn ctn_L1_43 0 NSYN W=10u L=1u
MpTb_L1_43_16 d1bar_L2 gp_2_42_14 ctn_L1_43 0 NSYN W=10u L=1u
MpTa_L1_43_17 dpre_L2_47 gp_2_47_14 ctp_L1_43 0 NSYN W=10u L=1u
MnTb_L1_43_17 d1bar_L2 vcn ctp_L1_43 0 NSYN W=10u L=1u
MnTa_L1_43_17 dpre_L2_47 vcn ctn_L1_43 0 NSYN W=10u L=1u
MpTb_L1_43_17 d1bar_L2 gp_2_47_14 ctn_L1_43 0 NSYN W=10u L=1u
Msa_bk_L1_43 ctn_L1_43 ctn_L1_43 0 0 NMIR W=20u L=1u
Msb_bk_L1_43 dpre_L1_43 ctn_L1_43 0 0 NMIR W=20u L=1u
Msc_bk_L1_43 ctp_L1_43 ctp_L1_43 0 0 NMIR W=20u L=1u
Msd_bk_L1_43 dpf_bk_L1_43 ctp_L1_43 0 0 NMIR W=20u L=1u
Mse_bk_L1_43 dpf_bk_L1_43 dpf_bk_L1_43 vdd vdd PMIR W=60u L=1u
Msf_bk_L1_43 dpre_L1_43 dpf_bk_L1_43 vdd vdd PMIR W=60u L=1u
R_bk_L1_43 dpre_L1_43 vrefd 16000.0
MpTa_L1_44_0 dpre_L2_2 gp_2_2_13 ctp_L1_44 0 NSYN W=10u L=1u
MnTb_L1_44_0 d1bar_L2 vcn ctp_L1_44 0 NSYN W=10u L=1u
MnTa_L1_44_0 dpre_L2_2 vcn ctn_L1_44 0 NSYN W=10u L=1u
MpTb_L1_44_0 d1bar_L2 gp_2_2_13 ctn_L1_44 0 NSYN W=10u L=1u
MpTa_L1_44_1 dpre_L2_4 gp_2_4_15 ctp_L1_44 0 NSYN W=10u L=1u
MnTb_L1_44_1 d1bar_L2 vcn ctp_L1_44 0 NSYN W=10u L=1u
MnTa_L1_44_1 dpre_L2_4 vcn ctn_L1_44 0 NSYN W=10u L=1u
MpTb_L1_44_1 d1bar_L2 gp_2_4_15 ctn_L1_44 0 NSYN W=10u L=1u
MpTa_L1_44_2 dpre_L2_8 gp_2_8_13 ctp_L1_44 0 NSYN W=10u L=1u
MnTb_L1_44_2 d1bar_L2 vcn ctp_L1_44 0 NSYN W=10u L=1u
MnTa_L1_44_2 dpre_L2_8 vcn ctn_L1_44 0 NSYN W=10u L=1u
MpTb_L1_44_2 d1bar_L2 gp_2_8_13 ctn_L1_44 0 NSYN W=10u L=1u
MpTa_L1_44_3 dpre_L2_13 gp_2_13_15 ctp_L1_44 0 NSYN W=10u L=1u
MnTb_L1_44_3 d1bar_L2 vcn ctp_L1_44 0 NSYN W=10u L=1u
MnTa_L1_44_3 dpre_L2_13 vcn ctn_L1_44 0 NSYN W=10u L=1u
MpTb_L1_44_3 d1bar_L2 gp_2_13_15 ctn_L1_44 0 NSYN W=10u L=1u
MpTa_L1_44_4 dpre_L2_19 gp_2_19_14 ctp_L1_44 0 NSYN W=10u L=1u
MnTb_L1_44_4 d1bar_L2 vcn ctp_L1_44 0 NSYN W=10u L=1u
MnTa_L1_44_4 dpre_L2_19 vcn ctn_L1_44 0 NSYN W=10u L=1u
MpTb_L1_44_4 d1bar_L2 gp_2_19_14 ctn_L1_44 0 NSYN W=10u L=1u
MpTa_L1_44_5 dpre_L2_27 gp_2_27_15 ctp_L1_44 0 NSYN W=10u L=1u
MnTb_L1_44_5 d1bar_L2 vcn ctp_L1_44 0 NSYN W=10u L=1u
MnTa_L1_44_5 dpre_L2_27 vcn ctn_L1_44 0 NSYN W=10u L=1u
MpTb_L1_44_5 d1bar_L2 gp_2_27_15 ctn_L1_44 0 NSYN W=10u L=1u
MpTa_L1_44_6 dpre_L2_32 gp_2_32_13 ctp_L1_44 0 NSYN W=10u L=1u
MnTb_L1_44_6 d1bar_L2 vcn ctp_L1_44 0 NSYN W=10u L=1u
MnTa_L1_44_6 dpre_L2_32 vcn ctn_L1_44 0 NSYN W=10u L=1u
MpTb_L1_44_6 d1bar_L2 gp_2_32_13 ctn_L1_44 0 NSYN W=10u L=1u
MpTa_L1_44_7 dpre_L2_33 gp_2_33_14 ctp_L1_44 0 NSYN W=10u L=1u
MnTb_L1_44_7 d1bar_L2 vcn ctp_L1_44 0 NSYN W=10u L=1u
MnTa_L1_44_7 dpre_L2_33 vcn ctn_L1_44 0 NSYN W=10u L=1u
MpTb_L1_44_7 d1bar_L2 gp_2_33_14 ctn_L1_44 0 NSYN W=10u L=1u
MpTa_L1_44_8 dpre_L2_37 gp_2_37_13 ctp_L1_44 0 NSYN W=10u L=1u
MnTb_L1_44_8 d1bar_L2 vcn ctp_L1_44 0 NSYN W=10u L=1u
MnTa_L1_44_8 dpre_L2_37 vcn ctn_L1_44 0 NSYN W=10u L=1u
MpTb_L1_44_8 d1bar_L2 gp_2_37_13 ctn_L1_44 0 NSYN W=10u L=1u
MpTa_L1_44_9 dpre_L2_38 gp_2_38_13 ctp_L1_44 0 NSYN W=10u L=1u
MnTb_L1_44_9 d1bar_L2 vcn ctp_L1_44 0 NSYN W=10u L=1u
MnTa_L1_44_9 dpre_L2_38 vcn ctn_L1_44 0 NSYN W=10u L=1u
MpTb_L1_44_9 d1bar_L2 gp_2_38_13 ctn_L1_44 0 NSYN W=10u L=1u
MpTa_L1_44_10 dpre_L2_39 gp_2_39_14 ctp_L1_44 0 NSYN W=10u L=1u
MnTb_L1_44_10 d1bar_L2 vcn ctp_L1_44 0 NSYN W=10u L=1u
MnTa_L1_44_10 dpre_L2_39 vcn ctn_L1_44 0 NSYN W=10u L=1u
MpTb_L1_44_10 d1bar_L2 gp_2_39_14 ctn_L1_44 0 NSYN W=10u L=1u
MpTa_L1_44_11 dpre_L2_40 gp_2_40_14 ctp_L1_44 0 NSYN W=10u L=1u
MnTb_L1_44_11 d1bar_L2 vcn ctp_L1_44 0 NSYN W=10u L=1u
MnTa_L1_44_11 dpre_L2_40 vcn ctn_L1_44 0 NSYN W=10u L=1u
MpTb_L1_44_11 d1bar_L2 gp_2_40_14 ctn_L1_44 0 NSYN W=10u L=1u
MpTa_L1_44_12 dpre_L2_41 gp_2_41_13 ctp_L1_44 0 NSYN W=10u L=1u
MnTb_L1_44_12 d1bar_L2 vcn ctp_L1_44 0 NSYN W=10u L=1u
MnTa_L1_44_12 dpre_L2_41 vcn ctn_L1_44 0 NSYN W=10u L=1u
MpTb_L1_44_12 d1bar_L2 gp_2_41_13 ctn_L1_44 0 NSYN W=10u L=1u
MpTa_L1_44_13 dpre_L2_42 gp_2_42_15 ctp_L1_44 0 NSYN W=10u L=1u
MnTb_L1_44_13 d1bar_L2 vcn ctp_L1_44 0 NSYN W=10u L=1u
MnTa_L1_44_13 dpre_L2_42 vcn ctn_L1_44 0 NSYN W=10u L=1u
MpTb_L1_44_13 d1bar_L2 gp_2_42_15 ctn_L1_44 0 NSYN W=10u L=1u
MpTa_L1_44_14 dpre_L2_46 gp_2_46_15 ctp_L1_44 0 NSYN W=10u L=1u
MnTb_L1_44_14 d1bar_L2 vcn ctp_L1_44 0 NSYN W=10u L=1u
MnTa_L1_44_14 dpre_L2_46 vcn ctn_L1_44 0 NSYN W=10u L=1u
MpTb_L1_44_14 d1bar_L2 gp_2_46_15 ctn_L1_44 0 NSYN W=10u L=1u
Msa_bk_L1_44 ctn_L1_44 ctn_L1_44 0 0 NMIR W=20u L=1u
Msb_bk_L1_44 dpre_L1_44 ctn_L1_44 0 0 NMIR W=20u L=1u
Msc_bk_L1_44 ctp_L1_44 ctp_L1_44 0 0 NMIR W=20u L=1u
Msd_bk_L1_44 dpf_bk_L1_44 ctp_L1_44 0 0 NMIR W=20u L=1u
Mse_bk_L1_44 dpf_bk_L1_44 dpf_bk_L1_44 vdd vdd PMIR W=60u L=1u
Msf_bk_L1_44 dpre_L1_44 dpf_bk_L1_44 vdd vdd PMIR W=60u L=1u
R_bk_L1_44 dpre_L1_44 vrefd 16000.0
MpTa_L1_45_0 dpre_L2_1 gp_2_1_14 ctp_L1_45 0 NSYN W=10u L=1u
MnTb_L1_45_0 d1bar_L2 vcn ctp_L1_45 0 NSYN W=10u L=1u
MnTa_L1_45_0 dpre_L2_1 vcn ctn_L1_45 0 NSYN W=10u L=1u
MpTb_L1_45_0 d1bar_L2 gp_2_1_14 ctn_L1_45 0 NSYN W=10u L=1u
MpTa_L1_45_1 dpre_L2_2 gp_2_2_14 ctp_L1_45 0 NSYN W=10u L=1u
MnTb_L1_45_1 d1bar_L2 vcn ctp_L1_45 0 NSYN W=10u L=1u
MnTa_L1_45_1 dpre_L2_2 vcn ctn_L1_45 0 NSYN W=10u L=1u
MpTb_L1_45_1 d1bar_L2 gp_2_2_14 ctn_L1_45 0 NSYN W=10u L=1u
MpTa_L1_45_2 dpre_L2_6 gp_2_6_15 ctp_L1_45 0 NSYN W=10u L=1u
MnTb_L1_45_2 d1bar_L2 vcn ctp_L1_45 0 NSYN W=10u L=1u
MnTa_L1_45_2 dpre_L2_6 vcn ctn_L1_45 0 NSYN W=10u L=1u
MpTb_L1_45_2 d1bar_L2 gp_2_6_15 ctn_L1_45 0 NSYN W=10u L=1u
MpTa_L1_45_3 dpre_L2_8 gp_2_8_14 ctp_L1_45 0 NSYN W=10u L=1u
MnTb_L1_45_3 d1bar_L2 vcn ctp_L1_45 0 NSYN W=10u L=1u
MnTa_L1_45_3 dpre_L2_8 vcn ctn_L1_45 0 NSYN W=10u L=1u
MpTb_L1_45_3 d1bar_L2 gp_2_8_14 ctn_L1_45 0 NSYN W=10u L=1u
MpTa_L1_45_4 dpre_L2_9 gp_2_9_15 ctp_L1_45 0 NSYN W=10u L=1u
MnTb_L1_45_4 d1bar_L2 vcn ctp_L1_45 0 NSYN W=10u L=1u
MnTa_L1_45_4 dpre_L2_9 vcn ctn_L1_45 0 NSYN W=10u L=1u
MpTb_L1_45_4 d1bar_L2 gp_2_9_15 ctn_L1_45 0 NSYN W=10u L=1u
MpTa_L1_45_5 dpre_L2_12 gp_2_12_14 ctp_L1_45 0 NSYN W=10u L=1u
MnTb_L1_45_5 d1bar_L2 vcn ctp_L1_45 0 NSYN W=10u L=1u
MnTa_L1_45_5 dpre_L2_12 vcn ctn_L1_45 0 NSYN W=10u L=1u
MpTb_L1_45_5 d1bar_L2 gp_2_12_14 ctn_L1_45 0 NSYN W=10u L=1u
MpTa_L1_45_6 dpre_L2_16 gp_2_16_15 ctp_L1_45 0 NSYN W=10u L=1u
MnTb_L1_45_6 d1bar_L2 vcn ctp_L1_45 0 NSYN W=10u L=1u
MnTa_L1_45_6 dpre_L2_16 vcn ctn_L1_45 0 NSYN W=10u L=1u
MpTb_L1_45_6 d1bar_L2 gp_2_16_15 ctn_L1_45 0 NSYN W=10u L=1u
MpTa_L1_45_7 dpre_L2_19 gp_2_19_15 ctp_L1_45 0 NSYN W=10u L=1u
MnTb_L1_45_7 d1bar_L2 vcn ctp_L1_45 0 NSYN W=10u L=1u
MnTa_L1_45_7 dpre_L2_19 vcn ctn_L1_45 0 NSYN W=10u L=1u
MpTb_L1_45_7 d1bar_L2 gp_2_19_15 ctn_L1_45 0 NSYN W=10u L=1u
MpTa_L1_45_8 dpre_L2_21 gp_2_21_14 ctp_L1_45 0 NSYN W=10u L=1u
MnTb_L1_45_8 d1bar_L2 vcn ctp_L1_45 0 NSYN W=10u L=1u
MnTa_L1_45_8 dpre_L2_21 vcn ctn_L1_45 0 NSYN W=10u L=1u
MpTb_L1_45_8 d1bar_L2 gp_2_21_14 ctn_L1_45 0 NSYN W=10u L=1u
MpTa_L1_45_9 dpre_L2_22 gp_2_22_14 ctp_L1_45 0 NSYN W=10u L=1u
MnTb_L1_45_9 d1bar_L2 vcn ctp_L1_45 0 NSYN W=10u L=1u
MnTa_L1_45_9 dpre_L2_22 vcn ctn_L1_45 0 NSYN W=10u L=1u
MpTb_L1_45_9 d1bar_L2 gp_2_22_14 ctn_L1_45 0 NSYN W=10u L=1u
MpTa_L1_45_10 dpre_L2_23 gp_2_23_14 ctp_L1_45 0 NSYN W=10u L=1u
MnTb_L1_45_10 d1bar_L2 vcn ctp_L1_45 0 NSYN W=10u L=1u
MnTa_L1_45_10 dpre_L2_23 vcn ctn_L1_45 0 NSYN W=10u L=1u
MpTb_L1_45_10 d1bar_L2 gp_2_23_14 ctn_L1_45 0 NSYN W=10u L=1u
MpTa_L1_45_11 dpre_L2_24 gp_2_24_15 ctp_L1_45 0 NSYN W=10u L=1u
MnTb_L1_45_11 d1bar_L2 vcn ctp_L1_45 0 NSYN W=10u L=1u
MnTa_L1_45_11 dpre_L2_24 vcn ctn_L1_45 0 NSYN W=10u L=1u
MpTb_L1_45_11 d1bar_L2 gp_2_24_15 ctn_L1_45 0 NSYN W=10u L=1u
MpTa_L1_45_12 dpre_L2_28 gp_2_28_15 ctp_L1_45 0 NSYN W=10u L=1u
MnTb_L1_45_12 d1bar_L2 vcn ctp_L1_45 0 NSYN W=10u L=1u
MnTa_L1_45_12 dpre_L2_28 vcn ctn_L1_45 0 NSYN W=10u L=1u
MpTb_L1_45_12 d1bar_L2 gp_2_28_15 ctn_L1_45 0 NSYN W=10u L=1u
MpTa_L1_45_13 dpre_L2_29 gp_2_29_14 ctp_L1_45 0 NSYN W=10u L=1u
MnTb_L1_45_13 d1bar_L2 vcn ctp_L1_45 0 NSYN W=10u L=1u
MnTa_L1_45_13 dpre_L2_29 vcn ctn_L1_45 0 NSYN W=10u L=1u
MpTb_L1_45_13 d1bar_L2 gp_2_29_14 ctn_L1_45 0 NSYN W=10u L=1u
MpTa_L1_45_14 dpre_L2_31 gp_2_31_14 ctp_L1_45 0 NSYN W=10u L=1u
MnTb_L1_45_14 d1bar_L2 vcn ctp_L1_45 0 NSYN W=10u L=1u
MnTa_L1_45_14 dpre_L2_31 vcn ctn_L1_45 0 NSYN W=10u L=1u
MpTb_L1_45_14 d1bar_L2 gp_2_31_14 ctn_L1_45 0 NSYN W=10u L=1u
MpTa_L1_45_15 dpre_L2_32 gp_2_32_14 ctp_L1_45 0 NSYN W=10u L=1u
MnTb_L1_45_15 d1bar_L2 vcn ctp_L1_45 0 NSYN W=10u L=1u
MnTa_L1_45_15 dpre_L2_32 vcn ctn_L1_45 0 NSYN W=10u L=1u
MpTb_L1_45_15 d1bar_L2 gp_2_32_14 ctn_L1_45 0 NSYN W=10u L=1u
MpTa_L1_45_16 dpre_L2_37 gp_2_37_14 ctp_L1_45 0 NSYN W=10u L=1u
MnTb_L1_45_16 d1bar_L2 vcn ctp_L1_45 0 NSYN W=10u L=1u
MnTa_L1_45_16 dpre_L2_37 vcn ctn_L1_45 0 NSYN W=10u L=1u
MpTb_L1_45_16 d1bar_L2 gp_2_37_14 ctn_L1_45 0 NSYN W=10u L=1u
MpTa_L1_45_17 dpre_L2_38 gp_2_38_14 ctp_L1_45 0 NSYN W=10u L=1u
MnTb_L1_45_17 d1bar_L2 vcn ctp_L1_45 0 NSYN W=10u L=1u
MnTa_L1_45_17 dpre_L2_38 vcn ctn_L1_45 0 NSYN W=10u L=1u
MpTb_L1_45_17 d1bar_L2 gp_2_38_14 ctn_L1_45 0 NSYN W=10u L=1u
MpTa_L1_45_18 dpre_L2_39 gp_2_39_15 ctp_L1_45 0 NSYN W=10u L=1u
MnTb_L1_45_18 d1bar_L2 vcn ctp_L1_45 0 NSYN W=10u L=1u
MnTa_L1_45_18 dpre_L2_39 vcn ctn_L1_45 0 NSYN W=10u L=1u
MpTb_L1_45_18 d1bar_L2 gp_2_39_15 ctn_L1_45 0 NSYN W=10u L=1u
MpTa_L1_45_19 dpre_L2_41 gp_2_41_14 ctp_L1_45 0 NSYN W=10u L=1u
MnTb_L1_45_19 d1bar_L2 vcn ctp_L1_45 0 NSYN W=10u L=1u
MnTa_L1_45_19 dpre_L2_41 vcn ctn_L1_45 0 NSYN W=10u L=1u
MpTb_L1_45_19 d1bar_L2 gp_2_41_14 ctn_L1_45 0 NSYN W=10u L=1u
Msa_bk_L1_45 ctn_L1_45 ctn_L1_45 0 0 NMIR W=20u L=1u
Msb_bk_L1_45 dpre_L1_45 ctn_L1_45 0 0 NMIR W=20u L=1u
Msc_bk_L1_45 ctp_L1_45 ctp_L1_45 0 0 NMIR W=20u L=1u
Msd_bk_L1_45 dpf_bk_L1_45 ctp_L1_45 0 0 NMIR W=20u L=1u
Mse_bk_L1_45 dpf_bk_L1_45 dpf_bk_L1_45 vdd vdd PMIR W=60u L=1u
Msf_bk_L1_45 dpre_L1_45 dpf_bk_L1_45 vdd vdd PMIR W=60u L=1u
R_bk_L1_45 dpre_L1_45 vrefd 16000.0
MpTa_L1_46_0 dpre_L2_1 gp_2_1_15 ctp_L1_46 0 NSYN W=10u L=1u
MnTb_L1_46_0 d1bar_L2 vcn ctp_L1_46 0 NSYN W=10u L=1u
MnTa_L1_46_0 dpre_L2_1 vcn ctn_L1_46 0 NSYN W=10u L=1u
MpTb_L1_46_0 d1bar_L2 gp_2_1_15 ctn_L1_46 0 NSYN W=10u L=1u
MpTa_L1_46_1 dpre_L2_8 gp_2_8_15 ctp_L1_46 0 NSYN W=10u L=1u
MnTb_L1_46_1 d1bar_L2 vcn ctp_L1_46 0 NSYN W=10u L=1u
MnTa_L1_46_1 dpre_L2_8 vcn ctn_L1_46 0 NSYN W=10u L=1u
MpTb_L1_46_1 d1bar_L2 gp_2_8_15 ctn_L1_46 0 NSYN W=10u L=1u
MpTa_L1_46_2 dpre_L2_12 gp_2_12_15 ctp_L1_46 0 NSYN W=10u L=1u
MnTb_L1_46_2 d1bar_L2 vcn ctp_L1_46 0 NSYN W=10u L=1u
MnTa_L1_46_2 dpre_L2_12 vcn ctn_L1_46 0 NSYN W=10u L=1u
MpTb_L1_46_2 d1bar_L2 gp_2_12_15 ctn_L1_46 0 NSYN W=10u L=1u
MpTa_L1_46_3 dpre_L2_15 gp_2_15_15 ctp_L1_46 0 NSYN W=10u L=1u
MnTb_L1_46_3 d1bar_L2 vcn ctp_L1_46 0 NSYN W=10u L=1u
MnTa_L1_46_3 dpre_L2_15 vcn ctn_L1_46 0 NSYN W=10u L=1u
MpTb_L1_46_3 d1bar_L2 gp_2_15_15 ctn_L1_46 0 NSYN W=10u L=1u
MpTa_L1_46_4 dpre_L2_17 gp_2_17_15 ctp_L1_46 0 NSYN W=10u L=1u
MnTb_L1_46_4 d1bar_L2 vcn ctp_L1_46 0 NSYN W=10u L=1u
MnTa_L1_46_4 dpre_L2_17 vcn ctn_L1_46 0 NSYN W=10u L=1u
MpTb_L1_46_4 d1bar_L2 gp_2_17_15 ctn_L1_46 0 NSYN W=10u L=1u
MpTa_L1_46_5 dpre_L2_20 gp_2_20_14 ctp_L1_46 0 NSYN W=10u L=1u
MnTb_L1_46_5 d1bar_L2 vcn ctp_L1_46 0 NSYN W=10u L=1u
MnTa_L1_46_5 dpre_L2_20 vcn ctn_L1_46 0 NSYN W=10u L=1u
MpTb_L1_46_5 d1bar_L2 gp_2_20_14 ctn_L1_46 0 NSYN W=10u L=1u
MpTa_L1_46_6 dpre_L2_22 gp_2_22_15 ctp_L1_46 0 NSYN W=10u L=1u
MnTb_L1_46_6 d1bar_L2 vcn ctp_L1_46 0 NSYN W=10u L=1u
MnTa_L1_46_6 dpre_L2_22 vcn ctn_L1_46 0 NSYN W=10u L=1u
MpTb_L1_46_6 d1bar_L2 gp_2_22_15 ctn_L1_46 0 NSYN W=10u L=1u
MpTa_L1_46_7 dpre_L2_23 gp_2_23_15 ctp_L1_46 0 NSYN W=10u L=1u
MnTb_L1_46_7 d1bar_L2 vcn ctp_L1_46 0 NSYN W=10u L=1u
MnTa_L1_46_7 dpre_L2_23 vcn ctn_L1_46 0 NSYN W=10u L=1u
MpTb_L1_46_7 d1bar_L2 gp_2_23_15 ctn_L1_46 0 NSYN W=10u L=1u
MpTa_L1_46_8 dpre_L2_26 gp_2_26_15 ctp_L1_46 0 NSYN W=10u L=1u
MnTb_L1_46_8 d1bar_L2 vcn ctp_L1_46 0 NSYN W=10u L=1u
MnTa_L1_46_8 dpre_L2_26 vcn ctn_L1_46 0 NSYN W=10u L=1u
MpTb_L1_46_8 d1bar_L2 gp_2_26_15 ctn_L1_46 0 NSYN W=10u L=1u
MpTa_L1_46_9 dpre_L2_29 gp_2_29_15 ctp_L1_46 0 NSYN W=10u L=1u
MnTb_L1_46_9 d1bar_L2 vcn ctp_L1_46 0 NSYN W=10u L=1u
MnTa_L1_46_9 dpre_L2_29 vcn ctn_L1_46 0 NSYN W=10u L=1u
MpTb_L1_46_9 d1bar_L2 gp_2_29_15 ctn_L1_46 0 NSYN W=10u L=1u
MpTa_L1_46_10 dpre_L2_31 gp_2_31_15 ctp_L1_46 0 NSYN W=10u L=1u
MnTb_L1_46_10 d1bar_L2 vcn ctp_L1_46 0 NSYN W=10u L=1u
MnTa_L1_46_10 dpre_L2_31 vcn ctn_L1_46 0 NSYN W=10u L=1u
MpTb_L1_46_10 d1bar_L2 gp_2_31_15 ctn_L1_46 0 NSYN W=10u L=1u
MpTa_L1_46_11 dpre_L2_32 gp_2_32_15 ctp_L1_46 0 NSYN W=10u L=1u
MnTb_L1_46_11 d1bar_L2 vcn ctp_L1_46 0 NSYN W=10u L=1u
MnTa_L1_46_11 dpre_L2_32 vcn ctn_L1_46 0 NSYN W=10u L=1u
MpTb_L1_46_11 d1bar_L2 gp_2_32_15 ctn_L1_46 0 NSYN W=10u L=1u
MpTa_L1_46_12 dpre_L2_35 gp_2_35_15 ctp_L1_46 0 NSYN W=10u L=1u
MnTb_L1_46_12 d1bar_L2 vcn ctp_L1_46 0 NSYN W=10u L=1u
MnTa_L1_46_12 dpre_L2_35 vcn ctn_L1_46 0 NSYN W=10u L=1u
MpTb_L1_46_12 d1bar_L2 gp_2_35_15 ctn_L1_46 0 NSYN W=10u L=1u
MpTa_L1_46_13 dpre_L2_36 gp_2_36_15 ctp_L1_46 0 NSYN W=10u L=1u
MnTb_L1_46_13 d1bar_L2 vcn ctp_L1_46 0 NSYN W=10u L=1u
MnTa_L1_46_13 dpre_L2_36 vcn ctn_L1_46 0 NSYN W=10u L=1u
MpTb_L1_46_13 d1bar_L2 gp_2_36_15 ctn_L1_46 0 NSYN W=10u L=1u
MpTa_L1_46_14 dpre_L2_38 gp_2_38_15 ctp_L1_46 0 NSYN W=10u L=1u
MnTb_L1_46_14 d1bar_L2 vcn ctp_L1_46 0 NSYN W=10u L=1u
MnTa_L1_46_14 dpre_L2_38 vcn ctn_L1_46 0 NSYN W=10u L=1u
MpTb_L1_46_14 d1bar_L2 gp_2_38_15 ctn_L1_46 0 NSYN W=10u L=1u
MpTa_L1_46_15 dpre_L2_40 gp_2_40_15 ctp_L1_46 0 NSYN W=10u L=1u
MnTb_L1_46_15 d1bar_L2 vcn ctp_L1_46 0 NSYN W=10u L=1u
MnTa_L1_46_15 dpre_L2_40 vcn ctn_L1_46 0 NSYN W=10u L=1u
MpTb_L1_46_15 d1bar_L2 gp_2_40_15 ctn_L1_46 0 NSYN W=10u L=1u
MpTa_L1_46_16 dpre_L2_41 gp_2_41_15 ctp_L1_46 0 NSYN W=10u L=1u
MnTb_L1_46_16 d1bar_L2 vcn ctp_L1_46 0 NSYN W=10u L=1u
MnTa_L1_46_16 dpre_L2_41 vcn ctn_L1_46 0 NSYN W=10u L=1u
MpTb_L1_46_16 d1bar_L2 gp_2_41_15 ctn_L1_46 0 NSYN W=10u L=1u
MpTa_L1_46_17 dpre_L2_47 gp_2_47_15 ctp_L1_46 0 NSYN W=10u L=1u
MnTb_L1_46_17 d1bar_L2 vcn ctp_L1_46 0 NSYN W=10u L=1u
MnTa_L1_46_17 dpre_L2_47 vcn ctn_L1_46 0 NSYN W=10u L=1u
MpTb_L1_46_17 d1bar_L2 gp_2_47_15 ctn_L1_46 0 NSYN W=10u L=1u
Msa_bk_L1_46 ctn_L1_46 ctn_L1_46 0 0 NMIR W=20u L=1u
Msb_bk_L1_46 dpre_L1_46 ctn_L1_46 0 0 NMIR W=20u L=1u
Msc_bk_L1_46 ctp_L1_46 ctp_L1_46 0 0 NMIR W=20u L=1u
Msd_bk_L1_46 dpf_bk_L1_46 ctp_L1_46 0 0 NMIR W=20u L=1u
Mse_bk_L1_46 dpf_bk_L1_46 dpf_bk_L1_46 vdd vdd PMIR W=60u L=1u
Msf_bk_L1_46 dpre_L1_46 dpf_bk_L1_46 vdd vdd PMIR W=60u L=1u
R_bk_L1_46 dpre_L1_46 vrefd 16000.0
MpTa_L1_47_0 dpre_L2_2 gp_2_2_15 ctp_L1_47 0 NSYN W=10u L=1u
MnTb_L1_47_0 d1bar_L2 vcn ctp_L1_47 0 NSYN W=10u L=1u
MnTa_L1_47_0 dpre_L2_2 vcn ctn_L1_47 0 NSYN W=10u L=1u
MpTb_L1_47_0 d1bar_L2 gp_2_2_15 ctn_L1_47 0 NSYN W=10u L=1u
MpTa_L1_47_1 dpre_L2_10 gp_2_10_15 ctp_L1_47 0 NSYN W=10u L=1u
MnTb_L1_47_1 d1bar_L2 vcn ctp_L1_47 0 NSYN W=10u L=1u
MnTa_L1_47_1 dpre_L2_10 vcn ctn_L1_47 0 NSYN W=10u L=1u
MpTb_L1_47_1 d1bar_L2 gp_2_10_15 ctn_L1_47 0 NSYN W=10u L=1u
MpTa_L1_47_2 dpre_L2_20 gp_2_20_15 ctp_L1_47 0 NSYN W=10u L=1u
MnTb_L1_47_2 d1bar_L2 vcn ctp_L1_47 0 NSYN W=10u L=1u
MnTa_L1_47_2 dpre_L2_20 vcn ctn_L1_47 0 NSYN W=10u L=1u
MpTb_L1_47_2 d1bar_L2 gp_2_20_15 ctn_L1_47 0 NSYN W=10u L=1u
MpTa_L1_47_3 dpre_L2_21 gp_2_21_15 ctp_L1_47 0 NSYN W=10u L=1u
MnTb_L1_47_3 d1bar_L2 vcn ctp_L1_47 0 NSYN W=10u L=1u
MnTa_L1_47_3 dpre_L2_21 vcn ctn_L1_47 0 NSYN W=10u L=1u
MpTb_L1_47_3 d1bar_L2 gp_2_21_15 ctn_L1_47 0 NSYN W=10u L=1u
MpTa_L1_47_4 dpre_L2_30 gp_2_30_15 ctp_L1_47 0 NSYN W=10u L=1u
MnTb_L1_47_4 d1bar_L2 vcn ctp_L1_47 0 NSYN W=10u L=1u
MnTa_L1_47_4 dpre_L2_30 vcn ctn_L1_47 0 NSYN W=10u L=1u
MpTb_L1_47_4 d1bar_L2 gp_2_30_15 ctn_L1_47 0 NSYN W=10u L=1u
MpTa_L1_47_5 dpre_L2_33 gp_2_33_15 ctp_L1_47 0 NSYN W=10u L=1u
MnTb_L1_47_5 d1bar_L2 vcn ctp_L1_47 0 NSYN W=10u L=1u
MnTa_L1_47_5 dpre_L2_33 vcn ctn_L1_47 0 NSYN W=10u L=1u
MpTb_L1_47_5 d1bar_L2 gp_2_33_15 ctn_L1_47 0 NSYN W=10u L=1u
MpTa_L1_47_6 dpre_L2_34 gp_2_34_15 ctp_L1_47 0 NSYN W=10u L=1u
MnTb_L1_47_6 d1bar_L2 vcn ctp_L1_47 0 NSYN W=10u L=1u
MnTa_L1_47_6 dpre_L2_34 vcn ctn_L1_47 0 NSYN W=10u L=1u
MpTb_L1_47_6 d1bar_L2 gp_2_34_15 ctn_L1_47 0 NSYN W=10u L=1u
MpTa_L1_47_7 dpre_L2_37 gp_2_37_15 ctp_L1_47 0 NSYN W=10u L=1u
MnTb_L1_47_7 d1bar_L2 vcn ctp_L1_47 0 NSYN W=10u L=1u
MnTa_L1_47_7 dpre_L2_37 vcn ctn_L1_47 0 NSYN W=10u L=1u
MpTb_L1_47_7 d1bar_L2 gp_2_37_15 ctn_L1_47 0 NSYN W=10u L=1u
MpTa_L1_47_8 dpre_L2_43 gp_2_43_15 ctp_L1_47 0 NSYN W=10u L=1u
MnTb_L1_47_8 d1bar_L2 vcn ctp_L1_47 0 NSYN W=10u L=1u
MnTa_L1_47_8 dpre_L2_43 vcn ctn_L1_47 0 NSYN W=10u L=1u
MpTb_L1_47_8 d1bar_L2 gp_2_43_15 ctn_L1_47 0 NSYN W=10u L=1u
MpTa_L1_47_9 dpre_L2_44 gp_2_44_15 ctp_L1_47 0 NSYN W=10u L=1u
MnTb_L1_47_9 d1bar_L2 vcn ctp_L1_47 0 NSYN W=10u L=1u
MnTa_L1_47_9 dpre_L2_44 vcn ctn_L1_47 0 NSYN W=10u L=1u
MpTb_L1_47_9 d1bar_L2 gp_2_44_15 ctn_L1_47 0 NSYN W=10u L=1u
MpTa_L1_47_10 dpre_L2_45 gp_2_45_15 ctp_L1_47 0 NSYN W=10u L=1u
MnTb_L1_47_10 d1bar_L2 vcn ctp_L1_47 0 NSYN W=10u L=1u
MnTa_L1_47_10 dpre_L2_45 vcn ctn_L1_47 0 NSYN W=10u L=1u
MpTb_L1_47_10 d1bar_L2 gp_2_45_15 ctn_L1_47 0 NSYN W=10u L=1u
Msa_bk_L1_47 ctn_L1_47 ctn_L1_47 0 0 NMIR W=20u L=1u
Msb_bk_L1_47 dpre_L1_47 ctn_L1_47 0 0 NMIR W=20u L=1u
Msc_bk_L1_47 ctp_L1_47 ctp_L1_47 0 0 NMIR W=20u L=1u
Msd_bk_L1_47 dpf_bk_L1_47 ctp_L1_47 0 0 NMIR W=20u L=1u
Mse_bk_L1_47 dpf_bk_L1_47 dpf_bk_L1_47 vdd vdd PMIR W=60u L=1u
Msf_bk_L1_47 dpre_L1_47 dpf_bk_L1_47 vdd vdd PMIR W=60u L=1u
R_bk_L1_47 dpre_L1_47 vrefd 16000.0
Rcm_L1_0 dpre_L1_0 d1bar_L1 10000.0
Rcm_L1_1 dpre_L1_1 d1bar_L1 10000.0
Rcm_L1_2 dpre_L1_2 d1bar_L1 10000.0
Rcm_L1_3 dpre_L1_3 d1bar_L1 10000.0
Rcm_L1_4 dpre_L1_4 d1bar_L1 10000.0
Rcm_L1_5 dpre_L1_5 d1bar_L1 10000.0
Rcm_L1_6 dpre_L1_6 d1bar_L1 10000.0
Rcm_L1_7 dpre_L1_7 d1bar_L1 10000.0
Rcm_L1_8 dpre_L1_8 d1bar_L1 10000.0
Rcm_L1_9 dpre_L1_9 d1bar_L1 10000.0
Rcm_L1_10 dpre_L1_10 d1bar_L1 10000.0
Rcm_L1_11 dpre_L1_11 d1bar_L1 10000.0
Rcm_L1_12 dpre_L1_12 d1bar_L1 10000.0
Rcm_L1_13 dpre_L1_13 d1bar_L1 10000.0
Rcm_L1_14 dpre_L1_14 d1bar_L1 10000.0
Rcm_L1_15 dpre_L1_15 d1bar_L1 10000.0
Rcm_L1_16 dpre_L1_16 d1bar_L1 10000.0
Rcm_L1_17 dpre_L1_17 d1bar_L1 10000.0
Rcm_L1_18 dpre_L1_18 d1bar_L1 10000.0
Rcm_L1_19 dpre_L1_19 d1bar_L1 10000.0
Rcm_L1_20 dpre_L1_20 d1bar_L1 10000.0
Rcm_L1_21 dpre_L1_21 d1bar_L1 10000.0
Rcm_L1_22 dpre_L1_22 d1bar_L1 10000.0
Rcm_L1_23 dpre_L1_23 d1bar_L1 10000.0
Rcm_L1_24 dpre_L1_24 d1bar_L1 10000.0
Rcm_L1_25 dpre_L1_25 d1bar_L1 10000.0
Rcm_L1_26 dpre_L1_26 d1bar_L1 10000.0
Rcm_L1_27 dpre_L1_27 d1bar_L1 10000.0
Rcm_L1_28 dpre_L1_28 d1bar_L1 10000.0
Rcm_L1_29 dpre_L1_29 d1bar_L1 10000.0
Rcm_L1_30 dpre_L1_30 d1bar_L1 10000.0
Rcm_L1_31 dpre_L1_31 d1bar_L1 10000.0
Rcm_L1_32 dpre_L1_32 d1bar_L1 10000.0
Rcm_L1_33 dpre_L1_33 d1bar_L1 10000.0
Rcm_L1_34 dpre_L1_34 d1bar_L1 10000.0
Rcm_L1_35 dpre_L1_35 d1bar_L1 10000.0
Rcm_L1_36 dpre_L1_36 d1bar_L1 10000.0
Rcm_L1_37 dpre_L1_37 d1bar_L1 10000.0
Rcm_L1_38 dpre_L1_38 d1bar_L1 10000.0
Rcm_L1_39 dpre_L1_39 d1bar_L1 10000.0
Rcm_L1_40 dpre_L1_40 d1bar_L1 10000.0
Rcm_L1_41 dpre_L1_41 d1bar_L1 10000.0
Rcm_L1_42 dpre_L1_42 d1bar_L1 10000.0
Rcm_L1_43 dpre_L1_43 d1bar_L1 10000.0
Rcm_L1_44 dpre_L1_44 d1bar_L1 10000.0
Rcm_L1_45 dpre_L1_45 d1bar_L1 10000.0
Rcm_L1_46 dpre_L1_46 d1bar_L1 10000.0
Rcm_L1_47 dpre_L1_47 d1bar_L1 10000.0
Ccm_L1 d1bar_L1 0 50f
Mt_uU_L1_0_0 ts_uU_L1_0_0 a0 0 0 NMIR W=48.0u L=1u
Mo1_uU_L1_0_0 da_uU_L1_0_0 d1bar_L1 ts_uU_L1_0_0 0 NMIR W=20u L=1u
Mo2_uU_L1_0_0 gp_1_0_0 dpre_L1_0 ts_uU_L1_0_0 0 NMIR W=20u L=1u
Mo3_uU_L1_0_0 da_uU_L1_0_0 da_uU_L1_0_0 vdd vdd PMIR W=60u L=1u
Mo4_uU_L1_0_0 gp_1_0_0 da_uU_L1_0_0 vdd vdd PMIR W=60u L=1u
Mt_uU_L1_0_1 ts_uU_L1_0_1 a1 0 0 NMIR W=48.0u L=1u
Mo1_uU_L1_0_1 da_uU_L1_0_1 d1bar_L1 ts_uU_L1_0_1 0 NMIR W=20u L=1u
Mo2_uU_L1_0_1 gp_1_0_1 dpre_L1_0 ts_uU_L1_0_1 0 NMIR W=20u L=1u
Mo3_uU_L1_0_1 da_uU_L1_0_1 da_uU_L1_0_1 vdd vdd PMIR W=60u L=1u
Mo4_uU_L1_0_1 gp_1_0_1 da_uU_L1_0_1 vdd vdd PMIR W=60u L=1u
Mt_uU_L1_1_0 ts_uU_L1_1_0 a0 0 0 NMIR W=48.0u L=1u
Mo1_uU_L1_1_0 da_uU_L1_1_0 d1bar_L1 ts_uU_L1_1_0 0 NMIR W=20u L=1u
Mo2_uU_L1_1_0 gp_1_1_0 dpre_L1_1 ts_uU_L1_1_0 0 NMIR W=20u L=1u
Mo3_uU_L1_1_0 da_uU_L1_1_0 da_uU_L1_1_0 vdd vdd PMIR W=60u L=1u
Mo4_uU_L1_1_0 gp_1_1_0 da_uU_L1_1_0 vdd vdd PMIR W=60u L=1u
Mt_uU_L1_1_1 ts_uU_L1_1_1 a1 0 0 NMIR W=48.0u L=1u
Mo1_uU_L1_1_1 da_uU_L1_1_1 d1bar_L1 ts_uU_L1_1_1 0 NMIR W=20u L=1u
Mo2_uU_L1_1_1 gp_1_1_1 dpre_L1_1 ts_uU_L1_1_1 0 NMIR W=20u L=1u
Mo3_uU_L1_1_1 da_uU_L1_1_1 da_uU_L1_1_1 vdd vdd PMIR W=60u L=1u
Mo4_uU_L1_1_1 gp_1_1_1 da_uU_L1_1_1 vdd vdd PMIR W=60u L=1u
Mt_uU_L1_2_0 ts_uU_L1_2_0 a0 0 0 NMIR W=48.0u L=1u
Mo1_uU_L1_2_0 da_uU_L1_2_0 d1bar_L1 ts_uU_L1_2_0 0 NMIR W=20u L=1u
Mo2_uU_L1_2_0 gp_1_2_0 dpre_L1_2 ts_uU_L1_2_0 0 NMIR W=20u L=1u
Mo3_uU_L1_2_0 da_uU_L1_2_0 da_uU_L1_2_0 vdd vdd PMIR W=60u L=1u
Mo4_uU_L1_2_0 gp_1_2_0 da_uU_L1_2_0 vdd vdd PMIR W=60u L=1u
Mt_uU_L1_2_1 ts_uU_L1_2_1 a1 0 0 NMIR W=48.0u L=1u
Mo1_uU_L1_2_1 da_uU_L1_2_1 d1bar_L1 ts_uU_L1_2_1 0 NMIR W=20u L=1u
Mo2_uU_L1_2_1 gp_1_2_1 dpre_L1_2 ts_uU_L1_2_1 0 NMIR W=20u L=1u
Mo3_uU_L1_2_1 da_uU_L1_2_1 da_uU_L1_2_1 vdd vdd PMIR W=60u L=1u
Mo4_uU_L1_2_1 gp_1_2_1 da_uU_L1_2_1 vdd vdd PMIR W=60u L=1u
Mt_uU_L1_3_0 ts_uU_L1_3_0 a0 0 0 NMIR W=48.0u L=1u
Mo1_uU_L1_3_0 da_uU_L1_3_0 d1bar_L1 ts_uU_L1_3_0 0 NMIR W=20u L=1u
Mo2_uU_L1_3_0 gp_1_3_0 dpre_L1_3 ts_uU_L1_3_0 0 NMIR W=20u L=1u
Mo3_uU_L1_3_0 da_uU_L1_3_0 da_uU_L1_3_0 vdd vdd PMIR W=60u L=1u
Mo4_uU_L1_3_0 gp_1_3_0 da_uU_L1_3_0 vdd vdd PMIR W=60u L=1u
Mt_uU_L1_3_1 ts_uU_L1_3_1 a1 0 0 NMIR W=48.0u L=1u
Mo1_uU_L1_3_1 da_uU_L1_3_1 d1bar_L1 ts_uU_L1_3_1 0 NMIR W=20u L=1u
Mo2_uU_L1_3_1 gp_1_3_1 dpre_L1_3 ts_uU_L1_3_1 0 NMIR W=20u L=1u
Mo3_uU_L1_3_1 da_uU_L1_3_1 da_uU_L1_3_1 vdd vdd PMIR W=60u L=1u
Mo4_uU_L1_3_1 gp_1_3_1 da_uU_L1_3_1 vdd vdd PMIR W=60u L=1u
Mt_uU_L1_4_0 ts_uU_L1_4_0 a0 0 0 NMIR W=48.0u L=1u
Mo1_uU_L1_4_0 da_uU_L1_4_0 d1bar_L1 ts_uU_L1_4_0 0 NMIR W=20u L=1u
Mo2_uU_L1_4_0 gp_1_4_0 dpre_L1_4 ts_uU_L1_4_0 0 NMIR W=20u L=1u
Mo3_uU_L1_4_0 da_uU_L1_4_0 da_uU_L1_4_0 vdd vdd PMIR W=60u L=1u
Mo4_uU_L1_4_0 gp_1_4_0 da_uU_L1_4_0 vdd vdd PMIR W=60u L=1u
Mt_uU_L1_4_1 ts_uU_L1_4_1 a1 0 0 NMIR W=48.0u L=1u
Mo1_uU_L1_4_1 da_uU_L1_4_1 d1bar_L1 ts_uU_L1_4_1 0 NMIR W=20u L=1u
Mo2_uU_L1_4_1 gp_1_4_1 dpre_L1_4 ts_uU_L1_4_1 0 NMIR W=20u L=1u
Mo3_uU_L1_4_1 da_uU_L1_4_1 da_uU_L1_4_1 vdd vdd PMIR W=60u L=1u
Mo4_uU_L1_4_1 gp_1_4_1 da_uU_L1_4_1 vdd vdd PMIR W=60u L=1u
Mt_uU_L1_5_0 ts_uU_L1_5_0 a0 0 0 NMIR W=48.0u L=1u
Mo1_uU_L1_5_0 da_uU_L1_5_0 d1bar_L1 ts_uU_L1_5_0 0 NMIR W=20u L=1u
Mo2_uU_L1_5_0 gp_1_5_0 dpre_L1_5 ts_uU_L1_5_0 0 NMIR W=20u L=1u
Mo3_uU_L1_5_0 da_uU_L1_5_0 da_uU_L1_5_0 vdd vdd PMIR W=60u L=1u
Mo4_uU_L1_5_0 gp_1_5_0 da_uU_L1_5_0 vdd vdd PMIR W=60u L=1u
Mt_uU_L1_5_1 ts_uU_L1_5_1 a1 0 0 NMIR W=48.0u L=1u
Mo1_uU_L1_5_1 da_uU_L1_5_1 d1bar_L1 ts_uU_L1_5_1 0 NMIR W=20u L=1u
Mo2_uU_L1_5_1 gp_1_5_1 dpre_L1_5 ts_uU_L1_5_1 0 NMIR W=20u L=1u
Mo3_uU_L1_5_1 da_uU_L1_5_1 da_uU_L1_5_1 vdd vdd PMIR W=60u L=1u
Mo4_uU_L1_5_1 gp_1_5_1 da_uU_L1_5_1 vdd vdd PMIR W=60u L=1u
Mt_uU_L1_6_0 ts_uU_L1_6_0 a0 0 0 NMIR W=48.0u L=1u
Mo1_uU_L1_6_0 da_uU_L1_6_0 d1bar_L1 ts_uU_L1_6_0 0 NMIR W=20u L=1u
Mo2_uU_L1_6_0 gp_1_6_0 dpre_L1_6 ts_uU_L1_6_0 0 NMIR W=20u L=1u
Mo3_uU_L1_6_0 da_uU_L1_6_0 da_uU_L1_6_0 vdd vdd PMIR W=60u L=1u
Mo4_uU_L1_6_0 gp_1_6_0 da_uU_L1_6_0 vdd vdd PMIR W=60u L=1u
Mt_uU_L1_6_1 ts_uU_L1_6_1 a1 0 0 NMIR W=48.0u L=1u
Mo1_uU_L1_6_1 da_uU_L1_6_1 d1bar_L1 ts_uU_L1_6_1 0 NMIR W=20u L=1u
Mo2_uU_L1_6_1 gp_1_6_1 dpre_L1_6 ts_uU_L1_6_1 0 NMIR W=20u L=1u
Mo3_uU_L1_6_1 da_uU_L1_6_1 da_uU_L1_6_1 vdd vdd PMIR W=60u L=1u
Mo4_uU_L1_6_1 gp_1_6_1 da_uU_L1_6_1 vdd vdd PMIR W=60u L=1u
Mt_uU_L1_7_0 ts_uU_L1_7_0 a0 0 0 NMIR W=48.0u L=1u
Mo1_uU_L1_7_0 da_uU_L1_7_0 d1bar_L1 ts_uU_L1_7_0 0 NMIR W=20u L=1u
Mo2_uU_L1_7_0 gp_1_7_0 dpre_L1_7 ts_uU_L1_7_0 0 NMIR W=20u L=1u
Mo3_uU_L1_7_0 da_uU_L1_7_0 da_uU_L1_7_0 vdd vdd PMIR W=60u L=1u
Mo4_uU_L1_7_0 gp_1_7_0 da_uU_L1_7_0 vdd vdd PMIR W=60u L=1u
Mt_uU_L1_7_1 ts_uU_L1_7_1 a1 0 0 NMIR W=48.0u L=1u
Mo1_uU_L1_7_1 da_uU_L1_7_1 d1bar_L1 ts_uU_L1_7_1 0 NMIR W=20u L=1u
Mo2_uU_L1_7_1 gp_1_7_1 dpre_L1_7 ts_uU_L1_7_1 0 NMIR W=20u L=1u
Mo3_uU_L1_7_1 da_uU_L1_7_1 da_uU_L1_7_1 vdd vdd PMIR W=60u L=1u
Mo4_uU_L1_7_1 gp_1_7_1 da_uU_L1_7_1 vdd vdd PMIR W=60u L=1u
Mt_uU_L1_8_0 ts_uU_L1_8_0 a0 0 0 NMIR W=48.0u L=1u
Mo1_uU_L1_8_0 da_uU_L1_8_0 d1bar_L1 ts_uU_L1_8_0 0 NMIR W=20u L=1u
Mo2_uU_L1_8_0 gp_1_8_0 dpre_L1_8 ts_uU_L1_8_0 0 NMIR W=20u L=1u
Mo3_uU_L1_8_0 da_uU_L1_8_0 da_uU_L1_8_0 vdd vdd PMIR W=60u L=1u
Mo4_uU_L1_8_0 gp_1_8_0 da_uU_L1_8_0 vdd vdd PMIR W=60u L=1u
Mt_uU_L1_8_1 ts_uU_L1_8_1 a1 0 0 NMIR W=48.0u L=1u
Mo1_uU_L1_8_1 da_uU_L1_8_1 d1bar_L1 ts_uU_L1_8_1 0 NMIR W=20u L=1u
Mo2_uU_L1_8_1 gp_1_8_1 dpre_L1_8 ts_uU_L1_8_1 0 NMIR W=20u L=1u
Mo3_uU_L1_8_1 da_uU_L1_8_1 da_uU_L1_8_1 vdd vdd PMIR W=60u L=1u
Mo4_uU_L1_8_1 gp_1_8_1 da_uU_L1_8_1 vdd vdd PMIR W=60u L=1u
Mt_uU_L1_9_0 ts_uU_L1_9_0 a0 0 0 NMIR W=48.0u L=1u
Mo1_uU_L1_9_0 da_uU_L1_9_0 d1bar_L1 ts_uU_L1_9_0 0 NMIR W=20u L=1u
Mo2_uU_L1_9_0 gp_1_9_0 dpre_L1_9 ts_uU_L1_9_0 0 NMIR W=20u L=1u
Mo3_uU_L1_9_0 da_uU_L1_9_0 da_uU_L1_9_0 vdd vdd PMIR W=60u L=1u
Mo4_uU_L1_9_0 gp_1_9_0 da_uU_L1_9_0 vdd vdd PMIR W=60u L=1u
Mt_uU_L1_9_1 ts_uU_L1_9_1 a1 0 0 NMIR W=48.0u L=1u
Mo1_uU_L1_9_1 da_uU_L1_9_1 d1bar_L1 ts_uU_L1_9_1 0 NMIR W=20u L=1u
Mo2_uU_L1_9_1 gp_1_9_1 dpre_L1_9 ts_uU_L1_9_1 0 NMIR W=20u L=1u
Mo3_uU_L1_9_1 da_uU_L1_9_1 da_uU_L1_9_1 vdd vdd PMIR W=60u L=1u
Mo4_uU_L1_9_1 gp_1_9_1 da_uU_L1_9_1 vdd vdd PMIR W=60u L=1u
Mt_uU_L1_10_0 ts_uU_L1_10_0 a0 0 0 NMIR W=48.0u L=1u
Mo1_uU_L1_10_0 da_uU_L1_10_0 d1bar_L1 ts_uU_L1_10_0 0 NMIR W=20u L=1u
Mo2_uU_L1_10_0 gp_1_10_0 dpre_L1_10 ts_uU_L1_10_0 0 NMIR W=20u L=1u
Mo3_uU_L1_10_0 da_uU_L1_10_0 da_uU_L1_10_0 vdd vdd PMIR W=60u L=1u
Mo4_uU_L1_10_0 gp_1_10_0 da_uU_L1_10_0 vdd vdd PMIR W=60u L=1u
Mt_uU_L1_10_1 ts_uU_L1_10_1 a1 0 0 NMIR W=48.0u L=1u
Mo1_uU_L1_10_1 da_uU_L1_10_1 d1bar_L1 ts_uU_L1_10_1 0 NMIR W=20u L=1u
Mo2_uU_L1_10_1 gp_1_10_1 dpre_L1_10 ts_uU_L1_10_1 0 NMIR W=20u L=1u
Mo3_uU_L1_10_1 da_uU_L1_10_1 da_uU_L1_10_1 vdd vdd PMIR W=60u L=1u
Mo4_uU_L1_10_1 gp_1_10_1 da_uU_L1_10_1 vdd vdd PMIR W=60u L=1u
Mt_uU_L1_11_0 ts_uU_L1_11_0 a0 0 0 NMIR W=48.0u L=1u
Mo1_uU_L1_11_0 da_uU_L1_11_0 d1bar_L1 ts_uU_L1_11_0 0 NMIR W=20u L=1u
Mo2_uU_L1_11_0 gp_1_11_0 dpre_L1_11 ts_uU_L1_11_0 0 NMIR W=20u L=1u
Mo3_uU_L1_11_0 da_uU_L1_11_0 da_uU_L1_11_0 vdd vdd PMIR W=60u L=1u
Mo4_uU_L1_11_0 gp_1_11_0 da_uU_L1_11_0 vdd vdd PMIR W=60u L=1u
Mt_uU_L1_11_1 ts_uU_L1_11_1 a1 0 0 NMIR W=48.0u L=1u
Mo1_uU_L1_11_1 da_uU_L1_11_1 d1bar_L1 ts_uU_L1_11_1 0 NMIR W=20u L=1u
Mo2_uU_L1_11_1 gp_1_11_1 dpre_L1_11 ts_uU_L1_11_1 0 NMIR W=20u L=1u
Mo3_uU_L1_11_1 da_uU_L1_11_1 da_uU_L1_11_1 vdd vdd PMIR W=60u L=1u
Mo4_uU_L1_11_1 gp_1_11_1 da_uU_L1_11_1 vdd vdd PMIR W=60u L=1u
Mt_uU_L1_12_0 ts_uU_L1_12_0 a0 0 0 NMIR W=48.0u L=1u
Mo1_uU_L1_12_0 da_uU_L1_12_0 d1bar_L1 ts_uU_L1_12_0 0 NMIR W=20u L=1u
Mo2_uU_L1_12_0 gp_1_12_0 dpre_L1_12 ts_uU_L1_12_0 0 NMIR W=20u L=1u
Mo3_uU_L1_12_0 da_uU_L1_12_0 da_uU_L1_12_0 vdd vdd PMIR W=60u L=1u
Mo4_uU_L1_12_0 gp_1_12_0 da_uU_L1_12_0 vdd vdd PMIR W=60u L=1u
Mt_uU_L1_12_1 ts_uU_L1_12_1 a1 0 0 NMIR W=48.0u L=1u
Mo1_uU_L1_12_1 da_uU_L1_12_1 d1bar_L1 ts_uU_L1_12_1 0 NMIR W=20u L=1u
Mo2_uU_L1_12_1 gp_1_12_1 dpre_L1_12 ts_uU_L1_12_1 0 NMIR W=20u L=1u
Mo3_uU_L1_12_1 da_uU_L1_12_1 da_uU_L1_12_1 vdd vdd PMIR W=60u L=1u
Mo4_uU_L1_12_1 gp_1_12_1 da_uU_L1_12_1 vdd vdd PMIR W=60u L=1u
Mt_uU_L1_13_0 ts_uU_L1_13_0 a0 0 0 NMIR W=48.0u L=1u
Mo1_uU_L1_13_0 da_uU_L1_13_0 d1bar_L1 ts_uU_L1_13_0 0 NMIR W=20u L=1u
Mo2_uU_L1_13_0 gp_1_13_0 dpre_L1_13 ts_uU_L1_13_0 0 NMIR W=20u L=1u
Mo3_uU_L1_13_0 da_uU_L1_13_0 da_uU_L1_13_0 vdd vdd PMIR W=60u L=1u
Mo4_uU_L1_13_0 gp_1_13_0 da_uU_L1_13_0 vdd vdd PMIR W=60u L=1u
Mt_uU_L1_13_1 ts_uU_L1_13_1 a1 0 0 NMIR W=48.0u L=1u
Mo1_uU_L1_13_1 da_uU_L1_13_1 d1bar_L1 ts_uU_L1_13_1 0 NMIR W=20u L=1u
Mo2_uU_L1_13_1 gp_1_13_1 dpre_L1_13 ts_uU_L1_13_1 0 NMIR W=20u L=1u
Mo3_uU_L1_13_1 da_uU_L1_13_1 da_uU_L1_13_1 vdd vdd PMIR W=60u L=1u
Mo4_uU_L1_13_1 gp_1_13_1 da_uU_L1_13_1 vdd vdd PMIR W=60u L=1u
Mt_uU_L1_14_0 ts_uU_L1_14_0 a0 0 0 NMIR W=48.0u L=1u
Mo1_uU_L1_14_0 da_uU_L1_14_0 d1bar_L1 ts_uU_L1_14_0 0 NMIR W=20u L=1u
Mo2_uU_L1_14_0 gp_1_14_0 dpre_L1_14 ts_uU_L1_14_0 0 NMIR W=20u L=1u
Mo3_uU_L1_14_0 da_uU_L1_14_0 da_uU_L1_14_0 vdd vdd PMIR W=60u L=1u
Mo4_uU_L1_14_0 gp_1_14_0 da_uU_L1_14_0 vdd vdd PMIR W=60u L=1u
Mt_uU_L1_14_1 ts_uU_L1_14_1 a1 0 0 NMIR W=48.0u L=1u
Mo1_uU_L1_14_1 da_uU_L1_14_1 d1bar_L1 ts_uU_L1_14_1 0 NMIR W=20u L=1u
Mo2_uU_L1_14_1 gp_1_14_1 dpre_L1_14 ts_uU_L1_14_1 0 NMIR W=20u L=1u
Mo3_uU_L1_14_1 da_uU_L1_14_1 da_uU_L1_14_1 vdd vdd PMIR W=60u L=1u
Mo4_uU_L1_14_1 gp_1_14_1 da_uU_L1_14_1 vdd vdd PMIR W=60u L=1u
Mt_uU_L1_15_0 ts_uU_L1_15_0 a0 0 0 NMIR W=48.0u L=1u
Mo1_uU_L1_15_0 da_uU_L1_15_0 d1bar_L1 ts_uU_L1_15_0 0 NMIR W=20u L=1u
Mo2_uU_L1_15_0 gp_1_15_0 dpre_L1_15 ts_uU_L1_15_0 0 NMIR W=20u L=1u
Mo3_uU_L1_15_0 da_uU_L1_15_0 da_uU_L1_15_0 vdd vdd PMIR W=60u L=1u
Mo4_uU_L1_15_0 gp_1_15_0 da_uU_L1_15_0 vdd vdd PMIR W=60u L=1u
Mt_uU_L1_15_1 ts_uU_L1_15_1 a1 0 0 NMIR W=48.0u L=1u
Mo1_uU_L1_15_1 da_uU_L1_15_1 d1bar_L1 ts_uU_L1_15_1 0 NMIR W=20u L=1u
Mo2_uU_L1_15_1 gp_1_15_1 dpre_L1_15 ts_uU_L1_15_1 0 NMIR W=20u L=1u
Mo3_uU_L1_15_1 da_uU_L1_15_1 da_uU_L1_15_1 vdd vdd PMIR W=60u L=1u
Mo4_uU_L1_15_1 gp_1_15_1 da_uU_L1_15_1 vdd vdd PMIR W=60u L=1u
Mt_uU_L1_16_0 ts_uU_L1_16_0 a0 0 0 NMIR W=48.0u L=1u
Mo1_uU_L1_16_0 da_uU_L1_16_0 d1bar_L1 ts_uU_L1_16_0 0 NMIR W=20u L=1u
Mo2_uU_L1_16_0 gp_1_16_0 dpre_L1_16 ts_uU_L1_16_0 0 NMIR W=20u L=1u
Mo3_uU_L1_16_0 da_uU_L1_16_0 da_uU_L1_16_0 vdd vdd PMIR W=60u L=1u
Mo4_uU_L1_16_0 gp_1_16_0 da_uU_L1_16_0 vdd vdd PMIR W=60u L=1u
Mt_uU_L1_16_1 ts_uU_L1_16_1 a1 0 0 NMIR W=48.0u L=1u
Mo1_uU_L1_16_1 da_uU_L1_16_1 d1bar_L1 ts_uU_L1_16_1 0 NMIR W=20u L=1u
Mo2_uU_L1_16_1 gp_1_16_1 dpre_L1_16 ts_uU_L1_16_1 0 NMIR W=20u L=1u
Mo3_uU_L1_16_1 da_uU_L1_16_1 da_uU_L1_16_1 vdd vdd PMIR W=60u L=1u
Mo4_uU_L1_16_1 gp_1_16_1 da_uU_L1_16_1 vdd vdd PMIR W=60u L=1u
Mt_uU_L1_17_0 ts_uU_L1_17_0 a0 0 0 NMIR W=48.0u L=1u
Mo1_uU_L1_17_0 da_uU_L1_17_0 d1bar_L1 ts_uU_L1_17_0 0 NMIR W=20u L=1u
Mo2_uU_L1_17_0 gp_1_17_0 dpre_L1_17 ts_uU_L1_17_0 0 NMIR W=20u L=1u
Mo3_uU_L1_17_0 da_uU_L1_17_0 da_uU_L1_17_0 vdd vdd PMIR W=60u L=1u
Mo4_uU_L1_17_0 gp_1_17_0 da_uU_L1_17_0 vdd vdd PMIR W=60u L=1u
Mt_uU_L1_17_1 ts_uU_L1_17_1 a1 0 0 NMIR W=48.0u L=1u
Mo1_uU_L1_17_1 da_uU_L1_17_1 d1bar_L1 ts_uU_L1_17_1 0 NMIR W=20u L=1u
Mo2_uU_L1_17_1 gp_1_17_1 dpre_L1_17 ts_uU_L1_17_1 0 NMIR W=20u L=1u
Mo3_uU_L1_17_1 da_uU_L1_17_1 da_uU_L1_17_1 vdd vdd PMIR W=60u L=1u
Mo4_uU_L1_17_1 gp_1_17_1 da_uU_L1_17_1 vdd vdd PMIR W=60u L=1u
Mt_uU_L1_18_0 ts_uU_L1_18_0 a0 0 0 NMIR W=48.0u L=1u
Mo1_uU_L1_18_0 da_uU_L1_18_0 d1bar_L1 ts_uU_L1_18_0 0 NMIR W=20u L=1u
Mo2_uU_L1_18_0 gp_1_18_0 dpre_L1_18 ts_uU_L1_18_0 0 NMIR W=20u L=1u
Mo3_uU_L1_18_0 da_uU_L1_18_0 da_uU_L1_18_0 vdd vdd PMIR W=60u L=1u
Mo4_uU_L1_18_0 gp_1_18_0 da_uU_L1_18_0 vdd vdd PMIR W=60u L=1u
Mt_uU_L1_18_1 ts_uU_L1_18_1 a1 0 0 NMIR W=48.0u L=1u
Mo1_uU_L1_18_1 da_uU_L1_18_1 d1bar_L1 ts_uU_L1_18_1 0 NMIR W=20u L=1u
Mo2_uU_L1_18_1 gp_1_18_1 dpre_L1_18 ts_uU_L1_18_1 0 NMIR W=20u L=1u
Mo3_uU_L1_18_1 da_uU_L1_18_1 da_uU_L1_18_1 vdd vdd PMIR W=60u L=1u
Mo4_uU_L1_18_1 gp_1_18_1 da_uU_L1_18_1 vdd vdd PMIR W=60u L=1u
Mt_uU_L1_19_0 ts_uU_L1_19_0 a0 0 0 NMIR W=48.0u L=1u
Mo1_uU_L1_19_0 da_uU_L1_19_0 d1bar_L1 ts_uU_L1_19_0 0 NMIR W=20u L=1u
Mo2_uU_L1_19_0 gp_1_19_0 dpre_L1_19 ts_uU_L1_19_0 0 NMIR W=20u L=1u
Mo3_uU_L1_19_0 da_uU_L1_19_0 da_uU_L1_19_0 vdd vdd PMIR W=60u L=1u
Mo4_uU_L1_19_0 gp_1_19_0 da_uU_L1_19_0 vdd vdd PMIR W=60u L=1u
Mt_uU_L1_19_1 ts_uU_L1_19_1 a1 0 0 NMIR W=48.0u L=1u
Mo1_uU_L1_19_1 da_uU_L1_19_1 d1bar_L1 ts_uU_L1_19_1 0 NMIR W=20u L=1u
Mo2_uU_L1_19_1 gp_1_19_1 dpre_L1_19 ts_uU_L1_19_1 0 NMIR W=20u L=1u
Mo3_uU_L1_19_1 da_uU_L1_19_1 da_uU_L1_19_1 vdd vdd PMIR W=60u L=1u
Mo4_uU_L1_19_1 gp_1_19_1 da_uU_L1_19_1 vdd vdd PMIR W=60u L=1u
Mt_uU_L1_20_0 ts_uU_L1_20_0 a0 0 0 NMIR W=48.0u L=1u
Mo1_uU_L1_20_0 da_uU_L1_20_0 d1bar_L1 ts_uU_L1_20_0 0 NMIR W=20u L=1u
Mo2_uU_L1_20_0 gp_1_20_0 dpre_L1_20 ts_uU_L1_20_0 0 NMIR W=20u L=1u
Mo3_uU_L1_20_0 da_uU_L1_20_0 da_uU_L1_20_0 vdd vdd PMIR W=60u L=1u
Mo4_uU_L1_20_0 gp_1_20_0 da_uU_L1_20_0 vdd vdd PMIR W=60u L=1u
Mt_uU_L1_20_1 ts_uU_L1_20_1 a1 0 0 NMIR W=48.0u L=1u
Mo1_uU_L1_20_1 da_uU_L1_20_1 d1bar_L1 ts_uU_L1_20_1 0 NMIR W=20u L=1u
Mo2_uU_L1_20_1 gp_1_20_1 dpre_L1_20 ts_uU_L1_20_1 0 NMIR W=20u L=1u
Mo3_uU_L1_20_1 da_uU_L1_20_1 da_uU_L1_20_1 vdd vdd PMIR W=60u L=1u
Mo4_uU_L1_20_1 gp_1_20_1 da_uU_L1_20_1 vdd vdd PMIR W=60u L=1u
Mt_uU_L1_21_0 ts_uU_L1_21_0 a0 0 0 NMIR W=48.0u L=1u
Mo1_uU_L1_21_0 da_uU_L1_21_0 d1bar_L1 ts_uU_L1_21_0 0 NMIR W=20u L=1u
Mo2_uU_L1_21_0 gp_1_21_0 dpre_L1_21 ts_uU_L1_21_0 0 NMIR W=20u L=1u
Mo3_uU_L1_21_0 da_uU_L1_21_0 da_uU_L1_21_0 vdd vdd PMIR W=60u L=1u
Mo4_uU_L1_21_0 gp_1_21_0 da_uU_L1_21_0 vdd vdd PMIR W=60u L=1u
Mt_uU_L1_21_1 ts_uU_L1_21_1 a1 0 0 NMIR W=48.0u L=1u
Mo1_uU_L1_21_1 da_uU_L1_21_1 d1bar_L1 ts_uU_L1_21_1 0 NMIR W=20u L=1u
Mo2_uU_L1_21_1 gp_1_21_1 dpre_L1_21 ts_uU_L1_21_1 0 NMIR W=20u L=1u
Mo3_uU_L1_21_1 da_uU_L1_21_1 da_uU_L1_21_1 vdd vdd PMIR W=60u L=1u
Mo4_uU_L1_21_1 gp_1_21_1 da_uU_L1_21_1 vdd vdd PMIR W=60u L=1u
Mt_uU_L1_22_0 ts_uU_L1_22_0 a0 0 0 NMIR W=48.0u L=1u
Mo1_uU_L1_22_0 da_uU_L1_22_0 d1bar_L1 ts_uU_L1_22_0 0 NMIR W=20u L=1u
Mo2_uU_L1_22_0 gp_1_22_0 dpre_L1_22 ts_uU_L1_22_0 0 NMIR W=20u L=1u
Mo3_uU_L1_22_0 da_uU_L1_22_0 da_uU_L1_22_0 vdd vdd PMIR W=60u L=1u
Mo4_uU_L1_22_0 gp_1_22_0 da_uU_L1_22_0 vdd vdd PMIR W=60u L=1u
Mt_uU_L1_22_1 ts_uU_L1_22_1 a1 0 0 NMIR W=48.0u L=1u
Mo1_uU_L1_22_1 da_uU_L1_22_1 d1bar_L1 ts_uU_L1_22_1 0 NMIR W=20u L=1u
Mo2_uU_L1_22_1 gp_1_22_1 dpre_L1_22 ts_uU_L1_22_1 0 NMIR W=20u L=1u
Mo3_uU_L1_22_1 da_uU_L1_22_1 da_uU_L1_22_1 vdd vdd PMIR W=60u L=1u
Mo4_uU_L1_22_1 gp_1_22_1 da_uU_L1_22_1 vdd vdd PMIR W=60u L=1u
Mt_uU_L1_23_0 ts_uU_L1_23_0 a0 0 0 NMIR W=48.0u L=1u
Mo1_uU_L1_23_0 da_uU_L1_23_0 d1bar_L1 ts_uU_L1_23_0 0 NMIR W=20u L=1u
Mo2_uU_L1_23_0 gp_1_23_0 dpre_L1_23 ts_uU_L1_23_0 0 NMIR W=20u L=1u
Mo3_uU_L1_23_0 da_uU_L1_23_0 da_uU_L1_23_0 vdd vdd PMIR W=60u L=1u
Mo4_uU_L1_23_0 gp_1_23_0 da_uU_L1_23_0 vdd vdd PMIR W=60u L=1u
Mt_uU_L1_23_1 ts_uU_L1_23_1 a1 0 0 NMIR W=48.0u L=1u
Mo1_uU_L1_23_1 da_uU_L1_23_1 d1bar_L1 ts_uU_L1_23_1 0 NMIR W=20u L=1u
Mo2_uU_L1_23_1 gp_1_23_1 dpre_L1_23 ts_uU_L1_23_1 0 NMIR W=20u L=1u
Mo3_uU_L1_23_1 da_uU_L1_23_1 da_uU_L1_23_1 vdd vdd PMIR W=60u L=1u
Mo4_uU_L1_23_1 gp_1_23_1 da_uU_L1_23_1 vdd vdd PMIR W=60u L=1u
Mt_uU_L1_24_0 ts_uU_L1_24_0 a0 0 0 NMIR W=48.0u L=1u
Mo1_uU_L1_24_0 da_uU_L1_24_0 d1bar_L1 ts_uU_L1_24_0 0 NMIR W=20u L=1u
Mo2_uU_L1_24_0 gp_1_24_0 dpre_L1_24 ts_uU_L1_24_0 0 NMIR W=20u L=1u
Mo3_uU_L1_24_0 da_uU_L1_24_0 da_uU_L1_24_0 vdd vdd PMIR W=60u L=1u
Mo4_uU_L1_24_0 gp_1_24_0 da_uU_L1_24_0 vdd vdd PMIR W=60u L=1u
Mt_uU_L1_24_1 ts_uU_L1_24_1 a1 0 0 NMIR W=48.0u L=1u
Mo1_uU_L1_24_1 da_uU_L1_24_1 d1bar_L1 ts_uU_L1_24_1 0 NMIR W=20u L=1u
Mo2_uU_L1_24_1 gp_1_24_1 dpre_L1_24 ts_uU_L1_24_1 0 NMIR W=20u L=1u
Mo3_uU_L1_24_1 da_uU_L1_24_1 da_uU_L1_24_1 vdd vdd PMIR W=60u L=1u
Mo4_uU_L1_24_1 gp_1_24_1 da_uU_L1_24_1 vdd vdd PMIR W=60u L=1u
Mt_uU_L1_25_0 ts_uU_L1_25_0 a0 0 0 NMIR W=48.0u L=1u
Mo1_uU_L1_25_0 da_uU_L1_25_0 d1bar_L1 ts_uU_L1_25_0 0 NMIR W=20u L=1u
Mo2_uU_L1_25_0 gp_1_25_0 dpre_L1_25 ts_uU_L1_25_0 0 NMIR W=20u L=1u
Mo3_uU_L1_25_0 da_uU_L1_25_0 da_uU_L1_25_0 vdd vdd PMIR W=60u L=1u
Mo4_uU_L1_25_0 gp_1_25_0 da_uU_L1_25_0 vdd vdd PMIR W=60u L=1u
Mt_uU_L1_25_1 ts_uU_L1_25_1 a1 0 0 NMIR W=48.0u L=1u
Mo1_uU_L1_25_1 da_uU_L1_25_1 d1bar_L1 ts_uU_L1_25_1 0 NMIR W=20u L=1u
Mo2_uU_L1_25_1 gp_1_25_1 dpre_L1_25 ts_uU_L1_25_1 0 NMIR W=20u L=1u
Mo3_uU_L1_25_1 da_uU_L1_25_1 da_uU_L1_25_1 vdd vdd PMIR W=60u L=1u
Mo4_uU_L1_25_1 gp_1_25_1 da_uU_L1_25_1 vdd vdd PMIR W=60u L=1u
Mt_uU_L1_26_0 ts_uU_L1_26_0 a0 0 0 NMIR W=48.0u L=1u
Mo1_uU_L1_26_0 da_uU_L1_26_0 d1bar_L1 ts_uU_L1_26_0 0 NMIR W=20u L=1u
Mo2_uU_L1_26_0 gp_1_26_0 dpre_L1_26 ts_uU_L1_26_0 0 NMIR W=20u L=1u
Mo3_uU_L1_26_0 da_uU_L1_26_0 da_uU_L1_26_0 vdd vdd PMIR W=60u L=1u
Mo4_uU_L1_26_0 gp_1_26_0 da_uU_L1_26_0 vdd vdd PMIR W=60u L=1u
Mt_uU_L1_26_1 ts_uU_L1_26_1 a1 0 0 NMIR W=48.0u L=1u
Mo1_uU_L1_26_1 da_uU_L1_26_1 d1bar_L1 ts_uU_L1_26_1 0 NMIR W=20u L=1u
Mo2_uU_L1_26_1 gp_1_26_1 dpre_L1_26 ts_uU_L1_26_1 0 NMIR W=20u L=1u
Mo3_uU_L1_26_1 da_uU_L1_26_1 da_uU_L1_26_1 vdd vdd PMIR W=60u L=1u
Mo4_uU_L1_26_1 gp_1_26_1 da_uU_L1_26_1 vdd vdd PMIR W=60u L=1u
Mt_uU_L1_27_0 ts_uU_L1_27_0 a0 0 0 NMIR W=48.0u L=1u
Mo1_uU_L1_27_0 da_uU_L1_27_0 d1bar_L1 ts_uU_L1_27_0 0 NMIR W=20u L=1u
Mo2_uU_L1_27_0 gp_1_27_0 dpre_L1_27 ts_uU_L1_27_0 0 NMIR W=20u L=1u
Mo3_uU_L1_27_0 da_uU_L1_27_0 da_uU_L1_27_0 vdd vdd PMIR W=60u L=1u
Mo4_uU_L1_27_0 gp_1_27_0 da_uU_L1_27_0 vdd vdd PMIR W=60u L=1u
Mt_uU_L1_27_1 ts_uU_L1_27_1 a1 0 0 NMIR W=48.0u L=1u
Mo1_uU_L1_27_1 da_uU_L1_27_1 d1bar_L1 ts_uU_L1_27_1 0 NMIR W=20u L=1u
Mo2_uU_L1_27_1 gp_1_27_1 dpre_L1_27 ts_uU_L1_27_1 0 NMIR W=20u L=1u
Mo3_uU_L1_27_1 da_uU_L1_27_1 da_uU_L1_27_1 vdd vdd PMIR W=60u L=1u
Mo4_uU_L1_27_1 gp_1_27_1 da_uU_L1_27_1 vdd vdd PMIR W=60u L=1u
Mt_uU_L1_28_0 ts_uU_L1_28_0 a0 0 0 NMIR W=48.0u L=1u
Mo1_uU_L1_28_0 da_uU_L1_28_0 d1bar_L1 ts_uU_L1_28_0 0 NMIR W=20u L=1u
Mo2_uU_L1_28_0 gp_1_28_0 dpre_L1_28 ts_uU_L1_28_0 0 NMIR W=20u L=1u
Mo3_uU_L1_28_0 da_uU_L1_28_0 da_uU_L1_28_0 vdd vdd PMIR W=60u L=1u
Mo4_uU_L1_28_0 gp_1_28_0 da_uU_L1_28_0 vdd vdd PMIR W=60u L=1u
Mt_uU_L1_28_1 ts_uU_L1_28_1 a1 0 0 NMIR W=48.0u L=1u
Mo1_uU_L1_28_1 da_uU_L1_28_1 d1bar_L1 ts_uU_L1_28_1 0 NMIR W=20u L=1u
Mo2_uU_L1_28_1 gp_1_28_1 dpre_L1_28 ts_uU_L1_28_1 0 NMIR W=20u L=1u
Mo3_uU_L1_28_1 da_uU_L1_28_1 da_uU_L1_28_1 vdd vdd PMIR W=60u L=1u
Mo4_uU_L1_28_1 gp_1_28_1 da_uU_L1_28_1 vdd vdd PMIR W=60u L=1u
Mt_uU_L1_29_0 ts_uU_L1_29_0 a0 0 0 NMIR W=48.0u L=1u
Mo1_uU_L1_29_0 da_uU_L1_29_0 d1bar_L1 ts_uU_L1_29_0 0 NMIR W=20u L=1u
Mo2_uU_L1_29_0 gp_1_29_0 dpre_L1_29 ts_uU_L1_29_0 0 NMIR W=20u L=1u
Mo3_uU_L1_29_0 da_uU_L1_29_0 da_uU_L1_29_0 vdd vdd PMIR W=60u L=1u
Mo4_uU_L1_29_0 gp_1_29_0 da_uU_L1_29_0 vdd vdd PMIR W=60u L=1u
Mt_uU_L1_29_1 ts_uU_L1_29_1 a1 0 0 NMIR W=48.0u L=1u
Mo1_uU_L1_29_1 da_uU_L1_29_1 d1bar_L1 ts_uU_L1_29_1 0 NMIR W=20u L=1u
Mo2_uU_L1_29_1 gp_1_29_1 dpre_L1_29 ts_uU_L1_29_1 0 NMIR W=20u L=1u
Mo3_uU_L1_29_1 da_uU_L1_29_1 da_uU_L1_29_1 vdd vdd PMIR W=60u L=1u
Mo4_uU_L1_29_1 gp_1_29_1 da_uU_L1_29_1 vdd vdd PMIR W=60u L=1u
Mt_uU_L1_30_0 ts_uU_L1_30_0 a0 0 0 NMIR W=48.0u L=1u
Mo1_uU_L1_30_0 da_uU_L1_30_0 d1bar_L1 ts_uU_L1_30_0 0 NMIR W=20u L=1u
Mo2_uU_L1_30_0 gp_1_30_0 dpre_L1_30 ts_uU_L1_30_0 0 NMIR W=20u L=1u
Mo3_uU_L1_30_0 da_uU_L1_30_0 da_uU_L1_30_0 vdd vdd PMIR W=60u L=1u
Mo4_uU_L1_30_0 gp_1_30_0 da_uU_L1_30_0 vdd vdd PMIR W=60u L=1u
Mt_uU_L1_30_1 ts_uU_L1_30_1 a1 0 0 NMIR W=48.0u L=1u
Mo1_uU_L1_30_1 da_uU_L1_30_1 d1bar_L1 ts_uU_L1_30_1 0 NMIR W=20u L=1u
Mo2_uU_L1_30_1 gp_1_30_1 dpre_L1_30 ts_uU_L1_30_1 0 NMIR W=20u L=1u
Mo3_uU_L1_30_1 da_uU_L1_30_1 da_uU_L1_30_1 vdd vdd PMIR W=60u L=1u
Mo4_uU_L1_30_1 gp_1_30_1 da_uU_L1_30_1 vdd vdd PMIR W=60u L=1u
Mt_uU_L1_31_0 ts_uU_L1_31_0 a0 0 0 NMIR W=48.0u L=1u
Mo1_uU_L1_31_0 da_uU_L1_31_0 d1bar_L1 ts_uU_L1_31_0 0 NMIR W=20u L=1u
Mo2_uU_L1_31_0 gp_1_31_0 dpre_L1_31 ts_uU_L1_31_0 0 NMIR W=20u L=1u
Mo3_uU_L1_31_0 da_uU_L1_31_0 da_uU_L1_31_0 vdd vdd PMIR W=60u L=1u
Mo4_uU_L1_31_0 gp_1_31_0 da_uU_L1_31_0 vdd vdd PMIR W=60u L=1u
Mt_uU_L1_31_1 ts_uU_L1_31_1 a1 0 0 NMIR W=48.0u L=1u
Mo1_uU_L1_31_1 da_uU_L1_31_1 d1bar_L1 ts_uU_L1_31_1 0 NMIR W=20u L=1u
Mo2_uU_L1_31_1 gp_1_31_1 dpre_L1_31 ts_uU_L1_31_1 0 NMIR W=20u L=1u
Mo3_uU_L1_31_1 da_uU_L1_31_1 da_uU_L1_31_1 vdd vdd PMIR W=60u L=1u
Mo4_uU_L1_31_1 gp_1_31_1 da_uU_L1_31_1 vdd vdd PMIR W=60u L=1u
Mt_uU_L1_32_0 ts_uU_L1_32_0 a0 0 0 NMIR W=48.0u L=1u
Mo1_uU_L1_32_0 da_uU_L1_32_0 d1bar_L1 ts_uU_L1_32_0 0 NMIR W=20u L=1u
Mo2_uU_L1_32_0 gp_1_32_0 dpre_L1_32 ts_uU_L1_32_0 0 NMIR W=20u L=1u
Mo3_uU_L1_32_0 da_uU_L1_32_0 da_uU_L1_32_0 vdd vdd PMIR W=60u L=1u
Mo4_uU_L1_32_0 gp_1_32_0 da_uU_L1_32_0 vdd vdd PMIR W=60u L=1u
Mt_uU_L1_32_1 ts_uU_L1_32_1 a1 0 0 NMIR W=48.0u L=1u
Mo1_uU_L1_32_1 da_uU_L1_32_1 d1bar_L1 ts_uU_L1_32_1 0 NMIR W=20u L=1u
Mo2_uU_L1_32_1 gp_1_32_1 dpre_L1_32 ts_uU_L1_32_1 0 NMIR W=20u L=1u
Mo3_uU_L1_32_1 da_uU_L1_32_1 da_uU_L1_32_1 vdd vdd PMIR W=60u L=1u
Mo4_uU_L1_32_1 gp_1_32_1 da_uU_L1_32_1 vdd vdd PMIR W=60u L=1u
Mt_uU_L1_33_0 ts_uU_L1_33_0 a0 0 0 NMIR W=48.0u L=1u
Mo1_uU_L1_33_0 da_uU_L1_33_0 d1bar_L1 ts_uU_L1_33_0 0 NMIR W=20u L=1u
Mo2_uU_L1_33_0 gp_1_33_0 dpre_L1_33 ts_uU_L1_33_0 0 NMIR W=20u L=1u
Mo3_uU_L1_33_0 da_uU_L1_33_0 da_uU_L1_33_0 vdd vdd PMIR W=60u L=1u
Mo4_uU_L1_33_0 gp_1_33_0 da_uU_L1_33_0 vdd vdd PMIR W=60u L=1u
Mt_uU_L1_33_1 ts_uU_L1_33_1 a1 0 0 NMIR W=48.0u L=1u
Mo1_uU_L1_33_1 da_uU_L1_33_1 d1bar_L1 ts_uU_L1_33_1 0 NMIR W=20u L=1u
Mo2_uU_L1_33_1 gp_1_33_1 dpre_L1_33 ts_uU_L1_33_1 0 NMIR W=20u L=1u
Mo3_uU_L1_33_1 da_uU_L1_33_1 da_uU_L1_33_1 vdd vdd PMIR W=60u L=1u
Mo4_uU_L1_33_1 gp_1_33_1 da_uU_L1_33_1 vdd vdd PMIR W=60u L=1u
Mt_uU_L1_34_0 ts_uU_L1_34_0 a0 0 0 NMIR W=48.0u L=1u
Mo1_uU_L1_34_0 da_uU_L1_34_0 d1bar_L1 ts_uU_L1_34_0 0 NMIR W=20u L=1u
Mo2_uU_L1_34_0 gp_1_34_0 dpre_L1_34 ts_uU_L1_34_0 0 NMIR W=20u L=1u
Mo3_uU_L1_34_0 da_uU_L1_34_0 da_uU_L1_34_0 vdd vdd PMIR W=60u L=1u
Mo4_uU_L1_34_0 gp_1_34_0 da_uU_L1_34_0 vdd vdd PMIR W=60u L=1u
Mt_uU_L1_34_1 ts_uU_L1_34_1 a1 0 0 NMIR W=48.0u L=1u
Mo1_uU_L1_34_1 da_uU_L1_34_1 d1bar_L1 ts_uU_L1_34_1 0 NMIR W=20u L=1u
Mo2_uU_L1_34_1 gp_1_34_1 dpre_L1_34 ts_uU_L1_34_1 0 NMIR W=20u L=1u
Mo3_uU_L1_34_1 da_uU_L1_34_1 da_uU_L1_34_1 vdd vdd PMIR W=60u L=1u
Mo4_uU_L1_34_1 gp_1_34_1 da_uU_L1_34_1 vdd vdd PMIR W=60u L=1u
Mt_uU_L1_35_0 ts_uU_L1_35_0 a0 0 0 NMIR W=48.0u L=1u
Mo1_uU_L1_35_0 da_uU_L1_35_0 d1bar_L1 ts_uU_L1_35_0 0 NMIR W=20u L=1u
Mo2_uU_L1_35_0 gp_1_35_0 dpre_L1_35 ts_uU_L1_35_0 0 NMIR W=20u L=1u
Mo3_uU_L1_35_0 da_uU_L1_35_0 da_uU_L1_35_0 vdd vdd PMIR W=60u L=1u
Mo4_uU_L1_35_0 gp_1_35_0 da_uU_L1_35_0 vdd vdd PMIR W=60u L=1u
Mt_uU_L1_35_1 ts_uU_L1_35_1 a1 0 0 NMIR W=48.0u L=1u
Mo1_uU_L1_35_1 da_uU_L1_35_1 d1bar_L1 ts_uU_L1_35_1 0 NMIR W=20u L=1u
Mo2_uU_L1_35_1 gp_1_35_1 dpre_L1_35 ts_uU_L1_35_1 0 NMIR W=20u L=1u
Mo3_uU_L1_35_1 da_uU_L1_35_1 da_uU_L1_35_1 vdd vdd PMIR W=60u L=1u
Mo4_uU_L1_35_1 gp_1_35_1 da_uU_L1_35_1 vdd vdd PMIR W=60u L=1u
Mt_uU_L1_36_0 ts_uU_L1_36_0 a0 0 0 NMIR W=48.0u L=1u
Mo1_uU_L1_36_0 da_uU_L1_36_0 d1bar_L1 ts_uU_L1_36_0 0 NMIR W=20u L=1u
Mo2_uU_L1_36_0 gp_1_36_0 dpre_L1_36 ts_uU_L1_36_0 0 NMIR W=20u L=1u
Mo3_uU_L1_36_0 da_uU_L1_36_0 da_uU_L1_36_0 vdd vdd PMIR W=60u L=1u
Mo4_uU_L1_36_0 gp_1_36_0 da_uU_L1_36_0 vdd vdd PMIR W=60u L=1u
Mt_uU_L1_36_1 ts_uU_L1_36_1 a1 0 0 NMIR W=48.0u L=1u
Mo1_uU_L1_36_1 da_uU_L1_36_1 d1bar_L1 ts_uU_L1_36_1 0 NMIR W=20u L=1u
Mo2_uU_L1_36_1 gp_1_36_1 dpre_L1_36 ts_uU_L1_36_1 0 NMIR W=20u L=1u
Mo3_uU_L1_36_1 da_uU_L1_36_1 da_uU_L1_36_1 vdd vdd PMIR W=60u L=1u
Mo4_uU_L1_36_1 gp_1_36_1 da_uU_L1_36_1 vdd vdd PMIR W=60u L=1u
Mt_uU_L1_37_0 ts_uU_L1_37_0 a0 0 0 NMIR W=48.0u L=1u
Mo1_uU_L1_37_0 da_uU_L1_37_0 d1bar_L1 ts_uU_L1_37_0 0 NMIR W=20u L=1u
Mo2_uU_L1_37_0 gp_1_37_0 dpre_L1_37 ts_uU_L1_37_0 0 NMIR W=20u L=1u
Mo3_uU_L1_37_0 da_uU_L1_37_0 da_uU_L1_37_0 vdd vdd PMIR W=60u L=1u
Mo4_uU_L1_37_0 gp_1_37_0 da_uU_L1_37_0 vdd vdd PMIR W=60u L=1u
Mt_uU_L1_37_1 ts_uU_L1_37_1 a1 0 0 NMIR W=48.0u L=1u
Mo1_uU_L1_37_1 da_uU_L1_37_1 d1bar_L1 ts_uU_L1_37_1 0 NMIR W=20u L=1u
Mo2_uU_L1_37_1 gp_1_37_1 dpre_L1_37 ts_uU_L1_37_1 0 NMIR W=20u L=1u
Mo3_uU_L1_37_1 da_uU_L1_37_1 da_uU_L1_37_1 vdd vdd PMIR W=60u L=1u
Mo4_uU_L1_37_1 gp_1_37_1 da_uU_L1_37_1 vdd vdd PMIR W=60u L=1u
Mt_uU_L1_38_0 ts_uU_L1_38_0 a0 0 0 NMIR W=48.0u L=1u
Mo1_uU_L1_38_0 da_uU_L1_38_0 d1bar_L1 ts_uU_L1_38_0 0 NMIR W=20u L=1u
Mo2_uU_L1_38_0 gp_1_38_0 dpre_L1_38 ts_uU_L1_38_0 0 NMIR W=20u L=1u
Mo3_uU_L1_38_0 da_uU_L1_38_0 da_uU_L1_38_0 vdd vdd PMIR W=60u L=1u
Mo4_uU_L1_38_0 gp_1_38_0 da_uU_L1_38_0 vdd vdd PMIR W=60u L=1u
Mt_uU_L1_38_1 ts_uU_L1_38_1 a1 0 0 NMIR W=48.0u L=1u
Mo1_uU_L1_38_1 da_uU_L1_38_1 d1bar_L1 ts_uU_L1_38_1 0 NMIR W=20u L=1u
Mo2_uU_L1_38_1 gp_1_38_1 dpre_L1_38 ts_uU_L1_38_1 0 NMIR W=20u L=1u
Mo3_uU_L1_38_1 da_uU_L1_38_1 da_uU_L1_38_1 vdd vdd PMIR W=60u L=1u
Mo4_uU_L1_38_1 gp_1_38_1 da_uU_L1_38_1 vdd vdd PMIR W=60u L=1u
Mt_uU_L1_39_0 ts_uU_L1_39_0 a0 0 0 NMIR W=48.0u L=1u
Mo1_uU_L1_39_0 da_uU_L1_39_0 d1bar_L1 ts_uU_L1_39_0 0 NMIR W=20u L=1u
Mo2_uU_L1_39_0 gp_1_39_0 dpre_L1_39 ts_uU_L1_39_0 0 NMIR W=20u L=1u
Mo3_uU_L1_39_0 da_uU_L1_39_0 da_uU_L1_39_0 vdd vdd PMIR W=60u L=1u
Mo4_uU_L1_39_0 gp_1_39_0 da_uU_L1_39_0 vdd vdd PMIR W=60u L=1u
Mt_uU_L1_39_1 ts_uU_L1_39_1 a1 0 0 NMIR W=48.0u L=1u
Mo1_uU_L1_39_1 da_uU_L1_39_1 d1bar_L1 ts_uU_L1_39_1 0 NMIR W=20u L=1u
Mo2_uU_L1_39_1 gp_1_39_1 dpre_L1_39 ts_uU_L1_39_1 0 NMIR W=20u L=1u
Mo3_uU_L1_39_1 da_uU_L1_39_1 da_uU_L1_39_1 vdd vdd PMIR W=60u L=1u
Mo4_uU_L1_39_1 gp_1_39_1 da_uU_L1_39_1 vdd vdd PMIR W=60u L=1u
Mt_uU_L1_40_0 ts_uU_L1_40_0 a0 0 0 NMIR W=48.0u L=1u
Mo1_uU_L1_40_0 da_uU_L1_40_0 d1bar_L1 ts_uU_L1_40_0 0 NMIR W=20u L=1u
Mo2_uU_L1_40_0 gp_1_40_0 dpre_L1_40 ts_uU_L1_40_0 0 NMIR W=20u L=1u
Mo3_uU_L1_40_0 da_uU_L1_40_0 da_uU_L1_40_0 vdd vdd PMIR W=60u L=1u
Mo4_uU_L1_40_0 gp_1_40_0 da_uU_L1_40_0 vdd vdd PMIR W=60u L=1u
Mt_uU_L1_40_1 ts_uU_L1_40_1 a1 0 0 NMIR W=48.0u L=1u
Mo1_uU_L1_40_1 da_uU_L1_40_1 d1bar_L1 ts_uU_L1_40_1 0 NMIR W=20u L=1u
Mo2_uU_L1_40_1 gp_1_40_1 dpre_L1_40 ts_uU_L1_40_1 0 NMIR W=20u L=1u
Mo3_uU_L1_40_1 da_uU_L1_40_1 da_uU_L1_40_1 vdd vdd PMIR W=60u L=1u
Mo4_uU_L1_40_1 gp_1_40_1 da_uU_L1_40_1 vdd vdd PMIR W=60u L=1u
Mt_uU_L1_41_0 ts_uU_L1_41_0 a0 0 0 NMIR W=48.0u L=1u
Mo1_uU_L1_41_0 da_uU_L1_41_0 d1bar_L1 ts_uU_L1_41_0 0 NMIR W=20u L=1u
Mo2_uU_L1_41_0 gp_1_41_0 dpre_L1_41 ts_uU_L1_41_0 0 NMIR W=20u L=1u
Mo3_uU_L1_41_0 da_uU_L1_41_0 da_uU_L1_41_0 vdd vdd PMIR W=60u L=1u
Mo4_uU_L1_41_0 gp_1_41_0 da_uU_L1_41_0 vdd vdd PMIR W=60u L=1u
Mt_uU_L1_41_1 ts_uU_L1_41_1 a1 0 0 NMIR W=48.0u L=1u
Mo1_uU_L1_41_1 da_uU_L1_41_1 d1bar_L1 ts_uU_L1_41_1 0 NMIR W=20u L=1u
Mo2_uU_L1_41_1 gp_1_41_1 dpre_L1_41 ts_uU_L1_41_1 0 NMIR W=20u L=1u
Mo3_uU_L1_41_1 da_uU_L1_41_1 da_uU_L1_41_1 vdd vdd PMIR W=60u L=1u
Mo4_uU_L1_41_1 gp_1_41_1 da_uU_L1_41_1 vdd vdd PMIR W=60u L=1u
Mt_uU_L1_42_0 ts_uU_L1_42_0 a0 0 0 NMIR W=48.0u L=1u
Mo1_uU_L1_42_0 da_uU_L1_42_0 d1bar_L1 ts_uU_L1_42_0 0 NMIR W=20u L=1u
Mo2_uU_L1_42_0 gp_1_42_0 dpre_L1_42 ts_uU_L1_42_0 0 NMIR W=20u L=1u
Mo3_uU_L1_42_0 da_uU_L1_42_0 da_uU_L1_42_0 vdd vdd PMIR W=60u L=1u
Mo4_uU_L1_42_0 gp_1_42_0 da_uU_L1_42_0 vdd vdd PMIR W=60u L=1u
Mt_uU_L1_42_1 ts_uU_L1_42_1 a1 0 0 NMIR W=48.0u L=1u
Mo1_uU_L1_42_1 da_uU_L1_42_1 d1bar_L1 ts_uU_L1_42_1 0 NMIR W=20u L=1u
Mo2_uU_L1_42_1 gp_1_42_1 dpre_L1_42 ts_uU_L1_42_1 0 NMIR W=20u L=1u
Mo3_uU_L1_42_1 da_uU_L1_42_1 da_uU_L1_42_1 vdd vdd PMIR W=60u L=1u
Mo4_uU_L1_42_1 gp_1_42_1 da_uU_L1_42_1 vdd vdd PMIR W=60u L=1u
Mt_uU_L1_43_0 ts_uU_L1_43_0 a0 0 0 NMIR W=48.0u L=1u
Mo1_uU_L1_43_0 da_uU_L1_43_0 d1bar_L1 ts_uU_L1_43_0 0 NMIR W=20u L=1u
Mo2_uU_L1_43_0 gp_1_43_0 dpre_L1_43 ts_uU_L1_43_0 0 NMIR W=20u L=1u
Mo3_uU_L1_43_0 da_uU_L1_43_0 da_uU_L1_43_0 vdd vdd PMIR W=60u L=1u
Mo4_uU_L1_43_0 gp_1_43_0 da_uU_L1_43_0 vdd vdd PMIR W=60u L=1u
Mt_uU_L1_43_1 ts_uU_L1_43_1 a1 0 0 NMIR W=48.0u L=1u
Mo1_uU_L1_43_1 da_uU_L1_43_1 d1bar_L1 ts_uU_L1_43_1 0 NMIR W=20u L=1u
Mo2_uU_L1_43_1 gp_1_43_1 dpre_L1_43 ts_uU_L1_43_1 0 NMIR W=20u L=1u
Mo3_uU_L1_43_1 da_uU_L1_43_1 da_uU_L1_43_1 vdd vdd PMIR W=60u L=1u
Mo4_uU_L1_43_1 gp_1_43_1 da_uU_L1_43_1 vdd vdd PMIR W=60u L=1u
Mt_uU_L1_44_0 ts_uU_L1_44_0 a0 0 0 NMIR W=48.0u L=1u
Mo1_uU_L1_44_0 da_uU_L1_44_0 d1bar_L1 ts_uU_L1_44_0 0 NMIR W=20u L=1u
Mo2_uU_L1_44_0 gp_1_44_0 dpre_L1_44 ts_uU_L1_44_0 0 NMIR W=20u L=1u
Mo3_uU_L1_44_0 da_uU_L1_44_0 da_uU_L1_44_0 vdd vdd PMIR W=60u L=1u
Mo4_uU_L1_44_0 gp_1_44_0 da_uU_L1_44_0 vdd vdd PMIR W=60u L=1u
Mt_uU_L1_44_1 ts_uU_L1_44_1 a1 0 0 NMIR W=48.0u L=1u
Mo1_uU_L1_44_1 da_uU_L1_44_1 d1bar_L1 ts_uU_L1_44_1 0 NMIR W=20u L=1u
Mo2_uU_L1_44_1 gp_1_44_1 dpre_L1_44 ts_uU_L1_44_1 0 NMIR W=20u L=1u
Mo3_uU_L1_44_1 da_uU_L1_44_1 da_uU_L1_44_1 vdd vdd PMIR W=60u L=1u
Mo4_uU_L1_44_1 gp_1_44_1 da_uU_L1_44_1 vdd vdd PMIR W=60u L=1u
Mt_uU_L1_45_0 ts_uU_L1_45_0 a0 0 0 NMIR W=48.0u L=1u
Mo1_uU_L1_45_0 da_uU_L1_45_0 d1bar_L1 ts_uU_L1_45_0 0 NMIR W=20u L=1u
Mo2_uU_L1_45_0 gp_1_45_0 dpre_L1_45 ts_uU_L1_45_0 0 NMIR W=20u L=1u
Mo3_uU_L1_45_0 da_uU_L1_45_0 da_uU_L1_45_0 vdd vdd PMIR W=60u L=1u
Mo4_uU_L1_45_0 gp_1_45_0 da_uU_L1_45_0 vdd vdd PMIR W=60u L=1u
Mt_uU_L1_45_1 ts_uU_L1_45_1 a1 0 0 NMIR W=48.0u L=1u
Mo1_uU_L1_45_1 da_uU_L1_45_1 d1bar_L1 ts_uU_L1_45_1 0 NMIR W=20u L=1u
Mo2_uU_L1_45_1 gp_1_45_1 dpre_L1_45 ts_uU_L1_45_1 0 NMIR W=20u L=1u
Mo3_uU_L1_45_1 da_uU_L1_45_1 da_uU_L1_45_1 vdd vdd PMIR W=60u L=1u
Mo4_uU_L1_45_1 gp_1_45_1 da_uU_L1_45_1 vdd vdd PMIR W=60u L=1u
Mt_uU_L1_46_0 ts_uU_L1_46_0 a0 0 0 NMIR W=48.0u L=1u
Mo1_uU_L1_46_0 da_uU_L1_46_0 d1bar_L1 ts_uU_L1_46_0 0 NMIR W=20u L=1u
Mo2_uU_L1_46_0 gp_1_46_0 dpre_L1_46 ts_uU_L1_46_0 0 NMIR W=20u L=1u
Mo3_uU_L1_46_0 da_uU_L1_46_0 da_uU_L1_46_0 vdd vdd PMIR W=60u L=1u
Mo4_uU_L1_46_0 gp_1_46_0 da_uU_L1_46_0 vdd vdd PMIR W=60u L=1u
Mt_uU_L1_46_1 ts_uU_L1_46_1 a1 0 0 NMIR W=48.0u L=1u
Mo1_uU_L1_46_1 da_uU_L1_46_1 d1bar_L1 ts_uU_L1_46_1 0 NMIR W=20u L=1u
Mo2_uU_L1_46_1 gp_1_46_1 dpre_L1_46 ts_uU_L1_46_1 0 NMIR W=20u L=1u
Mo3_uU_L1_46_1 da_uU_L1_46_1 da_uU_L1_46_1 vdd vdd PMIR W=60u L=1u
Mo4_uU_L1_46_1 gp_1_46_1 da_uU_L1_46_1 vdd vdd PMIR W=60u L=1u
Mt_uU_L1_47_0 ts_uU_L1_47_0 a0 0 0 NMIR W=48.0u L=1u
Mo1_uU_L1_47_0 da_uU_L1_47_0 d1bar_L1 ts_uU_L1_47_0 0 NMIR W=20u L=1u
Mo2_uU_L1_47_0 gp_1_47_0 dpre_L1_47 ts_uU_L1_47_0 0 NMIR W=20u L=1u
Mo3_uU_L1_47_0 da_uU_L1_47_0 da_uU_L1_47_0 vdd vdd PMIR W=60u L=1u
Mo4_uU_L1_47_0 gp_1_47_0 da_uU_L1_47_0 vdd vdd PMIR W=60u L=1u
Mt_uU_L1_47_1 ts_uU_L1_47_1 a1 0 0 NMIR W=48.0u L=1u
Mo1_uU_L1_47_1 da_uU_L1_47_1 d1bar_L1 ts_uU_L1_47_1 0 NMIR W=20u L=1u
Mo2_uU_L1_47_1 gp_1_47_1 dpre_L1_47 ts_uU_L1_47_1 0 NMIR W=20u L=1u
Mo3_uU_L1_47_1 da_uU_L1_47_1 da_uU_L1_47_1 vdd vdd PMIR W=60u L=1u
Mo4_uU_L1_47_1 gp_1_47_1 da_uU_L1_47_1 vdd vdd PMIR W=60u L=1u
.ic v(gp_1_0_0)=1.5372 v(gp_1_0_1)=2.0496 v(gp_1_0_b)=1.9896 v(gp_1_1_0)=1.6236 v(gp_1_1_1)=1.7964 v(gp_1_1_b)=1.764 v(gp_1_2_0)=1.9092 v(gp_1_2_1)=2.0076 v(gp_1_2_b)=1.5072 v(gp_1_3_0)=1.4604 v(gp_1_3_1)=2.0412 v(gp_1_3_b)=1.752 v(gp_1_4_0)=1.9884 v(gp_1_4_1)=1.4412 v(gp_1_4_b)=1.7604 v(gp_1_5_0)=1.9596 v(gp_1_5_1)=1.6044 v(gp_1_5_b)=2.1204 v(gp_1_6_0)=2.0892 v(gp_1_6_1)=1.4616 v(gp_1_6_b)=1.458 v(gp_1_7_0)=1.83 v(gp_1_7_1)=2.1156 v(gp_1_7_b)=1.7148 v(gp_1_8_0)=1.596 v(gp_1_8_1)=1.7436 v(gp_1_8_b)=1.4604 v(gp_1_9_0)=1.5996 v(gp_1_9_1)=1.7556 v(gp_1_9_b)=1.7964 v(gp_1_10_0)=1.608 v(gp_1_10_1)=1.6068 v(gp_1_10_b)=1.5972 v(gp_1_11_0)=1.7712 v(gp_1_11_1)=1.6488 v(gp_1_11_b)=1.4556 v(gp_1_12_0)=2.0436 v(gp_1_12_1)=1.8408 v(gp_1_12_b)=1.902 v(gp_1_13_0)=1.5744 v(gp_1_13_1)=2.1552 v(gp_1_13_b)=2.0592 v(gp_1_14_0)=1.5276 v(gp_1_14_1)=1.68 v(gp_1_14_b)=1.9596 v(gp_1_15_0)=1.9524 v(gp_1_15_1)=2.1144 v(gp_1_15_b)=1.7436 v(gp_1_16_0)=2.0376 v(gp_1_16_1)=1.9224 v(gp_1_16_b)=1.6584 v(gp_1_17_0)=1.8636 v(gp_1_17_1)=2.0748 v(gp_1_17_b)=2.0496 v(gp_1_18_0)=1.8036 v(gp_1_18_1)=1.8636 v(gp_1_18_b)=1.4652 v(gp_1_19_0)=1.6152 v(gp_1_19_1)=2.0136 v(gp_1_19_b)=1.7388 v(gp_1_20_0)=1.5648 v(gp_1_20_1)=1.8348 v(gp_1_20_b)=1.9464 v(gp_1_21_0)=1.926 v(gp_1_21_1)=1.71 v(gp_1_21_b)=1.7556 v(gp_1_22_0)=1.806 v(gp_1_22_1)=2.0004 v(gp_1_22_b)=1.8156 v(gp_1_23_0)=1.7232 v(gp_1_23_1)=1.7928 v(gp_1_23_b)=1.4616 v(gp_1_24_0)=1.4712 v(gp_1_24_1)=1.9464 v(gp_1_24_b)=2.148 v(gp_1_25_0)=1.8672 v(gp_1_25_1)=1.7232 v(gp_1_25_b)=1.5624 v(gp_1_26_0)=1.8012 v(gp_1_26_1)=2.1468 v(gp_1_26_b)=1.9944 v(gp_1_27_0)=1.8288 v(gp_1_27_1)=2.0592 v(gp_1_27_b)=1.6068 v(gp_1_28_0)=1.8096 v(gp_1_28_1)=2.1252 v(gp_1_28_b)=1.8564 v(gp_1_29_0)=1.77 v(gp_1_29_1)=1.6344 v(gp_1_29_b)=1.8348 v(gp_1_30_0)=2.1288 v(gp_1_30_1)=1.4436 v(gp_1_30_b)=2.004 v(gp_1_31_0)=2.0304 v(gp_1_31_1)=2.0784 v(gp_1_31_b)=1.9728 v(gp_1_32_0)=2.022 v(gp_1_32_1)=1.8132 v(gp_1_32_b)=1.8444 v(gp_1_33_0)=1.7472 v(gp_1_33_1)=1.4808 v(gp_1_33_b)=2.0664 v(gp_1_34_0)=1.8504 v(gp_1_34_1)=1.584 v(gp_1_34_b)=1.8036 v(gp_1_35_0)=1.7892 v(gp_1_35_1)=1.6968 v(gp_1_35_b)=1.6896 v(gp_1_36_0)=1.8276 v(gp_1_36_1)=1.8888 v(gp_1_36_b)=1.8804 v(gp_1_37_0)=1.77 v(gp_1_37_1)=1.4604 v(gp_1_37_b)=1.6056 v(gp_1_38_0)=1.5672 v(gp_1_38_1)=1.8612 v(gp_1_38_b)=2.0604 v(gp_1_39_0)=2.0148 v(gp_1_39_1)=2.0136 v(gp_1_39_b)=2.028 v(gp_1_40_0)=1.6236 v(gp_1_40_1)=2.046 v(gp_1_40_b)=1.9248 v(gp_1_41_0)=1.5 v(gp_1_41_1)=1.452 v(gp_1_41_b)=1.4508 v(gp_1_42_0)=1.9836 v(gp_1_42_1)=1.62 v(gp_1_42_b)=1.5192 v(gp_1_43_0)=1.89 v(gp_1_43_1)=1.6884 v(gp_1_43_b)=1.4904 v(gp_1_44_0)=1.5552 v(gp_1_44_1)=1.8192 v(gp_1_44_b)=1.5612 v(gp_1_45_0)=1.6368 v(gp_1_45_1)=1.9524 v(gp_1_45_b)=1.7676 v(gp_1_46_0)=1.6716 v(gp_1_46_1)=1.7808 v(gp_1_46_b)=1.4568 v(gp_1_47_0)=1.7184 v(gp_1_47_1)=1.7436 v(gp_1_47_b)=1.5756 v(gp_2_0_0)=1.518 v(gp_2_0_1)=2.088 v(gp_2_0_2)=1.8072 v(gp_2_0_3)=1.59 v(gp_2_0_4)=1.8756 v(gp_2_0_5)=2.028 v(gp_2_0_6)=1.4544 v(gp_2_0_7)=1.4532 v(gp_2_0_8)=1.5456 v(gp_2_0_9)=1.9572 v(gp_2_0_10)=1.5552 v(gp_2_0_11)=1.9476 v(gp_2_0_12)=1.9284 v(gp_2_0_13)=1.8324 v(gp_2_0_14)=1.5984 v(gp_2_0_15)=2.142 v(gp_2_0_b)=2.0148 v(gp_2_1_0)=1.812 v(gp_2_1_1)=1.6008 v(gp_2_1_2)=1.9068 v(gp_2_1_3)=1.7244 v(gp_2_1_4)=1.8552 v(gp_2_1_5)=1.6716 v(gp_2_1_6)=1.8948 v(gp_2_1_7)=1.482 v(gp_2_1_8)=1.6548 v(gp_2_1_9)=2.1372 v(gp_2_1_10)=2.07 v(gp_2_1_11)=1.6608 v(gp_2_1_12)=2.058 v(gp_2_1_13)=1.6632 v(gp_2_1_14)=2.1168 v(gp_2_1_15)=1.9752 v(gp_2_1_b)=1.74 v(gp_2_2_0)=1.6212 v(gp_2_2_1)=1.446 v(gp_2_2_2)=2.0724 v(gp_2_2_3)=1.4676 v(gp_2_2_4)=2.0304 v(gp_2_2_5)=2.1324 v(gp_2_2_6)=1.8504 v(gp_2_2_7)=1.5636 v(gp_2_2_8)=2.0652 v(gp_2_2_9)=2.1408 v(gp_2_2_10)=1.9464 v(gp_2_2_11)=1.806 v(gp_2_2_12)=1.7124 v(gp_2_2_13)=1.6896 v(gp_2_2_14)=1.5876 v(gp_2_2_15)=1.9248 v(gp_2_2_b)=1.752 v(gp_2_3_0)=1.5792 v(gp_2_3_1)=1.5156 v(gp_2_3_2)=1.92 v(gp_2_3_3)=1.6536 v(gp_2_3_4)=1.8 v(gp_2_3_5)=1.674 v(gp_2_3_6)=2.0676 v(gp_2_3_7)=2.088 v(gp_2_3_8)=1.4532 v(gp_2_3_9)=1.5852 v(gp_2_3_10)=1.6764 v(gp_2_3_11)=2.1504 v(gp_2_3_12)=2.004 v(gp_2_3_13)=1.6836 v(gp_2_3_14)=1.5936 v(gp_2_3_15)=1.926 v(gp_2_3_b)=2.0436 v(gp_2_4_0)=2.1108 v(gp_2_4_1)=1.6872 v(gp_2_4_2)=2.0748 v(gp_2_4_3)=1.9344 v(gp_2_4_4)=1.7892 v(gp_2_4_5)=2.1492 v(gp_2_4_6)=1.6092 v(gp_2_4_7)=1.962 v(gp_2_4_8)=1.5012 v(gp_2_4_9)=1.5624 v(gp_2_4_10)=2.0964 v(gp_2_4_11)=1.5936 v(gp_2_4_12)=1.986 v(gp_2_4_13)=1.872 v(gp_2_4_14)=2.046 v(gp_2_4_15)=1.7052 v(gp_2_4_b)=1.6848 v(gp_2_5_0)=1.65 v(gp_2_5_1)=2.064 v(gp_2_5_2)=1.8744 v(gp_2_5_3)=2.1276 v(gp_2_5_4)=2.0784 v(gp_2_5_5)=1.5372 v(gp_2_5_6)=1.8372 v(gp_2_5_7)=1.5156 v(gp_2_5_8)=1.4676 v(gp_2_5_9)=1.4928 v(gp_2_5_10)=2.064 v(gp_2_5_11)=2.0076 v(gp_2_5_12)=2.0364 v(gp_2_5_13)=1.686 v(gp_2_5_14)=1.8828 v(gp_2_5_15)=2.0028 v(gp_2_5_b)=1.7124 v(gp_2_6_0)=1.8504 v(gp_2_6_1)=1.6008 v(gp_2_6_2)=1.4988 v(gp_2_6_3)=1.632 v(gp_2_6_4)=2.0808 v(gp_2_6_5)=1.8468 v(gp_2_6_6)=2.106 v(gp_2_6_7)=1.77 v(gp_2_6_8)=1.6392 v(gp_2_6_9)=2.0064 v(gp_2_6_10)=2.0364 v(gp_2_6_11)=1.4484 v(gp_2_6_12)=1.9224 v(gp_2_6_13)=1.506 v(gp_2_6_14)=1.5228 v(gp_2_6_15)=2.0772 v(gp_2_6_b)=1.4688 v(gp_2_7_0)=1.6128 v(gp_2_7_1)=2.1516 v(gp_2_7_2)=1.7436 v(gp_2_7_3)=1.5228 v(gp_2_7_4)=1.56 v(gp_2_7_5)=1.614 v(gp_2_7_6)=1.9752 v(gp_2_7_7)=1.5144 v(gp_2_7_8)=2.0952 v(gp_2_7_9)=1.7124 v(gp_2_7_10)=2.1384 v(gp_2_7_11)=2.0952 v(gp_2_7_12)=1.6512 v(gp_2_7_13)=1.6224 v(gp_2_7_14)=1.7832 v(gp_2_7_15)=1.512 v(gp_2_7_b)=1.9092 v(gp_2_8_0)=1.4688 v(gp_2_8_1)=1.4472 v(gp_2_8_2)=2.148 v(gp_2_8_3)=1.6524 v(gp_2_8_4)=1.8696 v(gp_2_8_5)=1.764 v(gp_2_8_6)=1.6656 v(gp_2_8_7)=1.4856 v(gp_2_8_8)=2.0976 v(gp_2_8_9)=2.1384 v(gp_2_8_10)=2.1384 v(gp_2_8_11)=1.5204 v(gp_2_8_12)=1.5948 v(gp_2_8_13)=1.8852 v(gp_2_8_14)=2.1456 v(gp_2_8_15)=1.8312 v(gp_2_8_b)=1.9356 v(gp_2_9_0)=1.9164 v(gp_2_9_1)=1.626 v(gp_2_9_2)=1.83 v(gp_2_9_3)=1.6608 v(gp_2_9_4)=1.6176 v(gp_2_9_5)=1.4988 v(gp_2_9_6)=1.6416 v(gp_2_9_7)=2.148 v(gp_2_9_8)=1.7628 v(gp_2_9_9)=1.9092 v(gp_2_9_10)=1.9032 v(gp_2_9_11)=2.1168 v(gp_2_9_12)=1.7208 v(gp_2_9_13)=1.6608 v(gp_2_9_14)=1.6752 v(gp_2_9_15)=1.668 v(gp_2_9_b)=2.0496 v(gp_2_10_0)=2.0832 v(gp_2_10_1)=1.6584 v(gp_2_10_2)=1.6812 v(gp_2_10_3)=1.8324 v(gp_2_10_4)=1.8564 v(gp_2_10_5)=1.8696 v(gp_2_10_6)=1.6164 v(gp_2_10_7)=1.4544 v(gp_2_10_8)=1.6152 v(gp_2_10_9)=1.4916 v(gp_2_10_10)=1.8372 v(gp_2_10_11)=1.4916 v(gp_2_10_12)=1.494 v(gp_2_10_13)=1.8972 v(gp_2_10_14)=1.6488 v(gp_2_10_15)=2.01 v(gp_2_10_b)=1.7952 v(gp_2_11_0)=2.0616 v(gp_2_11_1)=1.5516 v(gp_2_11_2)=1.8012 v(gp_2_11_3)=2.0124 v(gp_2_11_4)=1.4952 v(gp_2_11_5)=2.124 v(gp_2_11_6)=1.5648 v(gp_2_11_7)=1.9992 v(gp_2_11_8)=2.1492 v(gp_2_11_9)=2.0316 v(gp_2_11_10)=1.6704 v(gp_2_11_11)=1.5168 v(gp_2_11_12)=1.8108 v(gp_2_11_13)=2.1024 v(gp_2_11_14)=1.6512 v(gp_2_11_15)=2.0832 v(gp_2_11_b)=1.542 v(gp_2_12_0)=2.0952 v(gp_2_12_1)=1.4628 v(gp_2_12_2)=1.668 v(gp_2_12_3)=2.0904 v(gp_2_12_4)=2.0184 v(gp_2_12_5)=2.0928 v(gp_2_12_6)=2.0448 v(gp_2_12_7)=1.9776 v(gp_2_12_8)=1.9368 v(gp_2_12_9)=1.5684 v(gp_2_12_10)=1.752 v(gp_2_12_11)=1.554 v(gp_2_12_12)=1.9548 v(gp_2_12_13)=1.9212 v(gp_2_12_14)=1.6224 v(gp_2_12_15)=1.4868 v(gp_2_12_b)=2.1336 v(gp_2_13_0)=2.022 v(gp_2_13_1)=1.836 v(gp_2_13_2)=1.83 v(gp_2_13_3)=2.0532 v(gp_2_13_4)=1.7664 v(gp_2_13_5)=1.7244 v(gp_2_13_6)=1.6836 v(gp_2_13_7)=1.626 v(gp_2_13_8)=1.458 v(gp_2_13_9)=1.9056 v(gp_2_13_10)=1.74 v(gp_2_13_11)=1.8504 v(gp_2_13_12)=1.4844 v(gp_2_13_13)=1.6956 v(gp_2_13_14)=1.5396 v(gp_2_13_15)=1.53 v(gp_2_13_b)=1.626 v(gp_2_14_0)=2.0364 v(gp_2_14_1)=1.7268 v(gp_2_14_2)=1.7292 v(gp_2_14_3)=1.8804 v(gp_2_14_4)=1.608 v(gp_2_14_5)=1.4448 v(gp_2_14_6)=1.8204 v(gp_2_14_7)=1.8012 v(gp_2_14_8)=1.9068 v(gp_2_14_9)=1.7556 v(gp_2_14_10)=1.9344 v(gp_2_14_11)=1.9668 v(gp_2_14_12)=1.6116 v(gp_2_14_13)=1.7964 v(gp_2_14_14)=1.7844 v(gp_2_14_15)=1.602 v(gp_2_14_b)=1.7364 v(gp_2_15_0)=1.8432 v(gp_2_15_1)=2.0928 v(gp_2_15_2)=2.1012 v(gp_2_15_3)=1.638 v(gp_2_15_4)=1.9056 v(gp_2_15_5)=1.4748 v(gp_2_15_6)=1.4916 v(gp_2_15_7)=1.8084 v(gp_2_15_8)=2.0712 v(gp_2_15_9)=1.5552 v(gp_2_15_10)=1.992 v(gp_2_15_11)=2.076 v(gp_2_15_12)=1.6644 v(gp_2_15_13)=1.9392 v(gp_2_15_14)=2.0508 v(gp_2_15_15)=1.7076 v(gp_2_15_b)=1.9452 v(gp_2_16_0)=1.9704 v(gp_2_16_1)=1.8684 v(gp_2_16_2)=2.0568 v(gp_2_16_3)=2.0856 v(gp_2_16_4)=2.1312 v(gp_2_16_5)=1.8516 v(gp_2_16_6)=1.5672 v(gp_2_16_7)=1.62 v(gp_2_16_8)=1.5972 v(gp_2_16_9)=1.8504 v(gp_2_16_10)=1.986 v(gp_2_16_11)=1.4772 v(gp_2_16_12)=1.9308 v(gp_2_16_13)=1.956 v(gp_2_16_14)=1.6908 v(gp_2_16_15)=1.8108 v(gp_2_16_b)=1.5588 v(gp_2_17_0)=1.9656 v(gp_2_17_1)=1.4688 v(gp_2_17_2)=2.1468 v(gp_2_17_3)=2.022 v(gp_2_17_4)=1.8924 v(gp_2_17_5)=1.6332 v(gp_2_17_6)=2.0976 v(gp_2_17_7)=2.1312 v(gp_2_17_8)=1.5396 v(gp_2_17_9)=1.998 v(gp_2_17_10)=2.046 v(gp_2_17_11)=1.9152 v(gp_2_17_12)=1.944 v(gp_2_17_13)=1.7604 v(gp_2_17_14)=2.106 v(gp_2_17_15)=2.1396 v(gp_2_17_b)=1.7148 v(gp_2_18_0)=2.0184 v(gp_2_18_1)=1.752 v(gp_2_18_2)=1.5588 v(gp_2_18_3)=1.674 v(gp_2_18_4)=1.5312 v(gp_2_18_5)=2.094 v(gp_2_18_6)=2.1312 v(gp_2_18_7)=1.5264 v(gp_2_18_8)=1.872 v(gp_2_18_9)=1.734 v(gp_2_18_10)=1.5252 v(gp_2_18_11)=1.6524 v(gp_2_18_12)=1.6188 v(gp_2_18_13)=1.98 v(gp_2_18_14)=1.4424 v(gp_2_18_15)=1.5768 v(gp_2_18_b)=1.7556 v(gp_2_19_0)=1.4556 v(gp_2_19_1)=1.8924 v(gp_2_19_2)=1.8756 v(gp_2_19_3)=2.0412 v(gp_2_19_4)=1.5888 v(gp_2_19_5)=1.6452 v(gp_2_19_6)=1.83 v(gp_2_19_7)=1.6368 v(gp_2_19_8)=1.8612 v(gp_2_19_9)=1.6212 v(gp_2_19_10)=1.932 v(gp_2_19_11)=2.01 v(gp_2_19_12)=2.022 v(gp_2_19_13)=2.1408 v(gp_2_19_14)=1.8324 v(gp_2_19_15)=1.7928 v(gp_2_19_b)=2.0556 v(gp_2_20_0)=1.9932 v(gp_2_20_1)=1.8504 v(gp_2_20_2)=1.716 v(gp_2_20_3)=1.644 v(gp_2_20_4)=1.518 v(gp_2_20_5)=2.022 v(gp_2_20_6)=1.5252 v(gp_2_20_7)=1.9776 v(gp_2_20_8)=1.8324 v(gp_2_20_9)=2.1348 v(gp_2_20_10)=1.9884 v(gp_2_20_11)=2.1408 v(gp_2_20_12)=1.5384 v(gp_2_20_13)=1.8 v(gp_2_20_14)=1.8528 v(gp_2_20_15)=1.6644 v(gp_2_20_b)=1.8024 v(gp_2_21_0)=1.6968 v(gp_2_21_1)=1.8204 v(gp_2_21_2)=1.4412 v(gp_2_21_3)=1.758 v(gp_2_21_4)=1.764 v(gp_2_21_5)=1.6596 v(gp_2_21_6)=1.728 v(gp_2_21_7)=2.004 v(gp_2_21_8)=1.932 v(gp_2_21_9)=1.794 v(gp_2_21_10)=1.9068 v(gp_2_21_11)=1.7124 v(gp_2_21_12)=1.5864 v(gp_2_21_13)=1.4424 v(gp_2_21_14)=1.6404 v(gp_2_21_15)=1.8708 v(gp_2_21_b)=2.0748 v(gp_2_22_0)=2.0376 v(gp_2_22_1)=1.8084 v(gp_2_22_2)=2.1504 v(gp_2_22_3)=1.7724 v(gp_2_22_4)=2.0412 v(gp_2_22_5)=1.734 v(gp_2_22_6)=1.9764 v(gp_2_22_7)=2.1516 v(gp_2_22_8)=1.6596 v(gp_2_22_9)=1.5624 v(gp_2_22_10)=1.8864 v(gp_2_22_11)=1.8228 v(gp_2_22_12)=1.6992 v(gp_2_22_13)=1.4424 v(gp_2_22_14)=1.7196 v(gp_2_22_15)=1.7472 v(gp_2_22_b)=1.7316 v(gp_2_23_0)=2.0604 v(gp_2_23_1)=1.8612 v(gp_2_23_2)=1.968 v(gp_2_23_3)=2.0868 v(gp_2_23_4)=1.9788 v(gp_2_23_5)=1.7952 v(gp_2_23_6)=1.9764 v(gp_2_23_7)=1.9008 v(gp_2_23_8)=1.9068 v(gp_2_23_9)=1.8936 v(gp_2_23_10)=1.7328 v(gp_2_23_11)=1.8936 v(gp_2_23_12)=1.896 v(gp_2_23_13)=2.1144 v(gp_2_23_14)=2.0028 v(gp_2_23_15)=2.0496 v(gp_2_23_b)=1.992 v(gp_2_24_0)=2.0268 v(gp_2_24_1)=1.8756 v(gp_2_24_2)=1.692 v(gp_2_24_3)=1.6308 v(gp_2_24_4)=1.95 v(gp_2_24_5)=2.0688 v(gp_2_24_6)=1.8324 v(gp_2_24_7)=1.5492 v(gp_2_24_8)=2.04 v(gp_2_24_9)=1.7892 v(gp_2_24_10)=1.776 v(gp_2_24_11)=1.4724 v(gp_2_24_12)=1.8072 v(gp_2_24_13)=1.9764 v(gp_2_24_14)=1.7448 v(gp_2_24_15)=1.6956 v(gp_2_24_b)=1.9128 v(gp_2_25_0)=1.4544 v(gp_2_25_1)=1.8048 v(gp_2_25_2)=2.1216 v(gp_2_25_3)=1.9368 v(gp_2_25_4)=1.7292 v(gp_2_25_5)=1.9356 v(gp_2_25_6)=1.8756 v(gp_2_25_7)=1.59 v(gp_2_25_8)=1.59 v(gp_2_25_9)=2.0784 v(gp_2_25_10)=1.6332 v(gp_2_25_11)=1.494 v(gp_2_25_12)=2.0376 v(gp_2_25_13)=1.8168 v(gp_2_25_14)=1.7052 v(gp_2_25_15)=1.8084 v(gp_2_25_b)=1.9704 v(gp_2_26_0)=1.5612 v(gp_2_26_1)=1.9104 v(gp_2_26_2)=1.9536 v(gp_2_26_3)=2.0268 v(gp_2_26_4)=1.6344 v(gp_2_26_5)=1.8792 v(gp_2_26_6)=1.6068 v(gp_2_26_7)=1.8444 v(gp_2_26_8)=1.5636 v(gp_2_26_9)=2.0088 v(gp_2_26_10)=2.064 v(gp_2_26_11)=1.6776 v(gp_2_26_12)=1.5996 v(gp_2_26_13)=2.1336 v(gp_2_26_14)=1.9488 v(gp_2_26_15)=2.0472 v(gp_2_26_b)=1.4616 v(gp_2_27_0)=2.088 v(gp_2_27_1)=1.8876 v(gp_2_27_2)=1.668 v(gp_2_27_3)=1.7508 v(gp_2_27_4)=1.9884 v(gp_2_27_5)=2.0052 v(gp_2_27_6)=1.5768 v(gp_2_27_7)=1.8912 v(gp_2_27_8)=1.5588 v(gp_2_27_9)=2.1408 v(gp_2_27_10)=1.7592 v(gp_2_27_11)=2.0976 v(gp_2_27_12)=1.9644 v(gp_2_27_13)=1.8768 v(gp_2_27_14)=1.6284 v(gp_2_27_15)=1.8192 v(gp_2_27_b)=1.5396 v(gp_2_28_0)=1.5396 v(gp_2_28_1)=1.9548 v(gp_2_28_2)=1.7004 v(gp_2_28_3)=1.9812 v(gp_2_28_4)=1.6128 v(gp_2_28_5)=1.9572 v(gp_2_28_6)=1.9572 v(gp_2_28_7)=1.6596 v(gp_2_28_8)=1.5168 v(gp_2_28_9)=1.7256 v(gp_2_28_10)=1.794 v(gp_2_28_11)=1.512 v(gp_2_28_12)=1.5744 v(gp_2_28_13)=1.4796 v(gp_2_28_14)=1.8708 v(gp_2_28_15)=2.0796 v(gp_2_28_b)=1.596 v(gp_2_29_0)=1.4652 v(gp_2_29_1)=1.9464 v(gp_2_29_2)=2.0268 v(gp_2_29_3)=2.1336 v(gp_2_29_4)=1.8816 v(gp_2_29_5)=1.686 v(gp_2_29_6)=2.0436 v(gp_2_29_7)=1.5252 v(gp_2_29_8)=1.9392 v(gp_2_29_9)=1.5084 v(gp_2_29_10)=1.728 v(gp_2_29_11)=1.7964 v(gp_2_29_12)=1.7124 v(gp_2_29_13)=1.5612 v(gp_2_29_14)=1.6068 v(gp_2_29_15)=2.0304 v(gp_2_29_b)=1.7736 v(gp_2_30_0)=1.8576 v(gp_2_30_1)=1.5924 v(gp_2_30_2)=1.9548 v(gp_2_30_3)=1.6776 v(gp_2_30_4)=1.8672 v(gp_2_30_5)=2.0952 v(gp_2_30_6)=2.1564 v(gp_2_30_7)=1.4736 v(gp_2_30_8)=2.0136 v(gp_2_30_9)=2.058 v(gp_2_30_10)=1.6704 v(gp_2_30_11)=1.716 v(gp_2_30_12)=1.8576 v(gp_2_30_13)=2.1012 v(gp_2_30_14)=1.728 v(gp_2_30_15)=2.0736 v(gp_2_30_b)=1.986 v(gp_2_31_0)=1.5492 v(gp_2_31_1)=2.0976 v(gp_2_31_2)=1.4508 v(gp_2_31_3)=1.5444 v(gp_2_31_4)=1.9188 v(gp_2_31_5)=1.4808 v(gp_2_31_6)=1.7136 v(gp_2_31_7)=1.5336 v(gp_2_31_8)=1.7736 v(gp_2_31_9)=2.0448 v(gp_2_31_10)=2.0928 v(gp_2_31_11)=1.4652 v(gp_2_31_12)=1.4844 v(gp_2_31_13)=2.0448 v(gp_2_31_14)=1.4712 v(gp_2_31_15)=1.6368 v(gp_2_31_b)=1.524 v(gp_2_32_0)=1.506 v(gp_2_32_1)=1.4604 v(gp_2_32_2)=1.8996 v(gp_2_32_3)=1.9764 v(gp_2_32_4)=1.9344 v(gp_2_32_5)=2.0484 v(gp_2_32_6)=1.9176 v(gp_2_32_7)=1.7208 v(gp_2_32_8)=1.8948 v(gp_2_32_9)=2.1384 v(gp_2_32_10)=1.902 v(gp_2_32_11)=1.6152 v(gp_2_32_12)=1.4832 v(gp_2_32_13)=2.1132 v(gp_2_32_14)=1.8648 v(gp_2_32_15)=1.692 v(gp_2_32_b)=1.8756 v(gp_2_33_0)=1.8432 v(gp_2_33_1)=1.8156 v(gp_2_33_2)=1.4832 v(gp_2_33_3)=1.6944 v(gp_2_33_4)=1.7376 v(gp_2_33_5)=1.584 v(gp_2_33_6)=2.0736 v(gp_2_33_7)=1.7448 v(gp_2_33_8)=1.9164 v(gp_2_33_9)=1.9536 v(gp_2_33_10)=1.9752 v(gp_2_33_11)=1.9596 v(gp_2_33_12)=1.9812 v(gp_2_33_13)=1.6212 v(gp_2_33_14)=2.1432 v(gp_2_33_15)=1.5492 v(gp_2_33_b)=2.1012 v(gp_2_34_0)=2.0556 v(gp_2_34_1)=2.0532 v(gp_2_34_2)=1.4784 v(gp_2_34_3)=1.506 v(gp_2_34_4)=2.0256 v(gp_2_34_5)=1.7784 v(gp_2_34_6)=1.7064 v(gp_2_34_7)=2.1492 v(gp_2_34_8)=1.4688 v(gp_2_34_9)=1.8228 v(gp_2_34_10)=1.7592 v(gp_2_34_11)=1.5324 v(gp_2_34_12)=1.7244 v(gp_2_34_13)=1.95 v(gp_2_34_14)=2.0748 v(gp_2_34_15)=1.458 v(gp_2_34_b)=1.818 v(gp_2_35_0)=1.5048 v(gp_2_35_1)=2.016 v(gp_2_35_2)=1.5012 v(gp_2_35_3)=1.4652 v(gp_2_35_4)=1.7172 v(gp_2_35_5)=1.968 v(gp_2_35_6)=1.6656 v(gp_2_35_7)=1.5336 v(gp_2_35_8)=2.0124 v(gp_2_35_9)=2.0208 v(gp_2_35_10)=2.0568 v(gp_2_35_11)=1.6584 v(gp_2_35_12)=1.746 v(gp_2_35_13)=1.6164 v(gp_2_35_14)=1.8408 v(gp_2_35_15)=1.6776 v(gp_2_35_b)=1.6836 v(gp_2_36_0)=2.004 v(gp_2_36_1)=2.1288 v(gp_2_36_2)=1.86 v(gp_2_36_3)=1.5156 v(gp_2_36_4)=1.9104 v(gp_2_36_5)=1.7628 v(gp_2_36_6)=2.1516 v(gp_2_36_7)=1.9584 v(gp_2_36_8)=2.0412 v(gp_2_36_9)=1.9452 v(gp_2_36_10)=1.8252 v(gp_2_36_11)=2.0856 v(gp_2_36_12)=2.0388 v(gp_2_36_13)=1.65 v(gp_2_36_14)=1.5528 v(gp_2_36_15)=1.7064 v(gp_2_36_b)=1.8156 v(gp_2_37_0)=1.5096 v(gp_2_37_1)=1.6884 v(gp_2_37_2)=1.854 v(gp_2_37_3)=1.4712 v(gp_2_37_4)=2.0268 v(gp_2_37_5)=1.9092 v(gp_2_37_6)=1.6656 v(gp_2_37_7)=1.6548 v(gp_2_37_8)=1.6944 v(gp_2_37_9)=1.674 v(gp_2_37_10)=1.9788 v(gp_2_37_11)=1.8012 v(gp_2_37_12)=1.8192 v(gp_2_37_13)=1.5468 v(gp_2_37_14)=2.0988 v(gp_2_37_15)=1.674 v(gp_2_37_b)=1.6764 v(gp_2_38_0)=1.4892 v(gp_2_38_1)=2.1456 v(gp_2_38_2)=1.7856 v(gp_2_38_3)=2.0976 v(gp_2_38_4)=2.1084 v(gp_2_38_5)=2.1384 v(gp_2_38_6)=2.0268 v(gp_2_38_7)=2.106 v(gp_2_38_8)=2.1036 v(gp_2_38_9)=2.0172 v(gp_2_38_10)=1.5372 v(gp_2_38_11)=1.8168 v(gp_2_38_12)=1.854 v(gp_2_38_13)=2.154 v(gp_2_38_14)=2.004 v(gp_2_38_15)=1.9464 v(gp_2_38_b)=1.9776 v(gp_2_39_0)=1.7004 v(gp_2_39_1)=2.118 v(gp_2_39_2)=1.9032 v(gp_2_39_3)=1.7304 v(gp_2_39_4)=1.7748 v(gp_2_39_5)=2.1456 v(gp_2_39_6)=1.8228 v(gp_2_39_7)=1.5612 v(gp_2_39_8)=1.5468 v(gp_2_39_9)=1.9344 v(gp_2_39_10)=1.8456 v(gp_2_39_11)=2.0928 v(gp_2_39_12)=1.5732 v(gp_2_39_13)=1.7364 v(gp_2_39_14)=1.9644 v(gp_2_39_15)=1.476 v(gp_2_39_b)=1.512 v(gp_2_40_0)=1.8324 v(gp_2_40_1)=1.6308 v(gp_2_40_2)=1.5168 v(gp_2_40_3)=1.6284 v(gp_2_40_4)=1.8948 v(gp_2_40_5)=1.8192 v(gp_2_40_6)=1.4964 v(gp_2_40_7)=1.4928 v(gp_2_40_8)=2.052 v(gp_2_40_9)=1.9032 v(gp_2_40_10)=1.5648 v(gp_2_40_11)=2.0604 v(gp_2_40_12)=1.4556 v(gp_2_40_13)=1.7052 v(gp_2_40_14)=2.0508 v(gp_2_40_15)=1.9512 v(gp_2_40_b)=1.644 v(gp_2_41_0)=2.082 v(gp_2_41_1)=1.8708 v(gp_2_41_2)=2.0628 v(gp_2_41_3)=2.0832 v(gp_2_41_4)=1.746 v(gp_2_41_5)=1.926 v(gp_2_41_6)=1.8324 v(gp_2_41_7)=2.1204 v(gp_2_41_8)=2.0148 v(gp_2_41_9)=1.962 v(gp_2_41_10)=2.0256 v(gp_2_41_11)=2.1588 v(gp_2_41_12)=1.6248 v(gp_2_41_13)=1.5852 v(gp_2_41_14)=1.9776 v(gp_2_41_15)=1.9944 v(gp_2_41_b)=1.8108 v(gp_2_42_0)=1.7904 v(gp_2_42_1)=1.7304 v(gp_2_42_2)=2.076 v(gp_2_42_3)=2.0136 v(gp_2_42_4)=1.8612 v(gp_2_42_5)=1.4688 v(gp_2_42_6)=2.0532 v(gp_2_42_7)=1.77 v(gp_2_42_8)=1.5768 v(gp_2_42_9)=1.656 v(gp_2_42_10)=1.938 v(gp_2_42_11)=1.4436 v(gp_2_42_12)=1.5264 v(gp_2_42_13)=1.6584 v(gp_2_42_14)=2.0784 v(gp_2_42_15)=1.9776 v(gp_2_42_b)=2.1384 v(gp_2_43_0)=1.8312 v(gp_2_43_1)=1.8516 v(gp_2_43_2)=1.8372 v(gp_2_43_3)=1.818 v(gp_2_43_4)=1.83 v(gp_2_43_5)=2.0292 v(gp_2_43_6)=2.1264 v(gp_2_43_7)=1.734 v(gp_2_43_8)=1.8936 v(gp_2_43_9)=1.662 v(gp_2_43_10)=1.6572 v(gp_2_43_11)=1.8048 v(gp_2_43_12)=1.8624 v(gp_2_43_13)=1.836 v(gp_2_43_14)=2.1432 v(gp_2_43_15)=1.5576 v(gp_2_43_b)=1.8984 v(gp_2_44_0)=2.1564 v(gp_2_44_1)=1.9704 v(gp_2_44_2)=1.848 v(gp_2_44_3)=1.7052 v(gp_2_44_4)=1.7292 v(gp_2_44_5)=2.1144 v(gp_2_44_6)=2.0844 v(gp_2_44_7)=1.9224 v(gp_2_44_8)=2.0868 v(gp_2_44_9)=2.106 v(gp_2_44_10)=2.0496 v(gp_2_44_11)=1.716 v(gp_2_44_12)=1.7748 v(gp_2_44_13)=2.0136 v(gp_2_44_14)=1.7088 v(gp_2_44_15)=1.98 v(gp_2_44_b)=1.7868 v(gp_2_45_0)=1.6824 v(gp_2_45_1)=1.7688 v(gp_2_45_2)=1.524 v(gp_2_45_3)=1.6956 v(gp_2_45_4)=1.7388 v(gp_2_45_5)=1.4532 v(gp_2_45_6)=1.5636 v(gp_2_45_7)=1.6272 v(gp_2_45_8)=2.058 v(gp_2_45_9)=1.8648 v(gp_2_45_10)=1.6464 v(gp_2_45_11)=2.1588 v(gp_2_45_12)=1.626 v(gp_2_45_13)=1.8096 v(gp_2_45_14)=1.9728 v(gp_2_45_15)=1.938 v(gp_2_45_b)=1.752 v(gp_2_46_0)=1.9992 v(gp_2_46_1)=1.7892 v(gp_2_46_2)=1.9548 v(gp_2_46_3)=1.794 v(gp_2_46_4)=2.1396 v(gp_2_46_5)=1.956 v(gp_2_46_6)=1.506 v(gp_2_46_7)=1.5336 v(gp_2_46_8)=2.136 v(gp_2_46_9)=1.6056 v(gp_2_46_10)=1.4592 v(gp_2_46_11)=1.6224 v(gp_2_46_12)=1.7856 v(gp_2_46_13)=2.1252 v(gp_2_46_14)=1.7268 v(gp_2_46_15)=1.9608 v(gp_2_46_b)=2.0412 v(gp_2_47_0)=1.5036 v(gp_2_47_1)=1.8804 v(gp_2_47_2)=2.1564 v(gp_2_47_3)=1.836 v(gp_2_47_4)=1.8252 v(gp_2_47_5)=1.6896 v(gp_2_47_6)=2.1216 v(gp_2_47_7)=2.1384 v(gp_2_47_8)=1.5144 v(gp_2_47_9)=1.8384 v(gp_2_47_10)=1.7424 v(gp_2_47_11)=1.9236 v(gp_2_47_12)=1.5252 v(gp_2_47_13)=1.6308 v(gp_2_47_14)=1.6404 v(gp_2_47_15)=1.7856 v(gp_2_47_b)=2.0112 v(gp_3_0_0)=2.058 v(gp_3_0_1)=2.0064 v(gp_3_0_2)=1.9272 v(gp_3_0_3)=1.5024 v(gp_3_0_4)=1.7208 v(gp_3_0_5)=1.9212 v(gp_3_0_6)=1.6524 v(gp_3_0_7)=1.806 v(gp_3_0_8)=2.0916 v(gp_3_0_9)=1.524 v(gp_3_0_10)=2.0544 v(gp_3_0_11)=1.5156 v(gp_3_0_12)=1.7184 v(gp_3_0_13)=2.0916 v(gp_3_0_14)=1.5852 v(gp_3_0_15)=1.8144 v(gp_3_0_b)=1.74 v(gp_3_1_0)=2.0796 v(gp_3_1_1)=2.154 v(gp_3_1_2)=1.6476 v(gp_3_1_3)=1.794 v(gp_3_1_4)=2.0844 v(gp_3_1_5)=1.8324 v(gp_3_1_6)=1.5948 v(gp_3_1_7)=1.9872 v(gp_3_1_8)=1.6824 v(gp_3_1_9)=1.7904 v(gp_3_1_10)=1.446 v(gp_3_1_11)=2.1516 v(gp_3_1_12)=1.9128 v(gp_3_1_13)=2.106 v(gp_3_1_14)=2.1372 v(gp_3_1_15)=1.6332 v(gp_3_1_b)=1.8288 v(gp_3_2_0)=1.7568 v(gp_3_2_1)=1.9872 v(gp_3_2_2)=2.046 v(gp_3_2_3)=1.6044 v(gp_3_2_4)=1.638 v(gp_3_2_5)=1.9488 v(gp_3_2_6)=1.7364 v(gp_3_2_7)=1.5336 v(gp_3_2_8)=1.5804 v(gp_3_2_9)=1.8444 v(gp_3_2_10)=1.8708 v(gp_3_2_11)=2.1312 v(gp_3_2_12)=1.824 v(gp_3_2_13)=1.878 v(gp_3_2_14)=1.5468 v(gp_3_2_15)=1.7376 v(gp_3_2_b)=1.6416 v(gp_3_3_0)=1.9404 v(gp_3_3_1)=1.632 v(gp_3_3_2)=1.5948 v(gp_3_3_3)=1.7052 v(gp_3_3_4)=1.7784 v(gp_3_3_5)=1.6836 v(gp_3_3_6)=1.8756 v(gp_3_3_7)=1.5708 v(gp_3_3_8)=2.0736 v(gp_3_3_9)=1.9404 v(gp_3_3_10)=1.8252 v(gp_3_3_11)=1.482 v(gp_3_3_12)=1.6752 v(gp_3_3_13)=1.9368 v(gp_3_3_14)=1.9044 v(gp_3_3_15)=2.0244 v(gp_3_3_b)=2.082 v(gp_3_4_0)=1.6668 v(gp_3_4_1)=1.7952 v(gp_3_4_2)=1.6776 v(gp_3_4_3)=1.5324 v(gp_3_4_4)=1.5408 v(gp_3_4_5)=1.6248 v(gp_3_4_6)=1.5036 v(gp_3_4_7)=1.8276 v(gp_3_4_8)=1.9464 v(gp_3_4_9)=1.8456 v(gp_3_4_10)=1.9332 v(gp_3_4_11)=1.6032 v(gp_3_4_12)=1.584 v(gp_3_4_13)=1.8492 v(gp_3_4_14)=2.0772 v(gp_3_4_15)=1.7436 v(gp_3_4_b)=1.4436 v(gp_3_5_0)=1.4544 v(gp_3_5_1)=1.6596 v(gp_3_5_2)=1.8828 v(gp_3_5_3)=1.5012 v(gp_3_5_4)=1.602 v(gp_3_5_5)=1.9296 v(gp_3_5_6)=2.1492 v(gp_3_5_7)=1.686 v(gp_3_5_8)=1.8732 v(gp_3_5_9)=1.8132 v(gp_3_5_10)=1.4568 v(gp_3_5_11)=1.6776 v(gp_3_5_12)=1.5408 v(gp_3_5_13)=1.62 v(gp_3_5_14)=1.9944 v(gp_3_5_15)=1.9308 v(gp_3_5_b)=1.47 v(gp_3_6_0)=1.4952 v(gp_3_6_1)=1.962 v(gp_3_6_2)=1.5144 v(gp_3_6_3)=1.668 v(gp_3_6_4)=1.6344 v(gp_3_6_5)=1.476 v(gp_3_6_6)=1.4628 v(gp_3_6_7)=1.5396 v(gp_3_6_8)=1.728 v(gp_3_6_9)=2.112 v(gp_3_6_10)=1.8996 v(gp_3_6_11)=1.614 v(gp_3_6_12)=1.9296 v(gp_3_6_13)=1.6368 v(gp_3_6_14)=1.8108 v(gp_3_6_15)=1.6716 v(gp_3_6_b)=2.1228 v(gp_3_7_0)=1.6932 v(gp_3_7_1)=2.0184 v(gp_3_7_2)=1.902 v(gp_3_7_3)=2.0472 v(gp_3_7_4)=1.8768 v(gp_3_7_5)=2.0664 v(gp_3_7_6)=1.7316 v(gp_3_7_7)=1.9284 v(gp_3_7_8)=1.8864 v(gp_3_7_9)=1.8204 v(gp_3_7_10)=1.8468 v(gp_3_7_11)=1.8252 v(gp_3_7_12)=1.7232 v(gp_3_7_13)=2.0868 v(gp_3_7_14)=1.896 v(gp_3_7_15)=1.8348 v(gp_3_7_b)=1.4784 v(gp_3_8_0)=1.806 v(gp_3_8_1)=1.566 v(gp_3_8_2)=1.5948 v(gp_3_8_3)=1.7532 v(gp_3_8_4)=1.8336 v(gp_3_8_5)=1.62 v(gp_3_8_6)=1.6356 v(gp_3_8_7)=1.8216 v(gp_3_8_8)=1.7808 v(gp_3_8_9)=1.7304 v(gp_3_8_10)=1.5144 v(gp_3_8_11)=1.7088 v(gp_3_8_12)=1.9116 v(gp_3_8_13)=1.8324 v(gp_3_8_14)=1.8324 v(gp_3_8_15)=2.0472 v(gp_3_8_b)=1.9608 v(gp_3_9_0)=1.9332 v(gp_3_9_1)=1.4616 v(gp_3_9_2)=1.662 v(gp_3_9_3)=1.9308 v(gp_3_9_4)=1.5516 v(gp_3_9_5)=2.0976 v(gp_3_9_6)=1.542 v(gp_3_9_7)=2.0724 v(gp_3_9_8)=1.596 v(gp_3_9_9)=2.046 v(gp_3_9_10)=2.0508 v(gp_3_9_11)=1.6812 v(gp_3_9_12)=2.0796 v(gp_3_9_13)=1.5552 v(gp_3_9_14)=2.0508 v(gp_3_9_15)=1.7148 v(gp_3_9_b)=1.7568 v(gp_3_10_0)=1.5252 v(gp_3_10_1)=1.8732 v(gp_3_10_2)=1.6344 v(gp_3_10_3)=1.92 v(gp_3_10_4)=2.016 v(gp_3_10_5)=1.8744 v(gp_3_10_6)=1.446 v(gp_3_10_7)=2.1252 v(gp_3_10_8)=2.1024 v(gp_3_10_9)=1.9032 v(gp_3_10_10)=1.7136 v(gp_3_10_11)=1.8444 v(gp_3_10_12)=2.076 v(gp_3_10_13)=1.7712 v(gp_3_10_14)=2.0016 v(gp_3_10_15)=1.8708 v(gp_3_10_b)=1.7436 v(gp_3_11_0)=2.112 v(gp_3_11_1)=1.734 v(gp_3_11_2)=1.8756 v(gp_3_11_3)=1.4784 v(gp_3_11_4)=1.7784 v(gp_3_11_5)=1.4664 v(gp_3_11_6)=1.9464 v(gp_3_11_7)=1.44 v(gp_3_11_8)=1.47 v(gp_3_11_9)=1.5204 v(gp_3_11_10)=1.5408 v(gp_3_11_11)=1.806 v(gp_3_11_12)=1.6968 v(gp_3_11_13)=1.6356 v(gp_3_11_14)=2.148 v(gp_3_11_15)=2.094 v(gp_3_11_b)=1.9116 v(gp_3_12_0)=2.0172 v(gp_3_12_1)=2.0304 v(gp_3_12_2)=1.6164 v(gp_3_12_3)=2.022 v(gp_3_12_4)=1.6128 v(gp_3_12_5)=1.8444 v(gp_3_12_6)=1.698 v(gp_3_12_7)=1.554 v(gp_3_12_8)=1.9992 v(gp_3_12_9)=2.1 v(gp_3_12_10)=1.6656 v(gp_3_12_11)=2.0736 v(gp_3_12_12)=1.6896 v(gp_3_12_13)=1.914 v(gp_3_12_14)=2.1564 v(gp_3_12_15)=1.9956 v(gp_3_12_b)=1.4796 v(gp_3_13_0)=1.7532 v(gp_3_13_1)=1.7112 v(gp_3_13_2)=1.6512 v(gp_3_13_3)=2.028 v(gp_3_13_4)=1.758 v(gp_3_13_5)=1.944 v(gp_3_13_6)=1.8972 v(gp_3_13_7)=1.8132 v(gp_3_13_8)=1.4808 v(gp_3_13_9)=1.9248 v(gp_3_13_10)=2.082 v(gp_3_13_11)=1.5636 v(gp_3_13_12)=1.9032 v(gp_3_13_13)=1.7904 v(gp_3_13_14)=1.686 v(gp_3_13_15)=1.9512 v(gp_3_13_b)=2.142 v(gp_3_14_0)=1.4556 v(gp_3_14_1)=2.0856 v(gp_3_14_2)=1.716 v(gp_3_14_3)=2.04 v(gp_3_14_4)=1.566 v(gp_3_14_5)=1.956 v(gp_3_14_6)=1.512 v(gp_3_14_7)=1.6812 v(gp_3_14_8)=2.1384 v(gp_3_14_9)=1.9128 v(gp_3_14_10)=2.0052 v(gp_3_14_11)=1.7724 v(gp_3_14_12)=1.7796 v(gp_3_14_13)=1.7952 v(gp_3_14_14)=1.9968 v(gp_3_14_15)=1.9608 v(gp_3_14_b)=1.5792 v(gp_3_15_0)=1.7568 v(gp_3_15_1)=1.83 v(gp_3_15_2)=1.8516 v(gp_3_15_3)=2.1072 v(gp_3_15_4)=2.0448 v(gp_3_15_5)=1.548 v(gp_3_15_6)=1.7112 v(gp_3_15_7)=1.518 v(gp_3_15_8)=1.4592 v(gp_3_15_9)=1.494 v(gp_3_15_10)=1.572 v(gp_3_15_11)=1.992 v(gp_3_15_12)=1.92 v(gp_3_15_13)=2.0148 v(gp_3_15_14)=1.6476 v(gp_3_15_15)=1.5516 v(gp_3_15_b)=2.1396 v(gp_3_16_0)=2.0352 v(gp_3_16_1)=2.1216 v(gp_3_16_2)=1.4532 v(gp_3_16_3)=1.7256 v(gp_3_16_4)=1.896 v(gp_3_16_5)=1.9704 v(gp_3_16_6)=2.0976 v(gp_3_16_7)=1.8276 v(gp_3_16_8)=1.7208 v(gp_3_16_9)=1.4436 v(gp_3_16_10)=2.0184 v(gp_3_16_11)=2.1468 v(gp_3_16_12)=2.0928 v(gp_3_16_13)=1.9164 v(gp_3_16_14)=1.686 v(gp_3_16_15)=1.6116 v(gp_3_16_b)=1.998 v(gp_3_17_0)=2.1132 v(gp_3_17_1)=2.1312 v(gp_3_17_2)=1.566 v(gp_3_17_3)=1.8612 v(gp_3_17_4)=1.8096 v(gp_3_17_5)=1.7472 v(gp_3_17_6)=2.0124 v(gp_3_17_7)=2.1132 v(gp_3_17_8)=1.962 v(gp_3_17_9)=1.944 v(gp_3_17_10)=1.9368 v(gp_3_17_11)=1.9104 v(gp_3_17_12)=1.8264 v(gp_3_17_13)=1.6188 v(gp_3_17_14)=2.0016 v(gp_3_17_15)=1.5252 v(gp_3_17_b)=1.9032 v(gp_3_18_0)=1.7184 v(gp_3_18_1)=1.8432 v(gp_3_18_2)=1.902 v(gp_3_18_3)=1.7844 v(gp_3_18_4)=2.1444 v(gp_3_18_5)=1.6128 v(gp_3_18_6)=1.4484 v(gp_3_18_7)=2.1276 v(gp_3_18_8)=1.6644 v(gp_3_18_9)=1.6404 v(gp_3_18_10)=1.7388 v(gp_3_18_11)=1.8684 v(gp_3_18_12)=2.1504 v(gp_3_18_13)=1.95 v(gp_3_18_14)=1.6692 v(gp_3_18_15)=1.8252 v(gp_3_18_b)=1.7628 v(gp_3_19_0)=1.8012 v(gp_3_19_1)=1.7412 v(gp_3_19_2)=1.5612 v(gp_3_19_3)=1.7244 v(gp_3_19_4)=1.7196 v(gp_3_19_5)=1.584 v(gp_3_19_6)=2.028 v(gp_3_19_7)=1.6992 v(gp_3_19_8)=1.5492 v(gp_3_19_9)=1.848 v(gp_3_19_10)=2.0484 v(gp_3_19_11)=2.0016 v(gp_3_19_12)=1.8876 v(gp_3_19_13)=1.9668 v(gp_3_19_14)=1.6824 v(gp_3_19_15)=1.5432 v(gp_3_19_b)=1.6236 v(gp_3_20_0)=1.692 v(gp_3_20_1)=1.6404 v(gp_3_20_2)=1.7772 v(gp_3_20_3)=1.5468 v(gp_3_20_4)=1.5336 v(gp_3_20_5)=1.6224 v(gp_3_20_6)=1.5816 v(gp_3_20_7)=2.0172 v(gp_3_20_8)=1.8276 v(gp_3_20_9)=1.5828 v(gp_3_20_10)=1.7496 v(gp_3_20_11)=2.0676 v(gp_3_20_12)=1.8564 v(gp_3_20_13)=1.8384 v(gp_3_20_14)=1.722 v(gp_3_20_15)=1.5816 v(gp_3_20_b)=1.89 v(gp_3_21_0)=1.4952 v(gp_3_21_1)=2.0064 v(gp_3_21_2)=1.482 v(gp_3_21_3)=1.9776 v(gp_3_21_4)=1.716 v(gp_3_21_5)=1.9308 v(gp_3_21_6)=1.866 v(gp_3_21_7)=1.5336 v(gp_3_21_8)=1.8276 v(gp_3_21_9)=1.494 v(gp_3_21_10)=1.614 v(gp_3_21_11)=1.7148 v(gp_3_21_12)=1.6452 v(gp_3_21_13)=1.9164 v(gp_3_21_14)=2.1504 v(gp_3_21_15)=1.6968 v(gp_3_21_b)=2.0436 v(gp_3_22_0)=1.602 v(gp_3_22_1)=1.9512 v(gp_3_22_2)=1.6908 v(gp_3_22_3)=1.8252 v(gp_3_22_4)=1.5036 v(gp_3_22_5)=2.0352 v(gp_3_22_6)=1.59 v(gp_3_22_7)=1.7736 v(gp_3_22_8)=1.6488 v(gp_3_22_9)=2.0232 v(gp_3_22_10)=1.8672 v(gp_3_22_11)=1.8828 v(gp_3_22_12)=1.9836 v(gp_3_22_13)=1.6236 v(gp_3_22_14)=1.482 v(gp_3_22_15)=2.0364 v(gp_3_22_b)=1.6668 v(gp_3_23_0)=2.0244 v(gp_3_23_1)=2.1288 v(gp_3_23_2)=1.8936 v(gp_3_23_3)=1.5144 v(gp_3_23_4)=2.0544 v(gp_3_23_5)=1.896 v(gp_3_23_6)=1.6176 v(gp_3_23_7)=1.59 v(gp_3_23_8)=1.806 v(gp_3_23_9)=1.5276 v(gp_3_23_10)=2.0928 v(gp_3_23_11)=1.95 v(gp_3_23_12)=2.0304 v(gp_3_23_13)=1.716 v(gp_3_23_14)=2.1048 v(gp_3_23_15)=1.536 v(gp_3_23_b)=1.956 v(gp_3_24_0)=1.6236 v(gp_3_24_1)=1.4424 v(gp_3_24_2)=1.5276 v(gp_3_24_3)=1.5852 v(gp_3_24_4)=1.9896 v(gp_3_24_5)=1.7124 v(gp_3_24_6)=1.7868 v(gp_3_24_7)=1.8816 v(gp_3_24_8)=1.6332 v(gp_3_24_9)=1.8996 v(gp_3_24_10)=1.9236 v(gp_3_24_11)=2.1036 v(gp_3_24_12)=1.8024 v(gp_3_24_13)=2.0556 v(gp_3_24_14)=2.1372 v(gp_3_24_15)=1.9932 v(gp_3_24_b)=1.7436 v(gp_3_25_0)=1.6356 v(gp_3_25_1)=1.5108 v(gp_3_25_2)=2.0388 v(gp_3_25_3)=1.5336 v(gp_3_25_4)=1.8432 v(gp_3_25_5)=1.7664 v(gp_3_25_6)=1.4724 v(gp_3_25_7)=1.5948 v(gp_3_25_8)=2.0328 v(gp_3_25_9)=1.8276 v(gp_3_25_10)=2.106 v(gp_3_25_11)=2.094 v(gp_3_25_12)=1.5072 v(gp_3_25_13)=1.9284 v(gp_3_25_14)=1.4712 v(gp_3_25_15)=1.7448 v(gp_3_25_b)=1.758 v(gp_3_26_0)=2.1288 v(gp_3_26_1)=1.8684 v(gp_3_26_2)=1.5768 v(gp_3_26_3)=1.8072 v(gp_3_26_4)=1.8156 v(gp_3_26_5)=1.5816 v(gp_3_26_6)=1.6992 v(gp_3_26_7)=2.0712 v(gp_3_26_8)=2.1468 v(gp_3_26_9)=1.9992 v(gp_3_26_10)=1.4868 v(gp_3_26_11)=2.0928 v(gp_3_26_12)=1.77 v(gp_3_26_13)=2.04 v(gp_3_26_14)=1.5672 v(gp_3_26_15)=1.5468 v(gp_3_26_b)=2.0928 v(gp_3_27_0)=1.6452 v(gp_3_27_1)=1.4712 v(gp_3_27_2)=1.8012 v(gp_3_27_3)=2.1528 v(gp_3_27_4)=2.0412 v(gp_3_27_5)=1.7256 v(gp_3_27_6)=2.1552 v(gp_3_27_7)=2.0136 v(gp_3_27_8)=2.046 v(gp_3_27_9)=1.9056 v(gp_3_27_10)=1.7244 v(gp_3_27_11)=2.0916 v(gp_3_27_12)=1.7784 v(gp_3_27_13)=2.1132 v(gp_3_27_14)=1.8372 v(gp_3_27_15)=2.0952 v(gp_3_27_b)=1.7832 v(gp_3_28_0)=1.7472 v(gp_3_28_1)=1.8636 v(gp_3_28_2)=1.668 v(gp_3_28_3)=1.548 v(gp_3_28_4)=1.8648 v(gp_3_28_5)=2.0532 v(gp_3_28_6)=1.6404 v(gp_3_28_7)=2.0628 v(gp_3_28_8)=2.0064 v(gp_3_28_9)=1.998 v(gp_3_28_10)=1.7388 v(gp_3_28_11)=2.1588 v(gp_3_28_12)=2.01 v(gp_3_28_13)=1.854 v(gp_3_28_14)=1.5216 v(gp_3_28_15)=1.8528 v(gp_3_28_b)=1.4508 v(gp_3_29_0)=2.0892 v(gp_3_29_1)=1.6824 v(gp_3_29_2)=1.7052 v(gp_3_29_3)=1.8372 v(gp_3_29_4)=1.8984 v(gp_3_29_5)=1.86 v(gp_3_29_6)=1.7892 v(gp_3_29_7)=1.8972 v(gp_3_29_8)=2.0496 v(gp_3_29_9)=1.7616 v(gp_3_29_10)=1.8 v(gp_3_29_11)=2.0232 v(gp_3_29_12)=1.4424 v(gp_3_29_13)=1.5552 v(gp_3_29_14)=1.674 v(gp_3_29_15)=1.5936 v(gp_3_29_b)=2.0856 v(gp_3_30_0)=1.5468 v(gp_3_30_1)=1.518 v(gp_3_30_2)=1.668 v(gp_3_30_3)=1.806 v(gp_3_30_4)=2.0316 v(gp_3_30_5)=2.1564 v(gp_3_30_6)=2.0532 v(gp_3_30_7)=1.878 v(gp_3_30_8)=1.4676 v(gp_3_30_9)=1.4856 v(gp_3_30_10)=1.8936 v(gp_3_30_11)=2.0304 v(gp_3_30_12)=1.6308 v(gp_3_30_13)=2.1384 v(gp_3_30_14)=1.836 v(gp_3_30_15)=1.8528 v(gp_3_30_b)=1.8852 v(gp_3_31_0)=1.494 v(gp_3_31_1)=1.5624 v(gp_3_31_2)=2.1144 v(gp_3_31_3)=1.632 v(gp_3_31_4)=1.5 v(gp_3_31_5)=1.6428 v(gp_3_31_6)=1.9632 v(gp_3_31_7)=1.6296 v(gp_3_31_8)=1.5912 v(gp_3_31_9)=1.6392 v(gp_3_31_10)=1.7856 v(gp_3_31_11)=1.9716 v(gp_3_31_12)=1.6572 v(gp_3_31_13)=2.0688 v(gp_3_31_14)=2.1432 v(gp_3_31_15)=2.0316 v(gp_3_31_b)=1.494 v(gp_3_32_0)=1.6668 v(gp_3_32_1)=2.106 v(gp_3_32_2)=2.0592 v(gp_3_32_3)=1.536 v(gp_3_32_4)=1.758 v(gp_3_32_5)=1.7016 v(gp_3_32_6)=1.9776 v(gp_3_32_7)=1.4604 v(gp_3_32_8)=1.6668 v(gp_3_32_9)=1.98 v(gp_3_32_10)=2.0784 v(gp_3_32_11)=1.4688 v(gp_3_32_12)=1.8636 v(gp_3_32_13)=1.9176 v(gp_3_32_14)=2.0688 v(gp_3_32_15)=1.746 v(gp_3_32_b)=2.1408 v(gp_3_33_0)=1.5816 v(gp_3_33_1)=1.5228 v(gp_3_33_2)=1.5336 v(gp_3_33_3)=1.8624 v(gp_3_33_4)=1.5276 v(gp_3_33_5)=1.632 v(gp_3_33_6)=1.5816 v(gp_3_33_7)=1.4796 v(gp_3_33_8)=2.1324 v(gp_3_33_9)=1.6812 v(gp_3_33_10)=2.1336 v(gp_3_33_11)=1.9608 v(gp_3_33_12)=1.5984 v(gp_3_33_13)=2.112 v(gp_3_33_14)=1.4472 v(gp_3_33_15)=2.1468 v(gp_3_33_b)=1.4628 v(gp_3_34_0)=1.6224 v(gp_3_34_1)=1.8372 v(gp_3_34_2)=1.4472 v(gp_3_34_3)=1.9908 v(gp_3_34_4)=1.5012 v(gp_3_34_5)=2.028 v(gp_3_34_6)=1.4652 v(gp_3_34_7)=1.8204 v(gp_3_34_8)=1.5912 v(gp_3_34_9)=1.6476 v(gp_3_34_10)=1.7928 v(gp_3_34_11)=1.7076 v(gp_3_34_12)=1.722 v(gp_3_34_13)=1.9104 v(gp_3_34_14)=1.5804 v(gp_3_34_15)=1.5708 v(gp_3_34_b)=1.9332 v(gp_3_35_0)=1.6536 v(gp_3_35_1)=2.112 v(gp_3_35_2)=1.7472 v(gp_3_35_3)=1.7808 v(gp_3_35_4)=1.4568 v(gp_3_35_5)=1.4544 v(gp_3_35_6)=1.5156 v(gp_3_35_7)=1.89 v(gp_3_35_8)=1.9188 v(gp_3_35_9)=2.1252 v(gp_3_35_10)=1.7508 v(gp_3_35_11)=1.95 v(gp_3_35_12)=1.6872 v(gp_3_35_13)=1.4928 v(gp_3_35_14)=1.7424 v(gp_3_35_15)=1.9452 v(gp_3_35_b)=2.0196 v(gp_3_36_0)=2.1252 v(gp_3_36_1)=2.0388 v(gp_3_36_2)=1.8456 v(gp_3_36_3)=1.836 v(gp_3_36_4)=1.8012 v(gp_3_36_5)=1.7844 v(gp_3_36_6)=1.9296 v(gp_3_36_7)=1.854 v(gp_3_36_8)=2.0568 v(gp_3_36_9)=1.764 v(gp_3_36_10)=1.7796 v(gp_3_36_11)=2.0388 v(gp_3_36_12)=1.926 v(gp_3_36_13)=1.818 v(gp_3_36_14)=1.8456 v(gp_3_36_15)=2.0196 v(gp_3_36_b)=1.8768 v(gp_3_37_0)=1.626 v(gp_3_37_1)=1.6632 v(gp_3_37_2)=1.8756 v(gp_3_37_3)=1.4736 v(gp_3_37_4)=1.77 v(gp_3_37_5)=2.082 v(gp_3_37_6)=1.6068 v(gp_3_37_7)=1.7592 v(gp_3_37_8)=1.944 v(gp_3_37_9)=2.106 v(gp_3_37_10)=1.9416 v(gp_3_37_11)=1.89 v(gp_3_37_12)=1.716 v(gp_3_37_13)=1.7544 v(gp_3_37_14)=1.902 v(gp_3_37_15)=1.6968 v(gp_3_37_b)=2.0052 v(gp_3_38_0)=1.446 v(gp_3_38_1)=1.9812 v(gp_3_38_2)=1.974 v(gp_3_38_3)=1.6608 v(gp_3_38_4)=1.4508 v(gp_3_38_5)=1.6836 v(gp_3_38_6)=1.8648 v(gp_3_38_7)=2.0064 v(gp_3_38_8)=2.0664 v(gp_3_38_9)=1.59 v(gp_3_38_10)=1.4988 v(gp_3_38_11)=1.5264 v(gp_3_38_12)=2.1516 v(gp_3_38_13)=1.9044 v(gp_3_38_14)=1.5324 v(gp_3_38_15)=1.9368 v(gp_3_38_b)=2.1312 v(gp_3_39_0)=1.8768 v(gp_3_39_1)=1.608 v(gp_3_39_2)=2.1324 v(gp_3_39_3)=1.944 v(gp_3_39_4)=1.572 v(gp_3_39_5)=1.992 v(gp_3_39_6)=1.8036 v(gp_3_39_7)=1.8528 v(gp_3_39_8)=1.7028 v(gp_3_39_9)=1.6512 v(gp_3_39_10)=1.7424 v(gp_3_39_11)=1.8192 v(gp_3_39_12)=1.7724 v(gp_3_39_13)=2.064 v(gp_3_39_14)=1.494 v(gp_3_39_15)=1.5828 v(gp_3_39_b)=2.1156 v(gp_3_40_0)=1.878 v(gp_3_40_1)=1.8852 v(gp_3_40_2)=1.8936 v(gp_3_40_3)=1.6152 v(gp_3_40_4)=1.7244 v(gp_3_40_5)=1.5912 v(gp_3_40_6)=1.5492 v(gp_3_40_7)=2.1528 v(gp_3_40_8)=1.9752 v(gp_3_40_9)=2.0724 v(gp_3_40_10)=1.4412 v(gp_3_40_11)=1.9476 v(gp_3_40_12)=1.6608 v(gp_3_40_13)=1.7988 v(gp_3_40_14)=1.926 v(gp_3_40_15)=1.4628 v(gp_3_40_b)=1.7064 v(gp_3_41_0)=1.8384 v(gp_3_41_1)=2.07 v(gp_3_41_2)=1.8096 v(gp_3_41_3)=1.6692 v(gp_3_41_4)=1.8744 v(gp_3_41_5)=1.86 v(gp_3_41_6)=1.65 v(gp_3_41_7)=1.8348 v(gp_3_41_8)=1.6392 v(gp_3_41_9)=1.4484 v(gp_3_41_10)=1.6632 v(gp_3_41_11)=1.5024 v(gp_3_41_12)=1.794 v(gp_3_41_13)=1.8012 v(gp_3_41_14)=2.0664 v(gp_3_41_15)=1.9788 v(gp_3_41_b)=1.98 v(gp_3_42_0)=2.1528 v(gp_3_42_1)=1.6308 v(gp_3_42_2)=1.7088 v(gp_3_42_3)=1.6056 v(gp_3_42_4)=1.5132 v(gp_3_42_5)=1.8108 v(gp_3_42_6)=1.8084 v(gp_3_42_7)=1.5336 v(gp_3_42_8)=2.1048 v(gp_3_42_9)=2.1444 v(gp_3_42_10)=1.4892 v(gp_3_42_11)=1.4424 v(gp_3_42_12)=1.4844 v(gp_3_42_13)=1.9668 v(gp_3_42_14)=2.0544 v(gp_3_42_15)=1.488 v(gp_3_42_b)=1.446 v(gp_3_43_0)=1.8276 v(gp_3_43_1)=1.68 v(gp_3_43_2)=1.4532 v(gp_3_43_3)=1.446 v(gp_3_43_4)=1.5924 v(gp_3_43_5)=1.584 v(gp_3_43_6)=1.6524 v(gp_3_43_7)=1.836 v(gp_3_43_8)=1.6212 v(gp_3_43_9)=1.608 v(gp_3_43_10)=1.5912 v(gp_3_43_11)=2.0784 v(gp_3_43_12)=1.6116 v(gp_3_43_13)=1.8396 v(gp_3_43_14)=1.7664 v(gp_3_43_15)=1.6788 v(gp_3_43_b)=1.7328 v(gp_3_44_0)=1.452 v(gp_3_44_1)=1.5732 v(gp_3_44_2)=1.9008 v(gp_3_44_3)=1.9884 v(gp_3_44_4)=1.5972 v(gp_3_44_5)=1.5672 v(gp_3_44_6)=2.0916 v(gp_3_44_7)=1.5108 v(gp_3_44_8)=2.0124 v(gp_3_44_9)=2.0724 v(gp_3_44_10)=1.5456 v(gp_3_44_11)=2.04 v(gp_3_44_12)=1.548 v(gp_3_44_13)=1.4712 v(gp_3_44_14)=1.6464 v(gp_3_44_15)=1.6884 v(gp_3_44_b)=1.8648 v(gp_3_45_0)=1.7592 v(gp_3_45_1)=2.0112 v(gp_3_45_2)=1.9188 v(gp_3_45_3)=1.5264 v(gp_3_45_4)=1.5852 v(gp_3_45_5)=1.9776 v(gp_3_45_6)=1.524 v(gp_3_45_7)=2.1264 v(gp_3_45_8)=2.0244 v(gp_3_45_9)=1.5984 v(gp_3_45_10)=1.6464 v(gp_3_45_11)=1.6212 v(gp_3_45_12)=1.7448 v(gp_3_45_13)=1.6188 v(gp_3_45_14)=1.4628 v(gp_3_45_15)=1.6212 v(gp_3_45_b)=1.5804 v(gp_3_46_0)=1.692 v(gp_3_46_1)=1.7676 v(gp_3_46_2)=2.07 v(gp_3_46_3)=1.9152 v(gp_3_46_4)=1.8828 v(gp_3_46_5)=2.0628 v(gp_3_46_6)=1.7184 v(gp_3_46_7)=1.7472 v(gp_3_46_8)=1.6164 v(gp_3_46_9)=2.0376 v(gp_3_46_10)=2.0712 v(gp_3_46_11)=2.0952 v(gp_3_46_12)=1.8756 v(gp_3_46_13)=1.5216 v(gp_3_46_14)=1.4916 v(gp_3_46_15)=2.0148 v(gp_3_46_b)=2.0772 v(gp_3_47_0)=1.8228 v(gp_3_47_1)=2.1024 v(gp_3_47_2)=2.1096 v(gp_3_47_3)=1.9836 v(gp_3_47_4)=1.7064 v(gp_3_47_5)=1.7688 v(gp_3_47_6)=1.6932 v(gp_3_47_7)=1.7256 v(gp_3_47_8)=1.7796 v(gp_3_47_9)=1.452 v(gp_3_47_10)=1.5312 v(gp_3_47_11)=1.5612 v(gp_3_47_12)=1.848 v(gp_3_47_13)=2.0676 v(gp_3_47_14)=1.9524 v(gp_3_47_15)=1.548 v(gp_3_47_b)=1.77 v(gp_o_0_0)=1.8912 v(gp_o_0_1)=1.5372 v(gp_o_0_2)=1.4976 v(gp_o_0_3)=1.8804 v(gp_o_0_4)=1.6092 v(gp_o_0_5)=1.9044 v(gp_o_0_6)=1.5636 v(gp_o_0_7)=2.0568 v(gp_o_0_8)=1.6632 v(gp_o_0_9)=1.7484 v(gp_o_0_10)=1.836 v(gp_o_0_11)=2.0784 v(gp_o_0_12)=2.1 v(gp_o_0_13)=2.0484 v(gp_o_0_14)=1.9332 v(gp_o_0_15)=1.4904 v(gp_o_0_16)=1.5744 v(gp_o_0_17)=1.8252 v(gp_o_0_18)=2.1492 v(gp_o_0_19)=1.9632 v(gp_o_0_20)=1.578 v(gp_o_0_21)=1.6968 v(gp_o_0_22)=2.1324 v(gp_o_0_23)=1.806 v(gp_o_0_24)=2.0664 v(gp_o_0_25)=2.058 v(gp_o_0_26)=2.0028 v(gp_o_0_27)=1.8912 v(gp_o_0_28)=1.92 v(gp_o_0_29)=1.686 v(gp_o_0_30)=1.5264 v(gp_o_0_31)=2.1228 v(gp_o_0_32)=1.464 v(gp_o_0_33)=1.6356 v(gp_o_0_34)=1.8816 v(gp_o_0_35)=2.1348 v(gp_o_0_36)=1.5912 v(gp_o_0_37)=1.6176 v(gp_o_0_38)=2.0508 v(gp_o_0_39)=1.6752 v(gp_o_0_40)=1.7304 v(gp_o_0_41)=1.6992 v(gp_o_0_42)=1.476 v(gp_o_0_43)=2.118 v(gp_o_0_44)=1.9428 v(gp_o_0_45)=1.4448 v(gp_o_0_46)=1.5096 v(gp_o_0_47)=1.5372 v(gp_o_0_b)=1.7052 v(gp_o_1_0)=2.0808 v(gp_o_1_1)=1.542 v(gp_o_1_2)=1.6044 v(gp_o_1_3)=1.6644 v(gp_o_1_4)=1.8072 v(gp_o_1_5)=2.0892 v(gp_o_1_6)=1.8288 v(gp_o_1_7)=2.0904 v(gp_o_1_8)=1.83 v(gp_o_1_9)=1.7508 v(gp_o_1_10)=2.0676 v(gp_o_1_11)=1.8588 v(gp_o_1_12)=1.782 v(gp_o_1_13)=1.8084 v(gp_o_1_14)=1.6956 v(gp_o_1_15)=1.752 v(gp_o_1_16)=1.4928 v(gp_o_1_17)=1.5876 v(gp_o_1_18)=1.9896 v(gp_o_1_19)=1.536 v(gp_o_1_20)=1.59 v(gp_o_1_21)=1.5576 v(gp_o_1_22)=1.7016 v(gp_o_1_23)=1.476 v(gp_o_1_24)=1.6992 v(gp_o_1_25)=1.8792 v(gp_o_1_26)=1.9284 v(gp_o_1_27)=2.064 v(gp_o_1_28)=1.5024 v(gp_o_1_29)=1.9032 v(gp_o_1_30)=1.5816 v(gp_o_1_31)=1.686 v(gp_o_1_32)=1.854 v(gp_o_1_33)=2.0436 v(gp_o_1_34)=1.9224 v(gp_o_1_35)=2.1492 v(gp_o_1_36)=1.4532 v(gp_o_1_37)=1.668 v(gp_o_1_38)=1.7856 v(gp_o_1_39)=1.4664 v(gp_o_1_40)=1.4772 v(gp_o_1_41)=1.704 v(gp_o_1_42)=1.842 v(gp_o_1_43)=1.5372 v(gp_o_1_44)=1.4892 v(gp_o_1_45)=1.6692 v(gp_o_1_46)=1.974 v(gp_o_1_47)=1.848 v(gp_o_1_b)=2.1576
.control
  tran 0.10200000000000001 18.0 uic
  wrdata deep_trace.txt v(y_0) v(y_1)
  wrdata deep_weights.txt v(gp_1_0_0) v(gp_1_0_1) v(gp_1_1_0) v(gp_1_1_1) v(gp_1_2_0) v(gp_1_2_1) v(gp_1_3_0) v(gp_1_3_1) v(gp_1_4_0) v(gp_1_4_1) v(gp_1_5_0) v(gp_1_5_1) v(gp_1_6_0) v(gp_1_6_1) v(gp_1_7_0) v(gp_1_7_1) v(gp_1_8_0) v(gp_1_8_1) v(gp_1_9_0) v(gp_1_9_1) v(gp_1_10_0) v(gp_1_10_1) v(gp_1_11_0) v(gp_1_11_1) v(gp_1_12_0) v(gp_1_12_1) v(gp_1_13_0) v(gp_1_13_1) v(gp_1_14_0) v(gp_1_14_1) v(gp_1_15_0) v(gp_1_15_1) v(gp_1_16_0) v(gp_1_16_1) v(gp_1_17_0) v(gp_1_17_1) v(gp_1_18_0) v(gp_1_18_1) v(gp_1_19_0) v(gp_1_19_1) v(gp_1_20_0) v(gp_1_20_1) v(gp_1_21_0) v(gp_1_21_1) v(gp_1_22_0) v(gp_1_22_1) v(gp_1_23_0) v(gp_1_23_1) v(gp_1_24_0) v(gp_1_24_1) v(gp_1_25_0) v(gp_1_25_1) v(gp_1_26_0) v(gp_1_26_1) v(gp_1_27_0) v(gp_1_27_1) v(gp_1_28_0) v(gp_1_28_1) v(gp_1_29_0) v(gp_1_29_1) v(gp_1_30_0) v(gp_1_30_1) v(gp_1_31_0) v(gp_1_31_1) v(gp_1_32_0) v(gp_1_32_1) v(gp_1_33_0) v(gp_1_33_1) v(gp_1_34_0) v(gp_1_34_1) v(gp_1_35_0) v(gp_1_35_1) v(gp_1_36_0) v(gp_1_36_1) v(gp_1_37_0) v(gp_1_37_1) v(gp_1_38_0) v(gp_1_38_1) v(gp_1_39_0) v(gp_1_39_1) v(gp_1_40_0) v(gp_1_40_1) v(gp_1_41_0) v(gp_1_41_1) v(gp_1_42_0) v(gp_1_42_1) v(gp_1_43_0) v(gp_1_43_1) v(gp_1_44_0) v(gp_1_44_1) v(gp_1_45_0) v(gp_1_45_1) v(gp_1_46_0) v(gp_1_46_1) v(gp_1_47_0) v(gp_1_47_1) v(gp_2_0_0) v(gp_2_0_1) v(gp_2_0_2) v(gp_2_0_3) v(gp_2_0_4) v(gp_2_0_5) v(gp_2_0_6) v(gp_2_0_7) v(gp_2_0_8) v(gp_2_0_9) v(gp_2_0_10) v(gp_2_0_11) v(gp_2_0_12) v(gp_2_0_13) v(gp_2_0_14) v(gp_2_0_15) v(gp_2_1_0) v(gp_2_1_1) v(gp_2_1_2) v(gp_2_1_3) v(gp_2_1_4) v(gp_2_1_5) v(gp_2_1_6) v(gp_2_1_7) v(gp_2_1_8) v(gp_2_1_9) v(gp_2_1_10) v(gp_2_1_11) v(gp_2_1_12) v(gp_2_1_13) v(gp_2_1_14) v(gp_2_1_15) v(gp_2_2_0) v(gp_2_2_1) v(gp_2_2_2) v(gp_2_2_3) v(gp_2_2_4) v(gp_2_2_5) v(gp_2_2_6) v(gp_2_2_7) v(gp_2_2_8) v(gp_2_2_9) v(gp_2_2_10) v(gp_2_2_11) v(gp_2_2_12) v(gp_2_2_13) v(gp_2_2_14) v(gp_2_2_15) v(gp_2_3_0) v(gp_2_3_1) v(gp_2_3_2) v(gp_2_3_3) v(gp_2_3_4) v(gp_2_3_5) v(gp_2_3_6) v(gp_2_3_7) v(gp_2_3_8) v(gp_2_3_9) v(gp_2_3_10) v(gp_2_3_11) v(gp_2_3_12) v(gp_2_3_13) v(gp_2_3_14) v(gp_2_3_15) v(gp_2_4_0) v(gp_2_4_1) v(gp_2_4_2) v(gp_2_4_3) v(gp_2_4_4) v(gp_2_4_5) v(gp_2_4_6) v(gp_2_4_7) v(gp_2_4_8) v(gp_2_4_9) v(gp_2_4_10) v(gp_2_4_11) v(gp_2_4_12) v(gp_2_4_13) v(gp_2_4_14) v(gp_2_4_15) v(gp_2_5_0) v(gp_2_5_1) v(gp_2_5_2) v(gp_2_5_3) v(gp_2_5_4) v(gp_2_5_5) v(gp_2_5_6) v(gp_2_5_7) v(gp_2_5_8) v(gp_2_5_9) v(gp_2_5_10) v(gp_2_5_11) v(gp_2_5_12) v(gp_2_5_13) v(gp_2_5_14) v(gp_2_5_15) v(gp_2_6_0) v(gp_2_6_1) v(gp_2_6_2) v(gp_2_6_3) v(gp_2_6_4) v(gp_2_6_5) v(gp_2_6_6) v(gp_2_6_7) v(gp_2_6_8) v(gp_2_6_9) v(gp_2_6_10) v(gp_2_6_11) v(gp_2_6_12) v(gp_2_6_13) v(gp_2_6_14) v(gp_2_6_15) v(gp_2_7_0) v(gp_2_7_1) v(gp_2_7_2) v(gp_2_7_3) v(gp_2_7_4) v(gp_2_7_5) v(gp_2_7_6) v(gp_2_7_7) v(gp_2_7_8) v(gp_2_7_9) v(gp_2_7_10) v(gp_2_7_11) v(gp_2_7_12) v(gp_2_7_13) v(gp_2_7_14) v(gp_2_7_15) v(gp_2_8_0) v(gp_2_8_1) v(gp_2_8_2) v(gp_2_8_3) v(gp_2_8_4) v(gp_2_8_5) v(gp_2_8_6) v(gp_2_8_7) v(gp_2_8_8) v(gp_2_8_9) v(gp_2_8_10) v(gp_2_8_11) v(gp_2_8_12) v(gp_2_8_13) v(gp_2_8_14) v(gp_2_8_15) v(gp_2_9_0) v(gp_2_9_1) v(gp_2_9_2) v(gp_2_9_3) v(gp_2_9_4) v(gp_2_9_5) v(gp_2_9_6) v(gp_2_9_7) v(gp_2_9_8) v(gp_2_9_9) v(gp_2_9_10) v(gp_2_9_11) v(gp_2_9_12) v(gp_2_9_13) v(gp_2_9_14) v(gp_2_9_15) v(gp_2_10_0) v(gp_2_10_1) v(gp_2_10_2) v(gp_2_10_3) v(gp_2_10_4) v(gp_2_10_5) v(gp_2_10_6) v(gp_2_10_7) v(gp_2_10_8) v(gp_2_10_9) v(gp_2_10_10) v(gp_2_10_11) v(gp_2_10_12) v(gp_2_10_13) v(gp_2_10_14) v(gp_2_10_15) v(gp_2_11_0) v(gp_2_11_1) v(gp_2_11_2) v(gp_2_11_3) v(gp_2_11_4) v(gp_2_11_5) v(gp_2_11_6) v(gp_2_11_7) v(gp_2_11_8) v(gp_2_11_9) v(gp_2_11_10) v(gp_2_11_11) v(gp_2_11_12) v(gp_2_11_13) v(gp_2_11_14) v(gp_2_11_15) v(gp_2_12_0) v(gp_2_12_1) v(gp_2_12_2) v(gp_2_12_3) v(gp_2_12_4) v(gp_2_12_5) v(gp_2_12_6) v(gp_2_12_7) v(gp_2_12_8) v(gp_2_12_9) v(gp_2_12_10) v(gp_2_12_11) v(gp_2_12_12) v(gp_2_12_13) v(gp_2_12_14) v(gp_2_12_15) v(gp_2_13_0) v(gp_2_13_1) v(gp_2_13_2) v(gp_2_13_3) v(gp_2_13_4) v(gp_2_13_5) v(gp_2_13_6) v(gp_2_13_7) v(gp_2_13_8) v(gp_2_13_9) v(gp_2_13_10) v(gp_2_13_11) v(gp_2_13_12) v(gp_2_13_13) v(gp_2_13_14) v(gp_2_13_15) v(gp_2_14_0) v(gp_2_14_1) v(gp_2_14_2) v(gp_2_14_3) v(gp_2_14_4) v(gp_2_14_5) v(gp_2_14_6) v(gp_2_14_7) v(gp_2_14_8) v(gp_2_14_9) v(gp_2_14_10) v(gp_2_14_11) v(gp_2_14_12) v(gp_2_14_13) v(gp_2_14_14) v(gp_2_14_15) v(gp_2_15_0) v(gp_2_15_1) v(gp_2_15_2) v(gp_2_15_3) v(gp_2_15_4) v(gp_2_15_5) v(gp_2_15_6) v(gp_2_15_7) v(gp_2_15_8) v(gp_2_15_9) v(gp_2_15_10) v(gp_2_15_11) v(gp_2_15_12) v(gp_2_15_13) v(gp_2_15_14) v(gp_2_15_15) v(gp_2_16_0) v(gp_2_16_1) v(gp_2_16_2) v(gp_2_16_3) v(gp_2_16_4) v(gp_2_16_5) v(gp_2_16_6) v(gp_2_16_7) v(gp_2_16_8) v(gp_2_16_9) v(gp_2_16_10) v(gp_2_16_11) v(gp_2_16_12) v(gp_2_16_13) v(gp_2_16_14) v(gp_2_16_15) v(gp_2_17_0) v(gp_2_17_1) v(gp_2_17_2) v(gp_2_17_3) v(gp_2_17_4) v(gp_2_17_5) v(gp_2_17_6) v(gp_2_17_7) v(gp_2_17_8) v(gp_2_17_9) v(gp_2_17_10) v(gp_2_17_11) v(gp_2_17_12) v(gp_2_17_13) v(gp_2_17_14) v(gp_2_17_15) v(gp_2_18_0) v(gp_2_18_1) v(gp_2_18_2) v(gp_2_18_3) v(gp_2_18_4) v(gp_2_18_5) v(gp_2_18_6) v(gp_2_18_7) v(gp_2_18_8) v(gp_2_18_9) v(gp_2_18_10) v(gp_2_18_11) v(gp_2_18_12) v(gp_2_18_13) v(gp_2_18_14) v(gp_2_18_15) v(gp_2_19_0) v(gp_2_19_1) v(gp_2_19_2) v(gp_2_19_3) v(gp_2_19_4) v(gp_2_19_5) v(gp_2_19_6) v(gp_2_19_7) v(gp_2_19_8) v(gp_2_19_9) v(gp_2_19_10) v(gp_2_19_11) v(gp_2_19_12) v(gp_2_19_13) v(gp_2_19_14) v(gp_2_19_15) v(gp_2_20_0) v(gp_2_20_1) v(gp_2_20_2) v(gp_2_20_3) v(gp_2_20_4) v(gp_2_20_5) v(gp_2_20_6) v(gp_2_20_7) v(gp_2_20_8) v(gp_2_20_9) v(gp_2_20_10) v(gp_2_20_11) v(gp_2_20_12) v(gp_2_20_13) v(gp_2_20_14) v(gp_2_20_15) v(gp_2_21_0) v(gp_2_21_1) v(gp_2_21_2) v(gp_2_21_3) v(gp_2_21_4) v(gp_2_21_5) v(gp_2_21_6) v(gp_2_21_7) v(gp_2_21_8) v(gp_2_21_9) v(gp_2_21_10) v(gp_2_21_11) v(gp_2_21_12) v(gp_2_21_13) v(gp_2_21_14) v(gp_2_21_15) v(gp_2_22_0) v(gp_2_22_1) v(gp_2_22_2) v(gp_2_22_3) v(gp_2_22_4) v(gp_2_22_5) v(gp_2_22_6) v(gp_2_22_7) v(gp_2_22_8) v(gp_2_22_9) v(gp_2_22_10) v(gp_2_22_11) v(gp_2_22_12) v(gp_2_22_13) v(gp_2_22_14) v(gp_2_22_15) v(gp_2_23_0) v(gp_2_23_1) v(gp_2_23_2) v(gp_2_23_3) v(gp_2_23_4) v(gp_2_23_5) v(gp_2_23_6) v(gp_2_23_7) v(gp_2_23_8) v(gp_2_23_9) v(gp_2_23_10) v(gp_2_23_11) v(gp_2_23_12) v(gp_2_23_13) v(gp_2_23_14) v(gp_2_23_15) v(gp_2_24_0) v(gp_2_24_1) v(gp_2_24_2) v(gp_2_24_3) v(gp_2_24_4) v(gp_2_24_5) v(gp_2_24_6) v(gp_2_24_7) v(gp_2_24_8) v(gp_2_24_9) v(gp_2_24_10) v(gp_2_24_11) v(gp_2_24_12) v(gp_2_24_13) v(gp_2_24_14) v(gp_2_24_15) v(gp_2_25_0) v(gp_2_25_1) v(gp_2_25_2) v(gp_2_25_3) v(gp_2_25_4) v(gp_2_25_5) v(gp_2_25_6) v(gp_2_25_7) v(gp_2_25_8) v(gp_2_25_9) v(gp_2_25_10) v(gp_2_25_11) v(gp_2_25_12) v(gp_2_25_13) v(gp_2_25_14) v(gp_2_25_15) v(gp_2_26_0) v(gp_2_26_1) v(gp_2_26_2) v(gp_2_26_3) v(gp_2_26_4) v(gp_2_26_5) v(gp_2_26_6) v(gp_2_26_7) v(gp_2_26_8) v(gp_2_26_9) v(gp_2_26_10) v(gp_2_26_11) v(gp_2_26_12) v(gp_2_26_13) v(gp_2_26_14) v(gp_2_26_15) v(gp_2_27_0) v(gp_2_27_1) v(gp_2_27_2) v(gp_2_27_3) v(gp_2_27_4) v(gp_2_27_5) v(gp_2_27_6) v(gp_2_27_7) v(gp_2_27_8) v(gp_2_27_9) v(gp_2_27_10) v(gp_2_27_11) v(gp_2_27_12) v(gp_2_27_13) v(gp_2_27_14) v(gp_2_27_15) v(gp_2_28_0) v(gp_2_28_1) v(gp_2_28_2) v(gp_2_28_3) v(gp_2_28_4) v(gp_2_28_5) v(gp_2_28_6) v(gp_2_28_7) v(gp_2_28_8) v(gp_2_28_9) v(gp_2_28_10) v(gp_2_28_11) v(gp_2_28_12) v(gp_2_28_13) v(gp_2_28_14) v(gp_2_28_15) v(gp_2_29_0) v(gp_2_29_1) v(gp_2_29_2) v(gp_2_29_3) v(gp_2_29_4) v(gp_2_29_5) v(gp_2_29_6) v(gp_2_29_7) v(gp_2_29_8) v(gp_2_29_9) v(gp_2_29_10) v(gp_2_29_11) v(gp_2_29_12) v(gp_2_29_13) v(gp_2_29_14) v(gp_2_29_15) v(gp_2_30_0) v(gp_2_30_1) v(gp_2_30_2) v(gp_2_30_3) v(gp_2_30_4) v(gp_2_30_5) v(gp_2_30_6) v(gp_2_30_7) v(gp_2_30_8) v(gp_2_30_9) v(gp_2_30_10) v(gp_2_30_11) v(gp_2_30_12) v(gp_2_30_13) v(gp_2_30_14) v(gp_2_30_15) v(gp_2_31_0) v(gp_2_31_1) v(gp_2_31_2) v(gp_2_31_3) v(gp_2_31_4) v(gp_2_31_5) v(gp_2_31_6) v(gp_2_31_7) v(gp_2_31_8) v(gp_2_31_9) v(gp_2_31_10) v(gp_2_31_11) v(gp_2_31_12) v(gp_2_31_13) v(gp_2_31_14) v(gp_2_31_15) v(gp_2_32_0) v(gp_2_32_1) v(gp_2_32_2) v(gp_2_32_3) v(gp_2_32_4) v(gp_2_32_5) v(gp_2_32_6) v(gp_2_32_7) v(gp_2_32_8) v(gp_2_32_9) v(gp_2_32_10) v(gp_2_32_11) v(gp_2_32_12) v(gp_2_32_13) v(gp_2_32_14) v(gp_2_32_15) v(gp_2_33_0) v(gp_2_33_1) v(gp_2_33_2) v(gp_2_33_3) v(gp_2_33_4) v(gp_2_33_5) v(gp_2_33_6) v(gp_2_33_7) v(gp_2_33_8) v(gp_2_33_9) v(gp_2_33_10) v(gp_2_33_11) v(gp_2_33_12) v(gp_2_33_13) v(gp_2_33_14) v(gp_2_33_15) v(gp_2_34_0) v(gp_2_34_1) v(gp_2_34_2) v(gp_2_34_3) v(gp_2_34_4) v(gp_2_34_5) v(gp_2_34_6) v(gp_2_34_7) v(gp_2_34_8) v(gp_2_34_9) v(gp_2_34_10) v(gp_2_34_11) v(gp_2_34_12) v(gp_2_34_13) v(gp_2_34_14) v(gp_2_34_15) v(gp_2_35_0) v(gp_2_35_1) v(gp_2_35_2) v(gp_2_35_3) v(gp_2_35_4) v(gp_2_35_5) v(gp_2_35_6) v(gp_2_35_7) v(gp_2_35_8) v(gp_2_35_9) v(gp_2_35_10) v(gp_2_35_11) v(gp_2_35_12) v(gp_2_35_13) v(gp_2_35_14) v(gp_2_35_15) v(gp_2_36_0) v(gp_2_36_1) v(gp_2_36_2) v(gp_2_36_3) v(gp_2_36_4) v(gp_2_36_5) v(gp_2_36_6) v(gp_2_36_7) v(gp_2_36_8) v(gp_2_36_9) v(gp_2_36_10) v(gp_2_36_11) v(gp_2_36_12) v(gp_2_36_13) v(gp_2_36_14) v(gp_2_36_15) v(gp_2_37_0) v(gp_2_37_1) v(gp_2_37_2) v(gp_2_37_3) v(gp_2_37_4) v(gp_2_37_5) v(gp_2_37_6) v(gp_2_37_7) v(gp_2_37_8) v(gp_2_37_9) v(gp_2_37_10) v(gp_2_37_11) v(gp_2_37_12) v(gp_2_37_13) v(gp_2_37_14) v(gp_2_37_15) v(gp_2_38_0) v(gp_2_38_1) v(gp_2_38_2) v(gp_2_38_3) v(gp_2_38_4) v(gp_2_38_5) v(gp_2_38_6) v(gp_2_38_7) v(gp_2_38_8) v(gp_2_38_9) v(gp_2_38_10) v(gp_2_38_11) v(gp_2_38_12) v(gp_2_38_13) v(gp_2_38_14) v(gp_2_38_15) v(gp_2_39_0) v(gp_2_39_1) v(gp_2_39_2) v(gp_2_39_3) v(gp_2_39_4) v(gp_2_39_5) v(gp_2_39_6) v(gp_2_39_7) v(gp_2_39_8) v(gp_2_39_9) v(gp_2_39_10) v(gp_2_39_11) v(gp_2_39_12) v(gp_2_39_13) v(gp_2_39_14) v(gp_2_39_15) v(gp_2_40_0) v(gp_2_40_1) v(gp_2_40_2) v(gp_2_40_3) v(gp_2_40_4) v(gp_2_40_5) v(gp_2_40_6) v(gp_2_40_7) v(gp_2_40_8) v(gp_2_40_9) v(gp_2_40_10) v(gp_2_40_11) v(gp_2_40_12) v(gp_2_40_13) v(gp_2_40_14) v(gp_2_40_15) v(gp_2_41_0) v(gp_2_41_1) v(gp_2_41_2) v(gp_2_41_3) v(gp_2_41_4) v(gp_2_41_5) v(gp_2_41_6) v(gp_2_41_7) v(gp_2_41_8) v(gp_2_41_9) v(gp_2_41_10) v(gp_2_41_11) v(gp_2_41_12) v(gp_2_41_13) v(gp_2_41_14) v(gp_2_41_15) v(gp_2_42_0) v(gp_2_42_1) v(gp_2_42_2) v(gp_2_42_3) v(gp_2_42_4) v(gp_2_42_5) v(gp_2_42_6) v(gp_2_42_7) v(gp_2_42_8) v(gp_2_42_9) v(gp_2_42_10) v(gp_2_42_11) v(gp_2_42_12) v(gp_2_42_13) v(gp_2_42_14) v(gp_2_42_15) v(gp_2_43_0) v(gp_2_43_1) v(gp_2_43_2) v(gp_2_43_3) v(gp_2_43_4) v(gp_2_43_5) v(gp_2_43_6) v(gp_2_43_7) v(gp_2_43_8) v(gp_2_43_9) v(gp_2_43_10) v(gp_2_43_11) v(gp_2_43_12) v(gp_2_43_13) v(gp_2_43_14) v(gp_2_43_15) v(gp_2_44_0) v(gp_2_44_1) v(gp_2_44_2) v(gp_2_44_3) v(gp_2_44_4) v(gp_2_44_5) v(gp_2_44_6) v(gp_2_44_7) v(gp_2_44_8) v(gp_2_44_9) v(gp_2_44_10) v(gp_2_44_11) v(gp_2_44_12) v(gp_2_44_13) v(gp_2_44_14) v(gp_2_44_15) v(gp_2_45_0) v(gp_2_45_1) v(gp_2_45_2) v(gp_2_45_3) v(gp_2_45_4) v(gp_2_45_5) v(gp_2_45_6) v(gp_2_45_7) v(gp_2_45_8) v(gp_2_45_9) v(gp_2_45_10) v(gp_2_45_11) v(gp_2_45_12) v(gp_2_45_13) v(gp_2_45_14) v(gp_2_45_15) v(gp_2_46_0) v(gp_2_46_1) v(gp_2_46_2) v(gp_2_46_3) v(gp_2_46_4) v(gp_2_46_5) v(gp_2_46_6) v(gp_2_46_7) v(gp_2_46_8) v(gp_2_46_9) v(gp_2_46_10) v(gp_2_46_11) v(gp_2_46_12) v(gp_2_46_13) v(gp_2_46_14) v(gp_2_46_15) v(gp_2_47_0) v(gp_2_47_1) v(gp_2_47_2) v(gp_2_47_3) v(gp_2_47_4) v(gp_2_47_5) v(gp_2_47_6) v(gp_2_47_7) v(gp_2_47_8) v(gp_2_47_9) v(gp_2_47_10) v(gp_2_47_11) v(gp_2_47_12) v(gp_2_47_13) v(gp_2_47_14) v(gp_2_47_15) v(gp_3_0_0) v(gp_3_0_1) v(gp_3_0_2) v(gp_3_0_3) v(gp_3_0_4) v(gp_3_0_5) v(gp_3_0_6) v(gp_3_0_7) v(gp_3_0_8) v(gp_3_0_9) v(gp_3_0_10) v(gp_3_0_11) v(gp_3_0_12) v(gp_3_0_13) v(gp_3_0_14) v(gp_3_0_15) v(gp_3_1_0) v(gp_3_1_1) v(gp_3_1_2) v(gp_3_1_3) v(gp_3_1_4) v(gp_3_1_5) v(gp_3_1_6) v(gp_3_1_7) v(gp_3_1_8) v(gp_3_1_9) v(gp_3_1_10) v(gp_3_1_11) v(gp_3_1_12) v(gp_3_1_13) v(gp_3_1_14) v(gp_3_1_15) v(gp_3_2_0) v(gp_3_2_1) v(gp_3_2_2) v(gp_3_2_3) v(gp_3_2_4) v(gp_3_2_5) v(gp_3_2_6) v(gp_3_2_7) v(gp_3_2_8) v(gp_3_2_9) v(gp_3_2_10) v(gp_3_2_11) v(gp_3_2_12) v(gp_3_2_13) v(gp_3_2_14) v(gp_3_2_15) v(gp_3_3_0) v(gp_3_3_1) v(gp_3_3_2) v(gp_3_3_3) v(gp_3_3_4) v(gp_3_3_5) v(gp_3_3_6) v(gp_3_3_7) v(gp_3_3_8) v(gp_3_3_9) v(gp_3_3_10) v(gp_3_3_11) v(gp_3_3_12) v(gp_3_3_13) v(gp_3_3_14) v(gp_3_3_15) v(gp_3_4_0) v(gp_3_4_1) v(gp_3_4_2) v(gp_3_4_3) v(gp_3_4_4) v(gp_3_4_5) v(gp_3_4_6) v(gp_3_4_7) v(gp_3_4_8) v(gp_3_4_9) v(gp_3_4_10) v(gp_3_4_11) v(gp_3_4_12) v(gp_3_4_13) v(gp_3_4_14) v(gp_3_4_15) v(gp_3_5_0) v(gp_3_5_1) v(gp_3_5_2) v(gp_3_5_3) v(gp_3_5_4) v(gp_3_5_5) v(gp_3_5_6) v(gp_3_5_7) v(gp_3_5_8) v(gp_3_5_9) v(gp_3_5_10) v(gp_3_5_11) v(gp_3_5_12) v(gp_3_5_13) v(gp_3_5_14) v(gp_3_5_15) v(gp_3_6_0) v(gp_3_6_1) v(gp_3_6_2) v(gp_3_6_3) v(gp_3_6_4) v(gp_3_6_5) v(gp_3_6_6) v(gp_3_6_7) v(gp_3_6_8) v(gp_3_6_9) v(gp_3_6_10) v(gp_3_6_11) v(gp_3_6_12) v(gp_3_6_13) v(gp_3_6_14) v(gp_3_6_15) v(gp_3_7_0) v(gp_3_7_1) v(gp_3_7_2) v(gp_3_7_3) v(gp_3_7_4) v(gp_3_7_5) v(gp_3_7_6) v(gp_3_7_7) v(gp_3_7_8) v(gp_3_7_9) v(gp_3_7_10) v(gp_3_7_11) v(gp_3_7_12) v(gp_3_7_13) v(gp_3_7_14) v(gp_3_7_15) v(gp_3_8_0) v(gp_3_8_1) v(gp_3_8_2) v(gp_3_8_3) v(gp_3_8_4) v(gp_3_8_5) v(gp_3_8_6) v(gp_3_8_7) v(gp_3_8_8) v(gp_3_8_9) v(gp_3_8_10) v(gp_3_8_11) v(gp_3_8_12) v(gp_3_8_13) v(gp_3_8_14) v(gp_3_8_15) v(gp_3_9_0) v(gp_3_9_1) v(gp_3_9_2) v(gp_3_9_3) v(gp_3_9_4) v(gp_3_9_5) v(gp_3_9_6) v(gp_3_9_7) v(gp_3_9_8) v(gp_3_9_9) v(gp_3_9_10) v(gp_3_9_11) v(gp_3_9_12) v(gp_3_9_13) v(gp_3_9_14) v(gp_3_9_15) v(gp_3_10_0) v(gp_3_10_1) v(gp_3_10_2) v(gp_3_10_3) v(gp_3_10_4) v(gp_3_10_5) v(gp_3_10_6) v(gp_3_10_7) v(gp_3_10_8) v(gp_3_10_9) v(gp_3_10_10) v(gp_3_10_11) v(gp_3_10_12) v(gp_3_10_13) v(gp_3_10_14) v(gp_3_10_15) v(gp_3_11_0) v(gp_3_11_1) v(gp_3_11_2) v(gp_3_11_3) v(gp_3_11_4) v(gp_3_11_5) v(gp_3_11_6) v(gp_3_11_7) v(gp_3_11_8) v(gp_3_11_9) v(gp_3_11_10) v(gp_3_11_11) v(gp_3_11_12) v(gp_3_11_13) v(gp_3_11_14) v(gp_3_11_15) v(gp_3_12_0) v(gp_3_12_1) v(gp_3_12_2) v(gp_3_12_3) v(gp_3_12_4) v(gp_3_12_5) v(gp_3_12_6) v(gp_3_12_7) v(gp_3_12_8) v(gp_3_12_9) v(gp_3_12_10) v(gp_3_12_11) v(gp_3_12_12) v(gp_3_12_13) v(gp_3_12_14) v(gp_3_12_15) v(gp_3_13_0) v(gp_3_13_1) v(gp_3_13_2) v(gp_3_13_3) v(gp_3_13_4) v(gp_3_13_5) v(gp_3_13_6) v(gp_3_13_7) v(gp_3_13_8) v(gp_3_13_9) v(gp_3_13_10) v(gp_3_13_11) v(gp_3_13_12) v(gp_3_13_13) v(gp_3_13_14) v(gp_3_13_15) v(gp_3_14_0) v(gp_3_14_1) v(gp_3_14_2) v(gp_3_14_3) v(gp_3_14_4) v(gp_3_14_5) v(gp_3_14_6) v(gp_3_14_7) v(gp_3_14_8) v(gp_3_14_9) v(gp_3_14_10) v(gp_3_14_11) v(gp_3_14_12) v(gp_3_14_13) v(gp_3_14_14) v(gp_3_14_15) v(gp_3_15_0) v(gp_3_15_1) v(gp_3_15_2) v(gp_3_15_3) v(gp_3_15_4) v(gp_3_15_5) v(gp_3_15_6) v(gp_3_15_7) v(gp_3_15_8) v(gp_3_15_9) v(gp_3_15_10) v(gp_3_15_11) v(gp_3_15_12) v(gp_3_15_13) v(gp_3_15_14) v(gp_3_15_15) v(gp_3_16_0) v(gp_3_16_1) v(gp_3_16_2) v(gp_3_16_3) v(gp_3_16_4) v(gp_3_16_5) v(gp_3_16_6) v(gp_3_16_7) v(gp_3_16_8) v(gp_3_16_9) v(gp_3_16_10) v(gp_3_16_11) v(gp_3_16_12) v(gp_3_16_13) v(gp_3_16_14) v(gp_3_16_15) v(gp_3_17_0) v(gp_3_17_1) v(gp_3_17_2) v(gp_3_17_3) v(gp_3_17_4) v(gp_3_17_5) v(gp_3_17_6) v(gp_3_17_7) v(gp_3_17_8) v(gp_3_17_9) v(gp_3_17_10) v(gp_3_17_11) v(gp_3_17_12) v(gp_3_17_13) v(gp_3_17_14) v(gp_3_17_15) v(gp_3_18_0) v(gp_3_18_1) v(gp_3_18_2) v(gp_3_18_3) v(gp_3_18_4) v(gp_3_18_5) v(gp_3_18_6) v(gp_3_18_7) v(gp_3_18_8) v(gp_3_18_9) v(gp_3_18_10) v(gp_3_18_11) v(gp_3_18_12) v(gp_3_18_13) v(gp_3_18_14) v(gp_3_18_15) v(gp_3_19_0) v(gp_3_19_1) v(gp_3_19_2) v(gp_3_19_3) v(gp_3_19_4) v(gp_3_19_5) v(gp_3_19_6) v(gp_3_19_7) v(gp_3_19_8) v(gp_3_19_9) v(gp_3_19_10) v(gp_3_19_11) v(gp_3_19_12) v(gp_3_19_13) v(gp_3_19_14) v(gp_3_19_15) v(gp_3_20_0) v(gp_3_20_1) v(gp_3_20_2) v(gp_3_20_3) v(gp_3_20_4) v(gp_3_20_5) v(gp_3_20_6) v(gp_3_20_7) v(gp_3_20_8) v(gp_3_20_9) v(gp_3_20_10) v(gp_3_20_11) v(gp_3_20_12) v(gp_3_20_13) v(gp_3_20_14) v(gp_3_20_15) v(gp_3_21_0) v(gp_3_21_1) v(gp_3_21_2) v(gp_3_21_3) v(gp_3_21_4) v(gp_3_21_5) v(gp_3_21_6) v(gp_3_21_7) v(gp_3_21_8) v(gp_3_21_9) v(gp_3_21_10) v(gp_3_21_11) v(gp_3_21_12) v(gp_3_21_13) v(gp_3_21_14) v(gp_3_21_15) v(gp_3_22_0) v(gp_3_22_1) v(gp_3_22_2) v(gp_3_22_3) v(gp_3_22_4) v(gp_3_22_5) v(gp_3_22_6) v(gp_3_22_7) v(gp_3_22_8) v(gp_3_22_9) v(gp_3_22_10) v(gp_3_22_11) v(gp_3_22_12) v(gp_3_22_13) v(gp_3_22_14) v(gp_3_22_15) v(gp_3_23_0) v(gp_3_23_1) v(gp_3_23_2) v(gp_3_23_3) v(gp_3_23_4) v(gp_3_23_5) v(gp_3_23_6) v(gp_3_23_7) v(gp_3_23_8) v(gp_3_23_9) v(gp_3_23_10) v(gp_3_23_11) v(gp_3_23_12) v(gp_3_23_13) v(gp_3_23_14) v(gp_3_23_15) v(gp_3_24_0) v(gp_3_24_1) v(gp_3_24_2) v(gp_3_24_3) v(gp_3_24_4) v(gp_3_24_5) v(gp_3_24_6) v(gp_3_24_7) v(gp_3_24_8) v(gp_3_24_9) v(gp_3_24_10) v(gp_3_24_11) v(gp_3_24_12) v(gp_3_24_13) v(gp_3_24_14) v(gp_3_24_15) v(gp_3_25_0) v(gp_3_25_1) v(gp_3_25_2) v(gp_3_25_3) v(gp_3_25_4) v(gp_3_25_5) v(gp_3_25_6) v(gp_3_25_7) v(gp_3_25_8) v(gp_3_25_9) v(gp_3_25_10) v(gp_3_25_11) v(gp_3_25_12) v(gp_3_25_13) v(gp_3_25_14) v(gp_3_25_15) v(gp_3_26_0) v(gp_3_26_1) v(gp_3_26_2) v(gp_3_26_3) v(gp_3_26_4) v(gp_3_26_5) v(gp_3_26_6) v(gp_3_26_7) v(gp_3_26_8) v(gp_3_26_9) v(gp_3_26_10) v(gp_3_26_11) v(gp_3_26_12) v(gp_3_26_13) v(gp_3_26_14) v(gp_3_26_15) v(gp_3_27_0) v(gp_3_27_1) v(gp_3_27_2) v(gp_3_27_3) v(gp_3_27_4) v(gp_3_27_5) v(gp_3_27_6) v(gp_3_27_7) v(gp_3_27_8) v(gp_3_27_9) v(gp_3_27_10) v(gp_3_27_11) v(gp_3_27_12) v(gp_3_27_13) v(gp_3_27_14) v(gp_3_27_15) v(gp_3_28_0) v(gp_3_28_1) v(gp_3_28_2) v(gp_3_28_3) v(gp_3_28_4) v(gp_3_28_5) v(gp_3_28_6) v(gp_3_28_7) v(gp_3_28_8) v(gp_3_28_9) v(gp_3_28_10) v(gp_3_28_11) v(gp_3_28_12) v(gp_3_28_13) v(gp_3_28_14) v(gp_3_28_15) v(gp_3_29_0) v(gp_3_29_1) v(gp_3_29_2) v(gp_3_29_3) v(gp_3_29_4) v(gp_3_29_5) v(gp_3_29_6) v(gp_3_29_7) v(gp_3_29_8) v(gp_3_29_9) v(gp_3_29_10) v(gp_3_29_11) v(gp_3_29_12) v(gp_3_29_13) v(gp_3_29_14) v(gp_3_29_15) v(gp_3_30_0) v(gp_3_30_1) v(gp_3_30_2) v(gp_3_30_3) v(gp_3_30_4) v(gp_3_30_5) v(gp_3_30_6) v(gp_3_30_7) v(gp_3_30_8) v(gp_3_30_9) v(gp_3_30_10) v(gp_3_30_11) v(gp_3_30_12) v(gp_3_30_13) v(gp_3_30_14) v(gp_3_30_15) v(gp_3_31_0) v(gp_3_31_1) v(gp_3_31_2) v(gp_3_31_3) v(gp_3_31_4) v(gp_3_31_5) v(gp_3_31_6) v(gp_3_31_7) v(gp_3_31_8) v(gp_3_31_9) v(gp_3_31_10) v(gp_3_31_11) v(gp_3_31_12) v(gp_3_31_13) v(gp_3_31_14) v(gp_3_31_15) v(gp_3_32_0) v(gp_3_32_1) v(gp_3_32_2) v(gp_3_32_3) v(gp_3_32_4) v(gp_3_32_5) v(gp_3_32_6) v(gp_3_32_7) v(gp_3_32_8) v(gp_3_32_9) v(gp_3_32_10) v(gp_3_32_11) v(gp_3_32_12) v(gp_3_32_13) v(gp_3_32_14) v(gp_3_32_15) v(gp_3_33_0) v(gp_3_33_1) v(gp_3_33_2) v(gp_3_33_3) v(gp_3_33_4) v(gp_3_33_5) v(gp_3_33_6) v(gp_3_33_7) v(gp_3_33_8) v(gp_3_33_9) v(gp_3_33_10) v(gp_3_33_11) v(gp_3_33_12) v(gp_3_33_13) v(gp_3_33_14) v(gp_3_33_15) v(gp_3_34_0) v(gp_3_34_1) v(gp_3_34_2) v(gp_3_34_3) v(gp_3_34_4) v(gp_3_34_5) v(gp_3_34_6) v(gp_3_34_7) v(gp_3_34_8) v(gp_3_34_9) v(gp_3_34_10) v(gp_3_34_11) v(gp_3_34_12) v(gp_3_34_13) v(gp_3_34_14) v(gp_3_34_15) v(gp_3_35_0) v(gp_3_35_1) v(gp_3_35_2) v(gp_3_35_3) v(gp_3_35_4) v(gp_3_35_5) v(gp_3_35_6) v(gp_3_35_7) v(gp_3_35_8) v(gp_3_35_9) v(gp_3_35_10) v(gp_3_35_11) v(gp_3_35_12) v(gp_3_35_13) v(gp_3_35_14) v(gp_3_35_15) v(gp_3_36_0) v(gp_3_36_1) v(gp_3_36_2) v(gp_3_36_3) v(gp_3_36_4) v(gp_3_36_5) v(gp_3_36_6) v(gp_3_36_7) v(gp_3_36_8) v(gp_3_36_9) v(gp_3_36_10) v(gp_3_36_11) v(gp_3_36_12) v(gp_3_36_13) v(gp_3_36_14) v(gp_3_36_15) v(gp_3_37_0) v(gp_3_37_1) v(gp_3_37_2) v(gp_3_37_3) v(gp_3_37_4) v(gp_3_37_5) v(gp_3_37_6) v(gp_3_37_7) v(gp_3_37_8) v(gp_3_37_9) v(gp_3_37_10) v(gp_3_37_11) v(gp_3_37_12) v(gp_3_37_13) v(gp_3_37_14) v(gp_3_37_15) v(gp_3_38_0) v(gp_3_38_1) v(gp_3_38_2) v(gp_3_38_3) v(gp_3_38_4) v(gp_3_38_5) v(gp_3_38_6) v(gp_3_38_7) v(gp_3_38_8) v(gp_3_38_9) v(gp_3_38_10) v(gp_3_38_11) v(gp_3_38_12) v(gp_3_38_13) v(gp_3_38_14) v(gp_3_38_15) v(gp_3_39_0) v(gp_3_39_1) v(gp_3_39_2) v(gp_3_39_3) v(gp_3_39_4) v(gp_3_39_5) v(gp_3_39_6) v(gp_3_39_7) v(gp_3_39_8) v(gp_3_39_9) v(gp_3_39_10) v(gp_3_39_11) v(gp_3_39_12) v(gp_3_39_13) v(gp_3_39_14) v(gp_3_39_15) v(gp_3_40_0) v(gp_3_40_1) v(gp_3_40_2) v(gp_3_40_3) v(gp_3_40_4) v(gp_3_40_5) v(gp_3_40_6) v(gp_3_40_7) v(gp_3_40_8) v(gp_3_40_9) v(gp_3_40_10) v(gp_3_40_11) v(gp_3_40_12) v(gp_3_40_13) v(gp_3_40_14) v(gp_3_40_15) v(gp_3_41_0) v(gp_3_41_1) v(gp_3_41_2) v(gp_3_41_3) v(gp_3_41_4) v(gp_3_41_5) v(gp_3_41_6) v(gp_3_41_7) v(gp_3_41_8) v(gp_3_41_9) v(gp_3_41_10) v(gp_3_41_11) v(gp_3_41_12) v(gp_3_41_13) v(gp_3_41_14) v(gp_3_41_15) v(gp_3_42_0) v(gp_3_42_1) v(gp_3_42_2) v(gp_3_42_3) v(gp_3_42_4) v(gp_3_42_5) v(gp_3_42_6) v(gp_3_42_7) v(gp_3_42_8) v(gp_3_42_9) v(gp_3_42_10) v(gp_3_42_11) v(gp_3_42_12) v(gp_3_42_13) v(gp_3_42_14) v(gp_3_42_15) v(gp_3_43_0) v(gp_3_43_1) v(gp_3_43_2) v(gp_3_43_3) v(gp_3_43_4) v(gp_3_43_5) v(gp_3_43_6) v(gp_3_43_7) v(gp_3_43_8) v(gp_3_43_9) v(gp_3_43_10) v(gp_3_43_11) v(gp_3_43_12) v(gp_3_43_13) v(gp_3_43_14) v(gp_3_43_15) v(gp_3_44_0) v(gp_3_44_1) v(gp_3_44_2) v(gp_3_44_3) v(gp_3_44_4) v(gp_3_44_5) v(gp_3_44_6) v(gp_3_44_7) v(gp_3_44_8) v(gp_3_44_9) v(gp_3_44_10) v(gp_3_44_11) v(gp_3_44_12) v(gp_3_44_13) v(gp_3_44_14) v(gp_3_44_15) v(gp_3_45_0) v(gp_3_45_1) v(gp_3_45_2) v(gp_3_45_3) v(gp_3_45_4) v(gp_3_45_5) v(gp_3_45_6) v(gp_3_45_7) v(gp_3_45_8) v(gp_3_45_9) v(gp_3_45_10) v(gp_3_45_11) v(gp_3_45_12) v(gp_3_45_13) v(gp_3_45_14) v(gp_3_45_15) v(gp_3_46_0) v(gp_3_46_1) v(gp_3_46_2) v(gp_3_46_3) v(gp_3_46_4) v(gp_3_46_5) v(gp_3_46_6) v(gp_3_46_7) v(gp_3_46_8) v(gp_3_46_9) v(gp_3_46_10) v(gp_3_46_11) v(gp_3_46_12) v(gp_3_46_13) v(gp_3_46_14) v(gp_3_46_15) v(gp_3_47_0) v(gp_3_47_1) v(gp_3_47_2) v(gp_3_47_3) v(gp_3_47_4) v(gp_3_47_5) v(gp_3_47_6) v(gp_3_47_7) v(gp_3_47_8) v(gp_3_47_9) v(gp_3_47_10) v(gp_3_47_11) v(gp_3_47_12) v(gp_3_47_13) v(gp_3_47_14) v(gp_3_47_15) v(gp_o_0_0) v(gp_o_0_1) v(gp_o_0_2) v(gp_o_0_3) v(gp_o_0_4) v(gp_o_0_5) v(gp_o_0_6) v(gp_o_0_7) v(gp_o_0_8) v(gp_o_0_9) v(gp_o_0_10) v(gp_o_0_11) v(gp_o_0_12) v(gp_o_0_13) v(gp_o_0_14) v(gp_o_0_15) v(gp_o_0_16) v(gp_o_0_17) v(gp_o_0_18) v(gp_o_0_19) v(gp_o_0_20) v(gp_o_0_21) v(gp_o_0_22) v(gp_o_0_23) v(gp_o_0_24) v(gp_o_0_25) v(gp_o_0_26) v(gp_o_0_27) v(gp_o_0_28) v(gp_o_0_29) v(gp_o_0_30) v(gp_o_0_31) v(gp_o_0_32) v(gp_o_0_33) v(gp_o_0_34) v(gp_o_0_35) v(gp_o_0_36) v(gp_o_0_37) v(gp_o_0_38) v(gp_o_0_39) v(gp_o_0_40) v(gp_o_0_41) v(gp_o_0_42) v(gp_o_0_43) v(gp_o_0_44) v(gp_o_0_45) v(gp_o_0_46) v(gp_o_0_47) v(gp_o_1_0) v(gp_o_1_1) v(gp_o_1_2) v(gp_o_1_3) v(gp_o_1_4) v(gp_o_1_5) v(gp_o_1_6) v(gp_o_1_7) v(gp_o_1_8) v(gp_o_1_9) v(gp_o_1_10) v(gp_o_1_11) v(gp_o_1_12) v(gp_o_1_13) v(gp_o_1_14) v(gp_o_1_15) v(gp_o_1_16) v(gp_o_1_17) v(gp_o_1_18) v(gp_o_1_19) v(gp_o_1_20) v(gp_o_1_21) v(gp_o_1_22) v(gp_o_1_23) v(gp_o_1_24) v(gp_o_1_25) v(gp_o_1_26) v(gp_o_1_27) v(gp_o_1_28) v(gp_o_1_29) v(gp_o_1_30) v(gp_o_1_31) v(gp_o_1_32) v(gp_o_1_33) v(gp_o_1_34) v(gp_o_1_35) v(gp_o_1_36) v(gp_o_1_37) v(gp_o_1_38) v(gp_o_1_39) v(gp_o_1_40) v(gp_o_1_41) v(gp_o_1_42) v(gp_o_1_43) v(gp_o_1_44) v(gp_o_1_45) v(gp_o_1_46) v(gp_o_1_47)
  echo DEEP_OK
.endc
.end
