fully in-spice PC learner
.model NNR NMOS (LEVEL=1 VTO=0.2 KP=120u LAMBDA=0.02 GAMMA=0 PHI=0.7)
.model PNR PMOS (LEVEL=1 VTO=-0.2 KP=40u LAMBDA=0.02 GAMMA=0 PHI=0.7)
.subckt gsyn inp inn wp wn outp outn vdd vbn
Mtail nt vbn 0 0 NNR W=400u L=100u
M5 na wp s5 0 NNR W=200u L=100u
Rd5 s5 nt 12k
M6 nb wn s6 0 NNR W=200u L=100u
Rd6 s6 nt 12k
M1 outp inp s1 0 NNR W=200u L=100u
Rd1 s1 na 12k
M2 outn inn s2 0 NNR W=200u L=100u
Rd2 s2 na 12k
M3 outn inp s3 0 NNR W=200u L=100u
Rd3 s3 nb 12k
M4 outp inn s4 0 NNR W=200u L=100u
Rd4 s4 nb 12k
.ends
.subckt cmld p n vdd
Rcs1 p cmx 300k
Rcs2 n cmx 300k
MLp p cmx vdd vdd PNR W=12000u L=100u
MLn n cmx vdd vdd PNR W=12000u L=100u
.ends
.subckt dneuron up un ap an vdd vbn
M1 an up tn 0 NNR W=200u L=100u
M2 ap un tn 0 NNR W=200u L=100u
Mt tn vbn 0 0 NNR W=200u L=100u
Xcm ap an vdd cmld
.ends
.subckt esub xp xn mp mn ep en vdd vbn
Mt nt vbn 0 0 NNR W=400u L=100u
M1x ep xn nt 0 NNR W=200u L=100u
M2x en xp nt 0 NNR W=200u L=100u
M1m ep mp nt 0 NNR W=200u L=100u
M2m en mn nt 0 NNR W=200u L=100u
RLp vdd ep 50k
RLn vdd en 50k
.ends
.subckt gprod xp xn yp yn wp wn vdd vbn
Mtail nt vbn 0 0 NNR W=400u L=100u
M5 na yp sy5 0 NNR W=200u L=100u
Rg5 sy5 nt 12k
M6 nb yn sy6 0 NNR W=200u L=100u
Rg6 sy6 nt 12k
M1 iop xp sx1 0 NNR W=200u L=100u
Rg1 sx1 na 12k
M2 ion xn sx2 0 NNR W=200u L=100u
Rg2 sx2 na 12k
M3 ion xp sx3 0 NNR W=200u L=100u
Rg3 sx3 nb 12k
M4 iop xn sx4 0 NNR W=200u L=100u
Rg4 sx4 nb 12k
Mlp iop iop vdd vdd PNR W=200u L=100u
Mln ion ion vdd vdd PNR W=200u L=100u
Mpu_wp wp iop vdd vdd PNR W=200u L=100u
MpRn nrn ion vdd vdd PNR W=200u L=100u
MnRn nrn nrn 0 0 NNR W=200u L=100u
Mpd_wp wp nrn 0 0 NNR W=200u L=100u
Mpu_wn wn ion vdd vdd PNR W=200u L=100u
MpRp nrp iop vdd vdd PNR W=200u L=100u
MnRp nrp nrp 0 0 NNR W=200u L=100u
Mpd_wn wn nrp 0 0 NNR W=200u L=100u
.ends
.subckt comp inp inn out vdd vbn
Mt nt vbn 0 0 NNR W=200u L=100u
M1 d1 inp nt 0 NNR W=200u L=100u
M2 out inn nt 0 NNR W=200u L=100u
M3 d1 d1 vdd vdd PNR W=200u L=100u
M4 out d1 vdd vdd PNR W=200u L=100u
.ends
Vdd vdd 0 1.0
Vbsyn vbsyn 0 0.6
Vbneu vbneu 0 0.35
Vgm gm 0 0.6
Vwcm wcm 0 0.5
Vgbl gbl 0 PWL(0.0n 0.85000 139.9n 0.85000 140.0n 0.85000 279.9n 0.85000 280.0n 0.85000 419.9n 0.85000 420.0n 0.85000 559.9n 0.85000 560.0n 0.85000 699.9n 0.85000 700.0n 0.85000 839.9n 0.85000 840.0n 0.85000 979.9n 0.85000 980.0n 0.85000 1119.9n 0.85000 1120.0n 0.85000 1259.9n 0.85000 1260.0n 0.85000 1399.9n 0.85000 1400.0n 0.85000 1539.9n 0.85000 1540.0n 0.85000 1679.9n 0.85000 1680.0n 0.85000 1819.9n 0.85000 1820.0n 0.85000 1959.9n 0.85000 1960.0n 0.85000 2099.9n 0.85000 2100.0n 0.85000 2239.9n 0.85000 2240.0n 0.85000 2379.9n 0.85000 2380.0n 0.85000 2519.9n 0.85000 2520.0n 0.85000 2659.9n 0.85000 2660.0n 0.85000 2799.9n 0.85000 2800.0n 0.85000 2939.9n 0.85000 2940.0n 0.85000 3079.9n 0.85000 3080.0n 0.85000 3219.9n 0.85000 3220.0n 0.85000 3359.9n 0.85000 3360.0n 0.85000 3499.9n 0.85000 3500.0n 0.85000 3639.9n 0.85000 3640.0n 0.85000 3779.9n 0.85000 3780.0n 0.85000 3919.9n 0.85000 3920.0n 0.85000 4059.9n 0.85000 4060.0n 0.85000 4199.9n 0.85000 4200.0n 0.85000 4339.9n 0.85000 4340.0n 0.85000 4479.9n 0.85000 4480.0n 0.85000 4619.9n 0.85000 4620.0n 0.85000 4759.9n 0.85000 4760.0n 0.85000 4899.9n 0.85000 4900.0n 0.85000 5039.9n 0.85000 5040.0n 0.85000 5179.9n 0.85000 5180.0n 0.85000 5319.9n 0.85000 5320.0n 0.85000 5459.9n 0.85000 5460.0n 0.85000 5599.9n 0.85000 5600.0n 0.85000 5739.9n 0.85000 5740.0n 0.85000 5879.9n 0.85000 5880.0n 0.85000 6019.9n 0.85000 6020.0n 0.85000 6159.9n 0.85000 6160.0n 0.85000 6299.9n 0.85000 6300.0n 0.85000 6439.9n 0.85000 6440.0n 0.85000 6579.9n 0.85000 6580.0n 0.85000 6719.9n 0.85000 6720.0n 0.85000 6859.9n 0.85000 6860.0n 0.85000 6999.9n 0.85000 7000.0n 0.85000 7139.9n 0.85000 7140.0n 0.85000 7279.9n 0.85000 7280.0n 0.85000 7419.9n 0.85000 7420.0n 0.85000 7559.9n 0.85000 7560.0n 0.85000 7699.9n 0.85000 7700.0n 0.85000 7839.9n 0.85000 7840.0n 0.85000 7979.9n 0.85000 7980.0n 0.85000 8119.9n 0.85000 8120.0n 0.85000 8259.9n 0.85000 8260.0n 0.85000 8399.9n 0.85000 8400.0n 0.85000 8539.9n 0.85000 8540.0n 0.85000 8679.9n 0.85000 8680.0n 0.85000 8819.9n 0.85000 8820.0n 0.85000 8959.9n 0.85000 8960.0n 0.85000 9099.9n 0.85000 9100.0n 0.85000 9239.9n 0.85000 9240.0n 0.85000 9379.9n 0.85000 9380.0n 0.85000 9519.9n 0.85000 9520.0n 0.85000 9659.9n 0.85000 9660.0n 0.85000 9799.9n 0.85000 9800.0n 0.85000 9939.9n 0.85000 9940.0n 0.85000 10079.9n 0.85000 10080.0n 0.85000 10219.9n 0.85000 10220.0n 0.85000 10359.9n 0.85000 10360.0n 0.85000 10499.9n 0.85000 10500.0n 0.85000 10639.9n 0.85000 10640.0n 0.85000 10779.9n 0.85000 10780.0n 0.85000 10919.9n 0.85000 10920.0n 0.85000 11059.9n 0.85000 11060.0n 0.85000 11199.9n 0.85000 11200.0n 0.85000 11339.9n 0.85000 11340.0n 0.85000 11479.9n 0.85000 11480.0n 0.85000 11619.9n 0.85000 11620.0n 0.85000 11759.9n 0.85000 11760.0n 0.85000 11899.9n 0.85000 11900.0n 0.85000 12039.9n 0.85000 12040.0n 0.85000 12179.9n 0.85000 12180.0n 0.85000 12319.9n 0.85000 12320.0n 0.85000 12459.9n 0.85000 12460.0n 0.85000 12599.9n 0.85000 12600.0n 0.85000 12739.9n 0.85000 12740.0n 0.85000 12879.9n 0.85000 12880.0n 0.85000 13019.9n 0.85000 13020.0n 0.85000 13159.9n 0.85000 13160.0n 0.85000 13299.9n 0.85000 13300.0n 0.85000 13439.9n 0.85000 13440.0n 0.85000 13579.9n 0.85000 13580.0n 0.85000 13719.9n 0.85000 13720.0n 0.85000 13859.9n 0.85000 13860.0n 0.85000 13999.9n 0.85000 14000.0n 0.85000 14139.9n 0.85000 14140.0n 0.85000 14279.9n 0.85000 14280.0n 0.85000 14419.9n 0.85000 14420.0n 0.85000 14559.9n 0.85000 14560.0n 0.85000 14699.9n 0.85000 14700.0n 0.85000 14839.9n 0.85000 14840.0n 0.85000 14979.9n 0.85000 14980.0n 0.85000 15119.9n 0.85000 15120.0n 0.85000 15259.9n 0.85000 15260.0n 0.85000 15399.9n 0.85000 15400.0n 0.85000 15539.9n 0.85000 15540.0n 0.85000 15679.9n 0.85000 15680.0n 0.85000 15819.9n 0.85000 15820.0n 0.85000 15959.9n 0.85000 15960.0n 0.85000 16099.9n 0.85000 16100.0n 0.85000 16239.9n 0.85000 16240.0n 0.85000 16379.9n 0.85000 16380.0n 0.85000 16519.9n 0.85000 16520.0n 0.85000 16659.9n 0.85000 16660.0n 0.85000 16799.9n 0.85000 16800.0n 0.85000 16939.9n 0.85000 16940.0n 0.85000 17079.9n 0.85000 17080.0n 0.85000 17219.9n 0.85000 17220.0n 0.85000 17359.9n 0.85000 17360.0n 0.85000 17499.9n 0.85000 17500.0n 0.85000 17639.9n 0.85000 17640.0n 0.85000 17779.9n 0.85000 17780.0n 0.85000 17919.9n 0.85000 17920.0n 0.85000 18059.9n 0.85000 18060.0n 0.85000 18199.9n 0.85000 18200.0n 0.85000 18339.9n 0.85000 18340.0n 0.85000 18479.9n 0.85000 18480.0n 0.85000 18619.9n 0.85000 18620.0n 0.85000 18759.9n 0.85000 18760.0n 0.85000 18899.9n 0.85000 18900.0n 0.85000 19039.9n 0.85000 19040.0n 0.85000 19179.9n 0.85000 19180.0n 0.85000 19319.9n 0.85000 19320.0n 0.85000 19459.9n 0.85000 19460.0n 0.85000 19599.9n 0.85000 19600.0n 0.85000 19739.9n 0.85000 19740.0n 0.85000 19879.9n 0.85000 19880.0n 0.85000 20019.9n 0.85000 20020.0n 0.85000 20159.9n 0.85000 20160.0n 0.85000 20299.9n 0.85000 20300.0n 0.85000 20439.9n 0.85000 20440.0n 0.85000 20579.9n 0.85000 20580.0n 0.85000 20719.9n 0.85000 20720.0n 0.85000 20859.9n 0.85000 20860.0n 0.85000 20999.9n 0.85000 21000.0n 0.85000 21139.9n 0.85000 21140.0n 0.85000 21279.9n 0.85000 21280.0n 0.85000 21419.9n 0.85000 21420.0n 0.85000 21559.9n 0.85000 21560.0n 0.85000 21699.9n 0.85000 21700.0n 0.85000 21839.9n 0.85000 21840.0n 0.85000 21979.9n 0.85000 21980.0n 0.85000 22119.9n 0.85000 22120.0n 0.85000 22259.9n 0.85000 22260.0n 0.85000 22399.9n 0.85000 22400.0n 0.85000 22539.9n 0.85000 22540.0n 0.85000 22679.9n 0.85000 22680.0n 0.85000 22819.9n 0.85000 22820.0n 0.85000 22959.9n 0.85000 22960.0n 0.85000 23099.9n 0.85000 23100.0n 0.85000 23239.9n 0.85000 23240.0n 0.85000 23379.9n 0.85000 23380.0n 0.85000 23519.9n 0.85000 23520.0n 0.85000 23659.9n 0.85000 23660.0n 0.85000 23799.9n 0.85000 23800.0n 0.85000 23939.9n 0.85000 23940.0n 0.85000 24079.9n 0.85000 24080.0n 0.85000 24219.9n 0.85000 24220.0n 0.85000 24359.9n 0.85000 24360.0n 0.85000 24499.9n 0.85000 24500.0n 0.85000 24639.9n 0.85000 24640.0n 0.85000 24779.9n 0.85000 24780.0n 0.85000 24919.9n 0.85000 24920.0n 0.85000 25059.9n 0.85000 25060.0n 0.85000 25199.9n 0.85000 25200.0n 0.85000 25339.9n 0.85000 25340.0n 0.85000 25479.9n 0.85000 25480.0n 0.85000 25619.9n 0.85000 25620.0n 0.85000 25759.9n 0.85000 25760.0n 0.85000 25899.9n 0.85000 25900.0n 0.85000 26039.9n 0.85000 26040.0n 0.85000 26179.9n 0.85000 26180.0n 0.85000 26319.9n 0.85000 26320.0n 0.85000 26459.9n 0.85000 26460.0n 0.85000 26599.9n 0.85000 26600.0n 0.85000 26739.9n 0.85000 26740.0n 0.85000 26879.9n 0.85000 26880.0n 0.85000 27019.9n 0.85000 27020.0n 0.85000 27159.9n 0.85000 27160.0n 0.85000 27299.9n 0.85000 27300.0n 0.85000 27439.9n 0.85000 27440.0n 0.85000 27579.9n 0.85000 27580.0n 0.85000 27719.9n 0.85000 27720.0n 0.85000 27859.9n 0.85000 27860.0n 0.85000 27999.9n 0.85000 28000.0n 0.85000 28139.9n 0.85000 28140.0n 0.85000 28279.9n 0.85000 28280.0n 0.85000 28419.9n 0.85000 28420.0n 0.85000 28559.9n 0.85000 28560.0n 0.85000 28699.9n 0.85000 28700.0n 0.85000 28839.9n 0.85000 28840.0n 0.85000 28979.9n 0.85000 28980.0n 0.85000 29119.9n 0.85000 29120.0n 0.85000 29259.9n 0.85000 29260.0n 0.85000 29399.9n 0.85000 29400.0n 0.85000 29539.9n 0.85000 29540.0n 0.85000 29679.9n 0.85000 29680.0n 0.85000 29819.9n 0.85000 29820.0n 0.85000 29959.9n 0.85000 29960.0n 0.85000 30099.9n 0.85000 30100.0n 0.85000 30239.9n 0.85000 30240.0n 0.85000 30379.9n 0.85000 30380.0n 0.85000 30519.9n 0.85000 30520.0n 0.85000 30659.9n 0.85000 30660.0n 0.85000 30799.9n 0.85000 30800.0n 0.85000 30939.9n 0.85000 30940.0n 0.85000 31079.9n 0.85000 31080.0n 0.85000 31219.9n 0.85000 31220.0n 0.85000 31359.9n 0.85000 31360.0n 0.85000 31499.9n 0.85000 31500.0n 0.85000 31639.9n 0.85000 31640.0n 0.85000 31779.9n 0.85000 31780.0n 0.85000 31919.9n 0.85000 31920.0n 0.85000 32059.9n 0.85000 32060.0n 0.85000 32199.9n 0.85000 32200.0n 0.85000 32339.9n 0.85000 32340.0n 0.85000 32479.9n 0.85000 32480.0n 0.85000 32619.9n 0.85000 32620.0n 0.85000 32759.9n 0.85000 32760.0n 0.85000 32899.9n 0.85000 32900.0n 0.85000 33039.9n 0.85000 33040.0n 0.85000 33179.9n 0.85000 33180.0n 0.85000 33319.9n 0.85000 33320.0n 0.85000 33459.9n 0.85000 33460.0n 0.85000 33599.9n 0.85000 33600.0n 0.85000 33739.9n 0.85000 33740.0n 0.85000 33879.9n 0.85000 33880.0n 0.85000 34019.9n 0.85000 34020.0n 0.85000 34159.9n 0.85000 34160.0n 0.85000 34299.9n 0.85000 34300.0n 0.85000 34439.9n 0.85000 34440.0n 0.85000 34579.9n 0.85000 34580.0n 0.85000 34719.9n 0.85000 34720.0n 0.85000 34859.9n 0.85000 34860.0n 0.85000 34999.9n 0.85000 35000.0n 0.85000 35139.9n 0.85000 35140.0n 0.85000 35279.9n 0.85000 35280.0n 0.85000 35419.9n 0.85000 35420.0n 0.85000 35559.9n 0.85000 35560.0n 0.85000 35699.9n 0.85000 35700.0n 0.85000 35839.9n 0.85000 35840.0n 0.85000 35979.9n 0.85000 35980.0n 0.85000 36119.9n 0.85000 36120.0n 0.85000 36259.9n 0.85000 36260.0n 0.85000 36399.9n 0.85000 36400.0n 0.85000 36539.9n 0.85000 36540.0n 0.85000 36679.9n 0.85000 36680.0n 0.85000 36819.9n 0.85000 36820.0n 0.85000 36959.9n 0.85000 36960.0n 0.85000 37099.9n 0.85000 37100.0n 0.85000 37239.9n 0.85000 37240.0n 0.85000 37379.9n 0.85000 37380.0n 0.85000 37519.9n 0.85000 37520.0n 0.85000 37659.9n 0.85000 37660.0n 0.85000 37799.9n 0.85000 37800.0n 0.85000 37939.9n 0.85000 37940.0n 0.85000 38079.9n 0.85000 38080.0n 0.85000 38219.9n 0.85000 38220.0n 0.85000 38359.9n 0.85000 38360.0n 0.85000 38499.9n 0.85000 38500.0n 0.85000 38639.9n 0.85000 38640.0n 0.85000 38779.9n 0.85000 38780.0n 0.85000 38919.9n 0.85000 38920.0n 0.85000 39059.9n 0.85000 39060.0n 0.85000 39199.9n 0.85000 39200.0n 0.85000 39339.9n 0.85000 39340.0n 0.85000 39479.9n 0.85000 39480.0n 0.85000 39619.9n 0.85000 39620.0n 0.85000 39759.9n 0.85000 39760.0n 0.85000 39899.9n 0.85000 39900.0n 0.85000 40039.9n 0.85000 40040.0n 0.85000 40179.9n 0.85000 40180.0n 0.85000 40319.9n 0.85000 40320.0n 0.85000 40459.9n 0.85000 40460.0n 0.85000 40599.9n 0.85000 40600.0n 0.85000 40739.9n 0.85000 40740.0n 0.85000 40879.9n 0.85000 40880.0n 0.85000 41019.9n 0.85000 41020.0n 0.85000 41159.9n 0.85000 41160.0n 0.85000 41299.9n 0.85000 41300.0n 0.85000 41439.9n 0.85000 41440.0n 0.85000 41579.9n 0.85000 41580.0n 0.85000 41719.9n 0.85000 41720.0n 0.85000 41859.9n 0.85000 41860.0n 0.85000 41999.9n 0.85000 42000.0n 0.85000 42139.9n 0.85000 42140.0n 0.85000 42279.9n 0.85000 42280.0n 0.85000 42419.9n 0.85000 42420.0n 0.85000 42559.9n 0.85000 42560.0n 0.85000 42699.9n 0.85000 42700.0n 0.85000 42839.9n 0.85000 42840.0n 0.85000 42979.9n 0.85000 42980.0n 0.85000 43119.9n 0.85000 43120.0n 0.85000 43259.9n 0.85000 43260.0n 0.85000 43399.9n 0.85000 43400.0n 0.85000 43539.9n 0.85000 43540.0n 0.85000 43679.9n 0.85000 43680.0n 0.85000 43819.9n 0.85000 43820.0n 0.85000 43959.9n 0.85000 43960.0n 0.85000 44099.9n 0.85000 44100.0n 0.85000 44239.9n 0.85000 44240.0n 0.85000 44379.9n 0.85000 44380.0n 0.85000 44519.9n 0.85000 44520.0n 0.85000 44659.9n 0.85000 44660.0n 0.85000 44799.9n 0.85000 44800.0n 0.85000 44939.9n 0.85000 44940.0n 0.85000 45079.9n 0.85000 45080.0n 0.85000 45219.9n 0.85000 45220.0n 0.85000 45359.9n 0.85000 45360.0n 0.85000 45499.9n 0.85000 45500.0n 0.85000 45639.9n 0.85000 45640.0n 0.85000 45779.9n 0.85000 45780.0n 0.85000 45919.9n 0.85000 45920.0n 0.85000 46059.9n 0.85000 46060.0n 0.85000 46199.9n 0.85000 46200.0n 0.85000 46339.9n 0.85000 46340.0n 0.85000 46479.9n 0.85000 46480.0n 0.85000 46619.9n 0.85000 46620.0n 0.85000 46759.9n 0.85000 46760.0n 0.85000 46899.9n 0.85000 46900.0n 0.85000 47039.9n 0.85000 47040.0n 0.00000 47179.9n 0.00000 47180.0n 0.00000 47319.9n 0.00000 47320.0n 0.00000 47459.9n 0.00000 47460.0n 0.00000 47599.9n 0.00000 47600.0n 0.00000 47739.9n 0.00000 47740.0n 0.00000 47879.9n 0.00000 47880.0n 0.00000 48019.9n 0.00000 48020.0n 0.00000 48159.9n 0.00000 48160.0n 0.00000 48299.9n 0.00000 48300.0n 0.00000 48439.9n 0.00000 48440.0n 0.00000 48579.9n 0.00000 48580.0n 0.00000 48719.9n 0.00000 48720.0n 0.00000 48859.9n 0.00000 48860.0n 0.00000 48999.9n 0.00000 49000.0n 0.00000 49139.9n 0.00000 49140.0n 0.00000 49279.9n 0.00000 49280.0n 0.00000 49419.9n 0.00000 49420.0n 0.00000 49559.9n 0.00000 49560.0n 0.00000 49699.9n 0.00000 49700.0n 0.00000 49839.9n 0.00000 49840.0n 0.00000 49979.9n 0.00000 49980.0n 0.00000 50119.9n 0.00000 50120.0n 0.00000 50259.9n 0.00000 50260.0n 0.00000 50399.9n 0.00000 50400.0n 0.00000 50539.9n 0.00000 50540.0n 0.00000 50679.9n 0.00000 50680.0n 0.00000 50819.9n 0.00000 50820.0n 0.00000 50959.9n 0.00000 50960.0n 0.00000 51099.9n 0.00000 51100.0n 0.00000 51239.9n 0.00000 51240.0n 0.00000 51379.9n 0.00000 51380.0n 0.00000 51519.9n 0.00000 51520.0n 0.00000 51659.9n 0.00000 51660.0n 0.00000 51799.9n 0.00000 51800.0n 0.00000 51939.9n 0.00000 51940.0n 0.00000 52079.9n 0.00000 52080.0n 0.00000 52219.9n 0.00000 52220.0n 0.00000 52359.9n 0.00000 52360.0n 0.00000 52499.9n 0.00000 52500.0n 0.00000)
Vxp0 a_xp0 0 PWL(0.0n 0.21498 139.9n 0.21498 140.0n 0.88832 279.9n 0.88832 280.0n 0.73600 419.9n 0.73600 420.0n 0.96459 559.9n 0.96459 560.0n 0.69969 699.9n 0.69969 700.0n 0.53141 839.9n 0.53141 840.0n -0.31038 979.9n -0.31038 980.0n 0.24079 1119.9n 0.24079 1120.0n 0.31139 1259.9n 0.31139 1260.0n 0.26419 1399.9n 0.26419 1400.0n 0.70685 1539.9n 0.70685 1540.0n -0.04662 1679.9n -0.04662 1680.0n 0.27643 1819.9n 0.27643 1820.0n 0.55006 1959.9n 0.55006 1960.0n 1.07007 2099.9n 1.07007 2100.0n 0.55066 2239.9n 0.55066 2240.0n 0.52079 2379.9n 0.52079 2380.0n 0.17082 2519.9n 0.17082 2520.0n 0.56449 2659.9n 0.56449 2660.0n 0.20119 2799.9n 0.20119 2800.0n 0.27076 2939.9n 0.27076 2940.0n 1.36668 3079.9n 1.36668 3080.0n 0.47556 3219.9n 0.47556 3220.0n 0.35630 3359.9n 0.35630 3360.0n 0.47556 3499.9n 0.47556 3500.0n 0.55006 3639.9n 0.55006 3640.0n 0.20119 3779.9n 0.20119 3780.0n 1.07007 3919.9n 1.07007 3920.0n 0.56449 4059.9n 0.56449 4060.0n 0.53141 4199.9n 0.53141 4200.0n 0.69969 4339.9n 0.69969 4340.0n 0.55066 4479.9n 0.55066 4480.0n 0.70685 4619.9n 0.70685 4620.0n 0.27643 4759.9n 0.27643 4760.0n 0.21498 4899.9n 0.21498 4900.0n -0.04662 5039.9n -0.04662 5040.0n 0.31139 5179.9n 0.31139 5180.0n 1.36668 5319.9n 1.36668 5320.0n 0.35630 5459.9n 0.35630 5460.0n 0.73600 5599.9n 0.73600 5600.0n 0.88832 5739.9n 0.88832 5740.0n 0.27076 5879.9n 0.27076 5880.0n 0.24079 6019.9n 0.24079 6020.0n 0.52079 6159.9n 0.52079 6160.0n -0.31038 6299.9n -0.31038 6300.0n 0.96459 6439.9n 0.96459 6440.0n 0.17082 6579.9n 0.17082 6580.0n 0.26419 6719.9n 0.26419 6720.0n 0.27076 6859.9n 0.27076 6860.0n 0.17082 6999.9n 0.17082 7000.0n -0.04662 7139.9n -0.04662 7140.0n 0.27643 7279.9n 0.27643 7280.0n 0.20119 7419.9n 0.20119 7420.0n 0.35630 7559.9n 0.35630 7560.0n 0.70685 7699.9n 0.70685 7700.0n 0.96459 7839.9n 0.96459 7840.0n 0.21498 7979.9n 0.21498 7980.0n 0.55066 8119.9n 0.55066 8120.0n 0.88832 8259.9n 0.88832 8260.0n 0.69969 8399.9n 0.69969 8400.0n 0.73600 8539.9n 0.73600 8540.0n 0.24079 8679.9n 0.24079 8680.0n 0.56449 8819.9n 0.56449 8820.0n 1.36668 8959.9n 1.36668 8960.0n 0.47556 9099.9n 0.47556 9100.0n -0.31038 9239.9n -0.31038 9240.0n 0.31139 9379.9n 0.31139 9380.0n 0.55006 9519.9n 0.55006 9520.0n 0.52079 9659.9n 0.52079 9660.0n 0.26419 9799.9n 0.26419 9800.0n 1.07007 9939.9n 1.07007 9940.0n 0.53141 10079.9n 0.53141 10080.0n 1.07007 10219.9n 1.07007 10220.0n 1.36668 10359.9n 1.36668 10360.0n 0.55066 10499.9n 0.55066 10500.0n 0.69969 10639.9n 0.69969 10640.0n 0.52079 10779.9n 0.52079 10780.0n -0.04662 10919.9n -0.04662 10920.0n 0.55006 11059.9n 0.55006 11060.0n 0.96459 11199.9n 0.96459 11200.0n 0.73600 11339.9n 0.73600 11340.0n 0.53141 11479.9n 0.53141 11480.0n 0.56449 11619.9n 0.56449 11620.0n 0.27076 11759.9n 0.27076 11760.0n 0.70685 11899.9n 0.70685 11900.0n 0.21498 12039.9n 0.21498 12040.0n 0.27643 12179.9n 0.27643 12180.0n 0.31139 12319.9n 0.31139 12320.0n 0.20119 12459.9n 0.20119 12460.0n 0.35630 12599.9n 0.35630 12600.0n 0.17082 12739.9n 0.17082 12740.0n -0.31038 12879.9n -0.31038 12880.0n 0.47556 13019.9n 0.47556 13020.0n 0.24079 13159.9n 0.24079 13160.0n 0.26419 13299.9n 0.26419 13300.0n 0.88832 13439.9n 0.88832 13440.0n 0.52079 13579.9n 0.52079 13580.0n 0.47556 13719.9n 0.47556 13720.0n 0.69969 13859.9n 0.69969 13860.0n 0.73600 13999.9n 0.73600 14000.0n 0.56449 14139.9n 0.56449 14140.0n -0.04662 14279.9n -0.04662 14280.0n 0.17082 14419.9n 0.17082 14420.0n 0.27643 14559.9n 0.27643 14560.0n 0.70685 14699.9n 0.70685 14700.0n 0.55066 14839.9n 0.55066 14840.0n 1.07007 14979.9n 1.07007 14980.0n 0.26419 15119.9n 0.26419 15120.0n 1.36668 15259.9n 1.36668 15260.0n 0.27076 15399.9n 0.27076 15400.0n 0.20119 15539.9n 0.20119 15540.0n 0.35630 15679.9n 0.35630 15680.0n 0.88832 15819.9n 0.88832 15820.0n 0.53141 15959.9n 0.53141 15960.0n 0.96459 16099.9n 0.96459 16100.0n -0.31038 16239.9n -0.31038 16240.0n 0.31139 16379.9n 0.31139 16380.0n 0.21498 16519.9n 0.21498 16520.0n 0.24079 16659.9n 0.24079 16660.0n 0.55006 16799.9n 0.55006 16800.0n 1.36668 16939.9n 1.36668 16940.0n -0.31038 17079.9n -0.31038 17080.0n 0.53141 17219.9n 0.53141 17220.0n 0.69969 17359.9n 0.69969 17360.0n 0.55066 17499.9n 0.55066 17500.0n 0.52079 17639.9n 0.52079 17640.0n 0.96459 17779.9n 0.96459 17780.0n 0.73600 17919.9n 0.73600 17920.0n 0.20119 18059.9n 0.20119 18060.0n 0.55006 18199.9n 0.55006 18200.0n 0.27643 18339.9n 0.27643 18340.0n 0.26419 18479.9n 0.26419 18480.0n -0.04662 18619.9n -0.04662 18620.0n 0.70685 18759.9n 0.70685 18760.0n 1.07007 18899.9n 1.07007 18900.0n 0.47556 19039.9n 0.47556 19040.0n 0.35630 19179.9n 0.35630 19180.0n 0.17082 19319.9n 0.17082 19320.0n 0.21498 19459.9n 0.21498 19460.0n 0.31139 19599.9n 0.31139 19600.0n 0.27076 19739.9n 0.27076 19740.0n 0.88832 19879.9n 0.88832 19880.0n 0.24079 20019.9n 0.24079 20020.0n 0.56449 20159.9n 0.56449 20160.0n -0.31038 20299.9n -0.31038 20300.0n 0.52079 20439.9n 0.52079 20440.0n 0.55006 20579.9n 0.55006 20580.0n 0.73600 20719.9n 0.73600 20720.0n 0.20119 20859.9n 0.20119 20860.0n 0.53141 20999.9n 0.53141 21000.0n -0.04662 21139.9n -0.04662 21140.0n 0.55066 21279.9n 0.55066 21280.0n 0.70685 21419.9n 0.70685 21420.0n 0.21498 21559.9n 0.21498 21560.0n 0.88832 21699.9n 0.88832 21700.0n 0.26419 21839.9n 0.26419 21840.0n 0.17082 21979.9n 0.17082 21980.0n 0.35630 22119.9n 0.35630 22120.0n 0.47556 22259.9n 0.47556 22260.0n 0.27076 22399.9n 0.27076 22400.0n 0.31139 22539.9n 0.31139 22540.0n 0.56449 22679.9n 0.56449 22680.0n 0.69969 22819.9n 0.69969 22820.0n 1.36668 22959.9n 1.36668 22960.0n 1.07007 23099.9n 1.07007 23100.0n 0.96459 23239.9n 0.96459 23240.0n 0.27643 23379.9n 0.27643 23380.0n 0.24079 23519.9n 0.24079 23520.0n 0.73600 23659.9n 0.73600 23660.0n 0.26419 23799.9n 0.26419 23800.0n 0.24079 23939.9n 0.24079 23940.0n 0.52079 24079.9n 0.52079 24080.0n 0.21498 24219.9n 0.21498 24220.0n 0.53141 24359.9n 0.53141 24360.0n 0.70685 24499.9n 0.70685 24500.0n 0.56449 24639.9n 0.56449 24640.0n 0.55066 24779.9n 0.55066 24780.0n -0.04662 24919.9n -0.04662 24920.0n 0.69969 25059.9n 0.69969 25060.0n 0.17082 25199.9n 0.17082 25200.0n 0.88832 25339.9n 0.88832 25340.0n 1.07007 25479.9n 1.07007 25480.0n 0.96459 25619.9n 0.96459 25620.0n -0.31038 25759.9n -0.31038 25760.0n 0.27076 25899.9n 0.27076 25900.0n 0.35630 26039.9n 0.35630 26040.0n 0.55006 26179.9n 0.55006 26180.0n 0.31139 26319.9n 0.31139 26320.0n 0.27643 26459.9n 0.27643 26460.0n 0.20119 26599.9n 0.20119 26600.0n 0.47556 26739.9n 0.47556 26740.0n 1.36668 26879.9n 1.36668 26880.0n 0.27643 27019.9n 0.27643 27020.0n 1.07007 27159.9n 1.07007 27160.0n 0.70685 27299.9n 0.70685 27300.0n 0.35630 27439.9n 0.35630 27440.0n -0.04662 27579.9n -0.04662 27580.0n -0.31038 27719.9n -0.31038 27720.0n 0.88832 27859.9n 0.88832 27860.0n 0.21498 27999.9n 0.21498 28000.0n 0.17082 28139.9n 0.17082 28140.0n 0.96459 28279.9n 0.96459 28280.0n 1.36668 28419.9n 1.36668 28420.0n 0.31139 28559.9n 0.31139 28560.0n 0.47556 28699.9n 0.47556 28700.0n 0.20119 28839.9n 0.20119 28840.0n 0.27076 28979.9n 0.27076 28980.0n 0.55006 29119.9n 0.55006 29120.0n 0.73600 29259.9n 0.73600 29260.0n 0.55066 29399.9n 0.55066 29400.0n 0.26419 29539.9n 0.26419 29540.0n 0.69969 29679.9n 0.69969 29680.0n 0.24079 29819.9n 0.24079 29820.0n 0.53141 29959.9n 0.53141 29960.0n 0.56449 30099.9n 0.56449 30100.0n 0.52079 30239.9n 0.52079 30240.0n 0.27076 30379.9n 0.27076 30380.0n 0.26419 30519.9n 0.26419 30520.0n 0.35630 30659.9n 0.35630 30660.0n 0.24079 30799.9n 0.24079 30800.0n 1.07007 30939.9n 1.07007 30940.0n 0.52079 31079.9n 0.52079 31080.0n 0.96459 31219.9n 0.96459 31220.0n 0.69969 31359.9n 0.69969 31360.0n 0.20119 31499.9n 0.20119 31500.0n 0.31139 31639.9n 0.31139 31640.0n 0.55066 31779.9n 0.55066 31780.0n -0.31038 31919.9n -0.31038 31920.0n 0.47556 32059.9n 0.47556 32060.0n 0.88832 32199.9n 0.88832 32200.0n 0.70685 32339.9n 0.70685 32340.0n 1.36668 32479.9n 1.36668 32480.0n 0.21498 32619.9n 0.21498 32620.0n 0.27643 32759.9n 0.27643 32760.0n 0.73600 32899.9n 0.73600 32900.0n 0.17082 33039.9n 0.17082 33040.0n 0.55006 33179.9n 0.55006 33180.0n 0.53141 33319.9n 0.53141 33320.0n 0.56449 33459.9n 0.56449 33460.0n -0.04662 33599.9n -0.04662 33600.0n 0.56449 33739.9n 0.56449 33740.0n 0.17082 33879.9n 0.17082 33880.0n 0.70685 34019.9n 0.70685 34020.0n 0.21498 34159.9n 0.21498 34160.0n 0.24079 34299.9n 0.24079 34300.0n 0.52079 34439.9n 0.52079 34440.0n 0.55006 34579.9n 0.55006 34580.0n 0.27643 34719.9n 0.27643 34720.0n 0.55066 34859.9n 0.55066 34860.0n 1.07007 34999.9n 1.07007 35000.0n 0.53141 35139.9n 0.53141 35140.0n 0.20119 35279.9n 0.20119 35280.0n 0.69969 35419.9n 0.69969 35420.0n 0.47556 35559.9n 0.47556 35560.0n 0.88832 35699.9n 0.88832 35700.0n 1.36668 35839.9n 1.36668 35840.0n 0.26419 35979.9n 0.26419 35980.0n 0.27076 36119.9n 0.27076 36120.0n -0.04662 36259.9n -0.04662 36260.0n 0.96459 36399.9n 0.96459 36400.0n 0.35630 36539.9n 0.35630 36540.0n -0.31038 36679.9n -0.31038 36680.0n 0.73600 36819.9n 0.73600 36820.0n 0.31139 36959.9n 0.31139 36960.0n -0.04662 37099.9n -0.04662 37100.0n 0.55006 37239.9n 0.55006 37240.0n 0.20119 37379.9n 0.20119 37380.0n 0.26419 37519.9n 0.26419 37520.0n 0.27643 37659.9n 0.27643 37660.0n 0.88832 37799.9n 0.88832 37800.0n 0.27076 37939.9n 0.27076 37940.0n 0.35630 38079.9n 0.35630 38080.0n 0.52079 38219.9n 0.52079 38220.0n 0.17082 38359.9n 0.17082 38360.0n 0.56449 38499.9n 0.56449 38500.0n 0.73600 38639.9n 0.73600 38640.0n 0.69969 38779.9n 0.69969 38780.0n 1.07007 38919.9n 1.07007 38920.0n 1.36668 39059.9n 1.36668 39060.0n 0.31139 39199.9n 0.31139 39200.0n 0.24079 39339.9n 0.24079 39340.0n -0.31038 39479.9n -0.31038 39480.0n 0.53141 39619.9n 0.53141 39620.0n 0.21498 39759.9n 0.21498 39760.0n 0.70685 39899.9n 0.70685 39900.0n 0.47556 40039.9n 0.47556 40040.0n 0.96459 40179.9n 0.96459 40180.0n 0.55066 40319.9n 0.55066 40320.0n 1.07007 40459.9n 1.07007 40460.0n 0.35630 40599.9n 0.35630 40600.0n -0.04662 40739.9n -0.04662 40740.0n 0.56449 40879.9n 0.56449 40880.0n 0.26419 41019.9n 0.26419 41020.0n 0.31139 41159.9n 0.31139 41160.0n 0.55066 41299.9n 0.55066 41300.0n 0.20119 41439.9n 0.20119 41440.0n 0.70685 41579.9n 0.70685 41580.0n 0.73600 41719.9n 0.73600 41720.0n 0.21498 41859.9n 0.21498 41860.0n 0.69969 41999.9n 0.69969 42000.0n 0.24079 42139.9n 0.24079 42140.0n 0.27643 42279.9n 0.27643 42280.0n 0.53141 42419.9n 0.53141 42420.0n 0.27076 42559.9n 0.27076 42560.0n 0.55006 42699.9n 0.55006 42700.0n 0.47556 42839.9n 0.47556 42840.0n 0.88832 42979.9n 0.88832 42980.0n 0.52079 43119.9n 0.52079 43120.0n 0.96459 43259.9n 0.96459 43260.0n -0.31038 43399.9n -0.31038 43400.0n 1.36668 43539.9n 1.36668 43540.0n 0.17082 43679.9n 0.17082 43680.0n 0.55006 43819.9n 0.55006 43820.0n 0.20119 43959.9n 0.20119 43960.0n 0.55066 44099.9n 0.55066 44100.0n 0.73600 44239.9n 0.73600 44240.0n 0.52079 44379.9n 0.52079 44380.0n 0.27076 44519.9n 0.27076 44520.0n -0.04662 44659.9n -0.04662 44660.0n 0.53141 44799.9n 0.53141 44800.0n 0.96459 44939.9n 0.96459 44940.0n 0.70685 45079.9n 0.70685 45080.0n 0.31139 45219.9n 0.31139 45220.0n 0.21498 45359.9n 0.21498 45360.0n 0.17082 45499.9n 0.17082 45500.0n 0.24079 45639.9n 0.24079 45640.0n 0.27643 45779.9n 0.27643 45780.0n 1.07007 45919.9n 1.07007 45920.0n 0.47556 46059.9n 0.47556 46060.0n -0.31038 46199.9n -0.31038 46200.0n 0.88832 46339.9n 0.88832 46340.0n 0.26419 46479.9n 0.26419 46480.0n 1.36668 46619.9n 1.36668 46620.0n 0.35630 46759.9n 0.35630 46760.0n 0.56449 46899.9n 0.56449 46900.0n 0.69969 47039.9n 0.69969 47040.0n 0.43581 47179.9n 0.43581 47180.0n 0.69502 47319.9n 0.69502 47320.0n 0.48508 47459.9n 0.48508 47460.0n 0.86030 47599.9n 0.86030 47600.0n 0.57742 47739.9n 0.57742 47740.0n 0.79287 47879.9n 0.79287 47880.0n 0.60090 48019.9n 0.60090 48020.0n 0.23371 48159.9n 0.23371 48160.0n 0.12484 48299.9n 0.12484 48300.0n 0.48351 48439.9n 0.48351 48440.0n 0.52272 48579.9n 0.52272 48580.0n 0.10421 48719.9n 0.10421 48720.0n 0.26187 48859.9n 0.26187 48860.0n 0.26993 48999.9n 0.26993 49000.0n 0.61195 49139.9n 0.61195 49140.0n 0.55435 49279.9n 0.55435 49280.0n 0.15028 49419.9n 0.15028 49420.0n 0.68626 49559.9n 0.68626 49560.0n 0.46500 49699.9n 0.46500 49700.0n 0.34619 49839.9n 0.34619 49840.0n 0.10559 49979.9n 0.10559 49980.0n -0.14927 50119.9n -0.14927 50120.0n 1.38855 50259.9n 1.38855 50260.0n 1.21890 50399.9n 1.21890 50400.0n 1.28851 50539.9n 1.28851 50540.0n 1.24585 50679.9n 1.24585 50680.0n -0.15208 50819.9n -0.15208 50820.0n 0.58159 50959.9n 0.58159 50960.0n 0.75662 51099.9n 0.75662 51100.0n -0.49277 51239.9n -0.49277 51240.0n -0.19260 51379.9n -0.19260 51380.0n 1.27962 51519.9n 1.27962 51520.0n 0.44267 51659.9n 0.44267 51660.0n 0.04400 51799.9n 0.04400 51800.0n 1.04710 51939.9n 1.04710 51940.0n 0.19758 52079.9n 0.19758 52080.0n 0.60264 52219.9n 0.60264 52220.0n -0.04029 52359.9n -0.04029 52360.0n 0.36851 52499.9n 0.36851 52500.0n 0.18248)
Vxn0 a_xn0 0 PWL(0.0n 0.78502 139.9n 0.78502 140.0n 0.11168 279.9n 0.11168 280.0n 0.26400 419.9n 0.26400 420.0n 0.03541 559.9n 0.03541 560.0n 0.30031 699.9n 0.30031 700.0n 0.46859 839.9n 0.46859 840.0n 1.31038 979.9n 1.31038 980.0n 0.75921 1119.9n 0.75921 1120.0n 0.68861 1259.9n 0.68861 1260.0n 0.73581 1399.9n 0.73581 1400.0n 0.29315 1539.9n 0.29315 1540.0n 1.04662 1679.9n 1.04662 1680.0n 0.72357 1819.9n 0.72357 1820.0n 0.44994 1959.9n 0.44994 1960.0n -0.07007 2099.9n -0.07007 2100.0n 0.44934 2239.9n 0.44934 2240.0n 0.47921 2379.9n 0.47921 2380.0n 0.82918 2519.9n 0.82918 2520.0n 0.43551 2659.9n 0.43551 2660.0n 0.79881 2799.9n 0.79881 2800.0n 0.72924 2939.9n 0.72924 2940.0n -0.36668 3079.9n -0.36668 3080.0n 0.52444 3219.9n 0.52444 3220.0n 0.64370 3359.9n 0.64370 3360.0n 0.52444 3499.9n 0.52444 3500.0n 0.44994 3639.9n 0.44994 3640.0n 0.79881 3779.9n 0.79881 3780.0n -0.07007 3919.9n -0.07007 3920.0n 0.43551 4059.9n 0.43551 4060.0n 0.46859 4199.9n 0.46859 4200.0n 0.30031 4339.9n 0.30031 4340.0n 0.44934 4479.9n 0.44934 4480.0n 0.29315 4619.9n 0.29315 4620.0n 0.72357 4759.9n 0.72357 4760.0n 0.78502 4899.9n 0.78502 4900.0n 1.04662 5039.9n 1.04662 5040.0n 0.68861 5179.9n 0.68861 5180.0n -0.36668 5319.9n -0.36668 5320.0n 0.64370 5459.9n 0.64370 5460.0n 0.26400 5599.9n 0.26400 5600.0n 0.11168 5739.9n 0.11168 5740.0n 0.72924 5879.9n 0.72924 5880.0n 0.75921 6019.9n 0.75921 6020.0n 0.47921 6159.9n 0.47921 6160.0n 1.31038 6299.9n 1.31038 6300.0n 0.03541 6439.9n 0.03541 6440.0n 0.82918 6579.9n 0.82918 6580.0n 0.73581 6719.9n 0.73581 6720.0n 0.72924 6859.9n 0.72924 6860.0n 0.82918 6999.9n 0.82918 7000.0n 1.04662 7139.9n 1.04662 7140.0n 0.72357 7279.9n 0.72357 7280.0n 0.79881 7419.9n 0.79881 7420.0n 0.64370 7559.9n 0.64370 7560.0n 0.29315 7699.9n 0.29315 7700.0n 0.03541 7839.9n 0.03541 7840.0n 0.78502 7979.9n 0.78502 7980.0n 0.44934 8119.9n 0.44934 8120.0n 0.11168 8259.9n 0.11168 8260.0n 0.30031 8399.9n 0.30031 8400.0n 0.26400 8539.9n 0.26400 8540.0n 0.75921 8679.9n 0.75921 8680.0n 0.43551 8819.9n 0.43551 8820.0n -0.36668 8959.9n -0.36668 8960.0n 0.52444 9099.9n 0.52444 9100.0n 1.31038 9239.9n 1.31038 9240.0n 0.68861 9379.9n 0.68861 9380.0n 0.44994 9519.9n 0.44994 9520.0n 0.47921 9659.9n 0.47921 9660.0n 0.73581 9799.9n 0.73581 9800.0n -0.07007 9939.9n -0.07007 9940.0n 0.46859 10079.9n 0.46859 10080.0n -0.07007 10219.9n -0.07007 10220.0n -0.36668 10359.9n -0.36668 10360.0n 0.44934 10499.9n 0.44934 10500.0n 0.30031 10639.9n 0.30031 10640.0n 0.47921 10779.9n 0.47921 10780.0n 1.04662 10919.9n 1.04662 10920.0n 0.44994 11059.9n 0.44994 11060.0n 0.03541 11199.9n 0.03541 11200.0n 0.26400 11339.9n 0.26400 11340.0n 0.46859 11479.9n 0.46859 11480.0n 0.43551 11619.9n 0.43551 11620.0n 0.72924 11759.9n 0.72924 11760.0n 0.29315 11899.9n 0.29315 11900.0n 0.78502 12039.9n 0.78502 12040.0n 0.72357 12179.9n 0.72357 12180.0n 0.68861 12319.9n 0.68861 12320.0n 0.79881 12459.9n 0.79881 12460.0n 0.64370 12599.9n 0.64370 12600.0n 0.82918 12739.9n 0.82918 12740.0n 1.31038 12879.9n 1.31038 12880.0n 0.52444 13019.9n 0.52444 13020.0n 0.75921 13159.9n 0.75921 13160.0n 0.73581 13299.9n 0.73581 13300.0n 0.11168 13439.9n 0.11168 13440.0n 0.47921 13579.9n 0.47921 13580.0n 0.52444 13719.9n 0.52444 13720.0n 0.30031 13859.9n 0.30031 13860.0n 0.26400 13999.9n 0.26400 14000.0n 0.43551 14139.9n 0.43551 14140.0n 1.04662 14279.9n 1.04662 14280.0n 0.82918 14419.9n 0.82918 14420.0n 0.72357 14559.9n 0.72357 14560.0n 0.29315 14699.9n 0.29315 14700.0n 0.44934 14839.9n 0.44934 14840.0n -0.07007 14979.9n -0.07007 14980.0n 0.73581 15119.9n 0.73581 15120.0n -0.36668 15259.9n -0.36668 15260.0n 0.72924 15399.9n 0.72924 15400.0n 0.79881 15539.9n 0.79881 15540.0n 0.64370 15679.9n 0.64370 15680.0n 0.11168 15819.9n 0.11168 15820.0n 0.46859 15959.9n 0.46859 15960.0n 0.03541 16099.9n 0.03541 16100.0n 1.31038 16239.9n 1.31038 16240.0n 0.68861 16379.9n 0.68861 16380.0n 0.78502 16519.9n 0.78502 16520.0n 0.75921 16659.9n 0.75921 16660.0n 0.44994 16799.9n 0.44994 16800.0n -0.36668 16939.9n -0.36668 16940.0n 1.31038 17079.9n 1.31038 17080.0n 0.46859 17219.9n 0.46859 17220.0n 0.30031 17359.9n 0.30031 17360.0n 0.44934 17499.9n 0.44934 17500.0n 0.47921 17639.9n 0.47921 17640.0n 0.03541 17779.9n 0.03541 17780.0n 0.26400 17919.9n 0.26400 17920.0n 0.79881 18059.9n 0.79881 18060.0n 0.44994 18199.9n 0.44994 18200.0n 0.72357 18339.9n 0.72357 18340.0n 0.73581 18479.9n 0.73581 18480.0n 1.04662 18619.9n 1.04662 18620.0n 0.29315 18759.9n 0.29315 18760.0n -0.07007 18899.9n -0.07007 18900.0n 0.52444 19039.9n 0.52444 19040.0n 0.64370 19179.9n 0.64370 19180.0n 0.82918 19319.9n 0.82918 19320.0n 0.78502 19459.9n 0.78502 19460.0n 0.68861 19599.9n 0.68861 19600.0n 0.72924 19739.9n 0.72924 19740.0n 0.11168 19879.9n 0.11168 19880.0n 0.75921 20019.9n 0.75921 20020.0n 0.43551 20159.9n 0.43551 20160.0n 1.31038 20299.9n 1.31038 20300.0n 0.47921 20439.9n 0.47921 20440.0n 0.44994 20579.9n 0.44994 20580.0n 0.26400 20719.9n 0.26400 20720.0n 0.79881 20859.9n 0.79881 20860.0n 0.46859 20999.9n 0.46859 21000.0n 1.04662 21139.9n 1.04662 21140.0n 0.44934 21279.9n 0.44934 21280.0n 0.29315 21419.9n 0.29315 21420.0n 0.78502 21559.9n 0.78502 21560.0n 0.11168 21699.9n 0.11168 21700.0n 0.73581 21839.9n 0.73581 21840.0n 0.82918 21979.9n 0.82918 21980.0n 0.64370 22119.9n 0.64370 22120.0n 0.52444 22259.9n 0.52444 22260.0n 0.72924 22399.9n 0.72924 22400.0n 0.68861 22539.9n 0.68861 22540.0n 0.43551 22679.9n 0.43551 22680.0n 0.30031 22819.9n 0.30031 22820.0n -0.36668 22959.9n -0.36668 22960.0n -0.07007 23099.9n -0.07007 23100.0n 0.03541 23239.9n 0.03541 23240.0n 0.72357 23379.9n 0.72357 23380.0n 0.75921 23519.9n 0.75921 23520.0n 0.26400 23659.9n 0.26400 23660.0n 0.73581 23799.9n 0.73581 23800.0n 0.75921 23939.9n 0.75921 23940.0n 0.47921 24079.9n 0.47921 24080.0n 0.78502 24219.9n 0.78502 24220.0n 0.46859 24359.9n 0.46859 24360.0n 0.29315 24499.9n 0.29315 24500.0n 0.43551 24639.9n 0.43551 24640.0n 0.44934 24779.9n 0.44934 24780.0n 1.04662 24919.9n 1.04662 24920.0n 0.30031 25059.9n 0.30031 25060.0n 0.82918 25199.9n 0.82918 25200.0n 0.11168 25339.9n 0.11168 25340.0n -0.07007 25479.9n -0.07007 25480.0n 0.03541 25619.9n 0.03541 25620.0n 1.31038 25759.9n 1.31038 25760.0n 0.72924 25899.9n 0.72924 25900.0n 0.64370 26039.9n 0.64370 26040.0n 0.44994 26179.9n 0.44994 26180.0n 0.68861 26319.9n 0.68861 26320.0n 0.72357 26459.9n 0.72357 26460.0n 0.79881 26599.9n 0.79881 26600.0n 0.52444 26739.9n 0.52444 26740.0n -0.36668 26879.9n -0.36668 26880.0n 0.72357 27019.9n 0.72357 27020.0n -0.07007 27159.9n -0.07007 27160.0n 0.29315 27299.9n 0.29315 27300.0n 0.64370 27439.9n 0.64370 27440.0n 1.04662 27579.9n 1.04662 27580.0n 1.31038 27719.9n 1.31038 27720.0n 0.11168 27859.9n 0.11168 27860.0n 0.78502 27999.9n 0.78502 28000.0n 0.82918 28139.9n 0.82918 28140.0n 0.03541 28279.9n 0.03541 28280.0n -0.36668 28419.9n -0.36668 28420.0n 0.68861 28559.9n 0.68861 28560.0n 0.52444 28699.9n 0.52444 28700.0n 0.79881 28839.9n 0.79881 28840.0n 0.72924 28979.9n 0.72924 28980.0n 0.44994 29119.9n 0.44994 29120.0n 0.26400 29259.9n 0.26400 29260.0n 0.44934 29399.9n 0.44934 29400.0n 0.73581 29539.9n 0.73581 29540.0n 0.30031 29679.9n 0.30031 29680.0n 0.75921 29819.9n 0.75921 29820.0n 0.46859 29959.9n 0.46859 29960.0n 0.43551 30099.9n 0.43551 30100.0n 0.47921 30239.9n 0.47921 30240.0n 0.72924 30379.9n 0.72924 30380.0n 0.73581 30519.9n 0.73581 30520.0n 0.64370 30659.9n 0.64370 30660.0n 0.75921 30799.9n 0.75921 30800.0n -0.07007 30939.9n -0.07007 30940.0n 0.47921 31079.9n 0.47921 31080.0n 0.03541 31219.9n 0.03541 31220.0n 0.30031 31359.9n 0.30031 31360.0n 0.79881 31499.9n 0.79881 31500.0n 0.68861 31639.9n 0.68861 31640.0n 0.44934 31779.9n 0.44934 31780.0n 1.31038 31919.9n 1.31038 31920.0n 0.52444 32059.9n 0.52444 32060.0n 0.11168 32199.9n 0.11168 32200.0n 0.29315 32339.9n 0.29315 32340.0n -0.36668 32479.9n -0.36668 32480.0n 0.78502 32619.9n 0.78502 32620.0n 0.72357 32759.9n 0.72357 32760.0n 0.26400 32899.9n 0.26400 32900.0n 0.82918 33039.9n 0.82918 33040.0n 0.44994 33179.9n 0.44994 33180.0n 0.46859 33319.9n 0.46859 33320.0n 0.43551 33459.9n 0.43551 33460.0n 1.04662 33599.9n 1.04662 33600.0n 0.43551 33739.9n 0.43551 33740.0n 0.82918 33879.9n 0.82918 33880.0n 0.29315 34019.9n 0.29315 34020.0n 0.78502 34159.9n 0.78502 34160.0n 0.75921 34299.9n 0.75921 34300.0n 0.47921 34439.9n 0.47921 34440.0n 0.44994 34579.9n 0.44994 34580.0n 0.72357 34719.9n 0.72357 34720.0n 0.44934 34859.9n 0.44934 34860.0n -0.07007 34999.9n -0.07007 35000.0n 0.46859 35139.9n 0.46859 35140.0n 0.79881 35279.9n 0.79881 35280.0n 0.30031 35419.9n 0.30031 35420.0n 0.52444 35559.9n 0.52444 35560.0n 0.11168 35699.9n 0.11168 35700.0n -0.36668 35839.9n -0.36668 35840.0n 0.73581 35979.9n 0.73581 35980.0n 0.72924 36119.9n 0.72924 36120.0n 1.04662 36259.9n 1.04662 36260.0n 0.03541 36399.9n 0.03541 36400.0n 0.64370 36539.9n 0.64370 36540.0n 1.31038 36679.9n 1.31038 36680.0n 0.26400 36819.9n 0.26400 36820.0n 0.68861 36959.9n 0.68861 36960.0n 1.04662 37099.9n 1.04662 37100.0n 0.44994 37239.9n 0.44994 37240.0n 0.79881 37379.9n 0.79881 37380.0n 0.73581 37519.9n 0.73581 37520.0n 0.72357 37659.9n 0.72357 37660.0n 0.11168 37799.9n 0.11168 37800.0n 0.72924 37939.9n 0.72924 37940.0n 0.64370 38079.9n 0.64370 38080.0n 0.47921 38219.9n 0.47921 38220.0n 0.82918 38359.9n 0.82918 38360.0n 0.43551 38499.9n 0.43551 38500.0n 0.26400 38639.9n 0.26400 38640.0n 0.30031 38779.9n 0.30031 38780.0n -0.07007 38919.9n -0.07007 38920.0n -0.36668 39059.9n -0.36668 39060.0n 0.68861 39199.9n 0.68861 39200.0n 0.75921 39339.9n 0.75921 39340.0n 1.31038 39479.9n 1.31038 39480.0n 0.46859 39619.9n 0.46859 39620.0n 0.78502 39759.9n 0.78502 39760.0n 0.29315 39899.9n 0.29315 39900.0n 0.52444 40039.9n 0.52444 40040.0n 0.03541 40179.9n 0.03541 40180.0n 0.44934 40319.9n 0.44934 40320.0n -0.07007 40459.9n -0.07007 40460.0n 0.64370 40599.9n 0.64370 40600.0n 1.04662 40739.9n 1.04662 40740.0n 0.43551 40879.9n 0.43551 40880.0n 0.73581 41019.9n 0.73581 41020.0n 0.68861 41159.9n 0.68861 41160.0n 0.44934 41299.9n 0.44934 41300.0n 0.79881 41439.9n 0.79881 41440.0n 0.29315 41579.9n 0.29315 41580.0n 0.26400 41719.9n 0.26400 41720.0n 0.78502 41859.9n 0.78502 41860.0n 0.30031 41999.9n 0.30031 42000.0n 0.75921 42139.9n 0.75921 42140.0n 0.72357 42279.9n 0.72357 42280.0n 0.46859 42419.9n 0.46859 42420.0n 0.72924 42559.9n 0.72924 42560.0n 0.44994 42699.9n 0.44994 42700.0n 0.52444 42839.9n 0.52444 42840.0n 0.11168 42979.9n 0.11168 42980.0n 0.47921 43119.9n 0.47921 43120.0n 0.03541 43259.9n 0.03541 43260.0n 1.31038 43399.9n 1.31038 43400.0n -0.36668 43539.9n -0.36668 43540.0n 0.82918 43679.9n 0.82918 43680.0n 0.44994 43819.9n 0.44994 43820.0n 0.79881 43959.9n 0.79881 43960.0n 0.44934 44099.9n 0.44934 44100.0n 0.26400 44239.9n 0.26400 44240.0n 0.47921 44379.9n 0.47921 44380.0n 0.72924 44519.9n 0.72924 44520.0n 1.04662 44659.9n 1.04662 44660.0n 0.46859 44799.9n 0.46859 44800.0n 0.03541 44939.9n 0.03541 44940.0n 0.29315 45079.9n 0.29315 45080.0n 0.68861 45219.9n 0.68861 45220.0n 0.78502 45359.9n 0.78502 45360.0n 0.82918 45499.9n 0.82918 45500.0n 0.75921 45639.9n 0.75921 45640.0n 0.72357 45779.9n 0.72357 45780.0n -0.07007 45919.9n -0.07007 45920.0n 0.52444 46059.9n 0.52444 46060.0n 1.31038 46199.9n 1.31038 46200.0n 0.11168 46339.9n 0.11168 46340.0n 0.73581 46479.9n 0.73581 46480.0n -0.36668 46619.9n -0.36668 46620.0n 0.64370 46759.9n 0.64370 46760.0n 0.43551 46899.9n 0.43551 46900.0n 0.30031 47039.9n 0.30031 47040.0n 0.56419 47179.9n 0.56419 47180.0n 0.30498 47319.9n 0.30498 47320.0n 0.51492 47459.9n 0.51492 47460.0n 0.13970 47599.9n 0.13970 47600.0n 0.42258 47739.9n 0.42258 47740.0n 0.20713 47879.9n 0.20713 47880.0n 0.39910 48019.9n 0.39910 48020.0n 0.76629 48159.9n 0.76629 48160.0n 0.87516 48299.9n 0.87516 48300.0n 0.51649 48439.9n 0.51649 48440.0n 0.47728 48579.9n 0.47728 48580.0n 0.89579 48719.9n 0.89579 48720.0n 0.73813 48859.9n 0.73813 48860.0n 0.73007 48999.9n 0.73007 49000.0n 0.38805 49139.9n 0.38805 49140.0n 0.44565 49279.9n 0.44565 49280.0n 0.84972 49419.9n 0.84972 49420.0n 0.31374 49559.9n 0.31374 49560.0n 0.53500 49699.9n 0.53500 49700.0n 0.65381 49839.9n 0.65381 49840.0n 0.89441 49979.9n 0.89441 49980.0n 1.14927 50119.9n 1.14927 50120.0n -0.38855 50259.9n -0.38855 50260.0n -0.21890 50399.9n -0.21890 50400.0n -0.28851 50539.9n -0.28851 50540.0n -0.24585 50679.9n -0.24585 50680.0n 1.15208 50819.9n 1.15208 50820.0n 0.41841 50959.9n 0.41841 50960.0n 0.24338 51099.9n 0.24338 51100.0n 1.49277 51239.9n 1.49277 51240.0n 1.19260 51379.9n 1.19260 51380.0n -0.27962 51519.9n -0.27962 51520.0n 0.55733 51659.9n 0.55733 51660.0n 0.95600 51799.9n 0.95600 51800.0n -0.04710 51939.9n -0.04710 51940.0n 0.80242 52079.9n 0.80242 52080.0n 0.39736 52219.9n 0.39736 52220.0n 1.04029 52359.9n 1.04029 52360.0n 0.63149 52499.9n 0.63149 52500.0n 0.81752)
Vxp1 a_xp1 0 PWL(0.0n 0.65842 139.9n 0.65842 140.0n -0.08309 279.9n -0.08309 280.0n 0.23835 419.9n 0.23835 420.0n -0.33158 559.9n -0.33158 560.0n 1.23180 699.9n 1.23180 700.0n -0.21828 839.9n -0.21828 840.0n 0.28700 979.9n 0.28700 980.0n 0.56595 1119.9n 0.56595 1120.0n 0.70122 1259.9n 0.70122 1260.0n -0.15161 1399.9n -0.15161 1400.0n 0.33171 1539.9n 0.33171 1540.0n 1.18224 1679.9n 1.18224 1680.0n -0.23386 1819.9n -0.23386 1820.0n 0.63482 1959.9n 0.63482 1960.0n 1.28574 2099.9n 1.28574 2100.0n 0.76415 2239.9n 0.76415 2240.0n 0.34013 2379.9n 0.34013 2380.0n 0.66096 2519.9n 0.66096 2520.0n 0.28189 2659.9n 0.28189 2660.0n 0.25911 2799.9n 0.25911 2800.0n 1.27694 2939.9n 1.27694 2940.0n 0.13226 3079.9n 0.13226 3080.0n -0.37792 3219.9n -0.37792 3220.0n 0.42554 3359.9n 0.42554 3360.0n -0.37792 3499.9n -0.37792 3500.0n 0.63482 3639.9n 0.63482 3640.0n 0.25911 3779.9n 0.25911 3780.0n 1.28574 3919.9n 1.28574 3920.0n 0.28189 4059.9n 0.28189 4060.0n -0.21828 4199.9n -0.21828 4200.0n 1.23180 4339.9n 1.23180 4340.0n 0.76415 4479.9n 0.76415 4480.0n 0.33171 4619.9n 0.33171 4620.0n -0.23386 4759.9n -0.23386 4760.0n 0.65842 4899.9n 0.65842 4900.0n 1.18224 5039.9n 1.18224 5040.0n 0.70122 5179.9n 0.70122 5180.0n 0.13226 5319.9n 0.13226 5320.0n 0.42554 5459.9n 0.42554 5460.0n 0.23835 5599.9n 0.23835 5600.0n -0.08309 5739.9n -0.08309 5740.0n 1.27694 5879.9n 1.27694 5880.0n 0.56595 6019.9n 0.56595 6020.0n 0.34013 6159.9n 0.34013 6160.0n 0.28700 6299.9n 0.28700 6300.0n -0.33158 6439.9n -0.33158 6440.0n 0.66096 6579.9n 0.66096 6580.0n -0.15161 6719.9n -0.15161 6720.0n 1.27694 6859.9n 1.27694 6860.0n 0.66096 6999.9n 0.66096 7000.0n 1.18224 7139.9n 1.18224 7140.0n -0.23386 7279.9n -0.23386 7280.0n 0.25911 7419.9n 0.25911 7420.0n 0.42554 7559.9n 0.42554 7560.0n 0.33171 7699.9n 0.33171 7700.0n -0.33158 7839.9n -0.33158 7840.0n 0.65842 7979.9n 0.65842 7980.0n 0.76415 8119.9n 0.76415 8120.0n -0.08309 8259.9n -0.08309 8260.0n 1.23180 8399.9n 1.23180 8400.0n 0.23835 8539.9n 0.23835 8540.0n 0.56595 8679.9n 0.56595 8680.0n 0.28189 8819.9n 0.28189 8820.0n 0.13226 8959.9n 0.13226 8960.0n -0.37792 9099.9n -0.37792 9100.0n 0.28700 9239.9n 0.28700 9240.0n 0.70122 9379.9n 0.70122 9380.0n 0.63482 9519.9n 0.63482 9520.0n 0.34013 9659.9n 0.34013 9660.0n -0.15161 9799.9n -0.15161 9800.0n 1.28574 9939.9n 1.28574 9940.0n -0.21828 10079.9n -0.21828 10080.0n 1.28574 10219.9n 1.28574 10220.0n 0.13226 10359.9n 0.13226 10360.0n 0.76415 10499.9n 0.76415 10500.0n 1.23180 10639.9n 1.23180 10640.0n 0.34013 10779.9n 0.34013 10780.0n 1.18224 10919.9n 1.18224 10920.0n 0.63482 11059.9n 0.63482 11060.0n -0.33158 11199.9n -0.33158 11200.0n 0.23835 11339.9n 0.23835 11340.0n -0.21828 11479.9n -0.21828 11480.0n 0.28189 11619.9n 0.28189 11620.0n 1.27694 11759.9n 1.27694 11760.0n 0.33171 11899.9n 0.33171 11900.0n 0.65842 12039.9n 0.65842 12040.0n -0.23386 12179.9n -0.23386 12180.0n 0.70122 12319.9n 0.70122 12320.0n 0.25911 12459.9n 0.25911 12460.0n 0.42554 12599.9n 0.42554 12600.0n 0.66096 12739.9n 0.66096 12740.0n 0.28700 12879.9n 0.28700 12880.0n -0.37792 13019.9n -0.37792 13020.0n 0.56595 13159.9n 0.56595 13160.0n -0.15161 13299.9n -0.15161 13300.0n -0.08309 13439.9n -0.08309 13440.0n 0.34013 13579.9n 0.34013 13580.0n -0.37792 13719.9n -0.37792 13720.0n 1.23180 13859.9n 1.23180 13860.0n 0.23835 13999.9n 0.23835 14000.0n 0.28189 14139.9n 0.28189 14140.0n 1.18224 14279.9n 1.18224 14280.0n 0.66096 14419.9n 0.66096 14420.0n -0.23386 14559.9n -0.23386 14560.0n 0.33171 14699.9n 0.33171 14700.0n 0.76415 14839.9n 0.76415 14840.0n 1.28574 14979.9n 1.28574 14980.0n -0.15161 15119.9n -0.15161 15120.0n 0.13226 15259.9n 0.13226 15260.0n 1.27694 15399.9n 1.27694 15400.0n 0.25911 15539.9n 0.25911 15540.0n 0.42554 15679.9n 0.42554 15680.0n -0.08309 15819.9n -0.08309 15820.0n -0.21828 15959.9n -0.21828 15960.0n -0.33158 16099.9n -0.33158 16100.0n 0.28700 16239.9n 0.28700 16240.0n 0.70122 16379.9n 0.70122 16380.0n 0.65842 16519.9n 0.65842 16520.0n 0.56595 16659.9n 0.56595 16660.0n 0.63482 16799.9n 0.63482 16800.0n 0.13226 16939.9n 0.13226 16940.0n 0.28700 17079.9n 0.28700 17080.0n -0.21828 17219.9n -0.21828 17220.0n 1.23180 17359.9n 1.23180 17360.0n 0.76415 17499.9n 0.76415 17500.0n 0.34013 17639.9n 0.34013 17640.0n -0.33158 17779.9n -0.33158 17780.0n 0.23835 17919.9n 0.23835 17920.0n 0.25911 18059.9n 0.25911 18060.0n 0.63482 18199.9n 0.63482 18200.0n -0.23386 18339.9n -0.23386 18340.0n -0.15161 18479.9n -0.15161 18480.0n 1.18224 18619.9n 1.18224 18620.0n 0.33171 18759.9n 0.33171 18760.0n 1.28574 18899.9n 1.28574 18900.0n -0.37792 19039.9n -0.37792 19040.0n 0.42554 19179.9n 0.42554 19180.0n 0.66096 19319.9n 0.66096 19320.0n 0.65842 19459.9n 0.65842 19460.0n 0.70122 19599.9n 0.70122 19600.0n 1.27694 19739.9n 1.27694 19740.0n -0.08309 19879.9n -0.08309 19880.0n 0.56595 20019.9n 0.56595 20020.0n 0.28189 20159.9n 0.28189 20160.0n 0.28700 20299.9n 0.28700 20300.0n 0.34013 20439.9n 0.34013 20440.0n 0.63482 20579.9n 0.63482 20580.0n 0.23835 20719.9n 0.23835 20720.0n 0.25911 20859.9n 0.25911 20860.0n -0.21828 20999.9n -0.21828 21000.0n 1.18224 21139.9n 1.18224 21140.0n 0.76415 21279.9n 0.76415 21280.0n 0.33171 21419.9n 0.33171 21420.0n 0.65842 21559.9n 0.65842 21560.0n -0.08309 21699.9n -0.08309 21700.0n -0.15161 21839.9n -0.15161 21840.0n 0.66096 21979.9n 0.66096 21980.0n 0.42554 22119.9n 0.42554 22120.0n -0.37792 22259.9n -0.37792 22260.0n 1.27694 22399.9n 1.27694 22400.0n 0.70122 22539.9n 0.70122 22540.0n 0.28189 22679.9n 0.28189 22680.0n 1.23180 22819.9n 1.23180 22820.0n 0.13226 22959.9n 0.13226 22960.0n 1.28574 23099.9n 1.28574 23100.0n -0.33158 23239.9n -0.33158 23240.0n -0.23386 23379.9n -0.23386 23380.0n 0.56595 23519.9n 0.56595 23520.0n 0.23835 23659.9n 0.23835 23660.0n -0.15161 23799.9n -0.15161 23800.0n 0.56595 23939.9n 0.56595 23940.0n 0.34013 24079.9n 0.34013 24080.0n 0.65842 24219.9n 0.65842 24220.0n -0.21828 24359.9n -0.21828 24360.0n 0.33171 24499.9n 0.33171 24500.0n 0.28189 24639.9n 0.28189 24640.0n 0.76415 24779.9n 0.76415 24780.0n 1.18224 24919.9n 1.18224 24920.0n 1.23180 25059.9n 1.23180 25060.0n 0.66096 25199.9n 0.66096 25200.0n -0.08309 25339.9n -0.08309 25340.0n 1.28574 25479.9n 1.28574 25480.0n -0.33158 25619.9n -0.33158 25620.0n 0.28700 25759.9n 0.28700 25760.0n 1.27694 25899.9n 1.27694 25900.0n 0.42554 26039.9n 0.42554 26040.0n 0.63482 26179.9n 0.63482 26180.0n 0.70122 26319.9n 0.70122 26320.0n -0.23386 26459.9n -0.23386 26460.0n 0.25911 26599.9n 0.25911 26600.0n -0.37792 26739.9n -0.37792 26740.0n 0.13226 26879.9n 0.13226 26880.0n -0.23386 27019.9n -0.23386 27020.0n 1.28574 27159.9n 1.28574 27160.0n 0.33171 27299.9n 0.33171 27300.0n 0.42554 27439.9n 0.42554 27440.0n 1.18224 27579.9n 1.18224 27580.0n 0.28700 27719.9n 0.28700 27720.0n -0.08309 27859.9n -0.08309 27860.0n 0.65842 27999.9n 0.65842 28000.0n 0.66096 28139.9n 0.66096 28140.0n -0.33158 28279.9n -0.33158 28280.0n 0.13226 28419.9n 0.13226 28420.0n 0.70122 28559.9n 0.70122 28560.0n -0.37792 28699.9n -0.37792 28700.0n 0.25911 28839.9n 0.25911 28840.0n 1.27694 28979.9n 1.27694 28980.0n 0.63482 29119.9n 0.63482 29120.0n 0.23835 29259.9n 0.23835 29260.0n 0.76415 29399.9n 0.76415 29400.0n -0.15161 29539.9n -0.15161 29540.0n 1.23180 29679.9n 1.23180 29680.0n 0.56595 29819.9n 0.56595 29820.0n -0.21828 29959.9n -0.21828 29960.0n 0.28189 30099.9n 0.28189 30100.0n 0.34013 30239.9n 0.34013 30240.0n 1.27694 30379.9n 1.27694 30380.0n -0.15161 30519.9n -0.15161 30520.0n 0.42554 30659.9n 0.42554 30660.0n 0.56595 30799.9n 0.56595 30800.0n 1.28574 30939.9n 1.28574 30940.0n 0.34013 31079.9n 0.34013 31080.0n -0.33158 31219.9n -0.33158 31220.0n 1.23180 31359.9n 1.23180 31360.0n 0.25911 31499.9n 0.25911 31500.0n 0.70122 31639.9n 0.70122 31640.0n 0.76415 31779.9n 0.76415 31780.0n 0.28700 31919.9n 0.28700 31920.0n -0.37792 32059.9n -0.37792 32060.0n -0.08309 32199.9n -0.08309 32200.0n 0.33171 32339.9n 0.33171 32340.0n 0.13226 32479.9n 0.13226 32480.0n 0.65842 32619.9n 0.65842 32620.0n -0.23386 32759.9n -0.23386 32760.0n 0.23835 32899.9n 0.23835 32900.0n 0.66096 33039.9n 0.66096 33040.0n 0.63482 33179.9n 0.63482 33180.0n -0.21828 33319.9n -0.21828 33320.0n 0.28189 33459.9n 0.28189 33460.0n 1.18224 33599.9n 1.18224 33600.0n 0.28189 33739.9n 0.28189 33740.0n 0.66096 33879.9n 0.66096 33880.0n 0.33171 34019.9n 0.33171 34020.0n 0.65842 34159.9n 0.65842 34160.0n 0.56595 34299.9n 0.56595 34300.0n 0.34013 34439.9n 0.34013 34440.0n 0.63482 34579.9n 0.63482 34580.0n -0.23386 34719.9n -0.23386 34720.0n 0.76415 34859.9n 0.76415 34860.0n 1.28574 34999.9n 1.28574 35000.0n -0.21828 35139.9n -0.21828 35140.0n 0.25911 35279.9n 0.25911 35280.0n 1.23180 35419.9n 1.23180 35420.0n -0.37792 35559.9n -0.37792 35560.0n -0.08309 35699.9n -0.08309 35700.0n 0.13226 35839.9n 0.13226 35840.0n -0.15161 35979.9n -0.15161 35980.0n 1.27694 36119.9n 1.27694 36120.0n 1.18224 36259.9n 1.18224 36260.0n -0.33158 36399.9n -0.33158 36400.0n 0.42554 36539.9n 0.42554 36540.0n 0.28700 36679.9n 0.28700 36680.0n 0.23835 36819.9n 0.23835 36820.0n 0.70122 36959.9n 0.70122 36960.0n 1.18224 37099.9n 1.18224 37100.0n 0.63482 37239.9n 0.63482 37240.0n 0.25911 37379.9n 0.25911 37380.0n -0.15161 37519.9n -0.15161 37520.0n -0.23386 37659.9n -0.23386 37660.0n -0.08309 37799.9n -0.08309 37800.0n 1.27694 37939.9n 1.27694 37940.0n 0.42554 38079.9n 0.42554 38080.0n 0.34013 38219.9n 0.34013 38220.0n 0.66096 38359.9n 0.66096 38360.0n 0.28189 38499.9n 0.28189 38500.0n 0.23835 38639.9n 0.23835 38640.0n 1.23180 38779.9n 1.23180 38780.0n 1.28574 38919.9n 1.28574 38920.0n 0.13226 39059.9n 0.13226 39060.0n 0.70122 39199.9n 0.70122 39200.0n 0.56595 39339.9n 0.56595 39340.0n 0.28700 39479.9n 0.28700 39480.0n -0.21828 39619.9n -0.21828 39620.0n 0.65842 39759.9n 0.65842 39760.0n 0.33171 39899.9n 0.33171 39900.0n -0.37792 40039.9n -0.37792 40040.0n -0.33158 40179.9n -0.33158 40180.0n 0.76415 40319.9n 0.76415 40320.0n 1.28574 40459.9n 1.28574 40460.0n 0.42554 40599.9n 0.42554 40600.0n 1.18224 40739.9n 1.18224 40740.0n 0.28189 40879.9n 0.28189 40880.0n -0.15161 41019.9n -0.15161 41020.0n 0.70122 41159.9n 0.70122 41160.0n 0.76415 41299.9n 0.76415 41300.0n 0.25911 41439.9n 0.25911 41440.0n 0.33171 41579.9n 0.33171 41580.0n 0.23835 41719.9n 0.23835 41720.0n 0.65842 41859.9n 0.65842 41860.0n 1.23180 41999.9n 1.23180 42000.0n 0.56595 42139.9n 0.56595 42140.0n -0.23386 42279.9n -0.23386 42280.0n -0.21828 42419.9n -0.21828 42420.0n 1.27694 42559.9n 1.27694 42560.0n 0.63482 42699.9n 0.63482 42700.0n -0.37792 42839.9n -0.37792 42840.0n -0.08309 42979.9n -0.08309 42980.0n 0.34013 43119.9n 0.34013 43120.0n -0.33158 43259.9n -0.33158 43260.0n 0.28700 43399.9n 0.28700 43400.0n 0.13226 43539.9n 0.13226 43540.0n 0.66096 43679.9n 0.66096 43680.0n 0.63482 43819.9n 0.63482 43820.0n 0.25911 43959.9n 0.25911 43960.0n 0.76415 44099.9n 0.76415 44100.0n 0.23835 44239.9n 0.23835 44240.0n 0.34013 44379.9n 0.34013 44380.0n 1.27694 44519.9n 1.27694 44520.0n 1.18224 44659.9n 1.18224 44660.0n -0.21828 44799.9n -0.21828 44800.0n -0.33158 44939.9n -0.33158 44940.0n 0.33171 45079.9n 0.33171 45080.0n 0.70122 45219.9n 0.70122 45220.0n 0.65842 45359.9n 0.65842 45360.0n 0.66096 45499.9n 0.66096 45500.0n 0.56595 45639.9n 0.56595 45640.0n -0.23386 45779.9n -0.23386 45780.0n 1.28574 45919.9n 1.28574 45920.0n -0.37792 46059.9n -0.37792 46060.0n 0.28700 46199.9n 0.28700 46200.0n -0.08309 46339.9n -0.08309 46340.0n -0.15161 46479.9n -0.15161 46480.0n 0.13226 46619.9n 0.13226 46620.0n 0.42554 46759.9n 0.42554 46760.0n 0.28189 46899.9n 0.28189 46900.0n 1.23180 47039.9n 1.23180 47040.0n 0.67130 47179.9n 0.67130 47180.0n 0.48458 47319.9n 0.48458 47320.0n 0.29915 47459.9n 0.29915 47460.0n 0.40313 47599.9n 0.40313 47600.0n 0.36576 47739.9n 0.36576 47740.0n 0.33730 47879.9n 0.33730 47880.0n 0.38385 48019.9n 0.38385 48020.0n 0.59706 48159.9n 0.59706 48160.0n 0.62307 48299.9n 0.62307 48300.0n 0.67018 48439.9n 0.67018 48440.0n 0.70540 48579.9n 0.70540 48580.0n 0.53582 48719.9n 0.53582 48720.0n 0.33357 48859.9n 0.33357 48860.0n 0.52885 48999.9n 0.52885 49000.0n 0.74383 49139.9n 0.74383 49140.0n 0.78409 49279.9n 0.78409 49280.0n 0.51936 49419.9n 0.51936 49420.0n 0.50532 49559.9n 0.50532 49560.0n 0.68189 49699.9n 0.68189 49700.0n 0.79862 49839.9n 0.79862 49840.0n 1.11225 49979.9n 1.11225 49980.0n 1.17517 50119.9n 1.17517 50120.0n 0.59247 50259.9n 0.59247 50260.0n 1.20712 50399.9n 1.20712 50400.0n 0.87402 50539.9n 0.87402 50540.0n -0.10545 50679.9n -0.10545 50680.0n -0.25282 50819.9n -0.25282 50820.0n -0.37666 50959.9n -0.37666 50960.0n 1.43391 51099.9n 1.43391 51100.0n 0.37511 51239.9n 0.37511 51240.0n 0.35780 51379.9n 0.35780 51380.0n 1.04281 51519.9n 1.04281 51520.0n 1.30757 51659.9n 1.30757 51660.0n -0.27950 51799.9n -0.27950 51800.0n 0.10137 51939.9n 0.10137 51940.0n 1.20727 52079.9n 1.20727 52080.0n 1.40210 52219.9n 1.40210 52220.0n 1.03003 52359.9n 1.03003 52360.0n -0.27250 52499.9n -0.27250 52500.0n -0.24444)
Vxn1 a_xn1 0 PWL(0.0n 0.34158 139.9n 0.34158 140.0n 1.08309 279.9n 1.08309 280.0n 0.76165 419.9n 0.76165 420.0n 1.33158 559.9n 1.33158 560.0n -0.23180 699.9n -0.23180 700.0n 1.21828 839.9n 1.21828 840.0n 0.71300 979.9n 0.71300 980.0n 0.43405 1119.9n 0.43405 1120.0n 0.29878 1259.9n 0.29878 1260.0n 1.15161 1399.9n 1.15161 1400.0n 0.66829 1539.9n 0.66829 1540.0n -0.18224 1679.9n -0.18224 1680.0n 1.23386 1819.9n 1.23386 1820.0n 0.36518 1959.9n 0.36518 1960.0n -0.28574 2099.9n -0.28574 2100.0n 0.23585 2239.9n 0.23585 2240.0n 0.65987 2379.9n 0.65987 2380.0n 0.33904 2519.9n 0.33904 2520.0n 0.71811 2659.9n 0.71811 2660.0n 0.74089 2799.9n 0.74089 2800.0n -0.27694 2939.9n -0.27694 2940.0n 0.86774 3079.9n 0.86774 3080.0n 1.37792 3219.9n 1.37792 3220.0n 0.57446 3359.9n 0.57446 3360.0n 1.37792 3499.9n 1.37792 3500.0n 0.36518 3639.9n 0.36518 3640.0n 0.74089 3779.9n 0.74089 3780.0n -0.28574 3919.9n -0.28574 3920.0n 0.71811 4059.9n 0.71811 4060.0n 1.21828 4199.9n 1.21828 4200.0n -0.23180 4339.9n -0.23180 4340.0n 0.23585 4479.9n 0.23585 4480.0n 0.66829 4619.9n 0.66829 4620.0n 1.23386 4759.9n 1.23386 4760.0n 0.34158 4899.9n 0.34158 4900.0n -0.18224 5039.9n -0.18224 5040.0n 0.29878 5179.9n 0.29878 5180.0n 0.86774 5319.9n 0.86774 5320.0n 0.57446 5459.9n 0.57446 5460.0n 0.76165 5599.9n 0.76165 5600.0n 1.08309 5739.9n 1.08309 5740.0n -0.27694 5879.9n -0.27694 5880.0n 0.43405 6019.9n 0.43405 6020.0n 0.65987 6159.9n 0.65987 6160.0n 0.71300 6299.9n 0.71300 6300.0n 1.33158 6439.9n 1.33158 6440.0n 0.33904 6579.9n 0.33904 6580.0n 1.15161 6719.9n 1.15161 6720.0n -0.27694 6859.9n -0.27694 6860.0n 0.33904 6999.9n 0.33904 7000.0n -0.18224 7139.9n -0.18224 7140.0n 1.23386 7279.9n 1.23386 7280.0n 0.74089 7419.9n 0.74089 7420.0n 0.57446 7559.9n 0.57446 7560.0n 0.66829 7699.9n 0.66829 7700.0n 1.33158 7839.9n 1.33158 7840.0n 0.34158 7979.9n 0.34158 7980.0n 0.23585 8119.9n 0.23585 8120.0n 1.08309 8259.9n 1.08309 8260.0n -0.23180 8399.9n -0.23180 8400.0n 0.76165 8539.9n 0.76165 8540.0n 0.43405 8679.9n 0.43405 8680.0n 0.71811 8819.9n 0.71811 8820.0n 0.86774 8959.9n 0.86774 8960.0n 1.37792 9099.9n 1.37792 9100.0n 0.71300 9239.9n 0.71300 9240.0n 0.29878 9379.9n 0.29878 9380.0n 0.36518 9519.9n 0.36518 9520.0n 0.65987 9659.9n 0.65987 9660.0n 1.15161 9799.9n 1.15161 9800.0n -0.28574 9939.9n -0.28574 9940.0n 1.21828 10079.9n 1.21828 10080.0n -0.28574 10219.9n -0.28574 10220.0n 0.86774 10359.9n 0.86774 10360.0n 0.23585 10499.9n 0.23585 10500.0n -0.23180 10639.9n -0.23180 10640.0n 0.65987 10779.9n 0.65987 10780.0n -0.18224 10919.9n -0.18224 10920.0n 0.36518 11059.9n 0.36518 11060.0n 1.33158 11199.9n 1.33158 11200.0n 0.76165 11339.9n 0.76165 11340.0n 1.21828 11479.9n 1.21828 11480.0n 0.71811 11619.9n 0.71811 11620.0n -0.27694 11759.9n -0.27694 11760.0n 0.66829 11899.9n 0.66829 11900.0n 0.34158 12039.9n 0.34158 12040.0n 1.23386 12179.9n 1.23386 12180.0n 0.29878 12319.9n 0.29878 12320.0n 0.74089 12459.9n 0.74089 12460.0n 0.57446 12599.9n 0.57446 12600.0n 0.33904 12739.9n 0.33904 12740.0n 0.71300 12879.9n 0.71300 12880.0n 1.37792 13019.9n 1.37792 13020.0n 0.43405 13159.9n 0.43405 13160.0n 1.15161 13299.9n 1.15161 13300.0n 1.08309 13439.9n 1.08309 13440.0n 0.65987 13579.9n 0.65987 13580.0n 1.37792 13719.9n 1.37792 13720.0n -0.23180 13859.9n -0.23180 13860.0n 0.76165 13999.9n 0.76165 14000.0n 0.71811 14139.9n 0.71811 14140.0n -0.18224 14279.9n -0.18224 14280.0n 0.33904 14419.9n 0.33904 14420.0n 1.23386 14559.9n 1.23386 14560.0n 0.66829 14699.9n 0.66829 14700.0n 0.23585 14839.9n 0.23585 14840.0n -0.28574 14979.9n -0.28574 14980.0n 1.15161 15119.9n 1.15161 15120.0n 0.86774 15259.9n 0.86774 15260.0n -0.27694 15399.9n -0.27694 15400.0n 0.74089 15539.9n 0.74089 15540.0n 0.57446 15679.9n 0.57446 15680.0n 1.08309 15819.9n 1.08309 15820.0n 1.21828 15959.9n 1.21828 15960.0n 1.33158 16099.9n 1.33158 16100.0n 0.71300 16239.9n 0.71300 16240.0n 0.29878 16379.9n 0.29878 16380.0n 0.34158 16519.9n 0.34158 16520.0n 0.43405 16659.9n 0.43405 16660.0n 0.36518 16799.9n 0.36518 16800.0n 0.86774 16939.9n 0.86774 16940.0n 0.71300 17079.9n 0.71300 17080.0n 1.21828 17219.9n 1.21828 17220.0n -0.23180 17359.9n -0.23180 17360.0n 0.23585 17499.9n 0.23585 17500.0n 0.65987 17639.9n 0.65987 17640.0n 1.33158 17779.9n 1.33158 17780.0n 0.76165 17919.9n 0.76165 17920.0n 0.74089 18059.9n 0.74089 18060.0n 0.36518 18199.9n 0.36518 18200.0n 1.23386 18339.9n 1.23386 18340.0n 1.15161 18479.9n 1.15161 18480.0n -0.18224 18619.9n -0.18224 18620.0n 0.66829 18759.9n 0.66829 18760.0n -0.28574 18899.9n -0.28574 18900.0n 1.37792 19039.9n 1.37792 19040.0n 0.57446 19179.9n 0.57446 19180.0n 0.33904 19319.9n 0.33904 19320.0n 0.34158 19459.9n 0.34158 19460.0n 0.29878 19599.9n 0.29878 19600.0n -0.27694 19739.9n -0.27694 19740.0n 1.08309 19879.9n 1.08309 19880.0n 0.43405 20019.9n 0.43405 20020.0n 0.71811 20159.9n 0.71811 20160.0n 0.71300 20299.9n 0.71300 20300.0n 0.65987 20439.9n 0.65987 20440.0n 0.36518 20579.9n 0.36518 20580.0n 0.76165 20719.9n 0.76165 20720.0n 0.74089 20859.9n 0.74089 20860.0n 1.21828 20999.9n 1.21828 21000.0n -0.18224 21139.9n -0.18224 21140.0n 0.23585 21279.9n 0.23585 21280.0n 0.66829 21419.9n 0.66829 21420.0n 0.34158 21559.9n 0.34158 21560.0n 1.08309 21699.9n 1.08309 21700.0n 1.15161 21839.9n 1.15161 21840.0n 0.33904 21979.9n 0.33904 21980.0n 0.57446 22119.9n 0.57446 22120.0n 1.37792 22259.9n 1.37792 22260.0n -0.27694 22399.9n -0.27694 22400.0n 0.29878 22539.9n 0.29878 22540.0n 0.71811 22679.9n 0.71811 22680.0n -0.23180 22819.9n -0.23180 22820.0n 0.86774 22959.9n 0.86774 22960.0n -0.28574 23099.9n -0.28574 23100.0n 1.33158 23239.9n 1.33158 23240.0n 1.23386 23379.9n 1.23386 23380.0n 0.43405 23519.9n 0.43405 23520.0n 0.76165 23659.9n 0.76165 23660.0n 1.15161 23799.9n 1.15161 23800.0n 0.43405 23939.9n 0.43405 23940.0n 0.65987 24079.9n 0.65987 24080.0n 0.34158 24219.9n 0.34158 24220.0n 1.21828 24359.9n 1.21828 24360.0n 0.66829 24499.9n 0.66829 24500.0n 0.71811 24639.9n 0.71811 24640.0n 0.23585 24779.9n 0.23585 24780.0n -0.18224 24919.9n -0.18224 24920.0n -0.23180 25059.9n -0.23180 25060.0n 0.33904 25199.9n 0.33904 25200.0n 1.08309 25339.9n 1.08309 25340.0n -0.28574 25479.9n -0.28574 25480.0n 1.33158 25619.9n 1.33158 25620.0n 0.71300 25759.9n 0.71300 25760.0n -0.27694 25899.9n -0.27694 25900.0n 0.57446 26039.9n 0.57446 26040.0n 0.36518 26179.9n 0.36518 26180.0n 0.29878 26319.9n 0.29878 26320.0n 1.23386 26459.9n 1.23386 26460.0n 0.74089 26599.9n 0.74089 26600.0n 1.37792 26739.9n 1.37792 26740.0n 0.86774 26879.9n 0.86774 26880.0n 1.23386 27019.9n 1.23386 27020.0n -0.28574 27159.9n -0.28574 27160.0n 0.66829 27299.9n 0.66829 27300.0n 0.57446 27439.9n 0.57446 27440.0n -0.18224 27579.9n -0.18224 27580.0n 0.71300 27719.9n 0.71300 27720.0n 1.08309 27859.9n 1.08309 27860.0n 0.34158 27999.9n 0.34158 28000.0n 0.33904 28139.9n 0.33904 28140.0n 1.33158 28279.9n 1.33158 28280.0n 0.86774 28419.9n 0.86774 28420.0n 0.29878 28559.9n 0.29878 28560.0n 1.37792 28699.9n 1.37792 28700.0n 0.74089 28839.9n 0.74089 28840.0n -0.27694 28979.9n -0.27694 28980.0n 0.36518 29119.9n 0.36518 29120.0n 0.76165 29259.9n 0.76165 29260.0n 0.23585 29399.9n 0.23585 29400.0n 1.15161 29539.9n 1.15161 29540.0n -0.23180 29679.9n -0.23180 29680.0n 0.43405 29819.9n 0.43405 29820.0n 1.21828 29959.9n 1.21828 29960.0n 0.71811 30099.9n 0.71811 30100.0n 0.65987 30239.9n 0.65987 30240.0n -0.27694 30379.9n -0.27694 30380.0n 1.15161 30519.9n 1.15161 30520.0n 0.57446 30659.9n 0.57446 30660.0n 0.43405 30799.9n 0.43405 30800.0n -0.28574 30939.9n -0.28574 30940.0n 0.65987 31079.9n 0.65987 31080.0n 1.33158 31219.9n 1.33158 31220.0n -0.23180 31359.9n -0.23180 31360.0n 0.74089 31499.9n 0.74089 31500.0n 0.29878 31639.9n 0.29878 31640.0n 0.23585 31779.9n 0.23585 31780.0n 0.71300 31919.9n 0.71300 31920.0n 1.37792 32059.9n 1.37792 32060.0n 1.08309 32199.9n 1.08309 32200.0n 0.66829 32339.9n 0.66829 32340.0n 0.86774 32479.9n 0.86774 32480.0n 0.34158 32619.9n 0.34158 32620.0n 1.23386 32759.9n 1.23386 32760.0n 0.76165 32899.9n 0.76165 32900.0n 0.33904 33039.9n 0.33904 33040.0n 0.36518 33179.9n 0.36518 33180.0n 1.21828 33319.9n 1.21828 33320.0n 0.71811 33459.9n 0.71811 33460.0n -0.18224 33599.9n -0.18224 33600.0n 0.71811 33739.9n 0.71811 33740.0n 0.33904 33879.9n 0.33904 33880.0n 0.66829 34019.9n 0.66829 34020.0n 0.34158 34159.9n 0.34158 34160.0n 0.43405 34299.9n 0.43405 34300.0n 0.65987 34439.9n 0.65987 34440.0n 0.36518 34579.9n 0.36518 34580.0n 1.23386 34719.9n 1.23386 34720.0n 0.23585 34859.9n 0.23585 34860.0n -0.28574 34999.9n -0.28574 35000.0n 1.21828 35139.9n 1.21828 35140.0n 0.74089 35279.9n 0.74089 35280.0n -0.23180 35419.9n -0.23180 35420.0n 1.37792 35559.9n 1.37792 35560.0n 1.08309 35699.9n 1.08309 35700.0n 0.86774 35839.9n 0.86774 35840.0n 1.15161 35979.9n 1.15161 35980.0n -0.27694 36119.9n -0.27694 36120.0n -0.18224 36259.9n -0.18224 36260.0n 1.33158 36399.9n 1.33158 36400.0n 0.57446 36539.9n 0.57446 36540.0n 0.71300 36679.9n 0.71300 36680.0n 0.76165 36819.9n 0.76165 36820.0n 0.29878 36959.9n 0.29878 36960.0n -0.18224 37099.9n -0.18224 37100.0n 0.36518 37239.9n 0.36518 37240.0n 0.74089 37379.9n 0.74089 37380.0n 1.15161 37519.9n 1.15161 37520.0n 1.23386 37659.9n 1.23386 37660.0n 1.08309 37799.9n 1.08309 37800.0n -0.27694 37939.9n -0.27694 37940.0n 0.57446 38079.9n 0.57446 38080.0n 0.65987 38219.9n 0.65987 38220.0n 0.33904 38359.9n 0.33904 38360.0n 0.71811 38499.9n 0.71811 38500.0n 0.76165 38639.9n 0.76165 38640.0n -0.23180 38779.9n -0.23180 38780.0n -0.28574 38919.9n -0.28574 38920.0n 0.86774 39059.9n 0.86774 39060.0n 0.29878 39199.9n 0.29878 39200.0n 0.43405 39339.9n 0.43405 39340.0n 0.71300 39479.9n 0.71300 39480.0n 1.21828 39619.9n 1.21828 39620.0n 0.34158 39759.9n 0.34158 39760.0n 0.66829 39899.9n 0.66829 39900.0n 1.37792 40039.9n 1.37792 40040.0n 1.33158 40179.9n 1.33158 40180.0n 0.23585 40319.9n 0.23585 40320.0n -0.28574 40459.9n -0.28574 40460.0n 0.57446 40599.9n 0.57446 40600.0n -0.18224 40739.9n -0.18224 40740.0n 0.71811 40879.9n 0.71811 40880.0n 1.15161 41019.9n 1.15161 41020.0n 0.29878 41159.9n 0.29878 41160.0n 0.23585 41299.9n 0.23585 41300.0n 0.74089 41439.9n 0.74089 41440.0n 0.66829 41579.9n 0.66829 41580.0n 0.76165 41719.9n 0.76165 41720.0n 0.34158 41859.9n 0.34158 41860.0n -0.23180 41999.9n -0.23180 42000.0n 0.43405 42139.9n 0.43405 42140.0n 1.23386 42279.9n 1.23386 42280.0n 1.21828 42419.9n 1.21828 42420.0n -0.27694 42559.9n -0.27694 42560.0n 0.36518 42699.9n 0.36518 42700.0n 1.37792 42839.9n 1.37792 42840.0n 1.08309 42979.9n 1.08309 42980.0n 0.65987 43119.9n 0.65987 43120.0n 1.33158 43259.9n 1.33158 43260.0n 0.71300 43399.9n 0.71300 43400.0n 0.86774 43539.9n 0.86774 43540.0n 0.33904 43679.9n 0.33904 43680.0n 0.36518 43819.9n 0.36518 43820.0n 0.74089 43959.9n 0.74089 43960.0n 0.23585 44099.9n 0.23585 44100.0n 0.76165 44239.9n 0.76165 44240.0n 0.65987 44379.9n 0.65987 44380.0n -0.27694 44519.9n -0.27694 44520.0n -0.18224 44659.9n -0.18224 44660.0n 1.21828 44799.9n 1.21828 44800.0n 1.33158 44939.9n 1.33158 44940.0n 0.66829 45079.9n 0.66829 45080.0n 0.29878 45219.9n 0.29878 45220.0n 0.34158 45359.9n 0.34158 45360.0n 0.33904 45499.9n 0.33904 45500.0n 0.43405 45639.9n 0.43405 45640.0n 1.23386 45779.9n 1.23386 45780.0n -0.28574 45919.9n -0.28574 45920.0n 1.37792 46059.9n 1.37792 46060.0n 0.71300 46199.9n 0.71300 46200.0n 1.08309 46339.9n 1.08309 46340.0n 1.15161 46479.9n 1.15161 46480.0n 0.86774 46619.9n 0.86774 46620.0n 0.57446 46759.9n 0.57446 46760.0n 0.71811 46899.9n 0.71811 46900.0n -0.23180 47039.9n -0.23180 47040.0n 0.32870 47179.9n 0.32870 47180.0n 0.51542 47319.9n 0.51542 47320.0n 0.70085 47459.9n 0.70085 47460.0n 0.59687 47599.9n 0.59687 47600.0n 0.63424 47739.9n 0.63424 47740.0n 0.66270 47879.9n 0.66270 47880.0n 0.61615 48019.9n 0.61615 48020.0n 0.40294 48159.9n 0.40294 48160.0n 0.37693 48299.9n 0.37693 48300.0n 0.32982 48439.9n 0.32982 48440.0n 0.29460 48579.9n 0.29460 48580.0n 0.46418 48719.9n 0.46418 48720.0n 0.66643 48859.9n 0.66643 48860.0n 0.47115 48999.9n 0.47115 49000.0n 0.25617 49139.9n 0.25617 49140.0n 0.21591 49279.9n 0.21591 49280.0n 0.48064 49419.9n 0.48064 49420.0n 0.49468 49559.9n 0.49468 49560.0n 0.31811 49699.9n 0.31811 49700.0n 0.20138 49839.9n 0.20138 49840.0n -0.11225 49979.9n -0.11225 49980.0n -0.17517 50119.9n -0.17517 50120.0n 0.40753 50259.9n 0.40753 50260.0n -0.20712 50399.9n -0.20712 50400.0n 0.12598 50539.9n 0.12598 50540.0n 1.10545 50679.9n 1.10545 50680.0n 1.25282 50819.9n 1.25282 50820.0n 1.37666 50959.9n 1.37666 50960.0n -0.43391 51099.9n -0.43391 51100.0n 0.62489 51239.9n 0.62489 51240.0n 0.64220 51379.9n 0.64220 51380.0n -0.04281 51519.9n -0.04281 51520.0n -0.30757 51659.9n -0.30757 51660.0n 1.27950 51799.9n 1.27950 51800.0n 0.89863 51939.9n 0.89863 51940.0n -0.20727 52079.9n -0.20727 52080.0n -0.40210 52219.9n -0.40210 52220.0n -0.03003 52359.9n -0.03003 52360.0n 1.27250 52499.9n 1.27250 52500.0n 1.24444)
Vxp2 a_xp2 0 PWL(0.0n 0.80000 139.9n 0.80000 140.0n 0.80000 279.9n 0.80000 280.0n 0.80000 419.9n 0.80000 420.0n 0.80000 559.9n 0.80000 560.0n 0.80000 699.9n 0.80000 700.0n 0.80000 839.9n 0.80000 840.0n 0.80000 979.9n 0.80000 980.0n 0.80000 1119.9n 0.80000 1120.0n 0.80000 1259.9n 0.80000 1260.0n 0.80000 1399.9n 0.80000 1400.0n 0.80000 1539.9n 0.80000 1540.0n 0.80000 1679.9n 0.80000 1680.0n 0.80000 1819.9n 0.80000 1820.0n 0.80000 1959.9n 0.80000 1960.0n 0.80000 2099.9n 0.80000 2100.0n 0.80000 2239.9n 0.80000 2240.0n 0.80000 2379.9n 0.80000 2380.0n 0.80000 2519.9n 0.80000 2520.0n 0.80000 2659.9n 0.80000 2660.0n 0.80000 2799.9n 0.80000 2800.0n 0.80000 2939.9n 0.80000 2940.0n 0.80000 3079.9n 0.80000 3080.0n 0.80000 3219.9n 0.80000 3220.0n 0.80000 3359.9n 0.80000 3360.0n 0.80000 3499.9n 0.80000 3500.0n 0.80000 3639.9n 0.80000 3640.0n 0.80000 3779.9n 0.80000 3780.0n 0.80000 3919.9n 0.80000 3920.0n 0.80000 4059.9n 0.80000 4060.0n 0.80000 4199.9n 0.80000 4200.0n 0.80000 4339.9n 0.80000 4340.0n 0.80000 4479.9n 0.80000 4480.0n 0.80000 4619.9n 0.80000 4620.0n 0.80000 4759.9n 0.80000 4760.0n 0.80000 4899.9n 0.80000 4900.0n 0.80000 5039.9n 0.80000 5040.0n 0.80000 5179.9n 0.80000 5180.0n 0.80000 5319.9n 0.80000 5320.0n 0.80000 5459.9n 0.80000 5460.0n 0.80000 5599.9n 0.80000 5600.0n 0.80000 5739.9n 0.80000 5740.0n 0.80000 5879.9n 0.80000 5880.0n 0.80000 6019.9n 0.80000 6020.0n 0.80000 6159.9n 0.80000 6160.0n 0.80000 6299.9n 0.80000 6300.0n 0.80000 6439.9n 0.80000 6440.0n 0.80000 6579.9n 0.80000 6580.0n 0.80000 6719.9n 0.80000 6720.0n 0.80000 6859.9n 0.80000 6860.0n 0.80000 6999.9n 0.80000 7000.0n 0.80000 7139.9n 0.80000 7140.0n 0.80000 7279.9n 0.80000 7280.0n 0.80000 7419.9n 0.80000 7420.0n 0.80000 7559.9n 0.80000 7560.0n 0.80000 7699.9n 0.80000 7700.0n 0.80000 7839.9n 0.80000 7840.0n 0.80000 7979.9n 0.80000 7980.0n 0.80000 8119.9n 0.80000 8120.0n 0.80000 8259.9n 0.80000 8260.0n 0.80000 8399.9n 0.80000 8400.0n 0.80000 8539.9n 0.80000 8540.0n 0.80000 8679.9n 0.80000 8680.0n 0.80000 8819.9n 0.80000 8820.0n 0.80000 8959.9n 0.80000 8960.0n 0.80000 9099.9n 0.80000 9100.0n 0.80000 9239.9n 0.80000 9240.0n 0.80000 9379.9n 0.80000 9380.0n 0.80000 9519.9n 0.80000 9520.0n 0.80000 9659.9n 0.80000 9660.0n 0.80000 9799.9n 0.80000 9800.0n 0.80000 9939.9n 0.80000 9940.0n 0.80000 10079.9n 0.80000 10080.0n 0.80000 10219.9n 0.80000 10220.0n 0.80000 10359.9n 0.80000 10360.0n 0.80000 10499.9n 0.80000 10500.0n 0.80000 10639.9n 0.80000 10640.0n 0.80000 10779.9n 0.80000 10780.0n 0.80000 10919.9n 0.80000 10920.0n 0.80000 11059.9n 0.80000 11060.0n 0.80000 11199.9n 0.80000 11200.0n 0.80000 11339.9n 0.80000 11340.0n 0.80000 11479.9n 0.80000 11480.0n 0.80000 11619.9n 0.80000 11620.0n 0.80000 11759.9n 0.80000 11760.0n 0.80000 11899.9n 0.80000 11900.0n 0.80000 12039.9n 0.80000 12040.0n 0.80000 12179.9n 0.80000 12180.0n 0.80000 12319.9n 0.80000 12320.0n 0.80000 12459.9n 0.80000 12460.0n 0.80000 12599.9n 0.80000 12600.0n 0.80000 12739.9n 0.80000 12740.0n 0.80000 12879.9n 0.80000 12880.0n 0.80000 13019.9n 0.80000 13020.0n 0.80000 13159.9n 0.80000 13160.0n 0.80000 13299.9n 0.80000 13300.0n 0.80000 13439.9n 0.80000 13440.0n 0.80000 13579.9n 0.80000 13580.0n 0.80000 13719.9n 0.80000 13720.0n 0.80000 13859.9n 0.80000 13860.0n 0.80000 13999.9n 0.80000 14000.0n 0.80000 14139.9n 0.80000 14140.0n 0.80000 14279.9n 0.80000 14280.0n 0.80000 14419.9n 0.80000 14420.0n 0.80000 14559.9n 0.80000 14560.0n 0.80000 14699.9n 0.80000 14700.0n 0.80000 14839.9n 0.80000 14840.0n 0.80000 14979.9n 0.80000 14980.0n 0.80000 15119.9n 0.80000 15120.0n 0.80000 15259.9n 0.80000 15260.0n 0.80000 15399.9n 0.80000 15400.0n 0.80000 15539.9n 0.80000 15540.0n 0.80000 15679.9n 0.80000 15680.0n 0.80000 15819.9n 0.80000 15820.0n 0.80000 15959.9n 0.80000 15960.0n 0.80000 16099.9n 0.80000 16100.0n 0.80000 16239.9n 0.80000 16240.0n 0.80000 16379.9n 0.80000 16380.0n 0.80000 16519.9n 0.80000 16520.0n 0.80000 16659.9n 0.80000 16660.0n 0.80000 16799.9n 0.80000 16800.0n 0.80000 16939.9n 0.80000 16940.0n 0.80000 17079.9n 0.80000 17080.0n 0.80000 17219.9n 0.80000 17220.0n 0.80000 17359.9n 0.80000 17360.0n 0.80000 17499.9n 0.80000 17500.0n 0.80000 17639.9n 0.80000 17640.0n 0.80000 17779.9n 0.80000 17780.0n 0.80000 17919.9n 0.80000 17920.0n 0.80000 18059.9n 0.80000 18060.0n 0.80000 18199.9n 0.80000 18200.0n 0.80000 18339.9n 0.80000 18340.0n 0.80000 18479.9n 0.80000 18480.0n 0.80000 18619.9n 0.80000 18620.0n 0.80000 18759.9n 0.80000 18760.0n 0.80000 18899.9n 0.80000 18900.0n 0.80000 19039.9n 0.80000 19040.0n 0.80000 19179.9n 0.80000 19180.0n 0.80000 19319.9n 0.80000 19320.0n 0.80000 19459.9n 0.80000 19460.0n 0.80000 19599.9n 0.80000 19600.0n 0.80000 19739.9n 0.80000 19740.0n 0.80000 19879.9n 0.80000 19880.0n 0.80000 20019.9n 0.80000 20020.0n 0.80000 20159.9n 0.80000 20160.0n 0.80000 20299.9n 0.80000 20300.0n 0.80000 20439.9n 0.80000 20440.0n 0.80000 20579.9n 0.80000 20580.0n 0.80000 20719.9n 0.80000 20720.0n 0.80000 20859.9n 0.80000 20860.0n 0.80000 20999.9n 0.80000 21000.0n 0.80000 21139.9n 0.80000 21140.0n 0.80000 21279.9n 0.80000 21280.0n 0.80000 21419.9n 0.80000 21420.0n 0.80000 21559.9n 0.80000 21560.0n 0.80000 21699.9n 0.80000 21700.0n 0.80000 21839.9n 0.80000 21840.0n 0.80000 21979.9n 0.80000 21980.0n 0.80000 22119.9n 0.80000 22120.0n 0.80000 22259.9n 0.80000 22260.0n 0.80000 22399.9n 0.80000 22400.0n 0.80000 22539.9n 0.80000 22540.0n 0.80000 22679.9n 0.80000 22680.0n 0.80000 22819.9n 0.80000 22820.0n 0.80000 22959.9n 0.80000 22960.0n 0.80000 23099.9n 0.80000 23100.0n 0.80000 23239.9n 0.80000 23240.0n 0.80000 23379.9n 0.80000 23380.0n 0.80000 23519.9n 0.80000 23520.0n 0.80000 23659.9n 0.80000 23660.0n 0.80000 23799.9n 0.80000 23800.0n 0.80000 23939.9n 0.80000 23940.0n 0.80000 24079.9n 0.80000 24080.0n 0.80000 24219.9n 0.80000 24220.0n 0.80000 24359.9n 0.80000 24360.0n 0.80000 24499.9n 0.80000 24500.0n 0.80000 24639.9n 0.80000 24640.0n 0.80000 24779.9n 0.80000 24780.0n 0.80000 24919.9n 0.80000 24920.0n 0.80000 25059.9n 0.80000 25060.0n 0.80000 25199.9n 0.80000 25200.0n 0.80000 25339.9n 0.80000 25340.0n 0.80000 25479.9n 0.80000 25480.0n 0.80000 25619.9n 0.80000 25620.0n 0.80000 25759.9n 0.80000 25760.0n 0.80000 25899.9n 0.80000 25900.0n 0.80000 26039.9n 0.80000 26040.0n 0.80000 26179.9n 0.80000 26180.0n 0.80000 26319.9n 0.80000 26320.0n 0.80000 26459.9n 0.80000 26460.0n 0.80000 26599.9n 0.80000 26600.0n 0.80000 26739.9n 0.80000 26740.0n 0.80000 26879.9n 0.80000 26880.0n 0.80000 27019.9n 0.80000 27020.0n 0.80000 27159.9n 0.80000 27160.0n 0.80000 27299.9n 0.80000 27300.0n 0.80000 27439.9n 0.80000 27440.0n 0.80000 27579.9n 0.80000 27580.0n 0.80000 27719.9n 0.80000 27720.0n 0.80000 27859.9n 0.80000 27860.0n 0.80000 27999.9n 0.80000 28000.0n 0.80000 28139.9n 0.80000 28140.0n 0.80000 28279.9n 0.80000 28280.0n 0.80000 28419.9n 0.80000 28420.0n 0.80000 28559.9n 0.80000 28560.0n 0.80000 28699.9n 0.80000 28700.0n 0.80000 28839.9n 0.80000 28840.0n 0.80000 28979.9n 0.80000 28980.0n 0.80000 29119.9n 0.80000 29120.0n 0.80000 29259.9n 0.80000 29260.0n 0.80000 29399.9n 0.80000 29400.0n 0.80000 29539.9n 0.80000 29540.0n 0.80000 29679.9n 0.80000 29680.0n 0.80000 29819.9n 0.80000 29820.0n 0.80000 29959.9n 0.80000 29960.0n 0.80000 30099.9n 0.80000 30100.0n 0.80000 30239.9n 0.80000 30240.0n 0.80000 30379.9n 0.80000 30380.0n 0.80000 30519.9n 0.80000 30520.0n 0.80000 30659.9n 0.80000 30660.0n 0.80000 30799.9n 0.80000 30800.0n 0.80000 30939.9n 0.80000 30940.0n 0.80000 31079.9n 0.80000 31080.0n 0.80000 31219.9n 0.80000 31220.0n 0.80000 31359.9n 0.80000 31360.0n 0.80000 31499.9n 0.80000 31500.0n 0.80000 31639.9n 0.80000 31640.0n 0.80000 31779.9n 0.80000 31780.0n 0.80000 31919.9n 0.80000 31920.0n 0.80000 32059.9n 0.80000 32060.0n 0.80000 32199.9n 0.80000 32200.0n 0.80000 32339.9n 0.80000 32340.0n 0.80000 32479.9n 0.80000 32480.0n 0.80000 32619.9n 0.80000 32620.0n 0.80000 32759.9n 0.80000 32760.0n 0.80000 32899.9n 0.80000 32900.0n 0.80000 33039.9n 0.80000 33040.0n 0.80000 33179.9n 0.80000 33180.0n 0.80000 33319.9n 0.80000 33320.0n 0.80000 33459.9n 0.80000 33460.0n 0.80000 33599.9n 0.80000 33600.0n 0.80000 33739.9n 0.80000 33740.0n 0.80000 33879.9n 0.80000 33880.0n 0.80000 34019.9n 0.80000 34020.0n 0.80000 34159.9n 0.80000 34160.0n 0.80000 34299.9n 0.80000 34300.0n 0.80000 34439.9n 0.80000 34440.0n 0.80000 34579.9n 0.80000 34580.0n 0.80000 34719.9n 0.80000 34720.0n 0.80000 34859.9n 0.80000 34860.0n 0.80000 34999.9n 0.80000 35000.0n 0.80000 35139.9n 0.80000 35140.0n 0.80000 35279.9n 0.80000 35280.0n 0.80000 35419.9n 0.80000 35420.0n 0.80000 35559.9n 0.80000 35560.0n 0.80000 35699.9n 0.80000 35700.0n 0.80000 35839.9n 0.80000 35840.0n 0.80000 35979.9n 0.80000 35980.0n 0.80000 36119.9n 0.80000 36120.0n 0.80000 36259.9n 0.80000 36260.0n 0.80000 36399.9n 0.80000 36400.0n 0.80000 36539.9n 0.80000 36540.0n 0.80000 36679.9n 0.80000 36680.0n 0.80000 36819.9n 0.80000 36820.0n 0.80000 36959.9n 0.80000 36960.0n 0.80000 37099.9n 0.80000 37100.0n 0.80000 37239.9n 0.80000 37240.0n 0.80000 37379.9n 0.80000 37380.0n 0.80000 37519.9n 0.80000 37520.0n 0.80000 37659.9n 0.80000 37660.0n 0.80000 37799.9n 0.80000 37800.0n 0.80000 37939.9n 0.80000 37940.0n 0.80000 38079.9n 0.80000 38080.0n 0.80000 38219.9n 0.80000 38220.0n 0.80000 38359.9n 0.80000 38360.0n 0.80000 38499.9n 0.80000 38500.0n 0.80000 38639.9n 0.80000 38640.0n 0.80000 38779.9n 0.80000 38780.0n 0.80000 38919.9n 0.80000 38920.0n 0.80000 39059.9n 0.80000 39060.0n 0.80000 39199.9n 0.80000 39200.0n 0.80000 39339.9n 0.80000 39340.0n 0.80000 39479.9n 0.80000 39480.0n 0.80000 39619.9n 0.80000 39620.0n 0.80000 39759.9n 0.80000 39760.0n 0.80000 39899.9n 0.80000 39900.0n 0.80000 40039.9n 0.80000 40040.0n 0.80000 40179.9n 0.80000 40180.0n 0.80000 40319.9n 0.80000 40320.0n 0.80000 40459.9n 0.80000 40460.0n 0.80000 40599.9n 0.80000 40600.0n 0.80000 40739.9n 0.80000 40740.0n 0.80000 40879.9n 0.80000 40880.0n 0.80000 41019.9n 0.80000 41020.0n 0.80000 41159.9n 0.80000 41160.0n 0.80000 41299.9n 0.80000 41300.0n 0.80000 41439.9n 0.80000 41440.0n 0.80000 41579.9n 0.80000 41580.0n 0.80000 41719.9n 0.80000 41720.0n 0.80000 41859.9n 0.80000 41860.0n 0.80000 41999.9n 0.80000 42000.0n 0.80000 42139.9n 0.80000 42140.0n 0.80000 42279.9n 0.80000 42280.0n 0.80000 42419.9n 0.80000 42420.0n 0.80000 42559.9n 0.80000 42560.0n 0.80000 42699.9n 0.80000 42700.0n 0.80000 42839.9n 0.80000 42840.0n 0.80000 42979.9n 0.80000 42980.0n 0.80000 43119.9n 0.80000 43120.0n 0.80000 43259.9n 0.80000 43260.0n 0.80000 43399.9n 0.80000 43400.0n 0.80000 43539.9n 0.80000 43540.0n 0.80000 43679.9n 0.80000 43680.0n 0.80000 43819.9n 0.80000 43820.0n 0.80000 43959.9n 0.80000 43960.0n 0.80000 44099.9n 0.80000 44100.0n 0.80000 44239.9n 0.80000 44240.0n 0.80000 44379.9n 0.80000 44380.0n 0.80000 44519.9n 0.80000 44520.0n 0.80000 44659.9n 0.80000 44660.0n 0.80000 44799.9n 0.80000 44800.0n 0.80000 44939.9n 0.80000 44940.0n 0.80000 45079.9n 0.80000 45080.0n 0.80000 45219.9n 0.80000 45220.0n 0.80000 45359.9n 0.80000 45360.0n 0.80000 45499.9n 0.80000 45500.0n 0.80000 45639.9n 0.80000 45640.0n 0.80000 45779.9n 0.80000 45780.0n 0.80000 45919.9n 0.80000 45920.0n 0.80000 46059.9n 0.80000 46060.0n 0.80000 46199.9n 0.80000 46200.0n 0.80000 46339.9n 0.80000 46340.0n 0.80000 46479.9n 0.80000 46480.0n 0.80000 46619.9n 0.80000 46620.0n 0.80000 46759.9n 0.80000 46760.0n 0.80000 46899.9n 0.80000 46900.0n 0.80000 47039.9n 0.80000 47040.0n 0.80000 47179.9n 0.80000 47180.0n 0.80000 47319.9n 0.80000 47320.0n 0.80000 47459.9n 0.80000 47460.0n 0.80000 47599.9n 0.80000 47600.0n 0.80000 47739.9n 0.80000 47740.0n 0.80000 47879.9n 0.80000 47880.0n 0.80000 48019.9n 0.80000 48020.0n 0.80000 48159.9n 0.80000 48160.0n 0.80000 48299.9n 0.80000 48300.0n 0.80000 48439.9n 0.80000 48440.0n 0.80000 48579.9n 0.80000 48580.0n 0.80000 48719.9n 0.80000 48720.0n 0.80000 48859.9n 0.80000 48860.0n 0.80000 48999.9n 0.80000 49000.0n 0.80000 49139.9n 0.80000 49140.0n 0.80000 49279.9n 0.80000 49280.0n 0.80000 49419.9n 0.80000 49420.0n 0.80000 49559.9n 0.80000 49560.0n 0.80000 49699.9n 0.80000 49700.0n 0.80000 49839.9n 0.80000 49840.0n 0.80000 49979.9n 0.80000 49980.0n 0.80000 50119.9n 0.80000 50120.0n 0.80000 50259.9n 0.80000 50260.0n 0.80000 50399.9n 0.80000 50400.0n 0.80000 50539.9n 0.80000 50540.0n 0.80000 50679.9n 0.80000 50680.0n 0.80000 50819.9n 0.80000 50820.0n 0.80000 50959.9n 0.80000 50960.0n 0.80000 51099.9n 0.80000 51100.0n 0.80000 51239.9n 0.80000 51240.0n 0.80000 51379.9n 0.80000 51380.0n 0.80000 51519.9n 0.80000 51520.0n 0.80000 51659.9n 0.80000 51660.0n 0.80000 51799.9n 0.80000 51800.0n 0.80000 51939.9n 0.80000 51940.0n 0.80000 52079.9n 0.80000 52080.0n 0.80000 52219.9n 0.80000 52220.0n 0.80000 52359.9n 0.80000 52360.0n 0.80000 52499.9n 0.80000 52500.0n 0.80000)
Vxn2 a_xn2 0 PWL(0.0n 0.20000 139.9n 0.20000 140.0n 0.20000 279.9n 0.20000 280.0n 0.20000 419.9n 0.20000 420.0n 0.20000 559.9n 0.20000 560.0n 0.20000 699.9n 0.20000 700.0n 0.20000 839.9n 0.20000 840.0n 0.20000 979.9n 0.20000 980.0n 0.20000 1119.9n 0.20000 1120.0n 0.20000 1259.9n 0.20000 1260.0n 0.20000 1399.9n 0.20000 1400.0n 0.20000 1539.9n 0.20000 1540.0n 0.20000 1679.9n 0.20000 1680.0n 0.20000 1819.9n 0.20000 1820.0n 0.20000 1959.9n 0.20000 1960.0n 0.20000 2099.9n 0.20000 2100.0n 0.20000 2239.9n 0.20000 2240.0n 0.20000 2379.9n 0.20000 2380.0n 0.20000 2519.9n 0.20000 2520.0n 0.20000 2659.9n 0.20000 2660.0n 0.20000 2799.9n 0.20000 2800.0n 0.20000 2939.9n 0.20000 2940.0n 0.20000 3079.9n 0.20000 3080.0n 0.20000 3219.9n 0.20000 3220.0n 0.20000 3359.9n 0.20000 3360.0n 0.20000 3499.9n 0.20000 3500.0n 0.20000 3639.9n 0.20000 3640.0n 0.20000 3779.9n 0.20000 3780.0n 0.20000 3919.9n 0.20000 3920.0n 0.20000 4059.9n 0.20000 4060.0n 0.20000 4199.9n 0.20000 4200.0n 0.20000 4339.9n 0.20000 4340.0n 0.20000 4479.9n 0.20000 4480.0n 0.20000 4619.9n 0.20000 4620.0n 0.20000 4759.9n 0.20000 4760.0n 0.20000 4899.9n 0.20000 4900.0n 0.20000 5039.9n 0.20000 5040.0n 0.20000 5179.9n 0.20000 5180.0n 0.20000 5319.9n 0.20000 5320.0n 0.20000 5459.9n 0.20000 5460.0n 0.20000 5599.9n 0.20000 5600.0n 0.20000 5739.9n 0.20000 5740.0n 0.20000 5879.9n 0.20000 5880.0n 0.20000 6019.9n 0.20000 6020.0n 0.20000 6159.9n 0.20000 6160.0n 0.20000 6299.9n 0.20000 6300.0n 0.20000 6439.9n 0.20000 6440.0n 0.20000 6579.9n 0.20000 6580.0n 0.20000 6719.9n 0.20000 6720.0n 0.20000 6859.9n 0.20000 6860.0n 0.20000 6999.9n 0.20000 7000.0n 0.20000 7139.9n 0.20000 7140.0n 0.20000 7279.9n 0.20000 7280.0n 0.20000 7419.9n 0.20000 7420.0n 0.20000 7559.9n 0.20000 7560.0n 0.20000 7699.9n 0.20000 7700.0n 0.20000 7839.9n 0.20000 7840.0n 0.20000 7979.9n 0.20000 7980.0n 0.20000 8119.9n 0.20000 8120.0n 0.20000 8259.9n 0.20000 8260.0n 0.20000 8399.9n 0.20000 8400.0n 0.20000 8539.9n 0.20000 8540.0n 0.20000 8679.9n 0.20000 8680.0n 0.20000 8819.9n 0.20000 8820.0n 0.20000 8959.9n 0.20000 8960.0n 0.20000 9099.9n 0.20000 9100.0n 0.20000 9239.9n 0.20000 9240.0n 0.20000 9379.9n 0.20000 9380.0n 0.20000 9519.9n 0.20000 9520.0n 0.20000 9659.9n 0.20000 9660.0n 0.20000 9799.9n 0.20000 9800.0n 0.20000 9939.9n 0.20000 9940.0n 0.20000 10079.9n 0.20000 10080.0n 0.20000 10219.9n 0.20000 10220.0n 0.20000 10359.9n 0.20000 10360.0n 0.20000 10499.9n 0.20000 10500.0n 0.20000 10639.9n 0.20000 10640.0n 0.20000 10779.9n 0.20000 10780.0n 0.20000 10919.9n 0.20000 10920.0n 0.20000 11059.9n 0.20000 11060.0n 0.20000 11199.9n 0.20000 11200.0n 0.20000 11339.9n 0.20000 11340.0n 0.20000 11479.9n 0.20000 11480.0n 0.20000 11619.9n 0.20000 11620.0n 0.20000 11759.9n 0.20000 11760.0n 0.20000 11899.9n 0.20000 11900.0n 0.20000 12039.9n 0.20000 12040.0n 0.20000 12179.9n 0.20000 12180.0n 0.20000 12319.9n 0.20000 12320.0n 0.20000 12459.9n 0.20000 12460.0n 0.20000 12599.9n 0.20000 12600.0n 0.20000 12739.9n 0.20000 12740.0n 0.20000 12879.9n 0.20000 12880.0n 0.20000 13019.9n 0.20000 13020.0n 0.20000 13159.9n 0.20000 13160.0n 0.20000 13299.9n 0.20000 13300.0n 0.20000 13439.9n 0.20000 13440.0n 0.20000 13579.9n 0.20000 13580.0n 0.20000 13719.9n 0.20000 13720.0n 0.20000 13859.9n 0.20000 13860.0n 0.20000 13999.9n 0.20000 14000.0n 0.20000 14139.9n 0.20000 14140.0n 0.20000 14279.9n 0.20000 14280.0n 0.20000 14419.9n 0.20000 14420.0n 0.20000 14559.9n 0.20000 14560.0n 0.20000 14699.9n 0.20000 14700.0n 0.20000 14839.9n 0.20000 14840.0n 0.20000 14979.9n 0.20000 14980.0n 0.20000 15119.9n 0.20000 15120.0n 0.20000 15259.9n 0.20000 15260.0n 0.20000 15399.9n 0.20000 15400.0n 0.20000 15539.9n 0.20000 15540.0n 0.20000 15679.9n 0.20000 15680.0n 0.20000 15819.9n 0.20000 15820.0n 0.20000 15959.9n 0.20000 15960.0n 0.20000 16099.9n 0.20000 16100.0n 0.20000 16239.9n 0.20000 16240.0n 0.20000 16379.9n 0.20000 16380.0n 0.20000 16519.9n 0.20000 16520.0n 0.20000 16659.9n 0.20000 16660.0n 0.20000 16799.9n 0.20000 16800.0n 0.20000 16939.9n 0.20000 16940.0n 0.20000 17079.9n 0.20000 17080.0n 0.20000 17219.9n 0.20000 17220.0n 0.20000 17359.9n 0.20000 17360.0n 0.20000 17499.9n 0.20000 17500.0n 0.20000 17639.9n 0.20000 17640.0n 0.20000 17779.9n 0.20000 17780.0n 0.20000 17919.9n 0.20000 17920.0n 0.20000 18059.9n 0.20000 18060.0n 0.20000 18199.9n 0.20000 18200.0n 0.20000 18339.9n 0.20000 18340.0n 0.20000 18479.9n 0.20000 18480.0n 0.20000 18619.9n 0.20000 18620.0n 0.20000 18759.9n 0.20000 18760.0n 0.20000 18899.9n 0.20000 18900.0n 0.20000 19039.9n 0.20000 19040.0n 0.20000 19179.9n 0.20000 19180.0n 0.20000 19319.9n 0.20000 19320.0n 0.20000 19459.9n 0.20000 19460.0n 0.20000 19599.9n 0.20000 19600.0n 0.20000 19739.9n 0.20000 19740.0n 0.20000 19879.9n 0.20000 19880.0n 0.20000 20019.9n 0.20000 20020.0n 0.20000 20159.9n 0.20000 20160.0n 0.20000 20299.9n 0.20000 20300.0n 0.20000 20439.9n 0.20000 20440.0n 0.20000 20579.9n 0.20000 20580.0n 0.20000 20719.9n 0.20000 20720.0n 0.20000 20859.9n 0.20000 20860.0n 0.20000 20999.9n 0.20000 21000.0n 0.20000 21139.9n 0.20000 21140.0n 0.20000 21279.9n 0.20000 21280.0n 0.20000 21419.9n 0.20000 21420.0n 0.20000 21559.9n 0.20000 21560.0n 0.20000 21699.9n 0.20000 21700.0n 0.20000 21839.9n 0.20000 21840.0n 0.20000 21979.9n 0.20000 21980.0n 0.20000 22119.9n 0.20000 22120.0n 0.20000 22259.9n 0.20000 22260.0n 0.20000 22399.9n 0.20000 22400.0n 0.20000 22539.9n 0.20000 22540.0n 0.20000 22679.9n 0.20000 22680.0n 0.20000 22819.9n 0.20000 22820.0n 0.20000 22959.9n 0.20000 22960.0n 0.20000 23099.9n 0.20000 23100.0n 0.20000 23239.9n 0.20000 23240.0n 0.20000 23379.9n 0.20000 23380.0n 0.20000 23519.9n 0.20000 23520.0n 0.20000 23659.9n 0.20000 23660.0n 0.20000 23799.9n 0.20000 23800.0n 0.20000 23939.9n 0.20000 23940.0n 0.20000 24079.9n 0.20000 24080.0n 0.20000 24219.9n 0.20000 24220.0n 0.20000 24359.9n 0.20000 24360.0n 0.20000 24499.9n 0.20000 24500.0n 0.20000 24639.9n 0.20000 24640.0n 0.20000 24779.9n 0.20000 24780.0n 0.20000 24919.9n 0.20000 24920.0n 0.20000 25059.9n 0.20000 25060.0n 0.20000 25199.9n 0.20000 25200.0n 0.20000 25339.9n 0.20000 25340.0n 0.20000 25479.9n 0.20000 25480.0n 0.20000 25619.9n 0.20000 25620.0n 0.20000 25759.9n 0.20000 25760.0n 0.20000 25899.9n 0.20000 25900.0n 0.20000 26039.9n 0.20000 26040.0n 0.20000 26179.9n 0.20000 26180.0n 0.20000 26319.9n 0.20000 26320.0n 0.20000 26459.9n 0.20000 26460.0n 0.20000 26599.9n 0.20000 26600.0n 0.20000 26739.9n 0.20000 26740.0n 0.20000 26879.9n 0.20000 26880.0n 0.20000 27019.9n 0.20000 27020.0n 0.20000 27159.9n 0.20000 27160.0n 0.20000 27299.9n 0.20000 27300.0n 0.20000 27439.9n 0.20000 27440.0n 0.20000 27579.9n 0.20000 27580.0n 0.20000 27719.9n 0.20000 27720.0n 0.20000 27859.9n 0.20000 27860.0n 0.20000 27999.9n 0.20000 28000.0n 0.20000 28139.9n 0.20000 28140.0n 0.20000 28279.9n 0.20000 28280.0n 0.20000 28419.9n 0.20000 28420.0n 0.20000 28559.9n 0.20000 28560.0n 0.20000 28699.9n 0.20000 28700.0n 0.20000 28839.9n 0.20000 28840.0n 0.20000 28979.9n 0.20000 28980.0n 0.20000 29119.9n 0.20000 29120.0n 0.20000 29259.9n 0.20000 29260.0n 0.20000 29399.9n 0.20000 29400.0n 0.20000 29539.9n 0.20000 29540.0n 0.20000 29679.9n 0.20000 29680.0n 0.20000 29819.9n 0.20000 29820.0n 0.20000 29959.9n 0.20000 29960.0n 0.20000 30099.9n 0.20000 30100.0n 0.20000 30239.9n 0.20000 30240.0n 0.20000 30379.9n 0.20000 30380.0n 0.20000 30519.9n 0.20000 30520.0n 0.20000 30659.9n 0.20000 30660.0n 0.20000 30799.9n 0.20000 30800.0n 0.20000 30939.9n 0.20000 30940.0n 0.20000 31079.9n 0.20000 31080.0n 0.20000 31219.9n 0.20000 31220.0n 0.20000 31359.9n 0.20000 31360.0n 0.20000 31499.9n 0.20000 31500.0n 0.20000 31639.9n 0.20000 31640.0n 0.20000 31779.9n 0.20000 31780.0n 0.20000 31919.9n 0.20000 31920.0n 0.20000 32059.9n 0.20000 32060.0n 0.20000 32199.9n 0.20000 32200.0n 0.20000 32339.9n 0.20000 32340.0n 0.20000 32479.9n 0.20000 32480.0n 0.20000 32619.9n 0.20000 32620.0n 0.20000 32759.9n 0.20000 32760.0n 0.20000 32899.9n 0.20000 32900.0n 0.20000 33039.9n 0.20000 33040.0n 0.20000 33179.9n 0.20000 33180.0n 0.20000 33319.9n 0.20000 33320.0n 0.20000 33459.9n 0.20000 33460.0n 0.20000 33599.9n 0.20000 33600.0n 0.20000 33739.9n 0.20000 33740.0n 0.20000 33879.9n 0.20000 33880.0n 0.20000 34019.9n 0.20000 34020.0n 0.20000 34159.9n 0.20000 34160.0n 0.20000 34299.9n 0.20000 34300.0n 0.20000 34439.9n 0.20000 34440.0n 0.20000 34579.9n 0.20000 34580.0n 0.20000 34719.9n 0.20000 34720.0n 0.20000 34859.9n 0.20000 34860.0n 0.20000 34999.9n 0.20000 35000.0n 0.20000 35139.9n 0.20000 35140.0n 0.20000 35279.9n 0.20000 35280.0n 0.20000 35419.9n 0.20000 35420.0n 0.20000 35559.9n 0.20000 35560.0n 0.20000 35699.9n 0.20000 35700.0n 0.20000 35839.9n 0.20000 35840.0n 0.20000 35979.9n 0.20000 35980.0n 0.20000 36119.9n 0.20000 36120.0n 0.20000 36259.9n 0.20000 36260.0n 0.20000 36399.9n 0.20000 36400.0n 0.20000 36539.9n 0.20000 36540.0n 0.20000 36679.9n 0.20000 36680.0n 0.20000 36819.9n 0.20000 36820.0n 0.20000 36959.9n 0.20000 36960.0n 0.20000 37099.9n 0.20000 37100.0n 0.20000 37239.9n 0.20000 37240.0n 0.20000 37379.9n 0.20000 37380.0n 0.20000 37519.9n 0.20000 37520.0n 0.20000 37659.9n 0.20000 37660.0n 0.20000 37799.9n 0.20000 37800.0n 0.20000 37939.9n 0.20000 37940.0n 0.20000 38079.9n 0.20000 38080.0n 0.20000 38219.9n 0.20000 38220.0n 0.20000 38359.9n 0.20000 38360.0n 0.20000 38499.9n 0.20000 38500.0n 0.20000 38639.9n 0.20000 38640.0n 0.20000 38779.9n 0.20000 38780.0n 0.20000 38919.9n 0.20000 38920.0n 0.20000 39059.9n 0.20000 39060.0n 0.20000 39199.9n 0.20000 39200.0n 0.20000 39339.9n 0.20000 39340.0n 0.20000 39479.9n 0.20000 39480.0n 0.20000 39619.9n 0.20000 39620.0n 0.20000 39759.9n 0.20000 39760.0n 0.20000 39899.9n 0.20000 39900.0n 0.20000 40039.9n 0.20000 40040.0n 0.20000 40179.9n 0.20000 40180.0n 0.20000 40319.9n 0.20000 40320.0n 0.20000 40459.9n 0.20000 40460.0n 0.20000 40599.9n 0.20000 40600.0n 0.20000 40739.9n 0.20000 40740.0n 0.20000 40879.9n 0.20000 40880.0n 0.20000 41019.9n 0.20000 41020.0n 0.20000 41159.9n 0.20000 41160.0n 0.20000 41299.9n 0.20000 41300.0n 0.20000 41439.9n 0.20000 41440.0n 0.20000 41579.9n 0.20000 41580.0n 0.20000 41719.9n 0.20000 41720.0n 0.20000 41859.9n 0.20000 41860.0n 0.20000 41999.9n 0.20000 42000.0n 0.20000 42139.9n 0.20000 42140.0n 0.20000 42279.9n 0.20000 42280.0n 0.20000 42419.9n 0.20000 42420.0n 0.20000 42559.9n 0.20000 42560.0n 0.20000 42699.9n 0.20000 42700.0n 0.20000 42839.9n 0.20000 42840.0n 0.20000 42979.9n 0.20000 42980.0n 0.20000 43119.9n 0.20000 43120.0n 0.20000 43259.9n 0.20000 43260.0n 0.20000 43399.9n 0.20000 43400.0n 0.20000 43539.9n 0.20000 43540.0n 0.20000 43679.9n 0.20000 43680.0n 0.20000 43819.9n 0.20000 43820.0n 0.20000 43959.9n 0.20000 43960.0n 0.20000 44099.9n 0.20000 44100.0n 0.20000 44239.9n 0.20000 44240.0n 0.20000 44379.9n 0.20000 44380.0n 0.20000 44519.9n 0.20000 44520.0n 0.20000 44659.9n 0.20000 44660.0n 0.20000 44799.9n 0.20000 44800.0n 0.20000 44939.9n 0.20000 44940.0n 0.20000 45079.9n 0.20000 45080.0n 0.20000 45219.9n 0.20000 45220.0n 0.20000 45359.9n 0.20000 45360.0n 0.20000 45499.9n 0.20000 45500.0n 0.20000 45639.9n 0.20000 45640.0n 0.20000 45779.9n 0.20000 45780.0n 0.20000 45919.9n 0.20000 45920.0n 0.20000 46059.9n 0.20000 46060.0n 0.20000 46199.9n 0.20000 46200.0n 0.20000 46339.9n 0.20000 46340.0n 0.20000 46479.9n 0.20000 46480.0n 0.20000 46619.9n 0.20000 46620.0n 0.20000 46759.9n 0.20000 46760.0n 0.20000 46899.9n 0.20000 46900.0n 0.20000 47039.9n 0.20000 47040.0n 0.20000 47179.9n 0.20000 47180.0n 0.20000 47319.9n 0.20000 47320.0n 0.20000 47459.9n 0.20000 47460.0n 0.20000 47599.9n 0.20000 47600.0n 0.20000 47739.9n 0.20000 47740.0n 0.20000 47879.9n 0.20000 47880.0n 0.20000 48019.9n 0.20000 48020.0n 0.20000 48159.9n 0.20000 48160.0n 0.20000 48299.9n 0.20000 48300.0n 0.20000 48439.9n 0.20000 48440.0n 0.20000 48579.9n 0.20000 48580.0n 0.20000 48719.9n 0.20000 48720.0n 0.20000 48859.9n 0.20000 48860.0n 0.20000 48999.9n 0.20000 49000.0n 0.20000 49139.9n 0.20000 49140.0n 0.20000 49279.9n 0.20000 49280.0n 0.20000 49419.9n 0.20000 49420.0n 0.20000 49559.9n 0.20000 49560.0n 0.20000 49699.9n 0.20000 49700.0n 0.20000 49839.9n 0.20000 49840.0n 0.20000 49979.9n 0.20000 49980.0n 0.20000 50119.9n 0.20000 50120.0n 0.20000 50259.9n 0.20000 50260.0n 0.20000 50399.9n 0.20000 50400.0n 0.20000 50539.9n 0.20000 50540.0n 0.20000 50679.9n 0.20000 50680.0n 0.20000 50819.9n 0.20000 50820.0n 0.20000 50959.9n 0.20000 50960.0n 0.20000 51099.9n 0.20000 51100.0n 0.20000 51239.9n 0.20000 51240.0n 0.20000 51379.9n 0.20000 51380.0n 0.20000 51519.9n 0.20000 51520.0n 0.20000 51659.9n 0.20000 51660.0n 0.20000 51799.9n 0.20000 51800.0n 0.20000 51939.9n 0.20000 51940.0n 0.20000 52079.9n 0.20000 52080.0n 0.20000 52219.9n 0.20000 52220.0n 0.20000 52359.9n 0.20000 52360.0n 0.20000 52499.9n 0.20000 52500.0n 0.20000)
Vxop0 xop0 0 PWL(0.0n 0.55000 139.9n 0.55000 140.0n 0.45000 279.9n 0.45000 280.0n 0.55000 419.9n 0.55000 420.0n 0.45000 559.9n 0.45000 560.0n 0.45000 699.9n 0.45000 700.0n 0.45000 839.9n 0.45000 840.0n 0.45000 979.9n 0.45000 980.0n 0.55000 1119.9n 0.55000 1120.0n 0.55000 1259.9n 0.55000 1260.0n 0.45000 1399.9n 0.45000 1400.0n 0.55000 1539.9n 0.55000 1540.0n 0.45000 1679.9n 0.45000 1680.0n 0.45000 1819.9n 0.45000 1820.0n 0.55000 1959.9n 0.55000 1960.0n 0.45000 2099.9n 0.45000 2100.0n 0.55000 2239.9n 0.55000 2240.0n 0.55000 2379.9n 0.55000 2380.0n 0.55000 2519.9n 0.55000 2520.0n 0.55000 2659.9n 0.55000 2660.0n 0.55000 2799.9n 0.55000 2800.0n 0.45000 2939.9n 0.45000 2940.0n 0.45000 3079.9n 0.45000 3080.0n 0.45000 3219.9n 0.45000 3220.0n 0.55000 3359.9n 0.55000 3360.0n 0.45000 3499.9n 0.45000 3500.0n 0.55000 3639.9n 0.55000 3640.0n 0.55000 3779.9n 0.55000 3780.0n 0.45000 3919.9n 0.45000 3920.0n 0.55000 4059.9n 0.55000 4060.0n 0.45000 4199.9n 0.45000 4200.0n 0.45000 4339.9n 0.45000 4340.0n 0.55000 4479.9n 0.55000 4480.0n 0.55000 4619.9n 0.55000 4620.0n 0.45000 4759.9n 0.45000 4760.0n 0.55000 4899.9n 0.55000 4900.0n 0.45000 5039.9n 0.45000 5040.0n 0.55000 5179.9n 0.55000 5180.0n 0.45000 5319.9n 0.45000 5320.0n 0.55000 5459.9n 0.55000 5460.0n 0.55000 5599.9n 0.55000 5600.0n 0.45000 5739.9n 0.45000 5740.0n 0.45000 5879.9n 0.45000 5880.0n 0.55000 6019.9n 0.55000 6020.0n 0.55000 6159.9n 0.55000 6160.0n 0.45000 6299.9n 0.45000 6300.0n 0.45000 6439.9n 0.45000 6440.0n 0.55000 6579.9n 0.55000 6580.0n 0.45000 6719.9n 0.45000 6720.0n 0.45000 6859.9n 0.45000 6860.0n 0.55000 6999.9n 0.55000 7000.0n 0.45000 7139.9n 0.45000 7140.0n 0.45000 7279.9n 0.45000 7280.0n 0.55000 7419.9n 0.55000 7420.0n 0.55000 7559.9n 0.55000 7560.0n 0.55000 7699.9n 0.55000 7700.0n 0.45000 7839.9n 0.45000 7840.0n 0.55000 7979.9n 0.55000 7980.0n 0.55000 8119.9n 0.55000 8120.0n 0.45000 8259.9n 0.45000 8260.0n 0.45000 8399.9n 0.45000 8400.0n 0.55000 8539.9n 0.55000 8540.0n 0.55000 8679.9n 0.55000 8680.0n 0.55000 8819.9n 0.55000 8820.0n 0.45000 8959.9n 0.45000 8960.0n 0.45000 9099.9n 0.45000 9100.0n 0.45000 9239.9n 0.45000 9240.0n 0.55000 9379.9n 0.55000 9380.0n 0.55000 9519.9n 0.55000 9520.0n 0.55000 9659.9n 0.55000 9660.0n 0.45000 9799.9n 0.45000 9800.0n 0.45000 9939.9n 0.45000 9940.0n 0.45000 10079.9n 0.45000 10080.0n 0.45000 10219.9n 0.45000 10220.0n 0.45000 10359.9n 0.45000 10360.0n 0.55000 10499.9n 0.55000 10500.0n 0.45000 10639.9n 0.45000 10640.0n 0.55000 10779.9n 0.55000 10780.0n 0.45000 10919.9n 0.45000 10920.0n 0.55000 11059.9n 0.55000 11060.0n 0.45000 11199.9n 0.45000 11200.0n 0.55000 11339.9n 0.55000 11340.0n 0.45000 11479.9n 0.45000 11480.0n 0.55000 11619.9n 0.55000 11620.0n 0.45000 11759.9n 0.45000 11760.0n 0.55000 11899.9n 0.55000 11900.0n 0.55000 12039.9n 0.55000 12040.0n 0.45000 12179.9n 0.45000 12180.0n 0.55000 12319.9n 0.55000 12320.0n 0.55000 12459.9n 0.55000 12460.0n 0.55000 12599.9n 0.55000 12600.0n 0.55000 12739.9n 0.55000 12740.0n 0.45000 12879.9n 0.45000 12880.0n 0.45000 13019.9n 0.45000 13020.0n 0.55000 13159.9n 0.55000 13160.0n 0.45000 13299.9n 0.45000 13300.0n 0.45000 13439.9n 0.45000 13440.0n 0.55000 13579.9n 0.55000 13580.0n 0.45000 13719.9n 0.45000 13720.0n 0.45000 13859.9n 0.45000 13860.0n 0.55000 13999.9n 0.55000 14000.0n 0.55000 14139.9n 0.55000 14140.0n 0.45000 14279.9n 0.45000 14280.0n 0.55000 14419.9n 0.55000 14420.0n 0.45000 14559.9n 0.45000 14560.0n 0.55000 14699.9n 0.55000 14700.0n 0.55000 14839.9n 0.55000 14840.0n 0.45000 14979.9n 0.45000 14980.0n 0.45000 15119.9n 0.45000 15120.0n 0.45000 15259.9n 0.45000 15260.0n 0.45000 15399.9n 0.45000 15400.0n 0.55000 15539.9n 0.55000 15540.0n 0.55000 15679.9n 0.55000 15680.0n 0.45000 15819.9n 0.45000 15820.0n 0.45000 15959.9n 0.45000 15960.0n 0.45000 16099.9n 0.45000 16100.0n 0.45000 16239.9n 0.45000 16240.0n 0.55000 16379.9n 0.55000 16380.0n 0.55000 16519.9n 0.55000 16520.0n 0.55000 16659.9n 0.55000 16660.0n 0.55000 16799.9n 0.55000 16800.0n 0.45000 16939.9n 0.45000 16940.0n 0.45000 17079.9n 0.45000 17080.0n 0.45000 17219.9n 0.45000 17220.0n 0.45000 17359.9n 0.45000 17360.0n 0.55000 17499.9n 0.55000 17500.0n 0.55000 17639.9n 0.55000 17640.0n 0.45000 17779.9n 0.45000 17780.0n 0.55000 17919.9n 0.55000 17920.0n 0.55000 18059.9n 0.55000 18060.0n 0.55000 18199.9n 0.55000 18200.0n 0.45000 18339.9n 0.45000 18340.0n 0.45000 18479.9n 0.45000 18480.0n 0.45000 18619.9n 0.45000 18620.0n 0.55000 18759.9n 0.55000 18760.0n 0.45000 18899.9n 0.45000 18900.0n 0.45000 19039.9n 0.45000 19040.0n 0.55000 19179.9n 0.55000 19180.0n 0.55000 19319.9n 0.55000 19320.0n 0.55000 19459.9n 0.55000 19460.0n 0.55000 19599.9n 0.55000 19600.0n 0.45000 19739.9n 0.45000 19740.0n 0.45000 19879.9n 0.45000 19880.0n 0.55000 20019.9n 0.55000 20020.0n 0.55000 20159.9n 0.55000 20160.0n 0.45000 20299.9n 0.45000 20300.0n 0.55000 20439.9n 0.55000 20440.0n 0.55000 20579.9n 0.55000 20580.0n 0.55000 20719.9n 0.55000 20720.0n 0.55000 20859.9n 0.55000 20860.0n 0.45000 20999.9n 0.45000 21000.0n 0.45000 21139.9n 0.45000 21140.0n 0.55000 21279.9n 0.55000 21280.0n 0.55000 21419.9n 0.55000 21420.0n 0.55000 21559.9n 0.55000 21560.0n 0.45000 21699.9n 0.45000 21700.0n 0.45000 21839.9n 0.45000 21840.0n 0.55000 21979.9n 0.55000 21980.0n 0.55000 22119.9n 0.55000 22120.0n 0.45000 22259.9n 0.45000 22260.0n 0.45000 22399.9n 0.45000 22400.0n 0.55000 22539.9n 0.55000 22540.0n 0.55000 22679.9n 0.55000 22680.0n 0.45000 22819.9n 0.45000 22820.0n 0.45000 22959.9n 0.45000 22960.0n 0.45000 23099.9n 0.45000 23100.0n 0.45000 23239.9n 0.45000 23240.0n 0.45000 23379.9n 0.45000 23380.0n 0.55000 23519.9n 0.55000 23520.0n 0.55000 23659.9n 0.55000 23660.0n 0.45000 23799.9n 0.45000 23800.0n 0.55000 23939.9n 0.55000 23940.0n 0.55000 24079.9n 0.55000 24080.0n 0.55000 24219.9n 0.55000 24220.0n 0.45000 24359.9n 0.45000 24360.0n 0.55000 24499.9n 0.55000 24500.0n 0.55000 24639.9n 0.55000 24640.0n 0.55000 24779.9n 0.55000 24780.0n 0.45000 24919.9n 0.45000 24920.0n 0.45000 25059.9n 0.45000 25060.0n 0.55000 25199.9n 0.55000 25200.0n 0.45000 25339.9n 0.45000 25340.0n 0.45000 25479.9n 0.45000 25480.0n 0.45000 25619.9n 0.45000 25620.0n 0.45000 25759.9n 0.45000 25760.0n 0.45000 25899.9n 0.45000 25900.0n 0.55000 26039.9n 0.55000 26040.0n 0.55000 26179.9n 0.55000 26180.0n 0.55000 26319.9n 0.55000 26320.0n 0.45000 26459.9n 0.45000 26460.0n 0.55000 26599.9n 0.55000 26600.0n 0.45000 26739.9n 0.45000 26740.0n 0.45000 26879.9n 0.45000 26880.0n 0.45000 27019.9n 0.45000 27020.0n 0.45000 27159.9n 0.45000 27160.0n 0.55000 27299.9n 0.55000 27300.0n 0.55000 27439.9n 0.55000 27440.0n 0.45000 27579.9n 0.45000 27580.0n 0.45000 27719.9n 0.45000 27720.0n 0.45000 27859.9n 0.45000 27860.0n 0.55000 27999.9n 0.55000 28000.0n 0.55000 28139.9n 0.55000 28140.0n 0.45000 28279.9n 0.45000 28280.0n 0.45000 28419.9n 0.45000 28420.0n 0.55000 28559.9n 0.55000 28560.0n 0.45000 28699.9n 0.45000 28700.0n 0.55000 28839.9n 0.55000 28840.0n 0.45000 28979.9n 0.45000 28980.0n 0.55000 29119.9n 0.55000 29120.0n 0.55000 29259.9n 0.55000 29260.0n 0.55000 29399.9n 0.55000 29400.0n 0.45000 29539.9n 0.45000 29540.0n 0.45000 29679.9n 0.45000 29680.0n 0.55000 29819.9n 0.55000 29820.0n 0.45000 29959.9n 0.45000 29960.0n 0.55000 30099.9n 0.55000 30100.0n 0.55000 30239.9n 0.55000 30240.0n 0.45000 30379.9n 0.45000 30380.0n 0.45000 30519.9n 0.45000 30520.0n 0.55000 30659.9n 0.55000 30660.0n 0.55000 30799.9n 0.55000 30800.0n 0.45000 30939.9n 0.45000 30940.0n 0.55000 31079.9n 0.55000 31080.0n 0.45000 31219.9n 0.45000 31220.0n 0.45000 31359.9n 0.45000 31360.0n 0.55000 31499.9n 0.55000 31500.0n 0.55000 31639.9n 0.55000 31640.0n 0.55000 31779.9n 0.55000 31780.0n 0.45000 31919.9n 0.45000 31920.0n 0.45000 32059.9n 0.45000 32060.0n 0.45000 32199.9n 0.45000 32200.0n 0.55000 32339.9n 0.55000 32340.0n 0.45000 32479.9n 0.45000 32480.0n 0.55000 32619.9n 0.55000 32620.0n 0.45000 32759.9n 0.45000 32760.0n 0.55000 32899.9n 0.55000 32900.0n 0.55000 33039.9n 0.55000 33040.0n 0.55000 33179.9n 0.55000 33180.0n 0.45000 33319.9n 0.45000 33320.0n 0.55000 33459.9n 0.55000 33460.0n 0.45000 33599.9n 0.45000 33600.0n 0.55000 33739.9n 0.55000 33740.0n 0.55000 33879.9n 0.55000 33880.0n 0.55000 34019.9n 0.55000 34020.0n 0.55000 34159.9n 0.55000 34160.0n 0.55000 34299.9n 0.55000 34300.0n 0.55000 34439.9n 0.55000 34440.0n 0.55000 34579.9n 0.55000 34580.0n 0.45000 34719.9n 0.45000 34720.0n 0.55000 34859.9n 0.55000 34860.0n 0.45000 34999.9n 0.45000 35000.0n 0.45000 35139.9n 0.45000 35140.0n 0.55000 35279.9n 0.55000 35280.0n 0.45000 35419.9n 0.45000 35420.0n 0.45000 35559.9n 0.45000 35560.0n 0.45000 35699.9n 0.45000 35700.0n 0.45000 35839.9n 0.45000 35840.0n 0.45000 35979.9n 0.45000 35980.0n 0.45000 36119.9n 0.45000 36120.0n 0.45000 36259.9n 0.45000 36260.0n 0.45000 36399.9n 0.45000 36400.0n 0.55000 36539.9n 0.55000 36540.0n 0.45000 36679.9n 0.45000 36680.0n 0.55000 36819.9n 0.55000 36820.0n 0.55000 36959.9n 0.55000 36960.0n 0.45000 37099.9n 0.45000 37100.0n 0.55000 37239.9n 0.55000 37240.0n 0.55000 37379.9n 0.55000 37380.0n 0.45000 37519.9n 0.45000 37520.0n 0.45000 37659.9n 0.45000 37660.0n 0.45000 37799.9n 0.45000 37800.0n 0.45000 37939.9n 0.45000 37940.0n 0.55000 38079.9n 0.55000 38080.0n 0.55000 38219.9n 0.55000 38220.0n 0.55000 38359.9n 0.55000 38360.0n 0.55000 38499.9n 0.55000 38500.0n 0.55000 38639.9n 0.55000 38640.0n 0.45000 38779.9n 0.45000 38780.0n 0.45000 38919.9n 0.45000 38920.0n 0.45000 39059.9n 0.45000 39060.0n 0.55000 39199.9n 0.55000 39200.0n 0.55000 39339.9n 0.55000 39340.0n 0.45000 39479.9n 0.45000 39480.0n 0.45000 39619.9n 0.45000 39620.0n 0.55000 39759.9n 0.55000 39760.0n 0.55000 39899.9n 0.55000 39900.0n 0.45000 40039.9n 0.45000 40040.0n 0.45000 40179.9n 0.45000 40180.0n 0.55000 40319.9n 0.55000 40320.0n 0.45000 40459.9n 0.45000 40460.0n 0.55000 40599.9n 0.55000 40600.0n 0.45000 40739.9n 0.45000 40740.0n 0.55000 40879.9n 0.55000 40880.0n 0.45000 41019.9n 0.45000 41020.0n 0.55000 41159.9n 0.55000 41160.0n 0.55000 41299.9n 0.55000 41300.0n 0.55000 41439.9n 0.55000 41440.0n 0.55000 41579.9n 0.55000 41580.0n 0.55000 41719.9n 0.55000 41720.0n 0.55000 41859.9n 0.55000 41860.0n 0.45000 41999.9n 0.45000 42000.0n 0.55000 42139.9n 0.55000 42140.0n 0.45000 42279.9n 0.45000 42280.0n 0.45000 42419.9n 0.45000 42420.0n 0.45000 42559.9n 0.45000 42560.0n 0.55000 42699.9n 0.55000 42700.0n 0.45000 42839.9n 0.45000 42840.0n 0.45000 42979.9n 0.45000 42980.0n 0.55000 43119.9n 0.55000 43120.0n 0.45000 43259.9n 0.45000 43260.0n 0.45000 43399.9n 0.45000 43400.0n 0.45000 43539.9n 0.45000 43540.0n 0.55000 43679.9n 0.55000 43680.0n 0.55000 43819.9n 0.55000 43820.0n 0.55000 43959.9n 0.55000 43960.0n 0.55000 44099.9n 0.55000 44100.0n 0.55000 44239.9n 0.55000 44240.0n 0.55000 44379.9n 0.55000 44380.0n 0.45000 44519.9n 0.45000 44520.0n 0.45000 44659.9n 0.45000 44660.0n 0.45000 44799.9n 0.45000 44800.0n 0.45000 44939.9n 0.45000 44940.0n 0.55000 45079.9n 0.55000 45080.0n 0.55000 45219.9n 0.55000 45220.0n 0.55000 45359.9n 0.55000 45360.0n 0.55000 45499.9n 0.55000 45500.0n 0.55000 45639.9n 0.55000 45640.0n 0.45000 45779.9n 0.45000 45780.0n 0.45000 45919.9n 0.45000 45920.0n 0.45000 46059.9n 0.45000 46060.0n 0.45000 46199.9n 0.45000 46200.0n 0.45000 46339.9n 0.45000 46340.0n 0.45000 46479.9n 0.45000 46480.0n 0.45000 46619.9n 0.45000 46620.0n 0.55000 46759.9n 0.55000 46760.0n 0.55000 46899.9n 0.55000 46900.0n 0.45000 47039.9n 0.45000 47040.0n 0.50000 47179.9n 0.50000 47180.0n 0.50000 47319.9n 0.50000 47320.0n 0.50000 47459.9n 0.50000 47460.0n 0.50000 47599.9n 0.50000 47600.0n 0.50000 47739.9n 0.50000 47740.0n 0.50000 47879.9n 0.50000 47880.0n 0.50000 48019.9n 0.50000 48020.0n 0.50000 48159.9n 0.50000 48160.0n 0.50000 48299.9n 0.50000 48300.0n 0.50000 48439.9n 0.50000 48440.0n 0.50000 48579.9n 0.50000 48580.0n 0.50000 48719.9n 0.50000 48720.0n 0.50000 48859.9n 0.50000 48860.0n 0.50000 48999.9n 0.50000 49000.0n 0.50000 49139.9n 0.50000 49140.0n 0.50000 49279.9n 0.50000 49280.0n 0.50000 49419.9n 0.50000 49420.0n 0.50000 49559.9n 0.50000 49560.0n 0.50000 49699.9n 0.50000 49700.0n 0.50000 49839.9n 0.50000 49840.0n 0.50000 49979.9n 0.50000 49980.0n 0.50000 50119.9n 0.50000 50120.0n 0.50000 50259.9n 0.50000 50260.0n 0.50000 50399.9n 0.50000 50400.0n 0.50000 50539.9n 0.50000 50540.0n 0.50000 50679.9n 0.50000 50680.0n 0.50000 50819.9n 0.50000 50820.0n 0.50000 50959.9n 0.50000 50960.0n 0.50000 51099.9n 0.50000 51100.0n 0.50000 51239.9n 0.50000 51240.0n 0.50000 51379.9n 0.50000 51380.0n 0.50000 51519.9n 0.50000 51520.0n 0.50000 51659.9n 0.50000 51660.0n 0.50000 51799.9n 0.50000 51800.0n 0.50000 51939.9n 0.50000 51940.0n 0.50000 52079.9n 0.50000 52080.0n 0.50000 52219.9n 0.50000 52220.0n 0.50000 52359.9n 0.50000 52360.0n 0.50000 52499.9n 0.50000 52500.0n 0.50000)
Vxon0 xon0 0 PWL(0.0n 0.45000 139.9n 0.45000 140.0n 0.55000 279.9n 0.55000 280.0n 0.45000 419.9n 0.45000 420.0n 0.55000 559.9n 0.55000 560.0n 0.55000 699.9n 0.55000 700.0n 0.55000 839.9n 0.55000 840.0n 0.55000 979.9n 0.55000 980.0n 0.45000 1119.9n 0.45000 1120.0n 0.45000 1259.9n 0.45000 1260.0n 0.55000 1399.9n 0.55000 1400.0n 0.45000 1539.9n 0.45000 1540.0n 0.55000 1679.9n 0.55000 1680.0n 0.55000 1819.9n 0.55000 1820.0n 0.45000 1959.9n 0.45000 1960.0n 0.55000 2099.9n 0.55000 2100.0n 0.45000 2239.9n 0.45000 2240.0n 0.45000 2379.9n 0.45000 2380.0n 0.45000 2519.9n 0.45000 2520.0n 0.45000 2659.9n 0.45000 2660.0n 0.45000 2799.9n 0.45000 2800.0n 0.55000 2939.9n 0.55000 2940.0n 0.55000 3079.9n 0.55000 3080.0n 0.55000 3219.9n 0.55000 3220.0n 0.45000 3359.9n 0.45000 3360.0n 0.55000 3499.9n 0.55000 3500.0n 0.45000 3639.9n 0.45000 3640.0n 0.45000 3779.9n 0.45000 3780.0n 0.55000 3919.9n 0.55000 3920.0n 0.45000 4059.9n 0.45000 4060.0n 0.55000 4199.9n 0.55000 4200.0n 0.55000 4339.9n 0.55000 4340.0n 0.45000 4479.9n 0.45000 4480.0n 0.45000 4619.9n 0.45000 4620.0n 0.55000 4759.9n 0.55000 4760.0n 0.45000 4899.9n 0.45000 4900.0n 0.55000 5039.9n 0.55000 5040.0n 0.45000 5179.9n 0.45000 5180.0n 0.55000 5319.9n 0.55000 5320.0n 0.45000 5459.9n 0.45000 5460.0n 0.45000 5599.9n 0.45000 5600.0n 0.55000 5739.9n 0.55000 5740.0n 0.55000 5879.9n 0.55000 5880.0n 0.45000 6019.9n 0.45000 6020.0n 0.45000 6159.9n 0.45000 6160.0n 0.55000 6299.9n 0.55000 6300.0n 0.55000 6439.9n 0.55000 6440.0n 0.45000 6579.9n 0.45000 6580.0n 0.55000 6719.9n 0.55000 6720.0n 0.55000 6859.9n 0.55000 6860.0n 0.45000 6999.9n 0.45000 7000.0n 0.55000 7139.9n 0.55000 7140.0n 0.55000 7279.9n 0.55000 7280.0n 0.45000 7419.9n 0.45000 7420.0n 0.45000 7559.9n 0.45000 7560.0n 0.45000 7699.9n 0.45000 7700.0n 0.55000 7839.9n 0.55000 7840.0n 0.45000 7979.9n 0.45000 7980.0n 0.45000 8119.9n 0.45000 8120.0n 0.55000 8259.9n 0.55000 8260.0n 0.55000 8399.9n 0.55000 8400.0n 0.45000 8539.9n 0.45000 8540.0n 0.45000 8679.9n 0.45000 8680.0n 0.45000 8819.9n 0.45000 8820.0n 0.55000 8959.9n 0.55000 8960.0n 0.55000 9099.9n 0.55000 9100.0n 0.55000 9239.9n 0.55000 9240.0n 0.45000 9379.9n 0.45000 9380.0n 0.45000 9519.9n 0.45000 9520.0n 0.45000 9659.9n 0.45000 9660.0n 0.55000 9799.9n 0.55000 9800.0n 0.55000 9939.9n 0.55000 9940.0n 0.55000 10079.9n 0.55000 10080.0n 0.55000 10219.9n 0.55000 10220.0n 0.55000 10359.9n 0.55000 10360.0n 0.45000 10499.9n 0.45000 10500.0n 0.55000 10639.9n 0.55000 10640.0n 0.45000 10779.9n 0.45000 10780.0n 0.55000 10919.9n 0.55000 10920.0n 0.45000 11059.9n 0.45000 11060.0n 0.55000 11199.9n 0.55000 11200.0n 0.45000 11339.9n 0.45000 11340.0n 0.55000 11479.9n 0.55000 11480.0n 0.45000 11619.9n 0.45000 11620.0n 0.55000 11759.9n 0.55000 11760.0n 0.45000 11899.9n 0.45000 11900.0n 0.45000 12039.9n 0.45000 12040.0n 0.55000 12179.9n 0.55000 12180.0n 0.45000 12319.9n 0.45000 12320.0n 0.45000 12459.9n 0.45000 12460.0n 0.45000 12599.9n 0.45000 12600.0n 0.45000 12739.9n 0.45000 12740.0n 0.55000 12879.9n 0.55000 12880.0n 0.55000 13019.9n 0.55000 13020.0n 0.45000 13159.9n 0.45000 13160.0n 0.55000 13299.9n 0.55000 13300.0n 0.55000 13439.9n 0.55000 13440.0n 0.45000 13579.9n 0.45000 13580.0n 0.55000 13719.9n 0.55000 13720.0n 0.55000 13859.9n 0.55000 13860.0n 0.45000 13999.9n 0.45000 14000.0n 0.45000 14139.9n 0.45000 14140.0n 0.55000 14279.9n 0.55000 14280.0n 0.45000 14419.9n 0.45000 14420.0n 0.55000 14559.9n 0.55000 14560.0n 0.45000 14699.9n 0.45000 14700.0n 0.45000 14839.9n 0.45000 14840.0n 0.55000 14979.9n 0.55000 14980.0n 0.55000 15119.9n 0.55000 15120.0n 0.55000 15259.9n 0.55000 15260.0n 0.55000 15399.9n 0.55000 15400.0n 0.45000 15539.9n 0.45000 15540.0n 0.45000 15679.9n 0.45000 15680.0n 0.55000 15819.9n 0.55000 15820.0n 0.55000 15959.9n 0.55000 15960.0n 0.55000 16099.9n 0.55000 16100.0n 0.55000 16239.9n 0.55000 16240.0n 0.45000 16379.9n 0.45000 16380.0n 0.45000 16519.9n 0.45000 16520.0n 0.45000 16659.9n 0.45000 16660.0n 0.45000 16799.9n 0.45000 16800.0n 0.55000 16939.9n 0.55000 16940.0n 0.55000 17079.9n 0.55000 17080.0n 0.55000 17219.9n 0.55000 17220.0n 0.55000 17359.9n 0.55000 17360.0n 0.45000 17499.9n 0.45000 17500.0n 0.45000 17639.9n 0.45000 17640.0n 0.55000 17779.9n 0.55000 17780.0n 0.45000 17919.9n 0.45000 17920.0n 0.45000 18059.9n 0.45000 18060.0n 0.45000 18199.9n 0.45000 18200.0n 0.55000 18339.9n 0.55000 18340.0n 0.55000 18479.9n 0.55000 18480.0n 0.55000 18619.9n 0.55000 18620.0n 0.45000 18759.9n 0.45000 18760.0n 0.55000 18899.9n 0.55000 18900.0n 0.55000 19039.9n 0.55000 19040.0n 0.45000 19179.9n 0.45000 19180.0n 0.45000 19319.9n 0.45000 19320.0n 0.45000 19459.9n 0.45000 19460.0n 0.45000 19599.9n 0.45000 19600.0n 0.55000 19739.9n 0.55000 19740.0n 0.55000 19879.9n 0.55000 19880.0n 0.45000 20019.9n 0.45000 20020.0n 0.45000 20159.9n 0.45000 20160.0n 0.55000 20299.9n 0.55000 20300.0n 0.45000 20439.9n 0.45000 20440.0n 0.45000 20579.9n 0.45000 20580.0n 0.45000 20719.9n 0.45000 20720.0n 0.45000 20859.9n 0.45000 20860.0n 0.55000 20999.9n 0.55000 21000.0n 0.55000 21139.9n 0.55000 21140.0n 0.45000 21279.9n 0.45000 21280.0n 0.45000 21419.9n 0.45000 21420.0n 0.45000 21559.9n 0.45000 21560.0n 0.55000 21699.9n 0.55000 21700.0n 0.55000 21839.9n 0.55000 21840.0n 0.45000 21979.9n 0.45000 21980.0n 0.45000 22119.9n 0.45000 22120.0n 0.55000 22259.9n 0.55000 22260.0n 0.55000 22399.9n 0.55000 22400.0n 0.45000 22539.9n 0.45000 22540.0n 0.45000 22679.9n 0.45000 22680.0n 0.55000 22819.9n 0.55000 22820.0n 0.55000 22959.9n 0.55000 22960.0n 0.55000 23099.9n 0.55000 23100.0n 0.55000 23239.9n 0.55000 23240.0n 0.55000 23379.9n 0.55000 23380.0n 0.45000 23519.9n 0.45000 23520.0n 0.45000 23659.9n 0.45000 23660.0n 0.55000 23799.9n 0.55000 23800.0n 0.45000 23939.9n 0.45000 23940.0n 0.45000 24079.9n 0.45000 24080.0n 0.45000 24219.9n 0.45000 24220.0n 0.55000 24359.9n 0.55000 24360.0n 0.45000 24499.9n 0.45000 24500.0n 0.45000 24639.9n 0.45000 24640.0n 0.45000 24779.9n 0.45000 24780.0n 0.55000 24919.9n 0.55000 24920.0n 0.55000 25059.9n 0.55000 25060.0n 0.45000 25199.9n 0.45000 25200.0n 0.55000 25339.9n 0.55000 25340.0n 0.55000 25479.9n 0.55000 25480.0n 0.55000 25619.9n 0.55000 25620.0n 0.55000 25759.9n 0.55000 25760.0n 0.55000 25899.9n 0.55000 25900.0n 0.45000 26039.9n 0.45000 26040.0n 0.45000 26179.9n 0.45000 26180.0n 0.45000 26319.9n 0.45000 26320.0n 0.55000 26459.9n 0.55000 26460.0n 0.45000 26599.9n 0.45000 26600.0n 0.55000 26739.9n 0.55000 26740.0n 0.55000 26879.9n 0.55000 26880.0n 0.55000 27019.9n 0.55000 27020.0n 0.55000 27159.9n 0.55000 27160.0n 0.45000 27299.9n 0.45000 27300.0n 0.45000 27439.9n 0.45000 27440.0n 0.55000 27579.9n 0.55000 27580.0n 0.55000 27719.9n 0.55000 27720.0n 0.55000 27859.9n 0.55000 27860.0n 0.45000 27999.9n 0.45000 28000.0n 0.45000 28139.9n 0.45000 28140.0n 0.55000 28279.9n 0.55000 28280.0n 0.55000 28419.9n 0.55000 28420.0n 0.45000 28559.9n 0.45000 28560.0n 0.55000 28699.9n 0.55000 28700.0n 0.45000 28839.9n 0.45000 28840.0n 0.55000 28979.9n 0.55000 28980.0n 0.45000 29119.9n 0.45000 29120.0n 0.45000 29259.9n 0.45000 29260.0n 0.45000 29399.9n 0.45000 29400.0n 0.55000 29539.9n 0.55000 29540.0n 0.55000 29679.9n 0.55000 29680.0n 0.45000 29819.9n 0.45000 29820.0n 0.55000 29959.9n 0.55000 29960.0n 0.45000 30099.9n 0.45000 30100.0n 0.45000 30239.9n 0.45000 30240.0n 0.55000 30379.9n 0.55000 30380.0n 0.55000 30519.9n 0.55000 30520.0n 0.45000 30659.9n 0.45000 30660.0n 0.45000 30799.9n 0.45000 30800.0n 0.55000 30939.9n 0.55000 30940.0n 0.45000 31079.9n 0.45000 31080.0n 0.55000 31219.9n 0.55000 31220.0n 0.55000 31359.9n 0.55000 31360.0n 0.45000 31499.9n 0.45000 31500.0n 0.45000 31639.9n 0.45000 31640.0n 0.45000 31779.9n 0.45000 31780.0n 0.55000 31919.9n 0.55000 31920.0n 0.55000 32059.9n 0.55000 32060.0n 0.55000 32199.9n 0.55000 32200.0n 0.45000 32339.9n 0.45000 32340.0n 0.55000 32479.9n 0.55000 32480.0n 0.45000 32619.9n 0.45000 32620.0n 0.55000 32759.9n 0.55000 32760.0n 0.45000 32899.9n 0.45000 32900.0n 0.45000 33039.9n 0.45000 33040.0n 0.45000 33179.9n 0.45000 33180.0n 0.55000 33319.9n 0.55000 33320.0n 0.45000 33459.9n 0.45000 33460.0n 0.55000 33599.9n 0.55000 33600.0n 0.45000 33739.9n 0.45000 33740.0n 0.45000 33879.9n 0.45000 33880.0n 0.45000 34019.9n 0.45000 34020.0n 0.45000 34159.9n 0.45000 34160.0n 0.45000 34299.9n 0.45000 34300.0n 0.45000 34439.9n 0.45000 34440.0n 0.45000 34579.9n 0.45000 34580.0n 0.55000 34719.9n 0.55000 34720.0n 0.45000 34859.9n 0.45000 34860.0n 0.55000 34999.9n 0.55000 35000.0n 0.55000 35139.9n 0.55000 35140.0n 0.45000 35279.9n 0.45000 35280.0n 0.55000 35419.9n 0.55000 35420.0n 0.55000 35559.9n 0.55000 35560.0n 0.55000 35699.9n 0.55000 35700.0n 0.55000 35839.9n 0.55000 35840.0n 0.55000 35979.9n 0.55000 35980.0n 0.55000 36119.9n 0.55000 36120.0n 0.55000 36259.9n 0.55000 36260.0n 0.55000 36399.9n 0.55000 36400.0n 0.45000 36539.9n 0.45000 36540.0n 0.55000 36679.9n 0.55000 36680.0n 0.45000 36819.9n 0.45000 36820.0n 0.45000 36959.9n 0.45000 36960.0n 0.55000 37099.9n 0.55000 37100.0n 0.45000 37239.9n 0.45000 37240.0n 0.45000 37379.9n 0.45000 37380.0n 0.55000 37519.9n 0.55000 37520.0n 0.55000 37659.9n 0.55000 37660.0n 0.55000 37799.9n 0.55000 37800.0n 0.55000 37939.9n 0.55000 37940.0n 0.45000 38079.9n 0.45000 38080.0n 0.45000 38219.9n 0.45000 38220.0n 0.45000 38359.9n 0.45000 38360.0n 0.45000 38499.9n 0.45000 38500.0n 0.45000 38639.9n 0.45000 38640.0n 0.55000 38779.9n 0.55000 38780.0n 0.55000 38919.9n 0.55000 38920.0n 0.55000 39059.9n 0.55000 39060.0n 0.45000 39199.9n 0.45000 39200.0n 0.45000 39339.9n 0.45000 39340.0n 0.55000 39479.9n 0.55000 39480.0n 0.55000 39619.9n 0.55000 39620.0n 0.45000 39759.9n 0.45000 39760.0n 0.45000 39899.9n 0.45000 39900.0n 0.55000 40039.9n 0.55000 40040.0n 0.55000 40179.9n 0.55000 40180.0n 0.45000 40319.9n 0.45000 40320.0n 0.55000 40459.9n 0.55000 40460.0n 0.45000 40599.9n 0.45000 40600.0n 0.55000 40739.9n 0.55000 40740.0n 0.45000 40879.9n 0.45000 40880.0n 0.55000 41019.9n 0.55000 41020.0n 0.45000 41159.9n 0.45000 41160.0n 0.45000 41299.9n 0.45000 41300.0n 0.45000 41439.9n 0.45000 41440.0n 0.45000 41579.9n 0.45000 41580.0n 0.45000 41719.9n 0.45000 41720.0n 0.45000 41859.9n 0.45000 41860.0n 0.55000 41999.9n 0.55000 42000.0n 0.45000 42139.9n 0.45000 42140.0n 0.55000 42279.9n 0.55000 42280.0n 0.55000 42419.9n 0.55000 42420.0n 0.55000 42559.9n 0.55000 42560.0n 0.45000 42699.9n 0.45000 42700.0n 0.55000 42839.9n 0.55000 42840.0n 0.55000 42979.9n 0.55000 42980.0n 0.45000 43119.9n 0.45000 43120.0n 0.55000 43259.9n 0.55000 43260.0n 0.55000 43399.9n 0.55000 43400.0n 0.55000 43539.9n 0.55000 43540.0n 0.45000 43679.9n 0.45000 43680.0n 0.45000 43819.9n 0.45000 43820.0n 0.45000 43959.9n 0.45000 43960.0n 0.45000 44099.9n 0.45000 44100.0n 0.45000 44239.9n 0.45000 44240.0n 0.45000 44379.9n 0.45000 44380.0n 0.55000 44519.9n 0.55000 44520.0n 0.55000 44659.9n 0.55000 44660.0n 0.55000 44799.9n 0.55000 44800.0n 0.55000 44939.9n 0.55000 44940.0n 0.45000 45079.9n 0.45000 45080.0n 0.45000 45219.9n 0.45000 45220.0n 0.45000 45359.9n 0.45000 45360.0n 0.45000 45499.9n 0.45000 45500.0n 0.45000 45639.9n 0.45000 45640.0n 0.55000 45779.9n 0.55000 45780.0n 0.55000 45919.9n 0.55000 45920.0n 0.55000 46059.9n 0.55000 46060.0n 0.55000 46199.9n 0.55000 46200.0n 0.55000 46339.9n 0.55000 46340.0n 0.55000 46479.9n 0.55000 46480.0n 0.55000 46619.9n 0.55000 46620.0n 0.45000 46759.9n 0.45000 46760.0n 0.45000 46899.9n 0.45000 46900.0n 0.55000 47039.9n 0.55000 47040.0n 0.50000 47179.9n 0.50000 47180.0n 0.50000 47319.9n 0.50000 47320.0n 0.50000 47459.9n 0.50000 47460.0n 0.50000 47599.9n 0.50000 47600.0n 0.50000 47739.9n 0.50000 47740.0n 0.50000 47879.9n 0.50000 47880.0n 0.50000 48019.9n 0.50000 48020.0n 0.50000 48159.9n 0.50000 48160.0n 0.50000 48299.9n 0.50000 48300.0n 0.50000 48439.9n 0.50000 48440.0n 0.50000 48579.9n 0.50000 48580.0n 0.50000 48719.9n 0.50000 48720.0n 0.50000 48859.9n 0.50000 48860.0n 0.50000 48999.9n 0.50000 49000.0n 0.50000 49139.9n 0.50000 49140.0n 0.50000 49279.9n 0.50000 49280.0n 0.50000 49419.9n 0.50000 49420.0n 0.50000 49559.9n 0.50000 49560.0n 0.50000 49699.9n 0.50000 49700.0n 0.50000 49839.9n 0.50000 49840.0n 0.50000 49979.9n 0.50000 49980.0n 0.50000 50119.9n 0.50000 50120.0n 0.50000 50259.9n 0.50000 50260.0n 0.50000 50399.9n 0.50000 50400.0n 0.50000 50539.9n 0.50000 50540.0n 0.50000 50679.9n 0.50000 50680.0n 0.50000 50819.9n 0.50000 50820.0n 0.50000 50959.9n 0.50000 50960.0n 0.50000 51099.9n 0.50000 51100.0n 0.50000 51239.9n 0.50000 51240.0n 0.50000 51379.9n 0.50000 51380.0n 0.50000 51519.9n 0.50000 51520.0n 0.50000 51659.9n 0.50000 51660.0n 0.50000 51799.9n 0.50000 51800.0n 0.50000 51939.9n 0.50000 51940.0n 0.50000 52079.9n 0.50000 52080.0n 0.50000 52219.9n 0.50000 52220.0n 0.50000 52359.9n 0.50000 52360.0n 0.50000 52499.9n 0.50000 52500.0n 0.50000)
Vxop1 xop1 0 PWL(0.0n 0.45000 139.9n 0.45000 140.0n 0.55000 279.9n 0.55000 280.0n 0.45000 419.9n 0.45000 420.0n 0.55000 559.9n 0.55000 560.0n 0.55000 699.9n 0.55000 700.0n 0.55000 839.9n 0.55000 840.0n 0.55000 979.9n 0.55000 980.0n 0.45000 1119.9n 0.45000 1120.0n 0.45000 1259.9n 0.45000 1260.0n 0.55000 1399.9n 0.55000 1400.0n 0.45000 1539.9n 0.45000 1540.0n 0.55000 1679.9n 0.55000 1680.0n 0.55000 1819.9n 0.55000 1820.0n 0.45000 1959.9n 0.45000 1960.0n 0.55000 2099.9n 0.55000 2100.0n 0.45000 2239.9n 0.45000 2240.0n 0.45000 2379.9n 0.45000 2380.0n 0.45000 2519.9n 0.45000 2520.0n 0.45000 2659.9n 0.45000 2660.0n 0.45000 2799.9n 0.45000 2800.0n 0.55000 2939.9n 0.55000 2940.0n 0.55000 3079.9n 0.55000 3080.0n 0.55000 3219.9n 0.55000 3220.0n 0.45000 3359.9n 0.45000 3360.0n 0.55000 3499.9n 0.55000 3500.0n 0.45000 3639.9n 0.45000 3640.0n 0.45000 3779.9n 0.45000 3780.0n 0.55000 3919.9n 0.55000 3920.0n 0.45000 4059.9n 0.45000 4060.0n 0.55000 4199.9n 0.55000 4200.0n 0.55000 4339.9n 0.55000 4340.0n 0.45000 4479.9n 0.45000 4480.0n 0.45000 4619.9n 0.45000 4620.0n 0.55000 4759.9n 0.55000 4760.0n 0.45000 4899.9n 0.45000 4900.0n 0.55000 5039.9n 0.55000 5040.0n 0.45000 5179.9n 0.45000 5180.0n 0.55000 5319.9n 0.55000 5320.0n 0.45000 5459.9n 0.45000 5460.0n 0.45000 5599.9n 0.45000 5600.0n 0.55000 5739.9n 0.55000 5740.0n 0.55000 5879.9n 0.55000 5880.0n 0.45000 6019.9n 0.45000 6020.0n 0.45000 6159.9n 0.45000 6160.0n 0.55000 6299.9n 0.55000 6300.0n 0.55000 6439.9n 0.55000 6440.0n 0.45000 6579.9n 0.45000 6580.0n 0.55000 6719.9n 0.55000 6720.0n 0.55000 6859.9n 0.55000 6860.0n 0.45000 6999.9n 0.45000 7000.0n 0.55000 7139.9n 0.55000 7140.0n 0.55000 7279.9n 0.55000 7280.0n 0.45000 7419.9n 0.45000 7420.0n 0.45000 7559.9n 0.45000 7560.0n 0.45000 7699.9n 0.45000 7700.0n 0.55000 7839.9n 0.55000 7840.0n 0.45000 7979.9n 0.45000 7980.0n 0.45000 8119.9n 0.45000 8120.0n 0.55000 8259.9n 0.55000 8260.0n 0.55000 8399.9n 0.55000 8400.0n 0.45000 8539.9n 0.45000 8540.0n 0.45000 8679.9n 0.45000 8680.0n 0.45000 8819.9n 0.45000 8820.0n 0.55000 8959.9n 0.55000 8960.0n 0.55000 9099.9n 0.55000 9100.0n 0.55000 9239.9n 0.55000 9240.0n 0.45000 9379.9n 0.45000 9380.0n 0.45000 9519.9n 0.45000 9520.0n 0.45000 9659.9n 0.45000 9660.0n 0.55000 9799.9n 0.55000 9800.0n 0.55000 9939.9n 0.55000 9940.0n 0.55000 10079.9n 0.55000 10080.0n 0.55000 10219.9n 0.55000 10220.0n 0.55000 10359.9n 0.55000 10360.0n 0.45000 10499.9n 0.45000 10500.0n 0.55000 10639.9n 0.55000 10640.0n 0.45000 10779.9n 0.45000 10780.0n 0.55000 10919.9n 0.55000 10920.0n 0.45000 11059.9n 0.45000 11060.0n 0.55000 11199.9n 0.55000 11200.0n 0.45000 11339.9n 0.45000 11340.0n 0.55000 11479.9n 0.55000 11480.0n 0.45000 11619.9n 0.45000 11620.0n 0.55000 11759.9n 0.55000 11760.0n 0.45000 11899.9n 0.45000 11900.0n 0.45000 12039.9n 0.45000 12040.0n 0.55000 12179.9n 0.55000 12180.0n 0.45000 12319.9n 0.45000 12320.0n 0.45000 12459.9n 0.45000 12460.0n 0.45000 12599.9n 0.45000 12600.0n 0.45000 12739.9n 0.45000 12740.0n 0.55000 12879.9n 0.55000 12880.0n 0.55000 13019.9n 0.55000 13020.0n 0.45000 13159.9n 0.45000 13160.0n 0.55000 13299.9n 0.55000 13300.0n 0.55000 13439.9n 0.55000 13440.0n 0.45000 13579.9n 0.45000 13580.0n 0.55000 13719.9n 0.55000 13720.0n 0.55000 13859.9n 0.55000 13860.0n 0.45000 13999.9n 0.45000 14000.0n 0.45000 14139.9n 0.45000 14140.0n 0.55000 14279.9n 0.55000 14280.0n 0.45000 14419.9n 0.45000 14420.0n 0.55000 14559.9n 0.55000 14560.0n 0.45000 14699.9n 0.45000 14700.0n 0.45000 14839.9n 0.45000 14840.0n 0.55000 14979.9n 0.55000 14980.0n 0.55000 15119.9n 0.55000 15120.0n 0.55000 15259.9n 0.55000 15260.0n 0.55000 15399.9n 0.55000 15400.0n 0.45000 15539.9n 0.45000 15540.0n 0.45000 15679.9n 0.45000 15680.0n 0.55000 15819.9n 0.55000 15820.0n 0.55000 15959.9n 0.55000 15960.0n 0.55000 16099.9n 0.55000 16100.0n 0.55000 16239.9n 0.55000 16240.0n 0.45000 16379.9n 0.45000 16380.0n 0.45000 16519.9n 0.45000 16520.0n 0.45000 16659.9n 0.45000 16660.0n 0.45000 16799.9n 0.45000 16800.0n 0.55000 16939.9n 0.55000 16940.0n 0.55000 17079.9n 0.55000 17080.0n 0.55000 17219.9n 0.55000 17220.0n 0.55000 17359.9n 0.55000 17360.0n 0.45000 17499.9n 0.45000 17500.0n 0.45000 17639.9n 0.45000 17640.0n 0.55000 17779.9n 0.55000 17780.0n 0.45000 17919.9n 0.45000 17920.0n 0.45000 18059.9n 0.45000 18060.0n 0.45000 18199.9n 0.45000 18200.0n 0.55000 18339.9n 0.55000 18340.0n 0.55000 18479.9n 0.55000 18480.0n 0.55000 18619.9n 0.55000 18620.0n 0.45000 18759.9n 0.45000 18760.0n 0.55000 18899.9n 0.55000 18900.0n 0.55000 19039.9n 0.55000 19040.0n 0.45000 19179.9n 0.45000 19180.0n 0.45000 19319.9n 0.45000 19320.0n 0.45000 19459.9n 0.45000 19460.0n 0.45000 19599.9n 0.45000 19600.0n 0.55000 19739.9n 0.55000 19740.0n 0.55000 19879.9n 0.55000 19880.0n 0.45000 20019.9n 0.45000 20020.0n 0.45000 20159.9n 0.45000 20160.0n 0.55000 20299.9n 0.55000 20300.0n 0.45000 20439.9n 0.45000 20440.0n 0.45000 20579.9n 0.45000 20580.0n 0.45000 20719.9n 0.45000 20720.0n 0.45000 20859.9n 0.45000 20860.0n 0.55000 20999.9n 0.55000 21000.0n 0.55000 21139.9n 0.55000 21140.0n 0.45000 21279.9n 0.45000 21280.0n 0.45000 21419.9n 0.45000 21420.0n 0.45000 21559.9n 0.45000 21560.0n 0.55000 21699.9n 0.55000 21700.0n 0.55000 21839.9n 0.55000 21840.0n 0.45000 21979.9n 0.45000 21980.0n 0.45000 22119.9n 0.45000 22120.0n 0.55000 22259.9n 0.55000 22260.0n 0.55000 22399.9n 0.55000 22400.0n 0.45000 22539.9n 0.45000 22540.0n 0.45000 22679.9n 0.45000 22680.0n 0.55000 22819.9n 0.55000 22820.0n 0.55000 22959.9n 0.55000 22960.0n 0.55000 23099.9n 0.55000 23100.0n 0.55000 23239.9n 0.55000 23240.0n 0.55000 23379.9n 0.55000 23380.0n 0.45000 23519.9n 0.45000 23520.0n 0.45000 23659.9n 0.45000 23660.0n 0.55000 23799.9n 0.55000 23800.0n 0.45000 23939.9n 0.45000 23940.0n 0.45000 24079.9n 0.45000 24080.0n 0.45000 24219.9n 0.45000 24220.0n 0.55000 24359.9n 0.55000 24360.0n 0.45000 24499.9n 0.45000 24500.0n 0.45000 24639.9n 0.45000 24640.0n 0.45000 24779.9n 0.45000 24780.0n 0.55000 24919.9n 0.55000 24920.0n 0.55000 25059.9n 0.55000 25060.0n 0.45000 25199.9n 0.45000 25200.0n 0.55000 25339.9n 0.55000 25340.0n 0.55000 25479.9n 0.55000 25480.0n 0.55000 25619.9n 0.55000 25620.0n 0.55000 25759.9n 0.55000 25760.0n 0.55000 25899.9n 0.55000 25900.0n 0.45000 26039.9n 0.45000 26040.0n 0.45000 26179.9n 0.45000 26180.0n 0.45000 26319.9n 0.45000 26320.0n 0.55000 26459.9n 0.55000 26460.0n 0.45000 26599.9n 0.45000 26600.0n 0.55000 26739.9n 0.55000 26740.0n 0.55000 26879.9n 0.55000 26880.0n 0.55000 27019.9n 0.55000 27020.0n 0.55000 27159.9n 0.55000 27160.0n 0.45000 27299.9n 0.45000 27300.0n 0.45000 27439.9n 0.45000 27440.0n 0.55000 27579.9n 0.55000 27580.0n 0.55000 27719.9n 0.55000 27720.0n 0.55000 27859.9n 0.55000 27860.0n 0.45000 27999.9n 0.45000 28000.0n 0.45000 28139.9n 0.45000 28140.0n 0.55000 28279.9n 0.55000 28280.0n 0.55000 28419.9n 0.55000 28420.0n 0.45000 28559.9n 0.45000 28560.0n 0.55000 28699.9n 0.55000 28700.0n 0.45000 28839.9n 0.45000 28840.0n 0.55000 28979.9n 0.55000 28980.0n 0.45000 29119.9n 0.45000 29120.0n 0.45000 29259.9n 0.45000 29260.0n 0.45000 29399.9n 0.45000 29400.0n 0.55000 29539.9n 0.55000 29540.0n 0.55000 29679.9n 0.55000 29680.0n 0.45000 29819.9n 0.45000 29820.0n 0.55000 29959.9n 0.55000 29960.0n 0.45000 30099.9n 0.45000 30100.0n 0.45000 30239.9n 0.45000 30240.0n 0.55000 30379.9n 0.55000 30380.0n 0.55000 30519.9n 0.55000 30520.0n 0.45000 30659.9n 0.45000 30660.0n 0.45000 30799.9n 0.45000 30800.0n 0.55000 30939.9n 0.55000 30940.0n 0.45000 31079.9n 0.45000 31080.0n 0.55000 31219.9n 0.55000 31220.0n 0.55000 31359.9n 0.55000 31360.0n 0.45000 31499.9n 0.45000 31500.0n 0.45000 31639.9n 0.45000 31640.0n 0.45000 31779.9n 0.45000 31780.0n 0.55000 31919.9n 0.55000 31920.0n 0.55000 32059.9n 0.55000 32060.0n 0.55000 32199.9n 0.55000 32200.0n 0.45000 32339.9n 0.45000 32340.0n 0.55000 32479.9n 0.55000 32480.0n 0.45000 32619.9n 0.45000 32620.0n 0.55000 32759.9n 0.55000 32760.0n 0.45000 32899.9n 0.45000 32900.0n 0.45000 33039.9n 0.45000 33040.0n 0.45000 33179.9n 0.45000 33180.0n 0.55000 33319.9n 0.55000 33320.0n 0.45000 33459.9n 0.45000 33460.0n 0.55000 33599.9n 0.55000 33600.0n 0.45000 33739.9n 0.45000 33740.0n 0.45000 33879.9n 0.45000 33880.0n 0.45000 34019.9n 0.45000 34020.0n 0.45000 34159.9n 0.45000 34160.0n 0.45000 34299.9n 0.45000 34300.0n 0.45000 34439.9n 0.45000 34440.0n 0.45000 34579.9n 0.45000 34580.0n 0.55000 34719.9n 0.55000 34720.0n 0.45000 34859.9n 0.45000 34860.0n 0.55000 34999.9n 0.55000 35000.0n 0.55000 35139.9n 0.55000 35140.0n 0.45000 35279.9n 0.45000 35280.0n 0.55000 35419.9n 0.55000 35420.0n 0.55000 35559.9n 0.55000 35560.0n 0.55000 35699.9n 0.55000 35700.0n 0.55000 35839.9n 0.55000 35840.0n 0.55000 35979.9n 0.55000 35980.0n 0.55000 36119.9n 0.55000 36120.0n 0.55000 36259.9n 0.55000 36260.0n 0.55000 36399.9n 0.55000 36400.0n 0.45000 36539.9n 0.45000 36540.0n 0.55000 36679.9n 0.55000 36680.0n 0.45000 36819.9n 0.45000 36820.0n 0.45000 36959.9n 0.45000 36960.0n 0.55000 37099.9n 0.55000 37100.0n 0.45000 37239.9n 0.45000 37240.0n 0.45000 37379.9n 0.45000 37380.0n 0.55000 37519.9n 0.55000 37520.0n 0.55000 37659.9n 0.55000 37660.0n 0.55000 37799.9n 0.55000 37800.0n 0.55000 37939.9n 0.55000 37940.0n 0.45000 38079.9n 0.45000 38080.0n 0.45000 38219.9n 0.45000 38220.0n 0.45000 38359.9n 0.45000 38360.0n 0.45000 38499.9n 0.45000 38500.0n 0.45000 38639.9n 0.45000 38640.0n 0.55000 38779.9n 0.55000 38780.0n 0.55000 38919.9n 0.55000 38920.0n 0.55000 39059.9n 0.55000 39060.0n 0.45000 39199.9n 0.45000 39200.0n 0.45000 39339.9n 0.45000 39340.0n 0.55000 39479.9n 0.55000 39480.0n 0.55000 39619.9n 0.55000 39620.0n 0.45000 39759.9n 0.45000 39760.0n 0.45000 39899.9n 0.45000 39900.0n 0.55000 40039.9n 0.55000 40040.0n 0.55000 40179.9n 0.55000 40180.0n 0.45000 40319.9n 0.45000 40320.0n 0.55000 40459.9n 0.55000 40460.0n 0.45000 40599.9n 0.45000 40600.0n 0.55000 40739.9n 0.55000 40740.0n 0.45000 40879.9n 0.45000 40880.0n 0.55000 41019.9n 0.55000 41020.0n 0.45000 41159.9n 0.45000 41160.0n 0.45000 41299.9n 0.45000 41300.0n 0.45000 41439.9n 0.45000 41440.0n 0.45000 41579.9n 0.45000 41580.0n 0.45000 41719.9n 0.45000 41720.0n 0.45000 41859.9n 0.45000 41860.0n 0.55000 41999.9n 0.55000 42000.0n 0.45000 42139.9n 0.45000 42140.0n 0.55000 42279.9n 0.55000 42280.0n 0.55000 42419.9n 0.55000 42420.0n 0.55000 42559.9n 0.55000 42560.0n 0.45000 42699.9n 0.45000 42700.0n 0.55000 42839.9n 0.55000 42840.0n 0.55000 42979.9n 0.55000 42980.0n 0.45000 43119.9n 0.45000 43120.0n 0.55000 43259.9n 0.55000 43260.0n 0.55000 43399.9n 0.55000 43400.0n 0.55000 43539.9n 0.55000 43540.0n 0.45000 43679.9n 0.45000 43680.0n 0.45000 43819.9n 0.45000 43820.0n 0.45000 43959.9n 0.45000 43960.0n 0.45000 44099.9n 0.45000 44100.0n 0.45000 44239.9n 0.45000 44240.0n 0.45000 44379.9n 0.45000 44380.0n 0.55000 44519.9n 0.55000 44520.0n 0.55000 44659.9n 0.55000 44660.0n 0.55000 44799.9n 0.55000 44800.0n 0.55000 44939.9n 0.55000 44940.0n 0.45000 45079.9n 0.45000 45080.0n 0.45000 45219.9n 0.45000 45220.0n 0.45000 45359.9n 0.45000 45360.0n 0.45000 45499.9n 0.45000 45500.0n 0.45000 45639.9n 0.45000 45640.0n 0.55000 45779.9n 0.55000 45780.0n 0.55000 45919.9n 0.55000 45920.0n 0.55000 46059.9n 0.55000 46060.0n 0.55000 46199.9n 0.55000 46200.0n 0.55000 46339.9n 0.55000 46340.0n 0.55000 46479.9n 0.55000 46480.0n 0.55000 46619.9n 0.55000 46620.0n 0.45000 46759.9n 0.45000 46760.0n 0.45000 46899.9n 0.45000 46900.0n 0.55000 47039.9n 0.55000 47040.0n 0.50000 47179.9n 0.50000 47180.0n 0.50000 47319.9n 0.50000 47320.0n 0.50000 47459.9n 0.50000 47460.0n 0.50000 47599.9n 0.50000 47600.0n 0.50000 47739.9n 0.50000 47740.0n 0.50000 47879.9n 0.50000 47880.0n 0.50000 48019.9n 0.50000 48020.0n 0.50000 48159.9n 0.50000 48160.0n 0.50000 48299.9n 0.50000 48300.0n 0.50000 48439.9n 0.50000 48440.0n 0.50000 48579.9n 0.50000 48580.0n 0.50000 48719.9n 0.50000 48720.0n 0.50000 48859.9n 0.50000 48860.0n 0.50000 48999.9n 0.50000 49000.0n 0.50000 49139.9n 0.50000 49140.0n 0.50000 49279.9n 0.50000 49280.0n 0.50000 49419.9n 0.50000 49420.0n 0.50000 49559.9n 0.50000 49560.0n 0.50000 49699.9n 0.50000 49700.0n 0.50000 49839.9n 0.50000 49840.0n 0.50000 49979.9n 0.50000 49980.0n 0.50000 50119.9n 0.50000 50120.0n 0.50000 50259.9n 0.50000 50260.0n 0.50000 50399.9n 0.50000 50400.0n 0.50000 50539.9n 0.50000 50540.0n 0.50000 50679.9n 0.50000 50680.0n 0.50000 50819.9n 0.50000 50820.0n 0.50000 50959.9n 0.50000 50960.0n 0.50000 51099.9n 0.50000 51100.0n 0.50000 51239.9n 0.50000 51240.0n 0.50000 51379.9n 0.50000 51380.0n 0.50000 51519.9n 0.50000 51520.0n 0.50000 51659.9n 0.50000 51660.0n 0.50000 51799.9n 0.50000 51800.0n 0.50000 51939.9n 0.50000 51940.0n 0.50000 52079.9n 0.50000 52080.0n 0.50000 52219.9n 0.50000 52220.0n 0.50000 52359.9n 0.50000 52360.0n 0.50000 52499.9n 0.50000 52500.0n 0.50000)
Vxon1 xon1 0 PWL(0.0n 0.55000 139.9n 0.55000 140.0n 0.45000 279.9n 0.45000 280.0n 0.55000 419.9n 0.55000 420.0n 0.45000 559.9n 0.45000 560.0n 0.45000 699.9n 0.45000 700.0n 0.45000 839.9n 0.45000 840.0n 0.45000 979.9n 0.45000 980.0n 0.55000 1119.9n 0.55000 1120.0n 0.55000 1259.9n 0.55000 1260.0n 0.45000 1399.9n 0.45000 1400.0n 0.55000 1539.9n 0.55000 1540.0n 0.45000 1679.9n 0.45000 1680.0n 0.45000 1819.9n 0.45000 1820.0n 0.55000 1959.9n 0.55000 1960.0n 0.45000 2099.9n 0.45000 2100.0n 0.55000 2239.9n 0.55000 2240.0n 0.55000 2379.9n 0.55000 2380.0n 0.55000 2519.9n 0.55000 2520.0n 0.55000 2659.9n 0.55000 2660.0n 0.55000 2799.9n 0.55000 2800.0n 0.45000 2939.9n 0.45000 2940.0n 0.45000 3079.9n 0.45000 3080.0n 0.45000 3219.9n 0.45000 3220.0n 0.55000 3359.9n 0.55000 3360.0n 0.45000 3499.9n 0.45000 3500.0n 0.55000 3639.9n 0.55000 3640.0n 0.55000 3779.9n 0.55000 3780.0n 0.45000 3919.9n 0.45000 3920.0n 0.55000 4059.9n 0.55000 4060.0n 0.45000 4199.9n 0.45000 4200.0n 0.45000 4339.9n 0.45000 4340.0n 0.55000 4479.9n 0.55000 4480.0n 0.55000 4619.9n 0.55000 4620.0n 0.45000 4759.9n 0.45000 4760.0n 0.55000 4899.9n 0.55000 4900.0n 0.45000 5039.9n 0.45000 5040.0n 0.55000 5179.9n 0.55000 5180.0n 0.45000 5319.9n 0.45000 5320.0n 0.55000 5459.9n 0.55000 5460.0n 0.55000 5599.9n 0.55000 5600.0n 0.45000 5739.9n 0.45000 5740.0n 0.45000 5879.9n 0.45000 5880.0n 0.55000 6019.9n 0.55000 6020.0n 0.55000 6159.9n 0.55000 6160.0n 0.45000 6299.9n 0.45000 6300.0n 0.45000 6439.9n 0.45000 6440.0n 0.55000 6579.9n 0.55000 6580.0n 0.45000 6719.9n 0.45000 6720.0n 0.45000 6859.9n 0.45000 6860.0n 0.55000 6999.9n 0.55000 7000.0n 0.45000 7139.9n 0.45000 7140.0n 0.45000 7279.9n 0.45000 7280.0n 0.55000 7419.9n 0.55000 7420.0n 0.55000 7559.9n 0.55000 7560.0n 0.55000 7699.9n 0.55000 7700.0n 0.45000 7839.9n 0.45000 7840.0n 0.55000 7979.9n 0.55000 7980.0n 0.55000 8119.9n 0.55000 8120.0n 0.45000 8259.9n 0.45000 8260.0n 0.45000 8399.9n 0.45000 8400.0n 0.55000 8539.9n 0.55000 8540.0n 0.55000 8679.9n 0.55000 8680.0n 0.55000 8819.9n 0.55000 8820.0n 0.45000 8959.9n 0.45000 8960.0n 0.45000 9099.9n 0.45000 9100.0n 0.45000 9239.9n 0.45000 9240.0n 0.55000 9379.9n 0.55000 9380.0n 0.55000 9519.9n 0.55000 9520.0n 0.55000 9659.9n 0.55000 9660.0n 0.45000 9799.9n 0.45000 9800.0n 0.45000 9939.9n 0.45000 9940.0n 0.45000 10079.9n 0.45000 10080.0n 0.45000 10219.9n 0.45000 10220.0n 0.45000 10359.9n 0.45000 10360.0n 0.55000 10499.9n 0.55000 10500.0n 0.45000 10639.9n 0.45000 10640.0n 0.55000 10779.9n 0.55000 10780.0n 0.45000 10919.9n 0.45000 10920.0n 0.55000 11059.9n 0.55000 11060.0n 0.45000 11199.9n 0.45000 11200.0n 0.55000 11339.9n 0.55000 11340.0n 0.45000 11479.9n 0.45000 11480.0n 0.55000 11619.9n 0.55000 11620.0n 0.45000 11759.9n 0.45000 11760.0n 0.55000 11899.9n 0.55000 11900.0n 0.55000 12039.9n 0.55000 12040.0n 0.45000 12179.9n 0.45000 12180.0n 0.55000 12319.9n 0.55000 12320.0n 0.55000 12459.9n 0.55000 12460.0n 0.55000 12599.9n 0.55000 12600.0n 0.55000 12739.9n 0.55000 12740.0n 0.45000 12879.9n 0.45000 12880.0n 0.45000 13019.9n 0.45000 13020.0n 0.55000 13159.9n 0.55000 13160.0n 0.45000 13299.9n 0.45000 13300.0n 0.45000 13439.9n 0.45000 13440.0n 0.55000 13579.9n 0.55000 13580.0n 0.45000 13719.9n 0.45000 13720.0n 0.45000 13859.9n 0.45000 13860.0n 0.55000 13999.9n 0.55000 14000.0n 0.55000 14139.9n 0.55000 14140.0n 0.45000 14279.9n 0.45000 14280.0n 0.55000 14419.9n 0.55000 14420.0n 0.45000 14559.9n 0.45000 14560.0n 0.55000 14699.9n 0.55000 14700.0n 0.55000 14839.9n 0.55000 14840.0n 0.45000 14979.9n 0.45000 14980.0n 0.45000 15119.9n 0.45000 15120.0n 0.45000 15259.9n 0.45000 15260.0n 0.45000 15399.9n 0.45000 15400.0n 0.55000 15539.9n 0.55000 15540.0n 0.55000 15679.9n 0.55000 15680.0n 0.45000 15819.9n 0.45000 15820.0n 0.45000 15959.9n 0.45000 15960.0n 0.45000 16099.9n 0.45000 16100.0n 0.45000 16239.9n 0.45000 16240.0n 0.55000 16379.9n 0.55000 16380.0n 0.55000 16519.9n 0.55000 16520.0n 0.55000 16659.9n 0.55000 16660.0n 0.55000 16799.9n 0.55000 16800.0n 0.45000 16939.9n 0.45000 16940.0n 0.45000 17079.9n 0.45000 17080.0n 0.45000 17219.9n 0.45000 17220.0n 0.45000 17359.9n 0.45000 17360.0n 0.55000 17499.9n 0.55000 17500.0n 0.55000 17639.9n 0.55000 17640.0n 0.45000 17779.9n 0.45000 17780.0n 0.55000 17919.9n 0.55000 17920.0n 0.55000 18059.9n 0.55000 18060.0n 0.55000 18199.9n 0.55000 18200.0n 0.45000 18339.9n 0.45000 18340.0n 0.45000 18479.9n 0.45000 18480.0n 0.45000 18619.9n 0.45000 18620.0n 0.55000 18759.9n 0.55000 18760.0n 0.45000 18899.9n 0.45000 18900.0n 0.45000 19039.9n 0.45000 19040.0n 0.55000 19179.9n 0.55000 19180.0n 0.55000 19319.9n 0.55000 19320.0n 0.55000 19459.9n 0.55000 19460.0n 0.55000 19599.9n 0.55000 19600.0n 0.45000 19739.9n 0.45000 19740.0n 0.45000 19879.9n 0.45000 19880.0n 0.55000 20019.9n 0.55000 20020.0n 0.55000 20159.9n 0.55000 20160.0n 0.45000 20299.9n 0.45000 20300.0n 0.55000 20439.9n 0.55000 20440.0n 0.55000 20579.9n 0.55000 20580.0n 0.55000 20719.9n 0.55000 20720.0n 0.55000 20859.9n 0.55000 20860.0n 0.45000 20999.9n 0.45000 21000.0n 0.45000 21139.9n 0.45000 21140.0n 0.55000 21279.9n 0.55000 21280.0n 0.55000 21419.9n 0.55000 21420.0n 0.55000 21559.9n 0.55000 21560.0n 0.45000 21699.9n 0.45000 21700.0n 0.45000 21839.9n 0.45000 21840.0n 0.55000 21979.9n 0.55000 21980.0n 0.55000 22119.9n 0.55000 22120.0n 0.45000 22259.9n 0.45000 22260.0n 0.45000 22399.9n 0.45000 22400.0n 0.55000 22539.9n 0.55000 22540.0n 0.55000 22679.9n 0.55000 22680.0n 0.45000 22819.9n 0.45000 22820.0n 0.45000 22959.9n 0.45000 22960.0n 0.45000 23099.9n 0.45000 23100.0n 0.45000 23239.9n 0.45000 23240.0n 0.45000 23379.9n 0.45000 23380.0n 0.55000 23519.9n 0.55000 23520.0n 0.55000 23659.9n 0.55000 23660.0n 0.45000 23799.9n 0.45000 23800.0n 0.55000 23939.9n 0.55000 23940.0n 0.55000 24079.9n 0.55000 24080.0n 0.55000 24219.9n 0.55000 24220.0n 0.45000 24359.9n 0.45000 24360.0n 0.55000 24499.9n 0.55000 24500.0n 0.55000 24639.9n 0.55000 24640.0n 0.55000 24779.9n 0.55000 24780.0n 0.45000 24919.9n 0.45000 24920.0n 0.45000 25059.9n 0.45000 25060.0n 0.55000 25199.9n 0.55000 25200.0n 0.45000 25339.9n 0.45000 25340.0n 0.45000 25479.9n 0.45000 25480.0n 0.45000 25619.9n 0.45000 25620.0n 0.45000 25759.9n 0.45000 25760.0n 0.45000 25899.9n 0.45000 25900.0n 0.55000 26039.9n 0.55000 26040.0n 0.55000 26179.9n 0.55000 26180.0n 0.55000 26319.9n 0.55000 26320.0n 0.45000 26459.9n 0.45000 26460.0n 0.55000 26599.9n 0.55000 26600.0n 0.45000 26739.9n 0.45000 26740.0n 0.45000 26879.9n 0.45000 26880.0n 0.45000 27019.9n 0.45000 27020.0n 0.45000 27159.9n 0.45000 27160.0n 0.55000 27299.9n 0.55000 27300.0n 0.55000 27439.9n 0.55000 27440.0n 0.45000 27579.9n 0.45000 27580.0n 0.45000 27719.9n 0.45000 27720.0n 0.45000 27859.9n 0.45000 27860.0n 0.55000 27999.9n 0.55000 28000.0n 0.55000 28139.9n 0.55000 28140.0n 0.45000 28279.9n 0.45000 28280.0n 0.45000 28419.9n 0.45000 28420.0n 0.55000 28559.9n 0.55000 28560.0n 0.45000 28699.9n 0.45000 28700.0n 0.55000 28839.9n 0.55000 28840.0n 0.45000 28979.9n 0.45000 28980.0n 0.55000 29119.9n 0.55000 29120.0n 0.55000 29259.9n 0.55000 29260.0n 0.55000 29399.9n 0.55000 29400.0n 0.45000 29539.9n 0.45000 29540.0n 0.45000 29679.9n 0.45000 29680.0n 0.55000 29819.9n 0.55000 29820.0n 0.45000 29959.9n 0.45000 29960.0n 0.55000 30099.9n 0.55000 30100.0n 0.55000 30239.9n 0.55000 30240.0n 0.45000 30379.9n 0.45000 30380.0n 0.45000 30519.9n 0.45000 30520.0n 0.55000 30659.9n 0.55000 30660.0n 0.55000 30799.9n 0.55000 30800.0n 0.45000 30939.9n 0.45000 30940.0n 0.55000 31079.9n 0.55000 31080.0n 0.45000 31219.9n 0.45000 31220.0n 0.45000 31359.9n 0.45000 31360.0n 0.55000 31499.9n 0.55000 31500.0n 0.55000 31639.9n 0.55000 31640.0n 0.55000 31779.9n 0.55000 31780.0n 0.45000 31919.9n 0.45000 31920.0n 0.45000 32059.9n 0.45000 32060.0n 0.45000 32199.9n 0.45000 32200.0n 0.55000 32339.9n 0.55000 32340.0n 0.45000 32479.9n 0.45000 32480.0n 0.55000 32619.9n 0.55000 32620.0n 0.45000 32759.9n 0.45000 32760.0n 0.55000 32899.9n 0.55000 32900.0n 0.55000 33039.9n 0.55000 33040.0n 0.55000 33179.9n 0.55000 33180.0n 0.45000 33319.9n 0.45000 33320.0n 0.55000 33459.9n 0.55000 33460.0n 0.45000 33599.9n 0.45000 33600.0n 0.55000 33739.9n 0.55000 33740.0n 0.55000 33879.9n 0.55000 33880.0n 0.55000 34019.9n 0.55000 34020.0n 0.55000 34159.9n 0.55000 34160.0n 0.55000 34299.9n 0.55000 34300.0n 0.55000 34439.9n 0.55000 34440.0n 0.55000 34579.9n 0.55000 34580.0n 0.45000 34719.9n 0.45000 34720.0n 0.55000 34859.9n 0.55000 34860.0n 0.45000 34999.9n 0.45000 35000.0n 0.45000 35139.9n 0.45000 35140.0n 0.55000 35279.9n 0.55000 35280.0n 0.45000 35419.9n 0.45000 35420.0n 0.45000 35559.9n 0.45000 35560.0n 0.45000 35699.9n 0.45000 35700.0n 0.45000 35839.9n 0.45000 35840.0n 0.45000 35979.9n 0.45000 35980.0n 0.45000 36119.9n 0.45000 36120.0n 0.45000 36259.9n 0.45000 36260.0n 0.45000 36399.9n 0.45000 36400.0n 0.55000 36539.9n 0.55000 36540.0n 0.45000 36679.9n 0.45000 36680.0n 0.55000 36819.9n 0.55000 36820.0n 0.55000 36959.9n 0.55000 36960.0n 0.45000 37099.9n 0.45000 37100.0n 0.55000 37239.9n 0.55000 37240.0n 0.55000 37379.9n 0.55000 37380.0n 0.45000 37519.9n 0.45000 37520.0n 0.45000 37659.9n 0.45000 37660.0n 0.45000 37799.9n 0.45000 37800.0n 0.45000 37939.9n 0.45000 37940.0n 0.55000 38079.9n 0.55000 38080.0n 0.55000 38219.9n 0.55000 38220.0n 0.55000 38359.9n 0.55000 38360.0n 0.55000 38499.9n 0.55000 38500.0n 0.55000 38639.9n 0.55000 38640.0n 0.45000 38779.9n 0.45000 38780.0n 0.45000 38919.9n 0.45000 38920.0n 0.45000 39059.9n 0.45000 39060.0n 0.55000 39199.9n 0.55000 39200.0n 0.55000 39339.9n 0.55000 39340.0n 0.45000 39479.9n 0.45000 39480.0n 0.45000 39619.9n 0.45000 39620.0n 0.55000 39759.9n 0.55000 39760.0n 0.55000 39899.9n 0.55000 39900.0n 0.45000 40039.9n 0.45000 40040.0n 0.45000 40179.9n 0.45000 40180.0n 0.55000 40319.9n 0.55000 40320.0n 0.45000 40459.9n 0.45000 40460.0n 0.55000 40599.9n 0.55000 40600.0n 0.45000 40739.9n 0.45000 40740.0n 0.55000 40879.9n 0.55000 40880.0n 0.45000 41019.9n 0.45000 41020.0n 0.55000 41159.9n 0.55000 41160.0n 0.55000 41299.9n 0.55000 41300.0n 0.55000 41439.9n 0.55000 41440.0n 0.55000 41579.9n 0.55000 41580.0n 0.55000 41719.9n 0.55000 41720.0n 0.55000 41859.9n 0.55000 41860.0n 0.45000 41999.9n 0.45000 42000.0n 0.55000 42139.9n 0.55000 42140.0n 0.45000 42279.9n 0.45000 42280.0n 0.45000 42419.9n 0.45000 42420.0n 0.45000 42559.9n 0.45000 42560.0n 0.55000 42699.9n 0.55000 42700.0n 0.45000 42839.9n 0.45000 42840.0n 0.45000 42979.9n 0.45000 42980.0n 0.55000 43119.9n 0.55000 43120.0n 0.45000 43259.9n 0.45000 43260.0n 0.45000 43399.9n 0.45000 43400.0n 0.45000 43539.9n 0.45000 43540.0n 0.55000 43679.9n 0.55000 43680.0n 0.55000 43819.9n 0.55000 43820.0n 0.55000 43959.9n 0.55000 43960.0n 0.55000 44099.9n 0.55000 44100.0n 0.55000 44239.9n 0.55000 44240.0n 0.55000 44379.9n 0.55000 44380.0n 0.45000 44519.9n 0.45000 44520.0n 0.45000 44659.9n 0.45000 44660.0n 0.45000 44799.9n 0.45000 44800.0n 0.45000 44939.9n 0.45000 44940.0n 0.55000 45079.9n 0.55000 45080.0n 0.55000 45219.9n 0.55000 45220.0n 0.55000 45359.9n 0.55000 45360.0n 0.55000 45499.9n 0.55000 45500.0n 0.55000 45639.9n 0.55000 45640.0n 0.45000 45779.9n 0.45000 45780.0n 0.45000 45919.9n 0.45000 45920.0n 0.45000 46059.9n 0.45000 46060.0n 0.45000 46199.9n 0.45000 46200.0n 0.45000 46339.9n 0.45000 46340.0n 0.45000 46479.9n 0.45000 46480.0n 0.45000 46619.9n 0.45000 46620.0n 0.55000 46759.9n 0.55000 46760.0n 0.55000 46899.9n 0.55000 46900.0n 0.45000 47039.9n 0.45000 47040.0n 0.50000 47179.9n 0.50000 47180.0n 0.50000 47319.9n 0.50000 47320.0n 0.50000 47459.9n 0.50000 47460.0n 0.50000 47599.9n 0.50000 47600.0n 0.50000 47739.9n 0.50000 47740.0n 0.50000 47879.9n 0.50000 47880.0n 0.50000 48019.9n 0.50000 48020.0n 0.50000 48159.9n 0.50000 48160.0n 0.50000 48299.9n 0.50000 48300.0n 0.50000 48439.9n 0.50000 48440.0n 0.50000 48579.9n 0.50000 48580.0n 0.50000 48719.9n 0.50000 48720.0n 0.50000 48859.9n 0.50000 48860.0n 0.50000 48999.9n 0.50000 49000.0n 0.50000 49139.9n 0.50000 49140.0n 0.50000 49279.9n 0.50000 49280.0n 0.50000 49419.9n 0.50000 49420.0n 0.50000 49559.9n 0.50000 49560.0n 0.50000 49699.9n 0.50000 49700.0n 0.50000 49839.9n 0.50000 49840.0n 0.50000 49979.9n 0.50000 49980.0n 0.50000 50119.9n 0.50000 50120.0n 0.50000 50259.9n 0.50000 50260.0n 0.50000 50399.9n 0.50000 50400.0n 0.50000 50539.9n 0.50000 50540.0n 0.50000 50679.9n 0.50000 50680.0n 0.50000 50819.9n 0.50000 50820.0n 0.50000 50959.9n 0.50000 50960.0n 0.50000 51099.9n 0.50000 51100.0n 0.50000 51239.9n 0.50000 51240.0n 0.50000 51379.9n 0.50000 51380.0n 0.50000 51519.9n 0.50000 51520.0n 0.50000 51659.9n 0.50000 51660.0n 0.50000 51799.9n 0.50000 51800.0n 0.50000 51939.9n 0.50000 51940.0n 0.50000 52079.9n 0.50000 52080.0n 0.50000 52219.9n 0.50000 52220.0n 0.50000 52359.9n 0.50000 52360.0n 0.50000 52499.9n 0.50000 52500.0n 0.50000)
Vwih_p_0_0 wih_p_0_0 0 0.9
Vwih_n_0_0 wih_n_0_0 0 0.3
Vwih_p_1_0 wih_p_1_0 0 0.3
Vwih_n_1_0 wih_n_1_0 0 0.8077526372768347
Vwih_p_2_0 wih_p_2_0 0 0.9
Vwih_n_2_0 wih_n_2_0 0 0.3
Xcm_xh0 xhp0 xhn0 vdd cmld
Rnd_xh0 xhp0 xhn0 20k
Cxh0p xhp0 0 1e-13
Cxh0n xhn0 0 1e-13
Xih_0_0 a_xp0 a_xn0 wih_p_0_0 wih_n_0_0 xhp0 xhn0 vdd vbsyn gsyn
Xih_1_0 a_xp1 a_xn1 wih_p_1_0 wih_n_1_0 xhp0 xhn0 vdd vbsyn gsyn
Xih_2_0 a_xp2 a_xn2 wih_p_2_0 wih_n_2_0 xhp0 xhn0 vdd vbsyn gsyn
Xn0 xhp0 xhn0 ahp0 ahn0 vdd vbneu dneuron
Vwih_p_0_1 wih_p_0_1 0 0.4076074543279496
Vwih_n_0_1 wih_n_0_1 0 0.5923925456720505
Vwih_p_1_1 wih_p_1_1 0 0.6875517955179162
Vwih_n_1_1 wih_n_1_1 0 0.31244820448208377
Vwih_p_2_1 wih_p_2_1 0 0.9
Vwih_n_2_1 wih_n_2_1 0 0.3
Xcm_xh1 xhp1 xhn1 vdd cmld
Rnd_xh1 xhp1 xhn1 20k
Cxh1p xhp1 0 1e-13
Cxh1n xhn1 0 1e-13
Xih_0_1 a_xp0 a_xn0 wih_p_0_1 wih_n_0_1 xhp1 xhn1 vdd vbsyn gsyn
Xih_1_1 a_xp1 a_xn1 wih_p_1_1 wih_n_1_1 xhp1 xhn1 vdd vbsyn gsyn
Xih_2_1 a_xp2 a_xn2 wih_p_2_1 wih_n_2_1 xhp1 xhn1 vdd vbsyn gsyn
Xn1 xhp1 xhn1 ahp1 ahn1 vdd vbneu dneuron
Vwih_p_0_2 wih_p_0_2 0 0.6986905748958001
Vwih_n_0_2 wih_n_0_2 0 0.30130942510419984
Vwih_p_1_2 wih_p_1_2 0 0.8611596583173695
Vwih_n_1_2 wih_n_1_2 0 0.3
Vwih_p_2_2 wih_p_2_2 0 0.3
Vwih_n_2_2 wih_n_2_2 0 0.9
Xcm_xh2 xhp2 xhn2 vdd cmld
Rnd_xh2 xhp2 xhn2 20k
Cxh2p xhp2 0 1e-13
Cxh2n xhn2 0 1e-13
Xih_0_2 a_xp0 a_xn0 wih_p_0_2 wih_n_0_2 xhp2 xhn2 vdd vbsyn gsyn
Xih_1_2 a_xp1 a_xn1 wih_p_1_2 wih_n_1_2 xhp2 xhn2 vdd vbsyn gsyn
Xih_2_2 a_xp2 a_xn2 wih_p_2_2 wih_n_2_2 xhp2 xhn2 vdd vbsyn gsyn
Xn2 xhp2 xhn2 ahp2 ahn2 vdd vbneu dneuron
Vwih_p_0_3 wih_p_0_3 0 0.3
Vwih_n_0_3 wih_n_0_3 0 0.7073156875091838
Vwih_p_1_3 wih_p_1_3 0 0.9
Vwih_n_1_3 wih_n_1_3 0 0.3
Vwih_p_2_3 wih_p_2_3 0 0.3968886139217385
Vwih_n_2_3 wih_n_2_3 0 0.6031113860782614
Xcm_xh3 xhp3 xhn3 vdd cmld
Rnd_xh3 xhp3 xhn3 20k
Cxh3p xhp3 0 1e-13
Cxh3n xhn3 0 1e-13
Xih_0_3 a_xp0 a_xn0 wih_p_0_3 wih_n_0_3 xhp3 xhn3 vdd vbsyn gsyn
Xih_1_3 a_xp1 a_xn1 wih_p_1_3 wih_n_1_3 xhp3 xhn3 vdd vbsyn gsyn
Xih_2_3 a_xp2 a_xn2 wih_p_2_3 wih_n_2_3 xhp3 xhn3 vdd vbsyn gsyn
Xn3 xhp3 xhn3 ahp3 ahn3 vdd vbneu dneuron
Vwih_p_0_4 wih_p_0_4 0 0.643383333655023
Vwih_n_0_4 wih_n_0_4 0 0.356616666344977
Vwih_p_1_4 wih_p_1_4 0 0.426609605197966
Vwih_n_1_4 wih_n_1_4 0 0.573390394802034
Vwih_p_2_4 wih_p_2_4 0 0.3
Vwih_n_2_4 wih_n_2_4 0 0.779710110256914
Xcm_xh4 xhp4 xhn4 vdd cmld
Rnd_xh4 xhp4 xhn4 20k
Cxh4p xhp4 0 1e-13
Cxh4n xhn4 0 1e-13
Xih_0_4 a_xp0 a_xn0 wih_p_0_4 wih_n_0_4 xhp4 xhn4 vdd vbsyn gsyn
Xih_1_4 a_xp1 a_xn1 wih_p_1_4 wih_n_1_4 xhp4 xhn4 vdd vbsyn gsyn
Xih_2_4 a_xp2 a_xn2 wih_p_2_4 wih_n_2_4 xhp4 xhn4 vdd vbsyn gsyn
Xn4 xhp4 xhn4 ahp4 ahn4 vdd vbneu dneuron
Vwih_p_0_5 wih_p_0_5 0 0.3
Vwih_n_0_5 wih_n_0_5 0 0.9
Vwih_p_1_5 wih_p_1_5 0 0.3
Vwih_n_1_5 wih_n_1_5 0 0.9
Vwih_p_2_5 wih_p_2_5 0 0.9
Vwih_n_2_5 wih_n_2_5 0 0.3
Xcm_xh5 xhp5 xhn5 vdd cmld
Rnd_xh5 xhp5 xhn5 20k
Cxh5p xhp5 0 1e-13
Cxh5n xhn5 0 1e-13
Xih_0_5 a_xp0 a_xn0 wih_p_0_5 wih_n_0_5 xhp5 xhn5 vdd vbsyn gsyn
Xih_1_5 a_xp1 a_xn1 wih_p_1_5 wih_n_1_5 xhp5 xhn5 vdd vbsyn gsyn
Xih_2_5 a_xp2 a_xn2 wih_p_2_5 wih_n_2_5 xhp5 xhn5 vdd vbsyn gsyn
Xn5 xhp5 xhn5 ahp5 ahn5 vdd vbneu dneuron
Vwih_p_0_6 wih_p_0_6 0 0.4644227134047597
Vwih_n_0_6 wih_n_0_6 0 0.5355772865952403
Vwih_p_1_6 wih_p_1_6 0 0.3
Vwih_n_1_6 wih_n_1_6 0 0.9
Vwih_p_2_6 wih_p_2_6 0 0.3
Vwih_n_2_6 wih_n_2_6 0 0.9
Xcm_xh6 xhp6 xhn6 vdd cmld
Rnd_xh6 xhp6 xhn6 20k
Cxh6p xhp6 0 1e-13
Cxh6n xhn6 0 1e-13
Xih_0_6 a_xp0 a_xn0 wih_p_0_6 wih_n_0_6 xhp6 xhn6 vdd vbsyn gsyn
Xih_1_6 a_xp1 a_xn1 wih_p_1_6 wih_n_1_6 xhp6 xhn6 vdd vbsyn gsyn
Xih_2_6 a_xp2 a_xn2 wih_p_2_6 wih_n_2_6 xhp6 xhn6 vdd vbsyn gsyn
Xn6 xhp6 xhn6 ahp6 ahn6 vdd vbneu dneuron
Vwih_p_0_7 wih_p_0_7 0 0.8930428788399948
Vwih_n_0_7 wih_n_0_7 0 0.3
Vwih_p_1_7 wih_p_1_7 0 0.3
Vwih_n_1_7 wih_n_1_7 0 0.9
Vwih_p_2_7 wih_p_2_7 0 0.3
Vwih_n_2_7 wih_n_2_7 0 0.7814083238372862
Xcm_xh7 xhp7 xhn7 vdd cmld
Rnd_xh7 xhp7 xhn7 20k
Cxh7p xhp7 0 1e-13
Cxh7n xhn7 0 1e-13
Xih_0_7 a_xp0 a_xn0 wih_p_0_7 wih_n_0_7 xhp7 xhn7 vdd vbsyn gsyn
Xih_1_7 a_xp1 a_xn1 wih_p_1_7 wih_n_1_7 xhp7 xhn7 vdd vbsyn gsyn
Xih_2_7 a_xp2 a_xn2 wih_p_2_7 wih_n_2_7 xhp7 xhn7 vdd vbsyn gsyn
Xn7 xhp7 xhn7 ahp7 ahn7 vdd vbneu dneuron
Vwih_p_0_8 wih_p_0_8 0 0.3
Vwih_n_0_8 wih_n_0_8 0 0.9
Vwih_p_1_8 wih_p_1_8 0 0.3
Vwih_n_1_8 wih_n_1_8 0 0.9
Vwih_p_2_8 wih_p_2_8 0 0.9
Vwih_n_2_8 wih_n_2_8 0 0.3
Xcm_xh8 xhp8 xhn8 vdd cmld
Rnd_xh8 xhp8 xhn8 20k
Cxh8p xhp8 0 1e-13
Cxh8n xhn8 0 1e-13
Xih_0_8 a_xp0 a_xn0 wih_p_0_8 wih_n_0_8 xhp8 xhn8 vdd vbsyn gsyn
Xih_1_8 a_xp1 a_xn1 wih_p_1_8 wih_n_1_8 xhp8 xhn8 vdd vbsyn gsyn
Xih_2_8 a_xp2 a_xn2 wih_p_2_8 wih_n_2_8 xhp8 xhn8 vdd vbsyn gsyn
Xn8 xhp8 xhn8 ahp8 ahn8 vdd vbneu dneuron
Vwih_p_0_9 wih_p_0_9 0 0.43659969851895275
Vwih_n_0_9 wih_n_0_9 0 0.5634003014810472
Vwih_p_1_9 wih_p_1_9 0 0.35532188681769517
Vwih_n_1_9 wih_n_1_9 0 0.6446781131823048
Vwih_p_2_9 wih_p_2_9 0 0.3
Vwih_n_2_9 wih_n_2_9 0 0.770652332104687
Xcm_xh9 xhp9 xhn9 vdd cmld
Rnd_xh9 xhp9 xhn9 20k
Cxh9p xhp9 0 1e-13
Cxh9n xhn9 0 1e-13
Xih_0_9 a_xp0 a_xn0 wih_p_0_9 wih_n_0_9 xhp9 xhn9 vdd vbsyn gsyn
Xih_1_9 a_xp1 a_xn1 wih_p_1_9 wih_n_1_9 xhp9 xhn9 vdd vbsyn gsyn
Xih_2_9 a_xp2 a_xn2 wih_p_2_9 wih_n_2_9 xhp9 xhn9 vdd vbsyn gsyn
Xn9 xhp9 xhn9 ahp9 ahn9 vdd vbneu dneuron
Vwih_p_0_10 wih_p_0_10 0 0.8206037983083873
Vwih_n_0_10 wih_n_0_10 0 0.3
Vwih_p_1_10 wih_p_1_10 0 0.5276620970012434
Vwih_n_1_10 wih_n_1_10 0 0.47233790299875655
Vwih_p_2_10 wih_p_2_10 0 0.6315537008964082
Vwih_n_2_10 wih_n_2_10 0 0.36844629910359183
Xcm_xh10 xhp10 xhn10 vdd cmld
Rnd_xh10 xhp10 xhn10 20k
Cxh10p xhp10 0 1e-13
Cxh10n xhn10 0 1e-13
Xih_0_10 a_xp0 a_xn0 wih_p_0_10 wih_n_0_10 xhp10 xhn10 vdd vbsyn gsyn
Xih_1_10 a_xp1 a_xn1 wih_p_1_10 wih_n_1_10 xhp10 xhn10 vdd vbsyn gsyn
Xih_2_10 a_xp2 a_xn2 wih_p_2_10 wih_n_2_10 xhp10 xhn10 vdd vbsyn gsyn
Xn10 xhp10 xhn10 ahp10 ahn10 vdd vbneu dneuron
Vwih_p_0_11 wih_p_0_11 0 0.5615896328228672
Vwih_n_0_11 wih_n_0_11 0 0.4384103671771328
Vwih_p_1_11 wih_p_1_11 0 0.3392052445189821
Vwih_n_1_11 wih_n_1_11 0 0.6607947554810178
Vwih_p_2_11 wih_p_2_11 0 0.3
Vwih_n_2_11 wih_n_2_11 0 0.7163998120574444
Xcm_xh11 xhp11 xhn11 vdd cmld
Rnd_xh11 xhp11 xhn11 20k
Cxh11p xhp11 0 1e-13
Cxh11n xhn11 0 1e-13
Xih_0_11 a_xp0 a_xn0 wih_p_0_11 wih_n_0_11 xhp11 xhn11 vdd vbsyn gsyn
Xih_1_11 a_xp1 a_xn1 wih_p_1_11 wih_n_1_11 xhp11 xhn11 vdd vbsyn gsyn
Xih_2_11 a_xp2 a_xn2 wih_p_2_11 wih_n_2_11 xhp11 xhn11 vdd vbsyn gsyn
Xn11 xhp11 xhn11 ahp11 ahn11 vdd vbneu dneuron
Vwih_p_0_12 wih_p_0_12 0 0.3
Vwih_n_0_12 wih_n_0_12 0 0.9
Vwih_p_1_12 wih_p_1_12 0 0.3
Vwih_n_1_12 wih_n_1_12 0 0.7213002021183876
Vwih_p_2_12 wih_p_2_12 0 0.9
Vwih_n_2_12 wih_n_2_12 0 0.3
Xcm_xh12 xhp12 xhn12 vdd cmld
Rnd_xh12 xhp12 xhn12 20k
Cxh12p xhp12 0 1e-13
Cxh12n xhn12 0 1e-13
Xih_0_12 a_xp0 a_xn0 wih_p_0_12 wih_n_0_12 xhp12 xhn12 vdd vbsyn gsyn
Xih_1_12 a_xp1 a_xn1 wih_p_1_12 wih_n_1_12 xhp12 xhn12 vdd vbsyn gsyn
Xih_2_12 a_xp2 a_xn2 wih_p_2_12 wih_n_2_12 xhp12 xhn12 vdd vbsyn gsyn
Xn12 xhp12 xhn12 ahp12 ahn12 vdd vbneu dneuron
Vwih_p_0_13 wih_p_0_13 0 0.3
Vwih_n_0_13 wih_n_0_13 0 0.9
Vwih_p_1_13 wih_p_1_13 0 0.5019673310802524
Vwih_n_1_13 wih_n_1_13 0 0.4980326689197476
Vwih_p_2_13 wih_p_2_13 0 0.6510764412903762
Vwih_n_2_13 wih_n_2_13 0 0.3489235587096237
Xcm_xh13 xhp13 xhn13 vdd cmld
Rnd_xh13 xhp13 xhn13 20k
Cxh13p xhp13 0 1e-13
Cxh13n xhn13 0 1e-13
Xih_0_13 a_xp0 a_xn0 wih_p_0_13 wih_n_0_13 xhp13 xhn13 vdd vbsyn gsyn
Xih_1_13 a_xp1 a_xn1 wih_p_1_13 wih_n_1_13 xhp13 xhn13 vdd vbsyn gsyn
Xih_2_13 a_xp2 a_xn2 wih_p_2_13 wih_n_2_13 xhp13 xhn13 vdd vbsyn gsyn
Xn13 xhp13 xhn13 ahp13 ahn13 vdd vbneu dneuron
Vwih_p_0_14 wih_p_0_14 0 0.9
Vwih_n_0_14 wih_n_0_14 0 0.3
Vwih_p_1_14 wih_p_1_14 0 0.9
Vwih_n_1_14 wih_n_1_14 0 0.3
Vwih_p_2_14 wih_p_2_14 0 0.321441830538693
Vwih_n_2_14 wih_n_2_14 0 0.678558169461307
Xcm_xh14 xhp14 xhn14 vdd cmld
Rnd_xh14 xhp14 xhn14 20k
Cxh14p xhp14 0 1e-13
Cxh14n xhn14 0 1e-13
Xih_0_14 a_xp0 a_xn0 wih_p_0_14 wih_n_0_14 xhp14 xhn14 vdd vbsyn gsyn
Xih_1_14 a_xp1 a_xn1 wih_p_1_14 wih_n_1_14 xhp14 xhn14 vdd vbsyn gsyn
Xih_2_14 a_xp2 a_xn2 wih_p_2_14 wih_n_2_14 xhp14 xhn14 vdd vbsyn gsyn
Xn14 xhp14 xhn14 ahp14 ahn14 vdd vbneu dneuron
Vwih_p_0_15 wih_p_0_15 0 0.3
Vwih_n_0_15 wih_n_0_15 0 0.8946964794631206
Vwih_p_1_15 wih_p_1_15 0 0.9
Vwih_n_1_15 wih_n_1_15 0 0.3
Vwih_p_2_15 wih_p_2_15 0 0.5958540050197993
Vwih_n_2_15 wih_n_2_15 0 0.4041459949802006
Xcm_xh15 xhp15 xhn15 vdd cmld
Rnd_xh15 xhp15 xhn15 20k
Cxh15p xhp15 0 1e-13
Cxh15n xhn15 0 1e-13
Xih_0_15 a_xp0 a_xn0 wih_p_0_15 wih_n_0_15 xhp15 xhn15 vdd vbsyn gsyn
Xih_1_15 a_xp1 a_xn1 wih_p_1_15 wih_n_1_15 xhp15 xhn15 vdd vbsyn gsyn
Xih_2_15 a_xp2 a_xn2 wih_p_2_15 wih_n_2_15 xhp15 xhn15 vdd vbsyn gsyn
Xn15 xhp15 xhn15 ahp15 ahn15 vdd vbneu dneuron
Vwih_p_0_16 wih_p_0_16 0 0.9
Vwih_n_0_16 wih_n_0_16 0 0.3
Vwih_p_1_16 wih_p_1_16 0 0.8264016782997259
Vwih_n_1_16 wih_n_1_16 0 0.3
Vwih_p_2_16 wih_p_2_16 0 0.3
Vwih_n_2_16 wih_n_2_16 0 0.8009587065328215
Xcm_xh16 xhp16 xhn16 vdd cmld
Rnd_xh16 xhp16 xhn16 20k
Cxh16p xhp16 0 1e-13
Cxh16n xhn16 0 1e-13
Xih_0_16 a_xp0 a_xn0 wih_p_0_16 wih_n_0_16 xhp16 xhn16 vdd vbsyn gsyn
Xih_1_16 a_xp1 a_xn1 wih_p_1_16 wih_n_1_16 xhp16 xhn16 vdd vbsyn gsyn
Xih_2_16 a_xp2 a_xn2 wih_p_2_16 wih_n_2_16 xhp16 xhn16 vdd vbsyn gsyn
Xn16 xhp16 xhn16 ahp16 ahn16 vdd vbneu dneuron
Vwih_p_0_17 wih_p_0_17 0 0.4115141976338063
Vwih_n_0_17 wih_n_0_17 0 0.5884858023661936
Vwih_p_1_17 wih_p_1_17 0 0.6903674851964131
Vwih_n_1_17 wih_n_1_17 0 0.3096325148035869
Vwih_p_2_17 wih_p_2_17 0 0.7253099866650734
Vwih_n_2_17 wih_n_2_17 0 0.3
Xcm_xh17 xhp17 xhn17 vdd cmld
Rnd_xh17 xhp17 xhn17 20k
Cxh17p xhp17 0 1e-13
Cxh17n xhn17 0 1e-13
Xih_0_17 a_xp0 a_xn0 wih_p_0_17 wih_n_0_17 xhp17 xhn17 vdd vbsyn gsyn
Xih_1_17 a_xp1 a_xn1 wih_p_1_17 wih_n_1_17 xhp17 xhn17 vdd vbsyn gsyn
Xih_2_17 a_xp2 a_xn2 wih_p_2_17 wih_n_2_17 xhp17 xhn17 vdd vbsyn gsyn
Xn17 xhp17 xhn17 ahp17 ahn17 vdd vbneu dneuron
Vwih_p_0_18 wih_p_0_18 0 0.3
Vwih_n_0_18 wih_n_0_18 0 0.9
Vwih_p_1_18 wih_p_1_18 0 0.3
Vwih_n_1_18 wih_n_1_18 0 0.9
Vwih_p_2_18 wih_p_2_18 0 0.3
Vwih_n_2_18 wih_n_2_18 0 0.9
Xcm_xh18 xhp18 xhn18 vdd cmld
Rnd_xh18 xhp18 xhn18 20k
Cxh18p xhp18 0 1e-13
Cxh18n xhn18 0 1e-13
Xih_0_18 a_xp0 a_xn0 wih_p_0_18 wih_n_0_18 xhp18 xhn18 vdd vbsyn gsyn
Xih_1_18 a_xp1 a_xn1 wih_p_1_18 wih_n_1_18 xhp18 xhn18 vdd vbsyn gsyn
Xih_2_18 a_xp2 a_xn2 wih_p_2_18 wih_n_2_18 xhp18 xhn18 vdd vbsyn gsyn
Xn18 xhp18 xhn18 ahp18 ahn18 vdd vbneu dneuron
Vwih_p_0_19 wih_p_0_19 0 0.7777220499589362
Vwih_n_0_19 wih_n_0_19 0 0.3
Vwih_p_1_19 wih_p_1_19 0 0.4310427827422266
Vwih_n_1_19 wih_n_1_19 0 0.5689572172577734
Vwih_p_2_19 wih_p_2_19 0 0.3
Vwih_n_2_19 wih_n_2_19 0 0.9
Xcm_xh19 xhp19 xhn19 vdd cmld
Rnd_xh19 xhp19 xhn19 20k
Cxh19p xhp19 0 1e-13
Cxh19n xhn19 0 1e-13
Xih_0_19 a_xp0 a_xn0 wih_p_0_19 wih_n_0_19 xhp19 xhn19 vdd vbsyn gsyn
Xih_1_19 a_xp1 a_xn1 wih_p_1_19 wih_n_1_19 xhp19 xhn19 vdd vbsyn gsyn
Xih_2_19 a_xp2 a_xn2 wih_p_2_19 wih_n_2_19 xhp19 xhn19 vdd vbsyn gsyn
Xn19 xhp19 xhn19 ahp19 ahn19 vdd vbneu dneuron
Vwih_p_0_20 wih_p_0_20 0 0.3
Vwih_n_0_20 wih_n_0_20 0 0.7478781116735951
Vwih_p_1_20 wih_p_1_20 0 0.3
Vwih_n_1_20 wih_n_1_20 0 0.9
Vwih_p_2_20 wih_p_2_20 0 0.3815696565850669
Vwih_n_2_20 wih_n_2_20 0 0.6184303434149331
Xcm_xh20 xhp20 xhn20 vdd cmld
Rnd_xh20 xhp20 xhn20 20k
Cxh20p xhp20 0 1e-13
Cxh20n xhn20 0 1e-13
Xih_0_20 a_xp0 a_xn0 wih_p_0_20 wih_n_0_20 xhp20 xhn20 vdd vbsyn gsyn
Xih_1_20 a_xp1 a_xn1 wih_p_1_20 wih_n_1_20 xhp20 xhn20 vdd vbsyn gsyn
Xih_2_20 a_xp2 a_xn2 wih_p_2_20 wih_n_2_20 xhp20 xhn20 vdd vbsyn gsyn
Xn20 xhp20 xhn20 ahp20 ahn20 vdd vbneu dneuron
Vwih_p_0_21 wih_p_0_21 0 0.3
Vwih_n_0_21 wih_n_0_21 0 0.8894118236059116
Vwih_p_1_21 wih_p_1_21 0 0.3
Vwih_n_1_21 wih_n_1_21 0 0.7510846099149556
Vwih_p_2_21 wih_p_2_21 0 0.46204030518827083
Vwih_n_2_21 wih_n_2_21 0 0.5379596948117292
Xcm_xh21 xhp21 xhn21 vdd cmld
Rnd_xh21 xhp21 xhn21 20k
Cxh21p xhp21 0 1e-13
Cxh21n xhn21 0 1e-13
Xih_0_21 a_xp0 a_xn0 wih_p_0_21 wih_n_0_21 xhp21 xhn21 vdd vbsyn gsyn
Xih_1_21 a_xp1 a_xn1 wih_p_1_21 wih_n_1_21 xhp21 xhn21 vdd vbsyn gsyn
Xih_2_21 a_xp2 a_xn2 wih_p_2_21 wih_n_2_21 xhp21 xhn21 vdd vbsyn gsyn
Xn21 xhp21 xhn21 ahp21 ahn21 vdd vbneu dneuron
Vwih_p_0_22 wih_p_0_22 0 0.582183485192292
Vwih_n_0_22 wih_n_0_22 0 0.417816514807708
Vwih_p_1_22 wih_p_1_22 0 0.5267999164136071
Vwih_n_1_22 wih_n_1_22 0 0.47320008358639293
Vwih_p_2_22 wih_p_2_22 0 0.9
Vwih_n_2_22 wih_n_2_22 0 0.3
Xcm_xh22 xhp22 xhn22 vdd cmld
Rnd_xh22 xhp22 xhn22 20k
Cxh22p xhp22 0 1e-13
Cxh22n xhn22 0 1e-13
Xih_0_22 a_xp0 a_xn0 wih_p_0_22 wih_n_0_22 xhp22 xhn22 vdd vbsyn gsyn
Xih_1_22 a_xp1 a_xn1 wih_p_1_22 wih_n_1_22 xhp22 xhn22 vdd vbsyn gsyn
Xih_2_22 a_xp2 a_xn2 wih_p_2_22 wih_n_2_22 xhp22 xhn22 vdd vbsyn gsyn
Xn22 xhp22 xhn22 ahp22 ahn22 vdd vbneu dneuron
Vwih_p_0_23 wih_p_0_23 0 0.9
Vwih_n_0_23 wih_n_0_23 0 0.3
Vwih_p_1_23 wih_p_1_23 0 0.8833839713323164
Vwih_n_1_23 wih_n_1_23 0 0.3
Vwih_p_2_23 wih_p_2_23 0 0.41466542792757277
Vwih_n_2_23 wih_n_2_23 0 0.5853345720724272
Xcm_xh23 xhp23 xhn23 vdd cmld
Rnd_xh23 xhp23 xhn23 20k
Cxh23p xhp23 0 1e-13
Cxh23n xhn23 0 1e-13
Xih_0_23 a_xp0 a_xn0 wih_p_0_23 wih_n_0_23 xhp23 xhn23 vdd vbsyn gsyn
Xih_1_23 a_xp1 a_xn1 wih_p_1_23 wih_n_1_23 xhp23 xhn23 vdd vbsyn gsyn
Xih_2_23 a_xp2 a_xn2 wih_p_2_23 wih_n_2_23 xhp23 xhn23 vdd vbsyn gsyn
Xn23 xhp23 xhn23 ahp23 ahn23 vdd vbneu dneuron
Vwih_p_0_24 wih_p_0_24 0 0.8383855046538757
Vwih_n_0_24 wih_n_0_24 0 0.3
Vwih_p_1_24 wih_p_1_24 0 0.3
Vwih_n_1_24 wih_n_1_24 0 0.8272699221557627
Vwih_p_2_24 wih_p_2_24 0 0.3
Vwih_n_2_24 wih_n_2_24 0 0.8716267349962367
Xcm_xh24 xhp24 xhn24 vdd cmld
Rnd_xh24 xhp24 xhn24 20k
Cxh24p xhp24 0 1e-13
Cxh24n xhn24 0 1e-13
Xih_0_24 a_xp0 a_xn0 wih_p_0_24 wih_n_0_24 xhp24 xhn24 vdd vbsyn gsyn
Xih_1_24 a_xp1 a_xn1 wih_p_1_24 wih_n_1_24 xhp24 xhn24 vdd vbsyn gsyn
Xih_2_24 a_xp2 a_xn2 wih_p_2_24 wih_n_2_24 xhp24 xhn24 vdd vbsyn gsyn
Xn24 xhp24 xhn24 ahp24 ahn24 vdd vbneu dneuron
Vwih_p_0_25 wih_p_0_25 0 0.3
Vwih_n_0_25 wih_n_0_25 0 0.8920600682828617
Vwih_p_1_25 wih_p_1_25 0 0.6315617547273517
Vwih_n_1_25 wih_n_1_25 0 0.36843824527264835
Vwih_p_2_25 wih_p_2_25 0 0.9
Vwih_n_2_25 wih_n_2_25 0 0.3
Xcm_xh25 xhp25 xhn25 vdd cmld
Rnd_xh25 xhp25 xhn25 20k
Cxh25p xhp25 0 1e-13
Cxh25n xhn25 0 1e-13
Xih_0_25 a_xp0 a_xn0 wih_p_0_25 wih_n_0_25 xhp25 xhn25 vdd vbsyn gsyn
Xih_1_25 a_xp1 a_xn1 wih_p_1_25 wih_n_1_25 xhp25 xhn25 vdd vbsyn gsyn
Xih_2_25 a_xp2 a_xn2 wih_p_2_25 wih_n_2_25 xhp25 xhn25 vdd vbsyn gsyn
Xn25 xhp25 xhn25 ahp25 ahn25 vdd vbneu dneuron
Vwih_p_0_26 wih_p_0_26 0 0.9
Vwih_n_0_26 wih_n_0_26 0 0.3
Vwih_p_1_26 wih_p_1_26 0 0.9
Vwih_n_1_26 wih_n_1_26 0 0.3
Vwih_p_2_26 wih_p_2_26 0 0.8139593149778681
Vwih_n_2_26 wih_n_2_26 0 0.3
Xcm_xh26 xhp26 xhn26 vdd cmld
Rnd_xh26 xhp26 xhn26 20k
Cxh26p xhp26 0 1e-13
Cxh26n xhn26 0 1e-13
Xih_0_26 a_xp0 a_xn0 wih_p_0_26 wih_n_0_26 xhp26 xhn26 vdd vbsyn gsyn
Xih_1_26 a_xp1 a_xn1 wih_p_1_26 wih_n_1_26 xhp26 xhn26 vdd vbsyn gsyn
Xih_2_26 a_xp2 a_xn2 wih_p_2_26 wih_n_2_26 xhp26 xhn26 vdd vbsyn gsyn
Xn26 xhp26 xhn26 ahp26 ahn26 vdd vbneu dneuron
Vwih_p_0_27 wih_p_0_27 0 0.3
Vwih_n_0_27 wih_n_0_27 0 0.8097470131671487
Vwih_p_1_27 wih_p_1_27 0 0.5344916941866533
Vwih_n_1_27 wih_n_1_27 0 0.4655083058133466
Vwih_p_2_27 wih_p_2_27 0 0.7445566783958016
Vwih_n_2_27 wih_n_2_27 0 0.3
Xcm_xh27 xhp27 xhn27 vdd cmld
Rnd_xh27 xhp27 xhn27 20k
Cxh27p xhp27 0 1e-13
Cxh27n xhn27 0 1e-13
Xih_0_27 a_xp0 a_xn0 wih_p_0_27 wih_n_0_27 xhp27 xhn27 vdd vbsyn gsyn
Xih_1_27 a_xp1 a_xn1 wih_p_1_27 wih_n_1_27 xhp27 xhn27 vdd vbsyn gsyn
Xih_2_27 a_xp2 a_xn2 wih_p_2_27 wih_n_2_27 xhp27 xhn27 vdd vbsyn gsyn
Xn27 xhp27 xhn27 ahp27 ahn27 vdd vbneu dneuron
Vwih_p_0_28 wih_p_0_28 0 0.44498611311859815
Vwih_n_0_28 wih_n_0_28 0 0.5550138868814019
Vwih_p_1_28 wih_p_1_28 0 0.9
Vwih_n_1_28 wih_n_1_28 0 0.3
Vwih_p_2_28 wih_p_2_28 0 0.3
Vwih_n_2_28 wih_n_2_28 0 0.8689778346029556
Xcm_xh28 xhp28 xhn28 vdd cmld
Rnd_xh28 xhp28 xhn28 20k
Cxh28p xhp28 0 1e-13
Cxh28n xhn28 0 1e-13
Xih_0_28 a_xp0 a_xn0 wih_p_0_28 wih_n_0_28 xhp28 xhn28 vdd vbsyn gsyn
Xih_1_28 a_xp1 a_xn1 wih_p_1_28 wih_n_1_28 xhp28 xhn28 vdd vbsyn gsyn
Xih_2_28 a_xp2 a_xn2 wih_p_2_28 wih_n_2_28 xhp28 xhn28 vdd vbsyn gsyn
Xn28 xhp28 xhn28 ahp28 ahn28 vdd vbneu dneuron
Vwih_p_0_29 wih_p_0_29 0 0.3
Vwih_n_0_29 wih_n_0_29 0 0.8213620141203385
Vwih_p_1_29 wih_p_1_29 0 0.6710202455048602
Vwih_n_1_29 wih_n_1_29 0 0.32897975449513983
Vwih_p_2_29 wih_p_2_29 0 0.9
Vwih_n_2_29 wih_n_2_29 0 0.3
Xcm_xh29 xhp29 xhn29 vdd cmld
Rnd_xh29 xhp29 xhn29 20k
Cxh29p xhp29 0 1e-13
Cxh29n xhn29 0 1e-13
Xih_0_29 a_xp0 a_xn0 wih_p_0_29 wih_n_0_29 xhp29 xhn29 vdd vbsyn gsyn
Xih_1_29 a_xp1 a_xn1 wih_p_1_29 wih_n_1_29 xhp29 xhn29 vdd vbsyn gsyn
Xih_2_29 a_xp2 a_xn2 wih_p_2_29 wih_n_2_29 xhp29 xhn29 vdd vbsyn gsyn
Xn29 xhp29 xhn29 ahp29 ahn29 vdd vbneu dneuron
Vwih_p_0_30 wih_p_0_30 0 0.3
Vwih_n_0_30 wih_n_0_30 0 0.9
Vwih_p_1_30 wih_p_1_30 0 0.3
Vwih_n_1_30 wih_n_1_30 0 0.88071809457155
Vwih_p_2_30 wih_p_2_30 0 0.9
Vwih_n_2_30 wih_n_2_30 0 0.3
Xcm_xh30 xhp30 xhn30 vdd cmld
Rnd_xh30 xhp30 xhn30 20k
Cxh30p xhp30 0 1e-13
Cxh30n xhn30 0 1e-13
Xih_0_30 a_xp0 a_xn0 wih_p_0_30 wih_n_0_30 xhp30 xhn30 vdd vbsyn gsyn
Xih_1_30 a_xp1 a_xn1 wih_p_1_30 wih_n_1_30 xhp30 xhn30 vdd vbsyn gsyn
Xih_2_30 a_xp2 a_xn2 wih_p_2_30 wih_n_2_30 xhp30 xhn30 vdd vbsyn gsyn
Xn30 xhp30 xhn30 ahp30 ahn30 vdd vbneu dneuron
Vwih_p_0_31 wih_p_0_31 0 0.3
Vwih_n_0_31 wih_n_0_31 0 0.80552795301878
Vwih_p_1_31 wih_p_1_31 0 0.9
Vwih_n_1_31 wih_n_1_31 0 0.3
Vwih_p_2_31 wih_p_2_31 0 0.3
Vwih_n_2_31 wih_n_2_31 0 0.869683849401294
Xcm_xh31 xhp31 xhn31 vdd cmld
Rnd_xh31 xhp31 xhn31 20k
Cxh31p xhp31 0 1e-13
Cxh31n xhn31 0 1e-13
Xih_0_31 a_xp0 a_xn0 wih_p_0_31 wih_n_0_31 xhp31 xhn31 vdd vbsyn gsyn
Xih_1_31 a_xp1 a_xn1 wih_p_1_31 wih_n_1_31 xhp31 xhn31 vdd vbsyn gsyn
Xih_2_31 a_xp2 a_xn2 wih_p_2_31 wih_n_2_31 xhp31 xhn31 vdd vbsyn gsyn
Xn31 xhp31 xhn31 ahp31 ahn31 vdd vbneu dneuron
Vahb_p ahbias_p 0 0.8
Vahb_n ahbias_n 0 0.2
Xcm_mo0 mop0 mon0 vdd cmld
Rmo0 mop0 mon0 20k
Cmo0p mop0 0 1e-13
Cmo0n mon0 0 1e-13
Cwp_0_0 who_p_0_0 0 150p
Cwn_0_0 who_n_0_0 0 150p
Rwp_0_0 who_p_0_0 wcm 200meg
Rwn_0_0 who_n_0_0 wcm 200meg
Xsyn_0_0 ahp0 ahn0 who_p_0_0 who_n_0_0 mop0 mon0 vdd vbsyn gsyn
Cwp_1_0 who_p_1_0 0 150p
Cwn_1_0 who_n_1_0 0 150p
Rwp_1_0 who_p_1_0 wcm 200meg
Rwn_1_0 who_n_1_0 wcm 200meg
Xsyn_1_0 ahp1 ahn1 who_p_1_0 who_n_1_0 mop0 mon0 vdd vbsyn gsyn
Cwp_2_0 who_p_2_0 0 150p
Cwn_2_0 who_n_2_0 0 150p
Rwp_2_0 who_p_2_0 wcm 200meg
Rwn_2_0 who_n_2_0 wcm 200meg
Xsyn_2_0 ahp2 ahn2 who_p_2_0 who_n_2_0 mop0 mon0 vdd vbsyn gsyn
Cwp_3_0 who_p_3_0 0 150p
Cwn_3_0 who_n_3_0 0 150p
Rwp_3_0 who_p_3_0 wcm 200meg
Rwn_3_0 who_n_3_0 wcm 200meg
Xsyn_3_0 ahp3 ahn3 who_p_3_0 who_n_3_0 mop0 mon0 vdd vbsyn gsyn
Cwp_4_0 who_p_4_0 0 150p
Cwn_4_0 who_n_4_0 0 150p
Rwp_4_0 who_p_4_0 wcm 200meg
Rwn_4_0 who_n_4_0 wcm 200meg
Xsyn_4_0 ahp4 ahn4 who_p_4_0 who_n_4_0 mop0 mon0 vdd vbsyn gsyn
Cwp_5_0 who_p_5_0 0 150p
Cwn_5_0 who_n_5_0 0 150p
Rwp_5_0 who_p_5_0 wcm 200meg
Rwn_5_0 who_n_5_0 wcm 200meg
Xsyn_5_0 ahp5 ahn5 who_p_5_0 who_n_5_0 mop0 mon0 vdd vbsyn gsyn
Cwp_6_0 who_p_6_0 0 150p
Cwn_6_0 who_n_6_0 0 150p
Rwp_6_0 who_p_6_0 wcm 200meg
Rwn_6_0 who_n_6_0 wcm 200meg
Xsyn_6_0 ahp6 ahn6 who_p_6_0 who_n_6_0 mop0 mon0 vdd vbsyn gsyn
Cwp_7_0 who_p_7_0 0 150p
Cwn_7_0 who_n_7_0 0 150p
Rwp_7_0 who_p_7_0 wcm 200meg
Rwn_7_0 who_n_7_0 wcm 200meg
Xsyn_7_0 ahp7 ahn7 who_p_7_0 who_n_7_0 mop0 mon0 vdd vbsyn gsyn
Cwp_8_0 who_p_8_0 0 150p
Cwn_8_0 who_n_8_0 0 150p
Rwp_8_0 who_p_8_0 wcm 200meg
Rwn_8_0 who_n_8_0 wcm 200meg
Xsyn_8_0 ahp8 ahn8 who_p_8_0 who_n_8_0 mop0 mon0 vdd vbsyn gsyn
Cwp_9_0 who_p_9_0 0 150p
Cwn_9_0 who_n_9_0 0 150p
Rwp_9_0 who_p_9_0 wcm 200meg
Rwn_9_0 who_n_9_0 wcm 200meg
Xsyn_9_0 ahp9 ahn9 who_p_9_0 who_n_9_0 mop0 mon0 vdd vbsyn gsyn
Cwp_10_0 who_p_10_0 0 150p
Cwn_10_0 who_n_10_0 0 150p
Rwp_10_0 who_p_10_0 wcm 200meg
Rwn_10_0 who_n_10_0 wcm 200meg
Xsyn_10_0 ahp10 ahn10 who_p_10_0 who_n_10_0 mop0 mon0 vdd vbsyn gsyn
Cwp_11_0 who_p_11_0 0 150p
Cwn_11_0 who_n_11_0 0 150p
Rwp_11_0 who_p_11_0 wcm 200meg
Rwn_11_0 who_n_11_0 wcm 200meg
Xsyn_11_0 ahp11 ahn11 who_p_11_0 who_n_11_0 mop0 mon0 vdd vbsyn gsyn
Cwp_12_0 who_p_12_0 0 150p
Cwn_12_0 who_n_12_0 0 150p
Rwp_12_0 who_p_12_0 wcm 200meg
Rwn_12_0 who_n_12_0 wcm 200meg
Xsyn_12_0 ahp12 ahn12 who_p_12_0 who_n_12_0 mop0 mon0 vdd vbsyn gsyn
Cwp_13_0 who_p_13_0 0 150p
Cwn_13_0 who_n_13_0 0 150p
Rwp_13_0 who_p_13_0 wcm 200meg
Rwn_13_0 who_n_13_0 wcm 200meg
Xsyn_13_0 ahp13 ahn13 who_p_13_0 who_n_13_0 mop0 mon0 vdd vbsyn gsyn
Cwp_14_0 who_p_14_0 0 150p
Cwn_14_0 who_n_14_0 0 150p
Rwp_14_0 who_p_14_0 wcm 200meg
Rwn_14_0 who_n_14_0 wcm 200meg
Xsyn_14_0 ahp14 ahn14 who_p_14_0 who_n_14_0 mop0 mon0 vdd vbsyn gsyn
Cwp_15_0 who_p_15_0 0 150p
Cwn_15_0 who_n_15_0 0 150p
Rwp_15_0 who_p_15_0 wcm 200meg
Rwn_15_0 who_n_15_0 wcm 200meg
Xsyn_15_0 ahp15 ahn15 who_p_15_0 who_n_15_0 mop0 mon0 vdd vbsyn gsyn
Cwp_16_0 who_p_16_0 0 150p
Cwn_16_0 who_n_16_0 0 150p
Rwp_16_0 who_p_16_0 wcm 200meg
Rwn_16_0 who_n_16_0 wcm 200meg
Xsyn_16_0 ahp16 ahn16 who_p_16_0 who_n_16_0 mop0 mon0 vdd vbsyn gsyn
Cwp_17_0 who_p_17_0 0 150p
Cwn_17_0 who_n_17_0 0 150p
Rwp_17_0 who_p_17_0 wcm 200meg
Rwn_17_0 who_n_17_0 wcm 200meg
Xsyn_17_0 ahp17 ahn17 who_p_17_0 who_n_17_0 mop0 mon0 vdd vbsyn gsyn
Cwp_18_0 who_p_18_0 0 150p
Cwn_18_0 who_n_18_0 0 150p
Rwp_18_0 who_p_18_0 wcm 200meg
Rwn_18_0 who_n_18_0 wcm 200meg
Xsyn_18_0 ahp18 ahn18 who_p_18_0 who_n_18_0 mop0 mon0 vdd vbsyn gsyn
Cwp_19_0 who_p_19_0 0 150p
Cwn_19_0 who_n_19_0 0 150p
Rwp_19_0 who_p_19_0 wcm 200meg
Rwn_19_0 who_n_19_0 wcm 200meg
Xsyn_19_0 ahp19 ahn19 who_p_19_0 who_n_19_0 mop0 mon0 vdd vbsyn gsyn
Cwp_20_0 who_p_20_0 0 150p
Cwn_20_0 who_n_20_0 0 150p
Rwp_20_0 who_p_20_0 wcm 200meg
Rwn_20_0 who_n_20_0 wcm 200meg
Xsyn_20_0 ahp20 ahn20 who_p_20_0 who_n_20_0 mop0 mon0 vdd vbsyn gsyn
Cwp_21_0 who_p_21_0 0 150p
Cwn_21_0 who_n_21_0 0 150p
Rwp_21_0 who_p_21_0 wcm 200meg
Rwn_21_0 who_n_21_0 wcm 200meg
Xsyn_21_0 ahp21 ahn21 who_p_21_0 who_n_21_0 mop0 mon0 vdd vbsyn gsyn
Cwp_22_0 who_p_22_0 0 150p
Cwn_22_0 who_n_22_0 0 150p
Rwp_22_0 who_p_22_0 wcm 200meg
Rwn_22_0 who_n_22_0 wcm 200meg
Xsyn_22_0 ahp22 ahn22 who_p_22_0 who_n_22_0 mop0 mon0 vdd vbsyn gsyn
Cwp_23_0 who_p_23_0 0 150p
Cwn_23_0 who_n_23_0 0 150p
Rwp_23_0 who_p_23_0 wcm 200meg
Rwn_23_0 who_n_23_0 wcm 200meg
Xsyn_23_0 ahp23 ahn23 who_p_23_0 who_n_23_0 mop0 mon0 vdd vbsyn gsyn
Cwp_24_0 who_p_24_0 0 150p
Cwn_24_0 who_n_24_0 0 150p
Rwp_24_0 who_p_24_0 wcm 200meg
Rwn_24_0 who_n_24_0 wcm 200meg
Xsyn_24_0 ahp24 ahn24 who_p_24_0 who_n_24_0 mop0 mon0 vdd vbsyn gsyn
Cwp_25_0 who_p_25_0 0 150p
Cwn_25_0 who_n_25_0 0 150p
Rwp_25_0 who_p_25_0 wcm 200meg
Rwn_25_0 who_n_25_0 wcm 200meg
Xsyn_25_0 ahp25 ahn25 who_p_25_0 who_n_25_0 mop0 mon0 vdd vbsyn gsyn
Cwp_26_0 who_p_26_0 0 150p
Cwn_26_0 who_n_26_0 0 150p
Rwp_26_0 who_p_26_0 wcm 200meg
Rwn_26_0 who_n_26_0 wcm 200meg
Xsyn_26_0 ahp26 ahn26 who_p_26_0 who_n_26_0 mop0 mon0 vdd vbsyn gsyn
Cwp_27_0 who_p_27_0 0 150p
Cwn_27_0 who_n_27_0 0 150p
Rwp_27_0 who_p_27_0 wcm 200meg
Rwn_27_0 who_n_27_0 wcm 200meg
Xsyn_27_0 ahp27 ahn27 who_p_27_0 who_n_27_0 mop0 mon0 vdd vbsyn gsyn
Cwp_28_0 who_p_28_0 0 150p
Cwn_28_0 who_n_28_0 0 150p
Rwp_28_0 who_p_28_0 wcm 200meg
Rwn_28_0 who_n_28_0 wcm 200meg
Xsyn_28_0 ahp28 ahn28 who_p_28_0 who_n_28_0 mop0 mon0 vdd vbsyn gsyn
Cwp_29_0 who_p_29_0 0 150p
Cwn_29_0 who_n_29_0 0 150p
Rwp_29_0 who_p_29_0 wcm 200meg
Rwn_29_0 who_n_29_0 wcm 200meg
Xsyn_29_0 ahp29 ahn29 who_p_29_0 who_n_29_0 mop0 mon0 vdd vbsyn gsyn
Cwp_30_0 who_p_30_0 0 150p
Cwn_30_0 who_n_30_0 0 150p
Rwp_30_0 who_p_30_0 wcm 200meg
Rwn_30_0 who_n_30_0 wcm 200meg
Xsyn_30_0 ahp30 ahn30 who_p_30_0 who_n_30_0 mop0 mon0 vdd vbsyn gsyn
Cwp_31_0 who_p_31_0 0 150p
Cwn_31_0 who_n_31_0 0 150p
Rwp_31_0 who_p_31_0 wcm 200meg
Rwn_31_0 who_n_31_0 wcm 200meg
Xsyn_31_0 ahp31 ahn31 who_p_31_0 who_n_31_0 mop0 mon0 vdd vbsyn gsyn
Cwp_32_0 who_p_32_0 0 150p
Cwn_32_0 who_n_32_0 0 150p
Rwp_32_0 who_p_32_0 wcm 200meg
Rwn_32_0 who_n_32_0 wcm 200meg
Xsyn_32_0 ahbias_p ahbias_n who_p_32_0 who_n_32_0 mop0 mon0 vdd vbsyn gsyn
Xeo0 xop0 xon0 mop0 mon0 eop0 eon0 vdd gm esub
Xcm_mo1 mop1 mon1 vdd cmld
Rmo1 mop1 mon1 20k
Cmo1p mop1 0 1e-13
Cmo1n mon1 0 1e-13
Cwp_0_1 who_p_0_1 0 150p
Cwn_0_1 who_n_0_1 0 150p
Rwp_0_1 who_p_0_1 wcm 200meg
Rwn_0_1 who_n_0_1 wcm 200meg
Xsyn_0_1 ahp0 ahn0 who_p_0_1 who_n_0_1 mop1 mon1 vdd vbsyn gsyn
Cwp_1_1 who_p_1_1 0 150p
Cwn_1_1 who_n_1_1 0 150p
Rwp_1_1 who_p_1_1 wcm 200meg
Rwn_1_1 who_n_1_1 wcm 200meg
Xsyn_1_1 ahp1 ahn1 who_p_1_1 who_n_1_1 mop1 mon1 vdd vbsyn gsyn
Cwp_2_1 who_p_2_1 0 150p
Cwn_2_1 who_n_2_1 0 150p
Rwp_2_1 who_p_2_1 wcm 200meg
Rwn_2_1 who_n_2_1 wcm 200meg
Xsyn_2_1 ahp2 ahn2 who_p_2_1 who_n_2_1 mop1 mon1 vdd vbsyn gsyn
Cwp_3_1 who_p_3_1 0 150p
Cwn_3_1 who_n_3_1 0 150p
Rwp_3_1 who_p_3_1 wcm 200meg
Rwn_3_1 who_n_3_1 wcm 200meg
Xsyn_3_1 ahp3 ahn3 who_p_3_1 who_n_3_1 mop1 mon1 vdd vbsyn gsyn
Cwp_4_1 who_p_4_1 0 150p
Cwn_4_1 who_n_4_1 0 150p
Rwp_4_1 who_p_4_1 wcm 200meg
Rwn_4_1 who_n_4_1 wcm 200meg
Xsyn_4_1 ahp4 ahn4 who_p_4_1 who_n_4_1 mop1 mon1 vdd vbsyn gsyn
Cwp_5_1 who_p_5_1 0 150p
Cwn_5_1 who_n_5_1 0 150p
Rwp_5_1 who_p_5_1 wcm 200meg
Rwn_5_1 who_n_5_1 wcm 200meg
Xsyn_5_1 ahp5 ahn5 who_p_5_1 who_n_5_1 mop1 mon1 vdd vbsyn gsyn
Cwp_6_1 who_p_6_1 0 150p
Cwn_6_1 who_n_6_1 0 150p
Rwp_6_1 who_p_6_1 wcm 200meg
Rwn_6_1 who_n_6_1 wcm 200meg
Xsyn_6_1 ahp6 ahn6 who_p_6_1 who_n_6_1 mop1 mon1 vdd vbsyn gsyn
Cwp_7_1 who_p_7_1 0 150p
Cwn_7_1 who_n_7_1 0 150p
Rwp_7_1 who_p_7_1 wcm 200meg
Rwn_7_1 who_n_7_1 wcm 200meg
Xsyn_7_1 ahp7 ahn7 who_p_7_1 who_n_7_1 mop1 mon1 vdd vbsyn gsyn
Cwp_8_1 who_p_8_1 0 150p
Cwn_8_1 who_n_8_1 0 150p
Rwp_8_1 who_p_8_1 wcm 200meg
Rwn_8_1 who_n_8_1 wcm 200meg
Xsyn_8_1 ahp8 ahn8 who_p_8_1 who_n_8_1 mop1 mon1 vdd vbsyn gsyn
Cwp_9_1 who_p_9_1 0 150p
Cwn_9_1 who_n_9_1 0 150p
Rwp_9_1 who_p_9_1 wcm 200meg
Rwn_9_1 who_n_9_1 wcm 200meg
Xsyn_9_1 ahp9 ahn9 who_p_9_1 who_n_9_1 mop1 mon1 vdd vbsyn gsyn
Cwp_10_1 who_p_10_1 0 150p
Cwn_10_1 who_n_10_1 0 150p
Rwp_10_1 who_p_10_1 wcm 200meg
Rwn_10_1 who_n_10_1 wcm 200meg
Xsyn_10_1 ahp10 ahn10 who_p_10_1 who_n_10_1 mop1 mon1 vdd vbsyn gsyn
Cwp_11_1 who_p_11_1 0 150p
Cwn_11_1 who_n_11_1 0 150p
Rwp_11_1 who_p_11_1 wcm 200meg
Rwn_11_1 who_n_11_1 wcm 200meg
Xsyn_11_1 ahp11 ahn11 who_p_11_1 who_n_11_1 mop1 mon1 vdd vbsyn gsyn
Cwp_12_1 who_p_12_1 0 150p
Cwn_12_1 who_n_12_1 0 150p
Rwp_12_1 who_p_12_1 wcm 200meg
Rwn_12_1 who_n_12_1 wcm 200meg
Xsyn_12_1 ahp12 ahn12 who_p_12_1 who_n_12_1 mop1 mon1 vdd vbsyn gsyn
Cwp_13_1 who_p_13_1 0 150p
Cwn_13_1 who_n_13_1 0 150p
Rwp_13_1 who_p_13_1 wcm 200meg
Rwn_13_1 who_n_13_1 wcm 200meg
Xsyn_13_1 ahp13 ahn13 who_p_13_1 who_n_13_1 mop1 mon1 vdd vbsyn gsyn
Cwp_14_1 who_p_14_1 0 150p
Cwn_14_1 who_n_14_1 0 150p
Rwp_14_1 who_p_14_1 wcm 200meg
Rwn_14_1 who_n_14_1 wcm 200meg
Xsyn_14_1 ahp14 ahn14 who_p_14_1 who_n_14_1 mop1 mon1 vdd vbsyn gsyn
Cwp_15_1 who_p_15_1 0 150p
Cwn_15_1 who_n_15_1 0 150p
Rwp_15_1 who_p_15_1 wcm 200meg
Rwn_15_1 who_n_15_1 wcm 200meg
Xsyn_15_1 ahp15 ahn15 who_p_15_1 who_n_15_1 mop1 mon1 vdd vbsyn gsyn
Cwp_16_1 who_p_16_1 0 150p
Cwn_16_1 who_n_16_1 0 150p
Rwp_16_1 who_p_16_1 wcm 200meg
Rwn_16_1 who_n_16_1 wcm 200meg
Xsyn_16_1 ahp16 ahn16 who_p_16_1 who_n_16_1 mop1 mon1 vdd vbsyn gsyn
Cwp_17_1 who_p_17_1 0 150p
Cwn_17_1 who_n_17_1 0 150p
Rwp_17_1 who_p_17_1 wcm 200meg
Rwn_17_1 who_n_17_1 wcm 200meg
Xsyn_17_1 ahp17 ahn17 who_p_17_1 who_n_17_1 mop1 mon1 vdd vbsyn gsyn
Cwp_18_1 who_p_18_1 0 150p
Cwn_18_1 who_n_18_1 0 150p
Rwp_18_1 who_p_18_1 wcm 200meg
Rwn_18_1 who_n_18_1 wcm 200meg
Xsyn_18_1 ahp18 ahn18 who_p_18_1 who_n_18_1 mop1 mon1 vdd vbsyn gsyn
Cwp_19_1 who_p_19_1 0 150p
Cwn_19_1 who_n_19_1 0 150p
Rwp_19_1 who_p_19_1 wcm 200meg
Rwn_19_1 who_n_19_1 wcm 200meg
Xsyn_19_1 ahp19 ahn19 who_p_19_1 who_n_19_1 mop1 mon1 vdd vbsyn gsyn
Cwp_20_1 who_p_20_1 0 150p
Cwn_20_1 who_n_20_1 0 150p
Rwp_20_1 who_p_20_1 wcm 200meg
Rwn_20_1 who_n_20_1 wcm 200meg
Xsyn_20_1 ahp20 ahn20 who_p_20_1 who_n_20_1 mop1 mon1 vdd vbsyn gsyn
Cwp_21_1 who_p_21_1 0 150p
Cwn_21_1 who_n_21_1 0 150p
Rwp_21_1 who_p_21_1 wcm 200meg
Rwn_21_1 who_n_21_1 wcm 200meg
Xsyn_21_1 ahp21 ahn21 who_p_21_1 who_n_21_1 mop1 mon1 vdd vbsyn gsyn
Cwp_22_1 who_p_22_1 0 150p
Cwn_22_1 who_n_22_1 0 150p
Rwp_22_1 who_p_22_1 wcm 200meg
Rwn_22_1 who_n_22_1 wcm 200meg
Xsyn_22_1 ahp22 ahn22 who_p_22_1 who_n_22_1 mop1 mon1 vdd vbsyn gsyn
Cwp_23_1 who_p_23_1 0 150p
Cwn_23_1 who_n_23_1 0 150p
Rwp_23_1 who_p_23_1 wcm 200meg
Rwn_23_1 who_n_23_1 wcm 200meg
Xsyn_23_1 ahp23 ahn23 who_p_23_1 who_n_23_1 mop1 mon1 vdd vbsyn gsyn
Cwp_24_1 who_p_24_1 0 150p
Cwn_24_1 who_n_24_1 0 150p
Rwp_24_1 who_p_24_1 wcm 200meg
Rwn_24_1 who_n_24_1 wcm 200meg
Xsyn_24_1 ahp24 ahn24 who_p_24_1 who_n_24_1 mop1 mon1 vdd vbsyn gsyn
Cwp_25_1 who_p_25_1 0 150p
Cwn_25_1 who_n_25_1 0 150p
Rwp_25_1 who_p_25_1 wcm 200meg
Rwn_25_1 who_n_25_1 wcm 200meg
Xsyn_25_1 ahp25 ahn25 who_p_25_1 who_n_25_1 mop1 mon1 vdd vbsyn gsyn
Cwp_26_1 who_p_26_1 0 150p
Cwn_26_1 who_n_26_1 0 150p
Rwp_26_1 who_p_26_1 wcm 200meg
Rwn_26_1 who_n_26_1 wcm 200meg
Xsyn_26_1 ahp26 ahn26 who_p_26_1 who_n_26_1 mop1 mon1 vdd vbsyn gsyn
Cwp_27_1 who_p_27_1 0 150p
Cwn_27_1 who_n_27_1 0 150p
Rwp_27_1 who_p_27_1 wcm 200meg
Rwn_27_1 who_n_27_1 wcm 200meg
Xsyn_27_1 ahp27 ahn27 who_p_27_1 who_n_27_1 mop1 mon1 vdd vbsyn gsyn
Cwp_28_1 who_p_28_1 0 150p
Cwn_28_1 who_n_28_1 0 150p
Rwp_28_1 who_p_28_1 wcm 200meg
Rwn_28_1 who_n_28_1 wcm 200meg
Xsyn_28_1 ahp28 ahn28 who_p_28_1 who_n_28_1 mop1 mon1 vdd vbsyn gsyn
Cwp_29_1 who_p_29_1 0 150p
Cwn_29_1 who_n_29_1 0 150p
Rwp_29_1 who_p_29_1 wcm 200meg
Rwn_29_1 who_n_29_1 wcm 200meg
Xsyn_29_1 ahp29 ahn29 who_p_29_1 who_n_29_1 mop1 mon1 vdd vbsyn gsyn
Cwp_30_1 who_p_30_1 0 150p
Cwn_30_1 who_n_30_1 0 150p
Rwp_30_1 who_p_30_1 wcm 200meg
Rwn_30_1 who_n_30_1 wcm 200meg
Xsyn_30_1 ahp30 ahn30 who_p_30_1 who_n_30_1 mop1 mon1 vdd vbsyn gsyn
Cwp_31_1 who_p_31_1 0 150p
Cwn_31_1 who_n_31_1 0 150p
Rwp_31_1 who_p_31_1 wcm 200meg
Rwn_31_1 who_n_31_1 wcm 200meg
Xsyn_31_1 ahp31 ahn31 who_p_31_1 who_n_31_1 mop1 mon1 vdd vbsyn gsyn
Cwp_32_1 who_p_32_1 0 150p
Cwn_32_1 who_n_32_1 0 150p
Rwp_32_1 who_p_32_1 wcm 200meg
Rwn_32_1 who_n_32_1 wcm 200meg
Xsyn_32_1 ahbias_p ahbias_n who_p_32_1 who_n_32_1 mop1 mon1 vdd vbsyn gsyn
Xeo1 xop1 xon1 mop1 mon1 eop1 eon1 vdd gm esub
Xlrn_0_0 eop0 eon0 ahp0 ahn0 who_p_0_0 who_n_0_0 vdd gbl gprod
Xlrn_1_0 eop0 eon0 ahp1 ahn1 who_p_1_0 who_n_1_0 vdd gbl gprod
Xlrn_2_0 eop0 eon0 ahp2 ahn2 who_p_2_0 who_n_2_0 vdd gbl gprod
Xlrn_3_0 eop0 eon0 ahp3 ahn3 who_p_3_0 who_n_3_0 vdd gbl gprod
Xlrn_4_0 eop0 eon0 ahp4 ahn4 who_p_4_0 who_n_4_0 vdd gbl gprod
Xlrn_5_0 eop0 eon0 ahp5 ahn5 who_p_5_0 who_n_5_0 vdd gbl gprod
Xlrn_6_0 eop0 eon0 ahp6 ahn6 who_p_6_0 who_n_6_0 vdd gbl gprod
Xlrn_7_0 eop0 eon0 ahp7 ahn7 who_p_7_0 who_n_7_0 vdd gbl gprod
Xlrn_8_0 eop0 eon0 ahp8 ahn8 who_p_8_0 who_n_8_0 vdd gbl gprod
Xlrn_9_0 eop0 eon0 ahp9 ahn9 who_p_9_0 who_n_9_0 vdd gbl gprod
Xlrn_10_0 eop0 eon0 ahp10 ahn10 who_p_10_0 who_n_10_0 vdd gbl gprod
Xlrn_11_0 eop0 eon0 ahp11 ahn11 who_p_11_0 who_n_11_0 vdd gbl gprod
Xlrn_12_0 eop0 eon0 ahp12 ahn12 who_p_12_0 who_n_12_0 vdd gbl gprod
Xlrn_13_0 eop0 eon0 ahp13 ahn13 who_p_13_0 who_n_13_0 vdd gbl gprod
Xlrn_14_0 eop0 eon0 ahp14 ahn14 who_p_14_0 who_n_14_0 vdd gbl gprod
Xlrn_15_0 eop0 eon0 ahp15 ahn15 who_p_15_0 who_n_15_0 vdd gbl gprod
Xlrn_16_0 eop0 eon0 ahp16 ahn16 who_p_16_0 who_n_16_0 vdd gbl gprod
Xlrn_17_0 eop0 eon0 ahp17 ahn17 who_p_17_0 who_n_17_0 vdd gbl gprod
Xlrn_18_0 eop0 eon0 ahp18 ahn18 who_p_18_0 who_n_18_0 vdd gbl gprod
Xlrn_19_0 eop0 eon0 ahp19 ahn19 who_p_19_0 who_n_19_0 vdd gbl gprod
Xlrn_20_0 eop0 eon0 ahp20 ahn20 who_p_20_0 who_n_20_0 vdd gbl gprod
Xlrn_21_0 eop0 eon0 ahp21 ahn21 who_p_21_0 who_n_21_0 vdd gbl gprod
Xlrn_22_0 eop0 eon0 ahp22 ahn22 who_p_22_0 who_n_22_0 vdd gbl gprod
Xlrn_23_0 eop0 eon0 ahp23 ahn23 who_p_23_0 who_n_23_0 vdd gbl gprod
Xlrn_24_0 eop0 eon0 ahp24 ahn24 who_p_24_0 who_n_24_0 vdd gbl gprod
Xlrn_25_0 eop0 eon0 ahp25 ahn25 who_p_25_0 who_n_25_0 vdd gbl gprod
Xlrn_26_0 eop0 eon0 ahp26 ahn26 who_p_26_0 who_n_26_0 vdd gbl gprod
Xlrn_27_0 eop0 eon0 ahp27 ahn27 who_p_27_0 who_n_27_0 vdd gbl gprod
Xlrn_28_0 eop0 eon0 ahp28 ahn28 who_p_28_0 who_n_28_0 vdd gbl gprod
Xlrn_29_0 eop0 eon0 ahp29 ahn29 who_p_29_0 who_n_29_0 vdd gbl gprod
Xlrn_30_0 eop0 eon0 ahp30 ahn30 who_p_30_0 who_n_30_0 vdd gbl gprod
Xlrn_31_0 eop0 eon0 ahp31 ahn31 who_p_31_0 who_n_31_0 vdd gbl gprod
Xlrn_32_0 eop0 eon0 ahbias_p ahbias_n who_p_32_0 who_n_32_0 vdd gbl gprod
Xlrn_0_1 eop1 eon1 ahp0 ahn0 who_p_0_1 who_n_0_1 vdd gbl gprod
Xlrn_1_1 eop1 eon1 ahp1 ahn1 who_p_1_1 who_n_1_1 vdd gbl gprod
Xlrn_2_1 eop1 eon1 ahp2 ahn2 who_p_2_1 who_n_2_1 vdd gbl gprod
Xlrn_3_1 eop1 eon1 ahp3 ahn3 who_p_3_1 who_n_3_1 vdd gbl gprod
Xlrn_4_1 eop1 eon1 ahp4 ahn4 who_p_4_1 who_n_4_1 vdd gbl gprod
Xlrn_5_1 eop1 eon1 ahp5 ahn5 who_p_5_1 who_n_5_1 vdd gbl gprod
Xlrn_6_1 eop1 eon1 ahp6 ahn6 who_p_6_1 who_n_6_1 vdd gbl gprod
Xlrn_7_1 eop1 eon1 ahp7 ahn7 who_p_7_1 who_n_7_1 vdd gbl gprod
Xlrn_8_1 eop1 eon1 ahp8 ahn8 who_p_8_1 who_n_8_1 vdd gbl gprod
Xlrn_9_1 eop1 eon1 ahp9 ahn9 who_p_9_1 who_n_9_1 vdd gbl gprod
Xlrn_10_1 eop1 eon1 ahp10 ahn10 who_p_10_1 who_n_10_1 vdd gbl gprod
Xlrn_11_1 eop1 eon1 ahp11 ahn11 who_p_11_1 who_n_11_1 vdd gbl gprod
Xlrn_12_1 eop1 eon1 ahp12 ahn12 who_p_12_1 who_n_12_1 vdd gbl gprod
Xlrn_13_1 eop1 eon1 ahp13 ahn13 who_p_13_1 who_n_13_1 vdd gbl gprod
Xlrn_14_1 eop1 eon1 ahp14 ahn14 who_p_14_1 who_n_14_1 vdd gbl gprod
Xlrn_15_1 eop1 eon1 ahp15 ahn15 who_p_15_1 who_n_15_1 vdd gbl gprod
Xlrn_16_1 eop1 eon1 ahp16 ahn16 who_p_16_1 who_n_16_1 vdd gbl gprod
Xlrn_17_1 eop1 eon1 ahp17 ahn17 who_p_17_1 who_n_17_1 vdd gbl gprod
Xlrn_18_1 eop1 eon1 ahp18 ahn18 who_p_18_1 who_n_18_1 vdd gbl gprod
Xlrn_19_1 eop1 eon1 ahp19 ahn19 who_p_19_1 who_n_19_1 vdd gbl gprod
Xlrn_20_1 eop1 eon1 ahp20 ahn20 who_p_20_1 who_n_20_1 vdd gbl gprod
Xlrn_21_1 eop1 eon1 ahp21 ahn21 who_p_21_1 who_n_21_1 vdd gbl gprod
Xlrn_22_1 eop1 eon1 ahp22 ahn22 who_p_22_1 who_n_22_1 vdd gbl gprod
Xlrn_23_1 eop1 eon1 ahp23 ahn23 who_p_23_1 who_n_23_1 vdd gbl gprod
Xlrn_24_1 eop1 eon1 ahp24 ahn24 who_p_24_1 who_n_24_1 vdd gbl gprod
Xlrn_25_1 eop1 eon1 ahp25 ahn25 who_p_25_1 who_n_25_1 vdd gbl gprod
Xlrn_26_1 eop1 eon1 ahp26 ahn26 who_p_26_1 who_n_26_1 vdd gbl gprod
Xlrn_27_1 eop1 eon1 ahp27 ahn27 who_p_27_1 who_n_27_1 vdd gbl gprod
Xlrn_28_1 eop1 eon1 ahp28 ahn28 who_p_28_1 who_n_28_1 vdd gbl gprod
Xlrn_29_1 eop1 eon1 ahp29 ahn29 who_p_29_1 who_n_29_1 vdd gbl gprod
Xlrn_30_1 eop1 eon1 ahp30 ahn30 who_p_30_1 who_n_30_1 vdd gbl gprod
Xlrn_31_1 eop1 eon1 ahp31 ahn31 who_p_31_1 who_n_31_1 vdd gbl gprod
Xlrn_32_1 eop1 eon1 ahbias_p ahbias_n who_p_32_1 who_n_32_1 vdd gbl gprod
.ic v(who_p_0_0)=0.5 v(who_n_0_0)=0.5
.ic v(who_p_1_0)=0.5 v(who_n_1_0)=0.5
.ic v(who_p_2_0)=0.5 v(who_n_2_0)=0.5
.ic v(who_p_3_0)=0.5 v(who_n_3_0)=0.5
.ic v(who_p_4_0)=0.5 v(who_n_4_0)=0.5
.ic v(who_p_5_0)=0.5 v(who_n_5_0)=0.5
.ic v(who_p_6_0)=0.5 v(who_n_6_0)=0.5
.ic v(who_p_7_0)=0.5 v(who_n_7_0)=0.5
.ic v(who_p_8_0)=0.5 v(who_n_8_0)=0.5
.ic v(who_p_9_0)=0.5 v(who_n_9_0)=0.5
.ic v(who_p_10_0)=0.5 v(who_n_10_0)=0.5
.ic v(who_p_11_0)=0.5 v(who_n_11_0)=0.5
.ic v(who_p_12_0)=0.5 v(who_n_12_0)=0.5
.ic v(who_p_13_0)=0.5 v(who_n_13_0)=0.5
.ic v(who_p_14_0)=0.5 v(who_n_14_0)=0.5
.ic v(who_p_15_0)=0.5 v(who_n_15_0)=0.5
.ic v(who_p_16_0)=0.5 v(who_n_16_0)=0.5
.ic v(who_p_17_0)=0.5 v(who_n_17_0)=0.5
.ic v(who_p_18_0)=0.5 v(who_n_18_0)=0.5
.ic v(who_p_19_0)=0.5 v(who_n_19_0)=0.5
.ic v(who_p_20_0)=0.5 v(who_n_20_0)=0.5
.ic v(who_p_21_0)=0.5 v(who_n_21_0)=0.5
.ic v(who_p_22_0)=0.5 v(who_n_22_0)=0.5
.ic v(who_p_23_0)=0.5 v(who_n_23_0)=0.5
.ic v(who_p_24_0)=0.5 v(who_n_24_0)=0.5
.ic v(who_p_25_0)=0.5 v(who_n_25_0)=0.5
.ic v(who_p_26_0)=0.5 v(who_n_26_0)=0.5
.ic v(who_p_27_0)=0.5 v(who_n_27_0)=0.5
.ic v(who_p_28_0)=0.5 v(who_n_28_0)=0.5
.ic v(who_p_29_0)=0.5 v(who_n_29_0)=0.5
.ic v(who_p_30_0)=0.5 v(who_n_30_0)=0.5
.ic v(who_p_31_0)=0.5 v(who_n_31_0)=0.5
.ic v(who_p_32_0)=0.5 v(who_n_32_0)=0.5
.ic v(who_p_0_1)=0.5 v(who_n_0_1)=0.5
.ic v(who_p_1_1)=0.5 v(who_n_1_1)=0.5
.ic v(who_p_2_1)=0.5 v(who_n_2_1)=0.5
.ic v(who_p_3_1)=0.5 v(who_n_3_1)=0.5
.ic v(who_p_4_1)=0.5 v(who_n_4_1)=0.5
.ic v(who_p_5_1)=0.5 v(who_n_5_1)=0.5
.ic v(who_p_6_1)=0.5 v(who_n_6_1)=0.5
.ic v(who_p_7_1)=0.5 v(who_n_7_1)=0.5
.ic v(who_p_8_1)=0.5 v(who_n_8_1)=0.5
.ic v(who_p_9_1)=0.5 v(who_n_9_1)=0.5
.ic v(who_p_10_1)=0.5 v(who_n_10_1)=0.5
.ic v(who_p_11_1)=0.5 v(who_n_11_1)=0.5
.ic v(who_p_12_1)=0.5 v(who_n_12_1)=0.5
.ic v(who_p_13_1)=0.5 v(who_n_13_1)=0.5
.ic v(who_p_14_1)=0.5 v(who_n_14_1)=0.5
.ic v(who_p_15_1)=0.5 v(who_n_15_1)=0.5
.ic v(who_p_16_1)=0.5 v(who_n_16_1)=0.5
.ic v(who_p_17_1)=0.5 v(who_n_17_1)=0.5
.ic v(who_p_18_1)=0.5 v(who_n_18_1)=0.5
.ic v(who_p_19_1)=0.5 v(who_n_19_1)=0.5
.ic v(who_p_20_1)=0.5 v(who_n_20_1)=0.5
.ic v(who_p_21_1)=0.5 v(who_n_21_1)=0.5
.ic v(who_p_22_1)=0.5 v(who_n_22_1)=0.5
.ic v(who_p_23_1)=0.5 v(who_n_23_1)=0.5
.ic v(who_p_24_1)=0.5 v(who_n_24_1)=0.5
.ic v(who_p_25_1)=0.5 v(who_n_25_1)=0.5
.ic v(who_p_26_1)=0.5 v(who_n_26_1)=0.5
.ic v(who_p_27_1)=0.5 v(who_n_27_1)=0.5
.ic v(who_p_28_1)=0.5 v(who_n_28_1)=0.5
.ic v(who_p_29_1)=0.5 v(who_n_29_1)=0.5
.ic v(who_p_30_1)=0.5 v(who_n_30_1)=0.5
.ic v(who_p_31_1)=0.5 v(who_n_31_1)=0.5
.ic v(who_p_32_1)=0.5 v(who_n_32_1)=0.5
.options gmin=1e-10 reltol=2e-3 cshunt=1e-14 method=gear
.control
tran 2n 52640n uic
wrdata ps_h0.dat v(mop0) v(mon0) v(mop1) v(mon1) v(who_p_0_0) v(who_n_0_0) v(who_p_1_0) v(who_n_1_0) v(who_p_2_0) v(who_n_2_0) v(who_p_3_0) v(who_n_3_0) v(who_p_4_0) v(who_n_4_0) v(who_p_5_0) v(who_n_5_0) v(who_p_6_0) v(who_n_6_0) v(who_p_7_0) v(who_n_7_0) v(who_p_8_0) v(who_n_8_0) v(who_p_9_0) v(who_n_9_0) v(who_p_10_0) v(who_n_10_0) v(who_p_11_0) v(who_n_11_0) v(who_p_12_0) v(who_n_12_0) v(who_p_13_0) v(who_n_13_0) v(who_p_14_0) v(who_n_14_0) v(who_p_15_0) v(who_n_15_0) v(who_p_16_0) v(who_n_16_0) v(who_p_17_0) v(who_n_17_0) v(who_p_18_0) v(who_n_18_0) v(who_p_19_0) v(who_n_19_0) v(who_p_20_0) v(who_n_20_0) v(who_p_21_0) v(who_n_21_0) v(who_p_22_0) v(who_n_22_0) v(who_p_23_0) v(who_n_23_0) v(who_p_24_0) v(who_n_24_0) v(who_p_25_0) v(who_n_25_0) v(who_p_26_0) v(who_n_26_0) v(who_p_27_0) v(who_n_27_0) v(who_p_28_0) v(who_n_28_0) v(who_p_29_0) v(who_n_29_0) v(who_p_30_0) v(who_n_30_0) v(who_p_31_0) v(who_n_31_0) v(who_p_0_1) v(who_n_0_1) v(who_p_1_1) v(who_n_1_1) v(who_p_2_1) v(who_n_2_1) v(who_p_3_1) v(who_n_3_1) v(who_p_4_1) v(who_n_4_1) v(who_p_5_1) v(who_n_5_1) v(who_p_6_1) v(who_n_6_1) v(who_p_7_1) v(who_n_7_1) v(who_p_8_1) v(who_n_8_1) v(who_p_9_1) v(who_n_9_1) v(who_p_10_1) v(who_n_10_1) v(who_p_11_1) v(who_n_11_1) v(who_p_12_1) v(who_n_12_1) v(who_p_13_1) v(who_n_13_1) v(who_p_14_1) v(who_n_14_1) v(who_p_15_1) v(who_n_15_1) v(who_p_16_1) v(who_n_16_1) v(who_p_17_1) v(who_n_17_1) v(who_p_18_1) v(who_n_18_1) v(who_p_19_1) v(who_n_19_1) v(who_p_20_1) v(who_n_20_1) v(who_p_21_1) v(who_n_21_1) v(who_p_22_1) v(who_n_22_1) v(who_p_23_1) v(who_n_23_1) v(who_p_24_1) v(who_n_24_1) v(who_p_25_1) v(who_n_25_1) v(who_p_26_1) v(who_n_26_1) v(who_p_27_1) v(who_n_27_1) v(who_p_28_1) v(who_n_28_1) v(who_p_29_1) v(who_n_29_1) v(who_p_30_1) v(who_n_30_1) v(who_p_31_1) v(who_n_31_1)
.endc
.end
