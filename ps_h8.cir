fully in-spice PC learner
.model NNR NMOS (LEVEL=1 VTO=0.2 KP=120u LAMBDA=0.02 GAMMA=0 PHI=0.7)
.model PNR PMOS (LEVEL=1 VTO=-0.2 KP=40u LAMBDA=0.02 GAMMA=0 PHI=0.7)
.subckt gsyn inp inn wp wn outp outn vdd vbn
Mtail nt vbn 0 0 NNR W=400u L=100u
M5 na wp s5 0 NNR W=200u L=100u
Rd5 s5 nt 12k
M6 nb wn s6 0 NNR W=200u L=100u
Rd6 s6 nt 12k
M1 outp inp s1 0 NNR W=200u L=100u
Rd1 s1 na 12k
M2 outn inn s2 0 NNR W=200u L=100u
Rd2 s2 na 12k
M3 outn inp s3 0 NNR W=200u L=100u
Rd3 s3 nb 12k
M4 outp inn s4 0 NNR W=200u L=100u
Rd4 s4 nb 12k
.ends
.subckt cmld p n vdd
Rcs1 p cmx 300k
Rcs2 n cmx 300k
MLp p cmx vdd vdd PNR W=3000u L=100u
MLn n cmx vdd vdd PNR W=3000u L=100u
.ends
.subckt dneuron up un ap an vdd vbn
M1 an up tn 0 NNR W=200u L=100u
M2 ap un tn 0 NNR W=200u L=100u
Mt tn vbn 0 0 NNR W=200u L=100u
Xcm ap an vdd cmld
.ends
.subckt esub xp xn mp mn ep en vdd vbn
Mt nt vbn 0 0 NNR W=400u L=100u
M1x ep xn nt 0 NNR W=200u L=100u
M2x en xp nt 0 NNR W=200u L=100u
M1m ep mp nt 0 NNR W=200u L=100u
M2m en mn nt 0 NNR W=200u L=100u
RLp vdd ep 50k
RLn vdd en 50k
.ends
.subckt gprod xp xn yp yn wp wn vdd vbn
Mtail nt vbn 0 0 NNR W=400u L=100u
M5 na yp nt 0 NNR W=200u L=100u
M6 nb yn nt 0 NNR W=200u L=100u
M1 iop xp na 0 NNR W=200u L=100u
M2 ion xn na 0 NNR W=200u L=100u
M3 ion xp nb 0 NNR W=200u L=100u
M4 iop xn nb 0 NNR W=200u L=100u
Mlp iop iop vdd vdd PNR W=200u L=100u
Mln ion ion vdd vdd PNR W=200u L=100u
Mpu_wp wp iop vdd vdd PNR W=200u L=100u
MpRn nrn ion vdd vdd PNR W=200u L=100u
MnRn nrn nrn 0 0 NNR W=200u L=100u
Mpd_wp wp nrn 0 0 NNR W=200u L=100u
Mpu_wn wn ion vdd vdd PNR W=200u L=100u
MpRp nrp iop vdd vdd PNR W=200u L=100u
MnRp nrp nrp 0 0 NNR W=200u L=100u
Mpd_wn wn nrp 0 0 NNR W=200u L=100u
.ends
Vdd vdd 0 1.0
Vbsyn vbsyn 0 0.6
Vbneu vbneu 0 0.35
Vgm gm 0 0.6
Vwcm wcm 0 0.5
Vgbl gbl 0 PWL(0.0n 0.80000 179.9n 0.80000 180.0n 0.80000 359.9n 0.80000 360.0n 0.80000 539.9n 0.80000 540.0n 0.80000 719.9n 0.80000 720.0n 0.80000 899.9n 0.80000 900.0n 0.80000 1079.9n 0.80000 1080.0n 0.80000 1259.9n 0.80000 1260.0n 0.80000 1439.9n 0.80000 1440.0n 0.80000 1619.9n 0.80000 1620.0n 0.80000 1799.9n 0.80000 1800.0n 0.80000 1979.9n 0.80000 1980.0n 0.80000 2159.9n 0.80000 2160.0n 0.80000 2339.9n 0.80000 2340.0n 0.80000 2519.9n 0.80000 2520.0n 0.80000 2699.9n 0.80000 2700.0n 0.80000 2879.9n 0.80000 2880.0n 0.80000 3059.9n 0.80000 3060.0n 0.80000 3239.9n 0.80000 3240.0n 0.80000 3419.9n 0.80000 3420.0n 0.80000 3599.9n 0.80000 3600.0n 0.80000 3779.9n 0.80000 3780.0n 0.80000 3959.9n 0.80000 3960.0n 0.80000 4139.9n 0.80000 4140.0n 0.80000 4319.9n 0.80000 4320.0n 0.80000 4499.9n 0.80000 4500.0n 0.80000 4679.9n 0.80000 4680.0n 0.80000 4859.9n 0.80000 4860.0n 0.80000 5039.9n 0.80000 5040.0n 0.80000 5219.9n 0.80000 5220.0n 0.80000 5399.9n 0.80000 5400.0n 0.80000 5579.9n 0.80000 5580.0n 0.80000 5759.9n 0.80000 5760.0n 0.80000 5939.9n 0.80000 5940.0n 0.80000 6119.9n 0.80000 6120.0n 0.80000 6299.9n 0.80000 6300.0n 0.80000 6479.9n 0.80000 6480.0n 0.80000 6659.9n 0.80000 6660.0n 0.80000 6839.9n 0.80000 6840.0n 0.80000 7019.9n 0.80000 7020.0n 0.80000 7199.9n 0.80000 7200.0n 0.80000 7379.9n 0.80000 7380.0n 0.80000 7559.9n 0.80000 7560.0n 0.80000 7739.9n 0.80000 7740.0n 0.80000 7919.9n 0.80000 7920.0n 0.80000 8099.9n 0.80000 8100.0n 0.80000 8279.9n 0.80000 8280.0n 0.80000 8459.9n 0.80000 8460.0n 0.80000 8639.9n 0.80000 8640.0n 0.80000 8819.9n 0.80000 8820.0n 0.80000 8999.9n 0.80000 9000.0n 0.80000 9179.9n 0.80000 9180.0n 0.80000 9359.9n 0.80000 9360.0n 0.80000 9539.9n 0.80000 9540.0n 0.80000 9719.9n 0.80000 9720.0n 0.80000 9899.9n 0.80000 9900.0n 0.80000 10079.9n 0.80000 10080.0n 0.80000 10259.9n 0.80000 10260.0n 0.80000 10439.9n 0.80000 10440.0n 0.80000 10619.9n 0.80000 10620.0n 0.80000 10799.9n 0.80000 10800.0n 0.80000 10979.9n 0.80000 10980.0n 0.80000 11159.9n 0.80000 11160.0n 0.80000 11339.9n 0.80000 11340.0n 0.80000 11519.9n 0.80000 11520.0n 0.80000 11699.9n 0.80000 11700.0n 0.80000 11879.9n 0.80000 11880.0n 0.80000 12059.9n 0.80000 12060.0n 0.80000 12239.9n 0.80000 12240.0n 0.80000 12419.9n 0.80000 12420.0n 0.80000 12599.9n 0.80000 12600.0n 0.80000 12779.9n 0.80000 12780.0n 0.80000 12959.9n 0.80000 12960.0n 0.80000 13139.9n 0.80000 13140.0n 0.80000 13319.9n 0.80000 13320.0n 0.80000 13499.9n 0.80000 13500.0n 0.80000 13679.9n 0.80000 13680.0n 0.80000 13859.9n 0.80000 13860.0n 0.80000 14039.9n 0.80000 14040.0n 0.80000 14219.9n 0.80000 14220.0n 0.80000 14399.9n 0.80000 14400.0n 0.80000 14579.9n 0.80000 14580.0n 0.80000 14759.9n 0.80000 14760.0n 0.80000 14939.9n 0.80000 14940.0n 0.80000 15119.9n 0.80000 15120.0n 0.80000 15299.9n 0.80000 15300.0n 0.80000 15479.9n 0.80000 15480.0n 0.80000 15659.9n 0.80000 15660.0n 0.80000 15839.9n 0.80000 15840.0n 0.80000 16019.9n 0.80000 16020.0n 0.80000 16199.9n 0.80000 16200.0n 0.80000 16379.9n 0.80000 16380.0n 0.80000 16559.9n 0.80000 16560.0n 0.80000 16739.9n 0.80000 16740.0n 0.80000 16919.9n 0.80000 16920.0n 0.80000 17099.9n 0.80000 17100.0n 0.80000 17279.9n 0.80000 17280.0n 0.80000 17459.9n 0.80000 17460.0n 0.80000 17639.9n 0.80000 17640.0n 0.80000 17819.9n 0.80000 17820.0n 0.80000 17999.9n 0.80000 18000.0n 0.80000 18179.9n 0.80000 18180.0n 0.80000 18359.9n 0.80000 18360.0n 0.80000 18539.9n 0.80000 18540.0n 0.80000 18719.9n 0.80000 18720.0n 0.80000 18899.9n 0.80000 18900.0n 0.80000 19079.9n 0.80000 19080.0n 0.80000 19259.9n 0.80000 19260.0n 0.80000 19439.9n 0.80000 19440.0n 0.80000 19619.9n 0.80000 19620.0n 0.80000 19799.9n 0.80000 19800.0n 0.80000 19979.9n 0.80000 19980.0n 0.80000 20159.9n 0.80000 20160.0n 0.80000 20339.9n 0.80000 20340.0n 0.80000 20519.9n 0.80000 20520.0n 0.80000 20699.9n 0.80000 20700.0n 0.80000 20879.9n 0.80000 20880.0n 0.80000 21059.9n 0.80000 21060.0n 0.80000 21239.9n 0.80000 21240.0n 0.80000 21419.9n 0.80000 21420.0n 0.80000 21599.9n 0.80000 21600.0n 0.80000 21779.9n 0.80000 21780.0n 0.80000 21959.9n 0.80000 21960.0n 0.80000 22139.9n 0.80000 22140.0n 0.80000 22319.9n 0.80000 22320.0n 0.80000 22499.9n 0.80000 22500.0n 0.80000 22679.9n 0.80000 22680.0n 0.80000 22859.9n 0.80000 22860.0n 0.80000 23039.9n 0.80000 23040.0n 0.80000 23219.9n 0.80000 23220.0n 0.80000 23399.9n 0.80000 23400.0n 0.80000 23579.9n 0.80000 23580.0n 0.80000 23759.9n 0.80000 23760.0n 0.80000 23939.9n 0.80000 23940.0n 0.80000 24119.9n 0.80000 24120.0n 0.80000 24299.9n 0.80000 24300.0n 0.80000 24479.9n 0.80000 24480.0n 0.80000 24659.9n 0.80000 24660.0n 0.80000 24839.9n 0.80000 24840.0n 0.80000 25019.9n 0.80000 25020.0n 0.80000 25199.9n 0.80000 25200.0n 0.80000 25379.9n 0.80000 25380.0n 0.80000 25559.9n 0.80000 25560.0n 0.80000 25739.9n 0.80000 25740.0n 0.80000 25919.9n 0.80000 25920.0n 0.80000 26099.9n 0.80000 26100.0n 0.80000 26279.9n 0.80000 26280.0n 0.80000 26459.9n 0.80000 26460.0n 0.80000 26639.9n 0.80000 26640.0n 0.80000 26819.9n 0.80000 26820.0n 0.80000 26999.9n 0.80000 27000.0n 0.80000 27179.9n 0.80000 27180.0n 0.80000 27359.9n 0.80000 27360.0n 0.80000 27539.9n 0.80000 27540.0n 0.80000 27719.9n 0.80000 27720.0n 0.80000 27899.9n 0.80000 27900.0n 0.80000 28079.9n 0.80000 28080.0n 0.80000 28259.9n 0.80000 28260.0n 0.80000 28439.9n 0.80000 28440.0n 0.80000 28619.9n 0.80000 28620.0n 0.80000 28799.9n 0.80000 28800.0n 0.80000 28979.9n 0.80000 28980.0n 0.80000 29159.9n 0.80000 29160.0n 0.80000 29339.9n 0.80000 29340.0n 0.80000 29519.9n 0.80000 29520.0n 0.80000 29699.9n 0.80000 29700.0n 0.80000 29879.9n 0.80000 29880.0n 0.80000 30059.9n 0.80000 30060.0n 0.80000 30239.9n 0.80000 30240.0n 0.80000 30419.9n 0.80000 30420.0n 0.80000 30599.9n 0.80000 30600.0n 0.80000 30779.9n 0.80000 30780.0n 0.80000 30959.9n 0.80000 30960.0n 0.80000 31139.9n 0.80000 31140.0n 0.80000 31319.9n 0.80000 31320.0n 0.80000 31499.9n 0.80000 31500.0n 0.80000 31679.9n 0.80000 31680.0n 0.80000 31859.9n 0.80000 31860.0n 0.80000 32039.9n 0.80000 32040.0n 0.80000 32219.9n 0.80000 32220.0n 0.80000 32399.9n 0.80000 32400.0n 0.80000 32579.9n 0.80000 32580.0n 0.80000 32759.9n 0.80000 32760.0n 0.80000 32939.9n 0.80000 32940.0n 0.80000 33119.9n 0.80000 33120.0n 0.80000 33299.9n 0.80000 33300.0n 0.80000 33479.9n 0.80000 33480.0n 0.80000 33659.9n 0.80000 33660.0n 0.80000 33839.9n 0.80000 33840.0n 0.80000 34019.9n 0.80000 34020.0n 0.80000 34199.9n 0.80000 34200.0n 0.80000 34379.9n 0.80000 34380.0n 0.80000 34559.9n 0.80000 34560.0n 0.80000 34739.9n 0.80000 34740.0n 0.80000 34919.9n 0.80000 34920.0n 0.80000 35099.9n 0.80000 35100.0n 0.80000 35279.9n 0.80000 35280.0n 0.80000 35459.9n 0.80000 35460.0n 0.80000 35639.9n 0.80000 35640.0n 0.80000 35819.9n 0.80000 35820.0n 0.80000 35999.9n 0.80000 36000.0n 0.80000 36179.9n 0.80000 36180.0n 0.80000 36359.9n 0.80000 36360.0n 0.80000 36539.9n 0.80000 36540.0n 0.80000 36719.9n 0.80000 36720.0n 0.80000 36899.9n 0.80000 36900.0n 0.80000 37079.9n 0.80000 37080.0n 0.80000 37259.9n 0.80000 37260.0n 0.80000 37439.9n 0.80000 37440.0n 0.80000 37619.9n 0.80000 37620.0n 0.80000 37799.9n 0.80000 37800.0n 0.80000 37979.9n 0.80000 37980.0n 0.80000 38159.9n 0.80000 38160.0n 0.80000 38339.9n 0.80000 38340.0n 0.80000 38519.9n 0.80000 38520.0n 0.80000 38699.9n 0.80000 38700.0n 0.80000 38879.9n 0.80000 38880.0n 0.80000 39059.9n 0.80000 39060.0n 0.80000 39239.9n 0.80000 39240.0n 0.80000 39419.9n 0.80000 39420.0n 0.80000 39599.9n 0.80000 39600.0n 0.80000 39779.9n 0.80000 39780.0n 0.80000 39959.9n 0.80000 39960.0n 0.80000 40139.9n 0.80000 40140.0n 0.80000 40319.9n 0.80000 40320.0n 0.80000 40499.9n 0.80000 40500.0n 0.80000 40679.9n 0.80000 40680.0n 0.80000 40859.9n 0.80000 40860.0n 0.80000 41039.9n 0.80000 41040.0n 0.80000 41219.9n 0.80000 41220.0n 0.80000 41399.9n 0.80000 41400.0n 0.80000 41579.9n 0.80000 41580.0n 0.80000 41759.9n 0.80000 41760.0n 0.80000 41939.9n 0.80000 41940.0n 0.80000 42119.9n 0.80000 42120.0n 0.80000 42299.9n 0.80000 42300.0n 0.80000 42479.9n 0.80000 42480.0n 0.80000 42659.9n 0.80000 42660.0n 0.80000 42839.9n 0.80000 42840.0n 0.80000 43019.9n 0.80000 43020.0n 0.80000 43199.9n 0.80000 43200.0n 0.80000 43379.9n 0.80000 43380.0n 0.80000 43559.9n 0.80000 43560.0n 0.80000 43739.9n 0.80000 43740.0n 0.80000 43919.9n 0.80000 43920.0n 0.80000 44099.9n 0.80000 44100.0n 0.80000 44279.9n 0.80000 44280.0n 0.80000 44459.9n 0.80000 44460.0n 0.80000 44639.9n 0.80000 44640.0n 0.80000 44819.9n 0.80000 44820.0n 0.80000 44999.9n 0.80000 45000.0n 0.80000 45179.9n 0.80000 45180.0n 0.80000 45359.9n 0.80000 45360.0n 0.80000 45539.9n 0.80000 45540.0n 0.80000 45719.9n 0.80000 45720.0n 0.80000 45899.9n 0.80000 45900.0n 0.80000 46079.9n 0.80000 46080.0n 0.80000 46259.9n 0.80000 46260.0n 0.80000 46439.9n 0.80000 46440.0n 0.80000 46619.9n 0.80000 46620.0n 0.80000 46799.9n 0.80000 46800.0n 0.80000 46979.9n 0.80000 46980.0n 0.80000 47159.9n 0.80000 47160.0n 0.80000 47339.9n 0.80000 47340.0n 0.80000 47519.9n 0.80000 47520.0n 0.80000 47699.9n 0.80000 47700.0n 0.80000 47879.9n 0.80000 47880.0n 0.80000 48059.9n 0.80000 48060.0n 0.80000 48239.9n 0.80000 48240.0n 0.80000 48419.9n 0.80000 48420.0n 0.80000 48599.9n 0.80000 48600.0n 0.80000 48779.9n 0.80000 48780.0n 0.80000 48959.9n 0.80000 48960.0n 0.80000 49139.9n 0.80000 49140.0n 0.80000 49319.9n 0.80000 49320.0n 0.80000 49499.9n 0.80000 49500.0n 0.80000 49679.9n 0.80000 49680.0n 0.80000 49859.9n 0.80000 49860.0n 0.80000 50039.9n 0.80000 50040.0n 0.80000 50219.9n 0.80000 50220.0n 0.80000 50399.9n 0.80000 50400.0n 0.80000 50579.9n 0.80000 50580.0n 0.80000 50759.9n 0.80000 50760.0n 0.80000 50939.9n 0.80000 50940.0n 0.80000 51119.9n 0.80000 51120.0n 0.80000 51299.9n 0.80000 51300.0n 0.80000 51479.9n 0.80000 51480.0n 0.80000 51659.9n 0.80000 51660.0n 0.80000 51839.9n 0.80000 51840.0n 0.80000 52019.9n 0.80000 52020.0n 0.80000 52199.9n 0.80000 52200.0n 0.80000 52379.9n 0.80000 52380.0n 0.80000 52559.9n 0.80000 52560.0n 0.80000 52739.9n 0.80000 52740.0n 0.80000 52919.9n 0.80000 52920.0n 0.80000 53099.9n 0.80000 53100.0n 0.80000 53279.9n 0.80000 53280.0n 0.80000 53459.9n 0.80000 53460.0n 0.80000 53639.9n 0.80000 53640.0n 0.80000 53819.9n 0.80000 53820.0n 0.80000 53999.9n 0.80000 54000.0n 0.80000 54179.9n 0.80000 54180.0n 0.80000 54359.9n 0.80000 54360.0n 0.80000 54539.9n 0.80000 54540.0n 0.80000 54719.9n 0.80000 54720.0n 0.80000 54899.9n 0.80000 54900.0n 0.80000 55079.9n 0.80000 55080.0n 0.80000 55259.9n 0.80000 55260.0n 0.80000 55439.9n 0.80000 55440.0n 0.80000 55619.9n 0.80000 55620.0n 0.80000 55799.9n 0.80000 55800.0n 0.80000 55979.9n 0.80000 55980.0n 0.80000 56159.9n 0.80000 56160.0n 0.80000 56339.9n 0.80000 56340.0n 0.80000 56519.9n 0.80000 56520.0n 0.80000 56699.9n 0.80000 56700.0n 0.80000 56879.9n 0.80000 56880.0n 0.80000 57059.9n 0.80000 57060.0n 0.80000 57239.9n 0.80000 57240.0n 0.80000 57419.9n 0.80000 57420.0n 0.80000 57599.9n 0.80000 57600.0n 0.80000 57779.9n 0.80000 57780.0n 0.80000 57959.9n 0.80000 57960.0n 0.80000 58139.9n 0.80000 58140.0n 0.80000 58319.9n 0.80000 58320.0n 0.80000 58499.9n 0.80000 58500.0n 0.80000 58679.9n 0.80000 58680.0n 0.80000 58859.9n 0.80000 58860.0n 0.80000 59039.9n 0.80000 59040.0n 0.80000 59219.9n 0.80000 59220.0n 0.80000 59399.9n 0.80000 59400.0n 0.80000 59579.9n 0.80000 59580.0n 0.80000 59759.9n 0.80000 59760.0n 0.80000 59939.9n 0.80000 59940.0n 0.80000 60119.9n 0.80000 60120.0n 0.80000 60299.9n 0.80000 60300.0n 0.80000 60479.9n 0.80000 60480.0n 0.80000 60659.9n 0.80000 60660.0n 0.80000 60839.9n 0.80000 60840.0n 0.80000 61019.9n 0.80000 61020.0n 0.80000 61199.9n 0.80000 61200.0n 0.80000 61379.9n 0.80000 61380.0n 0.80000 61559.9n 0.80000 61560.0n 0.80000 61739.9n 0.80000 61740.0n 0.80000 61919.9n 0.80000 61920.0n 0.80000 62099.9n 0.80000 62100.0n 0.80000 62279.9n 0.80000 62280.0n 0.80000 62459.9n 0.80000 62460.0n 0.80000 62639.9n 0.80000 62640.0n 0.80000 62819.9n 0.80000 62820.0n 0.80000 62999.9n 0.80000 63000.0n 0.80000 63179.9n 0.80000 63180.0n 0.80000 63359.9n 0.80000 63360.0n 0.80000 63539.9n 0.80000 63540.0n 0.80000 63719.9n 0.80000 63720.0n 0.80000 63899.9n 0.80000 63900.0n 0.80000 64079.9n 0.80000 64080.0n 0.80000 64259.9n 0.80000 64260.0n 0.80000 64439.9n 0.80000 64440.0n 0.80000 64619.9n 0.80000 64620.0n 0.80000 64799.9n 0.80000 64800.0n 0.80000 64979.9n 0.80000 64980.0n 0.80000 65159.9n 0.80000 65160.0n 0.80000 65339.9n 0.80000 65340.0n 0.80000 65519.9n 0.80000 65520.0n 0.80000 65699.9n 0.80000 65700.0n 0.80000 65879.9n 0.80000 65880.0n 0.80000 66059.9n 0.80000 66060.0n 0.80000 66239.9n 0.80000 66240.0n 0.80000 66419.9n 0.80000 66420.0n 0.80000 66599.9n 0.80000 66600.0n 0.80000 66779.9n 0.80000 66780.0n 0.80000 66959.9n 0.80000 66960.0n 0.80000 67139.9n 0.80000 67140.0n 0.80000 67319.9n 0.80000 67320.0n 0.80000 67499.9n 0.80000 67500.0n 0.80000 67679.9n 0.80000 67680.0n 0.80000 67859.9n 0.80000 67860.0n 0.80000 68039.9n 0.80000 68040.0n 0.80000 68219.9n 0.80000 68220.0n 0.80000 68399.9n 0.80000 68400.0n 0.80000 68579.9n 0.80000 68580.0n 0.80000 68759.9n 0.80000 68760.0n 0.80000 68939.9n 0.80000 68940.0n 0.80000 69119.9n 0.80000 69120.0n 0.80000 69299.9n 0.80000 69300.0n 0.80000 69479.9n 0.80000 69480.0n 0.80000 69659.9n 0.80000 69660.0n 0.80000 69839.9n 0.80000 69840.0n 0.80000 70019.9n 0.80000 70020.0n 0.80000 70199.9n 0.80000 70200.0n 0.80000 70379.9n 0.80000 70380.0n 0.80000 70559.9n 0.80000 70560.0n 0.80000 70739.9n 0.80000 70740.0n 0.80000 70919.9n 0.80000 70920.0n 0.80000 71099.9n 0.80000 71100.0n 0.80000 71279.9n 0.80000 71280.0n 0.80000 71459.9n 0.80000 71460.0n 0.80000 71639.9n 0.80000 71640.0n 0.80000 71819.9n 0.80000 71820.0n 0.80000 71999.9n 0.80000 72000.0n 0.80000 72179.9n 0.80000 72180.0n 0.80000 72359.9n 0.80000 72360.0n 0.80000 72539.9n 0.80000 72540.0n 0.80000 72719.9n 0.80000 72720.0n 0.80000 72899.9n 0.80000 72900.0n 0.80000 73079.9n 0.80000 73080.0n 0.80000 73259.9n 0.80000 73260.0n 0.80000 73439.9n 0.80000 73440.0n 0.80000 73619.9n 0.80000 73620.0n 0.80000 73799.9n 0.80000 73800.0n 0.80000 73979.9n 0.80000 73980.0n 0.80000 74159.9n 0.80000 74160.0n 0.80000 74339.9n 0.80000 74340.0n 0.80000 74519.9n 0.80000 74520.0n 0.80000 74699.9n 0.80000 74700.0n 0.80000 74879.9n 0.80000 74880.0n 0.80000 75059.9n 0.80000 75060.0n 0.80000 75239.9n 0.80000 75240.0n 0.80000 75419.9n 0.80000 75420.0n 0.80000 75599.9n 0.80000 75600.0n 0.80000 75779.9n 0.80000 75780.0n 0.80000 75959.9n 0.80000 75960.0n 0.80000 76139.9n 0.80000 76140.0n 0.80000 76319.9n 0.80000 76320.0n 0.80000 76499.9n 0.80000 76500.0n 0.80000 76679.9n 0.80000 76680.0n 0.80000 76859.9n 0.80000 76860.0n 0.80000 77039.9n 0.80000 77040.0n 0.80000 77219.9n 0.80000 77220.0n 0.80000 77399.9n 0.80000 77400.0n 0.80000 77579.9n 0.80000 77580.0n 0.80000 77759.9n 0.80000 77760.0n 0.80000 77939.9n 0.80000 77940.0n 0.80000 78119.9n 0.80000 78120.0n 0.80000 78299.9n 0.80000 78300.0n 0.80000 78479.9n 0.80000 78480.0n 0.80000 78659.9n 0.80000 78660.0n 0.80000 78839.9n 0.80000 78840.0n 0.80000 79019.9n 0.80000 79020.0n 0.80000 79199.9n 0.80000 79200.0n 0.80000 79379.9n 0.80000 79380.0n 0.80000 79559.9n 0.80000 79560.0n 0.80000 79739.9n 0.80000 79740.0n 0.80000 79919.9n 0.80000 79920.0n 0.80000 80099.9n 0.80000 80100.0n 0.80000 80279.9n 0.80000 80280.0n 0.80000 80459.9n 0.80000 80460.0n 0.80000 80639.9n 0.80000 80640.0n 0.80000 80819.9n 0.80000 80820.0n 0.80000 80999.9n 0.80000 81000.0n 0.80000 81179.9n 0.80000 81180.0n 0.80000 81359.9n 0.80000 81360.0n 0.80000 81539.9n 0.80000 81540.0n 0.80000 81719.9n 0.80000 81720.0n 0.80000 81899.9n 0.80000 81900.0n 0.80000 82079.9n 0.80000 82080.0n 0.80000 82259.9n 0.80000 82260.0n 0.80000 82439.9n 0.80000 82440.0n 0.80000 82619.9n 0.80000 82620.0n 0.80000 82799.9n 0.80000 82800.0n 0.80000 82979.9n 0.80000 82980.0n 0.80000 83159.9n 0.80000 83160.0n 0.80000 83339.9n 0.80000 83340.0n 0.80000 83519.9n 0.80000 83520.0n 0.80000 83699.9n 0.80000 83700.0n 0.80000 83879.9n 0.80000 83880.0n 0.80000 84059.9n 0.80000 84060.0n 0.80000 84239.9n 0.80000 84240.0n 0.80000 84419.9n 0.80000 84420.0n 0.80000 84599.9n 0.80000 84600.0n 0.80000 84779.9n 0.80000 84780.0n 0.80000 84959.9n 0.80000 84960.0n 0.80000 85139.9n 0.80000 85140.0n 0.80000 85319.9n 0.80000 85320.0n 0.80000 85499.9n 0.80000 85500.0n 0.80000 85679.9n 0.80000 85680.0n 0.80000 85859.9n 0.80000 85860.0n 0.80000 86039.9n 0.80000 86040.0n 0.80000 86219.9n 0.80000 86220.0n 0.80000 86399.9n 0.80000 86400.0n 0.80000 86579.9n 0.80000 86580.0n 0.80000 86759.9n 0.80000 86760.0n 0.80000 86939.9n 0.80000 86940.0n 0.80000 87119.9n 0.80000 87120.0n 0.80000 87299.9n 0.80000 87300.0n 0.80000 87479.9n 0.80000 87480.0n 0.80000 87659.9n 0.80000 87660.0n 0.80000 87839.9n 0.80000 87840.0n 0.80000 88019.9n 0.80000 88020.0n 0.80000 88199.9n 0.80000 88200.0n 0.80000 88379.9n 0.80000 88380.0n 0.80000 88559.9n 0.80000 88560.0n 0.80000 88739.9n 0.80000 88740.0n 0.80000 88919.9n 0.80000 88920.0n 0.80000 89099.9n 0.80000 89100.0n 0.80000 89279.9n 0.80000 89280.0n 0.80000 89459.9n 0.80000 89460.0n 0.80000 89639.9n 0.80000 89640.0n 0.80000 89819.9n 0.80000 89820.0n 0.80000 89999.9n 0.80000 90000.0n 0.80000 90179.9n 0.80000 90180.0n 0.80000 90359.9n 0.80000 90360.0n 0.80000 90539.9n 0.80000 90540.0n 0.80000 90719.9n 0.80000 90720.0n 0.80000 90899.9n 0.80000 90900.0n 0.80000 91079.9n 0.80000 91080.0n 0.80000 91259.9n 0.80000 91260.0n 0.80000 91439.9n 0.80000 91440.0n 0.80000 91619.9n 0.80000 91620.0n 0.80000 91799.9n 0.80000 91800.0n 0.80000 91979.9n 0.80000 91980.0n 0.80000 92159.9n 0.80000 92160.0n 0.80000 92339.9n 0.80000 92340.0n 0.80000 92519.9n 0.80000 92520.0n 0.80000 92699.9n 0.80000 92700.0n 0.80000 92879.9n 0.80000 92880.0n 0.80000 93059.9n 0.80000 93060.0n 0.80000 93239.9n 0.80000 93240.0n 0.80000 93419.9n 0.80000 93420.0n 0.80000 93599.9n 0.80000 93600.0n 0.80000 93779.9n 0.80000 93780.0n 0.80000 93959.9n 0.80000 93960.0n 0.80000 94139.9n 0.80000 94140.0n 0.80000 94319.9n 0.80000 94320.0n 0.80000 94499.9n 0.80000 94500.0n 0.80000 94679.9n 0.80000 94680.0n 0.80000 94859.9n 0.80000 94860.0n 0.80000 95039.9n 0.80000 95040.0n 0.80000 95219.9n 0.80000 95220.0n 0.80000 95399.9n 0.80000 95400.0n 0.80000 95579.9n 0.80000 95580.0n 0.80000 95759.9n 0.80000 95760.0n 0.80000 95939.9n 0.80000 95940.0n 0.80000 96119.9n 0.80000 96120.0n 0.80000 96299.9n 0.80000 96300.0n 0.80000 96479.9n 0.80000 96480.0n 0.80000 96659.9n 0.80000 96660.0n 0.80000 96839.9n 0.80000 96840.0n 0.80000 97019.9n 0.80000 97020.0n 0.80000 97199.9n 0.80000 97200.0n 0.80000 97379.9n 0.80000 97380.0n 0.80000 97559.9n 0.80000 97560.0n 0.80000 97739.9n 0.80000 97740.0n 0.80000 97919.9n 0.80000 97920.0n 0.80000 98099.9n 0.80000 98100.0n 0.80000 98279.9n 0.80000 98280.0n 0.80000 98459.9n 0.80000 98460.0n 0.80000 98639.9n 0.80000 98640.0n 0.80000 98819.9n 0.80000 98820.0n 0.80000 98999.9n 0.80000 99000.0n 0.80000 99179.9n 0.80000 99180.0n 0.80000 99359.9n 0.80000 99360.0n 0.80000 99539.9n 0.80000 99540.0n 0.80000 99719.9n 0.80000 99720.0n 0.80000 99899.9n 0.80000 99900.0n 0.80000 100079.9n 0.80000 100080.0n 0.80000 100259.9n 0.80000 100260.0n 0.80000 100439.9n 0.80000 100440.0n 0.80000 100619.9n 0.80000 100620.0n 0.80000 100799.9n 0.80000 100800.0n 0.80000 100979.9n 0.80000 100980.0n 0.80000 101159.9n 0.80000 101160.0n 0.80000 101339.9n 0.80000 101340.0n 0.80000 101519.9n 0.80000 101520.0n 0.80000 101699.9n 0.80000 101700.0n 0.80000 101879.9n 0.80000 101880.0n 0.80000 102059.9n 0.80000 102060.0n 0.80000 102239.9n 0.80000 102240.0n 0.80000 102419.9n 0.80000 102420.0n 0.80000 102599.9n 0.80000 102600.0n 0.80000 102779.9n 0.80000 102780.0n 0.80000 102959.9n 0.80000 102960.0n 0.80000 103139.9n 0.80000 103140.0n 0.80000 103319.9n 0.80000 103320.0n 0.80000 103499.9n 0.80000 103500.0n 0.80000 103679.9n 0.80000 103680.0n 0.80000 103859.9n 0.80000 103860.0n 0.80000 104039.9n 0.80000 104040.0n 0.80000 104219.9n 0.80000 104220.0n 0.80000 104399.9n 0.80000 104400.0n 0.80000 104579.9n 0.80000 104580.0n 0.80000 104759.9n 0.80000 104760.0n 0.80000 104939.9n 0.80000 104940.0n 0.80000 105119.9n 0.80000 105120.0n 0.80000 105299.9n 0.80000 105300.0n 0.80000 105479.9n 0.80000 105480.0n 0.80000 105659.9n 0.80000 105660.0n 0.80000 105839.9n 0.80000 105840.0n 0.80000 106019.9n 0.80000 106020.0n 0.80000 106199.9n 0.80000 106200.0n 0.80000 106379.9n 0.80000 106380.0n 0.80000 106559.9n 0.80000 106560.0n 0.80000 106739.9n 0.80000 106740.0n 0.80000 106919.9n 0.80000 106920.0n 0.80000 107099.9n 0.80000 107100.0n 0.80000 107279.9n 0.80000 107280.0n 0.80000 107459.9n 0.80000 107460.0n 0.80000 107639.9n 0.80000 107640.0n 0.80000 107819.9n 0.80000 107820.0n 0.80000 107999.9n 0.80000 108000.0n 0.80000 108179.9n 0.80000 108180.0n 0.80000 108359.9n 0.80000 108360.0n 0.80000 108539.9n 0.80000 108540.0n 0.80000 108719.9n 0.80000 108720.0n 0.80000 108899.9n 0.80000 108900.0n 0.80000 109079.9n 0.80000 109080.0n 0.80000 109259.9n 0.80000 109260.0n 0.80000 109439.9n 0.80000 109440.0n 0.80000 109619.9n 0.80000 109620.0n 0.80000 109799.9n 0.80000 109800.0n 0.80000 109979.9n 0.80000 109980.0n 0.80000 110159.9n 0.80000 110160.0n 0.80000 110339.9n 0.80000 110340.0n 0.80000 110519.9n 0.80000 110520.0n 0.80000 110699.9n 0.80000 110700.0n 0.80000 110879.9n 0.80000 110880.0n 0.80000 111059.9n 0.80000 111060.0n 0.80000 111239.9n 0.80000 111240.0n 0.80000 111419.9n 0.80000 111420.0n 0.80000 111599.9n 0.80000 111600.0n 0.80000 111779.9n 0.80000 111780.0n 0.80000 111959.9n 0.80000 111960.0n 0.80000 112139.9n 0.80000 112140.0n 0.80000 112319.9n 0.80000 112320.0n 0.80000 112499.9n 0.80000 112500.0n 0.80000 112679.9n 0.80000 112680.0n 0.80000 112859.9n 0.80000 112860.0n 0.80000 113039.9n 0.80000 113040.0n 0.80000 113219.9n 0.80000 113220.0n 0.80000 113399.9n 0.80000 113400.0n 0.80000 113579.9n 0.80000 113580.0n 0.80000 113759.9n 0.80000 113760.0n 0.80000 113939.9n 0.80000 113940.0n 0.80000 114119.9n 0.80000 114120.0n 0.80000 114299.9n 0.80000 114300.0n 0.80000 114479.9n 0.80000 114480.0n 0.80000 114659.9n 0.80000 114660.0n 0.80000 114839.9n 0.80000 114840.0n 0.80000 115019.9n 0.80000 115020.0n 0.80000 115199.9n 0.80000 115200.0n 0.80000 115379.9n 0.80000 115380.0n 0.80000 115559.9n 0.80000 115560.0n 0.80000 115739.9n 0.80000 115740.0n 0.80000 115919.9n 0.80000 115920.0n 0.80000 116099.9n 0.80000 116100.0n 0.80000 116279.9n 0.80000 116280.0n 0.80000 116459.9n 0.80000 116460.0n 0.80000 116639.9n 0.80000 116640.0n 0.80000 116819.9n 0.80000 116820.0n 0.80000 116999.9n 0.80000 117000.0n 0.80000 117179.9n 0.80000 117180.0n 0.80000 117359.9n 0.80000 117360.0n 0.80000 117539.9n 0.80000 117540.0n 0.80000 117719.9n 0.80000 117720.0n 0.80000 117899.9n 0.80000 117900.0n 0.80000 118079.9n 0.80000 118080.0n 0.80000 118259.9n 0.80000 118260.0n 0.80000 118439.9n 0.80000 118440.0n 0.80000 118619.9n 0.80000 118620.0n 0.80000 118799.9n 0.80000 118800.0n 0.80000 118979.9n 0.80000 118980.0n 0.80000 119159.9n 0.80000 119160.0n 0.80000 119339.9n 0.80000 119340.0n 0.80000 119519.9n 0.80000 119520.0n 0.80000 119699.9n 0.80000 119700.0n 0.80000 119879.9n 0.80000 119880.0n 0.80000 120059.9n 0.80000 120060.0n 0.80000 120239.9n 0.80000 120240.0n 0.80000 120419.9n 0.80000 120420.0n 0.80000 120599.9n 0.80000 120600.0n 0.80000 120779.9n 0.80000 120780.0n 0.80000 120959.9n 0.80000 120960.0n 0.80000 121139.9n 0.80000 121140.0n 0.80000 121319.9n 0.80000 121320.0n 0.80000 121499.9n 0.80000 121500.0n 0.80000 121679.9n 0.80000 121680.0n 0.80000 121859.9n 0.80000 121860.0n 0.80000 122039.9n 0.80000 122040.0n 0.80000 122219.9n 0.80000 122220.0n 0.80000 122399.9n 0.80000 122400.0n 0.80000 122579.9n 0.80000 122580.0n 0.80000 122759.9n 0.80000 122760.0n 0.80000 122939.9n 0.80000 122940.0n 0.80000 123119.9n 0.80000 123120.0n 0.80000 123299.9n 0.80000 123300.0n 0.80000 123479.9n 0.80000 123480.0n 0.80000 123659.9n 0.80000 123660.0n 0.80000 123839.9n 0.80000 123840.0n 0.80000 124019.9n 0.80000 124020.0n 0.80000 124199.9n 0.80000 124200.0n 0.80000 124379.9n 0.80000 124380.0n 0.80000 124559.9n 0.80000 124560.0n 0.80000 124739.9n 0.80000 124740.0n 0.80000 124919.9n 0.80000 124920.0n 0.80000 125099.9n 0.80000 125100.0n 0.80000 125279.9n 0.80000 125280.0n 0.80000 125459.9n 0.80000 125460.0n 0.80000 125639.9n 0.80000 125640.0n 0.80000 125819.9n 0.80000 125820.0n 0.80000 125999.9n 0.80000 126000.0n 0.80000 126179.9n 0.80000 126180.0n 0.80000 126359.9n 0.80000 126360.0n 0.80000 126539.9n 0.80000 126540.0n 0.80000 126719.9n 0.80000 126720.0n 0.80000 126899.9n 0.80000 126900.0n 0.80000 127079.9n 0.80000 127080.0n 0.80000 127259.9n 0.80000 127260.0n 0.80000 127439.9n 0.80000 127440.0n 0.80000 127619.9n 0.80000 127620.0n 0.80000 127799.9n 0.80000 127800.0n 0.80000 127979.9n 0.80000 127980.0n 0.80000 128159.9n 0.80000 128160.0n 0.80000 128339.9n 0.80000 128340.0n 0.80000 128519.9n 0.80000 128520.0n 0.80000 128699.9n 0.80000 128700.0n 0.80000 128879.9n 0.80000 128880.0n 0.80000 129059.9n 0.80000 129060.0n 0.80000 129239.9n 0.80000 129240.0n 0.80000 129419.9n 0.80000 129420.0n 0.80000 129599.9n 0.80000 129600.0n 0.80000 129779.9n 0.80000 129780.0n 0.80000 129959.9n 0.80000 129960.0n 0.80000 130139.9n 0.80000 130140.0n 0.80000 130319.9n 0.80000 130320.0n 0.80000 130499.9n 0.80000 130500.0n 0.80000 130679.9n 0.80000 130680.0n 0.80000 130859.9n 0.80000 130860.0n 0.80000 131039.9n 0.80000 131040.0n 0.80000 131219.9n 0.80000 131220.0n 0.80000 131399.9n 0.80000 131400.0n 0.80000 131579.9n 0.80000 131580.0n 0.80000 131759.9n 0.80000 131760.0n 0.80000 131939.9n 0.80000 131940.0n 0.80000 132119.9n 0.80000 132120.0n 0.80000 132299.9n 0.80000 132300.0n 0.80000 132479.9n 0.80000 132480.0n 0.80000 132659.9n 0.80000 132660.0n 0.80000 132839.9n 0.80000 132840.0n 0.80000 133019.9n 0.80000 133020.0n 0.80000 133199.9n 0.80000 133200.0n 0.80000 133379.9n 0.80000 133380.0n 0.80000 133559.9n 0.80000 133560.0n 0.80000 133739.9n 0.80000 133740.0n 0.80000 133919.9n 0.80000 133920.0n 0.80000 134099.9n 0.80000 134100.0n 0.80000 134279.9n 0.80000 134280.0n 0.80000 134459.9n 0.80000 134460.0n 0.80000 134639.9n 0.80000 134640.0n 0.80000 134819.9n 0.80000 134820.0n 0.80000 134999.9n 0.80000 135000.0n 0.80000 135179.9n 0.80000 135180.0n 0.80000 135359.9n 0.80000 135360.0n 0.80000 135539.9n 0.80000 135540.0n 0.80000 135719.9n 0.80000 135720.0n 0.80000 135899.9n 0.80000 135900.0n 0.80000 136079.9n 0.80000 136080.0n 0.80000 136259.9n 0.80000 136260.0n 0.80000 136439.9n 0.80000 136440.0n 0.80000 136619.9n 0.80000 136620.0n 0.80000 136799.9n 0.80000 136800.0n 0.80000 136979.9n 0.80000 136980.0n 0.80000 137159.9n 0.80000 137160.0n 0.80000 137339.9n 0.80000 137340.0n 0.80000 137519.9n 0.80000 137520.0n 0.80000 137699.9n 0.80000 137700.0n 0.80000 137879.9n 0.80000 137880.0n 0.80000 138059.9n 0.80000 138060.0n 0.80000 138239.9n 0.80000 138240.0n 0.80000 138419.9n 0.80000 138420.0n 0.80000 138599.9n 0.80000 138600.0n 0.80000 138779.9n 0.80000 138780.0n 0.80000 138959.9n 0.80000 138960.0n 0.80000 139139.9n 0.80000 139140.0n 0.80000 139319.9n 0.80000 139320.0n 0.80000 139499.9n 0.80000 139500.0n 0.80000 139679.9n 0.80000 139680.0n 0.80000 139859.9n 0.80000 139860.0n 0.80000 140039.9n 0.80000 140040.0n 0.80000 140219.9n 0.80000 140220.0n 0.80000 140399.9n 0.80000 140400.0n 0.80000 140579.9n 0.80000 140580.0n 0.80000 140759.9n 0.80000 140760.0n 0.80000 140939.9n 0.80000 140940.0n 0.80000 141119.9n 0.80000 141120.0n 0.80000 141299.9n 0.80000 141300.0n 0.80000 141479.9n 0.80000 141480.0n 0.80000 141659.9n 0.80000 141660.0n 0.80000 141839.9n 0.80000 141840.0n 0.80000 142019.9n 0.80000 142020.0n 0.80000 142199.9n 0.80000 142200.0n 0.80000 142379.9n 0.80000 142380.0n 0.80000 142559.9n 0.80000 142560.0n 0.80000 142739.9n 0.80000 142740.0n 0.80000 142919.9n 0.80000 142920.0n 0.80000 143099.9n 0.80000 143100.0n 0.80000 143279.9n 0.80000 143280.0n 0.80000 143459.9n 0.80000 143460.0n 0.80000 143639.9n 0.80000 143640.0n 0.80000 143819.9n 0.80000 143820.0n 0.80000 143999.9n 0.80000 144000.0n 0.80000 144179.9n 0.80000 144180.0n 0.80000 144359.9n 0.80000 144360.0n 0.80000 144539.9n 0.80000 144540.0n 0.80000 144719.9n 0.80000 144720.0n 0.80000 144899.9n 0.80000 144900.0n 0.80000 145079.9n 0.80000 145080.0n 0.80000 145259.9n 0.80000 145260.0n 0.80000 145439.9n 0.80000 145440.0n 0.80000 145619.9n 0.80000 145620.0n 0.80000 145799.9n 0.80000 145800.0n 0.80000 145979.9n 0.80000 145980.0n 0.80000 146159.9n 0.80000 146160.0n 0.80000 146339.9n 0.80000 146340.0n 0.80000 146519.9n 0.80000 146520.0n 0.80000 146699.9n 0.80000 146700.0n 0.80000 146879.9n 0.80000 146880.0n 0.80000 147059.9n 0.80000 147060.0n 0.80000 147239.9n 0.80000 147240.0n 0.80000 147419.9n 0.80000 147420.0n 0.80000 147599.9n 0.80000 147600.0n 0.80000 147779.9n 0.80000 147780.0n 0.80000 147959.9n 0.80000 147960.0n 0.80000 148139.9n 0.80000 148140.0n 0.80000 148319.9n 0.80000 148320.0n 0.80000 148499.9n 0.80000 148500.0n 0.80000 148679.9n 0.80000 148680.0n 0.80000 148859.9n 0.80000 148860.0n 0.80000 149039.9n 0.80000 149040.0n 0.80000 149219.9n 0.80000 149220.0n 0.80000 149399.9n 0.80000 149400.0n 0.80000 149579.9n 0.80000 149580.0n 0.80000 149759.9n 0.80000 149760.0n 0.80000 149939.9n 0.80000 149940.0n 0.80000 150119.9n 0.80000 150120.0n 0.80000 150299.9n 0.80000 150300.0n 0.80000 150479.9n 0.80000 150480.0n 0.80000 150659.9n 0.80000 150660.0n 0.80000 150839.9n 0.80000 150840.0n 0.80000 151019.9n 0.80000 151020.0n 0.80000 151199.9n 0.80000 151200.0n 0.80000 151379.9n 0.80000 151380.0n 0.80000 151559.9n 0.80000 151560.0n 0.80000 151739.9n 0.80000 151740.0n 0.80000 151919.9n 0.80000 151920.0n 0.80000 152099.9n 0.80000 152100.0n 0.80000 152279.9n 0.80000 152280.0n 0.80000 152459.9n 0.80000 152460.0n 0.80000 152639.9n 0.80000 152640.0n 0.80000 152819.9n 0.80000 152820.0n 0.80000 152999.9n 0.80000 153000.0n 0.80000 153179.9n 0.80000 153180.0n 0.80000 153359.9n 0.80000 153360.0n 0.80000 153539.9n 0.80000 153540.0n 0.80000 153719.9n 0.80000 153720.0n 0.80000 153899.9n 0.80000 153900.0n 0.80000 154079.9n 0.80000 154080.0n 0.80000 154259.9n 0.80000 154260.0n 0.80000 154439.9n 0.80000 154440.0n 0.80000 154619.9n 0.80000 154620.0n 0.80000 154799.9n 0.80000 154800.0n 0.80000 154979.9n 0.80000 154980.0n 0.80000 155159.9n 0.80000 155160.0n 0.80000 155339.9n 0.80000 155340.0n 0.80000 155519.9n 0.80000 155520.0n 0.80000 155699.9n 0.80000 155700.0n 0.80000 155879.9n 0.80000 155880.0n 0.80000 156059.9n 0.80000 156060.0n 0.80000 156239.9n 0.80000 156240.0n 0.80000 156419.9n 0.80000 156420.0n 0.80000 156599.9n 0.80000 156600.0n 0.80000 156779.9n 0.80000 156780.0n 0.80000 156959.9n 0.80000 156960.0n 0.80000 157139.9n 0.80000 157140.0n 0.80000 157319.9n 0.80000 157320.0n 0.80000 157499.9n 0.80000 157500.0n 0.80000 157679.9n 0.80000 157680.0n 0.80000 157859.9n 0.80000 157860.0n 0.80000 158039.9n 0.80000 158040.0n 0.80000 158219.9n 0.80000 158220.0n 0.80000 158399.9n 0.80000 158400.0n 0.80000 158579.9n 0.80000 158580.0n 0.80000 158759.9n 0.80000 158760.0n 0.80000 158939.9n 0.80000 158940.0n 0.80000 159119.9n 0.80000 159120.0n 0.80000 159299.9n 0.80000 159300.0n 0.80000 159479.9n 0.80000 159480.0n 0.80000 159659.9n 0.80000 159660.0n 0.80000 159839.9n 0.80000 159840.0n 0.80000 160019.9n 0.80000 160020.0n 0.80000 160199.9n 0.80000 160200.0n 0.80000 160379.9n 0.80000 160380.0n 0.80000 160559.9n 0.80000 160560.0n 0.80000 160739.9n 0.80000 160740.0n 0.80000 160919.9n 0.80000 160920.0n 0.80000 161099.9n 0.80000 161100.0n 0.80000 161279.9n 0.80000 161280.0n 0.80000 161459.9n 0.80000 161460.0n 0.80000 161639.9n 0.80000 161640.0n 0.80000 161819.9n 0.80000 161820.0n 0.80000 161999.9n 0.80000 162000.0n 0.80000 162179.9n 0.80000 162180.0n 0.80000 162359.9n 0.80000 162360.0n 0.80000 162539.9n 0.80000 162540.0n 0.80000 162719.9n 0.80000 162720.0n 0.80000 162899.9n 0.80000 162900.0n 0.80000 163079.9n 0.80000 163080.0n 0.80000 163259.9n 0.80000 163260.0n 0.80000 163439.9n 0.80000 163440.0n 0.80000 163619.9n 0.80000 163620.0n 0.80000 163799.9n 0.80000 163800.0n 0.80000 163979.9n 0.80000 163980.0n 0.80000 164159.9n 0.80000 164160.0n 0.80000 164339.9n 0.80000 164340.0n 0.80000 164519.9n 0.80000 164520.0n 0.80000 164699.9n 0.80000 164700.0n 0.80000 164879.9n 0.80000 164880.0n 0.80000 165059.9n 0.80000 165060.0n 0.80000 165239.9n 0.80000 165240.0n 0.80000 165419.9n 0.80000 165420.0n 0.80000 165599.9n 0.80000 165600.0n 0.80000 165779.9n 0.80000 165780.0n 0.80000 165959.9n 0.80000 165960.0n 0.80000 166139.9n 0.80000 166140.0n 0.80000 166319.9n 0.80000 166320.0n 0.80000 166499.9n 0.80000 166500.0n 0.80000 166679.9n 0.80000 166680.0n 0.80000 166859.9n 0.80000 166860.0n 0.80000 167039.9n 0.80000 167040.0n 0.80000 167219.9n 0.80000 167220.0n 0.80000 167399.9n 0.80000 167400.0n 0.80000 167579.9n 0.80000 167580.0n 0.80000 167759.9n 0.80000 167760.0n 0.80000 167939.9n 0.80000 167940.0n 0.80000 168119.9n 0.80000 168120.0n 0.80000 168299.9n 0.80000 168300.0n 0.80000 168479.9n 0.80000 168480.0n 0.80000 168659.9n 0.80000 168660.0n 0.80000 168839.9n 0.80000 168840.0n 0.80000 169019.9n 0.80000 169020.0n 0.80000 169199.9n 0.80000 169200.0n 0.80000 169379.9n 0.80000 169380.0n 0.80000 169559.9n 0.80000 169560.0n 0.80000 169739.9n 0.80000 169740.0n 0.80000 169919.9n 0.80000 169920.0n 0.80000 170099.9n 0.80000 170100.0n 0.80000 170279.9n 0.80000 170280.0n 0.80000 170459.9n 0.80000 170460.0n 0.80000 170639.9n 0.80000 170640.0n 0.80000 170819.9n 0.80000 170820.0n 0.80000 170999.9n 0.80000 171000.0n 0.80000 171179.9n 0.80000 171180.0n 0.80000 171359.9n 0.80000 171360.0n 0.80000 171539.9n 0.80000 171540.0n 0.80000 171719.9n 0.80000 171720.0n 0.80000 171899.9n 0.80000 171900.0n 0.80000 172079.9n 0.80000 172080.0n 0.80000 172259.9n 0.80000 172260.0n 0.80000 172439.9n 0.80000 172440.0n 0.80000 172619.9n 0.80000 172620.0n 0.80000 172799.9n 0.80000 172800.0n 0.00000 172979.9n 0.00000 172980.0n 0.00000 173159.9n 0.00000 173160.0n 0.00000 173339.9n 0.00000 173340.0n 0.00000 173519.9n 0.00000 173520.0n 0.00000 173699.9n 0.00000 173700.0n 0.00000 173879.9n 0.00000 173880.0n 0.00000 174059.9n 0.00000 174060.0n 0.00000 174239.9n 0.00000 174240.0n 0.00000 174419.9n 0.00000 174420.0n 0.00000 174599.9n 0.00000 174600.0n 0.00000 174779.9n 0.00000 174780.0n 0.00000 174959.9n 0.00000 174960.0n 0.00000 175139.9n 0.00000 175140.0n 0.00000 175319.9n 0.00000 175320.0n 0.00000 175499.9n 0.00000 175500.0n 0.00000 175679.9n 0.00000 175680.0n 0.00000 175859.9n 0.00000 175860.0n 0.00000 176039.9n 0.00000 176040.0n 0.00000 176219.9n 0.00000 176220.0n 0.00000 176399.9n 0.00000 176400.0n 0.00000 176579.9n 0.00000 176580.0n 0.00000 176759.9n 0.00000 176760.0n 0.00000 176939.9n 0.00000 176940.0n 0.00000 177119.9n 0.00000 177120.0n 0.00000 177299.9n 0.00000 177300.0n 0.00000 177479.9n 0.00000 177480.0n 0.00000 177659.9n 0.00000 177660.0n 0.00000 177839.9n 0.00000 177840.0n 0.00000 178019.9n 0.00000 178020.0n 0.00000 178199.9n 0.00000 178200.0n 0.00000 178379.9n 0.00000 178380.0n 0.00000 178559.9n 0.00000 178560.0n 0.00000 178739.9n 0.00000 178740.0n 0.00000 178919.9n 0.00000 178920.0n 0.00000 179099.9n 0.00000 179100.0n 0.00000 179279.9n 0.00000 179280.0n 0.00000 179459.9n 0.00000 179460.0n 0.00000 179639.9n 0.00000 179640.0n 0.00000 179819.9n 0.00000 179820.0n 0.00000 179999.9n 0.00000 180000.0n 0.00000 180179.9n 0.00000 180180.0n 0.00000 180359.9n 0.00000 180360.0n 0.00000 180539.9n 0.00000 180540.0n 0.00000 180719.9n 0.00000 180720.0n 0.00000 180899.9n 0.00000 180900.0n 0.00000 181079.9n 0.00000 181080.0n 0.00000 181259.9n 0.00000 181260.0n 0.00000 181439.9n 0.00000 181440.0n 0.00000 181619.9n 0.00000 181620.0n 0.00000 181799.9n 0.00000 181800.0n 0.00000 181979.9n 0.00000 181980.0n 0.00000 182159.9n 0.00000 182160.0n 0.00000 182339.9n 0.00000 182340.0n 0.00000 182519.9n 0.00000 182520.0n 0.00000 182699.9n 0.00000 182700.0n 0.00000 182879.9n 0.00000 182880.0n 0.00000 183059.9n 0.00000 183060.0n 0.00000 183239.9n 0.00000 183240.0n 0.00000 183419.9n 0.00000 183420.0n 0.00000)
Vxp0 a_xp0 0 PWL(0.0n 0.55006 179.9n 0.55006 180.0n 0.52079 359.9n 0.52079 360.0n 0.43581 539.9n 0.43581 540.0n 0.56449 719.9n 0.56449 720.0n 1.21890 899.9n 1.21890 900.0n 0.27076 1079.9n 0.27076 1080.0n 0.69969 1259.9n 0.69969 1260.0n 0.69502 1439.9n 0.69502 1440.0n 0.88832 1619.9n 0.88832 1620.0n 1.38855 1799.9n 1.38855 1800.0n -0.04662 1979.9n -0.04662 1980.0n 0.10559 2159.9n 0.10559 2160.0n 0.86030 2339.9n 0.86030 2340.0n 0.21498 2519.9n 0.21498 2520.0n 0.31139 2699.9n 0.31139 2700.0n 0.96459 2879.9n 0.96459 2880.0n 0.48508 3059.9n 0.48508 3060.0n -0.31038 3239.9n -0.31038 3240.0n 0.35630 3419.9n 0.35630 3420.0n 0.47556 3599.9n 0.47556 3600.0n 0.27643 3779.9n 0.27643 3780.0n 0.55066 3959.9n 0.55066 3960.0n 0.53141 4139.9n 0.53141 4140.0n 0.20119 4319.9n 0.20119 4320.0n 1.07007 4499.9n 1.07007 4500.0n 0.24079 4679.9n 0.24079 4680.0n 0.70685 4859.9n 0.70685 4860.0n 1.36668 5039.9n 1.36668 5040.0n 0.73600 5219.9n 0.73600 5220.0n -0.14927 5399.9n -0.14927 5400.0n 0.17082 5579.9n 0.17082 5580.0n 0.26419 5759.9n 0.26419 5760.0n 1.07007 5939.9n 1.07007 5940.0n 0.88832 6119.9n 0.88832 6120.0n 1.38855 6299.9n 1.38855 6300.0n 0.73600 6479.9n 0.73600 6480.0n 0.35630 6659.9n 0.35630 6660.0n 1.36668 6839.9n 1.36668 6840.0n -0.14927 7019.9n -0.14927 7020.0n 0.47556 7199.9n 0.47556 7200.0n 0.31139 7379.9n 0.31139 7380.0n -0.04662 7559.9n -0.04662 7560.0n 0.52079 7739.9n 0.52079 7740.0n 0.86030 7919.9n 0.86030 7920.0n 0.17082 8099.9n 0.17082 8100.0n 0.56449 8279.9n 0.56449 8280.0n 1.21890 8459.9n 1.21890 8460.0n 0.21498 8639.9n 0.21498 8640.0n 0.69969 8819.9n 0.69969 8820.0n -0.31038 8999.9n -0.31038 9000.0n 0.24079 9179.9n 0.24079 9180.0n 0.43581 9359.9n 0.43581 9360.0n 0.10559 9539.9n 0.10559 9540.0n 0.70685 9719.9n 0.70685 9720.0n 0.55006 9899.9n 0.55006 9900.0n 0.20119 10079.9n 0.20119 10080.0n 0.53141 10259.9n 0.53141 10260.0n 0.27076 10439.9n 0.27076 10440.0n 0.96459 10619.9n 0.96459 10620.0n 0.69502 10799.9n 0.69502 10800.0n 0.48508 10979.9n 0.48508 10980.0n 0.27643 11159.9n 0.27643 11160.0n 0.55066 11339.9n 0.55066 11340.0n 0.26419 11519.9n 0.26419 11520.0n 1.07007 11699.9n 1.07007 11700.0n -0.14927 11879.9n -0.14927 11880.0n 0.96459 12059.9n 0.96459 12060.0n 0.24079 12239.9n 0.24079 12240.0n 0.52079 12419.9n 0.52079 12420.0n 0.26419 12599.9n 0.26419 12600.0n 0.69969 12779.9n 0.69969 12780.0n 0.35630 12959.9n 0.35630 12960.0n 0.86030 13139.9n 0.86030 13140.0n 0.55066 13319.9n 0.55066 13320.0n 0.88832 13499.9n 0.88832 13500.0n 0.53141 13679.9n 0.53141 13680.0n 1.36668 13859.9n 1.36668 13860.0n 0.31139 14039.9n 0.31139 14040.0n 0.27643 14219.9n 0.27643 14220.0n 0.43581 14399.9n 0.43581 14400.0n 0.47556 14579.9n 0.47556 14580.0n 0.48508 14759.9n 0.48508 14760.0n 0.21498 14939.9n 0.21498 14940.0n 0.20119 15119.9n 0.20119 15120.0n 0.70685 15299.9n 0.70685 15300.0n 1.21890 15479.9n 1.21890 15480.0n 0.10559 15659.9n 0.10559 15660.0n 0.27076 15839.9n 0.27076 15840.0n 0.56449 16019.9n 0.56449 16020.0n 0.69502 16199.9n 0.69502 16200.0n 1.38855 16379.9n 1.38855 16380.0n 0.17082 16559.9n 0.17082 16560.0n 0.73600 16739.9n 0.73600 16740.0n -0.04662 16919.9n -0.04662 16920.0n -0.31038 17099.9n -0.31038 17100.0n 0.55006 17279.9n 0.55006 17280.0n -0.14927 17459.9n -0.14927 17460.0n 0.86030 17639.9n 0.86030 17640.0n 0.73600 17819.9n 0.73600 17820.0n 0.43581 17999.9n 0.43581 18000.0n 1.07007 18179.9n 1.07007 18180.0n 1.21890 18359.9n 1.21890 18360.0n 0.55066 18539.9n 0.55066 18540.0n -0.31038 18719.9n -0.31038 18720.0n 0.27076 18899.9n 0.27076 18900.0n 0.56449 19079.9n 0.56449 19080.0n 0.69969 19259.9n 0.69969 19260.0n 0.21498 19439.9n 0.21498 19440.0n 0.52079 19619.9n 0.52079 19620.0n 0.20119 19799.9n 0.20119 19800.0n 0.35630 19979.9n 0.35630 19980.0n 0.88832 20159.9n 0.88832 20160.0n 0.24079 20339.9n 0.24079 20340.0n 0.70685 20519.9n 0.70685 20520.0n -0.04662 20699.9n -0.04662 20700.0n 0.53141 20879.9n 0.53141 20880.0n 0.96459 21059.9n 0.96459 21060.0n 0.69502 21239.9n 0.69502 21240.0n 0.31139 21419.9n 0.31139 21420.0n 0.47556 21599.9n 0.47556 21600.0n 0.27643 21779.9n 0.27643 21780.0n 0.17082 21959.9n 0.17082 21960.0n 0.10559 22139.9n 0.10559 22140.0n 0.55006 22319.9n 0.55006 22320.0n 0.48508 22499.9n 0.48508 22500.0n 1.36668 22679.9n 1.36668 22680.0n 0.26419 22859.9n 0.26419 22860.0n 1.38855 23039.9n 1.38855 23040.0n 0.53141 23219.9n 0.53141 23220.0n 0.55006 23399.9n 0.55006 23400.0n 0.20119 23579.9n 0.20119 23580.0n 0.27643 23759.9n 0.27643 23760.0n 0.56449 23939.9n 0.56449 23940.0n -0.31038 24119.9n -0.31038 24120.0n 1.21890 24299.9n 1.21890 24300.0n 0.55066 24479.9n 0.55066 24480.0n 0.70685 24659.9n 0.70685 24660.0n 0.69502 24839.9n 0.69502 24840.0n 0.21498 25019.9n 0.21498 25020.0n 0.31139 25199.9n 0.31139 25200.0n 0.35630 25379.9n 0.35630 25380.0n 0.27076 25559.9n 0.27076 25560.0n 0.88832 25739.9n 0.88832 25740.0n 0.43581 25919.9n 0.43581 25920.0n -0.04662 26099.9n -0.04662 26100.0n 0.24079 26279.9n 0.24079 26280.0n 0.52079 26459.9n 0.52079 26460.0n 0.47556 26639.9n 0.47556 26640.0n 0.10559 26819.9n 0.10559 26820.0n 0.48508 26999.9n 0.48508 27000.0n 0.86030 27179.9n 0.86030 27180.0n 1.07007 27359.9n 1.07007 27360.0n 1.36668 27539.9n 1.36668 27540.0n 1.38855 27719.9n 1.38855 27720.0n -0.14927 27899.9n -0.14927 27900.0n 0.69969 28079.9n 0.69969 28080.0n 0.17082 28259.9n 0.17082 28260.0n 0.26419 28439.9n 0.26419 28440.0n 0.73600 28619.9n 0.73600 28620.0n 0.96459 28799.9n 0.96459 28800.0n 0.43581 28979.9n 0.43581 28980.0n 0.86030 29159.9n 0.86030 29160.0n 0.17082 29339.9n 0.17082 29340.0n 0.27643 29519.9n 0.27643 29520.0n 0.48508 29699.9n 0.48508 29700.0n 0.20119 29879.9n 0.20119 29880.0n 0.35630 30059.9n 0.35630 30060.0n 1.21890 30239.9n 1.21890 30240.0n 0.70685 30419.9n 0.70685 30420.0n 0.56449 30599.9n 0.56449 30600.0n 0.21498 30779.9n 0.21498 30780.0n 0.55066 30959.9n 0.55066 30960.0n 1.07007 31139.9n 1.07007 31140.0n 0.27076 31319.9n 0.27076 31320.0n 1.36668 31499.9n 1.36668 31500.0n 0.73600 31679.9n 0.73600 31680.0n 0.24079 31859.9n 0.24079 31860.0n 0.69502 32039.9n 0.69502 32040.0n 0.88832 32219.9n 0.88832 32220.0n -0.04662 32399.9n -0.04662 32400.0n 0.69969 32579.9n 0.69969 32580.0n 0.31139 32759.9n 0.31139 32760.0n 0.55006 32939.9n 0.55006 32940.0n 0.52079 33119.9n 0.52079 33120.0n 0.53141 33299.9n 0.53141 33300.0n -0.31038 33479.9n -0.31038 33480.0n 0.47556 33659.9n 0.47556 33660.0n -0.14927 33839.9n -0.14927 33840.0n 0.10559 34019.9n 0.10559 34020.0n 1.38855 34199.9n 1.38855 34200.0n 0.96459 34379.9n 0.96459 34380.0n 0.26419 34559.9n 0.26419 34560.0n 1.21890 34739.9n 1.21890 34740.0n 0.31139 34919.9n 0.31139 34920.0n 0.69502 35099.9n 0.69502 35100.0n 0.86030 35279.9n 0.86030 35280.0n 0.26419 35459.9n 0.26419 35460.0n 0.52079 35639.9n 0.52079 35640.0n 0.47556 35819.9n 0.47556 35820.0n 0.27076 35999.9n 0.27076 36000.0n -0.04662 36179.9n -0.04662 36180.0n 0.56449 36359.9n 0.56449 36360.0n 0.48508 36539.9n 0.48508 36540.0n 0.55006 36719.9n 0.55006 36720.0n 0.27643 36899.9n 0.27643 36900.0n 0.96459 37079.9n 0.96459 37080.0n 0.55066 37259.9n 0.55066 37260.0n -0.14927 37439.9n -0.14927 37440.0n 0.73600 37619.9n 0.73600 37620.0n 0.88832 37799.9n 0.88832 37800.0n -0.31038 37979.9n -0.31038 37980.0n 0.43581 38159.9n 0.43581 38160.0n 0.70685 38339.9n 0.70685 38340.0n 0.21498 38519.9n 0.21498 38520.0n 0.20119 38699.9n 0.20119 38700.0n 0.35630 38879.9n 0.35630 38880.0n 0.17082 39059.9n 0.17082 39060.0n 0.10559 39239.9n 0.10559 39240.0n 0.69969 39419.9n 0.69969 39420.0n 1.07007 39599.9n 1.07007 39600.0n 1.36668 39779.9n 1.36668 39780.0n 0.24079 39959.9n 0.24079 39960.0n 1.38855 40139.9n 1.38855 40140.0n 0.53141 40319.9n 0.53141 40320.0n 0.69502 40499.9n 0.69502 40500.0n 0.70685 40679.9n 0.70685 40680.0n 0.10559 40859.9n 0.10559 40860.0n -0.31038 41039.9n -0.31038 41040.0n 1.07007 41219.9n 1.07007 41220.0n 0.69969 41399.9n 0.69969 41400.0n 0.52079 41579.9n 0.52079 41580.0n 0.55066 41759.9n 0.55066 41760.0n 0.31139 41939.9n 0.31139 41940.0n 0.73600 42119.9n 0.73600 42120.0n 0.17082 42299.9n 0.17082 42300.0n 0.24079 42479.9n 0.24079 42480.0n 0.56449 42659.9n 0.56449 42660.0n 0.20119 42839.9n 0.20119 42840.0n -0.14927 43019.9n -0.14927 43020.0n 0.86030 43199.9n 0.86030 43200.0n 1.38855 43379.9n 1.38855 43380.0n 0.27076 43559.9n 0.27076 43560.0n 0.26419 43739.9n 0.26419 43740.0n 1.21890 43919.9n 1.21890 43920.0n 0.55006 44099.9n 0.55006 44100.0n 0.43581 44279.9n 0.43581 44280.0n 0.47556 44459.9n 0.47556 44460.0n 0.21498 44639.9n 0.21498 44640.0n 1.36668 44819.9n 1.36668 44820.0n 0.35630 44999.9n 0.35630 45000.0n 0.27643 45179.9n 0.27643 45180.0n 0.48508 45359.9n 0.48508 45360.0n 0.88832 45539.9n 0.88832 45540.0n 0.53141 45719.9n 0.53141 45720.0n -0.04662 45899.9n -0.04662 45900.0n 0.96459 46079.9n 0.96459 46080.0n 0.20119 46259.9n 0.20119 46260.0n 0.55066 46439.9n 0.55066 46440.0n 1.07007 46619.9n 1.07007 46620.0n 0.10559 46799.9n 0.10559 46800.0n 0.26419 46979.9n 0.26419 46980.0n 0.70685 47159.9n 0.70685 47160.0n 0.21498 47339.9n 0.21498 47340.0n 1.21890 47519.9n 1.21890 47520.0n 0.88832 47699.9n 0.88832 47700.0n 0.47556 47879.9n 0.47556 47880.0n 0.35630 48059.9n 0.35630 48060.0n 0.69969 48239.9n 0.69969 48240.0n 0.31139 48419.9n 0.31139 48420.0n 0.56449 48599.9n 0.56449 48600.0n 0.86030 48779.9n 0.86030 48780.0n 0.69502 48959.9n 0.69502 48960.0n -0.04662 49139.9n -0.04662 49140.0n 0.48508 49319.9n 0.48508 49320.0n 0.43581 49499.9n 0.43581 49500.0n -0.14927 49679.9n -0.14927 49680.0n 0.52079 49859.9n 0.52079 49860.0n -0.31038 50039.9n -0.31038 50040.0n 0.27076 50219.9n 0.27076 50220.0n 0.53141 50399.9n 0.53141 50400.0n 0.17082 50579.9n 0.17082 50580.0n 1.36668 50759.9n 1.36668 50760.0n 0.73600 50939.9n 0.73600 50940.0n 0.55006 51119.9n 0.55006 51120.0n 1.38855 51299.9n 1.38855 51300.0n 0.24079 51479.9n 0.24079 51480.0n 0.27643 51659.9n 0.27643 51660.0n 0.96459 51839.9n 0.96459 51840.0n 0.52079 52019.9n 0.52079 52020.0n 0.86030 52199.9n 0.86030 52200.0n 0.70685 52379.9n 0.70685 52380.0n 0.88832 52559.9n 0.88832 52560.0n 0.73600 52739.9n 0.73600 52740.0n 1.38855 52919.9n 1.38855 52920.0n 0.47556 53099.9n 0.47556 53100.0n 0.21498 53279.9n 0.21498 53280.0n 0.48508 53459.9n 0.48508 53460.0n 0.24079 53639.9n 0.24079 53640.0n 0.56449 53819.9n 0.56449 53820.0n -0.14927 53999.9n -0.14927 54000.0n 0.27643 54179.9n 0.27643 54180.0n 0.96459 54359.9n 0.96459 54360.0n 0.53141 54539.9n 0.53141 54540.0n 0.17082 54719.9n 0.17082 54720.0n -0.04662 54899.9n -0.04662 54900.0n 0.26419 55079.9n 0.26419 55080.0n 1.07007 55259.9n 1.07007 55260.0n -0.31038 55439.9n -0.31038 55440.0n 0.35630 55619.9n 0.35630 55620.0n 0.55006 55799.9n 0.55006 55800.0n 0.31139 55979.9n 0.31139 55980.0n 0.43581 56159.9n 0.43581 56160.0n 0.20119 56339.9n 0.20119 56340.0n 1.36668 56519.9n 1.36668 56520.0n 1.21890 56699.9n 1.21890 56700.0n 0.69969 56879.9n 0.69969 56880.0n 0.10559 57059.9n 0.10559 57060.0n 0.55066 57239.9n 0.55066 57240.0n 0.27076 57419.9n 0.27076 57420.0n 0.69502 57599.9n 0.69502 57600.0n 0.53141 57779.9n 0.53141 57780.0n 0.88832 57959.9n 0.88832 57960.0n 0.48508 58139.9n 0.48508 58140.0n 0.21498 58319.9n 0.21498 58320.0n 1.21890 58499.9n 1.21890 58500.0n 0.43581 58679.9n 0.43581 58680.0n 0.35630 58859.9n 0.35630 58860.0n 0.27643 59039.9n 0.27643 59040.0n 0.96459 59219.9n 0.96459 59220.0n 0.27076 59399.9n 0.27076 59400.0n -0.14927 59579.9n -0.14927 59580.0n -0.31038 59759.9n -0.31038 59760.0n 0.26419 59939.9n 0.26419 59940.0n 0.70685 60119.9n 0.70685 60120.0n 0.47556 60299.9n 0.47556 60300.0n 0.55006 60479.9n 0.55006 60480.0n 0.52079 60659.9n 0.52079 60660.0n 0.69502 60839.9n 0.69502 60840.0n 0.17082 61019.9n 0.17082 61020.0n 0.86030 61199.9n 0.86030 61200.0n 0.20119 61379.9n 0.20119 61380.0n 0.31139 61559.9n 0.31139 61560.0n 1.07007 61739.9n 1.07007 61740.0n 1.36668 61919.9n 1.36668 61920.0n 0.10559 62099.9n 0.10559 62100.0n 1.38855 62279.9n 1.38855 62280.0n 0.73600 62459.9n 0.73600 62460.0n 0.55066 62639.9n 0.55066 62640.0n 0.56449 62819.9n 0.56449 62820.0n 0.69969 62999.9n 0.69969 63000.0n -0.04662 63179.9n -0.04662 63180.0n 0.24079 63359.9n 0.24079 63360.0n 0.56449 63539.9n 0.56449 63540.0n 0.70685 63719.9n 0.70685 63720.0n 0.27076 63899.9n 0.27076 63900.0n 0.55006 64079.9n 0.55006 64080.0n 0.52079 64259.9n 0.52079 64260.0n 0.26419 64439.9n 0.26419 64440.0n 0.21498 64619.9n 0.21498 64620.0n 0.47556 64799.9n 0.47556 64800.0n 0.24079 64979.9n 0.24079 64980.0n 0.69969 65159.9n 0.69969 65160.0n 0.53141 65339.9n 0.53141 65340.0n 1.21890 65519.9n 1.21890 65520.0n 1.38855 65699.9n 1.38855 65700.0n 0.69502 65879.9n 0.69502 65880.0n 1.07007 66059.9n 1.07007 66060.0n 0.96459 66239.9n 0.96459 66240.0n 0.86030 66419.9n 0.86030 66420.0n 0.48508 66599.9n 0.48508 66600.0n 0.35630 66779.9n 0.35630 66780.0n 0.73600 66959.9n 0.73600 66960.0n 0.10559 67139.9n 0.10559 67140.0n 0.88832 67319.9n 0.88832 67320.0n 0.27643 67499.9n 0.27643 67500.0n 0.20119 67679.9n 0.20119 67680.0n 0.55066 67859.9n 0.55066 67860.0n -0.14927 68039.9n -0.14927 68040.0n 0.17082 68219.9n 0.17082 68220.0n 1.36668 68399.9n 1.36668 68400.0n 0.31139 68579.9n 0.31139 68580.0n -0.31038 68759.9n -0.31038 68760.0n -0.04662 68939.9n -0.04662 68940.0n 0.43581 69119.9n 0.43581 69120.0n 0.27643 69299.9n 0.27643 69300.0n 0.35630 69479.9n 0.35630 69480.0n 0.55006 69659.9n 0.55006 69660.0n 0.86030 69839.9n 0.86030 69840.0n 0.20119 70019.9n 0.20119 70020.0n -0.14927 70199.9n -0.14927 70200.0n 0.10559 70379.9n 0.10559 70380.0n 0.27076 70559.9n 0.27076 70560.0n -0.04662 70739.9n -0.04662 70740.0n 0.88832 70919.9n 0.88832 70920.0n 0.17082 71099.9n 0.17082 71100.0n 0.69502 71279.9n 0.69502 71280.0n 0.56449 71459.9n 0.56449 71460.0n 0.73600 71639.9n 0.73600 71640.0n 1.38855 71819.9n 1.38855 71820.0n 0.47556 71999.9n 0.47556 72000.0n -0.31038 72179.9n -0.31038 72180.0n 0.31139 72359.9n 0.31139 72360.0n 0.24079 72539.9n 0.24079 72540.0n 1.07007 72719.9n 1.07007 72720.0n 0.96459 72899.9n 0.96459 72900.0n 0.21498 73079.9n 0.21498 73080.0n 0.70685 73259.9n 0.70685 73260.0n 1.36668 73439.9n 1.36668 73440.0n 0.26419 73619.9n 0.26419 73620.0n 0.55066 73799.9n 0.55066 73800.0n 0.48508 73979.9n 0.48508 73980.0n 0.53141 74159.9n 0.53141 74160.0n 0.69969 74339.9n 0.69969 74340.0n 0.52079 74519.9n 0.52079 74520.0n 0.43581 74699.9n 0.43581 74700.0n 1.21890 74879.9n 1.21890 74880.0n 0.47556 75059.9n 0.47556 75060.0n 0.31139 75239.9n 0.31139 75240.0n 0.43581 75419.9n 0.43581 75420.0n 0.17082 75599.9n 0.17082 75600.0n 0.55066 75779.9n 0.55066 75780.0n 0.21498 75959.9n 0.21498 75960.0n 0.35630 76139.9n 0.35630 76140.0n 0.56449 76319.9n 0.56449 76320.0n -0.31038 76499.9n -0.31038 76500.0n 0.69969 76679.9n 0.69969 76680.0n 0.70685 76859.9n 0.70685 76860.0n 0.86030 77039.9n 0.86030 77040.0n 0.20119 77219.9n 0.20119 77220.0n 1.21890 77399.9n 1.21890 77400.0n 0.27076 77579.9n 0.27076 77580.0n 0.24079 77759.9n 0.24079 77760.0n 0.96459 77939.9n 0.96459 77940.0n 0.10559 78119.9n 0.10559 78120.0n 1.38855 78299.9n 1.38855 78300.0n 0.73600 78479.9n 0.73600 78480.0n 0.26419 78659.9n 0.26419 78660.0n -0.04662 78839.9n -0.04662 78840.0n -0.14927 79019.9n -0.14927 79020.0n 0.55006 79199.9n 0.55006 79200.0n 1.36668 79379.9n 1.36668 79380.0n 0.27643 79559.9n 0.27643 79560.0n 0.52079 79739.9n 0.52079 79740.0n 0.48508 79919.9n 0.48508 79920.0n 0.53141 80099.9n 0.53141 80100.0n 1.07007 80279.9n 1.07007 80280.0n 0.88832 80459.9n 0.88832 80460.0n 0.69502 80639.9n 0.69502 80640.0n 1.36668 80819.9n 1.36668 80820.0n 0.88832 80999.9n 0.88832 81000.0n 0.27643 81179.9n 0.27643 81180.0n 0.55066 81359.9n 0.55066 81360.0n 0.55006 81539.9n 0.55006 81540.0n 0.20119 81719.9n 0.20119 81720.0n 0.47556 81899.9n 0.47556 81900.0n 1.38855 82079.9n 1.38855 82080.0n 0.52079 82259.9n 0.52079 82260.0n 0.35630 82439.9n 0.35630 82440.0n 0.56449 82619.9n 0.56449 82620.0n 0.73600 82799.9n 0.73600 82800.0n 0.86030 82979.9n 0.86030 82980.0n 1.21890 83159.9n 1.21890 83160.0n 0.27076 83339.9n 0.27076 83340.0n -0.04662 83519.9n -0.04662 83520.0n 0.24079 83699.9n 0.24079 83700.0n 0.43581 83879.9n 0.43581 83880.0n 0.96459 84059.9n 0.96459 84060.0n 0.69969 84239.9n 0.69969 84240.0n 0.48508 84419.9n 0.48508 84420.0n -0.31038 84599.9n -0.31038 84600.0n 1.07007 84779.9n 1.07007 84780.0n 0.70685 84959.9n 0.70685 84960.0n 0.31139 85139.9n 0.31139 85140.0n 0.21498 85319.9n 0.21498 85320.0n 0.17082 85499.9n 0.17082 85500.0n 0.26419 85679.9n 0.26419 85680.0n 0.10559 85859.9n 0.10559 85860.0n 0.53141 86039.9n 0.53141 86040.0n 0.69502 86219.9n 0.69502 86220.0n -0.14927 86399.9n -0.14927 86400.0n 0.27076 86579.9n 0.27076 86580.0n 1.38855 86759.9n 1.38855 86760.0n 0.69969 86939.9n 0.69969 86940.0n 0.31139 87119.9n 0.31139 87120.0n -0.04662 87299.9n -0.04662 87300.0n 1.36668 87479.9n 1.36668 87480.0n 0.53141 87659.9n 0.53141 87660.0n 0.26419 87839.9n 0.26419 87840.0n 0.17082 88019.9n 0.17082 88020.0n -0.14927 88199.9n -0.14927 88200.0n 0.48508 88379.9n 0.48508 88380.0n 0.70685 88559.9n 0.70685 88560.0n 0.55006 88739.9n 0.55006 88740.0n 0.69502 88919.9n 0.69502 88920.0n 0.27643 89099.9n 0.27643 89100.0n 0.35630 89279.9n 0.35630 89280.0n 0.86030 89459.9n 0.86030 89460.0n 0.10559 89639.9n 0.10559 89640.0n 0.88832 89819.9n 0.88832 89820.0n 0.24079 89999.9n 0.24079 90000.0n 0.21498 90179.9n 0.21498 90180.0n 0.20119 90359.9n 0.20119 90360.0n 0.43581 90539.9n 0.43581 90540.0n 0.47556 90719.9n 0.47556 90720.0n 0.73600 90899.9n 0.73600 90900.0n 0.55066 91079.9n 0.55066 91080.0n 1.21890 91259.9n 1.21890 91260.0n -0.31038 91439.9n -0.31038 91440.0n 1.07007 91619.9n 1.07007 91620.0n 0.52079 91799.9n 0.52079 91800.0n 0.96459 91979.9n 0.96459 91980.0n 0.56449 92159.9n 0.56449 92160.0n 0.96459 92339.9n 0.96459 92340.0n 0.48508 92519.9n 0.48508 92520.0n 0.20119 92699.9n 0.20119 92700.0n 0.70685 92879.9n 0.70685 92880.0n 1.07007 93059.9n 1.07007 93060.0n 0.10559 93239.9n 0.10559 93240.0n 0.27076 93419.9n 0.27076 93420.0n 0.69502 93599.9n 0.69502 93600.0n 0.17082 93779.9n 0.17082 93780.0n 0.88832 93959.9n 0.88832 93960.0n -0.14927 94139.9n -0.14927 94140.0n 0.73600 94319.9n 0.73600 94320.0n 0.26419 94499.9n 0.26419 94500.0n 0.55066 94679.9n 0.55066 94680.0n 0.24079 94859.9n 0.24079 94860.0n 0.52079 95039.9n 0.52079 95040.0n 0.35630 95219.9n 0.35630 95220.0n 0.21498 95399.9n 0.21498 95400.0n 0.55006 95579.9n 0.55006 95580.0n 0.53141 95759.9n 0.53141 95760.0n 0.27643 95939.9n 0.27643 95940.0n 0.69969 96119.9n 0.69969 96120.0n 0.43581 96299.9n 0.43581 96300.0n 0.86030 96479.9n 0.86030 96480.0n 0.31139 96659.9n 0.31139 96660.0n 1.21890 96839.9n 1.21890 96840.0n 1.36668 97019.9n 1.36668 97020.0n 1.38855 97199.9n 1.38855 97200.0n 0.56449 97379.9n 0.56449 97380.0n 0.47556 97559.9n 0.47556 97560.0n -0.31038 97739.9n -0.31038 97740.0n -0.04662 97919.9n -0.04662 97920.0n 1.38855 98099.9n 1.38855 98100.0n 0.96459 98279.9n 0.96459 98280.0n 0.10559 98459.9n 0.10559 98460.0n 0.47556 98639.9n 0.47556 98640.0n 0.27643 98819.9n 0.27643 98820.0n 0.53141 98999.9n 0.53141 99000.0n 1.07007 99179.9n 1.07007 99180.0n -0.14927 99359.9n -0.14927 99360.0n 0.26419 99539.9n 0.26419 99540.0n 0.31139 99719.9n 0.31139 99720.0n 0.73600 99899.9n 0.73600 99900.0n 1.21890 100079.9n 1.21890 100080.0n 0.48508 100259.9n 0.48508 100260.0n 0.56449 100439.9n 0.56449 100440.0n 1.36668 100619.9n 1.36668 100620.0n 0.69969 100799.9n 0.69969 100800.0n 0.20119 100979.9n 0.20119 100980.0n 0.43581 101159.9n 0.43581 101160.0n 0.70685 101339.9n 0.70685 101340.0n -0.04662 101519.9n -0.04662 101520.0n 0.27076 101699.9n 0.27076 101700.0n 0.52079 101879.9n 0.52079 101880.0n 0.55006 102059.9n 0.55006 102060.0n 0.55066 102239.9n 0.55066 102240.0n 0.88832 102419.9n 0.88832 102420.0n 0.86030 102599.9n 0.86030 102600.0n 0.69502 102779.9n 0.69502 102780.0n 0.24079 102959.9n 0.24079 102960.0n -0.31038 103139.9n -0.31038 103140.0n 0.35630 103319.9n 0.35630 103320.0n 0.17082 103499.9n 0.17082 103500.0n 0.21498 103679.9n 0.21498 103680.0n 0.27076 103859.9n 0.27076 103860.0n 0.47556 104039.9n 0.47556 104040.0n 0.53141 104219.9n 0.53141 104220.0n -0.31038 104399.9n -0.31038 104400.0n 0.70685 104579.9n 0.70685 104580.0n 0.55006 104759.9n 0.55006 104760.0n 0.56449 104939.9n 0.56449 104940.0n 0.20119 105119.9n 0.20119 105120.0n 1.21890 105299.9n 1.21890 105300.0n -0.04662 105479.9n -0.04662 105480.0n 0.24079 105659.9n 0.24079 105660.0n 0.10559 105839.9n 0.10559 105840.0n 0.21498 106019.9n 0.21498 106020.0n 0.96459 106199.9n 0.96459 106200.0n 0.73600 106379.9n 0.73600 106380.0n 1.38855 106559.9n 1.38855 106560.0n 0.88832 106739.9n 0.88832 106740.0n 0.43581 106919.9n 0.43581 106920.0n 0.69502 107099.9n 0.69502 107100.0n 0.69969 107279.9n 0.69969 107280.0n 0.17082 107459.9n 0.17082 107460.0n 0.48508 107639.9n 0.48508 107640.0n 0.31139 107819.9n 0.31139 107820.0n 0.27643 107999.9n 0.27643 108000.0n 0.26419 108179.9n 0.26419 108180.0n 1.07007 108359.9n 1.07007 108360.0n 0.52079 108539.9n 0.52079 108540.0n 1.36668 108719.9n 1.36668 108720.0n 0.55066 108899.9n 0.55066 108900.0n 0.35630 109079.9n 0.35630 109080.0n 0.86030 109259.9n 0.86030 109260.0n -0.14927 109439.9n -0.14927 109440.0n 1.21890 109619.9n 1.21890 109620.0n 0.10559 109799.9n 0.10559 109800.0n 0.56449 109979.9n 0.56449 109980.0n -0.04662 110159.9n -0.04662 110160.0n 1.07007 110339.9n 1.07007 110340.0n 0.96459 110519.9n 0.96459 110520.0n 0.24079 110699.9n 0.24079 110700.0n 0.27076 110879.9n 0.27076 110880.0n 0.53141 111059.9n 0.53141 111060.0n 0.43581 111239.9n 0.43581 111240.0n 0.20119 111419.9n 0.20119 111420.0n 1.38855 111599.9n 1.38855 111600.0n 0.48508 111779.9n 0.48508 111780.0n 0.55006 111959.9n 0.55006 111960.0n 0.70685 112139.9n 0.70685 112140.0n 0.21498 112319.9n 0.21498 112320.0n 0.73600 112499.9n 0.73600 112500.0n 0.17082 112679.9n 0.17082 112680.0n -0.14927 112859.9n -0.14927 112860.0n 0.27643 113039.9n 0.27643 113040.0n 0.69502 113219.9n 0.69502 113220.0n 0.69969 113399.9n 0.69969 113400.0n 0.35630 113579.9n 0.35630 113580.0n 0.31139 113759.9n 0.31139 113760.0n 0.26419 113939.9n 0.26419 113940.0n 1.36668 114119.9n 1.36668 114120.0n -0.31038 114299.9n -0.31038 114300.0n 0.55066 114479.9n 0.55066 114480.0n 0.88832 114659.9n 0.88832 114660.0n 0.52079 114839.9n 0.52079 114840.0n 0.86030 115019.9n 0.86030 115020.0n 0.47556 115199.9n 0.47556 115200.0n -0.14927 115379.9n -0.14927 115380.0n 0.53141 115559.9n 0.53141 115560.0n 0.48508 115739.9n 0.48508 115740.0n 0.35630 115919.9n 0.35630 115920.0n 0.47556 116099.9n 0.47556 116100.0n 0.24079 116279.9n 0.24079 116280.0n 0.27643 116459.9n 0.27643 116460.0n 0.69969 116639.9n 0.69969 116640.0n 0.56449 116819.9n 0.56449 116820.0n 0.52079 116999.9n 0.52079 117000.0n 1.21890 117179.9n 1.21890 117180.0n 1.38855 117359.9n 1.38855 117360.0n 0.55006 117539.9n 0.55006 117540.0n -0.31038 117719.9n -0.31038 117720.0n 0.86030 117899.9n 0.86030 117900.0n 1.36668 118079.9n 1.36668 118080.0n -0.04662 118259.9n -0.04662 118260.0n 0.17082 118439.9n 0.17082 118440.0n 0.27076 118619.9n 0.27076 118620.0n 0.10559 118799.9n 0.10559 118800.0n 0.70685 118979.9n 0.70685 118980.0n 0.73600 119159.9n 0.73600 119160.0n 0.21498 119339.9n 0.21498 119340.0n 0.55066 119519.9n 0.55066 119520.0n 0.69502 119699.9n 0.69502 119700.0n 0.20119 119879.9n 0.20119 119880.0n 0.26419 120059.9n 0.26419 120060.0n 1.07007 120239.9n 1.07007 120240.0n 0.43581 120419.9n 0.43581 120420.0n 0.31139 120599.9n 0.31139 120600.0n 0.88832 120779.9n 0.88832 120780.0n 0.96459 120959.9n 0.96459 120960.0n -0.14927 121139.9n -0.14927 121140.0n 0.27076 121319.9n 0.27076 121320.0n 0.73600 121499.9n 0.73600 121500.0n 0.26419 121679.9n 0.26419 121680.0n -0.04662 121859.9n -0.04662 121860.0n 0.56449 122039.9n 0.56449 122040.0n 0.20119 122219.9n 0.20119 122220.0n 0.43581 122399.9n 0.43581 122400.0n 0.53141 122579.9n 0.53141 122580.0n 0.55066 122759.9n 0.55066 122760.0n 0.17082 122939.9n 0.17082 122940.0n -0.31038 123119.9n -0.31038 123120.0n 0.55006 123299.9n 0.55006 123300.0n 0.10559 123479.9n 0.10559 123480.0n 0.47556 123659.9n 0.47556 123660.0n 0.27643 123839.9n 0.27643 123840.0n 0.48508 124019.9n 0.48508 124020.0n 0.86030 124199.9n 0.86030 124200.0n 1.36668 124379.9n 1.36668 124380.0n 0.52079 124559.9n 0.52079 124560.0n 0.21498 124739.9n 0.21498 124740.0n 0.24079 124919.9n 0.24079 124920.0n 1.38855 125099.9n 1.38855 125100.0n 0.88832 125279.9n 0.88832 125280.0n 1.07007 125459.9n 1.07007 125460.0n 1.21890 125639.9n 1.21890 125640.0n 0.35630 125819.9n 0.35630 125820.0n 0.31139 125999.9n 0.31139 126000.0n 0.96459 126179.9n 0.96459 126180.0n 0.70685 126359.9n 0.70685 126360.0n 0.69969 126539.9n 0.69969 126540.0n 0.69502 126719.9n 0.69502 126720.0n 0.27076 126899.9n 0.27076 126900.0n 0.88832 127079.9n 0.88832 127080.0n 0.47556 127259.9n 0.47556 127260.0n -0.14927 127439.9n -0.14927 127440.0n 1.36668 127619.9n 1.36668 127620.0n 0.43581 127799.9n 0.43581 127800.0n 1.07007 127979.9n 1.07007 127980.0n 1.38855 128159.9n 1.38855 128160.0n 0.24079 128339.9n 0.24079 128340.0n 0.35630 128519.9n 0.35630 128520.0n 0.21498 128699.9n 0.21498 128700.0n 0.56449 128879.9n 0.56449 128880.0n 0.53141 129059.9n 0.53141 129060.0n 0.20119 129239.9n 0.20119 129240.0n 0.55006 129419.9n 0.55006 129420.0n 0.70685 129599.9n 0.70685 129600.0n 0.27643 129779.9n 0.27643 129780.0n 0.17082 129959.9n 0.17082 129960.0n 0.69502 130139.9n 0.69502 130140.0n 0.86030 130319.9n 0.86030 130320.0n 0.73600 130499.9n 0.73600 130500.0n 1.21890 130679.9n 1.21890 130680.0n -0.31038 130859.9n -0.31038 130860.0n 0.10559 131039.9n 0.10559 131040.0n 0.55066 131219.9n 0.55066 131220.0n 0.31139 131399.9n 0.31139 131400.0n -0.04662 131579.9n -0.04662 131580.0n 0.48508 131759.9n 0.48508 131760.0n 0.69969 131939.9n 0.69969 131940.0n 0.96459 132119.9n 0.96459 132120.0n 0.52079 132299.9n 0.52079 132300.0n 0.26419 132479.9n 0.26419 132480.0n 1.36668 132659.9n 1.36668 132660.0n 0.96459 132839.9n 0.96459 132840.0n 0.17082 133019.9n 0.17082 133020.0n 0.21498 133199.9n 0.21498 133200.0n 0.53141 133379.9n 0.53141 133380.0n 0.26419 133559.9n 0.26419 133560.0n 0.10559 133739.9n 0.10559 133740.0n 0.27643 133919.9n 0.27643 133920.0n 1.38855 134099.9n 1.38855 134100.0n 0.88832 134279.9n 0.88832 134280.0n 0.69502 134459.9n 0.69502 134460.0n 0.86030 134639.9n 0.86030 134640.0n -0.14927 134819.9n -0.14927 134820.0n 0.69969 134999.9n 0.69969 135000.0n 0.20119 135179.9n 0.20119 135180.0n 0.43581 135359.9n 0.43581 135360.0n 0.35630 135539.9n 0.35630 135540.0n 0.56449 135719.9n 0.56449 135720.0n 0.47556 135899.9n 0.47556 135900.0n 0.31139 136079.9n 0.31139 136080.0n 1.21890 136259.9n 1.21890 136260.0n 0.70685 136439.9n 0.70685 136440.0n 0.27076 136619.9n 0.27076 136620.0n 0.55006 136799.9n 0.55006 136800.0n 0.52079 136979.9n 0.52079 136980.0n 0.55066 137159.9n 0.55066 137160.0n 0.24079 137339.9n 0.24079 137340.0n 0.48508 137519.9n 0.48508 137520.0n 1.07007 137699.9n 1.07007 137700.0n 0.73600 137879.9n 0.73600 137880.0n -0.04662 138059.9n -0.04662 138060.0n -0.31038 138239.9n -0.31038 138240.0n 0.56449 138419.9n 0.56449 138420.0n 0.24079 138599.9n 0.24079 138600.0n 0.73600 138779.9n 0.73600 138780.0n 0.48508 138959.9n 0.48508 138960.0n 0.55066 139139.9n 0.55066 139140.0n 0.88832 139319.9n 0.88832 139320.0n 0.53141 139499.9n 0.53141 139500.0n 0.35630 139679.9n 0.35630 139680.0n 0.86030 139859.9n 0.86030 139860.0n 0.27076 140039.9n 0.27076 140040.0n -0.31038 140219.9n -0.31038 140220.0n 0.96459 140399.9n 0.96459 140400.0n 0.43581 140579.9n 0.43581 140580.0n 0.17082 140759.9n 0.17082 140760.0n 0.26419 140939.9n 0.26419 140940.0n 0.20119 141119.9n 0.20119 141120.0n -0.04662 141299.9n -0.04662 141300.0n 0.52079 141479.9n 0.52079 141480.0n 0.69502 141659.9n 0.69502 141660.0n -0.14927 141839.9n -0.14927 141840.0n 1.38855 142019.9n 1.38855 142020.0n 0.21498 142199.9n 0.21498 142200.0n 0.31139 142379.9n 0.31139 142380.0n 0.70685 142559.9n 0.70685 142560.0n 1.21890 142739.9n 1.21890 142740.0n 1.36668 142919.9n 1.36668 142920.0n 1.07007 143099.9n 1.07007 143100.0n 0.47556 143279.9n 0.47556 143280.0n 0.55006 143459.9n 0.55006 143460.0n 0.27643 143639.9n 0.27643 143640.0n 0.10559 143819.9n 0.10559 143820.0n 0.69969 143999.9n 0.69969 144000.0n 1.07007 144179.9n 1.07007 144180.0n 0.31139 144359.9n 0.31139 144360.0n 0.55006 144539.9n 0.55006 144540.0n 1.36668 144719.9n 1.36668 144720.0n 0.10559 144899.9n 0.10559 144900.0n 0.73600 145079.9n 0.73600 145080.0n 0.52079 145259.9n 0.52079 145260.0n 0.43581 145439.9n 0.43581 145440.0n 0.48508 145619.9n 0.48508 145620.0n 0.70685 145799.9n 0.70685 145800.0n 0.20119 145979.9n 0.20119 145980.0n 1.21890 146159.9n 1.21890 146160.0n 0.26419 146339.9n 0.26419 146340.0n 0.47556 146519.9n 0.47556 146520.0n 0.17082 146699.9n 0.17082 146700.0n 0.27643 146879.9n 0.27643 146880.0n 0.55066 147059.9n 0.55066 147060.0n 0.21498 147239.9n 0.21498 147240.0n 1.38855 147419.9n 1.38855 147420.0n 0.56449 147599.9n 0.56449 147600.0n 0.35630 147779.9n 0.35630 147780.0n 0.86030 147959.9n 0.86030 147960.0n 0.96459 148139.9n 0.96459 148140.0n 0.24079 148319.9n 0.24079 148320.0n -0.14927 148499.9n -0.14927 148500.0n -0.04662 148679.9n -0.04662 148680.0n -0.31038 148859.9n -0.31038 148860.0n 0.69969 149039.9n 0.69969 149040.0n 0.27076 149219.9n 0.27076 149220.0n 0.69502 149399.9n 0.69502 149400.0n 0.53141 149579.9n 0.53141 149580.0n 0.88832 149759.9n 0.88832 149760.0n -0.31038 149939.9n -0.31038 149940.0n 0.47556 150119.9n 0.47556 150120.0n 0.86030 150299.9n 0.86030 150300.0n 0.24079 150479.9n 0.24079 150480.0n 0.96459 150659.9n 0.96459 150660.0n 0.53141 150839.9n 0.53141 150840.0n 0.69502 151019.9n 0.69502 151020.0n 0.21498 151199.9n 0.21498 151200.0n 0.55006 151379.9n 0.55006 151380.0n 0.52079 151559.9n 0.52079 151560.0n 0.56449 151739.9n 0.56449 151740.0n 1.36668 151919.9n 1.36668 151920.0n 0.73600 152099.9n 0.73600 152100.0n 1.38855 152279.9n 1.38855 152280.0n 0.27643 152459.9n 0.27643 152460.0n 0.70685 152639.9n 0.70685 152640.0n 0.43581 152819.9n 0.43581 152820.0n 0.17082 152999.9n 0.17082 153000.0n 1.07007 153179.9n 1.07007 153180.0n 0.48508 153359.9n 0.48508 153360.0n 0.55066 153539.9n 0.55066 153540.0n 0.26419 153719.9n 0.26419 153720.0n 0.69969 153899.9n 0.69969 153900.0n 1.21890 154079.9n 1.21890 154080.0n -0.14927 154259.9n -0.14927 154260.0n 0.20119 154439.9n 0.20119 154440.0n 0.10559 154619.9n 0.10559 154620.0n 0.31139 154799.9n 0.31139 154800.0n 0.88832 154979.9n 0.88832 154980.0n 0.27076 155159.9n 0.27076 155160.0n -0.04662 155339.9n -0.04662 155340.0n 0.35630 155519.9n 0.35630 155520.0n 1.36668 155699.9n 1.36668 155700.0n 0.55006 155879.9n 0.55006 155880.0n 0.27076 156059.9n 0.27076 156060.0n 0.55066 156239.9n 0.55066 156240.0n 0.96459 156419.9n 0.96459 156420.0n 0.43581 156599.9n 0.43581 156600.0n 0.17082 156779.9n 0.17082 156780.0n 0.35630 156959.9n 0.35630 156960.0n 0.69502 157139.9n 0.69502 157140.0n 0.86030 157319.9n 0.86030 157320.0n 1.21890 157499.9n 1.21890 157500.0n 0.53141 157679.9n 0.53141 157680.0n 1.38855 157859.9n 1.38855 157860.0n 0.69969 158039.9n 0.69969 158040.0n 0.20119 158219.9n 0.20119 158220.0n 0.10559 158399.9n 0.10559 158400.0n 0.48508 158579.9n 0.48508 158580.0n 0.21498 158759.9n 0.21498 158760.0n 0.73600 158939.9n 0.73600 158940.0n 0.56449 159119.9n 0.56449 159120.0n 0.47556 159299.9n 0.47556 159300.0n 0.27643 159479.9n 0.27643 159480.0n 0.52079 159659.9n 0.52079 159660.0n 0.24079 159839.9n 0.24079 159840.0n 0.26419 160019.9n 0.26419 160020.0n -0.31038 160199.9n -0.31038 160200.0n -0.14927 160379.9n -0.14927 160380.0n -0.04662 160559.9n -0.04662 160560.0n 1.07007 160739.9n 1.07007 160740.0n 0.70685 160919.9n 0.70685 160920.0n 0.88832 161099.9n 0.88832 161100.0n 0.31139 161279.9n 0.31139 161280.0n 0.53141 161459.9n 0.53141 161460.0n -0.04662 161639.9n -0.04662 161640.0n 0.55066 161819.9n 0.55066 161820.0n 0.27643 161999.9n 0.27643 162000.0n 0.24079 162179.9n 0.24079 162180.0n 1.21890 162359.9n 1.21890 162360.0n 0.43581 162539.9n 0.43581 162540.0n 0.70685 162719.9n 0.70685 162720.0n 0.88832 162899.9n 0.88832 162900.0n 1.36668 163079.9n 1.36668 163080.0n 0.20119 163259.9n 0.20119 163260.0n 0.47556 163439.9n 0.47556 163440.0n 0.52079 163619.9n 0.52079 163620.0n 1.38855 163799.9n 1.38855 163800.0n 0.55006 163979.9n 0.55006 163980.0n 0.86030 164159.9n 0.86030 164160.0n -0.14927 164339.9n -0.14927 164340.0n 0.21498 164519.9n 0.21498 164520.0n 0.56449 164699.9n 0.56449 164700.0n 0.27076 164879.9n 0.27076 164880.0n 0.48508 165059.9n 0.48508 165060.0n 0.17082 165239.9n 0.17082 165240.0n 0.10559 165419.9n 0.10559 165420.0n 0.69502 165599.9n 0.69502 165600.0n 0.69969 165779.9n 0.69969 165780.0n 1.07007 165959.9n 1.07007 165960.0n 0.31139 166139.9n 0.31139 166140.0n 0.26419 166319.9n 0.26419 166320.0n 0.96459 166499.9n 0.96459 166500.0n 0.73600 166679.9n 0.73600 166680.0n -0.31038 166859.9n -0.31038 166860.0n 0.35630 167039.9n 0.35630 167040.0n 0.70685 167219.9n 0.70685 167220.0n 0.69502 167399.9n 0.69502 167400.0n 1.36668 167579.9n 1.36668 167580.0n 0.27643 167759.9n 0.27643 167760.0n 0.27076 167939.9n 0.27076 167940.0n 0.35630 168119.9n 0.35630 168120.0n 0.47556 168299.9n 0.47556 168300.0n 0.69969 168479.9n 0.69969 168480.0n 0.20119 168659.9n 0.20119 168660.0n 0.88832 168839.9n 0.88832 168840.0n 0.96459 169019.9n 0.96459 169020.0n 0.52079 169199.9n 0.52079 169200.0n 0.48508 169379.9n 0.48508 169380.0n 0.53141 169559.9n 0.53141 169560.0n 0.31139 169739.9n 0.31139 169740.0n 0.26419 169919.9n 0.26419 169920.0n -0.04662 170099.9n -0.04662 170100.0n 0.10559 170279.9n 0.10559 170280.0n -0.31038 170459.9n -0.31038 170460.0n 0.55006 170639.9n 0.55006 170640.0n 0.73600 170819.9n 0.73600 170820.0n 0.55066 170999.9n 0.55066 171000.0n 1.38855 171179.9n 1.38855 171180.0n 0.56449 171359.9n 0.56449 171360.0n 1.21890 171539.9n 1.21890 171540.0n 0.86030 171719.9n 0.86030 171720.0n 0.21498 171899.9n 0.21498 171900.0n 1.07007 172079.9n 1.07007 172080.0n -0.14927 172259.9n -0.14927 172260.0n 0.17082 172439.9n 0.17082 172440.0n 0.43581 172619.9n 0.43581 172620.0n 0.24079 172799.9n 0.24079 172800.0n 0.57742 172979.9n 0.57742 172980.0n 0.79287 173159.9n 0.79287 173160.0n 0.60090 173339.9n 0.60090 173340.0n 0.23371 173519.9n 0.23371 173520.0n 0.12484 173699.9n 0.12484 173700.0n 0.48351 173879.9n 0.48351 173880.0n 0.52272 174059.9n 0.52272 174060.0n 0.10421 174239.9n 0.10421 174240.0n 0.26187 174419.9n 0.26187 174420.0n 0.26993 174599.9n 0.26993 174600.0n 0.61195 174779.9n 0.61195 174780.0n 0.55435 174959.9n 0.55435 174960.0n 0.15028 175139.9n 0.15028 175140.0n 0.68626 175319.9n 0.68626 175320.0n 0.46500 175499.9n 0.46500 175500.0n 0.34619 175679.9n 0.34619 175680.0n 0.41172 175859.9n 0.41172 175860.0n 0.70707 176039.9n 0.70707 176040.0n 0.65136 176219.9n 0.65136 176220.0n 0.60081 176399.9n 0.60081 176400.0n 0.71496 176579.9n 0.71496 176580.0n 0.09082 176759.9n 0.09082 176760.0n 0.49669 176939.9n 0.49669 176940.0n 0.71193 177119.9n 0.71193 177120.0n 0.76576 177299.9n 0.76576 177300.0n 0.46112 177479.9n 0.46112 177480.0n 0.51272 177659.9n 0.51272 177660.0n 0.49148 177839.9n 0.49148 177840.0n 0.41550 178019.9n 0.41550 178020.0n 0.63432 178199.9n 0.63432 178200.0n 1.28851 178379.9n 1.28851 178380.0n 1.24585 178559.9n 1.24585 178560.0n -0.15208 178739.9n -0.15208 178740.0n 0.58159 178919.9n 0.58159 178920.0n 0.75662 179099.9n 0.75662 179100.0n -0.49277 179279.9n -0.49277 179280.0n -0.19260 179459.9n -0.19260 179460.0n 1.27962 179639.9n 1.27962 179640.0n 0.44267 179819.9n 0.44267 179820.0n 0.04400 179999.9n 0.04400 180000.0n 1.04710 180179.9n 1.04710 180180.0n 0.19758 180359.9n 0.19758 180360.0n 0.60264 180539.9n 0.60264 180540.0n -0.04029 180719.9n -0.04029 180720.0n 0.36851 180899.9n 0.36851 180900.0n 0.18248 181079.9n 0.18248 181080.0n -0.19808 181259.9n -0.19808 181260.0n -0.39872 181439.9n -0.39872 181440.0n 0.71881 181619.9n 0.71881 181620.0n -0.46004 181799.9n -0.46004 181800.0n 1.19303 181979.9n 1.19303 181980.0n 0.06458 182159.9n 0.06458 182160.0n -0.06311 182339.9n -0.06311 182340.0n -0.11193 182519.9n -0.11193 182520.0n -0.17413 182699.9n -0.17413 182700.0n -0.01300 182879.9n -0.01300 182880.0n -0.13586 183059.9n -0.13586 183060.0n -0.03731 183239.9n -0.03731 183240.0n 0.53061 183419.9n 0.53061 183420.0n 0.42812)
Vxn0 a_xn0 0 PWL(0.0n 0.44994 179.9n 0.44994 180.0n 0.47921 359.9n 0.47921 360.0n 0.56419 539.9n 0.56419 540.0n 0.43551 719.9n 0.43551 720.0n -0.21890 899.9n -0.21890 900.0n 0.72924 1079.9n 0.72924 1080.0n 0.30031 1259.9n 0.30031 1260.0n 0.30498 1439.9n 0.30498 1440.0n 0.11168 1619.9n 0.11168 1620.0n -0.38855 1799.9n -0.38855 1800.0n 1.04662 1979.9n 1.04662 1980.0n 0.89441 2159.9n 0.89441 2160.0n 0.13970 2339.9n 0.13970 2340.0n 0.78502 2519.9n 0.78502 2520.0n 0.68861 2699.9n 0.68861 2700.0n 0.03541 2879.9n 0.03541 2880.0n 0.51492 3059.9n 0.51492 3060.0n 1.31038 3239.9n 1.31038 3240.0n 0.64370 3419.9n 0.64370 3420.0n 0.52444 3599.9n 0.52444 3600.0n 0.72357 3779.9n 0.72357 3780.0n 0.44934 3959.9n 0.44934 3960.0n 0.46859 4139.9n 0.46859 4140.0n 0.79881 4319.9n 0.79881 4320.0n -0.07007 4499.9n -0.07007 4500.0n 0.75921 4679.9n 0.75921 4680.0n 0.29315 4859.9n 0.29315 4860.0n -0.36668 5039.9n -0.36668 5040.0n 0.26400 5219.9n 0.26400 5220.0n 1.14927 5399.9n 1.14927 5400.0n 0.82918 5579.9n 0.82918 5580.0n 0.73581 5759.9n 0.73581 5760.0n -0.07007 5939.9n -0.07007 5940.0n 0.11168 6119.9n 0.11168 6120.0n -0.38855 6299.9n -0.38855 6300.0n 0.26400 6479.9n 0.26400 6480.0n 0.64370 6659.9n 0.64370 6660.0n -0.36668 6839.9n -0.36668 6840.0n 1.14927 7019.9n 1.14927 7020.0n 0.52444 7199.9n 0.52444 7200.0n 0.68861 7379.9n 0.68861 7380.0n 1.04662 7559.9n 1.04662 7560.0n 0.47921 7739.9n 0.47921 7740.0n 0.13970 7919.9n 0.13970 7920.0n 0.82918 8099.9n 0.82918 8100.0n 0.43551 8279.9n 0.43551 8280.0n -0.21890 8459.9n -0.21890 8460.0n 0.78502 8639.9n 0.78502 8640.0n 0.30031 8819.9n 0.30031 8820.0n 1.31038 8999.9n 1.31038 9000.0n 0.75921 9179.9n 0.75921 9180.0n 0.56419 9359.9n 0.56419 9360.0n 0.89441 9539.9n 0.89441 9540.0n 0.29315 9719.9n 0.29315 9720.0n 0.44994 9899.9n 0.44994 9900.0n 0.79881 10079.9n 0.79881 10080.0n 0.46859 10259.9n 0.46859 10260.0n 0.72924 10439.9n 0.72924 10440.0n 0.03541 10619.9n 0.03541 10620.0n 0.30498 10799.9n 0.30498 10800.0n 0.51492 10979.9n 0.51492 10980.0n 0.72357 11159.9n 0.72357 11160.0n 0.44934 11339.9n 0.44934 11340.0n 0.73581 11519.9n 0.73581 11520.0n -0.07007 11699.9n -0.07007 11700.0n 1.14927 11879.9n 1.14927 11880.0n 0.03541 12059.9n 0.03541 12060.0n 0.75921 12239.9n 0.75921 12240.0n 0.47921 12419.9n 0.47921 12420.0n 0.73581 12599.9n 0.73581 12600.0n 0.30031 12779.9n 0.30031 12780.0n 0.64370 12959.9n 0.64370 12960.0n 0.13970 13139.9n 0.13970 13140.0n 0.44934 13319.9n 0.44934 13320.0n 0.11168 13499.9n 0.11168 13500.0n 0.46859 13679.9n 0.46859 13680.0n -0.36668 13859.9n -0.36668 13860.0n 0.68861 14039.9n 0.68861 14040.0n 0.72357 14219.9n 0.72357 14220.0n 0.56419 14399.9n 0.56419 14400.0n 0.52444 14579.9n 0.52444 14580.0n 0.51492 14759.9n 0.51492 14760.0n 0.78502 14939.9n 0.78502 14940.0n 0.79881 15119.9n 0.79881 15120.0n 0.29315 15299.9n 0.29315 15300.0n -0.21890 15479.9n -0.21890 15480.0n 0.89441 15659.9n 0.89441 15660.0n 0.72924 15839.9n 0.72924 15840.0n 0.43551 16019.9n 0.43551 16020.0n 0.30498 16199.9n 0.30498 16200.0n -0.38855 16379.9n -0.38855 16380.0n 0.82918 16559.9n 0.82918 16560.0n 0.26400 16739.9n 0.26400 16740.0n 1.04662 16919.9n 1.04662 16920.0n 1.31038 17099.9n 1.31038 17100.0n 0.44994 17279.9n 0.44994 17280.0n 1.14927 17459.9n 1.14927 17460.0n 0.13970 17639.9n 0.13970 17640.0n 0.26400 17819.9n 0.26400 17820.0n 0.56419 17999.9n 0.56419 18000.0n -0.07007 18179.9n -0.07007 18180.0n -0.21890 18359.9n -0.21890 18360.0n 0.44934 18539.9n 0.44934 18540.0n 1.31038 18719.9n 1.31038 18720.0n 0.72924 18899.9n 0.72924 18900.0n 0.43551 19079.9n 0.43551 19080.0n 0.30031 19259.9n 0.30031 19260.0n 0.78502 19439.9n 0.78502 19440.0n 0.47921 19619.9n 0.47921 19620.0n 0.79881 19799.9n 0.79881 19800.0n 0.64370 19979.9n 0.64370 19980.0n 0.11168 20159.9n 0.11168 20160.0n 0.75921 20339.9n 0.75921 20340.0n 0.29315 20519.9n 0.29315 20520.0n 1.04662 20699.9n 1.04662 20700.0n 0.46859 20879.9n 0.46859 20880.0n 0.03541 21059.9n 0.03541 21060.0n 0.30498 21239.9n 0.30498 21240.0n 0.68861 21419.9n 0.68861 21420.0n 0.52444 21599.9n 0.52444 21600.0n 0.72357 21779.9n 0.72357 21780.0n 0.82918 21959.9n 0.82918 21960.0n 0.89441 22139.9n 0.89441 22140.0n 0.44994 22319.9n 0.44994 22320.0n 0.51492 22499.9n 0.51492 22500.0n -0.36668 22679.9n -0.36668 22680.0n 0.73581 22859.9n 0.73581 22860.0n -0.38855 23039.9n -0.38855 23040.0n 0.46859 23219.9n 0.46859 23220.0n 0.44994 23399.9n 0.44994 23400.0n 0.79881 23579.9n 0.79881 23580.0n 0.72357 23759.9n 0.72357 23760.0n 0.43551 23939.9n 0.43551 23940.0n 1.31038 24119.9n 1.31038 24120.0n -0.21890 24299.9n -0.21890 24300.0n 0.44934 24479.9n 0.44934 24480.0n 0.29315 24659.9n 0.29315 24660.0n 0.30498 24839.9n 0.30498 24840.0n 0.78502 25019.9n 0.78502 25020.0n 0.68861 25199.9n 0.68861 25200.0n 0.64370 25379.9n 0.64370 25380.0n 0.72924 25559.9n 0.72924 25560.0n 0.11168 25739.9n 0.11168 25740.0n 0.56419 25919.9n 0.56419 25920.0n 1.04662 26099.9n 1.04662 26100.0n 0.75921 26279.9n 0.75921 26280.0n 0.47921 26459.9n 0.47921 26460.0n 0.52444 26639.9n 0.52444 26640.0n 0.89441 26819.9n 0.89441 26820.0n 0.51492 26999.9n 0.51492 27000.0n 0.13970 27179.9n 0.13970 27180.0n -0.07007 27359.9n -0.07007 27360.0n -0.36668 27539.9n -0.36668 27540.0n -0.38855 27719.9n -0.38855 27720.0n 1.14927 27899.9n 1.14927 27900.0n 0.30031 28079.9n 0.30031 28080.0n 0.82918 28259.9n 0.82918 28260.0n 0.73581 28439.9n 0.73581 28440.0n 0.26400 28619.9n 0.26400 28620.0n 0.03541 28799.9n 0.03541 28800.0n 0.56419 28979.9n 0.56419 28980.0n 0.13970 29159.9n 0.13970 29160.0n 0.82918 29339.9n 0.82918 29340.0n 0.72357 29519.9n 0.72357 29520.0n 0.51492 29699.9n 0.51492 29700.0n 0.79881 29879.9n 0.79881 29880.0n 0.64370 30059.9n 0.64370 30060.0n -0.21890 30239.9n -0.21890 30240.0n 0.29315 30419.9n 0.29315 30420.0n 0.43551 30599.9n 0.43551 30600.0n 0.78502 30779.9n 0.78502 30780.0n 0.44934 30959.9n 0.44934 30960.0n -0.07007 31139.9n -0.07007 31140.0n 0.72924 31319.9n 0.72924 31320.0n -0.36668 31499.9n -0.36668 31500.0n 0.26400 31679.9n 0.26400 31680.0n 0.75921 31859.9n 0.75921 31860.0n 0.30498 32039.9n 0.30498 32040.0n 0.11168 32219.9n 0.11168 32220.0n 1.04662 32399.9n 1.04662 32400.0n 0.30031 32579.9n 0.30031 32580.0n 0.68861 32759.9n 0.68861 32760.0n 0.44994 32939.9n 0.44994 32940.0n 0.47921 33119.9n 0.47921 33120.0n 0.46859 33299.9n 0.46859 33300.0n 1.31038 33479.9n 1.31038 33480.0n 0.52444 33659.9n 0.52444 33660.0n 1.14927 33839.9n 1.14927 33840.0n 0.89441 34019.9n 0.89441 34020.0n -0.38855 34199.9n -0.38855 34200.0n 0.03541 34379.9n 0.03541 34380.0n 0.73581 34559.9n 0.73581 34560.0n -0.21890 34739.9n -0.21890 34740.0n 0.68861 34919.9n 0.68861 34920.0n 0.30498 35099.9n 0.30498 35100.0n 0.13970 35279.9n 0.13970 35280.0n 0.73581 35459.9n 0.73581 35460.0n 0.47921 35639.9n 0.47921 35640.0n 0.52444 35819.9n 0.52444 35820.0n 0.72924 35999.9n 0.72924 36000.0n 1.04662 36179.9n 1.04662 36180.0n 0.43551 36359.9n 0.43551 36360.0n 0.51492 36539.9n 0.51492 36540.0n 0.44994 36719.9n 0.44994 36720.0n 0.72357 36899.9n 0.72357 36900.0n 0.03541 37079.9n 0.03541 37080.0n 0.44934 37259.9n 0.44934 37260.0n 1.14927 37439.9n 1.14927 37440.0n 0.26400 37619.9n 0.26400 37620.0n 0.11168 37799.9n 0.11168 37800.0n 1.31038 37979.9n 1.31038 37980.0n 0.56419 38159.9n 0.56419 38160.0n 0.29315 38339.9n 0.29315 38340.0n 0.78502 38519.9n 0.78502 38520.0n 0.79881 38699.9n 0.79881 38700.0n 0.64370 38879.9n 0.64370 38880.0n 0.82918 39059.9n 0.82918 39060.0n 0.89441 39239.9n 0.89441 39240.0n 0.30031 39419.9n 0.30031 39420.0n -0.07007 39599.9n -0.07007 39600.0n -0.36668 39779.9n -0.36668 39780.0n 0.75921 39959.9n 0.75921 39960.0n -0.38855 40139.9n -0.38855 40140.0n 0.46859 40319.9n 0.46859 40320.0n 0.30498 40499.9n 0.30498 40500.0n 0.29315 40679.9n 0.29315 40680.0n 0.89441 40859.9n 0.89441 40860.0n 1.31038 41039.9n 1.31038 41040.0n -0.07007 41219.9n -0.07007 41220.0n 0.30031 41399.9n 0.30031 41400.0n 0.47921 41579.9n 0.47921 41580.0n 0.44934 41759.9n 0.44934 41760.0n 0.68861 41939.9n 0.68861 41940.0n 0.26400 42119.9n 0.26400 42120.0n 0.82918 42299.9n 0.82918 42300.0n 0.75921 42479.9n 0.75921 42480.0n 0.43551 42659.9n 0.43551 42660.0n 0.79881 42839.9n 0.79881 42840.0n 1.14927 43019.9n 1.14927 43020.0n 0.13970 43199.9n 0.13970 43200.0n -0.38855 43379.9n -0.38855 43380.0n 0.72924 43559.9n 0.72924 43560.0n 0.73581 43739.9n 0.73581 43740.0n -0.21890 43919.9n -0.21890 43920.0n 0.44994 44099.9n 0.44994 44100.0n 0.56419 44279.9n 0.56419 44280.0n 0.52444 44459.9n 0.52444 44460.0n 0.78502 44639.9n 0.78502 44640.0n -0.36668 44819.9n -0.36668 44820.0n 0.64370 44999.9n 0.64370 45000.0n 0.72357 45179.9n 0.72357 45180.0n 0.51492 45359.9n 0.51492 45360.0n 0.11168 45539.9n 0.11168 45540.0n 0.46859 45719.9n 0.46859 45720.0n 1.04662 45899.9n 1.04662 45900.0n 0.03541 46079.9n 0.03541 46080.0n 0.79881 46259.9n 0.79881 46260.0n 0.44934 46439.9n 0.44934 46440.0n -0.07007 46619.9n -0.07007 46620.0n 0.89441 46799.9n 0.89441 46800.0n 0.73581 46979.9n 0.73581 46980.0n 0.29315 47159.9n 0.29315 47160.0n 0.78502 47339.9n 0.78502 47340.0n -0.21890 47519.9n -0.21890 47520.0n 0.11168 47699.9n 0.11168 47700.0n 0.52444 47879.9n 0.52444 47880.0n 0.64370 48059.9n 0.64370 48060.0n 0.30031 48239.9n 0.30031 48240.0n 0.68861 48419.9n 0.68861 48420.0n 0.43551 48599.9n 0.43551 48600.0n 0.13970 48779.9n 0.13970 48780.0n 0.30498 48959.9n 0.30498 48960.0n 1.04662 49139.9n 1.04662 49140.0n 0.51492 49319.9n 0.51492 49320.0n 0.56419 49499.9n 0.56419 49500.0n 1.14927 49679.9n 1.14927 49680.0n 0.47921 49859.9n 0.47921 49860.0n 1.31038 50039.9n 1.31038 50040.0n 0.72924 50219.9n 0.72924 50220.0n 0.46859 50399.9n 0.46859 50400.0n 0.82918 50579.9n 0.82918 50580.0n -0.36668 50759.9n -0.36668 50760.0n 0.26400 50939.9n 0.26400 50940.0n 0.44994 51119.9n 0.44994 51120.0n -0.38855 51299.9n -0.38855 51300.0n 0.75921 51479.9n 0.75921 51480.0n 0.72357 51659.9n 0.72357 51660.0n 0.03541 51839.9n 0.03541 51840.0n 0.47921 52019.9n 0.47921 52020.0n 0.13970 52199.9n 0.13970 52200.0n 0.29315 52379.9n 0.29315 52380.0n 0.11168 52559.9n 0.11168 52560.0n 0.26400 52739.9n 0.26400 52740.0n -0.38855 52919.9n -0.38855 52920.0n 0.52444 53099.9n 0.52444 53100.0n 0.78502 53279.9n 0.78502 53280.0n 0.51492 53459.9n 0.51492 53460.0n 0.75921 53639.9n 0.75921 53640.0n 0.43551 53819.9n 0.43551 53820.0n 1.14927 53999.9n 1.14927 54000.0n 0.72357 54179.9n 0.72357 54180.0n 0.03541 54359.9n 0.03541 54360.0n 0.46859 54539.9n 0.46859 54540.0n 0.82918 54719.9n 0.82918 54720.0n 1.04662 54899.9n 1.04662 54900.0n 0.73581 55079.9n 0.73581 55080.0n -0.07007 55259.9n -0.07007 55260.0n 1.31038 55439.9n 1.31038 55440.0n 0.64370 55619.9n 0.64370 55620.0n 0.44994 55799.9n 0.44994 55800.0n 0.68861 55979.9n 0.68861 55980.0n 0.56419 56159.9n 0.56419 56160.0n 0.79881 56339.9n 0.79881 56340.0n -0.36668 56519.9n -0.36668 56520.0n -0.21890 56699.9n -0.21890 56700.0n 0.30031 56879.9n 0.30031 56880.0n 0.89441 57059.9n 0.89441 57060.0n 0.44934 57239.9n 0.44934 57240.0n 0.72924 57419.9n 0.72924 57420.0n 0.30498 57599.9n 0.30498 57600.0n 0.46859 57779.9n 0.46859 57780.0n 0.11168 57959.9n 0.11168 57960.0n 0.51492 58139.9n 0.51492 58140.0n 0.78502 58319.9n 0.78502 58320.0n -0.21890 58499.9n -0.21890 58500.0n 0.56419 58679.9n 0.56419 58680.0n 0.64370 58859.9n 0.64370 58860.0n 0.72357 59039.9n 0.72357 59040.0n 0.03541 59219.9n 0.03541 59220.0n 0.72924 59399.9n 0.72924 59400.0n 1.14927 59579.9n 1.14927 59580.0n 1.31038 59759.9n 1.31038 59760.0n 0.73581 59939.9n 0.73581 59940.0n 0.29315 60119.9n 0.29315 60120.0n 0.52444 60299.9n 0.52444 60300.0n 0.44994 60479.9n 0.44994 60480.0n 0.47921 60659.9n 0.47921 60660.0n 0.30498 60839.9n 0.30498 60840.0n 0.82918 61019.9n 0.82918 61020.0n 0.13970 61199.9n 0.13970 61200.0n 0.79881 61379.9n 0.79881 61380.0n 0.68861 61559.9n 0.68861 61560.0n -0.07007 61739.9n -0.07007 61740.0n -0.36668 61919.9n -0.36668 61920.0n 0.89441 62099.9n 0.89441 62100.0n -0.38855 62279.9n -0.38855 62280.0n 0.26400 62459.9n 0.26400 62460.0n 0.44934 62639.9n 0.44934 62640.0n 0.43551 62819.9n 0.43551 62820.0n 0.30031 62999.9n 0.30031 63000.0n 1.04662 63179.9n 1.04662 63180.0n 0.75921 63359.9n 0.75921 63360.0n 0.43551 63539.9n 0.43551 63540.0n 0.29315 63719.9n 0.29315 63720.0n 0.72924 63899.9n 0.72924 63900.0n 0.44994 64079.9n 0.44994 64080.0n 0.47921 64259.9n 0.47921 64260.0n 0.73581 64439.9n 0.73581 64440.0n 0.78502 64619.9n 0.78502 64620.0n 0.52444 64799.9n 0.52444 64800.0n 0.75921 64979.9n 0.75921 64980.0n 0.30031 65159.9n 0.30031 65160.0n 0.46859 65339.9n 0.46859 65340.0n -0.21890 65519.9n -0.21890 65520.0n -0.38855 65699.9n -0.38855 65700.0n 0.30498 65879.9n 0.30498 65880.0n -0.07007 66059.9n -0.07007 66060.0n 0.03541 66239.9n 0.03541 66240.0n 0.13970 66419.9n 0.13970 66420.0n 0.51492 66599.9n 0.51492 66600.0n 0.64370 66779.9n 0.64370 66780.0n 0.26400 66959.9n 0.26400 66960.0n 0.89441 67139.9n 0.89441 67140.0n 0.11168 67319.9n 0.11168 67320.0n 0.72357 67499.9n 0.72357 67500.0n 0.79881 67679.9n 0.79881 67680.0n 0.44934 67859.9n 0.44934 67860.0n 1.14927 68039.9n 1.14927 68040.0n 0.82918 68219.9n 0.82918 68220.0n -0.36668 68399.9n -0.36668 68400.0n 0.68861 68579.9n 0.68861 68580.0n 1.31038 68759.9n 1.31038 68760.0n 1.04662 68939.9n 1.04662 68940.0n 0.56419 69119.9n 0.56419 69120.0n 0.72357 69299.9n 0.72357 69300.0n 0.64370 69479.9n 0.64370 69480.0n 0.44994 69659.9n 0.44994 69660.0n 0.13970 69839.9n 0.13970 69840.0n 0.79881 70019.9n 0.79881 70020.0n 1.14927 70199.9n 1.14927 70200.0n 0.89441 70379.9n 0.89441 70380.0n 0.72924 70559.9n 0.72924 70560.0n 1.04662 70739.9n 1.04662 70740.0n 0.11168 70919.9n 0.11168 70920.0n 0.82918 71099.9n 0.82918 71100.0n 0.30498 71279.9n 0.30498 71280.0n 0.43551 71459.9n 0.43551 71460.0n 0.26400 71639.9n 0.26400 71640.0n -0.38855 71819.9n -0.38855 71820.0n 0.52444 71999.9n 0.52444 72000.0n 1.31038 72179.9n 1.31038 72180.0n 0.68861 72359.9n 0.68861 72360.0n 0.75921 72539.9n 0.75921 72540.0n -0.07007 72719.9n -0.07007 72720.0n 0.03541 72899.9n 0.03541 72900.0n 0.78502 73079.9n 0.78502 73080.0n 0.29315 73259.9n 0.29315 73260.0n -0.36668 73439.9n -0.36668 73440.0n 0.73581 73619.9n 0.73581 73620.0n 0.44934 73799.9n 0.44934 73800.0n 0.51492 73979.9n 0.51492 73980.0n 0.46859 74159.9n 0.46859 74160.0n 0.30031 74339.9n 0.30031 74340.0n 0.47921 74519.9n 0.47921 74520.0n 0.56419 74699.9n 0.56419 74700.0n -0.21890 74879.9n -0.21890 74880.0n 0.52444 75059.9n 0.52444 75060.0n 0.68861 75239.9n 0.68861 75240.0n 0.56419 75419.9n 0.56419 75420.0n 0.82918 75599.9n 0.82918 75600.0n 0.44934 75779.9n 0.44934 75780.0n 0.78502 75959.9n 0.78502 75960.0n 0.64370 76139.9n 0.64370 76140.0n 0.43551 76319.9n 0.43551 76320.0n 1.31038 76499.9n 1.31038 76500.0n 0.30031 76679.9n 0.30031 76680.0n 0.29315 76859.9n 0.29315 76860.0n 0.13970 77039.9n 0.13970 77040.0n 0.79881 77219.9n 0.79881 77220.0n -0.21890 77399.9n -0.21890 77400.0n 0.72924 77579.9n 0.72924 77580.0n 0.75921 77759.9n 0.75921 77760.0n 0.03541 77939.9n 0.03541 77940.0n 0.89441 78119.9n 0.89441 78120.0n -0.38855 78299.9n -0.38855 78300.0n 0.26400 78479.9n 0.26400 78480.0n 0.73581 78659.9n 0.73581 78660.0n 1.04662 78839.9n 1.04662 78840.0n 1.14927 79019.9n 1.14927 79020.0n 0.44994 79199.9n 0.44994 79200.0n -0.36668 79379.9n -0.36668 79380.0n 0.72357 79559.9n 0.72357 79560.0n 0.47921 79739.9n 0.47921 79740.0n 0.51492 79919.9n 0.51492 79920.0n 0.46859 80099.9n 0.46859 80100.0n -0.07007 80279.9n -0.07007 80280.0n 0.11168 80459.9n 0.11168 80460.0n 0.30498 80639.9n 0.30498 80640.0n -0.36668 80819.9n -0.36668 80820.0n 0.11168 80999.9n 0.11168 81000.0n 0.72357 81179.9n 0.72357 81180.0n 0.44934 81359.9n 0.44934 81360.0n 0.44994 81539.9n 0.44994 81540.0n 0.79881 81719.9n 0.79881 81720.0n 0.52444 81899.9n 0.52444 81900.0n -0.38855 82079.9n -0.38855 82080.0n 0.47921 82259.9n 0.47921 82260.0n 0.64370 82439.9n 0.64370 82440.0n 0.43551 82619.9n 0.43551 82620.0n 0.26400 82799.9n 0.26400 82800.0n 0.13970 82979.9n 0.13970 82980.0n -0.21890 83159.9n -0.21890 83160.0n 0.72924 83339.9n 0.72924 83340.0n 1.04662 83519.9n 1.04662 83520.0n 0.75921 83699.9n 0.75921 83700.0n 0.56419 83879.9n 0.56419 83880.0n 0.03541 84059.9n 0.03541 84060.0n 0.30031 84239.9n 0.30031 84240.0n 0.51492 84419.9n 0.51492 84420.0n 1.31038 84599.9n 1.31038 84600.0n -0.07007 84779.9n -0.07007 84780.0n 0.29315 84959.9n 0.29315 84960.0n 0.68861 85139.9n 0.68861 85140.0n 0.78502 85319.9n 0.78502 85320.0n 0.82918 85499.9n 0.82918 85500.0n 0.73581 85679.9n 0.73581 85680.0n 0.89441 85859.9n 0.89441 85860.0n 0.46859 86039.9n 0.46859 86040.0n 0.30498 86219.9n 0.30498 86220.0n 1.14927 86399.9n 1.14927 86400.0n 0.72924 86579.9n 0.72924 86580.0n -0.38855 86759.9n -0.38855 86760.0n 0.30031 86939.9n 0.30031 86940.0n 0.68861 87119.9n 0.68861 87120.0n 1.04662 87299.9n 1.04662 87300.0n -0.36668 87479.9n -0.36668 87480.0n 0.46859 87659.9n 0.46859 87660.0n 0.73581 87839.9n 0.73581 87840.0n 0.82918 88019.9n 0.82918 88020.0n 1.14927 88199.9n 1.14927 88200.0n 0.51492 88379.9n 0.51492 88380.0n 0.29315 88559.9n 0.29315 88560.0n 0.44994 88739.9n 0.44994 88740.0n 0.30498 88919.9n 0.30498 88920.0n 0.72357 89099.9n 0.72357 89100.0n 0.64370 89279.9n 0.64370 89280.0n 0.13970 89459.9n 0.13970 89460.0n 0.89441 89639.9n 0.89441 89640.0n 0.11168 89819.9n 0.11168 89820.0n 0.75921 89999.9n 0.75921 90000.0n 0.78502 90179.9n 0.78502 90180.0n 0.79881 90359.9n 0.79881 90360.0n 0.56419 90539.9n 0.56419 90540.0n 0.52444 90719.9n 0.52444 90720.0n 0.26400 90899.9n 0.26400 90900.0n 0.44934 91079.9n 0.44934 91080.0n -0.21890 91259.9n -0.21890 91260.0n 1.31038 91439.9n 1.31038 91440.0n -0.07007 91619.9n -0.07007 91620.0n 0.47921 91799.9n 0.47921 91800.0n 0.03541 91979.9n 0.03541 91980.0n 0.43551 92159.9n 0.43551 92160.0n 0.03541 92339.9n 0.03541 92340.0n 0.51492 92519.9n 0.51492 92520.0n 0.79881 92699.9n 0.79881 92700.0n 0.29315 92879.9n 0.29315 92880.0n -0.07007 93059.9n -0.07007 93060.0n 0.89441 93239.9n 0.89441 93240.0n 0.72924 93419.9n 0.72924 93420.0n 0.30498 93599.9n 0.30498 93600.0n 0.82918 93779.9n 0.82918 93780.0n 0.11168 93959.9n 0.11168 93960.0n 1.14927 94139.9n 1.14927 94140.0n 0.26400 94319.9n 0.26400 94320.0n 0.73581 94499.9n 0.73581 94500.0n 0.44934 94679.9n 0.44934 94680.0n 0.75921 94859.9n 0.75921 94860.0n 0.47921 95039.9n 0.47921 95040.0n 0.64370 95219.9n 0.64370 95220.0n 0.78502 95399.9n 0.78502 95400.0n 0.44994 95579.9n 0.44994 95580.0n 0.46859 95759.9n 0.46859 95760.0n 0.72357 95939.9n 0.72357 95940.0n 0.30031 96119.9n 0.30031 96120.0n 0.56419 96299.9n 0.56419 96300.0n 0.13970 96479.9n 0.13970 96480.0n 0.68861 96659.9n 0.68861 96660.0n -0.21890 96839.9n -0.21890 96840.0n -0.36668 97019.9n -0.36668 97020.0n -0.38855 97199.9n -0.38855 97200.0n 0.43551 97379.9n 0.43551 97380.0n 0.52444 97559.9n 0.52444 97560.0n 1.31038 97739.9n 1.31038 97740.0n 1.04662 97919.9n 1.04662 97920.0n -0.38855 98099.9n -0.38855 98100.0n 0.03541 98279.9n 0.03541 98280.0n 0.89441 98459.9n 0.89441 98460.0n 0.52444 98639.9n 0.52444 98640.0n 0.72357 98819.9n 0.72357 98820.0n 0.46859 98999.9n 0.46859 99000.0n -0.07007 99179.9n -0.07007 99180.0n 1.14927 99359.9n 1.14927 99360.0n 0.73581 99539.9n 0.73581 99540.0n 0.68861 99719.9n 0.68861 99720.0n 0.26400 99899.9n 0.26400 99900.0n -0.21890 100079.9n -0.21890 100080.0n 0.51492 100259.9n 0.51492 100260.0n 0.43551 100439.9n 0.43551 100440.0n -0.36668 100619.9n -0.36668 100620.0n 0.30031 100799.9n 0.30031 100800.0n 0.79881 100979.9n 0.79881 100980.0n 0.56419 101159.9n 0.56419 101160.0n 0.29315 101339.9n 0.29315 101340.0n 1.04662 101519.9n 1.04662 101520.0n 0.72924 101699.9n 0.72924 101700.0n 0.47921 101879.9n 0.47921 101880.0n 0.44994 102059.9n 0.44994 102060.0n 0.44934 102239.9n 0.44934 102240.0n 0.11168 102419.9n 0.11168 102420.0n 0.13970 102599.9n 0.13970 102600.0n 0.30498 102779.9n 0.30498 102780.0n 0.75921 102959.9n 0.75921 102960.0n 1.31038 103139.9n 1.31038 103140.0n 0.64370 103319.9n 0.64370 103320.0n 0.82918 103499.9n 0.82918 103500.0n 0.78502 103679.9n 0.78502 103680.0n 0.72924 103859.9n 0.72924 103860.0n 0.52444 104039.9n 0.52444 104040.0n 0.46859 104219.9n 0.46859 104220.0n 1.31038 104399.9n 1.31038 104400.0n 0.29315 104579.9n 0.29315 104580.0n 0.44994 104759.9n 0.44994 104760.0n 0.43551 104939.9n 0.43551 104940.0n 0.79881 105119.9n 0.79881 105120.0n -0.21890 105299.9n -0.21890 105300.0n 1.04662 105479.9n 1.04662 105480.0n 0.75921 105659.9n 0.75921 105660.0n 0.89441 105839.9n 0.89441 105840.0n 0.78502 106019.9n 0.78502 106020.0n 0.03541 106199.9n 0.03541 106200.0n 0.26400 106379.9n 0.26400 106380.0n -0.38855 106559.9n -0.38855 106560.0n 0.11168 106739.9n 0.11168 106740.0n 0.56419 106919.9n 0.56419 106920.0n 0.30498 107099.9n 0.30498 107100.0n 0.30031 107279.9n 0.30031 107280.0n 0.82918 107459.9n 0.82918 107460.0n 0.51492 107639.9n 0.51492 107640.0n 0.68861 107819.9n 0.68861 107820.0n 0.72357 107999.9n 0.72357 108000.0n 0.73581 108179.9n 0.73581 108180.0n -0.07007 108359.9n -0.07007 108360.0n 0.47921 108539.9n 0.47921 108540.0n -0.36668 108719.9n -0.36668 108720.0n 0.44934 108899.9n 0.44934 108900.0n 0.64370 109079.9n 0.64370 109080.0n 0.13970 109259.9n 0.13970 109260.0n 1.14927 109439.9n 1.14927 109440.0n -0.21890 109619.9n -0.21890 109620.0n 0.89441 109799.9n 0.89441 109800.0n 0.43551 109979.9n 0.43551 109980.0n 1.04662 110159.9n 1.04662 110160.0n -0.07007 110339.9n -0.07007 110340.0n 0.03541 110519.9n 0.03541 110520.0n 0.75921 110699.9n 0.75921 110700.0n 0.72924 110879.9n 0.72924 110880.0n 0.46859 111059.9n 0.46859 111060.0n 0.56419 111239.9n 0.56419 111240.0n 0.79881 111419.9n 0.79881 111420.0n -0.38855 111599.9n -0.38855 111600.0n 0.51492 111779.9n 0.51492 111780.0n 0.44994 111959.9n 0.44994 111960.0n 0.29315 112139.9n 0.29315 112140.0n 0.78502 112319.9n 0.78502 112320.0n 0.26400 112499.9n 0.26400 112500.0n 0.82918 112679.9n 0.82918 112680.0n 1.14927 112859.9n 1.14927 112860.0n 0.72357 113039.9n 0.72357 113040.0n 0.30498 113219.9n 0.30498 113220.0n 0.30031 113399.9n 0.30031 113400.0n 0.64370 113579.9n 0.64370 113580.0n 0.68861 113759.9n 0.68861 113760.0n 0.73581 113939.9n 0.73581 113940.0n -0.36668 114119.9n -0.36668 114120.0n 1.31038 114299.9n 1.31038 114300.0n 0.44934 114479.9n 0.44934 114480.0n 0.11168 114659.9n 0.11168 114660.0n 0.47921 114839.9n 0.47921 114840.0n 0.13970 115019.9n 0.13970 115020.0n 0.52444 115199.9n 0.52444 115200.0n 1.14927 115379.9n 1.14927 115380.0n 0.46859 115559.9n 0.46859 115560.0n 0.51492 115739.9n 0.51492 115740.0n 0.64370 115919.9n 0.64370 115920.0n 0.52444 116099.9n 0.52444 116100.0n 0.75921 116279.9n 0.75921 116280.0n 0.72357 116459.9n 0.72357 116460.0n 0.30031 116639.9n 0.30031 116640.0n 0.43551 116819.9n 0.43551 116820.0n 0.47921 116999.9n 0.47921 117000.0n -0.21890 117179.9n -0.21890 117180.0n -0.38855 117359.9n -0.38855 117360.0n 0.44994 117539.9n 0.44994 117540.0n 1.31038 117719.9n 1.31038 117720.0n 0.13970 117899.9n 0.13970 117900.0n -0.36668 118079.9n -0.36668 118080.0n 1.04662 118259.9n 1.04662 118260.0n 0.82918 118439.9n 0.82918 118440.0n 0.72924 118619.9n 0.72924 118620.0n 0.89441 118799.9n 0.89441 118800.0n 0.29315 118979.9n 0.29315 118980.0n 0.26400 119159.9n 0.26400 119160.0n 0.78502 119339.9n 0.78502 119340.0n 0.44934 119519.9n 0.44934 119520.0n 0.30498 119699.9n 0.30498 119700.0n 0.79881 119879.9n 0.79881 119880.0n 0.73581 120059.9n 0.73581 120060.0n -0.07007 120239.9n -0.07007 120240.0n 0.56419 120419.9n 0.56419 120420.0n 0.68861 120599.9n 0.68861 120600.0n 0.11168 120779.9n 0.11168 120780.0n 0.03541 120959.9n 0.03541 120960.0n 1.14927 121139.9n 1.14927 121140.0n 0.72924 121319.9n 0.72924 121320.0n 0.26400 121499.9n 0.26400 121500.0n 0.73581 121679.9n 0.73581 121680.0n 1.04662 121859.9n 1.04662 121860.0n 0.43551 122039.9n 0.43551 122040.0n 0.79881 122219.9n 0.79881 122220.0n 0.56419 122399.9n 0.56419 122400.0n 0.46859 122579.9n 0.46859 122580.0n 0.44934 122759.9n 0.44934 122760.0n 0.82918 122939.9n 0.82918 122940.0n 1.31038 123119.9n 1.31038 123120.0n 0.44994 123299.9n 0.44994 123300.0n 0.89441 123479.9n 0.89441 123480.0n 0.52444 123659.9n 0.52444 123660.0n 0.72357 123839.9n 0.72357 123840.0n 0.51492 124019.9n 0.51492 124020.0n 0.13970 124199.9n 0.13970 124200.0n -0.36668 124379.9n -0.36668 124380.0n 0.47921 124559.9n 0.47921 124560.0n 0.78502 124739.9n 0.78502 124740.0n 0.75921 124919.9n 0.75921 124920.0n -0.38855 125099.9n -0.38855 125100.0n 0.11168 125279.9n 0.11168 125280.0n -0.07007 125459.9n -0.07007 125460.0n -0.21890 125639.9n -0.21890 125640.0n 0.64370 125819.9n 0.64370 125820.0n 0.68861 125999.9n 0.68861 126000.0n 0.03541 126179.9n 0.03541 126180.0n 0.29315 126359.9n 0.29315 126360.0n 0.30031 126539.9n 0.30031 126540.0n 0.30498 126719.9n 0.30498 126720.0n 0.72924 126899.9n 0.72924 126900.0n 0.11168 127079.9n 0.11168 127080.0n 0.52444 127259.9n 0.52444 127260.0n 1.14927 127439.9n 1.14927 127440.0n -0.36668 127619.9n -0.36668 127620.0n 0.56419 127799.9n 0.56419 127800.0n -0.07007 127979.9n -0.07007 127980.0n -0.38855 128159.9n -0.38855 128160.0n 0.75921 128339.9n 0.75921 128340.0n 0.64370 128519.9n 0.64370 128520.0n 0.78502 128699.9n 0.78502 128700.0n 0.43551 128879.9n 0.43551 128880.0n 0.46859 129059.9n 0.46859 129060.0n 0.79881 129239.9n 0.79881 129240.0n 0.44994 129419.9n 0.44994 129420.0n 0.29315 129599.9n 0.29315 129600.0n 0.72357 129779.9n 0.72357 129780.0n 0.82918 129959.9n 0.82918 129960.0n 0.30498 130139.9n 0.30498 130140.0n 0.13970 130319.9n 0.13970 130320.0n 0.26400 130499.9n 0.26400 130500.0n -0.21890 130679.9n -0.21890 130680.0n 1.31038 130859.9n 1.31038 130860.0n 0.89441 131039.9n 0.89441 131040.0n 0.44934 131219.9n 0.44934 131220.0n 0.68861 131399.9n 0.68861 131400.0n 1.04662 131579.9n 1.04662 131580.0n 0.51492 131759.9n 0.51492 131760.0n 0.30031 131939.9n 0.30031 131940.0n 0.03541 132119.9n 0.03541 132120.0n 0.47921 132299.9n 0.47921 132300.0n 0.73581 132479.9n 0.73581 132480.0n -0.36668 132659.9n -0.36668 132660.0n 0.03541 132839.9n 0.03541 132840.0n 0.82918 133019.9n 0.82918 133020.0n 0.78502 133199.9n 0.78502 133200.0n 0.46859 133379.9n 0.46859 133380.0n 0.73581 133559.9n 0.73581 133560.0n 0.89441 133739.9n 0.89441 133740.0n 0.72357 133919.9n 0.72357 133920.0n -0.38855 134099.9n -0.38855 134100.0n 0.11168 134279.9n 0.11168 134280.0n 0.30498 134459.9n 0.30498 134460.0n 0.13970 134639.9n 0.13970 134640.0n 1.14927 134819.9n 1.14927 134820.0n 0.30031 134999.9n 0.30031 135000.0n 0.79881 135179.9n 0.79881 135180.0n 0.56419 135359.9n 0.56419 135360.0n 0.64370 135539.9n 0.64370 135540.0n 0.43551 135719.9n 0.43551 135720.0n 0.52444 135899.9n 0.52444 135900.0n 0.68861 136079.9n 0.68861 136080.0n -0.21890 136259.9n -0.21890 136260.0n 0.29315 136439.9n 0.29315 136440.0n 0.72924 136619.9n 0.72924 136620.0n 0.44994 136799.9n 0.44994 136800.0n 0.47921 136979.9n 0.47921 136980.0n 0.44934 137159.9n 0.44934 137160.0n 0.75921 137339.9n 0.75921 137340.0n 0.51492 137519.9n 0.51492 137520.0n -0.07007 137699.9n -0.07007 137700.0n 0.26400 137879.9n 0.26400 137880.0n 1.04662 138059.9n 1.04662 138060.0n 1.31038 138239.9n 1.31038 138240.0n 0.43551 138419.9n 0.43551 138420.0n 0.75921 138599.9n 0.75921 138600.0n 0.26400 138779.9n 0.26400 138780.0n 0.51492 138959.9n 0.51492 138960.0n 0.44934 139139.9n 0.44934 139140.0n 0.11168 139319.9n 0.11168 139320.0n 0.46859 139499.9n 0.46859 139500.0n 0.64370 139679.9n 0.64370 139680.0n 0.13970 139859.9n 0.13970 139860.0n 0.72924 140039.9n 0.72924 140040.0n 1.31038 140219.9n 1.31038 140220.0n 0.03541 140399.9n 0.03541 140400.0n 0.56419 140579.9n 0.56419 140580.0n 0.82918 140759.9n 0.82918 140760.0n 0.73581 140939.9n 0.73581 140940.0n 0.79881 141119.9n 0.79881 141120.0n 1.04662 141299.9n 1.04662 141300.0n 0.47921 141479.9n 0.47921 141480.0n 0.30498 141659.9n 0.30498 141660.0n 1.14927 141839.9n 1.14927 141840.0n -0.38855 142019.9n -0.38855 142020.0n 0.78502 142199.9n 0.78502 142200.0n 0.68861 142379.9n 0.68861 142380.0n 0.29315 142559.9n 0.29315 142560.0n -0.21890 142739.9n -0.21890 142740.0n -0.36668 142919.9n -0.36668 142920.0n -0.07007 143099.9n -0.07007 143100.0n 0.52444 143279.9n 0.52444 143280.0n 0.44994 143459.9n 0.44994 143460.0n 0.72357 143639.9n 0.72357 143640.0n 0.89441 143819.9n 0.89441 143820.0n 0.30031 143999.9n 0.30031 144000.0n -0.07007 144179.9n -0.07007 144180.0n 0.68861 144359.9n 0.68861 144360.0n 0.44994 144539.9n 0.44994 144540.0n -0.36668 144719.9n -0.36668 144720.0n 0.89441 144899.9n 0.89441 144900.0n 0.26400 145079.9n 0.26400 145080.0n 0.47921 145259.9n 0.47921 145260.0n 0.56419 145439.9n 0.56419 145440.0n 0.51492 145619.9n 0.51492 145620.0n 0.29315 145799.9n 0.29315 145800.0n 0.79881 145979.9n 0.79881 145980.0n -0.21890 146159.9n -0.21890 146160.0n 0.73581 146339.9n 0.73581 146340.0n 0.52444 146519.9n 0.52444 146520.0n 0.82918 146699.9n 0.82918 146700.0n 0.72357 146879.9n 0.72357 146880.0n 0.44934 147059.9n 0.44934 147060.0n 0.78502 147239.9n 0.78502 147240.0n -0.38855 147419.9n -0.38855 147420.0n 0.43551 147599.9n 0.43551 147600.0n 0.64370 147779.9n 0.64370 147780.0n 0.13970 147959.9n 0.13970 147960.0n 0.03541 148139.9n 0.03541 148140.0n 0.75921 148319.9n 0.75921 148320.0n 1.14927 148499.9n 1.14927 148500.0n 1.04662 148679.9n 1.04662 148680.0n 1.31038 148859.9n 1.31038 148860.0n 0.30031 149039.9n 0.30031 149040.0n 0.72924 149219.9n 0.72924 149220.0n 0.30498 149399.9n 0.30498 149400.0n 0.46859 149579.9n 0.46859 149580.0n 0.11168 149759.9n 0.11168 149760.0n 1.31038 149939.9n 1.31038 149940.0n 0.52444 150119.9n 0.52444 150120.0n 0.13970 150299.9n 0.13970 150300.0n 0.75921 150479.9n 0.75921 150480.0n 0.03541 150659.9n 0.03541 150660.0n 0.46859 150839.9n 0.46859 150840.0n 0.30498 151019.9n 0.30498 151020.0n 0.78502 151199.9n 0.78502 151200.0n 0.44994 151379.9n 0.44994 151380.0n 0.47921 151559.9n 0.47921 151560.0n 0.43551 151739.9n 0.43551 151740.0n -0.36668 151919.9n -0.36668 151920.0n 0.26400 152099.9n 0.26400 152100.0n -0.38855 152279.9n -0.38855 152280.0n 0.72357 152459.9n 0.72357 152460.0n 0.29315 152639.9n 0.29315 152640.0n 0.56419 152819.9n 0.56419 152820.0n 0.82918 152999.9n 0.82918 153000.0n -0.07007 153179.9n -0.07007 153180.0n 0.51492 153359.9n 0.51492 153360.0n 0.44934 153539.9n 0.44934 153540.0n 0.73581 153719.9n 0.73581 153720.0n 0.30031 153899.9n 0.30031 153900.0n -0.21890 154079.9n -0.21890 154080.0n 1.14927 154259.9n 1.14927 154260.0n 0.79881 154439.9n 0.79881 154440.0n 0.89441 154619.9n 0.89441 154620.0n 0.68861 154799.9n 0.68861 154800.0n 0.11168 154979.9n 0.11168 154980.0n 0.72924 155159.9n 0.72924 155160.0n 1.04662 155339.9n 1.04662 155340.0n 0.64370 155519.9n 0.64370 155520.0n -0.36668 155699.9n -0.36668 155700.0n 0.44994 155879.9n 0.44994 155880.0n 0.72924 156059.9n 0.72924 156060.0n 0.44934 156239.9n 0.44934 156240.0n 0.03541 156419.9n 0.03541 156420.0n 0.56419 156599.9n 0.56419 156600.0n 0.82918 156779.9n 0.82918 156780.0n 0.64370 156959.9n 0.64370 156960.0n 0.30498 157139.9n 0.30498 157140.0n 0.13970 157319.9n 0.13970 157320.0n -0.21890 157499.9n -0.21890 157500.0n 0.46859 157679.9n 0.46859 157680.0n -0.38855 157859.9n -0.38855 157860.0n 0.30031 158039.9n 0.30031 158040.0n 0.79881 158219.9n 0.79881 158220.0n 0.89441 158399.9n 0.89441 158400.0n 0.51492 158579.9n 0.51492 158580.0n 0.78502 158759.9n 0.78502 158760.0n 0.26400 158939.9n 0.26400 158940.0n 0.43551 159119.9n 0.43551 159120.0n 0.52444 159299.9n 0.52444 159300.0n 0.72357 159479.9n 0.72357 159480.0n 0.47921 159659.9n 0.47921 159660.0n 0.75921 159839.9n 0.75921 159840.0n 0.73581 160019.9n 0.73581 160020.0n 1.31038 160199.9n 1.31038 160200.0n 1.14927 160379.9n 1.14927 160380.0n 1.04662 160559.9n 1.04662 160560.0n -0.07007 160739.9n -0.07007 160740.0n 0.29315 160919.9n 0.29315 160920.0n 0.11168 161099.9n 0.11168 161100.0n 0.68861 161279.9n 0.68861 161280.0n 0.46859 161459.9n 0.46859 161460.0n 1.04662 161639.9n 1.04662 161640.0n 0.44934 161819.9n 0.44934 161820.0n 0.72357 161999.9n 0.72357 162000.0n 0.75921 162179.9n 0.75921 162180.0n -0.21890 162359.9n -0.21890 162360.0n 0.56419 162539.9n 0.56419 162540.0n 0.29315 162719.9n 0.29315 162720.0n 0.11168 162899.9n 0.11168 162900.0n -0.36668 163079.9n -0.36668 163080.0n 0.79881 163259.9n 0.79881 163260.0n 0.52444 163439.9n 0.52444 163440.0n 0.47921 163619.9n 0.47921 163620.0n -0.38855 163799.9n -0.38855 163800.0n 0.44994 163979.9n 0.44994 163980.0n 0.13970 164159.9n 0.13970 164160.0n 1.14927 164339.9n 1.14927 164340.0n 0.78502 164519.9n 0.78502 164520.0n 0.43551 164699.9n 0.43551 164700.0n 0.72924 164879.9n 0.72924 164880.0n 0.51492 165059.9n 0.51492 165060.0n 0.82918 165239.9n 0.82918 165240.0n 0.89441 165419.9n 0.89441 165420.0n 0.30498 165599.9n 0.30498 165600.0n 0.30031 165779.9n 0.30031 165780.0n -0.07007 165959.9n -0.07007 165960.0n 0.68861 166139.9n 0.68861 166140.0n 0.73581 166319.9n 0.73581 166320.0n 0.03541 166499.9n 0.03541 166500.0n 0.26400 166679.9n 0.26400 166680.0n 1.31038 166859.9n 1.31038 166860.0n 0.64370 167039.9n 0.64370 167040.0n 0.29315 167219.9n 0.29315 167220.0n 0.30498 167399.9n 0.30498 167400.0n -0.36668 167579.9n -0.36668 167580.0n 0.72357 167759.9n 0.72357 167760.0n 0.72924 167939.9n 0.72924 167940.0n 0.64370 168119.9n 0.64370 168120.0n 0.52444 168299.9n 0.52444 168300.0n 0.30031 168479.9n 0.30031 168480.0n 0.79881 168659.9n 0.79881 168660.0n 0.11168 168839.9n 0.11168 168840.0n 0.03541 169019.9n 0.03541 169020.0n 0.47921 169199.9n 0.47921 169200.0n 0.51492 169379.9n 0.51492 169380.0n 0.46859 169559.9n 0.46859 169560.0n 0.68861 169739.9n 0.68861 169740.0n 0.73581 169919.9n 0.73581 169920.0n 1.04662 170099.9n 1.04662 170100.0n 0.89441 170279.9n 0.89441 170280.0n 1.31038 170459.9n 1.31038 170460.0n 0.44994 170639.9n 0.44994 170640.0n 0.26400 170819.9n 0.26400 170820.0n 0.44934 170999.9n 0.44934 171000.0n -0.38855 171179.9n -0.38855 171180.0n 0.43551 171359.9n 0.43551 171360.0n -0.21890 171539.9n -0.21890 171540.0n 0.13970 171719.9n 0.13970 171720.0n 0.78502 171899.9n 0.78502 171900.0n -0.07007 172079.9n -0.07007 172080.0n 1.14927 172259.9n 1.14927 172260.0n 0.82918 172439.9n 0.82918 172440.0n 0.56419 172619.9n 0.56419 172620.0n 0.75921 172799.9n 0.75921 172800.0n 0.42258 172979.9n 0.42258 172980.0n 0.20713 173159.9n 0.20713 173160.0n 0.39910 173339.9n 0.39910 173340.0n 0.76629 173519.9n 0.76629 173520.0n 0.87516 173699.9n 0.87516 173700.0n 0.51649 173879.9n 0.51649 173880.0n 0.47728 174059.9n 0.47728 174060.0n 0.89579 174239.9n 0.89579 174240.0n 0.73813 174419.9n 0.73813 174420.0n 0.73007 174599.9n 0.73007 174600.0n 0.38805 174779.9n 0.38805 174780.0n 0.44565 174959.9n 0.44565 174960.0n 0.84972 175139.9n 0.84972 175140.0n 0.31374 175319.9n 0.31374 175320.0n 0.53500 175499.9n 0.53500 175500.0n 0.65381 175679.9n 0.65381 175680.0n 0.58828 175859.9n 0.58828 175860.0n 0.29293 176039.9n 0.29293 176040.0n 0.34864 176219.9n 0.34864 176220.0n 0.39919 176399.9n 0.39919 176400.0n 0.28504 176579.9n 0.28504 176580.0n 0.90918 176759.9n 0.90918 176760.0n 0.50331 176939.9n 0.50331 176940.0n 0.28807 177119.9n 0.28807 177120.0n 0.23424 177299.9n 0.23424 177300.0n 0.53888 177479.9n 0.53888 177480.0n 0.48728 177659.9n 0.48728 177660.0n 0.50852 177839.9n 0.50852 177840.0n 0.58450 178019.9n 0.58450 178020.0n 0.36568 178199.9n 0.36568 178200.0n -0.28851 178379.9n -0.28851 178380.0n -0.24585 178559.9n -0.24585 178560.0n 1.15208 178739.9n 1.15208 178740.0n 0.41841 178919.9n 0.41841 178920.0n 0.24338 179099.9n 0.24338 179100.0n 1.49277 179279.9n 1.49277 179280.0n 1.19260 179459.9n 1.19260 179460.0n -0.27962 179639.9n -0.27962 179640.0n 0.55733 179819.9n 0.55733 179820.0n 0.95600 179999.9n 0.95600 180000.0n -0.04710 180179.9n -0.04710 180180.0n 0.80242 180359.9n 0.80242 180360.0n 0.39736 180539.9n 0.39736 180540.0n 1.04029 180719.9n 1.04029 180720.0n 0.63149 180899.9n 0.63149 180900.0n 0.81752 181079.9n 0.81752 181080.0n 1.19808 181259.9n 1.19808 181260.0n 1.39872 181439.9n 1.39872 181440.0n 0.28119 181619.9n 0.28119 181620.0n 1.46004 181799.9n 1.46004 181800.0n -0.19303 181979.9n -0.19303 181980.0n 0.93542 182159.9n 0.93542 182160.0n 1.06311 182339.9n 1.06311 182340.0n 1.11193 182519.9n 1.11193 182520.0n 1.17413 182699.9n 1.17413 182700.0n 1.01300 182879.9n 1.01300 182880.0n 1.13586 183059.9n 1.13586 183060.0n 1.03731 183239.9n 1.03731 183240.0n 0.46939 183419.9n 0.46939 183420.0n 0.57188)
Vxp1 a_xp1 0 PWL(0.0n 0.63482 179.9n 0.63482 180.0n 0.34013 359.9n 0.34013 360.0n 0.67130 539.9n 0.67130 540.0n 0.28189 719.9n 0.28189 720.0n 1.20712 899.9n 1.20712 900.0n 1.27694 1079.9n 1.27694 1080.0n 1.23180 1259.9n 1.23180 1260.0n 0.48458 1439.9n 0.48458 1440.0n -0.08309 1619.9n -0.08309 1620.0n 0.59247 1799.9n 0.59247 1800.0n 1.18224 1979.9n 1.18224 1980.0n 1.11225 2159.9n 1.11225 2160.0n 0.40313 2339.9n 0.40313 2340.0n 0.65842 2519.9n 0.65842 2520.0n 0.70122 2699.9n 0.70122 2700.0n -0.33158 2879.9n -0.33158 2880.0n 0.29915 3059.9n 0.29915 3060.0n 0.28700 3239.9n 0.28700 3240.0n 0.42554 3419.9n 0.42554 3420.0n -0.37792 3599.9n -0.37792 3600.0n -0.23386 3779.9n -0.23386 3780.0n 0.76415 3959.9n 0.76415 3960.0n -0.21828 4139.9n -0.21828 4140.0n 0.25911 4319.9n 0.25911 4320.0n 1.28574 4499.9n 1.28574 4500.0n 0.56595 4679.9n 0.56595 4680.0n 0.33171 4859.9n 0.33171 4860.0n 0.13226 5039.9n 0.13226 5040.0n 0.23835 5219.9n 0.23835 5220.0n 1.17517 5399.9n 1.17517 5400.0n 0.66096 5579.9n 0.66096 5580.0n -0.15161 5759.9n -0.15161 5760.0n 1.28574 5939.9n 1.28574 5940.0n -0.08309 6119.9n -0.08309 6120.0n 0.59247 6299.9n 0.59247 6300.0n 0.23835 6479.9n 0.23835 6480.0n 0.42554 6659.9n 0.42554 6660.0n 0.13226 6839.9n 0.13226 6840.0n 1.17517 7019.9n 1.17517 7020.0n -0.37792 7199.9n -0.37792 7200.0n 0.70122 7379.9n 0.70122 7380.0n 1.18224 7559.9n 1.18224 7560.0n 0.34013 7739.9n 0.34013 7740.0n 0.40313 7919.9n 0.40313 7920.0n 0.66096 8099.9n 0.66096 8100.0n 0.28189 8279.9n 0.28189 8280.0n 1.20712 8459.9n 1.20712 8460.0n 0.65842 8639.9n 0.65842 8640.0n 1.23180 8819.9n 1.23180 8820.0n 0.28700 8999.9n 0.28700 9000.0n 0.56595 9179.9n 0.56595 9180.0n 0.67130 9359.9n 0.67130 9360.0n 1.11225 9539.9n 1.11225 9540.0n 0.33171 9719.9n 0.33171 9720.0n 0.63482 9899.9n 0.63482 9900.0n 0.25911 10079.9n 0.25911 10080.0n -0.21828 10259.9n -0.21828 10260.0n 1.27694 10439.9n 1.27694 10440.0n -0.33158 10619.9n -0.33158 10620.0n 0.48458 10799.9n 0.48458 10800.0n 0.29915 10979.9n 0.29915 10980.0n -0.23386 11159.9n -0.23386 11160.0n 0.76415 11339.9n 0.76415 11340.0n -0.15161 11519.9n -0.15161 11520.0n 1.28574 11699.9n 1.28574 11700.0n 1.17517 11879.9n 1.17517 11880.0n -0.33158 12059.9n -0.33158 12060.0n 0.56595 12239.9n 0.56595 12240.0n 0.34013 12419.9n 0.34013 12420.0n -0.15161 12599.9n -0.15161 12600.0n 1.23180 12779.9n 1.23180 12780.0n 0.42554 12959.9n 0.42554 12960.0n 0.40313 13139.9n 0.40313 13140.0n 0.76415 13319.9n 0.76415 13320.0n -0.08309 13499.9n -0.08309 13500.0n -0.21828 13679.9n -0.21828 13680.0n 0.13226 13859.9n 0.13226 13860.0n 0.70122 14039.9n 0.70122 14040.0n -0.23386 14219.9n -0.23386 14220.0n 0.67130 14399.9n 0.67130 14400.0n -0.37792 14579.9n -0.37792 14580.0n 0.29915 14759.9n 0.29915 14760.0n 0.65842 14939.9n 0.65842 14940.0n 0.25911 15119.9n 0.25911 15120.0n 0.33171 15299.9n 0.33171 15300.0n 1.20712 15479.9n 1.20712 15480.0n 1.11225 15659.9n 1.11225 15660.0n 1.27694 15839.9n 1.27694 15840.0n 0.28189 16019.9n 0.28189 16020.0n 0.48458 16199.9n 0.48458 16200.0n 0.59247 16379.9n 0.59247 16380.0n 0.66096 16559.9n 0.66096 16560.0n 0.23835 16739.9n 0.23835 16740.0n 1.18224 16919.9n 1.18224 16920.0n 0.28700 17099.9n 0.28700 17100.0n 0.63482 17279.9n 0.63482 17280.0n 1.17517 17459.9n 1.17517 17460.0n 0.40313 17639.9n 0.40313 17640.0n 0.23835 17819.9n 0.23835 17820.0n 0.67130 17999.9n 0.67130 18000.0n 1.28574 18179.9n 1.28574 18180.0n 1.20712 18359.9n 1.20712 18360.0n 0.76415 18539.9n 0.76415 18540.0n 0.28700 18719.9n 0.28700 18720.0n 1.27694 18899.9n 1.27694 18900.0n 0.28189 19079.9n 0.28189 19080.0n 1.23180 19259.9n 1.23180 19260.0n 0.65842 19439.9n 0.65842 19440.0n 0.34013 19619.9n 0.34013 19620.0n 0.25911 19799.9n 0.25911 19800.0n 0.42554 19979.9n 0.42554 19980.0n -0.08309 20159.9n -0.08309 20160.0n 0.56595 20339.9n 0.56595 20340.0n 0.33171 20519.9n 0.33171 20520.0n 1.18224 20699.9n 1.18224 20700.0n -0.21828 20879.9n -0.21828 20880.0n -0.33158 21059.9n -0.33158 21060.0n 0.48458 21239.9n 0.48458 21240.0n 0.70122 21419.9n 0.70122 21420.0n -0.37792 21599.9n -0.37792 21600.0n -0.23386 21779.9n -0.23386 21780.0n 0.66096 21959.9n 0.66096 21960.0n 1.11225 22139.9n 1.11225 22140.0n 0.63482 22319.9n 0.63482 22320.0n 0.29915 22499.9n 0.29915 22500.0n 0.13226 22679.9n 0.13226 22680.0n -0.15161 22859.9n -0.15161 22860.0n 0.59247 23039.9n 0.59247 23040.0n -0.21828 23219.9n -0.21828 23220.0n 0.63482 23399.9n 0.63482 23400.0n 0.25911 23579.9n 0.25911 23580.0n -0.23386 23759.9n -0.23386 23760.0n 0.28189 23939.9n 0.28189 23940.0n 0.28700 24119.9n 0.28700 24120.0n 1.20712 24299.9n 1.20712 24300.0n 0.76415 24479.9n 0.76415 24480.0n 0.33171 24659.9n 0.33171 24660.0n 0.48458 24839.9n 0.48458 24840.0n 0.65842 25019.9n 0.65842 25020.0n 0.70122 25199.9n 0.70122 25200.0n 0.42554 25379.9n 0.42554 25380.0n 1.27694 25559.9n 1.27694 25560.0n -0.08309 25739.9n -0.08309 25740.0n 0.67130 25919.9n 0.67130 25920.0n 1.18224 26099.9n 1.18224 26100.0n 0.56595 26279.9n 0.56595 26280.0n 0.34013 26459.9n 0.34013 26460.0n -0.37792 26639.9n -0.37792 26640.0n 1.11225 26819.9n 1.11225 26820.0n 0.29915 26999.9n 0.29915 27000.0n 0.40313 27179.9n 0.40313 27180.0n 1.28574 27359.9n 1.28574 27360.0n 0.13226 27539.9n 0.13226 27540.0n 0.59247 27719.9n 0.59247 27720.0n 1.17517 27899.9n 1.17517 27900.0n 1.23180 28079.9n 1.23180 28080.0n 0.66096 28259.9n 0.66096 28260.0n -0.15161 28439.9n -0.15161 28440.0n 0.23835 28619.9n 0.23835 28620.0n -0.33158 28799.9n -0.33158 28800.0n 0.67130 28979.9n 0.67130 28980.0n 0.40313 29159.9n 0.40313 29160.0n 0.66096 29339.9n 0.66096 29340.0n -0.23386 29519.9n -0.23386 29520.0n 0.29915 29699.9n 0.29915 29700.0n 0.25911 29879.9n 0.25911 29880.0n 0.42554 30059.9n 0.42554 30060.0n 1.20712 30239.9n 1.20712 30240.0n 0.33171 30419.9n 0.33171 30420.0n 0.28189 30599.9n 0.28189 30600.0n 0.65842 30779.9n 0.65842 30780.0n 0.76415 30959.9n 0.76415 30960.0n 1.28574 31139.9n 1.28574 31140.0n 1.27694 31319.9n 1.27694 31320.0n 0.13226 31499.9n 0.13226 31500.0n 0.23835 31679.9n 0.23835 31680.0n 0.56595 31859.9n 0.56595 31860.0n 0.48458 32039.9n 0.48458 32040.0n -0.08309 32219.9n -0.08309 32220.0n 1.18224 32399.9n 1.18224 32400.0n 1.23180 32579.9n 1.23180 32580.0n 0.70122 32759.9n 0.70122 32760.0n 0.63482 32939.9n 0.63482 32940.0n 0.34013 33119.9n 0.34013 33120.0n -0.21828 33299.9n -0.21828 33300.0n 0.28700 33479.9n 0.28700 33480.0n -0.37792 33659.9n -0.37792 33660.0n 1.17517 33839.9n 1.17517 33840.0n 1.11225 34019.9n 1.11225 34020.0n 0.59247 34199.9n 0.59247 34200.0n -0.33158 34379.9n -0.33158 34380.0n -0.15161 34559.9n -0.15161 34560.0n 1.20712 34739.9n 1.20712 34740.0n 0.70122 34919.9n 0.70122 34920.0n 0.48458 35099.9n 0.48458 35100.0n 0.40313 35279.9n 0.40313 35280.0n -0.15161 35459.9n -0.15161 35460.0n 0.34013 35639.9n 0.34013 35640.0n -0.37792 35819.9n -0.37792 35820.0n 1.27694 35999.9n 1.27694 36000.0n 1.18224 36179.9n 1.18224 36180.0n 0.28189 36359.9n 0.28189 36360.0n 0.29915 36539.9n 0.29915 36540.0n 0.63482 36719.9n 0.63482 36720.0n -0.23386 36899.9n -0.23386 36900.0n -0.33158 37079.9n -0.33158 37080.0n 0.76415 37259.9n 0.76415 37260.0n 1.17517 37439.9n 1.17517 37440.0n 0.23835 37619.9n 0.23835 37620.0n -0.08309 37799.9n -0.08309 37800.0n 0.28700 37979.9n 0.28700 37980.0n 0.67130 38159.9n 0.67130 38160.0n 0.33171 38339.9n 0.33171 38340.0n 0.65842 38519.9n 0.65842 38520.0n 0.25911 38699.9n 0.25911 38700.0n 0.42554 38879.9n 0.42554 38880.0n 0.66096 39059.9n 0.66096 39060.0n 1.11225 39239.9n 1.11225 39240.0n 1.23180 39419.9n 1.23180 39420.0n 1.28574 39599.9n 1.28574 39600.0n 0.13226 39779.9n 0.13226 39780.0n 0.56595 39959.9n 0.56595 39960.0n 0.59247 40139.9n 0.59247 40140.0n -0.21828 40319.9n -0.21828 40320.0n 0.48458 40499.9n 0.48458 40500.0n 0.33171 40679.9n 0.33171 40680.0n 1.11225 40859.9n 1.11225 40860.0n 0.28700 41039.9n 0.28700 41040.0n 1.28574 41219.9n 1.28574 41220.0n 1.23180 41399.9n 1.23180 41400.0n 0.34013 41579.9n 0.34013 41580.0n 0.76415 41759.9n 0.76415 41760.0n 0.70122 41939.9n 0.70122 41940.0n 0.23835 42119.9n 0.23835 42120.0n 0.66096 42299.9n 0.66096 42300.0n 0.56595 42479.9n 0.56595 42480.0n 0.28189 42659.9n 0.28189 42660.0n 0.25911 42839.9n 0.25911 42840.0n 1.17517 43019.9n 1.17517 43020.0n 0.40313 43199.9n 0.40313 43200.0n 0.59247 43379.9n 0.59247 43380.0n 1.27694 43559.9n 1.27694 43560.0n -0.15161 43739.9n -0.15161 43740.0n 1.20712 43919.9n 1.20712 43920.0n 0.63482 44099.9n 0.63482 44100.0n 0.67130 44279.9n 0.67130 44280.0n -0.37792 44459.9n -0.37792 44460.0n 0.65842 44639.9n 0.65842 44640.0n 0.13226 44819.9n 0.13226 44820.0n 0.42554 44999.9n 0.42554 45000.0n -0.23386 45179.9n -0.23386 45180.0n 0.29915 45359.9n 0.29915 45360.0n -0.08309 45539.9n -0.08309 45540.0n -0.21828 45719.9n -0.21828 45720.0n 1.18224 45899.9n 1.18224 45900.0n -0.33158 46079.9n -0.33158 46080.0n 0.25911 46259.9n 0.25911 46260.0n 0.76415 46439.9n 0.76415 46440.0n 1.28574 46619.9n 1.28574 46620.0n 1.11225 46799.9n 1.11225 46800.0n -0.15161 46979.9n -0.15161 46980.0n 0.33171 47159.9n 0.33171 47160.0n 0.65842 47339.9n 0.65842 47340.0n 1.20712 47519.9n 1.20712 47520.0n -0.08309 47699.9n -0.08309 47700.0n -0.37792 47879.9n -0.37792 47880.0n 0.42554 48059.9n 0.42554 48060.0n 1.23180 48239.9n 1.23180 48240.0n 0.70122 48419.9n 0.70122 48420.0n 0.28189 48599.9n 0.28189 48600.0n 0.40313 48779.9n 0.40313 48780.0n 0.48458 48959.9n 0.48458 48960.0n 1.18224 49139.9n 1.18224 49140.0n 0.29915 49319.9n 0.29915 49320.0n 0.67130 49499.9n 0.67130 49500.0n 1.17517 49679.9n 1.17517 49680.0n 0.34013 49859.9n 0.34013 49860.0n 0.28700 50039.9n 0.28700 50040.0n 1.27694 50219.9n 1.27694 50220.0n -0.21828 50399.9n -0.21828 50400.0n 0.66096 50579.9n 0.66096 50580.0n 0.13226 50759.9n 0.13226 50760.0n 0.23835 50939.9n 0.23835 50940.0n 0.63482 51119.9n 0.63482 51120.0n 0.59247 51299.9n 0.59247 51300.0n 0.56595 51479.9n 0.56595 51480.0n -0.23386 51659.9n -0.23386 51660.0n -0.33158 51839.9n -0.33158 51840.0n 0.34013 52019.9n 0.34013 52020.0n 0.40313 52199.9n 0.40313 52200.0n 0.33171 52379.9n 0.33171 52380.0n -0.08309 52559.9n -0.08309 52560.0n 0.23835 52739.9n 0.23835 52740.0n 0.59247 52919.9n 0.59247 52920.0n -0.37792 53099.9n -0.37792 53100.0n 0.65842 53279.9n 0.65842 53280.0n 0.29915 53459.9n 0.29915 53460.0n 0.56595 53639.9n 0.56595 53640.0n 0.28189 53819.9n 0.28189 53820.0n 1.17517 53999.9n 1.17517 54000.0n -0.23386 54179.9n -0.23386 54180.0n -0.33158 54359.9n -0.33158 54360.0n -0.21828 54539.9n -0.21828 54540.0n 0.66096 54719.9n 0.66096 54720.0n 1.18224 54899.9n 1.18224 54900.0n -0.15161 55079.9n -0.15161 55080.0n 1.28574 55259.9n 1.28574 55260.0n 0.28700 55439.9n 0.28700 55440.0n 0.42554 55619.9n 0.42554 55620.0n 0.63482 55799.9n 0.63482 55800.0n 0.70122 55979.9n 0.70122 55980.0n 0.67130 56159.9n 0.67130 56160.0n 0.25911 56339.9n 0.25911 56340.0n 0.13226 56519.9n 0.13226 56520.0n 1.20712 56699.9n 1.20712 56700.0n 1.23180 56879.9n 1.23180 56880.0n 1.11225 57059.9n 1.11225 57060.0n 0.76415 57239.9n 0.76415 57240.0n 1.27694 57419.9n 1.27694 57420.0n 0.48458 57599.9n 0.48458 57600.0n -0.21828 57779.9n -0.21828 57780.0n -0.08309 57959.9n -0.08309 57960.0n 0.29915 58139.9n 0.29915 58140.0n 0.65842 58319.9n 0.65842 58320.0n 1.20712 58499.9n 1.20712 58500.0n 0.67130 58679.9n 0.67130 58680.0n 0.42554 58859.9n 0.42554 58860.0n -0.23386 59039.9n -0.23386 59040.0n -0.33158 59219.9n -0.33158 59220.0n 1.27694 59399.9n 1.27694 59400.0n 1.17517 59579.9n 1.17517 59580.0n 0.28700 59759.9n 0.28700 59760.0n -0.15161 59939.9n -0.15161 59940.0n 0.33171 60119.9n 0.33171 60120.0n -0.37792 60299.9n -0.37792 60300.0n 0.63482 60479.9n 0.63482 60480.0n 0.34013 60659.9n 0.34013 60660.0n 0.48458 60839.9n 0.48458 60840.0n 0.66096 61019.9n 0.66096 61020.0n 0.40313 61199.9n 0.40313 61200.0n 0.25911 61379.9n 0.25911 61380.0n 0.70122 61559.9n 0.70122 61560.0n 1.28574 61739.9n 1.28574 61740.0n 0.13226 61919.9n 0.13226 61920.0n 1.11225 62099.9n 1.11225 62100.0n 0.59247 62279.9n 0.59247 62280.0n 0.23835 62459.9n 0.23835 62460.0n 0.76415 62639.9n 0.76415 62640.0n 0.28189 62819.9n 0.28189 62820.0n 1.23180 62999.9n 1.23180 63000.0n 1.18224 63179.9n 1.18224 63180.0n 0.56595 63359.9n 0.56595 63360.0n 0.28189 63539.9n 0.28189 63540.0n 0.33171 63719.9n 0.33171 63720.0n 1.27694 63899.9n 1.27694 63900.0n 0.63482 64079.9n 0.63482 64080.0n 0.34013 64259.9n 0.34013 64260.0n -0.15161 64439.9n -0.15161 64440.0n 0.65842 64619.9n 0.65842 64620.0n -0.37792 64799.9n -0.37792 64800.0n 0.56595 64979.9n 0.56595 64980.0n 1.23180 65159.9n 1.23180 65160.0n -0.21828 65339.9n -0.21828 65340.0n 1.20712 65519.9n 1.20712 65520.0n 0.59247 65699.9n 0.59247 65700.0n 0.48458 65879.9n 0.48458 65880.0n 1.28574 66059.9n 1.28574 66060.0n -0.33158 66239.9n -0.33158 66240.0n 0.40313 66419.9n 0.40313 66420.0n 0.29915 66599.9n 0.29915 66600.0n 0.42554 66779.9n 0.42554 66780.0n 0.23835 66959.9n 0.23835 66960.0n 1.11225 67139.9n 1.11225 67140.0n -0.08309 67319.9n -0.08309 67320.0n -0.23386 67499.9n -0.23386 67500.0n 0.25911 67679.9n 0.25911 67680.0n 0.76415 67859.9n 0.76415 67860.0n 1.17517 68039.9n 1.17517 68040.0n 0.66096 68219.9n 0.66096 68220.0n 0.13226 68399.9n 0.13226 68400.0n 0.70122 68579.9n 0.70122 68580.0n 0.28700 68759.9n 0.28700 68760.0n 1.18224 68939.9n 1.18224 68940.0n 0.67130 69119.9n 0.67130 69120.0n -0.23386 69299.9n -0.23386 69300.0n 0.42554 69479.9n 0.42554 69480.0n 0.63482 69659.9n 0.63482 69660.0n 0.40313 69839.9n 0.40313 69840.0n 0.25911 70019.9n 0.25911 70020.0n 1.17517 70199.9n 1.17517 70200.0n 1.11225 70379.9n 1.11225 70380.0n 1.27694 70559.9n 1.27694 70560.0n 1.18224 70739.9n 1.18224 70740.0n -0.08309 70919.9n -0.08309 70920.0n 0.66096 71099.9n 0.66096 71100.0n 0.48458 71279.9n 0.48458 71280.0n 0.28189 71459.9n 0.28189 71460.0n 0.23835 71639.9n 0.23835 71640.0n 0.59247 71819.9n 0.59247 71820.0n -0.37792 71999.9n -0.37792 72000.0n 0.28700 72179.9n 0.28700 72180.0n 0.70122 72359.9n 0.70122 72360.0n 0.56595 72539.9n 0.56595 72540.0n 1.28574 72719.9n 1.28574 72720.0n -0.33158 72899.9n -0.33158 72900.0n 0.65842 73079.9n 0.65842 73080.0n 0.33171 73259.9n 0.33171 73260.0n 0.13226 73439.9n 0.13226 73440.0n -0.15161 73619.9n -0.15161 73620.0n 0.76415 73799.9n 0.76415 73800.0n 0.29915 73979.9n 0.29915 73980.0n -0.21828 74159.9n -0.21828 74160.0n 1.23180 74339.9n 1.23180 74340.0n 0.34013 74519.9n 0.34013 74520.0n 0.67130 74699.9n 0.67130 74700.0n 1.20712 74879.9n 1.20712 74880.0n -0.37792 75059.9n -0.37792 75060.0n 0.70122 75239.9n 0.70122 75240.0n 0.67130 75419.9n 0.67130 75420.0n 0.66096 75599.9n 0.66096 75600.0n 0.76415 75779.9n 0.76415 75780.0n 0.65842 75959.9n 0.65842 75960.0n 0.42554 76139.9n 0.42554 76140.0n 0.28189 76319.9n 0.28189 76320.0n 0.28700 76499.9n 0.28700 76500.0n 1.23180 76679.9n 1.23180 76680.0n 0.33171 76859.9n 0.33171 76860.0n 0.40313 77039.9n 0.40313 77040.0n 0.25911 77219.9n 0.25911 77220.0n 1.20712 77399.9n 1.20712 77400.0n 1.27694 77579.9n 1.27694 77580.0n 0.56595 77759.9n 0.56595 77760.0n -0.33158 77939.9n -0.33158 77940.0n 1.11225 78119.9n 1.11225 78120.0n 0.59247 78299.9n 0.59247 78300.0n 0.23835 78479.9n 0.23835 78480.0n -0.15161 78659.9n -0.15161 78660.0n 1.18224 78839.9n 1.18224 78840.0n 1.17517 79019.9n 1.17517 79020.0n 0.63482 79199.9n 0.63482 79200.0n 0.13226 79379.9n 0.13226 79380.0n -0.23386 79559.9n -0.23386 79560.0n 0.34013 79739.9n 0.34013 79740.0n 0.29915 79919.9n 0.29915 79920.0n -0.21828 80099.9n -0.21828 80100.0n 1.28574 80279.9n 1.28574 80280.0n -0.08309 80459.9n -0.08309 80460.0n 0.48458 80639.9n 0.48458 80640.0n 0.13226 80819.9n 0.13226 80820.0n -0.08309 80999.9n -0.08309 81000.0n -0.23386 81179.9n -0.23386 81180.0n 0.76415 81359.9n 0.76415 81360.0n 0.63482 81539.9n 0.63482 81540.0n 0.25911 81719.9n 0.25911 81720.0n -0.37792 81899.9n -0.37792 81900.0n 0.59247 82079.9n 0.59247 82080.0n 0.34013 82259.9n 0.34013 82260.0n 0.42554 82439.9n 0.42554 82440.0n 0.28189 82619.9n 0.28189 82620.0n 0.23835 82799.9n 0.23835 82800.0n 0.40313 82979.9n 0.40313 82980.0n 1.20712 83159.9n 1.20712 83160.0n 1.27694 83339.9n 1.27694 83340.0n 1.18224 83519.9n 1.18224 83520.0n 0.56595 83699.9n 0.56595 83700.0n 0.67130 83879.9n 0.67130 83880.0n -0.33158 84059.9n -0.33158 84060.0n 1.23180 84239.9n 1.23180 84240.0n 0.29915 84419.9n 0.29915 84420.0n 0.28700 84599.9n 0.28700 84600.0n 1.28574 84779.9n 1.28574 84780.0n 0.33171 84959.9n 0.33171 84960.0n 0.70122 85139.9n 0.70122 85140.0n 0.65842 85319.9n 0.65842 85320.0n 0.66096 85499.9n 0.66096 85500.0n -0.15161 85679.9n -0.15161 85680.0n 1.11225 85859.9n 1.11225 85860.0n -0.21828 86039.9n -0.21828 86040.0n 0.48458 86219.9n 0.48458 86220.0n 1.17517 86399.9n 1.17517 86400.0n 1.27694 86579.9n 1.27694 86580.0n 0.59247 86759.9n 0.59247 86760.0n 1.23180 86939.9n 1.23180 86940.0n 0.70122 87119.9n 0.70122 87120.0n 1.18224 87299.9n 1.18224 87300.0n 0.13226 87479.9n 0.13226 87480.0n -0.21828 87659.9n -0.21828 87660.0n -0.15161 87839.9n -0.15161 87840.0n 0.66096 88019.9n 0.66096 88020.0n 1.17517 88199.9n 1.17517 88200.0n 0.29915 88379.9n 0.29915 88380.0n 0.33171 88559.9n 0.33171 88560.0n 0.63482 88739.9n 0.63482 88740.0n 0.48458 88919.9n 0.48458 88920.0n -0.23386 89099.9n -0.23386 89100.0n 0.42554 89279.9n 0.42554 89280.0n 0.40313 89459.9n 0.40313 89460.0n 1.11225 89639.9n 1.11225 89640.0n -0.08309 89819.9n -0.08309 89820.0n 0.56595 89999.9n 0.56595 90000.0n 0.65842 90179.9n 0.65842 90180.0n 0.25911 90359.9n 0.25911 90360.0n 0.67130 90539.9n 0.67130 90540.0n -0.37792 90719.9n -0.37792 90720.0n 0.23835 90899.9n 0.23835 90900.0n 0.76415 91079.9n 0.76415 91080.0n 1.20712 91259.9n 1.20712 91260.0n 0.28700 91439.9n 0.28700 91440.0n 1.28574 91619.9n 1.28574 91620.0n 0.34013 91799.9n 0.34013 91800.0n -0.33158 91979.9n -0.33158 91980.0n 0.28189 92159.9n 0.28189 92160.0n -0.33158 92339.9n -0.33158 92340.0n 0.29915 92519.9n 0.29915 92520.0n 0.25911 92699.9n 0.25911 92700.0n 0.33171 92879.9n 0.33171 92880.0n 1.28574 93059.9n 1.28574 93060.0n 1.11225 93239.9n 1.11225 93240.0n 1.27694 93419.9n 1.27694 93420.0n 0.48458 93599.9n 0.48458 93600.0n 0.66096 93779.9n 0.66096 93780.0n -0.08309 93959.9n -0.08309 93960.0n 1.17517 94139.9n 1.17517 94140.0n 0.23835 94319.9n 0.23835 94320.0n -0.15161 94499.9n -0.15161 94500.0n 0.76415 94679.9n 0.76415 94680.0n 0.56595 94859.9n 0.56595 94860.0n 0.34013 95039.9n 0.34013 95040.0n 0.42554 95219.9n 0.42554 95220.0n 0.65842 95399.9n 0.65842 95400.0n 0.63482 95579.9n 0.63482 95580.0n -0.21828 95759.9n -0.21828 95760.0n -0.23386 95939.9n -0.23386 95940.0n 1.23180 96119.9n 1.23180 96120.0n 0.67130 96299.9n 0.67130 96300.0n 0.40313 96479.9n 0.40313 96480.0n 0.70122 96659.9n 0.70122 96660.0n 1.20712 96839.9n 1.20712 96840.0n 0.13226 97019.9n 0.13226 97020.0n 0.59247 97199.9n 0.59247 97200.0n 0.28189 97379.9n 0.28189 97380.0n -0.37792 97559.9n -0.37792 97560.0n 0.28700 97739.9n 0.28700 97740.0n 1.18224 97919.9n 1.18224 97920.0n 0.59247 98099.9n 0.59247 98100.0n -0.33158 98279.9n -0.33158 98280.0n 1.11225 98459.9n 1.11225 98460.0n -0.37792 98639.9n -0.37792 98640.0n -0.23386 98819.9n -0.23386 98820.0n -0.21828 98999.9n -0.21828 99000.0n 1.28574 99179.9n 1.28574 99180.0n 1.17517 99359.9n 1.17517 99360.0n -0.15161 99539.9n -0.15161 99540.0n 0.70122 99719.9n 0.70122 99720.0n 0.23835 99899.9n 0.23835 99900.0n 1.20712 100079.9n 1.20712 100080.0n 0.29915 100259.9n 0.29915 100260.0n 0.28189 100439.9n 0.28189 100440.0n 0.13226 100619.9n 0.13226 100620.0n 1.23180 100799.9n 1.23180 100800.0n 0.25911 100979.9n 0.25911 100980.0n 0.67130 101159.9n 0.67130 101160.0n 0.33171 101339.9n 0.33171 101340.0n 1.18224 101519.9n 1.18224 101520.0n 1.27694 101699.9n 1.27694 101700.0n 0.34013 101879.9n 0.34013 101880.0n 0.63482 102059.9n 0.63482 102060.0n 0.76415 102239.9n 0.76415 102240.0n -0.08309 102419.9n -0.08309 102420.0n 0.40313 102599.9n 0.40313 102600.0n 0.48458 102779.9n 0.48458 102780.0n 0.56595 102959.9n 0.56595 102960.0n 0.28700 103139.9n 0.28700 103140.0n 0.42554 103319.9n 0.42554 103320.0n 0.66096 103499.9n 0.66096 103500.0n 0.65842 103679.9n 0.65842 103680.0n 1.27694 103859.9n 1.27694 103860.0n -0.37792 104039.9n -0.37792 104040.0n -0.21828 104219.9n -0.21828 104220.0n 0.28700 104399.9n 0.28700 104400.0n 0.33171 104579.9n 0.33171 104580.0n 0.63482 104759.9n 0.63482 104760.0n 0.28189 104939.9n 0.28189 104940.0n 0.25911 105119.9n 0.25911 105120.0n 1.20712 105299.9n 1.20712 105300.0n 1.18224 105479.9n 1.18224 105480.0n 0.56595 105659.9n 0.56595 105660.0n 1.11225 105839.9n 1.11225 105840.0n 0.65842 106019.9n 0.65842 106020.0n -0.33158 106199.9n -0.33158 106200.0n 0.23835 106379.9n 0.23835 106380.0n 0.59247 106559.9n 0.59247 106560.0n -0.08309 106739.9n -0.08309 106740.0n 0.67130 106919.9n 0.67130 106920.0n 0.48458 107099.9n 0.48458 107100.0n 1.23180 107279.9n 1.23180 107280.0n 0.66096 107459.9n 0.66096 107460.0n 0.29915 107639.9n 0.29915 107640.0n 0.70122 107819.9n 0.70122 107820.0n -0.23386 107999.9n -0.23386 108000.0n -0.15161 108179.9n -0.15161 108180.0n 1.28574 108359.9n 1.28574 108360.0n 0.34013 108539.9n 0.34013 108540.0n 0.13226 108719.9n 0.13226 108720.0n 0.76415 108899.9n 0.76415 108900.0n 0.42554 109079.9n 0.42554 109080.0n 0.40313 109259.9n 0.40313 109260.0n 1.17517 109439.9n 1.17517 109440.0n 1.20712 109619.9n 1.20712 109620.0n 1.11225 109799.9n 1.11225 109800.0n 0.28189 109979.9n 0.28189 109980.0n 1.18224 110159.9n 1.18224 110160.0n 1.28574 110339.9n 1.28574 110340.0n -0.33158 110519.9n -0.33158 110520.0n 0.56595 110699.9n 0.56595 110700.0n 1.27694 110879.9n 1.27694 110880.0n -0.21828 111059.9n -0.21828 111060.0n 0.67130 111239.9n 0.67130 111240.0n 0.25911 111419.9n 0.25911 111420.0n 0.59247 111599.9n 0.59247 111600.0n 0.29915 111779.9n 0.29915 111780.0n 0.63482 111959.9n 0.63482 111960.0n 0.33171 112139.9n 0.33171 112140.0n 0.65842 112319.9n 0.65842 112320.0n 0.23835 112499.9n 0.23835 112500.0n 0.66096 112679.9n 0.66096 112680.0n 1.17517 112859.9n 1.17517 112860.0n -0.23386 113039.9n -0.23386 113040.0n 0.48458 113219.9n 0.48458 113220.0n 1.23180 113399.9n 1.23180 113400.0n 0.42554 113579.9n 0.42554 113580.0n 0.70122 113759.9n 0.70122 113760.0n -0.15161 113939.9n -0.15161 113940.0n 0.13226 114119.9n 0.13226 114120.0n 0.28700 114299.9n 0.28700 114300.0n 0.76415 114479.9n 0.76415 114480.0n -0.08309 114659.9n -0.08309 114660.0n 0.34013 114839.9n 0.34013 114840.0n 0.40313 115019.9n 0.40313 115020.0n -0.37792 115199.9n -0.37792 115200.0n 1.17517 115379.9n 1.17517 115380.0n -0.21828 115559.9n -0.21828 115560.0n 0.29915 115739.9n 0.29915 115740.0n 0.42554 115919.9n 0.42554 115920.0n -0.37792 116099.9n -0.37792 116100.0n 0.56595 116279.9n 0.56595 116280.0n -0.23386 116459.9n -0.23386 116460.0n 1.23180 116639.9n 1.23180 116640.0n 0.28189 116819.9n 0.28189 116820.0n 0.34013 116999.9n 0.34013 117000.0n 1.20712 117179.9n 1.20712 117180.0n 0.59247 117359.9n 0.59247 117360.0n 0.63482 117539.9n 0.63482 117540.0n 0.28700 117719.9n 0.28700 117720.0n 0.40313 117899.9n 0.40313 117900.0n 0.13226 118079.9n 0.13226 118080.0n 1.18224 118259.9n 1.18224 118260.0n 0.66096 118439.9n 0.66096 118440.0n 1.27694 118619.9n 1.27694 118620.0n 1.11225 118799.9n 1.11225 118800.0n 0.33171 118979.9n 0.33171 118980.0n 0.23835 119159.9n 0.23835 119160.0n 0.65842 119339.9n 0.65842 119340.0n 0.76415 119519.9n 0.76415 119520.0n 0.48458 119699.9n 0.48458 119700.0n 0.25911 119879.9n 0.25911 119880.0n -0.15161 120059.9n -0.15161 120060.0n 1.28574 120239.9n 1.28574 120240.0n 0.67130 120419.9n 0.67130 120420.0n 0.70122 120599.9n 0.70122 120600.0n -0.08309 120779.9n -0.08309 120780.0n -0.33158 120959.9n -0.33158 120960.0n 1.17517 121139.9n 1.17517 121140.0n 1.27694 121319.9n 1.27694 121320.0n 0.23835 121499.9n 0.23835 121500.0n -0.15161 121679.9n -0.15161 121680.0n 1.18224 121859.9n 1.18224 121860.0n 0.28189 122039.9n 0.28189 122040.0n 0.25911 122219.9n 0.25911 122220.0n 0.67130 122399.9n 0.67130 122400.0n -0.21828 122579.9n -0.21828 122580.0n 0.76415 122759.9n 0.76415 122760.0n 0.66096 122939.9n 0.66096 122940.0n 0.28700 123119.9n 0.28700 123120.0n 0.63482 123299.9n 0.63482 123300.0n 1.11225 123479.9n 1.11225 123480.0n -0.37792 123659.9n -0.37792 123660.0n -0.23386 123839.9n -0.23386 123840.0n 0.29915 124019.9n 0.29915 124020.0n 0.40313 124199.9n 0.40313 124200.0n 0.13226 124379.9n 0.13226 124380.0n 0.34013 124559.9n 0.34013 124560.0n 0.65842 124739.9n 0.65842 124740.0n 0.56595 124919.9n 0.56595 124920.0n 0.59247 125099.9n 0.59247 125100.0n -0.08309 125279.9n -0.08309 125280.0n 1.28574 125459.9n 1.28574 125460.0n 1.20712 125639.9n 1.20712 125640.0n 0.42554 125819.9n 0.42554 125820.0n 0.70122 125999.9n 0.70122 126000.0n -0.33158 126179.9n -0.33158 126180.0n 0.33171 126359.9n 0.33171 126360.0n 1.23180 126539.9n 1.23180 126540.0n 0.48458 126719.9n 0.48458 126720.0n 1.27694 126899.9n 1.27694 126900.0n -0.08309 127079.9n -0.08309 127080.0n -0.37792 127259.9n -0.37792 127260.0n 1.17517 127439.9n 1.17517 127440.0n 0.13226 127619.9n 0.13226 127620.0n 0.67130 127799.9n 0.67130 127800.0n 1.28574 127979.9n 1.28574 127980.0n 0.59247 128159.9n 0.59247 128160.0n 0.56595 128339.9n 0.56595 128340.0n 0.42554 128519.9n 0.42554 128520.0n 0.65842 128699.9n 0.65842 128700.0n 0.28189 128879.9n 0.28189 128880.0n -0.21828 129059.9n -0.21828 129060.0n 0.25911 129239.9n 0.25911 129240.0n 0.63482 129419.9n 0.63482 129420.0n 0.33171 129599.9n 0.33171 129600.0n -0.23386 129779.9n -0.23386 129780.0n 0.66096 129959.9n 0.66096 129960.0n 0.48458 130139.9n 0.48458 130140.0n 0.40313 130319.9n 0.40313 130320.0n 0.23835 130499.9n 0.23835 130500.0n 1.20712 130679.9n 1.20712 130680.0n 0.28700 130859.9n 0.28700 130860.0n 1.11225 131039.9n 1.11225 131040.0n 0.76415 131219.9n 0.76415 131220.0n 0.70122 131399.9n 0.70122 131400.0n 1.18224 131579.9n 1.18224 131580.0n 0.29915 131759.9n 0.29915 131760.0n 1.23180 131939.9n 1.23180 131940.0n -0.33158 132119.9n -0.33158 132120.0n 0.34013 132299.9n 0.34013 132300.0n -0.15161 132479.9n -0.15161 132480.0n 0.13226 132659.9n 0.13226 132660.0n -0.33158 132839.9n -0.33158 132840.0n 0.66096 133019.9n 0.66096 133020.0n 0.65842 133199.9n 0.65842 133200.0n -0.21828 133379.9n -0.21828 133380.0n -0.15161 133559.9n -0.15161 133560.0n 1.11225 133739.9n 1.11225 133740.0n -0.23386 133919.9n -0.23386 133920.0n 0.59247 134099.9n 0.59247 134100.0n -0.08309 134279.9n -0.08309 134280.0n 0.48458 134459.9n 0.48458 134460.0n 0.40313 134639.9n 0.40313 134640.0n 1.17517 134819.9n 1.17517 134820.0n 1.23180 134999.9n 1.23180 135000.0n 0.25911 135179.9n 0.25911 135180.0n 0.67130 135359.9n 0.67130 135360.0n 0.42554 135539.9n 0.42554 135540.0n 0.28189 135719.9n 0.28189 135720.0n -0.37792 135899.9n -0.37792 135900.0n 0.70122 136079.9n 0.70122 136080.0n 1.20712 136259.9n 1.20712 136260.0n 0.33171 136439.9n 0.33171 136440.0n 1.27694 136619.9n 1.27694 136620.0n 0.63482 136799.9n 0.63482 136800.0n 0.34013 136979.9n 0.34013 136980.0n 0.76415 137159.9n 0.76415 137160.0n 0.56595 137339.9n 0.56595 137340.0n 0.29915 137519.9n 0.29915 137520.0n 1.28574 137699.9n 1.28574 137700.0n 0.23835 137879.9n 0.23835 137880.0n 1.18224 138059.9n 1.18224 138060.0n 0.28700 138239.9n 0.28700 138240.0n 0.28189 138419.9n 0.28189 138420.0n 0.56595 138599.9n 0.56595 138600.0n 0.23835 138779.9n 0.23835 138780.0n 0.29915 138959.9n 0.29915 138960.0n 0.76415 139139.9n 0.76415 139140.0n -0.08309 139319.9n -0.08309 139320.0n -0.21828 139499.9n -0.21828 139500.0n 0.42554 139679.9n 0.42554 139680.0n 0.40313 139859.9n 0.40313 139860.0n 1.27694 140039.9n 1.27694 140040.0n 0.28700 140219.9n 0.28700 140220.0n -0.33158 140399.9n -0.33158 140400.0n 0.67130 140579.9n 0.67130 140580.0n 0.66096 140759.9n 0.66096 140760.0n -0.15161 140939.9n -0.15161 140940.0n 0.25911 141119.9n 0.25911 141120.0n 1.18224 141299.9n 1.18224 141300.0n 0.34013 141479.9n 0.34013 141480.0n 0.48458 141659.9n 0.48458 141660.0n 1.17517 141839.9n 1.17517 141840.0n 0.59247 142019.9n 0.59247 142020.0n 0.65842 142199.9n 0.65842 142200.0n 0.70122 142379.9n 0.70122 142380.0n 0.33171 142559.9n 0.33171 142560.0n 1.20712 142739.9n 1.20712 142740.0n 0.13226 142919.9n 0.13226 142920.0n 1.28574 143099.9n 1.28574 143100.0n -0.37792 143279.9n -0.37792 143280.0n 0.63482 143459.9n 0.63482 143460.0n -0.23386 143639.9n -0.23386 143640.0n 1.11225 143819.9n 1.11225 143820.0n 1.23180 143999.9n 1.23180 144000.0n 1.28574 144179.9n 1.28574 144180.0n 0.70122 144359.9n 0.70122 144360.0n 0.63482 144539.9n 0.63482 144540.0n 0.13226 144719.9n 0.13226 144720.0n 1.11225 144899.9n 1.11225 144900.0n 0.23835 145079.9n 0.23835 145080.0n 0.34013 145259.9n 0.34013 145260.0n 0.67130 145439.9n 0.67130 145440.0n 0.29915 145619.9n 0.29915 145620.0n 0.33171 145799.9n 0.33171 145800.0n 0.25911 145979.9n 0.25911 145980.0n 1.20712 146159.9n 1.20712 146160.0n -0.15161 146339.9n -0.15161 146340.0n -0.37792 146519.9n -0.37792 146520.0n 0.66096 146699.9n 0.66096 146700.0n -0.23386 146879.9n -0.23386 146880.0n 0.76415 147059.9n 0.76415 147060.0n 0.65842 147239.9n 0.65842 147240.0n 0.59247 147419.9n 0.59247 147420.0n 0.28189 147599.9n 0.28189 147600.0n 0.42554 147779.9n 0.42554 147780.0n 0.40313 147959.9n 0.40313 147960.0n -0.33158 148139.9n -0.33158 148140.0n 0.56595 148319.9n 0.56595 148320.0n 1.17517 148499.9n 1.17517 148500.0n 1.18224 148679.9n 1.18224 148680.0n 0.28700 148859.9n 0.28700 148860.0n 1.23180 149039.9n 1.23180 149040.0n 1.27694 149219.9n 1.27694 149220.0n 0.48458 149399.9n 0.48458 149400.0n -0.21828 149579.9n -0.21828 149580.0n -0.08309 149759.9n -0.08309 149760.0n 0.28700 149939.9n 0.28700 149940.0n -0.37792 150119.9n -0.37792 150120.0n 0.40313 150299.9n 0.40313 150300.0n 0.56595 150479.9n 0.56595 150480.0n -0.33158 150659.9n -0.33158 150660.0n -0.21828 150839.9n -0.21828 150840.0n 0.48458 151019.9n 0.48458 151020.0n 0.65842 151199.9n 0.65842 151200.0n 0.63482 151379.9n 0.63482 151380.0n 0.34013 151559.9n 0.34013 151560.0n 0.28189 151739.9n 0.28189 151740.0n 0.13226 151919.9n 0.13226 151920.0n 0.23835 152099.9n 0.23835 152100.0n 0.59247 152279.9n 0.59247 152280.0n -0.23386 152459.9n -0.23386 152460.0n 0.33171 152639.9n 0.33171 152640.0n 0.67130 152819.9n 0.67130 152820.0n 0.66096 152999.9n 0.66096 153000.0n 1.28574 153179.9n 1.28574 153180.0n 0.29915 153359.9n 0.29915 153360.0n 0.76415 153539.9n 0.76415 153540.0n -0.15161 153719.9n -0.15161 153720.0n 1.23180 153899.9n 1.23180 153900.0n 1.20712 154079.9n 1.20712 154080.0n 1.17517 154259.9n 1.17517 154260.0n 0.25911 154439.9n 0.25911 154440.0n 1.11225 154619.9n 1.11225 154620.0n 0.70122 154799.9n 0.70122 154800.0n -0.08309 154979.9n -0.08309 154980.0n 1.27694 155159.9n 1.27694 155160.0n 1.18224 155339.9n 1.18224 155340.0n 0.42554 155519.9n 0.42554 155520.0n 0.13226 155699.9n 0.13226 155700.0n 0.63482 155879.9n 0.63482 155880.0n 1.27694 156059.9n 1.27694 156060.0n 0.76415 156239.9n 0.76415 156240.0n -0.33158 156419.9n -0.33158 156420.0n 0.67130 156599.9n 0.67130 156600.0n 0.66096 156779.9n 0.66096 156780.0n 0.42554 156959.9n 0.42554 156960.0n 0.48458 157139.9n 0.48458 157140.0n 0.40313 157319.9n 0.40313 157320.0n 1.20712 157499.9n 1.20712 157500.0n -0.21828 157679.9n -0.21828 157680.0n 0.59247 157859.9n 0.59247 157860.0n 1.23180 158039.9n 1.23180 158040.0n 0.25911 158219.9n 0.25911 158220.0n 1.11225 158399.9n 1.11225 158400.0n 0.29915 158579.9n 0.29915 158580.0n 0.65842 158759.9n 0.65842 158760.0n 0.23835 158939.9n 0.23835 158940.0n 0.28189 159119.9n 0.28189 159120.0n -0.37792 159299.9n -0.37792 159300.0n -0.23386 159479.9n -0.23386 159480.0n 0.34013 159659.9n 0.34013 159660.0n 0.56595 159839.9n 0.56595 159840.0n -0.15161 160019.9n -0.15161 160020.0n 0.28700 160199.9n 0.28700 160200.0n 1.17517 160379.9n 1.17517 160380.0n 1.18224 160559.9n 1.18224 160560.0n 1.28574 160739.9n 1.28574 160740.0n 0.33171 160919.9n 0.33171 160920.0n -0.08309 161099.9n -0.08309 161100.0n 0.70122 161279.9n 0.70122 161280.0n -0.21828 161459.9n -0.21828 161460.0n 1.18224 161639.9n 1.18224 161640.0n 0.76415 161819.9n 0.76415 161820.0n -0.23386 161999.9n -0.23386 162000.0n 0.56595 162179.9n 0.56595 162180.0n 1.20712 162359.9n 1.20712 162360.0n 0.67130 162539.9n 0.67130 162540.0n 0.33171 162719.9n 0.33171 162720.0n -0.08309 162899.9n -0.08309 162900.0n 0.13226 163079.9n 0.13226 163080.0n 0.25911 163259.9n 0.25911 163260.0n -0.37792 163439.9n -0.37792 163440.0n 0.34013 163619.9n 0.34013 163620.0n 0.59247 163799.9n 0.59247 163800.0n 0.63482 163979.9n 0.63482 163980.0n 0.40313 164159.9n 0.40313 164160.0n 1.17517 164339.9n 1.17517 164340.0n 0.65842 164519.9n 0.65842 164520.0n 0.28189 164699.9n 0.28189 164700.0n 1.27694 164879.9n 1.27694 164880.0n 0.29915 165059.9n 0.29915 165060.0n 0.66096 165239.9n 0.66096 165240.0n 1.11225 165419.9n 1.11225 165420.0n 0.48458 165599.9n 0.48458 165600.0n 1.23180 165779.9n 1.23180 165780.0n 1.28574 165959.9n 1.28574 165960.0n 0.70122 166139.9n 0.70122 166140.0n -0.15161 166319.9n -0.15161 166320.0n -0.33158 166499.9n -0.33158 166500.0n 0.23835 166679.9n 0.23835 166680.0n 0.28700 166859.9n 0.28700 166860.0n 0.42554 167039.9n 0.42554 167040.0n 0.33171 167219.9n 0.33171 167220.0n 0.48458 167399.9n 0.48458 167400.0n 0.13226 167579.9n 0.13226 167580.0n -0.23386 167759.9n -0.23386 167760.0n 1.27694 167939.9n 1.27694 167940.0n 0.42554 168119.9n 0.42554 168120.0n -0.37792 168299.9n -0.37792 168300.0n 1.23180 168479.9n 1.23180 168480.0n 0.25911 168659.9n 0.25911 168660.0n -0.08309 168839.9n -0.08309 168840.0n -0.33158 169019.9n -0.33158 169020.0n 0.34013 169199.9n 0.34013 169200.0n 0.29915 169379.9n 0.29915 169380.0n -0.21828 169559.9n -0.21828 169560.0n 0.70122 169739.9n 0.70122 169740.0n -0.15161 169919.9n -0.15161 169920.0n 1.18224 170099.9n 1.18224 170100.0n 1.11225 170279.9n 1.11225 170280.0n 0.28700 170459.9n 0.28700 170460.0n 0.63482 170639.9n 0.63482 170640.0n 0.23835 170819.9n 0.23835 170820.0n 0.76415 170999.9n 0.76415 171000.0n 0.59247 171179.9n 0.59247 171180.0n 0.28189 171359.9n 0.28189 171360.0n 1.20712 171539.9n 1.20712 171540.0n 0.40313 171719.9n 0.40313 171720.0n 0.65842 171899.9n 0.65842 171900.0n 1.28574 172079.9n 1.28574 172080.0n 1.17517 172259.9n 1.17517 172260.0n 0.66096 172439.9n 0.66096 172440.0n 0.67130 172619.9n 0.67130 172620.0n 0.56595 172799.9n 0.56595 172800.0n 0.36576 172979.9n 0.36576 172980.0n 0.33730 173159.9n 0.33730 173160.0n 0.38385 173339.9n 0.38385 173340.0n 0.59706 173519.9n 0.59706 173520.0n 0.62307 173699.9n 0.62307 173700.0n 0.67018 173879.9n 0.67018 173880.0n 0.70540 174059.9n 0.70540 174060.0n 0.53582 174239.9n 0.53582 174240.0n 0.33357 174419.9n 0.33357 174420.0n 0.52885 174599.9n 0.52885 174600.0n 0.74383 174779.9n 0.74383 174780.0n 0.78409 174959.9n 0.78409 174960.0n 0.51936 175139.9n 0.51936 175140.0n 0.50532 175319.9n 0.50532 175320.0n 0.68189 175499.9n 0.68189 175500.0n 0.79862 175679.9n 0.79862 175680.0n 0.35050 175859.9n 0.35050 175860.0n 0.16858 176039.9n 0.16858 176040.0n 0.55253 176219.9n 0.55253 176220.0n 0.60823 176399.9n 0.60823 176400.0n 0.63611 176579.9n 0.63611 176580.0n 0.41197 176759.9n 0.41197 176760.0n 0.69413 176939.9n 0.69413 176940.0n 0.58457 177119.9n 0.58457 177120.0n 0.33751 177299.9n 0.33751 177300.0n 0.71381 177479.9n 0.71381 177480.0n 0.64266 177659.9n 0.64266 177660.0n 0.16018 177839.9n 0.16018 177840.0n 0.78157 178019.9n 0.78157 178020.0n 0.22203 178199.9n 0.22203 178200.0n 0.87402 178379.9n 0.87402 178380.0n -0.10545 178559.9n -0.10545 178560.0n -0.25282 178739.9n -0.25282 178740.0n -0.37666 178919.9n -0.37666 178920.0n 1.43391 179099.9n 1.43391 179100.0n 0.37511 179279.9n 0.37511 179280.0n 0.35780 179459.9n 0.35780 179460.0n 1.04281 179639.9n 1.04281 179640.0n 1.30757 179819.9n 1.30757 179820.0n -0.27950 179999.9n -0.27950 180000.0n 0.10137 180179.9n 0.10137 180180.0n 1.20727 180359.9n 1.20727 180360.0n 1.40210 180539.9n 1.40210 180540.0n 1.03003 180719.9n 1.03003 180720.0n -0.27250 180899.9n -0.27250 180900.0n -0.24444 181079.9n -0.24444 181080.0n 0.81835 181259.9n 0.81835 181260.0n 0.11792 181439.9n 0.11792 181440.0n -0.41822 181619.9n -0.41822 181620.0n 0.75242 181799.9n 0.75242 181800.0n 0.57354 181979.9n 0.57354 181980.0n 1.22124 182159.9n 1.22124 182160.0n 1.07258 182339.9n 1.07258 182340.0n 1.14286 182519.9n 1.14286 182520.0n -0.14226 182699.9n -0.14226 182700.0n 1.32817 182879.9n 1.32817 182880.0n 1.08864 183059.9n 1.08864 183060.0n 1.09055 183239.9n 1.09055 183240.0n 1.50665 183419.9n 1.50665 183420.0n -0.21520)
Vxn1 a_xn1 0 PWL(0.0n 0.36518 179.9n 0.36518 180.0n 0.65987 359.9n 0.65987 360.0n 0.32870 539.9n 0.32870 540.0n 0.71811 719.9n 0.71811 720.0n -0.20712 899.9n -0.20712 900.0n -0.27694 1079.9n -0.27694 1080.0n -0.23180 1259.9n -0.23180 1260.0n 0.51542 1439.9n 0.51542 1440.0n 1.08309 1619.9n 1.08309 1620.0n 0.40753 1799.9n 0.40753 1800.0n -0.18224 1979.9n -0.18224 1980.0n -0.11225 2159.9n -0.11225 2160.0n 0.59687 2339.9n 0.59687 2340.0n 0.34158 2519.9n 0.34158 2520.0n 0.29878 2699.9n 0.29878 2700.0n 1.33158 2879.9n 1.33158 2880.0n 0.70085 3059.9n 0.70085 3060.0n 0.71300 3239.9n 0.71300 3240.0n 0.57446 3419.9n 0.57446 3420.0n 1.37792 3599.9n 1.37792 3600.0n 1.23386 3779.9n 1.23386 3780.0n 0.23585 3959.9n 0.23585 3960.0n 1.21828 4139.9n 1.21828 4140.0n 0.74089 4319.9n 0.74089 4320.0n -0.28574 4499.9n -0.28574 4500.0n 0.43405 4679.9n 0.43405 4680.0n 0.66829 4859.9n 0.66829 4860.0n 0.86774 5039.9n 0.86774 5040.0n 0.76165 5219.9n 0.76165 5220.0n -0.17517 5399.9n -0.17517 5400.0n 0.33904 5579.9n 0.33904 5580.0n 1.15161 5759.9n 1.15161 5760.0n -0.28574 5939.9n -0.28574 5940.0n 1.08309 6119.9n 1.08309 6120.0n 0.40753 6299.9n 0.40753 6300.0n 0.76165 6479.9n 0.76165 6480.0n 0.57446 6659.9n 0.57446 6660.0n 0.86774 6839.9n 0.86774 6840.0n -0.17517 7019.9n -0.17517 7020.0n 1.37792 7199.9n 1.37792 7200.0n 0.29878 7379.9n 0.29878 7380.0n -0.18224 7559.9n -0.18224 7560.0n 0.65987 7739.9n 0.65987 7740.0n 0.59687 7919.9n 0.59687 7920.0n 0.33904 8099.9n 0.33904 8100.0n 0.71811 8279.9n 0.71811 8280.0n -0.20712 8459.9n -0.20712 8460.0n 0.34158 8639.9n 0.34158 8640.0n -0.23180 8819.9n -0.23180 8820.0n 0.71300 8999.9n 0.71300 9000.0n 0.43405 9179.9n 0.43405 9180.0n 0.32870 9359.9n 0.32870 9360.0n -0.11225 9539.9n -0.11225 9540.0n 0.66829 9719.9n 0.66829 9720.0n 0.36518 9899.9n 0.36518 9900.0n 0.74089 10079.9n 0.74089 10080.0n 1.21828 10259.9n 1.21828 10260.0n -0.27694 10439.9n -0.27694 10440.0n 1.33158 10619.9n 1.33158 10620.0n 0.51542 10799.9n 0.51542 10800.0n 0.70085 10979.9n 0.70085 10980.0n 1.23386 11159.9n 1.23386 11160.0n 0.23585 11339.9n 0.23585 11340.0n 1.15161 11519.9n 1.15161 11520.0n -0.28574 11699.9n -0.28574 11700.0n -0.17517 11879.9n -0.17517 11880.0n 1.33158 12059.9n 1.33158 12060.0n 0.43405 12239.9n 0.43405 12240.0n 0.65987 12419.9n 0.65987 12420.0n 1.15161 12599.9n 1.15161 12600.0n -0.23180 12779.9n -0.23180 12780.0n 0.57446 12959.9n 0.57446 12960.0n 0.59687 13139.9n 0.59687 13140.0n 0.23585 13319.9n 0.23585 13320.0n 1.08309 13499.9n 1.08309 13500.0n 1.21828 13679.9n 1.21828 13680.0n 0.86774 13859.9n 0.86774 13860.0n 0.29878 14039.9n 0.29878 14040.0n 1.23386 14219.9n 1.23386 14220.0n 0.32870 14399.9n 0.32870 14400.0n 1.37792 14579.9n 1.37792 14580.0n 0.70085 14759.9n 0.70085 14760.0n 0.34158 14939.9n 0.34158 14940.0n 0.74089 15119.9n 0.74089 15120.0n 0.66829 15299.9n 0.66829 15300.0n -0.20712 15479.9n -0.20712 15480.0n -0.11225 15659.9n -0.11225 15660.0n -0.27694 15839.9n -0.27694 15840.0n 0.71811 16019.9n 0.71811 16020.0n 0.51542 16199.9n 0.51542 16200.0n 0.40753 16379.9n 0.40753 16380.0n 0.33904 16559.9n 0.33904 16560.0n 0.76165 16739.9n 0.76165 16740.0n -0.18224 16919.9n -0.18224 16920.0n 0.71300 17099.9n 0.71300 17100.0n 0.36518 17279.9n 0.36518 17280.0n -0.17517 17459.9n -0.17517 17460.0n 0.59687 17639.9n 0.59687 17640.0n 0.76165 17819.9n 0.76165 17820.0n 0.32870 17999.9n 0.32870 18000.0n -0.28574 18179.9n -0.28574 18180.0n -0.20712 18359.9n -0.20712 18360.0n 0.23585 18539.9n 0.23585 18540.0n 0.71300 18719.9n 0.71300 18720.0n -0.27694 18899.9n -0.27694 18900.0n 0.71811 19079.9n 0.71811 19080.0n -0.23180 19259.9n -0.23180 19260.0n 0.34158 19439.9n 0.34158 19440.0n 0.65987 19619.9n 0.65987 19620.0n 0.74089 19799.9n 0.74089 19800.0n 0.57446 19979.9n 0.57446 19980.0n 1.08309 20159.9n 1.08309 20160.0n 0.43405 20339.9n 0.43405 20340.0n 0.66829 20519.9n 0.66829 20520.0n -0.18224 20699.9n -0.18224 20700.0n 1.21828 20879.9n 1.21828 20880.0n 1.33158 21059.9n 1.33158 21060.0n 0.51542 21239.9n 0.51542 21240.0n 0.29878 21419.9n 0.29878 21420.0n 1.37792 21599.9n 1.37792 21600.0n 1.23386 21779.9n 1.23386 21780.0n 0.33904 21959.9n 0.33904 21960.0n -0.11225 22139.9n -0.11225 22140.0n 0.36518 22319.9n 0.36518 22320.0n 0.70085 22499.9n 0.70085 22500.0n 0.86774 22679.9n 0.86774 22680.0n 1.15161 22859.9n 1.15161 22860.0n 0.40753 23039.9n 0.40753 23040.0n 1.21828 23219.9n 1.21828 23220.0n 0.36518 23399.9n 0.36518 23400.0n 0.74089 23579.9n 0.74089 23580.0n 1.23386 23759.9n 1.23386 23760.0n 0.71811 23939.9n 0.71811 23940.0n 0.71300 24119.9n 0.71300 24120.0n -0.20712 24299.9n -0.20712 24300.0n 0.23585 24479.9n 0.23585 24480.0n 0.66829 24659.9n 0.66829 24660.0n 0.51542 24839.9n 0.51542 24840.0n 0.34158 25019.9n 0.34158 25020.0n 0.29878 25199.9n 0.29878 25200.0n 0.57446 25379.9n 0.57446 25380.0n -0.27694 25559.9n -0.27694 25560.0n 1.08309 25739.9n 1.08309 25740.0n 0.32870 25919.9n 0.32870 25920.0n -0.18224 26099.9n -0.18224 26100.0n 0.43405 26279.9n 0.43405 26280.0n 0.65987 26459.9n 0.65987 26460.0n 1.37792 26639.9n 1.37792 26640.0n -0.11225 26819.9n -0.11225 26820.0n 0.70085 26999.9n 0.70085 27000.0n 0.59687 27179.9n 0.59687 27180.0n -0.28574 27359.9n -0.28574 27360.0n 0.86774 27539.9n 0.86774 27540.0n 0.40753 27719.9n 0.40753 27720.0n -0.17517 27899.9n -0.17517 27900.0n -0.23180 28079.9n -0.23180 28080.0n 0.33904 28259.9n 0.33904 28260.0n 1.15161 28439.9n 1.15161 28440.0n 0.76165 28619.9n 0.76165 28620.0n 1.33158 28799.9n 1.33158 28800.0n 0.32870 28979.9n 0.32870 28980.0n 0.59687 29159.9n 0.59687 29160.0n 0.33904 29339.9n 0.33904 29340.0n 1.23386 29519.9n 1.23386 29520.0n 0.70085 29699.9n 0.70085 29700.0n 0.74089 29879.9n 0.74089 29880.0n 0.57446 30059.9n 0.57446 30060.0n -0.20712 30239.9n -0.20712 30240.0n 0.66829 30419.9n 0.66829 30420.0n 0.71811 30599.9n 0.71811 30600.0n 0.34158 30779.9n 0.34158 30780.0n 0.23585 30959.9n 0.23585 30960.0n -0.28574 31139.9n -0.28574 31140.0n -0.27694 31319.9n -0.27694 31320.0n 0.86774 31499.9n 0.86774 31500.0n 0.76165 31679.9n 0.76165 31680.0n 0.43405 31859.9n 0.43405 31860.0n 0.51542 32039.9n 0.51542 32040.0n 1.08309 32219.9n 1.08309 32220.0n -0.18224 32399.9n -0.18224 32400.0n -0.23180 32579.9n -0.23180 32580.0n 0.29878 32759.9n 0.29878 32760.0n 0.36518 32939.9n 0.36518 32940.0n 0.65987 33119.9n 0.65987 33120.0n 1.21828 33299.9n 1.21828 33300.0n 0.71300 33479.9n 0.71300 33480.0n 1.37792 33659.9n 1.37792 33660.0n -0.17517 33839.9n -0.17517 33840.0n -0.11225 34019.9n -0.11225 34020.0n 0.40753 34199.9n 0.40753 34200.0n 1.33158 34379.9n 1.33158 34380.0n 1.15161 34559.9n 1.15161 34560.0n -0.20712 34739.9n -0.20712 34740.0n 0.29878 34919.9n 0.29878 34920.0n 0.51542 35099.9n 0.51542 35100.0n 0.59687 35279.9n 0.59687 35280.0n 1.15161 35459.9n 1.15161 35460.0n 0.65987 35639.9n 0.65987 35640.0n 1.37792 35819.9n 1.37792 35820.0n -0.27694 35999.9n -0.27694 36000.0n -0.18224 36179.9n -0.18224 36180.0n 0.71811 36359.9n 0.71811 36360.0n 0.70085 36539.9n 0.70085 36540.0n 0.36518 36719.9n 0.36518 36720.0n 1.23386 36899.9n 1.23386 36900.0n 1.33158 37079.9n 1.33158 37080.0n 0.23585 37259.9n 0.23585 37260.0n -0.17517 37439.9n -0.17517 37440.0n 0.76165 37619.9n 0.76165 37620.0n 1.08309 37799.9n 1.08309 37800.0n 0.71300 37979.9n 0.71300 37980.0n 0.32870 38159.9n 0.32870 38160.0n 0.66829 38339.9n 0.66829 38340.0n 0.34158 38519.9n 0.34158 38520.0n 0.74089 38699.9n 0.74089 38700.0n 0.57446 38879.9n 0.57446 38880.0n 0.33904 39059.9n 0.33904 39060.0n -0.11225 39239.9n -0.11225 39240.0n -0.23180 39419.9n -0.23180 39420.0n -0.28574 39599.9n -0.28574 39600.0n 0.86774 39779.9n 0.86774 39780.0n 0.43405 39959.9n 0.43405 39960.0n 0.40753 40139.9n 0.40753 40140.0n 1.21828 40319.9n 1.21828 40320.0n 0.51542 40499.9n 0.51542 40500.0n 0.66829 40679.9n 0.66829 40680.0n -0.11225 40859.9n -0.11225 40860.0n 0.71300 41039.9n 0.71300 41040.0n -0.28574 41219.9n -0.28574 41220.0n -0.23180 41399.9n -0.23180 41400.0n 0.65987 41579.9n 0.65987 41580.0n 0.23585 41759.9n 0.23585 41760.0n 0.29878 41939.9n 0.29878 41940.0n 0.76165 42119.9n 0.76165 42120.0n 0.33904 42299.9n 0.33904 42300.0n 0.43405 42479.9n 0.43405 42480.0n 0.71811 42659.9n 0.71811 42660.0n 0.74089 42839.9n 0.74089 42840.0n -0.17517 43019.9n -0.17517 43020.0n 0.59687 43199.9n 0.59687 43200.0n 0.40753 43379.9n 0.40753 43380.0n -0.27694 43559.9n -0.27694 43560.0n 1.15161 43739.9n 1.15161 43740.0n -0.20712 43919.9n -0.20712 43920.0n 0.36518 44099.9n 0.36518 44100.0n 0.32870 44279.9n 0.32870 44280.0n 1.37792 44459.9n 1.37792 44460.0n 0.34158 44639.9n 0.34158 44640.0n 0.86774 44819.9n 0.86774 44820.0n 0.57446 44999.9n 0.57446 45000.0n 1.23386 45179.9n 1.23386 45180.0n 0.70085 45359.9n 0.70085 45360.0n 1.08309 45539.9n 1.08309 45540.0n 1.21828 45719.9n 1.21828 45720.0n -0.18224 45899.9n -0.18224 45900.0n 1.33158 46079.9n 1.33158 46080.0n 0.74089 46259.9n 0.74089 46260.0n 0.23585 46439.9n 0.23585 46440.0n -0.28574 46619.9n -0.28574 46620.0n -0.11225 46799.9n -0.11225 46800.0n 1.15161 46979.9n 1.15161 46980.0n 0.66829 47159.9n 0.66829 47160.0n 0.34158 47339.9n 0.34158 47340.0n -0.20712 47519.9n -0.20712 47520.0n 1.08309 47699.9n 1.08309 47700.0n 1.37792 47879.9n 1.37792 47880.0n 0.57446 48059.9n 0.57446 48060.0n -0.23180 48239.9n -0.23180 48240.0n 0.29878 48419.9n 0.29878 48420.0n 0.71811 48599.9n 0.71811 48600.0n 0.59687 48779.9n 0.59687 48780.0n 0.51542 48959.9n 0.51542 48960.0n -0.18224 49139.9n -0.18224 49140.0n 0.70085 49319.9n 0.70085 49320.0n 0.32870 49499.9n 0.32870 49500.0n -0.17517 49679.9n -0.17517 49680.0n 0.65987 49859.9n 0.65987 49860.0n 0.71300 50039.9n 0.71300 50040.0n -0.27694 50219.9n -0.27694 50220.0n 1.21828 50399.9n 1.21828 50400.0n 0.33904 50579.9n 0.33904 50580.0n 0.86774 50759.9n 0.86774 50760.0n 0.76165 50939.9n 0.76165 50940.0n 0.36518 51119.9n 0.36518 51120.0n 0.40753 51299.9n 0.40753 51300.0n 0.43405 51479.9n 0.43405 51480.0n 1.23386 51659.9n 1.23386 51660.0n 1.33158 51839.9n 1.33158 51840.0n 0.65987 52019.9n 0.65987 52020.0n 0.59687 52199.9n 0.59687 52200.0n 0.66829 52379.9n 0.66829 52380.0n 1.08309 52559.9n 1.08309 52560.0n 0.76165 52739.9n 0.76165 52740.0n 0.40753 52919.9n 0.40753 52920.0n 1.37792 53099.9n 1.37792 53100.0n 0.34158 53279.9n 0.34158 53280.0n 0.70085 53459.9n 0.70085 53460.0n 0.43405 53639.9n 0.43405 53640.0n 0.71811 53819.9n 0.71811 53820.0n -0.17517 53999.9n -0.17517 54000.0n 1.23386 54179.9n 1.23386 54180.0n 1.33158 54359.9n 1.33158 54360.0n 1.21828 54539.9n 1.21828 54540.0n 0.33904 54719.9n 0.33904 54720.0n -0.18224 54899.9n -0.18224 54900.0n 1.15161 55079.9n 1.15161 55080.0n -0.28574 55259.9n -0.28574 55260.0n 0.71300 55439.9n 0.71300 55440.0n 0.57446 55619.9n 0.57446 55620.0n 0.36518 55799.9n 0.36518 55800.0n 0.29878 55979.9n 0.29878 55980.0n 0.32870 56159.9n 0.32870 56160.0n 0.74089 56339.9n 0.74089 56340.0n 0.86774 56519.9n 0.86774 56520.0n -0.20712 56699.9n -0.20712 56700.0n -0.23180 56879.9n -0.23180 56880.0n -0.11225 57059.9n -0.11225 57060.0n 0.23585 57239.9n 0.23585 57240.0n -0.27694 57419.9n -0.27694 57420.0n 0.51542 57599.9n 0.51542 57600.0n 1.21828 57779.9n 1.21828 57780.0n 1.08309 57959.9n 1.08309 57960.0n 0.70085 58139.9n 0.70085 58140.0n 0.34158 58319.9n 0.34158 58320.0n -0.20712 58499.9n -0.20712 58500.0n 0.32870 58679.9n 0.32870 58680.0n 0.57446 58859.9n 0.57446 58860.0n 1.23386 59039.9n 1.23386 59040.0n 1.33158 59219.9n 1.33158 59220.0n -0.27694 59399.9n -0.27694 59400.0n -0.17517 59579.9n -0.17517 59580.0n 0.71300 59759.9n 0.71300 59760.0n 1.15161 59939.9n 1.15161 59940.0n 0.66829 60119.9n 0.66829 60120.0n 1.37792 60299.9n 1.37792 60300.0n 0.36518 60479.9n 0.36518 60480.0n 0.65987 60659.9n 0.65987 60660.0n 0.51542 60839.9n 0.51542 60840.0n 0.33904 61019.9n 0.33904 61020.0n 0.59687 61199.9n 0.59687 61200.0n 0.74089 61379.9n 0.74089 61380.0n 0.29878 61559.9n 0.29878 61560.0n -0.28574 61739.9n -0.28574 61740.0n 0.86774 61919.9n 0.86774 61920.0n -0.11225 62099.9n -0.11225 62100.0n 0.40753 62279.9n 0.40753 62280.0n 0.76165 62459.9n 0.76165 62460.0n 0.23585 62639.9n 0.23585 62640.0n 0.71811 62819.9n 0.71811 62820.0n -0.23180 62999.9n -0.23180 63000.0n -0.18224 63179.9n -0.18224 63180.0n 0.43405 63359.9n 0.43405 63360.0n 0.71811 63539.9n 0.71811 63540.0n 0.66829 63719.9n 0.66829 63720.0n -0.27694 63899.9n -0.27694 63900.0n 0.36518 64079.9n 0.36518 64080.0n 0.65987 64259.9n 0.65987 64260.0n 1.15161 64439.9n 1.15161 64440.0n 0.34158 64619.9n 0.34158 64620.0n 1.37792 64799.9n 1.37792 64800.0n 0.43405 64979.9n 0.43405 64980.0n -0.23180 65159.9n -0.23180 65160.0n 1.21828 65339.9n 1.21828 65340.0n -0.20712 65519.9n -0.20712 65520.0n 0.40753 65699.9n 0.40753 65700.0n 0.51542 65879.9n 0.51542 65880.0n -0.28574 66059.9n -0.28574 66060.0n 1.33158 66239.9n 1.33158 66240.0n 0.59687 66419.9n 0.59687 66420.0n 0.70085 66599.9n 0.70085 66600.0n 0.57446 66779.9n 0.57446 66780.0n 0.76165 66959.9n 0.76165 66960.0n -0.11225 67139.9n -0.11225 67140.0n 1.08309 67319.9n 1.08309 67320.0n 1.23386 67499.9n 1.23386 67500.0n 0.74089 67679.9n 0.74089 67680.0n 0.23585 67859.9n 0.23585 67860.0n -0.17517 68039.9n -0.17517 68040.0n 0.33904 68219.9n 0.33904 68220.0n 0.86774 68399.9n 0.86774 68400.0n 0.29878 68579.9n 0.29878 68580.0n 0.71300 68759.9n 0.71300 68760.0n -0.18224 68939.9n -0.18224 68940.0n 0.32870 69119.9n 0.32870 69120.0n 1.23386 69299.9n 1.23386 69300.0n 0.57446 69479.9n 0.57446 69480.0n 0.36518 69659.9n 0.36518 69660.0n 0.59687 69839.9n 0.59687 69840.0n 0.74089 70019.9n 0.74089 70020.0n -0.17517 70199.9n -0.17517 70200.0n -0.11225 70379.9n -0.11225 70380.0n -0.27694 70559.9n -0.27694 70560.0n -0.18224 70739.9n -0.18224 70740.0n 1.08309 70919.9n 1.08309 70920.0n 0.33904 71099.9n 0.33904 71100.0n 0.51542 71279.9n 0.51542 71280.0n 0.71811 71459.9n 0.71811 71460.0n 0.76165 71639.9n 0.76165 71640.0n 0.40753 71819.9n 0.40753 71820.0n 1.37792 71999.9n 1.37792 72000.0n 0.71300 72179.9n 0.71300 72180.0n 0.29878 72359.9n 0.29878 72360.0n 0.43405 72539.9n 0.43405 72540.0n -0.28574 72719.9n -0.28574 72720.0n 1.33158 72899.9n 1.33158 72900.0n 0.34158 73079.9n 0.34158 73080.0n 0.66829 73259.9n 0.66829 73260.0n 0.86774 73439.9n 0.86774 73440.0n 1.15161 73619.9n 1.15161 73620.0n 0.23585 73799.9n 0.23585 73800.0n 0.70085 73979.9n 0.70085 73980.0n 1.21828 74159.9n 1.21828 74160.0n -0.23180 74339.9n -0.23180 74340.0n 0.65987 74519.9n 0.65987 74520.0n 0.32870 74699.9n 0.32870 74700.0n -0.20712 74879.9n -0.20712 74880.0n 1.37792 75059.9n 1.37792 75060.0n 0.29878 75239.9n 0.29878 75240.0n 0.32870 75419.9n 0.32870 75420.0n 0.33904 75599.9n 0.33904 75600.0n 0.23585 75779.9n 0.23585 75780.0n 0.34158 75959.9n 0.34158 75960.0n 0.57446 76139.9n 0.57446 76140.0n 0.71811 76319.9n 0.71811 76320.0n 0.71300 76499.9n 0.71300 76500.0n -0.23180 76679.9n -0.23180 76680.0n 0.66829 76859.9n 0.66829 76860.0n 0.59687 77039.9n 0.59687 77040.0n 0.74089 77219.9n 0.74089 77220.0n -0.20712 77399.9n -0.20712 77400.0n -0.27694 77579.9n -0.27694 77580.0n 0.43405 77759.9n 0.43405 77760.0n 1.33158 77939.9n 1.33158 77940.0n -0.11225 78119.9n -0.11225 78120.0n 0.40753 78299.9n 0.40753 78300.0n 0.76165 78479.9n 0.76165 78480.0n 1.15161 78659.9n 1.15161 78660.0n -0.18224 78839.9n -0.18224 78840.0n -0.17517 79019.9n -0.17517 79020.0n 0.36518 79199.9n 0.36518 79200.0n 0.86774 79379.9n 0.86774 79380.0n 1.23386 79559.9n 1.23386 79560.0n 0.65987 79739.9n 0.65987 79740.0n 0.70085 79919.9n 0.70085 79920.0n 1.21828 80099.9n 1.21828 80100.0n -0.28574 80279.9n -0.28574 80280.0n 1.08309 80459.9n 1.08309 80460.0n 0.51542 80639.9n 0.51542 80640.0n 0.86774 80819.9n 0.86774 80820.0n 1.08309 80999.9n 1.08309 81000.0n 1.23386 81179.9n 1.23386 81180.0n 0.23585 81359.9n 0.23585 81360.0n 0.36518 81539.9n 0.36518 81540.0n 0.74089 81719.9n 0.74089 81720.0n 1.37792 81899.9n 1.37792 81900.0n 0.40753 82079.9n 0.40753 82080.0n 0.65987 82259.9n 0.65987 82260.0n 0.57446 82439.9n 0.57446 82440.0n 0.71811 82619.9n 0.71811 82620.0n 0.76165 82799.9n 0.76165 82800.0n 0.59687 82979.9n 0.59687 82980.0n -0.20712 83159.9n -0.20712 83160.0n -0.27694 83339.9n -0.27694 83340.0n -0.18224 83519.9n -0.18224 83520.0n 0.43405 83699.9n 0.43405 83700.0n 0.32870 83879.9n 0.32870 83880.0n 1.33158 84059.9n 1.33158 84060.0n -0.23180 84239.9n -0.23180 84240.0n 0.70085 84419.9n 0.70085 84420.0n 0.71300 84599.9n 0.71300 84600.0n -0.28574 84779.9n -0.28574 84780.0n 0.66829 84959.9n 0.66829 84960.0n 0.29878 85139.9n 0.29878 85140.0n 0.34158 85319.9n 0.34158 85320.0n 0.33904 85499.9n 0.33904 85500.0n 1.15161 85679.9n 1.15161 85680.0n -0.11225 85859.9n -0.11225 85860.0n 1.21828 86039.9n 1.21828 86040.0n 0.51542 86219.9n 0.51542 86220.0n -0.17517 86399.9n -0.17517 86400.0n -0.27694 86579.9n -0.27694 86580.0n 0.40753 86759.9n 0.40753 86760.0n -0.23180 86939.9n -0.23180 86940.0n 0.29878 87119.9n 0.29878 87120.0n -0.18224 87299.9n -0.18224 87300.0n 0.86774 87479.9n 0.86774 87480.0n 1.21828 87659.9n 1.21828 87660.0n 1.15161 87839.9n 1.15161 87840.0n 0.33904 88019.9n 0.33904 88020.0n -0.17517 88199.9n -0.17517 88200.0n 0.70085 88379.9n 0.70085 88380.0n 0.66829 88559.9n 0.66829 88560.0n 0.36518 88739.9n 0.36518 88740.0n 0.51542 88919.9n 0.51542 88920.0n 1.23386 89099.9n 1.23386 89100.0n 0.57446 89279.9n 0.57446 89280.0n 0.59687 89459.9n 0.59687 89460.0n -0.11225 89639.9n -0.11225 89640.0n 1.08309 89819.9n 1.08309 89820.0n 0.43405 89999.9n 0.43405 90000.0n 0.34158 90179.9n 0.34158 90180.0n 0.74089 90359.9n 0.74089 90360.0n 0.32870 90539.9n 0.32870 90540.0n 1.37792 90719.9n 1.37792 90720.0n 0.76165 90899.9n 0.76165 90900.0n 0.23585 91079.9n 0.23585 91080.0n -0.20712 91259.9n -0.20712 91260.0n 0.71300 91439.9n 0.71300 91440.0n -0.28574 91619.9n -0.28574 91620.0n 0.65987 91799.9n 0.65987 91800.0n 1.33158 91979.9n 1.33158 91980.0n 0.71811 92159.9n 0.71811 92160.0n 1.33158 92339.9n 1.33158 92340.0n 0.70085 92519.9n 0.70085 92520.0n 0.74089 92699.9n 0.74089 92700.0n 0.66829 92879.9n 0.66829 92880.0n -0.28574 93059.9n -0.28574 93060.0n -0.11225 93239.9n -0.11225 93240.0n -0.27694 93419.9n -0.27694 93420.0n 0.51542 93599.9n 0.51542 93600.0n 0.33904 93779.9n 0.33904 93780.0n 1.08309 93959.9n 1.08309 93960.0n -0.17517 94139.9n -0.17517 94140.0n 0.76165 94319.9n 0.76165 94320.0n 1.15161 94499.9n 1.15161 94500.0n 0.23585 94679.9n 0.23585 94680.0n 0.43405 94859.9n 0.43405 94860.0n 0.65987 95039.9n 0.65987 95040.0n 0.57446 95219.9n 0.57446 95220.0n 0.34158 95399.9n 0.34158 95400.0n 0.36518 95579.9n 0.36518 95580.0n 1.21828 95759.9n 1.21828 95760.0n 1.23386 95939.9n 1.23386 95940.0n -0.23180 96119.9n -0.23180 96120.0n 0.32870 96299.9n 0.32870 96300.0n 0.59687 96479.9n 0.59687 96480.0n 0.29878 96659.9n 0.29878 96660.0n -0.20712 96839.9n -0.20712 96840.0n 0.86774 97019.9n 0.86774 97020.0n 0.40753 97199.9n 0.40753 97200.0n 0.71811 97379.9n 0.71811 97380.0n 1.37792 97559.9n 1.37792 97560.0n 0.71300 97739.9n 0.71300 97740.0n -0.18224 97919.9n -0.18224 97920.0n 0.40753 98099.9n 0.40753 98100.0n 1.33158 98279.9n 1.33158 98280.0n -0.11225 98459.9n -0.11225 98460.0n 1.37792 98639.9n 1.37792 98640.0n 1.23386 98819.9n 1.23386 98820.0n 1.21828 98999.9n 1.21828 99000.0n -0.28574 99179.9n -0.28574 99180.0n -0.17517 99359.9n -0.17517 99360.0n 1.15161 99539.9n 1.15161 99540.0n 0.29878 99719.9n 0.29878 99720.0n 0.76165 99899.9n 0.76165 99900.0n -0.20712 100079.9n -0.20712 100080.0n 0.70085 100259.9n 0.70085 100260.0n 0.71811 100439.9n 0.71811 100440.0n 0.86774 100619.9n 0.86774 100620.0n -0.23180 100799.9n -0.23180 100800.0n 0.74089 100979.9n 0.74089 100980.0n 0.32870 101159.9n 0.32870 101160.0n 0.66829 101339.9n 0.66829 101340.0n -0.18224 101519.9n -0.18224 101520.0n -0.27694 101699.9n -0.27694 101700.0n 0.65987 101879.9n 0.65987 101880.0n 0.36518 102059.9n 0.36518 102060.0n 0.23585 102239.9n 0.23585 102240.0n 1.08309 102419.9n 1.08309 102420.0n 0.59687 102599.9n 0.59687 102600.0n 0.51542 102779.9n 0.51542 102780.0n 0.43405 102959.9n 0.43405 102960.0n 0.71300 103139.9n 0.71300 103140.0n 0.57446 103319.9n 0.57446 103320.0n 0.33904 103499.9n 0.33904 103500.0n 0.34158 103679.9n 0.34158 103680.0n -0.27694 103859.9n -0.27694 103860.0n 1.37792 104039.9n 1.37792 104040.0n 1.21828 104219.9n 1.21828 104220.0n 0.71300 104399.9n 0.71300 104400.0n 0.66829 104579.9n 0.66829 104580.0n 0.36518 104759.9n 0.36518 104760.0n 0.71811 104939.9n 0.71811 104940.0n 0.74089 105119.9n 0.74089 105120.0n -0.20712 105299.9n -0.20712 105300.0n -0.18224 105479.9n -0.18224 105480.0n 0.43405 105659.9n 0.43405 105660.0n -0.11225 105839.9n -0.11225 105840.0n 0.34158 106019.9n 0.34158 106020.0n 1.33158 106199.9n 1.33158 106200.0n 0.76165 106379.9n 0.76165 106380.0n 0.40753 106559.9n 0.40753 106560.0n 1.08309 106739.9n 1.08309 106740.0n 0.32870 106919.9n 0.32870 106920.0n 0.51542 107099.9n 0.51542 107100.0n -0.23180 107279.9n -0.23180 107280.0n 0.33904 107459.9n 0.33904 107460.0n 0.70085 107639.9n 0.70085 107640.0n 0.29878 107819.9n 0.29878 107820.0n 1.23386 107999.9n 1.23386 108000.0n 1.15161 108179.9n 1.15161 108180.0n -0.28574 108359.9n -0.28574 108360.0n 0.65987 108539.9n 0.65987 108540.0n 0.86774 108719.9n 0.86774 108720.0n 0.23585 108899.9n 0.23585 108900.0n 0.57446 109079.9n 0.57446 109080.0n 0.59687 109259.9n 0.59687 109260.0n -0.17517 109439.9n -0.17517 109440.0n -0.20712 109619.9n -0.20712 109620.0n -0.11225 109799.9n -0.11225 109800.0n 0.71811 109979.9n 0.71811 109980.0n -0.18224 110159.9n -0.18224 110160.0n -0.28574 110339.9n -0.28574 110340.0n 1.33158 110519.9n 1.33158 110520.0n 0.43405 110699.9n 0.43405 110700.0n -0.27694 110879.9n -0.27694 110880.0n 1.21828 111059.9n 1.21828 111060.0n 0.32870 111239.9n 0.32870 111240.0n 0.74089 111419.9n 0.74089 111420.0n 0.40753 111599.9n 0.40753 111600.0n 0.70085 111779.9n 0.70085 111780.0n 0.36518 111959.9n 0.36518 111960.0n 0.66829 112139.9n 0.66829 112140.0n 0.34158 112319.9n 0.34158 112320.0n 0.76165 112499.9n 0.76165 112500.0n 0.33904 112679.9n 0.33904 112680.0n -0.17517 112859.9n -0.17517 112860.0n 1.23386 113039.9n 1.23386 113040.0n 0.51542 113219.9n 0.51542 113220.0n -0.23180 113399.9n -0.23180 113400.0n 0.57446 113579.9n 0.57446 113580.0n 0.29878 113759.9n 0.29878 113760.0n 1.15161 113939.9n 1.15161 113940.0n 0.86774 114119.9n 0.86774 114120.0n 0.71300 114299.9n 0.71300 114300.0n 0.23585 114479.9n 0.23585 114480.0n 1.08309 114659.9n 1.08309 114660.0n 0.65987 114839.9n 0.65987 114840.0n 0.59687 115019.9n 0.59687 115020.0n 1.37792 115199.9n 1.37792 115200.0n -0.17517 115379.9n -0.17517 115380.0n 1.21828 115559.9n 1.21828 115560.0n 0.70085 115739.9n 0.70085 115740.0n 0.57446 115919.9n 0.57446 115920.0n 1.37792 116099.9n 1.37792 116100.0n 0.43405 116279.9n 0.43405 116280.0n 1.23386 116459.9n 1.23386 116460.0n -0.23180 116639.9n -0.23180 116640.0n 0.71811 116819.9n 0.71811 116820.0n 0.65987 116999.9n 0.65987 117000.0n -0.20712 117179.9n -0.20712 117180.0n 0.40753 117359.9n 0.40753 117360.0n 0.36518 117539.9n 0.36518 117540.0n 0.71300 117719.9n 0.71300 117720.0n 0.59687 117899.9n 0.59687 117900.0n 0.86774 118079.9n 0.86774 118080.0n -0.18224 118259.9n -0.18224 118260.0n 0.33904 118439.9n 0.33904 118440.0n -0.27694 118619.9n -0.27694 118620.0n -0.11225 118799.9n -0.11225 118800.0n 0.66829 118979.9n 0.66829 118980.0n 0.76165 119159.9n 0.76165 119160.0n 0.34158 119339.9n 0.34158 119340.0n 0.23585 119519.9n 0.23585 119520.0n 0.51542 119699.9n 0.51542 119700.0n 0.74089 119879.9n 0.74089 119880.0n 1.15161 120059.9n 1.15161 120060.0n -0.28574 120239.9n -0.28574 120240.0n 0.32870 120419.9n 0.32870 120420.0n 0.29878 120599.9n 0.29878 120600.0n 1.08309 120779.9n 1.08309 120780.0n 1.33158 120959.9n 1.33158 120960.0n -0.17517 121139.9n -0.17517 121140.0n -0.27694 121319.9n -0.27694 121320.0n 0.76165 121499.9n 0.76165 121500.0n 1.15161 121679.9n 1.15161 121680.0n -0.18224 121859.9n -0.18224 121860.0n 0.71811 122039.9n 0.71811 122040.0n 0.74089 122219.9n 0.74089 122220.0n 0.32870 122399.9n 0.32870 122400.0n 1.21828 122579.9n 1.21828 122580.0n 0.23585 122759.9n 0.23585 122760.0n 0.33904 122939.9n 0.33904 122940.0n 0.71300 123119.9n 0.71300 123120.0n 0.36518 123299.9n 0.36518 123300.0n -0.11225 123479.9n -0.11225 123480.0n 1.37792 123659.9n 1.37792 123660.0n 1.23386 123839.9n 1.23386 123840.0n 0.70085 124019.9n 0.70085 124020.0n 0.59687 124199.9n 0.59687 124200.0n 0.86774 124379.9n 0.86774 124380.0n 0.65987 124559.9n 0.65987 124560.0n 0.34158 124739.9n 0.34158 124740.0n 0.43405 124919.9n 0.43405 124920.0n 0.40753 125099.9n 0.40753 125100.0n 1.08309 125279.9n 1.08309 125280.0n -0.28574 125459.9n -0.28574 125460.0n -0.20712 125639.9n -0.20712 125640.0n 0.57446 125819.9n 0.57446 125820.0n 0.29878 125999.9n 0.29878 126000.0n 1.33158 126179.9n 1.33158 126180.0n 0.66829 126359.9n 0.66829 126360.0n -0.23180 126539.9n -0.23180 126540.0n 0.51542 126719.9n 0.51542 126720.0n -0.27694 126899.9n -0.27694 126900.0n 1.08309 127079.9n 1.08309 127080.0n 1.37792 127259.9n 1.37792 127260.0n -0.17517 127439.9n -0.17517 127440.0n 0.86774 127619.9n 0.86774 127620.0n 0.32870 127799.9n 0.32870 127800.0n -0.28574 127979.9n -0.28574 127980.0n 0.40753 128159.9n 0.40753 128160.0n 0.43405 128339.9n 0.43405 128340.0n 0.57446 128519.9n 0.57446 128520.0n 0.34158 128699.9n 0.34158 128700.0n 0.71811 128879.9n 0.71811 128880.0n 1.21828 129059.9n 1.21828 129060.0n 0.74089 129239.9n 0.74089 129240.0n 0.36518 129419.9n 0.36518 129420.0n 0.66829 129599.9n 0.66829 129600.0n 1.23386 129779.9n 1.23386 129780.0n 0.33904 129959.9n 0.33904 129960.0n 0.51542 130139.9n 0.51542 130140.0n 0.59687 130319.9n 0.59687 130320.0n 0.76165 130499.9n 0.76165 130500.0n -0.20712 130679.9n -0.20712 130680.0n 0.71300 130859.9n 0.71300 130860.0n -0.11225 131039.9n -0.11225 131040.0n 0.23585 131219.9n 0.23585 131220.0n 0.29878 131399.9n 0.29878 131400.0n -0.18224 131579.9n -0.18224 131580.0n 0.70085 131759.9n 0.70085 131760.0n -0.23180 131939.9n -0.23180 131940.0n 1.33158 132119.9n 1.33158 132120.0n 0.65987 132299.9n 0.65987 132300.0n 1.15161 132479.9n 1.15161 132480.0n 0.86774 132659.9n 0.86774 132660.0n 1.33158 132839.9n 1.33158 132840.0n 0.33904 133019.9n 0.33904 133020.0n 0.34158 133199.9n 0.34158 133200.0n 1.21828 133379.9n 1.21828 133380.0n 1.15161 133559.9n 1.15161 133560.0n -0.11225 133739.9n -0.11225 133740.0n 1.23386 133919.9n 1.23386 133920.0n 0.40753 134099.9n 0.40753 134100.0n 1.08309 134279.9n 1.08309 134280.0n 0.51542 134459.9n 0.51542 134460.0n 0.59687 134639.9n 0.59687 134640.0n -0.17517 134819.9n -0.17517 134820.0n -0.23180 134999.9n -0.23180 135000.0n 0.74089 135179.9n 0.74089 135180.0n 0.32870 135359.9n 0.32870 135360.0n 0.57446 135539.9n 0.57446 135540.0n 0.71811 135719.9n 0.71811 135720.0n 1.37792 135899.9n 1.37792 135900.0n 0.29878 136079.9n 0.29878 136080.0n -0.20712 136259.9n -0.20712 136260.0n 0.66829 136439.9n 0.66829 136440.0n -0.27694 136619.9n -0.27694 136620.0n 0.36518 136799.9n 0.36518 136800.0n 0.65987 136979.9n 0.65987 136980.0n 0.23585 137159.9n 0.23585 137160.0n 0.43405 137339.9n 0.43405 137340.0n 0.70085 137519.9n 0.70085 137520.0n -0.28574 137699.9n -0.28574 137700.0n 0.76165 137879.9n 0.76165 137880.0n -0.18224 138059.9n -0.18224 138060.0n 0.71300 138239.9n 0.71300 138240.0n 0.71811 138419.9n 0.71811 138420.0n 0.43405 138599.9n 0.43405 138600.0n 0.76165 138779.9n 0.76165 138780.0n 0.70085 138959.9n 0.70085 138960.0n 0.23585 139139.9n 0.23585 139140.0n 1.08309 139319.9n 1.08309 139320.0n 1.21828 139499.9n 1.21828 139500.0n 0.57446 139679.9n 0.57446 139680.0n 0.59687 139859.9n 0.59687 139860.0n -0.27694 140039.9n -0.27694 140040.0n 0.71300 140219.9n 0.71300 140220.0n 1.33158 140399.9n 1.33158 140400.0n 0.32870 140579.9n 0.32870 140580.0n 0.33904 140759.9n 0.33904 140760.0n 1.15161 140939.9n 1.15161 140940.0n 0.74089 141119.9n 0.74089 141120.0n -0.18224 141299.9n -0.18224 141300.0n 0.65987 141479.9n 0.65987 141480.0n 0.51542 141659.9n 0.51542 141660.0n -0.17517 141839.9n -0.17517 141840.0n 0.40753 142019.9n 0.40753 142020.0n 0.34158 142199.9n 0.34158 142200.0n 0.29878 142379.9n 0.29878 142380.0n 0.66829 142559.9n 0.66829 142560.0n -0.20712 142739.9n -0.20712 142740.0n 0.86774 142919.9n 0.86774 142920.0n -0.28574 143099.9n -0.28574 143100.0n 1.37792 143279.9n 1.37792 143280.0n 0.36518 143459.9n 0.36518 143460.0n 1.23386 143639.9n 1.23386 143640.0n -0.11225 143819.9n -0.11225 143820.0n -0.23180 143999.9n -0.23180 144000.0n -0.28574 144179.9n -0.28574 144180.0n 0.29878 144359.9n 0.29878 144360.0n 0.36518 144539.9n 0.36518 144540.0n 0.86774 144719.9n 0.86774 144720.0n -0.11225 144899.9n -0.11225 144900.0n 0.76165 145079.9n 0.76165 145080.0n 0.65987 145259.9n 0.65987 145260.0n 0.32870 145439.9n 0.32870 145440.0n 0.70085 145619.9n 0.70085 145620.0n 0.66829 145799.9n 0.66829 145800.0n 0.74089 145979.9n 0.74089 145980.0n -0.20712 146159.9n -0.20712 146160.0n 1.15161 146339.9n 1.15161 146340.0n 1.37792 146519.9n 1.37792 146520.0n 0.33904 146699.9n 0.33904 146700.0n 1.23386 146879.9n 1.23386 146880.0n 0.23585 147059.9n 0.23585 147060.0n 0.34158 147239.9n 0.34158 147240.0n 0.40753 147419.9n 0.40753 147420.0n 0.71811 147599.9n 0.71811 147600.0n 0.57446 147779.9n 0.57446 147780.0n 0.59687 147959.9n 0.59687 147960.0n 1.33158 148139.9n 1.33158 148140.0n 0.43405 148319.9n 0.43405 148320.0n -0.17517 148499.9n -0.17517 148500.0n -0.18224 148679.9n -0.18224 148680.0n 0.71300 148859.9n 0.71300 148860.0n -0.23180 149039.9n -0.23180 149040.0n -0.27694 149219.9n -0.27694 149220.0n 0.51542 149399.9n 0.51542 149400.0n 1.21828 149579.9n 1.21828 149580.0n 1.08309 149759.9n 1.08309 149760.0n 0.71300 149939.9n 0.71300 149940.0n 1.37792 150119.9n 1.37792 150120.0n 0.59687 150299.9n 0.59687 150300.0n 0.43405 150479.9n 0.43405 150480.0n 1.33158 150659.9n 1.33158 150660.0n 1.21828 150839.9n 1.21828 150840.0n 0.51542 151019.9n 0.51542 151020.0n 0.34158 151199.9n 0.34158 151200.0n 0.36518 151379.9n 0.36518 151380.0n 0.65987 151559.9n 0.65987 151560.0n 0.71811 151739.9n 0.71811 151740.0n 0.86774 151919.9n 0.86774 151920.0n 0.76165 152099.9n 0.76165 152100.0n 0.40753 152279.9n 0.40753 152280.0n 1.23386 152459.9n 1.23386 152460.0n 0.66829 152639.9n 0.66829 152640.0n 0.32870 152819.9n 0.32870 152820.0n 0.33904 152999.9n 0.33904 153000.0n -0.28574 153179.9n -0.28574 153180.0n 0.70085 153359.9n 0.70085 153360.0n 0.23585 153539.9n 0.23585 153540.0n 1.15161 153719.9n 1.15161 153720.0n -0.23180 153899.9n -0.23180 153900.0n -0.20712 154079.9n -0.20712 154080.0n -0.17517 154259.9n -0.17517 154260.0n 0.74089 154439.9n 0.74089 154440.0n -0.11225 154619.9n -0.11225 154620.0n 0.29878 154799.9n 0.29878 154800.0n 1.08309 154979.9n 1.08309 154980.0n -0.27694 155159.9n -0.27694 155160.0n -0.18224 155339.9n -0.18224 155340.0n 0.57446 155519.9n 0.57446 155520.0n 0.86774 155699.9n 0.86774 155700.0n 0.36518 155879.9n 0.36518 155880.0n -0.27694 156059.9n -0.27694 156060.0n 0.23585 156239.9n 0.23585 156240.0n 1.33158 156419.9n 1.33158 156420.0n 0.32870 156599.9n 0.32870 156600.0n 0.33904 156779.9n 0.33904 156780.0n 0.57446 156959.9n 0.57446 156960.0n 0.51542 157139.9n 0.51542 157140.0n 0.59687 157319.9n 0.59687 157320.0n -0.20712 157499.9n -0.20712 157500.0n 1.21828 157679.9n 1.21828 157680.0n 0.40753 157859.9n 0.40753 157860.0n -0.23180 158039.9n -0.23180 158040.0n 0.74089 158219.9n 0.74089 158220.0n -0.11225 158399.9n -0.11225 158400.0n 0.70085 158579.9n 0.70085 158580.0n 0.34158 158759.9n 0.34158 158760.0n 0.76165 158939.9n 0.76165 158940.0n 0.71811 159119.9n 0.71811 159120.0n 1.37792 159299.9n 1.37792 159300.0n 1.23386 159479.9n 1.23386 159480.0n 0.65987 159659.9n 0.65987 159660.0n 0.43405 159839.9n 0.43405 159840.0n 1.15161 160019.9n 1.15161 160020.0n 0.71300 160199.9n 0.71300 160200.0n -0.17517 160379.9n -0.17517 160380.0n -0.18224 160559.9n -0.18224 160560.0n -0.28574 160739.9n -0.28574 160740.0n 0.66829 160919.9n 0.66829 160920.0n 1.08309 161099.9n 1.08309 161100.0n 0.29878 161279.9n 0.29878 161280.0n 1.21828 161459.9n 1.21828 161460.0n -0.18224 161639.9n -0.18224 161640.0n 0.23585 161819.9n 0.23585 161820.0n 1.23386 161999.9n 1.23386 162000.0n 0.43405 162179.9n 0.43405 162180.0n -0.20712 162359.9n -0.20712 162360.0n 0.32870 162539.9n 0.32870 162540.0n 0.66829 162719.9n 0.66829 162720.0n 1.08309 162899.9n 1.08309 162900.0n 0.86774 163079.9n 0.86774 163080.0n 0.74089 163259.9n 0.74089 163260.0n 1.37792 163439.9n 1.37792 163440.0n 0.65987 163619.9n 0.65987 163620.0n 0.40753 163799.9n 0.40753 163800.0n 0.36518 163979.9n 0.36518 163980.0n 0.59687 164159.9n 0.59687 164160.0n -0.17517 164339.9n -0.17517 164340.0n 0.34158 164519.9n 0.34158 164520.0n 0.71811 164699.9n 0.71811 164700.0n -0.27694 164879.9n -0.27694 164880.0n 0.70085 165059.9n 0.70085 165060.0n 0.33904 165239.9n 0.33904 165240.0n -0.11225 165419.9n -0.11225 165420.0n 0.51542 165599.9n 0.51542 165600.0n -0.23180 165779.9n -0.23180 165780.0n -0.28574 165959.9n -0.28574 165960.0n 0.29878 166139.9n 0.29878 166140.0n 1.15161 166319.9n 1.15161 166320.0n 1.33158 166499.9n 1.33158 166500.0n 0.76165 166679.9n 0.76165 166680.0n 0.71300 166859.9n 0.71300 166860.0n 0.57446 167039.9n 0.57446 167040.0n 0.66829 167219.9n 0.66829 167220.0n 0.51542 167399.9n 0.51542 167400.0n 0.86774 167579.9n 0.86774 167580.0n 1.23386 167759.9n 1.23386 167760.0n -0.27694 167939.9n -0.27694 167940.0n 0.57446 168119.9n 0.57446 168120.0n 1.37792 168299.9n 1.37792 168300.0n -0.23180 168479.9n -0.23180 168480.0n 0.74089 168659.9n 0.74089 168660.0n 1.08309 168839.9n 1.08309 168840.0n 1.33158 169019.9n 1.33158 169020.0n 0.65987 169199.9n 0.65987 169200.0n 0.70085 169379.9n 0.70085 169380.0n 1.21828 169559.9n 1.21828 169560.0n 0.29878 169739.9n 0.29878 169740.0n 1.15161 169919.9n 1.15161 169920.0n -0.18224 170099.9n -0.18224 170100.0n -0.11225 170279.9n -0.11225 170280.0n 0.71300 170459.9n 0.71300 170460.0n 0.36518 170639.9n 0.36518 170640.0n 0.76165 170819.9n 0.76165 170820.0n 0.23585 170999.9n 0.23585 171000.0n 0.40753 171179.9n 0.40753 171180.0n 0.71811 171359.9n 0.71811 171360.0n -0.20712 171539.9n -0.20712 171540.0n 0.59687 171719.9n 0.59687 171720.0n 0.34158 171899.9n 0.34158 171900.0n -0.28574 172079.9n -0.28574 172080.0n -0.17517 172259.9n -0.17517 172260.0n 0.33904 172439.9n 0.33904 172440.0n 0.32870 172619.9n 0.32870 172620.0n 0.43405 172799.9n 0.43405 172800.0n 0.63424 172979.9n 0.63424 172980.0n 0.66270 173159.9n 0.66270 173160.0n 0.61615 173339.9n 0.61615 173340.0n 0.40294 173519.9n 0.40294 173520.0n 0.37693 173699.9n 0.37693 173700.0n 0.32982 173879.9n 0.32982 173880.0n 0.29460 174059.9n 0.29460 174060.0n 0.46418 174239.9n 0.46418 174240.0n 0.66643 174419.9n 0.66643 174420.0n 0.47115 174599.9n 0.47115 174600.0n 0.25617 174779.9n 0.25617 174780.0n 0.21591 174959.9n 0.21591 174960.0n 0.48064 175139.9n 0.48064 175140.0n 0.49468 175319.9n 0.49468 175320.0n 0.31811 175499.9n 0.31811 175500.0n 0.20138 175679.9n 0.20138 175680.0n 0.64950 175859.9n 0.64950 175860.0n 0.83142 176039.9n 0.83142 176040.0n 0.44747 176219.9n 0.44747 176220.0n 0.39177 176399.9n 0.39177 176400.0n 0.36389 176579.9n 0.36389 176580.0n 0.58803 176759.9n 0.58803 176760.0n 0.30587 176939.9n 0.30587 176940.0n 0.41543 177119.9n 0.41543 177120.0n 0.66249 177299.9n 0.66249 177300.0n 0.28619 177479.9n 0.28619 177480.0n 0.35734 177659.9n 0.35734 177660.0n 0.83982 177839.9n 0.83982 177840.0n 0.21843 178019.9n 0.21843 178020.0n 0.77797 178199.9n 0.77797 178200.0n 0.12598 178379.9n 0.12598 178380.0n 1.10545 178559.9n 1.10545 178560.0n 1.25282 178739.9n 1.25282 178740.0n 1.37666 178919.9n 1.37666 178920.0n -0.43391 179099.9n -0.43391 179100.0n 0.62489 179279.9n 0.62489 179280.0n 0.64220 179459.9n 0.64220 179460.0n -0.04281 179639.9n -0.04281 179640.0n -0.30757 179819.9n -0.30757 179820.0n 1.27950 179999.9n 1.27950 180000.0n 0.89863 180179.9n 0.89863 180180.0n -0.20727 180359.9n -0.20727 180360.0n -0.40210 180539.9n -0.40210 180540.0n -0.03003 180719.9n -0.03003 180720.0n 1.27250 180899.9n 1.27250 180900.0n 1.24444 181079.9n 1.24444 181080.0n 0.18165 181259.9n 0.18165 181260.0n 0.88208 181439.9n 0.88208 181440.0n 1.41822 181619.9n 1.41822 181620.0n 0.24758 181799.9n 0.24758 181800.0n 0.42646 181979.9n 0.42646 181980.0n -0.22124 182159.9n -0.22124 182160.0n -0.07258 182339.9n -0.07258 182340.0n -0.14286 182519.9n -0.14286 182520.0n 1.14226 182699.9n 1.14226 182700.0n -0.32817 182879.9n -0.32817 182880.0n -0.08864 183059.9n -0.08864 183060.0n -0.09055 183239.9n -0.09055 183240.0n -0.50665 183419.9n -0.50665 183420.0n 1.21520)
Vxp2 a_xp2 0 PWL(0.0n 0.80000 179.9n 0.80000 180.0n 0.80000 359.9n 0.80000 360.0n 0.80000 539.9n 0.80000 540.0n 0.80000 719.9n 0.80000 720.0n 0.80000 899.9n 0.80000 900.0n 0.80000 1079.9n 0.80000 1080.0n 0.80000 1259.9n 0.80000 1260.0n 0.80000 1439.9n 0.80000 1440.0n 0.80000 1619.9n 0.80000 1620.0n 0.80000 1799.9n 0.80000 1800.0n 0.80000 1979.9n 0.80000 1980.0n 0.80000 2159.9n 0.80000 2160.0n 0.80000 2339.9n 0.80000 2340.0n 0.80000 2519.9n 0.80000 2520.0n 0.80000 2699.9n 0.80000 2700.0n 0.80000 2879.9n 0.80000 2880.0n 0.80000 3059.9n 0.80000 3060.0n 0.80000 3239.9n 0.80000 3240.0n 0.80000 3419.9n 0.80000 3420.0n 0.80000 3599.9n 0.80000 3600.0n 0.80000 3779.9n 0.80000 3780.0n 0.80000 3959.9n 0.80000 3960.0n 0.80000 4139.9n 0.80000 4140.0n 0.80000 4319.9n 0.80000 4320.0n 0.80000 4499.9n 0.80000 4500.0n 0.80000 4679.9n 0.80000 4680.0n 0.80000 4859.9n 0.80000 4860.0n 0.80000 5039.9n 0.80000 5040.0n 0.80000 5219.9n 0.80000 5220.0n 0.80000 5399.9n 0.80000 5400.0n 0.80000 5579.9n 0.80000 5580.0n 0.80000 5759.9n 0.80000 5760.0n 0.80000 5939.9n 0.80000 5940.0n 0.80000 6119.9n 0.80000 6120.0n 0.80000 6299.9n 0.80000 6300.0n 0.80000 6479.9n 0.80000 6480.0n 0.80000 6659.9n 0.80000 6660.0n 0.80000 6839.9n 0.80000 6840.0n 0.80000 7019.9n 0.80000 7020.0n 0.80000 7199.9n 0.80000 7200.0n 0.80000 7379.9n 0.80000 7380.0n 0.80000 7559.9n 0.80000 7560.0n 0.80000 7739.9n 0.80000 7740.0n 0.80000 7919.9n 0.80000 7920.0n 0.80000 8099.9n 0.80000 8100.0n 0.80000 8279.9n 0.80000 8280.0n 0.80000 8459.9n 0.80000 8460.0n 0.80000 8639.9n 0.80000 8640.0n 0.80000 8819.9n 0.80000 8820.0n 0.80000 8999.9n 0.80000 9000.0n 0.80000 9179.9n 0.80000 9180.0n 0.80000 9359.9n 0.80000 9360.0n 0.80000 9539.9n 0.80000 9540.0n 0.80000 9719.9n 0.80000 9720.0n 0.80000 9899.9n 0.80000 9900.0n 0.80000 10079.9n 0.80000 10080.0n 0.80000 10259.9n 0.80000 10260.0n 0.80000 10439.9n 0.80000 10440.0n 0.80000 10619.9n 0.80000 10620.0n 0.80000 10799.9n 0.80000 10800.0n 0.80000 10979.9n 0.80000 10980.0n 0.80000 11159.9n 0.80000 11160.0n 0.80000 11339.9n 0.80000 11340.0n 0.80000 11519.9n 0.80000 11520.0n 0.80000 11699.9n 0.80000 11700.0n 0.80000 11879.9n 0.80000 11880.0n 0.80000 12059.9n 0.80000 12060.0n 0.80000 12239.9n 0.80000 12240.0n 0.80000 12419.9n 0.80000 12420.0n 0.80000 12599.9n 0.80000 12600.0n 0.80000 12779.9n 0.80000 12780.0n 0.80000 12959.9n 0.80000 12960.0n 0.80000 13139.9n 0.80000 13140.0n 0.80000 13319.9n 0.80000 13320.0n 0.80000 13499.9n 0.80000 13500.0n 0.80000 13679.9n 0.80000 13680.0n 0.80000 13859.9n 0.80000 13860.0n 0.80000 14039.9n 0.80000 14040.0n 0.80000 14219.9n 0.80000 14220.0n 0.80000 14399.9n 0.80000 14400.0n 0.80000 14579.9n 0.80000 14580.0n 0.80000 14759.9n 0.80000 14760.0n 0.80000 14939.9n 0.80000 14940.0n 0.80000 15119.9n 0.80000 15120.0n 0.80000 15299.9n 0.80000 15300.0n 0.80000 15479.9n 0.80000 15480.0n 0.80000 15659.9n 0.80000 15660.0n 0.80000 15839.9n 0.80000 15840.0n 0.80000 16019.9n 0.80000 16020.0n 0.80000 16199.9n 0.80000 16200.0n 0.80000 16379.9n 0.80000 16380.0n 0.80000 16559.9n 0.80000 16560.0n 0.80000 16739.9n 0.80000 16740.0n 0.80000 16919.9n 0.80000 16920.0n 0.80000 17099.9n 0.80000 17100.0n 0.80000 17279.9n 0.80000 17280.0n 0.80000 17459.9n 0.80000 17460.0n 0.80000 17639.9n 0.80000 17640.0n 0.80000 17819.9n 0.80000 17820.0n 0.80000 17999.9n 0.80000 18000.0n 0.80000 18179.9n 0.80000 18180.0n 0.80000 18359.9n 0.80000 18360.0n 0.80000 18539.9n 0.80000 18540.0n 0.80000 18719.9n 0.80000 18720.0n 0.80000 18899.9n 0.80000 18900.0n 0.80000 19079.9n 0.80000 19080.0n 0.80000 19259.9n 0.80000 19260.0n 0.80000 19439.9n 0.80000 19440.0n 0.80000 19619.9n 0.80000 19620.0n 0.80000 19799.9n 0.80000 19800.0n 0.80000 19979.9n 0.80000 19980.0n 0.80000 20159.9n 0.80000 20160.0n 0.80000 20339.9n 0.80000 20340.0n 0.80000 20519.9n 0.80000 20520.0n 0.80000 20699.9n 0.80000 20700.0n 0.80000 20879.9n 0.80000 20880.0n 0.80000 21059.9n 0.80000 21060.0n 0.80000 21239.9n 0.80000 21240.0n 0.80000 21419.9n 0.80000 21420.0n 0.80000 21599.9n 0.80000 21600.0n 0.80000 21779.9n 0.80000 21780.0n 0.80000 21959.9n 0.80000 21960.0n 0.80000 22139.9n 0.80000 22140.0n 0.80000 22319.9n 0.80000 22320.0n 0.80000 22499.9n 0.80000 22500.0n 0.80000 22679.9n 0.80000 22680.0n 0.80000 22859.9n 0.80000 22860.0n 0.80000 23039.9n 0.80000 23040.0n 0.80000 23219.9n 0.80000 23220.0n 0.80000 23399.9n 0.80000 23400.0n 0.80000 23579.9n 0.80000 23580.0n 0.80000 23759.9n 0.80000 23760.0n 0.80000 23939.9n 0.80000 23940.0n 0.80000 24119.9n 0.80000 24120.0n 0.80000 24299.9n 0.80000 24300.0n 0.80000 24479.9n 0.80000 24480.0n 0.80000 24659.9n 0.80000 24660.0n 0.80000 24839.9n 0.80000 24840.0n 0.80000 25019.9n 0.80000 25020.0n 0.80000 25199.9n 0.80000 25200.0n 0.80000 25379.9n 0.80000 25380.0n 0.80000 25559.9n 0.80000 25560.0n 0.80000 25739.9n 0.80000 25740.0n 0.80000 25919.9n 0.80000 25920.0n 0.80000 26099.9n 0.80000 26100.0n 0.80000 26279.9n 0.80000 26280.0n 0.80000 26459.9n 0.80000 26460.0n 0.80000 26639.9n 0.80000 26640.0n 0.80000 26819.9n 0.80000 26820.0n 0.80000 26999.9n 0.80000 27000.0n 0.80000 27179.9n 0.80000 27180.0n 0.80000 27359.9n 0.80000 27360.0n 0.80000 27539.9n 0.80000 27540.0n 0.80000 27719.9n 0.80000 27720.0n 0.80000 27899.9n 0.80000 27900.0n 0.80000 28079.9n 0.80000 28080.0n 0.80000 28259.9n 0.80000 28260.0n 0.80000 28439.9n 0.80000 28440.0n 0.80000 28619.9n 0.80000 28620.0n 0.80000 28799.9n 0.80000 28800.0n 0.80000 28979.9n 0.80000 28980.0n 0.80000 29159.9n 0.80000 29160.0n 0.80000 29339.9n 0.80000 29340.0n 0.80000 29519.9n 0.80000 29520.0n 0.80000 29699.9n 0.80000 29700.0n 0.80000 29879.9n 0.80000 29880.0n 0.80000 30059.9n 0.80000 30060.0n 0.80000 30239.9n 0.80000 30240.0n 0.80000 30419.9n 0.80000 30420.0n 0.80000 30599.9n 0.80000 30600.0n 0.80000 30779.9n 0.80000 30780.0n 0.80000 30959.9n 0.80000 30960.0n 0.80000 31139.9n 0.80000 31140.0n 0.80000 31319.9n 0.80000 31320.0n 0.80000 31499.9n 0.80000 31500.0n 0.80000 31679.9n 0.80000 31680.0n 0.80000 31859.9n 0.80000 31860.0n 0.80000 32039.9n 0.80000 32040.0n 0.80000 32219.9n 0.80000 32220.0n 0.80000 32399.9n 0.80000 32400.0n 0.80000 32579.9n 0.80000 32580.0n 0.80000 32759.9n 0.80000 32760.0n 0.80000 32939.9n 0.80000 32940.0n 0.80000 33119.9n 0.80000 33120.0n 0.80000 33299.9n 0.80000 33300.0n 0.80000 33479.9n 0.80000 33480.0n 0.80000 33659.9n 0.80000 33660.0n 0.80000 33839.9n 0.80000 33840.0n 0.80000 34019.9n 0.80000 34020.0n 0.80000 34199.9n 0.80000 34200.0n 0.80000 34379.9n 0.80000 34380.0n 0.80000 34559.9n 0.80000 34560.0n 0.80000 34739.9n 0.80000 34740.0n 0.80000 34919.9n 0.80000 34920.0n 0.80000 35099.9n 0.80000 35100.0n 0.80000 35279.9n 0.80000 35280.0n 0.80000 35459.9n 0.80000 35460.0n 0.80000 35639.9n 0.80000 35640.0n 0.80000 35819.9n 0.80000 35820.0n 0.80000 35999.9n 0.80000 36000.0n 0.80000 36179.9n 0.80000 36180.0n 0.80000 36359.9n 0.80000 36360.0n 0.80000 36539.9n 0.80000 36540.0n 0.80000 36719.9n 0.80000 36720.0n 0.80000 36899.9n 0.80000 36900.0n 0.80000 37079.9n 0.80000 37080.0n 0.80000 37259.9n 0.80000 37260.0n 0.80000 37439.9n 0.80000 37440.0n 0.80000 37619.9n 0.80000 37620.0n 0.80000 37799.9n 0.80000 37800.0n 0.80000 37979.9n 0.80000 37980.0n 0.80000 38159.9n 0.80000 38160.0n 0.80000 38339.9n 0.80000 38340.0n 0.80000 38519.9n 0.80000 38520.0n 0.80000 38699.9n 0.80000 38700.0n 0.80000 38879.9n 0.80000 38880.0n 0.80000 39059.9n 0.80000 39060.0n 0.80000 39239.9n 0.80000 39240.0n 0.80000 39419.9n 0.80000 39420.0n 0.80000 39599.9n 0.80000 39600.0n 0.80000 39779.9n 0.80000 39780.0n 0.80000 39959.9n 0.80000 39960.0n 0.80000 40139.9n 0.80000 40140.0n 0.80000 40319.9n 0.80000 40320.0n 0.80000 40499.9n 0.80000 40500.0n 0.80000 40679.9n 0.80000 40680.0n 0.80000 40859.9n 0.80000 40860.0n 0.80000 41039.9n 0.80000 41040.0n 0.80000 41219.9n 0.80000 41220.0n 0.80000 41399.9n 0.80000 41400.0n 0.80000 41579.9n 0.80000 41580.0n 0.80000 41759.9n 0.80000 41760.0n 0.80000 41939.9n 0.80000 41940.0n 0.80000 42119.9n 0.80000 42120.0n 0.80000 42299.9n 0.80000 42300.0n 0.80000 42479.9n 0.80000 42480.0n 0.80000 42659.9n 0.80000 42660.0n 0.80000 42839.9n 0.80000 42840.0n 0.80000 43019.9n 0.80000 43020.0n 0.80000 43199.9n 0.80000 43200.0n 0.80000 43379.9n 0.80000 43380.0n 0.80000 43559.9n 0.80000 43560.0n 0.80000 43739.9n 0.80000 43740.0n 0.80000 43919.9n 0.80000 43920.0n 0.80000 44099.9n 0.80000 44100.0n 0.80000 44279.9n 0.80000 44280.0n 0.80000 44459.9n 0.80000 44460.0n 0.80000 44639.9n 0.80000 44640.0n 0.80000 44819.9n 0.80000 44820.0n 0.80000 44999.9n 0.80000 45000.0n 0.80000 45179.9n 0.80000 45180.0n 0.80000 45359.9n 0.80000 45360.0n 0.80000 45539.9n 0.80000 45540.0n 0.80000 45719.9n 0.80000 45720.0n 0.80000 45899.9n 0.80000 45900.0n 0.80000 46079.9n 0.80000 46080.0n 0.80000 46259.9n 0.80000 46260.0n 0.80000 46439.9n 0.80000 46440.0n 0.80000 46619.9n 0.80000 46620.0n 0.80000 46799.9n 0.80000 46800.0n 0.80000 46979.9n 0.80000 46980.0n 0.80000 47159.9n 0.80000 47160.0n 0.80000 47339.9n 0.80000 47340.0n 0.80000 47519.9n 0.80000 47520.0n 0.80000 47699.9n 0.80000 47700.0n 0.80000 47879.9n 0.80000 47880.0n 0.80000 48059.9n 0.80000 48060.0n 0.80000 48239.9n 0.80000 48240.0n 0.80000 48419.9n 0.80000 48420.0n 0.80000 48599.9n 0.80000 48600.0n 0.80000 48779.9n 0.80000 48780.0n 0.80000 48959.9n 0.80000 48960.0n 0.80000 49139.9n 0.80000 49140.0n 0.80000 49319.9n 0.80000 49320.0n 0.80000 49499.9n 0.80000 49500.0n 0.80000 49679.9n 0.80000 49680.0n 0.80000 49859.9n 0.80000 49860.0n 0.80000 50039.9n 0.80000 50040.0n 0.80000 50219.9n 0.80000 50220.0n 0.80000 50399.9n 0.80000 50400.0n 0.80000 50579.9n 0.80000 50580.0n 0.80000 50759.9n 0.80000 50760.0n 0.80000 50939.9n 0.80000 50940.0n 0.80000 51119.9n 0.80000 51120.0n 0.80000 51299.9n 0.80000 51300.0n 0.80000 51479.9n 0.80000 51480.0n 0.80000 51659.9n 0.80000 51660.0n 0.80000 51839.9n 0.80000 51840.0n 0.80000 52019.9n 0.80000 52020.0n 0.80000 52199.9n 0.80000 52200.0n 0.80000 52379.9n 0.80000 52380.0n 0.80000 52559.9n 0.80000 52560.0n 0.80000 52739.9n 0.80000 52740.0n 0.80000 52919.9n 0.80000 52920.0n 0.80000 53099.9n 0.80000 53100.0n 0.80000 53279.9n 0.80000 53280.0n 0.80000 53459.9n 0.80000 53460.0n 0.80000 53639.9n 0.80000 53640.0n 0.80000 53819.9n 0.80000 53820.0n 0.80000 53999.9n 0.80000 54000.0n 0.80000 54179.9n 0.80000 54180.0n 0.80000 54359.9n 0.80000 54360.0n 0.80000 54539.9n 0.80000 54540.0n 0.80000 54719.9n 0.80000 54720.0n 0.80000 54899.9n 0.80000 54900.0n 0.80000 55079.9n 0.80000 55080.0n 0.80000 55259.9n 0.80000 55260.0n 0.80000 55439.9n 0.80000 55440.0n 0.80000 55619.9n 0.80000 55620.0n 0.80000 55799.9n 0.80000 55800.0n 0.80000 55979.9n 0.80000 55980.0n 0.80000 56159.9n 0.80000 56160.0n 0.80000 56339.9n 0.80000 56340.0n 0.80000 56519.9n 0.80000 56520.0n 0.80000 56699.9n 0.80000 56700.0n 0.80000 56879.9n 0.80000 56880.0n 0.80000 57059.9n 0.80000 57060.0n 0.80000 57239.9n 0.80000 57240.0n 0.80000 57419.9n 0.80000 57420.0n 0.80000 57599.9n 0.80000 57600.0n 0.80000 57779.9n 0.80000 57780.0n 0.80000 57959.9n 0.80000 57960.0n 0.80000 58139.9n 0.80000 58140.0n 0.80000 58319.9n 0.80000 58320.0n 0.80000 58499.9n 0.80000 58500.0n 0.80000 58679.9n 0.80000 58680.0n 0.80000 58859.9n 0.80000 58860.0n 0.80000 59039.9n 0.80000 59040.0n 0.80000 59219.9n 0.80000 59220.0n 0.80000 59399.9n 0.80000 59400.0n 0.80000 59579.9n 0.80000 59580.0n 0.80000 59759.9n 0.80000 59760.0n 0.80000 59939.9n 0.80000 59940.0n 0.80000 60119.9n 0.80000 60120.0n 0.80000 60299.9n 0.80000 60300.0n 0.80000 60479.9n 0.80000 60480.0n 0.80000 60659.9n 0.80000 60660.0n 0.80000 60839.9n 0.80000 60840.0n 0.80000 61019.9n 0.80000 61020.0n 0.80000 61199.9n 0.80000 61200.0n 0.80000 61379.9n 0.80000 61380.0n 0.80000 61559.9n 0.80000 61560.0n 0.80000 61739.9n 0.80000 61740.0n 0.80000 61919.9n 0.80000 61920.0n 0.80000 62099.9n 0.80000 62100.0n 0.80000 62279.9n 0.80000 62280.0n 0.80000 62459.9n 0.80000 62460.0n 0.80000 62639.9n 0.80000 62640.0n 0.80000 62819.9n 0.80000 62820.0n 0.80000 62999.9n 0.80000 63000.0n 0.80000 63179.9n 0.80000 63180.0n 0.80000 63359.9n 0.80000 63360.0n 0.80000 63539.9n 0.80000 63540.0n 0.80000 63719.9n 0.80000 63720.0n 0.80000 63899.9n 0.80000 63900.0n 0.80000 64079.9n 0.80000 64080.0n 0.80000 64259.9n 0.80000 64260.0n 0.80000 64439.9n 0.80000 64440.0n 0.80000 64619.9n 0.80000 64620.0n 0.80000 64799.9n 0.80000 64800.0n 0.80000 64979.9n 0.80000 64980.0n 0.80000 65159.9n 0.80000 65160.0n 0.80000 65339.9n 0.80000 65340.0n 0.80000 65519.9n 0.80000 65520.0n 0.80000 65699.9n 0.80000 65700.0n 0.80000 65879.9n 0.80000 65880.0n 0.80000 66059.9n 0.80000 66060.0n 0.80000 66239.9n 0.80000 66240.0n 0.80000 66419.9n 0.80000 66420.0n 0.80000 66599.9n 0.80000 66600.0n 0.80000 66779.9n 0.80000 66780.0n 0.80000 66959.9n 0.80000 66960.0n 0.80000 67139.9n 0.80000 67140.0n 0.80000 67319.9n 0.80000 67320.0n 0.80000 67499.9n 0.80000 67500.0n 0.80000 67679.9n 0.80000 67680.0n 0.80000 67859.9n 0.80000 67860.0n 0.80000 68039.9n 0.80000 68040.0n 0.80000 68219.9n 0.80000 68220.0n 0.80000 68399.9n 0.80000 68400.0n 0.80000 68579.9n 0.80000 68580.0n 0.80000 68759.9n 0.80000 68760.0n 0.80000 68939.9n 0.80000 68940.0n 0.80000 69119.9n 0.80000 69120.0n 0.80000 69299.9n 0.80000 69300.0n 0.80000 69479.9n 0.80000 69480.0n 0.80000 69659.9n 0.80000 69660.0n 0.80000 69839.9n 0.80000 69840.0n 0.80000 70019.9n 0.80000 70020.0n 0.80000 70199.9n 0.80000 70200.0n 0.80000 70379.9n 0.80000 70380.0n 0.80000 70559.9n 0.80000 70560.0n 0.80000 70739.9n 0.80000 70740.0n 0.80000 70919.9n 0.80000 70920.0n 0.80000 71099.9n 0.80000 71100.0n 0.80000 71279.9n 0.80000 71280.0n 0.80000 71459.9n 0.80000 71460.0n 0.80000 71639.9n 0.80000 71640.0n 0.80000 71819.9n 0.80000 71820.0n 0.80000 71999.9n 0.80000 72000.0n 0.80000 72179.9n 0.80000 72180.0n 0.80000 72359.9n 0.80000 72360.0n 0.80000 72539.9n 0.80000 72540.0n 0.80000 72719.9n 0.80000 72720.0n 0.80000 72899.9n 0.80000 72900.0n 0.80000 73079.9n 0.80000 73080.0n 0.80000 73259.9n 0.80000 73260.0n 0.80000 73439.9n 0.80000 73440.0n 0.80000 73619.9n 0.80000 73620.0n 0.80000 73799.9n 0.80000 73800.0n 0.80000 73979.9n 0.80000 73980.0n 0.80000 74159.9n 0.80000 74160.0n 0.80000 74339.9n 0.80000 74340.0n 0.80000 74519.9n 0.80000 74520.0n 0.80000 74699.9n 0.80000 74700.0n 0.80000 74879.9n 0.80000 74880.0n 0.80000 75059.9n 0.80000 75060.0n 0.80000 75239.9n 0.80000 75240.0n 0.80000 75419.9n 0.80000 75420.0n 0.80000 75599.9n 0.80000 75600.0n 0.80000 75779.9n 0.80000 75780.0n 0.80000 75959.9n 0.80000 75960.0n 0.80000 76139.9n 0.80000 76140.0n 0.80000 76319.9n 0.80000 76320.0n 0.80000 76499.9n 0.80000 76500.0n 0.80000 76679.9n 0.80000 76680.0n 0.80000 76859.9n 0.80000 76860.0n 0.80000 77039.9n 0.80000 77040.0n 0.80000 77219.9n 0.80000 77220.0n 0.80000 77399.9n 0.80000 77400.0n 0.80000 77579.9n 0.80000 77580.0n 0.80000 77759.9n 0.80000 77760.0n 0.80000 77939.9n 0.80000 77940.0n 0.80000 78119.9n 0.80000 78120.0n 0.80000 78299.9n 0.80000 78300.0n 0.80000 78479.9n 0.80000 78480.0n 0.80000 78659.9n 0.80000 78660.0n 0.80000 78839.9n 0.80000 78840.0n 0.80000 79019.9n 0.80000 79020.0n 0.80000 79199.9n 0.80000 79200.0n 0.80000 79379.9n 0.80000 79380.0n 0.80000 79559.9n 0.80000 79560.0n 0.80000 79739.9n 0.80000 79740.0n 0.80000 79919.9n 0.80000 79920.0n 0.80000 80099.9n 0.80000 80100.0n 0.80000 80279.9n 0.80000 80280.0n 0.80000 80459.9n 0.80000 80460.0n 0.80000 80639.9n 0.80000 80640.0n 0.80000 80819.9n 0.80000 80820.0n 0.80000 80999.9n 0.80000 81000.0n 0.80000 81179.9n 0.80000 81180.0n 0.80000 81359.9n 0.80000 81360.0n 0.80000 81539.9n 0.80000 81540.0n 0.80000 81719.9n 0.80000 81720.0n 0.80000 81899.9n 0.80000 81900.0n 0.80000 82079.9n 0.80000 82080.0n 0.80000 82259.9n 0.80000 82260.0n 0.80000 82439.9n 0.80000 82440.0n 0.80000 82619.9n 0.80000 82620.0n 0.80000 82799.9n 0.80000 82800.0n 0.80000 82979.9n 0.80000 82980.0n 0.80000 83159.9n 0.80000 83160.0n 0.80000 83339.9n 0.80000 83340.0n 0.80000 83519.9n 0.80000 83520.0n 0.80000 83699.9n 0.80000 83700.0n 0.80000 83879.9n 0.80000 83880.0n 0.80000 84059.9n 0.80000 84060.0n 0.80000 84239.9n 0.80000 84240.0n 0.80000 84419.9n 0.80000 84420.0n 0.80000 84599.9n 0.80000 84600.0n 0.80000 84779.9n 0.80000 84780.0n 0.80000 84959.9n 0.80000 84960.0n 0.80000 85139.9n 0.80000 85140.0n 0.80000 85319.9n 0.80000 85320.0n 0.80000 85499.9n 0.80000 85500.0n 0.80000 85679.9n 0.80000 85680.0n 0.80000 85859.9n 0.80000 85860.0n 0.80000 86039.9n 0.80000 86040.0n 0.80000 86219.9n 0.80000 86220.0n 0.80000 86399.9n 0.80000 86400.0n 0.80000 86579.9n 0.80000 86580.0n 0.80000 86759.9n 0.80000 86760.0n 0.80000 86939.9n 0.80000 86940.0n 0.80000 87119.9n 0.80000 87120.0n 0.80000 87299.9n 0.80000 87300.0n 0.80000 87479.9n 0.80000 87480.0n 0.80000 87659.9n 0.80000 87660.0n 0.80000 87839.9n 0.80000 87840.0n 0.80000 88019.9n 0.80000 88020.0n 0.80000 88199.9n 0.80000 88200.0n 0.80000 88379.9n 0.80000 88380.0n 0.80000 88559.9n 0.80000 88560.0n 0.80000 88739.9n 0.80000 88740.0n 0.80000 88919.9n 0.80000 88920.0n 0.80000 89099.9n 0.80000 89100.0n 0.80000 89279.9n 0.80000 89280.0n 0.80000 89459.9n 0.80000 89460.0n 0.80000 89639.9n 0.80000 89640.0n 0.80000 89819.9n 0.80000 89820.0n 0.80000 89999.9n 0.80000 90000.0n 0.80000 90179.9n 0.80000 90180.0n 0.80000 90359.9n 0.80000 90360.0n 0.80000 90539.9n 0.80000 90540.0n 0.80000 90719.9n 0.80000 90720.0n 0.80000 90899.9n 0.80000 90900.0n 0.80000 91079.9n 0.80000 91080.0n 0.80000 91259.9n 0.80000 91260.0n 0.80000 91439.9n 0.80000 91440.0n 0.80000 91619.9n 0.80000 91620.0n 0.80000 91799.9n 0.80000 91800.0n 0.80000 91979.9n 0.80000 91980.0n 0.80000 92159.9n 0.80000 92160.0n 0.80000 92339.9n 0.80000 92340.0n 0.80000 92519.9n 0.80000 92520.0n 0.80000 92699.9n 0.80000 92700.0n 0.80000 92879.9n 0.80000 92880.0n 0.80000 93059.9n 0.80000 93060.0n 0.80000 93239.9n 0.80000 93240.0n 0.80000 93419.9n 0.80000 93420.0n 0.80000 93599.9n 0.80000 93600.0n 0.80000 93779.9n 0.80000 93780.0n 0.80000 93959.9n 0.80000 93960.0n 0.80000 94139.9n 0.80000 94140.0n 0.80000 94319.9n 0.80000 94320.0n 0.80000 94499.9n 0.80000 94500.0n 0.80000 94679.9n 0.80000 94680.0n 0.80000 94859.9n 0.80000 94860.0n 0.80000 95039.9n 0.80000 95040.0n 0.80000 95219.9n 0.80000 95220.0n 0.80000 95399.9n 0.80000 95400.0n 0.80000 95579.9n 0.80000 95580.0n 0.80000 95759.9n 0.80000 95760.0n 0.80000 95939.9n 0.80000 95940.0n 0.80000 96119.9n 0.80000 96120.0n 0.80000 96299.9n 0.80000 96300.0n 0.80000 96479.9n 0.80000 96480.0n 0.80000 96659.9n 0.80000 96660.0n 0.80000 96839.9n 0.80000 96840.0n 0.80000 97019.9n 0.80000 97020.0n 0.80000 97199.9n 0.80000 97200.0n 0.80000 97379.9n 0.80000 97380.0n 0.80000 97559.9n 0.80000 97560.0n 0.80000 97739.9n 0.80000 97740.0n 0.80000 97919.9n 0.80000 97920.0n 0.80000 98099.9n 0.80000 98100.0n 0.80000 98279.9n 0.80000 98280.0n 0.80000 98459.9n 0.80000 98460.0n 0.80000 98639.9n 0.80000 98640.0n 0.80000 98819.9n 0.80000 98820.0n 0.80000 98999.9n 0.80000 99000.0n 0.80000 99179.9n 0.80000 99180.0n 0.80000 99359.9n 0.80000 99360.0n 0.80000 99539.9n 0.80000 99540.0n 0.80000 99719.9n 0.80000 99720.0n 0.80000 99899.9n 0.80000 99900.0n 0.80000 100079.9n 0.80000 100080.0n 0.80000 100259.9n 0.80000 100260.0n 0.80000 100439.9n 0.80000 100440.0n 0.80000 100619.9n 0.80000 100620.0n 0.80000 100799.9n 0.80000 100800.0n 0.80000 100979.9n 0.80000 100980.0n 0.80000 101159.9n 0.80000 101160.0n 0.80000 101339.9n 0.80000 101340.0n 0.80000 101519.9n 0.80000 101520.0n 0.80000 101699.9n 0.80000 101700.0n 0.80000 101879.9n 0.80000 101880.0n 0.80000 102059.9n 0.80000 102060.0n 0.80000 102239.9n 0.80000 102240.0n 0.80000 102419.9n 0.80000 102420.0n 0.80000 102599.9n 0.80000 102600.0n 0.80000 102779.9n 0.80000 102780.0n 0.80000 102959.9n 0.80000 102960.0n 0.80000 103139.9n 0.80000 103140.0n 0.80000 103319.9n 0.80000 103320.0n 0.80000 103499.9n 0.80000 103500.0n 0.80000 103679.9n 0.80000 103680.0n 0.80000 103859.9n 0.80000 103860.0n 0.80000 104039.9n 0.80000 104040.0n 0.80000 104219.9n 0.80000 104220.0n 0.80000 104399.9n 0.80000 104400.0n 0.80000 104579.9n 0.80000 104580.0n 0.80000 104759.9n 0.80000 104760.0n 0.80000 104939.9n 0.80000 104940.0n 0.80000 105119.9n 0.80000 105120.0n 0.80000 105299.9n 0.80000 105300.0n 0.80000 105479.9n 0.80000 105480.0n 0.80000 105659.9n 0.80000 105660.0n 0.80000 105839.9n 0.80000 105840.0n 0.80000 106019.9n 0.80000 106020.0n 0.80000 106199.9n 0.80000 106200.0n 0.80000 106379.9n 0.80000 106380.0n 0.80000 106559.9n 0.80000 106560.0n 0.80000 106739.9n 0.80000 106740.0n 0.80000 106919.9n 0.80000 106920.0n 0.80000 107099.9n 0.80000 107100.0n 0.80000 107279.9n 0.80000 107280.0n 0.80000 107459.9n 0.80000 107460.0n 0.80000 107639.9n 0.80000 107640.0n 0.80000 107819.9n 0.80000 107820.0n 0.80000 107999.9n 0.80000 108000.0n 0.80000 108179.9n 0.80000 108180.0n 0.80000 108359.9n 0.80000 108360.0n 0.80000 108539.9n 0.80000 108540.0n 0.80000 108719.9n 0.80000 108720.0n 0.80000 108899.9n 0.80000 108900.0n 0.80000 109079.9n 0.80000 109080.0n 0.80000 109259.9n 0.80000 109260.0n 0.80000 109439.9n 0.80000 109440.0n 0.80000 109619.9n 0.80000 109620.0n 0.80000 109799.9n 0.80000 109800.0n 0.80000 109979.9n 0.80000 109980.0n 0.80000 110159.9n 0.80000 110160.0n 0.80000 110339.9n 0.80000 110340.0n 0.80000 110519.9n 0.80000 110520.0n 0.80000 110699.9n 0.80000 110700.0n 0.80000 110879.9n 0.80000 110880.0n 0.80000 111059.9n 0.80000 111060.0n 0.80000 111239.9n 0.80000 111240.0n 0.80000 111419.9n 0.80000 111420.0n 0.80000 111599.9n 0.80000 111600.0n 0.80000 111779.9n 0.80000 111780.0n 0.80000 111959.9n 0.80000 111960.0n 0.80000 112139.9n 0.80000 112140.0n 0.80000 112319.9n 0.80000 112320.0n 0.80000 112499.9n 0.80000 112500.0n 0.80000 112679.9n 0.80000 112680.0n 0.80000 112859.9n 0.80000 112860.0n 0.80000 113039.9n 0.80000 113040.0n 0.80000 113219.9n 0.80000 113220.0n 0.80000 113399.9n 0.80000 113400.0n 0.80000 113579.9n 0.80000 113580.0n 0.80000 113759.9n 0.80000 113760.0n 0.80000 113939.9n 0.80000 113940.0n 0.80000 114119.9n 0.80000 114120.0n 0.80000 114299.9n 0.80000 114300.0n 0.80000 114479.9n 0.80000 114480.0n 0.80000 114659.9n 0.80000 114660.0n 0.80000 114839.9n 0.80000 114840.0n 0.80000 115019.9n 0.80000 115020.0n 0.80000 115199.9n 0.80000 115200.0n 0.80000 115379.9n 0.80000 115380.0n 0.80000 115559.9n 0.80000 115560.0n 0.80000 115739.9n 0.80000 115740.0n 0.80000 115919.9n 0.80000 115920.0n 0.80000 116099.9n 0.80000 116100.0n 0.80000 116279.9n 0.80000 116280.0n 0.80000 116459.9n 0.80000 116460.0n 0.80000 116639.9n 0.80000 116640.0n 0.80000 116819.9n 0.80000 116820.0n 0.80000 116999.9n 0.80000 117000.0n 0.80000 117179.9n 0.80000 117180.0n 0.80000 117359.9n 0.80000 117360.0n 0.80000 117539.9n 0.80000 117540.0n 0.80000 117719.9n 0.80000 117720.0n 0.80000 117899.9n 0.80000 117900.0n 0.80000 118079.9n 0.80000 118080.0n 0.80000 118259.9n 0.80000 118260.0n 0.80000 118439.9n 0.80000 118440.0n 0.80000 118619.9n 0.80000 118620.0n 0.80000 118799.9n 0.80000 118800.0n 0.80000 118979.9n 0.80000 118980.0n 0.80000 119159.9n 0.80000 119160.0n 0.80000 119339.9n 0.80000 119340.0n 0.80000 119519.9n 0.80000 119520.0n 0.80000 119699.9n 0.80000 119700.0n 0.80000 119879.9n 0.80000 119880.0n 0.80000 120059.9n 0.80000 120060.0n 0.80000 120239.9n 0.80000 120240.0n 0.80000 120419.9n 0.80000 120420.0n 0.80000 120599.9n 0.80000 120600.0n 0.80000 120779.9n 0.80000 120780.0n 0.80000 120959.9n 0.80000 120960.0n 0.80000 121139.9n 0.80000 121140.0n 0.80000 121319.9n 0.80000 121320.0n 0.80000 121499.9n 0.80000 121500.0n 0.80000 121679.9n 0.80000 121680.0n 0.80000 121859.9n 0.80000 121860.0n 0.80000 122039.9n 0.80000 122040.0n 0.80000 122219.9n 0.80000 122220.0n 0.80000 122399.9n 0.80000 122400.0n 0.80000 122579.9n 0.80000 122580.0n 0.80000 122759.9n 0.80000 122760.0n 0.80000 122939.9n 0.80000 122940.0n 0.80000 123119.9n 0.80000 123120.0n 0.80000 123299.9n 0.80000 123300.0n 0.80000 123479.9n 0.80000 123480.0n 0.80000 123659.9n 0.80000 123660.0n 0.80000 123839.9n 0.80000 123840.0n 0.80000 124019.9n 0.80000 124020.0n 0.80000 124199.9n 0.80000 124200.0n 0.80000 124379.9n 0.80000 124380.0n 0.80000 124559.9n 0.80000 124560.0n 0.80000 124739.9n 0.80000 124740.0n 0.80000 124919.9n 0.80000 124920.0n 0.80000 125099.9n 0.80000 125100.0n 0.80000 125279.9n 0.80000 125280.0n 0.80000 125459.9n 0.80000 125460.0n 0.80000 125639.9n 0.80000 125640.0n 0.80000 125819.9n 0.80000 125820.0n 0.80000 125999.9n 0.80000 126000.0n 0.80000 126179.9n 0.80000 126180.0n 0.80000 126359.9n 0.80000 126360.0n 0.80000 126539.9n 0.80000 126540.0n 0.80000 126719.9n 0.80000 126720.0n 0.80000 126899.9n 0.80000 126900.0n 0.80000 127079.9n 0.80000 127080.0n 0.80000 127259.9n 0.80000 127260.0n 0.80000 127439.9n 0.80000 127440.0n 0.80000 127619.9n 0.80000 127620.0n 0.80000 127799.9n 0.80000 127800.0n 0.80000 127979.9n 0.80000 127980.0n 0.80000 128159.9n 0.80000 128160.0n 0.80000 128339.9n 0.80000 128340.0n 0.80000 128519.9n 0.80000 128520.0n 0.80000 128699.9n 0.80000 128700.0n 0.80000 128879.9n 0.80000 128880.0n 0.80000 129059.9n 0.80000 129060.0n 0.80000 129239.9n 0.80000 129240.0n 0.80000 129419.9n 0.80000 129420.0n 0.80000 129599.9n 0.80000 129600.0n 0.80000 129779.9n 0.80000 129780.0n 0.80000 129959.9n 0.80000 129960.0n 0.80000 130139.9n 0.80000 130140.0n 0.80000 130319.9n 0.80000 130320.0n 0.80000 130499.9n 0.80000 130500.0n 0.80000 130679.9n 0.80000 130680.0n 0.80000 130859.9n 0.80000 130860.0n 0.80000 131039.9n 0.80000 131040.0n 0.80000 131219.9n 0.80000 131220.0n 0.80000 131399.9n 0.80000 131400.0n 0.80000 131579.9n 0.80000 131580.0n 0.80000 131759.9n 0.80000 131760.0n 0.80000 131939.9n 0.80000 131940.0n 0.80000 132119.9n 0.80000 132120.0n 0.80000 132299.9n 0.80000 132300.0n 0.80000 132479.9n 0.80000 132480.0n 0.80000 132659.9n 0.80000 132660.0n 0.80000 132839.9n 0.80000 132840.0n 0.80000 133019.9n 0.80000 133020.0n 0.80000 133199.9n 0.80000 133200.0n 0.80000 133379.9n 0.80000 133380.0n 0.80000 133559.9n 0.80000 133560.0n 0.80000 133739.9n 0.80000 133740.0n 0.80000 133919.9n 0.80000 133920.0n 0.80000 134099.9n 0.80000 134100.0n 0.80000 134279.9n 0.80000 134280.0n 0.80000 134459.9n 0.80000 134460.0n 0.80000 134639.9n 0.80000 134640.0n 0.80000 134819.9n 0.80000 134820.0n 0.80000 134999.9n 0.80000 135000.0n 0.80000 135179.9n 0.80000 135180.0n 0.80000 135359.9n 0.80000 135360.0n 0.80000 135539.9n 0.80000 135540.0n 0.80000 135719.9n 0.80000 135720.0n 0.80000 135899.9n 0.80000 135900.0n 0.80000 136079.9n 0.80000 136080.0n 0.80000 136259.9n 0.80000 136260.0n 0.80000 136439.9n 0.80000 136440.0n 0.80000 136619.9n 0.80000 136620.0n 0.80000 136799.9n 0.80000 136800.0n 0.80000 136979.9n 0.80000 136980.0n 0.80000 137159.9n 0.80000 137160.0n 0.80000 137339.9n 0.80000 137340.0n 0.80000 137519.9n 0.80000 137520.0n 0.80000 137699.9n 0.80000 137700.0n 0.80000 137879.9n 0.80000 137880.0n 0.80000 138059.9n 0.80000 138060.0n 0.80000 138239.9n 0.80000 138240.0n 0.80000 138419.9n 0.80000 138420.0n 0.80000 138599.9n 0.80000 138600.0n 0.80000 138779.9n 0.80000 138780.0n 0.80000 138959.9n 0.80000 138960.0n 0.80000 139139.9n 0.80000 139140.0n 0.80000 139319.9n 0.80000 139320.0n 0.80000 139499.9n 0.80000 139500.0n 0.80000 139679.9n 0.80000 139680.0n 0.80000 139859.9n 0.80000 139860.0n 0.80000 140039.9n 0.80000 140040.0n 0.80000 140219.9n 0.80000 140220.0n 0.80000 140399.9n 0.80000 140400.0n 0.80000 140579.9n 0.80000 140580.0n 0.80000 140759.9n 0.80000 140760.0n 0.80000 140939.9n 0.80000 140940.0n 0.80000 141119.9n 0.80000 141120.0n 0.80000 141299.9n 0.80000 141300.0n 0.80000 141479.9n 0.80000 141480.0n 0.80000 141659.9n 0.80000 141660.0n 0.80000 141839.9n 0.80000 141840.0n 0.80000 142019.9n 0.80000 142020.0n 0.80000 142199.9n 0.80000 142200.0n 0.80000 142379.9n 0.80000 142380.0n 0.80000 142559.9n 0.80000 142560.0n 0.80000 142739.9n 0.80000 142740.0n 0.80000 142919.9n 0.80000 142920.0n 0.80000 143099.9n 0.80000 143100.0n 0.80000 143279.9n 0.80000 143280.0n 0.80000 143459.9n 0.80000 143460.0n 0.80000 143639.9n 0.80000 143640.0n 0.80000 143819.9n 0.80000 143820.0n 0.80000 143999.9n 0.80000 144000.0n 0.80000 144179.9n 0.80000 144180.0n 0.80000 144359.9n 0.80000 144360.0n 0.80000 144539.9n 0.80000 144540.0n 0.80000 144719.9n 0.80000 144720.0n 0.80000 144899.9n 0.80000 144900.0n 0.80000 145079.9n 0.80000 145080.0n 0.80000 145259.9n 0.80000 145260.0n 0.80000 145439.9n 0.80000 145440.0n 0.80000 145619.9n 0.80000 145620.0n 0.80000 145799.9n 0.80000 145800.0n 0.80000 145979.9n 0.80000 145980.0n 0.80000 146159.9n 0.80000 146160.0n 0.80000 146339.9n 0.80000 146340.0n 0.80000 146519.9n 0.80000 146520.0n 0.80000 146699.9n 0.80000 146700.0n 0.80000 146879.9n 0.80000 146880.0n 0.80000 147059.9n 0.80000 147060.0n 0.80000 147239.9n 0.80000 147240.0n 0.80000 147419.9n 0.80000 147420.0n 0.80000 147599.9n 0.80000 147600.0n 0.80000 147779.9n 0.80000 147780.0n 0.80000 147959.9n 0.80000 147960.0n 0.80000 148139.9n 0.80000 148140.0n 0.80000 148319.9n 0.80000 148320.0n 0.80000 148499.9n 0.80000 148500.0n 0.80000 148679.9n 0.80000 148680.0n 0.80000 148859.9n 0.80000 148860.0n 0.80000 149039.9n 0.80000 149040.0n 0.80000 149219.9n 0.80000 149220.0n 0.80000 149399.9n 0.80000 149400.0n 0.80000 149579.9n 0.80000 149580.0n 0.80000 149759.9n 0.80000 149760.0n 0.80000 149939.9n 0.80000 149940.0n 0.80000 150119.9n 0.80000 150120.0n 0.80000 150299.9n 0.80000 150300.0n 0.80000 150479.9n 0.80000 150480.0n 0.80000 150659.9n 0.80000 150660.0n 0.80000 150839.9n 0.80000 150840.0n 0.80000 151019.9n 0.80000 151020.0n 0.80000 151199.9n 0.80000 151200.0n 0.80000 151379.9n 0.80000 151380.0n 0.80000 151559.9n 0.80000 151560.0n 0.80000 151739.9n 0.80000 151740.0n 0.80000 151919.9n 0.80000 151920.0n 0.80000 152099.9n 0.80000 152100.0n 0.80000 152279.9n 0.80000 152280.0n 0.80000 152459.9n 0.80000 152460.0n 0.80000 152639.9n 0.80000 152640.0n 0.80000 152819.9n 0.80000 152820.0n 0.80000 152999.9n 0.80000 153000.0n 0.80000 153179.9n 0.80000 153180.0n 0.80000 153359.9n 0.80000 153360.0n 0.80000 153539.9n 0.80000 153540.0n 0.80000 153719.9n 0.80000 153720.0n 0.80000 153899.9n 0.80000 153900.0n 0.80000 154079.9n 0.80000 154080.0n 0.80000 154259.9n 0.80000 154260.0n 0.80000 154439.9n 0.80000 154440.0n 0.80000 154619.9n 0.80000 154620.0n 0.80000 154799.9n 0.80000 154800.0n 0.80000 154979.9n 0.80000 154980.0n 0.80000 155159.9n 0.80000 155160.0n 0.80000 155339.9n 0.80000 155340.0n 0.80000 155519.9n 0.80000 155520.0n 0.80000 155699.9n 0.80000 155700.0n 0.80000 155879.9n 0.80000 155880.0n 0.80000 156059.9n 0.80000 156060.0n 0.80000 156239.9n 0.80000 156240.0n 0.80000 156419.9n 0.80000 156420.0n 0.80000 156599.9n 0.80000 156600.0n 0.80000 156779.9n 0.80000 156780.0n 0.80000 156959.9n 0.80000 156960.0n 0.80000 157139.9n 0.80000 157140.0n 0.80000 157319.9n 0.80000 157320.0n 0.80000 157499.9n 0.80000 157500.0n 0.80000 157679.9n 0.80000 157680.0n 0.80000 157859.9n 0.80000 157860.0n 0.80000 158039.9n 0.80000 158040.0n 0.80000 158219.9n 0.80000 158220.0n 0.80000 158399.9n 0.80000 158400.0n 0.80000 158579.9n 0.80000 158580.0n 0.80000 158759.9n 0.80000 158760.0n 0.80000 158939.9n 0.80000 158940.0n 0.80000 159119.9n 0.80000 159120.0n 0.80000 159299.9n 0.80000 159300.0n 0.80000 159479.9n 0.80000 159480.0n 0.80000 159659.9n 0.80000 159660.0n 0.80000 159839.9n 0.80000 159840.0n 0.80000 160019.9n 0.80000 160020.0n 0.80000 160199.9n 0.80000 160200.0n 0.80000 160379.9n 0.80000 160380.0n 0.80000 160559.9n 0.80000 160560.0n 0.80000 160739.9n 0.80000 160740.0n 0.80000 160919.9n 0.80000 160920.0n 0.80000 161099.9n 0.80000 161100.0n 0.80000 161279.9n 0.80000 161280.0n 0.80000 161459.9n 0.80000 161460.0n 0.80000 161639.9n 0.80000 161640.0n 0.80000 161819.9n 0.80000 161820.0n 0.80000 161999.9n 0.80000 162000.0n 0.80000 162179.9n 0.80000 162180.0n 0.80000 162359.9n 0.80000 162360.0n 0.80000 162539.9n 0.80000 162540.0n 0.80000 162719.9n 0.80000 162720.0n 0.80000 162899.9n 0.80000 162900.0n 0.80000 163079.9n 0.80000 163080.0n 0.80000 163259.9n 0.80000 163260.0n 0.80000 163439.9n 0.80000 163440.0n 0.80000 163619.9n 0.80000 163620.0n 0.80000 163799.9n 0.80000 163800.0n 0.80000 163979.9n 0.80000 163980.0n 0.80000 164159.9n 0.80000 164160.0n 0.80000 164339.9n 0.80000 164340.0n 0.80000 164519.9n 0.80000 164520.0n 0.80000 164699.9n 0.80000 164700.0n 0.80000 164879.9n 0.80000 164880.0n 0.80000 165059.9n 0.80000 165060.0n 0.80000 165239.9n 0.80000 165240.0n 0.80000 165419.9n 0.80000 165420.0n 0.80000 165599.9n 0.80000 165600.0n 0.80000 165779.9n 0.80000 165780.0n 0.80000 165959.9n 0.80000 165960.0n 0.80000 166139.9n 0.80000 166140.0n 0.80000 166319.9n 0.80000 166320.0n 0.80000 166499.9n 0.80000 166500.0n 0.80000 166679.9n 0.80000 166680.0n 0.80000 166859.9n 0.80000 166860.0n 0.80000 167039.9n 0.80000 167040.0n 0.80000 167219.9n 0.80000 167220.0n 0.80000 167399.9n 0.80000 167400.0n 0.80000 167579.9n 0.80000 167580.0n 0.80000 167759.9n 0.80000 167760.0n 0.80000 167939.9n 0.80000 167940.0n 0.80000 168119.9n 0.80000 168120.0n 0.80000 168299.9n 0.80000 168300.0n 0.80000 168479.9n 0.80000 168480.0n 0.80000 168659.9n 0.80000 168660.0n 0.80000 168839.9n 0.80000 168840.0n 0.80000 169019.9n 0.80000 169020.0n 0.80000 169199.9n 0.80000 169200.0n 0.80000 169379.9n 0.80000 169380.0n 0.80000 169559.9n 0.80000 169560.0n 0.80000 169739.9n 0.80000 169740.0n 0.80000 169919.9n 0.80000 169920.0n 0.80000 170099.9n 0.80000 170100.0n 0.80000 170279.9n 0.80000 170280.0n 0.80000 170459.9n 0.80000 170460.0n 0.80000 170639.9n 0.80000 170640.0n 0.80000 170819.9n 0.80000 170820.0n 0.80000 170999.9n 0.80000 171000.0n 0.80000 171179.9n 0.80000 171180.0n 0.80000 171359.9n 0.80000 171360.0n 0.80000 171539.9n 0.80000 171540.0n 0.80000 171719.9n 0.80000 171720.0n 0.80000 171899.9n 0.80000 171900.0n 0.80000 172079.9n 0.80000 172080.0n 0.80000 172259.9n 0.80000 172260.0n 0.80000 172439.9n 0.80000 172440.0n 0.80000 172619.9n 0.80000 172620.0n 0.80000 172799.9n 0.80000 172800.0n 0.80000 172979.9n 0.80000 172980.0n 0.80000 173159.9n 0.80000 173160.0n 0.80000 173339.9n 0.80000 173340.0n 0.80000 173519.9n 0.80000 173520.0n 0.80000 173699.9n 0.80000 173700.0n 0.80000 173879.9n 0.80000 173880.0n 0.80000 174059.9n 0.80000 174060.0n 0.80000 174239.9n 0.80000 174240.0n 0.80000 174419.9n 0.80000 174420.0n 0.80000 174599.9n 0.80000 174600.0n 0.80000 174779.9n 0.80000 174780.0n 0.80000 174959.9n 0.80000 174960.0n 0.80000 175139.9n 0.80000 175140.0n 0.80000 175319.9n 0.80000 175320.0n 0.80000 175499.9n 0.80000 175500.0n 0.80000 175679.9n 0.80000 175680.0n 0.80000 175859.9n 0.80000 175860.0n 0.80000 176039.9n 0.80000 176040.0n 0.80000 176219.9n 0.80000 176220.0n 0.80000 176399.9n 0.80000 176400.0n 0.80000 176579.9n 0.80000 176580.0n 0.80000 176759.9n 0.80000 176760.0n 0.80000 176939.9n 0.80000 176940.0n 0.80000 177119.9n 0.80000 177120.0n 0.80000 177299.9n 0.80000 177300.0n 0.80000 177479.9n 0.80000 177480.0n 0.80000 177659.9n 0.80000 177660.0n 0.80000 177839.9n 0.80000 177840.0n 0.80000 178019.9n 0.80000 178020.0n 0.80000 178199.9n 0.80000 178200.0n 0.80000 178379.9n 0.80000 178380.0n 0.80000 178559.9n 0.80000 178560.0n 0.80000 178739.9n 0.80000 178740.0n 0.80000 178919.9n 0.80000 178920.0n 0.80000 179099.9n 0.80000 179100.0n 0.80000 179279.9n 0.80000 179280.0n 0.80000 179459.9n 0.80000 179460.0n 0.80000 179639.9n 0.80000 179640.0n 0.80000 179819.9n 0.80000 179820.0n 0.80000 179999.9n 0.80000 180000.0n 0.80000 180179.9n 0.80000 180180.0n 0.80000 180359.9n 0.80000 180360.0n 0.80000 180539.9n 0.80000 180540.0n 0.80000 180719.9n 0.80000 180720.0n 0.80000 180899.9n 0.80000 180900.0n 0.80000 181079.9n 0.80000 181080.0n 0.80000 181259.9n 0.80000 181260.0n 0.80000 181439.9n 0.80000 181440.0n 0.80000 181619.9n 0.80000 181620.0n 0.80000 181799.9n 0.80000 181800.0n 0.80000 181979.9n 0.80000 181980.0n 0.80000 182159.9n 0.80000 182160.0n 0.80000 182339.9n 0.80000 182340.0n 0.80000 182519.9n 0.80000 182520.0n 0.80000 182699.9n 0.80000 182700.0n 0.80000 182879.9n 0.80000 182880.0n 0.80000 183059.9n 0.80000 183060.0n 0.80000 183239.9n 0.80000 183240.0n 0.80000 183419.9n 0.80000 183420.0n 0.80000)
Vxn2 a_xn2 0 PWL(0.0n 0.20000 179.9n 0.20000 180.0n 0.20000 359.9n 0.20000 360.0n 0.20000 539.9n 0.20000 540.0n 0.20000 719.9n 0.20000 720.0n 0.20000 899.9n 0.20000 900.0n 0.20000 1079.9n 0.20000 1080.0n 0.20000 1259.9n 0.20000 1260.0n 0.20000 1439.9n 0.20000 1440.0n 0.20000 1619.9n 0.20000 1620.0n 0.20000 1799.9n 0.20000 1800.0n 0.20000 1979.9n 0.20000 1980.0n 0.20000 2159.9n 0.20000 2160.0n 0.20000 2339.9n 0.20000 2340.0n 0.20000 2519.9n 0.20000 2520.0n 0.20000 2699.9n 0.20000 2700.0n 0.20000 2879.9n 0.20000 2880.0n 0.20000 3059.9n 0.20000 3060.0n 0.20000 3239.9n 0.20000 3240.0n 0.20000 3419.9n 0.20000 3420.0n 0.20000 3599.9n 0.20000 3600.0n 0.20000 3779.9n 0.20000 3780.0n 0.20000 3959.9n 0.20000 3960.0n 0.20000 4139.9n 0.20000 4140.0n 0.20000 4319.9n 0.20000 4320.0n 0.20000 4499.9n 0.20000 4500.0n 0.20000 4679.9n 0.20000 4680.0n 0.20000 4859.9n 0.20000 4860.0n 0.20000 5039.9n 0.20000 5040.0n 0.20000 5219.9n 0.20000 5220.0n 0.20000 5399.9n 0.20000 5400.0n 0.20000 5579.9n 0.20000 5580.0n 0.20000 5759.9n 0.20000 5760.0n 0.20000 5939.9n 0.20000 5940.0n 0.20000 6119.9n 0.20000 6120.0n 0.20000 6299.9n 0.20000 6300.0n 0.20000 6479.9n 0.20000 6480.0n 0.20000 6659.9n 0.20000 6660.0n 0.20000 6839.9n 0.20000 6840.0n 0.20000 7019.9n 0.20000 7020.0n 0.20000 7199.9n 0.20000 7200.0n 0.20000 7379.9n 0.20000 7380.0n 0.20000 7559.9n 0.20000 7560.0n 0.20000 7739.9n 0.20000 7740.0n 0.20000 7919.9n 0.20000 7920.0n 0.20000 8099.9n 0.20000 8100.0n 0.20000 8279.9n 0.20000 8280.0n 0.20000 8459.9n 0.20000 8460.0n 0.20000 8639.9n 0.20000 8640.0n 0.20000 8819.9n 0.20000 8820.0n 0.20000 8999.9n 0.20000 9000.0n 0.20000 9179.9n 0.20000 9180.0n 0.20000 9359.9n 0.20000 9360.0n 0.20000 9539.9n 0.20000 9540.0n 0.20000 9719.9n 0.20000 9720.0n 0.20000 9899.9n 0.20000 9900.0n 0.20000 10079.9n 0.20000 10080.0n 0.20000 10259.9n 0.20000 10260.0n 0.20000 10439.9n 0.20000 10440.0n 0.20000 10619.9n 0.20000 10620.0n 0.20000 10799.9n 0.20000 10800.0n 0.20000 10979.9n 0.20000 10980.0n 0.20000 11159.9n 0.20000 11160.0n 0.20000 11339.9n 0.20000 11340.0n 0.20000 11519.9n 0.20000 11520.0n 0.20000 11699.9n 0.20000 11700.0n 0.20000 11879.9n 0.20000 11880.0n 0.20000 12059.9n 0.20000 12060.0n 0.20000 12239.9n 0.20000 12240.0n 0.20000 12419.9n 0.20000 12420.0n 0.20000 12599.9n 0.20000 12600.0n 0.20000 12779.9n 0.20000 12780.0n 0.20000 12959.9n 0.20000 12960.0n 0.20000 13139.9n 0.20000 13140.0n 0.20000 13319.9n 0.20000 13320.0n 0.20000 13499.9n 0.20000 13500.0n 0.20000 13679.9n 0.20000 13680.0n 0.20000 13859.9n 0.20000 13860.0n 0.20000 14039.9n 0.20000 14040.0n 0.20000 14219.9n 0.20000 14220.0n 0.20000 14399.9n 0.20000 14400.0n 0.20000 14579.9n 0.20000 14580.0n 0.20000 14759.9n 0.20000 14760.0n 0.20000 14939.9n 0.20000 14940.0n 0.20000 15119.9n 0.20000 15120.0n 0.20000 15299.9n 0.20000 15300.0n 0.20000 15479.9n 0.20000 15480.0n 0.20000 15659.9n 0.20000 15660.0n 0.20000 15839.9n 0.20000 15840.0n 0.20000 16019.9n 0.20000 16020.0n 0.20000 16199.9n 0.20000 16200.0n 0.20000 16379.9n 0.20000 16380.0n 0.20000 16559.9n 0.20000 16560.0n 0.20000 16739.9n 0.20000 16740.0n 0.20000 16919.9n 0.20000 16920.0n 0.20000 17099.9n 0.20000 17100.0n 0.20000 17279.9n 0.20000 17280.0n 0.20000 17459.9n 0.20000 17460.0n 0.20000 17639.9n 0.20000 17640.0n 0.20000 17819.9n 0.20000 17820.0n 0.20000 17999.9n 0.20000 18000.0n 0.20000 18179.9n 0.20000 18180.0n 0.20000 18359.9n 0.20000 18360.0n 0.20000 18539.9n 0.20000 18540.0n 0.20000 18719.9n 0.20000 18720.0n 0.20000 18899.9n 0.20000 18900.0n 0.20000 19079.9n 0.20000 19080.0n 0.20000 19259.9n 0.20000 19260.0n 0.20000 19439.9n 0.20000 19440.0n 0.20000 19619.9n 0.20000 19620.0n 0.20000 19799.9n 0.20000 19800.0n 0.20000 19979.9n 0.20000 19980.0n 0.20000 20159.9n 0.20000 20160.0n 0.20000 20339.9n 0.20000 20340.0n 0.20000 20519.9n 0.20000 20520.0n 0.20000 20699.9n 0.20000 20700.0n 0.20000 20879.9n 0.20000 20880.0n 0.20000 21059.9n 0.20000 21060.0n 0.20000 21239.9n 0.20000 21240.0n 0.20000 21419.9n 0.20000 21420.0n 0.20000 21599.9n 0.20000 21600.0n 0.20000 21779.9n 0.20000 21780.0n 0.20000 21959.9n 0.20000 21960.0n 0.20000 22139.9n 0.20000 22140.0n 0.20000 22319.9n 0.20000 22320.0n 0.20000 22499.9n 0.20000 22500.0n 0.20000 22679.9n 0.20000 22680.0n 0.20000 22859.9n 0.20000 22860.0n 0.20000 23039.9n 0.20000 23040.0n 0.20000 23219.9n 0.20000 23220.0n 0.20000 23399.9n 0.20000 23400.0n 0.20000 23579.9n 0.20000 23580.0n 0.20000 23759.9n 0.20000 23760.0n 0.20000 23939.9n 0.20000 23940.0n 0.20000 24119.9n 0.20000 24120.0n 0.20000 24299.9n 0.20000 24300.0n 0.20000 24479.9n 0.20000 24480.0n 0.20000 24659.9n 0.20000 24660.0n 0.20000 24839.9n 0.20000 24840.0n 0.20000 25019.9n 0.20000 25020.0n 0.20000 25199.9n 0.20000 25200.0n 0.20000 25379.9n 0.20000 25380.0n 0.20000 25559.9n 0.20000 25560.0n 0.20000 25739.9n 0.20000 25740.0n 0.20000 25919.9n 0.20000 25920.0n 0.20000 26099.9n 0.20000 26100.0n 0.20000 26279.9n 0.20000 26280.0n 0.20000 26459.9n 0.20000 26460.0n 0.20000 26639.9n 0.20000 26640.0n 0.20000 26819.9n 0.20000 26820.0n 0.20000 26999.9n 0.20000 27000.0n 0.20000 27179.9n 0.20000 27180.0n 0.20000 27359.9n 0.20000 27360.0n 0.20000 27539.9n 0.20000 27540.0n 0.20000 27719.9n 0.20000 27720.0n 0.20000 27899.9n 0.20000 27900.0n 0.20000 28079.9n 0.20000 28080.0n 0.20000 28259.9n 0.20000 28260.0n 0.20000 28439.9n 0.20000 28440.0n 0.20000 28619.9n 0.20000 28620.0n 0.20000 28799.9n 0.20000 28800.0n 0.20000 28979.9n 0.20000 28980.0n 0.20000 29159.9n 0.20000 29160.0n 0.20000 29339.9n 0.20000 29340.0n 0.20000 29519.9n 0.20000 29520.0n 0.20000 29699.9n 0.20000 29700.0n 0.20000 29879.9n 0.20000 29880.0n 0.20000 30059.9n 0.20000 30060.0n 0.20000 30239.9n 0.20000 30240.0n 0.20000 30419.9n 0.20000 30420.0n 0.20000 30599.9n 0.20000 30600.0n 0.20000 30779.9n 0.20000 30780.0n 0.20000 30959.9n 0.20000 30960.0n 0.20000 31139.9n 0.20000 31140.0n 0.20000 31319.9n 0.20000 31320.0n 0.20000 31499.9n 0.20000 31500.0n 0.20000 31679.9n 0.20000 31680.0n 0.20000 31859.9n 0.20000 31860.0n 0.20000 32039.9n 0.20000 32040.0n 0.20000 32219.9n 0.20000 32220.0n 0.20000 32399.9n 0.20000 32400.0n 0.20000 32579.9n 0.20000 32580.0n 0.20000 32759.9n 0.20000 32760.0n 0.20000 32939.9n 0.20000 32940.0n 0.20000 33119.9n 0.20000 33120.0n 0.20000 33299.9n 0.20000 33300.0n 0.20000 33479.9n 0.20000 33480.0n 0.20000 33659.9n 0.20000 33660.0n 0.20000 33839.9n 0.20000 33840.0n 0.20000 34019.9n 0.20000 34020.0n 0.20000 34199.9n 0.20000 34200.0n 0.20000 34379.9n 0.20000 34380.0n 0.20000 34559.9n 0.20000 34560.0n 0.20000 34739.9n 0.20000 34740.0n 0.20000 34919.9n 0.20000 34920.0n 0.20000 35099.9n 0.20000 35100.0n 0.20000 35279.9n 0.20000 35280.0n 0.20000 35459.9n 0.20000 35460.0n 0.20000 35639.9n 0.20000 35640.0n 0.20000 35819.9n 0.20000 35820.0n 0.20000 35999.9n 0.20000 36000.0n 0.20000 36179.9n 0.20000 36180.0n 0.20000 36359.9n 0.20000 36360.0n 0.20000 36539.9n 0.20000 36540.0n 0.20000 36719.9n 0.20000 36720.0n 0.20000 36899.9n 0.20000 36900.0n 0.20000 37079.9n 0.20000 37080.0n 0.20000 37259.9n 0.20000 37260.0n 0.20000 37439.9n 0.20000 37440.0n 0.20000 37619.9n 0.20000 37620.0n 0.20000 37799.9n 0.20000 37800.0n 0.20000 37979.9n 0.20000 37980.0n 0.20000 38159.9n 0.20000 38160.0n 0.20000 38339.9n 0.20000 38340.0n 0.20000 38519.9n 0.20000 38520.0n 0.20000 38699.9n 0.20000 38700.0n 0.20000 38879.9n 0.20000 38880.0n 0.20000 39059.9n 0.20000 39060.0n 0.20000 39239.9n 0.20000 39240.0n 0.20000 39419.9n 0.20000 39420.0n 0.20000 39599.9n 0.20000 39600.0n 0.20000 39779.9n 0.20000 39780.0n 0.20000 39959.9n 0.20000 39960.0n 0.20000 40139.9n 0.20000 40140.0n 0.20000 40319.9n 0.20000 40320.0n 0.20000 40499.9n 0.20000 40500.0n 0.20000 40679.9n 0.20000 40680.0n 0.20000 40859.9n 0.20000 40860.0n 0.20000 41039.9n 0.20000 41040.0n 0.20000 41219.9n 0.20000 41220.0n 0.20000 41399.9n 0.20000 41400.0n 0.20000 41579.9n 0.20000 41580.0n 0.20000 41759.9n 0.20000 41760.0n 0.20000 41939.9n 0.20000 41940.0n 0.20000 42119.9n 0.20000 42120.0n 0.20000 42299.9n 0.20000 42300.0n 0.20000 42479.9n 0.20000 42480.0n 0.20000 42659.9n 0.20000 42660.0n 0.20000 42839.9n 0.20000 42840.0n 0.20000 43019.9n 0.20000 43020.0n 0.20000 43199.9n 0.20000 43200.0n 0.20000 43379.9n 0.20000 43380.0n 0.20000 43559.9n 0.20000 43560.0n 0.20000 43739.9n 0.20000 43740.0n 0.20000 43919.9n 0.20000 43920.0n 0.20000 44099.9n 0.20000 44100.0n 0.20000 44279.9n 0.20000 44280.0n 0.20000 44459.9n 0.20000 44460.0n 0.20000 44639.9n 0.20000 44640.0n 0.20000 44819.9n 0.20000 44820.0n 0.20000 44999.9n 0.20000 45000.0n 0.20000 45179.9n 0.20000 45180.0n 0.20000 45359.9n 0.20000 45360.0n 0.20000 45539.9n 0.20000 45540.0n 0.20000 45719.9n 0.20000 45720.0n 0.20000 45899.9n 0.20000 45900.0n 0.20000 46079.9n 0.20000 46080.0n 0.20000 46259.9n 0.20000 46260.0n 0.20000 46439.9n 0.20000 46440.0n 0.20000 46619.9n 0.20000 46620.0n 0.20000 46799.9n 0.20000 46800.0n 0.20000 46979.9n 0.20000 46980.0n 0.20000 47159.9n 0.20000 47160.0n 0.20000 47339.9n 0.20000 47340.0n 0.20000 47519.9n 0.20000 47520.0n 0.20000 47699.9n 0.20000 47700.0n 0.20000 47879.9n 0.20000 47880.0n 0.20000 48059.9n 0.20000 48060.0n 0.20000 48239.9n 0.20000 48240.0n 0.20000 48419.9n 0.20000 48420.0n 0.20000 48599.9n 0.20000 48600.0n 0.20000 48779.9n 0.20000 48780.0n 0.20000 48959.9n 0.20000 48960.0n 0.20000 49139.9n 0.20000 49140.0n 0.20000 49319.9n 0.20000 49320.0n 0.20000 49499.9n 0.20000 49500.0n 0.20000 49679.9n 0.20000 49680.0n 0.20000 49859.9n 0.20000 49860.0n 0.20000 50039.9n 0.20000 50040.0n 0.20000 50219.9n 0.20000 50220.0n 0.20000 50399.9n 0.20000 50400.0n 0.20000 50579.9n 0.20000 50580.0n 0.20000 50759.9n 0.20000 50760.0n 0.20000 50939.9n 0.20000 50940.0n 0.20000 51119.9n 0.20000 51120.0n 0.20000 51299.9n 0.20000 51300.0n 0.20000 51479.9n 0.20000 51480.0n 0.20000 51659.9n 0.20000 51660.0n 0.20000 51839.9n 0.20000 51840.0n 0.20000 52019.9n 0.20000 52020.0n 0.20000 52199.9n 0.20000 52200.0n 0.20000 52379.9n 0.20000 52380.0n 0.20000 52559.9n 0.20000 52560.0n 0.20000 52739.9n 0.20000 52740.0n 0.20000 52919.9n 0.20000 52920.0n 0.20000 53099.9n 0.20000 53100.0n 0.20000 53279.9n 0.20000 53280.0n 0.20000 53459.9n 0.20000 53460.0n 0.20000 53639.9n 0.20000 53640.0n 0.20000 53819.9n 0.20000 53820.0n 0.20000 53999.9n 0.20000 54000.0n 0.20000 54179.9n 0.20000 54180.0n 0.20000 54359.9n 0.20000 54360.0n 0.20000 54539.9n 0.20000 54540.0n 0.20000 54719.9n 0.20000 54720.0n 0.20000 54899.9n 0.20000 54900.0n 0.20000 55079.9n 0.20000 55080.0n 0.20000 55259.9n 0.20000 55260.0n 0.20000 55439.9n 0.20000 55440.0n 0.20000 55619.9n 0.20000 55620.0n 0.20000 55799.9n 0.20000 55800.0n 0.20000 55979.9n 0.20000 55980.0n 0.20000 56159.9n 0.20000 56160.0n 0.20000 56339.9n 0.20000 56340.0n 0.20000 56519.9n 0.20000 56520.0n 0.20000 56699.9n 0.20000 56700.0n 0.20000 56879.9n 0.20000 56880.0n 0.20000 57059.9n 0.20000 57060.0n 0.20000 57239.9n 0.20000 57240.0n 0.20000 57419.9n 0.20000 57420.0n 0.20000 57599.9n 0.20000 57600.0n 0.20000 57779.9n 0.20000 57780.0n 0.20000 57959.9n 0.20000 57960.0n 0.20000 58139.9n 0.20000 58140.0n 0.20000 58319.9n 0.20000 58320.0n 0.20000 58499.9n 0.20000 58500.0n 0.20000 58679.9n 0.20000 58680.0n 0.20000 58859.9n 0.20000 58860.0n 0.20000 59039.9n 0.20000 59040.0n 0.20000 59219.9n 0.20000 59220.0n 0.20000 59399.9n 0.20000 59400.0n 0.20000 59579.9n 0.20000 59580.0n 0.20000 59759.9n 0.20000 59760.0n 0.20000 59939.9n 0.20000 59940.0n 0.20000 60119.9n 0.20000 60120.0n 0.20000 60299.9n 0.20000 60300.0n 0.20000 60479.9n 0.20000 60480.0n 0.20000 60659.9n 0.20000 60660.0n 0.20000 60839.9n 0.20000 60840.0n 0.20000 61019.9n 0.20000 61020.0n 0.20000 61199.9n 0.20000 61200.0n 0.20000 61379.9n 0.20000 61380.0n 0.20000 61559.9n 0.20000 61560.0n 0.20000 61739.9n 0.20000 61740.0n 0.20000 61919.9n 0.20000 61920.0n 0.20000 62099.9n 0.20000 62100.0n 0.20000 62279.9n 0.20000 62280.0n 0.20000 62459.9n 0.20000 62460.0n 0.20000 62639.9n 0.20000 62640.0n 0.20000 62819.9n 0.20000 62820.0n 0.20000 62999.9n 0.20000 63000.0n 0.20000 63179.9n 0.20000 63180.0n 0.20000 63359.9n 0.20000 63360.0n 0.20000 63539.9n 0.20000 63540.0n 0.20000 63719.9n 0.20000 63720.0n 0.20000 63899.9n 0.20000 63900.0n 0.20000 64079.9n 0.20000 64080.0n 0.20000 64259.9n 0.20000 64260.0n 0.20000 64439.9n 0.20000 64440.0n 0.20000 64619.9n 0.20000 64620.0n 0.20000 64799.9n 0.20000 64800.0n 0.20000 64979.9n 0.20000 64980.0n 0.20000 65159.9n 0.20000 65160.0n 0.20000 65339.9n 0.20000 65340.0n 0.20000 65519.9n 0.20000 65520.0n 0.20000 65699.9n 0.20000 65700.0n 0.20000 65879.9n 0.20000 65880.0n 0.20000 66059.9n 0.20000 66060.0n 0.20000 66239.9n 0.20000 66240.0n 0.20000 66419.9n 0.20000 66420.0n 0.20000 66599.9n 0.20000 66600.0n 0.20000 66779.9n 0.20000 66780.0n 0.20000 66959.9n 0.20000 66960.0n 0.20000 67139.9n 0.20000 67140.0n 0.20000 67319.9n 0.20000 67320.0n 0.20000 67499.9n 0.20000 67500.0n 0.20000 67679.9n 0.20000 67680.0n 0.20000 67859.9n 0.20000 67860.0n 0.20000 68039.9n 0.20000 68040.0n 0.20000 68219.9n 0.20000 68220.0n 0.20000 68399.9n 0.20000 68400.0n 0.20000 68579.9n 0.20000 68580.0n 0.20000 68759.9n 0.20000 68760.0n 0.20000 68939.9n 0.20000 68940.0n 0.20000 69119.9n 0.20000 69120.0n 0.20000 69299.9n 0.20000 69300.0n 0.20000 69479.9n 0.20000 69480.0n 0.20000 69659.9n 0.20000 69660.0n 0.20000 69839.9n 0.20000 69840.0n 0.20000 70019.9n 0.20000 70020.0n 0.20000 70199.9n 0.20000 70200.0n 0.20000 70379.9n 0.20000 70380.0n 0.20000 70559.9n 0.20000 70560.0n 0.20000 70739.9n 0.20000 70740.0n 0.20000 70919.9n 0.20000 70920.0n 0.20000 71099.9n 0.20000 71100.0n 0.20000 71279.9n 0.20000 71280.0n 0.20000 71459.9n 0.20000 71460.0n 0.20000 71639.9n 0.20000 71640.0n 0.20000 71819.9n 0.20000 71820.0n 0.20000 71999.9n 0.20000 72000.0n 0.20000 72179.9n 0.20000 72180.0n 0.20000 72359.9n 0.20000 72360.0n 0.20000 72539.9n 0.20000 72540.0n 0.20000 72719.9n 0.20000 72720.0n 0.20000 72899.9n 0.20000 72900.0n 0.20000 73079.9n 0.20000 73080.0n 0.20000 73259.9n 0.20000 73260.0n 0.20000 73439.9n 0.20000 73440.0n 0.20000 73619.9n 0.20000 73620.0n 0.20000 73799.9n 0.20000 73800.0n 0.20000 73979.9n 0.20000 73980.0n 0.20000 74159.9n 0.20000 74160.0n 0.20000 74339.9n 0.20000 74340.0n 0.20000 74519.9n 0.20000 74520.0n 0.20000 74699.9n 0.20000 74700.0n 0.20000 74879.9n 0.20000 74880.0n 0.20000 75059.9n 0.20000 75060.0n 0.20000 75239.9n 0.20000 75240.0n 0.20000 75419.9n 0.20000 75420.0n 0.20000 75599.9n 0.20000 75600.0n 0.20000 75779.9n 0.20000 75780.0n 0.20000 75959.9n 0.20000 75960.0n 0.20000 76139.9n 0.20000 76140.0n 0.20000 76319.9n 0.20000 76320.0n 0.20000 76499.9n 0.20000 76500.0n 0.20000 76679.9n 0.20000 76680.0n 0.20000 76859.9n 0.20000 76860.0n 0.20000 77039.9n 0.20000 77040.0n 0.20000 77219.9n 0.20000 77220.0n 0.20000 77399.9n 0.20000 77400.0n 0.20000 77579.9n 0.20000 77580.0n 0.20000 77759.9n 0.20000 77760.0n 0.20000 77939.9n 0.20000 77940.0n 0.20000 78119.9n 0.20000 78120.0n 0.20000 78299.9n 0.20000 78300.0n 0.20000 78479.9n 0.20000 78480.0n 0.20000 78659.9n 0.20000 78660.0n 0.20000 78839.9n 0.20000 78840.0n 0.20000 79019.9n 0.20000 79020.0n 0.20000 79199.9n 0.20000 79200.0n 0.20000 79379.9n 0.20000 79380.0n 0.20000 79559.9n 0.20000 79560.0n 0.20000 79739.9n 0.20000 79740.0n 0.20000 79919.9n 0.20000 79920.0n 0.20000 80099.9n 0.20000 80100.0n 0.20000 80279.9n 0.20000 80280.0n 0.20000 80459.9n 0.20000 80460.0n 0.20000 80639.9n 0.20000 80640.0n 0.20000 80819.9n 0.20000 80820.0n 0.20000 80999.9n 0.20000 81000.0n 0.20000 81179.9n 0.20000 81180.0n 0.20000 81359.9n 0.20000 81360.0n 0.20000 81539.9n 0.20000 81540.0n 0.20000 81719.9n 0.20000 81720.0n 0.20000 81899.9n 0.20000 81900.0n 0.20000 82079.9n 0.20000 82080.0n 0.20000 82259.9n 0.20000 82260.0n 0.20000 82439.9n 0.20000 82440.0n 0.20000 82619.9n 0.20000 82620.0n 0.20000 82799.9n 0.20000 82800.0n 0.20000 82979.9n 0.20000 82980.0n 0.20000 83159.9n 0.20000 83160.0n 0.20000 83339.9n 0.20000 83340.0n 0.20000 83519.9n 0.20000 83520.0n 0.20000 83699.9n 0.20000 83700.0n 0.20000 83879.9n 0.20000 83880.0n 0.20000 84059.9n 0.20000 84060.0n 0.20000 84239.9n 0.20000 84240.0n 0.20000 84419.9n 0.20000 84420.0n 0.20000 84599.9n 0.20000 84600.0n 0.20000 84779.9n 0.20000 84780.0n 0.20000 84959.9n 0.20000 84960.0n 0.20000 85139.9n 0.20000 85140.0n 0.20000 85319.9n 0.20000 85320.0n 0.20000 85499.9n 0.20000 85500.0n 0.20000 85679.9n 0.20000 85680.0n 0.20000 85859.9n 0.20000 85860.0n 0.20000 86039.9n 0.20000 86040.0n 0.20000 86219.9n 0.20000 86220.0n 0.20000 86399.9n 0.20000 86400.0n 0.20000 86579.9n 0.20000 86580.0n 0.20000 86759.9n 0.20000 86760.0n 0.20000 86939.9n 0.20000 86940.0n 0.20000 87119.9n 0.20000 87120.0n 0.20000 87299.9n 0.20000 87300.0n 0.20000 87479.9n 0.20000 87480.0n 0.20000 87659.9n 0.20000 87660.0n 0.20000 87839.9n 0.20000 87840.0n 0.20000 88019.9n 0.20000 88020.0n 0.20000 88199.9n 0.20000 88200.0n 0.20000 88379.9n 0.20000 88380.0n 0.20000 88559.9n 0.20000 88560.0n 0.20000 88739.9n 0.20000 88740.0n 0.20000 88919.9n 0.20000 88920.0n 0.20000 89099.9n 0.20000 89100.0n 0.20000 89279.9n 0.20000 89280.0n 0.20000 89459.9n 0.20000 89460.0n 0.20000 89639.9n 0.20000 89640.0n 0.20000 89819.9n 0.20000 89820.0n 0.20000 89999.9n 0.20000 90000.0n 0.20000 90179.9n 0.20000 90180.0n 0.20000 90359.9n 0.20000 90360.0n 0.20000 90539.9n 0.20000 90540.0n 0.20000 90719.9n 0.20000 90720.0n 0.20000 90899.9n 0.20000 90900.0n 0.20000 91079.9n 0.20000 91080.0n 0.20000 91259.9n 0.20000 91260.0n 0.20000 91439.9n 0.20000 91440.0n 0.20000 91619.9n 0.20000 91620.0n 0.20000 91799.9n 0.20000 91800.0n 0.20000 91979.9n 0.20000 91980.0n 0.20000 92159.9n 0.20000 92160.0n 0.20000 92339.9n 0.20000 92340.0n 0.20000 92519.9n 0.20000 92520.0n 0.20000 92699.9n 0.20000 92700.0n 0.20000 92879.9n 0.20000 92880.0n 0.20000 93059.9n 0.20000 93060.0n 0.20000 93239.9n 0.20000 93240.0n 0.20000 93419.9n 0.20000 93420.0n 0.20000 93599.9n 0.20000 93600.0n 0.20000 93779.9n 0.20000 93780.0n 0.20000 93959.9n 0.20000 93960.0n 0.20000 94139.9n 0.20000 94140.0n 0.20000 94319.9n 0.20000 94320.0n 0.20000 94499.9n 0.20000 94500.0n 0.20000 94679.9n 0.20000 94680.0n 0.20000 94859.9n 0.20000 94860.0n 0.20000 95039.9n 0.20000 95040.0n 0.20000 95219.9n 0.20000 95220.0n 0.20000 95399.9n 0.20000 95400.0n 0.20000 95579.9n 0.20000 95580.0n 0.20000 95759.9n 0.20000 95760.0n 0.20000 95939.9n 0.20000 95940.0n 0.20000 96119.9n 0.20000 96120.0n 0.20000 96299.9n 0.20000 96300.0n 0.20000 96479.9n 0.20000 96480.0n 0.20000 96659.9n 0.20000 96660.0n 0.20000 96839.9n 0.20000 96840.0n 0.20000 97019.9n 0.20000 97020.0n 0.20000 97199.9n 0.20000 97200.0n 0.20000 97379.9n 0.20000 97380.0n 0.20000 97559.9n 0.20000 97560.0n 0.20000 97739.9n 0.20000 97740.0n 0.20000 97919.9n 0.20000 97920.0n 0.20000 98099.9n 0.20000 98100.0n 0.20000 98279.9n 0.20000 98280.0n 0.20000 98459.9n 0.20000 98460.0n 0.20000 98639.9n 0.20000 98640.0n 0.20000 98819.9n 0.20000 98820.0n 0.20000 98999.9n 0.20000 99000.0n 0.20000 99179.9n 0.20000 99180.0n 0.20000 99359.9n 0.20000 99360.0n 0.20000 99539.9n 0.20000 99540.0n 0.20000 99719.9n 0.20000 99720.0n 0.20000 99899.9n 0.20000 99900.0n 0.20000 100079.9n 0.20000 100080.0n 0.20000 100259.9n 0.20000 100260.0n 0.20000 100439.9n 0.20000 100440.0n 0.20000 100619.9n 0.20000 100620.0n 0.20000 100799.9n 0.20000 100800.0n 0.20000 100979.9n 0.20000 100980.0n 0.20000 101159.9n 0.20000 101160.0n 0.20000 101339.9n 0.20000 101340.0n 0.20000 101519.9n 0.20000 101520.0n 0.20000 101699.9n 0.20000 101700.0n 0.20000 101879.9n 0.20000 101880.0n 0.20000 102059.9n 0.20000 102060.0n 0.20000 102239.9n 0.20000 102240.0n 0.20000 102419.9n 0.20000 102420.0n 0.20000 102599.9n 0.20000 102600.0n 0.20000 102779.9n 0.20000 102780.0n 0.20000 102959.9n 0.20000 102960.0n 0.20000 103139.9n 0.20000 103140.0n 0.20000 103319.9n 0.20000 103320.0n 0.20000 103499.9n 0.20000 103500.0n 0.20000 103679.9n 0.20000 103680.0n 0.20000 103859.9n 0.20000 103860.0n 0.20000 104039.9n 0.20000 104040.0n 0.20000 104219.9n 0.20000 104220.0n 0.20000 104399.9n 0.20000 104400.0n 0.20000 104579.9n 0.20000 104580.0n 0.20000 104759.9n 0.20000 104760.0n 0.20000 104939.9n 0.20000 104940.0n 0.20000 105119.9n 0.20000 105120.0n 0.20000 105299.9n 0.20000 105300.0n 0.20000 105479.9n 0.20000 105480.0n 0.20000 105659.9n 0.20000 105660.0n 0.20000 105839.9n 0.20000 105840.0n 0.20000 106019.9n 0.20000 106020.0n 0.20000 106199.9n 0.20000 106200.0n 0.20000 106379.9n 0.20000 106380.0n 0.20000 106559.9n 0.20000 106560.0n 0.20000 106739.9n 0.20000 106740.0n 0.20000 106919.9n 0.20000 106920.0n 0.20000 107099.9n 0.20000 107100.0n 0.20000 107279.9n 0.20000 107280.0n 0.20000 107459.9n 0.20000 107460.0n 0.20000 107639.9n 0.20000 107640.0n 0.20000 107819.9n 0.20000 107820.0n 0.20000 107999.9n 0.20000 108000.0n 0.20000 108179.9n 0.20000 108180.0n 0.20000 108359.9n 0.20000 108360.0n 0.20000 108539.9n 0.20000 108540.0n 0.20000 108719.9n 0.20000 108720.0n 0.20000 108899.9n 0.20000 108900.0n 0.20000 109079.9n 0.20000 109080.0n 0.20000 109259.9n 0.20000 109260.0n 0.20000 109439.9n 0.20000 109440.0n 0.20000 109619.9n 0.20000 109620.0n 0.20000 109799.9n 0.20000 109800.0n 0.20000 109979.9n 0.20000 109980.0n 0.20000 110159.9n 0.20000 110160.0n 0.20000 110339.9n 0.20000 110340.0n 0.20000 110519.9n 0.20000 110520.0n 0.20000 110699.9n 0.20000 110700.0n 0.20000 110879.9n 0.20000 110880.0n 0.20000 111059.9n 0.20000 111060.0n 0.20000 111239.9n 0.20000 111240.0n 0.20000 111419.9n 0.20000 111420.0n 0.20000 111599.9n 0.20000 111600.0n 0.20000 111779.9n 0.20000 111780.0n 0.20000 111959.9n 0.20000 111960.0n 0.20000 112139.9n 0.20000 112140.0n 0.20000 112319.9n 0.20000 112320.0n 0.20000 112499.9n 0.20000 112500.0n 0.20000 112679.9n 0.20000 112680.0n 0.20000 112859.9n 0.20000 112860.0n 0.20000 113039.9n 0.20000 113040.0n 0.20000 113219.9n 0.20000 113220.0n 0.20000 113399.9n 0.20000 113400.0n 0.20000 113579.9n 0.20000 113580.0n 0.20000 113759.9n 0.20000 113760.0n 0.20000 113939.9n 0.20000 113940.0n 0.20000 114119.9n 0.20000 114120.0n 0.20000 114299.9n 0.20000 114300.0n 0.20000 114479.9n 0.20000 114480.0n 0.20000 114659.9n 0.20000 114660.0n 0.20000 114839.9n 0.20000 114840.0n 0.20000 115019.9n 0.20000 115020.0n 0.20000 115199.9n 0.20000 115200.0n 0.20000 115379.9n 0.20000 115380.0n 0.20000 115559.9n 0.20000 115560.0n 0.20000 115739.9n 0.20000 115740.0n 0.20000 115919.9n 0.20000 115920.0n 0.20000 116099.9n 0.20000 116100.0n 0.20000 116279.9n 0.20000 116280.0n 0.20000 116459.9n 0.20000 116460.0n 0.20000 116639.9n 0.20000 116640.0n 0.20000 116819.9n 0.20000 116820.0n 0.20000 116999.9n 0.20000 117000.0n 0.20000 117179.9n 0.20000 117180.0n 0.20000 117359.9n 0.20000 117360.0n 0.20000 117539.9n 0.20000 117540.0n 0.20000 117719.9n 0.20000 117720.0n 0.20000 117899.9n 0.20000 117900.0n 0.20000 118079.9n 0.20000 118080.0n 0.20000 118259.9n 0.20000 118260.0n 0.20000 118439.9n 0.20000 118440.0n 0.20000 118619.9n 0.20000 118620.0n 0.20000 118799.9n 0.20000 118800.0n 0.20000 118979.9n 0.20000 118980.0n 0.20000 119159.9n 0.20000 119160.0n 0.20000 119339.9n 0.20000 119340.0n 0.20000 119519.9n 0.20000 119520.0n 0.20000 119699.9n 0.20000 119700.0n 0.20000 119879.9n 0.20000 119880.0n 0.20000 120059.9n 0.20000 120060.0n 0.20000 120239.9n 0.20000 120240.0n 0.20000 120419.9n 0.20000 120420.0n 0.20000 120599.9n 0.20000 120600.0n 0.20000 120779.9n 0.20000 120780.0n 0.20000 120959.9n 0.20000 120960.0n 0.20000 121139.9n 0.20000 121140.0n 0.20000 121319.9n 0.20000 121320.0n 0.20000 121499.9n 0.20000 121500.0n 0.20000 121679.9n 0.20000 121680.0n 0.20000 121859.9n 0.20000 121860.0n 0.20000 122039.9n 0.20000 122040.0n 0.20000 122219.9n 0.20000 122220.0n 0.20000 122399.9n 0.20000 122400.0n 0.20000 122579.9n 0.20000 122580.0n 0.20000 122759.9n 0.20000 122760.0n 0.20000 122939.9n 0.20000 122940.0n 0.20000 123119.9n 0.20000 123120.0n 0.20000 123299.9n 0.20000 123300.0n 0.20000 123479.9n 0.20000 123480.0n 0.20000 123659.9n 0.20000 123660.0n 0.20000 123839.9n 0.20000 123840.0n 0.20000 124019.9n 0.20000 124020.0n 0.20000 124199.9n 0.20000 124200.0n 0.20000 124379.9n 0.20000 124380.0n 0.20000 124559.9n 0.20000 124560.0n 0.20000 124739.9n 0.20000 124740.0n 0.20000 124919.9n 0.20000 124920.0n 0.20000 125099.9n 0.20000 125100.0n 0.20000 125279.9n 0.20000 125280.0n 0.20000 125459.9n 0.20000 125460.0n 0.20000 125639.9n 0.20000 125640.0n 0.20000 125819.9n 0.20000 125820.0n 0.20000 125999.9n 0.20000 126000.0n 0.20000 126179.9n 0.20000 126180.0n 0.20000 126359.9n 0.20000 126360.0n 0.20000 126539.9n 0.20000 126540.0n 0.20000 126719.9n 0.20000 126720.0n 0.20000 126899.9n 0.20000 126900.0n 0.20000 127079.9n 0.20000 127080.0n 0.20000 127259.9n 0.20000 127260.0n 0.20000 127439.9n 0.20000 127440.0n 0.20000 127619.9n 0.20000 127620.0n 0.20000 127799.9n 0.20000 127800.0n 0.20000 127979.9n 0.20000 127980.0n 0.20000 128159.9n 0.20000 128160.0n 0.20000 128339.9n 0.20000 128340.0n 0.20000 128519.9n 0.20000 128520.0n 0.20000 128699.9n 0.20000 128700.0n 0.20000 128879.9n 0.20000 128880.0n 0.20000 129059.9n 0.20000 129060.0n 0.20000 129239.9n 0.20000 129240.0n 0.20000 129419.9n 0.20000 129420.0n 0.20000 129599.9n 0.20000 129600.0n 0.20000 129779.9n 0.20000 129780.0n 0.20000 129959.9n 0.20000 129960.0n 0.20000 130139.9n 0.20000 130140.0n 0.20000 130319.9n 0.20000 130320.0n 0.20000 130499.9n 0.20000 130500.0n 0.20000 130679.9n 0.20000 130680.0n 0.20000 130859.9n 0.20000 130860.0n 0.20000 131039.9n 0.20000 131040.0n 0.20000 131219.9n 0.20000 131220.0n 0.20000 131399.9n 0.20000 131400.0n 0.20000 131579.9n 0.20000 131580.0n 0.20000 131759.9n 0.20000 131760.0n 0.20000 131939.9n 0.20000 131940.0n 0.20000 132119.9n 0.20000 132120.0n 0.20000 132299.9n 0.20000 132300.0n 0.20000 132479.9n 0.20000 132480.0n 0.20000 132659.9n 0.20000 132660.0n 0.20000 132839.9n 0.20000 132840.0n 0.20000 133019.9n 0.20000 133020.0n 0.20000 133199.9n 0.20000 133200.0n 0.20000 133379.9n 0.20000 133380.0n 0.20000 133559.9n 0.20000 133560.0n 0.20000 133739.9n 0.20000 133740.0n 0.20000 133919.9n 0.20000 133920.0n 0.20000 134099.9n 0.20000 134100.0n 0.20000 134279.9n 0.20000 134280.0n 0.20000 134459.9n 0.20000 134460.0n 0.20000 134639.9n 0.20000 134640.0n 0.20000 134819.9n 0.20000 134820.0n 0.20000 134999.9n 0.20000 135000.0n 0.20000 135179.9n 0.20000 135180.0n 0.20000 135359.9n 0.20000 135360.0n 0.20000 135539.9n 0.20000 135540.0n 0.20000 135719.9n 0.20000 135720.0n 0.20000 135899.9n 0.20000 135900.0n 0.20000 136079.9n 0.20000 136080.0n 0.20000 136259.9n 0.20000 136260.0n 0.20000 136439.9n 0.20000 136440.0n 0.20000 136619.9n 0.20000 136620.0n 0.20000 136799.9n 0.20000 136800.0n 0.20000 136979.9n 0.20000 136980.0n 0.20000 137159.9n 0.20000 137160.0n 0.20000 137339.9n 0.20000 137340.0n 0.20000 137519.9n 0.20000 137520.0n 0.20000 137699.9n 0.20000 137700.0n 0.20000 137879.9n 0.20000 137880.0n 0.20000 138059.9n 0.20000 138060.0n 0.20000 138239.9n 0.20000 138240.0n 0.20000 138419.9n 0.20000 138420.0n 0.20000 138599.9n 0.20000 138600.0n 0.20000 138779.9n 0.20000 138780.0n 0.20000 138959.9n 0.20000 138960.0n 0.20000 139139.9n 0.20000 139140.0n 0.20000 139319.9n 0.20000 139320.0n 0.20000 139499.9n 0.20000 139500.0n 0.20000 139679.9n 0.20000 139680.0n 0.20000 139859.9n 0.20000 139860.0n 0.20000 140039.9n 0.20000 140040.0n 0.20000 140219.9n 0.20000 140220.0n 0.20000 140399.9n 0.20000 140400.0n 0.20000 140579.9n 0.20000 140580.0n 0.20000 140759.9n 0.20000 140760.0n 0.20000 140939.9n 0.20000 140940.0n 0.20000 141119.9n 0.20000 141120.0n 0.20000 141299.9n 0.20000 141300.0n 0.20000 141479.9n 0.20000 141480.0n 0.20000 141659.9n 0.20000 141660.0n 0.20000 141839.9n 0.20000 141840.0n 0.20000 142019.9n 0.20000 142020.0n 0.20000 142199.9n 0.20000 142200.0n 0.20000 142379.9n 0.20000 142380.0n 0.20000 142559.9n 0.20000 142560.0n 0.20000 142739.9n 0.20000 142740.0n 0.20000 142919.9n 0.20000 142920.0n 0.20000 143099.9n 0.20000 143100.0n 0.20000 143279.9n 0.20000 143280.0n 0.20000 143459.9n 0.20000 143460.0n 0.20000 143639.9n 0.20000 143640.0n 0.20000 143819.9n 0.20000 143820.0n 0.20000 143999.9n 0.20000 144000.0n 0.20000 144179.9n 0.20000 144180.0n 0.20000 144359.9n 0.20000 144360.0n 0.20000 144539.9n 0.20000 144540.0n 0.20000 144719.9n 0.20000 144720.0n 0.20000 144899.9n 0.20000 144900.0n 0.20000 145079.9n 0.20000 145080.0n 0.20000 145259.9n 0.20000 145260.0n 0.20000 145439.9n 0.20000 145440.0n 0.20000 145619.9n 0.20000 145620.0n 0.20000 145799.9n 0.20000 145800.0n 0.20000 145979.9n 0.20000 145980.0n 0.20000 146159.9n 0.20000 146160.0n 0.20000 146339.9n 0.20000 146340.0n 0.20000 146519.9n 0.20000 146520.0n 0.20000 146699.9n 0.20000 146700.0n 0.20000 146879.9n 0.20000 146880.0n 0.20000 147059.9n 0.20000 147060.0n 0.20000 147239.9n 0.20000 147240.0n 0.20000 147419.9n 0.20000 147420.0n 0.20000 147599.9n 0.20000 147600.0n 0.20000 147779.9n 0.20000 147780.0n 0.20000 147959.9n 0.20000 147960.0n 0.20000 148139.9n 0.20000 148140.0n 0.20000 148319.9n 0.20000 148320.0n 0.20000 148499.9n 0.20000 148500.0n 0.20000 148679.9n 0.20000 148680.0n 0.20000 148859.9n 0.20000 148860.0n 0.20000 149039.9n 0.20000 149040.0n 0.20000 149219.9n 0.20000 149220.0n 0.20000 149399.9n 0.20000 149400.0n 0.20000 149579.9n 0.20000 149580.0n 0.20000 149759.9n 0.20000 149760.0n 0.20000 149939.9n 0.20000 149940.0n 0.20000 150119.9n 0.20000 150120.0n 0.20000 150299.9n 0.20000 150300.0n 0.20000 150479.9n 0.20000 150480.0n 0.20000 150659.9n 0.20000 150660.0n 0.20000 150839.9n 0.20000 150840.0n 0.20000 151019.9n 0.20000 151020.0n 0.20000 151199.9n 0.20000 151200.0n 0.20000 151379.9n 0.20000 151380.0n 0.20000 151559.9n 0.20000 151560.0n 0.20000 151739.9n 0.20000 151740.0n 0.20000 151919.9n 0.20000 151920.0n 0.20000 152099.9n 0.20000 152100.0n 0.20000 152279.9n 0.20000 152280.0n 0.20000 152459.9n 0.20000 152460.0n 0.20000 152639.9n 0.20000 152640.0n 0.20000 152819.9n 0.20000 152820.0n 0.20000 152999.9n 0.20000 153000.0n 0.20000 153179.9n 0.20000 153180.0n 0.20000 153359.9n 0.20000 153360.0n 0.20000 153539.9n 0.20000 153540.0n 0.20000 153719.9n 0.20000 153720.0n 0.20000 153899.9n 0.20000 153900.0n 0.20000 154079.9n 0.20000 154080.0n 0.20000 154259.9n 0.20000 154260.0n 0.20000 154439.9n 0.20000 154440.0n 0.20000 154619.9n 0.20000 154620.0n 0.20000 154799.9n 0.20000 154800.0n 0.20000 154979.9n 0.20000 154980.0n 0.20000 155159.9n 0.20000 155160.0n 0.20000 155339.9n 0.20000 155340.0n 0.20000 155519.9n 0.20000 155520.0n 0.20000 155699.9n 0.20000 155700.0n 0.20000 155879.9n 0.20000 155880.0n 0.20000 156059.9n 0.20000 156060.0n 0.20000 156239.9n 0.20000 156240.0n 0.20000 156419.9n 0.20000 156420.0n 0.20000 156599.9n 0.20000 156600.0n 0.20000 156779.9n 0.20000 156780.0n 0.20000 156959.9n 0.20000 156960.0n 0.20000 157139.9n 0.20000 157140.0n 0.20000 157319.9n 0.20000 157320.0n 0.20000 157499.9n 0.20000 157500.0n 0.20000 157679.9n 0.20000 157680.0n 0.20000 157859.9n 0.20000 157860.0n 0.20000 158039.9n 0.20000 158040.0n 0.20000 158219.9n 0.20000 158220.0n 0.20000 158399.9n 0.20000 158400.0n 0.20000 158579.9n 0.20000 158580.0n 0.20000 158759.9n 0.20000 158760.0n 0.20000 158939.9n 0.20000 158940.0n 0.20000 159119.9n 0.20000 159120.0n 0.20000 159299.9n 0.20000 159300.0n 0.20000 159479.9n 0.20000 159480.0n 0.20000 159659.9n 0.20000 159660.0n 0.20000 159839.9n 0.20000 159840.0n 0.20000 160019.9n 0.20000 160020.0n 0.20000 160199.9n 0.20000 160200.0n 0.20000 160379.9n 0.20000 160380.0n 0.20000 160559.9n 0.20000 160560.0n 0.20000 160739.9n 0.20000 160740.0n 0.20000 160919.9n 0.20000 160920.0n 0.20000 161099.9n 0.20000 161100.0n 0.20000 161279.9n 0.20000 161280.0n 0.20000 161459.9n 0.20000 161460.0n 0.20000 161639.9n 0.20000 161640.0n 0.20000 161819.9n 0.20000 161820.0n 0.20000 161999.9n 0.20000 162000.0n 0.20000 162179.9n 0.20000 162180.0n 0.20000 162359.9n 0.20000 162360.0n 0.20000 162539.9n 0.20000 162540.0n 0.20000 162719.9n 0.20000 162720.0n 0.20000 162899.9n 0.20000 162900.0n 0.20000 163079.9n 0.20000 163080.0n 0.20000 163259.9n 0.20000 163260.0n 0.20000 163439.9n 0.20000 163440.0n 0.20000 163619.9n 0.20000 163620.0n 0.20000 163799.9n 0.20000 163800.0n 0.20000 163979.9n 0.20000 163980.0n 0.20000 164159.9n 0.20000 164160.0n 0.20000 164339.9n 0.20000 164340.0n 0.20000 164519.9n 0.20000 164520.0n 0.20000 164699.9n 0.20000 164700.0n 0.20000 164879.9n 0.20000 164880.0n 0.20000 165059.9n 0.20000 165060.0n 0.20000 165239.9n 0.20000 165240.0n 0.20000 165419.9n 0.20000 165420.0n 0.20000 165599.9n 0.20000 165600.0n 0.20000 165779.9n 0.20000 165780.0n 0.20000 165959.9n 0.20000 165960.0n 0.20000 166139.9n 0.20000 166140.0n 0.20000 166319.9n 0.20000 166320.0n 0.20000 166499.9n 0.20000 166500.0n 0.20000 166679.9n 0.20000 166680.0n 0.20000 166859.9n 0.20000 166860.0n 0.20000 167039.9n 0.20000 167040.0n 0.20000 167219.9n 0.20000 167220.0n 0.20000 167399.9n 0.20000 167400.0n 0.20000 167579.9n 0.20000 167580.0n 0.20000 167759.9n 0.20000 167760.0n 0.20000 167939.9n 0.20000 167940.0n 0.20000 168119.9n 0.20000 168120.0n 0.20000 168299.9n 0.20000 168300.0n 0.20000 168479.9n 0.20000 168480.0n 0.20000 168659.9n 0.20000 168660.0n 0.20000 168839.9n 0.20000 168840.0n 0.20000 169019.9n 0.20000 169020.0n 0.20000 169199.9n 0.20000 169200.0n 0.20000 169379.9n 0.20000 169380.0n 0.20000 169559.9n 0.20000 169560.0n 0.20000 169739.9n 0.20000 169740.0n 0.20000 169919.9n 0.20000 169920.0n 0.20000 170099.9n 0.20000 170100.0n 0.20000 170279.9n 0.20000 170280.0n 0.20000 170459.9n 0.20000 170460.0n 0.20000 170639.9n 0.20000 170640.0n 0.20000 170819.9n 0.20000 170820.0n 0.20000 170999.9n 0.20000 171000.0n 0.20000 171179.9n 0.20000 171180.0n 0.20000 171359.9n 0.20000 171360.0n 0.20000 171539.9n 0.20000 171540.0n 0.20000 171719.9n 0.20000 171720.0n 0.20000 171899.9n 0.20000 171900.0n 0.20000 172079.9n 0.20000 172080.0n 0.20000 172259.9n 0.20000 172260.0n 0.20000 172439.9n 0.20000 172440.0n 0.20000 172619.9n 0.20000 172620.0n 0.20000 172799.9n 0.20000 172800.0n 0.20000 172979.9n 0.20000 172980.0n 0.20000 173159.9n 0.20000 173160.0n 0.20000 173339.9n 0.20000 173340.0n 0.20000 173519.9n 0.20000 173520.0n 0.20000 173699.9n 0.20000 173700.0n 0.20000 173879.9n 0.20000 173880.0n 0.20000 174059.9n 0.20000 174060.0n 0.20000 174239.9n 0.20000 174240.0n 0.20000 174419.9n 0.20000 174420.0n 0.20000 174599.9n 0.20000 174600.0n 0.20000 174779.9n 0.20000 174780.0n 0.20000 174959.9n 0.20000 174960.0n 0.20000 175139.9n 0.20000 175140.0n 0.20000 175319.9n 0.20000 175320.0n 0.20000 175499.9n 0.20000 175500.0n 0.20000 175679.9n 0.20000 175680.0n 0.20000 175859.9n 0.20000 175860.0n 0.20000 176039.9n 0.20000 176040.0n 0.20000 176219.9n 0.20000 176220.0n 0.20000 176399.9n 0.20000 176400.0n 0.20000 176579.9n 0.20000 176580.0n 0.20000 176759.9n 0.20000 176760.0n 0.20000 176939.9n 0.20000 176940.0n 0.20000 177119.9n 0.20000 177120.0n 0.20000 177299.9n 0.20000 177300.0n 0.20000 177479.9n 0.20000 177480.0n 0.20000 177659.9n 0.20000 177660.0n 0.20000 177839.9n 0.20000 177840.0n 0.20000 178019.9n 0.20000 178020.0n 0.20000 178199.9n 0.20000 178200.0n 0.20000 178379.9n 0.20000 178380.0n 0.20000 178559.9n 0.20000 178560.0n 0.20000 178739.9n 0.20000 178740.0n 0.20000 178919.9n 0.20000 178920.0n 0.20000 179099.9n 0.20000 179100.0n 0.20000 179279.9n 0.20000 179280.0n 0.20000 179459.9n 0.20000 179460.0n 0.20000 179639.9n 0.20000 179640.0n 0.20000 179819.9n 0.20000 179820.0n 0.20000 179999.9n 0.20000 180000.0n 0.20000 180179.9n 0.20000 180180.0n 0.20000 180359.9n 0.20000 180360.0n 0.20000 180539.9n 0.20000 180540.0n 0.20000 180719.9n 0.20000 180720.0n 0.20000 180899.9n 0.20000 180900.0n 0.20000 181079.9n 0.20000 181080.0n 0.20000 181259.9n 0.20000 181260.0n 0.20000 181439.9n 0.20000 181440.0n 0.20000 181619.9n 0.20000 181620.0n 0.20000 181799.9n 0.20000 181800.0n 0.20000 181979.9n 0.20000 181980.0n 0.20000 182159.9n 0.20000 182160.0n 0.20000 182339.9n 0.20000 182340.0n 0.20000 182519.9n 0.20000 182520.0n 0.20000 182699.9n 0.20000 182700.0n 0.20000 182879.9n 0.20000 182880.0n 0.20000 183059.9n 0.20000 183060.0n 0.20000 183239.9n 0.20000 183240.0n 0.20000 183419.9n 0.20000 183420.0n 0.20000)
Vxop0 xop0 0 PWL(0.0n 0.70000 179.9n 0.70000 180.0n 0.70000 359.9n 0.70000 360.0n 0.70000 539.9n 0.70000 540.0n 0.70000 719.9n 0.70000 720.0n 0.30000 899.9n 0.30000 900.0n 0.30000 1079.9n 0.30000 1080.0n 0.30000 1259.9n 0.30000 1260.0n 0.70000 1439.9n 0.70000 1440.0n 0.30000 1619.9n 0.30000 1620.0n 0.30000 1799.9n 0.30000 1800.0n 0.30000 1979.9n 0.30000 1980.0n 0.30000 2159.9n 0.30000 2160.0n 0.70000 2339.9n 0.70000 2340.0n 0.70000 2519.9n 0.70000 2520.0n 0.70000 2699.9n 0.70000 2700.0n 0.30000 2879.9n 0.30000 2880.0n 0.70000 3059.9n 0.70000 3060.0n 0.30000 3239.9n 0.30000 3240.0n 0.70000 3419.9n 0.70000 3420.0n 0.30000 3599.9n 0.30000 3600.0n 0.30000 3779.9n 0.30000 3780.0n 0.70000 3959.9n 0.70000 3960.0n 0.30000 4139.9n 0.30000 4140.0n 0.70000 4319.9n 0.70000 4320.0n 0.30000 4499.9n 0.30000 4500.0n 0.70000 4679.9n 0.70000 4680.0n 0.70000 4859.9n 0.70000 4860.0n 0.30000 5039.9n 0.30000 5040.0n 0.70000 5219.9n 0.70000 5220.0n 0.30000 5399.9n 0.30000 5400.0n 0.70000 5579.9n 0.70000 5580.0n 0.30000 5759.9n 0.30000 5760.0n 0.30000 5939.9n 0.30000 5940.0n 0.30000 6119.9n 0.30000 6120.0n 0.30000 6299.9n 0.30000 6300.0n 0.70000 6479.9n 0.70000 6480.0n 0.70000 6659.9n 0.70000 6660.0n 0.30000 6839.9n 0.30000 6840.0n 0.30000 7019.9n 0.30000 7020.0n 0.30000 7199.9n 0.30000 7200.0n 0.70000 7379.9n 0.70000 7380.0n 0.30000 7559.9n 0.30000 7560.0n 0.70000 7739.9n 0.70000 7740.0n 0.70000 7919.9n 0.70000 7920.0n 0.70000 8099.9n 0.70000 8100.0n 0.70000 8279.9n 0.70000 8280.0n 0.30000 8459.9n 0.30000 8460.0n 0.70000 8639.9n 0.70000 8640.0n 0.30000 8819.9n 0.30000 8820.0n 0.30000 8999.9n 0.30000 9000.0n 0.70000 9179.9n 0.70000 9180.0n 0.70000 9359.9n 0.70000 9360.0n 0.30000 9539.9n 0.30000 9540.0n 0.70000 9719.9n 0.70000 9720.0n 0.70000 9899.9n 0.70000 9900.0n 0.70000 10079.9n 0.70000 10080.0n 0.30000 10259.9n 0.30000 10260.0n 0.30000 10439.9n 0.30000 10440.0n 0.30000 10619.9n 0.30000 10620.0n 0.70000 10799.9n 0.70000 10800.0n 0.70000 10979.9n 0.70000 10980.0n 0.30000 11159.9n 0.30000 11160.0n 0.70000 11339.9n 0.70000 11340.0n 0.30000 11519.9n 0.30000 11520.0n 0.30000 11699.9n 0.30000 11700.0n 0.30000 11879.9n 0.30000 11880.0n 0.30000 12059.9n 0.30000 12060.0n 0.70000 12239.9n 0.70000 12240.0n 0.70000 12419.9n 0.70000 12420.0n 0.30000 12599.9n 0.30000 12600.0n 0.30000 12779.9n 0.30000 12780.0n 0.70000 12959.9n 0.70000 12960.0n 0.70000 13139.9n 0.70000 13140.0n 0.70000 13319.9n 0.70000 13320.0n 0.30000 13499.9n 0.30000 13500.0n 0.30000 13679.9n 0.30000 13680.0n 0.30000 13859.9n 0.30000 13860.0n 0.70000 14039.9n 0.70000 14040.0n 0.30000 14219.9n 0.30000 14220.0n 0.70000 14399.9n 0.70000 14400.0n 0.30000 14579.9n 0.30000 14580.0n 0.70000 14759.9n 0.70000 14760.0n 0.70000 14939.9n 0.70000 14940.0n 0.70000 15119.9n 0.70000 15120.0n 0.70000 15299.9n 0.70000 15300.0n 0.30000 15479.9n 0.30000 15480.0n 0.30000 15659.9n 0.30000 15660.0n 0.30000 15839.9n 0.30000 15840.0n 0.70000 16019.9n 0.70000 16020.0n 0.70000 16199.9n 0.70000 16200.0n 0.30000 16379.9n 0.30000 16380.0n 0.70000 16559.9n 0.70000 16560.0n 0.70000 16739.9n 0.70000 16740.0n 0.30000 16919.9n 0.30000 16920.0n 0.30000 17099.9n 0.30000 17100.0n 0.70000 17279.9n 0.70000 17280.0n 0.30000 17459.9n 0.30000 17460.0n 0.70000 17639.9n 0.70000 17640.0n 0.70000 17819.9n 0.70000 17820.0n 0.70000 17999.9n 0.70000 18000.0n 0.30000 18179.9n 0.30000 18180.0n 0.30000 18359.9n 0.30000 18360.0n 0.70000 18539.9n 0.70000 18540.0n 0.30000 18719.9n 0.30000 18720.0n 0.30000 18899.9n 0.30000 18900.0n 0.70000 19079.9n 0.70000 19080.0n 0.30000 19259.9n 0.30000 19260.0n 0.70000 19439.9n 0.70000 19440.0n 0.70000 19619.9n 0.70000 19620.0n 0.70000 19799.9n 0.70000 19800.0n 0.70000 19979.9n 0.70000 19980.0n 0.30000 20159.9n 0.30000 20160.0n 0.70000 20339.9n 0.70000 20340.0n 0.70000 20519.9n 0.70000 20520.0n 0.30000 20699.9n 0.30000 20700.0n 0.30000 20879.9n 0.30000 20880.0n 0.30000 21059.9n 0.30000 21060.0n 0.70000 21239.9n 0.70000 21240.0n 0.70000 21419.9n 0.70000 21420.0n 0.30000 21599.9n 0.30000 21600.0n 0.30000 21779.9n 0.30000 21780.0n 0.70000 21959.9n 0.70000 21960.0n 0.30000 22139.9n 0.30000 22140.0n 0.70000 22319.9n 0.70000 22320.0n 0.70000 22499.9n 0.70000 22500.0n 0.30000 22679.9n 0.30000 22680.0n 0.30000 22859.9n 0.30000 22860.0n 0.30000 23039.9n 0.30000 23040.0n 0.30000 23219.9n 0.30000 23220.0n 0.70000 23399.9n 0.70000 23400.0n 0.70000 23579.9n 0.70000 23580.0n 0.30000 23759.9n 0.30000 23760.0n 0.70000 23939.9n 0.70000 23940.0n 0.30000 24119.9n 0.30000 24120.0n 0.30000 24299.9n 0.30000 24300.0n 0.70000 24479.9n 0.70000 24480.0n 0.70000 24659.9n 0.70000 24660.0n 0.70000 24839.9n 0.70000 24840.0n 0.70000 25019.9n 0.70000 25020.0n 0.70000 25199.9n 0.70000 25200.0n 0.70000 25379.9n 0.70000 25380.0n 0.30000 25559.9n 0.30000 25560.0n 0.30000 25739.9n 0.30000 25740.0n 0.70000 25919.9n 0.70000 25920.0n 0.30000 26099.9n 0.30000 26100.0n 0.70000 26279.9n 0.70000 26280.0n 0.70000 26459.9n 0.70000 26460.0n 0.30000 26639.9n 0.30000 26640.0n 0.30000 26819.9n 0.30000 26820.0n 0.70000 26999.9n 0.70000 27000.0n 0.70000 27179.9n 0.70000 27180.0n 0.30000 27359.9n 0.30000 27360.0n 0.30000 27539.9n 0.30000 27540.0n 0.30000 27719.9n 0.30000 27720.0n 0.30000 27899.9n 0.30000 27900.0n 0.30000 28079.9n 0.30000 28080.0n 0.70000 28259.9n 0.70000 28260.0n 0.30000 28439.9n 0.30000 28440.0n 0.70000 28619.9n 0.70000 28620.0n 0.30000 28799.9n 0.30000 28800.0n 0.70000 28979.9n 0.70000 28980.0n 0.70000 29159.9n 0.70000 29160.0n 0.70000 29339.9n 0.70000 29340.0n 0.30000 29519.9n 0.30000 29520.0n 0.70000 29699.9n 0.70000 29700.0n 0.70000 29879.9n 0.70000 29880.0n 0.70000 30059.9n 0.70000 30060.0n 0.30000 30239.9n 0.30000 30240.0n 0.70000 30419.9n 0.70000 30420.0n 0.70000 30599.9n 0.70000 30600.0n 0.70000 30779.9n 0.70000 30780.0n 0.70000 30959.9n 0.70000 30960.0n 0.30000 31139.9n 0.30000 31140.0n 0.30000 31319.9n 0.30000 31320.0n 0.30000 31499.9n 0.30000 31500.0n 0.70000 31679.9n 0.70000 31680.0n 0.70000 31859.9n 0.70000 31860.0n 0.70000 32039.9n 0.70000 32040.0n 0.30000 32219.9n 0.30000 32220.0n 0.30000 32399.9n 0.30000 32400.0n 0.30000 32579.9n 0.30000 32580.0n 0.70000 32759.9n 0.70000 32760.0n 0.70000 32939.9n 0.70000 32940.0n 0.70000 33119.9n 0.70000 33120.0n 0.30000 33299.9n 0.30000 33300.0n 0.30000 33479.9n 0.30000 33480.0n 0.30000 33659.9n 0.30000 33660.0n 0.30000 33839.9n 0.30000 33840.0n 0.30000 34019.9n 0.30000 34020.0n 0.30000 34199.9n 0.30000 34200.0n 0.30000 34379.9n 0.30000 34380.0n 0.30000 34559.9n 0.30000 34560.0n 0.30000 34739.9n 0.30000 34740.0n 0.70000 34919.9n 0.70000 34920.0n 0.70000 35099.9n 0.70000 35100.0n 0.70000 35279.9n 0.70000 35280.0n 0.30000 35459.9n 0.30000 35460.0n 0.70000 35639.9n 0.70000 35640.0n 0.30000 35819.9n 0.30000 35820.0n 0.30000 35999.9n 0.30000 36000.0n 0.30000 36179.9n 0.30000 36180.0n 0.70000 36359.9n 0.70000 36360.0n 0.70000 36539.9n 0.70000 36540.0n 0.70000 36719.9n 0.70000 36720.0n 0.30000 36899.9n 0.30000 36900.0n 0.30000 37079.9n 0.30000 37080.0n 0.70000 37259.9n 0.70000 37260.0n 0.30000 37439.9n 0.30000 37440.0n 0.70000 37619.9n 0.70000 37620.0n 0.30000 37799.9n 0.30000 37800.0n 0.30000 37979.9n 0.30000 37980.0n 0.70000 38159.9n 0.70000 38160.0n 0.70000 38339.9n 0.70000 38340.0n 0.70000 38519.9n 0.70000 38520.0n 0.70000 38699.9n 0.70000 38700.0n 0.70000 38879.9n 0.70000 38880.0n 0.70000 39059.9n 0.70000 39060.0n 0.30000 39239.9n 0.30000 39240.0n 0.30000 39419.9n 0.30000 39420.0n 0.30000 39599.9n 0.30000 39600.0n 0.30000 39779.9n 0.30000 39780.0n 0.70000 39959.9n 0.70000 39960.0n 0.30000 40139.9n 0.30000 40140.0n 0.30000 40319.9n 0.30000 40320.0n 0.70000 40499.9n 0.70000 40500.0n 0.70000 40679.9n 0.70000 40680.0n 0.30000 40859.9n 0.30000 40860.0n 0.30000 41039.9n 0.30000 41040.0n 0.30000 41219.9n 0.30000 41220.0n 0.30000 41399.9n 0.30000 41400.0n 0.70000 41579.9n 0.70000 41580.0n 0.70000 41759.9n 0.70000 41760.0n 0.70000 41939.9n 0.70000 41940.0n 0.70000 42119.9n 0.70000 42120.0n 0.70000 42299.9n 0.70000 42300.0n 0.70000 42479.9n 0.70000 42480.0n 0.70000 42659.9n 0.70000 42660.0n 0.70000 42839.9n 0.70000 42840.0n 0.30000 43019.9n 0.30000 43020.0n 0.70000 43199.9n 0.70000 43200.0n 0.30000 43379.9n 0.30000 43380.0n 0.30000 43559.9n 0.30000 43560.0n 0.30000 43739.9n 0.30000 43740.0n 0.30000 43919.9n 0.30000 43920.0n 0.70000 44099.9n 0.70000 44100.0n 0.70000 44279.9n 0.70000 44280.0n 0.30000 44459.9n 0.30000 44460.0n 0.70000 44639.9n 0.70000 44640.0n 0.30000 44819.9n 0.30000 44820.0n 0.70000 44999.9n 0.70000 45000.0n 0.30000 45179.9n 0.30000 45180.0n 0.70000 45359.9n 0.70000 45360.0n 0.30000 45539.9n 0.30000 45540.0n 0.30000 45719.9n 0.30000 45720.0n 0.30000 45899.9n 0.30000 45900.0n 0.30000 46079.9n 0.30000 46080.0n 0.70000 46259.9n 0.70000 46260.0n 0.70000 46439.9n 0.70000 46440.0n 0.30000 46619.9n 0.30000 46620.0n 0.30000 46799.9n 0.30000 46800.0n 0.30000 46979.9n 0.30000 46980.0n 0.70000 47159.9n 0.70000 47160.0n 0.70000 47339.9n 0.70000 47340.0n 0.30000 47519.9n 0.30000 47520.0n 0.30000 47699.9n 0.30000 47700.0n 0.30000 47879.9n 0.30000 47880.0n 0.70000 48059.9n 0.70000 48060.0n 0.30000 48239.9n 0.30000 48240.0n 0.70000 48419.9n 0.70000 48420.0n 0.70000 48599.9n 0.70000 48600.0n 0.70000 48779.9n 0.70000 48780.0n 0.70000 48959.9n 0.70000 48960.0n 0.30000 49139.9n 0.30000 49140.0n 0.70000 49319.9n 0.70000 49320.0n 0.70000 49499.9n 0.70000 49500.0n 0.30000 49679.9n 0.30000 49680.0n 0.70000 49859.9n 0.70000 49860.0n 0.30000 50039.9n 0.30000 50040.0n 0.30000 50219.9n 0.30000 50220.0n 0.30000 50399.9n 0.30000 50400.0n 0.70000 50579.9n 0.70000 50580.0n 0.30000 50759.9n 0.30000 50760.0n 0.70000 50939.9n 0.70000 50940.0n 0.70000 51119.9n 0.70000 51120.0n 0.30000 51299.9n 0.30000 51300.0n 0.70000 51479.9n 0.70000 51480.0n 0.30000 51659.9n 0.30000 51660.0n 0.30000 51839.9n 0.30000 51840.0n 0.70000 52019.9n 0.70000 52020.0n 0.70000 52199.9n 0.70000 52200.0n 0.70000 52379.9n 0.70000 52380.0n 0.30000 52559.9n 0.30000 52560.0n 0.70000 52739.9n 0.70000 52740.0n 0.30000 52919.9n 0.30000 52920.0n 0.30000 53099.9n 0.30000 53100.0n 0.70000 53279.9n 0.70000 53280.0n 0.70000 53459.9n 0.70000 53460.0n 0.70000 53639.9n 0.70000 53640.0n 0.70000 53819.9n 0.70000 53820.0n 0.30000 53999.9n 0.30000 54000.0n 0.30000 54179.9n 0.30000 54180.0n 0.30000 54359.9n 0.30000 54360.0n 0.30000 54539.9n 0.30000 54540.0n 0.70000 54719.9n 0.70000 54720.0n 0.30000 54899.9n 0.30000 54900.0n 0.30000 55079.9n 0.30000 55080.0n 0.30000 55259.9n 0.30000 55260.0n 0.30000 55439.9n 0.30000 55440.0n 0.70000 55619.9n 0.70000 55620.0n 0.70000 55799.9n 0.70000 55800.0n 0.70000 55979.9n 0.70000 55980.0n 0.70000 56159.9n 0.70000 56160.0n 0.70000 56339.9n 0.70000 56340.0n 0.30000 56519.9n 0.30000 56520.0n 0.30000 56699.9n 0.30000 56700.0n 0.30000 56879.9n 0.30000 56880.0n 0.30000 57059.9n 0.30000 57060.0n 0.70000 57239.9n 0.70000 57240.0n 0.30000 57419.9n 0.30000 57420.0n 0.70000 57599.9n 0.70000 57600.0n 0.30000 57779.9n 0.30000 57780.0n 0.30000 57959.9n 0.30000 57960.0n 0.70000 58139.9n 0.70000 58140.0n 0.70000 58319.9n 0.70000 58320.0n 0.30000 58499.9n 0.30000 58500.0n 0.70000 58679.9n 0.70000 58680.0n 0.70000 58859.9n 0.70000 58860.0n 0.30000 59039.9n 0.30000 59040.0n 0.30000 59219.9n 0.30000 59220.0n 0.30000 59399.9n 0.30000 59400.0n 0.30000 59579.9n 0.30000 59580.0n 0.30000 59759.9n 0.30000 59760.0n 0.30000 59939.9n 0.30000 59940.0n 0.70000 60119.9n 0.70000 60120.0n 0.30000 60299.9n 0.30000 60300.0n 0.70000 60479.9n 0.70000 60480.0n 0.70000 60659.9n 0.70000 60660.0n 0.70000 60839.9n 0.70000 60840.0n 0.70000 61019.9n 0.70000 61020.0n 0.70000 61199.9n 0.70000 61200.0n 0.70000 61379.9n 0.70000 61380.0n 0.70000 61559.9n 0.70000 61560.0n 0.30000 61739.9n 0.30000 61740.0n 0.30000 61919.9n 0.30000 61920.0n 0.30000 62099.9n 0.30000 62100.0n 0.30000 62279.9n 0.30000 62280.0n 0.70000 62459.9n 0.70000 62460.0n 0.70000 62639.9n 0.70000 62640.0n 0.70000 62819.9n 0.70000 62820.0n 0.30000 62999.9n 0.30000 63000.0n 0.30000 63179.9n 0.30000 63180.0n 0.70000 63359.9n 0.70000 63360.0n 0.70000 63539.9n 0.70000 63540.0n 0.70000 63719.9n 0.70000 63720.0n 0.30000 63899.9n 0.30000 63900.0n 0.70000 64079.9n 0.70000 64080.0n 0.70000 64259.9n 0.70000 64260.0n 0.30000 64439.9n 0.30000 64440.0n 0.70000 64619.9n 0.70000 64620.0n 0.30000 64799.9n 0.30000 64800.0n 0.70000 64979.9n 0.70000 64980.0n 0.30000 65159.9n 0.30000 65160.0n 0.30000 65339.9n 0.30000 65340.0n 0.30000 65519.9n 0.30000 65520.0n 0.30000 65699.9n 0.30000 65700.0n 0.70000 65879.9n 0.70000 65880.0n 0.30000 66059.9n 0.30000 66060.0n 0.30000 66239.9n 0.30000 66240.0n 0.70000 66419.9n 0.70000 66420.0n 0.70000 66599.9n 0.70000 66600.0n 0.70000 66779.9n 0.70000 66780.0n 0.70000 66959.9n 0.70000 66960.0n 0.30000 67139.9n 0.30000 67140.0n 0.30000 67319.9n 0.30000 67320.0n 0.30000 67499.9n 0.30000 67500.0n 0.70000 67679.9n 0.70000 67680.0n 0.70000 67859.9n 0.70000 67860.0n 0.30000 68039.9n 0.30000 68040.0n 0.70000 68219.9n 0.70000 68220.0n 0.30000 68399.9n 0.30000 68400.0n 0.70000 68579.9n 0.70000 68580.0n 0.30000 68759.9n 0.30000 68760.0n 0.30000 68939.9n 0.30000 68940.0n 0.70000 69119.9n 0.70000 69120.0n 0.30000 69299.9n 0.30000 69300.0n 0.70000 69479.9n 0.70000 69480.0n 0.70000 69659.9n 0.70000 69660.0n 0.70000 69839.9n 0.70000 69840.0n 0.70000 70019.9n 0.70000 70020.0n 0.30000 70199.9n 0.30000 70200.0n 0.30000 70379.9n 0.30000 70380.0n 0.30000 70559.9n 0.30000 70560.0n 0.30000 70739.9n 0.30000 70740.0n 0.30000 70919.9n 0.30000 70920.0n 0.70000 71099.9n 0.70000 71100.0n 0.70000 71279.9n 0.70000 71280.0n 0.70000 71459.9n 0.70000 71460.0n 0.70000 71639.9n 0.70000 71640.0n 0.30000 71819.9n 0.30000 71820.0n 0.30000 71999.9n 0.30000 72000.0n 0.30000 72179.9n 0.30000 72180.0n 0.70000 72359.9n 0.70000 72360.0n 0.70000 72539.9n 0.70000 72540.0n 0.30000 72719.9n 0.30000 72720.0n 0.30000 72899.9n 0.30000 72900.0n 0.70000 73079.9n 0.70000 73080.0n 0.70000 73259.9n 0.70000 73260.0n 0.30000 73439.9n 0.30000 73440.0n 0.30000 73619.9n 0.30000 73620.0n 0.70000 73799.9n 0.70000 73800.0n 0.70000 73979.9n 0.70000 73980.0n 0.30000 74159.9n 0.30000 74160.0n 0.30000 74339.9n 0.30000 74340.0n 0.70000 74519.9n 0.70000 74520.0n 0.70000 74699.9n 0.70000 74700.0n 0.30000 74879.9n 0.30000 74880.0n 0.30000 75059.9n 0.30000 75060.0n 0.70000 75239.9n 0.70000 75240.0n 0.70000 75419.9n 0.70000 75420.0n 0.70000 75599.9n 0.70000 75600.0n 0.70000 75779.9n 0.70000 75780.0n 0.70000 75959.9n 0.70000 75960.0n 0.70000 76139.9n 0.70000 76140.0n 0.70000 76319.9n 0.70000 76320.0n 0.30000 76499.9n 0.30000 76500.0n 0.30000 76679.9n 0.30000 76680.0n 0.70000 76859.9n 0.70000 76860.0n 0.70000 77039.9n 0.70000 77040.0n 0.70000 77219.9n 0.70000 77220.0n 0.30000 77399.9n 0.30000 77400.0n 0.30000 77579.9n 0.30000 77580.0n 0.70000 77759.9n 0.70000 77760.0n 0.30000 77939.9n 0.30000 77940.0n 0.30000 78119.9n 0.30000 78120.0n 0.30000 78299.9n 0.30000 78300.0n 0.70000 78479.9n 0.70000 78480.0n 0.30000 78659.9n 0.30000 78660.0n 0.30000 78839.9n 0.30000 78840.0n 0.30000 79019.9n 0.30000 79020.0n 0.70000 79199.9n 0.70000 79200.0n 0.30000 79379.9n 0.30000 79380.0n 0.30000 79559.9n 0.30000 79560.0n 0.70000 79739.9n 0.70000 79740.0n 0.70000 79919.9n 0.70000 79920.0n 0.30000 80099.9n 0.30000 80100.0n 0.30000 80279.9n 0.30000 80280.0n 0.30000 80459.9n 0.30000 80460.0n 0.70000 80639.9n 0.70000 80640.0n 0.30000 80819.9n 0.30000 80820.0n 0.30000 80999.9n 0.30000 81000.0n 0.30000 81179.9n 0.30000 81180.0n 0.70000 81359.9n 0.70000 81360.0n 0.70000 81539.9n 0.70000 81540.0n 0.70000 81719.9n 0.70000 81720.0n 0.30000 81899.9n 0.30000 81900.0n 0.30000 82079.9n 0.30000 82080.0n 0.70000 82259.9n 0.70000 82260.0n 0.70000 82439.9n 0.70000 82440.0n 0.70000 82619.9n 0.70000 82620.0n 0.70000 82799.9n 0.70000 82800.0n 0.70000 82979.9n 0.70000 82980.0n 0.30000 83159.9n 0.30000 83160.0n 0.30000 83339.9n 0.30000 83340.0n 0.30000 83519.9n 0.30000 83520.0n 0.70000 83699.9n 0.70000 83700.0n 0.70000 83879.9n 0.70000 83880.0n 0.30000 84059.9n 0.30000 84060.0n 0.30000 84239.9n 0.30000 84240.0n 0.70000 84419.9n 0.70000 84420.0n 0.30000 84599.9n 0.30000 84600.0n 0.30000 84779.9n 0.30000 84780.0n 0.70000 84959.9n 0.70000 84960.0n 0.70000 85139.9n 0.70000 85140.0n 0.70000 85319.9n 0.70000 85320.0n 0.70000 85499.9n 0.70000 85500.0n 0.30000 85679.9n 0.30000 85680.0n 0.30000 85859.9n 0.30000 85860.0n 0.30000 86039.9n 0.30000 86040.0n 0.70000 86219.9n 0.70000 86220.0n 0.30000 86399.9n 0.30000 86400.0n 0.30000 86579.9n 0.30000 86580.0n 0.30000 86759.9n 0.30000 86760.0n 0.30000 86939.9n 0.30000 86940.0n 0.70000 87119.9n 0.70000 87120.0n 0.30000 87299.9n 0.30000 87300.0n 0.30000 87479.9n 0.30000 87480.0n 0.30000 87659.9n 0.30000 87660.0n 0.30000 87839.9n 0.30000 87840.0n 0.70000 88019.9n 0.70000 88020.0n 0.30000 88199.9n 0.30000 88200.0n 0.70000 88379.9n 0.70000 88380.0n 0.70000 88559.9n 0.70000 88560.0n 0.70000 88739.9n 0.70000 88740.0n 0.70000 88919.9n 0.70000 88920.0n 0.30000 89099.9n 0.30000 89100.0n 0.70000 89279.9n 0.70000 89280.0n 0.70000 89459.9n 0.70000 89460.0n 0.30000 89639.9n 0.30000 89640.0n 0.30000 89819.9n 0.30000 89820.0n 0.70000 89999.9n 0.70000 90000.0n 0.70000 90179.9n 0.70000 90180.0n 0.70000 90359.9n 0.70000 90360.0n 0.70000 90539.9n 0.70000 90540.0n 0.30000 90719.9n 0.30000 90720.0n 0.70000 90899.9n 0.70000 90900.0n 0.70000 91079.9n 0.70000 91080.0n 0.30000 91259.9n 0.30000 91260.0n 0.30000 91439.9n 0.30000 91440.0n 0.30000 91619.9n 0.30000 91620.0n 0.70000 91799.9n 0.70000 91800.0n 0.30000 91979.9n 0.30000 91980.0n 0.70000 92159.9n 0.70000 92160.0n 0.30000 92339.9n 0.30000 92340.0n 0.70000 92519.9n 0.70000 92520.0n 0.70000 92699.9n 0.70000 92700.0n 0.70000 92879.9n 0.70000 92880.0n 0.30000 93059.9n 0.30000 93060.0n 0.30000 93239.9n 0.30000 93240.0n 0.30000 93419.9n 0.30000 93420.0n 0.70000 93599.9n 0.70000 93600.0n 0.70000 93779.9n 0.70000 93780.0n 0.30000 93959.9n 0.30000 93960.0n 0.30000 94139.9n 0.30000 94140.0n 0.70000 94319.9n 0.70000 94320.0n 0.30000 94499.9n 0.30000 94500.0n 0.70000 94679.9n 0.70000 94680.0n 0.70000 94859.9n 0.70000 94860.0n 0.70000 95039.9n 0.70000 95040.0n 0.70000 95219.9n 0.70000 95220.0n 0.70000 95399.9n 0.70000 95400.0n 0.70000 95579.9n 0.70000 95580.0n 0.30000 95759.9n 0.30000 95760.0n 0.30000 95939.9n 0.30000 95940.0n 0.30000 96119.9n 0.30000 96120.0n 0.70000 96299.9n 0.70000 96300.0n 0.70000 96479.9n 0.70000 96480.0n 0.70000 96659.9n 0.70000 96660.0n 0.30000 96839.9n 0.30000 96840.0n 0.30000 97019.9n 0.30000 97020.0n 0.30000 97199.9n 0.30000 97200.0n 0.70000 97379.9n 0.70000 97380.0n 0.30000 97559.9n 0.30000 97560.0n 0.30000 97739.9n 0.30000 97740.0n 0.30000 97919.9n 0.30000 97920.0n 0.30000 98099.9n 0.30000 98100.0n 0.30000 98279.9n 0.30000 98280.0n 0.30000 98459.9n 0.30000 98460.0n 0.30000 98639.9n 0.30000 98640.0n 0.30000 98819.9n 0.30000 98820.0n 0.30000 98999.9n 0.30000 99000.0n 0.30000 99179.9n 0.30000 99180.0n 0.30000 99359.9n 0.30000 99360.0n 0.30000 99539.9n 0.30000 99540.0n 0.70000 99719.9n 0.70000 99720.0n 0.70000 99899.9n 0.70000 99900.0n 0.30000 100079.9n 0.30000 100080.0n 0.70000 100259.9n 0.70000 100260.0n 0.70000 100439.9n 0.70000 100440.0n 0.30000 100619.9n 0.30000 100620.0n 0.30000 100799.9n 0.30000 100800.0n 0.70000 100979.9n 0.70000 100980.0n 0.70000 101159.9n 0.70000 101160.0n 0.70000 101339.9n 0.70000 101340.0n 0.30000 101519.9n 0.30000 101520.0n 0.30000 101699.9n 0.30000 101700.0n 0.70000 101879.9n 0.70000 101880.0n 0.70000 102059.9n 0.70000 102060.0n 0.70000 102239.9n 0.70000 102240.0n 0.30000 102419.9n 0.30000 102420.0n 0.70000 102599.9n 0.70000 102600.0n 0.70000 102779.9n 0.70000 102780.0n 0.70000 102959.9n 0.70000 102960.0n 0.30000 103139.9n 0.30000 103140.0n 0.70000 103319.9n 0.70000 103320.0n 0.70000 103499.9n 0.70000 103500.0n 0.70000 103679.9n 0.70000 103680.0n 0.30000 103859.9n 0.30000 103860.0n 0.30000 104039.9n 0.30000 104040.0n 0.30000 104219.9n 0.30000 104220.0n 0.30000 104399.9n 0.30000 104400.0n 0.70000 104579.9n 0.70000 104580.0n 0.70000 104759.9n 0.70000 104760.0n 0.70000 104939.9n 0.70000 104940.0n 0.70000 105119.9n 0.70000 105120.0n 0.30000 105299.9n 0.30000 105300.0n 0.30000 105479.9n 0.30000 105480.0n 0.70000 105659.9n 0.70000 105660.0n 0.30000 105839.9n 0.30000 105840.0n 0.70000 106019.9n 0.70000 106020.0n 0.30000 106199.9n 0.30000 106200.0n 0.70000 106379.9n 0.70000 106380.0n 0.30000 106559.9n 0.30000 106560.0n 0.30000 106739.9n 0.30000 106740.0n 0.70000 106919.9n 0.70000 106920.0n 0.70000 107099.9n 0.70000 107100.0n 0.30000 107279.9n 0.30000 107280.0n 0.70000 107459.9n 0.70000 107460.0n 0.70000 107639.9n 0.70000 107640.0n 0.70000 107819.9n 0.70000 107820.0n 0.30000 107999.9n 0.30000 108000.0n 0.30000 108179.9n 0.30000 108180.0n 0.30000 108359.9n 0.30000 108360.0n 0.70000 108539.9n 0.70000 108540.0n 0.30000 108719.9n 0.30000 108720.0n 0.70000 108899.9n 0.70000 108900.0n 0.70000 109079.9n 0.70000 109080.0n 0.70000 109259.9n 0.70000 109260.0n 0.30000 109439.9n 0.30000 109440.0n 0.30000 109619.9n 0.30000 109620.0n 0.30000 109799.9n 0.30000 109800.0n 0.70000 109979.9n 0.70000 109980.0n 0.30000 110159.9n 0.30000 110160.0n 0.30000 110339.9n 0.30000 110340.0n 0.30000 110519.9n 0.30000 110520.0n 0.70000 110699.9n 0.70000 110700.0n 0.30000 110879.9n 0.30000 110880.0n 0.30000 111059.9n 0.30000 111060.0n 0.70000 111239.9n 0.70000 111240.0n 0.70000 111419.9n 0.70000 111420.0n 0.30000 111599.9n 0.30000 111600.0n 0.70000 111779.9n 0.70000 111780.0n 0.70000 111959.9n 0.70000 111960.0n 0.70000 112139.9n 0.70000 112140.0n 0.70000 112319.9n 0.70000 112320.0n 0.70000 112499.9n 0.70000 112500.0n 0.70000 112679.9n 0.70000 112680.0n 0.30000 112859.9n 0.30000 112860.0n 0.30000 113039.9n 0.30000 113040.0n 0.70000 113219.9n 0.70000 113220.0n 0.30000 113399.9n 0.30000 113400.0n 0.70000 113579.9n 0.70000 113580.0n 0.70000 113759.9n 0.70000 113760.0n 0.30000 113939.9n 0.30000 113940.0n 0.30000 114119.9n 0.30000 114120.0n 0.30000 114299.9n 0.30000 114300.0n 0.70000 114479.9n 0.70000 114480.0n 0.30000 114659.9n 0.30000 114660.0n 0.70000 114839.9n 0.70000 114840.0n 0.70000 115019.9n 0.70000 115020.0n 0.30000 115199.9n 0.30000 115200.0n 0.30000 115379.9n 0.30000 115380.0n 0.30000 115559.9n 0.30000 115560.0n 0.70000 115739.9n 0.70000 115740.0n 0.70000 115919.9n 0.70000 115920.0n 0.30000 116099.9n 0.30000 116100.0n 0.70000 116279.9n 0.70000 116280.0n 0.30000 116459.9n 0.30000 116460.0n 0.30000 116639.9n 0.30000 116640.0n 0.70000 116819.9n 0.70000 116820.0n 0.70000 116999.9n 0.70000 117000.0n 0.30000 117179.9n 0.30000 117180.0n 0.30000 117359.9n 0.30000 117360.0n 0.70000 117539.9n 0.70000 117540.0n 0.30000 117719.9n 0.30000 117720.0n 0.70000 117899.9n 0.70000 117900.0n 0.30000 118079.9n 0.30000 118080.0n 0.30000 118259.9n 0.30000 118260.0n 0.70000 118439.9n 0.70000 118440.0n 0.30000 118619.9n 0.30000 118620.0n 0.30000 118799.9n 0.30000 118800.0n 0.70000 118979.9n 0.70000 118980.0n 0.70000 119159.9n 0.70000 119160.0n 0.70000 119339.9n 0.70000 119340.0n 0.70000 119519.9n 0.70000 119520.0n 0.70000 119699.9n 0.70000 119700.0n 0.70000 119879.9n 0.70000 119880.0n 0.30000 120059.9n 0.30000 120060.0n 0.30000 120239.9n 0.30000 120240.0n 0.70000 120419.9n 0.70000 120420.0n 0.70000 120599.9n 0.70000 120600.0n 0.30000 120779.9n 0.30000 120780.0n 0.30000 120959.9n 0.30000 120960.0n 0.30000 121139.9n 0.30000 121140.0n 0.30000 121319.9n 0.30000 121320.0n 0.70000 121499.9n 0.70000 121500.0n 0.30000 121679.9n 0.30000 121680.0n 0.30000 121859.9n 0.30000 121860.0n 0.70000 122039.9n 0.70000 122040.0n 0.70000 122219.9n 0.70000 122220.0n 0.70000 122399.9n 0.70000 122400.0n 0.30000 122579.9n 0.30000 122580.0n 0.70000 122759.9n 0.70000 122760.0n 0.70000 122939.9n 0.70000 122940.0n 0.30000 123119.9n 0.30000 123120.0n 0.70000 123299.9n 0.70000 123300.0n 0.30000 123479.9n 0.30000 123480.0n 0.30000 123659.9n 0.30000 123660.0n 0.30000 123839.9n 0.30000 123840.0n 0.70000 124019.9n 0.70000 124020.0n 0.70000 124199.9n 0.70000 124200.0n 0.30000 124379.9n 0.30000 124380.0n 0.70000 124559.9n 0.70000 124560.0n 0.70000 124739.9n 0.70000 124740.0n 0.70000 124919.9n 0.70000 124920.0n 0.30000 125099.9n 0.30000 125100.0n 0.30000 125279.9n 0.30000 125280.0n 0.30000 125459.9n 0.30000 125460.0n 0.30000 125639.9n 0.30000 125640.0n 0.70000 125819.9n 0.70000 125820.0n 0.70000 125999.9n 0.70000 126000.0n 0.30000 126179.9n 0.30000 126180.0n 0.70000 126359.9n 0.70000 126360.0n 0.30000 126539.9n 0.30000 126540.0n 0.70000 126719.9n 0.70000 126720.0n 0.30000 126899.9n 0.30000 126900.0n 0.30000 127079.9n 0.30000 127080.0n 0.30000 127259.9n 0.30000 127260.0n 0.30000 127439.9n 0.30000 127440.0n 0.30000 127619.9n 0.30000 127620.0n 0.70000 127799.9n 0.70000 127800.0n 0.30000 127979.9n 0.30000 127980.0n 0.30000 128159.9n 0.30000 128160.0n 0.70000 128339.9n 0.70000 128340.0n 0.70000 128519.9n 0.70000 128520.0n 0.70000 128699.9n 0.70000 128700.0n 0.70000 128879.9n 0.70000 128880.0n 0.30000 129059.9n 0.30000 129060.0n 0.70000 129239.9n 0.70000 129240.0n 0.70000 129419.9n 0.70000 129420.0n 0.70000 129599.9n 0.70000 129600.0n 0.30000 129779.9n 0.30000 129780.0n 0.70000 129959.9n 0.70000 129960.0n 0.70000 130139.9n 0.70000 130140.0n 0.70000 130319.9n 0.70000 130320.0n 0.70000 130499.9n 0.70000 130500.0n 0.30000 130679.9n 0.30000 130680.0n 0.30000 130859.9n 0.30000 130860.0n 0.30000 131039.9n 0.30000 131040.0n 0.70000 131219.9n 0.70000 131220.0n 0.70000 131399.9n 0.70000 131400.0n 0.30000 131579.9n 0.30000 131580.0n 0.70000 131759.9n 0.70000 131760.0n 0.30000 131939.9n 0.30000 131940.0n 0.30000 132119.9n 0.30000 132120.0n 0.70000 132299.9n 0.70000 132300.0n 0.30000 132479.9n 0.30000 132480.0n 0.30000 132659.9n 0.30000 132660.0n 0.30000 132839.9n 0.30000 132840.0n 0.70000 133019.9n 0.70000 133020.0n 0.70000 133199.9n 0.70000 133200.0n 0.30000 133379.9n 0.30000 133380.0n 0.30000 133559.9n 0.30000 133560.0n 0.30000 133739.9n 0.30000 133740.0n 0.30000 133919.9n 0.30000 133920.0n 0.30000 134099.9n 0.30000 134100.0n 0.30000 134279.9n 0.30000 134280.0n 0.70000 134459.9n 0.70000 134460.0n 0.70000 134639.9n 0.70000 134640.0n 0.30000 134819.9n 0.30000 134820.0n 0.30000 134999.9n 0.30000 135000.0n 0.70000 135179.9n 0.70000 135180.0n 0.70000 135359.9n 0.70000 135360.0n 0.70000 135539.9n 0.70000 135540.0n 0.70000 135719.9n 0.70000 135720.0n 0.30000 135899.9n 0.30000 135900.0n 0.70000 136079.9n 0.70000 136080.0n 0.30000 136259.9n 0.30000 136260.0n 0.70000 136439.9n 0.70000 136440.0n 0.30000 136619.9n 0.30000 136620.0n 0.70000 136799.9n 0.70000 136800.0n 0.70000 136979.9n 0.70000 136980.0n 0.70000 137159.9n 0.70000 137160.0n 0.70000 137339.9n 0.70000 137340.0n 0.70000 137519.9n 0.70000 137520.0n 0.30000 137699.9n 0.30000 137700.0n 0.70000 137879.9n 0.70000 137880.0n 0.30000 138059.9n 0.30000 138060.0n 0.30000 138239.9n 0.30000 138240.0n 0.70000 138419.9n 0.70000 138420.0n 0.70000 138599.9n 0.70000 138600.0n 0.70000 138779.9n 0.70000 138780.0n 0.70000 138959.9n 0.70000 138960.0n 0.70000 139139.9n 0.70000 139140.0n 0.30000 139319.9n 0.30000 139320.0n 0.30000 139499.9n 0.30000 139500.0n 0.70000 139679.9n 0.70000 139680.0n 0.70000 139859.9n 0.70000 139860.0n 0.30000 140039.9n 0.30000 140040.0n 0.30000 140219.9n 0.30000 140220.0n 0.30000 140399.9n 0.30000 140400.0n 0.70000 140579.9n 0.70000 140580.0n 0.70000 140759.9n 0.70000 140760.0n 0.30000 140939.9n 0.30000 140940.0n 0.70000 141119.9n 0.70000 141120.0n 0.30000 141299.9n 0.30000 141300.0n 0.70000 141479.9n 0.70000 141480.0n 0.70000 141659.9n 0.70000 141660.0n 0.30000 141839.9n 0.30000 141840.0n 0.30000 142019.9n 0.30000 142020.0n 0.70000 142199.9n 0.70000 142200.0n 0.70000 142379.9n 0.70000 142380.0n 0.70000 142559.9n 0.70000 142560.0n 0.30000 142739.9n 0.30000 142740.0n 0.30000 142919.9n 0.30000 142920.0n 0.30000 143099.9n 0.30000 143100.0n 0.30000 143279.9n 0.30000 143280.0n 0.70000 143459.9n 0.70000 143460.0n 0.30000 143639.9n 0.30000 143640.0n 0.30000 143819.9n 0.30000 143820.0n 0.30000 143999.9n 0.30000 144000.0n 0.30000 144179.9n 0.30000 144180.0n 0.70000 144359.9n 0.70000 144360.0n 0.70000 144539.9n 0.70000 144540.0n 0.30000 144719.9n 0.30000 144720.0n 0.30000 144899.9n 0.30000 144900.0n 0.70000 145079.9n 0.70000 145080.0n 0.70000 145259.9n 0.70000 145260.0n 0.70000 145439.9n 0.70000 145440.0n 0.70000 145619.9n 0.70000 145620.0n 0.70000 145799.9n 0.70000 145800.0n 0.70000 145979.9n 0.70000 145980.0n 0.30000 146159.9n 0.30000 146160.0n 0.30000 146339.9n 0.30000 146340.0n 0.30000 146519.9n 0.30000 146520.0n 0.70000 146699.9n 0.70000 146700.0n 0.30000 146879.9n 0.30000 146880.0n 0.70000 147059.9n 0.70000 147060.0n 0.70000 147239.9n 0.70000 147240.0n 0.30000 147419.9n 0.30000 147420.0n 0.70000 147599.9n 0.70000 147600.0n 0.70000 147779.9n 0.70000 147780.0n 0.70000 147959.9n 0.70000 147960.0n 0.30000 148139.9n 0.30000 148140.0n 0.70000 148319.9n 0.70000 148320.0n 0.30000 148499.9n 0.30000 148500.0n 0.30000 148679.9n 0.30000 148680.0n 0.30000 148859.9n 0.30000 148860.0n 0.30000 149039.9n 0.30000 149040.0n 0.30000 149219.9n 0.30000 149220.0n 0.70000 149399.9n 0.70000 149400.0n 0.30000 149579.9n 0.30000 149580.0n 0.30000 149759.9n 0.30000 149760.0n 0.30000 149939.9n 0.30000 149940.0n 0.30000 150119.9n 0.30000 150120.0n 0.70000 150299.9n 0.70000 150300.0n 0.70000 150479.9n 0.70000 150480.0n 0.30000 150659.9n 0.30000 150660.0n 0.30000 150839.9n 0.30000 150840.0n 0.70000 151019.9n 0.70000 151020.0n 0.70000 151199.9n 0.70000 151200.0n 0.70000 151379.9n 0.70000 151380.0n 0.70000 151559.9n 0.70000 151560.0n 0.70000 151739.9n 0.70000 151740.0n 0.30000 151919.9n 0.30000 151920.0n 0.70000 152099.9n 0.70000 152100.0n 0.30000 152279.9n 0.30000 152280.0n 0.30000 152459.9n 0.30000 152460.0n 0.70000 152639.9n 0.70000 152640.0n 0.70000 152819.9n 0.70000 152820.0n 0.70000 152999.9n 0.70000 153000.0n 0.30000 153179.9n 0.30000 153180.0n 0.70000 153359.9n 0.70000 153360.0n 0.70000 153539.9n 0.70000 153540.0n 0.30000 153719.9n 0.30000 153720.0n 0.30000 153899.9n 0.30000 153900.0n 0.30000 154079.9n 0.30000 154080.0n 0.30000 154259.9n 0.30000 154260.0n 0.70000 154439.9n 0.70000 154440.0n 0.30000 154619.9n 0.30000 154620.0n 0.70000 154799.9n 0.70000 154800.0n 0.30000 154979.9n 0.30000 154980.0n 0.30000 155159.9n 0.30000 155160.0n 0.30000 155339.9n 0.30000 155340.0n 0.70000 155519.9n 0.70000 155520.0n 0.30000 155699.9n 0.30000 155700.0n 0.70000 155879.9n 0.70000 155880.0n 0.30000 156059.9n 0.30000 156060.0n 0.70000 156239.9n 0.70000 156240.0n 0.30000 156419.9n 0.30000 156420.0n 0.70000 156599.9n 0.70000 156600.0n 0.70000 156779.9n 0.70000 156780.0n 0.70000 156959.9n 0.70000 156960.0n 0.70000 157139.9n 0.70000 157140.0n 0.70000 157319.9n 0.70000 157320.0n 0.30000 157499.9n 0.30000 157500.0n 0.30000 157679.9n 0.30000 157680.0n 0.30000 157859.9n 0.30000 157860.0n 0.30000 158039.9n 0.30000 158040.0n 0.70000 158219.9n 0.70000 158220.0n 0.30000 158399.9n 0.30000 158400.0n 0.70000 158579.9n 0.70000 158580.0n 0.70000 158759.9n 0.70000 158760.0n 0.70000 158939.9n 0.70000 158940.0n 0.70000 159119.9n 0.70000 159120.0n 0.30000 159299.9n 0.30000 159300.0n 0.30000 159479.9n 0.30000 159480.0n 0.70000 159659.9n 0.70000 159660.0n 0.70000 159839.9n 0.70000 159840.0n 0.30000 160019.9n 0.30000 160020.0n 0.30000 160199.9n 0.30000 160200.0n 0.30000 160379.9n 0.30000 160380.0n 0.30000 160559.9n 0.30000 160560.0n 0.30000 160739.9n 0.30000 160740.0n 0.70000 160919.9n 0.70000 160920.0n 0.30000 161099.9n 0.30000 161100.0n 0.70000 161279.9n 0.70000 161280.0n 0.30000 161459.9n 0.30000 161460.0n 0.30000 161639.9n 0.30000 161640.0n 0.70000 161819.9n 0.70000 161820.0n 0.30000 161999.9n 0.30000 162000.0n 0.70000 162179.9n 0.70000 162180.0n 0.30000 162359.9n 0.30000 162360.0n 0.70000 162539.9n 0.70000 162540.0n 0.70000 162719.9n 0.70000 162720.0n 0.30000 162899.9n 0.30000 162900.0n 0.30000 163079.9n 0.30000 163080.0n 0.70000 163259.9n 0.70000 163260.0n 0.30000 163439.9n 0.30000 163440.0n 0.70000 163619.9n 0.70000 163620.0n 0.30000 163799.9n 0.30000 163800.0n 0.70000 163979.9n 0.70000 163980.0n 0.70000 164159.9n 0.70000 164160.0n 0.30000 164339.9n 0.30000 164340.0n 0.70000 164519.9n 0.70000 164520.0n 0.70000 164699.9n 0.70000 164700.0n 0.30000 164879.9n 0.30000 164880.0n 0.70000 165059.9n 0.70000 165060.0n 0.70000 165239.9n 0.70000 165240.0n 0.30000 165419.9n 0.30000 165420.0n 0.70000 165599.9n 0.70000 165600.0n 0.30000 165779.9n 0.30000 165780.0n 0.30000 165959.9n 0.30000 165960.0n 0.70000 166139.9n 0.70000 166140.0n 0.30000 166319.9n 0.30000 166320.0n 0.30000 166499.9n 0.30000 166500.0n 0.70000 166679.9n 0.70000 166680.0n 0.30000 166859.9n 0.30000 166860.0n 0.70000 167039.9n 0.70000 167040.0n 0.70000 167219.9n 0.70000 167220.0n 0.70000 167399.9n 0.70000 167400.0n 0.30000 167579.9n 0.30000 167580.0n 0.30000 167759.9n 0.30000 167760.0n 0.30000 167939.9n 0.30000 167940.0n 0.70000 168119.9n 0.70000 168120.0n 0.30000 168299.9n 0.30000 168300.0n 0.30000 168479.9n 0.30000 168480.0n 0.70000 168659.9n 0.70000 168660.0n 0.30000 168839.9n 0.30000 168840.0n 0.30000 169019.9n 0.30000 169020.0n 0.70000 169199.9n 0.70000 169200.0n 0.70000 169379.9n 0.70000 169380.0n 0.30000 169559.9n 0.30000 169560.0n 0.70000 169739.9n 0.70000 169740.0n 0.30000 169919.9n 0.30000 169920.0n 0.30000 170099.9n 0.30000 170100.0n 0.30000 170279.9n 0.30000 170280.0n 0.30000 170459.9n 0.30000 170460.0n 0.70000 170639.9n 0.70000 170640.0n 0.70000 170819.9n 0.70000 170820.0n 0.70000 170999.9n 0.70000 171000.0n 0.30000 171179.9n 0.30000 171180.0n 0.70000 171359.9n 0.70000 171360.0n 0.30000 171539.9n 0.30000 171540.0n 0.70000 171719.9n 0.70000 171720.0n 0.70000 171899.9n 0.70000 171900.0n 0.30000 172079.9n 0.30000 172080.0n 0.30000 172259.9n 0.30000 172260.0n 0.70000 172439.9n 0.70000 172440.0n 0.70000 172619.9n 0.70000 172620.0n 0.70000 172799.9n 0.70000 172800.0n 0.50000 172979.9n 0.50000 172980.0n 0.50000 173159.9n 0.50000 173160.0n 0.50000 173339.9n 0.50000 173340.0n 0.50000 173519.9n 0.50000 173520.0n 0.50000 173699.9n 0.50000 173700.0n 0.50000 173879.9n 0.50000 173880.0n 0.50000 174059.9n 0.50000 174060.0n 0.50000 174239.9n 0.50000 174240.0n 0.50000 174419.9n 0.50000 174420.0n 0.50000 174599.9n 0.50000 174600.0n 0.50000 174779.9n 0.50000 174780.0n 0.50000 174959.9n 0.50000 174960.0n 0.50000 175139.9n 0.50000 175140.0n 0.50000 175319.9n 0.50000 175320.0n 0.50000 175499.9n 0.50000 175500.0n 0.50000 175679.9n 0.50000 175680.0n 0.50000 175859.9n 0.50000 175860.0n 0.50000 176039.9n 0.50000 176040.0n 0.50000 176219.9n 0.50000 176220.0n 0.50000 176399.9n 0.50000 176400.0n 0.50000 176579.9n 0.50000 176580.0n 0.50000 176759.9n 0.50000 176760.0n 0.50000 176939.9n 0.50000 176940.0n 0.50000 177119.9n 0.50000 177120.0n 0.50000 177299.9n 0.50000 177300.0n 0.50000 177479.9n 0.50000 177480.0n 0.50000 177659.9n 0.50000 177660.0n 0.50000 177839.9n 0.50000 177840.0n 0.50000 178019.9n 0.50000 178020.0n 0.50000 178199.9n 0.50000 178200.0n 0.50000 178379.9n 0.50000 178380.0n 0.50000 178559.9n 0.50000 178560.0n 0.50000 178739.9n 0.50000 178740.0n 0.50000 178919.9n 0.50000 178920.0n 0.50000 179099.9n 0.50000 179100.0n 0.50000 179279.9n 0.50000 179280.0n 0.50000 179459.9n 0.50000 179460.0n 0.50000 179639.9n 0.50000 179640.0n 0.50000 179819.9n 0.50000 179820.0n 0.50000 179999.9n 0.50000 180000.0n 0.50000 180179.9n 0.50000 180180.0n 0.50000 180359.9n 0.50000 180360.0n 0.50000 180539.9n 0.50000 180540.0n 0.50000 180719.9n 0.50000 180720.0n 0.50000 180899.9n 0.50000 180900.0n 0.50000 181079.9n 0.50000 181080.0n 0.50000 181259.9n 0.50000 181260.0n 0.50000 181439.9n 0.50000 181440.0n 0.50000 181619.9n 0.50000 181620.0n 0.50000 181799.9n 0.50000 181800.0n 0.50000 181979.9n 0.50000 181980.0n 0.50000 182159.9n 0.50000 182160.0n 0.50000 182339.9n 0.50000 182340.0n 0.50000 182519.9n 0.50000 182520.0n 0.50000 182699.9n 0.50000 182700.0n 0.50000 182879.9n 0.50000 182880.0n 0.50000 183059.9n 0.50000 183060.0n 0.50000 183239.9n 0.50000 183240.0n 0.50000 183419.9n 0.50000 183420.0n 0.50000)
Vxon0 xon0 0 PWL(0.0n 0.30000 179.9n 0.30000 180.0n 0.30000 359.9n 0.30000 360.0n 0.30000 539.9n 0.30000 540.0n 0.30000 719.9n 0.30000 720.0n 0.70000 899.9n 0.70000 900.0n 0.70000 1079.9n 0.70000 1080.0n 0.70000 1259.9n 0.70000 1260.0n 0.30000 1439.9n 0.30000 1440.0n 0.70000 1619.9n 0.70000 1620.0n 0.70000 1799.9n 0.70000 1800.0n 0.70000 1979.9n 0.70000 1980.0n 0.70000 2159.9n 0.70000 2160.0n 0.30000 2339.9n 0.30000 2340.0n 0.30000 2519.9n 0.30000 2520.0n 0.30000 2699.9n 0.30000 2700.0n 0.70000 2879.9n 0.70000 2880.0n 0.30000 3059.9n 0.30000 3060.0n 0.70000 3239.9n 0.70000 3240.0n 0.30000 3419.9n 0.30000 3420.0n 0.70000 3599.9n 0.70000 3600.0n 0.70000 3779.9n 0.70000 3780.0n 0.30000 3959.9n 0.30000 3960.0n 0.70000 4139.9n 0.70000 4140.0n 0.30000 4319.9n 0.30000 4320.0n 0.70000 4499.9n 0.70000 4500.0n 0.30000 4679.9n 0.30000 4680.0n 0.30000 4859.9n 0.30000 4860.0n 0.70000 5039.9n 0.70000 5040.0n 0.30000 5219.9n 0.30000 5220.0n 0.70000 5399.9n 0.70000 5400.0n 0.30000 5579.9n 0.30000 5580.0n 0.70000 5759.9n 0.70000 5760.0n 0.70000 5939.9n 0.70000 5940.0n 0.70000 6119.9n 0.70000 6120.0n 0.70000 6299.9n 0.70000 6300.0n 0.30000 6479.9n 0.30000 6480.0n 0.30000 6659.9n 0.30000 6660.0n 0.70000 6839.9n 0.70000 6840.0n 0.70000 7019.9n 0.70000 7020.0n 0.70000 7199.9n 0.70000 7200.0n 0.30000 7379.9n 0.30000 7380.0n 0.70000 7559.9n 0.70000 7560.0n 0.30000 7739.9n 0.30000 7740.0n 0.30000 7919.9n 0.30000 7920.0n 0.30000 8099.9n 0.30000 8100.0n 0.30000 8279.9n 0.30000 8280.0n 0.70000 8459.9n 0.70000 8460.0n 0.30000 8639.9n 0.30000 8640.0n 0.70000 8819.9n 0.70000 8820.0n 0.70000 8999.9n 0.70000 9000.0n 0.30000 9179.9n 0.30000 9180.0n 0.30000 9359.9n 0.30000 9360.0n 0.70000 9539.9n 0.70000 9540.0n 0.30000 9719.9n 0.30000 9720.0n 0.30000 9899.9n 0.30000 9900.0n 0.30000 10079.9n 0.30000 10080.0n 0.70000 10259.9n 0.70000 10260.0n 0.70000 10439.9n 0.70000 10440.0n 0.70000 10619.9n 0.70000 10620.0n 0.30000 10799.9n 0.30000 10800.0n 0.30000 10979.9n 0.30000 10980.0n 0.70000 11159.9n 0.70000 11160.0n 0.30000 11339.9n 0.30000 11340.0n 0.70000 11519.9n 0.70000 11520.0n 0.70000 11699.9n 0.70000 11700.0n 0.70000 11879.9n 0.70000 11880.0n 0.70000 12059.9n 0.70000 12060.0n 0.30000 12239.9n 0.30000 12240.0n 0.30000 12419.9n 0.30000 12420.0n 0.70000 12599.9n 0.70000 12600.0n 0.70000 12779.9n 0.70000 12780.0n 0.30000 12959.9n 0.30000 12960.0n 0.30000 13139.9n 0.30000 13140.0n 0.30000 13319.9n 0.30000 13320.0n 0.70000 13499.9n 0.70000 13500.0n 0.70000 13679.9n 0.70000 13680.0n 0.70000 13859.9n 0.70000 13860.0n 0.30000 14039.9n 0.30000 14040.0n 0.70000 14219.9n 0.70000 14220.0n 0.30000 14399.9n 0.30000 14400.0n 0.70000 14579.9n 0.70000 14580.0n 0.30000 14759.9n 0.30000 14760.0n 0.30000 14939.9n 0.30000 14940.0n 0.30000 15119.9n 0.30000 15120.0n 0.30000 15299.9n 0.30000 15300.0n 0.70000 15479.9n 0.70000 15480.0n 0.70000 15659.9n 0.70000 15660.0n 0.70000 15839.9n 0.70000 15840.0n 0.30000 16019.9n 0.30000 16020.0n 0.30000 16199.9n 0.30000 16200.0n 0.70000 16379.9n 0.70000 16380.0n 0.30000 16559.9n 0.30000 16560.0n 0.30000 16739.9n 0.30000 16740.0n 0.70000 16919.9n 0.70000 16920.0n 0.70000 17099.9n 0.70000 17100.0n 0.30000 17279.9n 0.30000 17280.0n 0.70000 17459.9n 0.70000 17460.0n 0.30000 17639.9n 0.30000 17640.0n 0.30000 17819.9n 0.30000 17820.0n 0.30000 17999.9n 0.30000 18000.0n 0.70000 18179.9n 0.70000 18180.0n 0.70000 18359.9n 0.70000 18360.0n 0.30000 18539.9n 0.30000 18540.0n 0.70000 18719.9n 0.70000 18720.0n 0.70000 18899.9n 0.70000 18900.0n 0.30000 19079.9n 0.30000 19080.0n 0.70000 19259.9n 0.70000 19260.0n 0.30000 19439.9n 0.30000 19440.0n 0.30000 19619.9n 0.30000 19620.0n 0.30000 19799.9n 0.30000 19800.0n 0.30000 19979.9n 0.30000 19980.0n 0.70000 20159.9n 0.70000 20160.0n 0.30000 20339.9n 0.30000 20340.0n 0.30000 20519.9n 0.30000 20520.0n 0.70000 20699.9n 0.70000 20700.0n 0.70000 20879.9n 0.70000 20880.0n 0.70000 21059.9n 0.70000 21060.0n 0.30000 21239.9n 0.30000 21240.0n 0.30000 21419.9n 0.30000 21420.0n 0.70000 21599.9n 0.70000 21600.0n 0.70000 21779.9n 0.70000 21780.0n 0.30000 21959.9n 0.30000 21960.0n 0.70000 22139.9n 0.70000 22140.0n 0.30000 22319.9n 0.30000 22320.0n 0.30000 22499.9n 0.30000 22500.0n 0.70000 22679.9n 0.70000 22680.0n 0.70000 22859.9n 0.70000 22860.0n 0.70000 23039.9n 0.70000 23040.0n 0.70000 23219.9n 0.70000 23220.0n 0.30000 23399.9n 0.30000 23400.0n 0.30000 23579.9n 0.30000 23580.0n 0.70000 23759.9n 0.70000 23760.0n 0.30000 23939.9n 0.30000 23940.0n 0.70000 24119.9n 0.70000 24120.0n 0.70000 24299.9n 0.70000 24300.0n 0.30000 24479.9n 0.30000 24480.0n 0.30000 24659.9n 0.30000 24660.0n 0.30000 24839.9n 0.30000 24840.0n 0.30000 25019.9n 0.30000 25020.0n 0.30000 25199.9n 0.30000 25200.0n 0.30000 25379.9n 0.30000 25380.0n 0.70000 25559.9n 0.70000 25560.0n 0.70000 25739.9n 0.70000 25740.0n 0.30000 25919.9n 0.30000 25920.0n 0.70000 26099.9n 0.70000 26100.0n 0.30000 26279.9n 0.30000 26280.0n 0.30000 26459.9n 0.30000 26460.0n 0.70000 26639.9n 0.70000 26640.0n 0.70000 26819.9n 0.70000 26820.0n 0.30000 26999.9n 0.30000 27000.0n 0.30000 27179.9n 0.30000 27180.0n 0.70000 27359.9n 0.70000 27360.0n 0.70000 27539.9n 0.70000 27540.0n 0.70000 27719.9n 0.70000 27720.0n 0.70000 27899.9n 0.70000 27900.0n 0.70000 28079.9n 0.70000 28080.0n 0.30000 28259.9n 0.30000 28260.0n 0.70000 28439.9n 0.70000 28440.0n 0.30000 28619.9n 0.30000 28620.0n 0.70000 28799.9n 0.70000 28800.0n 0.30000 28979.9n 0.30000 28980.0n 0.30000 29159.9n 0.30000 29160.0n 0.30000 29339.9n 0.30000 29340.0n 0.70000 29519.9n 0.70000 29520.0n 0.30000 29699.9n 0.30000 29700.0n 0.30000 29879.9n 0.30000 29880.0n 0.30000 30059.9n 0.30000 30060.0n 0.70000 30239.9n 0.70000 30240.0n 0.30000 30419.9n 0.30000 30420.0n 0.30000 30599.9n 0.30000 30600.0n 0.30000 30779.9n 0.30000 30780.0n 0.30000 30959.9n 0.30000 30960.0n 0.70000 31139.9n 0.70000 31140.0n 0.70000 31319.9n 0.70000 31320.0n 0.70000 31499.9n 0.70000 31500.0n 0.30000 31679.9n 0.30000 31680.0n 0.30000 31859.9n 0.30000 31860.0n 0.30000 32039.9n 0.30000 32040.0n 0.70000 32219.9n 0.70000 32220.0n 0.70000 32399.9n 0.70000 32400.0n 0.70000 32579.9n 0.70000 32580.0n 0.30000 32759.9n 0.30000 32760.0n 0.30000 32939.9n 0.30000 32940.0n 0.30000 33119.9n 0.30000 33120.0n 0.70000 33299.9n 0.70000 33300.0n 0.70000 33479.9n 0.70000 33480.0n 0.70000 33659.9n 0.70000 33660.0n 0.70000 33839.9n 0.70000 33840.0n 0.70000 34019.9n 0.70000 34020.0n 0.70000 34199.9n 0.70000 34200.0n 0.70000 34379.9n 0.70000 34380.0n 0.70000 34559.9n 0.70000 34560.0n 0.70000 34739.9n 0.70000 34740.0n 0.30000 34919.9n 0.30000 34920.0n 0.30000 35099.9n 0.30000 35100.0n 0.30000 35279.9n 0.30000 35280.0n 0.70000 35459.9n 0.70000 35460.0n 0.30000 35639.9n 0.30000 35640.0n 0.70000 35819.9n 0.70000 35820.0n 0.70000 35999.9n 0.70000 36000.0n 0.70000 36179.9n 0.70000 36180.0n 0.30000 36359.9n 0.30000 36360.0n 0.30000 36539.9n 0.30000 36540.0n 0.30000 36719.9n 0.30000 36720.0n 0.70000 36899.9n 0.70000 36900.0n 0.70000 37079.9n 0.70000 37080.0n 0.30000 37259.9n 0.30000 37260.0n 0.70000 37439.9n 0.70000 37440.0n 0.30000 37619.9n 0.30000 37620.0n 0.70000 37799.9n 0.70000 37800.0n 0.70000 37979.9n 0.70000 37980.0n 0.30000 38159.9n 0.30000 38160.0n 0.30000 38339.9n 0.30000 38340.0n 0.30000 38519.9n 0.30000 38520.0n 0.30000 38699.9n 0.30000 38700.0n 0.30000 38879.9n 0.30000 38880.0n 0.30000 39059.9n 0.30000 39060.0n 0.70000 39239.9n 0.70000 39240.0n 0.70000 39419.9n 0.70000 39420.0n 0.70000 39599.9n 0.70000 39600.0n 0.70000 39779.9n 0.70000 39780.0n 0.30000 39959.9n 0.30000 39960.0n 0.70000 40139.9n 0.70000 40140.0n 0.70000 40319.9n 0.70000 40320.0n 0.30000 40499.9n 0.30000 40500.0n 0.30000 40679.9n 0.30000 40680.0n 0.70000 40859.9n 0.70000 40860.0n 0.70000 41039.9n 0.70000 41040.0n 0.70000 41219.9n 0.70000 41220.0n 0.70000 41399.9n 0.70000 41400.0n 0.30000 41579.9n 0.30000 41580.0n 0.30000 41759.9n 0.30000 41760.0n 0.30000 41939.9n 0.30000 41940.0n 0.30000 42119.9n 0.30000 42120.0n 0.30000 42299.9n 0.30000 42300.0n 0.30000 42479.9n 0.30000 42480.0n 0.30000 42659.9n 0.30000 42660.0n 0.30000 42839.9n 0.30000 42840.0n 0.70000 43019.9n 0.70000 43020.0n 0.30000 43199.9n 0.30000 43200.0n 0.70000 43379.9n 0.70000 43380.0n 0.70000 43559.9n 0.70000 43560.0n 0.70000 43739.9n 0.70000 43740.0n 0.70000 43919.9n 0.70000 43920.0n 0.30000 44099.9n 0.30000 44100.0n 0.30000 44279.9n 0.30000 44280.0n 0.70000 44459.9n 0.70000 44460.0n 0.30000 44639.9n 0.30000 44640.0n 0.70000 44819.9n 0.70000 44820.0n 0.30000 44999.9n 0.30000 45000.0n 0.70000 45179.9n 0.70000 45180.0n 0.30000 45359.9n 0.30000 45360.0n 0.70000 45539.9n 0.70000 45540.0n 0.70000 45719.9n 0.70000 45720.0n 0.70000 45899.9n 0.70000 45900.0n 0.70000 46079.9n 0.70000 46080.0n 0.30000 46259.9n 0.30000 46260.0n 0.30000 46439.9n 0.30000 46440.0n 0.70000 46619.9n 0.70000 46620.0n 0.70000 46799.9n 0.70000 46800.0n 0.70000 46979.9n 0.70000 46980.0n 0.30000 47159.9n 0.30000 47160.0n 0.30000 47339.9n 0.30000 47340.0n 0.70000 47519.9n 0.70000 47520.0n 0.70000 47699.9n 0.70000 47700.0n 0.70000 47879.9n 0.70000 47880.0n 0.30000 48059.9n 0.30000 48060.0n 0.70000 48239.9n 0.70000 48240.0n 0.30000 48419.9n 0.30000 48420.0n 0.30000 48599.9n 0.30000 48600.0n 0.30000 48779.9n 0.30000 48780.0n 0.30000 48959.9n 0.30000 48960.0n 0.70000 49139.9n 0.70000 49140.0n 0.30000 49319.9n 0.30000 49320.0n 0.30000 49499.9n 0.30000 49500.0n 0.70000 49679.9n 0.70000 49680.0n 0.30000 49859.9n 0.30000 49860.0n 0.70000 50039.9n 0.70000 50040.0n 0.70000 50219.9n 0.70000 50220.0n 0.70000 50399.9n 0.70000 50400.0n 0.30000 50579.9n 0.30000 50580.0n 0.70000 50759.9n 0.70000 50760.0n 0.30000 50939.9n 0.30000 50940.0n 0.30000 51119.9n 0.30000 51120.0n 0.70000 51299.9n 0.70000 51300.0n 0.30000 51479.9n 0.30000 51480.0n 0.70000 51659.9n 0.70000 51660.0n 0.70000 51839.9n 0.70000 51840.0n 0.30000 52019.9n 0.30000 52020.0n 0.30000 52199.9n 0.30000 52200.0n 0.30000 52379.9n 0.30000 52380.0n 0.70000 52559.9n 0.70000 52560.0n 0.30000 52739.9n 0.30000 52740.0n 0.70000 52919.9n 0.70000 52920.0n 0.70000 53099.9n 0.70000 53100.0n 0.30000 53279.9n 0.30000 53280.0n 0.30000 53459.9n 0.30000 53460.0n 0.30000 53639.9n 0.30000 53640.0n 0.30000 53819.9n 0.30000 53820.0n 0.70000 53999.9n 0.70000 54000.0n 0.70000 54179.9n 0.70000 54180.0n 0.70000 54359.9n 0.70000 54360.0n 0.70000 54539.9n 0.70000 54540.0n 0.30000 54719.9n 0.30000 54720.0n 0.70000 54899.9n 0.70000 54900.0n 0.70000 55079.9n 0.70000 55080.0n 0.70000 55259.9n 0.70000 55260.0n 0.70000 55439.9n 0.70000 55440.0n 0.30000 55619.9n 0.30000 55620.0n 0.30000 55799.9n 0.30000 55800.0n 0.30000 55979.9n 0.30000 55980.0n 0.30000 56159.9n 0.30000 56160.0n 0.30000 56339.9n 0.30000 56340.0n 0.70000 56519.9n 0.70000 56520.0n 0.70000 56699.9n 0.70000 56700.0n 0.70000 56879.9n 0.70000 56880.0n 0.70000 57059.9n 0.70000 57060.0n 0.30000 57239.9n 0.30000 57240.0n 0.70000 57419.9n 0.70000 57420.0n 0.30000 57599.9n 0.30000 57600.0n 0.70000 57779.9n 0.70000 57780.0n 0.70000 57959.9n 0.70000 57960.0n 0.30000 58139.9n 0.30000 58140.0n 0.30000 58319.9n 0.30000 58320.0n 0.70000 58499.9n 0.70000 58500.0n 0.30000 58679.9n 0.30000 58680.0n 0.30000 58859.9n 0.30000 58860.0n 0.70000 59039.9n 0.70000 59040.0n 0.70000 59219.9n 0.70000 59220.0n 0.70000 59399.9n 0.70000 59400.0n 0.70000 59579.9n 0.70000 59580.0n 0.70000 59759.9n 0.70000 59760.0n 0.70000 59939.9n 0.70000 59940.0n 0.30000 60119.9n 0.30000 60120.0n 0.70000 60299.9n 0.70000 60300.0n 0.30000 60479.9n 0.30000 60480.0n 0.30000 60659.9n 0.30000 60660.0n 0.30000 60839.9n 0.30000 60840.0n 0.30000 61019.9n 0.30000 61020.0n 0.30000 61199.9n 0.30000 61200.0n 0.30000 61379.9n 0.30000 61380.0n 0.30000 61559.9n 0.30000 61560.0n 0.70000 61739.9n 0.70000 61740.0n 0.70000 61919.9n 0.70000 61920.0n 0.70000 62099.9n 0.70000 62100.0n 0.70000 62279.9n 0.70000 62280.0n 0.30000 62459.9n 0.30000 62460.0n 0.30000 62639.9n 0.30000 62640.0n 0.30000 62819.9n 0.30000 62820.0n 0.70000 62999.9n 0.70000 63000.0n 0.70000 63179.9n 0.70000 63180.0n 0.30000 63359.9n 0.30000 63360.0n 0.30000 63539.9n 0.30000 63540.0n 0.30000 63719.9n 0.30000 63720.0n 0.70000 63899.9n 0.70000 63900.0n 0.30000 64079.9n 0.30000 64080.0n 0.30000 64259.9n 0.30000 64260.0n 0.70000 64439.9n 0.70000 64440.0n 0.30000 64619.9n 0.30000 64620.0n 0.70000 64799.9n 0.70000 64800.0n 0.30000 64979.9n 0.30000 64980.0n 0.70000 65159.9n 0.70000 65160.0n 0.70000 65339.9n 0.70000 65340.0n 0.70000 65519.9n 0.70000 65520.0n 0.70000 65699.9n 0.70000 65700.0n 0.30000 65879.9n 0.30000 65880.0n 0.70000 66059.9n 0.70000 66060.0n 0.70000 66239.9n 0.70000 66240.0n 0.30000 66419.9n 0.30000 66420.0n 0.30000 66599.9n 0.30000 66600.0n 0.30000 66779.9n 0.30000 66780.0n 0.30000 66959.9n 0.30000 66960.0n 0.70000 67139.9n 0.70000 67140.0n 0.70000 67319.9n 0.70000 67320.0n 0.70000 67499.9n 0.70000 67500.0n 0.30000 67679.9n 0.30000 67680.0n 0.30000 67859.9n 0.30000 67860.0n 0.70000 68039.9n 0.70000 68040.0n 0.30000 68219.9n 0.30000 68220.0n 0.70000 68399.9n 0.70000 68400.0n 0.30000 68579.9n 0.30000 68580.0n 0.70000 68759.9n 0.70000 68760.0n 0.70000 68939.9n 0.70000 68940.0n 0.30000 69119.9n 0.30000 69120.0n 0.70000 69299.9n 0.70000 69300.0n 0.30000 69479.9n 0.30000 69480.0n 0.30000 69659.9n 0.30000 69660.0n 0.30000 69839.9n 0.30000 69840.0n 0.30000 70019.9n 0.30000 70020.0n 0.70000 70199.9n 0.70000 70200.0n 0.70000 70379.9n 0.70000 70380.0n 0.70000 70559.9n 0.70000 70560.0n 0.70000 70739.9n 0.70000 70740.0n 0.70000 70919.9n 0.70000 70920.0n 0.30000 71099.9n 0.30000 71100.0n 0.30000 71279.9n 0.30000 71280.0n 0.30000 71459.9n 0.30000 71460.0n 0.30000 71639.9n 0.30000 71640.0n 0.70000 71819.9n 0.70000 71820.0n 0.70000 71999.9n 0.70000 72000.0n 0.70000 72179.9n 0.70000 72180.0n 0.30000 72359.9n 0.30000 72360.0n 0.30000 72539.9n 0.30000 72540.0n 0.70000 72719.9n 0.70000 72720.0n 0.70000 72899.9n 0.70000 72900.0n 0.30000 73079.9n 0.30000 73080.0n 0.30000 73259.9n 0.30000 73260.0n 0.70000 73439.9n 0.70000 73440.0n 0.70000 73619.9n 0.70000 73620.0n 0.30000 73799.9n 0.30000 73800.0n 0.30000 73979.9n 0.30000 73980.0n 0.70000 74159.9n 0.70000 74160.0n 0.70000 74339.9n 0.70000 74340.0n 0.30000 74519.9n 0.30000 74520.0n 0.30000 74699.9n 0.30000 74700.0n 0.70000 74879.9n 0.70000 74880.0n 0.70000 75059.9n 0.70000 75060.0n 0.30000 75239.9n 0.30000 75240.0n 0.30000 75419.9n 0.30000 75420.0n 0.30000 75599.9n 0.30000 75600.0n 0.30000 75779.9n 0.30000 75780.0n 0.30000 75959.9n 0.30000 75960.0n 0.30000 76139.9n 0.30000 76140.0n 0.30000 76319.9n 0.30000 76320.0n 0.70000 76499.9n 0.70000 76500.0n 0.70000 76679.9n 0.70000 76680.0n 0.30000 76859.9n 0.30000 76860.0n 0.30000 77039.9n 0.30000 77040.0n 0.30000 77219.9n 0.30000 77220.0n 0.70000 77399.9n 0.70000 77400.0n 0.70000 77579.9n 0.70000 77580.0n 0.30000 77759.9n 0.30000 77760.0n 0.70000 77939.9n 0.70000 77940.0n 0.70000 78119.9n 0.70000 78120.0n 0.70000 78299.9n 0.70000 78300.0n 0.30000 78479.9n 0.30000 78480.0n 0.70000 78659.9n 0.70000 78660.0n 0.70000 78839.9n 0.70000 78840.0n 0.70000 79019.9n 0.70000 79020.0n 0.30000 79199.9n 0.30000 79200.0n 0.70000 79379.9n 0.70000 79380.0n 0.70000 79559.9n 0.70000 79560.0n 0.30000 79739.9n 0.30000 79740.0n 0.30000 79919.9n 0.30000 79920.0n 0.70000 80099.9n 0.70000 80100.0n 0.70000 80279.9n 0.70000 80280.0n 0.70000 80459.9n 0.70000 80460.0n 0.30000 80639.9n 0.30000 80640.0n 0.70000 80819.9n 0.70000 80820.0n 0.70000 80999.9n 0.70000 81000.0n 0.70000 81179.9n 0.70000 81180.0n 0.30000 81359.9n 0.30000 81360.0n 0.30000 81539.9n 0.30000 81540.0n 0.30000 81719.9n 0.30000 81720.0n 0.70000 81899.9n 0.70000 81900.0n 0.70000 82079.9n 0.70000 82080.0n 0.30000 82259.9n 0.30000 82260.0n 0.30000 82439.9n 0.30000 82440.0n 0.30000 82619.9n 0.30000 82620.0n 0.30000 82799.9n 0.30000 82800.0n 0.30000 82979.9n 0.30000 82980.0n 0.70000 83159.9n 0.70000 83160.0n 0.70000 83339.9n 0.70000 83340.0n 0.70000 83519.9n 0.70000 83520.0n 0.30000 83699.9n 0.30000 83700.0n 0.30000 83879.9n 0.30000 83880.0n 0.70000 84059.9n 0.70000 84060.0n 0.70000 84239.9n 0.70000 84240.0n 0.30000 84419.9n 0.30000 84420.0n 0.70000 84599.9n 0.70000 84600.0n 0.70000 84779.9n 0.70000 84780.0n 0.30000 84959.9n 0.30000 84960.0n 0.30000 85139.9n 0.30000 85140.0n 0.30000 85319.9n 0.30000 85320.0n 0.30000 85499.9n 0.30000 85500.0n 0.70000 85679.9n 0.70000 85680.0n 0.70000 85859.9n 0.70000 85860.0n 0.70000 86039.9n 0.70000 86040.0n 0.30000 86219.9n 0.30000 86220.0n 0.70000 86399.9n 0.70000 86400.0n 0.70000 86579.9n 0.70000 86580.0n 0.70000 86759.9n 0.70000 86760.0n 0.70000 86939.9n 0.70000 86940.0n 0.30000 87119.9n 0.30000 87120.0n 0.70000 87299.9n 0.70000 87300.0n 0.70000 87479.9n 0.70000 87480.0n 0.70000 87659.9n 0.70000 87660.0n 0.70000 87839.9n 0.70000 87840.0n 0.30000 88019.9n 0.30000 88020.0n 0.70000 88199.9n 0.70000 88200.0n 0.30000 88379.9n 0.30000 88380.0n 0.30000 88559.9n 0.30000 88560.0n 0.30000 88739.9n 0.30000 88740.0n 0.30000 88919.9n 0.30000 88920.0n 0.70000 89099.9n 0.70000 89100.0n 0.30000 89279.9n 0.30000 89280.0n 0.30000 89459.9n 0.30000 89460.0n 0.70000 89639.9n 0.70000 89640.0n 0.70000 89819.9n 0.70000 89820.0n 0.30000 89999.9n 0.30000 90000.0n 0.30000 90179.9n 0.30000 90180.0n 0.30000 90359.9n 0.30000 90360.0n 0.30000 90539.9n 0.30000 90540.0n 0.70000 90719.9n 0.70000 90720.0n 0.30000 90899.9n 0.30000 90900.0n 0.30000 91079.9n 0.30000 91080.0n 0.70000 91259.9n 0.70000 91260.0n 0.70000 91439.9n 0.70000 91440.0n 0.70000 91619.9n 0.70000 91620.0n 0.30000 91799.9n 0.30000 91800.0n 0.70000 91979.9n 0.70000 91980.0n 0.30000 92159.9n 0.30000 92160.0n 0.70000 92339.9n 0.70000 92340.0n 0.30000 92519.9n 0.30000 92520.0n 0.30000 92699.9n 0.30000 92700.0n 0.30000 92879.9n 0.30000 92880.0n 0.70000 93059.9n 0.70000 93060.0n 0.70000 93239.9n 0.70000 93240.0n 0.70000 93419.9n 0.70000 93420.0n 0.30000 93599.9n 0.30000 93600.0n 0.30000 93779.9n 0.30000 93780.0n 0.70000 93959.9n 0.70000 93960.0n 0.70000 94139.9n 0.70000 94140.0n 0.30000 94319.9n 0.30000 94320.0n 0.70000 94499.9n 0.70000 94500.0n 0.30000 94679.9n 0.30000 94680.0n 0.30000 94859.9n 0.30000 94860.0n 0.30000 95039.9n 0.30000 95040.0n 0.30000 95219.9n 0.30000 95220.0n 0.30000 95399.9n 0.30000 95400.0n 0.30000 95579.9n 0.30000 95580.0n 0.70000 95759.9n 0.70000 95760.0n 0.70000 95939.9n 0.70000 95940.0n 0.70000 96119.9n 0.70000 96120.0n 0.30000 96299.9n 0.30000 96300.0n 0.30000 96479.9n 0.30000 96480.0n 0.30000 96659.9n 0.30000 96660.0n 0.70000 96839.9n 0.70000 96840.0n 0.70000 97019.9n 0.70000 97020.0n 0.70000 97199.9n 0.70000 97200.0n 0.30000 97379.9n 0.30000 97380.0n 0.70000 97559.9n 0.70000 97560.0n 0.70000 97739.9n 0.70000 97740.0n 0.70000 97919.9n 0.70000 97920.0n 0.70000 98099.9n 0.70000 98100.0n 0.70000 98279.9n 0.70000 98280.0n 0.70000 98459.9n 0.70000 98460.0n 0.70000 98639.9n 0.70000 98640.0n 0.70000 98819.9n 0.70000 98820.0n 0.70000 98999.9n 0.70000 99000.0n 0.70000 99179.9n 0.70000 99180.0n 0.70000 99359.9n 0.70000 99360.0n 0.70000 99539.9n 0.70000 99540.0n 0.30000 99719.9n 0.30000 99720.0n 0.30000 99899.9n 0.30000 99900.0n 0.70000 100079.9n 0.70000 100080.0n 0.30000 100259.9n 0.30000 100260.0n 0.30000 100439.9n 0.30000 100440.0n 0.70000 100619.9n 0.70000 100620.0n 0.70000 100799.9n 0.70000 100800.0n 0.30000 100979.9n 0.30000 100980.0n 0.30000 101159.9n 0.30000 101160.0n 0.30000 101339.9n 0.30000 101340.0n 0.70000 101519.9n 0.70000 101520.0n 0.70000 101699.9n 0.70000 101700.0n 0.30000 101879.9n 0.30000 101880.0n 0.30000 102059.9n 0.30000 102060.0n 0.30000 102239.9n 0.30000 102240.0n 0.70000 102419.9n 0.70000 102420.0n 0.30000 102599.9n 0.30000 102600.0n 0.30000 102779.9n 0.30000 102780.0n 0.30000 102959.9n 0.30000 102960.0n 0.70000 103139.9n 0.70000 103140.0n 0.30000 103319.9n 0.30000 103320.0n 0.30000 103499.9n 0.30000 103500.0n 0.30000 103679.9n 0.30000 103680.0n 0.70000 103859.9n 0.70000 103860.0n 0.70000 104039.9n 0.70000 104040.0n 0.70000 104219.9n 0.70000 104220.0n 0.70000 104399.9n 0.70000 104400.0n 0.30000 104579.9n 0.30000 104580.0n 0.30000 104759.9n 0.30000 104760.0n 0.30000 104939.9n 0.30000 104940.0n 0.30000 105119.9n 0.30000 105120.0n 0.70000 105299.9n 0.70000 105300.0n 0.70000 105479.9n 0.70000 105480.0n 0.30000 105659.9n 0.30000 105660.0n 0.70000 105839.9n 0.70000 105840.0n 0.30000 106019.9n 0.30000 106020.0n 0.70000 106199.9n 0.70000 106200.0n 0.30000 106379.9n 0.30000 106380.0n 0.70000 106559.9n 0.70000 106560.0n 0.70000 106739.9n 0.70000 106740.0n 0.30000 106919.9n 0.30000 106920.0n 0.30000 107099.9n 0.30000 107100.0n 0.70000 107279.9n 0.70000 107280.0n 0.30000 107459.9n 0.30000 107460.0n 0.30000 107639.9n 0.30000 107640.0n 0.30000 107819.9n 0.30000 107820.0n 0.70000 107999.9n 0.70000 108000.0n 0.70000 108179.9n 0.70000 108180.0n 0.70000 108359.9n 0.70000 108360.0n 0.30000 108539.9n 0.30000 108540.0n 0.70000 108719.9n 0.70000 108720.0n 0.30000 108899.9n 0.30000 108900.0n 0.30000 109079.9n 0.30000 109080.0n 0.30000 109259.9n 0.30000 109260.0n 0.70000 109439.9n 0.70000 109440.0n 0.70000 109619.9n 0.70000 109620.0n 0.70000 109799.9n 0.70000 109800.0n 0.30000 109979.9n 0.30000 109980.0n 0.70000 110159.9n 0.70000 110160.0n 0.70000 110339.9n 0.70000 110340.0n 0.70000 110519.9n 0.70000 110520.0n 0.30000 110699.9n 0.30000 110700.0n 0.70000 110879.9n 0.70000 110880.0n 0.70000 111059.9n 0.70000 111060.0n 0.30000 111239.9n 0.30000 111240.0n 0.30000 111419.9n 0.30000 111420.0n 0.70000 111599.9n 0.70000 111600.0n 0.30000 111779.9n 0.30000 111780.0n 0.30000 111959.9n 0.30000 111960.0n 0.30000 112139.9n 0.30000 112140.0n 0.30000 112319.9n 0.30000 112320.0n 0.30000 112499.9n 0.30000 112500.0n 0.30000 112679.9n 0.30000 112680.0n 0.70000 112859.9n 0.70000 112860.0n 0.70000 113039.9n 0.70000 113040.0n 0.30000 113219.9n 0.30000 113220.0n 0.70000 113399.9n 0.70000 113400.0n 0.30000 113579.9n 0.30000 113580.0n 0.30000 113759.9n 0.30000 113760.0n 0.70000 113939.9n 0.70000 113940.0n 0.70000 114119.9n 0.70000 114120.0n 0.70000 114299.9n 0.70000 114300.0n 0.30000 114479.9n 0.30000 114480.0n 0.70000 114659.9n 0.70000 114660.0n 0.30000 114839.9n 0.30000 114840.0n 0.30000 115019.9n 0.30000 115020.0n 0.70000 115199.9n 0.70000 115200.0n 0.70000 115379.9n 0.70000 115380.0n 0.70000 115559.9n 0.70000 115560.0n 0.30000 115739.9n 0.30000 115740.0n 0.30000 115919.9n 0.30000 115920.0n 0.70000 116099.9n 0.70000 116100.0n 0.30000 116279.9n 0.30000 116280.0n 0.70000 116459.9n 0.70000 116460.0n 0.70000 116639.9n 0.70000 116640.0n 0.30000 116819.9n 0.30000 116820.0n 0.30000 116999.9n 0.30000 117000.0n 0.70000 117179.9n 0.70000 117180.0n 0.70000 117359.9n 0.70000 117360.0n 0.30000 117539.9n 0.30000 117540.0n 0.70000 117719.9n 0.70000 117720.0n 0.30000 117899.9n 0.30000 117900.0n 0.70000 118079.9n 0.70000 118080.0n 0.70000 118259.9n 0.70000 118260.0n 0.30000 118439.9n 0.30000 118440.0n 0.70000 118619.9n 0.70000 118620.0n 0.70000 118799.9n 0.70000 118800.0n 0.30000 118979.9n 0.30000 118980.0n 0.30000 119159.9n 0.30000 119160.0n 0.30000 119339.9n 0.30000 119340.0n 0.30000 119519.9n 0.30000 119520.0n 0.30000 119699.9n 0.30000 119700.0n 0.30000 119879.9n 0.30000 119880.0n 0.70000 120059.9n 0.70000 120060.0n 0.70000 120239.9n 0.70000 120240.0n 0.30000 120419.9n 0.30000 120420.0n 0.30000 120599.9n 0.30000 120600.0n 0.70000 120779.9n 0.70000 120780.0n 0.70000 120959.9n 0.70000 120960.0n 0.70000 121139.9n 0.70000 121140.0n 0.70000 121319.9n 0.70000 121320.0n 0.30000 121499.9n 0.30000 121500.0n 0.70000 121679.9n 0.70000 121680.0n 0.70000 121859.9n 0.70000 121860.0n 0.30000 122039.9n 0.30000 122040.0n 0.30000 122219.9n 0.30000 122220.0n 0.30000 122399.9n 0.30000 122400.0n 0.70000 122579.9n 0.70000 122580.0n 0.30000 122759.9n 0.30000 122760.0n 0.30000 122939.9n 0.30000 122940.0n 0.70000 123119.9n 0.70000 123120.0n 0.30000 123299.9n 0.30000 123300.0n 0.70000 123479.9n 0.70000 123480.0n 0.70000 123659.9n 0.70000 123660.0n 0.70000 123839.9n 0.70000 123840.0n 0.30000 124019.9n 0.30000 124020.0n 0.30000 124199.9n 0.30000 124200.0n 0.70000 124379.9n 0.70000 124380.0n 0.30000 124559.9n 0.30000 124560.0n 0.30000 124739.9n 0.30000 124740.0n 0.30000 124919.9n 0.30000 124920.0n 0.70000 125099.9n 0.70000 125100.0n 0.70000 125279.9n 0.70000 125280.0n 0.70000 125459.9n 0.70000 125460.0n 0.70000 125639.9n 0.70000 125640.0n 0.30000 125819.9n 0.30000 125820.0n 0.30000 125999.9n 0.30000 126000.0n 0.70000 126179.9n 0.70000 126180.0n 0.30000 126359.9n 0.30000 126360.0n 0.70000 126539.9n 0.70000 126540.0n 0.30000 126719.9n 0.30000 126720.0n 0.70000 126899.9n 0.70000 126900.0n 0.70000 127079.9n 0.70000 127080.0n 0.70000 127259.9n 0.70000 127260.0n 0.70000 127439.9n 0.70000 127440.0n 0.70000 127619.9n 0.70000 127620.0n 0.30000 127799.9n 0.30000 127800.0n 0.70000 127979.9n 0.70000 127980.0n 0.70000 128159.9n 0.70000 128160.0n 0.30000 128339.9n 0.30000 128340.0n 0.30000 128519.9n 0.30000 128520.0n 0.30000 128699.9n 0.30000 128700.0n 0.30000 128879.9n 0.30000 128880.0n 0.70000 129059.9n 0.70000 129060.0n 0.30000 129239.9n 0.30000 129240.0n 0.30000 129419.9n 0.30000 129420.0n 0.30000 129599.9n 0.30000 129600.0n 0.70000 129779.9n 0.70000 129780.0n 0.30000 129959.9n 0.30000 129960.0n 0.30000 130139.9n 0.30000 130140.0n 0.30000 130319.9n 0.30000 130320.0n 0.30000 130499.9n 0.30000 130500.0n 0.70000 130679.9n 0.70000 130680.0n 0.70000 130859.9n 0.70000 130860.0n 0.70000 131039.9n 0.70000 131040.0n 0.30000 131219.9n 0.30000 131220.0n 0.30000 131399.9n 0.30000 131400.0n 0.70000 131579.9n 0.70000 131580.0n 0.30000 131759.9n 0.30000 131760.0n 0.70000 131939.9n 0.70000 131940.0n 0.70000 132119.9n 0.70000 132120.0n 0.30000 132299.9n 0.30000 132300.0n 0.70000 132479.9n 0.70000 132480.0n 0.70000 132659.9n 0.70000 132660.0n 0.70000 132839.9n 0.70000 132840.0n 0.30000 133019.9n 0.30000 133020.0n 0.30000 133199.9n 0.30000 133200.0n 0.70000 133379.9n 0.70000 133380.0n 0.70000 133559.9n 0.70000 133560.0n 0.70000 133739.9n 0.70000 133740.0n 0.70000 133919.9n 0.70000 133920.0n 0.70000 134099.9n 0.70000 134100.0n 0.70000 134279.9n 0.70000 134280.0n 0.30000 134459.9n 0.30000 134460.0n 0.30000 134639.9n 0.30000 134640.0n 0.70000 134819.9n 0.70000 134820.0n 0.70000 134999.9n 0.70000 135000.0n 0.30000 135179.9n 0.30000 135180.0n 0.30000 135359.9n 0.30000 135360.0n 0.30000 135539.9n 0.30000 135540.0n 0.30000 135719.9n 0.30000 135720.0n 0.70000 135899.9n 0.70000 135900.0n 0.30000 136079.9n 0.30000 136080.0n 0.70000 136259.9n 0.70000 136260.0n 0.30000 136439.9n 0.30000 136440.0n 0.70000 136619.9n 0.70000 136620.0n 0.30000 136799.9n 0.30000 136800.0n 0.30000 136979.9n 0.30000 136980.0n 0.30000 137159.9n 0.30000 137160.0n 0.30000 137339.9n 0.30000 137340.0n 0.30000 137519.9n 0.30000 137520.0n 0.70000 137699.9n 0.70000 137700.0n 0.30000 137879.9n 0.30000 137880.0n 0.70000 138059.9n 0.70000 138060.0n 0.70000 138239.9n 0.70000 138240.0n 0.30000 138419.9n 0.30000 138420.0n 0.30000 138599.9n 0.30000 138600.0n 0.30000 138779.9n 0.30000 138780.0n 0.30000 138959.9n 0.30000 138960.0n 0.30000 139139.9n 0.30000 139140.0n 0.70000 139319.9n 0.70000 139320.0n 0.70000 139499.9n 0.70000 139500.0n 0.30000 139679.9n 0.30000 139680.0n 0.30000 139859.9n 0.30000 139860.0n 0.70000 140039.9n 0.70000 140040.0n 0.70000 140219.9n 0.70000 140220.0n 0.70000 140399.9n 0.70000 140400.0n 0.30000 140579.9n 0.30000 140580.0n 0.30000 140759.9n 0.30000 140760.0n 0.70000 140939.9n 0.70000 140940.0n 0.30000 141119.9n 0.30000 141120.0n 0.70000 141299.9n 0.70000 141300.0n 0.30000 141479.9n 0.30000 141480.0n 0.30000 141659.9n 0.30000 141660.0n 0.70000 141839.9n 0.70000 141840.0n 0.70000 142019.9n 0.70000 142020.0n 0.30000 142199.9n 0.30000 142200.0n 0.30000 142379.9n 0.30000 142380.0n 0.30000 142559.9n 0.30000 142560.0n 0.70000 142739.9n 0.70000 142740.0n 0.70000 142919.9n 0.70000 142920.0n 0.70000 143099.9n 0.70000 143100.0n 0.70000 143279.9n 0.70000 143280.0n 0.30000 143459.9n 0.30000 143460.0n 0.70000 143639.9n 0.70000 143640.0n 0.70000 143819.9n 0.70000 143820.0n 0.70000 143999.9n 0.70000 144000.0n 0.70000 144179.9n 0.70000 144180.0n 0.30000 144359.9n 0.30000 144360.0n 0.30000 144539.9n 0.30000 144540.0n 0.70000 144719.9n 0.70000 144720.0n 0.70000 144899.9n 0.70000 144900.0n 0.30000 145079.9n 0.30000 145080.0n 0.30000 145259.9n 0.30000 145260.0n 0.30000 145439.9n 0.30000 145440.0n 0.30000 145619.9n 0.30000 145620.0n 0.30000 145799.9n 0.30000 145800.0n 0.30000 145979.9n 0.30000 145980.0n 0.70000 146159.9n 0.70000 146160.0n 0.70000 146339.9n 0.70000 146340.0n 0.70000 146519.9n 0.70000 146520.0n 0.30000 146699.9n 0.30000 146700.0n 0.70000 146879.9n 0.70000 146880.0n 0.30000 147059.9n 0.30000 147060.0n 0.30000 147239.9n 0.30000 147240.0n 0.70000 147419.9n 0.70000 147420.0n 0.30000 147599.9n 0.30000 147600.0n 0.30000 147779.9n 0.30000 147780.0n 0.30000 147959.9n 0.30000 147960.0n 0.70000 148139.9n 0.70000 148140.0n 0.30000 148319.9n 0.30000 148320.0n 0.70000 148499.9n 0.70000 148500.0n 0.70000 148679.9n 0.70000 148680.0n 0.70000 148859.9n 0.70000 148860.0n 0.70000 149039.9n 0.70000 149040.0n 0.70000 149219.9n 0.70000 149220.0n 0.30000 149399.9n 0.30000 149400.0n 0.70000 149579.9n 0.70000 149580.0n 0.70000 149759.9n 0.70000 149760.0n 0.70000 149939.9n 0.70000 149940.0n 0.70000 150119.9n 0.70000 150120.0n 0.30000 150299.9n 0.30000 150300.0n 0.30000 150479.9n 0.30000 150480.0n 0.70000 150659.9n 0.70000 150660.0n 0.70000 150839.9n 0.70000 150840.0n 0.30000 151019.9n 0.30000 151020.0n 0.30000 151199.9n 0.30000 151200.0n 0.30000 151379.9n 0.30000 151380.0n 0.30000 151559.9n 0.30000 151560.0n 0.30000 151739.9n 0.30000 151740.0n 0.70000 151919.9n 0.70000 151920.0n 0.30000 152099.9n 0.30000 152100.0n 0.70000 152279.9n 0.70000 152280.0n 0.70000 152459.9n 0.70000 152460.0n 0.30000 152639.9n 0.30000 152640.0n 0.30000 152819.9n 0.30000 152820.0n 0.30000 152999.9n 0.30000 153000.0n 0.70000 153179.9n 0.70000 153180.0n 0.30000 153359.9n 0.30000 153360.0n 0.30000 153539.9n 0.30000 153540.0n 0.70000 153719.9n 0.70000 153720.0n 0.70000 153899.9n 0.70000 153900.0n 0.70000 154079.9n 0.70000 154080.0n 0.70000 154259.9n 0.70000 154260.0n 0.30000 154439.9n 0.30000 154440.0n 0.70000 154619.9n 0.70000 154620.0n 0.30000 154799.9n 0.30000 154800.0n 0.70000 154979.9n 0.70000 154980.0n 0.70000 155159.9n 0.70000 155160.0n 0.70000 155339.9n 0.70000 155340.0n 0.30000 155519.9n 0.30000 155520.0n 0.70000 155699.9n 0.70000 155700.0n 0.30000 155879.9n 0.30000 155880.0n 0.70000 156059.9n 0.70000 156060.0n 0.30000 156239.9n 0.30000 156240.0n 0.70000 156419.9n 0.70000 156420.0n 0.30000 156599.9n 0.30000 156600.0n 0.30000 156779.9n 0.30000 156780.0n 0.30000 156959.9n 0.30000 156960.0n 0.30000 157139.9n 0.30000 157140.0n 0.30000 157319.9n 0.30000 157320.0n 0.70000 157499.9n 0.70000 157500.0n 0.70000 157679.9n 0.70000 157680.0n 0.70000 157859.9n 0.70000 157860.0n 0.70000 158039.9n 0.70000 158040.0n 0.30000 158219.9n 0.30000 158220.0n 0.70000 158399.9n 0.70000 158400.0n 0.30000 158579.9n 0.30000 158580.0n 0.30000 158759.9n 0.30000 158760.0n 0.30000 158939.9n 0.30000 158940.0n 0.30000 159119.9n 0.30000 159120.0n 0.70000 159299.9n 0.70000 159300.0n 0.70000 159479.9n 0.70000 159480.0n 0.30000 159659.9n 0.30000 159660.0n 0.30000 159839.9n 0.30000 159840.0n 0.70000 160019.9n 0.70000 160020.0n 0.70000 160199.9n 0.70000 160200.0n 0.70000 160379.9n 0.70000 160380.0n 0.70000 160559.9n 0.70000 160560.0n 0.70000 160739.9n 0.70000 160740.0n 0.30000 160919.9n 0.30000 160920.0n 0.70000 161099.9n 0.70000 161100.0n 0.30000 161279.9n 0.30000 161280.0n 0.70000 161459.9n 0.70000 161460.0n 0.70000 161639.9n 0.70000 161640.0n 0.30000 161819.9n 0.30000 161820.0n 0.70000 161999.9n 0.70000 162000.0n 0.30000 162179.9n 0.30000 162180.0n 0.70000 162359.9n 0.70000 162360.0n 0.30000 162539.9n 0.30000 162540.0n 0.30000 162719.9n 0.30000 162720.0n 0.70000 162899.9n 0.70000 162900.0n 0.70000 163079.9n 0.70000 163080.0n 0.30000 163259.9n 0.30000 163260.0n 0.70000 163439.9n 0.70000 163440.0n 0.30000 163619.9n 0.30000 163620.0n 0.70000 163799.9n 0.70000 163800.0n 0.30000 163979.9n 0.30000 163980.0n 0.30000 164159.9n 0.30000 164160.0n 0.70000 164339.9n 0.70000 164340.0n 0.30000 164519.9n 0.30000 164520.0n 0.30000 164699.9n 0.30000 164700.0n 0.70000 164879.9n 0.70000 164880.0n 0.30000 165059.9n 0.30000 165060.0n 0.30000 165239.9n 0.30000 165240.0n 0.70000 165419.9n 0.70000 165420.0n 0.30000 165599.9n 0.30000 165600.0n 0.70000 165779.9n 0.70000 165780.0n 0.70000 165959.9n 0.70000 165960.0n 0.30000 166139.9n 0.30000 166140.0n 0.70000 166319.9n 0.70000 166320.0n 0.70000 166499.9n 0.70000 166500.0n 0.30000 166679.9n 0.30000 166680.0n 0.70000 166859.9n 0.70000 166860.0n 0.30000 167039.9n 0.30000 167040.0n 0.30000 167219.9n 0.30000 167220.0n 0.30000 167399.9n 0.30000 167400.0n 0.70000 167579.9n 0.70000 167580.0n 0.70000 167759.9n 0.70000 167760.0n 0.70000 167939.9n 0.70000 167940.0n 0.30000 168119.9n 0.30000 168120.0n 0.70000 168299.9n 0.70000 168300.0n 0.70000 168479.9n 0.70000 168480.0n 0.30000 168659.9n 0.30000 168660.0n 0.70000 168839.9n 0.70000 168840.0n 0.70000 169019.9n 0.70000 169020.0n 0.30000 169199.9n 0.30000 169200.0n 0.30000 169379.9n 0.30000 169380.0n 0.70000 169559.9n 0.70000 169560.0n 0.30000 169739.9n 0.30000 169740.0n 0.70000 169919.9n 0.70000 169920.0n 0.70000 170099.9n 0.70000 170100.0n 0.70000 170279.9n 0.70000 170280.0n 0.70000 170459.9n 0.70000 170460.0n 0.30000 170639.9n 0.30000 170640.0n 0.30000 170819.9n 0.30000 170820.0n 0.30000 170999.9n 0.30000 171000.0n 0.70000 171179.9n 0.70000 171180.0n 0.30000 171359.9n 0.30000 171360.0n 0.70000 171539.9n 0.70000 171540.0n 0.30000 171719.9n 0.30000 171720.0n 0.30000 171899.9n 0.30000 171900.0n 0.70000 172079.9n 0.70000 172080.0n 0.70000 172259.9n 0.70000 172260.0n 0.30000 172439.9n 0.30000 172440.0n 0.30000 172619.9n 0.30000 172620.0n 0.30000 172799.9n 0.30000 172800.0n 0.50000 172979.9n 0.50000 172980.0n 0.50000 173159.9n 0.50000 173160.0n 0.50000 173339.9n 0.50000 173340.0n 0.50000 173519.9n 0.50000 173520.0n 0.50000 173699.9n 0.50000 173700.0n 0.50000 173879.9n 0.50000 173880.0n 0.50000 174059.9n 0.50000 174060.0n 0.50000 174239.9n 0.50000 174240.0n 0.50000 174419.9n 0.50000 174420.0n 0.50000 174599.9n 0.50000 174600.0n 0.50000 174779.9n 0.50000 174780.0n 0.50000 174959.9n 0.50000 174960.0n 0.50000 175139.9n 0.50000 175140.0n 0.50000 175319.9n 0.50000 175320.0n 0.50000 175499.9n 0.50000 175500.0n 0.50000 175679.9n 0.50000 175680.0n 0.50000 175859.9n 0.50000 175860.0n 0.50000 176039.9n 0.50000 176040.0n 0.50000 176219.9n 0.50000 176220.0n 0.50000 176399.9n 0.50000 176400.0n 0.50000 176579.9n 0.50000 176580.0n 0.50000 176759.9n 0.50000 176760.0n 0.50000 176939.9n 0.50000 176940.0n 0.50000 177119.9n 0.50000 177120.0n 0.50000 177299.9n 0.50000 177300.0n 0.50000 177479.9n 0.50000 177480.0n 0.50000 177659.9n 0.50000 177660.0n 0.50000 177839.9n 0.50000 177840.0n 0.50000 178019.9n 0.50000 178020.0n 0.50000 178199.9n 0.50000 178200.0n 0.50000 178379.9n 0.50000 178380.0n 0.50000 178559.9n 0.50000 178560.0n 0.50000 178739.9n 0.50000 178740.0n 0.50000 178919.9n 0.50000 178920.0n 0.50000 179099.9n 0.50000 179100.0n 0.50000 179279.9n 0.50000 179280.0n 0.50000 179459.9n 0.50000 179460.0n 0.50000 179639.9n 0.50000 179640.0n 0.50000 179819.9n 0.50000 179820.0n 0.50000 179999.9n 0.50000 180000.0n 0.50000 180179.9n 0.50000 180180.0n 0.50000 180359.9n 0.50000 180360.0n 0.50000 180539.9n 0.50000 180540.0n 0.50000 180719.9n 0.50000 180720.0n 0.50000 180899.9n 0.50000 180900.0n 0.50000 181079.9n 0.50000 181080.0n 0.50000 181259.9n 0.50000 181260.0n 0.50000 181439.9n 0.50000 181440.0n 0.50000 181619.9n 0.50000 181620.0n 0.50000 181799.9n 0.50000 181800.0n 0.50000 181979.9n 0.50000 181980.0n 0.50000 182159.9n 0.50000 182160.0n 0.50000 182339.9n 0.50000 182340.0n 0.50000 182519.9n 0.50000 182520.0n 0.50000 182699.9n 0.50000 182700.0n 0.50000 182879.9n 0.50000 182880.0n 0.50000 183059.9n 0.50000 183060.0n 0.50000 183239.9n 0.50000 183240.0n 0.50000 183419.9n 0.50000 183420.0n 0.50000)
Vxop1 xop1 0 PWL(0.0n 0.30000 179.9n 0.30000 180.0n 0.30000 359.9n 0.30000 360.0n 0.30000 539.9n 0.30000 540.0n 0.30000 719.9n 0.30000 720.0n 0.70000 899.9n 0.70000 900.0n 0.70000 1079.9n 0.70000 1080.0n 0.70000 1259.9n 0.70000 1260.0n 0.30000 1439.9n 0.30000 1440.0n 0.70000 1619.9n 0.70000 1620.0n 0.70000 1799.9n 0.70000 1800.0n 0.70000 1979.9n 0.70000 1980.0n 0.70000 2159.9n 0.70000 2160.0n 0.30000 2339.9n 0.30000 2340.0n 0.30000 2519.9n 0.30000 2520.0n 0.30000 2699.9n 0.30000 2700.0n 0.70000 2879.9n 0.70000 2880.0n 0.30000 3059.9n 0.30000 3060.0n 0.70000 3239.9n 0.70000 3240.0n 0.30000 3419.9n 0.30000 3420.0n 0.70000 3599.9n 0.70000 3600.0n 0.70000 3779.9n 0.70000 3780.0n 0.30000 3959.9n 0.30000 3960.0n 0.70000 4139.9n 0.70000 4140.0n 0.30000 4319.9n 0.30000 4320.0n 0.70000 4499.9n 0.70000 4500.0n 0.30000 4679.9n 0.30000 4680.0n 0.30000 4859.9n 0.30000 4860.0n 0.70000 5039.9n 0.70000 5040.0n 0.30000 5219.9n 0.30000 5220.0n 0.70000 5399.9n 0.70000 5400.0n 0.30000 5579.9n 0.30000 5580.0n 0.70000 5759.9n 0.70000 5760.0n 0.70000 5939.9n 0.70000 5940.0n 0.70000 6119.9n 0.70000 6120.0n 0.70000 6299.9n 0.70000 6300.0n 0.30000 6479.9n 0.30000 6480.0n 0.30000 6659.9n 0.30000 6660.0n 0.70000 6839.9n 0.70000 6840.0n 0.70000 7019.9n 0.70000 7020.0n 0.70000 7199.9n 0.70000 7200.0n 0.30000 7379.9n 0.30000 7380.0n 0.70000 7559.9n 0.70000 7560.0n 0.30000 7739.9n 0.30000 7740.0n 0.30000 7919.9n 0.30000 7920.0n 0.30000 8099.9n 0.30000 8100.0n 0.30000 8279.9n 0.30000 8280.0n 0.70000 8459.9n 0.70000 8460.0n 0.30000 8639.9n 0.30000 8640.0n 0.70000 8819.9n 0.70000 8820.0n 0.70000 8999.9n 0.70000 9000.0n 0.30000 9179.9n 0.30000 9180.0n 0.30000 9359.9n 0.30000 9360.0n 0.70000 9539.9n 0.70000 9540.0n 0.30000 9719.9n 0.30000 9720.0n 0.30000 9899.9n 0.30000 9900.0n 0.30000 10079.9n 0.30000 10080.0n 0.70000 10259.9n 0.70000 10260.0n 0.70000 10439.9n 0.70000 10440.0n 0.70000 10619.9n 0.70000 10620.0n 0.30000 10799.9n 0.30000 10800.0n 0.30000 10979.9n 0.30000 10980.0n 0.70000 11159.9n 0.70000 11160.0n 0.30000 11339.9n 0.30000 11340.0n 0.70000 11519.9n 0.70000 11520.0n 0.70000 11699.9n 0.70000 11700.0n 0.70000 11879.9n 0.70000 11880.0n 0.70000 12059.9n 0.70000 12060.0n 0.30000 12239.9n 0.30000 12240.0n 0.30000 12419.9n 0.30000 12420.0n 0.70000 12599.9n 0.70000 12600.0n 0.70000 12779.9n 0.70000 12780.0n 0.30000 12959.9n 0.30000 12960.0n 0.30000 13139.9n 0.30000 13140.0n 0.30000 13319.9n 0.30000 13320.0n 0.70000 13499.9n 0.70000 13500.0n 0.70000 13679.9n 0.70000 13680.0n 0.70000 13859.9n 0.70000 13860.0n 0.30000 14039.9n 0.30000 14040.0n 0.70000 14219.9n 0.70000 14220.0n 0.30000 14399.9n 0.30000 14400.0n 0.70000 14579.9n 0.70000 14580.0n 0.30000 14759.9n 0.30000 14760.0n 0.30000 14939.9n 0.30000 14940.0n 0.30000 15119.9n 0.30000 15120.0n 0.30000 15299.9n 0.30000 15300.0n 0.70000 15479.9n 0.70000 15480.0n 0.70000 15659.9n 0.70000 15660.0n 0.70000 15839.9n 0.70000 15840.0n 0.30000 16019.9n 0.30000 16020.0n 0.30000 16199.9n 0.30000 16200.0n 0.70000 16379.9n 0.70000 16380.0n 0.30000 16559.9n 0.30000 16560.0n 0.30000 16739.9n 0.30000 16740.0n 0.70000 16919.9n 0.70000 16920.0n 0.70000 17099.9n 0.70000 17100.0n 0.30000 17279.9n 0.30000 17280.0n 0.70000 17459.9n 0.70000 17460.0n 0.30000 17639.9n 0.30000 17640.0n 0.30000 17819.9n 0.30000 17820.0n 0.30000 17999.9n 0.30000 18000.0n 0.70000 18179.9n 0.70000 18180.0n 0.70000 18359.9n 0.70000 18360.0n 0.30000 18539.9n 0.30000 18540.0n 0.70000 18719.9n 0.70000 18720.0n 0.70000 18899.9n 0.70000 18900.0n 0.30000 19079.9n 0.30000 19080.0n 0.70000 19259.9n 0.70000 19260.0n 0.30000 19439.9n 0.30000 19440.0n 0.30000 19619.9n 0.30000 19620.0n 0.30000 19799.9n 0.30000 19800.0n 0.30000 19979.9n 0.30000 19980.0n 0.70000 20159.9n 0.70000 20160.0n 0.30000 20339.9n 0.30000 20340.0n 0.30000 20519.9n 0.30000 20520.0n 0.70000 20699.9n 0.70000 20700.0n 0.70000 20879.9n 0.70000 20880.0n 0.70000 21059.9n 0.70000 21060.0n 0.30000 21239.9n 0.30000 21240.0n 0.30000 21419.9n 0.30000 21420.0n 0.70000 21599.9n 0.70000 21600.0n 0.70000 21779.9n 0.70000 21780.0n 0.30000 21959.9n 0.30000 21960.0n 0.70000 22139.9n 0.70000 22140.0n 0.30000 22319.9n 0.30000 22320.0n 0.30000 22499.9n 0.30000 22500.0n 0.70000 22679.9n 0.70000 22680.0n 0.70000 22859.9n 0.70000 22860.0n 0.70000 23039.9n 0.70000 23040.0n 0.70000 23219.9n 0.70000 23220.0n 0.30000 23399.9n 0.30000 23400.0n 0.30000 23579.9n 0.30000 23580.0n 0.70000 23759.9n 0.70000 23760.0n 0.30000 23939.9n 0.30000 23940.0n 0.70000 24119.9n 0.70000 24120.0n 0.70000 24299.9n 0.70000 24300.0n 0.30000 24479.9n 0.30000 24480.0n 0.30000 24659.9n 0.30000 24660.0n 0.30000 24839.9n 0.30000 24840.0n 0.30000 25019.9n 0.30000 25020.0n 0.30000 25199.9n 0.30000 25200.0n 0.30000 25379.9n 0.30000 25380.0n 0.70000 25559.9n 0.70000 25560.0n 0.70000 25739.9n 0.70000 25740.0n 0.30000 25919.9n 0.30000 25920.0n 0.70000 26099.9n 0.70000 26100.0n 0.30000 26279.9n 0.30000 26280.0n 0.30000 26459.9n 0.30000 26460.0n 0.70000 26639.9n 0.70000 26640.0n 0.70000 26819.9n 0.70000 26820.0n 0.30000 26999.9n 0.30000 27000.0n 0.30000 27179.9n 0.30000 27180.0n 0.70000 27359.9n 0.70000 27360.0n 0.70000 27539.9n 0.70000 27540.0n 0.70000 27719.9n 0.70000 27720.0n 0.70000 27899.9n 0.70000 27900.0n 0.70000 28079.9n 0.70000 28080.0n 0.30000 28259.9n 0.30000 28260.0n 0.70000 28439.9n 0.70000 28440.0n 0.30000 28619.9n 0.30000 28620.0n 0.70000 28799.9n 0.70000 28800.0n 0.30000 28979.9n 0.30000 28980.0n 0.30000 29159.9n 0.30000 29160.0n 0.30000 29339.9n 0.30000 29340.0n 0.70000 29519.9n 0.70000 29520.0n 0.30000 29699.9n 0.30000 29700.0n 0.30000 29879.9n 0.30000 29880.0n 0.30000 30059.9n 0.30000 30060.0n 0.70000 30239.9n 0.70000 30240.0n 0.30000 30419.9n 0.30000 30420.0n 0.30000 30599.9n 0.30000 30600.0n 0.30000 30779.9n 0.30000 30780.0n 0.30000 30959.9n 0.30000 30960.0n 0.70000 31139.9n 0.70000 31140.0n 0.70000 31319.9n 0.70000 31320.0n 0.70000 31499.9n 0.70000 31500.0n 0.30000 31679.9n 0.30000 31680.0n 0.30000 31859.9n 0.30000 31860.0n 0.30000 32039.9n 0.30000 32040.0n 0.70000 32219.9n 0.70000 32220.0n 0.70000 32399.9n 0.70000 32400.0n 0.70000 32579.9n 0.70000 32580.0n 0.30000 32759.9n 0.30000 32760.0n 0.30000 32939.9n 0.30000 32940.0n 0.30000 33119.9n 0.30000 33120.0n 0.70000 33299.9n 0.70000 33300.0n 0.70000 33479.9n 0.70000 33480.0n 0.70000 33659.9n 0.70000 33660.0n 0.70000 33839.9n 0.70000 33840.0n 0.70000 34019.9n 0.70000 34020.0n 0.70000 34199.9n 0.70000 34200.0n 0.70000 34379.9n 0.70000 34380.0n 0.70000 34559.9n 0.70000 34560.0n 0.70000 34739.9n 0.70000 34740.0n 0.30000 34919.9n 0.30000 34920.0n 0.30000 35099.9n 0.30000 35100.0n 0.30000 35279.9n 0.30000 35280.0n 0.70000 35459.9n 0.70000 35460.0n 0.30000 35639.9n 0.30000 35640.0n 0.70000 35819.9n 0.70000 35820.0n 0.70000 35999.9n 0.70000 36000.0n 0.70000 36179.9n 0.70000 36180.0n 0.30000 36359.9n 0.30000 36360.0n 0.30000 36539.9n 0.30000 36540.0n 0.30000 36719.9n 0.30000 36720.0n 0.70000 36899.9n 0.70000 36900.0n 0.70000 37079.9n 0.70000 37080.0n 0.30000 37259.9n 0.30000 37260.0n 0.70000 37439.9n 0.70000 37440.0n 0.30000 37619.9n 0.30000 37620.0n 0.70000 37799.9n 0.70000 37800.0n 0.70000 37979.9n 0.70000 37980.0n 0.30000 38159.9n 0.30000 38160.0n 0.30000 38339.9n 0.30000 38340.0n 0.30000 38519.9n 0.30000 38520.0n 0.30000 38699.9n 0.30000 38700.0n 0.30000 38879.9n 0.30000 38880.0n 0.30000 39059.9n 0.30000 39060.0n 0.70000 39239.9n 0.70000 39240.0n 0.70000 39419.9n 0.70000 39420.0n 0.70000 39599.9n 0.70000 39600.0n 0.70000 39779.9n 0.70000 39780.0n 0.30000 39959.9n 0.30000 39960.0n 0.70000 40139.9n 0.70000 40140.0n 0.70000 40319.9n 0.70000 40320.0n 0.30000 40499.9n 0.30000 40500.0n 0.30000 40679.9n 0.30000 40680.0n 0.70000 40859.9n 0.70000 40860.0n 0.70000 41039.9n 0.70000 41040.0n 0.70000 41219.9n 0.70000 41220.0n 0.70000 41399.9n 0.70000 41400.0n 0.30000 41579.9n 0.30000 41580.0n 0.30000 41759.9n 0.30000 41760.0n 0.30000 41939.9n 0.30000 41940.0n 0.30000 42119.9n 0.30000 42120.0n 0.30000 42299.9n 0.30000 42300.0n 0.30000 42479.9n 0.30000 42480.0n 0.30000 42659.9n 0.30000 42660.0n 0.30000 42839.9n 0.30000 42840.0n 0.70000 43019.9n 0.70000 43020.0n 0.30000 43199.9n 0.30000 43200.0n 0.70000 43379.9n 0.70000 43380.0n 0.70000 43559.9n 0.70000 43560.0n 0.70000 43739.9n 0.70000 43740.0n 0.70000 43919.9n 0.70000 43920.0n 0.30000 44099.9n 0.30000 44100.0n 0.30000 44279.9n 0.30000 44280.0n 0.70000 44459.9n 0.70000 44460.0n 0.30000 44639.9n 0.30000 44640.0n 0.70000 44819.9n 0.70000 44820.0n 0.30000 44999.9n 0.30000 45000.0n 0.70000 45179.9n 0.70000 45180.0n 0.30000 45359.9n 0.30000 45360.0n 0.70000 45539.9n 0.70000 45540.0n 0.70000 45719.9n 0.70000 45720.0n 0.70000 45899.9n 0.70000 45900.0n 0.70000 46079.9n 0.70000 46080.0n 0.30000 46259.9n 0.30000 46260.0n 0.30000 46439.9n 0.30000 46440.0n 0.70000 46619.9n 0.70000 46620.0n 0.70000 46799.9n 0.70000 46800.0n 0.70000 46979.9n 0.70000 46980.0n 0.30000 47159.9n 0.30000 47160.0n 0.30000 47339.9n 0.30000 47340.0n 0.70000 47519.9n 0.70000 47520.0n 0.70000 47699.9n 0.70000 47700.0n 0.70000 47879.9n 0.70000 47880.0n 0.30000 48059.9n 0.30000 48060.0n 0.70000 48239.9n 0.70000 48240.0n 0.30000 48419.9n 0.30000 48420.0n 0.30000 48599.9n 0.30000 48600.0n 0.30000 48779.9n 0.30000 48780.0n 0.30000 48959.9n 0.30000 48960.0n 0.70000 49139.9n 0.70000 49140.0n 0.30000 49319.9n 0.30000 49320.0n 0.30000 49499.9n 0.30000 49500.0n 0.70000 49679.9n 0.70000 49680.0n 0.30000 49859.9n 0.30000 49860.0n 0.70000 50039.9n 0.70000 50040.0n 0.70000 50219.9n 0.70000 50220.0n 0.70000 50399.9n 0.70000 50400.0n 0.30000 50579.9n 0.30000 50580.0n 0.70000 50759.9n 0.70000 50760.0n 0.30000 50939.9n 0.30000 50940.0n 0.30000 51119.9n 0.30000 51120.0n 0.70000 51299.9n 0.70000 51300.0n 0.30000 51479.9n 0.30000 51480.0n 0.70000 51659.9n 0.70000 51660.0n 0.70000 51839.9n 0.70000 51840.0n 0.30000 52019.9n 0.30000 52020.0n 0.30000 52199.9n 0.30000 52200.0n 0.30000 52379.9n 0.30000 52380.0n 0.70000 52559.9n 0.70000 52560.0n 0.30000 52739.9n 0.30000 52740.0n 0.70000 52919.9n 0.70000 52920.0n 0.70000 53099.9n 0.70000 53100.0n 0.30000 53279.9n 0.30000 53280.0n 0.30000 53459.9n 0.30000 53460.0n 0.30000 53639.9n 0.30000 53640.0n 0.30000 53819.9n 0.30000 53820.0n 0.70000 53999.9n 0.70000 54000.0n 0.70000 54179.9n 0.70000 54180.0n 0.70000 54359.9n 0.70000 54360.0n 0.70000 54539.9n 0.70000 54540.0n 0.30000 54719.9n 0.30000 54720.0n 0.70000 54899.9n 0.70000 54900.0n 0.70000 55079.9n 0.70000 55080.0n 0.70000 55259.9n 0.70000 55260.0n 0.70000 55439.9n 0.70000 55440.0n 0.30000 55619.9n 0.30000 55620.0n 0.30000 55799.9n 0.30000 55800.0n 0.30000 55979.9n 0.30000 55980.0n 0.30000 56159.9n 0.30000 56160.0n 0.30000 56339.9n 0.30000 56340.0n 0.70000 56519.9n 0.70000 56520.0n 0.70000 56699.9n 0.70000 56700.0n 0.70000 56879.9n 0.70000 56880.0n 0.70000 57059.9n 0.70000 57060.0n 0.30000 57239.9n 0.30000 57240.0n 0.70000 57419.9n 0.70000 57420.0n 0.30000 57599.9n 0.30000 57600.0n 0.70000 57779.9n 0.70000 57780.0n 0.70000 57959.9n 0.70000 57960.0n 0.30000 58139.9n 0.30000 58140.0n 0.30000 58319.9n 0.30000 58320.0n 0.70000 58499.9n 0.70000 58500.0n 0.30000 58679.9n 0.30000 58680.0n 0.30000 58859.9n 0.30000 58860.0n 0.70000 59039.9n 0.70000 59040.0n 0.70000 59219.9n 0.70000 59220.0n 0.70000 59399.9n 0.70000 59400.0n 0.70000 59579.9n 0.70000 59580.0n 0.70000 59759.9n 0.70000 59760.0n 0.70000 59939.9n 0.70000 59940.0n 0.30000 60119.9n 0.30000 60120.0n 0.70000 60299.9n 0.70000 60300.0n 0.30000 60479.9n 0.30000 60480.0n 0.30000 60659.9n 0.30000 60660.0n 0.30000 60839.9n 0.30000 60840.0n 0.30000 61019.9n 0.30000 61020.0n 0.30000 61199.9n 0.30000 61200.0n 0.30000 61379.9n 0.30000 61380.0n 0.30000 61559.9n 0.30000 61560.0n 0.70000 61739.9n 0.70000 61740.0n 0.70000 61919.9n 0.70000 61920.0n 0.70000 62099.9n 0.70000 62100.0n 0.70000 62279.9n 0.70000 62280.0n 0.30000 62459.9n 0.30000 62460.0n 0.30000 62639.9n 0.30000 62640.0n 0.30000 62819.9n 0.30000 62820.0n 0.70000 62999.9n 0.70000 63000.0n 0.70000 63179.9n 0.70000 63180.0n 0.30000 63359.9n 0.30000 63360.0n 0.30000 63539.9n 0.30000 63540.0n 0.30000 63719.9n 0.30000 63720.0n 0.70000 63899.9n 0.70000 63900.0n 0.30000 64079.9n 0.30000 64080.0n 0.30000 64259.9n 0.30000 64260.0n 0.70000 64439.9n 0.70000 64440.0n 0.30000 64619.9n 0.30000 64620.0n 0.70000 64799.9n 0.70000 64800.0n 0.30000 64979.9n 0.30000 64980.0n 0.70000 65159.9n 0.70000 65160.0n 0.70000 65339.9n 0.70000 65340.0n 0.70000 65519.9n 0.70000 65520.0n 0.70000 65699.9n 0.70000 65700.0n 0.30000 65879.9n 0.30000 65880.0n 0.70000 66059.9n 0.70000 66060.0n 0.70000 66239.9n 0.70000 66240.0n 0.30000 66419.9n 0.30000 66420.0n 0.30000 66599.9n 0.30000 66600.0n 0.30000 66779.9n 0.30000 66780.0n 0.30000 66959.9n 0.30000 66960.0n 0.70000 67139.9n 0.70000 67140.0n 0.70000 67319.9n 0.70000 67320.0n 0.70000 67499.9n 0.70000 67500.0n 0.30000 67679.9n 0.30000 67680.0n 0.30000 67859.9n 0.30000 67860.0n 0.70000 68039.9n 0.70000 68040.0n 0.30000 68219.9n 0.30000 68220.0n 0.70000 68399.9n 0.70000 68400.0n 0.30000 68579.9n 0.30000 68580.0n 0.70000 68759.9n 0.70000 68760.0n 0.70000 68939.9n 0.70000 68940.0n 0.30000 69119.9n 0.30000 69120.0n 0.70000 69299.9n 0.70000 69300.0n 0.30000 69479.9n 0.30000 69480.0n 0.30000 69659.9n 0.30000 69660.0n 0.30000 69839.9n 0.30000 69840.0n 0.30000 70019.9n 0.30000 70020.0n 0.70000 70199.9n 0.70000 70200.0n 0.70000 70379.9n 0.70000 70380.0n 0.70000 70559.9n 0.70000 70560.0n 0.70000 70739.9n 0.70000 70740.0n 0.70000 70919.9n 0.70000 70920.0n 0.30000 71099.9n 0.30000 71100.0n 0.30000 71279.9n 0.30000 71280.0n 0.30000 71459.9n 0.30000 71460.0n 0.30000 71639.9n 0.30000 71640.0n 0.70000 71819.9n 0.70000 71820.0n 0.70000 71999.9n 0.70000 72000.0n 0.70000 72179.9n 0.70000 72180.0n 0.30000 72359.9n 0.30000 72360.0n 0.30000 72539.9n 0.30000 72540.0n 0.70000 72719.9n 0.70000 72720.0n 0.70000 72899.9n 0.70000 72900.0n 0.30000 73079.9n 0.30000 73080.0n 0.30000 73259.9n 0.30000 73260.0n 0.70000 73439.9n 0.70000 73440.0n 0.70000 73619.9n 0.70000 73620.0n 0.30000 73799.9n 0.30000 73800.0n 0.30000 73979.9n 0.30000 73980.0n 0.70000 74159.9n 0.70000 74160.0n 0.70000 74339.9n 0.70000 74340.0n 0.30000 74519.9n 0.30000 74520.0n 0.30000 74699.9n 0.30000 74700.0n 0.70000 74879.9n 0.70000 74880.0n 0.70000 75059.9n 0.70000 75060.0n 0.30000 75239.9n 0.30000 75240.0n 0.30000 75419.9n 0.30000 75420.0n 0.30000 75599.9n 0.30000 75600.0n 0.30000 75779.9n 0.30000 75780.0n 0.30000 75959.9n 0.30000 75960.0n 0.30000 76139.9n 0.30000 76140.0n 0.30000 76319.9n 0.30000 76320.0n 0.70000 76499.9n 0.70000 76500.0n 0.70000 76679.9n 0.70000 76680.0n 0.30000 76859.9n 0.30000 76860.0n 0.30000 77039.9n 0.30000 77040.0n 0.30000 77219.9n 0.30000 77220.0n 0.70000 77399.9n 0.70000 77400.0n 0.70000 77579.9n 0.70000 77580.0n 0.30000 77759.9n 0.30000 77760.0n 0.70000 77939.9n 0.70000 77940.0n 0.70000 78119.9n 0.70000 78120.0n 0.70000 78299.9n 0.70000 78300.0n 0.30000 78479.9n 0.30000 78480.0n 0.70000 78659.9n 0.70000 78660.0n 0.70000 78839.9n 0.70000 78840.0n 0.70000 79019.9n 0.70000 79020.0n 0.30000 79199.9n 0.30000 79200.0n 0.70000 79379.9n 0.70000 79380.0n 0.70000 79559.9n 0.70000 79560.0n 0.30000 79739.9n 0.30000 79740.0n 0.30000 79919.9n 0.30000 79920.0n 0.70000 80099.9n 0.70000 80100.0n 0.70000 80279.9n 0.70000 80280.0n 0.70000 80459.9n 0.70000 80460.0n 0.30000 80639.9n 0.30000 80640.0n 0.70000 80819.9n 0.70000 80820.0n 0.70000 80999.9n 0.70000 81000.0n 0.70000 81179.9n 0.70000 81180.0n 0.30000 81359.9n 0.30000 81360.0n 0.30000 81539.9n 0.30000 81540.0n 0.30000 81719.9n 0.30000 81720.0n 0.70000 81899.9n 0.70000 81900.0n 0.70000 82079.9n 0.70000 82080.0n 0.30000 82259.9n 0.30000 82260.0n 0.30000 82439.9n 0.30000 82440.0n 0.30000 82619.9n 0.30000 82620.0n 0.30000 82799.9n 0.30000 82800.0n 0.30000 82979.9n 0.30000 82980.0n 0.70000 83159.9n 0.70000 83160.0n 0.70000 83339.9n 0.70000 83340.0n 0.70000 83519.9n 0.70000 83520.0n 0.30000 83699.9n 0.30000 83700.0n 0.30000 83879.9n 0.30000 83880.0n 0.70000 84059.9n 0.70000 84060.0n 0.70000 84239.9n 0.70000 84240.0n 0.30000 84419.9n 0.30000 84420.0n 0.70000 84599.9n 0.70000 84600.0n 0.70000 84779.9n 0.70000 84780.0n 0.30000 84959.9n 0.30000 84960.0n 0.30000 85139.9n 0.30000 85140.0n 0.30000 85319.9n 0.30000 85320.0n 0.30000 85499.9n 0.30000 85500.0n 0.70000 85679.9n 0.70000 85680.0n 0.70000 85859.9n 0.70000 85860.0n 0.70000 86039.9n 0.70000 86040.0n 0.30000 86219.9n 0.30000 86220.0n 0.70000 86399.9n 0.70000 86400.0n 0.70000 86579.9n 0.70000 86580.0n 0.70000 86759.9n 0.70000 86760.0n 0.70000 86939.9n 0.70000 86940.0n 0.30000 87119.9n 0.30000 87120.0n 0.70000 87299.9n 0.70000 87300.0n 0.70000 87479.9n 0.70000 87480.0n 0.70000 87659.9n 0.70000 87660.0n 0.70000 87839.9n 0.70000 87840.0n 0.30000 88019.9n 0.30000 88020.0n 0.70000 88199.9n 0.70000 88200.0n 0.30000 88379.9n 0.30000 88380.0n 0.30000 88559.9n 0.30000 88560.0n 0.30000 88739.9n 0.30000 88740.0n 0.30000 88919.9n 0.30000 88920.0n 0.70000 89099.9n 0.70000 89100.0n 0.30000 89279.9n 0.30000 89280.0n 0.30000 89459.9n 0.30000 89460.0n 0.70000 89639.9n 0.70000 89640.0n 0.70000 89819.9n 0.70000 89820.0n 0.30000 89999.9n 0.30000 90000.0n 0.30000 90179.9n 0.30000 90180.0n 0.30000 90359.9n 0.30000 90360.0n 0.30000 90539.9n 0.30000 90540.0n 0.70000 90719.9n 0.70000 90720.0n 0.30000 90899.9n 0.30000 90900.0n 0.30000 91079.9n 0.30000 91080.0n 0.70000 91259.9n 0.70000 91260.0n 0.70000 91439.9n 0.70000 91440.0n 0.70000 91619.9n 0.70000 91620.0n 0.30000 91799.9n 0.30000 91800.0n 0.70000 91979.9n 0.70000 91980.0n 0.30000 92159.9n 0.30000 92160.0n 0.70000 92339.9n 0.70000 92340.0n 0.30000 92519.9n 0.30000 92520.0n 0.30000 92699.9n 0.30000 92700.0n 0.30000 92879.9n 0.30000 92880.0n 0.70000 93059.9n 0.70000 93060.0n 0.70000 93239.9n 0.70000 93240.0n 0.70000 93419.9n 0.70000 93420.0n 0.30000 93599.9n 0.30000 93600.0n 0.30000 93779.9n 0.30000 93780.0n 0.70000 93959.9n 0.70000 93960.0n 0.70000 94139.9n 0.70000 94140.0n 0.30000 94319.9n 0.30000 94320.0n 0.70000 94499.9n 0.70000 94500.0n 0.30000 94679.9n 0.30000 94680.0n 0.30000 94859.9n 0.30000 94860.0n 0.30000 95039.9n 0.30000 95040.0n 0.30000 95219.9n 0.30000 95220.0n 0.30000 95399.9n 0.30000 95400.0n 0.30000 95579.9n 0.30000 95580.0n 0.70000 95759.9n 0.70000 95760.0n 0.70000 95939.9n 0.70000 95940.0n 0.70000 96119.9n 0.70000 96120.0n 0.30000 96299.9n 0.30000 96300.0n 0.30000 96479.9n 0.30000 96480.0n 0.30000 96659.9n 0.30000 96660.0n 0.70000 96839.9n 0.70000 96840.0n 0.70000 97019.9n 0.70000 97020.0n 0.70000 97199.9n 0.70000 97200.0n 0.30000 97379.9n 0.30000 97380.0n 0.70000 97559.9n 0.70000 97560.0n 0.70000 97739.9n 0.70000 97740.0n 0.70000 97919.9n 0.70000 97920.0n 0.70000 98099.9n 0.70000 98100.0n 0.70000 98279.9n 0.70000 98280.0n 0.70000 98459.9n 0.70000 98460.0n 0.70000 98639.9n 0.70000 98640.0n 0.70000 98819.9n 0.70000 98820.0n 0.70000 98999.9n 0.70000 99000.0n 0.70000 99179.9n 0.70000 99180.0n 0.70000 99359.9n 0.70000 99360.0n 0.70000 99539.9n 0.70000 99540.0n 0.30000 99719.9n 0.30000 99720.0n 0.30000 99899.9n 0.30000 99900.0n 0.70000 100079.9n 0.70000 100080.0n 0.30000 100259.9n 0.30000 100260.0n 0.30000 100439.9n 0.30000 100440.0n 0.70000 100619.9n 0.70000 100620.0n 0.70000 100799.9n 0.70000 100800.0n 0.30000 100979.9n 0.30000 100980.0n 0.30000 101159.9n 0.30000 101160.0n 0.30000 101339.9n 0.30000 101340.0n 0.70000 101519.9n 0.70000 101520.0n 0.70000 101699.9n 0.70000 101700.0n 0.30000 101879.9n 0.30000 101880.0n 0.30000 102059.9n 0.30000 102060.0n 0.30000 102239.9n 0.30000 102240.0n 0.70000 102419.9n 0.70000 102420.0n 0.30000 102599.9n 0.30000 102600.0n 0.30000 102779.9n 0.30000 102780.0n 0.30000 102959.9n 0.30000 102960.0n 0.70000 103139.9n 0.70000 103140.0n 0.30000 103319.9n 0.30000 103320.0n 0.30000 103499.9n 0.30000 103500.0n 0.30000 103679.9n 0.30000 103680.0n 0.70000 103859.9n 0.70000 103860.0n 0.70000 104039.9n 0.70000 104040.0n 0.70000 104219.9n 0.70000 104220.0n 0.70000 104399.9n 0.70000 104400.0n 0.30000 104579.9n 0.30000 104580.0n 0.30000 104759.9n 0.30000 104760.0n 0.30000 104939.9n 0.30000 104940.0n 0.30000 105119.9n 0.30000 105120.0n 0.70000 105299.9n 0.70000 105300.0n 0.70000 105479.9n 0.70000 105480.0n 0.30000 105659.9n 0.30000 105660.0n 0.70000 105839.9n 0.70000 105840.0n 0.30000 106019.9n 0.30000 106020.0n 0.70000 106199.9n 0.70000 106200.0n 0.30000 106379.9n 0.30000 106380.0n 0.70000 106559.9n 0.70000 106560.0n 0.70000 106739.9n 0.70000 106740.0n 0.30000 106919.9n 0.30000 106920.0n 0.30000 107099.9n 0.30000 107100.0n 0.70000 107279.9n 0.70000 107280.0n 0.30000 107459.9n 0.30000 107460.0n 0.30000 107639.9n 0.30000 107640.0n 0.30000 107819.9n 0.30000 107820.0n 0.70000 107999.9n 0.70000 108000.0n 0.70000 108179.9n 0.70000 108180.0n 0.70000 108359.9n 0.70000 108360.0n 0.30000 108539.9n 0.30000 108540.0n 0.70000 108719.9n 0.70000 108720.0n 0.30000 108899.9n 0.30000 108900.0n 0.30000 109079.9n 0.30000 109080.0n 0.30000 109259.9n 0.30000 109260.0n 0.70000 109439.9n 0.70000 109440.0n 0.70000 109619.9n 0.70000 109620.0n 0.70000 109799.9n 0.70000 109800.0n 0.30000 109979.9n 0.30000 109980.0n 0.70000 110159.9n 0.70000 110160.0n 0.70000 110339.9n 0.70000 110340.0n 0.70000 110519.9n 0.70000 110520.0n 0.30000 110699.9n 0.30000 110700.0n 0.70000 110879.9n 0.70000 110880.0n 0.70000 111059.9n 0.70000 111060.0n 0.30000 111239.9n 0.30000 111240.0n 0.30000 111419.9n 0.30000 111420.0n 0.70000 111599.9n 0.70000 111600.0n 0.30000 111779.9n 0.30000 111780.0n 0.30000 111959.9n 0.30000 111960.0n 0.30000 112139.9n 0.30000 112140.0n 0.30000 112319.9n 0.30000 112320.0n 0.30000 112499.9n 0.30000 112500.0n 0.30000 112679.9n 0.30000 112680.0n 0.70000 112859.9n 0.70000 112860.0n 0.70000 113039.9n 0.70000 113040.0n 0.30000 113219.9n 0.30000 113220.0n 0.70000 113399.9n 0.70000 113400.0n 0.30000 113579.9n 0.30000 113580.0n 0.30000 113759.9n 0.30000 113760.0n 0.70000 113939.9n 0.70000 113940.0n 0.70000 114119.9n 0.70000 114120.0n 0.70000 114299.9n 0.70000 114300.0n 0.30000 114479.9n 0.30000 114480.0n 0.70000 114659.9n 0.70000 114660.0n 0.30000 114839.9n 0.30000 114840.0n 0.30000 115019.9n 0.30000 115020.0n 0.70000 115199.9n 0.70000 115200.0n 0.70000 115379.9n 0.70000 115380.0n 0.70000 115559.9n 0.70000 115560.0n 0.30000 115739.9n 0.30000 115740.0n 0.30000 115919.9n 0.30000 115920.0n 0.70000 116099.9n 0.70000 116100.0n 0.30000 116279.9n 0.30000 116280.0n 0.70000 116459.9n 0.70000 116460.0n 0.70000 116639.9n 0.70000 116640.0n 0.30000 116819.9n 0.30000 116820.0n 0.30000 116999.9n 0.30000 117000.0n 0.70000 117179.9n 0.70000 117180.0n 0.70000 117359.9n 0.70000 117360.0n 0.30000 117539.9n 0.30000 117540.0n 0.70000 117719.9n 0.70000 117720.0n 0.30000 117899.9n 0.30000 117900.0n 0.70000 118079.9n 0.70000 118080.0n 0.70000 118259.9n 0.70000 118260.0n 0.30000 118439.9n 0.30000 118440.0n 0.70000 118619.9n 0.70000 118620.0n 0.70000 118799.9n 0.70000 118800.0n 0.30000 118979.9n 0.30000 118980.0n 0.30000 119159.9n 0.30000 119160.0n 0.30000 119339.9n 0.30000 119340.0n 0.30000 119519.9n 0.30000 119520.0n 0.30000 119699.9n 0.30000 119700.0n 0.30000 119879.9n 0.30000 119880.0n 0.70000 120059.9n 0.70000 120060.0n 0.70000 120239.9n 0.70000 120240.0n 0.30000 120419.9n 0.30000 120420.0n 0.30000 120599.9n 0.30000 120600.0n 0.70000 120779.9n 0.70000 120780.0n 0.70000 120959.9n 0.70000 120960.0n 0.70000 121139.9n 0.70000 121140.0n 0.70000 121319.9n 0.70000 121320.0n 0.30000 121499.9n 0.30000 121500.0n 0.70000 121679.9n 0.70000 121680.0n 0.70000 121859.9n 0.70000 121860.0n 0.30000 122039.9n 0.30000 122040.0n 0.30000 122219.9n 0.30000 122220.0n 0.30000 122399.9n 0.30000 122400.0n 0.70000 122579.9n 0.70000 122580.0n 0.30000 122759.9n 0.30000 122760.0n 0.30000 122939.9n 0.30000 122940.0n 0.70000 123119.9n 0.70000 123120.0n 0.30000 123299.9n 0.30000 123300.0n 0.70000 123479.9n 0.70000 123480.0n 0.70000 123659.9n 0.70000 123660.0n 0.70000 123839.9n 0.70000 123840.0n 0.30000 124019.9n 0.30000 124020.0n 0.30000 124199.9n 0.30000 124200.0n 0.70000 124379.9n 0.70000 124380.0n 0.30000 124559.9n 0.30000 124560.0n 0.30000 124739.9n 0.30000 124740.0n 0.30000 124919.9n 0.30000 124920.0n 0.70000 125099.9n 0.70000 125100.0n 0.70000 125279.9n 0.70000 125280.0n 0.70000 125459.9n 0.70000 125460.0n 0.70000 125639.9n 0.70000 125640.0n 0.30000 125819.9n 0.30000 125820.0n 0.30000 125999.9n 0.30000 126000.0n 0.70000 126179.9n 0.70000 126180.0n 0.30000 126359.9n 0.30000 126360.0n 0.70000 126539.9n 0.70000 126540.0n 0.30000 126719.9n 0.30000 126720.0n 0.70000 126899.9n 0.70000 126900.0n 0.70000 127079.9n 0.70000 127080.0n 0.70000 127259.9n 0.70000 127260.0n 0.70000 127439.9n 0.70000 127440.0n 0.70000 127619.9n 0.70000 127620.0n 0.30000 127799.9n 0.30000 127800.0n 0.70000 127979.9n 0.70000 127980.0n 0.70000 128159.9n 0.70000 128160.0n 0.30000 128339.9n 0.30000 128340.0n 0.30000 128519.9n 0.30000 128520.0n 0.30000 128699.9n 0.30000 128700.0n 0.30000 128879.9n 0.30000 128880.0n 0.70000 129059.9n 0.70000 129060.0n 0.30000 129239.9n 0.30000 129240.0n 0.30000 129419.9n 0.30000 129420.0n 0.30000 129599.9n 0.30000 129600.0n 0.70000 129779.9n 0.70000 129780.0n 0.30000 129959.9n 0.30000 129960.0n 0.30000 130139.9n 0.30000 130140.0n 0.30000 130319.9n 0.30000 130320.0n 0.30000 130499.9n 0.30000 130500.0n 0.70000 130679.9n 0.70000 130680.0n 0.70000 130859.9n 0.70000 130860.0n 0.70000 131039.9n 0.70000 131040.0n 0.30000 131219.9n 0.30000 131220.0n 0.30000 131399.9n 0.30000 131400.0n 0.70000 131579.9n 0.70000 131580.0n 0.30000 131759.9n 0.30000 131760.0n 0.70000 131939.9n 0.70000 131940.0n 0.70000 132119.9n 0.70000 132120.0n 0.30000 132299.9n 0.30000 132300.0n 0.70000 132479.9n 0.70000 132480.0n 0.70000 132659.9n 0.70000 132660.0n 0.70000 132839.9n 0.70000 132840.0n 0.30000 133019.9n 0.30000 133020.0n 0.30000 133199.9n 0.30000 133200.0n 0.70000 133379.9n 0.70000 133380.0n 0.70000 133559.9n 0.70000 133560.0n 0.70000 133739.9n 0.70000 133740.0n 0.70000 133919.9n 0.70000 133920.0n 0.70000 134099.9n 0.70000 134100.0n 0.70000 134279.9n 0.70000 134280.0n 0.30000 134459.9n 0.30000 134460.0n 0.30000 134639.9n 0.30000 134640.0n 0.70000 134819.9n 0.70000 134820.0n 0.70000 134999.9n 0.70000 135000.0n 0.30000 135179.9n 0.30000 135180.0n 0.30000 135359.9n 0.30000 135360.0n 0.30000 135539.9n 0.30000 135540.0n 0.30000 135719.9n 0.30000 135720.0n 0.70000 135899.9n 0.70000 135900.0n 0.30000 136079.9n 0.30000 136080.0n 0.70000 136259.9n 0.70000 136260.0n 0.30000 136439.9n 0.30000 136440.0n 0.70000 136619.9n 0.70000 136620.0n 0.30000 136799.9n 0.30000 136800.0n 0.30000 136979.9n 0.30000 136980.0n 0.30000 137159.9n 0.30000 137160.0n 0.30000 137339.9n 0.30000 137340.0n 0.30000 137519.9n 0.30000 137520.0n 0.70000 137699.9n 0.70000 137700.0n 0.30000 137879.9n 0.30000 137880.0n 0.70000 138059.9n 0.70000 138060.0n 0.70000 138239.9n 0.70000 138240.0n 0.30000 138419.9n 0.30000 138420.0n 0.30000 138599.9n 0.30000 138600.0n 0.30000 138779.9n 0.30000 138780.0n 0.30000 138959.9n 0.30000 138960.0n 0.30000 139139.9n 0.30000 139140.0n 0.70000 139319.9n 0.70000 139320.0n 0.70000 139499.9n 0.70000 139500.0n 0.30000 139679.9n 0.30000 139680.0n 0.30000 139859.9n 0.30000 139860.0n 0.70000 140039.9n 0.70000 140040.0n 0.70000 140219.9n 0.70000 140220.0n 0.70000 140399.9n 0.70000 140400.0n 0.30000 140579.9n 0.30000 140580.0n 0.30000 140759.9n 0.30000 140760.0n 0.70000 140939.9n 0.70000 140940.0n 0.30000 141119.9n 0.30000 141120.0n 0.70000 141299.9n 0.70000 141300.0n 0.30000 141479.9n 0.30000 141480.0n 0.30000 141659.9n 0.30000 141660.0n 0.70000 141839.9n 0.70000 141840.0n 0.70000 142019.9n 0.70000 142020.0n 0.30000 142199.9n 0.30000 142200.0n 0.30000 142379.9n 0.30000 142380.0n 0.30000 142559.9n 0.30000 142560.0n 0.70000 142739.9n 0.70000 142740.0n 0.70000 142919.9n 0.70000 142920.0n 0.70000 143099.9n 0.70000 143100.0n 0.70000 143279.9n 0.70000 143280.0n 0.30000 143459.9n 0.30000 143460.0n 0.70000 143639.9n 0.70000 143640.0n 0.70000 143819.9n 0.70000 143820.0n 0.70000 143999.9n 0.70000 144000.0n 0.70000 144179.9n 0.70000 144180.0n 0.30000 144359.9n 0.30000 144360.0n 0.30000 144539.9n 0.30000 144540.0n 0.70000 144719.9n 0.70000 144720.0n 0.70000 144899.9n 0.70000 144900.0n 0.30000 145079.9n 0.30000 145080.0n 0.30000 145259.9n 0.30000 145260.0n 0.30000 145439.9n 0.30000 145440.0n 0.30000 145619.9n 0.30000 145620.0n 0.30000 145799.9n 0.30000 145800.0n 0.30000 145979.9n 0.30000 145980.0n 0.70000 146159.9n 0.70000 146160.0n 0.70000 146339.9n 0.70000 146340.0n 0.70000 146519.9n 0.70000 146520.0n 0.30000 146699.9n 0.30000 146700.0n 0.70000 146879.9n 0.70000 146880.0n 0.30000 147059.9n 0.30000 147060.0n 0.30000 147239.9n 0.30000 147240.0n 0.70000 147419.9n 0.70000 147420.0n 0.30000 147599.9n 0.30000 147600.0n 0.30000 147779.9n 0.30000 147780.0n 0.30000 147959.9n 0.30000 147960.0n 0.70000 148139.9n 0.70000 148140.0n 0.30000 148319.9n 0.30000 148320.0n 0.70000 148499.9n 0.70000 148500.0n 0.70000 148679.9n 0.70000 148680.0n 0.70000 148859.9n 0.70000 148860.0n 0.70000 149039.9n 0.70000 149040.0n 0.70000 149219.9n 0.70000 149220.0n 0.30000 149399.9n 0.30000 149400.0n 0.70000 149579.9n 0.70000 149580.0n 0.70000 149759.9n 0.70000 149760.0n 0.70000 149939.9n 0.70000 149940.0n 0.70000 150119.9n 0.70000 150120.0n 0.30000 150299.9n 0.30000 150300.0n 0.30000 150479.9n 0.30000 150480.0n 0.70000 150659.9n 0.70000 150660.0n 0.70000 150839.9n 0.70000 150840.0n 0.30000 151019.9n 0.30000 151020.0n 0.30000 151199.9n 0.30000 151200.0n 0.30000 151379.9n 0.30000 151380.0n 0.30000 151559.9n 0.30000 151560.0n 0.30000 151739.9n 0.30000 151740.0n 0.70000 151919.9n 0.70000 151920.0n 0.30000 152099.9n 0.30000 152100.0n 0.70000 152279.9n 0.70000 152280.0n 0.70000 152459.9n 0.70000 152460.0n 0.30000 152639.9n 0.30000 152640.0n 0.30000 152819.9n 0.30000 152820.0n 0.30000 152999.9n 0.30000 153000.0n 0.70000 153179.9n 0.70000 153180.0n 0.30000 153359.9n 0.30000 153360.0n 0.30000 153539.9n 0.30000 153540.0n 0.70000 153719.9n 0.70000 153720.0n 0.70000 153899.9n 0.70000 153900.0n 0.70000 154079.9n 0.70000 154080.0n 0.70000 154259.9n 0.70000 154260.0n 0.30000 154439.9n 0.30000 154440.0n 0.70000 154619.9n 0.70000 154620.0n 0.30000 154799.9n 0.30000 154800.0n 0.70000 154979.9n 0.70000 154980.0n 0.70000 155159.9n 0.70000 155160.0n 0.70000 155339.9n 0.70000 155340.0n 0.30000 155519.9n 0.30000 155520.0n 0.70000 155699.9n 0.70000 155700.0n 0.30000 155879.9n 0.30000 155880.0n 0.70000 156059.9n 0.70000 156060.0n 0.30000 156239.9n 0.30000 156240.0n 0.70000 156419.9n 0.70000 156420.0n 0.30000 156599.9n 0.30000 156600.0n 0.30000 156779.9n 0.30000 156780.0n 0.30000 156959.9n 0.30000 156960.0n 0.30000 157139.9n 0.30000 157140.0n 0.30000 157319.9n 0.30000 157320.0n 0.70000 157499.9n 0.70000 157500.0n 0.70000 157679.9n 0.70000 157680.0n 0.70000 157859.9n 0.70000 157860.0n 0.70000 158039.9n 0.70000 158040.0n 0.30000 158219.9n 0.30000 158220.0n 0.70000 158399.9n 0.70000 158400.0n 0.30000 158579.9n 0.30000 158580.0n 0.30000 158759.9n 0.30000 158760.0n 0.30000 158939.9n 0.30000 158940.0n 0.30000 159119.9n 0.30000 159120.0n 0.70000 159299.9n 0.70000 159300.0n 0.70000 159479.9n 0.70000 159480.0n 0.30000 159659.9n 0.30000 159660.0n 0.30000 159839.9n 0.30000 159840.0n 0.70000 160019.9n 0.70000 160020.0n 0.70000 160199.9n 0.70000 160200.0n 0.70000 160379.9n 0.70000 160380.0n 0.70000 160559.9n 0.70000 160560.0n 0.70000 160739.9n 0.70000 160740.0n 0.30000 160919.9n 0.30000 160920.0n 0.70000 161099.9n 0.70000 161100.0n 0.30000 161279.9n 0.30000 161280.0n 0.70000 161459.9n 0.70000 161460.0n 0.70000 161639.9n 0.70000 161640.0n 0.30000 161819.9n 0.30000 161820.0n 0.70000 161999.9n 0.70000 162000.0n 0.30000 162179.9n 0.30000 162180.0n 0.70000 162359.9n 0.70000 162360.0n 0.30000 162539.9n 0.30000 162540.0n 0.30000 162719.9n 0.30000 162720.0n 0.70000 162899.9n 0.70000 162900.0n 0.70000 163079.9n 0.70000 163080.0n 0.30000 163259.9n 0.30000 163260.0n 0.70000 163439.9n 0.70000 163440.0n 0.30000 163619.9n 0.30000 163620.0n 0.70000 163799.9n 0.70000 163800.0n 0.30000 163979.9n 0.30000 163980.0n 0.30000 164159.9n 0.30000 164160.0n 0.70000 164339.9n 0.70000 164340.0n 0.30000 164519.9n 0.30000 164520.0n 0.30000 164699.9n 0.30000 164700.0n 0.70000 164879.9n 0.70000 164880.0n 0.30000 165059.9n 0.30000 165060.0n 0.30000 165239.9n 0.30000 165240.0n 0.70000 165419.9n 0.70000 165420.0n 0.30000 165599.9n 0.30000 165600.0n 0.70000 165779.9n 0.70000 165780.0n 0.70000 165959.9n 0.70000 165960.0n 0.30000 166139.9n 0.30000 166140.0n 0.70000 166319.9n 0.70000 166320.0n 0.70000 166499.9n 0.70000 166500.0n 0.30000 166679.9n 0.30000 166680.0n 0.70000 166859.9n 0.70000 166860.0n 0.30000 167039.9n 0.30000 167040.0n 0.30000 167219.9n 0.30000 167220.0n 0.30000 167399.9n 0.30000 167400.0n 0.70000 167579.9n 0.70000 167580.0n 0.70000 167759.9n 0.70000 167760.0n 0.70000 167939.9n 0.70000 167940.0n 0.30000 168119.9n 0.30000 168120.0n 0.70000 168299.9n 0.70000 168300.0n 0.70000 168479.9n 0.70000 168480.0n 0.30000 168659.9n 0.30000 168660.0n 0.70000 168839.9n 0.70000 168840.0n 0.70000 169019.9n 0.70000 169020.0n 0.30000 169199.9n 0.30000 169200.0n 0.30000 169379.9n 0.30000 169380.0n 0.70000 169559.9n 0.70000 169560.0n 0.30000 169739.9n 0.30000 169740.0n 0.70000 169919.9n 0.70000 169920.0n 0.70000 170099.9n 0.70000 170100.0n 0.70000 170279.9n 0.70000 170280.0n 0.70000 170459.9n 0.70000 170460.0n 0.30000 170639.9n 0.30000 170640.0n 0.30000 170819.9n 0.30000 170820.0n 0.30000 170999.9n 0.30000 171000.0n 0.70000 171179.9n 0.70000 171180.0n 0.30000 171359.9n 0.30000 171360.0n 0.70000 171539.9n 0.70000 171540.0n 0.30000 171719.9n 0.30000 171720.0n 0.30000 171899.9n 0.30000 171900.0n 0.70000 172079.9n 0.70000 172080.0n 0.70000 172259.9n 0.70000 172260.0n 0.30000 172439.9n 0.30000 172440.0n 0.30000 172619.9n 0.30000 172620.0n 0.30000 172799.9n 0.30000 172800.0n 0.50000 172979.9n 0.50000 172980.0n 0.50000 173159.9n 0.50000 173160.0n 0.50000 173339.9n 0.50000 173340.0n 0.50000 173519.9n 0.50000 173520.0n 0.50000 173699.9n 0.50000 173700.0n 0.50000 173879.9n 0.50000 173880.0n 0.50000 174059.9n 0.50000 174060.0n 0.50000 174239.9n 0.50000 174240.0n 0.50000 174419.9n 0.50000 174420.0n 0.50000 174599.9n 0.50000 174600.0n 0.50000 174779.9n 0.50000 174780.0n 0.50000 174959.9n 0.50000 174960.0n 0.50000 175139.9n 0.50000 175140.0n 0.50000 175319.9n 0.50000 175320.0n 0.50000 175499.9n 0.50000 175500.0n 0.50000 175679.9n 0.50000 175680.0n 0.50000 175859.9n 0.50000 175860.0n 0.50000 176039.9n 0.50000 176040.0n 0.50000 176219.9n 0.50000 176220.0n 0.50000 176399.9n 0.50000 176400.0n 0.50000 176579.9n 0.50000 176580.0n 0.50000 176759.9n 0.50000 176760.0n 0.50000 176939.9n 0.50000 176940.0n 0.50000 177119.9n 0.50000 177120.0n 0.50000 177299.9n 0.50000 177300.0n 0.50000 177479.9n 0.50000 177480.0n 0.50000 177659.9n 0.50000 177660.0n 0.50000 177839.9n 0.50000 177840.0n 0.50000 178019.9n 0.50000 178020.0n 0.50000 178199.9n 0.50000 178200.0n 0.50000 178379.9n 0.50000 178380.0n 0.50000 178559.9n 0.50000 178560.0n 0.50000 178739.9n 0.50000 178740.0n 0.50000 178919.9n 0.50000 178920.0n 0.50000 179099.9n 0.50000 179100.0n 0.50000 179279.9n 0.50000 179280.0n 0.50000 179459.9n 0.50000 179460.0n 0.50000 179639.9n 0.50000 179640.0n 0.50000 179819.9n 0.50000 179820.0n 0.50000 179999.9n 0.50000 180000.0n 0.50000 180179.9n 0.50000 180180.0n 0.50000 180359.9n 0.50000 180360.0n 0.50000 180539.9n 0.50000 180540.0n 0.50000 180719.9n 0.50000 180720.0n 0.50000 180899.9n 0.50000 180900.0n 0.50000 181079.9n 0.50000 181080.0n 0.50000 181259.9n 0.50000 181260.0n 0.50000 181439.9n 0.50000 181440.0n 0.50000 181619.9n 0.50000 181620.0n 0.50000 181799.9n 0.50000 181800.0n 0.50000 181979.9n 0.50000 181980.0n 0.50000 182159.9n 0.50000 182160.0n 0.50000 182339.9n 0.50000 182340.0n 0.50000 182519.9n 0.50000 182520.0n 0.50000 182699.9n 0.50000 182700.0n 0.50000 182879.9n 0.50000 182880.0n 0.50000 183059.9n 0.50000 183060.0n 0.50000 183239.9n 0.50000 183240.0n 0.50000 183419.9n 0.50000 183420.0n 0.50000)
Vxon1 xon1 0 PWL(0.0n 0.70000 179.9n 0.70000 180.0n 0.70000 359.9n 0.70000 360.0n 0.70000 539.9n 0.70000 540.0n 0.70000 719.9n 0.70000 720.0n 0.30000 899.9n 0.30000 900.0n 0.30000 1079.9n 0.30000 1080.0n 0.30000 1259.9n 0.30000 1260.0n 0.70000 1439.9n 0.70000 1440.0n 0.30000 1619.9n 0.30000 1620.0n 0.30000 1799.9n 0.30000 1800.0n 0.30000 1979.9n 0.30000 1980.0n 0.30000 2159.9n 0.30000 2160.0n 0.70000 2339.9n 0.70000 2340.0n 0.70000 2519.9n 0.70000 2520.0n 0.70000 2699.9n 0.70000 2700.0n 0.30000 2879.9n 0.30000 2880.0n 0.70000 3059.9n 0.70000 3060.0n 0.30000 3239.9n 0.30000 3240.0n 0.70000 3419.9n 0.70000 3420.0n 0.30000 3599.9n 0.30000 3600.0n 0.30000 3779.9n 0.30000 3780.0n 0.70000 3959.9n 0.70000 3960.0n 0.30000 4139.9n 0.30000 4140.0n 0.70000 4319.9n 0.70000 4320.0n 0.30000 4499.9n 0.30000 4500.0n 0.70000 4679.9n 0.70000 4680.0n 0.70000 4859.9n 0.70000 4860.0n 0.30000 5039.9n 0.30000 5040.0n 0.70000 5219.9n 0.70000 5220.0n 0.30000 5399.9n 0.30000 5400.0n 0.70000 5579.9n 0.70000 5580.0n 0.30000 5759.9n 0.30000 5760.0n 0.30000 5939.9n 0.30000 5940.0n 0.30000 6119.9n 0.30000 6120.0n 0.30000 6299.9n 0.30000 6300.0n 0.70000 6479.9n 0.70000 6480.0n 0.70000 6659.9n 0.70000 6660.0n 0.30000 6839.9n 0.30000 6840.0n 0.30000 7019.9n 0.30000 7020.0n 0.30000 7199.9n 0.30000 7200.0n 0.70000 7379.9n 0.70000 7380.0n 0.30000 7559.9n 0.30000 7560.0n 0.70000 7739.9n 0.70000 7740.0n 0.70000 7919.9n 0.70000 7920.0n 0.70000 8099.9n 0.70000 8100.0n 0.70000 8279.9n 0.70000 8280.0n 0.30000 8459.9n 0.30000 8460.0n 0.70000 8639.9n 0.70000 8640.0n 0.30000 8819.9n 0.30000 8820.0n 0.30000 8999.9n 0.30000 9000.0n 0.70000 9179.9n 0.70000 9180.0n 0.70000 9359.9n 0.70000 9360.0n 0.30000 9539.9n 0.30000 9540.0n 0.70000 9719.9n 0.70000 9720.0n 0.70000 9899.9n 0.70000 9900.0n 0.70000 10079.9n 0.70000 10080.0n 0.30000 10259.9n 0.30000 10260.0n 0.30000 10439.9n 0.30000 10440.0n 0.30000 10619.9n 0.30000 10620.0n 0.70000 10799.9n 0.70000 10800.0n 0.70000 10979.9n 0.70000 10980.0n 0.30000 11159.9n 0.30000 11160.0n 0.70000 11339.9n 0.70000 11340.0n 0.30000 11519.9n 0.30000 11520.0n 0.30000 11699.9n 0.30000 11700.0n 0.30000 11879.9n 0.30000 11880.0n 0.30000 12059.9n 0.30000 12060.0n 0.70000 12239.9n 0.70000 12240.0n 0.70000 12419.9n 0.70000 12420.0n 0.30000 12599.9n 0.30000 12600.0n 0.30000 12779.9n 0.30000 12780.0n 0.70000 12959.9n 0.70000 12960.0n 0.70000 13139.9n 0.70000 13140.0n 0.70000 13319.9n 0.70000 13320.0n 0.30000 13499.9n 0.30000 13500.0n 0.30000 13679.9n 0.30000 13680.0n 0.30000 13859.9n 0.30000 13860.0n 0.70000 14039.9n 0.70000 14040.0n 0.30000 14219.9n 0.30000 14220.0n 0.70000 14399.9n 0.70000 14400.0n 0.30000 14579.9n 0.30000 14580.0n 0.70000 14759.9n 0.70000 14760.0n 0.70000 14939.9n 0.70000 14940.0n 0.70000 15119.9n 0.70000 15120.0n 0.70000 15299.9n 0.70000 15300.0n 0.30000 15479.9n 0.30000 15480.0n 0.30000 15659.9n 0.30000 15660.0n 0.30000 15839.9n 0.30000 15840.0n 0.70000 16019.9n 0.70000 16020.0n 0.70000 16199.9n 0.70000 16200.0n 0.30000 16379.9n 0.30000 16380.0n 0.70000 16559.9n 0.70000 16560.0n 0.70000 16739.9n 0.70000 16740.0n 0.30000 16919.9n 0.30000 16920.0n 0.30000 17099.9n 0.30000 17100.0n 0.70000 17279.9n 0.70000 17280.0n 0.30000 17459.9n 0.30000 17460.0n 0.70000 17639.9n 0.70000 17640.0n 0.70000 17819.9n 0.70000 17820.0n 0.70000 17999.9n 0.70000 18000.0n 0.30000 18179.9n 0.30000 18180.0n 0.30000 18359.9n 0.30000 18360.0n 0.70000 18539.9n 0.70000 18540.0n 0.30000 18719.9n 0.30000 18720.0n 0.30000 18899.9n 0.30000 18900.0n 0.70000 19079.9n 0.70000 19080.0n 0.30000 19259.9n 0.30000 19260.0n 0.70000 19439.9n 0.70000 19440.0n 0.70000 19619.9n 0.70000 19620.0n 0.70000 19799.9n 0.70000 19800.0n 0.70000 19979.9n 0.70000 19980.0n 0.30000 20159.9n 0.30000 20160.0n 0.70000 20339.9n 0.70000 20340.0n 0.70000 20519.9n 0.70000 20520.0n 0.30000 20699.9n 0.30000 20700.0n 0.30000 20879.9n 0.30000 20880.0n 0.30000 21059.9n 0.30000 21060.0n 0.70000 21239.9n 0.70000 21240.0n 0.70000 21419.9n 0.70000 21420.0n 0.30000 21599.9n 0.30000 21600.0n 0.30000 21779.9n 0.30000 21780.0n 0.70000 21959.9n 0.70000 21960.0n 0.30000 22139.9n 0.30000 22140.0n 0.70000 22319.9n 0.70000 22320.0n 0.70000 22499.9n 0.70000 22500.0n 0.30000 22679.9n 0.30000 22680.0n 0.30000 22859.9n 0.30000 22860.0n 0.30000 23039.9n 0.30000 23040.0n 0.30000 23219.9n 0.30000 23220.0n 0.70000 23399.9n 0.70000 23400.0n 0.70000 23579.9n 0.70000 23580.0n 0.30000 23759.9n 0.30000 23760.0n 0.70000 23939.9n 0.70000 23940.0n 0.30000 24119.9n 0.30000 24120.0n 0.30000 24299.9n 0.30000 24300.0n 0.70000 24479.9n 0.70000 24480.0n 0.70000 24659.9n 0.70000 24660.0n 0.70000 24839.9n 0.70000 24840.0n 0.70000 25019.9n 0.70000 25020.0n 0.70000 25199.9n 0.70000 25200.0n 0.70000 25379.9n 0.70000 25380.0n 0.30000 25559.9n 0.30000 25560.0n 0.30000 25739.9n 0.30000 25740.0n 0.70000 25919.9n 0.70000 25920.0n 0.30000 26099.9n 0.30000 26100.0n 0.70000 26279.9n 0.70000 26280.0n 0.70000 26459.9n 0.70000 26460.0n 0.30000 26639.9n 0.30000 26640.0n 0.30000 26819.9n 0.30000 26820.0n 0.70000 26999.9n 0.70000 27000.0n 0.70000 27179.9n 0.70000 27180.0n 0.30000 27359.9n 0.30000 27360.0n 0.30000 27539.9n 0.30000 27540.0n 0.30000 27719.9n 0.30000 27720.0n 0.30000 27899.9n 0.30000 27900.0n 0.30000 28079.9n 0.30000 28080.0n 0.70000 28259.9n 0.70000 28260.0n 0.30000 28439.9n 0.30000 28440.0n 0.70000 28619.9n 0.70000 28620.0n 0.30000 28799.9n 0.30000 28800.0n 0.70000 28979.9n 0.70000 28980.0n 0.70000 29159.9n 0.70000 29160.0n 0.70000 29339.9n 0.70000 29340.0n 0.30000 29519.9n 0.30000 29520.0n 0.70000 29699.9n 0.70000 29700.0n 0.70000 29879.9n 0.70000 29880.0n 0.70000 30059.9n 0.70000 30060.0n 0.30000 30239.9n 0.30000 30240.0n 0.70000 30419.9n 0.70000 30420.0n 0.70000 30599.9n 0.70000 30600.0n 0.70000 30779.9n 0.70000 30780.0n 0.70000 30959.9n 0.70000 30960.0n 0.30000 31139.9n 0.30000 31140.0n 0.30000 31319.9n 0.30000 31320.0n 0.30000 31499.9n 0.30000 31500.0n 0.70000 31679.9n 0.70000 31680.0n 0.70000 31859.9n 0.70000 31860.0n 0.70000 32039.9n 0.70000 32040.0n 0.30000 32219.9n 0.30000 32220.0n 0.30000 32399.9n 0.30000 32400.0n 0.30000 32579.9n 0.30000 32580.0n 0.70000 32759.9n 0.70000 32760.0n 0.70000 32939.9n 0.70000 32940.0n 0.70000 33119.9n 0.70000 33120.0n 0.30000 33299.9n 0.30000 33300.0n 0.30000 33479.9n 0.30000 33480.0n 0.30000 33659.9n 0.30000 33660.0n 0.30000 33839.9n 0.30000 33840.0n 0.30000 34019.9n 0.30000 34020.0n 0.30000 34199.9n 0.30000 34200.0n 0.30000 34379.9n 0.30000 34380.0n 0.30000 34559.9n 0.30000 34560.0n 0.30000 34739.9n 0.30000 34740.0n 0.70000 34919.9n 0.70000 34920.0n 0.70000 35099.9n 0.70000 35100.0n 0.70000 35279.9n 0.70000 35280.0n 0.30000 35459.9n 0.30000 35460.0n 0.70000 35639.9n 0.70000 35640.0n 0.30000 35819.9n 0.30000 35820.0n 0.30000 35999.9n 0.30000 36000.0n 0.30000 36179.9n 0.30000 36180.0n 0.70000 36359.9n 0.70000 36360.0n 0.70000 36539.9n 0.70000 36540.0n 0.70000 36719.9n 0.70000 36720.0n 0.30000 36899.9n 0.30000 36900.0n 0.30000 37079.9n 0.30000 37080.0n 0.70000 37259.9n 0.70000 37260.0n 0.30000 37439.9n 0.30000 37440.0n 0.70000 37619.9n 0.70000 37620.0n 0.30000 37799.9n 0.30000 37800.0n 0.30000 37979.9n 0.30000 37980.0n 0.70000 38159.9n 0.70000 38160.0n 0.70000 38339.9n 0.70000 38340.0n 0.70000 38519.9n 0.70000 38520.0n 0.70000 38699.9n 0.70000 38700.0n 0.70000 38879.9n 0.70000 38880.0n 0.70000 39059.9n 0.70000 39060.0n 0.30000 39239.9n 0.30000 39240.0n 0.30000 39419.9n 0.30000 39420.0n 0.30000 39599.9n 0.30000 39600.0n 0.30000 39779.9n 0.30000 39780.0n 0.70000 39959.9n 0.70000 39960.0n 0.30000 40139.9n 0.30000 40140.0n 0.30000 40319.9n 0.30000 40320.0n 0.70000 40499.9n 0.70000 40500.0n 0.70000 40679.9n 0.70000 40680.0n 0.30000 40859.9n 0.30000 40860.0n 0.30000 41039.9n 0.30000 41040.0n 0.30000 41219.9n 0.30000 41220.0n 0.30000 41399.9n 0.30000 41400.0n 0.70000 41579.9n 0.70000 41580.0n 0.70000 41759.9n 0.70000 41760.0n 0.70000 41939.9n 0.70000 41940.0n 0.70000 42119.9n 0.70000 42120.0n 0.70000 42299.9n 0.70000 42300.0n 0.70000 42479.9n 0.70000 42480.0n 0.70000 42659.9n 0.70000 42660.0n 0.70000 42839.9n 0.70000 42840.0n 0.30000 43019.9n 0.30000 43020.0n 0.70000 43199.9n 0.70000 43200.0n 0.30000 43379.9n 0.30000 43380.0n 0.30000 43559.9n 0.30000 43560.0n 0.30000 43739.9n 0.30000 43740.0n 0.30000 43919.9n 0.30000 43920.0n 0.70000 44099.9n 0.70000 44100.0n 0.70000 44279.9n 0.70000 44280.0n 0.30000 44459.9n 0.30000 44460.0n 0.70000 44639.9n 0.70000 44640.0n 0.30000 44819.9n 0.30000 44820.0n 0.70000 44999.9n 0.70000 45000.0n 0.30000 45179.9n 0.30000 45180.0n 0.70000 45359.9n 0.70000 45360.0n 0.30000 45539.9n 0.30000 45540.0n 0.30000 45719.9n 0.30000 45720.0n 0.30000 45899.9n 0.30000 45900.0n 0.30000 46079.9n 0.30000 46080.0n 0.70000 46259.9n 0.70000 46260.0n 0.70000 46439.9n 0.70000 46440.0n 0.30000 46619.9n 0.30000 46620.0n 0.30000 46799.9n 0.30000 46800.0n 0.30000 46979.9n 0.30000 46980.0n 0.70000 47159.9n 0.70000 47160.0n 0.70000 47339.9n 0.70000 47340.0n 0.30000 47519.9n 0.30000 47520.0n 0.30000 47699.9n 0.30000 47700.0n 0.30000 47879.9n 0.30000 47880.0n 0.70000 48059.9n 0.70000 48060.0n 0.30000 48239.9n 0.30000 48240.0n 0.70000 48419.9n 0.70000 48420.0n 0.70000 48599.9n 0.70000 48600.0n 0.70000 48779.9n 0.70000 48780.0n 0.70000 48959.9n 0.70000 48960.0n 0.30000 49139.9n 0.30000 49140.0n 0.70000 49319.9n 0.70000 49320.0n 0.70000 49499.9n 0.70000 49500.0n 0.30000 49679.9n 0.30000 49680.0n 0.70000 49859.9n 0.70000 49860.0n 0.30000 50039.9n 0.30000 50040.0n 0.30000 50219.9n 0.30000 50220.0n 0.30000 50399.9n 0.30000 50400.0n 0.70000 50579.9n 0.70000 50580.0n 0.30000 50759.9n 0.30000 50760.0n 0.70000 50939.9n 0.70000 50940.0n 0.70000 51119.9n 0.70000 51120.0n 0.30000 51299.9n 0.30000 51300.0n 0.70000 51479.9n 0.70000 51480.0n 0.30000 51659.9n 0.30000 51660.0n 0.30000 51839.9n 0.30000 51840.0n 0.70000 52019.9n 0.70000 52020.0n 0.70000 52199.9n 0.70000 52200.0n 0.70000 52379.9n 0.70000 52380.0n 0.30000 52559.9n 0.30000 52560.0n 0.70000 52739.9n 0.70000 52740.0n 0.30000 52919.9n 0.30000 52920.0n 0.30000 53099.9n 0.30000 53100.0n 0.70000 53279.9n 0.70000 53280.0n 0.70000 53459.9n 0.70000 53460.0n 0.70000 53639.9n 0.70000 53640.0n 0.70000 53819.9n 0.70000 53820.0n 0.30000 53999.9n 0.30000 54000.0n 0.30000 54179.9n 0.30000 54180.0n 0.30000 54359.9n 0.30000 54360.0n 0.30000 54539.9n 0.30000 54540.0n 0.70000 54719.9n 0.70000 54720.0n 0.30000 54899.9n 0.30000 54900.0n 0.30000 55079.9n 0.30000 55080.0n 0.30000 55259.9n 0.30000 55260.0n 0.30000 55439.9n 0.30000 55440.0n 0.70000 55619.9n 0.70000 55620.0n 0.70000 55799.9n 0.70000 55800.0n 0.70000 55979.9n 0.70000 55980.0n 0.70000 56159.9n 0.70000 56160.0n 0.70000 56339.9n 0.70000 56340.0n 0.30000 56519.9n 0.30000 56520.0n 0.30000 56699.9n 0.30000 56700.0n 0.30000 56879.9n 0.30000 56880.0n 0.30000 57059.9n 0.30000 57060.0n 0.70000 57239.9n 0.70000 57240.0n 0.30000 57419.9n 0.30000 57420.0n 0.70000 57599.9n 0.70000 57600.0n 0.30000 57779.9n 0.30000 57780.0n 0.30000 57959.9n 0.30000 57960.0n 0.70000 58139.9n 0.70000 58140.0n 0.70000 58319.9n 0.70000 58320.0n 0.30000 58499.9n 0.30000 58500.0n 0.70000 58679.9n 0.70000 58680.0n 0.70000 58859.9n 0.70000 58860.0n 0.30000 59039.9n 0.30000 59040.0n 0.30000 59219.9n 0.30000 59220.0n 0.30000 59399.9n 0.30000 59400.0n 0.30000 59579.9n 0.30000 59580.0n 0.30000 59759.9n 0.30000 59760.0n 0.30000 59939.9n 0.30000 59940.0n 0.70000 60119.9n 0.70000 60120.0n 0.30000 60299.9n 0.30000 60300.0n 0.70000 60479.9n 0.70000 60480.0n 0.70000 60659.9n 0.70000 60660.0n 0.70000 60839.9n 0.70000 60840.0n 0.70000 61019.9n 0.70000 61020.0n 0.70000 61199.9n 0.70000 61200.0n 0.70000 61379.9n 0.70000 61380.0n 0.70000 61559.9n 0.70000 61560.0n 0.30000 61739.9n 0.30000 61740.0n 0.30000 61919.9n 0.30000 61920.0n 0.30000 62099.9n 0.30000 62100.0n 0.30000 62279.9n 0.30000 62280.0n 0.70000 62459.9n 0.70000 62460.0n 0.70000 62639.9n 0.70000 62640.0n 0.70000 62819.9n 0.70000 62820.0n 0.30000 62999.9n 0.30000 63000.0n 0.30000 63179.9n 0.30000 63180.0n 0.70000 63359.9n 0.70000 63360.0n 0.70000 63539.9n 0.70000 63540.0n 0.70000 63719.9n 0.70000 63720.0n 0.30000 63899.9n 0.30000 63900.0n 0.70000 64079.9n 0.70000 64080.0n 0.70000 64259.9n 0.70000 64260.0n 0.30000 64439.9n 0.30000 64440.0n 0.70000 64619.9n 0.70000 64620.0n 0.30000 64799.9n 0.30000 64800.0n 0.70000 64979.9n 0.70000 64980.0n 0.30000 65159.9n 0.30000 65160.0n 0.30000 65339.9n 0.30000 65340.0n 0.30000 65519.9n 0.30000 65520.0n 0.30000 65699.9n 0.30000 65700.0n 0.70000 65879.9n 0.70000 65880.0n 0.30000 66059.9n 0.30000 66060.0n 0.30000 66239.9n 0.30000 66240.0n 0.70000 66419.9n 0.70000 66420.0n 0.70000 66599.9n 0.70000 66600.0n 0.70000 66779.9n 0.70000 66780.0n 0.70000 66959.9n 0.70000 66960.0n 0.30000 67139.9n 0.30000 67140.0n 0.30000 67319.9n 0.30000 67320.0n 0.30000 67499.9n 0.30000 67500.0n 0.70000 67679.9n 0.70000 67680.0n 0.70000 67859.9n 0.70000 67860.0n 0.30000 68039.9n 0.30000 68040.0n 0.70000 68219.9n 0.70000 68220.0n 0.30000 68399.9n 0.30000 68400.0n 0.70000 68579.9n 0.70000 68580.0n 0.30000 68759.9n 0.30000 68760.0n 0.30000 68939.9n 0.30000 68940.0n 0.70000 69119.9n 0.70000 69120.0n 0.30000 69299.9n 0.30000 69300.0n 0.70000 69479.9n 0.70000 69480.0n 0.70000 69659.9n 0.70000 69660.0n 0.70000 69839.9n 0.70000 69840.0n 0.70000 70019.9n 0.70000 70020.0n 0.30000 70199.9n 0.30000 70200.0n 0.30000 70379.9n 0.30000 70380.0n 0.30000 70559.9n 0.30000 70560.0n 0.30000 70739.9n 0.30000 70740.0n 0.30000 70919.9n 0.30000 70920.0n 0.70000 71099.9n 0.70000 71100.0n 0.70000 71279.9n 0.70000 71280.0n 0.70000 71459.9n 0.70000 71460.0n 0.70000 71639.9n 0.70000 71640.0n 0.30000 71819.9n 0.30000 71820.0n 0.30000 71999.9n 0.30000 72000.0n 0.30000 72179.9n 0.30000 72180.0n 0.70000 72359.9n 0.70000 72360.0n 0.70000 72539.9n 0.70000 72540.0n 0.30000 72719.9n 0.30000 72720.0n 0.30000 72899.9n 0.30000 72900.0n 0.70000 73079.9n 0.70000 73080.0n 0.70000 73259.9n 0.70000 73260.0n 0.30000 73439.9n 0.30000 73440.0n 0.30000 73619.9n 0.30000 73620.0n 0.70000 73799.9n 0.70000 73800.0n 0.70000 73979.9n 0.70000 73980.0n 0.30000 74159.9n 0.30000 74160.0n 0.30000 74339.9n 0.30000 74340.0n 0.70000 74519.9n 0.70000 74520.0n 0.70000 74699.9n 0.70000 74700.0n 0.30000 74879.9n 0.30000 74880.0n 0.30000 75059.9n 0.30000 75060.0n 0.70000 75239.9n 0.70000 75240.0n 0.70000 75419.9n 0.70000 75420.0n 0.70000 75599.9n 0.70000 75600.0n 0.70000 75779.9n 0.70000 75780.0n 0.70000 75959.9n 0.70000 75960.0n 0.70000 76139.9n 0.70000 76140.0n 0.70000 76319.9n 0.70000 76320.0n 0.30000 76499.9n 0.30000 76500.0n 0.30000 76679.9n 0.30000 76680.0n 0.70000 76859.9n 0.70000 76860.0n 0.70000 77039.9n 0.70000 77040.0n 0.70000 77219.9n 0.70000 77220.0n 0.30000 77399.9n 0.30000 77400.0n 0.30000 77579.9n 0.30000 77580.0n 0.70000 77759.9n 0.70000 77760.0n 0.30000 77939.9n 0.30000 77940.0n 0.30000 78119.9n 0.30000 78120.0n 0.30000 78299.9n 0.30000 78300.0n 0.70000 78479.9n 0.70000 78480.0n 0.30000 78659.9n 0.30000 78660.0n 0.30000 78839.9n 0.30000 78840.0n 0.30000 79019.9n 0.30000 79020.0n 0.70000 79199.9n 0.70000 79200.0n 0.30000 79379.9n 0.30000 79380.0n 0.30000 79559.9n 0.30000 79560.0n 0.70000 79739.9n 0.70000 79740.0n 0.70000 79919.9n 0.70000 79920.0n 0.30000 80099.9n 0.30000 80100.0n 0.30000 80279.9n 0.30000 80280.0n 0.30000 80459.9n 0.30000 80460.0n 0.70000 80639.9n 0.70000 80640.0n 0.30000 80819.9n 0.30000 80820.0n 0.30000 80999.9n 0.30000 81000.0n 0.30000 81179.9n 0.30000 81180.0n 0.70000 81359.9n 0.70000 81360.0n 0.70000 81539.9n 0.70000 81540.0n 0.70000 81719.9n 0.70000 81720.0n 0.30000 81899.9n 0.30000 81900.0n 0.30000 82079.9n 0.30000 82080.0n 0.70000 82259.9n 0.70000 82260.0n 0.70000 82439.9n 0.70000 82440.0n 0.70000 82619.9n 0.70000 82620.0n 0.70000 82799.9n 0.70000 82800.0n 0.70000 82979.9n 0.70000 82980.0n 0.30000 83159.9n 0.30000 83160.0n 0.30000 83339.9n 0.30000 83340.0n 0.30000 83519.9n 0.30000 83520.0n 0.70000 83699.9n 0.70000 83700.0n 0.70000 83879.9n 0.70000 83880.0n 0.30000 84059.9n 0.30000 84060.0n 0.30000 84239.9n 0.30000 84240.0n 0.70000 84419.9n 0.70000 84420.0n 0.30000 84599.9n 0.30000 84600.0n 0.30000 84779.9n 0.30000 84780.0n 0.70000 84959.9n 0.70000 84960.0n 0.70000 85139.9n 0.70000 85140.0n 0.70000 85319.9n 0.70000 85320.0n 0.70000 85499.9n 0.70000 85500.0n 0.30000 85679.9n 0.30000 85680.0n 0.30000 85859.9n 0.30000 85860.0n 0.30000 86039.9n 0.30000 86040.0n 0.70000 86219.9n 0.70000 86220.0n 0.30000 86399.9n 0.30000 86400.0n 0.30000 86579.9n 0.30000 86580.0n 0.30000 86759.9n 0.30000 86760.0n 0.30000 86939.9n 0.30000 86940.0n 0.70000 87119.9n 0.70000 87120.0n 0.30000 87299.9n 0.30000 87300.0n 0.30000 87479.9n 0.30000 87480.0n 0.30000 87659.9n 0.30000 87660.0n 0.30000 87839.9n 0.30000 87840.0n 0.70000 88019.9n 0.70000 88020.0n 0.30000 88199.9n 0.30000 88200.0n 0.70000 88379.9n 0.70000 88380.0n 0.70000 88559.9n 0.70000 88560.0n 0.70000 88739.9n 0.70000 88740.0n 0.70000 88919.9n 0.70000 88920.0n 0.30000 89099.9n 0.30000 89100.0n 0.70000 89279.9n 0.70000 89280.0n 0.70000 89459.9n 0.70000 89460.0n 0.30000 89639.9n 0.30000 89640.0n 0.30000 89819.9n 0.30000 89820.0n 0.70000 89999.9n 0.70000 90000.0n 0.70000 90179.9n 0.70000 90180.0n 0.70000 90359.9n 0.70000 90360.0n 0.70000 90539.9n 0.70000 90540.0n 0.30000 90719.9n 0.30000 90720.0n 0.70000 90899.9n 0.70000 90900.0n 0.70000 91079.9n 0.70000 91080.0n 0.30000 91259.9n 0.30000 91260.0n 0.30000 91439.9n 0.30000 91440.0n 0.30000 91619.9n 0.30000 91620.0n 0.70000 91799.9n 0.70000 91800.0n 0.30000 91979.9n 0.30000 91980.0n 0.70000 92159.9n 0.70000 92160.0n 0.30000 92339.9n 0.30000 92340.0n 0.70000 92519.9n 0.70000 92520.0n 0.70000 92699.9n 0.70000 92700.0n 0.70000 92879.9n 0.70000 92880.0n 0.30000 93059.9n 0.30000 93060.0n 0.30000 93239.9n 0.30000 93240.0n 0.30000 93419.9n 0.30000 93420.0n 0.70000 93599.9n 0.70000 93600.0n 0.70000 93779.9n 0.70000 93780.0n 0.30000 93959.9n 0.30000 93960.0n 0.30000 94139.9n 0.30000 94140.0n 0.70000 94319.9n 0.70000 94320.0n 0.30000 94499.9n 0.30000 94500.0n 0.70000 94679.9n 0.70000 94680.0n 0.70000 94859.9n 0.70000 94860.0n 0.70000 95039.9n 0.70000 95040.0n 0.70000 95219.9n 0.70000 95220.0n 0.70000 95399.9n 0.70000 95400.0n 0.70000 95579.9n 0.70000 95580.0n 0.30000 95759.9n 0.30000 95760.0n 0.30000 95939.9n 0.30000 95940.0n 0.30000 96119.9n 0.30000 96120.0n 0.70000 96299.9n 0.70000 96300.0n 0.70000 96479.9n 0.70000 96480.0n 0.70000 96659.9n 0.70000 96660.0n 0.30000 96839.9n 0.30000 96840.0n 0.30000 97019.9n 0.30000 97020.0n 0.30000 97199.9n 0.30000 97200.0n 0.70000 97379.9n 0.70000 97380.0n 0.30000 97559.9n 0.30000 97560.0n 0.30000 97739.9n 0.30000 97740.0n 0.30000 97919.9n 0.30000 97920.0n 0.30000 98099.9n 0.30000 98100.0n 0.30000 98279.9n 0.30000 98280.0n 0.30000 98459.9n 0.30000 98460.0n 0.30000 98639.9n 0.30000 98640.0n 0.30000 98819.9n 0.30000 98820.0n 0.30000 98999.9n 0.30000 99000.0n 0.30000 99179.9n 0.30000 99180.0n 0.30000 99359.9n 0.30000 99360.0n 0.30000 99539.9n 0.30000 99540.0n 0.70000 99719.9n 0.70000 99720.0n 0.70000 99899.9n 0.70000 99900.0n 0.30000 100079.9n 0.30000 100080.0n 0.70000 100259.9n 0.70000 100260.0n 0.70000 100439.9n 0.70000 100440.0n 0.30000 100619.9n 0.30000 100620.0n 0.30000 100799.9n 0.30000 100800.0n 0.70000 100979.9n 0.70000 100980.0n 0.70000 101159.9n 0.70000 101160.0n 0.70000 101339.9n 0.70000 101340.0n 0.30000 101519.9n 0.30000 101520.0n 0.30000 101699.9n 0.30000 101700.0n 0.70000 101879.9n 0.70000 101880.0n 0.70000 102059.9n 0.70000 102060.0n 0.70000 102239.9n 0.70000 102240.0n 0.30000 102419.9n 0.30000 102420.0n 0.70000 102599.9n 0.70000 102600.0n 0.70000 102779.9n 0.70000 102780.0n 0.70000 102959.9n 0.70000 102960.0n 0.30000 103139.9n 0.30000 103140.0n 0.70000 103319.9n 0.70000 103320.0n 0.70000 103499.9n 0.70000 103500.0n 0.70000 103679.9n 0.70000 103680.0n 0.30000 103859.9n 0.30000 103860.0n 0.30000 104039.9n 0.30000 104040.0n 0.30000 104219.9n 0.30000 104220.0n 0.30000 104399.9n 0.30000 104400.0n 0.70000 104579.9n 0.70000 104580.0n 0.70000 104759.9n 0.70000 104760.0n 0.70000 104939.9n 0.70000 104940.0n 0.70000 105119.9n 0.70000 105120.0n 0.30000 105299.9n 0.30000 105300.0n 0.30000 105479.9n 0.30000 105480.0n 0.70000 105659.9n 0.70000 105660.0n 0.30000 105839.9n 0.30000 105840.0n 0.70000 106019.9n 0.70000 106020.0n 0.30000 106199.9n 0.30000 106200.0n 0.70000 106379.9n 0.70000 106380.0n 0.30000 106559.9n 0.30000 106560.0n 0.30000 106739.9n 0.30000 106740.0n 0.70000 106919.9n 0.70000 106920.0n 0.70000 107099.9n 0.70000 107100.0n 0.30000 107279.9n 0.30000 107280.0n 0.70000 107459.9n 0.70000 107460.0n 0.70000 107639.9n 0.70000 107640.0n 0.70000 107819.9n 0.70000 107820.0n 0.30000 107999.9n 0.30000 108000.0n 0.30000 108179.9n 0.30000 108180.0n 0.30000 108359.9n 0.30000 108360.0n 0.70000 108539.9n 0.70000 108540.0n 0.30000 108719.9n 0.30000 108720.0n 0.70000 108899.9n 0.70000 108900.0n 0.70000 109079.9n 0.70000 109080.0n 0.70000 109259.9n 0.70000 109260.0n 0.30000 109439.9n 0.30000 109440.0n 0.30000 109619.9n 0.30000 109620.0n 0.30000 109799.9n 0.30000 109800.0n 0.70000 109979.9n 0.70000 109980.0n 0.30000 110159.9n 0.30000 110160.0n 0.30000 110339.9n 0.30000 110340.0n 0.30000 110519.9n 0.30000 110520.0n 0.70000 110699.9n 0.70000 110700.0n 0.30000 110879.9n 0.30000 110880.0n 0.30000 111059.9n 0.30000 111060.0n 0.70000 111239.9n 0.70000 111240.0n 0.70000 111419.9n 0.70000 111420.0n 0.30000 111599.9n 0.30000 111600.0n 0.70000 111779.9n 0.70000 111780.0n 0.70000 111959.9n 0.70000 111960.0n 0.70000 112139.9n 0.70000 112140.0n 0.70000 112319.9n 0.70000 112320.0n 0.70000 112499.9n 0.70000 112500.0n 0.70000 112679.9n 0.70000 112680.0n 0.30000 112859.9n 0.30000 112860.0n 0.30000 113039.9n 0.30000 113040.0n 0.70000 113219.9n 0.70000 113220.0n 0.30000 113399.9n 0.30000 113400.0n 0.70000 113579.9n 0.70000 113580.0n 0.70000 113759.9n 0.70000 113760.0n 0.30000 113939.9n 0.30000 113940.0n 0.30000 114119.9n 0.30000 114120.0n 0.30000 114299.9n 0.30000 114300.0n 0.70000 114479.9n 0.70000 114480.0n 0.30000 114659.9n 0.30000 114660.0n 0.70000 114839.9n 0.70000 114840.0n 0.70000 115019.9n 0.70000 115020.0n 0.30000 115199.9n 0.30000 115200.0n 0.30000 115379.9n 0.30000 115380.0n 0.30000 115559.9n 0.30000 115560.0n 0.70000 115739.9n 0.70000 115740.0n 0.70000 115919.9n 0.70000 115920.0n 0.30000 116099.9n 0.30000 116100.0n 0.70000 116279.9n 0.70000 116280.0n 0.30000 116459.9n 0.30000 116460.0n 0.30000 116639.9n 0.30000 116640.0n 0.70000 116819.9n 0.70000 116820.0n 0.70000 116999.9n 0.70000 117000.0n 0.30000 117179.9n 0.30000 117180.0n 0.30000 117359.9n 0.30000 117360.0n 0.70000 117539.9n 0.70000 117540.0n 0.30000 117719.9n 0.30000 117720.0n 0.70000 117899.9n 0.70000 117900.0n 0.30000 118079.9n 0.30000 118080.0n 0.30000 118259.9n 0.30000 118260.0n 0.70000 118439.9n 0.70000 118440.0n 0.30000 118619.9n 0.30000 118620.0n 0.30000 118799.9n 0.30000 118800.0n 0.70000 118979.9n 0.70000 118980.0n 0.70000 119159.9n 0.70000 119160.0n 0.70000 119339.9n 0.70000 119340.0n 0.70000 119519.9n 0.70000 119520.0n 0.70000 119699.9n 0.70000 119700.0n 0.70000 119879.9n 0.70000 119880.0n 0.30000 120059.9n 0.30000 120060.0n 0.30000 120239.9n 0.30000 120240.0n 0.70000 120419.9n 0.70000 120420.0n 0.70000 120599.9n 0.70000 120600.0n 0.30000 120779.9n 0.30000 120780.0n 0.30000 120959.9n 0.30000 120960.0n 0.30000 121139.9n 0.30000 121140.0n 0.30000 121319.9n 0.30000 121320.0n 0.70000 121499.9n 0.70000 121500.0n 0.30000 121679.9n 0.30000 121680.0n 0.30000 121859.9n 0.30000 121860.0n 0.70000 122039.9n 0.70000 122040.0n 0.70000 122219.9n 0.70000 122220.0n 0.70000 122399.9n 0.70000 122400.0n 0.30000 122579.9n 0.30000 122580.0n 0.70000 122759.9n 0.70000 122760.0n 0.70000 122939.9n 0.70000 122940.0n 0.30000 123119.9n 0.30000 123120.0n 0.70000 123299.9n 0.70000 123300.0n 0.30000 123479.9n 0.30000 123480.0n 0.30000 123659.9n 0.30000 123660.0n 0.30000 123839.9n 0.30000 123840.0n 0.70000 124019.9n 0.70000 124020.0n 0.70000 124199.9n 0.70000 124200.0n 0.30000 124379.9n 0.30000 124380.0n 0.70000 124559.9n 0.70000 124560.0n 0.70000 124739.9n 0.70000 124740.0n 0.70000 124919.9n 0.70000 124920.0n 0.30000 125099.9n 0.30000 125100.0n 0.30000 125279.9n 0.30000 125280.0n 0.30000 125459.9n 0.30000 125460.0n 0.30000 125639.9n 0.30000 125640.0n 0.70000 125819.9n 0.70000 125820.0n 0.70000 125999.9n 0.70000 126000.0n 0.30000 126179.9n 0.30000 126180.0n 0.70000 126359.9n 0.70000 126360.0n 0.30000 126539.9n 0.30000 126540.0n 0.70000 126719.9n 0.70000 126720.0n 0.30000 126899.9n 0.30000 126900.0n 0.30000 127079.9n 0.30000 127080.0n 0.30000 127259.9n 0.30000 127260.0n 0.30000 127439.9n 0.30000 127440.0n 0.30000 127619.9n 0.30000 127620.0n 0.70000 127799.9n 0.70000 127800.0n 0.30000 127979.9n 0.30000 127980.0n 0.30000 128159.9n 0.30000 128160.0n 0.70000 128339.9n 0.70000 128340.0n 0.70000 128519.9n 0.70000 128520.0n 0.70000 128699.9n 0.70000 128700.0n 0.70000 128879.9n 0.70000 128880.0n 0.30000 129059.9n 0.30000 129060.0n 0.70000 129239.9n 0.70000 129240.0n 0.70000 129419.9n 0.70000 129420.0n 0.70000 129599.9n 0.70000 129600.0n 0.30000 129779.9n 0.30000 129780.0n 0.70000 129959.9n 0.70000 129960.0n 0.70000 130139.9n 0.70000 130140.0n 0.70000 130319.9n 0.70000 130320.0n 0.70000 130499.9n 0.70000 130500.0n 0.30000 130679.9n 0.30000 130680.0n 0.30000 130859.9n 0.30000 130860.0n 0.30000 131039.9n 0.30000 131040.0n 0.70000 131219.9n 0.70000 131220.0n 0.70000 131399.9n 0.70000 131400.0n 0.30000 131579.9n 0.30000 131580.0n 0.70000 131759.9n 0.70000 131760.0n 0.30000 131939.9n 0.30000 131940.0n 0.30000 132119.9n 0.30000 132120.0n 0.70000 132299.9n 0.70000 132300.0n 0.30000 132479.9n 0.30000 132480.0n 0.30000 132659.9n 0.30000 132660.0n 0.30000 132839.9n 0.30000 132840.0n 0.70000 133019.9n 0.70000 133020.0n 0.70000 133199.9n 0.70000 133200.0n 0.30000 133379.9n 0.30000 133380.0n 0.30000 133559.9n 0.30000 133560.0n 0.30000 133739.9n 0.30000 133740.0n 0.30000 133919.9n 0.30000 133920.0n 0.30000 134099.9n 0.30000 134100.0n 0.30000 134279.9n 0.30000 134280.0n 0.70000 134459.9n 0.70000 134460.0n 0.70000 134639.9n 0.70000 134640.0n 0.30000 134819.9n 0.30000 134820.0n 0.30000 134999.9n 0.30000 135000.0n 0.70000 135179.9n 0.70000 135180.0n 0.70000 135359.9n 0.70000 135360.0n 0.70000 135539.9n 0.70000 135540.0n 0.70000 135719.9n 0.70000 135720.0n 0.30000 135899.9n 0.30000 135900.0n 0.70000 136079.9n 0.70000 136080.0n 0.30000 136259.9n 0.30000 136260.0n 0.70000 136439.9n 0.70000 136440.0n 0.30000 136619.9n 0.30000 136620.0n 0.70000 136799.9n 0.70000 136800.0n 0.70000 136979.9n 0.70000 136980.0n 0.70000 137159.9n 0.70000 137160.0n 0.70000 137339.9n 0.70000 137340.0n 0.70000 137519.9n 0.70000 137520.0n 0.30000 137699.9n 0.30000 137700.0n 0.70000 137879.9n 0.70000 137880.0n 0.30000 138059.9n 0.30000 138060.0n 0.30000 138239.9n 0.30000 138240.0n 0.70000 138419.9n 0.70000 138420.0n 0.70000 138599.9n 0.70000 138600.0n 0.70000 138779.9n 0.70000 138780.0n 0.70000 138959.9n 0.70000 138960.0n 0.70000 139139.9n 0.70000 139140.0n 0.30000 139319.9n 0.30000 139320.0n 0.30000 139499.9n 0.30000 139500.0n 0.70000 139679.9n 0.70000 139680.0n 0.70000 139859.9n 0.70000 139860.0n 0.30000 140039.9n 0.30000 140040.0n 0.30000 140219.9n 0.30000 140220.0n 0.30000 140399.9n 0.30000 140400.0n 0.70000 140579.9n 0.70000 140580.0n 0.70000 140759.9n 0.70000 140760.0n 0.30000 140939.9n 0.30000 140940.0n 0.70000 141119.9n 0.70000 141120.0n 0.30000 141299.9n 0.30000 141300.0n 0.70000 141479.9n 0.70000 141480.0n 0.70000 141659.9n 0.70000 141660.0n 0.30000 141839.9n 0.30000 141840.0n 0.30000 142019.9n 0.30000 142020.0n 0.70000 142199.9n 0.70000 142200.0n 0.70000 142379.9n 0.70000 142380.0n 0.70000 142559.9n 0.70000 142560.0n 0.30000 142739.9n 0.30000 142740.0n 0.30000 142919.9n 0.30000 142920.0n 0.30000 143099.9n 0.30000 143100.0n 0.30000 143279.9n 0.30000 143280.0n 0.70000 143459.9n 0.70000 143460.0n 0.30000 143639.9n 0.30000 143640.0n 0.30000 143819.9n 0.30000 143820.0n 0.30000 143999.9n 0.30000 144000.0n 0.30000 144179.9n 0.30000 144180.0n 0.70000 144359.9n 0.70000 144360.0n 0.70000 144539.9n 0.70000 144540.0n 0.30000 144719.9n 0.30000 144720.0n 0.30000 144899.9n 0.30000 144900.0n 0.70000 145079.9n 0.70000 145080.0n 0.70000 145259.9n 0.70000 145260.0n 0.70000 145439.9n 0.70000 145440.0n 0.70000 145619.9n 0.70000 145620.0n 0.70000 145799.9n 0.70000 145800.0n 0.70000 145979.9n 0.70000 145980.0n 0.30000 146159.9n 0.30000 146160.0n 0.30000 146339.9n 0.30000 146340.0n 0.30000 146519.9n 0.30000 146520.0n 0.70000 146699.9n 0.70000 146700.0n 0.30000 146879.9n 0.30000 146880.0n 0.70000 147059.9n 0.70000 147060.0n 0.70000 147239.9n 0.70000 147240.0n 0.30000 147419.9n 0.30000 147420.0n 0.70000 147599.9n 0.70000 147600.0n 0.70000 147779.9n 0.70000 147780.0n 0.70000 147959.9n 0.70000 147960.0n 0.30000 148139.9n 0.30000 148140.0n 0.70000 148319.9n 0.70000 148320.0n 0.30000 148499.9n 0.30000 148500.0n 0.30000 148679.9n 0.30000 148680.0n 0.30000 148859.9n 0.30000 148860.0n 0.30000 149039.9n 0.30000 149040.0n 0.30000 149219.9n 0.30000 149220.0n 0.70000 149399.9n 0.70000 149400.0n 0.30000 149579.9n 0.30000 149580.0n 0.30000 149759.9n 0.30000 149760.0n 0.30000 149939.9n 0.30000 149940.0n 0.30000 150119.9n 0.30000 150120.0n 0.70000 150299.9n 0.70000 150300.0n 0.70000 150479.9n 0.70000 150480.0n 0.30000 150659.9n 0.30000 150660.0n 0.30000 150839.9n 0.30000 150840.0n 0.70000 151019.9n 0.70000 151020.0n 0.70000 151199.9n 0.70000 151200.0n 0.70000 151379.9n 0.70000 151380.0n 0.70000 151559.9n 0.70000 151560.0n 0.70000 151739.9n 0.70000 151740.0n 0.30000 151919.9n 0.30000 151920.0n 0.70000 152099.9n 0.70000 152100.0n 0.30000 152279.9n 0.30000 152280.0n 0.30000 152459.9n 0.30000 152460.0n 0.70000 152639.9n 0.70000 152640.0n 0.70000 152819.9n 0.70000 152820.0n 0.70000 152999.9n 0.70000 153000.0n 0.30000 153179.9n 0.30000 153180.0n 0.70000 153359.9n 0.70000 153360.0n 0.70000 153539.9n 0.70000 153540.0n 0.30000 153719.9n 0.30000 153720.0n 0.30000 153899.9n 0.30000 153900.0n 0.30000 154079.9n 0.30000 154080.0n 0.30000 154259.9n 0.30000 154260.0n 0.70000 154439.9n 0.70000 154440.0n 0.30000 154619.9n 0.30000 154620.0n 0.70000 154799.9n 0.70000 154800.0n 0.30000 154979.9n 0.30000 154980.0n 0.30000 155159.9n 0.30000 155160.0n 0.30000 155339.9n 0.30000 155340.0n 0.70000 155519.9n 0.70000 155520.0n 0.30000 155699.9n 0.30000 155700.0n 0.70000 155879.9n 0.70000 155880.0n 0.30000 156059.9n 0.30000 156060.0n 0.70000 156239.9n 0.70000 156240.0n 0.30000 156419.9n 0.30000 156420.0n 0.70000 156599.9n 0.70000 156600.0n 0.70000 156779.9n 0.70000 156780.0n 0.70000 156959.9n 0.70000 156960.0n 0.70000 157139.9n 0.70000 157140.0n 0.70000 157319.9n 0.70000 157320.0n 0.30000 157499.9n 0.30000 157500.0n 0.30000 157679.9n 0.30000 157680.0n 0.30000 157859.9n 0.30000 157860.0n 0.30000 158039.9n 0.30000 158040.0n 0.70000 158219.9n 0.70000 158220.0n 0.30000 158399.9n 0.30000 158400.0n 0.70000 158579.9n 0.70000 158580.0n 0.70000 158759.9n 0.70000 158760.0n 0.70000 158939.9n 0.70000 158940.0n 0.70000 159119.9n 0.70000 159120.0n 0.30000 159299.9n 0.30000 159300.0n 0.30000 159479.9n 0.30000 159480.0n 0.70000 159659.9n 0.70000 159660.0n 0.70000 159839.9n 0.70000 159840.0n 0.30000 160019.9n 0.30000 160020.0n 0.30000 160199.9n 0.30000 160200.0n 0.30000 160379.9n 0.30000 160380.0n 0.30000 160559.9n 0.30000 160560.0n 0.30000 160739.9n 0.30000 160740.0n 0.70000 160919.9n 0.70000 160920.0n 0.30000 161099.9n 0.30000 161100.0n 0.70000 161279.9n 0.70000 161280.0n 0.30000 161459.9n 0.30000 161460.0n 0.30000 161639.9n 0.30000 161640.0n 0.70000 161819.9n 0.70000 161820.0n 0.30000 161999.9n 0.30000 162000.0n 0.70000 162179.9n 0.70000 162180.0n 0.30000 162359.9n 0.30000 162360.0n 0.70000 162539.9n 0.70000 162540.0n 0.70000 162719.9n 0.70000 162720.0n 0.30000 162899.9n 0.30000 162900.0n 0.30000 163079.9n 0.30000 163080.0n 0.70000 163259.9n 0.70000 163260.0n 0.30000 163439.9n 0.30000 163440.0n 0.70000 163619.9n 0.70000 163620.0n 0.30000 163799.9n 0.30000 163800.0n 0.70000 163979.9n 0.70000 163980.0n 0.70000 164159.9n 0.70000 164160.0n 0.30000 164339.9n 0.30000 164340.0n 0.70000 164519.9n 0.70000 164520.0n 0.70000 164699.9n 0.70000 164700.0n 0.30000 164879.9n 0.30000 164880.0n 0.70000 165059.9n 0.70000 165060.0n 0.70000 165239.9n 0.70000 165240.0n 0.30000 165419.9n 0.30000 165420.0n 0.70000 165599.9n 0.70000 165600.0n 0.30000 165779.9n 0.30000 165780.0n 0.30000 165959.9n 0.30000 165960.0n 0.70000 166139.9n 0.70000 166140.0n 0.30000 166319.9n 0.30000 166320.0n 0.30000 166499.9n 0.30000 166500.0n 0.70000 166679.9n 0.70000 166680.0n 0.30000 166859.9n 0.30000 166860.0n 0.70000 167039.9n 0.70000 167040.0n 0.70000 167219.9n 0.70000 167220.0n 0.70000 167399.9n 0.70000 167400.0n 0.30000 167579.9n 0.30000 167580.0n 0.30000 167759.9n 0.30000 167760.0n 0.30000 167939.9n 0.30000 167940.0n 0.70000 168119.9n 0.70000 168120.0n 0.30000 168299.9n 0.30000 168300.0n 0.30000 168479.9n 0.30000 168480.0n 0.70000 168659.9n 0.70000 168660.0n 0.30000 168839.9n 0.30000 168840.0n 0.30000 169019.9n 0.30000 169020.0n 0.70000 169199.9n 0.70000 169200.0n 0.70000 169379.9n 0.70000 169380.0n 0.30000 169559.9n 0.30000 169560.0n 0.70000 169739.9n 0.70000 169740.0n 0.30000 169919.9n 0.30000 169920.0n 0.30000 170099.9n 0.30000 170100.0n 0.30000 170279.9n 0.30000 170280.0n 0.30000 170459.9n 0.30000 170460.0n 0.70000 170639.9n 0.70000 170640.0n 0.70000 170819.9n 0.70000 170820.0n 0.70000 170999.9n 0.70000 171000.0n 0.30000 171179.9n 0.30000 171180.0n 0.70000 171359.9n 0.70000 171360.0n 0.30000 171539.9n 0.30000 171540.0n 0.70000 171719.9n 0.70000 171720.0n 0.70000 171899.9n 0.70000 171900.0n 0.30000 172079.9n 0.30000 172080.0n 0.30000 172259.9n 0.30000 172260.0n 0.70000 172439.9n 0.70000 172440.0n 0.70000 172619.9n 0.70000 172620.0n 0.70000 172799.9n 0.70000 172800.0n 0.50000 172979.9n 0.50000 172980.0n 0.50000 173159.9n 0.50000 173160.0n 0.50000 173339.9n 0.50000 173340.0n 0.50000 173519.9n 0.50000 173520.0n 0.50000 173699.9n 0.50000 173700.0n 0.50000 173879.9n 0.50000 173880.0n 0.50000 174059.9n 0.50000 174060.0n 0.50000 174239.9n 0.50000 174240.0n 0.50000 174419.9n 0.50000 174420.0n 0.50000 174599.9n 0.50000 174600.0n 0.50000 174779.9n 0.50000 174780.0n 0.50000 174959.9n 0.50000 174960.0n 0.50000 175139.9n 0.50000 175140.0n 0.50000 175319.9n 0.50000 175320.0n 0.50000 175499.9n 0.50000 175500.0n 0.50000 175679.9n 0.50000 175680.0n 0.50000 175859.9n 0.50000 175860.0n 0.50000 176039.9n 0.50000 176040.0n 0.50000 176219.9n 0.50000 176220.0n 0.50000 176399.9n 0.50000 176400.0n 0.50000 176579.9n 0.50000 176580.0n 0.50000 176759.9n 0.50000 176760.0n 0.50000 176939.9n 0.50000 176940.0n 0.50000 177119.9n 0.50000 177120.0n 0.50000 177299.9n 0.50000 177300.0n 0.50000 177479.9n 0.50000 177480.0n 0.50000 177659.9n 0.50000 177660.0n 0.50000 177839.9n 0.50000 177840.0n 0.50000 178019.9n 0.50000 178020.0n 0.50000 178199.9n 0.50000 178200.0n 0.50000 178379.9n 0.50000 178380.0n 0.50000 178559.9n 0.50000 178560.0n 0.50000 178739.9n 0.50000 178740.0n 0.50000 178919.9n 0.50000 178920.0n 0.50000 179099.9n 0.50000 179100.0n 0.50000 179279.9n 0.50000 179280.0n 0.50000 179459.9n 0.50000 179460.0n 0.50000 179639.9n 0.50000 179640.0n 0.50000 179819.9n 0.50000 179820.0n 0.50000 179999.9n 0.50000 180000.0n 0.50000 180179.9n 0.50000 180180.0n 0.50000 180359.9n 0.50000 180360.0n 0.50000 180539.9n 0.50000 180540.0n 0.50000 180719.9n 0.50000 180720.0n 0.50000 180899.9n 0.50000 180900.0n 0.50000 181079.9n 0.50000 181080.0n 0.50000 181259.9n 0.50000 181260.0n 0.50000 181439.9n 0.50000 181440.0n 0.50000 181619.9n 0.50000 181620.0n 0.50000 181799.9n 0.50000 181800.0n 0.50000 181979.9n 0.50000 181980.0n 0.50000 182159.9n 0.50000 182160.0n 0.50000 182339.9n 0.50000 182340.0n 0.50000 182519.9n 0.50000 182520.0n 0.50000 182699.9n 0.50000 182700.0n 0.50000 182879.9n 0.50000 182880.0n 0.50000 183059.9n 0.50000 183060.0n 0.50000 183239.9n 0.50000 183240.0n 0.50000 183419.9n 0.50000 183420.0n 0.50000)
Vwih_p_0_0 wih_p_0_0 0 0.9
Vwih_n_0_0 wih_n_0_0 0 0.3
Vwih_p_1_0 wih_p_1_0 0 0.3
Vwih_n_1_0 wih_n_1_0 0 0.8077526372768347
Vwih_p_2_0 wih_p_2_0 0 0.9
Vwih_n_2_0 wih_n_2_0 0 0.3
Xcm_xh0 xhp0 xhn0 vdd cmld
Rnd_xh0 xhp0 xhn0 20k
Cxh0p xhp0 0 1e-13
Cxh0n xhn0 0 1e-13
Xih_0_0 a_xp0 a_xn0 wih_p_0_0 wih_n_0_0 xhp0 xhn0 vdd vbsyn gsyn
Xih_1_0 a_xp1 a_xn1 wih_p_1_0 wih_n_1_0 xhp0 xhn0 vdd vbsyn gsyn
Xih_2_0 a_xp2 a_xn2 wih_p_2_0 wih_n_2_0 xhp0 xhn0 vdd vbsyn gsyn
Xn0 xhp0 xhn0 ahp0 ahn0 vdd vbneu dneuron
Vwih_p_0_1 wih_p_0_1 0 0.4076074543279496
Vwih_n_0_1 wih_n_0_1 0 0.5923925456720505
Vwih_p_1_1 wih_p_1_1 0 0.6875517955179162
Vwih_n_1_1 wih_n_1_1 0 0.31244820448208377
Vwih_p_2_1 wih_p_2_1 0 0.9
Vwih_n_2_1 wih_n_2_1 0 0.3
Xcm_xh1 xhp1 xhn1 vdd cmld
Rnd_xh1 xhp1 xhn1 20k
Cxh1p xhp1 0 1e-13
Cxh1n xhn1 0 1e-13
Xih_0_1 a_xp0 a_xn0 wih_p_0_1 wih_n_0_1 xhp1 xhn1 vdd vbsyn gsyn
Xih_1_1 a_xp1 a_xn1 wih_p_1_1 wih_n_1_1 xhp1 xhn1 vdd vbsyn gsyn
Xih_2_1 a_xp2 a_xn2 wih_p_2_1 wih_n_2_1 xhp1 xhn1 vdd vbsyn gsyn
Xn1 xhp1 xhn1 ahp1 ahn1 vdd vbneu dneuron
Vwih_p_0_2 wih_p_0_2 0 0.6986905748958001
Vwih_n_0_2 wih_n_0_2 0 0.30130942510419984
Vwih_p_1_2 wih_p_1_2 0 0.8611596583173695
Vwih_n_1_2 wih_n_1_2 0 0.3
Vwih_p_2_2 wih_p_2_2 0 0.3
Vwih_n_2_2 wih_n_2_2 0 0.9
Xcm_xh2 xhp2 xhn2 vdd cmld
Rnd_xh2 xhp2 xhn2 20k
Cxh2p xhp2 0 1e-13
Cxh2n xhn2 0 1e-13
Xih_0_2 a_xp0 a_xn0 wih_p_0_2 wih_n_0_2 xhp2 xhn2 vdd vbsyn gsyn
Xih_1_2 a_xp1 a_xn1 wih_p_1_2 wih_n_1_2 xhp2 xhn2 vdd vbsyn gsyn
Xih_2_2 a_xp2 a_xn2 wih_p_2_2 wih_n_2_2 xhp2 xhn2 vdd vbsyn gsyn
Xn2 xhp2 xhn2 ahp2 ahn2 vdd vbneu dneuron
Vwih_p_0_3 wih_p_0_3 0 0.3
Vwih_n_0_3 wih_n_0_3 0 0.7073156875091838
Vwih_p_1_3 wih_p_1_3 0 0.9
Vwih_n_1_3 wih_n_1_3 0 0.3
Vwih_p_2_3 wih_p_2_3 0 0.3968886139217385
Vwih_n_2_3 wih_n_2_3 0 0.6031113860782614
Xcm_xh3 xhp3 xhn3 vdd cmld
Rnd_xh3 xhp3 xhn3 20k
Cxh3p xhp3 0 1e-13
Cxh3n xhn3 0 1e-13
Xih_0_3 a_xp0 a_xn0 wih_p_0_3 wih_n_0_3 xhp3 xhn3 vdd vbsyn gsyn
Xih_1_3 a_xp1 a_xn1 wih_p_1_3 wih_n_1_3 xhp3 xhn3 vdd vbsyn gsyn
Xih_2_3 a_xp2 a_xn2 wih_p_2_3 wih_n_2_3 xhp3 xhn3 vdd vbsyn gsyn
Xn3 xhp3 xhn3 ahp3 ahn3 vdd vbneu dneuron
Vwih_p_0_4 wih_p_0_4 0 0.643383333655023
Vwih_n_0_4 wih_n_0_4 0 0.356616666344977
Vwih_p_1_4 wih_p_1_4 0 0.426609605197966
Vwih_n_1_4 wih_n_1_4 0 0.573390394802034
Vwih_p_2_4 wih_p_2_4 0 0.3
Vwih_n_2_4 wih_n_2_4 0 0.779710110256914
Xcm_xh4 xhp4 xhn4 vdd cmld
Rnd_xh4 xhp4 xhn4 20k
Cxh4p xhp4 0 1e-13
Cxh4n xhn4 0 1e-13
Xih_0_4 a_xp0 a_xn0 wih_p_0_4 wih_n_0_4 xhp4 xhn4 vdd vbsyn gsyn
Xih_1_4 a_xp1 a_xn1 wih_p_1_4 wih_n_1_4 xhp4 xhn4 vdd vbsyn gsyn
Xih_2_4 a_xp2 a_xn2 wih_p_2_4 wih_n_2_4 xhp4 xhn4 vdd vbsyn gsyn
Xn4 xhp4 xhn4 ahp4 ahn4 vdd vbneu dneuron
Vwih_p_0_5 wih_p_0_5 0 0.3
Vwih_n_0_5 wih_n_0_5 0 0.9
Vwih_p_1_5 wih_p_1_5 0 0.3
Vwih_n_1_5 wih_n_1_5 0 0.9
Vwih_p_2_5 wih_p_2_5 0 0.9
Vwih_n_2_5 wih_n_2_5 0 0.3
Xcm_xh5 xhp5 xhn5 vdd cmld
Rnd_xh5 xhp5 xhn5 20k
Cxh5p xhp5 0 1e-13
Cxh5n xhn5 0 1e-13
Xih_0_5 a_xp0 a_xn0 wih_p_0_5 wih_n_0_5 xhp5 xhn5 vdd vbsyn gsyn
Xih_1_5 a_xp1 a_xn1 wih_p_1_5 wih_n_1_5 xhp5 xhn5 vdd vbsyn gsyn
Xih_2_5 a_xp2 a_xn2 wih_p_2_5 wih_n_2_5 xhp5 xhn5 vdd vbsyn gsyn
Xn5 xhp5 xhn5 ahp5 ahn5 vdd vbneu dneuron
Vwih_p_0_6 wih_p_0_6 0 0.4644227134047597
Vwih_n_0_6 wih_n_0_6 0 0.5355772865952403
Vwih_p_1_6 wih_p_1_6 0 0.3
Vwih_n_1_6 wih_n_1_6 0 0.9
Vwih_p_2_6 wih_p_2_6 0 0.3
Vwih_n_2_6 wih_n_2_6 0 0.9
Xcm_xh6 xhp6 xhn6 vdd cmld
Rnd_xh6 xhp6 xhn6 20k
Cxh6p xhp6 0 1e-13
Cxh6n xhn6 0 1e-13
Xih_0_6 a_xp0 a_xn0 wih_p_0_6 wih_n_0_6 xhp6 xhn6 vdd vbsyn gsyn
Xih_1_6 a_xp1 a_xn1 wih_p_1_6 wih_n_1_6 xhp6 xhn6 vdd vbsyn gsyn
Xih_2_6 a_xp2 a_xn2 wih_p_2_6 wih_n_2_6 xhp6 xhn6 vdd vbsyn gsyn
Xn6 xhp6 xhn6 ahp6 ahn6 vdd vbneu dneuron
Vwih_p_0_7 wih_p_0_7 0 0.8930428788399948
Vwih_n_0_7 wih_n_0_7 0 0.3
Vwih_p_1_7 wih_p_1_7 0 0.3
Vwih_n_1_7 wih_n_1_7 0 0.9
Vwih_p_2_7 wih_p_2_7 0 0.3
Vwih_n_2_7 wih_n_2_7 0 0.7814083238372862
Xcm_xh7 xhp7 xhn7 vdd cmld
Rnd_xh7 xhp7 xhn7 20k
Cxh7p xhp7 0 1e-13
Cxh7n xhn7 0 1e-13
Xih_0_7 a_xp0 a_xn0 wih_p_0_7 wih_n_0_7 xhp7 xhn7 vdd vbsyn gsyn
Xih_1_7 a_xp1 a_xn1 wih_p_1_7 wih_n_1_7 xhp7 xhn7 vdd vbsyn gsyn
Xih_2_7 a_xp2 a_xn2 wih_p_2_7 wih_n_2_7 xhp7 xhn7 vdd vbsyn gsyn
Xn7 xhp7 xhn7 ahp7 ahn7 vdd vbneu dneuron
Xcm_mo0 mop0 mon0 vdd cmld
Rmo0 mop0 mon0 25k
Cmo0p mop0 0 1e-13
Cmo0n mon0 0 1e-13
Cwp_0_0 who_p_0_0 0 20p
Cwn_0_0 who_n_0_0 0 20p
Rwp_0_0 who_p_0_0 wcm 200meg
Rwn_0_0 who_n_0_0 wcm 200meg
Xsyn_0_0 ahp0 ahn0 who_p_0_0 who_n_0_0 mop0 mon0 vdd vbsyn gsyn
Cwp_1_0 who_p_1_0 0 20p
Cwn_1_0 who_n_1_0 0 20p
Rwp_1_0 who_p_1_0 wcm 200meg
Rwn_1_0 who_n_1_0 wcm 200meg
Xsyn_1_0 ahp1 ahn1 who_p_1_0 who_n_1_0 mop0 mon0 vdd vbsyn gsyn
Cwp_2_0 who_p_2_0 0 20p
Cwn_2_0 who_n_2_0 0 20p
Rwp_2_0 who_p_2_0 wcm 200meg
Rwn_2_0 who_n_2_0 wcm 200meg
Xsyn_2_0 ahp2 ahn2 who_p_2_0 who_n_2_0 mop0 mon0 vdd vbsyn gsyn
Cwp_3_0 who_p_3_0 0 20p
Cwn_3_0 who_n_3_0 0 20p
Rwp_3_0 who_p_3_0 wcm 200meg
Rwn_3_0 who_n_3_0 wcm 200meg
Xsyn_3_0 ahp3 ahn3 who_p_3_0 who_n_3_0 mop0 mon0 vdd vbsyn gsyn
Cwp_4_0 who_p_4_0 0 20p
Cwn_4_0 who_n_4_0 0 20p
Rwp_4_0 who_p_4_0 wcm 200meg
Rwn_4_0 who_n_4_0 wcm 200meg
Xsyn_4_0 ahp4 ahn4 who_p_4_0 who_n_4_0 mop0 mon0 vdd vbsyn gsyn
Cwp_5_0 who_p_5_0 0 20p
Cwn_5_0 who_n_5_0 0 20p
Rwp_5_0 who_p_5_0 wcm 200meg
Rwn_5_0 who_n_5_0 wcm 200meg
Xsyn_5_0 ahp5 ahn5 who_p_5_0 who_n_5_0 mop0 mon0 vdd vbsyn gsyn
Cwp_6_0 who_p_6_0 0 20p
Cwn_6_0 who_n_6_0 0 20p
Rwp_6_0 who_p_6_0 wcm 200meg
Rwn_6_0 who_n_6_0 wcm 200meg
Xsyn_6_0 ahp6 ahn6 who_p_6_0 who_n_6_0 mop0 mon0 vdd vbsyn gsyn
Cwp_7_0 who_p_7_0 0 20p
Cwn_7_0 who_n_7_0 0 20p
Rwp_7_0 who_p_7_0 wcm 200meg
Rwn_7_0 who_n_7_0 wcm 200meg
Xsyn_7_0 ahp7 ahn7 who_p_7_0 who_n_7_0 mop0 mon0 vdd vbsyn gsyn
Xeo0 xop0 xon0 mop0 mon0 eop0 eon0 vdd gm esub
Xcm_mo1 mop1 mon1 vdd cmld
Rmo1 mop1 mon1 25k
Cmo1p mop1 0 1e-13
Cmo1n mon1 0 1e-13
Cwp_0_1 who_p_0_1 0 20p
Cwn_0_1 who_n_0_1 0 20p
Rwp_0_1 who_p_0_1 wcm 200meg
Rwn_0_1 who_n_0_1 wcm 200meg
Xsyn_0_1 ahp0 ahn0 who_p_0_1 who_n_0_1 mop1 mon1 vdd vbsyn gsyn
Cwp_1_1 who_p_1_1 0 20p
Cwn_1_1 who_n_1_1 0 20p
Rwp_1_1 who_p_1_1 wcm 200meg
Rwn_1_1 who_n_1_1 wcm 200meg
Xsyn_1_1 ahp1 ahn1 who_p_1_1 who_n_1_1 mop1 mon1 vdd vbsyn gsyn
Cwp_2_1 who_p_2_1 0 20p
Cwn_2_1 who_n_2_1 0 20p
Rwp_2_1 who_p_2_1 wcm 200meg
Rwn_2_1 who_n_2_1 wcm 200meg
Xsyn_2_1 ahp2 ahn2 who_p_2_1 who_n_2_1 mop1 mon1 vdd vbsyn gsyn
Cwp_3_1 who_p_3_1 0 20p
Cwn_3_1 who_n_3_1 0 20p
Rwp_3_1 who_p_3_1 wcm 200meg
Rwn_3_1 who_n_3_1 wcm 200meg
Xsyn_3_1 ahp3 ahn3 who_p_3_1 who_n_3_1 mop1 mon1 vdd vbsyn gsyn
Cwp_4_1 who_p_4_1 0 20p
Cwn_4_1 who_n_4_1 0 20p
Rwp_4_1 who_p_4_1 wcm 200meg
Rwn_4_1 who_n_4_1 wcm 200meg
Xsyn_4_1 ahp4 ahn4 who_p_4_1 who_n_4_1 mop1 mon1 vdd vbsyn gsyn
Cwp_5_1 who_p_5_1 0 20p
Cwn_5_1 who_n_5_1 0 20p
Rwp_5_1 who_p_5_1 wcm 200meg
Rwn_5_1 who_n_5_1 wcm 200meg
Xsyn_5_1 ahp5 ahn5 who_p_5_1 who_n_5_1 mop1 mon1 vdd vbsyn gsyn
Cwp_6_1 who_p_6_1 0 20p
Cwn_6_1 who_n_6_1 0 20p
Rwp_6_1 who_p_6_1 wcm 200meg
Rwn_6_1 who_n_6_1 wcm 200meg
Xsyn_6_1 ahp6 ahn6 who_p_6_1 who_n_6_1 mop1 mon1 vdd vbsyn gsyn
Cwp_7_1 who_p_7_1 0 20p
Cwn_7_1 who_n_7_1 0 20p
Rwp_7_1 who_p_7_1 wcm 200meg
Rwn_7_1 who_n_7_1 wcm 200meg
Xsyn_7_1 ahp7 ahn7 who_p_7_1 who_n_7_1 mop1 mon1 vdd vbsyn gsyn
Xeo1 xop1 xon1 mop1 mon1 eop1 eon1 vdd gm esub
Xlrn_0_0 eop0 eon0 ahp0 ahn0 who_p_0_0 who_n_0_0 vdd gbl gprod
Xlrn_1_0 eop0 eon0 ahp1 ahn1 who_p_1_0 who_n_1_0 vdd gbl gprod
Xlrn_2_0 eop0 eon0 ahp2 ahn2 who_p_2_0 who_n_2_0 vdd gbl gprod
Xlrn_3_0 eop0 eon0 ahp3 ahn3 who_p_3_0 who_n_3_0 vdd gbl gprod
Xlrn_4_0 eop0 eon0 ahp4 ahn4 who_p_4_0 who_n_4_0 vdd gbl gprod
Xlrn_5_0 eop0 eon0 ahp5 ahn5 who_p_5_0 who_n_5_0 vdd gbl gprod
Xlrn_6_0 eop0 eon0 ahp6 ahn6 who_p_6_0 who_n_6_0 vdd gbl gprod
Xlrn_7_0 eop0 eon0 ahp7 ahn7 who_p_7_0 who_n_7_0 vdd gbl gprod
Xlrn_0_1 eop1 eon1 ahp0 ahn0 who_p_0_1 who_n_0_1 vdd gbl gprod
Xlrn_1_1 eop1 eon1 ahp1 ahn1 who_p_1_1 who_n_1_1 vdd gbl gprod
Xlrn_2_1 eop1 eon1 ahp2 ahn2 who_p_2_1 who_n_2_1 vdd gbl gprod
Xlrn_3_1 eop1 eon1 ahp3 ahn3 who_p_3_1 who_n_3_1 vdd gbl gprod
Xlrn_4_1 eop1 eon1 ahp4 ahn4 who_p_4_1 who_n_4_1 vdd gbl gprod
Xlrn_5_1 eop1 eon1 ahp5 ahn5 who_p_5_1 who_n_5_1 vdd gbl gprod
Xlrn_6_1 eop1 eon1 ahp6 ahn6 who_p_6_1 who_n_6_1 vdd gbl gprod
Xlrn_7_1 eop1 eon1 ahp7 ahn7 who_p_7_1 who_n_7_1 vdd gbl gprod
.ic v(who_p_0_0)=0.5 v(who_n_0_0)=0.5
.ic v(who_p_1_0)=0.5 v(who_n_1_0)=0.5
.ic v(who_p_2_0)=0.5 v(who_n_2_0)=0.5
.ic v(who_p_3_0)=0.5 v(who_n_3_0)=0.5
.ic v(who_p_4_0)=0.5 v(who_n_4_0)=0.5
.ic v(who_p_5_0)=0.5 v(who_n_5_0)=0.5
.ic v(who_p_6_0)=0.5 v(who_n_6_0)=0.5
.ic v(who_p_7_0)=0.5 v(who_n_7_0)=0.5
.ic v(who_p_0_1)=0.5 v(who_n_0_1)=0.5
.ic v(who_p_1_1)=0.5 v(who_n_1_1)=0.5
.ic v(who_p_2_1)=0.5 v(who_n_2_1)=0.5
.ic v(who_p_3_1)=0.5 v(who_n_3_1)=0.5
.ic v(who_p_4_1)=0.5 v(who_n_4_1)=0.5
.ic v(who_p_5_1)=0.5 v(who_n_5_1)=0.5
.ic v(who_p_6_1)=0.5 v(who_n_6_1)=0.5
.ic v(who_p_7_1)=0.5 v(who_n_7_1)=0.5
.options gmin=1e-10 reltol=2e-3 cshunt=1e-14 method=gear
.control
tran 2n 183600n uic
wrdata ps_h8.dat v(mop0) v(mon0) v(mop1) v(mon1) v(ahp0) v(ahn0) v(ahp1) v(ahn1) v(ahp2) v(ahn2) v(ahp3) v(ahn3) v(ahp4) v(ahn4) v(ahp5) v(ahn5) v(ahp6) v(ahn6) v(ahp7) v(ahn7) v(who_p_0_0) v(who_n_0_0) v(who_p_1_0) v(who_n_1_0) v(who_p_2_0) v(who_n_2_0) v(who_p_3_0) v(who_n_3_0) v(who_p_4_0) v(who_n_4_0) v(who_p_5_0) v(who_n_5_0) v(who_p_6_0) v(who_n_6_0) v(who_p_7_0) v(who_n_7_0) v(who_p_0_1) v(who_n_0_1) v(who_p_1_1) v(who_n_1_1) v(who_p_2_1) v(who_n_2_1) v(who_p_3_1) v(who_n_3_1) v(who_p_4_1) v(who_n_4_1) v(who_p_5_1) v(who_n_5_1) v(who_p_6_1) v(who_n_6_1) v(who_p_7_1) v(who_n_7_1)
.endc
.end
