* Physical random features + PERAZ analog delta-rule readout
* MIT; Thomas Dybdahl Ahle and contributors; see generate.py and README.md
* Family adaptation, NOT a reproduction of the historical Python-feature score.
Rtailbiashi vdd n_tailbias 5333.33333333
Rtailbiaslo n_tailbias 0 4666.66666667
Rfixed0_0hi vdd n_fixed0_0 38894.4031844
Rfixed0_0lo n_fixed0_0 0 61105.5968156
Mfp0_0 in4 n_fixed0_0 n_hp0 0 syn W=10u L=1u
Mfn0_0 in4 vweight n_hn0 0 syn W=10u L=1u
Rfixed0_1hi vdd n_fixed0_1 52742.3941829
Rfixed0_1lo n_fixed0_1 0 47257.6058171
Mfp0_1 in9 n_fixed0_1 n_hp0 0 syn W=10u L=1u
Mfn0_1 in9 vweight n_hn0 0 syn W=10u L=1u
Rfixed0_2hi vdd n_fixed0_2 58202.8869184
Rfixed0_2lo n_fixed0_2 0 41797.1130816
Mfp0_2 in13 n_fixed0_2 n_hp0 0 syn W=10u L=1u
Mfn0_2 in13 vweight n_hn0 0 syn W=10u L=1u
Rfixed0_3hi vdd n_fixed0_3 39477.7580528
Rfixed0_3lo n_fixed0_3 0 60522.2419472
Mfp0_3 in12 n_fixed0_3 n_hp0 0 syn W=10u L=1u
Mfn0_3 in12 vweight n_hn0 0 syn W=10u L=1u
Rfixed0_4hi vdd n_fixed0_4 48517.5264168
Rfixed0_4lo n_fixed0_4 0 51482.4735832
Mfp0_4 vbias n_fixed0_4 n_hp0 0 syn W=10u L=1u
Mfn0_4 vbias vweight n_hn0 0 syn W=10u L=1u
Mh0a n_hn0 n_hn0 0 0 nch W=20u L=1u
Mh0b n_z0 n_hn0 0 0 nch W=20u L=1u
Mh0c n_hp0 n_hp0 0 0 nch W=20u L=1u
Mh0d n_mirrorh0 n_hp0 0 0 nch W=20u L=1u
Mh0e n_mirrorh0 n_mirrorh0 vdd vdd pch W=60u L=1u
Mh0f n_z0 n_mirrorh0 vdd vdd pch W=60u L=1u
Rh0sum n_z0 vref 8000
Mactp0 n_dd0 n_z0 n_tail0 0 nch W=12u L=1u
Mactn0 n_dm0 vref n_tail0 0 nch W=12u L=1u
Macttail0 n_tail0 n_tailbias 0 0 nch W=32u L=1u
Mactload0 n_dm0 n_dm0 vdd vdd pch W=40u L=1u
Mactmirror0 n_dd0 n_dd0 vdd vdd pch W=40u L=1u
Mactout0 n_hv0 n_dd0 vdd vdd pch W=40u L=1u
Rhvlo0 n_hv0 vref 9600
Rhvhi0 n_hv0 vbias 48000
Rfixed1_0hi vdd n_fixed1_0 63947.1574184
Rfixed1_0lo n_fixed1_0 0 36052.8425816
Mfp1_0 in3 n_fixed1_0 n_hp1 0 syn W=10u L=1u
Mfn1_0 in3 vweight n_hn1 0 syn W=10u L=1u
Rfixed1_1hi vdd n_fixed1_1 65767.9557435
Rfixed1_1lo n_fixed1_1 0 34232.0442565
Mfp1_1 in7 n_fixed1_1 n_hp1 0 syn W=10u L=1u
Mfn1_1 in7 vweight n_hn1 0 syn W=10u L=1u
Rfixed1_2hi vdd n_fixed1_2 28417.3372474
Rfixed1_2lo n_fixed1_2 0 71582.6627526
Mfp1_2 in0 n_fixed1_2 n_hp1 0 syn W=10u L=1u
Mfn1_2 in0 vweight n_hn1 0 syn W=10u L=1u
Rfixed1_3hi vdd n_fixed1_3 21904.8527084
Rfixed1_3lo n_fixed1_3 0 78095.1472916
Mfp1_3 in6 n_fixed1_3 n_hp1 0 syn W=10u L=1u
Mfn1_3 in6 vweight n_hn1 0 syn W=10u L=1u
Rfixed1_4hi vdd n_fixed1_4 39880.2689713
Rfixed1_4lo n_fixed1_4 0 60119.7310287
Mfp1_4 vbias n_fixed1_4 n_hp1 0 syn W=10u L=1u
Mfn1_4 vbias vweight n_hn1 0 syn W=10u L=1u
Mh1a n_hn1 n_hn1 0 0 nch W=20u L=1u
Mh1b n_z1 n_hn1 0 0 nch W=20u L=1u
Mh1c n_hp1 n_hp1 0 0 nch W=20u L=1u
Mh1d n_mirrorh1 n_hp1 0 0 nch W=20u L=1u
Mh1e n_mirrorh1 n_mirrorh1 vdd vdd pch W=60u L=1u
Mh1f n_z1 n_mirrorh1 vdd vdd pch W=60u L=1u
Rh1sum n_z1 vref 8000
Mactp1 n_dd1 n_z1 n_tail1 0 nch W=12u L=1u
Mactn1 n_dm1 vref n_tail1 0 nch W=12u L=1u
Macttail1 n_tail1 n_tailbias 0 0 nch W=32u L=1u
Mactload1 n_dm1 n_dm1 vdd vdd pch W=40u L=1u
Mactmirror1 n_dd1 n_dd1 vdd vdd pch W=40u L=1u
Mactout1 n_hv1 n_dd1 vdd vdd pch W=40u L=1u
Rhvlo1 n_hv1 vref 9600
Rhvhi1 n_hv1 vbias 48000
Rfixed2_0hi vdd n_fixed2_0 36285.5619105
Rfixed2_0lo n_fixed2_0 0 63714.4380895
Mfp2_0 in7 n_fixed2_0 n_hp2 0 syn W=10u L=1u
Mfn2_0 in7 vweight n_hn2 0 syn W=10u L=1u
Rfixed2_1hi vdd n_fixed2_1 39277.1524964
Rfixed2_1lo n_fixed2_1 0 60722.8475036
Mfp2_1 in9 n_fixed2_1 n_hp2 0 syn W=10u L=1u
Mfn2_1 in9 vweight n_hn2 0 syn W=10u L=1u
Rfixed2_2hi vdd n_fixed2_2 78108.3211286
Rfixed2_2lo n_fixed2_2 0 21891.6788714
Mfp2_2 in1 n_fixed2_2 n_hp2 0 syn W=10u L=1u
Mfn2_2 in1 vweight n_hn2 0 syn W=10u L=1u
Rfixed2_3hi vdd n_fixed2_3 50145.887241
Rfixed2_3lo n_fixed2_3 0 49854.112759
Mfp2_3 in5 n_fixed2_3 n_hp2 0 syn W=10u L=1u
Mfn2_3 in5 vweight n_hn2 0 syn W=10u L=1u
Rfixed2_4hi vdd n_fixed2_4 44274.6334556
Rfixed2_4lo n_fixed2_4 0 55725.3665444
Mfp2_4 vbias n_fixed2_4 n_hp2 0 syn W=10u L=1u
Mfn2_4 vbias vweight n_hn2 0 syn W=10u L=1u
Mh2a n_hn2 n_hn2 0 0 nch W=20u L=1u
Mh2b n_z2 n_hn2 0 0 nch W=20u L=1u
Mh2c n_hp2 n_hp2 0 0 nch W=20u L=1u
Mh2d n_mirrorh2 n_hp2 0 0 nch W=20u L=1u
Mh2e n_mirrorh2 n_mirrorh2 vdd vdd pch W=60u L=1u
Mh2f n_z2 n_mirrorh2 vdd vdd pch W=60u L=1u
Rh2sum n_z2 vref 8000
Mactp2 n_dd2 n_z2 n_tail2 0 nch W=12u L=1u
Mactn2 n_dm2 vref n_tail2 0 nch W=12u L=1u
Macttail2 n_tail2 n_tailbias 0 0 nch W=32u L=1u
Mactload2 n_dm2 n_dm2 vdd vdd pch W=40u L=1u
Mactmirror2 n_dd2 n_dd2 vdd vdd pch W=40u L=1u
Mactout2 n_hv2 n_dd2 vdd vdd pch W=40u L=1u
Rhvlo2 n_hv2 vref 9600
Rhvhi2 n_hv2 vbias 48000
Rfixed3_0hi vdd n_fixed3_0 32092.5790234
Rfixed3_0lo n_fixed3_0 0 67907.4209766
Mfp3_0 in13 n_fixed3_0 n_hp3 0 syn W=10u L=1u
Mfn3_0 in13 vweight n_hn3 0 syn W=10u L=1u
Rfixed3_1hi vdd n_fixed3_1 36834.8305628
Rfixed3_1lo n_fixed3_1 0 63165.1694372
Mfp3_1 in11 n_fixed3_1 n_hp3 0 syn W=10u L=1u
Mfn3_1 in11 vweight n_hn3 0 syn W=10u L=1u
Rfixed3_2hi vdd n_fixed3_2 22392.8596844
Rfixed3_2lo n_fixed3_2 0 77607.1403156
Mfp3_2 in0 n_fixed3_2 n_hp3 0 syn W=10u L=1u
Mfn3_2 in0 vweight n_hn3 0 syn W=10u L=1u
Rfixed3_3hi vdd n_fixed3_3 52137.9775219
Rfixed3_3lo n_fixed3_3 0 47862.0224781
Mfp3_3 in8 n_fixed3_3 n_hp3 0 syn W=10u L=1u
Mfn3_3 in8 vweight n_hn3 0 syn W=10u L=1u
Rfixed3_4hi vdd n_fixed3_4 39840.2730915
Rfixed3_4lo n_fixed3_4 0 60159.7269085
Mfp3_4 vbias n_fixed3_4 n_hp3 0 syn W=10u L=1u
Mfn3_4 vbias vweight n_hn3 0 syn W=10u L=1u
Mh3a n_hn3 n_hn3 0 0 nch W=20u L=1u
Mh3b n_z3 n_hn3 0 0 nch W=20u L=1u
Mh3c n_hp3 n_hp3 0 0 nch W=20u L=1u
Mh3d n_mirrorh3 n_hp3 0 0 nch W=20u L=1u
Mh3e n_mirrorh3 n_mirrorh3 vdd vdd pch W=60u L=1u
Mh3f n_z3 n_mirrorh3 vdd vdd pch W=60u L=1u
Rh3sum n_z3 vref 8000
Mactp3 n_dd3 n_z3 n_tail3 0 nch W=12u L=1u
Mactn3 n_dm3 vref n_tail3 0 nch W=12u L=1u
Macttail3 n_tail3 n_tailbias 0 0 nch W=32u L=1u
Mactload3 n_dm3 n_dm3 vdd vdd pch W=40u L=1u
Mactmirror3 n_dd3 n_dd3 vdd vdd pch W=40u L=1u
Mactout3 n_hv3 n_dd3 vdd vdd pch W=40u L=1u
Rhvlo3 n_hv3 vref 9600
Rhvhi3 n_hv3 vbias 48000
Rfixed4_0hi vdd n_fixed4_0 53345.9800847
Rfixed4_0lo n_fixed4_0 0 46654.0199153
Mfp4_0 in7 n_fixed4_0 n_hp4 0 syn W=10u L=1u
Mfn4_0 in7 vweight n_hn4 0 syn W=10u L=1u
Rfixed4_1hi vdd n_fixed4_1 36537.8684151
Rfixed4_1lo n_fixed4_1 0 63462.1315849
Mfp4_1 in10 n_fixed4_1 n_hp4 0 syn W=10u L=1u
Mfn4_1 in10 vweight n_hn4 0 syn W=10u L=1u
Rfixed4_2hi vdd n_fixed4_2 8512.59980081
Rfixed4_2lo n_fixed4_2 0 91487.4001992
Mfp4_2 in3 n_fixed4_2 n_hp4 0 syn W=10u L=1u
Mfn4_2 in3 vweight n_hn4 0 syn W=10u L=1u
Rfixed4_3hi vdd n_fixed4_3 35722.4244756
Rfixed4_3lo n_fixed4_3 0 64277.5755244
Mfp4_3 in12 n_fixed4_3 n_hp4 0 syn W=10u L=1u
Mfn4_3 in12 vweight n_hn4 0 syn W=10u L=1u
Rfixed4_4hi vdd n_fixed4_4 51205.3418225
Rfixed4_4lo n_fixed4_4 0 48794.6581775
Mfp4_4 vbias n_fixed4_4 n_hp4 0 syn W=10u L=1u
Mfn4_4 vbias vweight n_hn4 0 syn W=10u L=1u
Mh4a n_hn4 n_hn4 0 0 nch W=20u L=1u
Mh4b n_z4 n_hn4 0 0 nch W=20u L=1u
Mh4c n_hp4 n_hp4 0 0 nch W=20u L=1u
Mh4d n_mirrorh4 n_hp4 0 0 nch W=20u L=1u
Mh4e n_mirrorh4 n_mirrorh4 vdd vdd pch W=60u L=1u
Mh4f n_z4 n_mirrorh4 vdd vdd pch W=60u L=1u
Rh4sum n_z4 vref 8000
Mactp4 n_dd4 n_z4 n_tail4 0 nch W=12u L=1u
Mactn4 n_dm4 vref n_tail4 0 nch W=12u L=1u
Macttail4 n_tail4 n_tailbias 0 0 nch W=32u L=1u
Mactload4 n_dm4 n_dm4 vdd vdd pch W=40u L=1u
Mactmirror4 n_dd4 n_dd4 vdd vdd pch W=40u L=1u
Mactout4 n_hv4 n_dd4 vdd vdd pch W=40u L=1u
Rhvlo4 n_hv4 vref 9600
Rhvhi4 n_hv4 vbias 48000
Rfixed5_0hi vdd n_fixed5_0 48300.4397159
Rfixed5_0lo n_fixed5_0 0 51699.5602841
Mfp5_0 in5 n_fixed5_0 n_hp5 0 syn W=10u L=1u
Mfn5_0 in5 vweight n_hn5 0 syn W=10u L=1u
Rfixed5_1hi vdd n_fixed5_1 29129.6629365
Rfixed5_1lo n_fixed5_1 0 70870.3370635
Mfp5_1 in10 n_fixed5_1 n_hp5 0 syn W=10u L=1u
Mfn5_1 in10 vweight n_hn5 0 syn W=10u L=1u
Rfixed5_2hi vdd n_fixed5_2 29677.0822971
Rfixed5_2lo n_fixed5_2 0 70322.9177029
Mfp5_2 in11 n_fixed5_2 n_hp5 0 syn W=10u L=1u
Mfn5_2 in11 vweight n_hn5 0 syn W=10u L=1u
Rfixed5_3hi vdd n_fixed5_3 44681.2238364
Rfixed5_3lo n_fixed5_3 0 55318.7761636
Mfp5_3 in4 n_fixed5_3 n_hp5 0 syn W=10u L=1u
Mfn5_3 in4 vweight n_hn5 0 syn W=10u L=1u
Rfixed5_4hi vdd n_fixed5_4 52923.6402261
Rfixed5_4lo n_fixed5_4 0 47076.3597739
Mfp5_4 vbias n_fixed5_4 n_hp5 0 syn W=10u L=1u
Mfn5_4 vbias vweight n_hn5 0 syn W=10u L=1u
Mh5a n_hn5 n_hn5 0 0 nch W=20u L=1u
Mh5b n_z5 n_hn5 0 0 nch W=20u L=1u
Mh5c n_hp5 n_hp5 0 0 nch W=20u L=1u
Mh5d n_mirrorh5 n_hp5 0 0 nch W=20u L=1u
Mh5e n_mirrorh5 n_mirrorh5 vdd vdd pch W=60u L=1u
Mh5f n_z5 n_mirrorh5 vdd vdd pch W=60u L=1u
Rh5sum n_z5 vref 8000
Mactp5 n_dd5 n_z5 n_tail5 0 nch W=12u L=1u
Mactn5 n_dm5 vref n_tail5 0 nch W=12u L=1u
Macttail5 n_tail5 n_tailbias 0 0 nch W=32u L=1u
Mactload5 n_dm5 n_dm5 vdd vdd pch W=40u L=1u
Mactmirror5 n_dd5 n_dd5 vdd vdd pch W=40u L=1u
Mactout5 n_hv5 n_dd5 vdd vdd pch W=40u L=1u
Rhvlo5 n_hv5 vref 9600
Rhvhi5 n_hv5 vbias 48000
Rfixed6_0hi vdd n_fixed6_0 34971.2565064
Rfixed6_0lo n_fixed6_0 0 65028.7434936
Mfp6_0 in13 n_fixed6_0 n_hp6 0 syn W=10u L=1u
Mfn6_0 in13 vweight n_hn6 0 syn W=10u L=1u
Rfixed6_1hi vdd n_fixed6_1 27333.7972463
Rfixed6_1lo n_fixed6_1 0 72666.2027537
Mfp6_1 in8 n_fixed6_1 n_hp6 0 syn W=10u L=1u
Mfn6_1 in8 vweight n_hn6 0 syn W=10u L=1u
Rfixed6_2hi vdd n_fixed6_2 20666.69066
Rfixed6_2lo n_fixed6_2 0 79333.30934
Mfp6_2 in15 n_fixed6_2 n_hp6 0 syn W=10u L=1u
Mfn6_2 in15 vweight n_hn6 0 syn W=10u L=1u
Rfixed6_3hi vdd n_fixed6_3 43255.2333359
Rfixed6_3lo n_fixed6_3 0 56744.7666641
Mfp6_3 in10 n_fixed6_3 n_hp6 0 syn W=10u L=1u
Mfn6_3 in10 vweight n_hn6 0 syn W=10u L=1u
Rfixed6_4hi vdd n_fixed6_4 32235.8646187
Rfixed6_4lo n_fixed6_4 0 67764.1353813
Mfp6_4 vbias n_fixed6_4 n_hp6 0 syn W=10u L=1u
Mfn6_4 vbias vweight n_hn6 0 syn W=10u L=1u
Mh6a n_hn6 n_hn6 0 0 nch W=20u L=1u
Mh6b n_z6 n_hn6 0 0 nch W=20u L=1u
Mh6c n_hp6 n_hp6 0 0 nch W=20u L=1u
Mh6d n_mirrorh6 n_hp6 0 0 nch W=20u L=1u
Mh6e n_mirrorh6 n_mirrorh6 vdd vdd pch W=60u L=1u
Mh6f n_z6 n_mirrorh6 vdd vdd pch W=60u L=1u
Rh6sum n_z6 vref 8000
Mactp6 n_dd6 n_z6 n_tail6 0 nch W=12u L=1u
Mactn6 n_dm6 vref n_tail6 0 nch W=12u L=1u
Macttail6 n_tail6 n_tailbias 0 0 nch W=32u L=1u
Mactload6 n_dm6 n_dm6 vdd vdd pch W=40u L=1u
Mactmirror6 n_dd6 n_dd6 vdd vdd pch W=40u L=1u
Mactout6 n_hv6 n_dd6 vdd vdd pch W=40u L=1u
Rhvlo6 n_hv6 vref 9600
Rhvhi6 n_hv6 vbias 48000
Rfixed7_0hi vdd n_fixed7_0 46045.2132387
Rfixed7_0lo n_fixed7_0 0 53954.7867613
Mfp7_0 in1 n_fixed7_0 n_hp7 0 syn W=10u L=1u
Mfn7_0 in1 vweight n_hn7 0 syn W=10u L=1u
Rfixed7_1hi vdd n_fixed7_1 34940.7548696
Rfixed7_1lo n_fixed7_1 0 65059.2451304
Mfp7_1 in7 n_fixed7_1 n_hp7 0 syn W=10u L=1u
Mfn7_1 in7 vweight n_hn7 0 syn W=10u L=1u
Rfixed7_2hi vdd n_fixed7_2 56480.6070829
Rfixed7_2lo n_fixed7_2 0 43519.3929171
Mfp7_2 in3 n_fixed7_2 n_hp7 0 syn W=10u L=1u
Mfn7_2 in3 vweight n_hn7 0 syn W=10u L=1u
Rfixed7_3hi vdd n_fixed7_3 30220.1381031
Rfixed7_3lo n_fixed7_3 0 69779.8618969
Mfp7_3 in11 n_fixed7_3 n_hp7 0 syn W=10u L=1u
Mfn7_3 in11 vweight n_hn7 0 syn W=10u L=1u
Rfixed7_4hi vdd n_fixed7_4 30692.8971572
Rfixed7_4lo n_fixed7_4 0 69307.1028428
Mfp7_4 vbias n_fixed7_4 n_hp7 0 syn W=10u L=1u
Mfn7_4 vbias vweight n_hn7 0 syn W=10u L=1u
Mh7a n_hn7 n_hn7 0 0 nch W=20u L=1u
Mh7b n_z7 n_hn7 0 0 nch W=20u L=1u
Mh7c n_hp7 n_hp7 0 0 nch W=20u L=1u
Mh7d n_mirrorh7 n_hp7 0 0 nch W=20u L=1u
Mh7e n_mirrorh7 n_mirrorh7 vdd vdd pch W=60u L=1u
Mh7f n_z7 n_mirrorh7 vdd vdd pch W=60u L=1u
Rh7sum n_z7 vref 8000
Mactp7 n_dd7 n_z7 n_tail7 0 nch W=12u L=1u
Mactn7 n_dm7 vref n_tail7 0 nch W=12u L=1u
Macttail7 n_tail7 n_tailbias 0 0 nch W=32u L=1u
Mactload7 n_dm7 n_dm7 vdd vdd pch W=40u L=1u
Mactmirror7 n_dd7 n_dd7 vdd vdd pch W=40u L=1u
Mactout7 n_hv7 n_dd7 vdd vdd pch W=40u L=1u
Rhvlo7 n_hv7 vref 9600
Rhvhi7 n_hv7 vbias 48000
Rfixed8_0hi vdd n_fixed8_0 68894.9531973
Rfixed8_0lo n_fixed8_0 0 31105.0468027
Mfp8_0 in11 n_fixed8_0 n_hp8 0 syn W=10u L=1u
Mfn8_0 in11 vweight n_hn8 0 syn W=10u L=1u
Rfixed8_1hi vdd n_fixed8_1 41531.2797968
Rfixed8_1lo n_fixed8_1 0 58468.7202032
Mfp8_1 in1 n_fixed8_1 n_hp8 0 syn W=10u L=1u
Mfn8_1 in1 vweight n_hn8 0 syn W=10u L=1u
Rfixed8_2hi vdd n_fixed8_2 56516.8047524
Rfixed8_2lo n_fixed8_2 0 43483.1952476
Mfp8_2 in7 n_fixed8_2 n_hp8 0 syn W=10u L=1u
Mfn8_2 in7 vweight n_hn8 0 syn W=10u L=1u
Rfixed8_3hi vdd n_fixed8_3 42185.574033
Rfixed8_3lo n_fixed8_3 0 57814.425967
Mfp8_3 in10 n_fixed8_3 n_hp8 0 syn W=10u L=1u
Mfn8_3 in10 vweight n_hn8 0 syn W=10u L=1u
Rfixed8_4hi vdd n_fixed8_4 42037.6798896
Rfixed8_4lo n_fixed8_4 0 57962.3201104
Mfp8_4 vbias n_fixed8_4 n_hp8 0 syn W=10u L=1u
Mfn8_4 vbias vweight n_hn8 0 syn W=10u L=1u
Mh8a n_hn8 n_hn8 0 0 nch W=20u L=1u
Mh8b n_z8 n_hn8 0 0 nch W=20u L=1u
Mh8c n_hp8 n_hp8 0 0 nch W=20u L=1u
Mh8d n_mirrorh8 n_hp8 0 0 nch W=20u L=1u
Mh8e n_mirrorh8 n_mirrorh8 vdd vdd pch W=60u L=1u
Mh8f n_z8 n_mirrorh8 vdd vdd pch W=60u L=1u
Rh8sum n_z8 vref 8000
Mactp8 n_dd8 n_z8 n_tail8 0 nch W=12u L=1u
Mactn8 n_dm8 vref n_tail8 0 nch W=12u L=1u
Macttail8 n_tail8 n_tailbias 0 0 nch W=32u L=1u
Mactload8 n_dm8 n_dm8 vdd vdd pch W=40u L=1u
Mactmirror8 n_dd8 n_dd8 vdd vdd pch W=40u L=1u
Mactout8 n_hv8 n_dd8 vdd vdd pch W=40u L=1u
Rhvlo8 n_hv8 vref 9600
Rhvhi8 n_hv8 vbias 48000
Rfixed9_0hi vdd n_fixed9_0 39735.7202788
Rfixed9_0lo n_fixed9_0 0 60264.2797212
Mfp9_0 in1 n_fixed9_0 n_hp9 0 syn W=10u L=1u
Mfn9_0 in1 vweight n_hn9 0 syn W=10u L=1u
Rfixed9_1hi vdd n_fixed9_1 53893.669358
Rfixed9_1lo n_fixed9_1 0 46106.330642
Mfp9_1 in4 n_fixed9_1 n_hp9 0 syn W=10u L=1u
Mfn9_1 in4 vweight n_hn9 0 syn W=10u L=1u
Rfixed9_2hi vdd n_fixed9_2 49212.1188494
Rfixed9_2lo n_fixed9_2 0 50787.8811506
Mfp9_2 in11 n_fixed9_2 n_hp9 0 syn W=10u L=1u
Mfn9_2 in11 vweight n_hn9 0 syn W=10u L=1u
Rfixed9_3hi vdd n_fixed9_3 30553.6305409
Rfixed9_3lo n_fixed9_3 0 69446.3694591
Mfp9_3 in9 n_fixed9_3 n_hp9 0 syn W=10u L=1u
Mfn9_3 in9 vweight n_hn9 0 syn W=10u L=1u
Rfixed9_4hi vdd n_fixed9_4 31363.7284842
Rfixed9_4lo n_fixed9_4 0 68636.2715158
Mfp9_4 vbias n_fixed9_4 n_hp9 0 syn W=10u L=1u
Mfn9_4 vbias vweight n_hn9 0 syn W=10u L=1u
Mh9a n_hn9 n_hn9 0 0 nch W=20u L=1u
Mh9b n_z9 n_hn9 0 0 nch W=20u L=1u
Mh9c n_hp9 n_hp9 0 0 nch W=20u L=1u
Mh9d n_mirrorh9 n_hp9 0 0 nch W=20u L=1u
Mh9e n_mirrorh9 n_mirrorh9 vdd vdd pch W=60u L=1u
Mh9f n_z9 n_mirrorh9 vdd vdd pch W=60u L=1u
Rh9sum n_z9 vref 8000
Mactp9 n_dd9 n_z9 n_tail9 0 nch W=12u L=1u
Mactn9 n_dm9 vref n_tail9 0 nch W=12u L=1u
Macttail9 n_tail9 n_tailbias 0 0 nch W=32u L=1u
Mactload9 n_dm9 n_dm9 vdd vdd pch W=40u L=1u
Mactmirror9 n_dd9 n_dd9 vdd vdd pch W=40u L=1u
Mactout9 n_hv9 n_dd9 vdd vdd pch W=40u L=1u
Rhvlo9 n_hv9 vref 9600
Rhvhi9 n_hv9 vbias 48000
Rfixed10_0hi vdd n_fixed10_0 21580.2197015
Rfixed10_0lo n_fixed10_0 0 78419.7802985
Mfp10_0 in0 n_fixed10_0 n_hp10 0 syn W=10u L=1u
Mfn10_0 in0 vweight n_hn10 0 syn W=10u L=1u
Rfixed10_1hi vdd n_fixed10_1 50113.3368898
Rfixed10_1lo n_fixed10_1 0 49886.6631102
Mfp10_1 in12 n_fixed10_1 n_hp10 0 syn W=10u L=1u
Mfn10_1 in12 vweight n_hn10 0 syn W=10u L=1u
Rfixed10_2hi vdd n_fixed10_2 52624.3099908
Rfixed10_2lo n_fixed10_2 0 47375.6900092
Mfp10_2 in3 n_fixed10_2 n_hp10 0 syn W=10u L=1u
Mfn10_2 in3 vweight n_hn10 0 syn W=10u L=1u
Rfixed10_3hi vdd n_fixed10_3 31357.1689744
Rfixed10_3lo n_fixed10_3 0 68642.8310256
Mfp10_3 in8 n_fixed10_3 n_hp10 0 syn W=10u L=1u
Mfn10_3 in8 vweight n_hn10 0 syn W=10u L=1u
Rfixed10_4hi vdd n_fixed10_4 35527.8740557
Rfixed10_4lo n_fixed10_4 0 64472.1259443
Mfp10_4 vbias n_fixed10_4 n_hp10 0 syn W=10u L=1u
Mfn10_4 vbias vweight n_hn10 0 syn W=10u L=1u
Mh10a n_hn10 n_hn10 0 0 nch W=20u L=1u
Mh10b n_z10 n_hn10 0 0 nch W=20u L=1u
Mh10c n_hp10 n_hp10 0 0 nch W=20u L=1u
Mh10d n_mirrorh10 n_hp10 0 0 nch W=20u L=1u
Mh10e n_mirrorh10 n_mirrorh10 vdd vdd pch W=60u L=1u
Mh10f n_z10 n_mirrorh10 vdd vdd pch W=60u L=1u
Rh10sum n_z10 vref 8000
Mactp10 n_dd10 n_z10 n_tail10 0 nch W=12u L=1u
Mactn10 n_dm10 vref n_tail10 0 nch W=12u L=1u
Macttail10 n_tail10 n_tailbias 0 0 nch W=32u L=1u
Mactload10 n_dm10 n_dm10 vdd vdd pch W=40u L=1u
Mactmirror10 n_dd10 n_dd10 vdd vdd pch W=40u L=1u
Mactout10 n_hv10 n_dd10 vdd vdd pch W=40u L=1u
Rhvlo10 n_hv10 vref 9600
Rhvhi10 n_hv10 vbias 48000
Rfixed11_0hi vdd n_fixed11_0 52733.01621
Rfixed11_0lo n_fixed11_0 0 47266.98379
Mfp11_0 in8 n_fixed11_0 n_hp11 0 syn W=10u L=1u
Mfn11_0 in8 vweight n_hn11 0 syn W=10u L=1u
Rfixed11_1hi vdd n_fixed11_1 38280.8636843
Rfixed11_1lo n_fixed11_1 0 61719.1363157
Mfp11_1 in10 n_fixed11_1 n_hp11 0 syn W=10u L=1u
Mfn11_1 in10 vweight n_hn11 0 syn W=10u L=1u
Rfixed11_2hi vdd n_fixed11_2 40474.7604164
Rfixed11_2lo n_fixed11_2 0 59525.2395836
Mfp11_2 in15 n_fixed11_2 n_hp11 0 syn W=10u L=1u
Mfn11_2 in15 vweight n_hn11 0 syn W=10u L=1u
Rfixed11_3hi vdd n_fixed11_3 33516.5930639
Rfixed11_3lo n_fixed11_3 0 66483.4069361
Mfp11_3 in9 n_fixed11_3 n_hp11 0 syn W=10u L=1u
Mfn11_3 in9 vweight n_hn11 0 syn W=10u L=1u
Rfixed11_4hi vdd n_fixed11_4 55100.7697152
Rfixed11_4lo n_fixed11_4 0 44899.2302848
Mfp11_4 vbias n_fixed11_4 n_hp11 0 syn W=10u L=1u
Mfn11_4 vbias vweight n_hn11 0 syn W=10u L=1u
Mh11a n_hn11 n_hn11 0 0 nch W=20u L=1u
Mh11b n_z11 n_hn11 0 0 nch W=20u L=1u
Mh11c n_hp11 n_hp11 0 0 nch W=20u L=1u
Mh11d n_mirrorh11 n_hp11 0 0 nch W=20u L=1u
Mh11e n_mirrorh11 n_mirrorh11 vdd vdd pch W=60u L=1u
Mh11f n_z11 n_mirrorh11 vdd vdd pch W=60u L=1u
Rh11sum n_z11 vref 8000
Mactp11 n_dd11 n_z11 n_tail11 0 nch W=12u L=1u
Mactn11 n_dm11 vref n_tail11 0 nch W=12u L=1u
Macttail11 n_tail11 n_tailbias 0 0 nch W=32u L=1u
Mactload11 n_dm11 n_dm11 vdd vdd pch W=40u L=1u
Mactmirror11 n_dd11 n_dd11 vdd vdd pch W=40u L=1u
Mactout11 n_hv11 n_dd11 vdd vdd pch W=40u L=1u
Rhvlo11 n_hv11 vref 9600
Rhvhi11 n_hv11 vbias 48000
Rfixed12_0hi vdd n_fixed12_0 28748.368136
Rfixed12_0lo n_fixed12_0 0 71251.631864
Mfp12_0 in4 n_fixed12_0 n_hp12 0 syn W=10u L=1u
Mfn12_0 in4 vweight n_hn12 0 syn W=10u L=1u
Rfixed12_1hi vdd n_fixed12_1 6666.66666667
Rfixed12_1lo n_fixed12_1 0 93333.3333333
Mfp12_1 in8 n_fixed12_1 n_hp12 0 syn W=10u L=1u
Mfn12_1 in8 vweight n_hn12 0 syn W=10u L=1u
Rfixed12_2hi vdd n_fixed12_2 55764.7216609
Rfixed12_2lo n_fixed12_2 0 44235.2783391
Mfp12_2 in12 n_fixed12_2 n_hp12 0 syn W=10u L=1u
Mfn12_2 in12 vweight n_hn12 0 syn W=10u L=1u
Rfixed12_3hi vdd n_fixed12_3 38119.2370912
Rfixed12_3lo n_fixed12_3 0 61880.7629088
Mfp12_3 in14 n_fixed12_3 n_hp12 0 syn W=10u L=1u
Mfn12_3 in14 vweight n_hn12 0 syn W=10u L=1u
Rfixed12_4hi vdd n_fixed12_4 58680.1627216
Rfixed12_4lo n_fixed12_4 0 41319.8372784
Mfp12_4 vbias n_fixed12_4 n_hp12 0 syn W=10u L=1u
Mfn12_4 vbias vweight n_hn12 0 syn W=10u L=1u
Mh12a n_hn12 n_hn12 0 0 nch W=20u L=1u
Mh12b n_z12 n_hn12 0 0 nch W=20u L=1u
Mh12c n_hp12 n_hp12 0 0 nch W=20u L=1u
Mh12d n_mirrorh12 n_hp12 0 0 nch W=20u L=1u
Mh12e n_mirrorh12 n_mirrorh12 vdd vdd pch W=60u L=1u
Mh12f n_z12 n_mirrorh12 vdd vdd pch W=60u L=1u
Rh12sum n_z12 vref 8000
Mactp12 n_dd12 n_z12 n_tail12 0 nch W=12u L=1u
Mactn12 n_dm12 vref n_tail12 0 nch W=12u L=1u
Macttail12 n_tail12 n_tailbias 0 0 nch W=32u L=1u
Mactload12 n_dm12 n_dm12 vdd vdd pch W=40u L=1u
Mactmirror12 n_dd12 n_dd12 vdd vdd pch W=40u L=1u
Mactout12 n_hv12 n_dd12 vdd vdd pch W=40u L=1u
Rhvlo12 n_hv12 vref 9600
Rhvhi12 n_hv12 vbias 48000
Rfixed13_0hi vdd n_fixed13_0 53291.9736739
Rfixed13_0lo n_fixed13_0 0 46708.0263261
Mfp13_0 in13 n_fixed13_0 n_hp13 0 syn W=10u L=1u
Mfn13_0 in13 vweight n_hn13 0 syn W=10u L=1u
Rfixed13_1hi vdd n_fixed13_1 40806.2259422
Rfixed13_1lo n_fixed13_1 0 59193.7740578
Mfp13_1 in7 n_fixed13_1 n_hp13 0 syn W=10u L=1u
Mfn13_1 in7 vweight n_hn13 0 syn W=10u L=1u
Rfixed13_2hi vdd n_fixed13_2 39519.2560659
Rfixed13_2lo n_fixed13_2 0 60480.7439341
Mfp13_2 in15 n_fixed13_2 n_hp13 0 syn W=10u L=1u
Mfn13_2 in15 vweight n_hn13 0 syn W=10u L=1u
Rfixed13_3hi vdd n_fixed13_3 68361.387187
Rfixed13_3lo n_fixed13_3 0 31638.612813
Mfp13_3 in5 n_fixed13_3 n_hp13 0 syn W=10u L=1u
Mfn13_3 in5 vweight n_hn13 0 syn W=10u L=1u
Rfixed13_4hi vdd n_fixed13_4 43651.3901613
Rfixed13_4lo n_fixed13_4 0 56348.6098387
Mfp13_4 vbias n_fixed13_4 n_hp13 0 syn W=10u L=1u
Mfn13_4 vbias vweight n_hn13 0 syn W=10u L=1u
Mh13a n_hn13 n_hn13 0 0 nch W=20u L=1u
Mh13b n_z13 n_hn13 0 0 nch W=20u L=1u
Mh13c n_hp13 n_hp13 0 0 nch W=20u L=1u
Mh13d n_mirrorh13 n_hp13 0 0 nch W=20u L=1u
Mh13e n_mirrorh13 n_mirrorh13 vdd vdd pch W=60u L=1u
Mh13f n_z13 n_mirrorh13 vdd vdd pch W=60u L=1u
Rh13sum n_z13 vref 8000
Mactp13 n_dd13 n_z13 n_tail13 0 nch W=12u L=1u
Mactn13 n_dm13 vref n_tail13 0 nch W=12u L=1u
Macttail13 n_tail13 n_tailbias 0 0 nch W=32u L=1u
Mactload13 n_dm13 n_dm13 vdd vdd pch W=40u L=1u
Mactmirror13 n_dd13 n_dd13 vdd vdd pch W=40u L=1u
Mactout13 n_hv13 n_dd13 vdd vdd pch W=40u L=1u
Rhvlo13 n_hv13 vref 9600
Rhvhi13 n_hv13 vbias 48000
Rfixed14_0hi vdd n_fixed14_0 32040.8020698
Rfixed14_0lo n_fixed14_0 0 67959.1979302
Mfp14_0 in10 n_fixed14_0 n_hp14 0 syn W=10u L=1u
Mfn14_0 in10 vweight n_hn14 0 syn W=10u L=1u
Rfixed14_1hi vdd n_fixed14_1 62296.5771076
Rfixed14_1lo n_fixed14_1 0 37703.4228924
Mfp14_1 in7 n_fixed14_1 n_hp14 0 syn W=10u L=1u
Mfn14_1 in7 vweight n_hn14 0 syn W=10u L=1u
Rfixed14_2hi vdd n_fixed14_2 49994.5869728
Rfixed14_2lo n_fixed14_2 0 50005.4130272
Mfp14_2 in9 n_fixed14_2 n_hp14 0 syn W=10u L=1u
Mfn14_2 in9 vweight n_hn14 0 syn W=10u L=1u
Rfixed14_3hi vdd n_fixed14_3 43300.0254117
Rfixed14_3lo n_fixed14_3 0 56699.9745883
Mfp14_3 in0 n_fixed14_3 n_hp14 0 syn W=10u L=1u
Mfn14_3 in0 vweight n_hn14 0 syn W=10u L=1u
Rfixed14_4hi vdd n_fixed14_4 31152.8774651
Rfixed14_4lo n_fixed14_4 0 68847.1225349
Mfp14_4 vbias n_fixed14_4 n_hp14 0 syn W=10u L=1u
Mfn14_4 vbias vweight n_hn14 0 syn W=10u L=1u
Mh14a n_hn14 n_hn14 0 0 nch W=20u L=1u
Mh14b n_z14 n_hn14 0 0 nch W=20u L=1u
Mh14c n_hp14 n_hp14 0 0 nch W=20u L=1u
Mh14d n_mirrorh14 n_hp14 0 0 nch W=20u L=1u
Mh14e n_mirrorh14 n_mirrorh14 vdd vdd pch W=60u L=1u
Mh14f n_z14 n_mirrorh14 vdd vdd pch W=60u L=1u
Rh14sum n_z14 vref 8000
Mactp14 n_dd14 n_z14 n_tail14 0 nch W=12u L=1u
Mactn14 n_dm14 vref n_tail14 0 nch W=12u L=1u
Macttail14 n_tail14 n_tailbias 0 0 nch W=32u L=1u
Mactload14 n_dm14 n_dm14 vdd vdd pch W=40u L=1u
Mactmirror14 n_dd14 n_dd14 vdd vdd pch W=40u L=1u
Mactout14 n_hv14 n_dd14 vdd vdd pch W=40u L=1u
Rhvlo14 n_hv14 vref 9600
Rhvhi14 n_hv14 vbias 48000
Rfixed15_0hi vdd n_fixed15_0 28519.5351809
Rfixed15_0lo n_fixed15_0 0 71480.4648191
Mfp15_0 in8 n_fixed15_0 n_hp15 0 syn W=10u L=1u
Mfn15_0 in8 vweight n_hn15 0 syn W=10u L=1u
Rfixed15_1hi vdd n_fixed15_1 9687.9124472
Rfixed15_1lo n_fixed15_1 0 90312.0875528
Mfp15_1 in0 n_fixed15_1 n_hp15 0 syn W=10u L=1u
Mfn15_1 in0 vweight n_hn15 0 syn W=10u L=1u
Rfixed15_2hi vdd n_fixed15_2 25630.581239
Rfixed15_2lo n_fixed15_2 0 74369.418761
Mfp15_2 in13 n_fixed15_2 n_hp15 0 syn W=10u L=1u
Mfn15_2 in13 vweight n_hn15 0 syn W=10u L=1u
Rfixed15_3hi vdd n_fixed15_3 66710.0724718
Rfixed15_3lo n_fixed15_3 0 33289.9275282
Mfp15_3 in10 n_fixed15_3 n_hp15 0 syn W=10u L=1u
Mfn15_3 in10 vweight n_hn15 0 syn W=10u L=1u
Rfixed15_4hi vdd n_fixed15_4 35937.2259241
Rfixed15_4lo n_fixed15_4 0 64062.7740759
Mfp15_4 vbias n_fixed15_4 n_hp15 0 syn W=10u L=1u
Mfn15_4 vbias vweight n_hn15 0 syn W=10u L=1u
Mh15a n_hn15 n_hn15 0 0 nch W=20u L=1u
Mh15b n_z15 n_hn15 0 0 nch W=20u L=1u
Mh15c n_hp15 n_hp15 0 0 nch W=20u L=1u
Mh15d n_mirrorh15 n_hp15 0 0 nch W=20u L=1u
Mh15e n_mirrorh15 n_mirrorh15 vdd vdd pch W=60u L=1u
Mh15f n_z15 n_mirrorh15 vdd vdd pch W=60u L=1u
Rh15sum n_z15 vref 8000
Mactp15 n_dd15 n_z15 n_tail15 0 nch W=12u L=1u
Mactn15 n_dm15 vref n_tail15 0 nch W=12u L=1u
Macttail15 n_tail15 n_tailbias 0 0 nch W=32u L=1u
Mactload15 n_dm15 n_dm15 vdd vdd pch W=40u L=1u
Mactmirror15 n_dd15 n_dd15 vdd vdd pch W=40u L=1u
Mactout15 n_hv15 n_dd15 vdd vdd pch W=40u L=1u
Rhvlo15 n_hv15 vref 9600
Rhvhi15 n_hv15 vbias 48000
Rfixed16_0hi vdd n_fixed16_0 36882.5968129
Rfixed16_0lo n_fixed16_0 0 63117.4031871
Mfp16_0 in8 n_fixed16_0 n_hp16 0 syn W=10u L=1u
Mfn16_0 in8 vweight n_hn16 0 syn W=10u L=1u
Rfixed16_1hi vdd n_fixed16_1 50181.5795664
Rfixed16_1lo n_fixed16_1 0 49818.4204336
Mfp16_1 in3 n_fixed16_1 n_hp16 0 syn W=10u L=1u
Mfn16_1 in3 vweight n_hn16 0 syn W=10u L=1u
Rfixed16_2hi vdd n_fixed16_2 42526.9551595
Rfixed16_2lo n_fixed16_2 0 57473.0448405
Mfp16_2 in4 n_fixed16_2 n_hp16 0 syn W=10u L=1u
Mfn16_2 in4 vweight n_hn16 0 syn W=10u L=1u
Rfixed16_3hi vdd n_fixed16_3 30230.6463698
Rfixed16_3lo n_fixed16_3 0 69769.3536302
Mfp16_3 in1 n_fixed16_3 n_hp16 0 syn W=10u L=1u
Mfn16_3 in1 vweight n_hn16 0 syn W=10u L=1u
Rfixed16_4hi vdd n_fixed16_4 40672.838356
Rfixed16_4lo n_fixed16_4 0 59327.161644
Mfp16_4 vbias n_fixed16_4 n_hp16 0 syn W=10u L=1u
Mfn16_4 vbias vweight n_hn16 0 syn W=10u L=1u
Mh16a n_hn16 n_hn16 0 0 nch W=20u L=1u
Mh16b n_z16 n_hn16 0 0 nch W=20u L=1u
Mh16c n_hp16 n_hp16 0 0 nch W=20u L=1u
Mh16d n_mirrorh16 n_hp16 0 0 nch W=20u L=1u
Mh16e n_mirrorh16 n_mirrorh16 vdd vdd pch W=60u L=1u
Mh16f n_z16 n_mirrorh16 vdd vdd pch W=60u L=1u
Rh16sum n_z16 vref 8000
Mactp16 n_dd16 n_z16 n_tail16 0 nch W=12u L=1u
Mactn16 n_dm16 vref n_tail16 0 nch W=12u L=1u
Macttail16 n_tail16 n_tailbias 0 0 nch W=32u L=1u
Mactload16 n_dm16 n_dm16 vdd vdd pch W=40u L=1u
Mactmirror16 n_dd16 n_dd16 vdd vdd pch W=40u L=1u
Mactout16 n_hv16 n_dd16 vdd vdd pch W=40u L=1u
Rhvlo16 n_hv16 vref 9600
Rhvhi16 n_hv16 vbias 48000
Rfixed17_0hi vdd n_fixed17_0 6666.66666667
Rfixed17_0lo n_fixed17_0 0 93333.3333333
Mfp17_0 in8 n_fixed17_0 n_hp17 0 syn W=10u L=1u
Mfn17_0 in8 vweight n_hn17 0 syn W=10u L=1u
Rfixed17_1hi vdd n_fixed17_1 54102.2292838
Rfixed17_1lo n_fixed17_1 0 45897.7707162
Mfp17_1 in10 n_fixed17_1 n_hp17 0 syn W=10u L=1u
Mfn17_1 in10 vweight n_hn17 0 syn W=10u L=1u
Rfixed17_2hi vdd n_fixed17_2 35874.2388619
Rfixed17_2lo n_fixed17_2 0 64125.7611381
Mfp17_2 in11 n_fixed17_2 n_hp17 0 syn W=10u L=1u
Mfn17_2 in11 vweight n_hn17 0 syn W=10u L=1u
Rfixed17_3hi vdd n_fixed17_3 43595.877446
Rfixed17_3lo n_fixed17_3 0 56404.122554
Mfp17_3 in4 n_fixed17_3 n_hp17 0 syn W=10u L=1u
Mfn17_3 in4 vweight n_hn17 0 syn W=10u L=1u
Rfixed17_4hi vdd n_fixed17_4 39700.9849069
Rfixed17_4lo n_fixed17_4 0 60299.0150931
Mfp17_4 vbias n_fixed17_4 n_hp17 0 syn W=10u L=1u
Mfn17_4 vbias vweight n_hn17 0 syn W=10u L=1u
Mh17a n_hn17 n_hn17 0 0 nch W=20u L=1u
Mh17b n_z17 n_hn17 0 0 nch W=20u L=1u
Mh17c n_hp17 n_hp17 0 0 nch W=20u L=1u
Mh17d n_mirrorh17 n_hp17 0 0 nch W=20u L=1u
Mh17e n_mirrorh17 n_mirrorh17 vdd vdd pch W=60u L=1u
Mh17f n_z17 n_mirrorh17 vdd vdd pch W=60u L=1u
Rh17sum n_z17 vref 8000
Mactp17 n_dd17 n_z17 n_tail17 0 nch W=12u L=1u
Mactn17 n_dm17 vref n_tail17 0 nch W=12u L=1u
Macttail17 n_tail17 n_tailbias 0 0 nch W=32u L=1u
Mactload17 n_dm17 n_dm17 vdd vdd pch W=40u L=1u
Mactmirror17 n_dd17 n_dd17 vdd vdd pch W=40u L=1u
Mactout17 n_hv17 n_dd17 vdd vdd pch W=40u L=1u
Rhvlo17 n_hv17 vref 9600
Rhvhi17 n_hv17 vbias 48000
Rfixed18_0hi vdd n_fixed18_0 36964.3406427
Rfixed18_0lo n_fixed18_0 0 63035.6593573
Mfp18_0 in12 n_fixed18_0 n_hp18 0 syn W=10u L=1u
Mfn18_0 in12 vweight n_hn18 0 syn W=10u L=1u
Rfixed18_1hi vdd n_fixed18_1 32600.449842
Rfixed18_1lo n_fixed18_1 0 67399.550158
Mfp18_1 in5 n_fixed18_1 n_hp18 0 syn W=10u L=1u
Mfn18_1 in5 vweight n_hn18 0 syn W=10u L=1u
Rfixed18_2hi vdd n_fixed18_2 23905.2411521
Rfixed18_2lo n_fixed18_2 0 76094.7588479
Mfp18_2 in6 n_fixed18_2 n_hp18 0 syn W=10u L=1u
Mfn18_2 in6 vweight n_hn18 0 syn W=10u L=1u
Rfixed18_3hi vdd n_fixed18_3 51721.5930705
Rfixed18_3lo n_fixed18_3 0 48278.4069295
Mfp18_3 in15 n_fixed18_3 n_hp18 0 syn W=10u L=1u
Mfn18_3 in15 vweight n_hn18 0 syn W=10u L=1u
Rfixed18_4hi vdd n_fixed18_4 37109.9791617
Rfixed18_4lo n_fixed18_4 0 62890.0208383
Mfp18_4 vbias n_fixed18_4 n_hp18 0 syn W=10u L=1u
Mfn18_4 vbias vweight n_hn18 0 syn W=10u L=1u
Mh18a n_hn18 n_hn18 0 0 nch W=20u L=1u
Mh18b n_z18 n_hn18 0 0 nch W=20u L=1u
Mh18c n_hp18 n_hp18 0 0 nch W=20u L=1u
Mh18d n_mirrorh18 n_hp18 0 0 nch W=20u L=1u
Mh18e n_mirrorh18 n_mirrorh18 vdd vdd pch W=60u L=1u
Mh18f n_z18 n_mirrorh18 vdd vdd pch W=60u L=1u
Rh18sum n_z18 vref 8000
Mactp18 n_dd18 n_z18 n_tail18 0 nch W=12u L=1u
Mactn18 n_dm18 vref n_tail18 0 nch W=12u L=1u
Macttail18 n_tail18 n_tailbias 0 0 nch W=32u L=1u
Mactload18 n_dm18 n_dm18 vdd vdd pch W=40u L=1u
Mactmirror18 n_dd18 n_dd18 vdd vdd pch W=40u L=1u
Mactout18 n_hv18 n_dd18 vdd vdd pch W=40u L=1u
Rhvlo18 n_hv18 vref 9600
Rhvhi18 n_hv18 vbias 48000
Rfixed19_0hi vdd n_fixed19_0 18010.3938277
Rfixed19_0lo n_fixed19_0 0 81989.6061723
Mfp19_0 in0 n_fixed19_0 n_hp19 0 syn W=10u L=1u
Mfn19_0 in0 vweight n_hn19 0 syn W=10u L=1u
Rfixed19_1hi vdd n_fixed19_1 23920.735489
Rfixed19_1lo n_fixed19_1 0 76079.264511
Mfp19_1 in3 n_fixed19_1 n_hp19 0 syn W=10u L=1u
Mfn19_1 in3 vweight n_hn19 0 syn W=10u L=1u
Rfixed19_2hi vdd n_fixed19_2 18872.8935328
Rfixed19_2lo n_fixed19_2 0 81127.1064672
Mfp19_2 in15 n_fixed19_2 n_hp19 0 syn W=10u L=1u
Mfn19_2 in15 vweight n_hn19 0 syn W=10u L=1u
Rfixed19_3hi vdd n_fixed19_3 26084.8164017
Rfixed19_3lo n_fixed19_3 0 73915.1835983
Mfp19_3 in6 n_fixed19_3 n_hp19 0 syn W=10u L=1u
Mfn19_3 in6 vweight n_hn19 0 syn W=10u L=1u
Rfixed19_4hi vdd n_fixed19_4 29001.8577423
Rfixed19_4lo n_fixed19_4 0 70998.1422577
Mfp19_4 vbias n_fixed19_4 n_hp19 0 syn W=10u L=1u
Mfn19_4 vbias vweight n_hn19 0 syn W=10u L=1u
Mh19a n_hn19 n_hn19 0 0 nch W=20u L=1u
Mh19b n_z19 n_hn19 0 0 nch W=20u L=1u
Mh19c n_hp19 n_hp19 0 0 nch W=20u L=1u
Mh19d n_mirrorh19 n_hp19 0 0 nch W=20u L=1u
Mh19e n_mirrorh19 n_mirrorh19 vdd vdd pch W=60u L=1u
Mh19f n_z19 n_mirrorh19 vdd vdd pch W=60u L=1u
Rh19sum n_z19 vref 8000
Mactp19 n_dd19 n_z19 n_tail19 0 nch W=12u L=1u
Mactn19 n_dm19 vref n_tail19 0 nch W=12u L=1u
Macttail19 n_tail19 n_tailbias 0 0 nch W=32u L=1u
Mactload19 n_dm19 n_dm19 vdd vdd pch W=40u L=1u
Mactmirror19 n_dd19 n_dd19 vdd vdd pch W=40u L=1u
Mactout19 n_hv19 n_dd19 vdd vdd pch W=40u L=1u
Rhvlo19 n_hv19 vref 9600
Rhvhi19 n_hv19 vbias 48000
Rfixed20_0hi vdd n_fixed20_0 16718.6922759
Rfixed20_0lo n_fixed20_0 0 83281.3077241
Mfp20_0 in13 n_fixed20_0 n_hp20 0 syn W=10u L=1u
Mfn20_0 in13 vweight n_hn20 0 syn W=10u L=1u
Rfixed20_1hi vdd n_fixed20_1 43391.6381059
Rfixed20_1lo n_fixed20_1 0 56608.3618941
Mfp20_1 in8 n_fixed20_1 n_hp20 0 syn W=10u L=1u
Mfn20_1 in8 vweight n_hn20 0 syn W=10u L=1u
Rfixed20_2hi vdd n_fixed20_2 46175.7656587
Rfixed20_2lo n_fixed20_2 0 53824.2343413
Mfp20_2 in15 n_fixed20_2 n_hp20 0 syn W=10u L=1u
Mfn20_2 in15 vweight n_hn20 0 syn W=10u L=1u
Rfixed20_3hi vdd n_fixed20_3 57171.0746539
Rfixed20_3lo n_fixed20_3 0 42828.9253461
Mfp20_3 in3 n_fixed20_3 n_hp20 0 syn W=10u L=1u
Mfn20_3 in3 vweight n_hn20 0 syn W=10u L=1u
Rfixed20_4hi vdd n_fixed20_4 42057.6342172
Rfixed20_4lo n_fixed20_4 0 57942.3657828
Mfp20_4 vbias n_fixed20_4 n_hp20 0 syn W=10u L=1u
Mfn20_4 vbias vweight n_hn20 0 syn W=10u L=1u
Mh20a n_hn20 n_hn20 0 0 nch W=20u L=1u
Mh20b n_z20 n_hn20 0 0 nch W=20u L=1u
Mh20c n_hp20 n_hp20 0 0 nch W=20u L=1u
Mh20d n_mirrorh20 n_hp20 0 0 nch W=20u L=1u
Mh20e n_mirrorh20 n_mirrorh20 vdd vdd pch W=60u L=1u
Mh20f n_z20 n_mirrorh20 vdd vdd pch W=60u L=1u
Rh20sum n_z20 vref 8000
Mactp20 n_dd20 n_z20 n_tail20 0 nch W=12u L=1u
Mactn20 n_dm20 vref n_tail20 0 nch W=12u L=1u
Macttail20 n_tail20 n_tailbias 0 0 nch W=32u L=1u
Mactload20 n_dm20 n_dm20 vdd vdd pch W=40u L=1u
Mactmirror20 n_dd20 n_dd20 vdd vdd pch W=40u L=1u
Mactout20 n_hv20 n_dd20 vdd vdd pch W=40u L=1u
Rhvlo20 n_hv20 vref 9600
Rhvhi20 n_hv20 vbias 48000
Rfixed21_0hi vdd n_fixed21_0 40622.5490994
Rfixed21_0lo n_fixed21_0 0 59377.4509006
Mfp21_0 in10 n_fixed21_0 n_hp21 0 syn W=10u L=1u
Mfn21_0 in10 vweight n_hn21 0 syn W=10u L=1u
Rfixed21_1hi vdd n_fixed21_1 26909.3287146
Rfixed21_1lo n_fixed21_1 0 73090.6712854
Mfp21_1 in15 n_fixed21_1 n_hp21 0 syn W=10u L=1u
Mfn21_1 in15 vweight n_hn21 0 syn W=10u L=1u
Rfixed21_2hi vdd n_fixed21_2 34932.2802989
Rfixed21_2lo n_fixed21_2 0 65067.7197011
Mfp21_2 in14 n_fixed21_2 n_hp21 0 syn W=10u L=1u
Mfn21_2 in14 vweight n_hn21 0 syn W=10u L=1u
Rfixed21_3hi vdd n_fixed21_3 6666.66666667
Rfixed21_3lo n_fixed21_3 0 93333.3333333
Mfp21_3 in6 n_fixed21_3 n_hp21 0 syn W=10u L=1u
Mfn21_3 in6 vweight n_hn21 0 syn W=10u L=1u
Rfixed21_4hi vdd n_fixed21_4 43407.5810621
Rfixed21_4lo n_fixed21_4 0 56592.4189379
Mfp21_4 vbias n_fixed21_4 n_hp21 0 syn W=10u L=1u
Mfn21_4 vbias vweight n_hn21 0 syn W=10u L=1u
Mh21a n_hn21 n_hn21 0 0 nch W=20u L=1u
Mh21b n_z21 n_hn21 0 0 nch W=20u L=1u
Mh21c n_hp21 n_hp21 0 0 nch W=20u L=1u
Mh21d n_mirrorh21 n_hp21 0 0 nch W=20u L=1u
Mh21e n_mirrorh21 n_mirrorh21 vdd vdd pch W=60u L=1u
Mh21f n_z21 n_mirrorh21 vdd vdd pch W=60u L=1u
Rh21sum n_z21 vref 8000
Mactp21 n_dd21 n_z21 n_tail21 0 nch W=12u L=1u
Mactn21 n_dm21 vref n_tail21 0 nch W=12u L=1u
Macttail21 n_tail21 n_tailbias 0 0 nch W=32u L=1u
Mactload21 n_dm21 n_dm21 vdd vdd pch W=40u L=1u
Mactmirror21 n_dd21 n_dd21 vdd vdd pch W=40u L=1u
Mactout21 n_hv21 n_dd21 vdd vdd pch W=40u L=1u
Rhvlo21 n_hv21 vref 9600
Rhvhi21 n_hv21 vbias 48000
Rfixed22_0hi vdd n_fixed22_0 54606.9999777
Rfixed22_0lo n_fixed22_0 0 45393.0000223
Mfp22_0 in9 n_fixed22_0 n_hp22 0 syn W=10u L=1u
Mfn22_0 in9 vweight n_hn22 0 syn W=10u L=1u
Rfixed22_1hi vdd n_fixed22_1 6666.66666667
Rfixed22_1lo n_fixed22_1 0 93333.3333333
Mfp22_1 in1 n_fixed22_1 n_hp22 0 syn W=10u L=1u
Mfn22_1 in1 vweight n_hn22 0 syn W=10u L=1u
Rfixed22_2hi vdd n_fixed22_2 40668.8334163
Rfixed22_2lo n_fixed22_2 0 59331.1665837
Mfp22_2 in13 n_fixed22_2 n_hp22 0 syn W=10u L=1u
Mfn22_2 in13 vweight n_hn22 0 syn W=10u L=1u
Rfixed22_3hi vdd n_fixed22_3 57277.8615817
Rfixed22_3lo n_fixed22_3 0 42722.1384183
Mfp22_3 in14 n_fixed22_3 n_hp22 0 syn W=10u L=1u
Mfn22_3 in14 vweight n_hn22 0 syn W=10u L=1u
Rfixed22_4hi vdd n_fixed22_4 40016.1134679
Rfixed22_4lo n_fixed22_4 0 59983.8865321
Mfp22_4 vbias n_fixed22_4 n_hp22 0 syn W=10u L=1u
Mfn22_4 vbias vweight n_hn22 0 syn W=10u L=1u
Mh22a n_hn22 n_hn22 0 0 nch W=20u L=1u
Mh22b n_z22 n_hn22 0 0 nch W=20u L=1u
Mh22c n_hp22 n_hp22 0 0 nch W=20u L=1u
Mh22d n_mirrorh22 n_hp22 0 0 nch W=20u L=1u
Mh22e n_mirrorh22 n_mirrorh22 vdd vdd pch W=60u L=1u
Mh22f n_z22 n_mirrorh22 vdd vdd pch W=60u L=1u
Rh22sum n_z22 vref 8000
Mactp22 n_dd22 n_z22 n_tail22 0 nch W=12u L=1u
Mactn22 n_dm22 vref n_tail22 0 nch W=12u L=1u
Macttail22 n_tail22 n_tailbias 0 0 nch W=32u L=1u
Mactload22 n_dm22 n_dm22 vdd vdd pch W=40u L=1u
Mactmirror22 n_dd22 n_dd22 vdd vdd pch W=40u L=1u
Mactout22 n_hv22 n_dd22 vdd vdd pch W=40u L=1u
Rhvlo22 n_hv22 vref 9600
Rhvhi22 n_hv22 vbias 48000
Rfixed23_0hi vdd n_fixed23_0 37825.0727929
Rfixed23_0lo n_fixed23_0 0 62174.9272071
Mfp23_0 in1 n_fixed23_0 n_hp23 0 syn W=10u L=1u
Mfn23_0 in1 vweight n_hn23 0 syn W=10u L=1u
Rfixed23_1hi vdd n_fixed23_1 18946.2215388
Rfixed23_1lo n_fixed23_1 0 81053.7784612
Mfp23_1 in9 n_fixed23_1 n_hp23 0 syn W=10u L=1u
Mfn23_1 in9 vweight n_hn23 0 syn W=10u L=1u
Rfixed23_2hi vdd n_fixed23_2 45096.3993125
Rfixed23_2lo n_fixed23_2 0 54903.6006875
Mfp23_2 in13 n_fixed23_2 n_hp23 0 syn W=10u L=1u
Mfn23_2 in13 vweight n_hn23 0 syn W=10u L=1u
Rfixed23_3hi vdd n_fixed23_3 24129.0738858
Rfixed23_3lo n_fixed23_3 0 75870.9261142
Mfp23_3 in3 n_fixed23_3 n_hp23 0 syn W=10u L=1u
Mfn23_3 in3 vweight n_hn23 0 syn W=10u L=1u
Rfixed23_4hi vdd n_fixed23_4 25233.7622556
Rfixed23_4lo n_fixed23_4 0 74766.2377444
Mfp23_4 vbias n_fixed23_4 n_hp23 0 syn W=10u L=1u
Mfn23_4 vbias vweight n_hn23 0 syn W=10u L=1u
Mh23a n_hn23 n_hn23 0 0 nch W=20u L=1u
Mh23b n_z23 n_hn23 0 0 nch W=20u L=1u
Mh23c n_hp23 n_hp23 0 0 nch W=20u L=1u
Mh23d n_mirrorh23 n_hp23 0 0 nch W=20u L=1u
Mh23e n_mirrorh23 n_mirrorh23 vdd vdd pch W=60u L=1u
Mh23f n_z23 n_mirrorh23 vdd vdd pch W=60u L=1u
Rh23sum n_z23 vref 8000
Mactp23 n_dd23 n_z23 n_tail23 0 nch W=12u L=1u
Mactn23 n_dm23 vref n_tail23 0 nch W=12u L=1u
Macttail23 n_tail23 n_tailbias 0 0 nch W=32u L=1u
Mactload23 n_dm23 n_dm23 vdd vdd pch W=40u L=1u
Mactmirror23 n_dd23 n_dd23 vdd vdd pch W=40u L=1u
Mactout23 n_hv23 n_dd23 vdd vdd pch W=40u L=1u
Rhvlo23 n_hv23 vref 9600
Rhvhi23 n_hv23 vbias 48000
Rfixed24_0hi vdd n_fixed24_0 22322.2335263
Rfixed24_0lo n_fixed24_0 0 77677.7664737
Mfp24_0 in1 n_fixed24_0 n_hp24 0 syn W=10u L=1u
Mfn24_0 in1 vweight n_hn24 0 syn W=10u L=1u
Rfixed24_1hi vdd n_fixed24_1 27321.0200607
Rfixed24_1lo n_fixed24_1 0 72678.9799393
Mfp24_1 in6 n_fixed24_1 n_hp24 0 syn W=10u L=1u
Mfn24_1 in6 vweight n_hn24 0 syn W=10u L=1u
Rfixed24_2hi vdd n_fixed24_2 22246.735197
Rfixed24_2lo n_fixed24_2 0 77753.264803
Mfp24_2 in3 n_fixed24_2 n_hp24 0 syn W=10u L=1u
Mfn24_2 in3 vweight n_hn24 0 syn W=10u L=1u
Rfixed24_3hi vdd n_fixed24_3 53493.2132555
Rfixed24_3lo n_fixed24_3 0 46506.7867445
Mfp24_3 in5 n_fixed24_3 n_hp24 0 syn W=10u L=1u
Mfn24_3 in5 vweight n_hn24 0 syn W=10u L=1u
Rfixed24_4hi vdd n_fixed24_4 59626.5880162
Rfixed24_4lo n_fixed24_4 0 40373.4119838
Mfp24_4 vbias n_fixed24_4 n_hp24 0 syn W=10u L=1u
Mfn24_4 vbias vweight n_hn24 0 syn W=10u L=1u
Mh24a n_hn24 n_hn24 0 0 nch W=20u L=1u
Mh24b n_z24 n_hn24 0 0 nch W=20u L=1u
Mh24c n_hp24 n_hp24 0 0 nch W=20u L=1u
Mh24d n_mirrorh24 n_hp24 0 0 nch W=20u L=1u
Mh24e n_mirrorh24 n_mirrorh24 vdd vdd pch W=60u L=1u
Mh24f n_z24 n_mirrorh24 vdd vdd pch W=60u L=1u
Rh24sum n_z24 vref 8000
Mactp24 n_dd24 n_z24 n_tail24 0 nch W=12u L=1u
Mactn24 n_dm24 vref n_tail24 0 nch W=12u L=1u
Macttail24 n_tail24 n_tailbias 0 0 nch W=32u L=1u
Mactload24 n_dm24 n_dm24 vdd vdd pch W=40u L=1u
Mactmirror24 n_dd24 n_dd24 vdd vdd pch W=40u L=1u
Mactout24 n_hv24 n_dd24 vdd vdd pch W=40u L=1u
Rhvlo24 n_hv24 vref 9600
Rhvhi24 n_hv24 vbias 48000
Rfixed25_0hi vdd n_fixed25_0 38111.973543
Rfixed25_0lo n_fixed25_0 0 61888.026457
Mfp25_0 in12 n_fixed25_0 n_hp25 0 syn W=10u L=1u
Mfn25_0 in12 vweight n_hn25 0 syn W=10u L=1u
Rfixed25_1hi vdd n_fixed25_1 17195.7322497
Rfixed25_1lo n_fixed25_1 0 82804.2677503
Mfp25_1 in4 n_fixed25_1 n_hp25 0 syn W=10u L=1u
Mfn25_1 in4 vweight n_hn25 0 syn W=10u L=1u
Rfixed25_2hi vdd n_fixed25_2 37525.8568322
Rfixed25_2lo n_fixed25_2 0 62474.1431678
Mfp25_2 in8 n_fixed25_2 n_hp25 0 syn W=10u L=1u
Mfn25_2 in8 vweight n_hn25 0 syn W=10u L=1u
Rfixed25_3hi vdd n_fixed25_3 51075.6432892
Rfixed25_3lo n_fixed25_3 0 48924.3567108
Mfp25_3 in7 n_fixed25_3 n_hp25 0 syn W=10u L=1u
Mfn25_3 in7 vweight n_hn25 0 syn W=10u L=1u
Rfixed25_4hi vdd n_fixed25_4 36098.8349254
Rfixed25_4lo n_fixed25_4 0 63901.1650746
Mfp25_4 vbias n_fixed25_4 n_hp25 0 syn W=10u L=1u
Mfn25_4 vbias vweight n_hn25 0 syn W=10u L=1u
Mh25a n_hn25 n_hn25 0 0 nch W=20u L=1u
Mh25b n_z25 n_hn25 0 0 nch W=20u L=1u
Mh25c n_hp25 n_hp25 0 0 nch W=20u L=1u
Mh25d n_mirrorh25 n_hp25 0 0 nch W=20u L=1u
Mh25e n_mirrorh25 n_mirrorh25 vdd vdd pch W=60u L=1u
Mh25f n_z25 n_mirrorh25 vdd vdd pch W=60u L=1u
Rh25sum n_z25 vref 8000
Mactp25 n_dd25 n_z25 n_tail25 0 nch W=12u L=1u
Mactn25 n_dm25 vref n_tail25 0 nch W=12u L=1u
Macttail25 n_tail25 n_tailbias 0 0 nch W=32u L=1u
Mactload25 n_dm25 n_dm25 vdd vdd pch W=40u L=1u
Mactmirror25 n_dd25 n_dd25 vdd vdd pch W=40u L=1u
Mactout25 n_hv25 n_dd25 vdd vdd pch W=40u L=1u
Rhvlo25 n_hv25 vref 9600
Rhvhi25 n_hv25 vbias 48000
Rfixed26_0hi vdd n_fixed26_0 31959.1716782
Rfixed26_0lo n_fixed26_0 0 68040.8283218
Mfp26_0 in5 n_fixed26_0 n_hp26 0 syn W=10u L=1u
Mfn26_0 in5 vweight n_hn26 0 syn W=10u L=1u
Rfixed26_1hi vdd n_fixed26_1 59891.6899067
Rfixed26_1lo n_fixed26_1 0 40108.3100933
Mfp26_1 in3 n_fixed26_1 n_hp26 0 syn W=10u L=1u
Mfn26_1 in3 vweight n_hn26 0 syn W=10u L=1u
Rfixed26_2hi vdd n_fixed26_2 28339.2720893
Rfixed26_2lo n_fixed26_2 0 71660.7279107
Mfp26_2 in13 n_fixed26_2 n_hp26 0 syn W=10u L=1u
Mfn26_2 in13 vweight n_hn26 0 syn W=10u L=1u
Rfixed26_3hi vdd n_fixed26_3 26749.495532
Rfixed26_3lo n_fixed26_3 0 73250.504468
Mfp26_3 in15 n_fixed26_3 n_hp26 0 syn W=10u L=1u
Mfn26_3 in15 vweight n_hn26 0 syn W=10u L=1u
Rfixed26_4hi vdd n_fixed26_4 40389.1451903
Rfixed26_4lo n_fixed26_4 0 59610.8548097
Mfp26_4 vbias n_fixed26_4 n_hp26 0 syn W=10u L=1u
Mfn26_4 vbias vweight n_hn26 0 syn W=10u L=1u
Mh26a n_hn26 n_hn26 0 0 nch W=20u L=1u
Mh26b n_z26 n_hn26 0 0 nch W=20u L=1u
Mh26c n_hp26 n_hp26 0 0 nch W=20u L=1u
Mh26d n_mirrorh26 n_hp26 0 0 nch W=20u L=1u
Mh26e n_mirrorh26 n_mirrorh26 vdd vdd pch W=60u L=1u
Mh26f n_z26 n_mirrorh26 vdd vdd pch W=60u L=1u
Rh26sum n_z26 vref 8000
Mactp26 n_dd26 n_z26 n_tail26 0 nch W=12u L=1u
Mactn26 n_dm26 vref n_tail26 0 nch W=12u L=1u
Macttail26 n_tail26 n_tailbias 0 0 nch W=32u L=1u
Mactload26 n_dm26 n_dm26 vdd vdd pch W=40u L=1u
Mactmirror26 n_dd26 n_dd26 vdd vdd pch W=40u L=1u
Mactout26 n_hv26 n_dd26 vdd vdd pch W=40u L=1u
Rhvlo26 n_hv26 vref 9600
Rhvhi26 n_hv26 vbias 48000
Rfixed27_0hi vdd n_fixed27_0 32535.8703449
Rfixed27_0lo n_fixed27_0 0 67464.1296551
Mfp27_0 in12 n_fixed27_0 n_hp27 0 syn W=10u L=1u
Mfn27_0 in12 vweight n_hn27 0 syn W=10u L=1u
Rfixed27_1hi vdd n_fixed27_1 12699.8245017
Rfixed27_1lo n_fixed27_1 0 87300.1754983
Mfp27_1 in14 n_fixed27_1 n_hp27 0 syn W=10u L=1u
Mfn27_1 in14 vweight n_hn27 0 syn W=10u L=1u
Rfixed27_2hi vdd n_fixed27_2 56274.1254755
Rfixed27_2lo n_fixed27_2 0 43725.8745245
Mfp27_2 in8 n_fixed27_2 n_hp27 0 syn W=10u L=1u
Mfn27_2 in8 vweight n_hn27 0 syn W=10u L=1u
Rfixed27_3hi vdd n_fixed27_3 67827.7198574
Rfixed27_3lo n_fixed27_3 0 32172.2801426
Mfp27_3 in5 n_fixed27_3 n_hp27 0 syn W=10u L=1u
Mfn27_3 in5 vweight n_hn27 0 syn W=10u L=1u
Rfixed27_4hi vdd n_fixed27_4 43048.6774122
Rfixed27_4lo n_fixed27_4 0 56951.3225878
Mfp27_4 vbias n_fixed27_4 n_hp27 0 syn W=10u L=1u
Mfn27_4 vbias vweight n_hn27 0 syn W=10u L=1u
Mh27a n_hn27 n_hn27 0 0 nch W=20u L=1u
Mh27b n_z27 n_hn27 0 0 nch W=20u L=1u
Mh27c n_hp27 n_hp27 0 0 nch W=20u L=1u
Mh27d n_mirrorh27 n_hp27 0 0 nch W=20u L=1u
Mh27e n_mirrorh27 n_mirrorh27 vdd vdd pch W=60u L=1u
Mh27f n_z27 n_mirrorh27 vdd vdd pch W=60u L=1u
Rh27sum n_z27 vref 8000
Mactp27 n_dd27 n_z27 n_tail27 0 nch W=12u L=1u
Mactn27 n_dm27 vref n_tail27 0 nch W=12u L=1u
Macttail27 n_tail27 n_tailbias 0 0 nch W=32u L=1u
Mactload27 n_dm27 n_dm27 vdd vdd pch W=40u L=1u
Mactmirror27 n_dd27 n_dd27 vdd vdd pch W=40u L=1u
Mactout27 n_hv27 n_dd27 vdd vdd pch W=40u L=1u
Rhvlo27 n_hv27 vref 9600
Rhvhi27 n_hv27 vbias 48000
Rfixed28_0hi vdd n_fixed28_0 31240.8348667
Rfixed28_0lo n_fixed28_0 0 68759.1651333
Mfp28_0 in7 n_fixed28_0 n_hp28 0 syn W=10u L=1u
Mfn28_0 in7 vweight n_hn28 0 syn W=10u L=1u
Rfixed28_1hi vdd n_fixed28_1 34843.5698551
Rfixed28_1lo n_fixed28_1 0 65156.4301449
Mfp28_1 in1 n_fixed28_1 n_hp28 0 syn W=10u L=1u
Mfn28_1 in1 vweight n_hn28 0 syn W=10u L=1u
Rfixed28_2hi vdd n_fixed28_2 30222.8025045
Rfixed28_2lo n_fixed28_2 0 69777.1974955
Mfp28_2 in11 n_fixed28_2 n_hp28 0 syn W=10u L=1u
Mfn28_2 in11 vweight n_hn28 0 syn W=10u L=1u
Rfixed28_3hi vdd n_fixed28_3 46120.0106595
Rfixed28_3lo n_fixed28_3 0 53879.9893405
Mfp28_3 in0 n_fixed28_3 n_hp28 0 syn W=10u L=1u
Mfn28_3 in0 vweight n_hn28 0 syn W=10u L=1u
Rfixed28_4hi vdd n_fixed28_4 39354.0044775
Rfixed28_4lo n_fixed28_4 0 60645.9955225
Mfp28_4 vbias n_fixed28_4 n_hp28 0 syn W=10u L=1u
Mfn28_4 vbias vweight n_hn28 0 syn W=10u L=1u
Mh28a n_hn28 n_hn28 0 0 nch W=20u L=1u
Mh28b n_z28 n_hn28 0 0 nch W=20u L=1u
Mh28c n_hp28 n_hp28 0 0 nch W=20u L=1u
Mh28d n_mirrorh28 n_hp28 0 0 nch W=20u L=1u
Mh28e n_mirrorh28 n_mirrorh28 vdd vdd pch W=60u L=1u
Mh28f n_z28 n_mirrorh28 vdd vdd pch W=60u L=1u
Rh28sum n_z28 vref 8000
Mactp28 n_dd28 n_z28 n_tail28 0 nch W=12u L=1u
Mactn28 n_dm28 vref n_tail28 0 nch W=12u L=1u
Macttail28 n_tail28 n_tailbias 0 0 nch W=32u L=1u
Mactload28 n_dm28 n_dm28 vdd vdd pch W=40u L=1u
Mactmirror28 n_dd28 n_dd28 vdd vdd pch W=40u L=1u
Mactout28 n_hv28 n_dd28 vdd vdd pch W=40u L=1u
Rhvlo28 n_hv28 vref 9600
Rhvhi28 n_hv28 vbias 48000
Rfixed29_0hi vdd n_fixed29_0 62531.5619371
Rfixed29_0lo n_fixed29_0 0 37468.4380629
Mfp29_0 in8 n_fixed29_0 n_hp29 0 syn W=10u L=1u
Mfn29_0 in8 vweight n_hn29 0 syn W=10u L=1u
Rfixed29_1hi vdd n_fixed29_1 30790.0546049
Rfixed29_1lo n_fixed29_1 0 69209.9453951
Mfp29_1 in5 n_fixed29_1 n_hp29 0 syn W=10u L=1u
Mfn29_1 in5 vweight n_hn29 0 syn W=10u L=1u
Rfixed29_2hi vdd n_fixed29_2 31991.4755965
Rfixed29_2lo n_fixed29_2 0 68008.5244035
Mfp29_2 in14 n_fixed29_2 n_hp29 0 syn W=10u L=1u
Mfn29_2 in14 vweight n_hn29 0 syn W=10u L=1u
Rfixed29_3hi vdd n_fixed29_3 12792.8835246
Rfixed29_3lo n_fixed29_3 0 87207.1164754
Mfp29_3 in13 n_fixed29_3 n_hp29 0 syn W=10u L=1u
Mfn29_3 in13 vweight n_hn29 0 syn W=10u L=1u
Rfixed29_4hi vdd n_fixed29_4 44994.8497002
Rfixed29_4lo n_fixed29_4 0 55005.1502998
Mfp29_4 vbias n_fixed29_4 n_hp29 0 syn W=10u L=1u
Mfn29_4 vbias vweight n_hn29 0 syn W=10u L=1u
Mh29a n_hn29 n_hn29 0 0 nch W=20u L=1u
Mh29b n_z29 n_hn29 0 0 nch W=20u L=1u
Mh29c n_hp29 n_hp29 0 0 nch W=20u L=1u
Mh29d n_mirrorh29 n_hp29 0 0 nch W=20u L=1u
Mh29e n_mirrorh29 n_mirrorh29 vdd vdd pch W=60u L=1u
Mh29f n_z29 n_mirrorh29 vdd vdd pch W=60u L=1u
Rh29sum n_z29 vref 8000
Mactp29 n_dd29 n_z29 n_tail29 0 nch W=12u L=1u
Mactn29 n_dm29 vref n_tail29 0 nch W=12u L=1u
Macttail29 n_tail29 n_tailbias 0 0 nch W=32u L=1u
Mactload29 n_dm29 n_dm29 vdd vdd pch W=40u L=1u
Mactmirror29 n_dd29 n_dd29 vdd vdd pch W=40u L=1u
Mactout29 n_hv29 n_dd29 vdd vdd pch W=40u L=1u
Rhvlo29 n_hv29 vref 9600
Rhvhi29 n_hv29 vbias 48000
Rfixed30_0hi vdd n_fixed30_0 38139.7645203
Rfixed30_0lo n_fixed30_0 0 61860.2354797
Mfp30_0 in15 n_fixed30_0 n_hp30 0 syn W=10u L=1u
Mfn30_0 in15 vweight n_hn30 0 syn W=10u L=1u
Rfixed30_1hi vdd n_fixed30_1 54539.2529157
Rfixed30_1lo n_fixed30_1 0 45460.7470843
Mfp30_1 in2 n_fixed30_1 n_hp30 0 syn W=10u L=1u
Mfn30_1 in2 vweight n_hn30 0 syn W=10u L=1u
Rfixed30_2hi vdd n_fixed30_2 53575.1200967
Rfixed30_2lo n_fixed30_2 0 46424.8799033
Mfp30_2 in9 n_fixed30_2 n_hp30 0 syn W=10u L=1u
Mfn30_2 in9 vweight n_hn30 0 syn W=10u L=1u
Rfixed30_3hi vdd n_fixed30_3 30972.3809637
Rfixed30_3lo n_fixed30_3 0 69027.6190363
Mfp30_3 in8 n_fixed30_3 n_hp30 0 syn W=10u L=1u
Mfn30_3 in8 vweight n_hn30 0 syn W=10u L=1u
Rfixed30_4hi vdd n_fixed30_4 35302.2213063
Rfixed30_4lo n_fixed30_4 0 64697.7786937
Mfp30_4 vbias n_fixed30_4 n_hp30 0 syn W=10u L=1u
Mfn30_4 vbias vweight n_hn30 0 syn W=10u L=1u
Mh30a n_hn30 n_hn30 0 0 nch W=20u L=1u
Mh30b n_z30 n_hn30 0 0 nch W=20u L=1u
Mh30c n_hp30 n_hp30 0 0 nch W=20u L=1u
Mh30d n_mirrorh30 n_hp30 0 0 nch W=20u L=1u
Mh30e n_mirrorh30 n_mirrorh30 vdd vdd pch W=60u L=1u
Mh30f n_z30 n_mirrorh30 vdd vdd pch W=60u L=1u
Rh30sum n_z30 vref 8000
Mactp30 n_dd30 n_z30 n_tail30 0 nch W=12u L=1u
Mactn30 n_dm30 vref n_tail30 0 nch W=12u L=1u
Macttail30 n_tail30 n_tailbias 0 0 nch W=32u L=1u
Mactload30 n_dm30 n_dm30 vdd vdd pch W=40u L=1u
Mactmirror30 n_dd30 n_dd30 vdd vdd pch W=40u L=1u
Mactout30 n_hv30 n_dd30 vdd vdd pch W=40u L=1u
Rhvlo30 n_hv30 vref 9600
Rhvhi30 n_hv30 vbias 48000
Rfixed31_0hi vdd n_fixed31_0 40518.0531057
Rfixed31_0lo n_fixed31_0 0 59481.9468943
Mfp31_0 in4 n_fixed31_0 n_hp31 0 syn W=10u L=1u
Mfn31_0 in4 vweight n_hn31 0 syn W=10u L=1u
Rfixed31_1hi vdd n_fixed31_1 72453.7318156
Rfixed31_1lo n_fixed31_1 0 27546.2681844
Mfp31_1 in5 n_fixed31_1 n_hp31 0 syn W=10u L=1u
Mfn31_1 in5 vweight n_hn31 0 syn W=10u L=1u
Rfixed31_2hi vdd n_fixed31_2 59861.8550619
Rfixed31_2lo n_fixed31_2 0 40138.1449381
Mfp31_2 in1 n_fixed31_2 n_hp31 0 syn W=10u L=1u
Mfn31_2 in1 vweight n_hn31 0 syn W=10u L=1u
Rfixed31_3hi vdd n_fixed31_3 21326.562892
Rfixed31_3lo n_fixed31_3 0 78673.437108
Mfp31_3 in9 n_fixed31_3 n_hp31 0 syn W=10u L=1u
Mfn31_3 in9 vweight n_hn31 0 syn W=10u L=1u
Rfixed31_4hi vdd n_fixed31_4 35120.004121
Rfixed31_4lo n_fixed31_4 0 64879.995879
Mfp31_4 vbias n_fixed31_4 n_hp31 0 syn W=10u L=1u
Mfn31_4 vbias vweight n_hn31 0 syn W=10u L=1u
Mh31a n_hn31 n_hn31 0 0 nch W=20u L=1u
Mh31b n_z31 n_hn31 0 0 nch W=20u L=1u
Mh31c n_hp31 n_hp31 0 0 nch W=20u L=1u
Mh31d n_mirrorh31 n_hp31 0 0 nch W=20u L=1u
Mh31e n_mirrorh31 n_mirrorh31 vdd vdd pch W=60u L=1u
Mh31f n_z31 n_mirrorh31 vdd vdd pch W=60u L=1u
Rh31sum n_z31 vref 8000
Mactp31 n_dd31 n_z31 n_tail31 0 nch W=12u L=1u
Mactn31 n_dm31 vref n_tail31 0 nch W=12u L=1u
Macttail31 n_tail31 n_tailbias 0 0 nch W=32u L=1u
Mactload31 n_dm31 n_dm31 vdd vdd pch W=40u L=1u
Mactmirror31 n_dd31 n_dd31 vdd vdd pch W=40u L=1u
Mactout31 n_hv31 n_dd31 vdd vdd pch W=40u L=1u
Rhvlo31 n_hv31 vref 9600
Rhvhi31 n_hv31 vbias 48000
Rfixed32_0hi vdd n_fixed32_0 74872.8815469
Rfixed32_0lo n_fixed32_0 0 25127.1184531
Mfp32_0 in2 n_fixed32_0 n_hp32 0 syn W=10u L=1u
Mfn32_0 in2 vweight n_hn32 0 syn W=10u L=1u
Rfixed32_1hi vdd n_fixed32_1 54947.1556927
Rfixed32_1lo n_fixed32_1 0 45052.8443073
Mfp32_1 in4 n_fixed32_1 n_hp32 0 syn W=10u L=1u
Mfn32_1 in4 vweight n_hn32 0 syn W=10u L=1u
Rfixed32_2hi vdd n_fixed32_2 52958.8264713
Rfixed32_2lo n_fixed32_2 0 47041.1735287
Mfp32_2 in5 n_fixed32_2 n_hp32 0 syn W=10u L=1u
Mfn32_2 in5 vweight n_hn32 0 syn W=10u L=1u
Rfixed32_3hi vdd n_fixed32_3 36478.419942
Rfixed32_3lo n_fixed32_3 0 63521.580058
Mfp32_3 in14 n_fixed32_3 n_hp32 0 syn W=10u L=1u
Mfn32_3 in14 vweight n_hn32 0 syn W=10u L=1u
Rfixed32_4hi vdd n_fixed32_4 36397.6364344
Rfixed32_4lo n_fixed32_4 0 63602.3635656
Mfp32_4 vbias n_fixed32_4 n_hp32 0 syn W=10u L=1u
Mfn32_4 vbias vweight n_hn32 0 syn W=10u L=1u
Mh32a n_hn32 n_hn32 0 0 nch W=20u L=1u
Mh32b n_z32 n_hn32 0 0 nch W=20u L=1u
Mh32c n_hp32 n_hp32 0 0 nch W=20u L=1u
Mh32d n_mirrorh32 n_hp32 0 0 nch W=20u L=1u
Mh32e n_mirrorh32 n_mirrorh32 vdd vdd pch W=60u L=1u
Mh32f n_z32 n_mirrorh32 vdd vdd pch W=60u L=1u
Rh32sum n_z32 vref 8000
Mactp32 n_dd32 n_z32 n_tail32 0 nch W=12u L=1u
Mactn32 n_dm32 vref n_tail32 0 nch W=12u L=1u
Macttail32 n_tail32 n_tailbias 0 0 nch W=32u L=1u
Mactload32 n_dm32 n_dm32 vdd vdd pch W=40u L=1u
Mactmirror32 n_dd32 n_dd32 vdd vdd pch W=40u L=1u
Mactout32 n_hv32 n_dd32 vdd vdd pch W=40u L=1u
Rhvlo32 n_hv32 vref 9600
Rhvhi32 n_hv32 vbias 48000
Rfixed33_0hi vdd n_fixed33_0 70418.1891479
Rfixed33_0lo n_fixed33_0 0 29581.8108521
Mfp33_0 in0 n_fixed33_0 n_hp33 0 syn W=10u L=1u
Mfn33_0 in0 vweight n_hn33 0 syn W=10u L=1u
Rfixed33_1hi vdd n_fixed33_1 33087.902728
Rfixed33_1lo n_fixed33_1 0 66912.097272
Mfp33_1 in9 n_fixed33_1 n_hp33 0 syn W=10u L=1u
Mfn33_1 in9 vweight n_hn33 0 syn W=10u L=1u
Rfixed33_2hi vdd n_fixed33_2 35510.2153938
Rfixed33_2lo n_fixed33_2 0 64489.7846062
Mfp33_2 in10 n_fixed33_2 n_hp33 0 syn W=10u L=1u
Mfn33_2 in10 vweight n_hn33 0 syn W=10u L=1u
Rfixed33_3hi vdd n_fixed33_3 36425.53318
Rfixed33_3lo n_fixed33_3 0 63574.46682
Mfp33_3 in15 n_fixed33_3 n_hp33 0 syn W=10u L=1u
Mfn33_3 in15 vweight n_hn33 0 syn W=10u L=1u
Rfixed33_4hi vdd n_fixed33_4 41574.4597367
Rfixed33_4lo n_fixed33_4 0 58425.5402633
Mfp33_4 vbias n_fixed33_4 n_hp33 0 syn W=10u L=1u
Mfn33_4 vbias vweight n_hn33 0 syn W=10u L=1u
Mh33a n_hn33 n_hn33 0 0 nch W=20u L=1u
Mh33b n_z33 n_hn33 0 0 nch W=20u L=1u
Mh33c n_hp33 n_hp33 0 0 nch W=20u L=1u
Mh33d n_mirrorh33 n_hp33 0 0 nch W=20u L=1u
Mh33e n_mirrorh33 n_mirrorh33 vdd vdd pch W=60u L=1u
Mh33f n_z33 n_mirrorh33 vdd vdd pch W=60u L=1u
Rh33sum n_z33 vref 8000
Mactp33 n_dd33 n_z33 n_tail33 0 nch W=12u L=1u
Mactn33 n_dm33 vref n_tail33 0 nch W=12u L=1u
Macttail33 n_tail33 n_tailbias 0 0 nch W=32u L=1u
Mactload33 n_dm33 n_dm33 vdd vdd pch W=40u L=1u
Mactmirror33 n_dd33 n_dd33 vdd vdd pch W=40u L=1u
Mactout33 n_hv33 n_dd33 vdd vdd pch W=40u L=1u
Rhvlo33 n_hv33 vref 9600
Rhvhi33 n_hv33 vbias 48000
Rfixed34_0hi vdd n_fixed34_0 30417.6752288
Rfixed34_0lo n_fixed34_0 0 69582.3247712
Mfp34_0 in7 n_fixed34_0 n_hp34 0 syn W=10u L=1u
Mfn34_0 in7 vweight n_hn34 0 syn W=10u L=1u
Rfixed34_1hi vdd n_fixed34_1 24468.4426601
Rfixed34_1lo n_fixed34_1 0 75531.5573399
Mfp34_1 in12 n_fixed34_1 n_hp34 0 syn W=10u L=1u
Mfn34_1 in12 vweight n_hn34 0 syn W=10u L=1u
Rfixed34_2hi vdd n_fixed34_2 44125.6769723
Rfixed34_2lo n_fixed34_2 0 55874.3230277
Mfp34_2 in9 n_fixed34_2 n_hp34 0 syn W=10u L=1u
Mfn34_2 in9 vweight n_hn34 0 syn W=10u L=1u
Rfixed34_3hi vdd n_fixed34_3 48896.3088532
Rfixed34_3lo n_fixed34_3 0 51103.6911468
Mfp34_3 in6 n_fixed34_3 n_hp34 0 syn W=10u L=1u
Mfn34_3 in6 vweight n_hn34 0 syn W=10u L=1u
Rfixed34_4hi vdd n_fixed34_4 34993.0776118
Rfixed34_4lo n_fixed34_4 0 65006.9223882
Mfp34_4 vbias n_fixed34_4 n_hp34 0 syn W=10u L=1u
Mfn34_4 vbias vweight n_hn34 0 syn W=10u L=1u
Mh34a n_hn34 n_hn34 0 0 nch W=20u L=1u
Mh34b n_z34 n_hn34 0 0 nch W=20u L=1u
Mh34c n_hp34 n_hp34 0 0 nch W=20u L=1u
Mh34d n_mirrorh34 n_hp34 0 0 nch W=20u L=1u
Mh34e n_mirrorh34 n_mirrorh34 vdd vdd pch W=60u L=1u
Mh34f n_z34 n_mirrorh34 vdd vdd pch W=60u L=1u
Rh34sum n_z34 vref 8000
Mactp34 n_dd34 n_z34 n_tail34 0 nch W=12u L=1u
Mactn34 n_dm34 vref n_tail34 0 nch W=12u L=1u
Macttail34 n_tail34 n_tailbias 0 0 nch W=32u L=1u
Mactload34 n_dm34 n_dm34 vdd vdd pch W=40u L=1u
Mactmirror34 n_dd34 n_dd34 vdd vdd pch W=40u L=1u
Mactout34 n_hv34 n_dd34 vdd vdd pch W=40u L=1u
Rhvlo34 n_hv34 vref 9600
Rhvhi34 n_hv34 vbias 48000
Rfixed35_0hi vdd n_fixed35_0 54731.1615222
Rfixed35_0lo n_fixed35_0 0 45268.8384778
Mfp35_0 in12 n_fixed35_0 n_hp35 0 syn W=10u L=1u
Mfn35_0 in12 vweight n_hn35 0 syn W=10u L=1u
Rfixed35_1hi vdd n_fixed35_1 64986.0462456
Rfixed35_1lo n_fixed35_1 0 35013.9537544
Mfp35_1 in15 n_fixed35_1 n_hp35 0 syn W=10u L=1u
Mfn35_1 in15 vweight n_hn35 0 syn W=10u L=1u
Rfixed35_2hi vdd n_fixed35_2 48154.7640519
Rfixed35_2lo n_fixed35_2 0 51845.2359481
Mfp35_2 in8 n_fixed35_2 n_hp35 0 syn W=10u L=1u
Mfn35_2 in8 vweight n_hn35 0 syn W=10u L=1u
Rfixed35_3hi vdd n_fixed35_3 44480.210554
Rfixed35_3lo n_fixed35_3 0 55519.789446
Mfp35_3 in4 n_fixed35_3 n_hp35 0 syn W=10u L=1u
Mfn35_3 in4 vweight n_hn35 0 syn W=10u L=1u
Rfixed35_4hi vdd n_fixed35_4 34774.8298906
Rfixed35_4lo n_fixed35_4 0 65225.1701094
Mfp35_4 vbias n_fixed35_4 n_hp35 0 syn W=10u L=1u
Mfn35_4 vbias vweight n_hn35 0 syn W=10u L=1u
Mh35a n_hn35 n_hn35 0 0 nch W=20u L=1u
Mh35b n_z35 n_hn35 0 0 nch W=20u L=1u
Mh35c n_hp35 n_hp35 0 0 nch W=20u L=1u
Mh35d n_mirrorh35 n_hp35 0 0 nch W=20u L=1u
Mh35e n_mirrorh35 n_mirrorh35 vdd vdd pch W=60u L=1u
Mh35f n_z35 n_mirrorh35 vdd vdd pch W=60u L=1u
Rh35sum n_z35 vref 8000
Mactp35 n_dd35 n_z35 n_tail35 0 nch W=12u L=1u
Mactn35 n_dm35 vref n_tail35 0 nch W=12u L=1u
Macttail35 n_tail35 n_tailbias 0 0 nch W=32u L=1u
Mactload35 n_dm35 n_dm35 vdd vdd pch W=40u L=1u
Mactmirror35 n_dd35 n_dd35 vdd vdd pch W=40u L=1u
Mactout35 n_hv35 n_dd35 vdd vdd pch W=40u L=1u
Rhvlo35 n_hv35 vref 9600
Rhvhi35 n_hv35 vbias 48000
Rfixed36_0hi vdd n_fixed36_0 31279.1721288
Rfixed36_0lo n_fixed36_0 0 68720.8278712
Mfp36_0 in10 n_fixed36_0 n_hp36 0 syn W=10u L=1u
Mfn36_0 in10 vweight n_hn36 0 syn W=10u L=1u
Rfixed36_1hi vdd n_fixed36_1 76979.3758181
Rfixed36_1lo n_fixed36_1 0 23020.6241819
Mfp36_1 in0 n_fixed36_1 n_hp36 0 syn W=10u L=1u
Mfn36_1 in0 vweight n_hn36 0 syn W=10u L=1u
Rfixed36_2hi vdd n_fixed36_2 42155.968151
Rfixed36_2lo n_fixed36_2 0 57844.031849
Mfp36_2 in14 n_fixed36_2 n_hp36 0 syn W=10u L=1u
Mfn36_2 in14 vweight n_hn36 0 syn W=10u L=1u
Rfixed36_3hi vdd n_fixed36_3 54484.9598779
Rfixed36_3lo n_fixed36_3 0 45515.0401221
Mfp36_3 in13 n_fixed36_3 n_hp36 0 syn W=10u L=1u
Mfn36_3 in13 vweight n_hn36 0 syn W=10u L=1u
Rfixed36_4hi vdd n_fixed36_4 46517.2892761
Rfixed36_4lo n_fixed36_4 0 53482.7107239
Mfp36_4 vbias n_fixed36_4 n_hp36 0 syn W=10u L=1u
Mfn36_4 vbias vweight n_hn36 0 syn W=10u L=1u
Mh36a n_hn36 n_hn36 0 0 nch W=20u L=1u
Mh36b n_z36 n_hn36 0 0 nch W=20u L=1u
Mh36c n_hp36 n_hp36 0 0 nch W=20u L=1u
Mh36d n_mirrorh36 n_hp36 0 0 nch W=20u L=1u
Mh36e n_mirrorh36 n_mirrorh36 vdd vdd pch W=60u L=1u
Mh36f n_z36 n_mirrorh36 vdd vdd pch W=60u L=1u
Rh36sum n_z36 vref 8000
Mactp36 n_dd36 n_z36 n_tail36 0 nch W=12u L=1u
Mactn36 n_dm36 vref n_tail36 0 nch W=12u L=1u
Macttail36 n_tail36 n_tailbias 0 0 nch W=32u L=1u
Mactload36 n_dm36 n_dm36 vdd vdd pch W=40u L=1u
Mactmirror36 n_dd36 n_dd36 vdd vdd pch W=40u L=1u
Mactout36 n_hv36 n_dd36 vdd vdd pch W=40u L=1u
Rhvlo36 n_hv36 vref 9600
Rhvhi36 n_hv36 vbias 48000
Rfixed37_0hi vdd n_fixed37_0 29390.7790774
Rfixed37_0lo n_fixed37_0 0 70609.2209226
Mfp37_0 in2 n_fixed37_0 n_hp37 0 syn W=10u L=1u
Mfn37_0 in2 vweight n_hn37 0 syn W=10u L=1u
Rfixed37_1hi vdd n_fixed37_1 32046.5091459
Rfixed37_1lo n_fixed37_1 0 67953.4908541
Mfp37_1 in14 n_fixed37_1 n_hp37 0 syn W=10u L=1u
Mfn37_1 in14 vweight n_hn37 0 syn W=10u L=1u
Rfixed37_2hi vdd n_fixed37_2 41527.7514902
Rfixed37_2lo n_fixed37_2 0 58472.2485098
Mfp37_2 in5 n_fixed37_2 n_hp37 0 syn W=10u L=1u
Mfn37_2 in5 vweight n_hn37 0 syn W=10u L=1u
Rfixed37_3hi vdd n_fixed37_3 34984.7988586
Rfixed37_3lo n_fixed37_3 0 65015.2011414
Mfp37_3 in9 n_fixed37_3 n_hp37 0 syn W=10u L=1u
Mfn37_3 in9 vweight n_hn37 0 syn W=10u L=1u
Rfixed37_4hi vdd n_fixed37_4 28717.2993042
Rfixed37_4lo n_fixed37_4 0 71282.7006958
Mfp37_4 vbias n_fixed37_4 n_hp37 0 syn W=10u L=1u
Mfn37_4 vbias vweight n_hn37 0 syn W=10u L=1u
Mh37a n_hn37 n_hn37 0 0 nch W=20u L=1u
Mh37b n_z37 n_hn37 0 0 nch W=20u L=1u
Mh37c n_hp37 n_hp37 0 0 nch W=20u L=1u
Mh37d n_mirrorh37 n_hp37 0 0 nch W=20u L=1u
Mh37e n_mirrorh37 n_mirrorh37 vdd vdd pch W=60u L=1u
Mh37f n_z37 n_mirrorh37 vdd vdd pch W=60u L=1u
Rh37sum n_z37 vref 8000
Mactp37 n_dd37 n_z37 n_tail37 0 nch W=12u L=1u
Mactn37 n_dm37 vref n_tail37 0 nch W=12u L=1u
Macttail37 n_tail37 n_tailbias 0 0 nch W=32u L=1u
Mactload37 n_dm37 n_dm37 vdd vdd pch W=40u L=1u
Mactmirror37 n_dd37 n_dd37 vdd vdd pch W=40u L=1u
Mactout37 n_hv37 n_dd37 vdd vdd pch W=40u L=1u
Rhvlo37 n_hv37 vref 9600
Rhvhi37 n_hv37 vbias 48000
Rfixed38_0hi vdd n_fixed38_0 35365.3071626
Rfixed38_0lo n_fixed38_0 0 64634.6928374
Mfp38_0 in15 n_fixed38_0 n_hp38 0 syn W=10u L=1u
Mfn38_0 in15 vweight n_hn38 0 syn W=10u L=1u
Rfixed38_1hi vdd n_fixed38_1 29609.7454409
Rfixed38_1lo n_fixed38_1 0 70390.2545591
Mfp38_1 in10 n_fixed38_1 n_hp38 0 syn W=10u L=1u
Mfn38_1 in10 vweight n_hn38 0 syn W=10u L=1u
Rfixed38_2hi vdd n_fixed38_2 35056.4834481
Rfixed38_2lo n_fixed38_2 0 64943.5165519
Mfp38_2 in5 n_fixed38_2 n_hp38 0 syn W=10u L=1u
Mfn38_2 in5 vweight n_hn38 0 syn W=10u L=1u
Rfixed38_3hi vdd n_fixed38_3 25036.6619836
Rfixed38_3lo n_fixed38_3 0 74963.3380164
Mfp38_3 in4 n_fixed38_3 n_hp38 0 syn W=10u L=1u
Mfn38_3 in4 vweight n_hn38 0 syn W=10u L=1u
Rfixed38_4hi vdd n_fixed38_4 38464.7455179
Rfixed38_4lo n_fixed38_4 0 61535.2544821
Mfp38_4 vbias n_fixed38_4 n_hp38 0 syn W=10u L=1u
Mfn38_4 vbias vweight n_hn38 0 syn W=10u L=1u
Mh38a n_hn38 n_hn38 0 0 nch W=20u L=1u
Mh38b n_z38 n_hn38 0 0 nch W=20u L=1u
Mh38c n_hp38 n_hp38 0 0 nch W=20u L=1u
Mh38d n_mirrorh38 n_hp38 0 0 nch W=20u L=1u
Mh38e n_mirrorh38 n_mirrorh38 vdd vdd pch W=60u L=1u
Mh38f n_z38 n_mirrorh38 vdd vdd pch W=60u L=1u
Rh38sum n_z38 vref 8000
Mactp38 n_dd38 n_z38 n_tail38 0 nch W=12u L=1u
Mactn38 n_dm38 vref n_tail38 0 nch W=12u L=1u
Macttail38 n_tail38 n_tailbias 0 0 nch W=32u L=1u
Mactload38 n_dm38 n_dm38 vdd vdd pch W=40u L=1u
Mactmirror38 n_dd38 n_dd38 vdd vdd pch W=40u L=1u
Mactout38 n_hv38 n_dd38 vdd vdd pch W=40u L=1u
Rhvlo38 n_hv38 vref 9600
Rhvhi38 n_hv38 vbias 48000
Rfixed39_0hi vdd n_fixed39_0 46527.6070749
Rfixed39_0lo n_fixed39_0 0 53472.3929251
Mfp39_0 in14 n_fixed39_0 n_hp39 0 syn W=10u L=1u
Mfn39_0 in14 vweight n_hn39 0 syn W=10u L=1u
Rfixed39_1hi vdd n_fixed39_1 64584.7880875
Rfixed39_1lo n_fixed39_1 0 35415.2119125
Mfp39_1 in1 n_fixed39_1 n_hp39 0 syn W=10u L=1u
Mfn39_1 in1 vweight n_hn39 0 syn W=10u L=1u
Rfixed39_2hi vdd n_fixed39_2 71071.4861754
Rfixed39_2lo n_fixed39_2 0 28928.5138246
Mfp39_2 in10 n_fixed39_2 n_hp39 0 syn W=10u L=1u
Mfn39_2 in10 vweight n_hn39 0 syn W=10u L=1u
Rfixed39_3hi vdd n_fixed39_3 51020.6424571
Rfixed39_3lo n_fixed39_3 0 48979.3575429
Mfp39_3 in9 n_fixed39_3 n_hp39 0 syn W=10u L=1u
Mfn39_3 in9 vweight n_hn39 0 syn W=10u L=1u
Rfixed39_4hi vdd n_fixed39_4 35469.3044273
Rfixed39_4lo n_fixed39_4 0 64530.6955727
Mfp39_4 vbias n_fixed39_4 n_hp39 0 syn W=10u L=1u
Mfn39_4 vbias vweight n_hn39 0 syn W=10u L=1u
Mh39a n_hn39 n_hn39 0 0 nch W=20u L=1u
Mh39b n_z39 n_hn39 0 0 nch W=20u L=1u
Mh39c n_hp39 n_hp39 0 0 nch W=20u L=1u
Mh39d n_mirrorh39 n_hp39 0 0 nch W=20u L=1u
Mh39e n_mirrorh39 n_mirrorh39 vdd vdd pch W=60u L=1u
Mh39f n_z39 n_mirrorh39 vdd vdd pch W=60u L=1u
Rh39sum n_z39 vref 8000
Mactp39 n_dd39 n_z39 n_tail39 0 nch W=12u L=1u
Mactn39 n_dm39 vref n_tail39 0 nch W=12u L=1u
Macttail39 n_tail39 n_tailbias 0 0 nch W=32u L=1u
Mactload39 n_dm39 n_dm39 vdd vdd pch W=40u L=1u
Mactmirror39 n_dd39 n_dd39 vdd vdd pch W=40u L=1u
Mactout39 n_hv39 n_dd39 vdd vdd pch W=40u L=1u
Rhvlo39 n_hv39 vref 9600
Rhvhi39 n_hv39 vbias 48000
Rfixed40_0hi vdd n_fixed40_0 19783.7556894
Rfixed40_0lo n_fixed40_0 0 80216.2443106
Mfp40_0 in10 n_fixed40_0 n_hp40 0 syn W=10u L=1u
Mfn40_0 in10 vweight n_hn40 0 syn W=10u L=1u
Rfixed40_1hi vdd n_fixed40_1 68905.582294
Rfixed40_1lo n_fixed40_1 0 31094.417706
Mfp40_1 in2 n_fixed40_1 n_hp40 0 syn W=10u L=1u
Mfn40_1 in2 vweight n_hn40 0 syn W=10u L=1u
Rfixed40_2hi vdd n_fixed40_2 44898.1815276
Rfixed40_2lo n_fixed40_2 0 55101.8184724
Mfp40_2 in5 n_fixed40_2 n_hp40 0 syn W=10u L=1u
Mfn40_2 in5 vweight n_hn40 0 syn W=10u L=1u
Rfixed40_3hi vdd n_fixed40_3 25783.8039395
Rfixed40_3lo n_fixed40_3 0 74216.1960605
Mfp40_3 in12 n_fixed40_3 n_hp40 0 syn W=10u L=1u
Mfn40_3 in12 vweight n_hn40 0 syn W=10u L=1u
Rfixed40_4hi vdd n_fixed40_4 50540.8694023
Rfixed40_4lo n_fixed40_4 0 49459.1305977
Mfp40_4 vbias n_fixed40_4 n_hp40 0 syn W=10u L=1u
Mfn40_4 vbias vweight n_hn40 0 syn W=10u L=1u
Mh40a n_hn40 n_hn40 0 0 nch W=20u L=1u
Mh40b n_z40 n_hn40 0 0 nch W=20u L=1u
Mh40c n_hp40 n_hp40 0 0 nch W=20u L=1u
Mh40d n_mirrorh40 n_hp40 0 0 nch W=20u L=1u
Mh40e n_mirrorh40 n_mirrorh40 vdd vdd pch W=60u L=1u
Mh40f n_z40 n_mirrorh40 vdd vdd pch W=60u L=1u
Rh40sum n_z40 vref 8000
Mactp40 n_dd40 n_z40 n_tail40 0 nch W=12u L=1u
Mactn40 n_dm40 vref n_tail40 0 nch W=12u L=1u
Macttail40 n_tail40 n_tailbias 0 0 nch W=32u L=1u
Mactload40 n_dm40 n_dm40 vdd vdd pch W=40u L=1u
Mactmirror40 n_dd40 n_dd40 vdd vdd pch W=40u L=1u
Mactout40 n_hv40 n_dd40 vdd vdd pch W=40u L=1u
Rhvlo40 n_hv40 vref 9600
Rhvhi40 n_hv40 vbias 48000
Rfixed41_0hi vdd n_fixed41_0 46013.7053186
Rfixed41_0lo n_fixed41_0 0 53986.2946814
Mfp41_0 in2 n_fixed41_0 n_hp41 0 syn W=10u L=1u
Mfn41_0 in2 vweight n_hn41 0 syn W=10u L=1u
Rfixed41_1hi vdd n_fixed41_1 33952.3539952
Rfixed41_1lo n_fixed41_1 0 66047.6460048
Mfp41_1 in3 n_fixed41_1 n_hp41 0 syn W=10u L=1u
Mfn41_1 in3 vweight n_hn41 0 syn W=10u L=1u
Rfixed41_2hi vdd n_fixed41_2 55775.3825881
Rfixed41_2lo n_fixed41_2 0 44224.6174119
Mfp41_2 in14 n_fixed41_2 n_hp41 0 syn W=10u L=1u
Mfn41_2 in14 vweight n_hn41 0 syn W=10u L=1u
Rfixed41_3hi vdd n_fixed41_3 43795.4868451
Rfixed41_3lo n_fixed41_3 0 56204.5131549
Mfp41_3 in0 n_fixed41_3 n_hp41 0 syn W=10u L=1u
Mfn41_3 in0 vweight n_hn41 0 syn W=10u L=1u
Rfixed41_4hi vdd n_fixed41_4 23351.4037446
Rfixed41_4lo n_fixed41_4 0 76648.5962554
Mfp41_4 vbias n_fixed41_4 n_hp41 0 syn W=10u L=1u
Mfn41_4 vbias vweight n_hn41 0 syn W=10u L=1u
Mh41a n_hn41 n_hn41 0 0 nch W=20u L=1u
Mh41b n_z41 n_hn41 0 0 nch W=20u L=1u
Mh41c n_hp41 n_hp41 0 0 nch W=20u L=1u
Mh41d n_mirrorh41 n_hp41 0 0 nch W=20u L=1u
Mh41e n_mirrorh41 n_mirrorh41 vdd vdd pch W=60u L=1u
Mh41f n_z41 n_mirrorh41 vdd vdd pch W=60u L=1u
Rh41sum n_z41 vref 8000
Mactp41 n_dd41 n_z41 n_tail41 0 nch W=12u L=1u
Mactn41 n_dm41 vref n_tail41 0 nch W=12u L=1u
Macttail41 n_tail41 n_tailbias 0 0 nch W=32u L=1u
Mactload41 n_dm41 n_dm41 vdd vdd pch W=40u L=1u
Mactmirror41 n_dd41 n_dd41 vdd vdd pch W=40u L=1u
Mactout41 n_hv41 n_dd41 vdd vdd pch W=40u L=1u
Rhvlo41 n_hv41 vref 9600
Rhvhi41 n_hv41 vbias 48000
Rfixed42_0hi vdd n_fixed42_0 47494.8602871
Rfixed42_0lo n_fixed42_0 0 52505.1397129
Mfp42_0 in2 n_fixed42_0 n_hp42 0 syn W=10u L=1u
Mfn42_0 in2 vweight n_hn42 0 syn W=10u L=1u
Rfixed42_1hi vdd n_fixed42_1 11422.6723728
Rfixed42_1lo n_fixed42_1 0 88577.3276272
Mfp42_1 in0 n_fixed42_1 n_hp42 0 syn W=10u L=1u
Mfn42_1 in0 vweight n_hn42 0 syn W=10u L=1u
Rfixed42_2hi vdd n_fixed42_2 73180.1341785
Rfixed42_2lo n_fixed42_2 0 26819.8658215
Mfp42_2 in10 n_fixed42_2 n_hp42 0 syn W=10u L=1u
Mfn42_2 in10 vweight n_hn42 0 syn W=10u L=1u
Rfixed42_3hi vdd n_fixed42_3 38594.2426639
Rfixed42_3lo n_fixed42_3 0 61405.7573361
Mfp42_3 in14 n_fixed42_3 n_hp42 0 syn W=10u L=1u
Mfn42_3 in14 vweight n_hn42 0 syn W=10u L=1u
Rfixed42_4hi vdd n_fixed42_4 34431.7552168
Rfixed42_4lo n_fixed42_4 0 65568.2447832
Mfp42_4 vbias n_fixed42_4 n_hp42 0 syn W=10u L=1u
Mfn42_4 vbias vweight n_hn42 0 syn W=10u L=1u
Mh42a n_hn42 n_hn42 0 0 nch W=20u L=1u
Mh42b n_z42 n_hn42 0 0 nch W=20u L=1u
Mh42c n_hp42 n_hp42 0 0 nch W=20u L=1u
Mh42d n_mirrorh42 n_hp42 0 0 nch W=20u L=1u
Mh42e n_mirrorh42 n_mirrorh42 vdd vdd pch W=60u L=1u
Mh42f n_z42 n_mirrorh42 vdd vdd pch W=60u L=1u
Rh42sum n_z42 vref 8000
Mactp42 n_dd42 n_z42 n_tail42 0 nch W=12u L=1u
Mactn42 n_dm42 vref n_tail42 0 nch W=12u L=1u
Macttail42 n_tail42 n_tailbias 0 0 nch W=32u L=1u
Mactload42 n_dm42 n_dm42 vdd vdd pch W=40u L=1u
Mactmirror42 n_dd42 n_dd42 vdd vdd pch W=40u L=1u
Mactout42 n_hv42 n_dd42 vdd vdd pch W=40u L=1u
Rhvlo42 n_hv42 vref 9600
Rhvhi42 n_hv42 vbias 48000
Rfixed43_0hi vdd n_fixed43_0 23793.4867698
Rfixed43_0lo n_fixed43_0 0 76206.5132302
Mfp43_0 in10 n_fixed43_0 n_hp43 0 syn W=10u L=1u
Mfn43_0 in10 vweight n_hn43 0 syn W=10u L=1u
Rfixed43_1hi vdd n_fixed43_1 26624.3393651
Rfixed43_1lo n_fixed43_1 0 73375.6606349
Mfp43_1 in1 n_fixed43_1 n_hp43 0 syn W=10u L=1u
Mfn43_1 in1 vweight n_hn43 0 syn W=10u L=1u
Rfixed43_2hi vdd n_fixed43_2 14450.4002314
Rfixed43_2lo n_fixed43_2 0 85549.5997686
Mfp43_2 in8 n_fixed43_2 n_hp43 0 syn W=10u L=1u
Mfn43_2 in8 vweight n_hn43 0 syn W=10u L=1u
Rfixed43_3hi vdd n_fixed43_3 9196.21118775
Rfixed43_3lo n_fixed43_3 0 90803.7888123
Mfp43_3 in15 n_fixed43_3 n_hp43 0 syn W=10u L=1u
Mfn43_3 in15 vweight n_hn43 0 syn W=10u L=1u
Rfixed43_4hi vdd n_fixed43_4 41466.0752037
Rfixed43_4lo n_fixed43_4 0 58533.9247963
Mfp43_4 vbias n_fixed43_4 n_hp43 0 syn W=10u L=1u
Mfn43_4 vbias vweight n_hn43 0 syn W=10u L=1u
Mh43a n_hn43 n_hn43 0 0 nch W=20u L=1u
Mh43b n_z43 n_hn43 0 0 nch W=20u L=1u
Mh43c n_hp43 n_hp43 0 0 nch W=20u L=1u
Mh43d n_mirrorh43 n_hp43 0 0 nch W=20u L=1u
Mh43e n_mirrorh43 n_mirrorh43 vdd vdd pch W=60u L=1u
Mh43f n_z43 n_mirrorh43 vdd vdd pch W=60u L=1u
Rh43sum n_z43 vref 8000
Mactp43 n_dd43 n_z43 n_tail43 0 nch W=12u L=1u
Mactn43 n_dm43 vref n_tail43 0 nch W=12u L=1u
Macttail43 n_tail43 n_tailbias 0 0 nch W=32u L=1u
Mactload43 n_dm43 n_dm43 vdd vdd pch W=40u L=1u
Mactmirror43 n_dd43 n_dd43 vdd vdd pch W=40u L=1u
Mactout43 n_hv43 n_dd43 vdd vdd pch W=40u L=1u
Rhvlo43 n_hv43 vref 9600
Rhvhi43 n_hv43 vbias 48000
Rfixed44_0hi vdd n_fixed44_0 77247.5703565
Rfixed44_0lo n_fixed44_0 0 22752.4296435
Mfp44_0 in10 n_fixed44_0 n_hp44 0 syn W=10u L=1u
Mfn44_0 in10 vweight n_hn44 0 syn W=10u L=1u
Rfixed44_1hi vdd n_fixed44_1 43369.4562483
Rfixed44_1lo n_fixed44_1 0 56630.5437517
Mfp44_1 in4 n_fixed44_1 n_hp44 0 syn W=10u L=1u
Mfn44_1 in4 vweight n_hn44 0 syn W=10u L=1u
Rfixed44_2hi vdd n_fixed44_2 49524.2739711
Rfixed44_2lo n_fixed44_2 0 50475.7260289
Mfp44_2 in1 n_fixed44_2 n_hp44 0 syn W=10u L=1u
Mfn44_2 in1 vweight n_hn44 0 syn W=10u L=1u
Rfixed44_3hi vdd n_fixed44_3 6666.66666667
Rfixed44_3lo n_fixed44_3 0 93333.3333333
Mfp44_3 in11 n_fixed44_3 n_hp44 0 syn W=10u L=1u
Mfn44_3 in11 vweight n_hn44 0 syn W=10u L=1u
Rfixed44_4hi vdd n_fixed44_4 28479.6633503
Rfixed44_4lo n_fixed44_4 0 71520.3366497
Mfp44_4 vbias n_fixed44_4 n_hp44 0 syn W=10u L=1u
Mfn44_4 vbias vweight n_hn44 0 syn W=10u L=1u
Mh44a n_hn44 n_hn44 0 0 nch W=20u L=1u
Mh44b n_z44 n_hn44 0 0 nch W=20u L=1u
Mh44c n_hp44 n_hp44 0 0 nch W=20u L=1u
Mh44d n_mirrorh44 n_hp44 0 0 nch W=20u L=1u
Mh44e n_mirrorh44 n_mirrorh44 vdd vdd pch W=60u L=1u
Mh44f n_z44 n_mirrorh44 vdd vdd pch W=60u L=1u
Rh44sum n_z44 vref 8000
Mactp44 n_dd44 n_z44 n_tail44 0 nch W=12u L=1u
Mactn44 n_dm44 vref n_tail44 0 nch W=12u L=1u
Macttail44 n_tail44 n_tailbias 0 0 nch W=32u L=1u
Mactload44 n_dm44 n_dm44 vdd vdd pch W=40u L=1u
Mactmirror44 n_dd44 n_dd44 vdd vdd pch W=40u L=1u
Mactout44 n_hv44 n_dd44 vdd vdd pch W=40u L=1u
Rhvlo44 n_hv44 vref 9600
Rhvhi44 n_hv44 vbias 48000
Rfixed45_0hi vdd n_fixed45_0 11542.0271637
Rfixed45_0lo n_fixed45_0 0 88457.9728363
Mfp45_0 in1 n_fixed45_0 n_hp45 0 syn W=10u L=1u
Mfn45_0 in1 vweight n_hn45 0 syn W=10u L=1u
Rfixed45_1hi vdd n_fixed45_1 27936.9510071
Rfixed45_1lo n_fixed45_1 0 72063.0489929
Mfp45_1 in12 n_fixed45_1 n_hp45 0 syn W=10u L=1u
Mfn45_1 in12 vweight n_hn45 0 syn W=10u L=1u
Rfixed45_2hi vdd n_fixed45_2 74277.2980507
Rfixed45_2lo n_fixed45_2 0 25722.7019493
Mfp45_2 in5 n_fixed45_2 n_hp45 0 syn W=10u L=1u
Mfn45_2 in5 vweight n_hn45 0 syn W=10u L=1u
Rfixed45_3hi vdd n_fixed45_3 25106.2278265
Rfixed45_3lo n_fixed45_3 0 74893.7721735
Mfp45_3 in9 n_fixed45_3 n_hp45 0 syn W=10u L=1u
Mfn45_3 in9 vweight n_hn45 0 syn W=10u L=1u
Rfixed45_4hi vdd n_fixed45_4 51618.144114
Rfixed45_4lo n_fixed45_4 0 48381.855886
Mfp45_4 vbias n_fixed45_4 n_hp45 0 syn W=10u L=1u
Mfn45_4 vbias vweight n_hn45 0 syn W=10u L=1u
Mh45a n_hn45 n_hn45 0 0 nch W=20u L=1u
Mh45b n_z45 n_hn45 0 0 nch W=20u L=1u
Mh45c n_hp45 n_hp45 0 0 nch W=20u L=1u
Mh45d n_mirrorh45 n_hp45 0 0 nch W=20u L=1u
Mh45e n_mirrorh45 n_mirrorh45 vdd vdd pch W=60u L=1u
Mh45f n_z45 n_mirrorh45 vdd vdd pch W=60u L=1u
Rh45sum n_z45 vref 8000
Mactp45 n_dd45 n_z45 n_tail45 0 nch W=12u L=1u
Mactn45 n_dm45 vref n_tail45 0 nch W=12u L=1u
Macttail45 n_tail45 n_tailbias 0 0 nch W=32u L=1u
Mactload45 n_dm45 n_dm45 vdd vdd pch W=40u L=1u
Mactmirror45 n_dd45 n_dd45 vdd vdd pch W=40u L=1u
Mactout45 n_hv45 n_dd45 vdd vdd pch W=40u L=1u
Rhvlo45 n_hv45 vref 9600
Rhvhi45 n_hv45 vbias 48000
Rfixed46_0hi vdd n_fixed46_0 45113.4776405
Rfixed46_0lo n_fixed46_0 0 54886.5223595
Mfp46_0 in6 n_fixed46_0 n_hp46 0 syn W=10u L=1u
Mfn46_0 in6 vweight n_hn46 0 syn W=10u L=1u
Rfixed46_1hi vdd n_fixed46_1 41227.376182
Rfixed46_1lo n_fixed46_1 0 58772.623818
Mfp46_1 in2 n_fixed46_1 n_hp46 0 syn W=10u L=1u
Mfn46_1 in2 vweight n_hn46 0 syn W=10u L=1u
Rfixed46_2hi vdd n_fixed46_2 31865.1908291
Rfixed46_2lo n_fixed46_2 0 68134.8091709
Mfp46_2 in4 n_fixed46_2 n_hp46 0 syn W=10u L=1u
Mfn46_2 in4 vweight n_hn46 0 syn W=10u L=1u
Rfixed46_3hi vdd n_fixed46_3 49573.3769763
Rfixed46_3lo n_fixed46_3 0 50426.6230237
Mfp46_3 in15 n_fixed46_3 n_hp46 0 syn W=10u L=1u
Mfn46_3 in15 vweight n_hn46 0 syn W=10u L=1u
Rfixed46_4hi vdd n_fixed46_4 37809.3847945
Rfixed46_4lo n_fixed46_4 0 62190.6152055
Mfp46_4 vbias n_fixed46_4 n_hp46 0 syn W=10u L=1u
Mfn46_4 vbias vweight n_hn46 0 syn W=10u L=1u
Mh46a n_hn46 n_hn46 0 0 nch W=20u L=1u
Mh46b n_z46 n_hn46 0 0 nch W=20u L=1u
Mh46c n_hp46 n_hp46 0 0 nch W=20u L=1u
Mh46d n_mirrorh46 n_hp46 0 0 nch W=20u L=1u
Mh46e n_mirrorh46 n_mirrorh46 vdd vdd pch W=60u L=1u
Mh46f n_z46 n_mirrorh46 vdd vdd pch W=60u L=1u
Rh46sum n_z46 vref 8000
Mactp46 n_dd46 n_z46 n_tail46 0 nch W=12u L=1u
Mactn46 n_dm46 vref n_tail46 0 nch W=12u L=1u
Macttail46 n_tail46 n_tailbias 0 0 nch W=32u L=1u
Mactload46 n_dm46 n_dm46 vdd vdd pch W=40u L=1u
Mactmirror46 n_dd46 n_dd46 vdd vdd pch W=40u L=1u
Mactout46 n_hv46 n_dd46 vdd vdd pch W=40u L=1u
Rhvlo46 n_hv46 vref 9600
Rhvhi46 n_hv46 vbias 48000
Rfixed47_0hi vdd n_fixed47_0 64848.3294067
Rfixed47_0lo n_fixed47_0 0 35151.6705933
Mfp47_0 in14 n_fixed47_0 n_hp47 0 syn W=10u L=1u
Mfn47_0 in14 vweight n_hn47 0 syn W=10u L=1u
Rfixed47_1hi vdd n_fixed47_1 40024.7657545
Rfixed47_1lo n_fixed47_1 0 59975.2342455
Mfp47_1 in12 n_fixed47_1 n_hp47 0 syn W=10u L=1u
Mfn47_1 in12 vweight n_hn47 0 syn W=10u L=1u
Rfixed47_2hi vdd n_fixed47_2 22068.890906
Rfixed47_2lo n_fixed47_2 0 77931.109094
Mfp47_2 in6 n_fixed47_2 n_hp47 0 syn W=10u L=1u
Mfn47_2 in6 vweight n_hn47 0 syn W=10u L=1u
Rfixed47_3hi vdd n_fixed47_3 42393.6252963
Rfixed47_3lo n_fixed47_3 0 57606.3747037
Mfp47_3 in8 n_fixed47_3 n_hp47 0 syn W=10u L=1u
Mfn47_3 in8 vweight n_hn47 0 syn W=10u L=1u
Rfixed47_4hi vdd n_fixed47_4 40291.786154
Rfixed47_4lo n_fixed47_4 0 59708.213846
Mfp47_4 vbias n_fixed47_4 n_hp47 0 syn W=10u L=1u
Mfn47_4 vbias vweight n_hn47 0 syn W=10u L=1u
Mh47a n_hn47 n_hn47 0 0 nch W=20u L=1u
Mh47b n_z47 n_hn47 0 0 nch W=20u L=1u
Mh47c n_hp47 n_hp47 0 0 nch W=20u L=1u
Mh47d n_mirrorh47 n_hp47 0 0 nch W=20u L=1u
Mh47e n_mirrorh47 n_mirrorh47 vdd vdd pch W=60u L=1u
Mh47f n_z47 n_mirrorh47 vdd vdd pch W=60u L=1u
Rh47sum n_z47 vref 8000
Mactp47 n_dd47 n_z47 n_tail47 0 nch W=12u L=1u
Mactn47 n_dm47 vref n_tail47 0 nch W=12u L=1u
Macttail47 n_tail47 n_tailbias 0 0 nch W=32u L=1u
Mactload47 n_dm47 n_dm47 vdd vdd pch W=40u L=1u
Mactmirror47 n_dd47 n_dd47 vdd vdd pch W=40u L=1u
Mactout47 n_hv47 n_dd47 vdd vdd pch W=40u L=1u
Rhvlo47 n_hv47 vref 9600
Rhvhi47 n_hv47 vbias 48000
Rfixed48_0hi vdd n_fixed48_0 16248.556213
Rfixed48_0lo n_fixed48_0 0 83751.443787
Mfp48_0 in10 n_fixed48_0 n_hp48 0 syn W=10u L=1u
Mfn48_0 in10 vweight n_hn48 0 syn W=10u L=1u
Rfixed48_1hi vdd n_fixed48_1 36328.5743266
Rfixed48_1lo n_fixed48_1 0 63671.4256734
Mfp48_1 in2 n_fixed48_1 n_hp48 0 syn W=10u L=1u
Mfn48_1 in2 vweight n_hn48 0 syn W=10u L=1u
Rfixed48_2hi vdd n_fixed48_2 58769.2171964
Rfixed48_2lo n_fixed48_2 0 41230.7828036
Mfp48_2 in4 n_fixed48_2 n_hp48 0 syn W=10u L=1u
Mfn48_2 in4 vweight n_hn48 0 syn W=10u L=1u
Rfixed48_3hi vdd n_fixed48_3 29166.2942268
Rfixed48_3lo n_fixed48_3 0 70833.7057732
Mfp48_3 in7 n_fixed48_3 n_hp48 0 syn W=10u L=1u
Mfn48_3 in7 vweight n_hn48 0 syn W=10u L=1u
Rfixed48_4hi vdd n_fixed48_4 32787.3606138
Rfixed48_4lo n_fixed48_4 0 67212.6393862
Mfp48_4 vbias n_fixed48_4 n_hp48 0 syn W=10u L=1u
Mfn48_4 vbias vweight n_hn48 0 syn W=10u L=1u
Mh48a n_hn48 n_hn48 0 0 nch W=20u L=1u
Mh48b n_z48 n_hn48 0 0 nch W=20u L=1u
Mh48c n_hp48 n_hp48 0 0 nch W=20u L=1u
Mh48d n_mirrorh48 n_hp48 0 0 nch W=20u L=1u
Mh48e n_mirrorh48 n_mirrorh48 vdd vdd pch W=60u L=1u
Mh48f n_z48 n_mirrorh48 vdd vdd pch W=60u L=1u
Rh48sum n_z48 vref 8000
Mactp48 n_dd48 n_z48 n_tail48 0 nch W=12u L=1u
Mactn48 n_dm48 vref n_tail48 0 nch W=12u L=1u
Macttail48 n_tail48 n_tailbias 0 0 nch W=32u L=1u
Mactload48 n_dm48 n_dm48 vdd vdd pch W=40u L=1u
Mactmirror48 n_dd48 n_dd48 vdd vdd pch W=40u L=1u
Mactout48 n_hv48 n_dd48 vdd vdd pch W=40u L=1u
Rhvlo48 n_hv48 vref 9600
Rhvhi48 n_hv48 vbias 48000
Rfixed49_0hi vdd n_fixed49_0 34043.7856897
Rfixed49_0lo n_fixed49_0 0 65956.2143103
Mfp49_0 in4 n_fixed49_0 n_hp49 0 syn W=10u L=1u
Mfn49_0 in4 vweight n_hn49 0 syn W=10u L=1u
Rfixed49_1hi vdd n_fixed49_1 41792.3615562
Rfixed49_1lo n_fixed49_1 0 58207.6384438
Mfp49_1 in9 n_fixed49_1 n_hp49 0 syn W=10u L=1u
Mfn49_1 in9 vweight n_hn49 0 syn W=10u L=1u
Rfixed49_2hi vdd n_fixed49_2 8731.22385179
Rfixed49_2lo n_fixed49_2 0 91268.7761482
Mfp49_2 in2 n_fixed49_2 n_hp49 0 syn W=10u L=1u
Mfn49_2 in2 vweight n_hn49 0 syn W=10u L=1u
Rfixed49_3hi vdd n_fixed49_3 53514.2773948
Rfixed49_3lo n_fixed49_3 0 46485.7226052
Mfp49_3 in13 n_fixed49_3 n_hp49 0 syn W=10u L=1u
Mfn49_3 in13 vweight n_hn49 0 syn W=10u L=1u
Rfixed49_4hi vdd n_fixed49_4 34946.3078622
Rfixed49_4lo n_fixed49_4 0 65053.6921378
Mfp49_4 vbias n_fixed49_4 n_hp49 0 syn W=10u L=1u
Mfn49_4 vbias vweight n_hn49 0 syn W=10u L=1u
Mh49a n_hn49 n_hn49 0 0 nch W=20u L=1u
Mh49b n_z49 n_hn49 0 0 nch W=20u L=1u
Mh49c n_hp49 n_hp49 0 0 nch W=20u L=1u
Mh49d n_mirrorh49 n_hp49 0 0 nch W=20u L=1u
Mh49e n_mirrorh49 n_mirrorh49 vdd vdd pch W=60u L=1u
Mh49f n_z49 n_mirrorh49 vdd vdd pch W=60u L=1u
Rh49sum n_z49 vref 8000
Mactp49 n_dd49 n_z49 n_tail49 0 nch W=12u L=1u
Mactn49 n_dm49 vref n_tail49 0 nch W=12u L=1u
Macttail49 n_tail49 n_tailbias 0 0 nch W=32u L=1u
Mactload49 n_dm49 n_dm49 vdd vdd pch W=40u L=1u
Mactmirror49 n_dd49 n_dd49 vdd vdd pch W=40u L=1u
Mactout49 n_hv49 n_dd49 vdd vdd pch W=40u L=1u
Rhvlo49 n_hv49 vref 9600
Rhvhi49 n_hv49 vbias 48000
Rfixed50_0hi vdd n_fixed50_0 33600.6873616
Rfixed50_0lo n_fixed50_0 0 66399.3126384
Mfp50_0 in2 n_fixed50_0 n_hp50 0 syn W=10u L=1u
Mfn50_0 in2 vweight n_hn50 0 syn W=10u L=1u
Rfixed50_1hi vdd n_fixed50_1 26921.134457
Rfixed50_1lo n_fixed50_1 0 73078.865543
Mfp50_1 in3 n_fixed50_1 n_hp50 0 syn W=10u L=1u
Mfn50_1 in3 vweight n_hn50 0 syn W=10u L=1u
Rfixed50_2hi vdd n_fixed50_2 10655.5212851
Rfixed50_2lo n_fixed50_2 0 89344.4787149
Mfp50_2 in7 n_fixed50_2 n_hp50 0 syn W=10u L=1u
Mfn50_2 in7 vweight n_hn50 0 syn W=10u L=1u
Rfixed50_3hi vdd n_fixed50_3 63347.7401299
Rfixed50_3lo n_fixed50_3 0 36652.2598701
Mfp50_3 in0 n_fixed50_3 n_hp50 0 syn W=10u L=1u
Mfn50_3 in0 vweight n_hn50 0 syn W=10u L=1u
Rfixed50_4hi vdd n_fixed50_4 29231.2791086
Rfixed50_4lo n_fixed50_4 0 70768.7208914
Mfp50_4 vbias n_fixed50_4 n_hp50 0 syn W=10u L=1u
Mfn50_4 vbias vweight n_hn50 0 syn W=10u L=1u
Mh50a n_hn50 n_hn50 0 0 nch W=20u L=1u
Mh50b n_z50 n_hn50 0 0 nch W=20u L=1u
Mh50c n_hp50 n_hp50 0 0 nch W=20u L=1u
Mh50d n_mirrorh50 n_hp50 0 0 nch W=20u L=1u
Mh50e n_mirrorh50 n_mirrorh50 vdd vdd pch W=60u L=1u
Mh50f n_z50 n_mirrorh50 vdd vdd pch W=60u L=1u
Rh50sum n_z50 vref 8000
Mactp50 n_dd50 n_z50 n_tail50 0 nch W=12u L=1u
Mactn50 n_dm50 vref n_tail50 0 nch W=12u L=1u
Macttail50 n_tail50 n_tailbias 0 0 nch W=32u L=1u
Mactload50 n_dm50 n_dm50 vdd vdd pch W=40u L=1u
Mactmirror50 n_dd50 n_dd50 vdd vdd pch W=40u L=1u
Mactout50 n_hv50 n_dd50 vdd vdd pch W=40u L=1u
Rhvlo50 n_hv50 vref 9600
Rhvhi50 n_hv50 vbias 48000
Rfixed51_0hi vdd n_fixed51_0 50116.9248704
Rfixed51_0lo n_fixed51_0 0 49883.0751296
Mfp51_0 in7 n_fixed51_0 n_hp51 0 syn W=10u L=1u
Mfn51_0 in7 vweight n_hn51 0 syn W=10u L=1u
Rfixed51_1hi vdd n_fixed51_1 56106.2677582
Rfixed51_1lo n_fixed51_1 0 43893.7322418
Mfp51_1 in3 n_fixed51_1 n_hp51 0 syn W=10u L=1u
Mfn51_1 in3 vweight n_hn51 0 syn W=10u L=1u
Rfixed51_2hi vdd n_fixed51_2 78506.6136335
Rfixed51_2lo n_fixed51_2 0 21493.3863665
Mfp51_2 in5 n_fixed51_2 n_hp51 0 syn W=10u L=1u
Mfn51_2 in5 vweight n_hn51 0 syn W=10u L=1u
Rfixed51_3hi vdd n_fixed51_3 43495.1672563
Rfixed51_3lo n_fixed51_3 0 56504.8327437
Mfp51_3 in15 n_fixed51_3 n_hp51 0 syn W=10u L=1u
Mfn51_3 in15 vweight n_hn51 0 syn W=10u L=1u
Rfixed51_4hi vdd n_fixed51_4 47349.5841458
Rfixed51_4lo n_fixed51_4 0 52650.4158542
Mfp51_4 vbias n_fixed51_4 n_hp51 0 syn W=10u L=1u
Mfn51_4 vbias vweight n_hn51 0 syn W=10u L=1u
Mh51a n_hn51 n_hn51 0 0 nch W=20u L=1u
Mh51b n_z51 n_hn51 0 0 nch W=20u L=1u
Mh51c n_hp51 n_hp51 0 0 nch W=20u L=1u
Mh51d n_mirrorh51 n_hp51 0 0 nch W=20u L=1u
Mh51e n_mirrorh51 n_mirrorh51 vdd vdd pch W=60u L=1u
Mh51f n_z51 n_mirrorh51 vdd vdd pch W=60u L=1u
Rh51sum n_z51 vref 8000
Mactp51 n_dd51 n_z51 n_tail51 0 nch W=12u L=1u
Mactn51 n_dm51 vref n_tail51 0 nch W=12u L=1u
Macttail51 n_tail51 n_tailbias 0 0 nch W=32u L=1u
Mactload51 n_dm51 n_dm51 vdd vdd pch W=40u L=1u
Mactmirror51 n_dd51 n_dd51 vdd vdd pch W=40u L=1u
Mactout51 n_hv51 n_dd51 vdd vdd pch W=40u L=1u
Rhvlo51 n_hv51 vref 9600
Rhvhi51 n_hv51 vbias 48000
Rfixed52_0hi vdd n_fixed52_0 15073.8211583
Rfixed52_0lo n_fixed52_0 0 84926.1788417
Mfp52_0 in8 n_fixed52_0 n_hp52 0 syn W=10u L=1u
Mfn52_0 in8 vweight n_hn52 0 syn W=10u L=1u
Rfixed52_1hi vdd n_fixed52_1 53378.0379195
Rfixed52_1lo n_fixed52_1 0 46621.9620805
Mfp52_1 in10 n_fixed52_1 n_hp52 0 syn W=10u L=1u
Mfn52_1 in10 vweight n_hn52 0 syn W=10u L=1u
Rfixed52_2hi vdd n_fixed52_2 49774.6474301
Rfixed52_2lo n_fixed52_2 0 50225.3525699
Mfp52_2 in3 n_fixed52_2 n_hp52 0 syn W=10u L=1u
Mfn52_2 in3 vweight n_hn52 0 syn W=10u L=1u
Rfixed52_3hi vdd n_fixed52_3 52648.6653713
Rfixed52_3lo n_fixed52_3 0 47351.3346287
Mfp52_3 in0 n_fixed52_3 n_hp52 0 syn W=10u L=1u
Mfn52_3 in0 vweight n_hn52 0 syn W=10u L=1u
Rfixed52_4hi vdd n_fixed52_4 54739.1357838
Rfixed52_4lo n_fixed52_4 0 45260.8642162
Mfp52_4 vbias n_fixed52_4 n_hp52 0 syn W=10u L=1u
Mfn52_4 vbias vweight n_hn52 0 syn W=10u L=1u
Mh52a n_hn52 n_hn52 0 0 nch W=20u L=1u
Mh52b n_z52 n_hn52 0 0 nch W=20u L=1u
Mh52c n_hp52 n_hp52 0 0 nch W=20u L=1u
Mh52d n_mirrorh52 n_hp52 0 0 nch W=20u L=1u
Mh52e n_mirrorh52 n_mirrorh52 vdd vdd pch W=60u L=1u
Mh52f n_z52 n_mirrorh52 vdd vdd pch W=60u L=1u
Rh52sum n_z52 vref 8000
Mactp52 n_dd52 n_z52 n_tail52 0 nch W=12u L=1u
Mactn52 n_dm52 vref n_tail52 0 nch W=12u L=1u
Macttail52 n_tail52 n_tailbias 0 0 nch W=32u L=1u
Mactload52 n_dm52 n_dm52 vdd vdd pch W=40u L=1u
Mactmirror52 n_dd52 n_dd52 vdd vdd pch W=40u L=1u
Mactout52 n_hv52 n_dd52 vdd vdd pch W=40u L=1u
Rhvlo52 n_hv52 vref 9600
Rhvhi52 n_hv52 vbias 48000
Rfixed53_0hi vdd n_fixed53_0 42158.2590814
Rfixed53_0lo n_fixed53_0 0 57841.7409186
Mfp53_0 in6 n_fixed53_0 n_hp53 0 syn W=10u L=1u
Mfn53_0 in6 vweight n_hn53 0 syn W=10u L=1u
Rfixed53_1hi vdd n_fixed53_1 46474.7846308
Rfixed53_1lo n_fixed53_1 0 53525.2153692
Mfp53_1 in4 n_fixed53_1 n_hp53 0 syn W=10u L=1u
Mfn53_1 in4 vweight n_hn53 0 syn W=10u L=1u
Rfixed53_2hi vdd n_fixed53_2 19886.2864125
Rfixed53_2lo n_fixed53_2 0 80113.7135875
Mfp53_2 in14 n_fixed53_2 n_hp53 0 syn W=10u L=1u
Mfn53_2 in14 vweight n_hn53 0 syn W=10u L=1u
Rfixed53_3hi vdd n_fixed53_3 26836.6347608
Rfixed53_3lo n_fixed53_3 0 73163.3652392
Mfp53_3 in11 n_fixed53_3 n_hp53 0 syn W=10u L=1u
Mfn53_3 in11 vweight n_hn53 0 syn W=10u L=1u
Rfixed53_4hi vdd n_fixed53_4 28842.4069201
Rfixed53_4lo n_fixed53_4 0 71157.5930799
Mfp53_4 vbias n_fixed53_4 n_hp53 0 syn W=10u L=1u
Mfn53_4 vbias vweight n_hn53 0 syn W=10u L=1u
Mh53a n_hn53 n_hn53 0 0 nch W=20u L=1u
Mh53b n_z53 n_hn53 0 0 nch W=20u L=1u
Mh53c n_hp53 n_hp53 0 0 nch W=20u L=1u
Mh53d n_mirrorh53 n_hp53 0 0 nch W=20u L=1u
Mh53e n_mirrorh53 n_mirrorh53 vdd vdd pch W=60u L=1u
Mh53f n_z53 n_mirrorh53 vdd vdd pch W=60u L=1u
Rh53sum n_z53 vref 8000
Mactp53 n_dd53 n_z53 n_tail53 0 nch W=12u L=1u
Mactn53 n_dm53 vref n_tail53 0 nch W=12u L=1u
Macttail53 n_tail53 n_tailbias 0 0 nch W=32u L=1u
Mactload53 n_dm53 n_dm53 vdd vdd pch W=40u L=1u
Mactmirror53 n_dd53 n_dd53 vdd vdd pch W=40u L=1u
Mactout53 n_hv53 n_dd53 vdd vdd pch W=40u L=1u
Rhvlo53 n_hv53 vref 9600
Rhvhi53 n_hv53 vbias 48000
Rfixed54_0hi vdd n_fixed54_0 6666.66666667
Rfixed54_0lo n_fixed54_0 0 93333.3333333
Mfp54_0 in14 n_fixed54_0 n_hp54 0 syn W=10u L=1u
Mfn54_0 in14 vweight n_hn54 0 syn W=10u L=1u
Rfixed54_1hi vdd n_fixed54_1 65588.2298902
Rfixed54_1lo n_fixed54_1 0 34411.7701098
Mfp54_1 in9 n_fixed54_1 n_hp54 0 syn W=10u L=1u
Mfn54_1 in9 vweight n_hn54 0 syn W=10u L=1u
Rfixed54_2hi vdd n_fixed54_2 49357.1031096
Rfixed54_2lo n_fixed54_2 0 50642.8968904
Mfp54_2 in1 n_fixed54_2 n_hp54 0 syn W=10u L=1u
Mfn54_2 in1 vweight n_hn54 0 syn W=10u L=1u
Rfixed54_3hi vdd n_fixed54_3 44491.9649209
Rfixed54_3lo n_fixed54_3 0 55508.0350791
Mfp54_3 in13 n_fixed54_3 n_hp54 0 syn W=10u L=1u
Mfn54_3 in13 vweight n_hn54 0 syn W=10u L=1u
Rfixed54_4hi vdd n_fixed54_4 40021.8412121
Rfixed54_4lo n_fixed54_4 0 59978.1587879
Mfp54_4 vbias n_fixed54_4 n_hp54 0 syn W=10u L=1u
Mfn54_4 vbias vweight n_hn54 0 syn W=10u L=1u
Mh54a n_hn54 n_hn54 0 0 nch W=20u L=1u
Mh54b n_z54 n_hn54 0 0 nch W=20u L=1u
Mh54c n_hp54 n_hp54 0 0 nch W=20u L=1u
Mh54d n_mirrorh54 n_hp54 0 0 nch W=20u L=1u
Mh54e n_mirrorh54 n_mirrorh54 vdd vdd pch W=60u L=1u
Mh54f n_z54 n_mirrorh54 vdd vdd pch W=60u L=1u
Rh54sum n_z54 vref 8000
Mactp54 n_dd54 n_z54 n_tail54 0 nch W=12u L=1u
Mactn54 n_dm54 vref n_tail54 0 nch W=12u L=1u
Macttail54 n_tail54 n_tailbias 0 0 nch W=32u L=1u
Mactload54 n_dm54 n_dm54 vdd vdd pch W=40u L=1u
Mactmirror54 n_dd54 n_dd54 vdd vdd pch W=40u L=1u
Mactout54 n_hv54 n_dd54 vdd vdd pch W=40u L=1u
Rhvlo54 n_hv54 vref 9600
Rhvhi54 n_hv54 vbias 48000
Rfixed55_0hi vdd n_fixed55_0 28323.5847397
Rfixed55_0lo n_fixed55_0 0 71676.4152603
Mfp55_0 in1 n_fixed55_0 n_hp55 0 syn W=10u L=1u
Mfn55_0 in1 vweight n_hn55 0 syn W=10u L=1u
Rfixed55_1hi vdd n_fixed55_1 43158.7051984
Rfixed55_1lo n_fixed55_1 0 56841.2948016
Mfp55_1 in7 n_fixed55_1 n_hp55 0 syn W=10u L=1u
Mfn55_1 in7 vweight n_hn55 0 syn W=10u L=1u
Rfixed55_2hi vdd n_fixed55_2 55087.2094849
Rfixed55_2lo n_fixed55_2 0 44912.7905151
Mfp55_2 in10 n_fixed55_2 n_hp55 0 syn W=10u L=1u
Mfn55_2 in10 vweight n_hn55 0 syn W=10u L=1u
Rfixed55_3hi vdd n_fixed55_3 49957.5522309
Rfixed55_3lo n_fixed55_3 0 50042.4477691
Mfp55_3 in6 n_fixed55_3 n_hp55 0 syn W=10u L=1u
Mfn55_3 in6 vweight n_hn55 0 syn W=10u L=1u
Rfixed55_4hi vdd n_fixed55_4 40472.3942672
Rfixed55_4lo n_fixed55_4 0 59527.6057328
Mfp55_4 vbias n_fixed55_4 n_hp55 0 syn W=10u L=1u
Mfn55_4 vbias vweight n_hn55 0 syn W=10u L=1u
Mh55a n_hn55 n_hn55 0 0 nch W=20u L=1u
Mh55b n_z55 n_hn55 0 0 nch W=20u L=1u
Mh55c n_hp55 n_hp55 0 0 nch W=20u L=1u
Mh55d n_mirrorh55 n_hp55 0 0 nch W=20u L=1u
Mh55e n_mirrorh55 n_mirrorh55 vdd vdd pch W=60u L=1u
Mh55f n_z55 n_mirrorh55 vdd vdd pch W=60u L=1u
Rh55sum n_z55 vref 8000
Mactp55 n_dd55 n_z55 n_tail55 0 nch W=12u L=1u
Mactn55 n_dm55 vref n_tail55 0 nch W=12u L=1u
Macttail55 n_tail55 n_tailbias 0 0 nch W=32u L=1u
Mactload55 n_dm55 n_dm55 vdd vdd pch W=40u L=1u
Mactmirror55 n_dd55 n_dd55 vdd vdd pch W=40u L=1u
Mactout55 n_hv55 n_dd55 vdd vdd pch W=40u L=1u
Rhvlo55 n_hv55 vref 9600
Rhvhi55 n_hv55 vbias 48000
Rfixed56_0hi vdd n_fixed56_0 40250.5238385
Rfixed56_0lo n_fixed56_0 0 59749.4761615
Mfp56_0 in1 n_fixed56_0 n_hp56 0 syn W=10u L=1u
Mfn56_0 in1 vweight n_hn56 0 syn W=10u L=1u
Rfixed56_1hi vdd n_fixed56_1 32311.2301033
Rfixed56_1lo n_fixed56_1 0 67688.7698967
Mfp56_1 in8 n_fixed56_1 n_hp56 0 syn W=10u L=1u
Mfn56_1 in8 vweight n_hn56 0 syn W=10u L=1u
Rfixed56_2hi vdd n_fixed56_2 40572.6827765
Rfixed56_2lo n_fixed56_2 0 59427.3172235
Mfp56_2 in15 n_fixed56_2 n_hp56 0 syn W=10u L=1u
Mfn56_2 in15 vweight n_hn56 0 syn W=10u L=1u
Rfixed56_3hi vdd n_fixed56_3 46945.9372313
Rfixed56_3lo n_fixed56_3 0 53054.0627687
Mfp56_3 in12 n_fixed56_3 n_hp56 0 syn W=10u L=1u
Mfn56_3 in12 vweight n_hn56 0 syn W=10u L=1u
Rfixed56_4hi vdd n_fixed56_4 18286.068852
Rfixed56_4lo n_fixed56_4 0 81713.931148
Mfp56_4 vbias n_fixed56_4 n_hp56 0 syn W=10u L=1u
Mfn56_4 vbias vweight n_hn56 0 syn W=10u L=1u
Mh56a n_hn56 n_hn56 0 0 nch W=20u L=1u
Mh56b n_z56 n_hn56 0 0 nch W=20u L=1u
Mh56c n_hp56 n_hp56 0 0 nch W=20u L=1u
Mh56d n_mirrorh56 n_hp56 0 0 nch W=20u L=1u
Mh56e n_mirrorh56 n_mirrorh56 vdd vdd pch W=60u L=1u
Mh56f n_z56 n_mirrorh56 vdd vdd pch W=60u L=1u
Rh56sum n_z56 vref 8000
Mactp56 n_dd56 n_z56 n_tail56 0 nch W=12u L=1u
Mactn56 n_dm56 vref n_tail56 0 nch W=12u L=1u
Macttail56 n_tail56 n_tailbias 0 0 nch W=32u L=1u
Mactload56 n_dm56 n_dm56 vdd vdd pch W=40u L=1u
Mactmirror56 n_dd56 n_dd56 vdd vdd pch W=40u L=1u
Mactout56 n_hv56 n_dd56 vdd vdd pch W=40u L=1u
Rhvlo56 n_hv56 vref 9600
Rhvhi56 n_hv56 vbias 48000
Rfixed57_0hi vdd n_fixed57_0 46928.4074549
Rfixed57_0lo n_fixed57_0 0 53071.5925451
Mfp57_0 in2 n_fixed57_0 n_hp57 0 syn W=10u L=1u
Mfn57_0 in2 vweight n_hn57 0 syn W=10u L=1u
Rfixed57_1hi vdd n_fixed57_1 23905.8253461
Rfixed57_1lo n_fixed57_1 0 76094.1746539
Mfp57_1 in7 n_fixed57_1 n_hp57 0 syn W=10u L=1u
Mfn57_1 in7 vweight n_hn57 0 syn W=10u L=1u
Rfixed57_2hi vdd n_fixed57_2 42943.756536
Rfixed57_2lo n_fixed57_2 0 57056.243464
Mfp57_2 in13 n_fixed57_2 n_hp57 0 syn W=10u L=1u
Mfn57_2 in13 vweight n_hn57 0 syn W=10u L=1u
Rfixed57_3hi vdd n_fixed57_3 34227.4126931
Rfixed57_3lo n_fixed57_3 0 65772.5873069
Mfp57_3 in3 n_fixed57_3 n_hp57 0 syn W=10u L=1u
Mfn57_3 in3 vweight n_hn57 0 syn W=10u L=1u
Rfixed57_4hi vdd n_fixed57_4 48393.75365
Rfixed57_4lo n_fixed57_4 0 51606.24635
Mfp57_4 vbias n_fixed57_4 n_hp57 0 syn W=10u L=1u
Mfn57_4 vbias vweight n_hn57 0 syn W=10u L=1u
Mh57a n_hn57 n_hn57 0 0 nch W=20u L=1u
Mh57b n_z57 n_hn57 0 0 nch W=20u L=1u
Mh57c n_hp57 n_hp57 0 0 nch W=20u L=1u
Mh57d n_mirrorh57 n_hp57 0 0 nch W=20u L=1u
Mh57e n_mirrorh57 n_mirrorh57 vdd vdd pch W=60u L=1u
Mh57f n_z57 n_mirrorh57 vdd vdd pch W=60u L=1u
Rh57sum n_z57 vref 8000
Mactp57 n_dd57 n_z57 n_tail57 0 nch W=12u L=1u
Mactn57 n_dm57 vref n_tail57 0 nch W=12u L=1u
Macttail57 n_tail57 n_tailbias 0 0 nch W=32u L=1u
Mactload57 n_dm57 n_dm57 vdd vdd pch W=40u L=1u
Mactmirror57 n_dd57 n_dd57 vdd vdd pch W=40u L=1u
Mactout57 n_hv57 n_dd57 vdd vdd pch W=40u L=1u
Rhvlo57 n_hv57 vref 9600
Rhvhi57 n_hv57 vbias 48000
Rfixed58_0hi vdd n_fixed58_0 14420.1088685
Rfixed58_0lo n_fixed58_0 0 85579.8911315
Mfp58_0 in5 n_fixed58_0 n_hp58 0 syn W=10u L=1u
Mfn58_0 in5 vweight n_hn58 0 syn W=10u L=1u
Rfixed58_1hi vdd n_fixed58_1 13988.9478148
Rfixed58_1lo n_fixed58_1 0 86011.0521852
Mfp58_1 in14 n_fixed58_1 n_hp58 0 syn W=10u L=1u
Mfn58_1 in14 vweight n_hn58 0 syn W=10u L=1u
Rfixed58_2hi vdd n_fixed58_2 31874.6623821
Rfixed58_2lo n_fixed58_2 0 68125.3376179
Mfp58_2 in15 n_fixed58_2 n_hp58 0 syn W=10u L=1u
Mfn58_2 in15 vweight n_hn58 0 syn W=10u L=1u
Rfixed58_3hi vdd n_fixed58_3 42117.6021606
Rfixed58_3lo n_fixed58_3 0 57882.3978394
Mfp58_3 in7 n_fixed58_3 n_hp58 0 syn W=10u L=1u
Mfn58_3 in7 vweight n_hn58 0 syn W=10u L=1u
Rfixed58_4hi vdd n_fixed58_4 46884.3739762
Rfixed58_4lo n_fixed58_4 0 53115.6260238
Mfp58_4 vbias n_fixed58_4 n_hp58 0 syn W=10u L=1u
Mfn58_4 vbias vweight n_hn58 0 syn W=10u L=1u
Mh58a n_hn58 n_hn58 0 0 nch W=20u L=1u
Mh58b n_z58 n_hn58 0 0 nch W=20u L=1u
Mh58c n_hp58 n_hp58 0 0 nch W=20u L=1u
Mh58d n_mirrorh58 n_hp58 0 0 nch W=20u L=1u
Mh58e n_mirrorh58 n_mirrorh58 vdd vdd pch W=60u L=1u
Mh58f n_z58 n_mirrorh58 vdd vdd pch W=60u L=1u
Rh58sum n_z58 vref 8000
Mactp58 n_dd58 n_z58 n_tail58 0 nch W=12u L=1u
Mactn58 n_dm58 vref n_tail58 0 nch W=12u L=1u
Macttail58 n_tail58 n_tailbias 0 0 nch W=32u L=1u
Mactload58 n_dm58 n_dm58 vdd vdd pch W=40u L=1u
Mactmirror58 n_dd58 n_dd58 vdd vdd pch W=40u L=1u
Mactout58 n_hv58 n_dd58 vdd vdd pch W=40u L=1u
Rhvlo58 n_hv58 vref 9600
Rhvhi58 n_hv58 vbias 48000
Rfixed59_0hi vdd n_fixed59_0 50093.6201762
Rfixed59_0lo n_fixed59_0 0 49906.3798238
Mfp59_0 in3 n_fixed59_0 n_hp59 0 syn W=10u L=1u
Mfn59_0 in3 vweight n_hn59 0 syn W=10u L=1u
Rfixed59_1hi vdd n_fixed59_1 39689.1852144
Rfixed59_1lo n_fixed59_1 0 60310.8147856
Mfp59_1 in10 n_fixed59_1 n_hp59 0 syn W=10u L=1u
Mfn59_1 in10 vweight n_hn59 0 syn W=10u L=1u
Rfixed59_2hi vdd n_fixed59_2 12266.8555047
Rfixed59_2lo n_fixed59_2 0 87733.1444953
Mfp59_2 in4 n_fixed59_2 n_hp59 0 syn W=10u L=1u
Mfn59_2 in4 vweight n_hn59 0 syn W=10u L=1u
Rfixed59_3hi vdd n_fixed59_3 29188.7821852
Rfixed59_3lo n_fixed59_3 0 70811.2178148
Mfp59_3 in13 n_fixed59_3 n_hp59 0 syn W=10u L=1u
Mfn59_3 in13 vweight n_hn59 0 syn W=10u L=1u
Rfixed59_4hi vdd n_fixed59_4 39863.8092412
Rfixed59_4lo n_fixed59_4 0 60136.1907588
Mfp59_4 vbias n_fixed59_4 n_hp59 0 syn W=10u L=1u
Mfn59_4 vbias vweight n_hn59 0 syn W=10u L=1u
Mh59a n_hn59 n_hn59 0 0 nch W=20u L=1u
Mh59b n_z59 n_hn59 0 0 nch W=20u L=1u
Mh59c n_hp59 n_hp59 0 0 nch W=20u L=1u
Mh59d n_mirrorh59 n_hp59 0 0 nch W=20u L=1u
Mh59e n_mirrorh59 n_mirrorh59 vdd vdd pch W=60u L=1u
Mh59f n_z59 n_mirrorh59 vdd vdd pch W=60u L=1u
Rh59sum n_z59 vref 8000
Mactp59 n_dd59 n_z59 n_tail59 0 nch W=12u L=1u
Mactn59 n_dm59 vref n_tail59 0 nch W=12u L=1u
Macttail59 n_tail59 n_tailbias 0 0 nch W=32u L=1u
Mactload59 n_dm59 n_dm59 vdd vdd pch W=40u L=1u
Mactmirror59 n_dd59 n_dd59 vdd vdd pch W=40u L=1u
Mactout59 n_hv59 n_dd59 vdd vdd pch W=40u L=1u
Rhvlo59 n_hv59 vref 9600
Rhvhi59 n_hv59 vbias 48000
Rfixed60_0hi vdd n_fixed60_0 55819.4879169
Rfixed60_0lo n_fixed60_0 0 44180.5120831
Mfp60_0 in14 n_fixed60_0 n_hp60 0 syn W=10u L=1u
Mfn60_0 in14 vweight n_hn60 0 syn W=10u L=1u
Rfixed60_1hi vdd n_fixed60_1 56329.9031493
Rfixed60_1lo n_fixed60_1 0 43670.0968507
Mfp60_1 in9 n_fixed60_1 n_hp60 0 syn W=10u L=1u
Mfn60_1 in9 vweight n_hn60 0 syn W=10u L=1u
Rfixed60_2hi vdd n_fixed60_2 34207.5629397
Rfixed60_2lo n_fixed60_2 0 65792.4370603
Mfp60_2 in0 n_fixed60_2 n_hp60 0 syn W=10u L=1u
Mfn60_2 in0 vweight n_hn60 0 syn W=10u L=1u
Rfixed60_3hi vdd n_fixed60_3 49747.9602491
Rfixed60_3lo n_fixed60_3 0 50252.0397509
Mfp60_3 in13 n_fixed60_3 n_hp60 0 syn W=10u L=1u
Mfn60_3 in13 vweight n_hn60 0 syn W=10u L=1u
Rfixed60_4hi vdd n_fixed60_4 42258.9197031
Rfixed60_4lo n_fixed60_4 0 57741.0802969
Mfp60_4 vbias n_fixed60_4 n_hp60 0 syn W=10u L=1u
Mfn60_4 vbias vweight n_hn60 0 syn W=10u L=1u
Mh60a n_hn60 n_hn60 0 0 nch W=20u L=1u
Mh60b n_z60 n_hn60 0 0 nch W=20u L=1u
Mh60c n_hp60 n_hp60 0 0 nch W=20u L=1u
Mh60d n_mirrorh60 n_hp60 0 0 nch W=20u L=1u
Mh60e n_mirrorh60 n_mirrorh60 vdd vdd pch W=60u L=1u
Mh60f n_z60 n_mirrorh60 vdd vdd pch W=60u L=1u
Rh60sum n_z60 vref 8000
Mactp60 n_dd60 n_z60 n_tail60 0 nch W=12u L=1u
Mactn60 n_dm60 vref n_tail60 0 nch W=12u L=1u
Macttail60 n_tail60 n_tailbias 0 0 nch W=32u L=1u
Mactload60 n_dm60 n_dm60 vdd vdd pch W=40u L=1u
Mactmirror60 n_dd60 n_dd60 vdd vdd pch W=40u L=1u
Mactout60 n_hv60 n_dd60 vdd vdd pch W=40u L=1u
Rhvlo60 n_hv60 vref 9600
Rhvhi60 n_hv60 vbias 48000
Rfixed61_0hi vdd n_fixed61_0 19657.2711108
Rfixed61_0lo n_fixed61_0 0 80342.7288892
Mfp61_0 in8 n_fixed61_0 n_hp61 0 syn W=10u L=1u
Mfn61_0 in8 vweight n_hn61 0 syn W=10u L=1u
Rfixed61_1hi vdd n_fixed61_1 40140.1424223
Rfixed61_1lo n_fixed61_1 0 59859.8575777
Mfp61_1 in4 n_fixed61_1 n_hp61 0 syn W=10u L=1u
Mfn61_1 in4 vweight n_hn61 0 syn W=10u L=1u
Rfixed61_2hi vdd n_fixed61_2 14718.446784
Rfixed61_2lo n_fixed61_2 0 85281.553216
Mfp61_2 in9 n_fixed61_2 n_hp61 0 syn W=10u L=1u
Mfn61_2 in9 vweight n_hn61 0 syn W=10u L=1u
Rfixed61_3hi vdd n_fixed61_3 32261.1419341
Rfixed61_3lo n_fixed61_3 0 67738.8580659
Mfp61_3 in12 n_fixed61_3 n_hp61 0 syn W=10u L=1u
Mfn61_3 in12 vweight n_hn61 0 syn W=10u L=1u
Rfixed61_4hi vdd n_fixed61_4 54652.8028652
Rfixed61_4lo n_fixed61_4 0 45347.1971348
Mfp61_4 vbias n_fixed61_4 n_hp61 0 syn W=10u L=1u
Mfn61_4 vbias vweight n_hn61 0 syn W=10u L=1u
Mh61a n_hn61 n_hn61 0 0 nch W=20u L=1u
Mh61b n_z61 n_hn61 0 0 nch W=20u L=1u
Mh61c n_hp61 n_hp61 0 0 nch W=20u L=1u
Mh61d n_mirrorh61 n_hp61 0 0 nch W=20u L=1u
Mh61e n_mirrorh61 n_mirrorh61 vdd vdd pch W=60u L=1u
Mh61f n_z61 n_mirrorh61 vdd vdd pch W=60u L=1u
Rh61sum n_z61 vref 8000
Mactp61 n_dd61 n_z61 n_tail61 0 nch W=12u L=1u
Mactn61 n_dm61 vref n_tail61 0 nch W=12u L=1u
Macttail61 n_tail61 n_tailbias 0 0 nch W=32u L=1u
Mactload61 n_dm61 n_dm61 vdd vdd pch W=40u L=1u
Mactmirror61 n_dd61 n_dd61 vdd vdd pch W=40u L=1u
Mactout61 n_hv61 n_dd61 vdd vdd pch W=40u L=1u
Rhvlo61 n_hv61 vref 9600
Rhvhi61 n_hv61 vbias 48000
Rfixed62_0hi vdd n_fixed62_0 47442.9030755
Rfixed62_0lo n_fixed62_0 0 52557.0969245
Mfp62_0 in5 n_fixed62_0 n_hp62 0 syn W=10u L=1u
Mfn62_0 in5 vweight n_hn62 0 syn W=10u L=1u
Rfixed62_1hi vdd n_fixed62_1 35906.1915026
Rfixed62_1lo n_fixed62_1 0 64093.8084974
Mfp62_1 in8 n_fixed62_1 n_hp62 0 syn W=10u L=1u
Mfn62_1 in8 vweight n_hn62 0 syn W=10u L=1u
Rfixed62_2hi vdd n_fixed62_2 31262.9675212
Rfixed62_2lo n_fixed62_2 0 68737.0324788
Mfp62_2 in15 n_fixed62_2 n_hp62 0 syn W=10u L=1u
Mfn62_2 in15 vweight n_hn62 0 syn W=10u L=1u
Rfixed62_3hi vdd n_fixed62_3 6884.19943445
Rfixed62_3lo n_fixed62_3 0 93115.8005655
Mfp62_3 in7 n_fixed62_3 n_hp62 0 syn W=10u L=1u
Mfn62_3 in7 vweight n_hn62 0 syn W=10u L=1u
Rfixed62_4hi vdd n_fixed62_4 35742.7287064
Rfixed62_4lo n_fixed62_4 0 64257.2712936
Mfp62_4 vbias n_fixed62_4 n_hp62 0 syn W=10u L=1u
Mfn62_4 vbias vweight n_hn62 0 syn W=10u L=1u
Mh62a n_hn62 n_hn62 0 0 nch W=20u L=1u
Mh62b n_z62 n_hn62 0 0 nch W=20u L=1u
Mh62c n_hp62 n_hp62 0 0 nch W=20u L=1u
Mh62d n_mirrorh62 n_hp62 0 0 nch W=20u L=1u
Mh62e n_mirrorh62 n_mirrorh62 vdd vdd pch W=60u L=1u
Mh62f n_z62 n_mirrorh62 vdd vdd pch W=60u L=1u
Rh62sum n_z62 vref 8000
Mactp62 n_dd62 n_z62 n_tail62 0 nch W=12u L=1u
Mactn62 n_dm62 vref n_tail62 0 nch W=12u L=1u
Macttail62 n_tail62 n_tailbias 0 0 nch W=32u L=1u
Mactload62 n_dm62 n_dm62 vdd vdd pch W=40u L=1u
Mactmirror62 n_dd62 n_dd62 vdd vdd pch W=40u L=1u
Mactout62 n_hv62 n_dd62 vdd vdd pch W=40u L=1u
Rhvlo62 n_hv62 vref 9600
Rhvhi62 n_hv62 vbias 48000
Rfixed63_0hi vdd n_fixed63_0 10814.8053294
Rfixed63_0lo n_fixed63_0 0 89185.1946706
Mfp63_0 in0 n_fixed63_0 n_hp63 0 syn W=10u L=1u
Mfn63_0 in0 vweight n_hn63 0 syn W=10u L=1u
Rfixed63_1hi vdd n_fixed63_1 26072.7169033
Rfixed63_1lo n_fixed63_1 0 73927.2830967
Mfp63_1 in1 n_fixed63_1 n_hp63 0 syn W=10u L=1u
Mfn63_1 in1 vweight n_hn63 0 syn W=10u L=1u
Rfixed63_2hi vdd n_fixed63_2 38840.8333172
Rfixed63_2lo n_fixed63_2 0 61159.1666828
Mfp63_2 in9 n_fixed63_2 n_hp63 0 syn W=10u L=1u
Mfn63_2 in9 vweight n_hn63 0 syn W=10u L=1u
Rfixed63_3hi vdd n_fixed63_3 52308.9323569
Rfixed63_3lo n_fixed63_3 0 47691.0676431
Mfp63_3 in11 n_fixed63_3 n_hp63 0 syn W=10u L=1u
Mfn63_3 in11 vweight n_hn63 0 syn W=10u L=1u
Rfixed63_4hi vdd n_fixed63_4 51877.7428079
Rfixed63_4lo n_fixed63_4 0 48122.2571921
Mfp63_4 vbias n_fixed63_4 n_hp63 0 syn W=10u L=1u
Mfn63_4 vbias vweight n_hn63 0 syn W=10u L=1u
Mh63a n_hn63 n_hn63 0 0 nch W=20u L=1u
Mh63b n_z63 n_hn63 0 0 nch W=20u L=1u
Mh63c n_hp63 n_hp63 0 0 nch W=20u L=1u
Mh63d n_mirrorh63 n_hp63 0 0 nch W=20u L=1u
Mh63e n_mirrorh63 n_mirrorh63 vdd vdd pch W=60u L=1u
Mh63f n_z63 n_mirrorh63 vdd vdd pch W=60u L=1u
Rh63sum n_z63 vref 8000
Mactp63 n_dd63 n_z63 n_tail63 0 nch W=12u L=1u
Mactn63 n_dm63 vref n_tail63 0 nch W=12u L=1u
Macttail63 n_tail63 n_tailbias 0 0 nch W=32u L=1u
Mactload63 n_dm63 n_dm63 vdd vdd pch W=40u L=1u
Mactmirror63 n_dd63 n_dd63 vdd vdd pch W=40u L=1u
Mactout63 n_hv63 n_dd63 vdd vdd pch W=40u L=1u
Rhvlo63 n_hv63 vref 9600
Rhvhi63 n_hv63 vbias 48000
Rfixed64_0hi vdd n_fixed64_0 52922.0876716
Rfixed64_0lo n_fixed64_0 0 47077.9123284
Mfp64_0 in4 n_fixed64_0 n_hp64 0 syn W=10u L=1u
Mfn64_0 in4 vweight n_hn64 0 syn W=10u L=1u
Rfixed64_1hi vdd n_fixed64_1 46338.3491002
Rfixed64_1lo n_fixed64_1 0 53661.6508998
Mfp64_1 in1 n_fixed64_1 n_hp64 0 syn W=10u L=1u
Mfn64_1 in1 vweight n_hn64 0 syn W=10u L=1u
Rfixed64_2hi vdd n_fixed64_2 55655.4664206
Rfixed64_2lo n_fixed64_2 0 44344.5335794
Mfp64_2 in8 n_fixed64_2 n_hp64 0 syn W=10u L=1u
Mfn64_2 in8 vweight n_hn64 0 syn W=10u L=1u
Rfixed64_3hi vdd n_fixed64_3 40298.3304342
Rfixed64_3lo n_fixed64_3 0 59701.6695658
Mfp64_3 in5 n_fixed64_3 n_hp64 0 syn W=10u L=1u
Mfn64_3 in5 vweight n_hn64 0 syn W=10u L=1u
Rfixed64_4hi vdd n_fixed64_4 40337.1576184
Rfixed64_4lo n_fixed64_4 0 59662.8423816
Mfp64_4 vbias n_fixed64_4 n_hp64 0 syn W=10u L=1u
Mfn64_4 vbias vweight n_hn64 0 syn W=10u L=1u
Mh64a n_hn64 n_hn64 0 0 nch W=20u L=1u
Mh64b n_z64 n_hn64 0 0 nch W=20u L=1u
Mh64c n_hp64 n_hp64 0 0 nch W=20u L=1u
Mh64d n_mirrorh64 n_hp64 0 0 nch W=20u L=1u
Mh64e n_mirrorh64 n_mirrorh64 vdd vdd pch W=60u L=1u
Mh64f n_z64 n_mirrorh64 vdd vdd pch W=60u L=1u
Rh64sum n_z64 vref 8000
Mactp64 n_dd64 n_z64 n_tail64 0 nch W=12u L=1u
Mactn64 n_dm64 vref n_tail64 0 nch W=12u L=1u
Macttail64 n_tail64 n_tailbias 0 0 nch W=32u L=1u
Mactload64 n_dm64 n_dm64 vdd vdd pch W=40u L=1u
Mactmirror64 n_dd64 n_dd64 vdd vdd pch W=40u L=1u
Mactout64 n_hv64 n_dd64 vdd vdd pch W=40u L=1u
Rhvlo64 n_hv64 vref 9600
Rhvhi64 n_hv64 vbias 48000
Rfixed65_0hi vdd n_fixed65_0 40121.5937108
Rfixed65_0lo n_fixed65_0 0 59878.4062892
Mfp65_0 in14 n_fixed65_0 n_hp65 0 syn W=10u L=1u
Mfn65_0 in14 vweight n_hn65 0 syn W=10u L=1u
Rfixed65_1hi vdd n_fixed65_1 45680.8785157
Rfixed65_1lo n_fixed65_1 0 54319.1214843
Mfp65_1 in11 n_fixed65_1 n_hp65 0 syn W=10u L=1u
Mfn65_1 in11 vweight n_hn65 0 syn W=10u L=1u
Rfixed65_2hi vdd n_fixed65_2 24158.0652676
Rfixed65_2lo n_fixed65_2 0 75841.9347324
Mfp65_2 in7 n_fixed65_2 n_hp65 0 syn W=10u L=1u
Mfn65_2 in7 vweight n_hn65 0 syn W=10u L=1u
Rfixed65_3hi vdd n_fixed65_3 34782.6406496
Rfixed65_3lo n_fixed65_3 0 65217.3593504
Mfp65_3 in5 n_fixed65_3 n_hp65 0 syn W=10u L=1u
Mfn65_3 in5 vweight n_hn65 0 syn W=10u L=1u
Rfixed65_4hi vdd n_fixed65_4 52366.8425283
Rfixed65_4lo n_fixed65_4 0 47633.1574717
Mfp65_4 vbias n_fixed65_4 n_hp65 0 syn W=10u L=1u
Mfn65_4 vbias vweight n_hn65 0 syn W=10u L=1u
Mh65a n_hn65 n_hn65 0 0 nch W=20u L=1u
Mh65b n_z65 n_hn65 0 0 nch W=20u L=1u
Mh65c n_hp65 n_hp65 0 0 nch W=20u L=1u
Mh65d n_mirrorh65 n_hp65 0 0 nch W=20u L=1u
Mh65e n_mirrorh65 n_mirrorh65 vdd vdd pch W=60u L=1u
Mh65f n_z65 n_mirrorh65 vdd vdd pch W=60u L=1u
Rh65sum n_z65 vref 8000
Mactp65 n_dd65 n_z65 n_tail65 0 nch W=12u L=1u
Mactn65 n_dm65 vref n_tail65 0 nch W=12u L=1u
Macttail65 n_tail65 n_tailbias 0 0 nch W=32u L=1u
Mactload65 n_dm65 n_dm65 vdd vdd pch W=40u L=1u
Mactmirror65 n_dd65 n_dd65 vdd vdd pch W=40u L=1u
Mactout65 n_hv65 n_dd65 vdd vdd pch W=40u L=1u
Rhvlo65 n_hv65 vref 9600
Rhvhi65 n_hv65 vbias 48000
Rfixed66_0hi vdd n_fixed66_0 55717.7135712
Rfixed66_0lo n_fixed66_0 0 44282.2864288
Mfp66_0 in15 n_fixed66_0 n_hp66 0 syn W=10u L=1u
Mfn66_0 in15 vweight n_hn66 0 syn W=10u L=1u
Rfixed66_1hi vdd n_fixed66_1 25677.3245151
Rfixed66_1lo n_fixed66_1 0 74322.6754849
Mfp66_1 in1 n_fixed66_1 n_hp66 0 syn W=10u L=1u
Mfn66_1 in1 vweight n_hn66 0 syn W=10u L=1u
Rfixed66_2hi vdd n_fixed66_2 16332.6898909
Rfixed66_2lo n_fixed66_2 0 83667.3101091
Mfp66_2 in10 n_fixed66_2 n_hp66 0 syn W=10u L=1u
Mfn66_2 in10 vweight n_hn66 0 syn W=10u L=1u
Rfixed66_3hi vdd n_fixed66_3 40768.955792
Rfixed66_3lo n_fixed66_3 0 59231.044208
Mfp66_3 in6 n_fixed66_3 n_hp66 0 syn W=10u L=1u
Mfn66_3 in6 vweight n_hn66 0 syn W=10u L=1u
Rfixed66_4hi vdd n_fixed66_4 42364.7741114
Rfixed66_4lo n_fixed66_4 0 57635.2258886
Mfp66_4 vbias n_fixed66_4 n_hp66 0 syn W=10u L=1u
Mfn66_4 vbias vweight n_hn66 0 syn W=10u L=1u
Mh66a n_hn66 n_hn66 0 0 nch W=20u L=1u
Mh66b n_z66 n_hn66 0 0 nch W=20u L=1u
Mh66c n_hp66 n_hp66 0 0 nch W=20u L=1u
Mh66d n_mirrorh66 n_hp66 0 0 nch W=20u L=1u
Mh66e n_mirrorh66 n_mirrorh66 vdd vdd pch W=60u L=1u
Mh66f n_z66 n_mirrorh66 vdd vdd pch W=60u L=1u
Rh66sum n_z66 vref 8000
Mactp66 n_dd66 n_z66 n_tail66 0 nch W=12u L=1u
Mactn66 n_dm66 vref n_tail66 0 nch W=12u L=1u
Macttail66 n_tail66 n_tailbias 0 0 nch W=32u L=1u
Mactload66 n_dm66 n_dm66 vdd vdd pch W=40u L=1u
Mactmirror66 n_dd66 n_dd66 vdd vdd pch W=40u L=1u
Mactout66 n_hv66 n_dd66 vdd vdd pch W=40u L=1u
Rhvlo66 n_hv66 vref 9600
Rhvhi66 n_hv66 vbias 48000
Rfixed67_0hi vdd n_fixed67_0 66887.6849289
Rfixed67_0lo n_fixed67_0 0 33112.3150711
Mfp67_0 in6 n_fixed67_0 n_hp67 0 syn W=10u L=1u
Mfn67_0 in6 vweight n_hn67 0 syn W=10u L=1u
Rfixed67_1hi vdd n_fixed67_1 31336.7812116
Rfixed67_1lo n_fixed67_1 0 68663.2187884
Mfp67_1 in14 n_fixed67_1 n_hp67 0 syn W=10u L=1u
Mfn67_1 in14 vweight n_hn67 0 syn W=10u L=1u
Rfixed67_2hi vdd n_fixed67_2 54734.4677449
Rfixed67_2lo n_fixed67_2 0 45265.5322551
Mfp67_2 in7 n_fixed67_2 n_hp67 0 syn W=10u L=1u
Mfn67_2 in7 vweight n_hn67 0 syn W=10u L=1u
Rfixed67_3hi vdd n_fixed67_3 41665.6647176
Rfixed67_3lo n_fixed67_3 0 58334.3352824
Mfp67_3 in9 n_fixed67_3 n_hp67 0 syn W=10u L=1u
Mfn67_3 in9 vweight n_hn67 0 syn W=10u L=1u
Rfixed67_4hi vdd n_fixed67_4 64676.7855877
Rfixed67_4lo n_fixed67_4 0 35323.2144123
Mfp67_4 vbias n_fixed67_4 n_hp67 0 syn W=10u L=1u
Mfn67_4 vbias vweight n_hn67 0 syn W=10u L=1u
Mh67a n_hn67 n_hn67 0 0 nch W=20u L=1u
Mh67b n_z67 n_hn67 0 0 nch W=20u L=1u
Mh67c n_hp67 n_hp67 0 0 nch W=20u L=1u
Mh67d n_mirrorh67 n_hp67 0 0 nch W=20u L=1u
Mh67e n_mirrorh67 n_mirrorh67 vdd vdd pch W=60u L=1u
Mh67f n_z67 n_mirrorh67 vdd vdd pch W=60u L=1u
Rh67sum n_z67 vref 8000
Mactp67 n_dd67 n_z67 n_tail67 0 nch W=12u L=1u
Mactn67 n_dm67 vref n_tail67 0 nch W=12u L=1u
Macttail67 n_tail67 n_tailbias 0 0 nch W=32u L=1u
Mactload67 n_dm67 n_dm67 vdd vdd pch W=40u L=1u
Mactmirror67 n_dd67 n_dd67 vdd vdd pch W=40u L=1u
Mactout67 n_hv67 n_dd67 vdd vdd pch W=40u L=1u
Rhvlo67 n_hv67 vref 9600
Rhvhi67 n_hv67 vbias 48000
Rfixed68_0hi vdd n_fixed68_0 54946.8982017
Rfixed68_0lo n_fixed68_0 0 45053.1017983
Mfp68_0 in9 n_fixed68_0 n_hp68 0 syn W=10u L=1u
Mfn68_0 in9 vweight n_hn68 0 syn W=10u L=1u
Rfixed68_1hi vdd n_fixed68_1 54042.0302491
Rfixed68_1lo n_fixed68_1 0 45957.9697509
Mfp68_1 in11 n_fixed68_1 n_hp68 0 syn W=10u L=1u
Mfn68_1 in11 vweight n_hn68 0 syn W=10u L=1u
Rfixed68_2hi vdd n_fixed68_2 40888.1491174
Rfixed68_2lo n_fixed68_2 0 59111.8508826
Mfp68_2 in2 n_fixed68_2 n_hp68 0 syn W=10u L=1u
Mfn68_2 in2 vweight n_hn68 0 syn W=10u L=1u
Rfixed68_3hi vdd n_fixed68_3 38918.439076
Rfixed68_3lo n_fixed68_3 0 61081.560924
Mfp68_3 in7 n_fixed68_3 n_hp68 0 syn W=10u L=1u
Mfn68_3 in7 vweight n_hn68 0 syn W=10u L=1u
Rfixed68_4hi vdd n_fixed68_4 46734.7303763
Rfixed68_4lo n_fixed68_4 0 53265.2696237
Mfp68_4 vbias n_fixed68_4 n_hp68 0 syn W=10u L=1u
Mfn68_4 vbias vweight n_hn68 0 syn W=10u L=1u
Mh68a n_hn68 n_hn68 0 0 nch W=20u L=1u
Mh68b n_z68 n_hn68 0 0 nch W=20u L=1u
Mh68c n_hp68 n_hp68 0 0 nch W=20u L=1u
Mh68d n_mirrorh68 n_hp68 0 0 nch W=20u L=1u
Mh68e n_mirrorh68 n_mirrorh68 vdd vdd pch W=60u L=1u
Mh68f n_z68 n_mirrorh68 vdd vdd pch W=60u L=1u
Rh68sum n_z68 vref 8000
Mactp68 n_dd68 n_z68 n_tail68 0 nch W=12u L=1u
Mactn68 n_dm68 vref n_tail68 0 nch W=12u L=1u
Macttail68 n_tail68 n_tailbias 0 0 nch W=32u L=1u
Mactload68 n_dm68 n_dm68 vdd vdd pch W=40u L=1u
Mactmirror68 n_dd68 n_dd68 vdd vdd pch W=40u L=1u
Mactout68 n_hv68 n_dd68 vdd vdd pch W=40u L=1u
Rhvlo68 n_hv68 vref 9600
Rhvhi68 n_hv68 vbias 48000
Rfixed69_0hi vdd n_fixed69_0 28737.2039031
Rfixed69_0lo n_fixed69_0 0 71262.7960969
Mfp69_0 in12 n_fixed69_0 n_hp69 0 syn W=10u L=1u
Mfn69_0 in12 vweight n_hn69 0 syn W=10u L=1u
Rfixed69_1hi vdd n_fixed69_1 63390.428377
Rfixed69_1lo n_fixed69_1 0 36609.571623
Mfp69_1 in5 n_fixed69_1 n_hp69 0 syn W=10u L=1u
Mfn69_1 in5 vweight n_hn69 0 syn W=10u L=1u
Rfixed69_2hi vdd n_fixed69_2 53719.839699
Rfixed69_2lo n_fixed69_2 0 46280.160301
Mfp69_2 in13 n_fixed69_2 n_hp69 0 syn W=10u L=1u
Mfn69_2 in13 vweight n_hn69 0 syn W=10u L=1u
Rfixed69_3hi vdd n_fixed69_3 17803.8146606
Rfixed69_3lo n_fixed69_3 0 82196.1853394
Mfp69_3 in9 n_fixed69_3 n_hp69 0 syn W=10u L=1u
Mfn69_3 in9 vweight n_hn69 0 syn W=10u L=1u
Rfixed69_4hi vdd n_fixed69_4 48288.1529642
Rfixed69_4lo n_fixed69_4 0 51711.8470358
Mfp69_4 vbias n_fixed69_4 n_hp69 0 syn W=10u L=1u
Mfn69_4 vbias vweight n_hn69 0 syn W=10u L=1u
Mh69a n_hn69 n_hn69 0 0 nch W=20u L=1u
Mh69b n_z69 n_hn69 0 0 nch W=20u L=1u
Mh69c n_hp69 n_hp69 0 0 nch W=20u L=1u
Mh69d n_mirrorh69 n_hp69 0 0 nch W=20u L=1u
Mh69e n_mirrorh69 n_mirrorh69 vdd vdd pch W=60u L=1u
Mh69f n_z69 n_mirrorh69 vdd vdd pch W=60u L=1u
Rh69sum n_z69 vref 8000
Mactp69 n_dd69 n_z69 n_tail69 0 nch W=12u L=1u
Mactn69 n_dm69 vref n_tail69 0 nch W=12u L=1u
Macttail69 n_tail69 n_tailbias 0 0 nch W=32u L=1u
Mactload69 n_dm69 n_dm69 vdd vdd pch W=40u L=1u
Mactmirror69 n_dd69 n_dd69 vdd vdd pch W=40u L=1u
Mactout69 n_hv69 n_dd69 vdd vdd pch W=40u L=1u
Rhvlo69 n_hv69 vref 9600
Rhvhi69 n_hv69 vbias 48000
Rfixed70_0hi vdd n_fixed70_0 26476.8647778
Rfixed70_0lo n_fixed70_0 0 73523.1352222
Mfp70_0 in15 n_fixed70_0 n_hp70 0 syn W=10u L=1u
Mfn70_0 in15 vweight n_hn70 0 syn W=10u L=1u
Rfixed70_1hi vdd n_fixed70_1 42844.4533387
Rfixed70_1lo n_fixed70_1 0 57155.5466613
Mfp70_1 in11 n_fixed70_1 n_hp70 0 syn W=10u L=1u
Mfn70_1 in11 vweight n_hn70 0 syn W=10u L=1u
Rfixed70_2hi vdd n_fixed70_2 13585.4051753
Rfixed70_2lo n_fixed70_2 0 86414.5948247
Mfp70_2 in3 n_fixed70_2 n_hp70 0 syn W=10u L=1u
Mfn70_2 in3 vweight n_hn70 0 syn W=10u L=1u
Rfixed70_3hi vdd n_fixed70_3 36532.0786227
Rfixed70_3lo n_fixed70_3 0 63467.9213773
Mfp70_3 in10 n_fixed70_3 n_hp70 0 syn W=10u L=1u
Mfn70_3 in10 vweight n_hn70 0 syn W=10u L=1u
Rfixed70_4hi vdd n_fixed70_4 31944.6798522
Rfixed70_4lo n_fixed70_4 0 68055.3201478
Mfp70_4 vbias n_fixed70_4 n_hp70 0 syn W=10u L=1u
Mfn70_4 vbias vweight n_hn70 0 syn W=10u L=1u
Mh70a n_hn70 n_hn70 0 0 nch W=20u L=1u
Mh70b n_z70 n_hn70 0 0 nch W=20u L=1u
Mh70c n_hp70 n_hp70 0 0 nch W=20u L=1u
Mh70d n_mirrorh70 n_hp70 0 0 nch W=20u L=1u
Mh70e n_mirrorh70 n_mirrorh70 vdd vdd pch W=60u L=1u
Mh70f n_z70 n_mirrorh70 vdd vdd pch W=60u L=1u
Rh70sum n_z70 vref 8000
Mactp70 n_dd70 n_z70 n_tail70 0 nch W=12u L=1u
Mactn70 n_dm70 vref n_tail70 0 nch W=12u L=1u
Macttail70 n_tail70 n_tailbias 0 0 nch W=32u L=1u
Mactload70 n_dm70 n_dm70 vdd vdd pch W=40u L=1u
Mactmirror70 n_dd70 n_dd70 vdd vdd pch W=40u L=1u
Mactout70 n_hv70 n_dd70 vdd vdd pch W=40u L=1u
Rhvlo70 n_hv70 vref 9600
Rhvhi70 n_hv70 vbias 48000
Rfixed71_0hi vdd n_fixed71_0 15942.752792
Rfixed71_0lo n_fixed71_0 0 84057.247208
Mfp71_0 in12 n_fixed71_0 n_hp71 0 syn W=10u L=1u
Mfn71_0 in12 vweight n_hn71 0 syn W=10u L=1u
Rfixed71_1hi vdd n_fixed71_1 36638.4721962
Rfixed71_1lo n_fixed71_1 0 63361.5278038
Mfp71_1 in15 n_fixed71_1 n_hp71 0 syn W=10u L=1u
Mfn71_1 in15 vweight n_hn71 0 syn W=10u L=1u
Rfixed71_2hi vdd n_fixed71_2 70448.7060359
Rfixed71_2lo n_fixed71_2 0 29551.2939641
Mfp71_2 in4 n_fixed71_2 n_hp71 0 syn W=10u L=1u
Mfn71_2 in4 vweight n_hn71 0 syn W=10u L=1u
Rfixed71_3hi vdd n_fixed71_3 52184.1973506
Rfixed71_3lo n_fixed71_3 0 47815.8026494
Mfp71_3 in2 n_fixed71_3 n_hp71 0 syn W=10u L=1u
Mfn71_3 in2 vweight n_hn71 0 syn W=10u L=1u
Rfixed71_4hi vdd n_fixed71_4 44753.9290586
Rfixed71_4lo n_fixed71_4 0 55246.0709414
Mfp71_4 vbias n_fixed71_4 n_hp71 0 syn W=10u L=1u
Mfn71_4 vbias vweight n_hn71 0 syn W=10u L=1u
Mh71a n_hn71 n_hn71 0 0 nch W=20u L=1u
Mh71b n_z71 n_hn71 0 0 nch W=20u L=1u
Mh71c n_hp71 n_hp71 0 0 nch W=20u L=1u
Mh71d n_mirrorh71 n_hp71 0 0 nch W=20u L=1u
Mh71e n_mirrorh71 n_mirrorh71 vdd vdd pch W=60u L=1u
Mh71f n_z71 n_mirrorh71 vdd vdd pch W=60u L=1u
Rh71sum n_z71 vref 8000
Mactp71 n_dd71 n_z71 n_tail71 0 nch W=12u L=1u
Mactn71 n_dm71 vref n_tail71 0 nch W=12u L=1u
Macttail71 n_tail71 n_tailbias 0 0 nch W=32u L=1u
Mactload71 n_dm71 n_dm71 vdd vdd pch W=40u L=1u
Mactmirror71 n_dd71 n_dd71 vdd vdd pch W=40u L=1u
Mactout71 n_hv71 n_dd71 vdd vdd pch W=40u L=1u
Rhvlo71 n_hv71 vref 9600
Rhvhi71 n_hv71 vbias 48000
Rfixed72_0hi vdd n_fixed72_0 25324.2701856
Rfixed72_0lo n_fixed72_0 0 74675.7298144
Mfp72_0 in8 n_fixed72_0 n_hp72 0 syn W=10u L=1u
Mfn72_0 in8 vweight n_hn72 0 syn W=10u L=1u
Rfixed72_1hi vdd n_fixed72_1 54872.1415445
Rfixed72_1lo n_fixed72_1 0 45127.8584555
Mfp72_1 in12 n_fixed72_1 n_hp72 0 syn W=10u L=1u
Mfn72_1 in12 vweight n_hn72 0 syn W=10u L=1u
Rfixed72_2hi vdd n_fixed72_2 21799.636828
Rfixed72_2lo n_fixed72_2 0 78200.363172
Mfp72_2 in11 n_fixed72_2 n_hp72 0 syn W=10u L=1u
Mfn72_2 in11 vweight n_hn72 0 syn W=10u L=1u
Rfixed72_3hi vdd n_fixed72_3 14251.6700712
Rfixed72_3lo n_fixed72_3 0 85748.3299288
Mfp72_3 in6 n_fixed72_3 n_hp72 0 syn W=10u L=1u
Mfn72_3 in6 vweight n_hn72 0 syn W=10u L=1u
Rfixed72_4hi vdd n_fixed72_4 49305.8246937
Rfixed72_4lo n_fixed72_4 0 50694.1753063
Mfp72_4 vbias n_fixed72_4 n_hp72 0 syn W=10u L=1u
Mfn72_4 vbias vweight n_hn72 0 syn W=10u L=1u
Mh72a n_hn72 n_hn72 0 0 nch W=20u L=1u
Mh72b n_z72 n_hn72 0 0 nch W=20u L=1u
Mh72c n_hp72 n_hp72 0 0 nch W=20u L=1u
Mh72d n_mirrorh72 n_hp72 0 0 nch W=20u L=1u
Mh72e n_mirrorh72 n_mirrorh72 vdd vdd pch W=60u L=1u
Mh72f n_z72 n_mirrorh72 vdd vdd pch W=60u L=1u
Rh72sum n_z72 vref 8000
Mactp72 n_dd72 n_z72 n_tail72 0 nch W=12u L=1u
Mactn72 n_dm72 vref n_tail72 0 nch W=12u L=1u
Macttail72 n_tail72 n_tailbias 0 0 nch W=32u L=1u
Mactload72 n_dm72 n_dm72 vdd vdd pch W=40u L=1u
Mactmirror72 n_dd72 n_dd72 vdd vdd pch W=40u L=1u
Mactout72 n_hv72 n_dd72 vdd vdd pch W=40u L=1u
Rhvlo72 n_hv72 vref 9600
Rhvhi72 n_hv72 vbias 48000
Rfixed73_0hi vdd n_fixed73_0 38186.7563652
Rfixed73_0lo n_fixed73_0 0 61813.2436348
Mfp73_0 in1 n_fixed73_0 n_hp73 0 syn W=10u L=1u
Mfn73_0 in1 vweight n_hn73 0 syn W=10u L=1u
Rfixed73_1hi vdd n_fixed73_1 40576.3533743
Rfixed73_1lo n_fixed73_1 0 59423.6466257
Mfp73_1 in4 n_fixed73_1 n_hp73 0 syn W=10u L=1u
Mfn73_1 in4 vweight n_hn73 0 syn W=10u L=1u
Rfixed73_2hi vdd n_fixed73_2 57458.1768664
Rfixed73_2lo n_fixed73_2 0 42541.8231336
Mfp73_2 in8 n_fixed73_2 n_hp73 0 syn W=10u L=1u
Mfn73_2 in8 vweight n_hn73 0 syn W=10u L=1u
Rfixed73_3hi vdd n_fixed73_3 54961.8666014
Rfixed73_3lo n_fixed73_3 0 45038.1333986
Mfp73_3 in15 n_fixed73_3 n_hp73 0 syn W=10u L=1u
Mfn73_3 in15 vweight n_hn73 0 syn W=10u L=1u
Rfixed73_4hi vdd n_fixed73_4 30377.7935724
Rfixed73_4lo n_fixed73_4 0 69622.2064276
Mfp73_4 vbias n_fixed73_4 n_hp73 0 syn W=10u L=1u
Mfn73_4 vbias vweight n_hn73 0 syn W=10u L=1u
Mh73a n_hn73 n_hn73 0 0 nch W=20u L=1u
Mh73b n_z73 n_hn73 0 0 nch W=20u L=1u
Mh73c n_hp73 n_hp73 0 0 nch W=20u L=1u
Mh73d n_mirrorh73 n_hp73 0 0 nch W=20u L=1u
Mh73e n_mirrorh73 n_mirrorh73 vdd vdd pch W=60u L=1u
Mh73f n_z73 n_mirrorh73 vdd vdd pch W=60u L=1u
Rh73sum n_z73 vref 8000
Mactp73 n_dd73 n_z73 n_tail73 0 nch W=12u L=1u
Mactn73 n_dm73 vref n_tail73 0 nch W=12u L=1u
Macttail73 n_tail73 n_tailbias 0 0 nch W=32u L=1u
Mactload73 n_dm73 n_dm73 vdd vdd pch W=40u L=1u
Mactmirror73 n_dd73 n_dd73 vdd vdd pch W=40u L=1u
Mactout73 n_hv73 n_dd73 vdd vdd pch W=40u L=1u
Rhvlo73 n_hv73 vref 9600
Rhvhi73 n_hv73 vbias 48000
Rfixed74_0hi vdd n_fixed74_0 15924.6041909
Rfixed74_0lo n_fixed74_0 0 84075.3958091
Mfp74_0 in0 n_fixed74_0 n_hp74 0 syn W=10u L=1u
Mfn74_0 in0 vweight n_hn74 0 syn W=10u L=1u
Rfixed74_1hi vdd n_fixed74_1 48475.5674919
Rfixed74_1lo n_fixed74_1 0 51524.4325081
Mfp74_1 in2 n_fixed74_1 n_hp74 0 syn W=10u L=1u
Mfn74_1 in2 vweight n_hn74 0 syn W=10u L=1u
Rfixed74_2hi vdd n_fixed74_2 60784.839086
Rfixed74_2lo n_fixed74_2 0 39215.160914
Mfp74_2 in8 n_fixed74_2 n_hp74 0 syn W=10u L=1u
Mfn74_2 in8 vweight n_hn74 0 syn W=10u L=1u
Rfixed74_3hi vdd n_fixed74_3 25279.4515184
Rfixed74_3lo n_fixed74_3 0 74720.5484816
Mfp74_3 in11 n_fixed74_3 n_hp74 0 syn W=10u L=1u
Mfn74_3 in11 vweight n_hn74 0 syn W=10u L=1u
Rfixed74_4hi vdd n_fixed74_4 44507.7650496
Rfixed74_4lo n_fixed74_4 0 55492.2349504
Mfp74_4 vbias n_fixed74_4 n_hp74 0 syn W=10u L=1u
Mfn74_4 vbias vweight n_hn74 0 syn W=10u L=1u
Mh74a n_hn74 n_hn74 0 0 nch W=20u L=1u
Mh74b n_z74 n_hn74 0 0 nch W=20u L=1u
Mh74c n_hp74 n_hp74 0 0 nch W=20u L=1u
Mh74d n_mirrorh74 n_hp74 0 0 nch W=20u L=1u
Mh74e n_mirrorh74 n_mirrorh74 vdd vdd pch W=60u L=1u
Mh74f n_z74 n_mirrorh74 vdd vdd pch W=60u L=1u
Rh74sum n_z74 vref 8000
Mactp74 n_dd74 n_z74 n_tail74 0 nch W=12u L=1u
Mactn74 n_dm74 vref n_tail74 0 nch W=12u L=1u
Macttail74 n_tail74 n_tailbias 0 0 nch W=32u L=1u
Mactload74 n_dm74 n_dm74 vdd vdd pch W=40u L=1u
Mactmirror74 n_dd74 n_dd74 vdd vdd pch W=40u L=1u
Mactout74 n_hv74 n_dd74 vdd vdd pch W=40u L=1u
Rhvlo74 n_hv74 vref 9600
Rhvhi74 n_hv74 vbias 48000
Rfixed75_0hi vdd n_fixed75_0 46992.6103006
Rfixed75_0lo n_fixed75_0 0 53007.3896994
Mfp75_0 in6 n_fixed75_0 n_hp75 0 syn W=10u L=1u
Mfn75_0 in6 vweight n_hn75 0 syn W=10u L=1u
Rfixed75_1hi vdd n_fixed75_1 16525.9230252
Rfixed75_1lo n_fixed75_1 0 83474.0769748
Mfp75_1 in3 n_fixed75_1 n_hp75 0 syn W=10u L=1u
Mfn75_1 in3 vweight n_hn75 0 syn W=10u L=1u
Rfixed75_2hi vdd n_fixed75_2 29213.3041169
Rfixed75_2lo n_fixed75_2 0 70786.6958831
Mfp75_2 in5 n_fixed75_2 n_hp75 0 syn W=10u L=1u
Mfn75_2 in5 vweight n_hn75 0 syn W=10u L=1u
Rfixed75_3hi vdd n_fixed75_3 19335.966048
Rfixed75_3lo n_fixed75_3 0 80664.033952
Mfp75_3 in4 n_fixed75_3 n_hp75 0 syn W=10u L=1u
Mfn75_3 in4 vweight n_hn75 0 syn W=10u L=1u
Rfixed75_4hi vdd n_fixed75_4 46525.9973677
Rfixed75_4lo n_fixed75_4 0 53474.0026323
Mfp75_4 vbias n_fixed75_4 n_hp75 0 syn W=10u L=1u
Mfn75_4 vbias vweight n_hn75 0 syn W=10u L=1u
Mh75a n_hn75 n_hn75 0 0 nch W=20u L=1u
Mh75b n_z75 n_hn75 0 0 nch W=20u L=1u
Mh75c n_hp75 n_hp75 0 0 nch W=20u L=1u
Mh75d n_mirrorh75 n_hp75 0 0 nch W=20u L=1u
Mh75e n_mirrorh75 n_mirrorh75 vdd vdd pch W=60u L=1u
Mh75f n_z75 n_mirrorh75 vdd vdd pch W=60u L=1u
Rh75sum n_z75 vref 8000
Mactp75 n_dd75 n_z75 n_tail75 0 nch W=12u L=1u
Mactn75 n_dm75 vref n_tail75 0 nch W=12u L=1u
Macttail75 n_tail75 n_tailbias 0 0 nch W=32u L=1u
Mactload75 n_dm75 n_dm75 vdd vdd pch W=40u L=1u
Mactmirror75 n_dd75 n_dd75 vdd vdd pch W=40u L=1u
Mactout75 n_hv75 n_dd75 vdd vdd pch W=40u L=1u
Rhvlo75 n_hv75 vref 9600
Rhvhi75 n_hv75 vbias 48000
Rfixed76_0hi vdd n_fixed76_0 26689.1333956
Rfixed76_0lo n_fixed76_0 0 73310.8666044
Mfp76_0 in14 n_fixed76_0 n_hp76 0 syn W=10u L=1u
Mfn76_0 in14 vweight n_hn76 0 syn W=10u L=1u
Rfixed76_1hi vdd n_fixed76_1 35698.8454305
Rfixed76_1lo n_fixed76_1 0 64301.1545695
Mfp76_1 in8 n_fixed76_1 n_hp76 0 syn W=10u L=1u
Mfn76_1 in8 vweight n_hn76 0 syn W=10u L=1u
Rfixed76_2hi vdd n_fixed76_2 45227.10111
Rfixed76_2lo n_fixed76_2 0 54772.89889
Mfp76_2 in15 n_fixed76_2 n_hp76 0 syn W=10u L=1u
Mfn76_2 in15 vweight n_hn76 0 syn W=10u L=1u
Rfixed76_3hi vdd n_fixed76_3 80000
Rfixed76_3lo n_fixed76_3 0 20000
Mfp76_3 in11 n_fixed76_3 n_hp76 0 syn W=10u L=1u
Mfn76_3 in11 vweight n_hn76 0 syn W=10u L=1u
Rfixed76_4hi vdd n_fixed76_4 47332.8609932
Rfixed76_4lo n_fixed76_4 0 52667.1390068
Mfp76_4 vbias n_fixed76_4 n_hp76 0 syn W=10u L=1u
Mfn76_4 vbias vweight n_hn76 0 syn W=10u L=1u
Mh76a n_hn76 n_hn76 0 0 nch W=20u L=1u
Mh76b n_z76 n_hn76 0 0 nch W=20u L=1u
Mh76c n_hp76 n_hp76 0 0 nch W=20u L=1u
Mh76d n_mirrorh76 n_hp76 0 0 nch W=20u L=1u
Mh76e n_mirrorh76 n_mirrorh76 vdd vdd pch W=60u L=1u
Mh76f n_z76 n_mirrorh76 vdd vdd pch W=60u L=1u
Rh76sum n_z76 vref 8000
Mactp76 n_dd76 n_z76 n_tail76 0 nch W=12u L=1u
Mactn76 n_dm76 vref n_tail76 0 nch W=12u L=1u
Macttail76 n_tail76 n_tailbias 0 0 nch W=32u L=1u
Mactload76 n_dm76 n_dm76 vdd vdd pch W=40u L=1u
Mactmirror76 n_dd76 n_dd76 vdd vdd pch W=40u L=1u
Mactout76 n_hv76 n_dd76 vdd vdd pch W=40u L=1u
Rhvlo76 n_hv76 vref 9600
Rhvhi76 n_hv76 vbias 48000
Rfixed77_0hi vdd n_fixed77_0 45409.661703
Rfixed77_0lo n_fixed77_0 0 54590.338297
Mfp77_0 in7 n_fixed77_0 n_hp77 0 syn W=10u L=1u
Mfn77_0 in7 vweight n_hn77 0 syn W=10u L=1u
Rfixed77_1hi vdd n_fixed77_1 26204.1505729
Rfixed77_1lo n_fixed77_1 0 73795.8494271
Mfp77_1 in6 n_fixed77_1 n_hp77 0 syn W=10u L=1u
Mfn77_1 in6 vweight n_hn77 0 syn W=10u L=1u
Rfixed77_2hi vdd n_fixed77_2 13998.3335865
Rfixed77_2lo n_fixed77_2 0 86001.6664135
Mfp77_2 in8 n_fixed77_2 n_hp77 0 syn W=10u L=1u
Mfn77_2 in8 vweight n_hn77 0 syn W=10u L=1u
Rfixed77_3hi vdd n_fixed77_3 30022.3038804
Rfixed77_3lo n_fixed77_3 0 69977.6961196
Mfp77_3 in14 n_fixed77_3 n_hp77 0 syn W=10u L=1u
Mfn77_3 in14 vweight n_hn77 0 syn W=10u L=1u
Rfixed77_4hi vdd n_fixed77_4 45537.0940132
Rfixed77_4lo n_fixed77_4 0 54462.9059868
Mfp77_4 vbias n_fixed77_4 n_hp77 0 syn W=10u L=1u
Mfn77_4 vbias vweight n_hn77 0 syn W=10u L=1u
Mh77a n_hn77 n_hn77 0 0 nch W=20u L=1u
Mh77b n_z77 n_hn77 0 0 nch W=20u L=1u
Mh77c n_hp77 n_hp77 0 0 nch W=20u L=1u
Mh77d n_mirrorh77 n_hp77 0 0 nch W=20u L=1u
Mh77e n_mirrorh77 n_mirrorh77 vdd vdd pch W=60u L=1u
Mh77f n_z77 n_mirrorh77 vdd vdd pch W=60u L=1u
Rh77sum n_z77 vref 8000
Mactp77 n_dd77 n_z77 n_tail77 0 nch W=12u L=1u
Mactn77 n_dm77 vref n_tail77 0 nch W=12u L=1u
Macttail77 n_tail77 n_tailbias 0 0 nch W=32u L=1u
Mactload77 n_dm77 n_dm77 vdd vdd pch W=40u L=1u
Mactmirror77 n_dd77 n_dd77 vdd vdd pch W=40u L=1u
Mactout77 n_hv77 n_dd77 vdd vdd pch W=40u L=1u
Rhvlo77 n_hv77 vref 9600
Rhvhi77 n_hv77 vbias 48000
Rfixed78_0hi vdd n_fixed78_0 39111.2374561
Rfixed78_0lo n_fixed78_0 0 60888.7625439
Mfp78_0 in7 n_fixed78_0 n_hp78 0 syn W=10u L=1u
Mfn78_0 in7 vweight n_hn78 0 syn W=10u L=1u
Rfixed78_1hi vdd n_fixed78_1 15506.666732
Rfixed78_1lo n_fixed78_1 0 84493.333268
Mfp78_1 in4 n_fixed78_1 n_hp78 0 syn W=10u L=1u
Mfn78_1 in4 vweight n_hn78 0 syn W=10u L=1u
Rfixed78_2hi vdd n_fixed78_2 19968.2387333
Rfixed78_2lo n_fixed78_2 0 80031.7612667
Mfp78_2 in9 n_fixed78_2 n_hp78 0 syn W=10u L=1u
Mfn78_2 in9 vweight n_hn78 0 syn W=10u L=1u
Rfixed78_3hi vdd n_fixed78_3 66935.4931554
Rfixed78_3lo n_fixed78_3 0 33064.5068446
Mfp78_3 in11 n_fixed78_3 n_hp78 0 syn W=10u L=1u
Mfn78_3 in11 vweight n_hn78 0 syn W=10u L=1u
Rfixed78_4hi vdd n_fixed78_4 55646.610307
Rfixed78_4lo n_fixed78_4 0 44353.389693
Mfp78_4 vbias n_fixed78_4 n_hp78 0 syn W=10u L=1u
Mfn78_4 vbias vweight n_hn78 0 syn W=10u L=1u
Mh78a n_hn78 n_hn78 0 0 nch W=20u L=1u
Mh78b n_z78 n_hn78 0 0 nch W=20u L=1u
Mh78c n_hp78 n_hp78 0 0 nch W=20u L=1u
Mh78d n_mirrorh78 n_hp78 0 0 nch W=20u L=1u
Mh78e n_mirrorh78 n_mirrorh78 vdd vdd pch W=60u L=1u
Mh78f n_z78 n_mirrorh78 vdd vdd pch W=60u L=1u
Rh78sum n_z78 vref 8000
Mactp78 n_dd78 n_z78 n_tail78 0 nch W=12u L=1u
Mactn78 n_dm78 vref n_tail78 0 nch W=12u L=1u
Macttail78 n_tail78 n_tailbias 0 0 nch W=32u L=1u
Mactload78 n_dm78 n_dm78 vdd vdd pch W=40u L=1u
Mactmirror78 n_dd78 n_dd78 vdd vdd pch W=40u L=1u
Mactout78 n_hv78 n_dd78 vdd vdd pch W=40u L=1u
Rhvlo78 n_hv78 vref 9600
Rhvhi78 n_hv78 vbias 48000
Rfixed79_0hi vdd n_fixed79_0 18035.6581908
Rfixed79_0lo n_fixed79_0 0 81964.3418092
Mfp79_0 in7 n_fixed79_0 n_hp79 0 syn W=10u L=1u
Mfn79_0 in7 vweight n_hn79 0 syn W=10u L=1u
Rfixed79_1hi vdd n_fixed79_1 15702.8895487
Rfixed79_1lo n_fixed79_1 0 84297.1104513
Mfp79_1 in12 n_fixed79_1 n_hp79 0 syn W=10u L=1u
Mfn79_1 in12 vweight n_hn79 0 syn W=10u L=1u
Rfixed79_2hi vdd n_fixed79_2 28089.5214691
Rfixed79_2lo n_fixed79_2 0 71910.4785309
Mfp79_2 in4 n_fixed79_2 n_hp79 0 syn W=10u L=1u
Mfn79_2 in4 vweight n_hn79 0 syn W=10u L=1u
Rfixed79_3hi vdd n_fixed79_3 24884.1251696
Rfixed79_3lo n_fixed79_3 0 75115.8748304
Mfp79_3 in3 n_fixed79_3 n_hp79 0 syn W=10u L=1u
Mfn79_3 in3 vweight n_hn79 0 syn W=10u L=1u
Rfixed79_4hi vdd n_fixed79_4 47942.4080671
Rfixed79_4lo n_fixed79_4 0 52057.5919329
Mfp79_4 vbias n_fixed79_4 n_hp79 0 syn W=10u L=1u
Mfn79_4 vbias vweight n_hn79 0 syn W=10u L=1u
Mh79a n_hn79 n_hn79 0 0 nch W=20u L=1u
Mh79b n_z79 n_hn79 0 0 nch W=20u L=1u
Mh79c n_hp79 n_hp79 0 0 nch W=20u L=1u
Mh79d n_mirrorh79 n_hp79 0 0 nch W=20u L=1u
Mh79e n_mirrorh79 n_mirrorh79 vdd vdd pch W=60u L=1u
Mh79f n_z79 n_mirrorh79 vdd vdd pch W=60u L=1u
Rh79sum n_z79 vref 8000
Mactp79 n_dd79 n_z79 n_tail79 0 nch W=12u L=1u
Mactn79 n_dm79 vref n_tail79 0 nch W=12u L=1u
Macttail79 n_tail79 n_tailbias 0 0 nch W=32u L=1u
Mactload79 n_dm79 n_dm79 vdd vdd pch W=40u L=1u
Mactmirror79 n_dd79 n_dd79 vdd vdd pch W=40u L=1u
Mactout79 n_hv79 n_dd79 vdd vdd pch W=40u L=1u
Rhvlo79 n_hv79 vref 9600
Rhvhi79 n_hv79 vbias 48000
Rfixed80_0hi vdd n_fixed80_0 48978.1233925
Rfixed80_0lo n_fixed80_0 0 51021.8766075
Mfp80_0 in4 n_fixed80_0 n_hp80 0 syn W=10u L=1u
Mfn80_0 in4 vweight n_hn80 0 syn W=10u L=1u
Rfixed80_1hi vdd n_fixed80_1 41514.2224508
Rfixed80_1lo n_fixed80_1 0 58485.7775492
Mfp80_1 in9 n_fixed80_1 n_hp80 0 syn W=10u L=1u
Mfn80_1 in9 vweight n_hn80 0 syn W=10u L=1u
Rfixed80_2hi vdd n_fixed80_2 22907.191592
Rfixed80_2lo n_fixed80_2 0 77092.808408
Mfp80_2 in15 n_fixed80_2 n_hp80 0 syn W=10u L=1u
Mfn80_2 in15 vweight n_hn80 0 syn W=10u L=1u
Rfixed80_3hi vdd n_fixed80_3 19833.9539314
Rfixed80_3lo n_fixed80_3 0 80166.0460686
Mfp80_3 in7 n_fixed80_3 n_hp80 0 syn W=10u L=1u
Mfn80_3 in7 vweight n_hn80 0 syn W=10u L=1u
Rfixed80_4hi vdd n_fixed80_4 48935.5761468
Rfixed80_4lo n_fixed80_4 0 51064.4238532
Mfp80_4 vbias n_fixed80_4 n_hp80 0 syn W=10u L=1u
Mfn80_4 vbias vweight n_hn80 0 syn W=10u L=1u
Mh80a n_hn80 n_hn80 0 0 nch W=20u L=1u
Mh80b n_z80 n_hn80 0 0 nch W=20u L=1u
Mh80c n_hp80 n_hp80 0 0 nch W=20u L=1u
Mh80d n_mirrorh80 n_hp80 0 0 nch W=20u L=1u
Mh80e n_mirrorh80 n_mirrorh80 vdd vdd pch W=60u L=1u
Mh80f n_z80 n_mirrorh80 vdd vdd pch W=60u L=1u
Rh80sum n_z80 vref 8000
Mactp80 n_dd80 n_z80 n_tail80 0 nch W=12u L=1u
Mactn80 n_dm80 vref n_tail80 0 nch W=12u L=1u
Macttail80 n_tail80 n_tailbias 0 0 nch W=32u L=1u
Mactload80 n_dm80 n_dm80 vdd vdd pch W=40u L=1u
Mactmirror80 n_dd80 n_dd80 vdd vdd pch W=40u L=1u
Mactout80 n_hv80 n_dd80 vdd vdd pch W=40u L=1u
Rhvlo80 n_hv80 vref 9600
Rhvhi80 n_hv80 vbias 48000
Rfixed81_0hi vdd n_fixed81_0 18696.1888511
Rfixed81_0lo n_fixed81_0 0 81303.8111489
Mfp81_0 in7 n_fixed81_0 n_hp81 0 syn W=10u L=1u
Mfn81_0 in7 vweight n_hn81 0 syn W=10u L=1u
Rfixed81_1hi vdd n_fixed81_1 42800.3462196
Rfixed81_1lo n_fixed81_1 0 57199.6537804
Mfp81_1 in1 n_fixed81_1 n_hp81 0 syn W=10u L=1u
Mfn81_1 in1 vweight n_hn81 0 syn W=10u L=1u
Rfixed81_2hi vdd n_fixed81_2 53953.129794
Rfixed81_2lo n_fixed81_2 0 46046.870206
Mfp81_2 in11 n_fixed81_2 n_hp81 0 syn W=10u L=1u
Mfn81_2 in11 vweight n_hn81 0 syn W=10u L=1u
Rfixed81_3hi vdd n_fixed81_3 26843.8606674
Rfixed81_3lo n_fixed81_3 0 73156.1393326
Mfp81_3 in3 n_fixed81_3 n_hp81 0 syn W=10u L=1u
Mfn81_3 in3 vweight n_hn81 0 syn W=10u L=1u
Rfixed81_4hi vdd n_fixed81_4 34805.1854736
Rfixed81_4lo n_fixed81_4 0 65194.8145264
Mfp81_4 vbias n_fixed81_4 n_hp81 0 syn W=10u L=1u
Mfn81_4 vbias vweight n_hn81 0 syn W=10u L=1u
Mh81a n_hn81 n_hn81 0 0 nch W=20u L=1u
Mh81b n_z81 n_hn81 0 0 nch W=20u L=1u
Mh81c n_hp81 n_hp81 0 0 nch W=20u L=1u
Mh81d n_mirrorh81 n_hp81 0 0 nch W=20u L=1u
Mh81e n_mirrorh81 n_mirrorh81 vdd vdd pch W=60u L=1u
Mh81f n_z81 n_mirrorh81 vdd vdd pch W=60u L=1u
Rh81sum n_z81 vref 8000
Mactp81 n_dd81 n_z81 n_tail81 0 nch W=12u L=1u
Mactn81 n_dm81 vref n_tail81 0 nch W=12u L=1u
Macttail81 n_tail81 n_tailbias 0 0 nch W=32u L=1u
Mactload81 n_dm81 n_dm81 vdd vdd pch W=40u L=1u
Mactmirror81 n_dd81 n_dd81 vdd vdd pch W=40u L=1u
Mactout81 n_hv81 n_dd81 vdd vdd pch W=40u L=1u
Rhvlo81 n_hv81 vref 9600
Rhvhi81 n_hv81 vbias 48000
Rfixed82_0hi vdd n_fixed82_0 10854.3565034
Rfixed82_0lo n_fixed82_0 0 89145.6434966
Mfp82_0 in15 n_fixed82_0 n_hp82 0 syn W=10u L=1u
Mfn82_0 in15 vweight n_hn82 0 syn W=10u L=1u
Rfixed82_1hi vdd n_fixed82_1 31536.2481984
Rfixed82_1lo n_fixed82_1 0 68463.7518016
Mfp82_1 in14 n_fixed82_1 n_hp82 0 syn W=10u L=1u
Mfn82_1 in14 vweight n_hn82 0 syn W=10u L=1u
Rfixed82_2hi vdd n_fixed82_2 12448.2174905
Rfixed82_2lo n_fixed82_2 0 87551.7825095
Mfp82_2 in1 n_fixed82_2 n_hp82 0 syn W=10u L=1u
Mfn82_2 in1 vweight n_hn82 0 syn W=10u L=1u
Rfixed82_3hi vdd n_fixed82_3 35940.333854
Rfixed82_3lo n_fixed82_3 0 64059.666146
Mfp82_3 in2 n_fixed82_3 n_hp82 0 syn W=10u L=1u
Mfn82_3 in2 vweight n_hn82 0 syn W=10u L=1u
Rfixed82_4hi vdd n_fixed82_4 43960.8496477
Rfixed82_4lo n_fixed82_4 0 56039.1503523
Mfp82_4 vbias n_fixed82_4 n_hp82 0 syn W=10u L=1u
Mfn82_4 vbias vweight n_hn82 0 syn W=10u L=1u
Mh82a n_hn82 n_hn82 0 0 nch W=20u L=1u
Mh82b n_z82 n_hn82 0 0 nch W=20u L=1u
Mh82c n_hp82 n_hp82 0 0 nch W=20u L=1u
Mh82d n_mirrorh82 n_hp82 0 0 nch W=20u L=1u
Mh82e n_mirrorh82 n_mirrorh82 vdd vdd pch W=60u L=1u
Mh82f n_z82 n_mirrorh82 vdd vdd pch W=60u L=1u
Rh82sum n_z82 vref 8000
Mactp82 n_dd82 n_z82 n_tail82 0 nch W=12u L=1u
Mactn82 n_dm82 vref n_tail82 0 nch W=12u L=1u
Macttail82 n_tail82 n_tailbias 0 0 nch W=32u L=1u
Mactload82 n_dm82 n_dm82 vdd vdd pch W=40u L=1u
Mactmirror82 n_dd82 n_dd82 vdd vdd pch W=40u L=1u
Mactout82 n_hv82 n_dd82 vdd vdd pch W=40u L=1u
Rhvlo82 n_hv82 vref 9600
Rhvhi82 n_hv82 vbias 48000
Rfixed83_0hi vdd n_fixed83_0 57782.2167975
Rfixed83_0lo n_fixed83_0 0 42217.7832025
Mfp83_0 in14 n_fixed83_0 n_hp83 0 syn W=10u L=1u
Mfn83_0 in14 vweight n_hn83 0 syn W=10u L=1u
Rfixed83_1hi vdd n_fixed83_1 21126.3344167
Rfixed83_1lo n_fixed83_1 0 78873.6655833
Mfp83_1 in5 n_fixed83_1 n_hp83 0 syn W=10u L=1u
Mfn83_1 in5 vweight n_hn83 0 syn W=10u L=1u
Rfixed83_2hi vdd n_fixed83_2 22702.9520216
Rfixed83_2lo n_fixed83_2 0 77297.0479784
Mfp83_2 in10 n_fixed83_2 n_hp83 0 syn W=10u L=1u
Mfn83_2 in10 vweight n_hn83 0 syn W=10u L=1u
Rfixed83_3hi vdd n_fixed83_3 26087.3258447
Rfixed83_3lo n_fixed83_3 0 73912.6741553
Mfp83_3 in4 n_fixed83_3 n_hp83 0 syn W=10u L=1u
Mfn83_3 in4 vweight n_hn83 0 syn W=10u L=1u
Rfixed83_4hi vdd n_fixed83_4 35257.7135954
Rfixed83_4lo n_fixed83_4 0 64742.2864046
Mfp83_4 vbias n_fixed83_4 n_hp83 0 syn W=10u L=1u
Mfn83_4 vbias vweight n_hn83 0 syn W=10u L=1u
Mh83a n_hn83 n_hn83 0 0 nch W=20u L=1u
Mh83b n_z83 n_hn83 0 0 nch W=20u L=1u
Mh83c n_hp83 n_hp83 0 0 nch W=20u L=1u
Mh83d n_mirrorh83 n_hp83 0 0 nch W=20u L=1u
Mh83e n_mirrorh83 n_mirrorh83 vdd vdd pch W=60u L=1u
Mh83f n_z83 n_mirrorh83 vdd vdd pch W=60u L=1u
Rh83sum n_z83 vref 8000
Mactp83 n_dd83 n_z83 n_tail83 0 nch W=12u L=1u
Mactn83 n_dm83 vref n_tail83 0 nch W=12u L=1u
Macttail83 n_tail83 n_tailbias 0 0 nch W=32u L=1u
Mactload83 n_dm83 n_dm83 vdd vdd pch W=40u L=1u
Mactmirror83 n_dd83 n_dd83 vdd vdd pch W=40u L=1u
Mactout83 n_hv83 n_dd83 vdd vdd pch W=40u L=1u
Rhvlo83 n_hv83 vref 9600
Rhvhi83 n_hv83 vbias 48000
Rfixed84_0hi vdd n_fixed84_0 34076.9062826
Rfixed84_0lo n_fixed84_0 0 65923.0937174
Mfp84_0 in15 n_fixed84_0 n_hp84 0 syn W=10u L=1u
Mfn84_0 in15 vweight n_hn84 0 syn W=10u L=1u
Rfixed84_1hi vdd n_fixed84_1 29447.2736414
Rfixed84_1lo n_fixed84_1 0 70552.7263586
Mfp84_1 in7 n_fixed84_1 n_hp84 0 syn W=10u L=1u
Mfn84_1 in7 vweight n_hn84 0 syn W=10u L=1u
Rfixed84_2hi vdd n_fixed84_2 32075.8717396
Rfixed84_2lo n_fixed84_2 0 67924.1282604
Mfp84_2 in6 n_fixed84_2 n_hp84 0 syn W=10u L=1u
Mfn84_2 in6 vweight n_hn84 0 syn W=10u L=1u
Rfixed84_3hi vdd n_fixed84_3 56798.5168899
Rfixed84_3lo n_fixed84_3 0 43201.4831101
Mfp84_3 in12 n_fixed84_3 n_hp84 0 syn W=10u L=1u
Mfn84_3 in12 vweight n_hn84 0 syn W=10u L=1u
Rfixed84_4hi vdd n_fixed84_4 45040.8776866
Rfixed84_4lo n_fixed84_4 0 54959.1223134
Mfp84_4 vbias n_fixed84_4 n_hp84 0 syn W=10u L=1u
Mfn84_4 vbias vweight n_hn84 0 syn W=10u L=1u
Mh84a n_hn84 n_hn84 0 0 nch W=20u L=1u
Mh84b n_z84 n_hn84 0 0 nch W=20u L=1u
Mh84c n_hp84 n_hp84 0 0 nch W=20u L=1u
Mh84d n_mirrorh84 n_hp84 0 0 nch W=20u L=1u
Mh84e n_mirrorh84 n_mirrorh84 vdd vdd pch W=60u L=1u
Mh84f n_z84 n_mirrorh84 vdd vdd pch W=60u L=1u
Rh84sum n_z84 vref 8000
Mactp84 n_dd84 n_z84 n_tail84 0 nch W=12u L=1u
Mactn84 n_dm84 vref n_tail84 0 nch W=12u L=1u
Macttail84 n_tail84 n_tailbias 0 0 nch W=32u L=1u
Mactload84 n_dm84 n_dm84 vdd vdd pch W=40u L=1u
Mactmirror84 n_dd84 n_dd84 vdd vdd pch W=40u L=1u
Mactout84 n_hv84 n_dd84 vdd vdd pch W=40u L=1u
Rhvlo84 n_hv84 vref 9600
Rhvhi84 n_hv84 vbias 48000
Rfixed85_0hi vdd n_fixed85_0 45536.9452875
Rfixed85_0lo n_fixed85_0 0 54463.0547125
Mfp85_0 in8 n_fixed85_0 n_hp85 0 syn W=10u L=1u
Mfn85_0 in8 vweight n_hn85 0 syn W=10u L=1u
Rfixed85_1hi vdd n_fixed85_1 31135.6213227
Rfixed85_1lo n_fixed85_1 0 68864.3786773
Mfp85_1 in5 n_fixed85_1 n_hp85 0 syn W=10u L=1u
Mfn85_1 in5 vweight n_hn85 0 syn W=10u L=1u
Rfixed85_2hi vdd n_fixed85_2 32577.5951805
Rfixed85_2lo n_fixed85_2 0 67422.4048195
Mfp85_2 in7 n_fixed85_2 n_hp85 0 syn W=10u L=1u
Mfn85_2 in7 vweight n_hn85 0 syn W=10u L=1u
Rfixed85_3hi vdd n_fixed85_3 37415.7288274
Rfixed85_3lo n_fixed85_3 0 62584.2711726
Mfp85_3 in9 n_fixed85_3 n_hp85 0 syn W=10u L=1u
Mfn85_3 in9 vweight n_hn85 0 syn W=10u L=1u
Rfixed85_4hi vdd n_fixed85_4 39301.7280057
Rfixed85_4lo n_fixed85_4 0 60698.2719943
Mfp85_4 vbias n_fixed85_4 n_hp85 0 syn W=10u L=1u
Mfn85_4 vbias vweight n_hn85 0 syn W=10u L=1u
Mh85a n_hn85 n_hn85 0 0 nch W=20u L=1u
Mh85b n_z85 n_hn85 0 0 nch W=20u L=1u
Mh85c n_hp85 n_hp85 0 0 nch W=20u L=1u
Mh85d n_mirrorh85 n_hp85 0 0 nch W=20u L=1u
Mh85e n_mirrorh85 n_mirrorh85 vdd vdd pch W=60u L=1u
Mh85f n_z85 n_mirrorh85 vdd vdd pch W=60u L=1u
Rh85sum n_z85 vref 8000
Mactp85 n_dd85 n_z85 n_tail85 0 nch W=12u L=1u
Mactn85 n_dm85 vref n_tail85 0 nch W=12u L=1u
Macttail85 n_tail85 n_tailbias 0 0 nch W=32u L=1u
Mactload85 n_dm85 n_dm85 vdd vdd pch W=40u L=1u
Mactmirror85 n_dd85 n_dd85 vdd vdd pch W=40u L=1u
Mactout85 n_hv85 n_dd85 vdd vdd pch W=40u L=1u
Rhvlo85 n_hv85 vref 9600
Rhvhi85 n_hv85 vbias 48000
Rfixed86_0hi vdd n_fixed86_0 15229.0366284
Rfixed86_0lo n_fixed86_0 0 84770.9633716
Mfp86_0 in0 n_fixed86_0 n_hp86 0 syn W=10u L=1u
Mfn86_0 in0 vweight n_hn86 0 syn W=10u L=1u
Rfixed86_1hi vdd n_fixed86_1 60800.9809045
Rfixed86_1lo n_fixed86_1 0 39199.0190955
Mfp86_1 in13 n_fixed86_1 n_hp86 0 syn W=10u L=1u
Mfn86_1 in13 vweight n_hn86 0 syn W=10u L=1u
Rfixed86_2hi vdd n_fixed86_2 42550.0126974
Rfixed86_2lo n_fixed86_2 0 57449.9873026
Mfp86_2 in7 n_fixed86_2 n_hp86 0 syn W=10u L=1u
Mfn86_2 in7 vweight n_hn86 0 syn W=10u L=1u
Rfixed86_3hi vdd n_fixed86_3 29294.1480997
Rfixed86_3lo n_fixed86_3 0 70705.8519003
Mfp86_3 in5 n_fixed86_3 n_hp86 0 syn W=10u L=1u
Mfn86_3 in5 vweight n_hn86 0 syn W=10u L=1u
Rfixed86_4hi vdd n_fixed86_4 31679.3193549
Rfixed86_4lo n_fixed86_4 0 68320.6806451
Mfp86_4 vbias n_fixed86_4 n_hp86 0 syn W=10u L=1u
Mfn86_4 vbias vweight n_hn86 0 syn W=10u L=1u
Mh86a n_hn86 n_hn86 0 0 nch W=20u L=1u
Mh86b n_z86 n_hn86 0 0 nch W=20u L=1u
Mh86c n_hp86 n_hp86 0 0 nch W=20u L=1u
Mh86d n_mirrorh86 n_hp86 0 0 nch W=20u L=1u
Mh86e n_mirrorh86 n_mirrorh86 vdd vdd pch W=60u L=1u
Mh86f n_z86 n_mirrorh86 vdd vdd pch W=60u L=1u
Rh86sum n_z86 vref 8000
Mactp86 n_dd86 n_z86 n_tail86 0 nch W=12u L=1u
Mactn86 n_dm86 vref n_tail86 0 nch W=12u L=1u
Macttail86 n_tail86 n_tailbias 0 0 nch W=32u L=1u
Mactload86 n_dm86 n_dm86 vdd vdd pch W=40u L=1u
Mactmirror86 n_dd86 n_dd86 vdd vdd pch W=40u L=1u
Mactout86 n_hv86 n_dd86 vdd vdd pch W=40u L=1u
Rhvlo86 n_hv86 vref 9600
Rhvhi86 n_hv86 vbias 48000
Rfixed87_0hi vdd n_fixed87_0 13752.6576916
Rfixed87_0lo n_fixed87_0 0 86247.3423084
Mfp87_0 in4 n_fixed87_0 n_hp87 0 syn W=10u L=1u
Mfn87_0 in4 vweight n_hn87 0 syn W=10u L=1u
Rfixed87_1hi vdd n_fixed87_1 65878.8624309
Rfixed87_1lo n_fixed87_1 0 34121.1375691
Mfp87_1 in12 n_fixed87_1 n_hp87 0 syn W=10u L=1u
Mfn87_1 in12 vweight n_hn87 0 syn W=10u L=1u
Rfixed87_2hi vdd n_fixed87_2 17833.1058696
Rfixed87_2lo n_fixed87_2 0 82166.8941304
Mfp87_2 in0 n_fixed87_2 n_hp87 0 syn W=10u L=1u
Mfn87_2 in0 vweight n_hn87 0 syn W=10u L=1u
Rfixed87_3hi vdd n_fixed87_3 60732.438776
Rfixed87_3lo n_fixed87_3 0 39267.561224
Mfp87_3 in13 n_fixed87_3 n_hp87 0 syn W=10u L=1u
Mfn87_3 in13 vweight n_hn87 0 syn W=10u L=1u
Rfixed87_4hi vdd n_fixed87_4 42841.1641019
Rfixed87_4lo n_fixed87_4 0 57158.8358981
Mfp87_4 vbias n_fixed87_4 n_hp87 0 syn W=10u L=1u
Mfn87_4 vbias vweight n_hn87 0 syn W=10u L=1u
Mh87a n_hn87 n_hn87 0 0 nch W=20u L=1u
Mh87b n_z87 n_hn87 0 0 nch W=20u L=1u
Mh87c n_hp87 n_hp87 0 0 nch W=20u L=1u
Mh87d n_mirrorh87 n_hp87 0 0 nch W=20u L=1u
Mh87e n_mirrorh87 n_mirrorh87 vdd vdd pch W=60u L=1u
Mh87f n_z87 n_mirrorh87 vdd vdd pch W=60u L=1u
Rh87sum n_z87 vref 8000
Mactp87 n_dd87 n_z87 n_tail87 0 nch W=12u L=1u
Mactn87 n_dm87 vref n_tail87 0 nch W=12u L=1u
Macttail87 n_tail87 n_tailbias 0 0 nch W=32u L=1u
Mactload87 n_dm87 n_dm87 vdd vdd pch W=40u L=1u
Mactmirror87 n_dd87 n_dd87 vdd vdd pch W=40u L=1u
Mactout87 n_hv87 n_dd87 vdd vdd pch W=40u L=1u
Rhvlo87 n_hv87 vref 9600
Rhvhi87 n_hv87 vbias 48000
Rfixed88_0hi vdd n_fixed88_0 48174.4445631
Rfixed88_0lo n_fixed88_0 0 51825.5554369
Mfp88_0 in8 n_fixed88_0 n_hp88 0 syn W=10u L=1u
Mfn88_0 in8 vweight n_hn88 0 syn W=10u L=1u
Rfixed88_1hi vdd n_fixed88_1 51577.4536603
Rfixed88_1lo n_fixed88_1 0 48422.5463397
Mfp88_1 in2 n_fixed88_1 n_hp88 0 syn W=10u L=1u
Mfn88_1 in2 vweight n_hn88 0 syn W=10u L=1u
Rfixed88_2hi vdd n_fixed88_2 19402.4807054
Rfixed88_2lo n_fixed88_2 0 80597.5192946
Mfp88_2 in1 n_fixed88_2 n_hp88 0 syn W=10u L=1u
Mfn88_2 in1 vweight n_hn88 0 syn W=10u L=1u
Rfixed88_3hi vdd n_fixed88_3 38125.8633942
Rfixed88_3lo n_fixed88_3 0 61874.1366058
Mfp88_3 in7 n_fixed88_3 n_hp88 0 syn W=10u L=1u
Mfn88_3 in7 vweight n_hn88 0 syn W=10u L=1u
Rfixed88_4hi vdd n_fixed88_4 44324.9187215
Rfixed88_4lo n_fixed88_4 0 55675.0812785
Mfp88_4 vbias n_fixed88_4 n_hp88 0 syn W=10u L=1u
Mfn88_4 vbias vweight n_hn88 0 syn W=10u L=1u
Mh88a n_hn88 n_hn88 0 0 nch W=20u L=1u
Mh88b n_z88 n_hn88 0 0 nch W=20u L=1u
Mh88c n_hp88 n_hp88 0 0 nch W=20u L=1u
Mh88d n_mirrorh88 n_hp88 0 0 nch W=20u L=1u
Mh88e n_mirrorh88 n_mirrorh88 vdd vdd pch W=60u L=1u
Mh88f n_z88 n_mirrorh88 vdd vdd pch W=60u L=1u
Rh88sum n_z88 vref 8000
Mactp88 n_dd88 n_z88 n_tail88 0 nch W=12u L=1u
Mactn88 n_dm88 vref n_tail88 0 nch W=12u L=1u
Macttail88 n_tail88 n_tailbias 0 0 nch W=32u L=1u
Mactload88 n_dm88 n_dm88 vdd vdd pch W=40u L=1u
Mactmirror88 n_dd88 n_dd88 vdd vdd pch W=40u L=1u
Mactout88 n_hv88 n_dd88 vdd vdd pch W=40u L=1u
Rhvlo88 n_hv88 vref 9600
Rhvhi88 n_hv88 vbias 48000
Rfixed89_0hi vdd n_fixed89_0 41364.6437553
Rfixed89_0lo n_fixed89_0 0 58635.3562447
Mfp89_0 in8 n_fixed89_0 n_hp89 0 syn W=10u L=1u
Mfn89_0 in8 vweight n_hn89 0 syn W=10u L=1u
Rfixed89_1hi vdd n_fixed89_1 36683.0901148
Rfixed89_1lo n_fixed89_1 0 63316.9098852
Mfp89_1 in12 n_fixed89_1 n_hp89 0 syn W=10u L=1u
Mfn89_1 in12 vweight n_hn89 0 syn W=10u L=1u
Rfixed89_2hi vdd n_fixed89_2 37864.5619634
Rfixed89_2lo n_fixed89_2 0 62135.4380366
Mfp89_2 in1 n_fixed89_2 n_hp89 0 syn W=10u L=1u
Mfn89_2 in1 vweight n_hn89 0 syn W=10u L=1u
Rfixed89_3hi vdd n_fixed89_3 57882.5628985
Rfixed89_3lo n_fixed89_3 0 42117.4371015
Mfp89_3 in6 n_fixed89_3 n_hp89 0 syn W=10u L=1u
Mfn89_3 in6 vweight n_hn89 0 syn W=10u L=1u
Rfixed89_4hi vdd n_fixed89_4 50470.6289047
Rfixed89_4lo n_fixed89_4 0 49529.3710953
Mfp89_4 vbias n_fixed89_4 n_hp89 0 syn W=10u L=1u
Mfn89_4 vbias vweight n_hn89 0 syn W=10u L=1u
Mh89a n_hn89 n_hn89 0 0 nch W=20u L=1u
Mh89b n_z89 n_hn89 0 0 nch W=20u L=1u
Mh89c n_hp89 n_hp89 0 0 nch W=20u L=1u
Mh89d n_mirrorh89 n_hp89 0 0 nch W=20u L=1u
Mh89e n_mirrorh89 n_mirrorh89 vdd vdd pch W=60u L=1u
Mh89f n_z89 n_mirrorh89 vdd vdd pch W=60u L=1u
Rh89sum n_z89 vref 8000
Mactp89 n_dd89 n_z89 n_tail89 0 nch W=12u L=1u
Mactn89 n_dm89 vref n_tail89 0 nch W=12u L=1u
Macttail89 n_tail89 n_tailbias 0 0 nch W=32u L=1u
Mactload89 n_dm89 n_dm89 vdd vdd pch W=40u L=1u
Mactmirror89 n_dd89 n_dd89 vdd vdd pch W=40u L=1u
Mactout89 n_hv89 n_dd89 vdd vdd pch W=40u L=1u
Rhvlo89 n_hv89 vref 9600
Rhvhi89 n_hv89 vbias 48000
Rfixed90_0hi vdd n_fixed90_0 46327.8127244
Rfixed90_0lo n_fixed90_0 0 53672.1872756
Mfp90_0 in6 n_fixed90_0 n_hp90 0 syn W=10u L=1u
Mfn90_0 in6 vweight n_hn90 0 syn W=10u L=1u
Rfixed90_1hi vdd n_fixed90_1 28456.2684886
Rfixed90_1lo n_fixed90_1 0 71543.7315114
Mfp90_1 in10 n_fixed90_1 n_hp90 0 syn W=10u L=1u
Mfn90_1 in10 vweight n_hn90 0 syn W=10u L=1u
Rfixed90_2hi vdd n_fixed90_2 41463.6637842
Rfixed90_2lo n_fixed90_2 0 58536.3362158
Mfp90_2 in7 n_fixed90_2 n_hp90 0 syn W=10u L=1u
Mfn90_2 in7 vweight n_hn90 0 syn W=10u L=1u
Rfixed90_3hi vdd n_fixed90_3 16363.0487164
Rfixed90_3lo n_fixed90_3 0 83636.9512836
Mfp90_3 in15 n_fixed90_3 n_hp90 0 syn W=10u L=1u
Mfn90_3 in15 vweight n_hn90 0 syn W=10u L=1u
Rfixed90_4hi vdd n_fixed90_4 39681.1289641
Rfixed90_4lo n_fixed90_4 0 60318.8710359
Mfp90_4 vbias n_fixed90_4 n_hp90 0 syn W=10u L=1u
Mfn90_4 vbias vweight n_hn90 0 syn W=10u L=1u
Mh90a n_hn90 n_hn90 0 0 nch W=20u L=1u
Mh90b n_z90 n_hn90 0 0 nch W=20u L=1u
Mh90c n_hp90 n_hp90 0 0 nch W=20u L=1u
Mh90d n_mirrorh90 n_hp90 0 0 nch W=20u L=1u
Mh90e n_mirrorh90 n_mirrorh90 vdd vdd pch W=60u L=1u
Mh90f n_z90 n_mirrorh90 vdd vdd pch W=60u L=1u
Rh90sum n_z90 vref 8000
Mactp90 n_dd90 n_z90 n_tail90 0 nch W=12u L=1u
Mactn90 n_dm90 vref n_tail90 0 nch W=12u L=1u
Macttail90 n_tail90 n_tailbias 0 0 nch W=32u L=1u
Mactload90 n_dm90 n_dm90 vdd vdd pch W=40u L=1u
Mactmirror90 n_dd90 n_dd90 vdd vdd pch W=40u L=1u
Mactout90 n_hv90 n_dd90 vdd vdd pch W=40u L=1u
Rhvlo90 n_hv90 vref 9600
Rhvhi90 n_hv90 vbias 48000
Rfixed91_0hi vdd n_fixed91_0 17816.1988498
Rfixed91_0lo n_fixed91_0 0 82183.8011502
Mfp91_0 in5 n_fixed91_0 n_hp91 0 syn W=10u L=1u
Mfn91_0 in5 vweight n_hn91 0 syn W=10u L=1u
Rfixed91_1hi vdd n_fixed91_1 47621.387682
Rfixed91_1lo n_fixed91_1 0 52378.612318
Mfp91_1 in15 n_fixed91_1 n_hp91 0 syn W=10u L=1u
Mfn91_1 in15 vweight n_hn91 0 syn W=10u L=1u
Rfixed91_2hi vdd n_fixed91_2 62516.790928
Rfixed91_2lo n_fixed91_2 0 37483.209072
Mfp91_2 in6 n_fixed91_2 n_hp91 0 syn W=10u L=1u
Mfn91_2 in6 vweight n_hn91 0 syn W=10u L=1u
Rfixed91_3hi vdd n_fixed91_3 6666.66666667
Rfixed91_3lo n_fixed91_3 0 93333.3333333
Mfp91_3 in9 n_fixed91_3 n_hp91 0 syn W=10u L=1u
Mfn91_3 in9 vweight n_hn91 0 syn W=10u L=1u
Rfixed91_4hi vdd n_fixed91_4 43484.0884535
Rfixed91_4lo n_fixed91_4 0 56515.9115465
Mfp91_4 vbias n_fixed91_4 n_hp91 0 syn W=10u L=1u
Mfn91_4 vbias vweight n_hn91 0 syn W=10u L=1u
Mh91a n_hn91 n_hn91 0 0 nch W=20u L=1u
Mh91b n_z91 n_hn91 0 0 nch W=20u L=1u
Mh91c n_hp91 n_hp91 0 0 nch W=20u L=1u
Mh91d n_mirrorh91 n_hp91 0 0 nch W=20u L=1u
Mh91e n_mirrorh91 n_mirrorh91 vdd vdd pch W=60u L=1u
Mh91f n_z91 n_mirrorh91 vdd vdd pch W=60u L=1u
Rh91sum n_z91 vref 8000
Mactp91 n_dd91 n_z91 n_tail91 0 nch W=12u L=1u
Mactn91 n_dm91 vref n_tail91 0 nch W=12u L=1u
Macttail91 n_tail91 n_tailbias 0 0 nch W=32u L=1u
Mactload91 n_dm91 n_dm91 vdd vdd pch W=40u L=1u
Mactmirror91 n_dd91 n_dd91 vdd vdd pch W=40u L=1u
Mactout91 n_hv91 n_dd91 vdd vdd pch W=40u L=1u
Rhvlo91 n_hv91 vref 9600
Rhvhi91 n_hv91 vbias 48000
Rfixed92_0hi vdd n_fixed92_0 27228.1214398
Rfixed92_0lo n_fixed92_0 0 72771.8785602
Mfp92_0 in13 n_fixed92_0 n_hp92 0 syn W=10u L=1u
Mfn92_0 in13 vweight n_hn92 0 syn W=10u L=1u
Rfixed92_1hi vdd n_fixed92_1 51977.7107632
Rfixed92_1lo n_fixed92_1 0 48022.2892368
Mfp92_1 in8 n_fixed92_1 n_hp92 0 syn W=10u L=1u
Mfn92_1 in8 vweight n_hn92 0 syn W=10u L=1u
Rfixed92_2hi vdd n_fixed92_2 53786.1703736
Rfixed92_2lo n_fixed92_2 0 46213.8296264
Mfp92_2 in3 n_fixed92_2 n_hp92 0 syn W=10u L=1u
Mfn92_2 in3 vweight n_hn92 0 syn W=10u L=1u
Rfixed92_3hi vdd n_fixed92_3 62460.7508873
Rfixed92_3lo n_fixed92_3 0 37539.2491127
Mfp92_3 in11 n_fixed92_3 n_hp92 0 syn W=10u L=1u
Mfn92_3 in11 vweight n_hn92 0 syn W=10u L=1u
Rfixed92_4hi vdd n_fixed92_4 40561.8808669
Rfixed92_4lo n_fixed92_4 0 59438.1191331
Mfp92_4 vbias n_fixed92_4 n_hp92 0 syn W=10u L=1u
Mfn92_4 vbias vweight n_hn92 0 syn W=10u L=1u
Mh92a n_hn92 n_hn92 0 0 nch W=20u L=1u
Mh92b n_z92 n_hn92 0 0 nch W=20u L=1u
Mh92c n_hp92 n_hp92 0 0 nch W=20u L=1u
Mh92d n_mirrorh92 n_hp92 0 0 nch W=20u L=1u
Mh92e n_mirrorh92 n_mirrorh92 vdd vdd pch W=60u L=1u
Mh92f n_z92 n_mirrorh92 vdd vdd pch W=60u L=1u
Rh92sum n_z92 vref 8000
Mactp92 n_dd92 n_z92 n_tail92 0 nch W=12u L=1u
Mactn92 n_dm92 vref n_tail92 0 nch W=12u L=1u
Macttail92 n_tail92 n_tailbias 0 0 nch W=32u L=1u
Mactload92 n_dm92 n_dm92 vdd vdd pch W=40u L=1u
Mactmirror92 n_dd92 n_dd92 vdd vdd pch W=40u L=1u
Mactout92 n_hv92 n_dd92 vdd vdd pch W=40u L=1u
Rhvlo92 n_hv92 vref 9600
Rhvhi92 n_hv92 vbias 48000
Rfixed93_0hi vdd n_fixed93_0 66611.2309087
Rfixed93_0lo n_fixed93_0 0 33388.7690913
Mfp93_0 in2 n_fixed93_0 n_hp93 0 syn W=10u L=1u
Mfn93_0 in2 vweight n_hn93 0 syn W=10u L=1u
Rfixed93_1hi vdd n_fixed93_1 18247.3774299
Rfixed93_1lo n_fixed93_1 0 81752.6225701
Mfp93_1 in4 n_fixed93_1 n_hp93 0 syn W=10u L=1u
Mfn93_1 in4 vweight n_hn93 0 syn W=10u L=1u
Rfixed93_2hi vdd n_fixed93_2 9657.10255811
Rfixed93_2lo n_fixed93_2 0 90342.8974419
Mfp93_2 in15 n_fixed93_2 n_hp93 0 syn W=10u L=1u
Mfn93_2 in15 vweight n_hn93 0 syn W=10u L=1u
Rfixed93_3hi vdd n_fixed93_3 20095.9376256
Rfixed93_3lo n_fixed93_3 0 79904.0623744
Mfp93_3 in1 n_fixed93_3 n_hp93 0 syn W=10u L=1u
Mfn93_3 in1 vweight n_hn93 0 syn W=10u L=1u
Rfixed93_4hi vdd n_fixed93_4 52902.1135173
Rfixed93_4lo n_fixed93_4 0 47097.8864827
Mfp93_4 vbias n_fixed93_4 n_hp93 0 syn W=10u L=1u
Mfn93_4 vbias vweight n_hn93 0 syn W=10u L=1u
Mh93a n_hn93 n_hn93 0 0 nch W=20u L=1u
Mh93b n_z93 n_hn93 0 0 nch W=20u L=1u
Mh93c n_hp93 n_hp93 0 0 nch W=20u L=1u
Mh93d n_mirrorh93 n_hp93 0 0 nch W=20u L=1u
Mh93e n_mirrorh93 n_mirrorh93 vdd vdd pch W=60u L=1u
Mh93f n_z93 n_mirrorh93 vdd vdd pch W=60u L=1u
Rh93sum n_z93 vref 8000
Mactp93 n_dd93 n_z93 n_tail93 0 nch W=12u L=1u
Mactn93 n_dm93 vref n_tail93 0 nch W=12u L=1u
Macttail93 n_tail93 n_tailbias 0 0 nch W=32u L=1u
Mactload93 n_dm93 n_dm93 vdd vdd pch W=40u L=1u
Mactmirror93 n_dd93 n_dd93 vdd vdd pch W=40u L=1u
Mactout93 n_hv93 n_dd93 vdd vdd pch W=40u L=1u
Rhvlo93 n_hv93 vref 9600
Rhvhi93 n_hv93 vbias 48000
Rfixed94_0hi vdd n_fixed94_0 55728.5568022
Rfixed94_0lo n_fixed94_0 0 44271.4431978
Mfp94_0 in1 n_fixed94_0 n_hp94 0 syn W=10u L=1u
Mfn94_0 in1 vweight n_hn94 0 syn W=10u L=1u
Rfixed94_1hi vdd n_fixed94_1 36914.1962392
Rfixed94_1lo n_fixed94_1 0 63085.8037608
Mfp94_1 in10 n_fixed94_1 n_hp94 0 syn W=10u L=1u
Mfn94_1 in10 vweight n_hn94 0 syn W=10u L=1u
Rfixed94_2hi vdd n_fixed94_2 35252.6611272
Rfixed94_2lo n_fixed94_2 0 64747.3388728
Mfp94_2 in15 n_fixed94_2 n_hp94 0 syn W=10u L=1u
Mfn94_2 in15 vweight n_hn94 0 syn W=10u L=1u
Rfixed94_3hi vdd n_fixed94_3 40458.1629109
Rfixed94_3lo n_fixed94_3 0 59541.8370891
Mfp94_3 in8 n_fixed94_3 n_hp94 0 syn W=10u L=1u
Mfn94_3 in8 vweight n_hn94 0 syn W=10u L=1u
Rfixed94_4hi vdd n_fixed94_4 48844.4734323
Rfixed94_4lo n_fixed94_4 0 51155.5265677
Mfp94_4 vbias n_fixed94_4 n_hp94 0 syn W=10u L=1u
Mfn94_4 vbias vweight n_hn94 0 syn W=10u L=1u
Mh94a n_hn94 n_hn94 0 0 nch W=20u L=1u
Mh94b n_z94 n_hn94 0 0 nch W=20u L=1u
Mh94c n_hp94 n_hp94 0 0 nch W=20u L=1u
Mh94d n_mirrorh94 n_hp94 0 0 nch W=20u L=1u
Mh94e n_mirrorh94 n_mirrorh94 vdd vdd pch W=60u L=1u
Mh94f n_z94 n_mirrorh94 vdd vdd pch W=60u L=1u
Rh94sum n_z94 vref 8000
Mactp94 n_dd94 n_z94 n_tail94 0 nch W=12u L=1u
Mactn94 n_dm94 vref n_tail94 0 nch W=12u L=1u
Macttail94 n_tail94 n_tailbias 0 0 nch W=32u L=1u
Mactload94 n_dm94 n_dm94 vdd vdd pch W=40u L=1u
Mactmirror94 n_dd94 n_dd94 vdd vdd pch W=40u L=1u
Mactout94 n_hv94 n_dd94 vdd vdd pch W=40u L=1u
Rhvlo94 n_hv94 vref 9600
Rhvhi94 n_hv94 vbias 48000
Rfixed95_0hi vdd n_fixed95_0 43543.404401
Rfixed95_0lo n_fixed95_0 0 56456.595599
Mfp95_0 in4 n_fixed95_0 n_hp95 0 syn W=10u L=1u
Mfn95_0 in4 vweight n_hn95 0 syn W=10u L=1u
Rfixed95_1hi vdd n_fixed95_1 49067.0747954
Rfixed95_1lo n_fixed95_1 0 50932.9252046
Mfp95_1 in14 n_fixed95_1 n_hp95 0 syn W=10u L=1u
Mfn95_1 in14 vweight n_hn95 0 syn W=10u L=1u
Rfixed95_2hi vdd n_fixed95_2 73264.6590111
Rfixed95_2lo n_fixed95_2 0 26735.3409889
Mfp95_2 in6 n_fixed95_2 n_hp95 0 syn W=10u L=1u
Mfn95_2 in6 vweight n_hn95 0 syn W=10u L=1u
Rfixed95_3hi vdd n_fixed95_3 19920.1472983
Rfixed95_3lo n_fixed95_3 0 80079.8527017
Mfp95_3 in12 n_fixed95_3 n_hp95 0 syn W=10u L=1u
Mfn95_3 in12 vweight n_hn95 0 syn W=10u L=1u
Rfixed95_4hi vdd n_fixed95_4 38434.4140573
Rfixed95_4lo n_fixed95_4 0 61565.5859427
Mfp95_4 vbias n_fixed95_4 n_hp95 0 syn W=10u L=1u
Mfn95_4 vbias vweight n_hn95 0 syn W=10u L=1u
Mh95a n_hn95 n_hn95 0 0 nch W=20u L=1u
Mh95b n_z95 n_hn95 0 0 nch W=20u L=1u
Mh95c n_hp95 n_hp95 0 0 nch W=20u L=1u
Mh95d n_mirrorh95 n_hp95 0 0 nch W=20u L=1u
Mh95e n_mirrorh95 n_mirrorh95 vdd vdd pch W=60u L=1u
Mh95f n_z95 n_mirrorh95 vdd vdd pch W=60u L=1u
Rh95sum n_z95 vref 8000
Mactp95 n_dd95 n_z95 n_tail95 0 nch W=12u L=1u
Mactn95 n_dm95 vref n_tail95 0 nch W=12u L=1u
Macttail95 n_tail95 n_tailbias 0 0 nch W=32u L=1u
Mactload95 n_dm95 n_dm95 vdd vdd pch W=40u L=1u
Mactmirror95 n_dd95 n_dd95 vdd vdd pch W=40u L=1u
Mactout95 n_hv95 n_dd95 vdd vdd pch W=40u L=1u
Rhvlo95 n_hv95 vref 9600
Rhvhi95 n_hv95 vbias 48000
Mo0a n_on0 n_on0 0 0 nch W=20u L=1u
Mo0b out0 n_on0 0 0 nch W=20u L=1u
Mo0c n_op0 n_op0 0 0 nch W=20u L=1u
Mo0d n_mirroro0 n_op0 0 0 nch W=20u L=1u
Mo0e n_mirroro0 n_mirroro0 vdd vdd pch W=60u L=1u
Mo0f out0 n_mirroro0 vdd vdd pch W=60u L=1u
Ro0sum out0 vref 7000
Rtargetin0 target0 n_target0 30000
Rtargetref0 vbias n_target0 36402.5695931
Rtargetzero0 n_target0 0 25512.7563782
Merrorp0 n_error0 n_mirroro0 vdd vdd pch W=60u L=1u
Merrorn0 n_error0 n_on0 0 0 nch W=20u L=1u
Moffset0 n_error0 voffset vdd vdd pch W=10u L=1u
Mtarget0 n_error0 n_target0 0 0 nch W=10u L=1u
Rerror0 n_error0 verror 7000
Rcommon0 n_error0 n_common 10000
Raz0 n_error0 n_azfeed0 6000
Maztrack0 n_azfeed0 learn n_az0 0 syn W=1000u L=1u
Caz0 n_az0 0 1e-05
Mazreset0 verror reset n_az0 0 syn W=1000u L=1u
Rinit0_0hi reset n_init0_0 432.769872397
Rinit0_0lo n_init0_0 0 567.230127603
Cw0_0 n_w0_0 0 5e-06
Mreset0_0 n_init0_0 reset n_w0_0 0 syn W=1000u L=1u
Mpos0_0 n_hv0 n_w0_0 n_op0 0 syn W=4u L=1u
Mneg0_0 n_hv0 vweight n_on0 0 syn W=4u L=1u
Menable0_0 n_enable0_0 learn 0 0 nch W=1000u L=1u
Mutail0_0 n_utail0_0 n_hv0 n_enable0_0 0 nch W=20u L=1u
Mu1_0_0 n_up0_0 n_az0 n_utail0_0 0 nch W=20u L=1u
Mu2_0_0 n_w0_0 n_error0 n_utail0_0 0 nch W=20u L=1u
Mu3_0_0 n_up0_0 n_up0_0 vdd vdd pch W=60u L=1u
Mu4_0_0 n_w0_0 n_up0_0 vdd vdd pch W=60u L=1u
Rinit0_1hi reset n_init0_1 375.968523428
Rinit0_1lo n_init0_1 0 624.031476572
Cw0_1 n_w0_1 0 5e-06
Mreset0_1 n_init0_1 reset n_w0_1 0 syn W=1000u L=1u
Mpos0_1 n_hv1 n_w0_1 n_op0 0 syn W=4u L=1u
Mneg0_1 n_hv1 vweight n_on0 0 syn W=4u L=1u
Menable0_1 n_enable0_1 learn 0 0 nch W=1000u L=1u
Mutail0_1 n_utail0_1 n_hv1 n_enable0_1 0 nch W=20u L=1u
Mu1_0_1 n_up0_1 n_az0 n_utail0_1 0 nch W=20u L=1u
Mu2_0_1 n_w0_1 n_error0 n_utail0_1 0 nch W=20u L=1u
Mu3_0_1 n_up0_1 n_up0_1 vdd vdd pch W=60u L=1u
Mu4_0_1 n_w0_1 n_up0_1 vdd vdd pch W=60u L=1u
Rinit0_2hi reset n_init0_2 433.137177645
Rinit0_2lo n_init0_2 0 566.862822355
Cw0_2 n_w0_2 0 5e-06
Mreset0_2 n_init0_2 reset n_w0_2 0 syn W=1000u L=1u
Mpos0_2 n_hv2 n_w0_2 n_op0 0 syn W=4u L=1u
Mneg0_2 n_hv2 vweight n_on0 0 syn W=4u L=1u
Menable0_2 n_enable0_2 learn 0 0 nch W=1000u L=1u
Mutail0_2 n_utail0_2 n_hv2 n_enable0_2 0 nch W=20u L=1u
Mu1_0_2 n_up0_2 n_az0 n_utail0_2 0 nch W=20u L=1u
Mu2_0_2 n_w0_2 n_error0 n_utail0_2 0 nch W=20u L=1u
Mu3_0_2 n_up0_2 n_up0_2 vdd vdd pch W=60u L=1u
Mu4_0_2 n_w0_2 n_up0_2 vdd vdd pch W=60u L=1u
Rinit0_3hi reset n_init0_3 437.264534319
Rinit0_3lo n_init0_3 0 562.735465681
Cw0_3 n_w0_3 0 5e-06
Mreset0_3 n_init0_3 reset n_w0_3 0 syn W=1000u L=1u
Mpos0_3 n_hv3 n_w0_3 n_op0 0 syn W=4u L=1u
Mneg0_3 n_hv3 vweight n_on0 0 syn W=4u L=1u
Menable0_3 n_enable0_3 learn 0 0 nch W=1000u L=1u
Mutail0_3 n_utail0_3 n_hv3 n_enable0_3 0 nch W=20u L=1u
Mu1_0_3 n_up0_3 n_az0 n_utail0_3 0 nch W=20u L=1u
Mu2_0_3 n_w0_3 n_error0 n_utail0_3 0 nch W=20u L=1u
Mu3_0_3 n_up0_3 n_up0_3 vdd vdd pch W=60u L=1u
Mu4_0_3 n_w0_3 n_up0_3 vdd vdd pch W=60u L=1u
Rinit0_4hi reset n_init0_4 409.261103834
Rinit0_4lo n_init0_4 0 590.738896166
Cw0_4 n_w0_4 0 5e-06
Mreset0_4 n_init0_4 reset n_w0_4 0 syn W=1000u L=1u
Mpos0_4 n_hv4 n_w0_4 n_op0 0 syn W=4u L=1u
Mneg0_4 n_hv4 vweight n_on0 0 syn W=4u L=1u
Menable0_4 n_enable0_4 learn 0 0 nch W=1000u L=1u
Mutail0_4 n_utail0_4 n_hv4 n_enable0_4 0 nch W=20u L=1u
Mu1_0_4 n_up0_4 n_az0 n_utail0_4 0 nch W=20u L=1u
Mu2_0_4 n_w0_4 n_error0 n_utail0_4 0 nch W=20u L=1u
Mu3_0_4 n_up0_4 n_up0_4 vdd vdd pch W=60u L=1u
Mu4_0_4 n_w0_4 n_up0_4 vdd vdd pch W=60u L=1u
Rinit0_5hi reset n_init0_5 381.391506039
Rinit0_5lo n_init0_5 0 618.608493961
Cw0_5 n_w0_5 0 5e-06
Mreset0_5 n_init0_5 reset n_w0_5 0 syn W=1000u L=1u
Mpos0_5 n_hv5 n_w0_5 n_op0 0 syn W=4u L=1u
Mneg0_5 n_hv5 vweight n_on0 0 syn W=4u L=1u
Menable0_5 n_enable0_5 learn 0 0 nch W=1000u L=1u
Mutail0_5 n_utail0_5 n_hv5 n_enable0_5 0 nch W=20u L=1u
Mu1_0_5 n_up0_5 n_az0 n_utail0_5 0 nch W=20u L=1u
Mu2_0_5 n_w0_5 n_error0 n_utail0_5 0 nch W=20u L=1u
Mu3_0_5 n_up0_5 n_up0_5 vdd vdd pch W=60u L=1u
Mu4_0_5 n_w0_5 n_up0_5 vdd vdd pch W=60u L=1u
Rinit0_6hi reset n_init0_6 414.943464556
Rinit0_6lo n_init0_6 0 585.056535444
Cw0_6 n_w0_6 0 5e-06
Mreset0_6 n_init0_6 reset n_w0_6 0 syn W=1000u L=1u
Mpos0_6 n_hv6 n_w0_6 n_op0 0 syn W=4u L=1u
Mneg0_6 n_hv6 vweight n_on0 0 syn W=4u L=1u
Menable0_6 n_enable0_6 learn 0 0 nch W=1000u L=1u
Mutail0_6 n_utail0_6 n_hv6 n_enable0_6 0 nch W=20u L=1u
Mu1_0_6 n_up0_6 n_az0 n_utail0_6 0 nch W=20u L=1u
Mu2_0_6 n_w0_6 n_error0 n_utail0_6 0 nch W=20u L=1u
Mu3_0_6 n_up0_6 n_up0_6 vdd vdd pch W=60u L=1u
Mu4_0_6 n_w0_6 n_up0_6 vdd vdd pch W=60u L=1u
Rinit0_7hi reset n_init0_7 429.599608028
Rinit0_7lo n_init0_7 0 570.400391972
Cw0_7 n_w0_7 0 5e-06
Mreset0_7 n_init0_7 reset n_w0_7 0 syn W=1000u L=1u
Mpos0_7 n_hv7 n_w0_7 n_op0 0 syn W=4u L=1u
Mneg0_7 n_hv7 vweight n_on0 0 syn W=4u L=1u
Menable0_7 n_enable0_7 learn 0 0 nch W=1000u L=1u
Mutail0_7 n_utail0_7 n_hv7 n_enable0_7 0 nch W=20u L=1u
Mu1_0_7 n_up0_7 n_az0 n_utail0_7 0 nch W=20u L=1u
Mu2_0_7 n_w0_7 n_error0 n_utail0_7 0 nch W=20u L=1u
Mu3_0_7 n_up0_7 n_up0_7 vdd vdd pch W=60u L=1u
Mu4_0_7 n_w0_7 n_up0_7 vdd vdd pch W=60u L=1u
Rinit0_8hi reset n_init0_8 376.434222233
Rinit0_8lo n_init0_8 0 623.565777767
Cw0_8 n_w0_8 0 5e-06
Mreset0_8 n_init0_8 reset n_w0_8 0 syn W=1000u L=1u
Mpos0_8 n_hv8 n_w0_8 n_op0 0 syn W=4u L=1u
Mneg0_8 n_hv8 vweight n_on0 0 syn W=4u L=1u
Menable0_8 n_enable0_8 learn 0 0 nch W=1000u L=1u
Mutail0_8 n_utail0_8 n_hv8 n_enable0_8 0 nch W=20u L=1u
Mu1_0_8 n_up0_8 n_az0 n_utail0_8 0 nch W=20u L=1u
Mu2_0_8 n_w0_8 n_error0 n_utail0_8 0 nch W=20u L=1u
Mu3_0_8 n_up0_8 n_up0_8 vdd vdd pch W=60u L=1u
Mu4_0_8 n_w0_8 n_up0_8 vdd vdd pch W=60u L=1u
Rinit0_9hi reset n_init0_9 375.446449448
Rinit0_9lo n_init0_9 0 624.553550552
Cw0_9 n_w0_9 0 5e-06
Mreset0_9 n_init0_9 reset n_w0_9 0 syn W=1000u L=1u
Mpos0_9 n_hv9 n_w0_9 n_op0 0 syn W=4u L=1u
Mneg0_9 n_hv9 vweight n_on0 0 syn W=4u L=1u
Menable0_9 n_enable0_9 learn 0 0 nch W=1000u L=1u
Mutail0_9 n_utail0_9 n_hv9 n_enable0_9 0 nch W=20u L=1u
Mu1_0_9 n_up0_9 n_az0 n_utail0_9 0 nch W=20u L=1u
Mu2_0_9 n_w0_9 n_error0 n_utail0_9 0 nch W=20u L=1u
Mu3_0_9 n_up0_9 n_up0_9 vdd vdd pch W=60u L=1u
Mu4_0_9 n_w0_9 n_up0_9 vdd vdd pch W=60u L=1u
Rinit0_10hi reset n_init0_10 371.531216098
Rinit0_10lo n_init0_10 0 628.468783902
Cw0_10 n_w0_10 0 5e-06
Mreset0_10 n_init0_10 reset n_w0_10 0 syn W=1000u L=1u
Mpos0_10 n_hv10 n_w0_10 n_op0 0 syn W=4u L=1u
Mneg0_10 n_hv10 vweight n_on0 0 syn W=4u L=1u
Menable0_10 n_enable0_10 learn 0 0 nch W=1000u L=1u
Mutail0_10 n_utail0_10 n_hv10 n_enable0_10 0 nch W=20u L=1u
Mu1_0_10 n_up0_10 n_az0 n_utail0_10 0 nch W=20u L=1u
Mu2_0_10 n_w0_10 n_error0 n_utail0_10 0 nch W=20u L=1u
Mu3_0_10 n_up0_10 n_up0_10 vdd vdd pch W=60u L=1u
Mu4_0_10 n_w0_10 n_up0_10 vdd vdd pch W=60u L=1u
Rinit0_11hi reset n_init0_11 415.700442139
Rinit0_11lo n_init0_11 0 584.299557861
Cw0_11 n_w0_11 0 5e-06
Mreset0_11 n_init0_11 reset n_w0_11 0 syn W=1000u L=1u
Mpos0_11 n_hv11 n_w0_11 n_op0 0 syn W=4u L=1u
Mneg0_11 n_hv11 vweight n_on0 0 syn W=4u L=1u
Menable0_11 n_enable0_11 learn 0 0 nch W=1000u L=1u
Mutail0_11 n_utail0_11 n_hv11 n_enable0_11 0 nch W=20u L=1u
Mu1_0_11 n_up0_11 n_az0 n_utail0_11 0 nch W=20u L=1u
Mu2_0_11 n_w0_11 n_error0 n_utail0_11 0 nch W=20u L=1u
Mu3_0_11 n_up0_11 n_up0_11 vdd vdd pch W=60u L=1u
Mu4_0_11 n_w0_11 n_up0_11 vdd vdd pch W=60u L=1u
Rinit0_12hi reset n_init0_12 406.013571118
Rinit0_12lo n_init0_12 0 593.986428882
Cw0_12 n_w0_12 0 5e-06
Mreset0_12 n_init0_12 reset n_w0_12 0 syn W=1000u L=1u
Mpos0_12 n_hv12 n_w0_12 n_op0 0 syn W=4u L=1u
Mneg0_12 n_hv12 vweight n_on0 0 syn W=4u L=1u
Menable0_12 n_enable0_12 learn 0 0 nch W=1000u L=1u
Mutail0_12 n_utail0_12 n_hv12 n_enable0_12 0 nch W=20u L=1u
Mu1_0_12 n_up0_12 n_az0 n_utail0_12 0 nch W=20u L=1u
Mu2_0_12 n_w0_12 n_error0 n_utail0_12 0 nch W=20u L=1u
Mu3_0_12 n_up0_12 n_up0_12 vdd vdd pch W=60u L=1u
Mu4_0_12 n_w0_12 n_up0_12 vdd vdd pch W=60u L=1u
Rinit0_13hi reset n_init0_13 420.36880046
Rinit0_13lo n_init0_13 0 579.63119954
Cw0_13 n_w0_13 0 5e-06
Mreset0_13 n_init0_13 reset n_w0_13 0 syn W=1000u L=1u
Mpos0_13 n_hv13 n_w0_13 n_op0 0 syn W=4u L=1u
Mneg0_13 n_hv13 vweight n_on0 0 syn W=4u L=1u
Menable0_13 n_enable0_13 learn 0 0 nch W=1000u L=1u
Mutail0_13 n_utail0_13 n_hv13 n_enable0_13 0 nch W=20u L=1u
Mu1_0_13 n_up0_13 n_az0 n_utail0_13 0 nch W=20u L=1u
Mu2_0_13 n_w0_13 n_error0 n_utail0_13 0 nch W=20u L=1u
Mu3_0_13 n_up0_13 n_up0_13 vdd vdd pch W=60u L=1u
Mu4_0_13 n_w0_13 n_up0_13 vdd vdd pch W=60u L=1u
Rinit0_14hi reset n_init0_14 395.425800559
Rinit0_14lo n_init0_14 0 604.574199441
Cw0_14 n_w0_14 0 5e-06
Mreset0_14 n_init0_14 reset n_w0_14 0 syn W=1000u L=1u
Mpos0_14 n_hv14 n_w0_14 n_op0 0 syn W=4u L=1u
Mneg0_14 n_hv14 vweight n_on0 0 syn W=4u L=1u
Menable0_14 n_enable0_14 learn 0 0 nch W=1000u L=1u
Mutail0_14 n_utail0_14 n_hv14 n_enable0_14 0 nch W=20u L=1u
Mu1_0_14 n_up0_14 n_az0 n_utail0_14 0 nch W=20u L=1u
Mu2_0_14 n_w0_14 n_error0 n_utail0_14 0 nch W=20u L=1u
Mu3_0_14 n_up0_14 n_up0_14 vdd vdd pch W=60u L=1u
Mu4_0_14 n_w0_14 n_up0_14 vdd vdd pch W=60u L=1u
Rinit0_15hi reset n_init0_15 413.591426657
Rinit0_15lo n_init0_15 0 586.408573343
Cw0_15 n_w0_15 0 5e-06
Mreset0_15 n_init0_15 reset n_w0_15 0 syn W=1000u L=1u
Mpos0_15 n_hv15 n_w0_15 n_op0 0 syn W=4u L=1u
Mneg0_15 n_hv15 vweight n_on0 0 syn W=4u L=1u
Menable0_15 n_enable0_15 learn 0 0 nch W=1000u L=1u
Mutail0_15 n_utail0_15 n_hv15 n_enable0_15 0 nch W=20u L=1u
Mu1_0_15 n_up0_15 n_az0 n_utail0_15 0 nch W=20u L=1u
Mu2_0_15 n_w0_15 n_error0 n_utail0_15 0 nch W=20u L=1u
Mu3_0_15 n_up0_15 n_up0_15 vdd vdd pch W=60u L=1u
Mu4_0_15 n_w0_15 n_up0_15 vdd vdd pch W=60u L=1u
Rinit0_16hi reset n_init0_16 412.906933123
Rinit0_16lo n_init0_16 0 587.093066877
Cw0_16 n_w0_16 0 5e-06
Mreset0_16 n_init0_16 reset n_w0_16 0 syn W=1000u L=1u
Mpos0_16 n_hv16 n_w0_16 n_op0 0 syn W=4u L=1u
Mneg0_16 n_hv16 vweight n_on0 0 syn W=4u L=1u
Menable0_16 n_enable0_16 learn 0 0 nch W=1000u L=1u
Mutail0_16 n_utail0_16 n_hv16 n_enable0_16 0 nch W=20u L=1u
Mu1_0_16 n_up0_16 n_az0 n_utail0_16 0 nch W=20u L=1u
Mu2_0_16 n_w0_16 n_error0 n_utail0_16 0 nch W=20u L=1u
Mu3_0_16 n_up0_16 n_up0_16 vdd vdd pch W=60u L=1u
Mu4_0_16 n_w0_16 n_up0_16 vdd vdd pch W=60u L=1u
Rinit0_17hi reset n_init0_17 377.310286527
Rinit0_17lo n_init0_17 0 622.689713473
Cw0_17 n_w0_17 0 5e-06
Mreset0_17 n_init0_17 reset n_w0_17 0 syn W=1000u L=1u
Mpos0_17 n_hv17 n_w0_17 n_op0 0 syn W=4u L=1u
Mneg0_17 n_hv17 vweight n_on0 0 syn W=4u L=1u
Menable0_17 n_enable0_17 learn 0 0 nch W=1000u L=1u
Mutail0_17 n_utail0_17 n_hv17 n_enable0_17 0 nch W=20u L=1u
Mu1_0_17 n_up0_17 n_az0 n_utail0_17 0 nch W=20u L=1u
Mu2_0_17 n_w0_17 n_error0 n_utail0_17 0 nch W=20u L=1u
Mu3_0_17 n_up0_17 n_up0_17 vdd vdd pch W=60u L=1u
Mu4_0_17 n_w0_17 n_up0_17 vdd vdd pch W=60u L=1u
Rinit0_18hi reset n_init0_18 363.496307197
Rinit0_18lo n_init0_18 0 636.503692803
Cw0_18 n_w0_18 0 5e-06
Mreset0_18 n_init0_18 reset n_w0_18 0 syn W=1000u L=1u
Mpos0_18 n_hv18 n_w0_18 n_op0 0 syn W=4u L=1u
Mneg0_18 n_hv18 vweight n_on0 0 syn W=4u L=1u
Menable0_18 n_enable0_18 learn 0 0 nch W=1000u L=1u
Mutail0_18 n_utail0_18 n_hv18 n_enable0_18 0 nch W=20u L=1u
Mu1_0_18 n_up0_18 n_az0 n_utail0_18 0 nch W=20u L=1u
Mu2_0_18 n_w0_18 n_error0 n_utail0_18 0 nch W=20u L=1u
Mu3_0_18 n_up0_18 n_up0_18 vdd vdd pch W=60u L=1u
Mu4_0_18 n_w0_18 n_up0_18 vdd vdd pch W=60u L=1u
Rinit0_19hi reset n_init0_19 393.268774461
Rinit0_19lo n_init0_19 0 606.731225539
Cw0_19 n_w0_19 0 5e-06
Mreset0_19 n_init0_19 reset n_w0_19 0 syn W=1000u L=1u
Mpos0_19 n_hv19 n_w0_19 n_op0 0 syn W=4u L=1u
Mneg0_19 n_hv19 vweight n_on0 0 syn W=4u L=1u
Menable0_19 n_enable0_19 learn 0 0 nch W=1000u L=1u
Mutail0_19 n_utail0_19 n_hv19 n_enable0_19 0 nch W=20u L=1u
Mu1_0_19 n_up0_19 n_az0 n_utail0_19 0 nch W=20u L=1u
Mu2_0_19 n_w0_19 n_error0 n_utail0_19 0 nch W=20u L=1u
Mu3_0_19 n_up0_19 n_up0_19 vdd vdd pch W=60u L=1u
Mu4_0_19 n_w0_19 n_up0_19 vdd vdd pch W=60u L=1u
Rinit0_20hi reset n_init0_20 431.62496559
Rinit0_20lo n_init0_20 0 568.37503441
Cw0_20 n_w0_20 0 5e-06
Mreset0_20 n_init0_20 reset n_w0_20 0 syn W=1000u L=1u
Mpos0_20 n_hv20 n_w0_20 n_op0 0 syn W=4u L=1u
Mneg0_20 n_hv20 vweight n_on0 0 syn W=4u L=1u
Menable0_20 n_enable0_20 learn 0 0 nch W=1000u L=1u
Mutail0_20 n_utail0_20 n_hv20 n_enable0_20 0 nch W=20u L=1u
Mu1_0_20 n_up0_20 n_az0 n_utail0_20 0 nch W=20u L=1u
Mu2_0_20 n_w0_20 n_error0 n_utail0_20 0 nch W=20u L=1u
Mu3_0_20 n_up0_20 n_up0_20 vdd vdd pch W=60u L=1u
Mu4_0_20 n_w0_20 n_up0_20 vdd vdd pch W=60u L=1u
Rinit0_21hi reset n_init0_21 387.794005385
Rinit0_21lo n_init0_21 0 612.205994615
Cw0_21 n_w0_21 0 5e-06
Mreset0_21 n_init0_21 reset n_w0_21 0 syn W=1000u L=1u
Mpos0_21 n_hv21 n_w0_21 n_op0 0 syn W=4u L=1u
Mneg0_21 n_hv21 vweight n_on0 0 syn W=4u L=1u
Menable0_21 n_enable0_21 learn 0 0 nch W=1000u L=1u
Mutail0_21 n_utail0_21 n_hv21 n_enable0_21 0 nch W=20u L=1u
Mu1_0_21 n_up0_21 n_az0 n_utail0_21 0 nch W=20u L=1u
Mu2_0_21 n_w0_21 n_error0 n_utail0_21 0 nch W=20u L=1u
Mu3_0_21 n_up0_21 n_up0_21 vdd vdd pch W=60u L=1u
Mu4_0_21 n_w0_21 n_up0_21 vdd vdd pch W=60u L=1u
Rinit0_22hi reset n_init0_22 404.111062572
Rinit0_22lo n_init0_22 0 595.888937428
Cw0_22 n_w0_22 0 5e-06
Mreset0_22 n_init0_22 reset n_w0_22 0 syn W=1000u L=1u
Mpos0_22 n_hv22 n_w0_22 n_op0 0 syn W=4u L=1u
Mneg0_22 n_hv22 vweight n_on0 0 syn W=4u L=1u
Menable0_22 n_enable0_22 learn 0 0 nch W=1000u L=1u
Mutail0_22 n_utail0_22 n_hv22 n_enable0_22 0 nch W=20u L=1u
Mu1_0_22 n_up0_22 n_az0 n_utail0_22 0 nch W=20u L=1u
Mu2_0_22 n_w0_22 n_error0 n_utail0_22 0 nch W=20u L=1u
Mu3_0_22 n_up0_22 n_up0_22 vdd vdd pch W=60u L=1u
Mu4_0_22 n_w0_22 n_up0_22 vdd vdd pch W=60u L=1u
Rinit0_23hi reset n_init0_23 360.957555438
Rinit0_23lo n_init0_23 0 639.042444562
Cw0_23 n_w0_23 0 5e-06
Mreset0_23 n_init0_23 reset n_w0_23 0 syn W=1000u L=1u
Mpos0_23 n_hv23 n_w0_23 n_op0 0 syn W=4u L=1u
Mneg0_23 n_hv23 vweight n_on0 0 syn W=4u L=1u
Menable0_23 n_enable0_23 learn 0 0 nch W=1000u L=1u
Mutail0_23 n_utail0_23 n_hv23 n_enable0_23 0 nch W=20u L=1u
Mu1_0_23 n_up0_23 n_az0 n_utail0_23 0 nch W=20u L=1u
Mu2_0_23 n_w0_23 n_error0 n_utail0_23 0 nch W=20u L=1u
Mu3_0_23 n_up0_23 n_up0_23 vdd vdd pch W=60u L=1u
Mu4_0_23 n_w0_23 n_up0_23 vdd vdd pch W=60u L=1u
Rinit0_24hi reset n_init0_24 382.449480388
Rinit0_24lo n_init0_24 0 617.550519612
Cw0_24 n_w0_24 0 5e-06
Mreset0_24 n_init0_24 reset n_w0_24 0 syn W=1000u L=1u
Mpos0_24 n_hv24 n_w0_24 n_op0 0 syn W=4u L=1u
Mneg0_24 n_hv24 vweight n_on0 0 syn W=4u L=1u
Menable0_24 n_enable0_24 learn 0 0 nch W=1000u L=1u
Mutail0_24 n_utail0_24 n_hv24 n_enable0_24 0 nch W=20u L=1u
Mu1_0_24 n_up0_24 n_az0 n_utail0_24 0 nch W=20u L=1u
Mu2_0_24 n_w0_24 n_error0 n_utail0_24 0 nch W=20u L=1u
Mu3_0_24 n_up0_24 n_up0_24 vdd vdd pch W=60u L=1u
Mu4_0_24 n_w0_24 n_up0_24 vdd vdd pch W=60u L=1u
Rinit0_25hi reset n_init0_25 373.217111479
Rinit0_25lo n_init0_25 0 626.782888521
Cw0_25 n_w0_25 0 5e-06
Mreset0_25 n_init0_25 reset n_w0_25 0 syn W=1000u L=1u
Mpos0_25 n_hv25 n_w0_25 n_op0 0 syn W=4u L=1u
Mneg0_25 n_hv25 vweight n_on0 0 syn W=4u L=1u
Menable0_25 n_enable0_25 learn 0 0 nch W=1000u L=1u
Mutail0_25 n_utail0_25 n_hv25 n_enable0_25 0 nch W=20u L=1u
Mu1_0_25 n_up0_25 n_az0 n_utail0_25 0 nch W=20u L=1u
Mu2_0_25 n_w0_25 n_error0 n_utail0_25 0 nch W=20u L=1u
Mu3_0_25 n_up0_25 n_up0_25 vdd vdd pch W=60u L=1u
Mu4_0_25 n_w0_25 n_up0_25 vdd vdd pch W=60u L=1u
Rinit0_26hi reset n_init0_26 383.897099185
Rinit0_26lo n_init0_26 0 616.102900815
Cw0_26 n_w0_26 0 5e-06
Mreset0_26 n_init0_26 reset n_w0_26 0 syn W=1000u L=1u
Mpos0_26 n_hv26 n_w0_26 n_op0 0 syn W=4u L=1u
Mneg0_26 n_hv26 vweight n_on0 0 syn W=4u L=1u
Menable0_26 n_enable0_26 learn 0 0 nch W=1000u L=1u
Mutail0_26 n_utail0_26 n_hv26 n_enable0_26 0 nch W=20u L=1u
Mu1_0_26 n_up0_26 n_az0 n_utail0_26 0 nch W=20u L=1u
Mu2_0_26 n_w0_26 n_error0 n_utail0_26 0 nch W=20u L=1u
Mu3_0_26 n_up0_26 n_up0_26 vdd vdd pch W=60u L=1u
Mu4_0_26 n_w0_26 n_up0_26 vdd vdd pch W=60u L=1u
Rinit0_27hi reset n_init0_27 397.150479537
Rinit0_27lo n_init0_27 0 602.849520463
Cw0_27 n_w0_27 0 5e-06
Mreset0_27 n_init0_27 reset n_w0_27 0 syn W=1000u L=1u
Mpos0_27 n_hv27 n_w0_27 n_op0 0 syn W=4u L=1u
Mneg0_27 n_hv27 vweight n_on0 0 syn W=4u L=1u
Menable0_27 n_enable0_27 learn 0 0 nch W=1000u L=1u
Mutail0_27 n_utail0_27 n_hv27 n_enable0_27 0 nch W=20u L=1u
Mu1_0_27 n_up0_27 n_az0 n_utail0_27 0 nch W=20u L=1u
Mu2_0_27 n_w0_27 n_error0 n_utail0_27 0 nch W=20u L=1u
Mu3_0_27 n_up0_27 n_up0_27 vdd vdd pch W=60u L=1u
Mu4_0_27 n_w0_27 n_up0_27 vdd vdd pch W=60u L=1u
Rinit0_28hi reset n_init0_28 368.254528654
Rinit0_28lo n_init0_28 0 631.745471346
Cw0_28 n_w0_28 0 5e-06
Mreset0_28 n_init0_28 reset n_w0_28 0 syn W=1000u L=1u
Mpos0_28 n_hv28 n_w0_28 n_op0 0 syn W=4u L=1u
Mneg0_28 n_hv28 vweight n_on0 0 syn W=4u L=1u
Menable0_28 n_enable0_28 learn 0 0 nch W=1000u L=1u
Mutail0_28 n_utail0_28 n_hv28 n_enable0_28 0 nch W=20u L=1u
Mu1_0_28 n_up0_28 n_az0 n_utail0_28 0 nch W=20u L=1u
Mu2_0_28 n_w0_28 n_error0 n_utail0_28 0 nch W=20u L=1u
Mu3_0_28 n_up0_28 n_up0_28 vdd vdd pch W=60u L=1u
Mu4_0_28 n_w0_28 n_up0_28 vdd vdd pch W=60u L=1u
Rinit0_29hi reset n_init0_29 373.470634823
Rinit0_29lo n_init0_29 0 626.529365177
Cw0_29 n_w0_29 0 5e-06
Mreset0_29 n_init0_29 reset n_w0_29 0 syn W=1000u L=1u
Mpos0_29 n_hv29 n_w0_29 n_op0 0 syn W=4u L=1u
Mneg0_29 n_hv29 vweight n_on0 0 syn W=4u L=1u
Menable0_29 n_enable0_29 learn 0 0 nch W=1000u L=1u
Mutail0_29 n_utail0_29 n_hv29 n_enable0_29 0 nch W=20u L=1u
Mu1_0_29 n_up0_29 n_az0 n_utail0_29 0 nch W=20u L=1u
Mu2_0_29 n_w0_29 n_error0 n_utail0_29 0 nch W=20u L=1u
Mu3_0_29 n_up0_29 n_up0_29 vdd vdd pch W=60u L=1u
Mu4_0_29 n_w0_29 n_up0_29 vdd vdd pch W=60u L=1u
Rinit0_30hi reset n_init0_30 416.693928991
Rinit0_30lo n_init0_30 0 583.306071009
Cw0_30 n_w0_30 0 5e-06
Mreset0_30 n_init0_30 reset n_w0_30 0 syn W=1000u L=1u
Mpos0_30 n_hv30 n_w0_30 n_op0 0 syn W=4u L=1u
Mneg0_30 n_hv30 vweight n_on0 0 syn W=4u L=1u
Menable0_30 n_enable0_30 learn 0 0 nch W=1000u L=1u
Mutail0_30 n_utail0_30 n_hv30 n_enable0_30 0 nch W=20u L=1u
Mu1_0_30 n_up0_30 n_az0 n_utail0_30 0 nch W=20u L=1u
Mu2_0_30 n_w0_30 n_error0 n_utail0_30 0 nch W=20u L=1u
Mu3_0_30 n_up0_30 n_up0_30 vdd vdd pch W=60u L=1u
Mu4_0_30 n_w0_30 n_up0_30 vdd vdd pch W=60u L=1u
Rinit0_31hi reset n_init0_31 427.437448382
Rinit0_31lo n_init0_31 0 572.562551618
Cw0_31 n_w0_31 0 5e-06
Mreset0_31 n_init0_31 reset n_w0_31 0 syn W=1000u L=1u
Mpos0_31 n_hv31 n_w0_31 n_op0 0 syn W=4u L=1u
Mneg0_31 n_hv31 vweight n_on0 0 syn W=4u L=1u
Menable0_31 n_enable0_31 learn 0 0 nch W=1000u L=1u
Mutail0_31 n_utail0_31 n_hv31 n_enable0_31 0 nch W=20u L=1u
Mu1_0_31 n_up0_31 n_az0 n_utail0_31 0 nch W=20u L=1u
Mu2_0_31 n_w0_31 n_error0 n_utail0_31 0 nch W=20u L=1u
Mu3_0_31 n_up0_31 n_up0_31 vdd vdd pch W=60u L=1u
Mu4_0_31 n_w0_31 n_up0_31 vdd vdd pch W=60u L=1u
Rinit0_32hi reset n_init0_32 410.371850497
Rinit0_32lo n_init0_32 0 589.628149503
Cw0_32 n_w0_32 0 5e-06
Mreset0_32 n_init0_32 reset n_w0_32 0 syn W=1000u L=1u
Mpos0_32 n_hv32 n_w0_32 n_op0 0 syn W=4u L=1u
Mneg0_32 n_hv32 vweight n_on0 0 syn W=4u L=1u
Menable0_32 n_enable0_32 learn 0 0 nch W=1000u L=1u
Mutail0_32 n_utail0_32 n_hv32 n_enable0_32 0 nch W=20u L=1u
Mu1_0_32 n_up0_32 n_az0 n_utail0_32 0 nch W=20u L=1u
Mu2_0_32 n_w0_32 n_error0 n_utail0_32 0 nch W=20u L=1u
Mu3_0_32 n_up0_32 n_up0_32 vdd vdd pch W=60u L=1u
Mu4_0_32 n_w0_32 n_up0_32 vdd vdd pch W=60u L=1u
Rinit0_33hi reset n_init0_33 398.313786194
Rinit0_33lo n_init0_33 0 601.686213806
Cw0_33 n_w0_33 0 5e-06
Mreset0_33 n_init0_33 reset n_w0_33 0 syn W=1000u L=1u
Mpos0_33 n_hv33 n_w0_33 n_op0 0 syn W=4u L=1u
Mneg0_33 n_hv33 vweight n_on0 0 syn W=4u L=1u
Menable0_33 n_enable0_33 learn 0 0 nch W=1000u L=1u
Mutail0_33 n_utail0_33 n_hv33 n_enable0_33 0 nch W=20u L=1u
Mu1_0_33 n_up0_33 n_az0 n_utail0_33 0 nch W=20u L=1u
Mu2_0_33 n_w0_33 n_error0 n_utail0_33 0 nch W=20u L=1u
Mu3_0_33 n_up0_33 n_up0_33 vdd vdd pch W=60u L=1u
Mu4_0_33 n_w0_33 n_up0_33 vdd vdd pch W=60u L=1u
Rinit0_34hi reset n_init0_34 432.209592814
Rinit0_34lo n_init0_34 0 567.790407186
Cw0_34 n_w0_34 0 5e-06
Mreset0_34 n_init0_34 reset n_w0_34 0 syn W=1000u L=1u
Mpos0_34 n_hv34 n_w0_34 n_op0 0 syn W=4u L=1u
Mneg0_34 n_hv34 vweight n_on0 0 syn W=4u L=1u
Menable0_34 n_enable0_34 learn 0 0 nch W=1000u L=1u
Mutail0_34 n_utail0_34 n_hv34 n_enable0_34 0 nch W=20u L=1u
Mu1_0_34 n_up0_34 n_az0 n_utail0_34 0 nch W=20u L=1u
Mu2_0_34 n_w0_34 n_error0 n_utail0_34 0 nch W=20u L=1u
Mu3_0_34 n_up0_34 n_up0_34 vdd vdd pch W=60u L=1u
Mu4_0_34 n_w0_34 n_up0_34 vdd vdd pch W=60u L=1u
Rinit0_35hi reset n_init0_35 412.369657084
Rinit0_35lo n_init0_35 0 587.630342916
Cw0_35 n_w0_35 0 5e-06
Mreset0_35 n_init0_35 reset n_w0_35 0 syn W=1000u L=1u
Mpos0_35 n_hv35 n_w0_35 n_op0 0 syn W=4u L=1u
Mneg0_35 n_hv35 vweight n_on0 0 syn W=4u L=1u
Menable0_35 n_enable0_35 learn 0 0 nch W=1000u L=1u
Mutail0_35 n_utail0_35 n_hv35 n_enable0_35 0 nch W=20u L=1u
Mu1_0_35 n_up0_35 n_az0 n_utail0_35 0 nch W=20u L=1u
Mu2_0_35 n_w0_35 n_error0 n_utail0_35 0 nch W=20u L=1u
Mu3_0_35 n_up0_35 n_up0_35 vdd vdd pch W=60u L=1u
Mu4_0_35 n_w0_35 n_up0_35 vdd vdd pch W=60u L=1u
Rinit0_36hi reset n_init0_36 394.007546863
Rinit0_36lo n_init0_36 0 605.992453137
Cw0_36 n_w0_36 0 5e-06
Mreset0_36 n_init0_36 reset n_w0_36 0 syn W=1000u L=1u
Mpos0_36 n_hv36 n_w0_36 n_op0 0 syn W=4u L=1u
Mneg0_36 n_hv36 vweight n_on0 0 syn W=4u L=1u
Menable0_36 n_enable0_36 learn 0 0 nch W=1000u L=1u
Mutail0_36 n_utail0_36 n_hv36 n_enable0_36 0 nch W=20u L=1u
Mu1_0_36 n_up0_36 n_az0 n_utail0_36 0 nch W=20u L=1u
Mu2_0_36 n_w0_36 n_error0 n_utail0_36 0 nch W=20u L=1u
Mu3_0_36 n_up0_36 n_up0_36 vdd vdd pch W=60u L=1u
Mu4_0_36 n_w0_36 n_up0_36 vdd vdd pch W=60u L=1u
Rinit0_37hi reset n_init0_37 436.514030516
Rinit0_37lo n_init0_37 0 563.485969484
Cw0_37 n_w0_37 0 5e-06
Mreset0_37 n_init0_37 reset n_w0_37 0 syn W=1000u L=1u
Mpos0_37 n_hv37 n_w0_37 n_op0 0 syn W=4u L=1u
Mneg0_37 n_hv37 vweight n_on0 0 syn W=4u L=1u
Menable0_37 n_enable0_37 learn 0 0 nch W=1000u L=1u
Mutail0_37 n_utail0_37 n_hv37 n_enable0_37 0 nch W=20u L=1u
Mu1_0_37 n_up0_37 n_az0 n_utail0_37 0 nch W=20u L=1u
Mu2_0_37 n_w0_37 n_error0 n_utail0_37 0 nch W=20u L=1u
Mu3_0_37 n_up0_37 n_up0_37 vdd vdd pch W=60u L=1u
Mu4_0_37 n_w0_37 n_up0_37 vdd vdd pch W=60u L=1u
Rinit0_38hi reset n_init0_38 374.804105878
Rinit0_38lo n_init0_38 0 625.195894122
Cw0_38 n_w0_38 0 5e-06
Mreset0_38 n_init0_38 reset n_w0_38 0 syn W=1000u L=1u
Mpos0_38 n_hv38 n_w0_38 n_op0 0 syn W=4u L=1u
Mneg0_38 n_hv38 vweight n_on0 0 syn W=4u L=1u
Menable0_38 n_enable0_38 learn 0 0 nch W=1000u L=1u
Mutail0_38 n_utail0_38 n_hv38 n_enable0_38 0 nch W=20u L=1u
Mu1_0_38 n_up0_38 n_az0 n_utail0_38 0 nch W=20u L=1u
Mu2_0_38 n_w0_38 n_error0 n_utail0_38 0 nch W=20u L=1u
Mu3_0_38 n_up0_38 n_up0_38 vdd vdd pch W=60u L=1u
Mu4_0_38 n_w0_38 n_up0_38 vdd vdd pch W=60u L=1u
Rinit0_39hi reset n_init0_39 387.910636345
Rinit0_39lo n_init0_39 0 612.089363655
Cw0_39 n_w0_39 0 5e-06
Mreset0_39 n_init0_39 reset n_w0_39 0 syn W=1000u L=1u
Mpos0_39 n_hv39 n_w0_39 n_op0 0 syn W=4u L=1u
Mneg0_39 n_hv39 vweight n_on0 0 syn W=4u L=1u
Menable0_39 n_enable0_39 learn 0 0 nch W=1000u L=1u
Mutail0_39 n_utail0_39 n_hv39 n_enable0_39 0 nch W=20u L=1u
Mu1_0_39 n_up0_39 n_az0 n_utail0_39 0 nch W=20u L=1u
Mu2_0_39 n_w0_39 n_error0 n_utail0_39 0 nch W=20u L=1u
Mu3_0_39 n_up0_39 n_up0_39 vdd vdd pch W=60u L=1u
Mu4_0_39 n_w0_39 n_up0_39 vdd vdd pch W=60u L=1u
Rinit0_40hi reset n_init0_40 414.907986273
Rinit0_40lo n_init0_40 0 585.092013727
Cw0_40 n_w0_40 0 5e-06
Mreset0_40 n_init0_40 reset n_w0_40 0 syn W=1000u L=1u
Mpos0_40 n_hv40 n_w0_40 n_op0 0 syn W=4u L=1u
Mneg0_40 n_hv40 vweight n_on0 0 syn W=4u L=1u
Menable0_40 n_enable0_40 learn 0 0 nch W=1000u L=1u
Mutail0_40 n_utail0_40 n_hv40 n_enable0_40 0 nch W=20u L=1u
Mu1_0_40 n_up0_40 n_az0 n_utail0_40 0 nch W=20u L=1u
Mu2_0_40 n_w0_40 n_error0 n_utail0_40 0 nch W=20u L=1u
Mu3_0_40 n_up0_40 n_up0_40 vdd vdd pch W=60u L=1u
Mu4_0_40 n_w0_40 n_up0_40 vdd vdd pch W=60u L=1u
Rinit0_41hi reset n_init0_41 416.1343215
Rinit0_41lo n_init0_41 0 583.8656785
Cw0_41 n_w0_41 0 5e-06
Mreset0_41 n_init0_41 reset n_w0_41 0 syn W=1000u L=1u
Mpos0_41 n_hv41 n_w0_41 n_op0 0 syn W=4u L=1u
Mneg0_41 n_hv41 vweight n_on0 0 syn W=4u L=1u
Menable0_41 n_enable0_41 learn 0 0 nch W=1000u L=1u
Mutail0_41 n_utail0_41 n_hv41 n_enable0_41 0 nch W=20u L=1u
Mu1_0_41 n_up0_41 n_az0 n_utail0_41 0 nch W=20u L=1u
Mu2_0_41 n_w0_41 n_error0 n_utail0_41 0 nch W=20u L=1u
Mu3_0_41 n_up0_41 n_up0_41 vdd vdd pch W=60u L=1u
Mu4_0_41 n_w0_41 n_up0_41 vdd vdd pch W=60u L=1u
Rinit0_42hi reset n_init0_42 411.790708737
Rinit0_42lo n_init0_42 0 588.209291263
Cw0_42 n_w0_42 0 5e-06
Mreset0_42 n_init0_42 reset n_w0_42 0 syn W=1000u L=1u
Mpos0_42 n_hv42 n_w0_42 n_op0 0 syn W=4u L=1u
Mneg0_42 n_hv42 vweight n_on0 0 syn W=4u L=1u
Menable0_42 n_enable0_42 learn 0 0 nch W=1000u L=1u
Mutail0_42 n_utail0_42 n_hv42 n_enable0_42 0 nch W=20u L=1u
Mu1_0_42 n_up0_42 n_az0 n_utail0_42 0 nch W=20u L=1u
Mu2_0_42 n_w0_42 n_error0 n_utail0_42 0 nch W=20u L=1u
Mu3_0_42 n_up0_42 n_up0_42 vdd vdd pch W=60u L=1u
Mu4_0_42 n_w0_42 n_up0_42 vdd vdd pch W=60u L=1u
Rinit0_43hi reset n_init0_43 413.976904304
Rinit0_43lo n_init0_43 0 586.023095696
Cw0_43 n_w0_43 0 5e-06
Mreset0_43 n_init0_43 reset n_w0_43 0 syn W=1000u L=1u
Mpos0_43 n_hv43 n_w0_43 n_op0 0 syn W=4u L=1u
Mneg0_43 n_hv43 vweight n_on0 0 syn W=4u L=1u
Menable0_43 n_enable0_43 learn 0 0 nch W=1000u L=1u
Mutail0_43 n_utail0_43 n_hv43 n_enable0_43 0 nch W=20u L=1u
Mu1_0_43 n_up0_43 n_az0 n_utail0_43 0 nch W=20u L=1u
Mu2_0_43 n_w0_43 n_error0 n_utail0_43 0 nch W=20u L=1u
Mu3_0_43 n_up0_43 n_up0_43 vdd vdd pch W=60u L=1u
Mu4_0_43 n_w0_43 n_up0_43 vdd vdd pch W=60u L=1u
Rinit0_44hi reset n_init0_44 380.118897843
Rinit0_44lo n_init0_44 0 619.881102157
Cw0_44 n_w0_44 0 5e-06
Mreset0_44 n_init0_44 reset n_w0_44 0 syn W=1000u L=1u
Mpos0_44 n_hv44 n_w0_44 n_op0 0 syn W=4u L=1u
Mneg0_44 n_hv44 vweight n_on0 0 syn W=4u L=1u
Menable0_44 n_enable0_44 learn 0 0 nch W=1000u L=1u
Mutail0_44 n_utail0_44 n_hv44 n_enable0_44 0 nch W=20u L=1u
Mu1_0_44 n_up0_44 n_az0 n_utail0_44 0 nch W=20u L=1u
Mu2_0_44 n_w0_44 n_error0 n_utail0_44 0 nch W=20u L=1u
Mu3_0_44 n_up0_44 n_up0_44 vdd vdd pch W=60u L=1u
Mu4_0_44 n_w0_44 n_up0_44 vdd vdd pch W=60u L=1u
Rinit0_45hi reset n_init0_45 399.915451402
Rinit0_45lo n_init0_45 0 600.084548598
Cw0_45 n_w0_45 0 5e-06
Mreset0_45 n_init0_45 reset n_w0_45 0 syn W=1000u L=1u
Mpos0_45 n_hv45 n_w0_45 n_op0 0 syn W=4u L=1u
Mneg0_45 n_hv45 vweight n_on0 0 syn W=4u L=1u
Menable0_45 n_enable0_45 learn 0 0 nch W=1000u L=1u
Mutail0_45 n_utail0_45 n_hv45 n_enable0_45 0 nch W=20u L=1u
Mu1_0_45 n_up0_45 n_az0 n_utail0_45 0 nch W=20u L=1u
Mu2_0_45 n_w0_45 n_error0 n_utail0_45 0 nch W=20u L=1u
Mu3_0_45 n_up0_45 n_up0_45 vdd vdd pch W=60u L=1u
Mu4_0_45 n_w0_45 n_up0_45 vdd vdd pch W=60u L=1u
Rinit0_46hi reset n_init0_46 397.909728216
Rinit0_46lo n_init0_46 0 602.090271784
Cw0_46 n_w0_46 0 5e-06
Mreset0_46 n_init0_46 reset n_w0_46 0 syn W=1000u L=1u
Mpos0_46 n_hv46 n_w0_46 n_op0 0 syn W=4u L=1u
Mneg0_46 n_hv46 vweight n_on0 0 syn W=4u L=1u
Menable0_46 n_enable0_46 learn 0 0 nch W=1000u L=1u
Mutail0_46 n_utail0_46 n_hv46 n_enable0_46 0 nch W=20u L=1u
Mu1_0_46 n_up0_46 n_az0 n_utail0_46 0 nch W=20u L=1u
Mu2_0_46 n_w0_46 n_error0 n_utail0_46 0 nch W=20u L=1u
Mu3_0_46 n_up0_46 n_up0_46 vdd vdd pch W=60u L=1u
Mu4_0_46 n_w0_46 n_up0_46 vdd vdd pch W=60u L=1u
Rinit0_47hi reset n_init0_47 428.099480082
Rinit0_47lo n_init0_47 0 571.900519918
Cw0_47 n_w0_47 0 5e-06
Mreset0_47 n_init0_47 reset n_w0_47 0 syn W=1000u L=1u
Mpos0_47 n_hv47 n_w0_47 n_op0 0 syn W=4u L=1u
Mneg0_47 n_hv47 vweight n_on0 0 syn W=4u L=1u
Menable0_47 n_enable0_47 learn 0 0 nch W=1000u L=1u
Mutail0_47 n_utail0_47 n_hv47 n_enable0_47 0 nch W=20u L=1u
Mu1_0_47 n_up0_47 n_az0 n_utail0_47 0 nch W=20u L=1u
Mu2_0_47 n_w0_47 n_error0 n_utail0_47 0 nch W=20u L=1u
Mu3_0_47 n_up0_47 n_up0_47 vdd vdd pch W=60u L=1u
Mu4_0_47 n_w0_47 n_up0_47 vdd vdd pch W=60u L=1u
Rinit0_48hi reset n_init0_48 366.846559807
Rinit0_48lo n_init0_48 0 633.153440193
Cw0_48 n_w0_48 0 5e-06
Mreset0_48 n_init0_48 reset n_w0_48 0 syn W=1000u L=1u
Mpos0_48 n_hv48 n_w0_48 n_op0 0 syn W=4u L=1u
Mneg0_48 n_hv48 vweight n_on0 0 syn W=4u L=1u
Menable0_48 n_enable0_48 learn 0 0 nch W=1000u L=1u
Mutail0_48 n_utail0_48 n_hv48 n_enable0_48 0 nch W=20u L=1u
Mu1_0_48 n_up0_48 n_az0 n_utail0_48 0 nch W=20u L=1u
Mu2_0_48 n_w0_48 n_error0 n_utail0_48 0 nch W=20u L=1u
Mu3_0_48 n_up0_48 n_up0_48 vdd vdd pch W=60u L=1u
Mu4_0_48 n_w0_48 n_up0_48 vdd vdd pch W=60u L=1u
Rinit0_49hi reset n_init0_49 413.954165706
Rinit0_49lo n_init0_49 0 586.045834294
Cw0_49 n_w0_49 0 5e-06
Mreset0_49 n_init0_49 reset n_w0_49 0 syn W=1000u L=1u
Mpos0_49 n_hv49 n_w0_49 n_op0 0 syn W=4u L=1u
Mneg0_49 n_hv49 vweight n_on0 0 syn W=4u L=1u
Menable0_49 n_enable0_49 learn 0 0 nch W=1000u L=1u
Mutail0_49 n_utail0_49 n_hv49 n_enable0_49 0 nch W=20u L=1u
Mu1_0_49 n_up0_49 n_az0 n_utail0_49 0 nch W=20u L=1u
Mu2_0_49 n_w0_49 n_error0 n_utail0_49 0 nch W=20u L=1u
Mu3_0_49 n_up0_49 n_up0_49 vdd vdd pch W=60u L=1u
Mu4_0_49 n_w0_49 n_up0_49 vdd vdd pch W=60u L=1u
Rinit0_50hi reset n_init0_50 413.794843809
Rinit0_50lo n_init0_50 0 586.205156191
Cw0_50 n_w0_50 0 5e-06
Mreset0_50 n_init0_50 reset n_w0_50 0 syn W=1000u L=1u
Mpos0_50 n_hv50 n_w0_50 n_op0 0 syn W=4u L=1u
Mneg0_50 n_hv50 vweight n_on0 0 syn W=4u L=1u
Menable0_50 n_enable0_50 learn 0 0 nch W=1000u L=1u
Mutail0_50 n_utail0_50 n_hv50 n_enable0_50 0 nch W=20u L=1u
Mu1_0_50 n_up0_50 n_az0 n_utail0_50 0 nch W=20u L=1u
Mu2_0_50 n_w0_50 n_error0 n_utail0_50 0 nch W=20u L=1u
Mu3_0_50 n_up0_50 n_up0_50 vdd vdd pch W=60u L=1u
Mu4_0_50 n_w0_50 n_up0_50 vdd vdd pch W=60u L=1u
Rinit0_51hi reset n_init0_51 434.492308824
Rinit0_51lo n_init0_51 0 565.507691176
Cw0_51 n_w0_51 0 5e-06
Mreset0_51 n_init0_51 reset n_w0_51 0 syn W=1000u L=1u
Mpos0_51 n_hv51 n_w0_51 n_op0 0 syn W=4u L=1u
Mneg0_51 n_hv51 vweight n_on0 0 syn W=4u L=1u
Menable0_51 n_enable0_51 learn 0 0 nch W=1000u L=1u
Mutail0_51 n_utail0_51 n_hv51 n_enable0_51 0 nch W=20u L=1u
Mu1_0_51 n_up0_51 n_az0 n_utail0_51 0 nch W=20u L=1u
Mu2_0_51 n_w0_51 n_error0 n_utail0_51 0 nch W=20u L=1u
Mu3_0_51 n_up0_51 n_up0_51 vdd vdd pch W=60u L=1u
Mu4_0_51 n_w0_51 n_up0_51 vdd vdd pch W=60u L=1u
Rinit0_52hi reset n_init0_52 361.64707346
Rinit0_52lo n_init0_52 0 638.35292654
Cw0_52 n_w0_52 0 5e-06
Mreset0_52 n_init0_52 reset n_w0_52 0 syn W=1000u L=1u
Mpos0_52 n_hv52 n_w0_52 n_op0 0 syn W=4u L=1u
Mneg0_52 n_hv52 vweight n_on0 0 syn W=4u L=1u
Menable0_52 n_enable0_52 learn 0 0 nch W=1000u L=1u
Mutail0_52 n_utail0_52 n_hv52 n_enable0_52 0 nch W=20u L=1u
Mu1_0_52 n_up0_52 n_az0 n_utail0_52 0 nch W=20u L=1u
Mu2_0_52 n_w0_52 n_error0 n_utail0_52 0 nch W=20u L=1u
Mu3_0_52 n_up0_52 n_up0_52 vdd vdd pch W=60u L=1u
Mu4_0_52 n_w0_52 n_up0_52 vdd vdd pch W=60u L=1u
Rinit0_53hi reset n_init0_53 401.624172655
Rinit0_53lo n_init0_53 0 598.375827345
Cw0_53 n_w0_53 0 5e-06
Mreset0_53 n_init0_53 reset n_w0_53 0 syn W=1000u L=1u
Mpos0_53 n_hv53 n_w0_53 n_op0 0 syn W=4u L=1u
Mneg0_53 n_hv53 vweight n_on0 0 syn W=4u L=1u
Menable0_53 n_enable0_53 learn 0 0 nch W=1000u L=1u
Mutail0_53 n_utail0_53 n_hv53 n_enable0_53 0 nch W=20u L=1u
Mu1_0_53 n_up0_53 n_az0 n_utail0_53 0 nch W=20u L=1u
Mu2_0_53 n_w0_53 n_error0 n_utail0_53 0 nch W=20u L=1u
Mu3_0_53 n_up0_53 n_up0_53 vdd vdd pch W=60u L=1u
Mu4_0_53 n_w0_53 n_up0_53 vdd vdd pch W=60u L=1u
Rinit0_54hi reset n_init0_54 366.969221017
Rinit0_54lo n_init0_54 0 633.030778983
Cw0_54 n_w0_54 0 5e-06
Mreset0_54 n_init0_54 reset n_w0_54 0 syn W=1000u L=1u
Mpos0_54 n_hv54 n_w0_54 n_op0 0 syn W=4u L=1u
Mneg0_54 n_hv54 vweight n_on0 0 syn W=4u L=1u
Menable0_54 n_enable0_54 learn 0 0 nch W=1000u L=1u
Mutail0_54 n_utail0_54 n_hv54 n_enable0_54 0 nch W=20u L=1u
Mu1_0_54 n_up0_54 n_az0 n_utail0_54 0 nch W=20u L=1u
Mu2_0_54 n_w0_54 n_error0 n_utail0_54 0 nch W=20u L=1u
Mu3_0_54 n_up0_54 n_up0_54 vdd vdd pch W=60u L=1u
Mu4_0_54 n_w0_54 n_up0_54 vdd vdd pch W=60u L=1u
Rinit0_55hi reset n_init0_55 365.7906206
Rinit0_55lo n_init0_55 0 634.2093794
Cw0_55 n_w0_55 0 5e-06
Mreset0_55 n_init0_55 reset n_w0_55 0 syn W=1000u L=1u
Mpos0_55 n_hv55 n_w0_55 n_op0 0 syn W=4u L=1u
Mneg0_55 n_hv55 vweight n_on0 0 syn W=4u L=1u
Menable0_55 n_enable0_55 learn 0 0 nch W=1000u L=1u
Mutail0_55 n_utail0_55 n_hv55 n_enable0_55 0 nch W=20u L=1u
Mu1_0_55 n_up0_55 n_az0 n_utail0_55 0 nch W=20u L=1u
Mu2_0_55 n_w0_55 n_error0 n_utail0_55 0 nch W=20u L=1u
Mu3_0_55 n_up0_55 n_up0_55 vdd vdd pch W=60u L=1u
Mu4_0_55 n_w0_55 n_up0_55 vdd vdd pch W=60u L=1u
Rinit0_56hi reset n_init0_56 362.419828546
Rinit0_56lo n_init0_56 0 637.580171454
Cw0_56 n_w0_56 0 5e-06
Mreset0_56 n_init0_56 reset n_w0_56 0 syn W=1000u L=1u
Mpos0_56 n_hv56 n_w0_56 n_op0 0 syn W=4u L=1u
Mneg0_56 n_hv56 vweight n_on0 0 syn W=4u L=1u
Menable0_56 n_enable0_56 learn 0 0 nch W=1000u L=1u
Mutail0_56 n_utail0_56 n_hv56 n_enable0_56 0 nch W=20u L=1u
Mu1_0_56 n_up0_56 n_az0 n_utail0_56 0 nch W=20u L=1u
Mu2_0_56 n_w0_56 n_error0 n_utail0_56 0 nch W=20u L=1u
Mu3_0_56 n_up0_56 n_up0_56 vdd vdd pch W=60u L=1u
Mu4_0_56 n_w0_56 n_up0_56 vdd vdd pch W=60u L=1u
Rinit0_57hi reset n_init0_57 374.749656981
Rinit0_57lo n_init0_57 0 625.250343019
Cw0_57 n_w0_57 0 5e-06
Mreset0_57 n_init0_57 reset n_w0_57 0 syn W=1000u L=1u
Mpos0_57 n_hv57 n_w0_57 n_op0 0 syn W=4u L=1u
Mneg0_57 n_hv57 vweight n_on0 0 syn W=4u L=1u
Menable0_57 n_enable0_57 learn 0 0 nch W=1000u L=1u
Mutail0_57 n_utail0_57 n_hv57 n_enable0_57 0 nch W=20u L=1u
Mu1_0_57 n_up0_57 n_az0 n_utail0_57 0 nch W=20u L=1u
Mu2_0_57 n_w0_57 n_error0 n_utail0_57 0 nch W=20u L=1u
Mu3_0_57 n_up0_57 n_up0_57 vdd vdd pch W=60u L=1u
Mu4_0_57 n_w0_57 n_up0_57 vdd vdd pch W=60u L=1u
Rinit0_58hi reset n_init0_58 365.964541985
Rinit0_58lo n_init0_58 0 634.035458015
Cw0_58 n_w0_58 0 5e-06
Mreset0_58 n_init0_58 reset n_w0_58 0 syn W=1000u L=1u
Mpos0_58 n_hv58 n_w0_58 n_op0 0 syn W=4u L=1u
Mneg0_58 n_hv58 vweight n_on0 0 syn W=4u L=1u
Menable0_58 n_enable0_58 learn 0 0 nch W=1000u L=1u
Mutail0_58 n_utail0_58 n_hv58 n_enable0_58 0 nch W=20u L=1u
Mu1_0_58 n_up0_58 n_az0 n_utail0_58 0 nch W=20u L=1u
Mu2_0_58 n_w0_58 n_error0 n_utail0_58 0 nch W=20u L=1u
Mu3_0_58 n_up0_58 n_up0_58 vdd vdd pch W=60u L=1u
Mu4_0_58 n_w0_58 n_up0_58 vdd vdd pch W=60u L=1u
Rinit0_59hi reset n_init0_59 366.216854108
Rinit0_59lo n_init0_59 0 633.783145892
Cw0_59 n_w0_59 0 5e-06
Mreset0_59 n_init0_59 reset n_w0_59 0 syn W=1000u L=1u
Mpos0_59 n_hv59 n_w0_59 n_op0 0 syn W=4u L=1u
Mneg0_59 n_hv59 vweight n_on0 0 syn W=4u L=1u
Menable0_59 n_enable0_59 learn 0 0 nch W=1000u L=1u
Mutail0_59 n_utail0_59 n_hv59 n_enable0_59 0 nch W=20u L=1u
Mu1_0_59 n_up0_59 n_az0 n_utail0_59 0 nch W=20u L=1u
Mu2_0_59 n_w0_59 n_error0 n_utail0_59 0 nch W=20u L=1u
Mu3_0_59 n_up0_59 n_up0_59 vdd vdd pch W=60u L=1u
Mu4_0_59 n_w0_59 n_up0_59 vdd vdd pch W=60u L=1u
Rinit0_60hi reset n_init0_60 375.890585747
Rinit0_60lo n_init0_60 0 624.109414253
Cw0_60 n_w0_60 0 5e-06
Mreset0_60 n_init0_60 reset n_w0_60 0 syn W=1000u L=1u
Mpos0_60 n_hv60 n_w0_60 n_op0 0 syn W=4u L=1u
Mneg0_60 n_hv60 vweight n_on0 0 syn W=4u L=1u
Menable0_60 n_enable0_60 learn 0 0 nch W=1000u L=1u
Mutail0_60 n_utail0_60 n_hv60 n_enable0_60 0 nch W=20u L=1u
Mu1_0_60 n_up0_60 n_az0 n_utail0_60 0 nch W=20u L=1u
Mu2_0_60 n_w0_60 n_error0 n_utail0_60 0 nch W=20u L=1u
Mu3_0_60 n_up0_60 n_up0_60 vdd vdd pch W=60u L=1u
Mu4_0_60 n_w0_60 n_up0_60 vdd vdd pch W=60u L=1u
Rinit0_61hi reset n_init0_61 429.233502717
Rinit0_61lo n_init0_61 0 570.766497283
Cw0_61 n_w0_61 0 5e-06
Mreset0_61 n_init0_61 reset n_w0_61 0 syn W=1000u L=1u
Mpos0_61 n_hv61 n_w0_61 n_op0 0 syn W=4u L=1u
Mneg0_61 n_hv61 vweight n_on0 0 syn W=4u L=1u
Menable0_61 n_enable0_61 learn 0 0 nch W=1000u L=1u
Mutail0_61 n_utail0_61 n_hv61 n_enable0_61 0 nch W=20u L=1u
Mu1_0_61 n_up0_61 n_az0 n_utail0_61 0 nch W=20u L=1u
Mu2_0_61 n_w0_61 n_error0 n_utail0_61 0 nch W=20u L=1u
Mu3_0_61 n_up0_61 n_up0_61 vdd vdd pch W=60u L=1u
Mu4_0_61 n_w0_61 n_up0_61 vdd vdd pch W=60u L=1u
Rinit0_62hi reset n_init0_62 398.103062217
Rinit0_62lo n_init0_62 0 601.896937783
Cw0_62 n_w0_62 0 5e-06
Mreset0_62 n_init0_62 reset n_w0_62 0 syn W=1000u L=1u
Mpos0_62 n_hv62 n_w0_62 n_op0 0 syn W=4u L=1u
Mneg0_62 n_hv62 vweight n_on0 0 syn W=4u L=1u
Menable0_62 n_enable0_62 learn 0 0 nch W=1000u L=1u
Mutail0_62 n_utail0_62 n_hv62 n_enable0_62 0 nch W=20u L=1u
Mu1_0_62 n_up0_62 n_az0 n_utail0_62 0 nch W=20u L=1u
Mu2_0_62 n_w0_62 n_error0 n_utail0_62 0 nch W=20u L=1u
Mu3_0_62 n_up0_62 n_up0_62 vdd vdd pch W=60u L=1u
Mu4_0_62 n_w0_62 n_up0_62 vdd vdd pch W=60u L=1u
Rinit0_63hi reset n_init0_63 393.95167896
Rinit0_63lo n_init0_63 0 606.04832104
Cw0_63 n_w0_63 0 5e-06
Mreset0_63 n_init0_63 reset n_w0_63 0 syn W=1000u L=1u
Mpos0_63 n_hv63 n_w0_63 n_op0 0 syn W=4u L=1u
Mneg0_63 n_hv63 vweight n_on0 0 syn W=4u L=1u
Menable0_63 n_enable0_63 learn 0 0 nch W=1000u L=1u
Mutail0_63 n_utail0_63 n_hv63 n_enable0_63 0 nch W=20u L=1u
Mu1_0_63 n_up0_63 n_az0 n_utail0_63 0 nch W=20u L=1u
Mu2_0_63 n_w0_63 n_error0 n_utail0_63 0 nch W=20u L=1u
Mu3_0_63 n_up0_63 n_up0_63 vdd vdd pch W=60u L=1u
Mu4_0_63 n_w0_63 n_up0_63 vdd vdd pch W=60u L=1u
Rinit0_64hi reset n_init0_64 360.600197761
Rinit0_64lo n_init0_64 0 639.399802239
Cw0_64 n_w0_64 0 5e-06
Mreset0_64 n_init0_64 reset n_w0_64 0 syn W=1000u L=1u
Mpos0_64 n_hv64 n_w0_64 n_op0 0 syn W=4u L=1u
Mneg0_64 n_hv64 vweight n_on0 0 syn W=4u L=1u
Menable0_64 n_enable0_64 learn 0 0 nch W=1000u L=1u
Mutail0_64 n_utail0_64 n_hv64 n_enable0_64 0 nch W=20u L=1u
Mu1_0_64 n_up0_64 n_az0 n_utail0_64 0 nch W=20u L=1u
Mu2_0_64 n_w0_64 n_error0 n_utail0_64 0 nch W=20u L=1u
Mu3_0_64 n_up0_64 n_up0_64 vdd vdd pch W=60u L=1u
Mu4_0_64 n_w0_64 n_up0_64 vdd vdd pch W=60u L=1u
Rinit0_65hi reset n_init0_65 377.284116003
Rinit0_65lo n_init0_65 0 622.715883997
Cw0_65 n_w0_65 0 5e-06
Mreset0_65 n_init0_65 reset n_w0_65 0 syn W=1000u L=1u
Mpos0_65 n_hv65 n_w0_65 n_op0 0 syn W=4u L=1u
Mneg0_65 n_hv65 vweight n_on0 0 syn W=4u L=1u
Menable0_65 n_enable0_65 learn 0 0 nch W=1000u L=1u
Mutail0_65 n_utail0_65 n_hv65 n_enable0_65 0 nch W=20u L=1u
Mu1_0_65 n_up0_65 n_az0 n_utail0_65 0 nch W=20u L=1u
Mu2_0_65 n_w0_65 n_error0 n_utail0_65 0 nch W=20u L=1u
Mu3_0_65 n_up0_65 n_up0_65 vdd vdd pch W=60u L=1u
Mu4_0_65 n_w0_65 n_up0_65 vdd vdd pch W=60u L=1u
Rinit0_66hi reset n_init0_66 383.766702668
Rinit0_66lo n_init0_66 0 616.233297332
Cw0_66 n_w0_66 0 5e-06
Mreset0_66 n_init0_66 reset n_w0_66 0 syn W=1000u L=1u
Mpos0_66 n_hv66 n_w0_66 n_op0 0 syn W=4u L=1u
Mneg0_66 n_hv66 vweight n_on0 0 syn W=4u L=1u
Menable0_66 n_enable0_66 learn 0 0 nch W=1000u L=1u
Mutail0_66 n_utail0_66 n_hv66 n_enable0_66 0 nch W=20u L=1u
Mu1_0_66 n_up0_66 n_az0 n_utail0_66 0 nch W=20u L=1u
Mu2_0_66 n_w0_66 n_error0 n_utail0_66 0 nch W=20u L=1u
Mu3_0_66 n_up0_66 n_up0_66 vdd vdd pch W=60u L=1u
Mu4_0_66 n_w0_66 n_up0_66 vdd vdd pch W=60u L=1u
Rinit0_67hi reset n_init0_67 380.268077052
Rinit0_67lo n_init0_67 0 619.731922948
Cw0_67 n_w0_67 0 5e-06
Mreset0_67 n_init0_67 reset n_w0_67 0 syn W=1000u L=1u
Mpos0_67 n_hv67 n_w0_67 n_op0 0 syn W=4u L=1u
Mneg0_67 n_hv67 vweight n_on0 0 syn W=4u L=1u
Menable0_67 n_enable0_67 learn 0 0 nch W=1000u L=1u
Mutail0_67 n_utail0_67 n_hv67 n_enable0_67 0 nch W=20u L=1u
Mu1_0_67 n_up0_67 n_az0 n_utail0_67 0 nch W=20u L=1u
Mu2_0_67 n_w0_67 n_error0 n_utail0_67 0 nch W=20u L=1u
Mu3_0_67 n_up0_67 n_up0_67 vdd vdd pch W=60u L=1u
Mu4_0_67 n_w0_67 n_up0_67 vdd vdd pch W=60u L=1u
Rinit0_68hi reset n_init0_68 411.073778873
Rinit0_68lo n_init0_68 0 588.926221127
Cw0_68 n_w0_68 0 5e-06
Mreset0_68 n_init0_68 reset n_w0_68 0 syn W=1000u L=1u
Mpos0_68 n_hv68 n_w0_68 n_op0 0 syn W=4u L=1u
Mneg0_68 n_hv68 vweight n_on0 0 syn W=4u L=1u
Menable0_68 n_enable0_68 learn 0 0 nch W=1000u L=1u
Mutail0_68 n_utail0_68 n_hv68 n_enable0_68 0 nch W=20u L=1u
Mu1_0_68 n_up0_68 n_az0 n_utail0_68 0 nch W=20u L=1u
Mu2_0_68 n_w0_68 n_error0 n_utail0_68 0 nch W=20u L=1u
Mu3_0_68 n_up0_68 n_up0_68 vdd vdd pch W=60u L=1u
Mu4_0_68 n_w0_68 n_up0_68 vdd vdd pch W=60u L=1u
Rinit0_69hi reset n_init0_69 364.614915373
Rinit0_69lo n_init0_69 0 635.385084627
Cw0_69 n_w0_69 0 5e-06
Mreset0_69 n_init0_69 reset n_w0_69 0 syn W=1000u L=1u
Mpos0_69 n_hv69 n_w0_69 n_op0 0 syn W=4u L=1u
Mneg0_69 n_hv69 vweight n_on0 0 syn W=4u L=1u
Menable0_69 n_enable0_69 learn 0 0 nch W=1000u L=1u
Mutail0_69 n_utail0_69 n_hv69 n_enable0_69 0 nch W=20u L=1u
Mu1_0_69 n_up0_69 n_az0 n_utail0_69 0 nch W=20u L=1u
Mu2_0_69 n_w0_69 n_error0 n_utail0_69 0 nch W=20u L=1u
Mu3_0_69 n_up0_69 n_up0_69 vdd vdd pch W=60u L=1u
Mu4_0_69 n_w0_69 n_up0_69 vdd vdd pch W=60u L=1u
Rinit0_70hi reset n_init0_70 388.519928831
Rinit0_70lo n_init0_70 0 611.480071169
Cw0_70 n_w0_70 0 5e-06
Mreset0_70 n_init0_70 reset n_w0_70 0 syn W=1000u L=1u
Mpos0_70 n_hv70 n_w0_70 n_op0 0 syn W=4u L=1u
Mneg0_70 n_hv70 vweight n_on0 0 syn W=4u L=1u
Menable0_70 n_enable0_70 learn 0 0 nch W=1000u L=1u
Mutail0_70 n_utail0_70 n_hv70 n_enable0_70 0 nch W=20u L=1u
Mu1_0_70 n_up0_70 n_az0 n_utail0_70 0 nch W=20u L=1u
Mu2_0_70 n_w0_70 n_error0 n_utail0_70 0 nch W=20u L=1u
Mu3_0_70 n_up0_70 n_up0_70 vdd vdd pch W=60u L=1u
Mu4_0_70 n_w0_70 n_up0_70 vdd vdd pch W=60u L=1u
Rinit0_71hi reset n_init0_71 407.794031318
Rinit0_71lo n_init0_71 0 592.205968682
Cw0_71 n_w0_71 0 5e-06
Mreset0_71 n_init0_71 reset n_w0_71 0 syn W=1000u L=1u
Mpos0_71 n_hv71 n_w0_71 n_op0 0 syn W=4u L=1u
Mneg0_71 n_hv71 vweight n_on0 0 syn W=4u L=1u
Menable0_71 n_enable0_71 learn 0 0 nch W=1000u L=1u
Mutail0_71 n_utail0_71 n_hv71 n_enable0_71 0 nch W=20u L=1u
Mu1_0_71 n_up0_71 n_az0 n_utail0_71 0 nch W=20u L=1u
Mu2_0_71 n_w0_71 n_error0 n_utail0_71 0 nch W=20u L=1u
Mu3_0_71 n_up0_71 n_up0_71 vdd vdd pch W=60u L=1u
Mu4_0_71 n_w0_71 n_up0_71 vdd vdd pch W=60u L=1u
Rinit0_72hi reset n_init0_72 402.834273816
Rinit0_72lo n_init0_72 0 597.165726184
Cw0_72 n_w0_72 0 5e-06
Mreset0_72 n_init0_72 reset n_w0_72 0 syn W=1000u L=1u
Mpos0_72 n_hv72 n_w0_72 n_op0 0 syn W=4u L=1u
Mneg0_72 n_hv72 vweight n_on0 0 syn W=4u L=1u
Menable0_72 n_enable0_72 learn 0 0 nch W=1000u L=1u
Mutail0_72 n_utail0_72 n_hv72 n_enable0_72 0 nch W=20u L=1u
Mu1_0_72 n_up0_72 n_az0 n_utail0_72 0 nch W=20u L=1u
Mu2_0_72 n_w0_72 n_error0 n_utail0_72 0 nch W=20u L=1u
Mu3_0_72 n_up0_72 n_up0_72 vdd vdd pch W=60u L=1u
Mu4_0_72 n_w0_72 n_up0_72 vdd vdd pch W=60u L=1u
Rinit0_73hi reset n_init0_73 361.619605815
Rinit0_73lo n_init0_73 0 638.380394185
Cw0_73 n_w0_73 0 5e-06
Mreset0_73 n_init0_73 reset n_w0_73 0 syn W=1000u L=1u
Mpos0_73 n_hv73 n_w0_73 n_op0 0 syn W=4u L=1u
Mneg0_73 n_hv73 vweight n_on0 0 syn W=4u L=1u
Menable0_73 n_enable0_73 learn 0 0 nch W=1000u L=1u
Mutail0_73 n_utail0_73 n_hv73 n_enable0_73 0 nch W=20u L=1u
Mu1_0_73 n_up0_73 n_az0 n_utail0_73 0 nch W=20u L=1u
Mu2_0_73 n_w0_73 n_error0 n_utail0_73 0 nch W=20u L=1u
Mu3_0_73 n_up0_73 n_up0_73 vdd vdd pch W=60u L=1u
Mu4_0_73 n_w0_73 n_up0_73 vdd vdd pch W=60u L=1u
Rinit0_74hi reset n_init0_74 397.429728205
Rinit0_74lo n_init0_74 0 602.570271795
Cw0_74 n_w0_74 0 5e-06
Mreset0_74 n_init0_74 reset n_w0_74 0 syn W=1000u L=1u
Mpos0_74 n_hv74 n_w0_74 n_op0 0 syn W=4u L=1u
Mneg0_74 n_hv74 vweight n_on0 0 syn W=4u L=1u
Menable0_74 n_enable0_74 learn 0 0 nch W=1000u L=1u
Mutail0_74 n_utail0_74 n_hv74 n_enable0_74 0 nch W=20u L=1u
Mu1_0_74 n_up0_74 n_az0 n_utail0_74 0 nch W=20u L=1u
Mu2_0_74 n_w0_74 n_error0 n_utail0_74 0 nch W=20u L=1u
Mu3_0_74 n_up0_74 n_up0_74 vdd vdd pch W=60u L=1u
Mu4_0_74 n_w0_74 n_up0_74 vdd vdd pch W=60u L=1u
Rinit0_75hi reset n_init0_75 426.57619713
Rinit0_75lo n_init0_75 0 573.42380287
Cw0_75 n_w0_75 0 5e-06
Mreset0_75 n_init0_75 reset n_w0_75 0 syn W=1000u L=1u
Mpos0_75 n_hv75 n_w0_75 n_op0 0 syn W=4u L=1u
Mneg0_75 n_hv75 vweight n_on0 0 syn W=4u L=1u
Menable0_75 n_enable0_75 learn 0 0 nch W=1000u L=1u
Mutail0_75 n_utail0_75 n_hv75 n_enable0_75 0 nch W=20u L=1u
Mu1_0_75 n_up0_75 n_az0 n_utail0_75 0 nch W=20u L=1u
Mu2_0_75 n_w0_75 n_error0 n_utail0_75 0 nch W=20u L=1u
Mu3_0_75 n_up0_75 n_up0_75 vdd vdd pch W=60u L=1u
Mu4_0_75 n_w0_75 n_up0_75 vdd vdd pch W=60u L=1u
Rinit0_76hi reset n_init0_76 428.131600469
Rinit0_76lo n_init0_76 0 571.868399531
Cw0_76 n_w0_76 0 5e-06
Mreset0_76 n_init0_76 reset n_w0_76 0 syn W=1000u L=1u
Mpos0_76 n_hv76 n_w0_76 n_op0 0 syn W=4u L=1u
Mneg0_76 n_hv76 vweight n_on0 0 syn W=4u L=1u
Menable0_76 n_enable0_76 learn 0 0 nch W=1000u L=1u
Mutail0_76 n_utail0_76 n_hv76 n_enable0_76 0 nch W=20u L=1u
Mu1_0_76 n_up0_76 n_az0 n_utail0_76 0 nch W=20u L=1u
Mu2_0_76 n_w0_76 n_error0 n_utail0_76 0 nch W=20u L=1u
Mu3_0_76 n_up0_76 n_up0_76 vdd vdd pch W=60u L=1u
Mu4_0_76 n_w0_76 n_up0_76 vdd vdd pch W=60u L=1u
Rinit0_77hi reset n_init0_77 385.020624267
Rinit0_77lo n_init0_77 0 614.979375733
Cw0_77 n_w0_77 0 5e-06
Mreset0_77 n_init0_77 reset n_w0_77 0 syn W=1000u L=1u
Mpos0_77 n_hv77 n_w0_77 n_op0 0 syn W=4u L=1u
Mneg0_77 n_hv77 vweight n_on0 0 syn W=4u L=1u
Menable0_77 n_enable0_77 learn 0 0 nch W=1000u L=1u
Mutail0_77 n_utail0_77 n_hv77 n_enable0_77 0 nch W=20u L=1u
Mu1_0_77 n_up0_77 n_az0 n_utail0_77 0 nch W=20u L=1u
Mu2_0_77 n_w0_77 n_error0 n_utail0_77 0 nch W=20u L=1u
Mu3_0_77 n_up0_77 n_up0_77 vdd vdd pch W=60u L=1u
Mu4_0_77 n_w0_77 n_up0_77 vdd vdd pch W=60u L=1u
Rinit0_78hi reset n_init0_78 394.977957527
Rinit0_78lo n_init0_78 0 605.022042473
Cw0_78 n_w0_78 0 5e-06
Mreset0_78 n_init0_78 reset n_w0_78 0 syn W=1000u L=1u
Mpos0_78 n_hv78 n_w0_78 n_op0 0 syn W=4u L=1u
Mneg0_78 n_hv78 vweight n_on0 0 syn W=4u L=1u
Menable0_78 n_enable0_78 learn 0 0 nch W=1000u L=1u
Mutail0_78 n_utail0_78 n_hv78 n_enable0_78 0 nch W=20u L=1u
Mu1_0_78 n_up0_78 n_az0 n_utail0_78 0 nch W=20u L=1u
Mu2_0_78 n_w0_78 n_error0 n_utail0_78 0 nch W=20u L=1u
Mu3_0_78 n_up0_78 n_up0_78 vdd vdd pch W=60u L=1u
Mu4_0_78 n_w0_78 n_up0_78 vdd vdd pch W=60u L=1u
Rinit0_79hi reset n_init0_79 367.455499105
Rinit0_79lo n_init0_79 0 632.544500895
Cw0_79 n_w0_79 0 5e-06
Mreset0_79 n_init0_79 reset n_w0_79 0 syn W=1000u L=1u
Mpos0_79 n_hv79 n_w0_79 n_op0 0 syn W=4u L=1u
Mneg0_79 n_hv79 vweight n_on0 0 syn W=4u L=1u
Menable0_79 n_enable0_79 learn 0 0 nch W=1000u L=1u
Mutail0_79 n_utail0_79 n_hv79 n_enable0_79 0 nch W=20u L=1u
Mu1_0_79 n_up0_79 n_az0 n_utail0_79 0 nch W=20u L=1u
Mu2_0_79 n_w0_79 n_error0 n_utail0_79 0 nch W=20u L=1u
Mu3_0_79 n_up0_79 n_up0_79 vdd vdd pch W=60u L=1u
Mu4_0_79 n_w0_79 n_up0_79 vdd vdd pch W=60u L=1u
Rinit0_80hi reset n_init0_80 425.231972476
Rinit0_80lo n_init0_80 0 574.768027524
Cw0_80 n_w0_80 0 5e-06
Mreset0_80 n_init0_80 reset n_w0_80 0 syn W=1000u L=1u
Mpos0_80 n_hv80 n_w0_80 n_op0 0 syn W=4u L=1u
Mneg0_80 n_hv80 vweight n_on0 0 syn W=4u L=1u
Menable0_80 n_enable0_80 learn 0 0 nch W=1000u L=1u
Mutail0_80 n_utail0_80 n_hv80 n_enable0_80 0 nch W=20u L=1u
Mu1_0_80 n_up0_80 n_az0 n_utail0_80 0 nch W=20u L=1u
Mu2_0_80 n_w0_80 n_error0 n_utail0_80 0 nch W=20u L=1u
Mu3_0_80 n_up0_80 n_up0_80 vdd vdd pch W=60u L=1u
Mu4_0_80 n_w0_80 n_up0_80 vdd vdd pch W=60u L=1u
Rinit0_81hi reset n_init0_81 407.111294902
Rinit0_81lo n_init0_81 0 592.888705098
Cw0_81 n_w0_81 0 5e-06
Mreset0_81 n_init0_81 reset n_w0_81 0 syn W=1000u L=1u
Mpos0_81 n_hv81 n_w0_81 n_op0 0 syn W=4u L=1u
Mneg0_81 n_hv81 vweight n_on0 0 syn W=4u L=1u
Menable0_81 n_enable0_81 learn 0 0 nch W=1000u L=1u
Mutail0_81 n_utail0_81 n_hv81 n_enable0_81 0 nch W=20u L=1u
Mu1_0_81 n_up0_81 n_az0 n_utail0_81 0 nch W=20u L=1u
Mu2_0_81 n_w0_81 n_error0 n_utail0_81 0 nch W=20u L=1u
Mu3_0_81 n_up0_81 n_up0_81 vdd vdd pch W=60u L=1u
Mu4_0_81 n_w0_81 n_up0_81 vdd vdd pch W=60u L=1u
Rinit0_82hi reset n_init0_82 381.763182509
Rinit0_82lo n_init0_82 0 618.236817491
Cw0_82 n_w0_82 0 5e-06
Mreset0_82 n_init0_82 reset n_w0_82 0 syn W=1000u L=1u
Mpos0_82 n_hv82 n_w0_82 n_op0 0 syn W=4u L=1u
Mneg0_82 n_hv82 vweight n_on0 0 syn W=4u L=1u
Menable0_82 n_enable0_82 learn 0 0 nch W=1000u L=1u
Mutail0_82 n_utail0_82 n_hv82 n_enable0_82 0 nch W=20u L=1u
Mu1_0_82 n_up0_82 n_az0 n_utail0_82 0 nch W=20u L=1u
Mu2_0_82 n_w0_82 n_error0 n_utail0_82 0 nch W=20u L=1u
Mu3_0_82 n_up0_82 n_up0_82 vdd vdd pch W=60u L=1u
Mu4_0_82 n_w0_82 n_up0_82 vdd vdd pch W=60u L=1u
Rinit0_83hi reset n_init0_83 435.991597288
Rinit0_83lo n_init0_83 0 564.008402712
Cw0_83 n_w0_83 0 5e-06
Mreset0_83 n_init0_83 reset n_w0_83 0 syn W=1000u L=1u
Mpos0_83 n_hv83 n_w0_83 n_op0 0 syn W=4u L=1u
Mneg0_83 n_hv83 vweight n_on0 0 syn W=4u L=1u
Menable0_83 n_enable0_83 learn 0 0 nch W=1000u L=1u
Mutail0_83 n_utail0_83 n_hv83 n_enable0_83 0 nch W=20u L=1u
Mu1_0_83 n_up0_83 n_az0 n_utail0_83 0 nch W=20u L=1u
Mu2_0_83 n_w0_83 n_error0 n_utail0_83 0 nch W=20u L=1u
Mu3_0_83 n_up0_83 n_up0_83 vdd vdd pch W=60u L=1u
Mu4_0_83 n_w0_83 n_up0_83 vdd vdd pch W=60u L=1u
Rinit0_84hi reset n_init0_84 432.062207473
Rinit0_84lo n_init0_84 0 567.937792527
Cw0_84 n_w0_84 0 5e-06
Mreset0_84 n_init0_84 reset n_w0_84 0 syn W=1000u L=1u
Mpos0_84 n_hv84 n_w0_84 n_op0 0 syn W=4u L=1u
Mneg0_84 n_hv84 vweight n_on0 0 syn W=4u L=1u
Menable0_84 n_enable0_84 learn 0 0 nch W=1000u L=1u
Mutail0_84 n_utail0_84 n_hv84 n_enable0_84 0 nch W=20u L=1u
Mu1_0_84 n_up0_84 n_az0 n_utail0_84 0 nch W=20u L=1u
Mu2_0_84 n_w0_84 n_error0 n_utail0_84 0 nch W=20u L=1u
Mu3_0_84 n_up0_84 n_up0_84 vdd vdd pch W=60u L=1u
Mu4_0_84 n_w0_84 n_up0_84 vdd vdd pch W=60u L=1u
Rinit0_85hi reset n_init0_85 396.343367886
Rinit0_85lo n_init0_85 0 603.656632114
Cw0_85 n_w0_85 0 5e-06
Mreset0_85 n_init0_85 reset n_w0_85 0 syn W=1000u L=1u
Mpos0_85 n_hv85 n_w0_85 n_op0 0 syn W=4u L=1u
Mneg0_85 n_hv85 vweight n_on0 0 syn W=4u L=1u
Menable0_85 n_enable0_85 learn 0 0 nch W=1000u L=1u
Mutail0_85 n_utail0_85 n_hv85 n_enable0_85 0 nch W=20u L=1u
Mu1_0_85 n_up0_85 n_az0 n_utail0_85 0 nch W=20u L=1u
Mu2_0_85 n_w0_85 n_error0 n_utail0_85 0 nch W=20u L=1u
Mu3_0_85 n_up0_85 n_up0_85 vdd vdd pch W=60u L=1u
Mu4_0_85 n_w0_85 n_up0_85 vdd vdd pch W=60u L=1u
Rinit0_86hi reset n_init0_86 418.741662672
Rinit0_86lo n_init0_86 0 581.258337328
Cw0_86 n_w0_86 0 5e-06
Mreset0_86 n_init0_86 reset n_w0_86 0 syn W=1000u L=1u
Mpos0_86 n_hv86 n_w0_86 n_op0 0 syn W=4u L=1u
Mneg0_86 n_hv86 vweight n_on0 0 syn W=4u L=1u
Menable0_86 n_enable0_86 learn 0 0 nch W=1000u L=1u
Mutail0_86 n_utail0_86 n_hv86 n_enable0_86 0 nch W=20u L=1u
Mu1_0_86 n_up0_86 n_az0 n_utail0_86 0 nch W=20u L=1u
Mu2_0_86 n_w0_86 n_error0 n_utail0_86 0 nch W=20u L=1u
Mu3_0_86 n_up0_86 n_up0_86 vdd vdd pch W=60u L=1u
Mu4_0_86 n_w0_86 n_up0_86 vdd vdd pch W=60u L=1u
Rinit0_87hi reset n_init0_87 431.444992301
Rinit0_87lo n_init0_87 0 568.555007699
Cw0_87 n_w0_87 0 5e-06
Mreset0_87 n_init0_87 reset n_w0_87 0 syn W=1000u L=1u
Mpos0_87 n_hv87 n_w0_87 n_op0 0 syn W=4u L=1u
Mneg0_87 n_hv87 vweight n_on0 0 syn W=4u L=1u
Menable0_87 n_enable0_87 learn 0 0 nch W=1000u L=1u
Mutail0_87 n_utail0_87 n_hv87 n_enable0_87 0 nch W=20u L=1u
Mu1_0_87 n_up0_87 n_az0 n_utail0_87 0 nch W=20u L=1u
Mu2_0_87 n_w0_87 n_error0 n_utail0_87 0 nch W=20u L=1u
Mu3_0_87 n_up0_87 n_up0_87 vdd vdd pch W=60u L=1u
Mu4_0_87 n_w0_87 n_up0_87 vdd vdd pch W=60u L=1u
Rinit0_88hi reset n_init0_88 419.06419452
Rinit0_88lo n_init0_88 0 580.93580548
Cw0_88 n_w0_88 0 5e-06
Mreset0_88 n_init0_88 reset n_w0_88 0 syn W=1000u L=1u
Mpos0_88 n_hv88 n_w0_88 n_op0 0 syn W=4u L=1u
Mneg0_88 n_hv88 vweight n_on0 0 syn W=4u L=1u
Menable0_88 n_enable0_88 learn 0 0 nch W=1000u L=1u
Mutail0_88 n_utail0_88 n_hv88 n_enable0_88 0 nch W=20u L=1u
Mu1_0_88 n_up0_88 n_az0 n_utail0_88 0 nch W=20u L=1u
Mu2_0_88 n_w0_88 n_error0 n_utail0_88 0 nch W=20u L=1u
Mu3_0_88 n_up0_88 n_up0_88 vdd vdd pch W=60u L=1u
Mu4_0_88 n_w0_88 n_up0_88 vdd vdd pch W=60u L=1u
Rinit0_89hi reset n_init0_89 389.428712981
Rinit0_89lo n_init0_89 0 610.571287019
Cw0_89 n_w0_89 0 5e-06
Mreset0_89 n_init0_89 reset n_w0_89 0 syn W=1000u L=1u
Mpos0_89 n_hv89 n_w0_89 n_op0 0 syn W=4u L=1u
Mneg0_89 n_hv89 vweight n_on0 0 syn W=4u L=1u
Menable0_89 n_enable0_89 learn 0 0 nch W=1000u L=1u
Mutail0_89 n_utail0_89 n_hv89 n_enable0_89 0 nch W=20u L=1u
Mu1_0_89 n_up0_89 n_az0 n_utail0_89 0 nch W=20u L=1u
Mu2_0_89 n_w0_89 n_error0 n_utail0_89 0 nch W=20u L=1u
Mu3_0_89 n_up0_89 n_up0_89 vdd vdd pch W=60u L=1u
Mu4_0_89 n_w0_89 n_up0_89 vdd vdd pch W=60u L=1u
Rinit0_90hi reset n_init0_90 397.889805054
Rinit0_90lo n_init0_90 0 602.110194946
Cw0_90 n_w0_90 0 5e-06
Mreset0_90 n_init0_90 reset n_w0_90 0 syn W=1000u L=1u
Mpos0_90 n_hv90 n_w0_90 n_op0 0 syn W=4u L=1u
Mneg0_90 n_hv90 vweight n_on0 0 syn W=4u L=1u
Menable0_90 n_enable0_90 learn 0 0 nch W=1000u L=1u
Mutail0_90 n_utail0_90 n_hv90 n_enable0_90 0 nch W=20u L=1u
Mu1_0_90 n_up0_90 n_az0 n_utail0_90 0 nch W=20u L=1u
Mu2_0_90 n_w0_90 n_error0 n_utail0_90 0 nch W=20u L=1u
Mu3_0_90 n_up0_90 n_up0_90 vdd vdd pch W=60u L=1u
Mu4_0_90 n_w0_90 n_up0_90 vdd vdd pch W=60u L=1u
Rinit0_91hi reset n_init0_91 433.720259157
Rinit0_91lo n_init0_91 0 566.279740843
Cw0_91 n_w0_91 0 5e-06
Mreset0_91 n_init0_91 reset n_w0_91 0 syn W=1000u L=1u
Mpos0_91 n_hv91 n_w0_91 n_op0 0 syn W=4u L=1u
Mneg0_91 n_hv91 vweight n_on0 0 syn W=4u L=1u
Menable0_91 n_enable0_91 learn 0 0 nch W=1000u L=1u
Mutail0_91 n_utail0_91 n_hv91 n_enable0_91 0 nch W=20u L=1u
Mu1_0_91 n_up0_91 n_az0 n_utail0_91 0 nch W=20u L=1u
Mu2_0_91 n_w0_91 n_error0 n_utail0_91 0 nch W=20u L=1u
Mu3_0_91 n_up0_91 n_up0_91 vdd vdd pch W=60u L=1u
Mu4_0_91 n_w0_91 n_up0_91 vdd vdd pch W=60u L=1u
Rinit0_92hi reset n_init0_92 434.175084356
Rinit0_92lo n_init0_92 0 565.824915644
Cw0_92 n_w0_92 0 5e-06
Mreset0_92 n_init0_92 reset n_w0_92 0 syn W=1000u L=1u
Mpos0_92 n_hv92 n_w0_92 n_op0 0 syn W=4u L=1u
Mneg0_92 n_hv92 vweight n_on0 0 syn W=4u L=1u
Menable0_92 n_enable0_92 learn 0 0 nch W=1000u L=1u
Mutail0_92 n_utail0_92 n_hv92 n_enable0_92 0 nch W=20u L=1u
Mu1_0_92 n_up0_92 n_az0 n_utail0_92 0 nch W=20u L=1u
Mu2_0_92 n_w0_92 n_error0 n_utail0_92 0 nch W=20u L=1u
Mu3_0_92 n_up0_92 n_up0_92 vdd vdd pch W=60u L=1u
Mu4_0_92 n_w0_92 n_up0_92 vdd vdd pch W=60u L=1u
Rinit0_93hi reset n_init0_93 371.949840655
Rinit0_93lo n_init0_93 0 628.050159345
Cw0_93 n_w0_93 0 5e-06
Mreset0_93 n_init0_93 reset n_w0_93 0 syn W=1000u L=1u
Mpos0_93 n_hv93 n_w0_93 n_op0 0 syn W=4u L=1u
Mneg0_93 n_hv93 vweight n_on0 0 syn W=4u L=1u
Menable0_93 n_enable0_93 learn 0 0 nch W=1000u L=1u
Mutail0_93 n_utail0_93 n_hv93 n_enable0_93 0 nch W=20u L=1u
Mu1_0_93 n_up0_93 n_az0 n_utail0_93 0 nch W=20u L=1u
Mu2_0_93 n_w0_93 n_error0 n_utail0_93 0 nch W=20u L=1u
Mu3_0_93 n_up0_93 n_up0_93 vdd vdd pch W=60u L=1u
Mu4_0_93 n_w0_93 n_up0_93 vdd vdd pch W=60u L=1u
Rinit0_94hi reset n_init0_94 388.540883161
Rinit0_94lo n_init0_94 0 611.459116839
Cw0_94 n_w0_94 0 5e-06
Mreset0_94 n_init0_94 reset n_w0_94 0 syn W=1000u L=1u
Mpos0_94 n_hv94 n_w0_94 n_op0 0 syn W=4u L=1u
Mneg0_94 n_hv94 vweight n_on0 0 syn W=4u L=1u
Menable0_94 n_enable0_94 learn 0 0 nch W=1000u L=1u
Mutail0_94 n_utail0_94 n_hv94 n_enable0_94 0 nch W=20u L=1u
Mu1_0_94 n_up0_94 n_az0 n_utail0_94 0 nch W=20u L=1u
Mu2_0_94 n_w0_94 n_error0 n_utail0_94 0 nch W=20u L=1u
Mu3_0_94 n_up0_94 n_up0_94 vdd vdd pch W=60u L=1u
Mu4_0_94 n_w0_94 n_up0_94 vdd vdd pch W=60u L=1u
Rinit0_95hi reset n_init0_95 426.13061934
Rinit0_95lo n_init0_95 0 573.86938066
Cw0_95 n_w0_95 0 5e-06
Mreset0_95 n_init0_95 reset n_w0_95 0 syn W=1000u L=1u
Mpos0_95 n_hv95 n_w0_95 n_op0 0 syn W=4u L=1u
Mneg0_95 n_hv95 vweight n_on0 0 syn W=4u L=1u
Menable0_95 n_enable0_95 learn 0 0 nch W=1000u L=1u
Mutail0_95 n_utail0_95 n_hv95 n_enable0_95 0 nch W=20u L=1u
Mu1_0_95 n_up0_95 n_az0 n_utail0_95 0 nch W=20u L=1u
Mu2_0_95 n_w0_95 n_error0 n_utail0_95 0 nch W=20u L=1u
Mu3_0_95 n_up0_95 n_up0_95 vdd vdd pch W=60u L=1u
Mu4_0_95 n_w0_95 n_up0_95 vdd vdd pch W=60u L=1u
Rinit0_96hi reset n_init0_96 371.053274612
Rinit0_96lo n_init0_96 0 628.946725388
Cw0_96 n_w0_96 0 5e-06
Mreset0_96 n_init0_96 reset n_w0_96 0 syn W=1000u L=1u
Mpos0_96 vbias n_w0_96 n_op0 0 syn W=4u L=1u
Mneg0_96 vbias vweight n_on0 0 syn W=4u L=1u
Menable0_96 n_enable0_96 learn 0 0 nch W=1000u L=1u
Mutail0_96 n_utail0_96 vbias n_enable0_96 0 nch W=20u L=1u
Mu1_0_96 n_up0_96 n_az0 n_utail0_96 0 nch W=20u L=1u
Mu2_0_96 n_w0_96 n_error0 n_utail0_96 0 nch W=20u L=1u
Mu3_0_96 n_up0_96 n_up0_96 vdd vdd pch W=60u L=1u
Mu4_0_96 n_w0_96 n_up0_96 vdd vdd pch W=60u L=1u
Mo1a n_on1 n_on1 0 0 nch W=20u L=1u
Mo1b out1 n_on1 0 0 nch W=20u L=1u
Mo1c n_op1 n_op1 0 0 nch W=20u L=1u
Mo1d n_mirroro1 n_op1 0 0 nch W=20u L=1u
Mo1e n_mirroro1 n_mirroro1 vdd vdd pch W=60u L=1u
Mo1f out1 n_mirroro1 vdd vdd pch W=60u L=1u
Ro1sum out1 vref 7000
Rtargetin1 target1 n_target1 30000
Rtargetref1 vbias n_target1 36402.5695931
Rtargetzero1 n_target1 0 25512.7563782
Merrorp1 n_error1 n_mirroro1 vdd vdd pch W=60u L=1u
Merrorn1 n_error1 n_on1 0 0 nch W=20u L=1u
Moffset1 n_error1 voffset vdd vdd pch W=10u L=1u
Mtarget1 n_error1 n_target1 0 0 nch W=10u L=1u
Rerror1 n_error1 verror 7000
Rcommon1 n_error1 n_common 10000
Raz1 n_error1 n_azfeed1 6000
Maztrack1 n_azfeed1 learn n_az1 0 syn W=1000u L=1u
Caz1 n_az1 0 1e-05
Mazreset1 verror reset n_az1 0 syn W=1000u L=1u
Rinit1_0hi reset n_init1_0 438.252049333
Rinit1_0lo n_init1_0 0 561.747950667
Cw1_0 n_w1_0 0 5e-06
Mreset1_0 n_init1_0 reset n_w1_0 0 syn W=1000u L=1u
Mpos1_0 n_hv0 n_w1_0 n_op1 0 syn W=4u L=1u
Mneg1_0 n_hv0 vweight n_on1 0 syn W=4u L=1u
Menable1_0 n_enable1_0 learn 0 0 nch W=1000u L=1u
Mutail1_0 n_utail1_0 n_hv0 n_enable1_0 0 nch W=20u L=1u
Mu1_1_0 n_up1_0 n_az1 n_utail1_0 0 nch W=20u L=1u
Mu2_1_0 n_w1_0 n_error1 n_utail1_0 0 nch W=20u L=1u
Mu3_1_0 n_up1_0 n_up1_0 vdd vdd pch W=60u L=1u
Mu4_1_0 n_w1_0 n_up1_0 vdd vdd pch W=60u L=1u
Rinit1_1hi reset n_init1_1 410.551616609
Rinit1_1lo n_init1_1 0 589.448383391
Cw1_1 n_w1_1 0 5e-06
Mreset1_1 n_init1_1 reset n_w1_1 0 syn W=1000u L=1u
Mpos1_1 n_hv1 n_w1_1 n_op1 0 syn W=4u L=1u
Mneg1_1 n_hv1 vweight n_on1 0 syn W=4u L=1u
Menable1_1 n_enable1_1 learn 0 0 nch W=1000u L=1u
Mutail1_1 n_utail1_1 n_hv1 n_enable1_1 0 nch W=20u L=1u
Mu1_1_1 n_up1_1 n_az1 n_utail1_1 0 nch W=20u L=1u
Mu2_1_1 n_w1_1 n_error1 n_utail1_1 0 nch W=20u L=1u
Mu3_1_1 n_up1_1 n_up1_1 vdd vdd pch W=60u L=1u
Mu4_1_1 n_w1_1 n_up1_1 vdd vdd pch W=60u L=1u
Rinit1_2hi reset n_init1_2 372.189621039
Rinit1_2lo n_init1_2 0 627.810378961
Cw1_2 n_w1_2 0 5e-06
Mreset1_2 n_init1_2 reset n_w1_2 0 syn W=1000u L=1u
Mpos1_2 n_hv2 n_w1_2 n_op1 0 syn W=4u L=1u
Mneg1_2 n_hv2 vweight n_on1 0 syn W=4u L=1u
Menable1_2 n_enable1_2 learn 0 0 nch W=1000u L=1u
Mutail1_2 n_utail1_2 n_hv2 n_enable1_2 0 nch W=20u L=1u
Mu1_1_2 n_up1_2 n_az1 n_utail1_2 0 nch W=20u L=1u
Mu2_1_2 n_w1_2 n_error1 n_utail1_2 0 nch W=20u L=1u
Mu3_1_2 n_up1_2 n_up1_2 vdd vdd pch W=60u L=1u
Mu4_1_2 n_w1_2 n_up1_2 vdd vdd pch W=60u L=1u
Rinit1_3hi reset n_init1_3 383.17772698
Rinit1_3lo n_init1_3 0 616.82227302
Cw1_3 n_w1_3 0 5e-06
Mreset1_3 n_init1_3 reset n_w1_3 0 syn W=1000u L=1u
Mpos1_3 n_hv3 n_w1_3 n_op1 0 syn W=4u L=1u
Mneg1_3 n_hv3 vweight n_on1 0 syn W=4u L=1u
Menable1_3 n_enable1_3 learn 0 0 nch W=1000u L=1u
Mutail1_3 n_utail1_3 n_hv3 n_enable1_3 0 nch W=20u L=1u
Mu1_1_3 n_up1_3 n_az1 n_utail1_3 0 nch W=20u L=1u
Mu2_1_3 n_w1_3 n_error1 n_utail1_3 0 nch W=20u L=1u
Mu3_1_3 n_up1_3 n_up1_3 vdd vdd pch W=60u L=1u
Mu4_1_3 n_w1_3 n_up1_3 vdd vdd pch W=60u L=1u
Rinit1_4hi reset n_init1_4 417.299807537
Rinit1_4lo n_init1_4 0 582.700192463
Cw1_4 n_w1_4 0 5e-06
Mreset1_4 n_init1_4 reset n_w1_4 0 syn W=1000u L=1u
Mpos1_4 n_hv4 n_w1_4 n_op1 0 syn W=4u L=1u
Mneg1_4 n_hv4 vweight n_on1 0 syn W=4u L=1u
Menable1_4 n_enable1_4 learn 0 0 nch W=1000u L=1u
Mutail1_4 n_utail1_4 n_hv4 n_enable1_4 0 nch W=20u L=1u
Mu1_1_4 n_up1_4 n_az1 n_utail1_4 0 nch W=20u L=1u
Mu2_1_4 n_w1_4 n_error1 n_utail1_4 0 nch W=20u L=1u
Mu3_1_4 n_up1_4 n_up1_4 vdd vdd pch W=60u L=1u
Mu4_1_4 n_w1_4 n_up1_4 vdd vdd pch W=60u L=1u
Rinit1_5hi reset n_init1_5 368.69748044
Rinit1_5lo n_init1_5 0 631.30251956
Cw1_5 n_w1_5 0 5e-06
Mreset1_5 n_init1_5 reset n_w1_5 0 syn W=1000u L=1u
Mpos1_5 n_hv5 n_w1_5 n_op1 0 syn W=4u L=1u
Mneg1_5 n_hv5 vweight n_on1 0 syn W=4u L=1u
Menable1_5 n_enable1_5 learn 0 0 nch W=1000u L=1u
Mutail1_5 n_utail1_5 n_hv5 n_enable1_5 0 nch W=20u L=1u
Mu1_1_5 n_up1_5 n_az1 n_utail1_5 0 nch W=20u L=1u
Mu2_1_5 n_w1_5 n_error1 n_utail1_5 0 nch W=20u L=1u
Mu3_1_5 n_up1_5 n_up1_5 vdd vdd pch W=60u L=1u
Mu4_1_5 n_w1_5 n_up1_5 vdd vdd pch W=60u L=1u
Rinit1_6hi reset n_init1_6 392.153759901
Rinit1_6lo n_init1_6 0 607.846240099
Cw1_6 n_w1_6 0 5e-06
Mreset1_6 n_init1_6 reset n_w1_6 0 syn W=1000u L=1u
Mpos1_6 n_hv6 n_w1_6 n_op1 0 syn W=4u L=1u
Mneg1_6 n_hv6 vweight n_on1 0 syn W=4u L=1u
Menable1_6 n_enable1_6 learn 0 0 nch W=1000u L=1u
Mutail1_6 n_utail1_6 n_hv6 n_enable1_6 0 nch W=20u L=1u
Mu1_1_6 n_up1_6 n_az1 n_utail1_6 0 nch W=20u L=1u
Mu2_1_6 n_w1_6 n_error1 n_utail1_6 0 nch W=20u L=1u
Mu3_1_6 n_up1_6 n_up1_6 vdd vdd pch W=60u L=1u
Mu4_1_6 n_w1_6 n_up1_6 vdd vdd pch W=60u L=1u
Rinit1_7hi reset n_init1_7 370.760534466
Rinit1_7lo n_init1_7 0 629.239465534
Cw1_7 n_w1_7 0 5e-06
Mreset1_7 n_init1_7 reset n_w1_7 0 syn W=1000u L=1u
Mpos1_7 n_hv7 n_w1_7 n_op1 0 syn W=4u L=1u
Mneg1_7 n_hv7 vweight n_on1 0 syn W=4u L=1u
Menable1_7 n_enable1_7 learn 0 0 nch W=1000u L=1u
Mutail1_7 n_utail1_7 n_hv7 n_enable1_7 0 nch W=20u L=1u
Mu1_1_7 n_up1_7 n_az1 n_utail1_7 0 nch W=20u L=1u
Mu2_1_7 n_w1_7 n_error1 n_utail1_7 0 nch W=20u L=1u
Mu3_1_7 n_up1_7 n_up1_7 vdd vdd pch W=60u L=1u
Mu4_1_7 n_w1_7 n_up1_7 vdd vdd pch W=60u L=1u
Rinit1_8hi reset n_init1_8 368.576530078
Rinit1_8lo n_init1_8 0 631.423469922
Cw1_8 n_w1_8 0 5e-06
Mreset1_8 n_init1_8 reset n_w1_8 0 syn W=1000u L=1u
Mpos1_8 n_hv8 n_w1_8 n_op1 0 syn W=4u L=1u
Mneg1_8 n_hv8 vweight n_on1 0 syn W=4u L=1u
Menable1_8 n_enable1_8 learn 0 0 nch W=1000u L=1u
Mutail1_8 n_utail1_8 n_hv8 n_enable1_8 0 nch W=20u L=1u
Mu1_1_8 n_up1_8 n_az1 n_utail1_8 0 nch W=20u L=1u
Mu2_1_8 n_w1_8 n_error1 n_utail1_8 0 nch W=20u L=1u
Mu3_1_8 n_up1_8 n_up1_8 vdd vdd pch W=60u L=1u
Mu4_1_8 n_w1_8 n_up1_8 vdd vdd pch W=60u L=1u
Rinit1_9hi reset n_init1_9 405.964473812
Rinit1_9lo n_init1_9 0 594.035526188
Cw1_9 n_w1_9 0 5e-06
Mreset1_9 n_init1_9 reset n_w1_9 0 syn W=1000u L=1u
Mpos1_9 n_hv9 n_w1_9 n_op1 0 syn W=4u L=1u
Mneg1_9 n_hv9 vweight n_on1 0 syn W=4u L=1u
Menable1_9 n_enable1_9 learn 0 0 nch W=1000u L=1u
Mutail1_9 n_utail1_9 n_hv9 n_enable1_9 0 nch W=20u L=1u
Mu1_1_9 n_up1_9 n_az1 n_utail1_9 0 nch W=20u L=1u
Mu2_1_9 n_w1_9 n_error1 n_utail1_9 0 nch W=20u L=1u
Mu3_1_9 n_up1_9 n_up1_9 vdd vdd pch W=60u L=1u
Mu4_1_9 n_w1_9 n_up1_9 vdd vdd pch W=60u L=1u
Rinit1_10hi reset n_init1_10 385.951972981
Rinit1_10lo n_init1_10 0 614.048027019
Cw1_10 n_w1_10 0 5e-06
Mreset1_10 n_init1_10 reset n_w1_10 0 syn W=1000u L=1u
Mpos1_10 n_hv10 n_w1_10 n_op1 0 syn W=4u L=1u
Mneg1_10 n_hv10 vweight n_on1 0 syn W=4u L=1u
Menable1_10 n_enable1_10 learn 0 0 nch W=1000u L=1u
Mutail1_10 n_utail1_10 n_hv10 n_enable1_10 0 nch W=20u L=1u
Mu1_1_10 n_up1_10 n_az1 n_utail1_10 0 nch W=20u L=1u
Mu2_1_10 n_w1_10 n_error1 n_utail1_10 0 nch W=20u L=1u
Mu3_1_10 n_up1_10 n_up1_10 vdd vdd pch W=60u L=1u
Mu4_1_10 n_w1_10 n_up1_10 vdd vdd pch W=60u L=1u
Rinit1_11hi reset n_init1_11 396.441894822
Rinit1_11lo n_init1_11 0 603.558105178
Cw1_11 n_w1_11 0 5e-06
Mreset1_11 n_init1_11 reset n_w1_11 0 syn W=1000u L=1u
Mpos1_11 n_hv11 n_w1_11 n_op1 0 syn W=4u L=1u
Mneg1_11 n_hv11 vweight n_on1 0 syn W=4u L=1u
Menable1_11 n_enable1_11 learn 0 0 nch W=1000u L=1u
Mutail1_11 n_utail1_11 n_hv11 n_enable1_11 0 nch W=20u L=1u
Mu1_1_11 n_up1_11 n_az1 n_utail1_11 0 nch W=20u L=1u
Mu2_1_11 n_w1_11 n_error1 n_utail1_11 0 nch W=20u L=1u
Mu3_1_11 n_up1_11 n_up1_11 vdd vdd pch W=60u L=1u
Mu4_1_11 n_w1_11 n_up1_11 vdd vdd pch W=60u L=1u
Rinit1_12hi reset n_init1_12 364.42118097
Rinit1_12lo n_init1_12 0 635.57881903
Cw1_12 n_w1_12 0 5e-06
Mreset1_12 n_init1_12 reset n_w1_12 0 syn W=1000u L=1u
Mpos1_12 n_hv12 n_w1_12 n_op1 0 syn W=4u L=1u
Mneg1_12 n_hv12 vweight n_on1 0 syn W=4u L=1u
Menable1_12 n_enable1_12 learn 0 0 nch W=1000u L=1u
Mutail1_12 n_utail1_12 n_hv12 n_enable1_12 0 nch W=20u L=1u
Mu1_1_12 n_up1_12 n_az1 n_utail1_12 0 nch W=20u L=1u
Mu2_1_12 n_w1_12 n_error1 n_utail1_12 0 nch W=20u L=1u
Mu3_1_12 n_up1_12 n_up1_12 vdd vdd pch W=60u L=1u
Mu4_1_12 n_w1_12 n_up1_12 vdd vdd pch W=60u L=1u
Rinit1_13hi reset n_init1_13 376.147140573
Rinit1_13lo n_init1_13 0 623.852859427
Cw1_13 n_w1_13 0 5e-06
Mreset1_13 n_init1_13 reset n_w1_13 0 syn W=1000u L=1u
Mpos1_13 n_hv13 n_w1_13 n_op1 0 syn W=4u L=1u
Mneg1_13 n_hv13 vweight n_on1 0 syn W=4u L=1u
Menable1_13 n_enable1_13 learn 0 0 nch W=1000u L=1u
Mutail1_13 n_utail1_13 n_hv13 n_enable1_13 0 nch W=20u L=1u
Mu1_1_13 n_up1_13 n_az1 n_utail1_13 0 nch W=20u L=1u
Mu2_1_13 n_w1_13 n_error1 n_utail1_13 0 nch W=20u L=1u
Mu3_1_13 n_up1_13 n_up1_13 vdd vdd pch W=60u L=1u
Mu4_1_13 n_w1_13 n_up1_13 vdd vdd pch W=60u L=1u
Rinit1_14hi reset n_init1_14 381.934519963
Rinit1_14lo n_init1_14 0 618.065480037
Cw1_14 n_w1_14 0 5e-06
Mreset1_14 n_init1_14 reset n_w1_14 0 syn W=1000u L=1u
Mpos1_14 n_hv14 n_w1_14 n_op1 0 syn W=4u L=1u
Mneg1_14 n_hv14 vweight n_on1 0 syn W=4u L=1u
Menable1_14 n_enable1_14 learn 0 0 nch W=1000u L=1u
Mutail1_14 n_utail1_14 n_hv14 n_enable1_14 0 nch W=20u L=1u
Mu1_1_14 n_up1_14 n_az1 n_utail1_14 0 nch W=20u L=1u
Mu2_1_14 n_w1_14 n_error1 n_utail1_14 0 nch W=20u L=1u
Mu3_1_14 n_up1_14 n_up1_14 vdd vdd pch W=60u L=1u
Mu4_1_14 n_w1_14 n_up1_14 vdd vdd pch W=60u L=1u
Rinit1_15hi reset n_init1_15 374.87741003
Rinit1_15lo n_init1_15 0 625.12258997
Cw1_15 n_w1_15 0 5e-06
Mreset1_15 n_init1_15 reset n_w1_15 0 syn W=1000u L=1u
Mpos1_15 n_hv15 n_w1_15 n_op1 0 syn W=4u L=1u
Mneg1_15 n_hv15 vweight n_on1 0 syn W=4u L=1u
Menable1_15 n_enable1_15 learn 0 0 nch W=1000u L=1u
Mutail1_15 n_utail1_15 n_hv15 n_enable1_15 0 nch W=20u L=1u
Mu1_1_15 n_up1_15 n_az1 n_utail1_15 0 nch W=20u L=1u
Mu2_1_15 n_w1_15 n_error1 n_utail1_15 0 nch W=20u L=1u
Mu3_1_15 n_up1_15 n_up1_15 vdd vdd pch W=60u L=1u
Mu4_1_15 n_w1_15 n_up1_15 vdd vdd pch W=60u L=1u
Rinit1_16hi reset n_init1_16 360.147203817
Rinit1_16lo n_init1_16 0 639.852796183
Cw1_16 n_w1_16 0 5e-06
Mreset1_16 n_init1_16 reset n_w1_16 0 syn W=1000u L=1u
Mpos1_16 n_hv16 n_w1_16 n_op1 0 syn W=4u L=1u
Mneg1_16 n_hv16 vweight n_on1 0 syn W=4u L=1u
Menable1_16 n_enable1_16 learn 0 0 nch W=1000u L=1u
Mutail1_16 n_utail1_16 n_hv16 n_enable1_16 0 nch W=20u L=1u
Mu1_1_16 n_up1_16 n_az1 n_utail1_16 0 nch W=20u L=1u
Mu2_1_16 n_w1_16 n_error1 n_utail1_16 0 nch W=20u L=1u
Mu3_1_16 n_up1_16 n_up1_16 vdd vdd pch W=60u L=1u
Mu4_1_16 n_w1_16 n_up1_16 vdd vdd pch W=60u L=1u
Rinit1_17hi reset n_init1_17 419.475105162
Rinit1_17lo n_init1_17 0 580.524894838
Cw1_17 n_w1_17 0 5e-06
Mreset1_17 n_init1_17 reset n_w1_17 0 syn W=1000u L=1u
Mpos1_17 n_hv17 n_w1_17 n_op1 0 syn W=4u L=1u
Mneg1_17 n_hv17 vweight n_on1 0 syn W=4u L=1u
Menable1_17 n_enable1_17 learn 0 0 nch W=1000u L=1u
Mutail1_17 n_utail1_17 n_hv17 n_enable1_17 0 nch W=20u L=1u
Mu1_1_17 n_up1_17 n_az1 n_utail1_17 0 nch W=20u L=1u
Mu2_1_17 n_w1_17 n_error1 n_utail1_17 0 nch W=20u L=1u
Mu3_1_17 n_up1_17 n_up1_17 vdd vdd pch W=60u L=1u
Mu4_1_17 n_w1_17 n_up1_17 vdd vdd pch W=60u L=1u
Rinit1_18hi reset n_init1_18 423.890909548
Rinit1_18lo n_init1_18 0 576.109090452
Cw1_18 n_w1_18 0 5e-06
Mreset1_18 n_init1_18 reset n_w1_18 0 syn W=1000u L=1u
Mpos1_18 n_hv18 n_w1_18 n_op1 0 syn W=4u L=1u
Mneg1_18 n_hv18 vweight n_on1 0 syn W=4u L=1u
Menable1_18 n_enable1_18 learn 0 0 nch W=1000u L=1u
Mutail1_18 n_utail1_18 n_hv18 n_enable1_18 0 nch W=20u L=1u
Mu1_1_18 n_up1_18 n_az1 n_utail1_18 0 nch W=20u L=1u
Mu2_1_18 n_w1_18 n_error1 n_utail1_18 0 nch W=20u L=1u
Mu3_1_18 n_up1_18 n_up1_18 vdd vdd pch W=60u L=1u
Mu4_1_18 n_w1_18 n_up1_18 vdd vdd pch W=60u L=1u
Rinit1_19hi reset n_init1_19 380.257374923
Rinit1_19lo n_init1_19 0 619.742625077
Cw1_19 n_w1_19 0 5e-06
Mreset1_19 n_init1_19 reset n_w1_19 0 syn W=1000u L=1u
Mpos1_19 n_hv19 n_w1_19 n_op1 0 syn W=4u L=1u
Mneg1_19 n_hv19 vweight n_on1 0 syn W=4u L=1u
Menable1_19 n_enable1_19 learn 0 0 nch W=1000u L=1u
Mutail1_19 n_utail1_19 n_hv19 n_enable1_19 0 nch W=20u L=1u
Mu1_1_19 n_up1_19 n_az1 n_utail1_19 0 nch W=20u L=1u
Mu2_1_19 n_w1_19 n_error1 n_utail1_19 0 nch W=20u L=1u
Mu3_1_19 n_up1_19 n_up1_19 vdd vdd pch W=60u L=1u
Mu4_1_19 n_w1_19 n_up1_19 vdd vdd pch W=60u L=1u
Rinit1_20hi reset n_init1_20 378.37339915
Rinit1_20lo n_init1_20 0 621.62660085
Cw1_20 n_w1_20 0 5e-06
Mreset1_20 n_init1_20 reset n_w1_20 0 syn W=1000u L=1u
Mpos1_20 n_hv20 n_w1_20 n_op1 0 syn W=4u L=1u
Mneg1_20 n_hv20 vweight n_on1 0 syn W=4u L=1u
Menable1_20 n_enable1_20 learn 0 0 nch W=1000u L=1u
Mutail1_20 n_utail1_20 n_hv20 n_enable1_20 0 nch W=20u L=1u
Mu1_1_20 n_up1_20 n_az1 n_utail1_20 0 nch W=20u L=1u
Mu2_1_20 n_w1_20 n_error1 n_utail1_20 0 nch W=20u L=1u
Mu3_1_20 n_up1_20 n_up1_20 vdd vdd pch W=60u L=1u
Mu4_1_20 n_w1_20 n_up1_20 vdd vdd pch W=60u L=1u
Rinit1_21hi reset n_init1_21 398.857296183
Rinit1_21lo n_init1_21 0 601.142703817
Cw1_21 n_w1_21 0 5e-06
Mreset1_21 n_init1_21 reset n_w1_21 0 syn W=1000u L=1u
Mpos1_21 n_hv21 n_w1_21 n_op1 0 syn W=4u L=1u
Mneg1_21 n_hv21 vweight n_on1 0 syn W=4u L=1u
Menable1_21 n_enable1_21 learn 0 0 nch W=1000u L=1u
Mutail1_21 n_utail1_21 n_hv21 n_enable1_21 0 nch W=20u L=1u
Mu1_1_21 n_up1_21 n_az1 n_utail1_21 0 nch W=20u L=1u
Mu2_1_21 n_w1_21 n_error1 n_utail1_21 0 nch W=20u L=1u
Mu3_1_21 n_up1_21 n_up1_21 vdd vdd pch W=60u L=1u
Mu4_1_21 n_w1_21 n_up1_21 vdd vdd pch W=60u L=1u
Rinit1_22hi reset n_init1_22 401.033934905
Rinit1_22lo n_init1_22 0 598.966065095
Cw1_22 n_w1_22 0 5e-06
Mreset1_22 n_init1_22 reset n_w1_22 0 syn W=1000u L=1u
Mpos1_22 n_hv22 n_w1_22 n_op1 0 syn W=4u L=1u
Mneg1_22 n_hv22 vweight n_on1 0 syn W=4u L=1u
Menable1_22 n_enable1_22 learn 0 0 nch W=1000u L=1u
Mutail1_22 n_utail1_22 n_hv22 n_enable1_22 0 nch W=20u L=1u
Mu1_1_22 n_up1_22 n_az1 n_utail1_22 0 nch W=20u L=1u
Mu2_1_22 n_w1_22 n_error1 n_utail1_22 0 nch W=20u L=1u
Mu3_1_22 n_up1_22 n_up1_22 vdd vdd pch W=60u L=1u
Mu4_1_22 n_w1_22 n_up1_22 vdd vdd pch W=60u L=1u
Rinit1_23hi reset n_init1_23 407.700554361
Rinit1_23lo n_init1_23 0 592.299445639
Cw1_23 n_w1_23 0 5e-06
Mreset1_23 n_init1_23 reset n_w1_23 0 syn W=1000u L=1u
Mpos1_23 n_hv23 n_w1_23 n_op1 0 syn W=4u L=1u
Mneg1_23 n_hv23 vweight n_on1 0 syn W=4u L=1u
Menable1_23 n_enable1_23 learn 0 0 nch W=1000u L=1u
Mutail1_23 n_utail1_23 n_hv23 n_enable1_23 0 nch W=20u L=1u
Mu1_1_23 n_up1_23 n_az1 n_utail1_23 0 nch W=20u L=1u
Mu2_1_23 n_w1_23 n_error1 n_utail1_23 0 nch W=20u L=1u
Mu3_1_23 n_up1_23 n_up1_23 vdd vdd pch W=60u L=1u
Mu4_1_23 n_w1_23 n_up1_23 vdd vdd pch W=60u L=1u
Rinit1_24hi reset n_init1_24 369.384245568
Rinit1_24lo n_init1_24 0 630.615754432
Cw1_24 n_w1_24 0 5e-06
Mreset1_24 n_init1_24 reset n_w1_24 0 syn W=1000u L=1u
Mpos1_24 n_hv24 n_w1_24 n_op1 0 syn W=4u L=1u
Mneg1_24 n_hv24 vweight n_on1 0 syn W=4u L=1u
Menable1_24 n_enable1_24 learn 0 0 nch W=1000u L=1u
Mutail1_24 n_utail1_24 n_hv24 n_enable1_24 0 nch W=20u L=1u
Mu1_1_24 n_up1_24 n_az1 n_utail1_24 0 nch W=20u L=1u
Mu2_1_24 n_w1_24 n_error1 n_utail1_24 0 nch W=20u L=1u
Mu3_1_24 n_up1_24 n_up1_24 vdd vdd pch W=60u L=1u
Mu4_1_24 n_w1_24 n_up1_24 vdd vdd pch W=60u L=1u
Rinit1_25hi reset n_init1_25 376.301449789
Rinit1_25lo n_init1_25 0 623.698550211
Cw1_25 n_w1_25 0 5e-06
Mreset1_25 n_init1_25 reset n_w1_25 0 syn W=1000u L=1u
Mpos1_25 n_hv25 n_w1_25 n_op1 0 syn W=4u L=1u
Mneg1_25 n_hv25 vweight n_on1 0 syn W=4u L=1u
Menable1_25 n_enable1_25 learn 0 0 nch W=1000u L=1u
Mutail1_25 n_utail1_25 n_hv25 n_enable1_25 0 nch W=20u L=1u
Mu1_1_25 n_up1_25 n_az1 n_utail1_25 0 nch W=20u L=1u
Mu2_1_25 n_w1_25 n_error1 n_utail1_25 0 nch W=20u L=1u
Mu3_1_25 n_up1_25 n_up1_25 vdd vdd pch W=60u L=1u
Mu4_1_25 n_w1_25 n_up1_25 vdd vdd pch W=60u L=1u
Rinit1_26hi reset n_init1_26 393.232192143
Rinit1_26lo n_init1_26 0 606.767807857
Cw1_26 n_w1_26 0 5e-06
Mreset1_26 n_init1_26 reset n_w1_26 0 syn W=1000u L=1u
Mpos1_26 n_hv26 n_w1_26 n_op1 0 syn W=4u L=1u
Mneg1_26 n_hv26 vweight n_on1 0 syn W=4u L=1u
Menable1_26 n_enable1_26 learn 0 0 nch W=1000u L=1u
Mutail1_26 n_utail1_26 n_hv26 n_enable1_26 0 nch W=20u L=1u
Mu1_1_26 n_up1_26 n_az1 n_utail1_26 0 nch W=20u L=1u
Mu2_1_26 n_w1_26 n_error1 n_utail1_26 0 nch W=20u L=1u
Mu3_1_26 n_up1_26 n_up1_26 vdd vdd pch W=60u L=1u
Mu4_1_26 n_w1_26 n_up1_26 vdd vdd pch W=60u L=1u
Rinit1_27hi reset n_init1_27 436.790473251
Rinit1_27lo n_init1_27 0 563.209526749
Cw1_27 n_w1_27 0 5e-06
Mreset1_27 n_init1_27 reset n_w1_27 0 syn W=1000u L=1u
Mpos1_27 n_hv27 n_w1_27 n_op1 0 syn W=4u L=1u
Mneg1_27 n_hv27 vweight n_on1 0 syn W=4u L=1u
Menable1_27 n_enable1_27 learn 0 0 nch W=1000u L=1u
Mutail1_27 n_utail1_27 n_hv27 n_enable1_27 0 nch W=20u L=1u
Mu1_1_27 n_up1_27 n_az1 n_utail1_27 0 nch W=20u L=1u
Mu2_1_27 n_w1_27 n_error1 n_utail1_27 0 nch W=20u L=1u
Mu3_1_27 n_up1_27 n_up1_27 vdd vdd pch W=60u L=1u
Mu4_1_27 n_w1_27 n_up1_27 vdd vdd pch W=60u L=1u
Rinit1_28hi reset n_init1_28 371.908672459
Rinit1_28lo n_init1_28 0 628.091327541
Cw1_28 n_w1_28 0 5e-06
Mreset1_28 n_init1_28 reset n_w1_28 0 syn W=1000u L=1u
Mpos1_28 n_hv28 n_w1_28 n_op1 0 syn W=4u L=1u
Mneg1_28 n_hv28 vweight n_on1 0 syn W=4u L=1u
Menable1_28 n_enable1_28 learn 0 0 nch W=1000u L=1u
Mutail1_28 n_utail1_28 n_hv28 n_enable1_28 0 nch W=20u L=1u
Mu1_1_28 n_up1_28 n_az1 n_utail1_28 0 nch W=20u L=1u
Mu2_1_28 n_w1_28 n_error1 n_utail1_28 0 nch W=20u L=1u
Mu3_1_28 n_up1_28 n_up1_28 vdd vdd pch W=60u L=1u
Mu4_1_28 n_w1_28 n_up1_28 vdd vdd pch W=60u L=1u
Rinit1_29hi reset n_init1_29 403.323705789
Rinit1_29lo n_init1_29 0 596.676294211
Cw1_29 n_w1_29 0 5e-06
Mreset1_29 n_init1_29 reset n_w1_29 0 syn W=1000u L=1u
Mpos1_29 n_hv29 n_w1_29 n_op1 0 syn W=4u L=1u
Mneg1_29 n_hv29 vweight n_on1 0 syn W=4u L=1u
Menable1_29 n_enable1_29 learn 0 0 nch W=1000u L=1u
Mutail1_29 n_utail1_29 n_hv29 n_enable1_29 0 nch W=20u L=1u
Mu1_1_29 n_up1_29 n_az1 n_utail1_29 0 nch W=20u L=1u
Mu2_1_29 n_w1_29 n_error1 n_utail1_29 0 nch W=20u L=1u
Mu3_1_29 n_up1_29 n_up1_29 vdd vdd pch W=60u L=1u
Mu4_1_29 n_w1_29 n_up1_29 vdd vdd pch W=60u L=1u
Rinit1_30hi reset n_init1_30 424.819157743
Rinit1_30lo n_init1_30 0 575.180842257
Cw1_30 n_w1_30 0 5e-06
Mreset1_30 n_init1_30 reset n_w1_30 0 syn W=1000u L=1u
Mpos1_30 n_hv30 n_w1_30 n_op1 0 syn W=4u L=1u
Mneg1_30 n_hv30 vweight n_on1 0 syn W=4u L=1u
Menable1_30 n_enable1_30 learn 0 0 nch W=1000u L=1u
Mutail1_30 n_utail1_30 n_hv30 n_enable1_30 0 nch W=20u L=1u
Mu1_1_30 n_up1_30 n_az1 n_utail1_30 0 nch W=20u L=1u
Mu2_1_30 n_w1_30 n_error1 n_utail1_30 0 nch W=20u L=1u
Mu3_1_30 n_up1_30 n_up1_30 vdd vdd pch W=60u L=1u
Mu4_1_30 n_w1_30 n_up1_30 vdd vdd pch W=60u L=1u
Rinit1_31hi reset n_init1_31 416.051657977
Rinit1_31lo n_init1_31 0 583.948342023
Cw1_31 n_w1_31 0 5e-06
Mreset1_31 n_init1_31 reset n_w1_31 0 syn W=1000u L=1u
Mpos1_31 n_hv31 n_w1_31 n_op1 0 syn W=4u L=1u
Mneg1_31 n_hv31 vweight n_on1 0 syn W=4u L=1u
Menable1_31 n_enable1_31 learn 0 0 nch W=1000u L=1u
Mutail1_31 n_utail1_31 n_hv31 n_enable1_31 0 nch W=20u L=1u
Mu1_1_31 n_up1_31 n_az1 n_utail1_31 0 nch W=20u L=1u
Mu2_1_31 n_w1_31 n_error1 n_utail1_31 0 nch W=20u L=1u
Mu3_1_31 n_up1_31 n_up1_31 vdd vdd pch W=60u L=1u
Mu4_1_31 n_w1_31 n_up1_31 vdd vdd pch W=60u L=1u
Rinit1_32hi reset n_init1_32 384.693241929
Rinit1_32lo n_init1_32 0 615.306758071
Cw1_32 n_w1_32 0 5e-06
Mreset1_32 n_init1_32 reset n_w1_32 0 syn W=1000u L=1u
Mpos1_32 n_hv32 n_w1_32 n_op1 0 syn W=4u L=1u
Mneg1_32 n_hv32 vweight n_on1 0 syn W=4u L=1u
Menable1_32 n_enable1_32 learn 0 0 nch W=1000u L=1u
Mutail1_32 n_utail1_32 n_hv32 n_enable1_32 0 nch W=20u L=1u
Mu1_1_32 n_up1_32 n_az1 n_utail1_32 0 nch W=20u L=1u
Mu2_1_32 n_w1_32 n_error1 n_utail1_32 0 nch W=20u L=1u
Mu3_1_32 n_up1_32 n_up1_32 vdd vdd pch W=60u L=1u
Mu4_1_32 n_w1_32 n_up1_32 vdd vdd pch W=60u L=1u
Rinit1_33hi reset n_init1_33 439.559433734
Rinit1_33lo n_init1_33 0 560.440566266
Cw1_33 n_w1_33 0 5e-06
Mreset1_33 n_init1_33 reset n_w1_33 0 syn W=1000u L=1u
Mpos1_33 n_hv33 n_w1_33 n_op1 0 syn W=4u L=1u
Mneg1_33 n_hv33 vweight n_on1 0 syn W=4u L=1u
Menable1_33 n_enable1_33 learn 0 0 nch W=1000u L=1u
Mutail1_33 n_utail1_33 n_hv33 n_enable1_33 0 nch W=20u L=1u
Mu1_1_33 n_up1_33 n_az1 n_utail1_33 0 nch W=20u L=1u
Mu2_1_33 n_w1_33 n_error1 n_utail1_33 0 nch W=20u L=1u
Mu3_1_33 n_up1_33 n_up1_33 vdd vdd pch W=60u L=1u
Mu4_1_33 n_w1_33 n_up1_33 vdd vdd pch W=60u L=1u
Rinit1_34hi reset n_init1_34 430.396428214
Rinit1_34lo n_init1_34 0 569.603571786
Cw1_34 n_w1_34 0 5e-06
Mreset1_34 n_init1_34 reset n_w1_34 0 syn W=1000u L=1u
Mpos1_34 n_hv34 n_w1_34 n_op1 0 syn W=4u L=1u
Mneg1_34 n_hv34 vweight n_on1 0 syn W=4u L=1u
Menable1_34 n_enable1_34 learn 0 0 nch W=1000u L=1u
Mutail1_34 n_utail1_34 n_hv34 n_enable1_34 0 nch W=20u L=1u
Mu1_1_34 n_up1_34 n_az1 n_utail1_34 0 nch W=20u L=1u
Mu2_1_34 n_w1_34 n_error1 n_utail1_34 0 nch W=20u L=1u
Mu3_1_34 n_up1_34 n_up1_34 vdd vdd pch W=60u L=1u
Mu4_1_34 n_w1_34 n_up1_34 vdd vdd pch W=60u L=1u
Rinit1_35hi reset n_init1_35 415.78770905
Rinit1_35lo n_init1_35 0 584.21229095
Cw1_35 n_w1_35 0 5e-06
Mreset1_35 n_init1_35 reset n_w1_35 0 syn W=1000u L=1u
Mpos1_35 n_hv35 n_w1_35 n_op1 0 syn W=4u L=1u
Mneg1_35 n_hv35 vweight n_on1 0 syn W=4u L=1u
Menable1_35 n_enable1_35 learn 0 0 nch W=1000u L=1u
Mutail1_35 n_utail1_35 n_hv35 n_enable1_35 0 nch W=20u L=1u
Mu1_1_35 n_up1_35 n_az1 n_utail1_35 0 nch W=20u L=1u
Mu2_1_35 n_w1_35 n_error1 n_utail1_35 0 nch W=20u L=1u
Mu3_1_35 n_up1_35 n_up1_35 vdd vdd pch W=60u L=1u
Mu4_1_35 n_w1_35 n_up1_35 vdd vdd pch W=60u L=1u
Rinit1_36hi reset n_init1_36 369.024691585
Rinit1_36lo n_init1_36 0 630.975308415
Cw1_36 n_w1_36 0 5e-06
Mreset1_36 n_init1_36 reset n_w1_36 0 syn W=1000u L=1u
Mpos1_36 n_hv36 n_w1_36 n_op1 0 syn W=4u L=1u
Mneg1_36 n_hv36 vweight n_on1 0 syn W=4u L=1u
Menable1_36 n_enable1_36 learn 0 0 nch W=1000u L=1u
Mutail1_36 n_utail1_36 n_hv36 n_enable1_36 0 nch W=20u L=1u
Mu1_1_36 n_up1_36 n_az1 n_utail1_36 0 nch W=20u L=1u
Mu2_1_36 n_w1_36 n_error1 n_utail1_36 0 nch W=20u L=1u
Mu3_1_36 n_up1_36 n_up1_36 vdd vdd pch W=60u L=1u
Mu4_1_36 n_w1_36 n_up1_36 vdd vdd pch W=60u L=1u
Rinit1_37hi reset n_init1_37 380.251164844
Rinit1_37lo n_init1_37 0 619.748835156
Cw1_37 n_w1_37 0 5e-06
Mreset1_37 n_init1_37 reset n_w1_37 0 syn W=1000u L=1u
Mpos1_37 n_hv37 n_w1_37 n_op1 0 syn W=4u L=1u
Mneg1_37 n_hv37 vweight n_on1 0 syn W=4u L=1u
Menable1_37 n_enable1_37 learn 0 0 nch W=1000u L=1u
Mutail1_37 n_utail1_37 n_hv37 n_enable1_37 0 nch W=20u L=1u
Mu1_1_37 n_up1_37 n_az1 n_utail1_37 0 nch W=20u L=1u
Mu2_1_37 n_w1_37 n_error1 n_utail1_37 0 nch W=20u L=1u
Mu3_1_37 n_up1_37 n_up1_37 vdd vdd pch W=60u L=1u
Mu4_1_37 n_w1_37 n_up1_37 vdd vdd pch W=60u L=1u
Rinit1_38hi reset n_init1_38 362.336661949
Rinit1_38lo n_init1_38 0 637.663338051
Cw1_38 n_w1_38 0 5e-06
Mreset1_38 n_init1_38 reset n_w1_38 0 syn W=1000u L=1u
Mpos1_38 n_hv38 n_w1_38 n_op1 0 syn W=4u L=1u
Mneg1_38 n_hv38 vweight n_on1 0 syn W=4u L=1u
Menable1_38 n_enable1_38 learn 0 0 nch W=1000u L=1u
Mutail1_38 n_utail1_38 n_hv38 n_enable1_38 0 nch W=20u L=1u
Mu1_1_38 n_up1_38 n_az1 n_utail1_38 0 nch W=20u L=1u
Mu2_1_38 n_w1_38 n_error1 n_utail1_38 0 nch W=20u L=1u
Mu3_1_38 n_up1_38 n_up1_38 vdd vdd pch W=60u L=1u
Mu4_1_38 n_w1_38 n_up1_38 vdd vdd pch W=60u L=1u
Rinit1_39hi reset n_init1_39 396.557700846
Rinit1_39lo n_init1_39 0 603.442299154
Cw1_39 n_w1_39 0 5e-06
Mreset1_39 n_init1_39 reset n_w1_39 0 syn W=1000u L=1u
Mpos1_39 n_hv39 n_w1_39 n_op1 0 syn W=4u L=1u
Mneg1_39 n_hv39 vweight n_on1 0 syn W=4u L=1u
Menable1_39 n_enable1_39 learn 0 0 nch W=1000u L=1u
Mutail1_39 n_utail1_39 n_hv39 n_enable1_39 0 nch W=20u L=1u
Mu1_1_39 n_up1_39 n_az1 n_utail1_39 0 nch W=20u L=1u
Mu2_1_39 n_w1_39 n_error1 n_utail1_39 0 nch W=20u L=1u
Mu3_1_39 n_up1_39 n_up1_39 vdd vdd pch W=60u L=1u
Mu4_1_39 n_w1_39 n_up1_39 vdd vdd pch W=60u L=1u
Rinit1_40hi reset n_init1_40 394.242541794
Rinit1_40lo n_init1_40 0 605.757458206
Cw1_40 n_w1_40 0 5e-06
Mreset1_40 n_init1_40 reset n_w1_40 0 syn W=1000u L=1u
Mpos1_40 n_hv40 n_w1_40 n_op1 0 syn W=4u L=1u
Mneg1_40 n_hv40 vweight n_on1 0 syn W=4u L=1u
Menable1_40 n_enable1_40 learn 0 0 nch W=1000u L=1u
Mutail1_40 n_utail1_40 n_hv40 n_enable1_40 0 nch W=20u L=1u
Mu1_1_40 n_up1_40 n_az1 n_utail1_40 0 nch W=20u L=1u
Mu2_1_40 n_w1_40 n_error1 n_utail1_40 0 nch W=20u L=1u
Mu3_1_40 n_up1_40 n_up1_40 vdd vdd pch W=60u L=1u
Mu4_1_40 n_w1_40 n_up1_40 vdd vdd pch W=60u L=1u
Rinit1_41hi reset n_init1_41 395.889855455
Rinit1_41lo n_init1_41 0 604.110144545
Cw1_41 n_w1_41 0 5e-06
Mreset1_41 n_init1_41 reset n_w1_41 0 syn W=1000u L=1u
Mpos1_41 n_hv41 n_w1_41 n_op1 0 syn W=4u L=1u
Mneg1_41 n_hv41 vweight n_on1 0 syn W=4u L=1u
Menable1_41 n_enable1_41 learn 0 0 nch W=1000u L=1u
Mutail1_41 n_utail1_41 n_hv41 n_enable1_41 0 nch W=20u L=1u
Mu1_1_41 n_up1_41 n_az1 n_utail1_41 0 nch W=20u L=1u
Mu2_1_41 n_w1_41 n_error1 n_utail1_41 0 nch W=20u L=1u
Mu3_1_41 n_up1_41 n_up1_41 vdd vdd pch W=60u L=1u
Mu4_1_41 n_w1_41 n_up1_41 vdd vdd pch W=60u L=1u
Rinit1_42hi reset n_init1_42 397.949822896
Rinit1_42lo n_init1_42 0 602.050177104
Cw1_42 n_w1_42 0 5e-06
Mreset1_42 n_init1_42 reset n_w1_42 0 syn W=1000u L=1u
Mpos1_42 n_hv42 n_w1_42 n_op1 0 syn W=4u L=1u
Mneg1_42 n_hv42 vweight n_on1 0 syn W=4u L=1u
Menable1_42 n_enable1_42 learn 0 0 nch W=1000u L=1u
Mutail1_42 n_utail1_42 n_hv42 n_enable1_42 0 nch W=20u L=1u
Mu1_1_42 n_up1_42 n_az1 n_utail1_42 0 nch W=20u L=1u
Mu2_1_42 n_w1_42 n_error1 n_utail1_42 0 nch W=20u L=1u
Mu3_1_42 n_up1_42 n_up1_42 vdd vdd pch W=60u L=1u
Mu4_1_42 n_w1_42 n_up1_42 vdd vdd pch W=60u L=1u
Rinit1_43hi reset n_init1_43 396.63675431
Rinit1_43lo n_init1_43 0 603.36324569
Cw1_43 n_w1_43 0 5e-06
Mreset1_43 n_init1_43 reset n_w1_43 0 syn W=1000u L=1u
Mpos1_43 n_hv43 n_w1_43 n_op1 0 syn W=4u L=1u
Mneg1_43 n_hv43 vweight n_on1 0 syn W=4u L=1u
Menable1_43 n_enable1_43 learn 0 0 nch W=1000u L=1u
Mutail1_43 n_utail1_43 n_hv43 n_enable1_43 0 nch W=20u L=1u
Mu1_1_43 n_up1_43 n_az1 n_utail1_43 0 nch W=20u L=1u
Mu2_1_43 n_w1_43 n_error1 n_utail1_43 0 nch W=20u L=1u
Mu3_1_43 n_up1_43 n_up1_43 vdd vdd pch W=60u L=1u
Mu4_1_43 n_w1_43 n_up1_43 vdd vdd pch W=60u L=1u
Rinit1_44hi reset n_init1_44 374.51459591
Rinit1_44lo n_init1_44 0 625.48540409
Cw1_44 n_w1_44 0 5e-06
Mreset1_44 n_init1_44 reset n_w1_44 0 syn W=1000u L=1u
Mpos1_44 n_hv44 n_w1_44 n_op1 0 syn W=4u L=1u
Mneg1_44 n_hv44 vweight n_on1 0 syn W=4u L=1u
Menable1_44 n_enable1_44 learn 0 0 nch W=1000u L=1u
Mutail1_44 n_utail1_44 n_hv44 n_enable1_44 0 nch W=20u L=1u
Mu1_1_44 n_up1_44 n_az1 n_utail1_44 0 nch W=20u L=1u
Mu2_1_44 n_w1_44 n_error1 n_utail1_44 0 nch W=20u L=1u
Mu3_1_44 n_up1_44 n_up1_44 vdd vdd pch W=60u L=1u
Mu4_1_44 n_w1_44 n_up1_44 vdd vdd pch W=60u L=1u
Rinit1_45hi reset n_init1_45 363.730501224
Rinit1_45lo n_init1_45 0 636.269498776
Cw1_45 n_w1_45 0 5e-06
Mreset1_45 n_init1_45 reset n_w1_45 0 syn W=1000u L=1u
Mpos1_45 n_hv45 n_w1_45 n_op1 0 syn W=4u L=1u
Mneg1_45 n_hv45 vweight n_on1 0 syn W=4u L=1u
Menable1_45 n_enable1_45 learn 0 0 nch W=1000u L=1u
Mutail1_45 n_utail1_45 n_hv45 n_enable1_45 0 nch W=20u L=1u
Mu1_1_45 n_up1_45 n_az1 n_utail1_45 0 nch W=20u L=1u
Mu2_1_45 n_w1_45 n_error1 n_utail1_45 0 nch W=20u L=1u
Mu3_1_45 n_up1_45 n_up1_45 vdd vdd pch W=60u L=1u
Mu4_1_45 n_w1_45 n_up1_45 vdd vdd pch W=60u L=1u
Rinit1_46hi reset n_init1_46 407.335938452
Rinit1_46lo n_init1_46 0 592.664061548
Cw1_46 n_w1_46 0 5e-06
Mreset1_46 n_init1_46 reset n_w1_46 0 syn W=1000u L=1u
Mpos1_46 n_hv46 n_w1_46 n_op1 0 syn W=4u L=1u
Mneg1_46 n_hv46 vweight n_on1 0 syn W=4u L=1u
Menable1_46 n_enable1_46 learn 0 0 nch W=1000u L=1u
Mutail1_46 n_utail1_46 n_hv46 n_enable1_46 0 nch W=20u L=1u
Mu1_1_46 n_up1_46 n_az1 n_utail1_46 0 nch W=20u L=1u
Mu2_1_46 n_w1_46 n_error1 n_utail1_46 0 nch W=20u L=1u
Mu3_1_46 n_up1_46 n_up1_46 vdd vdd pch W=60u L=1u
Mu4_1_46 n_w1_46 n_up1_46 vdd vdd pch W=60u L=1u
Rinit1_47hi reset n_init1_47 389.602780592
Rinit1_47lo n_init1_47 0 610.397219408
Cw1_47 n_w1_47 0 5e-06
Mreset1_47 n_init1_47 reset n_w1_47 0 syn W=1000u L=1u
Mpos1_47 n_hv47 n_w1_47 n_op1 0 syn W=4u L=1u
Mneg1_47 n_hv47 vweight n_on1 0 syn W=4u L=1u
Menable1_47 n_enable1_47 learn 0 0 nch W=1000u L=1u
Mutail1_47 n_utail1_47 n_hv47 n_enable1_47 0 nch W=20u L=1u
Mu1_1_47 n_up1_47 n_az1 n_utail1_47 0 nch W=20u L=1u
Mu2_1_47 n_w1_47 n_error1 n_utail1_47 0 nch W=20u L=1u
Mu3_1_47 n_up1_47 n_up1_47 vdd vdd pch W=60u L=1u
Mu4_1_47 n_w1_47 n_up1_47 vdd vdd pch W=60u L=1u
Rinit1_48hi reset n_init1_48 415.379247396
Rinit1_48lo n_init1_48 0 584.620752604
Cw1_48 n_w1_48 0 5e-06
Mreset1_48 n_init1_48 reset n_w1_48 0 syn W=1000u L=1u
Mpos1_48 n_hv48 n_w1_48 n_op1 0 syn W=4u L=1u
Mneg1_48 n_hv48 vweight n_on1 0 syn W=4u L=1u
Menable1_48 n_enable1_48 learn 0 0 nch W=1000u L=1u
Mutail1_48 n_utail1_48 n_hv48 n_enable1_48 0 nch W=20u L=1u
Mu1_1_48 n_up1_48 n_az1 n_utail1_48 0 nch W=20u L=1u
Mu2_1_48 n_w1_48 n_error1 n_utail1_48 0 nch W=20u L=1u
Mu3_1_48 n_up1_48 n_up1_48 vdd vdd pch W=60u L=1u
Mu4_1_48 n_w1_48 n_up1_48 vdd vdd pch W=60u L=1u
Rinit1_49hi reset n_init1_49 415.847169083
Rinit1_49lo n_init1_49 0 584.152830917
Cw1_49 n_w1_49 0 5e-06
Mreset1_49 n_init1_49 reset n_w1_49 0 syn W=1000u L=1u
Mpos1_49 n_hv49 n_w1_49 n_op1 0 syn W=4u L=1u
Mneg1_49 n_hv49 vweight n_on1 0 syn W=4u L=1u
Menable1_49 n_enable1_49 learn 0 0 nch W=1000u L=1u
Mutail1_49 n_utail1_49 n_hv49 n_enable1_49 0 nch W=20u L=1u
Mu1_1_49 n_up1_49 n_az1 n_utail1_49 0 nch W=20u L=1u
Mu2_1_49 n_w1_49 n_error1 n_utail1_49 0 nch W=20u L=1u
Mu3_1_49 n_up1_49 n_up1_49 vdd vdd pch W=60u L=1u
Mu4_1_49 n_w1_49 n_up1_49 vdd vdd pch W=60u L=1u
Rinit1_50hi reset n_init1_50 399.494611952
Rinit1_50lo n_init1_50 0 600.505388048
Cw1_50 n_w1_50 0 5e-06
Mreset1_50 n_init1_50 reset n_w1_50 0 syn W=1000u L=1u
Mpos1_50 n_hv50 n_w1_50 n_op1 0 syn W=4u L=1u
Mneg1_50 n_hv50 vweight n_on1 0 syn W=4u L=1u
Menable1_50 n_enable1_50 learn 0 0 nch W=1000u L=1u
Mutail1_50 n_utail1_50 n_hv50 n_enable1_50 0 nch W=20u L=1u
Mu1_1_50 n_up1_50 n_az1 n_utail1_50 0 nch W=20u L=1u
Mu2_1_50 n_w1_50 n_error1 n_utail1_50 0 nch W=20u L=1u
Mu3_1_50 n_up1_50 n_up1_50 vdd vdd pch W=60u L=1u
Mu4_1_50 n_w1_50 n_up1_50 vdd vdd pch W=60u L=1u
Rinit1_51hi reset n_init1_51 393.09858731
Rinit1_51lo n_init1_51 0 606.90141269
Cw1_51 n_w1_51 0 5e-06
Mreset1_51 n_init1_51 reset n_w1_51 0 syn W=1000u L=1u
Mpos1_51 n_hv51 n_w1_51 n_op1 0 syn W=4u L=1u
Mneg1_51 n_hv51 vweight n_on1 0 syn W=4u L=1u
Menable1_51 n_enable1_51 learn 0 0 nch W=1000u L=1u
Mutail1_51 n_utail1_51 n_hv51 n_enable1_51 0 nch W=20u L=1u
Mu1_1_51 n_up1_51 n_az1 n_utail1_51 0 nch W=20u L=1u
Mu2_1_51 n_w1_51 n_error1 n_utail1_51 0 nch W=20u L=1u
Mu3_1_51 n_up1_51 n_up1_51 vdd vdd pch W=60u L=1u
Mu4_1_51 n_w1_51 n_up1_51 vdd vdd pch W=60u L=1u
Rinit1_52hi reset n_init1_52 396.00044264
Rinit1_52lo n_init1_52 0 603.99955736
Cw1_52 n_w1_52 0 5e-06
Mreset1_52 n_init1_52 reset n_w1_52 0 syn W=1000u L=1u
Mpos1_52 n_hv52 n_w1_52 n_op1 0 syn W=4u L=1u
Mneg1_52 n_hv52 vweight n_on1 0 syn W=4u L=1u
Menable1_52 n_enable1_52 learn 0 0 nch W=1000u L=1u
Mutail1_52 n_utail1_52 n_hv52 n_enable1_52 0 nch W=20u L=1u
Mu1_1_52 n_up1_52 n_az1 n_utail1_52 0 nch W=20u L=1u
Mu2_1_52 n_w1_52 n_error1 n_utail1_52 0 nch W=20u L=1u
Mu3_1_52 n_up1_52 n_up1_52 vdd vdd pch W=60u L=1u
Mu4_1_52 n_w1_52 n_up1_52 vdd vdd pch W=60u L=1u
Rinit1_53hi reset n_init1_53 361.873623744
Rinit1_53lo n_init1_53 0 638.126376256
Cw1_53 n_w1_53 0 5e-06
Mreset1_53 n_init1_53 reset n_w1_53 0 syn W=1000u L=1u
Mpos1_53 n_hv53 n_w1_53 n_op1 0 syn W=4u L=1u
Mneg1_53 n_hv53 vweight n_on1 0 syn W=4u L=1u
Menable1_53 n_enable1_53 learn 0 0 nch W=1000u L=1u
Mutail1_53 n_utail1_53 n_hv53 n_enable1_53 0 nch W=20u L=1u
Mu1_1_53 n_up1_53 n_az1 n_utail1_53 0 nch W=20u L=1u
Mu2_1_53 n_w1_53 n_error1 n_utail1_53 0 nch W=20u L=1u
Mu3_1_53 n_up1_53 n_up1_53 vdd vdd pch W=60u L=1u
Mu4_1_53 n_w1_53 n_up1_53 vdd vdd pch W=60u L=1u
Rinit1_54hi reset n_init1_54 426.962300984
Rinit1_54lo n_init1_54 0 573.037699016
Cw1_54 n_w1_54 0 5e-06
Mreset1_54 n_init1_54 reset n_w1_54 0 syn W=1000u L=1u
Mpos1_54 n_hv54 n_w1_54 n_op1 0 syn W=4u L=1u
Mneg1_54 n_hv54 vweight n_on1 0 syn W=4u L=1u
Menable1_54 n_enable1_54 learn 0 0 nch W=1000u L=1u
Mutail1_54 n_utail1_54 n_hv54 n_enable1_54 0 nch W=20u L=1u
Mu1_1_54 n_up1_54 n_az1 n_utail1_54 0 nch W=20u L=1u
Mu2_1_54 n_w1_54 n_error1 n_utail1_54 0 nch W=20u L=1u
Mu3_1_54 n_up1_54 n_up1_54 vdd vdd pch W=60u L=1u
Mu4_1_54 n_w1_54 n_up1_54 vdd vdd pch W=60u L=1u
Rinit1_55hi reset n_init1_55 389.066846961
Rinit1_55lo n_init1_55 0 610.933153039
Cw1_55 n_w1_55 0 5e-06
Mreset1_55 n_init1_55 reset n_w1_55 0 syn W=1000u L=1u
Mpos1_55 n_hv55 n_w1_55 n_op1 0 syn W=4u L=1u
Mneg1_55 n_hv55 vweight n_on1 0 syn W=4u L=1u
Menable1_55 n_enable1_55 learn 0 0 nch W=1000u L=1u
Mutail1_55 n_utail1_55 n_hv55 n_enable1_55 0 nch W=20u L=1u
Mu1_1_55 n_up1_55 n_az1 n_utail1_55 0 nch W=20u L=1u
Mu2_1_55 n_w1_55 n_error1 n_utail1_55 0 nch W=20u L=1u
Mu3_1_55 n_up1_55 n_up1_55 vdd vdd pch W=60u L=1u
Mu4_1_55 n_w1_55 n_up1_55 vdd vdd pch W=60u L=1u
Rinit1_56hi reset n_init1_56 360.437519297
Rinit1_56lo n_init1_56 0 639.562480703
Cw1_56 n_w1_56 0 5e-06
Mreset1_56 n_init1_56 reset n_w1_56 0 syn W=1000u L=1u
Mpos1_56 n_hv56 n_w1_56 n_op1 0 syn W=4u L=1u
Mneg1_56 n_hv56 vweight n_on1 0 syn W=4u L=1u
Menable1_56 n_enable1_56 learn 0 0 nch W=1000u L=1u
Mutail1_56 n_utail1_56 n_hv56 n_enable1_56 0 nch W=20u L=1u
Mu1_1_56 n_up1_56 n_az1 n_utail1_56 0 nch W=20u L=1u
Mu2_1_56 n_w1_56 n_error1 n_utail1_56 0 nch W=20u L=1u
Mu3_1_56 n_up1_56 n_up1_56 vdd vdd pch W=60u L=1u
Mu4_1_56 n_w1_56 n_up1_56 vdd vdd pch W=60u L=1u
Rinit1_57hi reset n_init1_57 381.109177076
Rinit1_57lo n_init1_57 0 618.890822924
Cw1_57 n_w1_57 0 5e-06
Mreset1_57 n_init1_57 reset n_w1_57 0 syn W=1000u L=1u
Mpos1_57 n_hv57 n_w1_57 n_op1 0 syn W=4u L=1u
Mneg1_57 n_hv57 vweight n_on1 0 syn W=4u L=1u
Menable1_57 n_enable1_57 learn 0 0 nch W=1000u L=1u
Mutail1_57 n_utail1_57 n_hv57 n_enable1_57 0 nch W=20u L=1u
Mu1_1_57 n_up1_57 n_az1 n_utail1_57 0 nch W=20u L=1u
Mu2_1_57 n_w1_57 n_error1 n_utail1_57 0 nch W=20u L=1u
Mu3_1_57 n_up1_57 n_up1_57 vdd vdd pch W=60u L=1u
Mu4_1_57 n_w1_57 n_up1_57 vdd vdd pch W=60u L=1u
Rinit1_58hi reset n_init1_58 394.727318861
Rinit1_58lo n_init1_58 0 605.272681139
Cw1_58 n_w1_58 0 5e-06
Mreset1_58 n_init1_58 reset n_w1_58 0 syn W=1000u L=1u
Mpos1_58 n_hv58 n_w1_58 n_op1 0 syn W=4u L=1u
Mneg1_58 n_hv58 vweight n_on1 0 syn W=4u L=1u
Menable1_58 n_enable1_58 learn 0 0 nch W=1000u L=1u
Mutail1_58 n_utail1_58 n_hv58 n_enable1_58 0 nch W=20u L=1u
Mu1_1_58 n_up1_58 n_az1 n_utail1_58 0 nch W=20u L=1u
Mu2_1_58 n_w1_58 n_error1 n_utail1_58 0 nch W=20u L=1u
Mu3_1_58 n_up1_58 n_up1_58 vdd vdd pch W=60u L=1u
Mu4_1_58 n_w1_58 n_up1_58 vdd vdd pch W=60u L=1u
Rinit1_59hi reset n_init1_59 410.530947792
Rinit1_59lo n_init1_59 0 589.469052208
Cw1_59 n_w1_59 0 5e-06
Mreset1_59 n_init1_59 reset n_w1_59 0 syn W=1000u L=1u
Mpos1_59 n_hv59 n_w1_59 n_op1 0 syn W=4u L=1u
Mneg1_59 n_hv59 vweight n_on1 0 syn W=4u L=1u
Menable1_59 n_enable1_59 learn 0 0 nch W=1000u L=1u
Mutail1_59 n_utail1_59 n_hv59 n_enable1_59 0 nch W=20u L=1u
Mu1_1_59 n_up1_59 n_az1 n_utail1_59 0 nch W=20u L=1u
Mu2_1_59 n_w1_59 n_error1 n_utail1_59 0 nch W=20u L=1u
Mu3_1_59 n_up1_59 n_up1_59 vdd vdd pch W=60u L=1u
Mu4_1_59 n_w1_59 n_up1_59 vdd vdd pch W=60u L=1u
Rinit1_60hi reset n_init1_60 407.828889321
Rinit1_60lo n_init1_60 0 592.171110679
Cw1_60 n_w1_60 0 5e-06
Mreset1_60 n_init1_60 reset n_w1_60 0 syn W=1000u L=1u
Mpos1_60 n_hv60 n_w1_60 n_op1 0 syn W=4u L=1u
Mneg1_60 n_hv60 vweight n_on1 0 syn W=4u L=1u
Menable1_60 n_enable1_60 learn 0 0 nch W=1000u L=1u
Mutail1_60 n_utail1_60 n_hv60 n_enable1_60 0 nch W=20u L=1u
Mu1_1_60 n_up1_60 n_az1 n_utail1_60 0 nch W=20u L=1u
Mu2_1_60 n_w1_60 n_error1 n_utail1_60 0 nch W=20u L=1u
Mu3_1_60 n_up1_60 n_up1_60 vdd vdd pch W=60u L=1u
Mu4_1_60 n_w1_60 n_up1_60 vdd vdd pch W=60u L=1u
Rinit1_61hi reset n_init1_61 365.078152621
Rinit1_61lo n_init1_61 0 634.921847379
Cw1_61 n_w1_61 0 5e-06
Mreset1_61 n_init1_61 reset n_w1_61 0 syn W=1000u L=1u
Mpos1_61 n_hv61 n_w1_61 n_op1 0 syn W=4u L=1u
Mneg1_61 n_hv61 vweight n_on1 0 syn W=4u L=1u
Menable1_61 n_enable1_61 learn 0 0 nch W=1000u L=1u
Mutail1_61 n_utail1_61 n_hv61 n_enable1_61 0 nch W=20u L=1u
Mu1_1_61 n_up1_61 n_az1 n_utail1_61 0 nch W=20u L=1u
Mu2_1_61 n_w1_61 n_error1 n_utail1_61 0 nch W=20u L=1u
Mu3_1_61 n_up1_61 n_up1_61 vdd vdd pch W=60u L=1u
Mu4_1_61 n_w1_61 n_up1_61 vdd vdd pch W=60u L=1u
Rinit1_62hi reset n_init1_62 368.373564034
Rinit1_62lo n_init1_62 0 631.626435966
Cw1_62 n_w1_62 0 5e-06
Mreset1_62 n_init1_62 reset n_w1_62 0 syn W=1000u L=1u
Mpos1_62 n_hv62 n_w1_62 n_op1 0 syn W=4u L=1u
Mneg1_62 n_hv62 vweight n_on1 0 syn W=4u L=1u
Menable1_62 n_enable1_62 learn 0 0 nch W=1000u L=1u
Mutail1_62 n_utail1_62 n_hv62 n_enable1_62 0 nch W=20u L=1u
Mu1_1_62 n_up1_62 n_az1 n_utail1_62 0 nch W=20u L=1u
Mu2_1_62 n_w1_62 n_error1 n_utail1_62 0 nch W=20u L=1u
Mu3_1_62 n_up1_62 n_up1_62 vdd vdd pch W=60u L=1u
Mu4_1_62 n_w1_62 n_up1_62 vdd vdd pch W=60u L=1u
Rinit1_63hi reset n_init1_63 386.425896872
Rinit1_63lo n_init1_63 0 613.574103128
Cw1_63 n_w1_63 0 5e-06
Mreset1_63 n_init1_63 reset n_w1_63 0 syn W=1000u L=1u
Mpos1_63 n_hv63 n_w1_63 n_op1 0 syn W=4u L=1u
Mneg1_63 n_hv63 vweight n_on1 0 syn W=4u L=1u
Menable1_63 n_enable1_63 learn 0 0 nch W=1000u L=1u
Mutail1_63 n_utail1_63 n_hv63 n_enable1_63 0 nch W=20u L=1u
Mu1_1_63 n_up1_63 n_az1 n_utail1_63 0 nch W=20u L=1u
Mu2_1_63 n_w1_63 n_error1 n_utail1_63 0 nch W=20u L=1u
Mu3_1_63 n_up1_63 n_up1_63 vdd vdd pch W=60u L=1u
Mu4_1_63 n_w1_63 n_up1_63 vdd vdd pch W=60u L=1u
Rinit1_64hi reset n_init1_64 368.100168651
Rinit1_64lo n_init1_64 0 631.899831349
Cw1_64 n_w1_64 0 5e-06
Mreset1_64 n_init1_64 reset n_w1_64 0 syn W=1000u L=1u
Mpos1_64 n_hv64 n_w1_64 n_op1 0 syn W=4u L=1u
Mneg1_64 n_hv64 vweight n_on1 0 syn W=4u L=1u
Menable1_64 n_enable1_64 learn 0 0 nch W=1000u L=1u
Mutail1_64 n_utail1_64 n_hv64 n_enable1_64 0 nch W=20u L=1u
Mu1_1_64 n_up1_64 n_az1 n_utail1_64 0 nch W=20u L=1u
Mu2_1_64 n_w1_64 n_error1 n_utail1_64 0 nch W=20u L=1u
Mu3_1_64 n_up1_64 n_up1_64 vdd vdd pch W=60u L=1u
Mu4_1_64 n_w1_64 n_up1_64 vdd vdd pch W=60u L=1u
Rinit1_65hi reset n_init1_65 365.986908025
Rinit1_65lo n_init1_65 0 634.013091975
Cw1_65 n_w1_65 0 5e-06
Mreset1_65 n_init1_65 reset n_w1_65 0 syn W=1000u L=1u
Mpos1_65 n_hv65 n_w1_65 n_op1 0 syn W=4u L=1u
Mneg1_65 n_hv65 vweight n_on1 0 syn W=4u L=1u
Menable1_65 n_enable1_65 learn 0 0 nch W=1000u L=1u
Mutail1_65 n_utail1_65 n_hv65 n_enable1_65 0 nch W=20u L=1u
Mu1_1_65 n_up1_65 n_az1 n_utail1_65 0 nch W=20u L=1u
Mu2_1_65 n_w1_65 n_error1 n_utail1_65 0 nch W=20u L=1u
Mu3_1_65 n_up1_65 n_up1_65 vdd vdd pch W=60u L=1u
Mu4_1_65 n_w1_65 n_up1_65 vdd vdd pch W=60u L=1u
Rinit1_66hi reset n_init1_66 372.292514441
Rinit1_66lo n_init1_66 0 627.707485559
Cw1_66 n_w1_66 0 5e-06
Mreset1_66 n_init1_66 reset n_w1_66 0 syn W=1000u L=1u
Mpos1_66 n_hv66 n_w1_66 n_op1 0 syn W=4u L=1u
Mneg1_66 n_hv66 vweight n_on1 0 syn W=4u L=1u
Menable1_66 n_enable1_66 learn 0 0 nch W=1000u L=1u
Mutail1_66 n_utail1_66 n_hv66 n_enable1_66 0 nch W=20u L=1u
Mu1_1_66 n_up1_66 n_az1 n_utail1_66 0 nch W=20u L=1u
Mu2_1_66 n_w1_66 n_error1 n_utail1_66 0 nch W=20u L=1u
Mu3_1_66 n_up1_66 n_up1_66 vdd vdd pch W=60u L=1u
Mu4_1_66 n_w1_66 n_up1_66 vdd vdd pch W=60u L=1u
Rinit1_67hi reset n_init1_67 409.32670458
Rinit1_67lo n_init1_67 0 590.67329542
Cw1_67 n_w1_67 0 5e-06
Mreset1_67 n_init1_67 reset n_w1_67 0 syn W=1000u L=1u
Mpos1_67 n_hv67 n_w1_67 n_op1 0 syn W=4u L=1u
Mneg1_67 n_hv67 vweight n_on1 0 syn W=4u L=1u
Menable1_67 n_enable1_67 learn 0 0 nch W=1000u L=1u
Mutail1_67 n_utail1_67 n_hv67 n_enable1_67 0 nch W=20u L=1u
Mu1_1_67 n_up1_67 n_az1 n_utail1_67 0 nch W=20u L=1u
Mu2_1_67 n_w1_67 n_error1 n_utail1_67 0 nch W=20u L=1u
Mu3_1_67 n_up1_67 n_up1_67 vdd vdd pch W=60u L=1u
Mu4_1_67 n_w1_67 n_up1_67 vdd vdd pch W=60u L=1u
Rinit1_68hi reset n_init1_68 402.850828605
Rinit1_68lo n_init1_68 0 597.149171395
Cw1_68 n_w1_68 0 5e-06
Mreset1_68 n_init1_68 reset n_w1_68 0 syn W=1000u L=1u
Mpos1_68 n_hv68 n_w1_68 n_op1 0 syn W=4u L=1u
Mneg1_68 n_hv68 vweight n_on1 0 syn W=4u L=1u
Menable1_68 n_enable1_68 learn 0 0 nch W=1000u L=1u
Mutail1_68 n_utail1_68 n_hv68 n_enable1_68 0 nch W=20u L=1u
Mu1_1_68 n_up1_68 n_az1 n_utail1_68 0 nch W=20u L=1u
Mu2_1_68 n_w1_68 n_error1 n_utail1_68 0 nch W=20u L=1u
Mu3_1_68 n_up1_68 n_up1_68 vdd vdd pch W=60u L=1u
Mu4_1_68 n_w1_68 n_up1_68 vdd vdd pch W=60u L=1u
Rinit1_69hi reset n_init1_69 376.327399742
Rinit1_69lo n_init1_69 0 623.672600258
Cw1_69 n_w1_69 0 5e-06
Mreset1_69 n_init1_69 reset n_w1_69 0 syn W=1000u L=1u
Mpos1_69 n_hv69 n_w1_69 n_op1 0 syn W=4u L=1u
Mneg1_69 n_hv69 vweight n_on1 0 syn W=4u L=1u
Menable1_69 n_enable1_69 learn 0 0 nch W=1000u L=1u
Mutail1_69 n_utail1_69 n_hv69 n_enable1_69 0 nch W=20u L=1u
Mu1_1_69 n_up1_69 n_az1 n_utail1_69 0 nch W=20u L=1u
Mu2_1_69 n_w1_69 n_error1 n_utail1_69 0 nch W=20u L=1u
Mu3_1_69 n_up1_69 n_up1_69 vdd vdd pch W=60u L=1u
Mu4_1_69 n_w1_69 n_up1_69 vdd vdd pch W=60u L=1u
Rinit1_70hi reset n_init1_70 410.189357617
Rinit1_70lo n_init1_70 0 589.810642383
Cw1_70 n_w1_70 0 5e-06
Mreset1_70 n_init1_70 reset n_w1_70 0 syn W=1000u L=1u
Mpos1_70 n_hv70 n_w1_70 n_op1 0 syn W=4u L=1u
Mneg1_70 n_hv70 vweight n_on1 0 syn W=4u L=1u
Menable1_70 n_enable1_70 learn 0 0 nch W=1000u L=1u
Mutail1_70 n_utail1_70 n_hv70 n_enable1_70 0 nch W=20u L=1u
Mu1_1_70 n_up1_70 n_az1 n_utail1_70 0 nch W=20u L=1u
Mu2_1_70 n_w1_70 n_error1 n_utail1_70 0 nch W=20u L=1u
Mu3_1_70 n_up1_70 n_up1_70 vdd vdd pch W=60u L=1u
Mu4_1_70 n_w1_70 n_up1_70 vdd vdd pch W=60u L=1u
Rinit1_71hi reset n_init1_71 380.050895302
Rinit1_71lo n_init1_71 0 619.949104698
Cw1_71 n_w1_71 0 5e-06
Mreset1_71 n_init1_71 reset n_w1_71 0 syn W=1000u L=1u
Mpos1_71 n_hv71 n_w1_71 n_op1 0 syn W=4u L=1u
Mneg1_71 n_hv71 vweight n_on1 0 syn W=4u L=1u
Menable1_71 n_enable1_71 learn 0 0 nch W=1000u L=1u
Mutail1_71 n_utail1_71 n_hv71 n_enable1_71 0 nch W=20u L=1u
Mu1_1_71 n_up1_71 n_az1 n_utail1_71 0 nch W=20u L=1u
Mu2_1_71 n_w1_71 n_error1 n_utail1_71 0 nch W=20u L=1u
Mu3_1_71 n_up1_71 n_up1_71 vdd vdd pch W=60u L=1u
Mu4_1_71 n_w1_71 n_up1_71 vdd vdd pch W=60u L=1u
Rinit1_72hi reset n_init1_72 401.486369509
Rinit1_72lo n_init1_72 0 598.513630491
Cw1_72 n_w1_72 0 5e-06
Mreset1_72 n_init1_72 reset n_w1_72 0 syn W=1000u L=1u
Mpos1_72 n_hv72 n_w1_72 n_op1 0 syn W=4u L=1u
Mneg1_72 n_hv72 vweight n_on1 0 syn W=4u L=1u
Menable1_72 n_enable1_72 learn 0 0 nch W=1000u L=1u
Mutail1_72 n_utail1_72 n_hv72 n_enable1_72 0 nch W=20u L=1u
Mu1_1_72 n_up1_72 n_az1 n_utail1_72 0 nch W=20u L=1u
Mu2_1_72 n_w1_72 n_error1 n_utail1_72 0 nch W=20u L=1u
Mu3_1_72 n_up1_72 n_up1_72 vdd vdd pch W=60u L=1u
Mu4_1_72 n_w1_72 n_up1_72 vdd vdd pch W=60u L=1u
Rinit1_73hi reset n_init1_73 413.076695568
Rinit1_73lo n_init1_73 0 586.923304432
Cw1_73 n_w1_73 0 5e-06
Mreset1_73 n_init1_73 reset n_w1_73 0 syn W=1000u L=1u
Mpos1_73 n_hv73 n_w1_73 n_op1 0 syn W=4u L=1u
Mneg1_73 n_hv73 vweight n_on1 0 syn W=4u L=1u
Menable1_73 n_enable1_73 learn 0 0 nch W=1000u L=1u
Mutail1_73 n_utail1_73 n_hv73 n_enable1_73 0 nch W=20u L=1u
Mu1_1_73 n_up1_73 n_az1 n_utail1_73 0 nch W=20u L=1u
Mu2_1_73 n_w1_73 n_error1 n_utail1_73 0 nch W=20u L=1u
Mu3_1_73 n_up1_73 n_up1_73 vdd vdd pch W=60u L=1u
Mu4_1_73 n_w1_73 n_up1_73 vdd vdd pch W=60u L=1u
Rinit1_74hi reset n_init1_74 403.508136986
Rinit1_74lo n_init1_74 0 596.491863014
Cw1_74 n_w1_74 0 5e-06
Mreset1_74 n_init1_74 reset n_w1_74 0 syn W=1000u L=1u
Mpos1_74 n_hv74 n_w1_74 n_op1 0 syn W=4u L=1u
Mneg1_74 n_hv74 vweight n_on1 0 syn W=4u L=1u
Menable1_74 n_enable1_74 learn 0 0 nch W=1000u L=1u
Mutail1_74 n_utail1_74 n_hv74 n_enable1_74 0 nch W=20u L=1u
Mu1_1_74 n_up1_74 n_az1 n_utail1_74 0 nch W=20u L=1u
Mu2_1_74 n_w1_74 n_error1 n_utail1_74 0 nch W=20u L=1u
Mu3_1_74 n_up1_74 n_up1_74 vdd vdd pch W=60u L=1u
Mu4_1_74 n_w1_74 n_up1_74 vdd vdd pch W=60u L=1u
Rinit1_75hi reset n_init1_75 430.679243515
Rinit1_75lo n_init1_75 0 569.320756485
Cw1_75 n_w1_75 0 5e-06
Mreset1_75 n_init1_75 reset n_w1_75 0 syn W=1000u L=1u
Mpos1_75 n_hv75 n_w1_75 n_op1 0 syn W=4u L=1u
Mneg1_75 n_hv75 vweight n_on1 0 syn W=4u L=1u
Menable1_75 n_enable1_75 learn 0 0 nch W=1000u L=1u
Mutail1_75 n_utail1_75 n_hv75 n_enable1_75 0 nch W=20u L=1u
Mu1_1_75 n_up1_75 n_az1 n_utail1_75 0 nch W=20u L=1u
Mu2_1_75 n_w1_75 n_error1 n_utail1_75 0 nch W=20u L=1u
Mu3_1_75 n_up1_75 n_up1_75 vdd vdd pch W=60u L=1u
Mu4_1_75 n_w1_75 n_up1_75 vdd vdd pch W=60u L=1u
Rinit1_76hi reset n_init1_76 411.640259537
Rinit1_76lo n_init1_76 0 588.359740463
Cw1_76 n_w1_76 0 5e-06
Mreset1_76 n_init1_76 reset n_w1_76 0 syn W=1000u L=1u
Mpos1_76 n_hv76 n_w1_76 n_op1 0 syn W=4u L=1u
Mneg1_76 n_hv76 vweight n_on1 0 syn W=4u L=1u
Menable1_76 n_enable1_76 learn 0 0 nch W=1000u L=1u
Mutail1_76 n_utail1_76 n_hv76 n_enable1_76 0 nch W=20u L=1u
Mu1_1_76 n_up1_76 n_az1 n_utail1_76 0 nch W=20u L=1u
Mu2_1_76 n_w1_76 n_error1 n_utail1_76 0 nch W=20u L=1u
Mu3_1_76 n_up1_76 n_up1_76 vdd vdd pch W=60u L=1u
Mu4_1_76 n_w1_76 n_up1_76 vdd vdd pch W=60u L=1u
Rinit1_77hi reset n_init1_77 406.784445555
Rinit1_77lo n_init1_77 0 593.215554445
Cw1_77 n_w1_77 0 5e-06
Mreset1_77 n_init1_77 reset n_w1_77 0 syn W=1000u L=1u
Mpos1_77 n_hv77 n_w1_77 n_op1 0 syn W=4u L=1u
Mneg1_77 n_hv77 vweight n_on1 0 syn W=4u L=1u
Menable1_77 n_enable1_77 learn 0 0 nch W=1000u L=1u
Mutail1_77 n_utail1_77 n_hv77 n_enable1_77 0 nch W=20u L=1u
Mu1_1_77 n_up1_77 n_az1 n_utail1_77 0 nch W=20u L=1u
Mu2_1_77 n_w1_77 n_error1 n_utail1_77 0 nch W=20u L=1u
Mu3_1_77 n_up1_77 n_up1_77 vdd vdd pch W=60u L=1u
Mu4_1_77 n_w1_77 n_up1_77 vdd vdd pch W=60u L=1u
Rinit1_78hi reset n_init1_78 438.546913865
Rinit1_78lo n_init1_78 0 561.453086135
Cw1_78 n_w1_78 0 5e-06
Mreset1_78 n_init1_78 reset n_w1_78 0 syn W=1000u L=1u
Mpos1_78 n_hv78 n_w1_78 n_op1 0 syn W=4u L=1u
Mneg1_78 n_hv78 vweight n_on1 0 syn W=4u L=1u
Menable1_78 n_enable1_78 learn 0 0 nch W=1000u L=1u
Mutail1_78 n_utail1_78 n_hv78 n_enable1_78 0 nch W=20u L=1u
Mu1_1_78 n_up1_78 n_az1 n_utail1_78 0 nch W=20u L=1u
Mu2_1_78 n_w1_78 n_error1 n_utail1_78 0 nch W=20u L=1u
Mu3_1_78 n_up1_78 n_up1_78 vdd vdd pch W=60u L=1u
Mu4_1_78 n_w1_78 n_up1_78 vdd vdd pch W=60u L=1u
Rinit1_79hi reset n_init1_79 426.234082094
Rinit1_79lo n_init1_79 0 573.765917906
Cw1_79 n_w1_79 0 5e-06
Mreset1_79 n_init1_79 reset n_w1_79 0 syn W=1000u L=1u
Mpos1_79 n_hv79 n_w1_79 n_op1 0 syn W=4u L=1u
Mneg1_79 n_hv79 vweight n_on1 0 syn W=4u L=1u
Menable1_79 n_enable1_79 learn 0 0 nch W=1000u L=1u
Mutail1_79 n_utail1_79 n_hv79 n_enable1_79 0 nch W=20u L=1u
Mu1_1_79 n_up1_79 n_az1 n_utail1_79 0 nch W=20u L=1u
Mu2_1_79 n_w1_79 n_error1 n_utail1_79 0 nch W=20u L=1u
Mu3_1_79 n_up1_79 n_up1_79 vdd vdd pch W=60u L=1u
Mu4_1_79 n_w1_79 n_up1_79 vdd vdd pch W=60u L=1u
Rinit1_80hi reset n_init1_80 419.181356211
Rinit1_80lo n_init1_80 0 580.818643789
Cw1_80 n_w1_80 0 5e-06
Mreset1_80 n_init1_80 reset n_w1_80 0 syn W=1000u L=1u
Mpos1_80 n_hv80 n_w1_80 n_op1 0 syn W=4u L=1u
Mneg1_80 n_hv80 vweight n_on1 0 syn W=4u L=1u
Menable1_80 n_enable1_80 learn 0 0 nch W=1000u L=1u
Mutail1_80 n_utail1_80 n_hv80 n_enable1_80 0 nch W=20u L=1u
Mu1_1_80 n_up1_80 n_az1 n_utail1_80 0 nch W=20u L=1u
Mu2_1_80 n_w1_80 n_error1 n_utail1_80 0 nch W=20u L=1u
Mu3_1_80 n_up1_80 n_up1_80 vdd vdd pch W=60u L=1u
Mu4_1_80 n_w1_80 n_up1_80 vdd vdd pch W=60u L=1u
Rinit1_81hi reset n_init1_81 371.369277759
Rinit1_81lo n_init1_81 0 628.630722241
Cw1_81 n_w1_81 0 5e-06
Mreset1_81 n_init1_81 reset n_w1_81 0 syn W=1000u L=1u
Mpos1_81 n_hv81 n_w1_81 n_op1 0 syn W=4u L=1u
Mneg1_81 n_hv81 vweight n_on1 0 syn W=4u L=1u
Menable1_81 n_enable1_81 learn 0 0 nch W=1000u L=1u
Mutail1_81 n_utail1_81 n_hv81 n_enable1_81 0 nch W=20u L=1u
Mu1_1_81 n_up1_81 n_az1 n_utail1_81 0 nch W=20u L=1u
Mu2_1_81 n_w1_81 n_error1 n_utail1_81 0 nch W=20u L=1u
Mu3_1_81 n_up1_81 n_up1_81 vdd vdd pch W=60u L=1u
Mu4_1_81 n_w1_81 n_up1_81 vdd vdd pch W=60u L=1u
Rinit1_82hi reset n_init1_82 392.833829054
Rinit1_82lo n_init1_82 0 607.166170946
Cw1_82 n_w1_82 0 5e-06
Mreset1_82 n_init1_82 reset n_w1_82 0 syn W=1000u L=1u
Mpos1_82 n_hv82 n_w1_82 n_op1 0 syn W=4u L=1u
Mneg1_82 n_hv82 vweight n_on1 0 syn W=4u L=1u
Menable1_82 n_enable1_82 learn 0 0 nch W=1000u L=1u
Mutail1_82 n_utail1_82 n_hv82 n_enable1_82 0 nch W=20u L=1u
Mu1_1_82 n_up1_82 n_az1 n_utail1_82 0 nch W=20u L=1u
Mu2_1_82 n_w1_82 n_error1 n_utail1_82 0 nch W=20u L=1u
Mu3_1_82 n_up1_82 n_up1_82 vdd vdd pch W=60u L=1u
Mu4_1_82 n_w1_82 n_up1_82 vdd vdd pch W=60u L=1u
Rinit1_83hi reset n_init1_83 417.028407485
Rinit1_83lo n_init1_83 0 582.971592515
Cw1_83 n_w1_83 0 5e-06
Mreset1_83 n_init1_83 reset n_w1_83 0 syn W=1000u L=1u
Mpos1_83 n_hv83 n_w1_83 n_op1 0 syn W=4u L=1u
Mneg1_83 n_hv83 vweight n_on1 0 syn W=4u L=1u
Menable1_83 n_enable1_83 learn 0 0 nch W=1000u L=1u
Mutail1_83 n_utail1_83 n_hv83 n_enable1_83 0 nch W=20u L=1u
Mu1_1_83 n_up1_83 n_az1 n_utail1_83 0 nch W=20u L=1u
Mu2_1_83 n_w1_83 n_error1 n_utail1_83 0 nch W=20u L=1u
Mu3_1_83 n_up1_83 n_up1_83 vdd vdd pch W=60u L=1u
Mu4_1_83 n_w1_83 n_up1_83 vdd vdd pch W=60u L=1u
Rinit1_84hi reset n_init1_84 360.181864254
Rinit1_84lo n_init1_84 0 639.818135746
Cw1_84 n_w1_84 0 5e-06
Mreset1_84 n_init1_84 reset n_w1_84 0 syn W=1000u L=1u
Mpos1_84 n_hv84 n_w1_84 n_op1 0 syn W=4u L=1u
Mneg1_84 n_hv84 vweight n_on1 0 syn W=4u L=1u
Menable1_84 n_enable1_84 learn 0 0 nch W=1000u L=1u
Mutail1_84 n_utail1_84 n_hv84 n_enable1_84 0 nch W=20u L=1u
Mu1_1_84 n_up1_84 n_az1 n_utail1_84 0 nch W=20u L=1u
Mu2_1_84 n_w1_84 n_error1 n_utail1_84 0 nch W=20u L=1u
Mu3_1_84 n_up1_84 n_up1_84 vdd vdd pch W=60u L=1u
Mu4_1_84 n_w1_84 n_up1_84 vdd vdd pch W=60u L=1u
Rinit1_85hi reset n_init1_85 419.366351998
Rinit1_85lo n_init1_85 0 580.633648002
Cw1_85 n_w1_85 0 5e-06
Mreset1_85 n_init1_85 reset n_w1_85 0 syn W=1000u L=1u
Mpos1_85 n_hv85 n_w1_85 n_op1 0 syn W=4u L=1u
Mneg1_85 n_hv85 vweight n_on1 0 syn W=4u L=1u
Menable1_85 n_enable1_85 learn 0 0 nch W=1000u L=1u
Mutail1_85 n_utail1_85 n_hv85 n_enable1_85 0 nch W=20u L=1u
Mu1_1_85 n_up1_85 n_az1 n_utail1_85 0 nch W=20u L=1u
Mu2_1_85 n_w1_85 n_error1 n_utail1_85 0 nch W=20u L=1u
Mu3_1_85 n_up1_85 n_up1_85 vdd vdd pch W=60u L=1u
Mu4_1_85 n_w1_85 n_up1_85 vdd vdd pch W=60u L=1u
Rinit1_86hi reset n_init1_86 398.896933027
Rinit1_86lo n_init1_86 0 601.103066973
Cw1_86 n_w1_86 0 5e-06
Mreset1_86 n_init1_86 reset n_w1_86 0 syn W=1000u L=1u
Mpos1_86 n_hv86 n_w1_86 n_op1 0 syn W=4u L=1u
Mneg1_86 n_hv86 vweight n_on1 0 syn W=4u L=1u
Menable1_86 n_enable1_86 learn 0 0 nch W=1000u L=1u
Mutail1_86 n_utail1_86 n_hv86 n_enable1_86 0 nch W=20u L=1u
Mu1_1_86 n_up1_86 n_az1 n_utail1_86 0 nch W=20u L=1u
Mu2_1_86 n_w1_86 n_error1 n_utail1_86 0 nch W=20u L=1u
Mu3_1_86 n_up1_86 n_up1_86 vdd vdd pch W=60u L=1u
Mu4_1_86 n_w1_86 n_up1_86 vdd vdd pch W=60u L=1u
Rinit1_87hi reset n_init1_87 380.83841716
Rinit1_87lo n_init1_87 0 619.16158284
Cw1_87 n_w1_87 0 5e-06
Mreset1_87 n_init1_87 reset n_w1_87 0 syn W=1000u L=1u
Mpos1_87 n_hv87 n_w1_87 n_op1 0 syn W=4u L=1u
Mneg1_87 n_hv87 vweight n_on1 0 syn W=4u L=1u
Menable1_87 n_enable1_87 learn 0 0 nch W=1000u L=1u
Mutail1_87 n_utail1_87 n_hv87 n_enable1_87 0 nch W=20u L=1u
Mu1_1_87 n_up1_87 n_az1 n_utail1_87 0 nch W=20u L=1u
Mu2_1_87 n_w1_87 n_error1 n_utail1_87 0 nch W=20u L=1u
Mu3_1_87 n_up1_87 n_up1_87 vdd vdd pch W=60u L=1u
Mu4_1_87 n_w1_87 n_up1_87 vdd vdd pch W=60u L=1u
Rinit1_88hi reset n_init1_88 384.694356755
Rinit1_88lo n_init1_88 0 615.305643245
Cw1_88 n_w1_88 0 5e-06
Mreset1_88 n_init1_88 reset n_w1_88 0 syn W=1000u L=1u
Mpos1_88 n_hv88 n_w1_88 n_op1 0 syn W=4u L=1u
Mneg1_88 n_hv88 vweight n_on1 0 syn W=4u L=1u
Menable1_88 n_enable1_88 learn 0 0 nch W=1000u L=1u
Mutail1_88 n_utail1_88 n_hv88 n_enable1_88 0 nch W=20u L=1u
Mu1_1_88 n_up1_88 n_az1 n_utail1_88 0 nch W=20u L=1u
Mu2_1_88 n_w1_88 n_error1 n_utail1_88 0 nch W=20u L=1u
Mu3_1_88 n_up1_88 n_up1_88 vdd vdd pch W=60u L=1u
Mu4_1_88 n_w1_88 n_up1_88 vdd vdd pch W=60u L=1u
Rinit1_89hi reset n_init1_89 405.319785276
Rinit1_89lo n_init1_89 0 594.680214724
Cw1_89 n_w1_89 0 5e-06
Mreset1_89 n_init1_89 reset n_w1_89 0 syn W=1000u L=1u
Mpos1_89 n_hv89 n_w1_89 n_op1 0 syn W=4u L=1u
Mneg1_89 n_hv89 vweight n_on1 0 syn W=4u L=1u
Menable1_89 n_enable1_89 learn 0 0 nch W=1000u L=1u
Mutail1_89 n_utail1_89 n_hv89 n_enable1_89 0 nch W=20u L=1u
Mu1_1_89 n_up1_89 n_az1 n_utail1_89 0 nch W=20u L=1u
Mu2_1_89 n_w1_89 n_error1 n_utail1_89 0 nch W=20u L=1u
Mu3_1_89 n_up1_89 n_up1_89 vdd vdd pch W=60u L=1u
Mu4_1_89 n_w1_89 n_up1_89 vdd vdd pch W=60u L=1u
Rinit1_90hi reset n_init1_90 377.840184621
Rinit1_90lo n_init1_90 0 622.159815379
Cw1_90 n_w1_90 0 5e-06
Mreset1_90 n_init1_90 reset n_w1_90 0 syn W=1000u L=1u
Mpos1_90 n_hv90 n_w1_90 n_op1 0 syn W=4u L=1u
Mneg1_90 n_hv90 vweight n_on1 0 syn W=4u L=1u
Menable1_90 n_enable1_90 learn 0 0 nch W=1000u L=1u
Mutail1_90 n_utail1_90 n_hv90 n_enable1_90 0 nch W=20u L=1u
Mu1_1_90 n_up1_90 n_az1 n_utail1_90 0 nch W=20u L=1u
Mu2_1_90 n_w1_90 n_error1 n_utail1_90 0 nch W=20u L=1u
Mu3_1_90 n_up1_90 n_up1_90 vdd vdd pch W=60u L=1u
Mu4_1_90 n_w1_90 n_up1_90 vdd vdd pch W=60u L=1u
Rinit1_91hi reset n_init1_91 401.136471501
Rinit1_91lo n_init1_91 0 598.863528499
Cw1_91 n_w1_91 0 5e-06
Mreset1_91 n_init1_91 reset n_w1_91 0 syn W=1000u L=1u
Mpos1_91 n_hv91 n_w1_91 n_op1 0 syn W=4u L=1u
Mneg1_91 n_hv91 vweight n_on1 0 syn W=4u L=1u
Menable1_91 n_enable1_91 learn 0 0 nch W=1000u L=1u
Mutail1_91 n_utail1_91 n_hv91 n_enable1_91 0 nch W=20u L=1u
Mu1_1_91 n_up1_91 n_az1 n_utail1_91 0 nch W=20u L=1u
Mu2_1_91 n_w1_91 n_error1 n_utail1_91 0 nch W=20u L=1u
Mu3_1_91 n_up1_91 n_up1_91 vdd vdd pch W=60u L=1u
Mu4_1_91 n_w1_91 n_up1_91 vdd vdd pch W=60u L=1u
Rinit1_92hi reset n_init1_92 382.762794596
Rinit1_92lo n_init1_92 0 617.237205404
Cw1_92 n_w1_92 0 5e-06
Mreset1_92 n_init1_92 reset n_w1_92 0 syn W=1000u L=1u
Mpos1_92 n_hv92 n_w1_92 n_op1 0 syn W=4u L=1u
Mneg1_92 n_hv92 vweight n_on1 0 syn W=4u L=1u
Menable1_92 n_enable1_92 learn 0 0 nch W=1000u L=1u
Mutail1_92 n_utail1_92 n_hv92 n_enable1_92 0 nch W=20u L=1u
Mu1_1_92 n_up1_92 n_az1 n_utail1_92 0 nch W=20u L=1u
Mu2_1_92 n_w1_92 n_error1 n_utail1_92 0 nch W=20u L=1u
Mu3_1_92 n_up1_92 n_up1_92 vdd vdd pch W=60u L=1u
Mu4_1_92 n_w1_92 n_up1_92 vdd vdd pch W=60u L=1u
Rinit1_93hi reset n_init1_93 400.689876706
Rinit1_93lo n_init1_93 0 599.310123294
Cw1_93 n_w1_93 0 5e-06
Mreset1_93 n_init1_93 reset n_w1_93 0 syn W=1000u L=1u
Mpos1_93 n_hv93 n_w1_93 n_op1 0 syn W=4u L=1u
Mneg1_93 n_hv93 vweight n_on1 0 syn W=4u L=1u
Menable1_93 n_enable1_93 learn 0 0 nch W=1000u L=1u
Mutail1_93 n_utail1_93 n_hv93 n_enable1_93 0 nch W=20u L=1u
Mu1_1_93 n_up1_93 n_az1 n_utail1_93 0 nch W=20u L=1u
Mu2_1_93 n_w1_93 n_error1 n_utail1_93 0 nch W=20u L=1u
Mu3_1_93 n_up1_93 n_up1_93 vdd vdd pch W=60u L=1u
Mu4_1_93 n_w1_93 n_up1_93 vdd vdd pch W=60u L=1u
Rinit1_94hi reset n_init1_94 362.28042519
Rinit1_94lo n_init1_94 0 637.71957481
Cw1_94 n_w1_94 0 5e-06
Mreset1_94 n_init1_94 reset n_w1_94 0 syn W=1000u L=1u
Mpos1_94 n_hv94 n_w1_94 n_op1 0 syn W=4u L=1u
Mneg1_94 n_hv94 vweight n_on1 0 syn W=4u L=1u
Menable1_94 n_enable1_94 learn 0 0 nch W=1000u L=1u
Mutail1_94 n_utail1_94 n_hv94 n_enable1_94 0 nch W=20u L=1u
Mu1_1_94 n_up1_94 n_az1 n_utail1_94 0 nch W=20u L=1u
Mu2_1_94 n_w1_94 n_error1 n_utail1_94 0 nch W=20u L=1u
Mu3_1_94 n_up1_94 n_up1_94 vdd vdd pch W=60u L=1u
Mu4_1_94 n_w1_94 n_up1_94 vdd vdd pch W=60u L=1u
Rinit1_95hi reset n_init1_95 382.705604777
Rinit1_95lo n_init1_95 0 617.294395223
Cw1_95 n_w1_95 0 5e-06
Mreset1_95 n_init1_95 reset n_w1_95 0 syn W=1000u L=1u
Mpos1_95 n_hv95 n_w1_95 n_op1 0 syn W=4u L=1u
Mneg1_95 n_hv95 vweight n_on1 0 syn W=4u L=1u
Menable1_95 n_enable1_95 learn 0 0 nch W=1000u L=1u
Mutail1_95 n_utail1_95 n_hv95 n_enable1_95 0 nch W=20u L=1u
Mu1_1_95 n_up1_95 n_az1 n_utail1_95 0 nch W=20u L=1u
Mu2_1_95 n_w1_95 n_error1 n_utail1_95 0 nch W=20u L=1u
Mu3_1_95 n_up1_95 n_up1_95 vdd vdd pch W=60u L=1u
Mu4_1_95 n_w1_95 n_up1_95 vdd vdd pch W=60u L=1u
Rinit1_96hi reset n_init1_96 432.689821086
Rinit1_96lo n_init1_96 0 567.310178914
Cw1_96 n_w1_96 0 5e-06
Mreset1_96 n_init1_96 reset n_w1_96 0 syn W=1000u L=1u
Mpos1_96 vbias n_w1_96 n_op1 0 syn W=4u L=1u
Mneg1_96 vbias vweight n_on1 0 syn W=4u L=1u
Menable1_96 n_enable1_96 learn 0 0 nch W=1000u L=1u
Mutail1_96 n_utail1_96 vbias n_enable1_96 0 nch W=20u L=1u
Mu1_1_96 n_up1_96 n_az1 n_utail1_96 0 nch W=20u L=1u
Mu2_1_96 n_w1_96 n_error1 n_utail1_96 0 nch W=20u L=1u
Mu3_1_96 n_up1_96 n_up1_96 vdd vdd pch W=60u L=1u
Mu4_1_96 n_w1_96 n_up1_96 vdd vdd pch W=60u L=1u
Mo7a n_on7 n_on7 0 0 nch W=20u L=1u
Mo7b out7 n_on7 0 0 nch W=20u L=1u
Mo7c n_op7 n_op7 0 0 nch W=20u L=1u
Mo7d n_mirroro7 n_op7 0 0 nch W=20u L=1u
Mo7e n_mirroro7 n_mirroro7 vdd vdd pch W=60u L=1u
Mo7f out7 n_mirroro7 vdd vdd pch W=60u L=1u
Ro7sum out7 vref 7000
Rtargetin7 target7 n_target7 30000
Rtargetref7 vbias n_target7 36402.5695931
Rtargetzero7 n_target7 0 25512.7563782
Merrorp7 n_error7 n_mirroro7 vdd vdd pch W=60u L=1u
Merrorn7 n_error7 n_on7 0 0 nch W=20u L=1u
Moffset7 n_error7 voffset vdd vdd pch W=10u L=1u
Mtarget7 n_error7 n_target7 0 0 nch W=10u L=1u
Rerror7 n_error7 verror 7000
Rcommon7 n_error7 n_common 10000
Raz7 n_error7 n_azfeed7 6000
Maztrack7 n_azfeed7 learn n_az7 0 syn W=1000u L=1u
Caz7 n_az7 0 1e-05
Mazreset7 verror reset n_az7 0 syn W=1000u L=1u
Rinit7_0hi reset n_init7_0 429.64238989
Rinit7_0lo n_init7_0 0 570.35761011
Cw7_0 n_w7_0 0 5e-06
Mreset7_0 n_init7_0 reset n_w7_0 0 syn W=1000u L=1u
Mpos7_0 n_hv0 n_w7_0 n_op7 0 syn W=4u L=1u
Mneg7_0 n_hv0 vweight n_on7 0 syn W=4u L=1u
Menable7_0 n_enable7_0 learn 0 0 nch W=1000u L=1u
Mutail7_0 n_utail7_0 n_hv0 n_enable7_0 0 nch W=20u L=1u
Mu1_7_0 n_up7_0 n_az7 n_utail7_0 0 nch W=20u L=1u
Mu2_7_0 n_w7_0 n_error7 n_utail7_0 0 nch W=20u L=1u
Mu3_7_0 n_up7_0 n_up7_0 vdd vdd pch W=60u L=1u
Mu4_7_0 n_w7_0 n_up7_0 vdd vdd pch W=60u L=1u
Rinit7_1hi reset n_init7_1 362.678816229
Rinit7_1lo n_init7_1 0 637.321183771
Cw7_1 n_w7_1 0 5e-06
Mreset7_1 n_init7_1 reset n_w7_1 0 syn W=1000u L=1u
Mpos7_1 n_hv1 n_w7_1 n_op7 0 syn W=4u L=1u
Mneg7_1 n_hv1 vweight n_on7 0 syn W=4u L=1u
Menable7_1 n_enable7_1 learn 0 0 nch W=1000u L=1u
Mutail7_1 n_utail7_1 n_hv1 n_enable7_1 0 nch W=20u L=1u
Mu1_7_1 n_up7_1 n_az7 n_utail7_1 0 nch W=20u L=1u
Mu2_7_1 n_w7_1 n_error7 n_utail7_1 0 nch W=20u L=1u
Mu3_7_1 n_up7_1 n_up7_1 vdd vdd pch W=60u L=1u
Mu4_7_1 n_w7_1 n_up7_1 vdd vdd pch W=60u L=1u
Rinit7_2hi reset n_init7_2 421.661729973
Rinit7_2lo n_init7_2 0 578.338270027
Cw7_2 n_w7_2 0 5e-06
Mreset7_2 n_init7_2 reset n_w7_2 0 syn W=1000u L=1u
Mpos7_2 n_hv2 n_w7_2 n_op7 0 syn W=4u L=1u
Mneg7_2 n_hv2 vweight n_on7 0 syn W=4u L=1u
Menable7_2 n_enable7_2 learn 0 0 nch W=1000u L=1u
Mutail7_2 n_utail7_2 n_hv2 n_enable7_2 0 nch W=20u L=1u
Mu1_7_2 n_up7_2 n_az7 n_utail7_2 0 nch W=20u L=1u
Mu2_7_2 n_w7_2 n_error7 n_utail7_2 0 nch W=20u L=1u
Mu3_7_2 n_up7_2 n_up7_2 vdd vdd pch W=60u L=1u
Mu4_7_2 n_w7_2 n_up7_2 vdd vdd pch W=60u L=1u
Rinit7_3hi reset n_init7_3 437.909116087
Rinit7_3lo n_init7_3 0 562.090883913
Cw7_3 n_w7_3 0 5e-06
Mreset7_3 n_init7_3 reset n_w7_3 0 syn W=1000u L=1u
Mpos7_3 n_hv3 n_w7_3 n_op7 0 syn W=4u L=1u
Mneg7_3 n_hv3 vweight n_on7 0 syn W=4u L=1u
Menable7_3 n_enable7_3 learn 0 0 nch W=1000u L=1u
Mutail7_3 n_utail7_3 n_hv3 n_enable7_3 0 nch W=20u L=1u
Mu1_7_3 n_up7_3 n_az7 n_utail7_3 0 nch W=20u L=1u
Mu2_7_3 n_w7_3 n_error7 n_utail7_3 0 nch W=20u L=1u
Mu3_7_3 n_up7_3 n_up7_3 vdd vdd pch W=60u L=1u
Mu4_7_3 n_w7_3 n_up7_3 vdd vdd pch W=60u L=1u
Rinit7_4hi reset n_init7_4 419.742100146
Rinit7_4lo n_init7_4 0 580.257899854
Cw7_4 n_w7_4 0 5e-06
Mreset7_4 n_init7_4 reset n_w7_4 0 syn W=1000u L=1u
Mpos7_4 n_hv4 n_w7_4 n_op7 0 syn W=4u L=1u
Mneg7_4 n_hv4 vweight n_on7 0 syn W=4u L=1u
Menable7_4 n_enable7_4 learn 0 0 nch W=1000u L=1u
Mutail7_4 n_utail7_4 n_hv4 n_enable7_4 0 nch W=20u L=1u
Mu1_7_4 n_up7_4 n_az7 n_utail7_4 0 nch W=20u L=1u
Mu2_7_4 n_w7_4 n_error7 n_utail7_4 0 nch W=20u L=1u
Mu3_7_4 n_up7_4 n_up7_4 vdd vdd pch W=60u L=1u
Mu4_7_4 n_w7_4 n_up7_4 vdd vdd pch W=60u L=1u
Rinit7_5hi reset n_init7_5 401.617035404
Rinit7_5lo n_init7_5 0 598.382964596
Cw7_5 n_w7_5 0 5e-06
Mreset7_5 n_init7_5 reset n_w7_5 0 syn W=1000u L=1u
Mpos7_5 n_hv5 n_w7_5 n_op7 0 syn W=4u L=1u
Mneg7_5 n_hv5 vweight n_on7 0 syn W=4u L=1u
Menable7_5 n_enable7_5 learn 0 0 nch W=1000u L=1u
Mutail7_5 n_utail7_5 n_hv5 n_enable7_5 0 nch W=20u L=1u
Mu1_7_5 n_up7_5 n_az7 n_utail7_5 0 nch W=20u L=1u
Mu2_7_5 n_w7_5 n_error7 n_utail7_5 0 nch W=20u L=1u
Mu3_7_5 n_up7_5 n_up7_5 vdd vdd pch W=60u L=1u
Mu4_7_5 n_w7_5 n_up7_5 vdd vdd pch W=60u L=1u
Rinit7_6hi reset n_init7_6 363.82651502
Rinit7_6lo n_init7_6 0 636.17348498
Cw7_6 n_w7_6 0 5e-06
Mreset7_6 n_init7_6 reset n_w7_6 0 syn W=1000u L=1u
Mpos7_6 n_hv6 n_w7_6 n_op7 0 syn W=4u L=1u
Mneg7_6 n_hv6 vweight n_on7 0 syn W=4u L=1u
Menable7_6 n_enable7_6 learn 0 0 nch W=1000u L=1u
Mutail7_6 n_utail7_6 n_hv6 n_enable7_6 0 nch W=20u L=1u
Mu1_7_6 n_up7_6 n_az7 n_utail7_6 0 nch W=20u L=1u
Mu2_7_6 n_w7_6 n_error7 n_utail7_6 0 nch W=20u L=1u
Mu3_7_6 n_up7_6 n_up7_6 vdd vdd pch W=60u L=1u
Mu4_7_6 n_w7_6 n_up7_6 vdd vdd pch W=60u L=1u
Rinit7_7hi reset n_init7_7 408.069607824
Rinit7_7lo n_init7_7 0 591.930392176
Cw7_7 n_w7_7 0 5e-06
Mreset7_7 n_init7_7 reset n_w7_7 0 syn W=1000u L=1u
Mpos7_7 n_hv7 n_w7_7 n_op7 0 syn W=4u L=1u
Mneg7_7 n_hv7 vweight n_on7 0 syn W=4u L=1u
Menable7_7 n_enable7_7 learn 0 0 nch W=1000u L=1u
Mutail7_7 n_utail7_7 n_hv7 n_enable7_7 0 nch W=20u L=1u
Mu1_7_7 n_up7_7 n_az7 n_utail7_7 0 nch W=20u L=1u
Mu2_7_7 n_w7_7 n_error7 n_utail7_7 0 nch W=20u L=1u
Mu3_7_7 n_up7_7 n_up7_7 vdd vdd pch W=60u L=1u
Mu4_7_7 n_w7_7 n_up7_7 vdd vdd pch W=60u L=1u
Rinit7_8hi reset n_init7_8 382.119552977
Rinit7_8lo n_init7_8 0 617.880447023
Cw7_8 n_w7_8 0 5e-06
Mreset7_8 n_init7_8 reset n_w7_8 0 syn W=1000u L=1u
Mpos7_8 n_hv8 n_w7_8 n_op7 0 syn W=4u L=1u
Mneg7_8 n_hv8 vweight n_on7 0 syn W=4u L=1u
Menable7_8 n_enable7_8 learn 0 0 nch W=1000u L=1u
Mutail7_8 n_utail7_8 n_hv8 n_enable7_8 0 nch W=20u L=1u
Mu1_7_8 n_up7_8 n_az7 n_utail7_8 0 nch W=20u L=1u
Mu2_7_8 n_w7_8 n_error7 n_utail7_8 0 nch W=20u L=1u
Mu3_7_8 n_up7_8 n_up7_8 vdd vdd pch W=60u L=1u
Mu4_7_8 n_w7_8 n_up7_8 vdd vdd pch W=60u L=1u
Rinit7_9hi reset n_init7_9 373.250998257
Rinit7_9lo n_init7_9 0 626.749001743
Cw7_9 n_w7_9 0 5e-06
Mreset7_9 n_init7_9 reset n_w7_9 0 syn W=1000u L=1u
Mpos7_9 n_hv9 n_w7_9 n_op7 0 syn W=4u L=1u
Mneg7_9 n_hv9 vweight n_on7 0 syn W=4u L=1u
Menable7_9 n_enable7_9 learn 0 0 nch W=1000u L=1u
Mutail7_9 n_utail7_9 n_hv9 n_enable7_9 0 nch W=20u L=1u
Mu1_7_9 n_up7_9 n_az7 n_utail7_9 0 nch W=20u L=1u
Mu2_7_9 n_w7_9 n_error7 n_utail7_9 0 nch W=20u L=1u
Mu3_7_9 n_up7_9 n_up7_9 vdd vdd pch W=60u L=1u
Mu4_7_9 n_w7_9 n_up7_9 vdd vdd pch W=60u L=1u
Rinit7_10hi reset n_init7_10 432.867038591
Rinit7_10lo n_init7_10 0 567.132961409
Cw7_10 n_w7_10 0 5e-06
Mreset7_10 n_init7_10 reset n_w7_10 0 syn W=1000u L=1u
Mpos7_10 n_hv10 n_w7_10 n_op7 0 syn W=4u L=1u
Mneg7_10 n_hv10 vweight n_on7 0 syn W=4u L=1u
Menable7_10 n_enable7_10 learn 0 0 nch W=1000u L=1u
Mutail7_10 n_utail7_10 n_hv10 n_enable7_10 0 nch W=20u L=1u
Mu1_7_10 n_up7_10 n_az7 n_utail7_10 0 nch W=20u L=1u
Mu2_7_10 n_w7_10 n_error7 n_utail7_10 0 nch W=20u L=1u
Mu3_7_10 n_up7_10 n_up7_10 vdd vdd pch W=60u L=1u
Mu4_7_10 n_w7_10 n_up7_10 vdd vdd pch W=60u L=1u
Rinit7_11hi reset n_init7_11 391.048643616
Rinit7_11lo n_init7_11 0 608.951356384
Cw7_11 n_w7_11 0 5e-06
Mreset7_11 n_init7_11 reset n_w7_11 0 syn W=1000u L=1u
Mpos7_11 n_hv11 n_w7_11 n_op7 0 syn W=4u L=1u
Mneg7_11 n_hv11 vweight n_on7 0 syn W=4u L=1u
Menable7_11 n_enable7_11 learn 0 0 nch W=1000u L=1u
Mutail7_11 n_utail7_11 n_hv11 n_enable7_11 0 nch W=20u L=1u
Mu1_7_11 n_up7_11 n_az7 n_utail7_11 0 nch W=20u L=1u
Mu2_7_11 n_w7_11 n_error7 n_utail7_11 0 nch W=20u L=1u
Mu3_7_11 n_up7_11 n_up7_11 vdd vdd pch W=60u L=1u
Mu4_7_11 n_w7_11 n_up7_11 vdd vdd pch W=60u L=1u
Rinit7_12hi reset n_init7_12 360.337251394
Rinit7_12lo n_init7_12 0 639.662748606
Cw7_12 n_w7_12 0 5e-06
Mreset7_12 n_init7_12 reset n_w7_12 0 syn W=1000u L=1u
Mpos7_12 n_hv12 n_w7_12 n_op7 0 syn W=4u L=1u
Mneg7_12 n_hv12 vweight n_on7 0 syn W=4u L=1u
Menable7_12 n_enable7_12 learn 0 0 nch W=1000u L=1u
Mutail7_12 n_utail7_12 n_hv12 n_enable7_12 0 nch W=20u L=1u
Mu1_7_12 n_up7_12 n_az7 n_utail7_12 0 nch W=20u L=1u
Mu2_7_12 n_w7_12 n_error7 n_utail7_12 0 nch W=20u L=1u
Mu3_7_12 n_up7_12 n_up7_12 vdd vdd pch W=60u L=1u
Mu4_7_12 n_w7_12 n_up7_12 vdd vdd pch W=60u L=1u
Rinit7_13hi reset n_init7_13 396.032322515
Rinit7_13lo n_init7_13 0 603.967677485
Cw7_13 n_w7_13 0 5e-06
Mreset7_13 n_init7_13 reset n_w7_13 0 syn W=1000u L=1u
Mpos7_13 n_hv13 n_w7_13 n_op7 0 syn W=4u L=1u
Mneg7_13 n_hv13 vweight n_on7 0 syn W=4u L=1u
Menable7_13 n_enable7_13 learn 0 0 nch W=1000u L=1u
Mutail7_13 n_utail7_13 n_hv13 n_enable7_13 0 nch W=20u L=1u
Mu1_7_13 n_up7_13 n_az7 n_utail7_13 0 nch W=20u L=1u
Mu2_7_13 n_w7_13 n_error7 n_utail7_13 0 nch W=20u L=1u
Mu3_7_13 n_up7_13 n_up7_13 vdd vdd pch W=60u L=1u
Mu4_7_13 n_w7_13 n_up7_13 vdd vdd pch W=60u L=1u
Rinit7_14hi reset n_init7_14 397.241105782
Rinit7_14lo n_init7_14 0 602.758894218
Cw7_14 n_w7_14 0 5e-06
Mreset7_14 n_init7_14 reset n_w7_14 0 syn W=1000u L=1u
Mpos7_14 n_hv14 n_w7_14 n_op7 0 syn W=4u L=1u
Mneg7_14 n_hv14 vweight n_on7 0 syn W=4u L=1u
Menable7_14 n_enable7_14 learn 0 0 nch W=1000u L=1u
Mutail7_14 n_utail7_14 n_hv14 n_enable7_14 0 nch W=20u L=1u
Mu1_7_14 n_up7_14 n_az7 n_utail7_14 0 nch W=20u L=1u
Mu2_7_14 n_w7_14 n_error7 n_utail7_14 0 nch W=20u L=1u
Mu3_7_14 n_up7_14 n_up7_14 vdd vdd pch W=60u L=1u
Mu4_7_14 n_w7_14 n_up7_14 vdd vdd pch W=60u L=1u
Rinit7_15hi reset n_init7_15 412.263796898
Rinit7_15lo n_init7_15 0 587.736203102
Cw7_15 n_w7_15 0 5e-06
Mreset7_15 n_init7_15 reset n_w7_15 0 syn W=1000u L=1u
Mpos7_15 n_hv15 n_w7_15 n_op7 0 syn W=4u L=1u
Mneg7_15 n_hv15 vweight n_on7 0 syn W=4u L=1u
Menable7_15 n_enable7_15 learn 0 0 nch W=1000u L=1u
Mutail7_15 n_utail7_15 n_hv15 n_enable7_15 0 nch W=20u L=1u
Mu1_7_15 n_up7_15 n_az7 n_utail7_15 0 nch W=20u L=1u
Mu2_7_15 n_w7_15 n_error7 n_utail7_15 0 nch W=20u L=1u
Mu3_7_15 n_up7_15 n_up7_15 vdd vdd pch W=60u L=1u
Mu4_7_15 n_w7_15 n_up7_15 vdd vdd pch W=60u L=1u
Rinit7_16hi reset n_init7_16 364.311568349
Rinit7_16lo n_init7_16 0 635.688431651
Cw7_16 n_w7_16 0 5e-06
Mreset7_16 n_init7_16 reset n_w7_16 0 syn W=1000u L=1u
Mpos7_16 n_hv16 n_w7_16 n_op7 0 syn W=4u L=1u
Mneg7_16 n_hv16 vweight n_on7 0 syn W=4u L=1u
Menable7_16 n_enable7_16 learn 0 0 nch W=1000u L=1u
Mutail7_16 n_utail7_16 n_hv16 n_enable7_16 0 nch W=20u L=1u
Mu1_7_16 n_up7_16 n_az7 n_utail7_16 0 nch W=20u L=1u
Mu2_7_16 n_w7_16 n_error7 n_utail7_16 0 nch W=20u L=1u
Mu3_7_16 n_up7_16 n_up7_16 vdd vdd pch W=60u L=1u
Mu4_7_16 n_w7_16 n_up7_16 vdd vdd pch W=60u L=1u
Rinit7_17hi reset n_init7_17 362.432060882
Rinit7_17lo n_init7_17 0 637.567939118
Cw7_17 n_w7_17 0 5e-06
Mreset7_17 n_init7_17 reset n_w7_17 0 syn W=1000u L=1u
Mpos7_17 n_hv17 n_w7_17 n_op7 0 syn W=4u L=1u
Mneg7_17 n_hv17 vweight n_on7 0 syn W=4u L=1u
Menable7_17 n_enable7_17 learn 0 0 nch W=1000u L=1u
Mutail7_17 n_utail7_17 n_hv17 n_enable7_17 0 nch W=20u L=1u
Mu1_7_17 n_up7_17 n_az7 n_utail7_17 0 nch W=20u L=1u
Mu2_7_17 n_w7_17 n_error7 n_utail7_17 0 nch W=20u L=1u
Mu3_7_17 n_up7_17 n_up7_17 vdd vdd pch W=60u L=1u
Mu4_7_17 n_w7_17 n_up7_17 vdd vdd pch W=60u L=1u
Rinit7_18hi reset n_init7_18 431.746412078
Rinit7_18lo n_init7_18 0 568.253587922
Cw7_18 n_w7_18 0 5e-06
Mreset7_18 n_init7_18 reset n_w7_18 0 syn W=1000u L=1u
Mpos7_18 n_hv18 n_w7_18 n_op7 0 syn W=4u L=1u
Mneg7_18 n_hv18 vweight n_on7 0 syn W=4u L=1u
Menable7_18 n_enable7_18 learn 0 0 nch W=1000u L=1u
Mutail7_18 n_utail7_18 n_hv18 n_enable7_18 0 nch W=20u L=1u
Mu1_7_18 n_up7_18 n_az7 n_utail7_18 0 nch W=20u L=1u
Mu2_7_18 n_w7_18 n_error7 n_utail7_18 0 nch W=20u L=1u
Mu3_7_18 n_up7_18 n_up7_18 vdd vdd pch W=60u L=1u
Mu4_7_18 n_w7_18 n_up7_18 vdd vdd pch W=60u L=1u
Rinit7_19hi reset n_init7_19 395.773291183
Rinit7_19lo n_init7_19 0 604.226708817
Cw7_19 n_w7_19 0 5e-06
Mreset7_19 n_init7_19 reset n_w7_19 0 syn W=1000u L=1u
Mpos7_19 n_hv19 n_w7_19 n_op7 0 syn W=4u L=1u
Mneg7_19 n_hv19 vweight n_on7 0 syn W=4u L=1u
Menable7_19 n_enable7_19 learn 0 0 nch W=1000u L=1u
Mutail7_19 n_utail7_19 n_hv19 n_enable7_19 0 nch W=20u L=1u
Mu1_7_19 n_up7_19 n_az7 n_utail7_19 0 nch W=20u L=1u
Mu2_7_19 n_w7_19 n_error7 n_utail7_19 0 nch W=20u L=1u
Mu3_7_19 n_up7_19 n_up7_19 vdd vdd pch W=60u L=1u
Mu4_7_19 n_w7_19 n_up7_19 vdd vdd pch W=60u L=1u
Rinit7_20hi reset n_init7_20 406.429661611
Rinit7_20lo n_init7_20 0 593.570338389
Cw7_20 n_w7_20 0 5e-06
Mreset7_20 n_init7_20 reset n_w7_20 0 syn W=1000u L=1u
Mpos7_20 n_hv20 n_w7_20 n_op7 0 syn W=4u L=1u
Mneg7_20 n_hv20 vweight n_on7 0 syn W=4u L=1u
Menable7_20 n_enable7_20 learn 0 0 nch W=1000u L=1u
Mutail7_20 n_utail7_20 n_hv20 n_enable7_20 0 nch W=20u L=1u
Mu1_7_20 n_up7_20 n_az7 n_utail7_20 0 nch W=20u L=1u
Mu2_7_20 n_w7_20 n_error7 n_utail7_20 0 nch W=20u L=1u
Mu3_7_20 n_up7_20 n_up7_20 vdd vdd pch W=60u L=1u
Mu4_7_20 n_w7_20 n_up7_20 vdd vdd pch W=60u L=1u
Rinit7_21hi reset n_init7_21 386.268307125
Rinit7_21lo n_init7_21 0 613.731692875
Cw7_21 n_w7_21 0 5e-06
Mreset7_21 n_init7_21 reset n_w7_21 0 syn W=1000u L=1u
Mpos7_21 n_hv21 n_w7_21 n_op7 0 syn W=4u L=1u
Mneg7_21 n_hv21 vweight n_on7 0 syn W=4u L=1u
Menable7_21 n_enable7_21 learn 0 0 nch W=1000u L=1u
Mutail7_21 n_utail7_21 n_hv21 n_enable7_21 0 nch W=20u L=1u
Mu1_7_21 n_up7_21 n_az7 n_utail7_21 0 nch W=20u L=1u
Mu2_7_21 n_w7_21 n_error7 n_utail7_21 0 nch W=20u L=1u
Mu3_7_21 n_up7_21 n_up7_21 vdd vdd pch W=60u L=1u
Mu4_7_21 n_w7_21 n_up7_21 vdd vdd pch W=60u L=1u
Rinit7_22hi reset n_init7_22 430.508269074
Rinit7_22lo n_init7_22 0 569.491730926
Cw7_22 n_w7_22 0 5e-06
Mreset7_22 n_init7_22 reset n_w7_22 0 syn W=1000u L=1u
Mpos7_22 n_hv22 n_w7_22 n_op7 0 syn W=4u L=1u
Mneg7_22 n_hv22 vweight n_on7 0 syn W=4u L=1u
Menable7_22 n_enable7_22 learn 0 0 nch W=1000u L=1u
Mutail7_22 n_utail7_22 n_hv22 n_enable7_22 0 nch W=20u L=1u
Mu1_7_22 n_up7_22 n_az7 n_utail7_22 0 nch W=20u L=1u
Mu2_7_22 n_w7_22 n_error7 n_utail7_22 0 nch W=20u L=1u
Mu3_7_22 n_up7_22 n_up7_22 vdd vdd pch W=60u L=1u
Mu4_7_22 n_w7_22 n_up7_22 vdd vdd pch W=60u L=1u
Rinit7_23hi reset n_init7_23 418.773256728
Rinit7_23lo n_init7_23 0 581.226743272
Cw7_23 n_w7_23 0 5e-06
Mreset7_23 n_init7_23 reset n_w7_23 0 syn W=1000u L=1u
Mpos7_23 n_hv23 n_w7_23 n_op7 0 syn W=4u L=1u
Mneg7_23 n_hv23 vweight n_on7 0 syn W=4u L=1u
Menable7_23 n_enable7_23 learn 0 0 nch W=1000u L=1u
Mutail7_23 n_utail7_23 n_hv23 n_enable7_23 0 nch W=20u L=1u
Mu1_7_23 n_up7_23 n_az7 n_utail7_23 0 nch W=20u L=1u
Mu2_7_23 n_w7_23 n_error7 n_utail7_23 0 nch W=20u L=1u
Mu3_7_23 n_up7_23 n_up7_23 vdd vdd pch W=60u L=1u
Mu4_7_23 n_w7_23 n_up7_23 vdd vdd pch W=60u L=1u
Rinit7_24hi reset n_init7_24 417.699729694
Rinit7_24lo n_init7_24 0 582.300270306
Cw7_24 n_w7_24 0 5e-06
Mreset7_24 n_init7_24 reset n_w7_24 0 syn W=1000u L=1u
Mpos7_24 n_hv24 n_w7_24 n_op7 0 syn W=4u L=1u
Mneg7_24 n_hv24 vweight n_on7 0 syn W=4u L=1u
Menable7_24 n_enable7_24 learn 0 0 nch W=1000u L=1u
Mutail7_24 n_utail7_24 n_hv24 n_enable7_24 0 nch W=20u L=1u
Mu1_7_24 n_up7_24 n_az7 n_utail7_24 0 nch W=20u L=1u
Mu2_7_24 n_w7_24 n_error7 n_utail7_24 0 nch W=20u L=1u
Mu3_7_24 n_up7_24 n_up7_24 vdd vdd pch W=60u L=1u
Mu4_7_24 n_w7_24 n_up7_24 vdd vdd pch W=60u L=1u
Rinit7_25hi reset n_init7_25 401.622964856
Rinit7_25lo n_init7_25 0 598.377035144
Cw7_25 n_w7_25 0 5e-06
Mreset7_25 n_init7_25 reset n_w7_25 0 syn W=1000u L=1u
Mpos7_25 n_hv25 n_w7_25 n_op7 0 syn W=4u L=1u
Mneg7_25 n_hv25 vweight n_on7 0 syn W=4u L=1u
Menable7_25 n_enable7_25 learn 0 0 nch W=1000u L=1u
Mutail7_25 n_utail7_25 n_hv25 n_enable7_25 0 nch W=20u L=1u
Mu1_7_25 n_up7_25 n_az7 n_utail7_25 0 nch W=20u L=1u
Mu2_7_25 n_w7_25 n_error7 n_utail7_25 0 nch W=20u L=1u
Mu3_7_25 n_up7_25 n_up7_25 vdd vdd pch W=60u L=1u
Mu4_7_25 n_w7_25 n_up7_25 vdd vdd pch W=60u L=1u
Rinit7_26hi reset n_init7_26 376.537373242
Rinit7_26lo n_init7_26 0 623.462626758
Cw7_26 n_w7_26 0 5e-06
Mreset7_26 n_init7_26 reset n_w7_26 0 syn W=1000u L=1u
Mpos7_26 n_hv26 n_w7_26 n_op7 0 syn W=4u L=1u
Mneg7_26 n_hv26 vweight n_on7 0 syn W=4u L=1u
Menable7_26 n_enable7_26 learn 0 0 nch W=1000u L=1u
Mutail7_26 n_utail7_26 n_hv26 n_enable7_26 0 nch W=20u L=1u
Mu1_7_26 n_up7_26 n_az7 n_utail7_26 0 nch W=20u L=1u
Mu2_7_26 n_w7_26 n_error7 n_utail7_26 0 nch W=20u L=1u
Mu3_7_26 n_up7_26 n_up7_26 vdd vdd pch W=60u L=1u
Mu4_7_26 n_w7_26 n_up7_26 vdd vdd pch W=60u L=1u
Rinit7_27hi reset n_init7_27 371.37219903
Rinit7_27lo n_init7_27 0 628.62780097
Cw7_27 n_w7_27 0 5e-06
Mreset7_27 n_init7_27 reset n_w7_27 0 syn W=1000u L=1u
Mpos7_27 n_hv27 n_w7_27 n_op7 0 syn W=4u L=1u
Mneg7_27 n_hv27 vweight n_on7 0 syn W=4u L=1u
Menable7_27 n_enable7_27 learn 0 0 nch W=1000u L=1u
Mutail7_27 n_utail7_27 n_hv27 n_enable7_27 0 nch W=20u L=1u
Mu1_7_27 n_up7_27 n_az7 n_utail7_27 0 nch W=20u L=1u
Mu2_7_27 n_w7_27 n_error7 n_utail7_27 0 nch W=20u L=1u
Mu3_7_27 n_up7_27 n_up7_27 vdd vdd pch W=60u L=1u
Mu4_7_27 n_w7_27 n_up7_27 vdd vdd pch W=60u L=1u
Rinit7_28hi reset n_init7_28 377.086108795
Rinit7_28lo n_init7_28 0 622.913891205
Cw7_28 n_w7_28 0 5e-06
Mreset7_28 n_init7_28 reset n_w7_28 0 syn W=1000u L=1u
Mpos7_28 n_hv28 n_w7_28 n_op7 0 syn W=4u L=1u
Mneg7_28 n_hv28 vweight n_on7 0 syn W=4u L=1u
Menable7_28 n_enable7_28 learn 0 0 nch W=1000u L=1u
Mutail7_28 n_utail7_28 n_hv28 n_enable7_28 0 nch W=20u L=1u
Mu1_7_28 n_up7_28 n_az7 n_utail7_28 0 nch W=20u L=1u
Mu2_7_28 n_w7_28 n_error7 n_utail7_28 0 nch W=20u L=1u
Mu3_7_28 n_up7_28 n_up7_28 vdd vdd pch W=60u L=1u
Mu4_7_28 n_w7_28 n_up7_28 vdd vdd pch W=60u L=1u
Rinit7_29hi reset n_init7_29 385.855453226
Rinit7_29lo n_init7_29 0 614.144546774
Cw7_29 n_w7_29 0 5e-06
Mreset7_29 n_init7_29 reset n_w7_29 0 syn W=1000u L=1u
Mpos7_29 n_hv29 n_w7_29 n_op7 0 syn W=4u L=1u
Mneg7_29 n_hv29 vweight n_on7 0 syn W=4u L=1u
Menable7_29 n_enable7_29 learn 0 0 nch W=1000u L=1u
Mutail7_29 n_utail7_29 n_hv29 n_enable7_29 0 nch W=20u L=1u
Mu1_7_29 n_up7_29 n_az7 n_utail7_29 0 nch W=20u L=1u
Mu2_7_29 n_w7_29 n_error7 n_utail7_29 0 nch W=20u L=1u
Mu3_7_29 n_up7_29 n_up7_29 vdd vdd pch W=60u L=1u
Mu4_7_29 n_w7_29 n_up7_29 vdd vdd pch W=60u L=1u
Rinit7_30hi reset n_init7_30 433.024579366
Rinit7_30lo n_init7_30 0 566.975420634
Cw7_30 n_w7_30 0 5e-06
Mreset7_30 n_init7_30 reset n_w7_30 0 syn W=1000u L=1u
Mpos7_30 n_hv30 n_w7_30 n_op7 0 syn W=4u L=1u
Mneg7_30 n_hv30 vweight n_on7 0 syn W=4u L=1u
Menable7_30 n_enable7_30 learn 0 0 nch W=1000u L=1u
Mutail7_30 n_utail7_30 n_hv30 n_enable7_30 0 nch W=20u L=1u
Mu1_7_30 n_up7_30 n_az7 n_utail7_30 0 nch W=20u L=1u
Mu2_7_30 n_w7_30 n_error7 n_utail7_30 0 nch W=20u L=1u
Mu3_7_30 n_up7_30 n_up7_30 vdd vdd pch W=60u L=1u
Mu4_7_30 n_w7_30 n_up7_30 vdd vdd pch W=60u L=1u
Rinit7_31hi reset n_init7_31 408.822634146
Rinit7_31lo n_init7_31 0 591.177365854
Cw7_31 n_w7_31 0 5e-06
Mreset7_31 n_init7_31 reset n_w7_31 0 syn W=1000u L=1u
Mpos7_31 n_hv31 n_w7_31 n_op7 0 syn W=4u L=1u
Mneg7_31 n_hv31 vweight n_on7 0 syn W=4u L=1u
Menable7_31 n_enable7_31 learn 0 0 nch W=1000u L=1u
Mutail7_31 n_utail7_31 n_hv31 n_enable7_31 0 nch W=20u L=1u
Mu1_7_31 n_up7_31 n_az7 n_utail7_31 0 nch W=20u L=1u
Mu2_7_31 n_w7_31 n_error7 n_utail7_31 0 nch W=20u L=1u
Mu3_7_31 n_up7_31 n_up7_31 vdd vdd pch W=60u L=1u
Mu4_7_31 n_w7_31 n_up7_31 vdd vdd pch W=60u L=1u
Rinit7_32hi reset n_init7_32 386.503870221
Rinit7_32lo n_init7_32 0 613.496129779
Cw7_32 n_w7_32 0 5e-06
Mreset7_32 n_init7_32 reset n_w7_32 0 syn W=1000u L=1u
Mpos7_32 n_hv32 n_w7_32 n_op7 0 syn W=4u L=1u
Mneg7_32 n_hv32 vweight n_on7 0 syn W=4u L=1u
Menable7_32 n_enable7_32 learn 0 0 nch W=1000u L=1u
Mutail7_32 n_utail7_32 n_hv32 n_enable7_32 0 nch W=20u L=1u
Mu1_7_32 n_up7_32 n_az7 n_utail7_32 0 nch W=20u L=1u
Mu2_7_32 n_w7_32 n_error7 n_utail7_32 0 nch W=20u L=1u
Mu3_7_32 n_up7_32 n_up7_32 vdd vdd pch W=60u L=1u
Mu4_7_32 n_w7_32 n_up7_32 vdd vdd pch W=60u L=1u
Rinit7_33hi reset n_init7_33 416.460177492
Rinit7_33lo n_init7_33 0 583.539822508
Cw7_33 n_w7_33 0 5e-06
Mreset7_33 n_init7_33 reset n_w7_33 0 syn W=1000u L=1u
Mpos7_33 n_hv33 n_w7_33 n_op7 0 syn W=4u L=1u
Mneg7_33 n_hv33 vweight n_on7 0 syn W=4u L=1u
Menable7_33 n_enable7_33 learn 0 0 nch W=1000u L=1u
Mutail7_33 n_utail7_33 n_hv33 n_enable7_33 0 nch W=20u L=1u
Mu1_7_33 n_up7_33 n_az7 n_utail7_33 0 nch W=20u L=1u
Mu2_7_33 n_w7_33 n_error7 n_utail7_33 0 nch W=20u L=1u
Mu3_7_33 n_up7_33 n_up7_33 vdd vdd pch W=60u L=1u
Mu4_7_33 n_w7_33 n_up7_33 vdd vdd pch W=60u L=1u
Rinit7_34hi reset n_init7_34 399.37452823
Rinit7_34lo n_init7_34 0 600.62547177
Cw7_34 n_w7_34 0 5e-06
Mreset7_34 n_init7_34 reset n_w7_34 0 syn W=1000u L=1u
Mpos7_34 n_hv34 n_w7_34 n_op7 0 syn W=4u L=1u
Mneg7_34 n_hv34 vweight n_on7 0 syn W=4u L=1u
Menable7_34 n_enable7_34 learn 0 0 nch W=1000u L=1u
Mutail7_34 n_utail7_34 n_hv34 n_enable7_34 0 nch W=20u L=1u
Mu1_7_34 n_up7_34 n_az7 n_utail7_34 0 nch W=20u L=1u
Mu2_7_34 n_w7_34 n_error7 n_utail7_34 0 nch W=20u L=1u
Mu3_7_34 n_up7_34 n_up7_34 vdd vdd pch W=60u L=1u
Mu4_7_34 n_w7_34 n_up7_34 vdd vdd pch W=60u L=1u
Rinit7_35hi reset n_init7_35 367.59373105
Rinit7_35lo n_init7_35 0 632.40626895
Cw7_35 n_w7_35 0 5e-06
Mreset7_35 n_init7_35 reset n_w7_35 0 syn W=1000u L=1u
Mpos7_35 n_hv35 n_w7_35 n_op7 0 syn W=4u L=1u
Mneg7_35 n_hv35 vweight n_on7 0 syn W=4u L=1u
Menable7_35 n_enable7_35 learn 0 0 nch W=1000u L=1u
Mutail7_35 n_utail7_35 n_hv35 n_enable7_35 0 nch W=20u L=1u
Mu1_7_35 n_up7_35 n_az7 n_utail7_35 0 nch W=20u L=1u
Mu2_7_35 n_w7_35 n_error7 n_utail7_35 0 nch W=20u L=1u
Mu3_7_35 n_up7_35 n_up7_35 vdd vdd pch W=60u L=1u
Mu4_7_35 n_w7_35 n_up7_35 vdd vdd pch W=60u L=1u
Rinit7_36hi reset n_init7_36 430.707437035
Rinit7_36lo n_init7_36 0 569.292562965
Cw7_36 n_w7_36 0 5e-06
Mreset7_36 n_init7_36 reset n_w7_36 0 syn W=1000u L=1u
Mpos7_36 n_hv36 n_w7_36 n_op7 0 syn W=4u L=1u
Mneg7_36 n_hv36 vweight n_on7 0 syn W=4u L=1u
Menable7_36 n_enable7_36 learn 0 0 nch W=1000u L=1u
Mutail7_36 n_utail7_36 n_hv36 n_enable7_36 0 nch W=20u L=1u
Mu1_7_36 n_up7_36 n_az7 n_utail7_36 0 nch W=20u L=1u
Mu2_7_36 n_w7_36 n_error7 n_utail7_36 0 nch W=20u L=1u
Mu3_7_36 n_up7_36 n_up7_36 vdd vdd pch W=60u L=1u
Mu4_7_36 n_w7_36 n_up7_36 vdd vdd pch W=60u L=1u
Rinit7_37hi reset n_init7_37 371.689867688
Rinit7_37lo n_init7_37 0 628.310132312
Cw7_37 n_w7_37 0 5e-06
Mreset7_37 n_init7_37 reset n_w7_37 0 syn W=1000u L=1u
Mpos7_37 n_hv37 n_w7_37 n_op7 0 syn W=4u L=1u
Mneg7_37 n_hv37 vweight n_on7 0 syn W=4u L=1u
Menable7_37 n_enable7_37 learn 0 0 nch W=1000u L=1u
Mutail7_37 n_utail7_37 n_hv37 n_enable7_37 0 nch W=20u L=1u
Mu1_7_37 n_up7_37 n_az7 n_utail7_37 0 nch W=20u L=1u
Mu2_7_37 n_w7_37 n_error7 n_utail7_37 0 nch W=20u L=1u
Mu3_7_37 n_up7_37 n_up7_37 vdd vdd pch W=60u L=1u
Mu4_7_37 n_w7_37 n_up7_37 vdd vdd pch W=60u L=1u
Rinit7_38hi reset n_init7_38 431.533626229
Rinit7_38lo n_init7_38 0 568.466373771
Cw7_38 n_w7_38 0 5e-06
Mreset7_38 n_init7_38 reset n_w7_38 0 syn W=1000u L=1u
Mpos7_38 n_hv38 n_w7_38 n_op7 0 syn W=4u L=1u
Mneg7_38 n_hv38 vweight n_on7 0 syn W=4u L=1u
Menable7_38 n_enable7_38 learn 0 0 nch W=1000u L=1u
Mutail7_38 n_utail7_38 n_hv38 n_enable7_38 0 nch W=20u L=1u
Mu1_7_38 n_up7_38 n_az7 n_utail7_38 0 nch W=20u L=1u
Mu2_7_38 n_w7_38 n_error7 n_utail7_38 0 nch W=20u L=1u
Mu3_7_38 n_up7_38 n_up7_38 vdd vdd pch W=60u L=1u
Mu4_7_38 n_w7_38 n_up7_38 vdd vdd pch W=60u L=1u
Rinit7_39hi reset n_init7_39 409.090845219
Rinit7_39lo n_init7_39 0 590.909154781
Cw7_39 n_w7_39 0 5e-06
Mreset7_39 n_init7_39 reset n_w7_39 0 syn W=1000u L=1u
Mpos7_39 n_hv39 n_w7_39 n_op7 0 syn W=4u L=1u
Mneg7_39 n_hv39 vweight n_on7 0 syn W=4u L=1u
Menable7_39 n_enable7_39 learn 0 0 nch W=1000u L=1u
Mutail7_39 n_utail7_39 n_hv39 n_enable7_39 0 nch W=20u L=1u
Mu1_7_39 n_up7_39 n_az7 n_utail7_39 0 nch W=20u L=1u
Mu2_7_39 n_w7_39 n_error7 n_utail7_39 0 nch W=20u L=1u
Mu3_7_39 n_up7_39 n_up7_39 vdd vdd pch W=60u L=1u
Mu4_7_39 n_w7_39 n_up7_39 vdd vdd pch W=60u L=1u
Rinit7_40hi reset n_init7_40 367.568847714
Rinit7_40lo n_init7_40 0 632.431152286
Cw7_40 n_w7_40 0 5e-06
Mreset7_40 n_init7_40 reset n_w7_40 0 syn W=1000u L=1u
Mpos7_40 n_hv40 n_w7_40 n_op7 0 syn W=4u L=1u
Mneg7_40 n_hv40 vweight n_on7 0 syn W=4u L=1u
Menable7_40 n_enable7_40 learn 0 0 nch W=1000u L=1u
Mutail7_40 n_utail7_40 n_hv40 n_enable7_40 0 nch W=20u L=1u
Mu1_7_40 n_up7_40 n_az7 n_utail7_40 0 nch W=20u L=1u
Mu2_7_40 n_w7_40 n_error7 n_utail7_40 0 nch W=20u L=1u
Mu3_7_40 n_up7_40 n_up7_40 vdd vdd pch W=60u L=1u
Mu4_7_40 n_w7_40 n_up7_40 vdd vdd pch W=60u L=1u
Rinit7_41hi reset n_init7_41 423.903995057
Rinit7_41lo n_init7_41 0 576.096004943
Cw7_41 n_w7_41 0 5e-06
Mreset7_41 n_init7_41 reset n_w7_41 0 syn W=1000u L=1u
Mpos7_41 n_hv41 n_w7_41 n_op7 0 syn W=4u L=1u
Mneg7_41 n_hv41 vweight n_on7 0 syn W=4u L=1u
Menable7_41 n_enable7_41 learn 0 0 nch W=1000u L=1u
Mutail7_41 n_utail7_41 n_hv41 n_enable7_41 0 nch W=20u L=1u
Mu1_7_41 n_up7_41 n_az7 n_utail7_41 0 nch W=20u L=1u
Mu2_7_41 n_w7_41 n_error7 n_utail7_41 0 nch W=20u L=1u
Mu3_7_41 n_up7_41 n_up7_41 vdd vdd pch W=60u L=1u
Mu4_7_41 n_w7_41 n_up7_41 vdd vdd pch W=60u L=1u
Rinit7_42hi reset n_init7_42 398.340589847
Rinit7_42lo n_init7_42 0 601.659410153
Cw7_42 n_w7_42 0 5e-06
Mreset7_42 n_init7_42 reset n_w7_42 0 syn W=1000u L=1u
Mpos7_42 n_hv42 n_w7_42 n_op7 0 syn W=4u L=1u
Mneg7_42 n_hv42 vweight n_on7 0 syn W=4u L=1u
Menable7_42 n_enable7_42 learn 0 0 nch W=1000u L=1u
Mutail7_42 n_utail7_42 n_hv42 n_enable7_42 0 nch W=20u L=1u
Mu1_7_42 n_up7_42 n_az7 n_utail7_42 0 nch W=20u L=1u
Mu2_7_42 n_w7_42 n_error7 n_utail7_42 0 nch W=20u L=1u
Mu3_7_42 n_up7_42 n_up7_42 vdd vdd pch W=60u L=1u
Mu4_7_42 n_w7_42 n_up7_42 vdd vdd pch W=60u L=1u
Rinit7_43hi reset n_init7_43 406.671677385
Rinit7_43lo n_init7_43 0 593.328322615
Cw7_43 n_w7_43 0 5e-06
Mreset7_43 n_init7_43 reset n_w7_43 0 syn W=1000u L=1u
Mpos7_43 n_hv43 n_w7_43 n_op7 0 syn W=4u L=1u
Mneg7_43 n_hv43 vweight n_on7 0 syn W=4u L=1u
Menable7_43 n_enable7_43 learn 0 0 nch W=1000u L=1u
Mutail7_43 n_utail7_43 n_hv43 n_enable7_43 0 nch W=20u L=1u
Mu1_7_43 n_up7_43 n_az7 n_utail7_43 0 nch W=20u L=1u
Mu2_7_43 n_w7_43 n_error7 n_utail7_43 0 nch W=20u L=1u
Mu3_7_43 n_up7_43 n_up7_43 vdd vdd pch W=60u L=1u
Mu4_7_43 n_w7_43 n_up7_43 vdd vdd pch W=60u L=1u
Rinit7_44hi reset n_init7_44 368.964217344
Rinit7_44lo n_init7_44 0 631.035782656
Cw7_44 n_w7_44 0 5e-06
Mreset7_44 n_init7_44 reset n_w7_44 0 syn W=1000u L=1u
Mpos7_44 n_hv44 n_w7_44 n_op7 0 syn W=4u L=1u
Mneg7_44 n_hv44 vweight n_on7 0 syn W=4u L=1u
Menable7_44 n_enable7_44 learn 0 0 nch W=1000u L=1u
Mutail7_44 n_utail7_44 n_hv44 n_enable7_44 0 nch W=20u L=1u
Mu1_7_44 n_up7_44 n_az7 n_utail7_44 0 nch W=20u L=1u
Mu2_7_44 n_w7_44 n_error7 n_utail7_44 0 nch W=20u L=1u
Mu3_7_44 n_up7_44 n_up7_44 vdd vdd pch W=60u L=1u
Mu4_7_44 n_w7_44 n_up7_44 vdd vdd pch W=60u L=1u
Rinit7_45hi reset n_init7_45 360.634824314
Rinit7_45lo n_init7_45 0 639.365175686
Cw7_45 n_w7_45 0 5e-06
Mreset7_45 n_init7_45 reset n_w7_45 0 syn W=1000u L=1u
Mpos7_45 n_hv45 n_w7_45 n_op7 0 syn W=4u L=1u
Mneg7_45 n_hv45 vweight n_on7 0 syn W=4u L=1u
Menable7_45 n_enable7_45 learn 0 0 nch W=1000u L=1u
Mutail7_45 n_utail7_45 n_hv45 n_enable7_45 0 nch W=20u L=1u
Mu1_7_45 n_up7_45 n_az7 n_utail7_45 0 nch W=20u L=1u
Mu2_7_45 n_w7_45 n_error7 n_utail7_45 0 nch W=20u L=1u
Mu3_7_45 n_up7_45 n_up7_45 vdd vdd pch W=60u L=1u
Mu4_7_45 n_w7_45 n_up7_45 vdd vdd pch W=60u L=1u
Rinit7_46hi reset n_init7_46 416.912595112
Rinit7_46lo n_init7_46 0 583.087404888
Cw7_46 n_w7_46 0 5e-06
Mreset7_46 n_init7_46 reset n_w7_46 0 syn W=1000u L=1u
Mpos7_46 n_hv46 n_w7_46 n_op7 0 syn W=4u L=1u
Mneg7_46 n_hv46 vweight n_on7 0 syn W=4u L=1u
Menable7_46 n_enable7_46 learn 0 0 nch W=1000u L=1u
Mutail7_46 n_utail7_46 n_hv46 n_enable7_46 0 nch W=20u L=1u
Mu1_7_46 n_up7_46 n_az7 n_utail7_46 0 nch W=20u L=1u
Mu2_7_46 n_w7_46 n_error7 n_utail7_46 0 nch W=20u L=1u
Mu3_7_46 n_up7_46 n_up7_46 vdd vdd pch W=60u L=1u
Mu4_7_46 n_w7_46 n_up7_46 vdd vdd pch W=60u L=1u
Rinit7_47hi reset n_init7_47 400.601876596
Rinit7_47lo n_init7_47 0 599.398123404
Cw7_47 n_w7_47 0 5e-06
Mreset7_47 n_init7_47 reset n_w7_47 0 syn W=1000u L=1u
Mpos7_47 n_hv47 n_w7_47 n_op7 0 syn W=4u L=1u
Mneg7_47 n_hv47 vweight n_on7 0 syn W=4u L=1u
Menable7_47 n_enable7_47 learn 0 0 nch W=1000u L=1u
Mutail7_47 n_utail7_47 n_hv47 n_enable7_47 0 nch W=20u L=1u
Mu1_7_47 n_up7_47 n_az7 n_utail7_47 0 nch W=20u L=1u
Mu2_7_47 n_w7_47 n_error7 n_utail7_47 0 nch W=20u L=1u
Mu3_7_47 n_up7_47 n_up7_47 vdd vdd pch W=60u L=1u
Mu4_7_47 n_w7_47 n_up7_47 vdd vdd pch W=60u L=1u
Rinit7_48hi reset n_init7_48 368.399587983
Rinit7_48lo n_init7_48 0 631.600412017
Cw7_48 n_w7_48 0 5e-06
Mreset7_48 n_init7_48 reset n_w7_48 0 syn W=1000u L=1u
Mpos7_48 n_hv48 n_w7_48 n_op7 0 syn W=4u L=1u
Mneg7_48 n_hv48 vweight n_on7 0 syn W=4u L=1u
Menable7_48 n_enable7_48 learn 0 0 nch W=1000u L=1u
Mutail7_48 n_utail7_48 n_hv48 n_enable7_48 0 nch W=20u L=1u
Mu1_7_48 n_up7_48 n_az7 n_utail7_48 0 nch W=20u L=1u
Mu2_7_48 n_w7_48 n_error7 n_utail7_48 0 nch W=20u L=1u
Mu3_7_48 n_up7_48 n_up7_48 vdd vdd pch W=60u L=1u
Mu4_7_48 n_w7_48 n_up7_48 vdd vdd pch W=60u L=1u
Rinit7_49hi reset n_init7_49 396.416345887
Rinit7_49lo n_init7_49 0 603.583654113
Cw7_49 n_w7_49 0 5e-06
Mreset7_49 n_init7_49 reset n_w7_49 0 syn W=1000u L=1u
Mpos7_49 n_hv49 n_w7_49 n_op7 0 syn W=4u L=1u
Mneg7_49 n_hv49 vweight n_on7 0 syn W=4u L=1u
Menable7_49 n_enable7_49 learn 0 0 nch W=1000u L=1u
Mutail7_49 n_utail7_49 n_hv49 n_enable7_49 0 nch W=20u L=1u
Mu1_7_49 n_up7_49 n_az7 n_utail7_49 0 nch W=20u L=1u
Mu2_7_49 n_w7_49 n_error7 n_utail7_49 0 nch W=20u L=1u
Mu3_7_49 n_up7_49 n_up7_49 vdd vdd pch W=60u L=1u
Mu4_7_49 n_w7_49 n_up7_49 vdd vdd pch W=60u L=1u
Rinit7_50hi reset n_init7_50 422.830004818
Rinit7_50lo n_init7_50 0 577.169995182
Cw7_50 n_w7_50 0 5e-06
Mreset7_50 n_init7_50 reset n_w7_50 0 syn W=1000u L=1u
Mpos7_50 n_hv50 n_w7_50 n_op7 0 syn W=4u L=1u
Mneg7_50 n_hv50 vweight n_on7 0 syn W=4u L=1u
Menable7_50 n_enable7_50 learn 0 0 nch W=1000u L=1u
Mutail7_50 n_utail7_50 n_hv50 n_enable7_50 0 nch W=20u L=1u
Mu1_7_50 n_up7_50 n_az7 n_utail7_50 0 nch W=20u L=1u
Mu2_7_50 n_w7_50 n_error7 n_utail7_50 0 nch W=20u L=1u
Mu3_7_50 n_up7_50 n_up7_50 vdd vdd pch W=60u L=1u
Mu4_7_50 n_w7_50 n_up7_50 vdd vdd pch W=60u L=1u
Rinit7_51hi reset n_init7_51 379.227015004
Rinit7_51lo n_init7_51 0 620.772984996
Cw7_51 n_w7_51 0 5e-06
Mreset7_51 n_init7_51 reset n_w7_51 0 syn W=1000u L=1u
Mpos7_51 n_hv51 n_w7_51 n_op7 0 syn W=4u L=1u
Mneg7_51 n_hv51 vweight n_on7 0 syn W=4u L=1u
Menable7_51 n_enable7_51 learn 0 0 nch W=1000u L=1u
Mutail7_51 n_utail7_51 n_hv51 n_enable7_51 0 nch W=20u L=1u
Mu1_7_51 n_up7_51 n_az7 n_utail7_51 0 nch W=20u L=1u
Mu2_7_51 n_w7_51 n_error7 n_utail7_51 0 nch W=20u L=1u
Mu3_7_51 n_up7_51 n_up7_51 vdd vdd pch W=60u L=1u
Mu4_7_51 n_w7_51 n_up7_51 vdd vdd pch W=60u L=1u
Rinit7_52hi reset n_init7_52 413.03285607
Rinit7_52lo n_init7_52 0 586.96714393
Cw7_52 n_w7_52 0 5e-06
Mreset7_52 n_init7_52 reset n_w7_52 0 syn W=1000u L=1u
Mpos7_52 n_hv52 n_w7_52 n_op7 0 syn W=4u L=1u
Mneg7_52 n_hv52 vweight n_on7 0 syn W=4u L=1u
Menable7_52 n_enable7_52 learn 0 0 nch W=1000u L=1u
Mutail7_52 n_utail7_52 n_hv52 n_enable7_52 0 nch W=20u L=1u
Mu1_7_52 n_up7_52 n_az7 n_utail7_52 0 nch W=20u L=1u
Mu2_7_52 n_w7_52 n_error7 n_utail7_52 0 nch W=20u L=1u
Mu3_7_52 n_up7_52 n_up7_52 vdd vdd pch W=60u L=1u
Mu4_7_52 n_w7_52 n_up7_52 vdd vdd pch W=60u L=1u
Rinit7_53hi reset n_init7_53 401.122050224
Rinit7_53lo n_init7_53 0 598.877949776
Cw7_53 n_w7_53 0 5e-06
Mreset7_53 n_init7_53 reset n_w7_53 0 syn W=1000u L=1u
Mpos7_53 n_hv53 n_w7_53 n_op7 0 syn W=4u L=1u
Mneg7_53 n_hv53 vweight n_on7 0 syn W=4u L=1u
Menable7_53 n_enable7_53 learn 0 0 nch W=1000u L=1u
Mutail7_53 n_utail7_53 n_hv53 n_enable7_53 0 nch W=20u L=1u
Mu1_7_53 n_up7_53 n_az7 n_utail7_53 0 nch W=20u L=1u
Mu2_7_53 n_w7_53 n_error7 n_utail7_53 0 nch W=20u L=1u
Mu3_7_53 n_up7_53 n_up7_53 vdd vdd pch W=60u L=1u
Mu4_7_53 n_w7_53 n_up7_53 vdd vdd pch W=60u L=1u
Rinit7_54hi reset n_init7_54 439.315047408
Rinit7_54lo n_init7_54 0 560.684952592
Cw7_54 n_w7_54 0 5e-06
Mreset7_54 n_init7_54 reset n_w7_54 0 syn W=1000u L=1u
Mpos7_54 n_hv54 n_w7_54 n_op7 0 syn W=4u L=1u
Mneg7_54 n_hv54 vweight n_on7 0 syn W=4u L=1u
Menable7_54 n_enable7_54 learn 0 0 nch W=1000u L=1u
Mutail7_54 n_utail7_54 n_hv54 n_enable7_54 0 nch W=20u L=1u
Mu1_7_54 n_up7_54 n_az7 n_utail7_54 0 nch W=20u L=1u
Mu2_7_54 n_w7_54 n_error7 n_utail7_54 0 nch W=20u L=1u
Mu3_7_54 n_up7_54 n_up7_54 vdd vdd pch W=60u L=1u
Mu4_7_54 n_w7_54 n_up7_54 vdd vdd pch W=60u L=1u
Rinit7_55hi reset n_init7_55 360.88263647
Rinit7_55lo n_init7_55 0 639.11736353
Cw7_55 n_w7_55 0 5e-06
Mreset7_55 n_init7_55 reset n_w7_55 0 syn W=1000u L=1u
Mpos7_55 n_hv55 n_w7_55 n_op7 0 syn W=4u L=1u
Mneg7_55 n_hv55 vweight n_on7 0 syn W=4u L=1u
Menable7_55 n_enable7_55 learn 0 0 nch W=1000u L=1u
Mutail7_55 n_utail7_55 n_hv55 n_enable7_55 0 nch W=20u L=1u
Mu1_7_55 n_up7_55 n_az7 n_utail7_55 0 nch W=20u L=1u
Mu2_7_55 n_w7_55 n_error7 n_utail7_55 0 nch W=20u L=1u
Mu3_7_55 n_up7_55 n_up7_55 vdd vdd pch W=60u L=1u
Mu4_7_55 n_w7_55 n_up7_55 vdd vdd pch W=60u L=1u
Rinit7_56hi reset n_init7_56 387.417411001
Rinit7_56lo n_init7_56 0 612.582588999
Cw7_56 n_w7_56 0 5e-06
Mreset7_56 n_init7_56 reset n_w7_56 0 syn W=1000u L=1u
Mpos7_56 n_hv56 n_w7_56 n_op7 0 syn W=4u L=1u
Mneg7_56 n_hv56 vweight n_on7 0 syn W=4u L=1u
Menable7_56 n_enable7_56 learn 0 0 nch W=1000u L=1u
Mutail7_56 n_utail7_56 n_hv56 n_enable7_56 0 nch W=20u L=1u
Mu1_7_56 n_up7_56 n_az7 n_utail7_56 0 nch W=20u L=1u
Mu2_7_56 n_w7_56 n_error7 n_utail7_56 0 nch W=20u L=1u
Mu3_7_56 n_up7_56 n_up7_56 vdd vdd pch W=60u L=1u
Mu4_7_56 n_w7_56 n_up7_56 vdd vdd pch W=60u L=1u
Rinit7_57hi reset n_init7_57 365.934972235
Rinit7_57lo n_init7_57 0 634.065027765
Cw7_57 n_w7_57 0 5e-06
Mreset7_57 n_init7_57 reset n_w7_57 0 syn W=1000u L=1u
Mpos7_57 n_hv57 n_w7_57 n_op7 0 syn W=4u L=1u
Mneg7_57 n_hv57 vweight n_on7 0 syn W=4u L=1u
Menable7_57 n_enable7_57 learn 0 0 nch W=1000u L=1u
Mutail7_57 n_utail7_57 n_hv57 n_enable7_57 0 nch W=20u L=1u
Mu1_7_57 n_up7_57 n_az7 n_utail7_57 0 nch W=20u L=1u
Mu2_7_57 n_w7_57 n_error7 n_utail7_57 0 nch W=20u L=1u
Mu3_7_57 n_up7_57 n_up7_57 vdd vdd pch W=60u L=1u
Mu4_7_57 n_w7_57 n_up7_57 vdd vdd pch W=60u L=1u
Rinit7_58hi reset n_init7_58 362.505177433
Rinit7_58lo n_init7_58 0 637.494822567
Cw7_58 n_w7_58 0 5e-06
Mreset7_58 n_init7_58 reset n_w7_58 0 syn W=1000u L=1u
Mpos7_58 n_hv58 n_w7_58 n_op7 0 syn W=4u L=1u
Mneg7_58 n_hv58 vweight n_on7 0 syn W=4u L=1u
Menable7_58 n_enable7_58 learn 0 0 nch W=1000u L=1u
Mutail7_58 n_utail7_58 n_hv58 n_enable7_58 0 nch W=20u L=1u
Mu1_7_58 n_up7_58 n_az7 n_utail7_58 0 nch W=20u L=1u
Mu2_7_58 n_w7_58 n_error7 n_utail7_58 0 nch W=20u L=1u
Mu3_7_58 n_up7_58 n_up7_58 vdd vdd pch W=60u L=1u
Mu4_7_58 n_w7_58 n_up7_58 vdd vdd pch W=60u L=1u
Rinit7_59hi reset n_init7_59 418.597305383
Rinit7_59lo n_init7_59 0 581.402694617
Cw7_59 n_w7_59 0 5e-06
Mreset7_59 n_init7_59 reset n_w7_59 0 syn W=1000u L=1u
Mpos7_59 n_hv59 n_w7_59 n_op7 0 syn W=4u L=1u
Mneg7_59 n_hv59 vweight n_on7 0 syn W=4u L=1u
Menable7_59 n_enable7_59 learn 0 0 nch W=1000u L=1u
Mutail7_59 n_utail7_59 n_hv59 n_enable7_59 0 nch W=20u L=1u
Mu1_7_59 n_up7_59 n_az7 n_utail7_59 0 nch W=20u L=1u
Mu2_7_59 n_w7_59 n_error7 n_utail7_59 0 nch W=20u L=1u
Mu3_7_59 n_up7_59 n_up7_59 vdd vdd pch W=60u L=1u
Mu4_7_59 n_w7_59 n_up7_59 vdd vdd pch W=60u L=1u
Rinit7_60hi reset n_init7_60 396.757121905
Rinit7_60lo n_init7_60 0 603.242878095
Cw7_60 n_w7_60 0 5e-06
Mreset7_60 n_init7_60 reset n_w7_60 0 syn W=1000u L=1u
Mpos7_60 n_hv60 n_w7_60 n_op7 0 syn W=4u L=1u
Mneg7_60 n_hv60 vweight n_on7 0 syn W=4u L=1u
Menable7_60 n_enable7_60 learn 0 0 nch W=1000u L=1u
Mutail7_60 n_utail7_60 n_hv60 n_enable7_60 0 nch W=20u L=1u
Mu1_7_60 n_up7_60 n_az7 n_utail7_60 0 nch W=20u L=1u
Mu2_7_60 n_w7_60 n_error7 n_utail7_60 0 nch W=20u L=1u
Mu3_7_60 n_up7_60 n_up7_60 vdd vdd pch W=60u L=1u
Mu4_7_60 n_w7_60 n_up7_60 vdd vdd pch W=60u L=1u
Rinit7_61hi reset n_init7_61 404.779901326
Rinit7_61lo n_init7_61 0 595.220098674
Cw7_61 n_w7_61 0 5e-06
Mreset7_61 n_init7_61 reset n_w7_61 0 syn W=1000u L=1u
Mpos7_61 n_hv61 n_w7_61 n_op7 0 syn W=4u L=1u
Mneg7_61 n_hv61 vweight n_on7 0 syn W=4u L=1u
Menable7_61 n_enable7_61 learn 0 0 nch W=1000u L=1u
Mutail7_61 n_utail7_61 n_hv61 n_enable7_61 0 nch W=20u L=1u
Mu1_7_61 n_up7_61 n_az7 n_utail7_61 0 nch W=20u L=1u
Mu2_7_61 n_w7_61 n_error7 n_utail7_61 0 nch W=20u L=1u
Mu3_7_61 n_up7_61 n_up7_61 vdd vdd pch W=60u L=1u
Mu4_7_61 n_w7_61 n_up7_61 vdd vdd pch W=60u L=1u
Rinit7_62hi reset n_init7_62 379.211582599
Rinit7_62lo n_init7_62 0 620.788417401
Cw7_62 n_w7_62 0 5e-06
Mreset7_62 n_init7_62 reset n_w7_62 0 syn W=1000u L=1u
Mpos7_62 n_hv62 n_w7_62 n_op7 0 syn W=4u L=1u
Mneg7_62 n_hv62 vweight n_on7 0 syn W=4u L=1u
Menable7_62 n_enable7_62 learn 0 0 nch W=1000u L=1u
Mutail7_62 n_utail7_62 n_hv62 n_enable7_62 0 nch W=20u L=1u
Mu1_7_62 n_up7_62 n_az7 n_utail7_62 0 nch W=20u L=1u
Mu2_7_62 n_w7_62 n_error7 n_utail7_62 0 nch W=20u L=1u
Mu3_7_62 n_up7_62 n_up7_62 vdd vdd pch W=60u L=1u
Mu4_7_62 n_w7_62 n_up7_62 vdd vdd pch W=60u L=1u
Rinit7_63hi reset n_init7_63 372.609146773
Rinit7_63lo n_init7_63 0 627.390853227
Cw7_63 n_w7_63 0 5e-06
Mreset7_63 n_init7_63 reset n_w7_63 0 syn W=1000u L=1u
Mpos7_63 n_hv63 n_w7_63 n_op7 0 syn W=4u L=1u
Mneg7_63 n_hv63 vweight n_on7 0 syn W=4u L=1u
Menable7_63 n_enable7_63 learn 0 0 nch W=1000u L=1u
Mutail7_63 n_utail7_63 n_hv63 n_enable7_63 0 nch W=20u L=1u
Mu1_7_63 n_up7_63 n_az7 n_utail7_63 0 nch W=20u L=1u
Mu2_7_63 n_w7_63 n_error7 n_utail7_63 0 nch W=20u L=1u
Mu3_7_63 n_up7_63 n_up7_63 vdd vdd pch W=60u L=1u
Mu4_7_63 n_w7_63 n_up7_63 vdd vdd pch W=60u L=1u
Rinit7_64hi reset n_init7_64 421.715187128
Rinit7_64lo n_init7_64 0 578.284812872
Cw7_64 n_w7_64 0 5e-06
Mreset7_64 n_init7_64 reset n_w7_64 0 syn W=1000u L=1u
Mpos7_64 n_hv64 n_w7_64 n_op7 0 syn W=4u L=1u
Mneg7_64 n_hv64 vweight n_on7 0 syn W=4u L=1u
Menable7_64 n_enable7_64 learn 0 0 nch W=1000u L=1u
Mutail7_64 n_utail7_64 n_hv64 n_enable7_64 0 nch W=20u L=1u
Mu1_7_64 n_up7_64 n_az7 n_utail7_64 0 nch W=20u L=1u
Mu2_7_64 n_w7_64 n_error7 n_utail7_64 0 nch W=20u L=1u
Mu3_7_64 n_up7_64 n_up7_64 vdd vdd pch W=60u L=1u
Mu4_7_64 n_w7_64 n_up7_64 vdd vdd pch W=60u L=1u
Rinit7_65hi reset n_init7_65 418.034826952
Rinit7_65lo n_init7_65 0 581.965173048
Cw7_65 n_w7_65 0 5e-06
Mreset7_65 n_init7_65 reset n_w7_65 0 syn W=1000u L=1u
Mpos7_65 n_hv65 n_w7_65 n_op7 0 syn W=4u L=1u
Mneg7_65 n_hv65 vweight n_on7 0 syn W=4u L=1u
Menable7_65 n_enable7_65 learn 0 0 nch W=1000u L=1u
Mutail7_65 n_utail7_65 n_hv65 n_enable7_65 0 nch W=20u L=1u
Mu1_7_65 n_up7_65 n_az7 n_utail7_65 0 nch W=20u L=1u
Mu2_7_65 n_w7_65 n_error7 n_utail7_65 0 nch W=20u L=1u
Mu3_7_65 n_up7_65 n_up7_65 vdd vdd pch W=60u L=1u
Mu4_7_65 n_w7_65 n_up7_65 vdd vdd pch W=60u L=1u
Rinit7_66hi reset n_init7_66 383.49907622
Rinit7_66lo n_init7_66 0 616.50092378
Cw7_66 n_w7_66 0 5e-06
Mreset7_66 n_init7_66 reset n_w7_66 0 syn W=1000u L=1u
Mpos7_66 n_hv66 n_w7_66 n_op7 0 syn W=4u L=1u
Mneg7_66 n_hv66 vweight n_on7 0 syn W=4u L=1u
Menable7_66 n_enable7_66 learn 0 0 nch W=1000u L=1u
Mutail7_66 n_utail7_66 n_hv66 n_enable7_66 0 nch W=20u L=1u
Mu1_7_66 n_up7_66 n_az7 n_utail7_66 0 nch W=20u L=1u
Mu2_7_66 n_w7_66 n_error7 n_utail7_66 0 nch W=20u L=1u
Mu3_7_66 n_up7_66 n_up7_66 vdd vdd pch W=60u L=1u
Mu4_7_66 n_w7_66 n_up7_66 vdd vdd pch W=60u L=1u
Rinit7_67hi reset n_init7_67 407.068555863
Rinit7_67lo n_init7_67 0 592.931444137
Cw7_67 n_w7_67 0 5e-06
Mreset7_67 n_init7_67 reset n_w7_67 0 syn W=1000u L=1u
Mpos7_67 n_hv67 n_w7_67 n_op7 0 syn W=4u L=1u
Mneg7_67 n_hv67 vweight n_on7 0 syn W=4u L=1u
Menable7_67 n_enable7_67 learn 0 0 nch W=1000u L=1u
Mutail7_67 n_utail7_67 n_hv67 n_enable7_67 0 nch W=20u L=1u
Mu1_7_67 n_up7_67 n_az7 n_utail7_67 0 nch W=20u L=1u
Mu2_7_67 n_w7_67 n_error7 n_utail7_67 0 nch W=20u L=1u
Mu3_7_67 n_up7_67 n_up7_67 vdd vdd pch W=60u L=1u
Mu4_7_67 n_w7_67 n_up7_67 vdd vdd pch W=60u L=1u
Rinit7_68hi reset n_init7_68 429.583877172
Rinit7_68lo n_init7_68 0 570.416122828
Cw7_68 n_w7_68 0 5e-06
Mreset7_68 n_init7_68 reset n_w7_68 0 syn W=1000u L=1u
Mpos7_68 n_hv68 n_w7_68 n_op7 0 syn W=4u L=1u
Mneg7_68 n_hv68 vweight n_on7 0 syn W=4u L=1u
Menable7_68 n_enable7_68 learn 0 0 nch W=1000u L=1u
Mutail7_68 n_utail7_68 n_hv68 n_enable7_68 0 nch W=20u L=1u
Mu1_7_68 n_up7_68 n_az7 n_utail7_68 0 nch W=20u L=1u
Mu2_7_68 n_w7_68 n_error7 n_utail7_68 0 nch W=20u L=1u
Mu3_7_68 n_up7_68 n_up7_68 vdd vdd pch W=60u L=1u
Mu4_7_68 n_w7_68 n_up7_68 vdd vdd pch W=60u L=1u
Rinit7_69hi reset n_init7_69 424.375152941
Rinit7_69lo n_init7_69 0 575.624847059
Cw7_69 n_w7_69 0 5e-06
Mreset7_69 n_init7_69 reset n_w7_69 0 syn W=1000u L=1u
Mpos7_69 n_hv69 n_w7_69 n_op7 0 syn W=4u L=1u
Mneg7_69 n_hv69 vweight n_on7 0 syn W=4u L=1u
Menable7_69 n_enable7_69 learn 0 0 nch W=1000u L=1u
Mutail7_69 n_utail7_69 n_hv69 n_enable7_69 0 nch W=20u L=1u
Mu1_7_69 n_up7_69 n_az7 n_utail7_69 0 nch W=20u L=1u
Mu2_7_69 n_w7_69 n_error7 n_utail7_69 0 nch W=20u L=1u
Mu3_7_69 n_up7_69 n_up7_69 vdd vdd pch W=60u L=1u
Mu4_7_69 n_w7_69 n_up7_69 vdd vdd pch W=60u L=1u
Rinit7_70hi reset n_init7_70 395.132054907
Rinit7_70lo n_init7_70 0 604.867945093
Cw7_70 n_w7_70 0 5e-06
Mreset7_70 n_init7_70 reset n_w7_70 0 syn W=1000u L=1u
Mpos7_70 n_hv70 n_w7_70 n_op7 0 syn W=4u L=1u
Mneg7_70 n_hv70 vweight n_on7 0 syn W=4u L=1u
Menable7_70 n_enable7_70 learn 0 0 nch W=1000u L=1u
Mutail7_70 n_utail7_70 n_hv70 n_enable7_70 0 nch W=20u L=1u
Mu1_7_70 n_up7_70 n_az7 n_utail7_70 0 nch W=20u L=1u
Mu2_7_70 n_w7_70 n_error7 n_utail7_70 0 nch W=20u L=1u
Mu3_7_70 n_up7_70 n_up7_70 vdd vdd pch W=60u L=1u
Mu4_7_70 n_w7_70 n_up7_70 vdd vdd pch W=60u L=1u
Rinit7_71hi reset n_init7_71 392.120444236
Rinit7_71lo n_init7_71 0 607.879555764
Cw7_71 n_w7_71 0 5e-06
Mreset7_71 n_init7_71 reset n_w7_71 0 syn W=1000u L=1u
Mpos7_71 n_hv71 n_w7_71 n_op7 0 syn W=4u L=1u
Mneg7_71 n_hv71 vweight n_on7 0 syn W=4u L=1u
Menable7_71 n_enable7_71 learn 0 0 nch W=1000u L=1u
Mutail7_71 n_utail7_71 n_hv71 n_enable7_71 0 nch W=20u L=1u
Mu1_7_71 n_up7_71 n_az7 n_utail7_71 0 nch W=20u L=1u
Mu2_7_71 n_w7_71 n_error7 n_utail7_71 0 nch W=20u L=1u
Mu3_7_71 n_up7_71 n_up7_71 vdd vdd pch W=60u L=1u
Mu4_7_71 n_w7_71 n_up7_71 vdd vdd pch W=60u L=1u
Rinit7_72hi reset n_init7_72 363.194274271
Rinit7_72lo n_init7_72 0 636.805725729
Cw7_72 n_w7_72 0 5e-06
Mreset7_72 n_init7_72 reset n_w7_72 0 syn W=1000u L=1u
Mpos7_72 n_hv72 n_w7_72 n_op7 0 syn W=4u L=1u
Mneg7_72 n_hv72 vweight n_on7 0 syn W=4u L=1u
Menable7_72 n_enable7_72 learn 0 0 nch W=1000u L=1u
Mutail7_72 n_utail7_72 n_hv72 n_enable7_72 0 nch W=20u L=1u
Mu1_7_72 n_up7_72 n_az7 n_utail7_72 0 nch W=20u L=1u
Mu2_7_72 n_w7_72 n_error7 n_utail7_72 0 nch W=20u L=1u
Mu3_7_72 n_up7_72 n_up7_72 vdd vdd pch W=60u L=1u
Mu4_7_72 n_w7_72 n_up7_72 vdd vdd pch W=60u L=1u
Rinit7_73hi reset n_init7_73 397.377603749
Rinit7_73lo n_init7_73 0 602.622396251
Cw7_73 n_w7_73 0 5e-06
Mreset7_73 n_init7_73 reset n_w7_73 0 syn W=1000u L=1u
Mpos7_73 n_hv73 n_w7_73 n_op7 0 syn W=4u L=1u
Mneg7_73 n_hv73 vweight n_on7 0 syn W=4u L=1u
Menable7_73 n_enable7_73 learn 0 0 nch W=1000u L=1u
Mutail7_73 n_utail7_73 n_hv73 n_enable7_73 0 nch W=20u L=1u
Mu1_7_73 n_up7_73 n_az7 n_utail7_73 0 nch W=20u L=1u
Mu2_7_73 n_w7_73 n_error7 n_utail7_73 0 nch W=20u L=1u
Mu3_7_73 n_up7_73 n_up7_73 vdd vdd pch W=60u L=1u
Mu4_7_73 n_w7_73 n_up7_73 vdd vdd pch W=60u L=1u
Rinit7_74hi reset n_init7_74 391.281538898
Rinit7_74lo n_init7_74 0 608.718461102
Cw7_74 n_w7_74 0 5e-06
Mreset7_74 n_init7_74 reset n_w7_74 0 syn W=1000u L=1u
Mpos7_74 n_hv74 n_w7_74 n_op7 0 syn W=4u L=1u
Mneg7_74 n_hv74 vweight n_on7 0 syn W=4u L=1u
Menable7_74 n_enable7_74 learn 0 0 nch W=1000u L=1u
Mutail7_74 n_utail7_74 n_hv74 n_enable7_74 0 nch W=20u L=1u
Mu1_7_74 n_up7_74 n_az7 n_utail7_74 0 nch W=20u L=1u
Mu2_7_74 n_w7_74 n_error7 n_utail7_74 0 nch W=20u L=1u
Mu3_7_74 n_up7_74 n_up7_74 vdd vdd pch W=60u L=1u
Mu4_7_74 n_w7_74 n_up7_74 vdd vdd pch W=60u L=1u
Rinit7_75hi reset n_init7_75 428.091619643
Rinit7_75lo n_init7_75 0 571.908380357
Cw7_75 n_w7_75 0 5e-06
Mreset7_75 n_init7_75 reset n_w7_75 0 syn W=1000u L=1u
Mpos7_75 n_hv75 n_w7_75 n_op7 0 syn W=4u L=1u
Mneg7_75 n_hv75 vweight n_on7 0 syn W=4u L=1u
Menable7_75 n_enable7_75 learn 0 0 nch W=1000u L=1u
Mutail7_75 n_utail7_75 n_hv75 n_enable7_75 0 nch W=20u L=1u
Mu1_7_75 n_up7_75 n_az7 n_utail7_75 0 nch W=20u L=1u
Mu2_7_75 n_w7_75 n_error7 n_utail7_75 0 nch W=20u L=1u
Mu3_7_75 n_up7_75 n_up7_75 vdd vdd pch W=60u L=1u
Mu4_7_75 n_w7_75 n_up7_75 vdd vdd pch W=60u L=1u
Rinit7_76hi reset n_init7_76 406.895846563
Rinit7_76lo n_init7_76 0 593.104153437
Cw7_76 n_w7_76 0 5e-06
Mreset7_76 n_init7_76 reset n_w7_76 0 syn W=1000u L=1u
Mpos7_76 n_hv76 n_w7_76 n_op7 0 syn W=4u L=1u
Mneg7_76 n_hv76 vweight n_on7 0 syn W=4u L=1u
Menable7_76 n_enable7_76 learn 0 0 nch W=1000u L=1u
Mutail7_76 n_utail7_76 n_hv76 n_enable7_76 0 nch W=20u L=1u
Mu1_7_76 n_up7_76 n_az7 n_utail7_76 0 nch W=20u L=1u
Mu2_7_76 n_w7_76 n_error7 n_utail7_76 0 nch W=20u L=1u
Mu3_7_76 n_up7_76 n_up7_76 vdd vdd pch W=60u L=1u
Mu4_7_76 n_w7_76 n_up7_76 vdd vdd pch W=60u L=1u
Rinit7_77hi reset n_init7_77 417.616696668
Rinit7_77lo n_init7_77 0 582.383303332
Cw7_77 n_w7_77 0 5e-06
Mreset7_77 n_init7_77 reset n_w7_77 0 syn W=1000u L=1u
Mpos7_77 n_hv77 n_w7_77 n_op7 0 syn W=4u L=1u
Mneg7_77 n_hv77 vweight n_on7 0 syn W=4u L=1u
Menable7_77 n_enable7_77 learn 0 0 nch W=1000u L=1u
Mutail7_77 n_utail7_77 n_hv77 n_enable7_77 0 nch W=20u L=1u
Mu1_7_77 n_up7_77 n_az7 n_utail7_77 0 nch W=20u L=1u
Mu2_7_77 n_w7_77 n_error7 n_utail7_77 0 nch W=20u L=1u
Mu3_7_77 n_up7_77 n_up7_77 vdd vdd pch W=60u L=1u
Mu4_7_77 n_w7_77 n_up7_77 vdd vdd pch W=60u L=1u
Rinit7_78hi reset n_init7_78 384.366172966
Rinit7_78lo n_init7_78 0 615.633827034
Cw7_78 n_w7_78 0 5e-06
Mreset7_78 n_init7_78 reset n_w7_78 0 syn W=1000u L=1u
Mpos7_78 n_hv78 n_w7_78 n_op7 0 syn W=4u L=1u
Mneg7_78 n_hv78 vweight n_on7 0 syn W=4u L=1u
Menable7_78 n_enable7_78 learn 0 0 nch W=1000u L=1u
Mutail7_78 n_utail7_78 n_hv78 n_enable7_78 0 nch W=20u L=1u
Mu1_7_78 n_up7_78 n_az7 n_utail7_78 0 nch W=20u L=1u
Mu2_7_78 n_w7_78 n_error7 n_utail7_78 0 nch W=20u L=1u
Mu3_7_78 n_up7_78 n_up7_78 vdd vdd pch W=60u L=1u
Mu4_7_78 n_w7_78 n_up7_78 vdd vdd pch W=60u L=1u
Rinit7_79hi reset n_init7_79 418.63541991
Rinit7_79lo n_init7_79 0 581.36458009
Cw7_79 n_w7_79 0 5e-06
Mreset7_79 n_init7_79 reset n_w7_79 0 syn W=1000u L=1u
Mpos7_79 n_hv79 n_w7_79 n_op7 0 syn W=4u L=1u
Mneg7_79 n_hv79 vweight n_on7 0 syn W=4u L=1u
Menable7_79 n_enable7_79 learn 0 0 nch W=1000u L=1u
Mutail7_79 n_utail7_79 n_hv79 n_enable7_79 0 nch W=20u L=1u
Mu1_7_79 n_up7_79 n_az7 n_utail7_79 0 nch W=20u L=1u
Mu2_7_79 n_w7_79 n_error7 n_utail7_79 0 nch W=20u L=1u
Mu3_7_79 n_up7_79 n_up7_79 vdd vdd pch W=60u L=1u
Mu4_7_79 n_w7_79 n_up7_79 vdd vdd pch W=60u L=1u
Rinit7_80hi reset n_init7_80 422.847975195
Rinit7_80lo n_init7_80 0 577.152024805
Cw7_80 n_w7_80 0 5e-06
Mreset7_80 n_init7_80 reset n_w7_80 0 syn W=1000u L=1u
Mpos7_80 n_hv80 n_w7_80 n_op7 0 syn W=4u L=1u
Mneg7_80 n_hv80 vweight n_on7 0 syn W=4u L=1u
Menable7_80 n_enable7_80 learn 0 0 nch W=1000u L=1u
Mutail7_80 n_utail7_80 n_hv80 n_enable7_80 0 nch W=20u L=1u
Mu1_7_80 n_up7_80 n_az7 n_utail7_80 0 nch W=20u L=1u
Mu2_7_80 n_w7_80 n_error7 n_utail7_80 0 nch W=20u L=1u
Mu3_7_80 n_up7_80 n_up7_80 vdd vdd pch W=60u L=1u
Mu4_7_80 n_w7_80 n_up7_80 vdd vdd pch W=60u L=1u
Rinit7_81hi reset n_init7_81 410.585248113
Rinit7_81lo n_init7_81 0 589.414751887
Cw7_81 n_w7_81 0 5e-06
Mreset7_81 n_init7_81 reset n_w7_81 0 syn W=1000u L=1u
Mpos7_81 n_hv81 n_w7_81 n_op7 0 syn W=4u L=1u
Mneg7_81 n_hv81 vweight n_on7 0 syn W=4u L=1u
Menable7_81 n_enable7_81 learn 0 0 nch W=1000u L=1u
Mutail7_81 n_utail7_81 n_hv81 n_enable7_81 0 nch W=20u L=1u
Mu1_7_81 n_up7_81 n_az7 n_utail7_81 0 nch W=20u L=1u
Mu2_7_81 n_w7_81 n_error7 n_utail7_81 0 nch W=20u L=1u
Mu3_7_81 n_up7_81 n_up7_81 vdd vdd pch W=60u L=1u
Mu4_7_81 n_w7_81 n_up7_81 vdd vdd pch W=60u L=1u
Rinit7_82hi reset n_init7_82 402.3560755
Rinit7_82lo n_init7_82 0 597.6439245
Cw7_82 n_w7_82 0 5e-06
Mreset7_82 n_init7_82 reset n_w7_82 0 syn W=1000u L=1u
Mpos7_82 n_hv82 n_w7_82 n_op7 0 syn W=4u L=1u
Mneg7_82 n_hv82 vweight n_on7 0 syn W=4u L=1u
Menable7_82 n_enable7_82 learn 0 0 nch W=1000u L=1u
Mutail7_82 n_utail7_82 n_hv82 n_enable7_82 0 nch W=20u L=1u
Mu1_7_82 n_up7_82 n_az7 n_utail7_82 0 nch W=20u L=1u
Mu2_7_82 n_w7_82 n_error7 n_utail7_82 0 nch W=20u L=1u
Mu3_7_82 n_up7_82 n_up7_82 vdd vdd pch W=60u L=1u
Mu4_7_82 n_w7_82 n_up7_82 vdd vdd pch W=60u L=1u
Rinit7_83hi reset n_init7_83 412.928402319
Rinit7_83lo n_init7_83 0 587.071597681
Cw7_83 n_w7_83 0 5e-06
Mreset7_83 n_init7_83 reset n_w7_83 0 syn W=1000u L=1u
Mpos7_83 n_hv83 n_w7_83 n_op7 0 syn W=4u L=1u
Mneg7_83 n_hv83 vweight n_on7 0 syn W=4u L=1u
Menable7_83 n_enable7_83 learn 0 0 nch W=1000u L=1u
Mutail7_83 n_utail7_83 n_hv83 n_enable7_83 0 nch W=20u L=1u
Mu1_7_83 n_up7_83 n_az7 n_utail7_83 0 nch W=20u L=1u
Mu2_7_83 n_w7_83 n_error7 n_utail7_83 0 nch W=20u L=1u
Mu3_7_83 n_up7_83 n_up7_83 vdd vdd pch W=60u L=1u
Mu4_7_83 n_w7_83 n_up7_83 vdd vdd pch W=60u L=1u
Rinit7_84hi reset n_init7_84 391.541427518
Rinit7_84lo n_init7_84 0 608.458572482
Cw7_84 n_w7_84 0 5e-06
Mreset7_84 n_init7_84 reset n_w7_84 0 syn W=1000u L=1u
Mpos7_84 n_hv84 n_w7_84 n_op7 0 syn W=4u L=1u
Mneg7_84 n_hv84 vweight n_on7 0 syn W=4u L=1u
Menable7_84 n_enable7_84 learn 0 0 nch W=1000u L=1u
Mutail7_84 n_utail7_84 n_hv84 n_enable7_84 0 nch W=20u L=1u
Mu1_7_84 n_up7_84 n_az7 n_utail7_84 0 nch W=20u L=1u
Mu2_7_84 n_w7_84 n_error7 n_utail7_84 0 nch W=20u L=1u
Mu3_7_84 n_up7_84 n_up7_84 vdd vdd pch W=60u L=1u
Mu4_7_84 n_w7_84 n_up7_84 vdd vdd pch W=60u L=1u
Rinit7_85hi reset n_init7_85 425.503706491
Rinit7_85lo n_init7_85 0 574.496293509
Cw7_85 n_w7_85 0 5e-06
Mreset7_85 n_init7_85 reset n_w7_85 0 syn W=1000u L=1u
Mpos7_85 n_hv85 n_w7_85 n_op7 0 syn W=4u L=1u
Mneg7_85 n_hv85 vweight n_on7 0 syn W=4u L=1u
Menable7_85 n_enable7_85 learn 0 0 nch W=1000u L=1u
Mutail7_85 n_utail7_85 n_hv85 n_enable7_85 0 nch W=20u L=1u
Mu1_7_85 n_up7_85 n_az7 n_utail7_85 0 nch W=20u L=1u
Mu2_7_85 n_w7_85 n_error7 n_utail7_85 0 nch W=20u L=1u
Mu3_7_85 n_up7_85 n_up7_85 vdd vdd pch W=60u L=1u
Mu4_7_85 n_w7_85 n_up7_85 vdd vdd pch W=60u L=1u
Rinit7_86hi reset n_init7_86 369.607176435
Rinit7_86lo n_init7_86 0 630.392823565
Cw7_86 n_w7_86 0 5e-06
Mreset7_86 n_init7_86 reset n_w7_86 0 syn W=1000u L=1u
Mpos7_86 n_hv86 n_w7_86 n_op7 0 syn W=4u L=1u
Mneg7_86 n_hv86 vweight n_on7 0 syn W=4u L=1u
Menable7_86 n_enable7_86 learn 0 0 nch W=1000u L=1u
Mutail7_86 n_utail7_86 n_hv86 n_enable7_86 0 nch W=20u L=1u
Mu1_7_86 n_up7_86 n_az7 n_utail7_86 0 nch W=20u L=1u
Mu2_7_86 n_w7_86 n_error7 n_utail7_86 0 nch W=20u L=1u
Mu3_7_86 n_up7_86 n_up7_86 vdd vdd pch W=60u L=1u
Mu4_7_86 n_w7_86 n_up7_86 vdd vdd pch W=60u L=1u
Rinit7_87hi reset n_init7_87 384.466290801
Rinit7_87lo n_init7_87 0 615.533709199
Cw7_87 n_w7_87 0 5e-06
Mreset7_87 n_init7_87 reset n_w7_87 0 syn W=1000u L=1u
Mpos7_87 n_hv87 n_w7_87 n_op7 0 syn W=4u L=1u
Mneg7_87 n_hv87 vweight n_on7 0 syn W=4u L=1u
Menable7_87 n_enable7_87 learn 0 0 nch W=1000u L=1u
Mutail7_87 n_utail7_87 n_hv87 n_enable7_87 0 nch W=20u L=1u
Mu1_7_87 n_up7_87 n_az7 n_utail7_87 0 nch W=20u L=1u
Mu2_7_87 n_w7_87 n_error7 n_utail7_87 0 nch W=20u L=1u
Mu3_7_87 n_up7_87 n_up7_87 vdd vdd pch W=60u L=1u
Mu4_7_87 n_w7_87 n_up7_87 vdd vdd pch W=60u L=1u
Rinit7_88hi reset n_init7_88 397.218942553
Rinit7_88lo n_init7_88 0 602.781057447
Cw7_88 n_w7_88 0 5e-06
Mreset7_88 n_init7_88 reset n_w7_88 0 syn W=1000u L=1u
Mpos7_88 n_hv88 n_w7_88 n_op7 0 syn W=4u L=1u
Mneg7_88 n_hv88 vweight n_on7 0 syn W=4u L=1u
Menable7_88 n_enable7_88 learn 0 0 nch W=1000u L=1u
Mutail7_88 n_utail7_88 n_hv88 n_enable7_88 0 nch W=20u L=1u
Mu1_7_88 n_up7_88 n_az7 n_utail7_88 0 nch W=20u L=1u
Mu2_7_88 n_w7_88 n_error7 n_utail7_88 0 nch W=20u L=1u
Mu3_7_88 n_up7_88 n_up7_88 vdd vdd pch W=60u L=1u
Mu4_7_88 n_w7_88 n_up7_88 vdd vdd pch W=60u L=1u
Rinit7_89hi reset n_init7_89 435.347017942
Rinit7_89lo n_init7_89 0 564.652982058
Cw7_89 n_w7_89 0 5e-06
Mreset7_89 n_init7_89 reset n_w7_89 0 syn W=1000u L=1u
Mpos7_89 n_hv89 n_w7_89 n_op7 0 syn W=4u L=1u
Mneg7_89 n_hv89 vweight n_on7 0 syn W=4u L=1u
Menable7_89 n_enable7_89 learn 0 0 nch W=1000u L=1u
Mutail7_89 n_utail7_89 n_hv89 n_enable7_89 0 nch W=20u L=1u
Mu1_7_89 n_up7_89 n_az7 n_utail7_89 0 nch W=20u L=1u
Mu2_7_89 n_w7_89 n_error7 n_utail7_89 0 nch W=20u L=1u
Mu3_7_89 n_up7_89 n_up7_89 vdd vdd pch W=60u L=1u
Mu4_7_89 n_w7_89 n_up7_89 vdd vdd pch W=60u L=1u
Rinit7_90hi reset n_init7_90 413.919468803
Rinit7_90lo n_init7_90 0 586.080531197
Cw7_90 n_w7_90 0 5e-06
Mreset7_90 n_init7_90 reset n_w7_90 0 syn W=1000u L=1u
Mpos7_90 n_hv90 n_w7_90 n_op7 0 syn W=4u L=1u
Mneg7_90 n_hv90 vweight n_on7 0 syn W=4u L=1u
Menable7_90 n_enable7_90 learn 0 0 nch W=1000u L=1u
Mutail7_90 n_utail7_90 n_hv90 n_enable7_90 0 nch W=20u L=1u
Mu1_7_90 n_up7_90 n_az7 n_utail7_90 0 nch W=20u L=1u
Mu2_7_90 n_w7_90 n_error7 n_utail7_90 0 nch W=20u L=1u
Mu3_7_90 n_up7_90 n_up7_90 vdd vdd pch W=60u L=1u
Mu4_7_90 n_w7_90 n_up7_90 vdd vdd pch W=60u L=1u
Rinit7_91hi reset n_init7_91 384.791410485
Rinit7_91lo n_init7_91 0 615.208589515
Cw7_91 n_w7_91 0 5e-06
Mreset7_91 n_init7_91 reset n_w7_91 0 syn W=1000u L=1u
Mpos7_91 n_hv91 n_w7_91 n_op7 0 syn W=4u L=1u
Mneg7_91 n_hv91 vweight n_on7 0 syn W=4u L=1u
Menable7_91 n_enable7_91 learn 0 0 nch W=1000u L=1u
Mutail7_91 n_utail7_91 n_hv91 n_enable7_91 0 nch W=20u L=1u
Mu1_7_91 n_up7_91 n_az7 n_utail7_91 0 nch W=20u L=1u
Mu2_7_91 n_w7_91 n_error7 n_utail7_91 0 nch W=20u L=1u
Mu3_7_91 n_up7_91 n_up7_91 vdd vdd pch W=60u L=1u
Mu4_7_91 n_w7_91 n_up7_91 vdd vdd pch W=60u L=1u
Rinit7_92hi reset n_init7_92 388.394857787
Rinit7_92lo n_init7_92 0 611.605142213
Cw7_92 n_w7_92 0 5e-06
Mreset7_92 n_init7_92 reset n_w7_92 0 syn W=1000u L=1u
Mpos7_92 n_hv92 n_w7_92 n_op7 0 syn W=4u L=1u
Mneg7_92 n_hv92 vweight n_on7 0 syn W=4u L=1u
Menable7_92 n_enable7_92 learn 0 0 nch W=1000u L=1u
Mutail7_92 n_utail7_92 n_hv92 n_enable7_92 0 nch W=20u L=1u
Mu1_7_92 n_up7_92 n_az7 n_utail7_92 0 nch W=20u L=1u
Mu2_7_92 n_w7_92 n_error7 n_utail7_92 0 nch W=20u L=1u
Mu3_7_92 n_up7_92 n_up7_92 vdd vdd pch W=60u L=1u
Mu4_7_92 n_w7_92 n_up7_92 vdd vdd pch W=60u L=1u
Rinit7_93hi reset n_init7_93 375.043665773
Rinit7_93lo n_init7_93 0 624.956334227
Cw7_93 n_w7_93 0 5e-06
Mreset7_93 n_init7_93 reset n_w7_93 0 syn W=1000u L=1u
Mpos7_93 n_hv93 n_w7_93 n_op7 0 syn W=4u L=1u
Mneg7_93 n_hv93 vweight n_on7 0 syn W=4u L=1u
Menable7_93 n_enable7_93 learn 0 0 nch W=1000u L=1u
Mutail7_93 n_utail7_93 n_hv93 n_enable7_93 0 nch W=20u L=1u
Mu1_7_93 n_up7_93 n_az7 n_utail7_93 0 nch W=20u L=1u
Mu2_7_93 n_w7_93 n_error7 n_utail7_93 0 nch W=20u L=1u
Mu3_7_93 n_up7_93 n_up7_93 vdd vdd pch W=60u L=1u
Mu4_7_93 n_w7_93 n_up7_93 vdd vdd pch W=60u L=1u
Rinit7_94hi reset n_init7_94 368.679316513
Rinit7_94lo n_init7_94 0 631.320683487
Cw7_94 n_w7_94 0 5e-06
Mreset7_94 n_init7_94 reset n_w7_94 0 syn W=1000u L=1u
Mpos7_94 n_hv94 n_w7_94 n_op7 0 syn W=4u L=1u
Mneg7_94 n_hv94 vweight n_on7 0 syn W=4u L=1u
Menable7_94 n_enable7_94 learn 0 0 nch W=1000u L=1u
Mutail7_94 n_utail7_94 n_hv94 n_enable7_94 0 nch W=20u L=1u
Mu1_7_94 n_up7_94 n_az7 n_utail7_94 0 nch W=20u L=1u
Mu2_7_94 n_w7_94 n_error7 n_utail7_94 0 nch W=20u L=1u
Mu3_7_94 n_up7_94 n_up7_94 vdd vdd pch W=60u L=1u
Mu4_7_94 n_w7_94 n_up7_94 vdd vdd pch W=60u L=1u
Rinit7_95hi reset n_init7_95 414.770690428
Rinit7_95lo n_init7_95 0 585.229309572
Cw7_95 n_w7_95 0 5e-06
Mreset7_95 n_init7_95 reset n_w7_95 0 syn W=1000u L=1u
Mpos7_95 n_hv95 n_w7_95 n_op7 0 syn W=4u L=1u
Mneg7_95 n_hv95 vweight n_on7 0 syn W=4u L=1u
Menable7_95 n_enable7_95 learn 0 0 nch W=1000u L=1u
Mutail7_95 n_utail7_95 n_hv95 n_enable7_95 0 nch W=20u L=1u
Mu1_7_95 n_up7_95 n_az7 n_utail7_95 0 nch W=20u L=1u
Mu2_7_95 n_w7_95 n_error7 n_utail7_95 0 nch W=20u L=1u
Mu3_7_95 n_up7_95 n_up7_95 vdd vdd pch W=60u L=1u
Mu4_7_95 n_w7_95 n_up7_95 vdd vdd pch W=60u L=1u
Rinit7_96hi reset n_init7_96 400.501545381
Rinit7_96lo n_init7_96 0 599.498454619
Cw7_96 n_w7_96 0 5e-06
Mreset7_96 n_init7_96 reset n_w7_96 0 syn W=1000u L=1u
Mpos7_96 vbias n_w7_96 n_op7 0 syn W=4u L=1u
Mneg7_96 vbias vweight n_on7 0 syn W=4u L=1u
Menable7_96 n_enable7_96 learn 0 0 nch W=1000u L=1u
Mutail7_96 n_utail7_96 vbias n_enable7_96 0 nch W=20u L=1u
Mu1_7_96 n_up7_96 n_az7 n_utail7_96 0 nch W=20u L=1u
Mu2_7_96 n_w7_96 n_error7 n_utail7_96 0 nch W=20u L=1u
Mu3_7_96 n_up7_96 n_up7_96 vdd vdd pch W=60u L=1u
Mu4_7_96 n_w7_96 n_up7_96 vdd vdd pch W=60u L=1u
Ccommon n_common 0 5e-14
