gsyn gain test load=activeload
.model NNR NMOS (LEVEL=1 VTO=0.2 KP=120u LAMBDA=0.02 GAMMA=0 PHI=0.7)
.model PNR PMOS (LEVEL=1 VTO=-0.2 KP=40u LAMBDA=0.02 GAMMA=0 PHI=0.7)
.subckt gsyn inp inn wp wn outp outn vdd vbn
Mtail nt vbn 0 0 NNR W=400u L=100u
M5 na wp nt 0 NNR W=200u L=100u
M6 nb wn nt 0 NNR W=200u L=100u
M1 outp inp na 0 NNR W=200u L=100u
M2 outn inn na 0 NNR W=200u L=100u
M3 outn inp nb 0 NNR W=200u L=100u
M4 outp inn nb 0 NNR W=200u L=100u
.ends
.subckt cmld p n vdd
Rcs1 p cmx 300k
Rcs2 n cmx 300k
MLp p cmx vdd vdd PNR W=1000u L=100u
MLn n cmx vdd vdd PNR W=1000u L=100u
.ends
Vdd vdd 0 1.0
Vbsyn vbsyn 0 0.45
Vinp inp 0 0.5
Vinn inn 0 0.5
Vwp wp 0 0.62
Vwn wn 0 0.38
Vcm vcm 0 0.5
Xs inp inn wp wn outp outn vdd vbsyn gsyn
Mlp outp pb vdd vdd PNR W=300u L=200u
Mln outn pb vdd vdd PNR W=300u L=200u
Vpb pb 0 0.55
.control
dc Vinp 0.40 0.60 0.005
let din = v(inp)-0.5
let dout = v(outp)-v(outn)
wrdata gg_gg.dat dout din
.endc
.end
