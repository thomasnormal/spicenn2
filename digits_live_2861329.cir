digits differential current-mode EP (live)
.model NNR NMOS (LEVEL=1 VTO=0.2  KP=120u LAMBDA=0.02 GAMMA=0 PHI=0.7)
.model PNR PMOS (LEVEL=1 VTO=-0.2 KP=40u  LAMBDA=0.02 GAMMA=0 PHI=0.7)
.subckt dsyn inp inn outp outn wp wn vdd
M1 outp inp tp 0 NNR W=200u L=100u
M2 outn inn tp 0 NNR W=200u L=100u
Mtp tp wp 0 0 NNR W=200u L=100u
M3 outn inp tn 0 NNR W=200u L=100u
M4 outp inn tn 0 NNR W=200u L=100u
Mtn tn wn 0 0 NNR W=200u L=100u
.ends
.subckt dneuron up un ap an vdd vbn
M1 an up tn 0 NNR W=200u L=100u
M2 ap un tn 0 NNR W=200u L=100u
Mt tn vbn 0 0 NNR W=200u L=100u
RLa vdd ap 800k
RLb vdd an 800k
.ends

Vdd vdd 0 1.0
Vbn vbn 0 0.30
Vbp_hi bp_hi 0 0.8
Vbp_lo bp_lo 0 0.2
Vaxp0 a_xp0 0 0.5
Vaxn0 a_xn0 0 0.5
Vaxp1 a_xp1 0 0.5
Vaxn1 a_xn1 0 0.5
Vtp0 vtp0 0 0.5
Vtn0 vtn0 0 0.5
Vtp1 vtp1 0 0.5
Vtn1 vtn1 0 0.5
Mlp_h0 up_h0 up_h0 vdd vdd PNR W=900u L=100u
Mln_h0 un_h0 un_h0 vdd vdd PNR W=900u L=100u
Xn_h0 up_h0 un_h0 ap_h0 an_h0 vdd vbn dneuron
Vwp_ih_0_0 wp_ih_0_0 0 0.4338
Vwn_ih_0_0 wn_ih_0_0 0 0.4062
X_ih_0_0 a_xp0 a_xn0 up_h0 un_h0 wp_ih_0_0 wn_ih_0_0 vdd dsyn
Vwp_ih_1_0 wp_ih_1_0 0 0.4529
Vwn_ih_1_0 wn_ih_1_0 0 0.3871
X_ih_1_0 a_xp1 a_xn1 up_h0 un_h0 wp_ih_1_0 wn_ih_1_0 vdd dsyn
Vwp_bh_0 wp_bh_0 0 0.4562
Vwn_bh_0 wn_bh_0 0 0.3838
X_bh_0 bp_hi bp_lo up_h0 un_h0 wp_bh_0 wn_bh_0 vdd dsyn
Mlp_h1 up_h1 up_h1 vdd vdd PNR W=900u L=100u
Mln_h1 un_h1 un_h1 vdd vdd PNR W=900u L=100u
Xn_h1 up_h1 un_h1 ap_h1 an_h1 vdd vbn dneuron
Vwp_ih_0_1 wp_ih_0_1 0 0.4379
Vwn_ih_0_1 wn_ih_0_1 0 0.4021
X_ih_0_1 a_xp0 a_xn0 up_h1 un_h1 wp_ih_0_1 wn_ih_0_1 vdd dsyn
Vwp_ih_1_1 wp_ih_1_1 0 0.3985
Vwn_ih_1_1 wn_ih_1_1 0 0.4415
X_ih_1_1 a_xp1 a_xn1 up_h1 un_h1 wp_ih_1_1 wn_ih_1_1 vdd dsyn
Vwp_bh_1 wp_bh_1 0 0.4318
Vwn_bh_1 wn_bh_1 0 0.4082
X_bh_1 bp_hi bp_lo up_h1 un_h1 wp_bh_1 wn_bh_1 vdd dsyn
Mlp_h2 up_h2 up_h2 vdd vdd PNR W=900u L=100u
Mln_h2 un_h2 un_h2 vdd vdd PNR W=900u L=100u
Xn_h2 up_h2 un_h2 ap_h2 an_h2 vdd vbn dneuron
Vwp_ih_0_2 wp_ih_0_2 0 0.4211
Vwn_ih_0_2 wn_ih_0_2 0 0.4189
X_ih_0_2 a_xp0 a_xn0 up_h2 un_h2 wp_ih_0_2 wn_ih_0_2 vdd dsyn
Vwp_ih_1_2 wp_ih_1_2 0 0.4419
Vwn_ih_1_2 wn_ih_1_2 0 0.3981
X_ih_1_2 a_xp1 a_xn1 up_h2 un_h2 wp_ih_1_2 wn_ih_1_2 vdd dsyn
Vwp_bh_2 wp_bh_2 0 0.4007
Vwn_bh_2 wn_bh_2 0 0.4393
X_bh_2 bp_hi bp_lo up_h2 un_h2 wp_bh_2 wn_bh_2 vdd dsyn
Mlp_h3 up_h3 up_h3 vdd vdd PNR W=900u L=100u
Mln_h3 un_h3 un_h3 vdd vdd PNR W=900u L=100u
Xn_h3 up_h3 un_h3 ap_h3 an_h3 vdd vbn dneuron
Vwp_ih_0_3 wp_ih_0_3 0 0.4440
Vwn_ih_0_3 wn_ih_0_3 0 0.3960
X_ih_0_3 a_xp0 a_xn0 up_h3 un_h3 wp_ih_0_3 wn_ih_0_3 vdd dsyn
Vwp_ih_1_3 wp_ih_1_3 0 0.4216
Vwn_ih_1_3 wn_ih_1_3 0 0.4184
X_ih_1_3 a_xp1 a_xn1 up_h3 un_h3 wp_ih_1_3 wn_ih_1_3 vdd dsyn
Vwp_bh_3 wp_bh_3 0 0.4097
Vwn_bh_3 wn_bh_3 0 0.4303
X_bh_3 bp_hi bp_lo up_h3 un_h3 wp_bh_3 wn_bh_3 vdd dsyn
Mlp_h4 up_h4 up_h4 vdd vdd PNR W=900u L=100u
Mln_h4 un_h4 un_h4 vdd vdd PNR W=900u L=100u
Xn_h4 up_h4 un_h4 ap_h4 an_h4 vdd vbn dneuron
Vwp_ih_0_4 wp_ih_0_4 0 0.4203
Vwn_ih_0_4 wn_ih_0_4 0 0.4197
X_ih_0_4 a_xp0 a_xn0 up_h4 un_h4 wp_ih_0_4 wn_ih_0_4 vdd dsyn
Vwp_ih_1_4 wp_ih_1_4 0 0.4090
Vwn_ih_1_4 wn_ih_1_4 0 0.4310
X_ih_1_4 a_xp1 a_xn1 up_h4 un_h4 wp_ih_1_4 wn_ih_1_4 vdd dsyn
Vwp_bh_4 wp_bh_4 0 0.3116
Vwn_bh_4 wn_bh_4 0 0.5284
X_bh_4 bp_hi bp_lo up_h4 un_h4 wp_bh_4 wn_bh_4 vdd dsyn
Mlp_h5 up_h5 up_h5 vdd vdd PNR W=900u L=100u
Mln_h5 un_h5 un_h5 vdd vdd PNR W=900u L=100u
Xn_h5 up_h5 un_h5 ap_h5 an_h5 vdd vbn dneuron
Vwp_ih_0_5 wp_ih_0_5 0 0.3444
Vwn_ih_0_5 wn_ih_0_5 0 0.4956
X_ih_0_5 a_xp0 a_xn0 up_h5 un_h5 wp_ih_0_5 wn_ih_0_5 vdd dsyn
Vwp_ih_1_5 wp_ih_1_5 0 0.4130
Vwn_ih_1_5 wn_ih_1_5 0 0.4270
X_ih_1_5 a_xp1 a_xn1 up_h5 un_h5 wp_ih_1_5 wn_ih_1_5 vdd dsyn
Vwp_bh_5 wp_bh_5 0 0.4287
Vwn_bh_5 wn_bh_5 0 0.4113
X_bh_5 bp_hi bp_lo up_h5 un_h5 wp_bh_5 wn_bh_5 vdd dsyn
Mlp_h6 up_h6 up_h6 vdd vdd PNR W=900u L=100u
Mln_h6 un_h6 un_h6 vdd vdd PNR W=900u L=100u
Xn_h6 up_h6 un_h6 ap_h6 an_h6 vdd vbn dneuron
Vwp_ih_0_6 wp_ih_0_6 0 0.5047
Vwn_ih_0_6 wn_ih_0_6 0 0.3353
X_ih_0_6 a_xp0 a_xn0 up_h6 un_h6 wp_ih_0_6 wn_ih_0_6 vdd dsyn
Vwp_ih_1_6 wp_ih_1_6 0 0.3755
Vwn_ih_1_6 wn_ih_1_6 0 0.4645
X_ih_1_6 a_xp1 a_xn1 up_h6 un_h6 wp_ih_1_6 wn_ih_1_6 vdd dsyn
Vwp_bh_6 wp_bh_6 0 0.4459
Vwn_bh_6 wn_bh_6 0 0.3941
X_bh_6 bp_hi bp_lo up_h6 un_h6 wp_bh_6 wn_bh_6 vdd dsyn
Mlp_h7 up_h7 up_h7 vdd vdd PNR W=900u L=100u
Mln_h7 un_h7 un_h7 vdd vdd PNR W=900u L=100u
Xn_h7 up_h7 un_h7 ap_h7 an_h7 vdd vbn dneuron
Vwp_ih_0_7 wp_ih_0_7 0 0.4465
Vwn_ih_0_7 wn_ih_0_7 0 0.3935
X_ih_0_7 a_xp0 a_xn0 up_h7 un_h7 wp_ih_0_7 wn_ih_0_7 vdd dsyn
Vwp_ih_1_7 wp_ih_1_7 0 0.3994
Vwn_ih_1_7 wn_ih_1_7 0 0.4406
X_ih_1_7 a_xp1 a_xn1 up_h7 un_h7 wp_ih_1_7 wn_ih_1_7 vdd dsyn
Vwp_bh_7 wp_bh_7 0 0.4244
Vwn_bh_7 wn_bh_7 0 0.4156
X_bh_7 bp_hi bp_lo up_h7 un_h7 wp_bh_7 wn_bh_7 vdd dsyn
Mlp_h8 up_h8 up_h8 vdd vdd PNR W=900u L=100u
Mln_h8 un_h8 un_h8 vdd vdd PNR W=900u L=100u
Xn_h8 up_h8 un_h8 ap_h8 an_h8 vdd vbn dneuron
Vwp_ih_0_8 wp_ih_0_8 0 0.3709
Vwn_ih_0_8 wn_ih_0_8 0 0.4691
X_ih_0_8 a_xp0 a_xn0 up_h8 un_h8 wp_ih_0_8 wn_ih_0_8 vdd dsyn
Vwp_ih_1_8 wp_ih_1_8 0 0.3927
Vwn_ih_1_8 wn_ih_1_8 0 0.4473
X_ih_1_8 a_xp1 a_xn1 up_h8 un_h8 wp_ih_1_8 wn_ih_1_8 vdd dsyn
Vwp_bh_8 wp_bh_8 0 0.4161
Vwn_bh_8 wn_bh_8 0 0.4239
X_bh_8 bp_hi bp_lo up_h8 un_h8 wp_bh_8 wn_bh_8 vdd dsyn
Mlp_h9 up_h9 up_h9 vdd vdd PNR W=900u L=100u
Mln_h9 un_h9 un_h9 vdd vdd PNR W=900u L=100u
Xn_h9 up_h9 un_h9 ap_h9 an_h9 vdd vbn dneuron
Vwp_ih_0_9 wp_ih_0_9 0 0.4238
Vwn_ih_0_9 wn_ih_0_9 0 0.4162
X_ih_0_9 a_xp0 a_xn0 up_h9 un_h9 wp_ih_0_9 wn_ih_0_9 vdd dsyn
Vwp_ih_1_9 wp_ih_1_9 0 0.4214
Vwn_ih_1_9 wn_ih_1_9 0 0.4186
X_ih_1_9 a_xp1 a_xn1 up_h9 un_h9 wp_ih_1_9 wn_ih_1_9 vdd dsyn
Vwp_bh_9 wp_bh_9 0 0.4556
Vwn_bh_9 wn_bh_9 0 0.3844
X_bh_9 bp_hi bp_lo up_h9 un_h9 wp_bh_9 wn_bh_9 vdd dsyn
Mlp_h10 up_h10 up_h10 vdd vdd PNR W=900u L=100u
Mln_h10 un_h10 un_h10 vdd vdd PNR W=900u L=100u
Xn_h10 up_h10 un_h10 ap_h10 an_h10 vdd vbn dneuron
Vwp_ih_0_10 wp_ih_0_10 0 0.4328
Vwn_ih_0_10 wn_ih_0_10 0 0.4072
X_ih_0_10 a_xp0 a_xn0 up_h10 un_h10 wp_ih_0_10 wn_ih_0_10 vdd dsyn
Vwp_ih_1_10 wp_ih_1_10 0 0.3873
Vwn_ih_1_10 wn_ih_1_10 0 0.4527
X_ih_1_10 a_xp1 a_xn1 up_h10 un_h10 wp_ih_1_10 wn_ih_1_10 vdd dsyn
Vwp_bh_10 wp_bh_10 0 0.4552
Vwn_bh_10 wn_bh_10 0 0.3848
X_bh_10 bp_hi bp_lo up_h10 un_h10 wp_bh_10 wn_bh_10 vdd dsyn
Mlp_h11 up_h11 up_h11 vdd vdd PNR W=900u L=100u
Mln_h11 un_h11 un_h11 vdd vdd PNR W=900u L=100u
Xn_h11 up_h11 un_h11 ap_h11 an_h11 vdd vbn dneuron
Vwp_ih_0_11 wp_ih_0_11 0 0.3771
Vwn_ih_0_11 wn_ih_0_11 0 0.4629
X_ih_0_11 a_xp0 a_xn0 up_h11 un_h11 wp_ih_0_11 wn_ih_0_11 vdd dsyn
Vwp_ih_1_11 wp_ih_1_11 0 0.4566
Vwn_ih_1_11 wn_ih_1_11 0 0.3834
X_ih_1_11 a_xp1 a_xn1 up_h11 un_h11 wp_ih_1_11 wn_ih_1_11 vdd dsyn
Vwp_bh_11 wp_bh_11 0 0.4074
Vwn_bh_11 wn_bh_11 0 0.4326
X_bh_11 bp_hi bp_lo up_h11 un_h11 wp_bh_11 wn_bh_11 vdd dsyn
Mlp_h12 up_h12 up_h12 vdd vdd PNR W=900u L=100u
Mln_h12 un_h12 un_h12 vdd vdd PNR W=900u L=100u
Xn_h12 up_h12 un_h12 ap_h12 an_h12 vdd vbn dneuron
Vwp_ih_0_12 wp_ih_0_12 0 0.4222
Vwn_ih_0_12 wn_ih_0_12 0 0.4178
X_ih_0_12 a_xp0 a_xn0 up_h12 un_h12 wp_ih_0_12 wn_ih_0_12 vdd dsyn
Vwp_ih_1_12 wp_ih_1_12 0 0.4309
Vwn_ih_1_12 wn_ih_1_12 0 0.4091
X_ih_1_12 a_xp1 a_xn1 up_h12 un_h12 wp_ih_1_12 wn_ih_1_12 vdd dsyn
Vwp_bh_12 wp_bh_12 0 0.4280
Vwn_bh_12 wn_bh_12 0 0.4120
X_bh_12 bp_hi bp_lo up_h12 un_h12 wp_bh_12 wn_bh_12 vdd dsyn
Mlp_h13 up_h13 up_h13 vdd vdd PNR W=900u L=100u
Mln_h13 un_h13 un_h13 vdd vdd PNR W=900u L=100u
Xn_h13 up_h13 un_h13 ap_h13 an_h13 vdd vbn dneuron
Vwp_ih_0_13 wp_ih_0_13 0 0.4013
Vwn_ih_0_13 wn_ih_0_13 0 0.4387
X_ih_0_13 a_xp0 a_xn0 up_h13 un_h13 wp_ih_0_13 wn_ih_0_13 vdd dsyn
Vwp_ih_1_13 wp_ih_1_13 0 0.4294
Vwn_ih_1_13 wn_ih_1_13 0 0.4106
X_ih_1_13 a_xp1 a_xn1 up_h13 un_h13 wp_ih_1_13 wn_ih_1_13 vdd dsyn
Vwp_bh_13 wp_bh_13 0 0.4302
Vwn_bh_13 wn_bh_13 0 0.4098
X_bh_13 bp_hi bp_lo up_h13 un_h13 wp_bh_13 wn_bh_13 vdd dsyn
Mlp_h14 up_h14 up_h14 vdd vdd PNR W=900u L=100u
Mln_h14 un_h14 un_h14 vdd vdd PNR W=900u L=100u
Xn_h14 up_h14 un_h14 ap_h14 an_h14 vdd vbn dneuron
Vwp_ih_0_14 wp_ih_0_14 0 0.4690
Vwn_ih_0_14 wn_ih_0_14 0 0.3710
X_ih_0_14 a_xp0 a_xn0 up_h14 un_h14 wp_ih_0_14 wn_ih_0_14 vdd dsyn
Vwp_ih_1_14 wp_ih_1_14 0 0.4081
Vwn_ih_1_14 wn_ih_1_14 0 0.4319
X_ih_1_14 a_xp1 a_xn1 up_h14 un_h14 wp_ih_1_14 wn_ih_1_14 vdd dsyn
Vwp_bh_14 wp_bh_14 0 0.4301
Vwn_bh_14 wn_bh_14 0 0.4099
X_bh_14 bp_hi bp_lo up_h14 un_h14 wp_bh_14 wn_bh_14 vdd dsyn
Mlp_h15 up_h15 up_h15 vdd vdd PNR W=900u L=100u
Mln_h15 un_h15 un_h15 vdd vdd PNR W=900u L=100u
Xn_h15 up_h15 un_h15 ap_h15 an_h15 vdd vbn dneuron
Vwp_ih_0_15 wp_ih_0_15 0 0.4558
Vwn_ih_0_15 wn_ih_0_15 0 0.3842
X_ih_0_15 a_xp0 a_xn0 up_h15 un_h15 wp_ih_0_15 wn_ih_0_15 vdd dsyn
Vwp_ih_1_15 wp_ih_1_15 0 0.4062
Vwn_ih_1_15 wn_ih_1_15 0 0.4338
X_ih_1_15 a_xp1 a_xn1 up_h15 un_h15 wp_ih_1_15 wn_ih_1_15 vdd dsyn
Vwp_bh_15 wp_bh_15 0 0.4022
Vwn_bh_15 wn_bh_15 0 0.4378
X_bh_15 bp_hi bp_lo up_h15 un_h15 wp_bh_15 wn_bh_15 vdd dsyn
Mlp_o0 up_o0 up_o0 vdd vdd PNR W=5100u L=100u
Mln_o0 un_o0 un_o0 vdd vdd PNR W=5100u L=100u
Vwp_fo_0_0 wp_fo_0_0 0 0.4332
Vwn_fo_0_0 wn_fo_0_0 0 0.4068
X_fo_0_0 ap_h0 an_h0 up_o0 un_o0 wp_fo_0_0 wn_fo_0_0 vdd dsyn
Vwp_fo_1_0 wp_fo_1_0 0 0.4432
Vwn_fo_1_0 wn_fo_1_0 0 0.3968
X_fo_1_0 ap_h1 an_h1 up_o0 un_o0 wp_fo_1_0 wn_fo_1_0 vdd dsyn
Vwp_fo_2_0 wp_fo_2_0 0 0.3905
Vwn_fo_2_0 wn_fo_2_0 0 0.4495
X_fo_2_0 ap_h2 an_h2 up_o0 un_o0 wp_fo_2_0 wn_fo_2_0 vdd dsyn
Vwp_fo_3_0 wp_fo_3_0 0 0.4083
Vwn_fo_3_0 wn_fo_3_0 0 0.4317
X_fo_3_0 ap_h3 an_h3 up_o0 un_o0 wp_fo_3_0 wn_fo_3_0 vdd dsyn
Vwp_fo_4_0 wp_fo_4_0 0 0.4718
Vwn_fo_4_0 wn_fo_4_0 0 0.3682
X_fo_4_0 ap_h4 an_h4 up_o0 un_o0 wp_fo_4_0 wn_fo_4_0 vdd dsyn
Vwp_fo_5_0 wp_fo_5_0 0 0.4031
Vwn_fo_5_0 wn_fo_5_0 0 0.4369
X_fo_5_0 ap_h5 an_h5 up_o0 un_o0 wp_fo_5_0 wn_fo_5_0 vdd dsyn
Vwp_fo_6_0 wp_fo_6_0 0 0.4049
Vwn_fo_6_0 wn_fo_6_0 0 0.4351
X_fo_6_0 ap_h6 an_h6 up_o0 un_o0 wp_fo_6_0 wn_fo_6_0 vdd dsyn
Vwp_fo_7_0 wp_fo_7_0 0 0.3541
Vwn_fo_7_0 wn_fo_7_0 0 0.4859
X_fo_7_0 ap_h7 an_h7 up_o0 un_o0 wp_fo_7_0 wn_fo_7_0 vdd dsyn
Vwp_fo_8_0 wp_fo_8_0 0 0.4171
Vwn_fo_8_0 wn_fo_8_0 0 0.4229
X_fo_8_0 ap_h8 an_h8 up_o0 un_o0 wp_fo_8_0 wn_fo_8_0 vdd dsyn
Vwp_fo_9_0 wp_fo_9_0 0 0.3997
Vwn_fo_9_0 wn_fo_9_0 0 0.4403
X_fo_9_0 ap_h9 an_h9 up_o0 un_o0 wp_fo_9_0 wn_fo_9_0 vdd dsyn
Vwp_fo_10_0 wp_fo_10_0 0 0.4493
Vwn_fo_10_0 wn_fo_10_0 0 0.3907
X_fo_10_0 ap_h10 an_h10 up_o0 un_o0 wp_fo_10_0 wn_fo_10_0 vdd dsyn
Vwp_fo_11_0 wp_fo_11_0 0 0.4192
Vwn_fo_11_0 wn_fo_11_0 0 0.4208
X_fo_11_0 ap_h11 an_h11 up_o0 un_o0 wp_fo_11_0 wn_fo_11_0 vdd dsyn
Vwp_fo_12_0 wp_fo_12_0 0 0.3807
Vwn_fo_12_0 wn_fo_12_0 0 0.4593
X_fo_12_0 ap_h12 an_h12 up_o0 un_o0 wp_fo_12_0 wn_fo_12_0 vdd dsyn
Vwp_fo_13_0 wp_fo_13_0 0 0.4504
Vwn_fo_13_0 wn_fo_13_0 0 0.3896
X_fo_13_0 ap_h13 an_h13 up_o0 un_o0 wp_fo_13_0 wn_fo_13_0 vdd dsyn
Vwp_fo_14_0 wp_fo_14_0 0 0.3876
Vwn_fo_14_0 wn_fo_14_0 0 0.4524
X_fo_14_0 ap_h14 an_h14 up_o0 un_o0 wp_fo_14_0 wn_fo_14_0 vdd dsyn
Vwp_fo_15_0 wp_fo_15_0 0 0.3607
Vwn_fo_15_0 wn_fo_15_0 0 0.4793
X_fo_15_0 ap_h15 an_h15 up_o0 un_o0 wp_fo_15_0 wn_fo_15_0 vdd dsyn
Vwp_bo_0 wp_bo_0 0 0.4510
Vwn_bo_0 wn_bo_0 0 0.3890
X_bo_0 bp_hi bp_lo up_o0 un_o0 wp_bo_0 wn_bo_0 vdd dsyn
Rbp0 up_o0 vtp0 1e10
Rbn0 un_o0 vtn0 1e10
Mlp_o1 up_o1 up_o1 vdd vdd PNR W=5100u L=100u
Mln_o1 un_o1 un_o1 vdd vdd PNR W=5100u L=100u
Vwp_fo_0_1 wp_fo_0_1 0 0.3679
Vwn_fo_0_1 wn_fo_0_1 0 0.4721
X_fo_0_1 ap_h0 an_h0 up_o1 un_o1 wp_fo_0_1 wn_fo_0_1 vdd dsyn
Vwp_fo_1_1 wp_fo_1_1 0 0.4346
Vwn_fo_1_1 wn_fo_1_1 0 0.4054
X_fo_1_1 ap_h1 an_h1 up_o1 un_o1 wp_fo_1_1 wn_fo_1_1 vdd dsyn
Vwp_fo_2_1 wp_fo_2_1 0 0.4135
Vwn_fo_2_1 wn_fo_2_1 0 0.4265
X_fo_2_1 ap_h2 an_h2 up_o1 un_o1 wp_fo_2_1 wn_fo_2_1 vdd dsyn
Vwp_fo_3_1 wp_fo_3_1 0 0.3887
Vwn_fo_3_1 wn_fo_3_1 0 0.4513
X_fo_3_1 ap_h3 an_h3 up_o1 un_o1 wp_fo_3_1 wn_fo_3_1 vdd dsyn
Vwp_fo_4_1 wp_fo_4_1 0 0.4603
Vwn_fo_4_1 wn_fo_4_1 0 0.3797
X_fo_4_1 ap_h4 an_h4 up_o1 un_o1 wp_fo_4_1 wn_fo_4_1 vdd dsyn
Vwp_fo_5_1 wp_fo_5_1 0 0.4285
Vwn_fo_5_1 wn_fo_5_1 0 0.4115
X_fo_5_1 ap_h5 an_h5 up_o1 un_o1 wp_fo_5_1 wn_fo_5_1 vdd dsyn
Vwp_fo_6_1 wp_fo_6_1 0 0.5017
Vwn_fo_6_1 wn_fo_6_1 0 0.3383
X_fo_6_1 ap_h6 an_h6 up_o1 un_o1 wp_fo_6_1 wn_fo_6_1 vdd dsyn
Vwp_fo_7_1 wp_fo_7_1 0 0.4267
Vwn_fo_7_1 wn_fo_7_1 0 0.4133
X_fo_7_1 ap_h7 an_h7 up_o1 un_o1 wp_fo_7_1 wn_fo_7_1 vdd dsyn
Vwp_fo_8_1 wp_fo_8_1 0 0.3822
Vwn_fo_8_1 wn_fo_8_1 0 0.4578
X_fo_8_1 ap_h8 an_h8 up_o1 un_o1 wp_fo_8_1 wn_fo_8_1 vdd dsyn
Vwp_fo_9_1 wp_fo_9_1 0 0.4437
Vwn_fo_9_1 wn_fo_9_1 0 0.3963
X_fo_9_1 ap_h9 an_h9 up_o1 un_o1 wp_fo_9_1 wn_fo_9_1 vdd dsyn
Vwp_fo_10_1 wp_fo_10_1 0 0.3999
Vwn_fo_10_1 wn_fo_10_1 0 0.4401
X_fo_10_1 ap_h10 an_h10 up_o1 un_o1 wp_fo_10_1 wn_fo_10_1 vdd dsyn
Vwp_fo_11_1 wp_fo_11_1 0 0.3701
Vwn_fo_11_1 wn_fo_11_1 0 0.4699
X_fo_11_1 ap_h11 an_h11 up_o1 un_o1 wp_fo_11_1 wn_fo_11_1 vdd dsyn
Vwp_fo_12_1 wp_fo_12_1 0 0.3757
Vwn_fo_12_1 wn_fo_12_1 0 0.4643
X_fo_12_1 ap_h12 an_h12 up_o1 un_o1 wp_fo_12_1 wn_fo_12_1 vdd dsyn
Vwp_fo_13_1 wp_fo_13_1 0 0.3540
Vwn_fo_13_1 wn_fo_13_1 0 0.4860
X_fo_13_1 ap_h13 an_h13 up_o1 un_o1 wp_fo_13_1 wn_fo_13_1 vdd dsyn
Vwp_fo_14_1 wp_fo_14_1 0 0.4501
Vwn_fo_14_1 wn_fo_14_1 0 0.3899
X_fo_14_1 ap_h14 an_h14 up_o1 un_o1 wp_fo_14_1 wn_fo_14_1 vdd dsyn
Vwp_fo_15_1 wp_fo_15_1 0 0.4156
Vwn_fo_15_1 wn_fo_15_1 0 0.4244
X_fo_15_1 ap_h15 an_h15 up_o1 un_o1 wp_fo_15_1 wn_fo_15_1 vdd dsyn
Vwp_bo_1 wp_bo_1 0 0.4277
Vwn_bo_1 wn_bo_1 0 0.4123
X_bo_1 bp_hi bp_lo up_o1 un_o1 wp_bo_1 wn_bo_1 vdd dsyn
Rbp1 up_o1 vtp1 1e10
Rbn1 un_o1 vtn1 1e10
.nodeset v(up_h0)=0.5 v(un_h0)=0.5 v(ap_h0)=0.5 v(an_h0)=0.5 v(up_h1)=0.5 v(un_h1)=0.5 v(ap_h1)=0.5 v(an_h1)=0.5 v(up_h2)=0.5 v(un_h2)=0.5 v(ap_h2)=0.5 v(an_h2)=0.5 v(up_h3)=0.5 v(un_h3)=0.5 v(ap_h3)=0.5 v(an_h3)=0.5 v(up_h4)=0.5 v(un_h4)=0.5 v(ap_h4)=0.5 v(an_h4)=0.5 v(up_h5)=0.5 v(un_h5)=0.5 v(ap_h5)=0.5 v(an_h5)=0.5 v(up_h6)=0.5 v(un_h6)=0.5 v(ap_h6)=0.5 v(an_h6)=0.5 v(up_h7)=0.5 v(un_h7)=0.5 v(ap_h7)=0.5 v(an_h7)=0.5 v(up_h8)=0.5 v(un_h8)=0.5 v(ap_h8)=0.5 v(an_h8)=0.5 v(up_h9)=0.5 v(un_h9)=0.5 v(ap_h9)=0.5 v(an_h9)=0.5 v(up_h10)=0.5 v(un_h10)=0.5 v(ap_h10)=0.5 v(an_h10)=0.5 v(up_h11)=0.5 v(un_h11)=0.5 v(ap_h11)=0.5 v(an_h11)=0.5 v(up_h12)=0.5 v(un_h12)=0.5 v(ap_h12)=0.5 v(an_h12)=0.5 v(up_h13)=0.5 v(un_h13)=0.5 v(ap_h13)=0.5 v(an_h13)=0.5 v(up_h14)=0.5 v(un_h14)=0.5 v(ap_h14)=0.5 v(an_h14)=0.5 v(up_h15)=0.5 v(un_h15)=0.5 v(ap_h15)=0.5 v(an_h15)=0.5 v(up_o0)=0.5 v(un_o0)=0.5 v(up_o1)=0.5 v(un_o1)=0.5
.end
