pcL 2D
.model NNR NMOS (LEVEL=1 VTO=0.2 KP=120u LAMBDA=0.02 GAMMA=0 PHI=0.7)
.model PNR PMOS (LEVEL=1 VTO=-0.2 KP=40u LAMBDA=0.02 GAMMA=0 PHI=0.7)
.subckt gsyn inp inn wp wn outp outn vdd vbn
Mtail nt vbn 0 0 NNR W=400u L=100u
M5 na wp nt 0 NNR W=200u L=100u
M6 nb wn nt 0 NNR W=200u L=100u
M1 outp inp na 0 NNR W=200u L=100u
M2 outn inn na 0 NNR W=200u L=100u
M3 outn inp nb 0 NNR W=200u L=100u
M4 outp inn nb 0 NNR W=200u L=100u
.ends
.subckt cmld p n vdd
Rcs1 p cmx 300k
Rcs2 n cmx 300k
MLp p cmx vdd vdd PNR W=1000u L=100u
MLn n cmx vdd vdd PNR W=1000u L=100u
.ends
.subckt dneuron up un ap an vdd vbn
M1 an up tn 0 NNR W=200u L=100u
M2 ap un tn 0 NNR W=200u L=100u
Mt tn vbn 0 0 NNR W=200u L=100u
Xcm ap an vdd cmld
.ends
.subckt esub xp xn mp mn ep en vdd vbn
Mt nt vbn 0 0 NNR W=400u L=100u
M1x ep xn nt 0 NNR W=200u L=100u
M2x en xp nt 0 NNR W=200u L=100u
M1m ep mp nt 0 NNR W=200u L=100u
M2m en mn nt 0 NNR W=200u L=100u
RLp vdd ep 50k
RLn vdd en 50k
.ends
.subckt gprod xp xn yp yn wp wn vdd vbn
Mtail nt vbn 0 0 NNR W=400u L=100u
M5 na yp nt 0 NNR W=200u L=100u
M6 nb yn nt 0 NNR W=200u L=100u
M1 iop xp na 0 NNR W=200u L=100u
M2 ion xn na 0 NNR W=200u L=100u
M3 ion xp nb 0 NNR W=200u L=100u
M4 iop xn nb 0 NNR W=200u L=100u
Mlp iop iop vdd vdd PNR W=200u L=100u
Mln ion ion vdd vdd PNR W=200u L=100u
Mpu_wp wp iop vdd vdd PNR W=200u L=100u
MpRn nrn ion vdd vdd PNR W=200u L=100u
MnRn nrn nrn 0 0 NNR W=200u L=100u
Mpd_wp wp nrn 0 0 NNR W=200u L=100u
Mpu_wn wn ion vdd vdd PNR W=200u L=100u
MpRp nrp iop vdd vdd PNR W=200u L=100u
MnRp nrp nrp 0 0 NNR W=200u L=100u
Mpd_wn wn nrp 0 0 NNR W=200u L=100u
.ends
Vdd vdd 0 1.0
Vbsyn vbsyn 0 0.6
Vbneu vbneu 0 0.35
Vgm_h gm_h 0 0.6
Vgm_o gm_o 0 PWL(0 0.6 -0.1n 0.6 0.0n 0)
Vgblh gblh 0 PWL(0 0.85 -0.1n 0.85 0.0n 0)
Vgblo gblo 0 PWL(0 0.85 -0.1n 0.85 0.0n 0)
Vwcm wcm 0 0.5
Vx1p a_xp1 0 PWL(0.0n 0.3107 249.9n 0.3107 250.0n 0.4834 499.9n 0.4834 500.0n 0.6594 749.9n 0.6594 750.0n 0.7792 999.9n 0.7792 1000.0n 0.6041 1249.9n 0.6041 1250.0n 0.8206 1499.9n 0.8206 1500.0n 0.4166 1749.9n 0.4166 1750.0n 0.4589 1999.9n 0.4589 2000.0n 0.1745 2249.9n 0.1745 2250.0n 0.8124 2499.9n 0.8124 2500.0n 0.5672 2749.9n 0.5672 2750.0n 0.8897 2999.9n 0.8897 3000.0n 0.6001 3249.9n 0.6001 3250.0n 0.5490 3499.9n 0.5490 3500.0n 0.4447 3749.9n 0.4447 3750.0n 0.6754 3999.9n 0.6754 4000.0n 0.7608 4249.9n 0.7608 4250.0n 0.4149 4499.9n 0.4149 4500.0n 0.4621 4749.9n 0.4621 4750.0n 0.4913 4999.9n 0.4913 5000.0n 0.8701 5249.9n 0.8701 5250.0n 0.4959 5499.9n 0.4959 5500.0n 0.3560 5749.9n 0.3560 5750.0n 0.4287 5999.9n 0.4287 6000.0n 0.1548 6249.9n 0.1548 6250.0n 0.4628 6499.9n 0.4628 6500.0n 0.6434 6749.9n 0.6434 6750.0n 0.6490 6999.9n 0.6490 7000.0n 0.3383 7249.9n 0.3383 7250.0n 0.3113 7499.9n 0.3113 7500.0n 0.3461 7749.9n 0.3461 7750.0n 0.3966 7999.9n 0.3966 8000.0n 0.7259 8249.9n 0.7259 8250.0n 0.4362 8499.9n 0.4362 8500.0n 0.1795 8749.9n 0.1795 8750.0n 0.4950 8999.9n 0.4950 9000.0n 0.1662 9249.9n 0.1662 9250.0n 0.5373 9499.9n 0.5373 9500.0n 0.6102 9749.9n 0.6102 9750.0n 0.2205 9999.9n 0.2205 10000.0n 0.3834 10249.9n 0.3834 10250.0n 0.3521 10499.9n 0.3521 10500.0n 0.1178 10749.9n 0.1178 10750.0n 0.4857 10999.9n 0.4857 11000.0n 0.3739 11249.9n 0.3739 11250.0n 0.5464 11499.9n 0.5464 11500.0n 0.5108 11749.9n 0.5108 11750.0n 0.1733 11999.9n 0.1733 12000.0n 0.5952 12249.9n 0.5952 12250.0n 0.6668 12499.9n 0.6668 12500.0n 0.5810 12749.9n 0.5810 12750.0n 0.4974 12999.9n 0.4974 13000.0n 0.5851 13249.9n 0.5851 13250.0n 0.7953 13499.9n 0.7953 13500.0n 0.4494 13749.9n 0.4494 13750.0n 0.5682 13999.9n 0.5682 14000.0n 0.0625 14249.9n 0.0625 14250.0n 0.5828 14499.9n 0.5828 14500.0n 0.5344 14749.9n 0.5344 14750.0n 0.8837 14999.9n 0.8837 15000.0n 0.3835 15249.9n 0.3835 15250.0n 0.5269 15499.9n 0.5269 15500.0n 0.7309 15749.9n 0.7309 15750.0n 0.2192 15999.9n 0.2192 16000.0n 0.4891 16249.9n 0.4891 16250.0n 0.4404 16499.9n 0.4404 16500.0n 0.6080 16749.9n 0.6080 16750.0n 0.6372 16999.9n 0.6372 17000.0n 0.2036 17249.9n 0.2036 17250.0n 0.6318 17499.9n 0.6318 17500.0n 0.4164 17749.9n 0.4164 17750.0n 0.8548 17999.9n 0.8548 18000.0n 0.4007 18249.9n 0.4007 18250.0n 0.8394 18499.9n 0.8394 18500.0n 0.1395 18749.9n 0.1395 18750.0n 0.4399 18999.9n 0.4399 19000.0n 0.4083 19249.9n 0.4083 19250.0n 0.6674 19499.9n 0.6674 19500.0n 0.6152 19749.9n 0.6152 19750.0n 0.1826 19999.9n 0.1826 20000.0n 0.5099 20249.9n 0.5099 20250.0n 0.3440 20499.9n 0.3440 20500.0n 0.1220 20749.9n 0.1220 20750.0n 0.5003 20999.9n 0.5003 21000.0n 0.4500 21249.9n 0.4500 21250.0n 0.4604 21499.9n 0.4604 21500.0n 0.3923 21749.9n 0.3923 21750.0n 0.5082 21999.9n 0.5082 22000.0n 0.5900 22249.9n 0.5900 22250.0n 0.4540 22499.9n 0.4540 22500.0n 0.8848 22749.9n 0.8848 22750.0n 0.9031 22999.9n 0.9031 23000.0n 0.5982 23249.9n 0.5982 23250.0n 0.7884 23499.9n 0.7884 23500.0n 0.5984 23749.9n 0.5984 23750.0n 0.6475 23999.9n 0.6475 24000.0n 0.7248 24249.9n 0.7248 24250.0n 0.5652 24499.9n 0.5652 24500.0n 0.8078 24749.9n 0.8078 24750.0n 0.5265 24999.9n 0.5265 25000.0n 0.1138 25249.9n 0.1138 25250.0n 0.5127 25499.9n 0.5127 25500.0n 0.6153 25749.9n 0.6153 25750.0n 0.5668 25999.9n 0.5668 26000.0n 0.4542 26249.9n 0.4542 26250.0n 0.1480 26499.9n 0.1480 26500.0n 0.1295 26749.9n 0.1295 26750.0n 0.5404 26999.9n 0.5404 27000.0n 0.5047 27249.9n 0.5047 27250.0n 0.4449 27499.9n 0.4449 27500.0n 0.1719 27749.9n 0.1719 27750.0n 0.9143 27999.9n 0.9143 28000.0n 0.4263 28249.9n 0.4263 28250.0n 0.5295 28499.9n 0.5295 28500.0n 0.4966 28749.9n 0.4966 28750.0n 0.3282 28999.9n 0.3282 29000.0n 0.5205 29249.9n 0.5205 29250.0n 0.5118 29499.9n 0.5118 29500.0n 0.7286 29749.9n 0.7286 29750.0n 0.6077 29999.9n 0.6077 30000.0n 0.4215 30249.9n 0.4215 30250.0n 0.2410 30499.9n 0.2410 30500.0n 0.8596 30749.9n 0.8596 30750.0n 0.3531 30999.9n 0.3531 31000.0n 0.4916 31249.9n 0.4916 31250.0n 0.5131 31499.9n 0.5131 31500.0n 0.5148 31749.9n 0.5148 31750.0n 0.4990 31999.9n 0.4990 32000.0n 0.7439 32249.9n 0.7439 32250.0n 0.4710 32499.9n 0.4710 32500.0n 0.4143 32749.9n 0.4143 32750.0n 0.3898 32999.9n 0.3898 33000.0n 0.5549 33249.9n 0.5549 33250.0n 0.4100 33499.9n 0.4100 33500.0n 0.4793 33749.9n 0.4793 33750.0n 0.4557 33999.9n 0.4557 34000.0n 0.6234 34249.9n 0.6234 34250.0n 0.4238 34499.9n 0.4238 34500.0n 0.8056 34749.9n 0.8056 34750.0n 0.4407 34999.9n 0.4407 35000.0n 0.4888 35249.9n 0.4888 35250.0n 0.2490 35499.9n 0.2490 35500.0n 0.5055 35749.9n 0.5055 35750.0n 0.5332 35999.9n 0.5332 36000.0n 0.2488 36249.9n 0.2488 36250.0n 0.7628 36499.9n 0.7628 36500.0n 0.9218 36749.9n 0.9218 36750.0n 0.5327 36999.9n 0.5327 37000.0n 0.1877 37249.9n 0.1877 37250.0n 0.5220 37499.9n 0.5220 37500.0n 0.7683 37749.9n 0.7683 37750.0n 0.2826 37999.9n 0.2826 38000.0n 0.7503 38249.9n 0.7503 38250.0n 0.5496 38499.9n 0.5496 38500.0n 0.5926 38749.9n 0.5926 38750.0n 0.0822 38999.9n 0.0822 39000.0n 0.4909 39249.9n 0.4909 39250.0n 0.1510 39499.9n 0.1510 39500.0n 0.5025 39749.9n 0.5025 39750.0n 0.4007 39999.9n 0.4007 40000.0n 0.7427 40249.9n 0.7427 40250.0n 0.4708 40499.9n 0.4708 40500.0n 0.6064 40749.9n 0.6064 40750.0n 0.4868 40999.9n 0.4868 41000.0n 0.8672 41249.9n 0.8672 41250.0n 0.9111 41499.9n 0.9111 41500.0n 0.1655 41749.9n 0.1655 41750.0n 0.3815 41999.9n 0.3815 42000.0n 0.6848 42249.9n 0.6848 42250.0n 0.3297 42499.9n 0.3297 42500.0n 0.5605 42749.9n 0.5605 42750.0n 0.4192 42999.9n 0.4192 43000.0n 0.3928 43249.9n 0.3928 43250.0n 0.6123 43499.9n 0.6123 43500.0n 0.6237 43749.9n 0.6237 43750.0n 0.2074 43999.9n 0.2074 44000.0n 0.5478 44249.9n 0.5478 44250.0n 0.4129 44499.9n 0.4129 44500.0n 0.6830 44749.9n 0.6830 44750.0n 0.1937 44999.9n 0.1937 45000.0n 0.5244 45249.9n 0.5244 45250.0n 0.4512 45499.9n 0.4512 45500.0n 0.0933 45749.9n 0.0933 45750.0n 0.6260 45999.9n 0.6260 46000.0n 0.4417 46249.9n 0.4417 46250.0n 0.4687 46499.9n 0.4687 46500.0n 0.2400 46749.9n 0.2400 46750.0n 0.1891 46999.9n 0.1891 47000.0n 0.4894 47249.9n 0.4894 47250.0n 0.3980 47499.9n 0.3980 47500.0n 0.6248 47749.9n 0.6248 47750.0n 0.1171 47999.9n 0.1171 48000.0n 0.2090 48249.9n 0.2090 48250.0n 0.4003 48499.9n 0.4003 48500.0n 0.7930 48749.9n 0.7930 48750.0n 0.8645 48999.9n 0.8645 49000.0n 0.5203 49249.9n 0.5203 49250.0n 0.8861 49499.9n 0.8861 49500.0n 0.4202 49749.9n 0.4202 49750.0n 0.5898 49999.9n 0.5898 50000.0n 0.3159 50249.9n 0.3159 50250.0n 0.8697 50499.9n 0.8697 50500.0n 0.5664 50749.9n 0.5664 50750.0n 0.3695 50999.9n 0.3695 51000.0n 0.4873 51249.9n 0.4873 51250.0n 0.5406 51499.9n 0.5406 51500.0n 0.5882 51749.9n 0.5882 51750.0n 0.1745 51999.9n 0.1745 52000.0n 0.6262 52249.9n 0.6262 52250.0n 0.5196 52499.9n 0.5196 52500.0n 0.4668 52749.9n 0.4668 52750.0n 0.4960 52999.9n 0.4960 53000.0n 0.3800 53249.9n 0.3800 53250.0n 0.3455 53499.9n 0.3455 53500.0n 0.9257 53749.9n 0.9257 53750.0n 0.6576 53999.9n 0.6576 54000.0n 0.3747 54249.9n 0.3747 54250.0n 0.7746 54499.9n 0.7746 54500.0n 0.3713 54749.9n 0.3713 54750.0n 0.3294 54999.9n 0.3294 55000.0n 0.4735 55249.9n 0.4735 55250.0n 0.4244 55499.9n 0.4244 55500.0n 0.5882 55749.9n 0.5882 55750.0n 0.1955 55999.9n 0.1955 56000.0n 0.3663 56249.9n 0.3663 56250.0n 0.7755 56499.9n 0.7755 56500.0n 0.6479 56749.9n 0.6479 56750.0n 0.4875 56999.9n 0.4875 57000.0n 0.2020 57249.9n 0.2020 57250.0n 0.9150 57499.9n 0.9150 57500.0n 0.5539 57749.9n 0.5539 57750.0n 0.5446 57999.9n 0.5446 58000.0n 0.4626 58249.9n 0.4626 58250.0n 0.5260 58499.9n 0.5260 58500.0n 0.6738 58749.9n 0.6738 58750.0n 0.5565 58999.9n 0.5565 59000.0n 0.5394 59249.9n 0.5394 59250.0n 0.4379 59499.9n 0.4379 59500.0n 0.6543 59749.9n 0.6543 59750.0n 0.3827 59999.9n 0.3827 60000.0n 0.1945 60249.9n 0.1945 60250.0n 0.4131 60499.9n 0.4131 60500.0n 0.7737 60749.9n 0.7737 60750.0n 0.4327 60999.9n 0.4327 61000.0n 0.5388 61249.9n 0.5388 61250.0n 0.8164 61499.9n 0.8164 61500.0n 0.3755 61749.9n 0.3755 61750.0n 0.6427 61999.9n 0.6427 62000.0n 0.2278 62249.9n 0.2278 62250.0n 0.5159 62499.9n 0.5159 62500.0n 0.4750 62749.9n 0.4750 62750.0n 0.4420 62999.9n 0.4420 63000.0n 0.5618 63249.9n 0.5618 63250.0n 0.4188 63499.9n 0.4188 63500.0n 0.2514 63749.9n 0.2514 63750.0n 0.4818 63999.9n 0.4818 64000.0n 0.4185 64249.9n 0.4185 64250.0n 0.2248 64499.9n 0.2248 64500.0n 0.8860 64749.9n 0.8860 64750.0n 0.5571 64999.9n 0.5571 65000.0n 0.1985 65249.9n 0.1985 65250.0n 0.3903 65499.9n 0.3903 65500.0n 0.2457 65749.9n 0.2457 65750.0n 0.5817 65999.9n 0.5817 66000.0n 0.5994 66249.9n 0.5994 66250.0n 0.5087 66499.9n 0.5087 66500.0n 0.4843 66749.9n 0.4843 66750.0n 0.4745 66999.9n 0.4745 67000.0n 0.5087 67249.9n 0.5087 67250.0n 0.7977 67499.9n 0.7977 67500.0n 0.3940 67749.9n 0.3940 67750.0n 0.5985 67999.9n 0.5985 68000.0n 0.1595 68249.9n 0.1595 68250.0n 0.4961 68499.9n 0.4961 68500.0n 0.1854 68749.9n 0.1854 68750.0n 0.4534 68999.9n 0.4534 69000.0n 0.6136 69249.9n 0.6136 69250.0n 0.3679 69499.9n 0.3679 69500.0n 0.6053 69749.9n 0.6053 69750.0n 0.4777 69999.9n 0.4777 70000.0n 0.1851 70249.9n 0.1851 70250.0n 0.4144 70499.9n 0.4144 70500.0n 0.4306 70749.9n 0.4306 70750.0n 0.2134 70999.9n 0.2134 71000.0n 0.1361 71249.9n 0.1361 71250.0n 0.4943 71499.9n 0.4943 71500.0n 0.5039 71749.9n 0.5039 71750.0n 0.0500 71999.9n 0.0500 72000.0n 0.6514 72249.9n 0.6514 72250.0n 0.1603 72499.9n 0.1603 72500.0n 0.5608 72749.9n 0.5608 72750.0n 0.1634 72999.9n 0.1634 73000.0n 0.6511 73249.9n 0.6511 73250.0n 0.4930 73499.9n 0.4930 73500.0n 0.5982 73749.9n 0.5982 73750.0n 0.4309 73999.9n 0.4309 74000.0n 0.0535 74249.9n 0.0535 74250.0n 0.1649 74499.9n 0.1649 74500.0n 0.3798 74749.9n 0.3798 74750.0n 0.3535)
Vx1n a_xn1 0 PWL(0.0n 0.6893 249.9n 0.6893 250.0n 0.5166 499.9n 0.5166 500.0n 0.3406 749.9n 0.3406 750.0n 0.2208 999.9n 0.2208 1000.0n 0.3959 1249.9n 0.3959 1250.0n 0.1794 1499.9n 0.1794 1500.0n 0.5834 1749.9n 0.5834 1750.0n 0.5411 1999.9n 0.5411 2000.0n 0.8255 2249.9n 0.8255 2250.0n 0.1876 2499.9n 0.1876 2500.0n 0.4328 2749.9n 0.4328 2750.0n 0.1103 2999.9n 0.1103 3000.0n 0.3999 3249.9n 0.3999 3250.0n 0.4510 3499.9n 0.4510 3500.0n 0.5553 3749.9n 0.5553 3750.0n 0.3246 3999.9n 0.3246 4000.0n 0.2392 4249.9n 0.2392 4250.0n 0.5851 4499.9n 0.5851 4500.0n 0.5379 4749.9n 0.5379 4750.0n 0.5087 4999.9n 0.5087 5000.0n 0.1299 5249.9n 0.1299 5250.0n 0.5041 5499.9n 0.5041 5500.0n 0.6440 5749.9n 0.6440 5750.0n 0.5713 5999.9n 0.5713 6000.0n 0.8452 6249.9n 0.8452 6250.0n 0.5372 6499.9n 0.5372 6500.0n 0.3566 6749.9n 0.3566 6750.0n 0.3510 6999.9n 0.3510 7000.0n 0.6617 7249.9n 0.6617 7250.0n 0.6887 7499.9n 0.6887 7500.0n 0.6539 7749.9n 0.6539 7750.0n 0.6034 7999.9n 0.6034 8000.0n 0.2741 8249.9n 0.2741 8250.0n 0.5638 8499.9n 0.5638 8500.0n 0.8205 8749.9n 0.8205 8750.0n 0.5050 8999.9n 0.5050 9000.0n 0.8338 9249.9n 0.8338 9250.0n 0.4627 9499.9n 0.4627 9500.0n 0.3898 9749.9n 0.3898 9750.0n 0.7795 9999.9n 0.7795 10000.0n 0.6166 10249.9n 0.6166 10250.0n 0.6479 10499.9n 0.6479 10500.0n 0.8822 10749.9n 0.8822 10750.0n 0.5143 10999.9n 0.5143 11000.0n 0.6261 11249.9n 0.6261 11250.0n 0.4536 11499.9n 0.4536 11500.0n 0.4892 11749.9n 0.4892 11750.0n 0.8267 11999.9n 0.8267 12000.0n 0.4048 12249.9n 0.4048 12250.0n 0.3332 12499.9n 0.3332 12500.0n 0.4190 12749.9n 0.4190 12750.0n 0.5026 12999.9n 0.5026 13000.0n 0.4149 13249.9n 0.4149 13250.0n 0.2047 13499.9n 0.2047 13500.0n 0.5506 13749.9n 0.5506 13750.0n 0.4318 13999.9n 0.4318 14000.0n 0.9375 14249.9n 0.9375 14250.0n 0.4172 14499.9n 0.4172 14500.0n 0.4656 14749.9n 0.4656 14750.0n 0.1163 14999.9n 0.1163 15000.0n 0.6165 15249.9n 0.6165 15250.0n 0.4731 15499.9n 0.4731 15500.0n 0.2691 15749.9n 0.2691 15750.0n 0.7808 15999.9n 0.7808 16000.0n 0.5109 16249.9n 0.5109 16250.0n 0.5596 16499.9n 0.5596 16500.0n 0.3920 16749.9n 0.3920 16750.0n 0.3628 16999.9n 0.3628 17000.0n 0.7964 17249.9n 0.7964 17250.0n 0.3682 17499.9n 0.3682 17500.0n 0.5836 17749.9n 0.5836 17750.0n 0.1452 17999.9n 0.1452 18000.0n 0.5993 18249.9n 0.5993 18250.0n 0.1606 18499.9n 0.1606 18500.0n 0.8605 18749.9n 0.8605 18750.0n 0.5601 18999.9n 0.5601 19000.0n 0.5917 19249.9n 0.5917 19250.0n 0.3326 19499.9n 0.3326 19500.0n 0.3848 19749.9n 0.3848 19750.0n 0.8174 19999.9n 0.8174 20000.0n 0.4901 20249.9n 0.4901 20250.0n 0.6560 20499.9n 0.6560 20500.0n 0.8780 20749.9n 0.8780 20750.0n 0.4997 20999.9n 0.4997 21000.0n 0.5500 21249.9n 0.5500 21250.0n 0.5396 21499.9n 0.5396 21500.0n 0.6077 21749.9n 0.6077 21750.0n 0.4918 21999.9n 0.4918 22000.0n 0.4100 22249.9n 0.4100 22250.0n 0.5460 22499.9n 0.5460 22500.0n 0.1152 22749.9n 0.1152 22750.0n 0.0969 22999.9n 0.0969 23000.0n 0.4018 23249.9n 0.4018 23250.0n 0.2116 23499.9n 0.2116 23500.0n 0.4016 23749.9n 0.4016 23750.0n 0.3525 23999.9n 0.3525 24000.0n 0.2752 24249.9n 0.2752 24250.0n 0.4348 24499.9n 0.4348 24500.0n 0.1922 24749.9n 0.1922 24750.0n 0.4735 24999.9n 0.4735 25000.0n 0.8862 25249.9n 0.8862 25250.0n 0.4873 25499.9n 0.4873 25500.0n 0.3847 25749.9n 0.3847 25750.0n 0.4332 25999.9n 0.4332 26000.0n 0.5458 26249.9n 0.5458 26250.0n 0.8520 26499.9n 0.8520 26500.0n 0.8705 26749.9n 0.8705 26750.0n 0.4596 26999.9n 0.4596 27000.0n 0.4953 27249.9n 0.4953 27250.0n 0.5551 27499.9n 0.5551 27500.0n 0.8281 27749.9n 0.8281 27750.0n 0.0857 27999.9n 0.0857 28000.0n 0.5737 28249.9n 0.5737 28250.0n 0.4705 28499.9n 0.4705 28500.0n 0.5034 28749.9n 0.5034 28750.0n 0.6718 28999.9n 0.6718 29000.0n 0.4795 29249.9n 0.4795 29250.0n 0.4882 29499.9n 0.4882 29500.0n 0.2714 29749.9n 0.2714 29750.0n 0.3923 29999.9n 0.3923 30000.0n 0.5785 30249.9n 0.5785 30250.0n 0.7590 30499.9n 0.7590 30500.0n 0.1404 30749.9n 0.1404 30750.0n 0.6469 30999.9n 0.6469 31000.0n 0.5084 31249.9n 0.5084 31250.0n 0.4869 31499.9n 0.4869 31500.0n 0.4852 31749.9n 0.4852 31750.0n 0.5010 31999.9n 0.5010 32000.0n 0.2561 32249.9n 0.2561 32250.0n 0.5290 32499.9n 0.5290 32500.0n 0.5857 32749.9n 0.5857 32750.0n 0.6102 32999.9n 0.6102 33000.0n 0.4451 33249.9n 0.4451 33250.0n 0.5900 33499.9n 0.5900 33500.0n 0.5207 33749.9n 0.5207 33750.0n 0.5443 33999.9n 0.5443 34000.0n 0.3766 34249.9n 0.3766 34250.0n 0.5762 34499.9n 0.5762 34500.0n 0.1944 34749.9n 0.1944 34750.0n 0.5593 34999.9n 0.5593 35000.0n 0.5112 35249.9n 0.5112 35250.0n 0.7510 35499.9n 0.7510 35500.0n 0.4945 35749.9n 0.4945 35750.0n 0.4668 35999.9n 0.4668 36000.0n 0.7512 36249.9n 0.7512 36250.0n 0.2372 36499.9n 0.2372 36500.0n 0.0782 36749.9n 0.0782 36750.0n 0.4673 36999.9n 0.4673 37000.0n 0.8123 37249.9n 0.8123 37250.0n 0.4780 37499.9n 0.4780 37500.0n 0.2317 37749.9n 0.2317 37750.0n 0.7174 37999.9n 0.7174 38000.0n 0.2497 38249.9n 0.2497 38250.0n 0.4504 38499.9n 0.4504 38500.0n 0.4074 38749.9n 0.4074 38750.0n 0.9178 38999.9n 0.9178 39000.0n 0.5091 39249.9n 0.5091 39250.0n 0.8490 39499.9n 0.8490 39500.0n 0.4975 39749.9n 0.4975 39750.0n 0.5993 39999.9n 0.5993 40000.0n 0.2573 40249.9n 0.2573 40250.0n 0.5292 40499.9n 0.5292 40500.0n 0.3936 40749.9n 0.3936 40750.0n 0.5132 40999.9n 0.5132 41000.0n 0.1328 41249.9n 0.1328 41250.0n 0.0889 41499.9n 0.0889 41500.0n 0.8345 41749.9n 0.8345 41750.0n 0.6185 41999.9n 0.6185 42000.0n 0.3152 42249.9n 0.3152 42250.0n 0.6703 42499.9n 0.6703 42500.0n 0.4395 42749.9n 0.4395 42750.0n 0.5808 42999.9n 0.5808 43000.0n 0.6072 43249.9n 0.6072 43250.0n 0.3877 43499.9n 0.3877 43500.0n 0.3763 43749.9n 0.3763 43750.0n 0.7926 43999.9n 0.7926 44000.0n 0.4522 44249.9n 0.4522 44250.0n 0.5871 44499.9n 0.5871 44500.0n 0.3170 44749.9n 0.3170 44750.0n 0.8063 44999.9n 0.8063 45000.0n 0.4756 45249.9n 0.4756 45250.0n 0.5488 45499.9n 0.5488 45500.0n 0.9067 45749.9n 0.9067 45750.0n 0.3740 45999.9n 0.3740 46000.0n 0.5583 46249.9n 0.5583 46250.0n 0.5313 46499.9n 0.5313 46500.0n 0.7600 46749.9n 0.7600 46750.0n 0.8109 46999.9n 0.8109 47000.0n 0.5106 47249.9n 0.5106 47250.0n 0.6020 47499.9n 0.6020 47500.0n 0.3752 47749.9n 0.3752 47750.0n 0.8829 47999.9n 0.8829 48000.0n 0.7910 48249.9n 0.7910 48250.0n 0.5997 48499.9n 0.5997 48500.0n 0.2070 48749.9n 0.2070 48750.0n 0.1355 48999.9n 0.1355 49000.0n 0.4797 49249.9n 0.4797 49250.0n 0.1139 49499.9n 0.1139 49500.0n 0.5798 49749.9n 0.5798 49750.0n 0.4102 49999.9n 0.4102 50000.0n 0.6841 50249.9n 0.6841 50250.0n 0.1303 50499.9n 0.1303 50500.0n 0.4336 50749.9n 0.4336 50750.0n 0.6305 50999.9n 0.6305 51000.0n 0.5127 51249.9n 0.5127 51250.0n 0.4594 51499.9n 0.4594 51500.0n 0.4118 51749.9n 0.4118 51750.0n 0.8255 51999.9n 0.8255 52000.0n 0.3738 52249.9n 0.3738 52250.0n 0.4804 52499.9n 0.4804 52500.0n 0.5332 52749.9n 0.5332 52750.0n 0.5040 52999.9n 0.5040 53000.0n 0.6200 53249.9n 0.6200 53250.0n 0.6545 53499.9n 0.6545 53500.0n 0.0743 53749.9n 0.0743 53750.0n 0.3424 53999.9n 0.3424 54000.0n 0.6253 54249.9n 0.6253 54250.0n 0.2254 54499.9n 0.2254 54500.0n 0.6287 54749.9n 0.6287 54750.0n 0.6706 54999.9n 0.6706 55000.0n 0.5265 55249.9n 0.5265 55250.0n 0.5756 55499.9n 0.5756 55500.0n 0.4118 55749.9n 0.4118 55750.0n 0.8045 55999.9n 0.8045 56000.0n 0.6337 56249.9n 0.6337 56250.0n 0.2245 56499.9n 0.2245 56500.0n 0.3521 56749.9n 0.3521 56750.0n 0.5125 56999.9n 0.5125 57000.0n 0.7980 57249.9n 0.7980 57250.0n 0.0850 57499.9n 0.0850 57500.0n 0.4461 57749.9n 0.4461 57750.0n 0.4554 57999.9n 0.4554 58000.0n 0.5374 58249.9n 0.5374 58250.0n 0.4740 58499.9n 0.4740 58500.0n 0.3262 58749.9n 0.3262 58750.0n 0.4435 58999.9n 0.4435 59000.0n 0.4606 59249.9n 0.4606 59250.0n 0.5621 59499.9n 0.5621 59500.0n 0.3457 59749.9n 0.3457 59750.0n 0.6173 59999.9n 0.6173 60000.0n 0.8055 60249.9n 0.8055 60250.0n 0.5869 60499.9n 0.5869 60500.0n 0.2263 60749.9n 0.2263 60750.0n 0.5673 60999.9n 0.5673 61000.0n 0.4612 61249.9n 0.4612 61250.0n 0.1836 61499.9n 0.1836 61500.0n 0.6245 61749.9n 0.6245 61750.0n 0.3573 61999.9n 0.3573 62000.0n 0.7722 62249.9n 0.7722 62250.0n 0.4841 62499.9n 0.4841 62500.0n 0.5250 62749.9n 0.5250 62750.0n 0.5580 62999.9n 0.5580 63000.0n 0.4382 63249.9n 0.4382 63250.0n 0.5812 63499.9n 0.5812 63500.0n 0.7486 63749.9n 0.7486 63750.0n 0.5182 63999.9n 0.5182 64000.0n 0.5815 64249.9n 0.5815 64250.0n 0.7752 64499.9n 0.7752 64500.0n 0.1140 64749.9n 0.1140 64750.0n 0.4429 64999.9n 0.4429 65000.0n 0.8015 65249.9n 0.8015 65250.0n 0.6097 65499.9n 0.6097 65500.0n 0.7543 65749.9n 0.7543 65750.0n 0.4183 65999.9n 0.4183 66000.0n 0.4006 66249.9n 0.4006 66250.0n 0.4913 66499.9n 0.4913 66500.0n 0.5157 66749.9n 0.5157 66750.0n 0.5255 66999.9n 0.5255 67000.0n 0.4913 67249.9n 0.4913 67250.0n 0.2023 67499.9n 0.2023 67500.0n 0.6060 67749.9n 0.6060 67750.0n 0.4015 67999.9n 0.4015 68000.0n 0.8405 68249.9n 0.8405 68250.0n 0.5039 68499.9n 0.5039 68500.0n 0.8146 68749.9n 0.8146 68750.0n 0.5466 68999.9n 0.5466 69000.0n 0.3864 69249.9n 0.3864 69250.0n 0.6321 69499.9n 0.6321 69500.0n 0.3947 69749.9n 0.3947 69750.0n 0.5223 69999.9n 0.5223 70000.0n 0.8149 70249.9n 0.8149 70250.0n 0.5856 70499.9n 0.5856 70500.0n 0.5694 70749.9n 0.5694 70750.0n 0.7866 70999.9n 0.7866 71000.0n 0.8639 71249.9n 0.8639 71250.0n 0.5057 71499.9n 0.5057 71500.0n 0.4961 71749.9n 0.4961 71750.0n 0.9500 71999.9n 0.9500 72000.0n 0.3486 72249.9n 0.3486 72250.0n 0.8397 72499.9n 0.8397 72500.0n 0.4392 72749.9n 0.4392 72750.0n 0.8366 72999.9n 0.8366 73000.0n 0.3489 73249.9n 0.3489 73250.0n 0.5070 73499.9n 0.5070 73500.0n 0.4018 73749.9n 0.4018 73750.0n 0.5691 73999.9n 0.5691 74000.0n 0.9465 74249.9n 0.9465 74250.0n 0.8351 74499.9n 0.8351 74500.0n 0.6202 74749.9n 0.6202 74750.0n 0.6465)
Vx2p a_xp2 0 PWL(0.0n 0.2867 249.9n 0.2867 250.0n 0.6056 499.9n 0.6056 500.0n 0.5478 749.9n 0.5478 750.0n 0.5341 999.9n 0.5341 1000.0n 0.2439 1249.9n 0.2439 1250.0n 0.3040 1499.9n 0.3040 1500.0n 0.4408 1749.9n 0.4408 1750.0n 0.2156 1999.9n 0.2156 2000.0n 0.4130 2249.9n 0.4130 2250.0n 0.3661 2499.9n 0.3661 2500.0n 0.3402 2749.9n 0.3402 2750.0n 0.5111 2999.9n 0.5111 3000.0n 0.3727 3249.9n 0.3727 3250.0n 0.5158 3499.9n 0.5158 3500.0n 0.1021 3749.9n 0.1021 3750.0n 0.8639 3999.9n 0.8639 4000.0n 0.1936 4249.9n 0.1936 4250.0n 0.4825 4499.9n 0.4825 4500.0n 0.6100 4749.9n 0.6100 4750.0n 0.5067 4999.9n 0.5067 5000.0n 0.5723 5249.9n 0.5723 5250.0n 0.5043 5499.9n 0.5043 5500.0n 0.2449 5749.9n 0.2449 5750.0n 0.4143 5999.9n 0.4143 6000.0n 0.1990 6249.9n 0.1990 6250.0n 0.5343 6499.9n 0.5343 6500.0n 0.5017 6749.9n 0.5017 6750.0n 0.4856 6999.9n 0.4856 7000.0n 0.1330 7249.9n 0.1330 7250.0n 0.2461 7499.9n 0.2461 7500.0n 0.1328 7749.9n 0.1328 7750.0n 0.5884 7999.9n 0.5884 8000.0n 0.7682 8249.9n 0.7682 8250.0n 0.1712 8499.9n 0.1712 8500.0n 0.4529 8749.9n 0.4529 8750.0n 0.5066 8999.9n 0.5066 9000.0n 0.5340 9249.9n 0.5340 9250.0n 0.4694 9499.9n 0.4694 9500.0n 0.4535 9749.9n 0.4535 9750.0n 0.8503 9999.9n 0.8503 10000.0n 0.4495 10249.9n 0.4495 10250.0n 0.8039 10499.9n 0.8039 10500.0n 0.2472 10749.9n 0.2472 10750.0n 0.5210 10999.9n 0.5210 11000.0n 0.6041 11249.9n 0.6041 11250.0n 0.4622 11499.9n 0.4622 11500.0n 0.6086 11749.9n 0.6086 11750.0n 0.1858 11999.9n 0.1858 12000.0n 0.5628 12249.9n 0.5628 12250.0n 0.2022 12499.9n 0.2022 12500.0n 0.1421 12749.9n 0.1421 12750.0n 0.5271 12999.9n 0.5271 13000.0n 0.4158 13249.9n 0.4158 13250.0n 0.6209 13499.9n 0.6209 13500.0n 0.5825 13749.9n 0.5825 13750.0n 0.6052 13999.9n 0.6052 14000.0n 0.6455 14249.9n 0.6455 14250.0n 0.2114 14499.9n 0.2114 14500.0n 0.8228 14749.9n 0.8228 14750.0n 0.6371 14999.9n 0.6371 15000.0n 0.5819 15249.9n 0.5819 15250.0n 0.5977 15499.9n 0.5977 15500.0n 0.6566 15749.9n 0.6566 15750.0n 0.3499 15999.9n 0.3499 16000.0n 0.5260 16249.9n 0.5260 16250.0n 0.3993 16499.9n 0.3993 16500.0n 0.8493 16749.9n 0.8493 16750.0n 0.4500 16999.9n 0.4500 17000.0n 0.8387 17249.9n 0.8387 17250.0n 0.6115 17499.9n 0.6115 17500.0n 0.4197 17749.9n 0.4197 17750.0n 0.3257 17999.9n 0.3257 18000.0n 0.5421 18249.9n 0.5421 18250.0n 0.4025 18499.9n 0.4025 18500.0n 0.5045 18749.9n 0.5045 18750.0n 0.5330 18999.9n 0.5330 19000.0n 0.4210 19249.9n 0.4210 19250.0n 0.4990 19499.9n 0.4990 19500.0n 0.4643 19749.9n 0.4643 19750.0n 0.5855 19999.9n 0.5855 20000.0n 0.2129 20249.9n 0.2129 20250.0n 0.5068 20499.9n 0.5068 20500.0n 0.4339 20749.9n 0.4339 20750.0n 0.4850 20999.9n 0.4850 21000.0n 0.5318 21249.9n 0.5318 21250.0n 0.1377 21499.9n 0.1377 21500.0n 0.0841 21749.9n 0.0841 21750.0n 0.4986 21999.9n 0.4986 22000.0n 0.5880 22249.9n 0.5880 22250.0n 0.1854 22499.9n 0.1854 22500.0n 0.3116 22749.9n 0.3116 22750.0n 0.4203 22999.9n 0.4203 23000.0n 0.5139 23249.9n 0.5139 23250.0n 0.1634 23499.9n 0.1634 23500.0n 0.4920 23749.9n 0.4920 23750.0n 0.4621 23999.9n 0.4621 24000.0n 0.8174 24249.9n 0.8174 24250.0n 0.4921 24499.9n 0.4921 24500.0n 0.2435 24749.9n 0.2435 24750.0n 0.4410 24999.9n 0.4410 25000.0n 0.5531 25249.9n 0.5531 25250.0n 0.6568 25499.9n 0.6568 25500.0n 0.1474 25749.9n 0.1474 25750.0n 0.4669 25999.9n 0.4669 26000.0n 0.9184 26249.9n 0.9184 26250.0n 0.4166 26499.9n 0.4166 26500.0n 0.6435 26749.9n 0.6435 26750.0n 0.4835 26999.9n 0.4835 27000.0n 0.5066 27249.9n 0.5066 27250.0n 0.0510 27499.9n 0.0510 27500.0n 0.2181 27749.9n 0.2181 27750.0n 0.5804 27999.9n 0.5804 28000.0n 0.1452 28249.9n 0.1452 28250.0n 0.5077 28499.9n 0.5077 28500.0n 0.4905 28749.9n 0.4905 28750.0n 0.4907 28999.9n 0.4907 29000.0n 0.4924 29249.9n 0.4924 29250.0n 0.5114 29499.9n 0.5114 29500.0n 0.1405 29749.9n 0.1405 29750.0n 0.5546 29999.9n 0.5546 30000.0n 0.6159 30249.9n 0.6159 30250.0n 0.6249 30499.9n 0.6249 30500.0n 0.4247 30749.9n 0.4247 30750.0n 0.4448 30999.9n 0.4448 31000.0n 0.5817 31249.9n 0.5817 31250.0n 0.8367 31499.9n 0.8367 31500.0n 0.4881 31749.9n 0.4881 31750.0n 0.5250 31999.9n 0.5250 32000.0n 0.7534 32249.9n 0.7534 32250.0n 0.6067 32499.9n 0.6067 32500.0n 0.4548 32749.9n 0.4548 32750.0n 0.4664 32999.9n 0.4664 33000.0n 0.3529 33249.9n 0.3529 33250.0n 0.4696 33499.9n 0.4696 33500.0n 0.5725 33749.9n 0.5725 33750.0n 0.5290 33999.9n 0.5290 34000.0n 0.2221 34249.9n 0.2221 34250.0n 0.4301 34499.9n 0.4301 34500.0n 0.4220 34749.9n 0.4220 34750.0n 0.5641 34999.9n 0.5641 35000.0n 0.5018 35249.9n 0.5018 35250.0n 0.3372 35499.9n 0.3372 35500.0n 0.4906 35749.9n 0.4906 35750.0n 0.5532 35999.9n 0.5532 36000.0n 0.6705 36249.9n 0.6705 36250.0n 0.3331 36499.9n 0.3331 36500.0n 0.6236 36749.9n 0.6236 36750.0n 0.4287 36999.9n 0.4287 37000.0n 0.6874 37249.9n 0.6874 37250.0n 0.4561 37499.9n 0.4561 37500.0n 0.5589 37749.9n 0.5589 37750.0n 0.7085 37999.9n 0.7085 38000.0n 0.2200 38249.9n 0.2200 38250.0n 0.5654 38499.9n 0.5654 38500.0n 0.5075 38749.9n 0.5075 38750.0n 0.5515 38999.9n 0.5515 39000.0n 0.5060 39249.9n 0.5060 39250.0n 0.6474 39499.9n 0.6474 39500.0n 0.5567 39749.9n 0.5567 39750.0n 0.1268 39999.9n 0.1268 40000.0n 0.1685 40249.9n 0.1685 40250.0n 0.5119 40499.9n 0.5119 40500.0n 0.4482 40749.9n 0.4482 40750.0n 0.4611 40999.9n 0.4611 41000.0n 0.7008 41249.9n 0.7008 41250.0n 0.3395 41499.9n 0.3395 41500.0n 0.7704 41749.9n 0.7704 41750.0n 0.3839 41999.9n 0.3839 42000.0n 0.8817 42249.9n 0.8817 42250.0n 0.4818 42499.9n 0.4818 42500.0n 0.8522 42749.9n 0.8522 42750.0n 0.3906 42999.9n 0.3906 43000.0n 0.7887 43249.9n 0.7887 43250.0n 0.5019 43499.9n 0.5019 43500.0n 0.6096 43749.9n 0.6096 43750.0n 0.3803 43999.9n 0.3803 44000.0n 0.6225 44249.9n 0.6225 44250.0n 0.7898 44499.9n 0.7898 44500.0n 0.2769 44749.9n 0.2769 44750.0n 0.5018 44999.9n 0.5018 45000.0n 0.5223 45249.9n 0.5223 45250.0n 0.1701 45499.9n 0.1701 45500.0n 0.6533 45749.9n 0.6533 45750.0n 0.5795 45999.9n 0.5795 46000.0n 0.5096 46249.9n 0.5096 46250.0n 0.5141 46499.9n 0.5141 46500.0n 0.3540 46749.9n 0.3540 46750.0n 0.6399 46999.9n 0.6399 47000.0n 0.4995 47249.9n 0.4995 47250.0n 0.1728 47499.9n 0.1728 47500.0n 0.4957 47749.9n 0.4957 47750.0n 0.3594 47999.9n 0.3594 48000.0n 0.6177 48249.9n 0.6177 48250.0n 0.1072 48499.9n 0.1072 48500.0n 0.3239 48749.9n 0.3239 48750.0n 0.5585 48999.9n 0.5585 49000.0n 0.5100 49249.9n 0.5100 49250.0n 0.4477 49499.9n 0.4477 49500.0n 0.4816 49749.9n 0.4816 49750.0n 0.5363 49999.9n 0.5363 50000.0n 0.2164 50249.9n 0.2164 50250.0n 0.7663 50499.9n 0.7663 50500.0n 0.5603 50749.9n 0.5603 50750.0n 0.5938 50999.9n 0.5938 51000.0n 0.4899 51249.9n 0.4899 51250.0n 0.4085 51499.9n 0.4085 51500.0n 0.3823 51749.9n 0.3823 51750.0n 0.7841 51999.9n 0.7841 52000.0n 0.4878 52249.9n 0.4878 52250.0n 0.5330 52499.9n 0.5330 52500.0n 0.4502 52749.9n 0.4502 52750.0n 0.5050 52999.9n 0.5050 53000.0n 0.0685 53249.9n 0.0685 53250.0n 0.5339 53499.9n 0.5339 53500.0n 0.5880 53749.9n 0.5880 53750.0n 0.5514 53999.9n 0.5514 54000.0n 0.9168 54249.9n 0.9168 54250.0n 0.7020 54499.9n 0.7020 54500.0n 0.1973 54749.9n 0.1973 54750.0n 0.5466 54999.9n 0.5466 55000.0n 0.4754 55249.9n 0.4754 55250.0n 0.3792 55499.9n 0.3792 55500.0n 0.5330 55749.9n 0.5330 55750.0n 0.6848 55999.9n 0.6848 56000.0n 0.2125 56249.9n 0.2125 56250.0n 0.3074 56499.9n 0.3074 56500.0n 0.4501 56749.9n 0.4501 56750.0n 0.5120 56999.9n 0.5120 57000.0n 0.3498 57249.9n 0.3498 57250.0n 0.3180 57499.9n 0.3180 57500.0n 0.5214 57749.9n 0.5214 57750.0n 0.4969 57999.9n 0.4969 58000.0n 0.5141 58249.9n 0.5141 58250.0n 0.4620 58499.9n 0.4620 58500.0n 0.8209 58749.9n 0.8209 58750.0n 0.4782 58999.9n 0.4782 59000.0n 0.2206 59249.9n 0.2206 59250.0n 0.4205 59499.9n 0.4205 59500.0n 0.8091 59749.9n 0.8091 59750.0n 0.5510 59999.9n 0.5510 60000.0n 0.3225 60249.9n 0.3225 60250.0n 0.5635 60499.9n 0.5635 60500.0n 0.2805 60749.9n 0.2805 60750.0n 0.4832 60999.9n 0.4832 61000.0n 0.5314 61249.9n 0.5314 61250.0n 0.1819 61499.9n 0.1819 61500.0n 0.8042 61749.9n 0.8042 61750.0n 0.7805 61999.9n 0.7805 62000.0n 0.1646 62249.9n 0.1646 62250.0n 0.4513 62499.9n 0.4513 62500.0n 0.5858 62749.9n 0.5858 62750.0n 0.5086 62999.9n 0.5086 63000.0n 0.4907 63249.9n 0.4907 63250.0n 0.5340 63499.9n 0.5340 63500.0n 0.7574 63749.9n 0.7574 63750.0n 0.4996 63999.9n 0.4996 64000.0n 0.2215 64249.9n 0.2215 64250.0n 0.1592 64499.9n 0.1592 64500.0n 0.5877 64749.9n 0.5877 64750.0n 0.4797 64999.9n 0.4797 65000.0n 0.5844 65249.9n 0.5844 65250.0n 0.1436 65499.9n 0.1436 65500.0n 0.3239 65749.9n 0.3239 65750.0n 0.6493 65999.9n 0.6493 66000.0n 0.5008 66249.9n 0.5008 66250.0n 0.4500 66499.9n 0.4500 66500.0n 0.4822 66749.9n 0.4822 66750.0n 0.6777 66999.9n 0.6777 67000.0n 0.5379 67249.9n 0.5379 67250.0n 0.6968 67499.9n 0.6968 67500.0n 0.4653 67749.9n 0.4653 67750.0n 0.9197 67999.9n 0.9197 68000.0n 0.6886 68249.9n 0.6886 68250.0n 0.5013 68499.9n 0.5013 68500.0n 0.2560 68749.9n 0.2560 68750.0n 0.5994 68999.9n 0.5994 69000.0n 0.5828 69249.9n 0.5828 69250.0n 0.8421 69499.9n 0.8421 69500.0n 0.8258 69749.9n 0.8258 69750.0n 0.4989 69999.9n 0.4989 70000.0n 0.6708 70249.9n 0.6708 70250.0n 0.6054 70499.9n 0.6054 70500.0n 0.5615 70749.9n 0.5615 70750.0n 0.6905 70999.9n 0.6905 71000.0n 0.6860 71249.9n 0.6860 71250.0n 0.5074 71499.9n 0.5074 71500.0n 0.3712 71749.9n 0.3712 71750.0n 0.4202 71999.9n 0.4202 72000.0n 0.5155 72249.9n 0.5155 72250.0n 0.7175 72499.9n 0.7175 72500.0n 0.9186 72749.9n 0.9186 72750.0n 0.2746 72999.9n 0.2746 73000.0n 0.2551 73249.9n 0.2551 73250.0n 0.4334 73499.9n 0.4334 73500.0n 0.6051 73749.9n 0.6051 73750.0n 0.5041 73999.9n 0.5041 74000.0n 0.6027 74249.9n 0.6027 74250.0n 0.6377 74499.9n 0.6377 74500.0n 0.6307 74749.9n 0.6307 74750.0n 0.1618)
Vx2n a_xn2 0 PWL(0.0n 0.7133 249.9n 0.7133 250.0n 0.3944 499.9n 0.3944 500.0n 0.4522 749.9n 0.4522 750.0n 0.4659 999.9n 0.4659 1000.0n 0.7561 1249.9n 0.7561 1250.0n 0.6960 1499.9n 0.6960 1500.0n 0.5592 1749.9n 0.5592 1750.0n 0.7844 1999.9n 0.7844 2000.0n 0.5870 2249.9n 0.5870 2250.0n 0.6339 2499.9n 0.6339 2500.0n 0.6598 2749.9n 0.6598 2750.0n 0.4889 2999.9n 0.4889 3000.0n 0.6273 3249.9n 0.6273 3250.0n 0.4842 3499.9n 0.4842 3500.0n 0.8979 3749.9n 0.8979 3750.0n 0.1361 3999.9n 0.1361 4000.0n 0.8064 4249.9n 0.8064 4250.0n 0.5175 4499.9n 0.5175 4500.0n 0.3900 4749.9n 0.3900 4750.0n 0.4933 4999.9n 0.4933 5000.0n 0.4277 5249.9n 0.4277 5250.0n 0.4957 5499.9n 0.4957 5500.0n 0.7551 5749.9n 0.7551 5750.0n 0.5857 5999.9n 0.5857 6000.0n 0.8010 6249.9n 0.8010 6250.0n 0.4657 6499.9n 0.4657 6500.0n 0.4983 6749.9n 0.4983 6750.0n 0.5144 6999.9n 0.5144 7000.0n 0.8670 7249.9n 0.8670 7250.0n 0.7539 7499.9n 0.7539 7500.0n 0.8672 7749.9n 0.8672 7750.0n 0.4116 7999.9n 0.4116 8000.0n 0.2318 8249.9n 0.2318 8250.0n 0.8288 8499.9n 0.8288 8500.0n 0.5471 8749.9n 0.5471 8750.0n 0.4934 8999.9n 0.4934 9000.0n 0.4660 9249.9n 0.4660 9250.0n 0.5306 9499.9n 0.5306 9500.0n 0.5465 9749.9n 0.5465 9750.0n 0.1497 9999.9n 0.1497 10000.0n 0.5505 10249.9n 0.5505 10250.0n 0.1961 10499.9n 0.1961 10500.0n 0.7528 10749.9n 0.7528 10750.0n 0.4790 10999.9n 0.4790 11000.0n 0.3959 11249.9n 0.3959 11250.0n 0.5378 11499.9n 0.5378 11500.0n 0.3914 11749.9n 0.3914 11750.0n 0.8142 11999.9n 0.8142 12000.0n 0.4372 12249.9n 0.4372 12250.0n 0.7978 12499.9n 0.7978 12500.0n 0.8579 12749.9n 0.8579 12750.0n 0.4729 12999.9n 0.4729 13000.0n 0.5842 13249.9n 0.5842 13250.0n 0.3791 13499.9n 0.3791 13500.0n 0.4175 13749.9n 0.4175 13750.0n 0.3948 13999.9n 0.3948 14000.0n 0.3545 14249.9n 0.3545 14250.0n 0.7886 14499.9n 0.7886 14500.0n 0.1772 14749.9n 0.1772 14750.0n 0.3629 14999.9n 0.3629 15000.0n 0.4181 15249.9n 0.4181 15250.0n 0.4023 15499.9n 0.4023 15500.0n 0.3434 15749.9n 0.3434 15750.0n 0.6501 15999.9n 0.6501 16000.0n 0.4740 16249.9n 0.4740 16250.0n 0.6007 16499.9n 0.6007 16500.0n 0.1507 16749.9n 0.1507 16750.0n 0.5500 16999.9n 0.5500 17000.0n 0.1613 17249.9n 0.1613 17250.0n 0.3885 17499.9n 0.3885 17500.0n 0.5803 17749.9n 0.5803 17750.0n 0.6743 17999.9n 0.6743 18000.0n 0.4579 18249.9n 0.4579 18250.0n 0.5975 18499.9n 0.5975 18500.0n 0.4955 18749.9n 0.4955 18750.0n 0.4670 18999.9n 0.4670 19000.0n 0.5790 19249.9n 0.5790 19250.0n 0.5010 19499.9n 0.5010 19500.0n 0.5357 19749.9n 0.5357 19750.0n 0.4145 19999.9n 0.4145 20000.0n 0.7871 20249.9n 0.7871 20250.0n 0.4932 20499.9n 0.4932 20500.0n 0.5661 20749.9n 0.5661 20750.0n 0.5150 20999.9n 0.5150 21000.0n 0.4682 21249.9n 0.4682 21250.0n 0.8623 21499.9n 0.8623 21500.0n 0.9159 21749.9n 0.9159 21750.0n 0.5014 21999.9n 0.5014 22000.0n 0.4120 22249.9n 0.4120 22250.0n 0.8146 22499.9n 0.8146 22500.0n 0.6884 22749.9n 0.6884 22750.0n 0.5797 22999.9n 0.5797 23000.0n 0.4861 23249.9n 0.4861 23250.0n 0.8366 23499.9n 0.8366 23500.0n 0.5080 23749.9n 0.5080 23750.0n 0.5379 23999.9n 0.5379 24000.0n 0.1826 24249.9n 0.1826 24250.0n 0.5079 24499.9n 0.5079 24500.0n 0.7565 24749.9n 0.7565 24750.0n 0.5590 24999.9n 0.5590 25000.0n 0.4469 25249.9n 0.4469 25250.0n 0.3432 25499.9n 0.3432 25500.0n 0.8526 25749.9n 0.8526 25750.0n 0.5331 25999.9n 0.5331 26000.0n 0.0816 26249.9n 0.0816 26250.0n 0.5834 26499.9n 0.5834 26500.0n 0.3565 26749.9n 0.3565 26750.0n 0.5165 26999.9n 0.5165 27000.0n 0.4934 27249.9n 0.4934 27250.0n 0.9490 27499.9n 0.9490 27500.0n 0.7819 27749.9n 0.7819 27750.0n 0.4196 27999.9n 0.4196 28000.0n 0.8548 28249.9n 0.8548 28250.0n 0.4923 28499.9n 0.4923 28500.0n 0.5095 28749.9n 0.5095 28750.0n 0.5093 28999.9n 0.5093 29000.0n 0.5076 29249.9n 0.5076 29250.0n 0.4886 29499.9n 0.4886 29500.0n 0.8595 29749.9n 0.8595 29750.0n 0.4454 29999.9n 0.4454 30000.0n 0.3841 30249.9n 0.3841 30250.0n 0.3751 30499.9n 0.3751 30500.0n 0.5753 30749.9n 0.5753 30750.0n 0.5552 30999.9n 0.5552 31000.0n 0.4183 31249.9n 0.4183 31250.0n 0.1633 31499.9n 0.1633 31500.0n 0.5119 31749.9n 0.5119 31750.0n 0.4750 31999.9n 0.4750 32000.0n 0.2466 32249.9n 0.2466 32250.0n 0.3933 32499.9n 0.3933 32500.0n 0.5452 32749.9n 0.5452 32750.0n 0.5336 32999.9n 0.5336 33000.0n 0.6471 33249.9n 0.6471 33250.0n 0.5304 33499.9n 0.5304 33500.0n 0.4275 33749.9n 0.4275 33750.0n 0.4710 33999.9n 0.4710 34000.0n 0.7779 34249.9n 0.7779 34250.0n 0.5699 34499.9n 0.5699 34500.0n 0.5780 34749.9n 0.5780 34750.0n 0.4359 34999.9n 0.4359 35000.0n 0.4982 35249.9n 0.4982 35250.0n 0.6628 35499.9n 0.6628 35500.0n 0.5094 35749.9n 0.5094 35750.0n 0.4468 35999.9n 0.4468 36000.0n 0.3295 36249.9n 0.3295 36250.0n 0.6669 36499.9n 0.6669 36500.0n 0.3764 36749.9n 0.3764 36750.0n 0.5713 36999.9n 0.5713 37000.0n 0.3126 37249.9n 0.3126 37250.0n 0.5439 37499.9n 0.5439 37500.0n 0.4411 37749.9n 0.4411 37750.0n 0.2915 37999.9n 0.2915 38000.0n 0.7800 38249.9n 0.7800 38250.0n 0.4346 38499.9n 0.4346 38500.0n 0.4925 38749.9n 0.4925 38750.0n 0.4485 38999.9n 0.4485 39000.0n 0.4940 39249.9n 0.4940 39250.0n 0.3526 39499.9n 0.3526 39500.0n 0.4433 39749.9n 0.4433 39750.0n 0.8732 39999.9n 0.8732 40000.0n 0.8315 40249.9n 0.8315 40250.0n 0.4881 40499.9n 0.4881 40500.0n 0.5518 40749.9n 0.5518 40750.0n 0.5389 40999.9n 0.5389 41000.0n 0.2992 41249.9n 0.2992 41250.0n 0.6605 41499.9n 0.6605 41500.0n 0.2296 41749.9n 0.2296 41750.0n 0.6161 41999.9n 0.6161 42000.0n 0.1183 42249.9n 0.1183 42250.0n 0.5182 42499.9n 0.5182 42500.0n 0.1478 42749.9n 0.1478 42750.0n 0.6094 42999.9n 0.6094 43000.0n 0.2113 43249.9n 0.2113 43250.0n 0.4981 43499.9n 0.4981 43500.0n 0.3904 43749.9n 0.3904 43750.0n 0.6197 43999.9n 0.6197 44000.0n 0.3775 44249.9n 0.3775 44250.0n 0.2102 44499.9n 0.2102 44500.0n 0.7231 44749.9n 0.7231 44750.0n 0.4982 44999.9n 0.4982 45000.0n 0.4777 45249.9n 0.4777 45250.0n 0.8299 45499.9n 0.8299 45500.0n 0.3467 45749.9n 0.3467 45750.0n 0.4205 45999.9n 0.4205 46000.0n 0.4904 46249.9n 0.4904 46250.0n 0.4859 46499.9n 0.4859 46500.0n 0.6460 46749.9n 0.6460 46750.0n 0.3601 46999.9n 0.3601 47000.0n 0.5005 47249.9n 0.5005 47250.0n 0.8272 47499.9n 0.8272 47500.0n 0.5043 47749.9n 0.5043 47750.0n 0.6406 47999.9n 0.6406 48000.0n 0.3823 48249.9n 0.3823 48250.0n 0.8928 48499.9n 0.8928 48500.0n 0.6761 48749.9n 0.6761 48750.0n 0.4415 48999.9n 0.4415 49000.0n 0.4900 49249.9n 0.4900 49250.0n 0.5523 49499.9n 0.5523 49500.0n 0.5184 49749.9n 0.5184 49750.0n 0.4637 49999.9n 0.4637 50000.0n 0.7836 50249.9n 0.7836 50250.0n 0.2337 50499.9n 0.2337 50500.0n 0.4397 50749.9n 0.4397 50750.0n 0.4062 50999.9n 0.4062 51000.0n 0.5101 51249.9n 0.5101 51250.0n 0.5915 51499.9n 0.5915 51500.0n 0.6177 51749.9n 0.6177 51750.0n 0.2159 51999.9n 0.2159 52000.0n 0.5122 52249.9n 0.5122 52250.0n 0.4670 52499.9n 0.4670 52500.0n 0.5498 52749.9n 0.5498 52750.0n 0.4950 52999.9n 0.4950 53000.0n 0.9315 53249.9n 0.9315 53250.0n 0.4661 53499.9n 0.4661 53500.0n 0.4120 53749.9n 0.4120 53750.0n 0.4486 53999.9n 0.4486 54000.0n 0.0832 54249.9n 0.0832 54250.0n 0.2980 54499.9n 0.2980 54500.0n 0.8027 54749.9n 0.8027 54750.0n 0.4534 54999.9n 0.4534 55000.0n 0.5246 55249.9n 0.5246 55250.0n 0.6208 55499.9n 0.6208 55500.0n 0.4670 55749.9n 0.4670 55750.0n 0.3152 55999.9n 0.3152 56000.0n 0.7875 56249.9n 0.7875 56250.0n 0.6926 56499.9n 0.6926 56500.0n 0.5499 56749.9n 0.5499 56750.0n 0.4880 56999.9n 0.4880 57000.0n 0.6502 57249.9n 0.6502 57250.0n 0.6820 57499.9n 0.6820 57500.0n 0.4786 57749.9n 0.4786 57750.0n 0.5031 57999.9n 0.5031 58000.0n 0.4859 58249.9n 0.4859 58250.0n 0.5380 58499.9n 0.5380 58500.0n 0.1791 58749.9n 0.1791 58750.0n 0.5218 58999.9n 0.5218 59000.0n 0.7794 59249.9n 0.7794 59250.0n 0.5795 59499.9n 0.5795 59500.0n 0.1909 59749.9n 0.1909 59750.0n 0.4490 59999.9n 0.4490 60000.0n 0.6775 60249.9n 0.6775 60250.0n 0.4365 60499.9n 0.4365 60500.0n 0.7195 60749.9n 0.7195 60750.0n 0.5168 60999.9n 0.5168 61000.0n 0.4686 61249.9n 0.4686 61250.0n 0.8181 61499.9n 0.8181 61500.0n 0.1958 61749.9n 0.1958 61750.0n 0.2195 61999.9n 0.2195 62000.0n 0.8354 62249.9n 0.8354 62250.0n 0.5487 62499.9n 0.5487 62500.0n 0.4142 62749.9n 0.4142 62750.0n 0.4914 62999.9n 0.4914 63000.0n 0.5093 63249.9n 0.5093 63250.0n 0.4660 63499.9n 0.4660 63500.0n 0.2426 63749.9n 0.2426 63750.0n 0.5004 63999.9n 0.5004 64000.0n 0.7785 64249.9n 0.7785 64250.0n 0.8408 64499.9n 0.8408 64500.0n 0.4123 64749.9n 0.4123 64750.0n 0.5203 64999.9n 0.5203 65000.0n 0.4156 65249.9n 0.4156 65250.0n 0.8564 65499.9n 0.8564 65500.0n 0.6761 65749.9n 0.6761 65750.0n 0.3507 65999.9n 0.3507 66000.0n 0.4992 66249.9n 0.4992 66250.0n 0.5500 66499.9n 0.5500 66500.0n 0.5178 66749.9n 0.5178 66750.0n 0.3223 66999.9n 0.3223 67000.0n 0.4621 67249.9n 0.4621 67250.0n 0.3032 67499.9n 0.3032 67500.0n 0.5347 67749.9n 0.5347 67750.0n 0.0803 67999.9n 0.0803 68000.0n 0.3114 68249.9n 0.3114 68250.0n 0.4987 68499.9n 0.4987 68500.0n 0.7440 68749.9n 0.7440 68750.0n 0.4006 68999.9n 0.4006 69000.0n 0.4172 69249.9n 0.4172 69250.0n 0.1579 69499.9n 0.1579 69500.0n 0.1742 69749.9n 0.1742 69750.0n 0.5011 69999.9n 0.5011 70000.0n 0.3292 70249.9n 0.3292 70250.0n 0.3946 70499.9n 0.3946 70500.0n 0.4385 70749.9n 0.4385 70750.0n 0.3095 70999.9n 0.3095 71000.0n 0.3140 71249.9n 0.3140 71250.0n 0.4926 71499.9n 0.4926 71500.0n 0.6288 71749.9n 0.6288 71750.0n 0.5798 71999.9n 0.5798 72000.0n 0.4845 72249.9n 0.4845 72250.0n 0.2825 72499.9n 0.2825 72500.0n 0.0814 72749.9n 0.0814 72750.0n 0.7254 72999.9n 0.7254 73000.0n 0.7449 73249.9n 0.7449 73250.0n 0.5666 73499.9n 0.5666 73500.0n 0.3949 73749.9n 0.3949 73750.0n 0.4959 73999.9n 0.4959 74000.0n 0.3973 74249.9n 0.3973 74250.0n 0.3623 74499.9n 0.3623 74500.0n 0.3693 74749.9n 0.3693 74750.0n 0.8382)
Vx3p a_xp3 0 0.9500
Vx3n a_xn3 0 0.0500
Vxop xop 0 PWL(0.0n 0.5000 249.9n 0.5000 250.0n 0.5000 499.9n 0.5000 500.0n 0.5000 749.9n 0.5000 750.0n 0.5000 999.9n 0.5000 1000.0n 0.5000 1249.9n 0.5000 1250.0n 0.5000 1499.9n 0.5000 1500.0n 0.5000 1749.9n 0.5000 1750.0n 0.5000 1999.9n 0.5000 2000.0n 0.5000 2249.9n 0.5000 2250.0n 0.5000 2499.9n 0.5000 2500.0n 0.5000 2749.9n 0.5000 2750.0n 0.5000 2999.9n 0.5000 3000.0n 0.5000 3249.9n 0.5000 3250.0n 0.5000 3499.9n 0.5000 3500.0n 0.5000 3749.9n 0.5000 3750.0n 0.5000 3999.9n 0.5000 4000.0n 0.5000 4249.9n 0.5000 4250.0n 0.5000 4499.9n 0.5000 4500.0n 0.5000 4749.9n 0.5000 4750.0n 0.5000 4999.9n 0.5000 5000.0n 0.5000 5249.9n 0.5000 5250.0n 0.5000 5499.9n 0.5000 5500.0n 0.5000 5749.9n 0.5000 5750.0n 0.5000 5999.9n 0.5000 6000.0n 0.5000 6249.9n 0.5000 6250.0n 0.5000 6499.9n 0.5000 6500.0n 0.5000 6749.9n 0.5000 6750.0n 0.5000 6999.9n 0.5000 7000.0n 0.5000 7249.9n 0.5000 7250.0n 0.5000 7499.9n 0.5000 7500.0n 0.5000 7749.9n 0.5000 7750.0n 0.5000 7999.9n 0.5000 8000.0n 0.5000 8249.9n 0.5000 8250.0n 0.5000 8499.9n 0.5000 8500.0n 0.5000 8749.9n 0.5000 8750.0n 0.5000 8999.9n 0.5000 9000.0n 0.5000 9249.9n 0.5000 9250.0n 0.5000 9499.9n 0.5000 9500.0n 0.5000 9749.9n 0.5000 9750.0n 0.5000 9999.9n 0.5000 10000.0n 0.5000 10249.9n 0.5000 10250.0n 0.5000 10499.9n 0.5000 10500.0n 0.5000 10749.9n 0.5000 10750.0n 0.5000 10999.9n 0.5000 11000.0n 0.5000 11249.9n 0.5000 11250.0n 0.5000 11499.9n 0.5000 11500.0n 0.5000 11749.9n 0.5000 11750.0n 0.5000 11999.9n 0.5000 12000.0n 0.5000 12249.9n 0.5000 12250.0n 0.5000 12499.9n 0.5000 12500.0n 0.5000 12749.9n 0.5000 12750.0n 0.5000 12999.9n 0.5000 13000.0n 0.5000 13249.9n 0.5000 13250.0n 0.5000 13499.9n 0.5000 13500.0n 0.5000 13749.9n 0.5000 13750.0n 0.5000 13999.9n 0.5000 14000.0n 0.5000 14249.9n 0.5000 14250.0n 0.5000 14499.9n 0.5000 14500.0n 0.5000 14749.9n 0.5000 14750.0n 0.5000 14999.9n 0.5000 15000.0n 0.5000 15249.9n 0.5000 15250.0n 0.5000 15499.9n 0.5000 15500.0n 0.5000 15749.9n 0.5000 15750.0n 0.5000 15999.9n 0.5000 16000.0n 0.5000 16249.9n 0.5000 16250.0n 0.5000 16499.9n 0.5000 16500.0n 0.5000 16749.9n 0.5000 16750.0n 0.5000 16999.9n 0.5000 17000.0n 0.5000 17249.9n 0.5000 17250.0n 0.5000 17499.9n 0.5000 17500.0n 0.5000 17749.9n 0.5000 17750.0n 0.5000 17999.9n 0.5000 18000.0n 0.5000 18249.9n 0.5000 18250.0n 0.5000 18499.9n 0.5000 18500.0n 0.5000 18749.9n 0.5000 18750.0n 0.5000 18999.9n 0.5000 19000.0n 0.5000 19249.9n 0.5000 19250.0n 0.5000 19499.9n 0.5000 19500.0n 0.5000 19749.9n 0.5000 19750.0n 0.5000 19999.9n 0.5000 20000.0n 0.5000 20249.9n 0.5000 20250.0n 0.5000 20499.9n 0.5000 20500.0n 0.5000 20749.9n 0.5000 20750.0n 0.5000 20999.9n 0.5000 21000.0n 0.5000 21249.9n 0.5000 21250.0n 0.5000 21499.9n 0.5000 21500.0n 0.5000 21749.9n 0.5000 21750.0n 0.5000 21999.9n 0.5000 22000.0n 0.5000 22249.9n 0.5000 22250.0n 0.5000 22499.9n 0.5000 22500.0n 0.5000 22749.9n 0.5000 22750.0n 0.5000 22999.9n 0.5000 23000.0n 0.5000 23249.9n 0.5000 23250.0n 0.5000 23499.9n 0.5000 23500.0n 0.5000 23749.9n 0.5000 23750.0n 0.5000 23999.9n 0.5000 24000.0n 0.5000 24249.9n 0.5000 24250.0n 0.5000 24499.9n 0.5000 24500.0n 0.5000 24749.9n 0.5000 24750.0n 0.5000 24999.9n 0.5000 25000.0n 0.5000 25249.9n 0.5000 25250.0n 0.5000 25499.9n 0.5000 25500.0n 0.5000 25749.9n 0.5000 25750.0n 0.5000 25999.9n 0.5000 26000.0n 0.5000 26249.9n 0.5000 26250.0n 0.5000 26499.9n 0.5000 26500.0n 0.5000 26749.9n 0.5000 26750.0n 0.5000 26999.9n 0.5000 27000.0n 0.5000 27249.9n 0.5000 27250.0n 0.5000 27499.9n 0.5000 27500.0n 0.5000 27749.9n 0.5000 27750.0n 0.5000 27999.9n 0.5000 28000.0n 0.5000 28249.9n 0.5000 28250.0n 0.5000 28499.9n 0.5000 28500.0n 0.5000 28749.9n 0.5000 28750.0n 0.5000 28999.9n 0.5000 29000.0n 0.5000 29249.9n 0.5000 29250.0n 0.5000 29499.9n 0.5000 29500.0n 0.5000 29749.9n 0.5000 29750.0n 0.5000 29999.9n 0.5000 30000.0n 0.5000 30249.9n 0.5000 30250.0n 0.5000 30499.9n 0.5000 30500.0n 0.5000 30749.9n 0.5000 30750.0n 0.5000 30999.9n 0.5000 31000.0n 0.5000 31249.9n 0.5000 31250.0n 0.5000 31499.9n 0.5000 31500.0n 0.5000 31749.9n 0.5000 31750.0n 0.5000 31999.9n 0.5000 32000.0n 0.5000 32249.9n 0.5000 32250.0n 0.5000 32499.9n 0.5000 32500.0n 0.5000 32749.9n 0.5000 32750.0n 0.5000 32999.9n 0.5000 33000.0n 0.5000 33249.9n 0.5000 33250.0n 0.5000 33499.9n 0.5000 33500.0n 0.5000 33749.9n 0.5000 33750.0n 0.5000 33999.9n 0.5000 34000.0n 0.5000 34249.9n 0.5000 34250.0n 0.5000 34499.9n 0.5000 34500.0n 0.5000 34749.9n 0.5000 34750.0n 0.5000 34999.9n 0.5000 35000.0n 0.5000 35249.9n 0.5000 35250.0n 0.5000 35499.9n 0.5000 35500.0n 0.5000 35749.9n 0.5000 35750.0n 0.5000 35999.9n 0.5000 36000.0n 0.5000 36249.9n 0.5000 36250.0n 0.5000 36499.9n 0.5000 36500.0n 0.5000 36749.9n 0.5000 36750.0n 0.5000 36999.9n 0.5000 37000.0n 0.5000 37249.9n 0.5000 37250.0n 0.5000 37499.9n 0.5000 37500.0n 0.5000 37749.9n 0.5000 37750.0n 0.5000 37999.9n 0.5000 38000.0n 0.5000 38249.9n 0.5000 38250.0n 0.5000 38499.9n 0.5000 38500.0n 0.5000 38749.9n 0.5000 38750.0n 0.5000 38999.9n 0.5000 39000.0n 0.5000 39249.9n 0.5000 39250.0n 0.5000 39499.9n 0.5000 39500.0n 0.5000 39749.9n 0.5000 39750.0n 0.5000 39999.9n 0.5000 40000.0n 0.5000 40249.9n 0.5000 40250.0n 0.5000 40499.9n 0.5000 40500.0n 0.5000 40749.9n 0.5000 40750.0n 0.5000 40999.9n 0.5000 41000.0n 0.5000 41249.9n 0.5000 41250.0n 0.5000 41499.9n 0.5000 41500.0n 0.5000 41749.9n 0.5000 41750.0n 0.5000 41999.9n 0.5000 42000.0n 0.5000 42249.9n 0.5000 42250.0n 0.5000 42499.9n 0.5000 42500.0n 0.5000 42749.9n 0.5000 42750.0n 0.5000 42999.9n 0.5000 43000.0n 0.5000 43249.9n 0.5000 43250.0n 0.5000 43499.9n 0.5000 43500.0n 0.5000 43749.9n 0.5000 43750.0n 0.5000 43999.9n 0.5000 44000.0n 0.5000 44249.9n 0.5000 44250.0n 0.5000 44499.9n 0.5000 44500.0n 0.5000 44749.9n 0.5000 44750.0n 0.5000 44999.9n 0.5000 45000.0n 0.5000 45249.9n 0.5000 45250.0n 0.5000 45499.9n 0.5000 45500.0n 0.5000 45749.9n 0.5000 45750.0n 0.5000 45999.9n 0.5000 46000.0n 0.5000 46249.9n 0.5000 46250.0n 0.5000 46499.9n 0.5000 46500.0n 0.5000 46749.9n 0.5000 46750.0n 0.5000 46999.9n 0.5000 47000.0n 0.5000 47249.9n 0.5000 47250.0n 0.5000 47499.9n 0.5000 47500.0n 0.5000 47749.9n 0.5000 47750.0n 0.5000 47999.9n 0.5000 48000.0n 0.5000 48249.9n 0.5000 48250.0n 0.5000 48499.9n 0.5000 48500.0n 0.5000 48749.9n 0.5000 48750.0n 0.5000 48999.9n 0.5000 49000.0n 0.5000 49249.9n 0.5000 49250.0n 0.5000 49499.9n 0.5000 49500.0n 0.5000 49749.9n 0.5000 49750.0n 0.5000 49999.9n 0.5000 50000.0n 0.5000 50249.9n 0.5000 50250.0n 0.5000 50499.9n 0.5000 50500.0n 0.5000 50749.9n 0.5000 50750.0n 0.5000 50999.9n 0.5000 51000.0n 0.5000 51249.9n 0.5000 51250.0n 0.5000 51499.9n 0.5000 51500.0n 0.5000 51749.9n 0.5000 51750.0n 0.5000 51999.9n 0.5000 52000.0n 0.5000 52249.9n 0.5000 52250.0n 0.5000 52499.9n 0.5000 52500.0n 0.5000 52749.9n 0.5000 52750.0n 0.5000 52999.9n 0.5000 53000.0n 0.5000 53249.9n 0.5000 53250.0n 0.5000 53499.9n 0.5000 53500.0n 0.5000 53749.9n 0.5000 53750.0n 0.5000 53999.9n 0.5000 54000.0n 0.5000 54249.9n 0.5000 54250.0n 0.5000 54499.9n 0.5000 54500.0n 0.5000 54749.9n 0.5000 54750.0n 0.5000 54999.9n 0.5000 55000.0n 0.5000 55249.9n 0.5000 55250.0n 0.5000 55499.9n 0.5000 55500.0n 0.5000 55749.9n 0.5000 55750.0n 0.5000 55999.9n 0.5000 56000.0n 0.5000 56249.9n 0.5000 56250.0n 0.5000 56499.9n 0.5000 56500.0n 0.5000 56749.9n 0.5000 56750.0n 0.5000 56999.9n 0.5000 57000.0n 0.5000 57249.9n 0.5000 57250.0n 0.5000 57499.9n 0.5000 57500.0n 0.5000 57749.9n 0.5000 57750.0n 0.5000 57999.9n 0.5000 58000.0n 0.5000 58249.9n 0.5000 58250.0n 0.5000 58499.9n 0.5000 58500.0n 0.5000 58749.9n 0.5000 58750.0n 0.5000 58999.9n 0.5000 59000.0n 0.5000 59249.9n 0.5000 59250.0n 0.5000 59499.9n 0.5000 59500.0n 0.5000 59749.9n 0.5000 59750.0n 0.5000 59999.9n 0.5000 60000.0n 0.5000 60249.9n 0.5000 60250.0n 0.5000 60499.9n 0.5000 60500.0n 0.5000 60749.9n 0.5000 60750.0n 0.5000 60999.9n 0.5000 61000.0n 0.5000 61249.9n 0.5000 61250.0n 0.5000 61499.9n 0.5000 61500.0n 0.5000 61749.9n 0.5000 61750.0n 0.5000 61999.9n 0.5000 62000.0n 0.5000 62249.9n 0.5000 62250.0n 0.5000 62499.9n 0.5000 62500.0n 0.5000 62749.9n 0.5000 62750.0n 0.5000 62999.9n 0.5000 63000.0n 0.5000 63249.9n 0.5000 63250.0n 0.5000 63499.9n 0.5000 63500.0n 0.5000 63749.9n 0.5000 63750.0n 0.5000 63999.9n 0.5000 64000.0n 0.5000 64249.9n 0.5000 64250.0n 0.5000 64499.9n 0.5000 64500.0n 0.5000 64749.9n 0.5000 64750.0n 0.5000 64999.9n 0.5000 65000.0n 0.5000 65249.9n 0.5000 65250.0n 0.5000 65499.9n 0.5000 65500.0n 0.5000 65749.9n 0.5000 65750.0n 0.5000 65999.9n 0.5000 66000.0n 0.5000 66249.9n 0.5000 66250.0n 0.5000 66499.9n 0.5000 66500.0n 0.5000 66749.9n 0.5000 66750.0n 0.5000 66999.9n 0.5000 67000.0n 0.5000 67249.9n 0.5000 67250.0n 0.5000 67499.9n 0.5000 67500.0n 0.5000 67749.9n 0.5000 67750.0n 0.5000 67999.9n 0.5000 68000.0n 0.5000 68249.9n 0.5000 68250.0n 0.5000 68499.9n 0.5000 68500.0n 0.5000 68749.9n 0.5000 68750.0n 0.5000 68999.9n 0.5000 69000.0n 0.5000 69249.9n 0.5000 69250.0n 0.5000 69499.9n 0.5000 69500.0n 0.5000 69749.9n 0.5000 69750.0n 0.5000 69999.9n 0.5000 70000.0n 0.5000 70249.9n 0.5000 70250.0n 0.5000 70499.9n 0.5000 70500.0n 0.5000 70749.9n 0.5000 70750.0n 0.5000 70999.9n 0.5000 71000.0n 0.5000 71249.9n 0.5000 71250.0n 0.5000 71499.9n 0.5000 71500.0n 0.5000 71749.9n 0.5000 71750.0n 0.5000 71999.9n 0.5000 72000.0n 0.5000 72249.9n 0.5000 72250.0n 0.5000 72499.9n 0.5000 72500.0n 0.5000 72749.9n 0.5000 72750.0n 0.5000 72999.9n 0.5000 73000.0n 0.5000 73249.9n 0.5000 73250.0n 0.5000 73499.9n 0.5000 73500.0n 0.5000 73749.9n 0.5000 73750.0n 0.5000 73999.9n 0.5000 74000.0n 0.5000 74249.9n 0.5000 74250.0n 0.5000 74499.9n 0.5000 74500.0n 0.5000 74749.9n 0.5000 74750.0n 0.5000)
Vxon xon 0 PWL(0.0n 0.5000 249.9n 0.5000 250.0n 0.5000 499.9n 0.5000 500.0n 0.5000 749.9n 0.5000 750.0n 0.5000 999.9n 0.5000 1000.0n 0.5000 1249.9n 0.5000 1250.0n 0.5000 1499.9n 0.5000 1500.0n 0.5000 1749.9n 0.5000 1750.0n 0.5000 1999.9n 0.5000 2000.0n 0.5000 2249.9n 0.5000 2250.0n 0.5000 2499.9n 0.5000 2500.0n 0.5000 2749.9n 0.5000 2750.0n 0.5000 2999.9n 0.5000 3000.0n 0.5000 3249.9n 0.5000 3250.0n 0.5000 3499.9n 0.5000 3500.0n 0.5000 3749.9n 0.5000 3750.0n 0.5000 3999.9n 0.5000 4000.0n 0.5000 4249.9n 0.5000 4250.0n 0.5000 4499.9n 0.5000 4500.0n 0.5000 4749.9n 0.5000 4750.0n 0.5000 4999.9n 0.5000 5000.0n 0.5000 5249.9n 0.5000 5250.0n 0.5000 5499.9n 0.5000 5500.0n 0.5000 5749.9n 0.5000 5750.0n 0.5000 5999.9n 0.5000 6000.0n 0.5000 6249.9n 0.5000 6250.0n 0.5000 6499.9n 0.5000 6500.0n 0.5000 6749.9n 0.5000 6750.0n 0.5000 6999.9n 0.5000 7000.0n 0.5000 7249.9n 0.5000 7250.0n 0.5000 7499.9n 0.5000 7500.0n 0.5000 7749.9n 0.5000 7750.0n 0.5000 7999.9n 0.5000 8000.0n 0.5000 8249.9n 0.5000 8250.0n 0.5000 8499.9n 0.5000 8500.0n 0.5000 8749.9n 0.5000 8750.0n 0.5000 8999.9n 0.5000 9000.0n 0.5000 9249.9n 0.5000 9250.0n 0.5000 9499.9n 0.5000 9500.0n 0.5000 9749.9n 0.5000 9750.0n 0.5000 9999.9n 0.5000 10000.0n 0.5000 10249.9n 0.5000 10250.0n 0.5000 10499.9n 0.5000 10500.0n 0.5000 10749.9n 0.5000 10750.0n 0.5000 10999.9n 0.5000 11000.0n 0.5000 11249.9n 0.5000 11250.0n 0.5000 11499.9n 0.5000 11500.0n 0.5000 11749.9n 0.5000 11750.0n 0.5000 11999.9n 0.5000 12000.0n 0.5000 12249.9n 0.5000 12250.0n 0.5000 12499.9n 0.5000 12500.0n 0.5000 12749.9n 0.5000 12750.0n 0.5000 12999.9n 0.5000 13000.0n 0.5000 13249.9n 0.5000 13250.0n 0.5000 13499.9n 0.5000 13500.0n 0.5000 13749.9n 0.5000 13750.0n 0.5000 13999.9n 0.5000 14000.0n 0.5000 14249.9n 0.5000 14250.0n 0.5000 14499.9n 0.5000 14500.0n 0.5000 14749.9n 0.5000 14750.0n 0.5000 14999.9n 0.5000 15000.0n 0.5000 15249.9n 0.5000 15250.0n 0.5000 15499.9n 0.5000 15500.0n 0.5000 15749.9n 0.5000 15750.0n 0.5000 15999.9n 0.5000 16000.0n 0.5000 16249.9n 0.5000 16250.0n 0.5000 16499.9n 0.5000 16500.0n 0.5000 16749.9n 0.5000 16750.0n 0.5000 16999.9n 0.5000 17000.0n 0.5000 17249.9n 0.5000 17250.0n 0.5000 17499.9n 0.5000 17500.0n 0.5000 17749.9n 0.5000 17750.0n 0.5000 17999.9n 0.5000 18000.0n 0.5000 18249.9n 0.5000 18250.0n 0.5000 18499.9n 0.5000 18500.0n 0.5000 18749.9n 0.5000 18750.0n 0.5000 18999.9n 0.5000 19000.0n 0.5000 19249.9n 0.5000 19250.0n 0.5000 19499.9n 0.5000 19500.0n 0.5000 19749.9n 0.5000 19750.0n 0.5000 19999.9n 0.5000 20000.0n 0.5000 20249.9n 0.5000 20250.0n 0.5000 20499.9n 0.5000 20500.0n 0.5000 20749.9n 0.5000 20750.0n 0.5000 20999.9n 0.5000 21000.0n 0.5000 21249.9n 0.5000 21250.0n 0.5000 21499.9n 0.5000 21500.0n 0.5000 21749.9n 0.5000 21750.0n 0.5000 21999.9n 0.5000 22000.0n 0.5000 22249.9n 0.5000 22250.0n 0.5000 22499.9n 0.5000 22500.0n 0.5000 22749.9n 0.5000 22750.0n 0.5000 22999.9n 0.5000 23000.0n 0.5000 23249.9n 0.5000 23250.0n 0.5000 23499.9n 0.5000 23500.0n 0.5000 23749.9n 0.5000 23750.0n 0.5000 23999.9n 0.5000 24000.0n 0.5000 24249.9n 0.5000 24250.0n 0.5000 24499.9n 0.5000 24500.0n 0.5000 24749.9n 0.5000 24750.0n 0.5000 24999.9n 0.5000 25000.0n 0.5000 25249.9n 0.5000 25250.0n 0.5000 25499.9n 0.5000 25500.0n 0.5000 25749.9n 0.5000 25750.0n 0.5000 25999.9n 0.5000 26000.0n 0.5000 26249.9n 0.5000 26250.0n 0.5000 26499.9n 0.5000 26500.0n 0.5000 26749.9n 0.5000 26750.0n 0.5000 26999.9n 0.5000 27000.0n 0.5000 27249.9n 0.5000 27250.0n 0.5000 27499.9n 0.5000 27500.0n 0.5000 27749.9n 0.5000 27750.0n 0.5000 27999.9n 0.5000 28000.0n 0.5000 28249.9n 0.5000 28250.0n 0.5000 28499.9n 0.5000 28500.0n 0.5000 28749.9n 0.5000 28750.0n 0.5000 28999.9n 0.5000 29000.0n 0.5000 29249.9n 0.5000 29250.0n 0.5000 29499.9n 0.5000 29500.0n 0.5000 29749.9n 0.5000 29750.0n 0.5000 29999.9n 0.5000 30000.0n 0.5000 30249.9n 0.5000 30250.0n 0.5000 30499.9n 0.5000 30500.0n 0.5000 30749.9n 0.5000 30750.0n 0.5000 30999.9n 0.5000 31000.0n 0.5000 31249.9n 0.5000 31250.0n 0.5000 31499.9n 0.5000 31500.0n 0.5000 31749.9n 0.5000 31750.0n 0.5000 31999.9n 0.5000 32000.0n 0.5000 32249.9n 0.5000 32250.0n 0.5000 32499.9n 0.5000 32500.0n 0.5000 32749.9n 0.5000 32750.0n 0.5000 32999.9n 0.5000 33000.0n 0.5000 33249.9n 0.5000 33250.0n 0.5000 33499.9n 0.5000 33500.0n 0.5000 33749.9n 0.5000 33750.0n 0.5000 33999.9n 0.5000 34000.0n 0.5000 34249.9n 0.5000 34250.0n 0.5000 34499.9n 0.5000 34500.0n 0.5000 34749.9n 0.5000 34750.0n 0.5000 34999.9n 0.5000 35000.0n 0.5000 35249.9n 0.5000 35250.0n 0.5000 35499.9n 0.5000 35500.0n 0.5000 35749.9n 0.5000 35750.0n 0.5000 35999.9n 0.5000 36000.0n 0.5000 36249.9n 0.5000 36250.0n 0.5000 36499.9n 0.5000 36500.0n 0.5000 36749.9n 0.5000 36750.0n 0.5000 36999.9n 0.5000 37000.0n 0.5000 37249.9n 0.5000 37250.0n 0.5000 37499.9n 0.5000 37500.0n 0.5000 37749.9n 0.5000 37750.0n 0.5000 37999.9n 0.5000 38000.0n 0.5000 38249.9n 0.5000 38250.0n 0.5000 38499.9n 0.5000 38500.0n 0.5000 38749.9n 0.5000 38750.0n 0.5000 38999.9n 0.5000 39000.0n 0.5000 39249.9n 0.5000 39250.0n 0.5000 39499.9n 0.5000 39500.0n 0.5000 39749.9n 0.5000 39750.0n 0.5000 39999.9n 0.5000 40000.0n 0.5000 40249.9n 0.5000 40250.0n 0.5000 40499.9n 0.5000 40500.0n 0.5000 40749.9n 0.5000 40750.0n 0.5000 40999.9n 0.5000 41000.0n 0.5000 41249.9n 0.5000 41250.0n 0.5000 41499.9n 0.5000 41500.0n 0.5000 41749.9n 0.5000 41750.0n 0.5000 41999.9n 0.5000 42000.0n 0.5000 42249.9n 0.5000 42250.0n 0.5000 42499.9n 0.5000 42500.0n 0.5000 42749.9n 0.5000 42750.0n 0.5000 42999.9n 0.5000 43000.0n 0.5000 43249.9n 0.5000 43250.0n 0.5000 43499.9n 0.5000 43500.0n 0.5000 43749.9n 0.5000 43750.0n 0.5000 43999.9n 0.5000 44000.0n 0.5000 44249.9n 0.5000 44250.0n 0.5000 44499.9n 0.5000 44500.0n 0.5000 44749.9n 0.5000 44750.0n 0.5000 44999.9n 0.5000 45000.0n 0.5000 45249.9n 0.5000 45250.0n 0.5000 45499.9n 0.5000 45500.0n 0.5000 45749.9n 0.5000 45750.0n 0.5000 45999.9n 0.5000 46000.0n 0.5000 46249.9n 0.5000 46250.0n 0.5000 46499.9n 0.5000 46500.0n 0.5000 46749.9n 0.5000 46750.0n 0.5000 46999.9n 0.5000 47000.0n 0.5000 47249.9n 0.5000 47250.0n 0.5000 47499.9n 0.5000 47500.0n 0.5000 47749.9n 0.5000 47750.0n 0.5000 47999.9n 0.5000 48000.0n 0.5000 48249.9n 0.5000 48250.0n 0.5000 48499.9n 0.5000 48500.0n 0.5000 48749.9n 0.5000 48750.0n 0.5000 48999.9n 0.5000 49000.0n 0.5000 49249.9n 0.5000 49250.0n 0.5000 49499.9n 0.5000 49500.0n 0.5000 49749.9n 0.5000 49750.0n 0.5000 49999.9n 0.5000 50000.0n 0.5000 50249.9n 0.5000 50250.0n 0.5000 50499.9n 0.5000 50500.0n 0.5000 50749.9n 0.5000 50750.0n 0.5000 50999.9n 0.5000 51000.0n 0.5000 51249.9n 0.5000 51250.0n 0.5000 51499.9n 0.5000 51500.0n 0.5000 51749.9n 0.5000 51750.0n 0.5000 51999.9n 0.5000 52000.0n 0.5000 52249.9n 0.5000 52250.0n 0.5000 52499.9n 0.5000 52500.0n 0.5000 52749.9n 0.5000 52750.0n 0.5000 52999.9n 0.5000 53000.0n 0.5000 53249.9n 0.5000 53250.0n 0.5000 53499.9n 0.5000 53500.0n 0.5000 53749.9n 0.5000 53750.0n 0.5000 53999.9n 0.5000 54000.0n 0.5000 54249.9n 0.5000 54250.0n 0.5000 54499.9n 0.5000 54500.0n 0.5000 54749.9n 0.5000 54750.0n 0.5000 54999.9n 0.5000 55000.0n 0.5000 55249.9n 0.5000 55250.0n 0.5000 55499.9n 0.5000 55500.0n 0.5000 55749.9n 0.5000 55750.0n 0.5000 55999.9n 0.5000 56000.0n 0.5000 56249.9n 0.5000 56250.0n 0.5000 56499.9n 0.5000 56500.0n 0.5000 56749.9n 0.5000 56750.0n 0.5000 56999.9n 0.5000 57000.0n 0.5000 57249.9n 0.5000 57250.0n 0.5000 57499.9n 0.5000 57500.0n 0.5000 57749.9n 0.5000 57750.0n 0.5000 57999.9n 0.5000 58000.0n 0.5000 58249.9n 0.5000 58250.0n 0.5000 58499.9n 0.5000 58500.0n 0.5000 58749.9n 0.5000 58750.0n 0.5000 58999.9n 0.5000 59000.0n 0.5000 59249.9n 0.5000 59250.0n 0.5000 59499.9n 0.5000 59500.0n 0.5000 59749.9n 0.5000 59750.0n 0.5000 59999.9n 0.5000 60000.0n 0.5000 60249.9n 0.5000 60250.0n 0.5000 60499.9n 0.5000 60500.0n 0.5000 60749.9n 0.5000 60750.0n 0.5000 60999.9n 0.5000 61000.0n 0.5000 61249.9n 0.5000 61250.0n 0.5000 61499.9n 0.5000 61500.0n 0.5000 61749.9n 0.5000 61750.0n 0.5000 61999.9n 0.5000 62000.0n 0.5000 62249.9n 0.5000 62250.0n 0.5000 62499.9n 0.5000 62500.0n 0.5000 62749.9n 0.5000 62750.0n 0.5000 62999.9n 0.5000 63000.0n 0.5000 63249.9n 0.5000 63250.0n 0.5000 63499.9n 0.5000 63500.0n 0.5000 63749.9n 0.5000 63750.0n 0.5000 63999.9n 0.5000 64000.0n 0.5000 64249.9n 0.5000 64250.0n 0.5000 64499.9n 0.5000 64500.0n 0.5000 64749.9n 0.5000 64750.0n 0.5000 64999.9n 0.5000 65000.0n 0.5000 65249.9n 0.5000 65250.0n 0.5000 65499.9n 0.5000 65500.0n 0.5000 65749.9n 0.5000 65750.0n 0.5000 65999.9n 0.5000 66000.0n 0.5000 66249.9n 0.5000 66250.0n 0.5000 66499.9n 0.5000 66500.0n 0.5000 66749.9n 0.5000 66750.0n 0.5000 66999.9n 0.5000 67000.0n 0.5000 67249.9n 0.5000 67250.0n 0.5000 67499.9n 0.5000 67500.0n 0.5000 67749.9n 0.5000 67750.0n 0.5000 67999.9n 0.5000 68000.0n 0.5000 68249.9n 0.5000 68250.0n 0.5000 68499.9n 0.5000 68500.0n 0.5000 68749.9n 0.5000 68750.0n 0.5000 68999.9n 0.5000 69000.0n 0.5000 69249.9n 0.5000 69250.0n 0.5000 69499.9n 0.5000 69500.0n 0.5000 69749.9n 0.5000 69750.0n 0.5000 69999.9n 0.5000 70000.0n 0.5000 70249.9n 0.5000 70250.0n 0.5000 70499.9n 0.5000 70500.0n 0.5000 70749.9n 0.5000 70750.0n 0.5000 70999.9n 0.5000 71000.0n 0.5000 71249.9n 0.5000 71250.0n 0.5000 71499.9n 0.5000 71500.0n 0.5000 71749.9n 0.5000 71750.0n 0.5000 71999.9n 0.5000 72000.0n 0.5000 72249.9n 0.5000 72250.0n 0.5000 72499.9n 0.5000 72500.0n 0.5000 72749.9n 0.5000 72750.0n 0.5000 72999.9n 0.5000 73000.0n 0.5000 73249.9n 0.5000 73250.0n 0.5000 73499.9n 0.5000 73500.0n 0.5000 73749.9n 0.5000 73750.0n 0.5000 73999.9n 0.5000 74000.0n 0.5000 74249.9n 0.5000 74250.0n 0.5000 74499.9n 0.5000 74500.0n 0.5000 74749.9n 0.5000 74750.0n 0.5000)
Cwp_wih_1_0 wp_wih_1_0 0 30p
Cwn_wih_1_0 wn_wih_1_0 0 30p
Rwp_wih_1_0 wp_wih_1_0 wcm 2g
Rwn_wih_1_0 wn_wih_1_0 wcm 2g
Cwp_wih_2_0 wp_wih_2_0 0 30p
Cwn_wih_2_0 wn_wih_2_0 0 30p
Rwp_wih_2_0 wp_wih_2_0 wcm 2g
Rwn_wih_2_0 wn_wih_2_0 wcm 2g
Cwp_wih_3_0 wp_wih_3_0 0 30p
Cwn_wih_3_0 wn_wih_3_0 0 30p
Rwp_wih_3_0 wp_wih_3_0 wcm 2g
Rwn_wih_3_0 wn_wih_3_0 wcm 2g
Cwp_who_0 wp_who_0 0 30p
Cwn_who_0 wn_who_0 0 30p
Rwp_who_0 wp_who_0 wcm 2g
Rwn_who_0 wn_who_0 wcm 2g
Cwp_wih_1_1 wp_wih_1_1 0 30p
Cwn_wih_1_1 wn_wih_1_1 0 30p
Rwp_wih_1_1 wp_wih_1_1 wcm 2g
Rwn_wih_1_1 wn_wih_1_1 wcm 2g
Cwp_wih_2_1 wp_wih_2_1 0 30p
Cwn_wih_2_1 wn_wih_2_1 0 30p
Rwp_wih_2_1 wp_wih_2_1 wcm 2g
Rwn_wih_2_1 wn_wih_2_1 wcm 2g
Cwp_wih_3_1 wp_wih_3_1 0 30p
Cwn_wih_3_1 wn_wih_3_1 0 30p
Rwp_wih_3_1 wp_wih_3_1 wcm 2g
Rwn_wih_3_1 wn_wih_3_1 wcm 2g
Cwp_who_1 wp_who_1 0 30p
Cwn_who_1 wn_who_1 0 30p
Rwp_who_1 wp_who_1 wcm 2g
Rwn_who_1 wn_who_1 wcm 2g
Cwp_wih_1_2 wp_wih_1_2 0 30p
Cwn_wih_1_2 wn_wih_1_2 0 30p
Rwp_wih_1_2 wp_wih_1_2 wcm 2g
Rwn_wih_1_2 wn_wih_1_2 wcm 2g
Cwp_wih_2_2 wp_wih_2_2 0 30p
Cwn_wih_2_2 wn_wih_2_2 0 30p
Rwp_wih_2_2 wp_wih_2_2 wcm 2g
Rwn_wih_2_2 wn_wih_2_2 wcm 2g
Cwp_wih_3_2 wp_wih_3_2 0 30p
Cwn_wih_3_2 wn_wih_3_2 0 30p
Rwp_wih_3_2 wp_wih_3_2 wcm 2g
Rwn_wih_3_2 wn_wih_3_2 wcm 2g
Cwp_who_2 wp_who_2 0 30p
Cwn_who_2 wn_who_2 0 30p
Rwp_who_2 wp_who_2 wcm 2g
Rwn_who_2 wn_who_2 wcm 2g
Cwp_wih_1_3 wp_wih_1_3 0 30p
Cwn_wih_1_3 wn_wih_1_3 0 30p
Rwp_wih_1_3 wp_wih_1_3 wcm 2g
Rwn_wih_1_3 wn_wih_1_3 wcm 2g
Cwp_wih_2_3 wp_wih_2_3 0 30p
Cwn_wih_2_3 wn_wih_2_3 0 30p
Rwp_wih_2_3 wp_wih_2_3 wcm 2g
Rwn_wih_2_3 wn_wih_2_3 wcm 2g
Cwp_wih_3_3 wp_wih_3_3 0 30p
Cwn_wih_3_3 wn_wih_3_3 0 30p
Rwp_wih_3_3 wp_wih_3_3 wcm 2g
Rwn_wih_3_3 wn_wih_3_3 wcm 2g
Cwp_who_3 wp_who_3 0 30p
Cwn_who_3 wn_who_3 0 30p
Rwp_who_3 wp_who_3 wcm 2g
Rwn_who_3 wn_who_3 wcm 2g
Cwp_wih_1_4 wp_wih_1_4 0 30p
Cwn_wih_1_4 wn_wih_1_4 0 30p
Rwp_wih_1_4 wp_wih_1_4 wcm 2g
Rwn_wih_1_4 wn_wih_1_4 wcm 2g
Cwp_wih_2_4 wp_wih_2_4 0 30p
Cwn_wih_2_4 wn_wih_2_4 0 30p
Rwp_wih_2_4 wp_wih_2_4 wcm 2g
Rwn_wih_2_4 wn_wih_2_4 wcm 2g
Cwp_wih_3_4 wp_wih_3_4 0 30p
Cwn_wih_3_4 wn_wih_3_4 0 30p
Rwp_wih_3_4 wp_wih_3_4 wcm 2g
Rwn_wih_3_4 wn_wih_3_4 wcm 2g
Cwp_who_4 wp_who_4 0 30p
Cwn_who_4 wn_who_4 0 30p
Rwp_who_4 wp_who_4 wcm 2g
Rwn_who_4 wn_who_4 wcm 2g
Cwp_wih_1_5 wp_wih_1_5 0 30p
Cwn_wih_1_5 wn_wih_1_5 0 30p
Rwp_wih_1_5 wp_wih_1_5 wcm 2g
Rwn_wih_1_5 wn_wih_1_5 wcm 2g
Cwp_wih_2_5 wp_wih_2_5 0 30p
Cwn_wih_2_5 wn_wih_2_5 0 30p
Rwp_wih_2_5 wp_wih_2_5 wcm 2g
Rwn_wih_2_5 wn_wih_2_5 wcm 2g
Cwp_wih_3_5 wp_wih_3_5 0 30p
Cwn_wih_3_5 wn_wih_3_5 0 30p
Rwp_wih_3_5 wp_wih_3_5 wcm 2g
Rwn_wih_3_5 wn_wih_3_5 wcm 2g
Cwp_who_5 wp_who_5 0 30p
Cwn_who_5 wn_who_5 0 30p
Rwp_who_5 wp_who_5 wcm 2g
Rwn_who_5 wn_who_5 wcm 2g
Cwp_wih_1_6 wp_wih_1_6 0 30p
Cwn_wih_1_6 wn_wih_1_6 0 30p
Rwp_wih_1_6 wp_wih_1_6 wcm 2g
Rwn_wih_1_6 wn_wih_1_6 wcm 2g
Cwp_wih_2_6 wp_wih_2_6 0 30p
Cwn_wih_2_6 wn_wih_2_6 0 30p
Rwp_wih_2_6 wp_wih_2_6 wcm 2g
Rwn_wih_2_6 wn_wih_2_6 wcm 2g
Cwp_wih_3_6 wp_wih_3_6 0 30p
Cwn_wih_3_6 wn_wih_3_6 0 30p
Rwp_wih_3_6 wp_wih_3_6 wcm 2g
Rwn_wih_3_6 wn_wih_3_6 wcm 2g
Cwp_who_6 wp_who_6 0 30p
Cwn_who_6 wn_who_6 0 30p
Rwp_who_6 wp_who_6 wcm 2g
Rwn_who_6 wn_who_6 wcm 2g
Cwp_wih_1_7 wp_wih_1_7 0 30p
Cwn_wih_1_7 wn_wih_1_7 0 30p
Rwp_wih_1_7 wp_wih_1_7 wcm 2g
Rwn_wih_1_7 wn_wih_1_7 wcm 2g
Cwp_wih_2_7 wp_wih_2_7 0 30p
Cwn_wih_2_7 wn_wih_2_7 0 30p
Rwp_wih_2_7 wp_wih_2_7 wcm 2g
Rwn_wih_2_7 wn_wih_2_7 wcm 2g
Cwp_wih_3_7 wp_wih_3_7 0 30p
Cwn_wih_3_7 wn_wih_3_7 0 30p
Rwp_wih_3_7 wp_wih_3_7 wcm 2g
Rwn_wih_3_7 wn_wih_3_7 wcm 2g
Cwp_who_7 wp_who_7 0 30p
Cwn_who_7 wn_who_7 0 30p
Rwp_who_7 wp_who_7 wcm 2g
Rwn_who_7 wn_who_7 wcm 2g
Cwp_wih_1_8 wp_wih_1_8 0 30p
Cwn_wih_1_8 wn_wih_1_8 0 30p
Rwp_wih_1_8 wp_wih_1_8 wcm 2g
Rwn_wih_1_8 wn_wih_1_8 wcm 2g
Cwp_wih_2_8 wp_wih_2_8 0 30p
Cwn_wih_2_8 wn_wih_2_8 0 30p
Rwp_wih_2_8 wp_wih_2_8 wcm 2g
Rwn_wih_2_8 wn_wih_2_8 wcm 2g
Cwp_wih_3_8 wp_wih_3_8 0 30p
Cwn_wih_3_8 wn_wih_3_8 0 30p
Rwp_wih_3_8 wp_wih_3_8 wcm 2g
Rwn_wih_3_8 wn_wih_3_8 wcm 2g
Cwp_who_8 wp_who_8 0 30p
Cwn_who_8 wn_who_8 0 30p
Rwp_who_8 wp_who_8 wcm 2g
Rwn_who_8 wn_who_8 wcm 2g
Cwp_wih_1_9 wp_wih_1_9 0 30p
Cwn_wih_1_9 wn_wih_1_9 0 30p
Rwp_wih_1_9 wp_wih_1_9 wcm 2g
Rwn_wih_1_9 wn_wih_1_9 wcm 2g
Cwp_wih_2_9 wp_wih_2_9 0 30p
Cwn_wih_2_9 wn_wih_2_9 0 30p
Rwp_wih_2_9 wp_wih_2_9 wcm 2g
Rwn_wih_2_9 wn_wih_2_9 wcm 2g
Cwp_wih_3_9 wp_wih_3_9 0 30p
Cwn_wih_3_9 wn_wih_3_9 0 30p
Rwp_wih_3_9 wp_wih_3_9 wcm 2g
Rwn_wih_3_9 wn_wih_3_9 wcm 2g
Cwp_who_9 wp_who_9 0 30p
Cwn_who_9 wn_who_9 0 30p
Rwp_who_9 wp_who_9 wcm 2g
Rwn_who_9 wn_who_9 wcm 2g
Cwp_wih_1_10 wp_wih_1_10 0 30p
Cwn_wih_1_10 wn_wih_1_10 0 30p
Rwp_wih_1_10 wp_wih_1_10 wcm 2g
Rwn_wih_1_10 wn_wih_1_10 wcm 2g
Cwp_wih_2_10 wp_wih_2_10 0 30p
Cwn_wih_2_10 wn_wih_2_10 0 30p
Rwp_wih_2_10 wp_wih_2_10 wcm 2g
Rwn_wih_2_10 wn_wih_2_10 wcm 2g
Cwp_wih_3_10 wp_wih_3_10 0 30p
Cwn_wih_3_10 wn_wih_3_10 0 30p
Rwp_wih_3_10 wp_wih_3_10 wcm 2g
Rwn_wih_3_10 wn_wih_3_10 wcm 2g
Cwp_who_10 wp_who_10 0 30p
Cwn_who_10 wn_who_10 0 30p
Rwp_who_10 wp_who_10 wcm 2g
Rwn_who_10 wn_who_10 wcm 2g
Cwp_wih_1_11 wp_wih_1_11 0 30p
Cwn_wih_1_11 wn_wih_1_11 0 30p
Rwp_wih_1_11 wp_wih_1_11 wcm 2g
Rwn_wih_1_11 wn_wih_1_11 wcm 2g
Cwp_wih_2_11 wp_wih_2_11 0 30p
Cwn_wih_2_11 wn_wih_2_11 0 30p
Rwp_wih_2_11 wp_wih_2_11 wcm 2g
Rwn_wih_2_11 wn_wih_2_11 wcm 2g
Cwp_wih_3_11 wp_wih_3_11 0 30p
Cwn_wih_3_11 wn_wih_3_11 0 30p
Rwp_wih_3_11 wp_wih_3_11 wcm 2g
Rwn_wih_3_11 wn_wih_3_11 wcm 2g
Cwp_who_11 wp_who_11 0 30p
Cwn_who_11 wn_who_11 0 30p
Rwp_who_11 wp_who_11 wcm 2g
Rwn_who_11 wn_who_11 wcm 2g
Cwp_wih_1_12 wp_wih_1_12 0 30p
Cwn_wih_1_12 wn_wih_1_12 0 30p
Rwp_wih_1_12 wp_wih_1_12 wcm 2g
Rwn_wih_1_12 wn_wih_1_12 wcm 2g
Cwp_wih_2_12 wp_wih_2_12 0 30p
Cwn_wih_2_12 wn_wih_2_12 0 30p
Rwp_wih_2_12 wp_wih_2_12 wcm 2g
Rwn_wih_2_12 wn_wih_2_12 wcm 2g
Cwp_wih_3_12 wp_wih_3_12 0 30p
Cwn_wih_3_12 wn_wih_3_12 0 30p
Rwp_wih_3_12 wp_wih_3_12 wcm 2g
Rwn_wih_3_12 wn_wih_3_12 wcm 2g
Cwp_who_12 wp_who_12 0 30p
Cwn_who_12 wn_who_12 0 30p
Rwp_who_12 wp_who_12 wcm 2g
Rwn_who_12 wn_who_12 wcm 2g
Cwp_wih_1_13 wp_wih_1_13 0 30p
Cwn_wih_1_13 wn_wih_1_13 0 30p
Rwp_wih_1_13 wp_wih_1_13 wcm 2g
Rwn_wih_1_13 wn_wih_1_13 wcm 2g
Cwp_wih_2_13 wp_wih_2_13 0 30p
Cwn_wih_2_13 wn_wih_2_13 0 30p
Rwp_wih_2_13 wp_wih_2_13 wcm 2g
Rwn_wih_2_13 wn_wih_2_13 wcm 2g
Cwp_wih_3_13 wp_wih_3_13 0 30p
Cwn_wih_3_13 wn_wih_3_13 0 30p
Rwp_wih_3_13 wp_wih_3_13 wcm 2g
Rwn_wih_3_13 wn_wih_3_13 wcm 2g
Cwp_who_13 wp_who_13 0 30p
Cwn_who_13 wn_who_13 0 30p
Rwp_who_13 wp_who_13 wcm 2g
Rwn_who_13 wn_who_13 wcm 2g
Cwp_wih_1_14 wp_wih_1_14 0 30p
Cwn_wih_1_14 wn_wih_1_14 0 30p
Rwp_wih_1_14 wp_wih_1_14 wcm 2g
Rwn_wih_1_14 wn_wih_1_14 wcm 2g
Cwp_wih_2_14 wp_wih_2_14 0 30p
Cwn_wih_2_14 wn_wih_2_14 0 30p
Rwp_wih_2_14 wp_wih_2_14 wcm 2g
Rwn_wih_2_14 wn_wih_2_14 wcm 2g
Cwp_wih_3_14 wp_wih_3_14 0 30p
Cwn_wih_3_14 wn_wih_3_14 0 30p
Rwp_wih_3_14 wp_wih_3_14 wcm 2g
Rwn_wih_3_14 wn_wih_3_14 wcm 2g
Cwp_who_14 wp_who_14 0 30p
Cwn_who_14 wn_who_14 0 30p
Rwp_who_14 wp_who_14 wcm 2g
Rwn_who_14 wn_who_14 wcm 2g
Cwp_wih_1_15 wp_wih_1_15 0 30p
Cwn_wih_1_15 wn_wih_1_15 0 30p
Rwp_wih_1_15 wp_wih_1_15 wcm 2g
Rwn_wih_1_15 wn_wih_1_15 wcm 2g
Cwp_wih_2_15 wp_wih_2_15 0 30p
Cwn_wih_2_15 wn_wih_2_15 0 30p
Rwp_wih_2_15 wp_wih_2_15 wcm 2g
Rwn_wih_2_15 wn_wih_2_15 wcm 2g
Cwp_wih_3_15 wp_wih_3_15 0 30p
Cwn_wih_3_15 wn_wih_3_15 0 30p
Rwp_wih_3_15 wp_wih_3_15 wcm 2g
Rwn_wih_3_15 wn_wih_3_15 wcm 2g
Cwp_who_15 wp_who_15 0 30p
Cwn_who_15 wn_who_15 0 30p
Rwp_who_15 wp_who_15 wcm 2g
Rwn_who_15 wn_who_15 wcm 2g
Cwp_wih_1_16 wp_wih_1_16 0 30p
Cwn_wih_1_16 wn_wih_1_16 0 30p
Rwp_wih_1_16 wp_wih_1_16 wcm 2g
Rwn_wih_1_16 wn_wih_1_16 wcm 2g
Cwp_wih_2_16 wp_wih_2_16 0 30p
Cwn_wih_2_16 wn_wih_2_16 0 30p
Rwp_wih_2_16 wp_wih_2_16 wcm 2g
Rwn_wih_2_16 wn_wih_2_16 wcm 2g
Cwp_wih_3_16 wp_wih_3_16 0 30p
Cwn_wih_3_16 wn_wih_3_16 0 30p
Rwp_wih_3_16 wp_wih_3_16 wcm 2g
Rwn_wih_3_16 wn_wih_3_16 wcm 2g
Cwp_who_16 wp_who_16 0 30p
Cwn_who_16 wn_who_16 0 30p
Rwp_who_16 wp_who_16 wcm 2g
Rwn_who_16 wn_who_16 wcm 2g
Cwp_wih_1_17 wp_wih_1_17 0 30p
Cwn_wih_1_17 wn_wih_1_17 0 30p
Rwp_wih_1_17 wp_wih_1_17 wcm 2g
Rwn_wih_1_17 wn_wih_1_17 wcm 2g
Cwp_wih_2_17 wp_wih_2_17 0 30p
Cwn_wih_2_17 wn_wih_2_17 0 30p
Rwp_wih_2_17 wp_wih_2_17 wcm 2g
Rwn_wih_2_17 wn_wih_2_17 wcm 2g
Cwp_wih_3_17 wp_wih_3_17 0 30p
Cwn_wih_3_17 wn_wih_3_17 0 30p
Rwp_wih_3_17 wp_wih_3_17 wcm 2g
Rwn_wih_3_17 wn_wih_3_17 wcm 2g
Cwp_who_17 wp_who_17 0 30p
Cwn_who_17 wn_who_17 0 30p
Rwp_who_17 wp_who_17 wcm 2g
Rwn_who_17 wn_who_17 wcm 2g
Cwp_wih_1_18 wp_wih_1_18 0 30p
Cwn_wih_1_18 wn_wih_1_18 0 30p
Rwp_wih_1_18 wp_wih_1_18 wcm 2g
Rwn_wih_1_18 wn_wih_1_18 wcm 2g
Cwp_wih_2_18 wp_wih_2_18 0 30p
Cwn_wih_2_18 wn_wih_2_18 0 30p
Rwp_wih_2_18 wp_wih_2_18 wcm 2g
Rwn_wih_2_18 wn_wih_2_18 wcm 2g
Cwp_wih_3_18 wp_wih_3_18 0 30p
Cwn_wih_3_18 wn_wih_3_18 0 30p
Rwp_wih_3_18 wp_wih_3_18 wcm 2g
Rwn_wih_3_18 wn_wih_3_18 wcm 2g
Cwp_who_18 wp_who_18 0 30p
Cwn_who_18 wn_who_18 0 30p
Rwp_who_18 wp_who_18 wcm 2g
Rwn_who_18 wn_who_18 wcm 2g
Cwp_wih_1_19 wp_wih_1_19 0 30p
Cwn_wih_1_19 wn_wih_1_19 0 30p
Rwp_wih_1_19 wp_wih_1_19 wcm 2g
Rwn_wih_1_19 wn_wih_1_19 wcm 2g
Cwp_wih_2_19 wp_wih_2_19 0 30p
Cwn_wih_2_19 wn_wih_2_19 0 30p
Rwp_wih_2_19 wp_wih_2_19 wcm 2g
Rwn_wih_2_19 wn_wih_2_19 wcm 2g
Cwp_wih_3_19 wp_wih_3_19 0 30p
Cwn_wih_3_19 wn_wih_3_19 0 30p
Rwp_wih_3_19 wp_wih_3_19 wcm 2g
Rwn_wih_3_19 wn_wih_3_19 wcm 2g
Cwp_who_19 wp_who_19 0 30p
Cwn_who_19 wn_who_19 0 30p
Rwp_who_19 wp_who_19 wcm 2g
Rwn_who_19 wn_who_19 wcm 2g
Cwp_wih_1_20 wp_wih_1_20 0 30p
Cwn_wih_1_20 wn_wih_1_20 0 30p
Rwp_wih_1_20 wp_wih_1_20 wcm 2g
Rwn_wih_1_20 wn_wih_1_20 wcm 2g
Cwp_wih_2_20 wp_wih_2_20 0 30p
Cwn_wih_2_20 wn_wih_2_20 0 30p
Rwp_wih_2_20 wp_wih_2_20 wcm 2g
Rwn_wih_2_20 wn_wih_2_20 wcm 2g
Cwp_wih_3_20 wp_wih_3_20 0 30p
Cwn_wih_3_20 wn_wih_3_20 0 30p
Rwp_wih_3_20 wp_wih_3_20 wcm 2g
Rwn_wih_3_20 wn_wih_3_20 wcm 2g
Cwp_who_20 wp_who_20 0 30p
Cwn_who_20 wn_who_20 0 30p
Rwp_who_20 wp_who_20 wcm 2g
Rwn_who_20 wn_who_20 wcm 2g
Cwp_wih_1_21 wp_wih_1_21 0 30p
Cwn_wih_1_21 wn_wih_1_21 0 30p
Rwp_wih_1_21 wp_wih_1_21 wcm 2g
Rwn_wih_1_21 wn_wih_1_21 wcm 2g
Cwp_wih_2_21 wp_wih_2_21 0 30p
Cwn_wih_2_21 wn_wih_2_21 0 30p
Rwp_wih_2_21 wp_wih_2_21 wcm 2g
Rwn_wih_2_21 wn_wih_2_21 wcm 2g
Cwp_wih_3_21 wp_wih_3_21 0 30p
Cwn_wih_3_21 wn_wih_3_21 0 30p
Rwp_wih_3_21 wp_wih_3_21 wcm 2g
Rwn_wih_3_21 wn_wih_3_21 wcm 2g
Cwp_who_21 wp_who_21 0 30p
Cwn_who_21 wn_who_21 0 30p
Rwp_who_21 wp_who_21 wcm 2g
Rwn_who_21 wn_who_21 wcm 2g
Cwp_wih_1_22 wp_wih_1_22 0 30p
Cwn_wih_1_22 wn_wih_1_22 0 30p
Rwp_wih_1_22 wp_wih_1_22 wcm 2g
Rwn_wih_1_22 wn_wih_1_22 wcm 2g
Cwp_wih_2_22 wp_wih_2_22 0 30p
Cwn_wih_2_22 wn_wih_2_22 0 30p
Rwp_wih_2_22 wp_wih_2_22 wcm 2g
Rwn_wih_2_22 wn_wih_2_22 wcm 2g
Cwp_wih_3_22 wp_wih_3_22 0 30p
Cwn_wih_3_22 wn_wih_3_22 0 30p
Rwp_wih_3_22 wp_wih_3_22 wcm 2g
Rwn_wih_3_22 wn_wih_3_22 wcm 2g
Cwp_who_22 wp_who_22 0 30p
Cwn_who_22 wn_who_22 0 30p
Rwp_who_22 wp_who_22 wcm 2g
Rwn_who_22 wn_who_22 wcm 2g
Cwp_wih_1_23 wp_wih_1_23 0 30p
Cwn_wih_1_23 wn_wih_1_23 0 30p
Rwp_wih_1_23 wp_wih_1_23 wcm 2g
Rwn_wih_1_23 wn_wih_1_23 wcm 2g
Cwp_wih_2_23 wp_wih_2_23 0 30p
Cwn_wih_2_23 wn_wih_2_23 0 30p
Rwp_wih_2_23 wp_wih_2_23 wcm 2g
Rwn_wih_2_23 wn_wih_2_23 wcm 2g
Cwp_wih_3_23 wp_wih_3_23 0 30p
Cwn_wih_3_23 wn_wih_3_23 0 30p
Rwp_wih_3_23 wp_wih_3_23 wcm 2g
Rwn_wih_3_23 wn_wih_3_23 wcm 2g
Cwp_who_23 wp_who_23 0 30p
Cwn_who_23 wn_who_23 0 30p
Rwp_who_23 wp_who_23 wcm 2g
Rwn_who_23 wn_who_23 wcm 2g
Xcm_mh0 mhp0 mhn0 vdd cmld
Xcm_xh0 xhp0 xhn0 vdd cmld
Rnd_mh0 mhp0 mhn0 20k
Rnd_xh0 xhp0 xhn0 20k
Cxhp0 xhp0 0 0.4p
Cxhn0 xhn0 0 0.4p
X_ihm_1_0 a_xp1 a_xn1 wp_wih_1_0 wn_wih_1_0 mhp0 mhn0 vdd vbsyn gsyn
X_ihx_1_0 a_xp1 a_xn1 wp_wih_1_0 wn_wih_1_0 xhp0 xhn0 vdd vbsyn gsyn
X_ihm_2_0 a_xp2 a_xn2 wp_wih_2_0 wn_wih_2_0 mhp0 mhn0 vdd vbsyn gsyn
X_ihx_2_0 a_xp2 a_xn2 wp_wih_2_0 wn_wih_2_0 xhp0 xhn0 vdd vbsyn gsyn
X_ihm_3_0 a_xp3 a_xn3 wp_wih_3_0 wn_wih_3_0 mhp0 mhn0 vdd vbsyn gsyn
X_ihx_3_0 a_xp3 a_xn3 wp_wih_3_0 wn_wih_3_0 xhp0 xhn0 vdd vbsyn gsyn
X_bk_0 eop eon wp_who_0 wn_who_0 xhp0 xhn0 vdd vbsyn gsyn
Xn0 xhp0 xhn0 ahp0 ahn0 vdd vbneu dneuron
Xeh0 xhp0 xhn0 mhp0 mhn0 ehp0 ehn0 vdd gm_h esub
Xcm_mh1 mhp1 mhn1 vdd cmld
Xcm_xh1 xhp1 xhn1 vdd cmld
Rnd_mh1 mhp1 mhn1 20k
Rnd_xh1 xhp1 xhn1 20k
Cxhp1 xhp1 0 0.4p
Cxhn1 xhn1 0 0.4p
X_ihm_1_1 a_xp1 a_xn1 wp_wih_1_1 wn_wih_1_1 mhp1 mhn1 vdd vbsyn gsyn
X_ihx_1_1 a_xp1 a_xn1 wp_wih_1_1 wn_wih_1_1 xhp1 xhn1 vdd vbsyn gsyn
X_ihm_2_1 a_xp2 a_xn2 wp_wih_2_1 wn_wih_2_1 mhp1 mhn1 vdd vbsyn gsyn
X_ihx_2_1 a_xp2 a_xn2 wp_wih_2_1 wn_wih_2_1 xhp1 xhn1 vdd vbsyn gsyn
X_ihm_3_1 a_xp3 a_xn3 wp_wih_3_1 wn_wih_3_1 mhp1 mhn1 vdd vbsyn gsyn
X_ihx_3_1 a_xp3 a_xn3 wp_wih_3_1 wn_wih_3_1 xhp1 xhn1 vdd vbsyn gsyn
X_bk_1 eop eon wp_who_1 wn_who_1 xhp1 xhn1 vdd vbsyn gsyn
Xn1 xhp1 xhn1 ahp1 ahn1 vdd vbneu dneuron
Xeh1 xhp1 xhn1 mhp1 mhn1 ehp1 ehn1 vdd gm_h esub
Xcm_mh2 mhp2 mhn2 vdd cmld
Xcm_xh2 xhp2 xhn2 vdd cmld
Rnd_mh2 mhp2 mhn2 20k
Rnd_xh2 xhp2 xhn2 20k
Cxhp2 xhp2 0 0.4p
Cxhn2 xhn2 0 0.4p
X_ihm_1_2 a_xp1 a_xn1 wp_wih_1_2 wn_wih_1_2 mhp2 mhn2 vdd vbsyn gsyn
X_ihx_1_2 a_xp1 a_xn1 wp_wih_1_2 wn_wih_1_2 xhp2 xhn2 vdd vbsyn gsyn
X_ihm_2_2 a_xp2 a_xn2 wp_wih_2_2 wn_wih_2_2 mhp2 mhn2 vdd vbsyn gsyn
X_ihx_2_2 a_xp2 a_xn2 wp_wih_2_2 wn_wih_2_2 xhp2 xhn2 vdd vbsyn gsyn
X_ihm_3_2 a_xp3 a_xn3 wp_wih_3_2 wn_wih_3_2 mhp2 mhn2 vdd vbsyn gsyn
X_ihx_3_2 a_xp3 a_xn3 wp_wih_3_2 wn_wih_3_2 xhp2 xhn2 vdd vbsyn gsyn
X_bk_2 eop eon wp_who_2 wn_who_2 xhp2 xhn2 vdd vbsyn gsyn
Xn2 xhp2 xhn2 ahp2 ahn2 vdd vbneu dneuron
Xeh2 xhp2 xhn2 mhp2 mhn2 ehp2 ehn2 vdd gm_h esub
Xcm_mh3 mhp3 mhn3 vdd cmld
Xcm_xh3 xhp3 xhn3 vdd cmld
Rnd_mh3 mhp3 mhn3 20k
Rnd_xh3 xhp3 xhn3 20k
Cxhp3 xhp3 0 0.4p
Cxhn3 xhn3 0 0.4p
X_ihm_1_3 a_xp1 a_xn1 wp_wih_1_3 wn_wih_1_3 mhp3 mhn3 vdd vbsyn gsyn
X_ihx_1_3 a_xp1 a_xn1 wp_wih_1_3 wn_wih_1_3 xhp3 xhn3 vdd vbsyn gsyn
X_ihm_2_3 a_xp2 a_xn2 wp_wih_2_3 wn_wih_2_3 mhp3 mhn3 vdd vbsyn gsyn
X_ihx_2_3 a_xp2 a_xn2 wp_wih_2_3 wn_wih_2_3 xhp3 xhn3 vdd vbsyn gsyn
X_ihm_3_3 a_xp3 a_xn3 wp_wih_3_3 wn_wih_3_3 mhp3 mhn3 vdd vbsyn gsyn
X_ihx_3_3 a_xp3 a_xn3 wp_wih_3_3 wn_wih_3_3 xhp3 xhn3 vdd vbsyn gsyn
X_bk_3 eop eon wp_who_3 wn_who_3 xhp3 xhn3 vdd vbsyn gsyn
Xn3 xhp3 xhn3 ahp3 ahn3 vdd vbneu dneuron
Xeh3 xhp3 xhn3 mhp3 mhn3 ehp3 ehn3 vdd gm_h esub
Xcm_mh4 mhp4 mhn4 vdd cmld
Xcm_xh4 xhp4 xhn4 vdd cmld
Rnd_mh4 mhp4 mhn4 20k
Rnd_xh4 xhp4 xhn4 20k
Cxhp4 xhp4 0 0.4p
Cxhn4 xhn4 0 0.4p
X_ihm_1_4 a_xp1 a_xn1 wp_wih_1_4 wn_wih_1_4 mhp4 mhn4 vdd vbsyn gsyn
X_ihx_1_4 a_xp1 a_xn1 wp_wih_1_4 wn_wih_1_4 xhp4 xhn4 vdd vbsyn gsyn
X_ihm_2_4 a_xp2 a_xn2 wp_wih_2_4 wn_wih_2_4 mhp4 mhn4 vdd vbsyn gsyn
X_ihx_2_4 a_xp2 a_xn2 wp_wih_2_4 wn_wih_2_4 xhp4 xhn4 vdd vbsyn gsyn
X_ihm_3_4 a_xp3 a_xn3 wp_wih_3_4 wn_wih_3_4 mhp4 mhn4 vdd vbsyn gsyn
X_ihx_3_4 a_xp3 a_xn3 wp_wih_3_4 wn_wih_3_4 xhp4 xhn4 vdd vbsyn gsyn
X_bk_4 eop eon wp_who_4 wn_who_4 xhp4 xhn4 vdd vbsyn gsyn
Xn4 xhp4 xhn4 ahp4 ahn4 vdd vbneu dneuron
Xeh4 xhp4 xhn4 mhp4 mhn4 ehp4 ehn4 vdd gm_h esub
Xcm_mh5 mhp5 mhn5 vdd cmld
Xcm_xh5 xhp5 xhn5 vdd cmld
Rnd_mh5 mhp5 mhn5 20k
Rnd_xh5 xhp5 xhn5 20k
Cxhp5 xhp5 0 0.4p
Cxhn5 xhn5 0 0.4p
X_ihm_1_5 a_xp1 a_xn1 wp_wih_1_5 wn_wih_1_5 mhp5 mhn5 vdd vbsyn gsyn
X_ihx_1_5 a_xp1 a_xn1 wp_wih_1_5 wn_wih_1_5 xhp5 xhn5 vdd vbsyn gsyn
X_ihm_2_5 a_xp2 a_xn2 wp_wih_2_5 wn_wih_2_5 mhp5 mhn5 vdd vbsyn gsyn
X_ihx_2_5 a_xp2 a_xn2 wp_wih_2_5 wn_wih_2_5 xhp5 xhn5 vdd vbsyn gsyn
X_ihm_3_5 a_xp3 a_xn3 wp_wih_3_5 wn_wih_3_5 mhp5 mhn5 vdd vbsyn gsyn
X_ihx_3_5 a_xp3 a_xn3 wp_wih_3_5 wn_wih_3_5 xhp5 xhn5 vdd vbsyn gsyn
X_bk_5 eop eon wp_who_5 wn_who_5 xhp5 xhn5 vdd vbsyn gsyn
Xn5 xhp5 xhn5 ahp5 ahn5 vdd vbneu dneuron
Xeh5 xhp5 xhn5 mhp5 mhn5 ehp5 ehn5 vdd gm_h esub
Xcm_mh6 mhp6 mhn6 vdd cmld
Xcm_xh6 xhp6 xhn6 vdd cmld
Rnd_mh6 mhp6 mhn6 20k
Rnd_xh6 xhp6 xhn6 20k
Cxhp6 xhp6 0 0.4p
Cxhn6 xhn6 0 0.4p
X_ihm_1_6 a_xp1 a_xn1 wp_wih_1_6 wn_wih_1_6 mhp6 mhn6 vdd vbsyn gsyn
X_ihx_1_6 a_xp1 a_xn1 wp_wih_1_6 wn_wih_1_6 xhp6 xhn6 vdd vbsyn gsyn
X_ihm_2_6 a_xp2 a_xn2 wp_wih_2_6 wn_wih_2_6 mhp6 mhn6 vdd vbsyn gsyn
X_ihx_2_6 a_xp2 a_xn2 wp_wih_2_6 wn_wih_2_6 xhp6 xhn6 vdd vbsyn gsyn
X_ihm_3_6 a_xp3 a_xn3 wp_wih_3_6 wn_wih_3_6 mhp6 mhn6 vdd vbsyn gsyn
X_ihx_3_6 a_xp3 a_xn3 wp_wih_3_6 wn_wih_3_6 xhp6 xhn6 vdd vbsyn gsyn
X_bk_6 eop eon wp_who_6 wn_who_6 xhp6 xhn6 vdd vbsyn gsyn
Xn6 xhp6 xhn6 ahp6 ahn6 vdd vbneu dneuron
Xeh6 xhp6 xhn6 mhp6 mhn6 ehp6 ehn6 vdd gm_h esub
Xcm_mh7 mhp7 mhn7 vdd cmld
Xcm_xh7 xhp7 xhn7 vdd cmld
Rnd_mh7 mhp7 mhn7 20k
Rnd_xh7 xhp7 xhn7 20k
Cxhp7 xhp7 0 0.4p
Cxhn7 xhn7 0 0.4p
X_ihm_1_7 a_xp1 a_xn1 wp_wih_1_7 wn_wih_1_7 mhp7 mhn7 vdd vbsyn gsyn
X_ihx_1_7 a_xp1 a_xn1 wp_wih_1_7 wn_wih_1_7 xhp7 xhn7 vdd vbsyn gsyn
X_ihm_2_7 a_xp2 a_xn2 wp_wih_2_7 wn_wih_2_7 mhp7 mhn7 vdd vbsyn gsyn
X_ihx_2_7 a_xp2 a_xn2 wp_wih_2_7 wn_wih_2_7 xhp7 xhn7 vdd vbsyn gsyn
X_ihm_3_7 a_xp3 a_xn3 wp_wih_3_7 wn_wih_3_7 mhp7 mhn7 vdd vbsyn gsyn
X_ihx_3_7 a_xp3 a_xn3 wp_wih_3_7 wn_wih_3_7 xhp7 xhn7 vdd vbsyn gsyn
X_bk_7 eop eon wp_who_7 wn_who_7 xhp7 xhn7 vdd vbsyn gsyn
Xn7 xhp7 xhn7 ahp7 ahn7 vdd vbneu dneuron
Xeh7 xhp7 xhn7 mhp7 mhn7 ehp7 ehn7 vdd gm_h esub
Xcm_mh8 mhp8 mhn8 vdd cmld
Xcm_xh8 xhp8 xhn8 vdd cmld
Rnd_mh8 mhp8 mhn8 20k
Rnd_xh8 xhp8 xhn8 20k
Cxhp8 xhp8 0 0.4p
Cxhn8 xhn8 0 0.4p
X_ihm_1_8 a_xp1 a_xn1 wp_wih_1_8 wn_wih_1_8 mhp8 mhn8 vdd vbsyn gsyn
X_ihx_1_8 a_xp1 a_xn1 wp_wih_1_8 wn_wih_1_8 xhp8 xhn8 vdd vbsyn gsyn
X_ihm_2_8 a_xp2 a_xn2 wp_wih_2_8 wn_wih_2_8 mhp8 mhn8 vdd vbsyn gsyn
X_ihx_2_8 a_xp2 a_xn2 wp_wih_2_8 wn_wih_2_8 xhp8 xhn8 vdd vbsyn gsyn
X_ihm_3_8 a_xp3 a_xn3 wp_wih_3_8 wn_wih_3_8 mhp8 mhn8 vdd vbsyn gsyn
X_ihx_3_8 a_xp3 a_xn3 wp_wih_3_8 wn_wih_3_8 xhp8 xhn8 vdd vbsyn gsyn
X_bk_8 eop eon wp_who_8 wn_who_8 xhp8 xhn8 vdd vbsyn gsyn
Xn8 xhp8 xhn8 ahp8 ahn8 vdd vbneu dneuron
Xeh8 xhp8 xhn8 mhp8 mhn8 ehp8 ehn8 vdd gm_h esub
Xcm_mh9 mhp9 mhn9 vdd cmld
Xcm_xh9 xhp9 xhn9 vdd cmld
Rnd_mh9 mhp9 mhn9 20k
Rnd_xh9 xhp9 xhn9 20k
Cxhp9 xhp9 0 0.4p
Cxhn9 xhn9 0 0.4p
X_ihm_1_9 a_xp1 a_xn1 wp_wih_1_9 wn_wih_1_9 mhp9 mhn9 vdd vbsyn gsyn
X_ihx_1_9 a_xp1 a_xn1 wp_wih_1_9 wn_wih_1_9 xhp9 xhn9 vdd vbsyn gsyn
X_ihm_2_9 a_xp2 a_xn2 wp_wih_2_9 wn_wih_2_9 mhp9 mhn9 vdd vbsyn gsyn
X_ihx_2_9 a_xp2 a_xn2 wp_wih_2_9 wn_wih_2_9 xhp9 xhn9 vdd vbsyn gsyn
X_ihm_3_9 a_xp3 a_xn3 wp_wih_3_9 wn_wih_3_9 mhp9 mhn9 vdd vbsyn gsyn
X_ihx_3_9 a_xp3 a_xn3 wp_wih_3_9 wn_wih_3_9 xhp9 xhn9 vdd vbsyn gsyn
X_bk_9 eop eon wp_who_9 wn_who_9 xhp9 xhn9 vdd vbsyn gsyn
Xn9 xhp9 xhn9 ahp9 ahn9 vdd vbneu dneuron
Xeh9 xhp9 xhn9 mhp9 mhn9 ehp9 ehn9 vdd gm_h esub
Xcm_mh10 mhp10 mhn10 vdd cmld
Xcm_xh10 xhp10 xhn10 vdd cmld
Rnd_mh10 mhp10 mhn10 20k
Rnd_xh10 xhp10 xhn10 20k
Cxhp10 xhp10 0 0.4p
Cxhn10 xhn10 0 0.4p
X_ihm_1_10 a_xp1 a_xn1 wp_wih_1_10 wn_wih_1_10 mhp10 mhn10 vdd vbsyn gsyn
X_ihx_1_10 a_xp1 a_xn1 wp_wih_1_10 wn_wih_1_10 xhp10 xhn10 vdd vbsyn gsyn
X_ihm_2_10 a_xp2 a_xn2 wp_wih_2_10 wn_wih_2_10 mhp10 mhn10 vdd vbsyn gsyn
X_ihx_2_10 a_xp2 a_xn2 wp_wih_2_10 wn_wih_2_10 xhp10 xhn10 vdd vbsyn gsyn
X_ihm_3_10 a_xp3 a_xn3 wp_wih_3_10 wn_wih_3_10 mhp10 mhn10 vdd vbsyn gsyn
X_ihx_3_10 a_xp3 a_xn3 wp_wih_3_10 wn_wih_3_10 xhp10 xhn10 vdd vbsyn gsyn
X_bk_10 eop eon wp_who_10 wn_who_10 xhp10 xhn10 vdd vbsyn gsyn
Xn10 xhp10 xhn10 ahp10 ahn10 vdd vbneu dneuron
Xeh10 xhp10 xhn10 mhp10 mhn10 ehp10 ehn10 vdd gm_h esub
Xcm_mh11 mhp11 mhn11 vdd cmld
Xcm_xh11 xhp11 xhn11 vdd cmld
Rnd_mh11 mhp11 mhn11 20k
Rnd_xh11 xhp11 xhn11 20k
Cxhp11 xhp11 0 0.4p
Cxhn11 xhn11 0 0.4p
X_ihm_1_11 a_xp1 a_xn1 wp_wih_1_11 wn_wih_1_11 mhp11 mhn11 vdd vbsyn gsyn
X_ihx_1_11 a_xp1 a_xn1 wp_wih_1_11 wn_wih_1_11 xhp11 xhn11 vdd vbsyn gsyn
X_ihm_2_11 a_xp2 a_xn2 wp_wih_2_11 wn_wih_2_11 mhp11 mhn11 vdd vbsyn gsyn
X_ihx_2_11 a_xp2 a_xn2 wp_wih_2_11 wn_wih_2_11 xhp11 xhn11 vdd vbsyn gsyn
X_ihm_3_11 a_xp3 a_xn3 wp_wih_3_11 wn_wih_3_11 mhp11 mhn11 vdd vbsyn gsyn
X_ihx_3_11 a_xp3 a_xn3 wp_wih_3_11 wn_wih_3_11 xhp11 xhn11 vdd vbsyn gsyn
X_bk_11 eop eon wp_who_11 wn_who_11 xhp11 xhn11 vdd vbsyn gsyn
Xn11 xhp11 xhn11 ahp11 ahn11 vdd vbneu dneuron
Xeh11 xhp11 xhn11 mhp11 mhn11 ehp11 ehn11 vdd gm_h esub
Xcm_mh12 mhp12 mhn12 vdd cmld
Xcm_xh12 xhp12 xhn12 vdd cmld
Rnd_mh12 mhp12 mhn12 20k
Rnd_xh12 xhp12 xhn12 20k
Cxhp12 xhp12 0 0.4p
Cxhn12 xhn12 0 0.4p
X_ihm_1_12 a_xp1 a_xn1 wp_wih_1_12 wn_wih_1_12 mhp12 mhn12 vdd vbsyn gsyn
X_ihx_1_12 a_xp1 a_xn1 wp_wih_1_12 wn_wih_1_12 xhp12 xhn12 vdd vbsyn gsyn
X_ihm_2_12 a_xp2 a_xn2 wp_wih_2_12 wn_wih_2_12 mhp12 mhn12 vdd vbsyn gsyn
X_ihx_2_12 a_xp2 a_xn2 wp_wih_2_12 wn_wih_2_12 xhp12 xhn12 vdd vbsyn gsyn
X_ihm_3_12 a_xp3 a_xn3 wp_wih_3_12 wn_wih_3_12 mhp12 mhn12 vdd vbsyn gsyn
X_ihx_3_12 a_xp3 a_xn3 wp_wih_3_12 wn_wih_3_12 xhp12 xhn12 vdd vbsyn gsyn
X_bk_12 eop eon wp_who_12 wn_who_12 xhp12 xhn12 vdd vbsyn gsyn
Xn12 xhp12 xhn12 ahp12 ahn12 vdd vbneu dneuron
Xeh12 xhp12 xhn12 mhp12 mhn12 ehp12 ehn12 vdd gm_h esub
Xcm_mh13 mhp13 mhn13 vdd cmld
Xcm_xh13 xhp13 xhn13 vdd cmld
Rnd_mh13 mhp13 mhn13 20k
Rnd_xh13 xhp13 xhn13 20k
Cxhp13 xhp13 0 0.4p
Cxhn13 xhn13 0 0.4p
X_ihm_1_13 a_xp1 a_xn1 wp_wih_1_13 wn_wih_1_13 mhp13 mhn13 vdd vbsyn gsyn
X_ihx_1_13 a_xp1 a_xn1 wp_wih_1_13 wn_wih_1_13 xhp13 xhn13 vdd vbsyn gsyn
X_ihm_2_13 a_xp2 a_xn2 wp_wih_2_13 wn_wih_2_13 mhp13 mhn13 vdd vbsyn gsyn
X_ihx_2_13 a_xp2 a_xn2 wp_wih_2_13 wn_wih_2_13 xhp13 xhn13 vdd vbsyn gsyn
X_ihm_3_13 a_xp3 a_xn3 wp_wih_3_13 wn_wih_3_13 mhp13 mhn13 vdd vbsyn gsyn
X_ihx_3_13 a_xp3 a_xn3 wp_wih_3_13 wn_wih_3_13 xhp13 xhn13 vdd vbsyn gsyn
X_bk_13 eop eon wp_who_13 wn_who_13 xhp13 xhn13 vdd vbsyn gsyn
Xn13 xhp13 xhn13 ahp13 ahn13 vdd vbneu dneuron
Xeh13 xhp13 xhn13 mhp13 mhn13 ehp13 ehn13 vdd gm_h esub
Xcm_mh14 mhp14 mhn14 vdd cmld
Xcm_xh14 xhp14 xhn14 vdd cmld
Rnd_mh14 mhp14 mhn14 20k
Rnd_xh14 xhp14 xhn14 20k
Cxhp14 xhp14 0 0.4p
Cxhn14 xhn14 0 0.4p
X_ihm_1_14 a_xp1 a_xn1 wp_wih_1_14 wn_wih_1_14 mhp14 mhn14 vdd vbsyn gsyn
X_ihx_1_14 a_xp1 a_xn1 wp_wih_1_14 wn_wih_1_14 xhp14 xhn14 vdd vbsyn gsyn
X_ihm_2_14 a_xp2 a_xn2 wp_wih_2_14 wn_wih_2_14 mhp14 mhn14 vdd vbsyn gsyn
X_ihx_2_14 a_xp2 a_xn2 wp_wih_2_14 wn_wih_2_14 xhp14 xhn14 vdd vbsyn gsyn
X_ihm_3_14 a_xp3 a_xn3 wp_wih_3_14 wn_wih_3_14 mhp14 mhn14 vdd vbsyn gsyn
X_ihx_3_14 a_xp3 a_xn3 wp_wih_3_14 wn_wih_3_14 xhp14 xhn14 vdd vbsyn gsyn
X_bk_14 eop eon wp_who_14 wn_who_14 xhp14 xhn14 vdd vbsyn gsyn
Xn14 xhp14 xhn14 ahp14 ahn14 vdd vbneu dneuron
Xeh14 xhp14 xhn14 mhp14 mhn14 ehp14 ehn14 vdd gm_h esub
Xcm_mh15 mhp15 mhn15 vdd cmld
Xcm_xh15 xhp15 xhn15 vdd cmld
Rnd_mh15 mhp15 mhn15 20k
Rnd_xh15 xhp15 xhn15 20k
Cxhp15 xhp15 0 0.4p
Cxhn15 xhn15 0 0.4p
X_ihm_1_15 a_xp1 a_xn1 wp_wih_1_15 wn_wih_1_15 mhp15 mhn15 vdd vbsyn gsyn
X_ihx_1_15 a_xp1 a_xn1 wp_wih_1_15 wn_wih_1_15 xhp15 xhn15 vdd vbsyn gsyn
X_ihm_2_15 a_xp2 a_xn2 wp_wih_2_15 wn_wih_2_15 mhp15 mhn15 vdd vbsyn gsyn
X_ihx_2_15 a_xp2 a_xn2 wp_wih_2_15 wn_wih_2_15 xhp15 xhn15 vdd vbsyn gsyn
X_ihm_3_15 a_xp3 a_xn3 wp_wih_3_15 wn_wih_3_15 mhp15 mhn15 vdd vbsyn gsyn
X_ihx_3_15 a_xp3 a_xn3 wp_wih_3_15 wn_wih_3_15 xhp15 xhn15 vdd vbsyn gsyn
X_bk_15 eop eon wp_who_15 wn_who_15 xhp15 xhn15 vdd vbsyn gsyn
Xn15 xhp15 xhn15 ahp15 ahn15 vdd vbneu dneuron
Xeh15 xhp15 xhn15 mhp15 mhn15 ehp15 ehn15 vdd gm_h esub
Xcm_mh16 mhp16 mhn16 vdd cmld
Xcm_xh16 xhp16 xhn16 vdd cmld
Rnd_mh16 mhp16 mhn16 20k
Rnd_xh16 xhp16 xhn16 20k
Cxhp16 xhp16 0 0.4p
Cxhn16 xhn16 0 0.4p
X_ihm_1_16 a_xp1 a_xn1 wp_wih_1_16 wn_wih_1_16 mhp16 mhn16 vdd vbsyn gsyn
X_ihx_1_16 a_xp1 a_xn1 wp_wih_1_16 wn_wih_1_16 xhp16 xhn16 vdd vbsyn gsyn
X_ihm_2_16 a_xp2 a_xn2 wp_wih_2_16 wn_wih_2_16 mhp16 mhn16 vdd vbsyn gsyn
X_ihx_2_16 a_xp2 a_xn2 wp_wih_2_16 wn_wih_2_16 xhp16 xhn16 vdd vbsyn gsyn
X_ihm_3_16 a_xp3 a_xn3 wp_wih_3_16 wn_wih_3_16 mhp16 mhn16 vdd vbsyn gsyn
X_ihx_3_16 a_xp3 a_xn3 wp_wih_3_16 wn_wih_3_16 xhp16 xhn16 vdd vbsyn gsyn
X_bk_16 eop eon wp_who_16 wn_who_16 xhp16 xhn16 vdd vbsyn gsyn
Xn16 xhp16 xhn16 ahp16 ahn16 vdd vbneu dneuron
Xeh16 xhp16 xhn16 mhp16 mhn16 ehp16 ehn16 vdd gm_h esub
Xcm_mh17 mhp17 mhn17 vdd cmld
Xcm_xh17 xhp17 xhn17 vdd cmld
Rnd_mh17 mhp17 mhn17 20k
Rnd_xh17 xhp17 xhn17 20k
Cxhp17 xhp17 0 0.4p
Cxhn17 xhn17 0 0.4p
X_ihm_1_17 a_xp1 a_xn1 wp_wih_1_17 wn_wih_1_17 mhp17 mhn17 vdd vbsyn gsyn
X_ihx_1_17 a_xp1 a_xn1 wp_wih_1_17 wn_wih_1_17 xhp17 xhn17 vdd vbsyn gsyn
X_ihm_2_17 a_xp2 a_xn2 wp_wih_2_17 wn_wih_2_17 mhp17 mhn17 vdd vbsyn gsyn
X_ihx_2_17 a_xp2 a_xn2 wp_wih_2_17 wn_wih_2_17 xhp17 xhn17 vdd vbsyn gsyn
X_ihm_3_17 a_xp3 a_xn3 wp_wih_3_17 wn_wih_3_17 mhp17 mhn17 vdd vbsyn gsyn
X_ihx_3_17 a_xp3 a_xn3 wp_wih_3_17 wn_wih_3_17 xhp17 xhn17 vdd vbsyn gsyn
X_bk_17 eop eon wp_who_17 wn_who_17 xhp17 xhn17 vdd vbsyn gsyn
Xn17 xhp17 xhn17 ahp17 ahn17 vdd vbneu dneuron
Xeh17 xhp17 xhn17 mhp17 mhn17 ehp17 ehn17 vdd gm_h esub
Xcm_mh18 mhp18 mhn18 vdd cmld
Xcm_xh18 xhp18 xhn18 vdd cmld
Rnd_mh18 mhp18 mhn18 20k
Rnd_xh18 xhp18 xhn18 20k
Cxhp18 xhp18 0 0.4p
Cxhn18 xhn18 0 0.4p
X_ihm_1_18 a_xp1 a_xn1 wp_wih_1_18 wn_wih_1_18 mhp18 mhn18 vdd vbsyn gsyn
X_ihx_1_18 a_xp1 a_xn1 wp_wih_1_18 wn_wih_1_18 xhp18 xhn18 vdd vbsyn gsyn
X_ihm_2_18 a_xp2 a_xn2 wp_wih_2_18 wn_wih_2_18 mhp18 mhn18 vdd vbsyn gsyn
X_ihx_2_18 a_xp2 a_xn2 wp_wih_2_18 wn_wih_2_18 xhp18 xhn18 vdd vbsyn gsyn
X_ihm_3_18 a_xp3 a_xn3 wp_wih_3_18 wn_wih_3_18 mhp18 mhn18 vdd vbsyn gsyn
X_ihx_3_18 a_xp3 a_xn3 wp_wih_3_18 wn_wih_3_18 xhp18 xhn18 vdd vbsyn gsyn
X_bk_18 eop eon wp_who_18 wn_who_18 xhp18 xhn18 vdd vbsyn gsyn
Xn18 xhp18 xhn18 ahp18 ahn18 vdd vbneu dneuron
Xeh18 xhp18 xhn18 mhp18 mhn18 ehp18 ehn18 vdd gm_h esub
Xcm_mh19 mhp19 mhn19 vdd cmld
Xcm_xh19 xhp19 xhn19 vdd cmld
Rnd_mh19 mhp19 mhn19 20k
Rnd_xh19 xhp19 xhn19 20k
Cxhp19 xhp19 0 0.4p
Cxhn19 xhn19 0 0.4p
X_ihm_1_19 a_xp1 a_xn1 wp_wih_1_19 wn_wih_1_19 mhp19 mhn19 vdd vbsyn gsyn
X_ihx_1_19 a_xp1 a_xn1 wp_wih_1_19 wn_wih_1_19 xhp19 xhn19 vdd vbsyn gsyn
X_ihm_2_19 a_xp2 a_xn2 wp_wih_2_19 wn_wih_2_19 mhp19 mhn19 vdd vbsyn gsyn
X_ihx_2_19 a_xp2 a_xn2 wp_wih_2_19 wn_wih_2_19 xhp19 xhn19 vdd vbsyn gsyn
X_ihm_3_19 a_xp3 a_xn3 wp_wih_3_19 wn_wih_3_19 mhp19 mhn19 vdd vbsyn gsyn
X_ihx_3_19 a_xp3 a_xn3 wp_wih_3_19 wn_wih_3_19 xhp19 xhn19 vdd vbsyn gsyn
X_bk_19 eop eon wp_who_19 wn_who_19 xhp19 xhn19 vdd vbsyn gsyn
Xn19 xhp19 xhn19 ahp19 ahn19 vdd vbneu dneuron
Xeh19 xhp19 xhn19 mhp19 mhn19 ehp19 ehn19 vdd gm_h esub
Xcm_mh20 mhp20 mhn20 vdd cmld
Xcm_xh20 xhp20 xhn20 vdd cmld
Rnd_mh20 mhp20 mhn20 20k
Rnd_xh20 xhp20 xhn20 20k
Cxhp20 xhp20 0 0.4p
Cxhn20 xhn20 0 0.4p
X_ihm_1_20 a_xp1 a_xn1 wp_wih_1_20 wn_wih_1_20 mhp20 mhn20 vdd vbsyn gsyn
X_ihx_1_20 a_xp1 a_xn1 wp_wih_1_20 wn_wih_1_20 xhp20 xhn20 vdd vbsyn gsyn
X_ihm_2_20 a_xp2 a_xn2 wp_wih_2_20 wn_wih_2_20 mhp20 mhn20 vdd vbsyn gsyn
X_ihx_2_20 a_xp2 a_xn2 wp_wih_2_20 wn_wih_2_20 xhp20 xhn20 vdd vbsyn gsyn
X_ihm_3_20 a_xp3 a_xn3 wp_wih_3_20 wn_wih_3_20 mhp20 mhn20 vdd vbsyn gsyn
X_ihx_3_20 a_xp3 a_xn3 wp_wih_3_20 wn_wih_3_20 xhp20 xhn20 vdd vbsyn gsyn
X_bk_20 eop eon wp_who_20 wn_who_20 xhp20 xhn20 vdd vbsyn gsyn
Xn20 xhp20 xhn20 ahp20 ahn20 vdd vbneu dneuron
Xeh20 xhp20 xhn20 mhp20 mhn20 ehp20 ehn20 vdd gm_h esub
Xcm_mh21 mhp21 mhn21 vdd cmld
Xcm_xh21 xhp21 xhn21 vdd cmld
Rnd_mh21 mhp21 mhn21 20k
Rnd_xh21 xhp21 xhn21 20k
Cxhp21 xhp21 0 0.4p
Cxhn21 xhn21 0 0.4p
X_ihm_1_21 a_xp1 a_xn1 wp_wih_1_21 wn_wih_1_21 mhp21 mhn21 vdd vbsyn gsyn
X_ihx_1_21 a_xp1 a_xn1 wp_wih_1_21 wn_wih_1_21 xhp21 xhn21 vdd vbsyn gsyn
X_ihm_2_21 a_xp2 a_xn2 wp_wih_2_21 wn_wih_2_21 mhp21 mhn21 vdd vbsyn gsyn
X_ihx_2_21 a_xp2 a_xn2 wp_wih_2_21 wn_wih_2_21 xhp21 xhn21 vdd vbsyn gsyn
X_ihm_3_21 a_xp3 a_xn3 wp_wih_3_21 wn_wih_3_21 mhp21 mhn21 vdd vbsyn gsyn
X_ihx_3_21 a_xp3 a_xn3 wp_wih_3_21 wn_wih_3_21 xhp21 xhn21 vdd vbsyn gsyn
X_bk_21 eop eon wp_who_21 wn_who_21 xhp21 xhn21 vdd vbsyn gsyn
Xn21 xhp21 xhn21 ahp21 ahn21 vdd vbneu dneuron
Xeh21 xhp21 xhn21 mhp21 mhn21 ehp21 ehn21 vdd gm_h esub
Xcm_mh22 mhp22 mhn22 vdd cmld
Xcm_xh22 xhp22 xhn22 vdd cmld
Rnd_mh22 mhp22 mhn22 20k
Rnd_xh22 xhp22 xhn22 20k
Cxhp22 xhp22 0 0.4p
Cxhn22 xhn22 0 0.4p
X_ihm_1_22 a_xp1 a_xn1 wp_wih_1_22 wn_wih_1_22 mhp22 mhn22 vdd vbsyn gsyn
X_ihx_1_22 a_xp1 a_xn1 wp_wih_1_22 wn_wih_1_22 xhp22 xhn22 vdd vbsyn gsyn
X_ihm_2_22 a_xp2 a_xn2 wp_wih_2_22 wn_wih_2_22 mhp22 mhn22 vdd vbsyn gsyn
X_ihx_2_22 a_xp2 a_xn2 wp_wih_2_22 wn_wih_2_22 xhp22 xhn22 vdd vbsyn gsyn
X_ihm_3_22 a_xp3 a_xn3 wp_wih_3_22 wn_wih_3_22 mhp22 mhn22 vdd vbsyn gsyn
X_ihx_3_22 a_xp3 a_xn3 wp_wih_3_22 wn_wih_3_22 xhp22 xhn22 vdd vbsyn gsyn
X_bk_22 eop eon wp_who_22 wn_who_22 xhp22 xhn22 vdd vbsyn gsyn
Xn22 xhp22 xhn22 ahp22 ahn22 vdd vbneu dneuron
Xeh22 xhp22 xhn22 mhp22 mhn22 ehp22 ehn22 vdd gm_h esub
Xcm_mh23 mhp23 mhn23 vdd cmld
Xcm_xh23 xhp23 xhn23 vdd cmld
Rnd_mh23 mhp23 mhn23 20k
Rnd_xh23 xhp23 xhn23 20k
Cxhp23 xhp23 0 0.4p
Cxhn23 xhn23 0 0.4p
X_ihm_1_23 a_xp1 a_xn1 wp_wih_1_23 wn_wih_1_23 mhp23 mhn23 vdd vbsyn gsyn
X_ihx_1_23 a_xp1 a_xn1 wp_wih_1_23 wn_wih_1_23 xhp23 xhn23 vdd vbsyn gsyn
X_ihm_2_23 a_xp2 a_xn2 wp_wih_2_23 wn_wih_2_23 mhp23 mhn23 vdd vbsyn gsyn
X_ihx_2_23 a_xp2 a_xn2 wp_wih_2_23 wn_wih_2_23 xhp23 xhn23 vdd vbsyn gsyn
X_ihm_3_23 a_xp3 a_xn3 wp_wih_3_23 wn_wih_3_23 mhp23 mhn23 vdd vbsyn gsyn
X_ihx_3_23 a_xp3 a_xn3 wp_wih_3_23 wn_wih_3_23 xhp23 xhn23 vdd vbsyn gsyn
X_bk_23 eop eon wp_who_23 wn_who_23 xhp23 xhn23 vdd vbsyn gsyn
Xn23 xhp23 xhn23 ahp23 ahn23 vdd vbneu dneuron
Xeh23 xhp23 xhn23 mhp23 mhn23 ehp23 ehn23 vdd gm_h esub
Xcm_mo mop mon vdd cmld
Rnd_mo mop mon 20k
X_ho_0 ahp0 ahn0 wp_who_0 wn_who_0 mop mon vdd vbsyn gsyn
X_ho_1 ahp1 ahn1 wp_who_1 wn_who_1 mop mon vdd vbsyn gsyn
X_ho_2 ahp2 ahn2 wp_who_2 wn_who_2 mop mon vdd vbsyn gsyn
X_ho_3 ahp3 ahn3 wp_who_3 wn_who_3 mop mon vdd vbsyn gsyn
X_ho_4 ahp4 ahn4 wp_who_4 wn_who_4 mop mon vdd vbsyn gsyn
X_ho_5 ahp5 ahn5 wp_who_5 wn_who_5 mop mon vdd vbsyn gsyn
X_ho_6 ahp6 ahn6 wp_who_6 wn_who_6 mop mon vdd vbsyn gsyn
X_ho_7 ahp7 ahn7 wp_who_7 wn_who_7 mop mon vdd vbsyn gsyn
X_ho_8 ahp8 ahn8 wp_who_8 wn_who_8 mop mon vdd vbsyn gsyn
X_ho_9 ahp9 ahn9 wp_who_9 wn_who_9 mop mon vdd vbsyn gsyn
X_ho_10 ahp10 ahn10 wp_who_10 wn_who_10 mop mon vdd vbsyn gsyn
X_ho_11 ahp11 ahn11 wp_who_11 wn_who_11 mop mon vdd vbsyn gsyn
X_ho_12 ahp12 ahn12 wp_who_12 wn_who_12 mop mon vdd vbsyn gsyn
X_ho_13 ahp13 ahn13 wp_who_13 wn_who_13 mop mon vdd vbsyn gsyn
X_ho_14 ahp14 ahn14 wp_who_14 wn_who_14 mop mon vdd vbsyn gsyn
X_ho_15 ahp15 ahn15 wp_who_15 wn_who_15 mop mon vdd vbsyn gsyn
X_ho_16 ahp16 ahn16 wp_who_16 wn_who_16 mop mon vdd vbsyn gsyn
X_ho_17 ahp17 ahn17 wp_who_17 wn_who_17 mop mon vdd vbsyn gsyn
X_ho_18 ahp18 ahn18 wp_who_18 wn_who_18 mop mon vdd vbsyn gsyn
X_ho_19 ahp19 ahn19 wp_who_19 wn_who_19 mop mon vdd vbsyn gsyn
X_ho_20 ahp20 ahn20 wp_who_20 wn_who_20 mop mon vdd vbsyn gsyn
X_ho_21 ahp21 ahn21 wp_who_21 wn_who_21 mop mon vdd vbsyn gsyn
X_ho_22 ahp22 ahn22 wp_who_22 wn_who_22 mop mon vdd vbsyn gsyn
X_ho_23 ahp23 ahn23 wp_who_23 wn_who_23 mop mon vdd vbsyn gsyn
Xeo xop xon mop mon eop eon vdd gm_o esub
Xcm_mo2 mop2 mon2 vdd cmld
Rnd_mo2 mop2 mon2 20k
X_ho2_0 ahp0 ahn0 wp_who_0 wn_who_0 mop2 mon2 vdd vbsyn gsyn
X_ho2_1 ahp1 ahn1 wp_who_1 wn_who_1 mop2 mon2 vdd vbsyn gsyn
X_ho2_2 ahp2 ahn2 wp_who_2 wn_who_2 mop2 mon2 vdd vbsyn gsyn
X_ho2_3 ahp3 ahn3 wp_who_3 wn_who_3 mop2 mon2 vdd vbsyn gsyn
X_ho2_4 ahp4 ahn4 wp_who_4 wn_who_4 mop2 mon2 vdd vbsyn gsyn
X_ho2_5 ahp5 ahn5 wp_who_5 wn_who_5 mop2 mon2 vdd vbsyn gsyn
X_ho2_6 ahp6 ahn6 wp_who_6 wn_who_6 mop2 mon2 vdd vbsyn gsyn
X_ho2_7 ahp7 ahn7 wp_who_7 wn_who_7 mop2 mon2 vdd vbsyn gsyn
X_ho2_8 ahp8 ahn8 wp_who_8 wn_who_8 mop2 mon2 vdd vbsyn gsyn
X_ho2_9 ahp9 ahn9 wp_who_9 wn_who_9 mop2 mon2 vdd vbsyn gsyn
X_ho2_10 ahp10 ahn10 wp_who_10 wn_who_10 mop2 mon2 vdd vbsyn gsyn
X_ho2_11 ahp11 ahn11 wp_who_11 wn_who_11 mop2 mon2 vdd vbsyn gsyn
X_ho2_12 ahp12 ahn12 wp_who_12 wn_who_12 mop2 mon2 vdd vbsyn gsyn
X_ho2_13 ahp13 ahn13 wp_who_13 wn_who_13 mop2 mon2 vdd vbsyn gsyn
X_ho2_14 ahp14 ahn14 wp_who_14 wn_who_14 mop2 mon2 vdd vbsyn gsyn
X_ho2_15 ahp15 ahn15 wp_who_15 wn_who_15 mop2 mon2 vdd vbsyn gsyn
X_ho2_16 ahp16 ahn16 wp_who_16 wn_who_16 mop2 mon2 vdd vbsyn gsyn
X_ho2_17 ahp17 ahn17 wp_who_17 wn_who_17 mop2 mon2 vdd vbsyn gsyn
X_ho2_18 ahp18 ahn18 wp_who_18 wn_who_18 mop2 mon2 vdd vbsyn gsyn
X_ho2_19 ahp19 ahn19 wp_who_19 wn_who_19 mop2 mon2 vdd vbsyn gsyn
X_ho2_20 ahp20 ahn20 wp_who_20 wn_who_20 mop2 mon2 vdd vbsyn gsyn
X_ho2_21 ahp21 ahn21 wp_who_21 wn_who_21 mop2 mon2 vdd vbsyn gsyn
X_ho2_22 ahp22 ahn22 wp_who_22 wn_who_22 mop2 mon2 vdd vbsyn gsyn
X_ho2_23 ahp23 ahn23 wp_who_23 wn_who_23 mop2 mon2 vdd vbsyn gsyn
Xlih_1_0 ehp0 ehn0 a_xp1 a_xn1 wp_wih_1_0 wn_wih_1_0 vdd gblh gprod
Xlih_2_0 ehp0 ehn0 a_xp2 a_xn2 wp_wih_2_0 wn_wih_2_0 vdd gblh gprod
Xlih_3_0 ehp0 ehn0 a_xp3 a_xn3 wp_wih_3_0 wn_wih_3_0 vdd gblh gprod
Xlho_0 eop eon ahp0 ahn0 wp_who_0 wn_who_0 vdd gblo gprod
Xlih_1_1 ehp1 ehn1 a_xp1 a_xn1 wp_wih_1_1 wn_wih_1_1 vdd gblh gprod
Xlih_2_1 ehp1 ehn1 a_xp2 a_xn2 wp_wih_2_1 wn_wih_2_1 vdd gblh gprod
Xlih_3_1 ehp1 ehn1 a_xp3 a_xn3 wp_wih_3_1 wn_wih_3_1 vdd gblh gprod
Xlho_1 eop eon ahp1 ahn1 wp_who_1 wn_who_1 vdd gblo gprod
Xlih_1_2 ehp2 ehn2 a_xp1 a_xn1 wp_wih_1_2 wn_wih_1_2 vdd gblh gprod
Xlih_2_2 ehp2 ehn2 a_xp2 a_xn2 wp_wih_2_2 wn_wih_2_2 vdd gblh gprod
Xlih_3_2 ehp2 ehn2 a_xp3 a_xn3 wp_wih_3_2 wn_wih_3_2 vdd gblh gprod
Xlho_2 eop eon ahp2 ahn2 wp_who_2 wn_who_2 vdd gblo gprod
Xlih_1_3 ehp3 ehn3 a_xp1 a_xn1 wp_wih_1_3 wn_wih_1_3 vdd gblh gprod
Xlih_2_3 ehp3 ehn3 a_xp2 a_xn2 wp_wih_2_3 wn_wih_2_3 vdd gblh gprod
Xlih_3_3 ehp3 ehn3 a_xp3 a_xn3 wp_wih_3_3 wn_wih_3_3 vdd gblh gprod
Xlho_3 eop eon ahp3 ahn3 wp_who_3 wn_who_3 vdd gblo gprod
Xlih_1_4 ehp4 ehn4 a_xp1 a_xn1 wp_wih_1_4 wn_wih_1_4 vdd gblh gprod
Xlih_2_4 ehp4 ehn4 a_xp2 a_xn2 wp_wih_2_4 wn_wih_2_4 vdd gblh gprod
Xlih_3_4 ehp4 ehn4 a_xp3 a_xn3 wp_wih_3_4 wn_wih_3_4 vdd gblh gprod
Xlho_4 eop eon ahp4 ahn4 wp_who_4 wn_who_4 vdd gblo gprod
Xlih_1_5 ehp5 ehn5 a_xp1 a_xn1 wp_wih_1_5 wn_wih_1_5 vdd gblh gprod
Xlih_2_5 ehp5 ehn5 a_xp2 a_xn2 wp_wih_2_5 wn_wih_2_5 vdd gblh gprod
Xlih_3_5 ehp5 ehn5 a_xp3 a_xn3 wp_wih_3_5 wn_wih_3_5 vdd gblh gprod
Xlho_5 eop eon ahp5 ahn5 wp_who_5 wn_who_5 vdd gblo gprod
Xlih_1_6 ehp6 ehn6 a_xp1 a_xn1 wp_wih_1_6 wn_wih_1_6 vdd gblh gprod
Xlih_2_6 ehp6 ehn6 a_xp2 a_xn2 wp_wih_2_6 wn_wih_2_6 vdd gblh gprod
Xlih_3_6 ehp6 ehn6 a_xp3 a_xn3 wp_wih_3_6 wn_wih_3_6 vdd gblh gprod
Xlho_6 eop eon ahp6 ahn6 wp_who_6 wn_who_6 vdd gblo gprod
Xlih_1_7 ehp7 ehn7 a_xp1 a_xn1 wp_wih_1_7 wn_wih_1_7 vdd gblh gprod
Xlih_2_7 ehp7 ehn7 a_xp2 a_xn2 wp_wih_2_7 wn_wih_2_7 vdd gblh gprod
Xlih_3_7 ehp7 ehn7 a_xp3 a_xn3 wp_wih_3_7 wn_wih_3_7 vdd gblh gprod
Xlho_7 eop eon ahp7 ahn7 wp_who_7 wn_who_7 vdd gblo gprod
Xlih_1_8 ehp8 ehn8 a_xp1 a_xn1 wp_wih_1_8 wn_wih_1_8 vdd gblh gprod
Xlih_2_8 ehp8 ehn8 a_xp2 a_xn2 wp_wih_2_8 wn_wih_2_8 vdd gblh gprod
Xlih_3_8 ehp8 ehn8 a_xp3 a_xn3 wp_wih_3_8 wn_wih_3_8 vdd gblh gprod
Xlho_8 eop eon ahp8 ahn8 wp_who_8 wn_who_8 vdd gblo gprod
Xlih_1_9 ehp9 ehn9 a_xp1 a_xn1 wp_wih_1_9 wn_wih_1_9 vdd gblh gprod
Xlih_2_9 ehp9 ehn9 a_xp2 a_xn2 wp_wih_2_9 wn_wih_2_9 vdd gblh gprod
Xlih_3_9 ehp9 ehn9 a_xp3 a_xn3 wp_wih_3_9 wn_wih_3_9 vdd gblh gprod
Xlho_9 eop eon ahp9 ahn9 wp_who_9 wn_who_9 vdd gblo gprod
Xlih_1_10 ehp10 ehn10 a_xp1 a_xn1 wp_wih_1_10 wn_wih_1_10 vdd gblh gprod
Xlih_2_10 ehp10 ehn10 a_xp2 a_xn2 wp_wih_2_10 wn_wih_2_10 vdd gblh gprod
Xlih_3_10 ehp10 ehn10 a_xp3 a_xn3 wp_wih_3_10 wn_wih_3_10 vdd gblh gprod
Xlho_10 eop eon ahp10 ahn10 wp_who_10 wn_who_10 vdd gblo gprod
Xlih_1_11 ehp11 ehn11 a_xp1 a_xn1 wp_wih_1_11 wn_wih_1_11 vdd gblh gprod
Xlih_2_11 ehp11 ehn11 a_xp2 a_xn2 wp_wih_2_11 wn_wih_2_11 vdd gblh gprod
Xlih_3_11 ehp11 ehn11 a_xp3 a_xn3 wp_wih_3_11 wn_wih_3_11 vdd gblh gprod
Xlho_11 eop eon ahp11 ahn11 wp_who_11 wn_who_11 vdd gblo gprod
Xlih_1_12 ehp12 ehn12 a_xp1 a_xn1 wp_wih_1_12 wn_wih_1_12 vdd gblh gprod
Xlih_2_12 ehp12 ehn12 a_xp2 a_xn2 wp_wih_2_12 wn_wih_2_12 vdd gblh gprod
Xlih_3_12 ehp12 ehn12 a_xp3 a_xn3 wp_wih_3_12 wn_wih_3_12 vdd gblh gprod
Xlho_12 eop eon ahp12 ahn12 wp_who_12 wn_who_12 vdd gblo gprod
Xlih_1_13 ehp13 ehn13 a_xp1 a_xn1 wp_wih_1_13 wn_wih_1_13 vdd gblh gprod
Xlih_2_13 ehp13 ehn13 a_xp2 a_xn2 wp_wih_2_13 wn_wih_2_13 vdd gblh gprod
Xlih_3_13 ehp13 ehn13 a_xp3 a_xn3 wp_wih_3_13 wn_wih_3_13 vdd gblh gprod
Xlho_13 eop eon ahp13 ahn13 wp_who_13 wn_who_13 vdd gblo gprod
Xlih_1_14 ehp14 ehn14 a_xp1 a_xn1 wp_wih_1_14 wn_wih_1_14 vdd gblh gprod
Xlih_2_14 ehp14 ehn14 a_xp2 a_xn2 wp_wih_2_14 wn_wih_2_14 vdd gblh gprod
Xlih_3_14 ehp14 ehn14 a_xp3 a_xn3 wp_wih_3_14 wn_wih_3_14 vdd gblh gprod
Xlho_14 eop eon ahp14 ahn14 wp_who_14 wn_who_14 vdd gblo gprod
Xlih_1_15 ehp15 ehn15 a_xp1 a_xn1 wp_wih_1_15 wn_wih_1_15 vdd gblh gprod
Xlih_2_15 ehp15 ehn15 a_xp2 a_xn2 wp_wih_2_15 wn_wih_2_15 vdd gblh gprod
Xlih_3_15 ehp15 ehn15 a_xp3 a_xn3 wp_wih_3_15 wn_wih_3_15 vdd gblh gprod
Xlho_15 eop eon ahp15 ahn15 wp_who_15 wn_who_15 vdd gblo gprod
Xlih_1_16 ehp16 ehn16 a_xp1 a_xn1 wp_wih_1_16 wn_wih_1_16 vdd gblh gprod
Xlih_2_16 ehp16 ehn16 a_xp2 a_xn2 wp_wih_2_16 wn_wih_2_16 vdd gblh gprod
Xlih_3_16 ehp16 ehn16 a_xp3 a_xn3 wp_wih_3_16 wn_wih_3_16 vdd gblh gprod
Xlho_16 eop eon ahp16 ahn16 wp_who_16 wn_who_16 vdd gblo gprod
Xlih_1_17 ehp17 ehn17 a_xp1 a_xn1 wp_wih_1_17 wn_wih_1_17 vdd gblh gprod
Xlih_2_17 ehp17 ehn17 a_xp2 a_xn2 wp_wih_2_17 wn_wih_2_17 vdd gblh gprod
Xlih_3_17 ehp17 ehn17 a_xp3 a_xn3 wp_wih_3_17 wn_wih_3_17 vdd gblh gprod
Xlho_17 eop eon ahp17 ahn17 wp_who_17 wn_who_17 vdd gblo gprod
Xlih_1_18 ehp18 ehn18 a_xp1 a_xn1 wp_wih_1_18 wn_wih_1_18 vdd gblh gprod
Xlih_2_18 ehp18 ehn18 a_xp2 a_xn2 wp_wih_2_18 wn_wih_2_18 vdd gblh gprod
Xlih_3_18 ehp18 ehn18 a_xp3 a_xn3 wp_wih_3_18 wn_wih_3_18 vdd gblh gprod
Xlho_18 eop eon ahp18 ahn18 wp_who_18 wn_who_18 vdd gblo gprod
Xlih_1_19 ehp19 ehn19 a_xp1 a_xn1 wp_wih_1_19 wn_wih_1_19 vdd gblh gprod
Xlih_2_19 ehp19 ehn19 a_xp2 a_xn2 wp_wih_2_19 wn_wih_2_19 vdd gblh gprod
Xlih_3_19 ehp19 ehn19 a_xp3 a_xn3 wp_wih_3_19 wn_wih_3_19 vdd gblh gprod
Xlho_19 eop eon ahp19 ahn19 wp_who_19 wn_who_19 vdd gblo gprod
Xlih_1_20 ehp20 ehn20 a_xp1 a_xn1 wp_wih_1_20 wn_wih_1_20 vdd gblh gprod
Xlih_2_20 ehp20 ehn20 a_xp2 a_xn2 wp_wih_2_20 wn_wih_2_20 vdd gblh gprod
Xlih_3_20 ehp20 ehn20 a_xp3 a_xn3 wp_wih_3_20 wn_wih_3_20 vdd gblh gprod
Xlho_20 eop eon ahp20 ahn20 wp_who_20 wn_who_20 vdd gblo gprod
Xlih_1_21 ehp21 ehn21 a_xp1 a_xn1 wp_wih_1_21 wn_wih_1_21 vdd gblh gprod
Xlih_2_21 ehp21 ehn21 a_xp2 a_xn2 wp_wih_2_21 wn_wih_2_21 vdd gblh gprod
Xlih_3_21 ehp21 ehn21 a_xp3 a_xn3 wp_wih_3_21 wn_wih_3_21 vdd gblh gprod
Xlho_21 eop eon ahp21 ahn21 wp_who_21 wn_who_21 vdd gblo gprod
Xlih_1_22 ehp22 ehn22 a_xp1 a_xn1 wp_wih_1_22 wn_wih_1_22 vdd gblh gprod
Xlih_2_22 ehp22 ehn22 a_xp2 a_xn2 wp_wih_2_22 wn_wih_2_22 vdd gblh gprod
Xlih_3_22 ehp22 ehn22 a_xp3 a_xn3 wp_wih_3_22 wn_wih_3_22 vdd gblh gprod
Xlho_22 eop eon ahp22 ahn22 wp_who_22 wn_who_22 vdd gblo gprod
Xlih_1_23 ehp23 ehn23 a_xp1 a_xn1 wp_wih_1_23 wn_wih_1_23 vdd gblh gprod
Xlih_2_23 ehp23 ehn23 a_xp2 a_xn2 wp_wih_2_23 wn_wih_2_23 vdd gblh gprod
Xlih_3_23 ehp23 ehn23 a_xp3 a_xn3 wp_wih_3_23 wn_wih_3_23 vdd gblh gprod
Xlho_23 eop eon ahp23 ahn23 wp_who_23 wn_who_23 vdd gblo gprod
.ic v(wp_wih_1_0)=0.6382 v(wn_wih_1_0)=0.3618
.ic v(wp_wih_2_0)=0.8286 v(wn_wih_2_0)=0.1714
.ic v(wp_wih_3_0)=0.6322 v(wn_wih_3_0)=0.3678
.ic v(wp_who_0)=0.1500 v(wn_who_0)=0.9500
.ic v(wp_wih_1_1)=0.8621 v(wn_wih_1_1)=0.1500
.ic v(wp_wih_2_1)=0.6785 v(wn_wih_2_1)=0.3215
.ic v(wp_wih_3_1)=0.2852 v(wn_wih_3_1)=0.7148
.ic v(wp_who_1)=0.7324 v(wn_who_1)=0.2676
.ic v(wp_wih_1_2)=0.6458 v(wn_wih_1_2)=0.3542
.ic v(wp_wih_2_2)=0.6177 v(wn_wih_2_2)=0.3823
.ic v(wp_wih_3_2)=0.5114 v(wn_wih_3_2)=0.4886
.ic v(wp_who_2)=0.7187 v(wn_who_2)=0.2813
.ic v(wp_wih_1_3)=0.2054 v(wn_wih_1_3)=0.7946
.ic v(wp_wih_2_3)=0.4348 v(wn_wih_2_3)=0.5652
.ic v(wp_wih_3_3)=0.3072 v(wn_wih_3_3)=0.6928
.ic v(wp_who_3)=0.7395 v(wn_who_3)=0.2605
.ic v(wp_wih_1_4)=0.5159 v(wn_wih_1_4)=0.4841
.ic v(wp_wih_2_4)=0.3830 v(wn_wih_2_4)=0.6170
.ic v(wp_wih_3_4)=0.1872 v(wn_wih_3_4)=0.8128
.ic v(wp_who_4)=0.3971 v(wn_who_4)=0.6029
.ic v(wp_wih_1_5)=0.5033 v(wn_wih_1_5)=0.4967
.ic v(wp_wih_2_5)=0.3898 v(wn_wih_2_5)=0.6102
.ic v(wp_wih_3_5)=0.9500 v(wn_wih_3_5)=0.1500
.ic v(wp_who_5)=0.9027 v(wn_who_5)=0.1500
.ic v(wp_wih_1_6)=0.1500 v(wn_wih_1_6)=0.9500
.ic v(wp_wih_2_6)=0.1500 v(wn_wih_2_6)=0.9500
.ic v(wp_wih_3_6)=0.4301 v(wn_wih_3_6)=0.5699
.ic v(wp_who_6)=0.3311 v(wn_who_6)=0.6689
.ic v(wp_wih_1_7)=0.5855 v(wn_wih_1_7)=0.4145
.ic v(wp_wih_2_7)=0.5869 v(wn_wih_2_7)=0.4131
.ic v(wp_wih_3_7)=0.9500 v(wn_wih_3_7)=0.1500
.ic v(wp_who_7)=0.1500 v(wn_who_7)=0.9448
.ic v(wp_wih_1_8)=0.3490 v(wn_wih_1_8)=0.6510
.ic v(wp_wih_2_8)=0.9500 v(wn_wih_2_8)=0.1500
.ic v(wp_wih_3_8)=0.7587 v(wn_wih_3_8)=0.2413
.ic v(wp_who_8)=0.7652 v(wn_who_8)=0.2348
.ic v(wp_wih_1_9)=0.2944 v(wn_wih_1_9)=0.7056
.ic v(wp_wih_2_9)=0.1500 v(wn_wih_2_9)=0.9500
.ic v(wp_wih_3_9)=0.5670 v(wn_wih_3_9)=0.4330
.ic v(wp_who_9)=0.5436 v(wn_who_9)=0.4564
.ic v(wp_wih_1_10)=0.1500 v(wn_wih_1_10)=0.9500
.ic v(wp_wih_2_10)=0.2267 v(wn_wih_2_10)=0.7733
.ic v(wp_wih_3_10)=0.4712 v(wn_wih_3_10)=0.5288
.ic v(wp_who_10)=0.1500 v(wn_who_10)=0.8779
.ic v(wp_wih_1_11)=0.4607 v(wn_wih_1_11)=0.5393
.ic v(wp_wih_2_11)=0.5382 v(wn_wih_2_11)=0.4618
.ic v(wp_wih_3_11)=0.5142 v(wn_wih_3_11)=0.4858
.ic v(wp_who_11)=0.2975 v(wn_who_11)=0.7025
.ic v(wp_wih_1_12)=0.7375 v(wn_wih_1_12)=0.2625
.ic v(wp_wih_2_12)=0.8565 v(wn_wih_2_12)=0.1500
.ic v(wp_wih_3_12)=0.6283 v(wn_wih_3_12)=0.3717
.ic v(wp_who_12)=0.1727 v(wn_who_12)=0.8273
.ic v(wp_wih_1_13)=0.7927 v(wn_wih_1_13)=0.2073
.ic v(wp_wih_2_13)=0.2994 v(wn_wih_2_13)=0.7006
.ic v(wp_wih_3_13)=0.8517 v(wn_wih_3_13)=0.1500
.ic v(wp_who_13)=0.1500 v(wn_who_13)=0.9287
.ic v(wp_wih_1_14)=0.8658 v(wn_wih_1_14)=0.1500
.ic v(wp_wih_2_14)=0.4920 v(wn_wih_2_14)=0.5080
.ic v(wp_wih_3_14)=0.1500 v(wn_wih_3_14)=0.9500
.ic v(wp_who_14)=0.3744 v(wn_who_14)=0.6256
.ic v(wp_wih_1_15)=0.5216 v(wn_wih_1_15)=0.4784
.ic v(wp_wih_2_15)=0.6091 v(wn_wih_2_15)=0.3909
.ic v(wp_wih_3_15)=0.1500 v(wn_wih_3_15)=0.8929
.ic v(wp_who_15)=0.1500 v(wn_who_15)=0.9429
.ic v(wp_wih_1_16)=0.5798 v(wn_wih_1_16)=0.4202
.ic v(wp_wih_2_16)=0.3133 v(wn_wih_2_16)=0.6867
.ic v(wp_wih_3_16)=0.5942 v(wn_wih_3_16)=0.4058
.ic v(wp_who_16)=0.8038 v(wn_who_16)=0.1962
.ic v(wp_wih_1_17)=0.1500 v(wn_wih_1_17)=0.9500
.ic v(wp_wih_2_17)=0.6018 v(wn_wih_2_17)=0.3982
.ic v(wp_wih_3_17)=0.9500 v(wn_wih_3_17)=0.1500
.ic v(wp_who_17)=0.3810 v(wn_who_17)=0.6190
.ic v(wp_wih_1_18)=0.1757 v(wn_wih_1_18)=0.8243
.ic v(wp_wih_2_18)=0.8009 v(wn_wih_2_18)=0.1991
.ic v(wp_wih_3_18)=0.6014 v(wn_wih_3_18)=0.3986
.ic v(wp_who_18)=0.8584 v(wn_who_18)=0.1500
.ic v(wp_wih_1_19)=0.3619 v(wn_wih_1_19)=0.6381
.ic v(wp_wih_2_19)=0.1500 v(wn_wih_2_19)=0.9500
.ic v(wp_wih_3_19)=0.4560 v(wn_wih_3_19)=0.5440
.ic v(wp_who_19)=0.3217 v(wn_who_19)=0.6783
.ic v(wp_wih_1_20)=0.8101 v(wn_wih_1_20)=0.1899
.ic v(wp_wih_2_20)=0.5775 v(wn_wih_2_20)=0.4225
.ic v(wp_wih_3_20)=0.1500 v(wn_wih_3_20)=0.9500
.ic v(wp_who_20)=0.1500 v(wn_who_20)=0.9500
.ic v(wp_wih_1_21)=0.8535 v(wn_wih_1_21)=0.1500
.ic v(wp_wih_2_21)=0.7719 v(wn_wih_2_21)=0.2281
.ic v(wp_wih_3_21)=0.2439 v(wn_wih_3_21)=0.7561
.ic v(wp_who_21)=0.4996 v(wn_who_21)=0.5004
.ic v(wp_wih_1_22)=0.6782 v(wn_wih_1_22)=0.3218
.ic v(wp_wih_2_22)=0.6874 v(wn_wih_2_22)=0.3126
.ic v(wp_wih_3_22)=0.8505 v(wn_wih_3_22)=0.1500
.ic v(wp_who_22)=0.6026 v(wn_who_22)=0.3974
.ic v(wp_wih_1_23)=0.4621 v(wn_wih_1_23)=0.5379
.ic v(wp_wih_2_23)=0.3965 v(wn_wih_2_23)=0.6035
.ic v(wp_wih_3_23)=0.9223 v(wn_wih_3_23)=0.1500
.ic v(wp_who_23)=0.1500 v(wn_who_23)=0.9500
.options cshunt=1e-14 gmin=1e-10 reltol=2e-3
.tran 2n 75000n uic
.control
run
wrdata pcL2dpfb.dat v(mop) v(mon) v(mop2) v(mon2)
wrdata pcL2dhpfb.dat v(ahp0) v(ahn0) v(ahp1) v(ahn1) v(ahp2) v(ahn2) v(ahp3) v(ahn3) v(ahp4) v(ahn4) v(ahp5) v(ahn5) v(ahp6) v(ahn6) v(ahp7) v(ahn7) v(ahp8) v(ahn8) v(ahp9) v(ahn9) v(ahp10) v(ahn10) v(ahp11) v(ahn11) v(ahp12) v(ahn12) v(ahp13) v(ahn13) v(ahp14) v(ahn14) v(ahp15) v(ahn15) v(ahp16) v(ahn16) v(ahp17) v(ahn17) v(ahp18) v(ahn18) v(ahp19) v(ahn19) v(ahp20) v(ahn20) v(ahp21) v(ahn21) v(ahp22) v(ahn22) v(ahp23) v(ahn23)
.endc
.end
