pcL 2D
.model NNR NMOS (LEVEL=1 VTO=0.2 KP=120u LAMBDA=0.02 GAMMA=0 PHI=0.7)
.model PNR PMOS (LEVEL=1 VTO=-0.2 KP=40u LAMBDA=0.02 GAMMA=0 PHI=0.7)
.subckt gsyn inp inn wp wn outp outn vdd vbn
Mtail nt vbn 0 0 NNR W=400u L=100u
M5 na wp nt 0 NNR W=200u L=100u
M6 nb wn nt 0 NNR W=200u L=100u
M1 outp inp na 0 NNR W=200u L=100u
M2 outn inn na 0 NNR W=200u L=100u
M3 outn inp nb 0 NNR W=200u L=100u
M4 outp inn nb 0 NNR W=200u L=100u
.ends
.subckt cmld p n vdd
Rcs1 p cmx 300k
Rcs2 n cmx 300k
MLp p cmx vdd vdd PNR W=1000u L=100u
MLn n cmx vdd vdd PNR W=1000u L=100u
.ends
.subckt dneuron up un ap an vdd vbn
M1 an up tn 0 NNR W=200u L=100u
M2 ap un tn 0 NNR W=200u L=100u
Mt tn vbn 0 0 NNR W=200u L=100u
Xcm ap an vdd cmld
.ends
.subckt esub xp xn mp mn ep en vdd vbn
Mt nt vbn 0 0 NNR W=400u L=100u
M1x ep xn nt 0 NNR W=200u L=100u
M2x en xp nt 0 NNR W=200u L=100u
M1m ep mp nt 0 NNR W=200u L=100u
M2m en mn nt 0 NNR W=200u L=100u
RLp vdd ep 50k
RLn vdd en 50k
.ends
.subckt gprod xp xn yp yn wp wn vdd vbn
Mtail nt vbn 0 0 NNR W=400u L=100u
M5 na yp nt 0 NNR W=200u L=100u
M6 nb yn nt 0 NNR W=200u L=100u
M1 iop xp na 0 NNR W=200u L=100u
M2 ion xn na 0 NNR W=200u L=100u
M3 ion xp nb 0 NNR W=200u L=100u
M4 iop xn nb 0 NNR W=200u L=100u
Mlp iop iop vdd vdd PNR W=200u L=100u
Mln ion ion vdd vdd PNR W=200u L=100u
Mpu_wp wp iop vdd vdd PNR W=200u L=100u
MpRn nrn ion vdd vdd PNR W=200u L=100u
MnRn nrn nrn 0 0 NNR W=200u L=100u
Mpd_wp wp nrn 0 0 NNR W=200u L=100u
Mpu_wn wn ion vdd vdd PNR W=200u L=100u
MpRp nrp iop vdd vdd PNR W=200u L=100u
MnRp nrp nrp 0 0 NNR W=200u L=100u
Mpd_wn wn nrp 0 0 NNR W=200u L=100u
.ends
Vdd vdd 0 1.0
Vbsyn vbsyn 0 0.45
Vbneu vbneu 0 0.35
Vgm gm 0 0.6
Vgblh gblh 0 0.85
Vgblo gblo 0 0.85
Vwcm wcm 0 0.5
Vx1p a_xp1 0 PWL(0.0n 0.5490 249.9n 0.5490 250.0n 0.3113 499.9n 0.3113 500.0n 0.5851 749.9n 0.5851 750.0n 0.4959 999.9n 0.4959 1000.0n 0.3107 1249.9n 0.3107 1250.0n 0.4950 1499.9n 0.4950 1500.0n 0.5373 1749.9n 0.5373 1750.0n 0.8837 1999.9n 0.8837 2000.0n 0.1662 2249.9n 0.1662 2250.0n 0.4447 2499.9n 0.4447 2500.0n 0.6668 2749.9n 0.6668 2750.0n 0.1178 2999.9n 0.1178 3000.0n 0.4834 3249.9n 0.4834 3250.0n 0.7792 3499.9n 0.7792 3500.0n 0.4974 3749.9n 0.4974 3750.0n 0.3966 3999.9n 0.3966 4000.0n 0.3461 4249.9n 0.3461 4250.0n 0.5828 4499.9n 0.5828 4500.0n 0.5464 4749.9n 0.5464 4750.0n 0.8897 4999.9n 0.8897 5000.0n 0.2205 5249.9n 0.2205 5250.0n 0.3383 5499.9n 0.3383 5500.0n 0.7608 5749.9n 0.7608 5750.0n 0.8206 5999.9n 0.8206 6000.0n 0.6102 6249.9n 0.6102 6250.0n 0.5810 6499.9n 0.5810 6500.0n 0.0625 6749.9n 0.0625 6750.0n 0.1548 6999.9n 0.1548 7000.0n 0.4589 7249.9n 0.4589 7250.0n 0.4287 7499.9n 0.4287 7500.0n 0.6001 7749.9n 0.6001 7750.0n 0.3521 7999.9n 0.3521 8000.0n 0.4362 8249.9n 0.4362 8250.0n 0.8701 8499.9n 0.8701 8500.0n 0.4857 8749.9n 0.4857 8750.0n 0.1795 8999.9n 0.1795 9000.0n 0.5672 9249.9n 0.5672 9250.0n 0.6490 9499.9n 0.6490 9500.0n 0.4494 9749.9n 0.4494 9750.0n 0.7953 9999.9n 0.7953 10000.0n 0.6434 10249.9n 0.6434 10250.0n 0.1745 10499.9n 0.1745 10500.0n 0.3834 10749.9n 0.3834 10750.0n 0.8124 10999.9n 0.8124 11000.0n 0.5952 11249.9n 0.5952 11250.0n 0.3560 11499.9n 0.3560 11500.0n 0.4913 11749.9n 0.4913 11750.0n 0.4166 11999.9n 0.4166 12000.0n 0.5108 12249.9n 0.5108 12250.0n 0.4621 12499.9n 0.4621 12500.0n 0.3739 12749.9n 0.3739 12750.0n 0.6594 12999.9n 0.6594 13000.0n 0.6041 13249.9n 0.6041 13250.0n 0.4628 13499.9n 0.4628 13500.0n 0.7259 13749.9n 0.7259 13750.0n 0.5344 13999.9n 0.5344 14000.0n 0.6754 14249.9n 0.6754 14250.0n 0.5682 14499.9n 0.5682 14500.0n 0.4149 14749.9n 0.4149 14750.0n 0.1733 14999.9n 0.1733 15000.0n 0.4362 15249.9n 0.4362 15250.0n 0.8701 15499.9n 0.8701 15500.0n 0.3107 15749.9n 0.3107 15750.0n 0.5851 15999.9n 0.5851 16000.0n 0.5828 16249.9n 0.5828 16250.0n 0.1745 16499.9n 0.1745 16500.0n 0.6001 16749.9n 0.6001 16750.0n 0.8206 16999.9n 0.8206 17000.0n 0.4974 17249.9n 0.4974 17250.0n 0.6490 17499.9n 0.6490 17500.0n 0.4166 17749.9n 0.4166 17750.0n 0.2205 17999.9n 0.2205 18000.0n 0.4589 18249.9n 0.4589 18250.0n 0.3834 18499.9n 0.3834 18500.0n 0.4834 18749.9n 0.4834 18750.0n 0.6668 18999.9n 0.6668 19000.0n 0.5672 19249.9n 0.5672 19250.0n 0.5344 19499.9n 0.5344 19500.0n 0.5490 19749.9n 0.5490 19750.0n 0.1178 19999.9n 0.1178 20000.0n 0.5108 20249.9n 0.5108 20250.0n 0.6041 20499.9n 0.6041 20500.0n 0.1795 20749.9n 0.1795 20750.0n 0.5682 20999.9n 0.5682 21000.0n 0.5952 21249.9n 0.5952 21250.0n 0.4149 21499.9n 0.4149 21500.0n 0.4959 21749.9n 0.4959 21750.0n 0.1548 21999.9n 0.1548 22000.0n 0.6102 22249.9n 0.6102 22250.0n 0.5464 22499.9n 0.5464 22500.0n 0.3461 22749.9n 0.3461 22750.0n 0.6754 22999.9n 0.6754 23000.0n 0.4628 23249.9n 0.4628 23250.0n 0.0625 23499.9n 0.0625 23500.0n 0.4447 23749.9n 0.4447 23750.0n 0.4913 23999.9n 0.4913 24000.0n 0.3739 24249.9n 0.3739 24250.0n 0.7953 24499.9n 0.7953 24500.0n 0.8897 24749.9n 0.8897 24750.0n 0.1662 24999.9n 0.1662 25000.0n 0.8837 25249.9n 0.8837 25250.0n 0.3966 25499.9n 0.3966 25500.0n 0.4494 25749.9n 0.4494 25750.0n 0.7259 25999.9n 0.7259 26000.0n 0.8124 26249.9n 0.8124 26250.0n 0.5810 26499.9n 0.5810 26500.0n 0.3383 26749.9n 0.3383 26750.0n 0.6434 26999.9n 0.6434 27000.0n 0.4950 27249.9n 0.4950 27250.0n 0.6594 27499.9n 0.6594 27500.0n 0.4287 27749.9n 0.4287 27750.0n 0.4621 27999.9n 0.4621 28000.0n 0.5373 28249.9n 0.5373 28250.0n 0.3560 28499.9n 0.3560 28500.0n 0.7792 28749.9n 0.7792 28750.0n 0.3113 28999.9n 0.3113 29000.0n 0.7608 29249.9n 0.7608 29250.0n 0.1733 29499.9n 0.1733 29500.0n 0.3521 29749.9n 0.3521 29750.0n 0.4857 29999.9n 0.4857 30000.0n 0.4857 30249.9n 0.4857 30250.0n 0.4447 30499.9n 0.4447 30500.0n 0.5810 30749.9n 0.5810 30750.0n 0.3834 30999.9n 0.3834 31000.0n 0.8701 31249.9n 0.8701 31250.0n 0.4913 31499.9n 0.4913 31500.0n 0.7608 31749.9n 0.7608 31750.0n 0.2205 31999.9n 0.2205 32000.0n 0.1178 32249.9n 0.1178 32250.0n 0.6668 32499.9n 0.6668 32500.0n 0.3107 32749.9n 0.3107 32750.0n 0.5464 32999.9n 0.5464 33000.0n 0.5672 33249.9n 0.5672 33250.0n 0.6490 33499.9n 0.6490 33500.0n 0.3560 33749.9n 0.3560 33750.0n 0.3113 33999.9n 0.3113 34000.0n 0.6754 34249.9n 0.6754 34250.0n 0.7953 34499.9n 0.7953 34500.0n 0.4166 34749.9n 0.4166 34750.0n 0.3521 34999.9n 0.3521 35000.0n 0.4149 35249.9n 0.4149 35250.0n 0.4589 35499.9n 0.4589 35500.0n 0.4621 35749.9n 0.4621 35750.0n 0.6434 35999.9n 0.6434 36000.0n 0.4287 36249.9n 0.4287 36250.0n 0.8897 36499.9n 0.8897 36500.0n 0.8837 36749.9n 0.8837 36750.0n 0.5344 36999.9n 0.5344 37000.0n 0.4834 37249.9n 0.4834 37250.0n 0.4628 37499.9n 0.4628 37500.0n 0.4362 37749.9n 0.4362 37750.0n 0.1662 37999.9n 0.1662 38000.0n 0.3739 38249.9n 0.3739 38250.0n 0.1733 38499.9n 0.1733 38500.0n 0.5682 38749.9n 0.5682 38750.0n 0.3461 38999.9n 0.3461 39000.0n 0.1548 39249.9n 0.1548 39250.0n 0.8206 39499.9n 0.8206 39500.0n 0.4974 39749.9n 0.4974 39750.0n 0.1745 39999.9n 0.1745 40000.0n 0.1795 40249.9n 0.1795 40250.0n 0.7259 40499.9n 0.7259 40500.0n 0.6001 40749.9n 0.6001 40750.0n 0.7792 40999.9n 0.7792 41000.0n 0.5373 41249.9n 0.5373 41250.0n 0.3383 41499.9n 0.3383 41500.0n 0.0625 41749.9n 0.0625 41750.0n 0.4959 41999.9n 0.4959 42000.0n 0.5490 42249.9n 0.5490 42250.0n 0.8124 42499.9n 0.8124 42500.0n 0.3966 42749.9n 0.3966 42750.0n 0.6594 42999.9n 0.6594 43000.0n 0.4494 43249.9n 0.4494 43250.0n 0.4950 43499.9n 0.4950 43500.0n 0.6041 43749.9n 0.6041 43750.0n 0.5851 43999.9n 0.5851 44000.0n 0.5828 44249.9n 0.5828 44250.0n 0.5952 44499.9n 0.5952 44500.0n 0.5108 44749.9n 0.5108 44750.0n 0.6102 44999.9n 0.6102 45000.0n 0.1795 45249.9n 0.1795 45250.0n 0.8897 45499.9n 0.8897 45500.0n 0.4166 45749.9n 0.4166 45750.0n 0.4447 45999.9n 0.4447 46000.0n 0.8701 46249.9n 0.8701 46250.0n 0.4974 46499.9n 0.4974 46500.0n 0.5490 46749.9n 0.5490 46750.0n 0.5682 46999.9n 0.5682 47000.0n 0.4287 47249.9n 0.4287 47250.0n 0.3966 47499.9n 0.3966 47500.0n 0.6668 47749.9n 0.6668 47750.0n 0.7792 47999.9n 0.7792 48000.0n 0.3739 48249.9n 0.3739 48250.0n 0.2205 48499.9n 0.2205 48500.0n 0.8206 48749.9n 0.8206 48750.0n 0.4959 48999.9n 0.4959 49000.0n 0.4913 49249.9n 0.4913 49250.0n 0.5373 49499.9n 0.5373 49500.0n 0.3521 49749.9n 0.3521 49750.0n 0.7259 49999.9n 0.7259 50000.0n 0.4857 50249.9n 0.4857 50250.0n 0.3461 50499.9n 0.3461 50500.0n 0.3560 50749.9n 0.3560 50750.0n 0.4834 50999.9n 0.4834 51000.0n 0.4589 51249.9n 0.4589 51250.0n 0.8837 51499.9n 0.8837 51500.0n 0.5828 51749.9n 0.5828 51750.0n 0.7608 51999.9n 0.7608 52000.0n 0.5851 52249.9n 0.5851 52250.0n 0.5108 52499.9n 0.5108 52500.0n 0.6102 52749.9n 0.6102 52750.0n 0.6754 52999.9n 0.6754 53000.0n 0.4950 53249.9n 0.4950 53250.0n 0.4149 53499.9n 0.4149 53500.0n 0.1662 53749.9n 0.1662 53750.0n 0.4362 53999.9n 0.4362 54000.0n 0.5464 54249.9n 0.5464 54250.0n 0.8124 54499.9n 0.8124 54500.0n 0.6594 54749.9n 0.6594 54750.0n 0.3834 54999.9n 0.3834 55000.0n 0.5344 55249.9n 0.5344 55250.0n 0.4621 55499.9n 0.4621 55500.0n 0.1178 55749.9n 0.1178 55750.0n 0.0625 55999.9n 0.0625 56000.0n 0.5672 56249.9n 0.5672 56250.0n 0.7953 56499.9n 0.7953 56500.0n 0.1733 56749.9n 0.1733 56750.0n 0.4494 56999.9n 0.4494 57000.0n 0.3113 57249.9n 0.3113 57250.0n 0.3107 57499.9n 0.3107 57500.0n 0.6434 57749.9n 0.6434 57750.0n 0.1548 57999.9n 0.1548 58000.0n 0.6490 58249.9n 0.6490 58250.0n 0.6001 58499.9n 0.6001 58500.0n 0.5810 58749.9n 0.5810 58750.0n 0.4628 58999.9n 0.4628 59000.0n 0.1745 59249.9n 0.1745 59250.0n 0.5952 59499.9n 0.5952 59500.0n 0.6041 59749.9n 0.6041 59750.0n 0.3383 59999.9n 0.3383 60000.0n 0.7792 60249.9n 0.7792 60250.0n 0.4149 60499.9n 0.4149 60500.0n 0.4628 60749.9n 0.4628 60750.0n 0.5810 60999.9n 0.5810 61000.0n 0.6668 61249.9n 0.6668 61250.0n 0.4913 61499.9n 0.4913 61500.0n 0.7953 61749.9n 0.7953 61750.0n 0.3834 61999.9n 0.3834 62000.0n 0.3461 62249.9n 0.3461 62250.0n 0.4287 62499.9n 0.4287 62500.0n 0.4950 62749.9n 0.4950 62750.0n 0.8701 62999.9n 0.8701 63000.0n 0.4589 63249.9n 0.4589 63250.0n 0.5464 63499.9n 0.5464 63500.0n 0.4621 63749.9n 0.4621 63750.0n 0.4959 63999.9n 0.4959 64000.0n 0.6001 64249.9n 0.6001 64250.0n 0.6594 64499.9n 0.6594 64500.0n 0.7259 64749.9n 0.7259 64750.0n 0.6102 64999.9n 0.6102 65000.0n 0.6754 65249.9n 0.6754 65250.0n 0.6490 65499.9n 0.6490 65500.0n 0.6434 65749.9n 0.6434 65750.0n 0.5828 65999.9n 0.5828 66000.0n 0.1662 66249.9n 0.1662 66250.0n 0.3113 66499.9n 0.3113 66500.0n 0.5108 66749.9n 0.5108 66750.0n 0.5373 66999.9n 0.5373 67000.0n 0.1548 67249.9n 0.1548 67250.0n 0.1745 67499.9n 0.1745 67500.0n 0.7608 67749.9n 0.7608 67750.0n 0.8206 67999.9n 0.8206 68000.0n 0.3739 68249.9n 0.3739 68250.0n 0.4834 68499.9n 0.4834 68500.0n 0.2205 68749.9n 0.2205 68750.0n 0.1733 68999.9n 0.1733 69000.0n 0.3521 69249.9n 0.3521 69250.0n 0.8124 69499.9n 0.8124 69500.0n 0.3966 69749.9n 0.3966 69750.0n 0.3107 69999.9n 0.3107 70000.0n 0.5851 70249.9n 0.5851 70250.0n 0.4974 70499.9n 0.4974 70500.0n 0.8837 70749.9n 0.8837 70750.0n 0.5952 70999.9n 0.5952 71000.0n 0.4494 71249.9n 0.4494 71250.0n 0.8897 71499.9n 0.8897 71500.0n 0.5672 71749.9n 0.5672 71750.0n 0.5490 71999.9n 0.5490 72000.0n 0.3383 72249.9n 0.3383 72250.0n 0.1178 72499.9n 0.1178 72500.0n 0.4362 72749.9n 0.4362 72750.0n 0.6041 72999.9n 0.6041 73000.0n 0.5344 73249.9n 0.5344 73250.0n 0.4166 73499.9n 0.4166 73500.0n 0.1795 73749.9n 0.1795 73750.0n 0.5682 73999.9n 0.5682 74000.0n 0.4447 74249.9n 0.4447 74250.0n 0.3560 74499.9n 0.3560 74500.0n 0.0625 74749.9n 0.0625 74750.0n 0.4857 74999.9n 0.4857 75000.0n 0.4834 75249.9n 0.4834 75250.0n 0.5108 75499.9n 0.5108 75500.0n 0.4589 75749.9n 0.4589 75750.0n 0.8897 75999.9n 0.8897 76000.0n 0.5828 76249.9n 0.5828 76250.0n 0.4149 76499.9n 0.4149 76500.0n 0.6668 76749.9n 0.6668 76750.0n 0.4974 76999.9n 0.4974 77000.0n 0.6594 77249.9n 0.6594 77250.0n 0.5490 77499.9n 0.5490 77500.0n 0.4287 77749.9n 0.4287 77750.0n 0.4362 77999.9n 0.4362 78000.0n 0.6434 78249.9n 0.6434 78250.0n 0.6041 78499.9n 0.6041 78500.0n 0.3560 78749.9n 0.3560 78750.0n 0.1662 78999.9n 0.1662 79000.0n 0.7953 79249.9n 0.7953 79250.0n 0.3834 79499.9n 0.3834 79500.0n 0.4621 79749.9n 0.4621 79750.0n 0.5344 79999.9n 0.5344 80000.0n 0.5682 80249.9n 0.5682 80250.0n 0.1548 80499.9n 0.1548 80500.0n 0.2205 80749.9n 0.2205 80750.0n 0.4959 80999.9n 0.4959 81000.0n 0.7259 81249.9n 0.7259 81250.0n 0.4913 81499.9n 0.4913 81500.0n 0.6754 81749.9n 0.6754 81750.0n 0.5810 81999.9n 0.5810 82000.0n 0.6490 82249.9n 0.6490 82250.0n 0.7792 82499.9n 0.7792 82500.0n 0.4950 82749.9n 0.4950 82750.0n 0.1795 82999.9n 0.1795 83000.0n 0.5464 83249.9n 0.5464 83250.0n 0.6001 83499.9n 0.6001 83500.0n 0.8206 83749.9n 0.8206 83750.0n 0.4166 83999.9n 0.4166 84000.0n 0.8837 84249.9n 0.8837 84250.0n 0.4494 84499.9n 0.4494 84500.0n 0.4447 84749.9n 0.4447 84750.0n 0.8701 84999.9n 0.8701 85000.0n 0.1178 85249.9n 0.1178 85250.0n 0.3383 85499.9n 0.3383 85500.0n 0.0625 85749.9n 0.0625 85750.0n 0.3107 85999.9n 0.3107 86000.0n 0.5373 86249.9n 0.5373 86250.0n 0.5952 86499.9n 0.5952 86500.0n 0.6102 86749.9n 0.6102 86750.0n 0.3521 86999.9n 0.3521 87000.0n 0.5672 87249.9n 0.5672 87250.0n 0.3113 87499.9n 0.3113 87500.0n 0.4628 87749.9n 0.4628 87750.0n 0.1733 87999.9n 0.1733 88000.0n 0.3461 88249.9n 0.3461 88250.0n 0.7608 88499.9n 0.7608 88500.0n 0.8124 88749.9n 0.8124 88750.0n 0.5851 88999.9n 0.5851 89000.0n 0.4857 89249.9n 0.4857 89250.0n 0.3966 89499.9n 0.3966 89500.0n 0.3739 89749.9n 0.3739 89750.0n 0.1745 89999.9n 0.1745 90000.0n 0.2205 90249.9n 0.2205 90250.0n 0.4974 90499.9n 0.4974 90500.0n 0.7259 90749.9n 0.7259 90750.0n 0.3521 90999.9n 0.3521 91000.0n 0.4447 91249.9n 0.4447 91250.0n 0.1548 91499.9n 0.1548 91500.0n 0.1795 91749.9n 0.1795 91750.0n 0.7792 91999.9n 0.7792 92000.0n 0.3113 92249.9n 0.3113 92250.0n 0.4149 92499.9n 0.4149 92500.0n 0.5828 92749.9n 0.5828 92750.0n 0.4959 92999.9n 0.4959 93000.0n 0.6434 93249.9n 0.6434 93250.0n 0.3461 93499.9n 0.3461 93500.0n 0.4950 93749.9n 0.4950 93750.0n 0.6041 93999.9n 0.6041 94000.0n 0.8837 94249.9n 0.8837 94250.0n 0.1745 94499.9n 0.1745 94500.0n 0.8897 94749.9n 0.8897 94750.0n 0.7608 94999.9n 0.7608 95000.0n 0.6001 95249.9n 0.6001 95250.0n 0.8206 95499.9n 0.8206 95500.0n 0.0625 95749.9n 0.0625 95750.0n 0.5464 95999.9n 0.5464 96000.0n 0.8701 96249.9n 0.8701 96250.0n 0.1178 96499.9n 0.1178 96500.0n 0.5952 96749.9n 0.5952 96750.0n 0.3383 96999.9n 0.3383 97000.0n 0.5682 97249.9n 0.5682 97250.0n 0.6754 97499.9n 0.6754 97500.0n 0.4857 97749.9n 0.4857 97750.0n 0.5108 97999.9n 0.5108 98000.0n 0.6594 98249.9n 0.6594 98250.0n 0.3560 98499.9n 0.3560 98500.0n 0.4913 98749.9n 0.4913 98750.0n 0.1662 98999.9n 0.1662 99000.0n 0.5672 99249.9n 0.5672 99250.0n 0.3107 99499.9n 0.3107 99500.0n 0.4628 99749.9n 0.4628 99750.0n 0.4834 99999.9n 0.4834 100000.0n 0.5373 100249.9n 0.5373 100250.0n 0.4362 100499.9n 0.4362 100500.0n 0.3834 100749.9n 0.3834 100750.0n 0.4589 100999.9n 0.4589 101000.0n 0.4494 101249.9n 0.4494 101250.0n 0.4166 101499.9n 0.4166 101500.0n 0.6668 101749.9n 0.6668 101750.0n 0.5490 101999.9n 0.5490 102000.0n 0.3966 102249.9n 0.3966 102250.0n 0.8124 102499.9n 0.8124 102500.0n 0.5810 102749.9n 0.5810 102750.0n 0.6102 102999.9n 0.6102 103000.0n 0.5851 103249.9n 0.5851 103250.0n 0.7953 103499.9n 0.7953 103500.0n 0.3739 103749.9n 0.3739 103750.0n 0.4287 103999.9n 0.4287 104000.0n 0.6490 104249.9n 0.6490 104250.0n 0.1733 104499.9n 0.1733 104500.0n 0.4621 104749.9n 0.4621 104750.0n 0.5344 104999.9n 0.5344 105000.0n 0.4950 105249.9n 0.4950 105250.0n 0.5828 105499.9n 0.5828 105500.0n 0.5464 105749.9n 0.5464 105750.0n 0.5490 105999.9n 0.5490 106000.0n 0.4447 106249.9n 0.4447 106250.0n 0.6668 106499.9n 0.6668 106500.0n 0.5682 106749.9n 0.5682 106750.0n 0.7608 106999.9n 0.7608 107000.0n 0.5373 107249.9n 0.5373 107250.0n 0.4959 107499.9n 0.4959 107500.0n 0.6434 107749.9n 0.6434 107750.0n 0.1795 107999.9n 0.1795 108000.0n 0.6001 108249.9n 0.6001 108250.0n 0.8206 108499.9n 0.8206 108500.0n 0.7259 108749.9n 0.7259 108750.0n 0.3383 108999.9n 0.3383 109000.0n 0.1745 109249.9n 0.1745 109250.0n 0.3834 109499.9n 0.3834 109500.0n 0.4628 109749.9n 0.4628 109750.0n 0.4913 109999.9n 0.4913 110000.0n 0.6594 110249.9n 0.6594 110250.0n 0.4166 110499.9n 0.4166 110500.0n 0.4974 110749.9n 0.4974 110750.0n 0.4834 110999.9n 0.4834 111000.0n 0.4287 111249.9n 0.4287 111250.0n 0.3113 111499.9n 0.3113 111500.0n 0.5810 111749.9n 0.5810 111750.0n 0.5672 111999.9n 0.5672 112000.0n 0.1733 112249.9n 0.1733 112250.0n 0.6102 112499.9n 0.6102 112500.0n 0.3560 112749.9n 0.3560 112750.0n 0.6490 112999.9n 0.6490 113000.0n 0.4362 113249.9n 0.4362 113250.0n 0.6041 113499.9n 0.6041 113500.0n 0.0625 113749.9n 0.0625 113750.0n 0.8701 113999.9n 0.8701 114000.0n 0.5108 114249.9n 0.5108 114250.0n 0.3966 114499.9n 0.3966 114500.0n 0.7792 114749.9n 0.7792 114750.0n 0.4494 114999.9n 0.4494 115000.0n 0.8837 115249.9n 0.8837 115250.0n 0.5952 115499.9n 0.5952 115500.0n 0.4589 115749.9n 0.4589 115750.0n 0.5344 115999.9n 0.5344 116000.0n 0.8124 116249.9n 0.8124 116250.0n 0.1662 116499.9n 0.1662 116500.0n 0.3461 116749.9n 0.3461 116750.0n 0.1178 116999.9n 0.1178 117000.0n 0.7953 117249.9n 0.7953 117250.0n 0.3739 117499.9n 0.3739 117500.0n 0.8897 117749.9n 0.8897 117750.0n 0.4149 117999.9n 0.4149 118000.0n 0.1548 118249.9n 0.1548 118250.0n 0.4857 118499.9n 0.4857 118500.0n 0.3521 118749.9n 0.3521 118750.0n 0.5851 118999.9n 0.5851 119000.0n 0.3107 119249.9n 0.3107 119250.0n 0.4621 119499.9n 0.4621 119500.0n 0.2205 119749.9n 0.2205 119750.0n 0.6754 119999.9n 0.6754 120000.0n 0.1795 120249.9n 0.1795 120250.0n 0.4447 120499.9n 0.4447 120500.0n 0.7608 120749.9n 0.7608 120750.0n 0.4913 120999.9n 0.4913 121000.0n 0.3383 121249.9n 0.3383 121250.0n 0.8837 121499.9n 0.8837 121500.0n 0.8124 121749.9n 0.8124 121750.0n 0.1733 121999.9n 0.1733 122000.0n 0.4857 122249.9n 0.4857 122250.0n 0.4287 122499.9n 0.4287 122500.0n 0.6594 122749.9n 0.6594 122750.0n 0.4834 122999.9n 0.4834 123000.0n 0.6041 123249.9n 0.6041 123250.0n 0.3966 123499.9n 0.3966 123500.0n 0.6434 123749.9n 0.6434 123750.0n 0.1662 123999.9n 0.1662 124000.0n 0.4974 124249.9n 0.4974 124250.0n 0.8897 124499.9n 0.8897 124500.0n 0.5490 124749.9n 0.5490 124750.0n 0.3739 124999.9n 0.3739 125000.0n 0.4494 125249.9n 0.4494 125250.0n 0.3521 125499.9n 0.3521 125500.0n 0.4621 125749.9n 0.4621 125750.0n 0.3107 125999.9n 0.3107 126000.0n 0.5464 126249.9n 0.5464 126250.0n 0.6668 126499.9n 0.6668 126500.0n 0.3834 126749.9n 0.3834 126750.0n 0.7259 126999.9n 0.7259 127000.0n 0.5682 127249.9n 0.5682 127250.0n 0.5952 127499.9n 0.5952 127500.0n 0.4149 127749.9n 0.4149 127750.0n 0.8701 127999.9n 0.8701 128000.0n 0.2205 128249.9n 0.2205 128250.0n 0.5672 128499.9n 0.5672 128500.0n 0.5851 128749.9n 0.5851 128750.0n 0.1548 128999.9n 0.1548 129000.0n 0.1178 129249.9n 0.1178 129250.0n 0.7792 129499.9n 0.7792 129500.0n 0.6754 129749.9n 0.6754 129750.0n 0.4589 129999.9n 0.4589 130000.0n 0.4362 130249.9n 0.4362 130250.0n 0.0625 130499.9n 0.0625 130500.0n 0.4959 130749.9n 0.4959 130750.0n 0.4166 130999.9n 0.4166 131000.0n 0.5828 131249.9n 0.5828 131250.0n 0.4950 131499.9n 0.4950 131500.0n 0.6102 131749.9n 0.6102 131750.0n 0.7953 131999.9n 0.7953 132000.0n 0.5373 132249.9n 0.5373 132250.0n 0.6490 132499.9n 0.6490 132500.0n 0.3560 132749.9n 0.3560 132750.0n 0.6001 132999.9n 0.6001 133000.0n 0.5108 133249.9n 0.5108 133250.0n 0.8206 133499.9n 0.8206 133500.0n 0.4628 133749.9n 0.4628 133750.0n 0.5344 133999.9n 0.5344 134000.0n 0.3113 134249.9n 0.3113 134250.0n 0.1745 134499.9n 0.1745 134500.0n 0.5810 134749.9n 0.5810 134750.0n 0.3461 134999.9n 0.3461 135000.0n 0.4589 135249.9n 0.4589 135250.0n 0.1662 135499.9n 0.1662 135500.0n 0.4447 135749.9n 0.4447 135750.0n 0.4974 135999.9n 0.4974 136000.0n 0.5373 136249.9n 0.5373 136250.0n 0.5490 136499.9n 0.5490 136500.0n 0.3966 136749.9n 0.3966 136750.0n 0.4857 136999.9n 0.4857 137000.0n 0.3834 137249.9n 0.3834 137250.0n 0.8897 137499.9n 0.8897 137500.0n 0.3461 137749.9n 0.3461 137750.0n 0.5464 137999.9n 0.5464 138000.0n 0.3113 138249.9n 0.3113 138250.0n 0.6668 138499.9n 0.6668 138500.0n 0.5952 138749.9n 0.5952 138750.0n 0.7953 138999.9n 0.7953 139000.0n 0.4959 139249.9n 0.4959 139250.0n 0.4628 139499.9n 0.4628 139500.0n 0.8206 139749.9n 0.8206 139750.0n 0.4149 139999.9n 0.4149 140000.0n 0.6041 140249.9n 0.6041 140250.0n 0.4362 140499.9n 0.4362 140500.0n 0.6102 140749.9n 0.6102 140750.0n 0.8837 140999.9n 0.8837 141000.0n 0.1745 141249.9n 0.1745 141250.0n 0.1795 141499.9n 0.1795 141500.0n 0.4913 141749.9n 0.4913 141750.0n 0.3739 141999.9n 0.3739 142000.0n 0.4621 142249.9n 0.4621 142250.0n 0.5672 142499.9n 0.5672 142500.0n 0.5851 142749.9n 0.5851 142750.0n 0.6001 142999.9n 0.6001 143000.0n 0.7608 143249.9n 0.7608 143250.0n 0.5810 143499.9n 0.5810 143500.0n 0.7792 143749.9n 0.7792 143750.0n 0.2205 143999.9n 0.2205 144000.0n 0.4166 144249.9n 0.4166 144250.0n 0.8701 144499.9n 0.8701 144500.0n 0.4834 144749.9n 0.4834 144750.0n 0.4950 144999.9n 0.4950 145000.0n 0.3521 145249.9n 0.3521 145250.0n 0.3107 145499.9n 0.3107 145500.0n 0.5108 145749.9n 0.5108 145750.0n 0.5828 145999.9n 0.5828 146000.0n 0.7259 146249.9n 0.7259 146250.0n 0.5344 146499.9n 0.5344 146500.0n 0.1178 146749.9n 0.1178 146750.0n 0.0625 146999.9n 0.0625 147000.0n 0.6594 147249.9n 0.6594 147250.0n 0.8124 147499.9n 0.8124 147500.0n 0.6754 147749.9n 0.6754 147750.0n 0.6490 147999.9n 0.6490 148000.0n 0.1733 148249.9n 0.1733 148250.0n 0.3383 148499.9n 0.3383 148500.0n 0.3560 148749.9n 0.3560 148750.0n 0.5682 148999.9n 0.5682 149000.0n 0.4494 149249.9n 0.4494 149250.0n 0.4287 149499.9n 0.4287 149500.0n 0.1548 149749.9n 0.1548 149750.0n 0.6434 149999.9n 0.6434 150000.0n 0.3834 150249.9n 0.3834 150250.0n 0.5490 150499.9n 0.5490 150500.0n 0.1733 150749.9n 0.1733 150750.0n 0.6754 150999.9n 0.6754 151000.0n 0.3521 151249.9n 0.3521 151250.0n 0.4166 151499.9n 0.4166 151500.0n 0.1548 151749.9n 0.1548 151750.0n 0.5108 151999.9n 0.5108 152000.0n 0.5851 152249.9n 0.5851 152250.0n 0.4447 152499.9n 0.4447 152500.0n 0.3560 152749.9n 0.3560 152750.0n 0.5828 152999.9n 0.5828 153000.0n 0.3383 153249.9n 0.3383 153250.0n 0.8124 153499.9n 0.8124 153500.0n 0.6434 153749.9n 0.6434 153750.0n 0.4628 153999.9n 0.4628 154000.0n 0.7953 154249.9n 0.7953 154250.0n 0.4494 154499.9n 0.4494 154500.0n 0.6102 154749.9n 0.6102 154750.0n 0.5672 154999.9n 0.5672 155000.0n 0.6594 155249.9n 0.6594 155250.0n 0.3739 155499.9n 0.3739 155500.0n 0.2205 155749.9n 0.2205 155750.0n 0.4287 155999.9n 0.4287 156000.0n 0.3966 156249.9n 0.3966 156250.0n 0.1662 156499.9n 0.1662 156500.0n 0.6490 156749.9n 0.6490 156750.0n 0.7792 156999.9n 0.7792 157000.0n 0.5952 157249.9n 0.5952 157250.0n 0.1178 157499.9n 0.1178 157500.0n 0.5344 157749.9n 0.5344 157750.0n 0.8206 157999.9n 0.8206 158000.0n 0.1745 158249.9n 0.1745 158250.0n 0.3113 158499.9n 0.3113 158500.0n 0.1795 158749.9n 0.1795 158750.0n 0.5464 158999.9n 0.5464 159000.0n 0.4857 159249.9n 0.4857 159250.0n 0.4950 159499.9n 0.4950 159500.0n 0.4621 159749.9n 0.4621 159750.0n 0.6001 159999.9n 0.6001 160000.0n 0.7259 160249.9n 0.7259 160250.0n 0.5682 160499.9n 0.5682 160500.0n 0.3461 160749.9n 0.3461 160750.0n 0.4959 160999.9n 0.4959 161000.0n 0.4913 161249.9n 0.4913 161250.0n 0.8701 161499.9n 0.8701 161500.0n 0.0625 161749.9n 0.0625 161750.0n 0.6668 161999.9n 0.6668 162000.0n 0.8897 162249.9n 0.8897 162250.0n 0.6041 162499.9n 0.6041 162500.0n 0.8837 162749.9n 0.8837 162750.0n 0.5810 162999.9n 0.5810 163000.0n 0.7608 163249.9n 0.7608 163250.0n 0.4834 163499.9n 0.4834 163500.0n 0.3107 163749.9n 0.3107 163750.0n 0.4974 163999.9n 0.4974 164000.0n 0.4149 164249.9n 0.4149 164250.0n 0.4589 164499.9n 0.4589 164500.0n 0.5373 164749.9n 0.5373 164750.0n 0.4362 164999.9n 0.4362 165000.0n 0.6594 165249.9n 0.6594 165250.0n 0.3461 165499.9n 0.3461 165500.0n 0.3521 165749.9n 0.3521 165750.0n 0.4621 165999.9n 0.4621 166000.0n 0.4166 166249.9n 0.4166 166250.0n 0.6041 166499.9n 0.6041 166500.0n 0.7259 166749.9n 0.7259 166750.0n 0.5828 166999.9n 0.5828 167000.0n 0.4857 167249.9n 0.4857 167250.0n 0.5682 167499.9n 0.5682 167500.0n 0.0625 167749.9n 0.0625 167750.0n 0.6434 167999.9n 0.6434 168000.0n 0.4494 168249.9n 0.4494 168250.0n 0.4287 168499.9n 0.4287 168500.0n 0.1795 168749.9n 0.1795 168750.0n 0.1548 168999.9n 0.1548 169000.0n 0.4149 169249.9n 0.4149 169250.0n 0.1178 169499.9n 0.1178 169500.0n 0.8837 169749.9n 0.8837 169750.0n 0.8124 169999.9n 0.8124 170000.0n 0.5952 170249.9n 0.5952 170250.0n 0.5851 170499.9n 0.5851 170500.0n 0.4974 170749.9n 0.4974 170750.0n 0.6754 170999.9n 0.6754 171000.0n 0.3560 171249.9n 0.3560 171250.0n 0.6102 171499.9n 0.6102 171500.0n 0.1662 171749.9n 0.1662 171750.0n 0.1745 171999.9n 0.1745 172000.0n 0.5810 172249.9n 0.5810 172250.0n 0.3113 172499.9n 0.3113 172500.0n 0.6490 172749.9n 0.6490 172750.0n 0.5672 172999.9n 0.5672 173000.0n 0.5490 173249.9n 0.5490 173250.0n 0.4362 173499.9n 0.4362 173500.0n 0.5108 173749.9n 0.5108 173750.0n 0.4447 173999.9n 0.4447 174000.0n 0.2205 174249.9n 0.2205 174250.0n 0.4589 174499.9n 0.4589 174500.0n 0.7953 174749.9n 0.7953 174750.0n 0.3966 174999.9n 0.3966 175000.0n 0.5464 175249.9n 0.5464 175250.0n 0.4913 175499.9n 0.4913 175500.0n 0.4628 175749.9n 0.4628 175750.0n 0.4834 175999.9n 0.4834 176000.0n 0.8206 176249.9n 0.8206 176250.0n 0.3107 176499.9n 0.3107 176500.0n 0.1733 176749.9n 0.1733 176750.0n 0.6668 176999.9n 0.6668 177000.0n 0.6001 177249.9n 0.6001 177250.0n 0.8897 177499.9n 0.8897 177500.0n 0.3739 177749.9n 0.3739 177750.0n 0.4950 177999.9n 0.4950 178000.0n 0.7792 178249.9n 0.7792 178250.0n 0.5373 178499.9n 0.5373 178500.0n 0.3383 178749.9n 0.3383 178750.0n 0.7608 178999.9n 0.7608 179000.0n 0.4959 179249.9n 0.4959 179250.0n 0.3834 179499.9n 0.3834 179500.0n 0.5344 179749.9n 0.5344 179750.0n 0.8701 179999.9n 0.8701 180000.0n 0.4494 180249.9n 0.4494 180250.0n 0.7953 180499.9n 0.7953 180500.0n 0.3739 180749.9n 0.3739 180750.0n 0.4974 180999.9n 0.4974 181000.0n 0.6041 181249.9n 0.6041 181250.0n 0.5464 181499.9n 0.5464 181500.0n 0.6594 181749.9n 0.6594 181750.0n 0.5810 181999.9n 0.5810 182000.0n 0.5344 182249.9n 0.5344 182250.0n 0.6668 182499.9n 0.6668 182500.0n 0.1745 182749.9n 0.1745 182750.0n 0.5672 182999.9n 0.5672 183000.0n 0.4362 183249.9n 0.4362 183250.0n 0.4447 183499.9n 0.4447 183500.0n 0.8701 183749.9n 0.8701 183750.0n 0.6754 183999.9n 0.6754 184000.0n 0.8124 184249.9n 0.8124 184250.0n 0.5828 184499.9n 0.5828 184500.0n 0.4621 184749.9n 0.4621 184750.0n 0.6490 184999.9n 0.6490 185000.0n 0.5682 185249.9n 0.5682 185250.0n 0.4834 185499.9n 0.4834 185500.0n 0.7608 185749.9n 0.7608 185750.0n 0.3383 185999.9n 0.3383 186000.0n 0.4149 186249.9n 0.4149 186250.0n 0.6102 186499.9n 0.6102 186500.0n 0.1178 186749.9n 0.1178 186750.0n 0.2205 186999.9n 0.2205 187000.0n 0.3560 187249.9n 0.3560 187250.0n 0.1662 187499.9n 0.1662 187500.0n 0.1795 187749.9n 0.1795 187750.0n 0.3107 187999.9n 0.3107 188000.0n 0.8206 188249.9n 0.8206 188250.0n 0.5490 188499.9n 0.5490 188500.0n 0.4857 188749.9n 0.4857 188750.0n 0.6434 188999.9n 0.6434 189000.0n 0.3966 189249.9n 0.3966 189250.0n 0.8837 189499.9n 0.8837 189500.0n 0.4959 189749.9n 0.4959 189750.0n 0.4166 189999.9n 0.4166 190000.0n 0.1548 190249.9n 0.1548 190250.0n 0.4628 190499.9n 0.4628 190500.0n 0.3521 190749.9n 0.3521 190750.0n 0.5108 190999.9n 0.5108 191000.0n 0.3113 191249.9n 0.3113 191250.0n 0.5373 191499.9n 0.5373 191500.0n 0.7259 191749.9n 0.7259 191750.0n 0.8897 191999.9n 0.8897 192000.0n 0.0625 192249.9n 0.0625 192250.0n 0.4589 192499.9n 0.4589 192500.0n 0.5952 192749.9n 0.5952 192750.0n 0.1733 192999.9n 0.1733 193000.0n 0.4913 193249.9n 0.4913 193250.0n 0.6001 193499.9n 0.6001 193500.0n 0.4950 193749.9n 0.4950 193750.0n 0.7792 193999.9n 0.7792 194000.0n 0.3834 194249.9n 0.3834 194250.0n 0.3461 194499.9n 0.3461 194500.0n 0.4287 194749.9n 0.4287 194750.0n 0.5851 194999.9n 0.5851 195000.0n 0.4166 195249.9n 0.4166 195250.0n 0.4834 195499.9n 0.4834 195500.0n 0.1733 195749.9n 0.1733 195750.0n 0.1178 195999.9n 0.1178 196000.0n 0.7792 196249.9n 0.7792 196250.0n 0.4857 196499.9n 0.4857 196500.0n 0.2205 196749.9n 0.2205 196750.0n 0.5828 196999.9n 0.5828 197000.0n 0.7259 197249.9n 0.7259 197250.0n 0.4959 197499.9n 0.4959 197500.0n 0.4950 197749.9n 0.4950 197750.0n 0.0625 197999.9n 0.0625 198000.0n 0.4287 198249.9n 0.4287 198250.0n 0.5108 198499.9n 0.5108 198500.0n 0.5682 198749.9n 0.5682 198750.0n 0.8837 198999.9n 0.8837 199000.0n 0.8897 199249.9n 0.8897 199250.0n 0.4589 199499.9n 0.4589 199500.0n 0.1795 199749.9n 0.1795 199750.0n 0.4494 199999.9n 0.4494 200000.0n 0.5373 200249.9n 0.5373 200250.0n 0.1662 200499.9n 0.1662 200500.0n 0.5344 200749.9n 0.5344 200750.0n 0.7608 200999.9n 0.7608 201000.0n 0.3834 201249.9n 0.3834 201250.0n 0.5952 201499.9n 0.5952 201500.0n 0.4974 201749.9n 0.4974 201750.0n 0.8206 201999.9n 0.8206 202000.0n 0.4149 202249.9n 0.4149 202250.0n 0.5464 202499.9n 0.5464 202500.0n 0.6001 202749.9n 0.6001 202750.0n 0.4628 202999.9n 0.4628 203000.0n 0.4362 203249.9n 0.4362 203250.0n 0.7953 203499.9n 0.7953 203500.0n 0.4913 203749.9n 0.4913 203750.0n 0.1745 203999.9n 0.1745 204000.0n 0.8124 204249.9n 0.8124 204250.0n 0.1548 204499.9n 0.1548 204500.0n 0.6490 204749.9n 0.6490 204750.0n 0.3383 204999.9n 0.3383 205000.0n 0.8701 205249.9n 0.8701 205250.0n 0.5810 205499.9n 0.5810 205500.0n 0.3521 205749.9n 0.3521 205750.0n 0.4447 205999.9n 0.4447 206000.0n 0.5851 206249.9n 0.5851 206250.0n 0.5490 206499.9n 0.5490 206500.0n 0.3739 206749.9n 0.3739 206750.0n 0.3560 206999.9n 0.3560 207000.0n 0.6434 207249.9n 0.6434 207250.0n 0.3107 207499.9n 0.3107 207500.0n 0.5672 207749.9n 0.5672 207750.0n 0.6102 207999.9n 0.6102 208000.0n 0.3113 208249.9n 0.3113 208250.0n 0.6041 208499.9n 0.6041 208500.0n 0.4621 208749.9n 0.4621 208750.0n 0.3461 208999.9n 0.3461 209000.0n 0.6668 209249.9n 0.6668 209250.0n 0.6754 209499.9n 0.6754 209500.0n 0.6594 209749.9n 0.6594 209750.0n 0.3966 209999.9n 0.3966 210000.0n 0.4166 210249.9n 0.4166 210250.0n 0.1548 210499.9n 0.1548 210500.0n 0.4974 210749.9n 0.4974 210750.0n 0.5828 210999.9n 0.5828 211000.0n 0.4494 211249.9n 0.4494 211250.0n 0.3461 211499.9n 0.3461 211500.0n 0.6668 211749.9n 0.6668 211750.0n 0.5490 211999.9n 0.5490 212000.0n 0.4950 212249.9n 0.4950 212250.0n 0.3113 212499.9n 0.3113 212500.0n 0.7792 212749.9n 0.7792 212750.0n 0.4628 212999.9n 0.4628 213000.0n 0.5344 213249.9n 0.5344 213250.0n 0.3834 213499.9n 0.3834 213500.0n 0.6041 213749.9n 0.6041 213750.0n 0.3560 213999.9n 0.3560 214000.0n 0.8897 214249.9n 0.8897 214250.0n 0.1795 214499.9n 0.1795 214500.0n 0.1745 214749.9n 0.1745 214750.0n 0.8837 214999.9n 0.8837 215000.0n 0.4589 215249.9n 0.4589 215250.0n 0.4621 215499.9n 0.4621 215500.0n 0.1733 215749.9n 0.1733 215750.0n 0.4913 215999.9n 0.4913 216000.0n 0.0625 216249.9n 0.0625 216250.0n 0.7608 216499.9n 0.7608 216500.0n 0.4149 216749.9n 0.4149 216750.0n 0.3383 216999.9n 0.3383 217000.0n 0.4959 217249.9n 0.4959 217250.0n 0.6594 217499.9n 0.6594 217500.0n 0.4447 217749.9n 0.4447 217750.0n 0.5108 217999.9n 0.5108 218000.0n 0.5672 218249.9n 0.5672 218250.0n 0.4834 218499.9n 0.4834 218500.0n 0.5952 218749.9n 0.5952 218750.0n 0.8701 218999.9n 0.8701 219000.0n 0.3107 219249.9n 0.3107 219250.0n 0.2205 219499.9n 0.2205 219500.0n 0.1662 219749.9n 0.1662 219750.0n 0.6490 219999.9n 0.6490 220000.0n 0.8206 220249.9n 0.8206 220250.0n 0.6754 220499.9n 0.6754 220500.0n 0.4287 220749.9n 0.4287 220750.0n 0.5810 220999.9n 0.5810 221000.0n 0.5373 221249.9n 0.5373 221250.0n 0.7953 221499.9n 0.7953 221500.0n 0.3521 221749.9n 0.3521 221750.0n 0.6001 221999.9n 0.6001 222000.0n 0.6102 222249.9n 0.6102 222250.0n 0.6434 222499.9n 0.6434 222500.0n 0.5464 222749.9n 0.5464 222750.0n 0.7259 222999.9n 0.7259 223000.0n 0.4857 223249.9n 0.4857 223250.0n 0.5851 223499.9n 0.5851 223500.0n 0.1178 223749.9n 0.1178 223750.0n 0.3966 223999.9n 0.3966 224000.0n 0.5682 224249.9n 0.5682 224250.0n 0.8124 224499.9n 0.8124 224500.0n 0.4362 224749.9n 0.4362 224750.0n 0.3739 224999.9n 0.3739 225000.0n 0.5810 225249.9n 0.5810 225250.0n 0.6001 225499.9n 0.6001 225500.0n 0.1795 225749.9n 0.1795 225750.0n 0.4834 225999.9n 0.4834 226000.0n 0.4857 226249.9n 0.4857 226250.0n 0.6594 226499.9n 0.6594 226500.0n 0.5344 226749.9n 0.5344 226750.0n 0.6490 226999.9n 0.6490 227000.0n 0.4166 227249.9n 0.4166 227250.0n 0.6434 227499.9n 0.6434 227500.0n 0.5682 227749.9n 0.5682 227750.0n 0.7608 227999.9n 0.7608 228000.0n 0.7792 228249.9n 0.7792 228250.0n 0.3107 228499.9n 0.3107 228500.0n 0.5828 228749.9n 0.5828 228750.0n 0.6754 228999.9n 0.6754 229000.0n 0.4149 229249.9n 0.4149 229250.0n 0.8897 229499.9n 0.8897 229500.0n 0.0625 229749.9n 0.0625 229750.0n 0.5373 229999.9n 0.5373 230000.0n 0.2205 230249.9n 0.2205 230250.0n 0.1548 230499.9n 0.1548 230500.0n 0.8701 230749.9n 0.8701 230750.0n 0.4959 230999.9n 0.4959 231000.0n 0.4589 231249.9n 0.4589 231250.0n 0.1662 231499.9n 0.1662 231500.0n 0.5851 231749.9n 0.5851 231750.0n 0.3113 231999.9n 0.3113 232000.0n 0.6668 232249.9n 0.6668 232250.0n 0.1178 232499.9n 0.1178 232500.0n 0.1733 232749.9n 0.1733 232750.0n 0.7259 232999.9n 0.7259 233000.0n 0.4628 233249.9n 0.4628 233250.0n 0.4621 233499.9n 0.4621 233500.0n 0.4447 233749.9n 0.4447 233750.0n 0.3739 233999.9n 0.3739 234000.0n 0.3461 234249.9n 0.3461 234250.0n 0.1745 234499.9n 0.1745 234500.0n 0.8124 234749.9n 0.8124 234750.0n 0.8837 234999.9n 0.8837 235000.0n 0.3383 235249.9n 0.3383 235250.0n 0.5672 235499.9n 0.5672 235500.0n 0.6041 235749.9n 0.6041 235750.0n 0.3560 235999.9n 0.3560 236000.0n 0.3834 236249.9n 0.3834 236250.0n 0.4913 236499.9n 0.4913 236500.0n 0.5490 236749.9n 0.5490 236750.0n 0.4362 236999.9n 0.4362 237000.0n 0.3966 237249.9n 0.3966 237250.0n 0.8206 237499.9n 0.8206 237500.0n 0.7953 237749.9n 0.7953 237750.0n 0.4494 237999.9n 0.4494 238000.0n 0.4974 238249.9n 0.4974 238250.0n 0.5108 238499.9n 0.5108 238500.0n 0.4287 238749.9n 0.4287 238750.0n 0.3521 238999.9n 0.3521 239000.0n 0.6102 239249.9n 0.6102 239250.0n 0.5464 239499.9n 0.5464 239500.0n 0.5952 239749.9n 0.5952 239750.0n 0.4950 239999.9n 0.4950 240000.0n 0.6754 240249.9n 0.6754 240250.0n 0.4166 240499.9n 0.4166 240500.0n 0.4950 240749.9n 0.4950 240750.0n 0.1795 240999.9n 0.1795 241000.0n 0.6490 241249.9n 0.6490 241250.0n 0.3107 241499.9n 0.3107 241500.0n 0.3383 241749.9n 0.3383 241750.0n 0.4959 241999.9n 0.4959 242000.0n 0.4447 242249.9n 0.4447 242250.0n 0.4857 242499.9n 0.4857 242500.0n 0.3739 242749.9n 0.3739 242750.0n 0.4628 242999.9n 0.4628 243000.0n 0.1662 243249.9n 0.1662 243250.0n 0.8837 243499.9n 0.8837 243500.0n 0.4974 243749.9n 0.4974 243750.0n 0.4287 243999.9n 0.4287 244000.0n 0.5464 244249.9n 0.5464 244250.0n 0.3966 244499.9n 0.3966 244500.0n 0.4621 244749.9n 0.4621 244750.0n 0.8206 244999.9n 0.8206 245000.0n 0.5828 245249.9n 0.5828 245250.0n 0.6668 245499.9n 0.6668 245500.0n 0.5373 245749.9n 0.5373 245750.0n 0.4494 245999.9n 0.4494 246000.0n 0.5851 246249.9n 0.5851 246250.0n 0.7608 246499.9n 0.7608 246500.0n 0.8124 246749.9n 0.8124 246750.0n 0.5108 246999.9n 0.5108 247000.0n 0.8897 247249.9n 0.8897 247250.0n 0.6434 247499.9n 0.6434 247500.0n 0.3461 247749.9n 0.3461 247750.0n 0.6041 247999.9n 0.6041 248000.0n 0.3113 248249.9n 0.3113 248250.0n 0.5810 248499.9n 0.5810 248500.0n 0.3834 248749.9n 0.3834 248750.0n 0.1548 248999.9n 0.1548 249000.0n 0.5672 249249.9n 0.5672 249250.0n 0.6594 249499.9n 0.6594 249500.0n 0.1745 249749.9n 0.1745 249750.0n 0.5344 249999.9n 0.5344 250000.0n 0.4362 250249.9n 0.4362 250250.0n 0.0625 250499.9n 0.0625 250500.0n 0.3521 250749.9n 0.3521 250750.0n 0.6102 250999.9n 0.6102 251000.0n 0.5682 251249.9n 0.5682 251250.0n 0.4149 251499.9n 0.4149 251500.0n 0.2205 251749.9n 0.2205 251750.0n 0.4589 251999.9n 0.4589 252000.0n 0.4834 252249.9n 0.4834 252250.0n 0.3560 252499.9n 0.3560 252500.0n 0.4913 252749.9n 0.4913 252750.0n 0.7953 252999.9n 0.7953 253000.0n 0.8701 253249.9n 0.8701 253250.0n 0.5490 253499.9n 0.5490 253500.0n 0.7259 253749.9n 0.7259 253750.0n 0.1733 253999.9n 0.1733 254000.0n 0.6001 254249.9n 0.6001 254250.0n 0.7792 254499.9n 0.7792 254500.0n 0.1178 254749.9n 0.1178 254750.0n 0.5952 254999.9n 0.5952 255000.0n 0.5682 255249.9n 0.5682 255250.0n 0.8837 255499.9n 0.8837 255500.0n 0.8124 255749.9n 0.8124 255750.0n 0.3966 255999.9n 0.3966 256000.0n 0.5810 256249.9n 0.5810 256250.0n 0.5344 256499.9n 0.5344 256500.0n 0.5828 256749.9n 0.5828 256750.0n 0.3521 256999.9n 0.3521 257000.0n 0.4149 257249.9n 0.4149 257250.0n 0.6490 257499.9n 0.6490 257500.0n 0.4974 257749.9n 0.4974 257750.0n 0.4834 257999.9n 0.4834 258000.0n 0.0625 258249.9n 0.0625 258250.0n 0.5490 258499.9n 0.5490 258500.0n 0.5464 258749.9n 0.5464 258750.0n 0.3739 258999.9n 0.3739 259000.0n 0.1795 259249.9n 0.1795 259250.0n 0.6754 259499.9n 0.6754 259500.0n 0.4857 259749.9n 0.4857 259750.0n 0.3834 259999.9n 0.3834 260000.0n 0.6668 260249.9n 0.6668 260250.0n 0.7259 260499.9n 0.7259 260500.0n 0.1662 260749.9n 0.1662 260750.0n 0.6594 260999.9n 0.6594 261000.0n 0.3113 261249.9n 0.3113 261250.0n 0.4913 261499.9n 0.4913 261500.0n 0.4362 261749.9n 0.4362 261750.0n 0.4950 261999.9n 0.4950 262000.0n 0.2205 262249.9n 0.2205 262250.0n 0.7792 262499.9n 0.7792 262500.0n 0.1178 262749.9n 0.1178 262750.0n 0.8897 262999.9n 0.8897 263000.0n 0.4589 263249.9n 0.4589 263250.0n 0.4494 263499.9n 0.4494 263500.0n 0.8206 263749.9n 0.8206 263750.0n 0.3560 263999.9n 0.3560 264000.0n 0.7608 264249.9n 0.7608 264250.0n 0.8701 264499.9n 0.8701 264500.0n 0.3461 264749.9n 0.3461 264750.0n 0.4628 264999.9n 0.4628 265000.0n 0.1733 265249.9n 0.1733 265250.0n 0.5952 265499.9n 0.5952 265500.0n 0.6001 265749.9n 0.6001 265750.0n 0.5851 265999.9n 0.5851 266000.0n 0.3383 266249.9n 0.3383 266250.0n 0.5373 266499.9n 0.5373 266500.0n 0.7953 266749.9n 0.7953 266750.0n 0.3107 266999.9n 0.3107 267000.0n 0.4959 267249.9n 0.4959 267250.0n 0.6102 267499.9n 0.6102 267500.0n 0.6041 267749.9n 0.6041 267750.0n 0.5672 267999.9n 0.5672 268000.0n 0.4621 268249.9n 0.4621 268250.0n 0.1745 268499.9n 0.1745 268500.0n 0.5108 268749.9n 0.5108 268750.0n 0.4166 268999.9n 0.4166 269000.0n 0.6434 269249.9n 0.6434 269250.0n 0.4447 269499.9n 0.4447 269500.0n 0.4287 269749.9n 0.4287 269750.0n 0.1548 269999.9n 0.1548 270000.0n 0.5810 270249.9n 0.5810 270250.0n 0.5108 270499.9n 0.5108 270500.0n 0.3739 270749.9n 0.3739 270750.0n 0.1745 270999.9n 0.1745 271000.0n 0.4447 271249.9n 0.4447 271250.0n 0.8837 271499.9n 0.8837 271500.0n 0.3383 271749.9n 0.3383 271750.0n 0.3521 271999.9n 0.3521 272000.0n 0.4913 272249.9n 0.4913 272250.0n 0.4494 272499.9n 0.4494 272500.0n 0.4287 272749.9n 0.4287 272750.0n 0.6102 272999.9n 0.6102 273000.0n 0.8206 273249.9n 0.8206 273250.0n 0.3560 273499.9n 0.3560 273500.0n 0.4950 273749.9n 0.4950 273750.0n 0.3113 273999.9n 0.3113 274000.0n 0.7608 274249.9n 0.7608 274250.0n 0.6594 274499.9n 0.6594 274500.0n 0.1548 274749.9n 0.1548 274750.0n 0.1662 274999.9n 0.1662 275000.0n 0.4959 275249.9n 0.4959 275250.0n 0.3834 275499.9n 0.3834 275500.0n 0.4628 275749.9n 0.4628 275750.0n 0.5464 275999.9n 0.5464 276000.0n 0.4589 276249.9n 0.4589 276250.0n 0.3966 276499.9n 0.3966 276500.0n 0.5952 276749.9n 0.5952 276750.0n 0.2205 276999.9n 0.2205 277000.0n 0.8897 277249.9n 0.8897 277250.0n 0.8124 277499.9n 0.8124 277500.0n 0.5373 277749.9n 0.5373 277750.0n 0.8701 277999.9n 0.8701 278000.0n 0.4834 278249.9n 0.4834 278250.0n 0.7792 278499.9n 0.7792 278500.0n 0.6668 278749.9n 0.6668 278750.0n 0.4149 278999.9n 0.4149 279000.0n 0.6754 279249.9n 0.6754 279250.0n 0.5672 279499.9n 0.5672 279500.0n 0.1178 279749.9n 0.1178 279750.0n 0.5828 279999.9n 0.5828 280000.0n 0.4362 280249.9n 0.4362 280250.0n 0.4974 280499.9n 0.4974 280500.0n 0.4621 280749.9n 0.4621 280750.0n 0.4166 280999.9n 0.4166 281000.0n 0.5490 281249.9n 0.5490 281250.0n 0.6001 281499.9n 0.6001 281500.0n 0.5344 281749.9n 0.5344 281750.0n 0.5851 281999.9n 0.5851 282000.0n 0.0625 282249.9n 0.0625 282250.0n 0.6041 282499.9n 0.6041 282500.0n 0.1733 282749.9n 0.1733 282750.0n 0.6490 282999.9n 0.6490 283000.0n 0.7953 283249.9n 0.7953 283250.0n 0.4857 283499.9n 0.4857 283500.0n 0.6434 283749.9n 0.6434 283750.0n 0.1795 283999.9n 0.1795 284000.0n 0.5682 284249.9n 0.5682 284250.0n 0.3107 284499.9n 0.3107 284500.0n 0.7259 284749.9n 0.7259 284750.0n 0.3461 284999.9n 0.3461 285000.0n 0.6490 285249.9n 0.6490 285250.0n 0.0625 285499.9n 0.0625 285500.0n 0.4834 285749.9n 0.4834 285750.0n 0.3461 285999.9n 0.3461 286000.0n 0.8837 286249.9n 0.8837 286250.0n 0.1548 286499.9n 0.1548 286500.0n 0.3966 286749.9n 0.3966 286750.0n 0.8206 286999.9n 0.8206 287000.0n 0.4950 287249.9n 0.4950 287250.0n 0.3107 287499.9n 0.3107 287500.0n 0.6041 287749.9n 0.6041 287750.0n 0.4447 287999.9n 0.4447 288000.0n 0.4621 288249.9n 0.4621 288250.0n 0.2205 288499.9n 0.2205 288500.0n 0.4857 288749.9n 0.4857 288750.0n 0.3834 288999.9n 0.3834 289000.0n 0.5672 289249.9n 0.5672 289250.0n 0.5373 289499.9n 0.5373 289500.0n 0.5952 289749.9n 0.5952 289750.0n 0.6594 289999.9n 0.6594 290000.0n 0.6668 290249.9n 0.6668 290250.0n 0.1178 290499.9n 0.1178 290500.0n 0.3560 290749.9n 0.3560 290750.0n 0.3739 290999.9n 0.3739 291000.0n 0.5108 291249.9n 0.5108 291250.0n 0.4589 291499.9n 0.4589 291500.0n 0.1662 291749.9n 0.1662 291750.0n 0.6754 291999.9n 0.6754 292000.0n 0.3383 292249.9n 0.3383 292250.0n 0.6434 292499.9n 0.6434 292500.0n 0.7608 292749.9n 0.7608 292750.0n 0.5464 292999.9n 0.5464 293000.0n 0.5682 293249.9n 0.5682 293250.0n 0.4287 293499.9n 0.4287 293500.0n 0.5851 293749.9n 0.5851 293750.0n 0.6001 293999.9n 0.6001 294000.0n 0.4913 294249.9n 0.4913 294250.0n 0.8897 294499.9n 0.8897 294500.0n 0.4628 294749.9n 0.4628 294750.0n 0.1795 294999.9n 0.1795 295000.0n 0.5810 295249.9n 0.5810 295250.0n 0.1733 295499.9n 0.1733 295500.0n 0.4362 295749.9n 0.4362 295750.0n 0.7953 295999.9n 0.7953 296000.0n 0.8701 296249.9n 0.8701 296250.0n 0.3113 296499.9n 0.3113 296500.0n 0.5344 296749.9n 0.5344 296750.0n 0.5828 296999.9n 0.5828 297000.0n 0.4959 297249.9n 0.4959 297250.0n 0.6102 297499.9n 0.6102 297500.0n 0.4974 297749.9n 0.4974 297750.0n 0.8124 297999.9n 0.8124 298000.0n 0.1745 298249.9n 0.1745 298250.0n 0.7792 298499.9n 0.7792 298500.0n 0.4149 298749.9n 0.4149 298750.0n 0.7259 298999.9n 0.7259 299000.0n 0.4166 299249.9n 0.4166 299250.0n 0.5490 299499.9n 0.5490 299500.0n 0.3521 299749.9n 0.3521 299750.0n 0.4494 299999.9n 0.4494 300000.0n 0.4362 300249.9n 0.4362 300250.0n 0.5828 300499.9n 0.5828 300500.0n 0.3739 300749.9n 0.3739 300750.0n 0.1733 300999.9n 0.1733 301000.0n 0.4149 301249.9n 0.4149 301250.0n 0.5344 301499.9n 0.5344 301500.0n 0.1178 301749.9n 0.1178 301750.0n 0.6594 301999.9n 0.6594 302000.0n 0.8124 302249.9n 0.8124 302250.0n 0.4447 302499.9n 0.4447 302500.0n 0.4950 302749.9n 0.4950 302750.0n 0.4834 302999.9n 0.4834 303000.0n 0.5373 303249.9n 0.5373 303250.0n 0.1795 303499.9n 0.1795 303500.0n 0.3461 303749.9n 0.3461 303750.0n 0.3521 303999.9n 0.3521 304000.0n 0.5851 304249.9n 0.5851 304250.0n 0.5490 304499.9n 0.5490 304500.0n 0.3113 304749.9n 0.3113 304750.0n 0.7792 304999.9n 0.7792 305000.0n 0.5672 305249.9n 0.5672 305250.0n 0.7259 305499.9n 0.7259 305500.0n 0.5682 305749.9n 0.5682 305750.0n 0.4494 305999.9n 0.4494 306000.0n 0.6102 306249.9n 0.6102 306250.0n 0.8897 306499.9n 0.8897 306500.0n 0.6041 306749.9n 0.6041 306750.0n 0.4857 306999.9n 0.4857 307000.0n 0.1662 307249.9n 0.1662 307250.0n 0.2205 307499.9n 0.2205 307500.0n 0.6434 307749.9n 0.6434 307750.0n 0.6001 307999.9n 0.6001 308000.0n 0.4287 308249.9n 0.4287 308250.0n 0.5952 308499.9n 0.5952 308500.0n 0.7608 308749.9n 0.7608 308750.0n 0.1548 308999.9n 0.1548 309000.0n 0.4628 309249.9n 0.4628 309250.0n 0.5108 309499.9n 0.5108 309500.0n 0.3834 309749.9n 0.3834 309750.0n 0.6490 309999.9n 0.6490 310000.0n 0.4589 310249.9n 0.4589 310250.0n 0.3107 310499.9n 0.3107 310500.0n 0.8206 310749.9n 0.8206 310750.0n 0.4974 310999.9n 0.4974 311000.0n 0.8701 311249.9n 0.8701 311250.0n 0.3560 311499.9n 0.3560 311500.0n 0.4959 311749.9n 0.4959 311750.0n 0.3966 311999.9n 0.3966 312000.0n 0.4913 312249.9n 0.4913 312250.0n 0.1745 312499.9n 0.1745 312500.0n 0.0625 312749.9n 0.0625 312750.0n 0.4621 312999.9n 0.4621 313000.0n 0.5464 313249.9n 0.5464 313250.0n 0.6754 313499.9n 0.6754 313500.0n 0.3383 313749.9n 0.3383 313750.0n 0.6668 313999.9n 0.6668 314000.0n 0.8837 314249.9n 0.8837 314250.0n 0.4166 314499.9n 0.4166 314500.0n 0.5810 314749.9n 0.5810 314750.0n 0.7953 314999.9n 0.7953 315000.0n 0.4287 315249.9n 0.4287 315250.0n 0.1733 315499.9n 0.1733 315500.0n 0.5464 315749.9n 0.5464 315750.0n 0.8701 315999.9n 0.8701 316000.0n 0.4589 316249.9n 0.4589 316250.0n 0.6001 316499.9n 0.6001 316500.0n 0.4149 316749.9n 0.4149 316750.0n 0.7608 316999.9n 0.7608 317000.0n 0.3461 317249.9n 0.3461 317250.0n 0.3560 317499.9n 0.3560 317500.0n 0.7953 317749.9n 0.7953 317750.0n 0.1548 317999.9n 0.1548 318000.0n 0.5490 318249.9n 0.5490 318250.0n 0.4913 318499.9n 0.4913 318500.0n 0.2205 318749.9n 0.2205 318750.0n 0.1178 318999.9n 0.1178 319000.0n 0.1745 319249.9n 0.1745 319250.0n 0.5682 319499.9n 0.5682 319500.0n 0.3739 319749.9n 0.3739 319750.0n 0.5344 319999.9n 0.5344 320000.0n 0.4362 320249.9n 0.4362 320250.0n 0.5810 320499.9n 0.5810 320500.0n 0.4166 320749.9n 0.4166 320750.0n 0.1795 320999.9n 0.1795 321000.0n 0.5108 321249.9n 0.5108 321250.0n 0.3113 321499.9n 0.3113 321500.0n 0.6490 321749.9n 0.6490 321750.0n 0.4974 321999.9n 0.4974 322000.0n 0.5952 322249.9n 0.5952 322250.0n 0.4959 322499.9n 0.4959 322500.0n 0.6754 322749.9n 0.6754 322750.0n 0.7259 322999.9n 0.7259 323000.0n 0.6102 323249.9n 0.6102 323250.0n 0.8206 323499.9n 0.8206 323500.0n 0.6041 323749.9n 0.6041 323750.0n 0.0625 323999.9n 0.0625 324000.0n 0.4834 324249.9n 0.4834 324250.0n 0.3521 324499.9n 0.3521 324500.0n 0.4950 324749.9n 0.4950 324750.0n 0.6668 324999.9n 0.6668 325000.0n 0.8124 325249.9n 0.8124 325250.0n 0.4447 325499.9n 0.4447 325500.0n 0.5851 325749.9n 0.5851 325750.0n 0.7792 325999.9n 0.7792 326000.0n 0.3834 326249.9n 0.3834 326250.0n 0.3383 326499.9n 0.3383 326500.0n 0.4621 326749.9n 0.4621 326750.0n 0.8897 326999.9n 0.8897 327000.0n 0.6434 327249.9n 0.6434 327250.0n 0.3966 327499.9n 0.3966 327500.0n 0.3107 327749.9n 0.3107 327750.0n 0.4494 327999.9n 0.4494 328000.0n 0.5373 328249.9n 0.5373 328250.0n 0.5828 328499.9n 0.5828 328500.0n 0.4628 328749.9n 0.4628 328750.0n 0.8837 328999.9n 0.8837 329000.0n 0.4857 329249.9n 0.4857 329250.0n 0.5672 329499.9n 0.5672 329500.0n 0.1662 329749.9n 0.1662 329750.0n 0.6594 329999.9n 0.6594 330000.0n 0.5810 330249.9n 0.5810 330250.0n 0.5108 330499.9n 0.5108 330500.0n 0.6490 330749.9n 0.6490 330750.0n 0.4589 330999.9n 0.4589 331000.0n 0.5490 331249.9n 0.5490 331250.0n 0.4494 331499.9n 0.4494 331500.0n 0.5952 331749.9n 0.5952 331750.0n 0.4834 331999.9n 0.4834 332000.0n 0.6001 332249.9n 0.6001 332250.0n 0.6594 332499.9n 0.6594 332500.0n 0.3461 332749.9n 0.3461 332750.0n 0.3521 332999.9n 0.3521 333000.0n 0.3739 333249.9n 0.3739 333250.0n 0.0625 333499.9n 0.0625 333500.0n 0.6668 333749.9n 0.6668 333750.0n 0.7608 333999.9n 0.7608 334000.0n 0.3113 334249.9n 0.3113 334250.0n 0.1795 334499.9n 0.1795 334500.0n 0.7259 334749.9n 0.7259 334750.0n 0.4166 334999.9n 0.4166 335000.0n 0.8837 335249.9n 0.8837 335250.0n 0.5344 335499.9n 0.5344 335500.0n 0.3966 335749.9n 0.3966 335750.0n 0.4621 335999.9n 0.4621 336000.0n 0.4362 336249.9n 0.4362 336250.0n 0.4628 336499.9n 0.4628 336500.0n 0.4959 336749.9n 0.4959 336750.0n 0.5682 336999.9n 0.5682 337000.0n 0.5672 337249.9n 0.5672 337250.0n 0.7953 337499.9n 0.7953 337500.0n 0.8897 337749.9n 0.8897 337750.0n 0.4287 337999.9n 0.4287 338000.0n 0.3383 338249.9n 0.3383 338250.0n 0.6434 338499.9n 0.6434 338500.0n 0.1178 338749.9n 0.1178 338750.0n 0.5851 338999.9n 0.5851 339000.0n 0.5464 339249.9n 0.5464 339250.0n 0.8124 339499.9n 0.8124 339500.0n 0.1548 339749.9n 0.1548 339750.0n 0.4149 339999.9n 0.4149 340000.0n 0.8206 340249.9n 0.8206 340250.0n 0.4974 340499.9n 0.4974 340500.0n 0.3834 340749.9n 0.3834 340750.0n 0.4913 340999.9n 0.4913 341000.0n 0.4447 341249.9n 0.4447 341250.0n 0.7792 341499.9n 0.7792 341500.0n 0.4857 341749.9n 0.4857 341750.0n 0.4950 341999.9n 0.4950 342000.0n 0.3560 342249.9n 0.3560 342250.0n 0.1733 342499.9n 0.1733 342500.0n 0.3107 342749.9n 0.3107 342750.0n 0.8701 342999.9n 0.8701 343000.0n 0.1662 343249.9n 0.1662 343250.0n 0.6041 343499.9n 0.6041 343500.0n 0.6102 343749.9n 0.6102 343750.0n 0.1745 343999.9n 0.1745 344000.0n 0.2205 344249.9n 0.2205 344250.0n 0.5373 344499.9n 0.5373 344500.0n 0.6754 344749.9n 0.6754 344750.0n 0.5828 344999.9n 0.5828 345000.0n 0.5851 345249.9n 0.5851 345250.0n 0.5672 345499.9n 0.5672 345500.0n 0.4834 345749.9n 0.4834 345750.0n 0.6001 345999.9n 0.6001 346000.0n 0.4166 346249.9n 0.4166 346250.0n 0.5682 346499.9n 0.5682 346500.0n 0.3107 346749.9n 0.3107 346750.0n 0.1548 346999.9n 0.1548 347000.0n 0.3560 347249.9n 0.3560 347250.0n 0.5952 347499.9n 0.5952 347500.0n 0.8206 347749.9n 0.8206 347750.0n 0.0625 347999.9n 0.0625 348000.0n 0.4362 348249.9n 0.4362 348250.0n 0.5344 348499.9n 0.5344 348500.0n 0.4149 348749.9n 0.4149 348750.0n 0.5828 348999.9n 0.5828 349000.0n 0.5373 349249.9n 0.5373 349250.0n 0.8124 349499.9n 0.8124 349500.0n 0.4447 349749.9n 0.4447 349750.0n 0.4287 349999.9n 0.4287 350000.0n 0.8701 350249.9n 0.8701 350250.0n 0.5490 350499.9n 0.5490 350500.0n 0.4621 350749.9n 0.4621 350750.0n 0.3113 350999.9n 0.3113 351000.0n 0.4974 351249.9n 0.4974 351250.0n 0.3383 351499.9n 0.3383 351500.0n 0.2205 351749.9n 0.2205 351750.0n 0.1745 351999.9n 0.1745 352000.0n 0.5464 352249.9n 0.5464 352250.0n 0.8837 352499.9n 0.8837 352500.0n 0.6490 352749.9n 0.6490 352750.0n 0.7953 352999.9n 0.7953 353000.0n 0.7259 353249.9n 0.7259 353250.0n 0.1733 353499.9n 0.1733 353500.0n 0.5108 353749.9n 0.5108 353750.0n 0.3966 353999.9n 0.3966 354000.0n 0.1795 354249.9n 0.1795 354250.0n 0.6594 354499.9n 0.6594 354500.0n 0.1662 354749.9n 0.1662 354750.0n 0.3739 354999.9n 0.3739 355000.0n 0.4950 355249.9n 0.4950 355250.0n 0.4959 355499.9n 0.4959 355500.0n 0.6102 355749.9n 0.6102 355750.0n 0.4857 355999.9n 0.4857 356000.0n 0.3834 356249.9n 0.3834 356250.0n 0.7608 356499.9n 0.7608 356500.0n 0.3461 356749.9n 0.3461 356750.0n 0.3521 356999.9n 0.3521 357000.0n 0.6434 357249.9n 0.6434 357250.0n 0.1178 357499.9n 0.1178 357500.0n 0.4913 357749.9n 0.4913 357750.0n 0.4628 357999.9n 0.4628 358000.0n 0.6041 358249.9n 0.6041 358250.0n 0.5810 358499.9n 0.5810 358500.0n 0.4494 358749.9n 0.4494 358750.0n 0.6668 358999.9n 0.6668 359000.0n 0.7792 359249.9n 0.7792 359250.0n 0.4589 359499.9n 0.4589 359500.0n 0.6754 359749.9n 0.6754 359750.0n 0.8897 359999.9n 0.8897 360000.0n 0.6001 360249.9n 0.6001 360250.0n 0.5828 360499.9n 0.5828 360500.0n 0.4913 360749.9n 0.4913 360750.0n 0.7792 360999.9n 0.7792 361000.0n 0.1548 361249.9n 0.1548 361250.0n 0.5672 361499.9n 0.5672 361500.0n 0.6754 361749.9n 0.6754 361750.0n 0.2205 361999.9n 0.2205 362000.0n 0.3739 362249.9n 0.3739 362250.0n 0.0625 362499.9n 0.0625 362500.0n 0.1745 362749.9n 0.1745 362750.0n 0.6041 362999.9n 0.6041 363000.0n 0.5464 363249.9n 0.5464 363250.0n 0.4834 363499.9n 0.4834 363500.0n 0.4959 363749.9n 0.4959 363750.0n 0.6594 363999.9n 0.6594 364000.0n 0.8701 364249.9n 0.8701 364250.0n 0.3560 364499.9n 0.3560 364500.0n 0.4589 364749.9n 0.4589 364750.0n 0.7953 364999.9n 0.7953 365000.0n 0.3521 365249.9n 0.3521 365250.0n 0.5682 365499.9n 0.5682 365500.0n 0.8124 365749.9n 0.8124 365750.0n 0.6434 365999.9n 0.6434 366000.0n 0.1795 366249.9n 0.1795 366250.0n 0.6668 366499.9n 0.6668 366500.0n 0.5952 366749.9n 0.5952 366750.0n 0.4362 366999.9n 0.4362 367000.0n 0.1178 367249.9n 0.1178 367250.0n 0.3461 367499.9n 0.3461 367500.0n 0.3107 367749.9n 0.3107 367750.0n 0.5108 367999.9n 0.5108 368000.0n 0.4628 368249.9n 0.4628 368250.0n 0.4166 368499.9n 0.4166 368500.0n 0.4857 368749.9n 0.4857 368750.0n 0.7259 368999.9n 0.7259 369000.0n 0.5490 369249.9n 0.5490 369250.0n 0.3113 369499.9n 0.3113 369500.0n 0.4621 369749.9n 0.4621 369750.0n 0.7608 369999.9n 0.7608 370000.0n 0.4494 370249.9n 0.4494 370250.0n 0.5373 370499.9n 0.5373 370500.0n 0.6102 370749.9n 0.6102 370750.0n 0.4447 370999.9n 0.4447 371000.0n 0.5851 371249.9n 0.5851 371250.0n 0.8206 371499.9n 0.8206 371500.0n 0.8837 371749.9n 0.8837 371750.0n 0.5344 371999.9n 0.5344 372000.0n 0.5810 372249.9n 0.5810 372250.0n 0.6490 372499.9n 0.6490 372500.0n 0.4149 372749.9n 0.4149 372750.0n 0.8897 372999.9n 0.8897 373000.0n 0.4974 373249.9n 0.4974 373250.0n 0.1662 373499.9n 0.1662 373500.0n 0.3834 373749.9n 0.3834 373750.0n 0.1733 373999.9n 0.1733 374000.0n 0.4950 374249.9n 0.4950 374250.0n 0.3383 374499.9n 0.3383 374500.0n 0.3966 374749.9n 0.3966 374750.0n 0.4287 374999.9n 0.4287 375000.0n 0.6754 375249.9n 0.6754 375250.0n 0.6668 375499.9n 0.6668 375500.0n 0.4950 375749.9n 0.4950 375750.0n 0.6490 375999.9n 0.6490 376000.0n 0.7608 376249.9n 0.7608 376250.0n 0.4494 376499.9n 0.4494 376500.0n 0.4974 376749.9n 0.4974 376750.0n 0.4628 376999.9n 0.4628 377000.0n 0.7792 377249.9n 0.7792 377250.0n 0.3113 377499.9n 0.3113 377500.0n 0.5952 377749.9n 0.5952 377750.0n 0.1795 377999.9n 0.1795 378000.0n 0.4287 378249.9n 0.4287 378250.0n 0.5810 378499.9n 0.5810 378500.0n 0.5682 378749.9n 0.5682 378750.0n 0.3107 378999.9n 0.3107 379000.0n 0.7953 379249.9n 0.7953 379250.0n 0.4362 379499.9n 0.4362 379500.0n 0.2205 379749.9n 0.2205 379750.0n 0.7259 379999.9n 0.7259 380000.0n 0.4959 380249.9n 0.4959 380250.0n 0.5464 380499.9n 0.5464 380500.0n 0.1548 380749.9n 0.1548 380750.0n 0.3966 380999.9n 0.3966 381000.0n 0.0625 381249.9n 0.0625 381250.0n 0.3521 381499.9n 0.3521 381500.0n 0.6434 381749.9n 0.6434 381750.0n 0.5490 381999.9n 0.5490 382000.0n 0.3560 382249.9n 0.3560 382250.0n 0.6041 382499.9n 0.6041 382500.0n 0.3834 382749.9n 0.3834 382750.0n 0.8701 382999.9n 0.8701 383000.0n 0.5851 383249.9n 0.5851 383250.0n 0.3739 383499.9n 0.3739 383500.0n 0.1178 383749.9n 0.1178 383750.0n 0.5672 383999.9n 0.5672 384000.0n 0.4166 384249.9n 0.4166 384250.0n 0.1733 384499.9n 0.1733 384500.0n 0.3461 384749.9n 0.3461 384750.0n 0.6102 384999.9n 0.6102 385000.0n 0.4913 385249.9n 0.4913 385250.0n 0.8897 385499.9n 0.8897 385500.0n 0.4149 385749.9n 0.4149 385750.0n 0.4857 385999.9n 0.4857 386000.0n 0.8124 386249.9n 0.8124 386250.0n 0.5373 386499.9n 0.5373 386500.0n 0.3383 386749.9n 0.3383 386750.0n 0.1662 386999.9n 0.1662 387000.0n 0.6594 387249.9n 0.6594 387250.0n 0.5344 387499.9n 0.5344 387500.0n 0.4589 387749.9n 0.4589 387750.0n 0.1745 387999.9n 0.1745 388000.0n 0.5108 388249.9n 0.5108 388250.0n 0.8837 388499.9n 0.8837 388500.0n 0.5828 388749.9n 0.5828 388750.0n 0.4447 388999.9n 0.4447 389000.0n 0.8206 389249.9n 0.8206 389250.0n 0.4834 389499.9n 0.4834 389500.0n 0.6001 389749.9n 0.6001 389750.0n 0.4621 389999.9n 0.4621 390000.0n 0.4621 390249.9n 0.4621 390250.0n 0.2205 390499.9n 0.2205 390500.0n 0.4913 390749.9n 0.4913 390750.0n 0.4628 390999.9n 0.4628 391000.0n 0.8124 391249.9n 0.8124 391250.0n 0.5851 391499.9n 0.5851 391500.0n 0.3107 391749.9n 0.3107 391750.0n 0.1662 391999.9n 0.1662 392000.0n 0.3739 392249.9n 0.3739 392250.0n 0.6754 392499.9n 0.6754 392500.0n 0.4494 392749.9n 0.4494 392750.0n 0.3113 392999.9n 0.3113 393000.0n 0.3966 393249.9n 0.3966 393250.0n 0.5672 393499.9n 0.5672 393500.0n 0.1548 393749.9n 0.1548 393750.0n 0.5810 393999.9n 0.5810 394000.0n 0.5344 394249.9n 0.5344 394250.0n 0.3521 394499.9n 0.3521 394500.0n 0.7259 394749.9n 0.7259 394750.0n 0.6041 394999.9n 0.6041 395000.0n 0.7608 395249.9n 0.7608 395250.0n 0.5464 395499.9n 0.5464 395500.0n 0.4974 395749.9n 0.4974 395750.0n 0.8837 395999.9n 0.8837 396000.0n 0.8897 396249.9n 0.8897 396250.0n 0.5682 396499.9n 0.5682 396500.0n 0.0625 396749.9n 0.0625 396750.0n 0.4149 396999.9n 0.4149 397000.0n 0.4166 397249.9n 0.4166 397250.0n 0.7953 397499.9n 0.7953 397500.0n 0.5108 397749.9n 0.5108 397750.0n 0.4362 397999.9n 0.4362 398000.0n 0.4950 398249.9n 0.4950 398250.0n 0.6594 398499.9n 0.6594 398500.0n 0.6490 398749.9n 0.6490 398750.0n 0.4447 398999.9n 0.4447 399000.0n 0.3560 399249.9n 0.3560 399250.0n 0.1795 399499.9n 0.1795 399500.0n 0.1178 399749.9n 0.1178 399750.0n 0.6668 399999.9n 0.6668 400000.0n 0.4589 400249.9n 0.4589 400250.0n 0.5952 400499.9n 0.5952 400500.0n 0.4834 400749.9n 0.4834 400750.0n 0.1745 400999.9n 0.1745 401000.0n 0.3834 401249.9n 0.3834 401250.0n 0.5828 401499.9n 0.5828 401500.0n 0.4857 401749.9n 0.4857 401750.0n 0.6434 401999.9n 0.6434 402000.0n 0.8701 402249.9n 0.8701 402250.0n 0.5373 402499.9n 0.5373 402500.0n 0.3461 402749.9n 0.3461 402750.0n 0.4287 402999.9n 0.4287 403000.0n 0.6102 403249.9n 0.6102 403250.0n 0.4959 403499.9n 0.4959 403500.0n 0.5490 403749.9n 0.5490 403750.0n 0.8206 403999.9n 0.8206 404000.0n 0.1733 404249.9n 0.1733 404250.0n 0.6001 404499.9n 0.6001 404500.0n 0.7792 404749.9n 0.7792 404750.0n 0.3383 404999.9n 0.3383 405000.0n 0.4621 405249.9n 0.4621 405250.0n 0.0625 405499.9n 0.0625 405500.0n 0.5344 405749.9n 0.5344 405750.0n 0.1795 405999.9n 0.1795 406000.0n 0.7259 406249.9n 0.7259 406250.0n 0.3834 406499.9n 0.3834 406500.0n 0.4950 406749.9n 0.4950 406750.0n 0.5464 406999.9n 0.5464 407000.0n 0.1733 407249.9n 0.1733 407250.0n 0.4974 407499.9n 0.4974 407500.0n 0.4857 407749.9n 0.4857 407750.0n 0.3107 407999.9n 0.3107 408000.0n 0.1745 408249.9n 0.1745 408250.0n 0.6754 408499.9n 0.6754 408500.0n 0.6594 408749.9n 0.6594 408750.0n 0.8206 408999.9n 0.8206 409000.0n 0.5952 409249.9n 0.5952 409250.0n 0.4287 409499.9n 0.4287 409500.0n 0.8124 409749.9n 0.8124 409750.0n 0.3383 409999.9n 0.3383 410000.0n 0.3113 410249.9n 0.3113 410250.0n 0.5108 410499.9n 0.5108 410500.0n 0.4628 410749.9n 0.4628 410750.0n 0.4959 410999.9n 0.4959 411000.0n 0.3521 411249.9n 0.3521 411250.0n 0.5682 411499.9n 0.5682 411500.0n 0.2205 411749.9n 0.2205 411750.0n 0.4494 411999.9n 0.4494 412000.0n 0.5672 412249.9n 0.5672 412250.0n 0.1662 412499.9n 0.1662 412500.0n 0.1178 412749.9n 0.1178 412750.0n 0.4834 412999.9n 0.4834 413000.0n 0.4913 413249.9n 0.4913 413250.0n 0.4589 413499.9n 0.4589 413500.0n 0.8897 413749.9n 0.8897 413750.0n 0.6001 413999.9n 0.6001 414000.0n 0.4166 414249.9n 0.4166 414250.0n 0.4447 414499.9n 0.4447 414500.0n 0.1548 414749.9n 0.1548 414750.0n 0.7792 414999.9n 0.7792 415000.0n 0.5828 415249.9n 0.5828 415250.0n 0.5851 415499.9n 0.5851 415500.0n 0.6102 415749.9n 0.6102 415750.0n 0.5810 415999.9n 0.5810 416000.0n 0.6041 416249.9n 0.6041 416250.0n 0.6668 416499.9n 0.6668 416500.0n 0.6490 416749.9n 0.6490 416750.0n 0.6434 416999.9n 0.6434 417000.0n 0.4149 417249.9n 0.4149 417250.0n 0.8837 417499.9n 0.8837 417500.0n 0.8701 417749.9n 0.8701 417750.0n 0.3739 417999.9n 0.3739 418000.0n 0.3966 418249.9n 0.3966 418250.0n 0.3560 418499.9n 0.3560 418500.0n 0.7608 418749.9n 0.7608 418750.0n 0.5490 418999.9n 0.5490 419000.0n 0.4362 419249.9n 0.4362 419250.0n 0.7953 419499.9n 0.7953 419500.0n 0.3461 419749.9n 0.3461 419750.0n 0.5373 419999.9n 0.5373 420000.0n 0.4857 420249.9n 0.4857 420250.0n 0.3107 420499.9n 0.3107 420500.0n 0.6754 420749.9n 0.6754 420750.0n 0.7608 420999.9n 0.7608 421000.0n 0.4628 421249.9n 0.4628 421250.0n 0.5672 421499.9n 0.5672 421500.0n 0.8206 421749.9n 0.8206 421750.0n 0.3739 421999.9n 0.3739 422000.0n 0.1662 422249.9n 0.1662 422250.0n 0.4149 422499.9n 0.4149 422500.0n 0.5490 422749.9n 0.5490 422750.0n 0.3461 422999.9n 0.3461 423000.0n 0.7953 423249.9n 0.7953 423250.0n 0.5108 423499.9n 0.5108 423500.0n 0.1795 423749.9n 0.1795 423750.0n 0.4494 423999.9n 0.4494 424000.0n 0.4621 424249.9n 0.4621 424250.0n 0.4974 424499.9n 0.4974 424500.0n 0.8837 424749.9n 0.8837 424750.0n 0.8701 424999.9n 0.8701 425000.0n 0.5952 425249.9n 0.5952 425250.0n 0.5810 425499.9n 0.5810 425500.0n 0.4959 425749.9n 0.4959 425750.0n 0.7259 425999.9n 0.7259 426000.0n 0.3834 426249.9n 0.3834 426250.0n 0.6041 426499.9n 0.6041 426500.0n 0.5344 426749.9n 0.5344 426750.0n 0.1178 426999.9n 0.1178 427000.0n 0.5682 427249.9n 0.5682 427250.0n 0.5828 427499.9n 0.5828 427500.0n 0.5851 427749.9n 0.5851 427750.0n 0.1745 427999.9n 0.1745 428000.0n 0.4287 428249.9n 0.4287 428250.0n 0.6434 428499.9n 0.6434 428500.0n 0.3113 428749.9n 0.3113 428750.0n 0.4362 428999.9n 0.4362 429000.0n 0.3560 429249.9n 0.3560 429250.0n 0.6102 429499.9n 0.6102 429500.0n 0.6490 429749.9n 0.6490 429750.0n 0.8124 429999.9n 0.8124 430000.0n 0.6001 430249.9n 0.6001 430250.0n 0.5464 430499.9n 0.5464 430500.0n 0.1733 430749.9n 0.1733 430750.0n 0.3521 430999.9n 0.3521 431000.0n 0.2205 431249.9n 0.2205 431250.0n 0.4913 431499.9n 0.4913 431500.0n 0.8897 431749.9n 0.8897 431750.0n 0.6668 431999.9n 0.6668 432000.0n 0.4589 432249.9n 0.4589 432250.0n 0.6594 432499.9n 0.6594 432500.0n 0.4834 432749.9n 0.4834 432750.0n 0.4447 432999.9n 0.4447 433000.0n 0.4950 433249.9n 0.4950 433250.0n 0.4166 433499.9n 0.4166 433500.0n 0.7792 433749.9n 0.7792 433750.0n 0.3383 433999.9n 0.3383 434000.0n 0.5373 434249.9n 0.5373 434250.0n 0.3966 434499.9n 0.3966 434500.0n 0.1548 434749.9n 0.1548 434750.0n 0.0625 434999.9n 0.0625 435000.0n 0.4857 435249.9n 0.4857 435250.0n 0.3107 435499.9n 0.3107 435500.0n 0.6668 435749.9n 0.6668 435750.0n 0.8206 435999.9n 0.8206 436000.0n 0.5810 436249.9n 0.5810 436250.0n 0.4494 436499.9n 0.4494 436500.0n 0.4950 436749.9n 0.4950 436750.0n 0.4628 436999.9n 0.4628 437000.0n 0.7608 437249.9n 0.7608 437250.0n 0.4362 437499.9n 0.4362 437500.0n 0.4834 437749.9n 0.4834 437750.0n 0.1662 437999.9n 0.1662 438000.0n 0.7792 438249.9n 0.7792 438250.0n 0.4913 438499.9n 0.4913 438500.0n 0.4149 438749.9n 0.4149 438750.0n 0.1733 438999.9n 0.1733 439000.0n 0.7953 439249.9n 0.7953 439250.0n 0.5828 439499.9n 0.5828 439500.0n 0.4589 439749.9n 0.4589 439750.0n 0.4959 439999.9n 0.4959 440000.0n 0.6102 440249.9n 0.6102 440250.0n 0.6001 440499.9n 0.6001 440500.0n 0.4287 440749.9n 0.4287 440750.0n 0.3966 440999.9n 0.3966 441000.0n 0.5373 441249.9n 0.5373 441250.0n 0.1178 441499.9n 0.1178 441500.0n 0.6594 441749.9n 0.6594 441750.0n 0.6041 441999.9n 0.6041 442000.0n 0.3113 442249.9n 0.3113 442250.0n 0.6434 442499.9n 0.6434 442500.0n 0.3834 442749.9n 0.3834 442750.0n 0.4621 442999.9n 0.4621 443000.0n 0.5490 443249.9n 0.5490 443250.0n 0.6490 443499.9n 0.6490 443500.0n 0.4974 443749.9n 0.4974 443750.0n 0.8837 443999.9n 0.8837 444000.0n 0.5851 444249.9n 0.5851 444250.0n 0.5464 444499.9n 0.5464 444500.0n 0.3739 444749.9n 0.3739 444750.0n 0.3461 444999.9n 0.3461 445000.0n 0.1745 445249.9n 0.1745 445250.0n 0.2205 445499.9n 0.2205 445500.0n 0.1548 445749.9n 0.1548 445750.0n 0.3521 445999.9n 0.3521 446000.0n 0.4447 446249.9n 0.4447 446250.0n 0.8701 446499.9n 0.8701 446500.0n 0.8124 446749.9n 0.8124 446750.0n 0.5344 446999.9n 0.5344 447000.0n 0.1795 447249.9n 0.1795 447250.0n 0.3383 447499.9n 0.3383 447500.0n 0.0625 447749.9n 0.0625 447750.0n 0.5952 447999.9n 0.5952 448000.0n 0.6754 448249.9n 0.6754 448250.0n 0.5672 448499.9n 0.5672 448500.0n 0.5682 448749.9n 0.5682 448750.0n 0.3560 448999.9n 0.3560 449000.0n 0.5108 449249.9n 0.5108 449250.0n 0.4166 449499.9n 0.4166 449500.0n 0.7259 449749.9n 0.7259 449750.0n 0.8897 449999.9n 0.8897 450000.0n 0.7683 450249.9n 0.7683 450250.0n 0.2826 450499.9n 0.2826 450500.0n 0.7503 450749.9n 0.7503 450750.0n 0.5496 450999.9n 0.5496 451000.0n 0.5926 451249.9n 0.5926 451250.0n 0.0822 451499.9n 0.0822 451500.0n 0.4909 451749.9n 0.4909 451750.0n 0.1510 451999.9n 0.1510 452000.0n 0.5025 452249.9n 0.5025 452250.0n 0.4007 452499.9n 0.4007 452500.0n 0.7427 452749.9n 0.7427 452750.0n 0.4708 452999.9n 0.4708 453000.0n 0.6064 453249.9n 0.6064 453250.0n 0.4868 453499.9n 0.4868 453500.0n 0.8672 453749.9n 0.8672 453750.0n 0.9111 453999.9n 0.9111 454000.0n 0.1655 454249.9n 0.1655 454250.0n 0.3815 454499.9n 0.3815 454500.0n 0.6848 454749.9n 0.6848 454750.0n 0.3297 454999.9n 0.3297 455000.0n 0.5605 455249.9n 0.5605 455250.0n 0.4192 455499.9n 0.4192 455500.0n 0.3928 455749.9n 0.3928 455750.0n 0.6123 455999.9n 0.6123 456000.0n 0.6237 456249.9n 0.6237 456250.0n 0.2074 456499.9n 0.2074 456500.0n 0.5478 456749.9n 0.5478 456750.0n 0.4129 456999.9n 0.4129 457000.0n 0.6830 457249.9n 0.6830 457250.0n 0.1937 457499.9n 0.1937 457500.0n 0.5244 457749.9n 0.5244 457750.0n 0.4512 457999.9n 0.4512 458000.0n 0.0933 458249.9n 0.0933 458250.0n 0.6260 458499.9n 0.6260 458500.0n 0.4417 458749.9n 0.4417 458750.0n 0.4687 458999.9n 0.4687 459000.0n 0.2400 459249.9n 0.2400 459250.0n 0.1891 459499.9n 0.1891 459500.0n 0.4894 459749.9n 0.4894 459750.0n 0.3980 459999.9n 0.3980 460000.0n 0.6248 460249.9n 0.6248 460250.0n 0.1171 460499.9n 0.1171 460500.0n 0.2090 460749.9n 0.2090 460750.0n 0.4003 460999.9n 0.4003 461000.0n 0.7930 461249.9n 0.7930 461250.0n 0.8645 461499.9n 0.8645 461500.0n 0.5203 461749.9n 0.5203 461750.0n 0.8861 461999.9n 0.8861 462000.0n 0.4202 462249.9n 0.4202 462250.0n 0.5898 462499.9n 0.5898 462500.0n 0.3159 462749.9n 0.3159 462750.0n 0.8697 462999.9n 0.8697 463000.0n 0.5664 463249.9n 0.5664 463250.0n 0.3695 463499.9n 0.3695 463500.0n 0.4873 463749.9n 0.4873 463750.0n 0.5406 463999.9n 0.5406 464000.0n 0.5882 464249.9n 0.5882 464250.0n 0.1745 464499.9n 0.1745 464500.0n 0.6262 464749.9n 0.6262 464750.0n 0.5196 464999.9n 0.5196 465000.0n 0.4668 465249.9n 0.4668 465250.0n 0.4960 465499.9n 0.4960 465500.0n 0.3800 465749.9n 0.3800 465750.0n 0.3455 465999.9n 0.3455 466000.0n 0.9257 466249.9n 0.9257 466250.0n 0.6576 466499.9n 0.6576 466500.0n 0.3747 466749.9n 0.3747 466750.0n 0.7746 466999.9n 0.7746 467000.0n 0.3713 467249.9n 0.3713 467250.0n 0.3294 467499.9n 0.3294 467500.0n 0.4735 467749.9n 0.4735 467750.0n 0.4244 467999.9n 0.4244 468000.0n 0.5882 468249.9n 0.5882 468250.0n 0.1955 468499.9n 0.1955 468500.0n 0.3663 468749.9n 0.3663 468750.0n 0.7755 468999.9n 0.7755 469000.0n 0.6479 469249.9n 0.6479 469250.0n 0.4875 469499.9n 0.4875 469500.0n 0.2020 469749.9n 0.2020 469750.0n 0.9150 469999.9n 0.9150 470000.0n 0.5539 470249.9n 0.5539 470250.0n 0.5446 470499.9n 0.5446 470500.0n 0.4626 470749.9n 0.4626 470750.0n 0.5260 470999.9n 0.5260 471000.0n 0.6738 471249.9n 0.6738 471250.0n 0.5565 471499.9n 0.5565 471500.0n 0.5394 471749.9n 0.5394 471750.0n 0.4379 471999.9n 0.4379 472000.0n 0.6543 472249.9n 0.6543 472250.0n 0.3827 472499.9n 0.3827 472500.0n 0.1945 472749.9n 0.1945 472750.0n 0.4131 472999.9n 0.4131 473000.0n 0.7737 473249.9n 0.7737 473250.0n 0.4327 473499.9n 0.4327 473500.0n 0.5388 473749.9n 0.5388 473750.0n 0.8164 473999.9n 0.8164 474000.0n 0.3755 474249.9n 0.3755 474250.0n 0.6427 474499.9n 0.6427 474500.0n 0.2278 474749.9n 0.2278 474750.0n 0.5159 474999.9n 0.5159 475000.0n 0.4750 475249.9n 0.4750 475250.0n 0.4420 475499.9n 0.4420 475500.0n 0.5618 475749.9n 0.5618 475750.0n 0.4188 475999.9n 0.4188 476000.0n 0.2514 476249.9n 0.2514 476250.0n 0.4818 476499.9n 0.4818 476500.0n 0.4185 476749.9n 0.4185 476750.0n 0.2248 476999.9n 0.2248 477000.0n 0.8860 477249.9n 0.8860 477250.0n 0.5571 477499.9n 0.5571 477500.0n 0.1985 477749.9n 0.1985 477750.0n 0.3903 477999.9n 0.3903 478000.0n 0.2457 478249.9n 0.2457 478250.0n 0.5817 478499.9n 0.5817 478500.0n 0.5994 478749.9n 0.5994 478750.0n 0.5087 478999.9n 0.5087 479000.0n 0.4843 479249.9n 0.4843 479250.0n 0.4745 479499.9n 0.4745 479500.0n 0.5087 479749.9n 0.5087 479750.0n 0.7977)
Vx1n a_xn1 0 PWL(0.0n 0.4510 249.9n 0.4510 250.0n 0.6887 499.9n 0.6887 500.0n 0.4149 749.9n 0.4149 750.0n 0.5041 999.9n 0.5041 1000.0n 0.6893 1249.9n 0.6893 1250.0n 0.5050 1499.9n 0.5050 1500.0n 0.4627 1749.9n 0.4627 1750.0n 0.1163 1999.9n 0.1163 2000.0n 0.8338 2249.9n 0.8338 2250.0n 0.5553 2499.9n 0.5553 2500.0n 0.3332 2749.9n 0.3332 2750.0n 0.8822 2999.9n 0.8822 3000.0n 0.5166 3249.9n 0.5166 3250.0n 0.2208 3499.9n 0.2208 3500.0n 0.5026 3749.9n 0.5026 3750.0n 0.6034 3999.9n 0.6034 4000.0n 0.6539 4249.9n 0.6539 4250.0n 0.4172 4499.9n 0.4172 4500.0n 0.4536 4749.9n 0.4536 4750.0n 0.1103 4999.9n 0.1103 5000.0n 0.7795 5249.9n 0.7795 5250.0n 0.6617 5499.9n 0.6617 5500.0n 0.2392 5749.9n 0.2392 5750.0n 0.1794 5999.9n 0.1794 6000.0n 0.3898 6249.9n 0.3898 6250.0n 0.4190 6499.9n 0.4190 6500.0n 0.9375 6749.9n 0.9375 6750.0n 0.8452 6999.9n 0.8452 7000.0n 0.5411 7249.9n 0.5411 7250.0n 0.5713 7499.9n 0.5713 7500.0n 0.3999 7749.9n 0.3999 7750.0n 0.6479 7999.9n 0.6479 8000.0n 0.5638 8249.9n 0.5638 8250.0n 0.1299 8499.9n 0.1299 8500.0n 0.5143 8749.9n 0.5143 8750.0n 0.8205 8999.9n 0.8205 9000.0n 0.4328 9249.9n 0.4328 9250.0n 0.3510 9499.9n 0.3510 9500.0n 0.5506 9749.9n 0.5506 9750.0n 0.2047 9999.9n 0.2047 10000.0n 0.3566 10249.9n 0.3566 10250.0n 0.8255 10499.9n 0.8255 10500.0n 0.6166 10749.9n 0.6166 10750.0n 0.1876 10999.9n 0.1876 11000.0n 0.4048 11249.9n 0.4048 11250.0n 0.6440 11499.9n 0.6440 11500.0n 0.5087 11749.9n 0.5087 11750.0n 0.5834 11999.9n 0.5834 12000.0n 0.4892 12249.9n 0.4892 12250.0n 0.5379 12499.9n 0.5379 12500.0n 0.6261 12749.9n 0.6261 12750.0n 0.3406 12999.9n 0.3406 13000.0n 0.3959 13249.9n 0.3959 13250.0n 0.5372 13499.9n 0.5372 13500.0n 0.2741 13749.9n 0.2741 13750.0n 0.4656 13999.9n 0.4656 14000.0n 0.3246 14249.9n 0.3246 14250.0n 0.4318 14499.9n 0.4318 14500.0n 0.5851 14749.9n 0.5851 14750.0n 0.8267 14999.9n 0.8267 15000.0n 0.5638 15249.9n 0.5638 15250.0n 0.1299 15499.9n 0.1299 15500.0n 0.6893 15749.9n 0.6893 15750.0n 0.4149 15999.9n 0.4149 16000.0n 0.4172 16249.9n 0.4172 16250.0n 0.8255 16499.9n 0.8255 16500.0n 0.3999 16749.9n 0.3999 16750.0n 0.1794 16999.9n 0.1794 17000.0n 0.5026 17249.9n 0.5026 17250.0n 0.3510 17499.9n 0.3510 17500.0n 0.5834 17749.9n 0.5834 17750.0n 0.7795 17999.9n 0.7795 18000.0n 0.5411 18249.9n 0.5411 18250.0n 0.6166 18499.9n 0.6166 18500.0n 0.5166 18749.9n 0.5166 18750.0n 0.3332 18999.9n 0.3332 19000.0n 0.4328 19249.9n 0.4328 19250.0n 0.4656 19499.9n 0.4656 19500.0n 0.4510 19749.9n 0.4510 19750.0n 0.8822 19999.9n 0.8822 20000.0n 0.4892 20249.9n 0.4892 20250.0n 0.3959 20499.9n 0.3959 20500.0n 0.8205 20749.9n 0.8205 20750.0n 0.4318 20999.9n 0.4318 21000.0n 0.4048 21249.9n 0.4048 21250.0n 0.5851 21499.9n 0.5851 21500.0n 0.5041 21749.9n 0.5041 21750.0n 0.8452 21999.9n 0.8452 22000.0n 0.3898 22249.9n 0.3898 22250.0n 0.4536 22499.9n 0.4536 22500.0n 0.6539 22749.9n 0.6539 22750.0n 0.3246 22999.9n 0.3246 23000.0n 0.5372 23249.9n 0.5372 23250.0n 0.9375 23499.9n 0.9375 23500.0n 0.5553 23749.9n 0.5553 23750.0n 0.5087 23999.9n 0.5087 24000.0n 0.6261 24249.9n 0.6261 24250.0n 0.2047 24499.9n 0.2047 24500.0n 0.1103 24749.9n 0.1103 24750.0n 0.8338 24999.9n 0.8338 25000.0n 0.1163 25249.9n 0.1163 25250.0n 0.6034 25499.9n 0.6034 25500.0n 0.5506 25749.9n 0.5506 25750.0n 0.2741 25999.9n 0.2741 26000.0n 0.1876 26249.9n 0.1876 26250.0n 0.4190 26499.9n 0.4190 26500.0n 0.6617 26749.9n 0.6617 26750.0n 0.3566 26999.9n 0.3566 27000.0n 0.5050 27249.9n 0.5050 27250.0n 0.3406 27499.9n 0.3406 27500.0n 0.5713 27749.9n 0.5713 27750.0n 0.5379 27999.9n 0.5379 28000.0n 0.4627 28249.9n 0.4627 28250.0n 0.6440 28499.9n 0.6440 28500.0n 0.2208 28749.9n 0.2208 28750.0n 0.6887 28999.9n 0.6887 29000.0n 0.2392 29249.9n 0.2392 29250.0n 0.8267 29499.9n 0.8267 29500.0n 0.6479 29749.9n 0.6479 29750.0n 0.5143 29999.9n 0.5143 30000.0n 0.5143 30249.9n 0.5143 30250.0n 0.5553 30499.9n 0.5553 30500.0n 0.4190 30749.9n 0.4190 30750.0n 0.6166 30999.9n 0.6166 31000.0n 0.1299 31249.9n 0.1299 31250.0n 0.5087 31499.9n 0.5087 31500.0n 0.2392 31749.9n 0.2392 31750.0n 0.7795 31999.9n 0.7795 32000.0n 0.8822 32249.9n 0.8822 32250.0n 0.3332 32499.9n 0.3332 32500.0n 0.6893 32749.9n 0.6893 32750.0n 0.4536 32999.9n 0.4536 33000.0n 0.4328 33249.9n 0.4328 33250.0n 0.3510 33499.9n 0.3510 33500.0n 0.6440 33749.9n 0.6440 33750.0n 0.6887 33999.9n 0.6887 34000.0n 0.3246 34249.9n 0.3246 34250.0n 0.2047 34499.9n 0.2047 34500.0n 0.5834 34749.9n 0.5834 34750.0n 0.6479 34999.9n 0.6479 35000.0n 0.5851 35249.9n 0.5851 35250.0n 0.5411 35499.9n 0.5411 35500.0n 0.5379 35749.9n 0.5379 35750.0n 0.3566 35999.9n 0.3566 36000.0n 0.5713 36249.9n 0.5713 36250.0n 0.1103 36499.9n 0.1103 36500.0n 0.1163 36749.9n 0.1163 36750.0n 0.4656 36999.9n 0.4656 37000.0n 0.5166 37249.9n 0.5166 37250.0n 0.5372 37499.9n 0.5372 37500.0n 0.5638 37749.9n 0.5638 37750.0n 0.8338 37999.9n 0.8338 38000.0n 0.6261 38249.9n 0.6261 38250.0n 0.8267 38499.9n 0.8267 38500.0n 0.4318 38749.9n 0.4318 38750.0n 0.6539 38999.9n 0.6539 39000.0n 0.8452 39249.9n 0.8452 39250.0n 0.1794 39499.9n 0.1794 39500.0n 0.5026 39749.9n 0.5026 39750.0n 0.8255 39999.9n 0.8255 40000.0n 0.8205 40249.9n 0.8205 40250.0n 0.2741 40499.9n 0.2741 40500.0n 0.3999 40749.9n 0.3999 40750.0n 0.2208 40999.9n 0.2208 41000.0n 0.4627 41249.9n 0.4627 41250.0n 0.6617 41499.9n 0.6617 41500.0n 0.9375 41749.9n 0.9375 41750.0n 0.5041 41999.9n 0.5041 42000.0n 0.4510 42249.9n 0.4510 42250.0n 0.1876 42499.9n 0.1876 42500.0n 0.6034 42749.9n 0.6034 42750.0n 0.3406 42999.9n 0.3406 43000.0n 0.5506 43249.9n 0.5506 43250.0n 0.5050 43499.9n 0.5050 43500.0n 0.3959 43749.9n 0.3959 43750.0n 0.4149 43999.9n 0.4149 44000.0n 0.4172 44249.9n 0.4172 44250.0n 0.4048 44499.9n 0.4048 44500.0n 0.4892 44749.9n 0.4892 44750.0n 0.3898 44999.9n 0.3898 45000.0n 0.8205 45249.9n 0.8205 45250.0n 0.1103 45499.9n 0.1103 45500.0n 0.5834 45749.9n 0.5834 45750.0n 0.5553 45999.9n 0.5553 46000.0n 0.1299 46249.9n 0.1299 46250.0n 0.5026 46499.9n 0.5026 46500.0n 0.4510 46749.9n 0.4510 46750.0n 0.4318 46999.9n 0.4318 47000.0n 0.5713 47249.9n 0.5713 47250.0n 0.6034 47499.9n 0.6034 47500.0n 0.3332 47749.9n 0.3332 47750.0n 0.2208 47999.9n 0.2208 48000.0n 0.6261 48249.9n 0.6261 48250.0n 0.7795 48499.9n 0.7795 48500.0n 0.1794 48749.9n 0.1794 48750.0n 0.5041 48999.9n 0.5041 49000.0n 0.5087 49249.9n 0.5087 49250.0n 0.4627 49499.9n 0.4627 49500.0n 0.6479 49749.9n 0.6479 49750.0n 0.2741 49999.9n 0.2741 50000.0n 0.5143 50249.9n 0.5143 50250.0n 0.6539 50499.9n 0.6539 50500.0n 0.6440 50749.9n 0.6440 50750.0n 0.5166 50999.9n 0.5166 51000.0n 0.5411 51249.9n 0.5411 51250.0n 0.1163 51499.9n 0.1163 51500.0n 0.4172 51749.9n 0.4172 51750.0n 0.2392 51999.9n 0.2392 52000.0n 0.4149 52249.9n 0.4149 52250.0n 0.4892 52499.9n 0.4892 52500.0n 0.3898 52749.9n 0.3898 52750.0n 0.3246 52999.9n 0.3246 53000.0n 0.5050 53249.9n 0.5050 53250.0n 0.5851 53499.9n 0.5851 53500.0n 0.8338 53749.9n 0.8338 53750.0n 0.5638 53999.9n 0.5638 54000.0n 0.4536 54249.9n 0.4536 54250.0n 0.1876 54499.9n 0.1876 54500.0n 0.3406 54749.9n 0.3406 54750.0n 0.6166 54999.9n 0.6166 55000.0n 0.4656 55249.9n 0.4656 55250.0n 0.5379 55499.9n 0.5379 55500.0n 0.8822 55749.9n 0.8822 55750.0n 0.9375 55999.9n 0.9375 56000.0n 0.4328 56249.9n 0.4328 56250.0n 0.2047 56499.9n 0.2047 56500.0n 0.8267 56749.9n 0.8267 56750.0n 0.5506 56999.9n 0.5506 57000.0n 0.6887 57249.9n 0.6887 57250.0n 0.6893 57499.9n 0.6893 57500.0n 0.3566 57749.9n 0.3566 57750.0n 0.8452 57999.9n 0.8452 58000.0n 0.3510 58249.9n 0.3510 58250.0n 0.3999 58499.9n 0.3999 58500.0n 0.4190 58749.9n 0.4190 58750.0n 0.5372 58999.9n 0.5372 59000.0n 0.8255 59249.9n 0.8255 59250.0n 0.4048 59499.9n 0.4048 59500.0n 0.3959 59749.9n 0.3959 59750.0n 0.6617 59999.9n 0.6617 60000.0n 0.2208 60249.9n 0.2208 60250.0n 0.5851 60499.9n 0.5851 60500.0n 0.5372 60749.9n 0.5372 60750.0n 0.4190 60999.9n 0.4190 61000.0n 0.3332 61249.9n 0.3332 61250.0n 0.5087 61499.9n 0.5087 61500.0n 0.2047 61749.9n 0.2047 61750.0n 0.6166 61999.9n 0.6166 62000.0n 0.6539 62249.9n 0.6539 62250.0n 0.5713 62499.9n 0.5713 62500.0n 0.5050 62749.9n 0.5050 62750.0n 0.1299 62999.9n 0.1299 63000.0n 0.5411 63249.9n 0.5411 63250.0n 0.4536 63499.9n 0.4536 63500.0n 0.5379 63749.9n 0.5379 63750.0n 0.5041 63999.9n 0.5041 64000.0n 0.3999 64249.9n 0.3999 64250.0n 0.3406 64499.9n 0.3406 64500.0n 0.2741 64749.9n 0.2741 64750.0n 0.3898 64999.9n 0.3898 65000.0n 0.3246 65249.9n 0.3246 65250.0n 0.3510 65499.9n 0.3510 65500.0n 0.3566 65749.9n 0.3566 65750.0n 0.4172 65999.9n 0.4172 66000.0n 0.8338 66249.9n 0.8338 66250.0n 0.6887 66499.9n 0.6887 66500.0n 0.4892 66749.9n 0.4892 66750.0n 0.4627 66999.9n 0.4627 67000.0n 0.8452 67249.9n 0.8452 67250.0n 0.8255 67499.9n 0.8255 67500.0n 0.2392 67749.9n 0.2392 67750.0n 0.1794 67999.9n 0.1794 68000.0n 0.6261 68249.9n 0.6261 68250.0n 0.5166 68499.9n 0.5166 68500.0n 0.7795 68749.9n 0.7795 68750.0n 0.8267 68999.9n 0.8267 69000.0n 0.6479 69249.9n 0.6479 69250.0n 0.1876 69499.9n 0.1876 69500.0n 0.6034 69749.9n 0.6034 69750.0n 0.6893 69999.9n 0.6893 70000.0n 0.4149 70249.9n 0.4149 70250.0n 0.5026 70499.9n 0.5026 70500.0n 0.1163 70749.9n 0.1163 70750.0n 0.4048 70999.9n 0.4048 71000.0n 0.5506 71249.9n 0.5506 71250.0n 0.1103 71499.9n 0.1103 71500.0n 0.4328 71749.9n 0.4328 71750.0n 0.4510 71999.9n 0.4510 72000.0n 0.6617 72249.9n 0.6617 72250.0n 0.8822 72499.9n 0.8822 72500.0n 0.5638 72749.9n 0.5638 72750.0n 0.3959 72999.9n 0.3959 73000.0n 0.4656 73249.9n 0.4656 73250.0n 0.5834 73499.9n 0.5834 73500.0n 0.8205 73749.9n 0.8205 73750.0n 0.4318 73999.9n 0.4318 74000.0n 0.5553 74249.9n 0.5553 74250.0n 0.6440 74499.9n 0.6440 74500.0n 0.9375 74749.9n 0.9375 74750.0n 0.5143 74999.9n 0.5143 75000.0n 0.5166 75249.9n 0.5166 75250.0n 0.4892 75499.9n 0.4892 75500.0n 0.5411 75749.9n 0.5411 75750.0n 0.1103 75999.9n 0.1103 76000.0n 0.4172 76249.9n 0.4172 76250.0n 0.5851 76499.9n 0.5851 76500.0n 0.3332 76749.9n 0.3332 76750.0n 0.5026 76999.9n 0.5026 77000.0n 0.3406 77249.9n 0.3406 77250.0n 0.4510 77499.9n 0.4510 77500.0n 0.5713 77749.9n 0.5713 77750.0n 0.5638 77999.9n 0.5638 78000.0n 0.3566 78249.9n 0.3566 78250.0n 0.3959 78499.9n 0.3959 78500.0n 0.6440 78749.9n 0.6440 78750.0n 0.8338 78999.9n 0.8338 79000.0n 0.2047 79249.9n 0.2047 79250.0n 0.6166 79499.9n 0.6166 79500.0n 0.5379 79749.9n 0.5379 79750.0n 0.4656 79999.9n 0.4656 80000.0n 0.4318 80249.9n 0.4318 80250.0n 0.8452 80499.9n 0.8452 80500.0n 0.7795 80749.9n 0.7795 80750.0n 0.5041 80999.9n 0.5041 81000.0n 0.2741 81249.9n 0.2741 81250.0n 0.5087 81499.9n 0.5087 81500.0n 0.3246 81749.9n 0.3246 81750.0n 0.4190 81999.9n 0.4190 82000.0n 0.3510 82249.9n 0.3510 82250.0n 0.2208 82499.9n 0.2208 82500.0n 0.5050 82749.9n 0.5050 82750.0n 0.8205 82999.9n 0.8205 83000.0n 0.4536 83249.9n 0.4536 83250.0n 0.3999 83499.9n 0.3999 83500.0n 0.1794 83749.9n 0.1794 83750.0n 0.5834 83999.9n 0.5834 84000.0n 0.1163 84249.9n 0.1163 84250.0n 0.5506 84499.9n 0.5506 84500.0n 0.5553 84749.9n 0.5553 84750.0n 0.1299 84999.9n 0.1299 85000.0n 0.8822 85249.9n 0.8822 85250.0n 0.6617 85499.9n 0.6617 85500.0n 0.9375 85749.9n 0.9375 85750.0n 0.6893 85999.9n 0.6893 86000.0n 0.4627 86249.9n 0.4627 86250.0n 0.4048 86499.9n 0.4048 86500.0n 0.3898 86749.9n 0.3898 86750.0n 0.6479 86999.9n 0.6479 87000.0n 0.4328 87249.9n 0.4328 87250.0n 0.6887 87499.9n 0.6887 87500.0n 0.5372 87749.9n 0.5372 87750.0n 0.8267 87999.9n 0.8267 88000.0n 0.6539 88249.9n 0.6539 88250.0n 0.2392 88499.9n 0.2392 88500.0n 0.1876 88749.9n 0.1876 88750.0n 0.4149 88999.9n 0.4149 89000.0n 0.5143 89249.9n 0.5143 89250.0n 0.6034 89499.9n 0.6034 89500.0n 0.6261 89749.9n 0.6261 89750.0n 0.8255 89999.9n 0.8255 90000.0n 0.7795 90249.9n 0.7795 90250.0n 0.5026 90499.9n 0.5026 90500.0n 0.2741 90749.9n 0.2741 90750.0n 0.6479 90999.9n 0.6479 91000.0n 0.5553 91249.9n 0.5553 91250.0n 0.8452 91499.9n 0.8452 91500.0n 0.8205 91749.9n 0.8205 91750.0n 0.2208 91999.9n 0.2208 92000.0n 0.6887 92249.9n 0.6887 92250.0n 0.5851 92499.9n 0.5851 92500.0n 0.4172 92749.9n 0.4172 92750.0n 0.5041 92999.9n 0.5041 93000.0n 0.3566 93249.9n 0.3566 93250.0n 0.6539 93499.9n 0.6539 93500.0n 0.5050 93749.9n 0.5050 93750.0n 0.3959 93999.9n 0.3959 94000.0n 0.1163 94249.9n 0.1163 94250.0n 0.8255 94499.9n 0.8255 94500.0n 0.1103 94749.9n 0.1103 94750.0n 0.2392 94999.9n 0.2392 95000.0n 0.3999 95249.9n 0.3999 95250.0n 0.1794 95499.9n 0.1794 95500.0n 0.9375 95749.9n 0.9375 95750.0n 0.4536 95999.9n 0.4536 96000.0n 0.1299 96249.9n 0.1299 96250.0n 0.8822 96499.9n 0.8822 96500.0n 0.4048 96749.9n 0.4048 96750.0n 0.6617 96999.9n 0.6617 97000.0n 0.4318 97249.9n 0.4318 97250.0n 0.3246 97499.9n 0.3246 97500.0n 0.5143 97749.9n 0.5143 97750.0n 0.4892 97999.9n 0.4892 98000.0n 0.3406 98249.9n 0.3406 98250.0n 0.6440 98499.9n 0.6440 98500.0n 0.5087 98749.9n 0.5087 98750.0n 0.8338 98999.9n 0.8338 99000.0n 0.4328 99249.9n 0.4328 99250.0n 0.6893 99499.9n 0.6893 99500.0n 0.5372 99749.9n 0.5372 99750.0n 0.5166 99999.9n 0.5166 100000.0n 0.4627 100249.9n 0.4627 100250.0n 0.5638 100499.9n 0.5638 100500.0n 0.6166 100749.9n 0.6166 100750.0n 0.5411 100999.9n 0.5411 101000.0n 0.5506 101249.9n 0.5506 101250.0n 0.5834 101499.9n 0.5834 101500.0n 0.3332 101749.9n 0.3332 101750.0n 0.4510 101999.9n 0.4510 102000.0n 0.6034 102249.9n 0.6034 102250.0n 0.1876 102499.9n 0.1876 102500.0n 0.4190 102749.9n 0.4190 102750.0n 0.3898 102999.9n 0.3898 103000.0n 0.4149 103249.9n 0.4149 103250.0n 0.2047 103499.9n 0.2047 103500.0n 0.6261 103749.9n 0.6261 103750.0n 0.5713 103999.9n 0.5713 104000.0n 0.3510 104249.9n 0.3510 104250.0n 0.8267 104499.9n 0.8267 104500.0n 0.5379 104749.9n 0.5379 104750.0n 0.4656 104999.9n 0.4656 105000.0n 0.5050 105249.9n 0.5050 105250.0n 0.4172 105499.9n 0.4172 105500.0n 0.4536 105749.9n 0.4536 105750.0n 0.4510 105999.9n 0.4510 106000.0n 0.5553 106249.9n 0.5553 106250.0n 0.3332 106499.9n 0.3332 106500.0n 0.4318 106749.9n 0.4318 106750.0n 0.2392 106999.9n 0.2392 107000.0n 0.4627 107249.9n 0.4627 107250.0n 0.5041 107499.9n 0.5041 107500.0n 0.3566 107749.9n 0.3566 107750.0n 0.8205 107999.9n 0.8205 108000.0n 0.3999 108249.9n 0.3999 108250.0n 0.1794 108499.9n 0.1794 108500.0n 0.2741 108749.9n 0.2741 108750.0n 0.6617 108999.9n 0.6617 109000.0n 0.8255 109249.9n 0.8255 109250.0n 0.6166 109499.9n 0.6166 109500.0n 0.5372 109749.9n 0.5372 109750.0n 0.5087 109999.9n 0.5087 110000.0n 0.3406 110249.9n 0.3406 110250.0n 0.5834 110499.9n 0.5834 110500.0n 0.5026 110749.9n 0.5026 110750.0n 0.5166 110999.9n 0.5166 111000.0n 0.5713 111249.9n 0.5713 111250.0n 0.6887 111499.9n 0.6887 111500.0n 0.4190 111749.9n 0.4190 111750.0n 0.4328 111999.9n 0.4328 112000.0n 0.8267 112249.9n 0.8267 112250.0n 0.3898 112499.9n 0.3898 112500.0n 0.6440 112749.9n 0.6440 112750.0n 0.3510 112999.9n 0.3510 113000.0n 0.5638 113249.9n 0.5638 113250.0n 0.3959 113499.9n 0.3959 113500.0n 0.9375 113749.9n 0.9375 113750.0n 0.1299 113999.9n 0.1299 114000.0n 0.4892 114249.9n 0.4892 114250.0n 0.6034 114499.9n 0.6034 114500.0n 0.2208 114749.9n 0.2208 114750.0n 0.5506 114999.9n 0.5506 115000.0n 0.1163 115249.9n 0.1163 115250.0n 0.4048 115499.9n 0.4048 115500.0n 0.5411 115749.9n 0.5411 115750.0n 0.4656 115999.9n 0.4656 116000.0n 0.1876 116249.9n 0.1876 116250.0n 0.8338 116499.9n 0.8338 116500.0n 0.6539 116749.9n 0.6539 116750.0n 0.8822 116999.9n 0.8822 117000.0n 0.2047 117249.9n 0.2047 117250.0n 0.6261 117499.9n 0.6261 117500.0n 0.1103 117749.9n 0.1103 117750.0n 0.5851 117999.9n 0.5851 118000.0n 0.8452 118249.9n 0.8452 118250.0n 0.5143 118499.9n 0.5143 118500.0n 0.6479 118749.9n 0.6479 118750.0n 0.4149 118999.9n 0.4149 119000.0n 0.6893 119249.9n 0.6893 119250.0n 0.5379 119499.9n 0.5379 119500.0n 0.7795 119749.9n 0.7795 119750.0n 0.3246 119999.9n 0.3246 120000.0n 0.8205 120249.9n 0.8205 120250.0n 0.5553 120499.9n 0.5553 120500.0n 0.2392 120749.9n 0.2392 120750.0n 0.5087 120999.9n 0.5087 121000.0n 0.6617 121249.9n 0.6617 121250.0n 0.1163 121499.9n 0.1163 121500.0n 0.1876 121749.9n 0.1876 121750.0n 0.8267 121999.9n 0.8267 122000.0n 0.5143 122249.9n 0.5143 122250.0n 0.5713 122499.9n 0.5713 122500.0n 0.3406 122749.9n 0.3406 122750.0n 0.5166 122999.9n 0.5166 123000.0n 0.3959 123249.9n 0.3959 123250.0n 0.6034 123499.9n 0.6034 123500.0n 0.3566 123749.9n 0.3566 123750.0n 0.8338 123999.9n 0.8338 124000.0n 0.5026 124249.9n 0.5026 124250.0n 0.1103 124499.9n 0.1103 124500.0n 0.4510 124749.9n 0.4510 124750.0n 0.6261 124999.9n 0.6261 125000.0n 0.5506 125249.9n 0.5506 125250.0n 0.6479 125499.9n 0.6479 125500.0n 0.5379 125749.9n 0.5379 125750.0n 0.6893 125999.9n 0.6893 126000.0n 0.4536 126249.9n 0.4536 126250.0n 0.3332 126499.9n 0.3332 126500.0n 0.6166 126749.9n 0.6166 126750.0n 0.2741 126999.9n 0.2741 127000.0n 0.4318 127249.9n 0.4318 127250.0n 0.4048 127499.9n 0.4048 127500.0n 0.5851 127749.9n 0.5851 127750.0n 0.1299 127999.9n 0.1299 128000.0n 0.7795 128249.9n 0.7795 128250.0n 0.4328 128499.9n 0.4328 128500.0n 0.4149 128749.9n 0.4149 128750.0n 0.8452 128999.9n 0.8452 129000.0n 0.8822 129249.9n 0.8822 129250.0n 0.2208 129499.9n 0.2208 129500.0n 0.3246 129749.9n 0.3246 129750.0n 0.5411 129999.9n 0.5411 130000.0n 0.5638 130249.9n 0.5638 130250.0n 0.9375 130499.9n 0.9375 130500.0n 0.5041 130749.9n 0.5041 130750.0n 0.5834 130999.9n 0.5834 131000.0n 0.4172 131249.9n 0.4172 131250.0n 0.5050 131499.9n 0.5050 131500.0n 0.3898 131749.9n 0.3898 131750.0n 0.2047 131999.9n 0.2047 132000.0n 0.4627 132249.9n 0.4627 132250.0n 0.3510 132499.9n 0.3510 132500.0n 0.6440 132749.9n 0.6440 132750.0n 0.3999 132999.9n 0.3999 133000.0n 0.4892 133249.9n 0.4892 133250.0n 0.1794 133499.9n 0.1794 133500.0n 0.5372 133749.9n 0.5372 133750.0n 0.4656 133999.9n 0.4656 134000.0n 0.6887 134249.9n 0.6887 134250.0n 0.8255 134499.9n 0.8255 134500.0n 0.4190 134749.9n 0.4190 134750.0n 0.6539 134999.9n 0.6539 135000.0n 0.5411 135249.9n 0.5411 135250.0n 0.8338 135499.9n 0.8338 135500.0n 0.5553 135749.9n 0.5553 135750.0n 0.5026 135999.9n 0.5026 136000.0n 0.4627 136249.9n 0.4627 136250.0n 0.4510 136499.9n 0.4510 136500.0n 0.6034 136749.9n 0.6034 136750.0n 0.5143 136999.9n 0.5143 137000.0n 0.6166 137249.9n 0.6166 137250.0n 0.1103 137499.9n 0.1103 137500.0n 0.6539 137749.9n 0.6539 137750.0n 0.4536 137999.9n 0.4536 138000.0n 0.6887 138249.9n 0.6887 138250.0n 0.3332 138499.9n 0.3332 138500.0n 0.4048 138749.9n 0.4048 138750.0n 0.2047 138999.9n 0.2047 139000.0n 0.5041 139249.9n 0.5041 139250.0n 0.5372 139499.9n 0.5372 139500.0n 0.1794 139749.9n 0.1794 139750.0n 0.5851 139999.9n 0.5851 140000.0n 0.3959 140249.9n 0.3959 140250.0n 0.5638 140499.9n 0.5638 140500.0n 0.3898 140749.9n 0.3898 140750.0n 0.1163 140999.9n 0.1163 141000.0n 0.8255 141249.9n 0.8255 141250.0n 0.8205 141499.9n 0.8205 141500.0n 0.5087 141749.9n 0.5087 141750.0n 0.6261 141999.9n 0.6261 142000.0n 0.5379 142249.9n 0.5379 142250.0n 0.4328 142499.9n 0.4328 142500.0n 0.4149 142749.9n 0.4149 142750.0n 0.3999 142999.9n 0.3999 143000.0n 0.2392 143249.9n 0.2392 143250.0n 0.4190 143499.9n 0.4190 143500.0n 0.2208 143749.9n 0.2208 143750.0n 0.7795 143999.9n 0.7795 144000.0n 0.5834 144249.9n 0.5834 144250.0n 0.1299 144499.9n 0.1299 144500.0n 0.5166 144749.9n 0.5166 144750.0n 0.5050 144999.9n 0.5050 145000.0n 0.6479 145249.9n 0.6479 145250.0n 0.6893 145499.9n 0.6893 145500.0n 0.4892 145749.9n 0.4892 145750.0n 0.4172 145999.9n 0.4172 146000.0n 0.2741 146249.9n 0.2741 146250.0n 0.4656 146499.9n 0.4656 146500.0n 0.8822 146749.9n 0.8822 146750.0n 0.9375 146999.9n 0.9375 147000.0n 0.3406 147249.9n 0.3406 147250.0n 0.1876 147499.9n 0.1876 147500.0n 0.3246 147749.9n 0.3246 147750.0n 0.3510 147999.9n 0.3510 148000.0n 0.8267 148249.9n 0.8267 148250.0n 0.6617 148499.9n 0.6617 148500.0n 0.6440 148749.9n 0.6440 148750.0n 0.4318 148999.9n 0.4318 149000.0n 0.5506 149249.9n 0.5506 149250.0n 0.5713 149499.9n 0.5713 149500.0n 0.8452 149749.9n 0.8452 149750.0n 0.3566 149999.9n 0.3566 150000.0n 0.6166 150249.9n 0.6166 150250.0n 0.4510 150499.9n 0.4510 150500.0n 0.8267 150749.9n 0.8267 150750.0n 0.3246 150999.9n 0.3246 151000.0n 0.6479 151249.9n 0.6479 151250.0n 0.5834 151499.9n 0.5834 151500.0n 0.8452 151749.9n 0.8452 151750.0n 0.4892 151999.9n 0.4892 152000.0n 0.4149 152249.9n 0.4149 152250.0n 0.5553 152499.9n 0.5553 152500.0n 0.6440 152749.9n 0.6440 152750.0n 0.4172 152999.9n 0.4172 153000.0n 0.6617 153249.9n 0.6617 153250.0n 0.1876 153499.9n 0.1876 153500.0n 0.3566 153749.9n 0.3566 153750.0n 0.5372 153999.9n 0.5372 154000.0n 0.2047 154249.9n 0.2047 154250.0n 0.5506 154499.9n 0.5506 154500.0n 0.3898 154749.9n 0.3898 154750.0n 0.4328 154999.9n 0.4328 155000.0n 0.3406 155249.9n 0.3406 155250.0n 0.6261 155499.9n 0.6261 155500.0n 0.7795 155749.9n 0.7795 155750.0n 0.5713 155999.9n 0.5713 156000.0n 0.6034 156249.9n 0.6034 156250.0n 0.8338 156499.9n 0.8338 156500.0n 0.3510 156749.9n 0.3510 156750.0n 0.2208 156999.9n 0.2208 157000.0n 0.4048 157249.9n 0.4048 157250.0n 0.8822 157499.9n 0.8822 157500.0n 0.4656 157749.9n 0.4656 157750.0n 0.1794 157999.9n 0.1794 158000.0n 0.8255 158249.9n 0.8255 158250.0n 0.6887 158499.9n 0.6887 158500.0n 0.8205 158749.9n 0.8205 158750.0n 0.4536 158999.9n 0.4536 159000.0n 0.5143 159249.9n 0.5143 159250.0n 0.5050 159499.9n 0.5050 159500.0n 0.5379 159749.9n 0.5379 159750.0n 0.3999 159999.9n 0.3999 160000.0n 0.2741 160249.9n 0.2741 160250.0n 0.4318 160499.9n 0.4318 160500.0n 0.6539 160749.9n 0.6539 160750.0n 0.5041 160999.9n 0.5041 161000.0n 0.5087 161249.9n 0.5087 161250.0n 0.1299 161499.9n 0.1299 161500.0n 0.9375 161749.9n 0.9375 161750.0n 0.3332 161999.9n 0.3332 162000.0n 0.1103 162249.9n 0.1103 162250.0n 0.3959 162499.9n 0.3959 162500.0n 0.1163 162749.9n 0.1163 162750.0n 0.4190 162999.9n 0.4190 163000.0n 0.2392 163249.9n 0.2392 163250.0n 0.5166 163499.9n 0.5166 163500.0n 0.6893 163749.9n 0.6893 163750.0n 0.5026 163999.9n 0.5026 164000.0n 0.5851 164249.9n 0.5851 164250.0n 0.5411 164499.9n 0.5411 164500.0n 0.4627 164749.9n 0.4627 164750.0n 0.5638 164999.9n 0.5638 165000.0n 0.3406 165249.9n 0.3406 165250.0n 0.6539 165499.9n 0.6539 165500.0n 0.6479 165749.9n 0.6479 165750.0n 0.5379 165999.9n 0.5379 166000.0n 0.5834 166249.9n 0.5834 166250.0n 0.3959 166499.9n 0.3959 166500.0n 0.2741 166749.9n 0.2741 166750.0n 0.4172 166999.9n 0.4172 167000.0n 0.5143 167249.9n 0.5143 167250.0n 0.4318 167499.9n 0.4318 167500.0n 0.9375 167749.9n 0.9375 167750.0n 0.3566 167999.9n 0.3566 168000.0n 0.5506 168249.9n 0.5506 168250.0n 0.5713 168499.9n 0.5713 168500.0n 0.8205 168749.9n 0.8205 168750.0n 0.8452 168999.9n 0.8452 169000.0n 0.5851 169249.9n 0.5851 169250.0n 0.8822 169499.9n 0.8822 169500.0n 0.1163 169749.9n 0.1163 169750.0n 0.1876 169999.9n 0.1876 170000.0n 0.4048 170249.9n 0.4048 170250.0n 0.4149 170499.9n 0.4149 170500.0n 0.5026 170749.9n 0.5026 170750.0n 0.3246 170999.9n 0.3246 171000.0n 0.6440 171249.9n 0.6440 171250.0n 0.3898 171499.9n 0.3898 171500.0n 0.8338 171749.9n 0.8338 171750.0n 0.8255 171999.9n 0.8255 172000.0n 0.4190 172249.9n 0.4190 172250.0n 0.6887 172499.9n 0.6887 172500.0n 0.3510 172749.9n 0.3510 172750.0n 0.4328 172999.9n 0.4328 173000.0n 0.4510 173249.9n 0.4510 173250.0n 0.5638 173499.9n 0.5638 173500.0n 0.4892 173749.9n 0.4892 173750.0n 0.5553 173999.9n 0.5553 174000.0n 0.7795 174249.9n 0.7795 174250.0n 0.5411 174499.9n 0.5411 174500.0n 0.2047 174749.9n 0.2047 174750.0n 0.6034 174999.9n 0.6034 175000.0n 0.4536 175249.9n 0.4536 175250.0n 0.5087 175499.9n 0.5087 175500.0n 0.5372 175749.9n 0.5372 175750.0n 0.5166 175999.9n 0.5166 176000.0n 0.1794 176249.9n 0.1794 176250.0n 0.6893 176499.9n 0.6893 176500.0n 0.8267 176749.9n 0.8267 176750.0n 0.3332 176999.9n 0.3332 177000.0n 0.3999 177249.9n 0.3999 177250.0n 0.1103 177499.9n 0.1103 177500.0n 0.6261 177749.9n 0.6261 177750.0n 0.5050 177999.9n 0.5050 178000.0n 0.2208 178249.9n 0.2208 178250.0n 0.4627 178499.9n 0.4627 178500.0n 0.6617 178749.9n 0.6617 178750.0n 0.2392 178999.9n 0.2392 179000.0n 0.5041 179249.9n 0.5041 179250.0n 0.6166 179499.9n 0.6166 179500.0n 0.4656 179749.9n 0.4656 179750.0n 0.1299 179999.9n 0.1299 180000.0n 0.5506 180249.9n 0.5506 180250.0n 0.2047 180499.9n 0.2047 180500.0n 0.6261 180749.9n 0.6261 180750.0n 0.5026 180999.9n 0.5026 181000.0n 0.3959 181249.9n 0.3959 181250.0n 0.4536 181499.9n 0.4536 181500.0n 0.3406 181749.9n 0.3406 181750.0n 0.4190 181999.9n 0.4190 182000.0n 0.4656 182249.9n 0.4656 182250.0n 0.3332 182499.9n 0.3332 182500.0n 0.8255 182749.9n 0.8255 182750.0n 0.4328 182999.9n 0.4328 183000.0n 0.5638 183249.9n 0.5638 183250.0n 0.5553 183499.9n 0.5553 183500.0n 0.1299 183749.9n 0.1299 183750.0n 0.3246 183999.9n 0.3246 184000.0n 0.1876 184249.9n 0.1876 184250.0n 0.4172 184499.9n 0.4172 184500.0n 0.5379 184749.9n 0.5379 184750.0n 0.3510 184999.9n 0.3510 185000.0n 0.4318 185249.9n 0.4318 185250.0n 0.5166 185499.9n 0.5166 185500.0n 0.2392 185749.9n 0.2392 185750.0n 0.6617 185999.9n 0.6617 186000.0n 0.5851 186249.9n 0.5851 186250.0n 0.3898 186499.9n 0.3898 186500.0n 0.8822 186749.9n 0.8822 186750.0n 0.7795 186999.9n 0.7795 187000.0n 0.6440 187249.9n 0.6440 187250.0n 0.8338 187499.9n 0.8338 187500.0n 0.8205 187749.9n 0.8205 187750.0n 0.6893 187999.9n 0.6893 188000.0n 0.1794 188249.9n 0.1794 188250.0n 0.4510 188499.9n 0.4510 188500.0n 0.5143 188749.9n 0.5143 188750.0n 0.3566 188999.9n 0.3566 189000.0n 0.6034 189249.9n 0.6034 189250.0n 0.1163 189499.9n 0.1163 189500.0n 0.5041 189749.9n 0.5041 189750.0n 0.5834 189999.9n 0.5834 190000.0n 0.8452 190249.9n 0.8452 190250.0n 0.5372 190499.9n 0.5372 190500.0n 0.6479 190749.9n 0.6479 190750.0n 0.4892 190999.9n 0.4892 191000.0n 0.6887 191249.9n 0.6887 191250.0n 0.4627 191499.9n 0.4627 191500.0n 0.2741 191749.9n 0.2741 191750.0n 0.1103 191999.9n 0.1103 192000.0n 0.9375 192249.9n 0.9375 192250.0n 0.5411 192499.9n 0.5411 192500.0n 0.4048 192749.9n 0.4048 192750.0n 0.8267 192999.9n 0.8267 193000.0n 0.5087 193249.9n 0.5087 193250.0n 0.3999 193499.9n 0.3999 193500.0n 0.5050 193749.9n 0.5050 193750.0n 0.2208 193999.9n 0.2208 194000.0n 0.6166 194249.9n 0.6166 194250.0n 0.6539 194499.9n 0.6539 194500.0n 0.5713 194749.9n 0.5713 194750.0n 0.4149 194999.9n 0.4149 195000.0n 0.5834 195249.9n 0.5834 195250.0n 0.5166 195499.9n 0.5166 195500.0n 0.8267 195749.9n 0.8267 195750.0n 0.8822 195999.9n 0.8822 196000.0n 0.2208 196249.9n 0.2208 196250.0n 0.5143 196499.9n 0.5143 196500.0n 0.7795 196749.9n 0.7795 196750.0n 0.4172 196999.9n 0.4172 197000.0n 0.2741 197249.9n 0.2741 197250.0n 0.5041 197499.9n 0.5041 197500.0n 0.5050 197749.9n 0.5050 197750.0n 0.9375 197999.9n 0.9375 198000.0n 0.5713 198249.9n 0.5713 198250.0n 0.4892 198499.9n 0.4892 198500.0n 0.4318 198749.9n 0.4318 198750.0n 0.1163 198999.9n 0.1163 199000.0n 0.1103 199249.9n 0.1103 199250.0n 0.5411 199499.9n 0.5411 199500.0n 0.8205 199749.9n 0.8205 199750.0n 0.5506 199999.9n 0.5506 200000.0n 0.4627 200249.9n 0.4627 200250.0n 0.8338 200499.9n 0.8338 200500.0n 0.4656 200749.9n 0.4656 200750.0n 0.2392 200999.9n 0.2392 201000.0n 0.6166 201249.9n 0.6166 201250.0n 0.4048 201499.9n 0.4048 201500.0n 0.5026 201749.9n 0.5026 201750.0n 0.1794 201999.9n 0.1794 202000.0n 0.5851 202249.9n 0.5851 202250.0n 0.4536 202499.9n 0.4536 202500.0n 0.3999 202749.9n 0.3999 202750.0n 0.5372 202999.9n 0.5372 203000.0n 0.5638 203249.9n 0.5638 203250.0n 0.2047 203499.9n 0.2047 203500.0n 0.5087 203749.9n 0.5087 203750.0n 0.8255 203999.9n 0.8255 204000.0n 0.1876 204249.9n 0.1876 204250.0n 0.8452 204499.9n 0.8452 204500.0n 0.3510 204749.9n 0.3510 204750.0n 0.6617 204999.9n 0.6617 205000.0n 0.1299 205249.9n 0.1299 205250.0n 0.4190 205499.9n 0.4190 205500.0n 0.6479 205749.9n 0.6479 205750.0n 0.5553 205999.9n 0.5553 206000.0n 0.4149 206249.9n 0.4149 206250.0n 0.4510 206499.9n 0.4510 206500.0n 0.6261 206749.9n 0.6261 206750.0n 0.6440 206999.9n 0.6440 207000.0n 0.3566 207249.9n 0.3566 207250.0n 0.6893 207499.9n 0.6893 207500.0n 0.4328 207749.9n 0.4328 207750.0n 0.3898 207999.9n 0.3898 208000.0n 0.6887 208249.9n 0.6887 208250.0n 0.3959 208499.9n 0.3959 208500.0n 0.5379 208749.9n 0.5379 208750.0n 0.6539 208999.9n 0.6539 209000.0n 0.3332 209249.9n 0.3332 209250.0n 0.3246 209499.9n 0.3246 209500.0n 0.3406 209749.9n 0.3406 209750.0n 0.6034 209999.9n 0.6034 210000.0n 0.5834 210249.9n 0.5834 210250.0n 0.8452 210499.9n 0.8452 210500.0n 0.5026 210749.9n 0.5026 210750.0n 0.4172 210999.9n 0.4172 211000.0n 0.5506 211249.9n 0.5506 211250.0n 0.6539 211499.9n 0.6539 211500.0n 0.3332 211749.9n 0.3332 211750.0n 0.4510 211999.9n 0.4510 212000.0n 0.5050 212249.9n 0.5050 212250.0n 0.6887 212499.9n 0.6887 212500.0n 0.2208 212749.9n 0.2208 212750.0n 0.5372 212999.9n 0.5372 213000.0n 0.4656 213249.9n 0.4656 213250.0n 0.6166 213499.9n 0.6166 213500.0n 0.3959 213749.9n 0.3959 213750.0n 0.6440 213999.9n 0.6440 214000.0n 0.1103 214249.9n 0.1103 214250.0n 0.8205 214499.9n 0.8205 214500.0n 0.8255 214749.9n 0.8255 214750.0n 0.1163 214999.9n 0.1163 215000.0n 0.5411 215249.9n 0.5411 215250.0n 0.5379 215499.9n 0.5379 215500.0n 0.8267 215749.9n 0.8267 215750.0n 0.5087 215999.9n 0.5087 216000.0n 0.9375 216249.9n 0.9375 216250.0n 0.2392 216499.9n 0.2392 216500.0n 0.5851 216749.9n 0.5851 216750.0n 0.6617 216999.9n 0.6617 217000.0n 0.5041 217249.9n 0.5041 217250.0n 0.3406 217499.9n 0.3406 217500.0n 0.5553 217749.9n 0.5553 217750.0n 0.4892 217999.9n 0.4892 218000.0n 0.4328 218249.9n 0.4328 218250.0n 0.5166 218499.9n 0.5166 218500.0n 0.4048 218749.9n 0.4048 218750.0n 0.1299 218999.9n 0.1299 219000.0n 0.6893 219249.9n 0.6893 219250.0n 0.7795 219499.9n 0.7795 219500.0n 0.8338 219749.9n 0.8338 219750.0n 0.3510 219999.9n 0.3510 220000.0n 0.1794 220249.9n 0.1794 220250.0n 0.3246 220499.9n 0.3246 220500.0n 0.5713 220749.9n 0.5713 220750.0n 0.4190 220999.9n 0.4190 221000.0n 0.4627 221249.9n 0.4627 221250.0n 0.2047 221499.9n 0.2047 221500.0n 0.6479 221749.9n 0.6479 221750.0n 0.3999 221999.9n 0.3999 222000.0n 0.3898 222249.9n 0.3898 222250.0n 0.3566 222499.9n 0.3566 222500.0n 0.4536 222749.9n 0.4536 222750.0n 0.2741 222999.9n 0.2741 223000.0n 0.5143 223249.9n 0.5143 223250.0n 0.4149 223499.9n 0.4149 223500.0n 0.8822 223749.9n 0.8822 223750.0n 0.6034 223999.9n 0.6034 224000.0n 0.4318 224249.9n 0.4318 224250.0n 0.1876 224499.9n 0.1876 224500.0n 0.5638 224749.9n 0.5638 224750.0n 0.6261 224999.9n 0.6261 225000.0n 0.4190 225249.9n 0.4190 225250.0n 0.3999 225499.9n 0.3999 225500.0n 0.8205 225749.9n 0.8205 225750.0n 0.5166 225999.9n 0.5166 226000.0n 0.5143 226249.9n 0.5143 226250.0n 0.3406 226499.9n 0.3406 226500.0n 0.4656 226749.9n 0.4656 226750.0n 0.3510 226999.9n 0.3510 227000.0n 0.5834 227249.9n 0.5834 227250.0n 0.3566 227499.9n 0.3566 227500.0n 0.4318 227749.9n 0.4318 227750.0n 0.2392 227999.9n 0.2392 228000.0n 0.2208 228249.9n 0.2208 228250.0n 0.6893 228499.9n 0.6893 228500.0n 0.4172 228749.9n 0.4172 228750.0n 0.3246 228999.9n 0.3246 229000.0n 0.5851 229249.9n 0.5851 229250.0n 0.1103 229499.9n 0.1103 229500.0n 0.9375 229749.9n 0.9375 229750.0n 0.4627 229999.9n 0.4627 230000.0n 0.7795 230249.9n 0.7795 230250.0n 0.8452 230499.9n 0.8452 230500.0n 0.1299 230749.9n 0.1299 230750.0n 0.5041 230999.9n 0.5041 231000.0n 0.5411 231249.9n 0.5411 231250.0n 0.8338 231499.9n 0.8338 231500.0n 0.4149 231749.9n 0.4149 231750.0n 0.6887 231999.9n 0.6887 232000.0n 0.3332 232249.9n 0.3332 232250.0n 0.8822 232499.9n 0.8822 232500.0n 0.8267 232749.9n 0.8267 232750.0n 0.2741 232999.9n 0.2741 233000.0n 0.5372 233249.9n 0.5372 233250.0n 0.5379 233499.9n 0.5379 233500.0n 0.5553 233749.9n 0.5553 233750.0n 0.6261 233999.9n 0.6261 234000.0n 0.6539 234249.9n 0.6539 234250.0n 0.8255 234499.9n 0.8255 234500.0n 0.1876 234749.9n 0.1876 234750.0n 0.1163 234999.9n 0.1163 235000.0n 0.6617 235249.9n 0.6617 235250.0n 0.4328 235499.9n 0.4328 235500.0n 0.3959 235749.9n 0.3959 235750.0n 0.6440 235999.9n 0.6440 236000.0n 0.6166 236249.9n 0.6166 236250.0n 0.5087 236499.9n 0.5087 236500.0n 0.4510 236749.9n 0.4510 236750.0n 0.5638 236999.9n 0.5638 237000.0n 0.6034 237249.9n 0.6034 237250.0n 0.1794 237499.9n 0.1794 237500.0n 0.2047 237749.9n 0.2047 237750.0n 0.5506 237999.9n 0.5506 238000.0n 0.5026 238249.9n 0.5026 238250.0n 0.4892 238499.9n 0.4892 238500.0n 0.5713 238749.9n 0.5713 238750.0n 0.6479 238999.9n 0.6479 239000.0n 0.3898 239249.9n 0.3898 239250.0n 0.4536 239499.9n 0.4536 239500.0n 0.4048 239749.9n 0.4048 239750.0n 0.5050 239999.9n 0.5050 240000.0n 0.3246 240249.9n 0.3246 240250.0n 0.5834 240499.9n 0.5834 240500.0n 0.5050 240749.9n 0.5050 240750.0n 0.8205 240999.9n 0.8205 241000.0n 0.3510 241249.9n 0.3510 241250.0n 0.6893 241499.9n 0.6893 241500.0n 0.6617 241749.9n 0.6617 241750.0n 0.5041 241999.9n 0.5041 242000.0n 0.5553 242249.9n 0.5553 242250.0n 0.5143 242499.9n 0.5143 242500.0n 0.6261 242749.9n 0.6261 242750.0n 0.5372 242999.9n 0.5372 243000.0n 0.8338 243249.9n 0.8338 243250.0n 0.1163 243499.9n 0.1163 243500.0n 0.5026 243749.9n 0.5026 243750.0n 0.5713 243999.9n 0.5713 244000.0n 0.4536 244249.9n 0.4536 244250.0n 0.6034 244499.9n 0.6034 244500.0n 0.5379 244749.9n 0.5379 244750.0n 0.1794 244999.9n 0.1794 245000.0n 0.4172 245249.9n 0.4172 245250.0n 0.3332 245499.9n 0.3332 245500.0n 0.4627 245749.9n 0.4627 245750.0n 0.5506 245999.9n 0.5506 246000.0n 0.4149 246249.9n 0.4149 246250.0n 0.2392 246499.9n 0.2392 246500.0n 0.1876 246749.9n 0.1876 246750.0n 0.4892 246999.9n 0.4892 247000.0n 0.1103 247249.9n 0.1103 247250.0n 0.3566 247499.9n 0.3566 247500.0n 0.6539 247749.9n 0.6539 247750.0n 0.3959 247999.9n 0.3959 248000.0n 0.6887 248249.9n 0.6887 248250.0n 0.4190 248499.9n 0.4190 248500.0n 0.6166 248749.9n 0.6166 248750.0n 0.8452 248999.9n 0.8452 249000.0n 0.4328 249249.9n 0.4328 249250.0n 0.3406 249499.9n 0.3406 249500.0n 0.8255 249749.9n 0.8255 249750.0n 0.4656 249999.9n 0.4656 250000.0n 0.5638 250249.9n 0.5638 250250.0n 0.9375 250499.9n 0.9375 250500.0n 0.6479 250749.9n 0.6479 250750.0n 0.3898 250999.9n 0.3898 251000.0n 0.4318 251249.9n 0.4318 251250.0n 0.5851 251499.9n 0.5851 251500.0n 0.7795 251749.9n 0.7795 251750.0n 0.5411 251999.9n 0.5411 252000.0n 0.5166 252249.9n 0.5166 252250.0n 0.6440 252499.9n 0.6440 252500.0n 0.5087 252749.9n 0.5087 252750.0n 0.2047 252999.9n 0.2047 253000.0n 0.1299 253249.9n 0.1299 253250.0n 0.4510 253499.9n 0.4510 253500.0n 0.2741 253749.9n 0.2741 253750.0n 0.8267 253999.9n 0.8267 254000.0n 0.3999 254249.9n 0.3999 254250.0n 0.2208 254499.9n 0.2208 254500.0n 0.8822 254749.9n 0.8822 254750.0n 0.4048 254999.9n 0.4048 255000.0n 0.4318 255249.9n 0.4318 255250.0n 0.1163 255499.9n 0.1163 255500.0n 0.1876 255749.9n 0.1876 255750.0n 0.6034 255999.9n 0.6034 256000.0n 0.4190 256249.9n 0.4190 256250.0n 0.4656 256499.9n 0.4656 256500.0n 0.4172 256749.9n 0.4172 256750.0n 0.6479 256999.9n 0.6479 257000.0n 0.5851 257249.9n 0.5851 257250.0n 0.3510 257499.9n 0.3510 257500.0n 0.5026 257749.9n 0.5026 257750.0n 0.5166 257999.9n 0.5166 258000.0n 0.9375 258249.9n 0.9375 258250.0n 0.4510 258499.9n 0.4510 258500.0n 0.4536 258749.9n 0.4536 258750.0n 0.6261 258999.9n 0.6261 259000.0n 0.8205 259249.9n 0.8205 259250.0n 0.3246 259499.9n 0.3246 259500.0n 0.5143 259749.9n 0.5143 259750.0n 0.6166 259999.9n 0.6166 260000.0n 0.3332 260249.9n 0.3332 260250.0n 0.2741 260499.9n 0.2741 260500.0n 0.8338 260749.9n 0.8338 260750.0n 0.3406 260999.9n 0.3406 261000.0n 0.6887 261249.9n 0.6887 261250.0n 0.5087 261499.9n 0.5087 261500.0n 0.5638 261749.9n 0.5638 261750.0n 0.5050 261999.9n 0.5050 262000.0n 0.7795 262249.9n 0.7795 262250.0n 0.2208 262499.9n 0.2208 262500.0n 0.8822 262749.9n 0.8822 262750.0n 0.1103 262999.9n 0.1103 263000.0n 0.5411 263249.9n 0.5411 263250.0n 0.5506 263499.9n 0.5506 263500.0n 0.1794 263749.9n 0.1794 263750.0n 0.6440 263999.9n 0.6440 264000.0n 0.2392 264249.9n 0.2392 264250.0n 0.1299 264499.9n 0.1299 264500.0n 0.6539 264749.9n 0.6539 264750.0n 0.5372 264999.9n 0.5372 265000.0n 0.8267 265249.9n 0.8267 265250.0n 0.4048 265499.9n 0.4048 265500.0n 0.3999 265749.9n 0.3999 265750.0n 0.4149 265999.9n 0.4149 266000.0n 0.6617 266249.9n 0.6617 266250.0n 0.4627 266499.9n 0.4627 266500.0n 0.2047 266749.9n 0.2047 266750.0n 0.6893 266999.9n 0.6893 267000.0n 0.5041 267249.9n 0.5041 267250.0n 0.3898 267499.9n 0.3898 267500.0n 0.3959 267749.9n 0.3959 267750.0n 0.4328 267999.9n 0.4328 268000.0n 0.5379 268249.9n 0.5379 268250.0n 0.8255 268499.9n 0.8255 268500.0n 0.4892 268749.9n 0.4892 268750.0n 0.5834 268999.9n 0.5834 269000.0n 0.3566 269249.9n 0.3566 269250.0n 0.5553 269499.9n 0.5553 269500.0n 0.5713 269749.9n 0.5713 269750.0n 0.8452 269999.9n 0.8452 270000.0n 0.4190 270249.9n 0.4190 270250.0n 0.4892 270499.9n 0.4892 270500.0n 0.6261 270749.9n 0.6261 270750.0n 0.8255 270999.9n 0.8255 271000.0n 0.5553 271249.9n 0.5553 271250.0n 0.1163 271499.9n 0.1163 271500.0n 0.6617 271749.9n 0.6617 271750.0n 0.6479 271999.9n 0.6479 272000.0n 0.5087 272249.9n 0.5087 272250.0n 0.5506 272499.9n 0.5506 272500.0n 0.5713 272749.9n 0.5713 272750.0n 0.3898 272999.9n 0.3898 273000.0n 0.1794 273249.9n 0.1794 273250.0n 0.6440 273499.9n 0.6440 273500.0n 0.5050 273749.9n 0.5050 273750.0n 0.6887 273999.9n 0.6887 274000.0n 0.2392 274249.9n 0.2392 274250.0n 0.3406 274499.9n 0.3406 274500.0n 0.8452 274749.9n 0.8452 274750.0n 0.8338 274999.9n 0.8338 275000.0n 0.5041 275249.9n 0.5041 275250.0n 0.6166 275499.9n 0.6166 275500.0n 0.5372 275749.9n 0.5372 275750.0n 0.4536 275999.9n 0.4536 276000.0n 0.5411 276249.9n 0.5411 276250.0n 0.6034 276499.9n 0.6034 276500.0n 0.4048 276749.9n 0.4048 276750.0n 0.7795 276999.9n 0.7795 277000.0n 0.1103 277249.9n 0.1103 277250.0n 0.1876 277499.9n 0.1876 277500.0n 0.4627 277749.9n 0.4627 277750.0n 0.1299 277999.9n 0.1299 278000.0n 0.5166 278249.9n 0.5166 278250.0n 0.2208 278499.9n 0.2208 278500.0n 0.3332 278749.9n 0.3332 278750.0n 0.5851 278999.9n 0.5851 279000.0n 0.3246 279249.9n 0.3246 279250.0n 0.4328 279499.9n 0.4328 279500.0n 0.8822 279749.9n 0.8822 279750.0n 0.4172 279999.9n 0.4172 280000.0n 0.5638 280249.9n 0.5638 280250.0n 0.5026 280499.9n 0.5026 280500.0n 0.5379 280749.9n 0.5379 280750.0n 0.5834 280999.9n 0.5834 281000.0n 0.4510 281249.9n 0.4510 281250.0n 0.3999 281499.9n 0.3999 281500.0n 0.4656 281749.9n 0.4656 281750.0n 0.4149 281999.9n 0.4149 282000.0n 0.9375 282249.9n 0.9375 282250.0n 0.3959 282499.9n 0.3959 282500.0n 0.8267 282749.9n 0.8267 282750.0n 0.3510 282999.9n 0.3510 283000.0n 0.2047 283249.9n 0.2047 283250.0n 0.5143 283499.9n 0.5143 283500.0n 0.3566 283749.9n 0.3566 283750.0n 0.8205 283999.9n 0.8205 284000.0n 0.4318 284249.9n 0.4318 284250.0n 0.6893 284499.9n 0.6893 284500.0n 0.2741 284749.9n 0.2741 284750.0n 0.6539 284999.9n 0.6539 285000.0n 0.3510 285249.9n 0.3510 285250.0n 0.9375 285499.9n 0.9375 285500.0n 0.5166 285749.9n 0.5166 285750.0n 0.6539 285999.9n 0.6539 286000.0n 0.1163 286249.9n 0.1163 286250.0n 0.8452 286499.9n 0.8452 286500.0n 0.6034 286749.9n 0.6034 286750.0n 0.1794 286999.9n 0.1794 287000.0n 0.5050 287249.9n 0.5050 287250.0n 0.6893 287499.9n 0.6893 287500.0n 0.3959 287749.9n 0.3959 287750.0n 0.5553 287999.9n 0.5553 288000.0n 0.5379 288249.9n 0.5379 288250.0n 0.7795 288499.9n 0.7795 288500.0n 0.5143 288749.9n 0.5143 288750.0n 0.6166 288999.9n 0.6166 289000.0n 0.4328 289249.9n 0.4328 289250.0n 0.4627 289499.9n 0.4627 289500.0n 0.4048 289749.9n 0.4048 289750.0n 0.3406 289999.9n 0.3406 290000.0n 0.3332 290249.9n 0.3332 290250.0n 0.8822 290499.9n 0.8822 290500.0n 0.6440 290749.9n 0.6440 290750.0n 0.6261 290999.9n 0.6261 291000.0n 0.4892 291249.9n 0.4892 291250.0n 0.5411 291499.9n 0.5411 291500.0n 0.8338 291749.9n 0.8338 291750.0n 0.3246 291999.9n 0.3246 292000.0n 0.6617 292249.9n 0.6617 292250.0n 0.3566 292499.9n 0.3566 292500.0n 0.2392 292749.9n 0.2392 292750.0n 0.4536 292999.9n 0.4536 293000.0n 0.4318 293249.9n 0.4318 293250.0n 0.5713 293499.9n 0.5713 293500.0n 0.4149 293749.9n 0.4149 293750.0n 0.3999 293999.9n 0.3999 294000.0n 0.5087 294249.9n 0.5087 294250.0n 0.1103 294499.9n 0.1103 294500.0n 0.5372 294749.9n 0.5372 294750.0n 0.8205 294999.9n 0.8205 295000.0n 0.4190 295249.9n 0.4190 295250.0n 0.8267 295499.9n 0.8267 295500.0n 0.5638 295749.9n 0.5638 295750.0n 0.2047 295999.9n 0.2047 296000.0n 0.1299 296249.9n 0.1299 296250.0n 0.6887 296499.9n 0.6887 296500.0n 0.4656 296749.9n 0.4656 296750.0n 0.4172 296999.9n 0.4172 297000.0n 0.5041 297249.9n 0.5041 297250.0n 0.3898 297499.9n 0.3898 297500.0n 0.5026 297749.9n 0.5026 297750.0n 0.1876 297999.9n 0.1876 298000.0n 0.8255 298249.9n 0.8255 298250.0n 0.2208 298499.9n 0.2208 298500.0n 0.5851 298749.9n 0.5851 298750.0n 0.2741 298999.9n 0.2741 299000.0n 0.5834 299249.9n 0.5834 299250.0n 0.4510 299499.9n 0.4510 299500.0n 0.6479 299749.9n 0.6479 299750.0n 0.5506 299999.9n 0.5506 300000.0n 0.5638 300249.9n 0.5638 300250.0n 0.4172 300499.9n 0.4172 300500.0n 0.6261 300749.9n 0.6261 300750.0n 0.8267 300999.9n 0.8267 301000.0n 0.5851 301249.9n 0.5851 301250.0n 0.4656 301499.9n 0.4656 301500.0n 0.8822 301749.9n 0.8822 301750.0n 0.3406 301999.9n 0.3406 302000.0n 0.1876 302249.9n 0.1876 302250.0n 0.5553 302499.9n 0.5553 302500.0n 0.5050 302749.9n 0.5050 302750.0n 0.5166 302999.9n 0.5166 303000.0n 0.4627 303249.9n 0.4627 303250.0n 0.8205 303499.9n 0.8205 303500.0n 0.6539 303749.9n 0.6539 303750.0n 0.6479 303999.9n 0.6479 304000.0n 0.4149 304249.9n 0.4149 304250.0n 0.4510 304499.9n 0.4510 304500.0n 0.6887 304749.9n 0.6887 304750.0n 0.2208 304999.9n 0.2208 305000.0n 0.4328 305249.9n 0.4328 305250.0n 0.2741 305499.9n 0.2741 305500.0n 0.4318 305749.9n 0.4318 305750.0n 0.5506 305999.9n 0.5506 306000.0n 0.3898 306249.9n 0.3898 306250.0n 0.1103 306499.9n 0.1103 306500.0n 0.3959 306749.9n 0.3959 306750.0n 0.5143 306999.9n 0.5143 307000.0n 0.8338 307249.9n 0.8338 307250.0n 0.7795 307499.9n 0.7795 307500.0n 0.3566 307749.9n 0.3566 307750.0n 0.3999 307999.9n 0.3999 308000.0n 0.5713 308249.9n 0.5713 308250.0n 0.4048 308499.9n 0.4048 308500.0n 0.2392 308749.9n 0.2392 308750.0n 0.8452 308999.9n 0.8452 309000.0n 0.5372 309249.9n 0.5372 309250.0n 0.4892 309499.9n 0.4892 309500.0n 0.6166 309749.9n 0.6166 309750.0n 0.3510 309999.9n 0.3510 310000.0n 0.5411 310249.9n 0.5411 310250.0n 0.6893 310499.9n 0.6893 310500.0n 0.1794 310749.9n 0.1794 310750.0n 0.5026 310999.9n 0.5026 311000.0n 0.1299 311249.9n 0.1299 311250.0n 0.6440 311499.9n 0.6440 311500.0n 0.5041 311749.9n 0.5041 311750.0n 0.6034 311999.9n 0.6034 312000.0n 0.5087 312249.9n 0.5087 312250.0n 0.8255 312499.9n 0.8255 312500.0n 0.9375 312749.9n 0.9375 312750.0n 0.5379 312999.9n 0.5379 313000.0n 0.4536 313249.9n 0.4536 313250.0n 0.3246 313499.9n 0.3246 313500.0n 0.6617 313749.9n 0.6617 313750.0n 0.3332 313999.9n 0.3332 314000.0n 0.1163 314249.9n 0.1163 314250.0n 0.5834 314499.9n 0.5834 314500.0n 0.4190 314749.9n 0.4190 314750.0n 0.2047 314999.9n 0.2047 315000.0n 0.5713 315249.9n 0.5713 315250.0n 0.8267 315499.9n 0.8267 315500.0n 0.4536 315749.9n 0.4536 315750.0n 0.1299 315999.9n 0.1299 316000.0n 0.5411 316249.9n 0.5411 316250.0n 0.3999 316499.9n 0.3999 316500.0n 0.5851 316749.9n 0.5851 316750.0n 0.2392 316999.9n 0.2392 317000.0n 0.6539 317249.9n 0.6539 317250.0n 0.6440 317499.9n 0.6440 317500.0n 0.2047 317749.9n 0.2047 317750.0n 0.8452 317999.9n 0.8452 318000.0n 0.4510 318249.9n 0.4510 318250.0n 0.5087 318499.9n 0.5087 318500.0n 0.7795 318749.9n 0.7795 318750.0n 0.8822 318999.9n 0.8822 319000.0n 0.8255 319249.9n 0.8255 319250.0n 0.4318 319499.9n 0.4318 319500.0n 0.6261 319749.9n 0.6261 319750.0n 0.4656 319999.9n 0.4656 320000.0n 0.5638 320249.9n 0.5638 320250.0n 0.4190 320499.9n 0.4190 320500.0n 0.5834 320749.9n 0.5834 320750.0n 0.8205 320999.9n 0.8205 321000.0n 0.4892 321249.9n 0.4892 321250.0n 0.6887 321499.9n 0.6887 321500.0n 0.3510 321749.9n 0.3510 321750.0n 0.5026 321999.9n 0.5026 322000.0n 0.4048 322249.9n 0.4048 322250.0n 0.5041 322499.9n 0.5041 322500.0n 0.3246 322749.9n 0.3246 322750.0n 0.2741 322999.9n 0.2741 323000.0n 0.3898 323249.9n 0.3898 323250.0n 0.1794 323499.9n 0.1794 323500.0n 0.3959 323749.9n 0.3959 323750.0n 0.9375 323999.9n 0.9375 324000.0n 0.5166 324249.9n 0.5166 324250.0n 0.6479 324499.9n 0.6479 324500.0n 0.5050 324749.9n 0.5050 324750.0n 0.3332 324999.9n 0.3332 325000.0n 0.1876 325249.9n 0.1876 325250.0n 0.5553 325499.9n 0.5553 325500.0n 0.4149 325749.9n 0.4149 325750.0n 0.2208 325999.9n 0.2208 326000.0n 0.6166 326249.9n 0.6166 326250.0n 0.6617 326499.9n 0.6617 326500.0n 0.5379 326749.9n 0.5379 326750.0n 0.1103 326999.9n 0.1103 327000.0n 0.3566 327249.9n 0.3566 327250.0n 0.6034 327499.9n 0.6034 327500.0n 0.6893 327749.9n 0.6893 327750.0n 0.5506 327999.9n 0.5506 328000.0n 0.4627 328249.9n 0.4627 328250.0n 0.4172 328499.9n 0.4172 328500.0n 0.5372 328749.9n 0.5372 328750.0n 0.1163 328999.9n 0.1163 329000.0n 0.5143 329249.9n 0.5143 329250.0n 0.4328 329499.9n 0.4328 329500.0n 0.8338 329749.9n 0.8338 329750.0n 0.3406 329999.9n 0.3406 330000.0n 0.4190 330249.9n 0.4190 330250.0n 0.4892 330499.9n 0.4892 330500.0n 0.3510 330749.9n 0.3510 330750.0n 0.5411 330999.9n 0.5411 331000.0n 0.4510 331249.9n 0.4510 331250.0n 0.5506 331499.9n 0.5506 331500.0n 0.4048 331749.9n 0.4048 331750.0n 0.5166 331999.9n 0.5166 332000.0n 0.3999 332249.9n 0.3999 332250.0n 0.3406 332499.9n 0.3406 332500.0n 0.6539 332749.9n 0.6539 332750.0n 0.6479 332999.9n 0.6479 333000.0n 0.6261 333249.9n 0.6261 333250.0n 0.9375 333499.9n 0.9375 333500.0n 0.3332 333749.9n 0.3332 333750.0n 0.2392 333999.9n 0.2392 334000.0n 0.6887 334249.9n 0.6887 334250.0n 0.8205 334499.9n 0.8205 334500.0n 0.2741 334749.9n 0.2741 334750.0n 0.5834 334999.9n 0.5834 335000.0n 0.1163 335249.9n 0.1163 335250.0n 0.4656 335499.9n 0.4656 335500.0n 0.6034 335749.9n 0.6034 335750.0n 0.5379 335999.9n 0.5379 336000.0n 0.5638 336249.9n 0.5638 336250.0n 0.5372 336499.9n 0.5372 336500.0n 0.5041 336749.9n 0.5041 336750.0n 0.4318 336999.9n 0.4318 337000.0n 0.4328 337249.9n 0.4328 337250.0n 0.2047 337499.9n 0.2047 337500.0n 0.1103 337749.9n 0.1103 337750.0n 0.5713 337999.9n 0.5713 338000.0n 0.6617 338249.9n 0.6617 338250.0n 0.3566 338499.9n 0.3566 338500.0n 0.8822 338749.9n 0.8822 338750.0n 0.4149 338999.9n 0.4149 339000.0n 0.4536 339249.9n 0.4536 339250.0n 0.1876 339499.9n 0.1876 339500.0n 0.8452 339749.9n 0.8452 339750.0n 0.5851 339999.9n 0.5851 340000.0n 0.1794 340249.9n 0.1794 340250.0n 0.5026 340499.9n 0.5026 340500.0n 0.6166 340749.9n 0.6166 340750.0n 0.5087 340999.9n 0.5087 341000.0n 0.5553 341249.9n 0.5553 341250.0n 0.2208 341499.9n 0.2208 341500.0n 0.5143 341749.9n 0.5143 341750.0n 0.5050 341999.9n 0.5050 342000.0n 0.6440 342249.9n 0.6440 342250.0n 0.8267 342499.9n 0.8267 342500.0n 0.6893 342749.9n 0.6893 342750.0n 0.1299 342999.9n 0.1299 343000.0n 0.8338 343249.9n 0.8338 343250.0n 0.3959 343499.9n 0.3959 343500.0n 0.3898 343749.9n 0.3898 343750.0n 0.8255 343999.9n 0.8255 344000.0n 0.7795 344249.9n 0.7795 344250.0n 0.4627 344499.9n 0.4627 344500.0n 0.3246 344749.9n 0.3246 344750.0n 0.4172 344999.9n 0.4172 345000.0n 0.4149 345249.9n 0.4149 345250.0n 0.4328 345499.9n 0.4328 345500.0n 0.5166 345749.9n 0.5166 345750.0n 0.3999 345999.9n 0.3999 346000.0n 0.5834 346249.9n 0.5834 346250.0n 0.4318 346499.9n 0.4318 346500.0n 0.6893 346749.9n 0.6893 346750.0n 0.8452 346999.9n 0.8452 347000.0n 0.6440 347249.9n 0.6440 347250.0n 0.4048 347499.9n 0.4048 347500.0n 0.1794 347749.9n 0.1794 347750.0n 0.9375 347999.9n 0.9375 348000.0n 0.5638 348249.9n 0.5638 348250.0n 0.4656 348499.9n 0.4656 348500.0n 0.5851 348749.9n 0.5851 348750.0n 0.4172 348999.9n 0.4172 349000.0n 0.4627 349249.9n 0.4627 349250.0n 0.1876 349499.9n 0.1876 349500.0n 0.5553 349749.9n 0.5553 349750.0n 0.5713 349999.9n 0.5713 350000.0n 0.1299 350249.9n 0.1299 350250.0n 0.4510 350499.9n 0.4510 350500.0n 0.5379 350749.9n 0.5379 350750.0n 0.6887 350999.9n 0.6887 351000.0n 0.5026 351249.9n 0.5026 351250.0n 0.6617 351499.9n 0.6617 351500.0n 0.7795 351749.9n 0.7795 351750.0n 0.8255 351999.9n 0.8255 352000.0n 0.4536 352249.9n 0.4536 352250.0n 0.1163 352499.9n 0.1163 352500.0n 0.3510 352749.9n 0.3510 352750.0n 0.2047 352999.9n 0.2047 353000.0n 0.2741 353249.9n 0.2741 353250.0n 0.8267 353499.9n 0.8267 353500.0n 0.4892 353749.9n 0.4892 353750.0n 0.6034 353999.9n 0.6034 354000.0n 0.8205 354249.9n 0.8205 354250.0n 0.3406 354499.9n 0.3406 354500.0n 0.8338 354749.9n 0.8338 354750.0n 0.6261 354999.9n 0.6261 355000.0n 0.5050 355249.9n 0.5050 355250.0n 0.5041 355499.9n 0.5041 355500.0n 0.3898 355749.9n 0.3898 355750.0n 0.5143 355999.9n 0.5143 356000.0n 0.6166 356249.9n 0.6166 356250.0n 0.2392 356499.9n 0.2392 356500.0n 0.6539 356749.9n 0.6539 356750.0n 0.6479 356999.9n 0.6479 357000.0n 0.3566 357249.9n 0.3566 357250.0n 0.8822 357499.9n 0.8822 357500.0n 0.5087 357749.9n 0.5087 357750.0n 0.5372 357999.9n 0.5372 358000.0n 0.3959 358249.9n 0.3959 358250.0n 0.4190 358499.9n 0.4190 358500.0n 0.5506 358749.9n 0.5506 358750.0n 0.3332 358999.9n 0.3332 359000.0n 0.2208 359249.9n 0.2208 359250.0n 0.5411 359499.9n 0.5411 359500.0n 0.3246 359749.9n 0.3246 359750.0n 0.1103 359999.9n 0.1103 360000.0n 0.3999 360249.9n 0.3999 360250.0n 0.4172 360499.9n 0.4172 360500.0n 0.5087 360749.9n 0.5087 360750.0n 0.2208 360999.9n 0.2208 361000.0n 0.8452 361249.9n 0.8452 361250.0n 0.4328 361499.9n 0.4328 361500.0n 0.3246 361749.9n 0.3246 361750.0n 0.7795 361999.9n 0.7795 362000.0n 0.6261 362249.9n 0.6261 362250.0n 0.9375 362499.9n 0.9375 362500.0n 0.8255 362749.9n 0.8255 362750.0n 0.3959 362999.9n 0.3959 363000.0n 0.4536 363249.9n 0.4536 363250.0n 0.5166 363499.9n 0.5166 363500.0n 0.5041 363749.9n 0.5041 363750.0n 0.3406 363999.9n 0.3406 364000.0n 0.1299 364249.9n 0.1299 364250.0n 0.6440 364499.9n 0.6440 364500.0n 0.5411 364749.9n 0.5411 364750.0n 0.2047 364999.9n 0.2047 365000.0n 0.6479 365249.9n 0.6479 365250.0n 0.4318 365499.9n 0.4318 365500.0n 0.1876 365749.9n 0.1876 365750.0n 0.3566 365999.9n 0.3566 366000.0n 0.8205 366249.9n 0.8205 366250.0n 0.3332 366499.9n 0.3332 366500.0n 0.4048 366749.9n 0.4048 366750.0n 0.5638 366999.9n 0.5638 367000.0n 0.8822 367249.9n 0.8822 367250.0n 0.6539 367499.9n 0.6539 367500.0n 0.6893 367749.9n 0.6893 367750.0n 0.4892 367999.9n 0.4892 368000.0n 0.5372 368249.9n 0.5372 368250.0n 0.5834 368499.9n 0.5834 368500.0n 0.5143 368749.9n 0.5143 368750.0n 0.2741 368999.9n 0.2741 369000.0n 0.4510 369249.9n 0.4510 369250.0n 0.6887 369499.9n 0.6887 369500.0n 0.5379 369749.9n 0.5379 369750.0n 0.2392 369999.9n 0.2392 370000.0n 0.5506 370249.9n 0.5506 370250.0n 0.4627 370499.9n 0.4627 370500.0n 0.3898 370749.9n 0.3898 370750.0n 0.5553 370999.9n 0.5553 371000.0n 0.4149 371249.9n 0.4149 371250.0n 0.1794 371499.9n 0.1794 371500.0n 0.1163 371749.9n 0.1163 371750.0n 0.4656 371999.9n 0.4656 372000.0n 0.4190 372249.9n 0.4190 372250.0n 0.3510 372499.9n 0.3510 372500.0n 0.5851 372749.9n 0.5851 372750.0n 0.1103 372999.9n 0.1103 373000.0n 0.5026 373249.9n 0.5026 373250.0n 0.8338 373499.9n 0.8338 373500.0n 0.6166 373749.9n 0.6166 373750.0n 0.8267 373999.9n 0.8267 374000.0n 0.5050 374249.9n 0.5050 374250.0n 0.6617 374499.9n 0.6617 374500.0n 0.6034 374749.9n 0.6034 374750.0n 0.5713 374999.9n 0.5713 375000.0n 0.3246 375249.9n 0.3246 375250.0n 0.3332 375499.9n 0.3332 375500.0n 0.5050 375749.9n 0.5050 375750.0n 0.3510 375999.9n 0.3510 376000.0n 0.2392 376249.9n 0.2392 376250.0n 0.5506 376499.9n 0.5506 376500.0n 0.5026 376749.9n 0.5026 376750.0n 0.5372 376999.9n 0.5372 377000.0n 0.2208 377249.9n 0.2208 377250.0n 0.6887 377499.9n 0.6887 377500.0n 0.4048 377749.9n 0.4048 377750.0n 0.8205 377999.9n 0.8205 378000.0n 0.5713 378249.9n 0.5713 378250.0n 0.4190 378499.9n 0.4190 378500.0n 0.4318 378749.9n 0.4318 378750.0n 0.6893 378999.9n 0.6893 379000.0n 0.2047 379249.9n 0.2047 379250.0n 0.5638 379499.9n 0.5638 379500.0n 0.7795 379749.9n 0.7795 379750.0n 0.2741 379999.9n 0.2741 380000.0n 0.5041 380249.9n 0.5041 380250.0n 0.4536 380499.9n 0.4536 380500.0n 0.8452 380749.9n 0.8452 380750.0n 0.6034 380999.9n 0.6034 381000.0n 0.9375 381249.9n 0.9375 381250.0n 0.6479 381499.9n 0.6479 381500.0n 0.3566 381749.9n 0.3566 381750.0n 0.4510 381999.9n 0.4510 382000.0n 0.6440 382249.9n 0.6440 382250.0n 0.3959 382499.9n 0.3959 382500.0n 0.6166 382749.9n 0.6166 382750.0n 0.1299 382999.9n 0.1299 383000.0n 0.4149 383249.9n 0.4149 383250.0n 0.6261 383499.9n 0.6261 383500.0n 0.8822 383749.9n 0.8822 383750.0n 0.4328 383999.9n 0.4328 384000.0n 0.5834 384249.9n 0.5834 384250.0n 0.8267 384499.9n 0.8267 384500.0n 0.6539 384749.9n 0.6539 384750.0n 0.3898 384999.9n 0.3898 385000.0n 0.5087 385249.9n 0.5087 385250.0n 0.1103 385499.9n 0.1103 385500.0n 0.5851 385749.9n 0.5851 385750.0n 0.5143 385999.9n 0.5143 386000.0n 0.1876 386249.9n 0.1876 386250.0n 0.4627 386499.9n 0.4627 386500.0n 0.6617 386749.9n 0.6617 386750.0n 0.8338 386999.9n 0.8338 387000.0n 0.3406 387249.9n 0.3406 387250.0n 0.4656 387499.9n 0.4656 387500.0n 0.5411 387749.9n 0.5411 387750.0n 0.8255 387999.9n 0.8255 388000.0n 0.4892 388249.9n 0.4892 388250.0n 0.1163 388499.9n 0.1163 388500.0n 0.4172 388749.9n 0.4172 388750.0n 0.5553 388999.9n 0.5553 389000.0n 0.1794 389249.9n 0.1794 389250.0n 0.5166 389499.9n 0.5166 389500.0n 0.3999 389749.9n 0.3999 389750.0n 0.5379 389999.9n 0.5379 390000.0n 0.5379 390249.9n 0.5379 390250.0n 0.7795 390499.9n 0.7795 390500.0n 0.5087 390749.9n 0.5087 390750.0n 0.5372 390999.9n 0.5372 391000.0n 0.1876 391249.9n 0.1876 391250.0n 0.4149 391499.9n 0.4149 391500.0n 0.6893 391749.9n 0.6893 391750.0n 0.8338 391999.9n 0.8338 392000.0n 0.6261 392249.9n 0.6261 392250.0n 0.3246 392499.9n 0.3246 392500.0n 0.5506 392749.9n 0.5506 392750.0n 0.6887 392999.9n 0.6887 393000.0n 0.6034 393249.9n 0.6034 393250.0n 0.4328 393499.9n 0.4328 393500.0n 0.8452 393749.9n 0.8452 393750.0n 0.4190 393999.9n 0.4190 394000.0n 0.4656 394249.9n 0.4656 394250.0n 0.6479 394499.9n 0.6479 394500.0n 0.2741 394749.9n 0.2741 394750.0n 0.3959 394999.9n 0.3959 395000.0n 0.2392 395249.9n 0.2392 395250.0n 0.4536 395499.9n 0.4536 395500.0n 0.5026 395749.9n 0.5026 395750.0n 0.1163 395999.9n 0.1163 396000.0n 0.1103 396249.9n 0.1103 396250.0n 0.4318 396499.9n 0.4318 396500.0n 0.9375 396749.9n 0.9375 396750.0n 0.5851 396999.9n 0.5851 397000.0n 0.5834 397249.9n 0.5834 397250.0n 0.2047 397499.9n 0.2047 397500.0n 0.4892 397749.9n 0.4892 397750.0n 0.5638 397999.9n 0.5638 398000.0n 0.5050 398249.9n 0.5050 398250.0n 0.3406 398499.9n 0.3406 398500.0n 0.3510 398749.9n 0.3510 398750.0n 0.5553 398999.9n 0.5553 399000.0n 0.6440 399249.9n 0.6440 399250.0n 0.8205 399499.9n 0.8205 399500.0n 0.8822 399749.9n 0.8822 399750.0n 0.3332 399999.9n 0.3332 400000.0n 0.5411 400249.9n 0.5411 400250.0n 0.4048 400499.9n 0.4048 400500.0n 0.5166 400749.9n 0.5166 400750.0n 0.8255 400999.9n 0.8255 401000.0n 0.6166 401249.9n 0.6166 401250.0n 0.4172 401499.9n 0.4172 401500.0n 0.5143 401749.9n 0.5143 401750.0n 0.3566 401999.9n 0.3566 402000.0n 0.1299 402249.9n 0.1299 402250.0n 0.4627 402499.9n 0.4627 402500.0n 0.6539 402749.9n 0.6539 402750.0n 0.5713 402999.9n 0.5713 403000.0n 0.3898 403249.9n 0.3898 403250.0n 0.5041 403499.9n 0.5041 403500.0n 0.4510 403749.9n 0.4510 403750.0n 0.1794 403999.9n 0.1794 404000.0n 0.8267 404249.9n 0.8267 404250.0n 0.3999 404499.9n 0.3999 404500.0n 0.2208 404749.9n 0.2208 404750.0n 0.6617 404999.9n 0.6617 405000.0n 0.5379 405249.9n 0.5379 405250.0n 0.9375 405499.9n 0.9375 405500.0n 0.4656 405749.9n 0.4656 405750.0n 0.8205 405999.9n 0.8205 406000.0n 0.2741 406249.9n 0.2741 406250.0n 0.6166 406499.9n 0.6166 406500.0n 0.5050 406749.9n 0.5050 406750.0n 0.4536 406999.9n 0.4536 407000.0n 0.8267 407249.9n 0.8267 407250.0n 0.5026 407499.9n 0.5026 407500.0n 0.5143 407749.9n 0.5143 407750.0n 0.6893 407999.9n 0.6893 408000.0n 0.8255 408249.9n 0.8255 408250.0n 0.3246 408499.9n 0.3246 408500.0n 0.3406 408749.9n 0.3406 408750.0n 0.1794 408999.9n 0.1794 409000.0n 0.4048 409249.9n 0.4048 409250.0n 0.5713 409499.9n 0.5713 409500.0n 0.1876 409749.9n 0.1876 409750.0n 0.6617 409999.9n 0.6617 410000.0n 0.6887 410249.9n 0.6887 410250.0n 0.4892 410499.9n 0.4892 410500.0n 0.5372 410749.9n 0.5372 410750.0n 0.5041 410999.9n 0.5041 411000.0n 0.6479 411249.9n 0.6479 411250.0n 0.4318 411499.9n 0.4318 411500.0n 0.7795 411749.9n 0.7795 411750.0n 0.5506 411999.9n 0.5506 412000.0n 0.4328 412249.9n 0.4328 412250.0n 0.8338 412499.9n 0.8338 412500.0n 0.8822 412749.9n 0.8822 412750.0n 0.5166 412999.9n 0.5166 413000.0n 0.5087 413249.9n 0.5087 413250.0n 0.5411 413499.9n 0.5411 413500.0n 0.1103 413749.9n 0.1103 413750.0n 0.3999 413999.9n 0.3999 414000.0n 0.5834 414249.9n 0.5834 414250.0n 0.5553 414499.9n 0.5553 414500.0n 0.8452 414749.9n 0.8452 414750.0n 0.2208 414999.9n 0.2208 415000.0n 0.4172 415249.9n 0.4172 415250.0n 0.4149 415499.9n 0.4149 415500.0n 0.3898 415749.9n 0.3898 415750.0n 0.4190 415999.9n 0.4190 416000.0n 0.3959 416249.9n 0.3959 416250.0n 0.3332 416499.9n 0.3332 416500.0n 0.3510 416749.9n 0.3510 416750.0n 0.3566 416999.9n 0.3566 417000.0n 0.5851 417249.9n 0.5851 417250.0n 0.1163 417499.9n 0.1163 417500.0n 0.1299 417749.9n 0.1299 417750.0n 0.6261 417999.9n 0.6261 418000.0n 0.6034 418249.9n 0.6034 418250.0n 0.6440 418499.9n 0.6440 418500.0n 0.2392 418749.9n 0.2392 418750.0n 0.4510 418999.9n 0.4510 419000.0n 0.5638 419249.9n 0.5638 419250.0n 0.2047 419499.9n 0.2047 419500.0n 0.6539 419749.9n 0.6539 419750.0n 0.4627 419999.9n 0.4627 420000.0n 0.5143 420249.9n 0.5143 420250.0n 0.6893 420499.9n 0.6893 420500.0n 0.3246 420749.9n 0.3246 420750.0n 0.2392 420999.9n 0.2392 421000.0n 0.5372 421249.9n 0.5372 421250.0n 0.4328 421499.9n 0.4328 421500.0n 0.1794 421749.9n 0.1794 421750.0n 0.6261 421999.9n 0.6261 422000.0n 0.8338 422249.9n 0.8338 422250.0n 0.5851 422499.9n 0.5851 422500.0n 0.4510 422749.9n 0.4510 422750.0n 0.6539 422999.9n 0.6539 423000.0n 0.2047 423249.9n 0.2047 423250.0n 0.4892 423499.9n 0.4892 423500.0n 0.8205 423749.9n 0.8205 423750.0n 0.5506 423999.9n 0.5506 424000.0n 0.5379 424249.9n 0.5379 424250.0n 0.5026 424499.9n 0.5026 424500.0n 0.1163 424749.9n 0.1163 424750.0n 0.1299 424999.9n 0.1299 425000.0n 0.4048 425249.9n 0.4048 425250.0n 0.4190 425499.9n 0.4190 425500.0n 0.5041 425749.9n 0.5041 425750.0n 0.2741 425999.9n 0.2741 426000.0n 0.6166 426249.9n 0.6166 426250.0n 0.3959 426499.9n 0.3959 426500.0n 0.4656 426749.9n 0.4656 426750.0n 0.8822 426999.9n 0.8822 427000.0n 0.4318 427249.9n 0.4318 427250.0n 0.4172 427499.9n 0.4172 427500.0n 0.4149 427749.9n 0.4149 427750.0n 0.8255 427999.9n 0.8255 428000.0n 0.5713 428249.9n 0.5713 428250.0n 0.3566 428499.9n 0.3566 428500.0n 0.6887 428749.9n 0.6887 428750.0n 0.5638 428999.9n 0.5638 429000.0n 0.6440 429249.9n 0.6440 429250.0n 0.3898 429499.9n 0.3898 429500.0n 0.3510 429749.9n 0.3510 429750.0n 0.1876 429999.9n 0.1876 430000.0n 0.3999 430249.9n 0.3999 430250.0n 0.4536 430499.9n 0.4536 430500.0n 0.8267 430749.9n 0.8267 430750.0n 0.6479 430999.9n 0.6479 431000.0n 0.7795 431249.9n 0.7795 431250.0n 0.5087 431499.9n 0.5087 431500.0n 0.1103 431749.9n 0.1103 431750.0n 0.3332 431999.9n 0.3332 432000.0n 0.5411 432249.9n 0.5411 432250.0n 0.3406 432499.9n 0.3406 432500.0n 0.5166 432749.9n 0.5166 432750.0n 0.5553 432999.9n 0.5553 433000.0n 0.5050 433249.9n 0.5050 433250.0n 0.5834 433499.9n 0.5834 433500.0n 0.2208 433749.9n 0.2208 433750.0n 0.6617 433999.9n 0.6617 434000.0n 0.4627 434249.9n 0.4627 434250.0n 0.6034 434499.9n 0.6034 434500.0n 0.8452 434749.9n 0.8452 434750.0n 0.9375 434999.9n 0.9375 435000.0n 0.5143 435249.9n 0.5143 435250.0n 0.6893 435499.9n 0.6893 435500.0n 0.3332 435749.9n 0.3332 435750.0n 0.1794 435999.9n 0.1794 436000.0n 0.4190 436249.9n 0.4190 436250.0n 0.5506 436499.9n 0.5506 436500.0n 0.5050 436749.9n 0.5050 436750.0n 0.5372 436999.9n 0.5372 437000.0n 0.2392 437249.9n 0.2392 437250.0n 0.5638 437499.9n 0.5638 437500.0n 0.5166 437749.9n 0.5166 437750.0n 0.8338 437999.9n 0.8338 438000.0n 0.2208 438249.9n 0.2208 438250.0n 0.5087 438499.9n 0.5087 438500.0n 0.5851 438749.9n 0.5851 438750.0n 0.8267 438999.9n 0.8267 439000.0n 0.2047 439249.9n 0.2047 439250.0n 0.4172 439499.9n 0.4172 439500.0n 0.5411 439749.9n 0.5411 439750.0n 0.5041 439999.9n 0.5041 440000.0n 0.3898 440249.9n 0.3898 440250.0n 0.3999 440499.9n 0.3999 440500.0n 0.5713 440749.9n 0.5713 440750.0n 0.6034 440999.9n 0.6034 441000.0n 0.4627 441249.9n 0.4627 441250.0n 0.8822 441499.9n 0.8822 441500.0n 0.3406 441749.9n 0.3406 441750.0n 0.3959 441999.9n 0.3959 442000.0n 0.6887 442249.9n 0.6887 442250.0n 0.3566 442499.9n 0.3566 442500.0n 0.6166 442749.9n 0.6166 442750.0n 0.5379 442999.9n 0.5379 443000.0n 0.4510 443249.9n 0.4510 443250.0n 0.3510 443499.9n 0.3510 443500.0n 0.5026 443749.9n 0.5026 443750.0n 0.1163 443999.9n 0.1163 444000.0n 0.4149 444249.9n 0.4149 444250.0n 0.4536 444499.9n 0.4536 444500.0n 0.6261 444749.9n 0.6261 444750.0n 0.6539 444999.9n 0.6539 445000.0n 0.8255 445249.9n 0.8255 445250.0n 0.7795 445499.9n 0.7795 445500.0n 0.8452 445749.9n 0.8452 445750.0n 0.6479 445999.9n 0.6479 446000.0n 0.5553 446249.9n 0.5553 446250.0n 0.1299 446499.9n 0.1299 446500.0n 0.1876 446749.9n 0.1876 446750.0n 0.4656 446999.9n 0.4656 447000.0n 0.8205 447249.9n 0.8205 447250.0n 0.6617 447499.9n 0.6617 447500.0n 0.9375 447749.9n 0.9375 447750.0n 0.4048 447999.9n 0.4048 448000.0n 0.3246 448249.9n 0.3246 448250.0n 0.4328 448499.9n 0.4328 448500.0n 0.4318 448749.9n 0.4318 448750.0n 0.6440 448999.9n 0.6440 449000.0n 0.4892 449249.9n 0.4892 449250.0n 0.5834 449499.9n 0.5834 449500.0n 0.2741 449749.9n 0.2741 449750.0n 0.1103 449999.9n 0.1103 450000.0n 0.2317 450249.9n 0.2317 450250.0n 0.7174 450499.9n 0.7174 450500.0n 0.2497 450749.9n 0.2497 450750.0n 0.4504 450999.9n 0.4504 451000.0n 0.4074 451249.9n 0.4074 451250.0n 0.9178 451499.9n 0.9178 451500.0n 0.5091 451749.9n 0.5091 451750.0n 0.8490 451999.9n 0.8490 452000.0n 0.4975 452249.9n 0.4975 452250.0n 0.5993 452499.9n 0.5993 452500.0n 0.2573 452749.9n 0.2573 452750.0n 0.5292 452999.9n 0.5292 453000.0n 0.3936 453249.9n 0.3936 453250.0n 0.5132 453499.9n 0.5132 453500.0n 0.1328 453749.9n 0.1328 453750.0n 0.0889 453999.9n 0.0889 454000.0n 0.8345 454249.9n 0.8345 454250.0n 0.6185 454499.9n 0.6185 454500.0n 0.3152 454749.9n 0.3152 454750.0n 0.6703 454999.9n 0.6703 455000.0n 0.4395 455249.9n 0.4395 455250.0n 0.5808 455499.9n 0.5808 455500.0n 0.6072 455749.9n 0.6072 455750.0n 0.3877 455999.9n 0.3877 456000.0n 0.3763 456249.9n 0.3763 456250.0n 0.7926 456499.9n 0.7926 456500.0n 0.4522 456749.9n 0.4522 456750.0n 0.5871 456999.9n 0.5871 457000.0n 0.3170 457249.9n 0.3170 457250.0n 0.8063 457499.9n 0.8063 457500.0n 0.4756 457749.9n 0.4756 457750.0n 0.5488 457999.9n 0.5488 458000.0n 0.9067 458249.9n 0.9067 458250.0n 0.3740 458499.9n 0.3740 458500.0n 0.5583 458749.9n 0.5583 458750.0n 0.5313 458999.9n 0.5313 459000.0n 0.7600 459249.9n 0.7600 459250.0n 0.8109 459499.9n 0.8109 459500.0n 0.5106 459749.9n 0.5106 459750.0n 0.6020 459999.9n 0.6020 460000.0n 0.3752 460249.9n 0.3752 460250.0n 0.8829 460499.9n 0.8829 460500.0n 0.7910 460749.9n 0.7910 460750.0n 0.5997 460999.9n 0.5997 461000.0n 0.2070 461249.9n 0.2070 461250.0n 0.1355 461499.9n 0.1355 461500.0n 0.4797 461749.9n 0.4797 461750.0n 0.1139 461999.9n 0.1139 462000.0n 0.5798 462249.9n 0.5798 462250.0n 0.4102 462499.9n 0.4102 462500.0n 0.6841 462749.9n 0.6841 462750.0n 0.1303 462999.9n 0.1303 463000.0n 0.4336 463249.9n 0.4336 463250.0n 0.6305 463499.9n 0.6305 463500.0n 0.5127 463749.9n 0.5127 463750.0n 0.4594 463999.9n 0.4594 464000.0n 0.4118 464249.9n 0.4118 464250.0n 0.8255 464499.9n 0.8255 464500.0n 0.3738 464749.9n 0.3738 464750.0n 0.4804 464999.9n 0.4804 465000.0n 0.5332 465249.9n 0.5332 465250.0n 0.5040 465499.9n 0.5040 465500.0n 0.6200 465749.9n 0.6200 465750.0n 0.6545 465999.9n 0.6545 466000.0n 0.0743 466249.9n 0.0743 466250.0n 0.3424 466499.9n 0.3424 466500.0n 0.6253 466749.9n 0.6253 466750.0n 0.2254 466999.9n 0.2254 467000.0n 0.6287 467249.9n 0.6287 467250.0n 0.6706 467499.9n 0.6706 467500.0n 0.5265 467749.9n 0.5265 467750.0n 0.5756 467999.9n 0.5756 468000.0n 0.4118 468249.9n 0.4118 468250.0n 0.8045 468499.9n 0.8045 468500.0n 0.6337 468749.9n 0.6337 468750.0n 0.2245 468999.9n 0.2245 469000.0n 0.3521 469249.9n 0.3521 469250.0n 0.5125 469499.9n 0.5125 469500.0n 0.7980 469749.9n 0.7980 469750.0n 0.0850 469999.9n 0.0850 470000.0n 0.4461 470249.9n 0.4461 470250.0n 0.4554 470499.9n 0.4554 470500.0n 0.5374 470749.9n 0.5374 470750.0n 0.4740 470999.9n 0.4740 471000.0n 0.3262 471249.9n 0.3262 471250.0n 0.4435 471499.9n 0.4435 471500.0n 0.4606 471749.9n 0.4606 471750.0n 0.5621 471999.9n 0.5621 472000.0n 0.3457 472249.9n 0.3457 472250.0n 0.6173 472499.9n 0.6173 472500.0n 0.8055 472749.9n 0.8055 472750.0n 0.5869 472999.9n 0.5869 473000.0n 0.2263 473249.9n 0.2263 473250.0n 0.5673 473499.9n 0.5673 473500.0n 0.4612 473749.9n 0.4612 473750.0n 0.1836 473999.9n 0.1836 474000.0n 0.6245 474249.9n 0.6245 474250.0n 0.3573 474499.9n 0.3573 474500.0n 0.7722 474749.9n 0.7722 474750.0n 0.4841 474999.9n 0.4841 475000.0n 0.5250 475249.9n 0.5250 475250.0n 0.5580 475499.9n 0.5580 475500.0n 0.4382 475749.9n 0.4382 475750.0n 0.5812 475999.9n 0.5812 476000.0n 0.7486 476249.9n 0.7486 476250.0n 0.5182 476499.9n 0.5182 476500.0n 0.5815 476749.9n 0.5815 476750.0n 0.7752 476999.9n 0.7752 477000.0n 0.1140 477249.9n 0.1140 477250.0n 0.4429 477499.9n 0.4429 477500.0n 0.8015 477749.9n 0.8015 477750.0n 0.6097 477999.9n 0.6097 478000.0n 0.7543 478249.9n 0.7543 478250.0n 0.4183 478499.9n 0.4183 478500.0n 0.4006 478749.9n 0.4006 478750.0n 0.4913 478999.9n 0.4913 479000.0n 0.5157 479249.9n 0.5157 479250.0n 0.5255 479499.9n 0.5255 479500.0n 0.4913 479749.9n 0.4913 479750.0n 0.2023)
Vx2p a_xp2 0 PWL(0.0n 0.5158 249.9n 0.5158 250.0n 0.2461 499.9n 0.2461 500.0n 0.4158 749.9n 0.4158 750.0n 0.5043 999.9n 0.5043 1000.0n 0.2867 1249.9n 0.2867 1250.0n 0.5066 1499.9n 0.5066 1500.0n 0.4694 1749.9n 0.4694 1750.0n 0.6371 1999.9n 0.6371 2000.0n 0.5340 2249.9n 0.5340 2250.0n 0.1021 2499.9n 0.1021 2500.0n 0.2022 2749.9n 0.2022 2750.0n 0.2472 2999.9n 0.2472 3000.0n 0.6056 3249.9n 0.6056 3250.0n 0.5341 3499.9n 0.5341 3500.0n 0.5271 3749.9n 0.5271 3750.0n 0.5884 3999.9n 0.5884 4000.0n 0.1328 4249.9n 0.1328 4250.0n 0.2114 4499.9n 0.2114 4500.0n 0.4622 4749.9n 0.4622 4750.0n 0.5111 4999.9n 0.5111 5000.0n 0.8503 5249.9n 0.8503 5250.0n 0.1330 5499.9n 0.1330 5500.0n 0.1936 5749.9n 0.1936 5750.0n 0.3040 5999.9n 0.3040 6000.0n 0.4535 6249.9n 0.4535 6250.0n 0.1421 6499.9n 0.1421 6500.0n 0.6455 6749.9n 0.6455 6750.0n 0.1990 6999.9n 0.1990 7000.0n 0.2156 7249.9n 0.2156 7250.0n 0.4143 7499.9n 0.4143 7500.0n 0.3727 7749.9n 0.3727 7750.0n 0.8039 7999.9n 0.8039 8000.0n 0.1712 8249.9n 0.1712 8250.0n 0.5723 8499.9n 0.5723 8500.0n 0.5210 8749.9n 0.5210 8750.0n 0.4529 8999.9n 0.4529 9000.0n 0.3402 9249.9n 0.3402 9250.0n 0.4856 9499.9n 0.4856 9500.0n 0.5825 9749.9n 0.5825 9750.0n 0.6209 9999.9n 0.6209 10000.0n 0.5017 10249.9n 0.5017 10250.0n 0.4130 10499.9n 0.4130 10500.0n 0.4495 10749.9n 0.4495 10750.0n 0.3661 10999.9n 0.3661 11000.0n 0.5628 11249.9n 0.5628 11250.0n 0.2449 11499.9n 0.2449 11500.0n 0.5067 11749.9n 0.5067 11750.0n 0.4408 11999.9n 0.4408 12000.0n 0.6086 12249.9n 0.6086 12250.0n 0.6100 12499.9n 0.6100 12500.0n 0.6041 12749.9n 0.6041 12750.0n 0.5478 12999.9n 0.5478 13000.0n 0.2439 13249.9n 0.2439 13250.0n 0.5343 13499.9n 0.5343 13500.0n 0.7682 13749.9n 0.7682 13750.0n 0.8228 13999.9n 0.8228 14000.0n 0.8639 14249.9n 0.8639 14250.0n 0.6052 14499.9n 0.6052 14500.0n 0.4825 14749.9n 0.4825 14750.0n 0.1858 14999.9n 0.1858 15000.0n 0.1712 15249.9n 0.1712 15250.0n 0.5723 15499.9n 0.5723 15500.0n 0.2867 15749.9n 0.2867 15750.0n 0.4158 15999.9n 0.4158 16000.0n 0.2114 16249.9n 0.2114 16250.0n 0.4130 16499.9n 0.4130 16500.0n 0.3727 16749.9n 0.3727 16750.0n 0.3040 16999.9n 0.3040 17000.0n 0.5271 17249.9n 0.5271 17250.0n 0.4856 17499.9n 0.4856 17500.0n 0.4408 17749.9n 0.4408 17750.0n 0.8503 17999.9n 0.8503 18000.0n 0.2156 18249.9n 0.2156 18250.0n 0.4495 18499.9n 0.4495 18500.0n 0.6056 18749.9n 0.6056 18750.0n 0.2022 18999.9n 0.2022 19000.0n 0.3402 19249.9n 0.3402 19250.0n 0.8228 19499.9n 0.8228 19500.0n 0.5158 19749.9n 0.5158 19750.0n 0.2472 19999.9n 0.2472 20000.0n 0.6086 20249.9n 0.6086 20250.0n 0.2439 20499.9n 0.2439 20500.0n 0.4529 20749.9n 0.4529 20750.0n 0.6052 20999.9n 0.6052 21000.0n 0.5628 21249.9n 0.5628 21250.0n 0.4825 21499.9n 0.4825 21500.0n 0.5043 21749.9n 0.5043 21750.0n 0.1990 21999.9n 0.1990 22000.0n 0.4535 22249.9n 0.4535 22250.0n 0.4622 22499.9n 0.4622 22500.0n 0.1328 22749.9n 0.1328 22750.0n 0.8639 22999.9n 0.8639 23000.0n 0.5343 23249.9n 0.5343 23250.0n 0.6455 23499.9n 0.6455 23500.0n 0.1021 23749.9n 0.1021 23750.0n 0.5067 23999.9n 0.5067 24000.0n 0.6041 24249.9n 0.6041 24250.0n 0.6209 24499.9n 0.6209 24500.0n 0.5111 24749.9n 0.5111 24750.0n 0.5340 24999.9n 0.5340 25000.0n 0.6371 25249.9n 0.6371 25250.0n 0.5884 25499.9n 0.5884 25500.0n 0.5825 25749.9n 0.5825 25750.0n 0.7682 25999.9n 0.7682 26000.0n 0.3661 26249.9n 0.3661 26250.0n 0.1421 26499.9n 0.1421 26500.0n 0.1330 26749.9n 0.1330 26750.0n 0.5017 26999.9n 0.5017 27000.0n 0.5066 27249.9n 0.5066 27250.0n 0.5478 27499.9n 0.5478 27500.0n 0.4143 27749.9n 0.4143 27750.0n 0.6100 27999.9n 0.6100 28000.0n 0.4694 28249.9n 0.4694 28250.0n 0.2449 28499.9n 0.2449 28500.0n 0.5341 28749.9n 0.5341 28750.0n 0.2461 28999.9n 0.2461 29000.0n 0.1936 29249.9n 0.1936 29250.0n 0.1858 29499.9n 0.1858 29500.0n 0.8039 29749.9n 0.8039 29750.0n 0.5210 29999.9n 0.5210 30000.0n 0.5210 30249.9n 0.5210 30250.0n 0.1021 30499.9n 0.1021 30500.0n 0.1421 30749.9n 0.1421 30750.0n 0.4495 30999.9n 0.4495 31000.0n 0.5723 31249.9n 0.5723 31250.0n 0.5067 31499.9n 0.5067 31500.0n 0.1936 31749.9n 0.1936 31750.0n 0.8503 31999.9n 0.8503 32000.0n 0.2472 32249.9n 0.2472 32250.0n 0.2022 32499.9n 0.2022 32500.0n 0.2867 32749.9n 0.2867 32750.0n 0.4622 32999.9n 0.4622 33000.0n 0.3402 33249.9n 0.3402 33250.0n 0.4856 33499.9n 0.4856 33500.0n 0.2449 33749.9n 0.2449 33750.0n 0.2461 33999.9n 0.2461 34000.0n 0.8639 34249.9n 0.8639 34250.0n 0.6209 34499.9n 0.6209 34500.0n 0.4408 34749.9n 0.4408 34750.0n 0.8039 34999.9n 0.8039 35000.0n 0.4825 35249.9n 0.4825 35250.0n 0.2156 35499.9n 0.2156 35500.0n 0.6100 35749.9n 0.6100 35750.0n 0.5017 35999.9n 0.5017 36000.0n 0.4143 36249.9n 0.4143 36250.0n 0.5111 36499.9n 0.5111 36500.0n 0.6371 36749.9n 0.6371 36750.0n 0.8228 36999.9n 0.8228 37000.0n 0.6056 37249.9n 0.6056 37250.0n 0.5343 37499.9n 0.5343 37500.0n 0.1712 37749.9n 0.1712 37750.0n 0.5340 37999.9n 0.5340 38000.0n 0.6041 38249.9n 0.6041 38250.0n 0.1858 38499.9n 0.1858 38500.0n 0.6052 38749.9n 0.6052 38750.0n 0.1328 38999.9n 0.1328 39000.0n 0.1990 39249.9n 0.1990 39250.0n 0.3040 39499.9n 0.3040 39500.0n 0.5271 39749.9n 0.5271 39750.0n 0.4130 39999.9n 0.4130 40000.0n 0.4529 40249.9n 0.4529 40250.0n 0.7682 40499.9n 0.7682 40500.0n 0.3727 40749.9n 0.3727 40750.0n 0.5341 40999.9n 0.5341 41000.0n 0.4694 41249.9n 0.4694 41250.0n 0.1330 41499.9n 0.1330 41500.0n 0.6455 41749.9n 0.6455 41750.0n 0.5043 41999.9n 0.5043 42000.0n 0.5158 42249.9n 0.5158 42250.0n 0.3661 42499.9n 0.3661 42500.0n 0.5884 42749.9n 0.5884 42750.0n 0.5478 42999.9n 0.5478 43000.0n 0.5825 43249.9n 0.5825 43250.0n 0.5066 43499.9n 0.5066 43500.0n 0.2439 43749.9n 0.2439 43750.0n 0.4158 43999.9n 0.4158 44000.0n 0.2114 44249.9n 0.2114 44250.0n 0.5628 44499.9n 0.5628 44500.0n 0.6086 44749.9n 0.6086 44750.0n 0.4535 44999.9n 0.4535 45000.0n 0.4529 45249.9n 0.4529 45250.0n 0.5111 45499.9n 0.5111 45500.0n 0.4408 45749.9n 0.4408 45750.0n 0.1021 45999.9n 0.1021 46000.0n 0.5723 46249.9n 0.5723 46250.0n 0.5271 46499.9n 0.5271 46500.0n 0.5158 46749.9n 0.5158 46750.0n 0.6052 46999.9n 0.6052 47000.0n 0.4143 47249.9n 0.4143 47250.0n 0.5884 47499.9n 0.5884 47500.0n 0.2022 47749.9n 0.2022 47750.0n 0.5341 47999.9n 0.5341 48000.0n 0.6041 48249.9n 0.6041 48250.0n 0.8503 48499.9n 0.8503 48500.0n 0.3040 48749.9n 0.3040 48750.0n 0.5043 48999.9n 0.5043 49000.0n 0.5067 49249.9n 0.5067 49250.0n 0.4694 49499.9n 0.4694 49500.0n 0.8039 49749.9n 0.8039 49750.0n 0.7682 49999.9n 0.7682 50000.0n 0.5210 50249.9n 0.5210 50250.0n 0.1328 50499.9n 0.1328 50500.0n 0.2449 50749.9n 0.2449 50750.0n 0.6056 50999.9n 0.6056 51000.0n 0.2156 51249.9n 0.2156 51250.0n 0.6371 51499.9n 0.6371 51500.0n 0.2114 51749.9n 0.2114 51750.0n 0.1936 51999.9n 0.1936 52000.0n 0.4158 52249.9n 0.4158 52250.0n 0.6086 52499.9n 0.6086 52500.0n 0.4535 52749.9n 0.4535 52750.0n 0.8639 52999.9n 0.8639 53000.0n 0.5066 53249.9n 0.5066 53250.0n 0.4825 53499.9n 0.4825 53500.0n 0.5340 53749.9n 0.5340 53750.0n 0.1712 53999.9n 0.1712 54000.0n 0.4622 54249.9n 0.4622 54250.0n 0.3661 54499.9n 0.3661 54500.0n 0.5478 54749.9n 0.5478 54750.0n 0.4495 54999.9n 0.4495 55000.0n 0.8228 55249.9n 0.8228 55250.0n 0.6100 55499.9n 0.6100 55500.0n 0.2472 55749.9n 0.2472 55750.0n 0.6455 55999.9n 0.6455 56000.0n 0.3402 56249.9n 0.3402 56250.0n 0.6209 56499.9n 0.6209 56500.0n 0.1858 56749.9n 0.1858 56750.0n 0.5825 56999.9n 0.5825 57000.0n 0.2461 57249.9n 0.2461 57250.0n 0.2867 57499.9n 0.2867 57500.0n 0.5017 57749.9n 0.5017 57750.0n 0.1990 57999.9n 0.1990 58000.0n 0.4856 58249.9n 0.4856 58250.0n 0.3727 58499.9n 0.3727 58500.0n 0.1421 58749.9n 0.1421 58750.0n 0.5343 58999.9n 0.5343 59000.0n 0.4130 59249.9n 0.4130 59250.0n 0.5628 59499.9n 0.5628 59500.0n 0.2439 59749.9n 0.2439 59750.0n 0.1330 59999.9n 0.1330 60000.0n 0.5341 60249.9n 0.5341 60250.0n 0.4825 60499.9n 0.4825 60500.0n 0.5343 60749.9n 0.5343 60750.0n 0.1421 60999.9n 0.1421 61000.0n 0.2022 61249.9n 0.2022 61250.0n 0.5067 61499.9n 0.5067 61500.0n 0.6209 61749.9n 0.6209 61750.0n 0.4495 61999.9n 0.4495 62000.0n 0.1328 62249.9n 0.1328 62250.0n 0.4143 62499.9n 0.4143 62500.0n 0.5066 62749.9n 0.5066 62750.0n 0.5723 62999.9n 0.5723 63000.0n 0.2156 63249.9n 0.2156 63250.0n 0.4622 63499.9n 0.4622 63500.0n 0.6100 63749.9n 0.6100 63750.0n 0.5043 63999.9n 0.5043 64000.0n 0.3727 64249.9n 0.3727 64250.0n 0.5478 64499.9n 0.5478 64500.0n 0.7682 64749.9n 0.7682 64750.0n 0.4535 64999.9n 0.4535 65000.0n 0.8639 65249.9n 0.8639 65250.0n 0.4856 65499.9n 0.4856 65500.0n 0.5017 65749.9n 0.5017 65750.0n 0.2114 65999.9n 0.2114 66000.0n 0.5340 66249.9n 0.5340 66250.0n 0.2461 66499.9n 0.2461 66500.0n 0.6086 66749.9n 0.6086 66750.0n 0.4694 66999.9n 0.4694 67000.0n 0.1990 67249.9n 0.1990 67250.0n 0.4130 67499.9n 0.4130 67500.0n 0.1936 67749.9n 0.1936 67750.0n 0.3040 67999.9n 0.3040 68000.0n 0.6041 68249.9n 0.6041 68250.0n 0.6056 68499.9n 0.6056 68500.0n 0.8503 68749.9n 0.8503 68750.0n 0.1858 68999.9n 0.1858 69000.0n 0.8039 69249.9n 0.8039 69250.0n 0.3661 69499.9n 0.3661 69500.0n 0.5884 69749.9n 0.5884 69750.0n 0.2867 69999.9n 0.2867 70000.0n 0.4158 70249.9n 0.4158 70250.0n 0.5271 70499.9n 0.5271 70500.0n 0.6371 70749.9n 0.6371 70750.0n 0.5628 70999.9n 0.5628 71000.0n 0.5825 71249.9n 0.5825 71250.0n 0.5111 71499.9n 0.5111 71500.0n 0.3402 71749.9n 0.3402 71750.0n 0.5158 71999.9n 0.5158 72000.0n 0.1330 72249.9n 0.1330 72250.0n 0.2472 72499.9n 0.2472 72500.0n 0.1712 72749.9n 0.1712 72750.0n 0.2439 72999.9n 0.2439 73000.0n 0.8228 73249.9n 0.8228 73250.0n 0.4408 73499.9n 0.4408 73500.0n 0.4529 73749.9n 0.4529 73750.0n 0.6052 73999.9n 0.6052 74000.0n 0.1021 74249.9n 0.1021 74250.0n 0.2449 74499.9n 0.2449 74500.0n 0.6455 74749.9n 0.6455 74750.0n 0.5210 74999.9n 0.5210 75000.0n 0.6056 75249.9n 0.6056 75250.0n 0.6086 75499.9n 0.6086 75500.0n 0.2156 75749.9n 0.2156 75750.0n 0.5111 75999.9n 0.5111 76000.0n 0.2114 76249.9n 0.2114 76250.0n 0.4825 76499.9n 0.4825 76500.0n 0.2022 76749.9n 0.2022 76750.0n 0.5271 76999.9n 0.5271 77000.0n 0.5478 77249.9n 0.5478 77250.0n 0.5158 77499.9n 0.5158 77500.0n 0.4143 77749.9n 0.4143 77750.0n 0.1712 77999.9n 0.1712 78000.0n 0.5017 78249.9n 0.5017 78250.0n 0.2439 78499.9n 0.2439 78500.0n 0.2449 78749.9n 0.2449 78750.0n 0.5340 78999.9n 0.5340 79000.0n 0.6209 79249.9n 0.6209 79250.0n 0.4495 79499.9n 0.4495 79500.0n 0.6100 79749.9n 0.6100 79750.0n 0.8228 79999.9n 0.8228 80000.0n 0.6052 80249.9n 0.6052 80250.0n 0.1990 80499.9n 0.1990 80500.0n 0.8503 80749.9n 0.8503 80750.0n 0.5043 80999.9n 0.5043 81000.0n 0.7682 81249.9n 0.7682 81250.0n 0.5067 81499.9n 0.5067 81500.0n 0.8639 81749.9n 0.8639 81750.0n 0.1421 81999.9n 0.1421 82000.0n 0.4856 82249.9n 0.4856 82250.0n 0.5341 82499.9n 0.5341 82500.0n 0.5066 82749.9n 0.5066 82750.0n 0.4529 82999.9n 0.4529 83000.0n 0.4622 83249.9n 0.4622 83250.0n 0.3727 83499.9n 0.3727 83500.0n 0.3040 83749.9n 0.3040 83750.0n 0.4408 83999.9n 0.4408 84000.0n 0.6371 84249.9n 0.6371 84250.0n 0.5825 84499.9n 0.5825 84500.0n 0.1021 84749.9n 0.1021 84750.0n 0.5723 84999.9n 0.5723 85000.0n 0.2472 85249.9n 0.2472 85250.0n 0.1330 85499.9n 0.1330 85500.0n 0.6455 85749.9n 0.6455 85750.0n 0.2867 85999.9n 0.2867 86000.0n 0.4694 86249.9n 0.4694 86250.0n 0.5628 86499.9n 0.5628 86500.0n 0.4535 86749.9n 0.4535 86750.0n 0.8039 86999.9n 0.8039 87000.0n 0.3402 87249.9n 0.3402 87250.0n 0.2461 87499.9n 0.2461 87500.0n 0.5343 87749.9n 0.5343 87750.0n 0.1858 87999.9n 0.1858 88000.0n 0.1328 88249.9n 0.1328 88250.0n 0.1936 88499.9n 0.1936 88500.0n 0.3661 88749.9n 0.3661 88750.0n 0.4158 88999.9n 0.4158 89000.0n 0.5210 89249.9n 0.5210 89250.0n 0.5884 89499.9n 0.5884 89500.0n 0.6041 89749.9n 0.6041 89750.0n 0.4130 89999.9n 0.4130 90000.0n 0.8503 90249.9n 0.8503 90250.0n 0.5271 90499.9n 0.5271 90500.0n 0.7682 90749.9n 0.7682 90750.0n 0.8039 90999.9n 0.8039 91000.0n 0.1021 91249.9n 0.1021 91250.0n 0.1990 91499.9n 0.1990 91500.0n 0.4529 91749.9n 0.4529 91750.0n 0.5341 91999.9n 0.5341 92000.0n 0.2461 92249.9n 0.2461 92250.0n 0.4825 92499.9n 0.4825 92500.0n 0.2114 92749.9n 0.2114 92750.0n 0.5043 92999.9n 0.5043 93000.0n 0.5017 93249.9n 0.5017 93250.0n 0.1328 93499.9n 0.1328 93500.0n 0.5066 93749.9n 0.5066 93750.0n 0.2439 93999.9n 0.2439 94000.0n 0.6371 94249.9n 0.6371 94250.0n 0.4130 94499.9n 0.4130 94500.0n 0.5111 94749.9n 0.5111 94750.0n 0.1936 94999.9n 0.1936 95000.0n 0.3727 95249.9n 0.3727 95250.0n 0.3040 95499.9n 0.3040 95500.0n 0.6455 95749.9n 0.6455 95750.0n 0.4622 95999.9n 0.4622 96000.0n 0.5723 96249.9n 0.5723 96250.0n 0.2472 96499.9n 0.2472 96500.0n 0.5628 96749.9n 0.5628 96750.0n 0.1330 96999.9n 0.1330 97000.0n 0.6052 97249.9n 0.6052 97250.0n 0.8639 97499.9n 0.8639 97500.0n 0.5210 97749.9n 0.5210 97750.0n 0.6086 97999.9n 0.6086 98000.0n 0.5478 98249.9n 0.5478 98250.0n 0.2449 98499.9n 0.2449 98500.0n 0.5067 98749.9n 0.5067 98750.0n 0.5340 98999.9n 0.5340 99000.0n 0.3402 99249.9n 0.3402 99250.0n 0.2867 99499.9n 0.2867 99500.0n 0.5343 99749.9n 0.5343 99750.0n 0.6056 99999.9n 0.6056 100000.0n 0.4694 100249.9n 0.4694 100250.0n 0.1712 100499.9n 0.1712 100500.0n 0.4495 100749.9n 0.4495 100750.0n 0.2156 100999.9n 0.2156 101000.0n 0.5825 101249.9n 0.5825 101250.0n 0.4408 101499.9n 0.4408 101500.0n 0.2022 101749.9n 0.2022 101750.0n 0.5158 101999.9n 0.5158 102000.0n 0.5884 102249.9n 0.5884 102250.0n 0.3661 102499.9n 0.3661 102500.0n 0.1421 102749.9n 0.1421 102750.0n 0.4535 102999.9n 0.4535 103000.0n 0.4158 103249.9n 0.4158 103250.0n 0.6209 103499.9n 0.6209 103500.0n 0.6041 103749.9n 0.6041 103750.0n 0.4143 103999.9n 0.4143 104000.0n 0.4856 104249.9n 0.4856 104250.0n 0.1858 104499.9n 0.1858 104500.0n 0.6100 104749.9n 0.6100 104750.0n 0.8228 104999.9n 0.8228 105000.0n 0.5066 105249.9n 0.5066 105250.0n 0.2114 105499.9n 0.2114 105500.0n 0.4622 105749.9n 0.4622 105750.0n 0.5158 105999.9n 0.5158 106000.0n 0.1021 106249.9n 0.1021 106250.0n 0.2022 106499.9n 0.2022 106500.0n 0.6052 106749.9n 0.6052 106750.0n 0.1936 106999.9n 0.1936 107000.0n 0.4694 107249.9n 0.4694 107250.0n 0.5043 107499.9n 0.5043 107500.0n 0.5017 107749.9n 0.5017 107750.0n 0.4529 107999.9n 0.4529 108000.0n 0.3727 108249.9n 0.3727 108250.0n 0.3040 108499.9n 0.3040 108500.0n 0.7682 108749.9n 0.7682 108750.0n 0.1330 108999.9n 0.1330 109000.0n 0.4130 109249.9n 0.4130 109250.0n 0.4495 109499.9n 0.4495 109500.0n 0.5343 109749.9n 0.5343 109750.0n 0.5067 109999.9n 0.5067 110000.0n 0.5478 110249.9n 0.5478 110250.0n 0.4408 110499.9n 0.4408 110500.0n 0.5271 110749.9n 0.5271 110750.0n 0.6056 110999.9n 0.6056 111000.0n 0.4143 111249.9n 0.4143 111250.0n 0.2461 111499.9n 0.2461 111500.0n 0.1421 111749.9n 0.1421 111750.0n 0.3402 111999.9n 0.3402 112000.0n 0.1858 112249.9n 0.1858 112250.0n 0.4535 112499.9n 0.4535 112500.0n 0.2449 112749.9n 0.2449 112750.0n 0.4856 112999.9n 0.4856 113000.0n 0.1712 113249.9n 0.1712 113250.0n 0.2439 113499.9n 0.2439 113500.0n 0.6455 113749.9n 0.6455 113750.0n 0.5723 113999.9n 0.5723 114000.0n 0.6086 114249.9n 0.6086 114250.0n 0.5884 114499.9n 0.5884 114500.0n 0.5341 114749.9n 0.5341 114750.0n 0.5825 114999.9n 0.5825 115000.0n 0.6371 115249.9n 0.6371 115250.0n 0.5628 115499.9n 0.5628 115500.0n 0.2156 115749.9n 0.2156 115750.0n 0.8228 115999.9n 0.8228 116000.0n 0.3661 116249.9n 0.3661 116250.0n 0.5340 116499.9n 0.5340 116500.0n 0.1328 116749.9n 0.1328 116750.0n 0.2472 116999.9n 0.2472 117000.0n 0.6209 117249.9n 0.6209 117250.0n 0.6041 117499.9n 0.6041 117500.0n 0.5111 117749.9n 0.5111 117750.0n 0.4825 117999.9n 0.4825 118000.0n 0.1990 118249.9n 0.1990 118250.0n 0.5210 118499.9n 0.5210 118500.0n 0.8039 118749.9n 0.8039 118750.0n 0.4158 118999.9n 0.4158 119000.0n 0.2867 119249.9n 0.2867 119250.0n 0.6100 119499.9n 0.6100 119500.0n 0.8503 119749.9n 0.8503 119750.0n 0.8639 119999.9n 0.8639 120000.0n 0.4529 120249.9n 0.4529 120250.0n 0.1021 120499.9n 0.1021 120500.0n 0.1936 120749.9n 0.1936 120750.0n 0.5067 120999.9n 0.5067 121000.0n 0.1330 121249.9n 0.1330 121250.0n 0.6371 121499.9n 0.6371 121500.0n 0.3661 121749.9n 0.3661 121750.0n 0.1858 121999.9n 0.1858 122000.0n 0.5210 122249.9n 0.5210 122250.0n 0.4143 122499.9n 0.4143 122500.0n 0.5478 122749.9n 0.5478 122750.0n 0.6056 122999.9n 0.6056 123000.0n 0.2439 123249.9n 0.2439 123250.0n 0.5884 123499.9n 0.5884 123500.0n 0.5017 123749.9n 0.5017 123750.0n 0.5340 123999.9n 0.5340 124000.0n 0.5271 124249.9n 0.5271 124250.0n 0.5111 124499.9n 0.5111 124500.0n 0.5158 124749.9n 0.5158 124750.0n 0.6041 124999.9n 0.6041 125000.0n 0.5825 125249.9n 0.5825 125250.0n 0.8039 125499.9n 0.8039 125500.0n 0.6100 125749.9n 0.6100 125750.0n 0.2867 125999.9n 0.2867 126000.0n 0.4622 126249.9n 0.4622 126250.0n 0.2022 126499.9n 0.2022 126500.0n 0.4495 126749.9n 0.4495 126750.0n 0.7682 126999.9n 0.7682 127000.0n 0.6052 127249.9n 0.6052 127250.0n 0.5628 127499.9n 0.5628 127500.0n 0.4825 127749.9n 0.4825 127750.0n 0.5723 127999.9n 0.5723 128000.0n 0.8503 128249.9n 0.8503 128250.0n 0.3402 128499.9n 0.3402 128500.0n 0.4158 128749.9n 0.4158 128750.0n 0.1990 128999.9n 0.1990 129000.0n 0.2472 129249.9n 0.2472 129250.0n 0.5341 129499.9n 0.5341 129500.0n 0.8639 129749.9n 0.8639 129750.0n 0.2156 129999.9n 0.2156 130000.0n 0.1712 130249.9n 0.1712 130250.0n 0.6455 130499.9n 0.6455 130500.0n 0.5043 130749.9n 0.5043 130750.0n 0.4408 130999.9n 0.4408 131000.0n 0.2114 131249.9n 0.2114 131250.0n 0.5066 131499.9n 0.5066 131500.0n 0.4535 131749.9n 0.4535 131750.0n 0.6209 131999.9n 0.6209 132000.0n 0.4694 132249.9n 0.4694 132250.0n 0.4856 132499.9n 0.4856 132500.0n 0.2449 132749.9n 0.2449 132750.0n 0.3727 132999.9n 0.3727 133000.0n 0.6086 133249.9n 0.6086 133250.0n 0.3040 133499.9n 0.3040 133500.0n 0.5343 133749.9n 0.5343 133750.0n 0.8228 133999.9n 0.8228 134000.0n 0.2461 134249.9n 0.2461 134250.0n 0.4130 134499.9n 0.4130 134500.0n 0.1421 134749.9n 0.1421 134750.0n 0.1328 134999.9n 0.1328 135000.0n 0.2156 135249.9n 0.2156 135250.0n 0.5340 135499.9n 0.5340 135500.0n 0.1021 135749.9n 0.1021 135750.0n 0.5271 135999.9n 0.5271 136000.0n 0.4694 136249.9n 0.4694 136250.0n 0.5158 136499.9n 0.5158 136500.0n 0.5884 136749.9n 0.5884 136750.0n 0.5210 136999.9n 0.5210 137000.0n 0.4495 137249.9n 0.4495 137250.0n 0.5111 137499.9n 0.5111 137500.0n 0.1328 137749.9n 0.1328 137750.0n 0.4622 137999.9n 0.4622 138000.0n 0.2461 138249.9n 0.2461 138250.0n 0.2022 138499.9n 0.2022 138500.0n 0.5628 138749.9n 0.5628 138750.0n 0.6209 138999.9n 0.6209 139000.0n 0.5043 139249.9n 0.5043 139250.0n 0.5343 139499.9n 0.5343 139500.0n 0.3040 139749.9n 0.3040 139750.0n 0.4825 139999.9n 0.4825 140000.0n 0.2439 140249.9n 0.2439 140250.0n 0.1712 140499.9n 0.1712 140500.0n 0.4535 140749.9n 0.4535 140750.0n 0.6371 140999.9n 0.6371 141000.0n 0.4130 141249.9n 0.4130 141250.0n 0.4529 141499.9n 0.4529 141500.0n 0.5067 141749.9n 0.5067 141750.0n 0.6041 141999.9n 0.6041 142000.0n 0.6100 142249.9n 0.6100 142250.0n 0.3402 142499.9n 0.3402 142500.0n 0.4158 142749.9n 0.4158 142750.0n 0.3727 142999.9n 0.3727 143000.0n 0.1936 143249.9n 0.1936 143250.0n 0.1421 143499.9n 0.1421 143500.0n 0.5341 143749.9n 0.5341 143750.0n 0.8503 143999.9n 0.8503 144000.0n 0.4408 144249.9n 0.4408 144250.0n 0.5723 144499.9n 0.5723 144500.0n 0.6056 144749.9n 0.6056 144750.0n 0.5066 144999.9n 0.5066 145000.0n 0.8039 145249.9n 0.8039 145250.0n 0.2867 145499.9n 0.2867 145500.0n 0.6086 145749.9n 0.6086 145750.0n 0.2114 145999.9n 0.2114 146000.0n 0.7682 146249.9n 0.7682 146250.0n 0.8228 146499.9n 0.8228 146500.0n 0.2472 146749.9n 0.2472 146750.0n 0.6455 146999.9n 0.6455 147000.0n 0.5478 147249.9n 0.5478 147250.0n 0.3661 147499.9n 0.3661 147500.0n 0.8639 147749.9n 0.8639 147750.0n 0.4856 147999.9n 0.4856 148000.0n 0.1858 148249.9n 0.1858 148250.0n 0.1330 148499.9n 0.1330 148500.0n 0.2449 148749.9n 0.2449 148750.0n 0.6052 148999.9n 0.6052 149000.0n 0.5825 149249.9n 0.5825 149250.0n 0.4143 149499.9n 0.4143 149500.0n 0.1990 149749.9n 0.1990 149750.0n 0.5017 149999.9n 0.5017 150000.0n 0.4495 150249.9n 0.4495 150250.0n 0.5158 150499.9n 0.5158 150500.0n 0.1858 150749.9n 0.1858 150750.0n 0.8639 150999.9n 0.8639 151000.0n 0.8039 151249.9n 0.8039 151250.0n 0.4408 151499.9n 0.4408 151500.0n 0.1990 151749.9n 0.1990 151750.0n 0.6086 151999.9n 0.6086 152000.0n 0.4158 152249.9n 0.4158 152250.0n 0.1021 152499.9n 0.1021 152500.0n 0.2449 152749.9n 0.2449 152750.0n 0.2114 152999.9n 0.2114 153000.0n 0.1330 153249.9n 0.1330 153250.0n 0.3661 153499.9n 0.3661 153500.0n 0.5017 153749.9n 0.5017 153750.0n 0.5343 153999.9n 0.5343 154000.0n 0.6209 154249.9n 0.6209 154250.0n 0.5825 154499.9n 0.5825 154500.0n 0.4535 154749.9n 0.4535 154750.0n 0.3402 154999.9n 0.3402 155000.0n 0.5478 155249.9n 0.5478 155250.0n 0.6041 155499.9n 0.6041 155500.0n 0.8503 155749.9n 0.8503 155750.0n 0.4143 155999.9n 0.4143 156000.0n 0.5884 156249.9n 0.5884 156250.0n 0.5340 156499.9n 0.5340 156500.0n 0.4856 156749.9n 0.4856 156750.0n 0.5341 156999.9n 0.5341 157000.0n 0.5628 157249.9n 0.5628 157250.0n 0.2472 157499.9n 0.2472 157500.0n 0.8228 157749.9n 0.8228 157750.0n 0.3040 157999.9n 0.3040 158000.0n 0.4130 158249.9n 0.4130 158250.0n 0.2461 158499.9n 0.2461 158500.0n 0.4529 158749.9n 0.4529 158750.0n 0.4622 158999.9n 0.4622 159000.0n 0.5210 159249.9n 0.5210 159250.0n 0.5066 159499.9n 0.5066 159500.0n 0.6100 159749.9n 0.6100 159750.0n 0.3727 159999.9n 0.3727 160000.0n 0.7682 160249.9n 0.7682 160250.0n 0.6052 160499.9n 0.6052 160500.0n 0.1328 160749.9n 0.1328 160750.0n 0.5043 160999.9n 0.5043 161000.0n 0.5067 161249.9n 0.5067 161250.0n 0.5723 161499.9n 0.5723 161500.0n 0.6455 161749.9n 0.6455 161750.0n 0.2022 161999.9n 0.2022 162000.0n 0.5111 162249.9n 0.5111 162250.0n 0.2439 162499.9n 0.2439 162500.0n 0.6371 162749.9n 0.6371 162750.0n 0.1421 162999.9n 0.1421 163000.0n 0.1936 163249.9n 0.1936 163250.0n 0.6056 163499.9n 0.6056 163500.0n 0.2867 163749.9n 0.2867 163750.0n 0.5271 163999.9n 0.5271 164000.0n 0.4825 164249.9n 0.4825 164250.0n 0.2156 164499.9n 0.2156 164500.0n 0.4694 164749.9n 0.4694 164750.0n 0.1712 164999.9n 0.1712 165000.0n 0.5478 165249.9n 0.5478 165250.0n 0.1328 165499.9n 0.1328 165500.0n 0.8039 165749.9n 0.8039 165750.0n 0.6100 165999.9n 0.6100 166000.0n 0.4408 166249.9n 0.4408 166250.0n 0.2439 166499.9n 0.2439 166500.0n 0.7682 166749.9n 0.7682 166750.0n 0.2114 166999.9n 0.2114 167000.0n 0.5210 167249.9n 0.5210 167250.0n 0.6052 167499.9n 0.6052 167500.0n 0.6455 167749.9n 0.6455 167750.0n 0.5017 167999.9n 0.5017 168000.0n 0.5825 168249.9n 0.5825 168250.0n 0.4143 168499.9n 0.4143 168500.0n 0.4529 168749.9n 0.4529 168750.0n 0.1990 168999.9n 0.1990 169000.0n 0.4825 169249.9n 0.4825 169250.0n 0.2472 169499.9n 0.2472 169500.0n 0.6371 169749.9n 0.6371 169750.0n 0.3661 169999.9n 0.3661 170000.0n 0.5628 170249.9n 0.5628 170250.0n 0.4158 170499.9n 0.4158 170500.0n 0.5271 170749.9n 0.5271 170750.0n 0.8639 170999.9n 0.8639 171000.0n 0.2449 171249.9n 0.2449 171250.0n 0.4535 171499.9n 0.4535 171500.0n 0.5340 171749.9n 0.5340 171750.0n 0.4130 171999.9n 0.4130 172000.0n 0.1421 172249.9n 0.1421 172250.0n 0.2461 172499.9n 0.2461 172500.0n 0.4856 172749.9n 0.4856 172750.0n 0.3402 172999.9n 0.3402 173000.0n 0.5158 173249.9n 0.5158 173250.0n 0.1712 173499.9n 0.1712 173500.0n 0.6086 173749.9n 0.6086 173750.0n 0.1021 173999.9n 0.1021 174000.0n 0.8503 174249.9n 0.8503 174250.0n 0.2156 174499.9n 0.2156 174500.0n 0.6209 174749.9n 0.6209 174750.0n 0.5884 174999.9n 0.5884 175000.0n 0.4622 175249.9n 0.4622 175250.0n 0.5067 175499.9n 0.5067 175500.0n 0.5343 175749.9n 0.5343 175750.0n 0.6056 175999.9n 0.6056 176000.0n 0.3040 176249.9n 0.3040 176250.0n 0.2867 176499.9n 0.2867 176500.0n 0.1858 176749.9n 0.1858 176750.0n 0.2022 176999.9n 0.2022 177000.0n 0.3727 177249.9n 0.3727 177250.0n 0.5111 177499.9n 0.5111 177500.0n 0.6041 177749.9n 0.6041 177750.0n 0.5066 177999.9n 0.5066 178000.0n 0.5341 178249.9n 0.5341 178250.0n 0.4694 178499.9n 0.4694 178500.0n 0.1330 178749.9n 0.1330 178750.0n 0.1936 178999.9n 0.1936 179000.0n 0.5043 179249.9n 0.5043 179250.0n 0.4495 179499.9n 0.4495 179500.0n 0.8228 179749.9n 0.8228 179750.0n 0.5723 179999.9n 0.5723 180000.0n 0.5825 180249.9n 0.5825 180250.0n 0.6209 180499.9n 0.6209 180500.0n 0.6041 180749.9n 0.6041 180750.0n 0.5271 180999.9n 0.5271 181000.0n 0.2439 181249.9n 0.2439 181250.0n 0.4622 181499.9n 0.4622 181500.0n 0.5478 181749.9n 0.5478 181750.0n 0.1421 181999.9n 0.1421 182000.0n 0.8228 182249.9n 0.8228 182250.0n 0.2022 182499.9n 0.2022 182500.0n 0.4130 182749.9n 0.4130 182750.0n 0.3402 182999.9n 0.3402 183000.0n 0.1712 183249.9n 0.1712 183250.0n 0.1021 183499.9n 0.1021 183500.0n 0.5723 183749.9n 0.5723 183750.0n 0.8639 183999.9n 0.8639 184000.0n 0.3661 184249.9n 0.3661 184250.0n 0.2114 184499.9n 0.2114 184500.0n 0.6100 184749.9n 0.6100 184750.0n 0.4856 184999.9n 0.4856 185000.0n 0.6052 185249.9n 0.6052 185250.0n 0.6056 185499.9n 0.6056 185500.0n 0.1936 185749.9n 0.1936 185750.0n 0.1330 185999.9n 0.1330 186000.0n 0.4825 186249.9n 0.4825 186250.0n 0.4535 186499.9n 0.4535 186500.0n 0.2472 186749.9n 0.2472 186750.0n 0.8503 186999.9n 0.8503 187000.0n 0.2449 187249.9n 0.2449 187250.0n 0.5340 187499.9n 0.5340 187500.0n 0.4529 187749.9n 0.4529 187750.0n 0.2867 187999.9n 0.2867 188000.0n 0.3040 188249.9n 0.3040 188250.0n 0.5158 188499.9n 0.5158 188500.0n 0.5210 188749.9n 0.5210 188750.0n 0.5017 188999.9n 0.5017 189000.0n 0.5884 189249.9n 0.5884 189250.0n 0.6371 189499.9n 0.6371 189500.0n 0.5043 189749.9n 0.5043 189750.0n 0.4408 189999.9n 0.4408 190000.0n 0.1990 190249.9n 0.1990 190250.0n 0.5343 190499.9n 0.5343 190500.0n 0.8039 190749.9n 0.8039 190750.0n 0.6086 190999.9n 0.6086 191000.0n 0.2461 191249.9n 0.2461 191250.0n 0.4694 191499.9n 0.4694 191500.0n 0.7682 191749.9n 0.7682 191750.0n 0.5111 191999.9n 0.5111 192000.0n 0.6455 192249.9n 0.6455 192250.0n 0.2156 192499.9n 0.2156 192500.0n 0.5628 192749.9n 0.5628 192750.0n 0.1858 192999.9n 0.1858 193000.0n 0.5067 193249.9n 0.5067 193250.0n 0.3727 193499.9n 0.3727 193500.0n 0.5066 193749.9n 0.5066 193750.0n 0.5341 193999.9n 0.5341 194000.0n 0.4495 194249.9n 0.4495 194250.0n 0.1328 194499.9n 0.1328 194500.0n 0.4143 194749.9n 0.4143 194750.0n 0.4158 194999.9n 0.4158 195000.0n 0.4408 195249.9n 0.4408 195250.0n 0.6056 195499.9n 0.6056 195500.0n 0.1858 195749.9n 0.1858 195750.0n 0.2472 195999.9n 0.2472 196000.0n 0.5341 196249.9n 0.5341 196250.0n 0.5210 196499.9n 0.5210 196500.0n 0.8503 196749.9n 0.8503 196750.0n 0.2114 196999.9n 0.2114 197000.0n 0.7682 197249.9n 0.7682 197250.0n 0.5043 197499.9n 0.5043 197500.0n 0.5066 197749.9n 0.5066 197750.0n 0.6455 197999.9n 0.6455 198000.0n 0.4143 198249.9n 0.4143 198250.0n 0.6086 198499.9n 0.6086 198500.0n 0.6052 198749.9n 0.6052 198750.0n 0.6371 198999.9n 0.6371 199000.0n 0.5111 199249.9n 0.5111 199250.0n 0.2156 199499.9n 0.2156 199500.0n 0.4529 199749.9n 0.4529 199750.0n 0.5825 199999.9n 0.5825 200000.0n 0.4694 200249.9n 0.4694 200250.0n 0.5340 200499.9n 0.5340 200500.0n 0.8228 200749.9n 0.8228 200750.0n 0.1936 200999.9n 0.1936 201000.0n 0.4495 201249.9n 0.4495 201250.0n 0.5628 201499.9n 0.5628 201500.0n 0.5271 201749.9n 0.5271 201750.0n 0.3040 201999.9n 0.3040 202000.0n 0.4825 202249.9n 0.4825 202250.0n 0.4622 202499.9n 0.4622 202500.0n 0.3727 202749.9n 0.3727 202750.0n 0.5343 202999.9n 0.5343 203000.0n 0.1712 203249.9n 0.1712 203250.0n 0.6209 203499.9n 0.6209 203500.0n 0.5067 203749.9n 0.5067 203750.0n 0.4130 203999.9n 0.4130 204000.0n 0.3661 204249.9n 0.3661 204250.0n 0.1990 204499.9n 0.1990 204500.0n 0.4856 204749.9n 0.4856 204750.0n 0.1330 204999.9n 0.1330 205000.0n 0.5723 205249.9n 0.5723 205250.0n 0.1421 205499.9n 0.1421 205500.0n 0.8039 205749.9n 0.8039 205750.0n 0.1021 205999.9n 0.1021 206000.0n 0.4158 206249.9n 0.4158 206250.0n 0.5158 206499.9n 0.5158 206500.0n 0.6041 206749.9n 0.6041 206750.0n 0.2449 206999.9n 0.2449 207000.0n 0.5017 207249.9n 0.5017 207250.0n 0.2867 207499.9n 0.2867 207500.0n 0.3402 207749.9n 0.3402 207750.0n 0.4535 207999.9n 0.4535 208000.0n 0.2461 208249.9n 0.2461 208250.0n 0.2439 208499.9n 0.2439 208500.0n 0.6100 208749.9n 0.6100 208750.0n 0.1328 208999.9n 0.1328 209000.0n 0.2022 209249.9n 0.2022 209250.0n 0.8639 209499.9n 0.8639 209500.0n 0.5478 209749.9n 0.5478 209750.0n 0.5884 209999.9n 0.5884 210000.0n 0.4408 210249.9n 0.4408 210250.0n 0.1990 210499.9n 0.1990 210500.0n 0.5271 210749.9n 0.5271 210750.0n 0.2114 210999.9n 0.2114 211000.0n 0.5825 211249.9n 0.5825 211250.0n 0.1328 211499.9n 0.1328 211500.0n 0.2022 211749.9n 0.2022 211750.0n 0.5158 211999.9n 0.5158 212000.0n 0.5066 212249.9n 0.5066 212250.0n 0.2461 212499.9n 0.2461 212500.0n 0.5341 212749.9n 0.5341 212750.0n 0.5343 212999.9n 0.5343 213000.0n 0.8228 213249.9n 0.8228 213250.0n 0.4495 213499.9n 0.4495 213500.0n 0.2439 213749.9n 0.2439 213750.0n 0.2449 213999.9n 0.2449 214000.0n 0.5111 214249.9n 0.5111 214250.0n 0.4529 214499.9n 0.4529 214500.0n 0.4130 214749.9n 0.4130 214750.0n 0.6371 214999.9n 0.6371 215000.0n 0.2156 215249.9n 0.2156 215250.0n 0.6100 215499.9n 0.6100 215500.0n 0.1858 215749.9n 0.1858 215750.0n 0.5067 215999.9n 0.5067 216000.0n 0.6455 216249.9n 0.6455 216250.0n 0.1936 216499.9n 0.1936 216500.0n 0.4825 216749.9n 0.4825 216750.0n 0.1330 216999.9n 0.1330 217000.0n 0.5043 217249.9n 0.5043 217250.0n 0.5478 217499.9n 0.5478 217500.0n 0.1021 217749.9n 0.1021 217750.0n 0.6086 217999.9n 0.6086 218000.0n 0.3402 218249.9n 0.3402 218250.0n 0.6056 218499.9n 0.6056 218500.0n 0.5628 218749.9n 0.5628 218750.0n 0.5723 218999.9n 0.5723 219000.0n 0.2867 219249.9n 0.2867 219250.0n 0.8503 219499.9n 0.8503 219500.0n 0.5340 219749.9n 0.5340 219750.0n 0.4856 219999.9n 0.4856 220000.0n 0.3040 220249.9n 0.3040 220250.0n 0.8639 220499.9n 0.8639 220500.0n 0.4143 220749.9n 0.4143 220750.0n 0.1421 220999.9n 0.1421 221000.0n 0.4694 221249.9n 0.4694 221250.0n 0.6209 221499.9n 0.6209 221500.0n 0.8039 221749.9n 0.8039 221750.0n 0.3727 221999.9n 0.3727 222000.0n 0.4535 222249.9n 0.4535 222250.0n 0.5017 222499.9n 0.5017 222500.0n 0.4622 222749.9n 0.4622 222750.0n 0.7682 222999.9n 0.7682 223000.0n 0.5210 223249.9n 0.5210 223250.0n 0.4158 223499.9n 0.4158 223500.0n 0.2472 223749.9n 0.2472 223750.0n 0.5884 223999.9n 0.5884 224000.0n 0.6052 224249.9n 0.6052 224250.0n 0.3661 224499.9n 0.3661 224500.0n 0.1712 224749.9n 0.1712 224750.0n 0.6041 224999.9n 0.6041 225000.0n 0.1421 225249.9n 0.1421 225250.0n 0.3727 225499.9n 0.3727 225500.0n 0.4529 225749.9n 0.4529 225750.0n 0.6056 225999.9n 0.6056 226000.0n 0.5210 226249.9n 0.5210 226250.0n 0.5478 226499.9n 0.5478 226500.0n 0.8228 226749.9n 0.8228 226750.0n 0.4856 226999.9n 0.4856 227000.0n 0.4408 227249.9n 0.4408 227250.0n 0.5017 227499.9n 0.5017 227500.0n 0.6052 227749.9n 0.6052 227750.0n 0.1936 227999.9n 0.1936 228000.0n 0.5341 228249.9n 0.5341 228250.0n 0.2867 228499.9n 0.2867 228500.0n 0.2114 228749.9n 0.2114 228750.0n 0.8639 228999.9n 0.8639 229000.0n 0.4825 229249.9n 0.4825 229250.0n 0.5111 229499.9n 0.5111 229500.0n 0.6455 229749.9n 0.6455 229750.0n 0.4694 229999.9n 0.4694 230000.0n 0.8503 230249.9n 0.8503 230250.0n 0.1990 230499.9n 0.1990 230500.0n 0.5723 230749.9n 0.5723 230750.0n 0.5043 230999.9n 0.5043 231000.0n 0.2156 231249.9n 0.2156 231250.0n 0.5340 231499.9n 0.5340 231500.0n 0.4158 231749.9n 0.4158 231750.0n 0.2461 231999.9n 0.2461 232000.0n 0.2022 232249.9n 0.2022 232250.0n 0.2472 232499.9n 0.2472 232500.0n 0.1858 232749.9n 0.1858 232750.0n 0.7682 232999.9n 0.7682 233000.0n 0.5343 233249.9n 0.5343 233250.0n 0.6100 233499.9n 0.6100 233500.0n 0.1021 233749.9n 0.1021 233750.0n 0.6041 233999.9n 0.6041 234000.0n 0.1328 234249.9n 0.1328 234250.0n 0.4130 234499.9n 0.4130 234500.0n 0.3661 234749.9n 0.3661 234750.0n 0.6371 234999.9n 0.6371 235000.0n 0.1330 235249.9n 0.1330 235250.0n 0.3402 235499.9n 0.3402 235500.0n 0.2439 235749.9n 0.2439 235750.0n 0.2449 235999.9n 0.2449 236000.0n 0.4495 236249.9n 0.4495 236250.0n 0.5067 236499.9n 0.5067 236500.0n 0.5158 236749.9n 0.5158 236750.0n 0.1712 236999.9n 0.1712 237000.0n 0.5884 237249.9n 0.5884 237250.0n 0.3040 237499.9n 0.3040 237500.0n 0.6209 237749.9n 0.6209 237750.0n 0.5825 237999.9n 0.5825 238000.0n 0.5271 238249.9n 0.5271 238250.0n 0.6086 238499.9n 0.6086 238500.0n 0.4143 238749.9n 0.4143 238750.0n 0.8039 238999.9n 0.8039 239000.0n 0.4535 239249.9n 0.4535 239250.0n 0.4622 239499.9n 0.4622 239500.0n 0.5628 239749.9n 0.5628 239750.0n 0.5066 239999.9n 0.5066 240000.0n 0.8639 240249.9n 0.8639 240250.0n 0.4408 240499.9n 0.4408 240500.0n 0.5066 240749.9n 0.5066 240750.0n 0.4529 240999.9n 0.4529 241000.0n 0.4856 241249.9n 0.4856 241250.0n 0.2867 241499.9n 0.2867 241500.0n 0.1330 241749.9n 0.1330 241750.0n 0.5043 241999.9n 0.5043 242000.0n 0.1021 242249.9n 0.1021 242250.0n 0.5210 242499.9n 0.5210 242500.0n 0.6041 242749.9n 0.6041 242750.0n 0.5343 242999.9n 0.5343 243000.0n 0.5340 243249.9n 0.5340 243250.0n 0.6371 243499.9n 0.6371 243500.0n 0.5271 243749.9n 0.5271 243750.0n 0.4143 243999.9n 0.4143 244000.0n 0.4622 244249.9n 0.4622 244250.0n 0.5884 244499.9n 0.5884 244500.0n 0.6100 244749.9n 0.6100 244750.0n 0.3040 244999.9n 0.3040 245000.0n 0.2114 245249.9n 0.2114 245250.0n 0.2022 245499.9n 0.2022 245500.0n 0.4694 245749.9n 0.4694 245750.0n 0.5825 245999.9n 0.5825 246000.0n 0.4158 246249.9n 0.4158 246250.0n 0.1936 246499.9n 0.1936 246500.0n 0.3661 246749.9n 0.3661 246750.0n 0.6086 246999.9n 0.6086 247000.0n 0.5111 247249.9n 0.5111 247250.0n 0.5017 247499.9n 0.5017 247500.0n 0.1328 247749.9n 0.1328 247750.0n 0.2439 247999.9n 0.2439 248000.0n 0.2461 248249.9n 0.2461 248250.0n 0.1421 248499.9n 0.1421 248500.0n 0.4495 248749.9n 0.4495 248750.0n 0.1990 248999.9n 0.1990 249000.0n 0.3402 249249.9n 0.3402 249250.0n 0.5478 249499.9n 0.5478 249500.0n 0.4130 249749.9n 0.4130 249750.0n 0.8228 249999.9n 0.8228 250000.0n 0.1712 250249.9n 0.1712 250250.0n 0.6455 250499.9n 0.6455 250500.0n 0.8039 250749.9n 0.8039 250750.0n 0.4535 250999.9n 0.4535 251000.0n 0.6052 251249.9n 0.6052 251250.0n 0.4825 251499.9n 0.4825 251500.0n 0.8503 251749.9n 0.8503 251750.0n 0.2156 251999.9n 0.2156 252000.0n 0.6056 252249.9n 0.6056 252250.0n 0.2449 252499.9n 0.2449 252500.0n 0.5067 252749.9n 0.5067 252750.0n 0.6209 252999.9n 0.6209 253000.0n 0.5723 253249.9n 0.5723 253250.0n 0.5158 253499.9n 0.5158 253500.0n 0.7682 253749.9n 0.7682 253750.0n 0.1858 253999.9n 0.1858 254000.0n 0.3727 254249.9n 0.3727 254250.0n 0.5341 254499.9n 0.5341 254500.0n 0.2472 254749.9n 0.2472 254750.0n 0.5628 254999.9n 0.5628 255000.0n 0.6052 255249.9n 0.6052 255250.0n 0.6371 255499.9n 0.6371 255500.0n 0.3661 255749.9n 0.3661 255750.0n 0.5884 255999.9n 0.5884 256000.0n 0.1421 256249.9n 0.1421 256250.0n 0.8228 256499.9n 0.8228 256500.0n 0.2114 256749.9n 0.2114 256750.0n 0.8039 256999.9n 0.8039 257000.0n 0.4825 257249.9n 0.4825 257250.0n 0.4856 257499.9n 0.4856 257500.0n 0.5271 257749.9n 0.5271 257750.0n 0.6056 257999.9n 0.6056 258000.0n 0.6455 258249.9n 0.6455 258250.0n 0.5158 258499.9n 0.5158 258500.0n 0.4622 258749.9n 0.4622 258750.0n 0.6041 258999.9n 0.6041 259000.0n 0.4529 259249.9n 0.4529 259250.0n 0.8639 259499.9n 0.8639 259500.0n 0.5210 259749.9n 0.5210 259750.0n 0.4495 259999.9n 0.4495 260000.0n 0.2022 260249.9n 0.2022 260250.0n 0.7682 260499.9n 0.7682 260500.0n 0.5340 260749.9n 0.5340 260750.0n 0.5478 260999.9n 0.5478 261000.0n 0.2461 261249.9n 0.2461 261250.0n 0.5067 261499.9n 0.5067 261500.0n 0.1712 261749.9n 0.1712 261750.0n 0.5066 261999.9n 0.5066 262000.0n 0.8503 262249.9n 0.8503 262250.0n 0.5341 262499.9n 0.5341 262500.0n 0.2472 262749.9n 0.2472 262750.0n 0.5111 262999.9n 0.5111 263000.0n 0.2156 263249.9n 0.2156 263250.0n 0.5825 263499.9n 0.5825 263500.0n 0.3040 263749.9n 0.3040 263750.0n 0.2449 263999.9n 0.2449 264000.0n 0.1936 264249.9n 0.1936 264250.0n 0.5723 264499.9n 0.5723 264500.0n 0.1328 264749.9n 0.1328 264750.0n 0.5343 264999.9n 0.5343 265000.0n 0.1858 265249.9n 0.1858 265250.0n 0.5628 265499.9n 0.5628 265500.0n 0.3727 265749.9n 0.3727 265750.0n 0.4158 265999.9n 0.4158 266000.0n 0.1330 266249.9n 0.1330 266250.0n 0.4694 266499.9n 0.4694 266500.0n 0.6209 266749.9n 0.6209 266750.0n 0.2867 266999.9n 0.2867 267000.0n 0.5043 267249.9n 0.5043 267250.0n 0.4535 267499.9n 0.4535 267500.0n 0.2439 267749.9n 0.2439 267750.0n 0.3402 267999.9n 0.3402 268000.0n 0.6100 268249.9n 0.6100 268250.0n 0.4130 268499.9n 0.4130 268500.0n 0.6086 268749.9n 0.6086 268750.0n 0.4408 268999.9n 0.4408 269000.0n 0.5017 269249.9n 0.5017 269250.0n 0.1021 269499.9n 0.1021 269500.0n 0.4143 269749.9n 0.4143 269750.0n 0.1990 269999.9n 0.1990 270000.0n 0.1421 270249.9n 0.1421 270250.0n 0.6086 270499.9n 0.6086 270500.0n 0.6041 270749.9n 0.6041 270750.0n 0.4130 270999.9n 0.4130 271000.0n 0.1021 271249.9n 0.1021 271250.0n 0.6371 271499.9n 0.6371 271500.0n 0.1330 271749.9n 0.1330 271750.0n 0.8039 271999.9n 0.8039 272000.0n 0.5067 272249.9n 0.5067 272250.0n 0.5825 272499.9n 0.5825 272500.0n 0.4143 272749.9n 0.4143 272750.0n 0.4535 272999.9n 0.4535 273000.0n 0.3040 273249.9n 0.3040 273250.0n 0.2449 273499.9n 0.2449 273500.0n 0.5066 273749.9n 0.5066 273750.0n 0.2461 273999.9n 0.2461 274000.0n 0.1936 274249.9n 0.1936 274250.0n 0.5478 274499.9n 0.5478 274500.0n 0.1990 274749.9n 0.1990 274750.0n 0.5340 274999.9n 0.5340 275000.0n 0.5043 275249.9n 0.5043 275250.0n 0.4495 275499.9n 0.4495 275500.0n 0.5343 275749.9n 0.5343 275750.0n 0.4622 275999.9n 0.4622 276000.0n 0.2156 276249.9n 0.2156 276250.0n 0.5884 276499.9n 0.5884 276500.0n 0.5628 276749.9n 0.5628 276750.0n 0.8503 276999.9n 0.8503 277000.0n 0.5111 277249.9n 0.5111 277250.0n 0.3661 277499.9n 0.3661 277500.0n 0.4694 277749.9n 0.4694 277750.0n 0.5723 277999.9n 0.5723 278000.0n 0.6056 278249.9n 0.6056 278250.0n 0.5341 278499.9n 0.5341 278500.0n 0.2022 278749.9n 0.2022 278750.0n 0.4825 278999.9n 0.4825 279000.0n 0.8639 279249.9n 0.8639 279250.0n 0.3402 279499.9n 0.3402 279500.0n 0.2472 279749.9n 0.2472 279750.0n 0.2114 279999.9n 0.2114 280000.0n 0.1712 280249.9n 0.1712 280250.0n 0.5271 280499.9n 0.5271 280500.0n 0.6100 280749.9n 0.6100 280750.0n 0.4408 280999.9n 0.4408 281000.0n 0.5158 281249.9n 0.5158 281250.0n 0.3727 281499.9n 0.3727 281500.0n 0.8228 281749.9n 0.8228 281750.0n 0.4158 281999.9n 0.4158 282000.0n 0.6455 282249.9n 0.6455 282250.0n 0.2439 282499.9n 0.2439 282500.0n 0.1858 282749.9n 0.1858 282750.0n 0.4856 282999.9n 0.4856 283000.0n 0.6209 283249.9n 0.6209 283250.0n 0.5210 283499.9n 0.5210 283500.0n 0.5017 283749.9n 0.5017 283750.0n 0.4529 283999.9n 0.4529 284000.0n 0.6052 284249.9n 0.6052 284250.0n 0.2867 284499.9n 0.2867 284500.0n 0.7682 284749.9n 0.7682 284750.0n 0.1328 284999.9n 0.1328 285000.0n 0.4856 285249.9n 0.4856 285250.0n 0.6455 285499.9n 0.6455 285500.0n 0.6056 285749.9n 0.6056 285750.0n 0.1328 285999.9n 0.1328 286000.0n 0.6371 286249.9n 0.6371 286250.0n 0.1990 286499.9n 0.1990 286500.0n 0.5884 286749.9n 0.5884 286750.0n 0.3040 286999.9n 0.3040 287000.0n 0.5066 287249.9n 0.5066 287250.0n 0.2867 287499.9n 0.2867 287500.0n 0.2439 287749.9n 0.2439 287750.0n 0.1021 287999.9n 0.1021 288000.0n 0.6100 288249.9n 0.6100 288250.0n 0.8503 288499.9n 0.8503 288500.0n 0.5210 288749.9n 0.5210 288750.0n 0.4495 288999.9n 0.4495 289000.0n 0.3402 289249.9n 0.3402 289250.0n 0.4694 289499.9n 0.4694 289500.0n 0.5628 289749.9n 0.5628 289750.0n 0.5478 289999.9n 0.5478 290000.0n 0.2022 290249.9n 0.2022 290250.0n 0.2472 290499.9n 0.2472 290500.0n 0.2449 290749.9n 0.2449 290750.0n 0.6041 290999.9n 0.6041 291000.0n 0.6086 291249.9n 0.6086 291250.0n 0.2156 291499.9n 0.2156 291500.0n 0.5340 291749.9n 0.5340 291750.0n 0.8639 291999.9n 0.8639 292000.0n 0.1330 292249.9n 0.1330 292250.0n 0.5017 292499.9n 0.5017 292500.0n 0.1936 292749.9n 0.1936 292750.0n 0.4622 292999.9n 0.4622 293000.0n 0.6052 293249.9n 0.6052 293250.0n 0.4143 293499.9n 0.4143 293500.0n 0.4158 293749.9n 0.4158 293750.0n 0.3727 293999.9n 0.3727 294000.0n 0.5067 294249.9n 0.5067 294250.0n 0.5111 294499.9n 0.5111 294500.0n 0.5343 294749.9n 0.5343 294750.0n 0.4529 294999.9n 0.4529 295000.0n 0.1421 295249.9n 0.1421 295250.0n 0.1858 295499.9n 0.1858 295500.0n 0.1712 295749.9n 0.1712 295750.0n 0.6209 295999.9n 0.6209 296000.0n 0.5723 296249.9n 0.5723 296250.0n 0.2461 296499.9n 0.2461 296500.0n 0.8228 296749.9n 0.8228 296750.0n 0.2114 296999.9n 0.2114 297000.0n 0.5043 297249.9n 0.5043 297250.0n 0.4535 297499.9n 0.4535 297500.0n 0.5271 297749.9n 0.5271 297750.0n 0.3661 297999.9n 0.3661 298000.0n 0.4130 298249.9n 0.4130 298250.0n 0.5341 298499.9n 0.5341 298500.0n 0.4825 298749.9n 0.4825 298750.0n 0.7682 298999.9n 0.7682 299000.0n 0.4408 299249.9n 0.4408 299250.0n 0.5158 299499.9n 0.5158 299500.0n 0.8039 299749.9n 0.8039 299750.0n 0.5825 299999.9n 0.5825 300000.0n 0.1712 300249.9n 0.1712 300250.0n 0.2114 300499.9n 0.2114 300500.0n 0.6041 300749.9n 0.6041 300750.0n 0.1858 300999.9n 0.1858 301000.0n 0.4825 301249.9n 0.4825 301250.0n 0.8228 301499.9n 0.8228 301500.0n 0.2472 301749.9n 0.2472 301750.0n 0.5478 301999.9n 0.5478 302000.0n 0.3661 302249.9n 0.3661 302250.0n 0.1021 302499.9n 0.1021 302500.0n 0.5066 302749.9n 0.5066 302750.0n 0.6056 302999.9n 0.6056 303000.0n 0.4694 303249.9n 0.4694 303250.0n 0.4529 303499.9n 0.4529 303500.0n 0.1328 303749.9n 0.1328 303750.0n 0.8039 303999.9n 0.8039 304000.0n 0.4158 304249.9n 0.4158 304250.0n 0.5158 304499.9n 0.5158 304500.0n 0.2461 304749.9n 0.2461 304750.0n 0.5341 304999.9n 0.5341 305000.0n 0.3402 305249.9n 0.3402 305250.0n 0.7682 305499.9n 0.7682 305500.0n 0.6052 305749.9n 0.6052 305750.0n 0.5825 305999.9n 0.5825 306000.0n 0.4535 306249.9n 0.4535 306250.0n 0.5111 306499.9n 0.5111 306500.0n 0.2439 306749.9n 0.2439 306750.0n 0.5210 306999.9n 0.5210 307000.0n 0.5340 307249.9n 0.5340 307250.0n 0.8503 307499.9n 0.8503 307500.0n 0.5017 307749.9n 0.5017 307750.0n 0.3727 307999.9n 0.3727 308000.0n 0.4143 308249.9n 0.4143 308250.0n 0.5628 308499.9n 0.5628 308500.0n 0.1936 308749.9n 0.1936 308750.0n 0.1990 308999.9n 0.1990 309000.0n 0.5343 309249.9n 0.5343 309250.0n 0.6086 309499.9n 0.6086 309500.0n 0.4495 309749.9n 0.4495 309750.0n 0.4856 309999.9n 0.4856 310000.0n 0.2156 310249.9n 0.2156 310250.0n 0.2867 310499.9n 0.2867 310500.0n 0.3040 310749.9n 0.3040 310750.0n 0.5271 310999.9n 0.5271 311000.0n 0.5723 311249.9n 0.5723 311250.0n 0.2449 311499.9n 0.2449 311500.0n 0.5043 311749.9n 0.5043 311750.0n 0.5884 311999.9n 0.5884 312000.0n 0.5067 312249.9n 0.5067 312250.0n 0.4130 312499.9n 0.4130 312500.0n 0.6455 312749.9n 0.6455 312750.0n 0.6100 312999.9n 0.6100 313000.0n 0.4622 313249.9n 0.4622 313250.0n 0.8639 313499.9n 0.8639 313500.0n 0.1330 313749.9n 0.1330 313750.0n 0.2022 313999.9n 0.2022 314000.0n 0.6371 314249.9n 0.6371 314250.0n 0.4408 314499.9n 0.4408 314500.0n 0.1421 314749.9n 0.1421 314750.0n 0.6209 314999.9n 0.6209 315000.0n 0.4143 315249.9n 0.4143 315250.0n 0.1858 315499.9n 0.1858 315500.0n 0.4622 315749.9n 0.4622 315750.0n 0.5723 315999.9n 0.5723 316000.0n 0.2156 316249.9n 0.2156 316250.0n 0.3727 316499.9n 0.3727 316500.0n 0.4825 316749.9n 0.4825 316750.0n 0.1936 316999.9n 0.1936 317000.0n 0.1328 317249.9n 0.1328 317250.0n 0.2449 317499.9n 0.2449 317500.0n 0.6209 317749.9n 0.6209 317750.0n 0.1990 317999.9n 0.1990 318000.0n 0.5158 318249.9n 0.5158 318250.0n 0.5067 318499.9n 0.5067 318500.0n 0.8503 318749.9n 0.8503 318750.0n 0.2472 318999.9n 0.2472 319000.0n 0.4130 319249.9n 0.4130 319250.0n 0.6052 319499.9n 0.6052 319500.0n 0.6041 319749.9n 0.6041 319750.0n 0.8228 319999.9n 0.8228 320000.0n 0.1712 320249.9n 0.1712 320250.0n 0.1421 320499.9n 0.1421 320500.0n 0.4408 320749.9n 0.4408 320750.0n 0.4529 320999.9n 0.4529 321000.0n 0.6086 321249.9n 0.6086 321250.0n 0.2461 321499.9n 0.2461 321500.0n 0.4856 321749.9n 0.4856 321750.0n 0.5271 321999.9n 0.5271 322000.0n 0.5628 322249.9n 0.5628 322250.0n 0.5043 322499.9n 0.5043 322500.0n 0.8639 322749.9n 0.8639 322750.0n 0.7682 322999.9n 0.7682 323000.0n 0.4535 323249.9n 0.4535 323250.0n 0.3040 323499.9n 0.3040 323500.0n 0.2439 323749.9n 0.2439 323750.0n 0.6455 323999.9n 0.6455 324000.0n 0.6056 324249.9n 0.6056 324250.0n 0.8039 324499.9n 0.8039 324500.0n 0.5066 324749.9n 0.5066 324750.0n 0.2022 324999.9n 0.2022 325000.0n 0.3661 325249.9n 0.3661 325250.0n 0.1021 325499.9n 0.1021 325500.0n 0.4158 325749.9n 0.4158 325750.0n 0.5341 325999.9n 0.5341 326000.0n 0.4495 326249.9n 0.4495 326250.0n 0.1330 326499.9n 0.1330 326500.0n 0.6100 326749.9n 0.6100 326750.0n 0.5111 326999.9n 0.5111 327000.0n 0.5017 327249.9n 0.5017 327250.0n 0.5884 327499.9n 0.5884 327500.0n 0.2867 327749.9n 0.2867 327750.0n 0.5825 327999.9n 0.5825 328000.0n 0.4694 328249.9n 0.4694 328250.0n 0.2114 328499.9n 0.2114 328500.0n 0.5343 328749.9n 0.5343 328750.0n 0.6371 328999.9n 0.6371 329000.0n 0.5210 329249.9n 0.5210 329250.0n 0.3402 329499.9n 0.3402 329500.0n 0.5340 329749.9n 0.5340 329750.0n 0.5478 329999.9n 0.5478 330000.0n 0.1421 330249.9n 0.1421 330250.0n 0.6086 330499.9n 0.6086 330500.0n 0.4856 330749.9n 0.4856 330750.0n 0.2156 330999.9n 0.2156 331000.0n 0.5158 331249.9n 0.5158 331250.0n 0.5825 331499.9n 0.5825 331500.0n 0.5628 331749.9n 0.5628 331750.0n 0.6056 331999.9n 0.6056 332000.0n 0.3727 332249.9n 0.3727 332250.0n 0.5478 332499.9n 0.5478 332500.0n 0.1328 332749.9n 0.1328 332750.0n 0.8039 332999.9n 0.8039 333000.0n 0.6041 333249.9n 0.6041 333250.0n 0.6455 333499.9n 0.6455 333500.0n 0.2022 333749.9n 0.2022 333750.0n 0.1936 333999.9n 0.1936 334000.0n 0.2461 334249.9n 0.2461 334250.0n 0.4529 334499.9n 0.4529 334500.0n 0.7682 334749.9n 0.7682 334750.0n 0.4408 334999.9n 0.4408 335000.0n 0.6371 335249.9n 0.6371 335250.0n 0.8228 335499.9n 0.8228 335500.0n 0.5884 335749.9n 0.5884 335750.0n 0.6100 335999.9n 0.6100 336000.0n 0.1712 336249.9n 0.1712 336250.0n 0.5343 336499.9n 0.5343 336500.0n 0.5043 336749.9n 0.5043 336750.0n 0.6052 336999.9n 0.6052 337000.0n 0.3402 337249.9n 0.3402 337250.0n 0.6209 337499.9n 0.6209 337500.0n 0.5111 337749.9n 0.5111 337750.0n 0.4143 337999.9n 0.4143 338000.0n 0.1330 338249.9n 0.1330 338250.0n 0.5017 338499.9n 0.5017 338500.0n 0.2472 338749.9n 0.2472 338750.0n 0.4158 338999.9n 0.4158 339000.0n 0.4622 339249.9n 0.4622 339250.0n 0.3661 339499.9n 0.3661 339500.0n 0.1990 339749.9n 0.1990 339750.0n 0.4825 339999.9n 0.4825 340000.0n 0.3040 340249.9n 0.3040 340250.0n 0.5271 340499.9n 0.5271 340500.0n 0.4495 340749.9n 0.4495 340750.0n 0.5067 340999.9n 0.5067 341000.0n 0.1021 341249.9n 0.1021 341250.0n 0.5341 341499.9n 0.5341 341500.0n 0.5210 341749.9n 0.5210 341750.0n 0.5066 341999.9n 0.5066 342000.0n 0.2449 342249.9n 0.2449 342250.0n 0.1858 342499.9n 0.1858 342500.0n 0.2867 342749.9n 0.2867 342750.0n 0.5723 342999.9n 0.5723 343000.0n 0.5340 343249.9n 0.5340 343250.0n 0.2439 343499.9n 0.2439 343500.0n 0.4535 343749.9n 0.4535 343750.0n 0.4130 343999.9n 0.4130 344000.0n 0.8503 344249.9n 0.8503 344250.0n 0.4694 344499.9n 0.4694 344500.0n 0.8639 344749.9n 0.8639 344750.0n 0.2114 344999.9n 0.2114 345000.0n 0.4158 345249.9n 0.4158 345250.0n 0.3402 345499.9n 0.3402 345500.0n 0.6056 345749.9n 0.6056 345750.0n 0.3727 345999.9n 0.3727 346000.0n 0.4408 346249.9n 0.4408 346250.0n 0.6052 346499.9n 0.6052 346500.0n 0.2867 346749.9n 0.2867 346750.0n 0.1990 346999.9n 0.1990 347000.0n 0.2449 347249.9n 0.2449 347250.0n 0.5628 347499.9n 0.5628 347500.0n 0.3040 347749.9n 0.3040 347750.0n 0.6455 347999.9n 0.6455 348000.0n 0.1712 348249.9n 0.1712 348250.0n 0.8228 348499.9n 0.8228 348500.0n 0.4825 348749.9n 0.4825 348750.0n 0.2114 348999.9n 0.2114 349000.0n 0.4694 349249.9n 0.4694 349250.0n 0.3661 349499.9n 0.3661 349500.0n 0.1021 349749.9n 0.1021 349750.0n 0.4143 349999.9n 0.4143 350000.0n 0.5723 350249.9n 0.5723 350250.0n 0.5158 350499.9n 0.5158 350500.0n 0.6100 350749.9n 0.6100 350750.0n 0.2461 350999.9n 0.2461 351000.0n 0.5271 351249.9n 0.5271 351250.0n 0.1330 351499.9n 0.1330 351500.0n 0.8503 351749.9n 0.8503 351750.0n 0.4130 351999.9n 0.4130 352000.0n 0.4622 352249.9n 0.4622 352250.0n 0.6371 352499.9n 0.6371 352500.0n 0.4856 352749.9n 0.4856 352750.0n 0.6209 352999.9n 0.6209 353000.0n 0.7682 353249.9n 0.7682 353250.0n 0.1858 353499.9n 0.1858 353500.0n 0.6086 353749.9n 0.6086 353750.0n 0.5884 353999.9n 0.5884 354000.0n 0.4529 354249.9n 0.4529 354250.0n 0.5478 354499.9n 0.5478 354500.0n 0.5340 354749.9n 0.5340 354750.0n 0.6041 354999.9n 0.6041 355000.0n 0.5066 355249.9n 0.5066 355250.0n 0.5043 355499.9n 0.5043 355500.0n 0.4535 355749.9n 0.4535 355750.0n 0.5210 355999.9n 0.5210 356000.0n 0.4495 356249.9n 0.4495 356250.0n 0.1936 356499.9n 0.1936 356500.0n 0.1328 356749.9n 0.1328 356750.0n 0.8039 356999.9n 0.8039 357000.0n 0.5017 357249.9n 0.5017 357250.0n 0.2472 357499.9n 0.2472 357500.0n 0.5067 357749.9n 0.5067 357750.0n 0.5343 357999.9n 0.5343 358000.0n 0.2439 358249.9n 0.2439 358250.0n 0.1421 358499.9n 0.1421 358500.0n 0.5825 358749.9n 0.5825 358750.0n 0.2022 358999.9n 0.2022 359000.0n 0.5341 359249.9n 0.5341 359250.0n 0.2156 359499.9n 0.2156 359500.0n 0.8639 359749.9n 0.8639 359750.0n 0.5111 359999.9n 0.5111 360000.0n 0.3727 360249.9n 0.3727 360250.0n 0.2114 360499.9n 0.2114 360500.0n 0.5067 360749.9n 0.5067 360750.0n 0.5341 360999.9n 0.5341 361000.0n 0.1990 361249.9n 0.1990 361250.0n 0.3402 361499.9n 0.3402 361500.0n 0.8639 361749.9n 0.8639 361750.0n 0.8503 361999.9n 0.8503 362000.0n 0.6041 362249.9n 0.6041 362250.0n 0.6455 362499.9n 0.6455 362500.0n 0.4130 362749.9n 0.4130 362750.0n 0.2439 362999.9n 0.2439 363000.0n 0.4622 363249.9n 0.4622 363250.0n 0.6056 363499.9n 0.6056 363500.0n 0.5043 363749.9n 0.5043 363750.0n 0.5478 363999.9n 0.5478 364000.0n 0.5723 364249.9n 0.5723 364250.0n 0.2449 364499.9n 0.2449 364500.0n 0.2156 364749.9n 0.2156 364750.0n 0.6209 364999.9n 0.6209 365000.0n 0.8039 365249.9n 0.8039 365250.0n 0.6052 365499.9n 0.6052 365500.0n 0.3661 365749.9n 0.3661 365750.0n 0.5017 365999.9n 0.5017 366000.0n 0.4529 366249.9n 0.4529 366250.0n 0.2022 366499.9n 0.2022 366500.0n 0.5628 366749.9n 0.5628 366750.0n 0.1712 366999.9n 0.1712 367000.0n 0.2472 367249.9n 0.2472 367250.0n 0.1328 367499.9n 0.1328 367500.0n 0.2867 367749.9n 0.2867 367750.0n 0.6086 367999.9n 0.6086 368000.0n 0.5343 368249.9n 0.5343 368250.0n 0.4408 368499.9n 0.4408 368500.0n 0.5210 368749.9n 0.5210 368750.0n 0.7682 368999.9n 0.7682 369000.0n 0.5158 369249.9n 0.5158 369250.0n 0.2461 369499.9n 0.2461 369500.0n 0.6100 369749.9n 0.6100 369750.0n 0.1936 369999.9n 0.1936 370000.0n 0.5825 370249.9n 0.5825 370250.0n 0.4694 370499.9n 0.4694 370500.0n 0.4535 370749.9n 0.4535 370750.0n 0.1021 370999.9n 0.1021 371000.0n 0.4158 371249.9n 0.4158 371250.0n 0.3040 371499.9n 0.3040 371500.0n 0.6371 371749.9n 0.6371 371750.0n 0.8228 371999.9n 0.8228 372000.0n 0.1421 372249.9n 0.1421 372250.0n 0.4856 372499.9n 0.4856 372500.0n 0.4825 372749.9n 0.4825 372750.0n 0.5111 372999.9n 0.5111 373000.0n 0.5271 373249.9n 0.5271 373250.0n 0.5340 373499.9n 0.5340 373500.0n 0.4495 373749.9n 0.4495 373750.0n 0.1858 373999.9n 0.1858 374000.0n 0.5066 374249.9n 0.5066 374250.0n 0.1330 374499.9n 0.1330 374500.0n 0.5884 374749.9n 0.5884 374750.0n 0.4143 374999.9n 0.4143 375000.0n 0.8639 375249.9n 0.8639 375250.0n 0.2022 375499.9n 0.2022 375500.0n 0.5066 375749.9n 0.5066 375750.0n 0.4856 375999.9n 0.4856 376000.0n 0.1936 376249.9n 0.1936 376250.0n 0.5825 376499.9n 0.5825 376500.0n 0.5271 376749.9n 0.5271 376750.0n 0.5343 376999.9n 0.5343 377000.0n 0.5341 377249.9n 0.5341 377250.0n 0.2461 377499.9n 0.2461 377500.0n 0.5628 377749.9n 0.5628 377750.0n 0.4529 377999.9n 0.4529 378000.0n 0.4143 378249.9n 0.4143 378250.0n 0.1421 378499.9n 0.1421 378500.0n 0.6052 378749.9n 0.6052 378750.0n 0.2867 378999.9n 0.2867 379000.0n 0.6209 379249.9n 0.6209 379250.0n 0.1712 379499.9n 0.1712 379500.0n 0.8503 379749.9n 0.8503 379750.0n 0.7682 379999.9n 0.7682 380000.0n 0.5043 380249.9n 0.5043 380250.0n 0.4622 380499.9n 0.4622 380500.0n 0.1990 380749.9n 0.1990 380750.0n 0.5884 380999.9n 0.5884 381000.0n 0.6455 381249.9n 0.6455 381250.0n 0.8039 381499.9n 0.8039 381500.0n 0.5017 381749.9n 0.5017 381750.0n 0.5158 381999.9n 0.5158 382000.0n 0.2449 382249.9n 0.2449 382250.0n 0.2439 382499.9n 0.2439 382500.0n 0.4495 382749.9n 0.4495 382750.0n 0.5723 382999.9n 0.5723 383000.0n 0.4158 383249.9n 0.4158 383250.0n 0.6041 383499.9n 0.6041 383500.0n 0.2472 383749.9n 0.2472 383750.0n 0.3402 383999.9n 0.3402 384000.0n 0.4408 384249.9n 0.4408 384250.0n 0.1858 384499.9n 0.1858 384500.0n 0.1328 384749.9n 0.1328 384750.0n 0.4535 384999.9n 0.4535 385000.0n 0.5067 385249.9n 0.5067 385250.0n 0.5111 385499.9n 0.5111 385500.0n 0.4825 385749.9n 0.4825 385750.0n 0.5210 385999.9n 0.5210 386000.0n 0.3661 386249.9n 0.3661 386250.0n 0.4694 386499.9n 0.4694 386500.0n 0.1330 386749.9n 0.1330 386750.0n 0.5340 386999.9n 0.5340 387000.0n 0.5478 387249.9n 0.5478 387250.0n 0.8228 387499.9n 0.8228 387500.0n 0.2156 387749.9n 0.2156 387750.0n 0.4130 387999.9n 0.4130 388000.0n 0.6086 388249.9n 0.6086 388250.0n 0.6371 388499.9n 0.6371 388500.0n 0.2114 388749.9n 0.2114 388750.0n 0.1021 388999.9n 0.1021 389000.0n 0.3040 389249.9n 0.3040 389250.0n 0.6056 389499.9n 0.6056 389500.0n 0.3727 389749.9n 0.3727 389750.0n 0.6100 389999.9n 0.6100 390000.0n 0.6100 390249.9n 0.6100 390250.0n 0.8503 390499.9n 0.8503 390500.0n 0.5067 390749.9n 0.5067 390750.0n 0.5343 390999.9n 0.5343 391000.0n 0.3661 391249.9n 0.3661 391250.0n 0.4158 391499.9n 0.4158 391500.0n 0.2867 391749.9n 0.2867 391750.0n 0.5340 391999.9n 0.5340 392000.0n 0.6041 392249.9n 0.6041 392250.0n 0.8639 392499.9n 0.8639 392500.0n 0.5825 392749.9n 0.5825 392750.0n 0.2461 392999.9n 0.2461 393000.0n 0.5884 393249.9n 0.5884 393250.0n 0.3402 393499.9n 0.3402 393500.0n 0.1990 393749.9n 0.1990 393750.0n 0.1421 393999.9n 0.1421 394000.0n 0.8228 394249.9n 0.8228 394250.0n 0.8039 394499.9n 0.8039 394500.0n 0.7682 394749.9n 0.7682 394750.0n 0.2439 394999.9n 0.2439 395000.0n 0.1936 395249.9n 0.1936 395250.0n 0.4622 395499.9n 0.4622 395500.0n 0.5271 395749.9n 0.5271 395750.0n 0.6371 395999.9n 0.6371 396000.0n 0.5111 396249.9n 0.5111 396250.0n 0.6052 396499.9n 0.6052 396500.0n 0.6455 396749.9n 0.6455 396750.0n 0.4825 396999.9n 0.4825 397000.0n 0.4408 397249.9n 0.4408 397250.0n 0.6209 397499.9n 0.6209 397500.0n 0.6086 397749.9n 0.6086 397750.0n 0.1712 397999.9n 0.1712 398000.0n 0.5066 398249.9n 0.5066 398250.0n 0.5478 398499.9n 0.5478 398500.0n 0.4856 398749.9n 0.4856 398750.0n 0.1021 398999.9n 0.1021 399000.0n 0.2449 399249.9n 0.2449 399250.0n 0.4529 399499.9n 0.4529 399500.0n 0.2472 399749.9n 0.2472 399750.0n 0.2022 399999.9n 0.2022 400000.0n 0.2156 400249.9n 0.2156 400250.0n 0.5628 400499.9n 0.5628 400500.0n 0.6056 400749.9n 0.6056 400750.0n 0.4130 400999.9n 0.4130 401000.0n 0.4495 401249.9n 0.4495 401250.0n 0.2114 401499.9n 0.2114 401500.0n 0.5210 401749.9n 0.5210 401750.0n 0.5017 401999.9n 0.5017 402000.0n 0.5723 402249.9n 0.5723 402250.0n 0.4694 402499.9n 0.4694 402500.0n 0.1328 402749.9n 0.1328 402750.0n 0.4143 402999.9n 0.4143 403000.0n 0.4535 403249.9n 0.4535 403250.0n 0.5043 403499.9n 0.5043 403500.0n 0.5158 403749.9n 0.5158 403750.0n 0.3040 403999.9n 0.3040 404000.0n 0.1858 404249.9n 0.1858 404250.0n 0.3727 404499.9n 0.3727 404500.0n 0.5341 404749.9n 0.5341 404750.0n 0.1330 404999.9n 0.1330 405000.0n 0.6100 405249.9n 0.6100 405250.0n 0.6455 405499.9n 0.6455 405500.0n 0.8228 405749.9n 0.8228 405750.0n 0.4529 405999.9n 0.4529 406000.0n 0.7682 406249.9n 0.7682 406250.0n 0.4495 406499.9n 0.4495 406500.0n 0.5066 406749.9n 0.5066 406750.0n 0.4622 406999.9n 0.4622 407000.0n 0.1858 407249.9n 0.1858 407250.0n 0.5271 407499.9n 0.5271 407500.0n 0.5210 407749.9n 0.5210 407750.0n 0.2867 407999.9n 0.2867 408000.0n 0.4130 408249.9n 0.4130 408250.0n 0.8639 408499.9n 0.8639 408500.0n 0.5478 408749.9n 0.5478 408750.0n 0.3040 408999.9n 0.3040 409000.0n 0.5628 409249.9n 0.5628 409250.0n 0.4143 409499.9n 0.4143 409500.0n 0.3661 409749.9n 0.3661 409750.0n 0.1330 409999.9n 0.1330 410000.0n 0.2461 410249.9n 0.2461 410250.0n 0.6086 410499.9n 0.6086 410500.0n 0.5343 410749.9n 0.5343 410750.0n 0.5043 410999.9n 0.5043 411000.0n 0.8039 411249.9n 0.8039 411250.0n 0.6052 411499.9n 0.6052 411500.0n 0.8503 411749.9n 0.8503 411750.0n 0.5825 411999.9n 0.5825 412000.0n 0.3402 412249.9n 0.3402 412250.0n 0.5340 412499.9n 0.5340 412500.0n 0.2472 412749.9n 0.2472 412750.0n 0.6056 412999.9n 0.6056 413000.0n 0.5067 413249.9n 0.5067 413250.0n 0.2156 413499.9n 0.2156 413500.0n 0.5111 413749.9n 0.5111 413750.0n 0.3727 413999.9n 0.3727 414000.0n 0.4408 414249.9n 0.4408 414250.0n 0.1021 414499.9n 0.1021 414500.0n 0.1990 414749.9n 0.1990 414750.0n 0.5341 414999.9n 0.5341 415000.0n 0.2114 415249.9n 0.2114 415250.0n 0.4158 415499.9n 0.4158 415500.0n 0.4535 415749.9n 0.4535 415750.0n 0.1421 415999.9n 0.1421 416000.0n 0.2439 416249.9n 0.2439 416250.0n 0.2022 416499.9n 0.2022 416500.0n 0.4856 416749.9n 0.4856 416750.0n 0.5017 416999.9n 0.5017 417000.0n 0.4825 417249.9n 0.4825 417250.0n 0.6371 417499.9n 0.6371 417500.0n 0.5723 417749.9n 0.5723 417750.0n 0.6041 417999.9n 0.6041 418000.0n 0.5884 418249.9n 0.5884 418250.0n 0.2449 418499.9n 0.2449 418500.0n 0.1936 418749.9n 0.1936 418750.0n 0.5158 418999.9n 0.5158 419000.0n 0.1712 419249.9n 0.1712 419250.0n 0.6209 419499.9n 0.6209 419500.0n 0.1328 419749.9n 0.1328 419750.0n 0.4694 419999.9n 0.4694 420000.0n 0.5210 420249.9n 0.5210 420250.0n 0.2867 420499.9n 0.2867 420500.0n 0.8639 420749.9n 0.8639 420750.0n 0.1936 420999.9n 0.1936 421000.0n 0.5343 421249.9n 0.5343 421250.0n 0.3402 421499.9n 0.3402 421500.0n 0.3040 421749.9n 0.3040 421750.0n 0.6041 421999.9n 0.6041 422000.0n 0.5340 422249.9n 0.5340 422250.0n 0.4825 422499.9n 0.4825 422500.0n 0.5158 422749.9n 0.5158 422750.0n 0.1328 422999.9n 0.1328 423000.0n 0.6209 423249.9n 0.6209 423250.0n 0.6086 423499.9n 0.6086 423500.0n 0.4529 423749.9n 0.4529 423750.0n 0.5825 423999.9n 0.5825 424000.0n 0.6100 424249.9n 0.6100 424250.0n 0.5271 424499.9n 0.5271 424500.0n 0.6371 424749.9n 0.6371 424750.0n 0.5723 424999.9n 0.5723 425000.0n 0.5628 425249.9n 0.5628 425250.0n 0.1421 425499.9n 0.1421 425500.0n 0.5043 425749.9n 0.5043 425750.0n 0.7682 425999.9n 0.7682 426000.0n 0.4495 426249.9n 0.4495 426250.0n 0.2439 426499.9n 0.2439 426500.0n 0.8228 426749.9n 0.8228 426750.0n 0.2472 426999.9n 0.2472 427000.0n 0.6052 427249.9n 0.6052 427250.0n 0.2114 427499.9n 0.2114 427500.0n 0.4158 427749.9n 0.4158 427750.0n 0.4130 427999.9n 0.4130 428000.0n 0.4143 428249.9n 0.4143 428250.0n 0.5017 428499.9n 0.5017 428500.0n 0.2461 428749.9n 0.2461 428750.0n 0.1712 428999.9n 0.1712 429000.0n 0.2449 429249.9n 0.2449 429250.0n 0.4535 429499.9n 0.4535 429500.0n 0.4856 429749.9n 0.4856 429750.0n 0.3661 429999.9n 0.3661 430000.0n 0.3727 430249.9n 0.3727 430250.0n 0.4622 430499.9n 0.4622 430500.0n 0.1858 430749.9n 0.1858 430750.0n 0.8039 430999.9n 0.8039 431000.0n 0.8503 431249.9n 0.8503 431250.0n 0.5067 431499.9n 0.5067 431500.0n 0.5111 431749.9n 0.5111 431750.0n 0.2022 431999.9n 0.2022 432000.0n 0.2156 432249.9n 0.2156 432250.0n 0.5478 432499.9n 0.5478 432500.0n 0.6056 432749.9n 0.6056 432750.0n 0.1021 432999.9n 0.1021 433000.0n 0.5066 433249.9n 0.5066 433250.0n 0.4408 433499.9n 0.4408 433500.0n 0.5341 433749.9n 0.5341 433750.0n 0.1330 433999.9n 0.1330 434000.0n 0.4694 434249.9n 0.4694 434250.0n 0.5884 434499.9n 0.5884 434500.0n 0.1990 434749.9n 0.1990 434750.0n 0.6455 434999.9n 0.6455 435000.0n 0.5210 435249.9n 0.5210 435250.0n 0.2867 435499.9n 0.2867 435500.0n 0.2022 435749.9n 0.2022 435750.0n 0.3040 435999.9n 0.3040 436000.0n 0.1421 436249.9n 0.1421 436250.0n 0.5825 436499.9n 0.5825 436500.0n 0.5066 436749.9n 0.5066 436750.0n 0.5343 436999.9n 0.5343 437000.0n 0.1936 437249.9n 0.1936 437250.0n 0.1712 437499.9n 0.1712 437500.0n 0.6056 437749.9n 0.6056 437750.0n 0.5340 437999.9n 0.5340 438000.0n 0.5341 438249.9n 0.5341 438250.0n 0.5067 438499.9n 0.5067 438500.0n 0.4825 438749.9n 0.4825 438750.0n 0.1858 438999.9n 0.1858 439000.0n 0.6209 439249.9n 0.6209 439250.0n 0.2114 439499.9n 0.2114 439500.0n 0.2156 439749.9n 0.2156 439750.0n 0.5043 439999.9n 0.5043 440000.0n 0.4535 440249.9n 0.4535 440250.0n 0.3727 440499.9n 0.3727 440500.0n 0.4143 440749.9n 0.4143 440750.0n 0.5884 440999.9n 0.5884 441000.0n 0.4694 441249.9n 0.4694 441250.0n 0.2472 441499.9n 0.2472 441500.0n 0.5478 441749.9n 0.5478 441750.0n 0.2439 441999.9n 0.2439 442000.0n 0.2461 442249.9n 0.2461 442250.0n 0.5017 442499.9n 0.5017 442500.0n 0.4495 442749.9n 0.4495 442750.0n 0.6100 442999.9n 0.6100 443000.0n 0.5158 443249.9n 0.5158 443250.0n 0.4856 443499.9n 0.4856 443500.0n 0.5271 443749.9n 0.5271 443750.0n 0.6371 443999.9n 0.6371 444000.0n 0.4158 444249.9n 0.4158 444250.0n 0.4622 444499.9n 0.4622 444500.0n 0.6041 444749.9n 0.6041 444750.0n 0.1328 444999.9n 0.1328 445000.0n 0.4130 445249.9n 0.4130 445250.0n 0.8503 445499.9n 0.8503 445500.0n 0.1990 445749.9n 0.1990 445750.0n 0.8039 445999.9n 0.8039 446000.0n 0.1021 446249.9n 0.1021 446250.0n 0.5723 446499.9n 0.5723 446500.0n 0.3661 446749.9n 0.3661 446750.0n 0.8228 446999.9n 0.8228 447000.0n 0.4529 447249.9n 0.4529 447250.0n 0.1330 447499.9n 0.1330 447500.0n 0.6455 447749.9n 0.6455 447750.0n 0.5628 447999.9n 0.5628 448000.0n 0.8639 448249.9n 0.8639 448250.0n 0.3402 448499.9n 0.3402 448500.0n 0.6052 448749.9n 0.6052 448750.0n 0.2449 448999.9n 0.2449 449000.0n 0.6086 449249.9n 0.6086 449250.0n 0.4408 449499.9n 0.4408 449500.0n 0.7682 449749.9n 0.7682 449750.0n 0.5111 449999.9n 0.5111 450000.0n 0.5589 450249.9n 0.5589 450250.0n 0.7085 450499.9n 0.7085 450500.0n 0.2200 450749.9n 0.2200 450750.0n 0.5654 450999.9n 0.5654 451000.0n 0.5075 451249.9n 0.5075 451250.0n 0.5515 451499.9n 0.5515 451500.0n 0.5060 451749.9n 0.5060 451750.0n 0.6474 451999.9n 0.6474 452000.0n 0.5567 452249.9n 0.5567 452250.0n 0.1268 452499.9n 0.1268 452500.0n 0.1685 452749.9n 0.1685 452750.0n 0.5119 452999.9n 0.5119 453000.0n 0.4482 453249.9n 0.4482 453250.0n 0.4611 453499.9n 0.4611 453500.0n 0.7008 453749.9n 0.7008 453750.0n 0.3395 453999.9n 0.3395 454000.0n 0.7704 454249.9n 0.7704 454250.0n 0.3839 454499.9n 0.3839 454500.0n 0.8817 454749.9n 0.8817 454750.0n 0.4818 454999.9n 0.4818 455000.0n 0.8522 455249.9n 0.8522 455250.0n 0.3906 455499.9n 0.3906 455500.0n 0.7887 455749.9n 0.7887 455750.0n 0.5019 455999.9n 0.5019 456000.0n 0.6096 456249.9n 0.6096 456250.0n 0.3803 456499.9n 0.3803 456500.0n 0.6225 456749.9n 0.6225 456750.0n 0.7898 456999.9n 0.7898 457000.0n 0.2769 457249.9n 0.2769 457250.0n 0.5018 457499.9n 0.5018 457500.0n 0.5223 457749.9n 0.5223 457750.0n 0.1701 457999.9n 0.1701 458000.0n 0.6533 458249.9n 0.6533 458250.0n 0.5795 458499.9n 0.5795 458500.0n 0.5096 458749.9n 0.5096 458750.0n 0.5141 458999.9n 0.5141 459000.0n 0.3540 459249.9n 0.3540 459250.0n 0.6399 459499.9n 0.6399 459500.0n 0.4995 459749.9n 0.4995 459750.0n 0.1728 459999.9n 0.1728 460000.0n 0.4957 460249.9n 0.4957 460250.0n 0.3594 460499.9n 0.3594 460500.0n 0.6177 460749.9n 0.6177 460750.0n 0.1072 460999.9n 0.1072 461000.0n 0.3239 461249.9n 0.3239 461250.0n 0.5585 461499.9n 0.5585 461500.0n 0.5100 461749.9n 0.5100 461750.0n 0.4477 461999.9n 0.4477 462000.0n 0.4816 462249.9n 0.4816 462250.0n 0.5363 462499.9n 0.5363 462500.0n 0.2164 462749.9n 0.2164 462750.0n 0.7663 462999.9n 0.7663 463000.0n 0.5603 463249.9n 0.5603 463250.0n 0.5938 463499.9n 0.5938 463500.0n 0.4899 463749.9n 0.4899 463750.0n 0.4085 463999.9n 0.4085 464000.0n 0.3823 464249.9n 0.3823 464250.0n 0.7841 464499.9n 0.7841 464500.0n 0.4878 464749.9n 0.4878 464750.0n 0.5330 464999.9n 0.5330 465000.0n 0.4502 465249.9n 0.4502 465250.0n 0.5050 465499.9n 0.5050 465500.0n 0.0685 465749.9n 0.0685 465750.0n 0.5339 465999.9n 0.5339 466000.0n 0.5880 466249.9n 0.5880 466250.0n 0.5514 466499.9n 0.5514 466500.0n 0.9168 466749.9n 0.9168 466750.0n 0.7020 466999.9n 0.7020 467000.0n 0.1973 467249.9n 0.1973 467250.0n 0.5466 467499.9n 0.5466 467500.0n 0.4754 467749.9n 0.4754 467750.0n 0.3792 467999.9n 0.3792 468000.0n 0.5330 468249.9n 0.5330 468250.0n 0.6848 468499.9n 0.6848 468500.0n 0.2125 468749.9n 0.2125 468750.0n 0.3074 468999.9n 0.3074 469000.0n 0.4501 469249.9n 0.4501 469250.0n 0.5120 469499.9n 0.5120 469500.0n 0.3498 469749.9n 0.3498 469750.0n 0.3180 469999.9n 0.3180 470000.0n 0.5214 470249.9n 0.5214 470250.0n 0.4969 470499.9n 0.4969 470500.0n 0.5141 470749.9n 0.5141 470750.0n 0.4620 470999.9n 0.4620 471000.0n 0.8209 471249.9n 0.8209 471250.0n 0.4782 471499.9n 0.4782 471500.0n 0.2206 471749.9n 0.2206 471750.0n 0.4205 471999.9n 0.4205 472000.0n 0.8091 472249.9n 0.8091 472250.0n 0.5510 472499.9n 0.5510 472500.0n 0.3225 472749.9n 0.3225 472750.0n 0.5635 472999.9n 0.5635 473000.0n 0.2805 473249.9n 0.2805 473250.0n 0.4832 473499.9n 0.4832 473500.0n 0.5314 473749.9n 0.5314 473750.0n 0.1819 473999.9n 0.1819 474000.0n 0.8042 474249.9n 0.8042 474250.0n 0.7805 474499.9n 0.7805 474500.0n 0.1646 474749.9n 0.1646 474750.0n 0.4513 474999.9n 0.4513 475000.0n 0.5858 475249.9n 0.5858 475250.0n 0.5086 475499.9n 0.5086 475500.0n 0.4907 475749.9n 0.4907 475750.0n 0.5340 475999.9n 0.5340 476000.0n 0.7574 476249.9n 0.7574 476250.0n 0.4996 476499.9n 0.4996 476500.0n 0.2215 476749.9n 0.2215 476750.0n 0.1592 476999.9n 0.1592 477000.0n 0.5877 477249.9n 0.5877 477250.0n 0.4797 477499.9n 0.4797 477500.0n 0.5844 477749.9n 0.5844 477750.0n 0.1436 477999.9n 0.1436 478000.0n 0.3239 478249.9n 0.3239 478250.0n 0.6493 478499.9n 0.6493 478500.0n 0.5008 478749.9n 0.5008 478750.0n 0.4500 478999.9n 0.4500 479000.0n 0.4822 479249.9n 0.4822 479250.0n 0.6777 479499.9n 0.6777 479500.0n 0.5379 479749.9n 0.5379 479750.0n 0.6968)
Vx2n a_xn2 0 PWL(0.0n 0.4842 249.9n 0.4842 250.0n 0.7539 499.9n 0.7539 500.0n 0.5842 749.9n 0.5842 750.0n 0.4957 999.9n 0.4957 1000.0n 0.7133 1249.9n 0.7133 1250.0n 0.4934 1499.9n 0.4934 1500.0n 0.5306 1749.9n 0.5306 1750.0n 0.3629 1999.9n 0.3629 2000.0n 0.4660 2249.9n 0.4660 2250.0n 0.8979 2499.9n 0.8979 2500.0n 0.7978 2749.9n 0.7978 2750.0n 0.7528 2999.9n 0.7528 3000.0n 0.3944 3249.9n 0.3944 3250.0n 0.4659 3499.9n 0.4659 3500.0n 0.4729 3749.9n 0.4729 3750.0n 0.4116 3999.9n 0.4116 4000.0n 0.8672 4249.9n 0.8672 4250.0n 0.7886 4499.9n 0.7886 4500.0n 0.5378 4749.9n 0.5378 4750.0n 0.4889 4999.9n 0.4889 5000.0n 0.1497 5249.9n 0.1497 5250.0n 0.8670 5499.9n 0.8670 5500.0n 0.8064 5749.9n 0.8064 5750.0n 0.6960 5999.9n 0.6960 6000.0n 0.5465 6249.9n 0.5465 6250.0n 0.8579 6499.9n 0.8579 6500.0n 0.3545 6749.9n 0.3545 6750.0n 0.8010 6999.9n 0.8010 7000.0n 0.7844 7249.9n 0.7844 7250.0n 0.5857 7499.9n 0.5857 7500.0n 0.6273 7749.9n 0.6273 7750.0n 0.1961 7999.9n 0.1961 8000.0n 0.8288 8249.9n 0.8288 8250.0n 0.4277 8499.9n 0.4277 8500.0n 0.4790 8749.9n 0.4790 8750.0n 0.5471 8999.9n 0.5471 9000.0n 0.6598 9249.9n 0.6598 9250.0n 0.5144 9499.9n 0.5144 9500.0n 0.4175 9749.9n 0.4175 9750.0n 0.3791 9999.9n 0.3791 10000.0n 0.4983 10249.9n 0.4983 10250.0n 0.5870 10499.9n 0.5870 10500.0n 0.5505 10749.9n 0.5505 10750.0n 0.6339 10999.9n 0.6339 11000.0n 0.4372 11249.9n 0.4372 11250.0n 0.7551 11499.9n 0.7551 11500.0n 0.4933 11749.9n 0.4933 11750.0n 0.5592 11999.9n 0.5592 12000.0n 0.3914 12249.9n 0.3914 12250.0n 0.3900 12499.9n 0.3900 12500.0n 0.3959 12749.9n 0.3959 12750.0n 0.4522 12999.9n 0.4522 13000.0n 0.7561 13249.9n 0.7561 13250.0n 0.4657 13499.9n 0.4657 13500.0n 0.2318 13749.9n 0.2318 13750.0n 0.1772 13999.9n 0.1772 14000.0n 0.1361 14249.9n 0.1361 14250.0n 0.3948 14499.9n 0.3948 14500.0n 0.5175 14749.9n 0.5175 14750.0n 0.8142 14999.9n 0.8142 15000.0n 0.8288 15249.9n 0.8288 15250.0n 0.4277 15499.9n 0.4277 15500.0n 0.7133 15749.9n 0.7133 15750.0n 0.5842 15999.9n 0.5842 16000.0n 0.7886 16249.9n 0.7886 16250.0n 0.5870 16499.9n 0.5870 16500.0n 0.6273 16749.9n 0.6273 16750.0n 0.6960 16999.9n 0.6960 17000.0n 0.4729 17249.9n 0.4729 17250.0n 0.5144 17499.9n 0.5144 17500.0n 0.5592 17749.9n 0.5592 17750.0n 0.1497 17999.9n 0.1497 18000.0n 0.7844 18249.9n 0.7844 18250.0n 0.5505 18499.9n 0.5505 18500.0n 0.3944 18749.9n 0.3944 18750.0n 0.7978 18999.9n 0.7978 19000.0n 0.6598 19249.9n 0.6598 19250.0n 0.1772 19499.9n 0.1772 19500.0n 0.4842 19749.9n 0.4842 19750.0n 0.7528 19999.9n 0.7528 20000.0n 0.3914 20249.9n 0.3914 20250.0n 0.7561 20499.9n 0.7561 20500.0n 0.5471 20749.9n 0.5471 20750.0n 0.3948 20999.9n 0.3948 21000.0n 0.4372 21249.9n 0.4372 21250.0n 0.5175 21499.9n 0.5175 21500.0n 0.4957 21749.9n 0.4957 21750.0n 0.8010 21999.9n 0.8010 22000.0n 0.5465 22249.9n 0.5465 22250.0n 0.5378 22499.9n 0.5378 22500.0n 0.8672 22749.9n 0.8672 22750.0n 0.1361 22999.9n 0.1361 23000.0n 0.4657 23249.9n 0.4657 23250.0n 0.3545 23499.9n 0.3545 23500.0n 0.8979 23749.9n 0.8979 23750.0n 0.4933 23999.9n 0.4933 24000.0n 0.3959 24249.9n 0.3959 24250.0n 0.3791 24499.9n 0.3791 24500.0n 0.4889 24749.9n 0.4889 24750.0n 0.4660 24999.9n 0.4660 25000.0n 0.3629 25249.9n 0.3629 25250.0n 0.4116 25499.9n 0.4116 25500.0n 0.4175 25749.9n 0.4175 25750.0n 0.2318 25999.9n 0.2318 26000.0n 0.6339 26249.9n 0.6339 26250.0n 0.8579 26499.9n 0.8579 26500.0n 0.8670 26749.9n 0.8670 26750.0n 0.4983 26999.9n 0.4983 27000.0n 0.4934 27249.9n 0.4934 27250.0n 0.4522 27499.9n 0.4522 27500.0n 0.5857 27749.9n 0.5857 27750.0n 0.3900 27999.9n 0.3900 28000.0n 0.5306 28249.9n 0.5306 28250.0n 0.7551 28499.9n 0.7551 28500.0n 0.4659 28749.9n 0.4659 28750.0n 0.7539 28999.9n 0.7539 29000.0n 0.8064 29249.9n 0.8064 29250.0n 0.8142 29499.9n 0.8142 29500.0n 0.1961 29749.9n 0.1961 29750.0n 0.4790 29999.9n 0.4790 30000.0n 0.4790 30249.9n 0.4790 30250.0n 0.8979 30499.9n 0.8979 30500.0n 0.8579 30749.9n 0.8579 30750.0n 0.5505 30999.9n 0.5505 31000.0n 0.4277 31249.9n 0.4277 31250.0n 0.4933 31499.9n 0.4933 31500.0n 0.8064 31749.9n 0.8064 31750.0n 0.1497 31999.9n 0.1497 32000.0n 0.7528 32249.9n 0.7528 32250.0n 0.7978 32499.9n 0.7978 32500.0n 0.7133 32749.9n 0.7133 32750.0n 0.5378 32999.9n 0.5378 33000.0n 0.6598 33249.9n 0.6598 33250.0n 0.5144 33499.9n 0.5144 33500.0n 0.7551 33749.9n 0.7551 33750.0n 0.7539 33999.9n 0.7539 34000.0n 0.1361 34249.9n 0.1361 34250.0n 0.3791 34499.9n 0.3791 34500.0n 0.5592 34749.9n 0.5592 34750.0n 0.1961 34999.9n 0.1961 35000.0n 0.5175 35249.9n 0.5175 35250.0n 0.7844 35499.9n 0.7844 35500.0n 0.3900 35749.9n 0.3900 35750.0n 0.4983 35999.9n 0.4983 36000.0n 0.5857 36249.9n 0.5857 36250.0n 0.4889 36499.9n 0.4889 36500.0n 0.3629 36749.9n 0.3629 36750.0n 0.1772 36999.9n 0.1772 37000.0n 0.3944 37249.9n 0.3944 37250.0n 0.4657 37499.9n 0.4657 37500.0n 0.8288 37749.9n 0.8288 37750.0n 0.4660 37999.9n 0.4660 38000.0n 0.3959 38249.9n 0.3959 38250.0n 0.8142 38499.9n 0.8142 38500.0n 0.3948 38749.9n 0.3948 38750.0n 0.8672 38999.9n 0.8672 39000.0n 0.8010 39249.9n 0.8010 39250.0n 0.6960 39499.9n 0.6960 39500.0n 0.4729 39749.9n 0.4729 39750.0n 0.5870 39999.9n 0.5870 40000.0n 0.5471 40249.9n 0.5471 40250.0n 0.2318 40499.9n 0.2318 40500.0n 0.6273 40749.9n 0.6273 40750.0n 0.4659 40999.9n 0.4659 41000.0n 0.5306 41249.9n 0.5306 41250.0n 0.8670 41499.9n 0.8670 41500.0n 0.3545 41749.9n 0.3545 41750.0n 0.4957 41999.9n 0.4957 42000.0n 0.4842 42249.9n 0.4842 42250.0n 0.6339 42499.9n 0.6339 42500.0n 0.4116 42749.9n 0.4116 42750.0n 0.4522 42999.9n 0.4522 43000.0n 0.4175 43249.9n 0.4175 43250.0n 0.4934 43499.9n 0.4934 43500.0n 0.7561 43749.9n 0.7561 43750.0n 0.5842 43999.9n 0.5842 44000.0n 0.7886 44249.9n 0.7886 44250.0n 0.4372 44499.9n 0.4372 44500.0n 0.3914 44749.9n 0.3914 44750.0n 0.5465 44999.9n 0.5465 45000.0n 0.5471 45249.9n 0.5471 45250.0n 0.4889 45499.9n 0.4889 45500.0n 0.5592 45749.9n 0.5592 45750.0n 0.8979 45999.9n 0.8979 46000.0n 0.4277 46249.9n 0.4277 46250.0n 0.4729 46499.9n 0.4729 46500.0n 0.4842 46749.9n 0.4842 46750.0n 0.3948 46999.9n 0.3948 47000.0n 0.5857 47249.9n 0.5857 47250.0n 0.4116 47499.9n 0.4116 47500.0n 0.7978 47749.9n 0.7978 47750.0n 0.4659 47999.9n 0.4659 48000.0n 0.3959 48249.9n 0.3959 48250.0n 0.1497 48499.9n 0.1497 48500.0n 0.6960 48749.9n 0.6960 48750.0n 0.4957 48999.9n 0.4957 49000.0n 0.4933 49249.9n 0.4933 49250.0n 0.5306 49499.9n 0.5306 49500.0n 0.1961 49749.9n 0.1961 49750.0n 0.2318 49999.9n 0.2318 50000.0n 0.4790 50249.9n 0.4790 50250.0n 0.8672 50499.9n 0.8672 50500.0n 0.7551 50749.9n 0.7551 50750.0n 0.3944 50999.9n 0.3944 51000.0n 0.7844 51249.9n 0.7844 51250.0n 0.3629 51499.9n 0.3629 51500.0n 0.7886 51749.9n 0.7886 51750.0n 0.8064 51999.9n 0.8064 52000.0n 0.5842 52249.9n 0.5842 52250.0n 0.3914 52499.9n 0.3914 52500.0n 0.5465 52749.9n 0.5465 52750.0n 0.1361 52999.9n 0.1361 53000.0n 0.4934 53249.9n 0.4934 53250.0n 0.5175 53499.9n 0.5175 53500.0n 0.4660 53749.9n 0.4660 53750.0n 0.8288 53999.9n 0.8288 54000.0n 0.5378 54249.9n 0.5378 54250.0n 0.6339 54499.9n 0.6339 54500.0n 0.4522 54749.9n 0.4522 54750.0n 0.5505 54999.9n 0.5505 55000.0n 0.1772 55249.9n 0.1772 55250.0n 0.3900 55499.9n 0.3900 55500.0n 0.7528 55749.9n 0.7528 55750.0n 0.3545 55999.9n 0.3545 56000.0n 0.6598 56249.9n 0.6598 56250.0n 0.3791 56499.9n 0.3791 56500.0n 0.8142 56749.9n 0.8142 56750.0n 0.4175 56999.9n 0.4175 57000.0n 0.7539 57249.9n 0.7539 57250.0n 0.7133 57499.9n 0.7133 57500.0n 0.4983 57749.9n 0.4983 57750.0n 0.8010 57999.9n 0.8010 58000.0n 0.5144 58249.9n 0.5144 58250.0n 0.6273 58499.9n 0.6273 58500.0n 0.8579 58749.9n 0.8579 58750.0n 0.4657 58999.9n 0.4657 59000.0n 0.5870 59249.9n 0.5870 59250.0n 0.4372 59499.9n 0.4372 59500.0n 0.7561 59749.9n 0.7561 59750.0n 0.8670 59999.9n 0.8670 60000.0n 0.4659 60249.9n 0.4659 60250.0n 0.5175 60499.9n 0.5175 60500.0n 0.4657 60749.9n 0.4657 60750.0n 0.8579 60999.9n 0.8579 61000.0n 0.7978 61249.9n 0.7978 61250.0n 0.4933 61499.9n 0.4933 61500.0n 0.3791 61749.9n 0.3791 61750.0n 0.5505 61999.9n 0.5505 62000.0n 0.8672 62249.9n 0.8672 62250.0n 0.5857 62499.9n 0.5857 62500.0n 0.4934 62749.9n 0.4934 62750.0n 0.4277 62999.9n 0.4277 63000.0n 0.7844 63249.9n 0.7844 63250.0n 0.5378 63499.9n 0.5378 63500.0n 0.3900 63749.9n 0.3900 63750.0n 0.4957 63999.9n 0.4957 64000.0n 0.6273 64249.9n 0.6273 64250.0n 0.4522 64499.9n 0.4522 64500.0n 0.2318 64749.9n 0.2318 64750.0n 0.5465 64999.9n 0.5465 65000.0n 0.1361 65249.9n 0.1361 65250.0n 0.5144 65499.9n 0.5144 65500.0n 0.4983 65749.9n 0.4983 65750.0n 0.7886 65999.9n 0.7886 66000.0n 0.4660 66249.9n 0.4660 66250.0n 0.7539 66499.9n 0.7539 66500.0n 0.3914 66749.9n 0.3914 66750.0n 0.5306 66999.9n 0.5306 67000.0n 0.8010 67249.9n 0.8010 67250.0n 0.5870 67499.9n 0.5870 67500.0n 0.8064 67749.9n 0.8064 67750.0n 0.6960 67999.9n 0.6960 68000.0n 0.3959 68249.9n 0.3959 68250.0n 0.3944 68499.9n 0.3944 68500.0n 0.1497 68749.9n 0.1497 68750.0n 0.8142 68999.9n 0.8142 69000.0n 0.1961 69249.9n 0.1961 69250.0n 0.6339 69499.9n 0.6339 69500.0n 0.4116 69749.9n 0.4116 69750.0n 0.7133 69999.9n 0.7133 70000.0n 0.5842 70249.9n 0.5842 70250.0n 0.4729 70499.9n 0.4729 70500.0n 0.3629 70749.9n 0.3629 70750.0n 0.4372 70999.9n 0.4372 71000.0n 0.4175 71249.9n 0.4175 71250.0n 0.4889 71499.9n 0.4889 71500.0n 0.6598 71749.9n 0.6598 71750.0n 0.4842 71999.9n 0.4842 72000.0n 0.8670 72249.9n 0.8670 72250.0n 0.7528 72499.9n 0.7528 72500.0n 0.8288 72749.9n 0.8288 72750.0n 0.7561 72999.9n 0.7561 73000.0n 0.1772 73249.9n 0.1772 73250.0n 0.5592 73499.9n 0.5592 73500.0n 0.5471 73749.9n 0.5471 73750.0n 0.3948 73999.9n 0.3948 74000.0n 0.8979 74249.9n 0.8979 74250.0n 0.7551 74499.9n 0.7551 74500.0n 0.3545 74749.9n 0.3545 74750.0n 0.4790 74999.9n 0.4790 75000.0n 0.3944 75249.9n 0.3944 75250.0n 0.3914 75499.9n 0.3914 75500.0n 0.7844 75749.9n 0.7844 75750.0n 0.4889 75999.9n 0.4889 76000.0n 0.7886 76249.9n 0.7886 76250.0n 0.5175 76499.9n 0.5175 76500.0n 0.7978 76749.9n 0.7978 76750.0n 0.4729 76999.9n 0.4729 77000.0n 0.4522 77249.9n 0.4522 77250.0n 0.4842 77499.9n 0.4842 77500.0n 0.5857 77749.9n 0.5857 77750.0n 0.8288 77999.9n 0.8288 78000.0n 0.4983 78249.9n 0.4983 78250.0n 0.7561 78499.9n 0.7561 78500.0n 0.7551 78749.9n 0.7551 78750.0n 0.4660 78999.9n 0.4660 79000.0n 0.3791 79249.9n 0.3791 79250.0n 0.5505 79499.9n 0.5505 79500.0n 0.3900 79749.9n 0.3900 79750.0n 0.1772 79999.9n 0.1772 80000.0n 0.3948 80249.9n 0.3948 80250.0n 0.8010 80499.9n 0.8010 80500.0n 0.1497 80749.9n 0.1497 80750.0n 0.4957 80999.9n 0.4957 81000.0n 0.2318 81249.9n 0.2318 81250.0n 0.4933 81499.9n 0.4933 81500.0n 0.1361 81749.9n 0.1361 81750.0n 0.8579 81999.9n 0.8579 82000.0n 0.5144 82249.9n 0.5144 82250.0n 0.4659 82499.9n 0.4659 82500.0n 0.4934 82749.9n 0.4934 82750.0n 0.5471 82999.9n 0.5471 83000.0n 0.5378 83249.9n 0.5378 83250.0n 0.6273 83499.9n 0.6273 83500.0n 0.6960 83749.9n 0.6960 83750.0n 0.5592 83999.9n 0.5592 84000.0n 0.3629 84249.9n 0.3629 84250.0n 0.4175 84499.9n 0.4175 84500.0n 0.8979 84749.9n 0.8979 84750.0n 0.4277 84999.9n 0.4277 85000.0n 0.7528 85249.9n 0.7528 85250.0n 0.8670 85499.9n 0.8670 85500.0n 0.3545 85749.9n 0.3545 85750.0n 0.7133 85999.9n 0.7133 86000.0n 0.5306 86249.9n 0.5306 86250.0n 0.4372 86499.9n 0.4372 86500.0n 0.5465 86749.9n 0.5465 86750.0n 0.1961 86999.9n 0.1961 87000.0n 0.6598 87249.9n 0.6598 87250.0n 0.7539 87499.9n 0.7539 87500.0n 0.4657 87749.9n 0.4657 87750.0n 0.8142 87999.9n 0.8142 88000.0n 0.8672 88249.9n 0.8672 88250.0n 0.8064 88499.9n 0.8064 88500.0n 0.6339 88749.9n 0.6339 88750.0n 0.5842 88999.9n 0.5842 89000.0n 0.4790 89249.9n 0.4790 89250.0n 0.4116 89499.9n 0.4116 89500.0n 0.3959 89749.9n 0.3959 89750.0n 0.5870 89999.9n 0.5870 90000.0n 0.1497 90249.9n 0.1497 90250.0n 0.4729 90499.9n 0.4729 90500.0n 0.2318 90749.9n 0.2318 90750.0n 0.1961 90999.9n 0.1961 91000.0n 0.8979 91249.9n 0.8979 91250.0n 0.8010 91499.9n 0.8010 91500.0n 0.5471 91749.9n 0.5471 91750.0n 0.4659 91999.9n 0.4659 92000.0n 0.7539 92249.9n 0.7539 92250.0n 0.5175 92499.9n 0.5175 92500.0n 0.7886 92749.9n 0.7886 92750.0n 0.4957 92999.9n 0.4957 93000.0n 0.4983 93249.9n 0.4983 93250.0n 0.8672 93499.9n 0.8672 93500.0n 0.4934 93749.9n 0.4934 93750.0n 0.7561 93999.9n 0.7561 94000.0n 0.3629 94249.9n 0.3629 94250.0n 0.5870 94499.9n 0.5870 94500.0n 0.4889 94749.9n 0.4889 94750.0n 0.8064 94999.9n 0.8064 95000.0n 0.6273 95249.9n 0.6273 95250.0n 0.6960 95499.9n 0.6960 95500.0n 0.3545 95749.9n 0.3545 95750.0n 0.5378 95999.9n 0.5378 96000.0n 0.4277 96249.9n 0.4277 96250.0n 0.7528 96499.9n 0.7528 96500.0n 0.4372 96749.9n 0.4372 96750.0n 0.8670 96999.9n 0.8670 97000.0n 0.3948 97249.9n 0.3948 97250.0n 0.1361 97499.9n 0.1361 97500.0n 0.4790 97749.9n 0.4790 97750.0n 0.3914 97999.9n 0.3914 98000.0n 0.4522 98249.9n 0.4522 98250.0n 0.7551 98499.9n 0.7551 98500.0n 0.4933 98749.9n 0.4933 98750.0n 0.4660 98999.9n 0.4660 99000.0n 0.6598 99249.9n 0.6598 99250.0n 0.7133 99499.9n 0.7133 99500.0n 0.4657 99749.9n 0.4657 99750.0n 0.3944 99999.9n 0.3944 100000.0n 0.5306 100249.9n 0.5306 100250.0n 0.8288 100499.9n 0.8288 100500.0n 0.5505 100749.9n 0.5505 100750.0n 0.7844 100999.9n 0.7844 101000.0n 0.4175 101249.9n 0.4175 101250.0n 0.5592 101499.9n 0.5592 101500.0n 0.7978 101749.9n 0.7978 101750.0n 0.4842 101999.9n 0.4842 102000.0n 0.4116 102249.9n 0.4116 102250.0n 0.6339 102499.9n 0.6339 102500.0n 0.8579 102749.9n 0.8579 102750.0n 0.5465 102999.9n 0.5465 103000.0n 0.5842 103249.9n 0.5842 103250.0n 0.3791 103499.9n 0.3791 103500.0n 0.3959 103749.9n 0.3959 103750.0n 0.5857 103999.9n 0.5857 104000.0n 0.5144 104249.9n 0.5144 104250.0n 0.8142 104499.9n 0.8142 104500.0n 0.3900 104749.9n 0.3900 104750.0n 0.1772 104999.9n 0.1772 105000.0n 0.4934 105249.9n 0.4934 105250.0n 0.7886 105499.9n 0.7886 105500.0n 0.5378 105749.9n 0.5378 105750.0n 0.4842 105999.9n 0.4842 106000.0n 0.8979 106249.9n 0.8979 106250.0n 0.7978 106499.9n 0.7978 106500.0n 0.3948 106749.9n 0.3948 106750.0n 0.8064 106999.9n 0.8064 107000.0n 0.5306 107249.9n 0.5306 107250.0n 0.4957 107499.9n 0.4957 107500.0n 0.4983 107749.9n 0.4983 107750.0n 0.5471 107999.9n 0.5471 108000.0n 0.6273 108249.9n 0.6273 108250.0n 0.6960 108499.9n 0.6960 108500.0n 0.2318 108749.9n 0.2318 108750.0n 0.8670 108999.9n 0.8670 109000.0n 0.5870 109249.9n 0.5870 109250.0n 0.5505 109499.9n 0.5505 109500.0n 0.4657 109749.9n 0.4657 109750.0n 0.4933 109999.9n 0.4933 110000.0n 0.4522 110249.9n 0.4522 110250.0n 0.5592 110499.9n 0.5592 110500.0n 0.4729 110749.9n 0.4729 110750.0n 0.3944 110999.9n 0.3944 111000.0n 0.5857 111249.9n 0.5857 111250.0n 0.7539 111499.9n 0.7539 111500.0n 0.8579 111749.9n 0.8579 111750.0n 0.6598 111999.9n 0.6598 112000.0n 0.8142 112249.9n 0.8142 112250.0n 0.5465 112499.9n 0.5465 112500.0n 0.7551 112749.9n 0.7551 112750.0n 0.5144 112999.9n 0.5144 113000.0n 0.8288 113249.9n 0.8288 113250.0n 0.7561 113499.9n 0.7561 113500.0n 0.3545 113749.9n 0.3545 113750.0n 0.4277 113999.9n 0.4277 114000.0n 0.3914 114249.9n 0.3914 114250.0n 0.4116 114499.9n 0.4116 114500.0n 0.4659 114749.9n 0.4659 114750.0n 0.4175 114999.9n 0.4175 115000.0n 0.3629 115249.9n 0.3629 115250.0n 0.4372 115499.9n 0.4372 115500.0n 0.7844 115749.9n 0.7844 115750.0n 0.1772 115999.9n 0.1772 116000.0n 0.6339 116249.9n 0.6339 116250.0n 0.4660 116499.9n 0.4660 116500.0n 0.8672 116749.9n 0.8672 116750.0n 0.7528 116999.9n 0.7528 117000.0n 0.3791 117249.9n 0.3791 117250.0n 0.3959 117499.9n 0.3959 117500.0n 0.4889 117749.9n 0.4889 117750.0n 0.5175 117999.9n 0.5175 118000.0n 0.8010 118249.9n 0.8010 118250.0n 0.4790 118499.9n 0.4790 118500.0n 0.1961 118749.9n 0.1961 118750.0n 0.5842 118999.9n 0.5842 119000.0n 0.7133 119249.9n 0.7133 119250.0n 0.3900 119499.9n 0.3900 119500.0n 0.1497 119749.9n 0.1497 119750.0n 0.1361 119999.9n 0.1361 120000.0n 0.5471 120249.9n 0.5471 120250.0n 0.8979 120499.9n 0.8979 120500.0n 0.8064 120749.9n 0.8064 120750.0n 0.4933 120999.9n 0.4933 121000.0n 0.8670 121249.9n 0.8670 121250.0n 0.3629 121499.9n 0.3629 121500.0n 0.6339 121749.9n 0.6339 121750.0n 0.8142 121999.9n 0.8142 122000.0n 0.4790 122249.9n 0.4790 122250.0n 0.5857 122499.9n 0.5857 122500.0n 0.4522 122749.9n 0.4522 122750.0n 0.3944 122999.9n 0.3944 123000.0n 0.7561 123249.9n 0.7561 123250.0n 0.4116 123499.9n 0.4116 123500.0n 0.4983 123749.9n 0.4983 123750.0n 0.4660 123999.9n 0.4660 124000.0n 0.4729 124249.9n 0.4729 124250.0n 0.4889 124499.9n 0.4889 124500.0n 0.4842 124749.9n 0.4842 124750.0n 0.3959 124999.9n 0.3959 125000.0n 0.4175 125249.9n 0.4175 125250.0n 0.1961 125499.9n 0.1961 125500.0n 0.3900 125749.9n 0.3900 125750.0n 0.7133 125999.9n 0.7133 126000.0n 0.5378 126249.9n 0.5378 126250.0n 0.7978 126499.9n 0.7978 126500.0n 0.5505 126749.9n 0.5505 126750.0n 0.2318 126999.9n 0.2318 127000.0n 0.3948 127249.9n 0.3948 127250.0n 0.4372 127499.9n 0.4372 127500.0n 0.5175 127749.9n 0.5175 127750.0n 0.4277 127999.9n 0.4277 128000.0n 0.1497 128249.9n 0.1497 128250.0n 0.6598 128499.9n 0.6598 128500.0n 0.5842 128749.9n 0.5842 128750.0n 0.8010 128999.9n 0.8010 129000.0n 0.7528 129249.9n 0.7528 129250.0n 0.4659 129499.9n 0.4659 129500.0n 0.1361 129749.9n 0.1361 129750.0n 0.7844 129999.9n 0.7844 130000.0n 0.8288 130249.9n 0.8288 130250.0n 0.3545 130499.9n 0.3545 130500.0n 0.4957 130749.9n 0.4957 130750.0n 0.5592 130999.9n 0.5592 131000.0n 0.7886 131249.9n 0.7886 131250.0n 0.4934 131499.9n 0.4934 131500.0n 0.5465 131749.9n 0.5465 131750.0n 0.3791 131999.9n 0.3791 132000.0n 0.5306 132249.9n 0.5306 132250.0n 0.5144 132499.9n 0.5144 132500.0n 0.7551 132749.9n 0.7551 132750.0n 0.6273 132999.9n 0.6273 133000.0n 0.3914 133249.9n 0.3914 133250.0n 0.6960 133499.9n 0.6960 133500.0n 0.4657 133749.9n 0.4657 133750.0n 0.1772 133999.9n 0.1772 134000.0n 0.7539 134249.9n 0.7539 134250.0n 0.5870 134499.9n 0.5870 134500.0n 0.8579 134749.9n 0.8579 134750.0n 0.8672 134999.9n 0.8672 135000.0n 0.7844 135249.9n 0.7844 135250.0n 0.4660 135499.9n 0.4660 135500.0n 0.8979 135749.9n 0.8979 135750.0n 0.4729 135999.9n 0.4729 136000.0n 0.5306 136249.9n 0.5306 136250.0n 0.4842 136499.9n 0.4842 136500.0n 0.4116 136749.9n 0.4116 136750.0n 0.4790 136999.9n 0.4790 137000.0n 0.5505 137249.9n 0.5505 137250.0n 0.4889 137499.9n 0.4889 137500.0n 0.8672 137749.9n 0.8672 137750.0n 0.5378 137999.9n 0.5378 138000.0n 0.7539 138249.9n 0.7539 138250.0n 0.7978 138499.9n 0.7978 138500.0n 0.4372 138749.9n 0.4372 138750.0n 0.3791 138999.9n 0.3791 139000.0n 0.4957 139249.9n 0.4957 139250.0n 0.4657 139499.9n 0.4657 139500.0n 0.6960 139749.9n 0.6960 139750.0n 0.5175 139999.9n 0.5175 140000.0n 0.7561 140249.9n 0.7561 140250.0n 0.8288 140499.9n 0.8288 140500.0n 0.5465 140749.9n 0.5465 140750.0n 0.3629 140999.9n 0.3629 141000.0n 0.5870 141249.9n 0.5870 141250.0n 0.5471 141499.9n 0.5471 141500.0n 0.4933 141749.9n 0.4933 141750.0n 0.3959 141999.9n 0.3959 142000.0n 0.3900 142249.9n 0.3900 142250.0n 0.6598 142499.9n 0.6598 142500.0n 0.5842 142749.9n 0.5842 142750.0n 0.6273 142999.9n 0.6273 143000.0n 0.8064 143249.9n 0.8064 143250.0n 0.8579 143499.9n 0.8579 143500.0n 0.4659 143749.9n 0.4659 143750.0n 0.1497 143999.9n 0.1497 144000.0n 0.5592 144249.9n 0.5592 144250.0n 0.4277 144499.9n 0.4277 144500.0n 0.3944 144749.9n 0.3944 144750.0n 0.4934 144999.9n 0.4934 145000.0n 0.1961 145249.9n 0.1961 145250.0n 0.7133 145499.9n 0.7133 145500.0n 0.3914 145749.9n 0.3914 145750.0n 0.7886 145999.9n 0.7886 146000.0n 0.2318 146249.9n 0.2318 146250.0n 0.1772 146499.9n 0.1772 146500.0n 0.7528 146749.9n 0.7528 146750.0n 0.3545 146999.9n 0.3545 147000.0n 0.4522 147249.9n 0.4522 147250.0n 0.6339 147499.9n 0.6339 147500.0n 0.1361 147749.9n 0.1361 147750.0n 0.5144 147999.9n 0.5144 148000.0n 0.8142 148249.9n 0.8142 148250.0n 0.8670 148499.9n 0.8670 148500.0n 0.7551 148749.9n 0.7551 148750.0n 0.3948 148999.9n 0.3948 149000.0n 0.4175 149249.9n 0.4175 149250.0n 0.5857 149499.9n 0.5857 149500.0n 0.8010 149749.9n 0.8010 149750.0n 0.4983 149999.9n 0.4983 150000.0n 0.5505 150249.9n 0.5505 150250.0n 0.4842 150499.9n 0.4842 150500.0n 0.8142 150749.9n 0.8142 150750.0n 0.1361 150999.9n 0.1361 151000.0n 0.1961 151249.9n 0.1961 151250.0n 0.5592 151499.9n 0.5592 151500.0n 0.8010 151749.9n 0.8010 151750.0n 0.3914 151999.9n 0.3914 152000.0n 0.5842 152249.9n 0.5842 152250.0n 0.8979 152499.9n 0.8979 152500.0n 0.7551 152749.9n 0.7551 152750.0n 0.7886 152999.9n 0.7886 153000.0n 0.8670 153249.9n 0.8670 153250.0n 0.6339 153499.9n 0.6339 153500.0n 0.4983 153749.9n 0.4983 153750.0n 0.4657 153999.9n 0.4657 154000.0n 0.3791 154249.9n 0.3791 154250.0n 0.4175 154499.9n 0.4175 154500.0n 0.5465 154749.9n 0.5465 154750.0n 0.6598 154999.9n 0.6598 155000.0n 0.4522 155249.9n 0.4522 155250.0n 0.3959 155499.9n 0.3959 155500.0n 0.1497 155749.9n 0.1497 155750.0n 0.5857 155999.9n 0.5857 156000.0n 0.4116 156249.9n 0.4116 156250.0n 0.4660 156499.9n 0.4660 156500.0n 0.5144 156749.9n 0.5144 156750.0n 0.4659 156999.9n 0.4659 157000.0n 0.4372 157249.9n 0.4372 157250.0n 0.7528 157499.9n 0.7528 157500.0n 0.1772 157749.9n 0.1772 157750.0n 0.6960 157999.9n 0.6960 158000.0n 0.5870 158249.9n 0.5870 158250.0n 0.7539 158499.9n 0.7539 158500.0n 0.5471 158749.9n 0.5471 158750.0n 0.5378 158999.9n 0.5378 159000.0n 0.4790 159249.9n 0.4790 159250.0n 0.4934 159499.9n 0.4934 159500.0n 0.3900 159749.9n 0.3900 159750.0n 0.6273 159999.9n 0.6273 160000.0n 0.2318 160249.9n 0.2318 160250.0n 0.3948 160499.9n 0.3948 160500.0n 0.8672 160749.9n 0.8672 160750.0n 0.4957 160999.9n 0.4957 161000.0n 0.4933 161249.9n 0.4933 161250.0n 0.4277 161499.9n 0.4277 161500.0n 0.3545 161749.9n 0.3545 161750.0n 0.7978 161999.9n 0.7978 162000.0n 0.4889 162249.9n 0.4889 162250.0n 0.7561 162499.9n 0.7561 162500.0n 0.3629 162749.9n 0.3629 162750.0n 0.8579 162999.9n 0.8579 163000.0n 0.8064 163249.9n 0.8064 163250.0n 0.3944 163499.9n 0.3944 163500.0n 0.7133 163749.9n 0.7133 163750.0n 0.4729 163999.9n 0.4729 164000.0n 0.5175 164249.9n 0.5175 164250.0n 0.7844 164499.9n 0.7844 164500.0n 0.5306 164749.9n 0.5306 164750.0n 0.8288 164999.9n 0.8288 165000.0n 0.4522 165249.9n 0.4522 165250.0n 0.8672 165499.9n 0.8672 165500.0n 0.1961 165749.9n 0.1961 165750.0n 0.3900 165999.9n 0.3900 166000.0n 0.5592 166249.9n 0.5592 166250.0n 0.7561 166499.9n 0.7561 166500.0n 0.2318 166749.9n 0.2318 166750.0n 0.7886 166999.9n 0.7886 167000.0n 0.4790 167249.9n 0.4790 167250.0n 0.3948 167499.9n 0.3948 167500.0n 0.3545 167749.9n 0.3545 167750.0n 0.4983 167999.9n 0.4983 168000.0n 0.4175 168249.9n 0.4175 168250.0n 0.5857 168499.9n 0.5857 168500.0n 0.5471 168749.9n 0.5471 168750.0n 0.8010 168999.9n 0.8010 169000.0n 0.5175 169249.9n 0.5175 169250.0n 0.7528 169499.9n 0.7528 169500.0n 0.3629 169749.9n 0.3629 169750.0n 0.6339 169999.9n 0.6339 170000.0n 0.4372 170249.9n 0.4372 170250.0n 0.5842 170499.9n 0.5842 170500.0n 0.4729 170749.9n 0.4729 170750.0n 0.1361 170999.9n 0.1361 171000.0n 0.7551 171249.9n 0.7551 171250.0n 0.5465 171499.9n 0.5465 171500.0n 0.4660 171749.9n 0.4660 171750.0n 0.5870 171999.9n 0.5870 172000.0n 0.8579 172249.9n 0.8579 172250.0n 0.7539 172499.9n 0.7539 172500.0n 0.5144 172749.9n 0.5144 172750.0n 0.6598 172999.9n 0.6598 173000.0n 0.4842 173249.9n 0.4842 173250.0n 0.8288 173499.9n 0.8288 173500.0n 0.3914 173749.9n 0.3914 173750.0n 0.8979 173999.9n 0.8979 174000.0n 0.1497 174249.9n 0.1497 174250.0n 0.7844 174499.9n 0.7844 174500.0n 0.3791 174749.9n 0.3791 174750.0n 0.4116 174999.9n 0.4116 175000.0n 0.5378 175249.9n 0.5378 175250.0n 0.4933 175499.9n 0.4933 175500.0n 0.4657 175749.9n 0.4657 175750.0n 0.3944 175999.9n 0.3944 176000.0n 0.6960 176249.9n 0.6960 176250.0n 0.7133 176499.9n 0.7133 176500.0n 0.8142 176749.9n 0.8142 176750.0n 0.7978 176999.9n 0.7978 177000.0n 0.6273 177249.9n 0.6273 177250.0n 0.4889 177499.9n 0.4889 177500.0n 0.3959 177749.9n 0.3959 177750.0n 0.4934 177999.9n 0.4934 178000.0n 0.4659 178249.9n 0.4659 178250.0n 0.5306 178499.9n 0.5306 178500.0n 0.8670 178749.9n 0.8670 178750.0n 0.8064 178999.9n 0.8064 179000.0n 0.4957 179249.9n 0.4957 179250.0n 0.5505 179499.9n 0.5505 179500.0n 0.1772 179749.9n 0.1772 179750.0n 0.4277 179999.9n 0.4277 180000.0n 0.4175 180249.9n 0.4175 180250.0n 0.3791 180499.9n 0.3791 180500.0n 0.3959 180749.9n 0.3959 180750.0n 0.4729 180999.9n 0.4729 181000.0n 0.7561 181249.9n 0.7561 181250.0n 0.5378 181499.9n 0.5378 181500.0n 0.4522 181749.9n 0.4522 181750.0n 0.8579 181999.9n 0.8579 182000.0n 0.1772 182249.9n 0.1772 182250.0n 0.7978 182499.9n 0.7978 182500.0n 0.5870 182749.9n 0.5870 182750.0n 0.6598 182999.9n 0.6598 183000.0n 0.8288 183249.9n 0.8288 183250.0n 0.8979 183499.9n 0.8979 183500.0n 0.4277 183749.9n 0.4277 183750.0n 0.1361 183999.9n 0.1361 184000.0n 0.6339 184249.9n 0.6339 184250.0n 0.7886 184499.9n 0.7886 184500.0n 0.3900 184749.9n 0.3900 184750.0n 0.5144 184999.9n 0.5144 185000.0n 0.3948 185249.9n 0.3948 185250.0n 0.3944 185499.9n 0.3944 185500.0n 0.8064 185749.9n 0.8064 185750.0n 0.8670 185999.9n 0.8670 186000.0n 0.5175 186249.9n 0.5175 186250.0n 0.5465 186499.9n 0.5465 186500.0n 0.7528 186749.9n 0.7528 186750.0n 0.1497 186999.9n 0.1497 187000.0n 0.7551 187249.9n 0.7551 187250.0n 0.4660 187499.9n 0.4660 187500.0n 0.5471 187749.9n 0.5471 187750.0n 0.7133 187999.9n 0.7133 188000.0n 0.6960 188249.9n 0.6960 188250.0n 0.4842 188499.9n 0.4842 188500.0n 0.4790 188749.9n 0.4790 188750.0n 0.4983 188999.9n 0.4983 189000.0n 0.4116 189249.9n 0.4116 189250.0n 0.3629 189499.9n 0.3629 189500.0n 0.4957 189749.9n 0.4957 189750.0n 0.5592 189999.9n 0.5592 190000.0n 0.8010 190249.9n 0.8010 190250.0n 0.4657 190499.9n 0.4657 190500.0n 0.1961 190749.9n 0.1961 190750.0n 0.3914 190999.9n 0.3914 191000.0n 0.7539 191249.9n 0.7539 191250.0n 0.5306 191499.9n 0.5306 191500.0n 0.2318 191749.9n 0.2318 191750.0n 0.4889 191999.9n 0.4889 192000.0n 0.3545 192249.9n 0.3545 192250.0n 0.7844 192499.9n 0.7844 192500.0n 0.4372 192749.9n 0.4372 192750.0n 0.8142 192999.9n 0.8142 193000.0n 0.4933 193249.9n 0.4933 193250.0n 0.6273 193499.9n 0.6273 193500.0n 0.4934 193749.9n 0.4934 193750.0n 0.4659 193999.9n 0.4659 194000.0n 0.5505 194249.9n 0.5505 194250.0n 0.8672 194499.9n 0.8672 194500.0n 0.5857 194749.9n 0.5857 194750.0n 0.5842 194999.9n 0.5842 195000.0n 0.5592 195249.9n 0.5592 195250.0n 0.3944 195499.9n 0.3944 195500.0n 0.8142 195749.9n 0.8142 195750.0n 0.7528 195999.9n 0.7528 196000.0n 0.4659 196249.9n 0.4659 196250.0n 0.4790 196499.9n 0.4790 196500.0n 0.1497 196749.9n 0.1497 196750.0n 0.7886 196999.9n 0.7886 197000.0n 0.2318 197249.9n 0.2318 197250.0n 0.4957 197499.9n 0.4957 197500.0n 0.4934 197749.9n 0.4934 197750.0n 0.3545 197999.9n 0.3545 198000.0n 0.5857 198249.9n 0.5857 198250.0n 0.3914 198499.9n 0.3914 198500.0n 0.3948 198749.9n 0.3948 198750.0n 0.3629 198999.9n 0.3629 199000.0n 0.4889 199249.9n 0.4889 199250.0n 0.7844 199499.9n 0.7844 199500.0n 0.5471 199749.9n 0.5471 199750.0n 0.4175 199999.9n 0.4175 200000.0n 0.5306 200249.9n 0.5306 200250.0n 0.4660 200499.9n 0.4660 200500.0n 0.1772 200749.9n 0.1772 200750.0n 0.8064 200999.9n 0.8064 201000.0n 0.5505 201249.9n 0.5505 201250.0n 0.4372 201499.9n 0.4372 201500.0n 0.4729 201749.9n 0.4729 201750.0n 0.6960 201999.9n 0.6960 202000.0n 0.5175 202249.9n 0.5175 202250.0n 0.5378 202499.9n 0.5378 202500.0n 0.6273 202749.9n 0.6273 202750.0n 0.4657 202999.9n 0.4657 203000.0n 0.8288 203249.9n 0.8288 203250.0n 0.3791 203499.9n 0.3791 203500.0n 0.4933 203749.9n 0.4933 203750.0n 0.5870 203999.9n 0.5870 204000.0n 0.6339 204249.9n 0.6339 204250.0n 0.8010 204499.9n 0.8010 204500.0n 0.5144 204749.9n 0.5144 204750.0n 0.8670 204999.9n 0.8670 205000.0n 0.4277 205249.9n 0.4277 205250.0n 0.8579 205499.9n 0.8579 205500.0n 0.1961 205749.9n 0.1961 205750.0n 0.8979 205999.9n 0.8979 206000.0n 0.5842 206249.9n 0.5842 206250.0n 0.4842 206499.9n 0.4842 206500.0n 0.3959 206749.9n 0.3959 206750.0n 0.7551 206999.9n 0.7551 207000.0n 0.4983 207249.9n 0.4983 207250.0n 0.7133 207499.9n 0.7133 207500.0n 0.6598 207749.9n 0.6598 207750.0n 0.5465 207999.9n 0.5465 208000.0n 0.7539 208249.9n 0.7539 208250.0n 0.7561 208499.9n 0.7561 208500.0n 0.3900 208749.9n 0.3900 208750.0n 0.8672 208999.9n 0.8672 209000.0n 0.7978 209249.9n 0.7978 209250.0n 0.1361 209499.9n 0.1361 209500.0n 0.4522 209749.9n 0.4522 209750.0n 0.4116 209999.9n 0.4116 210000.0n 0.5592 210249.9n 0.5592 210250.0n 0.8010 210499.9n 0.8010 210500.0n 0.4729 210749.9n 0.4729 210750.0n 0.7886 210999.9n 0.7886 211000.0n 0.4175 211249.9n 0.4175 211250.0n 0.8672 211499.9n 0.8672 211500.0n 0.7978 211749.9n 0.7978 211750.0n 0.4842 211999.9n 0.4842 212000.0n 0.4934 212249.9n 0.4934 212250.0n 0.7539 212499.9n 0.7539 212500.0n 0.4659 212749.9n 0.4659 212750.0n 0.4657 212999.9n 0.4657 213000.0n 0.1772 213249.9n 0.1772 213250.0n 0.5505 213499.9n 0.5505 213500.0n 0.7561 213749.9n 0.7561 213750.0n 0.7551 213999.9n 0.7551 214000.0n 0.4889 214249.9n 0.4889 214250.0n 0.5471 214499.9n 0.5471 214500.0n 0.5870 214749.9n 0.5870 214750.0n 0.3629 214999.9n 0.3629 215000.0n 0.7844 215249.9n 0.7844 215250.0n 0.3900 215499.9n 0.3900 215500.0n 0.8142 215749.9n 0.8142 215750.0n 0.4933 215999.9n 0.4933 216000.0n 0.3545 216249.9n 0.3545 216250.0n 0.8064 216499.9n 0.8064 216500.0n 0.5175 216749.9n 0.5175 216750.0n 0.8670 216999.9n 0.8670 217000.0n 0.4957 217249.9n 0.4957 217250.0n 0.4522 217499.9n 0.4522 217500.0n 0.8979 217749.9n 0.8979 217750.0n 0.3914 217999.9n 0.3914 218000.0n 0.6598 218249.9n 0.6598 218250.0n 0.3944 218499.9n 0.3944 218500.0n 0.4372 218749.9n 0.4372 218750.0n 0.4277 218999.9n 0.4277 219000.0n 0.7133 219249.9n 0.7133 219250.0n 0.1497 219499.9n 0.1497 219500.0n 0.4660 219749.9n 0.4660 219750.0n 0.5144 219999.9n 0.5144 220000.0n 0.6960 220249.9n 0.6960 220250.0n 0.1361 220499.9n 0.1361 220500.0n 0.5857 220749.9n 0.5857 220750.0n 0.8579 220999.9n 0.8579 221000.0n 0.5306 221249.9n 0.5306 221250.0n 0.3791 221499.9n 0.3791 221500.0n 0.1961 221749.9n 0.1961 221750.0n 0.6273 221999.9n 0.6273 222000.0n 0.5465 222249.9n 0.5465 222250.0n 0.4983 222499.9n 0.4983 222500.0n 0.5378 222749.9n 0.5378 222750.0n 0.2318 222999.9n 0.2318 223000.0n 0.4790 223249.9n 0.4790 223250.0n 0.5842 223499.9n 0.5842 223500.0n 0.7528 223749.9n 0.7528 223750.0n 0.4116 223999.9n 0.4116 224000.0n 0.3948 224249.9n 0.3948 224250.0n 0.6339 224499.9n 0.6339 224500.0n 0.8288 224749.9n 0.8288 224750.0n 0.3959 224999.9n 0.3959 225000.0n 0.8579 225249.9n 0.8579 225250.0n 0.6273 225499.9n 0.6273 225500.0n 0.5471 225749.9n 0.5471 225750.0n 0.3944 225999.9n 0.3944 226000.0n 0.4790 226249.9n 0.4790 226250.0n 0.4522 226499.9n 0.4522 226500.0n 0.1772 226749.9n 0.1772 226750.0n 0.5144 226999.9n 0.5144 227000.0n 0.5592 227249.9n 0.5592 227250.0n 0.4983 227499.9n 0.4983 227500.0n 0.3948 227749.9n 0.3948 227750.0n 0.8064 227999.9n 0.8064 228000.0n 0.4659 228249.9n 0.4659 228250.0n 0.7133 228499.9n 0.7133 228500.0n 0.7886 228749.9n 0.7886 228750.0n 0.1361 228999.9n 0.1361 229000.0n 0.5175 229249.9n 0.5175 229250.0n 0.4889 229499.9n 0.4889 229500.0n 0.3545 229749.9n 0.3545 229750.0n 0.5306 229999.9n 0.5306 230000.0n 0.1497 230249.9n 0.1497 230250.0n 0.8010 230499.9n 0.8010 230500.0n 0.4277 230749.9n 0.4277 230750.0n 0.4957 230999.9n 0.4957 231000.0n 0.7844 231249.9n 0.7844 231250.0n 0.4660 231499.9n 0.4660 231500.0n 0.5842 231749.9n 0.5842 231750.0n 0.7539 231999.9n 0.7539 232000.0n 0.7978 232249.9n 0.7978 232250.0n 0.7528 232499.9n 0.7528 232500.0n 0.8142 232749.9n 0.8142 232750.0n 0.2318 232999.9n 0.2318 233000.0n 0.4657 233249.9n 0.4657 233250.0n 0.3900 233499.9n 0.3900 233500.0n 0.8979 233749.9n 0.8979 233750.0n 0.3959 233999.9n 0.3959 234000.0n 0.8672 234249.9n 0.8672 234250.0n 0.5870 234499.9n 0.5870 234500.0n 0.6339 234749.9n 0.6339 234750.0n 0.3629 234999.9n 0.3629 235000.0n 0.8670 235249.9n 0.8670 235250.0n 0.6598 235499.9n 0.6598 235500.0n 0.7561 235749.9n 0.7561 235750.0n 0.7551 235999.9n 0.7551 236000.0n 0.5505 236249.9n 0.5505 236250.0n 0.4933 236499.9n 0.4933 236500.0n 0.4842 236749.9n 0.4842 236750.0n 0.8288 236999.9n 0.8288 237000.0n 0.4116 237249.9n 0.4116 237250.0n 0.6960 237499.9n 0.6960 237500.0n 0.3791 237749.9n 0.3791 237750.0n 0.4175 237999.9n 0.4175 238000.0n 0.4729 238249.9n 0.4729 238250.0n 0.3914 238499.9n 0.3914 238500.0n 0.5857 238749.9n 0.5857 238750.0n 0.1961 238999.9n 0.1961 239000.0n 0.5465 239249.9n 0.5465 239250.0n 0.5378 239499.9n 0.5378 239500.0n 0.4372 239749.9n 0.4372 239750.0n 0.4934 239999.9n 0.4934 240000.0n 0.1361 240249.9n 0.1361 240250.0n 0.5592 240499.9n 0.5592 240500.0n 0.4934 240749.9n 0.4934 240750.0n 0.5471 240999.9n 0.5471 241000.0n 0.5144 241249.9n 0.5144 241250.0n 0.7133 241499.9n 0.7133 241500.0n 0.8670 241749.9n 0.8670 241750.0n 0.4957 241999.9n 0.4957 242000.0n 0.8979 242249.9n 0.8979 242250.0n 0.4790 242499.9n 0.4790 242500.0n 0.3959 242749.9n 0.3959 242750.0n 0.4657 242999.9n 0.4657 243000.0n 0.4660 243249.9n 0.4660 243250.0n 0.3629 243499.9n 0.3629 243500.0n 0.4729 243749.9n 0.4729 243750.0n 0.5857 243999.9n 0.5857 244000.0n 0.5378 244249.9n 0.5378 244250.0n 0.4116 244499.9n 0.4116 244500.0n 0.3900 244749.9n 0.3900 244750.0n 0.6960 244999.9n 0.6960 245000.0n 0.7886 245249.9n 0.7886 245250.0n 0.7978 245499.9n 0.7978 245500.0n 0.5306 245749.9n 0.5306 245750.0n 0.4175 245999.9n 0.4175 246000.0n 0.5842 246249.9n 0.5842 246250.0n 0.8064 246499.9n 0.8064 246500.0n 0.6339 246749.9n 0.6339 246750.0n 0.3914 246999.9n 0.3914 247000.0n 0.4889 247249.9n 0.4889 247250.0n 0.4983 247499.9n 0.4983 247500.0n 0.8672 247749.9n 0.8672 247750.0n 0.7561 247999.9n 0.7561 248000.0n 0.7539 248249.9n 0.7539 248250.0n 0.8579 248499.9n 0.8579 248500.0n 0.5505 248749.9n 0.5505 248750.0n 0.8010 248999.9n 0.8010 249000.0n 0.6598 249249.9n 0.6598 249250.0n 0.4522 249499.9n 0.4522 249500.0n 0.5870 249749.9n 0.5870 249750.0n 0.1772 249999.9n 0.1772 250000.0n 0.8288 250249.9n 0.8288 250250.0n 0.3545 250499.9n 0.3545 250500.0n 0.1961 250749.9n 0.1961 250750.0n 0.5465 250999.9n 0.5465 251000.0n 0.3948 251249.9n 0.3948 251250.0n 0.5175 251499.9n 0.5175 251500.0n 0.1497 251749.9n 0.1497 251750.0n 0.7844 251999.9n 0.7844 252000.0n 0.3944 252249.9n 0.3944 252250.0n 0.7551 252499.9n 0.7551 252500.0n 0.4933 252749.9n 0.4933 252750.0n 0.3791 252999.9n 0.3791 253000.0n 0.4277 253249.9n 0.4277 253250.0n 0.4842 253499.9n 0.4842 253500.0n 0.2318 253749.9n 0.2318 253750.0n 0.8142 253999.9n 0.8142 254000.0n 0.6273 254249.9n 0.6273 254250.0n 0.4659 254499.9n 0.4659 254500.0n 0.7528 254749.9n 0.7528 254750.0n 0.4372 254999.9n 0.4372 255000.0n 0.3948 255249.9n 0.3948 255250.0n 0.3629 255499.9n 0.3629 255500.0n 0.6339 255749.9n 0.6339 255750.0n 0.4116 255999.9n 0.4116 256000.0n 0.8579 256249.9n 0.8579 256250.0n 0.1772 256499.9n 0.1772 256500.0n 0.7886 256749.9n 0.7886 256750.0n 0.1961 256999.9n 0.1961 257000.0n 0.5175 257249.9n 0.5175 257250.0n 0.5144 257499.9n 0.5144 257500.0n 0.4729 257749.9n 0.4729 257750.0n 0.3944 257999.9n 0.3944 258000.0n 0.3545 258249.9n 0.3545 258250.0n 0.4842 258499.9n 0.4842 258500.0n 0.5378 258749.9n 0.5378 258750.0n 0.3959 258999.9n 0.3959 259000.0n 0.5471 259249.9n 0.5471 259250.0n 0.1361 259499.9n 0.1361 259500.0n 0.4790 259749.9n 0.4790 259750.0n 0.5505 259999.9n 0.5505 260000.0n 0.7978 260249.9n 0.7978 260250.0n 0.2318 260499.9n 0.2318 260500.0n 0.4660 260749.9n 0.4660 260750.0n 0.4522 260999.9n 0.4522 261000.0n 0.7539 261249.9n 0.7539 261250.0n 0.4933 261499.9n 0.4933 261500.0n 0.8288 261749.9n 0.8288 261750.0n 0.4934 261999.9n 0.4934 262000.0n 0.1497 262249.9n 0.1497 262250.0n 0.4659 262499.9n 0.4659 262500.0n 0.7528 262749.9n 0.7528 262750.0n 0.4889 262999.9n 0.4889 263000.0n 0.7844 263249.9n 0.7844 263250.0n 0.4175 263499.9n 0.4175 263500.0n 0.6960 263749.9n 0.6960 263750.0n 0.7551 263999.9n 0.7551 264000.0n 0.8064 264249.9n 0.8064 264250.0n 0.4277 264499.9n 0.4277 264500.0n 0.8672 264749.9n 0.8672 264750.0n 0.4657 264999.9n 0.4657 265000.0n 0.8142 265249.9n 0.8142 265250.0n 0.4372 265499.9n 0.4372 265500.0n 0.6273 265749.9n 0.6273 265750.0n 0.5842 265999.9n 0.5842 266000.0n 0.8670 266249.9n 0.8670 266250.0n 0.5306 266499.9n 0.5306 266500.0n 0.3791 266749.9n 0.3791 266750.0n 0.7133 266999.9n 0.7133 267000.0n 0.4957 267249.9n 0.4957 267250.0n 0.5465 267499.9n 0.5465 267500.0n 0.7561 267749.9n 0.7561 267750.0n 0.6598 267999.9n 0.6598 268000.0n 0.3900 268249.9n 0.3900 268250.0n 0.5870 268499.9n 0.5870 268500.0n 0.3914 268749.9n 0.3914 268750.0n 0.5592 268999.9n 0.5592 269000.0n 0.4983 269249.9n 0.4983 269250.0n 0.8979 269499.9n 0.8979 269500.0n 0.5857 269749.9n 0.5857 269750.0n 0.8010 269999.9n 0.8010 270000.0n 0.8579 270249.9n 0.8579 270250.0n 0.3914 270499.9n 0.3914 270500.0n 0.3959 270749.9n 0.3959 270750.0n 0.5870 270999.9n 0.5870 271000.0n 0.8979 271249.9n 0.8979 271250.0n 0.3629 271499.9n 0.3629 271500.0n 0.8670 271749.9n 0.8670 271750.0n 0.1961 271999.9n 0.1961 272000.0n 0.4933 272249.9n 0.4933 272250.0n 0.4175 272499.9n 0.4175 272500.0n 0.5857 272749.9n 0.5857 272750.0n 0.5465 272999.9n 0.5465 273000.0n 0.6960 273249.9n 0.6960 273250.0n 0.7551 273499.9n 0.7551 273500.0n 0.4934 273749.9n 0.4934 273750.0n 0.7539 273999.9n 0.7539 274000.0n 0.8064 274249.9n 0.8064 274250.0n 0.4522 274499.9n 0.4522 274500.0n 0.8010 274749.9n 0.8010 274750.0n 0.4660 274999.9n 0.4660 275000.0n 0.4957 275249.9n 0.4957 275250.0n 0.5505 275499.9n 0.5505 275500.0n 0.4657 275749.9n 0.4657 275750.0n 0.5378 275999.9n 0.5378 276000.0n 0.7844 276249.9n 0.7844 276250.0n 0.4116 276499.9n 0.4116 276500.0n 0.4372 276749.9n 0.4372 276750.0n 0.1497 276999.9n 0.1497 277000.0n 0.4889 277249.9n 0.4889 277250.0n 0.6339 277499.9n 0.6339 277500.0n 0.5306 277749.9n 0.5306 277750.0n 0.4277 277999.9n 0.4277 278000.0n 0.3944 278249.9n 0.3944 278250.0n 0.4659 278499.9n 0.4659 278500.0n 0.7978 278749.9n 0.7978 278750.0n 0.5175 278999.9n 0.5175 279000.0n 0.1361 279249.9n 0.1361 279250.0n 0.6598 279499.9n 0.6598 279500.0n 0.7528 279749.9n 0.7528 279750.0n 0.7886 279999.9n 0.7886 280000.0n 0.8288 280249.9n 0.8288 280250.0n 0.4729 280499.9n 0.4729 280500.0n 0.3900 280749.9n 0.3900 280750.0n 0.5592 280999.9n 0.5592 281000.0n 0.4842 281249.9n 0.4842 281250.0n 0.6273 281499.9n 0.6273 281500.0n 0.1772 281749.9n 0.1772 281750.0n 0.5842 281999.9n 0.5842 282000.0n 0.3545 282249.9n 0.3545 282250.0n 0.7561 282499.9n 0.7561 282500.0n 0.8142 282749.9n 0.8142 282750.0n 0.5144 282999.9n 0.5144 283000.0n 0.3791 283249.9n 0.3791 283250.0n 0.4790 283499.9n 0.4790 283500.0n 0.4983 283749.9n 0.4983 283750.0n 0.5471 283999.9n 0.5471 284000.0n 0.3948 284249.9n 0.3948 284250.0n 0.7133 284499.9n 0.7133 284500.0n 0.2318 284749.9n 0.2318 284750.0n 0.8672 284999.9n 0.8672 285000.0n 0.5144 285249.9n 0.5144 285250.0n 0.3545 285499.9n 0.3545 285500.0n 0.3944 285749.9n 0.3944 285750.0n 0.8672 285999.9n 0.8672 286000.0n 0.3629 286249.9n 0.3629 286250.0n 0.8010 286499.9n 0.8010 286500.0n 0.4116 286749.9n 0.4116 286750.0n 0.6960 286999.9n 0.6960 287000.0n 0.4934 287249.9n 0.4934 287250.0n 0.7133 287499.9n 0.7133 287500.0n 0.7561 287749.9n 0.7561 287750.0n 0.8979 287999.9n 0.8979 288000.0n 0.3900 288249.9n 0.3900 288250.0n 0.1497 288499.9n 0.1497 288500.0n 0.4790 288749.9n 0.4790 288750.0n 0.5505 288999.9n 0.5505 289000.0n 0.6598 289249.9n 0.6598 289250.0n 0.5306 289499.9n 0.5306 289500.0n 0.4372 289749.9n 0.4372 289750.0n 0.4522 289999.9n 0.4522 290000.0n 0.7978 290249.9n 0.7978 290250.0n 0.7528 290499.9n 0.7528 290500.0n 0.7551 290749.9n 0.7551 290750.0n 0.3959 290999.9n 0.3959 291000.0n 0.3914 291249.9n 0.3914 291250.0n 0.7844 291499.9n 0.7844 291500.0n 0.4660 291749.9n 0.4660 291750.0n 0.1361 291999.9n 0.1361 292000.0n 0.8670 292249.9n 0.8670 292250.0n 0.4983 292499.9n 0.4983 292500.0n 0.8064 292749.9n 0.8064 292750.0n 0.5378 292999.9n 0.5378 293000.0n 0.3948 293249.9n 0.3948 293250.0n 0.5857 293499.9n 0.5857 293500.0n 0.5842 293749.9n 0.5842 293750.0n 0.6273 293999.9n 0.6273 294000.0n 0.4933 294249.9n 0.4933 294250.0n 0.4889 294499.9n 0.4889 294500.0n 0.4657 294749.9n 0.4657 294750.0n 0.5471 294999.9n 0.5471 295000.0n 0.8579 295249.9n 0.8579 295250.0n 0.8142 295499.9n 0.8142 295500.0n 0.8288 295749.9n 0.8288 295750.0n 0.3791 295999.9n 0.3791 296000.0n 0.4277 296249.9n 0.4277 296250.0n 0.7539 296499.9n 0.7539 296500.0n 0.1772 296749.9n 0.1772 296750.0n 0.7886 296999.9n 0.7886 297000.0n 0.4957 297249.9n 0.4957 297250.0n 0.5465 297499.9n 0.5465 297500.0n 0.4729 297749.9n 0.4729 297750.0n 0.6339 297999.9n 0.6339 298000.0n 0.5870 298249.9n 0.5870 298250.0n 0.4659 298499.9n 0.4659 298500.0n 0.5175 298749.9n 0.5175 298750.0n 0.2318 298999.9n 0.2318 299000.0n 0.5592 299249.9n 0.5592 299250.0n 0.4842 299499.9n 0.4842 299500.0n 0.1961 299749.9n 0.1961 299750.0n 0.4175 299999.9n 0.4175 300000.0n 0.8288 300249.9n 0.8288 300250.0n 0.7886 300499.9n 0.7886 300500.0n 0.3959 300749.9n 0.3959 300750.0n 0.8142 300999.9n 0.8142 301000.0n 0.5175 301249.9n 0.5175 301250.0n 0.1772 301499.9n 0.1772 301500.0n 0.7528 301749.9n 0.7528 301750.0n 0.4522 301999.9n 0.4522 302000.0n 0.6339 302249.9n 0.6339 302250.0n 0.8979 302499.9n 0.8979 302500.0n 0.4934 302749.9n 0.4934 302750.0n 0.3944 302999.9n 0.3944 303000.0n 0.5306 303249.9n 0.5306 303250.0n 0.5471 303499.9n 0.5471 303500.0n 0.8672 303749.9n 0.8672 303750.0n 0.1961 303999.9n 0.1961 304000.0n 0.5842 304249.9n 0.5842 304250.0n 0.4842 304499.9n 0.4842 304500.0n 0.7539 304749.9n 0.7539 304750.0n 0.4659 304999.9n 0.4659 305000.0n 0.6598 305249.9n 0.6598 305250.0n 0.2318 305499.9n 0.2318 305500.0n 0.3948 305749.9n 0.3948 305750.0n 0.4175 305999.9n 0.4175 306000.0n 0.5465 306249.9n 0.5465 306250.0n 0.4889 306499.9n 0.4889 306500.0n 0.7561 306749.9n 0.7561 306750.0n 0.4790 306999.9n 0.4790 307000.0n 0.4660 307249.9n 0.4660 307250.0n 0.1497 307499.9n 0.1497 307500.0n 0.4983 307749.9n 0.4983 307750.0n 0.6273 307999.9n 0.6273 308000.0n 0.5857 308249.9n 0.5857 308250.0n 0.4372 308499.9n 0.4372 308500.0n 0.8064 308749.9n 0.8064 308750.0n 0.8010 308999.9n 0.8010 309000.0n 0.4657 309249.9n 0.4657 309250.0n 0.3914 309499.9n 0.3914 309500.0n 0.5505 309749.9n 0.5505 309750.0n 0.5144 309999.9n 0.5144 310000.0n 0.7844 310249.9n 0.7844 310250.0n 0.7133 310499.9n 0.7133 310500.0n 0.6960 310749.9n 0.6960 310750.0n 0.4729 310999.9n 0.4729 311000.0n 0.4277 311249.9n 0.4277 311250.0n 0.7551 311499.9n 0.7551 311500.0n 0.4957 311749.9n 0.4957 311750.0n 0.4116 311999.9n 0.4116 312000.0n 0.4933 312249.9n 0.4933 312250.0n 0.5870 312499.9n 0.5870 312500.0n 0.3545 312749.9n 0.3545 312750.0n 0.3900 312999.9n 0.3900 313000.0n 0.5378 313249.9n 0.5378 313250.0n 0.1361 313499.9n 0.1361 313500.0n 0.8670 313749.9n 0.8670 313750.0n 0.7978 313999.9n 0.7978 314000.0n 0.3629 314249.9n 0.3629 314250.0n 0.5592 314499.9n 0.5592 314500.0n 0.8579 314749.9n 0.8579 314750.0n 0.3791 314999.9n 0.3791 315000.0n 0.5857 315249.9n 0.5857 315250.0n 0.8142 315499.9n 0.8142 315500.0n 0.5378 315749.9n 0.5378 315750.0n 0.4277 315999.9n 0.4277 316000.0n 0.7844 316249.9n 0.7844 316250.0n 0.6273 316499.9n 0.6273 316500.0n 0.5175 316749.9n 0.5175 316750.0n 0.8064 316999.9n 0.8064 317000.0n 0.8672 317249.9n 0.8672 317250.0n 0.7551 317499.9n 0.7551 317500.0n 0.3791 317749.9n 0.3791 317750.0n 0.8010 317999.9n 0.8010 318000.0n 0.4842 318249.9n 0.4842 318250.0n 0.4933 318499.9n 0.4933 318500.0n 0.1497 318749.9n 0.1497 318750.0n 0.7528 318999.9n 0.7528 319000.0n 0.5870 319249.9n 0.5870 319250.0n 0.3948 319499.9n 0.3948 319500.0n 0.3959 319749.9n 0.3959 319750.0n 0.1772 319999.9n 0.1772 320000.0n 0.8288 320249.9n 0.8288 320250.0n 0.8579 320499.9n 0.8579 320500.0n 0.5592 320749.9n 0.5592 320750.0n 0.5471 320999.9n 0.5471 321000.0n 0.3914 321249.9n 0.3914 321250.0n 0.7539 321499.9n 0.7539 321500.0n 0.5144 321749.9n 0.5144 321750.0n 0.4729 321999.9n 0.4729 322000.0n 0.4372 322249.9n 0.4372 322250.0n 0.4957 322499.9n 0.4957 322500.0n 0.1361 322749.9n 0.1361 322750.0n 0.2318 322999.9n 0.2318 323000.0n 0.5465 323249.9n 0.5465 323250.0n 0.6960 323499.9n 0.6960 323500.0n 0.7561 323749.9n 0.7561 323750.0n 0.3545 323999.9n 0.3545 324000.0n 0.3944 324249.9n 0.3944 324250.0n 0.1961 324499.9n 0.1961 324500.0n 0.4934 324749.9n 0.4934 324750.0n 0.7978 324999.9n 0.7978 325000.0n 0.6339 325249.9n 0.6339 325250.0n 0.8979 325499.9n 0.8979 325500.0n 0.5842 325749.9n 0.5842 325750.0n 0.4659 325999.9n 0.4659 326000.0n 0.5505 326249.9n 0.5505 326250.0n 0.8670 326499.9n 0.8670 326500.0n 0.3900 326749.9n 0.3900 326750.0n 0.4889 326999.9n 0.4889 327000.0n 0.4983 327249.9n 0.4983 327250.0n 0.4116 327499.9n 0.4116 327500.0n 0.7133 327749.9n 0.7133 327750.0n 0.4175 327999.9n 0.4175 328000.0n 0.5306 328249.9n 0.5306 328250.0n 0.7886 328499.9n 0.7886 328500.0n 0.4657 328749.9n 0.4657 328750.0n 0.3629 328999.9n 0.3629 329000.0n 0.4790 329249.9n 0.4790 329250.0n 0.6598 329499.9n 0.6598 329500.0n 0.4660 329749.9n 0.4660 329750.0n 0.4522 329999.9n 0.4522 330000.0n 0.8579 330249.9n 0.8579 330250.0n 0.3914 330499.9n 0.3914 330500.0n 0.5144 330749.9n 0.5144 330750.0n 0.7844 330999.9n 0.7844 331000.0n 0.4842 331249.9n 0.4842 331250.0n 0.4175 331499.9n 0.4175 331500.0n 0.4372 331749.9n 0.4372 331750.0n 0.3944 331999.9n 0.3944 332000.0n 0.6273 332249.9n 0.6273 332250.0n 0.4522 332499.9n 0.4522 332500.0n 0.8672 332749.9n 0.8672 332750.0n 0.1961 332999.9n 0.1961 333000.0n 0.3959 333249.9n 0.3959 333250.0n 0.3545 333499.9n 0.3545 333500.0n 0.7978 333749.9n 0.7978 333750.0n 0.8064 333999.9n 0.8064 334000.0n 0.7539 334249.9n 0.7539 334250.0n 0.5471 334499.9n 0.5471 334500.0n 0.2318 334749.9n 0.2318 334750.0n 0.5592 334999.9n 0.5592 335000.0n 0.3629 335249.9n 0.3629 335250.0n 0.1772 335499.9n 0.1772 335500.0n 0.4116 335749.9n 0.4116 335750.0n 0.3900 335999.9n 0.3900 336000.0n 0.8288 336249.9n 0.8288 336250.0n 0.4657 336499.9n 0.4657 336500.0n 0.4957 336749.9n 0.4957 336750.0n 0.3948 336999.9n 0.3948 337000.0n 0.6598 337249.9n 0.6598 337250.0n 0.3791 337499.9n 0.3791 337500.0n 0.4889 337749.9n 0.4889 337750.0n 0.5857 337999.9n 0.5857 338000.0n 0.8670 338249.9n 0.8670 338250.0n 0.4983 338499.9n 0.4983 338500.0n 0.7528 338749.9n 0.7528 338750.0n 0.5842 338999.9n 0.5842 339000.0n 0.5378 339249.9n 0.5378 339250.0n 0.6339 339499.9n 0.6339 339500.0n 0.8010 339749.9n 0.8010 339750.0n 0.5175 339999.9n 0.5175 340000.0n 0.6960 340249.9n 0.6960 340250.0n 0.4729 340499.9n 0.4729 340500.0n 0.5505 340749.9n 0.5505 340750.0n 0.4933 340999.9n 0.4933 341000.0n 0.8979 341249.9n 0.8979 341250.0n 0.4659 341499.9n 0.4659 341500.0n 0.4790 341749.9n 0.4790 341750.0n 0.4934 341999.9n 0.4934 342000.0n 0.7551 342249.9n 0.7551 342250.0n 0.8142 342499.9n 0.8142 342500.0n 0.7133 342749.9n 0.7133 342750.0n 0.4277 342999.9n 0.4277 343000.0n 0.4660 343249.9n 0.4660 343250.0n 0.7561 343499.9n 0.7561 343500.0n 0.5465 343749.9n 0.5465 343750.0n 0.5870 343999.9n 0.5870 344000.0n 0.1497 344249.9n 0.1497 344250.0n 0.5306 344499.9n 0.5306 344500.0n 0.1361 344749.9n 0.1361 344750.0n 0.7886 344999.9n 0.7886 345000.0n 0.5842 345249.9n 0.5842 345250.0n 0.6598 345499.9n 0.6598 345500.0n 0.3944 345749.9n 0.3944 345750.0n 0.6273 345999.9n 0.6273 346000.0n 0.5592 346249.9n 0.5592 346250.0n 0.3948 346499.9n 0.3948 346500.0n 0.7133 346749.9n 0.7133 346750.0n 0.8010 346999.9n 0.8010 347000.0n 0.7551 347249.9n 0.7551 347250.0n 0.4372 347499.9n 0.4372 347500.0n 0.6960 347749.9n 0.6960 347750.0n 0.3545 347999.9n 0.3545 348000.0n 0.8288 348249.9n 0.8288 348250.0n 0.1772 348499.9n 0.1772 348500.0n 0.5175 348749.9n 0.5175 348750.0n 0.7886 348999.9n 0.7886 349000.0n 0.5306 349249.9n 0.5306 349250.0n 0.6339 349499.9n 0.6339 349500.0n 0.8979 349749.9n 0.8979 349750.0n 0.5857 349999.9n 0.5857 350000.0n 0.4277 350249.9n 0.4277 350250.0n 0.4842 350499.9n 0.4842 350500.0n 0.3900 350749.9n 0.3900 350750.0n 0.7539 350999.9n 0.7539 351000.0n 0.4729 351249.9n 0.4729 351250.0n 0.8670 351499.9n 0.8670 351500.0n 0.1497 351749.9n 0.1497 351750.0n 0.5870 351999.9n 0.5870 352000.0n 0.5378 352249.9n 0.5378 352250.0n 0.3629 352499.9n 0.3629 352500.0n 0.5144 352749.9n 0.5144 352750.0n 0.3791 352999.9n 0.3791 353000.0n 0.2318 353249.9n 0.2318 353250.0n 0.8142 353499.9n 0.8142 353500.0n 0.3914 353749.9n 0.3914 353750.0n 0.4116 353999.9n 0.4116 354000.0n 0.5471 354249.9n 0.5471 354250.0n 0.4522 354499.9n 0.4522 354500.0n 0.4660 354749.9n 0.4660 354750.0n 0.3959 354999.9n 0.3959 355000.0n 0.4934 355249.9n 0.4934 355250.0n 0.4957 355499.9n 0.4957 355500.0n 0.5465 355749.9n 0.5465 355750.0n 0.4790 355999.9n 0.4790 356000.0n 0.5505 356249.9n 0.5505 356250.0n 0.8064 356499.9n 0.8064 356500.0n 0.8672 356749.9n 0.8672 356750.0n 0.1961 356999.9n 0.1961 357000.0n 0.4983 357249.9n 0.4983 357250.0n 0.7528 357499.9n 0.7528 357500.0n 0.4933 357749.9n 0.4933 357750.0n 0.4657 357999.9n 0.4657 358000.0n 0.7561 358249.9n 0.7561 358250.0n 0.8579 358499.9n 0.8579 358500.0n 0.4175 358749.9n 0.4175 358750.0n 0.7978 358999.9n 0.7978 359000.0n 0.4659 359249.9n 0.4659 359250.0n 0.7844 359499.9n 0.7844 359500.0n 0.1361 359749.9n 0.1361 359750.0n 0.4889 359999.9n 0.4889 360000.0n 0.6273 360249.9n 0.6273 360250.0n 0.7886 360499.9n 0.7886 360500.0n 0.4933 360749.9n 0.4933 360750.0n 0.4659 360999.9n 0.4659 361000.0n 0.8010 361249.9n 0.8010 361250.0n 0.6598 361499.9n 0.6598 361500.0n 0.1361 361749.9n 0.1361 361750.0n 0.1497 361999.9n 0.1497 362000.0n 0.3959 362249.9n 0.3959 362250.0n 0.3545 362499.9n 0.3545 362500.0n 0.5870 362749.9n 0.5870 362750.0n 0.7561 362999.9n 0.7561 363000.0n 0.5378 363249.9n 0.5378 363250.0n 0.3944 363499.9n 0.3944 363500.0n 0.4957 363749.9n 0.4957 363750.0n 0.4522 363999.9n 0.4522 364000.0n 0.4277 364249.9n 0.4277 364250.0n 0.7551 364499.9n 0.7551 364500.0n 0.7844 364749.9n 0.7844 364750.0n 0.3791 364999.9n 0.3791 365000.0n 0.1961 365249.9n 0.1961 365250.0n 0.3948 365499.9n 0.3948 365500.0n 0.6339 365749.9n 0.6339 365750.0n 0.4983 365999.9n 0.4983 366000.0n 0.5471 366249.9n 0.5471 366250.0n 0.7978 366499.9n 0.7978 366500.0n 0.4372 366749.9n 0.4372 366750.0n 0.8288 366999.9n 0.8288 367000.0n 0.7528 367249.9n 0.7528 367250.0n 0.8672 367499.9n 0.8672 367500.0n 0.7133 367749.9n 0.7133 367750.0n 0.3914 367999.9n 0.3914 368000.0n 0.4657 368249.9n 0.4657 368250.0n 0.5592 368499.9n 0.5592 368500.0n 0.4790 368749.9n 0.4790 368750.0n 0.2318 368999.9n 0.2318 369000.0n 0.4842 369249.9n 0.4842 369250.0n 0.7539 369499.9n 0.7539 369500.0n 0.3900 369749.9n 0.3900 369750.0n 0.8064 369999.9n 0.8064 370000.0n 0.4175 370249.9n 0.4175 370250.0n 0.5306 370499.9n 0.5306 370500.0n 0.5465 370749.9n 0.5465 370750.0n 0.8979 370999.9n 0.8979 371000.0n 0.5842 371249.9n 0.5842 371250.0n 0.6960 371499.9n 0.6960 371500.0n 0.3629 371749.9n 0.3629 371750.0n 0.1772 371999.9n 0.1772 372000.0n 0.8579 372249.9n 0.8579 372250.0n 0.5144 372499.9n 0.5144 372500.0n 0.5175 372749.9n 0.5175 372750.0n 0.4889 372999.9n 0.4889 373000.0n 0.4729 373249.9n 0.4729 373250.0n 0.4660 373499.9n 0.4660 373500.0n 0.5505 373749.9n 0.5505 373750.0n 0.8142 373999.9n 0.8142 374000.0n 0.4934 374249.9n 0.4934 374250.0n 0.8670 374499.9n 0.8670 374500.0n 0.4116 374749.9n 0.4116 374750.0n 0.5857 374999.9n 0.5857 375000.0n 0.1361 375249.9n 0.1361 375250.0n 0.7978 375499.9n 0.7978 375500.0n 0.4934 375749.9n 0.4934 375750.0n 0.5144 375999.9n 0.5144 376000.0n 0.8064 376249.9n 0.8064 376250.0n 0.4175 376499.9n 0.4175 376500.0n 0.4729 376749.9n 0.4729 376750.0n 0.4657 376999.9n 0.4657 377000.0n 0.4659 377249.9n 0.4659 377250.0n 0.7539 377499.9n 0.7539 377500.0n 0.4372 377749.9n 0.4372 377750.0n 0.5471 377999.9n 0.5471 378000.0n 0.5857 378249.9n 0.5857 378250.0n 0.8579 378499.9n 0.8579 378500.0n 0.3948 378749.9n 0.3948 378750.0n 0.7133 378999.9n 0.7133 379000.0n 0.3791 379249.9n 0.3791 379250.0n 0.8288 379499.9n 0.8288 379500.0n 0.1497 379749.9n 0.1497 379750.0n 0.2318 379999.9n 0.2318 380000.0n 0.4957 380249.9n 0.4957 380250.0n 0.5378 380499.9n 0.5378 380500.0n 0.8010 380749.9n 0.8010 380750.0n 0.4116 380999.9n 0.4116 381000.0n 0.3545 381249.9n 0.3545 381250.0n 0.1961 381499.9n 0.1961 381500.0n 0.4983 381749.9n 0.4983 381750.0n 0.4842 381999.9n 0.4842 382000.0n 0.7551 382249.9n 0.7551 382250.0n 0.7561 382499.9n 0.7561 382500.0n 0.5505 382749.9n 0.5505 382750.0n 0.4277 382999.9n 0.4277 383000.0n 0.5842 383249.9n 0.5842 383250.0n 0.3959 383499.9n 0.3959 383500.0n 0.7528 383749.9n 0.7528 383750.0n 0.6598 383999.9n 0.6598 384000.0n 0.5592 384249.9n 0.5592 384250.0n 0.8142 384499.9n 0.8142 384500.0n 0.8672 384749.9n 0.8672 384750.0n 0.5465 384999.9n 0.5465 385000.0n 0.4933 385249.9n 0.4933 385250.0n 0.4889 385499.9n 0.4889 385500.0n 0.5175 385749.9n 0.5175 385750.0n 0.4790 385999.9n 0.4790 386000.0n 0.6339 386249.9n 0.6339 386250.0n 0.5306 386499.9n 0.5306 386500.0n 0.8670 386749.9n 0.8670 386750.0n 0.4660 386999.9n 0.4660 387000.0n 0.4522 387249.9n 0.4522 387250.0n 0.1772 387499.9n 0.1772 387500.0n 0.7844 387749.9n 0.7844 387750.0n 0.5870 387999.9n 0.5870 388000.0n 0.3914 388249.9n 0.3914 388250.0n 0.3629 388499.9n 0.3629 388500.0n 0.7886 388749.9n 0.7886 388750.0n 0.8979 388999.9n 0.8979 389000.0n 0.6960 389249.9n 0.6960 389250.0n 0.3944 389499.9n 0.3944 389500.0n 0.6273 389749.9n 0.6273 389750.0n 0.3900 389999.9n 0.3900 390000.0n 0.3900 390249.9n 0.3900 390250.0n 0.1497 390499.9n 0.1497 390500.0n 0.4933 390749.9n 0.4933 390750.0n 0.4657 390999.9n 0.4657 391000.0n 0.6339 391249.9n 0.6339 391250.0n 0.5842 391499.9n 0.5842 391500.0n 0.7133 391749.9n 0.7133 391750.0n 0.4660 391999.9n 0.4660 392000.0n 0.3959 392249.9n 0.3959 392250.0n 0.1361 392499.9n 0.1361 392500.0n 0.4175 392749.9n 0.4175 392750.0n 0.7539 392999.9n 0.7539 393000.0n 0.4116 393249.9n 0.4116 393250.0n 0.6598 393499.9n 0.6598 393500.0n 0.8010 393749.9n 0.8010 393750.0n 0.8579 393999.9n 0.8579 394000.0n 0.1772 394249.9n 0.1772 394250.0n 0.1961 394499.9n 0.1961 394500.0n 0.2318 394749.9n 0.2318 394750.0n 0.7561 394999.9n 0.7561 395000.0n 0.8064 395249.9n 0.8064 395250.0n 0.5378 395499.9n 0.5378 395500.0n 0.4729 395749.9n 0.4729 395750.0n 0.3629 395999.9n 0.3629 396000.0n 0.4889 396249.9n 0.4889 396250.0n 0.3948 396499.9n 0.3948 396500.0n 0.3545 396749.9n 0.3545 396750.0n 0.5175 396999.9n 0.5175 397000.0n 0.5592 397249.9n 0.5592 397250.0n 0.3791 397499.9n 0.3791 397500.0n 0.3914 397749.9n 0.3914 397750.0n 0.8288 397999.9n 0.8288 398000.0n 0.4934 398249.9n 0.4934 398250.0n 0.4522 398499.9n 0.4522 398500.0n 0.5144 398749.9n 0.5144 398750.0n 0.8979 398999.9n 0.8979 399000.0n 0.7551 399249.9n 0.7551 399250.0n 0.5471 399499.9n 0.5471 399500.0n 0.7528 399749.9n 0.7528 399750.0n 0.7978 399999.9n 0.7978 400000.0n 0.7844 400249.9n 0.7844 400250.0n 0.4372 400499.9n 0.4372 400500.0n 0.3944 400749.9n 0.3944 400750.0n 0.5870 400999.9n 0.5870 401000.0n 0.5505 401249.9n 0.5505 401250.0n 0.7886 401499.9n 0.7886 401500.0n 0.4790 401749.9n 0.4790 401750.0n 0.4983 401999.9n 0.4983 402000.0n 0.4277 402249.9n 0.4277 402250.0n 0.5306 402499.9n 0.5306 402500.0n 0.8672 402749.9n 0.8672 402750.0n 0.5857 402999.9n 0.5857 403000.0n 0.5465 403249.9n 0.5465 403250.0n 0.4957 403499.9n 0.4957 403500.0n 0.4842 403749.9n 0.4842 403750.0n 0.6960 403999.9n 0.6960 404000.0n 0.8142 404249.9n 0.8142 404250.0n 0.6273 404499.9n 0.6273 404500.0n 0.4659 404749.9n 0.4659 404750.0n 0.8670 404999.9n 0.8670 405000.0n 0.3900 405249.9n 0.3900 405250.0n 0.3545 405499.9n 0.3545 405500.0n 0.1772 405749.9n 0.1772 405750.0n 0.5471 405999.9n 0.5471 406000.0n 0.2318 406249.9n 0.2318 406250.0n 0.5505 406499.9n 0.5505 406500.0n 0.4934 406749.9n 0.4934 406750.0n 0.5378 406999.9n 0.5378 407000.0n 0.8142 407249.9n 0.8142 407250.0n 0.4729 407499.9n 0.4729 407500.0n 0.4790 407749.9n 0.4790 407750.0n 0.7133 407999.9n 0.7133 408000.0n 0.5870 408249.9n 0.5870 408250.0n 0.1361 408499.9n 0.1361 408500.0n 0.4522 408749.9n 0.4522 408750.0n 0.6960 408999.9n 0.6960 409000.0n 0.4372 409249.9n 0.4372 409250.0n 0.5857 409499.9n 0.5857 409500.0n 0.6339 409749.9n 0.6339 409750.0n 0.8670 409999.9n 0.8670 410000.0n 0.7539 410249.9n 0.7539 410250.0n 0.3914 410499.9n 0.3914 410500.0n 0.4657 410749.9n 0.4657 410750.0n 0.4957 410999.9n 0.4957 411000.0n 0.1961 411249.9n 0.1961 411250.0n 0.3948 411499.9n 0.3948 411500.0n 0.1497 411749.9n 0.1497 411750.0n 0.4175 411999.9n 0.4175 412000.0n 0.6598 412249.9n 0.6598 412250.0n 0.4660 412499.9n 0.4660 412500.0n 0.7528 412749.9n 0.7528 412750.0n 0.3944 412999.9n 0.3944 413000.0n 0.4933 413249.9n 0.4933 413250.0n 0.7844 413499.9n 0.7844 413500.0n 0.4889 413749.9n 0.4889 413750.0n 0.6273 413999.9n 0.6273 414000.0n 0.5592 414249.9n 0.5592 414250.0n 0.8979 414499.9n 0.8979 414500.0n 0.8010 414749.9n 0.8010 414750.0n 0.4659 414999.9n 0.4659 415000.0n 0.7886 415249.9n 0.7886 415250.0n 0.5842 415499.9n 0.5842 415500.0n 0.5465 415749.9n 0.5465 415750.0n 0.8579 415999.9n 0.8579 416000.0n 0.7561 416249.9n 0.7561 416250.0n 0.7978 416499.9n 0.7978 416500.0n 0.5144 416749.9n 0.5144 416750.0n 0.4983 416999.9n 0.4983 417000.0n 0.5175 417249.9n 0.5175 417250.0n 0.3629 417499.9n 0.3629 417500.0n 0.4277 417749.9n 0.4277 417750.0n 0.3959 417999.9n 0.3959 418000.0n 0.4116 418249.9n 0.4116 418250.0n 0.7551 418499.9n 0.7551 418500.0n 0.8064 418749.9n 0.8064 418750.0n 0.4842 418999.9n 0.4842 419000.0n 0.8288 419249.9n 0.8288 419250.0n 0.3791 419499.9n 0.3791 419500.0n 0.8672 419749.9n 0.8672 419750.0n 0.5306 419999.9n 0.5306 420000.0n 0.4790 420249.9n 0.4790 420250.0n 0.7133 420499.9n 0.7133 420500.0n 0.1361 420749.9n 0.1361 420750.0n 0.8064 420999.9n 0.8064 421000.0n 0.4657 421249.9n 0.4657 421250.0n 0.6598 421499.9n 0.6598 421500.0n 0.6960 421749.9n 0.6960 421750.0n 0.3959 421999.9n 0.3959 422000.0n 0.4660 422249.9n 0.4660 422250.0n 0.5175 422499.9n 0.5175 422500.0n 0.4842 422749.9n 0.4842 422750.0n 0.8672 422999.9n 0.8672 423000.0n 0.3791 423249.9n 0.3791 423250.0n 0.3914 423499.9n 0.3914 423500.0n 0.5471 423749.9n 0.5471 423750.0n 0.4175 423999.9n 0.4175 424000.0n 0.3900 424249.9n 0.3900 424250.0n 0.4729 424499.9n 0.4729 424500.0n 0.3629 424749.9n 0.3629 424750.0n 0.4277 424999.9n 0.4277 425000.0n 0.4372 425249.9n 0.4372 425250.0n 0.8579 425499.9n 0.8579 425500.0n 0.4957 425749.9n 0.4957 425750.0n 0.2318 425999.9n 0.2318 426000.0n 0.5505 426249.9n 0.5505 426250.0n 0.7561 426499.9n 0.7561 426500.0n 0.1772 426749.9n 0.1772 426750.0n 0.7528 426999.9n 0.7528 427000.0n 0.3948 427249.9n 0.3948 427250.0n 0.7886 427499.9n 0.7886 427500.0n 0.5842 427749.9n 0.5842 427750.0n 0.5870 427999.9n 0.5870 428000.0n 0.5857 428249.9n 0.5857 428250.0n 0.4983 428499.9n 0.4983 428500.0n 0.7539 428749.9n 0.7539 428750.0n 0.8288 428999.9n 0.8288 429000.0n 0.7551 429249.9n 0.7551 429250.0n 0.5465 429499.9n 0.5465 429500.0n 0.5144 429749.9n 0.5144 429750.0n 0.6339 429999.9n 0.6339 430000.0n 0.6273 430249.9n 0.6273 430250.0n 0.5378 430499.9n 0.5378 430500.0n 0.8142 430749.9n 0.8142 430750.0n 0.1961 430999.9n 0.1961 431000.0n 0.1497 431249.9n 0.1497 431250.0n 0.4933 431499.9n 0.4933 431500.0n 0.4889 431749.9n 0.4889 431750.0n 0.7978 431999.9n 0.7978 432000.0n 0.7844 432249.9n 0.7844 432250.0n 0.4522 432499.9n 0.4522 432500.0n 0.3944 432749.9n 0.3944 432750.0n 0.8979 432999.9n 0.8979 433000.0n 0.4934 433249.9n 0.4934 433250.0n 0.5592 433499.9n 0.5592 433500.0n 0.4659 433749.9n 0.4659 433750.0n 0.8670 433999.9n 0.8670 434000.0n 0.5306 434249.9n 0.5306 434250.0n 0.4116 434499.9n 0.4116 434500.0n 0.8010 434749.9n 0.8010 434750.0n 0.3545 434999.9n 0.3545 435000.0n 0.4790 435249.9n 0.4790 435250.0n 0.7133 435499.9n 0.7133 435500.0n 0.7978 435749.9n 0.7978 435750.0n 0.6960 435999.9n 0.6960 436000.0n 0.8579 436249.9n 0.8579 436250.0n 0.4175 436499.9n 0.4175 436500.0n 0.4934 436749.9n 0.4934 436750.0n 0.4657 436999.9n 0.4657 437000.0n 0.8064 437249.9n 0.8064 437250.0n 0.8288 437499.9n 0.8288 437500.0n 0.3944 437749.9n 0.3944 437750.0n 0.4660 437999.9n 0.4660 438000.0n 0.4659 438249.9n 0.4659 438250.0n 0.4933 438499.9n 0.4933 438500.0n 0.5175 438749.9n 0.5175 438750.0n 0.8142 438999.9n 0.8142 439000.0n 0.3791 439249.9n 0.3791 439250.0n 0.7886 439499.9n 0.7886 439500.0n 0.7844 439749.9n 0.7844 439750.0n 0.4957 439999.9n 0.4957 440000.0n 0.5465 440249.9n 0.5465 440250.0n 0.6273 440499.9n 0.6273 440500.0n 0.5857 440749.9n 0.5857 440750.0n 0.4116 440999.9n 0.4116 441000.0n 0.5306 441249.9n 0.5306 441250.0n 0.7528 441499.9n 0.7528 441500.0n 0.4522 441749.9n 0.4522 441750.0n 0.7561 441999.9n 0.7561 442000.0n 0.7539 442249.9n 0.7539 442250.0n 0.4983 442499.9n 0.4983 442500.0n 0.5505 442749.9n 0.5505 442750.0n 0.3900 442999.9n 0.3900 443000.0n 0.4842 443249.9n 0.4842 443250.0n 0.5144 443499.9n 0.5144 443500.0n 0.4729 443749.9n 0.4729 443750.0n 0.3629 443999.9n 0.3629 444000.0n 0.5842 444249.9n 0.5842 444250.0n 0.5378 444499.9n 0.5378 444500.0n 0.3959 444749.9n 0.3959 444750.0n 0.8672 444999.9n 0.8672 445000.0n 0.5870 445249.9n 0.5870 445250.0n 0.1497 445499.9n 0.1497 445500.0n 0.8010 445749.9n 0.8010 445750.0n 0.1961 445999.9n 0.1961 446000.0n 0.8979 446249.9n 0.8979 446250.0n 0.4277 446499.9n 0.4277 446500.0n 0.6339 446749.9n 0.6339 446750.0n 0.1772 446999.9n 0.1772 447000.0n 0.5471 447249.9n 0.5471 447250.0n 0.8670 447499.9n 0.8670 447500.0n 0.3545 447749.9n 0.3545 447750.0n 0.4372 447999.9n 0.4372 448000.0n 0.1361 448249.9n 0.1361 448250.0n 0.6598 448499.9n 0.6598 448500.0n 0.3948 448749.9n 0.3948 448750.0n 0.7551 448999.9n 0.7551 449000.0n 0.3914 449249.9n 0.3914 449250.0n 0.5592 449499.9n 0.5592 449500.0n 0.2318 449749.9n 0.2318 449750.0n 0.4889 449999.9n 0.4889 450000.0n 0.4411 450249.9n 0.4411 450250.0n 0.2915 450499.9n 0.2915 450500.0n 0.7800 450749.9n 0.7800 450750.0n 0.4346 450999.9n 0.4346 451000.0n 0.4925 451249.9n 0.4925 451250.0n 0.4485 451499.9n 0.4485 451500.0n 0.4940 451749.9n 0.4940 451750.0n 0.3526 451999.9n 0.3526 452000.0n 0.4433 452249.9n 0.4433 452250.0n 0.8732 452499.9n 0.8732 452500.0n 0.8315 452749.9n 0.8315 452750.0n 0.4881 452999.9n 0.4881 453000.0n 0.5518 453249.9n 0.5518 453250.0n 0.5389 453499.9n 0.5389 453500.0n 0.2992 453749.9n 0.2992 453750.0n 0.6605 453999.9n 0.6605 454000.0n 0.2296 454249.9n 0.2296 454250.0n 0.6161 454499.9n 0.6161 454500.0n 0.1183 454749.9n 0.1183 454750.0n 0.5182 454999.9n 0.5182 455000.0n 0.1478 455249.9n 0.1478 455250.0n 0.6094 455499.9n 0.6094 455500.0n 0.2113 455749.9n 0.2113 455750.0n 0.4981 455999.9n 0.4981 456000.0n 0.3904 456249.9n 0.3904 456250.0n 0.6197 456499.9n 0.6197 456500.0n 0.3775 456749.9n 0.3775 456750.0n 0.2102 456999.9n 0.2102 457000.0n 0.7231 457249.9n 0.7231 457250.0n 0.4982 457499.9n 0.4982 457500.0n 0.4777 457749.9n 0.4777 457750.0n 0.8299 457999.9n 0.8299 458000.0n 0.3467 458249.9n 0.3467 458250.0n 0.4205 458499.9n 0.4205 458500.0n 0.4904 458749.9n 0.4904 458750.0n 0.4859 458999.9n 0.4859 459000.0n 0.6460 459249.9n 0.6460 459250.0n 0.3601 459499.9n 0.3601 459500.0n 0.5005 459749.9n 0.5005 459750.0n 0.8272 459999.9n 0.8272 460000.0n 0.5043 460249.9n 0.5043 460250.0n 0.6406 460499.9n 0.6406 460500.0n 0.3823 460749.9n 0.3823 460750.0n 0.8928 460999.9n 0.8928 461000.0n 0.6761 461249.9n 0.6761 461250.0n 0.4415 461499.9n 0.4415 461500.0n 0.4900 461749.9n 0.4900 461750.0n 0.5523 461999.9n 0.5523 462000.0n 0.5184 462249.9n 0.5184 462250.0n 0.4637 462499.9n 0.4637 462500.0n 0.7836 462749.9n 0.7836 462750.0n 0.2337 462999.9n 0.2337 463000.0n 0.4397 463249.9n 0.4397 463250.0n 0.4062 463499.9n 0.4062 463500.0n 0.5101 463749.9n 0.5101 463750.0n 0.5915 463999.9n 0.5915 464000.0n 0.6177 464249.9n 0.6177 464250.0n 0.2159 464499.9n 0.2159 464500.0n 0.5122 464749.9n 0.5122 464750.0n 0.4670 464999.9n 0.4670 465000.0n 0.5498 465249.9n 0.5498 465250.0n 0.4950 465499.9n 0.4950 465500.0n 0.9315 465749.9n 0.9315 465750.0n 0.4661 465999.9n 0.4661 466000.0n 0.4120 466249.9n 0.4120 466250.0n 0.4486 466499.9n 0.4486 466500.0n 0.0832 466749.9n 0.0832 466750.0n 0.2980 466999.9n 0.2980 467000.0n 0.8027 467249.9n 0.8027 467250.0n 0.4534 467499.9n 0.4534 467500.0n 0.5246 467749.9n 0.5246 467750.0n 0.6208 467999.9n 0.6208 468000.0n 0.4670 468249.9n 0.4670 468250.0n 0.3152 468499.9n 0.3152 468500.0n 0.7875 468749.9n 0.7875 468750.0n 0.6926 468999.9n 0.6926 469000.0n 0.5499 469249.9n 0.5499 469250.0n 0.4880 469499.9n 0.4880 469500.0n 0.6502 469749.9n 0.6502 469750.0n 0.6820 469999.9n 0.6820 470000.0n 0.4786 470249.9n 0.4786 470250.0n 0.5031 470499.9n 0.5031 470500.0n 0.4859 470749.9n 0.4859 470750.0n 0.5380 470999.9n 0.5380 471000.0n 0.1791 471249.9n 0.1791 471250.0n 0.5218 471499.9n 0.5218 471500.0n 0.7794 471749.9n 0.7794 471750.0n 0.5795 471999.9n 0.5795 472000.0n 0.1909 472249.9n 0.1909 472250.0n 0.4490 472499.9n 0.4490 472500.0n 0.6775 472749.9n 0.6775 472750.0n 0.4365 472999.9n 0.4365 473000.0n 0.7195 473249.9n 0.7195 473250.0n 0.5168 473499.9n 0.5168 473500.0n 0.4686 473749.9n 0.4686 473750.0n 0.8181 473999.9n 0.8181 474000.0n 0.1958 474249.9n 0.1958 474250.0n 0.2195 474499.9n 0.2195 474500.0n 0.8354 474749.9n 0.8354 474750.0n 0.5487 474999.9n 0.5487 475000.0n 0.4142 475249.9n 0.4142 475250.0n 0.4914 475499.9n 0.4914 475500.0n 0.5093 475749.9n 0.5093 475750.0n 0.4660 475999.9n 0.4660 476000.0n 0.2426 476249.9n 0.2426 476250.0n 0.5004 476499.9n 0.5004 476500.0n 0.7785 476749.9n 0.7785 476750.0n 0.8408 476999.9n 0.8408 477000.0n 0.4123 477249.9n 0.4123 477250.0n 0.5203 477499.9n 0.5203 477500.0n 0.4156 477749.9n 0.4156 477750.0n 0.8564 477999.9n 0.8564 478000.0n 0.6761 478249.9n 0.6761 478250.0n 0.3507 478499.9n 0.3507 478500.0n 0.4992 478749.9n 0.4992 478750.0n 0.5500 478999.9n 0.5500 479000.0n 0.5178 479249.9n 0.5178 479250.0n 0.3223 479499.9n 0.3223 479500.0n 0.4621 479749.9n 0.4621 479750.0n 0.3032)
Vxop xop 0 PWL(0.0n 0.3000 249.9n 0.3000 250.0n 0.7000 499.9n 0.7000 500.0n 0.3000 749.9n 0.3000 750.0n 0.3000 999.9n 0.3000 1000.0n 0.7000 1249.9n 0.7000 1250.0n 0.3000 1499.9n 0.3000 1500.0n 0.3000 1749.9n 0.3000 1750.0n 0.7000 1999.9n 0.7000 2000.0n 0.7000 2249.9n 0.7000 2250.0n 0.7000 2499.9n 0.7000 2500.0n 0.7000 2749.9n 0.7000 2750.0n 0.7000 2999.9n 0.7000 3000.0n 0.3000 3249.9n 0.3000 3250.0n 0.7000 3499.9n 0.7000 3500.0n 0.3000 3749.9n 0.3000 3750.0n 0.3000 3999.9n 0.3000 4000.0n 0.7000 4249.9n 0.7000 4250.0n 0.7000 4499.9n 0.7000 4500.0n 0.3000 4749.9n 0.3000 4750.0n 0.7000 4999.9n 0.7000 5000.0n 0.7000 5249.9n 0.7000 5250.0n 0.7000 5499.9n 0.7000 5500.0n 0.7000 5749.9n 0.7000 5750.0n 0.7000 5999.9n 0.7000 6000.0n 0.3000 6249.9n 0.3000 6250.0n 0.7000 6499.9n 0.7000 6500.0n 0.7000 6749.9n 0.7000 6750.0n 0.7000 6999.9n 0.7000 7000.0n 0.7000 7249.9n 0.7000 7250.0n 0.3000 7499.9n 0.3000 7500.0n 0.3000 7749.9n 0.3000 7750.0n 0.7000 7999.9n 0.7000 8000.0n 0.7000 8249.9n 0.7000 8250.0n 0.7000 8499.9n 0.7000 8500.0n 0.3000 8749.9n 0.3000 8750.0n 0.7000 8999.9n 0.7000 9000.0n 0.3000 9249.9n 0.3000 9250.0n 0.3000 9499.9n 0.3000 9500.0n 0.3000 9749.9n 0.3000 9750.0n 0.7000 9999.9n 0.7000 10000.0n 0.3000 10249.9n 0.3000 10250.0n 0.7000 10499.9n 0.7000 10500.0n 0.3000 10749.9n 0.3000 10750.0n 0.7000 10999.9n 0.7000 11000.0n 0.3000 11249.9n 0.3000 11250.0n 0.7000 11499.9n 0.7000 11500.0n 0.3000 11749.9n 0.3000 11750.0n 0.3000 11999.9n 0.3000 12000.0n 0.3000 12249.9n 0.3000 12250.0n 0.3000 12499.9n 0.3000 12500.0n 0.3000 12749.9n 0.3000 12750.0n 0.3000 12999.9n 0.3000 13000.0n 0.7000 13249.9n 0.7000 13250.0n 0.3000 13499.9n 0.3000 13500.0n 0.7000 13749.9n 0.7000 13750.0n 0.7000 13999.9n 0.7000 14000.0n 0.7000 14249.9n 0.7000 14250.0n 0.3000 14499.9n 0.3000 14500.0n 0.3000 14749.9n 0.3000 14750.0n 0.7000 14999.9n 0.7000 15000.0n 0.7000 15249.9n 0.7000 15250.0n 0.7000 15499.9n 0.7000 15500.0n 0.7000 15749.9n 0.7000 15750.0n 0.3000 15999.9n 0.3000 16000.0n 0.7000 16249.9n 0.7000 16250.0n 0.7000 16499.9n 0.7000 16500.0n 0.3000 16749.9n 0.3000 16750.0n 0.7000 16999.9n 0.7000 17000.0n 0.3000 17249.9n 0.3000 17250.0n 0.3000 17499.9n 0.3000 17500.0n 0.3000 17749.9n 0.3000 17750.0n 0.7000 17999.9n 0.7000 18000.0n 0.7000 18249.9n 0.7000 18250.0n 0.3000 18499.9n 0.3000 18500.0n 0.3000 18749.9n 0.3000 18750.0n 0.7000 18999.9n 0.7000 19000.0n 0.3000 19249.9n 0.3000 19250.0n 0.7000 19499.9n 0.7000 19500.0n 0.3000 19749.9n 0.3000 19750.0n 0.7000 19999.9n 0.7000 20000.0n 0.3000 20249.9n 0.3000 20250.0n 0.7000 20499.9n 0.7000 20500.0n 0.7000 20749.9n 0.7000 20750.0n 0.3000 20999.9n 0.3000 21000.0n 0.3000 21249.9n 0.3000 21250.0n 0.3000 21499.9n 0.3000 21500.0n 0.3000 21749.9n 0.3000 21750.0n 0.7000 21999.9n 0.7000 22000.0n 0.3000 22249.9n 0.3000 22250.0n 0.3000 22499.9n 0.3000 22500.0n 0.7000 22749.9n 0.7000 22750.0n 0.7000 22999.9n 0.7000 23000.0n 0.3000 23249.9n 0.3000 23250.0n 0.7000 23499.9n 0.7000 23500.0n 0.7000 23749.9n 0.7000 23750.0n 0.3000 23999.9n 0.3000 24000.0n 0.3000 24249.9n 0.3000 24250.0n 0.7000 24499.9n 0.7000 24500.0n 0.7000 24749.9n 0.7000 24750.0n 0.7000 24999.9n 0.7000 25000.0n 0.7000 25249.9n 0.7000 25250.0n 0.3000 25499.9n 0.3000 25500.0n 0.3000 25749.9n 0.3000 25750.0n 0.7000 25999.9n 0.7000 26000.0n 0.7000 26249.9n 0.7000 26250.0n 0.7000 26499.9n 0.7000 26500.0n 0.7000 26749.9n 0.7000 26750.0n 0.3000 26999.9n 0.3000 27000.0n 0.3000 27249.9n 0.3000 27250.0n 0.3000 27499.9n 0.3000 27500.0n 0.3000 27749.9n 0.3000 27750.0n 0.3000 27999.9n 0.3000 28000.0n 0.3000 28249.9n 0.3000 28250.0n 0.7000 28499.9n 0.7000 28500.0n 0.7000 28749.9n 0.7000 28750.0n 0.7000 28999.9n 0.7000 29000.0n 0.7000 29249.9n 0.7000 29250.0n 0.7000 29499.9n 0.7000 29500.0n 0.7000 29749.9n 0.7000 29750.0n 0.3000 29999.9n 0.3000 30000.0n 0.3000 30249.9n 0.3000 30250.0n 0.7000 30499.9n 0.7000 30500.0n 0.7000 30749.9n 0.7000 30750.0n 0.3000 30999.9n 0.3000 31000.0n 0.7000 31249.9n 0.7000 31250.0n 0.3000 31499.9n 0.3000 31500.0n 0.7000 31749.9n 0.7000 31750.0n 0.7000 31999.9n 0.7000 32000.0n 0.7000 32249.9n 0.7000 32250.0n 0.7000 32499.9n 0.7000 32500.0n 0.7000 32749.9n 0.7000 32750.0n 0.3000 32999.9n 0.3000 33000.0n 0.3000 33249.9n 0.3000 33250.0n 0.3000 33499.9n 0.3000 33500.0n 0.7000 33749.9n 0.7000 33750.0n 0.7000 33999.9n 0.7000 34000.0n 0.7000 34249.9n 0.7000 34250.0n 0.7000 34499.9n 0.7000 34500.0n 0.3000 34749.9n 0.3000 34750.0n 0.7000 34999.9n 0.7000 35000.0n 0.3000 35249.9n 0.3000 35250.0n 0.7000 35499.9n 0.7000 35500.0n 0.3000 35749.9n 0.3000 35750.0n 0.3000 35999.9n 0.3000 36000.0n 0.3000 36249.9n 0.3000 36250.0n 0.7000 36499.9n 0.7000 36500.0n 0.7000 36749.9n 0.7000 36750.0n 0.7000 36999.9n 0.7000 37000.0n 0.3000 37249.9n 0.3000 37250.0n 0.3000 37499.9n 0.3000 37500.0n 0.7000 37749.9n 0.7000 37750.0n 0.7000 37999.9n 0.7000 38000.0n 0.3000 38249.9n 0.3000 38250.0n 0.7000 38499.9n 0.7000 38500.0n 0.3000 38749.9n 0.3000 38750.0n 0.7000 38999.9n 0.7000 39000.0n 0.7000 39249.9n 0.7000 39250.0n 0.7000 39499.9n 0.7000 39500.0n 0.3000 39749.9n 0.3000 39750.0n 0.7000 39999.9n 0.7000 40000.0n 0.7000 40249.9n 0.7000 40250.0n 0.7000 40499.9n 0.7000 40500.0n 0.3000 40749.9n 0.3000 40750.0n 0.7000 40999.9n 0.7000 41000.0n 0.3000 41249.9n 0.3000 41250.0n 0.7000 41499.9n 0.7000 41500.0n 0.7000 41749.9n 0.7000 41750.0n 0.3000 41999.9n 0.3000 42000.0n 0.3000 42249.9n 0.3000 42250.0n 0.7000 42499.9n 0.7000 42500.0n 0.3000 42749.9n 0.3000 42750.0n 0.3000 42999.9n 0.3000 43000.0n 0.3000 43249.9n 0.3000 43250.0n 0.3000 43499.9n 0.3000 43500.0n 0.7000 43749.9n 0.7000 43750.0n 0.3000 43999.9n 0.3000 44000.0n 0.7000 44249.9n 0.7000 44250.0n 0.3000 44499.9n 0.3000 44500.0n 0.3000 44749.9n 0.3000 44750.0n 0.3000 44999.9n 0.3000 45000.0n 0.7000 45249.9n 0.7000 45250.0n 0.7000 45499.9n 0.7000 45500.0n 0.3000 45749.9n 0.3000 45750.0n 0.7000 45999.9n 0.7000 46000.0n 0.7000 46249.9n 0.7000 46250.0n 0.3000 46499.9n 0.3000 46500.0n 0.3000 46749.9n 0.3000 46750.0n 0.3000 46999.9n 0.3000 47000.0n 0.3000 47249.9n 0.3000 47250.0n 0.3000 47499.9n 0.3000 47500.0n 0.7000 47749.9n 0.7000 47750.0n 0.7000 47999.9n 0.7000 48000.0n 0.3000 48249.9n 0.3000 48250.0n 0.7000 48499.9n 0.7000 48500.0n 0.7000 48749.9n 0.7000 48750.0n 0.3000 48999.9n 0.3000 49000.0n 0.3000 49249.9n 0.3000 49250.0n 0.3000 49499.9n 0.3000 49500.0n 0.7000 49749.9n 0.7000 49750.0n 0.7000 49999.9n 0.7000 50000.0n 0.3000 50249.9n 0.3000 50250.0n 0.7000 50499.9n 0.7000 50500.0n 0.7000 50749.9n 0.7000 50750.0n 0.3000 50999.9n 0.3000 51000.0n 0.7000 51249.9n 0.7000 51250.0n 0.7000 51499.9n 0.7000 51500.0n 0.7000 51749.9n 0.7000 51750.0n 0.7000 51999.9n 0.7000 52000.0n 0.3000 52249.9n 0.3000 52250.0n 0.3000 52499.9n 0.3000 52500.0n 0.3000 52749.9n 0.3000 52750.0n 0.7000 52999.9n 0.7000 53000.0n 0.3000 53249.9n 0.3000 53250.0n 0.3000 53499.9n 0.3000 53500.0n 0.7000 53749.9n 0.7000 53750.0n 0.7000 53999.9n 0.7000 54000.0n 0.3000 54249.9n 0.3000 54250.0n 0.7000 54499.9n 0.7000 54500.0n 0.3000 54749.9n 0.3000 54750.0n 0.3000 54999.9n 0.3000 55000.0n 0.7000 55249.9n 0.7000 55250.0n 0.3000 55499.9n 0.3000 55500.0n 0.7000 55749.9n 0.7000 55750.0n 0.7000 55999.9n 0.7000 56000.0n 0.3000 56249.9n 0.3000 56250.0n 0.7000 56499.9n 0.7000 56500.0n 0.7000 56749.9n 0.7000 56750.0n 0.3000 56999.9n 0.3000 57000.0n 0.7000 57249.9n 0.7000 57250.0n 0.7000 57499.9n 0.7000 57500.0n 0.3000 57749.9n 0.3000 57750.0n 0.7000 57999.9n 0.7000 58000.0n 0.3000 58249.9n 0.3000 58250.0n 0.3000 58499.9n 0.3000 58500.0n 0.7000 58749.9n 0.7000 58750.0n 0.3000 58999.9n 0.3000 59000.0n 0.7000 59249.9n 0.7000 59250.0n 0.3000 59499.9n 0.3000 59500.0n 0.7000 59749.9n 0.7000 59750.0n 0.7000 59999.9n 0.7000 60000.0n 0.7000 60249.9n 0.7000 60250.0n 0.3000 60499.9n 0.3000 60500.0n 0.3000 60749.9n 0.3000 60750.0n 0.7000 60999.9n 0.7000 61000.0n 0.7000 61249.9n 0.7000 61250.0n 0.3000 61499.9n 0.3000 61500.0n 0.7000 61749.9n 0.7000 61750.0n 0.3000 61999.9n 0.3000 62000.0n 0.7000 62249.9n 0.7000 62250.0n 0.3000 62499.9n 0.3000 62500.0n 0.3000 62749.9n 0.3000 62750.0n 0.7000 62999.9n 0.7000 63000.0n 0.7000 63249.9n 0.7000 63250.0n 0.3000 63499.9n 0.3000 63500.0n 0.3000 63749.9n 0.3000 63750.0n 0.3000 63999.9n 0.3000 64000.0n 0.3000 64249.9n 0.3000 64250.0n 0.3000 64499.9n 0.3000 64500.0n 0.7000 64749.9n 0.7000 64750.0n 0.3000 64999.9n 0.3000 65000.0n 0.7000 65249.9n 0.7000 65250.0n 0.3000 65499.9n 0.3000 65500.0n 0.3000 65749.9n 0.3000 65750.0n 0.7000 65999.9n 0.7000 66000.0n 0.7000 66249.9n 0.7000 66250.0n 0.7000 66499.9n 0.7000 66500.0n 0.3000 66749.9n 0.3000 66750.0n 0.3000 66999.9n 0.3000 67000.0n 0.7000 67249.9n 0.7000 67250.0n 0.7000 67499.9n 0.7000 67500.0n 0.7000 67749.9n 0.7000 67750.0n 0.7000 67999.9n 0.7000 68000.0n 0.3000 68249.9n 0.3000 68250.0n 0.3000 68499.9n 0.3000 68500.0n 0.7000 68749.9n 0.7000 68750.0n 0.7000 68999.9n 0.7000 69000.0n 0.7000 69249.9n 0.7000 69250.0n 0.7000 69499.9n 0.7000 69500.0n 0.3000 69749.9n 0.3000 69750.0n 0.7000 69999.9n 0.7000 70000.0n 0.3000 70249.9n 0.3000 70250.0n 0.3000 70499.9n 0.3000 70500.0n 0.7000 70749.9n 0.7000 70750.0n 0.3000 70999.9n 0.3000 71000.0n 0.3000 71249.9n 0.3000 71250.0n 0.7000 71499.9n 0.7000 71500.0n 0.3000 71749.9n 0.3000 71750.0n 0.3000 71999.9n 0.3000 72000.0n 0.7000 72249.9n 0.7000 72250.0n 0.7000 72499.9n 0.7000 72500.0n 0.7000 72749.9n 0.7000 72750.0n 0.7000 72999.9n 0.7000 73000.0n 0.7000 73249.9n 0.7000 73250.0n 0.3000 73499.9n 0.3000 73500.0n 0.7000 73749.9n 0.7000 73750.0n 0.3000 73999.9n 0.3000 74000.0n 0.7000 74249.9n 0.7000 74250.0n 0.7000 74499.9n 0.7000 74500.0n 0.7000 74749.9n 0.7000 74750.0n 0.3000 74999.9n 0.3000 75000.0n 0.3000 75249.9n 0.3000 75250.0n 0.3000 75499.9n 0.3000 75500.0n 0.7000 75749.9n 0.7000 75750.0n 0.7000 75999.9n 0.7000 76000.0n 0.7000 76249.9n 0.7000 76250.0n 0.3000 76499.9n 0.3000 76500.0n 0.7000 76749.9n 0.7000 76750.0n 0.3000 76999.9n 0.3000 77000.0n 0.3000 77249.9n 0.3000 77250.0n 0.3000 77499.9n 0.3000 77500.0n 0.3000 77749.9n 0.3000 77750.0n 0.7000 77999.9n 0.7000 78000.0n 0.3000 78249.9n 0.3000 78250.0n 0.7000 78499.9n 0.7000 78500.0n 0.7000 78749.9n 0.7000 78750.0n 0.7000 78999.9n 0.7000 79000.0n 0.7000 79249.9n 0.7000 79250.0n 0.3000 79499.9n 0.3000 79500.0n 0.3000 79749.9n 0.3000 79750.0n 0.7000 79999.9n 0.7000 80000.0n 0.3000 80249.9n 0.3000 80250.0n 0.7000 80499.9n 0.7000 80500.0n 0.7000 80749.9n 0.7000 80750.0n 0.3000 80999.9n 0.3000 81000.0n 0.7000 81249.9n 0.7000 81250.0n 0.3000 81499.9n 0.3000 81500.0n 0.7000 81749.9n 0.7000 81750.0n 0.7000 81999.9n 0.7000 82000.0n 0.3000 82249.9n 0.3000 82250.0n 0.7000 82499.9n 0.7000 82500.0n 0.3000 82749.9n 0.3000 82750.0n 0.7000 82999.9n 0.7000 83000.0n 0.3000 83249.9n 0.3000 83250.0n 0.3000 83499.9n 0.3000 83500.0n 0.7000 83749.9n 0.7000 83750.0n 0.3000 83999.9n 0.3000 84000.0n 0.7000 84249.9n 0.7000 84250.0n 0.3000 84499.9n 0.3000 84500.0n 0.7000 84749.9n 0.7000 84750.0n 0.7000 84999.9n 0.7000 85000.0n 0.7000 85249.9n 0.7000 85250.0n 0.7000 85499.9n 0.7000 85500.0n 0.7000 85749.9n 0.7000 85750.0n 0.7000 85999.9n 0.7000 86000.0n 0.3000 86249.9n 0.3000 86250.0n 0.3000 86499.9n 0.3000 86500.0n 0.3000 86749.9n 0.3000 86750.0n 0.7000 86999.9n 0.7000 87000.0n 0.3000 87249.9n 0.3000 87250.0n 0.7000 87499.9n 0.7000 87500.0n 0.3000 87749.9n 0.3000 87750.0n 0.7000 87999.9n 0.7000 88000.0n 0.7000 88249.9n 0.7000 88250.0n 0.7000 88499.9n 0.7000 88500.0n 0.7000 88749.9n 0.7000 88750.0n 0.3000 88999.9n 0.3000 89000.0n 0.3000 89249.9n 0.3000 89250.0n 0.3000 89499.9n 0.3000 89500.0n 0.3000 89749.9n 0.3000 89750.0n 0.7000 89999.9n 0.7000 90000.0n 0.7000 90249.9n 0.7000 90250.0n 0.3000 90499.9n 0.3000 90500.0n 0.7000 90749.9n 0.7000 90750.0n 0.7000 90999.9n 0.7000 91000.0n 0.7000 91249.9n 0.7000 91250.0n 0.7000 91499.9n 0.7000 91500.0n 0.7000 91749.9n 0.7000 91750.0n 0.7000 91999.9n 0.7000 92000.0n 0.7000 92249.9n 0.7000 92250.0n 0.3000 92499.9n 0.3000 92500.0n 0.7000 92749.9n 0.7000 92750.0n 0.3000 92999.9n 0.3000 93000.0n 0.3000 93249.9n 0.3000 93250.0n 0.7000 93499.9n 0.7000 93500.0n 0.3000 93749.9n 0.3000 93750.0n 0.7000 93999.9n 0.7000 94000.0n 0.7000 94249.9n 0.7000 94250.0n 0.7000 94499.9n 0.7000 94500.0n 0.7000 94749.9n 0.7000 94750.0n 0.7000 94999.9n 0.7000 95000.0n 0.3000 95249.9n 0.3000 95250.0n 0.7000 95499.9n 0.7000 95500.0n 0.7000 95749.9n 0.7000 95750.0n 0.3000 95999.9n 0.3000 96000.0n 0.7000 96249.9n 0.7000 96250.0n 0.7000 96499.9n 0.7000 96500.0n 0.3000 96749.9n 0.3000 96750.0n 0.7000 96999.9n 0.7000 97000.0n 0.3000 97249.9n 0.3000 97250.0n 0.7000 97499.9n 0.7000 97500.0n 0.3000 97749.9n 0.3000 97750.0n 0.3000 97999.9n 0.3000 98000.0n 0.3000 98249.9n 0.3000 98250.0n 0.7000 98499.9n 0.7000 98500.0n 0.3000 98749.9n 0.3000 98750.0n 0.7000 98999.9n 0.7000 99000.0n 0.3000 99249.9n 0.3000 99250.0n 0.7000 99499.9n 0.7000 99500.0n 0.3000 99749.9n 0.3000 99750.0n 0.3000 99999.9n 0.3000 100000.0n 0.3000 100249.9n 0.3000 100250.0n 0.7000 100499.9n 0.7000 100500.0n 0.3000 100749.9n 0.3000 100750.0n 0.7000 100999.9n 0.7000 101000.0n 0.3000 101249.9n 0.3000 101250.0n 0.3000 101499.9n 0.3000 101500.0n 0.7000 101749.9n 0.7000 101750.0n 0.3000 101999.9n 0.3000 102000.0n 0.3000 102249.9n 0.3000 102250.0n 0.7000 102499.9n 0.7000 102500.0n 0.7000 102749.9n 0.7000 102750.0n 0.3000 102999.9n 0.3000 103000.0n 0.3000 103249.9n 0.3000 103250.0n 0.7000 103499.9n 0.7000 103500.0n 0.3000 103749.9n 0.3000 103750.0n 0.3000 103999.9n 0.3000 104000.0n 0.3000 104249.9n 0.3000 104250.0n 0.7000 104499.9n 0.7000 104500.0n 0.3000 104749.9n 0.3000 104750.0n 0.7000 104999.9n 0.7000 105000.0n 0.3000 105249.9n 0.3000 105250.0n 0.7000 105499.9n 0.7000 105500.0n 0.3000 105749.9n 0.3000 105750.0n 0.3000 105999.9n 0.3000 106000.0n 0.7000 106249.9n 0.7000 106250.0n 0.7000 106499.9n 0.7000 106500.0n 0.3000 106749.9n 0.3000 106750.0n 0.7000 106999.9n 0.7000 107000.0n 0.3000 107249.9n 0.3000 107250.0n 0.3000 107499.9n 0.3000 107500.0n 0.3000 107749.9n 0.3000 107750.0n 0.7000 107999.9n 0.7000 108000.0n 0.3000 108249.9n 0.3000 108250.0n 0.7000 108499.9n 0.7000 108500.0n 0.7000 108749.9n 0.7000 108750.0n 0.7000 108999.9n 0.7000 109000.0n 0.7000 109249.9n 0.7000 109250.0n 0.3000 109499.9n 0.3000 109500.0n 0.3000 109749.9n 0.3000 109750.0n 0.3000 109999.9n 0.3000 110000.0n 0.3000 110249.9n 0.3000 110250.0n 0.3000 110499.9n 0.3000 110500.0n 0.3000 110749.9n 0.3000 110750.0n 0.3000 110999.9n 0.3000 111000.0n 0.3000 111249.9n 0.3000 111250.0n 0.7000 111499.9n 0.7000 111500.0n 0.7000 111749.9n 0.7000 111750.0n 0.3000 111999.9n 0.3000 112000.0n 0.7000 112249.9n 0.7000 112250.0n 0.3000 112499.9n 0.3000 112500.0n 0.7000 112749.9n 0.7000 112750.0n 0.3000 112999.9n 0.3000 113000.0n 0.7000 113249.9n 0.7000 113250.0n 0.7000 113499.9n 0.7000 113500.0n 0.7000 113749.9n 0.7000 113750.0n 0.7000 113999.9n 0.7000 114000.0n 0.3000 114249.9n 0.3000 114250.0n 0.3000 114499.9n 0.3000 114500.0n 0.7000 114749.9n 0.7000 114750.0n 0.3000 114999.9n 0.3000 115000.0n 0.7000 115249.9n 0.7000 115250.0n 0.3000 115499.9n 0.3000 115500.0n 0.7000 115749.9n 0.7000 115750.0n 0.7000 115999.9n 0.7000 116000.0n 0.7000 116249.9n 0.7000 116250.0n 0.7000 116499.9n 0.7000 116500.0n 0.7000 116749.9n 0.7000 116750.0n 0.7000 116999.9n 0.7000 117000.0n 0.7000 117249.9n 0.7000 117250.0n 0.3000 117499.9n 0.3000 117500.0n 0.7000 117749.9n 0.7000 117750.0n 0.3000 117999.9n 0.3000 118000.0n 0.7000 118249.9n 0.7000 118250.0n 0.3000 118499.9n 0.3000 118500.0n 0.7000 118749.9n 0.7000 118750.0n 0.3000 118999.9n 0.3000 119000.0n 0.7000 119249.9n 0.7000 119250.0n 0.3000 119499.9n 0.3000 119500.0n 0.7000 119749.9n 0.7000 119750.0n 0.7000 119999.9n 0.7000 120000.0n 0.7000 120249.9n 0.7000 120250.0n 0.7000 120499.9n 0.7000 120500.0n 0.7000 120749.9n 0.7000 120750.0n 0.3000 120999.9n 0.3000 121000.0n 0.7000 121249.9n 0.7000 121250.0n 0.7000 121499.9n 0.7000 121500.0n 0.7000 121749.9n 0.7000 121750.0n 0.7000 121999.9n 0.7000 122000.0n 0.3000 122249.9n 0.3000 122250.0n 0.3000 122499.9n 0.3000 122500.0n 0.3000 122749.9n 0.3000 122750.0n 0.3000 122999.9n 0.3000 123000.0n 0.7000 123249.9n 0.7000 123250.0n 0.3000 123499.9n 0.3000 123500.0n 0.3000 123749.9n 0.3000 123750.0n 0.7000 123999.9n 0.7000 124000.0n 0.3000 124249.9n 0.3000 124250.0n 0.7000 124499.9n 0.7000 124500.0n 0.3000 124749.9n 0.3000 124750.0n 0.3000 124999.9n 0.3000 125000.0n 0.3000 125249.9n 0.3000 125250.0n 0.7000 125499.9n 0.7000 125500.0n 0.3000 125749.9n 0.3000 125750.0n 0.7000 125999.9n 0.7000 126000.0n 0.3000 126249.9n 0.3000 126250.0n 0.7000 126499.9n 0.7000 126500.0n 0.3000 126749.9n 0.3000 126750.0n 0.7000 126999.9n 0.7000 127000.0n 0.3000 127249.9n 0.3000 127250.0n 0.3000 127499.9n 0.3000 127500.0n 0.3000 127749.9n 0.3000 127750.0n 0.7000 127999.9n 0.7000 128000.0n 0.7000 128249.9n 0.7000 128250.0n 0.3000 128499.9n 0.3000 128500.0n 0.3000 128749.9n 0.3000 128750.0n 0.7000 128999.9n 0.7000 129000.0n 0.7000 129249.9n 0.7000 129250.0n 0.7000 129499.9n 0.7000 129500.0n 0.7000 129749.9n 0.7000 129750.0n 0.7000 129999.9n 0.7000 130000.0n 0.7000 130249.9n 0.7000 130250.0n 0.7000 130499.9n 0.7000 130500.0n 0.3000 130749.9n 0.3000 130750.0n 0.3000 130999.9n 0.3000 131000.0n 0.7000 131249.9n 0.7000 131250.0n 0.3000 131499.9n 0.3000 131500.0n 0.3000 131749.9n 0.3000 131750.0n 0.7000 131999.9n 0.7000 132000.0n 0.3000 132249.9n 0.3000 132250.0n 0.3000 132499.9n 0.3000 132500.0n 0.7000 132749.9n 0.7000 132750.0n 0.3000 132999.9n 0.3000 133000.0n 0.3000 133249.9n 0.3000 133250.0n 0.7000 133499.9n 0.7000 133500.0n 0.3000 133749.9n 0.3000 133750.0n 0.7000 133999.9n 0.7000 134000.0n 0.7000 134249.9n 0.7000 134250.0n 0.7000 134499.9n 0.7000 134500.0n 0.7000 134749.9n 0.7000 134750.0n 0.7000 134999.9n 0.7000 135000.0n 0.7000 135249.9n 0.7000 135250.0n 0.7000 135499.9n 0.7000 135500.0n 0.7000 135749.9n 0.7000 135750.0n 0.3000 135999.9n 0.3000 136000.0n 0.3000 136249.9n 0.3000 136250.0n 0.3000 136499.9n 0.3000 136500.0n 0.3000 136749.9n 0.3000 136750.0n 0.3000 136999.9n 0.3000 137000.0n 0.3000 137249.9n 0.3000 137250.0n 0.7000 137499.9n 0.7000 137500.0n 0.7000 137749.9n 0.7000 137750.0n 0.3000 137999.9n 0.3000 138000.0n 0.7000 138249.9n 0.7000 138250.0n 0.7000 138499.9n 0.7000 138500.0n 0.3000 138749.9n 0.3000 138750.0n 0.7000 138999.9n 0.7000 139000.0n 0.3000 139249.9n 0.3000 139250.0n 0.3000 139499.9n 0.3000 139500.0n 0.7000 139749.9n 0.7000 139750.0n 0.3000 139999.9n 0.3000 140000.0n 0.7000 140249.9n 0.7000 140250.0n 0.7000 140499.9n 0.7000 140500.0n 0.3000 140749.9n 0.3000 140750.0n 0.7000 140999.9n 0.7000 141000.0n 0.7000 141249.9n 0.7000 141250.0n 0.7000 141499.9n 0.7000 141500.0n 0.3000 141749.9n 0.3000 141750.0n 0.3000 141999.9n 0.3000 142000.0n 0.3000 142249.9n 0.3000 142250.0n 0.3000 142499.9n 0.3000 142500.0n 0.3000 142749.9n 0.3000 142750.0n 0.3000 142999.9n 0.3000 143000.0n 0.7000 143249.9n 0.7000 143250.0n 0.7000 143499.9n 0.7000 143500.0n 0.7000 143749.9n 0.7000 143750.0n 0.7000 143999.9n 0.7000 144000.0n 0.3000 144249.9n 0.3000 144250.0n 0.7000 144499.9n 0.7000 144500.0n 0.3000 144749.9n 0.3000 144750.0n 0.3000 144999.9n 0.3000 145000.0n 0.7000 145249.9n 0.7000 145250.0n 0.7000 145499.9n 0.7000 145500.0n 0.3000 145749.9n 0.3000 145750.0n 0.7000 145999.9n 0.7000 146000.0n 0.7000 146249.9n 0.7000 146250.0n 0.7000 146499.9n 0.7000 146500.0n 0.7000 146749.9n 0.7000 146750.0n 0.7000 146999.9n 0.7000 147000.0n 0.3000 147249.9n 0.3000 147250.0n 0.7000 147499.9n 0.7000 147500.0n 0.7000 147749.9n 0.7000 147750.0n 0.3000 147999.9n 0.3000 148000.0n 0.7000 148249.9n 0.7000 148250.0n 0.7000 148499.9n 0.7000 148500.0n 0.7000 148749.9n 0.7000 148750.0n 0.3000 148999.9n 0.3000 149000.0n 0.3000 149249.9n 0.3000 149250.0n 0.3000 149499.9n 0.3000 149500.0n 0.7000 149749.9n 0.7000 149750.0n 0.3000 149999.9n 0.3000 150000.0n 0.3000 150249.9n 0.3000 150250.0n 0.3000 150499.9n 0.3000 150500.0n 0.7000 150749.9n 0.7000 150750.0n 0.7000 150999.9n 0.7000 151000.0n 0.7000 151249.9n 0.7000 151250.0n 0.3000 151499.9n 0.3000 151500.0n 0.7000 151749.9n 0.7000 151750.0n 0.3000 151999.9n 0.3000 152000.0n 0.3000 152249.9n 0.3000 152250.0n 0.7000 152499.9n 0.7000 152500.0n 0.7000 152749.9n 0.7000 152750.0n 0.7000 152999.9n 0.7000 153000.0n 0.7000 153249.9n 0.7000 153250.0n 0.7000 153499.9n 0.7000 153500.0n 0.3000 153749.9n 0.3000 153750.0n 0.3000 153999.9n 0.3000 154000.0n 0.7000 154249.9n 0.7000 154250.0n 0.3000 154499.9n 0.3000 154500.0n 0.3000 154749.9n 0.3000 154750.0n 0.3000 154999.9n 0.3000 155000.0n 0.3000 155249.9n 0.3000 155250.0n 0.3000 155499.9n 0.3000 155500.0n 0.7000 155749.9n 0.7000 155750.0n 0.3000 155999.9n 0.3000 156000.0n 0.3000 156249.9n 0.3000 156250.0n 0.7000 156499.9n 0.7000 156500.0n 0.3000 156749.9n 0.3000 156750.0n 0.7000 156999.9n 0.7000 157000.0n 0.3000 157249.9n 0.3000 157250.0n 0.7000 157499.9n 0.7000 157500.0n 0.7000 157749.9n 0.7000 157750.0n 0.7000 157999.9n 0.7000 158000.0n 0.7000 158249.9n 0.7000 158250.0n 0.7000 158499.9n 0.7000 158500.0n 0.7000 158749.9n 0.7000 158750.0n 0.3000 158999.9n 0.3000 159000.0n 0.3000 159249.9n 0.3000 159250.0n 0.3000 159499.9n 0.3000 159500.0n 0.3000 159749.9n 0.3000 159750.0n 0.3000 159999.9n 0.3000 160000.0n 0.7000 160249.9n 0.7000 160250.0n 0.3000 160499.9n 0.3000 160500.0n 0.7000 160749.9n 0.7000 160750.0n 0.3000 160999.9n 0.3000 161000.0n 0.3000 161249.9n 0.3000 161250.0n 0.7000 161499.9n 0.7000 161500.0n 0.7000 161749.9n 0.7000 161750.0n 0.7000 161999.9n 0.7000 162000.0n 0.7000 162249.9n 0.7000 162250.0n 0.7000 162499.9n 0.7000 162500.0n 0.7000 162749.9n 0.7000 162750.0n 0.7000 162999.9n 0.7000 163000.0n 0.7000 163249.9n 0.7000 163250.0n 0.3000 163499.9n 0.3000 163500.0n 0.7000 163749.9n 0.7000 163750.0n 0.3000 163999.9n 0.3000 164000.0n 0.3000 164249.9n 0.3000 164250.0n 0.7000 164499.9n 0.7000 164500.0n 0.3000 164749.9n 0.3000 164750.0n 0.7000 164999.9n 0.7000 165000.0n 0.3000 165249.9n 0.3000 165250.0n 0.7000 165499.9n 0.7000 165500.0n 0.7000 165749.9n 0.7000 165750.0n 0.3000 165999.9n 0.3000 166000.0n 0.3000 166249.9n 0.3000 166250.0n 0.7000 166499.9n 0.7000 166500.0n 0.7000 166749.9n 0.7000 166750.0n 0.7000 166999.9n 0.7000 167000.0n 0.3000 167249.9n 0.3000 167250.0n 0.3000 167499.9n 0.3000 167500.0n 0.7000 167749.9n 0.7000 167750.0n 0.3000 167999.9n 0.3000 168000.0n 0.3000 168249.9n 0.3000 168250.0n 0.3000 168499.9n 0.3000 168500.0n 0.7000 168749.9n 0.7000 168750.0n 0.7000 168999.9n 0.7000 169000.0n 0.3000 169249.9n 0.3000 169250.0n 0.7000 169499.9n 0.7000 169500.0n 0.7000 169749.9n 0.7000 169750.0n 0.7000 169999.9n 0.7000 170000.0n 0.3000 170249.9n 0.3000 170250.0n 0.3000 170499.9n 0.3000 170500.0n 0.3000 170749.9n 0.3000 170750.0n 0.7000 170999.9n 0.7000 171000.0n 0.7000 171249.9n 0.7000 171250.0n 0.3000 171499.9n 0.3000 171500.0n 0.7000 171749.9n 0.7000 171750.0n 0.7000 171999.9n 0.7000 172000.0n 0.7000 172249.9n 0.7000 172250.0n 0.7000 172499.9n 0.7000 172500.0n 0.3000 172749.9n 0.3000 172750.0n 0.3000 172999.9n 0.3000 173000.0n 0.3000 173249.9n 0.3000 173250.0n 0.7000 173499.9n 0.7000 173500.0n 0.3000 173749.9n 0.3000 173750.0n 0.7000 173999.9n 0.7000 174000.0n 0.7000 174249.9n 0.7000 174250.0n 0.7000 174499.9n 0.7000 174500.0n 0.7000 174749.9n 0.7000 174750.0n 0.3000 174999.9n 0.3000 175000.0n 0.3000 175249.9n 0.3000 175250.0n 0.3000 175499.9n 0.3000 175500.0n 0.3000 175749.9n 0.3000 175750.0n 0.3000 175999.9n 0.3000 176000.0n 0.7000 176249.9n 0.7000 176250.0n 0.7000 176499.9n 0.7000 176500.0n 0.7000 176749.9n 0.7000 176750.0n 0.7000 176999.9n 0.7000 177000.0n 0.3000 177249.9n 0.3000 177250.0n 0.7000 177499.9n 0.7000 177500.0n 0.3000 177749.9n 0.3000 177750.0n 0.3000 177999.9n 0.3000 178000.0n 0.7000 178249.9n 0.7000 178250.0n 0.3000 178499.9n 0.3000 178500.0n 0.7000 178749.9n 0.7000 178750.0n 0.7000 178999.9n 0.7000 179000.0n 0.3000 179249.9n 0.3000 179250.0n 0.3000 179499.9n 0.3000 179500.0n 0.7000 179749.9n 0.7000 179750.0n 0.7000 179999.9n 0.7000 180000.0n 0.3000 180249.9n 0.3000 180250.0n 0.7000 180499.9n 0.7000 180500.0n 0.3000 180749.9n 0.3000 180750.0n 0.3000 180999.9n 0.3000 181000.0n 0.7000 181249.9n 0.7000 181250.0n 0.3000 181499.9n 0.3000 181500.0n 0.3000 181749.9n 0.3000 181750.0n 0.7000 181999.9n 0.7000 182000.0n 0.7000 182249.9n 0.7000 182250.0n 0.7000 182499.9n 0.7000 182500.0n 0.7000 182749.9n 0.7000 182750.0n 0.3000 182999.9n 0.3000 183000.0n 0.7000 183249.9n 0.7000 183250.0n 0.7000 183499.9n 0.7000 183500.0n 0.7000 183749.9n 0.7000 183750.0n 0.7000 183999.9n 0.7000 184000.0n 0.7000 184249.9n 0.7000 184250.0n 0.7000 184499.9n 0.7000 184500.0n 0.3000 184749.9n 0.3000 184750.0n 0.3000 184999.9n 0.3000 185000.0n 0.3000 185249.9n 0.3000 185250.0n 0.3000 185499.9n 0.3000 185500.0n 0.7000 185749.9n 0.7000 185750.0n 0.7000 185999.9n 0.7000 186000.0n 0.3000 186249.9n 0.3000 186250.0n 0.3000 186499.9n 0.3000 186500.0n 0.7000 186749.9n 0.7000 186750.0n 0.7000 186999.9n 0.7000 187000.0n 0.7000 187249.9n 0.7000 187250.0n 0.7000 187499.9n 0.7000 187500.0n 0.7000 187749.9n 0.7000 187750.0n 0.7000 187999.9n 0.7000 188000.0n 0.7000 188249.9n 0.7000 188250.0n 0.3000 188499.9n 0.3000 188500.0n 0.3000 188749.9n 0.3000 188750.0n 0.3000 188999.9n 0.3000 189000.0n 0.3000 189249.9n 0.3000 189250.0n 0.7000 189499.9n 0.7000 189500.0n 0.3000 189749.9n 0.3000 189750.0n 0.3000 189999.9n 0.3000 190000.0n 0.7000 190249.9n 0.7000 190250.0n 0.3000 190499.9n 0.3000 190500.0n 0.7000 190749.9n 0.7000 190750.0n 0.3000 190999.9n 0.3000 191000.0n 0.7000 191249.9n 0.7000 191250.0n 0.3000 191499.9n 0.3000 191500.0n 0.7000 191749.9n 0.7000 191750.0n 0.7000 191999.9n 0.7000 192000.0n 0.7000 192249.9n 0.7000 192250.0n 0.7000 192499.9n 0.7000 192500.0n 0.3000 192749.9n 0.3000 192750.0n 0.7000 192999.9n 0.7000 193000.0n 0.3000 193249.9n 0.3000 193250.0n 0.3000 193499.9n 0.3000 193500.0n 0.3000 193749.9n 0.3000 193750.0n 0.7000 193999.9n 0.7000 194000.0n 0.3000 194249.9n 0.3000 194250.0n 0.7000 194499.9n 0.7000 194500.0n 0.3000 194749.9n 0.3000 194750.0n 0.3000 194999.9n 0.3000 195000.0n 0.3000 195249.9n 0.3000 195250.0n 0.3000 195499.9n 0.3000 195500.0n 0.7000 195749.9n 0.7000 195750.0n 0.7000 195999.9n 0.7000 196000.0n 0.7000 196249.9n 0.7000 196250.0n 0.3000 196499.9n 0.3000 196500.0n 0.7000 196749.9n 0.7000 196750.0n 0.7000 196999.9n 0.7000 197000.0n 0.7000 197249.9n 0.7000 197250.0n 0.3000 197499.9n 0.3000 197500.0n 0.3000 197749.9n 0.3000 197750.0n 0.7000 197999.9n 0.7000 198000.0n 0.3000 198249.9n 0.3000 198250.0n 0.3000 198499.9n 0.3000 198500.0n 0.3000 198749.9n 0.3000 198750.0n 0.7000 198999.9n 0.7000 199000.0n 0.7000 199249.9n 0.7000 199250.0n 0.7000 199499.9n 0.7000 199500.0n 0.7000 199749.9n 0.7000 199750.0n 0.3000 199999.9n 0.3000 200000.0n 0.3000 200249.9n 0.3000 200250.0n 0.7000 200499.9n 0.7000 200500.0n 0.7000 200749.9n 0.7000 200750.0n 0.7000 200999.9n 0.7000 201000.0n 0.3000 201249.9n 0.3000 201250.0n 0.3000 201499.9n 0.3000 201500.0n 0.3000 201749.9n 0.3000 201750.0n 0.7000 201999.9n 0.7000 202000.0n 0.3000 202249.9n 0.3000 202250.0n 0.3000 202499.9n 0.3000 202500.0n 0.3000 202749.9n 0.3000 202750.0n 0.3000 202999.9n 0.3000 203000.0n 0.7000 203249.9n 0.7000 203250.0n 0.7000 203499.9n 0.7000 203500.0n 0.3000 203749.9n 0.3000 203750.0n 0.7000 203999.9n 0.7000 204000.0n 0.7000 204249.9n 0.7000 204250.0n 0.7000 204499.9n 0.7000 204500.0n 0.3000 204749.9n 0.3000 204750.0n 0.7000 204999.9n 0.7000 205000.0n 0.7000 205249.9n 0.7000 205250.0n 0.7000 205499.9n 0.7000 205500.0n 0.7000 205749.9n 0.7000 205750.0n 0.7000 205999.9n 0.7000 206000.0n 0.3000 206249.9n 0.3000 206250.0n 0.3000 206499.9n 0.3000 206500.0n 0.3000 206749.9n 0.3000 206750.0n 0.7000 206999.9n 0.7000 207000.0n 0.3000 207249.9n 0.3000 207250.0n 0.7000 207499.9n 0.7000 207500.0n 0.3000 207749.9n 0.3000 207750.0n 0.3000 207999.9n 0.3000 208000.0n 0.7000 208249.9n 0.7000 208250.0n 0.7000 208499.9n 0.7000 208500.0n 0.3000 208749.9n 0.3000 208750.0n 0.7000 208999.9n 0.7000 209000.0n 0.7000 209249.9n 0.7000 209250.0n 0.7000 209499.9n 0.7000 209500.0n 0.3000 209749.9n 0.3000 209750.0n 0.3000 209999.9n 0.3000 210000.0n 0.3000 210249.9n 0.3000 210250.0n 0.7000 210499.9n 0.7000 210500.0n 0.3000 210749.9n 0.3000 210750.0n 0.7000 210999.9n 0.7000 211000.0n 0.3000 211249.9n 0.3000 211250.0n 0.7000 211499.9n 0.7000 211500.0n 0.7000 211749.9n 0.7000 211750.0n 0.3000 211999.9n 0.3000 212000.0n 0.3000 212249.9n 0.3000 212250.0n 0.7000 212499.9n 0.7000 212500.0n 0.7000 212749.9n 0.7000 212750.0n 0.3000 212999.9n 0.3000 213000.0n 0.7000 213249.9n 0.7000 213250.0n 0.3000 213499.9n 0.3000 213500.0n 0.7000 213749.9n 0.7000 213750.0n 0.7000 213999.9n 0.7000 214000.0n 0.7000 214249.9n 0.7000 214250.0n 0.7000 214499.9n 0.7000 214500.0n 0.7000 214749.9n 0.7000 214750.0n 0.7000 214999.9n 0.7000 215000.0n 0.7000 215249.9n 0.7000 215250.0n 0.3000 215499.9n 0.3000 215500.0n 0.7000 215749.9n 0.7000 215750.0n 0.3000 215999.9n 0.3000 216000.0n 0.7000 216249.9n 0.7000 216250.0n 0.7000 216499.9n 0.7000 216500.0n 0.3000 216749.9n 0.3000 216750.0n 0.7000 216999.9n 0.7000 217000.0n 0.3000 217249.9n 0.3000 217250.0n 0.3000 217499.9n 0.3000 217500.0n 0.7000 217749.9n 0.7000 217750.0n 0.3000 217999.9n 0.3000 218000.0n 0.3000 218249.9n 0.3000 218250.0n 0.3000 218499.9n 0.3000 218500.0n 0.3000 218749.9n 0.3000 218750.0n 0.7000 218999.9n 0.7000 219000.0n 0.7000 219249.9n 0.7000 219250.0n 0.7000 219499.9n 0.7000 219500.0n 0.7000 219749.9n 0.7000 219750.0n 0.3000 219999.9n 0.3000 220000.0n 0.7000 220249.9n 0.7000 220250.0n 0.7000 220499.9n 0.7000 220500.0n 0.3000 220749.9n 0.3000 220750.0n 0.7000 220999.9n 0.7000 221000.0n 0.3000 221249.9n 0.3000 221250.0n 0.7000 221499.9n 0.7000 221500.0n 0.7000 221749.9n 0.7000 221750.0n 0.3000 221999.9n 0.3000 222000.0n 0.3000 222249.9n 0.3000 222250.0n 0.3000 222499.9n 0.3000 222500.0n 0.3000 222749.9n 0.3000 222750.0n 0.7000 222999.9n 0.7000 223000.0n 0.3000 223249.9n 0.3000 223250.0n 0.3000 223499.9n 0.3000 223500.0n 0.7000 223749.9n 0.7000 223750.0n 0.3000 223999.9n 0.3000 224000.0n 0.3000 224249.9n 0.3000 224250.0n 0.7000 224499.9n 0.7000 224500.0n 0.7000 224749.9n 0.7000 224750.0n 0.3000 224999.9n 0.3000 225000.0n 0.7000 225249.9n 0.7000 225250.0n 0.3000 225499.9n 0.3000 225500.0n 0.7000 225749.9n 0.7000 225750.0n 0.3000 225999.9n 0.3000 226000.0n 0.3000 226249.9n 0.3000 226250.0n 0.3000 226499.9n 0.3000 226500.0n 0.7000 226749.9n 0.7000 226750.0n 0.3000 226999.9n 0.3000 227000.0n 0.3000 227249.9n 0.3000 227250.0n 0.3000 227499.9n 0.3000 227500.0n 0.3000 227749.9n 0.3000 227750.0n 0.7000 227999.9n 0.7000 228000.0n 0.7000 228249.9n 0.7000 228250.0n 0.7000 228499.9n 0.7000 228500.0n 0.7000 228749.9n 0.7000 228750.0n 0.7000 228999.9n 0.7000 229000.0n 0.3000 229249.9n 0.3000 229250.0n 0.7000 229499.9n 0.7000 229500.0n 0.7000 229749.9n 0.7000 229750.0n 0.3000 229999.9n 0.3000 230000.0n 0.7000 230249.9n 0.7000 230250.0n 0.7000 230499.9n 0.7000 230500.0n 0.7000 230749.9n 0.7000 230750.0n 0.3000 230999.9n 0.3000 231000.0n 0.7000 231249.9n 0.7000 231250.0n 0.7000 231499.9n 0.7000 231500.0n 0.3000 231749.9n 0.3000 231750.0n 0.7000 231999.9n 0.7000 232000.0n 0.7000 232249.9n 0.7000 232250.0n 0.7000 232499.9n 0.7000 232500.0n 0.7000 232749.9n 0.7000 232750.0n 0.7000 232999.9n 0.7000 233000.0n 0.3000 233249.9n 0.3000 233250.0n 0.3000 233499.9n 0.3000 233500.0n 0.7000 233749.9n 0.7000 233750.0n 0.3000 233999.9n 0.3000 234000.0n 0.7000 234249.9n 0.7000 234250.0n 0.7000 234499.9n 0.7000 234500.0n 0.7000 234749.9n 0.7000 234750.0n 0.7000 234999.9n 0.7000 235000.0n 0.7000 235249.9n 0.7000 235250.0n 0.3000 235499.9n 0.3000 235500.0n 0.7000 235749.9n 0.7000 235750.0n 0.7000 235999.9n 0.7000 236000.0n 0.3000 236249.9n 0.3000 236250.0n 0.3000 236499.9n 0.3000 236500.0n 0.3000 236749.9n 0.3000 236750.0n 0.7000 236999.9n 0.7000 237000.0n 0.3000 237249.9n 0.3000 237250.0n 0.7000 237499.9n 0.7000 237500.0n 0.7000 237749.9n 0.7000 237750.0n 0.3000 237999.9n 0.3000 238000.0n 0.3000 238249.9n 0.3000 238250.0n 0.3000 238499.9n 0.3000 238500.0n 0.3000 238749.9n 0.3000 238750.0n 0.7000 238999.9n 0.7000 239000.0n 0.3000 239249.9n 0.3000 239250.0n 0.3000 239499.9n 0.3000 239500.0n 0.3000 239749.9n 0.3000 239750.0n 0.3000 239999.9n 0.3000 240000.0n 0.7000 240249.9n 0.7000 240250.0n 0.3000 240499.9n 0.3000 240500.0n 0.3000 240749.9n 0.3000 240750.0n 0.7000 240999.9n 0.7000 241000.0n 0.3000 241249.9n 0.3000 241250.0n 0.7000 241499.9n 0.7000 241500.0n 0.7000 241749.9n 0.7000 241750.0n 0.3000 241999.9n 0.3000 242000.0n 0.7000 242249.9n 0.7000 242250.0n 0.3000 242499.9n 0.3000 242500.0n 0.3000 242749.9n 0.3000 242750.0n 0.3000 242999.9n 0.3000 243000.0n 0.7000 243249.9n 0.7000 243250.0n 0.7000 243499.9n 0.7000 243500.0n 0.3000 243749.9n 0.3000 243750.0n 0.3000 243999.9n 0.3000 244000.0n 0.3000 244249.9n 0.3000 244250.0n 0.3000 244499.9n 0.3000 244500.0n 0.3000 244749.9n 0.3000 244750.0n 0.7000 244999.9n 0.7000 245000.0n 0.7000 245249.9n 0.7000 245250.0n 0.7000 245499.9n 0.7000 245500.0n 0.3000 245749.9n 0.3000 245750.0n 0.3000 245999.9n 0.3000 246000.0n 0.3000 246249.9n 0.3000 246250.0n 0.7000 246499.9n 0.7000 246500.0n 0.7000 246749.9n 0.7000 246750.0n 0.3000 246999.9n 0.3000 247000.0n 0.7000 247249.9n 0.7000 247250.0n 0.3000 247499.9n 0.3000 247500.0n 0.7000 247749.9n 0.7000 247750.0n 0.7000 247999.9n 0.7000 248000.0n 0.7000 248249.9n 0.7000 248250.0n 0.7000 248499.9n 0.7000 248500.0n 0.3000 248749.9n 0.3000 248750.0n 0.7000 248999.9n 0.7000 249000.0n 0.3000 249249.9n 0.3000 249250.0n 0.3000 249499.9n 0.3000 249500.0n 0.7000 249749.9n 0.7000 249750.0n 0.7000 249999.9n 0.7000 250000.0n 0.7000 250249.9n 0.7000 250250.0n 0.7000 250499.9n 0.7000 250500.0n 0.7000 250749.9n 0.7000 250750.0n 0.3000 250999.9n 0.3000 251000.0n 0.3000 251249.9n 0.3000 251250.0n 0.3000 251499.9n 0.3000 251500.0n 0.7000 251749.9n 0.7000 251750.0n 0.7000 251999.9n 0.7000 252000.0n 0.3000 252249.9n 0.3000 252250.0n 0.7000 252499.9n 0.7000 252500.0n 0.3000 252749.9n 0.3000 252750.0n 0.7000 252999.9n 0.7000 253000.0n 0.7000 253249.9n 0.7000 253250.0n 0.3000 253499.9n 0.3000 253500.0n 0.7000 253749.9n 0.7000 253750.0n 0.7000 253999.9n 0.7000 254000.0n 0.3000 254249.9n 0.3000 254250.0n 0.7000 254499.9n 0.7000 254500.0n 0.7000 254749.9n 0.7000 254750.0n 0.3000 254999.9n 0.3000 255000.0n 0.3000 255249.9n 0.3000 255250.0n 0.7000 255499.9n 0.7000 255500.0n 0.7000 255749.9n 0.7000 255750.0n 0.3000 255999.9n 0.3000 256000.0n 0.7000 256249.9n 0.7000 256250.0n 0.7000 256499.9n 0.7000 256500.0n 0.7000 256749.9n 0.7000 256750.0n 0.7000 256999.9n 0.7000 257000.0n 0.3000 257249.9n 0.3000 257250.0n 0.3000 257499.9n 0.3000 257500.0n 0.3000 257749.9n 0.3000 257750.0n 0.3000 257999.9n 0.3000 258000.0n 0.7000 258249.9n 0.7000 258250.0n 0.3000 258499.9n 0.3000 258500.0n 0.3000 258749.9n 0.3000 258750.0n 0.3000 258999.9n 0.3000 259000.0n 0.7000 259249.9n 0.7000 259250.0n 0.7000 259499.9n 0.7000 259500.0n 0.3000 259749.9n 0.3000 259750.0n 0.3000 259999.9n 0.3000 260000.0n 0.7000 260249.9n 0.7000 260250.0n 0.7000 260499.9n 0.7000 260500.0n 0.7000 260749.9n 0.7000 260750.0n 0.3000 260999.9n 0.3000 261000.0n 0.7000 261249.9n 0.7000 261250.0n 0.3000 261499.9n 0.3000 261500.0n 0.7000 261749.9n 0.7000 261750.0n 0.3000 261999.9n 0.3000 262000.0n 0.7000 262249.9n 0.7000 262250.0n 0.7000 262499.9n 0.7000 262500.0n 0.7000 262749.9n 0.7000 262750.0n 0.7000 262999.9n 0.7000 263000.0n 0.7000 263249.9n 0.7000 263250.0n 0.3000 263499.9n 0.3000 263500.0n 0.7000 263749.9n 0.7000 263750.0n 0.7000 263999.9n 0.7000 264000.0n 0.7000 264249.9n 0.7000 264250.0n 0.7000 264499.9n 0.7000 264500.0n 0.7000 264749.9n 0.7000 264750.0n 0.3000 264999.9n 0.3000 265000.0n 0.7000 265249.9n 0.7000 265250.0n 0.3000 265499.9n 0.3000 265500.0n 0.3000 265749.9n 0.3000 265750.0n 0.3000 265999.9n 0.3000 266000.0n 0.7000 266249.9n 0.7000 266250.0n 0.3000 266499.9n 0.3000 266500.0n 0.7000 266749.9n 0.7000 266750.0n 0.7000 266999.9n 0.7000 267000.0n 0.3000 267249.9n 0.3000 267250.0n 0.3000 267499.9n 0.3000 267500.0n 0.7000 267749.9n 0.7000 267750.0n 0.3000 267999.9n 0.3000 268000.0n 0.3000 268249.9n 0.3000 268250.0n 0.7000 268499.9n 0.7000 268500.0n 0.3000 268749.9n 0.3000 268750.0n 0.3000 268999.9n 0.3000 269000.0n 0.3000 269249.9n 0.3000 269250.0n 0.7000 269499.9n 0.7000 269500.0n 0.3000 269749.9n 0.3000 269750.0n 0.7000 269999.9n 0.7000 270000.0n 0.7000 270249.9n 0.7000 270250.0n 0.3000 270499.9n 0.3000 270500.0n 0.3000 270749.9n 0.3000 270750.0n 0.7000 270999.9n 0.7000 271000.0n 0.7000 271249.9n 0.7000 271250.0n 0.7000 271499.9n 0.7000 271500.0n 0.7000 271749.9n 0.7000 271750.0n 0.7000 271999.9n 0.7000 272000.0n 0.3000 272249.9n 0.3000 272250.0n 0.3000 272499.9n 0.3000 272500.0n 0.3000 272749.9n 0.3000 272750.0n 0.3000 272999.9n 0.3000 273000.0n 0.7000 273249.9n 0.7000 273250.0n 0.7000 273499.9n 0.7000 273500.0n 0.3000 273749.9n 0.3000 273750.0n 0.7000 273999.9n 0.7000 274000.0n 0.7000 274249.9n 0.7000 274250.0n 0.3000 274499.9n 0.3000 274500.0n 0.7000 274749.9n 0.7000 274750.0n 0.7000 274999.9n 0.7000 275000.0n 0.3000 275249.9n 0.3000 275250.0n 0.3000 275499.9n 0.3000 275500.0n 0.3000 275749.9n 0.3000 275750.0n 0.3000 275999.9n 0.3000 276000.0n 0.7000 276249.9n 0.7000 276250.0n 0.3000 276499.9n 0.3000 276500.0n 0.3000 276749.9n 0.3000 276750.0n 0.7000 276999.9n 0.7000 277000.0n 0.7000 277249.9n 0.7000 277250.0n 0.7000 277499.9n 0.7000 277500.0n 0.3000 277749.9n 0.3000 277750.0n 0.7000 277999.9n 0.7000 278000.0n 0.3000 278249.9n 0.3000 278250.0n 0.7000 278499.9n 0.7000 278500.0n 0.7000 278749.9n 0.7000 278750.0n 0.3000 278999.9n 0.3000 279000.0n 0.7000 279249.9n 0.7000 279250.0n 0.3000 279499.9n 0.3000 279500.0n 0.7000 279749.9n 0.7000 279750.0n 0.7000 279999.9n 0.7000 280000.0n 0.7000 280249.9n 0.7000 280250.0n 0.3000 280499.9n 0.3000 280500.0n 0.3000 280749.9n 0.3000 280750.0n 0.3000 280999.9n 0.3000 281000.0n 0.3000 281249.9n 0.3000 281250.0n 0.3000 281499.9n 0.3000 281500.0n 0.7000 281749.9n 0.7000 281750.0n 0.3000 281999.9n 0.3000 282000.0n 0.7000 282249.9n 0.7000 282250.0n 0.7000 282499.9n 0.7000 282500.0n 0.7000 282749.9n 0.7000 282750.0n 0.3000 282999.9n 0.3000 283000.0n 0.7000 283249.9n 0.7000 283250.0n 0.3000 283499.9n 0.3000 283500.0n 0.3000 283749.9n 0.3000 283750.0n 0.7000 283999.9n 0.7000 284000.0n 0.3000 284249.9n 0.3000 284250.0n 0.7000 284499.9n 0.7000 284500.0n 0.7000 284749.9n 0.7000 284750.0n 0.7000 284999.9n 0.7000 285000.0n 0.3000 285249.9n 0.3000 285250.0n 0.7000 285499.9n 0.7000 285500.0n 0.3000 285749.9n 0.3000 285750.0n 0.7000 285999.9n 0.7000 286000.0n 0.7000 286249.9n 0.7000 286250.0n 0.7000 286499.9n 0.7000 286500.0n 0.3000 286749.9n 0.3000 286750.0n 0.7000 286999.9n 0.7000 287000.0n 0.3000 287249.9n 0.3000 287250.0n 0.7000 287499.9n 0.7000 287500.0n 0.7000 287749.9n 0.7000 287750.0n 0.7000 287999.9n 0.7000 288000.0n 0.3000 288249.9n 0.3000 288250.0n 0.7000 288499.9n 0.7000 288500.0n 0.3000 288749.9n 0.3000 288750.0n 0.3000 288999.9n 0.3000 289000.0n 0.3000 289249.9n 0.3000 289250.0n 0.3000 289499.9n 0.3000 289500.0n 0.3000 289749.9n 0.3000 289750.0n 0.3000 289999.9n 0.3000 290000.0n 0.7000 290249.9n 0.7000 290250.0n 0.7000 290499.9n 0.7000 290500.0n 0.7000 290749.9n 0.7000 290750.0n 0.3000 290999.9n 0.3000 291000.0n 0.3000 291249.9n 0.3000 291250.0n 0.7000 291499.9n 0.7000 291500.0n 0.7000 291749.9n 0.7000 291750.0n 0.7000 291999.9n 0.7000 292000.0n 0.7000 292249.9n 0.7000 292250.0n 0.3000 292499.9n 0.3000 292500.0n 0.7000 292749.9n 0.7000 292750.0n 0.3000 292999.9n 0.3000 293000.0n 0.3000 293249.9n 0.3000 293250.0n 0.3000 293499.9n 0.3000 293500.0n 0.3000 293749.9n 0.3000 293750.0n 0.3000 293999.9n 0.3000 294000.0n 0.3000 294249.9n 0.3000 294250.0n 0.7000 294499.9n 0.7000 294500.0n 0.3000 294749.9n 0.3000 294750.0n 0.7000 294999.9n 0.7000 295000.0n 0.7000 295249.9n 0.7000 295250.0n 0.7000 295499.9n 0.7000 295500.0n 0.7000 295749.9n 0.7000 295750.0n 0.7000 295999.9n 0.7000 296000.0n 0.7000 296249.9n 0.7000 296250.0n 0.7000 296499.9n 0.7000 296500.0n 0.7000 296749.9n 0.7000 296750.0n 0.7000 296999.9n 0.7000 297000.0n 0.3000 297249.9n 0.3000 297250.0n 0.3000 297499.9n 0.3000 297500.0n 0.3000 297749.9n 0.3000 297750.0n 0.7000 297999.9n 0.7000 298000.0n 0.7000 298249.9n 0.7000 298250.0n 0.7000 298499.9n 0.7000 298500.0n 0.3000 298749.9n 0.3000 298750.0n 0.7000 298999.9n 0.7000 299000.0n 0.3000 299249.9n 0.3000 299250.0n 0.3000 299499.9n 0.3000 299500.0n 0.7000 299749.9n 0.7000 299750.0n 0.3000 299999.9n 0.3000 300000.0n 0.7000 300249.9n 0.7000 300250.0n 0.7000 300499.9n 0.7000 300500.0n 0.3000 300749.9n 0.3000 300750.0n 0.7000 300999.9n 0.7000 301000.0n 0.3000 301249.9n 0.3000 301250.0n 0.7000 301499.9n 0.7000 301500.0n 0.7000 301749.9n 0.7000 301750.0n 0.3000 301999.9n 0.3000 302000.0n 0.7000 302249.9n 0.7000 302250.0n 0.7000 302499.9n 0.7000 302500.0n 0.3000 302749.9n 0.3000 302750.0n 0.3000 302999.9n 0.3000 303000.0n 0.3000 303249.9n 0.3000 303250.0n 0.7000 303499.9n 0.7000 303500.0n 0.7000 303749.9n 0.7000 303750.0n 0.7000 303999.9n 0.7000 304000.0n 0.3000 304249.9n 0.3000 304250.0n 0.3000 304499.9n 0.3000 304500.0n 0.7000 304749.9n 0.7000 304750.0n 0.7000 304999.9n 0.7000 305000.0n 0.3000 305249.9n 0.3000 305250.0n 0.7000 305499.9n 0.7000 305500.0n 0.3000 305749.9n 0.3000 305750.0n 0.3000 305999.9n 0.3000 306000.0n 0.3000 306249.9n 0.3000 306250.0n 0.7000 306499.9n 0.7000 306500.0n 0.7000 306749.9n 0.7000 306750.0n 0.3000 306999.9n 0.3000 307000.0n 0.7000 307249.9n 0.7000 307250.0n 0.7000 307499.9n 0.7000 307500.0n 0.3000 307749.9n 0.3000 307750.0n 0.3000 307999.9n 0.3000 308000.0n 0.3000 308249.9n 0.3000 308250.0n 0.3000 308499.9n 0.3000 308500.0n 0.7000 308749.9n 0.7000 308750.0n 0.7000 308999.9n 0.7000 309000.0n 0.3000 309249.9n 0.3000 309250.0n 0.3000 309499.9n 0.3000 309500.0n 0.3000 309749.9n 0.3000 309750.0n 0.3000 309999.9n 0.3000 310000.0n 0.7000 310249.9n 0.7000 310250.0n 0.7000 310499.9n 0.7000 310500.0n 0.7000 310749.9n 0.7000 310750.0n 0.3000 310999.9n 0.3000 311000.0n 0.7000 311249.9n 0.7000 311250.0n 0.7000 311499.9n 0.7000 311500.0n 0.3000 311749.9n 0.3000 311750.0n 0.3000 311999.9n 0.3000 312000.0n 0.3000 312249.9n 0.3000 312250.0n 0.7000 312499.9n 0.7000 312500.0n 0.7000 312749.9n 0.7000 312750.0n 0.3000 312999.9n 0.3000 313000.0n 0.3000 313249.9n 0.3000 313250.0n 0.7000 313499.9n 0.7000 313500.0n 0.7000 313749.9n 0.7000 313750.0n 0.7000 313999.9n 0.7000 314000.0n 0.7000 314249.9n 0.7000 314250.0n 0.3000 314499.9n 0.3000 314500.0n 0.7000 314749.9n 0.7000 314750.0n 0.7000 314999.9n 0.7000 315000.0n 0.3000 315249.9n 0.3000 315250.0n 0.7000 315499.9n 0.7000 315500.0n 0.3000 315749.9n 0.3000 315750.0n 0.7000 315999.9n 0.7000 316000.0n 0.7000 316249.9n 0.7000 316250.0n 0.3000 316499.9n 0.3000 316500.0n 0.3000 316749.9n 0.3000 316750.0n 0.7000 316999.9n 0.7000 317000.0n 0.7000 317249.9n 0.7000 317250.0n 0.7000 317499.9n 0.7000 317500.0n 0.7000 317749.9n 0.7000 317750.0n 0.7000 317999.9n 0.7000 318000.0n 0.3000 318249.9n 0.3000 318250.0n 0.3000 318499.9n 0.3000 318500.0n 0.7000 318749.9n 0.7000 318750.0n 0.7000 318999.9n 0.7000 319000.0n 0.7000 319249.9n 0.7000 319250.0n 0.3000 319499.9n 0.3000 319500.0n 0.3000 319749.9n 0.3000 319750.0n 0.7000 319999.9n 0.7000 320000.0n 0.7000 320249.9n 0.7000 320250.0n 0.7000 320499.9n 0.7000 320500.0n 0.3000 320749.9n 0.3000 320750.0n 0.7000 320999.9n 0.7000 321000.0n 0.3000 321249.9n 0.3000 321250.0n 0.7000 321499.9n 0.7000 321500.0n 0.3000 321749.9n 0.3000 321750.0n 0.3000 321999.9n 0.3000 322000.0n 0.3000 322249.9n 0.3000 322250.0n 0.3000 322499.9n 0.3000 322500.0n 0.7000 322749.9n 0.7000 322750.0n 0.7000 322999.9n 0.7000 323000.0n 0.3000 323249.9n 0.3000 323250.0n 0.7000 323499.9n 0.7000 323500.0n 0.7000 323749.9n 0.7000 323750.0n 0.7000 323999.9n 0.7000 324000.0n 0.3000 324249.9n 0.3000 324250.0n 0.7000 324499.9n 0.7000 324500.0n 0.3000 324749.9n 0.3000 324750.0n 0.7000 324999.9n 0.7000 325000.0n 0.7000 325249.9n 0.7000 325250.0n 0.7000 325499.9n 0.7000 325500.0n 0.3000 325749.9n 0.3000 325750.0n 0.7000 325999.9n 0.7000 326000.0n 0.3000 326249.9n 0.3000 326250.0n 0.7000 326499.9n 0.7000 326500.0n 0.3000 326749.9n 0.3000 326750.0n 0.7000 326999.9n 0.7000 327000.0n 0.3000 327249.9n 0.3000 327250.0n 0.3000 327499.9n 0.3000 327500.0n 0.7000 327749.9n 0.7000 327750.0n 0.3000 327999.9n 0.3000 328000.0n 0.3000 328249.9n 0.3000 328250.0n 0.7000 328499.9n 0.7000 328500.0n 0.3000 328749.9n 0.3000 328750.0n 0.7000 328999.9n 0.7000 329000.0n 0.3000 329249.9n 0.3000 329250.0n 0.3000 329499.9n 0.3000 329500.0n 0.7000 329749.9n 0.7000 329750.0n 0.3000 329999.9n 0.3000 330000.0n 0.7000 330249.9n 0.7000 330250.0n 0.3000 330499.9n 0.3000 330500.0n 0.3000 330749.9n 0.3000 330750.0n 0.7000 330999.9n 0.7000 331000.0n 0.3000 331249.9n 0.3000 331250.0n 0.3000 331499.9n 0.3000 331500.0n 0.3000 331749.9n 0.3000 331750.0n 0.3000 331999.9n 0.3000 332000.0n 0.3000 332249.9n 0.3000 332250.0n 0.3000 332499.9n 0.3000 332500.0n 0.7000 332749.9n 0.7000 332750.0n 0.7000 332999.9n 0.7000 333000.0n 0.3000 333249.9n 0.3000 333250.0n 0.7000 333499.9n 0.7000 333500.0n 0.7000 333749.9n 0.7000 333750.0n 0.7000 333999.9n 0.7000 334000.0n 0.7000 334249.9n 0.7000 334250.0n 0.7000 334499.9n 0.7000 334500.0n 0.7000 334749.9n 0.7000 334750.0n 0.3000 334999.9n 0.3000 335000.0n 0.7000 335249.9n 0.7000 335250.0n 0.7000 335499.9n 0.7000 335500.0n 0.3000 335749.9n 0.3000 335750.0n 0.3000 335999.9n 0.3000 336000.0n 0.7000 336249.9n 0.7000 336250.0n 0.3000 336499.9n 0.3000 336500.0n 0.3000 336749.9n 0.3000 336750.0n 0.3000 336999.9n 0.3000 337000.0n 0.3000 337249.9n 0.3000 337250.0n 0.7000 337499.9n 0.7000 337500.0n 0.7000 337749.9n 0.7000 337750.0n 0.3000 337999.9n 0.3000 338000.0n 0.7000 338249.9n 0.7000 338250.0n 0.3000 338499.9n 0.3000 338500.0n 0.7000 338749.9n 0.7000 338750.0n 0.3000 338999.9n 0.3000 339000.0n 0.3000 339249.9n 0.3000 339250.0n 0.7000 339499.9n 0.7000 339500.0n 0.7000 339749.9n 0.7000 339750.0n 0.3000 339999.9n 0.3000 340000.0n 0.7000 340249.9n 0.7000 340250.0n 0.3000 340499.9n 0.3000 340500.0n 0.3000 340749.9n 0.3000 340750.0n 0.3000 340999.9n 0.3000 341000.0n 0.7000 341249.9n 0.7000 341250.0n 0.7000 341499.9n 0.7000 341500.0n 0.3000 341749.9n 0.3000 341750.0n 0.3000 341999.9n 0.3000 342000.0n 0.7000 342249.9n 0.7000 342250.0n 0.7000 342499.9n 0.7000 342500.0n 0.7000 342749.9n 0.7000 342750.0n 0.7000 342999.9n 0.7000 343000.0n 0.7000 343249.9n 0.7000 343250.0n 0.7000 343499.9n 0.7000 343500.0n 0.3000 343749.9n 0.3000 343750.0n 0.7000 343999.9n 0.7000 344000.0n 0.7000 344249.9n 0.7000 344250.0n 0.3000 344499.9n 0.3000 344500.0n 0.7000 344749.9n 0.7000 344750.0n 0.7000 344999.9n 0.7000 345000.0n 0.3000 345249.9n 0.3000 345250.0n 0.3000 345499.9n 0.3000 345500.0n 0.3000 345749.9n 0.3000 345750.0n 0.3000 345999.9n 0.3000 346000.0n 0.3000 346249.9n 0.3000 346250.0n 0.3000 346499.9n 0.3000 346500.0n 0.7000 346749.9n 0.7000 346750.0n 0.7000 346999.9n 0.7000 347000.0n 0.7000 347249.9n 0.7000 347250.0n 0.3000 347499.9n 0.3000 347500.0n 0.7000 347749.9n 0.7000 347750.0n 0.7000 347999.9n 0.7000 348000.0n 0.7000 348249.9n 0.7000 348250.0n 0.7000 348499.9n 0.7000 348500.0n 0.3000 348749.9n 0.3000 348750.0n 0.7000 348999.9n 0.7000 349000.0n 0.3000 349249.9n 0.3000 349250.0n 0.7000 349499.9n 0.7000 349500.0n 0.7000 349749.9n 0.7000 349750.0n 0.3000 349999.9n 0.3000 350000.0n 0.7000 350249.9n 0.7000 350250.0n 0.3000 350499.9n 0.3000 350500.0n 0.3000 350749.9n 0.3000 350750.0n 0.7000 350999.9n 0.7000 351000.0n 0.3000 351249.9n 0.3000 351250.0n 0.7000 351499.9n 0.7000 351500.0n 0.7000 351749.9n 0.7000 351750.0n 0.7000 351999.9n 0.7000 352000.0n 0.3000 352249.9n 0.3000 352250.0n 0.7000 352499.9n 0.7000 352500.0n 0.3000 352749.9n 0.3000 352750.0n 0.7000 352999.9n 0.7000 353000.0n 0.7000 353249.9n 0.7000 353250.0n 0.7000 353499.9n 0.7000 353500.0n 0.3000 353749.9n 0.3000 353750.0n 0.3000 353999.9n 0.3000 354000.0n 0.7000 354249.9n 0.7000 354250.0n 0.3000 354499.9n 0.3000 354500.0n 0.7000 354749.9n 0.7000 354750.0n 0.3000 354999.9n 0.3000 355000.0n 0.3000 355249.9n 0.3000 355250.0n 0.3000 355499.9n 0.3000 355500.0n 0.3000 355749.9n 0.3000 355750.0n 0.3000 355999.9n 0.3000 356000.0n 0.3000 356249.9n 0.3000 356250.0n 0.7000 356499.9n 0.7000 356500.0n 0.7000 356749.9n 0.7000 356750.0n 0.7000 356999.9n 0.7000 357000.0n 0.3000 357249.9n 0.3000 357250.0n 0.7000 357499.9n 0.7000 357500.0n 0.3000 357749.9n 0.3000 357750.0n 0.3000 357999.9n 0.3000 358000.0n 0.7000 358249.9n 0.7000 358250.0n 0.7000 358499.9n 0.7000 358500.0n 0.3000 358749.9n 0.3000 358750.0n 0.7000 358999.9n 0.7000 359000.0n 0.7000 359249.9n 0.7000 359250.0n 0.7000 359499.9n 0.7000 359500.0n 0.7000 359749.9n 0.7000 359750.0n 0.7000 359999.9n 0.7000 360000.0n 0.3000 360249.9n 0.3000 360250.0n 0.7000 360499.9n 0.7000 360500.0n 0.3000 360749.9n 0.3000 360750.0n 0.7000 360999.9n 0.7000 361000.0n 0.7000 361249.9n 0.7000 361250.0n 0.3000 361499.9n 0.3000 361500.0n 0.7000 361749.9n 0.7000 361750.0n 0.7000 361999.9n 0.7000 362000.0n 0.3000 362249.9n 0.3000 362250.0n 0.7000 362499.9n 0.7000 362500.0n 0.7000 362749.9n 0.7000 362750.0n 0.7000 362999.9n 0.7000 363000.0n 0.3000 363249.9n 0.3000 363250.0n 0.3000 363499.9n 0.3000 363500.0n 0.3000 363749.9n 0.3000 363750.0n 0.3000 363999.9n 0.3000 364000.0n 0.7000 364249.9n 0.7000 364250.0n 0.7000 364499.9n 0.7000 364500.0n 0.7000 364749.9n 0.7000 364750.0n 0.7000 364999.9n 0.7000 365000.0n 0.7000 365249.9n 0.7000 365250.0n 0.3000 365499.9n 0.3000 365500.0n 0.7000 365749.9n 0.7000 365750.0n 0.3000 365999.9n 0.3000 366000.0n 0.7000 366249.9n 0.7000 366250.0n 0.7000 366499.9n 0.7000 366500.0n 0.3000 366749.9n 0.3000 366750.0n 0.7000 366999.9n 0.7000 367000.0n 0.7000 367249.9n 0.7000 367250.0n 0.7000 367499.9n 0.7000 367500.0n 0.7000 367749.9n 0.7000 367750.0n 0.3000 367999.9n 0.3000 368000.0n 0.3000 368249.9n 0.3000 368250.0n 0.3000 368499.9n 0.3000 368500.0n 0.3000 368749.9n 0.3000 368750.0n 0.7000 368999.9n 0.7000 369000.0n 0.3000 369249.9n 0.3000 369250.0n 0.7000 369499.9n 0.7000 369500.0n 0.3000 369749.9n 0.3000 369750.0n 0.7000 369999.9n 0.7000 370000.0n 0.3000 370249.9n 0.3000 370250.0n 0.3000 370499.9n 0.3000 370500.0n 0.3000 370749.9n 0.3000 370750.0n 0.7000 370999.9n 0.7000 371000.0n 0.3000 371249.9n 0.3000 371250.0n 0.7000 371499.9n 0.7000 371500.0n 0.7000 371749.9n 0.7000 371750.0n 0.7000 371999.9n 0.7000 372000.0n 0.7000 372249.9n 0.7000 372250.0n 0.3000 372499.9n 0.3000 372500.0n 0.3000 372749.9n 0.3000 372750.0n 0.7000 372999.9n 0.7000 373000.0n 0.3000 373249.9n 0.3000 373250.0n 0.7000 373499.9n 0.7000 373500.0n 0.3000 373749.9n 0.3000 373750.0n 0.7000 373999.9n 0.7000 374000.0n 0.3000 374249.9n 0.3000 374250.0n 0.7000 374499.9n 0.7000 374500.0n 0.3000 374749.9n 0.3000 374750.0n 0.3000 374999.9n 0.3000 375000.0n 0.7000 375249.9n 0.7000 375250.0n 0.7000 375499.9n 0.7000 375500.0n 0.3000 375749.9n 0.3000 375750.0n 0.3000 375999.9n 0.3000 376000.0n 0.7000 376249.9n 0.7000 376250.0n 0.3000 376499.9n 0.3000 376500.0n 0.3000 376749.9n 0.3000 376750.0n 0.3000 376999.9n 0.3000 377000.0n 0.7000 377249.9n 0.7000 377250.0n 0.7000 377499.9n 0.7000 377500.0n 0.3000 377749.9n 0.3000 377750.0n 0.7000 377999.9n 0.7000 378000.0n 0.3000 378249.9n 0.3000 378250.0n 0.7000 378499.9n 0.7000 378500.0n 0.3000 378749.9n 0.3000 378750.0n 0.7000 378999.9n 0.7000 379000.0n 0.7000 379249.9n 0.7000 379250.0n 0.7000 379499.9n 0.7000 379500.0n 0.7000 379749.9n 0.7000 379750.0n 0.7000 379999.9n 0.7000 380000.0n 0.3000 380249.9n 0.3000 380250.0n 0.3000 380499.9n 0.3000 380500.0n 0.7000 380749.9n 0.7000 380750.0n 0.3000 380999.9n 0.3000 381000.0n 0.7000 381249.9n 0.7000 381250.0n 0.7000 381499.9n 0.7000 381500.0n 0.3000 381749.9n 0.3000 381750.0n 0.3000 381999.9n 0.3000 382000.0n 0.7000 382249.9n 0.7000 382250.0n 0.7000 382499.9n 0.7000 382500.0n 0.3000 382749.9n 0.3000 382750.0n 0.7000 382999.9n 0.7000 383000.0n 0.3000 383249.9n 0.3000 383250.0n 0.3000 383499.9n 0.3000 383500.0n 0.7000 383749.9n 0.7000 383750.0n 0.3000 383999.9n 0.3000 384000.0n 0.3000 384249.9n 0.3000 384250.0n 0.7000 384499.9n 0.7000 384500.0n 0.7000 384749.9n 0.7000 384750.0n 0.3000 384999.9n 0.3000 385000.0n 0.3000 385249.9n 0.3000 385250.0n 0.7000 385499.9n 0.7000 385500.0n 0.3000 385749.9n 0.3000 385750.0n 0.3000 385999.9n 0.3000 386000.0n 0.7000 386249.9n 0.7000 386250.0n 0.3000 386499.9n 0.3000 386500.0n 0.7000 386749.9n 0.7000 386750.0n 0.7000 386999.9n 0.7000 387000.0n 0.3000 387249.9n 0.3000 387250.0n 0.7000 387499.9n 0.7000 387500.0n 0.7000 387749.9n 0.7000 387750.0n 0.7000 387999.9n 0.7000 388000.0n 0.3000 388249.9n 0.3000 388250.0n 0.7000 388499.9n 0.7000 388500.0n 0.7000 388749.9n 0.7000 388750.0n 0.7000 388999.9n 0.7000 389000.0n 0.7000 389249.9n 0.7000 389250.0n 0.3000 389499.9n 0.3000 389500.0n 0.3000 389749.9n 0.3000 389750.0n 0.3000 389999.9n 0.3000 390000.0n 0.3000 390249.9n 0.3000 390250.0n 0.7000 390499.9n 0.7000 390500.0n 0.3000 390749.9n 0.3000 390750.0n 0.3000 390999.9n 0.3000 391000.0n 0.7000 391249.9n 0.7000 391250.0n 0.3000 391499.9n 0.3000 391500.0n 0.7000 391749.9n 0.7000 391750.0n 0.7000 391999.9n 0.7000 392000.0n 0.3000 392249.9n 0.3000 392250.0n 0.7000 392499.9n 0.7000 392500.0n 0.3000 392749.9n 0.3000 392750.0n 0.7000 392999.9n 0.7000 393000.0n 0.3000 393249.9n 0.3000 393250.0n 0.3000 393499.9n 0.3000 393500.0n 0.7000 393749.9n 0.7000 393750.0n 0.7000 393999.9n 0.7000 394000.0n 0.7000 394249.9n 0.7000 394250.0n 0.7000 394499.9n 0.7000 394500.0n 0.7000 394749.9n 0.7000 394750.0n 0.7000 394999.9n 0.7000 395000.0n 0.7000 395249.9n 0.7000 395250.0n 0.3000 395499.9n 0.3000 395500.0n 0.3000 395749.9n 0.3000 395750.0n 0.7000 395999.9n 0.7000 396000.0n 0.7000 396249.9n 0.7000 396250.0n 0.3000 396499.9n 0.3000 396500.0n 0.7000 396749.9n 0.7000 396750.0n 0.3000 396999.9n 0.3000 397000.0n 0.3000 397249.9n 0.3000 397250.0n 0.7000 397499.9n 0.7000 397500.0n 0.3000 397749.9n 0.3000 397750.0n 0.7000 397999.9n 0.7000 398000.0n 0.3000 398249.9n 0.3000 398250.0n 0.3000 398499.9n 0.3000 398500.0n 0.3000 398749.9n 0.3000 398750.0n 0.7000 398999.9n 0.7000 399000.0n 0.7000 399249.9n 0.7000 399250.0n 0.7000 399499.9n 0.7000 399500.0n 0.7000 399749.9n 0.7000 399750.0n 0.7000 399999.9n 0.7000 400000.0n 0.7000 400249.9n 0.7000 400250.0n 0.3000 400499.9n 0.3000 400500.0n 0.3000 400749.9n 0.3000 400750.0n 0.7000 400999.9n 0.7000 401000.0n 0.3000 401249.9n 0.3000 401250.0n 0.7000 401499.9n 0.7000 401500.0n 0.3000 401749.9n 0.3000 401750.0n 0.3000 401999.9n 0.3000 402000.0n 0.7000 402249.9n 0.7000 402250.0n 0.3000 402499.9n 0.3000 402500.0n 0.7000 402749.9n 0.7000 402750.0n 0.3000 402999.9n 0.3000 403000.0n 0.3000 403249.9n 0.3000 403250.0n 0.3000 403499.9n 0.3000 403500.0n 0.3000 403749.9n 0.3000 403750.0n 0.7000 403999.9n 0.7000 404000.0n 0.7000 404249.9n 0.7000 404250.0n 0.3000 404499.9n 0.3000 404500.0n 0.7000 404749.9n 0.7000 404750.0n 0.7000 404999.9n 0.7000 405000.0n 0.3000 405249.9n 0.3000 405250.0n 0.7000 405499.9n 0.7000 405500.0n 0.7000 405749.9n 0.7000 405750.0n 0.7000 405999.9n 0.7000 406000.0n 0.7000 406249.9n 0.7000 406250.0n 0.3000 406499.9n 0.3000 406500.0n 0.3000 406749.9n 0.3000 406750.0n 0.3000 406999.9n 0.3000 407000.0n 0.7000 407249.9n 0.7000 407250.0n 0.3000 407499.9n 0.3000 407500.0n 0.3000 407749.9n 0.3000 407750.0n 0.7000 407999.9n 0.7000 408000.0n 0.7000 408249.9n 0.7000 408250.0n 0.7000 408499.9n 0.7000 408500.0n 0.3000 408749.9n 0.3000 408750.0n 0.7000 408999.9n 0.7000 409000.0n 0.3000 409249.9n 0.3000 409250.0n 0.3000 409499.9n 0.3000 409500.0n 0.7000 409749.9n 0.7000 409750.0n 0.7000 409999.9n 0.7000 410000.0n 0.7000 410249.9n 0.7000 410250.0n 0.3000 410499.9n 0.3000 410500.0n 0.3000 410749.9n 0.3000 410750.0n 0.3000 410999.9n 0.3000 411000.0n 0.7000 411249.9n 0.7000 411250.0n 0.3000 411499.9n 0.3000 411500.0n 0.7000 411749.9n 0.7000 411750.0n 0.3000 411999.9n 0.3000 412000.0n 0.3000 412249.9n 0.3000 412250.0n 0.7000 412499.9n 0.7000 412500.0n 0.7000 412749.9n 0.7000 412750.0n 0.3000 412999.9n 0.3000 413000.0n 0.3000 413249.9n 0.3000 413250.0n 0.7000 413499.9n 0.7000 413500.0n 0.7000 413749.9n 0.7000 413750.0n 0.3000 413999.9n 0.3000 414000.0n 0.3000 414249.9n 0.3000 414250.0n 0.7000 414499.9n 0.7000 414500.0n 0.7000 414749.9n 0.7000 414750.0n 0.7000 414999.9n 0.7000 415000.0n 0.7000 415249.9n 0.7000 415250.0n 0.3000 415499.9n 0.3000 415500.0n 0.3000 415749.9n 0.3000 415750.0n 0.7000 415999.9n 0.7000 416000.0n 0.7000 416249.9n 0.7000 416250.0n 0.7000 416499.9n 0.7000 416500.0n 0.3000 416749.9n 0.3000 416750.0n 0.3000 416999.9n 0.3000 417000.0n 0.3000 417249.9n 0.3000 417250.0n 0.7000 417499.9n 0.7000 417500.0n 0.7000 417749.9n 0.7000 417750.0n 0.3000 417999.9n 0.3000 418000.0n 0.3000 418249.9n 0.3000 418250.0n 0.7000 418499.9n 0.7000 418500.0n 0.7000 418749.9n 0.7000 418750.0n 0.3000 418999.9n 0.3000 419000.0n 0.7000 419249.9n 0.7000 419250.0n 0.7000 419499.9n 0.7000 419500.0n 0.7000 419749.9n 0.7000 419750.0n 0.3000 419999.9n 0.3000 420000.0n 0.3000 420249.9n 0.3000 420250.0n 0.7000 420499.9n 0.7000 420500.0n 0.7000 420749.9n 0.7000 420750.0n 0.7000 420999.9n 0.7000 421000.0n 0.3000 421249.9n 0.3000 421250.0n 0.3000 421499.9n 0.3000 421500.0n 0.7000 421749.9n 0.7000 421750.0n 0.3000 421999.9n 0.3000 422000.0n 0.7000 422249.9n 0.7000 422250.0n 0.3000 422499.9n 0.3000 422500.0n 0.3000 422749.9n 0.3000 422750.0n 0.7000 422999.9n 0.7000 423000.0n 0.7000 423249.9n 0.7000 423250.0n 0.3000 423499.9n 0.3000 423500.0n 0.7000 423749.9n 0.7000 423750.0n 0.3000 423999.9n 0.3000 424000.0n 0.3000 424249.9n 0.3000 424250.0n 0.3000 424499.9n 0.3000 424500.0n 0.7000 424749.9n 0.7000 424750.0n 0.7000 424999.9n 0.7000 425000.0n 0.3000 425249.9n 0.3000 425250.0n 0.7000 425499.9n 0.7000 425500.0n 0.3000 425749.9n 0.3000 425750.0n 0.7000 425999.9n 0.7000 426000.0n 0.3000 426249.9n 0.3000 426250.0n 0.7000 426499.9n 0.7000 426500.0n 0.7000 426749.9n 0.7000 426750.0n 0.7000 426999.9n 0.7000 427000.0n 0.3000 427249.9n 0.3000 427250.0n 0.7000 427499.9n 0.7000 427500.0n 0.3000 427749.9n 0.3000 427750.0n 0.7000 427999.9n 0.7000 428000.0n 0.3000 428249.9n 0.3000 428250.0n 0.3000 428499.9n 0.3000 428500.0n 0.7000 428749.9n 0.7000 428750.0n 0.7000 428999.9n 0.7000 429000.0n 0.7000 429249.9n 0.7000 429250.0n 0.3000 429499.9n 0.3000 429500.0n 0.3000 429749.9n 0.3000 429750.0n 0.7000 429999.9n 0.7000 430000.0n 0.3000 430249.9n 0.3000 430250.0n 0.3000 430499.9n 0.3000 430500.0n 0.7000 430749.9n 0.7000 430750.0n 0.7000 430999.9n 0.7000 431000.0n 0.7000 431249.9n 0.7000 431250.0n 0.3000 431499.9n 0.3000 431500.0n 0.7000 431749.9n 0.7000 431750.0n 0.7000 431999.9n 0.7000 432000.0n 0.7000 432249.9n 0.7000 432250.0n 0.3000 432499.9n 0.3000 432500.0n 0.3000 432749.9n 0.3000 432750.0n 0.7000 432999.9n 0.7000 433000.0n 0.3000 433249.9n 0.3000 433250.0n 0.3000 433499.9n 0.3000 433500.0n 0.7000 433749.9n 0.7000 433750.0n 0.7000 433999.9n 0.7000 434000.0n 0.3000 434249.9n 0.3000 434250.0n 0.3000 434499.9n 0.3000 434500.0n 0.7000 434749.9n 0.7000 434750.0n 0.7000 434999.9n 0.7000 435000.0n 0.3000 435249.9n 0.3000 435250.0n 0.7000 435499.9n 0.7000 435500.0n 0.7000 435749.9n 0.7000 435750.0n 0.7000 435999.9n 0.7000 436000.0n 0.7000 436249.9n 0.7000 436250.0n 0.3000 436499.9n 0.3000 436500.0n 0.3000 436749.9n 0.3000 436750.0n 0.3000 436999.9n 0.3000 437000.0n 0.7000 437249.9n 0.7000 437250.0n 0.7000 437499.9n 0.7000 437500.0n 0.3000 437749.9n 0.3000 437750.0n 0.7000 437999.9n 0.7000 438000.0n 0.7000 438249.9n 0.7000 438250.0n 0.3000 438499.9n 0.3000 438500.0n 0.3000 438749.9n 0.3000 438750.0n 0.7000 438999.9n 0.7000 439000.0n 0.7000 439249.9n 0.7000 439250.0n 0.7000 439499.9n 0.7000 439500.0n 0.7000 439749.9n 0.7000 439750.0n 0.3000 439999.9n 0.3000 440000.0n 0.3000 440249.9n 0.3000 440250.0n 0.3000 440499.9n 0.3000 440500.0n 0.3000 440749.9n 0.3000 440750.0n 0.3000 440999.9n 0.3000 441000.0n 0.3000 441249.9n 0.3000 441250.0n 0.7000 441499.9n 0.7000 441500.0n 0.3000 441749.9n 0.3000 441750.0n 0.7000 441999.9n 0.7000 442000.0n 0.7000 442249.9n 0.7000 442250.0n 0.3000 442499.9n 0.3000 442500.0n 0.3000 442749.9n 0.3000 442750.0n 0.3000 442999.9n 0.3000 443000.0n 0.3000 443249.9n 0.3000 443250.0n 0.3000 443499.9n 0.3000 443500.0n 0.3000 443749.9n 0.3000 443750.0n 0.7000 443999.9n 0.7000 444000.0n 0.3000 444249.9n 0.3000 444250.0n 0.3000 444499.9n 0.3000 444500.0n 0.3000 444749.9n 0.3000 444750.0n 0.7000 444999.9n 0.7000 445000.0n 0.7000 445249.9n 0.7000 445250.0n 0.7000 445499.9n 0.7000 445500.0n 0.7000 445749.9n 0.7000 445750.0n 0.7000 445999.9n 0.7000 446000.0n 0.7000 446249.9n 0.7000 446250.0n 0.7000 446499.9n 0.7000 446500.0n 0.7000 446749.9n 0.7000 446750.0n 0.7000 446999.9n 0.7000 447000.0n 0.7000 447249.9n 0.7000 447250.0n 0.7000 447499.9n 0.7000 447500.0n 0.7000 447749.9n 0.7000 447750.0n 0.3000 447999.9n 0.3000 448000.0n 0.7000 448249.9n 0.7000 448250.0n 0.3000 448499.9n 0.3000 448500.0n 0.3000 448749.9n 0.3000 448750.0n 0.7000 448999.9n 0.7000 449000.0n 0.3000 449249.9n 0.3000 449250.0n 0.3000 449499.9n 0.3000 449500.0n 0.7000 449749.9n 0.7000 449750.0n 0.7000 449999.9n 0.7000 450000.0n 0.5000 450249.9n 0.5000 450250.0n 0.5000 450499.9n 0.5000 450500.0n 0.5000 450749.9n 0.5000 450750.0n 0.5000 450999.9n 0.5000 451000.0n 0.5000 451249.9n 0.5000 451250.0n 0.5000 451499.9n 0.5000 451500.0n 0.5000 451749.9n 0.5000 451750.0n 0.5000 451999.9n 0.5000 452000.0n 0.5000 452249.9n 0.5000 452250.0n 0.5000 452499.9n 0.5000 452500.0n 0.5000 452749.9n 0.5000 452750.0n 0.5000 452999.9n 0.5000 453000.0n 0.5000 453249.9n 0.5000 453250.0n 0.5000 453499.9n 0.5000 453500.0n 0.5000 453749.9n 0.5000 453750.0n 0.5000 453999.9n 0.5000 454000.0n 0.5000 454249.9n 0.5000 454250.0n 0.5000 454499.9n 0.5000 454500.0n 0.5000 454749.9n 0.5000 454750.0n 0.5000 454999.9n 0.5000 455000.0n 0.5000 455249.9n 0.5000 455250.0n 0.5000 455499.9n 0.5000 455500.0n 0.5000 455749.9n 0.5000 455750.0n 0.5000 455999.9n 0.5000 456000.0n 0.5000 456249.9n 0.5000 456250.0n 0.5000 456499.9n 0.5000 456500.0n 0.5000 456749.9n 0.5000 456750.0n 0.5000 456999.9n 0.5000 457000.0n 0.5000 457249.9n 0.5000 457250.0n 0.5000 457499.9n 0.5000 457500.0n 0.5000 457749.9n 0.5000 457750.0n 0.5000 457999.9n 0.5000 458000.0n 0.5000 458249.9n 0.5000 458250.0n 0.5000 458499.9n 0.5000 458500.0n 0.5000 458749.9n 0.5000 458750.0n 0.5000 458999.9n 0.5000 459000.0n 0.5000 459249.9n 0.5000 459250.0n 0.5000 459499.9n 0.5000 459500.0n 0.5000 459749.9n 0.5000 459750.0n 0.5000 459999.9n 0.5000 460000.0n 0.5000 460249.9n 0.5000 460250.0n 0.5000 460499.9n 0.5000 460500.0n 0.5000 460749.9n 0.5000 460750.0n 0.5000 460999.9n 0.5000 461000.0n 0.5000 461249.9n 0.5000 461250.0n 0.5000 461499.9n 0.5000 461500.0n 0.5000 461749.9n 0.5000 461750.0n 0.5000 461999.9n 0.5000 462000.0n 0.5000 462249.9n 0.5000 462250.0n 0.5000 462499.9n 0.5000 462500.0n 0.5000 462749.9n 0.5000 462750.0n 0.5000 462999.9n 0.5000 463000.0n 0.5000 463249.9n 0.5000 463250.0n 0.5000 463499.9n 0.5000 463500.0n 0.5000 463749.9n 0.5000 463750.0n 0.5000 463999.9n 0.5000 464000.0n 0.5000 464249.9n 0.5000 464250.0n 0.5000 464499.9n 0.5000 464500.0n 0.5000 464749.9n 0.5000 464750.0n 0.5000 464999.9n 0.5000 465000.0n 0.5000 465249.9n 0.5000 465250.0n 0.5000 465499.9n 0.5000 465500.0n 0.5000 465749.9n 0.5000 465750.0n 0.5000 465999.9n 0.5000 466000.0n 0.5000 466249.9n 0.5000 466250.0n 0.5000 466499.9n 0.5000 466500.0n 0.5000 466749.9n 0.5000 466750.0n 0.5000 466999.9n 0.5000 467000.0n 0.5000 467249.9n 0.5000 467250.0n 0.5000 467499.9n 0.5000 467500.0n 0.5000 467749.9n 0.5000 467750.0n 0.5000 467999.9n 0.5000 468000.0n 0.5000 468249.9n 0.5000 468250.0n 0.5000 468499.9n 0.5000 468500.0n 0.5000 468749.9n 0.5000 468750.0n 0.5000 468999.9n 0.5000 469000.0n 0.5000 469249.9n 0.5000 469250.0n 0.5000 469499.9n 0.5000 469500.0n 0.5000 469749.9n 0.5000 469750.0n 0.5000 469999.9n 0.5000 470000.0n 0.5000 470249.9n 0.5000 470250.0n 0.5000 470499.9n 0.5000 470500.0n 0.5000 470749.9n 0.5000 470750.0n 0.5000 470999.9n 0.5000 471000.0n 0.5000 471249.9n 0.5000 471250.0n 0.5000 471499.9n 0.5000 471500.0n 0.5000 471749.9n 0.5000 471750.0n 0.5000 471999.9n 0.5000 472000.0n 0.5000 472249.9n 0.5000 472250.0n 0.5000 472499.9n 0.5000 472500.0n 0.5000 472749.9n 0.5000 472750.0n 0.5000 472999.9n 0.5000 473000.0n 0.5000 473249.9n 0.5000 473250.0n 0.5000 473499.9n 0.5000 473500.0n 0.5000 473749.9n 0.5000 473750.0n 0.5000 473999.9n 0.5000 474000.0n 0.5000 474249.9n 0.5000 474250.0n 0.5000 474499.9n 0.5000 474500.0n 0.5000 474749.9n 0.5000 474750.0n 0.5000 474999.9n 0.5000 475000.0n 0.5000 475249.9n 0.5000 475250.0n 0.5000 475499.9n 0.5000 475500.0n 0.5000 475749.9n 0.5000 475750.0n 0.5000 475999.9n 0.5000 476000.0n 0.5000 476249.9n 0.5000 476250.0n 0.5000 476499.9n 0.5000 476500.0n 0.5000 476749.9n 0.5000 476750.0n 0.5000 476999.9n 0.5000 477000.0n 0.5000 477249.9n 0.5000 477250.0n 0.5000 477499.9n 0.5000 477500.0n 0.5000 477749.9n 0.5000 477750.0n 0.5000 477999.9n 0.5000 478000.0n 0.5000 478249.9n 0.5000 478250.0n 0.5000 478499.9n 0.5000 478500.0n 0.5000 478749.9n 0.5000 478750.0n 0.5000 478999.9n 0.5000 479000.0n 0.5000 479249.9n 0.5000 479250.0n 0.5000 479499.9n 0.5000 479500.0n 0.5000 479749.9n 0.5000 479750.0n 0.5000)
Vxon xon 0 PWL(0.0n 0.7000 249.9n 0.7000 250.0n 0.3000 499.9n 0.3000 500.0n 0.7000 749.9n 0.7000 750.0n 0.7000 999.9n 0.7000 1000.0n 0.3000 1249.9n 0.3000 1250.0n 0.7000 1499.9n 0.7000 1500.0n 0.7000 1749.9n 0.7000 1750.0n 0.3000 1999.9n 0.3000 2000.0n 0.3000 2249.9n 0.3000 2250.0n 0.3000 2499.9n 0.3000 2500.0n 0.3000 2749.9n 0.3000 2750.0n 0.3000 2999.9n 0.3000 3000.0n 0.7000 3249.9n 0.7000 3250.0n 0.3000 3499.9n 0.3000 3500.0n 0.7000 3749.9n 0.7000 3750.0n 0.7000 3999.9n 0.7000 4000.0n 0.3000 4249.9n 0.3000 4250.0n 0.3000 4499.9n 0.3000 4500.0n 0.7000 4749.9n 0.7000 4750.0n 0.3000 4999.9n 0.3000 5000.0n 0.3000 5249.9n 0.3000 5250.0n 0.3000 5499.9n 0.3000 5500.0n 0.3000 5749.9n 0.3000 5750.0n 0.3000 5999.9n 0.3000 6000.0n 0.7000 6249.9n 0.7000 6250.0n 0.3000 6499.9n 0.3000 6500.0n 0.3000 6749.9n 0.3000 6750.0n 0.3000 6999.9n 0.3000 7000.0n 0.3000 7249.9n 0.3000 7250.0n 0.7000 7499.9n 0.7000 7500.0n 0.7000 7749.9n 0.7000 7750.0n 0.3000 7999.9n 0.3000 8000.0n 0.3000 8249.9n 0.3000 8250.0n 0.3000 8499.9n 0.3000 8500.0n 0.7000 8749.9n 0.7000 8750.0n 0.3000 8999.9n 0.3000 9000.0n 0.7000 9249.9n 0.7000 9250.0n 0.7000 9499.9n 0.7000 9500.0n 0.7000 9749.9n 0.7000 9750.0n 0.3000 9999.9n 0.3000 10000.0n 0.7000 10249.9n 0.7000 10250.0n 0.3000 10499.9n 0.3000 10500.0n 0.7000 10749.9n 0.7000 10750.0n 0.3000 10999.9n 0.3000 11000.0n 0.7000 11249.9n 0.7000 11250.0n 0.3000 11499.9n 0.3000 11500.0n 0.7000 11749.9n 0.7000 11750.0n 0.7000 11999.9n 0.7000 12000.0n 0.7000 12249.9n 0.7000 12250.0n 0.7000 12499.9n 0.7000 12500.0n 0.7000 12749.9n 0.7000 12750.0n 0.7000 12999.9n 0.7000 13000.0n 0.3000 13249.9n 0.3000 13250.0n 0.7000 13499.9n 0.7000 13500.0n 0.3000 13749.9n 0.3000 13750.0n 0.3000 13999.9n 0.3000 14000.0n 0.3000 14249.9n 0.3000 14250.0n 0.7000 14499.9n 0.7000 14500.0n 0.7000 14749.9n 0.7000 14750.0n 0.3000 14999.9n 0.3000 15000.0n 0.3000 15249.9n 0.3000 15250.0n 0.3000 15499.9n 0.3000 15500.0n 0.3000 15749.9n 0.3000 15750.0n 0.7000 15999.9n 0.7000 16000.0n 0.3000 16249.9n 0.3000 16250.0n 0.3000 16499.9n 0.3000 16500.0n 0.7000 16749.9n 0.7000 16750.0n 0.3000 16999.9n 0.3000 17000.0n 0.7000 17249.9n 0.7000 17250.0n 0.7000 17499.9n 0.7000 17500.0n 0.7000 17749.9n 0.7000 17750.0n 0.3000 17999.9n 0.3000 18000.0n 0.3000 18249.9n 0.3000 18250.0n 0.7000 18499.9n 0.7000 18500.0n 0.7000 18749.9n 0.7000 18750.0n 0.3000 18999.9n 0.3000 19000.0n 0.7000 19249.9n 0.7000 19250.0n 0.3000 19499.9n 0.3000 19500.0n 0.7000 19749.9n 0.7000 19750.0n 0.3000 19999.9n 0.3000 20000.0n 0.7000 20249.9n 0.7000 20250.0n 0.3000 20499.9n 0.3000 20500.0n 0.3000 20749.9n 0.3000 20750.0n 0.7000 20999.9n 0.7000 21000.0n 0.7000 21249.9n 0.7000 21250.0n 0.7000 21499.9n 0.7000 21500.0n 0.7000 21749.9n 0.7000 21750.0n 0.3000 21999.9n 0.3000 22000.0n 0.7000 22249.9n 0.7000 22250.0n 0.7000 22499.9n 0.7000 22500.0n 0.3000 22749.9n 0.3000 22750.0n 0.3000 22999.9n 0.3000 23000.0n 0.7000 23249.9n 0.7000 23250.0n 0.3000 23499.9n 0.3000 23500.0n 0.3000 23749.9n 0.3000 23750.0n 0.7000 23999.9n 0.7000 24000.0n 0.7000 24249.9n 0.7000 24250.0n 0.3000 24499.9n 0.3000 24500.0n 0.3000 24749.9n 0.3000 24750.0n 0.3000 24999.9n 0.3000 25000.0n 0.3000 25249.9n 0.3000 25250.0n 0.7000 25499.9n 0.7000 25500.0n 0.7000 25749.9n 0.7000 25750.0n 0.3000 25999.9n 0.3000 26000.0n 0.3000 26249.9n 0.3000 26250.0n 0.3000 26499.9n 0.3000 26500.0n 0.3000 26749.9n 0.3000 26750.0n 0.7000 26999.9n 0.7000 27000.0n 0.7000 27249.9n 0.7000 27250.0n 0.7000 27499.9n 0.7000 27500.0n 0.7000 27749.9n 0.7000 27750.0n 0.7000 27999.9n 0.7000 28000.0n 0.7000 28249.9n 0.7000 28250.0n 0.3000 28499.9n 0.3000 28500.0n 0.3000 28749.9n 0.3000 28750.0n 0.3000 28999.9n 0.3000 29000.0n 0.3000 29249.9n 0.3000 29250.0n 0.3000 29499.9n 0.3000 29500.0n 0.3000 29749.9n 0.3000 29750.0n 0.7000 29999.9n 0.7000 30000.0n 0.7000 30249.9n 0.7000 30250.0n 0.3000 30499.9n 0.3000 30500.0n 0.3000 30749.9n 0.3000 30750.0n 0.7000 30999.9n 0.7000 31000.0n 0.3000 31249.9n 0.3000 31250.0n 0.7000 31499.9n 0.7000 31500.0n 0.3000 31749.9n 0.3000 31750.0n 0.3000 31999.9n 0.3000 32000.0n 0.3000 32249.9n 0.3000 32250.0n 0.3000 32499.9n 0.3000 32500.0n 0.3000 32749.9n 0.3000 32750.0n 0.7000 32999.9n 0.7000 33000.0n 0.7000 33249.9n 0.7000 33250.0n 0.7000 33499.9n 0.7000 33500.0n 0.3000 33749.9n 0.3000 33750.0n 0.3000 33999.9n 0.3000 34000.0n 0.3000 34249.9n 0.3000 34250.0n 0.3000 34499.9n 0.3000 34500.0n 0.7000 34749.9n 0.7000 34750.0n 0.3000 34999.9n 0.3000 35000.0n 0.7000 35249.9n 0.7000 35250.0n 0.3000 35499.9n 0.3000 35500.0n 0.7000 35749.9n 0.7000 35750.0n 0.7000 35999.9n 0.7000 36000.0n 0.7000 36249.9n 0.7000 36250.0n 0.3000 36499.9n 0.3000 36500.0n 0.3000 36749.9n 0.3000 36750.0n 0.3000 36999.9n 0.3000 37000.0n 0.7000 37249.9n 0.7000 37250.0n 0.7000 37499.9n 0.7000 37500.0n 0.3000 37749.9n 0.3000 37750.0n 0.3000 37999.9n 0.3000 38000.0n 0.7000 38249.9n 0.7000 38250.0n 0.3000 38499.9n 0.3000 38500.0n 0.7000 38749.9n 0.7000 38750.0n 0.3000 38999.9n 0.3000 39000.0n 0.3000 39249.9n 0.3000 39250.0n 0.3000 39499.9n 0.3000 39500.0n 0.7000 39749.9n 0.7000 39750.0n 0.3000 39999.9n 0.3000 40000.0n 0.3000 40249.9n 0.3000 40250.0n 0.3000 40499.9n 0.3000 40500.0n 0.7000 40749.9n 0.7000 40750.0n 0.3000 40999.9n 0.3000 41000.0n 0.7000 41249.9n 0.7000 41250.0n 0.3000 41499.9n 0.3000 41500.0n 0.3000 41749.9n 0.3000 41750.0n 0.7000 41999.9n 0.7000 42000.0n 0.7000 42249.9n 0.7000 42250.0n 0.3000 42499.9n 0.3000 42500.0n 0.7000 42749.9n 0.7000 42750.0n 0.7000 42999.9n 0.7000 43000.0n 0.7000 43249.9n 0.7000 43250.0n 0.7000 43499.9n 0.7000 43500.0n 0.3000 43749.9n 0.3000 43750.0n 0.7000 43999.9n 0.7000 44000.0n 0.3000 44249.9n 0.3000 44250.0n 0.7000 44499.9n 0.7000 44500.0n 0.7000 44749.9n 0.7000 44750.0n 0.7000 44999.9n 0.7000 45000.0n 0.3000 45249.9n 0.3000 45250.0n 0.3000 45499.9n 0.3000 45500.0n 0.7000 45749.9n 0.7000 45750.0n 0.3000 45999.9n 0.3000 46000.0n 0.3000 46249.9n 0.3000 46250.0n 0.7000 46499.9n 0.7000 46500.0n 0.7000 46749.9n 0.7000 46750.0n 0.7000 46999.9n 0.7000 47000.0n 0.7000 47249.9n 0.7000 47250.0n 0.7000 47499.9n 0.7000 47500.0n 0.3000 47749.9n 0.3000 47750.0n 0.3000 47999.9n 0.3000 48000.0n 0.7000 48249.9n 0.7000 48250.0n 0.3000 48499.9n 0.3000 48500.0n 0.3000 48749.9n 0.3000 48750.0n 0.7000 48999.9n 0.7000 49000.0n 0.7000 49249.9n 0.7000 49250.0n 0.7000 49499.9n 0.7000 49500.0n 0.3000 49749.9n 0.3000 49750.0n 0.3000 49999.9n 0.3000 50000.0n 0.7000 50249.9n 0.7000 50250.0n 0.3000 50499.9n 0.3000 50500.0n 0.3000 50749.9n 0.3000 50750.0n 0.7000 50999.9n 0.7000 51000.0n 0.3000 51249.9n 0.3000 51250.0n 0.3000 51499.9n 0.3000 51500.0n 0.3000 51749.9n 0.3000 51750.0n 0.3000 51999.9n 0.3000 52000.0n 0.7000 52249.9n 0.7000 52250.0n 0.7000 52499.9n 0.7000 52500.0n 0.7000 52749.9n 0.7000 52750.0n 0.3000 52999.9n 0.3000 53000.0n 0.7000 53249.9n 0.7000 53250.0n 0.7000 53499.9n 0.7000 53500.0n 0.3000 53749.9n 0.3000 53750.0n 0.3000 53999.9n 0.3000 54000.0n 0.7000 54249.9n 0.7000 54250.0n 0.3000 54499.9n 0.3000 54500.0n 0.7000 54749.9n 0.7000 54750.0n 0.7000 54999.9n 0.7000 55000.0n 0.3000 55249.9n 0.3000 55250.0n 0.7000 55499.9n 0.7000 55500.0n 0.3000 55749.9n 0.3000 55750.0n 0.3000 55999.9n 0.3000 56000.0n 0.7000 56249.9n 0.7000 56250.0n 0.3000 56499.9n 0.3000 56500.0n 0.3000 56749.9n 0.3000 56750.0n 0.7000 56999.9n 0.7000 57000.0n 0.3000 57249.9n 0.3000 57250.0n 0.3000 57499.9n 0.3000 57500.0n 0.7000 57749.9n 0.7000 57750.0n 0.3000 57999.9n 0.3000 58000.0n 0.7000 58249.9n 0.7000 58250.0n 0.7000 58499.9n 0.7000 58500.0n 0.3000 58749.9n 0.3000 58750.0n 0.7000 58999.9n 0.7000 59000.0n 0.3000 59249.9n 0.3000 59250.0n 0.7000 59499.9n 0.7000 59500.0n 0.3000 59749.9n 0.3000 59750.0n 0.3000 59999.9n 0.3000 60000.0n 0.3000 60249.9n 0.3000 60250.0n 0.7000 60499.9n 0.7000 60500.0n 0.7000 60749.9n 0.7000 60750.0n 0.3000 60999.9n 0.3000 61000.0n 0.3000 61249.9n 0.3000 61250.0n 0.7000 61499.9n 0.7000 61500.0n 0.3000 61749.9n 0.3000 61750.0n 0.7000 61999.9n 0.7000 62000.0n 0.3000 62249.9n 0.3000 62250.0n 0.7000 62499.9n 0.7000 62500.0n 0.7000 62749.9n 0.7000 62750.0n 0.3000 62999.9n 0.3000 63000.0n 0.3000 63249.9n 0.3000 63250.0n 0.7000 63499.9n 0.7000 63500.0n 0.7000 63749.9n 0.7000 63750.0n 0.7000 63999.9n 0.7000 64000.0n 0.7000 64249.9n 0.7000 64250.0n 0.7000 64499.9n 0.7000 64500.0n 0.3000 64749.9n 0.3000 64750.0n 0.7000 64999.9n 0.7000 65000.0n 0.3000 65249.9n 0.3000 65250.0n 0.7000 65499.9n 0.7000 65500.0n 0.7000 65749.9n 0.7000 65750.0n 0.3000 65999.9n 0.3000 66000.0n 0.3000 66249.9n 0.3000 66250.0n 0.3000 66499.9n 0.3000 66500.0n 0.7000 66749.9n 0.7000 66750.0n 0.7000 66999.9n 0.7000 67000.0n 0.3000 67249.9n 0.3000 67250.0n 0.3000 67499.9n 0.3000 67500.0n 0.3000 67749.9n 0.3000 67750.0n 0.3000 67999.9n 0.3000 68000.0n 0.7000 68249.9n 0.7000 68250.0n 0.7000 68499.9n 0.7000 68500.0n 0.3000 68749.9n 0.3000 68750.0n 0.3000 68999.9n 0.3000 69000.0n 0.3000 69249.9n 0.3000 69250.0n 0.3000 69499.9n 0.3000 69500.0n 0.7000 69749.9n 0.7000 69750.0n 0.3000 69999.9n 0.3000 70000.0n 0.7000 70249.9n 0.7000 70250.0n 0.7000 70499.9n 0.7000 70500.0n 0.3000 70749.9n 0.3000 70750.0n 0.7000 70999.9n 0.7000 71000.0n 0.7000 71249.9n 0.7000 71250.0n 0.3000 71499.9n 0.3000 71500.0n 0.7000 71749.9n 0.7000 71750.0n 0.7000 71999.9n 0.7000 72000.0n 0.3000 72249.9n 0.3000 72250.0n 0.3000 72499.9n 0.3000 72500.0n 0.3000 72749.9n 0.3000 72750.0n 0.3000 72999.9n 0.3000 73000.0n 0.3000 73249.9n 0.3000 73250.0n 0.7000 73499.9n 0.7000 73500.0n 0.3000 73749.9n 0.3000 73750.0n 0.7000 73999.9n 0.7000 74000.0n 0.3000 74249.9n 0.3000 74250.0n 0.3000 74499.9n 0.3000 74500.0n 0.3000 74749.9n 0.3000 74750.0n 0.7000 74999.9n 0.7000 75000.0n 0.7000 75249.9n 0.7000 75250.0n 0.7000 75499.9n 0.7000 75500.0n 0.3000 75749.9n 0.3000 75750.0n 0.3000 75999.9n 0.3000 76000.0n 0.3000 76249.9n 0.3000 76250.0n 0.7000 76499.9n 0.7000 76500.0n 0.3000 76749.9n 0.3000 76750.0n 0.7000 76999.9n 0.7000 77000.0n 0.7000 77249.9n 0.7000 77250.0n 0.7000 77499.9n 0.7000 77500.0n 0.7000 77749.9n 0.7000 77750.0n 0.3000 77999.9n 0.3000 78000.0n 0.7000 78249.9n 0.7000 78250.0n 0.3000 78499.9n 0.3000 78500.0n 0.3000 78749.9n 0.3000 78750.0n 0.3000 78999.9n 0.3000 79000.0n 0.3000 79249.9n 0.3000 79250.0n 0.7000 79499.9n 0.7000 79500.0n 0.7000 79749.9n 0.7000 79750.0n 0.3000 79999.9n 0.3000 80000.0n 0.7000 80249.9n 0.7000 80250.0n 0.3000 80499.9n 0.3000 80500.0n 0.3000 80749.9n 0.3000 80750.0n 0.7000 80999.9n 0.7000 81000.0n 0.3000 81249.9n 0.3000 81250.0n 0.7000 81499.9n 0.7000 81500.0n 0.3000 81749.9n 0.3000 81750.0n 0.3000 81999.9n 0.3000 82000.0n 0.7000 82249.9n 0.7000 82250.0n 0.3000 82499.9n 0.3000 82500.0n 0.7000 82749.9n 0.7000 82750.0n 0.3000 82999.9n 0.3000 83000.0n 0.7000 83249.9n 0.7000 83250.0n 0.7000 83499.9n 0.7000 83500.0n 0.3000 83749.9n 0.3000 83750.0n 0.7000 83999.9n 0.7000 84000.0n 0.3000 84249.9n 0.3000 84250.0n 0.7000 84499.9n 0.7000 84500.0n 0.3000 84749.9n 0.3000 84750.0n 0.3000 84999.9n 0.3000 85000.0n 0.3000 85249.9n 0.3000 85250.0n 0.3000 85499.9n 0.3000 85500.0n 0.3000 85749.9n 0.3000 85750.0n 0.3000 85999.9n 0.3000 86000.0n 0.7000 86249.9n 0.7000 86250.0n 0.7000 86499.9n 0.7000 86500.0n 0.7000 86749.9n 0.7000 86750.0n 0.3000 86999.9n 0.3000 87000.0n 0.7000 87249.9n 0.7000 87250.0n 0.3000 87499.9n 0.3000 87500.0n 0.7000 87749.9n 0.7000 87750.0n 0.3000 87999.9n 0.3000 88000.0n 0.3000 88249.9n 0.3000 88250.0n 0.3000 88499.9n 0.3000 88500.0n 0.3000 88749.9n 0.3000 88750.0n 0.7000 88999.9n 0.7000 89000.0n 0.7000 89249.9n 0.7000 89250.0n 0.7000 89499.9n 0.7000 89500.0n 0.7000 89749.9n 0.7000 89750.0n 0.3000 89999.9n 0.3000 90000.0n 0.3000 90249.9n 0.3000 90250.0n 0.7000 90499.9n 0.7000 90500.0n 0.3000 90749.9n 0.3000 90750.0n 0.3000 90999.9n 0.3000 91000.0n 0.3000 91249.9n 0.3000 91250.0n 0.3000 91499.9n 0.3000 91500.0n 0.3000 91749.9n 0.3000 91750.0n 0.3000 91999.9n 0.3000 92000.0n 0.3000 92249.9n 0.3000 92250.0n 0.7000 92499.9n 0.7000 92500.0n 0.3000 92749.9n 0.3000 92750.0n 0.7000 92999.9n 0.7000 93000.0n 0.7000 93249.9n 0.7000 93250.0n 0.3000 93499.9n 0.3000 93500.0n 0.7000 93749.9n 0.7000 93750.0n 0.3000 93999.9n 0.3000 94000.0n 0.3000 94249.9n 0.3000 94250.0n 0.3000 94499.9n 0.3000 94500.0n 0.3000 94749.9n 0.3000 94750.0n 0.3000 94999.9n 0.3000 95000.0n 0.7000 95249.9n 0.7000 95250.0n 0.3000 95499.9n 0.3000 95500.0n 0.3000 95749.9n 0.3000 95750.0n 0.7000 95999.9n 0.7000 96000.0n 0.3000 96249.9n 0.3000 96250.0n 0.3000 96499.9n 0.3000 96500.0n 0.7000 96749.9n 0.7000 96750.0n 0.3000 96999.9n 0.3000 97000.0n 0.7000 97249.9n 0.7000 97250.0n 0.3000 97499.9n 0.3000 97500.0n 0.7000 97749.9n 0.7000 97750.0n 0.7000 97999.9n 0.7000 98000.0n 0.7000 98249.9n 0.7000 98250.0n 0.3000 98499.9n 0.3000 98500.0n 0.7000 98749.9n 0.7000 98750.0n 0.3000 98999.9n 0.3000 99000.0n 0.7000 99249.9n 0.7000 99250.0n 0.3000 99499.9n 0.3000 99500.0n 0.7000 99749.9n 0.7000 99750.0n 0.7000 99999.9n 0.7000 100000.0n 0.7000 100249.9n 0.7000 100250.0n 0.3000 100499.9n 0.3000 100500.0n 0.7000 100749.9n 0.7000 100750.0n 0.3000 100999.9n 0.3000 101000.0n 0.7000 101249.9n 0.7000 101250.0n 0.7000 101499.9n 0.7000 101500.0n 0.3000 101749.9n 0.3000 101750.0n 0.7000 101999.9n 0.7000 102000.0n 0.7000 102249.9n 0.7000 102250.0n 0.3000 102499.9n 0.3000 102500.0n 0.3000 102749.9n 0.3000 102750.0n 0.7000 102999.9n 0.7000 103000.0n 0.7000 103249.9n 0.7000 103250.0n 0.3000 103499.9n 0.3000 103500.0n 0.7000 103749.9n 0.7000 103750.0n 0.7000 103999.9n 0.7000 104000.0n 0.7000 104249.9n 0.7000 104250.0n 0.3000 104499.9n 0.3000 104500.0n 0.7000 104749.9n 0.7000 104750.0n 0.3000 104999.9n 0.3000 105000.0n 0.7000 105249.9n 0.7000 105250.0n 0.3000 105499.9n 0.3000 105500.0n 0.7000 105749.9n 0.7000 105750.0n 0.7000 105999.9n 0.7000 106000.0n 0.3000 106249.9n 0.3000 106250.0n 0.3000 106499.9n 0.3000 106500.0n 0.7000 106749.9n 0.7000 106750.0n 0.3000 106999.9n 0.3000 107000.0n 0.7000 107249.9n 0.7000 107250.0n 0.7000 107499.9n 0.7000 107500.0n 0.7000 107749.9n 0.7000 107750.0n 0.3000 107999.9n 0.3000 108000.0n 0.7000 108249.9n 0.7000 108250.0n 0.3000 108499.9n 0.3000 108500.0n 0.3000 108749.9n 0.3000 108750.0n 0.3000 108999.9n 0.3000 109000.0n 0.3000 109249.9n 0.3000 109250.0n 0.7000 109499.9n 0.7000 109500.0n 0.7000 109749.9n 0.7000 109750.0n 0.7000 109999.9n 0.7000 110000.0n 0.7000 110249.9n 0.7000 110250.0n 0.7000 110499.9n 0.7000 110500.0n 0.7000 110749.9n 0.7000 110750.0n 0.7000 110999.9n 0.7000 111000.0n 0.7000 111249.9n 0.7000 111250.0n 0.3000 111499.9n 0.3000 111500.0n 0.3000 111749.9n 0.3000 111750.0n 0.7000 111999.9n 0.7000 112000.0n 0.3000 112249.9n 0.3000 112250.0n 0.7000 112499.9n 0.7000 112500.0n 0.3000 112749.9n 0.3000 112750.0n 0.7000 112999.9n 0.7000 113000.0n 0.3000 113249.9n 0.3000 113250.0n 0.3000 113499.9n 0.3000 113500.0n 0.3000 113749.9n 0.3000 113750.0n 0.3000 113999.9n 0.3000 114000.0n 0.7000 114249.9n 0.7000 114250.0n 0.7000 114499.9n 0.7000 114500.0n 0.3000 114749.9n 0.3000 114750.0n 0.7000 114999.9n 0.7000 115000.0n 0.3000 115249.9n 0.3000 115250.0n 0.7000 115499.9n 0.7000 115500.0n 0.3000 115749.9n 0.3000 115750.0n 0.3000 115999.9n 0.3000 116000.0n 0.3000 116249.9n 0.3000 116250.0n 0.3000 116499.9n 0.3000 116500.0n 0.3000 116749.9n 0.3000 116750.0n 0.3000 116999.9n 0.3000 117000.0n 0.3000 117249.9n 0.3000 117250.0n 0.7000 117499.9n 0.7000 117500.0n 0.3000 117749.9n 0.3000 117750.0n 0.7000 117999.9n 0.7000 118000.0n 0.3000 118249.9n 0.3000 118250.0n 0.7000 118499.9n 0.7000 118500.0n 0.3000 118749.9n 0.3000 118750.0n 0.7000 118999.9n 0.7000 119000.0n 0.3000 119249.9n 0.3000 119250.0n 0.7000 119499.9n 0.7000 119500.0n 0.3000 119749.9n 0.3000 119750.0n 0.3000 119999.9n 0.3000 120000.0n 0.3000 120249.9n 0.3000 120250.0n 0.3000 120499.9n 0.3000 120500.0n 0.3000 120749.9n 0.3000 120750.0n 0.7000 120999.9n 0.7000 121000.0n 0.3000 121249.9n 0.3000 121250.0n 0.3000 121499.9n 0.3000 121500.0n 0.3000 121749.9n 0.3000 121750.0n 0.3000 121999.9n 0.3000 122000.0n 0.7000 122249.9n 0.7000 122250.0n 0.7000 122499.9n 0.7000 122500.0n 0.7000 122749.9n 0.7000 122750.0n 0.7000 122999.9n 0.7000 123000.0n 0.3000 123249.9n 0.3000 123250.0n 0.7000 123499.9n 0.7000 123500.0n 0.7000 123749.9n 0.7000 123750.0n 0.3000 123999.9n 0.3000 124000.0n 0.7000 124249.9n 0.7000 124250.0n 0.3000 124499.9n 0.3000 124500.0n 0.7000 124749.9n 0.7000 124750.0n 0.7000 124999.9n 0.7000 125000.0n 0.7000 125249.9n 0.7000 125250.0n 0.3000 125499.9n 0.3000 125500.0n 0.7000 125749.9n 0.7000 125750.0n 0.3000 125999.9n 0.3000 126000.0n 0.7000 126249.9n 0.7000 126250.0n 0.3000 126499.9n 0.3000 126500.0n 0.7000 126749.9n 0.7000 126750.0n 0.3000 126999.9n 0.3000 127000.0n 0.7000 127249.9n 0.7000 127250.0n 0.7000 127499.9n 0.7000 127500.0n 0.7000 127749.9n 0.7000 127750.0n 0.3000 127999.9n 0.3000 128000.0n 0.3000 128249.9n 0.3000 128250.0n 0.7000 128499.9n 0.7000 128500.0n 0.7000 128749.9n 0.7000 128750.0n 0.3000 128999.9n 0.3000 129000.0n 0.3000 129249.9n 0.3000 129250.0n 0.3000 129499.9n 0.3000 129500.0n 0.3000 129749.9n 0.3000 129750.0n 0.3000 129999.9n 0.3000 130000.0n 0.3000 130249.9n 0.3000 130250.0n 0.3000 130499.9n 0.3000 130500.0n 0.7000 130749.9n 0.7000 130750.0n 0.7000 130999.9n 0.7000 131000.0n 0.3000 131249.9n 0.3000 131250.0n 0.7000 131499.9n 0.7000 131500.0n 0.7000 131749.9n 0.7000 131750.0n 0.3000 131999.9n 0.3000 132000.0n 0.7000 132249.9n 0.7000 132250.0n 0.7000 132499.9n 0.7000 132500.0n 0.3000 132749.9n 0.3000 132750.0n 0.7000 132999.9n 0.7000 133000.0n 0.7000 133249.9n 0.7000 133250.0n 0.3000 133499.9n 0.3000 133500.0n 0.7000 133749.9n 0.7000 133750.0n 0.3000 133999.9n 0.3000 134000.0n 0.3000 134249.9n 0.3000 134250.0n 0.3000 134499.9n 0.3000 134500.0n 0.3000 134749.9n 0.3000 134750.0n 0.3000 134999.9n 0.3000 135000.0n 0.3000 135249.9n 0.3000 135250.0n 0.3000 135499.9n 0.3000 135500.0n 0.3000 135749.9n 0.3000 135750.0n 0.7000 135999.9n 0.7000 136000.0n 0.7000 136249.9n 0.7000 136250.0n 0.7000 136499.9n 0.7000 136500.0n 0.7000 136749.9n 0.7000 136750.0n 0.7000 136999.9n 0.7000 137000.0n 0.7000 137249.9n 0.7000 137250.0n 0.3000 137499.9n 0.3000 137500.0n 0.3000 137749.9n 0.3000 137750.0n 0.7000 137999.9n 0.7000 138000.0n 0.3000 138249.9n 0.3000 138250.0n 0.3000 138499.9n 0.3000 138500.0n 0.7000 138749.9n 0.7000 138750.0n 0.3000 138999.9n 0.3000 139000.0n 0.7000 139249.9n 0.7000 139250.0n 0.7000 139499.9n 0.7000 139500.0n 0.3000 139749.9n 0.3000 139750.0n 0.7000 139999.9n 0.7000 140000.0n 0.3000 140249.9n 0.3000 140250.0n 0.3000 140499.9n 0.3000 140500.0n 0.7000 140749.9n 0.7000 140750.0n 0.3000 140999.9n 0.3000 141000.0n 0.3000 141249.9n 0.3000 141250.0n 0.3000 141499.9n 0.3000 141500.0n 0.7000 141749.9n 0.7000 141750.0n 0.7000 141999.9n 0.7000 142000.0n 0.7000 142249.9n 0.7000 142250.0n 0.7000 142499.9n 0.7000 142500.0n 0.7000 142749.9n 0.7000 142750.0n 0.7000 142999.9n 0.7000 143000.0n 0.3000 143249.9n 0.3000 143250.0n 0.3000 143499.9n 0.3000 143500.0n 0.3000 143749.9n 0.3000 143750.0n 0.3000 143999.9n 0.3000 144000.0n 0.7000 144249.9n 0.7000 144250.0n 0.3000 144499.9n 0.3000 144500.0n 0.7000 144749.9n 0.7000 144750.0n 0.7000 144999.9n 0.7000 145000.0n 0.3000 145249.9n 0.3000 145250.0n 0.3000 145499.9n 0.3000 145500.0n 0.7000 145749.9n 0.7000 145750.0n 0.3000 145999.9n 0.3000 146000.0n 0.3000 146249.9n 0.3000 146250.0n 0.3000 146499.9n 0.3000 146500.0n 0.3000 146749.9n 0.3000 146750.0n 0.3000 146999.9n 0.3000 147000.0n 0.7000 147249.9n 0.7000 147250.0n 0.3000 147499.9n 0.3000 147500.0n 0.3000 147749.9n 0.3000 147750.0n 0.7000 147999.9n 0.7000 148000.0n 0.3000 148249.9n 0.3000 148250.0n 0.3000 148499.9n 0.3000 148500.0n 0.3000 148749.9n 0.3000 148750.0n 0.7000 148999.9n 0.7000 149000.0n 0.7000 149249.9n 0.7000 149250.0n 0.7000 149499.9n 0.7000 149500.0n 0.3000 149749.9n 0.3000 149750.0n 0.7000 149999.9n 0.7000 150000.0n 0.7000 150249.9n 0.7000 150250.0n 0.7000 150499.9n 0.7000 150500.0n 0.3000 150749.9n 0.3000 150750.0n 0.3000 150999.9n 0.3000 151000.0n 0.3000 151249.9n 0.3000 151250.0n 0.7000 151499.9n 0.7000 151500.0n 0.3000 151749.9n 0.3000 151750.0n 0.7000 151999.9n 0.7000 152000.0n 0.7000 152249.9n 0.7000 152250.0n 0.3000 152499.9n 0.3000 152500.0n 0.3000 152749.9n 0.3000 152750.0n 0.3000 152999.9n 0.3000 153000.0n 0.3000 153249.9n 0.3000 153250.0n 0.3000 153499.9n 0.3000 153500.0n 0.7000 153749.9n 0.7000 153750.0n 0.7000 153999.9n 0.7000 154000.0n 0.3000 154249.9n 0.3000 154250.0n 0.7000 154499.9n 0.7000 154500.0n 0.7000 154749.9n 0.7000 154750.0n 0.7000 154999.9n 0.7000 155000.0n 0.7000 155249.9n 0.7000 155250.0n 0.7000 155499.9n 0.7000 155500.0n 0.3000 155749.9n 0.3000 155750.0n 0.7000 155999.9n 0.7000 156000.0n 0.7000 156249.9n 0.7000 156250.0n 0.3000 156499.9n 0.3000 156500.0n 0.7000 156749.9n 0.7000 156750.0n 0.3000 156999.9n 0.3000 157000.0n 0.7000 157249.9n 0.7000 157250.0n 0.3000 157499.9n 0.3000 157500.0n 0.3000 157749.9n 0.3000 157750.0n 0.3000 157999.9n 0.3000 158000.0n 0.3000 158249.9n 0.3000 158250.0n 0.3000 158499.9n 0.3000 158500.0n 0.3000 158749.9n 0.3000 158750.0n 0.7000 158999.9n 0.7000 159000.0n 0.7000 159249.9n 0.7000 159250.0n 0.7000 159499.9n 0.7000 159500.0n 0.7000 159749.9n 0.7000 159750.0n 0.7000 159999.9n 0.7000 160000.0n 0.3000 160249.9n 0.3000 160250.0n 0.7000 160499.9n 0.7000 160500.0n 0.3000 160749.9n 0.3000 160750.0n 0.7000 160999.9n 0.7000 161000.0n 0.7000 161249.9n 0.7000 161250.0n 0.3000 161499.9n 0.3000 161500.0n 0.3000 161749.9n 0.3000 161750.0n 0.3000 161999.9n 0.3000 162000.0n 0.3000 162249.9n 0.3000 162250.0n 0.3000 162499.9n 0.3000 162500.0n 0.3000 162749.9n 0.3000 162750.0n 0.3000 162999.9n 0.3000 163000.0n 0.3000 163249.9n 0.3000 163250.0n 0.7000 163499.9n 0.7000 163500.0n 0.3000 163749.9n 0.3000 163750.0n 0.7000 163999.9n 0.7000 164000.0n 0.7000 164249.9n 0.7000 164250.0n 0.3000 164499.9n 0.3000 164500.0n 0.7000 164749.9n 0.7000 164750.0n 0.3000 164999.9n 0.3000 165000.0n 0.7000 165249.9n 0.7000 165250.0n 0.3000 165499.9n 0.3000 165500.0n 0.3000 165749.9n 0.3000 165750.0n 0.7000 165999.9n 0.7000 166000.0n 0.7000 166249.9n 0.7000 166250.0n 0.3000 166499.9n 0.3000 166500.0n 0.3000 166749.9n 0.3000 166750.0n 0.3000 166999.9n 0.3000 167000.0n 0.7000 167249.9n 0.7000 167250.0n 0.7000 167499.9n 0.7000 167500.0n 0.3000 167749.9n 0.3000 167750.0n 0.7000 167999.9n 0.7000 168000.0n 0.7000 168249.9n 0.7000 168250.0n 0.7000 168499.9n 0.7000 168500.0n 0.3000 168749.9n 0.3000 168750.0n 0.3000 168999.9n 0.3000 169000.0n 0.7000 169249.9n 0.7000 169250.0n 0.3000 169499.9n 0.3000 169500.0n 0.3000 169749.9n 0.3000 169750.0n 0.3000 169999.9n 0.3000 170000.0n 0.7000 170249.9n 0.7000 170250.0n 0.7000 170499.9n 0.7000 170500.0n 0.7000 170749.9n 0.7000 170750.0n 0.3000 170999.9n 0.3000 171000.0n 0.3000 171249.9n 0.3000 171250.0n 0.7000 171499.9n 0.7000 171500.0n 0.3000 171749.9n 0.3000 171750.0n 0.3000 171999.9n 0.3000 172000.0n 0.3000 172249.9n 0.3000 172250.0n 0.3000 172499.9n 0.3000 172500.0n 0.7000 172749.9n 0.7000 172750.0n 0.7000 172999.9n 0.7000 173000.0n 0.7000 173249.9n 0.7000 173250.0n 0.3000 173499.9n 0.3000 173500.0n 0.7000 173749.9n 0.7000 173750.0n 0.3000 173999.9n 0.3000 174000.0n 0.3000 174249.9n 0.3000 174250.0n 0.3000 174499.9n 0.3000 174500.0n 0.3000 174749.9n 0.3000 174750.0n 0.7000 174999.9n 0.7000 175000.0n 0.7000 175249.9n 0.7000 175250.0n 0.7000 175499.9n 0.7000 175500.0n 0.7000 175749.9n 0.7000 175750.0n 0.7000 175999.9n 0.7000 176000.0n 0.3000 176249.9n 0.3000 176250.0n 0.3000 176499.9n 0.3000 176500.0n 0.3000 176749.9n 0.3000 176750.0n 0.3000 176999.9n 0.3000 177000.0n 0.7000 177249.9n 0.7000 177250.0n 0.3000 177499.9n 0.3000 177500.0n 0.7000 177749.9n 0.7000 177750.0n 0.7000 177999.9n 0.7000 178000.0n 0.3000 178249.9n 0.3000 178250.0n 0.7000 178499.9n 0.7000 178500.0n 0.3000 178749.9n 0.3000 178750.0n 0.3000 178999.9n 0.3000 179000.0n 0.7000 179249.9n 0.7000 179250.0n 0.7000 179499.9n 0.7000 179500.0n 0.3000 179749.9n 0.3000 179750.0n 0.3000 179999.9n 0.3000 180000.0n 0.7000 180249.9n 0.7000 180250.0n 0.3000 180499.9n 0.3000 180500.0n 0.7000 180749.9n 0.7000 180750.0n 0.7000 180999.9n 0.7000 181000.0n 0.3000 181249.9n 0.3000 181250.0n 0.7000 181499.9n 0.7000 181500.0n 0.7000 181749.9n 0.7000 181750.0n 0.3000 181999.9n 0.3000 182000.0n 0.3000 182249.9n 0.3000 182250.0n 0.3000 182499.9n 0.3000 182500.0n 0.3000 182749.9n 0.3000 182750.0n 0.7000 182999.9n 0.7000 183000.0n 0.3000 183249.9n 0.3000 183250.0n 0.3000 183499.9n 0.3000 183500.0n 0.3000 183749.9n 0.3000 183750.0n 0.3000 183999.9n 0.3000 184000.0n 0.3000 184249.9n 0.3000 184250.0n 0.3000 184499.9n 0.3000 184500.0n 0.7000 184749.9n 0.7000 184750.0n 0.7000 184999.9n 0.7000 185000.0n 0.7000 185249.9n 0.7000 185250.0n 0.7000 185499.9n 0.7000 185500.0n 0.3000 185749.9n 0.3000 185750.0n 0.3000 185999.9n 0.3000 186000.0n 0.7000 186249.9n 0.7000 186250.0n 0.7000 186499.9n 0.7000 186500.0n 0.3000 186749.9n 0.3000 186750.0n 0.3000 186999.9n 0.3000 187000.0n 0.3000 187249.9n 0.3000 187250.0n 0.3000 187499.9n 0.3000 187500.0n 0.3000 187749.9n 0.3000 187750.0n 0.3000 187999.9n 0.3000 188000.0n 0.3000 188249.9n 0.3000 188250.0n 0.7000 188499.9n 0.7000 188500.0n 0.7000 188749.9n 0.7000 188750.0n 0.7000 188999.9n 0.7000 189000.0n 0.7000 189249.9n 0.7000 189250.0n 0.3000 189499.9n 0.3000 189500.0n 0.7000 189749.9n 0.7000 189750.0n 0.7000 189999.9n 0.7000 190000.0n 0.3000 190249.9n 0.3000 190250.0n 0.7000 190499.9n 0.7000 190500.0n 0.3000 190749.9n 0.3000 190750.0n 0.7000 190999.9n 0.7000 191000.0n 0.3000 191249.9n 0.3000 191250.0n 0.7000 191499.9n 0.7000 191500.0n 0.3000 191749.9n 0.3000 191750.0n 0.3000 191999.9n 0.3000 192000.0n 0.3000 192249.9n 0.3000 192250.0n 0.3000 192499.9n 0.3000 192500.0n 0.7000 192749.9n 0.7000 192750.0n 0.3000 192999.9n 0.3000 193000.0n 0.7000 193249.9n 0.7000 193250.0n 0.7000 193499.9n 0.7000 193500.0n 0.7000 193749.9n 0.7000 193750.0n 0.3000 193999.9n 0.3000 194000.0n 0.7000 194249.9n 0.7000 194250.0n 0.3000 194499.9n 0.3000 194500.0n 0.7000 194749.9n 0.7000 194750.0n 0.7000 194999.9n 0.7000 195000.0n 0.7000 195249.9n 0.7000 195250.0n 0.7000 195499.9n 0.7000 195500.0n 0.3000 195749.9n 0.3000 195750.0n 0.3000 195999.9n 0.3000 196000.0n 0.3000 196249.9n 0.3000 196250.0n 0.7000 196499.9n 0.7000 196500.0n 0.3000 196749.9n 0.3000 196750.0n 0.3000 196999.9n 0.3000 197000.0n 0.3000 197249.9n 0.3000 197250.0n 0.7000 197499.9n 0.7000 197500.0n 0.7000 197749.9n 0.7000 197750.0n 0.3000 197999.9n 0.3000 198000.0n 0.7000 198249.9n 0.7000 198250.0n 0.7000 198499.9n 0.7000 198500.0n 0.7000 198749.9n 0.7000 198750.0n 0.3000 198999.9n 0.3000 199000.0n 0.3000 199249.9n 0.3000 199250.0n 0.3000 199499.9n 0.3000 199500.0n 0.3000 199749.9n 0.3000 199750.0n 0.7000 199999.9n 0.7000 200000.0n 0.7000 200249.9n 0.7000 200250.0n 0.3000 200499.9n 0.3000 200500.0n 0.3000 200749.9n 0.3000 200750.0n 0.3000 200999.9n 0.3000 201000.0n 0.7000 201249.9n 0.7000 201250.0n 0.7000 201499.9n 0.7000 201500.0n 0.7000 201749.9n 0.7000 201750.0n 0.3000 201999.9n 0.3000 202000.0n 0.7000 202249.9n 0.7000 202250.0n 0.7000 202499.9n 0.7000 202500.0n 0.7000 202749.9n 0.7000 202750.0n 0.7000 202999.9n 0.7000 203000.0n 0.3000 203249.9n 0.3000 203250.0n 0.3000 203499.9n 0.3000 203500.0n 0.7000 203749.9n 0.7000 203750.0n 0.3000 203999.9n 0.3000 204000.0n 0.3000 204249.9n 0.3000 204250.0n 0.3000 204499.9n 0.3000 204500.0n 0.7000 204749.9n 0.7000 204750.0n 0.3000 204999.9n 0.3000 205000.0n 0.3000 205249.9n 0.3000 205250.0n 0.3000 205499.9n 0.3000 205500.0n 0.3000 205749.9n 0.3000 205750.0n 0.3000 205999.9n 0.3000 206000.0n 0.7000 206249.9n 0.7000 206250.0n 0.7000 206499.9n 0.7000 206500.0n 0.7000 206749.9n 0.7000 206750.0n 0.3000 206999.9n 0.3000 207000.0n 0.7000 207249.9n 0.7000 207250.0n 0.3000 207499.9n 0.3000 207500.0n 0.7000 207749.9n 0.7000 207750.0n 0.7000 207999.9n 0.7000 208000.0n 0.3000 208249.9n 0.3000 208250.0n 0.3000 208499.9n 0.3000 208500.0n 0.7000 208749.9n 0.7000 208750.0n 0.3000 208999.9n 0.3000 209000.0n 0.3000 209249.9n 0.3000 209250.0n 0.3000 209499.9n 0.3000 209500.0n 0.7000 209749.9n 0.7000 209750.0n 0.7000 209999.9n 0.7000 210000.0n 0.7000 210249.9n 0.7000 210250.0n 0.3000 210499.9n 0.3000 210500.0n 0.7000 210749.9n 0.7000 210750.0n 0.3000 210999.9n 0.3000 211000.0n 0.7000 211249.9n 0.7000 211250.0n 0.3000 211499.9n 0.3000 211500.0n 0.3000 211749.9n 0.3000 211750.0n 0.7000 211999.9n 0.7000 212000.0n 0.7000 212249.9n 0.7000 212250.0n 0.3000 212499.9n 0.3000 212500.0n 0.3000 212749.9n 0.3000 212750.0n 0.7000 212999.9n 0.7000 213000.0n 0.3000 213249.9n 0.3000 213250.0n 0.7000 213499.9n 0.7000 213500.0n 0.3000 213749.9n 0.3000 213750.0n 0.3000 213999.9n 0.3000 214000.0n 0.3000 214249.9n 0.3000 214250.0n 0.3000 214499.9n 0.3000 214500.0n 0.3000 214749.9n 0.3000 214750.0n 0.3000 214999.9n 0.3000 215000.0n 0.3000 215249.9n 0.3000 215250.0n 0.7000 215499.9n 0.7000 215500.0n 0.3000 215749.9n 0.3000 215750.0n 0.7000 215999.9n 0.7000 216000.0n 0.3000 216249.9n 0.3000 216250.0n 0.3000 216499.9n 0.3000 216500.0n 0.7000 216749.9n 0.7000 216750.0n 0.3000 216999.9n 0.3000 217000.0n 0.7000 217249.9n 0.7000 217250.0n 0.7000 217499.9n 0.7000 217500.0n 0.3000 217749.9n 0.3000 217750.0n 0.7000 217999.9n 0.7000 218000.0n 0.7000 218249.9n 0.7000 218250.0n 0.7000 218499.9n 0.7000 218500.0n 0.7000 218749.9n 0.7000 218750.0n 0.3000 218999.9n 0.3000 219000.0n 0.3000 219249.9n 0.3000 219250.0n 0.3000 219499.9n 0.3000 219500.0n 0.3000 219749.9n 0.3000 219750.0n 0.7000 219999.9n 0.7000 220000.0n 0.3000 220249.9n 0.3000 220250.0n 0.3000 220499.9n 0.3000 220500.0n 0.7000 220749.9n 0.7000 220750.0n 0.3000 220999.9n 0.3000 221000.0n 0.7000 221249.9n 0.7000 221250.0n 0.3000 221499.9n 0.3000 221500.0n 0.3000 221749.9n 0.3000 221750.0n 0.7000 221999.9n 0.7000 222000.0n 0.7000 222249.9n 0.7000 222250.0n 0.7000 222499.9n 0.7000 222500.0n 0.7000 222749.9n 0.7000 222750.0n 0.3000 222999.9n 0.3000 223000.0n 0.7000 223249.9n 0.7000 223250.0n 0.7000 223499.9n 0.7000 223500.0n 0.3000 223749.9n 0.3000 223750.0n 0.7000 223999.9n 0.7000 224000.0n 0.7000 224249.9n 0.7000 224250.0n 0.3000 224499.9n 0.3000 224500.0n 0.3000 224749.9n 0.3000 224750.0n 0.7000 224999.9n 0.7000 225000.0n 0.3000 225249.9n 0.3000 225250.0n 0.7000 225499.9n 0.7000 225500.0n 0.3000 225749.9n 0.3000 225750.0n 0.7000 225999.9n 0.7000 226000.0n 0.7000 226249.9n 0.7000 226250.0n 0.7000 226499.9n 0.7000 226500.0n 0.3000 226749.9n 0.3000 226750.0n 0.7000 226999.9n 0.7000 227000.0n 0.7000 227249.9n 0.7000 227250.0n 0.7000 227499.9n 0.7000 227500.0n 0.7000 227749.9n 0.7000 227750.0n 0.3000 227999.9n 0.3000 228000.0n 0.3000 228249.9n 0.3000 228250.0n 0.3000 228499.9n 0.3000 228500.0n 0.3000 228749.9n 0.3000 228750.0n 0.3000 228999.9n 0.3000 229000.0n 0.7000 229249.9n 0.7000 229250.0n 0.3000 229499.9n 0.3000 229500.0n 0.3000 229749.9n 0.3000 229750.0n 0.7000 229999.9n 0.7000 230000.0n 0.3000 230249.9n 0.3000 230250.0n 0.3000 230499.9n 0.3000 230500.0n 0.3000 230749.9n 0.3000 230750.0n 0.7000 230999.9n 0.7000 231000.0n 0.3000 231249.9n 0.3000 231250.0n 0.3000 231499.9n 0.3000 231500.0n 0.7000 231749.9n 0.7000 231750.0n 0.3000 231999.9n 0.3000 232000.0n 0.3000 232249.9n 0.3000 232250.0n 0.3000 232499.9n 0.3000 232500.0n 0.3000 232749.9n 0.3000 232750.0n 0.3000 232999.9n 0.3000 233000.0n 0.7000 233249.9n 0.7000 233250.0n 0.7000 233499.9n 0.7000 233500.0n 0.3000 233749.9n 0.3000 233750.0n 0.7000 233999.9n 0.7000 234000.0n 0.3000 234249.9n 0.3000 234250.0n 0.3000 234499.9n 0.3000 234500.0n 0.3000 234749.9n 0.3000 234750.0n 0.3000 234999.9n 0.3000 235000.0n 0.3000 235249.9n 0.3000 235250.0n 0.7000 235499.9n 0.7000 235500.0n 0.3000 235749.9n 0.3000 235750.0n 0.3000 235999.9n 0.3000 236000.0n 0.7000 236249.9n 0.7000 236250.0n 0.7000 236499.9n 0.7000 236500.0n 0.7000 236749.9n 0.7000 236750.0n 0.3000 236999.9n 0.3000 237000.0n 0.7000 237249.9n 0.7000 237250.0n 0.3000 237499.9n 0.3000 237500.0n 0.3000 237749.9n 0.3000 237750.0n 0.7000 237999.9n 0.7000 238000.0n 0.7000 238249.9n 0.7000 238250.0n 0.7000 238499.9n 0.7000 238500.0n 0.7000 238749.9n 0.7000 238750.0n 0.3000 238999.9n 0.3000 239000.0n 0.7000 239249.9n 0.7000 239250.0n 0.7000 239499.9n 0.7000 239500.0n 0.7000 239749.9n 0.7000 239750.0n 0.7000 239999.9n 0.7000 240000.0n 0.3000 240249.9n 0.3000 240250.0n 0.7000 240499.9n 0.7000 240500.0n 0.7000 240749.9n 0.7000 240750.0n 0.3000 240999.9n 0.3000 241000.0n 0.7000 241249.9n 0.7000 241250.0n 0.3000 241499.9n 0.3000 241500.0n 0.3000 241749.9n 0.3000 241750.0n 0.7000 241999.9n 0.7000 242000.0n 0.3000 242249.9n 0.3000 242250.0n 0.7000 242499.9n 0.7000 242500.0n 0.7000 242749.9n 0.7000 242750.0n 0.7000 242999.9n 0.7000 243000.0n 0.3000 243249.9n 0.3000 243250.0n 0.3000 243499.9n 0.3000 243500.0n 0.7000 243749.9n 0.7000 243750.0n 0.7000 243999.9n 0.7000 244000.0n 0.7000 244249.9n 0.7000 244250.0n 0.7000 244499.9n 0.7000 244500.0n 0.7000 244749.9n 0.7000 244750.0n 0.3000 244999.9n 0.3000 245000.0n 0.3000 245249.9n 0.3000 245250.0n 0.3000 245499.9n 0.3000 245500.0n 0.7000 245749.9n 0.7000 245750.0n 0.7000 245999.9n 0.7000 246000.0n 0.7000 246249.9n 0.7000 246250.0n 0.3000 246499.9n 0.3000 246500.0n 0.3000 246749.9n 0.3000 246750.0n 0.7000 246999.9n 0.7000 247000.0n 0.3000 247249.9n 0.3000 247250.0n 0.7000 247499.9n 0.7000 247500.0n 0.3000 247749.9n 0.3000 247750.0n 0.3000 247999.9n 0.3000 248000.0n 0.3000 248249.9n 0.3000 248250.0n 0.3000 248499.9n 0.3000 248500.0n 0.7000 248749.9n 0.7000 248750.0n 0.3000 248999.9n 0.3000 249000.0n 0.7000 249249.9n 0.7000 249250.0n 0.7000 249499.9n 0.7000 249500.0n 0.3000 249749.9n 0.3000 249750.0n 0.3000 249999.9n 0.3000 250000.0n 0.3000 250249.9n 0.3000 250250.0n 0.3000 250499.9n 0.3000 250500.0n 0.3000 250749.9n 0.3000 250750.0n 0.7000 250999.9n 0.7000 251000.0n 0.7000 251249.9n 0.7000 251250.0n 0.7000 251499.9n 0.7000 251500.0n 0.3000 251749.9n 0.3000 251750.0n 0.3000 251999.9n 0.3000 252000.0n 0.7000 252249.9n 0.7000 252250.0n 0.3000 252499.9n 0.3000 252500.0n 0.7000 252749.9n 0.7000 252750.0n 0.3000 252999.9n 0.3000 253000.0n 0.3000 253249.9n 0.3000 253250.0n 0.7000 253499.9n 0.7000 253500.0n 0.3000 253749.9n 0.3000 253750.0n 0.3000 253999.9n 0.3000 254000.0n 0.7000 254249.9n 0.7000 254250.0n 0.3000 254499.9n 0.3000 254500.0n 0.3000 254749.9n 0.3000 254750.0n 0.7000 254999.9n 0.7000 255000.0n 0.7000 255249.9n 0.7000 255250.0n 0.3000 255499.9n 0.3000 255500.0n 0.3000 255749.9n 0.3000 255750.0n 0.7000 255999.9n 0.7000 256000.0n 0.3000 256249.9n 0.3000 256250.0n 0.3000 256499.9n 0.3000 256500.0n 0.3000 256749.9n 0.3000 256750.0n 0.3000 256999.9n 0.3000 257000.0n 0.7000 257249.9n 0.7000 257250.0n 0.7000 257499.9n 0.7000 257500.0n 0.7000 257749.9n 0.7000 257750.0n 0.7000 257999.9n 0.7000 258000.0n 0.3000 258249.9n 0.3000 258250.0n 0.7000 258499.9n 0.7000 258500.0n 0.7000 258749.9n 0.7000 258750.0n 0.7000 258999.9n 0.7000 259000.0n 0.3000 259249.9n 0.3000 259250.0n 0.3000 259499.9n 0.3000 259500.0n 0.7000 259749.9n 0.7000 259750.0n 0.7000 259999.9n 0.7000 260000.0n 0.3000 260249.9n 0.3000 260250.0n 0.3000 260499.9n 0.3000 260500.0n 0.3000 260749.9n 0.3000 260750.0n 0.7000 260999.9n 0.7000 261000.0n 0.3000 261249.9n 0.3000 261250.0n 0.7000 261499.9n 0.7000 261500.0n 0.3000 261749.9n 0.3000 261750.0n 0.7000 261999.9n 0.7000 262000.0n 0.3000 262249.9n 0.3000 262250.0n 0.3000 262499.9n 0.3000 262500.0n 0.3000 262749.9n 0.3000 262750.0n 0.3000 262999.9n 0.3000 263000.0n 0.3000 263249.9n 0.3000 263250.0n 0.7000 263499.9n 0.7000 263500.0n 0.3000 263749.9n 0.3000 263750.0n 0.3000 263999.9n 0.3000 264000.0n 0.3000 264249.9n 0.3000 264250.0n 0.3000 264499.9n 0.3000 264500.0n 0.3000 264749.9n 0.3000 264750.0n 0.7000 264999.9n 0.7000 265000.0n 0.3000 265249.9n 0.3000 265250.0n 0.7000 265499.9n 0.7000 265500.0n 0.7000 265749.9n 0.7000 265750.0n 0.7000 265999.9n 0.7000 266000.0n 0.3000 266249.9n 0.3000 266250.0n 0.7000 266499.9n 0.7000 266500.0n 0.3000 266749.9n 0.3000 266750.0n 0.3000 266999.9n 0.3000 267000.0n 0.7000 267249.9n 0.7000 267250.0n 0.7000 267499.9n 0.7000 267500.0n 0.3000 267749.9n 0.3000 267750.0n 0.7000 267999.9n 0.7000 268000.0n 0.7000 268249.9n 0.7000 268250.0n 0.3000 268499.9n 0.3000 268500.0n 0.7000 268749.9n 0.7000 268750.0n 0.7000 268999.9n 0.7000 269000.0n 0.7000 269249.9n 0.7000 269250.0n 0.3000 269499.9n 0.3000 269500.0n 0.7000 269749.9n 0.7000 269750.0n 0.3000 269999.9n 0.3000 270000.0n 0.3000 270249.9n 0.3000 270250.0n 0.7000 270499.9n 0.7000 270500.0n 0.7000 270749.9n 0.7000 270750.0n 0.3000 270999.9n 0.3000 271000.0n 0.3000 271249.9n 0.3000 271250.0n 0.3000 271499.9n 0.3000 271500.0n 0.3000 271749.9n 0.3000 271750.0n 0.3000 271999.9n 0.3000 272000.0n 0.7000 272249.9n 0.7000 272250.0n 0.7000 272499.9n 0.7000 272500.0n 0.7000 272749.9n 0.7000 272750.0n 0.7000 272999.9n 0.7000 273000.0n 0.3000 273249.9n 0.3000 273250.0n 0.3000 273499.9n 0.3000 273500.0n 0.7000 273749.9n 0.7000 273750.0n 0.3000 273999.9n 0.3000 274000.0n 0.3000 274249.9n 0.3000 274250.0n 0.7000 274499.9n 0.7000 274500.0n 0.3000 274749.9n 0.3000 274750.0n 0.3000 274999.9n 0.3000 275000.0n 0.7000 275249.9n 0.7000 275250.0n 0.7000 275499.9n 0.7000 275500.0n 0.7000 275749.9n 0.7000 275750.0n 0.7000 275999.9n 0.7000 276000.0n 0.3000 276249.9n 0.3000 276250.0n 0.7000 276499.9n 0.7000 276500.0n 0.7000 276749.9n 0.7000 276750.0n 0.3000 276999.9n 0.3000 277000.0n 0.3000 277249.9n 0.3000 277250.0n 0.3000 277499.9n 0.3000 277500.0n 0.7000 277749.9n 0.7000 277750.0n 0.3000 277999.9n 0.3000 278000.0n 0.7000 278249.9n 0.7000 278250.0n 0.3000 278499.9n 0.3000 278500.0n 0.3000 278749.9n 0.3000 278750.0n 0.7000 278999.9n 0.7000 279000.0n 0.3000 279249.9n 0.3000 279250.0n 0.7000 279499.9n 0.7000 279500.0n 0.3000 279749.9n 0.3000 279750.0n 0.3000 279999.9n 0.3000 280000.0n 0.3000 280249.9n 0.3000 280250.0n 0.7000 280499.9n 0.7000 280500.0n 0.7000 280749.9n 0.7000 280750.0n 0.7000 280999.9n 0.7000 281000.0n 0.7000 281249.9n 0.7000 281250.0n 0.7000 281499.9n 0.7000 281500.0n 0.3000 281749.9n 0.3000 281750.0n 0.7000 281999.9n 0.7000 282000.0n 0.3000 282249.9n 0.3000 282250.0n 0.3000 282499.9n 0.3000 282500.0n 0.3000 282749.9n 0.3000 282750.0n 0.7000 282999.9n 0.7000 283000.0n 0.3000 283249.9n 0.3000 283250.0n 0.7000 283499.9n 0.7000 283500.0n 0.7000 283749.9n 0.7000 283750.0n 0.3000 283999.9n 0.3000 284000.0n 0.7000 284249.9n 0.7000 284250.0n 0.3000 284499.9n 0.3000 284500.0n 0.3000 284749.9n 0.3000 284750.0n 0.3000 284999.9n 0.3000 285000.0n 0.7000 285249.9n 0.7000 285250.0n 0.3000 285499.9n 0.3000 285500.0n 0.7000 285749.9n 0.7000 285750.0n 0.3000 285999.9n 0.3000 286000.0n 0.3000 286249.9n 0.3000 286250.0n 0.3000 286499.9n 0.3000 286500.0n 0.7000 286749.9n 0.7000 286750.0n 0.3000 286999.9n 0.3000 287000.0n 0.7000 287249.9n 0.7000 287250.0n 0.3000 287499.9n 0.3000 287500.0n 0.3000 287749.9n 0.3000 287750.0n 0.3000 287999.9n 0.3000 288000.0n 0.7000 288249.9n 0.7000 288250.0n 0.3000 288499.9n 0.3000 288500.0n 0.7000 288749.9n 0.7000 288750.0n 0.7000 288999.9n 0.7000 289000.0n 0.7000 289249.9n 0.7000 289250.0n 0.7000 289499.9n 0.7000 289500.0n 0.7000 289749.9n 0.7000 289750.0n 0.7000 289999.9n 0.7000 290000.0n 0.3000 290249.9n 0.3000 290250.0n 0.3000 290499.9n 0.3000 290500.0n 0.3000 290749.9n 0.3000 290750.0n 0.7000 290999.9n 0.7000 291000.0n 0.7000 291249.9n 0.7000 291250.0n 0.3000 291499.9n 0.3000 291500.0n 0.3000 291749.9n 0.3000 291750.0n 0.3000 291999.9n 0.3000 292000.0n 0.3000 292249.9n 0.3000 292250.0n 0.7000 292499.9n 0.7000 292500.0n 0.3000 292749.9n 0.3000 292750.0n 0.7000 292999.9n 0.7000 293000.0n 0.7000 293249.9n 0.7000 293250.0n 0.7000 293499.9n 0.7000 293500.0n 0.7000 293749.9n 0.7000 293750.0n 0.7000 293999.9n 0.7000 294000.0n 0.7000 294249.9n 0.7000 294250.0n 0.3000 294499.9n 0.3000 294500.0n 0.7000 294749.9n 0.7000 294750.0n 0.3000 294999.9n 0.3000 295000.0n 0.3000 295249.9n 0.3000 295250.0n 0.3000 295499.9n 0.3000 295500.0n 0.3000 295749.9n 0.3000 295750.0n 0.3000 295999.9n 0.3000 296000.0n 0.3000 296249.9n 0.3000 296250.0n 0.3000 296499.9n 0.3000 296500.0n 0.3000 296749.9n 0.3000 296750.0n 0.3000 296999.9n 0.3000 297000.0n 0.7000 297249.9n 0.7000 297250.0n 0.7000 297499.9n 0.7000 297500.0n 0.7000 297749.9n 0.7000 297750.0n 0.3000 297999.9n 0.3000 298000.0n 0.3000 298249.9n 0.3000 298250.0n 0.3000 298499.9n 0.3000 298500.0n 0.7000 298749.9n 0.7000 298750.0n 0.3000 298999.9n 0.3000 299000.0n 0.7000 299249.9n 0.7000 299250.0n 0.7000 299499.9n 0.7000 299500.0n 0.3000 299749.9n 0.3000 299750.0n 0.7000 299999.9n 0.7000 300000.0n 0.3000 300249.9n 0.3000 300250.0n 0.3000 300499.9n 0.3000 300500.0n 0.7000 300749.9n 0.7000 300750.0n 0.3000 300999.9n 0.3000 301000.0n 0.7000 301249.9n 0.7000 301250.0n 0.3000 301499.9n 0.3000 301500.0n 0.3000 301749.9n 0.3000 301750.0n 0.7000 301999.9n 0.7000 302000.0n 0.3000 302249.9n 0.3000 302250.0n 0.3000 302499.9n 0.3000 302500.0n 0.7000 302749.9n 0.7000 302750.0n 0.7000 302999.9n 0.7000 303000.0n 0.7000 303249.9n 0.7000 303250.0n 0.3000 303499.9n 0.3000 303500.0n 0.3000 303749.9n 0.3000 303750.0n 0.3000 303999.9n 0.3000 304000.0n 0.7000 304249.9n 0.7000 304250.0n 0.7000 304499.9n 0.7000 304500.0n 0.3000 304749.9n 0.3000 304750.0n 0.3000 304999.9n 0.3000 305000.0n 0.7000 305249.9n 0.7000 305250.0n 0.3000 305499.9n 0.3000 305500.0n 0.7000 305749.9n 0.7000 305750.0n 0.7000 305999.9n 0.7000 306000.0n 0.7000 306249.9n 0.7000 306250.0n 0.3000 306499.9n 0.3000 306500.0n 0.3000 306749.9n 0.3000 306750.0n 0.7000 306999.9n 0.7000 307000.0n 0.3000 307249.9n 0.3000 307250.0n 0.3000 307499.9n 0.3000 307500.0n 0.7000 307749.9n 0.7000 307750.0n 0.7000 307999.9n 0.7000 308000.0n 0.7000 308249.9n 0.7000 308250.0n 0.7000 308499.9n 0.7000 308500.0n 0.3000 308749.9n 0.3000 308750.0n 0.3000 308999.9n 0.3000 309000.0n 0.7000 309249.9n 0.7000 309250.0n 0.7000 309499.9n 0.7000 309500.0n 0.7000 309749.9n 0.7000 309750.0n 0.7000 309999.9n 0.7000 310000.0n 0.3000 310249.9n 0.3000 310250.0n 0.3000 310499.9n 0.3000 310500.0n 0.3000 310749.9n 0.3000 310750.0n 0.7000 310999.9n 0.7000 311000.0n 0.3000 311249.9n 0.3000 311250.0n 0.3000 311499.9n 0.3000 311500.0n 0.7000 311749.9n 0.7000 311750.0n 0.7000 311999.9n 0.7000 312000.0n 0.7000 312249.9n 0.7000 312250.0n 0.3000 312499.9n 0.3000 312500.0n 0.3000 312749.9n 0.3000 312750.0n 0.7000 312999.9n 0.7000 313000.0n 0.7000 313249.9n 0.7000 313250.0n 0.3000 313499.9n 0.3000 313500.0n 0.3000 313749.9n 0.3000 313750.0n 0.3000 313999.9n 0.3000 314000.0n 0.3000 314249.9n 0.3000 314250.0n 0.7000 314499.9n 0.7000 314500.0n 0.3000 314749.9n 0.3000 314750.0n 0.3000 314999.9n 0.3000 315000.0n 0.7000 315249.9n 0.7000 315250.0n 0.3000 315499.9n 0.3000 315500.0n 0.7000 315749.9n 0.7000 315750.0n 0.3000 315999.9n 0.3000 316000.0n 0.3000 316249.9n 0.3000 316250.0n 0.7000 316499.9n 0.7000 316500.0n 0.7000 316749.9n 0.7000 316750.0n 0.3000 316999.9n 0.3000 317000.0n 0.3000 317249.9n 0.3000 317250.0n 0.3000 317499.9n 0.3000 317500.0n 0.3000 317749.9n 0.3000 317750.0n 0.3000 317999.9n 0.3000 318000.0n 0.7000 318249.9n 0.7000 318250.0n 0.7000 318499.9n 0.7000 318500.0n 0.3000 318749.9n 0.3000 318750.0n 0.3000 318999.9n 0.3000 319000.0n 0.3000 319249.9n 0.3000 319250.0n 0.7000 319499.9n 0.7000 319500.0n 0.7000 319749.9n 0.7000 319750.0n 0.3000 319999.9n 0.3000 320000.0n 0.3000 320249.9n 0.3000 320250.0n 0.3000 320499.9n 0.3000 320500.0n 0.7000 320749.9n 0.7000 320750.0n 0.3000 320999.9n 0.3000 321000.0n 0.7000 321249.9n 0.7000 321250.0n 0.3000 321499.9n 0.3000 321500.0n 0.7000 321749.9n 0.7000 321750.0n 0.7000 321999.9n 0.7000 322000.0n 0.7000 322249.9n 0.7000 322250.0n 0.7000 322499.9n 0.7000 322500.0n 0.3000 322749.9n 0.3000 322750.0n 0.3000 322999.9n 0.3000 323000.0n 0.7000 323249.9n 0.7000 323250.0n 0.3000 323499.9n 0.3000 323500.0n 0.3000 323749.9n 0.3000 323750.0n 0.3000 323999.9n 0.3000 324000.0n 0.7000 324249.9n 0.7000 324250.0n 0.3000 324499.9n 0.3000 324500.0n 0.7000 324749.9n 0.7000 324750.0n 0.3000 324999.9n 0.3000 325000.0n 0.3000 325249.9n 0.3000 325250.0n 0.3000 325499.9n 0.3000 325500.0n 0.7000 325749.9n 0.7000 325750.0n 0.3000 325999.9n 0.3000 326000.0n 0.7000 326249.9n 0.7000 326250.0n 0.3000 326499.9n 0.3000 326500.0n 0.7000 326749.9n 0.7000 326750.0n 0.3000 326999.9n 0.3000 327000.0n 0.7000 327249.9n 0.7000 327250.0n 0.7000 327499.9n 0.7000 327500.0n 0.3000 327749.9n 0.3000 327750.0n 0.7000 327999.9n 0.7000 328000.0n 0.7000 328249.9n 0.7000 328250.0n 0.3000 328499.9n 0.3000 328500.0n 0.7000 328749.9n 0.7000 328750.0n 0.3000 328999.9n 0.3000 329000.0n 0.7000 329249.9n 0.7000 329250.0n 0.7000 329499.9n 0.7000 329500.0n 0.3000 329749.9n 0.3000 329750.0n 0.7000 329999.9n 0.7000 330000.0n 0.3000 330249.9n 0.3000 330250.0n 0.7000 330499.9n 0.7000 330500.0n 0.7000 330749.9n 0.7000 330750.0n 0.3000 330999.9n 0.3000 331000.0n 0.7000 331249.9n 0.7000 331250.0n 0.7000 331499.9n 0.7000 331500.0n 0.7000 331749.9n 0.7000 331750.0n 0.7000 331999.9n 0.7000 332000.0n 0.7000 332249.9n 0.7000 332250.0n 0.7000 332499.9n 0.7000 332500.0n 0.3000 332749.9n 0.3000 332750.0n 0.3000 332999.9n 0.3000 333000.0n 0.7000 333249.9n 0.7000 333250.0n 0.3000 333499.9n 0.3000 333500.0n 0.3000 333749.9n 0.3000 333750.0n 0.3000 333999.9n 0.3000 334000.0n 0.3000 334249.9n 0.3000 334250.0n 0.3000 334499.9n 0.3000 334500.0n 0.3000 334749.9n 0.3000 334750.0n 0.7000 334999.9n 0.7000 335000.0n 0.3000 335249.9n 0.3000 335250.0n 0.3000 335499.9n 0.3000 335500.0n 0.7000 335749.9n 0.7000 335750.0n 0.7000 335999.9n 0.7000 336000.0n 0.3000 336249.9n 0.3000 336250.0n 0.7000 336499.9n 0.7000 336500.0n 0.7000 336749.9n 0.7000 336750.0n 0.7000 336999.9n 0.7000 337000.0n 0.7000 337249.9n 0.7000 337250.0n 0.3000 337499.9n 0.3000 337500.0n 0.3000 337749.9n 0.3000 337750.0n 0.7000 337999.9n 0.7000 338000.0n 0.3000 338249.9n 0.3000 338250.0n 0.7000 338499.9n 0.7000 338500.0n 0.3000 338749.9n 0.3000 338750.0n 0.7000 338999.9n 0.7000 339000.0n 0.7000 339249.9n 0.7000 339250.0n 0.3000 339499.9n 0.3000 339500.0n 0.3000 339749.9n 0.3000 339750.0n 0.7000 339999.9n 0.7000 340000.0n 0.3000 340249.9n 0.3000 340250.0n 0.7000 340499.9n 0.7000 340500.0n 0.7000 340749.9n 0.7000 340750.0n 0.7000 340999.9n 0.7000 341000.0n 0.3000 341249.9n 0.3000 341250.0n 0.3000 341499.9n 0.3000 341500.0n 0.7000 341749.9n 0.7000 341750.0n 0.7000 341999.9n 0.7000 342000.0n 0.3000 342249.9n 0.3000 342250.0n 0.3000 342499.9n 0.3000 342500.0n 0.3000 342749.9n 0.3000 342750.0n 0.3000 342999.9n 0.3000 343000.0n 0.3000 343249.9n 0.3000 343250.0n 0.3000 343499.9n 0.3000 343500.0n 0.7000 343749.9n 0.7000 343750.0n 0.3000 343999.9n 0.3000 344000.0n 0.3000 344249.9n 0.3000 344250.0n 0.7000 344499.9n 0.7000 344500.0n 0.3000 344749.9n 0.3000 344750.0n 0.3000 344999.9n 0.3000 345000.0n 0.7000 345249.9n 0.7000 345250.0n 0.7000 345499.9n 0.7000 345500.0n 0.7000 345749.9n 0.7000 345750.0n 0.7000 345999.9n 0.7000 346000.0n 0.7000 346249.9n 0.7000 346250.0n 0.7000 346499.9n 0.7000 346500.0n 0.3000 346749.9n 0.3000 346750.0n 0.3000 346999.9n 0.3000 347000.0n 0.3000 347249.9n 0.3000 347250.0n 0.7000 347499.9n 0.7000 347500.0n 0.3000 347749.9n 0.3000 347750.0n 0.3000 347999.9n 0.3000 348000.0n 0.3000 348249.9n 0.3000 348250.0n 0.3000 348499.9n 0.3000 348500.0n 0.7000 348749.9n 0.7000 348750.0n 0.3000 348999.9n 0.3000 349000.0n 0.7000 349249.9n 0.7000 349250.0n 0.3000 349499.9n 0.3000 349500.0n 0.3000 349749.9n 0.3000 349750.0n 0.7000 349999.9n 0.7000 350000.0n 0.3000 350249.9n 0.3000 350250.0n 0.7000 350499.9n 0.7000 350500.0n 0.7000 350749.9n 0.7000 350750.0n 0.3000 350999.9n 0.3000 351000.0n 0.7000 351249.9n 0.7000 351250.0n 0.3000 351499.9n 0.3000 351500.0n 0.3000 351749.9n 0.3000 351750.0n 0.3000 351999.9n 0.3000 352000.0n 0.7000 352249.9n 0.7000 352250.0n 0.3000 352499.9n 0.3000 352500.0n 0.7000 352749.9n 0.7000 352750.0n 0.3000 352999.9n 0.3000 353000.0n 0.3000 353249.9n 0.3000 353250.0n 0.3000 353499.9n 0.3000 353500.0n 0.7000 353749.9n 0.7000 353750.0n 0.7000 353999.9n 0.7000 354000.0n 0.3000 354249.9n 0.3000 354250.0n 0.7000 354499.9n 0.7000 354500.0n 0.3000 354749.9n 0.3000 354750.0n 0.7000 354999.9n 0.7000 355000.0n 0.7000 355249.9n 0.7000 355250.0n 0.7000 355499.9n 0.7000 355500.0n 0.7000 355749.9n 0.7000 355750.0n 0.7000 355999.9n 0.7000 356000.0n 0.7000 356249.9n 0.7000 356250.0n 0.3000 356499.9n 0.3000 356500.0n 0.3000 356749.9n 0.3000 356750.0n 0.3000 356999.9n 0.3000 357000.0n 0.7000 357249.9n 0.7000 357250.0n 0.3000 357499.9n 0.3000 357500.0n 0.7000 357749.9n 0.7000 357750.0n 0.7000 357999.9n 0.7000 358000.0n 0.3000 358249.9n 0.3000 358250.0n 0.3000 358499.9n 0.3000 358500.0n 0.7000 358749.9n 0.7000 358750.0n 0.3000 358999.9n 0.3000 359000.0n 0.3000 359249.9n 0.3000 359250.0n 0.3000 359499.9n 0.3000 359500.0n 0.3000 359749.9n 0.3000 359750.0n 0.3000 359999.9n 0.3000 360000.0n 0.7000 360249.9n 0.7000 360250.0n 0.3000 360499.9n 0.3000 360500.0n 0.7000 360749.9n 0.7000 360750.0n 0.3000 360999.9n 0.3000 361000.0n 0.3000 361249.9n 0.3000 361250.0n 0.7000 361499.9n 0.7000 361500.0n 0.3000 361749.9n 0.3000 361750.0n 0.3000 361999.9n 0.3000 362000.0n 0.7000 362249.9n 0.7000 362250.0n 0.3000 362499.9n 0.3000 362500.0n 0.3000 362749.9n 0.3000 362750.0n 0.3000 362999.9n 0.3000 363000.0n 0.7000 363249.9n 0.7000 363250.0n 0.7000 363499.9n 0.7000 363500.0n 0.7000 363749.9n 0.7000 363750.0n 0.7000 363999.9n 0.7000 364000.0n 0.3000 364249.9n 0.3000 364250.0n 0.3000 364499.9n 0.3000 364500.0n 0.3000 364749.9n 0.3000 364750.0n 0.3000 364999.9n 0.3000 365000.0n 0.3000 365249.9n 0.3000 365250.0n 0.7000 365499.9n 0.7000 365500.0n 0.3000 365749.9n 0.3000 365750.0n 0.7000 365999.9n 0.7000 366000.0n 0.3000 366249.9n 0.3000 366250.0n 0.3000 366499.9n 0.3000 366500.0n 0.7000 366749.9n 0.7000 366750.0n 0.3000 366999.9n 0.3000 367000.0n 0.3000 367249.9n 0.3000 367250.0n 0.3000 367499.9n 0.3000 367500.0n 0.3000 367749.9n 0.3000 367750.0n 0.7000 367999.9n 0.7000 368000.0n 0.7000 368249.9n 0.7000 368250.0n 0.7000 368499.9n 0.7000 368500.0n 0.7000 368749.9n 0.7000 368750.0n 0.3000 368999.9n 0.3000 369000.0n 0.7000 369249.9n 0.7000 369250.0n 0.3000 369499.9n 0.3000 369500.0n 0.7000 369749.9n 0.7000 369750.0n 0.3000 369999.9n 0.3000 370000.0n 0.7000 370249.9n 0.7000 370250.0n 0.7000 370499.9n 0.7000 370500.0n 0.7000 370749.9n 0.7000 370750.0n 0.3000 370999.9n 0.3000 371000.0n 0.7000 371249.9n 0.7000 371250.0n 0.3000 371499.9n 0.3000 371500.0n 0.3000 371749.9n 0.3000 371750.0n 0.3000 371999.9n 0.3000 372000.0n 0.3000 372249.9n 0.3000 372250.0n 0.7000 372499.9n 0.7000 372500.0n 0.7000 372749.9n 0.7000 372750.0n 0.3000 372999.9n 0.3000 373000.0n 0.7000 373249.9n 0.7000 373250.0n 0.3000 373499.9n 0.3000 373500.0n 0.7000 373749.9n 0.7000 373750.0n 0.3000 373999.9n 0.3000 374000.0n 0.7000 374249.9n 0.7000 374250.0n 0.3000 374499.9n 0.3000 374500.0n 0.7000 374749.9n 0.7000 374750.0n 0.7000 374999.9n 0.7000 375000.0n 0.3000 375249.9n 0.3000 375250.0n 0.3000 375499.9n 0.3000 375500.0n 0.7000 375749.9n 0.7000 375750.0n 0.7000 375999.9n 0.7000 376000.0n 0.3000 376249.9n 0.3000 376250.0n 0.7000 376499.9n 0.7000 376500.0n 0.7000 376749.9n 0.7000 376750.0n 0.7000 376999.9n 0.7000 377000.0n 0.3000 377249.9n 0.3000 377250.0n 0.3000 377499.9n 0.3000 377500.0n 0.7000 377749.9n 0.7000 377750.0n 0.3000 377999.9n 0.3000 378000.0n 0.7000 378249.9n 0.7000 378250.0n 0.3000 378499.9n 0.3000 378500.0n 0.7000 378749.9n 0.7000 378750.0n 0.3000 378999.9n 0.3000 379000.0n 0.3000 379249.9n 0.3000 379250.0n 0.3000 379499.9n 0.3000 379500.0n 0.3000 379749.9n 0.3000 379750.0n 0.3000 379999.9n 0.3000 380000.0n 0.7000 380249.9n 0.7000 380250.0n 0.7000 380499.9n 0.7000 380500.0n 0.3000 380749.9n 0.3000 380750.0n 0.7000 380999.9n 0.7000 381000.0n 0.3000 381249.9n 0.3000 381250.0n 0.3000 381499.9n 0.3000 381500.0n 0.7000 381749.9n 0.7000 381750.0n 0.7000 381999.9n 0.7000 382000.0n 0.3000 382249.9n 0.3000 382250.0n 0.3000 382499.9n 0.3000 382500.0n 0.7000 382749.9n 0.7000 382750.0n 0.3000 382999.9n 0.3000 383000.0n 0.7000 383249.9n 0.7000 383250.0n 0.7000 383499.9n 0.7000 383500.0n 0.3000 383749.9n 0.3000 383750.0n 0.7000 383999.9n 0.7000 384000.0n 0.7000 384249.9n 0.7000 384250.0n 0.3000 384499.9n 0.3000 384500.0n 0.3000 384749.9n 0.3000 384750.0n 0.7000 384999.9n 0.7000 385000.0n 0.7000 385249.9n 0.7000 385250.0n 0.3000 385499.9n 0.3000 385500.0n 0.7000 385749.9n 0.7000 385750.0n 0.7000 385999.9n 0.7000 386000.0n 0.3000 386249.9n 0.3000 386250.0n 0.7000 386499.9n 0.7000 386500.0n 0.3000 386749.9n 0.3000 386750.0n 0.3000 386999.9n 0.3000 387000.0n 0.7000 387249.9n 0.7000 387250.0n 0.3000 387499.9n 0.3000 387500.0n 0.3000 387749.9n 0.3000 387750.0n 0.3000 387999.9n 0.3000 388000.0n 0.7000 388249.9n 0.7000 388250.0n 0.3000 388499.9n 0.3000 388500.0n 0.3000 388749.9n 0.3000 388750.0n 0.3000 388999.9n 0.3000 389000.0n 0.3000 389249.9n 0.3000 389250.0n 0.7000 389499.9n 0.7000 389500.0n 0.7000 389749.9n 0.7000 389750.0n 0.7000 389999.9n 0.7000 390000.0n 0.7000 390249.9n 0.7000 390250.0n 0.3000 390499.9n 0.3000 390500.0n 0.7000 390749.9n 0.7000 390750.0n 0.7000 390999.9n 0.7000 391000.0n 0.3000 391249.9n 0.3000 391250.0n 0.7000 391499.9n 0.7000 391500.0n 0.3000 391749.9n 0.3000 391750.0n 0.3000 391999.9n 0.3000 392000.0n 0.7000 392249.9n 0.7000 392250.0n 0.3000 392499.9n 0.3000 392500.0n 0.7000 392749.9n 0.7000 392750.0n 0.3000 392999.9n 0.3000 393000.0n 0.7000 393249.9n 0.7000 393250.0n 0.7000 393499.9n 0.7000 393500.0n 0.3000 393749.9n 0.3000 393750.0n 0.3000 393999.9n 0.3000 394000.0n 0.3000 394249.9n 0.3000 394250.0n 0.3000 394499.9n 0.3000 394500.0n 0.3000 394749.9n 0.3000 394750.0n 0.3000 394999.9n 0.3000 395000.0n 0.3000 395249.9n 0.3000 395250.0n 0.7000 395499.9n 0.7000 395500.0n 0.7000 395749.9n 0.7000 395750.0n 0.3000 395999.9n 0.3000 396000.0n 0.3000 396249.9n 0.3000 396250.0n 0.7000 396499.9n 0.7000 396500.0n 0.3000 396749.9n 0.3000 396750.0n 0.7000 396999.9n 0.7000 397000.0n 0.7000 397249.9n 0.7000 397250.0n 0.3000 397499.9n 0.3000 397500.0n 0.7000 397749.9n 0.7000 397750.0n 0.3000 397999.9n 0.3000 398000.0n 0.7000 398249.9n 0.7000 398250.0n 0.7000 398499.9n 0.7000 398500.0n 0.7000 398749.9n 0.7000 398750.0n 0.3000 398999.9n 0.3000 399000.0n 0.3000 399249.9n 0.3000 399250.0n 0.3000 399499.9n 0.3000 399500.0n 0.3000 399749.9n 0.3000 399750.0n 0.3000 399999.9n 0.3000 400000.0n 0.3000 400249.9n 0.3000 400250.0n 0.7000 400499.9n 0.7000 400500.0n 0.7000 400749.9n 0.7000 400750.0n 0.3000 400999.9n 0.3000 401000.0n 0.7000 401249.9n 0.7000 401250.0n 0.3000 401499.9n 0.3000 401500.0n 0.7000 401749.9n 0.7000 401750.0n 0.7000 401999.9n 0.7000 402000.0n 0.3000 402249.9n 0.3000 402250.0n 0.7000 402499.9n 0.7000 402500.0n 0.3000 402749.9n 0.3000 402750.0n 0.7000 402999.9n 0.7000 403000.0n 0.7000 403249.9n 0.7000 403250.0n 0.7000 403499.9n 0.7000 403500.0n 0.7000 403749.9n 0.7000 403750.0n 0.3000 403999.9n 0.3000 404000.0n 0.3000 404249.9n 0.3000 404250.0n 0.7000 404499.9n 0.7000 404500.0n 0.3000 404749.9n 0.3000 404750.0n 0.3000 404999.9n 0.3000 405000.0n 0.7000 405249.9n 0.7000 405250.0n 0.3000 405499.9n 0.3000 405500.0n 0.3000 405749.9n 0.3000 405750.0n 0.3000 405999.9n 0.3000 406000.0n 0.3000 406249.9n 0.3000 406250.0n 0.7000 406499.9n 0.7000 406500.0n 0.7000 406749.9n 0.7000 406750.0n 0.7000 406999.9n 0.7000 407000.0n 0.3000 407249.9n 0.3000 407250.0n 0.7000 407499.9n 0.7000 407500.0n 0.7000 407749.9n 0.7000 407750.0n 0.3000 407999.9n 0.3000 408000.0n 0.3000 408249.9n 0.3000 408250.0n 0.3000 408499.9n 0.3000 408500.0n 0.7000 408749.9n 0.7000 408750.0n 0.3000 408999.9n 0.3000 409000.0n 0.7000 409249.9n 0.7000 409250.0n 0.7000 409499.9n 0.7000 409500.0n 0.3000 409749.9n 0.3000 409750.0n 0.3000 409999.9n 0.3000 410000.0n 0.3000 410249.9n 0.3000 410250.0n 0.7000 410499.9n 0.7000 410500.0n 0.7000 410749.9n 0.7000 410750.0n 0.7000 410999.9n 0.7000 411000.0n 0.3000 411249.9n 0.3000 411250.0n 0.7000 411499.9n 0.7000 411500.0n 0.3000 411749.9n 0.3000 411750.0n 0.7000 411999.9n 0.7000 412000.0n 0.7000 412249.9n 0.7000 412250.0n 0.3000 412499.9n 0.3000 412500.0n 0.3000 412749.9n 0.3000 412750.0n 0.7000 412999.9n 0.7000 413000.0n 0.7000 413249.9n 0.7000 413250.0n 0.3000 413499.9n 0.3000 413500.0n 0.3000 413749.9n 0.3000 413750.0n 0.7000 413999.9n 0.7000 414000.0n 0.7000 414249.9n 0.7000 414250.0n 0.3000 414499.9n 0.3000 414500.0n 0.3000 414749.9n 0.3000 414750.0n 0.3000 414999.9n 0.3000 415000.0n 0.3000 415249.9n 0.3000 415250.0n 0.7000 415499.9n 0.7000 415500.0n 0.7000 415749.9n 0.7000 415750.0n 0.3000 415999.9n 0.3000 416000.0n 0.3000 416249.9n 0.3000 416250.0n 0.3000 416499.9n 0.3000 416500.0n 0.7000 416749.9n 0.7000 416750.0n 0.7000 416999.9n 0.7000 417000.0n 0.7000 417249.9n 0.7000 417250.0n 0.3000 417499.9n 0.3000 417500.0n 0.3000 417749.9n 0.3000 417750.0n 0.7000 417999.9n 0.7000 418000.0n 0.7000 418249.9n 0.7000 418250.0n 0.3000 418499.9n 0.3000 418500.0n 0.3000 418749.9n 0.3000 418750.0n 0.7000 418999.9n 0.7000 419000.0n 0.3000 419249.9n 0.3000 419250.0n 0.3000 419499.9n 0.3000 419500.0n 0.3000 419749.9n 0.3000 419750.0n 0.7000 419999.9n 0.7000 420000.0n 0.7000 420249.9n 0.7000 420250.0n 0.3000 420499.9n 0.3000 420500.0n 0.3000 420749.9n 0.3000 420750.0n 0.3000 420999.9n 0.3000 421000.0n 0.7000 421249.9n 0.7000 421250.0n 0.7000 421499.9n 0.7000 421500.0n 0.3000 421749.9n 0.3000 421750.0n 0.7000 421999.9n 0.7000 422000.0n 0.3000 422249.9n 0.3000 422250.0n 0.7000 422499.9n 0.7000 422500.0n 0.7000 422749.9n 0.7000 422750.0n 0.3000 422999.9n 0.3000 423000.0n 0.3000 423249.9n 0.3000 423250.0n 0.7000 423499.9n 0.7000 423500.0n 0.3000 423749.9n 0.3000 423750.0n 0.7000 423999.9n 0.7000 424000.0n 0.7000 424249.9n 0.7000 424250.0n 0.7000 424499.9n 0.7000 424500.0n 0.3000 424749.9n 0.3000 424750.0n 0.3000 424999.9n 0.3000 425000.0n 0.7000 425249.9n 0.7000 425250.0n 0.3000 425499.9n 0.3000 425500.0n 0.7000 425749.9n 0.7000 425750.0n 0.3000 425999.9n 0.3000 426000.0n 0.7000 426249.9n 0.7000 426250.0n 0.3000 426499.9n 0.3000 426500.0n 0.3000 426749.9n 0.3000 426750.0n 0.3000 426999.9n 0.3000 427000.0n 0.7000 427249.9n 0.7000 427250.0n 0.3000 427499.9n 0.3000 427500.0n 0.7000 427749.9n 0.7000 427750.0n 0.3000 427999.9n 0.3000 428000.0n 0.7000 428249.9n 0.7000 428250.0n 0.7000 428499.9n 0.7000 428500.0n 0.3000 428749.9n 0.3000 428750.0n 0.3000 428999.9n 0.3000 429000.0n 0.3000 429249.9n 0.3000 429250.0n 0.7000 429499.9n 0.7000 429500.0n 0.7000 429749.9n 0.7000 429750.0n 0.3000 429999.9n 0.3000 430000.0n 0.7000 430249.9n 0.7000 430250.0n 0.7000 430499.9n 0.7000 430500.0n 0.3000 430749.9n 0.3000 430750.0n 0.3000 430999.9n 0.3000 431000.0n 0.3000 431249.9n 0.3000 431250.0n 0.7000 431499.9n 0.7000 431500.0n 0.3000 431749.9n 0.3000 431750.0n 0.3000 431999.9n 0.3000 432000.0n 0.3000 432249.9n 0.3000 432250.0n 0.7000 432499.9n 0.7000 432500.0n 0.7000 432749.9n 0.7000 432750.0n 0.3000 432999.9n 0.3000 433000.0n 0.7000 433249.9n 0.7000 433250.0n 0.7000 433499.9n 0.7000 433500.0n 0.3000 433749.9n 0.3000 433750.0n 0.3000 433999.9n 0.3000 434000.0n 0.7000 434249.9n 0.7000 434250.0n 0.7000 434499.9n 0.7000 434500.0n 0.3000 434749.9n 0.3000 434750.0n 0.3000 434999.9n 0.3000 435000.0n 0.7000 435249.9n 0.7000 435250.0n 0.3000 435499.9n 0.3000 435500.0n 0.3000 435749.9n 0.3000 435750.0n 0.3000 435999.9n 0.3000 436000.0n 0.3000 436249.9n 0.3000 436250.0n 0.7000 436499.9n 0.7000 436500.0n 0.7000 436749.9n 0.7000 436750.0n 0.7000 436999.9n 0.7000 437000.0n 0.3000 437249.9n 0.3000 437250.0n 0.3000 437499.9n 0.3000 437500.0n 0.7000 437749.9n 0.7000 437750.0n 0.3000 437999.9n 0.3000 438000.0n 0.3000 438249.9n 0.3000 438250.0n 0.7000 438499.9n 0.7000 438500.0n 0.7000 438749.9n 0.7000 438750.0n 0.3000 438999.9n 0.3000 439000.0n 0.3000 439249.9n 0.3000 439250.0n 0.3000 439499.9n 0.3000 439500.0n 0.3000 439749.9n 0.3000 439750.0n 0.7000 439999.9n 0.7000 440000.0n 0.7000 440249.9n 0.7000 440250.0n 0.7000 440499.9n 0.7000 440500.0n 0.7000 440749.9n 0.7000 440750.0n 0.7000 440999.9n 0.7000 441000.0n 0.7000 441249.9n 0.7000 441250.0n 0.3000 441499.9n 0.3000 441500.0n 0.7000 441749.9n 0.7000 441750.0n 0.3000 441999.9n 0.3000 442000.0n 0.3000 442249.9n 0.3000 442250.0n 0.7000 442499.9n 0.7000 442500.0n 0.7000 442749.9n 0.7000 442750.0n 0.7000 442999.9n 0.7000 443000.0n 0.7000 443249.9n 0.7000 443250.0n 0.7000 443499.9n 0.7000 443500.0n 0.7000 443749.9n 0.7000 443750.0n 0.3000 443999.9n 0.3000 444000.0n 0.7000 444249.9n 0.7000 444250.0n 0.7000 444499.9n 0.7000 444500.0n 0.7000 444749.9n 0.7000 444750.0n 0.3000 444999.9n 0.3000 445000.0n 0.3000 445249.9n 0.3000 445250.0n 0.3000 445499.9n 0.3000 445500.0n 0.3000 445749.9n 0.3000 445750.0n 0.3000 445999.9n 0.3000 446000.0n 0.3000 446249.9n 0.3000 446250.0n 0.3000 446499.9n 0.3000 446500.0n 0.3000 446749.9n 0.3000 446750.0n 0.3000 446999.9n 0.3000 447000.0n 0.3000 447249.9n 0.3000 447250.0n 0.3000 447499.9n 0.3000 447500.0n 0.3000 447749.9n 0.3000 447750.0n 0.7000 447999.9n 0.7000 448000.0n 0.3000 448249.9n 0.3000 448250.0n 0.7000 448499.9n 0.7000 448500.0n 0.7000 448749.9n 0.7000 448750.0n 0.3000 448999.9n 0.3000 449000.0n 0.7000 449249.9n 0.7000 449250.0n 0.7000 449499.9n 0.7000 449500.0n 0.3000 449749.9n 0.3000 449750.0n 0.3000 449999.9n 0.3000 450000.0n 0.5000 450249.9n 0.5000 450250.0n 0.5000 450499.9n 0.5000 450500.0n 0.5000 450749.9n 0.5000 450750.0n 0.5000 450999.9n 0.5000 451000.0n 0.5000 451249.9n 0.5000 451250.0n 0.5000 451499.9n 0.5000 451500.0n 0.5000 451749.9n 0.5000 451750.0n 0.5000 451999.9n 0.5000 452000.0n 0.5000 452249.9n 0.5000 452250.0n 0.5000 452499.9n 0.5000 452500.0n 0.5000 452749.9n 0.5000 452750.0n 0.5000 452999.9n 0.5000 453000.0n 0.5000 453249.9n 0.5000 453250.0n 0.5000 453499.9n 0.5000 453500.0n 0.5000 453749.9n 0.5000 453750.0n 0.5000 453999.9n 0.5000 454000.0n 0.5000 454249.9n 0.5000 454250.0n 0.5000 454499.9n 0.5000 454500.0n 0.5000 454749.9n 0.5000 454750.0n 0.5000 454999.9n 0.5000 455000.0n 0.5000 455249.9n 0.5000 455250.0n 0.5000 455499.9n 0.5000 455500.0n 0.5000 455749.9n 0.5000 455750.0n 0.5000 455999.9n 0.5000 456000.0n 0.5000 456249.9n 0.5000 456250.0n 0.5000 456499.9n 0.5000 456500.0n 0.5000 456749.9n 0.5000 456750.0n 0.5000 456999.9n 0.5000 457000.0n 0.5000 457249.9n 0.5000 457250.0n 0.5000 457499.9n 0.5000 457500.0n 0.5000 457749.9n 0.5000 457750.0n 0.5000 457999.9n 0.5000 458000.0n 0.5000 458249.9n 0.5000 458250.0n 0.5000 458499.9n 0.5000 458500.0n 0.5000 458749.9n 0.5000 458750.0n 0.5000 458999.9n 0.5000 459000.0n 0.5000 459249.9n 0.5000 459250.0n 0.5000 459499.9n 0.5000 459500.0n 0.5000 459749.9n 0.5000 459750.0n 0.5000 459999.9n 0.5000 460000.0n 0.5000 460249.9n 0.5000 460250.0n 0.5000 460499.9n 0.5000 460500.0n 0.5000 460749.9n 0.5000 460750.0n 0.5000 460999.9n 0.5000 461000.0n 0.5000 461249.9n 0.5000 461250.0n 0.5000 461499.9n 0.5000 461500.0n 0.5000 461749.9n 0.5000 461750.0n 0.5000 461999.9n 0.5000 462000.0n 0.5000 462249.9n 0.5000 462250.0n 0.5000 462499.9n 0.5000 462500.0n 0.5000 462749.9n 0.5000 462750.0n 0.5000 462999.9n 0.5000 463000.0n 0.5000 463249.9n 0.5000 463250.0n 0.5000 463499.9n 0.5000 463500.0n 0.5000 463749.9n 0.5000 463750.0n 0.5000 463999.9n 0.5000 464000.0n 0.5000 464249.9n 0.5000 464250.0n 0.5000 464499.9n 0.5000 464500.0n 0.5000 464749.9n 0.5000 464750.0n 0.5000 464999.9n 0.5000 465000.0n 0.5000 465249.9n 0.5000 465250.0n 0.5000 465499.9n 0.5000 465500.0n 0.5000 465749.9n 0.5000 465750.0n 0.5000 465999.9n 0.5000 466000.0n 0.5000 466249.9n 0.5000 466250.0n 0.5000 466499.9n 0.5000 466500.0n 0.5000 466749.9n 0.5000 466750.0n 0.5000 466999.9n 0.5000 467000.0n 0.5000 467249.9n 0.5000 467250.0n 0.5000 467499.9n 0.5000 467500.0n 0.5000 467749.9n 0.5000 467750.0n 0.5000 467999.9n 0.5000 468000.0n 0.5000 468249.9n 0.5000 468250.0n 0.5000 468499.9n 0.5000 468500.0n 0.5000 468749.9n 0.5000 468750.0n 0.5000 468999.9n 0.5000 469000.0n 0.5000 469249.9n 0.5000 469250.0n 0.5000 469499.9n 0.5000 469500.0n 0.5000 469749.9n 0.5000 469750.0n 0.5000 469999.9n 0.5000 470000.0n 0.5000 470249.9n 0.5000 470250.0n 0.5000 470499.9n 0.5000 470500.0n 0.5000 470749.9n 0.5000 470750.0n 0.5000 470999.9n 0.5000 471000.0n 0.5000 471249.9n 0.5000 471250.0n 0.5000 471499.9n 0.5000 471500.0n 0.5000 471749.9n 0.5000 471750.0n 0.5000 471999.9n 0.5000 472000.0n 0.5000 472249.9n 0.5000 472250.0n 0.5000 472499.9n 0.5000 472500.0n 0.5000 472749.9n 0.5000 472750.0n 0.5000 472999.9n 0.5000 473000.0n 0.5000 473249.9n 0.5000 473250.0n 0.5000 473499.9n 0.5000 473500.0n 0.5000 473749.9n 0.5000 473750.0n 0.5000 473999.9n 0.5000 474000.0n 0.5000 474249.9n 0.5000 474250.0n 0.5000 474499.9n 0.5000 474500.0n 0.5000 474749.9n 0.5000 474750.0n 0.5000 474999.9n 0.5000 475000.0n 0.5000 475249.9n 0.5000 475250.0n 0.5000 475499.9n 0.5000 475500.0n 0.5000 475749.9n 0.5000 475750.0n 0.5000 475999.9n 0.5000 476000.0n 0.5000 476249.9n 0.5000 476250.0n 0.5000 476499.9n 0.5000 476500.0n 0.5000 476749.9n 0.5000 476750.0n 0.5000 476999.9n 0.5000 477000.0n 0.5000 477249.9n 0.5000 477250.0n 0.5000 477499.9n 0.5000 477500.0n 0.5000 477749.9n 0.5000 477750.0n 0.5000 477999.9n 0.5000 478000.0n 0.5000 478249.9n 0.5000 478250.0n 0.5000 478499.9n 0.5000 478500.0n 0.5000 478749.9n 0.5000 478750.0n 0.5000 478999.9n 0.5000 479000.0n 0.5000 479249.9n 0.5000 479250.0n 0.5000 479499.9n 0.5000 479500.0n 0.5000 479749.9n 0.5000 479750.0n 0.5000)
Cwp_wih_1_0 wp_wih_1_0 0 30p
Cwn_wih_1_0 wn_wih_1_0 0 30p
Rwp_wih_1_0 wp_wih_1_0 wcm 2g
Rwn_wih_1_0 wn_wih_1_0 wcm 2g
Cwp_wih_2_0 wp_wih_2_0 0 30p
Cwn_wih_2_0 wn_wih_2_0 0 30p
Rwp_wih_2_0 wp_wih_2_0 wcm 2g
Rwn_wih_2_0 wn_wih_2_0 wcm 2g
Cwp_who_0 wp_who_0 0 30p
Cwn_who_0 wn_who_0 0 30p
Rwp_who_0 wp_who_0 wcm 2g
Rwn_who_0 wn_who_0 wcm 2g
Cwp_wih_1_1 wp_wih_1_1 0 30p
Cwn_wih_1_1 wn_wih_1_1 0 30p
Rwp_wih_1_1 wp_wih_1_1 wcm 2g
Rwn_wih_1_1 wn_wih_1_1 wcm 2g
Cwp_wih_2_1 wp_wih_2_1 0 30p
Cwn_wih_2_1 wn_wih_2_1 0 30p
Rwp_wih_2_1 wp_wih_2_1 wcm 2g
Rwn_wih_2_1 wn_wih_2_1 wcm 2g
Cwp_who_1 wp_who_1 0 30p
Cwn_who_1 wn_who_1 0 30p
Rwp_who_1 wp_who_1 wcm 2g
Rwn_who_1 wn_who_1 wcm 2g
Cwp_wih_1_2 wp_wih_1_2 0 30p
Cwn_wih_1_2 wn_wih_1_2 0 30p
Rwp_wih_1_2 wp_wih_1_2 wcm 2g
Rwn_wih_1_2 wn_wih_1_2 wcm 2g
Cwp_wih_2_2 wp_wih_2_2 0 30p
Cwn_wih_2_2 wn_wih_2_2 0 30p
Rwp_wih_2_2 wp_wih_2_2 wcm 2g
Rwn_wih_2_2 wn_wih_2_2 wcm 2g
Cwp_who_2 wp_who_2 0 30p
Cwn_who_2 wn_who_2 0 30p
Rwp_who_2 wp_who_2 wcm 2g
Rwn_who_2 wn_who_2 wcm 2g
Cwp_wih_1_3 wp_wih_1_3 0 30p
Cwn_wih_1_3 wn_wih_1_3 0 30p
Rwp_wih_1_3 wp_wih_1_3 wcm 2g
Rwn_wih_1_3 wn_wih_1_3 wcm 2g
Cwp_wih_2_3 wp_wih_2_3 0 30p
Cwn_wih_2_3 wn_wih_2_3 0 30p
Rwp_wih_2_3 wp_wih_2_3 wcm 2g
Rwn_wih_2_3 wn_wih_2_3 wcm 2g
Cwp_who_3 wp_who_3 0 30p
Cwn_who_3 wn_who_3 0 30p
Rwp_who_3 wp_who_3 wcm 2g
Rwn_who_3 wn_who_3 wcm 2g
Cwp_wih_1_4 wp_wih_1_4 0 30p
Cwn_wih_1_4 wn_wih_1_4 0 30p
Rwp_wih_1_4 wp_wih_1_4 wcm 2g
Rwn_wih_1_4 wn_wih_1_4 wcm 2g
Cwp_wih_2_4 wp_wih_2_4 0 30p
Cwn_wih_2_4 wn_wih_2_4 0 30p
Rwp_wih_2_4 wp_wih_2_4 wcm 2g
Rwn_wih_2_4 wn_wih_2_4 wcm 2g
Cwp_who_4 wp_who_4 0 30p
Cwn_who_4 wn_who_4 0 30p
Rwp_who_4 wp_who_4 wcm 2g
Rwn_who_4 wn_who_4 wcm 2g
Cwp_wih_1_5 wp_wih_1_5 0 30p
Cwn_wih_1_5 wn_wih_1_5 0 30p
Rwp_wih_1_5 wp_wih_1_5 wcm 2g
Rwn_wih_1_5 wn_wih_1_5 wcm 2g
Cwp_wih_2_5 wp_wih_2_5 0 30p
Cwn_wih_2_5 wn_wih_2_5 0 30p
Rwp_wih_2_5 wp_wih_2_5 wcm 2g
Rwn_wih_2_5 wn_wih_2_5 wcm 2g
Cwp_who_5 wp_who_5 0 30p
Cwn_who_5 wn_who_5 0 30p
Rwp_who_5 wp_who_5 wcm 2g
Rwn_who_5 wn_who_5 wcm 2g
Cwp_wih_1_6 wp_wih_1_6 0 30p
Cwn_wih_1_6 wn_wih_1_6 0 30p
Rwp_wih_1_6 wp_wih_1_6 wcm 2g
Rwn_wih_1_6 wn_wih_1_6 wcm 2g
Cwp_wih_2_6 wp_wih_2_6 0 30p
Cwn_wih_2_6 wn_wih_2_6 0 30p
Rwp_wih_2_6 wp_wih_2_6 wcm 2g
Rwn_wih_2_6 wn_wih_2_6 wcm 2g
Cwp_who_6 wp_who_6 0 30p
Cwn_who_6 wn_who_6 0 30p
Rwp_who_6 wp_who_6 wcm 2g
Rwn_who_6 wn_who_6 wcm 2g
Cwp_wih_1_7 wp_wih_1_7 0 30p
Cwn_wih_1_7 wn_wih_1_7 0 30p
Rwp_wih_1_7 wp_wih_1_7 wcm 2g
Rwn_wih_1_7 wn_wih_1_7 wcm 2g
Cwp_wih_2_7 wp_wih_2_7 0 30p
Cwn_wih_2_7 wn_wih_2_7 0 30p
Rwp_wih_2_7 wp_wih_2_7 wcm 2g
Rwn_wih_2_7 wn_wih_2_7 wcm 2g
Cwp_who_7 wp_who_7 0 30p
Cwn_who_7 wn_who_7 0 30p
Rwp_who_7 wp_who_7 wcm 2g
Rwn_who_7 wn_who_7 wcm 2g
Cwp_wih_1_8 wp_wih_1_8 0 30p
Cwn_wih_1_8 wn_wih_1_8 0 30p
Rwp_wih_1_8 wp_wih_1_8 wcm 2g
Rwn_wih_1_8 wn_wih_1_8 wcm 2g
Cwp_wih_2_8 wp_wih_2_8 0 30p
Cwn_wih_2_8 wn_wih_2_8 0 30p
Rwp_wih_2_8 wp_wih_2_8 wcm 2g
Rwn_wih_2_8 wn_wih_2_8 wcm 2g
Cwp_who_8 wp_who_8 0 30p
Cwn_who_8 wn_who_8 0 30p
Rwp_who_8 wp_who_8 wcm 2g
Rwn_who_8 wn_who_8 wcm 2g
Cwp_wih_1_9 wp_wih_1_9 0 30p
Cwn_wih_1_9 wn_wih_1_9 0 30p
Rwp_wih_1_9 wp_wih_1_9 wcm 2g
Rwn_wih_1_9 wn_wih_1_9 wcm 2g
Cwp_wih_2_9 wp_wih_2_9 0 30p
Cwn_wih_2_9 wn_wih_2_9 0 30p
Rwp_wih_2_9 wp_wih_2_9 wcm 2g
Rwn_wih_2_9 wn_wih_2_9 wcm 2g
Cwp_who_9 wp_who_9 0 30p
Cwn_who_9 wn_who_9 0 30p
Rwp_who_9 wp_who_9 wcm 2g
Rwn_who_9 wn_who_9 wcm 2g
Cwp_wih_1_10 wp_wih_1_10 0 30p
Cwn_wih_1_10 wn_wih_1_10 0 30p
Rwp_wih_1_10 wp_wih_1_10 wcm 2g
Rwn_wih_1_10 wn_wih_1_10 wcm 2g
Cwp_wih_2_10 wp_wih_2_10 0 30p
Cwn_wih_2_10 wn_wih_2_10 0 30p
Rwp_wih_2_10 wp_wih_2_10 wcm 2g
Rwn_wih_2_10 wn_wih_2_10 wcm 2g
Cwp_who_10 wp_who_10 0 30p
Cwn_who_10 wn_who_10 0 30p
Rwp_who_10 wp_who_10 wcm 2g
Rwn_who_10 wn_who_10 wcm 2g
Cwp_wih_1_11 wp_wih_1_11 0 30p
Cwn_wih_1_11 wn_wih_1_11 0 30p
Rwp_wih_1_11 wp_wih_1_11 wcm 2g
Rwn_wih_1_11 wn_wih_1_11 wcm 2g
Cwp_wih_2_11 wp_wih_2_11 0 30p
Cwn_wih_2_11 wn_wih_2_11 0 30p
Rwp_wih_2_11 wp_wih_2_11 wcm 2g
Rwn_wih_2_11 wn_wih_2_11 wcm 2g
Cwp_who_11 wp_who_11 0 30p
Cwn_who_11 wn_who_11 0 30p
Rwp_who_11 wp_who_11 wcm 2g
Rwn_who_11 wn_who_11 wcm 2g
Cwp_wih_1_12 wp_wih_1_12 0 30p
Cwn_wih_1_12 wn_wih_1_12 0 30p
Rwp_wih_1_12 wp_wih_1_12 wcm 2g
Rwn_wih_1_12 wn_wih_1_12 wcm 2g
Cwp_wih_2_12 wp_wih_2_12 0 30p
Cwn_wih_2_12 wn_wih_2_12 0 30p
Rwp_wih_2_12 wp_wih_2_12 wcm 2g
Rwn_wih_2_12 wn_wih_2_12 wcm 2g
Cwp_who_12 wp_who_12 0 30p
Cwn_who_12 wn_who_12 0 30p
Rwp_who_12 wp_who_12 wcm 2g
Rwn_who_12 wn_who_12 wcm 2g
Cwp_wih_1_13 wp_wih_1_13 0 30p
Cwn_wih_1_13 wn_wih_1_13 0 30p
Rwp_wih_1_13 wp_wih_1_13 wcm 2g
Rwn_wih_1_13 wn_wih_1_13 wcm 2g
Cwp_wih_2_13 wp_wih_2_13 0 30p
Cwn_wih_2_13 wn_wih_2_13 0 30p
Rwp_wih_2_13 wp_wih_2_13 wcm 2g
Rwn_wih_2_13 wn_wih_2_13 wcm 2g
Cwp_who_13 wp_who_13 0 30p
Cwn_who_13 wn_who_13 0 30p
Rwp_who_13 wp_who_13 wcm 2g
Rwn_who_13 wn_who_13 wcm 2g
Cwp_wih_1_14 wp_wih_1_14 0 30p
Cwn_wih_1_14 wn_wih_1_14 0 30p
Rwp_wih_1_14 wp_wih_1_14 wcm 2g
Rwn_wih_1_14 wn_wih_1_14 wcm 2g
Cwp_wih_2_14 wp_wih_2_14 0 30p
Cwn_wih_2_14 wn_wih_2_14 0 30p
Rwp_wih_2_14 wp_wih_2_14 wcm 2g
Rwn_wih_2_14 wn_wih_2_14 wcm 2g
Cwp_who_14 wp_who_14 0 30p
Cwn_who_14 wn_who_14 0 30p
Rwp_who_14 wp_who_14 wcm 2g
Rwn_who_14 wn_who_14 wcm 2g
Cwp_wih_1_15 wp_wih_1_15 0 30p
Cwn_wih_1_15 wn_wih_1_15 0 30p
Rwp_wih_1_15 wp_wih_1_15 wcm 2g
Rwn_wih_1_15 wn_wih_1_15 wcm 2g
Cwp_wih_2_15 wp_wih_2_15 0 30p
Cwn_wih_2_15 wn_wih_2_15 0 30p
Rwp_wih_2_15 wp_wih_2_15 wcm 2g
Rwn_wih_2_15 wn_wih_2_15 wcm 2g
Cwp_who_15 wp_who_15 0 30p
Cwn_who_15 wn_who_15 0 30p
Rwp_who_15 wp_who_15 wcm 2g
Rwn_who_15 wn_who_15 wcm 2g
Xcm_mh0 mhp0 mhn0 vdd cmld
Xcm_xh0 xhp0 xhn0 vdd cmld
Rnd_mh0 mhp0 mhn0 20k
Rnd_xh0 xhp0 xhn0 20k
Cxhp0 xhp0 0 0.4p
Cxhn0 xhn0 0 0.4p
X_ihm_1_0 a_xp1 a_xn1 wp_wih_1_0 wn_wih_1_0 mhp0 mhn0 vdd vbsyn gsyn
X_ihx_1_0 a_xp1 a_xn1 wp_wih_1_0 wn_wih_1_0 xhp0 xhn0 vdd vbsyn gsyn
X_ihm_2_0 a_xp2 a_xn2 wp_wih_2_0 wn_wih_2_0 mhp0 mhn0 vdd vbsyn gsyn
X_ihx_2_0 a_xp2 a_xn2 wp_wih_2_0 wn_wih_2_0 xhp0 xhn0 vdd vbsyn gsyn
X_bk_0 eop eon wp_who_0 wn_who_0 xhp0 xhn0 vdd vbsyn gsyn
Xn0 xhp0 xhn0 ahp0 ahn0 vdd vbneu dneuron
Xeh0 xhp0 xhn0 mhp0 mhn0 ehp0 ehn0 vdd gm esub
Xcm_mh1 mhp1 mhn1 vdd cmld
Xcm_xh1 xhp1 xhn1 vdd cmld
Rnd_mh1 mhp1 mhn1 20k
Rnd_xh1 xhp1 xhn1 20k
Cxhp1 xhp1 0 0.4p
Cxhn1 xhn1 0 0.4p
X_ihm_1_1 a_xp1 a_xn1 wp_wih_1_1 wn_wih_1_1 mhp1 mhn1 vdd vbsyn gsyn
X_ihx_1_1 a_xp1 a_xn1 wp_wih_1_1 wn_wih_1_1 xhp1 xhn1 vdd vbsyn gsyn
X_ihm_2_1 a_xp2 a_xn2 wp_wih_2_1 wn_wih_2_1 mhp1 mhn1 vdd vbsyn gsyn
X_ihx_2_1 a_xp2 a_xn2 wp_wih_2_1 wn_wih_2_1 xhp1 xhn1 vdd vbsyn gsyn
X_bk_1 eop eon wp_who_1 wn_who_1 xhp1 xhn1 vdd vbsyn gsyn
Xn1 xhp1 xhn1 ahp1 ahn1 vdd vbneu dneuron
Xeh1 xhp1 xhn1 mhp1 mhn1 ehp1 ehn1 vdd gm esub
Xcm_mh2 mhp2 mhn2 vdd cmld
Xcm_xh2 xhp2 xhn2 vdd cmld
Rnd_mh2 mhp2 mhn2 20k
Rnd_xh2 xhp2 xhn2 20k
Cxhp2 xhp2 0 0.4p
Cxhn2 xhn2 0 0.4p
X_ihm_1_2 a_xp1 a_xn1 wp_wih_1_2 wn_wih_1_2 mhp2 mhn2 vdd vbsyn gsyn
X_ihx_1_2 a_xp1 a_xn1 wp_wih_1_2 wn_wih_1_2 xhp2 xhn2 vdd vbsyn gsyn
X_ihm_2_2 a_xp2 a_xn2 wp_wih_2_2 wn_wih_2_2 mhp2 mhn2 vdd vbsyn gsyn
X_ihx_2_2 a_xp2 a_xn2 wp_wih_2_2 wn_wih_2_2 xhp2 xhn2 vdd vbsyn gsyn
X_bk_2 eop eon wp_who_2 wn_who_2 xhp2 xhn2 vdd vbsyn gsyn
Xn2 xhp2 xhn2 ahp2 ahn2 vdd vbneu dneuron
Xeh2 xhp2 xhn2 mhp2 mhn2 ehp2 ehn2 vdd gm esub
Xcm_mh3 mhp3 mhn3 vdd cmld
Xcm_xh3 xhp3 xhn3 vdd cmld
Rnd_mh3 mhp3 mhn3 20k
Rnd_xh3 xhp3 xhn3 20k
Cxhp3 xhp3 0 0.4p
Cxhn3 xhn3 0 0.4p
X_ihm_1_3 a_xp1 a_xn1 wp_wih_1_3 wn_wih_1_3 mhp3 mhn3 vdd vbsyn gsyn
X_ihx_1_3 a_xp1 a_xn1 wp_wih_1_3 wn_wih_1_3 xhp3 xhn3 vdd vbsyn gsyn
X_ihm_2_3 a_xp2 a_xn2 wp_wih_2_3 wn_wih_2_3 mhp3 mhn3 vdd vbsyn gsyn
X_ihx_2_3 a_xp2 a_xn2 wp_wih_2_3 wn_wih_2_3 xhp3 xhn3 vdd vbsyn gsyn
X_bk_3 eop eon wp_who_3 wn_who_3 xhp3 xhn3 vdd vbsyn gsyn
Xn3 xhp3 xhn3 ahp3 ahn3 vdd vbneu dneuron
Xeh3 xhp3 xhn3 mhp3 mhn3 ehp3 ehn3 vdd gm esub
Xcm_mh4 mhp4 mhn4 vdd cmld
Xcm_xh4 xhp4 xhn4 vdd cmld
Rnd_mh4 mhp4 mhn4 20k
Rnd_xh4 xhp4 xhn4 20k
Cxhp4 xhp4 0 0.4p
Cxhn4 xhn4 0 0.4p
X_ihm_1_4 a_xp1 a_xn1 wp_wih_1_4 wn_wih_1_4 mhp4 mhn4 vdd vbsyn gsyn
X_ihx_1_4 a_xp1 a_xn1 wp_wih_1_4 wn_wih_1_4 xhp4 xhn4 vdd vbsyn gsyn
X_ihm_2_4 a_xp2 a_xn2 wp_wih_2_4 wn_wih_2_4 mhp4 mhn4 vdd vbsyn gsyn
X_ihx_2_4 a_xp2 a_xn2 wp_wih_2_4 wn_wih_2_4 xhp4 xhn4 vdd vbsyn gsyn
X_bk_4 eop eon wp_who_4 wn_who_4 xhp4 xhn4 vdd vbsyn gsyn
Xn4 xhp4 xhn4 ahp4 ahn4 vdd vbneu dneuron
Xeh4 xhp4 xhn4 mhp4 mhn4 ehp4 ehn4 vdd gm esub
Xcm_mh5 mhp5 mhn5 vdd cmld
Xcm_xh5 xhp5 xhn5 vdd cmld
Rnd_mh5 mhp5 mhn5 20k
Rnd_xh5 xhp5 xhn5 20k
Cxhp5 xhp5 0 0.4p
Cxhn5 xhn5 0 0.4p
X_ihm_1_5 a_xp1 a_xn1 wp_wih_1_5 wn_wih_1_5 mhp5 mhn5 vdd vbsyn gsyn
X_ihx_1_5 a_xp1 a_xn1 wp_wih_1_5 wn_wih_1_5 xhp5 xhn5 vdd vbsyn gsyn
X_ihm_2_5 a_xp2 a_xn2 wp_wih_2_5 wn_wih_2_5 mhp5 mhn5 vdd vbsyn gsyn
X_ihx_2_5 a_xp2 a_xn2 wp_wih_2_5 wn_wih_2_5 xhp5 xhn5 vdd vbsyn gsyn
X_bk_5 eop eon wp_who_5 wn_who_5 xhp5 xhn5 vdd vbsyn gsyn
Xn5 xhp5 xhn5 ahp5 ahn5 vdd vbneu dneuron
Xeh5 xhp5 xhn5 mhp5 mhn5 ehp5 ehn5 vdd gm esub
Xcm_mh6 mhp6 mhn6 vdd cmld
Xcm_xh6 xhp6 xhn6 vdd cmld
Rnd_mh6 mhp6 mhn6 20k
Rnd_xh6 xhp6 xhn6 20k
Cxhp6 xhp6 0 0.4p
Cxhn6 xhn6 0 0.4p
X_ihm_1_6 a_xp1 a_xn1 wp_wih_1_6 wn_wih_1_6 mhp6 mhn6 vdd vbsyn gsyn
X_ihx_1_6 a_xp1 a_xn1 wp_wih_1_6 wn_wih_1_6 xhp6 xhn6 vdd vbsyn gsyn
X_ihm_2_6 a_xp2 a_xn2 wp_wih_2_6 wn_wih_2_6 mhp6 mhn6 vdd vbsyn gsyn
X_ihx_2_6 a_xp2 a_xn2 wp_wih_2_6 wn_wih_2_6 xhp6 xhn6 vdd vbsyn gsyn
X_bk_6 eop eon wp_who_6 wn_who_6 xhp6 xhn6 vdd vbsyn gsyn
Xn6 xhp6 xhn6 ahp6 ahn6 vdd vbneu dneuron
Xeh6 xhp6 xhn6 mhp6 mhn6 ehp6 ehn6 vdd gm esub
Xcm_mh7 mhp7 mhn7 vdd cmld
Xcm_xh7 xhp7 xhn7 vdd cmld
Rnd_mh7 mhp7 mhn7 20k
Rnd_xh7 xhp7 xhn7 20k
Cxhp7 xhp7 0 0.4p
Cxhn7 xhn7 0 0.4p
X_ihm_1_7 a_xp1 a_xn1 wp_wih_1_7 wn_wih_1_7 mhp7 mhn7 vdd vbsyn gsyn
X_ihx_1_7 a_xp1 a_xn1 wp_wih_1_7 wn_wih_1_7 xhp7 xhn7 vdd vbsyn gsyn
X_ihm_2_7 a_xp2 a_xn2 wp_wih_2_7 wn_wih_2_7 mhp7 mhn7 vdd vbsyn gsyn
X_ihx_2_7 a_xp2 a_xn2 wp_wih_2_7 wn_wih_2_7 xhp7 xhn7 vdd vbsyn gsyn
X_bk_7 eop eon wp_who_7 wn_who_7 xhp7 xhn7 vdd vbsyn gsyn
Xn7 xhp7 xhn7 ahp7 ahn7 vdd vbneu dneuron
Xeh7 xhp7 xhn7 mhp7 mhn7 ehp7 ehn7 vdd gm esub
Xcm_mh8 mhp8 mhn8 vdd cmld
Xcm_xh8 xhp8 xhn8 vdd cmld
Rnd_mh8 mhp8 mhn8 20k
Rnd_xh8 xhp8 xhn8 20k
Cxhp8 xhp8 0 0.4p
Cxhn8 xhn8 0 0.4p
X_ihm_1_8 a_xp1 a_xn1 wp_wih_1_8 wn_wih_1_8 mhp8 mhn8 vdd vbsyn gsyn
X_ihx_1_8 a_xp1 a_xn1 wp_wih_1_8 wn_wih_1_8 xhp8 xhn8 vdd vbsyn gsyn
X_ihm_2_8 a_xp2 a_xn2 wp_wih_2_8 wn_wih_2_8 mhp8 mhn8 vdd vbsyn gsyn
X_ihx_2_8 a_xp2 a_xn2 wp_wih_2_8 wn_wih_2_8 xhp8 xhn8 vdd vbsyn gsyn
X_bk_8 eop eon wp_who_8 wn_who_8 xhp8 xhn8 vdd vbsyn gsyn
Xn8 xhp8 xhn8 ahp8 ahn8 vdd vbneu dneuron
Xeh8 xhp8 xhn8 mhp8 mhn8 ehp8 ehn8 vdd gm esub
Xcm_mh9 mhp9 mhn9 vdd cmld
Xcm_xh9 xhp9 xhn9 vdd cmld
Rnd_mh9 mhp9 mhn9 20k
Rnd_xh9 xhp9 xhn9 20k
Cxhp9 xhp9 0 0.4p
Cxhn9 xhn9 0 0.4p
X_ihm_1_9 a_xp1 a_xn1 wp_wih_1_9 wn_wih_1_9 mhp9 mhn9 vdd vbsyn gsyn
X_ihx_1_9 a_xp1 a_xn1 wp_wih_1_9 wn_wih_1_9 xhp9 xhn9 vdd vbsyn gsyn
X_ihm_2_9 a_xp2 a_xn2 wp_wih_2_9 wn_wih_2_9 mhp9 mhn9 vdd vbsyn gsyn
X_ihx_2_9 a_xp2 a_xn2 wp_wih_2_9 wn_wih_2_9 xhp9 xhn9 vdd vbsyn gsyn
X_bk_9 eop eon wp_who_9 wn_who_9 xhp9 xhn9 vdd vbsyn gsyn
Xn9 xhp9 xhn9 ahp9 ahn9 vdd vbneu dneuron
Xeh9 xhp9 xhn9 mhp9 mhn9 ehp9 ehn9 vdd gm esub
Xcm_mh10 mhp10 mhn10 vdd cmld
Xcm_xh10 xhp10 xhn10 vdd cmld
Rnd_mh10 mhp10 mhn10 20k
Rnd_xh10 xhp10 xhn10 20k
Cxhp10 xhp10 0 0.4p
Cxhn10 xhn10 0 0.4p
X_ihm_1_10 a_xp1 a_xn1 wp_wih_1_10 wn_wih_1_10 mhp10 mhn10 vdd vbsyn gsyn
X_ihx_1_10 a_xp1 a_xn1 wp_wih_1_10 wn_wih_1_10 xhp10 xhn10 vdd vbsyn gsyn
X_ihm_2_10 a_xp2 a_xn2 wp_wih_2_10 wn_wih_2_10 mhp10 mhn10 vdd vbsyn gsyn
X_ihx_2_10 a_xp2 a_xn2 wp_wih_2_10 wn_wih_2_10 xhp10 xhn10 vdd vbsyn gsyn
X_bk_10 eop eon wp_who_10 wn_who_10 xhp10 xhn10 vdd vbsyn gsyn
Xn10 xhp10 xhn10 ahp10 ahn10 vdd vbneu dneuron
Xeh10 xhp10 xhn10 mhp10 mhn10 ehp10 ehn10 vdd gm esub
Xcm_mh11 mhp11 mhn11 vdd cmld
Xcm_xh11 xhp11 xhn11 vdd cmld
Rnd_mh11 mhp11 mhn11 20k
Rnd_xh11 xhp11 xhn11 20k
Cxhp11 xhp11 0 0.4p
Cxhn11 xhn11 0 0.4p
X_ihm_1_11 a_xp1 a_xn1 wp_wih_1_11 wn_wih_1_11 mhp11 mhn11 vdd vbsyn gsyn
X_ihx_1_11 a_xp1 a_xn1 wp_wih_1_11 wn_wih_1_11 xhp11 xhn11 vdd vbsyn gsyn
X_ihm_2_11 a_xp2 a_xn2 wp_wih_2_11 wn_wih_2_11 mhp11 mhn11 vdd vbsyn gsyn
X_ihx_2_11 a_xp2 a_xn2 wp_wih_2_11 wn_wih_2_11 xhp11 xhn11 vdd vbsyn gsyn
X_bk_11 eop eon wp_who_11 wn_who_11 xhp11 xhn11 vdd vbsyn gsyn
Xn11 xhp11 xhn11 ahp11 ahn11 vdd vbneu dneuron
Xeh11 xhp11 xhn11 mhp11 mhn11 ehp11 ehn11 vdd gm esub
Xcm_mh12 mhp12 mhn12 vdd cmld
Xcm_xh12 xhp12 xhn12 vdd cmld
Rnd_mh12 mhp12 mhn12 20k
Rnd_xh12 xhp12 xhn12 20k
Cxhp12 xhp12 0 0.4p
Cxhn12 xhn12 0 0.4p
X_ihm_1_12 a_xp1 a_xn1 wp_wih_1_12 wn_wih_1_12 mhp12 mhn12 vdd vbsyn gsyn
X_ihx_1_12 a_xp1 a_xn1 wp_wih_1_12 wn_wih_1_12 xhp12 xhn12 vdd vbsyn gsyn
X_ihm_2_12 a_xp2 a_xn2 wp_wih_2_12 wn_wih_2_12 mhp12 mhn12 vdd vbsyn gsyn
X_ihx_2_12 a_xp2 a_xn2 wp_wih_2_12 wn_wih_2_12 xhp12 xhn12 vdd vbsyn gsyn
X_bk_12 eop eon wp_who_12 wn_who_12 xhp12 xhn12 vdd vbsyn gsyn
Xn12 xhp12 xhn12 ahp12 ahn12 vdd vbneu dneuron
Xeh12 xhp12 xhn12 mhp12 mhn12 ehp12 ehn12 vdd gm esub
Xcm_mh13 mhp13 mhn13 vdd cmld
Xcm_xh13 xhp13 xhn13 vdd cmld
Rnd_mh13 mhp13 mhn13 20k
Rnd_xh13 xhp13 xhn13 20k
Cxhp13 xhp13 0 0.4p
Cxhn13 xhn13 0 0.4p
X_ihm_1_13 a_xp1 a_xn1 wp_wih_1_13 wn_wih_1_13 mhp13 mhn13 vdd vbsyn gsyn
X_ihx_1_13 a_xp1 a_xn1 wp_wih_1_13 wn_wih_1_13 xhp13 xhn13 vdd vbsyn gsyn
X_ihm_2_13 a_xp2 a_xn2 wp_wih_2_13 wn_wih_2_13 mhp13 mhn13 vdd vbsyn gsyn
X_ihx_2_13 a_xp2 a_xn2 wp_wih_2_13 wn_wih_2_13 xhp13 xhn13 vdd vbsyn gsyn
X_bk_13 eop eon wp_who_13 wn_who_13 xhp13 xhn13 vdd vbsyn gsyn
Xn13 xhp13 xhn13 ahp13 ahn13 vdd vbneu dneuron
Xeh13 xhp13 xhn13 mhp13 mhn13 ehp13 ehn13 vdd gm esub
Xcm_mh14 mhp14 mhn14 vdd cmld
Xcm_xh14 xhp14 xhn14 vdd cmld
Rnd_mh14 mhp14 mhn14 20k
Rnd_xh14 xhp14 xhn14 20k
Cxhp14 xhp14 0 0.4p
Cxhn14 xhn14 0 0.4p
X_ihm_1_14 a_xp1 a_xn1 wp_wih_1_14 wn_wih_1_14 mhp14 mhn14 vdd vbsyn gsyn
X_ihx_1_14 a_xp1 a_xn1 wp_wih_1_14 wn_wih_1_14 xhp14 xhn14 vdd vbsyn gsyn
X_ihm_2_14 a_xp2 a_xn2 wp_wih_2_14 wn_wih_2_14 mhp14 mhn14 vdd vbsyn gsyn
X_ihx_2_14 a_xp2 a_xn2 wp_wih_2_14 wn_wih_2_14 xhp14 xhn14 vdd vbsyn gsyn
X_bk_14 eop eon wp_who_14 wn_who_14 xhp14 xhn14 vdd vbsyn gsyn
Xn14 xhp14 xhn14 ahp14 ahn14 vdd vbneu dneuron
Xeh14 xhp14 xhn14 mhp14 mhn14 ehp14 ehn14 vdd gm esub
Xcm_mh15 mhp15 mhn15 vdd cmld
Xcm_xh15 xhp15 xhn15 vdd cmld
Rnd_mh15 mhp15 mhn15 20k
Rnd_xh15 xhp15 xhn15 20k
Cxhp15 xhp15 0 0.4p
Cxhn15 xhn15 0 0.4p
X_ihm_1_15 a_xp1 a_xn1 wp_wih_1_15 wn_wih_1_15 mhp15 mhn15 vdd vbsyn gsyn
X_ihx_1_15 a_xp1 a_xn1 wp_wih_1_15 wn_wih_1_15 xhp15 xhn15 vdd vbsyn gsyn
X_ihm_2_15 a_xp2 a_xn2 wp_wih_2_15 wn_wih_2_15 mhp15 mhn15 vdd vbsyn gsyn
X_ihx_2_15 a_xp2 a_xn2 wp_wih_2_15 wn_wih_2_15 xhp15 xhn15 vdd vbsyn gsyn
X_bk_15 eop eon wp_who_15 wn_who_15 xhp15 xhn15 vdd vbsyn gsyn
Xn15 xhp15 xhn15 ahp15 ahn15 vdd vbneu dneuron
Xeh15 xhp15 xhn15 mhp15 mhn15 ehp15 ehn15 vdd gm esub
Xcm_mo mop mon vdd cmld
Rnd_mo mop mon 20k
X_ho_0 ahp0 ahn0 wp_who_0 wn_who_0 mop mon vdd vbsyn gsyn
X_ho_1 ahp1 ahn1 wp_who_1 wn_who_1 mop mon vdd vbsyn gsyn
X_ho_2 ahp2 ahn2 wp_who_2 wn_who_2 mop mon vdd vbsyn gsyn
X_ho_3 ahp3 ahn3 wp_who_3 wn_who_3 mop mon vdd vbsyn gsyn
X_ho_4 ahp4 ahn4 wp_who_4 wn_who_4 mop mon vdd vbsyn gsyn
X_ho_5 ahp5 ahn5 wp_who_5 wn_who_5 mop mon vdd vbsyn gsyn
X_ho_6 ahp6 ahn6 wp_who_6 wn_who_6 mop mon vdd vbsyn gsyn
X_ho_7 ahp7 ahn7 wp_who_7 wn_who_7 mop mon vdd vbsyn gsyn
X_ho_8 ahp8 ahn8 wp_who_8 wn_who_8 mop mon vdd vbsyn gsyn
X_ho_9 ahp9 ahn9 wp_who_9 wn_who_9 mop mon vdd vbsyn gsyn
X_ho_10 ahp10 ahn10 wp_who_10 wn_who_10 mop mon vdd vbsyn gsyn
X_ho_11 ahp11 ahn11 wp_who_11 wn_who_11 mop mon vdd vbsyn gsyn
X_ho_12 ahp12 ahn12 wp_who_12 wn_who_12 mop mon vdd vbsyn gsyn
X_ho_13 ahp13 ahn13 wp_who_13 wn_who_13 mop mon vdd vbsyn gsyn
X_ho_14 ahp14 ahn14 wp_who_14 wn_who_14 mop mon vdd vbsyn gsyn
X_ho_15 ahp15 ahn15 wp_who_15 wn_who_15 mop mon vdd vbsyn gsyn
Xeo xop xon mop mon eop eon vdd gm esub
Xcm_mo2 mop2 mon2 vdd cmld
Rnd_mo2 mop2 mon2 20k
X_ho2_0 ahp0 ahn0 wp_who_0 wn_who_0 mop2 mon2 vdd vbsyn gsyn
X_ho2_1 ahp1 ahn1 wp_who_1 wn_who_1 mop2 mon2 vdd vbsyn gsyn
X_ho2_2 ahp2 ahn2 wp_who_2 wn_who_2 mop2 mon2 vdd vbsyn gsyn
X_ho2_3 ahp3 ahn3 wp_who_3 wn_who_3 mop2 mon2 vdd vbsyn gsyn
X_ho2_4 ahp4 ahn4 wp_who_4 wn_who_4 mop2 mon2 vdd vbsyn gsyn
X_ho2_5 ahp5 ahn5 wp_who_5 wn_who_5 mop2 mon2 vdd vbsyn gsyn
X_ho2_6 ahp6 ahn6 wp_who_6 wn_who_6 mop2 mon2 vdd vbsyn gsyn
X_ho2_7 ahp7 ahn7 wp_who_7 wn_who_7 mop2 mon2 vdd vbsyn gsyn
X_ho2_8 ahp8 ahn8 wp_who_8 wn_who_8 mop2 mon2 vdd vbsyn gsyn
X_ho2_9 ahp9 ahn9 wp_who_9 wn_who_9 mop2 mon2 vdd vbsyn gsyn
X_ho2_10 ahp10 ahn10 wp_who_10 wn_who_10 mop2 mon2 vdd vbsyn gsyn
X_ho2_11 ahp11 ahn11 wp_who_11 wn_who_11 mop2 mon2 vdd vbsyn gsyn
X_ho2_12 ahp12 ahn12 wp_who_12 wn_who_12 mop2 mon2 vdd vbsyn gsyn
X_ho2_13 ahp13 ahn13 wp_who_13 wn_who_13 mop2 mon2 vdd vbsyn gsyn
X_ho2_14 ahp14 ahn14 wp_who_14 wn_who_14 mop2 mon2 vdd vbsyn gsyn
X_ho2_15 ahp15 ahn15 wp_who_15 wn_who_15 mop2 mon2 vdd vbsyn gsyn
Xlih_1_0 ehp0 ehn0 a_xp1 a_xn1 wp_wih_1_0 wn_wih_1_0 vdd gblh gprod
Xlih_2_0 ehp0 ehn0 a_xp2 a_xn2 wp_wih_2_0 wn_wih_2_0 vdd gblh gprod
Xlho_0 eon eop ahp0 ahn0 wp_who_0 wn_who_0 vdd gblo gprod
Xlih_1_1 ehp1 ehn1 a_xp1 a_xn1 wp_wih_1_1 wn_wih_1_1 vdd gblh gprod
Xlih_2_1 ehp1 ehn1 a_xp2 a_xn2 wp_wih_2_1 wn_wih_2_1 vdd gblh gprod
Xlho_1 eon eop ahp1 ahn1 wp_who_1 wn_who_1 vdd gblo gprod
Xlih_1_2 ehp2 ehn2 a_xp1 a_xn1 wp_wih_1_2 wn_wih_1_2 vdd gblh gprod
Xlih_2_2 ehp2 ehn2 a_xp2 a_xn2 wp_wih_2_2 wn_wih_2_2 vdd gblh gprod
Xlho_2 eon eop ahp2 ahn2 wp_who_2 wn_who_2 vdd gblo gprod
Xlih_1_3 ehp3 ehn3 a_xp1 a_xn1 wp_wih_1_3 wn_wih_1_3 vdd gblh gprod
Xlih_2_3 ehp3 ehn3 a_xp2 a_xn2 wp_wih_2_3 wn_wih_2_3 vdd gblh gprod
Xlho_3 eon eop ahp3 ahn3 wp_who_3 wn_who_3 vdd gblo gprod
Xlih_1_4 ehp4 ehn4 a_xp1 a_xn1 wp_wih_1_4 wn_wih_1_4 vdd gblh gprod
Xlih_2_4 ehp4 ehn4 a_xp2 a_xn2 wp_wih_2_4 wn_wih_2_4 vdd gblh gprod
Xlho_4 eon eop ahp4 ahn4 wp_who_4 wn_who_4 vdd gblo gprod
Xlih_1_5 ehp5 ehn5 a_xp1 a_xn1 wp_wih_1_5 wn_wih_1_5 vdd gblh gprod
Xlih_2_5 ehp5 ehn5 a_xp2 a_xn2 wp_wih_2_5 wn_wih_2_5 vdd gblh gprod
Xlho_5 eon eop ahp5 ahn5 wp_who_5 wn_who_5 vdd gblo gprod
Xlih_1_6 ehp6 ehn6 a_xp1 a_xn1 wp_wih_1_6 wn_wih_1_6 vdd gblh gprod
Xlih_2_6 ehp6 ehn6 a_xp2 a_xn2 wp_wih_2_6 wn_wih_2_6 vdd gblh gprod
Xlho_6 eon eop ahp6 ahn6 wp_who_6 wn_who_6 vdd gblo gprod
Xlih_1_7 ehp7 ehn7 a_xp1 a_xn1 wp_wih_1_7 wn_wih_1_7 vdd gblh gprod
Xlih_2_7 ehp7 ehn7 a_xp2 a_xn2 wp_wih_2_7 wn_wih_2_7 vdd gblh gprod
Xlho_7 eon eop ahp7 ahn7 wp_who_7 wn_who_7 vdd gblo gprod
Xlih_1_8 ehp8 ehn8 a_xp1 a_xn1 wp_wih_1_8 wn_wih_1_8 vdd gblh gprod
Xlih_2_8 ehp8 ehn8 a_xp2 a_xn2 wp_wih_2_8 wn_wih_2_8 vdd gblh gprod
Xlho_8 eon eop ahp8 ahn8 wp_who_8 wn_who_8 vdd gblo gprod
Xlih_1_9 ehp9 ehn9 a_xp1 a_xn1 wp_wih_1_9 wn_wih_1_9 vdd gblh gprod
Xlih_2_9 ehp9 ehn9 a_xp2 a_xn2 wp_wih_2_9 wn_wih_2_9 vdd gblh gprod
Xlho_9 eon eop ahp9 ahn9 wp_who_9 wn_who_9 vdd gblo gprod
Xlih_1_10 ehp10 ehn10 a_xp1 a_xn1 wp_wih_1_10 wn_wih_1_10 vdd gblh gprod
Xlih_2_10 ehp10 ehn10 a_xp2 a_xn2 wp_wih_2_10 wn_wih_2_10 vdd gblh gprod
Xlho_10 eon eop ahp10 ahn10 wp_who_10 wn_who_10 vdd gblo gprod
Xlih_1_11 ehp11 ehn11 a_xp1 a_xn1 wp_wih_1_11 wn_wih_1_11 vdd gblh gprod
Xlih_2_11 ehp11 ehn11 a_xp2 a_xn2 wp_wih_2_11 wn_wih_2_11 vdd gblh gprod
Xlho_11 eon eop ahp11 ahn11 wp_who_11 wn_who_11 vdd gblo gprod
Xlih_1_12 ehp12 ehn12 a_xp1 a_xn1 wp_wih_1_12 wn_wih_1_12 vdd gblh gprod
Xlih_2_12 ehp12 ehn12 a_xp2 a_xn2 wp_wih_2_12 wn_wih_2_12 vdd gblh gprod
Xlho_12 eon eop ahp12 ahn12 wp_who_12 wn_who_12 vdd gblo gprod
Xlih_1_13 ehp13 ehn13 a_xp1 a_xn1 wp_wih_1_13 wn_wih_1_13 vdd gblh gprod
Xlih_2_13 ehp13 ehn13 a_xp2 a_xn2 wp_wih_2_13 wn_wih_2_13 vdd gblh gprod
Xlho_13 eon eop ahp13 ahn13 wp_who_13 wn_who_13 vdd gblo gprod
Xlih_1_14 ehp14 ehn14 a_xp1 a_xn1 wp_wih_1_14 wn_wih_1_14 vdd gblh gprod
Xlih_2_14 ehp14 ehn14 a_xp2 a_xn2 wp_wih_2_14 wn_wih_2_14 vdd gblh gprod
Xlho_14 eon eop ahp14 ahn14 wp_who_14 wn_who_14 vdd gblo gprod
Xlih_1_15 ehp15 ehn15 a_xp1 a_xn1 wp_wih_1_15 wn_wih_1_15 vdd gblh gprod
Xlih_2_15 ehp15 ehn15 a_xp2 a_xn2 wp_wih_2_15 wn_wih_2_15 vdd gblh gprod
Xlho_15 eon eop ahp15 ahn15 wp_who_15 wn_who_15 vdd gblo gprod
.ic v(wp_wih_1_0)=0.5189 v(wn_wih_1_0)=0.4811
.ic v(wp_wih_2_0)=0.4802 v(wn_wih_2_0)=0.5198
.ic v(wp_who_0)=0.5961 v(wn_who_0)=0.4039
.ic v(wp_wih_1_1)=0.5157 v(wn_wih_1_1)=0.4843
.ic v(wp_wih_2_1)=0.4196 v(wn_wih_2_1)=0.5804
.ic v(wp_who_1)=0.5542 v(wn_who_1)=0.4458
.ic v(wp_wih_1_2)=0.6956 v(wn_wih_1_2)=0.3044
.ic v(wp_wih_2_2)=0.6421 v(wn_wih_2_2)=0.3579
.ic v(wp_who_2)=0.3944 v(wn_who_2)=0.6056
.ic v(wp_wih_1_3)=0.3102 v(wn_wih_1_3)=0.6898
.ic v(wp_wih_2_3)=0.4065 v(wn_wih_2_3)=0.5935
.ic v(wp_who_3)=0.5062 v(wn_who_3)=0.4938
.ic v(wp_wih_1_4)=0.3000 v(wn_wih_1_4)=0.8488
.ic v(wp_wih_2_4)=0.4672 v(wn_wih_2_4)=0.5328
.ic v(wp_who_4)=0.3131 v(wn_who_4)=0.6869
.ic v(wp_wih_1_5)=0.3902 v(wn_wih_1_5)=0.6098
.ic v(wp_wih_2_5)=0.4184 v(wn_wih_2_5)=0.5816
.ic v(wp_who_5)=0.4526 v(wn_who_5)=0.5474
.ic v(wp_wih_1_6)=0.5617 v(wn_wih_1_6)=0.4383
.ic v(wp_wih_2_6)=0.6564 v(wn_wih_2_6)=0.3436
.ic v(wp_who_6)=0.4807 v(wn_who_6)=0.5193
.ic v(wp_wih_1_7)=0.7050 v(wn_wih_1_7)=0.3000
.ic v(wp_wih_2_7)=0.4002 v(wn_wih_2_7)=0.5998
.ic v(wp_who_7)=0.5527 v(wn_who_7)=0.4473
.ic v(wp_wih_1_8)=0.6355 v(wn_wih_1_8)=0.3645
.ic v(wp_wih_2_8)=0.5141 v(wn_wih_2_8)=0.4859
.ic v(wp_who_8)=0.3885 v(wn_who_8)=0.6115
.ic v(wp_wih_1_9)=0.3617 v(wn_wih_1_9)=0.6383
.ic v(wp_wih_2_9)=0.4313 v(wn_wih_2_9)=0.5687
.ic v(wp_who_9)=0.5330 v(wn_who_9)=0.4670
.ic v(wp_wih_1_10)=0.3486 v(wn_wih_1_10)=0.6514
.ic v(wp_wih_2_10)=0.4686 v(wn_wih_2_10)=0.5314
.ic v(wp_who_10)=0.4761 v(wn_who_10)=0.5239
.ic v(wp_wih_1_11)=0.5811 v(wn_wih_1_11)=0.4189
.ic v(wp_wih_2_11)=0.5322 v(wn_wih_2_11)=0.4678
.ic v(wp_who_11)=0.5533 v(wn_who_11)=0.4467
.ic v(wp_wih_1_12)=0.4019 v(wn_wih_1_12)=0.5981
.ic v(wp_wih_2_12)=0.4806 v(wn_wih_2_12)=0.5194
.ic v(wp_who_12)=0.6176 v(wn_who_12)=0.3824
.ic v(wp_wih_1_13)=0.7240 v(wn_wih_1_13)=0.3000
.ic v(wp_wih_2_13)=0.3111 v(wn_wih_2_13)=0.6889
.ic v(wp_who_13)=0.7271 v(wn_who_13)=0.3000
.ic v(wp_wih_1_14)=0.7019 v(wn_wih_1_14)=0.3000
.ic v(wp_wih_2_14)=0.6172 v(wn_wih_2_14)=0.3828
.ic v(wp_who_14)=0.5397 v(wn_who_14)=0.4603
.ic v(wp_wih_1_15)=0.4529 v(wn_wih_1_15)=0.5471
.ic v(wp_wih_2_15)=0.7187 v(wn_wih_2_15)=0.3000
.ic v(wp_who_15)=0.7940 v(wn_who_15)=0.3000
.options cshunt=1e-14 gmin=1e-10 reltol=2e-3
.tran 2n 480000n uic
.control
run
wrdata pcL2dcd.dat v(mop) v(mon) v(mop2) v(mon2)
.endc
.end
