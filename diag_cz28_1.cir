diag
.model NNR NMOS (LEVEL=1 VTO=0.2 KP=120u LAMBDA=0.02 GAMMA=0 PHI=0.7)
.model PNR PMOS (LEVEL=1 VTO=-0.2 KP=40u LAMBDA=0.02 GAMMA=0 PHI=0.7)
.subckt gsyn inp inn wp wn outp outn vdd vbn
Mtail nt vbn 0 0 NNR W=400u L=100u
M5 na wp nt 0 NNR W=200u L=100u
M6 nb wn nt 0 NNR W=200u L=100u
M1 outp inp na 0 NNR W=200u L=100u
M2 outn inn na 0 NNR W=200u L=100u
M3 outn inp nb 0 NNR W=200u L=100u
M4 outp inn nb 0 NNR W=200u L=100u
.ends
.subckt cmld p n vdd
Rcs1 p cmx 300k
Rcs2 n cmx 300k
MLp p cmx vdd vdd PNR W=1000u L=100u
MLn n cmx vdd vdd PNR W=1000u L=100u
.ends
.subckt dneuron up un ap an vdd vbn
M1 an up tn 0 NNR W=200u L=100u
M2 ap un tn 0 NNR W=200u L=100u
Mt tn vbn 0 0 NNR W=200u L=100u
Xcm ap an vdd cmld
.ends
Vdd vdd 0 1.0
Vbsyn vbsyn 0 0.45
Vbneu vbneu 0 0.35
Vxp0 a_xp0 0 0.5
Vxn0 a_xn0 0 0.5
Vxp1 a_xp1 0 0.5
Vxn1 a_xn1 0 0.5
Vxp2 a_xp2 0 0.5
Vxn2 a_xn2 0 0.5
Vxp3 a_xp3 0 0.5
Vxn3 a_xn3 0 0.5
Vxp4 a_xp4 0 0.5
Vxn4 a_xn4 0 0.5
Vxp5 a_xp5 0 0.5
Vxn5 a_xn5 0 0.5
Vxp6 a_xp6 0 0.5
Vxn6 a_xn6 0 0.5
Vxp7 a_xp7 0 0.5
Vxn7 a_xn7 0 0.5
Vxp8 a_xp8 0 0.5
Vxn8 a_xn8 0 0.5
Vxp9 a_xp9 0 0.5
Vxn9 a_xn9 0 0.5
Vxp10 a_xp10 0 0.5
Vxn10 a_xn10 0 0.5
Vxp11 a_xp11 0 0.5
Vxn11 a_xn11 0 0.5
Vxp12 a_xp12 0 0.5
Vxn12 a_xn12 0 0.5
Vxp13 a_xp13 0 0.5
Vxn13 a_xn13 0 0.5
Vxp14 a_xp14 0 0.5
Vxn14 a_xn14 0 0.5
Vxp15 a_xp15 0 0.5
Vxn15 a_xn15 0 0.5
Vwp_ih_0_0 wp_ih_0_0 0 0.3
Vwn_ih_0_0 wn_ih_0_0 0 0.8447073951757524
Vwp_ih_1_0 wp_ih_1_0 0 0.3
Vwn_ih_1_0 wn_ih_1_0 0 0.7778738662453208
Vwp_ih_2_0 wp_ih_2_0 0 0.44686509781440487
Vwn_ih_2_0 wn_ih_2_0 0 0.5531349021855951
Vwp_ih_3_0 wp_ih_3_0 0 0.4198584147837914
Vwn_ih_3_0 wn_ih_3_0 0 0.5801415852162086
Vwp_ih_4_0 wp_ih_4_0 0 0.5813190225907194
Vwn_ih_4_0 wn_ih_4_0 0 0.41868097740928056
Vwp_ih_5_0 wp_ih_5_0 0 0.6069539677573622
Vwn_ih_5_0 wn_ih_5_0 0 0.3930460322426378
Vwp_ih_6_0 wp_ih_6_0 0 0.5001990400944885
Vwn_ih_6_0 wn_ih_6_0 0 0.49980095990551154
Vwp_ih_7_0 wp_ih_7_0 0 0.7389730680263853
Vwn_ih_7_0 wn_ih_7_0 0 0.3
Vwp_ih_8_0 wp_ih_8_0 0 0.7112655378198506
Vwn_ih_8_0 wn_ih_8_0 0 0.3
Vwp_ih_9_0 wp_ih_9_0 0 0.432728108703917
Vwn_ih_9_0 wn_ih_9_0 0 0.567271891296083
Vwp_ih_10_0 wp_ih_10_0 0 0.6265461335836492
Vwn_ih_10_0 wn_ih_10_0 0 0.3734538664163508
Vwp_ih_11_0 wp_ih_11_0 0 0.5519444633231242
Vwn_ih_11_0 wn_ih_11_0 0 0.44805553667687575
Vwp_ih_12_0 wp_ih_12_0 0 0.41101094120143006
Vwn_ih_12_0 wn_ih_12_0 0 0.5889890587985699
Vwp_ih_13_0 wp_ih_13_0 0 0.401778496804319
Vwn_ih_13_0 wn_ih_13_0 0 0.598221503195681
Vwp_ih_14_0 wp_ih_14_0 0 0.4412262826496415
Vwn_ih_14_0 wn_ih_14_0 0 0.5587737173503585
Vwp_ih_15_0 wp_ih_15_0 0 0.46530950937561966
Vwn_ih_15_0 wn_ih_15_0 0 0.5346904906243803
Vwp_ho_0_0 wp_ho_0_0 0 0.40271652098117017
Vwn_ho_0_0 wn_ho_0_0 0 0.5972834790188298
Vwp_ho_0_1 wp_ho_0_1 0 0.4032165241059666
Vwn_ho_0_1 wn_ho_0_1 0 0.5967834758940335
Vwp_ho_0_2 wp_ho_0_2 0 0.38979559817456305
Vwn_ho_0_2 wn_ho_0_2 0 0.6102044018254369
Vwp_ho_0_3 wp_ho_0_3 0 0.5649021610344259
Vwn_ho_0_3 wn_ho_0_3 0 0.4350978389655741
Vwp_ho_0_4 wp_ho_0_4 0 0.47981848043534353
Vwn_ho_0_4 wn_ho_0_4 0 0.5201815195646565
Vwp_ih_0_1 wp_ih_0_1 0 0.7343623539728423
Vwn_ih_0_1 wn_ih_0_1 0 0.3
Vwp_ih_1_1 wp_ih_1_1 0 0.7059237989522592
Vwn_ih_1_1 wn_ih_1_1 0 0.3
Vwp_ih_2_1 wp_ih_2_1 0 0.4871084177821339
Vwn_ih_2_1 wn_ih_2_1 0 0.5128915822178661
Vwp_ih_3_1 wp_ih_3_1 0 0.40617743528268996
Vwn_ih_3_1 wn_ih_3_1 0 0.5938225647173101
Vwp_ih_4_1 wp_ih_4_1 0 0.3
Vwn_ih_4_1 wn_ih_4_1 0 0.7504865377323169
Vwp_ih_5_1 wp_ih_5_1 0 0.3527625456943867
Vwn_ih_5_1 wn_ih_5_1 0 0.6472374543056133
Vwp_ih_6_1 wp_ih_6_1 0 0.523099775012195
Vwn_ih_6_1 wn_ih_6_1 0 0.476900224987805
Vwp_ih_7_1 wp_ih_7_1 0 0.3
Vwn_ih_7_1 wn_ih_7_1 0 0.9
Vwp_ih_8_1 wp_ih_8_1 0 0.3
Vwn_ih_8_1 wn_ih_8_1 0 0.8741415908788173
Vwp_ih_9_1 wp_ih_9_1 0 0.3
Vwn_ih_9_1 wn_ih_9_1 0 0.7554927237832549
Vwp_ih_10_1 wp_ih_10_1 0 0.6209670412432474
Vwn_ih_10_1 wn_ih_10_1 0 0.3790329587567525
Vwp_ih_11_1 wp_ih_11_1 0 0.6314922180326692
Vwn_ih_11_1 wn_ih_11_1 0 0.3685077819673308
Vwp_ih_12_1 wp_ih_12_1 0 0.565754970831351
Vwn_ih_12_1 wn_ih_12_1 0 0.4342450291686491
Vwp_ih_13_1 wp_ih_13_1 0 0.7190616914294362
Vwn_ih_13_1 wn_ih_13_1 0 0.3
Vwp_ih_14_1 wp_ih_14_1 0 0.3902868090280766
Vwn_ih_14_1 wn_ih_14_1 0 0.6097131909719234
Vwp_ih_15_1 wp_ih_15_1 0 0.5086960950617259
Vwn_ih_15_1 wn_ih_15_1 0 0.49130390493827414
Vwp_ho_1_0 wp_ho_1_0 0 0.5075244635725472
Vwn_ho_1_0 wn_ho_1_0 0 0.49247553642745284
Vwp_ho_1_1 wp_ho_1_1 0 0.3
Vwn_ho_1_1 wn_ho_1_1 0 0.7265407105641364
Vwp_ho_1_2 wp_ho_1_2 0 0.4130094771459157
Vwn_ho_1_2 wn_ho_1_2 0 0.5869905228540844
Vwp_ho_1_3 wp_ho_1_3 0 0.43694797889172826
Vwn_ho_1_3 wn_ho_1_3 0 0.5630520211082717
Vwp_ho_1_4 wp_ho_1_4 0 0.6493929627758215
Vwn_ho_1_4 wn_ho_1_4 0 0.3506070372241785
Vwp_ih_0_2 wp_ih_0_2 0 0.9
Vwn_ih_0_2 wn_ih_0_2 0 0.3
Vwp_ih_1_2 wp_ih_1_2 0 0.6265414199615167
Vwn_ih_1_2 wn_ih_1_2 0 0.3734585800384833
Vwp_ih_2_2 wp_ih_2_2 0 0.3
Vwn_ih_2_2 wn_ih_2_2 0 0.7690200914485201
Vwp_ih_3_2 wp_ih_3_2 0 0.45797725793885197
Vwn_ih_3_2 wn_ih_3_2 0 0.5420227420611481
Vwp_ih_4_2 wp_ih_4_2 0 0.5512142733266644
Vwn_ih_4_2 wn_ih_4_2 0 0.4487857266733356
Vwp_ih_5_2 wp_ih_5_2 0 0.3
Vwn_ih_5_2 wn_ih_5_2 0 0.7200021500857348
Vwp_ih_6_2 wp_ih_6_2 0 0.39790718779869794
Vwn_ih_6_2 wn_ih_6_2 0 0.6020928122013021
Vwp_ih_7_2 wp_ih_7_2 0 0.5543572196269259
Vwn_ih_7_2 wn_ih_7_2 0 0.44564278037307414
Vwp_ih_8_2 wp_ih_8_2 0 0.5683726209868444
Vwn_ih_8_2 wn_ih_8_2 0 0.4316273790131557
Vwp_ih_9_2 wp_ih_9_2 0 0.5762485608297733
Vwn_ih_9_2 wn_ih_9_2 0 0.42375143917022673
Vwp_ih_10_2 wp_ih_10_2 0 0.8174219824233624
Vwn_ih_10_2 wn_ih_10_2 0 0.3
Vwp_ih_11_2 wp_ih_11_2 0 0.5008970220781277
Vwn_ih_11_2 wn_ih_11_2 0 0.4991029779218723
Vwp_ih_12_2 wp_ih_12_2 0 0.5971950602420579
Vwn_ih_12_2 wn_ih_12_2 0 0.40280493975794207
Vwp_ih_13_2 wp_ih_13_2 0 0.42776464999322183
Vwn_ih_13_2 wn_ih_13_2 0 0.5722353500067782
Vwp_ih_14_2 wp_ih_14_2 0 0.3901958144373876
Vwn_ih_14_2 wn_ih_14_2 0 0.6098041855626124
Vwp_ih_15_2 wp_ih_15_2 0 0.5364458275158214
Vwn_ih_15_2 wn_ih_15_2 0 0.4635541724841786
Vwp_ho_2_0 wp_ho_2_0 0 0.33978821359844386
Vwn_ho_2_0 wn_ho_2_0 0 0.6602117864015562
Vwp_ho_2_1 wp_ho_2_1 0 0.3
Vwn_ho_2_1 wn_ho_2_1 0 0.7395300591323415
Vwp_ho_2_2 wp_ho_2_2 0 0.5909400888970288
Vwn_ho_2_2 wn_ho_2_2 0 0.4090599111029713
Vwp_ho_2_3 wp_ho_2_3 0 0.5628773439367065
Vwn_ho_2_3 wn_ho_2_3 0 0.4371226560632935
Vwp_ho_2_4 wp_ho_2_4 0 0.6679080391098605
Vwn_ho_2_4 wn_ho_2_4 0 0.3320919608901395
Vwp_ih_0_3 wp_ih_0_3 0 0.5957029053359448
Vwn_ih_0_3 wn_ih_0_3 0 0.40429709466405517
Vwp_ih_1_3 wp_ih_1_3 0 0.44392363758169207
Vwn_ih_1_3 wn_ih_1_3 0 0.5560763624183079
Vwp_ih_2_3 wp_ih_2_3 0 0.6271249377446446
Vwn_ih_2_3 wn_ih_2_3 0 0.37287506225535544
Vwp_ih_3_3 wp_ih_3_3 0 0.4348761372500023
Vwn_ih_3_3 wn_ih_3_3 0 0.5651238627499977
Vwp_ih_4_3 wp_ih_4_3 0 0.5075744663864107
Vwn_ih_4_3 wn_ih_4_3 0 0.4924255336135893
Vwp_ih_5_3 wp_ih_5_3 0 0.49356570253952187
Vwn_ih_5_3 wn_ih_5_3 0 0.5064342974604782
Vwp_ih_6_3 wp_ih_6_3 0 0.3642559498517251
Vwn_ih_6_3 wn_ih_6_3 0 0.635744050148275
Vwp_ih_7_3 wp_ih_7_3 0 0.9
Vwn_ih_7_3 wn_ih_7_3 0 0.3
Vwp_ih_8_3 wp_ih_8_3 0 0.8935915843317754
Vwn_ih_8_3 wn_ih_8_3 0 0.3
Vwp_ih_9_3 wp_ih_9_3 0 0.3
Vwn_ih_9_3 wn_ih_9_3 0 0.7462226489349079
Vwp_ih_10_3 wp_ih_10_3 0 0.5417520024426884
Vwn_ih_10_3 wn_ih_10_3 0 0.4582479975573116
Vwp_ih_11_3 wp_ih_11_3 0 0.9
Vwn_ih_11_3 wn_ih_11_3 0 0.3
Vwp_ih_12_3 wp_ih_12_3 0 0.42375597101677853
Vwn_ih_12_3 wn_ih_12_3 0 0.5762440289832215
Vwp_ih_13_3 wp_ih_13_3 0 0.5024756243598567
Vwn_ih_13_3 wn_ih_13_3 0 0.49752437564014323
Vwp_ih_14_3 wp_ih_14_3 0 0.3
Vwn_ih_14_3 wn_ih_14_3 0 0.721263081002917
Vwp_ih_15_3 wp_ih_15_3 0 0.3
Vwn_ih_15_3 wn_ih_15_3 0 0.9
Vwp_ho_3_0 wp_ho_3_0 0 0.3
Vwn_ho_3_0 wn_ho_3_0 0 0.7888293552495991
Vwp_ho_3_1 wp_ho_3_1 0 0.3
Vwn_ho_3_1 wn_ho_3_1 0 0.7201807855264872
Vwp_ho_3_2 wp_ho_3_2 0 0.3
Vwn_ho_3_2 wn_ho_3_2 0 0.9
Vwp_ho_3_3 wp_ho_3_3 0 0.4747587802734201
Vwn_ho_3_3 wn_ho_3_3 0 0.5252412197265799
Vwp_ho_3_4 wp_ho_3_4 0 0.3
Vwn_ho_3_4 wn_ho_3_4 0 0.7395969125395201
Vwp_ih_0_4 wp_ih_0_4 0 0.6694310462780555
Vwn_ih_0_4 wn_ih_0_4 0 0.3305689537219445
Vwp_ih_1_4 wp_ih_1_4 0 0.300833243230426
Vwn_ih_1_4 wn_ih_1_4 0 0.6991667567695741
Vwp_ih_2_4 wp_ih_2_4 0 0.6527703217256448
Vwn_ih_2_4 wn_ih_2_4 0 0.34722967827435525
Vwp_ih_3_4 wp_ih_3_4 0 0.652801584300905
Vwn_ih_3_4 wn_ih_3_4 0 0.34719841569909504
Vwp_ih_4_4 wp_ih_4_4 0 0.5104597059189208
Vwn_ih_4_4 wn_ih_4_4 0 0.4895402940810793
Vwp_ih_5_4 wp_ih_5_4 0 0.5480198720085727
Vwn_ih_5_4 wn_ih_5_4 0 0.4519801279914273
Vwp_ih_6_4 wp_ih_6_4 0 0.6698347438317642
Vwn_ih_6_4 wn_ih_6_4 0 0.3301652561682358
Vwp_ih_7_4 wp_ih_7_4 0 0.36103626021557145
Vwn_ih_7_4 wn_ih_7_4 0 0.6389637397844286
Vwp_ih_8_4 wp_ih_8_4 0 0.44203031851478747
Vwn_ih_8_4 wn_ih_8_4 0 0.5579696814852125
Vwp_ih_9_4 wp_ih_9_4 0 0.33147952282213383
Vwn_ih_9_4 wn_ih_9_4 0 0.6685204771778661
Vwp_ih_10_4 wp_ih_10_4 0 0.8464454878928866
Vwn_ih_10_4 wn_ih_10_4 0 0.3
Vwp_ih_11_4 wp_ih_11_4 0 0.6068472755285456
Vwn_ih_11_4 wn_ih_11_4 0 0.39315272447145444
Vwp_ih_12_4 wp_ih_12_4 0 0.5110117603408708
Vwn_ih_12_4 wn_ih_12_4 0 0.48898823965912913
Vwp_ih_13_4 wp_ih_13_4 0 0.35403746135770175
Vwn_ih_13_4 wn_ih_13_4 0 0.6459625386422982
Vwp_ih_14_4 wp_ih_14_4 0 0.6487519497592379
Vwn_ih_14_4 wn_ih_14_4 0 0.3512480502407621
Vwp_ih_15_4 wp_ih_15_4 0 0.3501287004035233
Vwn_ih_15_4 wn_ih_15_4 0 0.6498712995964767
Vwp_ho_4_0 wp_ho_4_0 0 0.3467446722099098
Vwn_ho_4_0 wn_ho_4_0 0 0.6532553277900902
Vwp_ho_4_1 wp_ho_4_1 0 0.5577816045102516
Vwn_ho_4_1 wn_ho_4_1 0 0.4422183954897484
Vwp_ho_4_2 wp_ho_4_2 0 0.5102773839439155
Vwn_ho_4_2 wn_ho_4_2 0 0.48972261605608447
Vwp_ho_4_3 wp_ho_4_3 0 0.8252321448049587
Vwn_ho_4_3 wn_ho_4_3 0 0.3
Vwp_ho_4_4 wp_ho_4_4 0 0.5846020491882313
Vwn_ho_4_4 wn_ho_4_4 0 0.41539795081176867
Vwp_ih_0_5 wp_ih_0_5 0 0.5062811696679229
Vwn_ih_0_5 wn_ih_0_5 0 0.4937188303320771
Vwp_ih_1_5 wp_ih_1_5 0 0.6165830498305779
Vwn_ih_1_5 wn_ih_1_5 0 0.3834169501694221
Vwp_ih_2_5 wp_ih_2_5 0 0.4365911768996641
Vwn_ih_2_5 wn_ih_2_5 0 0.5634088231003359
Vwp_ih_3_5 wp_ih_3_5 0 0.5052904490520526
Vwn_ih_3_5 wn_ih_3_5 0 0.49470955094794744
Vwp_ih_4_5 wp_ih_4_5 0 0.4037935181842774
Vwn_ih_4_5 wn_ih_4_5 0 0.5962064818157226
Vwp_ih_5_5 wp_ih_5_5 0 0.4300962236070759
Vwn_ih_5_5 wn_ih_5_5 0 0.5699037763929241
Vwp_ih_6_5 wp_ih_6_5 0 0.4251307650196151
Vwn_ih_6_5 wn_ih_6_5 0 0.5748692349803849
Vwp_ih_7_5 wp_ih_7_5 0 0.3
Vwn_ih_7_5 wn_ih_7_5 0 0.780900456087537
Vwp_ih_8_5 wp_ih_8_5 0 0.3352014778851188
Vwn_ih_8_5 wn_ih_8_5 0 0.6647985221148812
Vwp_ih_9_5 wp_ih_9_5 0 0.4606026539552943
Vwn_ih_9_5 wn_ih_9_5 0 0.5393973460447057
Vwp_ih_10_5 wp_ih_10_5 0 0.5851431882591571
Vwn_ih_10_5 wn_ih_10_5 0 0.4148568117408428
Vwp_ih_11_5 wp_ih_11_5 0 0.44896824999856644
Vwn_ih_11_5 wn_ih_11_5 0 0.5510317500014336
Vwp_ih_12_5 wp_ih_12_5 0 0.4716734326493119
Vwn_ih_12_5 wn_ih_12_5 0 0.5283265673506882
Vwp_ih_13_5 wp_ih_13_5 0 0.5136658960321326
Vwn_ih_13_5 wn_ih_13_5 0 0.48633410396786736
Vwp_ih_14_5 wp_ih_14_5 0 0.3650876671489038
Vwn_ih_14_5 wn_ih_14_5 0 0.6349123328510962
Vwp_ih_15_5 wp_ih_15_5 0 0.6129554885655593
Vwn_ih_15_5 wn_ih_15_5 0 0.38704451143444074
Vwp_ho_5_0 wp_ho_5_0 0 0.4157337111870421
Vwn_ho_5_0 wn_ho_5_0 0 0.584266288812958
Vwp_ho_5_1 wp_ho_5_1 0 0.8598651856548538
Vwn_ho_5_1 wn_ho_5_1 0 0.3
Vwp_ho_5_2 wp_ho_5_2 0 0.6276728546514441
Vwn_ho_5_2 wn_ho_5_2 0 0.37232714534855593
Vwp_ho_5_3 wp_ho_5_3 0 0.576316605390965
Vwn_ho_5_3 wn_ho_5_3 0 0.4236833946090351
Vwp_ho_5_4 wp_ho_5_4 0 0.3
Vwn_ho_5_4 wn_ho_5_4 0 0.7411043390036186
Vwp_ih_0_6 wp_ih_0_6 0 0.5131413419946718
Vwn_ih_0_6 wn_ih_0_6 0 0.4868586580053282
Vwp_ih_1_6 wp_ih_1_6 0 0.5275968536143284
Vwn_ih_1_6 wn_ih_1_6 0 0.4724031463856716
Vwp_ih_2_6 wp_ih_2_6 0 0.5178118189736441
Vwn_ih_2_6 wn_ih_2_6 0 0.4821881810263559
Vwp_ih_3_6 wp_ih_3_6 0 0.5774712346533359
Vwn_ih_3_6 wn_ih_3_6 0 0.4225287653466641
Vwp_ih_4_6 wp_ih_4_6 0 0.34152423026726664
Vwn_ih_4_6 wn_ih_4_6 0 0.6584757697327334
Vwp_ih_5_6 wp_ih_5_6 0 0.416110970077772
Vwn_ih_5_6 wn_ih_5_6 0 0.583889029922228
Vwp_ih_6_6 wp_ih_6_6 0 0.5645579852339635
Vwn_ih_6_6 wn_ih_6_6 0 0.4354420147660365
Vwp_ih_7_6 wp_ih_7_6 0 0.3
Vwn_ih_7_6 wn_ih_7_6 0 0.8414863974598374
Vwp_ih_8_6 wp_ih_8_6 0 0.30990385203524806
Vwn_ih_8_6 wn_ih_8_6 0 0.6900961479647519
Vwp_ih_9_6 wp_ih_9_6 0 0.4505862994133792
Vwn_ih_9_6 wn_ih_9_6 0 0.5494137005866208
Vwp_ih_10_6 wp_ih_10_6 0 0.5602942049552448
Vwn_ih_10_6 wn_ih_10_6 0 0.4397057950447551
Vwp_ih_11_6 wp_ih_11_6 0 0.48564174621662465
Vwn_ih_11_6 wn_ih_11_6 0 0.5143582537833754
Vwp_ih_12_6 wp_ih_12_6 0 0.5399883937067865
Vwn_ih_12_6 wn_ih_12_6 0 0.4600116062932135
Vwp_ih_13_6 wp_ih_13_6 0 0.49463382398155475
Vwn_ih_13_6 wn_ih_13_6 0 0.5053661760184452
Vwp_ih_14_6 wp_ih_14_6 0 0.3904380116096883
Vwn_ih_14_6 wn_ih_14_6 0 0.6095619883903117
Vwp_ih_15_6 wp_ih_15_6 0 0.4245751860000508
Vwn_ih_15_6 wn_ih_15_6 0 0.5754248139999492
Vwp_ho_6_0 wp_ho_6_0 0 0.4782179433311404
Vwn_ho_6_0 wn_ho_6_0 0 0.5217820566688596
Vwp_ho_6_1 wp_ho_6_1 0 0.6594486180590757
Vwn_ho_6_1 wn_ho_6_1 0 0.34055138194092427
Vwp_ho_6_2 wp_ho_6_2 0 0.4223590599861779
Vwn_ho_6_2 wn_ho_6_2 0 0.5776409400138222
Vwp_ho_6_3 wp_ho_6_3 0 0.3
Vwn_ho_6_3 wn_ho_6_3 0 0.8267567978595216
Vwp_ho_6_4 wp_ho_6_4 0 0.6386868632697204
Vwn_ho_6_4 wn_ho_6_4 0 0.36131313673027965
Vwp_ih_0_7 wp_ih_0_7 0 0.5453425971342809
Vwn_ih_0_7 wn_ih_0_7 0 0.45465740286571904
Vwp_ih_1_7 wp_ih_1_7 0 0.4310167881906093
Vwn_ih_1_7 wn_ih_1_7 0 0.5689832118093907
Vwp_ih_2_7 wp_ih_2_7 0 0.6047967029391713
Vwn_ih_2_7 wn_ih_2_7 0 0.39520329706082874
Vwp_ih_3_7 wp_ih_3_7 0 0.4281716942089967
Vwn_ih_3_7 wn_ih_3_7 0 0.5718283057910033
Vwp_ih_4_7 wp_ih_4_7 0 0.4025223217490252
Vwn_ih_4_7 wn_ih_4_7 0 0.5974776782509748
Vwp_ih_5_7 wp_ih_5_7 0 0.3
Vwn_ih_5_7 wn_ih_5_7 0 0.7017074400082164
Vwp_ih_6_7 wp_ih_6_7 0 0.6817697136164227
Vwn_ih_6_7 wn_ih_6_7 0 0.3182302863835773
Vwp_ih_7_7 wp_ih_7_7 0 0.40413814970991485
Vwn_ih_7_7 wn_ih_7_7 0 0.5958618502900851
Vwp_ih_8_7 wp_ih_8_7 0 0.4412007045340804
Vwn_ih_8_7 wn_ih_8_7 0 0.5587992954659197
Vwp_ih_9_7 wp_ih_9_7 0 0.4264788955573988
Vwn_ih_9_7 wn_ih_9_7 0 0.5735211044426012
Vwp_ih_10_7 wp_ih_10_7 0 0.5382427418346708
Vwn_ih_10_7 wn_ih_10_7 0 0.4617572581653292
Vwp_ih_11_7 wp_ih_11_7 0 0.47355107387359635
Vwn_ih_11_7 wn_ih_11_7 0 0.5264489261264036
Vwp_ih_12_7 wp_ih_12_7 0 0.45283617513740376
Vwn_ih_12_7 wn_ih_12_7 0 0.5471638248625962
Vwp_ih_13_7 wp_ih_13_7 0 0.5780796518209014
Vwn_ih_13_7 wn_ih_13_7 0 0.4219203481790986
Vwp_ih_14_7 wp_ih_14_7 0 0.6250377230992437
Vwn_ih_14_7 wn_ih_14_7 0 0.37496227690075634
Vwp_ih_15_7 wp_ih_15_7 0 0.5152775709474648
Vwn_ih_15_7 wn_ih_15_7 0 0.4847224290525351
Vwp_ho_7_0 wp_ho_7_0 0 0.6297860767654198
Vwn_ho_7_0 wn_ho_7_0 0 0.37021392323458024
Vwp_ho_7_1 wp_ho_7_1 0 0.315701199383411
Vwn_ho_7_1 wn_ho_7_1 0 0.684298800616589
Vwp_ho_7_2 wp_ho_7_2 0 0.6544396957029504
Vwn_ho_7_2 wn_ho_7_2 0 0.34556030429704965
Vwp_ho_7_3 wp_ho_7_3 0 0.36881140873623464
Vwn_ho_7_3 wn_ho_7_3 0 0.6311885912637654
Vwp_ho_7_4 wp_ho_7_4 0 0.3850068083492068
Vwn_ho_7_4 wn_ho_7_4 0 0.6149931916507931
Vwp_ih_0_8 wp_ih_0_8 0 0.38504042028765
Vwn_ih_0_8 wn_ih_0_8 0 0.6149595797123499
Vwp_ih_1_8 wp_ih_1_8 0 0.6868879731449221
Vwn_ih_1_8 wn_ih_1_8 0 0.3131120268550779
Vwp_ih_2_8 wp_ih_2_8 0 0.5598812031119068
Vwn_ih_2_8 wn_ih_2_8 0 0.44011879688809324
Vwp_ih_3_8 wp_ih_3_8 0 0.4971912763741304
Vwn_ih_3_8 wn_ih_3_8 0 0.5028087236258696
Vwp_ih_4_8 wp_ih_4_8 0 0.3
Vwn_ih_4_8 wn_ih_4_8 0 0.7508248566487132
Vwp_ih_5_8 wp_ih_5_8 0 0.4739413892301195
Vwn_ih_5_8 wn_ih_5_8 0 0.5260586107698805
Vwp_ih_6_8 wp_ih_6_8 0 0.4018489228834908
Vwn_ih_6_8 wn_ih_6_8 0 0.5981510771165092
Vwp_ih_7_8 wp_ih_7_8 0 0.4448573631709507
Vwn_ih_7_8 wn_ih_7_8 0 0.5551426368290493
Vwp_ih_8_8 wp_ih_8_8 0 0.486467214025472
Vwn_ih_8_8 wn_ih_8_8 0 0.513532785974528
Vwp_ih_9_8 wp_ih_9_8 0 0.3236430816123035
Vwn_ih_9_8 wn_ih_9_8 0 0.6763569183876965
Vwp_ih_10_8 wp_ih_10_8 0 0.43186137014207737
Vwn_ih_10_8 wn_ih_10_8 0 0.5681386298579226
Vwp_ih_11_8 wp_ih_11_8 0 0.5518800355946571
Vwn_ih_11_8 wn_ih_11_8 0 0.44811996440534285
Vwp_ih_12_8 wp_ih_12_8 0 0.4685808529591393
Vwn_ih_12_8 wn_ih_12_8 0 0.5314191470408607
Vwp_ih_13_8 wp_ih_13_8 0 0.5095238956752971
Vwn_ih_13_8 wn_ih_13_8 0 0.49047610432470284
Vwp_ih_14_8 wp_ih_14_8 0 0.6672665875048135
Vwn_ih_14_8 wn_ih_14_8 0 0.3327334124951865
Vwp_ih_15_8 wp_ih_15_8 0 0.5295563815030878
Vwn_ih_15_8 wn_ih_15_8 0 0.47044361849691213
Vwp_ho_8_0 wp_ho_8_0 0 0.6361222807967148
Vwn_ho_8_0 wn_ho_8_0 0 0.3638777192032851
Vwp_ho_8_1 wp_ho_8_1 0 0.5359551586890111
Vwn_ho_8_1 wn_ho_8_1 0 0.46404484131098894
Vwp_ho_8_2 wp_ho_8_2 0 0.48437084654352686
Vwn_ho_8_2 wn_ho_8_2 0 0.5156291534564732
Vwp_ho_8_3 wp_ho_8_3 0 0.6957897420383359
Vwn_ho_8_3 wn_ho_8_3 0 0.3042102579616641
Vwp_ho_8_4 wp_ho_8_4 0 0.5406345125874422
Vwn_ho_8_4 wn_ho_8_4 0 0.45936548741255784
Vwp_ih_0_9 wp_ih_0_9 0 0.3773323733720192
Vwn_ih_0_9 wn_ih_0_9 0 0.6226676266279808
Vwp_ih_1_9 wp_ih_1_9 0 0.3828355703140944
Vwn_ih_1_9 wn_ih_1_9 0 0.6171644296859056
Vwp_ih_2_9 wp_ih_2_9 0 0.35547063233427634
Vwn_ih_2_9 wn_ih_2_9 0 0.6445293676657237
Vwp_ih_3_9 wp_ih_3_9 0 0.37102775125835646
Vwn_ih_3_9 wn_ih_3_9 0 0.6289722487416436
Vwp_ih_4_9 wp_ih_4_9 0 0.7267936511825868
Vwn_ih_4_9 wn_ih_4_9 0 0.3
Vwp_ih_5_9 wp_ih_5_9 0 0.702561202916709
Vwn_ih_5_9 wn_ih_5_9 0 0.3
Vwp_ih_6_9 wp_ih_6_9 0 0.3616480461672694
Vwn_ih_6_9 wn_ih_6_9 0 0.6383519538327306
Vwp_ih_7_9 wp_ih_7_9 0 0.9
Vwn_ih_7_9 wn_ih_7_9 0 0.3
Vwp_ih_8_9 wp_ih_8_9 0 0.8581128975958362
Vwn_ih_8_9 wn_ih_8_9 0 0.3
Vwp_ih_9_9 wp_ih_9_9 0 0.7017932684600048
Vwn_ih_9_9 wn_ih_9_9 0 0.3
Vwp_ih_10_9 wp_ih_10_9 0 0.3859931494771768
Vwn_ih_10_9 wn_ih_10_9 0 0.6140068505228232
Vwp_ih_11_9 wp_ih_11_9 0 0.5070608094710903
Vwn_ih_11_9 wn_ih_11_9 0 0.49293919052890967
Vwp_ih_12_9 wp_ih_12_9 0 0.40633317048537004
Vwn_ih_12_9 wn_ih_12_9 0 0.59366682951463
Vwp_ih_13_9 wp_ih_13_9 0 0.41562184125597895
Vwn_ih_13_9 wn_ih_13_9 0 0.5843781587440211
Vwp_ih_14_9 wp_ih_14_9 0 0.36698681232624986
Vwn_ih_14_9 wn_ih_14_9 0 0.6330131876737501
Vwp_ih_15_9 wp_ih_15_9 0 0.6128753449756232
Vwn_ih_15_9 wn_ih_15_9 0 0.38712465502437676
Vwp_ho_9_0 wp_ho_9_0 0 0.8438153848583063
Vwn_ho_9_0 wn_ho_9_0 0 0.3
Vwp_ho_9_1 wp_ho_9_1 0 0.44225494482081257
Vwn_ho_9_1 wn_ho_9_1 0 0.5577450551791874
Vwp_ho_9_2 wp_ho_9_2 0 0.4258662770726018
Vwn_ho_9_2 wn_ho_9_2 0 0.5741337229273982
Vwp_ho_9_3 wp_ho_9_3 0 0.4199494020970012
Vwn_ho_9_3 wn_ho_9_3 0 0.5800505979029987
Vwp_ho_9_4 wp_ho_9_4 0 0.561546500152248
Vwn_ho_9_4 wn_ho_9_4 0 0.438453499847752
Vwp_ih_0_10 wp_ih_0_10 0 0.3232588195910343
Vwn_ih_0_10 wn_ih_0_10 0 0.6767411804089657
Vwp_ih_1_10 wp_ih_1_10 0 0.4561961045713463
Vwn_ih_1_10 wn_ih_1_10 0 0.5438038954286537
Vwp_ih_2_10 wp_ih_2_10 0 0.33216845110887827
Vwn_ih_2_10 wn_ih_2_10 0 0.6678315488911217
Vwp_ih_3_10 wp_ih_3_10 0 0.506175616168038
Vwn_ih_3_10 wn_ih_3_10 0 0.4938243838319621
Vwp_ih_4_10 wp_ih_4_10 0 0.5764947200519499
Vwn_ih_4_10 wn_ih_4_10 0 0.42350527994805004
Vwp_ih_5_10 wp_ih_5_10 0 0.5235587106562046
Vwn_ih_5_10 wn_ih_5_10 0 0.47644128934379537
Vwp_ih_6_10 wp_ih_6_10 0 0.43792071807820326
Vwn_ih_6_10 wn_ih_6_10 0 0.5620792819217967
Vwp_ih_7_10 wp_ih_7_10 0 0.5831468891692172
Vwn_ih_7_10 wn_ih_7_10 0 0.4168531108307828
Vwp_ih_8_10 wp_ih_8_10 0 0.640046760122324
Vwn_ih_8_10 wn_ih_8_10 0 0.359953239877676
Vwp_ih_9_10 wp_ih_9_10 0 0.6344401149291701
Vwn_ih_9_10 wn_ih_9_10 0 0.36555988507083
Vwp_ih_10_10 wp_ih_10_10 0 0.5028169624861814
Vwn_ih_10_10 wn_ih_10_10 0 0.49718303751381865
Vwp_ih_11_10 wp_ih_11_10 0 0.4254957309224528
Vwn_ih_11_10 wn_ih_11_10 0 0.5745042690775473
Vwp_ih_12_10 wp_ih_12_10 0 0.5191099267740787
Vwn_ih_12_10 wn_ih_12_10 0 0.48089007322592126
Vwp_ih_13_10 wp_ih_13_10 0 0.45035041077856686
Vwn_ih_13_10 wn_ih_13_10 0 0.5496495892214331
Vwp_ih_14_10 wp_ih_14_10 0 0.47032674049125156
Vwn_ih_14_10 wn_ih_14_10 0 0.5296732595087484
Vwp_ih_15_10 wp_ih_15_10 0 0.46387927121768463
Vwn_ih_15_10 wn_ih_15_10 0 0.5361207287823153
Vwp_ho_10_0 wp_ho_10_0 0 0.3481104327881949
Vwn_ho_10_0 wn_ho_10_0 0 0.651889567211805
Vwp_ho_10_1 wp_ho_10_1 0 0.33791767371383297
Vwn_ho_10_1 wn_ho_10_1 0 0.662082326286167
Vwp_ho_10_2 wp_ho_10_2 0 0.517358990620624
Vwn_ho_10_2 wn_ho_10_2 0 0.4826410093793761
Vwp_ho_10_3 wp_ho_10_3 0 0.3931115983894506
Vwn_ho_10_3 wn_ho_10_3 0 0.6068884016105494
Vwp_ho_10_4 wp_ho_10_4 0 0.6941860721774823
Vwn_ho_10_4 wn_ho_10_4 0 0.3058139278225177
Vwp_ih_0_11 wp_ih_0_11 0 0.5199583806060472
Vwn_ih_0_11 wn_ih_0_11 0 0.48004161939395285
Vwp_ih_1_11 wp_ih_1_11 0 0.5037268141385581
Vwn_ih_1_11 wn_ih_1_11 0 0.49627318586144187
Vwp_ih_2_11 wp_ih_2_11 0 0.4414509879714624
Vwn_ih_2_11 wn_ih_2_11 0 0.5585490120285376
Vwp_ih_3_11 wp_ih_3_11 0 0.6356228799119233
Vwn_ih_3_11 wn_ih_3_11 0 0.36437712008807666
Vwp_ih_4_11 wp_ih_4_11 0 0.49205432544557015
Vwn_ih_4_11 wn_ih_4_11 0 0.5079456745544298
Vwp_ih_5_11 wp_ih_5_11 0 0.5705864518648538
Vwn_ih_5_11 wn_ih_5_11 0 0.42941354813514615
Vwp_ih_6_11 wp_ih_6_11 0 0.44281090744449947
Vwn_ih_6_11 wn_ih_6_11 0 0.5571890925555005
Vwp_ih_7_11 wp_ih_7_11 0 0.5394174117912702
Vwn_ih_7_11 wn_ih_7_11 0 0.4605825882087298
Vwp_ih_8_11 wp_ih_8_11 0 0.620489323993939
Vwn_ih_8_11 wn_ih_8_11 0 0.37951067600606103
Vwp_ih_9_11 wp_ih_9_11 0 0.42329988081705167
Vwn_ih_9_11 wn_ih_9_11 0 0.5767001191829484
Vwp_ih_10_11 wp_ih_10_11 0 0.5846017080073264
Vwn_ih_10_11 wn_ih_10_11 0 0.41539829199267364
Vwp_ih_11_11 wp_ih_11_11 0 0.5885462842513047
Vwn_ih_11_11 wn_ih_11_11 0 0.41145371574869527
Vwp_ih_12_11 wp_ih_12_11 0 0.4853940196490889
Vwn_ih_12_11 wn_ih_12_11 0 0.5146059803509111
Vwp_ih_13_11 wp_ih_13_11 0 0.47312099231234445
Vwn_ih_13_11 wn_ih_13_11 0 0.5268790076876556
Vwp_ih_14_11 wp_ih_14_11 0 0.3462813659437952
Vwn_ih_14_11 wn_ih_14_11 0 0.6537186340562048
Vwp_ih_15_11 wp_ih_15_11 0 0.4417901180784079
Vwn_ih_15_11 wn_ih_15_11 0 0.558209881921592
Vwp_ho_11_0 wp_ho_11_0 0 0.38534950696284154
Vwn_ho_11_0 wn_ho_11_0 0 0.6146504930371585
Vwp_ho_11_1 wp_ho_11_1 0 0.6650826849038072
Vwn_ho_11_1 wn_ho_11_1 0 0.3349173150961928
Vwp_ho_11_2 wp_ho_11_2 0 0.37650519200701105
Vwn_ho_11_2 wn_ho_11_2 0 0.623494807992989
Vwp_ho_11_3 wp_ho_11_3 0 0.5403239466290096
Vwn_ho_11_3 wn_ho_11_3 0 0.4596760533709904
Vwp_ho_11_4 wp_ho_11_4 0 0.637603617325276
Vwn_ho_11_4 wn_ho_11_4 0 0.36239638267472396
Vwp_ih_0_12 wp_ih_0_12 0 0.5412233656555097
Vwn_ih_0_12 wn_ih_0_12 0 0.4587766343444904
Vwp_ih_1_12 wp_ih_1_12 0 0.5209245266696753
Vwn_ih_1_12 wn_ih_1_12 0 0.47907547333032474
Vwp_ih_2_12 wp_ih_2_12 0 0.4120209794004153
Vwn_ih_2_12 wn_ih_2_12 0 0.5879790205995847
Vwp_ih_3_12 wp_ih_3_12 0 0.3
Vwn_ih_3_12 wn_ih_3_12 0 0.7573533701326669
Vwp_ih_4_12 wp_ih_4_12 0 0.5592197662873689
Vwn_ih_4_12 wn_ih_4_12 0 0.44078023371263103
Vwp_ih_5_12 wp_ih_5_12 0 0.5420870310197642
Vwn_ih_5_12 wn_ih_5_12 0 0.4579129689802358
Vwp_ih_6_12 wp_ih_6_12 0 0.32482868403228715
Vwn_ih_6_12 wn_ih_6_12 0 0.6751713159677128
Vwp_ih_7_12 wp_ih_7_12 0 0.8861690565152766
Vwn_ih_7_12 wn_ih_7_12 0 0.3
Vwp_ih_8_12 wp_ih_8_12 0 0.9
Vwn_ih_8_12 wn_ih_8_12 0 0.3
Vwp_ih_9_12 wp_ih_9_12 0 0.37452950033432364
Vwn_ih_9_12 wn_ih_9_12 0 0.6254704996656764
Vwp_ih_10_12 wp_ih_10_12 0 0.6004438914675176
Vwn_ih_10_12 wn_ih_10_12 0 0.3995561085324823
Vwp_ih_11_12 wp_ih_11_12 0 0.6739793449393475
Vwn_ih_11_12 wn_ih_11_12 0 0.3260206550606525
Vwp_ih_12_12 wp_ih_12_12 0 0.6032170919587645
Vwn_ih_12_12 wn_ih_12_12 0 0.3967829080412355
Vwp_ih_13_12 wp_ih_13_12 0 0.5328523102495278
Vwn_ih_13_12 wn_ih_13_12 0 0.46714768975047216
Vwp_ih_14_12 wp_ih_14_12 0 0.46173881436474995
Vwn_ih_14_12 wn_ih_14_12 0 0.53826118563525
Vwp_ih_15_12 wp_ih_15_12 0 0.3744905012660473
Vwn_ih_15_12 wn_ih_15_12 0 0.6255094987339527
Vwp_ho_12_0 wp_ho_12_0 0 0.6261483477600276
Vwn_ho_12_0 wn_ho_12_0 0 0.37385165223997235
Vwp_ho_12_1 wp_ho_12_1 0 0.5113413691615549
Vwn_ho_12_1 wn_ho_12_1 0 0.488658630838445
Vwp_ho_12_2 wp_ho_12_2 0 0.593521450992493
Vwn_ho_12_2 wn_ho_12_2 0 0.406478549007507
Vwp_ho_12_3 wp_ho_12_3 0 0.5360534906824479
Vwn_ho_12_3 wn_ho_12_3 0 0.46394650931755216
Vwp_ho_12_4 wp_ho_12_4 0 0.4516628915926037
Vwn_ho_12_4 wn_ho_12_4 0 0.5483371084073964
Vwp_ih_0_13 wp_ih_0_13 0 0.6609025651725629
Vwn_ih_0_13 wn_ih_0_13 0 0.3390974348274372
Vwp_ih_1_13 wp_ih_1_13 0 0.5490668162689332
Vwn_ih_1_13 wn_ih_1_13 0 0.4509331837310669
Vwp_ih_2_13 wp_ih_2_13 0 0.6577590754016883
Vwn_ih_2_13 wn_ih_2_13 0 0.3422409245983117
Vwp_ih_3_13 wp_ih_3_13 0 0.5574424956980838
Vwn_ih_3_13 wn_ih_3_13 0 0.4425575043019162
Vwp_ih_4_13 wp_ih_4_13 0 0.3588841470779567
Vwn_ih_4_13 wn_ih_4_13 0 0.6411158529220433
Vwp_ih_5_13 wp_ih_5_13 0 0.609811762951468
Vwn_ih_5_13 wn_ih_5_13 0 0.390188237048532
Vwp_ih_6_13 wp_ih_6_13 0 0.6323316434580429
Vwn_ih_6_13 wn_ih_6_13 0 0.36766835654195706
Vwp_ih_7_13 wp_ih_7_13 0 0.31617628072515297
Vwn_ih_7_13 wn_ih_7_13 0 0.6838237192748471
Vwp_ih_8_13 wp_ih_8_13 0 0.3
Vwn_ih_8_13 wn_ih_8_13 0 0.8411635680716241
Vwp_ih_9_13 wp_ih_9_13 0 0.3723674610563031
Vwn_ih_9_13 wn_ih_9_13 0 0.627632538943697
Vwp_ih_10_13 wp_ih_10_13 0 0.5874194561531755
Vwn_ih_10_13 wn_ih_10_13 0 0.4125805438468245
Vwp_ih_11_13 wp_ih_11_13 0 0.6065505710010728
Vwn_ih_11_13 wn_ih_11_13 0 0.3934494289989272
Vwp_ih_12_13 wp_ih_12_13 0 0.6047108666788025
Vwn_ih_12_13 wn_ih_12_13 0 0.3952891333211975
Vwp_ih_13_13 wp_ih_13_13 0 0.3754453639275472
Vwn_ih_13_13 wn_ih_13_13 0 0.6245546360724528
Vwp_ih_14_13 wp_ih_14_13 0 0.5215083688971125
Vwn_ih_14_13 wn_ih_14_13 0 0.47849163110288756
Vwp_ih_15_13 wp_ih_15_13 0 0.5126077431886511
Vwn_ih_15_13 wn_ih_15_13 0 0.48739225681134896
Vwp_ho_13_0 wp_ho_13_0 0 0.5527767168490134
Vwn_ho_13_0 wn_ho_13_0 0 0.44722328315098664
Vwp_ho_13_1 wp_ho_13_1 0 0.5195953009889159
Vwn_ho_13_1 wn_ho_13_1 0 0.480404699011084
Vwp_ho_13_2 wp_ho_13_2 0 0.6112386524051479
Vwn_ho_13_2 wn_ho_13_2 0 0.38876134759485215
Vwp_ho_13_3 wp_ho_13_3 0 0.36253813336005236
Vwn_ho_13_3 wn_ho_13_3 0 0.6374618666399476
Vwp_ho_13_4 wp_ho_13_4 0 0.47039164558240565
Vwn_ho_13_4 wn_ho_13_4 0 0.5296083544175944
Vwp_ih_0_14 wp_ih_0_14 0 0.46180761429236206
Vwn_ih_0_14 wn_ih_0_14 0 0.5381923857076379
Vwp_ih_1_14 wp_ih_1_14 0 0.3157501492865086
Vwn_ih_1_14 wn_ih_1_14 0 0.6842498507134914
Vwp_ih_2_14 wp_ih_2_14 0 0.4378790169319408
Vwn_ih_2_14 wn_ih_2_14 0 0.5621209830680591
Vwp_ih_3_14 wp_ih_3_14 0 0.3322106369317761
Vwn_ih_3_14 wn_ih_3_14 0 0.6677893630682239
Vwp_ih_4_14 wp_ih_4_14 0 0.6889381743168279
Vwn_ih_4_14 wn_ih_4_14 0 0.31106182568317203
Vwp_ih_5_14 wp_ih_5_14 0 0.6642356136941879
Vwn_ih_5_14 wn_ih_5_14 0 0.33576438630581207
Vwp_ih_6_14 wp_ih_6_14 0 0.573407923751324
Vwn_ih_6_14 wn_ih_6_14 0 0.42659207624867596
Vwp_ih_7_14 wp_ih_7_14 0 0.8186594767160464
Vwn_ih_7_14 wn_ih_7_14 0 0.3
Vwp_ih_8_14 wp_ih_8_14 0 0.7273319983867669
Vwn_ih_8_14 wn_ih_8_14 0 0.3
Vwp_ih_9_14 wp_ih_9_14 0 0.7998800189182026
Vwn_ih_9_14 wn_ih_9_14 0 0.3
Vwp_ih_10_14 wp_ih_10_14 0 0.43389808321994167
Vwn_ih_10_14 wn_ih_10_14 0 0.5661019167800584
Vwp_ih_11_14 wp_ih_11_14 0 0.3
Vwn_ih_11_14 wn_ih_11_14 0 0.830870728507581
Vwp_ih_12_14 wp_ih_12_14 0 0.41647794798356813
Vwn_ih_12_14 wn_ih_12_14 0 0.5835220520164319
Vwp_ih_13_14 wp_ih_13_14 0 0.5356133734503277
Vwn_ih_13_14 wn_ih_13_14 0 0.46438662654967233
Vwp_ih_14_14 wp_ih_14_14 0 0.6415281135613644
Vwn_ih_14_14 wn_ih_14_14 0 0.3584718864386356
Vwp_ih_15_14 wp_ih_15_14 0 0.5776083893505948
Vwn_ih_15_14 wn_ih_15_14 0 0.4223916106494053
Vwp_ho_14_0 wp_ho_14_0 0 0.4760979133292243
Vwn_ho_14_0 wn_ho_14_0 0 0.5239020866707758
Vwp_ho_14_1 wp_ho_14_1 0 0.7585377146853105
Vwn_ho_14_1 wn_ho_14_1 0 0.3
Vwp_ho_14_2 wp_ho_14_2 0 0.3
Vwn_ho_14_2 wn_ho_14_2 0 0.7162484589615662
Vwp_ho_14_3 wp_ho_14_3 0 0.3
Vwn_ho_14_3 wn_ho_14_3 0 0.8441219660738317
Vwp_ho_14_4 wp_ho_14_4 0 0.49091975368828333
Vwn_ho_14_4 wn_ho_14_4 0 0.5090802463117167
Vwp_ih_0_15 wp_ih_0_15 0 0.6247905421801629
Vwn_ih_0_15 wn_ih_0_15 0 0.37520945781983706
Vwp_ih_1_15 wp_ih_1_15 0 0.6494806466300654
Vwn_ih_1_15 wn_ih_1_15 0 0.35051935336993456
Vwp_ih_2_15 wp_ih_2_15 0 0.33802437202109936
Vwn_ih_2_15 wn_ih_2_15 0 0.6619756279789006
Vwp_ih_3_15 wp_ih_3_15 0 0.3
Vwn_ih_3_15 wn_ih_3_15 0 0.7308362348095276
Vwp_ih_4_15 wp_ih_4_15 0 0.5524274710758221
Vwn_ih_4_15 wn_ih_4_15 0 0.4475725289241779
Vwp_ih_5_15 wp_ih_5_15 0 0.31088789630770486
Vwn_ih_5_15 wn_ih_5_15 0 0.6891121036922951
Vwp_ih_6_15 wp_ih_6_15 0 0.3458055716270939
Vwn_ih_6_15 wn_ih_6_15 0 0.6541944283729061
Vwp_ih_7_15 wp_ih_7_15 0 0.9
Vwn_ih_7_15 wn_ih_7_15 0 0.3
Vwp_ih_8_15 wp_ih_8_15 0 0.9
Vwn_ih_8_15 wn_ih_8_15 0 0.3
Vwp_ih_9_15 wp_ih_9_15 0 0.5999610386033801
Vwn_ih_9_15 wn_ih_9_15 0 0.40003896139661993
Vwp_ih_10_15 wp_ih_10_15 0 0.6573631233118413
Vwn_ih_10_15 wn_ih_10_15 0 0.34263687668815873
Vwp_ih_11_15 wp_ih_11_15 0 0.4984208334773091
Vwn_ih_11_15 wn_ih_11_15 0 0.5015791665226909
Vwp_ih_12_15 wp_ih_12_15 0 0.43866597646239736
Vwn_ih_12_15 wn_ih_12_15 0 0.5613340235376026
Vwp_ih_13_15 wp_ih_13_15 0 0.5919383141446961
Vwn_ih_13_15 wn_ih_13_15 0 0.40806168585530395
Vwp_ih_14_15 wp_ih_14_15 0 0.44488645108842173
Vwn_ih_14_15 wn_ih_14_15 0 0.5551135489115783
Vwp_ih_15_15 wp_ih_15_15 0 0.4019478863157694
Vwn_ih_15_15 wn_ih_15_15 0 0.5980521136842306
Vwp_ho_15_0 wp_ho_15_0 0 0.5300426458955486
Vwn_ho_15_0 wn_ho_15_0 0 0.46995735410445144
Vwp_ho_15_1 wp_ho_15_1 0 0.3841594012163815
Vwn_ho_15_1 wn_ho_15_1 0 0.6158405987836185
Vwp_ho_15_2 wp_ho_15_2 0 0.5922194815110235
Vwn_ho_15_2 wn_ho_15_2 0 0.4077805184889765
Vwp_ho_15_3 wp_ho_15_3 0 0.3
Vwn_ho_15_3 wn_ho_15_3 0 0.7041188601663207
Vwp_ho_15_4 wp_ho_15_4 0 0.5833859188637543
Vwn_ho_15_4 wn_ho_15_4 0 0.4166140811362456
Vwp_ih_0_16 wp_ih_0_16 0 0.38421500127998054
Vwn_ih_0_16 wn_ih_0_16 0 0.6157849987200195
Vwp_ih_1_16 wp_ih_1_16 0 0.3623295180800822
Vwn_ih_1_16 wn_ih_1_16 0 0.6376704819199178
Vwp_ih_2_16 wp_ih_2_16 0 0.4541544990715388
Vwn_ih_2_16 wn_ih_2_16 0 0.5458455009284612
Vwp_ih_3_16 wp_ih_3_16 0 0.4773146871498836
Vwn_ih_3_16 wn_ih_3_16 0 0.5226853128501164
Vwp_ih_4_16 wp_ih_4_16 0 0.5505285393533671
Vwn_ih_4_16 wn_ih_4_16 0 0.4494714606466329
Vwp_ih_5_16 wp_ih_5_16 0 0.5212850823772416
Vwn_ih_5_16 wn_ih_5_16 0 0.47871491762275836
Vwp_ih_6_16 wp_ih_6_16 0 0.3898321258821494
Vwn_ih_6_16 wn_ih_6_16 0 0.6101678741178507
Vwp_ih_7_16 wp_ih_7_16 0 0.6281931976095568
Vwn_ih_7_16 wn_ih_7_16 0 0.37180680239044317
Vwp_ih_8_16 wp_ih_8_16 0 0.6888313308763989
Vwn_ih_8_16 wn_ih_8_16 0 0.3111686691236011
Vwp_ih_9_16 wp_ih_9_16 0 0.692342672589887
Vwn_ih_9_16 wn_ih_9_16 0 0.307657327410113
Vwp_ih_10_16 wp_ih_10_16 0 0.35071489008399226
Vwn_ih_10_16 wn_ih_10_16 0 0.6492851099160077
Vwp_ih_11_16 wp_ih_11_16 0 0.33617237893630014
Vwn_ih_11_16 wn_ih_11_16 0 0.6638276210636999
Vwp_ih_12_16 wp_ih_12_16 0 0.3905285968337893
Vwn_ih_12_16 wn_ih_12_16 0 0.6094714031662107
Vwp_ih_13_16 wp_ih_13_16 0 0.5706441705763599
Vwn_ih_13_16 wn_ih_13_16 0 0.42935582942364015
Vwp_ih_14_16 wp_ih_14_16 0 0.5550315391000914
Vwn_ih_14_16 wn_ih_14_16 0 0.4449684608999086
Vwp_ih_15_16 wp_ih_15_16 0 0.393843697268135
Vwn_ih_15_16 wn_ih_15_16 0 0.6061563027318649
Vwp_ho_16_0 wp_ho_16_0 0 0.5597346380702994
Vwn_ho_16_0 wn_ho_16_0 0 0.44026536192970056
Vwp_ho_16_1 wp_ho_16_1 0 0.33515597143281434
Vwn_ho_16_1 wn_ho_16_1 0 0.6648440285671857
Vwp_ho_16_2 wp_ho_16_2 0 0.4650693436411831
Vwn_ho_16_2 wn_ho_16_2 0 0.534930656358817
Vwp_ho_16_3 wp_ho_16_3 0 0.5068244030965917
Vwn_ho_16_3 wn_ho_16_3 0 0.4931755969034083
Vwp_ho_16_4 wp_ho_16_4 0 0.3
Vwn_ho_16_4 wn_ho_16_4 0 0.8111872618230793
Vwp_ih_0_17 wp_ih_0_17 0 0.5126630501844299
Vwn_ih_0_17 wn_ih_0_17 0 0.4873369498155701
Vwp_ih_1_17 wp_ih_1_17 0 0.3383728757761729
Vwn_ih_1_17 wn_ih_1_17 0 0.6616271242238271
Vwp_ih_2_17 wp_ih_2_17 0 0.3993787764792032
Vwn_ih_2_17 wn_ih_2_17 0 0.6006212235207967
Vwp_ih_3_17 wp_ih_3_17 0 0.49879947194242785
Vwn_ih_3_17 wn_ih_3_17 0 0.5012005280575721
Vwp_ih_4_17 wp_ih_4_17 0 0.6266566733668153
Vwn_ih_4_17 wn_ih_4_17 0 0.3733433266331847
Vwp_ih_5_17 wp_ih_5_17 0 0.5113327113331371
Vwn_ih_5_17 wn_ih_5_17 0 0.488667288666863
Vwp_ih_6_17 wp_ih_6_17 0 0.3
Vwn_ih_6_17 wn_ih_6_17 0 0.7016185604137081
Vwp_ih_7_17 wp_ih_7_17 0 0.7852287877589134
Vwn_ih_7_17 wn_ih_7_17 0 0.3
Vwp_ih_8_17 wp_ih_8_17 0 0.9
Vwn_ih_8_17 wn_ih_8_17 0 0.3
Vwp_ih_9_17 wp_ih_9_17 0 0.4067851853438695
Vwn_ih_9_17 wn_ih_9_17 0 0.5932148146561305
Vwp_ih_10_17 wp_ih_10_17 0 0.6663474060825423
Vwn_ih_10_17 wn_ih_10_17 0 0.3336525939174578
Vwp_ih_11_17 wp_ih_11_17 0 0.724249340335667
Vwn_ih_11_17 wn_ih_11_17 0 0.3
Vwp_ih_12_17 wp_ih_12_17 0 0.49447525686758437
Vwn_ih_12_17 wn_ih_12_17 0 0.5055247431324156
Vwp_ih_13_17 wp_ih_13_17 0 0.3687969475428866
Vwn_ih_13_17 wn_ih_13_17 0 0.6312030524571134
Vwp_ih_14_17 wp_ih_14_17 0 0.4562016593722088
Vwn_ih_14_17 wn_ih_14_17 0 0.5437983406277912
Vwp_ih_15_17 wp_ih_15_17 0 0.3
Vwn_ih_15_17 wn_ih_15_17 0 0.7279201539436125
Vwp_ho_17_0 wp_ho_17_0 0 0.7801327178751912
Vwn_ho_17_0 wn_ho_17_0 0 0.3
Vwp_ho_17_1 wp_ho_17_1 0 0.5144393906645196
Vwn_ho_17_1 wn_ho_17_1 0 0.4855606093354804
Vwp_ho_17_2 wp_ho_17_2 0 0.5270508334482771
Vwn_ho_17_2 wn_ho_17_2 0 0.4729491665517229
Vwp_ho_17_3 wp_ho_17_3 0 0.3764619483595302
Vwn_ho_17_3 wn_ho_17_3 0 0.6235380516404698
Vwp_ho_17_4 wp_ho_17_4 0 0.40876059969173384
Vwn_ho_17_4 wn_ho_17_4 0 0.5912394003082662
Vwp_ih_0_18 wp_ih_0_18 0 0.5028998703972456
Vwn_ih_0_18 wn_ih_0_18 0 0.4971001296027544
Vwp_ih_1_18 wp_ih_1_18 0 0.5179173447920801
Vwn_ih_1_18 wn_ih_1_18 0 0.4820826552079199
Vwp_ih_2_18 wp_ih_2_18 0 0.3892154695693186
Vwn_ih_2_18 wn_ih_2_18 0 0.6107845304306814
Vwp_ih_3_18 wp_ih_3_18 0 0.408803683272038
Vwn_ih_3_18 wn_ih_3_18 0 0.591196316727962
Vwp_ih_4_18 wp_ih_4_18 0 0.49419879133614436
Vwn_ih_4_18 wn_ih_4_18 0 0.5058012086638557
Vwp_ih_5_18 wp_ih_5_18 0 0.5147032662549873
Vwn_ih_5_18 wn_ih_5_18 0 0.48529673374501275
Vwp_ih_6_18 wp_ih_6_18 0 0.4019989090529582
Vwn_ih_6_18 wn_ih_6_18 0 0.5980010909470418
Vwp_ih_7_18 wp_ih_7_18 0 0.7547977818489069
Vwn_ih_7_18 wn_ih_7_18 0 0.3
Vwp_ih_8_18 wp_ih_8_18 0 0.6389336147722
Vwn_ih_8_18 wn_ih_8_18 0 0.36106638522780005
Vwp_ih_9_18 wp_ih_9_18 0 0.3430872286331057
Vwn_ih_9_18 wn_ih_9_18 0 0.6569127713668943
Vwp_ih_10_18 wp_ih_10_18 0 0.5866256421151412
Vwn_ih_10_18 wn_ih_10_18 0 0.41337435788485877
Vwp_ih_11_18 wp_ih_11_18 0 0.5375776095155845
Vwn_ih_11_18 wn_ih_11_18 0 0.4624223904844155
Vwp_ih_12_18 wp_ih_12_18 0 0.47174557385330146
Vwn_ih_12_18 wn_ih_12_18 0 0.5282544261466986
Vwp_ih_13_18 wp_ih_13_18 0 0.6400459888782961
Vwn_ih_13_18 wn_ih_13_18 0 0.35995401112170383
Vwp_ih_14_18 wp_ih_14_18 0 0.7188220606185197
Vwn_ih_14_18 wn_ih_14_18 0 0.3
Vwp_ih_15_18 wp_ih_15_18 0 0.6033870714306091
Vwn_ih_15_18 wn_ih_15_18 0 0.39661292856939084
Vwp_ho_18_0 wp_ho_18_0 0 0.3
Vwn_ho_18_0 wn_ho_18_0 0 0.7572735427194541
Vwp_ho_18_1 wp_ho_18_1 0 0.6200312634636114
Vwn_ho_18_1 wn_ho_18_1 0 0.3799687365363887
Vwp_ho_18_2 wp_ho_18_2 0 0.40709566335176534
Vwn_ho_18_2 wn_ho_18_2 0 0.5929043366482347
Vwp_ho_18_3 wp_ho_18_3 0 0.3689150107838182
Vwn_ho_18_3 wn_ho_18_3 0 0.6310849892161818
Vwp_ho_18_4 wp_ho_18_4 0 0.3
Vwn_ho_18_4 wn_ho_18_4 0 0.7203357040457312
Vwp_ih_0_19 wp_ih_0_19 0 0.35583591546098914
Vwn_ih_0_19 wn_ih_0_19 0 0.6441640845390109
Vwp_ih_1_19 wp_ih_1_19 0 0.4709603468103458
Vwn_ih_1_19 wn_ih_1_19 0 0.5290396531896542
Vwp_ih_2_19 wp_ih_2_19 0 0.487577666069084
Vwn_ih_2_19 wn_ih_2_19 0 0.512422333930916
Vwp_ih_3_19 wp_ih_3_19 0 0.41980785548526467
Vwn_ih_3_19 wn_ih_3_19 0 0.5801921445147353
Vwp_ih_4_19 wp_ih_4_19 0 0.5190765124917013
Vwn_ih_4_19 wn_ih_4_19 0 0.4809234875082987
Vwp_ih_5_19 wp_ih_5_19 0 0.6098844829350579
Vwn_ih_5_19 wn_ih_5_19 0 0.390115517064942
Vwp_ih_6_19 wp_ih_6_19 0 0.5217960028250459
Vwn_ih_6_19 wn_ih_6_19 0 0.47820399717495404
Vwp_ih_7_19 wp_ih_7_19 0 0.7912882340551213
Vwn_ih_7_19 wn_ih_7_19 0 0.3
Vwp_ih_8_19 wp_ih_8_19 0 0.9
Vwn_ih_8_19 wn_ih_8_19 0 0.3
Vwp_ih_9_19 wp_ih_9_19 0 0.6073394236287192
Vwn_ih_9_19 wn_ih_9_19 0 0.3926605763712808
Vwp_ih_10_19 wp_ih_10_19 0 0.41996545452068446
Vwn_ih_10_19 wn_ih_10_19 0 0.5800345454793155
Vwp_ih_11_19 wp_ih_11_19 0 0.4743634297489363
Vwn_ih_11_19 wn_ih_11_19 0 0.5256365702510637
Vwp_ih_12_19 wp_ih_12_19 0 0.49493845384800045
Vwn_ih_12_19 wn_ih_12_19 0 0.5050615461519996
Vwp_ih_13_19 wp_ih_13_19 0 0.6506846030817527
Vwn_ih_13_19 wn_ih_13_19 0 0.3493153969182473
Vwp_ih_14_19 wp_ih_14_19 0 0.44747586168746667
Vwn_ih_14_19 wn_ih_14_19 0 0.5525241383125333
Vwp_ih_15_19 wp_ih_15_19 0 0.5371289780849483
Vwn_ih_15_19 wn_ih_15_19 0 0.46287102191505164
Vwp_ho_19_0 wp_ho_19_0 0 0.4773800911261328
Vwn_ho_19_0 wn_ho_19_0 0 0.5226199088738672
Vwp_ho_19_1 wp_ho_19_1 0 0.45110761369895697
Vwn_ho_19_1 wn_ho_19_1 0 0.548892386301043
Vwp_ho_19_2 wp_ho_19_2 0 0.47503284832059056
Vwn_ho_19_2 wn_ho_19_2 0 0.5249671516794094
Vwp_ho_19_3 wp_ho_19_3 0 0.6866268729267775
Vwn_ho_19_3 wn_ho_19_3 0 0.3133731270732225
Vwp_ho_19_4 wp_ho_19_4 0 0.6208392717723105
Vwn_ho_19_4 wn_ho_19_4 0 0.37916072822768954
Vwp_ih_0_20 wp_ih_0_20 0 0.511553110111614
Vwn_ih_0_20 wn_ih_0_20 0 0.4884468898883861
Vwp_ih_1_20 wp_ih_1_20 0 0.5034732326617084
Vwn_ih_1_20 wn_ih_1_20 0 0.4965267673382916
Vwp_ih_2_20 wp_ih_2_20 0 0.4403868227274527
Vwn_ih_2_20 wn_ih_2_20 0 0.5596131772725473
Vwp_ih_3_20 wp_ih_3_20 0 0.5201655329113553
Vwn_ih_3_20 wn_ih_3_20 0 0.47983446708864474
Vwp_ih_4_20 wp_ih_4_20 0 0.3929561012270942
Vwn_ih_4_20 wn_ih_4_20 0 0.6070438987729059
Vwp_ih_5_20 wp_ih_5_20 0 0.3
Vwn_ih_5_20 wn_ih_5_20 0 0.7713708352288202
Vwp_ih_6_20 wp_ih_6_20 0 0.5518978724042697
Vwn_ih_6_20 wn_ih_6_20 0 0.4481021275957303
Vwp_ih_7_20 wp_ih_7_20 0 0.3
Vwn_ih_7_20 wn_ih_7_20 0 0.719661347129205
Vwp_ih_8_20 wp_ih_8_20 0 0.3805084336400928
Vwn_ih_8_20 wn_ih_8_20 0 0.6194915663599072
Vwp_ih_9_20 wp_ih_9_20 0 0.5700803183613262
Vwn_ih_9_20 wn_ih_9_20 0 0.4299196816386737
Vwp_ih_10_20 wp_ih_10_20 0 0.6060847402796669
Vwn_ih_10_20 wn_ih_10_20 0 0.3939152597203332
Vwp_ih_11_20 wp_ih_11_20 0 0.46591967963994907
Vwn_ih_11_20 wn_ih_11_20 0 0.5340803203600509
Vwp_ih_12_20 wp_ih_12_20 0 0.5491818428945314
Vwn_ih_12_20 wn_ih_12_20 0 0.4508181571054686
Vwp_ih_13_20 wp_ih_13_20 0 0.4572245650197855
Vwn_ih_13_20 wn_ih_13_20 0 0.5427754349802145
Vwp_ih_14_20 wp_ih_14_20 0 0.3
Vwn_ih_14_20 wn_ih_14_20 0 0.7236059748219756
Vwp_ih_15_20 wp_ih_15_20 0 0.3917255758951349
Vwn_ih_15_20 wn_ih_15_20 0 0.6082744241048651
Vwp_ho_20_0 wp_ho_20_0 0 0.6280774787693482
Vwn_ho_20_0 wn_ho_20_0 0 0.3719225212306518
Vwp_ho_20_1 wp_ho_20_1 0 0.6247947564828337
Vwn_ho_20_1 wn_ho_20_1 0 0.37520524351716633
Vwp_ho_20_2 wp_ho_20_2 0 0.35490730185551667
Vwn_ho_20_2 wn_ho_20_2 0 0.6450926981444833
Vwp_ho_20_3 wp_ho_20_3 0 0.5342627293883616
Vwn_ho_20_3 wn_ho_20_3 0 0.46573727061163833
Vwp_ho_20_4 wp_ho_20_4 0 0.614410151054491
Vwn_ho_20_4 wn_ho_20_4 0 0.385589848945509
Vwp_ih_0_21 wp_ih_0_21 0 0.5197793890317963
Vwn_ih_0_21 wn_ih_0_21 0 0.48022061096820373
Vwp_ih_1_21 wp_ih_1_21 0 0.5949193447906533
Vwn_ih_1_21 wn_ih_1_21 0 0.40508065520934666
Vwp_ih_2_21 wp_ih_2_21 0 0.612244278644419
Vwn_ih_2_21 wn_ih_2_21 0 0.387755721355581
Vwp_ih_3_21 wp_ih_3_21 0 0.6357609272263695
Vwn_ih_3_21 wn_ih_3_21 0 0.36423907277363055
Vwp_ih_4_21 wp_ih_4_21 0 0.5520284184542141
Vwn_ih_4_21 wn_ih_4_21 0 0.44797158154578587
Vwp_ih_5_21 wp_ih_5_21 0 0.39757326014488154
Vwn_ih_5_21 wn_ih_5_21 0 0.6024267398551184
Vwp_ih_6_21 wp_ih_6_21 0 0.6352131213691976
Vwn_ih_6_21 wn_ih_6_21 0 0.3647868786308024
Vwp_ih_7_21 wp_ih_7_21 0 0.3
Vwn_ih_7_21 wn_ih_7_21 0 0.7530223057055527
Vwp_ih_8_21 wp_ih_8_21 0 0.48804361237465194
Vwn_ih_8_21 wn_ih_8_21 0 0.511956387625348
Vwp_ih_9_21 wp_ih_9_21 0 0.4135953240274891
Vwn_ih_9_21 wn_ih_9_21 0 0.5864046759725109
Vwp_ih_10_21 wp_ih_10_21 0 0.5641693478801036
Vwn_ih_10_21 wn_ih_10_21 0 0.4358306521198963
Vwp_ih_11_21 wp_ih_11_21 0 0.44636153105269266
Vwn_ih_11_21 wn_ih_11_21 0 0.5536384689473074
Vwp_ih_12_21 wp_ih_12_21 0 0.5352782671761246
Vwn_ih_12_21 wn_ih_12_21 0 0.46472173282387536
Vwp_ih_13_21 wp_ih_13_21 0 0.5447177914645721
Vwn_ih_13_21 wn_ih_13_21 0 0.4552822085354279
Vwp_ih_14_21 wp_ih_14_21 0 0.6309934039744602
Vwn_ih_14_21 wn_ih_14_21 0 0.36900659602553976
Vwp_ih_15_21 wp_ih_15_21 0 0.48885128967305913
Vwn_ih_15_21 wn_ih_15_21 0 0.5111487103269409
Vwp_ho_21_0 wp_ho_21_0 0 0.626203649871895
Vwn_ho_21_0 wn_ho_21_0 0 0.373796350128105
Vwp_ho_21_1 wp_ho_21_1 0 0.3926997006879607
Vwn_ho_21_1 wn_ho_21_1 0 0.6073002993120393
Vwp_ho_21_2 wp_ho_21_2 0 0.5821987859040026
Vwn_ho_21_2 wn_ho_21_2 0 0.41780121409599735
Vwp_ho_21_3 wp_ho_21_3 0 0.45269531711869465
Vwn_ho_21_3 wn_ho_21_3 0 0.5473046828813053
Vwp_ho_21_4 wp_ho_21_4 0 0.345906452480652
Vwn_ho_21_4 wn_ho_21_4 0 0.654093547519348
Vwp_ih_0_22 wp_ih_0_22 0 0.4826566384898992
Vwn_ih_0_22 wn_ih_0_22 0 0.5173433615101009
Vwp_ih_1_22 wp_ih_1_22 0 0.6635881697793522
Vwn_ih_1_22 wn_ih_1_22 0 0.3364118302206478
Vwp_ih_2_22 wp_ih_2_22 0 0.3853200168660399
Vwn_ih_2_22 wn_ih_2_22 0 0.6146799831339601
Vwp_ih_3_22 wp_ih_3_22 0 0.6848861574842873
Vwn_ih_3_22 wn_ih_3_22 0 0.3151138425157127
Vwp_ih_4_22 wp_ih_4_22 0 0.5385211422411925
Vwn_ih_4_22 wn_ih_4_22 0 0.46147885775880754
Vwp_ih_5_22 wp_ih_5_22 0 0.39961464063831065
Vwn_ih_5_22 wn_ih_5_22 0 0.6003853593616894
Vwp_ih_6_22 wp_ih_6_22 0 0.40706284204028886
Vwn_ih_6_22 wn_ih_6_22 0 0.5929371579597111
Vwp_ih_7_22 wp_ih_7_22 0 0.3
Vwn_ih_7_22 wn_ih_7_22 0 0.8537212375923133
Vwp_ih_8_22 wp_ih_8_22 0 0.3
Vwn_ih_8_22 wn_ih_8_22 0 0.7629058687091181
Vwp_ih_9_22 wp_ih_9_22 0 0.736900679630812
Vwn_ih_9_22 wn_ih_9_22 0 0.3
Vwp_ih_10_22 wp_ih_10_22 0 0.5221916978065142
Vwn_ih_10_22 wn_ih_10_22 0 0.4778083021934858
Vwp_ih_11_22 wp_ih_11_22 0 0.47704381727116624
Vwn_ih_11_22 wn_ih_11_22 0 0.5229561827288338
Vwp_ih_12_22 wp_ih_12_22 0 0.6340958648157402
Vwn_ih_12_22 wn_ih_12_22 0 0.3659041351842598
Vwp_ih_13_22 wp_ih_13_22 0 0.5652827015962976
Vwn_ih_13_22 wn_ih_13_22 0 0.43471729840370243
Vwp_ih_14_22 wp_ih_14_22 0 0.3
Vwn_ih_14_22 wn_ih_14_22 0 0.717349120765898
Vwp_ih_15_22 wp_ih_15_22 0 0.30462842208069796
Vwn_ih_15_22 wn_ih_15_22 0 0.695371577919302
Vwp_ho_22_0 wp_ho_22_0 0 0.5190787231542532
Vwn_ho_22_0 wn_ho_22_0 0 0.4809212768457468
Vwp_ho_22_1 wp_ho_22_1 0 0.5193044524304784
Vwn_ho_22_1 wn_ho_22_1 0 0.48069554756952165
Vwp_ho_22_2 wp_ho_22_2 0 0.38130224270137686
Vwn_ho_22_2 wn_ho_22_2 0 0.6186977572986232
Vwp_ho_22_3 wp_ho_22_3 0 0.6501955877995523
Vwn_ho_22_3 wn_ho_22_3 0 0.34980441220044767
Vwp_ho_22_4 wp_ho_22_4 0 0.42428591024461226
Vwn_ho_22_4 wn_ho_22_4 0 0.5757140897553877
Vwp_ih_0_23 wp_ih_0_23 0 0.3170803176697553
Vwn_ih_0_23 wn_ih_0_23 0 0.6829196823302447
Vwp_ih_1_23 wp_ih_1_23 0 0.4288713267718095
Vwn_ih_1_23 wn_ih_1_23 0 0.5711286732281905
Vwp_ih_2_23 wp_ih_2_23 0 0.39254276934147597
Vwn_ih_2_23 wn_ih_2_23 0 0.607457230658524
Vwp_ih_3_23 wp_ih_3_23 0 0.4744762493563733
Vwn_ih_3_23 wn_ih_3_23 0 0.5255237506436267
Vwp_ih_4_23 wp_ih_4_23 0 0.47604039924407754
Vwn_ih_4_23 wn_ih_4_23 0 0.5239596007559224
Vwp_ih_5_23 wp_ih_5_23 0 0.6597649543640638
Vwn_ih_5_23 wn_ih_5_23 0 0.3402350456359362
Vwp_ih_6_23 wp_ih_6_23 0 0.4842404674599859
Vwn_ih_6_23 wn_ih_6_23 0 0.5157595325400142
Vwp_ih_7_23 wp_ih_7_23 0 0.7619617334812507
Vwn_ih_7_23 wn_ih_7_23 0 0.3
Vwp_ih_8_23 wp_ih_8_23 0 0.5670080349037266
Vwn_ih_8_23 wn_ih_8_23 0 0.4329919650962734
Vwp_ih_9_23 wp_ih_9_23 0 0.5749797086509919
Vwn_ih_9_23 wn_ih_9_23 0 0.4250202913490081
Vwp_ih_10_23 wp_ih_10_23 0 0.46478198846719054
Vwn_ih_10_23 wn_ih_10_23 0 0.5352180115328095
Vwp_ih_11_23 wp_ih_11_23 0 0.5224536839165523
Vwn_ih_11_23 wn_ih_11_23 0 0.4775463160834476
Vwp_ih_12_23 wp_ih_12_23 0 0.4223016852841105
Vwn_ih_12_23 wn_ih_12_23 0 0.5776983147158895
Vwp_ih_13_23 wp_ih_13_23 0 0.5220859889299135
Vwn_ih_13_23 wn_ih_13_23 0 0.47791401107008646
Vwp_ih_14_23 wp_ih_14_23 0 0.608592041117094
Vwn_ih_14_23 wn_ih_14_23 0 0.391407958882906
Vwp_ih_15_23 wp_ih_15_23 0 0.6778517828184181
Vwn_ih_15_23 wn_ih_15_23 0 0.32214821718158193
Vwp_ho_23_0 wp_ho_23_0 0 0.3655803446279251
Vwn_ho_23_0 wn_ho_23_0 0 0.6344196553720749
Vwp_ho_23_1 wp_ho_23_1 0 0.43374811187422896
Vwn_ho_23_1 wn_ho_23_1 0 0.566251888125771
Vwp_ho_23_2 wp_ho_23_2 0 0.7729733187577966
Vwn_ho_23_2 wn_ho_23_2 0 0.3
Vwp_ho_23_3 wp_ho_23_3 0 0.4291725354060937
Vwn_ho_23_3 wn_ho_23_3 0 0.5708274645939063
Vwp_ho_23_4 wp_ho_23_4 0 0.6909102533291234
Vwn_ho_23_4 wn_ho_23_4 0 0.30908974667087663
Vwp_ih_0_24 wp_ih_0_24 0 0.4290011150799792
Vwn_ih_0_24 wn_ih_0_24 0 0.5709988849200208
Vwp_ih_1_24 wp_ih_1_24 0 0.9
Vwn_ih_1_24 wn_ih_1_24 0 0.3
Vwp_ih_2_24 wp_ih_2_24 0 0.466126262115866
Vwn_ih_2_24 wn_ih_2_24 0 0.533873737884134
Vwp_ih_3_24 wp_ih_3_24 0 0.9
Vwn_ih_3_24 wn_ih_3_24 0 0.3
Vwp_ih_4_24 wp_ih_4_24 0 0.7144130075471193
Vwn_ih_4_24 wn_ih_4_24 0 0.3
Vwp_ih_5_24 wp_ih_5_24 0 0.5448674380151224
Vwn_ih_5_24 wn_ih_5_24 0 0.45513256198487767
Vwp_ih_6_24 wp_ih_6_24 0 0.3
Vwn_ih_6_24 wn_ih_6_24 0 0.891849021540557
Vwp_ih_7_24 wp_ih_7_24 0 0.9
Vwn_ih_7_24 wn_ih_7_24 0 0.3
Vwp_ih_8_24 wp_ih_8_24 0 0.8136449014345097
Vwn_ih_8_24 wn_ih_8_24 0 0.3
Vwp_ih_9_24 wp_ih_9_24 0 0.4732186447405365
Vwn_ih_9_24 wn_ih_9_24 0 0.5267813552594636
Vwp_ih_10_24 wp_ih_10_24 0 0.49686702223354495
Vwn_ih_10_24 wn_ih_10_24 0 0.503132977766455
Vwp_ih_11_24 wp_ih_11_24 0 0.8953237802757112
Vwn_ih_11_24 wn_ih_11_24 0 0.3
Vwp_ih_12_24 wp_ih_12_24 0 0.49270702428744934
Vwn_ih_12_24 wn_ih_12_24 0 0.5072929757125506
Vwp_ih_13_24 wp_ih_13_24 0 0.5950538708687066
Vwn_ih_13_24 wn_ih_13_24 0 0.40494612913129335
Vwp_ih_14_24 wp_ih_14_24 0 0.3
Vwn_ih_14_24 wn_ih_14_24 0 0.8004219070872682
Vwp_ih_15_24 wp_ih_15_24 0 0.4223538574620551
Vwn_ih_15_24 wn_ih_15_24 0 0.5776461425379449
Vwp_ho_24_0 wp_ho_24_0 0 0.7999421609820695
Vwn_ho_24_0 wn_ho_24_0 0 0.3
Vwp_ho_24_1 wp_ho_24_1 0 0.856788346701348
Vwn_ho_24_1 wn_ho_24_1 0 0.3
Vwp_ho_24_2 wp_ho_24_2 0 0.8618972060335948
Vwn_ho_24_2 wn_ho_24_2 0 0.3
Vwp_ho_24_3 wp_ho_24_3 0 0.6300934572939816
Vwn_ho_24_3 wn_ho_24_3 0 0.3699065427060184
Vwp_ho_24_4 wp_ho_24_4 0 0.6866643604958991
Vwn_ho_24_4 wn_ho_24_4 0 0.3133356395041009
Vwp_ih_0_25 wp_ih_0_25 0 0.4565591749313708
Vwn_ih_0_25 wn_ih_0_25 0 0.5434408250686292
Vwp_ih_1_25 wp_ih_1_25 0 0.4033798678453638
Vwn_ih_1_25 wn_ih_1_25 0 0.5966201321546363
Vwp_ih_2_25 wp_ih_2_25 0 0.47247478090055595
Vwn_ih_2_25 wn_ih_2_25 0 0.527525219099444
Vwp_ih_3_25 wp_ih_3_25 0 0.4675258578443413
Vwn_ih_3_25 wn_ih_3_25 0 0.5324741421556587
Vwp_ih_4_25 wp_ih_4_25 0 0.5173815861017989
Vwn_ih_4_25 wn_ih_4_25 0 0.4826184138982012
Vwp_ih_5_25 wp_ih_5_25 0 0.4451529402971099
Vwn_ih_5_25 wn_ih_5_25 0 0.5548470597028902
Vwp_ih_6_25 wp_ih_6_25 0 0.6044819381469545
Vwn_ih_6_25 wn_ih_6_25 0 0.3955180618530455
Vwp_ih_7_25 wp_ih_7_25 0 0.7549453381127642
Vwn_ih_7_25 wn_ih_7_25 0 0.3
Vwp_ih_8_25 wp_ih_8_25 0 0.7854089934160462
Vwn_ih_8_25 wn_ih_8_25 0 0.3
Vwp_ih_9_25 wp_ih_9_25 0 0.6239247139202982
Vwn_ih_9_25 wn_ih_9_25 0 0.3760752860797018
Vwp_ih_10_25 wp_ih_10_25 0 0.35234371724096675
Vwn_ih_10_25 wn_ih_10_25 0 0.6476562827590333
Vwp_ih_11_25 wp_ih_11_25 0 0.4356334829271903
Vwn_ih_11_25 wn_ih_11_25 0 0.5643665170728097
Vwp_ih_12_25 wp_ih_12_25 0 0.5851907873966137
Vwn_ih_12_25 wn_ih_12_25 0 0.4148092126033863
Vwp_ih_13_25 wp_ih_13_25 0 0.30202194855719844
Vwn_ih_13_25 wn_ih_13_25 0 0.6979780514428016
Vwp_ih_14_25 wp_ih_14_25 0 0.6483870101904377
Vwn_ih_14_25 wn_ih_14_25 0 0.35161298980956235
Vwp_ih_15_25 wp_ih_15_25 0 0.34737392965493585
Vwn_ih_15_25 wn_ih_15_25 0 0.6526260703450641
Vwp_ho_25_0 wp_ho_25_0 0 0.3
Vwn_ho_25_0 wn_ho_25_0 0 0.7078290212038947
Vwp_ho_25_1 wp_ho_25_1 0 0.5333516629524895
Vwn_ho_25_1 wn_ho_25_1 0 0.46664833704751046
Vwp_ho_25_2 wp_ho_25_2 0 0.6236697742608788
Vwn_ho_25_2 wn_ho_25_2 0 0.3763302257391212
Vwp_ho_25_3 wp_ho_25_3 0 0.3731363037608057
Vwn_ho_25_3 wn_ho_25_3 0 0.6268636962391942
Vwp_ho_25_4 wp_ho_25_4 0 0.5022412642692917
Vwn_ho_25_4 wn_ho_25_4 0 0.4977587357307083
Vwp_ih_0_26 wp_ih_0_26 0 0.5299542395623686
Vwn_ih_0_26 wn_ih_0_26 0 0.47004576043763135
Vwp_ih_1_26 wp_ih_1_26 0 0.37407889757847074
Vwn_ih_1_26 wn_ih_1_26 0 0.6259211024215292
Vwp_ih_2_26 wp_ih_2_26 0 0.4592537463621361
Vwn_ih_2_26 wn_ih_2_26 0 0.5407462536378639
Vwp_ih_3_26 wp_ih_3_26 0 0.4786113615838822
Vwn_ih_3_26 wn_ih_3_26 0 0.5213886384161178
Vwp_ih_4_26 wp_ih_4_26 0 0.5013588779989221
Vwn_ih_4_26 wn_ih_4_26 0 0.49864112200107785
Vwp_ih_5_26 wp_ih_5_26 0 0.4411932648417254
Vwn_ih_5_26 wn_ih_5_26 0 0.5588067351582746
Vwp_ih_6_26 wp_ih_6_26 0 0.6071537230540055
Vwn_ih_6_26 wn_ih_6_26 0 0.39284627694599455
Vwp_ih_7_26 wp_ih_7_26 0 0.3
Vwn_ih_7_26 wn_ih_7_26 0 0.7333013069428196
Vwp_ih_8_26 wp_ih_8_26 0 0.36847307838293564
Vwn_ih_8_26 wn_ih_8_26 0 0.6315269216170644
Vwp_ih_9_26 wp_ih_9_26 0 0.8310430131577504
Vwn_ih_9_26 wn_ih_9_26 0 0.3
Vwp_ih_10_26 wp_ih_10_26 0 0.4733413884349911
Vwn_ih_10_26 wn_ih_10_26 0 0.5266586115650089
Vwp_ih_11_26 wp_ih_11_26 0 0.36135937791865275
Vwn_ih_11_26 wn_ih_11_26 0 0.6386406220813472
Vwp_ih_12_26 wp_ih_12_26 0 0.6092847214214202
Vwn_ih_12_26 wn_ih_12_26 0 0.3907152785785798
Vwp_ih_13_26 wp_ih_13_26 0 0.3991309888104134
Vwn_ih_13_26 wn_ih_13_26 0 0.6008690111895866
Vwp_ih_14_26 wp_ih_14_26 0 0.3495704188005854
Vwn_ih_14_26 wn_ih_14_26 0 0.6504295811994145
Vwp_ih_15_26 wp_ih_15_26 0 0.4921440285060362
Vwn_ih_15_26 wn_ih_15_26 0 0.5078559714939638
Vwp_ho_26_0 wp_ho_26_0 0 0.3490965274499712
Vwn_ho_26_0 wn_ho_26_0 0 0.6509034725500288
Vwp_ho_26_1 wp_ho_26_1 0 0.6138253732588995
Vwn_ho_26_1 wn_ho_26_1 0 0.3861746267411005
Vwp_ho_26_2 wp_ho_26_2 0 0.8670465820637823
Vwn_ho_26_2 wn_ho_26_2 0 0.3
Vwp_ho_26_3 wp_ho_26_3 0 0.49490213312460885
Vwn_ho_26_3 wn_ho_26_3 0 0.5050978668753912
Vwp_ho_26_4 wp_ho_26_4 0 0.5716922555877283
Vwn_ho_26_4 wn_ho_26_4 0 0.4283077444122717
Vwp_ih_0_27 wp_ih_0_27 0 0.5148746047545065
Vwn_ih_0_27 wn_ih_0_27 0 0.4851253952454935
Vwp_ih_1_27 wp_ih_1_27 0 0.49938524235501286
Vwn_ih_1_27 wn_ih_1_27 0 0.5006147576449872
Vwp_ih_2_27 wp_ih_2_27 0 0.5420685514561674
Vwn_ih_2_27 wn_ih_2_27 0 0.45793144854383255
Vwp_ih_3_27 wp_ih_3_27 0 0.5288707369381194
Vwn_ih_3_27 wn_ih_3_27 0 0.4711292630618806
Vwp_ih_4_27 wp_ih_4_27 0 0.4994196502485734
Vwn_ih_4_27 wn_ih_4_27 0 0.5005803497514266
Vwp_ih_5_27 wp_ih_5_27 0 0.6039889914591038
Vwn_ih_5_27 wn_ih_5_27 0 0.39601100854089627
Vwp_ih_6_27 wp_ih_6_27 0 0.4300379088140792
Vwn_ih_6_27 wn_ih_6_27 0 0.5699620911859208
Vwp_ih_7_27 wp_ih_7_27 0 0.5157828426743892
Vwn_ih_7_27 wn_ih_7_27 0 0.48421715732561077
Vwp_ih_8_27 wp_ih_8_27 0 0.5712791328828231
Vwn_ih_8_27 wn_ih_8_27 0 0.428720867117177
Vwp_ih_9_27 wp_ih_9_27 0 0.5975547209029096
Vwn_ih_9_27 wn_ih_9_27 0 0.4024452790970904
Vwp_ih_10_27 wp_ih_10_27 0 0.6611031122617369
Vwn_ih_10_27 wn_ih_10_27 0 0.3388968877382631
Vwp_ih_11_27 wp_ih_11_27 0 0.6558666764909641
Vwn_ih_11_27 wn_ih_11_27 0 0.3441333235090359
Vwp_ih_12_27 wp_ih_12_27 0 0.512940744151012
Vwn_ih_12_27 wn_ih_12_27 0 0.487059255848988
Vwp_ih_13_27 wp_ih_13_27 0 0.31666962448840275
Vwn_ih_13_27 wn_ih_13_27 0 0.6833303755115973
Vwp_ih_14_27 wp_ih_14_27 0 0.6323708717260368
Vwn_ih_14_27 wn_ih_14_27 0 0.36762912827396327
Vwp_ih_15_27 wp_ih_15_27 0 0.4681011029259246
Vwn_ih_15_27 wn_ih_15_27 0 0.5318988970740754
Vwp_ho_27_0 wp_ho_27_0 0 0.7019677722150034
Vwn_ho_27_0 wn_ho_27_0 0 0.3
Vwp_ho_27_1 wp_ho_27_1 0 0.6881658952550574
Vwn_ho_27_1 wn_ho_27_1 0 0.31183410474494255
Vwp_ho_27_2 wp_ho_27_2 0 0.3
Vwn_ho_27_2 wn_ho_27_2 0 0.7336516499743168
Vwp_ho_27_3 wp_ho_27_3 0 0.5492640308463113
Vwn_ho_27_3 wn_ho_27_3 0 0.45073596915368874
Vwp_ho_27_4 wp_ho_27_4 0 0.6471360524805424
Vwn_ho_27_4 wn_ho_27_4 0 0.3528639475194576
Xcm_xh0 xhp0 xhn0 vdd cmld
Rnd_xh0 xhp0 xhn0 20k
X_ihx_0_0 a_xp0 a_xn0 wp_ih_0_0 wn_ih_0_0 xhp0 xhn0 vdd vbsyn gsyn
X_ihx_1_0 a_xp1 a_xn1 wp_ih_1_0 wn_ih_1_0 xhp0 xhn0 vdd vbsyn gsyn
X_ihx_2_0 a_xp2 a_xn2 wp_ih_2_0 wn_ih_2_0 xhp0 xhn0 vdd vbsyn gsyn
X_ihx_3_0 a_xp3 a_xn3 wp_ih_3_0 wn_ih_3_0 xhp0 xhn0 vdd vbsyn gsyn
X_ihx_4_0 a_xp4 a_xn4 wp_ih_4_0 wn_ih_4_0 xhp0 xhn0 vdd vbsyn gsyn
X_ihx_5_0 a_xp5 a_xn5 wp_ih_5_0 wn_ih_5_0 xhp0 xhn0 vdd vbsyn gsyn
X_ihx_6_0 a_xp6 a_xn6 wp_ih_6_0 wn_ih_6_0 xhp0 xhn0 vdd vbsyn gsyn
X_ihx_7_0 a_xp7 a_xn7 wp_ih_7_0 wn_ih_7_0 xhp0 xhn0 vdd vbsyn gsyn
X_ihx_8_0 a_xp8 a_xn8 wp_ih_8_0 wn_ih_8_0 xhp0 xhn0 vdd vbsyn gsyn
X_ihx_9_0 a_xp9 a_xn9 wp_ih_9_0 wn_ih_9_0 xhp0 xhn0 vdd vbsyn gsyn
X_ihx_10_0 a_xp10 a_xn10 wp_ih_10_0 wn_ih_10_0 xhp0 xhn0 vdd vbsyn gsyn
X_ihx_11_0 a_xp11 a_xn11 wp_ih_11_0 wn_ih_11_0 xhp0 xhn0 vdd vbsyn gsyn
X_ihx_12_0 a_xp12 a_xn12 wp_ih_12_0 wn_ih_12_0 xhp0 xhn0 vdd vbsyn gsyn
X_ihx_13_0 a_xp13 a_xn13 wp_ih_13_0 wn_ih_13_0 xhp0 xhn0 vdd vbsyn gsyn
X_ihx_14_0 a_xp14 a_xn14 wp_ih_14_0 wn_ih_14_0 xhp0 xhn0 vdd vbsyn gsyn
X_ihx_15_0 a_xp15 a_xn15 wp_ih_15_0 wn_ih_15_0 xhp0 xhn0 vdd vbsyn gsyn
Xn0 xhp0 xhn0 ahp0 ahn0 vdd vbneu dneuron
Xcm_xh1 xhp1 xhn1 vdd cmld
Rnd_xh1 xhp1 xhn1 20k
X_ihx_0_1 a_xp0 a_xn0 wp_ih_0_1 wn_ih_0_1 xhp1 xhn1 vdd vbsyn gsyn
X_ihx_1_1 a_xp1 a_xn1 wp_ih_1_1 wn_ih_1_1 xhp1 xhn1 vdd vbsyn gsyn
X_ihx_2_1 a_xp2 a_xn2 wp_ih_2_1 wn_ih_2_1 xhp1 xhn1 vdd vbsyn gsyn
X_ihx_3_1 a_xp3 a_xn3 wp_ih_3_1 wn_ih_3_1 xhp1 xhn1 vdd vbsyn gsyn
X_ihx_4_1 a_xp4 a_xn4 wp_ih_4_1 wn_ih_4_1 xhp1 xhn1 vdd vbsyn gsyn
X_ihx_5_1 a_xp5 a_xn5 wp_ih_5_1 wn_ih_5_1 xhp1 xhn1 vdd vbsyn gsyn
X_ihx_6_1 a_xp6 a_xn6 wp_ih_6_1 wn_ih_6_1 xhp1 xhn1 vdd vbsyn gsyn
X_ihx_7_1 a_xp7 a_xn7 wp_ih_7_1 wn_ih_7_1 xhp1 xhn1 vdd vbsyn gsyn
X_ihx_8_1 a_xp8 a_xn8 wp_ih_8_1 wn_ih_8_1 xhp1 xhn1 vdd vbsyn gsyn
X_ihx_9_1 a_xp9 a_xn9 wp_ih_9_1 wn_ih_9_1 xhp1 xhn1 vdd vbsyn gsyn
X_ihx_10_1 a_xp10 a_xn10 wp_ih_10_1 wn_ih_10_1 xhp1 xhn1 vdd vbsyn gsyn
X_ihx_11_1 a_xp11 a_xn11 wp_ih_11_1 wn_ih_11_1 xhp1 xhn1 vdd vbsyn gsyn
X_ihx_12_1 a_xp12 a_xn12 wp_ih_12_1 wn_ih_12_1 xhp1 xhn1 vdd vbsyn gsyn
X_ihx_13_1 a_xp13 a_xn13 wp_ih_13_1 wn_ih_13_1 xhp1 xhn1 vdd vbsyn gsyn
X_ihx_14_1 a_xp14 a_xn14 wp_ih_14_1 wn_ih_14_1 xhp1 xhn1 vdd vbsyn gsyn
X_ihx_15_1 a_xp15 a_xn15 wp_ih_15_1 wn_ih_15_1 xhp1 xhn1 vdd vbsyn gsyn
Xn1 xhp1 xhn1 ahp1 ahn1 vdd vbneu dneuron
Xcm_xh2 xhp2 xhn2 vdd cmld
Rnd_xh2 xhp2 xhn2 20k
X_ihx_0_2 a_xp0 a_xn0 wp_ih_0_2 wn_ih_0_2 xhp2 xhn2 vdd vbsyn gsyn
X_ihx_1_2 a_xp1 a_xn1 wp_ih_1_2 wn_ih_1_2 xhp2 xhn2 vdd vbsyn gsyn
X_ihx_2_2 a_xp2 a_xn2 wp_ih_2_2 wn_ih_2_2 xhp2 xhn2 vdd vbsyn gsyn
X_ihx_3_2 a_xp3 a_xn3 wp_ih_3_2 wn_ih_3_2 xhp2 xhn2 vdd vbsyn gsyn
X_ihx_4_2 a_xp4 a_xn4 wp_ih_4_2 wn_ih_4_2 xhp2 xhn2 vdd vbsyn gsyn
X_ihx_5_2 a_xp5 a_xn5 wp_ih_5_2 wn_ih_5_2 xhp2 xhn2 vdd vbsyn gsyn
X_ihx_6_2 a_xp6 a_xn6 wp_ih_6_2 wn_ih_6_2 xhp2 xhn2 vdd vbsyn gsyn
X_ihx_7_2 a_xp7 a_xn7 wp_ih_7_2 wn_ih_7_2 xhp2 xhn2 vdd vbsyn gsyn
X_ihx_8_2 a_xp8 a_xn8 wp_ih_8_2 wn_ih_8_2 xhp2 xhn2 vdd vbsyn gsyn
X_ihx_9_2 a_xp9 a_xn9 wp_ih_9_2 wn_ih_9_2 xhp2 xhn2 vdd vbsyn gsyn
X_ihx_10_2 a_xp10 a_xn10 wp_ih_10_2 wn_ih_10_2 xhp2 xhn2 vdd vbsyn gsyn
X_ihx_11_2 a_xp11 a_xn11 wp_ih_11_2 wn_ih_11_2 xhp2 xhn2 vdd vbsyn gsyn
X_ihx_12_2 a_xp12 a_xn12 wp_ih_12_2 wn_ih_12_2 xhp2 xhn2 vdd vbsyn gsyn
X_ihx_13_2 a_xp13 a_xn13 wp_ih_13_2 wn_ih_13_2 xhp2 xhn2 vdd vbsyn gsyn
X_ihx_14_2 a_xp14 a_xn14 wp_ih_14_2 wn_ih_14_2 xhp2 xhn2 vdd vbsyn gsyn
X_ihx_15_2 a_xp15 a_xn15 wp_ih_15_2 wn_ih_15_2 xhp2 xhn2 vdd vbsyn gsyn
Xn2 xhp2 xhn2 ahp2 ahn2 vdd vbneu dneuron
Xcm_xh3 xhp3 xhn3 vdd cmld
Rnd_xh3 xhp3 xhn3 20k
X_ihx_0_3 a_xp0 a_xn0 wp_ih_0_3 wn_ih_0_3 xhp3 xhn3 vdd vbsyn gsyn
X_ihx_1_3 a_xp1 a_xn1 wp_ih_1_3 wn_ih_1_3 xhp3 xhn3 vdd vbsyn gsyn
X_ihx_2_3 a_xp2 a_xn2 wp_ih_2_3 wn_ih_2_3 xhp3 xhn3 vdd vbsyn gsyn
X_ihx_3_3 a_xp3 a_xn3 wp_ih_3_3 wn_ih_3_3 xhp3 xhn3 vdd vbsyn gsyn
X_ihx_4_3 a_xp4 a_xn4 wp_ih_4_3 wn_ih_4_3 xhp3 xhn3 vdd vbsyn gsyn
X_ihx_5_3 a_xp5 a_xn5 wp_ih_5_3 wn_ih_5_3 xhp3 xhn3 vdd vbsyn gsyn
X_ihx_6_3 a_xp6 a_xn6 wp_ih_6_3 wn_ih_6_3 xhp3 xhn3 vdd vbsyn gsyn
X_ihx_7_3 a_xp7 a_xn7 wp_ih_7_3 wn_ih_7_3 xhp3 xhn3 vdd vbsyn gsyn
X_ihx_8_3 a_xp8 a_xn8 wp_ih_8_3 wn_ih_8_3 xhp3 xhn3 vdd vbsyn gsyn
X_ihx_9_3 a_xp9 a_xn9 wp_ih_9_3 wn_ih_9_3 xhp3 xhn3 vdd vbsyn gsyn
X_ihx_10_3 a_xp10 a_xn10 wp_ih_10_3 wn_ih_10_3 xhp3 xhn3 vdd vbsyn gsyn
X_ihx_11_3 a_xp11 a_xn11 wp_ih_11_3 wn_ih_11_3 xhp3 xhn3 vdd vbsyn gsyn
X_ihx_12_3 a_xp12 a_xn12 wp_ih_12_3 wn_ih_12_3 xhp3 xhn3 vdd vbsyn gsyn
X_ihx_13_3 a_xp13 a_xn13 wp_ih_13_3 wn_ih_13_3 xhp3 xhn3 vdd vbsyn gsyn
X_ihx_14_3 a_xp14 a_xn14 wp_ih_14_3 wn_ih_14_3 xhp3 xhn3 vdd vbsyn gsyn
X_ihx_15_3 a_xp15 a_xn15 wp_ih_15_3 wn_ih_15_3 xhp3 xhn3 vdd vbsyn gsyn
Xn3 xhp3 xhn3 ahp3 ahn3 vdd vbneu dneuron
Xcm_xh4 xhp4 xhn4 vdd cmld
Rnd_xh4 xhp4 xhn4 20k
X_ihx_0_4 a_xp0 a_xn0 wp_ih_0_4 wn_ih_0_4 xhp4 xhn4 vdd vbsyn gsyn
X_ihx_1_4 a_xp1 a_xn1 wp_ih_1_4 wn_ih_1_4 xhp4 xhn4 vdd vbsyn gsyn
X_ihx_2_4 a_xp2 a_xn2 wp_ih_2_4 wn_ih_2_4 xhp4 xhn4 vdd vbsyn gsyn
X_ihx_3_4 a_xp3 a_xn3 wp_ih_3_4 wn_ih_3_4 xhp4 xhn4 vdd vbsyn gsyn
X_ihx_4_4 a_xp4 a_xn4 wp_ih_4_4 wn_ih_4_4 xhp4 xhn4 vdd vbsyn gsyn
X_ihx_5_4 a_xp5 a_xn5 wp_ih_5_4 wn_ih_5_4 xhp4 xhn4 vdd vbsyn gsyn
X_ihx_6_4 a_xp6 a_xn6 wp_ih_6_4 wn_ih_6_4 xhp4 xhn4 vdd vbsyn gsyn
X_ihx_7_4 a_xp7 a_xn7 wp_ih_7_4 wn_ih_7_4 xhp4 xhn4 vdd vbsyn gsyn
X_ihx_8_4 a_xp8 a_xn8 wp_ih_8_4 wn_ih_8_4 xhp4 xhn4 vdd vbsyn gsyn
X_ihx_9_4 a_xp9 a_xn9 wp_ih_9_4 wn_ih_9_4 xhp4 xhn4 vdd vbsyn gsyn
X_ihx_10_4 a_xp10 a_xn10 wp_ih_10_4 wn_ih_10_4 xhp4 xhn4 vdd vbsyn gsyn
X_ihx_11_4 a_xp11 a_xn11 wp_ih_11_4 wn_ih_11_4 xhp4 xhn4 vdd vbsyn gsyn
X_ihx_12_4 a_xp12 a_xn12 wp_ih_12_4 wn_ih_12_4 xhp4 xhn4 vdd vbsyn gsyn
X_ihx_13_4 a_xp13 a_xn13 wp_ih_13_4 wn_ih_13_4 xhp4 xhn4 vdd vbsyn gsyn
X_ihx_14_4 a_xp14 a_xn14 wp_ih_14_4 wn_ih_14_4 xhp4 xhn4 vdd vbsyn gsyn
X_ihx_15_4 a_xp15 a_xn15 wp_ih_15_4 wn_ih_15_4 xhp4 xhn4 vdd vbsyn gsyn
Xn4 xhp4 xhn4 ahp4 ahn4 vdd vbneu dneuron
Xcm_xh5 xhp5 xhn5 vdd cmld
Rnd_xh5 xhp5 xhn5 20k
X_ihx_0_5 a_xp0 a_xn0 wp_ih_0_5 wn_ih_0_5 xhp5 xhn5 vdd vbsyn gsyn
X_ihx_1_5 a_xp1 a_xn1 wp_ih_1_5 wn_ih_1_5 xhp5 xhn5 vdd vbsyn gsyn
X_ihx_2_5 a_xp2 a_xn2 wp_ih_2_5 wn_ih_2_5 xhp5 xhn5 vdd vbsyn gsyn
X_ihx_3_5 a_xp3 a_xn3 wp_ih_3_5 wn_ih_3_5 xhp5 xhn5 vdd vbsyn gsyn
X_ihx_4_5 a_xp4 a_xn4 wp_ih_4_5 wn_ih_4_5 xhp5 xhn5 vdd vbsyn gsyn
X_ihx_5_5 a_xp5 a_xn5 wp_ih_5_5 wn_ih_5_5 xhp5 xhn5 vdd vbsyn gsyn
X_ihx_6_5 a_xp6 a_xn6 wp_ih_6_5 wn_ih_6_5 xhp5 xhn5 vdd vbsyn gsyn
X_ihx_7_5 a_xp7 a_xn7 wp_ih_7_5 wn_ih_7_5 xhp5 xhn5 vdd vbsyn gsyn
X_ihx_8_5 a_xp8 a_xn8 wp_ih_8_5 wn_ih_8_5 xhp5 xhn5 vdd vbsyn gsyn
X_ihx_9_5 a_xp9 a_xn9 wp_ih_9_5 wn_ih_9_5 xhp5 xhn5 vdd vbsyn gsyn
X_ihx_10_5 a_xp10 a_xn10 wp_ih_10_5 wn_ih_10_5 xhp5 xhn5 vdd vbsyn gsyn
X_ihx_11_5 a_xp11 a_xn11 wp_ih_11_5 wn_ih_11_5 xhp5 xhn5 vdd vbsyn gsyn
X_ihx_12_5 a_xp12 a_xn12 wp_ih_12_5 wn_ih_12_5 xhp5 xhn5 vdd vbsyn gsyn
X_ihx_13_5 a_xp13 a_xn13 wp_ih_13_5 wn_ih_13_5 xhp5 xhn5 vdd vbsyn gsyn
X_ihx_14_5 a_xp14 a_xn14 wp_ih_14_5 wn_ih_14_5 xhp5 xhn5 vdd vbsyn gsyn
X_ihx_15_5 a_xp15 a_xn15 wp_ih_15_5 wn_ih_15_5 xhp5 xhn5 vdd vbsyn gsyn
Xn5 xhp5 xhn5 ahp5 ahn5 vdd vbneu dneuron
Xcm_xh6 xhp6 xhn6 vdd cmld
Rnd_xh6 xhp6 xhn6 20k
X_ihx_0_6 a_xp0 a_xn0 wp_ih_0_6 wn_ih_0_6 xhp6 xhn6 vdd vbsyn gsyn
X_ihx_1_6 a_xp1 a_xn1 wp_ih_1_6 wn_ih_1_6 xhp6 xhn6 vdd vbsyn gsyn
X_ihx_2_6 a_xp2 a_xn2 wp_ih_2_6 wn_ih_2_6 xhp6 xhn6 vdd vbsyn gsyn
X_ihx_3_6 a_xp3 a_xn3 wp_ih_3_6 wn_ih_3_6 xhp6 xhn6 vdd vbsyn gsyn
X_ihx_4_6 a_xp4 a_xn4 wp_ih_4_6 wn_ih_4_6 xhp6 xhn6 vdd vbsyn gsyn
X_ihx_5_6 a_xp5 a_xn5 wp_ih_5_6 wn_ih_5_6 xhp6 xhn6 vdd vbsyn gsyn
X_ihx_6_6 a_xp6 a_xn6 wp_ih_6_6 wn_ih_6_6 xhp6 xhn6 vdd vbsyn gsyn
X_ihx_7_6 a_xp7 a_xn7 wp_ih_7_6 wn_ih_7_6 xhp6 xhn6 vdd vbsyn gsyn
X_ihx_8_6 a_xp8 a_xn8 wp_ih_8_6 wn_ih_8_6 xhp6 xhn6 vdd vbsyn gsyn
X_ihx_9_6 a_xp9 a_xn9 wp_ih_9_6 wn_ih_9_6 xhp6 xhn6 vdd vbsyn gsyn
X_ihx_10_6 a_xp10 a_xn10 wp_ih_10_6 wn_ih_10_6 xhp6 xhn6 vdd vbsyn gsyn
X_ihx_11_6 a_xp11 a_xn11 wp_ih_11_6 wn_ih_11_6 xhp6 xhn6 vdd vbsyn gsyn
X_ihx_12_6 a_xp12 a_xn12 wp_ih_12_6 wn_ih_12_6 xhp6 xhn6 vdd vbsyn gsyn
X_ihx_13_6 a_xp13 a_xn13 wp_ih_13_6 wn_ih_13_6 xhp6 xhn6 vdd vbsyn gsyn
X_ihx_14_6 a_xp14 a_xn14 wp_ih_14_6 wn_ih_14_6 xhp6 xhn6 vdd vbsyn gsyn
X_ihx_15_6 a_xp15 a_xn15 wp_ih_15_6 wn_ih_15_6 xhp6 xhn6 vdd vbsyn gsyn
Xn6 xhp6 xhn6 ahp6 ahn6 vdd vbneu dneuron
Xcm_xh7 xhp7 xhn7 vdd cmld
Rnd_xh7 xhp7 xhn7 20k
X_ihx_0_7 a_xp0 a_xn0 wp_ih_0_7 wn_ih_0_7 xhp7 xhn7 vdd vbsyn gsyn
X_ihx_1_7 a_xp1 a_xn1 wp_ih_1_7 wn_ih_1_7 xhp7 xhn7 vdd vbsyn gsyn
X_ihx_2_7 a_xp2 a_xn2 wp_ih_2_7 wn_ih_2_7 xhp7 xhn7 vdd vbsyn gsyn
X_ihx_3_7 a_xp3 a_xn3 wp_ih_3_7 wn_ih_3_7 xhp7 xhn7 vdd vbsyn gsyn
X_ihx_4_7 a_xp4 a_xn4 wp_ih_4_7 wn_ih_4_7 xhp7 xhn7 vdd vbsyn gsyn
X_ihx_5_7 a_xp5 a_xn5 wp_ih_5_7 wn_ih_5_7 xhp7 xhn7 vdd vbsyn gsyn
X_ihx_6_7 a_xp6 a_xn6 wp_ih_6_7 wn_ih_6_7 xhp7 xhn7 vdd vbsyn gsyn
X_ihx_7_7 a_xp7 a_xn7 wp_ih_7_7 wn_ih_7_7 xhp7 xhn7 vdd vbsyn gsyn
X_ihx_8_7 a_xp8 a_xn8 wp_ih_8_7 wn_ih_8_7 xhp7 xhn7 vdd vbsyn gsyn
X_ihx_9_7 a_xp9 a_xn9 wp_ih_9_7 wn_ih_9_7 xhp7 xhn7 vdd vbsyn gsyn
X_ihx_10_7 a_xp10 a_xn10 wp_ih_10_7 wn_ih_10_7 xhp7 xhn7 vdd vbsyn gsyn
X_ihx_11_7 a_xp11 a_xn11 wp_ih_11_7 wn_ih_11_7 xhp7 xhn7 vdd vbsyn gsyn
X_ihx_12_7 a_xp12 a_xn12 wp_ih_12_7 wn_ih_12_7 xhp7 xhn7 vdd vbsyn gsyn
X_ihx_13_7 a_xp13 a_xn13 wp_ih_13_7 wn_ih_13_7 xhp7 xhn7 vdd vbsyn gsyn
X_ihx_14_7 a_xp14 a_xn14 wp_ih_14_7 wn_ih_14_7 xhp7 xhn7 vdd vbsyn gsyn
X_ihx_15_7 a_xp15 a_xn15 wp_ih_15_7 wn_ih_15_7 xhp7 xhn7 vdd vbsyn gsyn
Xn7 xhp7 xhn7 ahp7 ahn7 vdd vbneu dneuron
Xcm_xh8 xhp8 xhn8 vdd cmld
Rnd_xh8 xhp8 xhn8 20k
X_ihx_0_8 a_xp0 a_xn0 wp_ih_0_8 wn_ih_0_8 xhp8 xhn8 vdd vbsyn gsyn
X_ihx_1_8 a_xp1 a_xn1 wp_ih_1_8 wn_ih_1_8 xhp8 xhn8 vdd vbsyn gsyn
X_ihx_2_8 a_xp2 a_xn2 wp_ih_2_8 wn_ih_2_8 xhp8 xhn8 vdd vbsyn gsyn
X_ihx_3_8 a_xp3 a_xn3 wp_ih_3_8 wn_ih_3_8 xhp8 xhn8 vdd vbsyn gsyn
X_ihx_4_8 a_xp4 a_xn4 wp_ih_4_8 wn_ih_4_8 xhp8 xhn8 vdd vbsyn gsyn
X_ihx_5_8 a_xp5 a_xn5 wp_ih_5_8 wn_ih_5_8 xhp8 xhn8 vdd vbsyn gsyn
X_ihx_6_8 a_xp6 a_xn6 wp_ih_6_8 wn_ih_6_8 xhp8 xhn8 vdd vbsyn gsyn
X_ihx_7_8 a_xp7 a_xn7 wp_ih_7_8 wn_ih_7_8 xhp8 xhn8 vdd vbsyn gsyn
X_ihx_8_8 a_xp8 a_xn8 wp_ih_8_8 wn_ih_8_8 xhp8 xhn8 vdd vbsyn gsyn
X_ihx_9_8 a_xp9 a_xn9 wp_ih_9_8 wn_ih_9_8 xhp8 xhn8 vdd vbsyn gsyn
X_ihx_10_8 a_xp10 a_xn10 wp_ih_10_8 wn_ih_10_8 xhp8 xhn8 vdd vbsyn gsyn
X_ihx_11_8 a_xp11 a_xn11 wp_ih_11_8 wn_ih_11_8 xhp8 xhn8 vdd vbsyn gsyn
X_ihx_12_8 a_xp12 a_xn12 wp_ih_12_8 wn_ih_12_8 xhp8 xhn8 vdd vbsyn gsyn
X_ihx_13_8 a_xp13 a_xn13 wp_ih_13_8 wn_ih_13_8 xhp8 xhn8 vdd vbsyn gsyn
X_ihx_14_8 a_xp14 a_xn14 wp_ih_14_8 wn_ih_14_8 xhp8 xhn8 vdd vbsyn gsyn
X_ihx_15_8 a_xp15 a_xn15 wp_ih_15_8 wn_ih_15_8 xhp8 xhn8 vdd vbsyn gsyn
Xn8 xhp8 xhn8 ahp8 ahn8 vdd vbneu dneuron
Xcm_xh9 xhp9 xhn9 vdd cmld
Rnd_xh9 xhp9 xhn9 20k
X_ihx_0_9 a_xp0 a_xn0 wp_ih_0_9 wn_ih_0_9 xhp9 xhn9 vdd vbsyn gsyn
X_ihx_1_9 a_xp1 a_xn1 wp_ih_1_9 wn_ih_1_9 xhp9 xhn9 vdd vbsyn gsyn
X_ihx_2_9 a_xp2 a_xn2 wp_ih_2_9 wn_ih_2_9 xhp9 xhn9 vdd vbsyn gsyn
X_ihx_3_9 a_xp3 a_xn3 wp_ih_3_9 wn_ih_3_9 xhp9 xhn9 vdd vbsyn gsyn
X_ihx_4_9 a_xp4 a_xn4 wp_ih_4_9 wn_ih_4_9 xhp9 xhn9 vdd vbsyn gsyn
X_ihx_5_9 a_xp5 a_xn5 wp_ih_5_9 wn_ih_5_9 xhp9 xhn9 vdd vbsyn gsyn
X_ihx_6_9 a_xp6 a_xn6 wp_ih_6_9 wn_ih_6_9 xhp9 xhn9 vdd vbsyn gsyn
X_ihx_7_9 a_xp7 a_xn7 wp_ih_7_9 wn_ih_7_9 xhp9 xhn9 vdd vbsyn gsyn
X_ihx_8_9 a_xp8 a_xn8 wp_ih_8_9 wn_ih_8_9 xhp9 xhn9 vdd vbsyn gsyn
X_ihx_9_9 a_xp9 a_xn9 wp_ih_9_9 wn_ih_9_9 xhp9 xhn9 vdd vbsyn gsyn
X_ihx_10_9 a_xp10 a_xn10 wp_ih_10_9 wn_ih_10_9 xhp9 xhn9 vdd vbsyn gsyn
X_ihx_11_9 a_xp11 a_xn11 wp_ih_11_9 wn_ih_11_9 xhp9 xhn9 vdd vbsyn gsyn
X_ihx_12_9 a_xp12 a_xn12 wp_ih_12_9 wn_ih_12_9 xhp9 xhn9 vdd vbsyn gsyn
X_ihx_13_9 a_xp13 a_xn13 wp_ih_13_9 wn_ih_13_9 xhp9 xhn9 vdd vbsyn gsyn
X_ihx_14_9 a_xp14 a_xn14 wp_ih_14_9 wn_ih_14_9 xhp9 xhn9 vdd vbsyn gsyn
X_ihx_15_9 a_xp15 a_xn15 wp_ih_15_9 wn_ih_15_9 xhp9 xhn9 vdd vbsyn gsyn
Xn9 xhp9 xhn9 ahp9 ahn9 vdd vbneu dneuron
Xcm_xh10 xhp10 xhn10 vdd cmld
Rnd_xh10 xhp10 xhn10 20k
X_ihx_0_10 a_xp0 a_xn0 wp_ih_0_10 wn_ih_0_10 xhp10 xhn10 vdd vbsyn gsyn
X_ihx_1_10 a_xp1 a_xn1 wp_ih_1_10 wn_ih_1_10 xhp10 xhn10 vdd vbsyn gsyn
X_ihx_2_10 a_xp2 a_xn2 wp_ih_2_10 wn_ih_2_10 xhp10 xhn10 vdd vbsyn gsyn
X_ihx_3_10 a_xp3 a_xn3 wp_ih_3_10 wn_ih_3_10 xhp10 xhn10 vdd vbsyn gsyn
X_ihx_4_10 a_xp4 a_xn4 wp_ih_4_10 wn_ih_4_10 xhp10 xhn10 vdd vbsyn gsyn
X_ihx_5_10 a_xp5 a_xn5 wp_ih_5_10 wn_ih_5_10 xhp10 xhn10 vdd vbsyn gsyn
X_ihx_6_10 a_xp6 a_xn6 wp_ih_6_10 wn_ih_6_10 xhp10 xhn10 vdd vbsyn gsyn
X_ihx_7_10 a_xp7 a_xn7 wp_ih_7_10 wn_ih_7_10 xhp10 xhn10 vdd vbsyn gsyn
X_ihx_8_10 a_xp8 a_xn8 wp_ih_8_10 wn_ih_8_10 xhp10 xhn10 vdd vbsyn gsyn
X_ihx_9_10 a_xp9 a_xn9 wp_ih_9_10 wn_ih_9_10 xhp10 xhn10 vdd vbsyn gsyn
X_ihx_10_10 a_xp10 a_xn10 wp_ih_10_10 wn_ih_10_10 xhp10 xhn10 vdd vbsyn gsyn
X_ihx_11_10 a_xp11 a_xn11 wp_ih_11_10 wn_ih_11_10 xhp10 xhn10 vdd vbsyn gsyn
X_ihx_12_10 a_xp12 a_xn12 wp_ih_12_10 wn_ih_12_10 xhp10 xhn10 vdd vbsyn gsyn
X_ihx_13_10 a_xp13 a_xn13 wp_ih_13_10 wn_ih_13_10 xhp10 xhn10 vdd vbsyn gsyn
X_ihx_14_10 a_xp14 a_xn14 wp_ih_14_10 wn_ih_14_10 xhp10 xhn10 vdd vbsyn gsyn
X_ihx_15_10 a_xp15 a_xn15 wp_ih_15_10 wn_ih_15_10 xhp10 xhn10 vdd vbsyn gsyn
Xn10 xhp10 xhn10 ahp10 ahn10 vdd vbneu dneuron
Xcm_xh11 xhp11 xhn11 vdd cmld
Rnd_xh11 xhp11 xhn11 20k
X_ihx_0_11 a_xp0 a_xn0 wp_ih_0_11 wn_ih_0_11 xhp11 xhn11 vdd vbsyn gsyn
X_ihx_1_11 a_xp1 a_xn1 wp_ih_1_11 wn_ih_1_11 xhp11 xhn11 vdd vbsyn gsyn
X_ihx_2_11 a_xp2 a_xn2 wp_ih_2_11 wn_ih_2_11 xhp11 xhn11 vdd vbsyn gsyn
X_ihx_3_11 a_xp3 a_xn3 wp_ih_3_11 wn_ih_3_11 xhp11 xhn11 vdd vbsyn gsyn
X_ihx_4_11 a_xp4 a_xn4 wp_ih_4_11 wn_ih_4_11 xhp11 xhn11 vdd vbsyn gsyn
X_ihx_5_11 a_xp5 a_xn5 wp_ih_5_11 wn_ih_5_11 xhp11 xhn11 vdd vbsyn gsyn
X_ihx_6_11 a_xp6 a_xn6 wp_ih_6_11 wn_ih_6_11 xhp11 xhn11 vdd vbsyn gsyn
X_ihx_7_11 a_xp7 a_xn7 wp_ih_7_11 wn_ih_7_11 xhp11 xhn11 vdd vbsyn gsyn
X_ihx_8_11 a_xp8 a_xn8 wp_ih_8_11 wn_ih_8_11 xhp11 xhn11 vdd vbsyn gsyn
X_ihx_9_11 a_xp9 a_xn9 wp_ih_9_11 wn_ih_9_11 xhp11 xhn11 vdd vbsyn gsyn
X_ihx_10_11 a_xp10 a_xn10 wp_ih_10_11 wn_ih_10_11 xhp11 xhn11 vdd vbsyn gsyn
X_ihx_11_11 a_xp11 a_xn11 wp_ih_11_11 wn_ih_11_11 xhp11 xhn11 vdd vbsyn gsyn
X_ihx_12_11 a_xp12 a_xn12 wp_ih_12_11 wn_ih_12_11 xhp11 xhn11 vdd vbsyn gsyn
X_ihx_13_11 a_xp13 a_xn13 wp_ih_13_11 wn_ih_13_11 xhp11 xhn11 vdd vbsyn gsyn
X_ihx_14_11 a_xp14 a_xn14 wp_ih_14_11 wn_ih_14_11 xhp11 xhn11 vdd vbsyn gsyn
X_ihx_15_11 a_xp15 a_xn15 wp_ih_15_11 wn_ih_15_11 xhp11 xhn11 vdd vbsyn gsyn
Xn11 xhp11 xhn11 ahp11 ahn11 vdd vbneu dneuron
Xcm_xh12 xhp12 xhn12 vdd cmld
Rnd_xh12 xhp12 xhn12 20k
X_ihx_0_12 a_xp0 a_xn0 wp_ih_0_12 wn_ih_0_12 xhp12 xhn12 vdd vbsyn gsyn
X_ihx_1_12 a_xp1 a_xn1 wp_ih_1_12 wn_ih_1_12 xhp12 xhn12 vdd vbsyn gsyn
X_ihx_2_12 a_xp2 a_xn2 wp_ih_2_12 wn_ih_2_12 xhp12 xhn12 vdd vbsyn gsyn
X_ihx_3_12 a_xp3 a_xn3 wp_ih_3_12 wn_ih_3_12 xhp12 xhn12 vdd vbsyn gsyn
X_ihx_4_12 a_xp4 a_xn4 wp_ih_4_12 wn_ih_4_12 xhp12 xhn12 vdd vbsyn gsyn
X_ihx_5_12 a_xp5 a_xn5 wp_ih_5_12 wn_ih_5_12 xhp12 xhn12 vdd vbsyn gsyn
X_ihx_6_12 a_xp6 a_xn6 wp_ih_6_12 wn_ih_6_12 xhp12 xhn12 vdd vbsyn gsyn
X_ihx_7_12 a_xp7 a_xn7 wp_ih_7_12 wn_ih_7_12 xhp12 xhn12 vdd vbsyn gsyn
X_ihx_8_12 a_xp8 a_xn8 wp_ih_8_12 wn_ih_8_12 xhp12 xhn12 vdd vbsyn gsyn
X_ihx_9_12 a_xp9 a_xn9 wp_ih_9_12 wn_ih_9_12 xhp12 xhn12 vdd vbsyn gsyn
X_ihx_10_12 a_xp10 a_xn10 wp_ih_10_12 wn_ih_10_12 xhp12 xhn12 vdd vbsyn gsyn
X_ihx_11_12 a_xp11 a_xn11 wp_ih_11_12 wn_ih_11_12 xhp12 xhn12 vdd vbsyn gsyn
X_ihx_12_12 a_xp12 a_xn12 wp_ih_12_12 wn_ih_12_12 xhp12 xhn12 vdd vbsyn gsyn
X_ihx_13_12 a_xp13 a_xn13 wp_ih_13_12 wn_ih_13_12 xhp12 xhn12 vdd vbsyn gsyn
X_ihx_14_12 a_xp14 a_xn14 wp_ih_14_12 wn_ih_14_12 xhp12 xhn12 vdd vbsyn gsyn
X_ihx_15_12 a_xp15 a_xn15 wp_ih_15_12 wn_ih_15_12 xhp12 xhn12 vdd vbsyn gsyn
Xn12 xhp12 xhn12 ahp12 ahn12 vdd vbneu dneuron
Xcm_xh13 xhp13 xhn13 vdd cmld
Rnd_xh13 xhp13 xhn13 20k
X_ihx_0_13 a_xp0 a_xn0 wp_ih_0_13 wn_ih_0_13 xhp13 xhn13 vdd vbsyn gsyn
X_ihx_1_13 a_xp1 a_xn1 wp_ih_1_13 wn_ih_1_13 xhp13 xhn13 vdd vbsyn gsyn
X_ihx_2_13 a_xp2 a_xn2 wp_ih_2_13 wn_ih_2_13 xhp13 xhn13 vdd vbsyn gsyn
X_ihx_3_13 a_xp3 a_xn3 wp_ih_3_13 wn_ih_3_13 xhp13 xhn13 vdd vbsyn gsyn
X_ihx_4_13 a_xp4 a_xn4 wp_ih_4_13 wn_ih_4_13 xhp13 xhn13 vdd vbsyn gsyn
X_ihx_5_13 a_xp5 a_xn5 wp_ih_5_13 wn_ih_5_13 xhp13 xhn13 vdd vbsyn gsyn
X_ihx_6_13 a_xp6 a_xn6 wp_ih_6_13 wn_ih_6_13 xhp13 xhn13 vdd vbsyn gsyn
X_ihx_7_13 a_xp7 a_xn7 wp_ih_7_13 wn_ih_7_13 xhp13 xhn13 vdd vbsyn gsyn
X_ihx_8_13 a_xp8 a_xn8 wp_ih_8_13 wn_ih_8_13 xhp13 xhn13 vdd vbsyn gsyn
X_ihx_9_13 a_xp9 a_xn9 wp_ih_9_13 wn_ih_9_13 xhp13 xhn13 vdd vbsyn gsyn
X_ihx_10_13 a_xp10 a_xn10 wp_ih_10_13 wn_ih_10_13 xhp13 xhn13 vdd vbsyn gsyn
X_ihx_11_13 a_xp11 a_xn11 wp_ih_11_13 wn_ih_11_13 xhp13 xhn13 vdd vbsyn gsyn
X_ihx_12_13 a_xp12 a_xn12 wp_ih_12_13 wn_ih_12_13 xhp13 xhn13 vdd vbsyn gsyn
X_ihx_13_13 a_xp13 a_xn13 wp_ih_13_13 wn_ih_13_13 xhp13 xhn13 vdd vbsyn gsyn
X_ihx_14_13 a_xp14 a_xn14 wp_ih_14_13 wn_ih_14_13 xhp13 xhn13 vdd vbsyn gsyn
X_ihx_15_13 a_xp15 a_xn15 wp_ih_15_13 wn_ih_15_13 xhp13 xhn13 vdd vbsyn gsyn
Xn13 xhp13 xhn13 ahp13 ahn13 vdd vbneu dneuron
Xcm_xh14 xhp14 xhn14 vdd cmld
Rnd_xh14 xhp14 xhn14 20k
X_ihx_0_14 a_xp0 a_xn0 wp_ih_0_14 wn_ih_0_14 xhp14 xhn14 vdd vbsyn gsyn
X_ihx_1_14 a_xp1 a_xn1 wp_ih_1_14 wn_ih_1_14 xhp14 xhn14 vdd vbsyn gsyn
X_ihx_2_14 a_xp2 a_xn2 wp_ih_2_14 wn_ih_2_14 xhp14 xhn14 vdd vbsyn gsyn
X_ihx_3_14 a_xp3 a_xn3 wp_ih_3_14 wn_ih_3_14 xhp14 xhn14 vdd vbsyn gsyn
X_ihx_4_14 a_xp4 a_xn4 wp_ih_4_14 wn_ih_4_14 xhp14 xhn14 vdd vbsyn gsyn
X_ihx_5_14 a_xp5 a_xn5 wp_ih_5_14 wn_ih_5_14 xhp14 xhn14 vdd vbsyn gsyn
X_ihx_6_14 a_xp6 a_xn6 wp_ih_6_14 wn_ih_6_14 xhp14 xhn14 vdd vbsyn gsyn
X_ihx_7_14 a_xp7 a_xn7 wp_ih_7_14 wn_ih_7_14 xhp14 xhn14 vdd vbsyn gsyn
X_ihx_8_14 a_xp8 a_xn8 wp_ih_8_14 wn_ih_8_14 xhp14 xhn14 vdd vbsyn gsyn
X_ihx_9_14 a_xp9 a_xn9 wp_ih_9_14 wn_ih_9_14 xhp14 xhn14 vdd vbsyn gsyn
X_ihx_10_14 a_xp10 a_xn10 wp_ih_10_14 wn_ih_10_14 xhp14 xhn14 vdd vbsyn gsyn
X_ihx_11_14 a_xp11 a_xn11 wp_ih_11_14 wn_ih_11_14 xhp14 xhn14 vdd vbsyn gsyn
X_ihx_12_14 a_xp12 a_xn12 wp_ih_12_14 wn_ih_12_14 xhp14 xhn14 vdd vbsyn gsyn
X_ihx_13_14 a_xp13 a_xn13 wp_ih_13_14 wn_ih_13_14 xhp14 xhn14 vdd vbsyn gsyn
X_ihx_14_14 a_xp14 a_xn14 wp_ih_14_14 wn_ih_14_14 xhp14 xhn14 vdd vbsyn gsyn
X_ihx_15_14 a_xp15 a_xn15 wp_ih_15_14 wn_ih_15_14 xhp14 xhn14 vdd vbsyn gsyn
Xn14 xhp14 xhn14 ahp14 ahn14 vdd vbneu dneuron
Xcm_xh15 xhp15 xhn15 vdd cmld
Rnd_xh15 xhp15 xhn15 20k
X_ihx_0_15 a_xp0 a_xn0 wp_ih_0_15 wn_ih_0_15 xhp15 xhn15 vdd vbsyn gsyn
X_ihx_1_15 a_xp1 a_xn1 wp_ih_1_15 wn_ih_1_15 xhp15 xhn15 vdd vbsyn gsyn
X_ihx_2_15 a_xp2 a_xn2 wp_ih_2_15 wn_ih_2_15 xhp15 xhn15 vdd vbsyn gsyn
X_ihx_3_15 a_xp3 a_xn3 wp_ih_3_15 wn_ih_3_15 xhp15 xhn15 vdd vbsyn gsyn
X_ihx_4_15 a_xp4 a_xn4 wp_ih_4_15 wn_ih_4_15 xhp15 xhn15 vdd vbsyn gsyn
X_ihx_5_15 a_xp5 a_xn5 wp_ih_5_15 wn_ih_5_15 xhp15 xhn15 vdd vbsyn gsyn
X_ihx_6_15 a_xp6 a_xn6 wp_ih_6_15 wn_ih_6_15 xhp15 xhn15 vdd vbsyn gsyn
X_ihx_7_15 a_xp7 a_xn7 wp_ih_7_15 wn_ih_7_15 xhp15 xhn15 vdd vbsyn gsyn
X_ihx_8_15 a_xp8 a_xn8 wp_ih_8_15 wn_ih_8_15 xhp15 xhn15 vdd vbsyn gsyn
X_ihx_9_15 a_xp9 a_xn9 wp_ih_9_15 wn_ih_9_15 xhp15 xhn15 vdd vbsyn gsyn
X_ihx_10_15 a_xp10 a_xn10 wp_ih_10_15 wn_ih_10_15 xhp15 xhn15 vdd vbsyn gsyn
X_ihx_11_15 a_xp11 a_xn11 wp_ih_11_15 wn_ih_11_15 xhp15 xhn15 vdd vbsyn gsyn
X_ihx_12_15 a_xp12 a_xn12 wp_ih_12_15 wn_ih_12_15 xhp15 xhn15 vdd vbsyn gsyn
X_ihx_13_15 a_xp13 a_xn13 wp_ih_13_15 wn_ih_13_15 xhp15 xhn15 vdd vbsyn gsyn
X_ihx_14_15 a_xp14 a_xn14 wp_ih_14_15 wn_ih_14_15 xhp15 xhn15 vdd vbsyn gsyn
X_ihx_15_15 a_xp15 a_xn15 wp_ih_15_15 wn_ih_15_15 xhp15 xhn15 vdd vbsyn gsyn
Xn15 xhp15 xhn15 ahp15 ahn15 vdd vbneu dneuron
Xcm_xh16 xhp16 xhn16 vdd cmld
Rnd_xh16 xhp16 xhn16 20k
X_ihx_0_16 a_xp0 a_xn0 wp_ih_0_16 wn_ih_0_16 xhp16 xhn16 vdd vbsyn gsyn
X_ihx_1_16 a_xp1 a_xn1 wp_ih_1_16 wn_ih_1_16 xhp16 xhn16 vdd vbsyn gsyn
X_ihx_2_16 a_xp2 a_xn2 wp_ih_2_16 wn_ih_2_16 xhp16 xhn16 vdd vbsyn gsyn
X_ihx_3_16 a_xp3 a_xn3 wp_ih_3_16 wn_ih_3_16 xhp16 xhn16 vdd vbsyn gsyn
X_ihx_4_16 a_xp4 a_xn4 wp_ih_4_16 wn_ih_4_16 xhp16 xhn16 vdd vbsyn gsyn
X_ihx_5_16 a_xp5 a_xn5 wp_ih_5_16 wn_ih_5_16 xhp16 xhn16 vdd vbsyn gsyn
X_ihx_6_16 a_xp6 a_xn6 wp_ih_6_16 wn_ih_6_16 xhp16 xhn16 vdd vbsyn gsyn
X_ihx_7_16 a_xp7 a_xn7 wp_ih_7_16 wn_ih_7_16 xhp16 xhn16 vdd vbsyn gsyn
X_ihx_8_16 a_xp8 a_xn8 wp_ih_8_16 wn_ih_8_16 xhp16 xhn16 vdd vbsyn gsyn
X_ihx_9_16 a_xp9 a_xn9 wp_ih_9_16 wn_ih_9_16 xhp16 xhn16 vdd vbsyn gsyn
X_ihx_10_16 a_xp10 a_xn10 wp_ih_10_16 wn_ih_10_16 xhp16 xhn16 vdd vbsyn gsyn
X_ihx_11_16 a_xp11 a_xn11 wp_ih_11_16 wn_ih_11_16 xhp16 xhn16 vdd vbsyn gsyn
X_ihx_12_16 a_xp12 a_xn12 wp_ih_12_16 wn_ih_12_16 xhp16 xhn16 vdd vbsyn gsyn
X_ihx_13_16 a_xp13 a_xn13 wp_ih_13_16 wn_ih_13_16 xhp16 xhn16 vdd vbsyn gsyn
X_ihx_14_16 a_xp14 a_xn14 wp_ih_14_16 wn_ih_14_16 xhp16 xhn16 vdd vbsyn gsyn
X_ihx_15_16 a_xp15 a_xn15 wp_ih_15_16 wn_ih_15_16 xhp16 xhn16 vdd vbsyn gsyn
Xn16 xhp16 xhn16 ahp16 ahn16 vdd vbneu dneuron
Xcm_xh17 xhp17 xhn17 vdd cmld
Rnd_xh17 xhp17 xhn17 20k
X_ihx_0_17 a_xp0 a_xn0 wp_ih_0_17 wn_ih_0_17 xhp17 xhn17 vdd vbsyn gsyn
X_ihx_1_17 a_xp1 a_xn1 wp_ih_1_17 wn_ih_1_17 xhp17 xhn17 vdd vbsyn gsyn
X_ihx_2_17 a_xp2 a_xn2 wp_ih_2_17 wn_ih_2_17 xhp17 xhn17 vdd vbsyn gsyn
X_ihx_3_17 a_xp3 a_xn3 wp_ih_3_17 wn_ih_3_17 xhp17 xhn17 vdd vbsyn gsyn
X_ihx_4_17 a_xp4 a_xn4 wp_ih_4_17 wn_ih_4_17 xhp17 xhn17 vdd vbsyn gsyn
X_ihx_5_17 a_xp5 a_xn5 wp_ih_5_17 wn_ih_5_17 xhp17 xhn17 vdd vbsyn gsyn
X_ihx_6_17 a_xp6 a_xn6 wp_ih_6_17 wn_ih_6_17 xhp17 xhn17 vdd vbsyn gsyn
X_ihx_7_17 a_xp7 a_xn7 wp_ih_7_17 wn_ih_7_17 xhp17 xhn17 vdd vbsyn gsyn
X_ihx_8_17 a_xp8 a_xn8 wp_ih_8_17 wn_ih_8_17 xhp17 xhn17 vdd vbsyn gsyn
X_ihx_9_17 a_xp9 a_xn9 wp_ih_9_17 wn_ih_9_17 xhp17 xhn17 vdd vbsyn gsyn
X_ihx_10_17 a_xp10 a_xn10 wp_ih_10_17 wn_ih_10_17 xhp17 xhn17 vdd vbsyn gsyn
X_ihx_11_17 a_xp11 a_xn11 wp_ih_11_17 wn_ih_11_17 xhp17 xhn17 vdd vbsyn gsyn
X_ihx_12_17 a_xp12 a_xn12 wp_ih_12_17 wn_ih_12_17 xhp17 xhn17 vdd vbsyn gsyn
X_ihx_13_17 a_xp13 a_xn13 wp_ih_13_17 wn_ih_13_17 xhp17 xhn17 vdd vbsyn gsyn
X_ihx_14_17 a_xp14 a_xn14 wp_ih_14_17 wn_ih_14_17 xhp17 xhn17 vdd vbsyn gsyn
X_ihx_15_17 a_xp15 a_xn15 wp_ih_15_17 wn_ih_15_17 xhp17 xhn17 vdd vbsyn gsyn
Xn17 xhp17 xhn17 ahp17 ahn17 vdd vbneu dneuron
Xcm_xh18 xhp18 xhn18 vdd cmld
Rnd_xh18 xhp18 xhn18 20k
X_ihx_0_18 a_xp0 a_xn0 wp_ih_0_18 wn_ih_0_18 xhp18 xhn18 vdd vbsyn gsyn
X_ihx_1_18 a_xp1 a_xn1 wp_ih_1_18 wn_ih_1_18 xhp18 xhn18 vdd vbsyn gsyn
X_ihx_2_18 a_xp2 a_xn2 wp_ih_2_18 wn_ih_2_18 xhp18 xhn18 vdd vbsyn gsyn
X_ihx_3_18 a_xp3 a_xn3 wp_ih_3_18 wn_ih_3_18 xhp18 xhn18 vdd vbsyn gsyn
X_ihx_4_18 a_xp4 a_xn4 wp_ih_4_18 wn_ih_4_18 xhp18 xhn18 vdd vbsyn gsyn
X_ihx_5_18 a_xp5 a_xn5 wp_ih_5_18 wn_ih_5_18 xhp18 xhn18 vdd vbsyn gsyn
X_ihx_6_18 a_xp6 a_xn6 wp_ih_6_18 wn_ih_6_18 xhp18 xhn18 vdd vbsyn gsyn
X_ihx_7_18 a_xp7 a_xn7 wp_ih_7_18 wn_ih_7_18 xhp18 xhn18 vdd vbsyn gsyn
X_ihx_8_18 a_xp8 a_xn8 wp_ih_8_18 wn_ih_8_18 xhp18 xhn18 vdd vbsyn gsyn
X_ihx_9_18 a_xp9 a_xn9 wp_ih_9_18 wn_ih_9_18 xhp18 xhn18 vdd vbsyn gsyn
X_ihx_10_18 a_xp10 a_xn10 wp_ih_10_18 wn_ih_10_18 xhp18 xhn18 vdd vbsyn gsyn
X_ihx_11_18 a_xp11 a_xn11 wp_ih_11_18 wn_ih_11_18 xhp18 xhn18 vdd vbsyn gsyn
X_ihx_12_18 a_xp12 a_xn12 wp_ih_12_18 wn_ih_12_18 xhp18 xhn18 vdd vbsyn gsyn
X_ihx_13_18 a_xp13 a_xn13 wp_ih_13_18 wn_ih_13_18 xhp18 xhn18 vdd vbsyn gsyn
X_ihx_14_18 a_xp14 a_xn14 wp_ih_14_18 wn_ih_14_18 xhp18 xhn18 vdd vbsyn gsyn
X_ihx_15_18 a_xp15 a_xn15 wp_ih_15_18 wn_ih_15_18 xhp18 xhn18 vdd vbsyn gsyn
Xn18 xhp18 xhn18 ahp18 ahn18 vdd vbneu dneuron
Xcm_xh19 xhp19 xhn19 vdd cmld
Rnd_xh19 xhp19 xhn19 20k
X_ihx_0_19 a_xp0 a_xn0 wp_ih_0_19 wn_ih_0_19 xhp19 xhn19 vdd vbsyn gsyn
X_ihx_1_19 a_xp1 a_xn1 wp_ih_1_19 wn_ih_1_19 xhp19 xhn19 vdd vbsyn gsyn
X_ihx_2_19 a_xp2 a_xn2 wp_ih_2_19 wn_ih_2_19 xhp19 xhn19 vdd vbsyn gsyn
X_ihx_3_19 a_xp3 a_xn3 wp_ih_3_19 wn_ih_3_19 xhp19 xhn19 vdd vbsyn gsyn
X_ihx_4_19 a_xp4 a_xn4 wp_ih_4_19 wn_ih_4_19 xhp19 xhn19 vdd vbsyn gsyn
X_ihx_5_19 a_xp5 a_xn5 wp_ih_5_19 wn_ih_5_19 xhp19 xhn19 vdd vbsyn gsyn
X_ihx_6_19 a_xp6 a_xn6 wp_ih_6_19 wn_ih_6_19 xhp19 xhn19 vdd vbsyn gsyn
X_ihx_7_19 a_xp7 a_xn7 wp_ih_7_19 wn_ih_7_19 xhp19 xhn19 vdd vbsyn gsyn
X_ihx_8_19 a_xp8 a_xn8 wp_ih_8_19 wn_ih_8_19 xhp19 xhn19 vdd vbsyn gsyn
X_ihx_9_19 a_xp9 a_xn9 wp_ih_9_19 wn_ih_9_19 xhp19 xhn19 vdd vbsyn gsyn
X_ihx_10_19 a_xp10 a_xn10 wp_ih_10_19 wn_ih_10_19 xhp19 xhn19 vdd vbsyn gsyn
X_ihx_11_19 a_xp11 a_xn11 wp_ih_11_19 wn_ih_11_19 xhp19 xhn19 vdd vbsyn gsyn
X_ihx_12_19 a_xp12 a_xn12 wp_ih_12_19 wn_ih_12_19 xhp19 xhn19 vdd vbsyn gsyn
X_ihx_13_19 a_xp13 a_xn13 wp_ih_13_19 wn_ih_13_19 xhp19 xhn19 vdd vbsyn gsyn
X_ihx_14_19 a_xp14 a_xn14 wp_ih_14_19 wn_ih_14_19 xhp19 xhn19 vdd vbsyn gsyn
X_ihx_15_19 a_xp15 a_xn15 wp_ih_15_19 wn_ih_15_19 xhp19 xhn19 vdd vbsyn gsyn
Xn19 xhp19 xhn19 ahp19 ahn19 vdd vbneu dneuron
Xcm_xh20 xhp20 xhn20 vdd cmld
Rnd_xh20 xhp20 xhn20 20k
X_ihx_0_20 a_xp0 a_xn0 wp_ih_0_20 wn_ih_0_20 xhp20 xhn20 vdd vbsyn gsyn
X_ihx_1_20 a_xp1 a_xn1 wp_ih_1_20 wn_ih_1_20 xhp20 xhn20 vdd vbsyn gsyn
X_ihx_2_20 a_xp2 a_xn2 wp_ih_2_20 wn_ih_2_20 xhp20 xhn20 vdd vbsyn gsyn
X_ihx_3_20 a_xp3 a_xn3 wp_ih_3_20 wn_ih_3_20 xhp20 xhn20 vdd vbsyn gsyn
X_ihx_4_20 a_xp4 a_xn4 wp_ih_4_20 wn_ih_4_20 xhp20 xhn20 vdd vbsyn gsyn
X_ihx_5_20 a_xp5 a_xn5 wp_ih_5_20 wn_ih_5_20 xhp20 xhn20 vdd vbsyn gsyn
X_ihx_6_20 a_xp6 a_xn6 wp_ih_6_20 wn_ih_6_20 xhp20 xhn20 vdd vbsyn gsyn
X_ihx_7_20 a_xp7 a_xn7 wp_ih_7_20 wn_ih_7_20 xhp20 xhn20 vdd vbsyn gsyn
X_ihx_8_20 a_xp8 a_xn8 wp_ih_8_20 wn_ih_8_20 xhp20 xhn20 vdd vbsyn gsyn
X_ihx_9_20 a_xp9 a_xn9 wp_ih_9_20 wn_ih_9_20 xhp20 xhn20 vdd vbsyn gsyn
X_ihx_10_20 a_xp10 a_xn10 wp_ih_10_20 wn_ih_10_20 xhp20 xhn20 vdd vbsyn gsyn
X_ihx_11_20 a_xp11 a_xn11 wp_ih_11_20 wn_ih_11_20 xhp20 xhn20 vdd vbsyn gsyn
X_ihx_12_20 a_xp12 a_xn12 wp_ih_12_20 wn_ih_12_20 xhp20 xhn20 vdd vbsyn gsyn
X_ihx_13_20 a_xp13 a_xn13 wp_ih_13_20 wn_ih_13_20 xhp20 xhn20 vdd vbsyn gsyn
X_ihx_14_20 a_xp14 a_xn14 wp_ih_14_20 wn_ih_14_20 xhp20 xhn20 vdd vbsyn gsyn
X_ihx_15_20 a_xp15 a_xn15 wp_ih_15_20 wn_ih_15_20 xhp20 xhn20 vdd vbsyn gsyn
Xn20 xhp20 xhn20 ahp20 ahn20 vdd vbneu dneuron
Xcm_xh21 xhp21 xhn21 vdd cmld
Rnd_xh21 xhp21 xhn21 20k
X_ihx_0_21 a_xp0 a_xn0 wp_ih_0_21 wn_ih_0_21 xhp21 xhn21 vdd vbsyn gsyn
X_ihx_1_21 a_xp1 a_xn1 wp_ih_1_21 wn_ih_1_21 xhp21 xhn21 vdd vbsyn gsyn
X_ihx_2_21 a_xp2 a_xn2 wp_ih_2_21 wn_ih_2_21 xhp21 xhn21 vdd vbsyn gsyn
X_ihx_3_21 a_xp3 a_xn3 wp_ih_3_21 wn_ih_3_21 xhp21 xhn21 vdd vbsyn gsyn
X_ihx_4_21 a_xp4 a_xn4 wp_ih_4_21 wn_ih_4_21 xhp21 xhn21 vdd vbsyn gsyn
X_ihx_5_21 a_xp5 a_xn5 wp_ih_5_21 wn_ih_5_21 xhp21 xhn21 vdd vbsyn gsyn
X_ihx_6_21 a_xp6 a_xn6 wp_ih_6_21 wn_ih_6_21 xhp21 xhn21 vdd vbsyn gsyn
X_ihx_7_21 a_xp7 a_xn7 wp_ih_7_21 wn_ih_7_21 xhp21 xhn21 vdd vbsyn gsyn
X_ihx_8_21 a_xp8 a_xn8 wp_ih_8_21 wn_ih_8_21 xhp21 xhn21 vdd vbsyn gsyn
X_ihx_9_21 a_xp9 a_xn9 wp_ih_9_21 wn_ih_9_21 xhp21 xhn21 vdd vbsyn gsyn
X_ihx_10_21 a_xp10 a_xn10 wp_ih_10_21 wn_ih_10_21 xhp21 xhn21 vdd vbsyn gsyn
X_ihx_11_21 a_xp11 a_xn11 wp_ih_11_21 wn_ih_11_21 xhp21 xhn21 vdd vbsyn gsyn
X_ihx_12_21 a_xp12 a_xn12 wp_ih_12_21 wn_ih_12_21 xhp21 xhn21 vdd vbsyn gsyn
X_ihx_13_21 a_xp13 a_xn13 wp_ih_13_21 wn_ih_13_21 xhp21 xhn21 vdd vbsyn gsyn
X_ihx_14_21 a_xp14 a_xn14 wp_ih_14_21 wn_ih_14_21 xhp21 xhn21 vdd vbsyn gsyn
X_ihx_15_21 a_xp15 a_xn15 wp_ih_15_21 wn_ih_15_21 xhp21 xhn21 vdd vbsyn gsyn
Xn21 xhp21 xhn21 ahp21 ahn21 vdd vbneu dneuron
Xcm_xh22 xhp22 xhn22 vdd cmld
Rnd_xh22 xhp22 xhn22 20k
X_ihx_0_22 a_xp0 a_xn0 wp_ih_0_22 wn_ih_0_22 xhp22 xhn22 vdd vbsyn gsyn
X_ihx_1_22 a_xp1 a_xn1 wp_ih_1_22 wn_ih_1_22 xhp22 xhn22 vdd vbsyn gsyn
X_ihx_2_22 a_xp2 a_xn2 wp_ih_2_22 wn_ih_2_22 xhp22 xhn22 vdd vbsyn gsyn
X_ihx_3_22 a_xp3 a_xn3 wp_ih_3_22 wn_ih_3_22 xhp22 xhn22 vdd vbsyn gsyn
X_ihx_4_22 a_xp4 a_xn4 wp_ih_4_22 wn_ih_4_22 xhp22 xhn22 vdd vbsyn gsyn
X_ihx_5_22 a_xp5 a_xn5 wp_ih_5_22 wn_ih_5_22 xhp22 xhn22 vdd vbsyn gsyn
X_ihx_6_22 a_xp6 a_xn6 wp_ih_6_22 wn_ih_6_22 xhp22 xhn22 vdd vbsyn gsyn
X_ihx_7_22 a_xp7 a_xn7 wp_ih_7_22 wn_ih_7_22 xhp22 xhn22 vdd vbsyn gsyn
X_ihx_8_22 a_xp8 a_xn8 wp_ih_8_22 wn_ih_8_22 xhp22 xhn22 vdd vbsyn gsyn
X_ihx_9_22 a_xp9 a_xn9 wp_ih_9_22 wn_ih_9_22 xhp22 xhn22 vdd vbsyn gsyn
X_ihx_10_22 a_xp10 a_xn10 wp_ih_10_22 wn_ih_10_22 xhp22 xhn22 vdd vbsyn gsyn
X_ihx_11_22 a_xp11 a_xn11 wp_ih_11_22 wn_ih_11_22 xhp22 xhn22 vdd vbsyn gsyn
X_ihx_12_22 a_xp12 a_xn12 wp_ih_12_22 wn_ih_12_22 xhp22 xhn22 vdd vbsyn gsyn
X_ihx_13_22 a_xp13 a_xn13 wp_ih_13_22 wn_ih_13_22 xhp22 xhn22 vdd vbsyn gsyn
X_ihx_14_22 a_xp14 a_xn14 wp_ih_14_22 wn_ih_14_22 xhp22 xhn22 vdd vbsyn gsyn
X_ihx_15_22 a_xp15 a_xn15 wp_ih_15_22 wn_ih_15_22 xhp22 xhn22 vdd vbsyn gsyn
Xn22 xhp22 xhn22 ahp22 ahn22 vdd vbneu dneuron
Xcm_xh23 xhp23 xhn23 vdd cmld
Rnd_xh23 xhp23 xhn23 20k
X_ihx_0_23 a_xp0 a_xn0 wp_ih_0_23 wn_ih_0_23 xhp23 xhn23 vdd vbsyn gsyn
X_ihx_1_23 a_xp1 a_xn1 wp_ih_1_23 wn_ih_1_23 xhp23 xhn23 vdd vbsyn gsyn
X_ihx_2_23 a_xp2 a_xn2 wp_ih_2_23 wn_ih_2_23 xhp23 xhn23 vdd vbsyn gsyn
X_ihx_3_23 a_xp3 a_xn3 wp_ih_3_23 wn_ih_3_23 xhp23 xhn23 vdd vbsyn gsyn
X_ihx_4_23 a_xp4 a_xn4 wp_ih_4_23 wn_ih_4_23 xhp23 xhn23 vdd vbsyn gsyn
X_ihx_5_23 a_xp5 a_xn5 wp_ih_5_23 wn_ih_5_23 xhp23 xhn23 vdd vbsyn gsyn
X_ihx_6_23 a_xp6 a_xn6 wp_ih_6_23 wn_ih_6_23 xhp23 xhn23 vdd vbsyn gsyn
X_ihx_7_23 a_xp7 a_xn7 wp_ih_7_23 wn_ih_7_23 xhp23 xhn23 vdd vbsyn gsyn
X_ihx_8_23 a_xp8 a_xn8 wp_ih_8_23 wn_ih_8_23 xhp23 xhn23 vdd vbsyn gsyn
X_ihx_9_23 a_xp9 a_xn9 wp_ih_9_23 wn_ih_9_23 xhp23 xhn23 vdd vbsyn gsyn
X_ihx_10_23 a_xp10 a_xn10 wp_ih_10_23 wn_ih_10_23 xhp23 xhn23 vdd vbsyn gsyn
X_ihx_11_23 a_xp11 a_xn11 wp_ih_11_23 wn_ih_11_23 xhp23 xhn23 vdd vbsyn gsyn
X_ihx_12_23 a_xp12 a_xn12 wp_ih_12_23 wn_ih_12_23 xhp23 xhn23 vdd vbsyn gsyn
X_ihx_13_23 a_xp13 a_xn13 wp_ih_13_23 wn_ih_13_23 xhp23 xhn23 vdd vbsyn gsyn
X_ihx_14_23 a_xp14 a_xn14 wp_ih_14_23 wn_ih_14_23 xhp23 xhn23 vdd vbsyn gsyn
X_ihx_15_23 a_xp15 a_xn15 wp_ih_15_23 wn_ih_15_23 xhp23 xhn23 vdd vbsyn gsyn
Xn23 xhp23 xhn23 ahp23 ahn23 vdd vbneu dneuron
Xcm_xh24 xhp24 xhn24 vdd cmld
Rnd_xh24 xhp24 xhn24 20k
X_ihx_0_24 a_xp0 a_xn0 wp_ih_0_24 wn_ih_0_24 xhp24 xhn24 vdd vbsyn gsyn
X_ihx_1_24 a_xp1 a_xn1 wp_ih_1_24 wn_ih_1_24 xhp24 xhn24 vdd vbsyn gsyn
X_ihx_2_24 a_xp2 a_xn2 wp_ih_2_24 wn_ih_2_24 xhp24 xhn24 vdd vbsyn gsyn
X_ihx_3_24 a_xp3 a_xn3 wp_ih_3_24 wn_ih_3_24 xhp24 xhn24 vdd vbsyn gsyn
X_ihx_4_24 a_xp4 a_xn4 wp_ih_4_24 wn_ih_4_24 xhp24 xhn24 vdd vbsyn gsyn
X_ihx_5_24 a_xp5 a_xn5 wp_ih_5_24 wn_ih_5_24 xhp24 xhn24 vdd vbsyn gsyn
X_ihx_6_24 a_xp6 a_xn6 wp_ih_6_24 wn_ih_6_24 xhp24 xhn24 vdd vbsyn gsyn
X_ihx_7_24 a_xp7 a_xn7 wp_ih_7_24 wn_ih_7_24 xhp24 xhn24 vdd vbsyn gsyn
X_ihx_8_24 a_xp8 a_xn8 wp_ih_8_24 wn_ih_8_24 xhp24 xhn24 vdd vbsyn gsyn
X_ihx_9_24 a_xp9 a_xn9 wp_ih_9_24 wn_ih_9_24 xhp24 xhn24 vdd vbsyn gsyn
X_ihx_10_24 a_xp10 a_xn10 wp_ih_10_24 wn_ih_10_24 xhp24 xhn24 vdd vbsyn gsyn
X_ihx_11_24 a_xp11 a_xn11 wp_ih_11_24 wn_ih_11_24 xhp24 xhn24 vdd vbsyn gsyn
X_ihx_12_24 a_xp12 a_xn12 wp_ih_12_24 wn_ih_12_24 xhp24 xhn24 vdd vbsyn gsyn
X_ihx_13_24 a_xp13 a_xn13 wp_ih_13_24 wn_ih_13_24 xhp24 xhn24 vdd vbsyn gsyn
X_ihx_14_24 a_xp14 a_xn14 wp_ih_14_24 wn_ih_14_24 xhp24 xhn24 vdd vbsyn gsyn
X_ihx_15_24 a_xp15 a_xn15 wp_ih_15_24 wn_ih_15_24 xhp24 xhn24 vdd vbsyn gsyn
Xn24 xhp24 xhn24 ahp24 ahn24 vdd vbneu dneuron
Xcm_xh25 xhp25 xhn25 vdd cmld
Rnd_xh25 xhp25 xhn25 20k
X_ihx_0_25 a_xp0 a_xn0 wp_ih_0_25 wn_ih_0_25 xhp25 xhn25 vdd vbsyn gsyn
X_ihx_1_25 a_xp1 a_xn1 wp_ih_1_25 wn_ih_1_25 xhp25 xhn25 vdd vbsyn gsyn
X_ihx_2_25 a_xp2 a_xn2 wp_ih_2_25 wn_ih_2_25 xhp25 xhn25 vdd vbsyn gsyn
X_ihx_3_25 a_xp3 a_xn3 wp_ih_3_25 wn_ih_3_25 xhp25 xhn25 vdd vbsyn gsyn
X_ihx_4_25 a_xp4 a_xn4 wp_ih_4_25 wn_ih_4_25 xhp25 xhn25 vdd vbsyn gsyn
X_ihx_5_25 a_xp5 a_xn5 wp_ih_5_25 wn_ih_5_25 xhp25 xhn25 vdd vbsyn gsyn
X_ihx_6_25 a_xp6 a_xn6 wp_ih_6_25 wn_ih_6_25 xhp25 xhn25 vdd vbsyn gsyn
X_ihx_7_25 a_xp7 a_xn7 wp_ih_7_25 wn_ih_7_25 xhp25 xhn25 vdd vbsyn gsyn
X_ihx_8_25 a_xp8 a_xn8 wp_ih_8_25 wn_ih_8_25 xhp25 xhn25 vdd vbsyn gsyn
X_ihx_9_25 a_xp9 a_xn9 wp_ih_9_25 wn_ih_9_25 xhp25 xhn25 vdd vbsyn gsyn
X_ihx_10_25 a_xp10 a_xn10 wp_ih_10_25 wn_ih_10_25 xhp25 xhn25 vdd vbsyn gsyn
X_ihx_11_25 a_xp11 a_xn11 wp_ih_11_25 wn_ih_11_25 xhp25 xhn25 vdd vbsyn gsyn
X_ihx_12_25 a_xp12 a_xn12 wp_ih_12_25 wn_ih_12_25 xhp25 xhn25 vdd vbsyn gsyn
X_ihx_13_25 a_xp13 a_xn13 wp_ih_13_25 wn_ih_13_25 xhp25 xhn25 vdd vbsyn gsyn
X_ihx_14_25 a_xp14 a_xn14 wp_ih_14_25 wn_ih_14_25 xhp25 xhn25 vdd vbsyn gsyn
X_ihx_15_25 a_xp15 a_xn15 wp_ih_15_25 wn_ih_15_25 xhp25 xhn25 vdd vbsyn gsyn
Xn25 xhp25 xhn25 ahp25 ahn25 vdd vbneu dneuron
Xcm_xh26 xhp26 xhn26 vdd cmld
Rnd_xh26 xhp26 xhn26 20k
X_ihx_0_26 a_xp0 a_xn0 wp_ih_0_26 wn_ih_0_26 xhp26 xhn26 vdd vbsyn gsyn
X_ihx_1_26 a_xp1 a_xn1 wp_ih_1_26 wn_ih_1_26 xhp26 xhn26 vdd vbsyn gsyn
X_ihx_2_26 a_xp2 a_xn2 wp_ih_2_26 wn_ih_2_26 xhp26 xhn26 vdd vbsyn gsyn
X_ihx_3_26 a_xp3 a_xn3 wp_ih_3_26 wn_ih_3_26 xhp26 xhn26 vdd vbsyn gsyn
X_ihx_4_26 a_xp4 a_xn4 wp_ih_4_26 wn_ih_4_26 xhp26 xhn26 vdd vbsyn gsyn
X_ihx_5_26 a_xp5 a_xn5 wp_ih_5_26 wn_ih_5_26 xhp26 xhn26 vdd vbsyn gsyn
X_ihx_6_26 a_xp6 a_xn6 wp_ih_6_26 wn_ih_6_26 xhp26 xhn26 vdd vbsyn gsyn
X_ihx_7_26 a_xp7 a_xn7 wp_ih_7_26 wn_ih_7_26 xhp26 xhn26 vdd vbsyn gsyn
X_ihx_8_26 a_xp8 a_xn8 wp_ih_8_26 wn_ih_8_26 xhp26 xhn26 vdd vbsyn gsyn
X_ihx_9_26 a_xp9 a_xn9 wp_ih_9_26 wn_ih_9_26 xhp26 xhn26 vdd vbsyn gsyn
X_ihx_10_26 a_xp10 a_xn10 wp_ih_10_26 wn_ih_10_26 xhp26 xhn26 vdd vbsyn gsyn
X_ihx_11_26 a_xp11 a_xn11 wp_ih_11_26 wn_ih_11_26 xhp26 xhn26 vdd vbsyn gsyn
X_ihx_12_26 a_xp12 a_xn12 wp_ih_12_26 wn_ih_12_26 xhp26 xhn26 vdd vbsyn gsyn
X_ihx_13_26 a_xp13 a_xn13 wp_ih_13_26 wn_ih_13_26 xhp26 xhn26 vdd vbsyn gsyn
X_ihx_14_26 a_xp14 a_xn14 wp_ih_14_26 wn_ih_14_26 xhp26 xhn26 vdd vbsyn gsyn
X_ihx_15_26 a_xp15 a_xn15 wp_ih_15_26 wn_ih_15_26 xhp26 xhn26 vdd vbsyn gsyn
Xn26 xhp26 xhn26 ahp26 ahn26 vdd vbneu dneuron
Xcm_xh27 xhp27 xhn27 vdd cmld
Rnd_xh27 xhp27 xhn27 20k
X_ihx_0_27 a_xp0 a_xn0 wp_ih_0_27 wn_ih_0_27 xhp27 xhn27 vdd vbsyn gsyn
X_ihx_1_27 a_xp1 a_xn1 wp_ih_1_27 wn_ih_1_27 xhp27 xhn27 vdd vbsyn gsyn
X_ihx_2_27 a_xp2 a_xn2 wp_ih_2_27 wn_ih_2_27 xhp27 xhn27 vdd vbsyn gsyn
X_ihx_3_27 a_xp3 a_xn3 wp_ih_3_27 wn_ih_3_27 xhp27 xhn27 vdd vbsyn gsyn
X_ihx_4_27 a_xp4 a_xn4 wp_ih_4_27 wn_ih_4_27 xhp27 xhn27 vdd vbsyn gsyn
X_ihx_5_27 a_xp5 a_xn5 wp_ih_5_27 wn_ih_5_27 xhp27 xhn27 vdd vbsyn gsyn
X_ihx_6_27 a_xp6 a_xn6 wp_ih_6_27 wn_ih_6_27 xhp27 xhn27 vdd vbsyn gsyn
X_ihx_7_27 a_xp7 a_xn7 wp_ih_7_27 wn_ih_7_27 xhp27 xhn27 vdd vbsyn gsyn
X_ihx_8_27 a_xp8 a_xn8 wp_ih_8_27 wn_ih_8_27 xhp27 xhn27 vdd vbsyn gsyn
X_ihx_9_27 a_xp9 a_xn9 wp_ih_9_27 wn_ih_9_27 xhp27 xhn27 vdd vbsyn gsyn
X_ihx_10_27 a_xp10 a_xn10 wp_ih_10_27 wn_ih_10_27 xhp27 xhn27 vdd vbsyn gsyn
X_ihx_11_27 a_xp11 a_xn11 wp_ih_11_27 wn_ih_11_27 xhp27 xhn27 vdd vbsyn gsyn
X_ihx_12_27 a_xp12 a_xn12 wp_ih_12_27 wn_ih_12_27 xhp27 xhn27 vdd vbsyn gsyn
X_ihx_13_27 a_xp13 a_xn13 wp_ih_13_27 wn_ih_13_27 xhp27 xhn27 vdd vbsyn gsyn
X_ihx_14_27 a_xp14 a_xn14 wp_ih_14_27 wn_ih_14_27 xhp27 xhn27 vdd vbsyn gsyn
X_ihx_15_27 a_xp15 a_xn15 wp_ih_15_27 wn_ih_15_27 xhp27 xhn27 vdd vbsyn gsyn
Xn27 xhp27 xhn27 ahp27 ahn27 vdd vbneu dneuron
Xcm_mo0 mop0 mon0 vdd cmld
Rnd_mo0 mop0 mon0 20k
X_ho_0_0 ahp0 ahn0 wp_ho_0_0 wn_ho_0_0 mop0 mon0 vdd vbsyn gsyn
X_ho_1_0 ahp1 ahn1 wp_ho_1_0 wn_ho_1_0 mop0 mon0 vdd vbsyn gsyn
X_ho_2_0 ahp2 ahn2 wp_ho_2_0 wn_ho_2_0 mop0 mon0 vdd vbsyn gsyn
X_ho_3_0 ahp3 ahn3 wp_ho_3_0 wn_ho_3_0 mop0 mon0 vdd vbsyn gsyn
X_ho_4_0 ahp4 ahn4 wp_ho_4_0 wn_ho_4_0 mop0 mon0 vdd vbsyn gsyn
X_ho_5_0 ahp5 ahn5 wp_ho_5_0 wn_ho_5_0 mop0 mon0 vdd vbsyn gsyn
X_ho_6_0 ahp6 ahn6 wp_ho_6_0 wn_ho_6_0 mop0 mon0 vdd vbsyn gsyn
X_ho_7_0 ahp7 ahn7 wp_ho_7_0 wn_ho_7_0 mop0 mon0 vdd vbsyn gsyn
X_ho_8_0 ahp8 ahn8 wp_ho_8_0 wn_ho_8_0 mop0 mon0 vdd vbsyn gsyn
X_ho_9_0 ahp9 ahn9 wp_ho_9_0 wn_ho_9_0 mop0 mon0 vdd vbsyn gsyn
X_ho_10_0 ahp10 ahn10 wp_ho_10_0 wn_ho_10_0 mop0 mon0 vdd vbsyn gsyn
X_ho_11_0 ahp11 ahn11 wp_ho_11_0 wn_ho_11_0 mop0 mon0 vdd vbsyn gsyn
X_ho_12_0 ahp12 ahn12 wp_ho_12_0 wn_ho_12_0 mop0 mon0 vdd vbsyn gsyn
X_ho_13_0 ahp13 ahn13 wp_ho_13_0 wn_ho_13_0 mop0 mon0 vdd vbsyn gsyn
X_ho_14_0 ahp14 ahn14 wp_ho_14_0 wn_ho_14_0 mop0 mon0 vdd vbsyn gsyn
X_ho_15_0 ahp15 ahn15 wp_ho_15_0 wn_ho_15_0 mop0 mon0 vdd vbsyn gsyn
X_ho_16_0 ahp16 ahn16 wp_ho_16_0 wn_ho_16_0 mop0 mon0 vdd vbsyn gsyn
X_ho_17_0 ahp17 ahn17 wp_ho_17_0 wn_ho_17_0 mop0 mon0 vdd vbsyn gsyn
X_ho_18_0 ahp18 ahn18 wp_ho_18_0 wn_ho_18_0 mop0 mon0 vdd vbsyn gsyn
X_ho_19_0 ahp19 ahn19 wp_ho_19_0 wn_ho_19_0 mop0 mon0 vdd vbsyn gsyn
X_ho_20_0 ahp20 ahn20 wp_ho_20_0 wn_ho_20_0 mop0 mon0 vdd vbsyn gsyn
X_ho_21_0 ahp21 ahn21 wp_ho_21_0 wn_ho_21_0 mop0 mon0 vdd vbsyn gsyn
X_ho_22_0 ahp22 ahn22 wp_ho_22_0 wn_ho_22_0 mop0 mon0 vdd vbsyn gsyn
X_ho_23_0 ahp23 ahn23 wp_ho_23_0 wn_ho_23_0 mop0 mon0 vdd vbsyn gsyn
X_ho_24_0 ahp24 ahn24 wp_ho_24_0 wn_ho_24_0 mop0 mon0 vdd vbsyn gsyn
X_ho_25_0 ahp25 ahn25 wp_ho_25_0 wn_ho_25_0 mop0 mon0 vdd vbsyn gsyn
X_ho_26_0 ahp26 ahn26 wp_ho_26_0 wn_ho_26_0 mop0 mon0 vdd vbsyn gsyn
X_ho_27_0 ahp27 ahn27 wp_ho_27_0 wn_ho_27_0 mop0 mon0 vdd vbsyn gsyn
Xcm_mo1 mop1 mon1 vdd cmld
Rnd_mo1 mop1 mon1 20k
X_ho_0_1 ahp0 ahn0 wp_ho_0_1 wn_ho_0_1 mop1 mon1 vdd vbsyn gsyn
X_ho_1_1 ahp1 ahn1 wp_ho_1_1 wn_ho_1_1 mop1 mon1 vdd vbsyn gsyn
X_ho_2_1 ahp2 ahn2 wp_ho_2_1 wn_ho_2_1 mop1 mon1 vdd vbsyn gsyn
X_ho_3_1 ahp3 ahn3 wp_ho_3_1 wn_ho_3_1 mop1 mon1 vdd vbsyn gsyn
X_ho_4_1 ahp4 ahn4 wp_ho_4_1 wn_ho_4_1 mop1 mon1 vdd vbsyn gsyn
X_ho_5_1 ahp5 ahn5 wp_ho_5_1 wn_ho_5_1 mop1 mon1 vdd vbsyn gsyn
X_ho_6_1 ahp6 ahn6 wp_ho_6_1 wn_ho_6_1 mop1 mon1 vdd vbsyn gsyn
X_ho_7_1 ahp7 ahn7 wp_ho_7_1 wn_ho_7_1 mop1 mon1 vdd vbsyn gsyn
X_ho_8_1 ahp8 ahn8 wp_ho_8_1 wn_ho_8_1 mop1 mon1 vdd vbsyn gsyn
X_ho_9_1 ahp9 ahn9 wp_ho_9_1 wn_ho_9_1 mop1 mon1 vdd vbsyn gsyn
X_ho_10_1 ahp10 ahn10 wp_ho_10_1 wn_ho_10_1 mop1 mon1 vdd vbsyn gsyn
X_ho_11_1 ahp11 ahn11 wp_ho_11_1 wn_ho_11_1 mop1 mon1 vdd vbsyn gsyn
X_ho_12_1 ahp12 ahn12 wp_ho_12_1 wn_ho_12_1 mop1 mon1 vdd vbsyn gsyn
X_ho_13_1 ahp13 ahn13 wp_ho_13_1 wn_ho_13_1 mop1 mon1 vdd vbsyn gsyn
X_ho_14_1 ahp14 ahn14 wp_ho_14_1 wn_ho_14_1 mop1 mon1 vdd vbsyn gsyn
X_ho_15_1 ahp15 ahn15 wp_ho_15_1 wn_ho_15_1 mop1 mon1 vdd vbsyn gsyn
X_ho_16_1 ahp16 ahn16 wp_ho_16_1 wn_ho_16_1 mop1 mon1 vdd vbsyn gsyn
X_ho_17_1 ahp17 ahn17 wp_ho_17_1 wn_ho_17_1 mop1 mon1 vdd vbsyn gsyn
X_ho_18_1 ahp18 ahn18 wp_ho_18_1 wn_ho_18_1 mop1 mon1 vdd vbsyn gsyn
X_ho_19_1 ahp19 ahn19 wp_ho_19_1 wn_ho_19_1 mop1 mon1 vdd vbsyn gsyn
X_ho_20_1 ahp20 ahn20 wp_ho_20_1 wn_ho_20_1 mop1 mon1 vdd vbsyn gsyn
X_ho_21_1 ahp21 ahn21 wp_ho_21_1 wn_ho_21_1 mop1 mon1 vdd vbsyn gsyn
X_ho_22_1 ahp22 ahn22 wp_ho_22_1 wn_ho_22_1 mop1 mon1 vdd vbsyn gsyn
X_ho_23_1 ahp23 ahn23 wp_ho_23_1 wn_ho_23_1 mop1 mon1 vdd vbsyn gsyn
X_ho_24_1 ahp24 ahn24 wp_ho_24_1 wn_ho_24_1 mop1 mon1 vdd vbsyn gsyn
X_ho_25_1 ahp25 ahn25 wp_ho_25_1 wn_ho_25_1 mop1 mon1 vdd vbsyn gsyn
X_ho_26_1 ahp26 ahn26 wp_ho_26_1 wn_ho_26_1 mop1 mon1 vdd vbsyn gsyn
X_ho_27_1 ahp27 ahn27 wp_ho_27_1 wn_ho_27_1 mop1 mon1 vdd vbsyn gsyn
Xcm_mo2 mop2 mon2 vdd cmld
Rnd_mo2 mop2 mon2 20k
X_ho_0_2 ahp0 ahn0 wp_ho_0_2 wn_ho_0_2 mop2 mon2 vdd vbsyn gsyn
X_ho_1_2 ahp1 ahn1 wp_ho_1_2 wn_ho_1_2 mop2 mon2 vdd vbsyn gsyn
X_ho_2_2 ahp2 ahn2 wp_ho_2_2 wn_ho_2_2 mop2 mon2 vdd vbsyn gsyn
X_ho_3_2 ahp3 ahn3 wp_ho_3_2 wn_ho_3_2 mop2 mon2 vdd vbsyn gsyn
X_ho_4_2 ahp4 ahn4 wp_ho_4_2 wn_ho_4_2 mop2 mon2 vdd vbsyn gsyn
X_ho_5_2 ahp5 ahn5 wp_ho_5_2 wn_ho_5_2 mop2 mon2 vdd vbsyn gsyn
X_ho_6_2 ahp6 ahn6 wp_ho_6_2 wn_ho_6_2 mop2 mon2 vdd vbsyn gsyn
X_ho_7_2 ahp7 ahn7 wp_ho_7_2 wn_ho_7_2 mop2 mon2 vdd vbsyn gsyn
X_ho_8_2 ahp8 ahn8 wp_ho_8_2 wn_ho_8_2 mop2 mon2 vdd vbsyn gsyn
X_ho_9_2 ahp9 ahn9 wp_ho_9_2 wn_ho_9_2 mop2 mon2 vdd vbsyn gsyn
X_ho_10_2 ahp10 ahn10 wp_ho_10_2 wn_ho_10_2 mop2 mon2 vdd vbsyn gsyn
X_ho_11_2 ahp11 ahn11 wp_ho_11_2 wn_ho_11_2 mop2 mon2 vdd vbsyn gsyn
X_ho_12_2 ahp12 ahn12 wp_ho_12_2 wn_ho_12_2 mop2 mon2 vdd vbsyn gsyn
X_ho_13_2 ahp13 ahn13 wp_ho_13_2 wn_ho_13_2 mop2 mon2 vdd vbsyn gsyn
X_ho_14_2 ahp14 ahn14 wp_ho_14_2 wn_ho_14_2 mop2 mon2 vdd vbsyn gsyn
X_ho_15_2 ahp15 ahn15 wp_ho_15_2 wn_ho_15_2 mop2 mon2 vdd vbsyn gsyn
X_ho_16_2 ahp16 ahn16 wp_ho_16_2 wn_ho_16_2 mop2 mon2 vdd vbsyn gsyn
X_ho_17_2 ahp17 ahn17 wp_ho_17_2 wn_ho_17_2 mop2 mon2 vdd vbsyn gsyn
X_ho_18_2 ahp18 ahn18 wp_ho_18_2 wn_ho_18_2 mop2 mon2 vdd vbsyn gsyn
X_ho_19_2 ahp19 ahn19 wp_ho_19_2 wn_ho_19_2 mop2 mon2 vdd vbsyn gsyn
X_ho_20_2 ahp20 ahn20 wp_ho_20_2 wn_ho_20_2 mop2 mon2 vdd vbsyn gsyn
X_ho_21_2 ahp21 ahn21 wp_ho_21_2 wn_ho_21_2 mop2 mon2 vdd vbsyn gsyn
X_ho_22_2 ahp22 ahn22 wp_ho_22_2 wn_ho_22_2 mop2 mon2 vdd vbsyn gsyn
X_ho_23_2 ahp23 ahn23 wp_ho_23_2 wn_ho_23_2 mop2 mon2 vdd vbsyn gsyn
X_ho_24_2 ahp24 ahn24 wp_ho_24_2 wn_ho_24_2 mop2 mon2 vdd vbsyn gsyn
X_ho_25_2 ahp25 ahn25 wp_ho_25_2 wn_ho_25_2 mop2 mon2 vdd vbsyn gsyn
X_ho_26_2 ahp26 ahn26 wp_ho_26_2 wn_ho_26_2 mop2 mon2 vdd vbsyn gsyn
X_ho_27_2 ahp27 ahn27 wp_ho_27_2 wn_ho_27_2 mop2 mon2 vdd vbsyn gsyn
Xcm_mo3 mop3 mon3 vdd cmld
Rnd_mo3 mop3 mon3 20k
X_ho_0_3 ahp0 ahn0 wp_ho_0_3 wn_ho_0_3 mop3 mon3 vdd vbsyn gsyn
X_ho_1_3 ahp1 ahn1 wp_ho_1_3 wn_ho_1_3 mop3 mon3 vdd vbsyn gsyn
X_ho_2_3 ahp2 ahn2 wp_ho_2_3 wn_ho_2_3 mop3 mon3 vdd vbsyn gsyn
X_ho_3_3 ahp3 ahn3 wp_ho_3_3 wn_ho_3_3 mop3 mon3 vdd vbsyn gsyn
X_ho_4_3 ahp4 ahn4 wp_ho_4_3 wn_ho_4_3 mop3 mon3 vdd vbsyn gsyn
X_ho_5_3 ahp5 ahn5 wp_ho_5_3 wn_ho_5_3 mop3 mon3 vdd vbsyn gsyn
X_ho_6_3 ahp6 ahn6 wp_ho_6_3 wn_ho_6_3 mop3 mon3 vdd vbsyn gsyn
X_ho_7_3 ahp7 ahn7 wp_ho_7_3 wn_ho_7_3 mop3 mon3 vdd vbsyn gsyn
X_ho_8_3 ahp8 ahn8 wp_ho_8_3 wn_ho_8_3 mop3 mon3 vdd vbsyn gsyn
X_ho_9_3 ahp9 ahn9 wp_ho_9_3 wn_ho_9_3 mop3 mon3 vdd vbsyn gsyn
X_ho_10_3 ahp10 ahn10 wp_ho_10_3 wn_ho_10_3 mop3 mon3 vdd vbsyn gsyn
X_ho_11_3 ahp11 ahn11 wp_ho_11_3 wn_ho_11_3 mop3 mon3 vdd vbsyn gsyn
X_ho_12_3 ahp12 ahn12 wp_ho_12_3 wn_ho_12_3 mop3 mon3 vdd vbsyn gsyn
X_ho_13_3 ahp13 ahn13 wp_ho_13_3 wn_ho_13_3 mop3 mon3 vdd vbsyn gsyn
X_ho_14_3 ahp14 ahn14 wp_ho_14_3 wn_ho_14_3 mop3 mon3 vdd vbsyn gsyn
X_ho_15_3 ahp15 ahn15 wp_ho_15_3 wn_ho_15_3 mop3 mon3 vdd vbsyn gsyn
X_ho_16_3 ahp16 ahn16 wp_ho_16_3 wn_ho_16_3 mop3 mon3 vdd vbsyn gsyn
X_ho_17_3 ahp17 ahn17 wp_ho_17_3 wn_ho_17_3 mop3 mon3 vdd vbsyn gsyn
X_ho_18_3 ahp18 ahn18 wp_ho_18_3 wn_ho_18_3 mop3 mon3 vdd vbsyn gsyn
X_ho_19_3 ahp19 ahn19 wp_ho_19_3 wn_ho_19_3 mop3 mon3 vdd vbsyn gsyn
X_ho_20_3 ahp20 ahn20 wp_ho_20_3 wn_ho_20_3 mop3 mon3 vdd vbsyn gsyn
X_ho_21_3 ahp21 ahn21 wp_ho_21_3 wn_ho_21_3 mop3 mon3 vdd vbsyn gsyn
X_ho_22_3 ahp22 ahn22 wp_ho_22_3 wn_ho_22_3 mop3 mon3 vdd vbsyn gsyn
X_ho_23_3 ahp23 ahn23 wp_ho_23_3 wn_ho_23_3 mop3 mon3 vdd vbsyn gsyn
X_ho_24_3 ahp24 ahn24 wp_ho_24_3 wn_ho_24_3 mop3 mon3 vdd vbsyn gsyn
X_ho_25_3 ahp25 ahn25 wp_ho_25_3 wn_ho_25_3 mop3 mon3 vdd vbsyn gsyn
X_ho_26_3 ahp26 ahn26 wp_ho_26_3 wn_ho_26_3 mop3 mon3 vdd vbsyn gsyn
X_ho_27_3 ahp27 ahn27 wp_ho_27_3 wn_ho_27_3 mop3 mon3 vdd vbsyn gsyn
Xcm_mo4 mop4 mon4 vdd cmld
Rnd_mo4 mop4 mon4 20k
X_ho_0_4 ahp0 ahn0 wp_ho_0_4 wn_ho_0_4 mop4 mon4 vdd vbsyn gsyn
X_ho_1_4 ahp1 ahn1 wp_ho_1_4 wn_ho_1_4 mop4 mon4 vdd vbsyn gsyn
X_ho_2_4 ahp2 ahn2 wp_ho_2_4 wn_ho_2_4 mop4 mon4 vdd vbsyn gsyn
X_ho_3_4 ahp3 ahn3 wp_ho_3_4 wn_ho_3_4 mop4 mon4 vdd vbsyn gsyn
X_ho_4_4 ahp4 ahn4 wp_ho_4_4 wn_ho_4_4 mop4 mon4 vdd vbsyn gsyn
X_ho_5_4 ahp5 ahn5 wp_ho_5_4 wn_ho_5_4 mop4 mon4 vdd vbsyn gsyn
X_ho_6_4 ahp6 ahn6 wp_ho_6_4 wn_ho_6_4 mop4 mon4 vdd vbsyn gsyn
X_ho_7_4 ahp7 ahn7 wp_ho_7_4 wn_ho_7_4 mop4 mon4 vdd vbsyn gsyn
X_ho_8_4 ahp8 ahn8 wp_ho_8_4 wn_ho_8_4 mop4 mon4 vdd vbsyn gsyn
X_ho_9_4 ahp9 ahn9 wp_ho_9_4 wn_ho_9_4 mop4 mon4 vdd vbsyn gsyn
X_ho_10_4 ahp10 ahn10 wp_ho_10_4 wn_ho_10_4 mop4 mon4 vdd vbsyn gsyn
X_ho_11_4 ahp11 ahn11 wp_ho_11_4 wn_ho_11_4 mop4 mon4 vdd vbsyn gsyn
X_ho_12_4 ahp12 ahn12 wp_ho_12_4 wn_ho_12_4 mop4 mon4 vdd vbsyn gsyn
X_ho_13_4 ahp13 ahn13 wp_ho_13_4 wn_ho_13_4 mop4 mon4 vdd vbsyn gsyn
X_ho_14_4 ahp14 ahn14 wp_ho_14_4 wn_ho_14_4 mop4 mon4 vdd vbsyn gsyn
X_ho_15_4 ahp15 ahn15 wp_ho_15_4 wn_ho_15_4 mop4 mon4 vdd vbsyn gsyn
X_ho_16_4 ahp16 ahn16 wp_ho_16_4 wn_ho_16_4 mop4 mon4 vdd vbsyn gsyn
X_ho_17_4 ahp17 ahn17 wp_ho_17_4 wn_ho_17_4 mop4 mon4 vdd vbsyn gsyn
X_ho_18_4 ahp18 ahn18 wp_ho_18_4 wn_ho_18_4 mop4 mon4 vdd vbsyn gsyn
X_ho_19_4 ahp19 ahn19 wp_ho_19_4 wn_ho_19_4 mop4 mon4 vdd vbsyn gsyn
X_ho_20_4 ahp20 ahn20 wp_ho_20_4 wn_ho_20_4 mop4 mon4 vdd vbsyn gsyn
X_ho_21_4 ahp21 ahn21 wp_ho_21_4 wn_ho_21_4 mop4 mon4 vdd vbsyn gsyn
X_ho_22_4 ahp22 ahn22 wp_ho_22_4 wn_ho_22_4 mop4 mon4 vdd vbsyn gsyn
X_ho_23_4 ahp23 ahn23 wp_ho_23_4 wn_ho_23_4 mop4 mon4 vdd vbsyn gsyn
X_ho_24_4 ahp24 ahn24 wp_ho_24_4 wn_ho_24_4 mop4 mon4 vdd vbsyn gsyn
X_ho_25_4 ahp25 ahn25 wp_ho_25_4 wn_ho_25_4 mop4 mon4 vdd vbsyn gsyn
X_ho_26_4 ahp26 ahn26 wp_ho_26_4 wn_ho_26_4 mop4 mon4 vdd vbsyn gsyn
X_ho_27_4 ahp27 ahn27 wp_ho_27_4 wn_ho_27_4 mop4 mon4 vdd vbsyn gsyn
.options gmin=1e-10
.end
