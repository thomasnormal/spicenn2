fully in-spice PC learner
.model NNR NMOS (LEVEL=1 VTO=0.2 KP=120u LAMBDA=0.02 GAMMA=0 PHI=0.7)
.model PNR PMOS (LEVEL=1 VTO=-0.2 KP=40u LAMBDA=0.02 GAMMA=0 PHI=0.7)
.subckt gsyn inp inn wp wn outp outn vdd vbn
Mtail nt vbn 0 0 NNR W=400u L=100u
M5 na wp s5 0 NNR W=200u L=100u
Rd5 s5 nt 12k
M6 nb wn s6 0 NNR W=200u L=100u
Rd6 s6 nt 12k
M1 outp inp s1 0 NNR W=200u L=100u
Rd1 s1 na 12k
M2 outn inn s2 0 NNR W=200u L=100u
Rd2 s2 na 12k
M3 outn inp s3 0 NNR W=200u L=100u
Rd3 s3 nb 12k
M4 outp inn s4 0 NNR W=200u L=100u
Rd4 s4 nb 12k
.ends
.subckt cmld p n vdd
Rcs1 p cmx 300k
Rcs2 n cmx 300k
MLp p cmx vdd vdd PNR W=8000u L=100u
MLn n cmx vdd vdd PNR W=8000u L=100u
.ends
.subckt dneuron up un ap an vdd vbn
M1 an up tn 0 NNR W=200u L=100u
M2 ap un tn 0 NNR W=200u L=100u
Mt tn vbn 0 0 NNR W=200u L=100u
Xcm ap an vdd cmld
.ends
.subckt esub xp xn mp mn ep en vdd vbn
Mt nt vbn 0 0 NNR W=400u L=100u
M1x ep xn nt 0 NNR W=200u L=100u
M2x en xp nt 0 NNR W=200u L=100u
M1m ep mp nt 0 NNR W=200u L=100u
M2m en mn nt 0 NNR W=200u L=100u
RLp vdd ep 50k
RLn vdd en 50k
.ends
.subckt gprod xp xn yp yn wp wn vdd vbn
Mtail nt vbn 0 0 NNR W=400u L=100u
M5 na yp sy5 0 NNR W=200u L=100u
Rg5 sy5 nt 12k
M6 nb yn sy6 0 NNR W=200u L=100u
Rg6 sy6 nt 12k
M1 iop xp sx1 0 NNR W=200u L=100u
Rg1 sx1 na 12k
M2 ion xn sx2 0 NNR W=200u L=100u
Rg2 sx2 na 12k
M3 ion xp sx3 0 NNR W=200u L=100u
Rg3 sx3 nb 12k
M4 iop xn sx4 0 NNR W=200u L=100u
Rg4 sx4 nb 12k
Mlp iop iop vdd vdd PNR W=200u L=100u
Mln ion ion vdd vdd PNR W=200u L=100u
Mpu_wp wp iop vdd vdd PNR W=200u L=100u
MpRn nrn ion vdd vdd PNR W=200u L=100u
MnRn nrn nrn 0 0 NNR W=200u L=100u
Mpd_wp wp nrn 0 0 NNR W=200u L=100u
Mpu_wn wn ion vdd vdd PNR W=200u L=100u
MpRp nrp iop vdd vdd PNR W=200u L=100u
MnRp nrp nrp 0 0 NNR W=200u L=100u
Mpd_wn wn nrp 0 0 NNR W=200u L=100u
.ends
.subckt comp inp inn out vdd vbn
Mt nt vbn 0 0 NNR W=200u L=100u
M1 d1 inp nt 0 NNR W=200u L=100u
M2 out inn nt 0 NNR W=200u L=100u
M3 d1 d1 vdd vdd PNR W=200u L=100u
M4 out d1 vdd vdd PNR W=200u L=100u
.ends
Vdd vdd 0 1.0
Vbsyn vbsyn 0 0.6
Vbneu vbneu 0 0.35
Vgm gm 0 0.6
Vwcm wcm 0 0.5
Vgbl gbl 0 PWL(0.0n 0.85000 119.9n 0.85000 120.0n 0.85000 239.9n 0.85000 240.0n 0.85000 359.9n 0.85000 360.0n 0.85000 479.9n 0.85000 480.0n 0.85000 599.9n 0.85000 600.0n 0.85000 719.9n 0.85000 720.0n 0.85000 839.9n 0.85000 840.0n 0.85000 959.9n 0.85000 960.0n 0.85000 1079.9n 0.85000 1080.0n 0.85000 1199.9n 0.85000 1200.0n 0.85000 1319.9n 0.85000 1320.0n 0.85000 1439.9n 0.85000 1440.0n 0.85000 1559.9n 0.85000 1560.0n 0.85000 1679.9n 0.85000 1680.0n 0.85000 1799.9n 0.85000 1800.0n 0.85000 1919.9n 0.85000 1920.0n 0.85000 2039.9n 0.85000 2040.0n 0.85000 2159.9n 0.85000 2160.0n 0.85000 2279.9n 0.85000 2280.0n 0.85000 2399.9n 0.85000 2400.0n 0.85000 2519.9n 0.85000 2520.0n 0.85000 2639.9n 0.85000 2640.0n 0.85000 2759.9n 0.85000 2760.0n 0.85000 2879.9n 0.85000 2880.0n 0.85000 2999.9n 0.85000 3000.0n 0.85000 3119.9n 0.85000 3120.0n 0.85000 3239.9n 0.85000 3240.0n 0.85000 3359.9n 0.85000 3360.0n 0.85000 3479.9n 0.85000 3480.0n 0.85000 3599.9n 0.85000 3600.0n 0.85000 3719.9n 0.85000 3720.0n 0.85000 3839.9n 0.85000 3840.0n 0.85000 3959.9n 0.85000 3960.0n 0.85000 4079.9n 0.85000 4080.0n 0.85000 4199.9n 0.85000 4200.0n 0.85000 4319.9n 0.85000 4320.0n 0.85000 4439.9n 0.85000 4440.0n 0.85000 4559.9n 0.85000 4560.0n 0.85000 4679.9n 0.85000 4680.0n 0.85000 4799.9n 0.85000 4800.0n 0.85000 4919.9n 0.85000 4920.0n 0.85000 5039.9n 0.85000 5040.0n 0.85000 5159.9n 0.85000 5160.0n 0.85000 5279.9n 0.85000 5280.0n 0.85000 5399.9n 0.85000 5400.0n 0.85000 5519.9n 0.85000 5520.0n 0.85000 5639.9n 0.85000 5640.0n 0.85000 5759.9n 0.85000 5760.0n 0.00000 5879.9n 0.00000 5880.0n 0.00000 5999.9n 0.00000 6000.0n 0.00000 6119.9n 0.00000 6120.0n 0.00000 6239.9n 0.00000 6240.0n 0.00000 6359.9n 0.00000 6360.0n 0.00000 6479.9n 0.00000 6480.0n 0.00000 6599.9n 0.00000 6600.0n 0.00000 6719.9n 0.00000 6720.0n 0.00000 6839.9n 0.00000 6840.0n 0.00000 6959.9n 0.00000 6960.0n 0.00000 7079.9n 0.00000 7080.0n 0.00000 7199.9n 0.00000 7200.0n 0.00000 7319.9n 0.00000 7320.0n 0.00000 7439.9n 0.00000 7440.0n 0.00000 7559.9n 0.00000 7560.0n 0.00000 7679.9n 0.00000 7680.0n 0.00000 7799.9n 0.00000 7800.0n 0.00000 7919.9n 0.00000 7920.0n 0.00000 8039.9n 0.00000 8040.0n 0.00000 8159.9n 0.00000 8160.0n 0.00000 8279.9n 0.00000 8280.0n 0.00000 8399.9n 0.00000 8400.0n 0.00000 8519.9n 0.00000 8520.0n 0.00000 8639.9n 0.00000 8640.0n 0.00000 8759.9n 0.00000 8760.0n 0.00000 8879.9n 0.00000 8880.0n 0.00000 8999.9n 0.00000 9000.0n 0.00000 9119.9n 0.00000 9120.0n 0.00000 9239.9n 0.00000 9240.0n 0.00000 9359.9n 0.00000 9360.0n 0.00000 9479.9n 0.00000 9480.0n 0.00000 9599.9n 0.00000 9600.0n 0.00000 9719.9n 0.00000 9720.0n 0.00000 9839.9n 0.00000 9840.0n 0.00000 9959.9n 0.00000 9960.0n 0.00000 10079.9n 0.00000 10080.0n 0.00000 10199.9n 0.00000 10200.0n 0.00000 10319.9n 0.00000 10320.0n 0.00000 10439.9n 0.00000 10440.0n 0.00000 10559.9n 0.00000 10560.0n 0.85000 10679.9n 0.85000 10680.0n 0.85000 10799.9n 0.85000 10800.0n 0.85000 10919.9n 0.85000 10920.0n 0.85000 11039.9n 0.85000 11040.0n 0.85000 11159.9n 0.85000 11160.0n 0.85000 11279.9n 0.85000 11280.0n 0.85000 11399.9n 0.85000 11400.0n 0.85000 11519.9n 0.85000 11520.0n 0.85000 11639.9n 0.85000 11640.0n 0.85000 11759.9n 0.85000 11760.0n 0.85000 11879.9n 0.85000 11880.0n 0.85000 11999.9n 0.85000 12000.0n 0.85000 12119.9n 0.85000 12120.0n 0.85000 12239.9n 0.85000 12240.0n 0.85000 12359.9n 0.85000 12360.0n 0.85000 12479.9n 0.85000 12480.0n 0.85000 12599.9n 0.85000 12600.0n 0.85000 12719.9n 0.85000 12720.0n 0.85000 12839.9n 0.85000 12840.0n 0.85000 12959.9n 0.85000 12960.0n 0.85000 13079.9n 0.85000 13080.0n 0.85000 13199.9n 0.85000 13200.0n 0.85000 13319.9n 0.85000 13320.0n 0.85000 13439.9n 0.85000 13440.0n 0.85000 13559.9n 0.85000 13560.0n 0.85000 13679.9n 0.85000 13680.0n 0.85000 13799.9n 0.85000 13800.0n 0.85000 13919.9n 0.85000 13920.0n 0.85000 14039.9n 0.85000 14040.0n 0.85000 14159.9n 0.85000 14160.0n 0.85000 14279.9n 0.85000 14280.0n 0.85000 14399.9n 0.85000 14400.0n 0.85000 14519.9n 0.85000 14520.0n 0.85000 14639.9n 0.85000 14640.0n 0.85000 14759.9n 0.85000 14760.0n 0.85000 14879.9n 0.85000 14880.0n 0.85000 14999.9n 0.85000 15000.0n 0.85000 15119.9n 0.85000 15120.0n 0.85000 15239.9n 0.85000 15240.0n 0.85000 15359.9n 0.85000 15360.0n 0.85000 15479.9n 0.85000 15480.0n 0.85000 15599.9n 0.85000 15600.0n 0.85000 15719.9n 0.85000 15720.0n 0.85000 15839.9n 0.85000 15840.0n 0.85000 15959.9n 0.85000 15960.0n 0.85000 16079.9n 0.85000 16080.0n 0.85000 16199.9n 0.85000 16200.0n 0.85000 16319.9n 0.85000 16320.0n 0.00000 16439.9n 0.00000 16440.0n 0.00000 16559.9n 0.00000 16560.0n 0.00000 16679.9n 0.00000 16680.0n 0.00000 16799.9n 0.00000 16800.0n 0.00000 16919.9n 0.00000 16920.0n 0.00000 17039.9n 0.00000 17040.0n 0.00000 17159.9n 0.00000 17160.0n 0.00000 17279.9n 0.00000 17280.0n 0.00000 17399.9n 0.00000 17400.0n 0.00000 17519.9n 0.00000 17520.0n 0.00000 17639.9n 0.00000 17640.0n 0.00000 17759.9n 0.00000 17760.0n 0.00000 17879.9n 0.00000 17880.0n 0.00000 17999.9n 0.00000 18000.0n 0.00000 18119.9n 0.00000 18120.0n 0.00000 18239.9n 0.00000 18240.0n 0.00000 18359.9n 0.00000 18360.0n 0.00000 18479.9n 0.00000 18480.0n 0.00000 18599.9n 0.00000 18600.0n 0.00000 18719.9n 0.00000 18720.0n 0.00000 18839.9n 0.00000 18840.0n 0.00000 18959.9n 0.00000 18960.0n 0.00000 19079.9n 0.00000 19080.0n 0.00000 19199.9n 0.00000 19200.0n 0.00000 19319.9n 0.00000 19320.0n 0.00000 19439.9n 0.00000 19440.0n 0.00000 19559.9n 0.00000 19560.0n 0.00000 19679.9n 0.00000 19680.0n 0.00000 19799.9n 0.00000 19800.0n 0.00000 19919.9n 0.00000 19920.0n 0.00000 20039.9n 0.00000 20040.0n 0.00000 20159.9n 0.00000 20160.0n 0.00000 20279.9n 0.00000 20280.0n 0.00000 20399.9n 0.00000 20400.0n 0.00000 20519.9n 0.00000 20520.0n 0.00000 20639.9n 0.00000 20640.0n 0.00000 20759.9n 0.00000 20760.0n 0.00000 20879.9n 0.00000 20880.0n 0.00000 20999.9n 0.00000 21000.0n 0.00000)
Vxp0 a_xp0 0 PWL(0.0n 0.47556 119.9n 0.47556 120.0n 0.35630 239.9n 0.35630 240.0n 0.88832 359.9n 0.88832 360.0n 0.17082 479.9n 0.17082 480.0n 0.53141 599.9n 0.53141 600.0n 1.36668 719.9n 1.36668 720.0n 0.56449 839.9n 0.56449 840.0n 0.27643 959.9n 0.27643 960.0n 0.96459 1079.9n 0.96459 1080.0n 0.31139 1199.9n 0.31139 1200.0n -0.04662 1319.9n -0.04662 1320.0n 0.55006 1439.9n 0.55006 1440.0n 0.21498 1559.9n 0.21498 1560.0n 0.20119 1679.9n 0.20119 1680.0n 0.70685 1799.9n 0.70685 1800.0n 0.69969 1919.9n 0.69969 1920.0n 0.21498 2039.9n 0.21498 2040.0n 0.27643 2159.9n 0.27643 2160.0n 1.36668 2279.9n 1.36668 2280.0n 0.70685 2399.9n 0.70685 2400.0n 0.17082 2519.9n 0.17082 2520.0n 0.55006 2639.9n 0.55006 2640.0n 0.47556 2759.9n 0.47556 2760.0n 0.96459 2879.9n 0.96459 2880.0n 0.20119 2999.9n 0.20119 3000.0n 0.69969 3119.9n 0.69969 3120.0n 0.88832 3239.9n 0.88832 3240.0n 0.56449 3359.9n 0.56449 3360.0n -0.04662 3479.9n -0.04662 3480.0n 0.35630 3599.9n 0.35630 3600.0n 0.31139 3719.9n 0.31139 3720.0n 0.53141 3839.9n 0.53141 3840.0n 0.55006 3959.9n 0.55006 3960.0n 0.69969 4079.9n 0.69969 4080.0n 0.56449 4199.9n 0.56449 4200.0n 0.17082 4319.9n 0.17082 4320.0n 0.21498 4439.9n 0.21498 4440.0n 0.20119 4559.9n 0.20119 4560.0n 0.35630 4679.9n 0.35630 4680.0n 1.36668 4799.9n 1.36668 4800.0n 0.96459 4919.9n 0.96459 4920.0n 0.88832 5039.9n 0.88832 5040.0n -0.04662 5159.9n -0.04662 5160.0n 0.53141 5279.9n 0.53141 5280.0n 0.70685 5399.9n 0.70685 5400.0n 0.47556 5519.9n 0.47556 5520.0n 0.31139 5639.9n 0.31139 5640.0n 0.27643 5759.9n 0.27643 5760.0n 0.55066 5879.9n 0.55066 5880.0n 0.52079 5999.9n 0.52079 6000.0n 0.24079 6119.9n 0.24079 6120.0n 0.73600 6239.9n 0.73600 6240.0n 0.43581 6359.9n 0.43581 6360.0n 0.69502 6479.9n 0.69502 6480.0n 0.48508 6599.9n 0.48508 6600.0n 0.86030 6719.9n 0.86030 6720.0n 0.57742 6839.9n 0.57742 6840.0n 0.79287 6959.9n 0.79287 6960.0n 0.60090 7079.9n 0.60090 7080.0n 0.23371 7199.9n 0.23371 7200.0n 0.12484 7319.9n 0.12484 7320.0n 0.48351 7439.9n 0.48351 7440.0n 0.52272 7559.9n 0.52272 7560.0n 0.10421 7679.9n 0.10421 7680.0n 0.26187 7799.9n 0.26187 7800.0n 0.26993 7919.9n 0.26993 7920.0n 0.61195 8039.9n 0.61195 8040.0n 0.55435 8159.9n 0.55435 8160.0n -0.31038 8279.9n -0.31038 8280.0n 0.27076 8399.9n 0.27076 8400.0n 0.26419 8519.9n 0.26419 8520.0n 1.07007 8639.9n 1.07007 8640.0n 0.10559 8759.9n 0.10559 8760.0n -0.14927 8879.9n -0.14927 8880.0n 1.38855 8999.9n 1.38855 9000.0n 1.21890 9119.9n 1.21890 9120.0n 1.28851 9239.9n 1.28851 9240.0n 1.24585 9359.9n 1.24585 9360.0n -0.15208 9479.9n -0.15208 9480.0n 0.58159 9599.9n 0.58159 9600.0n 0.75662 9719.9n 0.75662 9720.0n -0.49277 9839.9n -0.49277 9840.0n -0.19260 9959.9n -0.19260 9960.0n 1.27962 10079.9n 1.27962 10080.0n 0.44267 10199.9n 0.44267 10200.0n 0.04400 10319.9n 0.04400 10320.0n 1.04710 10439.9n 1.04710 10440.0n 0.19758 10559.9n 0.19758 10560.0n 0.53141 10679.9n 0.53141 10680.0n 0.21498 10799.9n 0.21498 10800.0n 0.69969 10919.9n 0.69969 10920.0n 0.31139 11039.9n 0.31139 11040.0n 0.70685 11159.9n 0.70685 11160.0n -0.04662 11279.9n -0.04662 11280.0n 0.96459 11399.9n 0.96459 11400.0n 0.55006 11519.9n 0.55006 11520.0n 0.35630 11639.9n 0.35630 11640.0n 0.27643 11759.9n 0.27643 11760.0n 0.88832 11879.9n 0.88832 11880.0n 0.17082 11999.9n 0.17082 12000.0n 1.36668 12119.9n 1.36668 12120.0n 0.56449 12239.9n 0.56449 12240.0n 0.20119 12359.9n 0.20119 12360.0n 0.47556 12479.9n 0.47556 12480.0n 0.70685 12599.9n 0.70685 12600.0n 0.21498 12719.9n 0.21498 12720.0n 0.55006 12839.9n 0.55006 12840.0n 0.88832 12959.9n 0.88832 12960.0n 0.35630 13079.9n 0.35630 13080.0n 0.17082 13199.9n 0.17082 13200.0n 0.53141 13319.9n 0.53141 13320.0n 0.27643 13439.9n 0.27643 13440.0n 0.56449 13559.9n 0.56449 13560.0n 0.69969 13679.9n 0.69969 13680.0n 1.36668 13799.9n 1.36668 13800.0n 0.20119 13919.9n 0.20119 13920.0n 0.47556 14039.9n 0.47556 14040.0n -0.04662 14159.9n -0.04662 14160.0n 0.96459 14279.9n 0.96459 14280.0n 0.31139 14399.9n 0.31139 14400.0n 0.55006 14519.9n 0.55006 14520.0n 0.47556 14639.9n 0.47556 14640.0n 0.69969 14759.9n 0.69969 14760.0n 0.20119 14879.9n 0.20119 14880.0n 1.36668 14999.9n 1.36668 15000.0n 0.56449 15119.9n 0.56449 15120.0n 0.70685 15239.9n 0.70685 15240.0n 0.27643 15359.9n 0.27643 15360.0n 0.96459 15479.9n 0.96459 15480.0n 0.21498 15599.9n 0.21498 15600.0n 0.31139 15719.9n 0.31139 15720.0n 0.35630 15839.9n 0.35630 15840.0n -0.04662 15959.9n -0.04662 15960.0n 0.17082 16079.9n 0.17082 16080.0n 0.88832 16199.9n 0.88832 16200.0n 0.53141 16319.9n 0.53141 16320.0n 0.55066 16439.9n 0.55066 16440.0n 0.52079 16559.9n 0.52079 16560.0n 0.24079 16679.9n 0.24079 16680.0n 0.73600 16799.9n 0.73600 16800.0n 0.43581 16919.9n 0.43581 16920.0n 0.69502 17039.9n 0.69502 17040.0n 0.48508 17159.9n 0.48508 17160.0n 0.86030 17279.9n 0.86030 17280.0n 0.57742 17399.9n 0.57742 17400.0n 0.79287 17519.9n 0.79287 17520.0n 0.60090 17639.9n 0.60090 17640.0n 0.23371 17759.9n 0.23371 17760.0n 0.12484 17879.9n 0.12484 17880.0n 0.48351 17999.9n 0.48351 18000.0n 0.52272 18119.9n 0.52272 18120.0n 0.10421 18239.9n 0.10421 18240.0n 0.26187 18359.9n 0.26187 18360.0n 0.26993 18479.9n 0.26993 18480.0n 0.61195 18599.9n 0.61195 18600.0n 0.55435 18719.9n 0.55435 18720.0n -0.31038 18839.9n -0.31038 18840.0n 0.27076 18959.9n 0.27076 18960.0n 0.26419 19079.9n 0.26419 19080.0n 1.07007 19199.9n 1.07007 19200.0n 0.10559 19319.9n 0.10559 19320.0n -0.14927 19439.9n -0.14927 19440.0n 1.38855 19559.9n 1.38855 19560.0n 1.21890 19679.9n 1.21890 19680.0n 1.28851 19799.9n 1.28851 19800.0n 1.24585 19919.9n 1.24585 19920.0n -0.15208 20039.9n -0.15208 20040.0n 0.58159 20159.9n 0.58159 20160.0n 0.75662 20279.9n 0.75662 20280.0n -0.49277 20399.9n -0.49277 20400.0n -0.19260 20519.9n -0.19260 20520.0n 1.27962 20639.9n 1.27962 20640.0n 0.44267 20759.9n 0.44267 20760.0n 0.04400 20879.9n 0.04400 20880.0n 1.04710 20999.9n 1.04710 21000.0n 0.19758)
Vxn0 a_xn0 0 PWL(0.0n 0.52444 119.9n 0.52444 120.0n 0.64370 239.9n 0.64370 240.0n 0.11168 359.9n 0.11168 360.0n 0.82918 479.9n 0.82918 480.0n 0.46859 599.9n 0.46859 600.0n -0.36668 719.9n -0.36668 720.0n 0.43551 839.9n 0.43551 840.0n 0.72357 959.9n 0.72357 960.0n 0.03541 1079.9n 0.03541 1080.0n 0.68861 1199.9n 0.68861 1200.0n 1.04662 1319.9n 1.04662 1320.0n 0.44994 1439.9n 0.44994 1440.0n 0.78502 1559.9n 0.78502 1560.0n 0.79881 1679.9n 0.79881 1680.0n 0.29315 1799.9n 0.29315 1800.0n 0.30031 1919.9n 0.30031 1920.0n 0.78502 2039.9n 0.78502 2040.0n 0.72357 2159.9n 0.72357 2160.0n -0.36668 2279.9n -0.36668 2280.0n 0.29315 2399.9n 0.29315 2400.0n 0.82918 2519.9n 0.82918 2520.0n 0.44994 2639.9n 0.44994 2640.0n 0.52444 2759.9n 0.52444 2760.0n 0.03541 2879.9n 0.03541 2880.0n 0.79881 2999.9n 0.79881 3000.0n 0.30031 3119.9n 0.30031 3120.0n 0.11168 3239.9n 0.11168 3240.0n 0.43551 3359.9n 0.43551 3360.0n 1.04662 3479.9n 1.04662 3480.0n 0.64370 3599.9n 0.64370 3600.0n 0.68861 3719.9n 0.68861 3720.0n 0.46859 3839.9n 0.46859 3840.0n 0.44994 3959.9n 0.44994 3960.0n 0.30031 4079.9n 0.30031 4080.0n 0.43551 4199.9n 0.43551 4200.0n 0.82918 4319.9n 0.82918 4320.0n 0.78502 4439.9n 0.78502 4440.0n 0.79881 4559.9n 0.79881 4560.0n 0.64370 4679.9n 0.64370 4680.0n -0.36668 4799.9n -0.36668 4800.0n 0.03541 4919.9n 0.03541 4920.0n 0.11168 5039.9n 0.11168 5040.0n 1.04662 5159.9n 1.04662 5160.0n 0.46859 5279.9n 0.46859 5280.0n 0.29315 5399.9n 0.29315 5400.0n 0.52444 5519.9n 0.52444 5520.0n 0.68861 5639.9n 0.68861 5640.0n 0.72357 5759.9n 0.72357 5760.0n 0.44934 5879.9n 0.44934 5880.0n 0.47921 5999.9n 0.47921 6000.0n 0.75921 6119.9n 0.75921 6120.0n 0.26400 6239.9n 0.26400 6240.0n 0.56419 6359.9n 0.56419 6360.0n 0.30498 6479.9n 0.30498 6480.0n 0.51492 6599.9n 0.51492 6600.0n 0.13970 6719.9n 0.13970 6720.0n 0.42258 6839.9n 0.42258 6840.0n 0.20713 6959.9n 0.20713 6960.0n 0.39910 7079.9n 0.39910 7080.0n 0.76629 7199.9n 0.76629 7200.0n 0.87516 7319.9n 0.87516 7320.0n 0.51649 7439.9n 0.51649 7440.0n 0.47728 7559.9n 0.47728 7560.0n 0.89579 7679.9n 0.89579 7680.0n 0.73813 7799.9n 0.73813 7800.0n 0.73007 7919.9n 0.73007 7920.0n 0.38805 8039.9n 0.38805 8040.0n 0.44565 8159.9n 0.44565 8160.0n 1.31038 8279.9n 1.31038 8280.0n 0.72924 8399.9n 0.72924 8400.0n 0.73581 8519.9n 0.73581 8520.0n -0.07007 8639.9n -0.07007 8640.0n 0.89441 8759.9n 0.89441 8760.0n 1.14927 8879.9n 1.14927 8880.0n -0.38855 8999.9n -0.38855 9000.0n -0.21890 9119.9n -0.21890 9120.0n -0.28851 9239.9n -0.28851 9240.0n -0.24585 9359.9n -0.24585 9360.0n 1.15208 9479.9n 1.15208 9480.0n 0.41841 9599.9n 0.41841 9600.0n 0.24338 9719.9n 0.24338 9720.0n 1.49277 9839.9n 1.49277 9840.0n 1.19260 9959.9n 1.19260 9960.0n -0.27962 10079.9n -0.27962 10080.0n 0.55733 10199.9n 0.55733 10200.0n 0.95600 10319.9n 0.95600 10320.0n -0.04710 10439.9n -0.04710 10440.0n 0.80242 10559.9n 0.80242 10560.0n 0.46859 10679.9n 0.46859 10680.0n 0.78502 10799.9n 0.78502 10800.0n 0.30031 10919.9n 0.30031 10920.0n 0.68861 11039.9n 0.68861 11040.0n 0.29315 11159.9n 0.29315 11160.0n 1.04662 11279.9n 1.04662 11280.0n 0.03541 11399.9n 0.03541 11400.0n 0.44994 11519.9n 0.44994 11520.0n 0.64370 11639.9n 0.64370 11640.0n 0.72357 11759.9n 0.72357 11760.0n 0.11168 11879.9n 0.11168 11880.0n 0.82918 11999.9n 0.82918 12000.0n -0.36668 12119.9n -0.36668 12120.0n 0.43551 12239.9n 0.43551 12240.0n 0.79881 12359.9n 0.79881 12360.0n 0.52444 12479.9n 0.52444 12480.0n 0.29315 12599.9n 0.29315 12600.0n 0.78502 12719.9n 0.78502 12720.0n 0.44994 12839.9n 0.44994 12840.0n 0.11168 12959.9n 0.11168 12960.0n 0.64370 13079.9n 0.64370 13080.0n 0.82918 13199.9n 0.82918 13200.0n 0.46859 13319.9n 0.46859 13320.0n 0.72357 13439.9n 0.72357 13440.0n 0.43551 13559.9n 0.43551 13560.0n 0.30031 13679.9n 0.30031 13680.0n -0.36668 13799.9n -0.36668 13800.0n 0.79881 13919.9n 0.79881 13920.0n 0.52444 14039.9n 0.52444 14040.0n 1.04662 14159.9n 1.04662 14160.0n 0.03541 14279.9n 0.03541 14280.0n 0.68861 14399.9n 0.68861 14400.0n 0.44994 14519.9n 0.44994 14520.0n 0.52444 14639.9n 0.52444 14640.0n 0.30031 14759.9n 0.30031 14760.0n 0.79881 14879.9n 0.79881 14880.0n -0.36668 14999.9n -0.36668 15000.0n 0.43551 15119.9n 0.43551 15120.0n 0.29315 15239.9n 0.29315 15240.0n 0.72357 15359.9n 0.72357 15360.0n 0.03541 15479.9n 0.03541 15480.0n 0.78502 15599.9n 0.78502 15600.0n 0.68861 15719.9n 0.68861 15720.0n 0.64370 15839.9n 0.64370 15840.0n 1.04662 15959.9n 1.04662 15960.0n 0.82918 16079.9n 0.82918 16080.0n 0.11168 16199.9n 0.11168 16200.0n 0.46859 16319.9n 0.46859 16320.0n 0.44934 16439.9n 0.44934 16440.0n 0.47921 16559.9n 0.47921 16560.0n 0.75921 16679.9n 0.75921 16680.0n 0.26400 16799.9n 0.26400 16800.0n 0.56419 16919.9n 0.56419 16920.0n 0.30498 17039.9n 0.30498 17040.0n 0.51492 17159.9n 0.51492 17160.0n 0.13970 17279.9n 0.13970 17280.0n 0.42258 17399.9n 0.42258 17400.0n 0.20713 17519.9n 0.20713 17520.0n 0.39910 17639.9n 0.39910 17640.0n 0.76629 17759.9n 0.76629 17760.0n 0.87516 17879.9n 0.87516 17880.0n 0.51649 17999.9n 0.51649 18000.0n 0.47728 18119.9n 0.47728 18120.0n 0.89579 18239.9n 0.89579 18240.0n 0.73813 18359.9n 0.73813 18360.0n 0.73007 18479.9n 0.73007 18480.0n 0.38805 18599.9n 0.38805 18600.0n 0.44565 18719.9n 0.44565 18720.0n 1.31038 18839.9n 1.31038 18840.0n 0.72924 18959.9n 0.72924 18960.0n 0.73581 19079.9n 0.73581 19080.0n -0.07007 19199.9n -0.07007 19200.0n 0.89441 19319.9n 0.89441 19320.0n 1.14927 19439.9n 1.14927 19440.0n -0.38855 19559.9n -0.38855 19560.0n -0.21890 19679.9n -0.21890 19680.0n -0.28851 19799.9n -0.28851 19800.0n -0.24585 19919.9n -0.24585 19920.0n 1.15208 20039.9n 1.15208 20040.0n 0.41841 20159.9n 0.41841 20160.0n 0.24338 20279.9n 0.24338 20280.0n 1.49277 20399.9n 1.49277 20400.0n 1.19260 20519.9n 1.19260 20520.0n -0.27962 20639.9n -0.27962 20640.0n 0.55733 20759.9n 0.55733 20760.0n 0.95600 20879.9n 0.95600 20880.0n -0.04710 20999.9n -0.04710 21000.0n 0.80242)
Vxp1 a_xp1 0 PWL(0.0n -0.37792 119.9n -0.37792 120.0n 0.42554 239.9n 0.42554 240.0n -0.08309 359.9n -0.08309 360.0n 0.66096 479.9n 0.66096 480.0n -0.21828 599.9n -0.21828 600.0n 0.13226 719.9n 0.13226 720.0n 0.28189 839.9n 0.28189 840.0n -0.23386 959.9n -0.23386 960.0n -0.33158 1079.9n -0.33158 1080.0n 0.70122 1199.9n 0.70122 1200.0n 1.18224 1319.9n 1.18224 1320.0n 0.63482 1439.9n 0.63482 1440.0n 0.65842 1559.9n 0.65842 1560.0n 0.25911 1679.9n 0.25911 1680.0n 0.33171 1799.9n 0.33171 1800.0n 1.23180 1919.9n 1.23180 1920.0n 0.65842 2039.9n 0.65842 2040.0n -0.23386 2159.9n -0.23386 2160.0n 0.13226 2279.9n 0.13226 2280.0n 0.33171 2399.9n 0.33171 2400.0n 0.66096 2519.9n 0.66096 2520.0n 0.63482 2639.9n 0.63482 2640.0n -0.37792 2759.9n -0.37792 2760.0n -0.33158 2879.9n -0.33158 2880.0n 0.25911 2999.9n 0.25911 3000.0n 1.23180 3119.9n 1.23180 3120.0n -0.08309 3239.9n -0.08309 3240.0n 0.28189 3359.9n 0.28189 3360.0n 1.18224 3479.9n 1.18224 3480.0n 0.42554 3599.9n 0.42554 3600.0n 0.70122 3719.9n 0.70122 3720.0n -0.21828 3839.9n -0.21828 3840.0n 0.63482 3959.9n 0.63482 3960.0n 1.23180 4079.9n 1.23180 4080.0n 0.28189 4199.9n 0.28189 4200.0n 0.66096 4319.9n 0.66096 4320.0n 0.65842 4439.9n 0.65842 4440.0n 0.25911 4559.9n 0.25911 4560.0n 0.42554 4679.9n 0.42554 4680.0n 0.13226 4799.9n 0.13226 4800.0n -0.33158 4919.9n -0.33158 4920.0n -0.08309 5039.9n -0.08309 5040.0n 1.18224 5159.9n 1.18224 5160.0n -0.21828 5279.9n -0.21828 5280.0n 0.33171 5399.9n 0.33171 5400.0n -0.37792 5519.9n -0.37792 5520.0n 0.70122 5639.9n 0.70122 5640.0n -0.23386 5759.9n -0.23386 5760.0n 0.76415 5879.9n 0.76415 5880.0n 0.34013 5999.9n 0.34013 6000.0n 0.56595 6119.9n 0.56595 6120.0n 0.23835 6239.9n 0.23835 6240.0n 0.67130 6359.9n 0.67130 6360.0n 0.48458 6479.9n 0.48458 6480.0n 0.29915 6599.9n 0.29915 6600.0n 0.40313 6719.9n 0.40313 6720.0n 0.36576 6839.9n 0.36576 6840.0n 0.33730 6959.9n 0.33730 6960.0n 0.38385 7079.9n 0.38385 7080.0n 0.59706 7199.9n 0.59706 7200.0n 0.62307 7319.9n 0.62307 7320.0n 0.67018 7439.9n 0.67018 7440.0n 0.70540 7559.9n 0.70540 7560.0n 0.53582 7679.9n 0.53582 7680.0n 0.33357 7799.9n 0.33357 7800.0n 0.52885 7919.9n 0.52885 7920.0n 0.74383 8039.9n 0.74383 8040.0n 0.78409 8159.9n 0.78409 8160.0n 0.28700 8279.9n 0.28700 8280.0n 1.27694 8399.9n 1.27694 8400.0n -0.15161 8519.9n -0.15161 8520.0n 1.28574 8639.9n 1.28574 8640.0n 1.11225 8759.9n 1.11225 8760.0n 1.17517 8879.9n 1.17517 8880.0n 0.59247 8999.9n 0.59247 9000.0n 1.20712 9119.9n 1.20712 9120.0n 0.87402 9239.9n 0.87402 9240.0n -0.10545 9359.9n -0.10545 9360.0n -0.25282 9479.9n -0.25282 9480.0n -0.37666 9599.9n -0.37666 9600.0n 1.43391 9719.9n 1.43391 9720.0n 0.37511 9839.9n 0.37511 9840.0n 0.35780 9959.9n 0.35780 9960.0n 1.04281 10079.9n 1.04281 10080.0n 1.30757 10199.9n 1.30757 10200.0n -0.27950 10319.9n -0.27950 10320.0n 0.10137 10439.9n 0.10137 10440.0n 1.20727 10559.9n 1.20727 10560.0n -0.21828 10679.9n -0.21828 10680.0n 0.65842 10799.9n 0.65842 10800.0n 1.23180 10919.9n 1.23180 10920.0n 0.70122 11039.9n 0.70122 11040.0n 0.33171 11159.9n 0.33171 11160.0n 1.18224 11279.9n 1.18224 11280.0n -0.33158 11399.9n -0.33158 11400.0n 0.63482 11519.9n 0.63482 11520.0n 0.42554 11639.9n 0.42554 11640.0n -0.23386 11759.9n -0.23386 11760.0n -0.08309 11879.9n -0.08309 11880.0n 0.66096 11999.9n 0.66096 12000.0n 0.13226 12119.9n 0.13226 12120.0n 0.28189 12239.9n 0.28189 12240.0n 0.25911 12359.9n 0.25911 12360.0n -0.37792 12479.9n -0.37792 12480.0n 0.33171 12599.9n 0.33171 12600.0n 0.65842 12719.9n 0.65842 12720.0n 0.63482 12839.9n 0.63482 12840.0n -0.08309 12959.9n -0.08309 12960.0n 0.42554 13079.9n 0.42554 13080.0n 0.66096 13199.9n 0.66096 13200.0n -0.21828 13319.9n -0.21828 13320.0n -0.23386 13439.9n -0.23386 13440.0n 0.28189 13559.9n 0.28189 13560.0n 1.23180 13679.9n 1.23180 13680.0n 0.13226 13799.9n 0.13226 13800.0n 0.25911 13919.9n 0.25911 13920.0n -0.37792 14039.9n -0.37792 14040.0n 1.18224 14159.9n 1.18224 14160.0n -0.33158 14279.9n -0.33158 14280.0n 0.70122 14399.9n 0.70122 14400.0n 0.63482 14519.9n 0.63482 14520.0n -0.37792 14639.9n -0.37792 14640.0n 1.23180 14759.9n 1.23180 14760.0n 0.25911 14879.9n 0.25911 14880.0n 0.13226 14999.9n 0.13226 15000.0n 0.28189 15119.9n 0.28189 15120.0n 0.33171 15239.9n 0.33171 15240.0n -0.23386 15359.9n -0.23386 15360.0n -0.33158 15479.9n -0.33158 15480.0n 0.65842 15599.9n 0.65842 15600.0n 0.70122 15719.9n 0.70122 15720.0n 0.42554 15839.9n 0.42554 15840.0n 1.18224 15959.9n 1.18224 15960.0n 0.66096 16079.9n 0.66096 16080.0n -0.08309 16199.9n -0.08309 16200.0n -0.21828 16319.9n -0.21828 16320.0n 0.76415 16439.9n 0.76415 16440.0n 0.34013 16559.9n 0.34013 16560.0n 0.56595 16679.9n 0.56595 16680.0n 0.23835 16799.9n 0.23835 16800.0n 0.67130 16919.9n 0.67130 16920.0n 0.48458 17039.9n 0.48458 17040.0n 0.29915 17159.9n 0.29915 17160.0n 0.40313 17279.9n 0.40313 17280.0n 0.36576 17399.9n 0.36576 17400.0n 0.33730 17519.9n 0.33730 17520.0n 0.38385 17639.9n 0.38385 17640.0n 0.59706 17759.9n 0.59706 17760.0n 0.62307 17879.9n 0.62307 17880.0n 0.67018 17999.9n 0.67018 18000.0n 0.70540 18119.9n 0.70540 18120.0n 0.53582 18239.9n 0.53582 18240.0n 0.33357 18359.9n 0.33357 18360.0n 0.52885 18479.9n 0.52885 18480.0n 0.74383 18599.9n 0.74383 18600.0n 0.78409 18719.9n 0.78409 18720.0n 0.28700 18839.9n 0.28700 18840.0n 1.27694 18959.9n 1.27694 18960.0n -0.15161 19079.9n -0.15161 19080.0n 1.28574 19199.9n 1.28574 19200.0n 1.11225 19319.9n 1.11225 19320.0n 1.17517 19439.9n 1.17517 19440.0n 0.59247 19559.9n 0.59247 19560.0n 1.20712 19679.9n 1.20712 19680.0n 0.87402 19799.9n 0.87402 19800.0n -0.10545 19919.9n -0.10545 19920.0n -0.25282 20039.9n -0.25282 20040.0n -0.37666 20159.9n -0.37666 20160.0n 1.43391 20279.9n 1.43391 20280.0n 0.37511 20399.9n 0.37511 20400.0n 0.35780 20519.9n 0.35780 20520.0n 1.04281 20639.9n 1.04281 20640.0n 1.30757 20759.9n 1.30757 20760.0n -0.27950 20879.9n -0.27950 20880.0n 0.10137 20999.9n 0.10137 21000.0n 1.20727)
Vxn1 a_xn1 0 PWL(0.0n 1.37792 119.9n 1.37792 120.0n 0.57446 239.9n 0.57446 240.0n 1.08309 359.9n 1.08309 360.0n 0.33904 479.9n 0.33904 480.0n 1.21828 599.9n 1.21828 600.0n 0.86774 719.9n 0.86774 720.0n 0.71811 839.9n 0.71811 840.0n 1.23386 959.9n 1.23386 960.0n 1.33158 1079.9n 1.33158 1080.0n 0.29878 1199.9n 0.29878 1200.0n -0.18224 1319.9n -0.18224 1320.0n 0.36518 1439.9n 0.36518 1440.0n 0.34158 1559.9n 0.34158 1560.0n 0.74089 1679.9n 0.74089 1680.0n 0.66829 1799.9n 0.66829 1800.0n -0.23180 1919.9n -0.23180 1920.0n 0.34158 2039.9n 0.34158 2040.0n 1.23386 2159.9n 1.23386 2160.0n 0.86774 2279.9n 0.86774 2280.0n 0.66829 2399.9n 0.66829 2400.0n 0.33904 2519.9n 0.33904 2520.0n 0.36518 2639.9n 0.36518 2640.0n 1.37792 2759.9n 1.37792 2760.0n 1.33158 2879.9n 1.33158 2880.0n 0.74089 2999.9n 0.74089 3000.0n -0.23180 3119.9n -0.23180 3120.0n 1.08309 3239.9n 1.08309 3240.0n 0.71811 3359.9n 0.71811 3360.0n -0.18224 3479.9n -0.18224 3480.0n 0.57446 3599.9n 0.57446 3600.0n 0.29878 3719.9n 0.29878 3720.0n 1.21828 3839.9n 1.21828 3840.0n 0.36518 3959.9n 0.36518 3960.0n -0.23180 4079.9n -0.23180 4080.0n 0.71811 4199.9n 0.71811 4200.0n 0.33904 4319.9n 0.33904 4320.0n 0.34158 4439.9n 0.34158 4440.0n 0.74089 4559.9n 0.74089 4560.0n 0.57446 4679.9n 0.57446 4680.0n 0.86774 4799.9n 0.86774 4800.0n 1.33158 4919.9n 1.33158 4920.0n 1.08309 5039.9n 1.08309 5040.0n -0.18224 5159.9n -0.18224 5160.0n 1.21828 5279.9n 1.21828 5280.0n 0.66829 5399.9n 0.66829 5400.0n 1.37792 5519.9n 1.37792 5520.0n 0.29878 5639.9n 0.29878 5640.0n 1.23386 5759.9n 1.23386 5760.0n 0.23585 5879.9n 0.23585 5880.0n 0.65987 5999.9n 0.65987 6000.0n 0.43405 6119.9n 0.43405 6120.0n 0.76165 6239.9n 0.76165 6240.0n 0.32870 6359.9n 0.32870 6360.0n 0.51542 6479.9n 0.51542 6480.0n 0.70085 6599.9n 0.70085 6600.0n 0.59687 6719.9n 0.59687 6720.0n 0.63424 6839.9n 0.63424 6840.0n 0.66270 6959.9n 0.66270 6960.0n 0.61615 7079.9n 0.61615 7080.0n 0.40294 7199.9n 0.40294 7200.0n 0.37693 7319.9n 0.37693 7320.0n 0.32982 7439.9n 0.32982 7440.0n 0.29460 7559.9n 0.29460 7560.0n 0.46418 7679.9n 0.46418 7680.0n 0.66643 7799.9n 0.66643 7800.0n 0.47115 7919.9n 0.47115 7920.0n 0.25617 8039.9n 0.25617 8040.0n 0.21591 8159.9n 0.21591 8160.0n 0.71300 8279.9n 0.71300 8280.0n -0.27694 8399.9n -0.27694 8400.0n 1.15161 8519.9n 1.15161 8520.0n -0.28574 8639.9n -0.28574 8640.0n -0.11225 8759.9n -0.11225 8760.0n -0.17517 8879.9n -0.17517 8880.0n 0.40753 8999.9n 0.40753 9000.0n -0.20712 9119.9n -0.20712 9120.0n 0.12598 9239.9n 0.12598 9240.0n 1.10545 9359.9n 1.10545 9360.0n 1.25282 9479.9n 1.25282 9480.0n 1.37666 9599.9n 1.37666 9600.0n -0.43391 9719.9n -0.43391 9720.0n 0.62489 9839.9n 0.62489 9840.0n 0.64220 9959.9n 0.64220 9960.0n -0.04281 10079.9n -0.04281 10080.0n -0.30757 10199.9n -0.30757 10200.0n 1.27950 10319.9n 1.27950 10320.0n 0.89863 10439.9n 0.89863 10440.0n -0.20727 10559.9n -0.20727 10560.0n 1.21828 10679.9n 1.21828 10680.0n 0.34158 10799.9n 0.34158 10800.0n -0.23180 10919.9n -0.23180 10920.0n 0.29878 11039.9n 0.29878 11040.0n 0.66829 11159.9n 0.66829 11160.0n -0.18224 11279.9n -0.18224 11280.0n 1.33158 11399.9n 1.33158 11400.0n 0.36518 11519.9n 0.36518 11520.0n 0.57446 11639.9n 0.57446 11640.0n 1.23386 11759.9n 1.23386 11760.0n 1.08309 11879.9n 1.08309 11880.0n 0.33904 11999.9n 0.33904 12000.0n 0.86774 12119.9n 0.86774 12120.0n 0.71811 12239.9n 0.71811 12240.0n 0.74089 12359.9n 0.74089 12360.0n 1.37792 12479.9n 1.37792 12480.0n 0.66829 12599.9n 0.66829 12600.0n 0.34158 12719.9n 0.34158 12720.0n 0.36518 12839.9n 0.36518 12840.0n 1.08309 12959.9n 1.08309 12960.0n 0.57446 13079.9n 0.57446 13080.0n 0.33904 13199.9n 0.33904 13200.0n 1.21828 13319.9n 1.21828 13320.0n 1.23386 13439.9n 1.23386 13440.0n 0.71811 13559.9n 0.71811 13560.0n -0.23180 13679.9n -0.23180 13680.0n 0.86774 13799.9n 0.86774 13800.0n 0.74089 13919.9n 0.74089 13920.0n 1.37792 14039.9n 1.37792 14040.0n -0.18224 14159.9n -0.18224 14160.0n 1.33158 14279.9n 1.33158 14280.0n 0.29878 14399.9n 0.29878 14400.0n 0.36518 14519.9n 0.36518 14520.0n 1.37792 14639.9n 1.37792 14640.0n -0.23180 14759.9n -0.23180 14760.0n 0.74089 14879.9n 0.74089 14880.0n 0.86774 14999.9n 0.86774 15000.0n 0.71811 15119.9n 0.71811 15120.0n 0.66829 15239.9n 0.66829 15240.0n 1.23386 15359.9n 1.23386 15360.0n 1.33158 15479.9n 1.33158 15480.0n 0.34158 15599.9n 0.34158 15600.0n 0.29878 15719.9n 0.29878 15720.0n 0.57446 15839.9n 0.57446 15840.0n -0.18224 15959.9n -0.18224 15960.0n 0.33904 16079.9n 0.33904 16080.0n 1.08309 16199.9n 1.08309 16200.0n 1.21828 16319.9n 1.21828 16320.0n 0.23585 16439.9n 0.23585 16440.0n 0.65987 16559.9n 0.65987 16560.0n 0.43405 16679.9n 0.43405 16680.0n 0.76165 16799.9n 0.76165 16800.0n 0.32870 16919.9n 0.32870 16920.0n 0.51542 17039.9n 0.51542 17040.0n 0.70085 17159.9n 0.70085 17160.0n 0.59687 17279.9n 0.59687 17280.0n 0.63424 17399.9n 0.63424 17400.0n 0.66270 17519.9n 0.66270 17520.0n 0.61615 17639.9n 0.61615 17640.0n 0.40294 17759.9n 0.40294 17760.0n 0.37693 17879.9n 0.37693 17880.0n 0.32982 17999.9n 0.32982 18000.0n 0.29460 18119.9n 0.29460 18120.0n 0.46418 18239.9n 0.46418 18240.0n 0.66643 18359.9n 0.66643 18360.0n 0.47115 18479.9n 0.47115 18480.0n 0.25617 18599.9n 0.25617 18600.0n 0.21591 18719.9n 0.21591 18720.0n 0.71300 18839.9n 0.71300 18840.0n -0.27694 18959.9n -0.27694 18960.0n 1.15161 19079.9n 1.15161 19080.0n -0.28574 19199.9n -0.28574 19200.0n -0.11225 19319.9n -0.11225 19320.0n -0.17517 19439.9n -0.17517 19440.0n 0.40753 19559.9n 0.40753 19560.0n -0.20712 19679.9n -0.20712 19680.0n 0.12598 19799.9n 0.12598 19800.0n 1.10545 19919.9n 1.10545 19920.0n 1.25282 20039.9n 1.25282 20040.0n 1.37666 20159.9n 1.37666 20160.0n -0.43391 20279.9n -0.43391 20280.0n 0.62489 20399.9n 0.62489 20400.0n 0.64220 20519.9n 0.64220 20520.0n -0.04281 20639.9n -0.04281 20640.0n -0.30757 20759.9n -0.30757 20760.0n 1.27950 20879.9n 1.27950 20880.0n 0.89863 20999.9n 0.89863 21000.0n -0.20727)
Vxp2 a_xp2 0 PWL(0.0n 0.80000 119.9n 0.80000 120.0n 0.80000 239.9n 0.80000 240.0n 0.80000 359.9n 0.80000 360.0n 0.80000 479.9n 0.80000 480.0n 0.80000 599.9n 0.80000 600.0n 0.80000 719.9n 0.80000 720.0n 0.80000 839.9n 0.80000 840.0n 0.80000 959.9n 0.80000 960.0n 0.80000 1079.9n 0.80000 1080.0n 0.80000 1199.9n 0.80000 1200.0n 0.80000 1319.9n 0.80000 1320.0n 0.80000 1439.9n 0.80000 1440.0n 0.80000 1559.9n 0.80000 1560.0n 0.80000 1679.9n 0.80000 1680.0n 0.80000 1799.9n 0.80000 1800.0n 0.80000 1919.9n 0.80000 1920.0n 0.80000 2039.9n 0.80000 2040.0n 0.80000 2159.9n 0.80000 2160.0n 0.80000 2279.9n 0.80000 2280.0n 0.80000 2399.9n 0.80000 2400.0n 0.80000 2519.9n 0.80000 2520.0n 0.80000 2639.9n 0.80000 2640.0n 0.80000 2759.9n 0.80000 2760.0n 0.80000 2879.9n 0.80000 2880.0n 0.80000 2999.9n 0.80000 3000.0n 0.80000 3119.9n 0.80000 3120.0n 0.80000 3239.9n 0.80000 3240.0n 0.80000 3359.9n 0.80000 3360.0n 0.80000 3479.9n 0.80000 3480.0n 0.80000 3599.9n 0.80000 3600.0n 0.80000 3719.9n 0.80000 3720.0n 0.80000 3839.9n 0.80000 3840.0n 0.80000 3959.9n 0.80000 3960.0n 0.80000 4079.9n 0.80000 4080.0n 0.80000 4199.9n 0.80000 4200.0n 0.80000 4319.9n 0.80000 4320.0n 0.80000 4439.9n 0.80000 4440.0n 0.80000 4559.9n 0.80000 4560.0n 0.80000 4679.9n 0.80000 4680.0n 0.80000 4799.9n 0.80000 4800.0n 0.80000 4919.9n 0.80000 4920.0n 0.80000 5039.9n 0.80000 5040.0n 0.80000 5159.9n 0.80000 5160.0n 0.80000 5279.9n 0.80000 5280.0n 0.80000 5399.9n 0.80000 5400.0n 0.80000 5519.9n 0.80000 5520.0n 0.80000 5639.9n 0.80000 5640.0n 0.80000 5759.9n 0.80000 5760.0n 0.80000 5879.9n 0.80000 5880.0n 0.80000 5999.9n 0.80000 6000.0n 0.80000 6119.9n 0.80000 6120.0n 0.80000 6239.9n 0.80000 6240.0n 0.80000 6359.9n 0.80000 6360.0n 0.80000 6479.9n 0.80000 6480.0n 0.80000 6599.9n 0.80000 6600.0n 0.80000 6719.9n 0.80000 6720.0n 0.80000 6839.9n 0.80000 6840.0n 0.80000 6959.9n 0.80000 6960.0n 0.80000 7079.9n 0.80000 7080.0n 0.80000 7199.9n 0.80000 7200.0n 0.80000 7319.9n 0.80000 7320.0n 0.80000 7439.9n 0.80000 7440.0n 0.80000 7559.9n 0.80000 7560.0n 0.80000 7679.9n 0.80000 7680.0n 0.80000 7799.9n 0.80000 7800.0n 0.80000 7919.9n 0.80000 7920.0n 0.80000 8039.9n 0.80000 8040.0n 0.80000 8159.9n 0.80000 8160.0n 0.80000 8279.9n 0.80000 8280.0n 0.80000 8399.9n 0.80000 8400.0n 0.80000 8519.9n 0.80000 8520.0n 0.80000 8639.9n 0.80000 8640.0n 0.80000 8759.9n 0.80000 8760.0n 0.80000 8879.9n 0.80000 8880.0n 0.80000 8999.9n 0.80000 9000.0n 0.80000 9119.9n 0.80000 9120.0n 0.80000 9239.9n 0.80000 9240.0n 0.80000 9359.9n 0.80000 9360.0n 0.80000 9479.9n 0.80000 9480.0n 0.80000 9599.9n 0.80000 9600.0n 0.80000 9719.9n 0.80000 9720.0n 0.80000 9839.9n 0.80000 9840.0n 0.80000 9959.9n 0.80000 9960.0n 0.80000 10079.9n 0.80000 10080.0n 0.80000 10199.9n 0.80000 10200.0n 0.80000 10319.9n 0.80000 10320.0n 0.80000 10439.9n 0.80000 10440.0n 0.80000 10559.9n 0.80000 10560.0n 0.80000 10679.9n 0.80000 10680.0n 0.80000 10799.9n 0.80000 10800.0n 0.80000 10919.9n 0.80000 10920.0n 0.80000 11039.9n 0.80000 11040.0n 0.80000 11159.9n 0.80000 11160.0n 0.80000 11279.9n 0.80000 11280.0n 0.80000 11399.9n 0.80000 11400.0n 0.80000 11519.9n 0.80000 11520.0n 0.80000 11639.9n 0.80000 11640.0n 0.80000 11759.9n 0.80000 11760.0n 0.80000 11879.9n 0.80000 11880.0n 0.80000 11999.9n 0.80000 12000.0n 0.80000 12119.9n 0.80000 12120.0n 0.80000 12239.9n 0.80000 12240.0n 0.80000 12359.9n 0.80000 12360.0n 0.80000 12479.9n 0.80000 12480.0n 0.80000 12599.9n 0.80000 12600.0n 0.80000 12719.9n 0.80000 12720.0n 0.80000 12839.9n 0.80000 12840.0n 0.80000 12959.9n 0.80000 12960.0n 0.80000 13079.9n 0.80000 13080.0n 0.80000 13199.9n 0.80000 13200.0n 0.80000 13319.9n 0.80000 13320.0n 0.80000 13439.9n 0.80000 13440.0n 0.80000 13559.9n 0.80000 13560.0n 0.80000 13679.9n 0.80000 13680.0n 0.80000 13799.9n 0.80000 13800.0n 0.80000 13919.9n 0.80000 13920.0n 0.80000 14039.9n 0.80000 14040.0n 0.80000 14159.9n 0.80000 14160.0n 0.80000 14279.9n 0.80000 14280.0n 0.80000 14399.9n 0.80000 14400.0n 0.80000 14519.9n 0.80000 14520.0n 0.80000 14639.9n 0.80000 14640.0n 0.80000 14759.9n 0.80000 14760.0n 0.80000 14879.9n 0.80000 14880.0n 0.80000 14999.9n 0.80000 15000.0n 0.80000 15119.9n 0.80000 15120.0n 0.80000 15239.9n 0.80000 15240.0n 0.80000 15359.9n 0.80000 15360.0n 0.80000 15479.9n 0.80000 15480.0n 0.80000 15599.9n 0.80000 15600.0n 0.80000 15719.9n 0.80000 15720.0n 0.80000 15839.9n 0.80000 15840.0n 0.80000 15959.9n 0.80000 15960.0n 0.80000 16079.9n 0.80000 16080.0n 0.80000 16199.9n 0.80000 16200.0n 0.80000 16319.9n 0.80000 16320.0n 0.80000 16439.9n 0.80000 16440.0n 0.80000 16559.9n 0.80000 16560.0n 0.80000 16679.9n 0.80000 16680.0n 0.80000 16799.9n 0.80000 16800.0n 0.80000 16919.9n 0.80000 16920.0n 0.80000 17039.9n 0.80000 17040.0n 0.80000 17159.9n 0.80000 17160.0n 0.80000 17279.9n 0.80000 17280.0n 0.80000 17399.9n 0.80000 17400.0n 0.80000 17519.9n 0.80000 17520.0n 0.80000 17639.9n 0.80000 17640.0n 0.80000 17759.9n 0.80000 17760.0n 0.80000 17879.9n 0.80000 17880.0n 0.80000 17999.9n 0.80000 18000.0n 0.80000 18119.9n 0.80000 18120.0n 0.80000 18239.9n 0.80000 18240.0n 0.80000 18359.9n 0.80000 18360.0n 0.80000 18479.9n 0.80000 18480.0n 0.80000 18599.9n 0.80000 18600.0n 0.80000 18719.9n 0.80000 18720.0n 0.80000 18839.9n 0.80000 18840.0n 0.80000 18959.9n 0.80000 18960.0n 0.80000 19079.9n 0.80000 19080.0n 0.80000 19199.9n 0.80000 19200.0n 0.80000 19319.9n 0.80000 19320.0n 0.80000 19439.9n 0.80000 19440.0n 0.80000 19559.9n 0.80000 19560.0n 0.80000 19679.9n 0.80000 19680.0n 0.80000 19799.9n 0.80000 19800.0n 0.80000 19919.9n 0.80000 19920.0n 0.80000 20039.9n 0.80000 20040.0n 0.80000 20159.9n 0.80000 20160.0n 0.80000 20279.9n 0.80000 20280.0n 0.80000 20399.9n 0.80000 20400.0n 0.80000 20519.9n 0.80000 20520.0n 0.80000 20639.9n 0.80000 20640.0n 0.80000 20759.9n 0.80000 20760.0n 0.80000 20879.9n 0.80000 20880.0n 0.80000 20999.9n 0.80000 21000.0n 0.80000)
Vxn2 a_xn2 0 PWL(0.0n 0.20000 119.9n 0.20000 120.0n 0.20000 239.9n 0.20000 240.0n 0.20000 359.9n 0.20000 360.0n 0.20000 479.9n 0.20000 480.0n 0.20000 599.9n 0.20000 600.0n 0.20000 719.9n 0.20000 720.0n 0.20000 839.9n 0.20000 840.0n 0.20000 959.9n 0.20000 960.0n 0.20000 1079.9n 0.20000 1080.0n 0.20000 1199.9n 0.20000 1200.0n 0.20000 1319.9n 0.20000 1320.0n 0.20000 1439.9n 0.20000 1440.0n 0.20000 1559.9n 0.20000 1560.0n 0.20000 1679.9n 0.20000 1680.0n 0.20000 1799.9n 0.20000 1800.0n 0.20000 1919.9n 0.20000 1920.0n 0.20000 2039.9n 0.20000 2040.0n 0.20000 2159.9n 0.20000 2160.0n 0.20000 2279.9n 0.20000 2280.0n 0.20000 2399.9n 0.20000 2400.0n 0.20000 2519.9n 0.20000 2520.0n 0.20000 2639.9n 0.20000 2640.0n 0.20000 2759.9n 0.20000 2760.0n 0.20000 2879.9n 0.20000 2880.0n 0.20000 2999.9n 0.20000 3000.0n 0.20000 3119.9n 0.20000 3120.0n 0.20000 3239.9n 0.20000 3240.0n 0.20000 3359.9n 0.20000 3360.0n 0.20000 3479.9n 0.20000 3480.0n 0.20000 3599.9n 0.20000 3600.0n 0.20000 3719.9n 0.20000 3720.0n 0.20000 3839.9n 0.20000 3840.0n 0.20000 3959.9n 0.20000 3960.0n 0.20000 4079.9n 0.20000 4080.0n 0.20000 4199.9n 0.20000 4200.0n 0.20000 4319.9n 0.20000 4320.0n 0.20000 4439.9n 0.20000 4440.0n 0.20000 4559.9n 0.20000 4560.0n 0.20000 4679.9n 0.20000 4680.0n 0.20000 4799.9n 0.20000 4800.0n 0.20000 4919.9n 0.20000 4920.0n 0.20000 5039.9n 0.20000 5040.0n 0.20000 5159.9n 0.20000 5160.0n 0.20000 5279.9n 0.20000 5280.0n 0.20000 5399.9n 0.20000 5400.0n 0.20000 5519.9n 0.20000 5520.0n 0.20000 5639.9n 0.20000 5640.0n 0.20000 5759.9n 0.20000 5760.0n 0.20000 5879.9n 0.20000 5880.0n 0.20000 5999.9n 0.20000 6000.0n 0.20000 6119.9n 0.20000 6120.0n 0.20000 6239.9n 0.20000 6240.0n 0.20000 6359.9n 0.20000 6360.0n 0.20000 6479.9n 0.20000 6480.0n 0.20000 6599.9n 0.20000 6600.0n 0.20000 6719.9n 0.20000 6720.0n 0.20000 6839.9n 0.20000 6840.0n 0.20000 6959.9n 0.20000 6960.0n 0.20000 7079.9n 0.20000 7080.0n 0.20000 7199.9n 0.20000 7200.0n 0.20000 7319.9n 0.20000 7320.0n 0.20000 7439.9n 0.20000 7440.0n 0.20000 7559.9n 0.20000 7560.0n 0.20000 7679.9n 0.20000 7680.0n 0.20000 7799.9n 0.20000 7800.0n 0.20000 7919.9n 0.20000 7920.0n 0.20000 8039.9n 0.20000 8040.0n 0.20000 8159.9n 0.20000 8160.0n 0.20000 8279.9n 0.20000 8280.0n 0.20000 8399.9n 0.20000 8400.0n 0.20000 8519.9n 0.20000 8520.0n 0.20000 8639.9n 0.20000 8640.0n 0.20000 8759.9n 0.20000 8760.0n 0.20000 8879.9n 0.20000 8880.0n 0.20000 8999.9n 0.20000 9000.0n 0.20000 9119.9n 0.20000 9120.0n 0.20000 9239.9n 0.20000 9240.0n 0.20000 9359.9n 0.20000 9360.0n 0.20000 9479.9n 0.20000 9480.0n 0.20000 9599.9n 0.20000 9600.0n 0.20000 9719.9n 0.20000 9720.0n 0.20000 9839.9n 0.20000 9840.0n 0.20000 9959.9n 0.20000 9960.0n 0.20000 10079.9n 0.20000 10080.0n 0.20000 10199.9n 0.20000 10200.0n 0.20000 10319.9n 0.20000 10320.0n 0.20000 10439.9n 0.20000 10440.0n 0.20000 10559.9n 0.20000 10560.0n 0.20000 10679.9n 0.20000 10680.0n 0.20000 10799.9n 0.20000 10800.0n 0.20000 10919.9n 0.20000 10920.0n 0.20000 11039.9n 0.20000 11040.0n 0.20000 11159.9n 0.20000 11160.0n 0.20000 11279.9n 0.20000 11280.0n 0.20000 11399.9n 0.20000 11400.0n 0.20000 11519.9n 0.20000 11520.0n 0.20000 11639.9n 0.20000 11640.0n 0.20000 11759.9n 0.20000 11760.0n 0.20000 11879.9n 0.20000 11880.0n 0.20000 11999.9n 0.20000 12000.0n 0.20000 12119.9n 0.20000 12120.0n 0.20000 12239.9n 0.20000 12240.0n 0.20000 12359.9n 0.20000 12360.0n 0.20000 12479.9n 0.20000 12480.0n 0.20000 12599.9n 0.20000 12600.0n 0.20000 12719.9n 0.20000 12720.0n 0.20000 12839.9n 0.20000 12840.0n 0.20000 12959.9n 0.20000 12960.0n 0.20000 13079.9n 0.20000 13080.0n 0.20000 13199.9n 0.20000 13200.0n 0.20000 13319.9n 0.20000 13320.0n 0.20000 13439.9n 0.20000 13440.0n 0.20000 13559.9n 0.20000 13560.0n 0.20000 13679.9n 0.20000 13680.0n 0.20000 13799.9n 0.20000 13800.0n 0.20000 13919.9n 0.20000 13920.0n 0.20000 14039.9n 0.20000 14040.0n 0.20000 14159.9n 0.20000 14160.0n 0.20000 14279.9n 0.20000 14280.0n 0.20000 14399.9n 0.20000 14400.0n 0.20000 14519.9n 0.20000 14520.0n 0.20000 14639.9n 0.20000 14640.0n 0.20000 14759.9n 0.20000 14760.0n 0.20000 14879.9n 0.20000 14880.0n 0.20000 14999.9n 0.20000 15000.0n 0.20000 15119.9n 0.20000 15120.0n 0.20000 15239.9n 0.20000 15240.0n 0.20000 15359.9n 0.20000 15360.0n 0.20000 15479.9n 0.20000 15480.0n 0.20000 15599.9n 0.20000 15600.0n 0.20000 15719.9n 0.20000 15720.0n 0.20000 15839.9n 0.20000 15840.0n 0.20000 15959.9n 0.20000 15960.0n 0.20000 16079.9n 0.20000 16080.0n 0.20000 16199.9n 0.20000 16200.0n 0.20000 16319.9n 0.20000 16320.0n 0.20000 16439.9n 0.20000 16440.0n 0.20000 16559.9n 0.20000 16560.0n 0.20000 16679.9n 0.20000 16680.0n 0.20000 16799.9n 0.20000 16800.0n 0.20000 16919.9n 0.20000 16920.0n 0.20000 17039.9n 0.20000 17040.0n 0.20000 17159.9n 0.20000 17160.0n 0.20000 17279.9n 0.20000 17280.0n 0.20000 17399.9n 0.20000 17400.0n 0.20000 17519.9n 0.20000 17520.0n 0.20000 17639.9n 0.20000 17640.0n 0.20000 17759.9n 0.20000 17760.0n 0.20000 17879.9n 0.20000 17880.0n 0.20000 17999.9n 0.20000 18000.0n 0.20000 18119.9n 0.20000 18120.0n 0.20000 18239.9n 0.20000 18240.0n 0.20000 18359.9n 0.20000 18360.0n 0.20000 18479.9n 0.20000 18480.0n 0.20000 18599.9n 0.20000 18600.0n 0.20000 18719.9n 0.20000 18720.0n 0.20000 18839.9n 0.20000 18840.0n 0.20000 18959.9n 0.20000 18960.0n 0.20000 19079.9n 0.20000 19080.0n 0.20000 19199.9n 0.20000 19200.0n 0.20000 19319.9n 0.20000 19320.0n 0.20000 19439.9n 0.20000 19440.0n 0.20000 19559.9n 0.20000 19560.0n 0.20000 19679.9n 0.20000 19680.0n 0.20000 19799.9n 0.20000 19800.0n 0.20000 19919.9n 0.20000 19920.0n 0.20000 20039.9n 0.20000 20040.0n 0.20000 20159.9n 0.20000 20160.0n 0.20000 20279.9n 0.20000 20280.0n 0.20000 20399.9n 0.20000 20400.0n 0.20000 20519.9n 0.20000 20520.0n 0.20000 20639.9n 0.20000 20640.0n 0.20000 20759.9n 0.20000 20760.0n 0.20000 20879.9n 0.20000 20880.0n 0.20000 20999.9n 0.20000 21000.0n 0.20000)
Vxop0 xop0 0 PWL(0.0n 0.30000 119.9n 0.30000 120.0n 0.70000 239.9n 0.70000 240.0n 0.30000 359.9n 0.30000 360.0n 0.70000 479.9n 0.70000 480.0n 0.30000 599.9n 0.30000 600.0n 0.30000 719.9n 0.30000 720.0n 0.70000 839.9n 0.70000 840.0n 0.30000 959.9n 0.30000 960.0n 0.30000 1079.9n 0.30000 1080.0n 0.70000 1199.9n 0.70000 1200.0n 0.30000 1319.9n 0.30000 1320.0n 0.70000 1439.9n 0.70000 1440.0n 0.70000 1559.9n 0.70000 1560.0n 0.70000 1679.9n 0.70000 1680.0n 0.70000 1799.9n 0.70000 1800.0n 0.30000 1919.9n 0.30000 1920.0n 0.70000 2039.9n 0.70000 2040.0n 0.30000 2159.9n 0.30000 2160.0n 0.30000 2279.9n 0.30000 2280.0n 0.70000 2399.9n 0.70000 2400.0n 0.70000 2519.9n 0.70000 2520.0n 0.70000 2639.9n 0.70000 2640.0n 0.30000 2759.9n 0.30000 2760.0n 0.30000 2879.9n 0.30000 2880.0n 0.70000 2999.9n 0.70000 3000.0n 0.30000 3119.9n 0.30000 3120.0n 0.30000 3239.9n 0.30000 3240.0n 0.70000 3359.9n 0.70000 3360.0n 0.30000 3479.9n 0.30000 3480.0n 0.70000 3599.9n 0.70000 3600.0n 0.70000 3719.9n 0.70000 3720.0n 0.30000 3839.9n 0.30000 3840.0n 0.70000 3959.9n 0.70000 3960.0n 0.30000 4079.9n 0.30000 4080.0n 0.70000 4199.9n 0.70000 4200.0n 0.70000 4319.9n 0.70000 4320.0n 0.70000 4439.9n 0.70000 4440.0n 0.70000 4559.9n 0.70000 4560.0n 0.70000 4679.9n 0.70000 4680.0n 0.30000 4799.9n 0.30000 4800.0n 0.30000 4919.9n 0.30000 4920.0n 0.30000 5039.9n 0.30000 5040.0n 0.30000 5159.9n 0.30000 5160.0n 0.30000 5279.9n 0.30000 5280.0n 0.70000 5399.9n 0.70000 5400.0n 0.30000 5519.9n 0.30000 5520.0n 0.70000 5639.9n 0.70000 5640.0n 0.30000 5759.9n 0.30000 5760.0n 0.50000 5879.9n 0.50000 5880.0n 0.50000 5999.9n 0.50000 6000.0n 0.50000 6119.9n 0.50000 6120.0n 0.50000 6239.9n 0.50000 6240.0n 0.50000 6359.9n 0.50000 6360.0n 0.50000 6479.9n 0.50000 6480.0n 0.50000 6599.9n 0.50000 6600.0n 0.50000 6719.9n 0.50000 6720.0n 0.50000 6839.9n 0.50000 6840.0n 0.50000 6959.9n 0.50000 6960.0n 0.50000 7079.9n 0.50000 7080.0n 0.50000 7199.9n 0.50000 7200.0n 0.50000 7319.9n 0.50000 7320.0n 0.50000 7439.9n 0.50000 7440.0n 0.50000 7559.9n 0.50000 7560.0n 0.50000 7679.9n 0.50000 7680.0n 0.50000 7799.9n 0.50000 7800.0n 0.50000 7919.9n 0.50000 7920.0n 0.50000 8039.9n 0.50000 8040.0n 0.50000 8159.9n 0.50000 8160.0n 0.50000 8279.9n 0.50000 8280.0n 0.50000 8399.9n 0.50000 8400.0n 0.50000 8519.9n 0.50000 8520.0n 0.50000 8639.9n 0.50000 8640.0n 0.50000 8759.9n 0.50000 8760.0n 0.50000 8879.9n 0.50000 8880.0n 0.50000 8999.9n 0.50000 9000.0n 0.50000 9119.9n 0.50000 9120.0n 0.50000 9239.9n 0.50000 9240.0n 0.50000 9359.9n 0.50000 9360.0n 0.50000 9479.9n 0.50000 9480.0n 0.50000 9599.9n 0.50000 9600.0n 0.50000 9719.9n 0.50000 9720.0n 0.50000 9839.9n 0.50000 9840.0n 0.50000 9959.9n 0.50000 9960.0n 0.50000 10079.9n 0.50000 10080.0n 0.50000 10199.9n 0.50000 10200.0n 0.50000 10319.9n 0.50000 10320.0n 0.50000 10439.9n 0.50000 10440.0n 0.50000 10559.9n 0.50000 10560.0n 0.30000 10679.9n 0.30000 10680.0n 0.70000 10799.9n 0.70000 10800.0n 0.30000 10919.9n 0.30000 10920.0n 0.70000 11039.9n 0.70000 11040.0n 0.70000 11159.9n 0.70000 11160.0n 0.30000 11279.9n 0.30000 11280.0n 0.30000 11399.9n 0.30000 11400.0n 0.70000 11519.9n 0.70000 11520.0n 0.70000 11639.9n 0.70000 11640.0n 0.30000 11759.9n 0.30000 11760.0n 0.30000 11879.9n 0.30000 11880.0n 0.70000 11999.9n 0.70000 12000.0n 0.30000 12119.9n 0.30000 12120.0n 0.70000 12239.9n 0.70000 12240.0n 0.70000 12359.9n 0.70000 12360.0n 0.30000 12479.9n 0.30000 12480.0n 0.70000 12599.9n 0.70000 12600.0n 0.70000 12719.9n 0.70000 12720.0n 0.70000 12839.9n 0.70000 12840.0n 0.30000 12959.9n 0.30000 12960.0n 0.70000 13079.9n 0.70000 13080.0n 0.70000 13199.9n 0.70000 13200.0n 0.30000 13319.9n 0.30000 13320.0n 0.30000 13439.9n 0.30000 13440.0n 0.70000 13559.9n 0.70000 13560.0n 0.30000 13679.9n 0.30000 13680.0n 0.30000 13799.9n 0.30000 13800.0n 0.70000 13919.9n 0.70000 13920.0n 0.30000 14039.9n 0.30000 14040.0n 0.30000 14159.9n 0.30000 14160.0n 0.30000 14279.9n 0.30000 14280.0n 0.70000 14399.9n 0.70000 14400.0n 0.70000 14519.9n 0.70000 14520.0n 0.30000 14639.9n 0.30000 14640.0n 0.30000 14759.9n 0.30000 14760.0n 0.70000 14879.9n 0.70000 14880.0n 0.30000 14999.9n 0.30000 15000.0n 0.70000 15119.9n 0.70000 15120.0n 0.70000 15239.9n 0.70000 15240.0n 0.30000 15359.9n 0.30000 15360.0n 0.30000 15479.9n 0.30000 15480.0n 0.70000 15599.9n 0.70000 15600.0n 0.70000 15719.9n 0.70000 15720.0n 0.70000 15839.9n 0.70000 15840.0n 0.30000 15959.9n 0.30000 15960.0n 0.70000 16079.9n 0.70000 16080.0n 0.30000 16199.9n 0.30000 16200.0n 0.30000 16319.9n 0.30000 16320.0n 0.50000 16439.9n 0.50000 16440.0n 0.50000 16559.9n 0.50000 16560.0n 0.50000 16679.9n 0.50000 16680.0n 0.50000 16799.9n 0.50000 16800.0n 0.50000 16919.9n 0.50000 16920.0n 0.50000 17039.9n 0.50000 17040.0n 0.50000 17159.9n 0.50000 17160.0n 0.50000 17279.9n 0.50000 17280.0n 0.50000 17399.9n 0.50000 17400.0n 0.50000 17519.9n 0.50000 17520.0n 0.50000 17639.9n 0.50000 17640.0n 0.50000 17759.9n 0.50000 17760.0n 0.50000 17879.9n 0.50000 17880.0n 0.50000 17999.9n 0.50000 18000.0n 0.50000 18119.9n 0.50000 18120.0n 0.50000 18239.9n 0.50000 18240.0n 0.50000 18359.9n 0.50000 18360.0n 0.50000 18479.9n 0.50000 18480.0n 0.50000 18599.9n 0.50000 18600.0n 0.50000 18719.9n 0.50000 18720.0n 0.50000 18839.9n 0.50000 18840.0n 0.50000 18959.9n 0.50000 18960.0n 0.50000 19079.9n 0.50000 19080.0n 0.50000 19199.9n 0.50000 19200.0n 0.50000 19319.9n 0.50000 19320.0n 0.50000 19439.9n 0.50000 19440.0n 0.50000 19559.9n 0.50000 19560.0n 0.50000 19679.9n 0.50000 19680.0n 0.50000 19799.9n 0.50000 19800.0n 0.50000 19919.9n 0.50000 19920.0n 0.50000 20039.9n 0.50000 20040.0n 0.50000 20159.9n 0.50000 20160.0n 0.50000 20279.9n 0.50000 20280.0n 0.50000 20399.9n 0.50000 20400.0n 0.50000 20519.9n 0.50000 20520.0n 0.50000 20639.9n 0.50000 20640.0n 0.50000 20759.9n 0.50000 20760.0n 0.50000 20879.9n 0.50000 20880.0n 0.50000 20999.9n 0.50000 21000.0n 0.50000)
Vxon0 xon0 0 PWL(0.0n 0.70000 119.9n 0.70000 120.0n 0.30000 239.9n 0.30000 240.0n 0.70000 359.9n 0.70000 360.0n 0.30000 479.9n 0.30000 480.0n 0.70000 599.9n 0.70000 600.0n 0.70000 719.9n 0.70000 720.0n 0.30000 839.9n 0.30000 840.0n 0.70000 959.9n 0.70000 960.0n 0.70000 1079.9n 0.70000 1080.0n 0.30000 1199.9n 0.30000 1200.0n 0.70000 1319.9n 0.70000 1320.0n 0.30000 1439.9n 0.30000 1440.0n 0.30000 1559.9n 0.30000 1560.0n 0.30000 1679.9n 0.30000 1680.0n 0.30000 1799.9n 0.30000 1800.0n 0.70000 1919.9n 0.70000 1920.0n 0.30000 2039.9n 0.30000 2040.0n 0.70000 2159.9n 0.70000 2160.0n 0.70000 2279.9n 0.70000 2280.0n 0.30000 2399.9n 0.30000 2400.0n 0.30000 2519.9n 0.30000 2520.0n 0.30000 2639.9n 0.30000 2640.0n 0.70000 2759.9n 0.70000 2760.0n 0.70000 2879.9n 0.70000 2880.0n 0.30000 2999.9n 0.30000 3000.0n 0.70000 3119.9n 0.70000 3120.0n 0.70000 3239.9n 0.70000 3240.0n 0.30000 3359.9n 0.30000 3360.0n 0.70000 3479.9n 0.70000 3480.0n 0.30000 3599.9n 0.30000 3600.0n 0.30000 3719.9n 0.30000 3720.0n 0.70000 3839.9n 0.70000 3840.0n 0.30000 3959.9n 0.30000 3960.0n 0.70000 4079.9n 0.70000 4080.0n 0.30000 4199.9n 0.30000 4200.0n 0.30000 4319.9n 0.30000 4320.0n 0.30000 4439.9n 0.30000 4440.0n 0.30000 4559.9n 0.30000 4560.0n 0.30000 4679.9n 0.30000 4680.0n 0.70000 4799.9n 0.70000 4800.0n 0.70000 4919.9n 0.70000 4920.0n 0.70000 5039.9n 0.70000 5040.0n 0.70000 5159.9n 0.70000 5160.0n 0.70000 5279.9n 0.70000 5280.0n 0.30000 5399.9n 0.30000 5400.0n 0.70000 5519.9n 0.70000 5520.0n 0.30000 5639.9n 0.30000 5640.0n 0.70000 5759.9n 0.70000 5760.0n 0.50000 5879.9n 0.50000 5880.0n 0.50000 5999.9n 0.50000 6000.0n 0.50000 6119.9n 0.50000 6120.0n 0.50000 6239.9n 0.50000 6240.0n 0.50000 6359.9n 0.50000 6360.0n 0.50000 6479.9n 0.50000 6480.0n 0.50000 6599.9n 0.50000 6600.0n 0.50000 6719.9n 0.50000 6720.0n 0.50000 6839.9n 0.50000 6840.0n 0.50000 6959.9n 0.50000 6960.0n 0.50000 7079.9n 0.50000 7080.0n 0.50000 7199.9n 0.50000 7200.0n 0.50000 7319.9n 0.50000 7320.0n 0.50000 7439.9n 0.50000 7440.0n 0.50000 7559.9n 0.50000 7560.0n 0.50000 7679.9n 0.50000 7680.0n 0.50000 7799.9n 0.50000 7800.0n 0.50000 7919.9n 0.50000 7920.0n 0.50000 8039.9n 0.50000 8040.0n 0.50000 8159.9n 0.50000 8160.0n 0.50000 8279.9n 0.50000 8280.0n 0.50000 8399.9n 0.50000 8400.0n 0.50000 8519.9n 0.50000 8520.0n 0.50000 8639.9n 0.50000 8640.0n 0.50000 8759.9n 0.50000 8760.0n 0.50000 8879.9n 0.50000 8880.0n 0.50000 8999.9n 0.50000 9000.0n 0.50000 9119.9n 0.50000 9120.0n 0.50000 9239.9n 0.50000 9240.0n 0.50000 9359.9n 0.50000 9360.0n 0.50000 9479.9n 0.50000 9480.0n 0.50000 9599.9n 0.50000 9600.0n 0.50000 9719.9n 0.50000 9720.0n 0.50000 9839.9n 0.50000 9840.0n 0.50000 9959.9n 0.50000 9960.0n 0.50000 10079.9n 0.50000 10080.0n 0.50000 10199.9n 0.50000 10200.0n 0.50000 10319.9n 0.50000 10320.0n 0.50000 10439.9n 0.50000 10440.0n 0.50000 10559.9n 0.50000 10560.0n 0.70000 10679.9n 0.70000 10680.0n 0.30000 10799.9n 0.30000 10800.0n 0.70000 10919.9n 0.70000 10920.0n 0.30000 11039.9n 0.30000 11040.0n 0.30000 11159.9n 0.30000 11160.0n 0.70000 11279.9n 0.70000 11280.0n 0.70000 11399.9n 0.70000 11400.0n 0.30000 11519.9n 0.30000 11520.0n 0.30000 11639.9n 0.30000 11640.0n 0.70000 11759.9n 0.70000 11760.0n 0.70000 11879.9n 0.70000 11880.0n 0.30000 11999.9n 0.30000 12000.0n 0.70000 12119.9n 0.70000 12120.0n 0.30000 12239.9n 0.30000 12240.0n 0.30000 12359.9n 0.30000 12360.0n 0.70000 12479.9n 0.70000 12480.0n 0.30000 12599.9n 0.30000 12600.0n 0.30000 12719.9n 0.30000 12720.0n 0.30000 12839.9n 0.30000 12840.0n 0.70000 12959.9n 0.70000 12960.0n 0.30000 13079.9n 0.30000 13080.0n 0.30000 13199.9n 0.30000 13200.0n 0.70000 13319.9n 0.70000 13320.0n 0.70000 13439.9n 0.70000 13440.0n 0.30000 13559.9n 0.30000 13560.0n 0.70000 13679.9n 0.70000 13680.0n 0.70000 13799.9n 0.70000 13800.0n 0.30000 13919.9n 0.30000 13920.0n 0.70000 14039.9n 0.70000 14040.0n 0.70000 14159.9n 0.70000 14160.0n 0.70000 14279.9n 0.70000 14280.0n 0.30000 14399.9n 0.30000 14400.0n 0.30000 14519.9n 0.30000 14520.0n 0.70000 14639.9n 0.70000 14640.0n 0.70000 14759.9n 0.70000 14760.0n 0.30000 14879.9n 0.30000 14880.0n 0.70000 14999.9n 0.70000 15000.0n 0.30000 15119.9n 0.30000 15120.0n 0.30000 15239.9n 0.30000 15240.0n 0.70000 15359.9n 0.70000 15360.0n 0.70000 15479.9n 0.70000 15480.0n 0.30000 15599.9n 0.30000 15600.0n 0.30000 15719.9n 0.30000 15720.0n 0.30000 15839.9n 0.30000 15840.0n 0.70000 15959.9n 0.70000 15960.0n 0.30000 16079.9n 0.30000 16080.0n 0.70000 16199.9n 0.70000 16200.0n 0.70000 16319.9n 0.70000 16320.0n 0.50000 16439.9n 0.50000 16440.0n 0.50000 16559.9n 0.50000 16560.0n 0.50000 16679.9n 0.50000 16680.0n 0.50000 16799.9n 0.50000 16800.0n 0.50000 16919.9n 0.50000 16920.0n 0.50000 17039.9n 0.50000 17040.0n 0.50000 17159.9n 0.50000 17160.0n 0.50000 17279.9n 0.50000 17280.0n 0.50000 17399.9n 0.50000 17400.0n 0.50000 17519.9n 0.50000 17520.0n 0.50000 17639.9n 0.50000 17640.0n 0.50000 17759.9n 0.50000 17760.0n 0.50000 17879.9n 0.50000 17880.0n 0.50000 17999.9n 0.50000 18000.0n 0.50000 18119.9n 0.50000 18120.0n 0.50000 18239.9n 0.50000 18240.0n 0.50000 18359.9n 0.50000 18360.0n 0.50000 18479.9n 0.50000 18480.0n 0.50000 18599.9n 0.50000 18600.0n 0.50000 18719.9n 0.50000 18720.0n 0.50000 18839.9n 0.50000 18840.0n 0.50000 18959.9n 0.50000 18960.0n 0.50000 19079.9n 0.50000 19080.0n 0.50000 19199.9n 0.50000 19200.0n 0.50000 19319.9n 0.50000 19320.0n 0.50000 19439.9n 0.50000 19440.0n 0.50000 19559.9n 0.50000 19560.0n 0.50000 19679.9n 0.50000 19680.0n 0.50000 19799.9n 0.50000 19800.0n 0.50000 19919.9n 0.50000 19920.0n 0.50000 20039.9n 0.50000 20040.0n 0.50000 20159.9n 0.50000 20160.0n 0.50000 20279.9n 0.50000 20280.0n 0.50000 20399.9n 0.50000 20400.0n 0.50000 20519.9n 0.50000 20520.0n 0.50000 20639.9n 0.50000 20640.0n 0.50000 20759.9n 0.50000 20760.0n 0.50000 20879.9n 0.50000 20880.0n 0.50000 20999.9n 0.50000 21000.0n 0.50000)
Vxop1 xop1 0 PWL(0.0n 0.70000 119.9n 0.70000 120.0n 0.30000 239.9n 0.30000 240.0n 0.70000 359.9n 0.70000 360.0n 0.30000 479.9n 0.30000 480.0n 0.70000 599.9n 0.70000 600.0n 0.70000 719.9n 0.70000 720.0n 0.30000 839.9n 0.30000 840.0n 0.70000 959.9n 0.70000 960.0n 0.70000 1079.9n 0.70000 1080.0n 0.30000 1199.9n 0.30000 1200.0n 0.70000 1319.9n 0.70000 1320.0n 0.30000 1439.9n 0.30000 1440.0n 0.30000 1559.9n 0.30000 1560.0n 0.30000 1679.9n 0.30000 1680.0n 0.30000 1799.9n 0.30000 1800.0n 0.70000 1919.9n 0.70000 1920.0n 0.30000 2039.9n 0.30000 2040.0n 0.70000 2159.9n 0.70000 2160.0n 0.70000 2279.9n 0.70000 2280.0n 0.30000 2399.9n 0.30000 2400.0n 0.30000 2519.9n 0.30000 2520.0n 0.30000 2639.9n 0.30000 2640.0n 0.70000 2759.9n 0.70000 2760.0n 0.70000 2879.9n 0.70000 2880.0n 0.30000 2999.9n 0.30000 3000.0n 0.70000 3119.9n 0.70000 3120.0n 0.70000 3239.9n 0.70000 3240.0n 0.30000 3359.9n 0.30000 3360.0n 0.70000 3479.9n 0.70000 3480.0n 0.30000 3599.9n 0.30000 3600.0n 0.30000 3719.9n 0.30000 3720.0n 0.70000 3839.9n 0.70000 3840.0n 0.30000 3959.9n 0.30000 3960.0n 0.70000 4079.9n 0.70000 4080.0n 0.30000 4199.9n 0.30000 4200.0n 0.30000 4319.9n 0.30000 4320.0n 0.30000 4439.9n 0.30000 4440.0n 0.30000 4559.9n 0.30000 4560.0n 0.30000 4679.9n 0.30000 4680.0n 0.70000 4799.9n 0.70000 4800.0n 0.70000 4919.9n 0.70000 4920.0n 0.70000 5039.9n 0.70000 5040.0n 0.70000 5159.9n 0.70000 5160.0n 0.70000 5279.9n 0.70000 5280.0n 0.30000 5399.9n 0.30000 5400.0n 0.70000 5519.9n 0.70000 5520.0n 0.30000 5639.9n 0.30000 5640.0n 0.70000 5759.9n 0.70000 5760.0n 0.50000 5879.9n 0.50000 5880.0n 0.50000 5999.9n 0.50000 6000.0n 0.50000 6119.9n 0.50000 6120.0n 0.50000 6239.9n 0.50000 6240.0n 0.50000 6359.9n 0.50000 6360.0n 0.50000 6479.9n 0.50000 6480.0n 0.50000 6599.9n 0.50000 6600.0n 0.50000 6719.9n 0.50000 6720.0n 0.50000 6839.9n 0.50000 6840.0n 0.50000 6959.9n 0.50000 6960.0n 0.50000 7079.9n 0.50000 7080.0n 0.50000 7199.9n 0.50000 7200.0n 0.50000 7319.9n 0.50000 7320.0n 0.50000 7439.9n 0.50000 7440.0n 0.50000 7559.9n 0.50000 7560.0n 0.50000 7679.9n 0.50000 7680.0n 0.50000 7799.9n 0.50000 7800.0n 0.50000 7919.9n 0.50000 7920.0n 0.50000 8039.9n 0.50000 8040.0n 0.50000 8159.9n 0.50000 8160.0n 0.50000 8279.9n 0.50000 8280.0n 0.50000 8399.9n 0.50000 8400.0n 0.50000 8519.9n 0.50000 8520.0n 0.50000 8639.9n 0.50000 8640.0n 0.50000 8759.9n 0.50000 8760.0n 0.50000 8879.9n 0.50000 8880.0n 0.50000 8999.9n 0.50000 9000.0n 0.50000 9119.9n 0.50000 9120.0n 0.50000 9239.9n 0.50000 9240.0n 0.50000 9359.9n 0.50000 9360.0n 0.50000 9479.9n 0.50000 9480.0n 0.50000 9599.9n 0.50000 9600.0n 0.50000 9719.9n 0.50000 9720.0n 0.50000 9839.9n 0.50000 9840.0n 0.50000 9959.9n 0.50000 9960.0n 0.50000 10079.9n 0.50000 10080.0n 0.50000 10199.9n 0.50000 10200.0n 0.50000 10319.9n 0.50000 10320.0n 0.50000 10439.9n 0.50000 10440.0n 0.50000 10559.9n 0.50000 10560.0n 0.70000 10679.9n 0.70000 10680.0n 0.30000 10799.9n 0.30000 10800.0n 0.70000 10919.9n 0.70000 10920.0n 0.30000 11039.9n 0.30000 11040.0n 0.30000 11159.9n 0.30000 11160.0n 0.70000 11279.9n 0.70000 11280.0n 0.70000 11399.9n 0.70000 11400.0n 0.30000 11519.9n 0.30000 11520.0n 0.30000 11639.9n 0.30000 11640.0n 0.70000 11759.9n 0.70000 11760.0n 0.70000 11879.9n 0.70000 11880.0n 0.30000 11999.9n 0.30000 12000.0n 0.70000 12119.9n 0.70000 12120.0n 0.30000 12239.9n 0.30000 12240.0n 0.30000 12359.9n 0.30000 12360.0n 0.70000 12479.9n 0.70000 12480.0n 0.30000 12599.9n 0.30000 12600.0n 0.30000 12719.9n 0.30000 12720.0n 0.30000 12839.9n 0.30000 12840.0n 0.70000 12959.9n 0.70000 12960.0n 0.30000 13079.9n 0.30000 13080.0n 0.30000 13199.9n 0.30000 13200.0n 0.70000 13319.9n 0.70000 13320.0n 0.70000 13439.9n 0.70000 13440.0n 0.30000 13559.9n 0.30000 13560.0n 0.70000 13679.9n 0.70000 13680.0n 0.70000 13799.9n 0.70000 13800.0n 0.30000 13919.9n 0.30000 13920.0n 0.70000 14039.9n 0.70000 14040.0n 0.70000 14159.9n 0.70000 14160.0n 0.70000 14279.9n 0.70000 14280.0n 0.30000 14399.9n 0.30000 14400.0n 0.30000 14519.9n 0.30000 14520.0n 0.70000 14639.9n 0.70000 14640.0n 0.70000 14759.9n 0.70000 14760.0n 0.30000 14879.9n 0.30000 14880.0n 0.70000 14999.9n 0.70000 15000.0n 0.30000 15119.9n 0.30000 15120.0n 0.30000 15239.9n 0.30000 15240.0n 0.70000 15359.9n 0.70000 15360.0n 0.70000 15479.9n 0.70000 15480.0n 0.30000 15599.9n 0.30000 15600.0n 0.30000 15719.9n 0.30000 15720.0n 0.30000 15839.9n 0.30000 15840.0n 0.70000 15959.9n 0.70000 15960.0n 0.30000 16079.9n 0.30000 16080.0n 0.70000 16199.9n 0.70000 16200.0n 0.70000 16319.9n 0.70000 16320.0n 0.50000 16439.9n 0.50000 16440.0n 0.50000 16559.9n 0.50000 16560.0n 0.50000 16679.9n 0.50000 16680.0n 0.50000 16799.9n 0.50000 16800.0n 0.50000 16919.9n 0.50000 16920.0n 0.50000 17039.9n 0.50000 17040.0n 0.50000 17159.9n 0.50000 17160.0n 0.50000 17279.9n 0.50000 17280.0n 0.50000 17399.9n 0.50000 17400.0n 0.50000 17519.9n 0.50000 17520.0n 0.50000 17639.9n 0.50000 17640.0n 0.50000 17759.9n 0.50000 17760.0n 0.50000 17879.9n 0.50000 17880.0n 0.50000 17999.9n 0.50000 18000.0n 0.50000 18119.9n 0.50000 18120.0n 0.50000 18239.9n 0.50000 18240.0n 0.50000 18359.9n 0.50000 18360.0n 0.50000 18479.9n 0.50000 18480.0n 0.50000 18599.9n 0.50000 18600.0n 0.50000 18719.9n 0.50000 18720.0n 0.50000 18839.9n 0.50000 18840.0n 0.50000 18959.9n 0.50000 18960.0n 0.50000 19079.9n 0.50000 19080.0n 0.50000 19199.9n 0.50000 19200.0n 0.50000 19319.9n 0.50000 19320.0n 0.50000 19439.9n 0.50000 19440.0n 0.50000 19559.9n 0.50000 19560.0n 0.50000 19679.9n 0.50000 19680.0n 0.50000 19799.9n 0.50000 19800.0n 0.50000 19919.9n 0.50000 19920.0n 0.50000 20039.9n 0.50000 20040.0n 0.50000 20159.9n 0.50000 20160.0n 0.50000 20279.9n 0.50000 20280.0n 0.50000 20399.9n 0.50000 20400.0n 0.50000 20519.9n 0.50000 20520.0n 0.50000 20639.9n 0.50000 20640.0n 0.50000 20759.9n 0.50000 20760.0n 0.50000 20879.9n 0.50000 20880.0n 0.50000 20999.9n 0.50000 21000.0n 0.50000)
Vxon1 xon1 0 PWL(0.0n 0.30000 119.9n 0.30000 120.0n 0.70000 239.9n 0.70000 240.0n 0.30000 359.9n 0.30000 360.0n 0.70000 479.9n 0.70000 480.0n 0.30000 599.9n 0.30000 600.0n 0.30000 719.9n 0.30000 720.0n 0.70000 839.9n 0.70000 840.0n 0.30000 959.9n 0.30000 960.0n 0.30000 1079.9n 0.30000 1080.0n 0.70000 1199.9n 0.70000 1200.0n 0.30000 1319.9n 0.30000 1320.0n 0.70000 1439.9n 0.70000 1440.0n 0.70000 1559.9n 0.70000 1560.0n 0.70000 1679.9n 0.70000 1680.0n 0.70000 1799.9n 0.70000 1800.0n 0.30000 1919.9n 0.30000 1920.0n 0.70000 2039.9n 0.70000 2040.0n 0.30000 2159.9n 0.30000 2160.0n 0.30000 2279.9n 0.30000 2280.0n 0.70000 2399.9n 0.70000 2400.0n 0.70000 2519.9n 0.70000 2520.0n 0.70000 2639.9n 0.70000 2640.0n 0.30000 2759.9n 0.30000 2760.0n 0.30000 2879.9n 0.30000 2880.0n 0.70000 2999.9n 0.70000 3000.0n 0.30000 3119.9n 0.30000 3120.0n 0.30000 3239.9n 0.30000 3240.0n 0.70000 3359.9n 0.70000 3360.0n 0.30000 3479.9n 0.30000 3480.0n 0.70000 3599.9n 0.70000 3600.0n 0.70000 3719.9n 0.70000 3720.0n 0.30000 3839.9n 0.30000 3840.0n 0.70000 3959.9n 0.70000 3960.0n 0.30000 4079.9n 0.30000 4080.0n 0.70000 4199.9n 0.70000 4200.0n 0.70000 4319.9n 0.70000 4320.0n 0.70000 4439.9n 0.70000 4440.0n 0.70000 4559.9n 0.70000 4560.0n 0.70000 4679.9n 0.70000 4680.0n 0.30000 4799.9n 0.30000 4800.0n 0.30000 4919.9n 0.30000 4920.0n 0.30000 5039.9n 0.30000 5040.0n 0.30000 5159.9n 0.30000 5160.0n 0.30000 5279.9n 0.30000 5280.0n 0.70000 5399.9n 0.70000 5400.0n 0.30000 5519.9n 0.30000 5520.0n 0.70000 5639.9n 0.70000 5640.0n 0.30000 5759.9n 0.30000 5760.0n 0.50000 5879.9n 0.50000 5880.0n 0.50000 5999.9n 0.50000 6000.0n 0.50000 6119.9n 0.50000 6120.0n 0.50000 6239.9n 0.50000 6240.0n 0.50000 6359.9n 0.50000 6360.0n 0.50000 6479.9n 0.50000 6480.0n 0.50000 6599.9n 0.50000 6600.0n 0.50000 6719.9n 0.50000 6720.0n 0.50000 6839.9n 0.50000 6840.0n 0.50000 6959.9n 0.50000 6960.0n 0.50000 7079.9n 0.50000 7080.0n 0.50000 7199.9n 0.50000 7200.0n 0.50000 7319.9n 0.50000 7320.0n 0.50000 7439.9n 0.50000 7440.0n 0.50000 7559.9n 0.50000 7560.0n 0.50000 7679.9n 0.50000 7680.0n 0.50000 7799.9n 0.50000 7800.0n 0.50000 7919.9n 0.50000 7920.0n 0.50000 8039.9n 0.50000 8040.0n 0.50000 8159.9n 0.50000 8160.0n 0.50000 8279.9n 0.50000 8280.0n 0.50000 8399.9n 0.50000 8400.0n 0.50000 8519.9n 0.50000 8520.0n 0.50000 8639.9n 0.50000 8640.0n 0.50000 8759.9n 0.50000 8760.0n 0.50000 8879.9n 0.50000 8880.0n 0.50000 8999.9n 0.50000 9000.0n 0.50000 9119.9n 0.50000 9120.0n 0.50000 9239.9n 0.50000 9240.0n 0.50000 9359.9n 0.50000 9360.0n 0.50000 9479.9n 0.50000 9480.0n 0.50000 9599.9n 0.50000 9600.0n 0.50000 9719.9n 0.50000 9720.0n 0.50000 9839.9n 0.50000 9840.0n 0.50000 9959.9n 0.50000 9960.0n 0.50000 10079.9n 0.50000 10080.0n 0.50000 10199.9n 0.50000 10200.0n 0.50000 10319.9n 0.50000 10320.0n 0.50000 10439.9n 0.50000 10440.0n 0.50000 10559.9n 0.50000 10560.0n 0.30000 10679.9n 0.30000 10680.0n 0.70000 10799.9n 0.70000 10800.0n 0.30000 10919.9n 0.30000 10920.0n 0.70000 11039.9n 0.70000 11040.0n 0.70000 11159.9n 0.70000 11160.0n 0.30000 11279.9n 0.30000 11280.0n 0.30000 11399.9n 0.30000 11400.0n 0.70000 11519.9n 0.70000 11520.0n 0.70000 11639.9n 0.70000 11640.0n 0.30000 11759.9n 0.30000 11760.0n 0.30000 11879.9n 0.30000 11880.0n 0.70000 11999.9n 0.70000 12000.0n 0.30000 12119.9n 0.30000 12120.0n 0.70000 12239.9n 0.70000 12240.0n 0.70000 12359.9n 0.70000 12360.0n 0.30000 12479.9n 0.30000 12480.0n 0.70000 12599.9n 0.70000 12600.0n 0.70000 12719.9n 0.70000 12720.0n 0.70000 12839.9n 0.70000 12840.0n 0.30000 12959.9n 0.30000 12960.0n 0.70000 13079.9n 0.70000 13080.0n 0.70000 13199.9n 0.70000 13200.0n 0.30000 13319.9n 0.30000 13320.0n 0.30000 13439.9n 0.30000 13440.0n 0.70000 13559.9n 0.70000 13560.0n 0.30000 13679.9n 0.30000 13680.0n 0.30000 13799.9n 0.30000 13800.0n 0.70000 13919.9n 0.70000 13920.0n 0.30000 14039.9n 0.30000 14040.0n 0.30000 14159.9n 0.30000 14160.0n 0.30000 14279.9n 0.30000 14280.0n 0.70000 14399.9n 0.70000 14400.0n 0.70000 14519.9n 0.70000 14520.0n 0.30000 14639.9n 0.30000 14640.0n 0.30000 14759.9n 0.30000 14760.0n 0.70000 14879.9n 0.70000 14880.0n 0.30000 14999.9n 0.30000 15000.0n 0.70000 15119.9n 0.70000 15120.0n 0.70000 15239.9n 0.70000 15240.0n 0.30000 15359.9n 0.30000 15360.0n 0.30000 15479.9n 0.30000 15480.0n 0.70000 15599.9n 0.70000 15600.0n 0.70000 15719.9n 0.70000 15720.0n 0.70000 15839.9n 0.70000 15840.0n 0.30000 15959.9n 0.30000 15960.0n 0.70000 16079.9n 0.70000 16080.0n 0.30000 16199.9n 0.30000 16200.0n 0.30000 16319.9n 0.30000 16320.0n 0.50000 16439.9n 0.50000 16440.0n 0.50000 16559.9n 0.50000 16560.0n 0.50000 16679.9n 0.50000 16680.0n 0.50000 16799.9n 0.50000 16800.0n 0.50000 16919.9n 0.50000 16920.0n 0.50000 17039.9n 0.50000 17040.0n 0.50000 17159.9n 0.50000 17160.0n 0.50000 17279.9n 0.50000 17280.0n 0.50000 17399.9n 0.50000 17400.0n 0.50000 17519.9n 0.50000 17520.0n 0.50000 17639.9n 0.50000 17640.0n 0.50000 17759.9n 0.50000 17760.0n 0.50000 17879.9n 0.50000 17880.0n 0.50000 17999.9n 0.50000 18000.0n 0.50000 18119.9n 0.50000 18120.0n 0.50000 18239.9n 0.50000 18240.0n 0.50000 18359.9n 0.50000 18360.0n 0.50000 18479.9n 0.50000 18480.0n 0.50000 18599.9n 0.50000 18600.0n 0.50000 18719.9n 0.50000 18720.0n 0.50000 18839.9n 0.50000 18840.0n 0.50000 18959.9n 0.50000 18960.0n 0.50000 19079.9n 0.50000 19080.0n 0.50000 19199.9n 0.50000 19200.0n 0.50000 19319.9n 0.50000 19320.0n 0.50000 19439.9n 0.50000 19440.0n 0.50000 19559.9n 0.50000 19560.0n 0.50000 19679.9n 0.50000 19680.0n 0.50000 19799.9n 0.50000 19800.0n 0.50000 19919.9n 0.50000 19920.0n 0.50000 20039.9n 0.50000 20040.0n 0.50000 20159.9n 0.50000 20160.0n 0.50000 20279.9n 0.50000 20280.0n 0.50000 20399.9n 0.50000 20400.0n 0.50000 20519.9n 0.50000 20520.0n 0.50000 20639.9n 0.50000 20640.0n 0.50000 20759.9n 0.50000 20760.0n 0.50000 20879.9n 0.50000 20880.0n 0.50000 20999.9n 0.50000 21000.0n 0.50000)
Vwih_p_0_0 wih_p_0_0 0 0.9
Vwih_n_0_0 wih_n_0_0 0 0.3
Vwih_p_1_0 wih_p_1_0 0 0.3
Vwih_n_1_0 wih_n_1_0 0 0.8077526372768347
Vwih_p_2_0 wih_p_2_0 0 0.9
Vwih_n_2_0 wih_n_2_0 0 0.3
Xcm_xh0 xhp0 xhn0 vdd cmld
Rnd_xh0 xhp0 xhn0 20k
Cxh0p xhp0 0 1e-13
Cxh0n xhn0 0 1e-13
Xih_0_0 a_xp0 a_xn0 wih_p_0_0 wih_n_0_0 xhp0 xhn0 vdd vbsyn gsyn
Xih_1_0 a_xp1 a_xn1 wih_p_1_0 wih_n_1_0 xhp0 xhn0 vdd vbsyn gsyn
Xih_2_0 a_xp2 a_xn2 wih_p_2_0 wih_n_2_0 xhp0 xhn0 vdd vbsyn gsyn
Xn0 xhp0 xhn0 ahp0 ahn0 vdd vbneu dneuron
Vwih_p_0_1 wih_p_0_1 0 0.4076074543279496
Vwih_n_0_1 wih_n_0_1 0 0.5923925456720505
Vwih_p_1_1 wih_p_1_1 0 0.6875517955179162
Vwih_n_1_1 wih_n_1_1 0 0.31244820448208377
Vwih_p_2_1 wih_p_2_1 0 0.9
Vwih_n_2_1 wih_n_2_1 0 0.3
Xcm_xh1 xhp1 xhn1 vdd cmld
Rnd_xh1 xhp1 xhn1 20k
Cxh1p xhp1 0 1e-13
Cxh1n xhn1 0 1e-13
Xih_0_1 a_xp0 a_xn0 wih_p_0_1 wih_n_0_1 xhp1 xhn1 vdd vbsyn gsyn
Xih_1_1 a_xp1 a_xn1 wih_p_1_1 wih_n_1_1 xhp1 xhn1 vdd vbsyn gsyn
Xih_2_1 a_xp2 a_xn2 wih_p_2_1 wih_n_2_1 xhp1 xhn1 vdd vbsyn gsyn
Xn1 xhp1 xhn1 ahp1 ahn1 vdd vbneu dneuron
Vwih_p_0_2 wih_p_0_2 0 0.6986905748958001
Vwih_n_0_2 wih_n_0_2 0 0.30130942510419984
Vwih_p_1_2 wih_p_1_2 0 0.8611596583173695
Vwih_n_1_2 wih_n_1_2 0 0.3
Vwih_p_2_2 wih_p_2_2 0 0.3
Vwih_n_2_2 wih_n_2_2 0 0.9
Xcm_xh2 xhp2 xhn2 vdd cmld
Rnd_xh2 xhp2 xhn2 20k
Cxh2p xhp2 0 1e-13
Cxh2n xhn2 0 1e-13
Xih_0_2 a_xp0 a_xn0 wih_p_0_2 wih_n_0_2 xhp2 xhn2 vdd vbsyn gsyn
Xih_1_2 a_xp1 a_xn1 wih_p_1_2 wih_n_1_2 xhp2 xhn2 vdd vbsyn gsyn
Xih_2_2 a_xp2 a_xn2 wih_p_2_2 wih_n_2_2 xhp2 xhn2 vdd vbsyn gsyn
Xn2 xhp2 xhn2 ahp2 ahn2 vdd vbneu dneuron
Vwih_p_0_3 wih_p_0_3 0 0.3
Vwih_n_0_3 wih_n_0_3 0 0.7073156875091838
Vwih_p_1_3 wih_p_1_3 0 0.9
Vwih_n_1_3 wih_n_1_3 0 0.3
Vwih_p_2_3 wih_p_2_3 0 0.3968886139217385
Vwih_n_2_3 wih_n_2_3 0 0.6031113860782614
Xcm_xh3 xhp3 xhn3 vdd cmld
Rnd_xh3 xhp3 xhn3 20k
Cxh3p xhp3 0 1e-13
Cxh3n xhn3 0 1e-13
Xih_0_3 a_xp0 a_xn0 wih_p_0_3 wih_n_0_3 xhp3 xhn3 vdd vbsyn gsyn
Xih_1_3 a_xp1 a_xn1 wih_p_1_3 wih_n_1_3 xhp3 xhn3 vdd vbsyn gsyn
Xih_2_3 a_xp2 a_xn2 wih_p_2_3 wih_n_2_3 xhp3 xhn3 vdd vbsyn gsyn
Xn3 xhp3 xhn3 ahp3 ahn3 vdd vbneu dneuron
Vwih_p_0_4 wih_p_0_4 0 0.643383333655023
Vwih_n_0_4 wih_n_0_4 0 0.356616666344977
Vwih_p_1_4 wih_p_1_4 0 0.426609605197966
Vwih_n_1_4 wih_n_1_4 0 0.573390394802034
Vwih_p_2_4 wih_p_2_4 0 0.3
Vwih_n_2_4 wih_n_2_4 0 0.779710110256914
Xcm_xh4 xhp4 xhn4 vdd cmld
Rnd_xh4 xhp4 xhn4 20k
Cxh4p xhp4 0 1e-13
Cxh4n xhn4 0 1e-13
Xih_0_4 a_xp0 a_xn0 wih_p_0_4 wih_n_0_4 xhp4 xhn4 vdd vbsyn gsyn
Xih_1_4 a_xp1 a_xn1 wih_p_1_4 wih_n_1_4 xhp4 xhn4 vdd vbsyn gsyn
Xih_2_4 a_xp2 a_xn2 wih_p_2_4 wih_n_2_4 xhp4 xhn4 vdd vbsyn gsyn
Xn4 xhp4 xhn4 ahp4 ahn4 vdd vbneu dneuron
Vwih_p_0_5 wih_p_0_5 0 0.3
Vwih_n_0_5 wih_n_0_5 0 0.9
Vwih_p_1_5 wih_p_1_5 0 0.3
Vwih_n_1_5 wih_n_1_5 0 0.9
Vwih_p_2_5 wih_p_2_5 0 0.9
Vwih_n_2_5 wih_n_2_5 0 0.3
Xcm_xh5 xhp5 xhn5 vdd cmld
Rnd_xh5 xhp5 xhn5 20k
Cxh5p xhp5 0 1e-13
Cxh5n xhn5 0 1e-13
Xih_0_5 a_xp0 a_xn0 wih_p_0_5 wih_n_0_5 xhp5 xhn5 vdd vbsyn gsyn
Xih_1_5 a_xp1 a_xn1 wih_p_1_5 wih_n_1_5 xhp5 xhn5 vdd vbsyn gsyn
Xih_2_5 a_xp2 a_xn2 wih_p_2_5 wih_n_2_5 xhp5 xhn5 vdd vbsyn gsyn
Xn5 xhp5 xhn5 ahp5 ahn5 vdd vbneu dneuron
Vwih_p_0_6 wih_p_0_6 0 0.4644227134047597
Vwih_n_0_6 wih_n_0_6 0 0.5355772865952403
Vwih_p_1_6 wih_p_1_6 0 0.3
Vwih_n_1_6 wih_n_1_6 0 0.9
Vwih_p_2_6 wih_p_2_6 0 0.3
Vwih_n_2_6 wih_n_2_6 0 0.9
Xcm_xh6 xhp6 xhn6 vdd cmld
Rnd_xh6 xhp6 xhn6 20k
Cxh6p xhp6 0 1e-13
Cxh6n xhn6 0 1e-13
Xih_0_6 a_xp0 a_xn0 wih_p_0_6 wih_n_0_6 xhp6 xhn6 vdd vbsyn gsyn
Xih_1_6 a_xp1 a_xn1 wih_p_1_6 wih_n_1_6 xhp6 xhn6 vdd vbsyn gsyn
Xih_2_6 a_xp2 a_xn2 wih_p_2_6 wih_n_2_6 xhp6 xhn6 vdd vbsyn gsyn
Xn6 xhp6 xhn6 ahp6 ahn6 vdd vbneu dneuron
Vwih_p_0_7 wih_p_0_7 0 0.8930428788399948
Vwih_n_0_7 wih_n_0_7 0 0.3
Vwih_p_1_7 wih_p_1_7 0 0.3
Vwih_n_1_7 wih_n_1_7 0 0.9
Vwih_p_2_7 wih_p_2_7 0 0.3
Vwih_n_2_7 wih_n_2_7 0 0.7814083238372862
Xcm_xh7 xhp7 xhn7 vdd cmld
Rnd_xh7 xhp7 xhn7 20k
Cxh7p xhp7 0 1e-13
Cxh7n xhn7 0 1e-13
Xih_0_7 a_xp0 a_xn0 wih_p_0_7 wih_n_0_7 xhp7 xhn7 vdd vbsyn gsyn
Xih_1_7 a_xp1 a_xn1 wih_p_1_7 wih_n_1_7 xhp7 xhn7 vdd vbsyn gsyn
Xih_2_7 a_xp2 a_xn2 wih_p_2_7 wih_n_2_7 xhp7 xhn7 vdd vbsyn gsyn
Xn7 xhp7 xhn7 ahp7 ahn7 vdd vbneu dneuron
Vwih_p_0_8 wih_p_0_8 0 0.3
Vwih_n_0_8 wih_n_0_8 0 0.9
Vwih_p_1_8 wih_p_1_8 0 0.3
Vwih_n_1_8 wih_n_1_8 0 0.9
Vwih_p_2_8 wih_p_2_8 0 0.9
Vwih_n_2_8 wih_n_2_8 0 0.3
Xcm_xh8 xhp8 xhn8 vdd cmld
Rnd_xh8 xhp8 xhn8 20k
Cxh8p xhp8 0 1e-13
Cxh8n xhn8 0 1e-13
Xih_0_8 a_xp0 a_xn0 wih_p_0_8 wih_n_0_8 xhp8 xhn8 vdd vbsyn gsyn
Xih_1_8 a_xp1 a_xn1 wih_p_1_8 wih_n_1_8 xhp8 xhn8 vdd vbsyn gsyn
Xih_2_8 a_xp2 a_xn2 wih_p_2_8 wih_n_2_8 xhp8 xhn8 vdd vbsyn gsyn
Xn8 xhp8 xhn8 ahp8 ahn8 vdd vbneu dneuron
Vwih_p_0_9 wih_p_0_9 0 0.43659969851895275
Vwih_n_0_9 wih_n_0_9 0 0.5634003014810472
Vwih_p_1_9 wih_p_1_9 0 0.35532188681769517
Vwih_n_1_9 wih_n_1_9 0 0.6446781131823048
Vwih_p_2_9 wih_p_2_9 0 0.3
Vwih_n_2_9 wih_n_2_9 0 0.770652332104687
Xcm_xh9 xhp9 xhn9 vdd cmld
Rnd_xh9 xhp9 xhn9 20k
Cxh9p xhp9 0 1e-13
Cxh9n xhn9 0 1e-13
Xih_0_9 a_xp0 a_xn0 wih_p_0_9 wih_n_0_9 xhp9 xhn9 vdd vbsyn gsyn
Xih_1_9 a_xp1 a_xn1 wih_p_1_9 wih_n_1_9 xhp9 xhn9 vdd vbsyn gsyn
Xih_2_9 a_xp2 a_xn2 wih_p_2_9 wih_n_2_9 xhp9 xhn9 vdd vbsyn gsyn
Xn9 xhp9 xhn9 ahp9 ahn9 vdd vbneu dneuron
Vwih_p_0_10 wih_p_0_10 0 0.8206037983083873
Vwih_n_0_10 wih_n_0_10 0 0.3
Vwih_p_1_10 wih_p_1_10 0 0.5276620970012434
Vwih_n_1_10 wih_n_1_10 0 0.47233790299875655
Vwih_p_2_10 wih_p_2_10 0 0.6315537008964082
Vwih_n_2_10 wih_n_2_10 0 0.36844629910359183
Xcm_xh10 xhp10 xhn10 vdd cmld
Rnd_xh10 xhp10 xhn10 20k
Cxh10p xhp10 0 1e-13
Cxh10n xhn10 0 1e-13
Xih_0_10 a_xp0 a_xn0 wih_p_0_10 wih_n_0_10 xhp10 xhn10 vdd vbsyn gsyn
Xih_1_10 a_xp1 a_xn1 wih_p_1_10 wih_n_1_10 xhp10 xhn10 vdd vbsyn gsyn
Xih_2_10 a_xp2 a_xn2 wih_p_2_10 wih_n_2_10 xhp10 xhn10 vdd vbsyn gsyn
Xn10 xhp10 xhn10 ahp10 ahn10 vdd vbneu dneuron
Vwih_p_0_11 wih_p_0_11 0 0.5615896328228672
Vwih_n_0_11 wih_n_0_11 0 0.4384103671771328
Vwih_p_1_11 wih_p_1_11 0 0.3392052445189821
Vwih_n_1_11 wih_n_1_11 0 0.6607947554810178
Vwih_p_2_11 wih_p_2_11 0 0.3
Vwih_n_2_11 wih_n_2_11 0 0.7163998120574444
Xcm_xh11 xhp11 xhn11 vdd cmld
Rnd_xh11 xhp11 xhn11 20k
Cxh11p xhp11 0 1e-13
Cxh11n xhn11 0 1e-13
Xih_0_11 a_xp0 a_xn0 wih_p_0_11 wih_n_0_11 xhp11 xhn11 vdd vbsyn gsyn
Xih_1_11 a_xp1 a_xn1 wih_p_1_11 wih_n_1_11 xhp11 xhn11 vdd vbsyn gsyn
Xih_2_11 a_xp2 a_xn2 wih_p_2_11 wih_n_2_11 xhp11 xhn11 vdd vbsyn gsyn
Xn11 xhp11 xhn11 ahp11 ahn11 vdd vbneu dneuron
Vwih_p_0_12 wih_p_0_12 0 0.3
Vwih_n_0_12 wih_n_0_12 0 0.9
Vwih_p_1_12 wih_p_1_12 0 0.3
Vwih_n_1_12 wih_n_1_12 0 0.7213002021183876
Vwih_p_2_12 wih_p_2_12 0 0.9
Vwih_n_2_12 wih_n_2_12 0 0.3
Xcm_xh12 xhp12 xhn12 vdd cmld
Rnd_xh12 xhp12 xhn12 20k
Cxh12p xhp12 0 1e-13
Cxh12n xhn12 0 1e-13
Xih_0_12 a_xp0 a_xn0 wih_p_0_12 wih_n_0_12 xhp12 xhn12 vdd vbsyn gsyn
Xih_1_12 a_xp1 a_xn1 wih_p_1_12 wih_n_1_12 xhp12 xhn12 vdd vbsyn gsyn
Xih_2_12 a_xp2 a_xn2 wih_p_2_12 wih_n_2_12 xhp12 xhn12 vdd vbsyn gsyn
Xn12 xhp12 xhn12 ahp12 ahn12 vdd vbneu dneuron
Vwih_p_0_13 wih_p_0_13 0 0.3
Vwih_n_0_13 wih_n_0_13 0 0.9
Vwih_p_1_13 wih_p_1_13 0 0.5019673310802524
Vwih_n_1_13 wih_n_1_13 0 0.4980326689197476
Vwih_p_2_13 wih_p_2_13 0 0.6510764412903762
Vwih_n_2_13 wih_n_2_13 0 0.3489235587096237
Xcm_xh13 xhp13 xhn13 vdd cmld
Rnd_xh13 xhp13 xhn13 20k
Cxh13p xhp13 0 1e-13
Cxh13n xhn13 0 1e-13
Xih_0_13 a_xp0 a_xn0 wih_p_0_13 wih_n_0_13 xhp13 xhn13 vdd vbsyn gsyn
Xih_1_13 a_xp1 a_xn1 wih_p_1_13 wih_n_1_13 xhp13 xhn13 vdd vbsyn gsyn
Xih_2_13 a_xp2 a_xn2 wih_p_2_13 wih_n_2_13 xhp13 xhn13 vdd vbsyn gsyn
Xn13 xhp13 xhn13 ahp13 ahn13 vdd vbneu dneuron
Vwih_p_0_14 wih_p_0_14 0 0.9
Vwih_n_0_14 wih_n_0_14 0 0.3
Vwih_p_1_14 wih_p_1_14 0 0.9
Vwih_n_1_14 wih_n_1_14 0 0.3
Vwih_p_2_14 wih_p_2_14 0 0.321441830538693
Vwih_n_2_14 wih_n_2_14 0 0.678558169461307
Xcm_xh14 xhp14 xhn14 vdd cmld
Rnd_xh14 xhp14 xhn14 20k
Cxh14p xhp14 0 1e-13
Cxh14n xhn14 0 1e-13
Xih_0_14 a_xp0 a_xn0 wih_p_0_14 wih_n_0_14 xhp14 xhn14 vdd vbsyn gsyn
Xih_1_14 a_xp1 a_xn1 wih_p_1_14 wih_n_1_14 xhp14 xhn14 vdd vbsyn gsyn
Xih_2_14 a_xp2 a_xn2 wih_p_2_14 wih_n_2_14 xhp14 xhn14 vdd vbsyn gsyn
Xn14 xhp14 xhn14 ahp14 ahn14 vdd vbneu dneuron
Vwih_p_0_15 wih_p_0_15 0 0.3
Vwih_n_0_15 wih_n_0_15 0 0.8946964794631206
Vwih_p_1_15 wih_p_1_15 0 0.9
Vwih_n_1_15 wih_n_1_15 0 0.3
Vwih_p_2_15 wih_p_2_15 0 0.5958540050197993
Vwih_n_2_15 wih_n_2_15 0 0.4041459949802006
Xcm_xh15 xhp15 xhn15 vdd cmld
Rnd_xh15 xhp15 xhn15 20k
Cxh15p xhp15 0 1e-13
Cxh15n xhn15 0 1e-13
Xih_0_15 a_xp0 a_xn0 wih_p_0_15 wih_n_0_15 xhp15 xhn15 vdd vbsyn gsyn
Xih_1_15 a_xp1 a_xn1 wih_p_1_15 wih_n_1_15 xhp15 xhn15 vdd vbsyn gsyn
Xih_2_15 a_xp2 a_xn2 wih_p_2_15 wih_n_2_15 xhp15 xhn15 vdd vbsyn gsyn
Xn15 xhp15 xhn15 ahp15 ahn15 vdd vbneu dneuron
Vwih_p_0_16 wih_p_0_16 0 0.9
Vwih_n_0_16 wih_n_0_16 0 0.3
Vwih_p_1_16 wih_p_1_16 0 0.8264016782997259
Vwih_n_1_16 wih_n_1_16 0 0.3
Vwih_p_2_16 wih_p_2_16 0 0.3
Vwih_n_2_16 wih_n_2_16 0 0.8009587065328215
Xcm_xh16 xhp16 xhn16 vdd cmld
Rnd_xh16 xhp16 xhn16 20k
Cxh16p xhp16 0 1e-13
Cxh16n xhn16 0 1e-13
Xih_0_16 a_xp0 a_xn0 wih_p_0_16 wih_n_0_16 xhp16 xhn16 vdd vbsyn gsyn
Xih_1_16 a_xp1 a_xn1 wih_p_1_16 wih_n_1_16 xhp16 xhn16 vdd vbsyn gsyn
Xih_2_16 a_xp2 a_xn2 wih_p_2_16 wih_n_2_16 xhp16 xhn16 vdd vbsyn gsyn
Xn16 xhp16 xhn16 ahp16 ahn16 vdd vbneu dneuron
Vwih_p_0_17 wih_p_0_17 0 0.4115141976338063
Vwih_n_0_17 wih_n_0_17 0 0.5884858023661936
Vwih_p_1_17 wih_p_1_17 0 0.6903674851964131
Vwih_n_1_17 wih_n_1_17 0 0.3096325148035869
Vwih_p_2_17 wih_p_2_17 0 0.7253099866650734
Vwih_n_2_17 wih_n_2_17 0 0.3
Xcm_xh17 xhp17 xhn17 vdd cmld
Rnd_xh17 xhp17 xhn17 20k
Cxh17p xhp17 0 1e-13
Cxh17n xhn17 0 1e-13
Xih_0_17 a_xp0 a_xn0 wih_p_0_17 wih_n_0_17 xhp17 xhn17 vdd vbsyn gsyn
Xih_1_17 a_xp1 a_xn1 wih_p_1_17 wih_n_1_17 xhp17 xhn17 vdd vbsyn gsyn
Xih_2_17 a_xp2 a_xn2 wih_p_2_17 wih_n_2_17 xhp17 xhn17 vdd vbsyn gsyn
Xn17 xhp17 xhn17 ahp17 ahn17 vdd vbneu dneuron
Vwih_p_0_18 wih_p_0_18 0 0.3
Vwih_n_0_18 wih_n_0_18 0 0.9
Vwih_p_1_18 wih_p_1_18 0 0.3
Vwih_n_1_18 wih_n_1_18 0 0.9
Vwih_p_2_18 wih_p_2_18 0 0.3
Vwih_n_2_18 wih_n_2_18 0 0.9
Xcm_xh18 xhp18 xhn18 vdd cmld
Rnd_xh18 xhp18 xhn18 20k
Cxh18p xhp18 0 1e-13
Cxh18n xhn18 0 1e-13
Xih_0_18 a_xp0 a_xn0 wih_p_0_18 wih_n_0_18 xhp18 xhn18 vdd vbsyn gsyn
Xih_1_18 a_xp1 a_xn1 wih_p_1_18 wih_n_1_18 xhp18 xhn18 vdd vbsyn gsyn
Xih_2_18 a_xp2 a_xn2 wih_p_2_18 wih_n_2_18 xhp18 xhn18 vdd vbsyn gsyn
Xn18 xhp18 xhn18 ahp18 ahn18 vdd vbneu dneuron
Vwih_p_0_19 wih_p_0_19 0 0.7777220499589362
Vwih_n_0_19 wih_n_0_19 0 0.3
Vwih_p_1_19 wih_p_1_19 0 0.4310427827422266
Vwih_n_1_19 wih_n_1_19 0 0.5689572172577734
Vwih_p_2_19 wih_p_2_19 0 0.3
Vwih_n_2_19 wih_n_2_19 0 0.9
Xcm_xh19 xhp19 xhn19 vdd cmld
Rnd_xh19 xhp19 xhn19 20k
Cxh19p xhp19 0 1e-13
Cxh19n xhn19 0 1e-13
Xih_0_19 a_xp0 a_xn0 wih_p_0_19 wih_n_0_19 xhp19 xhn19 vdd vbsyn gsyn
Xih_1_19 a_xp1 a_xn1 wih_p_1_19 wih_n_1_19 xhp19 xhn19 vdd vbsyn gsyn
Xih_2_19 a_xp2 a_xn2 wih_p_2_19 wih_n_2_19 xhp19 xhn19 vdd vbsyn gsyn
Xn19 xhp19 xhn19 ahp19 ahn19 vdd vbneu dneuron
Vwih_p_0_20 wih_p_0_20 0 0.3
Vwih_n_0_20 wih_n_0_20 0 0.7478781116735951
Vwih_p_1_20 wih_p_1_20 0 0.3
Vwih_n_1_20 wih_n_1_20 0 0.9
Vwih_p_2_20 wih_p_2_20 0 0.3815696565850669
Vwih_n_2_20 wih_n_2_20 0 0.6184303434149331
Xcm_xh20 xhp20 xhn20 vdd cmld
Rnd_xh20 xhp20 xhn20 20k
Cxh20p xhp20 0 1e-13
Cxh20n xhn20 0 1e-13
Xih_0_20 a_xp0 a_xn0 wih_p_0_20 wih_n_0_20 xhp20 xhn20 vdd vbsyn gsyn
Xih_1_20 a_xp1 a_xn1 wih_p_1_20 wih_n_1_20 xhp20 xhn20 vdd vbsyn gsyn
Xih_2_20 a_xp2 a_xn2 wih_p_2_20 wih_n_2_20 xhp20 xhn20 vdd vbsyn gsyn
Xn20 xhp20 xhn20 ahp20 ahn20 vdd vbneu dneuron
Vwih_p_0_21 wih_p_0_21 0 0.3
Vwih_n_0_21 wih_n_0_21 0 0.8894118236059116
Vwih_p_1_21 wih_p_1_21 0 0.3
Vwih_n_1_21 wih_n_1_21 0 0.7510846099149556
Vwih_p_2_21 wih_p_2_21 0 0.46204030518827083
Vwih_n_2_21 wih_n_2_21 0 0.5379596948117292
Xcm_xh21 xhp21 xhn21 vdd cmld
Rnd_xh21 xhp21 xhn21 20k
Cxh21p xhp21 0 1e-13
Cxh21n xhn21 0 1e-13
Xih_0_21 a_xp0 a_xn0 wih_p_0_21 wih_n_0_21 xhp21 xhn21 vdd vbsyn gsyn
Xih_1_21 a_xp1 a_xn1 wih_p_1_21 wih_n_1_21 xhp21 xhn21 vdd vbsyn gsyn
Xih_2_21 a_xp2 a_xn2 wih_p_2_21 wih_n_2_21 xhp21 xhn21 vdd vbsyn gsyn
Xn21 xhp21 xhn21 ahp21 ahn21 vdd vbneu dneuron
Vwih_p_0_22 wih_p_0_22 0 0.582183485192292
Vwih_n_0_22 wih_n_0_22 0 0.417816514807708
Vwih_p_1_22 wih_p_1_22 0 0.5267999164136071
Vwih_n_1_22 wih_n_1_22 0 0.47320008358639293
Vwih_p_2_22 wih_p_2_22 0 0.9
Vwih_n_2_22 wih_n_2_22 0 0.3
Xcm_xh22 xhp22 xhn22 vdd cmld
Rnd_xh22 xhp22 xhn22 20k
Cxh22p xhp22 0 1e-13
Cxh22n xhn22 0 1e-13
Xih_0_22 a_xp0 a_xn0 wih_p_0_22 wih_n_0_22 xhp22 xhn22 vdd vbsyn gsyn
Xih_1_22 a_xp1 a_xn1 wih_p_1_22 wih_n_1_22 xhp22 xhn22 vdd vbsyn gsyn
Xih_2_22 a_xp2 a_xn2 wih_p_2_22 wih_n_2_22 xhp22 xhn22 vdd vbsyn gsyn
Xn22 xhp22 xhn22 ahp22 ahn22 vdd vbneu dneuron
Vwih_p_0_23 wih_p_0_23 0 0.9
Vwih_n_0_23 wih_n_0_23 0 0.3
Vwih_p_1_23 wih_p_1_23 0 0.8833839713323164
Vwih_n_1_23 wih_n_1_23 0 0.3
Vwih_p_2_23 wih_p_2_23 0 0.41466542792757277
Vwih_n_2_23 wih_n_2_23 0 0.5853345720724272
Xcm_xh23 xhp23 xhn23 vdd cmld
Rnd_xh23 xhp23 xhn23 20k
Cxh23p xhp23 0 1e-13
Cxh23n xhn23 0 1e-13
Xih_0_23 a_xp0 a_xn0 wih_p_0_23 wih_n_0_23 xhp23 xhn23 vdd vbsyn gsyn
Xih_1_23 a_xp1 a_xn1 wih_p_1_23 wih_n_1_23 xhp23 xhn23 vdd vbsyn gsyn
Xih_2_23 a_xp2 a_xn2 wih_p_2_23 wih_n_2_23 xhp23 xhn23 vdd vbsyn gsyn
Xn23 xhp23 xhn23 ahp23 ahn23 vdd vbneu dneuron
Vahb_p ahbias_p 0 0.8
Vahb_n ahbias_n 0 0.2
Xcm_mo0 mop0 mon0 vdd cmld
Rmo0 mop0 mon0 30k
Cmo0p mop0 0 1e-13
Cmo0n mon0 0 1e-13
Cwp_0_0 who_p_0_0 0 20p
Cwn_0_0 who_n_0_0 0 20p
Rwp_0_0 who_p_0_0 wcm 2g
Rwn_0_0 who_n_0_0 wcm 2g
Xsyn_0_0 ahp0 ahn0 who_p_0_0 who_n_0_0 mop0 mon0 vdd vbsyn gsyn
Cwp_1_0 who_p_1_0 0 20p
Cwn_1_0 who_n_1_0 0 20p
Rwp_1_0 who_p_1_0 wcm 2g
Rwn_1_0 who_n_1_0 wcm 2g
Xsyn_1_0 ahp1 ahn1 who_p_1_0 who_n_1_0 mop0 mon0 vdd vbsyn gsyn
Cwp_2_0 who_p_2_0 0 20p
Cwn_2_0 who_n_2_0 0 20p
Rwp_2_0 who_p_2_0 wcm 2g
Rwn_2_0 who_n_2_0 wcm 2g
Xsyn_2_0 ahp2 ahn2 who_p_2_0 who_n_2_0 mop0 mon0 vdd vbsyn gsyn
Cwp_3_0 who_p_3_0 0 20p
Cwn_3_0 who_n_3_0 0 20p
Rwp_3_0 who_p_3_0 wcm 2g
Rwn_3_0 who_n_3_0 wcm 2g
Xsyn_3_0 ahp3 ahn3 who_p_3_0 who_n_3_0 mop0 mon0 vdd vbsyn gsyn
Cwp_4_0 who_p_4_0 0 20p
Cwn_4_0 who_n_4_0 0 20p
Rwp_4_0 who_p_4_0 wcm 2g
Rwn_4_0 who_n_4_0 wcm 2g
Xsyn_4_0 ahp4 ahn4 who_p_4_0 who_n_4_0 mop0 mon0 vdd vbsyn gsyn
Cwp_5_0 who_p_5_0 0 20p
Cwn_5_0 who_n_5_0 0 20p
Rwp_5_0 who_p_5_0 wcm 2g
Rwn_5_0 who_n_5_0 wcm 2g
Xsyn_5_0 ahp5 ahn5 who_p_5_0 who_n_5_0 mop0 mon0 vdd vbsyn gsyn
Cwp_6_0 who_p_6_0 0 20p
Cwn_6_0 who_n_6_0 0 20p
Rwp_6_0 who_p_6_0 wcm 2g
Rwn_6_0 who_n_6_0 wcm 2g
Xsyn_6_0 ahp6 ahn6 who_p_6_0 who_n_6_0 mop0 mon0 vdd vbsyn gsyn
Cwp_7_0 who_p_7_0 0 20p
Cwn_7_0 who_n_7_0 0 20p
Rwp_7_0 who_p_7_0 wcm 2g
Rwn_7_0 who_n_7_0 wcm 2g
Xsyn_7_0 ahp7 ahn7 who_p_7_0 who_n_7_0 mop0 mon0 vdd vbsyn gsyn
Cwp_8_0 who_p_8_0 0 20p
Cwn_8_0 who_n_8_0 0 20p
Rwp_8_0 who_p_8_0 wcm 2g
Rwn_8_0 who_n_8_0 wcm 2g
Xsyn_8_0 ahp8 ahn8 who_p_8_0 who_n_8_0 mop0 mon0 vdd vbsyn gsyn
Cwp_9_0 who_p_9_0 0 20p
Cwn_9_0 who_n_9_0 0 20p
Rwp_9_0 who_p_9_0 wcm 2g
Rwn_9_0 who_n_9_0 wcm 2g
Xsyn_9_0 ahp9 ahn9 who_p_9_0 who_n_9_0 mop0 mon0 vdd vbsyn gsyn
Cwp_10_0 who_p_10_0 0 20p
Cwn_10_0 who_n_10_0 0 20p
Rwp_10_0 who_p_10_0 wcm 2g
Rwn_10_0 who_n_10_0 wcm 2g
Xsyn_10_0 ahp10 ahn10 who_p_10_0 who_n_10_0 mop0 mon0 vdd vbsyn gsyn
Cwp_11_0 who_p_11_0 0 20p
Cwn_11_0 who_n_11_0 0 20p
Rwp_11_0 who_p_11_0 wcm 2g
Rwn_11_0 who_n_11_0 wcm 2g
Xsyn_11_0 ahp11 ahn11 who_p_11_0 who_n_11_0 mop0 mon0 vdd vbsyn gsyn
Cwp_12_0 who_p_12_0 0 20p
Cwn_12_0 who_n_12_0 0 20p
Rwp_12_0 who_p_12_0 wcm 2g
Rwn_12_0 who_n_12_0 wcm 2g
Xsyn_12_0 ahp12 ahn12 who_p_12_0 who_n_12_0 mop0 mon0 vdd vbsyn gsyn
Cwp_13_0 who_p_13_0 0 20p
Cwn_13_0 who_n_13_0 0 20p
Rwp_13_0 who_p_13_0 wcm 2g
Rwn_13_0 who_n_13_0 wcm 2g
Xsyn_13_0 ahp13 ahn13 who_p_13_0 who_n_13_0 mop0 mon0 vdd vbsyn gsyn
Cwp_14_0 who_p_14_0 0 20p
Cwn_14_0 who_n_14_0 0 20p
Rwp_14_0 who_p_14_0 wcm 2g
Rwn_14_0 who_n_14_0 wcm 2g
Xsyn_14_0 ahp14 ahn14 who_p_14_0 who_n_14_0 mop0 mon0 vdd vbsyn gsyn
Cwp_15_0 who_p_15_0 0 20p
Cwn_15_0 who_n_15_0 0 20p
Rwp_15_0 who_p_15_0 wcm 2g
Rwn_15_0 who_n_15_0 wcm 2g
Xsyn_15_0 ahp15 ahn15 who_p_15_0 who_n_15_0 mop0 mon0 vdd vbsyn gsyn
Cwp_16_0 who_p_16_0 0 20p
Cwn_16_0 who_n_16_0 0 20p
Rwp_16_0 who_p_16_0 wcm 2g
Rwn_16_0 who_n_16_0 wcm 2g
Xsyn_16_0 ahp16 ahn16 who_p_16_0 who_n_16_0 mop0 mon0 vdd vbsyn gsyn
Cwp_17_0 who_p_17_0 0 20p
Cwn_17_0 who_n_17_0 0 20p
Rwp_17_0 who_p_17_0 wcm 2g
Rwn_17_0 who_n_17_0 wcm 2g
Xsyn_17_0 ahp17 ahn17 who_p_17_0 who_n_17_0 mop0 mon0 vdd vbsyn gsyn
Cwp_18_0 who_p_18_0 0 20p
Cwn_18_0 who_n_18_0 0 20p
Rwp_18_0 who_p_18_0 wcm 2g
Rwn_18_0 who_n_18_0 wcm 2g
Xsyn_18_0 ahp18 ahn18 who_p_18_0 who_n_18_0 mop0 mon0 vdd vbsyn gsyn
Cwp_19_0 who_p_19_0 0 20p
Cwn_19_0 who_n_19_0 0 20p
Rwp_19_0 who_p_19_0 wcm 2g
Rwn_19_0 who_n_19_0 wcm 2g
Xsyn_19_0 ahp19 ahn19 who_p_19_0 who_n_19_0 mop0 mon0 vdd vbsyn gsyn
Cwp_20_0 who_p_20_0 0 20p
Cwn_20_0 who_n_20_0 0 20p
Rwp_20_0 who_p_20_0 wcm 2g
Rwn_20_0 who_n_20_0 wcm 2g
Xsyn_20_0 ahp20 ahn20 who_p_20_0 who_n_20_0 mop0 mon0 vdd vbsyn gsyn
Cwp_21_0 who_p_21_0 0 20p
Cwn_21_0 who_n_21_0 0 20p
Rwp_21_0 who_p_21_0 wcm 2g
Rwn_21_0 who_n_21_0 wcm 2g
Xsyn_21_0 ahp21 ahn21 who_p_21_0 who_n_21_0 mop0 mon0 vdd vbsyn gsyn
Cwp_22_0 who_p_22_0 0 20p
Cwn_22_0 who_n_22_0 0 20p
Rwp_22_0 who_p_22_0 wcm 2g
Rwn_22_0 who_n_22_0 wcm 2g
Xsyn_22_0 ahp22 ahn22 who_p_22_0 who_n_22_0 mop0 mon0 vdd vbsyn gsyn
Cwp_23_0 who_p_23_0 0 20p
Cwn_23_0 who_n_23_0 0 20p
Rwp_23_0 who_p_23_0 wcm 2g
Rwn_23_0 who_n_23_0 wcm 2g
Xsyn_23_0 ahp23 ahn23 who_p_23_0 who_n_23_0 mop0 mon0 vdd vbsyn gsyn
Cwp_24_0 who_p_24_0 0 20p
Cwn_24_0 who_n_24_0 0 20p
Rwp_24_0 who_p_24_0 wcm 2g
Rwn_24_0 who_n_24_0 wcm 2g
Xsyn_24_0 ahbias_p ahbias_n who_p_24_0 who_n_24_0 mop0 mon0 vdd vbsyn gsyn
Xeo0 xop0 xon0 mop0 mon0 eop0 eon0 vdd gm esub
Xcm_mo1 mop1 mon1 vdd cmld
Rmo1 mop1 mon1 30k
Cmo1p mop1 0 1e-13
Cmo1n mon1 0 1e-13
Cwp_0_1 who_p_0_1 0 20p
Cwn_0_1 who_n_0_1 0 20p
Rwp_0_1 who_p_0_1 wcm 2g
Rwn_0_1 who_n_0_1 wcm 2g
Xsyn_0_1 ahp0 ahn0 who_p_0_1 who_n_0_1 mop1 mon1 vdd vbsyn gsyn
Cwp_1_1 who_p_1_1 0 20p
Cwn_1_1 who_n_1_1 0 20p
Rwp_1_1 who_p_1_1 wcm 2g
Rwn_1_1 who_n_1_1 wcm 2g
Xsyn_1_1 ahp1 ahn1 who_p_1_1 who_n_1_1 mop1 mon1 vdd vbsyn gsyn
Cwp_2_1 who_p_2_1 0 20p
Cwn_2_1 who_n_2_1 0 20p
Rwp_2_1 who_p_2_1 wcm 2g
Rwn_2_1 who_n_2_1 wcm 2g
Xsyn_2_1 ahp2 ahn2 who_p_2_1 who_n_2_1 mop1 mon1 vdd vbsyn gsyn
Cwp_3_1 who_p_3_1 0 20p
Cwn_3_1 who_n_3_1 0 20p
Rwp_3_1 who_p_3_1 wcm 2g
Rwn_3_1 who_n_3_1 wcm 2g
Xsyn_3_1 ahp3 ahn3 who_p_3_1 who_n_3_1 mop1 mon1 vdd vbsyn gsyn
Cwp_4_1 who_p_4_1 0 20p
Cwn_4_1 who_n_4_1 0 20p
Rwp_4_1 who_p_4_1 wcm 2g
Rwn_4_1 who_n_4_1 wcm 2g
Xsyn_4_1 ahp4 ahn4 who_p_4_1 who_n_4_1 mop1 mon1 vdd vbsyn gsyn
Cwp_5_1 who_p_5_1 0 20p
Cwn_5_1 who_n_5_1 0 20p
Rwp_5_1 who_p_5_1 wcm 2g
Rwn_5_1 who_n_5_1 wcm 2g
Xsyn_5_1 ahp5 ahn5 who_p_5_1 who_n_5_1 mop1 mon1 vdd vbsyn gsyn
Cwp_6_1 who_p_6_1 0 20p
Cwn_6_1 who_n_6_1 0 20p
Rwp_6_1 who_p_6_1 wcm 2g
Rwn_6_1 who_n_6_1 wcm 2g
Xsyn_6_1 ahp6 ahn6 who_p_6_1 who_n_6_1 mop1 mon1 vdd vbsyn gsyn
Cwp_7_1 who_p_7_1 0 20p
Cwn_7_1 who_n_7_1 0 20p
Rwp_7_1 who_p_7_1 wcm 2g
Rwn_7_1 who_n_7_1 wcm 2g
Xsyn_7_1 ahp7 ahn7 who_p_7_1 who_n_7_1 mop1 mon1 vdd vbsyn gsyn
Cwp_8_1 who_p_8_1 0 20p
Cwn_8_1 who_n_8_1 0 20p
Rwp_8_1 who_p_8_1 wcm 2g
Rwn_8_1 who_n_8_1 wcm 2g
Xsyn_8_1 ahp8 ahn8 who_p_8_1 who_n_8_1 mop1 mon1 vdd vbsyn gsyn
Cwp_9_1 who_p_9_1 0 20p
Cwn_9_1 who_n_9_1 0 20p
Rwp_9_1 who_p_9_1 wcm 2g
Rwn_9_1 who_n_9_1 wcm 2g
Xsyn_9_1 ahp9 ahn9 who_p_9_1 who_n_9_1 mop1 mon1 vdd vbsyn gsyn
Cwp_10_1 who_p_10_1 0 20p
Cwn_10_1 who_n_10_1 0 20p
Rwp_10_1 who_p_10_1 wcm 2g
Rwn_10_1 who_n_10_1 wcm 2g
Xsyn_10_1 ahp10 ahn10 who_p_10_1 who_n_10_1 mop1 mon1 vdd vbsyn gsyn
Cwp_11_1 who_p_11_1 0 20p
Cwn_11_1 who_n_11_1 0 20p
Rwp_11_1 who_p_11_1 wcm 2g
Rwn_11_1 who_n_11_1 wcm 2g
Xsyn_11_1 ahp11 ahn11 who_p_11_1 who_n_11_1 mop1 mon1 vdd vbsyn gsyn
Cwp_12_1 who_p_12_1 0 20p
Cwn_12_1 who_n_12_1 0 20p
Rwp_12_1 who_p_12_1 wcm 2g
Rwn_12_1 who_n_12_1 wcm 2g
Xsyn_12_1 ahp12 ahn12 who_p_12_1 who_n_12_1 mop1 mon1 vdd vbsyn gsyn
Cwp_13_1 who_p_13_1 0 20p
Cwn_13_1 who_n_13_1 0 20p
Rwp_13_1 who_p_13_1 wcm 2g
Rwn_13_1 who_n_13_1 wcm 2g
Xsyn_13_1 ahp13 ahn13 who_p_13_1 who_n_13_1 mop1 mon1 vdd vbsyn gsyn
Cwp_14_1 who_p_14_1 0 20p
Cwn_14_1 who_n_14_1 0 20p
Rwp_14_1 who_p_14_1 wcm 2g
Rwn_14_1 who_n_14_1 wcm 2g
Xsyn_14_1 ahp14 ahn14 who_p_14_1 who_n_14_1 mop1 mon1 vdd vbsyn gsyn
Cwp_15_1 who_p_15_1 0 20p
Cwn_15_1 who_n_15_1 0 20p
Rwp_15_1 who_p_15_1 wcm 2g
Rwn_15_1 who_n_15_1 wcm 2g
Xsyn_15_1 ahp15 ahn15 who_p_15_1 who_n_15_1 mop1 mon1 vdd vbsyn gsyn
Cwp_16_1 who_p_16_1 0 20p
Cwn_16_1 who_n_16_1 0 20p
Rwp_16_1 who_p_16_1 wcm 2g
Rwn_16_1 who_n_16_1 wcm 2g
Xsyn_16_1 ahp16 ahn16 who_p_16_1 who_n_16_1 mop1 mon1 vdd vbsyn gsyn
Cwp_17_1 who_p_17_1 0 20p
Cwn_17_1 who_n_17_1 0 20p
Rwp_17_1 who_p_17_1 wcm 2g
Rwn_17_1 who_n_17_1 wcm 2g
Xsyn_17_1 ahp17 ahn17 who_p_17_1 who_n_17_1 mop1 mon1 vdd vbsyn gsyn
Cwp_18_1 who_p_18_1 0 20p
Cwn_18_1 who_n_18_1 0 20p
Rwp_18_1 who_p_18_1 wcm 2g
Rwn_18_1 who_n_18_1 wcm 2g
Xsyn_18_1 ahp18 ahn18 who_p_18_1 who_n_18_1 mop1 mon1 vdd vbsyn gsyn
Cwp_19_1 who_p_19_1 0 20p
Cwn_19_1 who_n_19_1 0 20p
Rwp_19_1 who_p_19_1 wcm 2g
Rwn_19_1 who_n_19_1 wcm 2g
Xsyn_19_1 ahp19 ahn19 who_p_19_1 who_n_19_1 mop1 mon1 vdd vbsyn gsyn
Cwp_20_1 who_p_20_1 0 20p
Cwn_20_1 who_n_20_1 0 20p
Rwp_20_1 who_p_20_1 wcm 2g
Rwn_20_1 who_n_20_1 wcm 2g
Xsyn_20_1 ahp20 ahn20 who_p_20_1 who_n_20_1 mop1 mon1 vdd vbsyn gsyn
Cwp_21_1 who_p_21_1 0 20p
Cwn_21_1 who_n_21_1 0 20p
Rwp_21_1 who_p_21_1 wcm 2g
Rwn_21_1 who_n_21_1 wcm 2g
Xsyn_21_1 ahp21 ahn21 who_p_21_1 who_n_21_1 mop1 mon1 vdd vbsyn gsyn
Cwp_22_1 who_p_22_1 0 20p
Cwn_22_1 who_n_22_1 0 20p
Rwp_22_1 who_p_22_1 wcm 2g
Rwn_22_1 who_n_22_1 wcm 2g
Xsyn_22_1 ahp22 ahn22 who_p_22_1 who_n_22_1 mop1 mon1 vdd vbsyn gsyn
Cwp_23_1 who_p_23_1 0 20p
Cwn_23_1 who_n_23_1 0 20p
Rwp_23_1 who_p_23_1 wcm 2g
Rwn_23_1 who_n_23_1 wcm 2g
Xsyn_23_1 ahp23 ahn23 who_p_23_1 who_n_23_1 mop1 mon1 vdd vbsyn gsyn
Cwp_24_1 who_p_24_1 0 20p
Cwn_24_1 who_n_24_1 0 20p
Rwp_24_1 who_p_24_1 wcm 2g
Rwn_24_1 who_n_24_1 wcm 2g
Xsyn_24_1 ahbias_p ahbias_n who_p_24_1 who_n_24_1 mop1 mon1 vdd vbsyn gsyn
Xeo1 xop1 xon1 mop1 mon1 eop1 eon1 vdd gm esub
Vahref vahref 0 0.5
Cac_p_0 ahp0 yac_p_0 2p
Rac_p_0 yac_p_0 vahref 20meg
Cac_n_0 ahn0 yac_n_0 2p
Rac_n_0 yac_n_0 vahref 20meg
Cac_p_1 ahp1 yac_p_1 2p
Rac_p_1 yac_p_1 vahref 20meg
Cac_n_1 ahn1 yac_n_1 2p
Rac_n_1 yac_n_1 vahref 20meg
Cac_p_2 ahp2 yac_p_2 2p
Rac_p_2 yac_p_2 vahref 20meg
Cac_n_2 ahn2 yac_n_2 2p
Rac_n_2 yac_n_2 vahref 20meg
Cac_p_3 ahp3 yac_p_3 2p
Rac_p_3 yac_p_3 vahref 20meg
Cac_n_3 ahn3 yac_n_3 2p
Rac_n_3 yac_n_3 vahref 20meg
Cac_p_4 ahp4 yac_p_4 2p
Rac_p_4 yac_p_4 vahref 20meg
Cac_n_4 ahn4 yac_n_4 2p
Rac_n_4 yac_n_4 vahref 20meg
Cac_p_5 ahp5 yac_p_5 2p
Rac_p_5 yac_p_5 vahref 20meg
Cac_n_5 ahn5 yac_n_5 2p
Rac_n_5 yac_n_5 vahref 20meg
Cac_p_6 ahp6 yac_p_6 2p
Rac_p_6 yac_p_6 vahref 20meg
Cac_n_6 ahn6 yac_n_6 2p
Rac_n_6 yac_n_6 vahref 20meg
Cac_p_7 ahp7 yac_p_7 2p
Rac_p_7 yac_p_7 vahref 20meg
Cac_n_7 ahn7 yac_n_7 2p
Rac_n_7 yac_n_7 vahref 20meg
Cac_p_8 ahp8 yac_p_8 2p
Rac_p_8 yac_p_8 vahref 20meg
Cac_n_8 ahn8 yac_n_8 2p
Rac_n_8 yac_n_8 vahref 20meg
Cac_p_9 ahp9 yac_p_9 2p
Rac_p_9 yac_p_9 vahref 20meg
Cac_n_9 ahn9 yac_n_9 2p
Rac_n_9 yac_n_9 vahref 20meg
Cac_p_10 ahp10 yac_p_10 2p
Rac_p_10 yac_p_10 vahref 20meg
Cac_n_10 ahn10 yac_n_10 2p
Rac_n_10 yac_n_10 vahref 20meg
Cac_p_11 ahp11 yac_p_11 2p
Rac_p_11 yac_p_11 vahref 20meg
Cac_n_11 ahn11 yac_n_11 2p
Rac_n_11 yac_n_11 vahref 20meg
Cac_p_12 ahp12 yac_p_12 2p
Rac_p_12 yac_p_12 vahref 20meg
Cac_n_12 ahn12 yac_n_12 2p
Rac_n_12 yac_n_12 vahref 20meg
Cac_p_13 ahp13 yac_p_13 2p
Rac_p_13 yac_p_13 vahref 20meg
Cac_n_13 ahn13 yac_n_13 2p
Rac_n_13 yac_n_13 vahref 20meg
Cac_p_14 ahp14 yac_p_14 2p
Rac_p_14 yac_p_14 vahref 20meg
Cac_n_14 ahn14 yac_n_14 2p
Rac_n_14 yac_n_14 vahref 20meg
Cac_p_15 ahp15 yac_p_15 2p
Rac_p_15 yac_p_15 vahref 20meg
Cac_n_15 ahn15 yac_n_15 2p
Rac_n_15 yac_n_15 vahref 20meg
Cac_p_16 ahp16 yac_p_16 2p
Rac_p_16 yac_p_16 vahref 20meg
Cac_n_16 ahn16 yac_n_16 2p
Rac_n_16 yac_n_16 vahref 20meg
Cac_p_17 ahp17 yac_p_17 2p
Rac_p_17 yac_p_17 vahref 20meg
Cac_n_17 ahn17 yac_n_17 2p
Rac_n_17 yac_n_17 vahref 20meg
Cac_p_18 ahp18 yac_p_18 2p
Rac_p_18 yac_p_18 vahref 20meg
Cac_n_18 ahn18 yac_n_18 2p
Rac_n_18 yac_n_18 vahref 20meg
Cac_p_19 ahp19 yac_p_19 2p
Rac_p_19 yac_p_19 vahref 20meg
Cac_n_19 ahn19 yac_n_19 2p
Rac_n_19 yac_n_19 vahref 20meg
Cac_p_20 ahp20 yac_p_20 2p
Rac_p_20 yac_p_20 vahref 20meg
Cac_n_20 ahn20 yac_n_20 2p
Rac_n_20 yac_n_20 vahref 20meg
Cac_p_21 ahp21 yac_p_21 2p
Rac_p_21 yac_p_21 vahref 20meg
Cac_n_21 ahn21 yac_n_21 2p
Rac_n_21 yac_n_21 vahref 20meg
Cac_p_22 ahp22 yac_p_22 2p
Rac_p_22 yac_p_22 vahref 20meg
Cac_n_22 ahn22 yac_n_22 2p
Rac_n_22 yac_n_22 vahref 20meg
Cac_p_23 ahp23 yac_p_23 2p
Rac_p_23 yac_p_23 vahref 20meg
Cac_n_23 ahn23 yac_n_23 2p
Rac_n_23 yac_n_23 vahref 20meg
Xsc0 xop0 xon0 mop0 mon0 sop son vdd vbsyn gsyn
Xsc1 xop1 xon1 mop1 mon1 sop son vdd vbsyn gsyn
Xcm_s sop son vdd cmld
Rs sop son 40k
Vth sref 0 PWL(0.0n 0.95000 119.9n 0.95000 120.0n 0.95000 239.9n 0.95000 240.0n 0.95000 359.9n 0.95000 360.0n 0.95000 479.9n 0.95000 480.0n 0.95000 599.9n 0.95000 600.0n 0.95000 719.9n 0.95000 720.0n 0.95000 839.9n 0.95000 840.0n 0.95000 959.9n 0.95000 960.0n 0.95000 1079.9n 0.95000 1080.0n 0.95000 1199.9n 0.95000 1200.0n 0.95000 1319.9n 0.95000 1320.0n 0.95000 1439.9n 0.95000 1440.0n 0.95000 1559.9n 0.95000 1560.0n 0.95000 1679.9n 0.95000 1680.0n 0.95000 1799.9n 0.95000 1800.0n 0.95000 1919.9n 0.95000 1920.0n 0.95000 2039.9n 0.95000 2040.0n 0.95000 2159.9n 0.95000 2160.0n 0.95000 2279.9n 0.95000 2280.0n 0.95000 2399.9n 0.95000 2400.0n 0.95000 2519.9n 0.95000 2520.0n 0.95000 2639.9n 0.95000 2640.0n 0.95000 2759.9n 0.95000 2760.0n 0.95000 2879.9n 0.95000 2880.0n 0.95000 2999.9n 0.95000 3000.0n 0.95000 3119.9n 0.95000 3120.0n 0.95000 3239.9n 0.95000 3240.0n 0.95000 3359.9n 0.95000 3360.0n 0.95000 3479.9n 0.95000 3480.0n 0.95000 3599.9n 0.95000 3600.0n 0.95000 3719.9n 0.95000 3720.0n 0.95000 3839.9n 0.95000 3840.0n 0.95000 3959.9n 0.95000 3960.0n 0.95000 4079.9n 0.95000 4080.0n 0.95000 4199.9n 0.95000 4200.0n 0.95000 4319.9n 0.95000 4320.0n 0.95000 4439.9n 0.95000 4440.0n 0.95000 4559.9n 0.95000 4560.0n 0.95000 4679.9n 0.95000 4680.0n 0.95000 4799.9n 0.95000 4800.0n 0.95000 4919.9n 0.95000 4920.0n 0.95000 5039.9n 0.95000 5040.0n 0.95000 5159.9n 0.95000 5160.0n 0.95000 5279.9n 0.95000 5280.0n 0.95000 5399.9n 0.95000 5400.0n 0.95000 5519.9n 0.95000 5520.0n 0.95000 5639.9n 0.95000 5640.0n 0.95000 5759.9n 0.95000 5760.0n 0.95000 5879.9n 0.95000 5880.0n 0.95000 5999.9n 0.95000 6000.0n 0.95000 6119.9n 0.95000 6120.0n 0.95000 6239.9n 0.95000 6240.0n 0.95000 6359.9n 0.95000 6360.0n 0.95000 6479.9n 0.95000 6480.0n 0.95000 6599.9n 0.95000 6600.0n 0.95000 6719.9n 0.95000 6720.0n 0.95000 6839.9n 0.95000 6840.0n 0.95000 6959.9n 0.95000 6960.0n 0.95000 7079.9n 0.95000 7080.0n 0.95000 7199.9n 0.95000 7200.0n 0.95000 7319.9n 0.95000 7320.0n 0.95000 7439.9n 0.95000 7440.0n 0.95000 7559.9n 0.95000 7560.0n 0.95000 7679.9n 0.95000 7680.0n 0.95000 7799.9n 0.95000 7800.0n 0.95000 7919.9n 0.95000 7920.0n 0.95000 8039.9n 0.95000 8040.0n 0.95000 8159.9n 0.95000 8160.0n 0.95000 8279.9n 0.95000 8280.0n 0.95000 8399.9n 0.95000 8400.0n 0.95000 8519.9n 0.95000 8520.0n 0.95000 8639.9n 0.95000 8640.0n 0.95000 8759.9n 0.95000 8760.0n 0.95000 8879.9n 0.95000 8880.0n 0.95000 8999.9n 0.95000 9000.0n 0.95000 9119.9n 0.95000 9120.0n 0.95000 9239.9n 0.95000 9240.0n 0.95000 9359.9n 0.95000 9360.0n 0.95000 9479.9n 0.95000 9480.0n 0.95000 9599.9n 0.95000 9600.0n 0.95000 9719.9n 0.95000 9720.0n 0.95000 9839.9n 0.95000 9840.0n 0.95000 9959.9n 0.95000 9960.0n 0.95000 10079.9n 0.95000 10080.0n 0.95000 10199.9n 0.95000 10200.0n 0.95000 10319.9n 0.95000 10320.0n 0.95000 10439.9n 0.95000 10440.0n 0.95000 10559.9n 0.95000 10560.0n 0.50000 10679.9n 0.50000 10680.0n 0.50000 10799.9n 0.50000 10800.0n 0.50000 10919.9n 0.50000 10920.0n 0.50000 11039.9n 0.50000 11040.0n 0.50000 11159.9n 0.50000 11160.0n 0.50000 11279.9n 0.50000 11280.0n 0.50000 11399.9n 0.50000 11400.0n 0.50000 11519.9n 0.50000 11520.0n 0.50000 11639.9n 0.50000 11640.0n 0.50000 11759.9n 0.50000 11760.0n 0.50000 11879.9n 0.50000 11880.0n 0.50000 11999.9n 0.50000 12000.0n 0.50000 12119.9n 0.50000 12120.0n 0.50000 12239.9n 0.50000 12240.0n 0.50000 12359.9n 0.50000 12360.0n 0.50000 12479.9n 0.50000 12480.0n 0.50000 12599.9n 0.50000 12600.0n 0.50000 12719.9n 0.50000 12720.0n 0.50000 12839.9n 0.50000 12840.0n 0.50000 12959.9n 0.50000 12960.0n 0.50000 13079.9n 0.50000 13080.0n 0.50000 13199.9n 0.50000 13200.0n 0.50000 13319.9n 0.50000 13320.0n 0.50000 13439.9n 0.50000 13440.0n 0.50000 13559.9n 0.50000 13560.0n 0.50000 13679.9n 0.50000 13680.0n 0.50000 13799.9n 0.50000 13800.0n 0.50000 13919.9n 0.50000 13920.0n 0.50000 14039.9n 0.50000 14040.0n 0.50000 14159.9n 0.50000 14160.0n 0.50000 14279.9n 0.50000 14280.0n 0.50000 14399.9n 0.50000 14400.0n 0.50000 14519.9n 0.50000 14520.0n 0.50000 14639.9n 0.50000 14640.0n 0.50000 14759.9n 0.50000 14760.0n 0.50000 14879.9n 0.50000 14880.0n 0.50000 14999.9n 0.50000 15000.0n 0.50000 15119.9n 0.50000 15120.0n 0.50000 15239.9n 0.50000 15240.0n 0.50000 15359.9n 0.50000 15360.0n 0.50000 15479.9n 0.50000 15480.0n 0.50000 15599.9n 0.50000 15600.0n 0.50000 15719.9n 0.50000 15720.0n 0.50000 15839.9n 0.50000 15840.0n 0.50000 15959.9n 0.50000 15960.0n 0.50000 16079.9n 0.50000 16080.0n 0.50000 16199.9n 0.50000 16200.0n 0.50000 16319.9n 0.50000 16320.0n 0.50000 16439.9n 0.50000 16440.0n 0.50000 16559.9n 0.50000 16560.0n 0.50000 16679.9n 0.50000 16680.0n 0.50000 16799.9n 0.50000 16800.0n 0.50000 16919.9n 0.50000 16920.0n 0.50000 17039.9n 0.50000 17040.0n 0.50000 17159.9n 0.50000 17160.0n 0.50000 17279.9n 0.50000 17280.0n 0.50000 17399.9n 0.50000 17400.0n 0.50000 17519.9n 0.50000 17520.0n 0.50000 17639.9n 0.50000 17640.0n 0.50000 17759.9n 0.50000 17760.0n 0.50000 17879.9n 0.50000 17880.0n 0.50000 17999.9n 0.50000 18000.0n 0.50000 18119.9n 0.50000 18120.0n 0.50000 18239.9n 0.50000 18240.0n 0.50000 18359.9n 0.50000 18360.0n 0.50000 18479.9n 0.50000 18480.0n 0.50000 18599.9n 0.50000 18600.0n 0.50000 18719.9n 0.50000 18720.0n 0.50000 18839.9n 0.50000 18840.0n 0.50000 18959.9n 0.50000 18960.0n 0.50000 19079.9n 0.50000 19080.0n 0.50000 19199.9n 0.50000 19200.0n 0.50000 19319.9n 0.50000 19320.0n 0.50000 19439.9n 0.50000 19440.0n 0.50000 19559.9n 0.50000 19560.0n 0.50000 19679.9n 0.50000 19680.0n 0.50000 19799.9n 0.50000 19800.0n 0.50000 19919.9n 0.50000 19920.0n 0.50000 20039.9n 0.50000 20040.0n 0.50000 20159.9n 0.50000 20160.0n 0.50000 20279.9n 0.50000 20280.0n 0.50000 20399.9n 0.50000 20400.0n 0.50000 20519.9n 0.50000 20520.0n 0.50000 20639.9n 0.50000 20640.0n 0.50000 20759.9n 0.50000 20760.0n 0.50000 20879.9n 0.50000 20880.0n 0.50000 20999.9n 0.50000 21000.0n 0.50000)
Xcomp sref sop cdum conf vdd vbneu dneuron
Rgbl gbl gblg 30k
Mgate gblg conf 0 0 NNR W=600u L=100u
Cconf conf 0 2p
Csop sop 0 2p
Cgblg gblg 0 2p
Xlrn_0_0 eop0 eon0 yac_p_0 yac_n_0 who_p_0_0 who_n_0_0 vdd gblg gprod
Xlrn_1_0 eop0 eon0 yac_p_1 yac_n_1 who_p_1_0 who_n_1_0 vdd gblg gprod
Xlrn_2_0 eop0 eon0 yac_p_2 yac_n_2 who_p_2_0 who_n_2_0 vdd gblg gprod
Xlrn_3_0 eop0 eon0 yac_p_3 yac_n_3 who_p_3_0 who_n_3_0 vdd gblg gprod
Xlrn_4_0 eop0 eon0 yac_p_4 yac_n_4 who_p_4_0 who_n_4_0 vdd gblg gprod
Xlrn_5_0 eop0 eon0 yac_p_5 yac_n_5 who_p_5_0 who_n_5_0 vdd gblg gprod
Xlrn_6_0 eop0 eon0 yac_p_6 yac_n_6 who_p_6_0 who_n_6_0 vdd gblg gprod
Xlrn_7_0 eop0 eon0 yac_p_7 yac_n_7 who_p_7_0 who_n_7_0 vdd gblg gprod
Xlrn_8_0 eop0 eon0 yac_p_8 yac_n_8 who_p_8_0 who_n_8_0 vdd gblg gprod
Xlrn_9_0 eop0 eon0 yac_p_9 yac_n_9 who_p_9_0 who_n_9_0 vdd gblg gprod
Xlrn_10_0 eop0 eon0 yac_p_10 yac_n_10 who_p_10_0 who_n_10_0 vdd gblg gprod
Xlrn_11_0 eop0 eon0 yac_p_11 yac_n_11 who_p_11_0 who_n_11_0 vdd gblg gprod
Xlrn_12_0 eop0 eon0 yac_p_12 yac_n_12 who_p_12_0 who_n_12_0 vdd gblg gprod
Xlrn_13_0 eop0 eon0 yac_p_13 yac_n_13 who_p_13_0 who_n_13_0 vdd gblg gprod
Xlrn_14_0 eop0 eon0 yac_p_14 yac_n_14 who_p_14_0 who_n_14_0 vdd gblg gprod
Xlrn_15_0 eop0 eon0 yac_p_15 yac_n_15 who_p_15_0 who_n_15_0 vdd gblg gprod
Xlrn_16_0 eop0 eon0 yac_p_16 yac_n_16 who_p_16_0 who_n_16_0 vdd gblg gprod
Xlrn_17_0 eop0 eon0 yac_p_17 yac_n_17 who_p_17_0 who_n_17_0 vdd gblg gprod
Xlrn_18_0 eop0 eon0 yac_p_18 yac_n_18 who_p_18_0 who_n_18_0 vdd gblg gprod
Xlrn_19_0 eop0 eon0 yac_p_19 yac_n_19 who_p_19_0 who_n_19_0 vdd gblg gprod
Xlrn_20_0 eop0 eon0 yac_p_20 yac_n_20 who_p_20_0 who_n_20_0 vdd gblg gprod
Xlrn_21_0 eop0 eon0 yac_p_21 yac_n_21 who_p_21_0 who_n_21_0 vdd gblg gprod
Xlrn_22_0 eop0 eon0 yac_p_22 yac_n_22 who_p_22_0 who_n_22_0 vdd gblg gprod
Xlrn_23_0 eop0 eon0 yac_p_23 yac_n_23 who_p_23_0 who_n_23_0 vdd gblg gprod
Xlrn_24_0 eop0 eon0 ahbias_p ahbias_n who_p_24_0 who_n_24_0 vdd gblg gprod
Xlrn_0_1 eop1 eon1 yac_p_0 yac_n_0 who_p_0_1 who_n_0_1 vdd gblg gprod
Xlrn_1_1 eop1 eon1 yac_p_1 yac_n_1 who_p_1_1 who_n_1_1 vdd gblg gprod
Xlrn_2_1 eop1 eon1 yac_p_2 yac_n_2 who_p_2_1 who_n_2_1 vdd gblg gprod
Xlrn_3_1 eop1 eon1 yac_p_3 yac_n_3 who_p_3_1 who_n_3_1 vdd gblg gprod
Xlrn_4_1 eop1 eon1 yac_p_4 yac_n_4 who_p_4_1 who_n_4_1 vdd gblg gprod
Xlrn_5_1 eop1 eon1 yac_p_5 yac_n_5 who_p_5_1 who_n_5_1 vdd gblg gprod
Xlrn_6_1 eop1 eon1 yac_p_6 yac_n_6 who_p_6_1 who_n_6_1 vdd gblg gprod
Xlrn_7_1 eop1 eon1 yac_p_7 yac_n_7 who_p_7_1 who_n_7_1 vdd gblg gprod
Xlrn_8_1 eop1 eon1 yac_p_8 yac_n_8 who_p_8_1 who_n_8_1 vdd gblg gprod
Xlrn_9_1 eop1 eon1 yac_p_9 yac_n_9 who_p_9_1 who_n_9_1 vdd gblg gprod
Xlrn_10_1 eop1 eon1 yac_p_10 yac_n_10 who_p_10_1 who_n_10_1 vdd gblg gprod
Xlrn_11_1 eop1 eon1 yac_p_11 yac_n_11 who_p_11_1 who_n_11_1 vdd gblg gprod
Xlrn_12_1 eop1 eon1 yac_p_12 yac_n_12 who_p_12_1 who_n_12_1 vdd gblg gprod
Xlrn_13_1 eop1 eon1 yac_p_13 yac_n_13 who_p_13_1 who_n_13_1 vdd gblg gprod
Xlrn_14_1 eop1 eon1 yac_p_14 yac_n_14 who_p_14_1 who_n_14_1 vdd gblg gprod
Xlrn_15_1 eop1 eon1 yac_p_15 yac_n_15 who_p_15_1 who_n_15_1 vdd gblg gprod
Xlrn_16_1 eop1 eon1 yac_p_16 yac_n_16 who_p_16_1 who_n_16_1 vdd gblg gprod
Xlrn_17_1 eop1 eon1 yac_p_17 yac_n_17 who_p_17_1 who_n_17_1 vdd gblg gprod
Xlrn_18_1 eop1 eon1 yac_p_18 yac_n_18 who_p_18_1 who_n_18_1 vdd gblg gprod
Xlrn_19_1 eop1 eon1 yac_p_19 yac_n_19 who_p_19_1 who_n_19_1 vdd gblg gprod
Xlrn_20_1 eop1 eon1 yac_p_20 yac_n_20 who_p_20_1 who_n_20_1 vdd gblg gprod
Xlrn_21_1 eop1 eon1 yac_p_21 yac_n_21 who_p_21_1 who_n_21_1 vdd gblg gprod
Xlrn_22_1 eop1 eon1 yac_p_22 yac_n_22 who_p_22_1 who_n_22_1 vdd gblg gprod
Xlrn_23_1 eop1 eon1 yac_p_23 yac_n_23 who_p_23_1 who_n_23_1 vdd gblg gprod
Xlrn_24_1 eop1 eon1 ahbias_p ahbias_n who_p_24_1 who_n_24_1 vdd gblg gprod
.ic v(who_p_0_0)=0.5 v(who_n_0_0)=0.5
.ic v(who_p_1_0)=0.5 v(who_n_1_0)=0.5
.ic v(who_p_2_0)=0.5 v(who_n_2_0)=0.5
.ic v(who_p_3_0)=0.5 v(who_n_3_0)=0.5
.ic v(who_p_4_0)=0.5 v(who_n_4_0)=0.5
.ic v(who_p_5_0)=0.5 v(who_n_5_0)=0.5
.ic v(who_p_6_0)=0.5 v(who_n_6_0)=0.5
.ic v(who_p_7_0)=0.5 v(who_n_7_0)=0.5
.ic v(who_p_8_0)=0.5 v(who_n_8_0)=0.5
.ic v(who_p_9_0)=0.5 v(who_n_9_0)=0.5
.ic v(who_p_10_0)=0.5 v(who_n_10_0)=0.5
.ic v(who_p_11_0)=0.5 v(who_n_11_0)=0.5
.ic v(who_p_12_0)=0.5 v(who_n_12_0)=0.5
.ic v(who_p_13_0)=0.5 v(who_n_13_0)=0.5
.ic v(who_p_14_0)=0.5 v(who_n_14_0)=0.5
.ic v(who_p_15_0)=0.5 v(who_n_15_0)=0.5
.ic v(who_p_16_0)=0.5 v(who_n_16_0)=0.5
.ic v(who_p_17_0)=0.5 v(who_n_17_0)=0.5
.ic v(who_p_18_0)=0.5 v(who_n_18_0)=0.5
.ic v(who_p_19_0)=0.5 v(who_n_19_0)=0.5
.ic v(who_p_20_0)=0.5 v(who_n_20_0)=0.5
.ic v(who_p_21_0)=0.5 v(who_n_21_0)=0.5
.ic v(who_p_22_0)=0.5 v(who_n_22_0)=0.5
.ic v(who_p_23_0)=0.5 v(who_n_23_0)=0.5
.ic v(who_p_24_0)=0.5 v(who_n_24_0)=0.5
.ic v(who_p_0_1)=0.5 v(who_n_0_1)=0.5
.ic v(who_p_1_1)=0.5 v(who_n_1_1)=0.5
.ic v(who_p_2_1)=0.5 v(who_n_2_1)=0.5
.ic v(who_p_3_1)=0.5 v(who_n_3_1)=0.5
.ic v(who_p_4_1)=0.5 v(who_n_4_1)=0.5
.ic v(who_p_5_1)=0.5 v(who_n_5_1)=0.5
.ic v(who_p_6_1)=0.5 v(who_n_6_1)=0.5
.ic v(who_p_7_1)=0.5 v(who_n_7_1)=0.5
.ic v(who_p_8_1)=0.5 v(who_n_8_1)=0.5
.ic v(who_p_9_1)=0.5 v(who_n_9_1)=0.5
.ic v(who_p_10_1)=0.5 v(who_n_10_1)=0.5
.ic v(who_p_11_1)=0.5 v(who_n_11_1)=0.5
.ic v(who_p_12_1)=0.5 v(who_n_12_1)=0.5
.ic v(who_p_13_1)=0.5 v(who_n_13_1)=0.5
.ic v(who_p_14_1)=0.5 v(who_n_14_1)=0.5
.ic v(who_p_15_1)=0.5 v(who_n_15_1)=0.5
.ic v(who_p_16_1)=0.5 v(who_n_16_1)=0.5
.ic v(who_p_17_1)=0.5 v(who_n_17_1)=0.5
.ic v(who_p_18_1)=0.5 v(who_n_18_1)=0.5
.ic v(who_p_19_1)=0.5 v(who_n_19_1)=0.5
.ic v(who_p_20_1)=0.5 v(who_n_20_1)=0.5
.ic v(who_p_21_1)=0.5 v(who_n_21_1)=0.5
.ic v(who_p_22_1)=0.5 v(who_n_22_1)=0.5
.ic v(who_p_23_1)=0.5 v(who_n_23_1)=0.5
.ic v(who_p_24_1)=0.5 v(who_n_24_1)=0.5
.options gmin=1e-10 reltol=2e-3 cshunt=1e-14 method=gear
.control
tran 2n 21120n uic
wrdata ps_dbg.dat v(mop0) v(mon0) v(mop1) v(mon1)
.endc
.end
