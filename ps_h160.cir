fully in-spice PC learner
.model NNR NMOS (LEVEL=1 VTO=0.2 KP=120u LAMBDA=0.02 GAMMA=0 PHI=0.7)
.model PNR PMOS (LEVEL=1 VTO=-0.2 KP=40u LAMBDA=0.02 GAMMA=0 PHI=0.7)
.subckt gsyn inp inn wp wn outp outn vdd vbn
Mtail nt vbn 0 0 NNR W=400u L=100u
M5 na wp s5 0 NNR W=200u L=100u
Rd5 s5 nt 12k
M6 nb wn s6 0 NNR W=200u L=100u
Rd6 s6 nt 12k
M1 outp inp s1 0 NNR W=200u L=100u
Rd1 s1 na 12k
M2 outn inn s2 0 NNR W=200u L=100u
Rd2 s2 na 12k
M3 outn inp s3 0 NNR W=200u L=100u
Rd3 s3 nb 12k
M4 outp inn s4 0 NNR W=200u L=100u
Rd4 s4 nb 12k
.ends
.subckt gsynR inp inn wp wn outp outn vdd vbn
Mtail nt vbn 0 0 NNR W=400u L=100u
M5 na wp s5 0 NNR W=200u L=100u
Rd5 s5 nt 12k
M6 nb wn s6 0 NNR W=200u L=100u
Rd6 s6 nt 12k
M1 outp inp s1 0 NNR W=200u L=100u
Rd1 s1 na 12k
M2 outn inn s2 0 NNR W=200u L=100u
Rd2 s2 na 12k
M3 outn inp s3 0 NNR W=200u L=100u
Rd3 s3 nb 12k
M4 outp inn s4 0 NNR W=200u L=100u
Rd4 s4 nb 12k
.ends
.subckt cmld p n vdd
Rcs1 p cmx 300k
Rcs2 n cmx 300k
MLp p cmx vdd vdd PNR W=8000u L=100u
MLn n cmx vdd vdd PNR W=8000u L=100u
.ends
.subckt cmldW p n vdd
Rcs1 p cmx 300k
Rcs2 n cmx 300k
MLp p cmx vdd vdd PNR W=3000u L=100u
MLn n cmx vdd vdd PNR W=3000u L=100u
Rpd1 p 0 150k
Rpd2 n 0 150k
.ends
.subckt cmldR p n vdd vref vbn
Rcs1 p cmx 300k
Rcs2 n cmx 300k
Mt nt vbn 0 0 NNR W=200u L=100u
Ma da cmx nt 0 NNR W=100u L=100u
Mb db vref nt 0 NNR W=100u L=100u
MLa da da vdd vdd PNR W=100u L=100u
MLb db da vdd vdd PNR W=100u L=100u
MLp p db vdd vdd PNR W=8000u L=100u
MLn n db vdd vdd PNR W=8000u L=100u
.ends
.subckt dneuron up un ap an vdd vbn
M1 an up tn 0 NNR W=200u L=100u
M2 ap un tn 0 NNR W=200u L=100u
Mt tn vbn 0 0 NNR W=200u L=100u
Xcm ap an vdd cmld
.ends
.subckt esub xp xn mp mn ep en vdd vbn
Mtx ntx vbn 0 0 NNR W=400u L=100u
M1x ep xn ntx 0 NNR W=200u L=100u
M2x en xp ntx 0 NNR W=200u L=100u
Mtm ntm vbn 0 0 NNR W=400u L=100u
M1m ep mp ntm 0 NNR W=200u L=100u
M2m en mn ntm 0 NNR W=200u L=100u
RLp vdd ep 50k
RLn vdd en 50k
.ends
.subckt gprod xp xn yp yn wp wn vdd vbn
Mtail nt vbn 0 0 NNR W=400u L=100u
M5 na yp sy5 0 NNR W=200u L=100u
Rg5 sy5 nt 12k
M6 nb yn sy6 0 NNR W=200u L=100u
Rg6 sy6 nt 12k
M1 iop xp sx1 0 NNR W=200u L=100u
Rg1 sx1 na 12k
M2 ion xn sx2 0 NNR W=200u L=100u
Rg2 sx2 na 12k
M3 ion xp sx3 0 NNR W=200u L=100u
Rg3 sx3 nb 12k
M4 iop xn sx4 0 NNR W=200u L=100u
Rg4 sx4 nb 12k
Mlp iop iop vdd vdd PNR W=200u L=100u
Mln ion ion vdd vdd PNR W=200u L=100u
Mpu_wp wp iop vdd vdd PNR W=200u L=100u
MpRn nrn ion vdd vdd PNR W=200u L=100u
MnRn nrn nrn 0 0 NNR W=200u L=100u
Mpd_wp wp nrn 0 0 NNR W=200u L=100u
Mpu_wn wn ion vdd vdd PNR W=200u L=100u
MpRp nrp iop vdd vdd PNR W=200u L=100u
MnRp nrp nrp 0 0 NNR W=200u L=100u
Mpd_wn wn nrp 0 0 NNR W=200u L=100u
.ends
.subckt comp inp inn out vdd vbn
Mt nt vbn 0 0 NNR W=200u L=100u
M1 d1 inp nt 0 NNR W=200u L=100u
M2 out inn nt 0 NNR W=200u L=100u
M3 d1 d1 vdd vdd PNR W=200u L=100u
M4 out d1 vdd vdd PNR W=200u L=100u
.ends
Vdd vdd 0 1.0
Vbsyn vbsyn 0 1.1
Vbneu vbneu 0 0.35
Vgm gm 0 0.6
Vwcm wcm 0 0.5
Vgbl gbl 0 PWL(0.0n 0.85000 129.9n 0.85000 130.0n 0.85000 259.9n 0.85000 260.0n 0.85000 389.9n 0.85000 390.0n 0.85000 519.9n 0.85000 520.0n 0.85000 649.9n 0.85000 650.0n 0.85000 779.9n 0.85000 780.0n 0.85000 909.9n 0.85000 910.0n 0.85000 1039.9n 0.85000 1040.0n 0.85000 1169.9n 0.85000 1170.0n 0.85000 1299.9n 0.85000 1300.0n 0.85000 1429.9n 0.85000 1430.0n 0.85000 1559.9n 0.85000 1560.0n 0.85000 1689.9n 0.85000 1690.0n 0.85000 1819.9n 0.85000 1820.0n 0.85000 1949.9n 0.85000 1950.0n 0.85000 2079.9n 0.85000 2080.0n 0.85000 2209.9n 0.85000 2210.0n 0.85000 2339.9n 0.85000 2340.0n 0.85000 2469.9n 0.85000 2470.0n 0.85000 2599.9n 0.85000 2600.0n 0.85000 2729.9n 0.85000 2730.0n 0.85000 2859.9n 0.85000 2860.0n 0.85000 2989.9n 0.85000 2990.0n 0.85000 3119.9n 0.85000 3120.0n 0.85000 3249.9n 0.85000 3250.0n 0.85000 3379.9n 0.85000 3380.0n 0.85000 3509.9n 0.85000 3510.0n 0.85000 3639.9n 0.85000 3640.0n 0.85000 3769.9n 0.85000 3770.0n 0.85000 3899.9n 0.85000 3900.0n 0.85000 4029.9n 0.85000 4030.0n 0.85000 4159.9n 0.85000 4160.0n 0.85000 4289.9n 0.85000 4290.0n 0.85000 4419.9n 0.85000 4420.0n 0.85000 4549.9n 0.85000 4550.0n 0.85000 4679.9n 0.85000 4680.0n 0.85000 4809.9n 0.85000 4810.0n 0.85000 4939.9n 0.85000 4940.0n 0.85000 5069.9n 0.85000 5070.0n 0.85000 5199.9n 0.85000 5200.0n 0.85000 5329.9n 0.85000 5330.0n 0.85000 5459.9n 0.85000 5460.0n 0.85000 5589.9n 0.85000 5590.0n 0.85000 5719.9n 0.85000 5720.0n 0.85000 5849.9n 0.85000 5850.0n 0.85000 5979.9n 0.85000 5980.0n 0.85000 6109.9n 0.85000 6110.0n 0.85000 6239.9n 0.85000 6240.0n 0.85000 6369.9n 0.85000 6370.0n 0.85000 6499.9n 0.85000 6500.0n 0.85000 6629.9n 0.85000 6630.0n 0.85000 6759.9n 0.85000 6760.0n 0.85000 6889.9n 0.85000 6890.0n 0.85000 7019.9n 0.85000 7020.0n 0.85000 7149.9n 0.85000 7150.0n 0.85000 7279.9n 0.85000 7280.0n 0.85000 7409.9n 0.85000 7410.0n 0.85000 7539.9n 0.85000 7540.0n 0.85000 7669.9n 0.85000 7670.0n 0.85000 7799.9n 0.85000 7800.0n 0.85000 7929.9n 0.85000 7930.0n 0.85000 8059.9n 0.85000 8060.0n 0.85000 8189.9n 0.85000 8190.0n 0.85000 8319.9n 0.85000 8320.0n 0.85000 8449.9n 0.85000 8450.0n 0.85000 8579.9n 0.85000 8580.0n 0.85000 8709.9n 0.85000 8710.0n 0.85000 8839.9n 0.85000 8840.0n 0.85000 8969.9n 0.85000 8970.0n 0.85000 9099.9n 0.85000 9100.0n 0.85000 9229.9n 0.85000 9230.0n 0.85000 9359.9n 0.85000 9360.0n 0.85000 9489.9n 0.85000 9490.0n 0.85000 9619.9n 0.85000 9620.0n 0.85000 9749.9n 0.85000 9750.0n 0.85000 9879.9n 0.85000 9880.0n 0.85000 10009.9n 0.85000 10010.0n 0.85000 10139.9n 0.85000 10140.0n 0.85000 10269.9n 0.85000 10270.0n 0.85000 10399.9n 0.85000 10400.0n 0.85000 10529.9n 0.85000 10530.0n 0.85000 10659.9n 0.85000 10660.0n 0.85000 10789.9n 0.85000 10790.0n 0.85000 10919.9n 0.85000 10920.0n 0.85000 11049.9n 0.85000 11050.0n 0.85000 11179.9n 0.85000 11180.0n 0.85000 11309.9n 0.85000 11310.0n 0.85000 11439.9n 0.85000 11440.0n 0.85000 11569.9n 0.85000 11570.0n 0.85000 11699.9n 0.85000 11700.0n 0.85000 11829.9n 0.85000 11830.0n 0.85000 11959.9n 0.85000 11960.0n 0.85000 12089.9n 0.85000 12090.0n 0.85000 12219.9n 0.85000 12220.0n 0.85000 12349.9n 0.85000 12350.0n 0.85000 12479.9n 0.85000 12480.0n 0.85000 12609.9n 0.85000 12610.0n 0.85000 12739.9n 0.85000 12740.0n 0.85000 12869.9n 0.85000 12870.0n 0.85000 12999.9n 0.85000 13000.0n 0.85000 13129.9n 0.85000 13130.0n 0.85000 13259.9n 0.85000 13260.0n 0.85000 13389.9n 0.85000 13390.0n 0.85000 13519.9n 0.85000 13520.0n 0.85000 13649.9n 0.85000 13650.0n 0.85000 13779.9n 0.85000 13780.0n 0.85000 13909.9n 0.85000 13910.0n 0.85000 14039.9n 0.85000 14040.0n 0.85000 14169.9n 0.85000 14170.0n 0.85000 14299.9n 0.85000 14300.0n 0.85000 14429.9n 0.85000 14430.0n 0.85000 14559.9n 0.85000 14560.0n 0.85000 14689.9n 0.85000 14690.0n 0.85000 14819.9n 0.85000 14820.0n 0.85000 14949.9n 0.85000 14950.0n 0.85000 15079.9n 0.85000 15080.0n 0.85000 15209.9n 0.85000 15210.0n 0.85000 15339.9n 0.85000 15340.0n 0.85000 15469.9n 0.85000 15470.0n 0.85000 15599.9n 0.85000 15600.0n 0.85000 15729.9n 0.85000 15730.0n 0.85000 15859.9n 0.85000 15860.0n 0.85000 15989.9n 0.85000 15990.0n 0.85000 16119.9n 0.85000 16120.0n 0.85000 16249.9n 0.85000 16250.0n 0.85000 16379.9n 0.85000 16380.0n 0.85000 16509.9n 0.85000 16510.0n 0.85000 16639.9n 0.85000 16640.0n 0.85000 16769.9n 0.85000 16770.0n 0.85000 16899.9n 0.85000 16900.0n 0.85000 17029.9n 0.85000 17030.0n 0.85000 17159.9n 0.85000 17160.0n 0.85000 17289.9n 0.85000 17290.0n 0.85000 17419.9n 0.85000 17420.0n 0.85000 17549.9n 0.85000 17550.0n 0.85000 17679.9n 0.85000 17680.0n 0.85000 17809.9n 0.85000 17810.0n 0.85000 17939.9n 0.85000 17940.0n 0.85000 18069.9n 0.85000 18070.0n 0.85000 18199.9n 0.85000 18200.0n 0.85000 18329.9n 0.85000 18330.0n 0.85000 18459.9n 0.85000 18460.0n 0.85000 18589.9n 0.85000 18590.0n 0.85000 18719.9n 0.85000 18720.0n 0.85000 18849.9n 0.85000 18850.0n 0.85000 18979.9n 0.85000 18980.0n 0.85000 19109.9n 0.85000 19110.0n 0.85000 19239.9n 0.85000 19240.0n 0.85000 19369.9n 0.85000 19370.0n 0.85000 19499.9n 0.85000 19500.0n 0.85000 19629.9n 0.85000 19630.0n 0.85000 19759.9n 0.85000 19760.0n 0.85000 19889.9n 0.85000 19890.0n 0.85000 20019.9n 0.85000 20020.0n 0.85000 20149.9n 0.85000 20150.0n 0.85000 20279.9n 0.85000 20280.0n 0.85000 20409.9n 0.85000 20410.0n 0.85000 20539.9n 0.85000 20540.0n 0.85000 20669.9n 0.85000 20670.0n 0.85000 20799.9n 0.85000 20800.0n 0.85000 20929.9n 0.85000 20930.0n 0.85000 21059.9n 0.85000 21060.0n 0.85000 21189.9n 0.85000 21190.0n 0.85000 21319.9n 0.85000 21320.0n 0.85000 21449.9n 0.85000 21450.0n 0.85000 21579.9n 0.85000 21580.0n 0.85000 21709.9n 0.85000 21710.0n 0.85000 21839.9n 0.85000 21840.0n 0.00000 21969.9n 0.00000 21970.0n 0.00000 22099.9n 0.00000 22100.0n 0.00000 22229.9n 0.00000 22230.0n 0.00000 22359.9n 0.00000 22360.0n 0.00000 22489.9n 0.00000 22490.0n 0.00000 22619.9n 0.00000 22620.0n 0.00000 22749.9n 0.00000 22750.0n 0.00000 22879.9n 0.00000 22880.0n 0.00000 23009.9n 0.00000 23010.0n 0.00000 23139.9n 0.00000 23140.0n 0.00000 23269.9n 0.00000 23270.0n 0.00000 23399.9n 0.00000 23400.0n 0.00000 23529.9n 0.00000 23530.0n 0.00000 23659.9n 0.00000 23660.0n 0.00000 23789.9n 0.00000 23790.0n 0.00000 23919.9n 0.00000 23920.0n 0.00000 24049.9n 0.00000 24050.0n 0.00000 24179.9n 0.00000 24180.0n 0.00000 24309.9n 0.00000 24310.0n 0.00000 24439.9n 0.00000 24440.0n 0.00000 24569.9n 0.00000 24570.0n 0.00000 24699.9n 0.00000 24700.0n 0.00000 24829.9n 0.00000 24830.0n 0.00000 24959.9n 0.00000 24960.0n 0.00000 25089.9n 0.00000 25090.0n 0.00000 25219.9n 0.00000 25220.0n 0.00000 25349.9n 0.00000 25350.0n 0.00000 25479.9n 0.00000 25480.0n 0.00000 25609.9n 0.00000 25610.0n 0.00000 25739.9n 0.00000 25740.0n 0.00000 25869.9n 0.00000 25870.0n 0.00000 25999.9n 0.00000 26000.0n 0.00000 26129.9n 0.00000 26130.0n 0.00000 26259.9n 0.00000 26260.0n 0.00000 26389.9n 0.00000 26390.0n 0.00000 26519.9n 0.00000 26520.0n 0.00000 26649.9n 0.00000 26650.0n 0.00000 26779.9n 0.00000 26780.0n 0.00000 26909.9n 0.00000 26910.0n 0.00000 27039.9n 0.00000 27040.0n 0.00000 27169.9n 0.00000 27170.0n 0.00000 27299.9n 0.00000 27300.0n 0.00000 27429.9n 0.00000 27430.0n 0.00000 27559.9n 0.00000 27560.0n 0.00000 27689.9n 0.00000 27690.0n 0.00000 27819.9n 0.00000 27820.0n 0.00000 27949.9n 0.00000 27950.0n 0.00000 28079.9n 0.00000 28080.0n 0.85000 28209.9n 0.85000 28210.0n 0.85000 28339.9n 0.85000 28340.0n 0.85000 28469.9n 0.85000 28470.0n 0.85000 28599.9n 0.85000 28600.0n 0.85000 28729.9n 0.85000 28730.0n 0.85000 28859.9n 0.85000 28860.0n 0.85000 28989.9n 0.85000 28990.0n 0.85000 29119.9n 0.85000 29120.0n 0.85000 29249.9n 0.85000 29250.0n 0.85000 29379.9n 0.85000 29380.0n 0.85000 29509.9n 0.85000 29510.0n 0.85000 29639.9n 0.85000 29640.0n 0.85000 29769.9n 0.85000 29770.0n 0.85000 29899.9n 0.85000 29900.0n 0.85000 30029.9n 0.85000 30030.0n 0.85000 30159.9n 0.85000 30160.0n 0.85000 30289.9n 0.85000 30290.0n 0.85000 30419.9n 0.85000 30420.0n 0.85000 30549.9n 0.85000 30550.0n 0.85000 30679.9n 0.85000 30680.0n 0.85000 30809.9n 0.85000 30810.0n 0.85000 30939.9n 0.85000 30940.0n 0.85000 31069.9n 0.85000 31070.0n 0.85000 31199.9n 0.85000 31200.0n 0.85000 31329.9n 0.85000 31330.0n 0.85000 31459.9n 0.85000 31460.0n 0.85000 31589.9n 0.85000 31590.0n 0.85000 31719.9n 0.85000 31720.0n 0.85000 31849.9n 0.85000 31850.0n 0.85000 31979.9n 0.85000 31980.0n 0.85000 32109.9n 0.85000 32110.0n 0.85000 32239.9n 0.85000 32240.0n 0.85000 32369.9n 0.85000 32370.0n 0.85000 32499.9n 0.85000 32500.0n 0.85000 32629.9n 0.85000 32630.0n 0.85000 32759.9n 0.85000 32760.0n 0.85000 32889.9n 0.85000 32890.0n 0.85000 33019.9n 0.85000 33020.0n 0.85000 33149.9n 0.85000 33150.0n 0.85000 33279.9n 0.85000 33280.0n 0.85000 33409.9n 0.85000 33410.0n 0.85000 33539.9n 0.85000 33540.0n 0.85000 33669.9n 0.85000 33670.0n 0.85000 33799.9n 0.85000 33800.0n 0.85000 33929.9n 0.85000 33930.0n 0.85000 34059.9n 0.85000 34060.0n 0.85000 34189.9n 0.85000 34190.0n 0.85000 34319.9n 0.85000 34320.0n 0.85000 34449.9n 0.85000 34450.0n 0.85000 34579.9n 0.85000 34580.0n 0.85000 34709.9n 0.85000 34710.0n 0.85000 34839.9n 0.85000 34840.0n 0.85000 34969.9n 0.85000 34970.0n 0.85000 35099.9n 0.85000 35100.0n 0.85000 35229.9n 0.85000 35230.0n 0.85000 35359.9n 0.85000 35360.0n 0.85000 35489.9n 0.85000 35490.0n 0.85000 35619.9n 0.85000 35620.0n 0.85000 35749.9n 0.85000 35750.0n 0.85000 35879.9n 0.85000 35880.0n 0.85000 36009.9n 0.85000 36010.0n 0.85000 36139.9n 0.85000 36140.0n 0.85000 36269.9n 0.85000 36270.0n 0.85000 36399.9n 0.85000 36400.0n 0.85000 36529.9n 0.85000 36530.0n 0.85000 36659.9n 0.85000 36660.0n 0.85000 36789.9n 0.85000 36790.0n 0.85000 36919.9n 0.85000 36920.0n 0.85000 37049.9n 0.85000 37050.0n 0.85000 37179.9n 0.85000 37180.0n 0.85000 37309.9n 0.85000 37310.0n 0.85000 37439.9n 0.85000 37440.0n 0.85000 37569.9n 0.85000 37570.0n 0.85000 37699.9n 0.85000 37700.0n 0.85000 37829.9n 0.85000 37830.0n 0.85000 37959.9n 0.85000 37960.0n 0.85000 38089.9n 0.85000 38090.0n 0.85000 38219.9n 0.85000 38220.0n 0.85000 38349.9n 0.85000 38350.0n 0.85000 38479.9n 0.85000 38480.0n 0.85000 38609.9n 0.85000 38610.0n 0.85000 38739.9n 0.85000 38740.0n 0.85000 38869.9n 0.85000 38870.0n 0.85000 38999.9n 0.85000 39000.0n 0.85000 39129.9n 0.85000 39130.0n 0.85000 39259.9n 0.85000 39260.0n 0.85000 39389.9n 0.85000 39390.0n 0.85000 39519.9n 0.85000 39520.0n 0.85000 39649.9n 0.85000 39650.0n 0.85000 39779.9n 0.85000 39780.0n 0.85000 39909.9n 0.85000 39910.0n 0.85000 40039.9n 0.85000 40040.0n 0.85000 40169.9n 0.85000 40170.0n 0.85000 40299.9n 0.85000 40300.0n 0.85000 40429.9n 0.85000 40430.0n 0.85000 40559.9n 0.85000 40560.0n 0.85000 40689.9n 0.85000 40690.0n 0.85000 40819.9n 0.85000 40820.0n 0.85000 40949.9n 0.85000 40950.0n 0.85000 41079.9n 0.85000 41080.0n 0.85000 41209.9n 0.85000 41210.0n 0.85000 41339.9n 0.85000 41340.0n 0.85000 41469.9n 0.85000 41470.0n 0.85000 41599.9n 0.85000 41600.0n 0.85000 41729.9n 0.85000 41730.0n 0.85000 41859.9n 0.85000 41860.0n 0.85000 41989.9n 0.85000 41990.0n 0.85000 42119.9n 0.85000 42120.0n 0.85000 42249.9n 0.85000 42250.0n 0.85000 42379.9n 0.85000 42380.0n 0.85000 42509.9n 0.85000 42510.0n 0.85000 42639.9n 0.85000 42640.0n 0.85000 42769.9n 0.85000 42770.0n 0.85000 42899.9n 0.85000 42900.0n 0.85000 43029.9n 0.85000 43030.0n 0.85000 43159.9n 0.85000 43160.0n 0.85000 43289.9n 0.85000 43290.0n 0.85000 43419.9n 0.85000 43420.0n 0.85000 43549.9n 0.85000 43550.0n 0.85000 43679.9n 0.85000 43680.0n 0.85000 43809.9n 0.85000 43810.0n 0.85000 43939.9n 0.85000 43940.0n 0.85000 44069.9n 0.85000 44070.0n 0.85000 44199.9n 0.85000 44200.0n 0.85000 44329.9n 0.85000 44330.0n 0.85000 44459.9n 0.85000 44460.0n 0.85000 44589.9n 0.85000 44590.0n 0.85000 44719.9n 0.85000 44720.0n 0.85000 44849.9n 0.85000 44850.0n 0.85000 44979.9n 0.85000 44980.0n 0.85000 45109.9n 0.85000 45110.0n 0.85000 45239.9n 0.85000 45240.0n 0.85000 45369.9n 0.85000 45370.0n 0.85000 45499.9n 0.85000 45500.0n 0.85000 45629.9n 0.85000 45630.0n 0.85000 45759.9n 0.85000 45760.0n 0.85000 45889.9n 0.85000 45890.0n 0.85000 46019.9n 0.85000 46020.0n 0.85000 46149.9n 0.85000 46150.0n 0.85000 46279.9n 0.85000 46280.0n 0.85000 46409.9n 0.85000 46410.0n 0.85000 46539.9n 0.85000 46540.0n 0.85000 46669.9n 0.85000 46670.0n 0.85000 46799.9n 0.85000 46800.0n 0.85000 46929.9n 0.85000 46930.0n 0.85000 47059.9n 0.85000 47060.0n 0.85000 47189.9n 0.85000 47190.0n 0.85000 47319.9n 0.85000 47320.0n 0.85000 47449.9n 0.85000 47450.0n 0.85000 47579.9n 0.85000 47580.0n 0.85000 47709.9n 0.85000 47710.0n 0.85000 47839.9n 0.85000 47840.0n 0.85000 47969.9n 0.85000 47970.0n 0.85000 48099.9n 0.85000 48100.0n 0.85000 48229.9n 0.85000 48230.0n 0.85000 48359.9n 0.85000 48360.0n 0.85000 48489.9n 0.85000 48490.0n 0.85000 48619.9n 0.85000 48620.0n 0.85000 48749.9n 0.85000 48750.0n 0.85000 48879.9n 0.85000 48880.0n 0.85000 49009.9n 0.85000 49010.0n 0.85000 49139.9n 0.85000 49140.0n 0.85000 49269.9n 0.85000 49270.0n 0.85000 49399.9n 0.85000 49400.0n 0.85000 49529.9n 0.85000 49530.0n 0.85000 49659.9n 0.85000 49660.0n 0.85000 49789.9n 0.85000 49790.0n 0.85000 49919.9n 0.85000 49920.0n 0.00000 50049.9n 0.00000 50050.0n 0.00000 50179.9n 0.00000 50180.0n 0.00000 50309.9n 0.00000 50310.0n 0.00000 50439.9n 0.00000 50440.0n 0.00000 50569.9n 0.00000 50570.0n 0.00000 50699.9n 0.00000 50700.0n 0.00000 50829.9n 0.00000 50830.0n 0.00000 50959.9n 0.00000 50960.0n 0.00000 51089.9n 0.00000 51090.0n 0.00000 51219.9n 0.00000 51220.0n 0.00000 51349.9n 0.00000 51350.0n 0.00000 51479.9n 0.00000 51480.0n 0.00000 51609.9n 0.00000 51610.0n 0.00000 51739.9n 0.00000 51740.0n 0.00000 51869.9n 0.00000 51870.0n 0.00000 51999.9n 0.00000 52000.0n 0.00000 52129.9n 0.00000 52130.0n 0.00000 52259.9n 0.00000 52260.0n 0.00000 52389.9n 0.00000 52390.0n 0.00000 52519.9n 0.00000 52520.0n 0.00000 52649.9n 0.00000 52650.0n 0.00000 52779.9n 0.00000 52780.0n 0.00000 52909.9n 0.00000 52910.0n 0.00000 53039.9n 0.00000 53040.0n 0.00000 53169.9n 0.00000 53170.0n 0.00000 53299.9n 0.00000 53300.0n 0.00000 53429.9n 0.00000 53430.0n 0.00000 53559.9n 0.00000 53560.0n 0.00000 53689.9n 0.00000 53690.0n 0.00000 53819.9n 0.00000 53820.0n 0.00000 53949.9n 0.00000 53950.0n 0.00000 54079.9n 0.00000 54080.0n 0.00000 54209.9n 0.00000 54210.0n 0.00000 54339.9n 0.00000 54340.0n 0.00000 54469.9n 0.00000 54470.0n 0.00000 54599.9n 0.00000 54600.0n 0.00000 54729.9n 0.00000 54730.0n 0.00000 54859.9n 0.00000 54860.0n 0.00000 54989.9n 0.00000 54990.0n 0.00000 55119.9n 0.00000 55120.0n 0.00000 55249.9n 0.00000 55250.0n 0.00000 55379.9n 0.00000 55380.0n 0.00000 55509.9n 0.00000 55510.0n 0.00000 55639.9n 0.00000 55640.0n 0.00000 55769.9n 0.00000 55770.0n 0.00000 55899.9n 0.00000 55900.0n 0.00000 56029.9n 0.00000 56030.0n 0.00000 56159.9n 0.00000 56160.0n 0.85000 56289.9n 0.85000 56290.0n 0.85000 56419.9n 0.85000 56420.0n 0.85000 56549.9n 0.85000 56550.0n 0.85000 56679.9n 0.85000 56680.0n 0.85000 56809.9n 0.85000 56810.0n 0.85000 56939.9n 0.85000 56940.0n 0.85000 57069.9n 0.85000 57070.0n 0.85000 57199.9n 0.85000 57200.0n 0.85000 57329.9n 0.85000 57330.0n 0.85000 57459.9n 0.85000 57460.0n 0.85000 57589.9n 0.85000 57590.0n 0.85000 57719.9n 0.85000 57720.0n 0.85000 57849.9n 0.85000 57850.0n 0.85000 57979.9n 0.85000 57980.0n 0.85000 58109.9n 0.85000 58110.0n 0.85000 58239.9n 0.85000 58240.0n 0.85000 58369.9n 0.85000 58370.0n 0.85000 58499.9n 0.85000 58500.0n 0.85000 58629.9n 0.85000 58630.0n 0.85000 58759.9n 0.85000 58760.0n 0.85000 58889.9n 0.85000 58890.0n 0.85000 59019.9n 0.85000 59020.0n 0.85000 59149.9n 0.85000 59150.0n 0.85000 59279.9n 0.85000 59280.0n 0.85000 59409.9n 0.85000 59410.0n 0.85000 59539.9n 0.85000 59540.0n 0.85000 59669.9n 0.85000 59670.0n 0.85000 59799.9n 0.85000 59800.0n 0.85000 59929.9n 0.85000 59930.0n 0.85000 60059.9n 0.85000 60060.0n 0.85000 60189.9n 0.85000 60190.0n 0.85000 60319.9n 0.85000 60320.0n 0.85000 60449.9n 0.85000 60450.0n 0.85000 60579.9n 0.85000 60580.0n 0.85000 60709.9n 0.85000 60710.0n 0.85000 60839.9n 0.85000 60840.0n 0.85000 60969.9n 0.85000 60970.0n 0.85000 61099.9n 0.85000 61100.0n 0.85000 61229.9n 0.85000 61230.0n 0.85000 61359.9n 0.85000 61360.0n 0.85000 61489.9n 0.85000 61490.0n 0.85000 61619.9n 0.85000 61620.0n 0.85000 61749.9n 0.85000 61750.0n 0.85000 61879.9n 0.85000 61880.0n 0.85000 62009.9n 0.85000 62010.0n 0.85000 62139.9n 0.85000 62140.0n 0.85000 62269.9n 0.85000 62270.0n 0.85000 62399.9n 0.85000 62400.0n 0.85000 62529.9n 0.85000 62530.0n 0.85000 62659.9n 0.85000 62660.0n 0.85000 62789.9n 0.85000 62790.0n 0.85000 62919.9n 0.85000 62920.0n 0.85000 63049.9n 0.85000 63050.0n 0.85000 63179.9n 0.85000 63180.0n 0.85000 63309.9n 0.85000 63310.0n 0.85000 63439.9n 0.85000 63440.0n 0.85000 63569.9n 0.85000 63570.0n 0.85000 63699.9n 0.85000 63700.0n 0.85000 63829.9n 0.85000 63830.0n 0.85000 63959.9n 0.85000 63960.0n 0.85000 64089.9n 0.85000 64090.0n 0.85000 64219.9n 0.85000 64220.0n 0.85000 64349.9n 0.85000 64350.0n 0.85000 64479.9n 0.85000 64480.0n 0.85000 64609.9n 0.85000 64610.0n 0.85000 64739.9n 0.85000 64740.0n 0.85000 64869.9n 0.85000 64870.0n 0.85000 64999.9n 0.85000 65000.0n 0.85000 65129.9n 0.85000 65130.0n 0.85000 65259.9n 0.85000 65260.0n 0.85000 65389.9n 0.85000 65390.0n 0.85000 65519.9n 0.85000 65520.0n 0.85000 65649.9n 0.85000 65650.0n 0.85000 65779.9n 0.85000 65780.0n 0.85000 65909.9n 0.85000 65910.0n 0.85000 66039.9n 0.85000 66040.0n 0.85000 66169.9n 0.85000 66170.0n 0.85000 66299.9n 0.85000 66300.0n 0.85000 66429.9n 0.85000 66430.0n 0.85000 66559.9n 0.85000 66560.0n 0.85000 66689.9n 0.85000 66690.0n 0.85000 66819.9n 0.85000 66820.0n 0.85000 66949.9n 0.85000 66950.0n 0.85000 67079.9n 0.85000 67080.0n 0.85000 67209.9n 0.85000 67210.0n 0.85000 67339.9n 0.85000 67340.0n 0.85000 67469.9n 0.85000 67470.0n 0.85000 67599.9n 0.85000 67600.0n 0.85000 67729.9n 0.85000 67730.0n 0.85000 67859.9n 0.85000 67860.0n 0.85000 67989.9n 0.85000 67990.0n 0.85000 68119.9n 0.85000 68120.0n 0.85000 68249.9n 0.85000 68250.0n 0.85000 68379.9n 0.85000 68380.0n 0.85000 68509.9n 0.85000 68510.0n 0.85000 68639.9n 0.85000 68640.0n 0.85000 68769.9n 0.85000 68770.0n 0.85000 68899.9n 0.85000 68900.0n 0.85000 69029.9n 0.85000 69030.0n 0.85000 69159.9n 0.85000 69160.0n 0.85000 69289.9n 0.85000 69290.0n 0.85000 69419.9n 0.85000 69420.0n 0.85000 69549.9n 0.85000 69550.0n 0.85000 69679.9n 0.85000 69680.0n 0.85000 69809.9n 0.85000 69810.0n 0.85000 69939.9n 0.85000 69940.0n 0.85000 70069.9n 0.85000 70070.0n 0.85000 70199.9n 0.85000 70200.0n 0.85000 70329.9n 0.85000 70330.0n 0.85000 70459.9n 0.85000 70460.0n 0.85000 70589.9n 0.85000 70590.0n 0.85000 70719.9n 0.85000 70720.0n 0.85000 70849.9n 0.85000 70850.0n 0.85000 70979.9n 0.85000 70980.0n 0.85000 71109.9n 0.85000 71110.0n 0.85000 71239.9n 0.85000 71240.0n 0.85000 71369.9n 0.85000 71370.0n 0.85000 71499.9n 0.85000 71500.0n 0.85000 71629.9n 0.85000 71630.0n 0.85000 71759.9n 0.85000 71760.0n 0.85000 71889.9n 0.85000 71890.0n 0.85000 72019.9n 0.85000 72020.0n 0.85000 72149.9n 0.85000 72150.0n 0.85000 72279.9n 0.85000 72280.0n 0.85000 72409.9n 0.85000 72410.0n 0.85000 72539.9n 0.85000 72540.0n 0.85000 72669.9n 0.85000 72670.0n 0.85000 72799.9n 0.85000 72800.0n 0.85000 72929.9n 0.85000 72930.0n 0.85000 73059.9n 0.85000 73060.0n 0.85000 73189.9n 0.85000 73190.0n 0.85000 73319.9n 0.85000 73320.0n 0.85000 73449.9n 0.85000 73450.0n 0.85000 73579.9n 0.85000 73580.0n 0.85000 73709.9n 0.85000 73710.0n 0.85000 73839.9n 0.85000 73840.0n 0.85000 73969.9n 0.85000 73970.0n 0.85000 74099.9n 0.85000 74100.0n 0.85000 74229.9n 0.85000 74230.0n 0.85000 74359.9n 0.85000 74360.0n 0.85000 74489.9n 0.85000 74490.0n 0.85000 74619.9n 0.85000 74620.0n 0.85000 74749.9n 0.85000 74750.0n 0.85000 74879.9n 0.85000 74880.0n 0.85000 75009.9n 0.85000 75010.0n 0.85000 75139.9n 0.85000 75140.0n 0.85000 75269.9n 0.85000 75270.0n 0.85000 75399.9n 0.85000 75400.0n 0.85000 75529.9n 0.85000 75530.0n 0.85000 75659.9n 0.85000 75660.0n 0.85000 75789.9n 0.85000 75790.0n 0.85000 75919.9n 0.85000 75920.0n 0.85000 76049.9n 0.85000 76050.0n 0.85000 76179.9n 0.85000 76180.0n 0.85000 76309.9n 0.85000 76310.0n 0.85000 76439.9n 0.85000 76440.0n 0.85000 76569.9n 0.85000 76570.0n 0.85000 76699.9n 0.85000 76700.0n 0.85000 76829.9n 0.85000 76830.0n 0.85000 76959.9n 0.85000 76960.0n 0.85000 77089.9n 0.85000 77090.0n 0.85000 77219.9n 0.85000 77220.0n 0.85000 77349.9n 0.85000 77350.0n 0.85000 77479.9n 0.85000 77480.0n 0.85000 77609.9n 0.85000 77610.0n 0.85000 77739.9n 0.85000 77740.0n 0.85000 77869.9n 0.85000 77870.0n 0.85000 77999.9n 0.85000 78000.0n 0.00000 78129.9n 0.00000 78130.0n 0.00000 78259.9n 0.00000 78260.0n 0.00000 78389.9n 0.00000 78390.0n 0.00000 78519.9n 0.00000 78520.0n 0.00000 78649.9n 0.00000 78650.0n 0.00000 78779.9n 0.00000 78780.0n 0.00000 78909.9n 0.00000 78910.0n 0.00000 79039.9n 0.00000 79040.0n 0.00000 79169.9n 0.00000 79170.0n 0.00000 79299.9n 0.00000 79300.0n 0.00000 79429.9n 0.00000 79430.0n 0.00000 79559.9n 0.00000 79560.0n 0.00000 79689.9n 0.00000 79690.0n 0.00000 79819.9n 0.00000 79820.0n 0.00000 79949.9n 0.00000 79950.0n 0.00000 80079.9n 0.00000 80080.0n 0.00000 80209.9n 0.00000 80210.0n 0.00000 80339.9n 0.00000 80340.0n 0.00000 80469.9n 0.00000 80470.0n 0.00000 80599.9n 0.00000 80600.0n 0.00000 80729.9n 0.00000 80730.0n 0.00000 80859.9n 0.00000 80860.0n 0.00000 80989.9n 0.00000 80990.0n 0.00000 81119.9n 0.00000 81120.0n 0.00000 81249.9n 0.00000 81250.0n 0.00000 81379.9n 0.00000 81380.0n 0.00000 81509.9n 0.00000 81510.0n 0.00000 81639.9n 0.00000 81640.0n 0.00000 81769.9n 0.00000 81770.0n 0.00000 81899.9n 0.00000 81900.0n 0.00000 82029.9n 0.00000 82030.0n 0.00000 82159.9n 0.00000 82160.0n 0.00000 82289.9n 0.00000 82290.0n 0.00000 82419.9n 0.00000 82420.0n 0.00000 82549.9n 0.00000 82550.0n 0.00000 82679.9n 0.00000 82680.0n 0.00000 82809.9n 0.00000 82810.0n 0.00000 82939.9n 0.00000 82940.0n 0.00000 83069.9n 0.00000 83070.0n 0.00000 83199.9n 0.00000 83200.0n 0.00000 83329.9n 0.00000 83330.0n 0.00000 83459.9n 0.00000 83460.0n 0.00000 83589.9n 0.00000 83590.0n 0.00000 83719.9n 0.00000 83720.0n 0.00000 83849.9n 0.00000 83850.0n 0.00000 83979.9n 0.00000 83980.0n 0.00000 84109.9n 0.00000 84110.0n 0.00000 84239.9n 0.00000 84240.0n 0.85000 84369.9n 0.85000 84370.0n 0.85000 84499.9n 0.85000 84500.0n 0.85000 84629.9n 0.85000 84630.0n 0.85000 84759.9n 0.85000 84760.0n 0.85000 84889.9n 0.85000 84890.0n 0.85000 85019.9n 0.85000 85020.0n 0.85000 85149.9n 0.85000 85150.0n 0.85000 85279.9n 0.85000 85280.0n 0.85000 85409.9n 0.85000 85410.0n 0.85000 85539.9n 0.85000 85540.0n 0.85000 85669.9n 0.85000 85670.0n 0.85000 85799.9n 0.85000 85800.0n 0.85000 85929.9n 0.85000 85930.0n 0.85000 86059.9n 0.85000 86060.0n 0.85000 86189.9n 0.85000 86190.0n 0.85000 86319.9n 0.85000 86320.0n 0.85000 86449.9n 0.85000 86450.0n 0.85000 86579.9n 0.85000 86580.0n 0.85000 86709.9n 0.85000 86710.0n 0.85000 86839.9n 0.85000 86840.0n 0.85000 86969.9n 0.85000 86970.0n 0.85000 87099.9n 0.85000 87100.0n 0.85000 87229.9n 0.85000 87230.0n 0.85000 87359.9n 0.85000 87360.0n 0.85000 87489.9n 0.85000 87490.0n 0.85000 87619.9n 0.85000 87620.0n 0.85000 87749.9n 0.85000 87750.0n 0.85000 87879.9n 0.85000 87880.0n 0.85000 88009.9n 0.85000 88010.0n 0.85000 88139.9n 0.85000 88140.0n 0.85000 88269.9n 0.85000 88270.0n 0.85000 88399.9n 0.85000 88400.0n 0.85000 88529.9n 0.85000 88530.0n 0.85000 88659.9n 0.85000 88660.0n 0.85000 88789.9n 0.85000 88790.0n 0.85000 88919.9n 0.85000 88920.0n 0.85000 89049.9n 0.85000 89050.0n 0.85000 89179.9n 0.85000 89180.0n 0.85000 89309.9n 0.85000 89310.0n 0.85000 89439.9n 0.85000 89440.0n 0.85000 89569.9n 0.85000 89570.0n 0.85000 89699.9n 0.85000 89700.0n 0.85000 89829.9n 0.85000 89830.0n 0.85000 89959.9n 0.85000 89960.0n 0.85000 90089.9n 0.85000 90090.0n 0.85000 90219.9n 0.85000 90220.0n 0.85000 90349.9n 0.85000 90350.0n 0.85000 90479.9n 0.85000 90480.0n 0.85000 90609.9n 0.85000 90610.0n 0.85000 90739.9n 0.85000 90740.0n 0.85000 90869.9n 0.85000 90870.0n 0.85000 90999.9n 0.85000 91000.0n 0.85000 91129.9n 0.85000 91130.0n 0.85000 91259.9n 0.85000 91260.0n 0.85000 91389.9n 0.85000 91390.0n 0.85000 91519.9n 0.85000 91520.0n 0.85000 91649.9n 0.85000 91650.0n 0.85000 91779.9n 0.85000 91780.0n 0.85000 91909.9n 0.85000 91910.0n 0.85000 92039.9n 0.85000 92040.0n 0.85000 92169.9n 0.85000 92170.0n 0.85000 92299.9n 0.85000 92300.0n 0.85000 92429.9n 0.85000 92430.0n 0.85000 92559.9n 0.85000 92560.0n 0.85000 92689.9n 0.85000 92690.0n 0.85000 92819.9n 0.85000 92820.0n 0.85000 92949.9n 0.85000 92950.0n 0.85000 93079.9n 0.85000 93080.0n 0.85000 93209.9n 0.85000 93210.0n 0.85000 93339.9n 0.85000 93340.0n 0.85000 93469.9n 0.85000 93470.0n 0.85000 93599.9n 0.85000 93600.0n 0.85000 93729.9n 0.85000 93730.0n 0.85000 93859.9n 0.85000 93860.0n 0.85000 93989.9n 0.85000 93990.0n 0.85000 94119.9n 0.85000 94120.0n 0.85000 94249.9n 0.85000 94250.0n 0.85000 94379.9n 0.85000 94380.0n 0.85000 94509.9n 0.85000 94510.0n 0.85000 94639.9n 0.85000 94640.0n 0.85000 94769.9n 0.85000 94770.0n 0.85000 94899.9n 0.85000 94900.0n 0.85000 95029.9n 0.85000 95030.0n 0.85000 95159.9n 0.85000 95160.0n 0.85000 95289.9n 0.85000 95290.0n 0.85000 95419.9n 0.85000 95420.0n 0.85000 95549.9n 0.85000 95550.0n 0.85000 95679.9n 0.85000 95680.0n 0.85000 95809.9n 0.85000 95810.0n 0.85000 95939.9n 0.85000 95940.0n 0.85000 96069.9n 0.85000 96070.0n 0.85000 96199.9n 0.85000 96200.0n 0.85000 96329.9n 0.85000 96330.0n 0.85000 96459.9n 0.85000 96460.0n 0.85000 96589.9n 0.85000 96590.0n 0.85000 96719.9n 0.85000 96720.0n 0.85000 96849.9n 0.85000 96850.0n 0.85000 96979.9n 0.85000 96980.0n 0.85000 97109.9n 0.85000 97110.0n 0.85000 97239.9n 0.85000 97240.0n 0.85000 97369.9n 0.85000 97370.0n 0.85000 97499.9n 0.85000 97500.0n 0.85000 97629.9n 0.85000 97630.0n 0.85000 97759.9n 0.85000 97760.0n 0.85000 97889.9n 0.85000 97890.0n 0.85000 98019.9n 0.85000 98020.0n 0.85000 98149.9n 0.85000 98150.0n 0.85000 98279.9n 0.85000 98280.0n 0.85000 98409.9n 0.85000 98410.0n 0.85000 98539.9n 0.85000 98540.0n 0.85000 98669.9n 0.85000 98670.0n 0.85000 98799.9n 0.85000 98800.0n 0.85000 98929.9n 0.85000 98930.0n 0.85000 99059.9n 0.85000 99060.0n 0.85000 99189.9n 0.85000 99190.0n 0.85000 99319.9n 0.85000 99320.0n 0.85000 99449.9n 0.85000 99450.0n 0.85000 99579.9n 0.85000 99580.0n 0.85000 99709.9n 0.85000 99710.0n 0.85000 99839.9n 0.85000 99840.0n 0.85000 99969.9n 0.85000 99970.0n 0.85000 100099.9n 0.85000 100100.0n 0.85000 100229.9n 0.85000 100230.0n 0.85000 100359.9n 0.85000 100360.0n 0.85000 100489.9n 0.85000 100490.0n 0.85000 100619.9n 0.85000 100620.0n 0.85000 100749.9n 0.85000 100750.0n 0.85000 100879.9n 0.85000 100880.0n 0.85000 101009.9n 0.85000 101010.0n 0.85000 101139.9n 0.85000 101140.0n 0.85000 101269.9n 0.85000 101270.0n 0.85000 101399.9n 0.85000 101400.0n 0.85000 101529.9n 0.85000 101530.0n 0.85000 101659.9n 0.85000 101660.0n 0.85000 101789.9n 0.85000 101790.0n 0.85000 101919.9n 0.85000 101920.0n 0.85000 102049.9n 0.85000 102050.0n 0.85000 102179.9n 0.85000 102180.0n 0.85000 102309.9n 0.85000 102310.0n 0.85000 102439.9n 0.85000 102440.0n 0.85000 102569.9n 0.85000 102570.0n 0.85000 102699.9n 0.85000 102700.0n 0.85000 102829.9n 0.85000 102830.0n 0.85000 102959.9n 0.85000 102960.0n 0.85000 103089.9n 0.85000 103090.0n 0.85000 103219.9n 0.85000 103220.0n 0.85000 103349.9n 0.85000 103350.0n 0.85000 103479.9n 0.85000 103480.0n 0.85000 103609.9n 0.85000 103610.0n 0.85000 103739.9n 0.85000 103740.0n 0.85000 103869.9n 0.85000 103870.0n 0.85000 103999.9n 0.85000 104000.0n 0.85000 104129.9n 0.85000 104130.0n 0.85000 104259.9n 0.85000 104260.0n 0.85000 104389.9n 0.85000 104390.0n 0.85000 104519.9n 0.85000 104520.0n 0.85000 104649.9n 0.85000 104650.0n 0.85000 104779.9n 0.85000 104780.0n 0.85000 104909.9n 0.85000 104910.0n 0.85000 105039.9n 0.85000 105040.0n 0.85000 105169.9n 0.85000 105170.0n 0.85000 105299.9n 0.85000 105300.0n 0.85000 105429.9n 0.85000 105430.0n 0.85000 105559.9n 0.85000 105560.0n 0.85000 105689.9n 0.85000 105690.0n 0.85000 105819.9n 0.85000 105820.0n 0.85000 105949.9n 0.85000 105950.0n 0.85000 106079.9n 0.85000 106080.0n 0.00000 106209.9n 0.00000 106210.0n 0.00000 106339.9n 0.00000 106340.0n 0.00000 106469.9n 0.00000 106470.0n 0.00000 106599.9n 0.00000 106600.0n 0.00000 106729.9n 0.00000 106730.0n 0.00000 106859.9n 0.00000 106860.0n 0.00000 106989.9n 0.00000 106990.0n 0.00000 107119.9n 0.00000 107120.0n 0.00000 107249.9n 0.00000 107250.0n 0.00000 107379.9n 0.00000 107380.0n 0.00000 107509.9n 0.00000 107510.0n 0.00000 107639.9n 0.00000 107640.0n 0.00000 107769.9n 0.00000 107770.0n 0.00000 107899.9n 0.00000 107900.0n 0.00000 108029.9n 0.00000 108030.0n 0.00000 108159.9n 0.00000 108160.0n 0.00000 108289.9n 0.00000 108290.0n 0.00000 108419.9n 0.00000 108420.0n 0.00000 108549.9n 0.00000 108550.0n 0.00000 108679.9n 0.00000 108680.0n 0.00000 108809.9n 0.00000 108810.0n 0.00000 108939.9n 0.00000 108940.0n 0.00000 109069.9n 0.00000 109070.0n 0.00000 109199.9n 0.00000 109200.0n 0.00000 109329.9n 0.00000 109330.0n 0.00000 109459.9n 0.00000 109460.0n 0.00000 109589.9n 0.00000 109590.0n 0.00000 109719.9n 0.00000 109720.0n 0.00000 109849.9n 0.00000 109850.0n 0.00000 109979.9n 0.00000 109980.0n 0.00000 110109.9n 0.00000 110110.0n 0.00000 110239.9n 0.00000 110240.0n 0.00000 110369.9n 0.00000 110370.0n 0.00000 110499.9n 0.00000 110500.0n 0.00000 110629.9n 0.00000 110630.0n 0.00000 110759.9n 0.00000 110760.0n 0.00000 110889.9n 0.00000 110890.0n 0.00000 111019.9n 0.00000 111020.0n 0.00000 111149.9n 0.00000 111150.0n 0.00000 111279.9n 0.00000 111280.0n 0.00000 111409.9n 0.00000 111410.0n 0.00000 111539.9n 0.00000 111540.0n 0.00000 111669.9n 0.00000 111670.0n 0.00000 111799.9n 0.00000 111800.0n 0.00000 111929.9n 0.00000 111930.0n 0.00000 112059.9n 0.00000 112060.0n 0.00000 112189.9n 0.00000 112190.0n 0.00000 112319.9n 0.00000 112320.0n 0.85000 112449.9n 0.85000 112450.0n 0.85000 112579.9n 0.85000 112580.0n 0.85000 112709.9n 0.85000 112710.0n 0.85000 112839.9n 0.85000 112840.0n 0.85000 112969.9n 0.85000 112970.0n 0.85000 113099.9n 0.85000 113100.0n 0.85000 113229.9n 0.85000 113230.0n 0.85000 113359.9n 0.85000 113360.0n 0.85000 113489.9n 0.85000 113490.0n 0.85000 113619.9n 0.85000 113620.0n 0.85000 113749.9n 0.85000 113750.0n 0.85000 113879.9n 0.85000 113880.0n 0.85000 114009.9n 0.85000 114010.0n 0.85000 114139.9n 0.85000 114140.0n 0.85000 114269.9n 0.85000 114270.0n 0.85000 114399.9n 0.85000 114400.0n 0.85000 114529.9n 0.85000 114530.0n 0.85000 114659.9n 0.85000 114660.0n 0.85000 114789.9n 0.85000 114790.0n 0.85000 114919.9n 0.85000 114920.0n 0.85000 115049.9n 0.85000 115050.0n 0.85000 115179.9n 0.85000 115180.0n 0.85000 115309.9n 0.85000 115310.0n 0.85000 115439.9n 0.85000 115440.0n 0.85000 115569.9n 0.85000 115570.0n 0.85000 115699.9n 0.85000 115700.0n 0.85000 115829.9n 0.85000 115830.0n 0.85000 115959.9n 0.85000 115960.0n 0.85000 116089.9n 0.85000 116090.0n 0.85000 116219.9n 0.85000 116220.0n 0.85000 116349.9n 0.85000 116350.0n 0.85000 116479.9n 0.85000 116480.0n 0.85000 116609.9n 0.85000 116610.0n 0.85000 116739.9n 0.85000 116740.0n 0.85000 116869.9n 0.85000 116870.0n 0.85000 116999.9n 0.85000 117000.0n 0.85000 117129.9n 0.85000 117130.0n 0.85000 117259.9n 0.85000 117260.0n 0.85000 117389.9n 0.85000 117390.0n 0.85000 117519.9n 0.85000 117520.0n 0.85000 117649.9n 0.85000 117650.0n 0.85000 117779.9n 0.85000 117780.0n 0.85000 117909.9n 0.85000 117910.0n 0.85000 118039.9n 0.85000 118040.0n 0.85000 118169.9n 0.85000 118170.0n 0.85000 118299.9n 0.85000 118300.0n 0.85000 118429.9n 0.85000 118430.0n 0.85000 118559.9n 0.85000 118560.0n 0.85000 118689.9n 0.85000 118690.0n 0.85000 118819.9n 0.85000 118820.0n 0.85000 118949.9n 0.85000 118950.0n 0.85000 119079.9n 0.85000 119080.0n 0.85000 119209.9n 0.85000 119210.0n 0.85000 119339.9n 0.85000 119340.0n 0.85000 119469.9n 0.85000 119470.0n 0.85000 119599.9n 0.85000 119600.0n 0.85000 119729.9n 0.85000 119730.0n 0.85000 119859.9n 0.85000 119860.0n 0.85000 119989.9n 0.85000 119990.0n 0.85000 120119.9n 0.85000 120120.0n 0.85000 120249.9n 0.85000 120250.0n 0.85000 120379.9n 0.85000 120380.0n 0.85000 120509.9n 0.85000 120510.0n 0.85000 120639.9n 0.85000 120640.0n 0.85000 120769.9n 0.85000 120770.0n 0.85000 120899.9n 0.85000 120900.0n 0.85000 121029.9n 0.85000 121030.0n 0.85000 121159.9n 0.85000 121160.0n 0.85000 121289.9n 0.85000 121290.0n 0.85000 121419.9n 0.85000 121420.0n 0.85000 121549.9n 0.85000 121550.0n 0.85000 121679.9n 0.85000 121680.0n 0.85000 121809.9n 0.85000 121810.0n 0.85000 121939.9n 0.85000 121940.0n 0.85000 122069.9n 0.85000 122070.0n 0.85000 122199.9n 0.85000 122200.0n 0.85000 122329.9n 0.85000 122330.0n 0.85000 122459.9n 0.85000 122460.0n 0.85000 122589.9n 0.85000 122590.0n 0.85000 122719.9n 0.85000 122720.0n 0.85000 122849.9n 0.85000 122850.0n 0.85000 122979.9n 0.85000 122980.0n 0.85000 123109.9n 0.85000 123110.0n 0.85000 123239.9n 0.85000 123240.0n 0.85000 123369.9n 0.85000 123370.0n 0.85000 123499.9n 0.85000 123500.0n 0.85000 123629.9n 0.85000 123630.0n 0.85000 123759.9n 0.85000 123760.0n 0.85000 123889.9n 0.85000 123890.0n 0.85000 124019.9n 0.85000 124020.0n 0.85000 124149.9n 0.85000 124150.0n 0.85000 124279.9n 0.85000 124280.0n 0.85000 124409.9n 0.85000 124410.0n 0.85000 124539.9n 0.85000 124540.0n 0.85000 124669.9n 0.85000 124670.0n 0.85000 124799.9n 0.85000 124800.0n 0.85000 124929.9n 0.85000 124930.0n 0.85000 125059.9n 0.85000 125060.0n 0.85000 125189.9n 0.85000 125190.0n 0.85000 125319.9n 0.85000 125320.0n 0.85000 125449.9n 0.85000 125450.0n 0.85000 125579.9n 0.85000 125580.0n 0.85000 125709.9n 0.85000 125710.0n 0.85000 125839.9n 0.85000 125840.0n 0.85000 125969.9n 0.85000 125970.0n 0.85000 126099.9n 0.85000 126100.0n 0.85000 126229.9n 0.85000 126230.0n 0.85000 126359.9n 0.85000 126360.0n 0.85000 126489.9n 0.85000 126490.0n 0.85000 126619.9n 0.85000 126620.0n 0.85000 126749.9n 0.85000 126750.0n 0.85000 126879.9n 0.85000 126880.0n 0.85000 127009.9n 0.85000 127010.0n 0.85000 127139.9n 0.85000 127140.0n 0.85000 127269.9n 0.85000 127270.0n 0.85000 127399.9n 0.85000 127400.0n 0.85000 127529.9n 0.85000 127530.0n 0.85000 127659.9n 0.85000 127660.0n 0.85000 127789.9n 0.85000 127790.0n 0.85000 127919.9n 0.85000 127920.0n 0.85000 128049.9n 0.85000 128050.0n 0.85000 128179.9n 0.85000 128180.0n 0.85000 128309.9n 0.85000 128310.0n 0.85000 128439.9n 0.85000 128440.0n 0.85000 128569.9n 0.85000 128570.0n 0.85000 128699.9n 0.85000 128700.0n 0.85000 128829.9n 0.85000 128830.0n 0.85000 128959.9n 0.85000 128960.0n 0.85000 129089.9n 0.85000 129090.0n 0.85000 129219.9n 0.85000 129220.0n 0.85000 129349.9n 0.85000 129350.0n 0.85000 129479.9n 0.85000 129480.0n 0.85000 129609.9n 0.85000 129610.0n 0.85000 129739.9n 0.85000 129740.0n 0.85000 129869.9n 0.85000 129870.0n 0.85000 129999.9n 0.85000 130000.0n 0.85000 130129.9n 0.85000 130130.0n 0.85000 130259.9n 0.85000 130260.0n 0.85000 130389.9n 0.85000 130390.0n 0.85000 130519.9n 0.85000 130520.0n 0.85000 130649.9n 0.85000 130650.0n 0.85000 130779.9n 0.85000 130780.0n 0.85000 130909.9n 0.85000 130910.0n 0.85000 131039.9n 0.85000 131040.0n 0.85000 131169.9n 0.85000 131170.0n 0.85000 131299.9n 0.85000 131300.0n 0.85000 131429.9n 0.85000 131430.0n 0.85000 131559.9n 0.85000 131560.0n 0.85000 131689.9n 0.85000 131690.0n 0.85000 131819.9n 0.85000 131820.0n 0.85000 131949.9n 0.85000 131950.0n 0.85000 132079.9n 0.85000 132080.0n 0.85000 132209.9n 0.85000 132210.0n 0.85000 132339.9n 0.85000 132340.0n 0.85000 132469.9n 0.85000 132470.0n 0.85000 132599.9n 0.85000 132600.0n 0.85000 132729.9n 0.85000 132730.0n 0.85000 132859.9n 0.85000 132860.0n 0.85000 132989.9n 0.85000 132990.0n 0.85000 133119.9n 0.85000 133120.0n 0.85000 133249.9n 0.85000 133250.0n 0.85000 133379.9n 0.85000 133380.0n 0.85000 133509.9n 0.85000 133510.0n 0.85000 133639.9n 0.85000 133640.0n 0.85000 133769.9n 0.85000 133770.0n 0.85000 133899.9n 0.85000 133900.0n 0.85000 134029.9n 0.85000 134030.0n 0.85000 134159.9n 0.85000 134160.0n 0.00000 134289.9n 0.00000 134290.0n 0.00000 134419.9n 0.00000 134420.0n 0.00000 134549.9n 0.00000 134550.0n 0.00000 134679.9n 0.00000 134680.0n 0.00000 134809.9n 0.00000 134810.0n 0.00000 134939.9n 0.00000 134940.0n 0.00000 135069.9n 0.00000 135070.0n 0.00000 135199.9n 0.00000 135200.0n 0.00000 135329.9n 0.00000 135330.0n 0.00000 135459.9n 0.00000 135460.0n 0.00000 135589.9n 0.00000 135590.0n 0.00000 135719.9n 0.00000 135720.0n 0.00000 135849.9n 0.00000 135850.0n 0.00000 135979.9n 0.00000 135980.0n 0.00000 136109.9n 0.00000 136110.0n 0.00000 136239.9n 0.00000 136240.0n 0.00000 136369.9n 0.00000 136370.0n 0.00000 136499.9n 0.00000 136500.0n 0.00000 136629.9n 0.00000 136630.0n 0.00000 136759.9n 0.00000 136760.0n 0.00000 136889.9n 0.00000 136890.0n 0.00000 137019.9n 0.00000 137020.0n 0.00000 137149.9n 0.00000 137150.0n 0.00000 137279.9n 0.00000 137280.0n 0.00000 137409.9n 0.00000 137410.0n 0.00000 137539.9n 0.00000 137540.0n 0.00000 137669.9n 0.00000 137670.0n 0.00000 137799.9n 0.00000 137800.0n 0.00000 137929.9n 0.00000 137930.0n 0.00000 138059.9n 0.00000 138060.0n 0.00000 138189.9n 0.00000 138190.0n 0.00000 138319.9n 0.00000 138320.0n 0.00000 138449.9n 0.00000 138450.0n 0.00000 138579.9n 0.00000 138580.0n 0.00000 138709.9n 0.00000 138710.0n 0.00000 138839.9n 0.00000 138840.0n 0.00000 138969.9n 0.00000 138970.0n 0.00000 139099.9n 0.00000 139100.0n 0.00000 139229.9n 0.00000 139230.0n 0.00000 139359.9n 0.00000 139360.0n 0.00000 139489.9n 0.00000 139490.0n 0.00000 139619.9n 0.00000 139620.0n 0.00000 139749.9n 0.00000 139750.0n 0.00000 139879.9n 0.00000 139880.0n 0.00000 140009.9n 0.00000 140010.0n 0.00000 140139.9n 0.00000 140140.0n 0.00000 140269.9n 0.00000 140270.0n 0.00000 140399.9n 0.00000 140400.0n 0.85000 140529.9n 0.85000 140530.0n 0.85000 140659.9n 0.85000 140660.0n 0.85000 140789.9n 0.85000 140790.0n 0.85000 140919.9n 0.85000 140920.0n 0.85000 141049.9n 0.85000 141050.0n 0.85000 141179.9n 0.85000 141180.0n 0.85000 141309.9n 0.85000 141310.0n 0.85000 141439.9n 0.85000 141440.0n 0.85000 141569.9n 0.85000 141570.0n 0.85000 141699.9n 0.85000 141700.0n 0.85000 141829.9n 0.85000 141830.0n 0.85000 141959.9n 0.85000 141960.0n 0.85000 142089.9n 0.85000 142090.0n 0.85000 142219.9n 0.85000 142220.0n 0.85000 142349.9n 0.85000 142350.0n 0.85000 142479.9n 0.85000 142480.0n 0.85000 142609.9n 0.85000 142610.0n 0.85000 142739.9n 0.85000 142740.0n 0.85000 142869.9n 0.85000 142870.0n 0.85000 142999.9n 0.85000 143000.0n 0.85000 143129.9n 0.85000 143130.0n 0.85000 143259.9n 0.85000 143260.0n 0.85000 143389.9n 0.85000 143390.0n 0.85000 143519.9n 0.85000 143520.0n 0.85000 143649.9n 0.85000 143650.0n 0.85000 143779.9n 0.85000 143780.0n 0.85000 143909.9n 0.85000 143910.0n 0.85000 144039.9n 0.85000 144040.0n 0.85000 144169.9n 0.85000 144170.0n 0.85000 144299.9n 0.85000 144300.0n 0.85000 144429.9n 0.85000 144430.0n 0.85000 144559.9n 0.85000 144560.0n 0.85000 144689.9n 0.85000 144690.0n 0.85000 144819.9n 0.85000 144820.0n 0.85000 144949.9n 0.85000 144950.0n 0.85000 145079.9n 0.85000 145080.0n 0.85000 145209.9n 0.85000 145210.0n 0.85000 145339.9n 0.85000 145340.0n 0.85000 145469.9n 0.85000 145470.0n 0.85000 145599.9n 0.85000 145600.0n 0.85000 145729.9n 0.85000 145730.0n 0.85000 145859.9n 0.85000 145860.0n 0.85000 145989.9n 0.85000 145990.0n 0.85000 146119.9n 0.85000 146120.0n 0.85000 146249.9n 0.85000 146250.0n 0.85000 146379.9n 0.85000 146380.0n 0.85000 146509.9n 0.85000 146510.0n 0.85000 146639.9n 0.85000 146640.0n 0.85000 146769.9n 0.85000 146770.0n 0.85000 146899.9n 0.85000 146900.0n 0.85000 147029.9n 0.85000 147030.0n 0.85000 147159.9n 0.85000 147160.0n 0.85000 147289.9n 0.85000 147290.0n 0.85000 147419.9n 0.85000 147420.0n 0.85000 147549.9n 0.85000 147550.0n 0.85000 147679.9n 0.85000 147680.0n 0.85000 147809.9n 0.85000 147810.0n 0.85000 147939.9n 0.85000 147940.0n 0.85000 148069.9n 0.85000 148070.0n 0.85000 148199.9n 0.85000 148200.0n 0.85000 148329.9n 0.85000 148330.0n 0.85000 148459.9n 0.85000 148460.0n 0.85000 148589.9n 0.85000 148590.0n 0.85000 148719.9n 0.85000 148720.0n 0.85000 148849.9n 0.85000 148850.0n 0.85000 148979.9n 0.85000 148980.0n 0.85000 149109.9n 0.85000 149110.0n 0.85000 149239.9n 0.85000 149240.0n 0.85000 149369.9n 0.85000 149370.0n 0.85000 149499.9n 0.85000 149500.0n 0.85000 149629.9n 0.85000 149630.0n 0.85000 149759.9n 0.85000 149760.0n 0.85000 149889.9n 0.85000 149890.0n 0.85000 150019.9n 0.85000 150020.0n 0.85000 150149.9n 0.85000 150150.0n 0.85000 150279.9n 0.85000 150280.0n 0.85000 150409.9n 0.85000 150410.0n 0.85000 150539.9n 0.85000 150540.0n 0.85000 150669.9n 0.85000 150670.0n 0.85000 150799.9n 0.85000 150800.0n 0.85000 150929.9n 0.85000 150930.0n 0.85000 151059.9n 0.85000 151060.0n 0.85000 151189.9n 0.85000 151190.0n 0.85000 151319.9n 0.85000 151320.0n 0.85000 151449.9n 0.85000 151450.0n 0.85000 151579.9n 0.85000 151580.0n 0.85000 151709.9n 0.85000 151710.0n 0.85000 151839.9n 0.85000 151840.0n 0.85000 151969.9n 0.85000 151970.0n 0.85000 152099.9n 0.85000 152100.0n 0.85000 152229.9n 0.85000 152230.0n 0.85000 152359.9n 0.85000 152360.0n 0.85000 152489.9n 0.85000 152490.0n 0.85000 152619.9n 0.85000 152620.0n 0.85000 152749.9n 0.85000 152750.0n 0.85000 152879.9n 0.85000 152880.0n 0.85000 153009.9n 0.85000 153010.0n 0.85000 153139.9n 0.85000 153140.0n 0.85000 153269.9n 0.85000 153270.0n 0.85000 153399.9n 0.85000 153400.0n 0.85000 153529.9n 0.85000 153530.0n 0.85000 153659.9n 0.85000 153660.0n 0.85000 153789.9n 0.85000 153790.0n 0.85000 153919.9n 0.85000 153920.0n 0.85000 154049.9n 0.85000 154050.0n 0.85000 154179.9n 0.85000 154180.0n 0.85000 154309.9n 0.85000 154310.0n 0.85000 154439.9n 0.85000 154440.0n 0.85000 154569.9n 0.85000 154570.0n 0.85000 154699.9n 0.85000 154700.0n 0.85000 154829.9n 0.85000 154830.0n 0.85000 154959.9n 0.85000 154960.0n 0.85000 155089.9n 0.85000 155090.0n 0.85000 155219.9n 0.85000 155220.0n 0.85000 155349.9n 0.85000 155350.0n 0.85000 155479.9n 0.85000 155480.0n 0.85000 155609.9n 0.85000 155610.0n 0.85000 155739.9n 0.85000 155740.0n 0.85000 155869.9n 0.85000 155870.0n 0.85000 155999.9n 0.85000 156000.0n 0.85000 156129.9n 0.85000 156130.0n 0.85000 156259.9n 0.85000 156260.0n 0.85000 156389.9n 0.85000 156390.0n 0.85000 156519.9n 0.85000 156520.0n 0.85000 156649.9n 0.85000 156650.0n 0.85000 156779.9n 0.85000 156780.0n 0.85000 156909.9n 0.85000 156910.0n 0.85000 157039.9n 0.85000 157040.0n 0.85000 157169.9n 0.85000 157170.0n 0.85000 157299.9n 0.85000 157300.0n 0.85000 157429.9n 0.85000 157430.0n 0.85000 157559.9n 0.85000 157560.0n 0.85000 157689.9n 0.85000 157690.0n 0.85000 157819.9n 0.85000 157820.0n 0.85000 157949.9n 0.85000 157950.0n 0.85000 158079.9n 0.85000 158080.0n 0.85000 158209.9n 0.85000 158210.0n 0.85000 158339.9n 0.85000 158340.0n 0.85000 158469.9n 0.85000 158470.0n 0.85000 158599.9n 0.85000 158600.0n 0.85000 158729.9n 0.85000 158730.0n 0.85000 158859.9n 0.85000 158860.0n 0.85000 158989.9n 0.85000 158990.0n 0.85000 159119.9n 0.85000 159120.0n 0.85000 159249.9n 0.85000 159250.0n 0.85000 159379.9n 0.85000 159380.0n 0.85000 159509.9n 0.85000 159510.0n 0.85000 159639.9n 0.85000 159640.0n 0.85000 159769.9n 0.85000 159770.0n 0.85000 159899.9n 0.85000 159900.0n 0.85000 160029.9n 0.85000 160030.0n 0.85000 160159.9n 0.85000 160160.0n 0.85000 160289.9n 0.85000 160290.0n 0.85000 160419.9n 0.85000 160420.0n 0.85000 160549.9n 0.85000 160550.0n 0.85000 160679.9n 0.85000 160680.0n 0.85000 160809.9n 0.85000 160810.0n 0.85000 160939.9n 0.85000 160940.0n 0.85000 161069.9n 0.85000 161070.0n 0.85000 161199.9n 0.85000 161200.0n 0.85000 161329.9n 0.85000 161330.0n 0.85000 161459.9n 0.85000 161460.0n 0.85000 161589.9n 0.85000 161590.0n 0.85000 161719.9n 0.85000 161720.0n 0.85000 161849.9n 0.85000 161850.0n 0.85000 161979.9n 0.85000 161980.0n 0.85000 162109.9n 0.85000 162110.0n 0.85000 162239.9n 0.85000 162240.0n 0.00000 162369.9n 0.00000 162370.0n 0.00000 162499.9n 0.00000 162500.0n 0.00000 162629.9n 0.00000 162630.0n 0.00000 162759.9n 0.00000 162760.0n 0.00000 162889.9n 0.00000 162890.0n 0.00000 163019.9n 0.00000 163020.0n 0.00000 163149.9n 0.00000 163150.0n 0.00000 163279.9n 0.00000 163280.0n 0.00000 163409.9n 0.00000 163410.0n 0.00000 163539.9n 0.00000 163540.0n 0.00000 163669.9n 0.00000 163670.0n 0.00000 163799.9n 0.00000 163800.0n 0.00000 163929.9n 0.00000 163930.0n 0.00000 164059.9n 0.00000 164060.0n 0.00000 164189.9n 0.00000 164190.0n 0.00000 164319.9n 0.00000 164320.0n 0.00000 164449.9n 0.00000 164450.0n 0.00000 164579.9n 0.00000 164580.0n 0.00000 164709.9n 0.00000 164710.0n 0.00000 164839.9n 0.00000 164840.0n 0.00000 164969.9n 0.00000 164970.0n 0.00000 165099.9n 0.00000 165100.0n 0.00000 165229.9n 0.00000 165230.0n 0.00000 165359.9n 0.00000 165360.0n 0.00000 165489.9n 0.00000 165490.0n 0.00000 165619.9n 0.00000 165620.0n 0.00000 165749.9n 0.00000 165750.0n 0.00000 165879.9n 0.00000 165880.0n 0.00000 166009.9n 0.00000 166010.0n 0.00000 166139.9n 0.00000 166140.0n 0.00000 166269.9n 0.00000 166270.0n 0.00000 166399.9n 0.00000 166400.0n 0.00000 166529.9n 0.00000 166530.0n 0.00000 166659.9n 0.00000 166660.0n 0.00000 166789.9n 0.00000 166790.0n 0.00000 166919.9n 0.00000 166920.0n 0.00000 167049.9n 0.00000 167050.0n 0.00000 167179.9n 0.00000 167180.0n 0.00000 167309.9n 0.00000 167310.0n 0.00000 167439.9n 0.00000 167440.0n 0.00000 167569.9n 0.00000 167570.0n 0.00000 167699.9n 0.00000 167700.0n 0.00000 167829.9n 0.00000 167830.0n 0.00000 167959.9n 0.00000 167960.0n 0.00000 168089.9n 0.00000 168090.0n 0.00000 168219.9n 0.00000 168220.0n 0.00000 168349.9n 0.00000 168350.0n 0.00000)
Vxp0 a_xp0 0 PWL(0.0n 0.69969 129.9n 0.69969 130.0n 0.56449 259.9n 0.56449 260.0n 0.52079 389.9n 0.52079 390.0n 0.69502 519.9n 0.69502 520.0n 0.24079 649.9n 0.24079 650.0n 0.17082 779.9n 0.17082 780.0n 0.10559 909.9n 0.10559 910.0n 0.27076 1039.9n 0.27076 1040.0n -0.14927 1169.9n -0.14927 1170.0n 0.27643 1299.9n 0.27643 1300.0n 0.53141 1429.9n 0.53141 1430.0n 0.70685 1559.9n 0.70685 1560.0n 0.31139 1689.9n 0.31139 1690.0n 0.20119 1819.9n 0.20119 1820.0n 1.36668 1949.9n 1.36668 1950.0n 0.21498 2079.9n 0.21498 2080.0n 0.55006 2209.9n 0.55006 2210.0n 0.96459 2339.9n 0.96459 2340.0n 0.55066 2469.9n 0.55066 2470.0n 0.26419 2599.9n 0.26419 2600.0n -0.31038 2729.9n -0.31038 2730.0n 0.73600 2859.9n 0.73600 2860.0n 0.47556 2989.9n 0.47556 2990.0n -0.04662 3119.9n -0.04662 3120.0n 0.43581 3249.9n 0.43581 3250.0n 0.35630 3379.9n 0.35630 3380.0n 1.07007 3509.9n 1.07007 3510.0n 0.88832 3639.9n 0.88832 3640.0n 0.21498 3769.9n 0.21498 3770.0n 0.10559 3899.9n 0.10559 3900.0n 0.27643 4029.9n 0.27643 4030.0n -0.31038 4159.9n -0.31038 4160.0n 0.24079 4289.9n 0.24079 4290.0n 1.36668 4419.9n 1.36668 4420.0n 0.47556 4549.9n 0.47556 4550.0n 0.88832 4679.9n 0.88832 4680.0n 0.27076 4809.9n 0.27076 4810.0n 0.55006 4939.9n 0.55006 4940.0n 0.55066 5069.9n 0.55066 5070.0n 0.31139 5199.9n 0.31139 5200.0n 0.52079 5329.9n 0.52079 5330.0n 0.69502 5459.9n 0.69502 5460.0n 0.56449 5589.9n 0.56449 5590.0n 0.35630 5719.9n 0.35630 5720.0n 0.53141 5849.9n 0.53141 5850.0n 1.07007 5979.9n 1.07007 5980.0n 0.26419 6109.9n 0.26419 6110.0n -0.04662 6239.9n -0.04662 6240.0n -0.14927 6369.9n -0.14927 6370.0n 0.43581 6499.9n 0.43581 6500.0n 0.20119 6629.9n 0.20119 6630.0n 0.70685 6759.9n 0.70685 6760.0n 0.73600 6889.9n 0.73600 6890.0n 0.96459 7019.9n 0.96459 7020.0n 0.17082 7149.9n 0.17082 7150.0n 0.69969 7279.9n 0.69969 7280.0n 0.73600 7409.9n 0.73600 7410.0n 0.56449 7539.9n 0.56449 7540.0n -0.04662 7669.9n -0.04662 7670.0n 0.21498 7799.9n 0.21498 7800.0n 0.52079 7929.9n 0.52079 7930.0n -0.31038 8059.9n -0.31038 8060.0n 0.26419 8189.9n 0.26419 8190.0n 0.31139 8319.9n 0.31139 8320.0n 0.47556 8449.9n 0.47556 8450.0n 0.27643 8579.9n 0.27643 8580.0n 0.35630 8709.9n 0.35630 8710.0n 0.69969 8839.9n 0.69969 8840.0n 0.55006 8969.9n 0.55006 8970.0n 0.27076 9099.9n 0.27076 9100.0n 0.88832 9229.9n 0.88832 9230.0n 0.24079 9359.9n 0.24079 9360.0n 0.17082 9489.9n 0.17082 9490.0n 1.07007 9619.9n 1.07007 9620.0n 0.43581 9749.9n 0.43581 9750.0n 1.36668 9879.9n 1.36668 9880.0n 0.70685 10009.9n 0.70685 10010.0n 0.69502 10139.9n 0.69502 10140.0n 0.20119 10269.9n 0.20119 10270.0n 0.53141 10399.9n 0.53141 10400.0n 0.10559 10529.9n 0.10559 10530.0n 0.96459 10659.9n 0.96459 10660.0n -0.14927 10789.9n -0.14927 10790.0n 0.55066 10919.9n 0.55066 10920.0n 1.36668 11049.9n 1.36668 11050.0n 0.21498 11179.9n 0.21498 11180.0n 0.20119 11309.9n 0.20119 11310.0n -0.31038 11439.9n -0.31038 11440.0n 0.88832 11569.9n 0.88832 11570.0n 0.73600 11699.9n 0.73600 11700.0n -0.04662 11829.9n -0.04662 11830.0n 0.10559 11959.9n 0.10559 11960.0n 0.24079 12089.9n 0.24079 12090.0n 0.27076 12219.9n 0.27076 12220.0n 0.47556 12349.9n 0.47556 12350.0n 0.56449 12479.9n 0.56449 12480.0n 0.69969 12609.9n 0.69969 12610.0n 0.26419 12739.9n 0.26419 12740.0n -0.14927 12869.9n -0.14927 12870.0n 1.07007 12999.9n 1.07007 13000.0n 0.69502 13129.9n 0.69502 13130.0n 0.55006 13259.9n 0.55006 13260.0n 0.52079 13389.9n 0.52079 13390.0n 0.96459 13519.9n 0.96459 13520.0n 0.70685 13649.9n 0.70685 13650.0n 0.43581 13779.9n 0.43581 13780.0n 0.17082 13909.9n 0.17082 13910.0n 0.31139 14039.9n 0.31139 14040.0n 0.27643 14169.9n 0.27643 14170.0n 0.55066 14299.9n 0.55066 14300.0n 0.53141 14429.9n 0.53141 14430.0n 0.35630 14559.9n 0.35630 14560.0n -0.04662 14689.9n -0.04662 14690.0n 0.55006 14819.9n 0.55006 14820.0n -0.14927 14949.9n -0.14927 14950.0n 0.69969 15079.9n 0.69969 15080.0n 0.69502 15209.9n 0.69502 15210.0n 0.53141 15339.9n 0.53141 15340.0n 0.70685 15469.9n 0.70685 15470.0n 0.43581 15599.9n 0.43581 15600.0n 0.17082 15729.9n 0.17082 15730.0n 0.27076 15859.9n 0.27076 15860.0n 0.88832 15989.9n 0.88832 15990.0n 0.55066 16119.9n 0.55066 16120.0n 0.35630 16249.9n 0.35630 16250.0n 1.36668 16379.9n 1.36668 16380.0n 0.26419 16509.9n 0.26419 16510.0n 0.31139 16639.9n 0.31139 16640.0n 0.10559 16769.9n 0.10559 16770.0n 0.20119 16899.9n 0.20119 16900.0n 0.27643 17029.9n 0.27643 17030.0n 0.21498 17159.9n 0.21498 17160.0n 0.73600 17289.9n 0.73600 17290.0n 0.47556 17419.9n 0.47556 17420.0n 0.56449 17549.9n 0.56449 17550.0n 1.07007 17679.9n 1.07007 17680.0n -0.31038 17809.9n -0.31038 17810.0n 0.96459 17939.9n 0.96459 17940.0n 0.52079 18069.9n 0.52079 18070.0n 0.24079 18199.9n 0.24079 18200.0n 0.53141 18329.9n 0.53141 18330.0n 0.69969 18459.9n 0.69969 18460.0n 0.55066 18589.9n 0.55066 18590.0n 0.70685 18719.9n 0.70685 18720.0n 0.24079 18849.9n 0.24079 18850.0n 0.35630 18979.9n 0.35630 18980.0n 0.43581 19109.9n 0.43581 19110.0n -0.04662 19239.9n -0.04662 19240.0n 0.47556 19369.9n 0.47556 19370.0n 0.96459 19499.9n 0.96459 19500.0n 1.07007 19629.9n 1.07007 19630.0n 0.20119 19759.9n 0.20119 19760.0n -0.31038 19889.9n -0.31038 19890.0n 0.52079 20019.9n 0.52079 20020.0n 0.26419 20149.9n 0.26419 20150.0n 0.55006 20279.9n 0.55006 20280.0n 1.36668 20409.9n 1.36668 20410.0n 0.73600 20539.9n 0.73600 20540.0n 0.21498 20669.9n 0.21498 20670.0n 0.56449 20799.9n 0.56449 20800.0n 0.10559 20929.9n 0.10559 20930.0n 0.27643 21059.9n 0.27643 21060.0n 0.17082 21189.9n 0.17082 21190.0n 0.88832 21319.9n 0.88832 21320.0n 0.69502 21449.9n 0.69502 21450.0n 0.27076 21579.9n 0.27076 21580.0n -0.14927 21709.9n -0.14927 21710.0n 0.31139 21839.9n 0.31139 21840.0n 0.48508 21969.9n 0.48508 21970.0n 0.86030 22099.9n 0.86030 22100.0n 0.57742 22229.9n 0.57742 22230.0n 0.79287 22359.9n 0.79287 22360.0n 0.60090 22489.9n 0.60090 22490.0n 0.23371 22619.9n 0.23371 22620.0n 0.12484 22749.9n 0.12484 22750.0n 0.48351 22879.9n 0.48351 22880.0n 0.52272 23009.9n 0.52272 23010.0n 0.10421 23139.9n 0.10421 23140.0n 0.26187 23269.9n 0.26187 23270.0n 0.26993 23399.9n 0.26993 23400.0n 0.61195 23529.9n 0.61195 23530.0n 0.55435 23659.9n 0.55435 23660.0n 0.15028 23789.9n 0.15028 23790.0n 0.68626 23919.9n 0.68626 23920.0n 0.46500 24049.9n 0.46500 24050.0n 0.34619 24179.9n 0.34619 24180.0n 0.41172 24309.9n 0.41172 24310.0n 0.70707 24439.9n 0.70707 24440.0n 0.65136 24569.9n 0.65136 24570.0n 0.60081 24699.9n 0.60081 24700.0n 0.71496 24829.9n 0.71496 24830.0n 0.09082 24959.9n 0.09082 24960.0n 1.38855 25089.9n 1.38855 25090.0n 1.21890 25219.9n 1.21890 25220.0n 1.28851 25349.9n 1.28851 25350.0n 1.24585 25479.9n 1.24585 25480.0n -0.15208 25609.9n -0.15208 25610.0n 0.58159 25739.9n 0.58159 25740.0n 0.75662 25869.9n 0.75662 25870.0n -0.49277 25999.9n -0.49277 26000.0n -0.19260 26129.9n -0.19260 26130.0n 1.27962 26259.9n 1.27962 26260.0n 0.44267 26389.9n 0.44267 26390.0n 0.04400 26519.9n 0.04400 26520.0n 1.04710 26649.9n 1.04710 26650.0n 0.19758 26779.9n 0.19758 26780.0n 0.60264 26909.9n 0.60264 26910.0n -0.04029 27039.9n -0.04029 27040.0n 0.36851 27169.9n 0.36851 27170.0n 0.18248 27299.9n 0.18248 27300.0n -0.19808 27429.9n -0.19808 27430.0n -0.39872 27559.9n -0.39872 27560.0n 0.71881 27689.9n 0.71881 27690.0n -0.46004 27819.9n -0.46004 27820.0n 1.19303 27949.9n 1.19303 27950.0n 0.06458 28079.9n 0.06458 28080.0n 0.70685 28209.9n 0.70685 28210.0n 0.69502 28339.9n 0.69502 28340.0n -0.04662 28469.9n -0.04662 28470.0n 0.96459 28599.9n 0.96459 28600.0n 1.07007 28729.9n 1.07007 28730.0n 0.35630 28859.9n 0.35630 28860.0n 0.69969 28989.9n 0.69969 28990.0n 0.27076 29119.9n 0.27076 29120.0n 0.20119 29249.9n 0.20119 29250.0n 0.53141 29379.9n 0.53141 29380.0n 0.88832 29509.9n 0.88832 29510.0n 0.52079 29639.9n 0.52079 29640.0n 0.27643 29769.9n 0.27643 29770.0n -0.31038 29899.9n -0.31038 29900.0n 0.31139 30029.9n 0.31139 30030.0n 0.10559 30159.9n 0.10559 30160.0n 0.47556 30289.9n 0.47556 30290.0n -0.14927 30419.9n -0.14927 30420.0n 0.26419 30549.9n 0.26419 30550.0n 0.55006 30679.9n 0.55006 30680.0n 0.73600 30809.9n 0.73600 30810.0n 0.55066 30939.9n 0.55066 30940.0n 0.43581 31069.9n 0.43581 31070.0n 0.56449 31199.9n 0.56449 31200.0n 0.24079 31329.9n 0.24079 31330.0n 1.36668 31459.9n 1.36668 31460.0n 0.21498 31589.9n 0.21498 31590.0n 0.17082 31719.9n 0.17082 31720.0n 0.10559 31849.9n 0.10559 31850.0n 0.17082 31979.9n 0.17082 31980.0n 0.69502 32109.9n 0.69502 32110.0n 0.31139 32239.9n 0.31139 32240.0n 0.55006 32369.9n 0.55006 32370.0n 0.52079 32499.9n 0.52079 32500.0n 0.69969 32629.9n 0.69969 32630.0n 0.88832 32759.9n 0.88832 32760.0n 0.96459 32889.9n 0.96459 32890.0n 0.35630 33019.9n 0.35630 33020.0n 0.53141 33149.9n 0.53141 33150.0n 1.07007 33279.9n 1.07007 33280.0n 0.27076 33409.9n 0.27076 33410.0n -0.14927 33539.9n -0.14927 33540.0n 0.20119 33669.9n 0.20119 33670.0n -0.04662 33799.9n -0.04662 33800.0n 0.70685 33929.9n 0.70685 33930.0n 0.47556 34059.9n 0.47556 34060.0n 0.21498 34189.9n 0.21498 34190.0n 0.43581 34319.9n 0.43581 34320.0n 0.73600 34449.9n 0.73600 34450.0n 0.27643 34579.9n 0.27643 34580.0n 0.56449 34709.9n 0.56449 34710.0n 0.55066 34839.9n 0.55066 34840.0n 1.36668 34969.9n 1.36668 34970.0n -0.31038 35099.9n -0.31038 35100.0n 0.26419 35229.9n 0.26419 35230.0n 0.24079 35359.9n 0.24079 35360.0n 1.07007 35489.9n 1.07007 35490.0n 0.55066 35619.9n 0.55066 35620.0n 0.47556 35749.9n 0.47556 35750.0n -0.04662 35879.9n -0.04662 35880.0n 0.52079 36009.9n 0.52079 36010.0n 0.10559 36139.9n 0.10559 36140.0n 0.27076 36269.9n 0.27076 36270.0n 0.73600 36399.9n 0.73600 36400.0n 0.21498 36529.9n 0.21498 36530.0n 0.56449 36659.9n 0.56449 36660.0n 0.96459 36789.9n 0.96459 36790.0n 0.69969 36919.9n 0.69969 36920.0n 1.36668 37049.9n 1.36668 37050.0n 0.53141 37179.9n 0.53141 37180.0n 0.26419 37309.9n 0.26419 37310.0n 0.88832 37439.9n 0.88832 37440.0n 0.55006 37569.9n 0.55006 37570.0n 0.24079 37699.9n 0.24079 37700.0n 0.70685 37829.9n 0.70685 37830.0n 0.35630 37959.9n 0.35630 37960.0n 0.69502 38089.9n 0.69502 38090.0n 0.43581 38219.9n 0.43581 38220.0n 0.20119 38349.9n 0.20119 38350.0n -0.31038 38479.9n -0.31038 38480.0n -0.14927 38609.9n -0.14927 38610.0n 0.17082 38739.9n 0.17082 38740.0n 0.27643 38869.9n 0.27643 38870.0n 0.31139 38999.9n 0.31139 39000.0n 0.53141 39129.9n 0.53141 39130.0n 0.73600 39259.9n 0.73600 39260.0n 0.31139 39389.9n 0.31139 39390.0n 0.24079 39519.9n 0.24079 39520.0n 0.88832 39649.9n 0.88832 39650.0n 0.56449 39779.9n 0.56449 39780.0n 0.27076 39909.9n 0.27076 39910.0n 0.10559 40039.9n 0.10559 40040.0n 0.27643 40169.9n 0.27643 40170.0n 0.20119 40299.9n 0.20119 40300.0n 0.70685 40429.9n 0.70685 40430.0n 0.55066 40559.9n 0.55066 40560.0n -0.04662 40689.9n -0.04662 40690.0n 1.36668 40819.9n 1.36668 40820.0n 0.55006 40949.9n 0.55006 40950.0n 0.47556 41079.9n 0.47556 41080.0n 1.07007 41209.9n 1.07007 41210.0n 0.26419 41339.9n 0.26419 41340.0n 0.21498 41469.9n 0.21498 41470.0n 0.69502 41599.9n 0.69502 41600.0n -0.14927 41729.9n -0.14927 41730.0n -0.31038 41859.9n -0.31038 41860.0n 0.96459 41989.9n 0.96459 41990.0n 0.52079 42119.9n 0.52079 42120.0n 0.17082 42249.9n 0.17082 42250.0n 0.35630 42379.9n 0.35630 42380.0n 0.43581 42509.9n 0.43581 42510.0n 0.69969 42639.9n 0.69969 42640.0n 0.26419 42769.9n 0.26419 42770.0n 0.73600 42899.9n 0.73600 42900.0n 0.31139 43029.9n 0.31139 43030.0n 0.27643 43159.9n 0.27643 43160.0n 0.55006 43289.9n 0.55006 43290.0n 1.36668 43419.9n 1.36668 43420.0n -0.04662 43549.9n -0.04662 43550.0n 0.47556 43679.9n 0.47556 43680.0n -0.14927 43809.9n -0.14927 43810.0n 0.27076 43939.9n 0.27076 43940.0n 0.43581 44069.9n 0.43581 44070.0n 0.88832 44199.9n 0.88832 44200.0n 1.07007 44329.9n 1.07007 44330.0n 0.20119 44459.9n 0.20119 44460.0n 0.69502 44589.9n 0.69502 44590.0n 0.21498 44719.9n 0.21498 44720.0n 0.55066 44849.9n 0.55066 44850.0n 0.10559 44979.9n 0.10559 44980.0n 0.52079 45109.9n 0.52079 45110.0n -0.31038 45239.9n -0.31038 45240.0n 0.56449 45369.9n 0.56449 45370.0n 0.17082 45499.9n 0.17082 45500.0n 0.24079 45629.9n 0.24079 45630.0n 0.70685 45759.9n 0.70685 45760.0n 0.35630 45889.9n 0.35630 45890.0n 0.69969 46019.9n 0.69969 46020.0n 0.96459 46149.9n 0.96459 46150.0n 0.53141 46279.9n 0.53141 46280.0n 1.07007 46409.9n 1.07007 46410.0n 0.24079 46539.9n 0.24079 46540.0n 0.52079 46669.9n 0.52079 46670.0n 0.96459 46799.9n 0.96459 46800.0n 0.56449 46929.9n 0.56449 46930.0n -0.31038 47059.9n -0.31038 47060.0n -0.14927 47189.9n -0.14927 47190.0n 0.17082 47319.9n 0.17082 47320.0n 0.21498 47449.9n 0.21498 47450.0n 0.31139 47579.9n 0.31139 47580.0n 0.55006 47709.9n 0.55006 47710.0n 0.43581 47839.9n 0.43581 47840.0n 0.20119 47969.9n 0.20119 47970.0n 0.27643 48099.9n 0.27643 48100.0n 0.73600 48229.9n 0.73600 48230.0n 0.53141 48359.9n 0.53141 48360.0n 0.69502 48489.9n 0.69502 48490.0n -0.04662 48619.9n -0.04662 48620.0n 0.27076 48749.9n 0.27076 48750.0n 1.36668 48879.9n 1.36668 48880.0n 0.47556 49009.9n 0.47556 49010.0n 0.26419 49139.9n 0.26419 49140.0n 0.55066 49269.9n 0.55066 49270.0n 0.69969 49399.9n 0.69969 49400.0n 0.35630 49529.9n 0.35630 49530.0n 0.10559 49659.9n 0.10559 49660.0n 0.70685 49789.9n 0.70685 49790.0n 0.88832 49919.9n 0.88832 49920.0n 0.48508 50049.9n 0.48508 50050.0n 0.86030 50179.9n 0.86030 50180.0n 0.57742 50309.9n 0.57742 50310.0n 0.79287 50439.9n 0.79287 50440.0n 0.60090 50569.9n 0.60090 50570.0n 0.23371 50699.9n 0.23371 50700.0n 0.12484 50829.9n 0.12484 50830.0n 0.48351 50959.9n 0.48351 50960.0n 0.52272 51089.9n 0.52272 51090.0n 0.10421 51219.9n 0.10421 51220.0n 0.26187 51349.9n 0.26187 51350.0n 0.26993 51479.9n 0.26993 51480.0n 0.61195 51609.9n 0.61195 51610.0n 0.55435 51739.9n 0.55435 51740.0n 0.15028 51869.9n 0.15028 51870.0n 0.68626 51999.9n 0.68626 52000.0n 0.46500 52129.9n 0.46500 52130.0n 0.34619 52259.9n 0.34619 52260.0n 0.41172 52389.9n 0.41172 52390.0n 0.70707 52519.9n 0.70707 52520.0n 0.65136 52649.9n 0.65136 52650.0n 0.60081 52779.9n 0.60081 52780.0n 0.71496 52909.9n 0.71496 52910.0n 0.09082 53039.9n 0.09082 53040.0n 1.38855 53169.9n 1.38855 53170.0n 1.21890 53299.9n 1.21890 53300.0n 1.28851 53429.9n 1.28851 53430.0n 1.24585 53559.9n 1.24585 53560.0n -0.15208 53689.9n -0.15208 53690.0n 0.58159 53819.9n 0.58159 53820.0n 0.75662 53949.9n 0.75662 53950.0n -0.49277 54079.9n -0.49277 54080.0n -0.19260 54209.9n -0.19260 54210.0n 1.27962 54339.9n 1.27962 54340.0n 0.44267 54469.9n 0.44267 54470.0n 0.04400 54599.9n 0.04400 54600.0n 1.04710 54729.9n 1.04710 54730.0n 0.19758 54859.9n 0.19758 54860.0n 0.60264 54989.9n 0.60264 54990.0n -0.04029 55119.9n -0.04029 55120.0n 0.36851 55249.9n 0.36851 55250.0n 0.18248 55379.9n 0.18248 55380.0n -0.19808 55509.9n -0.19808 55510.0n -0.39872 55639.9n -0.39872 55640.0n 0.71881 55769.9n 0.71881 55770.0n -0.46004 55899.9n -0.46004 55900.0n 1.19303 56029.9n 1.19303 56030.0n 0.06458 56159.9n 0.06458 56160.0n 0.20119 56289.9n 0.20119 56290.0n 0.43581 56419.9n 0.43581 56420.0n 0.96459 56549.9n 0.96459 56550.0n 0.53141 56679.9n 0.53141 56680.0n 0.88832 56809.9n 0.88832 56810.0n 0.70685 56939.9n 0.70685 56940.0n 0.55006 57069.9n 0.55006 57070.0n 0.10559 57199.9n 0.10559 57200.0n 1.36668 57329.9n 1.36668 57330.0n 1.07007 57459.9n 1.07007 57460.0n 0.35630 57589.9n 0.35630 57590.0n 0.24079 57719.9n 0.24079 57720.0n 0.55066 57849.9n 0.55066 57850.0n -0.14927 57979.9n -0.14927 57980.0n 0.21498 58109.9n 0.21498 58110.0n 0.17082 58239.9n 0.17082 58240.0n 0.31139 58369.9n 0.31139 58370.0n 0.27643 58499.9n 0.27643 58500.0n 0.56449 58629.9n 0.56449 58630.0n 0.27076 58759.9n 0.27076 58760.0n 0.47556 58889.9n 0.47556 58890.0n -0.31038 59019.9n -0.31038 59020.0n -0.04662 59149.9n -0.04662 59150.0n 0.26419 59279.9n 0.26419 59280.0n 0.52079 59409.9n 0.52079 59410.0n 0.73600 59539.9n 0.73600 59540.0n 0.69502 59669.9n 0.69502 59670.0n 0.69969 59799.9n 0.69969 59800.0n -0.31038 59929.9n -0.31038 59930.0n 0.21498 60059.9n 0.21498 60060.0n -0.14927 60189.9n -0.14927 60190.0n 0.24079 60319.9n 0.24079 60320.0n 0.17082 60449.9n 0.17082 60450.0n 0.31139 60579.9n 0.31139 60580.0n 0.20119 60709.9n 0.20119 60710.0n 1.36668 60839.9n 1.36668 60840.0n 0.55006 60969.9n 0.55006 60970.0n 0.55066 61099.9n 0.55066 61100.0n 0.73600 61229.9n 0.73600 61230.0n 0.69969 61359.9n 0.69969 61360.0n -0.04662 61489.9n -0.04662 61490.0n 0.69502 61619.9n 0.69502 61620.0n 0.56449 61749.9n 0.56449 61750.0n 1.07007 61879.9n 1.07007 61880.0n 0.35630 62009.9n 0.35630 62010.0n 0.70685 62139.9n 0.70685 62140.0n 0.43581 62269.9n 0.43581 62270.0n 0.26419 62399.9n 0.26419 62400.0n 0.27076 62529.9n 0.27076 62530.0n 0.27643 62659.9n 0.27643 62660.0n 0.88832 62789.9n 0.88832 62790.0n 0.10559 62919.9n 0.10559 62920.0n 0.47556 63049.9n 0.47556 63050.0n 0.53141 63179.9n 0.53141 63180.0n 0.96459 63309.9n 0.96459 63310.0n 0.52079 63439.9n 0.52079 63440.0n -0.31038 63569.9n -0.31038 63570.0n 0.56449 63699.9n 0.56449 63700.0n 0.88832 63829.9n 0.88832 63830.0n 0.69969 63959.9n 0.69969 63960.0n -0.14927 64089.9n -0.14927 64090.0n 0.52079 64219.9n 0.52079 64220.0n 0.27643 64349.9n 0.27643 64350.0n 0.43581 64479.9n 0.43581 64480.0n -0.04662 64609.9n -0.04662 64610.0n 0.55006 64739.9n 0.55006 64740.0n 0.96459 64869.9n 0.96459 64870.0n 0.10559 64999.9n 0.10559 65000.0n 0.26419 65129.9n 0.26419 65130.0n 0.55066 65259.9n 0.55066 65260.0n 0.27076 65389.9n 0.27076 65390.0n 1.07007 65519.9n 1.07007 65520.0n 0.31139 65649.9n 0.31139 65650.0n 0.70685 65779.9n 0.70685 65780.0n 0.35630 65909.9n 0.35630 65910.0n 0.21498 66039.9n 0.21498 66040.0n 0.73600 66169.9n 0.73600 66170.0n 0.17082 66299.9n 0.17082 66300.0n 0.69502 66429.9n 0.69502 66430.0n 0.20119 66559.9n 0.20119 66560.0n 1.36668 66689.9n 1.36668 66690.0n 0.24079 66819.9n 0.24079 66820.0n 0.47556 66949.9n 0.47556 66950.0n 0.53141 67079.9n 0.53141 67080.0n 0.73600 67209.9n 0.73600 67210.0n 0.96459 67339.9n 0.96459 67340.0n 0.27076 67469.9n 0.27076 67470.0n 0.53141 67599.9n 0.53141 67600.0n 0.55066 67729.9n 0.55066 67730.0n 0.17082 67859.9n 0.17082 67860.0n 1.36668 67989.9n 1.36668 67990.0n 0.27643 68119.9n 0.27643 68120.0n 0.20119 68249.9n 0.20119 68250.0n 0.55006 68379.9n 0.55006 68380.0n 0.31139 68509.9n 0.31139 68510.0n 1.07007 68639.9n 1.07007 68640.0n 0.35630 68769.9n 0.35630 68770.0n 0.70685 68899.9n 0.70685 68900.0n 0.10559 69029.9n 0.10559 69030.0n 0.26419 69159.9n 0.26419 69160.0n 0.56449 69289.9n 0.56449 69290.0n -0.04662 69419.9n -0.04662 69420.0n -0.31038 69549.9n -0.31038 69550.0n 0.47556 69679.9n 0.47556 69680.0n 0.52079 69809.9n 0.52079 69810.0n 0.24079 69939.9n 0.24079 69940.0n 0.43581 70069.9n 0.43581 70070.0n 0.69969 70199.9n 0.69969 70200.0n 0.88832 70329.9n 0.88832 70330.0n 0.21498 70459.9n 0.21498 70460.0n -0.14927 70589.9n -0.14927 70590.0n 0.69502 70719.9n 0.69502 70720.0n -0.14927 70849.9n -0.14927 70850.0n 0.55066 70979.9n 0.55066 70980.0n 0.27643 71109.9n 0.27643 71110.0n 0.52079 71239.9n 0.52079 71240.0n -0.04662 71369.9n -0.04662 71370.0n 0.17082 71499.9n 0.17082 71500.0n 0.26419 71629.9n 0.26419 71630.0n 0.10559 71759.9n 0.10559 71760.0n 0.73600 71889.9n 0.73600 71890.0n 0.70685 72019.9n 0.70685 72020.0n 0.20119 72149.9n 0.20119 72150.0n 0.27076 72279.9n 0.27076 72280.0n 0.21498 72409.9n 0.21498 72410.0n 0.69969 72539.9n 0.69969 72540.0n 0.88832 72669.9n 0.88832 72670.0n 0.47556 72799.9n 0.47556 72800.0n -0.31038 72929.9n -0.31038 72930.0n 0.69502 73059.9n 0.69502 73060.0n 0.35630 73189.9n 0.35630 73190.0n 0.24079 73319.9n 0.24079 73320.0n 0.31139 73449.9n 0.31139 73450.0n 0.96459 73579.9n 0.96459 73580.0n 1.36668 73709.9n 1.36668 73710.0n 0.43581 73839.9n 0.43581 73840.0n 1.07007 73969.9n 1.07007 73970.0n 0.53141 74099.9n 0.53141 74100.0n 0.56449 74229.9n 0.56449 74230.0n 0.55006 74359.9n 0.55006 74360.0n 0.47556 74489.9n 0.47556 74490.0n 0.88832 74619.9n 0.88832 74620.0n 0.10559 74749.9n 0.10559 74750.0n 0.24079 74879.9n 0.24079 74880.0n 0.17082 75009.9n 0.17082 75010.0n 0.69502 75139.9n 0.69502 75140.0n 1.07007 75269.9n 1.07007 75270.0n -0.31038 75399.9n -0.31038 75400.0n 0.73600 75529.9n 0.73600 75530.0n 0.56449 75659.9n 0.56449 75660.0n 1.36668 75789.9n 1.36668 75790.0n 0.55066 75919.9n 0.55066 75920.0n 0.52079 76049.9n 0.52079 76050.0n 0.21498 76179.9n 0.21498 76180.0n 0.53141 76309.9n 0.53141 76310.0n 0.96459 76439.9n 0.96459 76440.0n 0.35630 76569.9n 0.35630 76570.0n 0.27643 76699.9n 0.27643 76700.0n 0.31139 76829.9n 0.31139 76830.0n 0.26419 76959.9n 0.26419 76960.0n 0.27076 77089.9n 0.27076 77090.0n 0.55006 77219.9n 0.55006 77220.0n 0.20119 77349.9n 0.20119 77350.0n 0.70685 77479.9n 0.70685 77480.0n -0.04662 77609.9n -0.04662 77610.0n 0.69969 77739.9n 0.69969 77740.0n 0.43581 77869.9n 0.43581 77870.0n -0.14927 77999.9n -0.14927 78000.0n 0.48508 78129.9n 0.48508 78130.0n 0.86030 78259.9n 0.86030 78260.0n 0.57742 78389.9n 0.57742 78390.0n 0.79287 78519.9n 0.79287 78520.0n 0.60090 78649.9n 0.60090 78650.0n 0.23371 78779.9n 0.23371 78780.0n 0.12484 78909.9n 0.12484 78910.0n 0.48351 79039.9n 0.48351 79040.0n 0.52272 79169.9n 0.52272 79170.0n 0.10421 79299.9n 0.10421 79300.0n 0.26187 79429.9n 0.26187 79430.0n 0.26993 79559.9n 0.26993 79560.0n 0.61195 79689.9n 0.61195 79690.0n 0.55435 79819.9n 0.55435 79820.0n 0.15028 79949.9n 0.15028 79950.0n 0.68626 80079.9n 0.68626 80080.0n 0.46500 80209.9n 0.46500 80210.0n 0.34619 80339.9n 0.34619 80340.0n 0.41172 80469.9n 0.41172 80470.0n 0.70707 80599.9n 0.70707 80600.0n 0.65136 80729.9n 0.65136 80730.0n 0.60081 80859.9n 0.60081 80860.0n 0.71496 80989.9n 0.71496 80990.0n 0.09082 81119.9n 0.09082 81120.0n 1.38855 81249.9n 1.38855 81250.0n 1.21890 81379.9n 1.21890 81380.0n 1.28851 81509.9n 1.28851 81510.0n 1.24585 81639.9n 1.24585 81640.0n -0.15208 81769.9n -0.15208 81770.0n 0.58159 81899.9n 0.58159 81900.0n 0.75662 82029.9n 0.75662 82030.0n -0.49277 82159.9n -0.49277 82160.0n -0.19260 82289.9n -0.19260 82290.0n 1.27962 82419.9n 1.27962 82420.0n 0.44267 82549.9n 0.44267 82550.0n 0.04400 82679.9n 0.04400 82680.0n 1.04710 82809.9n 1.04710 82810.0n 0.19758 82939.9n 0.19758 82940.0n 0.60264 83069.9n 0.60264 83070.0n -0.04029 83199.9n -0.04029 83200.0n 0.36851 83329.9n 0.36851 83330.0n 0.18248 83459.9n 0.18248 83460.0n -0.19808 83589.9n -0.19808 83590.0n -0.39872 83719.9n -0.39872 83720.0n 0.71881 83849.9n 0.71881 83850.0n -0.46004 83979.9n -0.46004 83980.0n 1.19303 84109.9n 1.19303 84110.0n 0.06458 84239.9n 0.06458 84240.0n 0.69502 84369.9n 0.69502 84370.0n 0.24079 84499.9n 0.24079 84500.0n 0.31139 84629.9n 0.31139 84630.0n 0.27643 84759.9n 0.27643 84760.0n 0.21498 84889.9n 0.21498 84890.0n 0.20119 85019.9n 0.20119 85020.0n 0.69969 85149.9n 0.69969 85150.0n -0.04662 85279.9n -0.04662 85280.0n 0.17082 85409.9n 0.17082 85410.0n 0.55066 85539.9n 0.55066 85540.0n 0.55006 85669.9n 0.55006 85670.0n 0.47556 85799.9n 0.47556 85800.0n 0.35630 85929.9n 0.35630 85930.0n 0.27076 86059.9n 0.27076 86060.0n 1.07007 86189.9n 1.07007 86190.0n -0.31038 86319.9n -0.31038 86320.0n 0.43581 86449.9n 0.43581 86450.0n 0.52079 86579.9n 0.52079 86580.0n 1.36668 86709.9n 1.36668 86710.0n 0.88832 86839.9n 0.88832 86840.0n 0.53141 86969.9n 0.53141 86970.0n 0.26419 87099.9n 0.26419 87100.0n -0.14927 87229.9n -0.14927 87230.0n 0.10559 87359.9n 0.10559 87360.0n 0.56449 87489.9n 0.56449 87490.0n 0.96459 87619.9n 0.96459 87620.0n 0.73600 87749.9n 0.73600 87750.0n 0.70685 87879.9n 0.70685 87880.0n 0.52079 88009.9n 0.52079 88010.0n 0.88832 88139.9n 0.88832 88140.0n 0.35630 88269.9n 0.35630 88270.0n 0.69502 88399.9n 0.69502 88400.0n 0.27643 88529.9n 0.27643 88530.0n 0.17082 88659.9n 0.17082 88660.0n -0.14927 88789.9n -0.14927 88790.0n 0.56449 88919.9n 0.56449 88920.0n 0.43581 89049.9n 0.43581 89050.0n 0.21498 89179.9n 0.21498 89180.0n 0.31139 89309.9n 0.31139 89310.0n 0.27076 89439.9n 0.27076 89440.0n -0.31038 89569.9n -0.31038 89570.0n -0.04662 89699.9n -0.04662 89700.0n 0.10559 89829.9n 0.10559 89830.0n 0.53141 89959.9n 0.53141 89960.0n 1.36668 90089.9n 1.36668 90090.0n 0.73600 90219.9n 0.73600 90220.0n 0.55006 90349.9n 0.55006 90350.0n 0.96459 90479.9n 0.96459 90480.0n 0.55066 90609.9n 0.55066 90610.0n 0.70685 90739.9n 0.70685 90740.0n 0.26419 90869.9n 0.26419 90870.0n 0.47556 90999.9n 0.47556 91000.0n 0.69969 91129.9n 0.69969 91130.0n 1.07007 91259.9n 1.07007 91260.0n 0.24079 91389.9n 0.24079 91390.0n 0.20119 91519.9n 0.20119 91520.0n 0.47556 91649.9n 0.47556 91650.0n 0.69969 91779.9n 0.69969 91780.0n 0.27076 91909.9n 0.27076 91910.0n 0.55006 92039.9n 0.55006 92040.0n 0.35630 92169.9n 0.35630 92170.0n 0.27643 92299.9n 0.27643 92300.0n 1.07007 92429.9n 1.07007 92430.0n 0.73600 92559.9n 0.73600 92560.0n 0.88832 92689.9n 0.88832 92690.0n 0.55066 92819.9n 0.55066 92820.0n 0.20119 92949.9n 0.20119 92950.0n 0.69502 93079.9n 0.69502 93080.0n 0.96459 93209.9n 0.96459 93210.0n 0.17082 93339.9n 0.17082 93340.0n 1.36668 93469.9n 1.36668 93470.0n 0.26419 93599.9n 0.26419 93600.0n 0.31139 93729.9n 0.31139 93730.0n 0.52079 93859.9n 0.52079 93860.0n 0.53141 93989.9n 0.53141 93990.0n 0.21498 94119.9n 0.21498 94120.0n 0.10559 94249.9n 0.10559 94250.0n 0.24079 94379.9n 0.24079 94380.0n -0.04662 94509.9n -0.04662 94510.0n -0.14927 94639.9n -0.14927 94640.0n -0.31038 94769.9n -0.31038 94770.0n 0.70685 94899.9n 0.70685 94900.0n 0.43581 95029.9n 0.43581 95030.0n 0.56449 95159.9n 0.56449 95160.0n 0.73600 95289.9n 0.73600 95290.0n 0.55066 95419.9n 0.55066 95420.0n 0.69969 95549.9n 0.69969 95550.0n 1.07007 95679.9n 1.07007 95680.0n 0.70685 95809.9n 0.70685 95810.0n 0.55006 95939.9n 0.55006 95940.0n -0.31038 96069.9n -0.31038 96070.0n -0.04662 96199.9n -0.04662 96200.0n 0.24079 96329.9n 0.24079 96330.0n 0.47556 96459.9n 0.47556 96460.0n 0.26419 96589.9n 0.26419 96590.0n 0.35630 96719.9n 0.35630 96720.0n 0.53141 96849.9n 0.53141 96850.0n 0.56449 96979.9n 0.56449 96980.0n 0.21498 97109.9n 0.21498 97110.0n 0.69502 97239.9n 0.69502 97240.0n 0.27076 97369.9n 0.27076 97370.0n 0.10559 97499.9n 0.10559 97500.0n 1.36668 97629.9n 1.36668 97630.0n 0.27643 97759.9n 0.27643 97760.0n -0.14927 97889.9n -0.14927 97890.0n 0.52079 98019.9n 0.52079 98020.0n 0.20119 98149.9n 0.20119 98150.0n 0.43581 98279.9n 0.43581 98280.0n 0.17082 98409.9n 0.17082 98410.0n 0.96459 98539.9n 0.96459 98540.0n 0.88832 98669.9n 0.88832 98670.0n 0.31139 98799.9n 0.31139 98800.0n 0.47556 98929.9n 0.47556 98930.0n 0.31139 99059.9n 0.31139 99060.0n 0.35630 99189.9n 0.35630 99190.0n 0.21498 99319.9n 0.21498 99320.0n 0.53141 99449.9n 0.53141 99450.0n 0.43581 99579.9n 0.43581 99580.0n 0.10559 99709.9n 0.10559 99710.0n 0.52079 99839.9n 0.52079 99840.0n -0.14927 99969.9n -0.14927 99970.0n 0.69969 100099.9n 0.69969 100100.0n 1.36668 100229.9n 1.36668 100230.0n 0.88832 100359.9n 0.88832 100360.0n -0.04662 100489.9n -0.04662 100490.0n 0.70685 100619.9n 0.70685 100620.0n -0.31038 100749.9n -0.31038 100750.0n 0.17082 100879.9n 0.17082 100880.0n 0.96459 101009.9n 0.96459 101010.0n 0.56449 101139.9n 0.56449 101140.0n 1.07007 101269.9n 1.07007 101270.0n 0.26419 101399.9n 0.26419 101400.0n 0.24079 101529.9n 0.24079 101530.0n 0.55006 101659.9n 0.55006 101660.0n 0.55066 101789.9n 0.55066 101790.0n 0.27643 101919.9n 0.27643 101920.0n 0.69502 102049.9n 0.69502 102050.0n 0.73600 102179.9n 0.73600 102180.0n 0.27076 102309.9n 0.27076 102310.0n 0.20119 102439.9n 0.20119 102440.0n 0.21498 102569.9n 0.21498 102570.0n 0.55066 102699.9n 0.55066 102700.0n -0.14927 102829.9n -0.14927 102830.0n 0.10559 102959.9n 0.10559 102960.0n 0.27076 103089.9n 0.27076 103090.0n 0.27643 103219.9n 0.27643 103220.0n 0.55006 103349.9n 0.55006 103350.0n 0.31139 103479.9n 0.31139 103480.0n 0.20119 103609.9n 0.20119 103610.0n 0.96459 103739.9n 0.96459 103740.0n 0.35630 103869.9n 0.35630 103870.0n 0.17082 103999.9n 0.17082 104000.0n 0.70685 104129.9n 0.70685 104130.0n 0.24079 104259.9n 0.24079 104260.0n 0.69502 104389.9n 0.69502 104390.0n 0.69969 104519.9n 0.69969 104520.0n 1.07007 104649.9n 1.07007 104650.0n -0.31038 104779.9n -0.31038 104780.0n -0.04662 104909.9n -0.04662 104910.0n 0.88832 105039.9n 0.88832 105040.0n 0.73600 105169.9n 0.73600 105170.0n 0.53141 105299.9n 0.53141 105300.0n 0.43581 105429.9n 0.43581 105430.0n 0.52079 105559.9n 0.52079 105560.0n 0.47556 105689.9n 0.47556 105690.0n 0.56449 105819.9n 0.56449 105820.0n 0.26419 105949.9n 0.26419 105950.0n 1.36668 106079.9n 1.36668 106080.0n 0.48508 106209.9n 0.48508 106210.0n 0.86030 106339.9n 0.86030 106340.0n 0.57742 106469.9n 0.57742 106470.0n 0.79287 106599.9n 0.79287 106600.0n 0.60090 106729.9n 0.60090 106730.0n 0.23371 106859.9n 0.23371 106860.0n 0.12484 106989.9n 0.12484 106990.0n 0.48351 107119.9n 0.48351 107120.0n 0.52272 107249.9n 0.52272 107250.0n 0.10421 107379.9n 0.10421 107380.0n 0.26187 107509.9n 0.26187 107510.0n 0.26993 107639.9n 0.26993 107640.0n 0.61195 107769.9n 0.61195 107770.0n 0.55435 107899.9n 0.55435 107900.0n 0.15028 108029.9n 0.15028 108030.0n 0.68626 108159.9n 0.68626 108160.0n 0.46500 108289.9n 0.46500 108290.0n 0.34619 108419.9n 0.34619 108420.0n 0.41172 108549.9n 0.41172 108550.0n 0.70707 108679.9n 0.70707 108680.0n 0.65136 108809.9n 0.65136 108810.0n 0.60081 108939.9n 0.60081 108940.0n 0.71496 109069.9n 0.71496 109070.0n 0.09082 109199.9n 0.09082 109200.0n 1.38855 109329.9n 1.38855 109330.0n 1.21890 109459.9n 1.21890 109460.0n 1.28851 109589.9n 1.28851 109590.0n 1.24585 109719.9n 1.24585 109720.0n -0.15208 109849.9n -0.15208 109850.0n 0.58159 109979.9n 0.58159 109980.0n 0.75662 110109.9n 0.75662 110110.0n -0.49277 110239.9n -0.49277 110240.0n -0.19260 110369.9n -0.19260 110370.0n 1.27962 110499.9n 1.27962 110500.0n 0.44267 110629.9n 0.44267 110630.0n 0.04400 110759.9n 0.04400 110760.0n 1.04710 110889.9n 1.04710 110890.0n 0.19758 111019.9n 0.19758 111020.0n 0.60264 111149.9n 0.60264 111150.0n -0.04029 111279.9n -0.04029 111280.0n 0.36851 111409.9n 0.36851 111410.0n 0.18248 111539.9n 0.18248 111540.0n -0.19808 111669.9n -0.19808 111670.0n -0.39872 111799.9n -0.39872 111800.0n 0.71881 111929.9n 0.71881 111930.0n -0.46004 112059.9n -0.46004 112060.0n 1.19303 112189.9n 1.19303 112190.0n 0.06458 112319.9n 0.06458 112320.0n 0.73600 112449.9n 0.73600 112450.0n 0.17082 112579.9n 0.17082 112580.0n 1.36668 112709.9n 1.36668 112710.0n 0.43581 112839.9n 0.43581 112840.0n 0.88832 112969.9n 0.88832 112970.0n 0.20119 113099.9n 0.20119 113100.0n 0.24079 113229.9n 0.24079 113230.0n 0.26419 113359.9n 0.26419 113360.0n 0.10559 113489.9n 0.10559 113490.0n -0.31038 113619.9n -0.31038 113620.0n 0.31139 113749.9n 0.31139 113750.0n 0.27076 113879.9n 0.27076 113880.0n 0.27643 114009.9n 0.27643 114010.0n 0.35630 114139.9n 0.35630 114140.0n 0.52079 114269.9n 0.52079 114270.0n 0.55066 114399.9n 0.55066 114400.0n 0.56449 114529.9n 0.56449 114530.0n 1.07007 114659.9n 1.07007 114660.0n 0.69502 114789.9n 0.69502 114790.0n 0.53141 114919.9n 0.53141 114920.0n 0.96459 115049.9n 0.96459 115050.0n -0.14927 115179.9n -0.14927 115180.0n 0.55006 115309.9n 0.55006 115310.0n 0.69969 115439.9n 0.69969 115440.0n 0.21498 115569.9n 0.21498 115570.0n 0.47556 115699.9n 0.47556 115700.0n 0.70685 115829.9n 0.70685 115830.0n -0.04662 115959.9n -0.04662 115960.0n -0.14927 116089.9n -0.14927 116090.0n 0.69502 116219.9n 0.69502 116220.0n 0.21498 116349.9n 0.21498 116350.0n 0.88832 116479.9n 0.88832 116480.0n 0.56449 116609.9n 0.56449 116610.0n 0.17082 116739.9n 0.17082 116740.0n 0.43581 116869.9n 0.43581 116870.0n 0.31139 116999.9n 0.31139 117000.0n 0.10559 117129.9n 0.10559 117130.0n 0.55006 117259.9n 0.55006 117260.0n 0.27076 117389.9n 0.27076 117390.0n 0.52079 117519.9n 0.52079 117520.0n 0.35630 117649.9n 0.35630 117650.0n 1.07007 117779.9n 1.07007 117780.0n 0.55066 117909.9n 0.55066 117910.0n -0.31038 118039.9n -0.31038 118040.0n 0.47556 118169.9n 0.47556 118170.0n 0.70685 118299.9n 0.70685 118300.0n 0.26419 118429.9n 0.26419 118430.0n 1.36668 118559.9n 1.36668 118560.0n 0.27643 118689.9n 0.27643 118690.0n 0.96459 118819.9n 0.96459 118820.0n 0.73600 118949.9n 0.73600 118950.0n 0.53141 119079.9n 0.53141 119080.0n 0.20119 119209.9n 0.20119 119210.0n 0.24079 119339.9n 0.24079 119340.0n -0.04662 119469.9n -0.04662 119470.0n 0.69969 119599.9n 0.69969 119600.0n 0.24079 119729.9n 0.24079 119730.0n 0.53141 119859.9n 0.53141 119860.0n -0.31038 119989.9n -0.31038 119990.0n 0.88832 120119.9n 0.88832 120120.0n 0.31139 120249.9n 0.31139 120250.0n 0.47556 120379.9n 0.47556 120380.0n 0.17082 120509.9n 0.17082 120510.0n 0.56449 120639.9n 0.56449 120640.0n 1.07007 120769.9n 1.07007 120770.0n 0.10559 120899.9n 0.10559 120900.0n 0.69502 121029.9n 0.69502 121030.0n 0.55006 121159.9n 0.55006 121160.0n 0.96459 121289.9n 0.96459 121290.0n 0.55066 121419.9n 0.55066 121420.0n 0.21498 121549.9n 0.21498 121550.0n -0.04662 121679.9n -0.04662 121680.0n 0.27076 121809.9n 0.27076 121810.0n 0.73600 121939.9n 0.73600 121940.0n -0.14927 122069.9n -0.14927 122070.0n 0.69969 122199.9n 0.69969 122200.0n 0.70685 122329.9n 0.70685 122330.0n 0.43581 122459.9n 0.43581 122460.0n 0.52079 122589.9n 0.52079 122590.0n 0.27643 122719.9n 0.27643 122720.0n 1.36668 122849.9n 1.36668 122850.0n 0.35630 122979.9n 0.35630 122980.0n 0.26419 123109.9n 0.26419 123110.0n 0.20119 123239.9n 0.20119 123240.0n 0.73600 123369.9n 0.73600 123370.0n 0.20119 123499.9n 0.20119 123500.0n -0.04662 123629.9n -0.04662 123630.0n 1.07007 123759.9n 1.07007 123760.0n 0.31139 123889.9n 0.31139 123890.0n 0.69502 124019.9n 0.69502 124020.0n -0.31038 124149.9n -0.31038 124150.0n 1.36668 124279.9n 1.36668 124280.0n 0.27643 124409.9n 0.27643 124410.0n 0.56449 124539.9n 0.56449 124540.0n 0.43581 124669.9n 0.43581 124670.0n 0.10559 124799.9n 0.10559 124800.0n 0.53141 124929.9n 0.53141 124930.0n 0.55066 125059.9n 0.55066 125060.0n 0.69969 125189.9n 0.69969 125190.0n 0.88832 125319.9n 0.88832 125320.0n 0.35630 125449.9n 0.35630 125450.0n 0.70685 125579.9n 0.70685 125580.0n 0.26419 125709.9n 0.26419 125710.0n 0.96459 125839.9n 0.96459 125840.0n 0.24079 125969.9n 0.24079 125970.0n 0.52079 126099.9n 0.52079 126100.0n 0.47556 126229.9n 0.47556 126230.0n -0.14927 126359.9n -0.14927 126360.0n 0.55006 126489.9n 0.55006 126490.0n 0.21498 126619.9n 0.21498 126620.0n 0.27076 126749.9n 0.27076 126750.0n 0.17082 126879.9n 0.17082 126880.0n 0.10559 127009.9n 0.10559 127010.0n 0.26419 127139.9n 0.26419 127140.0n 0.35630 127269.9n 0.35630 127270.0n 0.47556 127399.9n 0.47556 127400.0n 0.52079 127529.9n 0.52079 127530.0n 0.17082 127659.9n 0.17082 127660.0n -0.04662 127789.9n -0.04662 127790.0n -0.14927 127919.9n -0.14927 127920.0n 0.20119 128049.9n 0.20119 128050.0n 0.56449 128179.9n 0.56449 128180.0n -0.31038 128309.9n -0.31038 128310.0n 0.27643 128439.9n 0.27643 128440.0n 1.36668 128569.9n 1.36668 128570.0n 0.96459 128699.9n 0.96459 128700.0n 0.31139 128829.9n 0.31139 128830.0n 0.43581 128959.9n 0.43581 128960.0n 0.21498 129089.9n 0.21498 129090.0n 0.55066 129219.9n 0.55066 129220.0n 0.55006 129349.9n 0.55006 129350.0n 0.70685 129479.9n 0.70685 129480.0n 1.07007 129609.9n 1.07007 129610.0n 0.69502 129739.9n 0.69502 129740.0n 0.88832 129869.9n 0.88832 129870.0n 0.53141 129999.9n 0.53141 130000.0n 0.69969 130129.9n 0.69969 130130.0n 0.27076 130259.9n 0.27076 130260.0n 0.24079 130389.9n 0.24079 130390.0n 0.73600 130519.9n 0.73600 130520.0n 1.36668 130649.9n 1.36668 130650.0n 0.17082 130779.9n 0.17082 130780.0n 0.52079 130909.9n 0.52079 130910.0n 0.88832 131039.9n 0.88832 131040.0n 0.27643 131169.9n 0.27643 131170.0n 1.07007 131299.9n 1.07007 131300.0n 0.69969 131429.9n 0.69969 131430.0n 0.47556 131559.9n 0.47556 131560.0n 0.69502 131689.9n 0.69502 131690.0n 0.24079 131819.9n 0.24079 131820.0n 0.31139 131949.9n 0.31139 131950.0n 0.96459 132079.9n 0.96459 132080.0n 0.73600 132209.9n 0.73600 132210.0n -0.04662 132339.9n -0.04662 132340.0n 0.55066 132469.9n 0.55066 132470.0n -0.14927 132599.9n -0.14927 132600.0n 0.27076 132729.9n 0.27076 132730.0n 0.55006 132859.9n 0.55006 132860.0n 0.56449 132989.9n 0.56449 132990.0n 0.43581 133119.9n 0.43581 133120.0n 0.35630 133249.9n 0.35630 133250.0n 0.20119 133379.9n 0.20119 133380.0n 0.26419 133509.9n 0.26419 133510.0n -0.31038 133639.9n -0.31038 133640.0n 0.70685 133769.9n 0.70685 133770.0n 0.10559 133899.9n 0.10559 133900.0n 0.21498 134029.9n 0.21498 134030.0n 0.53141 134159.9n 0.53141 134160.0n 0.48508 134289.9n 0.48508 134290.0n 0.86030 134419.9n 0.86030 134420.0n 0.57742 134549.9n 0.57742 134550.0n 0.79287 134679.9n 0.79287 134680.0n 0.60090 134809.9n 0.60090 134810.0n 0.23371 134939.9n 0.23371 134940.0n 0.12484 135069.9n 0.12484 135070.0n 0.48351 135199.9n 0.48351 135200.0n 0.52272 135329.9n 0.52272 135330.0n 0.10421 135459.9n 0.10421 135460.0n 0.26187 135589.9n 0.26187 135590.0n 0.26993 135719.9n 0.26993 135720.0n 0.61195 135849.9n 0.61195 135850.0n 0.55435 135979.9n 0.55435 135980.0n 0.15028 136109.9n 0.15028 136110.0n 0.68626 136239.9n 0.68626 136240.0n 0.46500 136369.9n 0.46500 136370.0n 0.34619 136499.9n 0.34619 136500.0n 0.41172 136629.9n 0.41172 136630.0n 0.70707 136759.9n 0.70707 136760.0n 0.65136 136889.9n 0.65136 136890.0n 0.60081 137019.9n 0.60081 137020.0n 0.71496 137149.9n 0.71496 137150.0n 0.09082 137279.9n 0.09082 137280.0n 1.38855 137409.9n 1.38855 137410.0n 1.21890 137539.9n 1.21890 137540.0n 1.28851 137669.9n 1.28851 137670.0n 1.24585 137799.9n 1.24585 137800.0n -0.15208 137929.9n -0.15208 137930.0n 0.58159 138059.9n 0.58159 138060.0n 0.75662 138189.9n 0.75662 138190.0n -0.49277 138319.9n -0.49277 138320.0n -0.19260 138449.9n -0.19260 138450.0n 1.27962 138579.9n 1.27962 138580.0n 0.44267 138709.9n 0.44267 138710.0n 0.04400 138839.9n 0.04400 138840.0n 1.04710 138969.9n 1.04710 138970.0n 0.19758 139099.9n 0.19758 139100.0n 0.60264 139229.9n 0.60264 139230.0n -0.04029 139359.9n -0.04029 139360.0n 0.36851 139489.9n 0.36851 139490.0n 0.18248 139619.9n 0.18248 139620.0n -0.19808 139749.9n -0.19808 139750.0n -0.39872 139879.9n -0.39872 139880.0n 0.71881 140009.9n 0.71881 140010.0n -0.46004 140139.9n -0.46004 140140.0n 1.19303 140269.9n 1.19303 140270.0n 0.06458 140399.9n 0.06458 140400.0n 0.47556 140529.9n 0.47556 140530.0n 0.17082 140659.9n 0.17082 140660.0n -0.14927 140789.9n -0.14927 140790.0n 0.27643 140919.9n 0.27643 140920.0n 0.55006 141049.9n 0.55006 141050.0n 0.70685 141179.9n 0.70685 141180.0n -0.04662 141309.9n -0.04662 141310.0n 0.43581 141439.9n 0.43581 141440.0n -0.31038 141569.9n -0.31038 141570.0n 0.24079 141699.9n 0.24079 141700.0n 0.20119 141829.9n 0.20119 141830.0n 0.27076 141959.9n 0.27076 141960.0n 1.07007 142089.9n 1.07007 142090.0n 0.88832 142219.9n 0.88832 142220.0n 0.69502 142349.9n 0.69502 142350.0n 0.96459 142479.9n 0.96459 142480.0n 0.55066 142609.9n 0.55066 142610.0n 0.10559 142739.9n 0.10559 142740.0n 0.53141 142869.9n 0.53141 142870.0n 1.36668 142999.9n 1.36668 143000.0n 0.69969 143129.9n 0.69969 143130.0n 0.35630 143259.9n 0.35630 143260.0n 0.26419 143389.9n 0.26419 143390.0n 0.73600 143519.9n 0.73600 143520.0n 0.56449 143649.9n 0.56449 143650.0n 0.31139 143779.9n 0.31139 143780.0n 0.21498 143909.9n 0.21498 143910.0n 0.52079 144039.9n 0.52079 144040.0n 1.36668 144169.9n 1.36668 144170.0n -0.31038 144299.9n -0.31038 144300.0n 0.35630 144429.9n 0.35630 144430.0n 0.21498 144559.9n 0.21498 144560.0n 0.56449 144689.9n 0.56449 144690.0n 0.70685 144819.9n 0.70685 144820.0n -0.14927 144949.9n -0.14927 144950.0n 0.43581 145079.9n 0.43581 145080.0n 0.69502 145209.9n 0.69502 145210.0n 0.10559 145339.9n 0.10559 145340.0n 0.96459 145469.9n 0.96459 145470.0n 0.69969 145599.9n 0.69969 145600.0n 0.31139 145729.9n 0.31139 145730.0n 0.24079 145859.9n 0.24079 145860.0n 1.07007 145989.9n 1.07007 145990.0n 0.27643 146119.9n 0.27643 146120.0n 0.88832 146249.9n 0.88832 146250.0n 0.73600 146379.9n 0.73600 146380.0n 0.26419 146509.9n 0.26419 146510.0n 0.55006 146639.9n 0.55006 146640.0n 0.20119 146769.9n 0.20119 146770.0n 0.17082 146899.9n 0.17082 146900.0n 0.55066 147029.9n 0.55066 147030.0n 0.27076 147159.9n 0.27076 147160.0n 0.47556 147289.9n 0.47556 147290.0n 0.52079 147419.9n 0.52079 147420.0n 0.53141 147549.9n 0.53141 147550.0n -0.04662 147679.9n -0.04662 147680.0n 0.21498 147809.9n 0.21498 147810.0n 0.53141 147939.9n 0.53141 147940.0n 0.70685 148069.9n 0.70685 148070.0n -0.04662 148199.9n -0.04662 148200.0n -0.14927 148329.9n -0.14927 148330.0n 1.07007 148459.9n 1.07007 148460.0n 1.36668 148589.9n 1.36668 148590.0n 0.55006 148719.9n 0.55006 148720.0n -0.31038 148849.9n -0.31038 148850.0n 0.73600 148979.9n 0.73600 148980.0n 0.43581 149109.9n 0.43581 149110.0n 0.31139 149239.9n 0.31139 149240.0n 0.10559 149369.9n 0.10559 149370.0n 0.69969 149499.9n 0.69969 149500.0n 0.52079 149629.9n 0.52079 149630.0n 0.27643 149759.9n 0.27643 149760.0n 0.27076 149889.9n 0.27076 149890.0n 0.56449 150019.9n 0.56449 150020.0n 0.55066 150149.9n 0.55066 150150.0n 0.26419 150279.9n 0.26419 150280.0n 0.17082 150409.9n 0.17082 150410.0n 0.35630 150539.9n 0.35630 150540.0n 0.47556 150669.9n 0.47556 150670.0n 0.69502 150799.9n 0.69502 150800.0n 0.96459 150929.9n 0.96459 150930.0n 0.88832 151059.9n 0.88832 151060.0n 0.24079 151189.9n 0.24079 151190.0n 0.20119 151319.9n 0.20119 151320.0n 0.27643 151449.9n 0.27643 151450.0n 0.55066 151579.9n 0.55066 151580.0n 0.27076 151709.9n 0.27076 151710.0n 0.43581 151839.9n 0.43581 151840.0n 0.73600 151969.9n 0.73600 151970.0n 0.69969 152099.9n 0.69969 152100.0n 0.56449 152229.9n 0.56449 152230.0n 0.53141 152359.9n 0.53141 152360.0n 0.24079 152489.9n 0.24079 152490.0n 1.07007 152619.9n 1.07007 152620.0n -0.14927 152749.9n -0.14927 152750.0n 0.52079 152879.9n 0.52079 152880.0n 0.35630 153009.9n 0.35630 153010.0n 0.47556 153139.9n 0.47556 153140.0n 0.70685 153269.9n 0.70685 153270.0n 0.26419 153399.9n 0.26419 153400.0n 0.96459 153529.9n 0.96459 153530.0n 0.20119 153659.9n 0.20119 153660.0n 0.21498 153789.9n 0.21498 153790.0n 0.17082 153919.9n 0.17082 153920.0n -0.31038 154049.9n -0.31038 154050.0n -0.04662 154179.9n -0.04662 154180.0n 0.10559 154309.9n 0.10559 154310.0n 0.31139 154439.9n 0.31139 154440.0n 0.55006 154569.9n 0.55006 154570.0n 0.69502 154699.9n 0.69502 154700.0n 1.36668 154829.9n 1.36668 154830.0n 0.88832 154959.9n 0.88832 154960.0n -0.31038 155089.9n -0.31038 155090.0n 0.43581 155219.9n 0.43581 155220.0n 0.26419 155349.9n 0.26419 155350.0n 0.55006 155479.9n 0.55006 155480.0n 0.69502 155609.9n 0.69502 155610.0n 0.10559 155739.9n 0.10559 155740.0n 0.73600 155869.9n 0.73600 155870.0n 0.55066 155999.9n 0.55066 156000.0n 0.35630 156129.9n 0.35630 156130.0n 0.69969 156259.9n 0.69969 156260.0n 0.20119 156389.9n 0.20119 156390.0n 0.52079 156519.9n 0.52079 156520.0n 1.36668 156649.9n 1.36668 156650.0n 0.88832 156779.9n 0.88832 156780.0n -0.04662 156909.9n -0.04662 156910.0n 0.17082 157039.9n 0.17082 157040.0n 0.27076 157169.9n 0.27076 157170.0n 0.56449 157299.9n 0.56449 157300.0n 0.31139 157429.9n 0.31139 157430.0n 0.70685 157559.9n 0.70685 157560.0n -0.14927 157689.9n -0.14927 157690.0n 0.27643 157819.9n 0.27643 157820.0n 0.24079 157949.9n 0.24079 157950.0n 1.07007 158079.9n 1.07007 158080.0n 0.47556 158209.9n 0.47556 158210.0n 0.53141 158339.9n 0.53141 158340.0n 0.21498 158469.9n 0.21498 158470.0n 0.96459 158599.9n 0.96459 158600.0n 0.73600 158729.9n 0.73600 158730.0n 0.17082 158859.9n 0.17082 158860.0n 0.69502 158989.9n 0.69502 158990.0n 0.20119 159119.9n 0.20119 159120.0n 0.26419 159249.9n 0.26419 159250.0n -0.14927 159379.9n -0.14927 159380.0n 0.43581 159509.9n 0.43581 159510.0n 0.55006 159639.9n 0.55006 159640.0n 0.52079 159769.9n 0.52079 159770.0n 0.21498 159899.9n 0.21498 159900.0n 0.27643 160029.9n 0.27643 160030.0n 0.96459 160159.9n 0.96459 160160.0n 1.07007 160289.9n 1.07007 160290.0n 0.35630 160419.9n 0.35630 160420.0n 0.55066 160549.9n 0.55066 160550.0n 0.53141 160679.9n 0.53141 160680.0n 0.69969 160809.9n 0.69969 160810.0n 0.88832 160939.9n 0.88832 160940.0n 0.70685 161069.9n 0.70685 161070.0n 0.27076 161199.9n 0.27076 161200.0n 0.24079 161329.9n 0.24079 161330.0n 0.10559 161459.9n 0.10559 161460.0n 0.47556 161589.9n 0.47556 161590.0n 0.31139 161719.9n 0.31139 161720.0n -0.04662 161849.9n -0.04662 161850.0n -0.31038 161979.9n -0.31038 161980.0n 0.56449 162109.9n 0.56449 162110.0n 1.36668 162239.9n 1.36668 162240.0n 0.48508 162369.9n 0.48508 162370.0n 0.86030 162499.9n 0.86030 162500.0n 0.57742 162629.9n 0.57742 162630.0n 0.79287 162759.9n 0.79287 162760.0n 0.60090 162889.9n 0.60090 162890.0n 0.23371 163019.9n 0.23371 163020.0n 0.12484 163149.9n 0.12484 163150.0n 0.48351 163279.9n 0.48351 163280.0n 0.52272 163409.9n 0.52272 163410.0n 0.10421 163539.9n 0.10421 163540.0n 0.26187 163669.9n 0.26187 163670.0n 0.26993 163799.9n 0.26993 163800.0n 0.61195 163929.9n 0.61195 163930.0n 0.55435 164059.9n 0.55435 164060.0n 0.15028 164189.9n 0.15028 164190.0n 0.68626 164319.9n 0.68626 164320.0n 0.46500 164449.9n 0.46500 164450.0n 0.34619 164579.9n 0.34619 164580.0n 0.41172 164709.9n 0.41172 164710.0n 0.70707 164839.9n 0.70707 164840.0n 0.65136 164969.9n 0.65136 164970.0n 0.60081 165099.9n 0.60081 165100.0n 0.71496 165229.9n 0.71496 165230.0n 0.09082 165359.9n 0.09082 165360.0n 1.38855 165489.9n 1.38855 165490.0n 1.21890 165619.9n 1.21890 165620.0n 1.28851 165749.9n 1.28851 165750.0n 1.24585 165879.9n 1.24585 165880.0n -0.15208 166009.9n -0.15208 166010.0n 0.58159 166139.9n 0.58159 166140.0n 0.75662 166269.9n 0.75662 166270.0n -0.49277 166399.9n -0.49277 166400.0n -0.19260 166529.9n -0.19260 166530.0n 1.27962 166659.9n 1.27962 166660.0n 0.44267 166789.9n 0.44267 166790.0n 0.04400 166919.9n 0.04400 166920.0n 1.04710 167049.9n 1.04710 167050.0n 0.19758 167179.9n 0.19758 167180.0n 0.60264 167309.9n 0.60264 167310.0n -0.04029 167439.9n -0.04029 167440.0n 0.36851 167569.9n 0.36851 167570.0n 0.18248 167699.9n 0.18248 167700.0n -0.19808 167829.9n -0.19808 167830.0n -0.39872 167959.9n -0.39872 167960.0n 0.71881 168089.9n 0.71881 168090.0n -0.46004 168219.9n -0.46004 168220.0n 1.19303 168349.9n 1.19303 168350.0n 0.06458)
Vxn0 a_xn0 0 PWL(0.0n 0.30031 129.9n 0.30031 130.0n 0.43551 259.9n 0.43551 260.0n 0.47921 389.9n 0.47921 390.0n 0.30498 519.9n 0.30498 520.0n 0.75921 649.9n 0.75921 650.0n 0.82918 779.9n 0.82918 780.0n 0.89441 909.9n 0.89441 910.0n 0.72924 1039.9n 0.72924 1040.0n 1.14927 1169.9n 1.14927 1170.0n 0.72357 1299.9n 0.72357 1300.0n 0.46859 1429.9n 0.46859 1430.0n 0.29315 1559.9n 0.29315 1560.0n 0.68861 1689.9n 0.68861 1690.0n 0.79881 1819.9n 0.79881 1820.0n -0.36668 1949.9n -0.36668 1950.0n 0.78502 2079.9n 0.78502 2080.0n 0.44994 2209.9n 0.44994 2210.0n 0.03541 2339.9n 0.03541 2340.0n 0.44934 2469.9n 0.44934 2470.0n 0.73581 2599.9n 0.73581 2600.0n 1.31038 2729.9n 1.31038 2730.0n 0.26400 2859.9n 0.26400 2860.0n 0.52444 2989.9n 0.52444 2990.0n 1.04662 3119.9n 1.04662 3120.0n 0.56419 3249.9n 0.56419 3250.0n 0.64370 3379.9n 0.64370 3380.0n -0.07007 3509.9n -0.07007 3510.0n 0.11168 3639.9n 0.11168 3640.0n 0.78502 3769.9n 0.78502 3770.0n 0.89441 3899.9n 0.89441 3900.0n 0.72357 4029.9n 0.72357 4030.0n 1.31038 4159.9n 1.31038 4160.0n 0.75921 4289.9n 0.75921 4290.0n -0.36668 4419.9n -0.36668 4420.0n 0.52444 4549.9n 0.52444 4550.0n 0.11168 4679.9n 0.11168 4680.0n 0.72924 4809.9n 0.72924 4810.0n 0.44994 4939.9n 0.44994 4940.0n 0.44934 5069.9n 0.44934 5070.0n 0.68861 5199.9n 0.68861 5200.0n 0.47921 5329.9n 0.47921 5330.0n 0.30498 5459.9n 0.30498 5460.0n 0.43551 5589.9n 0.43551 5590.0n 0.64370 5719.9n 0.64370 5720.0n 0.46859 5849.9n 0.46859 5850.0n -0.07007 5979.9n -0.07007 5980.0n 0.73581 6109.9n 0.73581 6110.0n 1.04662 6239.9n 1.04662 6240.0n 1.14927 6369.9n 1.14927 6370.0n 0.56419 6499.9n 0.56419 6500.0n 0.79881 6629.9n 0.79881 6630.0n 0.29315 6759.9n 0.29315 6760.0n 0.26400 6889.9n 0.26400 6890.0n 0.03541 7019.9n 0.03541 7020.0n 0.82918 7149.9n 0.82918 7150.0n 0.30031 7279.9n 0.30031 7280.0n 0.26400 7409.9n 0.26400 7410.0n 0.43551 7539.9n 0.43551 7540.0n 1.04662 7669.9n 1.04662 7670.0n 0.78502 7799.9n 0.78502 7800.0n 0.47921 7929.9n 0.47921 7930.0n 1.31038 8059.9n 1.31038 8060.0n 0.73581 8189.9n 0.73581 8190.0n 0.68861 8319.9n 0.68861 8320.0n 0.52444 8449.9n 0.52444 8450.0n 0.72357 8579.9n 0.72357 8580.0n 0.64370 8709.9n 0.64370 8710.0n 0.30031 8839.9n 0.30031 8840.0n 0.44994 8969.9n 0.44994 8970.0n 0.72924 9099.9n 0.72924 9100.0n 0.11168 9229.9n 0.11168 9230.0n 0.75921 9359.9n 0.75921 9360.0n 0.82918 9489.9n 0.82918 9490.0n -0.07007 9619.9n -0.07007 9620.0n 0.56419 9749.9n 0.56419 9750.0n -0.36668 9879.9n -0.36668 9880.0n 0.29315 10009.9n 0.29315 10010.0n 0.30498 10139.9n 0.30498 10140.0n 0.79881 10269.9n 0.79881 10270.0n 0.46859 10399.9n 0.46859 10400.0n 0.89441 10529.9n 0.89441 10530.0n 0.03541 10659.9n 0.03541 10660.0n 1.14927 10789.9n 1.14927 10790.0n 0.44934 10919.9n 0.44934 10920.0n -0.36668 11049.9n -0.36668 11050.0n 0.78502 11179.9n 0.78502 11180.0n 0.79881 11309.9n 0.79881 11310.0n 1.31038 11439.9n 1.31038 11440.0n 0.11168 11569.9n 0.11168 11570.0n 0.26400 11699.9n 0.26400 11700.0n 1.04662 11829.9n 1.04662 11830.0n 0.89441 11959.9n 0.89441 11960.0n 0.75921 12089.9n 0.75921 12090.0n 0.72924 12219.9n 0.72924 12220.0n 0.52444 12349.9n 0.52444 12350.0n 0.43551 12479.9n 0.43551 12480.0n 0.30031 12609.9n 0.30031 12610.0n 0.73581 12739.9n 0.73581 12740.0n 1.14927 12869.9n 1.14927 12870.0n -0.07007 12999.9n -0.07007 13000.0n 0.30498 13129.9n 0.30498 13130.0n 0.44994 13259.9n 0.44994 13260.0n 0.47921 13389.9n 0.47921 13390.0n 0.03541 13519.9n 0.03541 13520.0n 0.29315 13649.9n 0.29315 13650.0n 0.56419 13779.9n 0.56419 13780.0n 0.82918 13909.9n 0.82918 13910.0n 0.68861 14039.9n 0.68861 14040.0n 0.72357 14169.9n 0.72357 14170.0n 0.44934 14299.9n 0.44934 14300.0n 0.46859 14429.9n 0.46859 14430.0n 0.64370 14559.9n 0.64370 14560.0n 1.04662 14689.9n 1.04662 14690.0n 0.44994 14819.9n 0.44994 14820.0n 1.14927 14949.9n 1.14927 14950.0n 0.30031 15079.9n 0.30031 15080.0n 0.30498 15209.9n 0.30498 15210.0n 0.46859 15339.9n 0.46859 15340.0n 0.29315 15469.9n 0.29315 15470.0n 0.56419 15599.9n 0.56419 15600.0n 0.82918 15729.9n 0.82918 15730.0n 0.72924 15859.9n 0.72924 15860.0n 0.11168 15989.9n 0.11168 15990.0n 0.44934 16119.9n 0.44934 16120.0n 0.64370 16249.9n 0.64370 16250.0n -0.36668 16379.9n -0.36668 16380.0n 0.73581 16509.9n 0.73581 16510.0n 0.68861 16639.9n 0.68861 16640.0n 0.89441 16769.9n 0.89441 16770.0n 0.79881 16899.9n 0.79881 16900.0n 0.72357 17029.9n 0.72357 17030.0n 0.78502 17159.9n 0.78502 17160.0n 0.26400 17289.9n 0.26400 17290.0n 0.52444 17419.9n 0.52444 17420.0n 0.43551 17549.9n 0.43551 17550.0n -0.07007 17679.9n -0.07007 17680.0n 1.31038 17809.9n 1.31038 17810.0n 0.03541 17939.9n 0.03541 17940.0n 0.47921 18069.9n 0.47921 18070.0n 0.75921 18199.9n 0.75921 18200.0n 0.46859 18329.9n 0.46859 18330.0n 0.30031 18459.9n 0.30031 18460.0n 0.44934 18589.9n 0.44934 18590.0n 0.29315 18719.9n 0.29315 18720.0n 0.75921 18849.9n 0.75921 18850.0n 0.64370 18979.9n 0.64370 18980.0n 0.56419 19109.9n 0.56419 19110.0n 1.04662 19239.9n 1.04662 19240.0n 0.52444 19369.9n 0.52444 19370.0n 0.03541 19499.9n 0.03541 19500.0n -0.07007 19629.9n -0.07007 19630.0n 0.79881 19759.9n 0.79881 19760.0n 1.31038 19889.9n 1.31038 19890.0n 0.47921 20019.9n 0.47921 20020.0n 0.73581 20149.9n 0.73581 20150.0n 0.44994 20279.9n 0.44994 20280.0n -0.36668 20409.9n -0.36668 20410.0n 0.26400 20539.9n 0.26400 20540.0n 0.78502 20669.9n 0.78502 20670.0n 0.43551 20799.9n 0.43551 20800.0n 0.89441 20929.9n 0.89441 20930.0n 0.72357 21059.9n 0.72357 21060.0n 0.82918 21189.9n 0.82918 21190.0n 0.11168 21319.9n 0.11168 21320.0n 0.30498 21449.9n 0.30498 21450.0n 0.72924 21579.9n 0.72924 21580.0n 1.14927 21709.9n 1.14927 21710.0n 0.68861 21839.9n 0.68861 21840.0n 0.51492 21969.9n 0.51492 21970.0n 0.13970 22099.9n 0.13970 22100.0n 0.42258 22229.9n 0.42258 22230.0n 0.20713 22359.9n 0.20713 22360.0n 0.39910 22489.9n 0.39910 22490.0n 0.76629 22619.9n 0.76629 22620.0n 0.87516 22749.9n 0.87516 22750.0n 0.51649 22879.9n 0.51649 22880.0n 0.47728 23009.9n 0.47728 23010.0n 0.89579 23139.9n 0.89579 23140.0n 0.73813 23269.9n 0.73813 23270.0n 0.73007 23399.9n 0.73007 23400.0n 0.38805 23529.9n 0.38805 23530.0n 0.44565 23659.9n 0.44565 23660.0n 0.84972 23789.9n 0.84972 23790.0n 0.31374 23919.9n 0.31374 23920.0n 0.53500 24049.9n 0.53500 24050.0n 0.65381 24179.9n 0.65381 24180.0n 0.58828 24309.9n 0.58828 24310.0n 0.29293 24439.9n 0.29293 24440.0n 0.34864 24569.9n 0.34864 24570.0n 0.39919 24699.9n 0.39919 24700.0n 0.28504 24829.9n 0.28504 24830.0n 0.90918 24959.9n 0.90918 24960.0n -0.38855 25089.9n -0.38855 25090.0n -0.21890 25219.9n -0.21890 25220.0n -0.28851 25349.9n -0.28851 25350.0n -0.24585 25479.9n -0.24585 25480.0n 1.15208 25609.9n 1.15208 25610.0n 0.41841 25739.9n 0.41841 25740.0n 0.24338 25869.9n 0.24338 25870.0n 1.49277 25999.9n 1.49277 26000.0n 1.19260 26129.9n 1.19260 26130.0n -0.27962 26259.9n -0.27962 26260.0n 0.55733 26389.9n 0.55733 26390.0n 0.95600 26519.9n 0.95600 26520.0n -0.04710 26649.9n -0.04710 26650.0n 0.80242 26779.9n 0.80242 26780.0n 0.39736 26909.9n 0.39736 26910.0n 1.04029 27039.9n 1.04029 27040.0n 0.63149 27169.9n 0.63149 27170.0n 0.81752 27299.9n 0.81752 27300.0n 1.19808 27429.9n 1.19808 27430.0n 1.39872 27559.9n 1.39872 27560.0n 0.28119 27689.9n 0.28119 27690.0n 1.46004 27819.9n 1.46004 27820.0n -0.19303 27949.9n -0.19303 27950.0n 0.93542 28079.9n 0.93542 28080.0n 0.29315 28209.9n 0.29315 28210.0n 0.30498 28339.9n 0.30498 28340.0n 1.04662 28469.9n 1.04662 28470.0n 0.03541 28599.9n 0.03541 28600.0n -0.07007 28729.9n -0.07007 28730.0n 0.64370 28859.9n 0.64370 28860.0n 0.30031 28989.9n 0.30031 28990.0n 0.72924 29119.9n 0.72924 29120.0n 0.79881 29249.9n 0.79881 29250.0n 0.46859 29379.9n 0.46859 29380.0n 0.11168 29509.9n 0.11168 29510.0n 0.47921 29639.9n 0.47921 29640.0n 0.72357 29769.9n 0.72357 29770.0n 1.31038 29899.9n 1.31038 29900.0n 0.68861 30029.9n 0.68861 30030.0n 0.89441 30159.9n 0.89441 30160.0n 0.52444 30289.9n 0.52444 30290.0n 1.14927 30419.9n 1.14927 30420.0n 0.73581 30549.9n 0.73581 30550.0n 0.44994 30679.9n 0.44994 30680.0n 0.26400 30809.9n 0.26400 30810.0n 0.44934 30939.9n 0.44934 30940.0n 0.56419 31069.9n 0.56419 31070.0n 0.43551 31199.9n 0.43551 31200.0n 0.75921 31329.9n 0.75921 31330.0n -0.36668 31459.9n -0.36668 31460.0n 0.78502 31589.9n 0.78502 31590.0n 0.82918 31719.9n 0.82918 31720.0n 0.89441 31849.9n 0.89441 31850.0n 0.82918 31979.9n 0.82918 31980.0n 0.30498 32109.9n 0.30498 32110.0n 0.68861 32239.9n 0.68861 32240.0n 0.44994 32369.9n 0.44994 32370.0n 0.47921 32499.9n 0.47921 32500.0n 0.30031 32629.9n 0.30031 32630.0n 0.11168 32759.9n 0.11168 32760.0n 0.03541 32889.9n 0.03541 32890.0n 0.64370 33019.9n 0.64370 33020.0n 0.46859 33149.9n 0.46859 33150.0n -0.07007 33279.9n -0.07007 33280.0n 0.72924 33409.9n 0.72924 33410.0n 1.14927 33539.9n 1.14927 33540.0n 0.79881 33669.9n 0.79881 33670.0n 1.04662 33799.9n 1.04662 33800.0n 0.29315 33929.9n 0.29315 33930.0n 0.52444 34059.9n 0.52444 34060.0n 0.78502 34189.9n 0.78502 34190.0n 0.56419 34319.9n 0.56419 34320.0n 0.26400 34449.9n 0.26400 34450.0n 0.72357 34579.9n 0.72357 34580.0n 0.43551 34709.9n 0.43551 34710.0n 0.44934 34839.9n 0.44934 34840.0n -0.36668 34969.9n -0.36668 34970.0n 1.31038 35099.9n 1.31038 35100.0n 0.73581 35229.9n 0.73581 35230.0n 0.75921 35359.9n 0.75921 35360.0n -0.07007 35489.9n -0.07007 35490.0n 0.44934 35619.9n 0.44934 35620.0n 0.52444 35749.9n 0.52444 35750.0n 1.04662 35879.9n 1.04662 35880.0n 0.47921 36009.9n 0.47921 36010.0n 0.89441 36139.9n 0.89441 36140.0n 0.72924 36269.9n 0.72924 36270.0n 0.26400 36399.9n 0.26400 36400.0n 0.78502 36529.9n 0.78502 36530.0n 0.43551 36659.9n 0.43551 36660.0n 0.03541 36789.9n 0.03541 36790.0n 0.30031 36919.9n 0.30031 36920.0n -0.36668 37049.9n -0.36668 37050.0n 0.46859 37179.9n 0.46859 37180.0n 0.73581 37309.9n 0.73581 37310.0n 0.11168 37439.9n 0.11168 37440.0n 0.44994 37569.9n 0.44994 37570.0n 0.75921 37699.9n 0.75921 37700.0n 0.29315 37829.9n 0.29315 37830.0n 0.64370 37959.9n 0.64370 37960.0n 0.30498 38089.9n 0.30498 38090.0n 0.56419 38219.9n 0.56419 38220.0n 0.79881 38349.9n 0.79881 38350.0n 1.31038 38479.9n 1.31038 38480.0n 1.14927 38609.9n 1.14927 38610.0n 0.82918 38739.9n 0.82918 38740.0n 0.72357 38869.9n 0.72357 38870.0n 0.68861 38999.9n 0.68861 39000.0n 0.46859 39129.9n 0.46859 39130.0n 0.26400 39259.9n 0.26400 39260.0n 0.68861 39389.9n 0.68861 39390.0n 0.75921 39519.9n 0.75921 39520.0n 0.11168 39649.9n 0.11168 39650.0n 0.43551 39779.9n 0.43551 39780.0n 0.72924 39909.9n 0.72924 39910.0n 0.89441 40039.9n 0.89441 40040.0n 0.72357 40169.9n 0.72357 40170.0n 0.79881 40299.9n 0.79881 40300.0n 0.29315 40429.9n 0.29315 40430.0n 0.44934 40559.9n 0.44934 40560.0n 1.04662 40689.9n 1.04662 40690.0n -0.36668 40819.9n -0.36668 40820.0n 0.44994 40949.9n 0.44994 40950.0n 0.52444 41079.9n 0.52444 41080.0n -0.07007 41209.9n -0.07007 41210.0n 0.73581 41339.9n 0.73581 41340.0n 0.78502 41469.9n 0.78502 41470.0n 0.30498 41599.9n 0.30498 41600.0n 1.14927 41729.9n 1.14927 41730.0n 1.31038 41859.9n 1.31038 41860.0n 0.03541 41989.9n 0.03541 41990.0n 0.47921 42119.9n 0.47921 42120.0n 0.82918 42249.9n 0.82918 42250.0n 0.64370 42379.9n 0.64370 42380.0n 0.56419 42509.9n 0.56419 42510.0n 0.30031 42639.9n 0.30031 42640.0n 0.73581 42769.9n 0.73581 42770.0n 0.26400 42899.9n 0.26400 42900.0n 0.68861 43029.9n 0.68861 43030.0n 0.72357 43159.9n 0.72357 43160.0n 0.44994 43289.9n 0.44994 43290.0n -0.36668 43419.9n -0.36668 43420.0n 1.04662 43549.9n 1.04662 43550.0n 0.52444 43679.9n 0.52444 43680.0n 1.14927 43809.9n 1.14927 43810.0n 0.72924 43939.9n 0.72924 43940.0n 0.56419 44069.9n 0.56419 44070.0n 0.11168 44199.9n 0.11168 44200.0n -0.07007 44329.9n -0.07007 44330.0n 0.79881 44459.9n 0.79881 44460.0n 0.30498 44589.9n 0.30498 44590.0n 0.78502 44719.9n 0.78502 44720.0n 0.44934 44849.9n 0.44934 44850.0n 0.89441 44979.9n 0.89441 44980.0n 0.47921 45109.9n 0.47921 45110.0n 1.31038 45239.9n 1.31038 45240.0n 0.43551 45369.9n 0.43551 45370.0n 0.82918 45499.9n 0.82918 45500.0n 0.75921 45629.9n 0.75921 45630.0n 0.29315 45759.9n 0.29315 45760.0n 0.64370 45889.9n 0.64370 45890.0n 0.30031 46019.9n 0.30031 46020.0n 0.03541 46149.9n 0.03541 46150.0n 0.46859 46279.9n 0.46859 46280.0n -0.07007 46409.9n -0.07007 46410.0n 0.75921 46539.9n 0.75921 46540.0n 0.47921 46669.9n 0.47921 46670.0n 0.03541 46799.9n 0.03541 46800.0n 0.43551 46929.9n 0.43551 46930.0n 1.31038 47059.9n 1.31038 47060.0n 1.14927 47189.9n 1.14927 47190.0n 0.82918 47319.9n 0.82918 47320.0n 0.78502 47449.9n 0.78502 47450.0n 0.68861 47579.9n 0.68861 47580.0n 0.44994 47709.9n 0.44994 47710.0n 0.56419 47839.9n 0.56419 47840.0n 0.79881 47969.9n 0.79881 47970.0n 0.72357 48099.9n 0.72357 48100.0n 0.26400 48229.9n 0.26400 48230.0n 0.46859 48359.9n 0.46859 48360.0n 0.30498 48489.9n 0.30498 48490.0n 1.04662 48619.9n 1.04662 48620.0n 0.72924 48749.9n 0.72924 48750.0n -0.36668 48879.9n -0.36668 48880.0n 0.52444 49009.9n 0.52444 49010.0n 0.73581 49139.9n 0.73581 49140.0n 0.44934 49269.9n 0.44934 49270.0n 0.30031 49399.9n 0.30031 49400.0n 0.64370 49529.9n 0.64370 49530.0n 0.89441 49659.9n 0.89441 49660.0n 0.29315 49789.9n 0.29315 49790.0n 0.11168 49919.9n 0.11168 49920.0n 0.51492 50049.9n 0.51492 50050.0n 0.13970 50179.9n 0.13970 50180.0n 0.42258 50309.9n 0.42258 50310.0n 0.20713 50439.9n 0.20713 50440.0n 0.39910 50569.9n 0.39910 50570.0n 0.76629 50699.9n 0.76629 50700.0n 0.87516 50829.9n 0.87516 50830.0n 0.51649 50959.9n 0.51649 50960.0n 0.47728 51089.9n 0.47728 51090.0n 0.89579 51219.9n 0.89579 51220.0n 0.73813 51349.9n 0.73813 51350.0n 0.73007 51479.9n 0.73007 51480.0n 0.38805 51609.9n 0.38805 51610.0n 0.44565 51739.9n 0.44565 51740.0n 0.84972 51869.9n 0.84972 51870.0n 0.31374 51999.9n 0.31374 52000.0n 0.53500 52129.9n 0.53500 52130.0n 0.65381 52259.9n 0.65381 52260.0n 0.58828 52389.9n 0.58828 52390.0n 0.29293 52519.9n 0.29293 52520.0n 0.34864 52649.9n 0.34864 52650.0n 0.39919 52779.9n 0.39919 52780.0n 0.28504 52909.9n 0.28504 52910.0n 0.90918 53039.9n 0.90918 53040.0n -0.38855 53169.9n -0.38855 53170.0n -0.21890 53299.9n -0.21890 53300.0n -0.28851 53429.9n -0.28851 53430.0n -0.24585 53559.9n -0.24585 53560.0n 1.15208 53689.9n 1.15208 53690.0n 0.41841 53819.9n 0.41841 53820.0n 0.24338 53949.9n 0.24338 53950.0n 1.49277 54079.9n 1.49277 54080.0n 1.19260 54209.9n 1.19260 54210.0n -0.27962 54339.9n -0.27962 54340.0n 0.55733 54469.9n 0.55733 54470.0n 0.95600 54599.9n 0.95600 54600.0n -0.04710 54729.9n -0.04710 54730.0n 0.80242 54859.9n 0.80242 54860.0n 0.39736 54989.9n 0.39736 54990.0n 1.04029 55119.9n 1.04029 55120.0n 0.63149 55249.9n 0.63149 55250.0n 0.81752 55379.9n 0.81752 55380.0n 1.19808 55509.9n 1.19808 55510.0n 1.39872 55639.9n 1.39872 55640.0n 0.28119 55769.9n 0.28119 55770.0n 1.46004 55899.9n 1.46004 55900.0n -0.19303 56029.9n -0.19303 56030.0n 0.93542 56159.9n 0.93542 56160.0n 0.79881 56289.9n 0.79881 56290.0n 0.56419 56419.9n 0.56419 56420.0n 0.03541 56549.9n 0.03541 56550.0n 0.46859 56679.9n 0.46859 56680.0n 0.11168 56809.9n 0.11168 56810.0n 0.29315 56939.9n 0.29315 56940.0n 0.44994 57069.9n 0.44994 57070.0n 0.89441 57199.9n 0.89441 57200.0n -0.36668 57329.9n -0.36668 57330.0n -0.07007 57459.9n -0.07007 57460.0n 0.64370 57589.9n 0.64370 57590.0n 0.75921 57719.9n 0.75921 57720.0n 0.44934 57849.9n 0.44934 57850.0n 1.14927 57979.9n 1.14927 57980.0n 0.78502 58109.9n 0.78502 58110.0n 0.82918 58239.9n 0.82918 58240.0n 0.68861 58369.9n 0.68861 58370.0n 0.72357 58499.9n 0.72357 58500.0n 0.43551 58629.9n 0.43551 58630.0n 0.72924 58759.9n 0.72924 58760.0n 0.52444 58889.9n 0.52444 58890.0n 1.31038 59019.9n 1.31038 59020.0n 1.04662 59149.9n 1.04662 59150.0n 0.73581 59279.9n 0.73581 59280.0n 0.47921 59409.9n 0.47921 59410.0n 0.26400 59539.9n 0.26400 59540.0n 0.30498 59669.9n 0.30498 59670.0n 0.30031 59799.9n 0.30031 59800.0n 1.31038 59929.9n 1.31038 59930.0n 0.78502 60059.9n 0.78502 60060.0n 1.14927 60189.9n 1.14927 60190.0n 0.75921 60319.9n 0.75921 60320.0n 0.82918 60449.9n 0.82918 60450.0n 0.68861 60579.9n 0.68861 60580.0n 0.79881 60709.9n 0.79881 60710.0n -0.36668 60839.9n -0.36668 60840.0n 0.44994 60969.9n 0.44994 60970.0n 0.44934 61099.9n 0.44934 61100.0n 0.26400 61229.9n 0.26400 61230.0n 0.30031 61359.9n 0.30031 61360.0n 1.04662 61489.9n 1.04662 61490.0n 0.30498 61619.9n 0.30498 61620.0n 0.43551 61749.9n 0.43551 61750.0n -0.07007 61879.9n -0.07007 61880.0n 0.64370 62009.9n 0.64370 62010.0n 0.29315 62139.9n 0.29315 62140.0n 0.56419 62269.9n 0.56419 62270.0n 0.73581 62399.9n 0.73581 62400.0n 0.72924 62529.9n 0.72924 62530.0n 0.72357 62659.9n 0.72357 62660.0n 0.11168 62789.9n 0.11168 62790.0n 0.89441 62919.9n 0.89441 62920.0n 0.52444 63049.9n 0.52444 63050.0n 0.46859 63179.9n 0.46859 63180.0n 0.03541 63309.9n 0.03541 63310.0n 0.47921 63439.9n 0.47921 63440.0n 1.31038 63569.9n 1.31038 63570.0n 0.43551 63699.9n 0.43551 63700.0n 0.11168 63829.9n 0.11168 63830.0n 0.30031 63959.9n 0.30031 63960.0n 1.14927 64089.9n 1.14927 64090.0n 0.47921 64219.9n 0.47921 64220.0n 0.72357 64349.9n 0.72357 64350.0n 0.56419 64479.9n 0.56419 64480.0n 1.04662 64609.9n 1.04662 64610.0n 0.44994 64739.9n 0.44994 64740.0n 0.03541 64869.9n 0.03541 64870.0n 0.89441 64999.9n 0.89441 65000.0n 0.73581 65129.9n 0.73581 65130.0n 0.44934 65259.9n 0.44934 65260.0n 0.72924 65389.9n 0.72924 65390.0n -0.07007 65519.9n -0.07007 65520.0n 0.68861 65649.9n 0.68861 65650.0n 0.29315 65779.9n 0.29315 65780.0n 0.64370 65909.9n 0.64370 65910.0n 0.78502 66039.9n 0.78502 66040.0n 0.26400 66169.9n 0.26400 66170.0n 0.82918 66299.9n 0.82918 66300.0n 0.30498 66429.9n 0.30498 66430.0n 0.79881 66559.9n 0.79881 66560.0n -0.36668 66689.9n -0.36668 66690.0n 0.75921 66819.9n 0.75921 66820.0n 0.52444 66949.9n 0.52444 66950.0n 0.46859 67079.9n 0.46859 67080.0n 0.26400 67209.9n 0.26400 67210.0n 0.03541 67339.9n 0.03541 67340.0n 0.72924 67469.9n 0.72924 67470.0n 0.46859 67599.9n 0.46859 67600.0n 0.44934 67729.9n 0.44934 67730.0n 0.82918 67859.9n 0.82918 67860.0n -0.36668 67989.9n -0.36668 67990.0n 0.72357 68119.9n 0.72357 68120.0n 0.79881 68249.9n 0.79881 68250.0n 0.44994 68379.9n 0.44994 68380.0n 0.68861 68509.9n 0.68861 68510.0n -0.07007 68639.9n -0.07007 68640.0n 0.64370 68769.9n 0.64370 68770.0n 0.29315 68899.9n 0.29315 68900.0n 0.89441 69029.9n 0.89441 69030.0n 0.73581 69159.9n 0.73581 69160.0n 0.43551 69289.9n 0.43551 69290.0n 1.04662 69419.9n 1.04662 69420.0n 1.31038 69549.9n 1.31038 69550.0n 0.52444 69679.9n 0.52444 69680.0n 0.47921 69809.9n 0.47921 69810.0n 0.75921 69939.9n 0.75921 69940.0n 0.56419 70069.9n 0.56419 70070.0n 0.30031 70199.9n 0.30031 70200.0n 0.11168 70329.9n 0.11168 70330.0n 0.78502 70459.9n 0.78502 70460.0n 1.14927 70589.9n 1.14927 70590.0n 0.30498 70719.9n 0.30498 70720.0n 1.14927 70849.9n 1.14927 70850.0n 0.44934 70979.9n 0.44934 70980.0n 0.72357 71109.9n 0.72357 71110.0n 0.47921 71239.9n 0.47921 71240.0n 1.04662 71369.9n 1.04662 71370.0n 0.82918 71499.9n 0.82918 71500.0n 0.73581 71629.9n 0.73581 71630.0n 0.89441 71759.9n 0.89441 71760.0n 0.26400 71889.9n 0.26400 71890.0n 0.29315 72019.9n 0.29315 72020.0n 0.79881 72149.9n 0.79881 72150.0n 0.72924 72279.9n 0.72924 72280.0n 0.78502 72409.9n 0.78502 72410.0n 0.30031 72539.9n 0.30031 72540.0n 0.11168 72669.9n 0.11168 72670.0n 0.52444 72799.9n 0.52444 72800.0n 1.31038 72929.9n 1.31038 72930.0n 0.30498 73059.9n 0.30498 73060.0n 0.64370 73189.9n 0.64370 73190.0n 0.75921 73319.9n 0.75921 73320.0n 0.68861 73449.9n 0.68861 73450.0n 0.03541 73579.9n 0.03541 73580.0n -0.36668 73709.9n -0.36668 73710.0n 0.56419 73839.9n 0.56419 73840.0n -0.07007 73969.9n -0.07007 73970.0n 0.46859 74099.9n 0.46859 74100.0n 0.43551 74229.9n 0.43551 74230.0n 0.44994 74359.9n 0.44994 74360.0n 0.52444 74489.9n 0.52444 74490.0n 0.11168 74619.9n 0.11168 74620.0n 0.89441 74749.9n 0.89441 74750.0n 0.75921 74879.9n 0.75921 74880.0n 0.82918 75009.9n 0.82918 75010.0n 0.30498 75139.9n 0.30498 75140.0n -0.07007 75269.9n -0.07007 75270.0n 1.31038 75399.9n 1.31038 75400.0n 0.26400 75529.9n 0.26400 75530.0n 0.43551 75659.9n 0.43551 75660.0n -0.36668 75789.9n -0.36668 75790.0n 0.44934 75919.9n 0.44934 75920.0n 0.47921 76049.9n 0.47921 76050.0n 0.78502 76179.9n 0.78502 76180.0n 0.46859 76309.9n 0.46859 76310.0n 0.03541 76439.9n 0.03541 76440.0n 0.64370 76569.9n 0.64370 76570.0n 0.72357 76699.9n 0.72357 76700.0n 0.68861 76829.9n 0.68861 76830.0n 0.73581 76959.9n 0.73581 76960.0n 0.72924 77089.9n 0.72924 77090.0n 0.44994 77219.9n 0.44994 77220.0n 0.79881 77349.9n 0.79881 77350.0n 0.29315 77479.9n 0.29315 77480.0n 1.04662 77609.9n 1.04662 77610.0n 0.30031 77739.9n 0.30031 77740.0n 0.56419 77869.9n 0.56419 77870.0n 1.14927 77999.9n 1.14927 78000.0n 0.51492 78129.9n 0.51492 78130.0n 0.13970 78259.9n 0.13970 78260.0n 0.42258 78389.9n 0.42258 78390.0n 0.20713 78519.9n 0.20713 78520.0n 0.39910 78649.9n 0.39910 78650.0n 0.76629 78779.9n 0.76629 78780.0n 0.87516 78909.9n 0.87516 78910.0n 0.51649 79039.9n 0.51649 79040.0n 0.47728 79169.9n 0.47728 79170.0n 0.89579 79299.9n 0.89579 79300.0n 0.73813 79429.9n 0.73813 79430.0n 0.73007 79559.9n 0.73007 79560.0n 0.38805 79689.9n 0.38805 79690.0n 0.44565 79819.9n 0.44565 79820.0n 0.84972 79949.9n 0.84972 79950.0n 0.31374 80079.9n 0.31374 80080.0n 0.53500 80209.9n 0.53500 80210.0n 0.65381 80339.9n 0.65381 80340.0n 0.58828 80469.9n 0.58828 80470.0n 0.29293 80599.9n 0.29293 80600.0n 0.34864 80729.9n 0.34864 80730.0n 0.39919 80859.9n 0.39919 80860.0n 0.28504 80989.9n 0.28504 80990.0n 0.90918 81119.9n 0.90918 81120.0n -0.38855 81249.9n -0.38855 81250.0n -0.21890 81379.9n -0.21890 81380.0n -0.28851 81509.9n -0.28851 81510.0n -0.24585 81639.9n -0.24585 81640.0n 1.15208 81769.9n 1.15208 81770.0n 0.41841 81899.9n 0.41841 81900.0n 0.24338 82029.9n 0.24338 82030.0n 1.49277 82159.9n 1.49277 82160.0n 1.19260 82289.9n 1.19260 82290.0n -0.27962 82419.9n -0.27962 82420.0n 0.55733 82549.9n 0.55733 82550.0n 0.95600 82679.9n 0.95600 82680.0n -0.04710 82809.9n -0.04710 82810.0n 0.80242 82939.9n 0.80242 82940.0n 0.39736 83069.9n 0.39736 83070.0n 1.04029 83199.9n 1.04029 83200.0n 0.63149 83329.9n 0.63149 83330.0n 0.81752 83459.9n 0.81752 83460.0n 1.19808 83589.9n 1.19808 83590.0n 1.39872 83719.9n 1.39872 83720.0n 0.28119 83849.9n 0.28119 83850.0n 1.46004 83979.9n 1.46004 83980.0n -0.19303 84109.9n -0.19303 84110.0n 0.93542 84239.9n 0.93542 84240.0n 0.30498 84369.9n 0.30498 84370.0n 0.75921 84499.9n 0.75921 84500.0n 0.68861 84629.9n 0.68861 84630.0n 0.72357 84759.9n 0.72357 84760.0n 0.78502 84889.9n 0.78502 84890.0n 0.79881 85019.9n 0.79881 85020.0n 0.30031 85149.9n 0.30031 85150.0n 1.04662 85279.9n 1.04662 85280.0n 0.82918 85409.9n 0.82918 85410.0n 0.44934 85539.9n 0.44934 85540.0n 0.44994 85669.9n 0.44994 85670.0n 0.52444 85799.9n 0.52444 85800.0n 0.64370 85929.9n 0.64370 85930.0n 0.72924 86059.9n 0.72924 86060.0n -0.07007 86189.9n -0.07007 86190.0n 1.31038 86319.9n 1.31038 86320.0n 0.56419 86449.9n 0.56419 86450.0n 0.47921 86579.9n 0.47921 86580.0n -0.36668 86709.9n -0.36668 86710.0n 0.11168 86839.9n 0.11168 86840.0n 0.46859 86969.9n 0.46859 86970.0n 0.73581 87099.9n 0.73581 87100.0n 1.14927 87229.9n 1.14927 87230.0n 0.89441 87359.9n 0.89441 87360.0n 0.43551 87489.9n 0.43551 87490.0n 0.03541 87619.9n 0.03541 87620.0n 0.26400 87749.9n 0.26400 87750.0n 0.29315 87879.9n 0.29315 87880.0n 0.47921 88009.9n 0.47921 88010.0n 0.11168 88139.9n 0.11168 88140.0n 0.64370 88269.9n 0.64370 88270.0n 0.30498 88399.9n 0.30498 88400.0n 0.72357 88529.9n 0.72357 88530.0n 0.82918 88659.9n 0.82918 88660.0n 1.14927 88789.9n 1.14927 88790.0n 0.43551 88919.9n 0.43551 88920.0n 0.56419 89049.9n 0.56419 89050.0n 0.78502 89179.9n 0.78502 89180.0n 0.68861 89309.9n 0.68861 89310.0n 0.72924 89439.9n 0.72924 89440.0n 1.31038 89569.9n 1.31038 89570.0n 1.04662 89699.9n 1.04662 89700.0n 0.89441 89829.9n 0.89441 89830.0n 0.46859 89959.9n 0.46859 89960.0n -0.36668 90089.9n -0.36668 90090.0n 0.26400 90219.9n 0.26400 90220.0n 0.44994 90349.9n 0.44994 90350.0n 0.03541 90479.9n 0.03541 90480.0n 0.44934 90609.9n 0.44934 90610.0n 0.29315 90739.9n 0.29315 90740.0n 0.73581 90869.9n 0.73581 90870.0n 0.52444 90999.9n 0.52444 91000.0n 0.30031 91129.9n 0.30031 91130.0n -0.07007 91259.9n -0.07007 91260.0n 0.75921 91389.9n 0.75921 91390.0n 0.79881 91519.9n 0.79881 91520.0n 0.52444 91649.9n 0.52444 91650.0n 0.30031 91779.9n 0.30031 91780.0n 0.72924 91909.9n 0.72924 91910.0n 0.44994 92039.9n 0.44994 92040.0n 0.64370 92169.9n 0.64370 92170.0n 0.72357 92299.9n 0.72357 92300.0n -0.07007 92429.9n -0.07007 92430.0n 0.26400 92559.9n 0.26400 92560.0n 0.11168 92689.9n 0.11168 92690.0n 0.44934 92819.9n 0.44934 92820.0n 0.79881 92949.9n 0.79881 92950.0n 0.30498 93079.9n 0.30498 93080.0n 0.03541 93209.9n 0.03541 93210.0n 0.82918 93339.9n 0.82918 93340.0n -0.36668 93469.9n -0.36668 93470.0n 0.73581 93599.9n 0.73581 93600.0n 0.68861 93729.9n 0.68861 93730.0n 0.47921 93859.9n 0.47921 93860.0n 0.46859 93989.9n 0.46859 93990.0n 0.78502 94119.9n 0.78502 94120.0n 0.89441 94249.9n 0.89441 94250.0n 0.75921 94379.9n 0.75921 94380.0n 1.04662 94509.9n 1.04662 94510.0n 1.14927 94639.9n 1.14927 94640.0n 1.31038 94769.9n 1.31038 94770.0n 0.29315 94899.9n 0.29315 94900.0n 0.56419 95029.9n 0.56419 95030.0n 0.43551 95159.9n 0.43551 95160.0n 0.26400 95289.9n 0.26400 95290.0n 0.44934 95419.9n 0.44934 95420.0n 0.30031 95549.9n 0.30031 95550.0n -0.07007 95679.9n -0.07007 95680.0n 0.29315 95809.9n 0.29315 95810.0n 0.44994 95939.9n 0.44994 95940.0n 1.31038 96069.9n 1.31038 96070.0n 1.04662 96199.9n 1.04662 96200.0n 0.75921 96329.9n 0.75921 96330.0n 0.52444 96459.9n 0.52444 96460.0n 0.73581 96589.9n 0.73581 96590.0n 0.64370 96719.9n 0.64370 96720.0n 0.46859 96849.9n 0.46859 96850.0n 0.43551 96979.9n 0.43551 96980.0n 0.78502 97109.9n 0.78502 97110.0n 0.30498 97239.9n 0.30498 97240.0n 0.72924 97369.9n 0.72924 97370.0n 0.89441 97499.9n 0.89441 97500.0n -0.36668 97629.9n -0.36668 97630.0n 0.72357 97759.9n 0.72357 97760.0n 1.14927 97889.9n 1.14927 97890.0n 0.47921 98019.9n 0.47921 98020.0n 0.79881 98149.9n 0.79881 98150.0n 0.56419 98279.9n 0.56419 98280.0n 0.82918 98409.9n 0.82918 98410.0n 0.03541 98539.9n 0.03541 98540.0n 0.11168 98669.9n 0.11168 98670.0n 0.68861 98799.9n 0.68861 98800.0n 0.52444 98929.9n 0.52444 98930.0n 0.68861 99059.9n 0.68861 99060.0n 0.64370 99189.9n 0.64370 99190.0n 0.78502 99319.9n 0.78502 99320.0n 0.46859 99449.9n 0.46859 99450.0n 0.56419 99579.9n 0.56419 99580.0n 0.89441 99709.9n 0.89441 99710.0n 0.47921 99839.9n 0.47921 99840.0n 1.14927 99969.9n 1.14927 99970.0n 0.30031 100099.9n 0.30031 100100.0n -0.36668 100229.9n -0.36668 100230.0n 0.11168 100359.9n 0.11168 100360.0n 1.04662 100489.9n 1.04662 100490.0n 0.29315 100619.9n 0.29315 100620.0n 1.31038 100749.9n 1.31038 100750.0n 0.82918 100879.9n 0.82918 100880.0n 0.03541 101009.9n 0.03541 101010.0n 0.43551 101139.9n 0.43551 101140.0n -0.07007 101269.9n -0.07007 101270.0n 0.73581 101399.9n 0.73581 101400.0n 0.75921 101529.9n 0.75921 101530.0n 0.44994 101659.9n 0.44994 101660.0n 0.44934 101789.9n 0.44934 101790.0n 0.72357 101919.9n 0.72357 101920.0n 0.30498 102049.9n 0.30498 102050.0n 0.26400 102179.9n 0.26400 102180.0n 0.72924 102309.9n 0.72924 102310.0n 0.79881 102439.9n 0.79881 102440.0n 0.78502 102569.9n 0.78502 102570.0n 0.44934 102699.9n 0.44934 102700.0n 1.14927 102829.9n 1.14927 102830.0n 0.89441 102959.9n 0.89441 102960.0n 0.72924 103089.9n 0.72924 103090.0n 0.72357 103219.9n 0.72357 103220.0n 0.44994 103349.9n 0.44994 103350.0n 0.68861 103479.9n 0.68861 103480.0n 0.79881 103609.9n 0.79881 103610.0n 0.03541 103739.9n 0.03541 103740.0n 0.64370 103869.9n 0.64370 103870.0n 0.82918 103999.9n 0.82918 104000.0n 0.29315 104129.9n 0.29315 104130.0n 0.75921 104259.9n 0.75921 104260.0n 0.30498 104389.9n 0.30498 104390.0n 0.30031 104519.9n 0.30031 104520.0n -0.07007 104649.9n -0.07007 104650.0n 1.31038 104779.9n 1.31038 104780.0n 1.04662 104909.9n 1.04662 104910.0n 0.11168 105039.9n 0.11168 105040.0n 0.26400 105169.9n 0.26400 105170.0n 0.46859 105299.9n 0.46859 105300.0n 0.56419 105429.9n 0.56419 105430.0n 0.47921 105559.9n 0.47921 105560.0n 0.52444 105689.9n 0.52444 105690.0n 0.43551 105819.9n 0.43551 105820.0n 0.73581 105949.9n 0.73581 105950.0n -0.36668 106079.9n -0.36668 106080.0n 0.51492 106209.9n 0.51492 106210.0n 0.13970 106339.9n 0.13970 106340.0n 0.42258 106469.9n 0.42258 106470.0n 0.20713 106599.9n 0.20713 106600.0n 0.39910 106729.9n 0.39910 106730.0n 0.76629 106859.9n 0.76629 106860.0n 0.87516 106989.9n 0.87516 106990.0n 0.51649 107119.9n 0.51649 107120.0n 0.47728 107249.9n 0.47728 107250.0n 0.89579 107379.9n 0.89579 107380.0n 0.73813 107509.9n 0.73813 107510.0n 0.73007 107639.9n 0.73007 107640.0n 0.38805 107769.9n 0.38805 107770.0n 0.44565 107899.9n 0.44565 107900.0n 0.84972 108029.9n 0.84972 108030.0n 0.31374 108159.9n 0.31374 108160.0n 0.53500 108289.9n 0.53500 108290.0n 0.65381 108419.9n 0.65381 108420.0n 0.58828 108549.9n 0.58828 108550.0n 0.29293 108679.9n 0.29293 108680.0n 0.34864 108809.9n 0.34864 108810.0n 0.39919 108939.9n 0.39919 108940.0n 0.28504 109069.9n 0.28504 109070.0n 0.90918 109199.9n 0.90918 109200.0n -0.38855 109329.9n -0.38855 109330.0n -0.21890 109459.9n -0.21890 109460.0n -0.28851 109589.9n -0.28851 109590.0n -0.24585 109719.9n -0.24585 109720.0n 1.15208 109849.9n 1.15208 109850.0n 0.41841 109979.9n 0.41841 109980.0n 0.24338 110109.9n 0.24338 110110.0n 1.49277 110239.9n 1.49277 110240.0n 1.19260 110369.9n 1.19260 110370.0n -0.27962 110499.9n -0.27962 110500.0n 0.55733 110629.9n 0.55733 110630.0n 0.95600 110759.9n 0.95600 110760.0n -0.04710 110889.9n -0.04710 110890.0n 0.80242 111019.9n 0.80242 111020.0n 0.39736 111149.9n 0.39736 111150.0n 1.04029 111279.9n 1.04029 111280.0n 0.63149 111409.9n 0.63149 111410.0n 0.81752 111539.9n 0.81752 111540.0n 1.19808 111669.9n 1.19808 111670.0n 1.39872 111799.9n 1.39872 111800.0n 0.28119 111929.9n 0.28119 111930.0n 1.46004 112059.9n 1.46004 112060.0n -0.19303 112189.9n -0.19303 112190.0n 0.93542 112319.9n 0.93542 112320.0n 0.26400 112449.9n 0.26400 112450.0n 0.82918 112579.9n 0.82918 112580.0n -0.36668 112709.9n -0.36668 112710.0n 0.56419 112839.9n 0.56419 112840.0n 0.11168 112969.9n 0.11168 112970.0n 0.79881 113099.9n 0.79881 113100.0n 0.75921 113229.9n 0.75921 113230.0n 0.73581 113359.9n 0.73581 113360.0n 0.89441 113489.9n 0.89441 113490.0n 1.31038 113619.9n 1.31038 113620.0n 0.68861 113749.9n 0.68861 113750.0n 0.72924 113879.9n 0.72924 113880.0n 0.72357 114009.9n 0.72357 114010.0n 0.64370 114139.9n 0.64370 114140.0n 0.47921 114269.9n 0.47921 114270.0n 0.44934 114399.9n 0.44934 114400.0n 0.43551 114529.9n 0.43551 114530.0n -0.07007 114659.9n -0.07007 114660.0n 0.30498 114789.9n 0.30498 114790.0n 0.46859 114919.9n 0.46859 114920.0n 0.03541 115049.9n 0.03541 115050.0n 1.14927 115179.9n 1.14927 115180.0n 0.44994 115309.9n 0.44994 115310.0n 0.30031 115439.9n 0.30031 115440.0n 0.78502 115569.9n 0.78502 115570.0n 0.52444 115699.9n 0.52444 115700.0n 0.29315 115829.9n 0.29315 115830.0n 1.04662 115959.9n 1.04662 115960.0n 1.14927 116089.9n 1.14927 116090.0n 0.30498 116219.9n 0.30498 116220.0n 0.78502 116349.9n 0.78502 116350.0n 0.11168 116479.9n 0.11168 116480.0n 0.43551 116609.9n 0.43551 116610.0n 0.82918 116739.9n 0.82918 116740.0n 0.56419 116869.9n 0.56419 116870.0n 0.68861 116999.9n 0.68861 117000.0n 0.89441 117129.9n 0.89441 117130.0n 0.44994 117259.9n 0.44994 117260.0n 0.72924 117389.9n 0.72924 117390.0n 0.47921 117519.9n 0.47921 117520.0n 0.64370 117649.9n 0.64370 117650.0n -0.07007 117779.9n -0.07007 117780.0n 0.44934 117909.9n 0.44934 117910.0n 1.31038 118039.9n 1.31038 118040.0n 0.52444 118169.9n 0.52444 118170.0n 0.29315 118299.9n 0.29315 118300.0n 0.73581 118429.9n 0.73581 118430.0n -0.36668 118559.9n -0.36668 118560.0n 0.72357 118689.9n 0.72357 118690.0n 0.03541 118819.9n 0.03541 118820.0n 0.26400 118949.9n 0.26400 118950.0n 0.46859 119079.9n 0.46859 119080.0n 0.79881 119209.9n 0.79881 119210.0n 0.75921 119339.9n 0.75921 119340.0n 1.04662 119469.9n 1.04662 119470.0n 0.30031 119599.9n 0.30031 119600.0n 0.75921 119729.9n 0.75921 119730.0n 0.46859 119859.9n 0.46859 119860.0n 1.31038 119989.9n 1.31038 119990.0n 0.11168 120119.9n 0.11168 120120.0n 0.68861 120249.9n 0.68861 120250.0n 0.52444 120379.9n 0.52444 120380.0n 0.82918 120509.9n 0.82918 120510.0n 0.43551 120639.9n 0.43551 120640.0n -0.07007 120769.9n -0.07007 120770.0n 0.89441 120899.9n 0.89441 120900.0n 0.30498 121029.9n 0.30498 121030.0n 0.44994 121159.9n 0.44994 121160.0n 0.03541 121289.9n 0.03541 121290.0n 0.44934 121419.9n 0.44934 121420.0n 0.78502 121549.9n 0.78502 121550.0n 1.04662 121679.9n 1.04662 121680.0n 0.72924 121809.9n 0.72924 121810.0n 0.26400 121939.9n 0.26400 121940.0n 1.14927 122069.9n 1.14927 122070.0n 0.30031 122199.9n 0.30031 122200.0n 0.29315 122329.9n 0.29315 122330.0n 0.56419 122459.9n 0.56419 122460.0n 0.47921 122589.9n 0.47921 122590.0n 0.72357 122719.9n 0.72357 122720.0n -0.36668 122849.9n -0.36668 122850.0n 0.64370 122979.9n 0.64370 122980.0n 0.73581 123109.9n 0.73581 123110.0n 0.79881 123239.9n 0.79881 123240.0n 0.26400 123369.9n 0.26400 123370.0n 0.79881 123499.9n 0.79881 123500.0n 1.04662 123629.9n 1.04662 123630.0n -0.07007 123759.9n -0.07007 123760.0n 0.68861 123889.9n 0.68861 123890.0n 0.30498 124019.9n 0.30498 124020.0n 1.31038 124149.9n 1.31038 124150.0n -0.36668 124279.9n -0.36668 124280.0n 0.72357 124409.9n 0.72357 124410.0n 0.43551 124539.9n 0.43551 124540.0n 0.56419 124669.9n 0.56419 124670.0n 0.89441 124799.9n 0.89441 124800.0n 0.46859 124929.9n 0.46859 124930.0n 0.44934 125059.9n 0.44934 125060.0n 0.30031 125189.9n 0.30031 125190.0n 0.11168 125319.9n 0.11168 125320.0n 0.64370 125449.9n 0.64370 125450.0n 0.29315 125579.9n 0.29315 125580.0n 0.73581 125709.9n 0.73581 125710.0n 0.03541 125839.9n 0.03541 125840.0n 0.75921 125969.9n 0.75921 125970.0n 0.47921 126099.9n 0.47921 126100.0n 0.52444 126229.9n 0.52444 126230.0n 1.14927 126359.9n 1.14927 126360.0n 0.44994 126489.9n 0.44994 126490.0n 0.78502 126619.9n 0.78502 126620.0n 0.72924 126749.9n 0.72924 126750.0n 0.82918 126879.9n 0.82918 126880.0n 0.89441 127009.9n 0.89441 127010.0n 0.73581 127139.9n 0.73581 127140.0n 0.64370 127269.9n 0.64370 127270.0n 0.52444 127399.9n 0.52444 127400.0n 0.47921 127529.9n 0.47921 127530.0n 0.82918 127659.9n 0.82918 127660.0n 1.04662 127789.9n 1.04662 127790.0n 1.14927 127919.9n 1.14927 127920.0n 0.79881 128049.9n 0.79881 128050.0n 0.43551 128179.9n 0.43551 128180.0n 1.31038 128309.9n 1.31038 128310.0n 0.72357 128439.9n 0.72357 128440.0n -0.36668 128569.9n -0.36668 128570.0n 0.03541 128699.9n 0.03541 128700.0n 0.68861 128829.9n 0.68861 128830.0n 0.56419 128959.9n 0.56419 128960.0n 0.78502 129089.9n 0.78502 129090.0n 0.44934 129219.9n 0.44934 129220.0n 0.44994 129349.9n 0.44994 129350.0n 0.29315 129479.9n 0.29315 129480.0n -0.07007 129609.9n -0.07007 129610.0n 0.30498 129739.9n 0.30498 129740.0n 0.11168 129869.9n 0.11168 129870.0n 0.46859 129999.9n 0.46859 130000.0n 0.30031 130129.9n 0.30031 130130.0n 0.72924 130259.9n 0.72924 130260.0n 0.75921 130389.9n 0.75921 130390.0n 0.26400 130519.9n 0.26400 130520.0n -0.36668 130649.9n -0.36668 130650.0n 0.82918 130779.9n 0.82918 130780.0n 0.47921 130909.9n 0.47921 130910.0n 0.11168 131039.9n 0.11168 131040.0n 0.72357 131169.9n 0.72357 131170.0n -0.07007 131299.9n -0.07007 131300.0n 0.30031 131429.9n 0.30031 131430.0n 0.52444 131559.9n 0.52444 131560.0n 0.30498 131689.9n 0.30498 131690.0n 0.75921 131819.9n 0.75921 131820.0n 0.68861 131949.9n 0.68861 131950.0n 0.03541 132079.9n 0.03541 132080.0n 0.26400 132209.9n 0.26400 132210.0n 1.04662 132339.9n 1.04662 132340.0n 0.44934 132469.9n 0.44934 132470.0n 1.14927 132599.9n 1.14927 132600.0n 0.72924 132729.9n 0.72924 132730.0n 0.44994 132859.9n 0.44994 132860.0n 0.43551 132989.9n 0.43551 132990.0n 0.56419 133119.9n 0.56419 133120.0n 0.64370 133249.9n 0.64370 133250.0n 0.79881 133379.9n 0.79881 133380.0n 0.73581 133509.9n 0.73581 133510.0n 1.31038 133639.9n 1.31038 133640.0n 0.29315 133769.9n 0.29315 133770.0n 0.89441 133899.9n 0.89441 133900.0n 0.78502 134029.9n 0.78502 134030.0n 0.46859 134159.9n 0.46859 134160.0n 0.51492 134289.9n 0.51492 134290.0n 0.13970 134419.9n 0.13970 134420.0n 0.42258 134549.9n 0.42258 134550.0n 0.20713 134679.9n 0.20713 134680.0n 0.39910 134809.9n 0.39910 134810.0n 0.76629 134939.9n 0.76629 134940.0n 0.87516 135069.9n 0.87516 135070.0n 0.51649 135199.9n 0.51649 135200.0n 0.47728 135329.9n 0.47728 135330.0n 0.89579 135459.9n 0.89579 135460.0n 0.73813 135589.9n 0.73813 135590.0n 0.73007 135719.9n 0.73007 135720.0n 0.38805 135849.9n 0.38805 135850.0n 0.44565 135979.9n 0.44565 135980.0n 0.84972 136109.9n 0.84972 136110.0n 0.31374 136239.9n 0.31374 136240.0n 0.53500 136369.9n 0.53500 136370.0n 0.65381 136499.9n 0.65381 136500.0n 0.58828 136629.9n 0.58828 136630.0n 0.29293 136759.9n 0.29293 136760.0n 0.34864 136889.9n 0.34864 136890.0n 0.39919 137019.9n 0.39919 137020.0n 0.28504 137149.9n 0.28504 137150.0n 0.90918 137279.9n 0.90918 137280.0n -0.38855 137409.9n -0.38855 137410.0n -0.21890 137539.9n -0.21890 137540.0n -0.28851 137669.9n -0.28851 137670.0n -0.24585 137799.9n -0.24585 137800.0n 1.15208 137929.9n 1.15208 137930.0n 0.41841 138059.9n 0.41841 138060.0n 0.24338 138189.9n 0.24338 138190.0n 1.49277 138319.9n 1.49277 138320.0n 1.19260 138449.9n 1.19260 138450.0n -0.27962 138579.9n -0.27962 138580.0n 0.55733 138709.9n 0.55733 138710.0n 0.95600 138839.9n 0.95600 138840.0n -0.04710 138969.9n -0.04710 138970.0n 0.80242 139099.9n 0.80242 139100.0n 0.39736 139229.9n 0.39736 139230.0n 1.04029 139359.9n 1.04029 139360.0n 0.63149 139489.9n 0.63149 139490.0n 0.81752 139619.9n 0.81752 139620.0n 1.19808 139749.9n 1.19808 139750.0n 1.39872 139879.9n 1.39872 139880.0n 0.28119 140009.9n 0.28119 140010.0n 1.46004 140139.9n 1.46004 140140.0n -0.19303 140269.9n -0.19303 140270.0n 0.93542 140399.9n 0.93542 140400.0n 0.52444 140529.9n 0.52444 140530.0n 0.82918 140659.9n 0.82918 140660.0n 1.14927 140789.9n 1.14927 140790.0n 0.72357 140919.9n 0.72357 140920.0n 0.44994 141049.9n 0.44994 141050.0n 0.29315 141179.9n 0.29315 141180.0n 1.04662 141309.9n 1.04662 141310.0n 0.56419 141439.9n 0.56419 141440.0n 1.31038 141569.9n 1.31038 141570.0n 0.75921 141699.9n 0.75921 141700.0n 0.79881 141829.9n 0.79881 141830.0n 0.72924 141959.9n 0.72924 141960.0n -0.07007 142089.9n -0.07007 142090.0n 0.11168 142219.9n 0.11168 142220.0n 0.30498 142349.9n 0.30498 142350.0n 0.03541 142479.9n 0.03541 142480.0n 0.44934 142609.9n 0.44934 142610.0n 0.89441 142739.9n 0.89441 142740.0n 0.46859 142869.9n 0.46859 142870.0n -0.36668 142999.9n -0.36668 143000.0n 0.30031 143129.9n 0.30031 143130.0n 0.64370 143259.9n 0.64370 143260.0n 0.73581 143389.9n 0.73581 143390.0n 0.26400 143519.9n 0.26400 143520.0n 0.43551 143649.9n 0.43551 143650.0n 0.68861 143779.9n 0.68861 143780.0n 0.78502 143909.9n 0.78502 143910.0n 0.47921 144039.9n 0.47921 144040.0n -0.36668 144169.9n -0.36668 144170.0n 1.31038 144299.9n 1.31038 144300.0n 0.64370 144429.9n 0.64370 144430.0n 0.78502 144559.9n 0.78502 144560.0n 0.43551 144689.9n 0.43551 144690.0n 0.29315 144819.9n 0.29315 144820.0n 1.14927 144949.9n 1.14927 144950.0n 0.56419 145079.9n 0.56419 145080.0n 0.30498 145209.9n 0.30498 145210.0n 0.89441 145339.9n 0.89441 145340.0n 0.03541 145469.9n 0.03541 145470.0n 0.30031 145599.9n 0.30031 145600.0n 0.68861 145729.9n 0.68861 145730.0n 0.75921 145859.9n 0.75921 145860.0n -0.07007 145989.9n -0.07007 145990.0n 0.72357 146119.9n 0.72357 146120.0n 0.11168 146249.9n 0.11168 146250.0n 0.26400 146379.9n 0.26400 146380.0n 0.73581 146509.9n 0.73581 146510.0n 0.44994 146639.9n 0.44994 146640.0n 0.79881 146769.9n 0.79881 146770.0n 0.82918 146899.9n 0.82918 146900.0n 0.44934 147029.9n 0.44934 147030.0n 0.72924 147159.9n 0.72924 147160.0n 0.52444 147289.9n 0.52444 147290.0n 0.47921 147419.9n 0.47921 147420.0n 0.46859 147549.9n 0.46859 147550.0n 1.04662 147679.9n 1.04662 147680.0n 0.78502 147809.9n 0.78502 147810.0n 0.46859 147939.9n 0.46859 147940.0n 0.29315 148069.9n 0.29315 148070.0n 1.04662 148199.9n 1.04662 148200.0n 1.14927 148329.9n 1.14927 148330.0n -0.07007 148459.9n -0.07007 148460.0n -0.36668 148589.9n -0.36668 148590.0n 0.44994 148719.9n 0.44994 148720.0n 1.31038 148849.9n 1.31038 148850.0n 0.26400 148979.9n 0.26400 148980.0n 0.56419 149109.9n 0.56419 149110.0n 0.68861 149239.9n 0.68861 149240.0n 0.89441 149369.9n 0.89441 149370.0n 0.30031 149499.9n 0.30031 149500.0n 0.47921 149629.9n 0.47921 149630.0n 0.72357 149759.9n 0.72357 149760.0n 0.72924 149889.9n 0.72924 149890.0n 0.43551 150019.9n 0.43551 150020.0n 0.44934 150149.9n 0.44934 150150.0n 0.73581 150279.9n 0.73581 150280.0n 0.82918 150409.9n 0.82918 150410.0n 0.64370 150539.9n 0.64370 150540.0n 0.52444 150669.9n 0.52444 150670.0n 0.30498 150799.9n 0.30498 150800.0n 0.03541 150929.9n 0.03541 150930.0n 0.11168 151059.9n 0.11168 151060.0n 0.75921 151189.9n 0.75921 151190.0n 0.79881 151319.9n 0.79881 151320.0n 0.72357 151449.9n 0.72357 151450.0n 0.44934 151579.9n 0.44934 151580.0n 0.72924 151709.9n 0.72924 151710.0n 0.56419 151839.9n 0.56419 151840.0n 0.26400 151969.9n 0.26400 151970.0n 0.30031 152099.9n 0.30031 152100.0n 0.43551 152229.9n 0.43551 152230.0n 0.46859 152359.9n 0.46859 152360.0n 0.75921 152489.9n 0.75921 152490.0n -0.07007 152619.9n -0.07007 152620.0n 1.14927 152749.9n 1.14927 152750.0n 0.47921 152879.9n 0.47921 152880.0n 0.64370 153009.9n 0.64370 153010.0n 0.52444 153139.9n 0.52444 153140.0n 0.29315 153269.9n 0.29315 153270.0n 0.73581 153399.9n 0.73581 153400.0n 0.03541 153529.9n 0.03541 153530.0n 0.79881 153659.9n 0.79881 153660.0n 0.78502 153789.9n 0.78502 153790.0n 0.82918 153919.9n 0.82918 153920.0n 1.31038 154049.9n 1.31038 154050.0n 1.04662 154179.9n 1.04662 154180.0n 0.89441 154309.9n 0.89441 154310.0n 0.68861 154439.9n 0.68861 154440.0n 0.44994 154569.9n 0.44994 154570.0n 0.30498 154699.9n 0.30498 154700.0n -0.36668 154829.9n -0.36668 154830.0n 0.11168 154959.9n 0.11168 154960.0n 1.31038 155089.9n 1.31038 155090.0n 0.56419 155219.9n 0.56419 155220.0n 0.73581 155349.9n 0.73581 155350.0n 0.44994 155479.9n 0.44994 155480.0n 0.30498 155609.9n 0.30498 155610.0n 0.89441 155739.9n 0.89441 155740.0n 0.26400 155869.9n 0.26400 155870.0n 0.44934 155999.9n 0.44934 156000.0n 0.64370 156129.9n 0.64370 156130.0n 0.30031 156259.9n 0.30031 156260.0n 0.79881 156389.9n 0.79881 156390.0n 0.47921 156519.9n 0.47921 156520.0n -0.36668 156649.9n -0.36668 156650.0n 0.11168 156779.9n 0.11168 156780.0n 1.04662 156909.9n 1.04662 156910.0n 0.82918 157039.9n 0.82918 157040.0n 0.72924 157169.9n 0.72924 157170.0n 0.43551 157299.9n 0.43551 157300.0n 0.68861 157429.9n 0.68861 157430.0n 0.29315 157559.9n 0.29315 157560.0n 1.14927 157689.9n 1.14927 157690.0n 0.72357 157819.9n 0.72357 157820.0n 0.75921 157949.9n 0.75921 157950.0n -0.07007 158079.9n -0.07007 158080.0n 0.52444 158209.9n 0.52444 158210.0n 0.46859 158339.9n 0.46859 158340.0n 0.78502 158469.9n 0.78502 158470.0n 0.03541 158599.9n 0.03541 158600.0n 0.26400 158729.9n 0.26400 158730.0n 0.82918 158859.9n 0.82918 158860.0n 0.30498 158989.9n 0.30498 158990.0n 0.79881 159119.9n 0.79881 159120.0n 0.73581 159249.9n 0.73581 159250.0n 1.14927 159379.9n 1.14927 159380.0n 0.56419 159509.9n 0.56419 159510.0n 0.44994 159639.9n 0.44994 159640.0n 0.47921 159769.9n 0.47921 159770.0n 0.78502 159899.9n 0.78502 159900.0n 0.72357 160029.9n 0.72357 160030.0n 0.03541 160159.9n 0.03541 160160.0n -0.07007 160289.9n -0.07007 160290.0n 0.64370 160419.9n 0.64370 160420.0n 0.44934 160549.9n 0.44934 160550.0n 0.46859 160679.9n 0.46859 160680.0n 0.30031 160809.9n 0.30031 160810.0n 0.11168 160939.9n 0.11168 160940.0n 0.29315 161069.9n 0.29315 161070.0n 0.72924 161199.9n 0.72924 161200.0n 0.75921 161329.9n 0.75921 161330.0n 0.89441 161459.9n 0.89441 161460.0n 0.52444 161589.9n 0.52444 161590.0n 0.68861 161719.9n 0.68861 161720.0n 1.04662 161849.9n 1.04662 161850.0n 1.31038 161979.9n 1.31038 161980.0n 0.43551 162109.9n 0.43551 162110.0n -0.36668 162239.9n -0.36668 162240.0n 0.51492 162369.9n 0.51492 162370.0n 0.13970 162499.9n 0.13970 162500.0n 0.42258 162629.9n 0.42258 162630.0n 0.20713 162759.9n 0.20713 162760.0n 0.39910 162889.9n 0.39910 162890.0n 0.76629 163019.9n 0.76629 163020.0n 0.87516 163149.9n 0.87516 163150.0n 0.51649 163279.9n 0.51649 163280.0n 0.47728 163409.9n 0.47728 163410.0n 0.89579 163539.9n 0.89579 163540.0n 0.73813 163669.9n 0.73813 163670.0n 0.73007 163799.9n 0.73007 163800.0n 0.38805 163929.9n 0.38805 163930.0n 0.44565 164059.9n 0.44565 164060.0n 0.84972 164189.9n 0.84972 164190.0n 0.31374 164319.9n 0.31374 164320.0n 0.53500 164449.9n 0.53500 164450.0n 0.65381 164579.9n 0.65381 164580.0n 0.58828 164709.9n 0.58828 164710.0n 0.29293 164839.9n 0.29293 164840.0n 0.34864 164969.9n 0.34864 164970.0n 0.39919 165099.9n 0.39919 165100.0n 0.28504 165229.9n 0.28504 165230.0n 0.90918 165359.9n 0.90918 165360.0n -0.38855 165489.9n -0.38855 165490.0n -0.21890 165619.9n -0.21890 165620.0n -0.28851 165749.9n -0.28851 165750.0n -0.24585 165879.9n -0.24585 165880.0n 1.15208 166009.9n 1.15208 166010.0n 0.41841 166139.9n 0.41841 166140.0n 0.24338 166269.9n 0.24338 166270.0n 1.49277 166399.9n 1.49277 166400.0n 1.19260 166529.9n 1.19260 166530.0n -0.27962 166659.9n -0.27962 166660.0n 0.55733 166789.9n 0.55733 166790.0n 0.95600 166919.9n 0.95600 166920.0n -0.04710 167049.9n -0.04710 167050.0n 0.80242 167179.9n 0.80242 167180.0n 0.39736 167309.9n 0.39736 167310.0n 1.04029 167439.9n 1.04029 167440.0n 0.63149 167569.9n 0.63149 167570.0n 0.81752 167699.9n 0.81752 167700.0n 1.19808 167829.9n 1.19808 167830.0n 1.39872 167959.9n 1.39872 167960.0n 0.28119 168089.9n 0.28119 168090.0n 1.46004 168219.9n 1.46004 168220.0n -0.19303 168349.9n -0.19303 168350.0n 0.93542)
Vxp1 a_xp1 0 PWL(0.0n 1.23180 129.9n 1.23180 130.0n 0.28189 259.9n 0.28189 260.0n 0.34013 389.9n 0.34013 390.0n 0.48458 519.9n 0.48458 520.0n 0.56595 649.9n 0.56595 650.0n 0.66096 779.9n 0.66096 780.0n 1.11225 909.9n 1.11225 910.0n 1.27694 1039.9n 1.27694 1040.0n 1.17517 1169.9n 1.17517 1170.0n -0.23386 1299.9n -0.23386 1300.0n -0.21828 1429.9n -0.21828 1430.0n 0.33171 1559.9n 0.33171 1560.0n 0.70122 1689.9n 0.70122 1690.0n 0.25911 1819.9n 0.25911 1820.0n 0.13226 1949.9n 0.13226 1950.0n 0.65842 2079.9n 0.65842 2080.0n 0.63482 2209.9n 0.63482 2210.0n -0.33158 2339.9n -0.33158 2340.0n 0.76415 2469.9n 0.76415 2470.0n -0.15161 2599.9n -0.15161 2600.0n 0.28700 2729.9n 0.28700 2730.0n 0.23835 2859.9n 0.23835 2860.0n -0.37792 2989.9n -0.37792 2990.0n 1.18224 3119.9n 1.18224 3120.0n 0.67130 3249.9n 0.67130 3250.0n 0.42554 3379.9n 0.42554 3380.0n 1.28574 3509.9n 1.28574 3510.0n -0.08309 3639.9n -0.08309 3640.0n 0.65842 3769.9n 0.65842 3770.0n 1.11225 3899.9n 1.11225 3900.0n -0.23386 4029.9n -0.23386 4030.0n 0.28700 4159.9n 0.28700 4160.0n 0.56595 4289.9n 0.56595 4290.0n 0.13226 4419.9n 0.13226 4420.0n -0.37792 4549.9n -0.37792 4550.0n -0.08309 4679.9n -0.08309 4680.0n 1.27694 4809.9n 1.27694 4810.0n 0.63482 4939.9n 0.63482 4940.0n 0.76415 5069.9n 0.76415 5070.0n 0.70122 5199.9n 0.70122 5200.0n 0.34013 5329.9n 0.34013 5330.0n 0.48458 5459.9n 0.48458 5460.0n 0.28189 5589.9n 0.28189 5590.0n 0.42554 5719.9n 0.42554 5720.0n -0.21828 5849.9n -0.21828 5850.0n 1.28574 5979.9n 1.28574 5980.0n -0.15161 6109.9n -0.15161 6110.0n 1.18224 6239.9n 1.18224 6240.0n 1.17517 6369.9n 1.17517 6370.0n 0.67130 6499.9n 0.67130 6500.0n 0.25911 6629.9n 0.25911 6630.0n 0.33171 6759.9n 0.33171 6760.0n 0.23835 6889.9n 0.23835 6890.0n -0.33158 7019.9n -0.33158 7020.0n 0.66096 7149.9n 0.66096 7150.0n 1.23180 7279.9n 1.23180 7280.0n 0.23835 7409.9n 0.23835 7410.0n 0.28189 7539.9n 0.28189 7540.0n 1.18224 7669.9n 1.18224 7670.0n 0.65842 7799.9n 0.65842 7800.0n 0.34013 7929.9n 0.34013 7930.0n 0.28700 8059.9n 0.28700 8060.0n -0.15161 8189.9n -0.15161 8190.0n 0.70122 8319.9n 0.70122 8320.0n -0.37792 8449.9n -0.37792 8450.0n -0.23386 8579.9n -0.23386 8580.0n 0.42554 8709.9n 0.42554 8710.0n 1.23180 8839.9n 1.23180 8840.0n 0.63482 8969.9n 0.63482 8970.0n 1.27694 9099.9n 1.27694 9100.0n -0.08309 9229.9n -0.08309 9230.0n 0.56595 9359.9n 0.56595 9360.0n 0.66096 9489.9n 0.66096 9490.0n 1.28574 9619.9n 1.28574 9620.0n 0.67130 9749.9n 0.67130 9750.0n 0.13226 9879.9n 0.13226 9880.0n 0.33171 10009.9n 0.33171 10010.0n 0.48458 10139.9n 0.48458 10140.0n 0.25911 10269.9n 0.25911 10270.0n -0.21828 10399.9n -0.21828 10400.0n 1.11225 10529.9n 1.11225 10530.0n -0.33158 10659.9n -0.33158 10660.0n 1.17517 10789.9n 1.17517 10790.0n 0.76415 10919.9n 0.76415 10920.0n 0.13226 11049.9n 0.13226 11050.0n 0.65842 11179.9n 0.65842 11180.0n 0.25911 11309.9n 0.25911 11310.0n 0.28700 11439.9n 0.28700 11440.0n -0.08309 11569.9n -0.08309 11570.0n 0.23835 11699.9n 0.23835 11700.0n 1.18224 11829.9n 1.18224 11830.0n 1.11225 11959.9n 1.11225 11960.0n 0.56595 12089.9n 0.56595 12090.0n 1.27694 12219.9n 1.27694 12220.0n -0.37792 12349.9n -0.37792 12350.0n 0.28189 12479.9n 0.28189 12480.0n 1.23180 12609.9n 1.23180 12610.0n -0.15161 12739.9n -0.15161 12740.0n 1.17517 12869.9n 1.17517 12870.0n 1.28574 12999.9n 1.28574 13000.0n 0.48458 13129.9n 0.48458 13130.0n 0.63482 13259.9n 0.63482 13260.0n 0.34013 13389.9n 0.34013 13390.0n -0.33158 13519.9n -0.33158 13520.0n 0.33171 13649.9n 0.33171 13650.0n 0.67130 13779.9n 0.67130 13780.0n 0.66096 13909.9n 0.66096 13910.0n 0.70122 14039.9n 0.70122 14040.0n -0.23386 14169.9n -0.23386 14170.0n 0.76415 14299.9n 0.76415 14300.0n -0.21828 14429.9n -0.21828 14430.0n 0.42554 14559.9n 0.42554 14560.0n 1.18224 14689.9n 1.18224 14690.0n 0.63482 14819.9n 0.63482 14820.0n 1.17517 14949.9n 1.17517 14950.0n 1.23180 15079.9n 1.23180 15080.0n 0.48458 15209.9n 0.48458 15210.0n -0.21828 15339.9n -0.21828 15340.0n 0.33171 15469.9n 0.33171 15470.0n 0.67130 15599.9n 0.67130 15600.0n 0.66096 15729.9n 0.66096 15730.0n 1.27694 15859.9n 1.27694 15860.0n -0.08309 15989.9n -0.08309 15990.0n 0.76415 16119.9n 0.76415 16120.0n 0.42554 16249.9n 0.42554 16250.0n 0.13226 16379.9n 0.13226 16380.0n -0.15161 16509.9n -0.15161 16510.0n 0.70122 16639.9n 0.70122 16640.0n 1.11225 16769.9n 1.11225 16770.0n 0.25911 16899.9n 0.25911 16900.0n -0.23386 17029.9n -0.23386 17030.0n 0.65842 17159.9n 0.65842 17160.0n 0.23835 17289.9n 0.23835 17290.0n -0.37792 17419.9n -0.37792 17420.0n 0.28189 17549.9n 0.28189 17550.0n 1.28574 17679.9n 1.28574 17680.0n 0.28700 17809.9n 0.28700 17810.0n -0.33158 17939.9n -0.33158 17940.0n 0.34013 18069.9n 0.34013 18070.0n 0.56595 18199.9n 0.56595 18200.0n -0.21828 18329.9n -0.21828 18330.0n 1.23180 18459.9n 1.23180 18460.0n 0.76415 18589.9n 0.76415 18590.0n 0.33171 18719.9n 0.33171 18720.0n 0.56595 18849.9n 0.56595 18850.0n 0.42554 18979.9n 0.42554 18980.0n 0.67130 19109.9n 0.67130 19110.0n 1.18224 19239.9n 1.18224 19240.0n -0.37792 19369.9n -0.37792 19370.0n -0.33158 19499.9n -0.33158 19500.0n 1.28574 19629.9n 1.28574 19630.0n 0.25911 19759.9n 0.25911 19760.0n 0.28700 19889.9n 0.28700 19890.0n 0.34013 20019.9n 0.34013 20020.0n -0.15161 20149.9n -0.15161 20150.0n 0.63482 20279.9n 0.63482 20280.0n 0.13226 20409.9n 0.13226 20410.0n 0.23835 20539.9n 0.23835 20540.0n 0.65842 20669.9n 0.65842 20670.0n 0.28189 20799.9n 0.28189 20800.0n 1.11225 20929.9n 1.11225 20930.0n -0.23386 21059.9n -0.23386 21060.0n 0.66096 21189.9n 0.66096 21190.0n -0.08309 21319.9n -0.08309 21320.0n 0.48458 21449.9n 0.48458 21450.0n 1.27694 21579.9n 1.27694 21580.0n 1.17517 21709.9n 1.17517 21710.0n 0.70122 21839.9n 0.70122 21840.0n 0.29915 21969.9n 0.29915 21970.0n 0.40313 22099.9n 0.40313 22100.0n 0.36576 22229.9n 0.36576 22230.0n 0.33730 22359.9n 0.33730 22360.0n 0.38385 22489.9n 0.38385 22490.0n 0.59706 22619.9n 0.59706 22620.0n 0.62307 22749.9n 0.62307 22750.0n 0.67018 22879.9n 0.67018 22880.0n 0.70540 23009.9n 0.70540 23010.0n 0.53582 23139.9n 0.53582 23140.0n 0.33357 23269.9n 0.33357 23270.0n 0.52885 23399.9n 0.52885 23400.0n 0.74383 23529.9n 0.74383 23530.0n 0.78409 23659.9n 0.78409 23660.0n 0.51936 23789.9n 0.51936 23790.0n 0.50532 23919.9n 0.50532 23920.0n 0.68189 24049.9n 0.68189 24050.0n 0.79862 24179.9n 0.79862 24180.0n 0.35050 24309.9n 0.35050 24310.0n 0.16858 24439.9n 0.16858 24440.0n 0.55253 24569.9n 0.55253 24570.0n 0.60823 24699.9n 0.60823 24700.0n 0.63611 24829.9n 0.63611 24830.0n 0.41197 24959.9n 0.41197 24960.0n 0.59247 25089.9n 0.59247 25090.0n 1.20712 25219.9n 1.20712 25220.0n 0.87402 25349.9n 0.87402 25350.0n -0.10545 25479.9n -0.10545 25480.0n -0.25282 25609.9n -0.25282 25610.0n -0.37666 25739.9n -0.37666 25740.0n 1.43391 25869.9n 1.43391 25870.0n 0.37511 25999.9n 0.37511 26000.0n 0.35780 26129.9n 0.35780 26130.0n 1.04281 26259.9n 1.04281 26260.0n 1.30757 26389.9n 1.30757 26390.0n -0.27950 26519.9n -0.27950 26520.0n 0.10137 26649.9n 0.10137 26650.0n 1.20727 26779.9n 1.20727 26780.0n 1.40210 26909.9n 1.40210 26910.0n 1.03003 27039.9n 1.03003 27040.0n -0.27250 27169.9n -0.27250 27170.0n -0.24444 27299.9n -0.24444 27300.0n 0.81835 27429.9n 0.81835 27430.0n 0.11792 27559.9n 0.11792 27560.0n -0.41822 27689.9n -0.41822 27690.0n 0.75242 27819.9n 0.75242 27820.0n 0.57354 27949.9n 0.57354 27950.0n 1.22124 28079.9n 1.22124 28080.0n 0.33171 28209.9n 0.33171 28210.0n 0.48458 28339.9n 0.48458 28340.0n 1.18224 28469.9n 1.18224 28470.0n -0.33158 28599.9n -0.33158 28600.0n 1.28574 28729.9n 1.28574 28730.0n 0.42554 28859.9n 0.42554 28860.0n 1.23180 28989.9n 1.23180 28990.0n 1.27694 29119.9n 1.27694 29120.0n 0.25911 29249.9n 0.25911 29250.0n -0.21828 29379.9n -0.21828 29380.0n -0.08309 29509.9n -0.08309 29510.0n 0.34013 29639.9n 0.34013 29640.0n -0.23386 29769.9n -0.23386 29770.0n 0.28700 29899.9n 0.28700 29900.0n 0.70122 30029.9n 0.70122 30030.0n 1.11225 30159.9n 1.11225 30160.0n -0.37792 30289.9n -0.37792 30290.0n 1.17517 30419.9n 1.17517 30420.0n -0.15161 30549.9n -0.15161 30550.0n 0.63482 30679.9n 0.63482 30680.0n 0.23835 30809.9n 0.23835 30810.0n 0.76415 30939.9n 0.76415 30940.0n 0.67130 31069.9n 0.67130 31070.0n 0.28189 31199.9n 0.28189 31200.0n 0.56595 31329.9n 0.56595 31330.0n 0.13226 31459.9n 0.13226 31460.0n 0.65842 31589.9n 0.65842 31590.0n 0.66096 31719.9n 0.66096 31720.0n 1.11225 31849.9n 1.11225 31850.0n 0.66096 31979.9n 0.66096 31980.0n 0.48458 32109.9n 0.48458 32110.0n 0.70122 32239.9n 0.70122 32240.0n 0.63482 32369.9n 0.63482 32370.0n 0.34013 32499.9n 0.34013 32500.0n 1.23180 32629.9n 1.23180 32630.0n -0.08309 32759.9n -0.08309 32760.0n -0.33158 32889.9n -0.33158 32890.0n 0.42554 33019.9n 0.42554 33020.0n -0.21828 33149.9n -0.21828 33150.0n 1.28574 33279.9n 1.28574 33280.0n 1.27694 33409.9n 1.27694 33410.0n 1.17517 33539.9n 1.17517 33540.0n 0.25911 33669.9n 0.25911 33670.0n 1.18224 33799.9n 1.18224 33800.0n 0.33171 33929.9n 0.33171 33930.0n -0.37792 34059.9n -0.37792 34060.0n 0.65842 34189.9n 0.65842 34190.0n 0.67130 34319.9n 0.67130 34320.0n 0.23835 34449.9n 0.23835 34450.0n -0.23386 34579.9n -0.23386 34580.0n 0.28189 34709.9n 0.28189 34710.0n 0.76415 34839.9n 0.76415 34840.0n 0.13226 34969.9n 0.13226 34970.0n 0.28700 35099.9n 0.28700 35100.0n -0.15161 35229.9n -0.15161 35230.0n 0.56595 35359.9n 0.56595 35360.0n 1.28574 35489.9n 1.28574 35490.0n 0.76415 35619.9n 0.76415 35620.0n -0.37792 35749.9n -0.37792 35750.0n 1.18224 35879.9n 1.18224 35880.0n 0.34013 36009.9n 0.34013 36010.0n 1.11225 36139.9n 1.11225 36140.0n 1.27694 36269.9n 1.27694 36270.0n 0.23835 36399.9n 0.23835 36400.0n 0.65842 36529.9n 0.65842 36530.0n 0.28189 36659.9n 0.28189 36660.0n -0.33158 36789.9n -0.33158 36790.0n 1.23180 36919.9n 1.23180 36920.0n 0.13226 37049.9n 0.13226 37050.0n -0.21828 37179.9n -0.21828 37180.0n -0.15161 37309.9n -0.15161 37310.0n -0.08309 37439.9n -0.08309 37440.0n 0.63482 37569.9n 0.63482 37570.0n 0.56595 37699.9n 0.56595 37700.0n 0.33171 37829.9n 0.33171 37830.0n 0.42554 37959.9n 0.42554 37960.0n 0.48458 38089.9n 0.48458 38090.0n 0.67130 38219.9n 0.67130 38220.0n 0.25911 38349.9n 0.25911 38350.0n 0.28700 38479.9n 0.28700 38480.0n 1.17517 38609.9n 1.17517 38610.0n 0.66096 38739.9n 0.66096 38740.0n -0.23386 38869.9n -0.23386 38870.0n 0.70122 38999.9n 0.70122 39000.0n -0.21828 39129.9n -0.21828 39130.0n 0.23835 39259.9n 0.23835 39260.0n 0.70122 39389.9n 0.70122 39390.0n 0.56595 39519.9n 0.56595 39520.0n -0.08309 39649.9n -0.08309 39650.0n 0.28189 39779.9n 0.28189 39780.0n 1.27694 39909.9n 1.27694 39910.0n 1.11225 40039.9n 1.11225 40040.0n -0.23386 40169.9n -0.23386 40170.0n 0.25911 40299.9n 0.25911 40300.0n 0.33171 40429.9n 0.33171 40430.0n 0.76415 40559.9n 0.76415 40560.0n 1.18224 40689.9n 1.18224 40690.0n 0.13226 40819.9n 0.13226 40820.0n 0.63482 40949.9n 0.63482 40950.0n -0.37792 41079.9n -0.37792 41080.0n 1.28574 41209.9n 1.28574 41210.0n -0.15161 41339.9n -0.15161 41340.0n 0.65842 41469.9n 0.65842 41470.0n 0.48458 41599.9n 0.48458 41600.0n 1.17517 41729.9n 1.17517 41730.0n 0.28700 41859.9n 0.28700 41860.0n -0.33158 41989.9n -0.33158 41990.0n 0.34013 42119.9n 0.34013 42120.0n 0.66096 42249.9n 0.66096 42250.0n 0.42554 42379.9n 0.42554 42380.0n 0.67130 42509.9n 0.67130 42510.0n 1.23180 42639.9n 1.23180 42640.0n -0.15161 42769.9n -0.15161 42770.0n 0.23835 42899.9n 0.23835 42900.0n 0.70122 43029.9n 0.70122 43030.0n -0.23386 43159.9n -0.23386 43160.0n 0.63482 43289.9n 0.63482 43290.0n 0.13226 43419.9n 0.13226 43420.0n 1.18224 43549.9n 1.18224 43550.0n -0.37792 43679.9n -0.37792 43680.0n 1.17517 43809.9n 1.17517 43810.0n 1.27694 43939.9n 1.27694 43940.0n 0.67130 44069.9n 0.67130 44070.0n -0.08309 44199.9n -0.08309 44200.0n 1.28574 44329.9n 1.28574 44330.0n 0.25911 44459.9n 0.25911 44460.0n 0.48458 44589.9n 0.48458 44590.0n 0.65842 44719.9n 0.65842 44720.0n 0.76415 44849.9n 0.76415 44850.0n 1.11225 44979.9n 1.11225 44980.0n 0.34013 45109.9n 0.34013 45110.0n 0.28700 45239.9n 0.28700 45240.0n 0.28189 45369.9n 0.28189 45370.0n 0.66096 45499.9n 0.66096 45500.0n 0.56595 45629.9n 0.56595 45630.0n 0.33171 45759.9n 0.33171 45760.0n 0.42554 45889.9n 0.42554 45890.0n 1.23180 46019.9n 1.23180 46020.0n -0.33158 46149.9n -0.33158 46150.0n -0.21828 46279.9n -0.21828 46280.0n 1.28574 46409.9n 1.28574 46410.0n 0.56595 46539.9n 0.56595 46540.0n 0.34013 46669.9n 0.34013 46670.0n -0.33158 46799.9n -0.33158 46800.0n 0.28189 46929.9n 0.28189 46930.0n 0.28700 47059.9n 0.28700 47060.0n 1.17517 47189.9n 1.17517 47190.0n 0.66096 47319.9n 0.66096 47320.0n 0.65842 47449.9n 0.65842 47450.0n 0.70122 47579.9n 0.70122 47580.0n 0.63482 47709.9n 0.63482 47710.0n 0.67130 47839.9n 0.67130 47840.0n 0.25911 47969.9n 0.25911 47970.0n -0.23386 48099.9n -0.23386 48100.0n 0.23835 48229.9n 0.23835 48230.0n -0.21828 48359.9n -0.21828 48360.0n 0.48458 48489.9n 0.48458 48490.0n 1.18224 48619.9n 1.18224 48620.0n 1.27694 48749.9n 1.27694 48750.0n 0.13226 48879.9n 0.13226 48880.0n -0.37792 49009.9n -0.37792 49010.0n -0.15161 49139.9n -0.15161 49140.0n 0.76415 49269.9n 0.76415 49270.0n 1.23180 49399.9n 1.23180 49400.0n 0.42554 49529.9n 0.42554 49530.0n 1.11225 49659.9n 1.11225 49660.0n 0.33171 49789.9n 0.33171 49790.0n -0.08309 49919.9n -0.08309 49920.0n 0.29915 50049.9n 0.29915 50050.0n 0.40313 50179.9n 0.40313 50180.0n 0.36576 50309.9n 0.36576 50310.0n 0.33730 50439.9n 0.33730 50440.0n 0.38385 50569.9n 0.38385 50570.0n 0.59706 50699.9n 0.59706 50700.0n 0.62307 50829.9n 0.62307 50830.0n 0.67018 50959.9n 0.67018 50960.0n 0.70540 51089.9n 0.70540 51090.0n 0.53582 51219.9n 0.53582 51220.0n 0.33357 51349.9n 0.33357 51350.0n 0.52885 51479.9n 0.52885 51480.0n 0.74383 51609.9n 0.74383 51610.0n 0.78409 51739.9n 0.78409 51740.0n 0.51936 51869.9n 0.51936 51870.0n 0.50532 51999.9n 0.50532 52000.0n 0.68189 52129.9n 0.68189 52130.0n 0.79862 52259.9n 0.79862 52260.0n 0.35050 52389.9n 0.35050 52390.0n 0.16858 52519.9n 0.16858 52520.0n 0.55253 52649.9n 0.55253 52650.0n 0.60823 52779.9n 0.60823 52780.0n 0.63611 52909.9n 0.63611 52910.0n 0.41197 53039.9n 0.41197 53040.0n 0.59247 53169.9n 0.59247 53170.0n 1.20712 53299.9n 1.20712 53300.0n 0.87402 53429.9n 0.87402 53430.0n -0.10545 53559.9n -0.10545 53560.0n -0.25282 53689.9n -0.25282 53690.0n -0.37666 53819.9n -0.37666 53820.0n 1.43391 53949.9n 1.43391 53950.0n 0.37511 54079.9n 0.37511 54080.0n 0.35780 54209.9n 0.35780 54210.0n 1.04281 54339.9n 1.04281 54340.0n 1.30757 54469.9n 1.30757 54470.0n -0.27950 54599.9n -0.27950 54600.0n 0.10137 54729.9n 0.10137 54730.0n 1.20727 54859.9n 1.20727 54860.0n 1.40210 54989.9n 1.40210 54990.0n 1.03003 55119.9n 1.03003 55120.0n -0.27250 55249.9n -0.27250 55250.0n -0.24444 55379.9n -0.24444 55380.0n 0.81835 55509.9n 0.81835 55510.0n 0.11792 55639.9n 0.11792 55640.0n -0.41822 55769.9n -0.41822 55770.0n 0.75242 55899.9n 0.75242 55900.0n 0.57354 56029.9n 0.57354 56030.0n 1.22124 56159.9n 1.22124 56160.0n 0.25911 56289.9n 0.25911 56290.0n 0.67130 56419.9n 0.67130 56420.0n -0.33158 56549.9n -0.33158 56550.0n -0.21828 56679.9n -0.21828 56680.0n -0.08309 56809.9n -0.08309 56810.0n 0.33171 56939.9n 0.33171 56940.0n 0.63482 57069.9n 0.63482 57070.0n 1.11225 57199.9n 1.11225 57200.0n 0.13226 57329.9n 0.13226 57330.0n 1.28574 57459.9n 1.28574 57460.0n 0.42554 57589.9n 0.42554 57590.0n 0.56595 57719.9n 0.56595 57720.0n 0.76415 57849.9n 0.76415 57850.0n 1.17517 57979.9n 1.17517 57980.0n 0.65842 58109.9n 0.65842 58110.0n 0.66096 58239.9n 0.66096 58240.0n 0.70122 58369.9n 0.70122 58370.0n -0.23386 58499.9n -0.23386 58500.0n 0.28189 58629.9n 0.28189 58630.0n 1.27694 58759.9n 1.27694 58760.0n -0.37792 58889.9n -0.37792 58890.0n 0.28700 59019.9n 0.28700 59020.0n 1.18224 59149.9n 1.18224 59150.0n -0.15161 59279.9n -0.15161 59280.0n 0.34013 59409.9n 0.34013 59410.0n 0.23835 59539.9n 0.23835 59540.0n 0.48458 59669.9n 0.48458 59670.0n 1.23180 59799.9n 1.23180 59800.0n 0.28700 59929.9n 0.28700 59930.0n 0.65842 60059.9n 0.65842 60060.0n 1.17517 60189.9n 1.17517 60190.0n 0.56595 60319.9n 0.56595 60320.0n 0.66096 60449.9n 0.66096 60450.0n 0.70122 60579.9n 0.70122 60580.0n 0.25911 60709.9n 0.25911 60710.0n 0.13226 60839.9n 0.13226 60840.0n 0.63482 60969.9n 0.63482 60970.0n 0.76415 61099.9n 0.76415 61100.0n 0.23835 61229.9n 0.23835 61230.0n 1.23180 61359.9n 1.23180 61360.0n 1.18224 61489.9n 1.18224 61490.0n 0.48458 61619.9n 0.48458 61620.0n 0.28189 61749.9n 0.28189 61750.0n 1.28574 61879.9n 1.28574 61880.0n 0.42554 62009.9n 0.42554 62010.0n 0.33171 62139.9n 0.33171 62140.0n 0.67130 62269.9n 0.67130 62270.0n -0.15161 62399.9n -0.15161 62400.0n 1.27694 62529.9n 1.27694 62530.0n -0.23386 62659.9n -0.23386 62660.0n -0.08309 62789.9n -0.08309 62790.0n 1.11225 62919.9n 1.11225 62920.0n -0.37792 63049.9n -0.37792 63050.0n -0.21828 63179.9n -0.21828 63180.0n -0.33158 63309.9n -0.33158 63310.0n 0.34013 63439.9n 0.34013 63440.0n 0.28700 63569.9n 0.28700 63570.0n 0.28189 63699.9n 0.28189 63700.0n -0.08309 63829.9n -0.08309 63830.0n 1.23180 63959.9n 1.23180 63960.0n 1.17517 64089.9n 1.17517 64090.0n 0.34013 64219.9n 0.34013 64220.0n -0.23386 64349.9n -0.23386 64350.0n 0.67130 64479.9n 0.67130 64480.0n 1.18224 64609.9n 1.18224 64610.0n 0.63482 64739.9n 0.63482 64740.0n -0.33158 64869.9n -0.33158 64870.0n 1.11225 64999.9n 1.11225 65000.0n -0.15161 65129.9n -0.15161 65130.0n 0.76415 65259.9n 0.76415 65260.0n 1.27694 65389.9n 1.27694 65390.0n 1.28574 65519.9n 1.28574 65520.0n 0.70122 65649.9n 0.70122 65650.0n 0.33171 65779.9n 0.33171 65780.0n 0.42554 65909.9n 0.42554 65910.0n 0.65842 66039.9n 0.65842 66040.0n 0.23835 66169.9n 0.23835 66170.0n 0.66096 66299.9n 0.66096 66300.0n 0.48458 66429.9n 0.48458 66430.0n 0.25911 66559.9n 0.25911 66560.0n 0.13226 66689.9n 0.13226 66690.0n 0.56595 66819.9n 0.56595 66820.0n -0.37792 66949.9n -0.37792 66950.0n -0.21828 67079.9n -0.21828 67080.0n 0.23835 67209.9n 0.23835 67210.0n -0.33158 67339.9n -0.33158 67340.0n 1.27694 67469.9n 1.27694 67470.0n -0.21828 67599.9n -0.21828 67600.0n 0.76415 67729.9n 0.76415 67730.0n 0.66096 67859.9n 0.66096 67860.0n 0.13226 67989.9n 0.13226 67990.0n -0.23386 68119.9n -0.23386 68120.0n 0.25911 68249.9n 0.25911 68250.0n 0.63482 68379.9n 0.63482 68380.0n 0.70122 68509.9n 0.70122 68510.0n 1.28574 68639.9n 1.28574 68640.0n 0.42554 68769.9n 0.42554 68770.0n 0.33171 68899.9n 0.33171 68900.0n 1.11225 69029.9n 1.11225 69030.0n -0.15161 69159.9n -0.15161 69160.0n 0.28189 69289.9n 0.28189 69290.0n 1.18224 69419.9n 1.18224 69420.0n 0.28700 69549.9n 0.28700 69550.0n -0.37792 69679.9n -0.37792 69680.0n 0.34013 69809.9n 0.34013 69810.0n 0.56595 69939.9n 0.56595 69940.0n 0.67130 70069.9n 0.67130 70070.0n 1.23180 70199.9n 1.23180 70200.0n -0.08309 70329.9n -0.08309 70330.0n 0.65842 70459.9n 0.65842 70460.0n 1.17517 70589.9n 1.17517 70590.0n 0.48458 70719.9n 0.48458 70720.0n 1.17517 70849.9n 1.17517 70850.0n 0.76415 70979.9n 0.76415 70980.0n -0.23386 71109.9n -0.23386 71110.0n 0.34013 71239.9n 0.34013 71240.0n 1.18224 71369.9n 1.18224 71370.0n 0.66096 71499.9n 0.66096 71500.0n -0.15161 71629.9n -0.15161 71630.0n 1.11225 71759.9n 1.11225 71760.0n 0.23835 71889.9n 0.23835 71890.0n 0.33171 72019.9n 0.33171 72020.0n 0.25911 72149.9n 0.25911 72150.0n 1.27694 72279.9n 1.27694 72280.0n 0.65842 72409.9n 0.65842 72410.0n 1.23180 72539.9n 1.23180 72540.0n -0.08309 72669.9n -0.08309 72670.0n -0.37792 72799.9n -0.37792 72800.0n 0.28700 72929.9n 0.28700 72930.0n 0.48458 73059.9n 0.48458 73060.0n 0.42554 73189.9n 0.42554 73190.0n 0.56595 73319.9n 0.56595 73320.0n 0.70122 73449.9n 0.70122 73450.0n -0.33158 73579.9n -0.33158 73580.0n 0.13226 73709.9n 0.13226 73710.0n 0.67130 73839.9n 0.67130 73840.0n 1.28574 73969.9n 1.28574 73970.0n -0.21828 74099.9n -0.21828 74100.0n 0.28189 74229.9n 0.28189 74230.0n 0.63482 74359.9n 0.63482 74360.0n -0.37792 74489.9n -0.37792 74490.0n -0.08309 74619.9n -0.08309 74620.0n 1.11225 74749.9n 1.11225 74750.0n 0.56595 74879.9n 0.56595 74880.0n 0.66096 75009.9n 0.66096 75010.0n 0.48458 75139.9n 0.48458 75140.0n 1.28574 75269.9n 1.28574 75270.0n 0.28700 75399.9n 0.28700 75400.0n 0.23835 75529.9n 0.23835 75530.0n 0.28189 75659.9n 0.28189 75660.0n 0.13226 75789.9n 0.13226 75790.0n 0.76415 75919.9n 0.76415 75920.0n 0.34013 76049.9n 0.34013 76050.0n 0.65842 76179.9n 0.65842 76180.0n -0.21828 76309.9n -0.21828 76310.0n -0.33158 76439.9n -0.33158 76440.0n 0.42554 76569.9n 0.42554 76570.0n -0.23386 76699.9n -0.23386 76700.0n 0.70122 76829.9n 0.70122 76830.0n -0.15161 76959.9n -0.15161 76960.0n 1.27694 77089.9n 1.27694 77090.0n 0.63482 77219.9n 0.63482 77220.0n 0.25911 77349.9n 0.25911 77350.0n 0.33171 77479.9n 0.33171 77480.0n 1.18224 77609.9n 1.18224 77610.0n 1.23180 77739.9n 1.23180 77740.0n 0.67130 77869.9n 0.67130 77870.0n 1.17517 77999.9n 1.17517 78000.0n 0.29915 78129.9n 0.29915 78130.0n 0.40313 78259.9n 0.40313 78260.0n 0.36576 78389.9n 0.36576 78390.0n 0.33730 78519.9n 0.33730 78520.0n 0.38385 78649.9n 0.38385 78650.0n 0.59706 78779.9n 0.59706 78780.0n 0.62307 78909.9n 0.62307 78910.0n 0.67018 79039.9n 0.67018 79040.0n 0.70540 79169.9n 0.70540 79170.0n 0.53582 79299.9n 0.53582 79300.0n 0.33357 79429.9n 0.33357 79430.0n 0.52885 79559.9n 0.52885 79560.0n 0.74383 79689.9n 0.74383 79690.0n 0.78409 79819.9n 0.78409 79820.0n 0.51936 79949.9n 0.51936 79950.0n 0.50532 80079.9n 0.50532 80080.0n 0.68189 80209.9n 0.68189 80210.0n 0.79862 80339.9n 0.79862 80340.0n 0.35050 80469.9n 0.35050 80470.0n 0.16858 80599.9n 0.16858 80600.0n 0.55253 80729.9n 0.55253 80730.0n 0.60823 80859.9n 0.60823 80860.0n 0.63611 80989.9n 0.63611 80990.0n 0.41197 81119.9n 0.41197 81120.0n 0.59247 81249.9n 0.59247 81250.0n 1.20712 81379.9n 1.20712 81380.0n 0.87402 81509.9n 0.87402 81510.0n -0.10545 81639.9n -0.10545 81640.0n -0.25282 81769.9n -0.25282 81770.0n -0.37666 81899.9n -0.37666 81900.0n 1.43391 82029.9n 1.43391 82030.0n 0.37511 82159.9n 0.37511 82160.0n 0.35780 82289.9n 0.35780 82290.0n 1.04281 82419.9n 1.04281 82420.0n 1.30757 82549.9n 1.30757 82550.0n -0.27950 82679.9n -0.27950 82680.0n 0.10137 82809.9n 0.10137 82810.0n 1.20727 82939.9n 1.20727 82940.0n 1.40210 83069.9n 1.40210 83070.0n 1.03003 83199.9n 1.03003 83200.0n -0.27250 83329.9n -0.27250 83330.0n -0.24444 83459.9n -0.24444 83460.0n 0.81835 83589.9n 0.81835 83590.0n 0.11792 83719.9n 0.11792 83720.0n -0.41822 83849.9n -0.41822 83850.0n 0.75242 83979.9n 0.75242 83980.0n 0.57354 84109.9n 0.57354 84110.0n 1.22124 84239.9n 1.22124 84240.0n 0.48458 84369.9n 0.48458 84370.0n 0.56595 84499.9n 0.56595 84500.0n 0.70122 84629.9n 0.70122 84630.0n -0.23386 84759.9n -0.23386 84760.0n 0.65842 84889.9n 0.65842 84890.0n 0.25911 85019.9n 0.25911 85020.0n 1.23180 85149.9n 1.23180 85150.0n 1.18224 85279.9n 1.18224 85280.0n 0.66096 85409.9n 0.66096 85410.0n 0.76415 85539.9n 0.76415 85540.0n 0.63482 85669.9n 0.63482 85670.0n -0.37792 85799.9n -0.37792 85800.0n 0.42554 85929.9n 0.42554 85930.0n 1.27694 86059.9n 1.27694 86060.0n 1.28574 86189.9n 1.28574 86190.0n 0.28700 86319.9n 0.28700 86320.0n 0.67130 86449.9n 0.67130 86450.0n 0.34013 86579.9n 0.34013 86580.0n 0.13226 86709.9n 0.13226 86710.0n -0.08309 86839.9n -0.08309 86840.0n -0.21828 86969.9n -0.21828 86970.0n -0.15161 87099.9n -0.15161 87100.0n 1.17517 87229.9n 1.17517 87230.0n 1.11225 87359.9n 1.11225 87360.0n 0.28189 87489.9n 0.28189 87490.0n -0.33158 87619.9n -0.33158 87620.0n 0.23835 87749.9n 0.23835 87750.0n 0.33171 87879.9n 0.33171 87880.0n 0.34013 88009.9n 0.34013 88010.0n -0.08309 88139.9n -0.08309 88140.0n 0.42554 88269.9n 0.42554 88270.0n 0.48458 88399.9n 0.48458 88400.0n -0.23386 88529.9n -0.23386 88530.0n 0.66096 88659.9n 0.66096 88660.0n 1.17517 88789.9n 1.17517 88790.0n 0.28189 88919.9n 0.28189 88920.0n 0.67130 89049.9n 0.67130 89050.0n 0.65842 89179.9n 0.65842 89180.0n 0.70122 89309.9n 0.70122 89310.0n 1.27694 89439.9n 1.27694 89440.0n 0.28700 89569.9n 0.28700 89570.0n 1.18224 89699.9n 1.18224 89700.0n 1.11225 89829.9n 1.11225 89830.0n -0.21828 89959.9n -0.21828 89960.0n 0.13226 90089.9n 0.13226 90090.0n 0.23835 90219.9n 0.23835 90220.0n 0.63482 90349.9n 0.63482 90350.0n -0.33158 90479.9n -0.33158 90480.0n 0.76415 90609.9n 0.76415 90610.0n 0.33171 90739.9n 0.33171 90740.0n -0.15161 90869.9n -0.15161 90870.0n -0.37792 90999.9n -0.37792 91000.0n 1.23180 91129.9n 1.23180 91130.0n 1.28574 91259.9n 1.28574 91260.0n 0.56595 91389.9n 0.56595 91390.0n 0.25911 91519.9n 0.25911 91520.0n -0.37792 91649.9n -0.37792 91650.0n 1.23180 91779.9n 1.23180 91780.0n 1.27694 91909.9n 1.27694 91910.0n 0.63482 92039.9n 0.63482 92040.0n 0.42554 92169.9n 0.42554 92170.0n -0.23386 92299.9n -0.23386 92300.0n 1.28574 92429.9n 1.28574 92430.0n 0.23835 92559.9n 0.23835 92560.0n -0.08309 92689.9n -0.08309 92690.0n 0.76415 92819.9n 0.76415 92820.0n 0.25911 92949.9n 0.25911 92950.0n 0.48458 93079.9n 0.48458 93080.0n -0.33158 93209.9n -0.33158 93210.0n 0.66096 93339.9n 0.66096 93340.0n 0.13226 93469.9n 0.13226 93470.0n -0.15161 93599.9n -0.15161 93600.0n 0.70122 93729.9n 0.70122 93730.0n 0.34013 93859.9n 0.34013 93860.0n -0.21828 93989.9n -0.21828 93990.0n 0.65842 94119.9n 0.65842 94120.0n 1.11225 94249.9n 1.11225 94250.0n 0.56595 94379.9n 0.56595 94380.0n 1.18224 94509.9n 1.18224 94510.0n 1.17517 94639.9n 1.17517 94640.0n 0.28700 94769.9n 0.28700 94770.0n 0.33171 94899.9n 0.33171 94900.0n 0.67130 95029.9n 0.67130 95030.0n 0.28189 95159.9n 0.28189 95160.0n 0.23835 95289.9n 0.23835 95290.0n 0.76415 95419.9n 0.76415 95420.0n 1.23180 95549.9n 1.23180 95550.0n 1.28574 95679.9n 1.28574 95680.0n 0.33171 95809.9n 0.33171 95810.0n 0.63482 95939.9n 0.63482 95940.0n 0.28700 96069.9n 0.28700 96070.0n 1.18224 96199.9n 1.18224 96200.0n 0.56595 96329.9n 0.56595 96330.0n -0.37792 96459.9n -0.37792 96460.0n -0.15161 96589.9n -0.15161 96590.0n 0.42554 96719.9n 0.42554 96720.0n -0.21828 96849.9n -0.21828 96850.0n 0.28189 96979.9n 0.28189 96980.0n 0.65842 97109.9n 0.65842 97110.0n 0.48458 97239.9n 0.48458 97240.0n 1.27694 97369.9n 1.27694 97370.0n 1.11225 97499.9n 1.11225 97500.0n 0.13226 97629.9n 0.13226 97630.0n -0.23386 97759.9n -0.23386 97760.0n 1.17517 97889.9n 1.17517 97890.0n 0.34013 98019.9n 0.34013 98020.0n 0.25911 98149.9n 0.25911 98150.0n 0.67130 98279.9n 0.67130 98280.0n 0.66096 98409.9n 0.66096 98410.0n -0.33158 98539.9n -0.33158 98540.0n -0.08309 98669.9n -0.08309 98670.0n 0.70122 98799.9n 0.70122 98800.0n -0.37792 98929.9n -0.37792 98930.0n 0.70122 99059.9n 0.70122 99060.0n 0.42554 99189.9n 0.42554 99190.0n 0.65842 99319.9n 0.65842 99320.0n -0.21828 99449.9n -0.21828 99450.0n 0.67130 99579.9n 0.67130 99580.0n 1.11225 99709.9n 1.11225 99710.0n 0.34013 99839.9n 0.34013 99840.0n 1.17517 99969.9n 1.17517 99970.0n 1.23180 100099.9n 1.23180 100100.0n 0.13226 100229.9n 0.13226 100230.0n -0.08309 100359.9n -0.08309 100360.0n 1.18224 100489.9n 1.18224 100490.0n 0.33171 100619.9n 0.33171 100620.0n 0.28700 100749.9n 0.28700 100750.0n 0.66096 100879.9n 0.66096 100880.0n -0.33158 101009.9n -0.33158 101010.0n 0.28189 101139.9n 0.28189 101140.0n 1.28574 101269.9n 1.28574 101270.0n -0.15161 101399.9n -0.15161 101400.0n 0.56595 101529.9n 0.56595 101530.0n 0.63482 101659.9n 0.63482 101660.0n 0.76415 101789.9n 0.76415 101790.0n -0.23386 101919.9n -0.23386 101920.0n 0.48458 102049.9n 0.48458 102050.0n 0.23835 102179.9n 0.23835 102180.0n 1.27694 102309.9n 1.27694 102310.0n 0.25911 102439.9n 0.25911 102440.0n 0.65842 102569.9n 0.65842 102570.0n 0.76415 102699.9n 0.76415 102700.0n 1.17517 102829.9n 1.17517 102830.0n 1.11225 102959.9n 1.11225 102960.0n 1.27694 103089.9n 1.27694 103090.0n -0.23386 103219.9n -0.23386 103220.0n 0.63482 103349.9n 0.63482 103350.0n 0.70122 103479.9n 0.70122 103480.0n 0.25911 103609.9n 0.25911 103610.0n -0.33158 103739.9n -0.33158 103740.0n 0.42554 103869.9n 0.42554 103870.0n 0.66096 103999.9n 0.66096 104000.0n 0.33171 104129.9n 0.33171 104130.0n 0.56595 104259.9n 0.56595 104260.0n 0.48458 104389.9n 0.48458 104390.0n 1.23180 104519.9n 1.23180 104520.0n 1.28574 104649.9n 1.28574 104650.0n 0.28700 104779.9n 0.28700 104780.0n 1.18224 104909.9n 1.18224 104910.0n -0.08309 105039.9n -0.08309 105040.0n 0.23835 105169.9n 0.23835 105170.0n -0.21828 105299.9n -0.21828 105300.0n 0.67130 105429.9n 0.67130 105430.0n 0.34013 105559.9n 0.34013 105560.0n -0.37792 105689.9n -0.37792 105690.0n 0.28189 105819.9n 0.28189 105820.0n -0.15161 105949.9n -0.15161 105950.0n 0.13226 106079.9n 0.13226 106080.0n 0.29915 106209.9n 0.29915 106210.0n 0.40313 106339.9n 0.40313 106340.0n 0.36576 106469.9n 0.36576 106470.0n 0.33730 106599.9n 0.33730 106600.0n 0.38385 106729.9n 0.38385 106730.0n 0.59706 106859.9n 0.59706 106860.0n 0.62307 106989.9n 0.62307 106990.0n 0.67018 107119.9n 0.67018 107120.0n 0.70540 107249.9n 0.70540 107250.0n 0.53582 107379.9n 0.53582 107380.0n 0.33357 107509.9n 0.33357 107510.0n 0.52885 107639.9n 0.52885 107640.0n 0.74383 107769.9n 0.74383 107770.0n 0.78409 107899.9n 0.78409 107900.0n 0.51936 108029.9n 0.51936 108030.0n 0.50532 108159.9n 0.50532 108160.0n 0.68189 108289.9n 0.68189 108290.0n 0.79862 108419.9n 0.79862 108420.0n 0.35050 108549.9n 0.35050 108550.0n 0.16858 108679.9n 0.16858 108680.0n 0.55253 108809.9n 0.55253 108810.0n 0.60823 108939.9n 0.60823 108940.0n 0.63611 109069.9n 0.63611 109070.0n 0.41197 109199.9n 0.41197 109200.0n 0.59247 109329.9n 0.59247 109330.0n 1.20712 109459.9n 1.20712 109460.0n 0.87402 109589.9n 0.87402 109590.0n -0.10545 109719.9n -0.10545 109720.0n -0.25282 109849.9n -0.25282 109850.0n -0.37666 109979.9n -0.37666 109980.0n 1.43391 110109.9n 1.43391 110110.0n 0.37511 110239.9n 0.37511 110240.0n 0.35780 110369.9n 0.35780 110370.0n 1.04281 110499.9n 1.04281 110500.0n 1.30757 110629.9n 1.30757 110630.0n -0.27950 110759.9n -0.27950 110760.0n 0.10137 110889.9n 0.10137 110890.0n 1.20727 111019.9n 1.20727 111020.0n 1.40210 111149.9n 1.40210 111150.0n 1.03003 111279.9n 1.03003 111280.0n -0.27250 111409.9n -0.27250 111410.0n -0.24444 111539.9n -0.24444 111540.0n 0.81835 111669.9n 0.81835 111670.0n 0.11792 111799.9n 0.11792 111800.0n -0.41822 111929.9n -0.41822 111930.0n 0.75242 112059.9n 0.75242 112060.0n 0.57354 112189.9n 0.57354 112190.0n 1.22124 112319.9n 1.22124 112320.0n 0.23835 112449.9n 0.23835 112450.0n 0.66096 112579.9n 0.66096 112580.0n 0.13226 112709.9n 0.13226 112710.0n 0.67130 112839.9n 0.67130 112840.0n -0.08309 112969.9n -0.08309 112970.0n 0.25911 113099.9n 0.25911 113100.0n 0.56595 113229.9n 0.56595 113230.0n -0.15161 113359.9n -0.15161 113360.0n 1.11225 113489.9n 1.11225 113490.0n 0.28700 113619.9n 0.28700 113620.0n 0.70122 113749.9n 0.70122 113750.0n 1.27694 113879.9n 1.27694 113880.0n -0.23386 114009.9n -0.23386 114010.0n 0.42554 114139.9n 0.42554 114140.0n 0.34013 114269.9n 0.34013 114270.0n 0.76415 114399.9n 0.76415 114400.0n 0.28189 114529.9n 0.28189 114530.0n 1.28574 114659.9n 1.28574 114660.0n 0.48458 114789.9n 0.48458 114790.0n -0.21828 114919.9n -0.21828 114920.0n -0.33158 115049.9n -0.33158 115050.0n 1.17517 115179.9n 1.17517 115180.0n 0.63482 115309.9n 0.63482 115310.0n 1.23180 115439.9n 1.23180 115440.0n 0.65842 115569.9n 0.65842 115570.0n -0.37792 115699.9n -0.37792 115700.0n 0.33171 115829.9n 0.33171 115830.0n 1.18224 115959.9n 1.18224 115960.0n 1.17517 116089.9n 1.17517 116090.0n 0.48458 116219.9n 0.48458 116220.0n 0.65842 116349.9n 0.65842 116350.0n -0.08309 116479.9n -0.08309 116480.0n 0.28189 116609.9n 0.28189 116610.0n 0.66096 116739.9n 0.66096 116740.0n 0.67130 116869.9n 0.67130 116870.0n 0.70122 116999.9n 0.70122 117000.0n 1.11225 117129.9n 1.11225 117130.0n 0.63482 117259.9n 0.63482 117260.0n 1.27694 117389.9n 1.27694 117390.0n 0.34013 117519.9n 0.34013 117520.0n 0.42554 117649.9n 0.42554 117650.0n 1.28574 117779.9n 1.28574 117780.0n 0.76415 117909.9n 0.76415 117910.0n 0.28700 118039.9n 0.28700 118040.0n -0.37792 118169.9n -0.37792 118170.0n 0.33171 118299.9n 0.33171 118300.0n -0.15161 118429.9n -0.15161 118430.0n 0.13226 118559.9n 0.13226 118560.0n -0.23386 118689.9n -0.23386 118690.0n -0.33158 118819.9n -0.33158 118820.0n 0.23835 118949.9n 0.23835 118950.0n -0.21828 119079.9n -0.21828 119080.0n 0.25911 119209.9n 0.25911 119210.0n 0.56595 119339.9n 0.56595 119340.0n 1.18224 119469.9n 1.18224 119470.0n 1.23180 119599.9n 1.23180 119600.0n 0.56595 119729.9n 0.56595 119730.0n -0.21828 119859.9n -0.21828 119860.0n 0.28700 119989.9n 0.28700 119990.0n -0.08309 120119.9n -0.08309 120120.0n 0.70122 120249.9n 0.70122 120250.0n -0.37792 120379.9n -0.37792 120380.0n 0.66096 120509.9n 0.66096 120510.0n 0.28189 120639.9n 0.28189 120640.0n 1.28574 120769.9n 1.28574 120770.0n 1.11225 120899.9n 1.11225 120900.0n 0.48458 121029.9n 0.48458 121030.0n 0.63482 121159.9n 0.63482 121160.0n -0.33158 121289.9n -0.33158 121290.0n 0.76415 121419.9n 0.76415 121420.0n 0.65842 121549.9n 0.65842 121550.0n 1.18224 121679.9n 1.18224 121680.0n 1.27694 121809.9n 1.27694 121810.0n 0.23835 121939.9n 0.23835 121940.0n 1.17517 122069.9n 1.17517 122070.0n 1.23180 122199.9n 1.23180 122200.0n 0.33171 122329.9n 0.33171 122330.0n 0.67130 122459.9n 0.67130 122460.0n 0.34013 122589.9n 0.34013 122590.0n -0.23386 122719.9n -0.23386 122720.0n 0.13226 122849.9n 0.13226 122850.0n 0.42554 122979.9n 0.42554 122980.0n -0.15161 123109.9n -0.15161 123110.0n 0.25911 123239.9n 0.25911 123240.0n 0.23835 123369.9n 0.23835 123370.0n 0.25911 123499.9n 0.25911 123500.0n 1.18224 123629.9n 1.18224 123630.0n 1.28574 123759.9n 1.28574 123760.0n 0.70122 123889.9n 0.70122 123890.0n 0.48458 124019.9n 0.48458 124020.0n 0.28700 124149.9n 0.28700 124150.0n 0.13226 124279.9n 0.13226 124280.0n -0.23386 124409.9n -0.23386 124410.0n 0.28189 124539.9n 0.28189 124540.0n 0.67130 124669.9n 0.67130 124670.0n 1.11225 124799.9n 1.11225 124800.0n -0.21828 124929.9n -0.21828 124930.0n 0.76415 125059.9n 0.76415 125060.0n 1.23180 125189.9n 1.23180 125190.0n -0.08309 125319.9n -0.08309 125320.0n 0.42554 125449.9n 0.42554 125450.0n 0.33171 125579.9n 0.33171 125580.0n -0.15161 125709.9n -0.15161 125710.0n -0.33158 125839.9n -0.33158 125840.0n 0.56595 125969.9n 0.56595 125970.0n 0.34013 126099.9n 0.34013 126100.0n -0.37792 126229.9n -0.37792 126230.0n 1.17517 126359.9n 1.17517 126360.0n 0.63482 126489.9n 0.63482 126490.0n 0.65842 126619.9n 0.65842 126620.0n 1.27694 126749.9n 1.27694 126750.0n 0.66096 126879.9n 0.66096 126880.0n 1.11225 127009.9n 1.11225 127010.0n -0.15161 127139.9n -0.15161 127140.0n 0.42554 127269.9n 0.42554 127270.0n -0.37792 127399.9n -0.37792 127400.0n 0.34013 127529.9n 0.34013 127530.0n 0.66096 127659.9n 0.66096 127660.0n 1.18224 127789.9n 1.18224 127790.0n 1.17517 127919.9n 1.17517 127920.0n 0.25911 128049.9n 0.25911 128050.0n 0.28189 128179.9n 0.28189 128180.0n 0.28700 128309.9n 0.28700 128310.0n -0.23386 128439.9n -0.23386 128440.0n 0.13226 128569.9n 0.13226 128570.0n -0.33158 128699.9n -0.33158 128700.0n 0.70122 128829.9n 0.70122 128830.0n 0.67130 128959.9n 0.67130 128960.0n 0.65842 129089.9n 0.65842 129090.0n 0.76415 129219.9n 0.76415 129220.0n 0.63482 129349.9n 0.63482 129350.0n 0.33171 129479.9n 0.33171 129480.0n 1.28574 129609.9n 1.28574 129610.0n 0.48458 129739.9n 0.48458 129740.0n -0.08309 129869.9n -0.08309 129870.0n -0.21828 129999.9n -0.21828 130000.0n 1.23180 130129.9n 1.23180 130130.0n 1.27694 130259.9n 1.27694 130260.0n 0.56595 130389.9n 0.56595 130390.0n 0.23835 130519.9n 0.23835 130520.0n 0.13226 130649.9n 0.13226 130650.0n 0.66096 130779.9n 0.66096 130780.0n 0.34013 130909.9n 0.34013 130910.0n -0.08309 131039.9n -0.08309 131040.0n -0.23386 131169.9n -0.23386 131170.0n 1.28574 131299.9n 1.28574 131300.0n 1.23180 131429.9n 1.23180 131430.0n -0.37792 131559.9n -0.37792 131560.0n 0.48458 131689.9n 0.48458 131690.0n 0.56595 131819.9n 0.56595 131820.0n 0.70122 131949.9n 0.70122 131950.0n -0.33158 132079.9n -0.33158 132080.0n 0.23835 132209.9n 0.23835 132210.0n 1.18224 132339.9n 1.18224 132340.0n 0.76415 132469.9n 0.76415 132470.0n 1.17517 132599.9n 1.17517 132600.0n 1.27694 132729.9n 1.27694 132730.0n 0.63482 132859.9n 0.63482 132860.0n 0.28189 132989.9n 0.28189 132990.0n 0.67130 133119.9n 0.67130 133120.0n 0.42554 133249.9n 0.42554 133250.0n 0.25911 133379.9n 0.25911 133380.0n -0.15161 133509.9n -0.15161 133510.0n 0.28700 133639.9n 0.28700 133640.0n 0.33171 133769.9n 0.33171 133770.0n 1.11225 133899.9n 1.11225 133900.0n 0.65842 134029.9n 0.65842 134030.0n -0.21828 134159.9n -0.21828 134160.0n 0.29915 134289.9n 0.29915 134290.0n 0.40313 134419.9n 0.40313 134420.0n 0.36576 134549.9n 0.36576 134550.0n 0.33730 134679.9n 0.33730 134680.0n 0.38385 134809.9n 0.38385 134810.0n 0.59706 134939.9n 0.59706 134940.0n 0.62307 135069.9n 0.62307 135070.0n 0.67018 135199.9n 0.67018 135200.0n 0.70540 135329.9n 0.70540 135330.0n 0.53582 135459.9n 0.53582 135460.0n 0.33357 135589.9n 0.33357 135590.0n 0.52885 135719.9n 0.52885 135720.0n 0.74383 135849.9n 0.74383 135850.0n 0.78409 135979.9n 0.78409 135980.0n 0.51936 136109.9n 0.51936 136110.0n 0.50532 136239.9n 0.50532 136240.0n 0.68189 136369.9n 0.68189 136370.0n 0.79862 136499.9n 0.79862 136500.0n 0.35050 136629.9n 0.35050 136630.0n 0.16858 136759.9n 0.16858 136760.0n 0.55253 136889.9n 0.55253 136890.0n 0.60823 137019.9n 0.60823 137020.0n 0.63611 137149.9n 0.63611 137150.0n 0.41197 137279.9n 0.41197 137280.0n 0.59247 137409.9n 0.59247 137410.0n 1.20712 137539.9n 1.20712 137540.0n 0.87402 137669.9n 0.87402 137670.0n -0.10545 137799.9n -0.10545 137800.0n -0.25282 137929.9n -0.25282 137930.0n -0.37666 138059.9n -0.37666 138060.0n 1.43391 138189.9n 1.43391 138190.0n 0.37511 138319.9n 0.37511 138320.0n 0.35780 138449.9n 0.35780 138450.0n 1.04281 138579.9n 1.04281 138580.0n 1.30757 138709.9n 1.30757 138710.0n -0.27950 138839.9n -0.27950 138840.0n 0.10137 138969.9n 0.10137 138970.0n 1.20727 139099.9n 1.20727 139100.0n 1.40210 139229.9n 1.40210 139230.0n 1.03003 139359.9n 1.03003 139360.0n -0.27250 139489.9n -0.27250 139490.0n -0.24444 139619.9n -0.24444 139620.0n 0.81835 139749.9n 0.81835 139750.0n 0.11792 139879.9n 0.11792 139880.0n -0.41822 140009.9n -0.41822 140010.0n 0.75242 140139.9n 0.75242 140140.0n 0.57354 140269.9n 0.57354 140270.0n 1.22124 140399.9n 1.22124 140400.0n -0.37792 140529.9n -0.37792 140530.0n 0.66096 140659.9n 0.66096 140660.0n 1.17517 140789.9n 1.17517 140790.0n -0.23386 140919.9n -0.23386 140920.0n 0.63482 141049.9n 0.63482 141050.0n 0.33171 141179.9n 0.33171 141180.0n 1.18224 141309.9n 1.18224 141310.0n 0.67130 141439.9n 0.67130 141440.0n 0.28700 141569.9n 0.28700 141570.0n 0.56595 141699.9n 0.56595 141700.0n 0.25911 141829.9n 0.25911 141830.0n 1.27694 141959.9n 1.27694 141960.0n 1.28574 142089.9n 1.28574 142090.0n -0.08309 142219.9n -0.08309 142220.0n 0.48458 142349.9n 0.48458 142350.0n -0.33158 142479.9n -0.33158 142480.0n 0.76415 142609.9n 0.76415 142610.0n 1.11225 142739.9n 1.11225 142740.0n -0.21828 142869.9n -0.21828 142870.0n 0.13226 142999.9n 0.13226 143000.0n 1.23180 143129.9n 1.23180 143130.0n 0.42554 143259.9n 0.42554 143260.0n -0.15161 143389.9n -0.15161 143390.0n 0.23835 143519.9n 0.23835 143520.0n 0.28189 143649.9n 0.28189 143650.0n 0.70122 143779.9n 0.70122 143780.0n 0.65842 143909.9n 0.65842 143910.0n 0.34013 144039.9n 0.34013 144040.0n 0.13226 144169.9n 0.13226 144170.0n 0.28700 144299.9n 0.28700 144300.0n 0.42554 144429.9n 0.42554 144430.0n 0.65842 144559.9n 0.65842 144560.0n 0.28189 144689.9n 0.28189 144690.0n 0.33171 144819.9n 0.33171 144820.0n 1.17517 144949.9n 1.17517 144950.0n 0.67130 145079.9n 0.67130 145080.0n 0.48458 145209.9n 0.48458 145210.0n 1.11225 145339.9n 1.11225 145340.0n -0.33158 145469.9n -0.33158 145470.0n 1.23180 145599.9n 1.23180 145600.0n 0.70122 145729.9n 0.70122 145730.0n 0.56595 145859.9n 0.56595 145860.0n 1.28574 145989.9n 1.28574 145990.0n -0.23386 146119.9n -0.23386 146120.0n -0.08309 146249.9n -0.08309 146250.0n 0.23835 146379.9n 0.23835 146380.0n -0.15161 146509.9n -0.15161 146510.0n 0.63482 146639.9n 0.63482 146640.0n 0.25911 146769.9n 0.25911 146770.0n 0.66096 146899.9n 0.66096 146900.0n 0.76415 147029.9n 0.76415 147030.0n 1.27694 147159.9n 1.27694 147160.0n -0.37792 147289.9n -0.37792 147290.0n 0.34013 147419.9n 0.34013 147420.0n -0.21828 147549.9n -0.21828 147550.0n 1.18224 147679.9n 1.18224 147680.0n 0.65842 147809.9n 0.65842 147810.0n -0.21828 147939.9n -0.21828 147940.0n 0.33171 148069.9n 0.33171 148070.0n 1.18224 148199.9n 1.18224 148200.0n 1.17517 148329.9n 1.17517 148330.0n 1.28574 148459.9n 1.28574 148460.0n 0.13226 148589.9n 0.13226 148590.0n 0.63482 148719.9n 0.63482 148720.0n 0.28700 148849.9n 0.28700 148850.0n 0.23835 148979.9n 0.23835 148980.0n 0.67130 149109.9n 0.67130 149110.0n 0.70122 149239.9n 0.70122 149240.0n 1.11225 149369.9n 1.11225 149370.0n 1.23180 149499.9n 1.23180 149500.0n 0.34013 149629.9n 0.34013 149630.0n -0.23386 149759.9n -0.23386 149760.0n 1.27694 149889.9n 1.27694 149890.0n 0.28189 150019.9n 0.28189 150020.0n 0.76415 150149.9n 0.76415 150150.0n -0.15161 150279.9n -0.15161 150280.0n 0.66096 150409.9n 0.66096 150410.0n 0.42554 150539.9n 0.42554 150540.0n -0.37792 150669.9n -0.37792 150670.0n 0.48458 150799.9n 0.48458 150800.0n -0.33158 150929.9n -0.33158 150930.0n -0.08309 151059.9n -0.08309 151060.0n 0.56595 151189.9n 0.56595 151190.0n 0.25911 151319.9n 0.25911 151320.0n -0.23386 151449.9n -0.23386 151450.0n 0.76415 151579.9n 0.76415 151580.0n 1.27694 151709.9n 1.27694 151710.0n 0.67130 151839.9n 0.67130 151840.0n 0.23835 151969.9n 0.23835 151970.0n 1.23180 152099.9n 1.23180 152100.0n 0.28189 152229.9n 0.28189 152230.0n -0.21828 152359.9n -0.21828 152360.0n 0.56595 152489.9n 0.56595 152490.0n 1.28574 152619.9n 1.28574 152620.0n 1.17517 152749.9n 1.17517 152750.0n 0.34013 152879.9n 0.34013 152880.0n 0.42554 153009.9n 0.42554 153010.0n -0.37792 153139.9n -0.37792 153140.0n 0.33171 153269.9n 0.33171 153270.0n -0.15161 153399.9n -0.15161 153400.0n -0.33158 153529.9n -0.33158 153530.0n 0.25911 153659.9n 0.25911 153660.0n 0.65842 153789.9n 0.65842 153790.0n 0.66096 153919.9n 0.66096 153920.0n 0.28700 154049.9n 0.28700 154050.0n 1.18224 154179.9n 1.18224 154180.0n 1.11225 154309.9n 1.11225 154310.0n 0.70122 154439.9n 0.70122 154440.0n 0.63482 154569.9n 0.63482 154570.0n 0.48458 154699.9n 0.48458 154700.0n 0.13226 154829.9n 0.13226 154830.0n -0.08309 154959.9n -0.08309 154960.0n 0.28700 155089.9n 0.28700 155090.0n 0.67130 155219.9n 0.67130 155220.0n -0.15161 155349.9n -0.15161 155350.0n 0.63482 155479.9n 0.63482 155480.0n 0.48458 155609.9n 0.48458 155610.0n 1.11225 155739.9n 1.11225 155740.0n 0.23835 155869.9n 0.23835 155870.0n 0.76415 155999.9n 0.76415 156000.0n 0.42554 156129.9n 0.42554 156130.0n 1.23180 156259.9n 1.23180 156260.0n 0.25911 156389.9n 0.25911 156390.0n 0.34013 156519.9n 0.34013 156520.0n 0.13226 156649.9n 0.13226 156650.0n -0.08309 156779.9n -0.08309 156780.0n 1.18224 156909.9n 1.18224 156910.0n 0.66096 157039.9n 0.66096 157040.0n 1.27694 157169.9n 1.27694 157170.0n 0.28189 157299.9n 0.28189 157300.0n 0.70122 157429.9n 0.70122 157430.0n 0.33171 157559.9n 0.33171 157560.0n 1.17517 157689.9n 1.17517 157690.0n -0.23386 157819.9n -0.23386 157820.0n 0.56595 157949.9n 0.56595 157950.0n 1.28574 158079.9n 1.28574 158080.0n -0.37792 158209.9n -0.37792 158210.0n -0.21828 158339.9n -0.21828 158340.0n 0.65842 158469.9n 0.65842 158470.0n -0.33158 158599.9n -0.33158 158600.0n 0.23835 158729.9n 0.23835 158730.0n 0.66096 158859.9n 0.66096 158860.0n 0.48458 158989.9n 0.48458 158990.0n 0.25911 159119.9n 0.25911 159120.0n -0.15161 159249.9n -0.15161 159250.0n 1.17517 159379.9n 1.17517 159380.0n 0.67130 159509.9n 0.67130 159510.0n 0.63482 159639.9n 0.63482 159640.0n 0.34013 159769.9n 0.34013 159770.0n 0.65842 159899.9n 0.65842 159900.0n -0.23386 160029.9n -0.23386 160030.0n -0.33158 160159.9n -0.33158 160160.0n 1.28574 160289.9n 1.28574 160290.0n 0.42554 160419.9n 0.42554 160420.0n 0.76415 160549.9n 0.76415 160550.0n -0.21828 160679.9n -0.21828 160680.0n 1.23180 160809.9n 1.23180 160810.0n -0.08309 160939.9n -0.08309 160940.0n 0.33171 161069.9n 0.33171 161070.0n 1.27694 161199.9n 1.27694 161200.0n 0.56595 161329.9n 0.56595 161330.0n 1.11225 161459.9n 1.11225 161460.0n -0.37792 161589.9n -0.37792 161590.0n 0.70122 161719.9n 0.70122 161720.0n 1.18224 161849.9n 1.18224 161850.0n 0.28700 161979.9n 0.28700 161980.0n 0.28189 162109.9n 0.28189 162110.0n 0.13226 162239.9n 0.13226 162240.0n 0.29915 162369.9n 0.29915 162370.0n 0.40313 162499.9n 0.40313 162500.0n 0.36576 162629.9n 0.36576 162630.0n 0.33730 162759.9n 0.33730 162760.0n 0.38385 162889.9n 0.38385 162890.0n 0.59706 163019.9n 0.59706 163020.0n 0.62307 163149.9n 0.62307 163150.0n 0.67018 163279.9n 0.67018 163280.0n 0.70540 163409.9n 0.70540 163410.0n 0.53582 163539.9n 0.53582 163540.0n 0.33357 163669.9n 0.33357 163670.0n 0.52885 163799.9n 0.52885 163800.0n 0.74383 163929.9n 0.74383 163930.0n 0.78409 164059.9n 0.78409 164060.0n 0.51936 164189.9n 0.51936 164190.0n 0.50532 164319.9n 0.50532 164320.0n 0.68189 164449.9n 0.68189 164450.0n 0.79862 164579.9n 0.79862 164580.0n 0.35050 164709.9n 0.35050 164710.0n 0.16858 164839.9n 0.16858 164840.0n 0.55253 164969.9n 0.55253 164970.0n 0.60823 165099.9n 0.60823 165100.0n 0.63611 165229.9n 0.63611 165230.0n 0.41197 165359.9n 0.41197 165360.0n 0.59247 165489.9n 0.59247 165490.0n 1.20712 165619.9n 1.20712 165620.0n 0.87402 165749.9n 0.87402 165750.0n -0.10545 165879.9n -0.10545 165880.0n -0.25282 166009.9n -0.25282 166010.0n -0.37666 166139.9n -0.37666 166140.0n 1.43391 166269.9n 1.43391 166270.0n 0.37511 166399.9n 0.37511 166400.0n 0.35780 166529.9n 0.35780 166530.0n 1.04281 166659.9n 1.04281 166660.0n 1.30757 166789.9n 1.30757 166790.0n -0.27950 166919.9n -0.27950 166920.0n 0.10137 167049.9n 0.10137 167050.0n 1.20727 167179.9n 1.20727 167180.0n 1.40210 167309.9n 1.40210 167310.0n 1.03003 167439.9n 1.03003 167440.0n -0.27250 167569.9n -0.27250 167570.0n -0.24444 167699.9n -0.24444 167700.0n 0.81835 167829.9n 0.81835 167830.0n 0.11792 167959.9n 0.11792 167960.0n -0.41822 168089.9n -0.41822 168090.0n 0.75242 168219.9n 0.75242 168220.0n 0.57354 168349.9n 0.57354 168350.0n 1.22124)
Vxn1 a_xn1 0 PWL(0.0n -0.23180 129.9n -0.23180 130.0n 0.71811 259.9n 0.71811 260.0n 0.65987 389.9n 0.65987 390.0n 0.51542 519.9n 0.51542 520.0n 0.43405 649.9n 0.43405 650.0n 0.33904 779.9n 0.33904 780.0n -0.11225 909.9n -0.11225 910.0n -0.27694 1039.9n -0.27694 1040.0n -0.17517 1169.9n -0.17517 1170.0n 1.23386 1299.9n 1.23386 1300.0n 1.21828 1429.9n 1.21828 1430.0n 0.66829 1559.9n 0.66829 1560.0n 0.29878 1689.9n 0.29878 1690.0n 0.74089 1819.9n 0.74089 1820.0n 0.86774 1949.9n 0.86774 1950.0n 0.34158 2079.9n 0.34158 2080.0n 0.36518 2209.9n 0.36518 2210.0n 1.33158 2339.9n 1.33158 2340.0n 0.23585 2469.9n 0.23585 2470.0n 1.15161 2599.9n 1.15161 2600.0n 0.71300 2729.9n 0.71300 2730.0n 0.76165 2859.9n 0.76165 2860.0n 1.37792 2989.9n 1.37792 2990.0n -0.18224 3119.9n -0.18224 3120.0n 0.32870 3249.9n 0.32870 3250.0n 0.57446 3379.9n 0.57446 3380.0n -0.28574 3509.9n -0.28574 3510.0n 1.08309 3639.9n 1.08309 3640.0n 0.34158 3769.9n 0.34158 3770.0n -0.11225 3899.9n -0.11225 3900.0n 1.23386 4029.9n 1.23386 4030.0n 0.71300 4159.9n 0.71300 4160.0n 0.43405 4289.9n 0.43405 4290.0n 0.86774 4419.9n 0.86774 4420.0n 1.37792 4549.9n 1.37792 4550.0n 1.08309 4679.9n 1.08309 4680.0n -0.27694 4809.9n -0.27694 4810.0n 0.36518 4939.9n 0.36518 4940.0n 0.23585 5069.9n 0.23585 5070.0n 0.29878 5199.9n 0.29878 5200.0n 0.65987 5329.9n 0.65987 5330.0n 0.51542 5459.9n 0.51542 5460.0n 0.71811 5589.9n 0.71811 5590.0n 0.57446 5719.9n 0.57446 5720.0n 1.21828 5849.9n 1.21828 5850.0n -0.28574 5979.9n -0.28574 5980.0n 1.15161 6109.9n 1.15161 6110.0n -0.18224 6239.9n -0.18224 6240.0n -0.17517 6369.9n -0.17517 6370.0n 0.32870 6499.9n 0.32870 6500.0n 0.74089 6629.9n 0.74089 6630.0n 0.66829 6759.9n 0.66829 6760.0n 0.76165 6889.9n 0.76165 6890.0n 1.33158 7019.9n 1.33158 7020.0n 0.33904 7149.9n 0.33904 7150.0n -0.23180 7279.9n -0.23180 7280.0n 0.76165 7409.9n 0.76165 7410.0n 0.71811 7539.9n 0.71811 7540.0n -0.18224 7669.9n -0.18224 7670.0n 0.34158 7799.9n 0.34158 7800.0n 0.65987 7929.9n 0.65987 7930.0n 0.71300 8059.9n 0.71300 8060.0n 1.15161 8189.9n 1.15161 8190.0n 0.29878 8319.9n 0.29878 8320.0n 1.37792 8449.9n 1.37792 8450.0n 1.23386 8579.9n 1.23386 8580.0n 0.57446 8709.9n 0.57446 8710.0n -0.23180 8839.9n -0.23180 8840.0n 0.36518 8969.9n 0.36518 8970.0n -0.27694 9099.9n -0.27694 9100.0n 1.08309 9229.9n 1.08309 9230.0n 0.43405 9359.9n 0.43405 9360.0n 0.33904 9489.9n 0.33904 9490.0n -0.28574 9619.9n -0.28574 9620.0n 0.32870 9749.9n 0.32870 9750.0n 0.86774 9879.9n 0.86774 9880.0n 0.66829 10009.9n 0.66829 10010.0n 0.51542 10139.9n 0.51542 10140.0n 0.74089 10269.9n 0.74089 10270.0n 1.21828 10399.9n 1.21828 10400.0n -0.11225 10529.9n -0.11225 10530.0n 1.33158 10659.9n 1.33158 10660.0n -0.17517 10789.9n -0.17517 10790.0n 0.23585 10919.9n 0.23585 10920.0n 0.86774 11049.9n 0.86774 11050.0n 0.34158 11179.9n 0.34158 11180.0n 0.74089 11309.9n 0.74089 11310.0n 0.71300 11439.9n 0.71300 11440.0n 1.08309 11569.9n 1.08309 11570.0n 0.76165 11699.9n 0.76165 11700.0n -0.18224 11829.9n -0.18224 11830.0n -0.11225 11959.9n -0.11225 11960.0n 0.43405 12089.9n 0.43405 12090.0n -0.27694 12219.9n -0.27694 12220.0n 1.37792 12349.9n 1.37792 12350.0n 0.71811 12479.9n 0.71811 12480.0n -0.23180 12609.9n -0.23180 12610.0n 1.15161 12739.9n 1.15161 12740.0n -0.17517 12869.9n -0.17517 12870.0n -0.28574 12999.9n -0.28574 13000.0n 0.51542 13129.9n 0.51542 13130.0n 0.36518 13259.9n 0.36518 13260.0n 0.65987 13389.9n 0.65987 13390.0n 1.33158 13519.9n 1.33158 13520.0n 0.66829 13649.9n 0.66829 13650.0n 0.32870 13779.9n 0.32870 13780.0n 0.33904 13909.9n 0.33904 13910.0n 0.29878 14039.9n 0.29878 14040.0n 1.23386 14169.9n 1.23386 14170.0n 0.23585 14299.9n 0.23585 14300.0n 1.21828 14429.9n 1.21828 14430.0n 0.57446 14559.9n 0.57446 14560.0n -0.18224 14689.9n -0.18224 14690.0n 0.36518 14819.9n 0.36518 14820.0n -0.17517 14949.9n -0.17517 14950.0n -0.23180 15079.9n -0.23180 15080.0n 0.51542 15209.9n 0.51542 15210.0n 1.21828 15339.9n 1.21828 15340.0n 0.66829 15469.9n 0.66829 15470.0n 0.32870 15599.9n 0.32870 15600.0n 0.33904 15729.9n 0.33904 15730.0n -0.27694 15859.9n -0.27694 15860.0n 1.08309 15989.9n 1.08309 15990.0n 0.23585 16119.9n 0.23585 16120.0n 0.57446 16249.9n 0.57446 16250.0n 0.86774 16379.9n 0.86774 16380.0n 1.15161 16509.9n 1.15161 16510.0n 0.29878 16639.9n 0.29878 16640.0n -0.11225 16769.9n -0.11225 16770.0n 0.74089 16899.9n 0.74089 16900.0n 1.23386 17029.9n 1.23386 17030.0n 0.34158 17159.9n 0.34158 17160.0n 0.76165 17289.9n 0.76165 17290.0n 1.37792 17419.9n 1.37792 17420.0n 0.71811 17549.9n 0.71811 17550.0n -0.28574 17679.9n -0.28574 17680.0n 0.71300 17809.9n 0.71300 17810.0n 1.33158 17939.9n 1.33158 17940.0n 0.65987 18069.9n 0.65987 18070.0n 0.43405 18199.9n 0.43405 18200.0n 1.21828 18329.9n 1.21828 18330.0n -0.23180 18459.9n -0.23180 18460.0n 0.23585 18589.9n 0.23585 18590.0n 0.66829 18719.9n 0.66829 18720.0n 0.43405 18849.9n 0.43405 18850.0n 0.57446 18979.9n 0.57446 18980.0n 0.32870 19109.9n 0.32870 19110.0n -0.18224 19239.9n -0.18224 19240.0n 1.37792 19369.9n 1.37792 19370.0n 1.33158 19499.9n 1.33158 19500.0n -0.28574 19629.9n -0.28574 19630.0n 0.74089 19759.9n 0.74089 19760.0n 0.71300 19889.9n 0.71300 19890.0n 0.65987 20019.9n 0.65987 20020.0n 1.15161 20149.9n 1.15161 20150.0n 0.36518 20279.9n 0.36518 20280.0n 0.86774 20409.9n 0.86774 20410.0n 0.76165 20539.9n 0.76165 20540.0n 0.34158 20669.9n 0.34158 20670.0n 0.71811 20799.9n 0.71811 20800.0n -0.11225 20929.9n -0.11225 20930.0n 1.23386 21059.9n 1.23386 21060.0n 0.33904 21189.9n 0.33904 21190.0n 1.08309 21319.9n 1.08309 21320.0n 0.51542 21449.9n 0.51542 21450.0n -0.27694 21579.9n -0.27694 21580.0n -0.17517 21709.9n -0.17517 21710.0n 0.29878 21839.9n 0.29878 21840.0n 0.70085 21969.9n 0.70085 21970.0n 0.59687 22099.9n 0.59687 22100.0n 0.63424 22229.9n 0.63424 22230.0n 0.66270 22359.9n 0.66270 22360.0n 0.61615 22489.9n 0.61615 22490.0n 0.40294 22619.9n 0.40294 22620.0n 0.37693 22749.9n 0.37693 22750.0n 0.32982 22879.9n 0.32982 22880.0n 0.29460 23009.9n 0.29460 23010.0n 0.46418 23139.9n 0.46418 23140.0n 0.66643 23269.9n 0.66643 23270.0n 0.47115 23399.9n 0.47115 23400.0n 0.25617 23529.9n 0.25617 23530.0n 0.21591 23659.9n 0.21591 23660.0n 0.48064 23789.9n 0.48064 23790.0n 0.49468 23919.9n 0.49468 23920.0n 0.31811 24049.9n 0.31811 24050.0n 0.20138 24179.9n 0.20138 24180.0n 0.64950 24309.9n 0.64950 24310.0n 0.83142 24439.9n 0.83142 24440.0n 0.44747 24569.9n 0.44747 24570.0n 0.39177 24699.9n 0.39177 24700.0n 0.36389 24829.9n 0.36389 24830.0n 0.58803 24959.9n 0.58803 24960.0n 0.40753 25089.9n 0.40753 25090.0n -0.20712 25219.9n -0.20712 25220.0n 0.12598 25349.9n 0.12598 25350.0n 1.10545 25479.9n 1.10545 25480.0n 1.25282 25609.9n 1.25282 25610.0n 1.37666 25739.9n 1.37666 25740.0n -0.43391 25869.9n -0.43391 25870.0n 0.62489 25999.9n 0.62489 26000.0n 0.64220 26129.9n 0.64220 26130.0n -0.04281 26259.9n -0.04281 26260.0n -0.30757 26389.9n -0.30757 26390.0n 1.27950 26519.9n 1.27950 26520.0n 0.89863 26649.9n 0.89863 26650.0n -0.20727 26779.9n -0.20727 26780.0n -0.40210 26909.9n -0.40210 26910.0n -0.03003 27039.9n -0.03003 27040.0n 1.27250 27169.9n 1.27250 27170.0n 1.24444 27299.9n 1.24444 27300.0n 0.18165 27429.9n 0.18165 27430.0n 0.88208 27559.9n 0.88208 27560.0n 1.41822 27689.9n 1.41822 27690.0n 0.24758 27819.9n 0.24758 27820.0n 0.42646 27949.9n 0.42646 27950.0n -0.22124 28079.9n -0.22124 28080.0n 0.66829 28209.9n 0.66829 28210.0n 0.51542 28339.9n 0.51542 28340.0n -0.18224 28469.9n -0.18224 28470.0n 1.33158 28599.9n 1.33158 28600.0n -0.28574 28729.9n -0.28574 28730.0n 0.57446 28859.9n 0.57446 28860.0n -0.23180 28989.9n -0.23180 28990.0n -0.27694 29119.9n -0.27694 29120.0n 0.74089 29249.9n 0.74089 29250.0n 1.21828 29379.9n 1.21828 29380.0n 1.08309 29509.9n 1.08309 29510.0n 0.65987 29639.9n 0.65987 29640.0n 1.23386 29769.9n 1.23386 29770.0n 0.71300 29899.9n 0.71300 29900.0n 0.29878 30029.9n 0.29878 30030.0n -0.11225 30159.9n -0.11225 30160.0n 1.37792 30289.9n 1.37792 30290.0n -0.17517 30419.9n -0.17517 30420.0n 1.15161 30549.9n 1.15161 30550.0n 0.36518 30679.9n 0.36518 30680.0n 0.76165 30809.9n 0.76165 30810.0n 0.23585 30939.9n 0.23585 30940.0n 0.32870 31069.9n 0.32870 31070.0n 0.71811 31199.9n 0.71811 31200.0n 0.43405 31329.9n 0.43405 31330.0n 0.86774 31459.9n 0.86774 31460.0n 0.34158 31589.9n 0.34158 31590.0n 0.33904 31719.9n 0.33904 31720.0n -0.11225 31849.9n -0.11225 31850.0n 0.33904 31979.9n 0.33904 31980.0n 0.51542 32109.9n 0.51542 32110.0n 0.29878 32239.9n 0.29878 32240.0n 0.36518 32369.9n 0.36518 32370.0n 0.65987 32499.9n 0.65987 32500.0n -0.23180 32629.9n -0.23180 32630.0n 1.08309 32759.9n 1.08309 32760.0n 1.33158 32889.9n 1.33158 32890.0n 0.57446 33019.9n 0.57446 33020.0n 1.21828 33149.9n 1.21828 33150.0n -0.28574 33279.9n -0.28574 33280.0n -0.27694 33409.9n -0.27694 33410.0n -0.17517 33539.9n -0.17517 33540.0n 0.74089 33669.9n 0.74089 33670.0n -0.18224 33799.9n -0.18224 33800.0n 0.66829 33929.9n 0.66829 33930.0n 1.37792 34059.9n 1.37792 34060.0n 0.34158 34189.9n 0.34158 34190.0n 0.32870 34319.9n 0.32870 34320.0n 0.76165 34449.9n 0.76165 34450.0n 1.23386 34579.9n 1.23386 34580.0n 0.71811 34709.9n 0.71811 34710.0n 0.23585 34839.9n 0.23585 34840.0n 0.86774 34969.9n 0.86774 34970.0n 0.71300 35099.9n 0.71300 35100.0n 1.15161 35229.9n 1.15161 35230.0n 0.43405 35359.9n 0.43405 35360.0n -0.28574 35489.9n -0.28574 35490.0n 0.23585 35619.9n 0.23585 35620.0n 1.37792 35749.9n 1.37792 35750.0n -0.18224 35879.9n -0.18224 35880.0n 0.65987 36009.9n 0.65987 36010.0n -0.11225 36139.9n -0.11225 36140.0n -0.27694 36269.9n -0.27694 36270.0n 0.76165 36399.9n 0.76165 36400.0n 0.34158 36529.9n 0.34158 36530.0n 0.71811 36659.9n 0.71811 36660.0n 1.33158 36789.9n 1.33158 36790.0n -0.23180 36919.9n -0.23180 36920.0n 0.86774 37049.9n 0.86774 37050.0n 1.21828 37179.9n 1.21828 37180.0n 1.15161 37309.9n 1.15161 37310.0n 1.08309 37439.9n 1.08309 37440.0n 0.36518 37569.9n 0.36518 37570.0n 0.43405 37699.9n 0.43405 37700.0n 0.66829 37829.9n 0.66829 37830.0n 0.57446 37959.9n 0.57446 37960.0n 0.51542 38089.9n 0.51542 38090.0n 0.32870 38219.9n 0.32870 38220.0n 0.74089 38349.9n 0.74089 38350.0n 0.71300 38479.9n 0.71300 38480.0n -0.17517 38609.9n -0.17517 38610.0n 0.33904 38739.9n 0.33904 38740.0n 1.23386 38869.9n 1.23386 38870.0n 0.29878 38999.9n 0.29878 39000.0n 1.21828 39129.9n 1.21828 39130.0n 0.76165 39259.9n 0.76165 39260.0n 0.29878 39389.9n 0.29878 39390.0n 0.43405 39519.9n 0.43405 39520.0n 1.08309 39649.9n 1.08309 39650.0n 0.71811 39779.9n 0.71811 39780.0n -0.27694 39909.9n -0.27694 39910.0n -0.11225 40039.9n -0.11225 40040.0n 1.23386 40169.9n 1.23386 40170.0n 0.74089 40299.9n 0.74089 40300.0n 0.66829 40429.9n 0.66829 40430.0n 0.23585 40559.9n 0.23585 40560.0n -0.18224 40689.9n -0.18224 40690.0n 0.86774 40819.9n 0.86774 40820.0n 0.36518 40949.9n 0.36518 40950.0n 1.37792 41079.9n 1.37792 41080.0n -0.28574 41209.9n -0.28574 41210.0n 1.15161 41339.9n 1.15161 41340.0n 0.34158 41469.9n 0.34158 41470.0n 0.51542 41599.9n 0.51542 41600.0n -0.17517 41729.9n -0.17517 41730.0n 0.71300 41859.9n 0.71300 41860.0n 1.33158 41989.9n 1.33158 41990.0n 0.65987 42119.9n 0.65987 42120.0n 0.33904 42249.9n 0.33904 42250.0n 0.57446 42379.9n 0.57446 42380.0n 0.32870 42509.9n 0.32870 42510.0n -0.23180 42639.9n -0.23180 42640.0n 1.15161 42769.9n 1.15161 42770.0n 0.76165 42899.9n 0.76165 42900.0n 0.29878 43029.9n 0.29878 43030.0n 1.23386 43159.9n 1.23386 43160.0n 0.36518 43289.9n 0.36518 43290.0n 0.86774 43419.9n 0.86774 43420.0n -0.18224 43549.9n -0.18224 43550.0n 1.37792 43679.9n 1.37792 43680.0n -0.17517 43809.9n -0.17517 43810.0n -0.27694 43939.9n -0.27694 43940.0n 0.32870 44069.9n 0.32870 44070.0n 1.08309 44199.9n 1.08309 44200.0n -0.28574 44329.9n -0.28574 44330.0n 0.74089 44459.9n 0.74089 44460.0n 0.51542 44589.9n 0.51542 44590.0n 0.34158 44719.9n 0.34158 44720.0n 0.23585 44849.9n 0.23585 44850.0n -0.11225 44979.9n -0.11225 44980.0n 0.65987 45109.9n 0.65987 45110.0n 0.71300 45239.9n 0.71300 45240.0n 0.71811 45369.9n 0.71811 45370.0n 0.33904 45499.9n 0.33904 45500.0n 0.43405 45629.9n 0.43405 45630.0n 0.66829 45759.9n 0.66829 45760.0n 0.57446 45889.9n 0.57446 45890.0n -0.23180 46019.9n -0.23180 46020.0n 1.33158 46149.9n 1.33158 46150.0n 1.21828 46279.9n 1.21828 46280.0n -0.28574 46409.9n -0.28574 46410.0n 0.43405 46539.9n 0.43405 46540.0n 0.65987 46669.9n 0.65987 46670.0n 1.33158 46799.9n 1.33158 46800.0n 0.71811 46929.9n 0.71811 46930.0n 0.71300 47059.9n 0.71300 47060.0n -0.17517 47189.9n -0.17517 47190.0n 0.33904 47319.9n 0.33904 47320.0n 0.34158 47449.9n 0.34158 47450.0n 0.29878 47579.9n 0.29878 47580.0n 0.36518 47709.9n 0.36518 47710.0n 0.32870 47839.9n 0.32870 47840.0n 0.74089 47969.9n 0.74089 47970.0n 1.23386 48099.9n 1.23386 48100.0n 0.76165 48229.9n 0.76165 48230.0n 1.21828 48359.9n 1.21828 48360.0n 0.51542 48489.9n 0.51542 48490.0n -0.18224 48619.9n -0.18224 48620.0n -0.27694 48749.9n -0.27694 48750.0n 0.86774 48879.9n 0.86774 48880.0n 1.37792 49009.9n 1.37792 49010.0n 1.15161 49139.9n 1.15161 49140.0n 0.23585 49269.9n 0.23585 49270.0n -0.23180 49399.9n -0.23180 49400.0n 0.57446 49529.9n 0.57446 49530.0n -0.11225 49659.9n -0.11225 49660.0n 0.66829 49789.9n 0.66829 49790.0n 1.08309 49919.9n 1.08309 49920.0n 0.70085 50049.9n 0.70085 50050.0n 0.59687 50179.9n 0.59687 50180.0n 0.63424 50309.9n 0.63424 50310.0n 0.66270 50439.9n 0.66270 50440.0n 0.61615 50569.9n 0.61615 50570.0n 0.40294 50699.9n 0.40294 50700.0n 0.37693 50829.9n 0.37693 50830.0n 0.32982 50959.9n 0.32982 50960.0n 0.29460 51089.9n 0.29460 51090.0n 0.46418 51219.9n 0.46418 51220.0n 0.66643 51349.9n 0.66643 51350.0n 0.47115 51479.9n 0.47115 51480.0n 0.25617 51609.9n 0.25617 51610.0n 0.21591 51739.9n 0.21591 51740.0n 0.48064 51869.9n 0.48064 51870.0n 0.49468 51999.9n 0.49468 52000.0n 0.31811 52129.9n 0.31811 52130.0n 0.20138 52259.9n 0.20138 52260.0n 0.64950 52389.9n 0.64950 52390.0n 0.83142 52519.9n 0.83142 52520.0n 0.44747 52649.9n 0.44747 52650.0n 0.39177 52779.9n 0.39177 52780.0n 0.36389 52909.9n 0.36389 52910.0n 0.58803 53039.9n 0.58803 53040.0n 0.40753 53169.9n 0.40753 53170.0n -0.20712 53299.9n -0.20712 53300.0n 0.12598 53429.9n 0.12598 53430.0n 1.10545 53559.9n 1.10545 53560.0n 1.25282 53689.9n 1.25282 53690.0n 1.37666 53819.9n 1.37666 53820.0n -0.43391 53949.9n -0.43391 53950.0n 0.62489 54079.9n 0.62489 54080.0n 0.64220 54209.9n 0.64220 54210.0n -0.04281 54339.9n -0.04281 54340.0n -0.30757 54469.9n -0.30757 54470.0n 1.27950 54599.9n 1.27950 54600.0n 0.89863 54729.9n 0.89863 54730.0n -0.20727 54859.9n -0.20727 54860.0n -0.40210 54989.9n -0.40210 54990.0n -0.03003 55119.9n -0.03003 55120.0n 1.27250 55249.9n 1.27250 55250.0n 1.24444 55379.9n 1.24444 55380.0n 0.18165 55509.9n 0.18165 55510.0n 0.88208 55639.9n 0.88208 55640.0n 1.41822 55769.9n 1.41822 55770.0n 0.24758 55899.9n 0.24758 55900.0n 0.42646 56029.9n 0.42646 56030.0n -0.22124 56159.9n -0.22124 56160.0n 0.74089 56289.9n 0.74089 56290.0n 0.32870 56419.9n 0.32870 56420.0n 1.33158 56549.9n 1.33158 56550.0n 1.21828 56679.9n 1.21828 56680.0n 1.08309 56809.9n 1.08309 56810.0n 0.66829 56939.9n 0.66829 56940.0n 0.36518 57069.9n 0.36518 57070.0n -0.11225 57199.9n -0.11225 57200.0n 0.86774 57329.9n 0.86774 57330.0n -0.28574 57459.9n -0.28574 57460.0n 0.57446 57589.9n 0.57446 57590.0n 0.43405 57719.9n 0.43405 57720.0n 0.23585 57849.9n 0.23585 57850.0n -0.17517 57979.9n -0.17517 57980.0n 0.34158 58109.9n 0.34158 58110.0n 0.33904 58239.9n 0.33904 58240.0n 0.29878 58369.9n 0.29878 58370.0n 1.23386 58499.9n 1.23386 58500.0n 0.71811 58629.9n 0.71811 58630.0n -0.27694 58759.9n -0.27694 58760.0n 1.37792 58889.9n 1.37792 58890.0n 0.71300 59019.9n 0.71300 59020.0n -0.18224 59149.9n -0.18224 59150.0n 1.15161 59279.9n 1.15161 59280.0n 0.65987 59409.9n 0.65987 59410.0n 0.76165 59539.9n 0.76165 59540.0n 0.51542 59669.9n 0.51542 59670.0n -0.23180 59799.9n -0.23180 59800.0n 0.71300 59929.9n 0.71300 59930.0n 0.34158 60059.9n 0.34158 60060.0n -0.17517 60189.9n -0.17517 60190.0n 0.43405 60319.9n 0.43405 60320.0n 0.33904 60449.9n 0.33904 60450.0n 0.29878 60579.9n 0.29878 60580.0n 0.74089 60709.9n 0.74089 60710.0n 0.86774 60839.9n 0.86774 60840.0n 0.36518 60969.9n 0.36518 60970.0n 0.23585 61099.9n 0.23585 61100.0n 0.76165 61229.9n 0.76165 61230.0n -0.23180 61359.9n -0.23180 61360.0n -0.18224 61489.9n -0.18224 61490.0n 0.51542 61619.9n 0.51542 61620.0n 0.71811 61749.9n 0.71811 61750.0n -0.28574 61879.9n -0.28574 61880.0n 0.57446 62009.9n 0.57446 62010.0n 0.66829 62139.9n 0.66829 62140.0n 0.32870 62269.9n 0.32870 62270.0n 1.15161 62399.9n 1.15161 62400.0n -0.27694 62529.9n -0.27694 62530.0n 1.23386 62659.9n 1.23386 62660.0n 1.08309 62789.9n 1.08309 62790.0n -0.11225 62919.9n -0.11225 62920.0n 1.37792 63049.9n 1.37792 63050.0n 1.21828 63179.9n 1.21828 63180.0n 1.33158 63309.9n 1.33158 63310.0n 0.65987 63439.9n 0.65987 63440.0n 0.71300 63569.9n 0.71300 63570.0n 0.71811 63699.9n 0.71811 63700.0n 1.08309 63829.9n 1.08309 63830.0n -0.23180 63959.9n -0.23180 63960.0n -0.17517 64089.9n -0.17517 64090.0n 0.65987 64219.9n 0.65987 64220.0n 1.23386 64349.9n 1.23386 64350.0n 0.32870 64479.9n 0.32870 64480.0n -0.18224 64609.9n -0.18224 64610.0n 0.36518 64739.9n 0.36518 64740.0n 1.33158 64869.9n 1.33158 64870.0n -0.11225 64999.9n -0.11225 65000.0n 1.15161 65129.9n 1.15161 65130.0n 0.23585 65259.9n 0.23585 65260.0n -0.27694 65389.9n -0.27694 65390.0n -0.28574 65519.9n -0.28574 65520.0n 0.29878 65649.9n 0.29878 65650.0n 0.66829 65779.9n 0.66829 65780.0n 0.57446 65909.9n 0.57446 65910.0n 0.34158 66039.9n 0.34158 66040.0n 0.76165 66169.9n 0.76165 66170.0n 0.33904 66299.9n 0.33904 66300.0n 0.51542 66429.9n 0.51542 66430.0n 0.74089 66559.9n 0.74089 66560.0n 0.86774 66689.9n 0.86774 66690.0n 0.43405 66819.9n 0.43405 66820.0n 1.37792 66949.9n 1.37792 66950.0n 1.21828 67079.9n 1.21828 67080.0n 0.76165 67209.9n 0.76165 67210.0n 1.33158 67339.9n 1.33158 67340.0n -0.27694 67469.9n -0.27694 67470.0n 1.21828 67599.9n 1.21828 67600.0n 0.23585 67729.9n 0.23585 67730.0n 0.33904 67859.9n 0.33904 67860.0n 0.86774 67989.9n 0.86774 67990.0n 1.23386 68119.9n 1.23386 68120.0n 0.74089 68249.9n 0.74089 68250.0n 0.36518 68379.9n 0.36518 68380.0n 0.29878 68509.9n 0.29878 68510.0n -0.28574 68639.9n -0.28574 68640.0n 0.57446 68769.9n 0.57446 68770.0n 0.66829 68899.9n 0.66829 68900.0n -0.11225 69029.9n -0.11225 69030.0n 1.15161 69159.9n 1.15161 69160.0n 0.71811 69289.9n 0.71811 69290.0n -0.18224 69419.9n -0.18224 69420.0n 0.71300 69549.9n 0.71300 69550.0n 1.37792 69679.9n 1.37792 69680.0n 0.65987 69809.9n 0.65987 69810.0n 0.43405 69939.9n 0.43405 69940.0n 0.32870 70069.9n 0.32870 70070.0n -0.23180 70199.9n -0.23180 70200.0n 1.08309 70329.9n 1.08309 70330.0n 0.34158 70459.9n 0.34158 70460.0n -0.17517 70589.9n -0.17517 70590.0n 0.51542 70719.9n 0.51542 70720.0n -0.17517 70849.9n -0.17517 70850.0n 0.23585 70979.9n 0.23585 70980.0n 1.23386 71109.9n 1.23386 71110.0n 0.65987 71239.9n 0.65987 71240.0n -0.18224 71369.9n -0.18224 71370.0n 0.33904 71499.9n 0.33904 71500.0n 1.15161 71629.9n 1.15161 71630.0n -0.11225 71759.9n -0.11225 71760.0n 0.76165 71889.9n 0.76165 71890.0n 0.66829 72019.9n 0.66829 72020.0n 0.74089 72149.9n 0.74089 72150.0n -0.27694 72279.9n -0.27694 72280.0n 0.34158 72409.9n 0.34158 72410.0n -0.23180 72539.9n -0.23180 72540.0n 1.08309 72669.9n 1.08309 72670.0n 1.37792 72799.9n 1.37792 72800.0n 0.71300 72929.9n 0.71300 72930.0n 0.51542 73059.9n 0.51542 73060.0n 0.57446 73189.9n 0.57446 73190.0n 0.43405 73319.9n 0.43405 73320.0n 0.29878 73449.9n 0.29878 73450.0n 1.33158 73579.9n 1.33158 73580.0n 0.86774 73709.9n 0.86774 73710.0n 0.32870 73839.9n 0.32870 73840.0n -0.28574 73969.9n -0.28574 73970.0n 1.21828 74099.9n 1.21828 74100.0n 0.71811 74229.9n 0.71811 74230.0n 0.36518 74359.9n 0.36518 74360.0n 1.37792 74489.9n 1.37792 74490.0n 1.08309 74619.9n 1.08309 74620.0n -0.11225 74749.9n -0.11225 74750.0n 0.43405 74879.9n 0.43405 74880.0n 0.33904 75009.9n 0.33904 75010.0n 0.51542 75139.9n 0.51542 75140.0n -0.28574 75269.9n -0.28574 75270.0n 0.71300 75399.9n 0.71300 75400.0n 0.76165 75529.9n 0.76165 75530.0n 0.71811 75659.9n 0.71811 75660.0n 0.86774 75789.9n 0.86774 75790.0n 0.23585 75919.9n 0.23585 75920.0n 0.65987 76049.9n 0.65987 76050.0n 0.34158 76179.9n 0.34158 76180.0n 1.21828 76309.9n 1.21828 76310.0n 1.33158 76439.9n 1.33158 76440.0n 0.57446 76569.9n 0.57446 76570.0n 1.23386 76699.9n 1.23386 76700.0n 0.29878 76829.9n 0.29878 76830.0n 1.15161 76959.9n 1.15161 76960.0n -0.27694 77089.9n -0.27694 77090.0n 0.36518 77219.9n 0.36518 77220.0n 0.74089 77349.9n 0.74089 77350.0n 0.66829 77479.9n 0.66829 77480.0n -0.18224 77609.9n -0.18224 77610.0n -0.23180 77739.9n -0.23180 77740.0n 0.32870 77869.9n 0.32870 77870.0n -0.17517 77999.9n -0.17517 78000.0n 0.70085 78129.9n 0.70085 78130.0n 0.59687 78259.9n 0.59687 78260.0n 0.63424 78389.9n 0.63424 78390.0n 0.66270 78519.9n 0.66270 78520.0n 0.61615 78649.9n 0.61615 78650.0n 0.40294 78779.9n 0.40294 78780.0n 0.37693 78909.9n 0.37693 78910.0n 0.32982 79039.9n 0.32982 79040.0n 0.29460 79169.9n 0.29460 79170.0n 0.46418 79299.9n 0.46418 79300.0n 0.66643 79429.9n 0.66643 79430.0n 0.47115 79559.9n 0.47115 79560.0n 0.25617 79689.9n 0.25617 79690.0n 0.21591 79819.9n 0.21591 79820.0n 0.48064 79949.9n 0.48064 79950.0n 0.49468 80079.9n 0.49468 80080.0n 0.31811 80209.9n 0.31811 80210.0n 0.20138 80339.9n 0.20138 80340.0n 0.64950 80469.9n 0.64950 80470.0n 0.83142 80599.9n 0.83142 80600.0n 0.44747 80729.9n 0.44747 80730.0n 0.39177 80859.9n 0.39177 80860.0n 0.36389 80989.9n 0.36389 80990.0n 0.58803 81119.9n 0.58803 81120.0n 0.40753 81249.9n 0.40753 81250.0n -0.20712 81379.9n -0.20712 81380.0n 0.12598 81509.9n 0.12598 81510.0n 1.10545 81639.9n 1.10545 81640.0n 1.25282 81769.9n 1.25282 81770.0n 1.37666 81899.9n 1.37666 81900.0n -0.43391 82029.9n -0.43391 82030.0n 0.62489 82159.9n 0.62489 82160.0n 0.64220 82289.9n 0.64220 82290.0n -0.04281 82419.9n -0.04281 82420.0n -0.30757 82549.9n -0.30757 82550.0n 1.27950 82679.9n 1.27950 82680.0n 0.89863 82809.9n 0.89863 82810.0n -0.20727 82939.9n -0.20727 82940.0n -0.40210 83069.9n -0.40210 83070.0n -0.03003 83199.9n -0.03003 83200.0n 1.27250 83329.9n 1.27250 83330.0n 1.24444 83459.9n 1.24444 83460.0n 0.18165 83589.9n 0.18165 83590.0n 0.88208 83719.9n 0.88208 83720.0n 1.41822 83849.9n 1.41822 83850.0n 0.24758 83979.9n 0.24758 83980.0n 0.42646 84109.9n 0.42646 84110.0n -0.22124 84239.9n -0.22124 84240.0n 0.51542 84369.9n 0.51542 84370.0n 0.43405 84499.9n 0.43405 84500.0n 0.29878 84629.9n 0.29878 84630.0n 1.23386 84759.9n 1.23386 84760.0n 0.34158 84889.9n 0.34158 84890.0n 0.74089 85019.9n 0.74089 85020.0n -0.23180 85149.9n -0.23180 85150.0n -0.18224 85279.9n -0.18224 85280.0n 0.33904 85409.9n 0.33904 85410.0n 0.23585 85539.9n 0.23585 85540.0n 0.36518 85669.9n 0.36518 85670.0n 1.37792 85799.9n 1.37792 85800.0n 0.57446 85929.9n 0.57446 85930.0n -0.27694 86059.9n -0.27694 86060.0n -0.28574 86189.9n -0.28574 86190.0n 0.71300 86319.9n 0.71300 86320.0n 0.32870 86449.9n 0.32870 86450.0n 0.65987 86579.9n 0.65987 86580.0n 0.86774 86709.9n 0.86774 86710.0n 1.08309 86839.9n 1.08309 86840.0n 1.21828 86969.9n 1.21828 86970.0n 1.15161 87099.9n 1.15161 87100.0n -0.17517 87229.9n -0.17517 87230.0n -0.11225 87359.9n -0.11225 87360.0n 0.71811 87489.9n 0.71811 87490.0n 1.33158 87619.9n 1.33158 87620.0n 0.76165 87749.9n 0.76165 87750.0n 0.66829 87879.9n 0.66829 87880.0n 0.65987 88009.9n 0.65987 88010.0n 1.08309 88139.9n 1.08309 88140.0n 0.57446 88269.9n 0.57446 88270.0n 0.51542 88399.9n 0.51542 88400.0n 1.23386 88529.9n 1.23386 88530.0n 0.33904 88659.9n 0.33904 88660.0n -0.17517 88789.9n -0.17517 88790.0n 0.71811 88919.9n 0.71811 88920.0n 0.32870 89049.9n 0.32870 89050.0n 0.34158 89179.9n 0.34158 89180.0n 0.29878 89309.9n 0.29878 89310.0n -0.27694 89439.9n -0.27694 89440.0n 0.71300 89569.9n 0.71300 89570.0n -0.18224 89699.9n -0.18224 89700.0n -0.11225 89829.9n -0.11225 89830.0n 1.21828 89959.9n 1.21828 89960.0n 0.86774 90089.9n 0.86774 90090.0n 0.76165 90219.9n 0.76165 90220.0n 0.36518 90349.9n 0.36518 90350.0n 1.33158 90479.9n 1.33158 90480.0n 0.23585 90609.9n 0.23585 90610.0n 0.66829 90739.9n 0.66829 90740.0n 1.15161 90869.9n 1.15161 90870.0n 1.37792 90999.9n 1.37792 91000.0n -0.23180 91129.9n -0.23180 91130.0n -0.28574 91259.9n -0.28574 91260.0n 0.43405 91389.9n 0.43405 91390.0n 0.74089 91519.9n 0.74089 91520.0n 1.37792 91649.9n 1.37792 91650.0n -0.23180 91779.9n -0.23180 91780.0n -0.27694 91909.9n -0.27694 91910.0n 0.36518 92039.9n 0.36518 92040.0n 0.57446 92169.9n 0.57446 92170.0n 1.23386 92299.9n 1.23386 92300.0n -0.28574 92429.9n -0.28574 92430.0n 0.76165 92559.9n 0.76165 92560.0n 1.08309 92689.9n 1.08309 92690.0n 0.23585 92819.9n 0.23585 92820.0n 0.74089 92949.9n 0.74089 92950.0n 0.51542 93079.9n 0.51542 93080.0n 1.33158 93209.9n 1.33158 93210.0n 0.33904 93339.9n 0.33904 93340.0n 0.86774 93469.9n 0.86774 93470.0n 1.15161 93599.9n 1.15161 93600.0n 0.29878 93729.9n 0.29878 93730.0n 0.65987 93859.9n 0.65987 93860.0n 1.21828 93989.9n 1.21828 93990.0n 0.34158 94119.9n 0.34158 94120.0n -0.11225 94249.9n -0.11225 94250.0n 0.43405 94379.9n 0.43405 94380.0n -0.18224 94509.9n -0.18224 94510.0n -0.17517 94639.9n -0.17517 94640.0n 0.71300 94769.9n 0.71300 94770.0n 0.66829 94899.9n 0.66829 94900.0n 0.32870 95029.9n 0.32870 95030.0n 0.71811 95159.9n 0.71811 95160.0n 0.76165 95289.9n 0.76165 95290.0n 0.23585 95419.9n 0.23585 95420.0n -0.23180 95549.9n -0.23180 95550.0n -0.28574 95679.9n -0.28574 95680.0n 0.66829 95809.9n 0.66829 95810.0n 0.36518 95939.9n 0.36518 95940.0n 0.71300 96069.9n 0.71300 96070.0n -0.18224 96199.9n -0.18224 96200.0n 0.43405 96329.9n 0.43405 96330.0n 1.37792 96459.9n 1.37792 96460.0n 1.15161 96589.9n 1.15161 96590.0n 0.57446 96719.9n 0.57446 96720.0n 1.21828 96849.9n 1.21828 96850.0n 0.71811 96979.9n 0.71811 96980.0n 0.34158 97109.9n 0.34158 97110.0n 0.51542 97239.9n 0.51542 97240.0n -0.27694 97369.9n -0.27694 97370.0n -0.11225 97499.9n -0.11225 97500.0n 0.86774 97629.9n 0.86774 97630.0n 1.23386 97759.9n 1.23386 97760.0n -0.17517 97889.9n -0.17517 97890.0n 0.65987 98019.9n 0.65987 98020.0n 0.74089 98149.9n 0.74089 98150.0n 0.32870 98279.9n 0.32870 98280.0n 0.33904 98409.9n 0.33904 98410.0n 1.33158 98539.9n 1.33158 98540.0n 1.08309 98669.9n 1.08309 98670.0n 0.29878 98799.9n 0.29878 98800.0n 1.37792 98929.9n 1.37792 98930.0n 0.29878 99059.9n 0.29878 99060.0n 0.57446 99189.9n 0.57446 99190.0n 0.34158 99319.9n 0.34158 99320.0n 1.21828 99449.9n 1.21828 99450.0n 0.32870 99579.9n 0.32870 99580.0n -0.11225 99709.9n -0.11225 99710.0n 0.65987 99839.9n 0.65987 99840.0n -0.17517 99969.9n -0.17517 99970.0n -0.23180 100099.9n -0.23180 100100.0n 0.86774 100229.9n 0.86774 100230.0n 1.08309 100359.9n 1.08309 100360.0n -0.18224 100489.9n -0.18224 100490.0n 0.66829 100619.9n 0.66829 100620.0n 0.71300 100749.9n 0.71300 100750.0n 0.33904 100879.9n 0.33904 100880.0n 1.33158 101009.9n 1.33158 101010.0n 0.71811 101139.9n 0.71811 101140.0n -0.28574 101269.9n -0.28574 101270.0n 1.15161 101399.9n 1.15161 101400.0n 0.43405 101529.9n 0.43405 101530.0n 0.36518 101659.9n 0.36518 101660.0n 0.23585 101789.9n 0.23585 101790.0n 1.23386 101919.9n 1.23386 101920.0n 0.51542 102049.9n 0.51542 102050.0n 0.76165 102179.9n 0.76165 102180.0n -0.27694 102309.9n -0.27694 102310.0n 0.74089 102439.9n 0.74089 102440.0n 0.34158 102569.9n 0.34158 102570.0n 0.23585 102699.9n 0.23585 102700.0n -0.17517 102829.9n -0.17517 102830.0n -0.11225 102959.9n -0.11225 102960.0n -0.27694 103089.9n -0.27694 103090.0n 1.23386 103219.9n 1.23386 103220.0n 0.36518 103349.9n 0.36518 103350.0n 0.29878 103479.9n 0.29878 103480.0n 0.74089 103609.9n 0.74089 103610.0n 1.33158 103739.9n 1.33158 103740.0n 0.57446 103869.9n 0.57446 103870.0n 0.33904 103999.9n 0.33904 104000.0n 0.66829 104129.9n 0.66829 104130.0n 0.43405 104259.9n 0.43405 104260.0n 0.51542 104389.9n 0.51542 104390.0n -0.23180 104519.9n -0.23180 104520.0n -0.28574 104649.9n -0.28574 104650.0n 0.71300 104779.9n 0.71300 104780.0n -0.18224 104909.9n -0.18224 104910.0n 1.08309 105039.9n 1.08309 105040.0n 0.76165 105169.9n 0.76165 105170.0n 1.21828 105299.9n 1.21828 105300.0n 0.32870 105429.9n 0.32870 105430.0n 0.65987 105559.9n 0.65987 105560.0n 1.37792 105689.9n 1.37792 105690.0n 0.71811 105819.9n 0.71811 105820.0n 1.15161 105949.9n 1.15161 105950.0n 0.86774 106079.9n 0.86774 106080.0n 0.70085 106209.9n 0.70085 106210.0n 0.59687 106339.9n 0.59687 106340.0n 0.63424 106469.9n 0.63424 106470.0n 0.66270 106599.9n 0.66270 106600.0n 0.61615 106729.9n 0.61615 106730.0n 0.40294 106859.9n 0.40294 106860.0n 0.37693 106989.9n 0.37693 106990.0n 0.32982 107119.9n 0.32982 107120.0n 0.29460 107249.9n 0.29460 107250.0n 0.46418 107379.9n 0.46418 107380.0n 0.66643 107509.9n 0.66643 107510.0n 0.47115 107639.9n 0.47115 107640.0n 0.25617 107769.9n 0.25617 107770.0n 0.21591 107899.9n 0.21591 107900.0n 0.48064 108029.9n 0.48064 108030.0n 0.49468 108159.9n 0.49468 108160.0n 0.31811 108289.9n 0.31811 108290.0n 0.20138 108419.9n 0.20138 108420.0n 0.64950 108549.9n 0.64950 108550.0n 0.83142 108679.9n 0.83142 108680.0n 0.44747 108809.9n 0.44747 108810.0n 0.39177 108939.9n 0.39177 108940.0n 0.36389 109069.9n 0.36389 109070.0n 0.58803 109199.9n 0.58803 109200.0n 0.40753 109329.9n 0.40753 109330.0n -0.20712 109459.9n -0.20712 109460.0n 0.12598 109589.9n 0.12598 109590.0n 1.10545 109719.9n 1.10545 109720.0n 1.25282 109849.9n 1.25282 109850.0n 1.37666 109979.9n 1.37666 109980.0n -0.43391 110109.9n -0.43391 110110.0n 0.62489 110239.9n 0.62489 110240.0n 0.64220 110369.9n 0.64220 110370.0n -0.04281 110499.9n -0.04281 110500.0n -0.30757 110629.9n -0.30757 110630.0n 1.27950 110759.9n 1.27950 110760.0n 0.89863 110889.9n 0.89863 110890.0n -0.20727 111019.9n -0.20727 111020.0n -0.40210 111149.9n -0.40210 111150.0n -0.03003 111279.9n -0.03003 111280.0n 1.27250 111409.9n 1.27250 111410.0n 1.24444 111539.9n 1.24444 111540.0n 0.18165 111669.9n 0.18165 111670.0n 0.88208 111799.9n 0.88208 111800.0n 1.41822 111929.9n 1.41822 111930.0n 0.24758 112059.9n 0.24758 112060.0n 0.42646 112189.9n 0.42646 112190.0n -0.22124 112319.9n -0.22124 112320.0n 0.76165 112449.9n 0.76165 112450.0n 0.33904 112579.9n 0.33904 112580.0n 0.86774 112709.9n 0.86774 112710.0n 0.32870 112839.9n 0.32870 112840.0n 1.08309 112969.9n 1.08309 112970.0n 0.74089 113099.9n 0.74089 113100.0n 0.43405 113229.9n 0.43405 113230.0n 1.15161 113359.9n 1.15161 113360.0n -0.11225 113489.9n -0.11225 113490.0n 0.71300 113619.9n 0.71300 113620.0n 0.29878 113749.9n 0.29878 113750.0n -0.27694 113879.9n -0.27694 113880.0n 1.23386 114009.9n 1.23386 114010.0n 0.57446 114139.9n 0.57446 114140.0n 0.65987 114269.9n 0.65987 114270.0n 0.23585 114399.9n 0.23585 114400.0n 0.71811 114529.9n 0.71811 114530.0n -0.28574 114659.9n -0.28574 114660.0n 0.51542 114789.9n 0.51542 114790.0n 1.21828 114919.9n 1.21828 114920.0n 1.33158 115049.9n 1.33158 115050.0n -0.17517 115179.9n -0.17517 115180.0n 0.36518 115309.9n 0.36518 115310.0n -0.23180 115439.9n -0.23180 115440.0n 0.34158 115569.9n 0.34158 115570.0n 1.37792 115699.9n 1.37792 115700.0n 0.66829 115829.9n 0.66829 115830.0n -0.18224 115959.9n -0.18224 115960.0n -0.17517 116089.9n -0.17517 116090.0n 0.51542 116219.9n 0.51542 116220.0n 0.34158 116349.9n 0.34158 116350.0n 1.08309 116479.9n 1.08309 116480.0n 0.71811 116609.9n 0.71811 116610.0n 0.33904 116739.9n 0.33904 116740.0n 0.32870 116869.9n 0.32870 116870.0n 0.29878 116999.9n 0.29878 117000.0n -0.11225 117129.9n -0.11225 117130.0n 0.36518 117259.9n 0.36518 117260.0n -0.27694 117389.9n -0.27694 117390.0n 0.65987 117519.9n 0.65987 117520.0n 0.57446 117649.9n 0.57446 117650.0n -0.28574 117779.9n -0.28574 117780.0n 0.23585 117909.9n 0.23585 117910.0n 0.71300 118039.9n 0.71300 118040.0n 1.37792 118169.9n 1.37792 118170.0n 0.66829 118299.9n 0.66829 118300.0n 1.15161 118429.9n 1.15161 118430.0n 0.86774 118559.9n 0.86774 118560.0n 1.23386 118689.9n 1.23386 118690.0n 1.33158 118819.9n 1.33158 118820.0n 0.76165 118949.9n 0.76165 118950.0n 1.21828 119079.9n 1.21828 119080.0n 0.74089 119209.9n 0.74089 119210.0n 0.43405 119339.9n 0.43405 119340.0n -0.18224 119469.9n -0.18224 119470.0n -0.23180 119599.9n -0.23180 119600.0n 0.43405 119729.9n 0.43405 119730.0n 1.21828 119859.9n 1.21828 119860.0n 0.71300 119989.9n 0.71300 119990.0n 1.08309 120119.9n 1.08309 120120.0n 0.29878 120249.9n 0.29878 120250.0n 1.37792 120379.9n 1.37792 120380.0n 0.33904 120509.9n 0.33904 120510.0n 0.71811 120639.9n 0.71811 120640.0n -0.28574 120769.9n -0.28574 120770.0n -0.11225 120899.9n -0.11225 120900.0n 0.51542 121029.9n 0.51542 121030.0n 0.36518 121159.9n 0.36518 121160.0n 1.33158 121289.9n 1.33158 121290.0n 0.23585 121419.9n 0.23585 121420.0n 0.34158 121549.9n 0.34158 121550.0n -0.18224 121679.9n -0.18224 121680.0n -0.27694 121809.9n -0.27694 121810.0n 0.76165 121939.9n 0.76165 121940.0n -0.17517 122069.9n -0.17517 122070.0n -0.23180 122199.9n -0.23180 122200.0n 0.66829 122329.9n 0.66829 122330.0n 0.32870 122459.9n 0.32870 122460.0n 0.65987 122589.9n 0.65987 122590.0n 1.23386 122719.9n 1.23386 122720.0n 0.86774 122849.9n 0.86774 122850.0n 0.57446 122979.9n 0.57446 122980.0n 1.15161 123109.9n 1.15161 123110.0n 0.74089 123239.9n 0.74089 123240.0n 0.76165 123369.9n 0.76165 123370.0n 0.74089 123499.9n 0.74089 123500.0n -0.18224 123629.9n -0.18224 123630.0n -0.28574 123759.9n -0.28574 123760.0n 0.29878 123889.9n 0.29878 123890.0n 0.51542 124019.9n 0.51542 124020.0n 0.71300 124149.9n 0.71300 124150.0n 0.86774 124279.9n 0.86774 124280.0n 1.23386 124409.9n 1.23386 124410.0n 0.71811 124539.9n 0.71811 124540.0n 0.32870 124669.9n 0.32870 124670.0n -0.11225 124799.9n -0.11225 124800.0n 1.21828 124929.9n 1.21828 124930.0n 0.23585 125059.9n 0.23585 125060.0n -0.23180 125189.9n -0.23180 125190.0n 1.08309 125319.9n 1.08309 125320.0n 0.57446 125449.9n 0.57446 125450.0n 0.66829 125579.9n 0.66829 125580.0n 1.15161 125709.9n 1.15161 125710.0n 1.33158 125839.9n 1.33158 125840.0n 0.43405 125969.9n 0.43405 125970.0n 0.65987 126099.9n 0.65987 126100.0n 1.37792 126229.9n 1.37792 126230.0n -0.17517 126359.9n -0.17517 126360.0n 0.36518 126489.9n 0.36518 126490.0n 0.34158 126619.9n 0.34158 126620.0n -0.27694 126749.9n -0.27694 126750.0n 0.33904 126879.9n 0.33904 126880.0n -0.11225 127009.9n -0.11225 127010.0n 1.15161 127139.9n 1.15161 127140.0n 0.57446 127269.9n 0.57446 127270.0n 1.37792 127399.9n 1.37792 127400.0n 0.65987 127529.9n 0.65987 127530.0n 0.33904 127659.9n 0.33904 127660.0n -0.18224 127789.9n -0.18224 127790.0n -0.17517 127919.9n -0.17517 127920.0n 0.74089 128049.9n 0.74089 128050.0n 0.71811 128179.9n 0.71811 128180.0n 0.71300 128309.9n 0.71300 128310.0n 1.23386 128439.9n 1.23386 128440.0n 0.86774 128569.9n 0.86774 128570.0n 1.33158 128699.9n 1.33158 128700.0n 0.29878 128829.9n 0.29878 128830.0n 0.32870 128959.9n 0.32870 128960.0n 0.34158 129089.9n 0.34158 129090.0n 0.23585 129219.9n 0.23585 129220.0n 0.36518 129349.9n 0.36518 129350.0n 0.66829 129479.9n 0.66829 129480.0n -0.28574 129609.9n -0.28574 129610.0n 0.51542 129739.9n 0.51542 129740.0n 1.08309 129869.9n 1.08309 129870.0n 1.21828 129999.9n 1.21828 130000.0n -0.23180 130129.9n -0.23180 130130.0n -0.27694 130259.9n -0.27694 130260.0n 0.43405 130389.9n 0.43405 130390.0n 0.76165 130519.9n 0.76165 130520.0n 0.86774 130649.9n 0.86774 130650.0n 0.33904 130779.9n 0.33904 130780.0n 0.65987 130909.9n 0.65987 130910.0n 1.08309 131039.9n 1.08309 131040.0n 1.23386 131169.9n 1.23386 131170.0n -0.28574 131299.9n -0.28574 131300.0n -0.23180 131429.9n -0.23180 131430.0n 1.37792 131559.9n 1.37792 131560.0n 0.51542 131689.9n 0.51542 131690.0n 0.43405 131819.9n 0.43405 131820.0n 0.29878 131949.9n 0.29878 131950.0n 1.33158 132079.9n 1.33158 132080.0n 0.76165 132209.9n 0.76165 132210.0n -0.18224 132339.9n -0.18224 132340.0n 0.23585 132469.9n 0.23585 132470.0n -0.17517 132599.9n -0.17517 132600.0n -0.27694 132729.9n -0.27694 132730.0n 0.36518 132859.9n 0.36518 132860.0n 0.71811 132989.9n 0.71811 132990.0n 0.32870 133119.9n 0.32870 133120.0n 0.57446 133249.9n 0.57446 133250.0n 0.74089 133379.9n 0.74089 133380.0n 1.15161 133509.9n 1.15161 133510.0n 0.71300 133639.9n 0.71300 133640.0n 0.66829 133769.9n 0.66829 133770.0n -0.11225 133899.9n -0.11225 133900.0n 0.34158 134029.9n 0.34158 134030.0n 1.21828 134159.9n 1.21828 134160.0n 0.70085 134289.9n 0.70085 134290.0n 0.59687 134419.9n 0.59687 134420.0n 0.63424 134549.9n 0.63424 134550.0n 0.66270 134679.9n 0.66270 134680.0n 0.61615 134809.9n 0.61615 134810.0n 0.40294 134939.9n 0.40294 134940.0n 0.37693 135069.9n 0.37693 135070.0n 0.32982 135199.9n 0.32982 135200.0n 0.29460 135329.9n 0.29460 135330.0n 0.46418 135459.9n 0.46418 135460.0n 0.66643 135589.9n 0.66643 135590.0n 0.47115 135719.9n 0.47115 135720.0n 0.25617 135849.9n 0.25617 135850.0n 0.21591 135979.9n 0.21591 135980.0n 0.48064 136109.9n 0.48064 136110.0n 0.49468 136239.9n 0.49468 136240.0n 0.31811 136369.9n 0.31811 136370.0n 0.20138 136499.9n 0.20138 136500.0n 0.64950 136629.9n 0.64950 136630.0n 0.83142 136759.9n 0.83142 136760.0n 0.44747 136889.9n 0.44747 136890.0n 0.39177 137019.9n 0.39177 137020.0n 0.36389 137149.9n 0.36389 137150.0n 0.58803 137279.9n 0.58803 137280.0n 0.40753 137409.9n 0.40753 137410.0n -0.20712 137539.9n -0.20712 137540.0n 0.12598 137669.9n 0.12598 137670.0n 1.10545 137799.9n 1.10545 137800.0n 1.25282 137929.9n 1.25282 137930.0n 1.37666 138059.9n 1.37666 138060.0n -0.43391 138189.9n -0.43391 138190.0n 0.62489 138319.9n 0.62489 138320.0n 0.64220 138449.9n 0.64220 138450.0n -0.04281 138579.9n -0.04281 138580.0n -0.30757 138709.9n -0.30757 138710.0n 1.27950 138839.9n 1.27950 138840.0n 0.89863 138969.9n 0.89863 138970.0n -0.20727 139099.9n -0.20727 139100.0n -0.40210 139229.9n -0.40210 139230.0n -0.03003 139359.9n -0.03003 139360.0n 1.27250 139489.9n 1.27250 139490.0n 1.24444 139619.9n 1.24444 139620.0n 0.18165 139749.9n 0.18165 139750.0n 0.88208 139879.9n 0.88208 139880.0n 1.41822 140009.9n 1.41822 140010.0n 0.24758 140139.9n 0.24758 140140.0n 0.42646 140269.9n 0.42646 140270.0n -0.22124 140399.9n -0.22124 140400.0n 1.37792 140529.9n 1.37792 140530.0n 0.33904 140659.9n 0.33904 140660.0n -0.17517 140789.9n -0.17517 140790.0n 1.23386 140919.9n 1.23386 140920.0n 0.36518 141049.9n 0.36518 141050.0n 0.66829 141179.9n 0.66829 141180.0n -0.18224 141309.9n -0.18224 141310.0n 0.32870 141439.9n 0.32870 141440.0n 0.71300 141569.9n 0.71300 141570.0n 0.43405 141699.9n 0.43405 141700.0n 0.74089 141829.9n 0.74089 141830.0n -0.27694 141959.9n -0.27694 141960.0n -0.28574 142089.9n -0.28574 142090.0n 1.08309 142219.9n 1.08309 142220.0n 0.51542 142349.9n 0.51542 142350.0n 1.33158 142479.9n 1.33158 142480.0n 0.23585 142609.9n 0.23585 142610.0n -0.11225 142739.9n -0.11225 142740.0n 1.21828 142869.9n 1.21828 142870.0n 0.86774 142999.9n 0.86774 143000.0n -0.23180 143129.9n -0.23180 143130.0n 0.57446 143259.9n 0.57446 143260.0n 1.15161 143389.9n 1.15161 143390.0n 0.76165 143519.9n 0.76165 143520.0n 0.71811 143649.9n 0.71811 143650.0n 0.29878 143779.9n 0.29878 143780.0n 0.34158 143909.9n 0.34158 143910.0n 0.65987 144039.9n 0.65987 144040.0n 0.86774 144169.9n 0.86774 144170.0n 0.71300 144299.9n 0.71300 144300.0n 0.57446 144429.9n 0.57446 144430.0n 0.34158 144559.9n 0.34158 144560.0n 0.71811 144689.9n 0.71811 144690.0n 0.66829 144819.9n 0.66829 144820.0n -0.17517 144949.9n -0.17517 144950.0n 0.32870 145079.9n 0.32870 145080.0n 0.51542 145209.9n 0.51542 145210.0n -0.11225 145339.9n -0.11225 145340.0n 1.33158 145469.9n 1.33158 145470.0n -0.23180 145599.9n -0.23180 145600.0n 0.29878 145729.9n 0.29878 145730.0n 0.43405 145859.9n 0.43405 145860.0n -0.28574 145989.9n -0.28574 145990.0n 1.23386 146119.9n 1.23386 146120.0n 1.08309 146249.9n 1.08309 146250.0n 0.76165 146379.9n 0.76165 146380.0n 1.15161 146509.9n 1.15161 146510.0n 0.36518 146639.9n 0.36518 146640.0n 0.74089 146769.9n 0.74089 146770.0n 0.33904 146899.9n 0.33904 146900.0n 0.23585 147029.9n 0.23585 147030.0n -0.27694 147159.9n -0.27694 147160.0n 1.37792 147289.9n 1.37792 147290.0n 0.65987 147419.9n 0.65987 147420.0n 1.21828 147549.9n 1.21828 147550.0n -0.18224 147679.9n -0.18224 147680.0n 0.34158 147809.9n 0.34158 147810.0n 1.21828 147939.9n 1.21828 147940.0n 0.66829 148069.9n 0.66829 148070.0n -0.18224 148199.9n -0.18224 148200.0n -0.17517 148329.9n -0.17517 148330.0n -0.28574 148459.9n -0.28574 148460.0n 0.86774 148589.9n 0.86774 148590.0n 0.36518 148719.9n 0.36518 148720.0n 0.71300 148849.9n 0.71300 148850.0n 0.76165 148979.9n 0.76165 148980.0n 0.32870 149109.9n 0.32870 149110.0n 0.29878 149239.9n 0.29878 149240.0n -0.11225 149369.9n -0.11225 149370.0n -0.23180 149499.9n -0.23180 149500.0n 0.65987 149629.9n 0.65987 149630.0n 1.23386 149759.9n 1.23386 149760.0n -0.27694 149889.9n -0.27694 149890.0n 0.71811 150019.9n 0.71811 150020.0n 0.23585 150149.9n 0.23585 150150.0n 1.15161 150279.9n 1.15161 150280.0n 0.33904 150409.9n 0.33904 150410.0n 0.57446 150539.9n 0.57446 150540.0n 1.37792 150669.9n 1.37792 150670.0n 0.51542 150799.9n 0.51542 150800.0n 1.33158 150929.9n 1.33158 150930.0n 1.08309 151059.9n 1.08309 151060.0n 0.43405 151189.9n 0.43405 151190.0n 0.74089 151319.9n 0.74089 151320.0n 1.23386 151449.9n 1.23386 151450.0n 0.23585 151579.9n 0.23585 151580.0n -0.27694 151709.9n -0.27694 151710.0n 0.32870 151839.9n 0.32870 151840.0n 0.76165 151969.9n 0.76165 151970.0n -0.23180 152099.9n -0.23180 152100.0n 0.71811 152229.9n 0.71811 152230.0n 1.21828 152359.9n 1.21828 152360.0n 0.43405 152489.9n 0.43405 152490.0n -0.28574 152619.9n -0.28574 152620.0n -0.17517 152749.9n -0.17517 152750.0n 0.65987 152879.9n 0.65987 152880.0n 0.57446 153009.9n 0.57446 153010.0n 1.37792 153139.9n 1.37792 153140.0n 0.66829 153269.9n 0.66829 153270.0n 1.15161 153399.9n 1.15161 153400.0n 1.33158 153529.9n 1.33158 153530.0n 0.74089 153659.9n 0.74089 153660.0n 0.34158 153789.9n 0.34158 153790.0n 0.33904 153919.9n 0.33904 153920.0n 0.71300 154049.9n 0.71300 154050.0n -0.18224 154179.9n -0.18224 154180.0n -0.11225 154309.9n -0.11225 154310.0n 0.29878 154439.9n 0.29878 154440.0n 0.36518 154569.9n 0.36518 154570.0n 0.51542 154699.9n 0.51542 154700.0n 0.86774 154829.9n 0.86774 154830.0n 1.08309 154959.9n 1.08309 154960.0n 0.71300 155089.9n 0.71300 155090.0n 0.32870 155219.9n 0.32870 155220.0n 1.15161 155349.9n 1.15161 155350.0n 0.36518 155479.9n 0.36518 155480.0n 0.51542 155609.9n 0.51542 155610.0n -0.11225 155739.9n -0.11225 155740.0n 0.76165 155869.9n 0.76165 155870.0n 0.23585 155999.9n 0.23585 156000.0n 0.57446 156129.9n 0.57446 156130.0n -0.23180 156259.9n -0.23180 156260.0n 0.74089 156389.9n 0.74089 156390.0n 0.65987 156519.9n 0.65987 156520.0n 0.86774 156649.9n 0.86774 156650.0n 1.08309 156779.9n 1.08309 156780.0n -0.18224 156909.9n -0.18224 156910.0n 0.33904 157039.9n 0.33904 157040.0n -0.27694 157169.9n -0.27694 157170.0n 0.71811 157299.9n 0.71811 157300.0n 0.29878 157429.9n 0.29878 157430.0n 0.66829 157559.9n 0.66829 157560.0n -0.17517 157689.9n -0.17517 157690.0n 1.23386 157819.9n 1.23386 157820.0n 0.43405 157949.9n 0.43405 157950.0n -0.28574 158079.9n -0.28574 158080.0n 1.37792 158209.9n 1.37792 158210.0n 1.21828 158339.9n 1.21828 158340.0n 0.34158 158469.9n 0.34158 158470.0n 1.33158 158599.9n 1.33158 158600.0n 0.76165 158729.9n 0.76165 158730.0n 0.33904 158859.9n 0.33904 158860.0n 0.51542 158989.9n 0.51542 158990.0n 0.74089 159119.9n 0.74089 159120.0n 1.15161 159249.9n 1.15161 159250.0n -0.17517 159379.9n -0.17517 159380.0n 0.32870 159509.9n 0.32870 159510.0n 0.36518 159639.9n 0.36518 159640.0n 0.65987 159769.9n 0.65987 159770.0n 0.34158 159899.9n 0.34158 159900.0n 1.23386 160029.9n 1.23386 160030.0n 1.33158 160159.9n 1.33158 160160.0n -0.28574 160289.9n -0.28574 160290.0n 0.57446 160419.9n 0.57446 160420.0n 0.23585 160549.9n 0.23585 160550.0n 1.21828 160679.9n 1.21828 160680.0n -0.23180 160809.9n -0.23180 160810.0n 1.08309 160939.9n 1.08309 160940.0n 0.66829 161069.9n 0.66829 161070.0n -0.27694 161199.9n -0.27694 161200.0n 0.43405 161329.9n 0.43405 161330.0n -0.11225 161459.9n -0.11225 161460.0n 1.37792 161589.9n 1.37792 161590.0n 0.29878 161719.9n 0.29878 161720.0n -0.18224 161849.9n -0.18224 161850.0n 0.71300 161979.9n 0.71300 161980.0n 0.71811 162109.9n 0.71811 162110.0n 0.86774 162239.9n 0.86774 162240.0n 0.70085 162369.9n 0.70085 162370.0n 0.59687 162499.9n 0.59687 162500.0n 0.63424 162629.9n 0.63424 162630.0n 0.66270 162759.9n 0.66270 162760.0n 0.61615 162889.9n 0.61615 162890.0n 0.40294 163019.9n 0.40294 163020.0n 0.37693 163149.9n 0.37693 163150.0n 0.32982 163279.9n 0.32982 163280.0n 0.29460 163409.9n 0.29460 163410.0n 0.46418 163539.9n 0.46418 163540.0n 0.66643 163669.9n 0.66643 163670.0n 0.47115 163799.9n 0.47115 163800.0n 0.25617 163929.9n 0.25617 163930.0n 0.21591 164059.9n 0.21591 164060.0n 0.48064 164189.9n 0.48064 164190.0n 0.49468 164319.9n 0.49468 164320.0n 0.31811 164449.9n 0.31811 164450.0n 0.20138 164579.9n 0.20138 164580.0n 0.64950 164709.9n 0.64950 164710.0n 0.83142 164839.9n 0.83142 164840.0n 0.44747 164969.9n 0.44747 164970.0n 0.39177 165099.9n 0.39177 165100.0n 0.36389 165229.9n 0.36389 165230.0n 0.58803 165359.9n 0.58803 165360.0n 0.40753 165489.9n 0.40753 165490.0n -0.20712 165619.9n -0.20712 165620.0n 0.12598 165749.9n 0.12598 165750.0n 1.10545 165879.9n 1.10545 165880.0n 1.25282 166009.9n 1.25282 166010.0n 1.37666 166139.9n 1.37666 166140.0n -0.43391 166269.9n -0.43391 166270.0n 0.62489 166399.9n 0.62489 166400.0n 0.64220 166529.9n 0.64220 166530.0n -0.04281 166659.9n -0.04281 166660.0n -0.30757 166789.9n -0.30757 166790.0n 1.27950 166919.9n 1.27950 166920.0n 0.89863 167049.9n 0.89863 167050.0n -0.20727 167179.9n -0.20727 167180.0n -0.40210 167309.9n -0.40210 167310.0n -0.03003 167439.9n -0.03003 167440.0n 1.27250 167569.9n 1.27250 167570.0n 1.24444 167699.9n 1.24444 167700.0n 0.18165 167829.9n 0.18165 167830.0n 0.88208 167959.9n 0.88208 167960.0n 1.41822 168089.9n 1.41822 168090.0n 0.24758 168219.9n 0.24758 168220.0n 0.42646 168349.9n 0.42646 168350.0n -0.22124)
Vxp2 a_xp2 0 PWL(0.0n 0.80000 129.9n 0.80000 130.0n 0.80000 259.9n 0.80000 260.0n 0.80000 389.9n 0.80000 390.0n 0.80000 519.9n 0.80000 520.0n 0.80000 649.9n 0.80000 650.0n 0.80000 779.9n 0.80000 780.0n 0.80000 909.9n 0.80000 910.0n 0.80000 1039.9n 0.80000 1040.0n 0.80000 1169.9n 0.80000 1170.0n 0.80000 1299.9n 0.80000 1300.0n 0.80000 1429.9n 0.80000 1430.0n 0.80000 1559.9n 0.80000 1560.0n 0.80000 1689.9n 0.80000 1690.0n 0.80000 1819.9n 0.80000 1820.0n 0.80000 1949.9n 0.80000 1950.0n 0.80000 2079.9n 0.80000 2080.0n 0.80000 2209.9n 0.80000 2210.0n 0.80000 2339.9n 0.80000 2340.0n 0.80000 2469.9n 0.80000 2470.0n 0.80000 2599.9n 0.80000 2600.0n 0.80000 2729.9n 0.80000 2730.0n 0.80000 2859.9n 0.80000 2860.0n 0.80000 2989.9n 0.80000 2990.0n 0.80000 3119.9n 0.80000 3120.0n 0.80000 3249.9n 0.80000 3250.0n 0.80000 3379.9n 0.80000 3380.0n 0.80000 3509.9n 0.80000 3510.0n 0.80000 3639.9n 0.80000 3640.0n 0.80000 3769.9n 0.80000 3770.0n 0.80000 3899.9n 0.80000 3900.0n 0.80000 4029.9n 0.80000 4030.0n 0.80000 4159.9n 0.80000 4160.0n 0.80000 4289.9n 0.80000 4290.0n 0.80000 4419.9n 0.80000 4420.0n 0.80000 4549.9n 0.80000 4550.0n 0.80000 4679.9n 0.80000 4680.0n 0.80000 4809.9n 0.80000 4810.0n 0.80000 4939.9n 0.80000 4940.0n 0.80000 5069.9n 0.80000 5070.0n 0.80000 5199.9n 0.80000 5200.0n 0.80000 5329.9n 0.80000 5330.0n 0.80000 5459.9n 0.80000 5460.0n 0.80000 5589.9n 0.80000 5590.0n 0.80000 5719.9n 0.80000 5720.0n 0.80000 5849.9n 0.80000 5850.0n 0.80000 5979.9n 0.80000 5980.0n 0.80000 6109.9n 0.80000 6110.0n 0.80000 6239.9n 0.80000 6240.0n 0.80000 6369.9n 0.80000 6370.0n 0.80000 6499.9n 0.80000 6500.0n 0.80000 6629.9n 0.80000 6630.0n 0.80000 6759.9n 0.80000 6760.0n 0.80000 6889.9n 0.80000 6890.0n 0.80000 7019.9n 0.80000 7020.0n 0.80000 7149.9n 0.80000 7150.0n 0.80000 7279.9n 0.80000 7280.0n 0.80000 7409.9n 0.80000 7410.0n 0.80000 7539.9n 0.80000 7540.0n 0.80000 7669.9n 0.80000 7670.0n 0.80000 7799.9n 0.80000 7800.0n 0.80000 7929.9n 0.80000 7930.0n 0.80000 8059.9n 0.80000 8060.0n 0.80000 8189.9n 0.80000 8190.0n 0.80000 8319.9n 0.80000 8320.0n 0.80000 8449.9n 0.80000 8450.0n 0.80000 8579.9n 0.80000 8580.0n 0.80000 8709.9n 0.80000 8710.0n 0.80000 8839.9n 0.80000 8840.0n 0.80000 8969.9n 0.80000 8970.0n 0.80000 9099.9n 0.80000 9100.0n 0.80000 9229.9n 0.80000 9230.0n 0.80000 9359.9n 0.80000 9360.0n 0.80000 9489.9n 0.80000 9490.0n 0.80000 9619.9n 0.80000 9620.0n 0.80000 9749.9n 0.80000 9750.0n 0.80000 9879.9n 0.80000 9880.0n 0.80000 10009.9n 0.80000 10010.0n 0.80000 10139.9n 0.80000 10140.0n 0.80000 10269.9n 0.80000 10270.0n 0.80000 10399.9n 0.80000 10400.0n 0.80000 10529.9n 0.80000 10530.0n 0.80000 10659.9n 0.80000 10660.0n 0.80000 10789.9n 0.80000 10790.0n 0.80000 10919.9n 0.80000 10920.0n 0.80000 11049.9n 0.80000 11050.0n 0.80000 11179.9n 0.80000 11180.0n 0.80000 11309.9n 0.80000 11310.0n 0.80000 11439.9n 0.80000 11440.0n 0.80000 11569.9n 0.80000 11570.0n 0.80000 11699.9n 0.80000 11700.0n 0.80000 11829.9n 0.80000 11830.0n 0.80000 11959.9n 0.80000 11960.0n 0.80000 12089.9n 0.80000 12090.0n 0.80000 12219.9n 0.80000 12220.0n 0.80000 12349.9n 0.80000 12350.0n 0.80000 12479.9n 0.80000 12480.0n 0.80000 12609.9n 0.80000 12610.0n 0.80000 12739.9n 0.80000 12740.0n 0.80000 12869.9n 0.80000 12870.0n 0.80000 12999.9n 0.80000 13000.0n 0.80000 13129.9n 0.80000 13130.0n 0.80000 13259.9n 0.80000 13260.0n 0.80000 13389.9n 0.80000 13390.0n 0.80000 13519.9n 0.80000 13520.0n 0.80000 13649.9n 0.80000 13650.0n 0.80000 13779.9n 0.80000 13780.0n 0.80000 13909.9n 0.80000 13910.0n 0.80000 14039.9n 0.80000 14040.0n 0.80000 14169.9n 0.80000 14170.0n 0.80000 14299.9n 0.80000 14300.0n 0.80000 14429.9n 0.80000 14430.0n 0.80000 14559.9n 0.80000 14560.0n 0.80000 14689.9n 0.80000 14690.0n 0.80000 14819.9n 0.80000 14820.0n 0.80000 14949.9n 0.80000 14950.0n 0.80000 15079.9n 0.80000 15080.0n 0.80000 15209.9n 0.80000 15210.0n 0.80000 15339.9n 0.80000 15340.0n 0.80000 15469.9n 0.80000 15470.0n 0.80000 15599.9n 0.80000 15600.0n 0.80000 15729.9n 0.80000 15730.0n 0.80000 15859.9n 0.80000 15860.0n 0.80000 15989.9n 0.80000 15990.0n 0.80000 16119.9n 0.80000 16120.0n 0.80000 16249.9n 0.80000 16250.0n 0.80000 16379.9n 0.80000 16380.0n 0.80000 16509.9n 0.80000 16510.0n 0.80000 16639.9n 0.80000 16640.0n 0.80000 16769.9n 0.80000 16770.0n 0.80000 16899.9n 0.80000 16900.0n 0.80000 17029.9n 0.80000 17030.0n 0.80000 17159.9n 0.80000 17160.0n 0.80000 17289.9n 0.80000 17290.0n 0.80000 17419.9n 0.80000 17420.0n 0.80000 17549.9n 0.80000 17550.0n 0.80000 17679.9n 0.80000 17680.0n 0.80000 17809.9n 0.80000 17810.0n 0.80000 17939.9n 0.80000 17940.0n 0.80000 18069.9n 0.80000 18070.0n 0.80000 18199.9n 0.80000 18200.0n 0.80000 18329.9n 0.80000 18330.0n 0.80000 18459.9n 0.80000 18460.0n 0.80000 18589.9n 0.80000 18590.0n 0.80000 18719.9n 0.80000 18720.0n 0.80000 18849.9n 0.80000 18850.0n 0.80000 18979.9n 0.80000 18980.0n 0.80000 19109.9n 0.80000 19110.0n 0.80000 19239.9n 0.80000 19240.0n 0.80000 19369.9n 0.80000 19370.0n 0.80000 19499.9n 0.80000 19500.0n 0.80000 19629.9n 0.80000 19630.0n 0.80000 19759.9n 0.80000 19760.0n 0.80000 19889.9n 0.80000 19890.0n 0.80000 20019.9n 0.80000 20020.0n 0.80000 20149.9n 0.80000 20150.0n 0.80000 20279.9n 0.80000 20280.0n 0.80000 20409.9n 0.80000 20410.0n 0.80000 20539.9n 0.80000 20540.0n 0.80000 20669.9n 0.80000 20670.0n 0.80000 20799.9n 0.80000 20800.0n 0.80000 20929.9n 0.80000 20930.0n 0.80000 21059.9n 0.80000 21060.0n 0.80000 21189.9n 0.80000 21190.0n 0.80000 21319.9n 0.80000 21320.0n 0.80000 21449.9n 0.80000 21450.0n 0.80000 21579.9n 0.80000 21580.0n 0.80000 21709.9n 0.80000 21710.0n 0.80000 21839.9n 0.80000 21840.0n 0.80000 21969.9n 0.80000 21970.0n 0.80000 22099.9n 0.80000 22100.0n 0.80000 22229.9n 0.80000 22230.0n 0.80000 22359.9n 0.80000 22360.0n 0.80000 22489.9n 0.80000 22490.0n 0.80000 22619.9n 0.80000 22620.0n 0.80000 22749.9n 0.80000 22750.0n 0.80000 22879.9n 0.80000 22880.0n 0.80000 23009.9n 0.80000 23010.0n 0.80000 23139.9n 0.80000 23140.0n 0.80000 23269.9n 0.80000 23270.0n 0.80000 23399.9n 0.80000 23400.0n 0.80000 23529.9n 0.80000 23530.0n 0.80000 23659.9n 0.80000 23660.0n 0.80000 23789.9n 0.80000 23790.0n 0.80000 23919.9n 0.80000 23920.0n 0.80000 24049.9n 0.80000 24050.0n 0.80000 24179.9n 0.80000 24180.0n 0.80000 24309.9n 0.80000 24310.0n 0.80000 24439.9n 0.80000 24440.0n 0.80000 24569.9n 0.80000 24570.0n 0.80000 24699.9n 0.80000 24700.0n 0.80000 24829.9n 0.80000 24830.0n 0.80000 24959.9n 0.80000 24960.0n 0.80000 25089.9n 0.80000 25090.0n 0.80000 25219.9n 0.80000 25220.0n 0.80000 25349.9n 0.80000 25350.0n 0.80000 25479.9n 0.80000 25480.0n 0.80000 25609.9n 0.80000 25610.0n 0.80000 25739.9n 0.80000 25740.0n 0.80000 25869.9n 0.80000 25870.0n 0.80000 25999.9n 0.80000 26000.0n 0.80000 26129.9n 0.80000 26130.0n 0.80000 26259.9n 0.80000 26260.0n 0.80000 26389.9n 0.80000 26390.0n 0.80000 26519.9n 0.80000 26520.0n 0.80000 26649.9n 0.80000 26650.0n 0.80000 26779.9n 0.80000 26780.0n 0.80000 26909.9n 0.80000 26910.0n 0.80000 27039.9n 0.80000 27040.0n 0.80000 27169.9n 0.80000 27170.0n 0.80000 27299.9n 0.80000 27300.0n 0.80000 27429.9n 0.80000 27430.0n 0.80000 27559.9n 0.80000 27560.0n 0.80000 27689.9n 0.80000 27690.0n 0.80000 27819.9n 0.80000 27820.0n 0.80000 27949.9n 0.80000 27950.0n 0.80000 28079.9n 0.80000 28080.0n 0.80000 28209.9n 0.80000 28210.0n 0.80000 28339.9n 0.80000 28340.0n 0.80000 28469.9n 0.80000 28470.0n 0.80000 28599.9n 0.80000 28600.0n 0.80000 28729.9n 0.80000 28730.0n 0.80000 28859.9n 0.80000 28860.0n 0.80000 28989.9n 0.80000 28990.0n 0.80000 29119.9n 0.80000 29120.0n 0.80000 29249.9n 0.80000 29250.0n 0.80000 29379.9n 0.80000 29380.0n 0.80000 29509.9n 0.80000 29510.0n 0.80000 29639.9n 0.80000 29640.0n 0.80000 29769.9n 0.80000 29770.0n 0.80000 29899.9n 0.80000 29900.0n 0.80000 30029.9n 0.80000 30030.0n 0.80000 30159.9n 0.80000 30160.0n 0.80000 30289.9n 0.80000 30290.0n 0.80000 30419.9n 0.80000 30420.0n 0.80000 30549.9n 0.80000 30550.0n 0.80000 30679.9n 0.80000 30680.0n 0.80000 30809.9n 0.80000 30810.0n 0.80000 30939.9n 0.80000 30940.0n 0.80000 31069.9n 0.80000 31070.0n 0.80000 31199.9n 0.80000 31200.0n 0.80000 31329.9n 0.80000 31330.0n 0.80000 31459.9n 0.80000 31460.0n 0.80000 31589.9n 0.80000 31590.0n 0.80000 31719.9n 0.80000 31720.0n 0.80000 31849.9n 0.80000 31850.0n 0.80000 31979.9n 0.80000 31980.0n 0.80000 32109.9n 0.80000 32110.0n 0.80000 32239.9n 0.80000 32240.0n 0.80000 32369.9n 0.80000 32370.0n 0.80000 32499.9n 0.80000 32500.0n 0.80000 32629.9n 0.80000 32630.0n 0.80000 32759.9n 0.80000 32760.0n 0.80000 32889.9n 0.80000 32890.0n 0.80000 33019.9n 0.80000 33020.0n 0.80000 33149.9n 0.80000 33150.0n 0.80000 33279.9n 0.80000 33280.0n 0.80000 33409.9n 0.80000 33410.0n 0.80000 33539.9n 0.80000 33540.0n 0.80000 33669.9n 0.80000 33670.0n 0.80000 33799.9n 0.80000 33800.0n 0.80000 33929.9n 0.80000 33930.0n 0.80000 34059.9n 0.80000 34060.0n 0.80000 34189.9n 0.80000 34190.0n 0.80000 34319.9n 0.80000 34320.0n 0.80000 34449.9n 0.80000 34450.0n 0.80000 34579.9n 0.80000 34580.0n 0.80000 34709.9n 0.80000 34710.0n 0.80000 34839.9n 0.80000 34840.0n 0.80000 34969.9n 0.80000 34970.0n 0.80000 35099.9n 0.80000 35100.0n 0.80000 35229.9n 0.80000 35230.0n 0.80000 35359.9n 0.80000 35360.0n 0.80000 35489.9n 0.80000 35490.0n 0.80000 35619.9n 0.80000 35620.0n 0.80000 35749.9n 0.80000 35750.0n 0.80000 35879.9n 0.80000 35880.0n 0.80000 36009.9n 0.80000 36010.0n 0.80000 36139.9n 0.80000 36140.0n 0.80000 36269.9n 0.80000 36270.0n 0.80000 36399.9n 0.80000 36400.0n 0.80000 36529.9n 0.80000 36530.0n 0.80000 36659.9n 0.80000 36660.0n 0.80000 36789.9n 0.80000 36790.0n 0.80000 36919.9n 0.80000 36920.0n 0.80000 37049.9n 0.80000 37050.0n 0.80000 37179.9n 0.80000 37180.0n 0.80000 37309.9n 0.80000 37310.0n 0.80000 37439.9n 0.80000 37440.0n 0.80000 37569.9n 0.80000 37570.0n 0.80000 37699.9n 0.80000 37700.0n 0.80000 37829.9n 0.80000 37830.0n 0.80000 37959.9n 0.80000 37960.0n 0.80000 38089.9n 0.80000 38090.0n 0.80000 38219.9n 0.80000 38220.0n 0.80000 38349.9n 0.80000 38350.0n 0.80000 38479.9n 0.80000 38480.0n 0.80000 38609.9n 0.80000 38610.0n 0.80000 38739.9n 0.80000 38740.0n 0.80000 38869.9n 0.80000 38870.0n 0.80000 38999.9n 0.80000 39000.0n 0.80000 39129.9n 0.80000 39130.0n 0.80000 39259.9n 0.80000 39260.0n 0.80000 39389.9n 0.80000 39390.0n 0.80000 39519.9n 0.80000 39520.0n 0.80000 39649.9n 0.80000 39650.0n 0.80000 39779.9n 0.80000 39780.0n 0.80000 39909.9n 0.80000 39910.0n 0.80000 40039.9n 0.80000 40040.0n 0.80000 40169.9n 0.80000 40170.0n 0.80000 40299.9n 0.80000 40300.0n 0.80000 40429.9n 0.80000 40430.0n 0.80000 40559.9n 0.80000 40560.0n 0.80000 40689.9n 0.80000 40690.0n 0.80000 40819.9n 0.80000 40820.0n 0.80000 40949.9n 0.80000 40950.0n 0.80000 41079.9n 0.80000 41080.0n 0.80000 41209.9n 0.80000 41210.0n 0.80000 41339.9n 0.80000 41340.0n 0.80000 41469.9n 0.80000 41470.0n 0.80000 41599.9n 0.80000 41600.0n 0.80000 41729.9n 0.80000 41730.0n 0.80000 41859.9n 0.80000 41860.0n 0.80000 41989.9n 0.80000 41990.0n 0.80000 42119.9n 0.80000 42120.0n 0.80000 42249.9n 0.80000 42250.0n 0.80000 42379.9n 0.80000 42380.0n 0.80000 42509.9n 0.80000 42510.0n 0.80000 42639.9n 0.80000 42640.0n 0.80000 42769.9n 0.80000 42770.0n 0.80000 42899.9n 0.80000 42900.0n 0.80000 43029.9n 0.80000 43030.0n 0.80000 43159.9n 0.80000 43160.0n 0.80000 43289.9n 0.80000 43290.0n 0.80000 43419.9n 0.80000 43420.0n 0.80000 43549.9n 0.80000 43550.0n 0.80000 43679.9n 0.80000 43680.0n 0.80000 43809.9n 0.80000 43810.0n 0.80000 43939.9n 0.80000 43940.0n 0.80000 44069.9n 0.80000 44070.0n 0.80000 44199.9n 0.80000 44200.0n 0.80000 44329.9n 0.80000 44330.0n 0.80000 44459.9n 0.80000 44460.0n 0.80000 44589.9n 0.80000 44590.0n 0.80000 44719.9n 0.80000 44720.0n 0.80000 44849.9n 0.80000 44850.0n 0.80000 44979.9n 0.80000 44980.0n 0.80000 45109.9n 0.80000 45110.0n 0.80000 45239.9n 0.80000 45240.0n 0.80000 45369.9n 0.80000 45370.0n 0.80000 45499.9n 0.80000 45500.0n 0.80000 45629.9n 0.80000 45630.0n 0.80000 45759.9n 0.80000 45760.0n 0.80000 45889.9n 0.80000 45890.0n 0.80000 46019.9n 0.80000 46020.0n 0.80000 46149.9n 0.80000 46150.0n 0.80000 46279.9n 0.80000 46280.0n 0.80000 46409.9n 0.80000 46410.0n 0.80000 46539.9n 0.80000 46540.0n 0.80000 46669.9n 0.80000 46670.0n 0.80000 46799.9n 0.80000 46800.0n 0.80000 46929.9n 0.80000 46930.0n 0.80000 47059.9n 0.80000 47060.0n 0.80000 47189.9n 0.80000 47190.0n 0.80000 47319.9n 0.80000 47320.0n 0.80000 47449.9n 0.80000 47450.0n 0.80000 47579.9n 0.80000 47580.0n 0.80000 47709.9n 0.80000 47710.0n 0.80000 47839.9n 0.80000 47840.0n 0.80000 47969.9n 0.80000 47970.0n 0.80000 48099.9n 0.80000 48100.0n 0.80000 48229.9n 0.80000 48230.0n 0.80000 48359.9n 0.80000 48360.0n 0.80000 48489.9n 0.80000 48490.0n 0.80000 48619.9n 0.80000 48620.0n 0.80000 48749.9n 0.80000 48750.0n 0.80000 48879.9n 0.80000 48880.0n 0.80000 49009.9n 0.80000 49010.0n 0.80000 49139.9n 0.80000 49140.0n 0.80000 49269.9n 0.80000 49270.0n 0.80000 49399.9n 0.80000 49400.0n 0.80000 49529.9n 0.80000 49530.0n 0.80000 49659.9n 0.80000 49660.0n 0.80000 49789.9n 0.80000 49790.0n 0.80000 49919.9n 0.80000 49920.0n 0.80000 50049.9n 0.80000 50050.0n 0.80000 50179.9n 0.80000 50180.0n 0.80000 50309.9n 0.80000 50310.0n 0.80000 50439.9n 0.80000 50440.0n 0.80000 50569.9n 0.80000 50570.0n 0.80000 50699.9n 0.80000 50700.0n 0.80000 50829.9n 0.80000 50830.0n 0.80000 50959.9n 0.80000 50960.0n 0.80000 51089.9n 0.80000 51090.0n 0.80000 51219.9n 0.80000 51220.0n 0.80000 51349.9n 0.80000 51350.0n 0.80000 51479.9n 0.80000 51480.0n 0.80000 51609.9n 0.80000 51610.0n 0.80000 51739.9n 0.80000 51740.0n 0.80000 51869.9n 0.80000 51870.0n 0.80000 51999.9n 0.80000 52000.0n 0.80000 52129.9n 0.80000 52130.0n 0.80000 52259.9n 0.80000 52260.0n 0.80000 52389.9n 0.80000 52390.0n 0.80000 52519.9n 0.80000 52520.0n 0.80000 52649.9n 0.80000 52650.0n 0.80000 52779.9n 0.80000 52780.0n 0.80000 52909.9n 0.80000 52910.0n 0.80000 53039.9n 0.80000 53040.0n 0.80000 53169.9n 0.80000 53170.0n 0.80000 53299.9n 0.80000 53300.0n 0.80000 53429.9n 0.80000 53430.0n 0.80000 53559.9n 0.80000 53560.0n 0.80000 53689.9n 0.80000 53690.0n 0.80000 53819.9n 0.80000 53820.0n 0.80000 53949.9n 0.80000 53950.0n 0.80000 54079.9n 0.80000 54080.0n 0.80000 54209.9n 0.80000 54210.0n 0.80000 54339.9n 0.80000 54340.0n 0.80000 54469.9n 0.80000 54470.0n 0.80000 54599.9n 0.80000 54600.0n 0.80000 54729.9n 0.80000 54730.0n 0.80000 54859.9n 0.80000 54860.0n 0.80000 54989.9n 0.80000 54990.0n 0.80000 55119.9n 0.80000 55120.0n 0.80000 55249.9n 0.80000 55250.0n 0.80000 55379.9n 0.80000 55380.0n 0.80000 55509.9n 0.80000 55510.0n 0.80000 55639.9n 0.80000 55640.0n 0.80000 55769.9n 0.80000 55770.0n 0.80000 55899.9n 0.80000 55900.0n 0.80000 56029.9n 0.80000 56030.0n 0.80000 56159.9n 0.80000 56160.0n 0.80000 56289.9n 0.80000 56290.0n 0.80000 56419.9n 0.80000 56420.0n 0.80000 56549.9n 0.80000 56550.0n 0.80000 56679.9n 0.80000 56680.0n 0.80000 56809.9n 0.80000 56810.0n 0.80000 56939.9n 0.80000 56940.0n 0.80000 57069.9n 0.80000 57070.0n 0.80000 57199.9n 0.80000 57200.0n 0.80000 57329.9n 0.80000 57330.0n 0.80000 57459.9n 0.80000 57460.0n 0.80000 57589.9n 0.80000 57590.0n 0.80000 57719.9n 0.80000 57720.0n 0.80000 57849.9n 0.80000 57850.0n 0.80000 57979.9n 0.80000 57980.0n 0.80000 58109.9n 0.80000 58110.0n 0.80000 58239.9n 0.80000 58240.0n 0.80000 58369.9n 0.80000 58370.0n 0.80000 58499.9n 0.80000 58500.0n 0.80000 58629.9n 0.80000 58630.0n 0.80000 58759.9n 0.80000 58760.0n 0.80000 58889.9n 0.80000 58890.0n 0.80000 59019.9n 0.80000 59020.0n 0.80000 59149.9n 0.80000 59150.0n 0.80000 59279.9n 0.80000 59280.0n 0.80000 59409.9n 0.80000 59410.0n 0.80000 59539.9n 0.80000 59540.0n 0.80000 59669.9n 0.80000 59670.0n 0.80000 59799.9n 0.80000 59800.0n 0.80000 59929.9n 0.80000 59930.0n 0.80000 60059.9n 0.80000 60060.0n 0.80000 60189.9n 0.80000 60190.0n 0.80000 60319.9n 0.80000 60320.0n 0.80000 60449.9n 0.80000 60450.0n 0.80000 60579.9n 0.80000 60580.0n 0.80000 60709.9n 0.80000 60710.0n 0.80000 60839.9n 0.80000 60840.0n 0.80000 60969.9n 0.80000 60970.0n 0.80000 61099.9n 0.80000 61100.0n 0.80000 61229.9n 0.80000 61230.0n 0.80000 61359.9n 0.80000 61360.0n 0.80000 61489.9n 0.80000 61490.0n 0.80000 61619.9n 0.80000 61620.0n 0.80000 61749.9n 0.80000 61750.0n 0.80000 61879.9n 0.80000 61880.0n 0.80000 62009.9n 0.80000 62010.0n 0.80000 62139.9n 0.80000 62140.0n 0.80000 62269.9n 0.80000 62270.0n 0.80000 62399.9n 0.80000 62400.0n 0.80000 62529.9n 0.80000 62530.0n 0.80000 62659.9n 0.80000 62660.0n 0.80000 62789.9n 0.80000 62790.0n 0.80000 62919.9n 0.80000 62920.0n 0.80000 63049.9n 0.80000 63050.0n 0.80000 63179.9n 0.80000 63180.0n 0.80000 63309.9n 0.80000 63310.0n 0.80000 63439.9n 0.80000 63440.0n 0.80000 63569.9n 0.80000 63570.0n 0.80000 63699.9n 0.80000 63700.0n 0.80000 63829.9n 0.80000 63830.0n 0.80000 63959.9n 0.80000 63960.0n 0.80000 64089.9n 0.80000 64090.0n 0.80000 64219.9n 0.80000 64220.0n 0.80000 64349.9n 0.80000 64350.0n 0.80000 64479.9n 0.80000 64480.0n 0.80000 64609.9n 0.80000 64610.0n 0.80000 64739.9n 0.80000 64740.0n 0.80000 64869.9n 0.80000 64870.0n 0.80000 64999.9n 0.80000 65000.0n 0.80000 65129.9n 0.80000 65130.0n 0.80000 65259.9n 0.80000 65260.0n 0.80000 65389.9n 0.80000 65390.0n 0.80000 65519.9n 0.80000 65520.0n 0.80000 65649.9n 0.80000 65650.0n 0.80000 65779.9n 0.80000 65780.0n 0.80000 65909.9n 0.80000 65910.0n 0.80000 66039.9n 0.80000 66040.0n 0.80000 66169.9n 0.80000 66170.0n 0.80000 66299.9n 0.80000 66300.0n 0.80000 66429.9n 0.80000 66430.0n 0.80000 66559.9n 0.80000 66560.0n 0.80000 66689.9n 0.80000 66690.0n 0.80000 66819.9n 0.80000 66820.0n 0.80000 66949.9n 0.80000 66950.0n 0.80000 67079.9n 0.80000 67080.0n 0.80000 67209.9n 0.80000 67210.0n 0.80000 67339.9n 0.80000 67340.0n 0.80000 67469.9n 0.80000 67470.0n 0.80000 67599.9n 0.80000 67600.0n 0.80000 67729.9n 0.80000 67730.0n 0.80000 67859.9n 0.80000 67860.0n 0.80000 67989.9n 0.80000 67990.0n 0.80000 68119.9n 0.80000 68120.0n 0.80000 68249.9n 0.80000 68250.0n 0.80000 68379.9n 0.80000 68380.0n 0.80000 68509.9n 0.80000 68510.0n 0.80000 68639.9n 0.80000 68640.0n 0.80000 68769.9n 0.80000 68770.0n 0.80000 68899.9n 0.80000 68900.0n 0.80000 69029.9n 0.80000 69030.0n 0.80000 69159.9n 0.80000 69160.0n 0.80000 69289.9n 0.80000 69290.0n 0.80000 69419.9n 0.80000 69420.0n 0.80000 69549.9n 0.80000 69550.0n 0.80000 69679.9n 0.80000 69680.0n 0.80000 69809.9n 0.80000 69810.0n 0.80000 69939.9n 0.80000 69940.0n 0.80000 70069.9n 0.80000 70070.0n 0.80000 70199.9n 0.80000 70200.0n 0.80000 70329.9n 0.80000 70330.0n 0.80000 70459.9n 0.80000 70460.0n 0.80000 70589.9n 0.80000 70590.0n 0.80000 70719.9n 0.80000 70720.0n 0.80000 70849.9n 0.80000 70850.0n 0.80000 70979.9n 0.80000 70980.0n 0.80000 71109.9n 0.80000 71110.0n 0.80000 71239.9n 0.80000 71240.0n 0.80000 71369.9n 0.80000 71370.0n 0.80000 71499.9n 0.80000 71500.0n 0.80000 71629.9n 0.80000 71630.0n 0.80000 71759.9n 0.80000 71760.0n 0.80000 71889.9n 0.80000 71890.0n 0.80000 72019.9n 0.80000 72020.0n 0.80000 72149.9n 0.80000 72150.0n 0.80000 72279.9n 0.80000 72280.0n 0.80000 72409.9n 0.80000 72410.0n 0.80000 72539.9n 0.80000 72540.0n 0.80000 72669.9n 0.80000 72670.0n 0.80000 72799.9n 0.80000 72800.0n 0.80000 72929.9n 0.80000 72930.0n 0.80000 73059.9n 0.80000 73060.0n 0.80000 73189.9n 0.80000 73190.0n 0.80000 73319.9n 0.80000 73320.0n 0.80000 73449.9n 0.80000 73450.0n 0.80000 73579.9n 0.80000 73580.0n 0.80000 73709.9n 0.80000 73710.0n 0.80000 73839.9n 0.80000 73840.0n 0.80000 73969.9n 0.80000 73970.0n 0.80000 74099.9n 0.80000 74100.0n 0.80000 74229.9n 0.80000 74230.0n 0.80000 74359.9n 0.80000 74360.0n 0.80000 74489.9n 0.80000 74490.0n 0.80000 74619.9n 0.80000 74620.0n 0.80000 74749.9n 0.80000 74750.0n 0.80000 74879.9n 0.80000 74880.0n 0.80000 75009.9n 0.80000 75010.0n 0.80000 75139.9n 0.80000 75140.0n 0.80000 75269.9n 0.80000 75270.0n 0.80000 75399.9n 0.80000 75400.0n 0.80000 75529.9n 0.80000 75530.0n 0.80000 75659.9n 0.80000 75660.0n 0.80000 75789.9n 0.80000 75790.0n 0.80000 75919.9n 0.80000 75920.0n 0.80000 76049.9n 0.80000 76050.0n 0.80000 76179.9n 0.80000 76180.0n 0.80000 76309.9n 0.80000 76310.0n 0.80000 76439.9n 0.80000 76440.0n 0.80000 76569.9n 0.80000 76570.0n 0.80000 76699.9n 0.80000 76700.0n 0.80000 76829.9n 0.80000 76830.0n 0.80000 76959.9n 0.80000 76960.0n 0.80000 77089.9n 0.80000 77090.0n 0.80000 77219.9n 0.80000 77220.0n 0.80000 77349.9n 0.80000 77350.0n 0.80000 77479.9n 0.80000 77480.0n 0.80000 77609.9n 0.80000 77610.0n 0.80000 77739.9n 0.80000 77740.0n 0.80000 77869.9n 0.80000 77870.0n 0.80000 77999.9n 0.80000 78000.0n 0.80000 78129.9n 0.80000 78130.0n 0.80000 78259.9n 0.80000 78260.0n 0.80000 78389.9n 0.80000 78390.0n 0.80000 78519.9n 0.80000 78520.0n 0.80000 78649.9n 0.80000 78650.0n 0.80000 78779.9n 0.80000 78780.0n 0.80000 78909.9n 0.80000 78910.0n 0.80000 79039.9n 0.80000 79040.0n 0.80000 79169.9n 0.80000 79170.0n 0.80000 79299.9n 0.80000 79300.0n 0.80000 79429.9n 0.80000 79430.0n 0.80000 79559.9n 0.80000 79560.0n 0.80000 79689.9n 0.80000 79690.0n 0.80000 79819.9n 0.80000 79820.0n 0.80000 79949.9n 0.80000 79950.0n 0.80000 80079.9n 0.80000 80080.0n 0.80000 80209.9n 0.80000 80210.0n 0.80000 80339.9n 0.80000 80340.0n 0.80000 80469.9n 0.80000 80470.0n 0.80000 80599.9n 0.80000 80600.0n 0.80000 80729.9n 0.80000 80730.0n 0.80000 80859.9n 0.80000 80860.0n 0.80000 80989.9n 0.80000 80990.0n 0.80000 81119.9n 0.80000 81120.0n 0.80000 81249.9n 0.80000 81250.0n 0.80000 81379.9n 0.80000 81380.0n 0.80000 81509.9n 0.80000 81510.0n 0.80000 81639.9n 0.80000 81640.0n 0.80000 81769.9n 0.80000 81770.0n 0.80000 81899.9n 0.80000 81900.0n 0.80000 82029.9n 0.80000 82030.0n 0.80000 82159.9n 0.80000 82160.0n 0.80000 82289.9n 0.80000 82290.0n 0.80000 82419.9n 0.80000 82420.0n 0.80000 82549.9n 0.80000 82550.0n 0.80000 82679.9n 0.80000 82680.0n 0.80000 82809.9n 0.80000 82810.0n 0.80000 82939.9n 0.80000 82940.0n 0.80000 83069.9n 0.80000 83070.0n 0.80000 83199.9n 0.80000 83200.0n 0.80000 83329.9n 0.80000 83330.0n 0.80000 83459.9n 0.80000 83460.0n 0.80000 83589.9n 0.80000 83590.0n 0.80000 83719.9n 0.80000 83720.0n 0.80000 83849.9n 0.80000 83850.0n 0.80000 83979.9n 0.80000 83980.0n 0.80000 84109.9n 0.80000 84110.0n 0.80000 84239.9n 0.80000 84240.0n 0.80000 84369.9n 0.80000 84370.0n 0.80000 84499.9n 0.80000 84500.0n 0.80000 84629.9n 0.80000 84630.0n 0.80000 84759.9n 0.80000 84760.0n 0.80000 84889.9n 0.80000 84890.0n 0.80000 85019.9n 0.80000 85020.0n 0.80000 85149.9n 0.80000 85150.0n 0.80000 85279.9n 0.80000 85280.0n 0.80000 85409.9n 0.80000 85410.0n 0.80000 85539.9n 0.80000 85540.0n 0.80000 85669.9n 0.80000 85670.0n 0.80000 85799.9n 0.80000 85800.0n 0.80000 85929.9n 0.80000 85930.0n 0.80000 86059.9n 0.80000 86060.0n 0.80000 86189.9n 0.80000 86190.0n 0.80000 86319.9n 0.80000 86320.0n 0.80000 86449.9n 0.80000 86450.0n 0.80000 86579.9n 0.80000 86580.0n 0.80000 86709.9n 0.80000 86710.0n 0.80000 86839.9n 0.80000 86840.0n 0.80000 86969.9n 0.80000 86970.0n 0.80000 87099.9n 0.80000 87100.0n 0.80000 87229.9n 0.80000 87230.0n 0.80000 87359.9n 0.80000 87360.0n 0.80000 87489.9n 0.80000 87490.0n 0.80000 87619.9n 0.80000 87620.0n 0.80000 87749.9n 0.80000 87750.0n 0.80000 87879.9n 0.80000 87880.0n 0.80000 88009.9n 0.80000 88010.0n 0.80000 88139.9n 0.80000 88140.0n 0.80000 88269.9n 0.80000 88270.0n 0.80000 88399.9n 0.80000 88400.0n 0.80000 88529.9n 0.80000 88530.0n 0.80000 88659.9n 0.80000 88660.0n 0.80000 88789.9n 0.80000 88790.0n 0.80000 88919.9n 0.80000 88920.0n 0.80000 89049.9n 0.80000 89050.0n 0.80000 89179.9n 0.80000 89180.0n 0.80000 89309.9n 0.80000 89310.0n 0.80000 89439.9n 0.80000 89440.0n 0.80000 89569.9n 0.80000 89570.0n 0.80000 89699.9n 0.80000 89700.0n 0.80000 89829.9n 0.80000 89830.0n 0.80000 89959.9n 0.80000 89960.0n 0.80000 90089.9n 0.80000 90090.0n 0.80000 90219.9n 0.80000 90220.0n 0.80000 90349.9n 0.80000 90350.0n 0.80000 90479.9n 0.80000 90480.0n 0.80000 90609.9n 0.80000 90610.0n 0.80000 90739.9n 0.80000 90740.0n 0.80000 90869.9n 0.80000 90870.0n 0.80000 90999.9n 0.80000 91000.0n 0.80000 91129.9n 0.80000 91130.0n 0.80000 91259.9n 0.80000 91260.0n 0.80000 91389.9n 0.80000 91390.0n 0.80000 91519.9n 0.80000 91520.0n 0.80000 91649.9n 0.80000 91650.0n 0.80000 91779.9n 0.80000 91780.0n 0.80000 91909.9n 0.80000 91910.0n 0.80000 92039.9n 0.80000 92040.0n 0.80000 92169.9n 0.80000 92170.0n 0.80000 92299.9n 0.80000 92300.0n 0.80000 92429.9n 0.80000 92430.0n 0.80000 92559.9n 0.80000 92560.0n 0.80000 92689.9n 0.80000 92690.0n 0.80000 92819.9n 0.80000 92820.0n 0.80000 92949.9n 0.80000 92950.0n 0.80000 93079.9n 0.80000 93080.0n 0.80000 93209.9n 0.80000 93210.0n 0.80000 93339.9n 0.80000 93340.0n 0.80000 93469.9n 0.80000 93470.0n 0.80000 93599.9n 0.80000 93600.0n 0.80000 93729.9n 0.80000 93730.0n 0.80000 93859.9n 0.80000 93860.0n 0.80000 93989.9n 0.80000 93990.0n 0.80000 94119.9n 0.80000 94120.0n 0.80000 94249.9n 0.80000 94250.0n 0.80000 94379.9n 0.80000 94380.0n 0.80000 94509.9n 0.80000 94510.0n 0.80000 94639.9n 0.80000 94640.0n 0.80000 94769.9n 0.80000 94770.0n 0.80000 94899.9n 0.80000 94900.0n 0.80000 95029.9n 0.80000 95030.0n 0.80000 95159.9n 0.80000 95160.0n 0.80000 95289.9n 0.80000 95290.0n 0.80000 95419.9n 0.80000 95420.0n 0.80000 95549.9n 0.80000 95550.0n 0.80000 95679.9n 0.80000 95680.0n 0.80000 95809.9n 0.80000 95810.0n 0.80000 95939.9n 0.80000 95940.0n 0.80000 96069.9n 0.80000 96070.0n 0.80000 96199.9n 0.80000 96200.0n 0.80000 96329.9n 0.80000 96330.0n 0.80000 96459.9n 0.80000 96460.0n 0.80000 96589.9n 0.80000 96590.0n 0.80000 96719.9n 0.80000 96720.0n 0.80000 96849.9n 0.80000 96850.0n 0.80000 96979.9n 0.80000 96980.0n 0.80000 97109.9n 0.80000 97110.0n 0.80000 97239.9n 0.80000 97240.0n 0.80000 97369.9n 0.80000 97370.0n 0.80000 97499.9n 0.80000 97500.0n 0.80000 97629.9n 0.80000 97630.0n 0.80000 97759.9n 0.80000 97760.0n 0.80000 97889.9n 0.80000 97890.0n 0.80000 98019.9n 0.80000 98020.0n 0.80000 98149.9n 0.80000 98150.0n 0.80000 98279.9n 0.80000 98280.0n 0.80000 98409.9n 0.80000 98410.0n 0.80000 98539.9n 0.80000 98540.0n 0.80000 98669.9n 0.80000 98670.0n 0.80000 98799.9n 0.80000 98800.0n 0.80000 98929.9n 0.80000 98930.0n 0.80000 99059.9n 0.80000 99060.0n 0.80000 99189.9n 0.80000 99190.0n 0.80000 99319.9n 0.80000 99320.0n 0.80000 99449.9n 0.80000 99450.0n 0.80000 99579.9n 0.80000 99580.0n 0.80000 99709.9n 0.80000 99710.0n 0.80000 99839.9n 0.80000 99840.0n 0.80000 99969.9n 0.80000 99970.0n 0.80000 100099.9n 0.80000 100100.0n 0.80000 100229.9n 0.80000 100230.0n 0.80000 100359.9n 0.80000 100360.0n 0.80000 100489.9n 0.80000 100490.0n 0.80000 100619.9n 0.80000 100620.0n 0.80000 100749.9n 0.80000 100750.0n 0.80000 100879.9n 0.80000 100880.0n 0.80000 101009.9n 0.80000 101010.0n 0.80000 101139.9n 0.80000 101140.0n 0.80000 101269.9n 0.80000 101270.0n 0.80000 101399.9n 0.80000 101400.0n 0.80000 101529.9n 0.80000 101530.0n 0.80000 101659.9n 0.80000 101660.0n 0.80000 101789.9n 0.80000 101790.0n 0.80000 101919.9n 0.80000 101920.0n 0.80000 102049.9n 0.80000 102050.0n 0.80000 102179.9n 0.80000 102180.0n 0.80000 102309.9n 0.80000 102310.0n 0.80000 102439.9n 0.80000 102440.0n 0.80000 102569.9n 0.80000 102570.0n 0.80000 102699.9n 0.80000 102700.0n 0.80000 102829.9n 0.80000 102830.0n 0.80000 102959.9n 0.80000 102960.0n 0.80000 103089.9n 0.80000 103090.0n 0.80000 103219.9n 0.80000 103220.0n 0.80000 103349.9n 0.80000 103350.0n 0.80000 103479.9n 0.80000 103480.0n 0.80000 103609.9n 0.80000 103610.0n 0.80000 103739.9n 0.80000 103740.0n 0.80000 103869.9n 0.80000 103870.0n 0.80000 103999.9n 0.80000 104000.0n 0.80000 104129.9n 0.80000 104130.0n 0.80000 104259.9n 0.80000 104260.0n 0.80000 104389.9n 0.80000 104390.0n 0.80000 104519.9n 0.80000 104520.0n 0.80000 104649.9n 0.80000 104650.0n 0.80000 104779.9n 0.80000 104780.0n 0.80000 104909.9n 0.80000 104910.0n 0.80000 105039.9n 0.80000 105040.0n 0.80000 105169.9n 0.80000 105170.0n 0.80000 105299.9n 0.80000 105300.0n 0.80000 105429.9n 0.80000 105430.0n 0.80000 105559.9n 0.80000 105560.0n 0.80000 105689.9n 0.80000 105690.0n 0.80000 105819.9n 0.80000 105820.0n 0.80000 105949.9n 0.80000 105950.0n 0.80000 106079.9n 0.80000 106080.0n 0.80000 106209.9n 0.80000 106210.0n 0.80000 106339.9n 0.80000 106340.0n 0.80000 106469.9n 0.80000 106470.0n 0.80000 106599.9n 0.80000 106600.0n 0.80000 106729.9n 0.80000 106730.0n 0.80000 106859.9n 0.80000 106860.0n 0.80000 106989.9n 0.80000 106990.0n 0.80000 107119.9n 0.80000 107120.0n 0.80000 107249.9n 0.80000 107250.0n 0.80000 107379.9n 0.80000 107380.0n 0.80000 107509.9n 0.80000 107510.0n 0.80000 107639.9n 0.80000 107640.0n 0.80000 107769.9n 0.80000 107770.0n 0.80000 107899.9n 0.80000 107900.0n 0.80000 108029.9n 0.80000 108030.0n 0.80000 108159.9n 0.80000 108160.0n 0.80000 108289.9n 0.80000 108290.0n 0.80000 108419.9n 0.80000 108420.0n 0.80000 108549.9n 0.80000 108550.0n 0.80000 108679.9n 0.80000 108680.0n 0.80000 108809.9n 0.80000 108810.0n 0.80000 108939.9n 0.80000 108940.0n 0.80000 109069.9n 0.80000 109070.0n 0.80000 109199.9n 0.80000 109200.0n 0.80000 109329.9n 0.80000 109330.0n 0.80000 109459.9n 0.80000 109460.0n 0.80000 109589.9n 0.80000 109590.0n 0.80000 109719.9n 0.80000 109720.0n 0.80000 109849.9n 0.80000 109850.0n 0.80000 109979.9n 0.80000 109980.0n 0.80000 110109.9n 0.80000 110110.0n 0.80000 110239.9n 0.80000 110240.0n 0.80000 110369.9n 0.80000 110370.0n 0.80000 110499.9n 0.80000 110500.0n 0.80000 110629.9n 0.80000 110630.0n 0.80000 110759.9n 0.80000 110760.0n 0.80000 110889.9n 0.80000 110890.0n 0.80000 111019.9n 0.80000 111020.0n 0.80000 111149.9n 0.80000 111150.0n 0.80000 111279.9n 0.80000 111280.0n 0.80000 111409.9n 0.80000 111410.0n 0.80000 111539.9n 0.80000 111540.0n 0.80000 111669.9n 0.80000 111670.0n 0.80000 111799.9n 0.80000 111800.0n 0.80000 111929.9n 0.80000 111930.0n 0.80000 112059.9n 0.80000 112060.0n 0.80000 112189.9n 0.80000 112190.0n 0.80000 112319.9n 0.80000 112320.0n 0.80000 112449.9n 0.80000 112450.0n 0.80000 112579.9n 0.80000 112580.0n 0.80000 112709.9n 0.80000 112710.0n 0.80000 112839.9n 0.80000 112840.0n 0.80000 112969.9n 0.80000 112970.0n 0.80000 113099.9n 0.80000 113100.0n 0.80000 113229.9n 0.80000 113230.0n 0.80000 113359.9n 0.80000 113360.0n 0.80000 113489.9n 0.80000 113490.0n 0.80000 113619.9n 0.80000 113620.0n 0.80000 113749.9n 0.80000 113750.0n 0.80000 113879.9n 0.80000 113880.0n 0.80000 114009.9n 0.80000 114010.0n 0.80000 114139.9n 0.80000 114140.0n 0.80000 114269.9n 0.80000 114270.0n 0.80000 114399.9n 0.80000 114400.0n 0.80000 114529.9n 0.80000 114530.0n 0.80000 114659.9n 0.80000 114660.0n 0.80000 114789.9n 0.80000 114790.0n 0.80000 114919.9n 0.80000 114920.0n 0.80000 115049.9n 0.80000 115050.0n 0.80000 115179.9n 0.80000 115180.0n 0.80000 115309.9n 0.80000 115310.0n 0.80000 115439.9n 0.80000 115440.0n 0.80000 115569.9n 0.80000 115570.0n 0.80000 115699.9n 0.80000 115700.0n 0.80000 115829.9n 0.80000 115830.0n 0.80000 115959.9n 0.80000 115960.0n 0.80000 116089.9n 0.80000 116090.0n 0.80000 116219.9n 0.80000 116220.0n 0.80000 116349.9n 0.80000 116350.0n 0.80000 116479.9n 0.80000 116480.0n 0.80000 116609.9n 0.80000 116610.0n 0.80000 116739.9n 0.80000 116740.0n 0.80000 116869.9n 0.80000 116870.0n 0.80000 116999.9n 0.80000 117000.0n 0.80000 117129.9n 0.80000 117130.0n 0.80000 117259.9n 0.80000 117260.0n 0.80000 117389.9n 0.80000 117390.0n 0.80000 117519.9n 0.80000 117520.0n 0.80000 117649.9n 0.80000 117650.0n 0.80000 117779.9n 0.80000 117780.0n 0.80000 117909.9n 0.80000 117910.0n 0.80000 118039.9n 0.80000 118040.0n 0.80000 118169.9n 0.80000 118170.0n 0.80000 118299.9n 0.80000 118300.0n 0.80000 118429.9n 0.80000 118430.0n 0.80000 118559.9n 0.80000 118560.0n 0.80000 118689.9n 0.80000 118690.0n 0.80000 118819.9n 0.80000 118820.0n 0.80000 118949.9n 0.80000 118950.0n 0.80000 119079.9n 0.80000 119080.0n 0.80000 119209.9n 0.80000 119210.0n 0.80000 119339.9n 0.80000 119340.0n 0.80000 119469.9n 0.80000 119470.0n 0.80000 119599.9n 0.80000 119600.0n 0.80000 119729.9n 0.80000 119730.0n 0.80000 119859.9n 0.80000 119860.0n 0.80000 119989.9n 0.80000 119990.0n 0.80000 120119.9n 0.80000 120120.0n 0.80000 120249.9n 0.80000 120250.0n 0.80000 120379.9n 0.80000 120380.0n 0.80000 120509.9n 0.80000 120510.0n 0.80000 120639.9n 0.80000 120640.0n 0.80000 120769.9n 0.80000 120770.0n 0.80000 120899.9n 0.80000 120900.0n 0.80000 121029.9n 0.80000 121030.0n 0.80000 121159.9n 0.80000 121160.0n 0.80000 121289.9n 0.80000 121290.0n 0.80000 121419.9n 0.80000 121420.0n 0.80000 121549.9n 0.80000 121550.0n 0.80000 121679.9n 0.80000 121680.0n 0.80000 121809.9n 0.80000 121810.0n 0.80000 121939.9n 0.80000 121940.0n 0.80000 122069.9n 0.80000 122070.0n 0.80000 122199.9n 0.80000 122200.0n 0.80000 122329.9n 0.80000 122330.0n 0.80000 122459.9n 0.80000 122460.0n 0.80000 122589.9n 0.80000 122590.0n 0.80000 122719.9n 0.80000 122720.0n 0.80000 122849.9n 0.80000 122850.0n 0.80000 122979.9n 0.80000 122980.0n 0.80000 123109.9n 0.80000 123110.0n 0.80000 123239.9n 0.80000 123240.0n 0.80000 123369.9n 0.80000 123370.0n 0.80000 123499.9n 0.80000 123500.0n 0.80000 123629.9n 0.80000 123630.0n 0.80000 123759.9n 0.80000 123760.0n 0.80000 123889.9n 0.80000 123890.0n 0.80000 124019.9n 0.80000 124020.0n 0.80000 124149.9n 0.80000 124150.0n 0.80000 124279.9n 0.80000 124280.0n 0.80000 124409.9n 0.80000 124410.0n 0.80000 124539.9n 0.80000 124540.0n 0.80000 124669.9n 0.80000 124670.0n 0.80000 124799.9n 0.80000 124800.0n 0.80000 124929.9n 0.80000 124930.0n 0.80000 125059.9n 0.80000 125060.0n 0.80000 125189.9n 0.80000 125190.0n 0.80000 125319.9n 0.80000 125320.0n 0.80000 125449.9n 0.80000 125450.0n 0.80000 125579.9n 0.80000 125580.0n 0.80000 125709.9n 0.80000 125710.0n 0.80000 125839.9n 0.80000 125840.0n 0.80000 125969.9n 0.80000 125970.0n 0.80000 126099.9n 0.80000 126100.0n 0.80000 126229.9n 0.80000 126230.0n 0.80000 126359.9n 0.80000 126360.0n 0.80000 126489.9n 0.80000 126490.0n 0.80000 126619.9n 0.80000 126620.0n 0.80000 126749.9n 0.80000 126750.0n 0.80000 126879.9n 0.80000 126880.0n 0.80000 127009.9n 0.80000 127010.0n 0.80000 127139.9n 0.80000 127140.0n 0.80000 127269.9n 0.80000 127270.0n 0.80000 127399.9n 0.80000 127400.0n 0.80000 127529.9n 0.80000 127530.0n 0.80000 127659.9n 0.80000 127660.0n 0.80000 127789.9n 0.80000 127790.0n 0.80000 127919.9n 0.80000 127920.0n 0.80000 128049.9n 0.80000 128050.0n 0.80000 128179.9n 0.80000 128180.0n 0.80000 128309.9n 0.80000 128310.0n 0.80000 128439.9n 0.80000 128440.0n 0.80000 128569.9n 0.80000 128570.0n 0.80000 128699.9n 0.80000 128700.0n 0.80000 128829.9n 0.80000 128830.0n 0.80000 128959.9n 0.80000 128960.0n 0.80000 129089.9n 0.80000 129090.0n 0.80000 129219.9n 0.80000 129220.0n 0.80000 129349.9n 0.80000 129350.0n 0.80000 129479.9n 0.80000 129480.0n 0.80000 129609.9n 0.80000 129610.0n 0.80000 129739.9n 0.80000 129740.0n 0.80000 129869.9n 0.80000 129870.0n 0.80000 129999.9n 0.80000 130000.0n 0.80000 130129.9n 0.80000 130130.0n 0.80000 130259.9n 0.80000 130260.0n 0.80000 130389.9n 0.80000 130390.0n 0.80000 130519.9n 0.80000 130520.0n 0.80000 130649.9n 0.80000 130650.0n 0.80000 130779.9n 0.80000 130780.0n 0.80000 130909.9n 0.80000 130910.0n 0.80000 131039.9n 0.80000 131040.0n 0.80000 131169.9n 0.80000 131170.0n 0.80000 131299.9n 0.80000 131300.0n 0.80000 131429.9n 0.80000 131430.0n 0.80000 131559.9n 0.80000 131560.0n 0.80000 131689.9n 0.80000 131690.0n 0.80000 131819.9n 0.80000 131820.0n 0.80000 131949.9n 0.80000 131950.0n 0.80000 132079.9n 0.80000 132080.0n 0.80000 132209.9n 0.80000 132210.0n 0.80000 132339.9n 0.80000 132340.0n 0.80000 132469.9n 0.80000 132470.0n 0.80000 132599.9n 0.80000 132600.0n 0.80000 132729.9n 0.80000 132730.0n 0.80000 132859.9n 0.80000 132860.0n 0.80000 132989.9n 0.80000 132990.0n 0.80000 133119.9n 0.80000 133120.0n 0.80000 133249.9n 0.80000 133250.0n 0.80000 133379.9n 0.80000 133380.0n 0.80000 133509.9n 0.80000 133510.0n 0.80000 133639.9n 0.80000 133640.0n 0.80000 133769.9n 0.80000 133770.0n 0.80000 133899.9n 0.80000 133900.0n 0.80000 134029.9n 0.80000 134030.0n 0.80000 134159.9n 0.80000 134160.0n 0.80000 134289.9n 0.80000 134290.0n 0.80000 134419.9n 0.80000 134420.0n 0.80000 134549.9n 0.80000 134550.0n 0.80000 134679.9n 0.80000 134680.0n 0.80000 134809.9n 0.80000 134810.0n 0.80000 134939.9n 0.80000 134940.0n 0.80000 135069.9n 0.80000 135070.0n 0.80000 135199.9n 0.80000 135200.0n 0.80000 135329.9n 0.80000 135330.0n 0.80000 135459.9n 0.80000 135460.0n 0.80000 135589.9n 0.80000 135590.0n 0.80000 135719.9n 0.80000 135720.0n 0.80000 135849.9n 0.80000 135850.0n 0.80000 135979.9n 0.80000 135980.0n 0.80000 136109.9n 0.80000 136110.0n 0.80000 136239.9n 0.80000 136240.0n 0.80000 136369.9n 0.80000 136370.0n 0.80000 136499.9n 0.80000 136500.0n 0.80000 136629.9n 0.80000 136630.0n 0.80000 136759.9n 0.80000 136760.0n 0.80000 136889.9n 0.80000 136890.0n 0.80000 137019.9n 0.80000 137020.0n 0.80000 137149.9n 0.80000 137150.0n 0.80000 137279.9n 0.80000 137280.0n 0.80000 137409.9n 0.80000 137410.0n 0.80000 137539.9n 0.80000 137540.0n 0.80000 137669.9n 0.80000 137670.0n 0.80000 137799.9n 0.80000 137800.0n 0.80000 137929.9n 0.80000 137930.0n 0.80000 138059.9n 0.80000 138060.0n 0.80000 138189.9n 0.80000 138190.0n 0.80000 138319.9n 0.80000 138320.0n 0.80000 138449.9n 0.80000 138450.0n 0.80000 138579.9n 0.80000 138580.0n 0.80000 138709.9n 0.80000 138710.0n 0.80000 138839.9n 0.80000 138840.0n 0.80000 138969.9n 0.80000 138970.0n 0.80000 139099.9n 0.80000 139100.0n 0.80000 139229.9n 0.80000 139230.0n 0.80000 139359.9n 0.80000 139360.0n 0.80000 139489.9n 0.80000 139490.0n 0.80000 139619.9n 0.80000 139620.0n 0.80000 139749.9n 0.80000 139750.0n 0.80000 139879.9n 0.80000 139880.0n 0.80000 140009.9n 0.80000 140010.0n 0.80000 140139.9n 0.80000 140140.0n 0.80000 140269.9n 0.80000 140270.0n 0.80000 140399.9n 0.80000 140400.0n 0.80000 140529.9n 0.80000 140530.0n 0.80000 140659.9n 0.80000 140660.0n 0.80000 140789.9n 0.80000 140790.0n 0.80000 140919.9n 0.80000 140920.0n 0.80000 141049.9n 0.80000 141050.0n 0.80000 141179.9n 0.80000 141180.0n 0.80000 141309.9n 0.80000 141310.0n 0.80000 141439.9n 0.80000 141440.0n 0.80000 141569.9n 0.80000 141570.0n 0.80000 141699.9n 0.80000 141700.0n 0.80000 141829.9n 0.80000 141830.0n 0.80000 141959.9n 0.80000 141960.0n 0.80000 142089.9n 0.80000 142090.0n 0.80000 142219.9n 0.80000 142220.0n 0.80000 142349.9n 0.80000 142350.0n 0.80000 142479.9n 0.80000 142480.0n 0.80000 142609.9n 0.80000 142610.0n 0.80000 142739.9n 0.80000 142740.0n 0.80000 142869.9n 0.80000 142870.0n 0.80000 142999.9n 0.80000 143000.0n 0.80000 143129.9n 0.80000 143130.0n 0.80000 143259.9n 0.80000 143260.0n 0.80000 143389.9n 0.80000 143390.0n 0.80000 143519.9n 0.80000 143520.0n 0.80000 143649.9n 0.80000 143650.0n 0.80000 143779.9n 0.80000 143780.0n 0.80000 143909.9n 0.80000 143910.0n 0.80000 144039.9n 0.80000 144040.0n 0.80000 144169.9n 0.80000 144170.0n 0.80000 144299.9n 0.80000 144300.0n 0.80000 144429.9n 0.80000 144430.0n 0.80000 144559.9n 0.80000 144560.0n 0.80000 144689.9n 0.80000 144690.0n 0.80000 144819.9n 0.80000 144820.0n 0.80000 144949.9n 0.80000 144950.0n 0.80000 145079.9n 0.80000 145080.0n 0.80000 145209.9n 0.80000 145210.0n 0.80000 145339.9n 0.80000 145340.0n 0.80000 145469.9n 0.80000 145470.0n 0.80000 145599.9n 0.80000 145600.0n 0.80000 145729.9n 0.80000 145730.0n 0.80000 145859.9n 0.80000 145860.0n 0.80000 145989.9n 0.80000 145990.0n 0.80000 146119.9n 0.80000 146120.0n 0.80000 146249.9n 0.80000 146250.0n 0.80000 146379.9n 0.80000 146380.0n 0.80000 146509.9n 0.80000 146510.0n 0.80000 146639.9n 0.80000 146640.0n 0.80000 146769.9n 0.80000 146770.0n 0.80000 146899.9n 0.80000 146900.0n 0.80000 147029.9n 0.80000 147030.0n 0.80000 147159.9n 0.80000 147160.0n 0.80000 147289.9n 0.80000 147290.0n 0.80000 147419.9n 0.80000 147420.0n 0.80000 147549.9n 0.80000 147550.0n 0.80000 147679.9n 0.80000 147680.0n 0.80000 147809.9n 0.80000 147810.0n 0.80000 147939.9n 0.80000 147940.0n 0.80000 148069.9n 0.80000 148070.0n 0.80000 148199.9n 0.80000 148200.0n 0.80000 148329.9n 0.80000 148330.0n 0.80000 148459.9n 0.80000 148460.0n 0.80000 148589.9n 0.80000 148590.0n 0.80000 148719.9n 0.80000 148720.0n 0.80000 148849.9n 0.80000 148850.0n 0.80000 148979.9n 0.80000 148980.0n 0.80000 149109.9n 0.80000 149110.0n 0.80000 149239.9n 0.80000 149240.0n 0.80000 149369.9n 0.80000 149370.0n 0.80000 149499.9n 0.80000 149500.0n 0.80000 149629.9n 0.80000 149630.0n 0.80000 149759.9n 0.80000 149760.0n 0.80000 149889.9n 0.80000 149890.0n 0.80000 150019.9n 0.80000 150020.0n 0.80000 150149.9n 0.80000 150150.0n 0.80000 150279.9n 0.80000 150280.0n 0.80000 150409.9n 0.80000 150410.0n 0.80000 150539.9n 0.80000 150540.0n 0.80000 150669.9n 0.80000 150670.0n 0.80000 150799.9n 0.80000 150800.0n 0.80000 150929.9n 0.80000 150930.0n 0.80000 151059.9n 0.80000 151060.0n 0.80000 151189.9n 0.80000 151190.0n 0.80000 151319.9n 0.80000 151320.0n 0.80000 151449.9n 0.80000 151450.0n 0.80000 151579.9n 0.80000 151580.0n 0.80000 151709.9n 0.80000 151710.0n 0.80000 151839.9n 0.80000 151840.0n 0.80000 151969.9n 0.80000 151970.0n 0.80000 152099.9n 0.80000 152100.0n 0.80000 152229.9n 0.80000 152230.0n 0.80000 152359.9n 0.80000 152360.0n 0.80000 152489.9n 0.80000 152490.0n 0.80000 152619.9n 0.80000 152620.0n 0.80000 152749.9n 0.80000 152750.0n 0.80000 152879.9n 0.80000 152880.0n 0.80000 153009.9n 0.80000 153010.0n 0.80000 153139.9n 0.80000 153140.0n 0.80000 153269.9n 0.80000 153270.0n 0.80000 153399.9n 0.80000 153400.0n 0.80000 153529.9n 0.80000 153530.0n 0.80000 153659.9n 0.80000 153660.0n 0.80000 153789.9n 0.80000 153790.0n 0.80000 153919.9n 0.80000 153920.0n 0.80000 154049.9n 0.80000 154050.0n 0.80000 154179.9n 0.80000 154180.0n 0.80000 154309.9n 0.80000 154310.0n 0.80000 154439.9n 0.80000 154440.0n 0.80000 154569.9n 0.80000 154570.0n 0.80000 154699.9n 0.80000 154700.0n 0.80000 154829.9n 0.80000 154830.0n 0.80000 154959.9n 0.80000 154960.0n 0.80000 155089.9n 0.80000 155090.0n 0.80000 155219.9n 0.80000 155220.0n 0.80000 155349.9n 0.80000 155350.0n 0.80000 155479.9n 0.80000 155480.0n 0.80000 155609.9n 0.80000 155610.0n 0.80000 155739.9n 0.80000 155740.0n 0.80000 155869.9n 0.80000 155870.0n 0.80000 155999.9n 0.80000 156000.0n 0.80000 156129.9n 0.80000 156130.0n 0.80000 156259.9n 0.80000 156260.0n 0.80000 156389.9n 0.80000 156390.0n 0.80000 156519.9n 0.80000 156520.0n 0.80000 156649.9n 0.80000 156650.0n 0.80000 156779.9n 0.80000 156780.0n 0.80000 156909.9n 0.80000 156910.0n 0.80000 157039.9n 0.80000 157040.0n 0.80000 157169.9n 0.80000 157170.0n 0.80000 157299.9n 0.80000 157300.0n 0.80000 157429.9n 0.80000 157430.0n 0.80000 157559.9n 0.80000 157560.0n 0.80000 157689.9n 0.80000 157690.0n 0.80000 157819.9n 0.80000 157820.0n 0.80000 157949.9n 0.80000 157950.0n 0.80000 158079.9n 0.80000 158080.0n 0.80000 158209.9n 0.80000 158210.0n 0.80000 158339.9n 0.80000 158340.0n 0.80000 158469.9n 0.80000 158470.0n 0.80000 158599.9n 0.80000 158600.0n 0.80000 158729.9n 0.80000 158730.0n 0.80000 158859.9n 0.80000 158860.0n 0.80000 158989.9n 0.80000 158990.0n 0.80000 159119.9n 0.80000 159120.0n 0.80000 159249.9n 0.80000 159250.0n 0.80000 159379.9n 0.80000 159380.0n 0.80000 159509.9n 0.80000 159510.0n 0.80000 159639.9n 0.80000 159640.0n 0.80000 159769.9n 0.80000 159770.0n 0.80000 159899.9n 0.80000 159900.0n 0.80000 160029.9n 0.80000 160030.0n 0.80000 160159.9n 0.80000 160160.0n 0.80000 160289.9n 0.80000 160290.0n 0.80000 160419.9n 0.80000 160420.0n 0.80000 160549.9n 0.80000 160550.0n 0.80000 160679.9n 0.80000 160680.0n 0.80000 160809.9n 0.80000 160810.0n 0.80000 160939.9n 0.80000 160940.0n 0.80000 161069.9n 0.80000 161070.0n 0.80000 161199.9n 0.80000 161200.0n 0.80000 161329.9n 0.80000 161330.0n 0.80000 161459.9n 0.80000 161460.0n 0.80000 161589.9n 0.80000 161590.0n 0.80000 161719.9n 0.80000 161720.0n 0.80000 161849.9n 0.80000 161850.0n 0.80000 161979.9n 0.80000 161980.0n 0.80000 162109.9n 0.80000 162110.0n 0.80000 162239.9n 0.80000 162240.0n 0.80000 162369.9n 0.80000 162370.0n 0.80000 162499.9n 0.80000 162500.0n 0.80000 162629.9n 0.80000 162630.0n 0.80000 162759.9n 0.80000 162760.0n 0.80000 162889.9n 0.80000 162890.0n 0.80000 163019.9n 0.80000 163020.0n 0.80000 163149.9n 0.80000 163150.0n 0.80000 163279.9n 0.80000 163280.0n 0.80000 163409.9n 0.80000 163410.0n 0.80000 163539.9n 0.80000 163540.0n 0.80000 163669.9n 0.80000 163670.0n 0.80000 163799.9n 0.80000 163800.0n 0.80000 163929.9n 0.80000 163930.0n 0.80000 164059.9n 0.80000 164060.0n 0.80000 164189.9n 0.80000 164190.0n 0.80000 164319.9n 0.80000 164320.0n 0.80000 164449.9n 0.80000 164450.0n 0.80000 164579.9n 0.80000 164580.0n 0.80000 164709.9n 0.80000 164710.0n 0.80000 164839.9n 0.80000 164840.0n 0.80000 164969.9n 0.80000 164970.0n 0.80000 165099.9n 0.80000 165100.0n 0.80000 165229.9n 0.80000 165230.0n 0.80000 165359.9n 0.80000 165360.0n 0.80000 165489.9n 0.80000 165490.0n 0.80000 165619.9n 0.80000 165620.0n 0.80000 165749.9n 0.80000 165750.0n 0.80000 165879.9n 0.80000 165880.0n 0.80000 166009.9n 0.80000 166010.0n 0.80000 166139.9n 0.80000 166140.0n 0.80000 166269.9n 0.80000 166270.0n 0.80000 166399.9n 0.80000 166400.0n 0.80000 166529.9n 0.80000 166530.0n 0.80000 166659.9n 0.80000 166660.0n 0.80000 166789.9n 0.80000 166790.0n 0.80000 166919.9n 0.80000 166920.0n 0.80000 167049.9n 0.80000 167050.0n 0.80000 167179.9n 0.80000 167180.0n 0.80000 167309.9n 0.80000 167310.0n 0.80000 167439.9n 0.80000 167440.0n 0.80000 167569.9n 0.80000 167570.0n 0.80000 167699.9n 0.80000 167700.0n 0.80000 167829.9n 0.80000 167830.0n 0.80000 167959.9n 0.80000 167960.0n 0.80000 168089.9n 0.80000 168090.0n 0.80000 168219.9n 0.80000 168220.0n 0.80000 168349.9n 0.80000 168350.0n 0.80000)
Vxn2 a_xn2 0 PWL(0.0n 0.20000 129.9n 0.20000 130.0n 0.20000 259.9n 0.20000 260.0n 0.20000 389.9n 0.20000 390.0n 0.20000 519.9n 0.20000 520.0n 0.20000 649.9n 0.20000 650.0n 0.20000 779.9n 0.20000 780.0n 0.20000 909.9n 0.20000 910.0n 0.20000 1039.9n 0.20000 1040.0n 0.20000 1169.9n 0.20000 1170.0n 0.20000 1299.9n 0.20000 1300.0n 0.20000 1429.9n 0.20000 1430.0n 0.20000 1559.9n 0.20000 1560.0n 0.20000 1689.9n 0.20000 1690.0n 0.20000 1819.9n 0.20000 1820.0n 0.20000 1949.9n 0.20000 1950.0n 0.20000 2079.9n 0.20000 2080.0n 0.20000 2209.9n 0.20000 2210.0n 0.20000 2339.9n 0.20000 2340.0n 0.20000 2469.9n 0.20000 2470.0n 0.20000 2599.9n 0.20000 2600.0n 0.20000 2729.9n 0.20000 2730.0n 0.20000 2859.9n 0.20000 2860.0n 0.20000 2989.9n 0.20000 2990.0n 0.20000 3119.9n 0.20000 3120.0n 0.20000 3249.9n 0.20000 3250.0n 0.20000 3379.9n 0.20000 3380.0n 0.20000 3509.9n 0.20000 3510.0n 0.20000 3639.9n 0.20000 3640.0n 0.20000 3769.9n 0.20000 3770.0n 0.20000 3899.9n 0.20000 3900.0n 0.20000 4029.9n 0.20000 4030.0n 0.20000 4159.9n 0.20000 4160.0n 0.20000 4289.9n 0.20000 4290.0n 0.20000 4419.9n 0.20000 4420.0n 0.20000 4549.9n 0.20000 4550.0n 0.20000 4679.9n 0.20000 4680.0n 0.20000 4809.9n 0.20000 4810.0n 0.20000 4939.9n 0.20000 4940.0n 0.20000 5069.9n 0.20000 5070.0n 0.20000 5199.9n 0.20000 5200.0n 0.20000 5329.9n 0.20000 5330.0n 0.20000 5459.9n 0.20000 5460.0n 0.20000 5589.9n 0.20000 5590.0n 0.20000 5719.9n 0.20000 5720.0n 0.20000 5849.9n 0.20000 5850.0n 0.20000 5979.9n 0.20000 5980.0n 0.20000 6109.9n 0.20000 6110.0n 0.20000 6239.9n 0.20000 6240.0n 0.20000 6369.9n 0.20000 6370.0n 0.20000 6499.9n 0.20000 6500.0n 0.20000 6629.9n 0.20000 6630.0n 0.20000 6759.9n 0.20000 6760.0n 0.20000 6889.9n 0.20000 6890.0n 0.20000 7019.9n 0.20000 7020.0n 0.20000 7149.9n 0.20000 7150.0n 0.20000 7279.9n 0.20000 7280.0n 0.20000 7409.9n 0.20000 7410.0n 0.20000 7539.9n 0.20000 7540.0n 0.20000 7669.9n 0.20000 7670.0n 0.20000 7799.9n 0.20000 7800.0n 0.20000 7929.9n 0.20000 7930.0n 0.20000 8059.9n 0.20000 8060.0n 0.20000 8189.9n 0.20000 8190.0n 0.20000 8319.9n 0.20000 8320.0n 0.20000 8449.9n 0.20000 8450.0n 0.20000 8579.9n 0.20000 8580.0n 0.20000 8709.9n 0.20000 8710.0n 0.20000 8839.9n 0.20000 8840.0n 0.20000 8969.9n 0.20000 8970.0n 0.20000 9099.9n 0.20000 9100.0n 0.20000 9229.9n 0.20000 9230.0n 0.20000 9359.9n 0.20000 9360.0n 0.20000 9489.9n 0.20000 9490.0n 0.20000 9619.9n 0.20000 9620.0n 0.20000 9749.9n 0.20000 9750.0n 0.20000 9879.9n 0.20000 9880.0n 0.20000 10009.9n 0.20000 10010.0n 0.20000 10139.9n 0.20000 10140.0n 0.20000 10269.9n 0.20000 10270.0n 0.20000 10399.9n 0.20000 10400.0n 0.20000 10529.9n 0.20000 10530.0n 0.20000 10659.9n 0.20000 10660.0n 0.20000 10789.9n 0.20000 10790.0n 0.20000 10919.9n 0.20000 10920.0n 0.20000 11049.9n 0.20000 11050.0n 0.20000 11179.9n 0.20000 11180.0n 0.20000 11309.9n 0.20000 11310.0n 0.20000 11439.9n 0.20000 11440.0n 0.20000 11569.9n 0.20000 11570.0n 0.20000 11699.9n 0.20000 11700.0n 0.20000 11829.9n 0.20000 11830.0n 0.20000 11959.9n 0.20000 11960.0n 0.20000 12089.9n 0.20000 12090.0n 0.20000 12219.9n 0.20000 12220.0n 0.20000 12349.9n 0.20000 12350.0n 0.20000 12479.9n 0.20000 12480.0n 0.20000 12609.9n 0.20000 12610.0n 0.20000 12739.9n 0.20000 12740.0n 0.20000 12869.9n 0.20000 12870.0n 0.20000 12999.9n 0.20000 13000.0n 0.20000 13129.9n 0.20000 13130.0n 0.20000 13259.9n 0.20000 13260.0n 0.20000 13389.9n 0.20000 13390.0n 0.20000 13519.9n 0.20000 13520.0n 0.20000 13649.9n 0.20000 13650.0n 0.20000 13779.9n 0.20000 13780.0n 0.20000 13909.9n 0.20000 13910.0n 0.20000 14039.9n 0.20000 14040.0n 0.20000 14169.9n 0.20000 14170.0n 0.20000 14299.9n 0.20000 14300.0n 0.20000 14429.9n 0.20000 14430.0n 0.20000 14559.9n 0.20000 14560.0n 0.20000 14689.9n 0.20000 14690.0n 0.20000 14819.9n 0.20000 14820.0n 0.20000 14949.9n 0.20000 14950.0n 0.20000 15079.9n 0.20000 15080.0n 0.20000 15209.9n 0.20000 15210.0n 0.20000 15339.9n 0.20000 15340.0n 0.20000 15469.9n 0.20000 15470.0n 0.20000 15599.9n 0.20000 15600.0n 0.20000 15729.9n 0.20000 15730.0n 0.20000 15859.9n 0.20000 15860.0n 0.20000 15989.9n 0.20000 15990.0n 0.20000 16119.9n 0.20000 16120.0n 0.20000 16249.9n 0.20000 16250.0n 0.20000 16379.9n 0.20000 16380.0n 0.20000 16509.9n 0.20000 16510.0n 0.20000 16639.9n 0.20000 16640.0n 0.20000 16769.9n 0.20000 16770.0n 0.20000 16899.9n 0.20000 16900.0n 0.20000 17029.9n 0.20000 17030.0n 0.20000 17159.9n 0.20000 17160.0n 0.20000 17289.9n 0.20000 17290.0n 0.20000 17419.9n 0.20000 17420.0n 0.20000 17549.9n 0.20000 17550.0n 0.20000 17679.9n 0.20000 17680.0n 0.20000 17809.9n 0.20000 17810.0n 0.20000 17939.9n 0.20000 17940.0n 0.20000 18069.9n 0.20000 18070.0n 0.20000 18199.9n 0.20000 18200.0n 0.20000 18329.9n 0.20000 18330.0n 0.20000 18459.9n 0.20000 18460.0n 0.20000 18589.9n 0.20000 18590.0n 0.20000 18719.9n 0.20000 18720.0n 0.20000 18849.9n 0.20000 18850.0n 0.20000 18979.9n 0.20000 18980.0n 0.20000 19109.9n 0.20000 19110.0n 0.20000 19239.9n 0.20000 19240.0n 0.20000 19369.9n 0.20000 19370.0n 0.20000 19499.9n 0.20000 19500.0n 0.20000 19629.9n 0.20000 19630.0n 0.20000 19759.9n 0.20000 19760.0n 0.20000 19889.9n 0.20000 19890.0n 0.20000 20019.9n 0.20000 20020.0n 0.20000 20149.9n 0.20000 20150.0n 0.20000 20279.9n 0.20000 20280.0n 0.20000 20409.9n 0.20000 20410.0n 0.20000 20539.9n 0.20000 20540.0n 0.20000 20669.9n 0.20000 20670.0n 0.20000 20799.9n 0.20000 20800.0n 0.20000 20929.9n 0.20000 20930.0n 0.20000 21059.9n 0.20000 21060.0n 0.20000 21189.9n 0.20000 21190.0n 0.20000 21319.9n 0.20000 21320.0n 0.20000 21449.9n 0.20000 21450.0n 0.20000 21579.9n 0.20000 21580.0n 0.20000 21709.9n 0.20000 21710.0n 0.20000 21839.9n 0.20000 21840.0n 0.20000 21969.9n 0.20000 21970.0n 0.20000 22099.9n 0.20000 22100.0n 0.20000 22229.9n 0.20000 22230.0n 0.20000 22359.9n 0.20000 22360.0n 0.20000 22489.9n 0.20000 22490.0n 0.20000 22619.9n 0.20000 22620.0n 0.20000 22749.9n 0.20000 22750.0n 0.20000 22879.9n 0.20000 22880.0n 0.20000 23009.9n 0.20000 23010.0n 0.20000 23139.9n 0.20000 23140.0n 0.20000 23269.9n 0.20000 23270.0n 0.20000 23399.9n 0.20000 23400.0n 0.20000 23529.9n 0.20000 23530.0n 0.20000 23659.9n 0.20000 23660.0n 0.20000 23789.9n 0.20000 23790.0n 0.20000 23919.9n 0.20000 23920.0n 0.20000 24049.9n 0.20000 24050.0n 0.20000 24179.9n 0.20000 24180.0n 0.20000 24309.9n 0.20000 24310.0n 0.20000 24439.9n 0.20000 24440.0n 0.20000 24569.9n 0.20000 24570.0n 0.20000 24699.9n 0.20000 24700.0n 0.20000 24829.9n 0.20000 24830.0n 0.20000 24959.9n 0.20000 24960.0n 0.20000 25089.9n 0.20000 25090.0n 0.20000 25219.9n 0.20000 25220.0n 0.20000 25349.9n 0.20000 25350.0n 0.20000 25479.9n 0.20000 25480.0n 0.20000 25609.9n 0.20000 25610.0n 0.20000 25739.9n 0.20000 25740.0n 0.20000 25869.9n 0.20000 25870.0n 0.20000 25999.9n 0.20000 26000.0n 0.20000 26129.9n 0.20000 26130.0n 0.20000 26259.9n 0.20000 26260.0n 0.20000 26389.9n 0.20000 26390.0n 0.20000 26519.9n 0.20000 26520.0n 0.20000 26649.9n 0.20000 26650.0n 0.20000 26779.9n 0.20000 26780.0n 0.20000 26909.9n 0.20000 26910.0n 0.20000 27039.9n 0.20000 27040.0n 0.20000 27169.9n 0.20000 27170.0n 0.20000 27299.9n 0.20000 27300.0n 0.20000 27429.9n 0.20000 27430.0n 0.20000 27559.9n 0.20000 27560.0n 0.20000 27689.9n 0.20000 27690.0n 0.20000 27819.9n 0.20000 27820.0n 0.20000 27949.9n 0.20000 27950.0n 0.20000 28079.9n 0.20000 28080.0n 0.20000 28209.9n 0.20000 28210.0n 0.20000 28339.9n 0.20000 28340.0n 0.20000 28469.9n 0.20000 28470.0n 0.20000 28599.9n 0.20000 28600.0n 0.20000 28729.9n 0.20000 28730.0n 0.20000 28859.9n 0.20000 28860.0n 0.20000 28989.9n 0.20000 28990.0n 0.20000 29119.9n 0.20000 29120.0n 0.20000 29249.9n 0.20000 29250.0n 0.20000 29379.9n 0.20000 29380.0n 0.20000 29509.9n 0.20000 29510.0n 0.20000 29639.9n 0.20000 29640.0n 0.20000 29769.9n 0.20000 29770.0n 0.20000 29899.9n 0.20000 29900.0n 0.20000 30029.9n 0.20000 30030.0n 0.20000 30159.9n 0.20000 30160.0n 0.20000 30289.9n 0.20000 30290.0n 0.20000 30419.9n 0.20000 30420.0n 0.20000 30549.9n 0.20000 30550.0n 0.20000 30679.9n 0.20000 30680.0n 0.20000 30809.9n 0.20000 30810.0n 0.20000 30939.9n 0.20000 30940.0n 0.20000 31069.9n 0.20000 31070.0n 0.20000 31199.9n 0.20000 31200.0n 0.20000 31329.9n 0.20000 31330.0n 0.20000 31459.9n 0.20000 31460.0n 0.20000 31589.9n 0.20000 31590.0n 0.20000 31719.9n 0.20000 31720.0n 0.20000 31849.9n 0.20000 31850.0n 0.20000 31979.9n 0.20000 31980.0n 0.20000 32109.9n 0.20000 32110.0n 0.20000 32239.9n 0.20000 32240.0n 0.20000 32369.9n 0.20000 32370.0n 0.20000 32499.9n 0.20000 32500.0n 0.20000 32629.9n 0.20000 32630.0n 0.20000 32759.9n 0.20000 32760.0n 0.20000 32889.9n 0.20000 32890.0n 0.20000 33019.9n 0.20000 33020.0n 0.20000 33149.9n 0.20000 33150.0n 0.20000 33279.9n 0.20000 33280.0n 0.20000 33409.9n 0.20000 33410.0n 0.20000 33539.9n 0.20000 33540.0n 0.20000 33669.9n 0.20000 33670.0n 0.20000 33799.9n 0.20000 33800.0n 0.20000 33929.9n 0.20000 33930.0n 0.20000 34059.9n 0.20000 34060.0n 0.20000 34189.9n 0.20000 34190.0n 0.20000 34319.9n 0.20000 34320.0n 0.20000 34449.9n 0.20000 34450.0n 0.20000 34579.9n 0.20000 34580.0n 0.20000 34709.9n 0.20000 34710.0n 0.20000 34839.9n 0.20000 34840.0n 0.20000 34969.9n 0.20000 34970.0n 0.20000 35099.9n 0.20000 35100.0n 0.20000 35229.9n 0.20000 35230.0n 0.20000 35359.9n 0.20000 35360.0n 0.20000 35489.9n 0.20000 35490.0n 0.20000 35619.9n 0.20000 35620.0n 0.20000 35749.9n 0.20000 35750.0n 0.20000 35879.9n 0.20000 35880.0n 0.20000 36009.9n 0.20000 36010.0n 0.20000 36139.9n 0.20000 36140.0n 0.20000 36269.9n 0.20000 36270.0n 0.20000 36399.9n 0.20000 36400.0n 0.20000 36529.9n 0.20000 36530.0n 0.20000 36659.9n 0.20000 36660.0n 0.20000 36789.9n 0.20000 36790.0n 0.20000 36919.9n 0.20000 36920.0n 0.20000 37049.9n 0.20000 37050.0n 0.20000 37179.9n 0.20000 37180.0n 0.20000 37309.9n 0.20000 37310.0n 0.20000 37439.9n 0.20000 37440.0n 0.20000 37569.9n 0.20000 37570.0n 0.20000 37699.9n 0.20000 37700.0n 0.20000 37829.9n 0.20000 37830.0n 0.20000 37959.9n 0.20000 37960.0n 0.20000 38089.9n 0.20000 38090.0n 0.20000 38219.9n 0.20000 38220.0n 0.20000 38349.9n 0.20000 38350.0n 0.20000 38479.9n 0.20000 38480.0n 0.20000 38609.9n 0.20000 38610.0n 0.20000 38739.9n 0.20000 38740.0n 0.20000 38869.9n 0.20000 38870.0n 0.20000 38999.9n 0.20000 39000.0n 0.20000 39129.9n 0.20000 39130.0n 0.20000 39259.9n 0.20000 39260.0n 0.20000 39389.9n 0.20000 39390.0n 0.20000 39519.9n 0.20000 39520.0n 0.20000 39649.9n 0.20000 39650.0n 0.20000 39779.9n 0.20000 39780.0n 0.20000 39909.9n 0.20000 39910.0n 0.20000 40039.9n 0.20000 40040.0n 0.20000 40169.9n 0.20000 40170.0n 0.20000 40299.9n 0.20000 40300.0n 0.20000 40429.9n 0.20000 40430.0n 0.20000 40559.9n 0.20000 40560.0n 0.20000 40689.9n 0.20000 40690.0n 0.20000 40819.9n 0.20000 40820.0n 0.20000 40949.9n 0.20000 40950.0n 0.20000 41079.9n 0.20000 41080.0n 0.20000 41209.9n 0.20000 41210.0n 0.20000 41339.9n 0.20000 41340.0n 0.20000 41469.9n 0.20000 41470.0n 0.20000 41599.9n 0.20000 41600.0n 0.20000 41729.9n 0.20000 41730.0n 0.20000 41859.9n 0.20000 41860.0n 0.20000 41989.9n 0.20000 41990.0n 0.20000 42119.9n 0.20000 42120.0n 0.20000 42249.9n 0.20000 42250.0n 0.20000 42379.9n 0.20000 42380.0n 0.20000 42509.9n 0.20000 42510.0n 0.20000 42639.9n 0.20000 42640.0n 0.20000 42769.9n 0.20000 42770.0n 0.20000 42899.9n 0.20000 42900.0n 0.20000 43029.9n 0.20000 43030.0n 0.20000 43159.9n 0.20000 43160.0n 0.20000 43289.9n 0.20000 43290.0n 0.20000 43419.9n 0.20000 43420.0n 0.20000 43549.9n 0.20000 43550.0n 0.20000 43679.9n 0.20000 43680.0n 0.20000 43809.9n 0.20000 43810.0n 0.20000 43939.9n 0.20000 43940.0n 0.20000 44069.9n 0.20000 44070.0n 0.20000 44199.9n 0.20000 44200.0n 0.20000 44329.9n 0.20000 44330.0n 0.20000 44459.9n 0.20000 44460.0n 0.20000 44589.9n 0.20000 44590.0n 0.20000 44719.9n 0.20000 44720.0n 0.20000 44849.9n 0.20000 44850.0n 0.20000 44979.9n 0.20000 44980.0n 0.20000 45109.9n 0.20000 45110.0n 0.20000 45239.9n 0.20000 45240.0n 0.20000 45369.9n 0.20000 45370.0n 0.20000 45499.9n 0.20000 45500.0n 0.20000 45629.9n 0.20000 45630.0n 0.20000 45759.9n 0.20000 45760.0n 0.20000 45889.9n 0.20000 45890.0n 0.20000 46019.9n 0.20000 46020.0n 0.20000 46149.9n 0.20000 46150.0n 0.20000 46279.9n 0.20000 46280.0n 0.20000 46409.9n 0.20000 46410.0n 0.20000 46539.9n 0.20000 46540.0n 0.20000 46669.9n 0.20000 46670.0n 0.20000 46799.9n 0.20000 46800.0n 0.20000 46929.9n 0.20000 46930.0n 0.20000 47059.9n 0.20000 47060.0n 0.20000 47189.9n 0.20000 47190.0n 0.20000 47319.9n 0.20000 47320.0n 0.20000 47449.9n 0.20000 47450.0n 0.20000 47579.9n 0.20000 47580.0n 0.20000 47709.9n 0.20000 47710.0n 0.20000 47839.9n 0.20000 47840.0n 0.20000 47969.9n 0.20000 47970.0n 0.20000 48099.9n 0.20000 48100.0n 0.20000 48229.9n 0.20000 48230.0n 0.20000 48359.9n 0.20000 48360.0n 0.20000 48489.9n 0.20000 48490.0n 0.20000 48619.9n 0.20000 48620.0n 0.20000 48749.9n 0.20000 48750.0n 0.20000 48879.9n 0.20000 48880.0n 0.20000 49009.9n 0.20000 49010.0n 0.20000 49139.9n 0.20000 49140.0n 0.20000 49269.9n 0.20000 49270.0n 0.20000 49399.9n 0.20000 49400.0n 0.20000 49529.9n 0.20000 49530.0n 0.20000 49659.9n 0.20000 49660.0n 0.20000 49789.9n 0.20000 49790.0n 0.20000 49919.9n 0.20000 49920.0n 0.20000 50049.9n 0.20000 50050.0n 0.20000 50179.9n 0.20000 50180.0n 0.20000 50309.9n 0.20000 50310.0n 0.20000 50439.9n 0.20000 50440.0n 0.20000 50569.9n 0.20000 50570.0n 0.20000 50699.9n 0.20000 50700.0n 0.20000 50829.9n 0.20000 50830.0n 0.20000 50959.9n 0.20000 50960.0n 0.20000 51089.9n 0.20000 51090.0n 0.20000 51219.9n 0.20000 51220.0n 0.20000 51349.9n 0.20000 51350.0n 0.20000 51479.9n 0.20000 51480.0n 0.20000 51609.9n 0.20000 51610.0n 0.20000 51739.9n 0.20000 51740.0n 0.20000 51869.9n 0.20000 51870.0n 0.20000 51999.9n 0.20000 52000.0n 0.20000 52129.9n 0.20000 52130.0n 0.20000 52259.9n 0.20000 52260.0n 0.20000 52389.9n 0.20000 52390.0n 0.20000 52519.9n 0.20000 52520.0n 0.20000 52649.9n 0.20000 52650.0n 0.20000 52779.9n 0.20000 52780.0n 0.20000 52909.9n 0.20000 52910.0n 0.20000 53039.9n 0.20000 53040.0n 0.20000 53169.9n 0.20000 53170.0n 0.20000 53299.9n 0.20000 53300.0n 0.20000 53429.9n 0.20000 53430.0n 0.20000 53559.9n 0.20000 53560.0n 0.20000 53689.9n 0.20000 53690.0n 0.20000 53819.9n 0.20000 53820.0n 0.20000 53949.9n 0.20000 53950.0n 0.20000 54079.9n 0.20000 54080.0n 0.20000 54209.9n 0.20000 54210.0n 0.20000 54339.9n 0.20000 54340.0n 0.20000 54469.9n 0.20000 54470.0n 0.20000 54599.9n 0.20000 54600.0n 0.20000 54729.9n 0.20000 54730.0n 0.20000 54859.9n 0.20000 54860.0n 0.20000 54989.9n 0.20000 54990.0n 0.20000 55119.9n 0.20000 55120.0n 0.20000 55249.9n 0.20000 55250.0n 0.20000 55379.9n 0.20000 55380.0n 0.20000 55509.9n 0.20000 55510.0n 0.20000 55639.9n 0.20000 55640.0n 0.20000 55769.9n 0.20000 55770.0n 0.20000 55899.9n 0.20000 55900.0n 0.20000 56029.9n 0.20000 56030.0n 0.20000 56159.9n 0.20000 56160.0n 0.20000 56289.9n 0.20000 56290.0n 0.20000 56419.9n 0.20000 56420.0n 0.20000 56549.9n 0.20000 56550.0n 0.20000 56679.9n 0.20000 56680.0n 0.20000 56809.9n 0.20000 56810.0n 0.20000 56939.9n 0.20000 56940.0n 0.20000 57069.9n 0.20000 57070.0n 0.20000 57199.9n 0.20000 57200.0n 0.20000 57329.9n 0.20000 57330.0n 0.20000 57459.9n 0.20000 57460.0n 0.20000 57589.9n 0.20000 57590.0n 0.20000 57719.9n 0.20000 57720.0n 0.20000 57849.9n 0.20000 57850.0n 0.20000 57979.9n 0.20000 57980.0n 0.20000 58109.9n 0.20000 58110.0n 0.20000 58239.9n 0.20000 58240.0n 0.20000 58369.9n 0.20000 58370.0n 0.20000 58499.9n 0.20000 58500.0n 0.20000 58629.9n 0.20000 58630.0n 0.20000 58759.9n 0.20000 58760.0n 0.20000 58889.9n 0.20000 58890.0n 0.20000 59019.9n 0.20000 59020.0n 0.20000 59149.9n 0.20000 59150.0n 0.20000 59279.9n 0.20000 59280.0n 0.20000 59409.9n 0.20000 59410.0n 0.20000 59539.9n 0.20000 59540.0n 0.20000 59669.9n 0.20000 59670.0n 0.20000 59799.9n 0.20000 59800.0n 0.20000 59929.9n 0.20000 59930.0n 0.20000 60059.9n 0.20000 60060.0n 0.20000 60189.9n 0.20000 60190.0n 0.20000 60319.9n 0.20000 60320.0n 0.20000 60449.9n 0.20000 60450.0n 0.20000 60579.9n 0.20000 60580.0n 0.20000 60709.9n 0.20000 60710.0n 0.20000 60839.9n 0.20000 60840.0n 0.20000 60969.9n 0.20000 60970.0n 0.20000 61099.9n 0.20000 61100.0n 0.20000 61229.9n 0.20000 61230.0n 0.20000 61359.9n 0.20000 61360.0n 0.20000 61489.9n 0.20000 61490.0n 0.20000 61619.9n 0.20000 61620.0n 0.20000 61749.9n 0.20000 61750.0n 0.20000 61879.9n 0.20000 61880.0n 0.20000 62009.9n 0.20000 62010.0n 0.20000 62139.9n 0.20000 62140.0n 0.20000 62269.9n 0.20000 62270.0n 0.20000 62399.9n 0.20000 62400.0n 0.20000 62529.9n 0.20000 62530.0n 0.20000 62659.9n 0.20000 62660.0n 0.20000 62789.9n 0.20000 62790.0n 0.20000 62919.9n 0.20000 62920.0n 0.20000 63049.9n 0.20000 63050.0n 0.20000 63179.9n 0.20000 63180.0n 0.20000 63309.9n 0.20000 63310.0n 0.20000 63439.9n 0.20000 63440.0n 0.20000 63569.9n 0.20000 63570.0n 0.20000 63699.9n 0.20000 63700.0n 0.20000 63829.9n 0.20000 63830.0n 0.20000 63959.9n 0.20000 63960.0n 0.20000 64089.9n 0.20000 64090.0n 0.20000 64219.9n 0.20000 64220.0n 0.20000 64349.9n 0.20000 64350.0n 0.20000 64479.9n 0.20000 64480.0n 0.20000 64609.9n 0.20000 64610.0n 0.20000 64739.9n 0.20000 64740.0n 0.20000 64869.9n 0.20000 64870.0n 0.20000 64999.9n 0.20000 65000.0n 0.20000 65129.9n 0.20000 65130.0n 0.20000 65259.9n 0.20000 65260.0n 0.20000 65389.9n 0.20000 65390.0n 0.20000 65519.9n 0.20000 65520.0n 0.20000 65649.9n 0.20000 65650.0n 0.20000 65779.9n 0.20000 65780.0n 0.20000 65909.9n 0.20000 65910.0n 0.20000 66039.9n 0.20000 66040.0n 0.20000 66169.9n 0.20000 66170.0n 0.20000 66299.9n 0.20000 66300.0n 0.20000 66429.9n 0.20000 66430.0n 0.20000 66559.9n 0.20000 66560.0n 0.20000 66689.9n 0.20000 66690.0n 0.20000 66819.9n 0.20000 66820.0n 0.20000 66949.9n 0.20000 66950.0n 0.20000 67079.9n 0.20000 67080.0n 0.20000 67209.9n 0.20000 67210.0n 0.20000 67339.9n 0.20000 67340.0n 0.20000 67469.9n 0.20000 67470.0n 0.20000 67599.9n 0.20000 67600.0n 0.20000 67729.9n 0.20000 67730.0n 0.20000 67859.9n 0.20000 67860.0n 0.20000 67989.9n 0.20000 67990.0n 0.20000 68119.9n 0.20000 68120.0n 0.20000 68249.9n 0.20000 68250.0n 0.20000 68379.9n 0.20000 68380.0n 0.20000 68509.9n 0.20000 68510.0n 0.20000 68639.9n 0.20000 68640.0n 0.20000 68769.9n 0.20000 68770.0n 0.20000 68899.9n 0.20000 68900.0n 0.20000 69029.9n 0.20000 69030.0n 0.20000 69159.9n 0.20000 69160.0n 0.20000 69289.9n 0.20000 69290.0n 0.20000 69419.9n 0.20000 69420.0n 0.20000 69549.9n 0.20000 69550.0n 0.20000 69679.9n 0.20000 69680.0n 0.20000 69809.9n 0.20000 69810.0n 0.20000 69939.9n 0.20000 69940.0n 0.20000 70069.9n 0.20000 70070.0n 0.20000 70199.9n 0.20000 70200.0n 0.20000 70329.9n 0.20000 70330.0n 0.20000 70459.9n 0.20000 70460.0n 0.20000 70589.9n 0.20000 70590.0n 0.20000 70719.9n 0.20000 70720.0n 0.20000 70849.9n 0.20000 70850.0n 0.20000 70979.9n 0.20000 70980.0n 0.20000 71109.9n 0.20000 71110.0n 0.20000 71239.9n 0.20000 71240.0n 0.20000 71369.9n 0.20000 71370.0n 0.20000 71499.9n 0.20000 71500.0n 0.20000 71629.9n 0.20000 71630.0n 0.20000 71759.9n 0.20000 71760.0n 0.20000 71889.9n 0.20000 71890.0n 0.20000 72019.9n 0.20000 72020.0n 0.20000 72149.9n 0.20000 72150.0n 0.20000 72279.9n 0.20000 72280.0n 0.20000 72409.9n 0.20000 72410.0n 0.20000 72539.9n 0.20000 72540.0n 0.20000 72669.9n 0.20000 72670.0n 0.20000 72799.9n 0.20000 72800.0n 0.20000 72929.9n 0.20000 72930.0n 0.20000 73059.9n 0.20000 73060.0n 0.20000 73189.9n 0.20000 73190.0n 0.20000 73319.9n 0.20000 73320.0n 0.20000 73449.9n 0.20000 73450.0n 0.20000 73579.9n 0.20000 73580.0n 0.20000 73709.9n 0.20000 73710.0n 0.20000 73839.9n 0.20000 73840.0n 0.20000 73969.9n 0.20000 73970.0n 0.20000 74099.9n 0.20000 74100.0n 0.20000 74229.9n 0.20000 74230.0n 0.20000 74359.9n 0.20000 74360.0n 0.20000 74489.9n 0.20000 74490.0n 0.20000 74619.9n 0.20000 74620.0n 0.20000 74749.9n 0.20000 74750.0n 0.20000 74879.9n 0.20000 74880.0n 0.20000 75009.9n 0.20000 75010.0n 0.20000 75139.9n 0.20000 75140.0n 0.20000 75269.9n 0.20000 75270.0n 0.20000 75399.9n 0.20000 75400.0n 0.20000 75529.9n 0.20000 75530.0n 0.20000 75659.9n 0.20000 75660.0n 0.20000 75789.9n 0.20000 75790.0n 0.20000 75919.9n 0.20000 75920.0n 0.20000 76049.9n 0.20000 76050.0n 0.20000 76179.9n 0.20000 76180.0n 0.20000 76309.9n 0.20000 76310.0n 0.20000 76439.9n 0.20000 76440.0n 0.20000 76569.9n 0.20000 76570.0n 0.20000 76699.9n 0.20000 76700.0n 0.20000 76829.9n 0.20000 76830.0n 0.20000 76959.9n 0.20000 76960.0n 0.20000 77089.9n 0.20000 77090.0n 0.20000 77219.9n 0.20000 77220.0n 0.20000 77349.9n 0.20000 77350.0n 0.20000 77479.9n 0.20000 77480.0n 0.20000 77609.9n 0.20000 77610.0n 0.20000 77739.9n 0.20000 77740.0n 0.20000 77869.9n 0.20000 77870.0n 0.20000 77999.9n 0.20000 78000.0n 0.20000 78129.9n 0.20000 78130.0n 0.20000 78259.9n 0.20000 78260.0n 0.20000 78389.9n 0.20000 78390.0n 0.20000 78519.9n 0.20000 78520.0n 0.20000 78649.9n 0.20000 78650.0n 0.20000 78779.9n 0.20000 78780.0n 0.20000 78909.9n 0.20000 78910.0n 0.20000 79039.9n 0.20000 79040.0n 0.20000 79169.9n 0.20000 79170.0n 0.20000 79299.9n 0.20000 79300.0n 0.20000 79429.9n 0.20000 79430.0n 0.20000 79559.9n 0.20000 79560.0n 0.20000 79689.9n 0.20000 79690.0n 0.20000 79819.9n 0.20000 79820.0n 0.20000 79949.9n 0.20000 79950.0n 0.20000 80079.9n 0.20000 80080.0n 0.20000 80209.9n 0.20000 80210.0n 0.20000 80339.9n 0.20000 80340.0n 0.20000 80469.9n 0.20000 80470.0n 0.20000 80599.9n 0.20000 80600.0n 0.20000 80729.9n 0.20000 80730.0n 0.20000 80859.9n 0.20000 80860.0n 0.20000 80989.9n 0.20000 80990.0n 0.20000 81119.9n 0.20000 81120.0n 0.20000 81249.9n 0.20000 81250.0n 0.20000 81379.9n 0.20000 81380.0n 0.20000 81509.9n 0.20000 81510.0n 0.20000 81639.9n 0.20000 81640.0n 0.20000 81769.9n 0.20000 81770.0n 0.20000 81899.9n 0.20000 81900.0n 0.20000 82029.9n 0.20000 82030.0n 0.20000 82159.9n 0.20000 82160.0n 0.20000 82289.9n 0.20000 82290.0n 0.20000 82419.9n 0.20000 82420.0n 0.20000 82549.9n 0.20000 82550.0n 0.20000 82679.9n 0.20000 82680.0n 0.20000 82809.9n 0.20000 82810.0n 0.20000 82939.9n 0.20000 82940.0n 0.20000 83069.9n 0.20000 83070.0n 0.20000 83199.9n 0.20000 83200.0n 0.20000 83329.9n 0.20000 83330.0n 0.20000 83459.9n 0.20000 83460.0n 0.20000 83589.9n 0.20000 83590.0n 0.20000 83719.9n 0.20000 83720.0n 0.20000 83849.9n 0.20000 83850.0n 0.20000 83979.9n 0.20000 83980.0n 0.20000 84109.9n 0.20000 84110.0n 0.20000 84239.9n 0.20000 84240.0n 0.20000 84369.9n 0.20000 84370.0n 0.20000 84499.9n 0.20000 84500.0n 0.20000 84629.9n 0.20000 84630.0n 0.20000 84759.9n 0.20000 84760.0n 0.20000 84889.9n 0.20000 84890.0n 0.20000 85019.9n 0.20000 85020.0n 0.20000 85149.9n 0.20000 85150.0n 0.20000 85279.9n 0.20000 85280.0n 0.20000 85409.9n 0.20000 85410.0n 0.20000 85539.9n 0.20000 85540.0n 0.20000 85669.9n 0.20000 85670.0n 0.20000 85799.9n 0.20000 85800.0n 0.20000 85929.9n 0.20000 85930.0n 0.20000 86059.9n 0.20000 86060.0n 0.20000 86189.9n 0.20000 86190.0n 0.20000 86319.9n 0.20000 86320.0n 0.20000 86449.9n 0.20000 86450.0n 0.20000 86579.9n 0.20000 86580.0n 0.20000 86709.9n 0.20000 86710.0n 0.20000 86839.9n 0.20000 86840.0n 0.20000 86969.9n 0.20000 86970.0n 0.20000 87099.9n 0.20000 87100.0n 0.20000 87229.9n 0.20000 87230.0n 0.20000 87359.9n 0.20000 87360.0n 0.20000 87489.9n 0.20000 87490.0n 0.20000 87619.9n 0.20000 87620.0n 0.20000 87749.9n 0.20000 87750.0n 0.20000 87879.9n 0.20000 87880.0n 0.20000 88009.9n 0.20000 88010.0n 0.20000 88139.9n 0.20000 88140.0n 0.20000 88269.9n 0.20000 88270.0n 0.20000 88399.9n 0.20000 88400.0n 0.20000 88529.9n 0.20000 88530.0n 0.20000 88659.9n 0.20000 88660.0n 0.20000 88789.9n 0.20000 88790.0n 0.20000 88919.9n 0.20000 88920.0n 0.20000 89049.9n 0.20000 89050.0n 0.20000 89179.9n 0.20000 89180.0n 0.20000 89309.9n 0.20000 89310.0n 0.20000 89439.9n 0.20000 89440.0n 0.20000 89569.9n 0.20000 89570.0n 0.20000 89699.9n 0.20000 89700.0n 0.20000 89829.9n 0.20000 89830.0n 0.20000 89959.9n 0.20000 89960.0n 0.20000 90089.9n 0.20000 90090.0n 0.20000 90219.9n 0.20000 90220.0n 0.20000 90349.9n 0.20000 90350.0n 0.20000 90479.9n 0.20000 90480.0n 0.20000 90609.9n 0.20000 90610.0n 0.20000 90739.9n 0.20000 90740.0n 0.20000 90869.9n 0.20000 90870.0n 0.20000 90999.9n 0.20000 91000.0n 0.20000 91129.9n 0.20000 91130.0n 0.20000 91259.9n 0.20000 91260.0n 0.20000 91389.9n 0.20000 91390.0n 0.20000 91519.9n 0.20000 91520.0n 0.20000 91649.9n 0.20000 91650.0n 0.20000 91779.9n 0.20000 91780.0n 0.20000 91909.9n 0.20000 91910.0n 0.20000 92039.9n 0.20000 92040.0n 0.20000 92169.9n 0.20000 92170.0n 0.20000 92299.9n 0.20000 92300.0n 0.20000 92429.9n 0.20000 92430.0n 0.20000 92559.9n 0.20000 92560.0n 0.20000 92689.9n 0.20000 92690.0n 0.20000 92819.9n 0.20000 92820.0n 0.20000 92949.9n 0.20000 92950.0n 0.20000 93079.9n 0.20000 93080.0n 0.20000 93209.9n 0.20000 93210.0n 0.20000 93339.9n 0.20000 93340.0n 0.20000 93469.9n 0.20000 93470.0n 0.20000 93599.9n 0.20000 93600.0n 0.20000 93729.9n 0.20000 93730.0n 0.20000 93859.9n 0.20000 93860.0n 0.20000 93989.9n 0.20000 93990.0n 0.20000 94119.9n 0.20000 94120.0n 0.20000 94249.9n 0.20000 94250.0n 0.20000 94379.9n 0.20000 94380.0n 0.20000 94509.9n 0.20000 94510.0n 0.20000 94639.9n 0.20000 94640.0n 0.20000 94769.9n 0.20000 94770.0n 0.20000 94899.9n 0.20000 94900.0n 0.20000 95029.9n 0.20000 95030.0n 0.20000 95159.9n 0.20000 95160.0n 0.20000 95289.9n 0.20000 95290.0n 0.20000 95419.9n 0.20000 95420.0n 0.20000 95549.9n 0.20000 95550.0n 0.20000 95679.9n 0.20000 95680.0n 0.20000 95809.9n 0.20000 95810.0n 0.20000 95939.9n 0.20000 95940.0n 0.20000 96069.9n 0.20000 96070.0n 0.20000 96199.9n 0.20000 96200.0n 0.20000 96329.9n 0.20000 96330.0n 0.20000 96459.9n 0.20000 96460.0n 0.20000 96589.9n 0.20000 96590.0n 0.20000 96719.9n 0.20000 96720.0n 0.20000 96849.9n 0.20000 96850.0n 0.20000 96979.9n 0.20000 96980.0n 0.20000 97109.9n 0.20000 97110.0n 0.20000 97239.9n 0.20000 97240.0n 0.20000 97369.9n 0.20000 97370.0n 0.20000 97499.9n 0.20000 97500.0n 0.20000 97629.9n 0.20000 97630.0n 0.20000 97759.9n 0.20000 97760.0n 0.20000 97889.9n 0.20000 97890.0n 0.20000 98019.9n 0.20000 98020.0n 0.20000 98149.9n 0.20000 98150.0n 0.20000 98279.9n 0.20000 98280.0n 0.20000 98409.9n 0.20000 98410.0n 0.20000 98539.9n 0.20000 98540.0n 0.20000 98669.9n 0.20000 98670.0n 0.20000 98799.9n 0.20000 98800.0n 0.20000 98929.9n 0.20000 98930.0n 0.20000 99059.9n 0.20000 99060.0n 0.20000 99189.9n 0.20000 99190.0n 0.20000 99319.9n 0.20000 99320.0n 0.20000 99449.9n 0.20000 99450.0n 0.20000 99579.9n 0.20000 99580.0n 0.20000 99709.9n 0.20000 99710.0n 0.20000 99839.9n 0.20000 99840.0n 0.20000 99969.9n 0.20000 99970.0n 0.20000 100099.9n 0.20000 100100.0n 0.20000 100229.9n 0.20000 100230.0n 0.20000 100359.9n 0.20000 100360.0n 0.20000 100489.9n 0.20000 100490.0n 0.20000 100619.9n 0.20000 100620.0n 0.20000 100749.9n 0.20000 100750.0n 0.20000 100879.9n 0.20000 100880.0n 0.20000 101009.9n 0.20000 101010.0n 0.20000 101139.9n 0.20000 101140.0n 0.20000 101269.9n 0.20000 101270.0n 0.20000 101399.9n 0.20000 101400.0n 0.20000 101529.9n 0.20000 101530.0n 0.20000 101659.9n 0.20000 101660.0n 0.20000 101789.9n 0.20000 101790.0n 0.20000 101919.9n 0.20000 101920.0n 0.20000 102049.9n 0.20000 102050.0n 0.20000 102179.9n 0.20000 102180.0n 0.20000 102309.9n 0.20000 102310.0n 0.20000 102439.9n 0.20000 102440.0n 0.20000 102569.9n 0.20000 102570.0n 0.20000 102699.9n 0.20000 102700.0n 0.20000 102829.9n 0.20000 102830.0n 0.20000 102959.9n 0.20000 102960.0n 0.20000 103089.9n 0.20000 103090.0n 0.20000 103219.9n 0.20000 103220.0n 0.20000 103349.9n 0.20000 103350.0n 0.20000 103479.9n 0.20000 103480.0n 0.20000 103609.9n 0.20000 103610.0n 0.20000 103739.9n 0.20000 103740.0n 0.20000 103869.9n 0.20000 103870.0n 0.20000 103999.9n 0.20000 104000.0n 0.20000 104129.9n 0.20000 104130.0n 0.20000 104259.9n 0.20000 104260.0n 0.20000 104389.9n 0.20000 104390.0n 0.20000 104519.9n 0.20000 104520.0n 0.20000 104649.9n 0.20000 104650.0n 0.20000 104779.9n 0.20000 104780.0n 0.20000 104909.9n 0.20000 104910.0n 0.20000 105039.9n 0.20000 105040.0n 0.20000 105169.9n 0.20000 105170.0n 0.20000 105299.9n 0.20000 105300.0n 0.20000 105429.9n 0.20000 105430.0n 0.20000 105559.9n 0.20000 105560.0n 0.20000 105689.9n 0.20000 105690.0n 0.20000 105819.9n 0.20000 105820.0n 0.20000 105949.9n 0.20000 105950.0n 0.20000 106079.9n 0.20000 106080.0n 0.20000 106209.9n 0.20000 106210.0n 0.20000 106339.9n 0.20000 106340.0n 0.20000 106469.9n 0.20000 106470.0n 0.20000 106599.9n 0.20000 106600.0n 0.20000 106729.9n 0.20000 106730.0n 0.20000 106859.9n 0.20000 106860.0n 0.20000 106989.9n 0.20000 106990.0n 0.20000 107119.9n 0.20000 107120.0n 0.20000 107249.9n 0.20000 107250.0n 0.20000 107379.9n 0.20000 107380.0n 0.20000 107509.9n 0.20000 107510.0n 0.20000 107639.9n 0.20000 107640.0n 0.20000 107769.9n 0.20000 107770.0n 0.20000 107899.9n 0.20000 107900.0n 0.20000 108029.9n 0.20000 108030.0n 0.20000 108159.9n 0.20000 108160.0n 0.20000 108289.9n 0.20000 108290.0n 0.20000 108419.9n 0.20000 108420.0n 0.20000 108549.9n 0.20000 108550.0n 0.20000 108679.9n 0.20000 108680.0n 0.20000 108809.9n 0.20000 108810.0n 0.20000 108939.9n 0.20000 108940.0n 0.20000 109069.9n 0.20000 109070.0n 0.20000 109199.9n 0.20000 109200.0n 0.20000 109329.9n 0.20000 109330.0n 0.20000 109459.9n 0.20000 109460.0n 0.20000 109589.9n 0.20000 109590.0n 0.20000 109719.9n 0.20000 109720.0n 0.20000 109849.9n 0.20000 109850.0n 0.20000 109979.9n 0.20000 109980.0n 0.20000 110109.9n 0.20000 110110.0n 0.20000 110239.9n 0.20000 110240.0n 0.20000 110369.9n 0.20000 110370.0n 0.20000 110499.9n 0.20000 110500.0n 0.20000 110629.9n 0.20000 110630.0n 0.20000 110759.9n 0.20000 110760.0n 0.20000 110889.9n 0.20000 110890.0n 0.20000 111019.9n 0.20000 111020.0n 0.20000 111149.9n 0.20000 111150.0n 0.20000 111279.9n 0.20000 111280.0n 0.20000 111409.9n 0.20000 111410.0n 0.20000 111539.9n 0.20000 111540.0n 0.20000 111669.9n 0.20000 111670.0n 0.20000 111799.9n 0.20000 111800.0n 0.20000 111929.9n 0.20000 111930.0n 0.20000 112059.9n 0.20000 112060.0n 0.20000 112189.9n 0.20000 112190.0n 0.20000 112319.9n 0.20000 112320.0n 0.20000 112449.9n 0.20000 112450.0n 0.20000 112579.9n 0.20000 112580.0n 0.20000 112709.9n 0.20000 112710.0n 0.20000 112839.9n 0.20000 112840.0n 0.20000 112969.9n 0.20000 112970.0n 0.20000 113099.9n 0.20000 113100.0n 0.20000 113229.9n 0.20000 113230.0n 0.20000 113359.9n 0.20000 113360.0n 0.20000 113489.9n 0.20000 113490.0n 0.20000 113619.9n 0.20000 113620.0n 0.20000 113749.9n 0.20000 113750.0n 0.20000 113879.9n 0.20000 113880.0n 0.20000 114009.9n 0.20000 114010.0n 0.20000 114139.9n 0.20000 114140.0n 0.20000 114269.9n 0.20000 114270.0n 0.20000 114399.9n 0.20000 114400.0n 0.20000 114529.9n 0.20000 114530.0n 0.20000 114659.9n 0.20000 114660.0n 0.20000 114789.9n 0.20000 114790.0n 0.20000 114919.9n 0.20000 114920.0n 0.20000 115049.9n 0.20000 115050.0n 0.20000 115179.9n 0.20000 115180.0n 0.20000 115309.9n 0.20000 115310.0n 0.20000 115439.9n 0.20000 115440.0n 0.20000 115569.9n 0.20000 115570.0n 0.20000 115699.9n 0.20000 115700.0n 0.20000 115829.9n 0.20000 115830.0n 0.20000 115959.9n 0.20000 115960.0n 0.20000 116089.9n 0.20000 116090.0n 0.20000 116219.9n 0.20000 116220.0n 0.20000 116349.9n 0.20000 116350.0n 0.20000 116479.9n 0.20000 116480.0n 0.20000 116609.9n 0.20000 116610.0n 0.20000 116739.9n 0.20000 116740.0n 0.20000 116869.9n 0.20000 116870.0n 0.20000 116999.9n 0.20000 117000.0n 0.20000 117129.9n 0.20000 117130.0n 0.20000 117259.9n 0.20000 117260.0n 0.20000 117389.9n 0.20000 117390.0n 0.20000 117519.9n 0.20000 117520.0n 0.20000 117649.9n 0.20000 117650.0n 0.20000 117779.9n 0.20000 117780.0n 0.20000 117909.9n 0.20000 117910.0n 0.20000 118039.9n 0.20000 118040.0n 0.20000 118169.9n 0.20000 118170.0n 0.20000 118299.9n 0.20000 118300.0n 0.20000 118429.9n 0.20000 118430.0n 0.20000 118559.9n 0.20000 118560.0n 0.20000 118689.9n 0.20000 118690.0n 0.20000 118819.9n 0.20000 118820.0n 0.20000 118949.9n 0.20000 118950.0n 0.20000 119079.9n 0.20000 119080.0n 0.20000 119209.9n 0.20000 119210.0n 0.20000 119339.9n 0.20000 119340.0n 0.20000 119469.9n 0.20000 119470.0n 0.20000 119599.9n 0.20000 119600.0n 0.20000 119729.9n 0.20000 119730.0n 0.20000 119859.9n 0.20000 119860.0n 0.20000 119989.9n 0.20000 119990.0n 0.20000 120119.9n 0.20000 120120.0n 0.20000 120249.9n 0.20000 120250.0n 0.20000 120379.9n 0.20000 120380.0n 0.20000 120509.9n 0.20000 120510.0n 0.20000 120639.9n 0.20000 120640.0n 0.20000 120769.9n 0.20000 120770.0n 0.20000 120899.9n 0.20000 120900.0n 0.20000 121029.9n 0.20000 121030.0n 0.20000 121159.9n 0.20000 121160.0n 0.20000 121289.9n 0.20000 121290.0n 0.20000 121419.9n 0.20000 121420.0n 0.20000 121549.9n 0.20000 121550.0n 0.20000 121679.9n 0.20000 121680.0n 0.20000 121809.9n 0.20000 121810.0n 0.20000 121939.9n 0.20000 121940.0n 0.20000 122069.9n 0.20000 122070.0n 0.20000 122199.9n 0.20000 122200.0n 0.20000 122329.9n 0.20000 122330.0n 0.20000 122459.9n 0.20000 122460.0n 0.20000 122589.9n 0.20000 122590.0n 0.20000 122719.9n 0.20000 122720.0n 0.20000 122849.9n 0.20000 122850.0n 0.20000 122979.9n 0.20000 122980.0n 0.20000 123109.9n 0.20000 123110.0n 0.20000 123239.9n 0.20000 123240.0n 0.20000 123369.9n 0.20000 123370.0n 0.20000 123499.9n 0.20000 123500.0n 0.20000 123629.9n 0.20000 123630.0n 0.20000 123759.9n 0.20000 123760.0n 0.20000 123889.9n 0.20000 123890.0n 0.20000 124019.9n 0.20000 124020.0n 0.20000 124149.9n 0.20000 124150.0n 0.20000 124279.9n 0.20000 124280.0n 0.20000 124409.9n 0.20000 124410.0n 0.20000 124539.9n 0.20000 124540.0n 0.20000 124669.9n 0.20000 124670.0n 0.20000 124799.9n 0.20000 124800.0n 0.20000 124929.9n 0.20000 124930.0n 0.20000 125059.9n 0.20000 125060.0n 0.20000 125189.9n 0.20000 125190.0n 0.20000 125319.9n 0.20000 125320.0n 0.20000 125449.9n 0.20000 125450.0n 0.20000 125579.9n 0.20000 125580.0n 0.20000 125709.9n 0.20000 125710.0n 0.20000 125839.9n 0.20000 125840.0n 0.20000 125969.9n 0.20000 125970.0n 0.20000 126099.9n 0.20000 126100.0n 0.20000 126229.9n 0.20000 126230.0n 0.20000 126359.9n 0.20000 126360.0n 0.20000 126489.9n 0.20000 126490.0n 0.20000 126619.9n 0.20000 126620.0n 0.20000 126749.9n 0.20000 126750.0n 0.20000 126879.9n 0.20000 126880.0n 0.20000 127009.9n 0.20000 127010.0n 0.20000 127139.9n 0.20000 127140.0n 0.20000 127269.9n 0.20000 127270.0n 0.20000 127399.9n 0.20000 127400.0n 0.20000 127529.9n 0.20000 127530.0n 0.20000 127659.9n 0.20000 127660.0n 0.20000 127789.9n 0.20000 127790.0n 0.20000 127919.9n 0.20000 127920.0n 0.20000 128049.9n 0.20000 128050.0n 0.20000 128179.9n 0.20000 128180.0n 0.20000 128309.9n 0.20000 128310.0n 0.20000 128439.9n 0.20000 128440.0n 0.20000 128569.9n 0.20000 128570.0n 0.20000 128699.9n 0.20000 128700.0n 0.20000 128829.9n 0.20000 128830.0n 0.20000 128959.9n 0.20000 128960.0n 0.20000 129089.9n 0.20000 129090.0n 0.20000 129219.9n 0.20000 129220.0n 0.20000 129349.9n 0.20000 129350.0n 0.20000 129479.9n 0.20000 129480.0n 0.20000 129609.9n 0.20000 129610.0n 0.20000 129739.9n 0.20000 129740.0n 0.20000 129869.9n 0.20000 129870.0n 0.20000 129999.9n 0.20000 130000.0n 0.20000 130129.9n 0.20000 130130.0n 0.20000 130259.9n 0.20000 130260.0n 0.20000 130389.9n 0.20000 130390.0n 0.20000 130519.9n 0.20000 130520.0n 0.20000 130649.9n 0.20000 130650.0n 0.20000 130779.9n 0.20000 130780.0n 0.20000 130909.9n 0.20000 130910.0n 0.20000 131039.9n 0.20000 131040.0n 0.20000 131169.9n 0.20000 131170.0n 0.20000 131299.9n 0.20000 131300.0n 0.20000 131429.9n 0.20000 131430.0n 0.20000 131559.9n 0.20000 131560.0n 0.20000 131689.9n 0.20000 131690.0n 0.20000 131819.9n 0.20000 131820.0n 0.20000 131949.9n 0.20000 131950.0n 0.20000 132079.9n 0.20000 132080.0n 0.20000 132209.9n 0.20000 132210.0n 0.20000 132339.9n 0.20000 132340.0n 0.20000 132469.9n 0.20000 132470.0n 0.20000 132599.9n 0.20000 132600.0n 0.20000 132729.9n 0.20000 132730.0n 0.20000 132859.9n 0.20000 132860.0n 0.20000 132989.9n 0.20000 132990.0n 0.20000 133119.9n 0.20000 133120.0n 0.20000 133249.9n 0.20000 133250.0n 0.20000 133379.9n 0.20000 133380.0n 0.20000 133509.9n 0.20000 133510.0n 0.20000 133639.9n 0.20000 133640.0n 0.20000 133769.9n 0.20000 133770.0n 0.20000 133899.9n 0.20000 133900.0n 0.20000 134029.9n 0.20000 134030.0n 0.20000 134159.9n 0.20000 134160.0n 0.20000 134289.9n 0.20000 134290.0n 0.20000 134419.9n 0.20000 134420.0n 0.20000 134549.9n 0.20000 134550.0n 0.20000 134679.9n 0.20000 134680.0n 0.20000 134809.9n 0.20000 134810.0n 0.20000 134939.9n 0.20000 134940.0n 0.20000 135069.9n 0.20000 135070.0n 0.20000 135199.9n 0.20000 135200.0n 0.20000 135329.9n 0.20000 135330.0n 0.20000 135459.9n 0.20000 135460.0n 0.20000 135589.9n 0.20000 135590.0n 0.20000 135719.9n 0.20000 135720.0n 0.20000 135849.9n 0.20000 135850.0n 0.20000 135979.9n 0.20000 135980.0n 0.20000 136109.9n 0.20000 136110.0n 0.20000 136239.9n 0.20000 136240.0n 0.20000 136369.9n 0.20000 136370.0n 0.20000 136499.9n 0.20000 136500.0n 0.20000 136629.9n 0.20000 136630.0n 0.20000 136759.9n 0.20000 136760.0n 0.20000 136889.9n 0.20000 136890.0n 0.20000 137019.9n 0.20000 137020.0n 0.20000 137149.9n 0.20000 137150.0n 0.20000 137279.9n 0.20000 137280.0n 0.20000 137409.9n 0.20000 137410.0n 0.20000 137539.9n 0.20000 137540.0n 0.20000 137669.9n 0.20000 137670.0n 0.20000 137799.9n 0.20000 137800.0n 0.20000 137929.9n 0.20000 137930.0n 0.20000 138059.9n 0.20000 138060.0n 0.20000 138189.9n 0.20000 138190.0n 0.20000 138319.9n 0.20000 138320.0n 0.20000 138449.9n 0.20000 138450.0n 0.20000 138579.9n 0.20000 138580.0n 0.20000 138709.9n 0.20000 138710.0n 0.20000 138839.9n 0.20000 138840.0n 0.20000 138969.9n 0.20000 138970.0n 0.20000 139099.9n 0.20000 139100.0n 0.20000 139229.9n 0.20000 139230.0n 0.20000 139359.9n 0.20000 139360.0n 0.20000 139489.9n 0.20000 139490.0n 0.20000 139619.9n 0.20000 139620.0n 0.20000 139749.9n 0.20000 139750.0n 0.20000 139879.9n 0.20000 139880.0n 0.20000 140009.9n 0.20000 140010.0n 0.20000 140139.9n 0.20000 140140.0n 0.20000 140269.9n 0.20000 140270.0n 0.20000 140399.9n 0.20000 140400.0n 0.20000 140529.9n 0.20000 140530.0n 0.20000 140659.9n 0.20000 140660.0n 0.20000 140789.9n 0.20000 140790.0n 0.20000 140919.9n 0.20000 140920.0n 0.20000 141049.9n 0.20000 141050.0n 0.20000 141179.9n 0.20000 141180.0n 0.20000 141309.9n 0.20000 141310.0n 0.20000 141439.9n 0.20000 141440.0n 0.20000 141569.9n 0.20000 141570.0n 0.20000 141699.9n 0.20000 141700.0n 0.20000 141829.9n 0.20000 141830.0n 0.20000 141959.9n 0.20000 141960.0n 0.20000 142089.9n 0.20000 142090.0n 0.20000 142219.9n 0.20000 142220.0n 0.20000 142349.9n 0.20000 142350.0n 0.20000 142479.9n 0.20000 142480.0n 0.20000 142609.9n 0.20000 142610.0n 0.20000 142739.9n 0.20000 142740.0n 0.20000 142869.9n 0.20000 142870.0n 0.20000 142999.9n 0.20000 143000.0n 0.20000 143129.9n 0.20000 143130.0n 0.20000 143259.9n 0.20000 143260.0n 0.20000 143389.9n 0.20000 143390.0n 0.20000 143519.9n 0.20000 143520.0n 0.20000 143649.9n 0.20000 143650.0n 0.20000 143779.9n 0.20000 143780.0n 0.20000 143909.9n 0.20000 143910.0n 0.20000 144039.9n 0.20000 144040.0n 0.20000 144169.9n 0.20000 144170.0n 0.20000 144299.9n 0.20000 144300.0n 0.20000 144429.9n 0.20000 144430.0n 0.20000 144559.9n 0.20000 144560.0n 0.20000 144689.9n 0.20000 144690.0n 0.20000 144819.9n 0.20000 144820.0n 0.20000 144949.9n 0.20000 144950.0n 0.20000 145079.9n 0.20000 145080.0n 0.20000 145209.9n 0.20000 145210.0n 0.20000 145339.9n 0.20000 145340.0n 0.20000 145469.9n 0.20000 145470.0n 0.20000 145599.9n 0.20000 145600.0n 0.20000 145729.9n 0.20000 145730.0n 0.20000 145859.9n 0.20000 145860.0n 0.20000 145989.9n 0.20000 145990.0n 0.20000 146119.9n 0.20000 146120.0n 0.20000 146249.9n 0.20000 146250.0n 0.20000 146379.9n 0.20000 146380.0n 0.20000 146509.9n 0.20000 146510.0n 0.20000 146639.9n 0.20000 146640.0n 0.20000 146769.9n 0.20000 146770.0n 0.20000 146899.9n 0.20000 146900.0n 0.20000 147029.9n 0.20000 147030.0n 0.20000 147159.9n 0.20000 147160.0n 0.20000 147289.9n 0.20000 147290.0n 0.20000 147419.9n 0.20000 147420.0n 0.20000 147549.9n 0.20000 147550.0n 0.20000 147679.9n 0.20000 147680.0n 0.20000 147809.9n 0.20000 147810.0n 0.20000 147939.9n 0.20000 147940.0n 0.20000 148069.9n 0.20000 148070.0n 0.20000 148199.9n 0.20000 148200.0n 0.20000 148329.9n 0.20000 148330.0n 0.20000 148459.9n 0.20000 148460.0n 0.20000 148589.9n 0.20000 148590.0n 0.20000 148719.9n 0.20000 148720.0n 0.20000 148849.9n 0.20000 148850.0n 0.20000 148979.9n 0.20000 148980.0n 0.20000 149109.9n 0.20000 149110.0n 0.20000 149239.9n 0.20000 149240.0n 0.20000 149369.9n 0.20000 149370.0n 0.20000 149499.9n 0.20000 149500.0n 0.20000 149629.9n 0.20000 149630.0n 0.20000 149759.9n 0.20000 149760.0n 0.20000 149889.9n 0.20000 149890.0n 0.20000 150019.9n 0.20000 150020.0n 0.20000 150149.9n 0.20000 150150.0n 0.20000 150279.9n 0.20000 150280.0n 0.20000 150409.9n 0.20000 150410.0n 0.20000 150539.9n 0.20000 150540.0n 0.20000 150669.9n 0.20000 150670.0n 0.20000 150799.9n 0.20000 150800.0n 0.20000 150929.9n 0.20000 150930.0n 0.20000 151059.9n 0.20000 151060.0n 0.20000 151189.9n 0.20000 151190.0n 0.20000 151319.9n 0.20000 151320.0n 0.20000 151449.9n 0.20000 151450.0n 0.20000 151579.9n 0.20000 151580.0n 0.20000 151709.9n 0.20000 151710.0n 0.20000 151839.9n 0.20000 151840.0n 0.20000 151969.9n 0.20000 151970.0n 0.20000 152099.9n 0.20000 152100.0n 0.20000 152229.9n 0.20000 152230.0n 0.20000 152359.9n 0.20000 152360.0n 0.20000 152489.9n 0.20000 152490.0n 0.20000 152619.9n 0.20000 152620.0n 0.20000 152749.9n 0.20000 152750.0n 0.20000 152879.9n 0.20000 152880.0n 0.20000 153009.9n 0.20000 153010.0n 0.20000 153139.9n 0.20000 153140.0n 0.20000 153269.9n 0.20000 153270.0n 0.20000 153399.9n 0.20000 153400.0n 0.20000 153529.9n 0.20000 153530.0n 0.20000 153659.9n 0.20000 153660.0n 0.20000 153789.9n 0.20000 153790.0n 0.20000 153919.9n 0.20000 153920.0n 0.20000 154049.9n 0.20000 154050.0n 0.20000 154179.9n 0.20000 154180.0n 0.20000 154309.9n 0.20000 154310.0n 0.20000 154439.9n 0.20000 154440.0n 0.20000 154569.9n 0.20000 154570.0n 0.20000 154699.9n 0.20000 154700.0n 0.20000 154829.9n 0.20000 154830.0n 0.20000 154959.9n 0.20000 154960.0n 0.20000 155089.9n 0.20000 155090.0n 0.20000 155219.9n 0.20000 155220.0n 0.20000 155349.9n 0.20000 155350.0n 0.20000 155479.9n 0.20000 155480.0n 0.20000 155609.9n 0.20000 155610.0n 0.20000 155739.9n 0.20000 155740.0n 0.20000 155869.9n 0.20000 155870.0n 0.20000 155999.9n 0.20000 156000.0n 0.20000 156129.9n 0.20000 156130.0n 0.20000 156259.9n 0.20000 156260.0n 0.20000 156389.9n 0.20000 156390.0n 0.20000 156519.9n 0.20000 156520.0n 0.20000 156649.9n 0.20000 156650.0n 0.20000 156779.9n 0.20000 156780.0n 0.20000 156909.9n 0.20000 156910.0n 0.20000 157039.9n 0.20000 157040.0n 0.20000 157169.9n 0.20000 157170.0n 0.20000 157299.9n 0.20000 157300.0n 0.20000 157429.9n 0.20000 157430.0n 0.20000 157559.9n 0.20000 157560.0n 0.20000 157689.9n 0.20000 157690.0n 0.20000 157819.9n 0.20000 157820.0n 0.20000 157949.9n 0.20000 157950.0n 0.20000 158079.9n 0.20000 158080.0n 0.20000 158209.9n 0.20000 158210.0n 0.20000 158339.9n 0.20000 158340.0n 0.20000 158469.9n 0.20000 158470.0n 0.20000 158599.9n 0.20000 158600.0n 0.20000 158729.9n 0.20000 158730.0n 0.20000 158859.9n 0.20000 158860.0n 0.20000 158989.9n 0.20000 158990.0n 0.20000 159119.9n 0.20000 159120.0n 0.20000 159249.9n 0.20000 159250.0n 0.20000 159379.9n 0.20000 159380.0n 0.20000 159509.9n 0.20000 159510.0n 0.20000 159639.9n 0.20000 159640.0n 0.20000 159769.9n 0.20000 159770.0n 0.20000 159899.9n 0.20000 159900.0n 0.20000 160029.9n 0.20000 160030.0n 0.20000 160159.9n 0.20000 160160.0n 0.20000 160289.9n 0.20000 160290.0n 0.20000 160419.9n 0.20000 160420.0n 0.20000 160549.9n 0.20000 160550.0n 0.20000 160679.9n 0.20000 160680.0n 0.20000 160809.9n 0.20000 160810.0n 0.20000 160939.9n 0.20000 160940.0n 0.20000 161069.9n 0.20000 161070.0n 0.20000 161199.9n 0.20000 161200.0n 0.20000 161329.9n 0.20000 161330.0n 0.20000 161459.9n 0.20000 161460.0n 0.20000 161589.9n 0.20000 161590.0n 0.20000 161719.9n 0.20000 161720.0n 0.20000 161849.9n 0.20000 161850.0n 0.20000 161979.9n 0.20000 161980.0n 0.20000 162109.9n 0.20000 162110.0n 0.20000 162239.9n 0.20000 162240.0n 0.20000 162369.9n 0.20000 162370.0n 0.20000 162499.9n 0.20000 162500.0n 0.20000 162629.9n 0.20000 162630.0n 0.20000 162759.9n 0.20000 162760.0n 0.20000 162889.9n 0.20000 162890.0n 0.20000 163019.9n 0.20000 163020.0n 0.20000 163149.9n 0.20000 163150.0n 0.20000 163279.9n 0.20000 163280.0n 0.20000 163409.9n 0.20000 163410.0n 0.20000 163539.9n 0.20000 163540.0n 0.20000 163669.9n 0.20000 163670.0n 0.20000 163799.9n 0.20000 163800.0n 0.20000 163929.9n 0.20000 163930.0n 0.20000 164059.9n 0.20000 164060.0n 0.20000 164189.9n 0.20000 164190.0n 0.20000 164319.9n 0.20000 164320.0n 0.20000 164449.9n 0.20000 164450.0n 0.20000 164579.9n 0.20000 164580.0n 0.20000 164709.9n 0.20000 164710.0n 0.20000 164839.9n 0.20000 164840.0n 0.20000 164969.9n 0.20000 164970.0n 0.20000 165099.9n 0.20000 165100.0n 0.20000 165229.9n 0.20000 165230.0n 0.20000 165359.9n 0.20000 165360.0n 0.20000 165489.9n 0.20000 165490.0n 0.20000 165619.9n 0.20000 165620.0n 0.20000 165749.9n 0.20000 165750.0n 0.20000 165879.9n 0.20000 165880.0n 0.20000 166009.9n 0.20000 166010.0n 0.20000 166139.9n 0.20000 166140.0n 0.20000 166269.9n 0.20000 166270.0n 0.20000 166399.9n 0.20000 166400.0n 0.20000 166529.9n 0.20000 166530.0n 0.20000 166659.9n 0.20000 166660.0n 0.20000 166789.9n 0.20000 166790.0n 0.20000 166919.9n 0.20000 166920.0n 0.20000 167049.9n 0.20000 167050.0n 0.20000 167179.9n 0.20000 167180.0n 0.20000 167309.9n 0.20000 167310.0n 0.20000 167439.9n 0.20000 167440.0n 0.20000 167569.9n 0.20000 167570.0n 0.20000 167699.9n 0.20000 167700.0n 0.20000 167829.9n 0.20000 167830.0n 0.20000 167959.9n 0.20000 167960.0n 0.20000 168089.9n 0.20000 168090.0n 0.20000 168219.9n 0.20000 168220.0n 0.20000 168349.9n 0.20000 168350.0n 0.20000)
Vxop0 xop0 0 PWL(0.0n 0.25000 129.9n 0.25000 130.0n 0.31000 259.9n 0.31000 260.0n 0.31000 389.9n 0.31000 390.0n 0.31000 519.9n 0.31000 520.0n 0.31000 649.9n 0.31000 650.0n 0.31000 779.9n 0.31000 780.0n 0.25000 909.9n 0.25000 910.0n 0.25000 1039.9n 0.25000 1040.0n 0.25000 1169.9n 0.25000 1170.0n 0.25000 1299.9n 0.25000 1300.0n 0.25000 1429.9n 0.25000 1430.0n 0.31000 1559.9n 0.31000 1560.0n 0.31000 1689.9n 0.31000 1690.0n 0.31000 1819.9n 0.31000 1820.0n 0.25000 1949.9n 0.25000 1950.0n 0.31000 2079.9n 0.31000 2080.0n 0.31000 2209.9n 0.31000 2210.0n 0.25000 2339.9n 0.25000 2340.0n 0.31000 2469.9n 0.31000 2470.0n 0.25000 2599.9n 0.25000 2600.0n 0.25000 2729.9n 0.25000 2730.0n 0.31000 2859.9n 0.31000 2860.0n 0.25000 2989.9n 0.25000 2990.0n 0.25000 3119.9n 0.25000 3120.0n 0.31000 3249.9n 0.31000 3250.0n 0.31000 3379.9n 0.31000 3380.0n 0.25000 3509.9n 0.25000 3510.0n 0.25000 3639.9n 0.25000 3640.0n 0.31000 3769.9n 0.31000 3770.0n 0.25000 3899.9n 0.25000 3900.0n 0.25000 4029.9n 0.25000 4030.0n 0.25000 4159.9n 0.25000 4160.0n 0.31000 4289.9n 0.31000 4290.0n 0.25000 4419.9n 0.25000 4420.0n 0.25000 4549.9n 0.25000 4550.0n 0.25000 4679.9n 0.25000 4680.0n 0.25000 4809.9n 0.25000 4810.0n 0.31000 4939.9n 0.31000 4940.0n 0.31000 5069.9n 0.31000 5070.0n 0.31000 5199.9n 0.31000 5200.0n 0.31000 5329.9n 0.31000 5330.0n 0.31000 5459.9n 0.31000 5460.0n 0.31000 5589.9n 0.31000 5590.0n 0.31000 5719.9n 0.31000 5720.0n 0.25000 5849.9n 0.25000 5850.0n 0.25000 5979.9n 0.25000 5980.0n 0.25000 6109.9n 0.25000 6110.0n 0.25000 6239.9n 0.25000 6240.0n 0.25000 6369.9n 0.25000 6370.0n 0.31000 6499.9n 0.31000 6500.0n 0.31000 6629.9n 0.31000 6630.0n 0.31000 6759.9n 0.31000 6760.0n 0.31000 6889.9n 0.31000 6890.0n 0.25000 7019.9n 0.25000 7020.0n 0.31000 7149.9n 0.31000 7150.0n 0.25000 7279.9n 0.25000 7280.0n 0.31000 7409.9n 0.31000 7410.0n 0.31000 7539.9n 0.31000 7540.0n 0.25000 7669.9n 0.25000 7670.0n 0.31000 7799.9n 0.31000 7800.0n 0.31000 7929.9n 0.31000 7930.0n 0.25000 8059.9n 0.25000 8060.0n 0.25000 8189.9n 0.25000 8190.0n 0.31000 8319.9n 0.31000 8320.0n 0.25000 8449.9n 0.25000 8450.0n 0.25000 8579.9n 0.25000 8580.0n 0.31000 8709.9n 0.31000 8710.0n 0.25000 8839.9n 0.25000 8840.0n 0.31000 8969.9n 0.31000 8970.0n 0.25000 9099.9n 0.25000 9100.0n 0.25000 9229.9n 0.25000 9230.0n 0.31000 9359.9n 0.31000 9360.0n 0.31000 9489.9n 0.31000 9490.0n 0.25000 9619.9n 0.25000 9620.0n 0.31000 9749.9n 0.31000 9750.0n 0.25000 9879.9n 0.25000 9880.0n 0.31000 10009.9n 0.31000 10010.0n 0.31000 10139.9n 0.31000 10140.0n 0.31000 10269.9n 0.31000 10270.0n 0.25000 10399.9n 0.25000 10400.0n 0.25000 10529.9n 0.25000 10530.0n 0.25000 10659.9n 0.25000 10660.0n 0.25000 10789.9n 0.25000 10790.0n 0.31000 10919.9n 0.31000 10920.0n 0.25000 11049.9n 0.25000 11050.0n 0.31000 11179.9n 0.31000 11180.0n 0.31000 11309.9n 0.31000 11310.0n 0.25000 11439.9n 0.25000 11440.0n 0.25000 11569.9n 0.25000 11570.0n 0.31000 11699.9n 0.31000 11700.0n 0.25000 11829.9n 0.25000 11830.0n 0.25000 11959.9n 0.25000 11960.0n 0.31000 12089.9n 0.31000 12090.0n 0.25000 12219.9n 0.25000 12220.0n 0.25000 12349.9n 0.25000 12350.0n 0.31000 12479.9n 0.31000 12480.0n 0.25000 12609.9n 0.25000 12610.0n 0.25000 12739.9n 0.25000 12740.0n 0.25000 12869.9n 0.25000 12870.0n 0.25000 12999.9n 0.25000 13000.0n 0.31000 13129.9n 0.31000 13130.0n 0.31000 13259.9n 0.31000 13260.0n 0.31000 13389.9n 0.31000 13390.0n 0.25000 13519.9n 0.25000 13520.0n 0.31000 13649.9n 0.31000 13650.0n 0.31000 13779.9n 0.31000 13780.0n 0.31000 13909.9n 0.31000 13910.0n 0.31000 14039.9n 0.31000 14040.0n 0.25000 14169.9n 0.25000 14170.0n 0.31000 14299.9n 0.31000 14300.0n 0.25000 14429.9n 0.25000 14430.0n 0.31000 14559.9n 0.31000 14560.0n 0.25000 14689.9n 0.25000 14690.0n 0.31000 14819.9n 0.31000 14820.0n 0.25000 14949.9n 0.25000 14950.0n 0.25000 15079.9n 0.25000 15080.0n 0.31000 15209.9n 0.31000 15210.0n 0.25000 15339.9n 0.25000 15340.0n 0.31000 15469.9n 0.31000 15470.0n 0.31000 15599.9n 0.31000 15600.0n 0.31000 15729.9n 0.31000 15730.0n 0.25000 15859.9n 0.25000 15860.0n 0.25000 15989.9n 0.25000 15990.0n 0.31000 16119.9n 0.31000 16120.0n 0.31000 16249.9n 0.31000 16250.0n 0.25000 16379.9n 0.25000 16380.0n 0.25000 16509.9n 0.25000 16510.0n 0.31000 16639.9n 0.31000 16640.0n 0.25000 16769.9n 0.25000 16770.0n 0.31000 16899.9n 0.31000 16900.0n 0.25000 17029.9n 0.25000 17030.0n 0.31000 17159.9n 0.31000 17160.0n 0.31000 17289.9n 0.31000 17290.0n 0.25000 17419.9n 0.25000 17420.0n 0.31000 17549.9n 0.31000 17550.0n 0.25000 17679.9n 0.25000 17680.0n 0.25000 17809.9n 0.25000 17810.0n 0.25000 17939.9n 0.25000 17940.0n 0.31000 18069.9n 0.31000 18070.0n 0.31000 18199.9n 0.31000 18200.0n 0.25000 18329.9n 0.25000 18330.0n 0.25000 18459.9n 0.25000 18460.0n 0.31000 18589.9n 0.31000 18590.0n 0.31000 18719.9n 0.31000 18720.0n 0.31000 18849.9n 0.31000 18850.0n 0.31000 18979.9n 0.31000 18980.0n 0.31000 19109.9n 0.31000 19110.0n 0.25000 19239.9n 0.25000 19240.0n 0.25000 19369.9n 0.25000 19370.0n 0.25000 19499.9n 0.25000 19500.0n 0.25000 19629.9n 0.25000 19630.0n 0.31000 19759.9n 0.31000 19760.0n 0.25000 19889.9n 0.25000 19890.0n 0.31000 20019.9n 0.31000 20020.0n 0.25000 20149.9n 0.25000 20150.0n 0.31000 20279.9n 0.31000 20280.0n 0.25000 20409.9n 0.25000 20410.0n 0.31000 20539.9n 0.31000 20540.0n 0.31000 20669.9n 0.31000 20670.0n 0.31000 20799.9n 0.31000 20800.0n 0.25000 20929.9n 0.25000 20930.0n 0.25000 21059.9n 0.25000 21060.0n 0.31000 21189.9n 0.31000 21190.0n 0.25000 21319.9n 0.25000 21320.0n 0.31000 21449.9n 0.31000 21450.0n 0.25000 21579.9n 0.25000 21580.0n 0.25000 21709.9n 0.25000 21710.0n 0.31000 21839.9n 0.31000 21840.0n 0.28000 21969.9n 0.28000 21970.0n 0.28000 22099.9n 0.28000 22100.0n 0.28000 22229.9n 0.28000 22230.0n 0.28000 22359.9n 0.28000 22360.0n 0.28000 22489.9n 0.28000 22490.0n 0.28000 22619.9n 0.28000 22620.0n 0.28000 22749.9n 0.28000 22750.0n 0.28000 22879.9n 0.28000 22880.0n 0.28000 23009.9n 0.28000 23010.0n 0.28000 23139.9n 0.28000 23140.0n 0.28000 23269.9n 0.28000 23270.0n 0.28000 23399.9n 0.28000 23400.0n 0.28000 23529.9n 0.28000 23530.0n 0.28000 23659.9n 0.28000 23660.0n 0.28000 23789.9n 0.28000 23790.0n 0.28000 23919.9n 0.28000 23920.0n 0.28000 24049.9n 0.28000 24050.0n 0.28000 24179.9n 0.28000 24180.0n 0.28000 24309.9n 0.28000 24310.0n 0.28000 24439.9n 0.28000 24440.0n 0.28000 24569.9n 0.28000 24570.0n 0.28000 24699.9n 0.28000 24700.0n 0.28000 24829.9n 0.28000 24830.0n 0.28000 24959.9n 0.28000 24960.0n 0.28000 25089.9n 0.28000 25090.0n 0.28000 25219.9n 0.28000 25220.0n 0.28000 25349.9n 0.28000 25350.0n 0.28000 25479.9n 0.28000 25480.0n 0.28000 25609.9n 0.28000 25610.0n 0.28000 25739.9n 0.28000 25740.0n 0.28000 25869.9n 0.28000 25870.0n 0.28000 25999.9n 0.28000 26000.0n 0.28000 26129.9n 0.28000 26130.0n 0.28000 26259.9n 0.28000 26260.0n 0.28000 26389.9n 0.28000 26390.0n 0.28000 26519.9n 0.28000 26520.0n 0.28000 26649.9n 0.28000 26650.0n 0.28000 26779.9n 0.28000 26780.0n 0.28000 26909.9n 0.28000 26910.0n 0.28000 27039.9n 0.28000 27040.0n 0.28000 27169.9n 0.28000 27170.0n 0.28000 27299.9n 0.28000 27300.0n 0.28000 27429.9n 0.28000 27430.0n 0.28000 27559.9n 0.28000 27560.0n 0.28000 27689.9n 0.28000 27690.0n 0.28000 27819.9n 0.28000 27820.0n 0.28000 27949.9n 0.28000 27950.0n 0.28000 28079.9n 0.28000 28080.0n 0.31000 28209.9n 0.31000 28210.0n 0.31000 28339.9n 0.31000 28340.0n 0.25000 28469.9n 0.25000 28470.0n 0.25000 28599.9n 0.25000 28600.0n 0.25000 28729.9n 0.25000 28730.0n 0.31000 28859.9n 0.31000 28860.0n 0.25000 28989.9n 0.25000 28990.0n 0.25000 29119.9n 0.25000 29120.0n 0.31000 29249.9n 0.31000 29250.0n 0.25000 29379.9n 0.25000 29380.0n 0.25000 29509.9n 0.25000 29510.0n 0.31000 29639.9n 0.31000 29640.0n 0.25000 29769.9n 0.25000 29770.0n 0.25000 29899.9n 0.25000 29900.0n 0.31000 30029.9n 0.31000 30030.0n 0.25000 30159.9n 0.25000 30160.0n 0.25000 30289.9n 0.25000 30290.0n 0.25000 30419.9n 0.25000 30420.0n 0.25000 30549.9n 0.25000 30550.0n 0.31000 30679.9n 0.31000 30680.0n 0.31000 30809.9n 0.31000 30810.0n 0.31000 30939.9n 0.31000 30940.0n 0.31000 31069.9n 0.31000 31070.0n 0.31000 31199.9n 0.31000 31200.0n 0.31000 31329.9n 0.31000 31330.0n 0.25000 31459.9n 0.25000 31460.0n 0.31000 31589.9n 0.31000 31590.0n 0.31000 31719.9n 0.31000 31720.0n 0.25000 31849.9n 0.25000 31850.0n 0.31000 31979.9n 0.31000 31980.0n 0.31000 32109.9n 0.31000 32110.0n 0.31000 32239.9n 0.31000 32240.0n 0.31000 32369.9n 0.31000 32370.0n 0.31000 32499.9n 0.31000 32500.0n 0.25000 32629.9n 0.25000 32630.0n 0.25000 32759.9n 0.25000 32760.0n 0.25000 32889.9n 0.25000 32890.0n 0.31000 33019.9n 0.31000 33020.0n 0.25000 33149.9n 0.25000 33150.0n 0.25000 33279.9n 0.25000 33280.0n 0.25000 33409.9n 0.25000 33410.0n 0.25000 33539.9n 0.25000 33540.0n 0.31000 33669.9n 0.31000 33670.0n 0.25000 33799.9n 0.25000 33800.0n 0.31000 33929.9n 0.31000 33930.0n 0.25000 34059.9n 0.25000 34060.0n 0.31000 34189.9n 0.31000 34190.0n 0.31000 34319.9n 0.31000 34320.0n 0.31000 34449.9n 0.31000 34450.0n 0.25000 34579.9n 0.25000 34580.0n 0.31000 34709.9n 0.31000 34710.0n 0.31000 34839.9n 0.31000 34840.0n 0.25000 34969.9n 0.25000 34970.0n 0.25000 35099.9n 0.25000 35100.0n 0.25000 35229.9n 0.25000 35230.0n 0.31000 35359.9n 0.31000 35360.0n 0.25000 35489.9n 0.25000 35490.0n 0.31000 35619.9n 0.31000 35620.0n 0.25000 35749.9n 0.25000 35750.0n 0.25000 35879.9n 0.25000 35880.0n 0.31000 36009.9n 0.31000 36010.0n 0.25000 36139.9n 0.25000 36140.0n 0.25000 36269.9n 0.25000 36270.0n 0.31000 36399.9n 0.31000 36400.0n 0.31000 36529.9n 0.31000 36530.0n 0.31000 36659.9n 0.31000 36660.0n 0.25000 36789.9n 0.25000 36790.0n 0.25000 36919.9n 0.25000 36920.0n 0.25000 37049.9n 0.25000 37050.0n 0.25000 37179.9n 0.25000 37180.0n 0.25000 37309.9n 0.25000 37310.0n 0.25000 37439.9n 0.25000 37440.0n 0.31000 37569.9n 0.31000 37570.0n 0.31000 37699.9n 0.31000 37700.0n 0.31000 37829.9n 0.31000 37830.0n 0.31000 37959.9n 0.31000 37960.0n 0.31000 38089.9n 0.31000 38090.0n 0.31000 38219.9n 0.31000 38220.0n 0.31000 38349.9n 0.31000 38350.0n 0.25000 38479.9n 0.25000 38480.0n 0.25000 38609.9n 0.25000 38610.0n 0.31000 38739.9n 0.31000 38740.0n 0.25000 38869.9n 0.25000 38870.0n 0.31000 38999.9n 0.31000 39000.0n 0.25000 39129.9n 0.25000 39130.0n 0.31000 39259.9n 0.31000 39260.0n 0.31000 39389.9n 0.31000 39390.0n 0.31000 39519.9n 0.31000 39520.0n 0.25000 39649.9n 0.25000 39650.0n 0.31000 39779.9n 0.31000 39780.0n 0.25000 39909.9n 0.25000 39910.0n 0.25000 40039.9n 0.25000 40040.0n 0.25000 40169.9n 0.25000 40170.0n 0.31000 40299.9n 0.31000 40300.0n 0.31000 40429.9n 0.31000 40430.0n 0.31000 40559.9n 0.31000 40560.0n 0.25000 40689.9n 0.25000 40690.0n 0.25000 40819.9n 0.25000 40820.0n 0.31000 40949.9n 0.31000 40950.0n 0.25000 41079.9n 0.25000 41080.0n 0.25000 41209.9n 0.25000 41210.0n 0.25000 41339.9n 0.25000 41340.0n 0.31000 41469.9n 0.31000 41470.0n 0.31000 41599.9n 0.31000 41600.0n 0.25000 41729.9n 0.25000 41730.0n 0.25000 41859.9n 0.25000 41860.0n 0.25000 41989.9n 0.25000 41990.0n 0.31000 42119.9n 0.31000 42120.0n 0.31000 42249.9n 0.31000 42250.0n 0.31000 42379.9n 0.31000 42380.0n 0.31000 42509.9n 0.31000 42510.0n 0.25000 42639.9n 0.25000 42640.0n 0.25000 42769.9n 0.25000 42770.0n 0.31000 42899.9n 0.31000 42900.0n 0.31000 43029.9n 0.31000 43030.0n 0.25000 43159.9n 0.25000 43160.0n 0.31000 43289.9n 0.31000 43290.0n 0.25000 43419.9n 0.25000 43420.0n 0.25000 43549.9n 0.25000 43550.0n 0.25000 43679.9n 0.25000 43680.0n 0.25000 43809.9n 0.25000 43810.0n 0.25000 43939.9n 0.25000 43940.0n 0.31000 44069.9n 0.31000 44070.0n 0.25000 44199.9n 0.25000 44200.0n 0.25000 44329.9n 0.25000 44330.0n 0.31000 44459.9n 0.31000 44460.0n 0.31000 44589.9n 0.31000 44590.0n 0.31000 44719.9n 0.31000 44720.0n 0.31000 44849.9n 0.31000 44850.0n 0.25000 44979.9n 0.25000 44980.0n 0.31000 45109.9n 0.31000 45110.0n 0.25000 45239.9n 0.25000 45240.0n 0.31000 45369.9n 0.31000 45370.0n 0.31000 45499.9n 0.31000 45500.0n 0.31000 45629.9n 0.31000 45630.0n 0.31000 45759.9n 0.31000 45760.0n 0.31000 45889.9n 0.31000 45890.0n 0.25000 46019.9n 0.25000 46020.0n 0.25000 46149.9n 0.25000 46150.0n 0.25000 46279.9n 0.25000 46280.0n 0.25000 46409.9n 0.25000 46410.0n 0.31000 46539.9n 0.31000 46540.0n 0.31000 46669.9n 0.31000 46670.0n 0.25000 46799.9n 0.25000 46800.0n 0.31000 46929.9n 0.31000 46930.0n 0.25000 47059.9n 0.25000 47060.0n 0.25000 47189.9n 0.25000 47190.0n 0.31000 47319.9n 0.31000 47320.0n 0.31000 47449.9n 0.31000 47450.0n 0.31000 47579.9n 0.31000 47580.0n 0.31000 47709.9n 0.31000 47710.0n 0.31000 47839.9n 0.31000 47840.0n 0.31000 47969.9n 0.31000 47970.0n 0.25000 48099.9n 0.25000 48100.0n 0.31000 48229.9n 0.31000 48230.0n 0.25000 48359.9n 0.25000 48360.0n 0.31000 48489.9n 0.31000 48490.0n 0.25000 48619.9n 0.25000 48620.0n 0.25000 48749.9n 0.25000 48750.0n 0.25000 48879.9n 0.25000 48880.0n 0.25000 49009.9n 0.25000 49010.0n 0.25000 49139.9n 0.25000 49140.0n 0.31000 49269.9n 0.31000 49270.0n 0.25000 49399.9n 0.25000 49400.0n 0.31000 49529.9n 0.31000 49530.0n 0.25000 49659.9n 0.25000 49660.0n 0.31000 49789.9n 0.31000 49790.0n 0.25000 49919.9n 0.25000 49920.0n 0.28000 50049.9n 0.28000 50050.0n 0.28000 50179.9n 0.28000 50180.0n 0.28000 50309.9n 0.28000 50310.0n 0.28000 50439.9n 0.28000 50440.0n 0.28000 50569.9n 0.28000 50570.0n 0.28000 50699.9n 0.28000 50700.0n 0.28000 50829.9n 0.28000 50830.0n 0.28000 50959.9n 0.28000 50960.0n 0.28000 51089.9n 0.28000 51090.0n 0.28000 51219.9n 0.28000 51220.0n 0.28000 51349.9n 0.28000 51350.0n 0.28000 51479.9n 0.28000 51480.0n 0.28000 51609.9n 0.28000 51610.0n 0.28000 51739.9n 0.28000 51740.0n 0.28000 51869.9n 0.28000 51870.0n 0.28000 51999.9n 0.28000 52000.0n 0.28000 52129.9n 0.28000 52130.0n 0.28000 52259.9n 0.28000 52260.0n 0.28000 52389.9n 0.28000 52390.0n 0.28000 52519.9n 0.28000 52520.0n 0.28000 52649.9n 0.28000 52650.0n 0.28000 52779.9n 0.28000 52780.0n 0.28000 52909.9n 0.28000 52910.0n 0.28000 53039.9n 0.28000 53040.0n 0.28000 53169.9n 0.28000 53170.0n 0.28000 53299.9n 0.28000 53300.0n 0.28000 53429.9n 0.28000 53430.0n 0.28000 53559.9n 0.28000 53560.0n 0.28000 53689.9n 0.28000 53690.0n 0.28000 53819.9n 0.28000 53820.0n 0.28000 53949.9n 0.28000 53950.0n 0.28000 54079.9n 0.28000 54080.0n 0.28000 54209.9n 0.28000 54210.0n 0.28000 54339.9n 0.28000 54340.0n 0.28000 54469.9n 0.28000 54470.0n 0.28000 54599.9n 0.28000 54600.0n 0.28000 54729.9n 0.28000 54730.0n 0.28000 54859.9n 0.28000 54860.0n 0.28000 54989.9n 0.28000 54990.0n 0.28000 55119.9n 0.28000 55120.0n 0.28000 55249.9n 0.28000 55250.0n 0.28000 55379.9n 0.28000 55380.0n 0.28000 55509.9n 0.28000 55510.0n 0.28000 55639.9n 0.28000 55640.0n 0.28000 55769.9n 0.28000 55770.0n 0.28000 55899.9n 0.28000 55900.0n 0.28000 56029.9n 0.28000 56030.0n 0.28000 56159.9n 0.28000 56160.0n 0.31000 56289.9n 0.31000 56290.0n 0.31000 56419.9n 0.31000 56420.0n 0.25000 56549.9n 0.25000 56550.0n 0.25000 56679.9n 0.25000 56680.0n 0.25000 56809.9n 0.25000 56810.0n 0.31000 56939.9n 0.31000 56940.0n 0.31000 57069.9n 0.31000 57070.0n 0.25000 57199.9n 0.25000 57200.0n 0.25000 57329.9n 0.25000 57330.0n 0.25000 57459.9n 0.25000 57460.0n 0.31000 57589.9n 0.31000 57590.0n 0.31000 57719.9n 0.31000 57720.0n 0.31000 57849.9n 0.31000 57850.0n 0.25000 57979.9n 0.25000 57980.0n 0.31000 58109.9n 0.31000 58110.0n 0.31000 58239.9n 0.31000 58240.0n 0.31000 58369.9n 0.31000 58370.0n 0.25000 58499.9n 0.25000 58500.0n 0.31000 58629.9n 0.31000 58630.0n 0.25000 58759.9n 0.25000 58760.0n 0.25000 58889.9n 0.25000 58890.0n 0.25000 59019.9n 0.25000 59020.0n 0.25000 59149.9n 0.25000 59150.0n 0.25000 59279.9n 0.25000 59280.0n 0.31000 59409.9n 0.31000 59410.0n 0.31000 59539.9n 0.31000 59540.0n 0.31000 59669.9n 0.31000 59670.0n 0.25000 59799.9n 0.25000 59800.0n 0.25000 59929.9n 0.25000 59930.0n 0.31000 60059.9n 0.31000 60060.0n 0.25000 60189.9n 0.25000 60190.0n 0.31000 60319.9n 0.31000 60320.0n 0.31000 60449.9n 0.31000 60450.0n 0.31000 60579.9n 0.31000 60580.0n 0.31000 60709.9n 0.31000 60710.0n 0.25000 60839.9n 0.25000 60840.0n 0.31000 60969.9n 0.31000 60970.0n 0.31000 61099.9n 0.31000 61100.0n 0.31000 61229.9n 0.31000 61230.0n 0.25000 61359.9n 0.25000 61360.0n 0.25000 61489.9n 0.25000 61490.0n 0.31000 61619.9n 0.31000 61620.0n 0.31000 61749.9n 0.31000 61750.0n 0.25000 61879.9n 0.25000 61880.0n 0.31000 62009.9n 0.31000 62010.0n 0.31000 62139.9n 0.31000 62140.0n 0.31000 62269.9n 0.31000 62270.0n 0.25000 62399.9n 0.25000 62400.0n 0.25000 62529.9n 0.25000 62530.0n 0.25000 62659.9n 0.25000 62660.0n 0.25000 62789.9n 0.25000 62790.0n 0.25000 62919.9n 0.25000 62920.0n 0.25000 63049.9n 0.25000 63050.0n 0.25000 63179.9n 0.25000 63180.0n 0.25000 63309.9n 0.25000 63310.0n 0.31000 63439.9n 0.31000 63440.0n 0.25000 63569.9n 0.25000 63570.0n 0.31000 63699.9n 0.31000 63700.0n 0.25000 63829.9n 0.25000 63830.0n 0.25000 63959.9n 0.25000 63960.0n 0.25000 64089.9n 0.25000 64090.0n 0.31000 64219.9n 0.31000 64220.0n 0.25000 64349.9n 0.25000 64350.0n 0.31000 64479.9n 0.31000 64480.0n 0.25000 64609.9n 0.25000 64610.0n 0.31000 64739.9n 0.31000 64740.0n 0.25000 64869.9n 0.25000 64870.0n 0.25000 64999.9n 0.25000 65000.0n 0.25000 65129.9n 0.25000 65130.0n 0.31000 65259.9n 0.31000 65260.0n 0.25000 65389.9n 0.25000 65390.0n 0.25000 65519.9n 0.25000 65520.0n 0.31000 65649.9n 0.31000 65650.0n 0.31000 65779.9n 0.31000 65780.0n 0.31000 65909.9n 0.31000 65910.0n 0.31000 66039.9n 0.31000 66040.0n 0.31000 66169.9n 0.31000 66170.0n 0.31000 66299.9n 0.31000 66300.0n 0.31000 66429.9n 0.31000 66430.0n 0.31000 66559.9n 0.31000 66560.0n 0.25000 66689.9n 0.25000 66690.0n 0.31000 66819.9n 0.31000 66820.0n 0.25000 66949.9n 0.25000 66950.0n 0.25000 67079.9n 0.25000 67080.0n 0.31000 67209.9n 0.31000 67210.0n 0.25000 67339.9n 0.25000 67340.0n 0.25000 67469.9n 0.25000 67470.0n 0.25000 67599.9n 0.25000 67600.0n 0.31000 67729.9n 0.31000 67730.0n 0.31000 67859.9n 0.31000 67860.0n 0.25000 67989.9n 0.25000 67990.0n 0.25000 68119.9n 0.25000 68120.0n 0.31000 68249.9n 0.31000 68250.0n 0.31000 68379.9n 0.31000 68380.0n 0.31000 68509.9n 0.31000 68510.0n 0.25000 68639.9n 0.25000 68640.0n 0.31000 68769.9n 0.31000 68770.0n 0.31000 68899.9n 0.31000 68900.0n 0.25000 69029.9n 0.25000 69030.0n 0.25000 69159.9n 0.25000 69160.0n 0.31000 69289.9n 0.31000 69290.0n 0.25000 69419.9n 0.25000 69420.0n 0.25000 69549.9n 0.25000 69550.0n 0.25000 69679.9n 0.25000 69680.0n 0.31000 69809.9n 0.31000 69810.0n 0.31000 69939.9n 0.31000 69940.0n 0.31000 70069.9n 0.31000 70070.0n 0.25000 70199.9n 0.25000 70200.0n 0.25000 70329.9n 0.25000 70330.0n 0.31000 70459.9n 0.31000 70460.0n 0.25000 70589.9n 0.25000 70590.0n 0.31000 70719.9n 0.31000 70720.0n 0.25000 70849.9n 0.25000 70850.0n 0.31000 70979.9n 0.31000 70980.0n 0.25000 71109.9n 0.25000 71110.0n 0.31000 71239.9n 0.31000 71240.0n 0.25000 71369.9n 0.25000 71370.0n 0.31000 71499.9n 0.31000 71500.0n 0.25000 71629.9n 0.25000 71630.0n 0.25000 71759.9n 0.25000 71760.0n 0.31000 71889.9n 0.31000 71890.0n 0.31000 72019.9n 0.31000 72020.0n 0.31000 72149.9n 0.31000 72150.0n 0.25000 72279.9n 0.25000 72280.0n 0.31000 72409.9n 0.31000 72410.0n 0.25000 72539.9n 0.25000 72540.0n 0.25000 72669.9n 0.25000 72670.0n 0.25000 72799.9n 0.25000 72800.0n 0.25000 72929.9n 0.25000 72930.0n 0.31000 73059.9n 0.31000 73060.0n 0.31000 73189.9n 0.31000 73190.0n 0.31000 73319.9n 0.31000 73320.0n 0.31000 73449.9n 0.31000 73450.0n 0.25000 73579.9n 0.25000 73580.0n 0.25000 73709.9n 0.25000 73710.0n 0.31000 73839.9n 0.31000 73840.0n 0.25000 73969.9n 0.25000 73970.0n 0.25000 74099.9n 0.25000 74100.0n 0.31000 74229.9n 0.31000 74230.0n 0.31000 74359.9n 0.31000 74360.0n 0.25000 74489.9n 0.25000 74490.0n 0.25000 74619.9n 0.25000 74620.0n 0.25000 74749.9n 0.25000 74750.0n 0.31000 74879.9n 0.31000 74880.0n 0.31000 75009.9n 0.31000 75010.0n 0.31000 75139.9n 0.31000 75140.0n 0.25000 75269.9n 0.25000 75270.0n 0.25000 75399.9n 0.25000 75400.0n 0.31000 75529.9n 0.31000 75530.0n 0.31000 75659.9n 0.31000 75660.0n 0.25000 75789.9n 0.25000 75790.0n 0.31000 75919.9n 0.31000 75920.0n 0.31000 76049.9n 0.31000 76050.0n 0.31000 76179.9n 0.31000 76180.0n 0.25000 76309.9n 0.25000 76310.0n 0.25000 76439.9n 0.25000 76440.0n 0.31000 76569.9n 0.31000 76570.0n 0.25000 76699.9n 0.25000 76700.0n 0.31000 76829.9n 0.31000 76830.0n 0.25000 76959.9n 0.25000 76960.0n 0.25000 77089.9n 0.25000 77090.0n 0.31000 77219.9n 0.31000 77220.0n 0.31000 77349.9n 0.31000 77350.0n 0.31000 77479.9n 0.31000 77480.0n 0.25000 77609.9n 0.25000 77610.0n 0.25000 77739.9n 0.25000 77740.0n 0.31000 77869.9n 0.31000 77870.0n 0.25000 77999.9n 0.25000 78000.0n 0.28000 78129.9n 0.28000 78130.0n 0.28000 78259.9n 0.28000 78260.0n 0.28000 78389.9n 0.28000 78390.0n 0.28000 78519.9n 0.28000 78520.0n 0.28000 78649.9n 0.28000 78650.0n 0.28000 78779.9n 0.28000 78780.0n 0.28000 78909.9n 0.28000 78910.0n 0.28000 79039.9n 0.28000 79040.0n 0.28000 79169.9n 0.28000 79170.0n 0.28000 79299.9n 0.28000 79300.0n 0.28000 79429.9n 0.28000 79430.0n 0.28000 79559.9n 0.28000 79560.0n 0.28000 79689.9n 0.28000 79690.0n 0.28000 79819.9n 0.28000 79820.0n 0.28000 79949.9n 0.28000 79950.0n 0.28000 80079.9n 0.28000 80080.0n 0.28000 80209.9n 0.28000 80210.0n 0.28000 80339.9n 0.28000 80340.0n 0.28000 80469.9n 0.28000 80470.0n 0.28000 80599.9n 0.28000 80600.0n 0.28000 80729.9n 0.28000 80730.0n 0.28000 80859.9n 0.28000 80860.0n 0.28000 80989.9n 0.28000 80990.0n 0.28000 81119.9n 0.28000 81120.0n 0.28000 81249.9n 0.28000 81250.0n 0.28000 81379.9n 0.28000 81380.0n 0.28000 81509.9n 0.28000 81510.0n 0.28000 81639.9n 0.28000 81640.0n 0.28000 81769.9n 0.28000 81770.0n 0.28000 81899.9n 0.28000 81900.0n 0.28000 82029.9n 0.28000 82030.0n 0.28000 82159.9n 0.28000 82160.0n 0.28000 82289.9n 0.28000 82290.0n 0.28000 82419.9n 0.28000 82420.0n 0.28000 82549.9n 0.28000 82550.0n 0.28000 82679.9n 0.28000 82680.0n 0.28000 82809.9n 0.28000 82810.0n 0.28000 82939.9n 0.28000 82940.0n 0.28000 83069.9n 0.28000 83070.0n 0.28000 83199.9n 0.28000 83200.0n 0.28000 83329.9n 0.28000 83330.0n 0.28000 83459.9n 0.28000 83460.0n 0.28000 83589.9n 0.28000 83590.0n 0.28000 83719.9n 0.28000 83720.0n 0.28000 83849.9n 0.28000 83850.0n 0.28000 83979.9n 0.28000 83980.0n 0.28000 84109.9n 0.28000 84110.0n 0.28000 84239.9n 0.28000 84240.0n 0.31000 84369.9n 0.31000 84370.0n 0.31000 84499.9n 0.31000 84500.0n 0.31000 84629.9n 0.31000 84630.0n 0.25000 84759.9n 0.25000 84760.0n 0.31000 84889.9n 0.31000 84890.0n 0.31000 85019.9n 0.31000 85020.0n 0.25000 85149.9n 0.25000 85150.0n 0.25000 85279.9n 0.25000 85280.0n 0.31000 85409.9n 0.31000 85410.0n 0.31000 85539.9n 0.31000 85540.0n 0.31000 85669.9n 0.31000 85670.0n 0.25000 85799.9n 0.25000 85800.0n 0.31000 85929.9n 0.31000 85930.0n 0.25000 86059.9n 0.25000 86060.0n 0.25000 86189.9n 0.25000 86190.0n 0.25000 86319.9n 0.25000 86320.0n 0.31000 86449.9n 0.31000 86450.0n 0.31000 86579.9n 0.31000 86580.0n 0.25000 86709.9n 0.25000 86710.0n 0.25000 86839.9n 0.25000 86840.0n 0.25000 86969.9n 0.25000 86970.0n 0.25000 87099.9n 0.25000 87100.0n 0.25000 87229.9n 0.25000 87230.0n 0.25000 87359.9n 0.25000 87360.0n 0.31000 87489.9n 0.31000 87490.0n 0.25000 87619.9n 0.25000 87620.0n 0.31000 87749.9n 0.31000 87750.0n 0.31000 87879.9n 0.31000 87880.0n 0.31000 88009.9n 0.31000 88010.0n 0.25000 88139.9n 0.25000 88140.0n 0.31000 88269.9n 0.31000 88270.0n 0.31000 88399.9n 0.31000 88400.0n 0.25000 88529.9n 0.25000 88530.0n 0.31000 88659.9n 0.31000 88660.0n 0.25000 88789.9n 0.25000 88790.0n 0.31000 88919.9n 0.31000 88920.0n 0.31000 89049.9n 0.31000 89050.0n 0.31000 89179.9n 0.31000 89180.0n 0.31000 89309.9n 0.31000 89310.0n 0.25000 89439.9n 0.25000 89440.0n 0.25000 89569.9n 0.25000 89570.0n 0.25000 89699.9n 0.25000 89700.0n 0.25000 89829.9n 0.25000 89830.0n 0.25000 89959.9n 0.25000 89960.0n 0.25000 90089.9n 0.25000 90090.0n 0.31000 90219.9n 0.31000 90220.0n 0.31000 90349.9n 0.31000 90350.0n 0.25000 90479.9n 0.25000 90480.0n 0.31000 90609.9n 0.31000 90610.0n 0.31000 90739.9n 0.31000 90740.0n 0.25000 90869.9n 0.25000 90870.0n 0.25000 90999.9n 0.25000 91000.0n 0.25000 91129.9n 0.25000 91130.0n 0.25000 91259.9n 0.25000 91260.0n 0.31000 91389.9n 0.31000 91390.0n 0.31000 91519.9n 0.31000 91520.0n 0.25000 91649.9n 0.25000 91650.0n 0.25000 91779.9n 0.25000 91780.0n 0.25000 91909.9n 0.25000 91910.0n 0.31000 92039.9n 0.31000 92040.0n 0.31000 92169.9n 0.31000 92170.0n 0.25000 92299.9n 0.25000 92300.0n 0.25000 92429.9n 0.25000 92430.0n 0.31000 92559.9n 0.31000 92560.0n 0.25000 92689.9n 0.25000 92690.0n 0.31000 92819.9n 0.31000 92820.0n 0.31000 92949.9n 0.31000 92950.0n 0.31000 93079.9n 0.31000 93080.0n 0.25000 93209.9n 0.25000 93210.0n 0.31000 93339.9n 0.31000 93340.0n 0.25000 93469.9n 0.25000 93470.0n 0.25000 93599.9n 0.25000 93600.0n 0.31000 93729.9n 0.31000 93730.0n 0.31000 93859.9n 0.31000 93860.0n 0.25000 93989.9n 0.25000 93990.0n 0.31000 94119.9n 0.31000 94120.0n 0.25000 94249.9n 0.25000 94250.0n 0.31000 94379.9n 0.31000 94380.0n 0.25000 94509.9n 0.25000 94510.0n 0.25000 94639.9n 0.25000 94640.0n 0.25000 94769.9n 0.25000 94770.0n 0.31000 94899.9n 0.31000 94900.0n 0.31000 95029.9n 0.31000 95030.0n 0.31000 95159.9n 0.31000 95160.0n 0.31000 95289.9n 0.31000 95290.0n 0.31000 95419.9n 0.31000 95420.0n 0.25000 95549.9n 0.25000 95550.0n 0.25000 95679.9n 0.25000 95680.0n 0.31000 95809.9n 0.31000 95810.0n 0.31000 95939.9n 0.31000 95940.0n 0.25000 96069.9n 0.25000 96070.0n 0.25000 96199.9n 0.25000 96200.0n 0.31000 96329.9n 0.31000 96330.0n 0.25000 96459.9n 0.25000 96460.0n 0.25000 96589.9n 0.25000 96590.0n 0.31000 96719.9n 0.31000 96720.0n 0.25000 96849.9n 0.25000 96850.0n 0.31000 96979.9n 0.31000 96980.0n 0.31000 97109.9n 0.31000 97110.0n 0.31000 97239.9n 0.31000 97240.0n 0.25000 97369.9n 0.25000 97370.0n 0.25000 97499.9n 0.25000 97500.0n 0.25000 97629.9n 0.25000 97630.0n 0.25000 97759.9n 0.25000 97760.0n 0.25000 97889.9n 0.25000 97890.0n 0.31000 98019.9n 0.31000 98020.0n 0.31000 98149.9n 0.31000 98150.0n 0.31000 98279.9n 0.31000 98280.0n 0.31000 98409.9n 0.31000 98410.0n 0.25000 98539.9n 0.25000 98540.0n 0.25000 98669.9n 0.25000 98670.0n 0.31000 98799.9n 0.31000 98800.0n 0.25000 98929.9n 0.25000 98930.0n 0.31000 99059.9n 0.31000 99060.0n 0.31000 99189.9n 0.31000 99190.0n 0.31000 99319.9n 0.31000 99320.0n 0.25000 99449.9n 0.25000 99450.0n 0.31000 99579.9n 0.31000 99580.0n 0.25000 99709.9n 0.25000 99710.0n 0.31000 99839.9n 0.31000 99840.0n 0.25000 99969.9n 0.25000 99970.0n 0.25000 100099.9n 0.25000 100100.0n 0.25000 100229.9n 0.25000 100230.0n 0.25000 100359.9n 0.25000 100360.0n 0.25000 100489.9n 0.25000 100490.0n 0.31000 100619.9n 0.31000 100620.0n 0.25000 100749.9n 0.25000 100750.0n 0.31000 100879.9n 0.31000 100880.0n 0.25000 101009.9n 0.25000 101010.0n 0.31000 101139.9n 0.31000 101140.0n 0.25000 101269.9n 0.25000 101270.0n 0.25000 101399.9n 0.25000 101400.0n 0.31000 101529.9n 0.31000 101530.0n 0.31000 101659.9n 0.31000 101660.0n 0.31000 101789.9n 0.31000 101790.0n 0.25000 101919.9n 0.25000 101920.0n 0.31000 102049.9n 0.31000 102050.0n 0.31000 102179.9n 0.31000 102180.0n 0.25000 102309.9n 0.25000 102310.0n 0.31000 102439.9n 0.31000 102440.0n 0.31000 102569.9n 0.31000 102570.0n 0.31000 102699.9n 0.31000 102700.0n 0.25000 102829.9n 0.25000 102830.0n 0.25000 102959.9n 0.25000 102960.0n 0.25000 103089.9n 0.25000 103090.0n 0.25000 103219.9n 0.25000 103220.0n 0.31000 103349.9n 0.31000 103350.0n 0.31000 103479.9n 0.31000 103480.0n 0.31000 103609.9n 0.31000 103610.0n 0.25000 103739.9n 0.25000 103740.0n 0.31000 103869.9n 0.31000 103870.0n 0.31000 103999.9n 0.31000 104000.0n 0.31000 104129.9n 0.31000 104130.0n 0.31000 104259.9n 0.31000 104260.0n 0.31000 104389.9n 0.31000 104390.0n 0.25000 104519.9n 0.25000 104520.0n 0.25000 104649.9n 0.25000 104650.0n 0.25000 104779.9n 0.25000 104780.0n 0.25000 104909.9n 0.25000 104910.0n 0.25000 105039.9n 0.25000 105040.0n 0.31000 105169.9n 0.31000 105170.0n 0.25000 105299.9n 0.25000 105300.0n 0.31000 105429.9n 0.31000 105430.0n 0.31000 105559.9n 0.31000 105560.0n 0.25000 105689.9n 0.25000 105690.0n 0.31000 105819.9n 0.31000 105820.0n 0.25000 105949.9n 0.25000 105950.0n 0.25000 106079.9n 0.25000 106080.0n 0.28000 106209.9n 0.28000 106210.0n 0.28000 106339.9n 0.28000 106340.0n 0.28000 106469.9n 0.28000 106470.0n 0.28000 106599.9n 0.28000 106600.0n 0.28000 106729.9n 0.28000 106730.0n 0.28000 106859.9n 0.28000 106860.0n 0.28000 106989.9n 0.28000 106990.0n 0.28000 107119.9n 0.28000 107120.0n 0.28000 107249.9n 0.28000 107250.0n 0.28000 107379.9n 0.28000 107380.0n 0.28000 107509.9n 0.28000 107510.0n 0.28000 107639.9n 0.28000 107640.0n 0.28000 107769.9n 0.28000 107770.0n 0.28000 107899.9n 0.28000 107900.0n 0.28000 108029.9n 0.28000 108030.0n 0.28000 108159.9n 0.28000 108160.0n 0.28000 108289.9n 0.28000 108290.0n 0.28000 108419.9n 0.28000 108420.0n 0.28000 108549.9n 0.28000 108550.0n 0.28000 108679.9n 0.28000 108680.0n 0.28000 108809.9n 0.28000 108810.0n 0.28000 108939.9n 0.28000 108940.0n 0.28000 109069.9n 0.28000 109070.0n 0.28000 109199.9n 0.28000 109200.0n 0.28000 109329.9n 0.28000 109330.0n 0.28000 109459.9n 0.28000 109460.0n 0.28000 109589.9n 0.28000 109590.0n 0.28000 109719.9n 0.28000 109720.0n 0.28000 109849.9n 0.28000 109850.0n 0.28000 109979.9n 0.28000 109980.0n 0.28000 110109.9n 0.28000 110110.0n 0.28000 110239.9n 0.28000 110240.0n 0.28000 110369.9n 0.28000 110370.0n 0.28000 110499.9n 0.28000 110500.0n 0.28000 110629.9n 0.28000 110630.0n 0.28000 110759.9n 0.28000 110760.0n 0.28000 110889.9n 0.28000 110890.0n 0.28000 111019.9n 0.28000 111020.0n 0.28000 111149.9n 0.28000 111150.0n 0.28000 111279.9n 0.28000 111280.0n 0.28000 111409.9n 0.28000 111410.0n 0.28000 111539.9n 0.28000 111540.0n 0.28000 111669.9n 0.28000 111670.0n 0.28000 111799.9n 0.28000 111800.0n 0.28000 111929.9n 0.28000 111930.0n 0.28000 112059.9n 0.28000 112060.0n 0.28000 112189.9n 0.28000 112190.0n 0.28000 112319.9n 0.28000 112320.0n 0.31000 112449.9n 0.31000 112450.0n 0.31000 112579.9n 0.31000 112580.0n 0.25000 112709.9n 0.25000 112710.0n 0.31000 112839.9n 0.31000 112840.0n 0.25000 112969.9n 0.25000 112970.0n 0.31000 113099.9n 0.31000 113100.0n 0.31000 113229.9n 0.31000 113230.0n 0.25000 113359.9n 0.25000 113360.0n 0.25000 113489.9n 0.25000 113490.0n 0.25000 113619.9n 0.25000 113620.0n 0.31000 113749.9n 0.31000 113750.0n 0.25000 113879.9n 0.25000 113880.0n 0.25000 114009.9n 0.25000 114010.0n 0.31000 114139.9n 0.31000 114140.0n 0.31000 114269.9n 0.31000 114270.0n 0.31000 114399.9n 0.31000 114400.0n 0.31000 114529.9n 0.31000 114530.0n 0.25000 114659.9n 0.25000 114660.0n 0.31000 114789.9n 0.31000 114790.0n 0.25000 114919.9n 0.25000 114920.0n 0.25000 115049.9n 0.25000 115050.0n 0.25000 115179.9n 0.25000 115180.0n 0.31000 115309.9n 0.31000 115310.0n 0.25000 115439.9n 0.25000 115440.0n 0.31000 115569.9n 0.31000 115570.0n 0.25000 115699.9n 0.25000 115700.0n 0.31000 115829.9n 0.31000 115830.0n 0.25000 115959.9n 0.25000 115960.0n 0.25000 116089.9n 0.25000 116090.0n 0.31000 116219.9n 0.31000 116220.0n 0.31000 116349.9n 0.31000 116350.0n 0.25000 116479.9n 0.25000 116480.0n 0.31000 116609.9n 0.31000 116610.0n 0.31000 116739.9n 0.31000 116740.0n 0.31000 116869.9n 0.31000 116870.0n 0.31000 116999.9n 0.31000 117000.0n 0.25000 117129.9n 0.25000 117130.0n 0.31000 117259.9n 0.31000 117260.0n 0.25000 117389.9n 0.25000 117390.0n 0.31000 117519.9n 0.31000 117520.0n 0.31000 117649.9n 0.31000 117650.0n 0.25000 117779.9n 0.25000 117780.0n 0.31000 117909.9n 0.31000 117910.0n 0.25000 118039.9n 0.25000 118040.0n 0.25000 118169.9n 0.25000 118170.0n 0.31000 118299.9n 0.31000 118300.0n 0.25000 118429.9n 0.25000 118430.0n 0.25000 118559.9n 0.25000 118560.0n 0.25000 118689.9n 0.25000 118690.0n 0.25000 118819.9n 0.25000 118820.0n 0.31000 118949.9n 0.31000 118950.0n 0.25000 119079.9n 0.25000 119080.0n 0.31000 119209.9n 0.31000 119210.0n 0.31000 119339.9n 0.31000 119340.0n 0.25000 119469.9n 0.25000 119470.0n 0.25000 119599.9n 0.25000 119600.0n 0.31000 119729.9n 0.31000 119730.0n 0.25000 119859.9n 0.25000 119860.0n 0.25000 119989.9n 0.25000 119990.0n 0.25000 120119.9n 0.25000 120120.0n 0.31000 120249.9n 0.31000 120250.0n 0.25000 120379.9n 0.25000 120380.0n 0.31000 120509.9n 0.31000 120510.0n 0.31000 120639.9n 0.31000 120640.0n 0.25000 120769.9n 0.25000 120770.0n 0.25000 120899.9n 0.25000 120900.0n 0.31000 121029.9n 0.31000 121030.0n 0.31000 121159.9n 0.31000 121160.0n 0.25000 121289.9n 0.25000 121290.0n 0.31000 121419.9n 0.31000 121420.0n 0.31000 121549.9n 0.31000 121550.0n 0.25000 121679.9n 0.25000 121680.0n 0.25000 121809.9n 0.25000 121810.0n 0.31000 121939.9n 0.31000 121940.0n 0.25000 122069.9n 0.25000 122070.0n 0.25000 122199.9n 0.25000 122200.0n 0.31000 122329.9n 0.31000 122330.0n 0.31000 122459.9n 0.31000 122460.0n 0.31000 122589.9n 0.31000 122590.0n 0.25000 122719.9n 0.25000 122720.0n 0.25000 122849.9n 0.25000 122850.0n 0.31000 122979.9n 0.31000 122980.0n 0.25000 123109.9n 0.25000 123110.0n 0.31000 123239.9n 0.31000 123240.0n 0.31000 123369.9n 0.31000 123370.0n 0.31000 123499.9n 0.31000 123500.0n 0.25000 123629.9n 0.25000 123630.0n 0.25000 123759.9n 0.25000 123760.0n 0.31000 123889.9n 0.31000 123890.0n 0.31000 124019.9n 0.31000 124020.0n 0.25000 124149.9n 0.25000 124150.0n 0.25000 124279.9n 0.25000 124280.0n 0.25000 124409.9n 0.25000 124410.0n 0.31000 124539.9n 0.31000 124540.0n 0.31000 124669.9n 0.31000 124670.0n 0.25000 124799.9n 0.25000 124800.0n 0.25000 124929.9n 0.25000 124930.0n 0.31000 125059.9n 0.31000 125060.0n 0.25000 125189.9n 0.25000 125190.0n 0.25000 125319.9n 0.25000 125320.0n 0.31000 125449.9n 0.31000 125450.0n 0.31000 125579.9n 0.31000 125580.0n 0.25000 125709.9n 0.25000 125710.0n 0.25000 125839.9n 0.25000 125840.0n 0.31000 125969.9n 0.31000 125970.0n 0.31000 126099.9n 0.31000 126100.0n 0.25000 126229.9n 0.25000 126230.0n 0.25000 126359.9n 0.25000 126360.0n 0.31000 126489.9n 0.31000 126490.0n 0.31000 126619.9n 0.31000 126620.0n 0.25000 126749.9n 0.25000 126750.0n 0.31000 126879.9n 0.31000 126880.0n 0.25000 127009.9n 0.25000 127010.0n 0.25000 127139.9n 0.25000 127140.0n 0.31000 127269.9n 0.31000 127270.0n 0.25000 127399.9n 0.25000 127400.0n 0.31000 127529.9n 0.31000 127530.0n 0.31000 127659.9n 0.31000 127660.0n 0.25000 127789.9n 0.25000 127790.0n 0.25000 127919.9n 0.25000 127920.0n 0.31000 128049.9n 0.31000 128050.0n 0.31000 128179.9n 0.31000 128180.0n 0.25000 128309.9n 0.25000 128310.0n 0.25000 128439.9n 0.25000 128440.0n 0.25000 128569.9n 0.25000 128570.0n 0.25000 128699.9n 0.25000 128700.0n 0.31000 128829.9n 0.31000 128830.0n 0.31000 128959.9n 0.31000 128960.0n 0.31000 129089.9n 0.31000 129090.0n 0.31000 129219.9n 0.31000 129220.0n 0.31000 129349.9n 0.31000 129350.0n 0.31000 129479.9n 0.31000 129480.0n 0.25000 129609.9n 0.25000 129610.0n 0.31000 129739.9n 0.31000 129740.0n 0.25000 129869.9n 0.25000 129870.0n 0.25000 129999.9n 0.25000 130000.0n 0.25000 130129.9n 0.25000 130130.0n 0.25000 130259.9n 0.25000 130260.0n 0.31000 130389.9n 0.31000 130390.0n 0.31000 130519.9n 0.31000 130520.0n 0.25000 130649.9n 0.25000 130650.0n 0.31000 130779.9n 0.31000 130780.0n 0.31000 130909.9n 0.31000 130910.0n 0.25000 131039.9n 0.25000 131040.0n 0.25000 131169.9n 0.25000 131170.0n 0.25000 131299.9n 0.25000 131300.0n 0.25000 131429.9n 0.25000 131430.0n 0.25000 131559.9n 0.25000 131560.0n 0.31000 131689.9n 0.31000 131690.0n 0.31000 131819.9n 0.31000 131820.0n 0.31000 131949.9n 0.31000 131950.0n 0.25000 132079.9n 0.25000 132080.0n 0.31000 132209.9n 0.31000 132210.0n 0.25000 132339.9n 0.25000 132340.0n 0.31000 132469.9n 0.31000 132470.0n 0.25000 132599.9n 0.25000 132600.0n 0.25000 132729.9n 0.25000 132730.0n 0.31000 132859.9n 0.31000 132860.0n 0.31000 132989.9n 0.31000 132990.0n 0.31000 133119.9n 0.31000 133120.0n 0.31000 133249.9n 0.31000 133250.0n 0.31000 133379.9n 0.31000 133380.0n 0.25000 133509.9n 0.25000 133510.0n 0.25000 133639.9n 0.25000 133640.0n 0.31000 133769.9n 0.31000 133770.0n 0.25000 133899.9n 0.25000 133900.0n 0.31000 134029.9n 0.31000 134030.0n 0.25000 134159.9n 0.25000 134160.0n 0.28000 134289.9n 0.28000 134290.0n 0.28000 134419.9n 0.28000 134420.0n 0.28000 134549.9n 0.28000 134550.0n 0.28000 134679.9n 0.28000 134680.0n 0.28000 134809.9n 0.28000 134810.0n 0.28000 134939.9n 0.28000 134940.0n 0.28000 135069.9n 0.28000 135070.0n 0.28000 135199.9n 0.28000 135200.0n 0.28000 135329.9n 0.28000 135330.0n 0.28000 135459.9n 0.28000 135460.0n 0.28000 135589.9n 0.28000 135590.0n 0.28000 135719.9n 0.28000 135720.0n 0.28000 135849.9n 0.28000 135850.0n 0.28000 135979.9n 0.28000 135980.0n 0.28000 136109.9n 0.28000 136110.0n 0.28000 136239.9n 0.28000 136240.0n 0.28000 136369.9n 0.28000 136370.0n 0.28000 136499.9n 0.28000 136500.0n 0.28000 136629.9n 0.28000 136630.0n 0.28000 136759.9n 0.28000 136760.0n 0.28000 136889.9n 0.28000 136890.0n 0.28000 137019.9n 0.28000 137020.0n 0.28000 137149.9n 0.28000 137150.0n 0.28000 137279.9n 0.28000 137280.0n 0.28000 137409.9n 0.28000 137410.0n 0.28000 137539.9n 0.28000 137540.0n 0.28000 137669.9n 0.28000 137670.0n 0.28000 137799.9n 0.28000 137800.0n 0.28000 137929.9n 0.28000 137930.0n 0.28000 138059.9n 0.28000 138060.0n 0.28000 138189.9n 0.28000 138190.0n 0.28000 138319.9n 0.28000 138320.0n 0.28000 138449.9n 0.28000 138450.0n 0.28000 138579.9n 0.28000 138580.0n 0.28000 138709.9n 0.28000 138710.0n 0.28000 138839.9n 0.28000 138840.0n 0.28000 138969.9n 0.28000 138970.0n 0.28000 139099.9n 0.28000 139100.0n 0.28000 139229.9n 0.28000 139230.0n 0.28000 139359.9n 0.28000 139360.0n 0.28000 139489.9n 0.28000 139490.0n 0.28000 139619.9n 0.28000 139620.0n 0.28000 139749.9n 0.28000 139750.0n 0.28000 139879.9n 0.28000 139880.0n 0.28000 140009.9n 0.28000 140010.0n 0.28000 140139.9n 0.28000 140140.0n 0.28000 140269.9n 0.28000 140270.0n 0.28000 140399.9n 0.28000 140400.0n 0.25000 140529.9n 0.25000 140530.0n 0.31000 140659.9n 0.31000 140660.0n 0.25000 140789.9n 0.25000 140790.0n 0.25000 140919.9n 0.25000 140920.0n 0.31000 141049.9n 0.31000 141050.0n 0.31000 141179.9n 0.31000 141180.0n 0.25000 141309.9n 0.25000 141310.0n 0.31000 141439.9n 0.31000 141440.0n 0.25000 141569.9n 0.25000 141570.0n 0.31000 141699.9n 0.31000 141700.0n 0.31000 141829.9n 0.31000 141830.0n 0.25000 141959.9n 0.25000 141960.0n 0.25000 142089.9n 0.25000 142090.0n 0.25000 142219.9n 0.25000 142220.0n 0.31000 142349.9n 0.31000 142350.0n 0.25000 142479.9n 0.25000 142480.0n 0.31000 142609.9n 0.31000 142610.0n 0.25000 142739.9n 0.25000 142740.0n 0.25000 142869.9n 0.25000 142870.0n 0.25000 142999.9n 0.25000 143000.0n 0.25000 143129.9n 0.25000 143130.0n 0.31000 143259.9n 0.31000 143260.0n 0.25000 143389.9n 0.25000 143390.0n 0.31000 143519.9n 0.31000 143520.0n 0.31000 143649.9n 0.31000 143650.0n 0.31000 143779.9n 0.31000 143780.0n 0.31000 143909.9n 0.31000 143910.0n 0.31000 144039.9n 0.31000 144040.0n 0.25000 144169.9n 0.25000 144170.0n 0.25000 144299.9n 0.25000 144300.0n 0.31000 144429.9n 0.31000 144430.0n 0.31000 144559.9n 0.31000 144560.0n 0.31000 144689.9n 0.31000 144690.0n 0.31000 144819.9n 0.31000 144820.0n 0.25000 144949.9n 0.25000 144950.0n 0.31000 145079.9n 0.31000 145080.0n 0.31000 145209.9n 0.31000 145210.0n 0.25000 145339.9n 0.25000 145340.0n 0.25000 145469.9n 0.25000 145470.0n 0.25000 145599.9n 0.25000 145600.0n 0.31000 145729.9n 0.31000 145730.0n 0.31000 145859.9n 0.31000 145860.0n 0.25000 145989.9n 0.25000 145990.0n 0.25000 146119.9n 0.25000 146120.0n 0.25000 146249.9n 0.25000 146250.0n 0.31000 146379.9n 0.31000 146380.0n 0.25000 146509.9n 0.25000 146510.0n 0.31000 146639.9n 0.31000 146640.0n 0.31000 146769.9n 0.31000 146770.0n 0.31000 146899.9n 0.31000 146900.0n 0.31000 147029.9n 0.31000 147030.0n 0.25000 147159.9n 0.25000 147160.0n 0.25000 147289.9n 0.25000 147290.0n 0.31000 147419.9n 0.31000 147420.0n 0.25000 147549.9n 0.25000 147550.0n 0.25000 147679.9n 0.25000 147680.0n 0.31000 147809.9n 0.31000 147810.0n 0.25000 147939.9n 0.25000 147940.0n 0.31000 148069.9n 0.31000 148070.0n 0.25000 148199.9n 0.25000 148200.0n 0.25000 148329.9n 0.25000 148330.0n 0.25000 148459.9n 0.25000 148460.0n 0.25000 148589.9n 0.25000 148590.0n 0.31000 148719.9n 0.31000 148720.0n 0.25000 148849.9n 0.25000 148850.0n 0.31000 148979.9n 0.31000 148980.0n 0.31000 149109.9n 0.31000 149110.0n 0.31000 149239.9n 0.31000 149240.0n 0.25000 149369.9n 0.25000 149370.0n 0.25000 149499.9n 0.25000 149500.0n 0.31000 149629.9n 0.31000 149630.0n 0.25000 149759.9n 0.25000 149760.0n 0.25000 149889.9n 0.25000 149890.0n 0.31000 150019.9n 0.31000 150020.0n 0.31000 150149.9n 0.31000 150150.0n 0.25000 150279.9n 0.25000 150280.0n 0.31000 150409.9n 0.31000 150410.0n 0.31000 150539.9n 0.31000 150540.0n 0.25000 150669.9n 0.25000 150670.0n 0.31000 150799.9n 0.31000 150800.0n 0.25000 150929.9n 0.25000 150930.0n 0.25000 151059.9n 0.25000 151060.0n 0.31000 151189.9n 0.31000 151190.0n 0.31000 151319.9n 0.31000 151320.0n 0.25000 151449.9n 0.25000 151450.0n 0.31000 151579.9n 0.31000 151580.0n 0.25000 151709.9n 0.25000 151710.0n 0.31000 151839.9n 0.31000 151840.0n 0.31000 151969.9n 0.31000 151970.0n 0.25000 152099.9n 0.25000 152100.0n 0.31000 152229.9n 0.31000 152230.0n 0.25000 152359.9n 0.25000 152360.0n 0.31000 152489.9n 0.31000 152490.0n 0.25000 152619.9n 0.25000 152620.0n 0.25000 152749.9n 0.25000 152750.0n 0.31000 152879.9n 0.31000 152880.0n 0.31000 153009.9n 0.31000 153010.0n 0.25000 153139.9n 0.25000 153140.0n 0.31000 153269.9n 0.31000 153270.0n 0.25000 153399.9n 0.25000 153400.0n 0.25000 153529.9n 0.25000 153530.0n 0.31000 153659.9n 0.31000 153660.0n 0.31000 153789.9n 0.31000 153790.0n 0.31000 153919.9n 0.31000 153920.0n 0.25000 154049.9n 0.25000 154050.0n 0.25000 154179.9n 0.25000 154180.0n 0.25000 154309.9n 0.25000 154310.0n 0.31000 154439.9n 0.31000 154440.0n 0.31000 154569.9n 0.31000 154570.0n 0.31000 154699.9n 0.31000 154700.0n 0.25000 154829.9n 0.25000 154830.0n 0.25000 154959.9n 0.25000 154960.0n 0.25000 155089.9n 0.25000 155090.0n 0.31000 155219.9n 0.31000 155220.0n 0.25000 155349.9n 0.25000 155350.0n 0.31000 155479.9n 0.31000 155480.0n 0.31000 155609.9n 0.31000 155610.0n 0.25000 155739.9n 0.25000 155740.0n 0.31000 155869.9n 0.31000 155870.0n 0.31000 155999.9n 0.31000 156000.0n 0.31000 156129.9n 0.31000 156130.0n 0.25000 156259.9n 0.25000 156260.0n 0.31000 156389.9n 0.31000 156390.0n 0.31000 156519.9n 0.31000 156520.0n 0.25000 156649.9n 0.25000 156650.0n 0.25000 156779.9n 0.25000 156780.0n 0.25000 156909.9n 0.25000 156910.0n 0.31000 157039.9n 0.31000 157040.0n 0.25000 157169.9n 0.25000 157170.0n 0.31000 157299.9n 0.31000 157300.0n 0.31000 157429.9n 0.31000 157430.0n 0.31000 157559.9n 0.31000 157560.0n 0.25000 157689.9n 0.25000 157690.0n 0.25000 157819.9n 0.25000 157820.0n 0.31000 157949.9n 0.31000 157950.0n 0.25000 158079.9n 0.25000 158080.0n 0.25000 158209.9n 0.25000 158210.0n 0.25000 158339.9n 0.25000 158340.0n 0.31000 158469.9n 0.31000 158470.0n 0.25000 158599.9n 0.25000 158600.0n 0.31000 158729.9n 0.31000 158730.0n 0.31000 158859.9n 0.31000 158860.0n 0.31000 158989.9n 0.31000 158990.0n 0.31000 159119.9n 0.31000 159120.0n 0.25000 159249.9n 0.25000 159250.0n 0.25000 159379.9n 0.25000 159380.0n 0.31000 159509.9n 0.31000 159510.0n 0.31000 159639.9n 0.31000 159640.0n 0.31000 159769.9n 0.31000 159770.0n 0.31000 159899.9n 0.31000 159900.0n 0.25000 160029.9n 0.25000 160030.0n 0.25000 160159.9n 0.25000 160160.0n 0.25000 160289.9n 0.25000 160290.0n 0.31000 160419.9n 0.31000 160420.0n 0.31000 160549.9n 0.31000 160550.0n 0.25000 160679.9n 0.25000 160680.0n 0.25000 160809.9n 0.25000 160810.0n 0.25000 160939.9n 0.25000 160940.0n 0.31000 161069.9n 0.31000 161070.0n 0.25000 161199.9n 0.25000 161200.0n 0.31000 161329.9n 0.31000 161330.0n 0.25000 161459.9n 0.25000 161460.0n 0.25000 161589.9n 0.25000 161590.0n 0.31000 161719.9n 0.31000 161720.0n 0.25000 161849.9n 0.25000 161850.0n 0.25000 161979.9n 0.25000 161980.0n 0.31000 162109.9n 0.31000 162110.0n 0.25000 162239.9n 0.25000 162240.0n 0.28000 162369.9n 0.28000 162370.0n 0.28000 162499.9n 0.28000 162500.0n 0.28000 162629.9n 0.28000 162630.0n 0.28000 162759.9n 0.28000 162760.0n 0.28000 162889.9n 0.28000 162890.0n 0.28000 163019.9n 0.28000 163020.0n 0.28000 163149.9n 0.28000 163150.0n 0.28000 163279.9n 0.28000 163280.0n 0.28000 163409.9n 0.28000 163410.0n 0.28000 163539.9n 0.28000 163540.0n 0.28000 163669.9n 0.28000 163670.0n 0.28000 163799.9n 0.28000 163800.0n 0.28000 163929.9n 0.28000 163930.0n 0.28000 164059.9n 0.28000 164060.0n 0.28000 164189.9n 0.28000 164190.0n 0.28000 164319.9n 0.28000 164320.0n 0.28000 164449.9n 0.28000 164450.0n 0.28000 164579.9n 0.28000 164580.0n 0.28000 164709.9n 0.28000 164710.0n 0.28000 164839.9n 0.28000 164840.0n 0.28000 164969.9n 0.28000 164970.0n 0.28000 165099.9n 0.28000 165100.0n 0.28000 165229.9n 0.28000 165230.0n 0.28000 165359.9n 0.28000 165360.0n 0.28000 165489.9n 0.28000 165490.0n 0.28000 165619.9n 0.28000 165620.0n 0.28000 165749.9n 0.28000 165750.0n 0.28000 165879.9n 0.28000 165880.0n 0.28000 166009.9n 0.28000 166010.0n 0.28000 166139.9n 0.28000 166140.0n 0.28000 166269.9n 0.28000 166270.0n 0.28000 166399.9n 0.28000 166400.0n 0.28000 166529.9n 0.28000 166530.0n 0.28000 166659.9n 0.28000 166660.0n 0.28000 166789.9n 0.28000 166790.0n 0.28000 166919.9n 0.28000 166920.0n 0.28000 167049.9n 0.28000 167050.0n 0.28000 167179.9n 0.28000 167180.0n 0.28000 167309.9n 0.28000 167310.0n 0.28000 167439.9n 0.28000 167440.0n 0.28000 167569.9n 0.28000 167570.0n 0.28000 167699.9n 0.28000 167700.0n 0.28000 167829.9n 0.28000 167830.0n 0.28000 167959.9n 0.28000 167960.0n 0.28000 168089.9n 0.28000 168090.0n 0.28000 168219.9n 0.28000 168220.0n 0.28000 168349.9n 0.28000 168350.0n 0.28000)
Vxon0 xon0 0 PWL(0.0n 0.31000 129.9n 0.31000 130.0n 0.25000 259.9n 0.25000 260.0n 0.25000 389.9n 0.25000 390.0n 0.25000 519.9n 0.25000 520.0n 0.25000 649.9n 0.25000 650.0n 0.25000 779.9n 0.25000 780.0n 0.31000 909.9n 0.31000 910.0n 0.31000 1039.9n 0.31000 1040.0n 0.31000 1169.9n 0.31000 1170.0n 0.31000 1299.9n 0.31000 1300.0n 0.31000 1429.9n 0.31000 1430.0n 0.25000 1559.9n 0.25000 1560.0n 0.25000 1689.9n 0.25000 1690.0n 0.25000 1819.9n 0.25000 1820.0n 0.31000 1949.9n 0.31000 1950.0n 0.25000 2079.9n 0.25000 2080.0n 0.25000 2209.9n 0.25000 2210.0n 0.31000 2339.9n 0.31000 2340.0n 0.25000 2469.9n 0.25000 2470.0n 0.31000 2599.9n 0.31000 2600.0n 0.31000 2729.9n 0.31000 2730.0n 0.25000 2859.9n 0.25000 2860.0n 0.31000 2989.9n 0.31000 2990.0n 0.31000 3119.9n 0.31000 3120.0n 0.25000 3249.9n 0.25000 3250.0n 0.25000 3379.9n 0.25000 3380.0n 0.31000 3509.9n 0.31000 3510.0n 0.31000 3639.9n 0.31000 3640.0n 0.25000 3769.9n 0.25000 3770.0n 0.31000 3899.9n 0.31000 3900.0n 0.31000 4029.9n 0.31000 4030.0n 0.31000 4159.9n 0.31000 4160.0n 0.25000 4289.9n 0.25000 4290.0n 0.31000 4419.9n 0.31000 4420.0n 0.31000 4549.9n 0.31000 4550.0n 0.31000 4679.9n 0.31000 4680.0n 0.31000 4809.9n 0.31000 4810.0n 0.25000 4939.9n 0.25000 4940.0n 0.25000 5069.9n 0.25000 5070.0n 0.25000 5199.9n 0.25000 5200.0n 0.25000 5329.9n 0.25000 5330.0n 0.25000 5459.9n 0.25000 5460.0n 0.25000 5589.9n 0.25000 5590.0n 0.25000 5719.9n 0.25000 5720.0n 0.31000 5849.9n 0.31000 5850.0n 0.31000 5979.9n 0.31000 5980.0n 0.31000 6109.9n 0.31000 6110.0n 0.31000 6239.9n 0.31000 6240.0n 0.31000 6369.9n 0.31000 6370.0n 0.25000 6499.9n 0.25000 6500.0n 0.25000 6629.9n 0.25000 6630.0n 0.25000 6759.9n 0.25000 6760.0n 0.25000 6889.9n 0.25000 6890.0n 0.31000 7019.9n 0.31000 7020.0n 0.25000 7149.9n 0.25000 7150.0n 0.31000 7279.9n 0.31000 7280.0n 0.25000 7409.9n 0.25000 7410.0n 0.25000 7539.9n 0.25000 7540.0n 0.31000 7669.9n 0.31000 7670.0n 0.25000 7799.9n 0.25000 7800.0n 0.25000 7929.9n 0.25000 7930.0n 0.31000 8059.9n 0.31000 8060.0n 0.31000 8189.9n 0.31000 8190.0n 0.25000 8319.9n 0.25000 8320.0n 0.31000 8449.9n 0.31000 8450.0n 0.31000 8579.9n 0.31000 8580.0n 0.25000 8709.9n 0.25000 8710.0n 0.31000 8839.9n 0.31000 8840.0n 0.25000 8969.9n 0.25000 8970.0n 0.31000 9099.9n 0.31000 9100.0n 0.31000 9229.9n 0.31000 9230.0n 0.25000 9359.9n 0.25000 9360.0n 0.25000 9489.9n 0.25000 9490.0n 0.31000 9619.9n 0.31000 9620.0n 0.25000 9749.9n 0.25000 9750.0n 0.31000 9879.9n 0.31000 9880.0n 0.25000 10009.9n 0.25000 10010.0n 0.25000 10139.9n 0.25000 10140.0n 0.25000 10269.9n 0.25000 10270.0n 0.31000 10399.9n 0.31000 10400.0n 0.31000 10529.9n 0.31000 10530.0n 0.31000 10659.9n 0.31000 10660.0n 0.31000 10789.9n 0.31000 10790.0n 0.25000 10919.9n 0.25000 10920.0n 0.31000 11049.9n 0.31000 11050.0n 0.25000 11179.9n 0.25000 11180.0n 0.25000 11309.9n 0.25000 11310.0n 0.31000 11439.9n 0.31000 11440.0n 0.31000 11569.9n 0.31000 11570.0n 0.25000 11699.9n 0.25000 11700.0n 0.31000 11829.9n 0.31000 11830.0n 0.31000 11959.9n 0.31000 11960.0n 0.25000 12089.9n 0.25000 12090.0n 0.31000 12219.9n 0.31000 12220.0n 0.31000 12349.9n 0.31000 12350.0n 0.25000 12479.9n 0.25000 12480.0n 0.31000 12609.9n 0.31000 12610.0n 0.31000 12739.9n 0.31000 12740.0n 0.31000 12869.9n 0.31000 12870.0n 0.31000 12999.9n 0.31000 13000.0n 0.25000 13129.9n 0.25000 13130.0n 0.25000 13259.9n 0.25000 13260.0n 0.25000 13389.9n 0.25000 13390.0n 0.31000 13519.9n 0.31000 13520.0n 0.25000 13649.9n 0.25000 13650.0n 0.25000 13779.9n 0.25000 13780.0n 0.25000 13909.9n 0.25000 13910.0n 0.25000 14039.9n 0.25000 14040.0n 0.31000 14169.9n 0.31000 14170.0n 0.25000 14299.9n 0.25000 14300.0n 0.31000 14429.9n 0.31000 14430.0n 0.25000 14559.9n 0.25000 14560.0n 0.31000 14689.9n 0.31000 14690.0n 0.25000 14819.9n 0.25000 14820.0n 0.31000 14949.9n 0.31000 14950.0n 0.31000 15079.9n 0.31000 15080.0n 0.25000 15209.9n 0.25000 15210.0n 0.31000 15339.9n 0.31000 15340.0n 0.25000 15469.9n 0.25000 15470.0n 0.25000 15599.9n 0.25000 15600.0n 0.25000 15729.9n 0.25000 15730.0n 0.31000 15859.9n 0.31000 15860.0n 0.31000 15989.9n 0.31000 15990.0n 0.25000 16119.9n 0.25000 16120.0n 0.25000 16249.9n 0.25000 16250.0n 0.31000 16379.9n 0.31000 16380.0n 0.31000 16509.9n 0.31000 16510.0n 0.25000 16639.9n 0.25000 16640.0n 0.31000 16769.9n 0.31000 16770.0n 0.25000 16899.9n 0.25000 16900.0n 0.31000 17029.9n 0.31000 17030.0n 0.25000 17159.9n 0.25000 17160.0n 0.25000 17289.9n 0.25000 17290.0n 0.31000 17419.9n 0.31000 17420.0n 0.25000 17549.9n 0.25000 17550.0n 0.31000 17679.9n 0.31000 17680.0n 0.31000 17809.9n 0.31000 17810.0n 0.31000 17939.9n 0.31000 17940.0n 0.25000 18069.9n 0.25000 18070.0n 0.25000 18199.9n 0.25000 18200.0n 0.31000 18329.9n 0.31000 18330.0n 0.31000 18459.9n 0.31000 18460.0n 0.25000 18589.9n 0.25000 18590.0n 0.25000 18719.9n 0.25000 18720.0n 0.25000 18849.9n 0.25000 18850.0n 0.25000 18979.9n 0.25000 18980.0n 0.25000 19109.9n 0.25000 19110.0n 0.31000 19239.9n 0.31000 19240.0n 0.31000 19369.9n 0.31000 19370.0n 0.31000 19499.9n 0.31000 19500.0n 0.31000 19629.9n 0.31000 19630.0n 0.25000 19759.9n 0.25000 19760.0n 0.31000 19889.9n 0.31000 19890.0n 0.25000 20019.9n 0.25000 20020.0n 0.31000 20149.9n 0.31000 20150.0n 0.25000 20279.9n 0.25000 20280.0n 0.31000 20409.9n 0.31000 20410.0n 0.25000 20539.9n 0.25000 20540.0n 0.25000 20669.9n 0.25000 20670.0n 0.25000 20799.9n 0.25000 20800.0n 0.31000 20929.9n 0.31000 20930.0n 0.31000 21059.9n 0.31000 21060.0n 0.25000 21189.9n 0.25000 21190.0n 0.31000 21319.9n 0.31000 21320.0n 0.25000 21449.9n 0.25000 21450.0n 0.31000 21579.9n 0.31000 21580.0n 0.31000 21709.9n 0.31000 21710.0n 0.25000 21839.9n 0.25000 21840.0n 0.28000 21969.9n 0.28000 21970.0n 0.28000 22099.9n 0.28000 22100.0n 0.28000 22229.9n 0.28000 22230.0n 0.28000 22359.9n 0.28000 22360.0n 0.28000 22489.9n 0.28000 22490.0n 0.28000 22619.9n 0.28000 22620.0n 0.28000 22749.9n 0.28000 22750.0n 0.28000 22879.9n 0.28000 22880.0n 0.28000 23009.9n 0.28000 23010.0n 0.28000 23139.9n 0.28000 23140.0n 0.28000 23269.9n 0.28000 23270.0n 0.28000 23399.9n 0.28000 23400.0n 0.28000 23529.9n 0.28000 23530.0n 0.28000 23659.9n 0.28000 23660.0n 0.28000 23789.9n 0.28000 23790.0n 0.28000 23919.9n 0.28000 23920.0n 0.28000 24049.9n 0.28000 24050.0n 0.28000 24179.9n 0.28000 24180.0n 0.28000 24309.9n 0.28000 24310.0n 0.28000 24439.9n 0.28000 24440.0n 0.28000 24569.9n 0.28000 24570.0n 0.28000 24699.9n 0.28000 24700.0n 0.28000 24829.9n 0.28000 24830.0n 0.28000 24959.9n 0.28000 24960.0n 0.28000 25089.9n 0.28000 25090.0n 0.28000 25219.9n 0.28000 25220.0n 0.28000 25349.9n 0.28000 25350.0n 0.28000 25479.9n 0.28000 25480.0n 0.28000 25609.9n 0.28000 25610.0n 0.28000 25739.9n 0.28000 25740.0n 0.28000 25869.9n 0.28000 25870.0n 0.28000 25999.9n 0.28000 26000.0n 0.28000 26129.9n 0.28000 26130.0n 0.28000 26259.9n 0.28000 26260.0n 0.28000 26389.9n 0.28000 26390.0n 0.28000 26519.9n 0.28000 26520.0n 0.28000 26649.9n 0.28000 26650.0n 0.28000 26779.9n 0.28000 26780.0n 0.28000 26909.9n 0.28000 26910.0n 0.28000 27039.9n 0.28000 27040.0n 0.28000 27169.9n 0.28000 27170.0n 0.28000 27299.9n 0.28000 27300.0n 0.28000 27429.9n 0.28000 27430.0n 0.28000 27559.9n 0.28000 27560.0n 0.28000 27689.9n 0.28000 27690.0n 0.28000 27819.9n 0.28000 27820.0n 0.28000 27949.9n 0.28000 27950.0n 0.28000 28079.9n 0.28000 28080.0n 0.25000 28209.9n 0.25000 28210.0n 0.25000 28339.9n 0.25000 28340.0n 0.31000 28469.9n 0.31000 28470.0n 0.31000 28599.9n 0.31000 28600.0n 0.31000 28729.9n 0.31000 28730.0n 0.25000 28859.9n 0.25000 28860.0n 0.31000 28989.9n 0.31000 28990.0n 0.31000 29119.9n 0.31000 29120.0n 0.25000 29249.9n 0.25000 29250.0n 0.31000 29379.9n 0.31000 29380.0n 0.31000 29509.9n 0.31000 29510.0n 0.25000 29639.9n 0.25000 29640.0n 0.31000 29769.9n 0.31000 29770.0n 0.31000 29899.9n 0.31000 29900.0n 0.25000 30029.9n 0.25000 30030.0n 0.31000 30159.9n 0.31000 30160.0n 0.31000 30289.9n 0.31000 30290.0n 0.31000 30419.9n 0.31000 30420.0n 0.31000 30549.9n 0.31000 30550.0n 0.25000 30679.9n 0.25000 30680.0n 0.25000 30809.9n 0.25000 30810.0n 0.25000 30939.9n 0.25000 30940.0n 0.25000 31069.9n 0.25000 31070.0n 0.25000 31199.9n 0.25000 31200.0n 0.25000 31329.9n 0.25000 31330.0n 0.31000 31459.9n 0.31000 31460.0n 0.25000 31589.9n 0.25000 31590.0n 0.25000 31719.9n 0.25000 31720.0n 0.31000 31849.9n 0.31000 31850.0n 0.25000 31979.9n 0.25000 31980.0n 0.25000 32109.9n 0.25000 32110.0n 0.25000 32239.9n 0.25000 32240.0n 0.25000 32369.9n 0.25000 32370.0n 0.25000 32499.9n 0.25000 32500.0n 0.31000 32629.9n 0.31000 32630.0n 0.31000 32759.9n 0.31000 32760.0n 0.31000 32889.9n 0.31000 32890.0n 0.25000 33019.9n 0.25000 33020.0n 0.31000 33149.9n 0.31000 33150.0n 0.31000 33279.9n 0.31000 33280.0n 0.31000 33409.9n 0.31000 33410.0n 0.31000 33539.9n 0.31000 33540.0n 0.25000 33669.9n 0.25000 33670.0n 0.31000 33799.9n 0.31000 33800.0n 0.25000 33929.9n 0.25000 33930.0n 0.31000 34059.9n 0.31000 34060.0n 0.25000 34189.9n 0.25000 34190.0n 0.25000 34319.9n 0.25000 34320.0n 0.25000 34449.9n 0.25000 34450.0n 0.31000 34579.9n 0.31000 34580.0n 0.25000 34709.9n 0.25000 34710.0n 0.25000 34839.9n 0.25000 34840.0n 0.31000 34969.9n 0.31000 34970.0n 0.31000 35099.9n 0.31000 35100.0n 0.31000 35229.9n 0.31000 35230.0n 0.25000 35359.9n 0.25000 35360.0n 0.31000 35489.9n 0.31000 35490.0n 0.25000 35619.9n 0.25000 35620.0n 0.31000 35749.9n 0.31000 35750.0n 0.31000 35879.9n 0.31000 35880.0n 0.25000 36009.9n 0.25000 36010.0n 0.31000 36139.9n 0.31000 36140.0n 0.31000 36269.9n 0.31000 36270.0n 0.25000 36399.9n 0.25000 36400.0n 0.25000 36529.9n 0.25000 36530.0n 0.25000 36659.9n 0.25000 36660.0n 0.31000 36789.9n 0.31000 36790.0n 0.31000 36919.9n 0.31000 36920.0n 0.31000 37049.9n 0.31000 37050.0n 0.31000 37179.9n 0.31000 37180.0n 0.31000 37309.9n 0.31000 37310.0n 0.31000 37439.9n 0.31000 37440.0n 0.25000 37569.9n 0.25000 37570.0n 0.25000 37699.9n 0.25000 37700.0n 0.25000 37829.9n 0.25000 37830.0n 0.25000 37959.9n 0.25000 37960.0n 0.25000 38089.9n 0.25000 38090.0n 0.25000 38219.9n 0.25000 38220.0n 0.25000 38349.9n 0.25000 38350.0n 0.31000 38479.9n 0.31000 38480.0n 0.31000 38609.9n 0.31000 38610.0n 0.25000 38739.9n 0.25000 38740.0n 0.31000 38869.9n 0.31000 38870.0n 0.25000 38999.9n 0.25000 39000.0n 0.31000 39129.9n 0.31000 39130.0n 0.25000 39259.9n 0.25000 39260.0n 0.25000 39389.9n 0.25000 39390.0n 0.25000 39519.9n 0.25000 39520.0n 0.31000 39649.9n 0.31000 39650.0n 0.25000 39779.9n 0.25000 39780.0n 0.31000 39909.9n 0.31000 39910.0n 0.31000 40039.9n 0.31000 40040.0n 0.31000 40169.9n 0.31000 40170.0n 0.25000 40299.9n 0.25000 40300.0n 0.25000 40429.9n 0.25000 40430.0n 0.25000 40559.9n 0.25000 40560.0n 0.31000 40689.9n 0.31000 40690.0n 0.31000 40819.9n 0.31000 40820.0n 0.25000 40949.9n 0.25000 40950.0n 0.31000 41079.9n 0.31000 41080.0n 0.31000 41209.9n 0.31000 41210.0n 0.31000 41339.9n 0.31000 41340.0n 0.25000 41469.9n 0.25000 41470.0n 0.25000 41599.9n 0.25000 41600.0n 0.31000 41729.9n 0.31000 41730.0n 0.31000 41859.9n 0.31000 41860.0n 0.31000 41989.9n 0.31000 41990.0n 0.25000 42119.9n 0.25000 42120.0n 0.25000 42249.9n 0.25000 42250.0n 0.25000 42379.9n 0.25000 42380.0n 0.25000 42509.9n 0.25000 42510.0n 0.31000 42639.9n 0.31000 42640.0n 0.31000 42769.9n 0.31000 42770.0n 0.25000 42899.9n 0.25000 42900.0n 0.25000 43029.9n 0.25000 43030.0n 0.31000 43159.9n 0.31000 43160.0n 0.25000 43289.9n 0.25000 43290.0n 0.31000 43419.9n 0.31000 43420.0n 0.31000 43549.9n 0.31000 43550.0n 0.31000 43679.9n 0.31000 43680.0n 0.31000 43809.9n 0.31000 43810.0n 0.31000 43939.9n 0.31000 43940.0n 0.25000 44069.9n 0.25000 44070.0n 0.31000 44199.9n 0.31000 44200.0n 0.31000 44329.9n 0.31000 44330.0n 0.25000 44459.9n 0.25000 44460.0n 0.25000 44589.9n 0.25000 44590.0n 0.25000 44719.9n 0.25000 44720.0n 0.25000 44849.9n 0.25000 44850.0n 0.31000 44979.9n 0.31000 44980.0n 0.25000 45109.9n 0.25000 45110.0n 0.31000 45239.9n 0.31000 45240.0n 0.25000 45369.9n 0.25000 45370.0n 0.25000 45499.9n 0.25000 45500.0n 0.25000 45629.9n 0.25000 45630.0n 0.25000 45759.9n 0.25000 45760.0n 0.25000 45889.9n 0.25000 45890.0n 0.31000 46019.9n 0.31000 46020.0n 0.31000 46149.9n 0.31000 46150.0n 0.31000 46279.9n 0.31000 46280.0n 0.31000 46409.9n 0.31000 46410.0n 0.25000 46539.9n 0.25000 46540.0n 0.25000 46669.9n 0.25000 46670.0n 0.31000 46799.9n 0.31000 46800.0n 0.25000 46929.9n 0.25000 46930.0n 0.31000 47059.9n 0.31000 47060.0n 0.31000 47189.9n 0.31000 47190.0n 0.25000 47319.9n 0.25000 47320.0n 0.25000 47449.9n 0.25000 47450.0n 0.25000 47579.9n 0.25000 47580.0n 0.25000 47709.9n 0.25000 47710.0n 0.25000 47839.9n 0.25000 47840.0n 0.25000 47969.9n 0.25000 47970.0n 0.31000 48099.9n 0.31000 48100.0n 0.25000 48229.9n 0.25000 48230.0n 0.31000 48359.9n 0.31000 48360.0n 0.25000 48489.9n 0.25000 48490.0n 0.31000 48619.9n 0.31000 48620.0n 0.31000 48749.9n 0.31000 48750.0n 0.31000 48879.9n 0.31000 48880.0n 0.31000 49009.9n 0.31000 49010.0n 0.31000 49139.9n 0.31000 49140.0n 0.25000 49269.9n 0.25000 49270.0n 0.31000 49399.9n 0.31000 49400.0n 0.25000 49529.9n 0.25000 49530.0n 0.31000 49659.9n 0.31000 49660.0n 0.25000 49789.9n 0.25000 49790.0n 0.31000 49919.9n 0.31000 49920.0n 0.28000 50049.9n 0.28000 50050.0n 0.28000 50179.9n 0.28000 50180.0n 0.28000 50309.9n 0.28000 50310.0n 0.28000 50439.9n 0.28000 50440.0n 0.28000 50569.9n 0.28000 50570.0n 0.28000 50699.9n 0.28000 50700.0n 0.28000 50829.9n 0.28000 50830.0n 0.28000 50959.9n 0.28000 50960.0n 0.28000 51089.9n 0.28000 51090.0n 0.28000 51219.9n 0.28000 51220.0n 0.28000 51349.9n 0.28000 51350.0n 0.28000 51479.9n 0.28000 51480.0n 0.28000 51609.9n 0.28000 51610.0n 0.28000 51739.9n 0.28000 51740.0n 0.28000 51869.9n 0.28000 51870.0n 0.28000 51999.9n 0.28000 52000.0n 0.28000 52129.9n 0.28000 52130.0n 0.28000 52259.9n 0.28000 52260.0n 0.28000 52389.9n 0.28000 52390.0n 0.28000 52519.9n 0.28000 52520.0n 0.28000 52649.9n 0.28000 52650.0n 0.28000 52779.9n 0.28000 52780.0n 0.28000 52909.9n 0.28000 52910.0n 0.28000 53039.9n 0.28000 53040.0n 0.28000 53169.9n 0.28000 53170.0n 0.28000 53299.9n 0.28000 53300.0n 0.28000 53429.9n 0.28000 53430.0n 0.28000 53559.9n 0.28000 53560.0n 0.28000 53689.9n 0.28000 53690.0n 0.28000 53819.9n 0.28000 53820.0n 0.28000 53949.9n 0.28000 53950.0n 0.28000 54079.9n 0.28000 54080.0n 0.28000 54209.9n 0.28000 54210.0n 0.28000 54339.9n 0.28000 54340.0n 0.28000 54469.9n 0.28000 54470.0n 0.28000 54599.9n 0.28000 54600.0n 0.28000 54729.9n 0.28000 54730.0n 0.28000 54859.9n 0.28000 54860.0n 0.28000 54989.9n 0.28000 54990.0n 0.28000 55119.9n 0.28000 55120.0n 0.28000 55249.9n 0.28000 55250.0n 0.28000 55379.9n 0.28000 55380.0n 0.28000 55509.9n 0.28000 55510.0n 0.28000 55639.9n 0.28000 55640.0n 0.28000 55769.9n 0.28000 55770.0n 0.28000 55899.9n 0.28000 55900.0n 0.28000 56029.9n 0.28000 56030.0n 0.28000 56159.9n 0.28000 56160.0n 0.25000 56289.9n 0.25000 56290.0n 0.25000 56419.9n 0.25000 56420.0n 0.31000 56549.9n 0.31000 56550.0n 0.31000 56679.9n 0.31000 56680.0n 0.31000 56809.9n 0.31000 56810.0n 0.25000 56939.9n 0.25000 56940.0n 0.25000 57069.9n 0.25000 57070.0n 0.31000 57199.9n 0.31000 57200.0n 0.31000 57329.9n 0.31000 57330.0n 0.31000 57459.9n 0.31000 57460.0n 0.25000 57589.9n 0.25000 57590.0n 0.25000 57719.9n 0.25000 57720.0n 0.25000 57849.9n 0.25000 57850.0n 0.31000 57979.9n 0.31000 57980.0n 0.25000 58109.9n 0.25000 58110.0n 0.25000 58239.9n 0.25000 58240.0n 0.25000 58369.9n 0.25000 58370.0n 0.31000 58499.9n 0.31000 58500.0n 0.25000 58629.9n 0.25000 58630.0n 0.31000 58759.9n 0.31000 58760.0n 0.31000 58889.9n 0.31000 58890.0n 0.31000 59019.9n 0.31000 59020.0n 0.31000 59149.9n 0.31000 59150.0n 0.31000 59279.9n 0.31000 59280.0n 0.25000 59409.9n 0.25000 59410.0n 0.25000 59539.9n 0.25000 59540.0n 0.25000 59669.9n 0.25000 59670.0n 0.31000 59799.9n 0.31000 59800.0n 0.31000 59929.9n 0.31000 59930.0n 0.25000 60059.9n 0.25000 60060.0n 0.31000 60189.9n 0.31000 60190.0n 0.25000 60319.9n 0.25000 60320.0n 0.25000 60449.9n 0.25000 60450.0n 0.25000 60579.9n 0.25000 60580.0n 0.25000 60709.9n 0.25000 60710.0n 0.31000 60839.9n 0.31000 60840.0n 0.25000 60969.9n 0.25000 60970.0n 0.25000 61099.9n 0.25000 61100.0n 0.25000 61229.9n 0.25000 61230.0n 0.31000 61359.9n 0.31000 61360.0n 0.31000 61489.9n 0.31000 61490.0n 0.25000 61619.9n 0.25000 61620.0n 0.25000 61749.9n 0.25000 61750.0n 0.31000 61879.9n 0.31000 61880.0n 0.25000 62009.9n 0.25000 62010.0n 0.25000 62139.9n 0.25000 62140.0n 0.25000 62269.9n 0.25000 62270.0n 0.31000 62399.9n 0.31000 62400.0n 0.31000 62529.9n 0.31000 62530.0n 0.31000 62659.9n 0.31000 62660.0n 0.31000 62789.9n 0.31000 62790.0n 0.31000 62919.9n 0.31000 62920.0n 0.31000 63049.9n 0.31000 63050.0n 0.31000 63179.9n 0.31000 63180.0n 0.31000 63309.9n 0.31000 63310.0n 0.25000 63439.9n 0.25000 63440.0n 0.31000 63569.9n 0.31000 63570.0n 0.25000 63699.9n 0.25000 63700.0n 0.31000 63829.9n 0.31000 63830.0n 0.31000 63959.9n 0.31000 63960.0n 0.31000 64089.9n 0.31000 64090.0n 0.25000 64219.9n 0.25000 64220.0n 0.31000 64349.9n 0.31000 64350.0n 0.25000 64479.9n 0.25000 64480.0n 0.31000 64609.9n 0.31000 64610.0n 0.25000 64739.9n 0.25000 64740.0n 0.31000 64869.9n 0.31000 64870.0n 0.31000 64999.9n 0.31000 65000.0n 0.31000 65129.9n 0.31000 65130.0n 0.25000 65259.9n 0.25000 65260.0n 0.31000 65389.9n 0.31000 65390.0n 0.31000 65519.9n 0.31000 65520.0n 0.25000 65649.9n 0.25000 65650.0n 0.25000 65779.9n 0.25000 65780.0n 0.25000 65909.9n 0.25000 65910.0n 0.25000 66039.9n 0.25000 66040.0n 0.25000 66169.9n 0.25000 66170.0n 0.25000 66299.9n 0.25000 66300.0n 0.25000 66429.9n 0.25000 66430.0n 0.25000 66559.9n 0.25000 66560.0n 0.31000 66689.9n 0.31000 66690.0n 0.25000 66819.9n 0.25000 66820.0n 0.31000 66949.9n 0.31000 66950.0n 0.31000 67079.9n 0.31000 67080.0n 0.25000 67209.9n 0.25000 67210.0n 0.31000 67339.9n 0.31000 67340.0n 0.31000 67469.9n 0.31000 67470.0n 0.31000 67599.9n 0.31000 67600.0n 0.25000 67729.9n 0.25000 67730.0n 0.25000 67859.9n 0.25000 67860.0n 0.31000 67989.9n 0.31000 67990.0n 0.31000 68119.9n 0.31000 68120.0n 0.25000 68249.9n 0.25000 68250.0n 0.25000 68379.9n 0.25000 68380.0n 0.25000 68509.9n 0.25000 68510.0n 0.31000 68639.9n 0.31000 68640.0n 0.25000 68769.9n 0.25000 68770.0n 0.25000 68899.9n 0.25000 68900.0n 0.31000 69029.9n 0.31000 69030.0n 0.31000 69159.9n 0.31000 69160.0n 0.25000 69289.9n 0.25000 69290.0n 0.31000 69419.9n 0.31000 69420.0n 0.31000 69549.9n 0.31000 69550.0n 0.31000 69679.9n 0.31000 69680.0n 0.25000 69809.9n 0.25000 69810.0n 0.25000 69939.9n 0.25000 69940.0n 0.25000 70069.9n 0.25000 70070.0n 0.31000 70199.9n 0.31000 70200.0n 0.31000 70329.9n 0.31000 70330.0n 0.25000 70459.9n 0.25000 70460.0n 0.31000 70589.9n 0.31000 70590.0n 0.25000 70719.9n 0.25000 70720.0n 0.31000 70849.9n 0.31000 70850.0n 0.25000 70979.9n 0.25000 70980.0n 0.31000 71109.9n 0.31000 71110.0n 0.25000 71239.9n 0.25000 71240.0n 0.31000 71369.9n 0.31000 71370.0n 0.25000 71499.9n 0.25000 71500.0n 0.31000 71629.9n 0.31000 71630.0n 0.31000 71759.9n 0.31000 71760.0n 0.25000 71889.9n 0.25000 71890.0n 0.25000 72019.9n 0.25000 72020.0n 0.25000 72149.9n 0.25000 72150.0n 0.31000 72279.9n 0.31000 72280.0n 0.25000 72409.9n 0.25000 72410.0n 0.31000 72539.9n 0.31000 72540.0n 0.31000 72669.9n 0.31000 72670.0n 0.31000 72799.9n 0.31000 72800.0n 0.31000 72929.9n 0.31000 72930.0n 0.25000 73059.9n 0.25000 73060.0n 0.25000 73189.9n 0.25000 73190.0n 0.25000 73319.9n 0.25000 73320.0n 0.25000 73449.9n 0.25000 73450.0n 0.31000 73579.9n 0.31000 73580.0n 0.31000 73709.9n 0.31000 73710.0n 0.25000 73839.9n 0.25000 73840.0n 0.31000 73969.9n 0.31000 73970.0n 0.31000 74099.9n 0.31000 74100.0n 0.25000 74229.9n 0.25000 74230.0n 0.25000 74359.9n 0.25000 74360.0n 0.31000 74489.9n 0.31000 74490.0n 0.31000 74619.9n 0.31000 74620.0n 0.31000 74749.9n 0.31000 74750.0n 0.25000 74879.9n 0.25000 74880.0n 0.25000 75009.9n 0.25000 75010.0n 0.25000 75139.9n 0.25000 75140.0n 0.31000 75269.9n 0.31000 75270.0n 0.31000 75399.9n 0.31000 75400.0n 0.25000 75529.9n 0.25000 75530.0n 0.25000 75659.9n 0.25000 75660.0n 0.31000 75789.9n 0.31000 75790.0n 0.25000 75919.9n 0.25000 75920.0n 0.25000 76049.9n 0.25000 76050.0n 0.25000 76179.9n 0.25000 76180.0n 0.31000 76309.9n 0.31000 76310.0n 0.31000 76439.9n 0.31000 76440.0n 0.25000 76569.9n 0.25000 76570.0n 0.31000 76699.9n 0.31000 76700.0n 0.25000 76829.9n 0.25000 76830.0n 0.31000 76959.9n 0.31000 76960.0n 0.31000 77089.9n 0.31000 77090.0n 0.25000 77219.9n 0.25000 77220.0n 0.25000 77349.9n 0.25000 77350.0n 0.25000 77479.9n 0.25000 77480.0n 0.31000 77609.9n 0.31000 77610.0n 0.31000 77739.9n 0.31000 77740.0n 0.25000 77869.9n 0.25000 77870.0n 0.31000 77999.9n 0.31000 78000.0n 0.28000 78129.9n 0.28000 78130.0n 0.28000 78259.9n 0.28000 78260.0n 0.28000 78389.9n 0.28000 78390.0n 0.28000 78519.9n 0.28000 78520.0n 0.28000 78649.9n 0.28000 78650.0n 0.28000 78779.9n 0.28000 78780.0n 0.28000 78909.9n 0.28000 78910.0n 0.28000 79039.9n 0.28000 79040.0n 0.28000 79169.9n 0.28000 79170.0n 0.28000 79299.9n 0.28000 79300.0n 0.28000 79429.9n 0.28000 79430.0n 0.28000 79559.9n 0.28000 79560.0n 0.28000 79689.9n 0.28000 79690.0n 0.28000 79819.9n 0.28000 79820.0n 0.28000 79949.9n 0.28000 79950.0n 0.28000 80079.9n 0.28000 80080.0n 0.28000 80209.9n 0.28000 80210.0n 0.28000 80339.9n 0.28000 80340.0n 0.28000 80469.9n 0.28000 80470.0n 0.28000 80599.9n 0.28000 80600.0n 0.28000 80729.9n 0.28000 80730.0n 0.28000 80859.9n 0.28000 80860.0n 0.28000 80989.9n 0.28000 80990.0n 0.28000 81119.9n 0.28000 81120.0n 0.28000 81249.9n 0.28000 81250.0n 0.28000 81379.9n 0.28000 81380.0n 0.28000 81509.9n 0.28000 81510.0n 0.28000 81639.9n 0.28000 81640.0n 0.28000 81769.9n 0.28000 81770.0n 0.28000 81899.9n 0.28000 81900.0n 0.28000 82029.9n 0.28000 82030.0n 0.28000 82159.9n 0.28000 82160.0n 0.28000 82289.9n 0.28000 82290.0n 0.28000 82419.9n 0.28000 82420.0n 0.28000 82549.9n 0.28000 82550.0n 0.28000 82679.9n 0.28000 82680.0n 0.28000 82809.9n 0.28000 82810.0n 0.28000 82939.9n 0.28000 82940.0n 0.28000 83069.9n 0.28000 83070.0n 0.28000 83199.9n 0.28000 83200.0n 0.28000 83329.9n 0.28000 83330.0n 0.28000 83459.9n 0.28000 83460.0n 0.28000 83589.9n 0.28000 83590.0n 0.28000 83719.9n 0.28000 83720.0n 0.28000 83849.9n 0.28000 83850.0n 0.28000 83979.9n 0.28000 83980.0n 0.28000 84109.9n 0.28000 84110.0n 0.28000 84239.9n 0.28000 84240.0n 0.25000 84369.9n 0.25000 84370.0n 0.25000 84499.9n 0.25000 84500.0n 0.25000 84629.9n 0.25000 84630.0n 0.31000 84759.9n 0.31000 84760.0n 0.25000 84889.9n 0.25000 84890.0n 0.25000 85019.9n 0.25000 85020.0n 0.31000 85149.9n 0.31000 85150.0n 0.31000 85279.9n 0.31000 85280.0n 0.25000 85409.9n 0.25000 85410.0n 0.25000 85539.9n 0.25000 85540.0n 0.25000 85669.9n 0.25000 85670.0n 0.31000 85799.9n 0.31000 85800.0n 0.25000 85929.9n 0.25000 85930.0n 0.31000 86059.9n 0.31000 86060.0n 0.31000 86189.9n 0.31000 86190.0n 0.31000 86319.9n 0.31000 86320.0n 0.25000 86449.9n 0.25000 86450.0n 0.25000 86579.9n 0.25000 86580.0n 0.31000 86709.9n 0.31000 86710.0n 0.31000 86839.9n 0.31000 86840.0n 0.31000 86969.9n 0.31000 86970.0n 0.31000 87099.9n 0.31000 87100.0n 0.31000 87229.9n 0.31000 87230.0n 0.31000 87359.9n 0.31000 87360.0n 0.25000 87489.9n 0.25000 87490.0n 0.31000 87619.9n 0.31000 87620.0n 0.25000 87749.9n 0.25000 87750.0n 0.25000 87879.9n 0.25000 87880.0n 0.25000 88009.9n 0.25000 88010.0n 0.31000 88139.9n 0.31000 88140.0n 0.25000 88269.9n 0.25000 88270.0n 0.25000 88399.9n 0.25000 88400.0n 0.31000 88529.9n 0.31000 88530.0n 0.25000 88659.9n 0.25000 88660.0n 0.31000 88789.9n 0.31000 88790.0n 0.25000 88919.9n 0.25000 88920.0n 0.25000 89049.9n 0.25000 89050.0n 0.25000 89179.9n 0.25000 89180.0n 0.25000 89309.9n 0.25000 89310.0n 0.31000 89439.9n 0.31000 89440.0n 0.31000 89569.9n 0.31000 89570.0n 0.31000 89699.9n 0.31000 89700.0n 0.31000 89829.9n 0.31000 89830.0n 0.31000 89959.9n 0.31000 89960.0n 0.31000 90089.9n 0.31000 90090.0n 0.25000 90219.9n 0.25000 90220.0n 0.25000 90349.9n 0.25000 90350.0n 0.31000 90479.9n 0.31000 90480.0n 0.25000 90609.9n 0.25000 90610.0n 0.25000 90739.9n 0.25000 90740.0n 0.31000 90869.9n 0.31000 90870.0n 0.31000 90999.9n 0.31000 91000.0n 0.31000 91129.9n 0.31000 91130.0n 0.31000 91259.9n 0.31000 91260.0n 0.25000 91389.9n 0.25000 91390.0n 0.25000 91519.9n 0.25000 91520.0n 0.31000 91649.9n 0.31000 91650.0n 0.31000 91779.9n 0.31000 91780.0n 0.31000 91909.9n 0.31000 91910.0n 0.25000 92039.9n 0.25000 92040.0n 0.25000 92169.9n 0.25000 92170.0n 0.31000 92299.9n 0.31000 92300.0n 0.31000 92429.9n 0.31000 92430.0n 0.25000 92559.9n 0.25000 92560.0n 0.31000 92689.9n 0.31000 92690.0n 0.25000 92819.9n 0.25000 92820.0n 0.25000 92949.9n 0.25000 92950.0n 0.25000 93079.9n 0.25000 93080.0n 0.31000 93209.9n 0.31000 93210.0n 0.25000 93339.9n 0.25000 93340.0n 0.31000 93469.9n 0.31000 93470.0n 0.31000 93599.9n 0.31000 93600.0n 0.25000 93729.9n 0.25000 93730.0n 0.25000 93859.9n 0.25000 93860.0n 0.31000 93989.9n 0.31000 93990.0n 0.25000 94119.9n 0.25000 94120.0n 0.31000 94249.9n 0.31000 94250.0n 0.25000 94379.9n 0.25000 94380.0n 0.31000 94509.9n 0.31000 94510.0n 0.31000 94639.9n 0.31000 94640.0n 0.31000 94769.9n 0.31000 94770.0n 0.25000 94899.9n 0.25000 94900.0n 0.25000 95029.9n 0.25000 95030.0n 0.25000 95159.9n 0.25000 95160.0n 0.25000 95289.9n 0.25000 95290.0n 0.25000 95419.9n 0.25000 95420.0n 0.31000 95549.9n 0.31000 95550.0n 0.31000 95679.9n 0.31000 95680.0n 0.25000 95809.9n 0.25000 95810.0n 0.25000 95939.9n 0.25000 95940.0n 0.31000 96069.9n 0.31000 96070.0n 0.31000 96199.9n 0.31000 96200.0n 0.25000 96329.9n 0.25000 96330.0n 0.31000 96459.9n 0.31000 96460.0n 0.31000 96589.9n 0.31000 96590.0n 0.25000 96719.9n 0.25000 96720.0n 0.31000 96849.9n 0.31000 96850.0n 0.25000 96979.9n 0.25000 96980.0n 0.25000 97109.9n 0.25000 97110.0n 0.25000 97239.9n 0.25000 97240.0n 0.31000 97369.9n 0.31000 97370.0n 0.31000 97499.9n 0.31000 97500.0n 0.31000 97629.9n 0.31000 97630.0n 0.31000 97759.9n 0.31000 97760.0n 0.31000 97889.9n 0.31000 97890.0n 0.25000 98019.9n 0.25000 98020.0n 0.25000 98149.9n 0.25000 98150.0n 0.25000 98279.9n 0.25000 98280.0n 0.25000 98409.9n 0.25000 98410.0n 0.31000 98539.9n 0.31000 98540.0n 0.31000 98669.9n 0.31000 98670.0n 0.25000 98799.9n 0.25000 98800.0n 0.31000 98929.9n 0.31000 98930.0n 0.25000 99059.9n 0.25000 99060.0n 0.25000 99189.9n 0.25000 99190.0n 0.25000 99319.9n 0.25000 99320.0n 0.31000 99449.9n 0.31000 99450.0n 0.25000 99579.9n 0.25000 99580.0n 0.31000 99709.9n 0.31000 99710.0n 0.25000 99839.9n 0.25000 99840.0n 0.31000 99969.9n 0.31000 99970.0n 0.31000 100099.9n 0.31000 100100.0n 0.31000 100229.9n 0.31000 100230.0n 0.31000 100359.9n 0.31000 100360.0n 0.31000 100489.9n 0.31000 100490.0n 0.25000 100619.9n 0.25000 100620.0n 0.31000 100749.9n 0.31000 100750.0n 0.25000 100879.9n 0.25000 100880.0n 0.31000 101009.9n 0.31000 101010.0n 0.25000 101139.9n 0.25000 101140.0n 0.31000 101269.9n 0.31000 101270.0n 0.31000 101399.9n 0.31000 101400.0n 0.25000 101529.9n 0.25000 101530.0n 0.25000 101659.9n 0.25000 101660.0n 0.25000 101789.9n 0.25000 101790.0n 0.31000 101919.9n 0.31000 101920.0n 0.25000 102049.9n 0.25000 102050.0n 0.25000 102179.9n 0.25000 102180.0n 0.31000 102309.9n 0.31000 102310.0n 0.25000 102439.9n 0.25000 102440.0n 0.25000 102569.9n 0.25000 102570.0n 0.25000 102699.9n 0.25000 102700.0n 0.31000 102829.9n 0.31000 102830.0n 0.31000 102959.9n 0.31000 102960.0n 0.31000 103089.9n 0.31000 103090.0n 0.31000 103219.9n 0.31000 103220.0n 0.25000 103349.9n 0.25000 103350.0n 0.25000 103479.9n 0.25000 103480.0n 0.25000 103609.9n 0.25000 103610.0n 0.31000 103739.9n 0.31000 103740.0n 0.25000 103869.9n 0.25000 103870.0n 0.25000 103999.9n 0.25000 104000.0n 0.25000 104129.9n 0.25000 104130.0n 0.25000 104259.9n 0.25000 104260.0n 0.25000 104389.9n 0.25000 104390.0n 0.31000 104519.9n 0.31000 104520.0n 0.31000 104649.9n 0.31000 104650.0n 0.31000 104779.9n 0.31000 104780.0n 0.31000 104909.9n 0.31000 104910.0n 0.31000 105039.9n 0.31000 105040.0n 0.25000 105169.9n 0.25000 105170.0n 0.31000 105299.9n 0.31000 105300.0n 0.25000 105429.9n 0.25000 105430.0n 0.25000 105559.9n 0.25000 105560.0n 0.31000 105689.9n 0.31000 105690.0n 0.25000 105819.9n 0.25000 105820.0n 0.31000 105949.9n 0.31000 105950.0n 0.31000 106079.9n 0.31000 106080.0n 0.28000 106209.9n 0.28000 106210.0n 0.28000 106339.9n 0.28000 106340.0n 0.28000 106469.9n 0.28000 106470.0n 0.28000 106599.9n 0.28000 106600.0n 0.28000 106729.9n 0.28000 106730.0n 0.28000 106859.9n 0.28000 106860.0n 0.28000 106989.9n 0.28000 106990.0n 0.28000 107119.9n 0.28000 107120.0n 0.28000 107249.9n 0.28000 107250.0n 0.28000 107379.9n 0.28000 107380.0n 0.28000 107509.9n 0.28000 107510.0n 0.28000 107639.9n 0.28000 107640.0n 0.28000 107769.9n 0.28000 107770.0n 0.28000 107899.9n 0.28000 107900.0n 0.28000 108029.9n 0.28000 108030.0n 0.28000 108159.9n 0.28000 108160.0n 0.28000 108289.9n 0.28000 108290.0n 0.28000 108419.9n 0.28000 108420.0n 0.28000 108549.9n 0.28000 108550.0n 0.28000 108679.9n 0.28000 108680.0n 0.28000 108809.9n 0.28000 108810.0n 0.28000 108939.9n 0.28000 108940.0n 0.28000 109069.9n 0.28000 109070.0n 0.28000 109199.9n 0.28000 109200.0n 0.28000 109329.9n 0.28000 109330.0n 0.28000 109459.9n 0.28000 109460.0n 0.28000 109589.9n 0.28000 109590.0n 0.28000 109719.9n 0.28000 109720.0n 0.28000 109849.9n 0.28000 109850.0n 0.28000 109979.9n 0.28000 109980.0n 0.28000 110109.9n 0.28000 110110.0n 0.28000 110239.9n 0.28000 110240.0n 0.28000 110369.9n 0.28000 110370.0n 0.28000 110499.9n 0.28000 110500.0n 0.28000 110629.9n 0.28000 110630.0n 0.28000 110759.9n 0.28000 110760.0n 0.28000 110889.9n 0.28000 110890.0n 0.28000 111019.9n 0.28000 111020.0n 0.28000 111149.9n 0.28000 111150.0n 0.28000 111279.9n 0.28000 111280.0n 0.28000 111409.9n 0.28000 111410.0n 0.28000 111539.9n 0.28000 111540.0n 0.28000 111669.9n 0.28000 111670.0n 0.28000 111799.9n 0.28000 111800.0n 0.28000 111929.9n 0.28000 111930.0n 0.28000 112059.9n 0.28000 112060.0n 0.28000 112189.9n 0.28000 112190.0n 0.28000 112319.9n 0.28000 112320.0n 0.25000 112449.9n 0.25000 112450.0n 0.25000 112579.9n 0.25000 112580.0n 0.31000 112709.9n 0.31000 112710.0n 0.25000 112839.9n 0.25000 112840.0n 0.31000 112969.9n 0.31000 112970.0n 0.25000 113099.9n 0.25000 113100.0n 0.25000 113229.9n 0.25000 113230.0n 0.31000 113359.9n 0.31000 113360.0n 0.31000 113489.9n 0.31000 113490.0n 0.31000 113619.9n 0.31000 113620.0n 0.25000 113749.9n 0.25000 113750.0n 0.31000 113879.9n 0.31000 113880.0n 0.31000 114009.9n 0.31000 114010.0n 0.25000 114139.9n 0.25000 114140.0n 0.25000 114269.9n 0.25000 114270.0n 0.25000 114399.9n 0.25000 114400.0n 0.25000 114529.9n 0.25000 114530.0n 0.31000 114659.9n 0.31000 114660.0n 0.25000 114789.9n 0.25000 114790.0n 0.31000 114919.9n 0.31000 114920.0n 0.31000 115049.9n 0.31000 115050.0n 0.31000 115179.9n 0.31000 115180.0n 0.25000 115309.9n 0.25000 115310.0n 0.31000 115439.9n 0.31000 115440.0n 0.25000 115569.9n 0.25000 115570.0n 0.31000 115699.9n 0.31000 115700.0n 0.25000 115829.9n 0.25000 115830.0n 0.31000 115959.9n 0.31000 115960.0n 0.31000 116089.9n 0.31000 116090.0n 0.25000 116219.9n 0.25000 116220.0n 0.25000 116349.9n 0.25000 116350.0n 0.31000 116479.9n 0.31000 116480.0n 0.25000 116609.9n 0.25000 116610.0n 0.25000 116739.9n 0.25000 116740.0n 0.25000 116869.9n 0.25000 116870.0n 0.25000 116999.9n 0.25000 117000.0n 0.31000 117129.9n 0.31000 117130.0n 0.25000 117259.9n 0.25000 117260.0n 0.31000 117389.9n 0.31000 117390.0n 0.25000 117519.9n 0.25000 117520.0n 0.25000 117649.9n 0.25000 117650.0n 0.31000 117779.9n 0.31000 117780.0n 0.25000 117909.9n 0.25000 117910.0n 0.31000 118039.9n 0.31000 118040.0n 0.31000 118169.9n 0.31000 118170.0n 0.25000 118299.9n 0.25000 118300.0n 0.31000 118429.9n 0.31000 118430.0n 0.31000 118559.9n 0.31000 118560.0n 0.31000 118689.9n 0.31000 118690.0n 0.31000 118819.9n 0.31000 118820.0n 0.25000 118949.9n 0.25000 118950.0n 0.31000 119079.9n 0.31000 119080.0n 0.25000 119209.9n 0.25000 119210.0n 0.25000 119339.9n 0.25000 119340.0n 0.31000 119469.9n 0.31000 119470.0n 0.31000 119599.9n 0.31000 119600.0n 0.25000 119729.9n 0.25000 119730.0n 0.31000 119859.9n 0.31000 119860.0n 0.31000 119989.9n 0.31000 119990.0n 0.31000 120119.9n 0.31000 120120.0n 0.25000 120249.9n 0.25000 120250.0n 0.31000 120379.9n 0.31000 120380.0n 0.25000 120509.9n 0.25000 120510.0n 0.25000 120639.9n 0.25000 120640.0n 0.31000 120769.9n 0.31000 120770.0n 0.31000 120899.9n 0.31000 120900.0n 0.25000 121029.9n 0.25000 121030.0n 0.25000 121159.9n 0.25000 121160.0n 0.31000 121289.9n 0.31000 121290.0n 0.25000 121419.9n 0.25000 121420.0n 0.25000 121549.9n 0.25000 121550.0n 0.31000 121679.9n 0.31000 121680.0n 0.31000 121809.9n 0.31000 121810.0n 0.25000 121939.9n 0.25000 121940.0n 0.31000 122069.9n 0.31000 122070.0n 0.31000 122199.9n 0.31000 122200.0n 0.25000 122329.9n 0.25000 122330.0n 0.25000 122459.9n 0.25000 122460.0n 0.25000 122589.9n 0.25000 122590.0n 0.31000 122719.9n 0.31000 122720.0n 0.31000 122849.9n 0.31000 122850.0n 0.25000 122979.9n 0.25000 122980.0n 0.31000 123109.9n 0.31000 123110.0n 0.25000 123239.9n 0.25000 123240.0n 0.25000 123369.9n 0.25000 123370.0n 0.25000 123499.9n 0.25000 123500.0n 0.31000 123629.9n 0.31000 123630.0n 0.31000 123759.9n 0.31000 123760.0n 0.25000 123889.9n 0.25000 123890.0n 0.25000 124019.9n 0.25000 124020.0n 0.31000 124149.9n 0.31000 124150.0n 0.31000 124279.9n 0.31000 124280.0n 0.31000 124409.9n 0.31000 124410.0n 0.25000 124539.9n 0.25000 124540.0n 0.25000 124669.9n 0.25000 124670.0n 0.31000 124799.9n 0.31000 124800.0n 0.31000 124929.9n 0.31000 124930.0n 0.25000 125059.9n 0.25000 125060.0n 0.31000 125189.9n 0.31000 125190.0n 0.31000 125319.9n 0.31000 125320.0n 0.25000 125449.9n 0.25000 125450.0n 0.25000 125579.9n 0.25000 125580.0n 0.31000 125709.9n 0.31000 125710.0n 0.31000 125839.9n 0.31000 125840.0n 0.25000 125969.9n 0.25000 125970.0n 0.25000 126099.9n 0.25000 126100.0n 0.31000 126229.9n 0.31000 126230.0n 0.31000 126359.9n 0.31000 126360.0n 0.25000 126489.9n 0.25000 126490.0n 0.25000 126619.9n 0.25000 126620.0n 0.31000 126749.9n 0.31000 126750.0n 0.25000 126879.9n 0.25000 126880.0n 0.31000 127009.9n 0.31000 127010.0n 0.31000 127139.9n 0.31000 127140.0n 0.25000 127269.9n 0.25000 127270.0n 0.31000 127399.9n 0.31000 127400.0n 0.25000 127529.9n 0.25000 127530.0n 0.25000 127659.9n 0.25000 127660.0n 0.31000 127789.9n 0.31000 127790.0n 0.31000 127919.9n 0.31000 127920.0n 0.25000 128049.9n 0.25000 128050.0n 0.25000 128179.9n 0.25000 128180.0n 0.31000 128309.9n 0.31000 128310.0n 0.31000 128439.9n 0.31000 128440.0n 0.31000 128569.9n 0.31000 128570.0n 0.31000 128699.9n 0.31000 128700.0n 0.25000 128829.9n 0.25000 128830.0n 0.25000 128959.9n 0.25000 128960.0n 0.25000 129089.9n 0.25000 129090.0n 0.25000 129219.9n 0.25000 129220.0n 0.25000 129349.9n 0.25000 129350.0n 0.25000 129479.9n 0.25000 129480.0n 0.31000 129609.9n 0.31000 129610.0n 0.25000 129739.9n 0.25000 129740.0n 0.31000 129869.9n 0.31000 129870.0n 0.31000 129999.9n 0.31000 130000.0n 0.31000 130129.9n 0.31000 130130.0n 0.31000 130259.9n 0.31000 130260.0n 0.25000 130389.9n 0.25000 130390.0n 0.25000 130519.9n 0.25000 130520.0n 0.31000 130649.9n 0.31000 130650.0n 0.25000 130779.9n 0.25000 130780.0n 0.25000 130909.9n 0.25000 130910.0n 0.31000 131039.9n 0.31000 131040.0n 0.31000 131169.9n 0.31000 131170.0n 0.31000 131299.9n 0.31000 131300.0n 0.31000 131429.9n 0.31000 131430.0n 0.31000 131559.9n 0.31000 131560.0n 0.25000 131689.9n 0.25000 131690.0n 0.25000 131819.9n 0.25000 131820.0n 0.25000 131949.9n 0.25000 131950.0n 0.31000 132079.9n 0.31000 132080.0n 0.25000 132209.9n 0.25000 132210.0n 0.31000 132339.9n 0.31000 132340.0n 0.25000 132469.9n 0.25000 132470.0n 0.31000 132599.9n 0.31000 132600.0n 0.31000 132729.9n 0.31000 132730.0n 0.25000 132859.9n 0.25000 132860.0n 0.25000 132989.9n 0.25000 132990.0n 0.25000 133119.9n 0.25000 133120.0n 0.25000 133249.9n 0.25000 133250.0n 0.25000 133379.9n 0.25000 133380.0n 0.31000 133509.9n 0.31000 133510.0n 0.31000 133639.9n 0.31000 133640.0n 0.25000 133769.9n 0.25000 133770.0n 0.31000 133899.9n 0.31000 133900.0n 0.25000 134029.9n 0.25000 134030.0n 0.31000 134159.9n 0.31000 134160.0n 0.28000 134289.9n 0.28000 134290.0n 0.28000 134419.9n 0.28000 134420.0n 0.28000 134549.9n 0.28000 134550.0n 0.28000 134679.9n 0.28000 134680.0n 0.28000 134809.9n 0.28000 134810.0n 0.28000 134939.9n 0.28000 134940.0n 0.28000 135069.9n 0.28000 135070.0n 0.28000 135199.9n 0.28000 135200.0n 0.28000 135329.9n 0.28000 135330.0n 0.28000 135459.9n 0.28000 135460.0n 0.28000 135589.9n 0.28000 135590.0n 0.28000 135719.9n 0.28000 135720.0n 0.28000 135849.9n 0.28000 135850.0n 0.28000 135979.9n 0.28000 135980.0n 0.28000 136109.9n 0.28000 136110.0n 0.28000 136239.9n 0.28000 136240.0n 0.28000 136369.9n 0.28000 136370.0n 0.28000 136499.9n 0.28000 136500.0n 0.28000 136629.9n 0.28000 136630.0n 0.28000 136759.9n 0.28000 136760.0n 0.28000 136889.9n 0.28000 136890.0n 0.28000 137019.9n 0.28000 137020.0n 0.28000 137149.9n 0.28000 137150.0n 0.28000 137279.9n 0.28000 137280.0n 0.28000 137409.9n 0.28000 137410.0n 0.28000 137539.9n 0.28000 137540.0n 0.28000 137669.9n 0.28000 137670.0n 0.28000 137799.9n 0.28000 137800.0n 0.28000 137929.9n 0.28000 137930.0n 0.28000 138059.9n 0.28000 138060.0n 0.28000 138189.9n 0.28000 138190.0n 0.28000 138319.9n 0.28000 138320.0n 0.28000 138449.9n 0.28000 138450.0n 0.28000 138579.9n 0.28000 138580.0n 0.28000 138709.9n 0.28000 138710.0n 0.28000 138839.9n 0.28000 138840.0n 0.28000 138969.9n 0.28000 138970.0n 0.28000 139099.9n 0.28000 139100.0n 0.28000 139229.9n 0.28000 139230.0n 0.28000 139359.9n 0.28000 139360.0n 0.28000 139489.9n 0.28000 139490.0n 0.28000 139619.9n 0.28000 139620.0n 0.28000 139749.9n 0.28000 139750.0n 0.28000 139879.9n 0.28000 139880.0n 0.28000 140009.9n 0.28000 140010.0n 0.28000 140139.9n 0.28000 140140.0n 0.28000 140269.9n 0.28000 140270.0n 0.28000 140399.9n 0.28000 140400.0n 0.31000 140529.9n 0.31000 140530.0n 0.25000 140659.9n 0.25000 140660.0n 0.31000 140789.9n 0.31000 140790.0n 0.31000 140919.9n 0.31000 140920.0n 0.25000 141049.9n 0.25000 141050.0n 0.25000 141179.9n 0.25000 141180.0n 0.31000 141309.9n 0.31000 141310.0n 0.25000 141439.9n 0.25000 141440.0n 0.31000 141569.9n 0.31000 141570.0n 0.25000 141699.9n 0.25000 141700.0n 0.25000 141829.9n 0.25000 141830.0n 0.31000 141959.9n 0.31000 141960.0n 0.31000 142089.9n 0.31000 142090.0n 0.31000 142219.9n 0.31000 142220.0n 0.25000 142349.9n 0.25000 142350.0n 0.31000 142479.9n 0.31000 142480.0n 0.25000 142609.9n 0.25000 142610.0n 0.31000 142739.9n 0.31000 142740.0n 0.31000 142869.9n 0.31000 142870.0n 0.31000 142999.9n 0.31000 143000.0n 0.31000 143129.9n 0.31000 143130.0n 0.25000 143259.9n 0.25000 143260.0n 0.31000 143389.9n 0.31000 143390.0n 0.25000 143519.9n 0.25000 143520.0n 0.25000 143649.9n 0.25000 143650.0n 0.25000 143779.9n 0.25000 143780.0n 0.25000 143909.9n 0.25000 143910.0n 0.25000 144039.9n 0.25000 144040.0n 0.31000 144169.9n 0.31000 144170.0n 0.31000 144299.9n 0.31000 144300.0n 0.25000 144429.9n 0.25000 144430.0n 0.25000 144559.9n 0.25000 144560.0n 0.25000 144689.9n 0.25000 144690.0n 0.25000 144819.9n 0.25000 144820.0n 0.31000 144949.9n 0.31000 144950.0n 0.25000 145079.9n 0.25000 145080.0n 0.25000 145209.9n 0.25000 145210.0n 0.31000 145339.9n 0.31000 145340.0n 0.31000 145469.9n 0.31000 145470.0n 0.31000 145599.9n 0.31000 145600.0n 0.25000 145729.9n 0.25000 145730.0n 0.25000 145859.9n 0.25000 145860.0n 0.31000 145989.9n 0.31000 145990.0n 0.31000 146119.9n 0.31000 146120.0n 0.31000 146249.9n 0.31000 146250.0n 0.25000 146379.9n 0.25000 146380.0n 0.31000 146509.9n 0.31000 146510.0n 0.25000 146639.9n 0.25000 146640.0n 0.25000 146769.9n 0.25000 146770.0n 0.25000 146899.9n 0.25000 146900.0n 0.25000 147029.9n 0.25000 147030.0n 0.31000 147159.9n 0.31000 147160.0n 0.31000 147289.9n 0.31000 147290.0n 0.25000 147419.9n 0.25000 147420.0n 0.31000 147549.9n 0.31000 147550.0n 0.31000 147679.9n 0.31000 147680.0n 0.25000 147809.9n 0.25000 147810.0n 0.31000 147939.9n 0.31000 147940.0n 0.25000 148069.9n 0.25000 148070.0n 0.31000 148199.9n 0.31000 148200.0n 0.31000 148329.9n 0.31000 148330.0n 0.31000 148459.9n 0.31000 148460.0n 0.31000 148589.9n 0.31000 148590.0n 0.25000 148719.9n 0.25000 148720.0n 0.31000 148849.9n 0.31000 148850.0n 0.25000 148979.9n 0.25000 148980.0n 0.25000 149109.9n 0.25000 149110.0n 0.25000 149239.9n 0.25000 149240.0n 0.31000 149369.9n 0.31000 149370.0n 0.31000 149499.9n 0.31000 149500.0n 0.25000 149629.9n 0.25000 149630.0n 0.31000 149759.9n 0.31000 149760.0n 0.31000 149889.9n 0.31000 149890.0n 0.25000 150019.9n 0.25000 150020.0n 0.25000 150149.9n 0.25000 150150.0n 0.31000 150279.9n 0.31000 150280.0n 0.25000 150409.9n 0.25000 150410.0n 0.25000 150539.9n 0.25000 150540.0n 0.31000 150669.9n 0.31000 150670.0n 0.25000 150799.9n 0.25000 150800.0n 0.31000 150929.9n 0.31000 150930.0n 0.31000 151059.9n 0.31000 151060.0n 0.25000 151189.9n 0.25000 151190.0n 0.25000 151319.9n 0.25000 151320.0n 0.31000 151449.9n 0.31000 151450.0n 0.25000 151579.9n 0.25000 151580.0n 0.31000 151709.9n 0.31000 151710.0n 0.25000 151839.9n 0.25000 151840.0n 0.25000 151969.9n 0.25000 151970.0n 0.31000 152099.9n 0.31000 152100.0n 0.25000 152229.9n 0.25000 152230.0n 0.31000 152359.9n 0.31000 152360.0n 0.25000 152489.9n 0.25000 152490.0n 0.31000 152619.9n 0.31000 152620.0n 0.31000 152749.9n 0.31000 152750.0n 0.25000 152879.9n 0.25000 152880.0n 0.25000 153009.9n 0.25000 153010.0n 0.31000 153139.9n 0.31000 153140.0n 0.25000 153269.9n 0.25000 153270.0n 0.31000 153399.9n 0.31000 153400.0n 0.31000 153529.9n 0.31000 153530.0n 0.25000 153659.9n 0.25000 153660.0n 0.25000 153789.9n 0.25000 153790.0n 0.25000 153919.9n 0.25000 153920.0n 0.31000 154049.9n 0.31000 154050.0n 0.31000 154179.9n 0.31000 154180.0n 0.31000 154309.9n 0.31000 154310.0n 0.25000 154439.9n 0.25000 154440.0n 0.25000 154569.9n 0.25000 154570.0n 0.25000 154699.9n 0.25000 154700.0n 0.31000 154829.9n 0.31000 154830.0n 0.31000 154959.9n 0.31000 154960.0n 0.31000 155089.9n 0.31000 155090.0n 0.25000 155219.9n 0.25000 155220.0n 0.31000 155349.9n 0.31000 155350.0n 0.25000 155479.9n 0.25000 155480.0n 0.25000 155609.9n 0.25000 155610.0n 0.31000 155739.9n 0.31000 155740.0n 0.25000 155869.9n 0.25000 155870.0n 0.25000 155999.9n 0.25000 156000.0n 0.25000 156129.9n 0.25000 156130.0n 0.31000 156259.9n 0.31000 156260.0n 0.25000 156389.9n 0.25000 156390.0n 0.25000 156519.9n 0.25000 156520.0n 0.31000 156649.9n 0.31000 156650.0n 0.31000 156779.9n 0.31000 156780.0n 0.31000 156909.9n 0.31000 156910.0n 0.25000 157039.9n 0.25000 157040.0n 0.31000 157169.9n 0.31000 157170.0n 0.25000 157299.9n 0.25000 157300.0n 0.25000 157429.9n 0.25000 157430.0n 0.25000 157559.9n 0.25000 157560.0n 0.31000 157689.9n 0.31000 157690.0n 0.31000 157819.9n 0.31000 157820.0n 0.25000 157949.9n 0.25000 157950.0n 0.31000 158079.9n 0.31000 158080.0n 0.31000 158209.9n 0.31000 158210.0n 0.31000 158339.9n 0.31000 158340.0n 0.25000 158469.9n 0.25000 158470.0n 0.31000 158599.9n 0.31000 158600.0n 0.25000 158729.9n 0.25000 158730.0n 0.25000 158859.9n 0.25000 158860.0n 0.25000 158989.9n 0.25000 158990.0n 0.25000 159119.9n 0.25000 159120.0n 0.31000 159249.9n 0.31000 159250.0n 0.31000 159379.9n 0.31000 159380.0n 0.25000 159509.9n 0.25000 159510.0n 0.25000 159639.9n 0.25000 159640.0n 0.25000 159769.9n 0.25000 159770.0n 0.25000 159899.9n 0.25000 159900.0n 0.31000 160029.9n 0.31000 160030.0n 0.31000 160159.9n 0.31000 160160.0n 0.31000 160289.9n 0.31000 160290.0n 0.25000 160419.9n 0.25000 160420.0n 0.25000 160549.9n 0.25000 160550.0n 0.31000 160679.9n 0.31000 160680.0n 0.31000 160809.9n 0.31000 160810.0n 0.31000 160939.9n 0.31000 160940.0n 0.25000 161069.9n 0.25000 161070.0n 0.31000 161199.9n 0.31000 161200.0n 0.25000 161329.9n 0.25000 161330.0n 0.31000 161459.9n 0.31000 161460.0n 0.31000 161589.9n 0.31000 161590.0n 0.25000 161719.9n 0.25000 161720.0n 0.31000 161849.9n 0.31000 161850.0n 0.31000 161979.9n 0.31000 161980.0n 0.25000 162109.9n 0.25000 162110.0n 0.31000 162239.9n 0.31000 162240.0n 0.28000 162369.9n 0.28000 162370.0n 0.28000 162499.9n 0.28000 162500.0n 0.28000 162629.9n 0.28000 162630.0n 0.28000 162759.9n 0.28000 162760.0n 0.28000 162889.9n 0.28000 162890.0n 0.28000 163019.9n 0.28000 163020.0n 0.28000 163149.9n 0.28000 163150.0n 0.28000 163279.9n 0.28000 163280.0n 0.28000 163409.9n 0.28000 163410.0n 0.28000 163539.9n 0.28000 163540.0n 0.28000 163669.9n 0.28000 163670.0n 0.28000 163799.9n 0.28000 163800.0n 0.28000 163929.9n 0.28000 163930.0n 0.28000 164059.9n 0.28000 164060.0n 0.28000 164189.9n 0.28000 164190.0n 0.28000 164319.9n 0.28000 164320.0n 0.28000 164449.9n 0.28000 164450.0n 0.28000 164579.9n 0.28000 164580.0n 0.28000 164709.9n 0.28000 164710.0n 0.28000 164839.9n 0.28000 164840.0n 0.28000 164969.9n 0.28000 164970.0n 0.28000 165099.9n 0.28000 165100.0n 0.28000 165229.9n 0.28000 165230.0n 0.28000 165359.9n 0.28000 165360.0n 0.28000 165489.9n 0.28000 165490.0n 0.28000 165619.9n 0.28000 165620.0n 0.28000 165749.9n 0.28000 165750.0n 0.28000 165879.9n 0.28000 165880.0n 0.28000 166009.9n 0.28000 166010.0n 0.28000 166139.9n 0.28000 166140.0n 0.28000 166269.9n 0.28000 166270.0n 0.28000 166399.9n 0.28000 166400.0n 0.28000 166529.9n 0.28000 166530.0n 0.28000 166659.9n 0.28000 166660.0n 0.28000 166789.9n 0.28000 166790.0n 0.28000 166919.9n 0.28000 166920.0n 0.28000 167049.9n 0.28000 167050.0n 0.28000 167179.9n 0.28000 167180.0n 0.28000 167309.9n 0.28000 167310.0n 0.28000 167439.9n 0.28000 167440.0n 0.28000 167569.9n 0.28000 167570.0n 0.28000 167699.9n 0.28000 167700.0n 0.28000 167829.9n 0.28000 167830.0n 0.28000 167959.9n 0.28000 167960.0n 0.28000 168089.9n 0.28000 168090.0n 0.28000 168219.9n 0.28000 168220.0n 0.28000 168349.9n 0.28000 168350.0n 0.28000)
Vxop1 xop1 0 PWL(0.0n 0.31000 129.9n 0.31000 130.0n 0.25000 259.9n 0.25000 260.0n 0.25000 389.9n 0.25000 390.0n 0.25000 519.9n 0.25000 520.0n 0.25000 649.9n 0.25000 650.0n 0.25000 779.9n 0.25000 780.0n 0.31000 909.9n 0.31000 910.0n 0.31000 1039.9n 0.31000 1040.0n 0.31000 1169.9n 0.31000 1170.0n 0.31000 1299.9n 0.31000 1300.0n 0.31000 1429.9n 0.31000 1430.0n 0.25000 1559.9n 0.25000 1560.0n 0.25000 1689.9n 0.25000 1690.0n 0.25000 1819.9n 0.25000 1820.0n 0.31000 1949.9n 0.31000 1950.0n 0.25000 2079.9n 0.25000 2080.0n 0.25000 2209.9n 0.25000 2210.0n 0.31000 2339.9n 0.31000 2340.0n 0.25000 2469.9n 0.25000 2470.0n 0.31000 2599.9n 0.31000 2600.0n 0.31000 2729.9n 0.31000 2730.0n 0.25000 2859.9n 0.25000 2860.0n 0.31000 2989.9n 0.31000 2990.0n 0.31000 3119.9n 0.31000 3120.0n 0.25000 3249.9n 0.25000 3250.0n 0.25000 3379.9n 0.25000 3380.0n 0.31000 3509.9n 0.31000 3510.0n 0.31000 3639.9n 0.31000 3640.0n 0.25000 3769.9n 0.25000 3770.0n 0.31000 3899.9n 0.31000 3900.0n 0.31000 4029.9n 0.31000 4030.0n 0.31000 4159.9n 0.31000 4160.0n 0.25000 4289.9n 0.25000 4290.0n 0.31000 4419.9n 0.31000 4420.0n 0.31000 4549.9n 0.31000 4550.0n 0.31000 4679.9n 0.31000 4680.0n 0.31000 4809.9n 0.31000 4810.0n 0.25000 4939.9n 0.25000 4940.0n 0.25000 5069.9n 0.25000 5070.0n 0.25000 5199.9n 0.25000 5200.0n 0.25000 5329.9n 0.25000 5330.0n 0.25000 5459.9n 0.25000 5460.0n 0.25000 5589.9n 0.25000 5590.0n 0.25000 5719.9n 0.25000 5720.0n 0.31000 5849.9n 0.31000 5850.0n 0.31000 5979.9n 0.31000 5980.0n 0.31000 6109.9n 0.31000 6110.0n 0.31000 6239.9n 0.31000 6240.0n 0.31000 6369.9n 0.31000 6370.0n 0.25000 6499.9n 0.25000 6500.0n 0.25000 6629.9n 0.25000 6630.0n 0.25000 6759.9n 0.25000 6760.0n 0.25000 6889.9n 0.25000 6890.0n 0.31000 7019.9n 0.31000 7020.0n 0.25000 7149.9n 0.25000 7150.0n 0.31000 7279.9n 0.31000 7280.0n 0.25000 7409.9n 0.25000 7410.0n 0.25000 7539.9n 0.25000 7540.0n 0.31000 7669.9n 0.31000 7670.0n 0.25000 7799.9n 0.25000 7800.0n 0.25000 7929.9n 0.25000 7930.0n 0.31000 8059.9n 0.31000 8060.0n 0.31000 8189.9n 0.31000 8190.0n 0.25000 8319.9n 0.25000 8320.0n 0.31000 8449.9n 0.31000 8450.0n 0.31000 8579.9n 0.31000 8580.0n 0.25000 8709.9n 0.25000 8710.0n 0.31000 8839.9n 0.31000 8840.0n 0.25000 8969.9n 0.25000 8970.0n 0.31000 9099.9n 0.31000 9100.0n 0.31000 9229.9n 0.31000 9230.0n 0.25000 9359.9n 0.25000 9360.0n 0.25000 9489.9n 0.25000 9490.0n 0.31000 9619.9n 0.31000 9620.0n 0.25000 9749.9n 0.25000 9750.0n 0.31000 9879.9n 0.31000 9880.0n 0.25000 10009.9n 0.25000 10010.0n 0.25000 10139.9n 0.25000 10140.0n 0.25000 10269.9n 0.25000 10270.0n 0.31000 10399.9n 0.31000 10400.0n 0.31000 10529.9n 0.31000 10530.0n 0.31000 10659.9n 0.31000 10660.0n 0.31000 10789.9n 0.31000 10790.0n 0.25000 10919.9n 0.25000 10920.0n 0.31000 11049.9n 0.31000 11050.0n 0.25000 11179.9n 0.25000 11180.0n 0.25000 11309.9n 0.25000 11310.0n 0.31000 11439.9n 0.31000 11440.0n 0.31000 11569.9n 0.31000 11570.0n 0.25000 11699.9n 0.25000 11700.0n 0.31000 11829.9n 0.31000 11830.0n 0.31000 11959.9n 0.31000 11960.0n 0.25000 12089.9n 0.25000 12090.0n 0.31000 12219.9n 0.31000 12220.0n 0.31000 12349.9n 0.31000 12350.0n 0.25000 12479.9n 0.25000 12480.0n 0.31000 12609.9n 0.31000 12610.0n 0.31000 12739.9n 0.31000 12740.0n 0.31000 12869.9n 0.31000 12870.0n 0.31000 12999.9n 0.31000 13000.0n 0.25000 13129.9n 0.25000 13130.0n 0.25000 13259.9n 0.25000 13260.0n 0.25000 13389.9n 0.25000 13390.0n 0.31000 13519.9n 0.31000 13520.0n 0.25000 13649.9n 0.25000 13650.0n 0.25000 13779.9n 0.25000 13780.0n 0.25000 13909.9n 0.25000 13910.0n 0.25000 14039.9n 0.25000 14040.0n 0.31000 14169.9n 0.31000 14170.0n 0.25000 14299.9n 0.25000 14300.0n 0.31000 14429.9n 0.31000 14430.0n 0.25000 14559.9n 0.25000 14560.0n 0.31000 14689.9n 0.31000 14690.0n 0.25000 14819.9n 0.25000 14820.0n 0.31000 14949.9n 0.31000 14950.0n 0.31000 15079.9n 0.31000 15080.0n 0.25000 15209.9n 0.25000 15210.0n 0.31000 15339.9n 0.31000 15340.0n 0.25000 15469.9n 0.25000 15470.0n 0.25000 15599.9n 0.25000 15600.0n 0.25000 15729.9n 0.25000 15730.0n 0.31000 15859.9n 0.31000 15860.0n 0.31000 15989.9n 0.31000 15990.0n 0.25000 16119.9n 0.25000 16120.0n 0.25000 16249.9n 0.25000 16250.0n 0.31000 16379.9n 0.31000 16380.0n 0.31000 16509.9n 0.31000 16510.0n 0.25000 16639.9n 0.25000 16640.0n 0.31000 16769.9n 0.31000 16770.0n 0.25000 16899.9n 0.25000 16900.0n 0.31000 17029.9n 0.31000 17030.0n 0.25000 17159.9n 0.25000 17160.0n 0.25000 17289.9n 0.25000 17290.0n 0.31000 17419.9n 0.31000 17420.0n 0.25000 17549.9n 0.25000 17550.0n 0.31000 17679.9n 0.31000 17680.0n 0.31000 17809.9n 0.31000 17810.0n 0.31000 17939.9n 0.31000 17940.0n 0.25000 18069.9n 0.25000 18070.0n 0.25000 18199.9n 0.25000 18200.0n 0.31000 18329.9n 0.31000 18330.0n 0.31000 18459.9n 0.31000 18460.0n 0.25000 18589.9n 0.25000 18590.0n 0.25000 18719.9n 0.25000 18720.0n 0.25000 18849.9n 0.25000 18850.0n 0.25000 18979.9n 0.25000 18980.0n 0.25000 19109.9n 0.25000 19110.0n 0.31000 19239.9n 0.31000 19240.0n 0.31000 19369.9n 0.31000 19370.0n 0.31000 19499.9n 0.31000 19500.0n 0.31000 19629.9n 0.31000 19630.0n 0.25000 19759.9n 0.25000 19760.0n 0.31000 19889.9n 0.31000 19890.0n 0.25000 20019.9n 0.25000 20020.0n 0.31000 20149.9n 0.31000 20150.0n 0.25000 20279.9n 0.25000 20280.0n 0.31000 20409.9n 0.31000 20410.0n 0.25000 20539.9n 0.25000 20540.0n 0.25000 20669.9n 0.25000 20670.0n 0.25000 20799.9n 0.25000 20800.0n 0.31000 20929.9n 0.31000 20930.0n 0.31000 21059.9n 0.31000 21060.0n 0.25000 21189.9n 0.25000 21190.0n 0.31000 21319.9n 0.31000 21320.0n 0.25000 21449.9n 0.25000 21450.0n 0.31000 21579.9n 0.31000 21580.0n 0.31000 21709.9n 0.31000 21710.0n 0.25000 21839.9n 0.25000 21840.0n 0.28000 21969.9n 0.28000 21970.0n 0.28000 22099.9n 0.28000 22100.0n 0.28000 22229.9n 0.28000 22230.0n 0.28000 22359.9n 0.28000 22360.0n 0.28000 22489.9n 0.28000 22490.0n 0.28000 22619.9n 0.28000 22620.0n 0.28000 22749.9n 0.28000 22750.0n 0.28000 22879.9n 0.28000 22880.0n 0.28000 23009.9n 0.28000 23010.0n 0.28000 23139.9n 0.28000 23140.0n 0.28000 23269.9n 0.28000 23270.0n 0.28000 23399.9n 0.28000 23400.0n 0.28000 23529.9n 0.28000 23530.0n 0.28000 23659.9n 0.28000 23660.0n 0.28000 23789.9n 0.28000 23790.0n 0.28000 23919.9n 0.28000 23920.0n 0.28000 24049.9n 0.28000 24050.0n 0.28000 24179.9n 0.28000 24180.0n 0.28000 24309.9n 0.28000 24310.0n 0.28000 24439.9n 0.28000 24440.0n 0.28000 24569.9n 0.28000 24570.0n 0.28000 24699.9n 0.28000 24700.0n 0.28000 24829.9n 0.28000 24830.0n 0.28000 24959.9n 0.28000 24960.0n 0.28000 25089.9n 0.28000 25090.0n 0.28000 25219.9n 0.28000 25220.0n 0.28000 25349.9n 0.28000 25350.0n 0.28000 25479.9n 0.28000 25480.0n 0.28000 25609.9n 0.28000 25610.0n 0.28000 25739.9n 0.28000 25740.0n 0.28000 25869.9n 0.28000 25870.0n 0.28000 25999.9n 0.28000 26000.0n 0.28000 26129.9n 0.28000 26130.0n 0.28000 26259.9n 0.28000 26260.0n 0.28000 26389.9n 0.28000 26390.0n 0.28000 26519.9n 0.28000 26520.0n 0.28000 26649.9n 0.28000 26650.0n 0.28000 26779.9n 0.28000 26780.0n 0.28000 26909.9n 0.28000 26910.0n 0.28000 27039.9n 0.28000 27040.0n 0.28000 27169.9n 0.28000 27170.0n 0.28000 27299.9n 0.28000 27300.0n 0.28000 27429.9n 0.28000 27430.0n 0.28000 27559.9n 0.28000 27560.0n 0.28000 27689.9n 0.28000 27690.0n 0.28000 27819.9n 0.28000 27820.0n 0.28000 27949.9n 0.28000 27950.0n 0.28000 28079.9n 0.28000 28080.0n 0.25000 28209.9n 0.25000 28210.0n 0.25000 28339.9n 0.25000 28340.0n 0.31000 28469.9n 0.31000 28470.0n 0.31000 28599.9n 0.31000 28600.0n 0.31000 28729.9n 0.31000 28730.0n 0.25000 28859.9n 0.25000 28860.0n 0.31000 28989.9n 0.31000 28990.0n 0.31000 29119.9n 0.31000 29120.0n 0.25000 29249.9n 0.25000 29250.0n 0.31000 29379.9n 0.31000 29380.0n 0.31000 29509.9n 0.31000 29510.0n 0.25000 29639.9n 0.25000 29640.0n 0.31000 29769.9n 0.31000 29770.0n 0.31000 29899.9n 0.31000 29900.0n 0.25000 30029.9n 0.25000 30030.0n 0.31000 30159.9n 0.31000 30160.0n 0.31000 30289.9n 0.31000 30290.0n 0.31000 30419.9n 0.31000 30420.0n 0.31000 30549.9n 0.31000 30550.0n 0.25000 30679.9n 0.25000 30680.0n 0.25000 30809.9n 0.25000 30810.0n 0.25000 30939.9n 0.25000 30940.0n 0.25000 31069.9n 0.25000 31070.0n 0.25000 31199.9n 0.25000 31200.0n 0.25000 31329.9n 0.25000 31330.0n 0.31000 31459.9n 0.31000 31460.0n 0.25000 31589.9n 0.25000 31590.0n 0.25000 31719.9n 0.25000 31720.0n 0.31000 31849.9n 0.31000 31850.0n 0.25000 31979.9n 0.25000 31980.0n 0.25000 32109.9n 0.25000 32110.0n 0.25000 32239.9n 0.25000 32240.0n 0.25000 32369.9n 0.25000 32370.0n 0.25000 32499.9n 0.25000 32500.0n 0.31000 32629.9n 0.31000 32630.0n 0.31000 32759.9n 0.31000 32760.0n 0.31000 32889.9n 0.31000 32890.0n 0.25000 33019.9n 0.25000 33020.0n 0.31000 33149.9n 0.31000 33150.0n 0.31000 33279.9n 0.31000 33280.0n 0.31000 33409.9n 0.31000 33410.0n 0.31000 33539.9n 0.31000 33540.0n 0.25000 33669.9n 0.25000 33670.0n 0.31000 33799.9n 0.31000 33800.0n 0.25000 33929.9n 0.25000 33930.0n 0.31000 34059.9n 0.31000 34060.0n 0.25000 34189.9n 0.25000 34190.0n 0.25000 34319.9n 0.25000 34320.0n 0.25000 34449.9n 0.25000 34450.0n 0.31000 34579.9n 0.31000 34580.0n 0.25000 34709.9n 0.25000 34710.0n 0.25000 34839.9n 0.25000 34840.0n 0.31000 34969.9n 0.31000 34970.0n 0.31000 35099.9n 0.31000 35100.0n 0.31000 35229.9n 0.31000 35230.0n 0.25000 35359.9n 0.25000 35360.0n 0.31000 35489.9n 0.31000 35490.0n 0.25000 35619.9n 0.25000 35620.0n 0.31000 35749.9n 0.31000 35750.0n 0.31000 35879.9n 0.31000 35880.0n 0.25000 36009.9n 0.25000 36010.0n 0.31000 36139.9n 0.31000 36140.0n 0.31000 36269.9n 0.31000 36270.0n 0.25000 36399.9n 0.25000 36400.0n 0.25000 36529.9n 0.25000 36530.0n 0.25000 36659.9n 0.25000 36660.0n 0.31000 36789.9n 0.31000 36790.0n 0.31000 36919.9n 0.31000 36920.0n 0.31000 37049.9n 0.31000 37050.0n 0.31000 37179.9n 0.31000 37180.0n 0.31000 37309.9n 0.31000 37310.0n 0.31000 37439.9n 0.31000 37440.0n 0.25000 37569.9n 0.25000 37570.0n 0.25000 37699.9n 0.25000 37700.0n 0.25000 37829.9n 0.25000 37830.0n 0.25000 37959.9n 0.25000 37960.0n 0.25000 38089.9n 0.25000 38090.0n 0.25000 38219.9n 0.25000 38220.0n 0.25000 38349.9n 0.25000 38350.0n 0.31000 38479.9n 0.31000 38480.0n 0.31000 38609.9n 0.31000 38610.0n 0.25000 38739.9n 0.25000 38740.0n 0.31000 38869.9n 0.31000 38870.0n 0.25000 38999.9n 0.25000 39000.0n 0.31000 39129.9n 0.31000 39130.0n 0.25000 39259.9n 0.25000 39260.0n 0.25000 39389.9n 0.25000 39390.0n 0.25000 39519.9n 0.25000 39520.0n 0.31000 39649.9n 0.31000 39650.0n 0.25000 39779.9n 0.25000 39780.0n 0.31000 39909.9n 0.31000 39910.0n 0.31000 40039.9n 0.31000 40040.0n 0.31000 40169.9n 0.31000 40170.0n 0.25000 40299.9n 0.25000 40300.0n 0.25000 40429.9n 0.25000 40430.0n 0.25000 40559.9n 0.25000 40560.0n 0.31000 40689.9n 0.31000 40690.0n 0.31000 40819.9n 0.31000 40820.0n 0.25000 40949.9n 0.25000 40950.0n 0.31000 41079.9n 0.31000 41080.0n 0.31000 41209.9n 0.31000 41210.0n 0.31000 41339.9n 0.31000 41340.0n 0.25000 41469.9n 0.25000 41470.0n 0.25000 41599.9n 0.25000 41600.0n 0.31000 41729.9n 0.31000 41730.0n 0.31000 41859.9n 0.31000 41860.0n 0.31000 41989.9n 0.31000 41990.0n 0.25000 42119.9n 0.25000 42120.0n 0.25000 42249.9n 0.25000 42250.0n 0.25000 42379.9n 0.25000 42380.0n 0.25000 42509.9n 0.25000 42510.0n 0.31000 42639.9n 0.31000 42640.0n 0.31000 42769.9n 0.31000 42770.0n 0.25000 42899.9n 0.25000 42900.0n 0.25000 43029.9n 0.25000 43030.0n 0.31000 43159.9n 0.31000 43160.0n 0.25000 43289.9n 0.25000 43290.0n 0.31000 43419.9n 0.31000 43420.0n 0.31000 43549.9n 0.31000 43550.0n 0.31000 43679.9n 0.31000 43680.0n 0.31000 43809.9n 0.31000 43810.0n 0.31000 43939.9n 0.31000 43940.0n 0.25000 44069.9n 0.25000 44070.0n 0.31000 44199.9n 0.31000 44200.0n 0.31000 44329.9n 0.31000 44330.0n 0.25000 44459.9n 0.25000 44460.0n 0.25000 44589.9n 0.25000 44590.0n 0.25000 44719.9n 0.25000 44720.0n 0.25000 44849.9n 0.25000 44850.0n 0.31000 44979.9n 0.31000 44980.0n 0.25000 45109.9n 0.25000 45110.0n 0.31000 45239.9n 0.31000 45240.0n 0.25000 45369.9n 0.25000 45370.0n 0.25000 45499.9n 0.25000 45500.0n 0.25000 45629.9n 0.25000 45630.0n 0.25000 45759.9n 0.25000 45760.0n 0.25000 45889.9n 0.25000 45890.0n 0.31000 46019.9n 0.31000 46020.0n 0.31000 46149.9n 0.31000 46150.0n 0.31000 46279.9n 0.31000 46280.0n 0.31000 46409.9n 0.31000 46410.0n 0.25000 46539.9n 0.25000 46540.0n 0.25000 46669.9n 0.25000 46670.0n 0.31000 46799.9n 0.31000 46800.0n 0.25000 46929.9n 0.25000 46930.0n 0.31000 47059.9n 0.31000 47060.0n 0.31000 47189.9n 0.31000 47190.0n 0.25000 47319.9n 0.25000 47320.0n 0.25000 47449.9n 0.25000 47450.0n 0.25000 47579.9n 0.25000 47580.0n 0.25000 47709.9n 0.25000 47710.0n 0.25000 47839.9n 0.25000 47840.0n 0.25000 47969.9n 0.25000 47970.0n 0.31000 48099.9n 0.31000 48100.0n 0.25000 48229.9n 0.25000 48230.0n 0.31000 48359.9n 0.31000 48360.0n 0.25000 48489.9n 0.25000 48490.0n 0.31000 48619.9n 0.31000 48620.0n 0.31000 48749.9n 0.31000 48750.0n 0.31000 48879.9n 0.31000 48880.0n 0.31000 49009.9n 0.31000 49010.0n 0.31000 49139.9n 0.31000 49140.0n 0.25000 49269.9n 0.25000 49270.0n 0.31000 49399.9n 0.31000 49400.0n 0.25000 49529.9n 0.25000 49530.0n 0.31000 49659.9n 0.31000 49660.0n 0.25000 49789.9n 0.25000 49790.0n 0.31000 49919.9n 0.31000 49920.0n 0.28000 50049.9n 0.28000 50050.0n 0.28000 50179.9n 0.28000 50180.0n 0.28000 50309.9n 0.28000 50310.0n 0.28000 50439.9n 0.28000 50440.0n 0.28000 50569.9n 0.28000 50570.0n 0.28000 50699.9n 0.28000 50700.0n 0.28000 50829.9n 0.28000 50830.0n 0.28000 50959.9n 0.28000 50960.0n 0.28000 51089.9n 0.28000 51090.0n 0.28000 51219.9n 0.28000 51220.0n 0.28000 51349.9n 0.28000 51350.0n 0.28000 51479.9n 0.28000 51480.0n 0.28000 51609.9n 0.28000 51610.0n 0.28000 51739.9n 0.28000 51740.0n 0.28000 51869.9n 0.28000 51870.0n 0.28000 51999.9n 0.28000 52000.0n 0.28000 52129.9n 0.28000 52130.0n 0.28000 52259.9n 0.28000 52260.0n 0.28000 52389.9n 0.28000 52390.0n 0.28000 52519.9n 0.28000 52520.0n 0.28000 52649.9n 0.28000 52650.0n 0.28000 52779.9n 0.28000 52780.0n 0.28000 52909.9n 0.28000 52910.0n 0.28000 53039.9n 0.28000 53040.0n 0.28000 53169.9n 0.28000 53170.0n 0.28000 53299.9n 0.28000 53300.0n 0.28000 53429.9n 0.28000 53430.0n 0.28000 53559.9n 0.28000 53560.0n 0.28000 53689.9n 0.28000 53690.0n 0.28000 53819.9n 0.28000 53820.0n 0.28000 53949.9n 0.28000 53950.0n 0.28000 54079.9n 0.28000 54080.0n 0.28000 54209.9n 0.28000 54210.0n 0.28000 54339.9n 0.28000 54340.0n 0.28000 54469.9n 0.28000 54470.0n 0.28000 54599.9n 0.28000 54600.0n 0.28000 54729.9n 0.28000 54730.0n 0.28000 54859.9n 0.28000 54860.0n 0.28000 54989.9n 0.28000 54990.0n 0.28000 55119.9n 0.28000 55120.0n 0.28000 55249.9n 0.28000 55250.0n 0.28000 55379.9n 0.28000 55380.0n 0.28000 55509.9n 0.28000 55510.0n 0.28000 55639.9n 0.28000 55640.0n 0.28000 55769.9n 0.28000 55770.0n 0.28000 55899.9n 0.28000 55900.0n 0.28000 56029.9n 0.28000 56030.0n 0.28000 56159.9n 0.28000 56160.0n 0.25000 56289.9n 0.25000 56290.0n 0.25000 56419.9n 0.25000 56420.0n 0.31000 56549.9n 0.31000 56550.0n 0.31000 56679.9n 0.31000 56680.0n 0.31000 56809.9n 0.31000 56810.0n 0.25000 56939.9n 0.25000 56940.0n 0.25000 57069.9n 0.25000 57070.0n 0.31000 57199.9n 0.31000 57200.0n 0.31000 57329.9n 0.31000 57330.0n 0.31000 57459.9n 0.31000 57460.0n 0.25000 57589.9n 0.25000 57590.0n 0.25000 57719.9n 0.25000 57720.0n 0.25000 57849.9n 0.25000 57850.0n 0.31000 57979.9n 0.31000 57980.0n 0.25000 58109.9n 0.25000 58110.0n 0.25000 58239.9n 0.25000 58240.0n 0.25000 58369.9n 0.25000 58370.0n 0.31000 58499.9n 0.31000 58500.0n 0.25000 58629.9n 0.25000 58630.0n 0.31000 58759.9n 0.31000 58760.0n 0.31000 58889.9n 0.31000 58890.0n 0.31000 59019.9n 0.31000 59020.0n 0.31000 59149.9n 0.31000 59150.0n 0.31000 59279.9n 0.31000 59280.0n 0.25000 59409.9n 0.25000 59410.0n 0.25000 59539.9n 0.25000 59540.0n 0.25000 59669.9n 0.25000 59670.0n 0.31000 59799.9n 0.31000 59800.0n 0.31000 59929.9n 0.31000 59930.0n 0.25000 60059.9n 0.25000 60060.0n 0.31000 60189.9n 0.31000 60190.0n 0.25000 60319.9n 0.25000 60320.0n 0.25000 60449.9n 0.25000 60450.0n 0.25000 60579.9n 0.25000 60580.0n 0.25000 60709.9n 0.25000 60710.0n 0.31000 60839.9n 0.31000 60840.0n 0.25000 60969.9n 0.25000 60970.0n 0.25000 61099.9n 0.25000 61100.0n 0.25000 61229.9n 0.25000 61230.0n 0.31000 61359.9n 0.31000 61360.0n 0.31000 61489.9n 0.31000 61490.0n 0.25000 61619.9n 0.25000 61620.0n 0.25000 61749.9n 0.25000 61750.0n 0.31000 61879.9n 0.31000 61880.0n 0.25000 62009.9n 0.25000 62010.0n 0.25000 62139.9n 0.25000 62140.0n 0.25000 62269.9n 0.25000 62270.0n 0.31000 62399.9n 0.31000 62400.0n 0.31000 62529.9n 0.31000 62530.0n 0.31000 62659.9n 0.31000 62660.0n 0.31000 62789.9n 0.31000 62790.0n 0.31000 62919.9n 0.31000 62920.0n 0.31000 63049.9n 0.31000 63050.0n 0.31000 63179.9n 0.31000 63180.0n 0.31000 63309.9n 0.31000 63310.0n 0.25000 63439.9n 0.25000 63440.0n 0.31000 63569.9n 0.31000 63570.0n 0.25000 63699.9n 0.25000 63700.0n 0.31000 63829.9n 0.31000 63830.0n 0.31000 63959.9n 0.31000 63960.0n 0.31000 64089.9n 0.31000 64090.0n 0.25000 64219.9n 0.25000 64220.0n 0.31000 64349.9n 0.31000 64350.0n 0.25000 64479.9n 0.25000 64480.0n 0.31000 64609.9n 0.31000 64610.0n 0.25000 64739.9n 0.25000 64740.0n 0.31000 64869.9n 0.31000 64870.0n 0.31000 64999.9n 0.31000 65000.0n 0.31000 65129.9n 0.31000 65130.0n 0.25000 65259.9n 0.25000 65260.0n 0.31000 65389.9n 0.31000 65390.0n 0.31000 65519.9n 0.31000 65520.0n 0.25000 65649.9n 0.25000 65650.0n 0.25000 65779.9n 0.25000 65780.0n 0.25000 65909.9n 0.25000 65910.0n 0.25000 66039.9n 0.25000 66040.0n 0.25000 66169.9n 0.25000 66170.0n 0.25000 66299.9n 0.25000 66300.0n 0.25000 66429.9n 0.25000 66430.0n 0.25000 66559.9n 0.25000 66560.0n 0.31000 66689.9n 0.31000 66690.0n 0.25000 66819.9n 0.25000 66820.0n 0.31000 66949.9n 0.31000 66950.0n 0.31000 67079.9n 0.31000 67080.0n 0.25000 67209.9n 0.25000 67210.0n 0.31000 67339.9n 0.31000 67340.0n 0.31000 67469.9n 0.31000 67470.0n 0.31000 67599.9n 0.31000 67600.0n 0.25000 67729.9n 0.25000 67730.0n 0.25000 67859.9n 0.25000 67860.0n 0.31000 67989.9n 0.31000 67990.0n 0.31000 68119.9n 0.31000 68120.0n 0.25000 68249.9n 0.25000 68250.0n 0.25000 68379.9n 0.25000 68380.0n 0.25000 68509.9n 0.25000 68510.0n 0.31000 68639.9n 0.31000 68640.0n 0.25000 68769.9n 0.25000 68770.0n 0.25000 68899.9n 0.25000 68900.0n 0.31000 69029.9n 0.31000 69030.0n 0.31000 69159.9n 0.31000 69160.0n 0.25000 69289.9n 0.25000 69290.0n 0.31000 69419.9n 0.31000 69420.0n 0.31000 69549.9n 0.31000 69550.0n 0.31000 69679.9n 0.31000 69680.0n 0.25000 69809.9n 0.25000 69810.0n 0.25000 69939.9n 0.25000 69940.0n 0.25000 70069.9n 0.25000 70070.0n 0.31000 70199.9n 0.31000 70200.0n 0.31000 70329.9n 0.31000 70330.0n 0.25000 70459.9n 0.25000 70460.0n 0.31000 70589.9n 0.31000 70590.0n 0.25000 70719.9n 0.25000 70720.0n 0.31000 70849.9n 0.31000 70850.0n 0.25000 70979.9n 0.25000 70980.0n 0.31000 71109.9n 0.31000 71110.0n 0.25000 71239.9n 0.25000 71240.0n 0.31000 71369.9n 0.31000 71370.0n 0.25000 71499.9n 0.25000 71500.0n 0.31000 71629.9n 0.31000 71630.0n 0.31000 71759.9n 0.31000 71760.0n 0.25000 71889.9n 0.25000 71890.0n 0.25000 72019.9n 0.25000 72020.0n 0.25000 72149.9n 0.25000 72150.0n 0.31000 72279.9n 0.31000 72280.0n 0.25000 72409.9n 0.25000 72410.0n 0.31000 72539.9n 0.31000 72540.0n 0.31000 72669.9n 0.31000 72670.0n 0.31000 72799.9n 0.31000 72800.0n 0.31000 72929.9n 0.31000 72930.0n 0.25000 73059.9n 0.25000 73060.0n 0.25000 73189.9n 0.25000 73190.0n 0.25000 73319.9n 0.25000 73320.0n 0.25000 73449.9n 0.25000 73450.0n 0.31000 73579.9n 0.31000 73580.0n 0.31000 73709.9n 0.31000 73710.0n 0.25000 73839.9n 0.25000 73840.0n 0.31000 73969.9n 0.31000 73970.0n 0.31000 74099.9n 0.31000 74100.0n 0.25000 74229.9n 0.25000 74230.0n 0.25000 74359.9n 0.25000 74360.0n 0.31000 74489.9n 0.31000 74490.0n 0.31000 74619.9n 0.31000 74620.0n 0.31000 74749.9n 0.31000 74750.0n 0.25000 74879.9n 0.25000 74880.0n 0.25000 75009.9n 0.25000 75010.0n 0.25000 75139.9n 0.25000 75140.0n 0.31000 75269.9n 0.31000 75270.0n 0.31000 75399.9n 0.31000 75400.0n 0.25000 75529.9n 0.25000 75530.0n 0.25000 75659.9n 0.25000 75660.0n 0.31000 75789.9n 0.31000 75790.0n 0.25000 75919.9n 0.25000 75920.0n 0.25000 76049.9n 0.25000 76050.0n 0.25000 76179.9n 0.25000 76180.0n 0.31000 76309.9n 0.31000 76310.0n 0.31000 76439.9n 0.31000 76440.0n 0.25000 76569.9n 0.25000 76570.0n 0.31000 76699.9n 0.31000 76700.0n 0.25000 76829.9n 0.25000 76830.0n 0.31000 76959.9n 0.31000 76960.0n 0.31000 77089.9n 0.31000 77090.0n 0.25000 77219.9n 0.25000 77220.0n 0.25000 77349.9n 0.25000 77350.0n 0.25000 77479.9n 0.25000 77480.0n 0.31000 77609.9n 0.31000 77610.0n 0.31000 77739.9n 0.31000 77740.0n 0.25000 77869.9n 0.25000 77870.0n 0.31000 77999.9n 0.31000 78000.0n 0.28000 78129.9n 0.28000 78130.0n 0.28000 78259.9n 0.28000 78260.0n 0.28000 78389.9n 0.28000 78390.0n 0.28000 78519.9n 0.28000 78520.0n 0.28000 78649.9n 0.28000 78650.0n 0.28000 78779.9n 0.28000 78780.0n 0.28000 78909.9n 0.28000 78910.0n 0.28000 79039.9n 0.28000 79040.0n 0.28000 79169.9n 0.28000 79170.0n 0.28000 79299.9n 0.28000 79300.0n 0.28000 79429.9n 0.28000 79430.0n 0.28000 79559.9n 0.28000 79560.0n 0.28000 79689.9n 0.28000 79690.0n 0.28000 79819.9n 0.28000 79820.0n 0.28000 79949.9n 0.28000 79950.0n 0.28000 80079.9n 0.28000 80080.0n 0.28000 80209.9n 0.28000 80210.0n 0.28000 80339.9n 0.28000 80340.0n 0.28000 80469.9n 0.28000 80470.0n 0.28000 80599.9n 0.28000 80600.0n 0.28000 80729.9n 0.28000 80730.0n 0.28000 80859.9n 0.28000 80860.0n 0.28000 80989.9n 0.28000 80990.0n 0.28000 81119.9n 0.28000 81120.0n 0.28000 81249.9n 0.28000 81250.0n 0.28000 81379.9n 0.28000 81380.0n 0.28000 81509.9n 0.28000 81510.0n 0.28000 81639.9n 0.28000 81640.0n 0.28000 81769.9n 0.28000 81770.0n 0.28000 81899.9n 0.28000 81900.0n 0.28000 82029.9n 0.28000 82030.0n 0.28000 82159.9n 0.28000 82160.0n 0.28000 82289.9n 0.28000 82290.0n 0.28000 82419.9n 0.28000 82420.0n 0.28000 82549.9n 0.28000 82550.0n 0.28000 82679.9n 0.28000 82680.0n 0.28000 82809.9n 0.28000 82810.0n 0.28000 82939.9n 0.28000 82940.0n 0.28000 83069.9n 0.28000 83070.0n 0.28000 83199.9n 0.28000 83200.0n 0.28000 83329.9n 0.28000 83330.0n 0.28000 83459.9n 0.28000 83460.0n 0.28000 83589.9n 0.28000 83590.0n 0.28000 83719.9n 0.28000 83720.0n 0.28000 83849.9n 0.28000 83850.0n 0.28000 83979.9n 0.28000 83980.0n 0.28000 84109.9n 0.28000 84110.0n 0.28000 84239.9n 0.28000 84240.0n 0.25000 84369.9n 0.25000 84370.0n 0.25000 84499.9n 0.25000 84500.0n 0.25000 84629.9n 0.25000 84630.0n 0.31000 84759.9n 0.31000 84760.0n 0.25000 84889.9n 0.25000 84890.0n 0.25000 85019.9n 0.25000 85020.0n 0.31000 85149.9n 0.31000 85150.0n 0.31000 85279.9n 0.31000 85280.0n 0.25000 85409.9n 0.25000 85410.0n 0.25000 85539.9n 0.25000 85540.0n 0.25000 85669.9n 0.25000 85670.0n 0.31000 85799.9n 0.31000 85800.0n 0.25000 85929.9n 0.25000 85930.0n 0.31000 86059.9n 0.31000 86060.0n 0.31000 86189.9n 0.31000 86190.0n 0.31000 86319.9n 0.31000 86320.0n 0.25000 86449.9n 0.25000 86450.0n 0.25000 86579.9n 0.25000 86580.0n 0.31000 86709.9n 0.31000 86710.0n 0.31000 86839.9n 0.31000 86840.0n 0.31000 86969.9n 0.31000 86970.0n 0.31000 87099.9n 0.31000 87100.0n 0.31000 87229.9n 0.31000 87230.0n 0.31000 87359.9n 0.31000 87360.0n 0.25000 87489.9n 0.25000 87490.0n 0.31000 87619.9n 0.31000 87620.0n 0.25000 87749.9n 0.25000 87750.0n 0.25000 87879.9n 0.25000 87880.0n 0.25000 88009.9n 0.25000 88010.0n 0.31000 88139.9n 0.31000 88140.0n 0.25000 88269.9n 0.25000 88270.0n 0.25000 88399.9n 0.25000 88400.0n 0.31000 88529.9n 0.31000 88530.0n 0.25000 88659.9n 0.25000 88660.0n 0.31000 88789.9n 0.31000 88790.0n 0.25000 88919.9n 0.25000 88920.0n 0.25000 89049.9n 0.25000 89050.0n 0.25000 89179.9n 0.25000 89180.0n 0.25000 89309.9n 0.25000 89310.0n 0.31000 89439.9n 0.31000 89440.0n 0.31000 89569.9n 0.31000 89570.0n 0.31000 89699.9n 0.31000 89700.0n 0.31000 89829.9n 0.31000 89830.0n 0.31000 89959.9n 0.31000 89960.0n 0.31000 90089.9n 0.31000 90090.0n 0.25000 90219.9n 0.25000 90220.0n 0.25000 90349.9n 0.25000 90350.0n 0.31000 90479.9n 0.31000 90480.0n 0.25000 90609.9n 0.25000 90610.0n 0.25000 90739.9n 0.25000 90740.0n 0.31000 90869.9n 0.31000 90870.0n 0.31000 90999.9n 0.31000 91000.0n 0.31000 91129.9n 0.31000 91130.0n 0.31000 91259.9n 0.31000 91260.0n 0.25000 91389.9n 0.25000 91390.0n 0.25000 91519.9n 0.25000 91520.0n 0.31000 91649.9n 0.31000 91650.0n 0.31000 91779.9n 0.31000 91780.0n 0.31000 91909.9n 0.31000 91910.0n 0.25000 92039.9n 0.25000 92040.0n 0.25000 92169.9n 0.25000 92170.0n 0.31000 92299.9n 0.31000 92300.0n 0.31000 92429.9n 0.31000 92430.0n 0.25000 92559.9n 0.25000 92560.0n 0.31000 92689.9n 0.31000 92690.0n 0.25000 92819.9n 0.25000 92820.0n 0.25000 92949.9n 0.25000 92950.0n 0.25000 93079.9n 0.25000 93080.0n 0.31000 93209.9n 0.31000 93210.0n 0.25000 93339.9n 0.25000 93340.0n 0.31000 93469.9n 0.31000 93470.0n 0.31000 93599.9n 0.31000 93600.0n 0.25000 93729.9n 0.25000 93730.0n 0.25000 93859.9n 0.25000 93860.0n 0.31000 93989.9n 0.31000 93990.0n 0.25000 94119.9n 0.25000 94120.0n 0.31000 94249.9n 0.31000 94250.0n 0.25000 94379.9n 0.25000 94380.0n 0.31000 94509.9n 0.31000 94510.0n 0.31000 94639.9n 0.31000 94640.0n 0.31000 94769.9n 0.31000 94770.0n 0.25000 94899.9n 0.25000 94900.0n 0.25000 95029.9n 0.25000 95030.0n 0.25000 95159.9n 0.25000 95160.0n 0.25000 95289.9n 0.25000 95290.0n 0.25000 95419.9n 0.25000 95420.0n 0.31000 95549.9n 0.31000 95550.0n 0.31000 95679.9n 0.31000 95680.0n 0.25000 95809.9n 0.25000 95810.0n 0.25000 95939.9n 0.25000 95940.0n 0.31000 96069.9n 0.31000 96070.0n 0.31000 96199.9n 0.31000 96200.0n 0.25000 96329.9n 0.25000 96330.0n 0.31000 96459.9n 0.31000 96460.0n 0.31000 96589.9n 0.31000 96590.0n 0.25000 96719.9n 0.25000 96720.0n 0.31000 96849.9n 0.31000 96850.0n 0.25000 96979.9n 0.25000 96980.0n 0.25000 97109.9n 0.25000 97110.0n 0.25000 97239.9n 0.25000 97240.0n 0.31000 97369.9n 0.31000 97370.0n 0.31000 97499.9n 0.31000 97500.0n 0.31000 97629.9n 0.31000 97630.0n 0.31000 97759.9n 0.31000 97760.0n 0.31000 97889.9n 0.31000 97890.0n 0.25000 98019.9n 0.25000 98020.0n 0.25000 98149.9n 0.25000 98150.0n 0.25000 98279.9n 0.25000 98280.0n 0.25000 98409.9n 0.25000 98410.0n 0.31000 98539.9n 0.31000 98540.0n 0.31000 98669.9n 0.31000 98670.0n 0.25000 98799.9n 0.25000 98800.0n 0.31000 98929.9n 0.31000 98930.0n 0.25000 99059.9n 0.25000 99060.0n 0.25000 99189.9n 0.25000 99190.0n 0.25000 99319.9n 0.25000 99320.0n 0.31000 99449.9n 0.31000 99450.0n 0.25000 99579.9n 0.25000 99580.0n 0.31000 99709.9n 0.31000 99710.0n 0.25000 99839.9n 0.25000 99840.0n 0.31000 99969.9n 0.31000 99970.0n 0.31000 100099.9n 0.31000 100100.0n 0.31000 100229.9n 0.31000 100230.0n 0.31000 100359.9n 0.31000 100360.0n 0.31000 100489.9n 0.31000 100490.0n 0.25000 100619.9n 0.25000 100620.0n 0.31000 100749.9n 0.31000 100750.0n 0.25000 100879.9n 0.25000 100880.0n 0.31000 101009.9n 0.31000 101010.0n 0.25000 101139.9n 0.25000 101140.0n 0.31000 101269.9n 0.31000 101270.0n 0.31000 101399.9n 0.31000 101400.0n 0.25000 101529.9n 0.25000 101530.0n 0.25000 101659.9n 0.25000 101660.0n 0.25000 101789.9n 0.25000 101790.0n 0.31000 101919.9n 0.31000 101920.0n 0.25000 102049.9n 0.25000 102050.0n 0.25000 102179.9n 0.25000 102180.0n 0.31000 102309.9n 0.31000 102310.0n 0.25000 102439.9n 0.25000 102440.0n 0.25000 102569.9n 0.25000 102570.0n 0.25000 102699.9n 0.25000 102700.0n 0.31000 102829.9n 0.31000 102830.0n 0.31000 102959.9n 0.31000 102960.0n 0.31000 103089.9n 0.31000 103090.0n 0.31000 103219.9n 0.31000 103220.0n 0.25000 103349.9n 0.25000 103350.0n 0.25000 103479.9n 0.25000 103480.0n 0.25000 103609.9n 0.25000 103610.0n 0.31000 103739.9n 0.31000 103740.0n 0.25000 103869.9n 0.25000 103870.0n 0.25000 103999.9n 0.25000 104000.0n 0.25000 104129.9n 0.25000 104130.0n 0.25000 104259.9n 0.25000 104260.0n 0.25000 104389.9n 0.25000 104390.0n 0.31000 104519.9n 0.31000 104520.0n 0.31000 104649.9n 0.31000 104650.0n 0.31000 104779.9n 0.31000 104780.0n 0.31000 104909.9n 0.31000 104910.0n 0.31000 105039.9n 0.31000 105040.0n 0.25000 105169.9n 0.25000 105170.0n 0.31000 105299.9n 0.31000 105300.0n 0.25000 105429.9n 0.25000 105430.0n 0.25000 105559.9n 0.25000 105560.0n 0.31000 105689.9n 0.31000 105690.0n 0.25000 105819.9n 0.25000 105820.0n 0.31000 105949.9n 0.31000 105950.0n 0.31000 106079.9n 0.31000 106080.0n 0.28000 106209.9n 0.28000 106210.0n 0.28000 106339.9n 0.28000 106340.0n 0.28000 106469.9n 0.28000 106470.0n 0.28000 106599.9n 0.28000 106600.0n 0.28000 106729.9n 0.28000 106730.0n 0.28000 106859.9n 0.28000 106860.0n 0.28000 106989.9n 0.28000 106990.0n 0.28000 107119.9n 0.28000 107120.0n 0.28000 107249.9n 0.28000 107250.0n 0.28000 107379.9n 0.28000 107380.0n 0.28000 107509.9n 0.28000 107510.0n 0.28000 107639.9n 0.28000 107640.0n 0.28000 107769.9n 0.28000 107770.0n 0.28000 107899.9n 0.28000 107900.0n 0.28000 108029.9n 0.28000 108030.0n 0.28000 108159.9n 0.28000 108160.0n 0.28000 108289.9n 0.28000 108290.0n 0.28000 108419.9n 0.28000 108420.0n 0.28000 108549.9n 0.28000 108550.0n 0.28000 108679.9n 0.28000 108680.0n 0.28000 108809.9n 0.28000 108810.0n 0.28000 108939.9n 0.28000 108940.0n 0.28000 109069.9n 0.28000 109070.0n 0.28000 109199.9n 0.28000 109200.0n 0.28000 109329.9n 0.28000 109330.0n 0.28000 109459.9n 0.28000 109460.0n 0.28000 109589.9n 0.28000 109590.0n 0.28000 109719.9n 0.28000 109720.0n 0.28000 109849.9n 0.28000 109850.0n 0.28000 109979.9n 0.28000 109980.0n 0.28000 110109.9n 0.28000 110110.0n 0.28000 110239.9n 0.28000 110240.0n 0.28000 110369.9n 0.28000 110370.0n 0.28000 110499.9n 0.28000 110500.0n 0.28000 110629.9n 0.28000 110630.0n 0.28000 110759.9n 0.28000 110760.0n 0.28000 110889.9n 0.28000 110890.0n 0.28000 111019.9n 0.28000 111020.0n 0.28000 111149.9n 0.28000 111150.0n 0.28000 111279.9n 0.28000 111280.0n 0.28000 111409.9n 0.28000 111410.0n 0.28000 111539.9n 0.28000 111540.0n 0.28000 111669.9n 0.28000 111670.0n 0.28000 111799.9n 0.28000 111800.0n 0.28000 111929.9n 0.28000 111930.0n 0.28000 112059.9n 0.28000 112060.0n 0.28000 112189.9n 0.28000 112190.0n 0.28000 112319.9n 0.28000 112320.0n 0.25000 112449.9n 0.25000 112450.0n 0.25000 112579.9n 0.25000 112580.0n 0.31000 112709.9n 0.31000 112710.0n 0.25000 112839.9n 0.25000 112840.0n 0.31000 112969.9n 0.31000 112970.0n 0.25000 113099.9n 0.25000 113100.0n 0.25000 113229.9n 0.25000 113230.0n 0.31000 113359.9n 0.31000 113360.0n 0.31000 113489.9n 0.31000 113490.0n 0.31000 113619.9n 0.31000 113620.0n 0.25000 113749.9n 0.25000 113750.0n 0.31000 113879.9n 0.31000 113880.0n 0.31000 114009.9n 0.31000 114010.0n 0.25000 114139.9n 0.25000 114140.0n 0.25000 114269.9n 0.25000 114270.0n 0.25000 114399.9n 0.25000 114400.0n 0.25000 114529.9n 0.25000 114530.0n 0.31000 114659.9n 0.31000 114660.0n 0.25000 114789.9n 0.25000 114790.0n 0.31000 114919.9n 0.31000 114920.0n 0.31000 115049.9n 0.31000 115050.0n 0.31000 115179.9n 0.31000 115180.0n 0.25000 115309.9n 0.25000 115310.0n 0.31000 115439.9n 0.31000 115440.0n 0.25000 115569.9n 0.25000 115570.0n 0.31000 115699.9n 0.31000 115700.0n 0.25000 115829.9n 0.25000 115830.0n 0.31000 115959.9n 0.31000 115960.0n 0.31000 116089.9n 0.31000 116090.0n 0.25000 116219.9n 0.25000 116220.0n 0.25000 116349.9n 0.25000 116350.0n 0.31000 116479.9n 0.31000 116480.0n 0.25000 116609.9n 0.25000 116610.0n 0.25000 116739.9n 0.25000 116740.0n 0.25000 116869.9n 0.25000 116870.0n 0.25000 116999.9n 0.25000 117000.0n 0.31000 117129.9n 0.31000 117130.0n 0.25000 117259.9n 0.25000 117260.0n 0.31000 117389.9n 0.31000 117390.0n 0.25000 117519.9n 0.25000 117520.0n 0.25000 117649.9n 0.25000 117650.0n 0.31000 117779.9n 0.31000 117780.0n 0.25000 117909.9n 0.25000 117910.0n 0.31000 118039.9n 0.31000 118040.0n 0.31000 118169.9n 0.31000 118170.0n 0.25000 118299.9n 0.25000 118300.0n 0.31000 118429.9n 0.31000 118430.0n 0.31000 118559.9n 0.31000 118560.0n 0.31000 118689.9n 0.31000 118690.0n 0.31000 118819.9n 0.31000 118820.0n 0.25000 118949.9n 0.25000 118950.0n 0.31000 119079.9n 0.31000 119080.0n 0.25000 119209.9n 0.25000 119210.0n 0.25000 119339.9n 0.25000 119340.0n 0.31000 119469.9n 0.31000 119470.0n 0.31000 119599.9n 0.31000 119600.0n 0.25000 119729.9n 0.25000 119730.0n 0.31000 119859.9n 0.31000 119860.0n 0.31000 119989.9n 0.31000 119990.0n 0.31000 120119.9n 0.31000 120120.0n 0.25000 120249.9n 0.25000 120250.0n 0.31000 120379.9n 0.31000 120380.0n 0.25000 120509.9n 0.25000 120510.0n 0.25000 120639.9n 0.25000 120640.0n 0.31000 120769.9n 0.31000 120770.0n 0.31000 120899.9n 0.31000 120900.0n 0.25000 121029.9n 0.25000 121030.0n 0.25000 121159.9n 0.25000 121160.0n 0.31000 121289.9n 0.31000 121290.0n 0.25000 121419.9n 0.25000 121420.0n 0.25000 121549.9n 0.25000 121550.0n 0.31000 121679.9n 0.31000 121680.0n 0.31000 121809.9n 0.31000 121810.0n 0.25000 121939.9n 0.25000 121940.0n 0.31000 122069.9n 0.31000 122070.0n 0.31000 122199.9n 0.31000 122200.0n 0.25000 122329.9n 0.25000 122330.0n 0.25000 122459.9n 0.25000 122460.0n 0.25000 122589.9n 0.25000 122590.0n 0.31000 122719.9n 0.31000 122720.0n 0.31000 122849.9n 0.31000 122850.0n 0.25000 122979.9n 0.25000 122980.0n 0.31000 123109.9n 0.31000 123110.0n 0.25000 123239.9n 0.25000 123240.0n 0.25000 123369.9n 0.25000 123370.0n 0.25000 123499.9n 0.25000 123500.0n 0.31000 123629.9n 0.31000 123630.0n 0.31000 123759.9n 0.31000 123760.0n 0.25000 123889.9n 0.25000 123890.0n 0.25000 124019.9n 0.25000 124020.0n 0.31000 124149.9n 0.31000 124150.0n 0.31000 124279.9n 0.31000 124280.0n 0.31000 124409.9n 0.31000 124410.0n 0.25000 124539.9n 0.25000 124540.0n 0.25000 124669.9n 0.25000 124670.0n 0.31000 124799.9n 0.31000 124800.0n 0.31000 124929.9n 0.31000 124930.0n 0.25000 125059.9n 0.25000 125060.0n 0.31000 125189.9n 0.31000 125190.0n 0.31000 125319.9n 0.31000 125320.0n 0.25000 125449.9n 0.25000 125450.0n 0.25000 125579.9n 0.25000 125580.0n 0.31000 125709.9n 0.31000 125710.0n 0.31000 125839.9n 0.31000 125840.0n 0.25000 125969.9n 0.25000 125970.0n 0.25000 126099.9n 0.25000 126100.0n 0.31000 126229.9n 0.31000 126230.0n 0.31000 126359.9n 0.31000 126360.0n 0.25000 126489.9n 0.25000 126490.0n 0.25000 126619.9n 0.25000 126620.0n 0.31000 126749.9n 0.31000 126750.0n 0.25000 126879.9n 0.25000 126880.0n 0.31000 127009.9n 0.31000 127010.0n 0.31000 127139.9n 0.31000 127140.0n 0.25000 127269.9n 0.25000 127270.0n 0.31000 127399.9n 0.31000 127400.0n 0.25000 127529.9n 0.25000 127530.0n 0.25000 127659.9n 0.25000 127660.0n 0.31000 127789.9n 0.31000 127790.0n 0.31000 127919.9n 0.31000 127920.0n 0.25000 128049.9n 0.25000 128050.0n 0.25000 128179.9n 0.25000 128180.0n 0.31000 128309.9n 0.31000 128310.0n 0.31000 128439.9n 0.31000 128440.0n 0.31000 128569.9n 0.31000 128570.0n 0.31000 128699.9n 0.31000 128700.0n 0.25000 128829.9n 0.25000 128830.0n 0.25000 128959.9n 0.25000 128960.0n 0.25000 129089.9n 0.25000 129090.0n 0.25000 129219.9n 0.25000 129220.0n 0.25000 129349.9n 0.25000 129350.0n 0.25000 129479.9n 0.25000 129480.0n 0.31000 129609.9n 0.31000 129610.0n 0.25000 129739.9n 0.25000 129740.0n 0.31000 129869.9n 0.31000 129870.0n 0.31000 129999.9n 0.31000 130000.0n 0.31000 130129.9n 0.31000 130130.0n 0.31000 130259.9n 0.31000 130260.0n 0.25000 130389.9n 0.25000 130390.0n 0.25000 130519.9n 0.25000 130520.0n 0.31000 130649.9n 0.31000 130650.0n 0.25000 130779.9n 0.25000 130780.0n 0.25000 130909.9n 0.25000 130910.0n 0.31000 131039.9n 0.31000 131040.0n 0.31000 131169.9n 0.31000 131170.0n 0.31000 131299.9n 0.31000 131300.0n 0.31000 131429.9n 0.31000 131430.0n 0.31000 131559.9n 0.31000 131560.0n 0.25000 131689.9n 0.25000 131690.0n 0.25000 131819.9n 0.25000 131820.0n 0.25000 131949.9n 0.25000 131950.0n 0.31000 132079.9n 0.31000 132080.0n 0.25000 132209.9n 0.25000 132210.0n 0.31000 132339.9n 0.31000 132340.0n 0.25000 132469.9n 0.25000 132470.0n 0.31000 132599.9n 0.31000 132600.0n 0.31000 132729.9n 0.31000 132730.0n 0.25000 132859.9n 0.25000 132860.0n 0.25000 132989.9n 0.25000 132990.0n 0.25000 133119.9n 0.25000 133120.0n 0.25000 133249.9n 0.25000 133250.0n 0.25000 133379.9n 0.25000 133380.0n 0.31000 133509.9n 0.31000 133510.0n 0.31000 133639.9n 0.31000 133640.0n 0.25000 133769.9n 0.25000 133770.0n 0.31000 133899.9n 0.31000 133900.0n 0.25000 134029.9n 0.25000 134030.0n 0.31000 134159.9n 0.31000 134160.0n 0.28000 134289.9n 0.28000 134290.0n 0.28000 134419.9n 0.28000 134420.0n 0.28000 134549.9n 0.28000 134550.0n 0.28000 134679.9n 0.28000 134680.0n 0.28000 134809.9n 0.28000 134810.0n 0.28000 134939.9n 0.28000 134940.0n 0.28000 135069.9n 0.28000 135070.0n 0.28000 135199.9n 0.28000 135200.0n 0.28000 135329.9n 0.28000 135330.0n 0.28000 135459.9n 0.28000 135460.0n 0.28000 135589.9n 0.28000 135590.0n 0.28000 135719.9n 0.28000 135720.0n 0.28000 135849.9n 0.28000 135850.0n 0.28000 135979.9n 0.28000 135980.0n 0.28000 136109.9n 0.28000 136110.0n 0.28000 136239.9n 0.28000 136240.0n 0.28000 136369.9n 0.28000 136370.0n 0.28000 136499.9n 0.28000 136500.0n 0.28000 136629.9n 0.28000 136630.0n 0.28000 136759.9n 0.28000 136760.0n 0.28000 136889.9n 0.28000 136890.0n 0.28000 137019.9n 0.28000 137020.0n 0.28000 137149.9n 0.28000 137150.0n 0.28000 137279.9n 0.28000 137280.0n 0.28000 137409.9n 0.28000 137410.0n 0.28000 137539.9n 0.28000 137540.0n 0.28000 137669.9n 0.28000 137670.0n 0.28000 137799.9n 0.28000 137800.0n 0.28000 137929.9n 0.28000 137930.0n 0.28000 138059.9n 0.28000 138060.0n 0.28000 138189.9n 0.28000 138190.0n 0.28000 138319.9n 0.28000 138320.0n 0.28000 138449.9n 0.28000 138450.0n 0.28000 138579.9n 0.28000 138580.0n 0.28000 138709.9n 0.28000 138710.0n 0.28000 138839.9n 0.28000 138840.0n 0.28000 138969.9n 0.28000 138970.0n 0.28000 139099.9n 0.28000 139100.0n 0.28000 139229.9n 0.28000 139230.0n 0.28000 139359.9n 0.28000 139360.0n 0.28000 139489.9n 0.28000 139490.0n 0.28000 139619.9n 0.28000 139620.0n 0.28000 139749.9n 0.28000 139750.0n 0.28000 139879.9n 0.28000 139880.0n 0.28000 140009.9n 0.28000 140010.0n 0.28000 140139.9n 0.28000 140140.0n 0.28000 140269.9n 0.28000 140270.0n 0.28000 140399.9n 0.28000 140400.0n 0.31000 140529.9n 0.31000 140530.0n 0.25000 140659.9n 0.25000 140660.0n 0.31000 140789.9n 0.31000 140790.0n 0.31000 140919.9n 0.31000 140920.0n 0.25000 141049.9n 0.25000 141050.0n 0.25000 141179.9n 0.25000 141180.0n 0.31000 141309.9n 0.31000 141310.0n 0.25000 141439.9n 0.25000 141440.0n 0.31000 141569.9n 0.31000 141570.0n 0.25000 141699.9n 0.25000 141700.0n 0.25000 141829.9n 0.25000 141830.0n 0.31000 141959.9n 0.31000 141960.0n 0.31000 142089.9n 0.31000 142090.0n 0.31000 142219.9n 0.31000 142220.0n 0.25000 142349.9n 0.25000 142350.0n 0.31000 142479.9n 0.31000 142480.0n 0.25000 142609.9n 0.25000 142610.0n 0.31000 142739.9n 0.31000 142740.0n 0.31000 142869.9n 0.31000 142870.0n 0.31000 142999.9n 0.31000 143000.0n 0.31000 143129.9n 0.31000 143130.0n 0.25000 143259.9n 0.25000 143260.0n 0.31000 143389.9n 0.31000 143390.0n 0.25000 143519.9n 0.25000 143520.0n 0.25000 143649.9n 0.25000 143650.0n 0.25000 143779.9n 0.25000 143780.0n 0.25000 143909.9n 0.25000 143910.0n 0.25000 144039.9n 0.25000 144040.0n 0.31000 144169.9n 0.31000 144170.0n 0.31000 144299.9n 0.31000 144300.0n 0.25000 144429.9n 0.25000 144430.0n 0.25000 144559.9n 0.25000 144560.0n 0.25000 144689.9n 0.25000 144690.0n 0.25000 144819.9n 0.25000 144820.0n 0.31000 144949.9n 0.31000 144950.0n 0.25000 145079.9n 0.25000 145080.0n 0.25000 145209.9n 0.25000 145210.0n 0.31000 145339.9n 0.31000 145340.0n 0.31000 145469.9n 0.31000 145470.0n 0.31000 145599.9n 0.31000 145600.0n 0.25000 145729.9n 0.25000 145730.0n 0.25000 145859.9n 0.25000 145860.0n 0.31000 145989.9n 0.31000 145990.0n 0.31000 146119.9n 0.31000 146120.0n 0.31000 146249.9n 0.31000 146250.0n 0.25000 146379.9n 0.25000 146380.0n 0.31000 146509.9n 0.31000 146510.0n 0.25000 146639.9n 0.25000 146640.0n 0.25000 146769.9n 0.25000 146770.0n 0.25000 146899.9n 0.25000 146900.0n 0.25000 147029.9n 0.25000 147030.0n 0.31000 147159.9n 0.31000 147160.0n 0.31000 147289.9n 0.31000 147290.0n 0.25000 147419.9n 0.25000 147420.0n 0.31000 147549.9n 0.31000 147550.0n 0.31000 147679.9n 0.31000 147680.0n 0.25000 147809.9n 0.25000 147810.0n 0.31000 147939.9n 0.31000 147940.0n 0.25000 148069.9n 0.25000 148070.0n 0.31000 148199.9n 0.31000 148200.0n 0.31000 148329.9n 0.31000 148330.0n 0.31000 148459.9n 0.31000 148460.0n 0.31000 148589.9n 0.31000 148590.0n 0.25000 148719.9n 0.25000 148720.0n 0.31000 148849.9n 0.31000 148850.0n 0.25000 148979.9n 0.25000 148980.0n 0.25000 149109.9n 0.25000 149110.0n 0.25000 149239.9n 0.25000 149240.0n 0.31000 149369.9n 0.31000 149370.0n 0.31000 149499.9n 0.31000 149500.0n 0.25000 149629.9n 0.25000 149630.0n 0.31000 149759.9n 0.31000 149760.0n 0.31000 149889.9n 0.31000 149890.0n 0.25000 150019.9n 0.25000 150020.0n 0.25000 150149.9n 0.25000 150150.0n 0.31000 150279.9n 0.31000 150280.0n 0.25000 150409.9n 0.25000 150410.0n 0.25000 150539.9n 0.25000 150540.0n 0.31000 150669.9n 0.31000 150670.0n 0.25000 150799.9n 0.25000 150800.0n 0.31000 150929.9n 0.31000 150930.0n 0.31000 151059.9n 0.31000 151060.0n 0.25000 151189.9n 0.25000 151190.0n 0.25000 151319.9n 0.25000 151320.0n 0.31000 151449.9n 0.31000 151450.0n 0.25000 151579.9n 0.25000 151580.0n 0.31000 151709.9n 0.31000 151710.0n 0.25000 151839.9n 0.25000 151840.0n 0.25000 151969.9n 0.25000 151970.0n 0.31000 152099.9n 0.31000 152100.0n 0.25000 152229.9n 0.25000 152230.0n 0.31000 152359.9n 0.31000 152360.0n 0.25000 152489.9n 0.25000 152490.0n 0.31000 152619.9n 0.31000 152620.0n 0.31000 152749.9n 0.31000 152750.0n 0.25000 152879.9n 0.25000 152880.0n 0.25000 153009.9n 0.25000 153010.0n 0.31000 153139.9n 0.31000 153140.0n 0.25000 153269.9n 0.25000 153270.0n 0.31000 153399.9n 0.31000 153400.0n 0.31000 153529.9n 0.31000 153530.0n 0.25000 153659.9n 0.25000 153660.0n 0.25000 153789.9n 0.25000 153790.0n 0.25000 153919.9n 0.25000 153920.0n 0.31000 154049.9n 0.31000 154050.0n 0.31000 154179.9n 0.31000 154180.0n 0.31000 154309.9n 0.31000 154310.0n 0.25000 154439.9n 0.25000 154440.0n 0.25000 154569.9n 0.25000 154570.0n 0.25000 154699.9n 0.25000 154700.0n 0.31000 154829.9n 0.31000 154830.0n 0.31000 154959.9n 0.31000 154960.0n 0.31000 155089.9n 0.31000 155090.0n 0.25000 155219.9n 0.25000 155220.0n 0.31000 155349.9n 0.31000 155350.0n 0.25000 155479.9n 0.25000 155480.0n 0.25000 155609.9n 0.25000 155610.0n 0.31000 155739.9n 0.31000 155740.0n 0.25000 155869.9n 0.25000 155870.0n 0.25000 155999.9n 0.25000 156000.0n 0.25000 156129.9n 0.25000 156130.0n 0.31000 156259.9n 0.31000 156260.0n 0.25000 156389.9n 0.25000 156390.0n 0.25000 156519.9n 0.25000 156520.0n 0.31000 156649.9n 0.31000 156650.0n 0.31000 156779.9n 0.31000 156780.0n 0.31000 156909.9n 0.31000 156910.0n 0.25000 157039.9n 0.25000 157040.0n 0.31000 157169.9n 0.31000 157170.0n 0.25000 157299.9n 0.25000 157300.0n 0.25000 157429.9n 0.25000 157430.0n 0.25000 157559.9n 0.25000 157560.0n 0.31000 157689.9n 0.31000 157690.0n 0.31000 157819.9n 0.31000 157820.0n 0.25000 157949.9n 0.25000 157950.0n 0.31000 158079.9n 0.31000 158080.0n 0.31000 158209.9n 0.31000 158210.0n 0.31000 158339.9n 0.31000 158340.0n 0.25000 158469.9n 0.25000 158470.0n 0.31000 158599.9n 0.31000 158600.0n 0.25000 158729.9n 0.25000 158730.0n 0.25000 158859.9n 0.25000 158860.0n 0.25000 158989.9n 0.25000 158990.0n 0.25000 159119.9n 0.25000 159120.0n 0.31000 159249.9n 0.31000 159250.0n 0.31000 159379.9n 0.31000 159380.0n 0.25000 159509.9n 0.25000 159510.0n 0.25000 159639.9n 0.25000 159640.0n 0.25000 159769.9n 0.25000 159770.0n 0.25000 159899.9n 0.25000 159900.0n 0.31000 160029.9n 0.31000 160030.0n 0.31000 160159.9n 0.31000 160160.0n 0.31000 160289.9n 0.31000 160290.0n 0.25000 160419.9n 0.25000 160420.0n 0.25000 160549.9n 0.25000 160550.0n 0.31000 160679.9n 0.31000 160680.0n 0.31000 160809.9n 0.31000 160810.0n 0.31000 160939.9n 0.31000 160940.0n 0.25000 161069.9n 0.25000 161070.0n 0.31000 161199.9n 0.31000 161200.0n 0.25000 161329.9n 0.25000 161330.0n 0.31000 161459.9n 0.31000 161460.0n 0.31000 161589.9n 0.31000 161590.0n 0.25000 161719.9n 0.25000 161720.0n 0.31000 161849.9n 0.31000 161850.0n 0.31000 161979.9n 0.31000 161980.0n 0.25000 162109.9n 0.25000 162110.0n 0.31000 162239.9n 0.31000 162240.0n 0.28000 162369.9n 0.28000 162370.0n 0.28000 162499.9n 0.28000 162500.0n 0.28000 162629.9n 0.28000 162630.0n 0.28000 162759.9n 0.28000 162760.0n 0.28000 162889.9n 0.28000 162890.0n 0.28000 163019.9n 0.28000 163020.0n 0.28000 163149.9n 0.28000 163150.0n 0.28000 163279.9n 0.28000 163280.0n 0.28000 163409.9n 0.28000 163410.0n 0.28000 163539.9n 0.28000 163540.0n 0.28000 163669.9n 0.28000 163670.0n 0.28000 163799.9n 0.28000 163800.0n 0.28000 163929.9n 0.28000 163930.0n 0.28000 164059.9n 0.28000 164060.0n 0.28000 164189.9n 0.28000 164190.0n 0.28000 164319.9n 0.28000 164320.0n 0.28000 164449.9n 0.28000 164450.0n 0.28000 164579.9n 0.28000 164580.0n 0.28000 164709.9n 0.28000 164710.0n 0.28000 164839.9n 0.28000 164840.0n 0.28000 164969.9n 0.28000 164970.0n 0.28000 165099.9n 0.28000 165100.0n 0.28000 165229.9n 0.28000 165230.0n 0.28000 165359.9n 0.28000 165360.0n 0.28000 165489.9n 0.28000 165490.0n 0.28000 165619.9n 0.28000 165620.0n 0.28000 165749.9n 0.28000 165750.0n 0.28000 165879.9n 0.28000 165880.0n 0.28000 166009.9n 0.28000 166010.0n 0.28000 166139.9n 0.28000 166140.0n 0.28000 166269.9n 0.28000 166270.0n 0.28000 166399.9n 0.28000 166400.0n 0.28000 166529.9n 0.28000 166530.0n 0.28000 166659.9n 0.28000 166660.0n 0.28000 166789.9n 0.28000 166790.0n 0.28000 166919.9n 0.28000 166920.0n 0.28000 167049.9n 0.28000 167050.0n 0.28000 167179.9n 0.28000 167180.0n 0.28000 167309.9n 0.28000 167310.0n 0.28000 167439.9n 0.28000 167440.0n 0.28000 167569.9n 0.28000 167570.0n 0.28000 167699.9n 0.28000 167700.0n 0.28000 167829.9n 0.28000 167830.0n 0.28000 167959.9n 0.28000 167960.0n 0.28000 168089.9n 0.28000 168090.0n 0.28000 168219.9n 0.28000 168220.0n 0.28000 168349.9n 0.28000 168350.0n 0.28000)
Vxon1 xon1 0 PWL(0.0n 0.25000 129.9n 0.25000 130.0n 0.31000 259.9n 0.31000 260.0n 0.31000 389.9n 0.31000 390.0n 0.31000 519.9n 0.31000 520.0n 0.31000 649.9n 0.31000 650.0n 0.31000 779.9n 0.31000 780.0n 0.25000 909.9n 0.25000 910.0n 0.25000 1039.9n 0.25000 1040.0n 0.25000 1169.9n 0.25000 1170.0n 0.25000 1299.9n 0.25000 1300.0n 0.25000 1429.9n 0.25000 1430.0n 0.31000 1559.9n 0.31000 1560.0n 0.31000 1689.9n 0.31000 1690.0n 0.31000 1819.9n 0.31000 1820.0n 0.25000 1949.9n 0.25000 1950.0n 0.31000 2079.9n 0.31000 2080.0n 0.31000 2209.9n 0.31000 2210.0n 0.25000 2339.9n 0.25000 2340.0n 0.31000 2469.9n 0.31000 2470.0n 0.25000 2599.9n 0.25000 2600.0n 0.25000 2729.9n 0.25000 2730.0n 0.31000 2859.9n 0.31000 2860.0n 0.25000 2989.9n 0.25000 2990.0n 0.25000 3119.9n 0.25000 3120.0n 0.31000 3249.9n 0.31000 3250.0n 0.31000 3379.9n 0.31000 3380.0n 0.25000 3509.9n 0.25000 3510.0n 0.25000 3639.9n 0.25000 3640.0n 0.31000 3769.9n 0.31000 3770.0n 0.25000 3899.9n 0.25000 3900.0n 0.25000 4029.9n 0.25000 4030.0n 0.25000 4159.9n 0.25000 4160.0n 0.31000 4289.9n 0.31000 4290.0n 0.25000 4419.9n 0.25000 4420.0n 0.25000 4549.9n 0.25000 4550.0n 0.25000 4679.9n 0.25000 4680.0n 0.25000 4809.9n 0.25000 4810.0n 0.31000 4939.9n 0.31000 4940.0n 0.31000 5069.9n 0.31000 5070.0n 0.31000 5199.9n 0.31000 5200.0n 0.31000 5329.9n 0.31000 5330.0n 0.31000 5459.9n 0.31000 5460.0n 0.31000 5589.9n 0.31000 5590.0n 0.31000 5719.9n 0.31000 5720.0n 0.25000 5849.9n 0.25000 5850.0n 0.25000 5979.9n 0.25000 5980.0n 0.25000 6109.9n 0.25000 6110.0n 0.25000 6239.9n 0.25000 6240.0n 0.25000 6369.9n 0.25000 6370.0n 0.31000 6499.9n 0.31000 6500.0n 0.31000 6629.9n 0.31000 6630.0n 0.31000 6759.9n 0.31000 6760.0n 0.31000 6889.9n 0.31000 6890.0n 0.25000 7019.9n 0.25000 7020.0n 0.31000 7149.9n 0.31000 7150.0n 0.25000 7279.9n 0.25000 7280.0n 0.31000 7409.9n 0.31000 7410.0n 0.31000 7539.9n 0.31000 7540.0n 0.25000 7669.9n 0.25000 7670.0n 0.31000 7799.9n 0.31000 7800.0n 0.31000 7929.9n 0.31000 7930.0n 0.25000 8059.9n 0.25000 8060.0n 0.25000 8189.9n 0.25000 8190.0n 0.31000 8319.9n 0.31000 8320.0n 0.25000 8449.9n 0.25000 8450.0n 0.25000 8579.9n 0.25000 8580.0n 0.31000 8709.9n 0.31000 8710.0n 0.25000 8839.9n 0.25000 8840.0n 0.31000 8969.9n 0.31000 8970.0n 0.25000 9099.9n 0.25000 9100.0n 0.25000 9229.9n 0.25000 9230.0n 0.31000 9359.9n 0.31000 9360.0n 0.31000 9489.9n 0.31000 9490.0n 0.25000 9619.9n 0.25000 9620.0n 0.31000 9749.9n 0.31000 9750.0n 0.25000 9879.9n 0.25000 9880.0n 0.31000 10009.9n 0.31000 10010.0n 0.31000 10139.9n 0.31000 10140.0n 0.31000 10269.9n 0.31000 10270.0n 0.25000 10399.9n 0.25000 10400.0n 0.25000 10529.9n 0.25000 10530.0n 0.25000 10659.9n 0.25000 10660.0n 0.25000 10789.9n 0.25000 10790.0n 0.31000 10919.9n 0.31000 10920.0n 0.25000 11049.9n 0.25000 11050.0n 0.31000 11179.9n 0.31000 11180.0n 0.31000 11309.9n 0.31000 11310.0n 0.25000 11439.9n 0.25000 11440.0n 0.25000 11569.9n 0.25000 11570.0n 0.31000 11699.9n 0.31000 11700.0n 0.25000 11829.9n 0.25000 11830.0n 0.25000 11959.9n 0.25000 11960.0n 0.31000 12089.9n 0.31000 12090.0n 0.25000 12219.9n 0.25000 12220.0n 0.25000 12349.9n 0.25000 12350.0n 0.31000 12479.9n 0.31000 12480.0n 0.25000 12609.9n 0.25000 12610.0n 0.25000 12739.9n 0.25000 12740.0n 0.25000 12869.9n 0.25000 12870.0n 0.25000 12999.9n 0.25000 13000.0n 0.31000 13129.9n 0.31000 13130.0n 0.31000 13259.9n 0.31000 13260.0n 0.31000 13389.9n 0.31000 13390.0n 0.25000 13519.9n 0.25000 13520.0n 0.31000 13649.9n 0.31000 13650.0n 0.31000 13779.9n 0.31000 13780.0n 0.31000 13909.9n 0.31000 13910.0n 0.31000 14039.9n 0.31000 14040.0n 0.25000 14169.9n 0.25000 14170.0n 0.31000 14299.9n 0.31000 14300.0n 0.25000 14429.9n 0.25000 14430.0n 0.31000 14559.9n 0.31000 14560.0n 0.25000 14689.9n 0.25000 14690.0n 0.31000 14819.9n 0.31000 14820.0n 0.25000 14949.9n 0.25000 14950.0n 0.25000 15079.9n 0.25000 15080.0n 0.31000 15209.9n 0.31000 15210.0n 0.25000 15339.9n 0.25000 15340.0n 0.31000 15469.9n 0.31000 15470.0n 0.31000 15599.9n 0.31000 15600.0n 0.31000 15729.9n 0.31000 15730.0n 0.25000 15859.9n 0.25000 15860.0n 0.25000 15989.9n 0.25000 15990.0n 0.31000 16119.9n 0.31000 16120.0n 0.31000 16249.9n 0.31000 16250.0n 0.25000 16379.9n 0.25000 16380.0n 0.25000 16509.9n 0.25000 16510.0n 0.31000 16639.9n 0.31000 16640.0n 0.25000 16769.9n 0.25000 16770.0n 0.31000 16899.9n 0.31000 16900.0n 0.25000 17029.9n 0.25000 17030.0n 0.31000 17159.9n 0.31000 17160.0n 0.31000 17289.9n 0.31000 17290.0n 0.25000 17419.9n 0.25000 17420.0n 0.31000 17549.9n 0.31000 17550.0n 0.25000 17679.9n 0.25000 17680.0n 0.25000 17809.9n 0.25000 17810.0n 0.25000 17939.9n 0.25000 17940.0n 0.31000 18069.9n 0.31000 18070.0n 0.31000 18199.9n 0.31000 18200.0n 0.25000 18329.9n 0.25000 18330.0n 0.25000 18459.9n 0.25000 18460.0n 0.31000 18589.9n 0.31000 18590.0n 0.31000 18719.9n 0.31000 18720.0n 0.31000 18849.9n 0.31000 18850.0n 0.31000 18979.9n 0.31000 18980.0n 0.31000 19109.9n 0.31000 19110.0n 0.25000 19239.9n 0.25000 19240.0n 0.25000 19369.9n 0.25000 19370.0n 0.25000 19499.9n 0.25000 19500.0n 0.25000 19629.9n 0.25000 19630.0n 0.31000 19759.9n 0.31000 19760.0n 0.25000 19889.9n 0.25000 19890.0n 0.31000 20019.9n 0.31000 20020.0n 0.25000 20149.9n 0.25000 20150.0n 0.31000 20279.9n 0.31000 20280.0n 0.25000 20409.9n 0.25000 20410.0n 0.31000 20539.9n 0.31000 20540.0n 0.31000 20669.9n 0.31000 20670.0n 0.31000 20799.9n 0.31000 20800.0n 0.25000 20929.9n 0.25000 20930.0n 0.25000 21059.9n 0.25000 21060.0n 0.31000 21189.9n 0.31000 21190.0n 0.25000 21319.9n 0.25000 21320.0n 0.31000 21449.9n 0.31000 21450.0n 0.25000 21579.9n 0.25000 21580.0n 0.25000 21709.9n 0.25000 21710.0n 0.31000 21839.9n 0.31000 21840.0n 0.28000 21969.9n 0.28000 21970.0n 0.28000 22099.9n 0.28000 22100.0n 0.28000 22229.9n 0.28000 22230.0n 0.28000 22359.9n 0.28000 22360.0n 0.28000 22489.9n 0.28000 22490.0n 0.28000 22619.9n 0.28000 22620.0n 0.28000 22749.9n 0.28000 22750.0n 0.28000 22879.9n 0.28000 22880.0n 0.28000 23009.9n 0.28000 23010.0n 0.28000 23139.9n 0.28000 23140.0n 0.28000 23269.9n 0.28000 23270.0n 0.28000 23399.9n 0.28000 23400.0n 0.28000 23529.9n 0.28000 23530.0n 0.28000 23659.9n 0.28000 23660.0n 0.28000 23789.9n 0.28000 23790.0n 0.28000 23919.9n 0.28000 23920.0n 0.28000 24049.9n 0.28000 24050.0n 0.28000 24179.9n 0.28000 24180.0n 0.28000 24309.9n 0.28000 24310.0n 0.28000 24439.9n 0.28000 24440.0n 0.28000 24569.9n 0.28000 24570.0n 0.28000 24699.9n 0.28000 24700.0n 0.28000 24829.9n 0.28000 24830.0n 0.28000 24959.9n 0.28000 24960.0n 0.28000 25089.9n 0.28000 25090.0n 0.28000 25219.9n 0.28000 25220.0n 0.28000 25349.9n 0.28000 25350.0n 0.28000 25479.9n 0.28000 25480.0n 0.28000 25609.9n 0.28000 25610.0n 0.28000 25739.9n 0.28000 25740.0n 0.28000 25869.9n 0.28000 25870.0n 0.28000 25999.9n 0.28000 26000.0n 0.28000 26129.9n 0.28000 26130.0n 0.28000 26259.9n 0.28000 26260.0n 0.28000 26389.9n 0.28000 26390.0n 0.28000 26519.9n 0.28000 26520.0n 0.28000 26649.9n 0.28000 26650.0n 0.28000 26779.9n 0.28000 26780.0n 0.28000 26909.9n 0.28000 26910.0n 0.28000 27039.9n 0.28000 27040.0n 0.28000 27169.9n 0.28000 27170.0n 0.28000 27299.9n 0.28000 27300.0n 0.28000 27429.9n 0.28000 27430.0n 0.28000 27559.9n 0.28000 27560.0n 0.28000 27689.9n 0.28000 27690.0n 0.28000 27819.9n 0.28000 27820.0n 0.28000 27949.9n 0.28000 27950.0n 0.28000 28079.9n 0.28000 28080.0n 0.31000 28209.9n 0.31000 28210.0n 0.31000 28339.9n 0.31000 28340.0n 0.25000 28469.9n 0.25000 28470.0n 0.25000 28599.9n 0.25000 28600.0n 0.25000 28729.9n 0.25000 28730.0n 0.31000 28859.9n 0.31000 28860.0n 0.25000 28989.9n 0.25000 28990.0n 0.25000 29119.9n 0.25000 29120.0n 0.31000 29249.9n 0.31000 29250.0n 0.25000 29379.9n 0.25000 29380.0n 0.25000 29509.9n 0.25000 29510.0n 0.31000 29639.9n 0.31000 29640.0n 0.25000 29769.9n 0.25000 29770.0n 0.25000 29899.9n 0.25000 29900.0n 0.31000 30029.9n 0.31000 30030.0n 0.25000 30159.9n 0.25000 30160.0n 0.25000 30289.9n 0.25000 30290.0n 0.25000 30419.9n 0.25000 30420.0n 0.25000 30549.9n 0.25000 30550.0n 0.31000 30679.9n 0.31000 30680.0n 0.31000 30809.9n 0.31000 30810.0n 0.31000 30939.9n 0.31000 30940.0n 0.31000 31069.9n 0.31000 31070.0n 0.31000 31199.9n 0.31000 31200.0n 0.31000 31329.9n 0.31000 31330.0n 0.25000 31459.9n 0.25000 31460.0n 0.31000 31589.9n 0.31000 31590.0n 0.31000 31719.9n 0.31000 31720.0n 0.25000 31849.9n 0.25000 31850.0n 0.31000 31979.9n 0.31000 31980.0n 0.31000 32109.9n 0.31000 32110.0n 0.31000 32239.9n 0.31000 32240.0n 0.31000 32369.9n 0.31000 32370.0n 0.31000 32499.9n 0.31000 32500.0n 0.25000 32629.9n 0.25000 32630.0n 0.25000 32759.9n 0.25000 32760.0n 0.25000 32889.9n 0.25000 32890.0n 0.31000 33019.9n 0.31000 33020.0n 0.25000 33149.9n 0.25000 33150.0n 0.25000 33279.9n 0.25000 33280.0n 0.25000 33409.9n 0.25000 33410.0n 0.25000 33539.9n 0.25000 33540.0n 0.31000 33669.9n 0.31000 33670.0n 0.25000 33799.9n 0.25000 33800.0n 0.31000 33929.9n 0.31000 33930.0n 0.25000 34059.9n 0.25000 34060.0n 0.31000 34189.9n 0.31000 34190.0n 0.31000 34319.9n 0.31000 34320.0n 0.31000 34449.9n 0.31000 34450.0n 0.25000 34579.9n 0.25000 34580.0n 0.31000 34709.9n 0.31000 34710.0n 0.31000 34839.9n 0.31000 34840.0n 0.25000 34969.9n 0.25000 34970.0n 0.25000 35099.9n 0.25000 35100.0n 0.25000 35229.9n 0.25000 35230.0n 0.31000 35359.9n 0.31000 35360.0n 0.25000 35489.9n 0.25000 35490.0n 0.31000 35619.9n 0.31000 35620.0n 0.25000 35749.9n 0.25000 35750.0n 0.25000 35879.9n 0.25000 35880.0n 0.31000 36009.9n 0.31000 36010.0n 0.25000 36139.9n 0.25000 36140.0n 0.25000 36269.9n 0.25000 36270.0n 0.31000 36399.9n 0.31000 36400.0n 0.31000 36529.9n 0.31000 36530.0n 0.31000 36659.9n 0.31000 36660.0n 0.25000 36789.9n 0.25000 36790.0n 0.25000 36919.9n 0.25000 36920.0n 0.25000 37049.9n 0.25000 37050.0n 0.25000 37179.9n 0.25000 37180.0n 0.25000 37309.9n 0.25000 37310.0n 0.25000 37439.9n 0.25000 37440.0n 0.31000 37569.9n 0.31000 37570.0n 0.31000 37699.9n 0.31000 37700.0n 0.31000 37829.9n 0.31000 37830.0n 0.31000 37959.9n 0.31000 37960.0n 0.31000 38089.9n 0.31000 38090.0n 0.31000 38219.9n 0.31000 38220.0n 0.31000 38349.9n 0.31000 38350.0n 0.25000 38479.9n 0.25000 38480.0n 0.25000 38609.9n 0.25000 38610.0n 0.31000 38739.9n 0.31000 38740.0n 0.25000 38869.9n 0.25000 38870.0n 0.31000 38999.9n 0.31000 39000.0n 0.25000 39129.9n 0.25000 39130.0n 0.31000 39259.9n 0.31000 39260.0n 0.31000 39389.9n 0.31000 39390.0n 0.31000 39519.9n 0.31000 39520.0n 0.25000 39649.9n 0.25000 39650.0n 0.31000 39779.9n 0.31000 39780.0n 0.25000 39909.9n 0.25000 39910.0n 0.25000 40039.9n 0.25000 40040.0n 0.25000 40169.9n 0.25000 40170.0n 0.31000 40299.9n 0.31000 40300.0n 0.31000 40429.9n 0.31000 40430.0n 0.31000 40559.9n 0.31000 40560.0n 0.25000 40689.9n 0.25000 40690.0n 0.25000 40819.9n 0.25000 40820.0n 0.31000 40949.9n 0.31000 40950.0n 0.25000 41079.9n 0.25000 41080.0n 0.25000 41209.9n 0.25000 41210.0n 0.25000 41339.9n 0.25000 41340.0n 0.31000 41469.9n 0.31000 41470.0n 0.31000 41599.9n 0.31000 41600.0n 0.25000 41729.9n 0.25000 41730.0n 0.25000 41859.9n 0.25000 41860.0n 0.25000 41989.9n 0.25000 41990.0n 0.31000 42119.9n 0.31000 42120.0n 0.31000 42249.9n 0.31000 42250.0n 0.31000 42379.9n 0.31000 42380.0n 0.31000 42509.9n 0.31000 42510.0n 0.25000 42639.9n 0.25000 42640.0n 0.25000 42769.9n 0.25000 42770.0n 0.31000 42899.9n 0.31000 42900.0n 0.31000 43029.9n 0.31000 43030.0n 0.25000 43159.9n 0.25000 43160.0n 0.31000 43289.9n 0.31000 43290.0n 0.25000 43419.9n 0.25000 43420.0n 0.25000 43549.9n 0.25000 43550.0n 0.25000 43679.9n 0.25000 43680.0n 0.25000 43809.9n 0.25000 43810.0n 0.25000 43939.9n 0.25000 43940.0n 0.31000 44069.9n 0.31000 44070.0n 0.25000 44199.9n 0.25000 44200.0n 0.25000 44329.9n 0.25000 44330.0n 0.31000 44459.9n 0.31000 44460.0n 0.31000 44589.9n 0.31000 44590.0n 0.31000 44719.9n 0.31000 44720.0n 0.31000 44849.9n 0.31000 44850.0n 0.25000 44979.9n 0.25000 44980.0n 0.31000 45109.9n 0.31000 45110.0n 0.25000 45239.9n 0.25000 45240.0n 0.31000 45369.9n 0.31000 45370.0n 0.31000 45499.9n 0.31000 45500.0n 0.31000 45629.9n 0.31000 45630.0n 0.31000 45759.9n 0.31000 45760.0n 0.31000 45889.9n 0.31000 45890.0n 0.25000 46019.9n 0.25000 46020.0n 0.25000 46149.9n 0.25000 46150.0n 0.25000 46279.9n 0.25000 46280.0n 0.25000 46409.9n 0.25000 46410.0n 0.31000 46539.9n 0.31000 46540.0n 0.31000 46669.9n 0.31000 46670.0n 0.25000 46799.9n 0.25000 46800.0n 0.31000 46929.9n 0.31000 46930.0n 0.25000 47059.9n 0.25000 47060.0n 0.25000 47189.9n 0.25000 47190.0n 0.31000 47319.9n 0.31000 47320.0n 0.31000 47449.9n 0.31000 47450.0n 0.31000 47579.9n 0.31000 47580.0n 0.31000 47709.9n 0.31000 47710.0n 0.31000 47839.9n 0.31000 47840.0n 0.31000 47969.9n 0.31000 47970.0n 0.25000 48099.9n 0.25000 48100.0n 0.31000 48229.9n 0.31000 48230.0n 0.25000 48359.9n 0.25000 48360.0n 0.31000 48489.9n 0.31000 48490.0n 0.25000 48619.9n 0.25000 48620.0n 0.25000 48749.9n 0.25000 48750.0n 0.25000 48879.9n 0.25000 48880.0n 0.25000 49009.9n 0.25000 49010.0n 0.25000 49139.9n 0.25000 49140.0n 0.31000 49269.9n 0.31000 49270.0n 0.25000 49399.9n 0.25000 49400.0n 0.31000 49529.9n 0.31000 49530.0n 0.25000 49659.9n 0.25000 49660.0n 0.31000 49789.9n 0.31000 49790.0n 0.25000 49919.9n 0.25000 49920.0n 0.28000 50049.9n 0.28000 50050.0n 0.28000 50179.9n 0.28000 50180.0n 0.28000 50309.9n 0.28000 50310.0n 0.28000 50439.9n 0.28000 50440.0n 0.28000 50569.9n 0.28000 50570.0n 0.28000 50699.9n 0.28000 50700.0n 0.28000 50829.9n 0.28000 50830.0n 0.28000 50959.9n 0.28000 50960.0n 0.28000 51089.9n 0.28000 51090.0n 0.28000 51219.9n 0.28000 51220.0n 0.28000 51349.9n 0.28000 51350.0n 0.28000 51479.9n 0.28000 51480.0n 0.28000 51609.9n 0.28000 51610.0n 0.28000 51739.9n 0.28000 51740.0n 0.28000 51869.9n 0.28000 51870.0n 0.28000 51999.9n 0.28000 52000.0n 0.28000 52129.9n 0.28000 52130.0n 0.28000 52259.9n 0.28000 52260.0n 0.28000 52389.9n 0.28000 52390.0n 0.28000 52519.9n 0.28000 52520.0n 0.28000 52649.9n 0.28000 52650.0n 0.28000 52779.9n 0.28000 52780.0n 0.28000 52909.9n 0.28000 52910.0n 0.28000 53039.9n 0.28000 53040.0n 0.28000 53169.9n 0.28000 53170.0n 0.28000 53299.9n 0.28000 53300.0n 0.28000 53429.9n 0.28000 53430.0n 0.28000 53559.9n 0.28000 53560.0n 0.28000 53689.9n 0.28000 53690.0n 0.28000 53819.9n 0.28000 53820.0n 0.28000 53949.9n 0.28000 53950.0n 0.28000 54079.9n 0.28000 54080.0n 0.28000 54209.9n 0.28000 54210.0n 0.28000 54339.9n 0.28000 54340.0n 0.28000 54469.9n 0.28000 54470.0n 0.28000 54599.9n 0.28000 54600.0n 0.28000 54729.9n 0.28000 54730.0n 0.28000 54859.9n 0.28000 54860.0n 0.28000 54989.9n 0.28000 54990.0n 0.28000 55119.9n 0.28000 55120.0n 0.28000 55249.9n 0.28000 55250.0n 0.28000 55379.9n 0.28000 55380.0n 0.28000 55509.9n 0.28000 55510.0n 0.28000 55639.9n 0.28000 55640.0n 0.28000 55769.9n 0.28000 55770.0n 0.28000 55899.9n 0.28000 55900.0n 0.28000 56029.9n 0.28000 56030.0n 0.28000 56159.9n 0.28000 56160.0n 0.31000 56289.9n 0.31000 56290.0n 0.31000 56419.9n 0.31000 56420.0n 0.25000 56549.9n 0.25000 56550.0n 0.25000 56679.9n 0.25000 56680.0n 0.25000 56809.9n 0.25000 56810.0n 0.31000 56939.9n 0.31000 56940.0n 0.31000 57069.9n 0.31000 57070.0n 0.25000 57199.9n 0.25000 57200.0n 0.25000 57329.9n 0.25000 57330.0n 0.25000 57459.9n 0.25000 57460.0n 0.31000 57589.9n 0.31000 57590.0n 0.31000 57719.9n 0.31000 57720.0n 0.31000 57849.9n 0.31000 57850.0n 0.25000 57979.9n 0.25000 57980.0n 0.31000 58109.9n 0.31000 58110.0n 0.31000 58239.9n 0.31000 58240.0n 0.31000 58369.9n 0.31000 58370.0n 0.25000 58499.9n 0.25000 58500.0n 0.31000 58629.9n 0.31000 58630.0n 0.25000 58759.9n 0.25000 58760.0n 0.25000 58889.9n 0.25000 58890.0n 0.25000 59019.9n 0.25000 59020.0n 0.25000 59149.9n 0.25000 59150.0n 0.25000 59279.9n 0.25000 59280.0n 0.31000 59409.9n 0.31000 59410.0n 0.31000 59539.9n 0.31000 59540.0n 0.31000 59669.9n 0.31000 59670.0n 0.25000 59799.9n 0.25000 59800.0n 0.25000 59929.9n 0.25000 59930.0n 0.31000 60059.9n 0.31000 60060.0n 0.25000 60189.9n 0.25000 60190.0n 0.31000 60319.9n 0.31000 60320.0n 0.31000 60449.9n 0.31000 60450.0n 0.31000 60579.9n 0.31000 60580.0n 0.31000 60709.9n 0.31000 60710.0n 0.25000 60839.9n 0.25000 60840.0n 0.31000 60969.9n 0.31000 60970.0n 0.31000 61099.9n 0.31000 61100.0n 0.31000 61229.9n 0.31000 61230.0n 0.25000 61359.9n 0.25000 61360.0n 0.25000 61489.9n 0.25000 61490.0n 0.31000 61619.9n 0.31000 61620.0n 0.31000 61749.9n 0.31000 61750.0n 0.25000 61879.9n 0.25000 61880.0n 0.31000 62009.9n 0.31000 62010.0n 0.31000 62139.9n 0.31000 62140.0n 0.31000 62269.9n 0.31000 62270.0n 0.25000 62399.9n 0.25000 62400.0n 0.25000 62529.9n 0.25000 62530.0n 0.25000 62659.9n 0.25000 62660.0n 0.25000 62789.9n 0.25000 62790.0n 0.25000 62919.9n 0.25000 62920.0n 0.25000 63049.9n 0.25000 63050.0n 0.25000 63179.9n 0.25000 63180.0n 0.25000 63309.9n 0.25000 63310.0n 0.31000 63439.9n 0.31000 63440.0n 0.25000 63569.9n 0.25000 63570.0n 0.31000 63699.9n 0.31000 63700.0n 0.25000 63829.9n 0.25000 63830.0n 0.25000 63959.9n 0.25000 63960.0n 0.25000 64089.9n 0.25000 64090.0n 0.31000 64219.9n 0.31000 64220.0n 0.25000 64349.9n 0.25000 64350.0n 0.31000 64479.9n 0.31000 64480.0n 0.25000 64609.9n 0.25000 64610.0n 0.31000 64739.9n 0.31000 64740.0n 0.25000 64869.9n 0.25000 64870.0n 0.25000 64999.9n 0.25000 65000.0n 0.25000 65129.9n 0.25000 65130.0n 0.31000 65259.9n 0.31000 65260.0n 0.25000 65389.9n 0.25000 65390.0n 0.25000 65519.9n 0.25000 65520.0n 0.31000 65649.9n 0.31000 65650.0n 0.31000 65779.9n 0.31000 65780.0n 0.31000 65909.9n 0.31000 65910.0n 0.31000 66039.9n 0.31000 66040.0n 0.31000 66169.9n 0.31000 66170.0n 0.31000 66299.9n 0.31000 66300.0n 0.31000 66429.9n 0.31000 66430.0n 0.31000 66559.9n 0.31000 66560.0n 0.25000 66689.9n 0.25000 66690.0n 0.31000 66819.9n 0.31000 66820.0n 0.25000 66949.9n 0.25000 66950.0n 0.25000 67079.9n 0.25000 67080.0n 0.31000 67209.9n 0.31000 67210.0n 0.25000 67339.9n 0.25000 67340.0n 0.25000 67469.9n 0.25000 67470.0n 0.25000 67599.9n 0.25000 67600.0n 0.31000 67729.9n 0.31000 67730.0n 0.31000 67859.9n 0.31000 67860.0n 0.25000 67989.9n 0.25000 67990.0n 0.25000 68119.9n 0.25000 68120.0n 0.31000 68249.9n 0.31000 68250.0n 0.31000 68379.9n 0.31000 68380.0n 0.31000 68509.9n 0.31000 68510.0n 0.25000 68639.9n 0.25000 68640.0n 0.31000 68769.9n 0.31000 68770.0n 0.31000 68899.9n 0.31000 68900.0n 0.25000 69029.9n 0.25000 69030.0n 0.25000 69159.9n 0.25000 69160.0n 0.31000 69289.9n 0.31000 69290.0n 0.25000 69419.9n 0.25000 69420.0n 0.25000 69549.9n 0.25000 69550.0n 0.25000 69679.9n 0.25000 69680.0n 0.31000 69809.9n 0.31000 69810.0n 0.31000 69939.9n 0.31000 69940.0n 0.31000 70069.9n 0.31000 70070.0n 0.25000 70199.9n 0.25000 70200.0n 0.25000 70329.9n 0.25000 70330.0n 0.31000 70459.9n 0.31000 70460.0n 0.25000 70589.9n 0.25000 70590.0n 0.31000 70719.9n 0.31000 70720.0n 0.25000 70849.9n 0.25000 70850.0n 0.31000 70979.9n 0.31000 70980.0n 0.25000 71109.9n 0.25000 71110.0n 0.31000 71239.9n 0.31000 71240.0n 0.25000 71369.9n 0.25000 71370.0n 0.31000 71499.9n 0.31000 71500.0n 0.25000 71629.9n 0.25000 71630.0n 0.25000 71759.9n 0.25000 71760.0n 0.31000 71889.9n 0.31000 71890.0n 0.31000 72019.9n 0.31000 72020.0n 0.31000 72149.9n 0.31000 72150.0n 0.25000 72279.9n 0.25000 72280.0n 0.31000 72409.9n 0.31000 72410.0n 0.25000 72539.9n 0.25000 72540.0n 0.25000 72669.9n 0.25000 72670.0n 0.25000 72799.9n 0.25000 72800.0n 0.25000 72929.9n 0.25000 72930.0n 0.31000 73059.9n 0.31000 73060.0n 0.31000 73189.9n 0.31000 73190.0n 0.31000 73319.9n 0.31000 73320.0n 0.31000 73449.9n 0.31000 73450.0n 0.25000 73579.9n 0.25000 73580.0n 0.25000 73709.9n 0.25000 73710.0n 0.31000 73839.9n 0.31000 73840.0n 0.25000 73969.9n 0.25000 73970.0n 0.25000 74099.9n 0.25000 74100.0n 0.31000 74229.9n 0.31000 74230.0n 0.31000 74359.9n 0.31000 74360.0n 0.25000 74489.9n 0.25000 74490.0n 0.25000 74619.9n 0.25000 74620.0n 0.25000 74749.9n 0.25000 74750.0n 0.31000 74879.9n 0.31000 74880.0n 0.31000 75009.9n 0.31000 75010.0n 0.31000 75139.9n 0.31000 75140.0n 0.25000 75269.9n 0.25000 75270.0n 0.25000 75399.9n 0.25000 75400.0n 0.31000 75529.9n 0.31000 75530.0n 0.31000 75659.9n 0.31000 75660.0n 0.25000 75789.9n 0.25000 75790.0n 0.31000 75919.9n 0.31000 75920.0n 0.31000 76049.9n 0.31000 76050.0n 0.31000 76179.9n 0.31000 76180.0n 0.25000 76309.9n 0.25000 76310.0n 0.25000 76439.9n 0.25000 76440.0n 0.31000 76569.9n 0.31000 76570.0n 0.25000 76699.9n 0.25000 76700.0n 0.31000 76829.9n 0.31000 76830.0n 0.25000 76959.9n 0.25000 76960.0n 0.25000 77089.9n 0.25000 77090.0n 0.31000 77219.9n 0.31000 77220.0n 0.31000 77349.9n 0.31000 77350.0n 0.31000 77479.9n 0.31000 77480.0n 0.25000 77609.9n 0.25000 77610.0n 0.25000 77739.9n 0.25000 77740.0n 0.31000 77869.9n 0.31000 77870.0n 0.25000 77999.9n 0.25000 78000.0n 0.28000 78129.9n 0.28000 78130.0n 0.28000 78259.9n 0.28000 78260.0n 0.28000 78389.9n 0.28000 78390.0n 0.28000 78519.9n 0.28000 78520.0n 0.28000 78649.9n 0.28000 78650.0n 0.28000 78779.9n 0.28000 78780.0n 0.28000 78909.9n 0.28000 78910.0n 0.28000 79039.9n 0.28000 79040.0n 0.28000 79169.9n 0.28000 79170.0n 0.28000 79299.9n 0.28000 79300.0n 0.28000 79429.9n 0.28000 79430.0n 0.28000 79559.9n 0.28000 79560.0n 0.28000 79689.9n 0.28000 79690.0n 0.28000 79819.9n 0.28000 79820.0n 0.28000 79949.9n 0.28000 79950.0n 0.28000 80079.9n 0.28000 80080.0n 0.28000 80209.9n 0.28000 80210.0n 0.28000 80339.9n 0.28000 80340.0n 0.28000 80469.9n 0.28000 80470.0n 0.28000 80599.9n 0.28000 80600.0n 0.28000 80729.9n 0.28000 80730.0n 0.28000 80859.9n 0.28000 80860.0n 0.28000 80989.9n 0.28000 80990.0n 0.28000 81119.9n 0.28000 81120.0n 0.28000 81249.9n 0.28000 81250.0n 0.28000 81379.9n 0.28000 81380.0n 0.28000 81509.9n 0.28000 81510.0n 0.28000 81639.9n 0.28000 81640.0n 0.28000 81769.9n 0.28000 81770.0n 0.28000 81899.9n 0.28000 81900.0n 0.28000 82029.9n 0.28000 82030.0n 0.28000 82159.9n 0.28000 82160.0n 0.28000 82289.9n 0.28000 82290.0n 0.28000 82419.9n 0.28000 82420.0n 0.28000 82549.9n 0.28000 82550.0n 0.28000 82679.9n 0.28000 82680.0n 0.28000 82809.9n 0.28000 82810.0n 0.28000 82939.9n 0.28000 82940.0n 0.28000 83069.9n 0.28000 83070.0n 0.28000 83199.9n 0.28000 83200.0n 0.28000 83329.9n 0.28000 83330.0n 0.28000 83459.9n 0.28000 83460.0n 0.28000 83589.9n 0.28000 83590.0n 0.28000 83719.9n 0.28000 83720.0n 0.28000 83849.9n 0.28000 83850.0n 0.28000 83979.9n 0.28000 83980.0n 0.28000 84109.9n 0.28000 84110.0n 0.28000 84239.9n 0.28000 84240.0n 0.31000 84369.9n 0.31000 84370.0n 0.31000 84499.9n 0.31000 84500.0n 0.31000 84629.9n 0.31000 84630.0n 0.25000 84759.9n 0.25000 84760.0n 0.31000 84889.9n 0.31000 84890.0n 0.31000 85019.9n 0.31000 85020.0n 0.25000 85149.9n 0.25000 85150.0n 0.25000 85279.9n 0.25000 85280.0n 0.31000 85409.9n 0.31000 85410.0n 0.31000 85539.9n 0.31000 85540.0n 0.31000 85669.9n 0.31000 85670.0n 0.25000 85799.9n 0.25000 85800.0n 0.31000 85929.9n 0.31000 85930.0n 0.25000 86059.9n 0.25000 86060.0n 0.25000 86189.9n 0.25000 86190.0n 0.25000 86319.9n 0.25000 86320.0n 0.31000 86449.9n 0.31000 86450.0n 0.31000 86579.9n 0.31000 86580.0n 0.25000 86709.9n 0.25000 86710.0n 0.25000 86839.9n 0.25000 86840.0n 0.25000 86969.9n 0.25000 86970.0n 0.25000 87099.9n 0.25000 87100.0n 0.25000 87229.9n 0.25000 87230.0n 0.25000 87359.9n 0.25000 87360.0n 0.31000 87489.9n 0.31000 87490.0n 0.25000 87619.9n 0.25000 87620.0n 0.31000 87749.9n 0.31000 87750.0n 0.31000 87879.9n 0.31000 87880.0n 0.31000 88009.9n 0.31000 88010.0n 0.25000 88139.9n 0.25000 88140.0n 0.31000 88269.9n 0.31000 88270.0n 0.31000 88399.9n 0.31000 88400.0n 0.25000 88529.9n 0.25000 88530.0n 0.31000 88659.9n 0.31000 88660.0n 0.25000 88789.9n 0.25000 88790.0n 0.31000 88919.9n 0.31000 88920.0n 0.31000 89049.9n 0.31000 89050.0n 0.31000 89179.9n 0.31000 89180.0n 0.31000 89309.9n 0.31000 89310.0n 0.25000 89439.9n 0.25000 89440.0n 0.25000 89569.9n 0.25000 89570.0n 0.25000 89699.9n 0.25000 89700.0n 0.25000 89829.9n 0.25000 89830.0n 0.25000 89959.9n 0.25000 89960.0n 0.25000 90089.9n 0.25000 90090.0n 0.31000 90219.9n 0.31000 90220.0n 0.31000 90349.9n 0.31000 90350.0n 0.25000 90479.9n 0.25000 90480.0n 0.31000 90609.9n 0.31000 90610.0n 0.31000 90739.9n 0.31000 90740.0n 0.25000 90869.9n 0.25000 90870.0n 0.25000 90999.9n 0.25000 91000.0n 0.25000 91129.9n 0.25000 91130.0n 0.25000 91259.9n 0.25000 91260.0n 0.31000 91389.9n 0.31000 91390.0n 0.31000 91519.9n 0.31000 91520.0n 0.25000 91649.9n 0.25000 91650.0n 0.25000 91779.9n 0.25000 91780.0n 0.25000 91909.9n 0.25000 91910.0n 0.31000 92039.9n 0.31000 92040.0n 0.31000 92169.9n 0.31000 92170.0n 0.25000 92299.9n 0.25000 92300.0n 0.25000 92429.9n 0.25000 92430.0n 0.31000 92559.9n 0.31000 92560.0n 0.25000 92689.9n 0.25000 92690.0n 0.31000 92819.9n 0.31000 92820.0n 0.31000 92949.9n 0.31000 92950.0n 0.31000 93079.9n 0.31000 93080.0n 0.25000 93209.9n 0.25000 93210.0n 0.31000 93339.9n 0.31000 93340.0n 0.25000 93469.9n 0.25000 93470.0n 0.25000 93599.9n 0.25000 93600.0n 0.31000 93729.9n 0.31000 93730.0n 0.31000 93859.9n 0.31000 93860.0n 0.25000 93989.9n 0.25000 93990.0n 0.31000 94119.9n 0.31000 94120.0n 0.25000 94249.9n 0.25000 94250.0n 0.31000 94379.9n 0.31000 94380.0n 0.25000 94509.9n 0.25000 94510.0n 0.25000 94639.9n 0.25000 94640.0n 0.25000 94769.9n 0.25000 94770.0n 0.31000 94899.9n 0.31000 94900.0n 0.31000 95029.9n 0.31000 95030.0n 0.31000 95159.9n 0.31000 95160.0n 0.31000 95289.9n 0.31000 95290.0n 0.31000 95419.9n 0.31000 95420.0n 0.25000 95549.9n 0.25000 95550.0n 0.25000 95679.9n 0.25000 95680.0n 0.31000 95809.9n 0.31000 95810.0n 0.31000 95939.9n 0.31000 95940.0n 0.25000 96069.9n 0.25000 96070.0n 0.25000 96199.9n 0.25000 96200.0n 0.31000 96329.9n 0.31000 96330.0n 0.25000 96459.9n 0.25000 96460.0n 0.25000 96589.9n 0.25000 96590.0n 0.31000 96719.9n 0.31000 96720.0n 0.25000 96849.9n 0.25000 96850.0n 0.31000 96979.9n 0.31000 96980.0n 0.31000 97109.9n 0.31000 97110.0n 0.31000 97239.9n 0.31000 97240.0n 0.25000 97369.9n 0.25000 97370.0n 0.25000 97499.9n 0.25000 97500.0n 0.25000 97629.9n 0.25000 97630.0n 0.25000 97759.9n 0.25000 97760.0n 0.25000 97889.9n 0.25000 97890.0n 0.31000 98019.9n 0.31000 98020.0n 0.31000 98149.9n 0.31000 98150.0n 0.31000 98279.9n 0.31000 98280.0n 0.31000 98409.9n 0.31000 98410.0n 0.25000 98539.9n 0.25000 98540.0n 0.25000 98669.9n 0.25000 98670.0n 0.31000 98799.9n 0.31000 98800.0n 0.25000 98929.9n 0.25000 98930.0n 0.31000 99059.9n 0.31000 99060.0n 0.31000 99189.9n 0.31000 99190.0n 0.31000 99319.9n 0.31000 99320.0n 0.25000 99449.9n 0.25000 99450.0n 0.31000 99579.9n 0.31000 99580.0n 0.25000 99709.9n 0.25000 99710.0n 0.31000 99839.9n 0.31000 99840.0n 0.25000 99969.9n 0.25000 99970.0n 0.25000 100099.9n 0.25000 100100.0n 0.25000 100229.9n 0.25000 100230.0n 0.25000 100359.9n 0.25000 100360.0n 0.25000 100489.9n 0.25000 100490.0n 0.31000 100619.9n 0.31000 100620.0n 0.25000 100749.9n 0.25000 100750.0n 0.31000 100879.9n 0.31000 100880.0n 0.25000 101009.9n 0.25000 101010.0n 0.31000 101139.9n 0.31000 101140.0n 0.25000 101269.9n 0.25000 101270.0n 0.25000 101399.9n 0.25000 101400.0n 0.31000 101529.9n 0.31000 101530.0n 0.31000 101659.9n 0.31000 101660.0n 0.31000 101789.9n 0.31000 101790.0n 0.25000 101919.9n 0.25000 101920.0n 0.31000 102049.9n 0.31000 102050.0n 0.31000 102179.9n 0.31000 102180.0n 0.25000 102309.9n 0.25000 102310.0n 0.31000 102439.9n 0.31000 102440.0n 0.31000 102569.9n 0.31000 102570.0n 0.31000 102699.9n 0.31000 102700.0n 0.25000 102829.9n 0.25000 102830.0n 0.25000 102959.9n 0.25000 102960.0n 0.25000 103089.9n 0.25000 103090.0n 0.25000 103219.9n 0.25000 103220.0n 0.31000 103349.9n 0.31000 103350.0n 0.31000 103479.9n 0.31000 103480.0n 0.31000 103609.9n 0.31000 103610.0n 0.25000 103739.9n 0.25000 103740.0n 0.31000 103869.9n 0.31000 103870.0n 0.31000 103999.9n 0.31000 104000.0n 0.31000 104129.9n 0.31000 104130.0n 0.31000 104259.9n 0.31000 104260.0n 0.31000 104389.9n 0.31000 104390.0n 0.25000 104519.9n 0.25000 104520.0n 0.25000 104649.9n 0.25000 104650.0n 0.25000 104779.9n 0.25000 104780.0n 0.25000 104909.9n 0.25000 104910.0n 0.25000 105039.9n 0.25000 105040.0n 0.31000 105169.9n 0.31000 105170.0n 0.25000 105299.9n 0.25000 105300.0n 0.31000 105429.9n 0.31000 105430.0n 0.31000 105559.9n 0.31000 105560.0n 0.25000 105689.9n 0.25000 105690.0n 0.31000 105819.9n 0.31000 105820.0n 0.25000 105949.9n 0.25000 105950.0n 0.25000 106079.9n 0.25000 106080.0n 0.28000 106209.9n 0.28000 106210.0n 0.28000 106339.9n 0.28000 106340.0n 0.28000 106469.9n 0.28000 106470.0n 0.28000 106599.9n 0.28000 106600.0n 0.28000 106729.9n 0.28000 106730.0n 0.28000 106859.9n 0.28000 106860.0n 0.28000 106989.9n 0.28000 106990.0n 0.28000 107119.9n 0.28000 107120.0n 0.28000 107249.9n 0.28000 107250.0n 0.28000 107379.9n 0.28000 107380.0n 0.28000 107509.9n 0.28000 107510.0n 0.28000 107639.9n 0.28000 107640.0n 0.28000 107769.9n 0.28000 107770.0n 0.28000 107899.9n 0.28000 107900.0n 0.28000 108029.9n 0.28000 108030.0n 0.28000 108159.9n 0.28000 108160.0n 0.28000 108289.9n 0.28000 108290.0n 0.28000 108419.9n 0.28000 108420.0n 0.28000 108549.9n 0.28000 108550.0n 0.28000 108679.9n 0.28000 108680.0n 0.28000 108809.9n 0.28000 108810.0n 0.28000 108939.9n 0.28000 108940.0n 0.28000 109069.9n 0.28000 109070.0n 0.28000 109199.9n 0.28000 109200.0n 0.28000 109329.9n 0.28000 109330.0n 0.28000 109459.9n 0.28000 109460.0n 0.28000 109589.9n 0.28000 109590.0n 0.28000 109719.9n 0.28000 109720.0n 0.28000 109849.9n 0.28000 109850.0n 0.28000 109979.9n 0.28000 109980.0n 0.28000 110109.9n 0.28000 110110.0n 0.28000 110239.9n 0.28000 110240.0n 0.28000 110369.9n 0.28000 110370.0n 0.28000 110499.9n 0.28000 110500.0n 0.28000 110629.9n 0.28000 110630.0n 0.28000 110759.9n 0.28000 110760.0n 0.28000 110889.9n 0.28000 110890.0n 0.28000 111019.9n 0.28000 111020.0n 0.28000 111149.9n 0.28000 111150.0n 0.28000 111279.9n 0.28000 111280.0n 0.28000 111409.9n 0.28000 111410.0n 0.28000 111539.9n 0.28000 111540.0n 0.28000 111669.9n 0.28000 111670.0n 0.28000 111799.9n 0.28000 111800.0n 0.28000 111929.9n 0.28000 111930.0n 0.28000 112059.9n 0.28000 112060.0n 0.28000 112189.9n 0.28000 112190.0n 0.28000 112319.9n 0.28000 112320.0n 0.31000 112449.9n 0.31000 112450.0n 0.31000 112579.9n 0.31000 112580.0n 0.25000 112709.9n 0.25000 112710.0n 0.31000 112839.9n 0.31000 112840.0n 0.25000 112969.9n 0.25000 112970.0n 0.31000 113099.9n 0.31000 113100.0n 0.31000 113229.9n 0.31000 113230.0n 0.25000 113359.9n 0.25000 113360.0n 0.25000 113489.9n 0.25000 113490.0n 0.25000 113619.9n 0.25000 113620.0n 0.31000 113749.9n 0.31000 113750.0n 0.25000 113879.9n 0.25000 113880.0n 0.25000 114009.9n 0.25000 114010.0n 0.31000 114139.9n 0.31000 114140.0n 0.31000 114269.9n 0.31000 114270.0n 0.31000 114399.9n 0.31000 114400.0n 0.31000 114529.9n 0.31000 114530.0n 0.25000 114659.9n 0.25000 114660.0n 0.31000 114789.9n 0.31000 114790.0n 0.25000 114919.9n 0.25000 114920.0n 0.25000 115049.9n 0.25000 115050.0n 0.25000 115179.9n 0.25000 115180.0n 0.31000 115309.9n 0.31000 115310.0n 0.25000 115439.9n 0.25000 115440.0n 0.31000 115569.9n 0.31000 115570.0n 0.25000 115699.9n 0.25000 115700.0n 0.31000 115829.9n 0.31000 115830.0n 0.25000 115959.9n 0.25000 115960.0n 0.25000 116089.9n 0.25000 116090.0n 0.31000 116219.9n 0.31000 116220.0n 0.31000 116349.9n 0.31000 116350.0n 0.25000 116479.9n 0.25000 116480.0n 0.31000 116609.9n 0.31000 116610.0n 0.31000 116739.9n 0.31000 116740.0n 0.31000 116869.9n 0.31000 116870.0n 0.31000 116999.9n 0.31000 117000.0n 0.25000 117129.9n 0.25000 117130.0n 0.31000 117259.9n 0.31000 117260.0n 0.25000 117389.9n 0.25000 117390.0n 0.31000 117519.9n 0.31000 117520.0n 0.31000 117649.9n 0.31000 117650.0n 0.25000 117779.9n 0.25000 117780.0n 0.31000 117909.9n 0.31000 117910.0n 0.25000 118039.9n 0.25000 118040.0n 0.25000 118169.9n 0.25000 118170.0n 0.31000 118299.9n 0.31000 118300.0n 0.25000 118429.9n 0.25000 118430.0n 0.25000 118559.9n 0.25000 118560.0n 0.25000 118689.9n 0.25000 118690.0n 0.25000 118819.9n 0.25000 118820.0n 0.31000 118949.9n 0.31000 118950.0n 0.25000 119079.9n 0.25000 119080.0n 0.31000 119209.9n 0.31000 119210.0n 0.31000 119339.9n 0.31000 119340.0n 0.25000 119469.9n 0.25000 119470.0n 0.25000 119599.9n 0.25000 119600.0n 0.31000 119729.9n 0.31000 119730.0n 0.25000 119859.9n 0.25000 119860.0n 0.25000 119989.9n 0.25000 119990.0n 0.25000 120119.9n 0.25000 120120.0n 0.31000 120249.9n 0.31000 120250.0n 0.25000 120379.9n 0.25000 120380.0n 0.31000 120509.9n 0.31000 120510.0n 0.31000 120639.9n 0.31000 120640.0n 0.25000 120769.9n 0.25000 120770.0n 0.25000 120899.9n 0.25000 120900.0n 0.31000 121029.9n 0.31000 121030.0n 0.31000 121159.9n 0.31000 121160.0n 0.25000 121289.9n 0.25000 121290.0n 0.31000 121419.9n 0.31000 121420.0n 0.31000 121549.9n 0.31000 121550.0n 0.25000 121679.9n 0.25000 121680.0n 0.25000 121809.9n 0.25000 121810.0n 0.31000 121939.9n 0.31000 121940.0n 0.25000 122069.9n 0.25000 122070.0n 0.25000 122199.9n 0.25000 122200.0n 0.31000 122329.9n 0.31000 122330.0n 0.31000 122459.9n 0.31000 122460.0n 0.31000 122589.9n 0.31000 122590.0n 0.25000 122719.9n 0.25000 122720.0n 0.25000 122849.9n 0.25000 122850.0n 0.31000 122979.9n 0.31000 122980.0n 0.25000 123109.9n 0.25000 123110.0n 0.31000 123239.9n 0.31000 123240.0n 0.31000 123369.9n 0.31000 123370.0n 0.31000 123499.9n 0.31000 123500.0n 0.25000 123629.9n 0.25000 123630.0n 0.25000 123759.9n 0.25000 123760.0n 0.31000 123889.9n 0.31000 123890.0n 0.31000 124019.9n 0.31000 124020.0n 0.25000 124149.9n 0.25000 124150.0n 0.25000 124279.9n 0.25000 124280.0n 0.25000 124409.9n 0.25000 124410.0n 0.31000 124539.9n 0.31000 124540.0n 0.31000 124669.9n 0.31000 124670.0n 0.25000 124799.9n 0.25000 124800.0n 0.25000 124929.9n 0.25000 124930.0n 0.31000 125059.9n 0.31000 125060.0n 0.25000 125189.9n 0.25000 125190.0n 0.25000 125319.9n 0.25000 125320.0n 0.31000 125449.9n 0.31000 125450.0n 0.31000 125579.9n 0.31000 125580.0n 0.25000 125709.9n 0.25000 125710.0n 0.25000 125839.9n 0.25000 125840.0n 0.31000 125969.9n 0.31000 125970.0n 0.31000 126099.9n 0.31000 126100.0n 0.25000 126229.9n 0.25000 126230.0n 0.25000 126359.9n 0.25000 126360.0n 0.31000 126489.9n 0.31000 126490.0n 0.31000 126619.9n 0.31000 126620.0n 0.25000 126749.9n 0.25000 126750.0n 0.31000 126879.9n 0.31000 126880.0n 0.25000 127009.9n 0.25000 127010.0n 0.25000 127139.9n 0.25000 127140.0n 0.31000 127269.9n 0.31000 127270.0n 0.25000 127399.9n 0.25000 127400.0n 0.31000 127529.9n 0.31000 127530.0n 0.31000 127659.9n 0.31000 127660.0n 0.25000 127789.9n 0.25000 127790.0n 0.25000 127919.9n 0.25000 127920.0n 0.31000 128049.9n 0.31000 128050.0n 0.31000 128179.9n 0.31000 128180.0n 0.25000 128309.9n 0.25000 128310.0n 0.25000 128439.9n 0.25000 128440.0n 0.25000 128569.9n 0.25000 128570.0n 0.25000 128699.9n 0.25000 128700.0n 0.31000 128829.9n 0.31000 128830.0n 0.31000 128959.9n 0.31000 128960.0n 0.31000 129089.9n 0.31000 129090.0n 0.31000 129219.9n 0.31000 129220.0n 0.31000 129349.9n 0.31000 129350.0n 0.31000 129479.9n 0.31000 129480.0n 0.25000 129609.9n 0.25000 129610.0n 0.31000 129739.9n 0.31000 129740.0n 0.25000 129869.9n 0.25000 129870.0n 0.25000 129999.9n 0.25000 130000.0n 0.25000 130129.9n 0.25000 130130.0n 0.25000 130259.9n 0.25000 130260.0n 0.31000 130389.9n 0.31000 130390.0n 0.31000 130519.9n 0.31000 130520.0n 0.25000 130649.9n 0.25000 130650.0n 0.31000 130779.9n 0.31000 130780.0n 0.31000 130909.9n 0.31000 130910.0n 0.25000 131039.9n 0.25000 131040.0n 0.25000 131169.9n 0.25000 131170.0n 0.25000 131299.9n 0.25000 131300.0n 0.25000 131429.9n 0.25000 131430.0n 0.25000 131559.9n 0.25000 131560.0n 0.31000 131689.9n 0.31000 131690.0n 0.31000 131819.9n 0.31000 131820.0n 0.31000 131949.9n 0.31000 131950.0n 0.25000 132079.9n 0.25000 132080.0n 0.31000 132209.9n 0.31000 132210.0n 0.25000 132339.9n 0.25000 132340.0n 0.31000 132469.9n 0.31000 132470.0n 0.25000 132599.9n 0.25000 132600.0n 0.25000 132729.9n 0.25000 132730.0n 0.31000 132859.9n 0.31000 132860.0n 0.31000 132989.9n 0.31000 132990.0n 0.31000 133119.9n 0.31000 133120.0n 0.31000 133249.9n 0.31000 133250.0n 0.31000 133379.9n 0.31000 133380.0n 0.25000 133509.9n 0.25000 133510.0n 0.25000 133639.9n 0.25000 133640.0n 0.31000 133769.9n 0.31000 133770.0n 0.25000 133899.9n 0.25000 133900.0n 0.31000 134029.9n 0.31000 134030.0n 0.25000 134159.9n 0.25000 134160.0n 0.28000 134289.9n 0.28000 134290.0n 0.28000 134419.9n 0.28000 134420.0n 0.28000 134549.9n 0.28000 134550.0n 0.28000 134679.9n 0.28000 134680.0n 0.28000 134809.9n 0.28000 134810.0n 0.28000 134939.9n 0.28000 134940.0n 0.28000 135069.9n 0.28000 135070.0n 0.28000 135199.9n 0.28000 135200.0n 0.28000 135329.9n 0.28000 135330.0n 0.28000 135459.9n 0.28000 135460.0n 0.28000 135589.9n 0.28000 135590.0n 0.28000 135719.9n 0.28000 135720.0n 0.28000 135849.9n 0.28000 135850.0n 0.28000 135979.9n 0.28000 135980.0n 0.28000 136109.9n 0.28000 136110.0n 0.28000 136239.9n 0.28000 136240.0n 0.28000 136369.9n 0.28000 136370.0n 0.28000 136499.9n 0.28000 136500.0n 0.28000 136629.9n 0.28000 136630.0n 0.28000 136759.9n 0.28000 136760.0n 0.28000 136889.9n 0.28000 136890.0n 0.28000 137019.9n 0.28000 137020.0n 0.28000 137149.9n 0.28000 137150.0n 0.28000 137279.9n 0.28000 137280.0n 0.28000 137409.9n 0.28000 137410.0n 0.28000 137539.9n 0.28000 137540.0n 0.28000 137669.9n 0.28000 137670.0n 0.28000 137799.9n 0.28000 137800.0n 0.28000 137929.9n 0.28000 137930.0n 0.28000 138059.9n 0.28000 138060.0n 0.28000 138189.9n 0.28000 138190.0n 0.28000 138319.9n 0.28000 138320.0n 0.28000 138449.9n 0.28000 138450.0n 0.28000 138579.9n 0.28000 138580.0n 0.28000 138709.9n 0.28000 138710.0n 0.28000 138839.9n 0.28000 138840.0n 0.28000 138969.9n 0.28000 138970.0n 0.28000 139099.9n 0.28000 139100.0n 0.28000 139229.9n 0.28000 139230.0n 0.28000 139359.9n 0.28000 139360.0n 0.28000 139489.9n 0.28000 139490.0n 0.28000 139619.9n 0.28000 139620.0n 0.28000 139749.9n 0.28000 139750.0n 0.28000 139879.9n 0.28000 139880.0n 0.28000 140009.9n 0.28000 140010.0n 0.28000 140139.9n 0.28000 140140.0n 0.28000 140269.9n 0.28000 140270.0n 0.28000 140399.9n 0.28000 140400.0n 0.25000 140529.9n 0.25000 140530.0n 0.31000 140659.9n 0.31000 140660.0n 0.25000 140789.9n 0.25000 140790.0n 0.25000 140919.9n 0.25000 140920.0n 0.31000 141049.9n 0.31000 141050.0n 0.31000 141179.9n 0.31000 141180.0n 0.25000 141309.9n 0.25000 141310.0n 0.31000 141439.9n 0.31000 141440.0n 0.25000 141569.9n 0.25000 141570.0n 0.31000 141699.9n 0.31000 141700.0n 0.31000 141829.9n 0.31000 141830.0n 0.25000 141959.9n 0.25000 141960.0n 0.25000 142089.9n 0.25000 142090.0n 0.25000 142219.9n 0.25000 142220.0n 0.31000 142349.9n 0.31000 142350.0n 0.25000 142479.9n 0.25000 142480.0n 0.31000 142609.9n 0.31000 142610.0n 0.25000 142739.9n 0.25000 142740.0n 0.25000 142869.9n 0.25000 142870.0n 0.25000 142999.9n 0.25000 143000.0n 0.25000 143129.9n 0.25000 143130.0n 0.31000 143259.9n 0.31000 143260.0n 0.25000 143389.9n 0.25000 143390.0n 0.31000 143519.9n 0.31000 143520.0n 0.31000 143649.9n 0.31000 143650.0n 0.31000 143779.9n 0.31000 143780.0n 0.31000 143909.9n 0.31000 143910.0n 0.31000 144039.9n 0.31000 144040.0n 0.25000 144169.9n 0.25000 144170.0n 0.25000 144299.9n 0.25000 144300.0n 0.31000 144429.9n 0.31000 144430.0n 0.31000 144559.9n 0.31000 144560.0n 0.31000 144689.9n 0.31000 144690.0n 0.31000 144819.9n 0.31000 144820.0n 0.25000 144949.9n 0.25000 144950.0n 0.31000 145079.9n 0.31000 145080.0n 0.31000 145209.9n 0.31000 145210.0n 0.25000 145339.9n 0.25000 145340.0n 0.25000 145469.9n 0.25000 145470.0n 0.25000 145599.9n 0.25000 145600.0n 0.31000 145729.9n 0.31000 145730.0n 0.31000 145859.9n 0.31000 145860.0n 0.25000 145989.9n 0.25000 145990.0n 0.25000 146119.9n 0.25000 146120.0n 0.25000 146249.9n 0.25000 146250.0n 0.31000 146379.9n 0.31000 146380.0n 0.25000 146509.9n 0.25000 146510.0n 0.31000 146639.9n 0.31000 146640.0n 0.31000 146769.9n 0.31000 146770.0n 0.31000 146899.9n 0.31000 146900.0n 0.31000 147029.9n 0.31000 147030.0n 0.25000 147159.9n 0.25000 147160.0n 0.25000 147289.9n 0.25000 147290.0n 0.31000 147419.9n 0.31000 147420.0n 0.25000 147549.9n 0.25000 147550.0n 0.25000 147679.9n 0.25000 147680.0n 0.31000 147809.9n 0.31000 147810.0n 0.25000 147939.9n 0.25000 147940.0n 0.31000 148069.9n 0.31000 148070.0n 0.25000 148199.9n 0.25000 148200.0n 0.25000 148329.9n 0.25000 148330.0n 0.25000 148459.9n 0.25000 148460.0n 0.25000 148589.9n 0.25000 148590.0n 0.31000 148719.9n 0.31000 148720.0n 0.25000 148849.9n 0.25000 148850.0n 0.31000 148979.9n 0.31000 148980.0n 0.31000 149109.9n 0.31000 149110.0n 0.31000 149239.9n 0.31000 149240.0n 0.25000 149369.9n 0.25000 149370.0n 0.25000 149499.9n 0.25000 149500.0n 0.31000 149629.9n 0.31000 149630.0n 0.25000 149759.9n 0.25000 149760.0n 0.25000 149889.9n 0.25000 149890.0n 0.31000 150019.9n 0.31000 150020.0n 0.31000 150149.9n 0.31000 150150.0n 0.25000 150279.9n 0.25000 150280.0n 0.31000 150409.9n 0.31000 150410.0n 0.31000 150539.9n 0.31000 150540.0n 0.25000 150669.9n 0.25000 150670.0n 0.31000 150799.9n 0.31000 150800.0n 0.25000 150929.9n 0.25000 150930.0n 0.25000 151059.9n 0.25000 151060.0n 0.31000 151189.9n 0.31000 151190.0n 0.31000 151319.9n 0.31000 151320.0n 0.25000 151449.9n 0.25000 151450.0n 0.31000 151579.9n 0.31000 151580.0n 0.25000 151709.9n 0.25000 151710.0n 0.31000 151839.9n 0.31000 151840.0n 0.31000 151969.9n 0.31000 151970.0n 0.25000 152099.9n 0.25000 152100.0n 0.31000 152229.9n 0.31000 152230.0n 0.25000 152359.9n 0.25000 152360.0n 0.31000 152489.9n 0.31000 152490.0n 0.25000 152619.9n 0.25000 152620.0n 0.25000 152749.9n 0.25000 152750.0n 0.31000 152879.9n 0.31000 152880.0n 0.31000 153009.9n 0.31000 153010.0n 0.25000 153139.9n 0.25000 153140.0n 0.31000 153269.9n 0.31000 153270.0n 0.25000 153399.9n 0.25000 153400.0n 0.25000 153529.9n 0.25000 153530.0n 0.31000 153659.9n 0.31000 153660.0n 0.31000 153789.9n 0.31000 153790.0n 0.31000 153919.9n 0.31000 153920.0n 0.25000 154049.9n 0.25000 154050.0n 0.25000 154179.9n 0.25000 154180.0n 0.25000 154309.9n 0.25000 154310.0n 0.31000 154439.9n 0.31000 154440.0n 0.31000 154569.9n 0.31000 154570.0n 0.31000 154699.9n 0.31000 154700.0n 0.25000 154829.9n 0.25000 154830.0n 0.25000 154959.9n 0.25000 154960.0n 0.25000 155089.9n 0.25000 155090.0n 0.31000 155219.9n 0.31000 155220.0n 0.25000 155349.9n 0.25000 155350.0n 0.31000 155479.9n 0.31000 155480.0n 0.31000 155609.9n 0.31000 155610.0n 0.25000 155739.9n 0.25000 155740.0n 0.31000 155869.9n 0.31000 155870.0n 0.31000 155999.9n 0.31000 156000.0n 0.31000 156129.9n 0.31000 156130.0n 0.25000 156259.9n 0.25000 156260.0n 0.31000 156389.9n 0.31000 156390.0n 0.31000 156519.9n 0.31000 156520.0n 0.25000 156649.9n 0.25000 156650.0n 0.25000 156779.9n 0.25000 156780.0n 0.25000 156909.9n 0.25000 156910.0n 0.31000 157039.9n 0.31000 157040.0n 0.25000 157169.9n 0.25000 157170.0n 0.31000 157299.9n 0.31000 157300.0n 0.31000 157429.9n 0.31000 157430.0n 0.31000 157559.9n 0.31000 157560.0n 0.25000 157689.9n 0.25000 157690.0n 0.25000 157819.9n 0.25000 157820.0n 0.31000 157949.9n 0.31000 157950.0n 0.25000 158079.9n 0.25000 158080.0n 0.25000 158209.9n 0.25000 158210.0n 0.25000 158339.9n 0.25000 158340.0n 0.31000 158469.9n 0.31000 158470.0n 0.25000 158599.9n 0.25000 158600.0n 0.31000 158729.9n 0.31000 158730.0n 0.31000 158859.9n 0.31000 158860.0n 0.31000 158989.9n 0.31000 158990.0n 0.31000 159119.9n 0.31000 159120.0n 0.25000 159249.9n 0.25000 159250.0n 0.25000 159379.9n 0.25000 159380.0n 0.31000 159509.9n 0.31000 159510.0n 0.31000 159639.9n 0.31000 159640.0n 0.31000 159769.9n 0.31000 159770.0n 0.31000 159899.9n 0.31000 159900.0n 0.25000 160029.9n 0.25000 160030.0n 0.25000 160159.9n 0.25000 160160.0n 0.25000 160289.9n 0.25000 160290.0n 0.31000 160419.9n 0.31000 160420.0n 0.31000 160549.9n 0.31000 160550.0n 0.25000 160679.9n 0.25000 160680.0n 0.25000 160809.9n 0.25000 160810.0n 0.25000 160939.9n 0.25000 160940.0n 0.31000 161069.9n 0.31000 161070.0n 0.25000 161199.9n 0.25000 161200.0n 0.31000 161329.9n 0.31000 161330.0n 0.25000 161459.9n 0.25000 161460.0n 0.25000 161589.9n 0.25000 161590.0n 0.31000 161719.9n 0.31000 161720.0n 0.25000 161849.9n 0.25000 161850.0n 0.25000 161979.9n 0.25000 161980.0n 0.31000 162109.9n 0.31000 162110.0n 0.25000 162239.9n 0.25000 162240.0n 0.28000 162369.9n 0.28000 162370.0n 0.28000 162499.9n 0.28000 162500.0n 0.28000 162629.9n 0.28000 162630.0n 0.28000 162759.9n 0.28000 162760.0n 0.28000 162889.9n 0.28000 162890.0n 0.28000 163019.9n 0.28000 163020.0n 0.28000 163149.9n 0.28000 163150.0n 0.28000 163279.9n 0.28000 163280.0n 0.28000 163409.9n 0.28000 163410.0n 0.28000 163539.9n 0.28000 163540.0n 0.28000 163669.9n 0.28000 163670.0n 0.28000 163799.9n 0.28000 163800.0n 0.28000 163929.9n 0.28000 163930.0n 0.28000 164059.9n 0.28000 164060.0n 0.28000 164189.9n 0.28000 164190.0n 0.28000 164319.9n 0.28000 164320.0n 0.28000 164449.9n 0.28000 164450.0n 0.28000 164579.9n 0.28000 164580.0n 0.28000 164709.9n 0.28000 164710.0n 0.28000 164839.9n 0.28000 164840.0n 0.28000 164969.9n 0.28000 164970.0n 0.28000 165099.9n 0.28000 165100.0n 0.28000 165229.9n 0.28000 165230.0n 0.28000 165359.9n 0.28000 165360.0n 0.28000 165489.9n 0.28000 165490.0n 0.28000 165619.9n 0.28000 165620.0n 0.28000 165749.9n 0.28000 165750.0n 0.28000 165879.9n 0.28000 165880.0n 0.28000 166009.9n 0.28000 166010.0n 0.28000 166139.9n 0.28000 166140.0n 0.28000 166269.9n 0.28000 166270.0n 0.28000 166399.9n 0.28000 166400.0n 0.28000 166529.9n 0.28000 166530.0n 0.28000 166659.9n 0.28000 166660.0n 0.28000 166789.9n 0.28000 166790.0n 0.28000 166919.9n 0.28000 166920.0n 0.28000 167049.9n 0.28000 167050.0n 0.28000 167179.9n 0.28000 167180.0n 0.28000 167309.9n 0.28000 167310.0n 0.28000 167439.9n 0.28000 167440.0n 0.28000 167569.9n 0.28000 167570.0n 0.28000 167699.9n 0.28000 167700.0n 0.28000 167829.9n 0.28000 167830.0n 0.28000 167959.9n 0.28000 167960.0n 0.28000 168089.9n 0.28000 168090.0n 0.28000 168219.9n 0.28000 168220.0n 0.28000 168349.9n 0.28000 168350.0n 0.28000)
Vahcm ahcm 0 0.666
Vwih_p_0_0 wih_p_0_0 0 0.9
Vwih_n_0_0 wih_n_0_0 0 0.3
Vwih_p_1_0 wih_p_1_0 0 0.3
Vwih_n_1_0 wih_n_1_0 0 0.7462021098214677
Vwih_p_2_0 wih_p_2_0 0 0.9
Vwih_n_2_0 wih_n_2_0 0 0.3
Xcm_xh0 xhp0 xhn0 vdd cmld
Rnd_xh0 xhp0 xhn0 20k
Cxh0p xhp0 0 1e-13
Cxh0n xhn0 0 1e-13
Xih_0_0 a_xp0 a_xn0 wih_p_0_0 wih_n_0_0 xhp0 xhn0 vdd vbsyn gsyn
Xih_1_0 a_xp1 a_xn1 wih_p_1_0 wih_n_1_0 xhp0 xhn0 vdd vbsyn gsyn
Xih_2_0 a_xp2 a_xn2 wih_p_2_0 wih_n_2_0 xhp0 xhn0 vdd vbsyn gsyn
Xn0 xhp0 xhn0 ahp0 ahn0 vdd vbneu dneuron
Vwih_p_0_1 wih_p_0_1 0 0.42608596346235966
Vwih_n_0_1 wih_n_0_1 0 0.5739140365376403
Vwih_p_1_1 wih_p_1_1 0 0.650041436414333
Vwih_n_1_1 wih_n_1_1 0 0.349958563585667
Vwih_p_2_1 wih_p_2_1 0 0.9
Vwih_n_2_1 wih_n_2_1 0 0.3
Xcm_xh1 xhp1 xhn1 vdd cmld
Rnd_xh1 xhp1 xhn1 20k
Cxh1p xhp1 0 1e-13
Cxh1n xhn1 0 1e-13
Xih_0_1 a_xp0 a_xn0 wih_p_0_1 wih_n_0_1 xhp1 xhn1 vdd vbsyn gsyn
Xih_1_1 a_xp1 a_xn1 wih_p_1_1 wih_n_1_1 xhp1 xhn1 vdd vbsyn gsyn
Xih_2_1 a_xp2 a_xn2 wih_p_2_1 wih_n_2_1 xhp1 xhn1 vdd vbsyn gsyn
Xn1 xhp1 xhn1 ahp1 ahn1 vdd vbneu dneuron
Vwih_p_0_2 wih_p_0_2 0 0.6589524599166401
Vwih_n_0_2 wih_n_0_2 0 0.3410475400833599
Vwih_p_1_2 wih_p_1_2 0 0.7889277266538957
Vwih_n_1_2 wih_n_1_2 0 0.3
Vwih_p_2_2 wih_p_2_2 0 0.3
Vwih_n_2_2 wih_n_2_2 0 0.9
Xcm_xh2 xhp2 xhn2 vdd cmld
Rnd_xh2 xhp2 xhn2 20k
Cxh2p xhp2 0 1e-13
Cxh2n xhn2 0 1e-13
Xih_0_2 a_xp0 a_xn0 wih_p_0_2 wih_n_0_2 xhp2 xhn2 vdd vbsyn gsyn
Xih_1_2 a_xp1 a_xn1 wih_p_1_2 wih_n_1_2 xhp2 xhn2 vdd vbsyn gsyn
Xih_2_2 a_xp2 a_xn2 wih_p_2_2 wih_n_2_2 xhp2 xhn2 vdd vbsyn gsyn
Xn2 xhp2 xhn2 ahp2 ahn2 vdd vbneu dneuron
Vwih_p_0_3 wih_p_0_3 0 0.33414744999265295
Vwih_n_0_3 wih_n_0_3 0 0.6658525500073471
Vwih_p_1_3 wih_p_1_3 0 0.9
Vwih_n_1_3 wih_n_1_3 0 0.3
Vwih_p_2_3 wih_p_2_3 0 0.4175108911373908
Vwih_n_2_3 wih_n_2_3 0 0.5824891088626092
Xcm_xh3 xhp3 xhn3 vdd cmld
Rnd_xh3 xhp3 xhn3 20k
Cxh3p xhp3 0 1e-13
Cxh3n xhn3 0 1e-13
Xih_0_3 a_xp0 a_xn0 wih_p_0_3 wih_n_0_3 xhp3 xhn3 vdd vbsyn gsyn
Xih_1_3 a_xp1 a_xn1 wih_p_1_3 wih_n_1_3 xhp3 xhn3 vdd vbsyn gsyn
Xih_2_3 a_xp2 a_xn2 wih_p_2_3 wih_n_2_3 xhp3 xhn3 vdd vbsyn gsyn
Xn3 xhp3 xhn3 ahp3 ahn3 vdd vbneu dneuron
Vwih_p_0_4 wih_p_0_4 0 0.6147066669240184
Vwih_n_0_4 wih_n_0_4 0 0.3852933330759816
Vwih_p_1_4 wih_p_1_4 0 0.44128768415837283
Vwih_n_1_4 wih_n_1_4 0 0.5587123158416272
Vwih_p_2_4 wih_p_2_4 0 0.3
Vwih_n_2_4 wih_n_2_4 0 0.7237680882055311
Xcm_xh4 xhp4 xhn4 vdd cmld
Rnd_xh4 xhp4 xhn4 20k
Cxh4p xhp4 0 1e-13
Cxh4n xhn4 0 1e-13
Xih_0_4 a_xp0 a_xn0 wih_p_0_4 wih_n_0_4 xhp4 xhn4 vdd vbsyn gsyn
Xih_1_4 a_xp1 a_xn1 wih_p_1_4 wih_n_1_4 xhp4 xhn4 vdd vbsyn gsyn
Xih_2_4 a_xp2 a_xn2 wih_p_2_4 wih_n_2_4 xhp4 xhn4 vdd vbsyn gsyn
Xn4 xhp4 xhn4 ahp4 ahn4 vdd vbneu dneuron
Vwih_p_0_5 wih_p_0_5 0 0.3
Vwih_n_0_5 wih_n_0_5 0 0.9
Vwih_p_1_5 wih_p_1_5 0 0.3
Vwih_n_1_5 wih_n_1_5 0 0.9
Vwih_p_2_5 wih_p_2_5 0 0.9
Vwih_n_2_5 wih_n_2_5 0 0.3
Xcm_xh5 xhp5 xhn5 vdd cmld
Rnd_xh5 xhp5 xhn5 20k
Cxh5p xhp5 0 1e-13
Cxh5n xhn5 0 1e-13
Xih_0_5 a_xp0 a_xn0 wih_p_0_5 wih_n_0_5 xhp5 xhn5 vdd vbsyn gsyn
Xih_1_5 a_xp1 a_xn1 wih_p_1_5 wih_n_1_5 xhp5 xhn5 vdd vbsyn gsyn
Xih_2_5 a_xp2 a_xn2 wih_p_2_5 wih_n_2_5 xhp5 xhn5 vdd vbsyn gsyn
Xn5 xhp5 xhn5 ahp5 ahn5 vdd vbneu dneuron
Vwih_p_0_6 wih_p_0_6 0 0.47153817072380777
Vwih_n_0_6 wih_n_0_6 0 0.5284618292761922
Vwih_p_1_6 wih_p_1_6 0 0.3
Vwih_n_1_6 wih_n_1_6 0 0.9
Vwih_p_2_6 wih_p_2_6 0 0.3
Vwih_n_2_6 wih_n_2_6 0 0.8254635455006005
Xcm_xh6 xhp6 xhn6 vdd cmld
Rnd_xh6 xhp6 xhn6 20k
Cxh6p xhp6 0 1e-13
Cxh6n xhn6 0 1e-13
Xih_0_6 a_xp0 a_xn0 wih_p_0_6 wih_n_0_6 xhp6 xhn6 vdd vbsyn gsyn
Xih_1_6 a_xp1 a_xn1 wih_p_1_6 wih_n_1_6 xhp6 xhn6 vdd vbsyn gsyn
Xih_2_6 a_xp2 a_xn2 wih_p_2_6 wih_n_2_6 xhp6 xhn6 vdd vbsyn gsyn
Xn6 xhp6 xhn6 ahp6 ahn6 vdd vbneu dneuron
Vwih_p_0_7 wih_p_0_7 0 0.8144343030719958
Vwih_n_0_7 wih_n_0_7 0 0.3
Vwih_p_1_7 wih_p_1_7 0 0.3
Vwih_n_1_7 wih_n_1_7 0 0.840973976613445
Vwih_p_2_7 wih_p_2_7 0 0.3
Vwih_n_2_7 wih_n_2_7 0 0.725126659069829
Xcm_xh7 xhp7 xhn7 vdd cmld
Rnd_xh7 xhp7 xhn7 20k
Cxh7p xhp7 0 1e-13
Cxh7n xhn7 0 1e-13
Xih_0_7 a_xp0 a_xn0 wih_p_0_7 wih_n_0_7 xhp7 xhn7 vdd vbsyn gsyn
Xih_1_7 a_xp1 a_xn1 wih_p_1_7 wih_n_1_7 xhp7 xhn7 vdd vbsyn gsyn
Xih_2_7 a_xp2 a_xn2 wih_p_2_7 wih_n_2_7 xhp7 xhn7 vdd vbsyn gsyn
Xn7 xhp7 xhn7 ahp7 ahn7 vdd vbneu dneuron
Vwih_p_0_8 wih_p_0_8 0 0.3
Vwih_n_0_8 wih_n_0_8 0 0.9
Vwih_p_1_8 wih_p_1_8 0 0.3
Vwih_n_1_8 wih_n_1_8 0 0.9
Vwih_p_2_8 wih_p_2_8 0 0.9
Vwih_n_2_8 wih_n_2_8 0 0.3
Xcm_xh8 xhp8 xhn8 vdd cmld
Rnd_xh8 xhp8 xhn8 20k
Cxh8p xhp8 0 1e-13
Cxh8n xhn8 0 1e-13
Xih_0_8 a_xp0 a_xn0 wih_p_0_8 wih_n_0_8 xhp8 xhn8 vdd vbsyn gsyn
Xih_1_8 a_xp1 a_xn1 wih_p_1_8 wih_n_1_8 xhp8 xhn8 vdd vbsyn gsyn
Xih_2_8 a_xp2 a_xn2 wih_p_2_8 wih_n_2_8 xhp8 xhn8 vdd vbsyn gsyn
Xn8 xhp8 xhn8 ahp8 ahn8 vdd vbneu dneuron
Vwih_p_0_9 wih_p_0_9 0 0.4492797588151622
Vwih_n_0_9 wih_n_0_9 0 0.5507202411848378
Vwih_p_1_9 wih_p_1_9 0 0.3842575094541561
Vwih_n_1_9 wih_n_1_9 0 0.615742490545844
Vwih_p_2_9 wih_p_2_9 0 0.3
Vwih_n_2_9 wih_n_2_9 0 0.7165218656837495
Xcm_xh9 xhp9 xhn9 vdd cmld
Rnd_xh9 xhp9 xhn9 20k
Cxh9p xhp9 0 1e-13
Cxh9n xhn9 0 1e-13
Xih_0_9 a_xp0 a_xn0 wih_p_0_9 wih_n_0_9 xhp9 xhn9 vdd vbsyn gsyn
Xih_1_9 a_xp1 a_xn1 wih_p_1_9 wih_n_1_9 xhp9 xhn9 vdd vbsyn gsyn
Xih_2_9 a_xp2 a_xn2 wih_p_2_9 wih_n_2_9 xhp9 xhn9 vdd vbsyn gsyn
Xn9 xhp9 xhn9 ahp9 ahn9 vdd vbneu dneuron
Vwih_p_0_10 wih_p_0_10 0 0.7564830386467098
Vwih_n_0_10 wih_n_0_10 0 0.3
Vwih_p_1_10 wih_p_1_10 0 0.5221296776009947
Vwih_n_1_10 wih_n_1_10 0 0.47787032239900523
Vwih_p_2_10 wih_p_2_10 0 0.6052429607171265
Vwih_n_2_10 wih_n_2_10 0 0.3947570392828735
Xcm_xh10 xhp10 xhn10 vdd cmld
Rnd_xh10 xhp10 xhn10 20k
Cxh10p xhp10 0 1e-13
Cxh10n xhn10 0 1e-13
Xih_0_10 a_xp0 a_xn0 wih_p_0_10 wih_n_0_10 xhp10 xhn10 vdd vbsyn gsyn
Xih_1_10 a_xp1 a_xn1 wih_p_1_10 wih_n_1_10 xhp10 xhn10 vdd vbsyn gsyn
Xih_2_10 a_xp2 a_xn2 wih_p_2_10 wih_n_2_10 xhp10 xhn10 vdd vbsyn gsyn
Xn10 xhp10 xhn10 ahp10 ahn10 vdd vbneu dneuron
Vwih_p_0_11 wih_p_0_11 0 0.5492717062582938
Vwih_n_0_11 wih_n_0_11 0 0.45072829374170625
Vwih_p_1_11 wih_p_1_11 0 0.37136419561518563
Vwih_n_1_11 wih_n_1_11 0 0.6286358043848144
Vwih_p_2_11 wih_p_2_11 0 0.3268801503540445
Vwih_n_2_11 wih_n_2_11 0 0.6731198496459555
Xcm_xh11 xhp11 xhn11 vdd cmld
Rnd_xh11 xhp11 xhn11 20k
Cxh11p xhp11 0 1e-13
Cxh11n xhn11 0 1e-13
Xih_0_11 a_xp0 a_xn0 wih_p_0_11 wih_n_0_11 xhp11 xhn11 vdd vbsyn gsyn
Xih_1_11 a_xp1 a_xn1 wih_p_1_11 wih_n_1_11 xhp11 xhn11 vdd vbsyn gsyn
Xih_2_11 a_xp2 a_xn2 wih_p_2_11 wih_n_2_11 xhp11 xhn11 vdd vbsyn gsyn
Xn11 xhp11 xhn11 ahp11 ahn11 vdd vbneu dneuron
Vwih_p_0_12 wih_p_0_12 0 0.3
Vwih_n_0_12 wih_n_0_12 0 0.9
Vwih_p_1_12 wih_p_1_12 0 0.32295983830528996
Vwih_n_1_12 wih_n_1_12 0 0.67704016169471
Vwih_p_2_12 wih_p_2_12 0 0.9
Vwih_n_2_12 wih_n_2_12 0 0.3
Xcm_xh12 xhp12 xhn12 vdd cmld
Rnd_xh12 xhp12 xhn12 20k
Cxh12p xhp12 0 1e-13
Cxh12n xhn12 0 1e-13
Xih_0_12 a_xp0 a_xn0 wih_p_0_12 wih_n_0_12 xhp12 xhn12 vdd vbsyn gsyn
Xih_1_12 a_xp1 a_xn1 wih_p_1_12 wih_n_1_12 xhp12 xhn12 vdd vbsyn gsyn
Xih_2_12 a_xp2 a_xn2 wih_p_2_12 wih_n_2_12 xhp12 xhn12 vdd vbsyn gsyn
Xn12 xhp12 xhn12 ahp12 ahn12 vdd vbneu dneuron
Vwih_p_0_13 wih_p_0_13 0 0.3
Vwih_n_0_13 wih_n_0_13 0 0.9
Vwih_p_1_13 wih_p_1_13 0 0.5015738648642019
Vwih_n_1_13 wih_n_1_13 0 0.4984261351357981
Vwih_p_2_13 wih_p_2_13 0 0.620861153032301
Vwih_n_2_13 wih_n_2_13 0 0.37913884696769895
Xcm_xh13 xhp13 xhn13 vdd cmld
Rnd_xh13 xhp13 xhn13 20k
Cxh13p xhp13 0 1e-13
Cxh13n xhn13 0 1e-13
Xih_0_13 a_xp0 a_xn0 wih_p_0_13 wih_n_0_13 xhp13 xhn13 vdd vbsyn gsyn
Xih_1_13 a_xp1 a_xn1 wih_p_1_13 wih_n_1_13 xhp13 xhn13 vdd vbsyn gsyn
Xih_2_13 a_xp2 a_xn2 wih_p_2_13 wih_n_2_13 xhp13 xhn13 vdd vbsyn gsyn
Xn13 xhp13 xhn13 ahp13 ahn13 vdd vbneu dneuron
Vwih_p_0_14 wih_p_0_14 0 0.9
Vwih_n_0_14 wih_n_0_14 0 0.3
Vwih_p_1_14 wih_p_1_14 0 0.9
Vwih_n_1_14 wih_n_1_14 0 0.3
Vwih_p_2_14 wih_p_2_14 0 0.3571534644309544
Vwih_n_2_14 wih_n_2_14 0 0.6428465355690456
Xcm_xh14 xhp14 xhn14 vdd cmld
Rnd_xh14 xhp14 xhn14 20k
Cxh14p xhp14 0 1e-13
Cxh14n xhn14 0 1e-13
Xih_0_14 a_xp0 a_xn0 wih_p_0_14 wih_n_0_14 xhp14 xhn14 vdd vbsyn gsyn
Xih_1_14 a_xp1 a_xn1 wih_p_1_14 wih_n_1_14 xhp14 xhn14 vdd vbsyn gsyn
Xih_2_14 a_xp2 a_xn2 wih_p_2_14 wih_n_2_14 xhp14 xhn14 vdd vbsyn gsyn
Xn14 xhp14 xhn14 ahp14 ahn14 vdd vbneu dneuron
Vwih_p_0_15 wih_p_0_15 0 0.3
Vwih_n_0_15 wih_n_0_15 0 0.8157571835704964
Vwih_p_1_15 wih_p_1_15 0 0.8816619922192422
Vwih_n_1_15 wih_n_1_15 0 0.3
Vwih_p_2_15 wih_p_2_15 0 0.5766832040158395
Vwih_n_2_15 wih_n_2_15 0 0.4233167959841605
Xcm_xh15 xhp15 xhn15 vdd cmld
Rnd_xh15 xhp15 xhn15 20k
Cxh15p xhp15 0 1e-13
Cxh15n xhn15 0 1e-13
Xih_0_15 a_xp0 a_xn0 wih_p_0_15 wih_n_0_15 xhp15 xhn15 vdd vbsyn gsyn
Xih_1_15 a_xp1 a_xn1 wih_p_1_15 wih_n_1_15 xhp15 xhn15 vdd vbsyn gsyn
Xih_2_15 a_xp2 a_xn2 wih_p_2_15 wih_n_2_15 xhp15 xhn15 vdd vbsyn gsyn
Xn15 xhp15 xhn15 ahp15 ahn15 vdd vbneu dneuron
Vwih_p_0_16 wih_p_0_16 0 0.9
Vwih_n_0_16 wih_n_0_16 0 0.3
Vwih_p_1_16 wih_p_1_16 0 0.7611213426397807
Vwih_n_1_16 wih_n_1_16 0 0.3
Vwih_p_2_16 wih_p_2_16 0 0.3
Vwih_n_2_16 wih_n_2_16 0 0.7407669652262572
Xcm_xh16 xhp16 xhn16 vdd cmld
Rnd_xh16 xhp16 xhn16 20k
Cxh16p xhp16 0 1e-13
Cxh16n xhn16 0 1e-13
Xih_0_16 a_xp0 a_xn0 wih_p_0_16 wih_n_0_16 xhp16 xhn16 vdd vbsyn gsyn
Xih_1_16 a_xp1 a_xn1 wih_p_1_16 wih_n_1_16 xhp16 xhn16 vdd vbsyn gsyn
Xih_2_16 a_xp2 a_xn2 wih_p_2_16 wih_n_2_16 xhp16 xhn16 vdd vbsyn gsyn
Xn16 xhp16 xhn16 ahp16 ahn16 vdd vbneu dneuron
Vwih_p_0_17 wih_p_0_17 0 0.4292113581070451
Vwih_n_0_17 wih_n_0_17 0 0.570788641892955
Vwih_p_1_17 wih_p_1_17 0 0.6522939881571305
Vwih_n_1_17 wih_n_1_17 0 0.34770601184286953
Vwih_p_2_17 wih_p_2_17 0 0.6802479893320587
Vwih_n_2_17 wih_n_2_17 0 0.31975201066794134
Xcm_xh17 xhp17 xhn17 vdd cmld
Rnd_xh17 xhp17 xhn17 20k
Cxh17p xhp17 0 1e-13
Cxh17n xhn17 0 1e-13
Xih_0_17 a_xp0 a_xn0 wih_p_0_17 wih_n_0_17 xhp17 xhn17 vdd vbsyn gsyn
Xih_1_17 a_xp1 a_xn1 wih_p_1_17 wih_n_1_17 xhp17 xhn17 vdd vbsyn gsyn
Xih_2_17 a_xp2 a_xn2 wih_p_2_17 wih_n_2_17 xhp17 xhn17 vdd vbsyn gsyn
Xn17 xhp17 xhn17 ahp17 ahn17 vdd vbneu dneuron
Vwih_p_0_18 wih_p_0_18 0 0.3
Vwih_n_0_18 wih_n_0_18 0 0.9
Vwih_p_1_18 wih_p_1_18 0 0.3
Vwih_n_1_18 wih_n_1_18 0 0.9
Vwih_p_2_18 wih_p_2_18 0 0.3
Vwih_n_2_18 wih_n_2_18 0 0.9
Xcm_xh18 xhp18 xhn18 vdd cmld
Rnd_xh18 xhp18 xhn18 20k
Cxh18p xhp18 0 1e-13
Cxh18n xhn18 0 1e-13
Xih_0_18 a_xp0 a_xn0 wih_p_0_18 wih_n_0_18 xhp18 xhn18 vdd vbsyn gsyn
Xih_1_18 a_xp1 a_xn1 wih_p_1_18 wih_n_1_18 xhp18 xhn18 vdd vbsyn gsyn
Xih_2_18 a_xp2 a_xn2 wih_p_2_18 wih_n_2_18 xhp18 xhn18 vdd vbsyn gsyn
Xn18 xhp18 xhn18 ahp18 ahn18 vdd vbneu dneuron
Vwih_p_0_19 wih_p_0_19 0 0.722177639967149
Vwih_n_0_19 wih_n_0_19 0 0.3
Vwih_p_1_19 wih_p_1_19 0 0.44483422619378127
Vwih_n_1_19 wih_n_1_19 0 0.5551657738062187
Vwih_p_2_19 wih_p_2_19 0 0.3
Vwih_n_2_19 wih_n_2_19 0 0.9
Xcm_xh19 xhp19 xhn19 vdd cmld
Rnd_xh19 xhp19 xhn19 20k
Cxh19p xhp19 0 1e-13
Cxh19n xhn19 0 1e-13
Xih_0_19 a_xp0 a_xn0 wih_p_0_19 wih_n_0_19 xhp19 xhn19 vdd vbsyn gsyn
Xih_1_19 a_xp1 a_xn1 wih_p_1_19 wih_n_1_19 xhp19 xhn19 vdd vbsyn gsyn
Xih_2_19 a_xp2 a_xn2 wih_p_2_19 wih_n_2_19 xhp19 xhn19 vdd vbsyn gsyn
Xn19 xhp19 xhn19 ahp19 ahn19 vdd vbneu dneuron
Vwih_p_0_20 wih_p_0_20 0 0.30169751066112394
Vwih_n_0_20 wih_n_0_20 0 0.6983024893388761
Vwih_p_1_20 wih_p_1_20 0 0.3
Vwih_n_1_20 wih_n_1_20 0 0.9
Vwih_p_2_20 wih_p_2_20 0 0.40525572526805353
Vwih_n_2_20 wih_n_2_20 0 0.5947442747319465
Xcm_xh20 xhp20 xhn20 vdd cmld
Rnd_xh20 xhp20 xhn20 20k
Cxh20p xhp20 0 1e-13
Cxh20n xhn20 0 1e-13
Xih_0_20 a_xp0 a_xn0 wih_p_0_20 wih_n_0_20 xhp20 xhn20 vdd vbsyn gsyn
Xih_1_20 a_xp1 a_xn1 wih_p_1_20 wih_n_1_20 xhp20 xhn20 vdd vbsyn gsyn
Xih_2_20 a_xp2 a_xn2 wih_p_2_20 wih_n_2_20 xhp20 xhn20 vdd vbsyn gsyn
Xn20 xhp20 xhn20 ahp20 ahn20 vdd vbneu dneuron
Vwih_p_0_21 wih_p_0_21 0 0.3
Vwih_n_0_21 wih_n_0_21 0 0.8115294588847293
Vwih_p_1_21 wih_p_1_21 0 0.3
Vwih_n_1_21 wih_n_1_21 0 0.7008676879319644
Vwih_p_2_21 wih_p_2_21 0 0.46963224415061666
Vwih_n_2_21 wih_n_2_21 0 0.5303677558493833
Xcm_xh21 xhp21 xhn21 vdd cmld
Rnd_xh21 xhp21 xhn21 20k
Cxh21p xhp21 0 1e-13
Cxh21n xhn21 0 1e-13
Xih_0_21 a_xp0 a_xn0 wih_p_0_21 wih_n_0_21 xhp21 xhn21 vdd vbsyn gsyn
Xih_1_21 a_xp1 a_xn1 wih_p_1_21 wih_n_1_21 xhp21 xhn21 vdd vbsyn gsyn
Xih_2_21 a_xp2 a_xn2 wih_p_2_21 wih_n_2_21 xhp21 xhn21 vdd vbsyn gsyn
Xn21 xhp21 xhn21 ahp21 ahn21 vdd vbneu dneuron
Vwih_p_0_22 wih_p_0_22 0 0.5657467881538336
Vwih_n_0_22 wih_n_0_22 0 0.4342532118461664
Vwih_p_1_22 wih_p_1_22 0 0.5214399331308857
Vwih_n_1_22 wih_n_1_22 0 0.47856006686911434
Vwih_p_2_22 wih_p_2_22 0 0.9
Vwih_n_2_22 wih_n_2_22 0 0.3
Xcm_xh22 xhp22 xhn22 vdd cmld
Rnd_xh22 xhp22 xhn22 20k
Cxh22p xhp22 0 1e-13
Cxh22n xhn22 0 1e-13
Xih_0_22 a_xp0 a_xn0 wih_p_0_22 wih_n_0_22 xhp22 xhn22 vdd vbsyn gsyn
Xih_1_22 a_xp1 a_xn1 wih_p_1_22 wih_n_1_22 xhp22 xhn22 vdd vbsyn gsyn
Xih_2_22 a_xp2 a_xn2 wih_p_2_22 wih_n_2_22 xhp22 xhn22 vdd vbsyn gsyn
Xn22 xhp22 xhn22 ahp22 ahn22 vdd vbneu dneuron
Vwih_p_0_23 wih_p_0_23 0 0.9
Vwih_n_0_23 wih_n_0_23 0 0.3
Vwih_p_1_23 wih_p_1_23 0 0.8067071770658532
Vwih_n_1_23 wih_n_1_23 0 0.3
Vwih_p_2_23 wih_p_2_23 0 0.4317323423420582
Vwih_n_2_23 wih_n_2_23 0 0.5682676576579417
Xcm_xh23 xhp23 xhn23 vdd cmld
Rnd_xh23 xhp23 xhn23 20k
Cxh23p xhp23 0 1e-13
Cxh23n xhn23 0 1e-13
Xih_0_23 a_xp0 a_xn0 wih_p_0_23 wih_n_0_23 xhp23 xhn23 vdd vbsyn gsyn
Xih_1_23 a_xp1 a_xn1 wih_p_1_23 wih_n_1_23 xhp23 xhn23 vdd vbsyn gsyn
Xih_2_23 a_xp2 a_xn2 wih_p_2_23 wih_n_2_23 xhp23 xhn23 vdd vbsyn gsyn
Xn23 xhp23 xhn23 ahp23 ahn23 vdd vbneu dneuron
Vwih_p_0_24 wih_p_0_24 0 0.7707084037231007
Vwih_n_0_24 wih_n_0_24 0 0.3
Vwih_p_1_24 wih_p_1_24 0 0.3
Vwih_n_1_24 wih_n_1_24 0 0.7618159377246101
Vwih_p_2_24 wih_p_2_24 0 0.3
Vwih_n_2_24 wih_n_2_24 0 0.7973013879969892
Xcm_xh24 xhp24 xhn24 vdd cmld
Rnd_xh24 xhp24 xhn24 20k
Cxh24p xhp24 0 1e-13
Cxh24n xhn24 0 1e-13
Xih_0_24 a_xp0 a_xn0 wih_p_0_24 wih_n_0_24 xhp24 xhn24 vdd vbsyn gsyn
Xih_1_24 a_xp1 a_xn1 wih_p_1_24 wih_n_1_24 xhp24 xhn24 vdd vbsyn gsyn
Xih_2_24 a_xp2 a_xn2 wih_p_2_24 wih_n_2_24 xhp24 xhn24 vdd vbsyn gsyn
Xn24 xhp24 xhn24 ahp24 ahn24 vdd vbneu dneuron
Vwih_p_0_25 wih_p_0_25 0 0.3
Vwih_n_0_25 wih_n_0_25 0 0.8136480546262893
Vwih_p_1_25 wih_p_1_25 0 0.6052494037818813
Vwih_n_1_25 wih_n_1_25 0 0.3947505962181187
Vwih_p_2_25 wih_p_2_25 0 0.9
Vwih_n_2_25 wih_n_2_25 0 0.3
Xcm_xh25 xhp25 xhn25 vdd cmld
Rnd_xh25 xhp25 xhn25 20k
Cxh25p xhp25 0 1e-13
Cxh25n xhn25 0 1e-13
Xih_0_25 a_xp0 a_xn0 wih_p_0_25 wih_n_0_25 xhp25 xhn25 vdd vbsyn gsyn
Xih_1_25 a_xp1 a_xn1 wih_p_1_25 wih_n_1_25 xhp25 xhn25 vdd vbsyn gsyn
Xih_2_25 a_xp2 a_xn2 wih_p_2_25 wih_n_2_25 xhp25 xhn25 vdd vbsyn gsyn
Xn25 xhp25 xhn25 ahp25 ahn25 vdd vbneu dneuron
Vwih_p_0_26 wih_p_0_26 0 0.9
Vwih_n_0_26 wih_n_0_26 0 0.3
Vwih_p_1_26 wih_p_1_26 0 0.9
Vwih_n_1_26 wih_n_1_26 0 0.3
Vwih_p_2_26 wih_p_2_26 0 0.7511674519822944
Vwih_n_2_26 wih_n_2_26 0 0.3
Xcm_xh26 xhp26 xhn26 vdd cmld
Rnd_xh26 xhp26 xhn26 20k
Cxh26p xhp26 0 1e-13
Cxh26n xhn26 0 1e-13
Xih_0_26 a_xp0 a_xn0 wih_p_0_26 wih_n_0_26 xhp26 xhn26 vdd vbsyn gsyn
Xih_1_26 a_xp1 a_xn1 wih_p_1_26 wih_n_1_26 xhp26 xhn26 vdd vbsyn gsyn
Xih_2_26 a_xp2 a_xn2 wih_p_2_26 wih_n_2_26 xhp26 xhn26 vdd vbsyn gsyn
Xn26 xhp26 xhn26 ahp26 ahn26 vdd vbneu dneuron
Vwih_p_0_27 wih_p_0_27 0 0.3
Vwih_n_0_27 wih_n_0_27 0 0.747797610533719
Vwih_p_1_27 wih_p_1_27 0 0.5275933553493227
Vwih_n_1_27 wih_n_1_27 0 0.47240664465067733
Vwih_p_2_27 wih_p_2_27 0 0.6956453427166414
Vwih_n_2_27 wih_n_2_27 0 0.30435465728335864
Xcm_xh27 xhp27 xhn27 vdd cmld
Rnd_xh27 xhp27 xhn27 20k
Cxh27p xhp27 0 1e-13
Cxh27n xhn27 0 1e-13
Xih_0_27 a_xp0 a_xn0 wih_p_0_27 wih_n_0_27 xhp27 xhn27 vdd vbsyn gsyn
Xih_1_27 a_xp1 a_xn1 wih_p_1_27 wih_n_1_27 xhp27 xhn27 vdd vbsyn gsyn
Xih_2_27 a_xp2 a_xn2 wih_p_2_27 wih_n_2_27 xhp27 xhn27 vdd vbsyn gsyn
Xn27 xhp27 xhn27 ahp27 ahn27 vdd vbneu dneuron
Vwih_p_0_28 wih_p_0_28 0 0.45598889049487856
Vwih_n_0_28 wih_n_0_28 0 0.5440111095051214
Vwih_p_1_28 wih_p_1_28 0 0.9
Vwih_n_1_28 wih_n_1_28 0 0.3
Vwih_p_2_28 wih_p_2_28 0 0.3
Vwih_n_2_28 wih_n_2_28 0 0.7951822676823646
Xcm_xh28 xhp28 xhn28 vdd cmld
Rnd_xh28 xhp28 xhn28 20k
Cxh28p xhp28 0 1e-13
Cxh28n xhn28 0 1e-13
Xih_0_28 a_xp0 a_xn0 wih_p_0_28 wih_n_0_28 xhp28 xhn28 vdd vbsyn gsyn
Xih_1_28 a_xp1 a_xn1 wih_p_1_28 wih_n_1_28 xhp28 xhn28 vdd vbsyn gsyn
Xih_2_28 a_xp2 a_xn2 wih_p_2_28 wih_n_2_28 xhp28 xhn28 vdd vbsyn gsyn
Xn28 xhp28 xhn28 ahp28 ahn28 vdd vbneu dneuron
Vwih_p_0_29 wih_p_0_29 0 0.3
Vwih_n_0_29 wih_n_0_29 0 0.7570896112962708
Vwih_p_1_29 wih_p_1_29 0 0.6368161964038881
Vwih_n_1_29 wih_n_1_29 0 0.3631838035961119
Vwih_p_2_29 wih_p_2_29 0 0.9
Vwih_n_2_29 wih_n_2_29 0 0.3
Xcm_xh29 xhp29 xhn29 vdd cmld
Rnd_xh29 xhp29 xhn29 20k
Cxh29p xhp29 0 1e-13
Cxh29n xhn29 0 1e-13
Xih_0_29 a_xp0 a_xn0 wih_p_0_29 wih_n_0_29 xhp29 xhn29 vdd vbsyn gsyn
Xih_1_29 a_xp1 a_xn1 wih_p_1_29 wih_n_1_29 xhp29 xhn29 vdd vbsyn gsyn
Xih_2_29 a_xp2 a_xn2 wih_p_2_29 wih_n_2_29 xhp29 xhn29 vdd vbsyn gsyn
Xn29 xhp29 xhn29 ahp29 ahn29 vdd vbneu dneuron
Vwih_p_0_30 wih_p_0_30 0 0.3
Vwih_n_0_30 wih_n_0_30 0 0.9
Vwih_p_1_30 wih_p_1_30 0 0.3
Vwih_n_1_30 wih_n_1_30 0 0.80457447565724
Vwih_p_2_30 wih_p_2_30 0 0.9
Vwih_n_2_30 wih_n_2_30 0 0.3
Xcm_xh30 xhp30 xhn30 vdd cmld
Rnd_xh30 xhp30 xhn30 20k
Cxh30p xhp30 0 1e-13
Cxh30n xhn30 0 1e-13
Xih_0_30 a_xp0 a_xn0 wih_p_0_30 wih_n_0_30 xhp30 xhn30 vdd vbsyn gsyn
Xih_1_30 a_xp1 a_xn1 wih_p_1_30 wih_n_1_30 xhp30 xhn30 vdd vbsyn gsyn
Xih_2_30 a_xp2 a_xn2 wih_p_2_30 wih_n_2_30 xhp30 xhn30 vdd vbsyn gsyn
Xn30 xhp30 xhn30 ahp30 ahn30 vdd vbneu dneuron
Vwih_p_0_31 wih_p_0_31 0 0.3
Vwih_n_0_31 wih_n_0_31 0 0.744422362415024
Vwih_p_1_31 wih_p_1_31 0 0.9
Vwih_n_1_31 wih_n_1_31 0 0.3
Vwih_p_2_31 wih_p_2_31 0 0.3
Vwih_n_2_31 wih_n_2_31 0 0.7957470795210353
Xcm_xh31 xhp31 xhn31 vdd cmld
Rnd_xh31 xhp31 xhn31 20k
Cxh31p xhp31 0 1e-13
Cxh31n xhn31 0 1e-13
Xih_0_31 a_xp0 a_xn0 wih_p_0_31 wih_n_0_31 xhp31 xhn31 vdd vbsyn gsyn
Xih_1_31 a_xp1 a_xn1 wih_p_1_31 wih_n_1_31 xhp31 xhn31 vdd vbsyn gsyn
Xih_2_31 a_xp2 a_xn2 wih_p_2_31 wih_n_2_31 xhp31 xhn31 vdd vbsyn gsyn
Xn31 xhp31 xhn31 ahp31 ahn31 vdd vbneu dneuron
Vwih_p_0_32 wih_p_0_32 0 0.8860373611819323
Vwih_n_0_32 wih_n_0_32 0 0.3
Vwih_p_1_32 wih_p_1_32 0 0.4682561081982902
Vwih_n_1_32 wih_n_1_32 0 0.5317438918017098
Vwih_p_2_32 wih_p_2_32 0 0.6654412187902091
Vwih_n_2_32 wih_n_2_32 0 0.3345587812097909
Xcm_xh32 xhp32 xhn32 vdd cmld
Rnd_xh32 xhp32 xhn32 20k
Cxh32p xhp32 0 1e-13
Cxh32n xhn32 0 1e-13
Xih_0_32 a_xp0 a_xn0 wih_p_0_32 wih_n_0_32 xhp32 xhn32 vdd vbsyn gsyn
Xih_1_32 a_xp1 a_xn1 wih_p_1_32 wih_n_1_32 xhp32 xhn32 vdd vbsyn gsyn
Xih_2_32 a_xp2 a_xn2 wih_p_2_32 wih_n_2_32 xhp32 xhn32 vdd vbsyn gsyn
Xn32 xhp32 xhn32 ahp32 ahn32 vdd vbneu dneuron
Vwih_p_0_33 wih_p_0_33 0 0.3
Vwih_n_0_33 wih_n_0_33 0 0.872918635304701
Vwih_p_1_33 wih_p_1_33 0 0.3
Vwih_n_1_33 wih_n_1_33 0 0.9
Vwih_p_2_33 wih_p_2_33 0 0.7791978442123003
Vwih_n_2_33 wih_n_2_33 0 0.3
Xcm_xh33 xhp33 xhn33 vdd cmld
Rnd_xh33 xhp33 xhn33 20k
Cxh33p xhp33 0 1e-13
Cxh33n xhn33 0 1e-13
Xih_0_33 a_xp0 a_xn0 wih_p_0_33 wih_n_0_33 xhp33 xhn33 vdd vbsyn gsyn
Xih_1_33 a_xp1 a_xn1 wih_p_1_33 wih_n_1_33 xhp33 xhn33 vdd vbsyn gsyn
Xih_2_33 a_xp2 a_xn2 wih_p_2_33 wih_n_2_33 xhp33 xhn33 vdd vbsyn gsyn
Xn33 xhp33 xhn33 ahp33 ahn33 vdd vbneu dneuron
Vwih_p_0_34 wih_p_0_34 0 0.30944926628536995
Vwih_n_0_34 wih_n_0_34 0 0.69055073371463
Vwih_p_1_34 wih_p_1_34 0 0.3
Vwih_n_1_34 wih_n_1_34 0 0.8307294984086524
Vwih_p_2_34 wih_p_2_34 0 0.3
Vwih_n_2_34 wih_n_2_34 0 0.8979054254592864
Xcm_xh34 xhp34 xhn34 vdd cmld
Rnd_xh34 xhp34 xhn34 20k
Cxh34p xhp34 0 1e-13
Cxh34n xhn34 0 1e-13
Xih_0_34 a_xp0 a_xn0 wih_p_0_34 wih_n_0_34 xhp34 xhn34 vdd vbsyn gsyn
Xih_1_34 a_xp1 a_xn1 wih_p_1_34 wih_n_1_34 xhp34 xhn34 vdd vbsyn gsyn
Xih_2_34 a_xp2 a_xn2 wih_p_2_34 wih_n_2_34 xhp34 xhn34 vdd vbsyn gsyn
Xn34 xhp34 xhn34 ahp34 ahn34 vdd vbneu dneuron
Vwih_p_0_35 wih_p_0_35 0 0.3
Vwih_n_0_35 wih_n_0_35 0 0.8762128740602273
Vwih_p_1_35 wih_p_1_35 0 0.9
Vwih_n_1_35 wih_n_1_35 0 0.3
Vwih_p_2_35 wih_p_2_35 0 0.3
Vwih_n_2_35 wih_n_2_35 0 0.8321515807086471
Xcm_xh35 xhp35 xhn35 vdd cmld
Rnd_xh35 xhp35 xhn35 20k
Cxh35p xhp35 0 1e-13
Cxh35n xhn35 0 1e-13
Xih_0_35 a_xp0 a_xn0 wih_p_0_35 wih_n_0_35 xhp35 xhn35 vdd vbsyn gsyn
Xih_1_35 a_xp1 a_xn1 wih_p_1_35 wih_n_1_35 xhp35 xhn35 vdd vbsyn gsyn
Xih_2_35 a_xp2 a_xn2 wih_p_2_35 wih_n_2_35 xhp35 xhn35 vdd vbsyn gsyn
Xn35 xhp35 xhn35 ahp35 ahn35 vdd vbneu dneuron
Vwih_p_0_36 wih_p_0_36 0 0.30470977578864855
Vwih_n_0_36 wih_n_0_36 0 0.6952902242113514
Vwih_p_1_36 wih_p_1_36 0 0.9
Vwih_n_1_36 wih_n_1_36 0 0.3
Vwih_p_2_36 wih_p_2_36 0 0.34436627732019964
Vwih_n_2_36 wih_n_2_36 0 0.6556337226798004
Xcm_xh36 xhp36 xhn36 vdd cmld
Rnd_xh36 xhp36 xhn36 20k
Cxh36p xhp36 0 1e-13
Cxh36n xhn36 0 1e-13
Xih_0_36 a_xp0 a_xn0 wih_p_0_36 wih_n_0_36 xhp36 xhn36 vdd vbsyn gsyn
Xih_1_36 a_xp1 a_xn1 wih_p_1_36 wih_n_1_36 xhp36 xhn36 vdd vbsyn gsyn
Xih_2_36 a_xp2 a_xn2 wih_p_2_36 wih_n_2_36 xhp36 xhn36 vdd vbsyn gsyn
Xn36 xhp36 xhn36 ahp36 ahn36 vdd vbneu dneuron
Vwih_p_0_37 wih_p_0_37 0 0.4979637066560694
Vwih_n_0_37 wih_n_0_37 0 0.5020362933439306
Vwih_p_1_37 wih_p_1_37 0 0.632354324712485
Vwih_n_1_37 wih_n_1_37 0 0.367645675287515
Vwih_p_2_37 wih_p_2_37 0 0.3934403276955831
Vwih_n_2_37 wih_n_2_37 0 0.6065596723044169
Xcm_xh37 xhp37 xhn37 vdd cmld
Rnd_xh37 xhp37 xhn37 20k
Cxh37p xhp37 0 1e-13
Cxh37n xhn37 0 1e-13
Xih_0_37 a_xp0 a_xn0 wih_p_0_37 wih_n_0_37 xhp37 xhn37 vdd vbsyn gsyn
Xih_1_37 a_xp1 a_xn1 wih_p_1_37 wih_n_1_37 xhp37 xhn37 vdd vbsyn gsyn
Xih_2_37 a_xp2 a_xn2 wih_p_2_37 wih_n_2_37 xhp37 xhn37 vdd vbsyn gsyn
Xn37 xhp37 xhn37 ahp37 ahn37 vdd vbneu dneuron
Vwih_p_0_38 wih_p_0_38 0 0.3
Vwih_n_0_38 wih_n_0_38 0 0.7477255893955157
Vwih_p_1_38 wih_p_1_38 0 0.9
Vwih_n_1_38 wih_n_1_38 0 0.3
Vwih_p_2_38 wih_p_2_38 0 0.6151390526684146
Vwih_n_2_38 wih_n_2_38 0 0.3848609473315854
Xcm_xh38 xhp38 xhn38 vdd cmld
Rnd_xh38 xhp38 xhn38 20k
Cxh38p xhp38 0 1e-13
Cxh38n xhn38 0 1e-13
Xih_0_38 a_xp0 a_xn0 wih_p_0_38 wih_n_0_38 xhp38 xhn38 vdd vbsyn gsyn
Xih_1_38 a_xp1 a_xn1 wih_p_1_38 wih_n_1_38 xhp38 xhn38 vdd vbsyn gsyn
Xih_2_38 a_xp2 a_xn2 wih_p_2_38 wih_n_2_38 xhp38 xhn38 vdd vbsyn gsyn
Xn38 xhp38 xhn38 ahp38 ahn38 vdd vbneu dneuron
Vwih_p_0_39 wih_p_0_39 0 0.3
Vwih_n_0_39 wih_n_0_39 0 0.7266176976796916
Vwih_p_1_39 wih_p_1_39 0 0.3
Vwih_n_1_39 wih_n_1_39 0 0.9
Vwih_p_2_39 wih_p_2_39 0 0.3
Vwih_n_2_39 wih_n_2_39 0 0.9
Xcm_xh39 xhp39 xhn39 vdd cmld
Rnd_xh39 xhp39 xhn39 20k
Cxh39p xhp39 0 1e-13
Cxh39n xhn39 0 1e-13
Xih_0_39 a_xp0 a_xn0 wih_p_0_39 wih_n_0_39 xhp39 xhn39 vdd vbsyn gsyn
Xih_1_39 a_xp1 a_xn1 wih_p_1_39 wih_n_1_39 xhp39 xhn39 vdd vbsyn gsyn
Xih_2_39 a_xp2 a_xn2 wih_p_2_39 wih_n_2_39 xhp39 xhn39 vdd vbsyn gsyn
Xn39 xhp39 xhn39 ahp39 ahn39 vdd vbneu dneuron
Vwih_p_0_40 wih_p_0_40 0 0.3
Vwih_n_0_40 wih_n_0_40 0 0.8688363432511002
Vwih_p_1_40 wih_p_1_40 0 0.3
Vwih_n_1_40 wih_n_1_40 0 0.9
Vwih_p_2_40 wih_p_2_40 0 0.9
Vwih_n_2_40 wih_n_2_40 0 0.3
Xcm_xh40 xhp40 xhn40 vdd cmld
Rnd_xh40 xhp40 xhn40 20k
Cxh40p xhp40 0 1e-13
Cxh40n xhn40 0 1e-13
Xih_0_40 a_xp0 a_xn0 wih_p_0_40 wih_n_0_40 xhp40 xhn40 vdd vbsyn gsyn
Xih_1_40 a_xp1 a_xn1 wih_p_1_40 wih_n_1_40 xhp40 xhn40 vdd vbsyn gsyn
Xih_2_40 a_xp2 a_xn2 wih_p_2_40 wih_n_2_40 xhp40 xhn40 vdd vbsyn gsyn
Xn40 xhp40 xhn40 ahp40 ahn40 vdd vbneu dneuron
Vwih_p_0_41 wih_p_0_41 0 0.5367562495654543
Vwih_n_0_41 wih_n_0_41 0 0.46324375043454563
Vwih_p_1_41 wih_p_1_41 0 0.6931953911527509
Vwih_n_1_41 wih_n_1_41 0 0.30680460884724914
Vwih_p_2_41 wih_p_2_41 0 0.3
Vwih_n_2_41 wih_n_2_41 0 0.9
Xcm_xh41 xhp41 xhn41 vdd cmld
Rnd_xh41 xhp41 xhn41 20k
Cxh41p xhp41 0 1e-13
Cxh41n xhn41 0 1e-13
Xih_0_41 a_xp0 a_xn0 wih_p_0_41 wih_n_0_41 xhp41 xhn41 vdd vbsyn gsyn
Xih_1_41 a_xp1 a_xn1 wih_p_1_41 wih_n_1_41 xhp41 xhn41 vdd vbsyn gsyn
Xih_2_41 a_xp2 a_xn2 wih_p_2_41 wih_n_2_41 xhp41 xhn41 vdd vbsyn gsyn
Xn41 xhp41 xhn41 ahp41 ahn41 vdd vbneu dneuron
Vwih_p_0_42 wih_p_0_42 0 0.3253612287601446
Vwih_n_0_42 wih_n_0_42 0 0.6746387712398554
Vwih_p_1_42 wih_p_1_42 0 0.4135641733870928
Vwih_n_1_42 wih_n_1_42 0 0.5864358266129072
Vwih_p_2_42 wih_p_2_42 0 0.5272123208853808
Vwih_n_2_42 wih_n_2_42 0 0.47278767911461916
Xcm_xh42 xhp42 xhn42 vdd cmld
Rnd_xh42 xhp42 xhn42 20k
Cxh42p xhp42 0 1e-13
Cxh42n xhn42 0 1e-13
Xih_0_42 a_xp0 a_xn0 wih_p_0_42 wih_n_0_42 xhp42 xhn42 vdd vbsyn gsyn
Xih_1_42 a_xp1 a_xn1 wih_p_1_42 wih_n_1_42 xhp42 xhn42 vdd vbsyn gsyn
Xih_2_42 a_xp2 a_xn2 wih_p_2_42 wih_n_2_42 xhp42 xhn42 vdd vbsyn gsyn
Xn42 xhp42 xhn42 ahp42 ahn42 vdd vbneu dneuron
Vwih_p_0_43 wih_p_0_43 0 0.4257370541580222
Vwih_n_0_43 wih_n_0_43 0 0.5742629458419778
Vwih_p_1_43 wih_p_1_43 0 0.3
Vwih_n_1_43 wih_n_1_43 0 0.9
Vwih_p_2_43 wih_p_2_43 0 0.8930657213899642
Vwih_n_2_43 wih_n_2_43 0 0.3
Xcm_xh43 xhp43 xhn43 vdd cmld
Rnd_xh43 xhp43 xhn43 20k
Cxh43p xhp43 0 1e-13
Cxh43n xhn43 0 1e-13
Xih_0_43 a_xp0 a_xn0 wih_p_0_43 wih_n_0_43 xhp43 xhn43 vdd vbsyn gsyn
Xih_1_43 a_xp1 a_xn1 wih_p_1_43 wih_n_1_43 xhp43 xhn43 vdd vbsyn gsyn
Xih_2_43 a_xp2 a_xn2 wih_p_2_43 wih_n_2_43 xhp43 xhn43 vdd vbsyn gsyn
Xn43 xhp43 xhn43 ahp43 ahn43 vdd vbneu dneuron
Vwih_p_0_44 wih_p_0_44 0 0.7557022479795288
Vwih_n_0_44 wih_n_0_44 0 0.3
Vwih_p_1_44 wih_p_1_44 0 0.5269496082056732
Vwih_n_1_44 wih_n_1_44 0 0.47305039179432684
Vwih_p_2_44 wih_p_2_44 0 0.8716041682808277
Vwih_n_2_44 wih_n_2_44 0 0.3
Xcm_xh44 xhp44 xhn44 vdd cmld
Rnd_xh44 xhp44 xhn44 20k
Cxh44p xhp44 0 1e-13
Cxh44n xhn44 0 1e-13
Xih_0_44 a_xp0 a_xn0 wih_p_0_44 wih_n_0_44 xhp44 xhn44 vdd vbsyn gsyn
Xih_1_44 a_xp1 a_xn1 wih_p_1_44 wih_n_1_44 xhp44 xhn44 vdd vbsyn gsyn
Xih_2_44 a_xp2 a_xn2 wih_p_2_44 wih_n_2_44 xhp44 xhn44 vdd vbsyn gsyn
Xn44 xhp44 xhn44 ahp44 ahn44 vdd vbneu dneuron
Vwih_p_0_45 wih_p_0_45 0 0.9
Vwih_n_0_45 wih_n_0_45 0 0.3
Vwih_p_1_45 wih_p_1_45 0 0.9
Vwih_n_1_45 wih_n_1_45 0 0.3
Vwih_p_2_45 wih_p_2_45 0 0.5586891420516871
Vwih_n_2_45 wih_n_2_45 0 0.44131085794831293
Xcm_xh45 xhp45 xhn45 vdd cmld
Rnd_xh45 xhp45 xhn45 20k
Cxh45p xhp45 0 1e-13
Cxh45n xhn45 0 1e-13
Xih_0_45 a_xp0 a_xn0 wih_p_0_45 wih_n_0_45 xhp45 xhn45 vdd vbsyn gsyn
Xih_1_45 a_xp1 a_xn1 wih_p_1_45 wih_n_1_45 xhp45 xhn45 vdd vbsyn gsyn
Xih_2_45 a_xp2 a_xn2 wih_p_2_45 wih_n_2_45 xhp45 xhn45 vdd vbsyn gsyn
Xn45 xhp45 xhn45 ahp45 ahn45 vdd vbneu dneuron
Vwih_p_0_46 wih_p_0_46 0 0.3866737865281155
Vwih_n_0_46 wih_n_0_46 0 0.6133262134718844
Vwih_p_1_46 wih_p_1_46 0 0.3272677039509979
Vwih_n_1_46 wih_n_1_46 0 0.6727322960490021
Vwih_p_2_46 wih_p_2_46 0 0.8208438740421408
Vwih_n_2_46 wih_n_2_46 0 0.3
Xcm_xh46 xhp46 xhn46 vdd cmld
Rnd_xh46 xhp46 xhn46 20k
Cxh46p xhp46 0 1e-13
Cxh46n xhn46 0 1e-13
Xih_0_46 a_xp0 a_xn0 wih_p_0_46 wih_n_0_46 xhp46 xhn46 vdd vbsyn gsyn
Xih_1_46 a_xp1 a_xn1 wih_p_1_46 wih_n_1_46 xhp46 xhn46 vdd vbsyn gsyn
Xih_2_46 a_xp2 a_xn2 wih_p_2_46 wih_n_2_46 xhp46 xhn46 vdd vbsyn gsyn
Xn46 xhp46 xhn46 ahp46 ahn46 vdd vbneu dneuron
Vwih_p_0_47 wih_p_0_47 0 0.3
Vwih_n_0_47 wih_n_0_47 0 0.7525273627089444
Vwih_p_1_47 wih_p_1_47 0 0.3
Vwih_n_1_47 wih_n_1_47 0 0.8288694044286706
Vwih_p_2_47 wih_p_2_47 0 0.6995828882029426
Vwih_n_2_47 wih_n_2_47 0 0.30041711179705743
Xcm_xh47 xhp47 xhn47 vdd cmld
Rnd_xh47 xhp47 xhn47 20k
Cxh47p xhp47 0 1e-13
Cxh47n xhn47 0 1e-13
Xih_0_47 a_xp0 a_xn0 wih_p_0_47 wih_n_0_47 xhp47 xhn47 vdd vbsyn gsyn
Xih_1_47 a_xp1 a_xn1 wih_p_1_47 wih_n_1_47 xhp47 xhn47 vdd vbsyn gsyn
Xih_2_47 a_xp2 a_xn2 wih_p_2_47 wih_n_2_47 xhp47 xhn47 vdd vbsyn gsyn
Xn47 xhp47 xhn47 ahp47 ahn47 vdd vbneu dneuron
Vwih_p_0_48 wih_p_0_48 0 0.6882815027846748
Vwih_n_0_48 wih_n_0_48 0 0.3117184972153252
Vwih_p_1_48 wih_p_1_48 0 0.7291578688858797
Vwih_n_1_48 wih_n_1_48 0 0.3
Vwih_p_2_48 wih_p_2_48 0 0.3
Vwih_n_2_48 wih_n_2_48 0 0.8057184948221677
Xcm_xh48 xhp48 xhn48 vdd cmld
Rnd_xh48 xhp48 xhn48 20k
Cxh48p xhp48 0 1e-13
Cxh48n xhn48 0 1e-13
Xih_0_48 a_xp0 a_xn0 wih_p_0_48 wih_n_0_48 xhp48 xhn48 vdd vbsyn gsyn
Xih_1_48 a_xp1 a_xn1 wih_p_1_48 wih_n_1_48 xhp48 xhn48 vdd vbsyn gsyn
Xih_2_48 a_xp2 a_xn2 wih_p_2_48 wih_n_2_48 xhp48 xhn48 vdd vbsyn gsyn
Xn48 xhp48 xhn48 ahp48 ahn48 vdd vbneu dneuron
Vwih_p_0_49 wih_p_0_49 0 0.6082653930844378
Vwih_n_0_49 wih_n_0_49 0 0.3917346069155621
Vwih_p_1_49 wih_p_1_49 0 0.8295069932651851
Vwih_n_1_49 wih_n_1_49 0 0.3
Vwih_p_2_49 wih_p_2_49 0 0.3272606720542568
Vwih_n_2_49 wih_n_2_49 0 0.6727393279457432
Xcm_xh49 xhp49 xhn49 vdd cmld
Rnd_xh49 xhp49 xhn49 20k
Cxh49p xhp49 0 1e-13
Cxh49n xhn49 0 1e-13
Xih_0_49 a_xp0 a_xn0 wih_p_0_49 wih_n_0_49 xhp49 xhn49 vdd vbsyn gsyn
Xih_1_49 a_xp1 a_xn1 wih_p_1_49 wih_n_1_49 xhp49 xhn49 vdd vbsyn gsyn
Xih_2_49 a_xp2 a_xn2 wih_p_2_49 wih_n_2_49 xhp49 xhn49 vdd vbsyn gsyn
Xn49 xhp49 xhn49 ahp49 ahn49 vdd vbneu dneuron
Vwih_p_0_50 wih_p_0_50 0 0.4034701937635092
Vwih_n_0_50 wih_n_0_50 0 0.5965298062364909
Vwih_p_1_50 wih_p_1_50 0 0.3927365402183496
Vwih_n_1_50 wih_n_1_50 0 0.6072634597816504
Vwih_p_2_50 wih_p_2_50 0 0.9
Vwih_n_2_50 wih_n_2_50 0 0.3
Xcm_xh50 xhp50 xhn50 vdd cmld
Rnd_xh50 xhp50 xhn50 20k
Cxh50p xhp50 0 1e-13
Cxh50n xhn50 0 1e-13
Xih_0_50 a_xp0 a_xn0 wih_p_0_50 wih_n_0_50 xhp50 xhn50 vdd vbsyn gsyn
Xih_1_50 a_xp1 a_xn1 wih_p_1_50 wih_n_1_50 xhp50 xhn50 vdd vbsyn gsyn
Xih_2_50 a_xp2 a_xn2 wih_p_2_50 wih_n_2_50 xhp50 xhn50 vdd vbsyn gsyn
Xn50 xhp50 xhn50 ahp50 ahn50 vdd vbneu dneuron
Vwih_p_0_51 wih_p_0_51 0 0.82429110136646
Vwih_n_0_51 wih_n_0_51 0 0.3
Vwih_p_1_51 wih_p_1_51 0 0.3
Vwih_n_1_51 wih_n_1_51 0 0.9
Vwih_p_2_51 wih_p_2_51 0 0.3
Vwih_n_2_51 wih_n_2_51 0 0.9
Xcm_xh51 xhp51 xhn51 vdd cmld
Rnd_xh51 xhp51 xhn51 20k
Cxh51p xhp51 0 1e-13
Cxh51n xhn51 0 1e-13
Xih_0_51 a_xp0 a_xn0 wih_p_0_51 wih_n_0_51 xhp51 xhn51 vdd vbsyn gsyn
Xih_1_51 a_xp1 a_xn1 wih_p_1_51 wih_n_1_51 xhp51 xhn51 vdd vbsyn gsyn
Xih_2_51 a_xp2 a_xn2 wih_p_2_51 wih_n_2_51 xhp51 xhn51 vdd vbsyn gsyn
Xn51 xhp51 xhn51 ahp51 ahn51 vdd vbneu dneuron
Vwih_p_0_52 wih_p_0_52 0 0.7340398554245041
Vwih_n_0_52 wih_n_0_52 0 0.3
Vwih_p_1_52 wih_p_1_52 0 0.42328288655999985
Vwih_n_1_52 wih_n_1_52 0 0.5767171134400001
Vwih_p_2_52 wih_p_2_52 0 0.6917260912209316
Vwih_n_2_52 wih_n_2_52 0 0.30827390877906835
Xcm_xh52 xhp52 xhn52 vdd cmld
Rnd_xh52 xhp52 xhn52 20k
Cxh52p xhp52 0 1e-13
Cxh52n xhn52 0 1e-13
Xih_0_52 a_xp0 a_xn0 wih_p_0_52 wih_n_0_52 xhp52 xhn52 vdd vbsyn gsyn
Xih_1_52 a_xp1 a_xn1 wih_p_1_52 wih_n_1_52 xhp52 xhn52 vdd vbsyn gsyn
Xih_2_52 a_xp2 a_xn2 wih_p_2_52 wih_n_2_52 xhp52 xhn52 vdd vbsyn gsyn
Xn52 xhp52 xhn52 ahp52 ahn52 vdd vbneu dneuron
Vwih_p_0_53 wih_p_0_53 0 0.5956503553331517
Vwih_n_0_53 wih_n_0_53 0 0.4043496446668483
Vwih_p_1_53 wih_p_1_53 0 0.8634563152958308
Vwih_n_1_53 wih_n_1_53 0 0.3
Vwih_p_2_53 wih_p_2_53 0 0.3
Vwih_n_2_53 wih_n_2_53 0 0.9
Xcm_xh53 xhp53 xhn53 vdd cmld
Rnd_xh53 xhp53 xhn53 20k
Cxh53p xhp53 0 1e-13
Cxh53n xhn53 0 1e-13
Xih_0_53 a_xp0 a_xn0 wih_p_0_53 wih_n_0_53 xhp53 xhn53 vdd vbsyn gsyn
Xih_1_53 a_xp1 a_xn1 wih_p_1_53 wih_n_1_53 xhp53 xhn53 vdd vbsyn gsyn
Xih_2_53 a_xp2 a_xn2 wih_p_2_53 wih_n_2_53 xhp53 xhn53 vdd vbsyn gsyn
Xn53 xhp53 xhn53 ahp53 ahn53 vdd vbneu dneuron
Vwih_p_0_54 wih_p_0_54 0 0.3027693178801407
Vwih_n_0_54 wih_n_0_54 0 0.6972306821198593
Vwih_p_1_54 wih_p_1_54 0 0.5903578656668507
Vwih_n_1_54 wih_n_1_54 0 0.40964213433314933
Vwih_p_2_54 wih_p_2_54 0 0.5844090317091097
Vwih_n_2_54 wih_n_2_54 0 0.41559096829089026
Xcm_xh54 xhp54 xhn54 vdd cmld
Rnd_xh54 xhp54 xhn54 20k
Cxh54p xhp54 0 1e-13
Cxh54n xhn54 0 1e-13
Xih_0_54 a_xp0 a_xn0 wih_p_0_54 wih_n_0_54 xhp54 xhn54 vdd vbsyn gsyn
Xih_1_54 a_xp1 a_xn1 wih_p_1_54 wih_n_1_54 xhp54 xhn54 vdd vbsyn gsyn
Xih_2_54 a_xp2 a_xn2 wih_p_2_54 wih_n_2_54 xhp54 xhn54 vdd vbsyn gsyn
Xn54 xhp54 xhn54 ahp54 ahn54 vdd vbneu dneuron
Vwih_p_0_55 wih_p_0_55 0 0.3
Vwih_n_0_55 wih_n_0_55 0 0.8413301686254171
Vwih_p_1_55 wih_p_1_55 0 0.31022278155436517
Vwih_n_1_55 wih_n_1_55 0 0.6897772184456348
Vwih_p_2_55 wih_p_2_55 0 0.3
Vwih_n_2_55 wih_n_2_55 0 0.7109034141132868
Xcm_xh55 xhp55 xhn55 vdd cmld
Rnd_xh55 xhp55 xhn55 20k
Cxh55p xhp55 0 1e-13
Cxh55n xhn55 0 1e-13
Xih_0_55 a_xp0 a_xn0 wih_p_0_55 wih_n_0_55 xhp55 xhn55 vdd vbsyn gsyn
Xih_1_55 a_xp1 a_xn1 wih_p_1_55 wih_n_1_55 xhp55 xhn55 vdd vbsyn gsyn
Xih_2_55 a_xp2 a_xn2 wih_p_2_55 wih_n_2_55 xhp55 xhn55 vdd vbsyn gsyn
Xn55 xhp55 xhn55 ahp55 ahn55 vdd vbneu dneuron
Vwih_p_0_56 wih_p_0_56 0 0.5160845000727355
Vwih_n_0_56 wih_n_0_56 0 0.4839154999272645
Vwih_p_1_56 wih_p_1_56 0 0.7522031302663645
Vwih_n_1_56 wih_n_1_56 0 0.3
Vwih_p_2_56 wih_p_2_56 0 0.40083134142074334
Vwih_n_2_56 wih_n_2_56 0 0.5991686585792566
Xcm_xh56 xhp56 xhn56 vdd cmld
Rnd_xh56 xhp56 xhn56 20k
Cxh56p xhp56 0 1e-13
Cxh56n xhn56 0 1e-13
Xih_0_56 a_xp0 a_xn0 wih_p_0_56 wih_n_0_56 xhp56 xhn56 vdd vbsyn gsyn
Xih_1_56 a_xp1 a_xn1 wih_p_1_56 wih_n_1_56 xhp56 xhn56 vdd vbsyn gsyn
Xih_2_56 a_xp2 a_xn2 wih_p_2_56 wih_n_2_56 xhp56 xhn56 vdd vbsyn gsyn
Xn56 xhp56 xhn56 ahp56 ahn56 vdd vbneu dneuron
Vwih_p_0_57 wih_p_0_57 0 0.44490054042829486
Vwih_n_0_57 wih_n_0_57 0 0.5550994595717051
Vwih_p_1_57 wih_p_1_57 0 0.3
Vwih_n_1_57 wih_n_1_57 0 0.9
Vwih_p_2_57 wih_p_2_57 0 0.3
Vwih_n_2_57 wih_n_2_57 0 0.8819972377407076
Xcm_xh57 xhp57 xhn57 vdd cmld
Rnd_xh57 xhp57 xhn57 20k
Cxh57p xhp57 0 1e-13
Cxh57n xhn57 0 1e-13
Xih_0_57 a_xp0 a_xn0 wih_p_0_57 wih_n_0_57 xhp57 xhn57 vdd vbsyn gsyn
Xih_1_57 a_xp1 a_xn1 wih_p_1_57 wih_n_1_57 xhp57 xhn57 vdd vbsyn gsyn
Xih_2_57 a_xp2 a_xn2 wih_p_2_57 wih_n_2_57 xhp57 xhn57 vdd vbsyn gsyn
Xn57 xhp57 xhn57 ahp57 ahn57 vdd vbneu dneuron
Vwih_p_0_58 wih_p_0_58 0 0.9
Vwih_n_0_58 wih_n_0_58 0 0.3
Vwih_p_1_58 wih_p_1_58 0 0.3
Vwih_n_1_58 wih_n_1_58 0 0.9
Vwih_p_2_58 wih_p_2_58 0 0.9
Vwih_n_2_58 wih_n_2_58 0 0.3
Xcm_xh58 xhp58 xhn58 vdd cmld
Rnd_xh58 xhp58 xhn58 20k
Cxh58p xhp58 0 1e-13
Cxh58n xhn58 0 1e-13
Xih_0_58 a_xp0 a_xn0 wih_p_0_58 wih_n_0_58 xhp58 xhn58 vdd vbsyn gsyn
Xih_1_58 a_xp1 a_xn1 wih_p_1_58 wih_n_1_58 xhp58 xhn58 vdd vbsyn gsyn
Xih_2_58 a_xp2 a_xn2 wih_p_2_58 wih_n_2_58 xhp58 xhn58 vdd vbsyn gsyn
Xn58 xhp58 xhn58 ahp58 ahn58 vdd vbneu dneuron
Vwih_p_0_59 wih_p_0_59 0 0.3927589552960591
Vwih_n_0_59 wih_n_0_59 0 0.6072410447039409
Vwih_p_1_59 wih_p_1_59 0 0.3
Vwih_n_1_59 wih_n_1_59 0 0.9
Vwih_p_2_59 wih_p_2_59 0 0.9
Vwih_n_2_59 wih_n_2_59 0 0.3
Xcm_xh59 xhp59 xhn59 vdd cmld
Rnd_xh59 xhp59 xhn59 20k
Cxh59p xhp59 0 1e-13
Cxh59n xhn59 0 1e-13
Xih_0_59 a_xp0 a_xn0 wih_p_0_59 wih_n_0_59 xhp59 xhn59 vdd vbsyn gsyn
Xih_1_59 a_xp1 a_xn1 wih_p_1_59 wih_n_1_59 xhp59 xhn59 vdd vbsyn gsyn
Xih_2_59 a_xp2 a_xn2 wih_p_2_59 wih_n_2_59 xhp59 xhn59 vdd vbsyn gsyn
Xn59 xhp59 xhn59 ahp59 ahn59 vdd vbneu dneuron
Vwih_p_0_60 wih_p_0_60 0 0.9
Vwih_n_0_60 wih_n_0_60 0 0.3
Vwih_p_1_60 wih_p_1_60 0 0.3188306399618352
Vwih_n_1_60 wih_n_1_60 0 0.6811693600381648
Vwih_p_2_60 wih_p_2_60 0 0.8122197166041571
Vwih_n_2_60 wih_n_2_60 0 0.3
Xcm_xh60 xhp60 xhn60 vdd cmld
Rnd_xh60 xhp60 xhn60 20k
Cxh60p xhp60 0 1e-13
Cxh60n xhn60 0 1e-13
Xih_0_60 a_xp0 a_xn0 wih_p_0_60 wih_n_0_60 xhp60 xhn60 vdd vbsyn gsyn
Xih_1_60 a_xp1 a_xn1 wih_p_1_60 wih_n_1_60 xhp60 xhn60 vdd vbsyn gsyn
Xih_2_60 a_xp2 a_xn2 wih_p_2_60 wih_n_2_60 xhp60 xhn60 vdd vbsyn gsyn
Xn60 xhp60 xhn60 ahp60 ahn60 vdd vbneu dneuron
Vwih_p_0_61 wih_p_0_61 0 0.3718779670097938
Vwih_n_0_61 wih_n_0_61 0 0.6281220329902062
Vwih_p_1_61 wih_p_1_61 0 0.5183334586232792
Vwih_n_1_61 wih_n_1_61 0 0.4816665413767209
Vwih_p_2_61 wih_p_2_61 0 0.5598570199334507
Vwih_n_2_61 wih_n_2_61 0 0.4401429800665493
Xcm_xh61 xhp61 xhn61 vdd cmld
Rnd_xh61 xhp61 xhn61 20k
Cxh61p xhp61 0 1e-13
Cxh61n xhn61 0 1e-13
Xih_0_61 a_xp0 a_xn0 wih_p_0_61 wih_n_0_61 xhp61 xhn61 vdd vbsyn gsyn
Xih_1_61 a_xp1 a_xn1 wih_p_1_61 wih_n_1_61 xhp61 xhn61 vdd vbsyn gsyn
Xih_2_61 a_xp2 a_xn2 wih_p_2_61 wih_n_2_61 xhp61 xhn61 vdd vbsyn gsyn
Xn61 xhp61 xhn61 ahp61 ahn61 vdd vbneu dneuron
Vwih_p_0_62 wih_p_0_62 0 0.41683620083089523
Vwih_n_0_62 wih_n_0_62 0 0.5831637991691048
Vwih_p_1_62 wih_p_1_62 0 0.6887741438457484
Vwih_n_1_62 wih_n_1_62 0 0.31122585615425163
Vwih_p_2_62 wih_p_2_62 0 0.6388696419786537
Vwih_n_2_62 wih_n_2_62 0 0.3611303580213463
Xcm_xh62 xhp62 xhn62 vdd cmld
Rnd_xh62 xhp62 xhn62 20k
Cxh62p xhp62 0 1e-13
Cxh62n xhn62 0 1e-13
Xih_0_62 a_xp0 a_xn0 wih_p_0_62 wih_n_0_62 xhp62 xhn62 vdd vbsyn gsyn
Xih_1_62 a_xp1 a_xn1 wih_p_1_62 wih_n_1_62 xhp62 xhn62 vdd vbsyn gsyn
Xih_2_62 a_xp2 a_xn2 wih_p_2_62 wih_n_2_62 xhp62 xhn62 vdd vbsyn gsyn
Xn62 xhp62 xhn62 ahp62 ahn62 vdd vbneu dneuron
Vwih_p_0_63 wih_p_0_63 0 0.31176144012528645
Vwih_n_0_63 wih_n_0_63 0 0.6882385598747136
Vwih_p_1_63 wih_p_1_63 0 0.606557537776604
Vwih_n_1_63 wih_n_1_63 0 0.39344246222339596
Vwih_p_2_63 wih_p_2_63 0 0.3125884897781846
Vwih_n_2_63 wih_n_2_63 0 0.6874115102218155
Xcm_xh63 xhp63 xhn63 vdd cmld
Rnd_xh63 xhp63 xhn63 20k
Cxh63p xhp63 0 1e-13
Cxh63n xhn63 0 1e-13
Xih_0_63 a_xp0 a_xn0 wih_p_0_63 wih_n_0_63 xhp63 xhn63 vdd vbsyn gsyn
Xih_1_63 a_xp1 a_xn1 wih_p_1_63 wih_n_1_63 xhp63 xhn63 vdd vbsyn gsyn
Xih_2_63 a_xp2 a_xn2 wih_p_2_63 wih_n_2_63 xhp63 xhn63 vdd vbsyn gsyn
Xn63 xhp63 xhn63 ahp63 ahn63 vdd vbneu dneuron
Vwih_p_0_64 wih_p_0_64 0 0.548174716276388
Vwih_n_0_64 wih_n_0_64 0 0.4518252837236119
Vwih_p_1_64 wih_p_1_64 0 0.3211269442798361
Vwih_n_1_64 wih_n_1_64 0 0.6788730557201639
Vwih_p_2_64 wih_p_2_64 0 0.5350246426637532
Vwih_n_2_64 wih_n_2_64 0 0.46497535733624684
Xcm_xh64 xhp64 xhn64 vdd cmld
Rnd_xh64 xhp64 xhn64 20k
Cxh64p xhp64 0 1e-13
Cxh64n xhn64 0 1e-13
Xih_0_64 a_xp0 a_xn0 wih_p_0_64 wih_n_0_64 xhp64 xhn64 vdd vbsyn gsyn
Xih_1_64 a_xp1 a_xn1 wih_p_1_64 wih_n_1_64 xhp64 xhn64 vdd vbsyn gsyn
Xih_2_64 a_xp2 a_xn2 wih_p_2_64 wih_n_2_64 xhp64 xhn64 vdd vbsyn gsyn
Xn64 xhp64 xhn64 ahp64 ahn64 vdd vbneu dneuron
Vwih_p_0_65 wih_p_0_65 0 0.9
Vwih_n_0_65 wih_n_0_65 0 0.3
Vwih_p_1_65 wih_p_1_65 0 0.3
Vwih_n_1_65 wih_n_1_65 0 0.7354009122932545
Vwih_p_2_65 wih_p_2_65 0 0.3
Vwih_n_2_65 wih_n_2_65 0 0.9
Xcm_xh65 xhp65 xhn65 vdd cmld
Rnd_xh65 xhp65 xhn65 20k
Cxh65p xhp65 0 1e-13
Cxh65n xhn65 0 1e-13
Xih_0_65 a_xp0 a_xn0 wih_p_0_65 wih_n_0_65 xhp65 xhn65 vdd vbsyn gsyn
Xih_1_65 a_xp1 a_xn1 wih_p_1_65 wih_n_1_65 xhp65 xhn65 vdd vbsyn gsyn
Xih_2_65 a_xp2 a_xn2 wih_p_2_65 wih_n_2_65 xhp65 xhn65 vdd vbsyn gsyn
Xn65 xhp65 xhn65 ahp65 ahn65 vdd vbneu dneuron
Vwih_p_0_66 wih_p_0_66 0 0.9
Vwih_n_0_66 wih_n_0_66 0 0.3
Vwih_p_1_66 wih_p_1_66 0 0.6052799858264201
Vwih_n_1_66 wih_n_1_66 0 0.39472001417357994
Vwih_p_2_66 wih_p_2_66 0 0.3
Vwih_n_2_66 wih_n_2_66 0 0.7342211064349417
Xcm_xh66 xhp66 xhn66 vdd cmld
Rnd_xh66 xhp66 xhn66 20k
Cxh66p xhp66 0 1e-13
Cxh66n xhn66 0 1e-13
Xih_0_66 a_xp0 a_xn0 wih_p_0_66 wih_n_0_66 xhp66 xhn66 vdd vbsyn gsyn
Xih_1_66 a_xp1 a_xn1 wih_p_1_66 wih_n_1_66 xhp66 xhn66 vdd vbsyn gsyn
Xih_2_66 a_xp2 a_xn2 wih_p_2_66 wih_n_2_66 xhp66 xhn66 vdd vbsyn gsyn
Xn66 xhp66 xhn66 ahp66 ahn66 vdd vbneu dneuron
Vwih_p_0_67 wih_p_0_67 0 0.41012602438655243
Vwih_n_0_67 wih_n_0_67 0 0.5898739756134476
Vwih_p_1_67 wih_p_1_67 0 0.3
Vwih_n_1_67 wih_n_1_67 0 0.8289503821304236
Vwih_p_2_67 wih_p_2_67 0 0.8376237838486824
Vwih_n_2_67 wih_n_2_67 0 0.3
Xcm_xh67 xhp67 xhn67 vdd cmld
Rnd_xh67 xhp67 xhn67 20k
Cxh67p xhp67 0 1e-13
Cxh67n xhn67 0 1e-13
Xih_0_67 a_xp0 a_xn0 wih_p_0_67 wih_n_0_67 xhp67 xhn67 vdd vbsyn gsyn
Xih_1_67 a_xp1 a_xn1 wih_p_1_67 wih_n_1_67 xhp67 xhn67 vdd vbsyn gsyn
Xih_2_67 a_xp2 a_xn2 wih_p_2_67 wih_n_2_67 xhp67 xhn67 vdd vbsyn gsyn
Xn67 xhp67 xhn67 ahp67 ahn67 vdd vbneu dneuron
Vwih_p_0_68 wih_p_0_68 0 0.756802042973268
Vwih_n_0_68 wih_n_0_68 0 0.3
Vwih_p_1_68 wih_p_1_68 0 0.726286048701539
Vwih_n_1_68 wih_n_1_68 0 0.3
Vwih_p_2_68 wih_p_2_68 0 0.5792732339790984
Vwih_n_2_68 wih_n_2_68 0 0.42072676602090164
Xcm_xh68 xhp68 xhn68 vdd cmld
Rnd_xh68 xhp68 xhn68 20k
Cxh68p xhp68 0 1e-13
Cxh68n xhn68 0 1e-13
Xih_0_68 a_xp0 a_xn0 wih_p_0_68 wih_n_0_68 xhp68 xhn68 vdd vbsyn gsyn
Xih_1_68 a_xp1 a_xn1 wih_p_1_68 wih_n_1_68 xhp68 xhn68 vdd vbsyn gsyn
Xih_2_68 a_xp2 a_xn2 wih_p_2_68 wih_n_2_68 xhp68 xhn68 vdd vbsyn gsyn
Xn68 xhp68 xhn68 ahp68 ahn68 vdd vbneu dneuron
Vwih_p_0_69 wih_p_0_69 0 0.3
Vwih_n_0_69 wih_n_0_69 0 0.9
Vwih_p_1_69 wih_p_1_69 0 0.3
Vwih_n_1_69 wih_n_1_69 0 0.9
Vwih_p_2_69 wih_p_2_69 0 0.6023841105799301
Vwih_n_2_69 wih_n_2_69 0 0.39761588942006987
Xcm_xh69 xhp69 xhn69 vdd cmld
Rnd_xh69 xhp69 xhn69 20k
Cxh69p xhp69 0 1e-13
Cxh69n xhn69 0 1e-13
Xih_0_69 a_xp0 a_xn0 wih_p_0_69 wih_n_0_69 xhp69 xhn69 vdd vbsyn gsyn
Xih_1_69 a_xp1 a_xn1 wih_p_1_69 wih_n_1_69 xhp69 xhn69 vdd vbsyn gsyn
Xih_2_69 a_xp2 a_xn2 wih_p_2_69 wih_n_2_69 xhp69 xhn69 vdd vbsyn gsyn
Xn69 xhp69 xhn69 ahp69 ahn69 vdd vbneu dneuron
Vwih_p_0_70 wih_p_0_70 0 0.3
Vwih_n_0_70 wih_n_0_70 0 0.9
Vwih_p_1_70 wih_p_1_70 0 0.47146797871612023
Vwih_n_1_70 wih_n_1_70 0 0.5285320212838798
Vwih_p_2_70 wih_p_2_70 0 0.3
Vwih_n_2_70 wih_n_2_70 0 0.8691124522826554
Xcm_xh70 xhp70 xhn70 vdd cmld
Rnd_xh70 xhp70 xhn70 20k
Cxh70p xhp70 0 1e-13
Cxh70n xhn70 0 1e-13
Xih_0_70 a_xp0 a_xn0 wih_p_0_70 wih_n_0_70 xhp70 xhn70 vdd vbsyn gsyn
Xih_1_70 a_xp1 a_xn1 wih_p_1_70 wih_n_1_70 xhp70 xhn70 vdd vbsyn gsyn
Xih_2_70 a_xp2 a_xn2 wih_p_2_70 wih_n_2_70 xhp70 xhn70 vdd vbsyn gsyn
Xn70 xhp70 xhn70 ahp70 ahn70 vdd vbneu dneuron
Vwih_p_0_71 wih_p_0_71 0 0.7279857321552641
Vwih_n_0_71 wih_n_0_71 0 0.3
Vwih_p_1_71 wih_p_1_71 0 0.4292235030423485
Vwih_n_1_71 wih_n_1_71 0 0.5707764969576514
Vwih_p_2_71 wih_p_2_71 0 0.8812105211548702
Vwih_n_2_71 wih_n_2_71 0 0.3
Xcm_xh71 xhp71 xhn71 vdd cmld
Rnd_xh71 xhp71 xhn71 20k
Cxh71p xhp71 0 1e-13
Cxh71n xhn71 0 1e-13
Xih_0_71 a_xp0 a_xn0 wih_p_0_71 wih_n_0_71 xhp71 xhn71 vdd vbsyn gsyn
Xih_1_71 a_xp1 a_xn1 wih_p_1_71 wih_n_1_71 xhp71 xhn71 vdd vbsyn gsyn
Xih_2_71 a_xp2 a_xn2 wih_p_2_71 wih_n_2_71 xhp71 xhn71 vdd vbsyn gsyn
Xn71 xhp71 xhn71 ahp71 ahn71 vdd vbneu dneuron
Vwih_p_0_72 wih_p_0_72 0 0.6215556809933008
Vwih_n_0_72 wih_n_0_72 0 0.37844431900669917
Vwih_p_1_72 wih_p_1_72 0 0.5409495507287507
Vwih_n_1_72 wih_n_1_72 0 0.4590504492712493
Vwih_p_2_72 wih_p_2_72 0 0.3
Vwih_n_2_72 wih_n_2_72 0 0.8504022315201034
Xcm_xh72 xhp72 xhn72 vdd cmld
Rnd_xh72 xhp72 xhn72 20k
Cxh72p xhp72 0 1e-13
Cxh72n xhn72 0 1e-13
Xih_0_72 a_xp0 a_xn0 wih_p_0_72 wih_n_0_72 xhp72 xhn72 vdd vbsyn gsyn
Xih_1_72 a_xp1 a_xn1 wih_p_1_72 wih_n_1_72 xhp72 xhn72 vdd vbsyn gsyn
Xih_2_72 a_xp2 a_xn2 wih_p_2_72 wih_n_2_72 xhp72 xhn72 vdd vbsyn gsyn
Xn72 xhp72 xhn72 ahp72 ahn72 vdd vbneu dneuron
Vwih_p_0_73 wih_p_0_73 0 0.7259751037529326
Vwih_n_0_73 wih_n_0_73 0 0.3
Vwih_p_1_73 wih_p_1_73 0 0.9
Vwih_n_1_73 wih_n_1_73 0 0.3
Vwih_p_2_73 wih_p_2_73 0 0.3
Vwih_n_2_73 wih_n_2_73 0 0.9
Xcm_xh73 xhp73 xhn73 vdd cmld
Rnd_xh73 xhp73 xhn73 20k
Cxh73p xhp73 0 1e-13
Cxh73n xhn73 0 1e-13
Xih_0_73 a_xp0 a_xn0 wih_p_0_73 wih_n_0_73 xhp73 xhn73 vdd vbsyn gsyn
Xih_1_73 a_xp1 a_xn1 wih_p_1_73 wih_n_1_73 xhp73 xhn73 vdd vbsyn gsyn
Xih_2_73 a_xp2 a_xn2 wih_p_2_73 wih_n_2_73 xhp73 xhn73 vdd vbsyn gsyn
Xn73 xhp73 xhn73 ahp73 ahn73 vdd vbneu dneuron
Vwih_p_0_74 wih_p_0_74 0 0.3
Vwih_n_0_74 wih_n_0_74 0 0.8685443812669471
Vwih_p_1_74 wih_p_1_74 0 0.9
Vwih_n_1_74 wih_n_1_74 0 0.3
Vwih_p_2_74 wih_p_2_74 0 0.6842448434110808
Vwih_n_2_74 wih_n_2_74 0 0.3157551565889192
Xcm_xh74 xhp74 xhn74 vdd cmld
Rnd_xh74 xhp74 xhn74 20k
Cxh74p xhp74 0 1e-13
Cxh74n xhn74 0 1e-13
Xih_0_74 a_xp0 a_xn0 wih_p_0_74 wih_n_0_74 xhp74 xhn74 vdd vbsyn gsyn
Xih_1_74 a_xp1 a_xn1 wih_p_1_74 wih_n_1_74 xhp74 xhn74 vdd vbsyn gsyn
Xih_2_74 a_xp2 a_xn2 wih_p_2_74 wih_n_2_74 xhp74 xhn74 vdd vbsyn gsyn
Xn74 xhp74 xhn74 ahp74 ahn74 vdd vbneu dneuron
Vwih_p_0_75 wih_p_0_75 0 0.3934653370079001
Vwih_n_0_75 wih_n_0_75 0 0.6065346629920999
Vwih_p_1_75 wih_p_1_75 0 0.7815122340886218
Vwih_n_1_75 wih_n_1_75 0 0.3
Vwih_p_2_75 wih_p_2_75 0 0.6196971570260454
Vwih_n_2_75 wih_n_2_75 0 0.3803028429739546
Xcm_xh75 xhp75 xhn75 vdd cmld
Rnd_xh75 xhp75 xhn75 20k
Cxh75p xhp75 0 1e-13
Cxh75n xhn75 0 1e-13
Xih_0_75 a_xp0 a_xn0 wih_p_0_75 wih_n_0_75 xhp75 xhn75 vdd vbsyn gsyn
Xih_1_75 a_xp1 a_xn1 wih_p_1_75 wih_n_1_75 xhp75 xhn75 vdd vbsyn gsyn
Xih_2_75 a_xp2 a_xn2 wih_p_2_75 wih_n_2_75 xhp75 xhn75 vdd vbsyn gsyn
Xn75 xhp75 xhn75 ahp75 ahn75 vdd vbneu dneuron
Vwih_p_0_76 wih_p_0_76 0 0.3
Vwih_n_0_76 wih_n_0_76 0 0.7349438995600257
Vwih_p_1_76 wih_p_1_76 0 0.3
Vwih_n_1_76 wih_n_1_76 0 0.7405847282365793
Vwih_p_2_76 wih_p_2_76 0 0.8078990969772955
Vwih_n_2_76 wih_n_2_76 0 0.3
Xcm_xh76 xhp76 xhn76 vdd cmld
Rnd_xh76 xhp76 xhn76 20k
Cxh76p xhp76 0 1e-13
Cxh76n xhn76 0 1e-13
Xih_0_76 a_xp0 a_xn0 wih_p_0_76 wih_n_0_76 xhp76 xhn76 vdd vbsyn gsyn
Xih_1_76 a_xp1 a_xn1 wih_p_1_76 wih_n_1_76 xhp76 xhn76 vdd vbsyn gsyn
Xih_2_76 a_xp2 a_xn2 wih_p_2_76 wih_n_2_76 xhp76 xhn76 vdd vbsyn gsyn
Xn76 xhp76 xhn76 ahp76 ahn76 vdd vbneu dneuron
Vwih_p_0_77 wih_p_0_77 0 0.6235896988043732
Vwih_n_0_77 wih_n_0_77 0 0.37641030119562674
Vwih_p_1_77 wih_p_1_77 0 0.8879656931940771
Vwih_n_1_77 wih_n_1_77 0 0.3
Vwih_p_2_77 wih_p_2_77 0 0.7353610691086008
Vwih_n_2_77 wih_n_2_77 0 0.3
Xcm_xh77 xhp77 xhn77 vdd cmld
Rnd_xh77 xhp77 xhn77 20k
Cxh77p xhp77 0 1e-13
Cxh77n xhn77 0 1e-13
Xih_0_77 a_xp0 a_xn0 wih_p_0_77 wih_n_0_77 xhp77 xhn77 vdd vbsyn gsyn
Xih_1_77 a_xp1 a_xn1 wih_p_1_77 wih_n_1_77 xhp77 xhn77 vdd vbsyn gsyn
Xih_2_77 a_xp2 a_xn2 wih_p_2_77 wih_n_2_77 xhp77 xhn77 vdd vbsyn gsyn
Xn77 xhp77 xhn77 ahp77 ahn77 vdd vbneu dneuron
Vwih_p_0_78 wih_p_0_78 0 0.3
Vwih_n_0_78 wih_n_0_78 0 0.7210383124626208
Vwih_p_1_78 wih_p_1_78 0 0.9
Vwih_n_1_78 wih_n_1_78 0 0.3
Vwih_p_2_78 wih_p_2_78 0 0.3
Vwih_n_2_78 wih_n_2_78 0 0.8323386488458286
Xcm_xh78 xhp78 xhn78 vdd cmld
Rnd_xh78 xhp78 xhn78 20k
Cxh78p xhp78 0 1e-13
Cxh78n xhn78 0 1e-13
Xih_0_78 a_xp0 a_xn0 wih_p_0_78 wih_n_0_78 xhp78 xhn78 vdd vbsyn gsyn
Xih_1_78 a_xp1 a_xn1 wih_p_1_78 wih_n_1_78 xhp78 xhn78 vdd vbsyn gsyn
Xih_2_78 a_xp2 a_xn2 wih_p_2_78 wih_n_2_78 xhp78 xhn78 vdd vbsyn gsyn
Xn78 xhp78 xhn78 ahp78 ahn78 vdd vbneu dneuron
Vwih_p_0_79 wih_p_0_79 0 0.33681377248138533
Vwih_n_0_79 wih_n_0_79 0 0.6631862275186147
Vwih_p_1_79 wih_p_1_79 0 0.3
Vwih_n_1_79 wih_n_1_79 0 0.7818015778876604
Vwih_p_2_79 wih_p_2_79 0 0.3
Vwih_n_2_79 wih_n_2_79 0 0.9
Xcm_xh79 xhp79 xhn79 vdd cmld
Rnd_xh79 xhp79 xhn79 20k
Cxh79p xhp79 0 1e-13
Cxh79n xhn79 0 1e-13
Xih_0_79 a_xp0 a_xn0 wih_p_0_79 wih_n_0_79 xhp79 xhn79 vdd vbsyn gsyn
Xih_1_79 a_xp1 a_xn1 wih_p_1_79 wih_n_1_79 xhp79 xhn79 vdd vbsyn gsyn
Xih_2_79 a_xp2 a_xn2 wih_p_2_79 wih_n_2_79 xhp79 xhn79 vdd vbsyn gsyn
Xn79 xhp79 xhn79 ahp79 ahn79 vdd vbneu dneuron
Vwih_p_0_80 wih_p_0_80 0 0.7241337188981494
Vwih_n_0_80 wih_n_0_80 0 0.3
Vwih_p_1_80 wih_p_1_80 0 0.3
Vwih_n_1_80 wih_n_1_80 0 0.8790271617034494
Vwih_p_2_80 wih_p_2_80 0 0.3
Vwih_n_2_80 wih_n_2_80 0 0.7463209433134159
Xcm_xh80 xhp80 xhn80 vdd cmld
Rnd_xh80 xhp80 xhn80 20k
Cxh80p xhp80 0 1e-13
Cxh80n xhn80 0 1e-13
Xih_0_80 a_xp0 a_xn0 wih_p_0_80 wih_n_0_80 xhp80 xhn80 vdd vbsyn gsyn
Xih_1_80 a_xp1 a_xn1 wih_p_1_80 wih_n_1_80 xhp80 xhn80 vdd vbsyn gsyn
Xih_2_80 a_xp2 a_xn2 wih_p_2_80 wih_n_2_80 xhp80 xhn80 vdd vbsyn gsyn
Xn80 xhp80 xhn80 ahp80 ahn80 vdd vbneu dneuron
Vwih_p_0_81 wih_p_0_81 0 0.8393982525300918
Vwih_n_0_81 wih_n_0_81 0 0.3
Vwih_p_1_81 wih_p_1_81 0 0.8114767339305737
Vwih_n_1_81 wih_n_1_81 0 0.3
Vwih_p_2_81 wih_p_2_81 0 0.3
Vwih_n_2_81 wih_n_2_81 0 0.7237127169236066
Xcm_xh81 xhp81 xhn81 vdd cmld
Rnd_xh81 xhp81 xhn81 20k
Cxh81p xhp81 0 1e-13
Cxh81n xhn81 0 1e-13
Xih_0_81 a_xp0 a_xn0 wih_p_0_81 wih_n_0_81 xhp81 xhn81 vdd vbsyn gsyn
Xih_1_81 a_xp1 a_xn1 wih_p_1_81 wih_n_1_81 xhp81 xhn81 vdd vbsyn gsyn
Xih_2_81 a_xp2 a_xn2 wih_p_2_81 wih_n_2_81 xhp81 xhn81 vdd vbsyn gsyn
Xn81 xhp81 xhn81 ahp81 ahn81 vdd vbneu dneuron
Vwih_p_0_82 wih_p_0_82 0 0.3
Vwih_n_0_82 wih_n_0_82 0 0.9
Vwih_p_1_82 wih_p_1_82 0 0.4624686859291478
Vwih_n_1_82 wih_n_1_82 0 0.5375313140708522
Vwih_p_2_82 wih_p_2_82 0 0.3
Vwih_n_2_82 wih_n_2_82 0 0.9
Xcm_xh82 xhp82 xhn82 vdd cmld
Rnd_xh82 xhp82 xhn82 20k
Cxh82p xhp82 0 1e-13
Cxh82n xhn82 0 1e-13
Xih_0_82 a_xp0 a_xn0 wih_p_0_82 wih_n_0_82 xhp82 xhn82 vdd vbsyn gsyn
Xih_1_82 a_xp1 a_xn1 wih_p_1_82 wih_n_1_82 xhp82 xhn82 vdd vbsyn gsyn
Xih_2_82 a_xp2 a_xn2 wih_p_2_82 wih_n_2_82 xhp82 xhn82 vdd vbsyn gsyn
Xn82 xhp82 xhn82 ahp82 ahn82 vdd vbneu dneuron
Vwih_p_0_83 wih_p_0_83 0 0.3
Vwih_n_0_83 wih_n_0_83 0 0.8637527150547787
Vwih_p_1_83 wih_p_1_83 0 0.36040053260087124
Vwih_n_1_83 wih_n_1_83 0 0.6395994673991288
Vwih_p_2_83 wih_p_2_83 0 0.44307311952171347
Vwih_n_2_83 wih_n_2_83 0 0.5569268804782865
Xcm_xh83 xhp83 xhn83 vdd cmld
Rnd_xh83 xhp83 xhn83 20k
Cxh83p xhp83 0 1e-13
Cxh83n xhn83 0 1e-13
Xih_0_83 a_xp0 a_xn0 wih_p_0_83 wih_n_0_83 xhp83 xhn83 vdd vbsyn gsyn
Xih_1_83 a_xp1 a_xn1 wih_p_1_83 wih_n_1_83 xhp83 xhn83 vdd vbsyn gsyn
Xih_2_83 a_xp2 a_xn2 wih_p_2_83 wih_n_2_83 xhp83 xhn83 vdd vbsyn gsyn
Xn83 xhp83 xhn83 ahp83 ahn83 vdd vbneu dneuron
Vwih_p_0_84 wih_p_0_84 0 0.30011712379822153
Vwih_n_0_84 wih_n_0_84 0 0.6998828762017785
Vwih_p_1_84 wih_p_1_84 0 0.44767583548126255
Vwih_n_1_84 wih_n_1_84 0 0.5523241645187374
Vwih_p_2_84 wih_p_2_84 0 0.9
Vwih_n_2_84 wih_n_2_84 0 0.3
Xcm_xh84 xhp84 xhn84 vdd cmld
Rnd_xh84 xhp84 xhn84 20k
Cxh84p xhp84 0 1e-13
Cxh84n xhn84 0 1e-13
Xih_0_84 a_xp0 a_xn0 wih_p_0_84 wih_n_0_84 xhp84 xhn84 vdd vbsyn gsyn
Xih_1_84 a_xp1 a_xn1 wih_p_1_84 wih_n_1_84 xhp84 xhn84 vdd vbsyn gsyn
Xih_2_84 a_xp2 a_xn2 wih_p_2_84 wih_n_2_84 xhp84 xhn84 vdd vbsyn gsyn
Xn84 xhp84 xhn84 ahp84 ahn84 vdd vbneu dneuron
Vwih_p_0_85 wih_p_0_85 0 0.7257654182690275
Vwih_n_0_85 wih_n_0_85 0 0.3
Vwih_p_1_85 wih_p_1_85 0 0.9
Vwih_n_1_85 wih_n_1_85 0 0.3
Vwih_p_2_85 wih_p_2_85 0 0.8225705835144528
Vwih_n_2_85 wih_n_2_85 0 0.3
Xcm_xh85 xhp85 xhn85 vdd cmld
Rnd_xh85 xhp85 xhn85 20k
Cxh85p xhp85 0 1e-13
Cxh85n xhn85 0 1e-13
Xih_0_85 a_xp0 a_xn0 wih_p_0_85 wih_n_0_85 xhp85 xhn85 vdd vbsyn gsyn
Xih_1_85 a_xp1 a_xn1 wih_p_1_85 wih_n_1_85 xhp85 xhn85 vdd vbsyn gsyn
Xih_2_85 a_xp2 a_xn2 wih_p_2_85 wih_n_2_85 xhp85 xhn85 vdd vbsyn gsyn
Xn85 xhp85 xhn85 ahp85 ahn85 vdd vbneu dneuron
Vwih_p_0_86 wih_p_0_86 0 0.5835134008109902
Vwih_n_0_86 wih_n_0_86 0 0.41648659918900977
Vwih_p_1_86 wih_p_1_86 0 0.3
Vwih_n_1_86 wih_n_1_86 0 0.9
Vwih_p_2_86 wih_p_2_86 0 0.3
Vwih_n_2_86 wih_n_2_86 0 0.9
Xcm_xh86 xhp86 xhn86 vdd cmld
Rnd_xh86 xhp86 xhn86 20k
Cxh86p xhp86 0 1e-13
Cxh86n xhn86 0 1e-13
Xih_0_86 a_xp0 a_xn0 wih_p_0_86 wih_n_0_86 xhp86 xhn86 vdd vbsyn gsyn
Xih_1_86 a_xp1 a_xn1 wih_p_1_86 wih_n_1_86 xhp86 xhn86 vdd vbsyn gsyn
Xih_2_86 a_xp2 a_xn2 wih_p_2_86 wih_n_2_86 xhp86 xhn86 vdd vbsyn gsyn
Xn86 xhp86 xhn86 ahp86 ahn86 vdd vbneu dneuron
Vwih_p_0_87 wih_p_0_87 0 0.492589299728029
Vwih_n_0_87 wih_n_0_87 0 0.507410700271971
Vwih_p_1_87 wih_p_1_87 0 0.35290125877541023
Vwih_n_1_87 wih_n_1_87 0 0.6470987412245898
Vwih_p_2_87 wih_p_2_87 0 0.3
Vwih_n_2_87 wih_n_2_87 0 0.8364355150614281
Xcm_xh87 xhp87 xhn87 vdd cmld
Rnd_xh87 xhp87 xhn87 20k
Cxh87p xhp87 0 1e-13
Cxh87n xhn87 0 1e-13
Xih_0_87 a_xp0 a_xn0 wih_p_0_87 wih_n_0_87 xhp87 xhn87 vdd vbsyn gsyn
Xih_1_87 a_xp1 a_xn1 wih_p_1_87 wih_n_1_87 xhp87 xhn87 vdd vbsyn gsyn
Xih_2_87 a_xp2 a_xn2 wih_p_2_87 wih_n_2_87 xhp87 xhn87 vdd vbsyn gsyn
Xn87 xhp87 xhn87 ahp87 ahn87 vdd vbneu dneuron
Vwih_p_0_88 wih_p_0_88 0 0.6474936606619771
Vwih_n_0_88 wih_n_0_88 0 0.3525063393380229
Vwih_p_1_88 wih_p_1_88 0 0.9
Vwih_n_1_88 wih_n_1_88 0 0.3
Vwih_p_2_88 wih_p_2_88 0 0.4754885054260318
Vwih_n_2_88 wih_n_2_88 0 0.5245114945739682
Xcm_xh88 xhp88 xhn88 vdd cmld
Rnd_xh88 xhp88 xhn88 20k
Cxh88p xhp88 0 1e-13
Cxh88n xhn88 0 1e-13
Xih_0_88 a_xp0 a_xn0 wih_p_0_88 wih_n_0_88 xhp88 xhn88 vdd vbsyn gsyn
Xih_1_88 a_xp1 a_xn1 wih_p_1_88 wih_n_1_88 xhp88 xhn88 vdd vbsyn gsyn
Xih_2_88 a_xp2 a_xn2 wih_p_2_88 wih_n_2_88 xhp88 xhn88 vdd vbsyn gsyn
Xn88 xhp88 xhn88 ahp88 ahn88 vdd vbneu dneuron
Vwih_p_0_89 wih_p_0_89 0 0.5309008013267725
Vwih_n_0_89 wih_n_0_89 0 0.46909919867322747
Vwih_p_1_89 wih_p_1_89 0 0.30309264751416864
Vwih_n_1_89 wih_n_1_89 0 0.6969073524858314
Vwih_p_2_89 wih_p_2_89 0 0.3
Vwih_n_2_89 wih_n_2_89 0 0.7476587267348129
Xcm_xh89 xhp89 xhn89 vdd cmld
Rnd_xh89 xhp89 xhn89 20k
Cxh89p xhp89 0 1e-13
Cxh89n xhn89 0 1e-13
Xih_0_89 a_xp0 a_xn0 wih_p_0_89 wih_n_0_89 xhp89 xhn89 vdd vbsyn gsyn
Xih_1_89 a_xp1 a_xn1 wih_p_1_89 wih_n_1_89 xhp89 xhn89 vdd vbsyn gsyn
Xih_2_89 a_xp2 a_xn2 wih_p_2_89 wih_n_2_89 xhp89 xhn89 vdd vbsyn gsyn
Xn89 xhp89 xhn89 ahp89 ahn89 vdd vbneu dneuron
Vwih_p_0_90 wih_p_0_90 0 0.9
Vwih_n_0_90 wih_n_0_90 0 0.3
Vwih_p_1_90 wih_p_1_90 0 0.3
Vwih_n_1_90 wih_n_1_90 0 0.9
Vwih_p_2_90 wih_p_2_90 0 0.4419591204936054
Vwih_n_2_90 wih_n_2_90 0 0.5580408795063946
Xcm_xh90 xhp90 xhn90 vdd cmld
Rnd_xh90 xhp90 xhn90 20k
Cxh90p xhp90 0 1e-13
Cxh90n xhn90 0 1e-13
Xih_0_90 a_xp0 a_xn0 wih_p_0_90 wih_n_0_90 xhp90 xhn90 vdd vbsyn gsyn
Xih_1_90 a_xp1 a_xn1 wih_p_1_90 wih_n_1_90 xhp90 xhn90 vdd vbsyn gsyn
Xih_2_90 a_xp2 a_xn2 wih_p_2_90 wih_n_2_90 xhp90 xhn90 vdd vbsyn gsyn
Xn90 xhp90 xhn90 ahp90 ahn90 vdd vbneu dneuron
Vwih_p_0_91 wih_p_0_91 0 0.3390295467392971
Vwih_n_0_91 wih_n_0_91 0 0.6609704532607029
Vwih_p_1_91 wih_p_1_91 0 0.46043901163246664
Vwih_n_1_91 wih_n_1_91 0 0.5395609883675334
Vwih_p_2_91 wih_p_2_91 0 0.8766800113934548
Vwih_n_2_91 wih_n_2_91 0 0.3
Xcm_xh91 xhp91 xhn91 vdd cmld
Rnd_xh91 xhp91 xhn91 20k
Cxh91p xhp91 0 1e-13
Cxh91n xhn91 0 1e-13
Xih_0_91 a_xp0 a_xn0 wih_p_0_91 wih_n_0_91 xhp91 xhn91 vdd vbsyn gsyn
Xih_1_91 a_xp1 a_xn1 wih_p_1_91 wih_n_1_91 xhp91 xhn91 vdd vbsyn gsyn
Xih_2_91 a_xp2 a_xn2 wih_p_2_91 wih_n_2_91 xhp91 xhn91 vdd vbsyn gsyn
Xn91 xhp91 xhn91 ahp91 ahn91 vdd vbneu dneuron
Vwih_p_0_92 wih_p_0_92 0 0.8577545483053022
Vwih_n_0_92 wih_n_0_92 0 0.3
Vwih_p_1_92 wih_p_1_92 0 0.4495596808796036
Vwih_n_1_92 wih_n_1_92 0 0.5504403191203964
Vwih_p_2_92 wih_p_2_92 0 0.9
Vwih_n_2_92 wih_n_2_92 0 0.3
Xcm_xh92 xhp92 xhn92 vdd cmld
Rnd_xh92 xhp92 xhn92 20k
Cxh92p xhp92 0 1e-13
Cxh92n xhn92 0 1e-13
Xih_0_92 a_xp0 a_xn0 wih_p_0_92 wih_n_0_92 xhp92 xhn92 vdd vbsyn gsyn
Xih_1_92 a_xp1 a_xn1 wih_p_1_92 wih_n_1_92 xhp92 xhn92 vdd vbsyn gsyn
Xih_2_92 a_xp2 a_xn2 wih_p_2_92 wih_n_2_92 xhp92 xhn92 vdd vbsyn gsyn
Xn92 xhp92 xhn92 ahp92 ahn92 vdd vbneu dneuron
Vwih_p_0_93 wih_p_0_93 0 0.3
Vwih_n_0_93 wih_n_0_93 0 0.7759569820282728
Vwih_p_1_93 wih_p_1_93 0 0.6280437603935034
Vwih_n_1_93 wih_n_1_93 0 0.3719562396064966
Vwih_p_2_93 wih_p_2_93 0 0.9
Vwih_n_2_93 wih_n_2_93 0 0.3
Xcm_xh93 xhp93 xhn93 vdd cmld
Rnd_xh93 xhp93 xhn93 20k
Cxh93p xhp93 0 1e-13
Cxh93n xhn93 0 1e-13
Xih_0_93 a_xp0 a_xn0 wih_p_0_93 wih_n_0_93 xhp93 xhn93 vdd vbsyn gsyn
Xih_1_93 a_xp1 a_xn1 wih_p_1_93 wih_n_1_93 xhp93 xhn93 vdd vbsyn gsyn
Xih_2_93 a_xp2 a_xn2 wih_p_2_93 wih_n_2_93 xhp93 xhn93 vdd vbsyn gsyn
Xn93 xhp93 xhn93 ahp93 ahn93 vdd vbneu dneuron
Vwih_p_0_94 wih_p_0_94 0 0.3
Vwih_n_0_94 wih_n_0_94 0 0.7079316581509588
Vwih_p_1_94 wih_p_1_94 0 0.5738422666536547
Vwih_n_1_94 wih_n_1_94 0 0.4261577333463453
Vwih_p_2_94 wih_p_2_94 0 0.9
Vwih_n_2_94 wih_n_2_94 0 0.3
Xcm_xh94 xhp94 xhn94 vdd cmld
Rnd_xh94 xhp94 xhn94 20k
Cxh94p xhp94 0 1e-13
Cxh94n xhn94 0 1e-13
Xih_0_94 a_xp0 a_xn0 wih_p_0_94 wih_n_0_94 xhp94 xhn94 vdd vbsyn gsyn
Xih_1_94 a_xp1 a_xn1 wih_p_1_94 wih_n_1_94 xhp94 xhn94 vdd vbsyn gsyn
Xih_2_94 a_xp2 a_xn2 wih_p_2_94 wih_n_2_94 xhp94 xhn94 vdd vbsyn gsyn
Xn94 xhp94 xhn94 ahp94 ahn94 vdd vbneu dneuron
Vwih_p_0_95 wih_p_0_95 0 0.3
Vwih_n_0_95 wih_n_0_95 0 0.8032919191111256
Vwih_p_1_95 wih_p_1_95 0 0.5231570523943855
Vwih_n_1_95 wih_n_1_95 0 0.47684294760561446
Vwih_p_2_95 wih_p_2_95 0 0.38667186559616573
Vwih_n_2_95 wih_n_2_95 0 0.6133281344038343
Xcm_xh95 xhp95 xhn95 vdd cmld
Rnd_xh95 xhp95 xhn95 20k
Cxh95p xhp95 0 1e-13
Cxh95n xhn95 0 1e-13
Xih_0_95 a_xp0 a_xn0 wih_p_0_95 wih_n_0_95 xhp95 xhn95 vdd vbsyn gsyn
Xih_1_95 a_xp1 a_xn1 wih_p_1_95 wih_n_1_95 xhp95 xhn95 vdd vbsyn gsyn
Xih_2_95 a_xp2 a_xn2 wih_p_2_95 wih_n_2_95 xhp95 xhn95 vdd vbsyn gsyn
Xn95 xhp95 xhn95 ahp95 ahn95 vdd vbneu dneuron
Vwih_p_0_96 wih_p_0_96 0 0.3
Vwih_n_0_96 wih_n_0_96 0 0.9
Vwih_p_1_96 wih_p_1_96 0 0.6455339995226503
Vwih_n_1_96 wih_n_1_96 0 0.35446600047734966
Vwih_p_2_96 wih_p_2_96 0 0.3
Vwih_n_2_96 wih_n_2_96 0 0.8038864612693306
Xcm_xh96 xhp96 xhn96 vdd cmld
Rnd_xh96 xhp96 xhn96 20k
Cxh96p xhp96 0 1e-13
Cxh96n xhn96 0 1e-13
Xih_0_96 a_xp0 a_xn0 wih_p_0_96 wih_n_0_96 xhp96 xhn96 vdd vbsyn gsyn
Xih_1_96 a_xp1 a_xn1 wih_p_1_96 wih_n_1_96 xhp96 xhn96 vdd vbsyn gsyn
Xih_2_96 a_xp2 a_xn2 wih_p_2_96 wih_n_2_96 xhp96 xhn96 vdd vbsyn gsyn
Xn96 xhp96 xhn96 ahp96 ahn96 vdd vbneu dneuron
Vwih_p_0_97 wih_p_0_97 0 0.9
Vwih_n_0_97 wih_n_0_97 0 0.3
Vwih_p_1_97 wih_p_1_97 0 0.507438029005672
Vwih_n_1_97 wih_n_1_97 0 0.492561970994328
Vwih_p_2_97 wih_p_2_97 0 0.4243461639607538
Vwih_n_2_97 wih_n_2_97 0 0.5756538360392462
Xcm_xh97 xhp97 xhn97 vdd cmld
Rnd_xh97 xhp97 xhn97 20k
Cxh97p xhp97 0 1e-13
Cxh97n xhn97 0 1e-13
Xih_0_97 a_xp0 a_xn0 wih_p_0_97 wih_n_0_97 xhp97 xhn97 vdd vbsyn gsyn
Xih_1_97 a_xp1 a_xn1 wih_p_1_97 wih_n_1_97 xhp97 xhn97 vdd vbsyn gsyn
Xih_2_97 a_xp2 a_xn2 wih_p_2_97 wih_n_2_97 xhp97 xhn97 vdd vbsyn gsyn
Xn97 xhp97 xhn97 ahp97 ahn97 vdd vbneu dneuron
Vwih_p_0_98 wih_p_0_98 0 0.5147138471671748
Vwih_n_0_98 wih_n_0_98 0 0.4852861528328251
Vwih_p_1_98 wih_p_1_98 0 0.5370034573434331
Vwih_n_1_98 wih_n_1_98 0 0.46299654265656687
Vwih_p_2_98 wih_p_2_98 0 0.42827927900158275
Vwih_n_2_98 wih_n_2_98 0 0.5717207209984172
Xcm_xh98 xhp98 xhn98 vdd cmld
Rnd_xh98 xhp98 xhn98 20k
Cxh98p xhp98 0 1e-13
Cxh98n xhn98 0 1e-13
Xih_0_98 a_xp0 a_xn0 wih_p_0_98 wih_n_0_98 xhp98 xhn98 vdd vbsyn gsyn
Xih_1_98 a_xp1 a_xn1 wih_p_1_98 wih_n_1_98 xhp98 xhn98 vdd vbsyn gsyn
Xih_2_98 a_xp2 a_xn2 wih_p_2_98 wih_n_2_98 xhp98 xhn98 vdd vbsyn gsyn
Xn98 xhp98 xhn98 ahp98 ahn98 vdd vbneu dneuron
Vwih_p_0_99 wih_p_0_99 0 0.520602266975014
Vwih_n_0_99 wih_n_0_99 0 0.47939773302498595
Vwih_p_1_99 wih_p_1_99 0 0.3
Vwih_n_1_99 wih_n_1_99 0 0.7069321613723347
Vwih_p_2_99 wih_p_2_99 0 0.32020177970723285
Vwih_n_2_99 wih_n_2_99 0 0.6797982202927672
Xcm_xh99 xhp99 xhn99 vdd cmld
Rnd_xh99 xhp99 xhn99 20k
Cxh99p xhp99 0 1e-13
Cxh99n xhn99 0 1e-13
Xih_0_99 a_xp0 a_xn0 wih_p_0_99 wih_n_0_99 xhp99 xhn99 vdd vbsyn gsyn
Xih_1_99 a_xp1 a_xn1 wih_p_1_99 wih_n_1_99 xhp99 xhn99 vdd vbsyn gsyn
Xih_2_99 a_xp2 a_xn2 wih_p_2_99 wih_n_2_99 xhp99 xhn99 vdd vbsyn gsyn
Xn99 xhp99 xhn99 ahp99 ahn99 vdd vbneu dneuron
Vwih_p_0_100 wih_p_0_100 0 0.6897356632887359
Vwih_n_0_100 wih_n_0_100 0 0.3102643367112641
Vwih_p_1_100 wih_p_1_100 0 0.3
Vwih_n_1_100 wih_n_1_100 0 0.9
Vwih_p_2_100 wih_p_2_100 0 0.3
Vwih_n_2_100 wih_n_2_100 0 0.7878139515362967
Xcm_xh100 xhp100 xhn100 vdd cmld
Rnd_xh100 xhp100 xhn100 20k
Cxh100p xhp100 0 1e-13
Cxh100n xhn100 0 1e-13
Xih_0_100 a_xp0 a_xn0 wih_p_0_100 wih_n_0_100 xhp100 xhn100 vdd vbsyn gsyn
Xih_1_100 a_xp1 a_xn1 wih_p_1_100 wih_n_1_100 xhp100 xhn100 vdd vbsyn gsyn
Xih_2_100 a_xp2 a_xn2 wih_p_2_100 wih_n_2_100 xhp100 xhn100 vdd vbsyn gsyn
Xn100 xhp100 xhn100 ahp100 ahn100 vdd vbneu dneuron
Vwih_p_0_101 wih_p_0_101 0 0.5030798736600309
Vwih_n_0_101 wih_n_0_101 0 0.4969201263399691
Vwih_p_1_101 wih_p_1_101 0 0.6232569638660875
Vwih_n_1_101 wih_n_1_101 0 0.3767430361339124
Vwih_p_2_101 wih_p_2_101 0 0.3594050643601497
Vwih_n_2_101 wih_n_2_101 0 0.6405949356398504
Xcm_xh101 xhp101 xhn101 vdd cmld
Rnd_xh101 xhp101 xhn101 20k
Cxh101p xhp101 0 1e-13
Cxh101n xhn101 0 1e-13
Xih_0_101 a_xp0 a_xn0 wih_p_0_101 wih_n_0_101 xhp101 xhn101 vdd vbsyn gsyn
Xih_1_101 a_xp1 a_xn1 wih_p_1_101 wih_n_1_101 xhp101 xhn101 vdd vbsyn gsyn
Xih_2_101 a_xp2 a_xn2 wih_p_2_101 wih_n_2_101 xhp101 xhn101 vdd vbsyn gsyn
Xn101 xhp101 xhn101 ahp101 ahn101 vdd vbneu dneuron
Vwih_p_0_102 wih_p_0_102 0 0.549040655664119
Vwih_n_0_102 wih_n_0_102 0 0.45095934433588103
Vwih_p_1_102 wih_p_1_102 0 0.37419270817769335
Vwih_n_1_102 wih_n_1_102 0 0.6258072918223067
Vwih_p_2_102 wih_p_2_102 0 0.3
Vwih_n_2_102 wih_n_2_102 0 0.9
Xcm_xh102 xhp102 xhn102 vdd cmld
Rnd_xh102 xhp102 xhn102 20k
Cxh102p xhp102 0 1e-13
Cxh102n xhn102 0 1e-13
Xih_0_102 a_xp0 a_xn0 wih_p_0_102 wih_n_0_102 xhp102 xhn102 vdd vbsyn gsyn
Xih_1_102 a_xp1 a_xn1 wih_p_1_102 wih_n_1_102 xhp102 xhn102 vdd vbsyn gsyn
Xih_2_102 a_xp2 a_xn2 wih_p_2_102 wih_n_2_102 xhp102 xhn102 vdd vbsyn gsyn
Xn102 xhp102 xhn102 ahp102 ahn102 vdd vbneu dneuron
Vwih_p_0_103 wih_p_0_103 0 0.8385695052304043
Vwih_n_0_103 wih_n_0_103 0 0.3
Vwih_p_1_103 wih_p_1_103 0 0.5964785585258754
Vwih_n_1_103 wih_n_1_103 0 0.40352144147412455
Vwih_p_2_103 wih_p_2_103 0 0.3
Vwih_n_2_103 wih_n_2_103 0 0.8446485279626963
Xcm_xh103 xhp103 xhn103 vdd cmld
Rnd_xh103 xhp103 xhn103 20k
Cxh103p xhp103 0 1e-13
Cxh103n xhn103 0 1e-13
Xih_0_103 a_xp0 a_xn0 wih_p_0_103 wih_n_0_103 xhp103 xhn103 vdd vbsyn gsyn
Xih_1_103 a_xp1 a_xn1 wih_p_1_103 wih_n_1_103 xhp103 xhn103 vdd vbsyn gsyn
Xih_2_103 a_xp2 a_xn2 wih_p_2_103 wih_n_2_103 xhp103 xhn103 vdd vbsyn gsyn
Xn103 xhp103 xhn103 ahp103 ahn103 vdd vbneu dneuron
Vwih_p_0_104 wih_p_0_104 0 0.9
Vwih_n_0_104 wih_n_0_104 0 0.3
Vwih_p_1_104 wih_p_1_104 0 0.7438980173249841
Vwih_n_1_104 wih_n_1_104 0 0.3
Vwih_p_2_104 wih_p_2_104 0 0.3
Vwih_n_2_104 wih_n_2_104 0 0.7251816066034233
Xcm_xh104 xhp104 xhn104 vdd cmld
Rnd_xh104 xhp104 xhn104 20k
Cxh104p xhp104 0 1e-13
Cxh104n xhn104 0 1e-13
Xih_0_104 a_xp0 a_xn0 wih_p_0_104 wih_n_0_104 xhp104 xhn104 vdd vbsyn gsyn
Xih_1_104 a_xp1 a_xn1 wih_p_1_104 wih_n_1_104 xhp104 xhn104 vdd vbsyn gsyn
Xih_2_104 a_xp2 a_xn2 wih_p_2_104 wih_n_2_104 xhp104 xhn104 vdd vbsyn gsyn
Xn104 xhp104 xhn104 ahp104 ahn104 vdd vbneu dneuron
Vwih_p_0_105 wih_p_0_105 0 0.8983640229839369
Vwih_n_0_105 wih_n_0_105 0 0.3
Vwih_p_1_105 wih_p_1_105 0 0.6940500188062954
Vwih_n_1_105 wih_n_1_105 0 0.30594998119370465
Vwih_p_2_105 wih_p_2_105 0 0.7983949180632306
Vwih_n_2_105 wih_n_2_105 0 0.3
Xcm_xh105 xhp105 xhn105 vdd cmld
Rnd_xh105 xhp105 xhn105 20k
Cxh105p xhp105 0 1e-13
Cxh105n xhn105 0 1e-13
Xih_0_105 a_xp0 a_xn0 wih_p_0_105 wih_n_0_105 xhp105 xhn105 vdd vbsyn gsyn
Xih_1_105 a_xp1 a_xn1 wih_p_1_105 wih_n_1_105 xhp105 xhn105 vdd vbsyn gsyn
Xih_2_105 a_xp2 a_xn2 wih_p_2_105 wih_n_2_105 xhp105 xhn105 vdd vbsyn gsyn
Xn105 xhp105 xhn105 ahp105 ahn105 vdd vbneu dneuron
Vwih_p_0_106 wih_p_0_106 0 0.3
Vwih_n_0_106 wih_n_0_106 0 0.7166457511145623
Vwih_p_1_106 wih_p_1_106 0 0.3
Vwih_n_1_106 wih_n_1_106 0 0.7003880553366788
Vwih_p_2_106 wih_p_2_106 0 0.3
Vwih_n_2_106 wih_n_2_106 0 0.7960870942686714
Xcm_xh106 xhp106 xhn106 vdd cmld
Rnd_xh106 xhp106 xhn106 20k
Cxh106p xhp106 0 1e-13
Cxh106n xhn106 0 1e-13
Xih_0_106 a_xp0 a_xn0 wih_p_0_106 wih_n_0_106 xhp106 xhn106 vdd vbsyn gsyn
Xih_1_106 a_xp1 a_xn1 wih_p_1_106 wih_n_1_106 xhp106 xhn106 vdd vbsyn gsyn
Xih_2_106 a_xp2 a_xn2 wih_p_2_106 wih_n_2_106 xhp106 xhn106 vdd vbsyn gsyn
Xn106 xhp106 xhn106 ahp106 ahn106 vdd vbneu dneuron
Vwih_p_0_107 wih_p_0_107 0 0.30521894898673485
Vwih_n_0_107 wih_n_0_107 0 0.6947810510132651
Vwih_p_1_107 wih_p_1_107 0 0.3
Vwih_n_1_107 wih_n_1_107 0 0.9
Vwih_p_2_107 wih_p_2_107 0 0.8901557860011247
Vwih_n_2_107 wih_n_2_107 0 0.3
Xcm_xh107 xhp107 xhn107 vdd cmld
Rnd_xh107 xhp107 xhn107 20k
Cxh107p xhp107 0 1e-13
Cxh107n xhn107 0 1e-13
Xih_0_107 a_xp0 a_xn0 wih_p_0_107 wih_n_0_107 xhp107 xhn107 vdd vbsyn gsyn
Xih_1_107 a_xp1 a_xn1 wih_p_1_107 wih_n_1_107 xhp107 xhn107 vdd vbsyn gsyn
Xih_2_107 a_xp2 a_xn2 wih_p_2_107 wih_n_2_107 xhp107 xhn107 vdd vbsyn gsyn
Xn107 xhp107 xhn107 ahp107 ahn107 vdd vbneu dneuron
Vwih_p_0_108 wih_p_0_108 0 0.3
Vwih_n_0_108 wih_n_0_108 0 0.9
Vwih_p_1_108 wih_p_1_108 0 0.7050964619445987
Vwih_n_1_108 wih_n_1_108 0 0.3
Vwih_p_2_108 wih_p_2_108 0 0.3
Vwih_n_2_108 wih_n_2_108 0 0.9
Xcm_xh108 xhp108 xhn108 vdd cmld
Rnd_xh108 xhp108 xhn108 20k
Cxh108p xhp108 0 1e-13
Cxh108n xhn108 0 1e-13
Xih_0_108 a_xp0 a_xn0 wih_p_0_108 wih_n_0_108 xhp108 xhn108 vdd vbsyn gsyn
Xih_1_108 a_xp1 a_xn1 wih_p_1_108 wih_n_1_108 xhp108 xhn108 vdd vbsyn gsyn
Xih_2_108 a_xp2 a_xn2 wih_p_2_108 wih_n_2_108 xhp108 xhn108 vdd vbsyn gsyn
Xn108 xhp108 xhn108 ahp108 ahn108 vdd vbneu dneuron
Vwih_p_0_109 wih_p_0_109 0 0.5420504537676425
Vwih_n_0_109 wih_n_0_109 0 0.45794954623235756
Vwih_p_1_109 wih_p_1_109 0 0.3
Vwih_n_1_109 wih_n_1_109 0 0.9
Vwih_p_2_109 wih_p_2_109 0 0.4928435667411274
Vwih_n_2_109 wih_n_2_109 0 0.5071564332588726
Xcm_xh109 xhp109 xhn109 vdd cmld
Rnd_xh109 xhp109 xhn109 20k
Cxh109p xhp109 0 1e-13
Cxh109n xhn109 0 1e-13
Xih_0_109 a_xp0 a_xn0 wih_p_0_109 wih_n_0_109 xhp109 xhn109 vdd vbsyn gsyn
Xih_1_109 a_xp1 a_xn1 wih_p_1_109 wih_n_1_109 xhp109 xhn109 vdd vbsyn gsyn
Xih_2_109 a_xp2 a_xn2 wih_p_2_109 wih_n_2_109 xhp109 xhn109 vdd vbsyn gsyn
Xn109 xhp109 xhn109 ahp109 ahn109 vdd vbneu dneuron
Vwih_p_0_110 wih_p_0_110 0 0.3
Vwih_n_0_110 wih_n_0_110 0 0.9
Vwih_p_1_110 wih_p_1_110 0 0.3
Vwih_n_1_110 wih_n_1_110 0 0.7130915798976784
Vwih_p_2_110 wih_p_2_110 0 0.7374706672427678
Vwih_n_2_110 wih_n_2_110 0 0.3
Xcm_xh110 xhp110 xhn110 vdd cmld
Rnd_xh110 xhp110 xhn110 20k
Cxh110p xhp110 0 1e-13
Cxh110n xhn110 0 1e-13
Xih_0_110 a_xp0 a_xn0 wih_p_0_110 wih_n_0_110 xhp110 xhn110 vdd vbsyn gsyn
Xih_1_110 a_xp1 a_xn1 wih_p_1_110 wih_n_1_110 xhp110 xhn110 vdd vbsyn gsyn
Xih_2_110 a_xp2 a_xn2 wih_p_2_110 wih_n_2_110 xhp110 xhn110 vdd vbsyn gsyn
Xn110 xhp110 xhn110 ahp110 ahn110 vdd vbneu dneuron
Vwih_p_0_111 wih_p_0_111 0 0.5770026421173775
Vwih_n_0_111 wih_n_0_111 0 0.4229973578826225
Vwih_p_1_111 wih_p_1_111 0 0.5615765253595616
Vwih_n_1_111 wih_n_1_111 0 0.43842347464043846
Vwih_p_2_111 wih_p_2_111 0 0.3
Vwih_n_2_111 wih_n_2_111 0 0.8090369339740895
Xcm_xh111 xhp111 xhn111 vdd cmld
Rnd_xh111 xhp111 xhn111 20k
Cxh111p xhp111 0 1e-13
Cxh111n xhn111 0 1e-13
Xih_0_111 a_xp0 a_xn0 wih_p_0_111 wih_n_0_111 xhp111 xhn111 vdd vbsyn gsyn
Xih_1_111 a_xp1 a_xn1 wih_p_1_111 wih_n_1_111 xhp111 xhn111 vdd vbsyn gsyn
Xih_2_111 a_xp2 a_xn2 wih_p_2_111 wih_n_2_111 xhp111 xhn111 vdd vbsyn gsyn
Xn111 xhp111 xhn111 ahp111 ahn111 vdd vbneu dneuron
Vwih_p_0_112 wih_p_0_112 0 0.3
Vwih_n_0_112 wih_n_0_112 0 0.9
Vwih_p_1_112 wih_p_1_112 0 0.3
Vwih_n_1_112 wih_n_1_112 0 0.8214892707070406
Vwih_p_2_112 wih_p_2_112 0 0.31605772977313384
Vwih_n_2_112 wih_n_2_112 0 0.6839422702268662
Xcm_xh112 xhp112 xhn112 vdd cmld
Rnd_xh112 xhp112 xhn112 20k
Cxh112p xhp112 0 1e-13
Cxh112n xhn112 0 1e-13
Xih_0_112 a_xp0 a_xn0 wih_p_0_112 wih_n_0_112 xhp112 xhn112 vdd vbsyn gsyn
Xih_1_112 a_xp1 a_xn1 wih_p_1_112 wih_n_1_112 xhp112 xhn112 vdd vbsyn gsyn
Xih_2_112 a_xp2 a_xn2 wih_p_2_112 wih_n_2_112 xhp112 xhn112 vdd vbsyn gsyn
Xn112 xhp112 xhn112 ahp112 ahn112 vdd vbneu dneuron
Vwih_p_0_113 wih_p_0_113 0 0.9
Vwih_n_0_113 wih_n_0_113 0 0.3
Vwih_p_1_113 wih_p_1_113 0 0.7050286057240855
Vwih_n_1_113 wih_n_1_113 0 0.3
Vwih_p_2_113 wih_p_2_113 0 0.6139264519215271
Vwih_n_2_113 wih_n_2_113 0 0.38607354807847294
Xcm_xh113 xhp113 xhn113 vdd cmld
Rnd_xh113 xhp113 xhn113 20k
Cxh113p xhp113 0 1e-13
Cxh113n xhn113 0 1e-13
Xih_0_113 a_xp0 a_xn0 wih_p_0_113 wih_n_0_113 xhp113 xhn113 vdd vbsyn gsyn
Xih_1_113 a_xp1 a_xn1 wih_p_1_113 wih_n_1_113 xhp113 xhn113 vdd vbsyn gsyn
Xih_2_113 a_xp2 a_xn2 wih_p_2_113 wih_n_2_113 xhp113 xhn113 vdd vbsyn gsyn
Xn113 xhp113 xhn113 ahp113 ahn113 vdd vbneu dneuron
Vwih_p_0_114 wih_p_0_114 0 0.3
Vwih_n_0_114 wih_n_0_114 0 0.7094708183673882
Vwih_p_1_114 wih_p_1_114 0 0.3
Vwih_n_1_114 wih_n_1_114 0 0.7625334393357461
Vwih_p_2_114 wih_p_2_114 0 0.7306238305375611
Vwih_n_2_114 wih_n_2_114 0 0.3
Xcm_xh114 xhp114 xhn114 vdd cmld
Rnd_xh114 xhp114 xhn114 20k
Cxh114p xhp114 0 1e-13
Cxh114n xhn114 0 1e-13
Xih_0_114 a_xp0 a_xn0 wih_p_0_114 wih_n_0_114 xhp114 xhn114 vdd vbsyn gsyn
Xih_1_114 a_xp1 a_xn1 wih_p_1_114 wih_n_1_114 xhp114 xhn114 vdd vbsyn gsyn
Xih_2_114 a_xp2 a_xn2 wih_p_2_114 wih_n_2_114 xhp114 xhn114 vdd vbsyn gsyn
Xn114 xhp114 xhn114 ahp114 ahn114 vdd vbneu dneuron
Vwih_p_0_115 wih_p_0_115 0 0.36606155074954466
Vwih_n_0_115 wih_n_0_115 0 0.6339384492504554
Vwih_p_1_115 wih_p_1_115 0 0.37871799223366365
Vwih_n_1_115 wih_n_1_115 0 0.6212820077663364
Vwih_p_2_115 wih_p_2_115 0 0.9
Vwih_n_2_115 wih_n_2_115 0 0.3
Xcm_xh115 xhp115 xhn115 vdd cmld
Rnd_xh115 xhp115 xhn115 20k
Cxh115p xhp115 0 1e-13
Cxh115n xhn115 0 1e-13
Xih_0_115 a_xp0 a_xn0 wih_p_0_115 wih_n_0_115 xhp115 xhn115 vdd vbsyn gsyn
Xih_1_115 a_xp1 a_xn1 wih_p_1_115 wih_n_1_115 xhp115 xhn115 vdd vbsyn gsyn
Xih_2_115 a_xp2 a_xn2 wih_p_2_115 wih_n_2_115 xhp115 xhn115 vdd vbsyn gsyn
Xn115 xhp115 xhn115 ahp115 ahn115 vdd vbneu dneuron
Vwih_p_0_116 wih_p_0_116 0 0.3
Vwih_n_0_116 wih_n_0_116 0 0.8534549707070831
Vwih_p_1_116 wih_p_1_116 0 0.3986219446094254
Vwih_n_1_116 wih_n_1_116 0 0.6013780553905747
Vwih_p_2_116 wih_p_2_116 0 0.41011161673437846
Vwih_n_2_116 wih_n_2_116 0 0.5898883832656215
Xcm_xh116 xhp116 xhn116 vdd cmld
Rnd_xh116 xhp116 xhn116 20k
Cxh116p xhp116 0 1e-13
Cxh116n xhn116 0 1e-13
Xih_0_116 a_xp0 a_xn0 wih_p_0_116 wih_n_0_116 xhp116 xhn116 vdd vbsyn gsyn
Xih_1_116 a_xp1 a_xn1 wih_p_1_116 wih_n_1_116 xhp116 xhn116 vdd vbsyn gsyn
Xih_2_116 a_xp2 a_xn2 wih_p_2_116 wih_n_2_116 xhp116 xhn116 vdd vbsyn gsyn
Xn116 xhp116 xhn116 ahp116 ahn116 vdd vbneu dneuron
Vwih_p_0_117 wih_p_0_117 0 0.3
Vwih_n_0_117 wih_n_0_117 0 0.7344799210883389
Vwih_p_1_117 wih_p_1_117 0 0.3
Vwih_n_1_117 wih_n_1_117 0 0.9
Vwih_p_2_117 wih_p_2_117 0 0.9
Vwih_n_2_117 wih_n_2_117 0 0.3
Xcm_xh117 xhp117 xhn117 vdd cmld
Rnd_xh117 xhp117 xhn117 20k
Cxh117p xhp117 0 1e-13
Cxh117n xhn117 0 1e-13
Xih_0_117 a_xp0 a_xn0 wih_p_0_117 wih_n_0_117 xhp117 xhn117 vdd vbsyn gsyn
Xih_1_117 a_xp1 a_xn1 wih_p_1_117 wih_n_1_117 xhp117 xhn117 vdd vbsyn gsyn
Xih_2_117 a_xp2 a_xn2 wih_p_2_117 wih_n_2_117 xhp117 xhn117 vdd vbsyn gsyn
Xn117 xhp117 xhn117 ahp117 ahn117 vdd vbneu dneuron
Vwih_p_0_118 wih_p_0_118 0 0.3
Vwih_n_0_118 wih_n_0_118 0 0.9
Vwih_p_1_118 wih_p_1_118 0 0.3
Vwih_n_1_118 wih_n_1_118 0 0.8267411801136051
Vwih_p_2_118 wih_p_2_118 0 0.5922554801661133
Vwih_n_2_118 wih_n_2_118 0 0.40774451983388676
Xcm_xh118 xhp118 xhn118 vdd cmld
Rnd_xh118 xhp118 xhn118 20k
Cxh118p xhp118 0 1e-13
Cxh118n xhn118 0 1e-13
Xih_0_118 a_xp0 a_xn0 wih_p_0_118 wih_n_0_118 xhp118 xhn118 vdd vbsyn gsyn
Xih_1_118 a_xp1 a_xn1 wih_p_1_118 wih_n_1_118 xhp118 xhn118 vdd vbsyn gsyn
Xih_2_118 a_xp2 a_xn2 wih_p_2_118 wih_n_2_118 xhp118 xhn118 vdd vbsyn gsyn
Xn118 xhp118 xhn118 ahp118 ahn118 vdd vbneu dneuron
Vwih_p_0_119 wih_p_0_119 0 0.3
Vwih_n_0_119 wih_n_0_119 0 0.9
Vwih_p_1_119 wih_p_1_119 0 0.443912089399497
Vwih_n_1_119 wih_n_1_119 0 0.556087910600503
Vwih_p_2_119 wih_p_2_119 0 0.4076257805047627
Vwih_n_2_119 wih_n_2_119 0 0.5923742194952373
Xcm_xh119 xhp119 xhn119 vdd cmld
Rnd_xh119 xhp119 xhn119 20k
Cxh119p xhp119 0 1e-13
Cxh119n xhn119 0 1e-13
Xih_0_119 a_xp0 a_xn0 wih_p_0_119 wih_n_0_119 xhp119 xhn119 vdd vbsyn gsyn
Xih_1_119 a_xp1 a_xn1 wih_p_1_119 wih_n_1_119 xhp119 xhn119 vdd vbsyn gsyn
Xih_2_119 a_xp2 a_xn2 wih_p_2_119 wih_n_2_119 xhp119 xhn119 vdd vbsyn gsyn
Xn119 xhp119 xhn119 ahp119 ahn119 vdd vbneu dneuron
Vwih_p_0_120 wih_p_0_120 0 0.41476998360707
Vwih_n_0_120 wih_n_0_120 0 0.58523001639293
Vwih_p_1_120 wih_p_1_120 0 0.44957598036055946
Vwih_n_1_120 wih_n_1_120 0 0.5504240196394405
Vwih_p_2_120 wih_p_2_120 0 0.3
Vwih_n_2_120 wih_n_2_120 0 0.9
Xcm_xh120 xhp120 xhn120 vdd cmld
Rnd_xh120 xhp120 xhn120 20k
Cxh120p xhp120 0 1e-13
Cxh120n xhn120 0 1e-13
Xih_0_120 a_xp0 a_xn0 wih_p_0_120 wih_n_0_120 xhp120 xhn120 vdd vbsyn gsyn
Xih_1_120 a_xp1 a_xn1 wih_p_1_120 wih_n_1_120 xhp120 xhn120 vdd vbsyn gsyn
Xih_2_120 a_xp2 a_xn2 wih_p_2_120 wih_n_2_120 xhp120 xhn120 vdd vbsyn gsyn
Xn120 xhp120 xhn120 ahp120 ahn120 vdd vbneu dneuron
Vwih_p_0_121 wih_p_0_121 0 0.3021789217303894
Vwih_n_0_121 wih_n_0_121 0 0.6978210782696106
Vwih_p_1_121 wih_p_1_121 0 0.9
Vwih_n_1_121 wih_n_1_121 0 0.3
Vwih_p_2_121 wih_p_2_121 0 0.9
Vwih_n_2_121 wih_n_2_121 0 0.3
Xcm_xh121 xhp121 xhn121 vdd cmld
Rnd_xh121 xhp121 xhn121 20k
Cxh121p xhp121 0 1e-13
Cxh121n xhn121 0 1e-13
Xih_0_121 a_xp0 a_xn0 wih_p_0_121 wih_n_0_121 xhp121 xhn121 vdd vbsyn gsyn
Xih_1_121 a_xp1 a_xn1 wih_p_1_121 wih_n_1_121 xhp121 xhn121 vdd vbsyn gsyn
Xih_2_121 a_xp2 a_xn2 wih_p_2_121 wih_n_2_121 xhp121 xhn121 vdd vbsyn gsyn
Xn121 xhp121 xhn121 ahp121 ahn121 vdd vbneu dneuron
Vwih_p_0_122 wih_p_0_122 0 0.3
Vwih_n_0_122 wih_n_0_122 0 0.709080252996829
Vwih_p_1_122 wih_p_1_122 0 0.8905625080451892
Vwih_n_1_122 wih_n_1_122 0 0.3
Vwih_p_2_122 wih_p_2_122 0 0.3
Vwih_n_2_122 wih_n_2_122 0 0.838351469546524
Xcm_xh122 xhp122 xhn122 vdd cmld
Rnd_xh122 xhp122 xhn122 20k
Cxh122p xhp122 0 1e-13
Cxh122n xhn122 0 1e-13
Xih_0_122 a_xp0 a_xn0 wih_p_0_122 wih_n_0_122 xhp122 xhn122 vdd vbsyn gsyn
Xih_1_122 a_xp1 a_xn1 wih_p_1_122 wih_n_1_122 xhp122 xhn122 vdd vbsyn gsyn
Xih_2_122 a_xp2 a_xn2 wih_p_2_122 wih_n_2_122 xhp122 xhn122 vdd vbsyn gsyn
Xn122 xhp122 xhn122 ahp122 ahn122 vdd vbneu dneuron
Vwih_p_0_123 wih_p_0_123 0 0.3
Vwih_n_0_123 wih_n_0_123 0 0.9
Vwih_p_1_123 wih_p_1_123 0 0.3
Vwih_n_1_123 wih_n_1_123 0 0.9
Vwih_p_2_123 wih_p_2_123 0 0.3
Vwih_n_2_123 wih_n_2_123 0 0.9
Xcm_xh123 xhp123 xhn123 vdd cmld
Rnd_xh123 xhp123 xhn123 20k
Cxh123p xhp123 0 1e-13
Cxh123n xhn123 0 1e-13
Xih_0_123 a_xp0 a_xn0 wih_p_0_123 wih_n_0_123 xhp123 xhn123 vdd vbsyn gsyn
Xih_1_123 a_xp1 a_xn1 wih_p_1_123 wih_n_1_123 xhp123 xhn123 vdd vbsyn gsyn
Xih_2_123 a_xp2 a_xn2 wih_p_2_123 wih_n_2_123 xhp123 xhn123 vdd vbsyn gsyn
Xn123 xhp123 xhn123 ahp123 ahn123 vdd vbneu dneuron
Vwih_p_0_124 wih_p_0_124 0 0.6655559565905101
Vwih_n_0_124 wih_n_0_124 0 0.33444404340948986
Vwih_p_1_124 wih_p_1_124 0 0.38280274508848866
Vwih_n_1_124 wih_n_1_124 0 0.6171972549115113
Vwih_p_2_124 wih_p_2_124 0 0.9
Vwih_n_2_124 wih_n_2_124 0 0.3
Xcm_xh124 xhp124 xhn124 vdd cmld
Rnd_xh124 xhp124 xhn124 20k
Cxh124p xhp124 0 1e-13
Cxh124n xhn124 0 1e-13
Xih_0_124 a_xp0 a_xn0 wih_p_0_124 wih_n_0_124 xhp124 xhn124 vdd vbsyn gsyn
Xih_1_124 a_xp1 a_xn1 wih_p_1_124 wih_n_1_124 xhp124 xhn124 vdd vbsyn gsyn
Xih_2_124 a_xp2 a_xn2 wih_p_2_124 wih_n_2_124 xhp124 xhn124 vdd vbsyn gsyn
Xn124 xhp124 xhn124 ahp124 ahn124 vdd vbneu dneuron
Vwih_p_0_125 wih_p_0_125 0 0.8021970978923891
Vwih_n_0_125 wih_n_0_125 0 0.3
Vwih_p_1_125 wih_p_1_125 0 0.37248269755464347
Vwih_n_1_125 wih_n_1_125 0 0.6275173024453565
Vwih_p_2_125 wih_p_2_125 0 0.4196190019712146
Vwih_n_2_125 wih_n_2_125 0 0.5803809980287854
Xcm_xh125 xhp125 xhn125 vdd cmld
Rnd_xh125 xhp125 xhn125 20k
Cxh125p xhp125 0 1e-13
Cxh125n xhn125 0 1e-13
Xih_0_125 a_xp0 a_xn0 wih_p_0_125 wih_n_0_125 xhp125 xhn125 vdd vbsyn gsyn
Xih_1_125 a_xp1 a_xn1 wih_p_1_125 wih_n_1_125 xhp125 xhn125 vdd vbsyn gsyn
Xih_2_125 a_xp2 a_xn2 wih_p_2_125 wih_n_2_125 xhp125 xhn125 vdd vbsyn gsyn
Xn125 xhp125 xhn125 ahp125 ahn125 vdd vbneu dneuron
Vwih_p_0_126 wih_p_0_126 0 0.4222717669783713
Vwih_n_0_126 wih_n_0_126 0 0.5777282330216287
Vwih_p_1_126 wih_p_1_126 0 0.8596781245666474
Vwih_n_1_126 wih_n_1_126 0 0.3
Vwih_p_2_126 wih_p_2_126 0 0.3616916557062759
Vwih_n_2_126 wih_n_2_126 0 0.6383083442937241
Xcm_xh126 xhp126 xhn126 vdd cmld
Rnd_xh126 xhp126 xhn126 20k
Cxh126p xhp126 0 1e-13
Cxh126n xhn126 0 1e-13
Xih_0_126 a_xp0 a_xn0 wih_p_0_126 wih_n_0_126 xhp126 xhn126 vdd vbsyn gsyn
Xih_1_126 a_xp1 a_xn1 wih_p_1_126 wih_n_1_126 xhp126 xhn126 vdd vbsyn gsyn
Xih_2_126 a_xp2 a_xn2 wih_p_2_126 wih_n_2_126 xhp126 xhn126 vdd vbsyn gsyn
Xn126 xhp126 xhn126 ahp126 ahn126 vdd vbneu dneuron
Vwih_p_0_127 wih_p_0_127 0 0.49477923170130933
Vwih_n_0_127 wih_n_0_127 0 0.5052207682986907
Vwih_p_1_127 wih_p_1_127 0 0.3
Vwih_n_1_127 wih_n_1_127 0 0.7647599481717704
Vwih_p_2_127 wih_p_2_127 0 0.9
Vwih_n_2_127 wih_n_2_127 0 0.3
Xcm_xh127 xhp127 xhn127 vdd cmld
Rnd_xh127 xhp127 xhn127 20k
Cxh127p xhp127 0 1e-13
Cxh127n xhn127 0 1e-13
Xih_0_127 a_xp0 a_xn0 wih_p_0_127 wih_n_0_127 xhp127 xhn127 vdd vbsyn gsyn
Xih_1_127 a_xp1 a_xn1 wih_p_1_127 wih_n_1_127 xhp127 xhn127 vdd vbsyn gsyn
Xih_2_127 a_xp2 a_xn2 wih_p_2_127 wih_n_2_127 xhp127 xhn127 vdd vbsyn gsyn
Xn127 xhp127 xhn127 ahp127 ahn127 vdd vbneu dneuron
Vwih_p_0_128 wih_p_0_128 0 0.37432031287602385
Vwih_n_0_128 wih_n_0_128 0 0.6256796871239761
Vwih_p_1_128 wih_p_1_128 0 0.3
Vwih_n_1_128 wih_n_1_128 0 0.7328467724540786
Vwih_p_2_128 wih_p_2_128 0 0.3
Vwih_n_2_128 wih_n_2_128 0 0.9
Xcm_xh128 xhp128 xhn128 vdd cmld
Rnd_xh128 xhp128 xhn128 20k
Cxh128p xhp128 0 1e-13
Cxh128n xhn128 0 1e-13
Xih_0_128 a_xp0 a_xn0 wih_p_0_128 wih_n_0_128 xhp128 xhn128 vdd vbsyn gsyn
Xih_1_128 a_xp1 a_xn1 wih_p_1_128 wih_n_1_128 xhp128 xhn128 vdd vbsyn gsyn
Xih_2_128 a_xp2 a_xn2 wih_p_2_128 wih_n_2_128 xhp128 xhn128 vdd vbsyn gsyn
Xn128 xhp128 xhn128 ahp128 ahn128 vdd vbneu dneuron
Vwih_p_0_129 wih_p_0_129 0 0.8478490888425874
Vwih_n_0_129 wih_n_0_129 0 0.3
Vwih_p_1_129 wih_p_1_129 0 0.3
Vwih_n_1_129 wih_n_1_129 0 0.7130128777314562
Vwih_p_2_129 wih_p_2_129 0 0.47466023286695336
Vwih_n_2_129 wih_n_2_129 0 0.5253397671330466
Xcm_xh129 xhp129 xhn129 vdd cmld
Rnd_xh129 xhp129 xhn129 20k
Cxh129p xhp129 0 1e-13
Cxh129n xhn129 0 1e-13
Xih_0_129 a_xp0 a_xn0 wih_p_0_129 wih_n_0_129 xhp129 xhn129 vdd vbsyn gsyn
Xih_1_129 a_xp1 a_xn1 wih_p_1_129 wih_n_1_129 xhp129 xhn129 vdd vbsyn gsyn
Xih_2_129 a_xp2 a_xn2 wih_p_2_129 wih_n_2_129 xhp129 xhn129 vdd vbsyn gsyn
Xn129 xhp129 xhn129 ahp129 ahn129 vdd vbneu dneuron
Vwih_p_0_130 wih_p_0_130 0 0.3522391809130101
Vwih_n_0_130 wih_n_0_130 0 0.6477608190869899
Vwih_p_1_130 wih_p_1_130 0 0.43285341599220273
Vwih_n_1_130 wih_n_1_130 0 0.5671465840077973
Vwih_p_2_130 wih_p_2_130 0 0.3
Vwih_n_2_130 wih_n_2_130 0 0.9
Xcm_xh130 xhp130 xhn130 vdd cmld
Rnd_xh130 xhp130 xhn130 20k
Cxh130p xhp130 0 1e-13
Cxh130n xhn130 0 1e-13
Xih_0_130 a_xp0 a_xn0 wih_p_0_130 wih_n_0_130 xhp130 xhn130 vdd vbsyn gsyn
Xih_1_130 a_xp1 a_xn1 wih_p_1_130 wih_n_1_130 xhp130 xhn130 vdd vbsyn gsyn
Xih_2_130 a_xp2 a_xn2 wih_p_2_130 wih_n_2_130 xhp130 xhn130 vdd vbsyn gsyn
Xn130 xhp130 xhn130 ahp130 ahn130 vdd vbneu dneuron
Vwih_p_0_131 wih_p_0_131 0 0.3
Vwih_n_0_131 wih_n_0_131 0 0.7824485020113101
Vwih_p_1_131 wih_p_1_131 0 0.3
Vwih_n_1_131 wih_n_1_131 0 0.8901001187810118
Vwih_p_2_131 wih_p_2_131 0 0.9
Vwih_n_2_131 wih_n_2_131 0 0.3
Xcm_xh131 xhp131 xhn131 vdd cmld
Rnd_xh131 xhp131 xhn131 20k
Cxh131p xhp131 0 1e-13
Cxh131n xhn131 0 1e-13
Xih_0_131 a_xp0 a_xn0 wih_p_0_131 wih_n_0_131 xhp131 xhn131 vdd vbsyn gsyn
Xih_1_131 a_xp1 a_xn1 wih_p_1_131 wih_n_1_131 xhp131 xhn131 vdd vbsyn gsyn
Xih_2_131 a_xp2 a_xn2 wih_p_2_131 wih_n_2_131 xhp131 xhn131 vdd vbsyn gsyn
Xn131 xhp131 xhn131 ahp131 ahn131 vdd vbneu dneuron
Vwih_p_0_132 wih_p_0_132 0 0.9
Vwih_n_0_132 wih_n_0_132 0 0.3
Vwih_p_1_132 wih_p_1_132 0 0.6577076385928876
Vwih_n_1_132 wih_n_1_132 0 0.3422923614071124
Vwih_p_2_132 wih_p_2_132 0 0.9
Vwih_n_2_132 wih_n_2_132 0 0.3
Xcm_xh132 xhp132 xhn132 vdd cmld
Rnd_xh132 xhp132 xhn132 20k
Cxh132p xhp132 0 1e-13
Cxh132n xhn132 0 1e-13
Xih_0_132 a_xp0 a_xn0 wih_p_0_132 wih_n_0_132 xhp132 xhn132 vdd vbsyn gsyn
Xih_1_132 a_xp1 a_xn1 wih_p_1_132 wih_n_1_132 xhp132 xhn132 vdd vbsyn gsyn
Xih_2_132 a_xp2 a_xn2 wih_p_2_132 wih_n_2_132 xhp132 xhn132 vdd vbsyn gsyn
Xn132 xhp132 xhn132 ahp132 ahn132 vdd vbneu dneuron
Vwih_p_0_133 wih_p_0_133 0 0.9
Vwih_n_0_133 wih_n_0_133 0 0.3
Vwih_p_1_133 wih_p_1_133 0 0.3
Vwih_n_1_133 wih_n_1_133 0 0.9
Vwih_p_2_133 wih_p_2_133 0 0.3
Vwih_n_2_133 wih_n_2_133 0 0.9
Xcm_xh133 xhp133 xhn133 vdd cmld
Rnd_xh133 xhp133 xhn133 20k
Cxh133p xhp133 0 1e-13
Cxh133n xhn133 0 1e-13
Xih_0_133 a_xp0 a_xn0 wih_p_0_133 wih_n_0_133 xhp133 xhn133 vdd vbsyn gsyn
Xih_1_133 a_xp1 a_xn1 wih_p_1_133 wih_n_1_133 xhp133 xhn133 vdd vbsyn gsyn
Xih_2_133 a_xp2 a_xn2 wih_p_2_133 wih_n_2_133 xhp133 xhn133 vdd vbsyn gsyn
Xn133 xhp133 xhn133 ahp133 ahn133 vdd vbneu dneuron
Vwih_p_0_134 wih_p_0_134 0 0.5964313933581133
Vwih_n_0_134 wih_n_0_134 0 0.40356860664188665
Vwih_p_1_134 wih_p_1_134 0 0.4750251734287647
Vwih_n_1_134 wih_n_1_134 0 0.5249748265712353
Vwih_p_2_134 wih_p_2_134 0 0.576131831112196
Vwih_n_2_134 wih_n_2_134 0 0.42386816888780393
Xcm_xh134 xhp134 xhn134 vdd cmld
Rnd_xh134 xhp134 xhn134 20k
Cxh134p xhp134 0 1e-13
Cxh134n xhn134 0 1e-13
Xih_0_134 a_xp0 a_xn0 wih_p_0_134 wih_n_0_134 xhp134 xhn134 vdd vbsyn gsyn
Xih_1_134 a_xp1 a_xn1 wih_p_1_134 wih_n_1_134 xhp134 xhn134 vdd vbsyn gsyn
Xih_2_134 a_xp2 a_xn2 wih_p_2_134 wih_n_2_134 xhp134 xhn134 vdd vbsyn gsyn
Xn134 xhp134 xhn134 ahp134 ahn134 vdd vbneu dneuron
Vwih_p_0_135 wih_p_0_135 0 0.3
Vwih_n_0_135 wih_n_0_135 0 0.7969752181950118
Vwih_p_1_135 wih_p_1_135 0 0.9
Vwih_n_1_135 wih_n_1_135 0 0.3
Vwih_p_2_135 wih_p_2_135 0 0.3735991483283892
Vwih_n_2_135 wih_n_2_135 0 0.6264008516716109
Xcm_xh135 xhp135 xhn135 vdd cmld
Rnd_xh135 xhp135 xhn135 20k
Cxh135p xhp135 0 1e-13
Cxh135n xhn135 0 1e-13
Xih_0_135 a_xp0 a_xn0 wih_p_0_135 wih_n_0_135 xhp135 xhn135 vdd vbsyn gsyn
Xih_1_135 a_xp1 a_xn1 wih_p_1_135 wih_n_1_135 xhp135 xhn135 vdd vbsyn gsyn
Xih_2_135 a_xp2 a_xn2 wih_p_2_135 wih_n_2_135 xhp135 xhn135 vdd vbsyn gsyn
Xn135 xhp135 xhn135 ahp135 ahn135 vdd vbneu dneuron
Vwih_p_0_136 wih_p_0_136 0 0.9
Vwih_n_0_136 wih_n_0_136 0 0.3
Vwih_p_1_136 wih_p_1_136 0 0.9
Vwih_n_1_136 wih_n_1_136 0 0.3
Vwih_p_2_136 wih_p_2_136 0 0.3
Vwih_n_2_136 wih_n_2_136 0 0.7106847428975316
Xcm_xh136 xhp136 xhn136 vdd cmld
Rnd_xh136 xhp136 xhn136 20k
Cxh136p xhp136 0 1e-13
Cxh136n xhn136 0 1e-13
Xih_0_136 a_xp0 a_xn0 wih_p_0_136 wih_n_0_136 xhp136 xhn136 vdd vbsyn gsyn
Xih_1_136 a_xp1 a_xn1 wih_p_1_136 wih_n_1_136 xhp136 xhn136 vdd vbsyn gsyn
Xih_2_136 a_xp2 a_xn2 wih_p_2_136 wih_n_2_136 xhp136 xhn136 vdd vbsyn gsyn
Xn136 xhp136 xhn136 ahp136 ahn136 vdd vbneu dneuron
Vwih_p_0_137 wih_p_0_137 0 0.7074972049821613
Vwih_n_0_137 wih_n_0_137 0 0.3
Vwih_p_1_137 wih_p_1_137 0 0.9
Vwih_n_1_137 wih_n_1_137 0 0.3
Vwih_p_2_137 wih_p_2_137 0 0.9
Vwih_n_2_137 wih_n_2_137 0 0.3
Xcm_xh137 xhp137 xhn137 vdd cmld
Rnd_xh137 xhp137 xhn137 20k
Cxh137p xhp137 0 1e-13
Cxh137n xhn137 0 1e-13
Xih_0_137 a_xp0 a_xn0 wih_p_0_137 wih_n_0_137 xhp137 xhn137 vdd vbsyn gsyn
Xih_1_137 a_xp1 a_xn1 wih_p_1_137 wih_n_1_137 xhp137 xhn137 vdd vbsyn gsyn
Xih_2_137 a_xp2 a_xn2 wih_p_2_137 wih_n_2_137 xhp137 xhn137 vdd vbsyn gsyn
Xn137 xhp137 xhn137 ahp137 ahn137 vdd vbneu dneuron
Vwih_p_0_138 wih_p_0_138 0 0.7706367959138589
Vwih_n_0_138 wih_n_0_138 0 0.3
Vwih_p_1_138 wih_p_1_138 0 0.658293924003461
Vwih_n_1_138 wih_n_1_138 0 0.341706075996539
Vwih_p_2_138 wih_p_2_138 0 0.5283861615187351
Vwih_n_2_138 wih_n_2_138 0 0.4716138384812649
Xcm_xh138 xhp138 xhn138 vdd cmld
Rnd_xh138 xhp138 xhn138 20k
Cxh138p xhp138 0 1e-13
Cxh138n xhn138 0 1e-13
Xih_0_138 a_xp0 a_xn0 wih_p_0_138 wih_n_0_138 xhp138 xhn138 vdd vbsyn gsyn
Xih_1_138 a_xp1 a_xn1 wih_p_1_138 wih_n_1_138 xhp138 xhn138 vdd vbsyn gsyn
Xih_2_138 a_xp2 a_xn2 wih_p_2_138 wih_n_2_138 xhp138 xhn138 vdd vbsyn gsyn
Xn138 xhp138 xhn138 ahp138 ahn138 vdd vbneu dneuron
Vwih_p_0_139 wih_p_0_139 0 0.9
Vwih_n_0_139 wih_n_0_139 0 0.3
Vwih_p_1_139 wih_p_1_139 0 0.7099018243440429
Vwih_n_1_139 wih_n_1_139 0 0.3
Vwih_p_2_139 wih_p_2_139 0 0.5447448581444762
Vwih_n_2_139 wih_n_2_139 0 0.4552551418555238
Xcm_xh139 xhp139 xhn139 vdd cmld
Rnd_xh139 xhp139 xhn139 20k
Cxh139p xhp139 0 1e-13
Cxh139n xhn139 0 1e-13
Xih_0_139 a_xp0 a_xn0 wih_p_0_139 wih_n_0_139 xhp139 xhn139 vdd vbsyn gsyn
Xih_1_139 a_xp1 a_xn1 wih_p_1_139 wih_n_1_139 xhp139 xhn139 vdd vbsyn gsyn
Xih_2_139 a_xp2 a_xn2 wih_p_2_139 wih_n_2_139 xhp139 xhn139 vdd vbsyn gsyn
Xn139 xhp139 xhn139 ahp139 ahn139 vdd vbneu dneuron
Vwih_p_0_140 wih_p_0_140 0 0.3298254765748203
Vwih_n_0_140 wih_n_0_140 0 0.6701745234251797
Vwih_p_1_140 wih_p_1_140 0 0.3
Vwih_n_1_140 wih_n_1_140 0 0.9
Vwih_p_2_140 wih_p_2_140 0 0.4375314730397877
Vwih_n_2_140 wih_n_2_140 0 0.5624685269602123
Xcm_xh140 xhp140 xhn140 vdd cmld
Rnd_xh140 xhp140 xhn140 20k
Cxh140p xhp140 0 1e-13
Cxh140n xhn140 0 1e-13
Xih_0_140 a_xp0 a_xn0 wih_p_0_140 wih_n_0_140 xhp140 xhn140 vdd vbsyn gsyn
Xih_1_140 a_xp1 a_xn1 wih_p_1_140 wih_n_1_140 xhp140 xhn140 vdd vbsyn gsyn
Xih_2_140 a_xp2 a_xn2 wih_p_2_140 wih_n_2_140 xhp140 xhn140 vdd vbsyn gsyn
Xn140 xhp140 xhn140 ahp140 ahn140 vdd vbneu dneuron
Vwih_p_0_141 wih_p_0_141 0 0.9
Vwih_n_0_141 wih_n_0_141 0 0.3
Vwih_p_1_141 wih_p_1_141 0 0.32589965686019606
Vwih_n_1_141 wih_n_1_141 0 0.6741003431398039
Vwih_p_2_141 wih_p_2_141 0 0.3
Vwih_n_2_141 wih_n_2_141 0 0.7308402152271418
Xcm_xh141 xhp141 xhn141 vdd cmld
Rnd_xh141 xhp141 xhn141 20k
Cxh141p xhp141 0 1e-13
Cxh141n xhn141 0 1e-13
Xih_0_141 a_xp0 a_xn0 wih_p_0_141 wih_n_0_141 xhp141 xhn141 vdd vbsyn gsyn
Xih_1_141 a_xp1 a_xn1 wih_p_1_141 wih_n_1_141 xhp141 xhn141 vdd vbsyn gsyn
Xih_2_141 a_xp2 a_xn2 wih_p_2_141 wih_n_2_141 xhp141 xhn141 vdd vbsyn gsyn
Xn141 xhp141 xhn141 ahp141 ahn141 vdd vbneu dneuron
Vwih_p_0_142 wih_p_0_142 0 0.4133616498152506
Vwih_n_0_142 wih_n_0_142 0 0.5866383501847494
Vwih_p_1_142 wih_p_1_142 0 0.42336723951149163
Vwih_n_1_142 wih_n_1_142 0 0.5766327604885083
Vwih_p_2_142 wih_p_2_142 0 0.3
Vwih_n_2_142 wih_n_2_142 0 0.7013029895252606
Xcm_xh142 xhp142 xhn142 vdd cmld
Rnd_xh142 xhp142 xhn142 20k
Cxh142p xhp142 0 1e-13
Cxh142n xhn142 0 1e-13
Xih_0_142 a_xp0 a_xn0 wih_p_0_142 wih_n_0_142 xhp142 xhn142 vdd vbsyn gsyn
Xih_1_142 a_xp1 a_xn1 wih_p_1_142 wih_n_1_142 xhp142 xhn142 vdd vbsyn gsyn
Xih_2_142 a_xp2 a_xn2 wih_p_2_142 wih_n_2_142 xhp142 xhn142 vdd vbsyn gsyn
Xn142 xhp142 xhn142 ahp142 ahn142 vdd vbneu dneuron
Vwih_p_0_143 wih_p_0_143 0 0.7315655419969673
Vwih_n_0_143 wih_n_0_143 0 0.3
Vwih_p_1_143 wih_p_1_143 0 0.617285563154351
Vwih_n_1_143 wih_n_1_143 0 0.38271443684564893
Vwih_p_2_143 wih_p_2_143 0 0.9
Vwih_n_2_143 wih_n_2_143 0 0.3
Xcm_xh143 xhp143 xhn143 vdd cmld
Rnd_xh143 xhp143 xhn143 20k
Cxh143p xhp143 0 1e-13
Cxh143n xhn143 0 1e-13
Xih_0_143 a_xp0 a_xn0 wih_p_0_143 wih_n_0_143 xhp143 xhn143 vdd vbsyn gsyn
Xih_1_143 a_xp1 a_xn1 wih_p_1_143 wih_n_1_143 xhp143 xhn143 vdd vbsyn gsyn
Xih_2_143 a_xp2 a_xn2 wih_p_2_143 wih_n_2_143 xhp143 xhn143 vdd vbsyn gsyn
Xn143 xhp143 xhn143 ahp143 ahn143 vdd vbneu dneuron
Vwih_p_0_144 wih_p_0_144 0 0.7165437333812344
Vwih_n_0_144 wih_n_0_144 0 0.3
Vwih_p_1_144 wih_p_1_144 0 0.567134373295665
Vwih_n_1_144 wih_n_1_144 0 0.43286562670433504
Vwih_p_2_144 wih_p_2_144 0 0.3
Vwih_n_2_144 wih_n_2_144 0 0.9
Xcm_xh144 xhp144 xhn144 vdd cmld
Rnd_xh144 xhp144 xhn144 20k
Cxh144p xhp144 0 1e-13
Cxh144n xhn144 0 1e-13
Xih_0_144 a_xp0 a_xn0 wih_p_0_144 wih_n_0_144 xhp144 xhn144 vdd vbsyn gsyn
Xih_1_144 a_xp1 a_xn1 wih_p_1_144 wih_n_1_144 xhp144 xhn144 vdd vbsyn gsyn
Xih_2_144 a_xp2 a_xn2 wih_p_2_144 wih_n_2_144 xhp144 xhn144 vdd vbsyn gsyn
Xn144 xhp144 xhn144 ahp144 ahn144 vdd vbneu dneuron
Vwih_p_0_145 wih_p_0_145 0 0.5709730383738978
Vwih_n_0_145 wih_n_0_145 0 0.4290269616261022
Vwih_p_1_145 wih_p_1_145 0 0.3
Vwih_n_1_145 wih_n_1_145 0 0.7351267145230538
Vwih_p_2_145 wih_p_2_145 0 0.8879820288393216
Vwih_n_2_145 wih_n_2_145 0 0.3
Xcm_xh145 xhp145 xhn145 vdd cmld
Rnd_xh145 xhp145 xhn145 20k
Cxh145p xhp145 0 1e-13
Cxh145n xhn145 0 1e-13
Xih_0_145 a_xp0 a_xn0 wih_p_0_145 wih_n_0_145 xhp145 xhn145 vdd vbsyn gsyn
Xih_1_145 a_xp1 a_xn1 wih_p_1_145 wih_n_1_145 xhp145 xhn145 vdd vbsyn gsyn
Xih_2_145 a_xp2 a_xn2 wih_p_2_145 wih_n_2_145 xhp145 xhn145 vdd vbsyn gsyn
Xn145 xhp145 xhn145 ahp145 ahn145 vdd vbneu dneuron
Vwih_p_0_146 wih_p_0_146 0 0.5264383713057131
Vwih_n_0_146 wih_n_0_146 0 0.4735616286942868
Vwih_p_1_146 wih_p_1_146 0 0.3
Vwih_n_1_146 wih_n_1_146 0 0.7745424199042548
Vwih_p_2_146 wih_p_2_146 0 0.30443338975952167
Vwih_n_2_146 wih_n_2_146 0 0.6955666102404783
Xcm_xh146 xhp146 xhn146 vdd cmld
Rnd_xh146 xhp146 xhn146 20k
Cxh146p xhp146 0 1e-13
Cxh146n xhn146 0 1e-13
Xih_0_146 a_xp0 a_xn0 wih_p_0_146 wih_n_0_146 xhp146 xhn146 vdd vbsyn gsyn
Xih_1_146 a_xp1 a_xn1 wih_p_1_146 wih_n_1_146 xhp146 xhn146 vdd vbsyn gsyn
Xih_2_146 a_xp2 a_xn2 wih_p_2_146 wih_n_2_146 xhp146 xhn146 vdd vbsyn gsyn
Xn146 xhp146 xhn146 ahp146 ahn146 vdd vbneu dneuron
Vwih_p_0_147 wih_p_0_147 0 0.3
Vwih_n_0_147 wih_n_0_147 0 0.9
Vwih_p_1_147 wih_p_1_147 0 0.3028830330993254
Vwih_n_1_147 wih_n_1_147 0 0.6971169669006746
Vwih_p_2_147 wih_p_2_147 0 0.6134672563047238
Vwih_n_2_147 wih_n_2_147 0 0.38653274369527624
Xcm_xh147 xhp147 xhn147 vdd cmld
Rnd_xh147 xhp147 xhn147 20k
Cxh147p xhp147 0 1e-13
Cxh147n xhn147 0 1e-13
Xih_0_147 a_xp0 a_xn0 wih_p_0_147 wih_n_0_147 xhp147 xhn147 vdd vbsyn gsyn
Xih_1_147 a_xp1 a_xn1 wih_p_1_147 wih_n_1_147 xhp147 xhn147 vdd vbsyn gsyn
Xih_2_147 a_xp2 a_xn2 wih_p_2_147 wih_n_2_147 xhp147 xhn147 vdd vbsyn gsyn
Xn147 xhp147 xhn147 ahp147 ahn147 vdd vbneu dneuron
Vwih_p_0_148 wih_p_0_148 0 0.9
Vwih_n_0_148 wih_n_0_148 0 0.3
Vwih_p_1_148 wih_p_1_148 0 0.6871481442089944
Vwih_n_1_148 wih_n_1_148 0 0.31285185579100566
Vwih_p_2_148 wih_p_2_148 0 0.791490492293804
Vwih_n_2_148 wih_n_2_148 0 0.3
Xcm_xh148 xhp148 xhn148 vdd cmld
Rnd_xh148 xhp148 xhn148 20k
Cxh148p xhp148 0 1e-13
Cxh148n xhn148 0 1e-13
Xih_0_148 a_xp0 a_xn0 wih_p_0_148 wih_n_0_148 xhp148 xhn148 vdd vbsyn gsyn
Xih_1_148 a_xp1 a_xn1 wih_p_1_148 wih_n_1_148 xhp148 xhn148 vdd vbsyn gsyn
Xih_2_148 a_xp2 a_xn2 wih_p_2_148 wih_n_2_148 xhp148 xhn148 vdd vbsyn gsyn
Xn148 xhp148 xhn148 ahp148 ahn148 vdd vbneu dneuron
Vwih_p_0_149 wih_p_0_149 0 0.8207979273947725
Vwih_n_0_149 wih_n_0_149 0 0.3
Vwih_p_1_149 wih_p_1_149 0 0.3834944510292356
Vwih_n_1_149 wih_n_1_149 0 0.6165055489707645
Vwih_p_2_149 wih_p_2_149 0 0.9
Vwih_n_2_149 wih_n_2_149 0 0.3
Xcm_xh149 xhp149 xhn149 vdd cmld
Rnd_xh149 xhp149 xhn149 20k
Cxh149p xhp149 0 1e-13
Cxh149n xhn149 0 1e-13
Xih_0_149 a_xp0 a_xn0 wih_p_0_149 wih_n_0_149 xhp149 xhn149 vdd vbsyn gsyn
Xih_1_149 a_xp1 a_xn1 wih_p_1_149 wih_n_1_149 xhp149 xhn149 vdd vbsyn gsyn
Xih_2_149 a_xp2 a_xn2 wih_p_2_149 wih_n_2_149 xhp149 xhn149 vdd vbsyn gsyn
Xn149 xhp149 xhn149 ahp149 ahn149 vdd vbneu dneuron
Vwih_p_0_150 wih_p_0_150 0 0.3
Vwih_n_0_150 wih_n_0_150 0 0.9
Vwih_p_1_150 wih_p_1_150 0 0.544417676679812
Vwih_n_1_150 wih_n_1_150 0 0.45558232332018794
Vwih_p_2_150 wih_p_2_150 0 0.310728104373418
Vwih_n_2_150 wih_n_2_150 0 0.689271895626582
Xcm_xh150 xhp150 xhn150 vdd cmld
Rnd_xh150 xhp150 xhn150 20k
Cxh150p xhp150 0 1e-13
Cxh150n xhn150 0 1e-13
Xih_0_150 a_xp0 a_xn0 wih_p_0_150 wih_n_0_150 xhp150 xhn150 vdd vbsyn gsyn
Xih_1_150 a_xp1 a_xn1 wih_p_1_150 wih_n_1_150 xhp150 xhn150 vdd vbsyn gsyn
Xih_2_150 a_xp2 a_xn2 wih_p_2_150 wih_n_2_150 xhp150 xhn150 vdd vbsyn gsyn
Xn150 xhp150 xhn150 ahp150 ahn150 vdd vbneu dneuron
Vwih_p_0_151 wih_p_0_151 0 0.3
Vwih_n_0_151 wih_n_0_151 0 0.9
Vwih_p_1_151 wih_p_1_151 0 0.9
Vwih_n_1_151 wih_n_1_151 0 0.3
Vwih_p_2_151 wih_p_2_151 0 0.3
Vwih_n_2_151 wih_n_2_151 0 0.9
Xcm_xh151 xhp151 xhn151 vdd cmld
Rnd_xh151 xhp151 xhn151 20k
Cxh151p xhp151 0 1e-13
Cxh151n xhn151 0 1e-13
Xih_0_151 a_xp0 a_xn0 wih_p_0_151 wih_n_0_151 xhp151 xhn151 vdd vbsyn gsyn
Xih_1_151 a_xp1 a_xn1 wih_p_1_151 wih_n_1_151 xhp151 xhn151 vdd vbsyn gsyn
Xih_2_151 a_xp2 a_xn2 wih_p_2_151 wih_n_2_151 xhp151 xhn151 vdd vbsyn gsyn
Xn151 xhp151 xhn151 ahp151 ahn151 vdd vbneu dneuron
Vwih_p_0_152 wih_p_0_152 0 0.748166088223502
Vwih_n_0_152 wih_n_0_152 0 0.3
Vwih_p_1_152 wih_p_1_152 0 0.9
Vwih_n_1_152 wih_n_1_152 0 0.3
Vwih_p_2_152 wih_p_2_152 0 0.42687557011447375
Vwih_n_2_152 wih_n_2_152 0 0.5731244298855263
Xcm_xh152 xhp152 xhn152 vdd cmld
Rnd_xh152 xhp152 xhn152 20k
Cxh152p xhp152 0 1e-13
Cxh152n xhn152 0 1e-13
Xih_0_152 a_xp0 a_xn0 wih_p_0_152 wih_n_0_152 xhp152 xhn152 vdd vbsyn gsyn
Xih_1_152 a_xp1 a_xn1 wih_p_1_152 wih_n_1_152 xhp152 xhn152 vdd vbsyn gsyn
Xih_2_152 a_xp2 a_xn2 wih_p_2_152 wih_n_2_152 xhp152 xhn152 vdd vbsyn gsyn
Xn152 xhp152 xhn152 ahp152 ahn152 vdd vbneu dneuron
Vwih_p_0_153 wih_p_0_153 0 0.4584662048964695
Vwih_n_0_153 wih_n_0_153 0 0.5415337951035305
Vwih_p_1_153 wih_p_1_153 0 0.3
Vwih_n_1_153 wih_n_1_153 0 0.9
Vwih_p_2_153 wih_p_2_153 0 0.4100694798359296
Vwih_n_2_153 wih_n_2_153 0 0.5899305201640703
Xcm_xh153 xhp153 xhn153 vdd cmld
Rnd_xh153 xhp153 xhn153 20k
Cxh153p xhp153 0 1e-13
Cxh153n xhn153 0 1e-13
Xih_0_153 a_xp0 a_xn0 wih_p_0_153 wih_n_0_153 xhp153 xhn153 vdd vbsyn gsyn
Xih_1_153 a_xp1 a_xn1 wih_p_1_153 wih_n_1_153 xhp153 xhn153 vdd vbsyn gsyn
Xih_2_153 a_xp2 a_xn2 wih_p_2_153 wih_n_2_153 xhp153 xhn153 vdd vbsyn gsyn
Xn153 xhp153 xhn153 ahp153 ahn153 vdd vbneu dneuron
Vwih_p_0_154 wih_p_0_154 0 0.9
Vwih_n_0_154 wih_n_0_154 0 0.3
Vwih_p_1_154 wih_p_1_154 0 0.3120369991639531
Vwih_n_1_154 wih_n_1_154 0 0.6879630008360469
Vwih_p_2_154 wih_p_2_154 0 0.3
Vwih_n_2_154 wih_n_2_154 0 0.8507836292853642
Xcm_xh154 xhp154 xhn154 vdd cmld
Rnd_xh154 xhp154 xhn154 20k
Cxh154p xhp154 0 1e-13
Cxh154n xhn154 0 1e-13
Xih_0_154 a_xp0 a_xn0 wih_p_0_154 wih_n_0_154 xhp154 xhn154 vdd vbsyn gsyn
Xih_1_154 a_xp1 a_xn1 wih_p_1_154 wih_n_1_154 xhp154 xhn154 vdd vbsyn gsyn
Xih_2_154 a_xp2 a_xn2 wih_p_2_154 wih_n_2_154 xhp154 xhn154 vdd vbsyn gsyn
Xn154 xhp154 xhn154 ahp154 ahn154 vdd vbneu dneuron
Vwih_p_0_155 wih_p_0_155 0 0.3
Vwih_n_0_155 wih_n_0_155 0 0.9
Vwih_p_1_155 wih_p_1_155 0 0.9
Vwih_n_1_155 wih_n_1_155 0 0.3
Vwih_p_2_155 wih_p_2_155 0 0.6482438243741052
Vwih_n_2_155 wih_n_2_155 0 0.3517561756258948
Xcm_xh155 xhp155 xhn155 vdd cmld
Rnd_xh155 xhp155 xhn155 20k
Cxh155p xhp155 0 1e-13
Cxh155n xhn155 0 1e-13
Xih_0_155 a_xp0 a_xn0 wih_p_0_155 wih_n_0_155 xhp155 xhn155 vdd vbsyn gsyn
Xih_1_155 a_xp1 a_xn1 wih_p_1_155 wih_n_1_155 xhp155 xhn155 vdd vbsyn gsyn
Xih_2_155 a_xp2 a_xn2 wih_p_2_155 wih_n_2_155 xhp155 xhn155 vdd vbsyn gsyn
Xn155 xhp155 xhn155 ahp155 ahn155 vdd vbneu dneuron
Vwih_p_0_156 wih_p_0_156 0 0.3912729594920419
Vwih_n_0_156 wih_n_0_156 0 0.6087270405079581
Vwih_p_1_156 wih_p_1_156 0 0.8754021909446104
Vwih_n_1_156 wih_n_1_156 0 0.3
Vwih_p_2_156 wih_p_2_156 0 0.30895470510991074
Vwih_n_2_156 wih_n_2_156 0 0.6910452948900893
Xcm_xh156 xhp156 xhn156 vdd cmld
Rnd_xh156 xhp156 xhn156 20k
Cxh156p xhp156 0 1e-13
Cxh156n xhn156 0 1e-13
Xih_0_156 a_xp0 a_xn0 wih_p_0_156 wih_n_0_156 xhp156 xhn156 vdd vbsyn gsyn
Xih_1_156 a_xp1 a_xn1 wih_p_1_156 wih_n_1_156 xhp156 xhn156 vdd vbsyn gsyn
Xih_2_156 a_xp2 a_xn2 wih_p_2_156 wih_n_2_156 xhp156 xhn156 vdd vbsyn gsyn
Xn156 xhp156 xhn156 ahp156 ahn156 vdd vbneu dneuron
Vwih_p_0_157 wih_p_0_157 0 0.3797533254033188
Vwih_n_0_157 wih_n_0_157 0 0.6202466745966813
Vwih_p_1_157 wih_p_1_157 0 0.9
Vwih_n_1_157 wih_n_1_157 0 0.3
Vwih_p_2_157 wih_p_2_157 0 0.3
Vwih_n_2_157 wih_n_2_157 0 0.8226556431510093
Xcm_xh157 xhp157 xhn157 vdd cmld
Rnd_xh157 xhp157 xhn157 20k
Cxh157p xhp157 0 1e-13
Cxh157n xhn157 0 1e-13
Xih_0_157 a_xp0 a_xn0 wih_p_0_157 wih_n_0_157 xhp157 xhn157 vdd vbsyn gsyn
Xih_1_157 a_xp1 a_xn1 wih_p_1_157 wih_n_1_157 xhp157 xhn157 vdd vbsyn gsyn
Xih_2_157 a_xp2 a_xn2 wih_p_2_157 wih_n_2_157 xhp157 xhn157 vdd vbsyn gsyn
Xn157 xhp157 xhn157 ahp157 ahn157 vdd vbneu dneuron
Vwih_p_0_158 wih_p_0_158 0 0.6045196552381066
Vwih_n_0_158 wih_n_0_158 0 0.39548034476189337
Vwih_p_1_158 wih_p_1_158 0 0.5804684560813536
Vwih_n_1_158 wih_n_1_158 0 0.41953154391864644
Vwih_p_2_158 wih_p_2_158 0 0.5350791347515961
Vwih_n_2_158 wih_n_2_158 0 0.4649208652484039
Xcm_xh158 xhp158 xhn158 vdd cmld
Rnd_xh158 xhp158 xhn158 20k
Cxh158p xhp158 0 1e-13
Cxh158n xhn158 0 1e-13
Xih_0_158 a_xp0 a_xn0 wih_p_0_158 wih_n_0_158 xhp158 xhn158 vdd vbsyn gsyn
Xih_1_158 a_xp1 a_xn1 wih_p_1_158 wih_n_1_158 xhp158 xhn158 vdd vbsyn gsyn
Xih_2_158 a_xp2 a_xn2 wih_p_2_158 wih_n_2_158 xhp158 xhn158 vdd vbsyn gsyn
Xn158 xhp158 xhn158 ahp158 ahn158 vdd vbneu dneuron
Vwih_p_0_159 wih_p_0_159 0 0.502258550170953
Vwih_n_0_159 wih_n_0_159 0 0.49774144982904706
Vwih_p_1_159 wih_p_1_159 0 0.3
Vwih_n_1_159 wih_n_1_159 0 0.9
Vwih_p_2_159 wih_p_2_159 0 0.4504996708780997
Vwih_n_2_159 wih_n_2_159 0 0.5495003291219003
Xcm_xh159 xhp159 xhn159 vdd cmld
Rnd_xh159 xhp159 xhn159 20k
Cxh159p xhp159 0 1e-13
Cxh159n xhn159 0 1e-13
Xih_0_159 a_xp0 a_xn0 wih_p_0_159 wih_n_0_159 xhp159 xhn159 vdd vbsyn gsyn
Xih_1_159 a_xp1 a_xn1 wih_p_1_159 wih_n_1_159 xhp159 xhn159 vdd vbsyn gsyn
Xih_2_159 a_xp2 a_xn2 wih_p_2_159 wih_n_2_159 xhp159 xhn159 vdd vbsyn gsyn
Xn159 xhp159 xhn159 ahp159 ahn159 vdd vbneu dneuron
Vahb_p ahbias_p 0 0.8
Vahb_n ahbias_n 0 0.2
Xcm_mo0 mop0 mon0 vdd cmldW
Rmo0 mop0 mon0 20k
Cmo0p mop0 0 1e-13
Cmo0n mon0 0 1e-13
Cwp_0_0 who_p_0_0 0 40p
Cwn_0_0 who_n_0_0 0 40p
Rwp_0_0 who_p_0_0 wcm 2g
Rwn_0_0 who_n_0_0 wcm 2g
Xsyn_0_0 ahp0 ahn0 who_p_0_0 who_n_0_0 mop0 mon0 vdd vbsyn gsynR
Cwp_1_0 who_p_1_0 0 40p
Cwn_1_0 who_n_1_0 0 40p
Rwp_1_0 who_p_1_0 wcm 2g
Rwn_1_0 who_n_1_0 wcm 2g
Xsyn_1_0 ahp1 ahn1 who_p_1_0 who_n_1_0 mop0 mon0 vdd vbsyn gsynR
Cwp_2_0 who_p_2_0 0 40p
Cwn_2_0 who_n_2_0 0 40p
Rwp_2_0 who_p_2_0 wcm 2g
Rwn_2_0 who_n_2_0 wcm 2g
Xsyn_2_0 ahp2 ahn2 who_p_2_0 who_n_2_0 mop0 mon0 vdd vbsyn gsynR
Cwp_3_0 who_p_3_0 0 40p
Cwn_3_0 who_n_3_0 0 40p
Rwp_3_0 who_p_3_0 wcm 2g
Rwn_3_0 who_n_3_0 wcm 2g
Xsyn_3_0 ahp3 ahn3 who_p_3_0 who_n_3_0 mop0 mon0 vdd vbsyn gsynR
Cwp_4_0 who_p_4_0 0 40p
Cwn_4_0 who_n_4_0 0 40p
Rwp_4_0 who_p_4_0 wcm 2g
Rwn_4_0 who_n_4_0 wcm 2g
Xsyn_4_0 ahp4 ahn4 who_p_4_0 who_n_4_0 mop0 mon0 vdd vbsyn gsynR
Cwp_5_0 who_p_5_0 0 40p
Cwn_5_0 who_n_5_0 0 40p
Rwp_5_0 who_p_5_0 wcm 2g
Rwn_5_0 who_n_5_0 wcm 2g
Xsyn_5_0 ahp5 ahn5 who_p_5_0 who_n_5_0 mop0 mon0 vdd vbsyn gsynR
Cwp_6_0 who_p_6_0 0 40p
Cwn_6_0 who_n_6_0 0 40p
Rwp_6_0 who_p_6_0 wcm 2g
Rwn_6_0 who_n_6_0 wcm 2g
Xsyn_6_0 ahp6 ahn6 who_p_6_0 who_n_6_0 mop0 mon0 vdd vbsyn gsynR
Cwp_7_0 who_p_7_0 0 40p
Cwn_7_0 who_n_7_0 0 40p
Rwp_7_0 who_p_7_0 wcm 2g
Rwn_7_0 who_n_7_0 wcm 2g
Xsyn_7_0 ahp7 ahn7 who_p_7_0 who_n_7_0 mop0 mon0 vdd vbsyn gsynR
Cwp_8_0 who_p_8_0 0 40p
Cwn_8_0 who_n_8_0 0 40p
Rwp_8_0 who_p_8_0 wcm 2g
Rwn_8_0 who_n_8_0 wcm 2g
Xsyn_8_0 ahp8 ahn8 who_p_8_0 who_n_8_0 mop0 mon0 vdd vbsyn gsynR
Cwp_9_0 who_p_9_0 0 40p
Cwn_9_0 who_n_9_0 0 40p
Rwp_9_0 who_p_9_0 wcm 2g
Rwn_9_0 who_n_9_0 wcm 2g
Xsyn_9_0 ahp9 ahn9 who_p_9_0 who_n_9_0 mop0 mon0 vdd vbsyn gsynR
Cwp_10_0 who_p_10_0 0 40p
Cwn_10_0 who_n_10_0 0 40p
Rwp_10_0 who_p_10_0 wcm 2g
Rwn_10_0 who_n_10_0 wcm 2g
Xsyn_10_0 ahp10 ahn10 who_p_10_0 who_n_10_0 mop0 mon0 vdd vbsyn gsynR
Cwp_11_0 who_p_11_0 0 40p
Cwn_11_0 who_n_11_0 0 40p
Rwp_11_0 who_p_11_0 wcm 2g
Rwn_11_0 who_n_11_0 wcm 2g
Xsyn_11_0 ahp11 ahn11 who_p_11_0 who_n_11_0 mop0 mon0 vdd vbsyn gsynR
Cwp_12_0 who_p_12_0 0 40p
Cwn_12_0 who_n_12_0 0 40p
Rwp_12_0 who_p_12_0 wcm 2g
Rwn_12_0 who_n_12_0 wcm 2g
Xsyn_12_0 ahp12 ahn12 who_p_12_0 who_n_12_0 mop0 mon0 vdd vbsyn gsynR
Cwp_13_0 who_p_13_0 0 40p
Cwn_13_0 who_n_13_0 0 40p
Rwp_13_0 who_p_13_0 wcm 2g
Rwn_13_0 who_n_13_0 wcm 2g
Xsyn_13_0 ahp13 ahn13 who_p_13_0 who_n_13_0 mop0 mon0 vdd vbsyn gsynR
Cwp_14_0 who_p_14_0 0 40p
Cwn_14_0 who_n_14_0 0 40p
Rwp_14_0 who_p_14_0 wcm 2g
Rwn_14_0 who_n_14_0 wcm 2g
Xsyn_14_0 ahp14 ahn14 who_p_14_0 who_n_14_0 mop0 mon0 vdd vbsyn gsynR
Cwp_15_0 who_p_15_0 0 40p
Cwn_15_0 who_n_15_0 0 40p
Rwp_15_0 who_p_15_0 wcm 2g
Rwn_15_0 who_n_15_0 wcm 2g
Xsyn_15_0 ahp15 ahn15 who_p_15_0 who_n_15_0 mop0 mon0 vdd vbsyn gsynR
Cwp_16_0 who_p_16_0 0 40p
Cwn_16_0 who_n_16_0 0 40p
Rwp_16_0 who_p_16_0 wcm 2g
Rwn_16_0 who_n_16_0 wcm 2g
Xsyn_16_0 ahp16 ahn16 who_p_16_0 who_n_16_0 mop0 mon0 vdd vbsyn gsynR
Cwp_17_0 who_p_17_0 0 40p
Cwn_17_0 who_n_17_0 0 40p
Rwp_17_0 who_p_17_0 wcm 2g
Rwn_17_0 who_n_17_0 wcm 2g
Xsyn_17_0 ahp17 ahn17 who_p_17_0 who_n_17_0 mop0 mon0 vdd vbsyn gsynR
Cwp_18_0 who_p_18_0 0 40p
Cwn_18_0 who_n_18_0 0 40p
Rwp_18_0 who_p_18_0 wcm 2g
Rwn_18_0 who_n_18_0 wcm 2g
Xsyn_18_0 ahp18 ahn18 who_p_18_0 who_n_18_0 mop0 mon0 vdd vbsyn gsynR
Cwp_19_0 who_p_19_0 0 40p
Cwn_19_0 who_n_19_0 0 40p
Rwp_19_0 who_p_19_0 wcm 2g
Rwn_19_0 who_n_19_0 wcm 2g
Xsyn_19_0 ahp19 ahn19 who_p_19_0 who_n_19_0 mop0 mon0 vdd vbsyn gsynR
Cwp_20_0 who_p_20_0 0 40p
Cwn_20_0 who_n_20_0 0 40p
Rwp_20_0 who_p_20_0 wcm 2g
Rwn_20_0 who_n_20_0 wcm 2g
Xsyn_20_0 ahp20 ahn20 who_p_20_0 who_n_20_0 mop0 mon0 vdd vbsyn gsynR
Cwp_21_0 who_p_21_0 0 40p
Cwn_21_0 who_n_21_0 0 40p
Rwp_21_0 who_p_21_0 wcm 2g
Rwn_21_0 who_n_21_0 wcm 2g
Xsyn_21_0 ahp21 ahn21 who_p_21_0 who_n_21_0 mop0 mon0 vdd vbsyn gsynR
Cwp_22_0 who_p_22_0 0 40p
Cwn_22_0 who_n_22_0 0 40p
Rwp_22_0 who_p_22_0 wcm 2g
Rwn_22_0 who_n_22_0 wcm 2g
Xsyn_22_0 ahp22 ahn22 who_p_22_0 who_n_22_0 mop0 mon0 vdd vbsyn gsynR
Cwp_23_0 who_p_23_0 0 40p
Cwn_23_0 who_n_23_0 0 40p
Rwp_23_0 who_p_23_0 wcm 2g
Rwn_23_0 who_n_23_0 wcm 2g
Xsyn_23_0 ahp23 ahn23 who_p_23_0 who_n_23_0 mop0 mon0 vdd vbsyn gsynR
Cwp_24_0 who_p_24_0 0 40p
Cwn_24_0 who_n_24_0 0 40p
Rwp_24_0 who_p_24_0 wcm 2g
Rwn_24_0 who_n_24_0 wcm 2g
Xsyn_24_0 ahp24 ahn24 who_p_24_0 who_n_24_0 mop0 mon0 vdd vbsyn gsynR
Cwp_25_0 who_p_25_0 0 40p
Cwn_25_0 who_n_25_0 0 40p
Rwp_25_0 who_p_25_0 wcm 2g
Rwn_25_0 who_n_25_0 wcm 2g
Xsyn_25_0 ahp25 ahn25 who_p_25_0 who_n_25_0 mop0 mon0 vdd vbsyn gsynR
Cwp_26_0 who_p_26_0 0 40p
Cwn_26_0 who_n_26_0 0 40p
Rwp_26_0 who_p_26_0 wcm 2g
Rwn_26_0 who_n_26_0 wcm 2g
Xsyn_26_0 ahp26 ahn26 who_p_26_0 who_n_26_0 mop0 mon0 vdd vbsyn gsynR
Cwp_27_0 who_p_27_0 0 40p
Cwn_27_0 who_n_27_0 0 40p
Rwp_27_0 who_p_27_0 wcm 2g
Rwn_27_0 who_n_27_0 wcm 2g
Xsyn_27_0 ahp27 ahn27 who_p_27_0 who_n_27_0 mop0 mon0 vdd vbsyn gsynR
Cwp_28_0 who_p_28_0 0 40p
Cwn_28_0 who_n_28_0 0 40p
Rwp_28_0 who_p_28_0 wcm 2g
Rwn_28_0 who_n_28_0 wcm 2g
Xsyn_28_0 ahp28 ahn28 who_p_28_0 who_n_28_0 mop0 mon0 vdd vbsyn gsynR
Cwp_29_0 who_p_29_0 0 40p
Cwn_29_0 who_n_29_0 0 40p
Rwp_29_0 who_p_29_0 wcm 2g
Rwn_29_0 who_n_29_0 wcm 2g
Xsyn_29_0 ahp29 ahn29 who_p_29_0 who_n_29_0 mop0 mon0 vdd vbsyn gsynR
Cwp_30_0 who_p_30_0 0 40p
Cwn_30_0 who_n_30_0 0 40p
Rwp_30_0 who_p_30_0 wcm 2g
Rwn_30_0 who_n_30_0 wcm 2g
Xsyn_30_0 ahp30 ahn30 who_p_30_0 who_n_30_0 mop0 mon0 vdd vbsyn gsynR
Cwp_31_0 who_p_31_0 0 40p
Cwn_31_0 who_n_31_0 0 40p
Rwp_31_0 who_p_31_0 wcm 2g
Rwn_31_0 who_n_31_0 wcm 2g
Xsyn_31_0 ahp31 ahn31 who_p_31_0 who_n_31_0 mop0 mon0 vdd vbsyn gsynR
Cwp_32_0 who_p_32_0 0 40p
Cwn_32_0 who_n_32_0 0 40p
Rwp_32_0 who_p_32_0 wcm 2g
Rwn_32_0 who_n_32_0 wcm 2g
Xsyn_32_0 ahp32 ahn32 who_p_32_0 who_n_32_0 mop0 mon0 vdd vbsyn gsynR
Cwp_33_0 who_p_33_0 0 40p
Cwn_33_0 who_n_33_0 0 40p
Rwp_33_0 who_p_33_0 wcm 2g
Rwn_33_0 who_n_33_0 wcm 2g
Xsyn_33_0 ahp33 ahn33 who_p_33_0 who_n_33_0 mop0 mon0 vdd vbsyn gsynR
Cwp_34_0 who_p_34_0 0 40p
Cwn_34_0 who_n_34_0 0 40p
Rwp_34_0 who_p_34_0 wcm 2g
Rwn_34_0 who_n_34_0 wcm 2g
Xsyn_34_0 ahp34 ahn34 who_p_34_0 who_n_34_0 mop0 mon0 vdd vbsyn gsynR
Cwp_35_0 who_p_35_0 0 40p
Cwn_35_0 who_n_35_0 0 40p
Rwp_35_0 who_p_35_0 wcm 2g
Rwn_35_0 who_n_35_0 wcm 2g
Xsyn_35_0 ahp35 ahn35 who_p_35_0 who_n_35_0 mop0 mon0 vdd vbsyn gsynR
Cwp_36_0 who_p_36_0 0 40p
Cwn_36_0 who_n_36_0 0 40p
Rwp_36_0 who_p_36_0 wcm 2g
Rwn_36_0 who_n_36_0 wcm 2g
Xsyn_36_0 ahp36 ahn36 who_p_36_0 who_n_36_0 mop0 mon0 vdd vbsyn gsynR
Cwp_37_0 who_p_37_0 0 40p
Cwn_37_0 who_n_37_0 0 40p
Rwp_37_0 who_p_37_0 wcm 2g
Rwn_37_0 who_n_37_0 wcm 2g
Xsyn_37_0 ahp37 ahn37 who_p_37_0 who_n_37_0 mop0 mon0 vdd vbsyn gsynR
Cwp_38_0 who_p_38_0 0 40p
Cwn_38_0 who_n_38_0 0 40p
Rwp_38_0 who_p_38_0 wcm 2g
Rwn_38_0 who_n_38_0 wcm 2g
Xsyn_38_0 ahp38 ahn38 who_p_38_0 who_n_38_0 mop0 mon0 vdd vbsyn gsynR
Cwp_39_0 who_p_39_0 0 40p
Cwn_39_0 who_n_39_0 0 40p
Rwp_39_0 who_p_39_0 wcm 2g
Rwn_39_0 who_n_39_0 wcm 2g
Xsyn_39_0 ahp39 ahn39 who_p_39_0 who_n_39_0 mop0 mon0 vdd vbsyn gsynR
Cwp_40_0 who_p_40_0 0 40p
Cwn_40_0 who_n_40_0 0 40p
Rwp_40_0 who_p_40_0 wcm 2g
Rwn_40_0 who_n_40_0 wcm 2g
Xsyn_40_0 ahp40 ahn40 who_p_40_0 who_n_40_0 mop0 mon0 vdd vbsyn gsynR
Cwp_41_0 who_p_41_0 0 40p
Cwn_41_0 who_n_41_0 0 40p
Rwp_41_0 who_p_41_0 wcm 2g
Rwn_41_0 who_n_41_0 wcm 2g
Xsyn_41_0 ahp41 ahn41 who_p_41_0 who_n_41_0 mop0 mon0 vdd vbsyn gsynR
Cwp_42_0 who_p_42_0 0 40p
Cwn_42_0 who_n_42_0 0 40p
Rwp_42_0 who_p_42_0 wcm 2g
Rwn_42_0 who_n_42_0 wcm 2g
Xsyn_42_0 ahp42 ahn42 who_p_42_0 who_n_42_0 mop0 mon0 vdd vbsyn gsynR
Cwp_43_0 who_p_43_0 0 40p
Cwn_43_0 who_n_43_0 0 40p
Rwp_43_0 who_p_43_0 wcm 2g
Rwn_43_0 who_n_43_0 wcm 2g
Xsyn_43_0 ahp43 ahn43 who_p_43_0 who_n_43_0 mop0 mon0 vdd vbsyn gsynR
Cwp_44_0 who_p_44_0 0 40p
Cwn_44_0 who_n_44_0 0 40p
Rwp_44_0 who_p_44_0 wcm 2g
Rwn_44_0 who_n_44_0 wcm 2g
Xsyn_44_0 ahp44 ahn44 who_p_44_0 who_n_44_0 mop0 mon0 vdd vbsyn gsynR
Cwp_45_0 who_p_45_0 0 40p
Cwn_45_0 who_n_45_0 0 40p
Rwp_45_0 who_p_45_0 wcm 2g
Rwn_45_0 who_n_45_0 wcm 2g
Xsyn_45_0 ahp45 ahn45 who_p_45_0 who_n_45_0 mop0 mon0 vdd vbsyn gsynR
Cwp_46_0 who_p_46_0 0 40p
Cwn_46_0 who_n_46_0 0 40p
Rwp_46_0 who_p_46_0 wcm 2g
Rwn_46_0 who_n_46_0 wcm 2g
Xsyn_46_0 ahp46 ahn46 who_p_46_0 who_n_46_0 mop0 mon0 vdd vbsyn gsynR
Cwp_47_0 who_p_47_0 0 40p
Cwn_47_0 who_n_47_0 0 40p
Rwp_47_0 who_p_47_0 wcm 2g
Rwn_47_0 who_n_47_0 wcm 2g
Xsyn_47_0 ahp47 ahn47 who_p_47_0 who_n_47_0 mop0 mon0 vdd vbsyn gsynR
Cwp_48_0 who_p_48_0 0 40p
Cwn_48_0 who_n_48_0 0 40p
Rwp_48_0 who_p_48_0 wcm 2g
Rwn_48_0 who_n_48_0 wcm 2g
Xsyn_48_0 ahp48 ahn48 who_p_48_0 who_n_48_0 mop0 mon0 vdd vbsyn gsynR
Cwp_49_0 who_p_49_0 0 40p
Cwn_49_0 who_n_49_0 0 40p
Rwp_49_0 who_p_49_0 wcm 2g
Rwn_49_0 who_n_49_0 wcm 2g
Xsyn_49_0 ahp49 ahn49 who_p_49_0 who_n_49_0 mop0 mon0 vdd vbsyn gsynR
Cwp_50_0 who_p_50_0 0 40p
Cwn_50_0 who_n_50_0 0 40p
Rwp_50_0 who_p_50_0 wcm 2g
Rwn_50_0 who_n_50_0 wcm 2g
Xsyn_50_0 ahp50 ahn50 who_p_50_0 who_n_50_0 mop0 mon0 vdd vbsyn gsynR
Cwp_51_0 who_p_51_0 0 40p
Cwn_51_0 who_n_51_0 0 40p
Rwp_51_0 who_p_51_0 wcm 2g
Rwn_51_0 who_n_51_0 wcm 2g
Xsyn_51_0 ahp51 ahn51 who_p_51_0 who_n_51_0 mop0 mon0 vdd vbsyn gsynR
Cwp_52_0 who_p_52_0 0 40p
Cwn_52_0 who_n_52_0 0 40p
Rwp_52_0 who_p_52_0 wcm 2g
Rwn_52_0 who_n_52_0 wcm 2g
Xsyn_52_0 ahp52 ahn52 who_p_52_0 who_n_52_0 mop0 mon0 vdd vbsyn gsynR
Cwp_53_0 who_p_53_0 0 40p
Cwn_53_0 who_n_53_0 0 40p
Rwp_53_0 who_p_53_0 wcm 2g
Rwn_53_0 who_n_53_0 wcm 2g
Xsyn_53_0 ahp53 ahn53 who_p_53_0 who_n_53_0 mop0 mon0 vdd vbsyn gsynR
Cwp_54_0 who_p_54_0 0 40p
Cwn_54_0 who_n_54_0 0 40p
Rwp_54_0 who_p_54_0 wcm 2g
Rwn_54_0 who_n_54_0 wcm 2g
Xsyn_54_0 ahp54 ahn54 who_p_54_0 who_n_54_0 mop0 mon0 vdd vbsyn gsynR
Cwp_55_0 who_p_55_0 0 40p
Cwn_55_0 who_n_55_0 0 40p
Rwp_55_0 who_p_55_0 wcm 2g
Rwn_55_0 who_n_55_0 wcm 2g
Xsyn_55_0 ahp55 ahn55 who_p_55_0 who_n_55_0 mop0 mon0 vdd vbsyn gsynR
Cwp_56_0 who_p_56_0 0 40p
Cwn_56_0 who_n_56_0 0 40p
Rwp_56_0 who_p_56_0 wcm 2g
Rwn_56_0 who_n_56_0 wcm 2g
Xsyn_56_0 ahp56 ahn56 who_p_56_0 who_n_56_0 mop0 mon0 vdd vbsyn gsynR
Cwp_57_0 who_p_57_0 0 40p
Cwn_57_0 who_n_57_0 0 40p
Rwp_57_0 who_p_57_0 wcm 2g
Rwn_57_0 who_n_57_0 wcm 2g
Xsyn_57_0 ahp57 ahn57 who_p_57_0 who_n_57_0 mop0 mon0 vdd vbsyn gsynR
Cwp_58_0 who_p_58_0 0 40p
Cwn_58_0 who_n_58_0 0 40p
Rwp_58_0 who_p_58_0 wcm 2g
Rwn_58_0 who_n_58_0 wcm 2g
Xsyn_58_0 ahp58 ahn58 who_p_58_0 who_n_58_0 mop0 mon0 vdd vbsyn gsynR
Cwp_59_0 who_p_59_0 0 40p
Cwn_59_0 who_n_59_0 0 40p
Rwp_59_0 who_p_59_0 wcm 2g
Rwn_59_0 who_n_59_0 wcm 2g
Xsyn_59_0 ahp59 ahn59 who_p_59_0 who_n_59_0 mop0 mon0 vdd vbsyn gsynR
Cwp_60_0 who_p_60_0 0 40p
Cwn_60_0 who_n_60_0 0 40p
Rwp_60_0 who_p_60_0 wcm 2g
Rwn_60_0 who_n_60_0 wcm 2g
Xsyn_60_0 ahp60 ahn60 who_p_60_0 who_n_60_0 mop0 mon0 vdd vbsyn gsynR
Cwp_61_0 who_p_61_0 0 40p
Cwn_61_0 who_n_61_0 0 40p
Rwp_61_0 who_p_61_0 wcm 2g
Rwn_61_0 who_n_61_0 wcm 2g
Xsyn_61_0 ahp61 ahn61 who_p_61_0 who_n_61_0 mop0 mon0 vdd vbsyn gsynR
Cwp_62_0 who_p_62_0 0 40p
Cwn_62_0 who_n_62_0 0 40p
Rwp_62_0 who_p_62_0 wcm 2g
Rwn_62_0 who_n_62_0 wcm 2g
Xsyn_62_0 ahp62 ahn62 who_p_62_0 who_n_62_0 mop0 mon0 vdd vbsyn gsynR
Cwp_63_0 who_p_63_0 0 40p
Cwn_63_0 who_n_63_0 0 40p
Rwp_63_0 who_p_63_0 wcm 2g
Rwn_63_0 who_n_63_0 wcm 2g
Xsyn_63_0 ahp63 ahn63 who_p_63_0 who_n_63_0 mop0 mon0 vdd vbsyn gsynR
Cwp_64_0 who_p_64_0 0 40p
Cwn_64_0 who_n_64_0 0 40p
Rwp_64_0 who_p_64_0 wcm 2g
Rwn_64_0 who_n_64_0 wcm 2g
Xsyn_64_0 ahp64 ahn64 who_p_64_0 who_n_64_0 mop0 mon0 vdd vbsyn gsynR
Cwp_65_0 who_p_65_0 0 40p
Cwn_65_0 who_n_65_0 0 40p
Rwp_65_0 who_p_65_0 wcm 2g
Rwn_65_0 who_n_65_0 wcm 2g
Xsyn_65_0 ahp65 ahn65 who_p_65_0 who_n_65_0 mop0 mon0 vdd vbsyn gsynR
Cwp_66_0 who_p_66_0 0 40p
Cwn_66_0 who_n_66_0 0 40p
Rwp_66_0 who_p_66_0 wcm 2g
Rwn_66_0 who_n_66_0 wcm 2g
Xsyn_66_0 ahp66 ahn66 who_p_66_0 who_n_66_0 mop0 mon0 vdd vbsyn gsynR
Cwp_67_0 who_p_67_0 0 40p
Cwn_67_0 who_n_67_0 0 40p
Rwp_67_0 who_p_67_0 wcm 2g
Rwn_67_0 who_n_67_0 wcm 2g
Xsyn_67_0 ahp67 ahn67 who_p_67_0 who_n_67_0 mop0 mon0 vdd vbsyn gsynR
Cwp_68_0 who_p_68_0 0 40p
Cwn_68_0 who_n_68_0 0 40p
Rwp_68_0 who_p_68_0 wcm 2g
Rwn_68_0 who_n_68_0 wcm 2g
Xsyn_68_0 ahp68 ahn68 who_p_68_0 who_n_68_0 mop0 mon0 vdd vbsyn gsynR
Cwp_69_0 who_p_69_0 0 40p
Cwn_69_0 who_n_69_0 0 40p
Rwp_69_0 who_p_69_0 wcm 2g
Rwn_69_0 who_n_69_0 wcm 2g
Xsyn_69_0 ahp69 ahn69 who_p_69_0 who_n_69_0 mop0 mon0 vdd vbsyn gsynR
Cwp_70_0 who_p_70_0 0 40p
Cwn_70_0 who_n_70_0 0 40p
Rwp_70_0 who_p_70_0 wcm 2g
Rwn_70_0 who_n_70_0 wcm 2g
Xsyn_70_0 ahp70 ahn70 who_p_70_0 who_n_70_0 mop0 mon0 vdd vbsyn gsynR
Cwp_71_0 who_p_71_0 0 40p
Cwn_71_0 who_n_71_0 0 40p
Rwp_71_0 who_p_71_0 wcm 2g
Rwn_71_0 who_n_71_0 wcm 2g
Xsyn_71_0 ahp71 ahn71 who_p_71_0 who_n_71_0 mop0 mon0 vdd vbsyn gsynR
Cwp_72_0 who_p_72_0 0 40p
Cwn_72_0 who_n_72_0 0 40p
Rwp_72_0 who_p_72_0 wcm 2g
Rwn_72_0 who_n_72_0 wcm 2g
Xsyn_72_0 ahp72 ahn72 who_p_72_0 who_n_72_0 mop0 mon0 vdd vbsyn gsynR
Cwp_73_0 who_p_73_0 0 40p
Cwn_73_0 who_n_73_0 0 40p
Rwp_73_0 who_p_73_0 wcm 2g
Rwn_73_0 who_n_73_0 wcm 2g
Xsyn_73_0 ahp73 ahn73 who_p_73_0 who_n_73_0 mop0 mon0 vdd vbsyn gsynR
Cwp_74_0 who_p_74_0 0 40p
Cwn_74_0 who_n_74_0 0 40p
Rwp_74_0 who_p_74_0 wcm 2g
Rwn_74_0 who_n_74_0 wcm 2g
Xsyn_74_0 ahp74 ahn74 who_p_74_0 who_n_74_0 mop0 mon0 vdd vbsyn gsynR
Cwp_75_0 who_p_75_0 0 40p
Cwn_75_0 who_n_75_0 0 40p
Rwp_75_0 who_p_75_0 wcm 2g
Rwn_75_0 who_n_75_0 wcm 2g
Xsyn_75_0 ahp75 ahn75 who_p_75_0 who_n_75_0 mop0 mon0 vdd vbsyn gsynR
Cwp_76_0 who_p_76_0 0 40p
Cwn_76_0 who_n_76_0 0 40p
Rwp_76_0 who_p_76_0 wcm 2g
Rwn_76_0 who_n_76_0 wcm 2g
Xsyn_76_0 ahp76 ahn76 who_p_76_0 who_n_76_0 mop0 mon0 vdd vbsyn gsynR
Cwp_77_0 who_p_77_0 0 40p
Cwn_77_0 who_n_77_0 0 40p
Rwp_77_0 who_p_77_0 wcm 2g
Rwn_77_0 who_n_77_0 wcm 2g
Xsyn_77_0 ahp77 ahn77 who_p_77_0 who_n_77_0 mop0 mon0 vdd vbsyn gsynR
Cwp_78_0 who_p_78_0 0 40p
Cwn_78_0 who_n_78_0 0 40p
Rwp_78_0 who_p_78_0 wcm 2g
Rwn_78_0 who_n_78_0 wcm 2g
Xsyn_78_0 ahp78 ahn78 who_p_78_0 who_n_78_0 mop0 mon0 vdd vbsyn gsynR
Cwp_79_0 who_p_79_0 0 40p
Cwn_79_0 who_n_79_0 0 40p
Rwp_79_0 who_p_79_0 wcm 2g
Rwn_79_0 who_n_79_0 wcm 2g
Xsyn_79_0 ahp79 ahn79 who_p_79_0 who_n_79_0 mop0 mon0 vdd vbsyn gsynR
Cwp_80_0 who_p_80_0 0 40p
Cwn_80_0 who_n_80_0 0 40p
Rwp_80_0 who_p_80_0 wcm 2g
Rwn_80_0 who_n_80_0 wcm 2g
Xsyn_80_0 ahp80 ahn80 who_p_80_0 who_n_80_0 mop0 mon0 vdd vbsyn gsynR
Cwp_81_0 who_p_81_0 0 40p
Cwn_81_0 who_n_81_0 0 40p
Rwp_81_0 who_p_81_0 wcm 2g
Rwn_81_0 who_n_81_0 wcm 2g
Xsyn_81_0 ahp81 ahn81 who_p_81_0 who_n_81_0 mop0 mon0 vdd vbsyn gsynR
Cwp_82_0 who_p_82_0 0 40p
Cwn_82_0 who_n_82_0 0 40p
Rwp_82_0 who_p_82_0 wcm 2g
Rwn_82_0 who_n_82_0 wcm 2g
Xsyn_82_0 ahp82 ahn82 who_p_82_0 who_n_82_0 mop0 mon0 vdd vbsyn gsynR
Cwp_83_0 who_p_83_0 0 40p
Cwn_83_0 who_n_83_0 0 40p
Rwp_83_0 who_p_83_0 wcm 2g
Rwn_83_0 who_n_83_0 wcm 2g
Xsyn_83_0 ahp83 ahn83 who_p_83_0 who_n_83_0 mop0 mon0 vdd vbsyn gsynR
Cwp_84_0 who_p_84_0 0 40p
Cwn_84_0 who_n_84_0 0 40p
Rwp_84_0 who_p_84_0 wcm 2g
Rwn_84_0 who_n_84_0 wcm 2g
Xsyn_84_0 ahp84 ahn84 who_p_84_0 who_n_84_0 mop0 mon0 vdd vbsyn gsynR
Cwp_85_0 who_p_85_0 0 40p
Cwn_85_0 who_n_85_0 0 40p
Rwp_85_0 who_p_85_0 wcm 2g
Rwn_85_0 who_n_85_0 wcm 2g
Xsyn_85_0 ahp85 ahn85 who_p_85_0 who_n_85_0 mop0 mon0 vdd vbsyn gsynR
Cwp_86_0 who_p_86_0 0 40p
Cwn_86_0 who_n_86_0 0 40p
Rwp_86_0 who_p_86_0 wcm 2g
Rwn_86_0 who_n_86_0 wcm 2g
Xsyn_86_0 ahp86 ahn86 who_p_86_0 who_n_86_0 mop0 mon0 vdd vbsyn gsynR
Cwp_87_0 who_p_87_0 0 40p
Cwn_87_0 who_n_87_0 0 40p
Rwp_87_0 who_p_87_0 wcm 2g
Rwn_87_0 who_n_87_0 wcm 2g
Xsyn_87_0 ahp87 ahn87 who_p_87_0 who_n_87_0 mop0 mon0 vdd vbsyn gsynR
Cwp_88_0 who_p_88_0 0 40p
Cwn_88_0 who_n_88_0 0 40p
Rwp_88_0 who_p_88_0 wcm 2g
Rwn_88_0 who_n_88_0 wcm 2g
Xsyn_88_0 ahp88 ahn88 who_p_88_0 who_n_88_0 mop0 mon0 vdd vbsyn gsynR
Cwp_89_0 who_p_89_0 0 40p
Cwn_89_0 who_n_89_0 0 40p
Rwp_89_0 who_p_89_0 wcm 2g
Rwn_89_0 who_n_89_0 wcm 2g
Xsyn_89_0 ahp89 ahn89 who_p_89_0 who_n_89_0 mop0 mon0 vdd vbsyn gsynR
Cwp_90_0 who_p_90_0 0 40p
Cwn_90_0 who_n_90_0 0 40p
Rwp_90_0 who_p_90_0 wcm 2g
Rwn_90_0 who_n_90_0 wcm 2g
Xsyn_90_0 ahp90 ahn90 who_p_90_0 who_n_90_0 mop0 mon0 vdd vbsyn gsynR
Cwp_91_0 who_p_91_0 0 40p
Cwn_91_0 who_n_91_0 0 40p
Rwp_91_0 who_p_91_0 wcm 2g
Rwn_91_0 who_n_91_0 wcm 2g
Xsyn_91_0 ahp91 ahn91 who_p_91_0 who_n_91_0 mop0 mon0 vdd vbsyn gsynR
Cwp_92_0 who_p_92_0 0 40p
Cwn_92_0 who_n_92_0 0 40p
Rwp_92_0 who_p_92_0 wcm 2g
Rwn_92_0 who_n_92_0 wcm 2g
Xsyn_92_0 ahp92 ahn92 who_p_92_0 who_n_92_0 mop0 mon0 vdd vbsyn gsynR
Cwp_93_0 who_p_93_0 0 40p
Cwn_93_0 who_n_93_0 0 40p
Rwp_93_0 who_p_93_0 wcm 2g
Rwn_93_0 who_n_93_0 wcm 2g
Xsyn_93_0 ahp93 ahn93 who_p_93_0 who_n_93_0 mop0 mon0 vdd vbsyn gsynR
Cwp_94_0 who_p_94_0 0 40p
Cwn_94_0 who_n_94_0 0 40p
Rwp_94_0 who_p_94_0 wcm 2g
Rwn_94_0 who_n_94_0 wcm 2g
Xsyn_94_0 ahp94 ahn94 who_p_94_0 who_n_94_0 mop0 mon0 vdd vbsyn gsynR
Cwp_95_0 who_p_95_0 0 40p
Cwn_95_0 who_n_95_0 0 40p
Rwp_95_0 who_p_95_0 wcm 2g
Rwn_95_0 who_n_95_0 wcm 2g
Xsyn_95_0 ahp95 ahn95 who_p_95_0 who_n_95_0 mop0 mon0 vdd vbsyn gsynR
Cwp_96_0 who_p_96_0 0 40p
Cwn_96_0 who_n_96_0 0 40p
Rwp_96_0 who_p_96_0 wcm 2g
Rwn_96_0 who_n_96_0 wcm 2g
Xsyn_96_0 ahp96 ahn96 who_p_96_0 who_n_96_0 mop0 mon0 vdd vbsyn gsynR
Cwp_97_0 who_p_97_0 0 40p
Cwn_97_0 who_n_97_0 0 40p
Rwp_97_0 who_p_97_0 wcm 2g
Rwn_97_0 who_n_97_0 wcm 2g
Xsyn_97_0 ahp97 ahn97 who_p_97_0 who_n_97_0 mop0 mon0 vdd vbsyn gsynR
Cwp_98_0 who_p_98_0 0 40p
Cwn_98_0 who_n_98_0 0 40p
Rwp_98_0 who_p_98_0 wcm 2g
Rwn_98_0 who_n_98_0 wcm 2g
Xsyn_98_0 ahp98 ahn98 who_p_98_0 who_n_98_0 mop0 mon0 vdd vbsyn gsynR
Cwp_99_0 who_p_99_0 0 40p
Cwn_99_0 who_n_99_0 0 40p
Rwp_99_0 who_p_99_0 wcm 2g
Rwn_99_0 who_n_99_0 wcm 2g
Xsyn_99_0 ahp99 ahn99 who_p_99_0 who_n_99_0 mop0 mon0 vdd vbsyn gsynR
Cwp_100_0 who_p_100_0 0 40p
Cwn_100_0 who_n_100_0 0 40p
Rwp_100_0 who_p_100_0 wcm 2g
Rwn_100_0 who_n_100_0 wcm 2g
Xsyn_100_0 ahp100 ahn100 who_p_100_0 who_n_100_0 mop0 mon0 vdd vbsyn gsynR
Cwp_101_0 who_p_101_0 0 40p
Cwn_101_0 who_n_101_0 0 40p
Rwp_101_0 who_p_101_0 wcm 2g
Rwn_101_0 who_n_101_0 wcm 2g
Xsyn_101_0 ahp101 ahn101 who_p_101_0 who_n_101_0 mop0 mon0 vdd vbsyn gsynR
Cwp_102_0 who_p_102_0 0 40p
Cwn_102_0 who_n_102_0 0 40p
Rwp_102_0 who_p_102_0 wcm 2g
Rwn_102_0 who_n_102_0 wcm 2g
Xsyn_102_0 ahp102 ahn102 who_p_102_0 who_n_102_0 mop0 mon0 vdd vbsyn gsynR
Cwp_103_0 who_p_103_0 0 40p
Cwn_103_0 who_n_103_0 0 40p
Rwp_103_0 who_p_103_0 wcm 2g
Rwn_103_0 who_n_103_0 wcm 2g
Xsyn_103_0 ahp103 ahn103 who_p_103_0 who_n_103_0 mop0 mon0 vdd vbsyn gsynR
Cwp_104_0 who_p_104_0 0 40p
Cwn_104_0 who_n_104_0 0 40p
Rwp_104_0 who_p_104_0 wcm 2g
Rwn_104_0 who_n_104_0 wcm 2g
Xsyn_104_0 ahp104 ahn104 who_p_104_0 who_n_104_0 mop0 mon0 vdd vbsyn gsynR
Cwp_105_0 who_p_105_0 0 40p
Cwn_105_0 who_n_105_0 0 40p
Rwp_105_0 who_p_105_0 wcm 2g
Rwn_105_0 who_n_105_0 wcm 2g
Xsyn_105_0 ahp105 ahn105 who_p_105_0 who_n_105_0 mop0 mon0 vdd vbsyn gsynR
Cwp_106_0 who_p_106_0 0 40p
Cwn_106_0 who_n_106_0 0 40p
Rwp_106_0 who_p_106_0 wcm 2g
Rwn_106_0 who_n_106_0 wcm 2g
Xsyn_106_0 ahp106 ahn106 who_p_106_0 who_n_106_0 mop0 mon0 vdd vbsyn gsynR
Cwp_107_0 who_p_107_0 0 40p
Cwn_107_0 who_n_107_0 0 40p
Rwp_107_0 who_p_107_0 wcm 2g
Rwn_107_0 who_n_107_0 wcm 2g
Xsyn_107_0 ahp107 ahn107 who_p_107_0 who_n_107_0 mop0 mon0 vdd vbsyn gsynR
Cwp_108_0 who_p_108_0 0 40p
Cwn_108_0 who_n_108_0 0 40p
Rwp_108_0 who_p_108_0 wcm 2g
Rwn_108_0 who_n_108_0 wcm 2g
Xsyn_108_0 ahp108 ahn108 who_p_108_0 who_n_108_0 mop0 mon0 vdd vbsyn gsynR
Cwp_109_0 who_p_109_0 0 40p
Cwn_109_0 who_n_109_0 0 40p
Rwp_109_0 who_p_109_0 wcm 2g
Rwn_109_0 who_n_109_0 wcm 2g
Xsyn_109_0 ahp109 ahn109 who_p_109_0 who_n_109_0 mop0 mon0 vdd vbsyn gsynR
Cwp_110_0 who_p_110_0 0 40p
Cwn_110_0 who_n_110_0 0 40p
Rwp_110_0 who_p_110_0 wcm 2g
Rwn_110_0 who_n_110_0 wcm 2g
Xsyn_110_0 ahp110 ahn110 who_p_110_0 who_n_110_0 mop0 mon0 vdd vbsyn gsynR
Cwp_111_0 who_p_111_0 0 40p
Cwn_111_0 who_n_111_0 0 40p
Rwp_111_0 who_p_111_0 wcm 2g
Rwn_111_0 who_n_111_0 wcm 2g
Xsyn_111_0 ahp111 ahn111 who_p_111_0 who_n_111_0 mop0 mon0 vdd vbsyn gsynR
Cwp_112_0 who_p_112_0 0 40p
Cwn_112_0 who_n_112_0 0 40p
Rwp_112_0 who_p_112_0 wcm 2g
Rwn_112_0 who_n_112_0 wcm 2g
Xsyn_112_0 ahp112 ahn112 who_p_112_0 who_n_112_0 mop0 mon0 vdd vbsyn gsynR
Cwp_113_0 who_p_113_0 0 40p
Cwn_113_0 who_n_113_0 0 40p
Rwp_113_0 who_p_113_0 wcm 2g
Rwn_113_0 who_n_113_0 wcm 2g
Xsyn_113_0 ahp113 ahn113 who_p_113_0 who_n_113_0 mop0 mon0 vdd vbsyn gsynR
Cwp_114_0 who_p_114_0 0 40p
Cwn_114_0 who_n_114_0 0 40p
Rwp_114_0 who_p_114_0 wcm 2g
Rwn_114_0 who_n_114_0 wcm 2g
Xsyn_114_0 ahp114 ahn114 who_p_114_0 who_n_114_0 mop0 mon0 vdd vbsyn gsynR
Cwp_115_0 who_p_115_0 0 40p
Cwn_115_0 who_n_115_0 0 40p
Rwp_115_0 who_p_115_0 wcm 2g
Rwn_115_0 who_n_115_0 wcm 2g
Xsyn_115_0 ahp115 ahn115 who_p_115_0 who_n_115_0 mop0 mon0 vdd vbsyn gsynR
Cwp_116_0 who_p_116_0 0 40p
Cwn_116_0 who_n_116_0 0 40p
Rwp_116_0 who_p_116_0 wcm 2g
Rwn_116_0 who_n_116_0 wcm 2g
Xsyn_116_0 ahp116 ahn116 who_p_116_0 who_n_116_0 mop0 mon0 vdd vbsyn gsynR
Cwp_117_0 who_p_117_0 0 40p
Cwn_117_0 who_n_117_0 0 40p
Rwp_117_0 who_p_117_0 wcm 2g
Rwn_117_0 who_n_117_0 wcm 2g
Xsyn_117_0 ahp117 ahn117 who_p_117_0 who_n_117_0 mop0 mon0 vdd vbsyn gsynR
Cwp_118_0 who_p_118_0 0 40p
Cwn_118_0 who_n_118_0 0 40p
Rwp_118_0 who_p_118_0 wcm 2g
Rwn_118_0 who_n_118_0 wcm 2g
Xsyn_118_0 ahp118 ahn118 who_p_118_0 who_n_118_0 mop0 mon0 vdd vbsyn gsynR
Cwp_119_0 who_p_119_0 0 40p
Cwn_119_0 who_n_119_0 0 40p
Rwp_119_0 who_p_119_0 wcm 2g
Rwn_119_0 who_n_119_0 wcm 2g
Xsyn_119_0 ahp119 ahn119 who_p_119_0 who_n_119_0 mop0 mon0 vdd vbsyn gsynR
Cwp_120_0 who_p_120_0 0 40p
Cwn_120_0 who_n_120_0 0 40p
Rwp_120_0 who_p_120_0 wcm 2g
Rwn_120_0 who_n_120_0 wcm 2g
Xsyn_120_0 ahp120 ahn120 who_p_120_0 who_n_120_0 mop0 mon0 vdd vbsyn gsynR
Cwp_121_0 who_p_121_0 0 40p
Cwn_121_0 who_n_121_0 0 40p
Rwp_121_0 who_p_121_0 wcm 2g
Rwn_121_0 who_n_121_0 wcm 2g
Xsyn_121_0 ahp121 ahn121 who_p_121_0 who_n_121_0 mop0 mon0 vdd vbsyn gsynR
Cwp_122_0 who_p_122_0 0 40p
Cwn_122_0 who_n_122_0 0 40p
Rwp_122_0 who_p_122_0 wcm 2g
Rwn_122_0 who_n_122_0 wcm 2g
Xsyn_122_0 ahp122 ahn122 who_p_122_0 who_n_122_0 mop0 mon0 vdd vbsyn gsynR
Cwp_123_0 who_p_123_0 0 40p
Cwn_123_0 who_n_123_0 0 40p
Rwp_123_0 who_p_123_0 wcm 2g
Rwn_123_0 who_n_123_0 wcm 2g
Xsyn_123_0 ahp123 ahn123 who_p_123_0 who_n_123_0 mop0 mon0 vdd vbsyn gsynR
Cwp_124_0 who_p_124_0 0 40p
Cwn_124_0 who_n_124_0 0 40p
Rwp_124_0 who_p_124_0 wcm 2g
Rwn_124_0 who_n_124_0 wcm 2g
Xsyn_124_0 ahp124 ahn124 who_p_124_0 who_n_124_0 mop0 mon0 vdd vbsyn gsynR
Cwp_125_0 who_p_125_0 0 40p
Cwn_125_0 who_n_125_0 0 40p
Rwp_125_0 who_p_125_0 wcm 2g
Rwn_125_0 who_n_125_0 wcm 2g
Xsyn_125_0 ahp125 ahn125 who_p_125_0 who_n_125_0 mop0 mon0 vdd vbsyn gsynR
Cwp_126_0 who_p_126_0 0 40p
Cwn_126_0 who_n_126_0 0 40p
Rwp_126_0 who_p_126_0 wcm 2g
Rwn_126_0 who_n_126_0 wcm 2g
Xsyn_126_0 ahp126 ahn126 who_p_126_0 who_n_126_0 mop0 mon0 vdd vbsyn gsynR
Cwp_127_0 who_p_127_0 0 40p
Cwn_127_0 who_n_127_0 0 40p
Rwp_127_0 who_p_127_0 wcm 2g
Rwn_127_0 who_n_127_0 wcm 2g
Xsyn_127_0 ahp127 ahn127 who_p_127_0 who_n_127_0 mop0 mon0 vdd vbsyn gsynR
Cwp_128_0 who_p_128_0 0 40p
Cwn_128_0 who_n_128_0 0 40p
Rwp_128_0 who_p_128_0 wcm 2g
Rwn_128_0 who_n_128_0 wcm 2g
Xsyn_128_0 ahp128 ahn128 who_p_128_0 who_n_128_0 mop0 mon0 vdd vbsyn gsynR
Cwp_129_0 who_p_129_0 0 40p
Cwn_129_0 who_n_129_0 0 40p
Rwp_129_0 who_p_129_0 wcm 2g
Rwn_129_0 who_n_129_0 wcm 2g
Xsyn_129_0 ahp129 ahn129 who_p_129_0 who_n_129_0 mop0 mon0 vdd vbsyn gsynR
Cwp_130_0 who_p_130_0 0 40p
Cwn_130_0 who_n_130_0 0 40p
Rwp_130_0 who_p_130_0 wcm 2g
Rwn_130_0 who_n_130_0 wcm 2g
Xsyn_130_0 ahp130 ahn130 who_p_130_0 who_n_130_0 mop0 mon0 vdd vbsyn gsynR
Cwp_131_0 who_p_131_0 0 40p
Cwn_131_0 who_n_131_0 0 40p
Rwp_131_0 who_p_131_0 wcm 2g
Rwn_131_0 who_n_131_0 wcm 2g
Xsyn_131_0 ahp131 ahn131 who_p_131_0 who_n_131_0 mop0 mon0 vdd vbsyn gsynR
Cwp_132_0 who_p_132_0 0 40p
Cwn_132_0 who_n_132_0 0 40p
Rwp_132_0 who_p_132_0 wcm 2g
Rwn_132_0 who_n_132_0 wcm 2g
Xsyn_132_0 ahp132 ahn132 who_p_132_0 who_n_132_0 mop0 mon0 vdd vbsyn gsynR
Cwp_133_0 who_p_133_0 0 40p
Cwn_133_0 who_n_133_0 0 40p
Rwp_133_0 who_p_133_0 wcm 2g
Rwn_133_0 who_n_133_0 wcm 2g
Xsyn_133_0 ahp133 ahn133 who_p_133_0 who_n_133_0 mop0 mon0 vdd vbsyn gsynR
Cwp_134_0 who_p_134_0 0 40p
Cwn_134_0 who_n_134_0 0 40p
Rwp_134_0 who_p_134_0 wcm 2g
Rwn_134_0 who_n_134_0 wcm 2g
Xsyn_134_0 ahp134 ahn134 who_p_134_0 who_n_134_0 mop0 mon0 vdd vbsyn gsynR
Cwp_135_0 who_p_135_0 0 40p
Cwn_135_0 who_n_135_0 0 40p
Rwp_135_0 who_p_135_0 wcm 2g
Rwn_135_0 who_n_135_0 wcm 2g
Xsyn_135_0 ahp135 ahn135 who_p_135_0 who_n_135_0 mop0 mon0 vdd vbsyn gsynR
Cwp_136_0 who_p_136_0 0 40p
Cwn_136_0 who_n_136_0 0 40p
Rwp_136_0 who_p_136_0 wcm 2g
Rwn_136_0 who_n_136_0 wcm 2g
Xsyn_136_0 ahp136 ahn136 who_p_136_0 who_n_136_0 mop0 mon0 vdd vbsyn gsynR
Cwp_137_0 who_p_137_0 0 40p
Cwn_137_0 who_n_137_0 0 40p
Rwp_137_0 who_p_137_0 wcm 2g
Rwn_137_0 who_n_137_0 wcm 2g
Xsyn_137_0 ahp137 ahn137 who_p_137_0 who_n_137_0 mop0 mon0 vdd vbsyn gsynR
Cwp_138_0 who_p_138_0 0 40p
Cwn_138_0 who_n_138_0 0 40p
Rwp_138_0 who_p_138_0 wcm 2g
Rwn_138_0 who_n_138_0 wcm 2g
Xsyn_138_0 ahp138 ahn138 who_p_138_0 who_n_138_0 mop0 mon0 vdd vbsyn gsynR
Cwp_139_0 who_p_139_0 0 40p
Cwn_139_0 who_n_139_0 0 40p
Rwp_139_0 who_p_139_0 wcm 2g
Rwn_139_0 who_n_139_0 wcm 2g
Xsyn_139_0 ahp139 ahn139 who_p_139_0 who_n_139_0 mop0 mon0 vdd vbsyn gsynR
Cwp_140_0 who_p_140_0 0 40p
Cwn_140_0 who_n_140_0 0 40p
Rwp_140_0 who_p_140_0 wcm 2g
Rwn_140_0 who_n_140_0 wcm 2g
Xsyn_140_0 ahp140 ahn140 who_p_140_0 who_n_140_0 mop0 mon0 vdd vbsyn gsynR
Cwp_141_0 who_p_141_0 0 40p
Cwn_141_0 who_n_141_0 0 40p
Rwp_141_0 who_p_141_0 wcm 2g
Rwn_141_0 who_n_141_0 wcm 2g
Xsyn_141_0 ahp141 ahn141 who_p_141_0 who_n_141_0 mop0 mon0 vdd vbsyn gsynR
Cwp_142_0 who_p_142_0 0 40p
Cwn_142_0 who_n_142_0 0 40p
Rwp_142_0 who_p_142_0 wcm 2g
Rwn_142_0 who_n_142_0 wcm 2g
Xsyn_142_0 ahp142 ahn142 who_p_142_0 who_n_142_0 mop0 mon0 vdd vbsyn gsynR
Cwp_143_0 who_p_143_0 0 40p
Cwn_143_0 who_n_143_0 0 40p
Rwp_143_0 who_p_143_0 wcm 2g
Rwn_143_0 who_n_143_0 wcm 2g
Xsyn_143_0 ahp143 ahn143 who_p_143_0 who_n_143_0 mop0 mon0 vdd vbsyn gsynR
Cwp_144_0 who_p_144_0 0 40p
Cwn_144_0 who_n_144_0 0 40p
Rwp_144_0 who_p_144_0 wcm 2g
Rwn_144_0 who_n_144_0 wcm 2g
Xsyn_144_0 ahp144 ahn144 who_p_144_0 who_n_144_0 mop0 mon0 vdd vbsyn gsynR
Cwp_145_0 who_p_145_0 0 40p
Cwn_145_0 who_n_145_0 0 40p
Rwp_145_0 who_p_145_0 wcm 2g
Rwn_145_0 who_n_145_0 wcm 2g
Xsyn_145_0 ahp145 ahn145 who_p_145_0 who_n_145_0 mop0 mon0 vdd vbsyn gsynR
Cwp_146_0 who_p_146_0 0 40p
Cwn_146_0 who_n_146_0 0 40p
Rwp_146_0 who_p_146_0 wcm 2g
Rwn_146_0 who_n_146_0 wcm 2g
Xsyn_146_0 ahp146 ahn146 who_p_146_0 who_n_146_0 mop0 mon0 vdd vbsyn gsynR
Cwp_147_0 who_p_147_0 0 40p
Cwn_147_0 who_n_147_0 0 40p
Rwp_147_0 who_p_147_0 wcm 2g
Rwn_147_0 who_n_147_0 wcm 2g
Xsyn_147_0 ahp147 ahn147 who_p_147_0 who_n_147_0 mop0 mon0 vdd vbsyn gsynR
Cwp_148_0 who_p_148_0 0 40p
Cwn_148_0 who_n_148_0 0 40p
Rwp_148_0 who_p_148_0 wcm 2g
Rwn_148_0 who_n_148_0 wcm 2g
Xsyn_148_0 ahp148 ahn148 who_p_148_0 who_n_148_0 mop0 mon0 vdd vbsyn gsynR
Cwp_149_0 who_p_149_0 0 40p
Cwn_149_0 who_n_149_0 0 40p
Rwp_149_0 who_p_149_0 wcm 2g
Rwn_149_0 who_n_149_0 wcm 2g
Xsyn_149_0 ahp149 ahn149 who_p_149_0 who_n_149_0 mop0 mon0 vdd vbsyn gsynR
Cwp_150_0 who_p_150_0 0 40p
Cwn_150_0 who_n_150_0 0 40p
Rwp_150_0 who_p_150_0 wcm 2g
Rwn_150_0 who_n_150_0 wcm 2g
Xsyn_150_0 ahp150 ahn150 who_p_150_0 who_n_150_0 mop0 mon0 vdd vbsyn gsynR
Cwp_151_0 who_p_151_0 0 40p
Cwn_151_0 who_n_151_0 0 40p
Rwp_151_0 who_p_151_0 wcm 2g
Rwn_151_0 who_n_151_0 wcm 2g
Xsyn_151_0 ahp151 ahn151 who_p_151_0 who_n_151_0 mop0 mon0 vdd vbsyn gsynR
Cwp_152_0 who_p_152_0 0 40p
Cwn_152_0 who_n_152_0 0 40p
Rwp_152_0 who_p_152_0 wcm 2g
Rwn_152_0 who_n_152_0 wcm 2g
Xsyn_152_0 ahp152 ahn152 who_p_152_0 who_n_152_0 mop0 mon0 vdd vbsyn gsynR
Cwp_153_0 who_p_153_0 0 40p
Cwn_153_0 who_n_153_0 0 40p
Rwp_153_0 who_p_153_0 wcm 2g
Rwn_153_0 who_n_153_0 wcm 2g
Xsyn_153_0 ahp153 ahn153 who_p_153_0 who_n_153_0 mop0 mon0 vdd vbsyn gsynR
Cwp_154_0 who_p_154_0 0 40p
Cwn_154_0 who_n_154_0 0 40p
Rwp_154_0 who_p_154_0 wcm 2g
Rwn_154_0 who_n_154_0 wcm 2g
Xsyn_154_0 ahp154 ahn154 who_p_154_0 who_n_154_0 mop0 mon0 vdd vbsyn gsynR
Cwp_155_0 who_p_155_0 0 40p
Cwn_155_0 who_n_155_0 0 40p
Rwp_155_0 who_p_155_0 wcm 2g
Rwn_155_0 who_n_155_0 wcm 2g
Xsyn_155_0 ahp155 ahn155 who_p_155_0 who_n_155_0 mop0 mon0 vdd vbsyn gsynR
Cwp_156_0 who_p_156_0 0 40p
Cwn_156_0 who_n_156_0 0 40p
Rwp_156_0 who_p_156_0 wcm 2g
Rwn_156_0 who_n_156_0 wcm 2g
Xsyn_156_0 ahp156 ahn156 who_p_156_0 who_n_156_0 mop0 mon0 vdd vbsyn gsynR
Cwp_157_0 who_p_157_0 0 40p
Cwn_157_0 who_n_157_0 0 40p
Rwp_157_0 who_p_157_0 wcm 2g
Rwn_157_0 who_n_157_0 wcm 2g
Xsyn_157_0 ahp157 ahn157 who_p_157_0 who_n_157_0 mop0 mon0 vdd vbsyn gsynR
Cwp_158_0 who_p_158_0 0 40p
Cwn_158_0 who_n_158_0 0 40p
Rwp_158_0 who_p_158_0 wcm 2g
Rwn_158_0 who_n_158_0 wcm 2g
Xsyn_158_0 ahp158 ahn158 who_p_158_0 who_n_158_0 mop0 mon0 vdd vbsyn gsynR
Cwp_159_0 who_p_159_0 0 40p
Cwn_159_0 who_n_159_0 0 40p
Rwp_159_0 who_p_159_0 wcm 2g
Rwn_159_0 who_n_159_0 wcm 2g
Xsyn_159_0 ahp159 ahn159 who_p_159_0 who_n_159_0 mop0 mon0 vdd vbsyn gsynR
Cwp_160_0 who_p_160_0 0 40p
Cwn_160_0 who_n_160_0 0 40p
Rwp_160_0 who_p_160_0 wcm 2g
Rwn_160_0 who_n_160_0 wcm 2g
Xsyn_160_0 ahbias_p ahbias_n who_p_160_0 who_n_160_0 mop0 mon0 vdd vbsyn gsynR
Xeo0 xop0 xon0 mop0 mon0 eop0 eon0 vdd gm esub
Xcm_mo1 mop1 mon1 vdd cmldW
Rmo1 mop1 mon1 20k
Cmo1p mop1 0 1e-13
Cmo1n mon1 0 1e-13
Cwp_0_1 who_p_0_1 0 40p
Cwn_0_1 who_n_0_1 0 40p
Rwp_0_1 who_p_0_1 wcm 2g
Rwn_0_1 who_n_0_1 wcm 2g
Xsyn_0_1 ahp0 ahn0 who_p_0_1 who_n_0_1 mop1 mon1 vdd vbsyn gsynR
Cwp_1_1 who_p_1_1 0 40p
Cwn_1_1 who_n_1_1 0 40p
Rwp_1_1 who_p_1_1 wcm 2g
Rwn_1_1 who_n_1_1 wcm 2g
Xsyn_1_1 ahp1 ahn1 who_p_1_1 who_n_1_1 mop1 mon1 vdd vbsyn gsynR
Cwp_2_1 who_p_2_1 0 40p
Cwn_2_1 who_n_2_1 0 40p
Rwp_2_1 who_p_2_1 wcm 2g
Rwn_2_1 who_n_2_1 wcm 2g
Xsyn_2_1 ahp2 ahn2 who_p_2_1 who_n_2_1 mop1 mon1 vdd vbsyn gsynR
Cwp_3_1 who_p_3_1 0 40p
Cwn_3_1 who_n_3_1 0 40p
Rwp_3_1 who_p_3_1 wcm 2g
Rwn_3_1 who_n_3_1 wcm 2g
Xsyn_3_1 ahp3 ahn3 who_p_3_1 who_n_3_1 mop1 mon1 vdd vbsyn gsynR
Cwp_4_1 who_p_4_1 0 40p
Cwn_4_1 who_n_4_1 0 40p
Rwp_4_1 who_p_4_1 wcm 2g
Rwn_4_1 who_n_4_1 wcm 2g
Xsyn_4_1 ahp4 ahn4 who_p_4_1 who_n_4_1 mop1 mon1 vdd vbsyn gsynR
Cwp_5_1 who_p_5_1 0 40p
Cwn_5_1 who_n_5_1 0 40p
Rwp_5_1 who_p_5_1 wcm 2g
Rwn_5_1 who_n_5_1 wcm 2g
Xsyn_5_1 ahp5 ahn5 who_p_5_1 who_n_5_1 mop1 mon1 vdd vbsyn gsynR
Cwp_6_1 who_p_6_1 0 40p
Cwn_6_1 who_n_6_1 0 40p
Rwp_6_1 who_p_6_1 wcm 2g
Rwn_6_1 who_n_6_1 wcm 2g
Xsyn_6_1 ahp6 ahn6 who_p_6_1 who_n_6_1 mop1 mon1 vdd vbsyn gsynR
Cwp_7_1 who_p_7_1 0 40p
Cwn_7_1 who_n_7_1 0 40p
Rwp_7_1 who_p_7_1 wcm 2g
Rwn_7_1 who_n_7_1 wcm 2g
Xsyn_7_1 ahp7 ahn7 who_p_7_1 who_n_7_1 mop1 mon1 vdd vbsyn gsynR
Cwp_8_1 who_p_8_1 0 40p
Cwn_8_1 who_n_8_1 0 40p
Rwp_8_1 who_p_8_1 wcm 2g
Rwn_8_1 who_n_8_1 wcm 2g
Xsyn_8_1 ahp8 ahn8 who_p_8_1 who_n_8_1 mop1 mon1 vdd vbsyn gsynR
Cwp_9_1 who_p_9_1 0 40p
Cwn_9_1 who_n_9_1 0 40p
Rwp_9_1 who_p_9_1 wcm 2g
Rwn_9_1 who_n_9_1 wcm 2g
Xsyn_9_1 ahp9 ahn9 who_p_9_1 who_n_9_1 mop1 mon1 vdd vbsyn gsynR
Cwp_10_1 who_p_10_1 0 40p
Cwn_10_1 who_n_10_1 0 40p
Rwp_10_1 who_p_10_1 wcm 2g
Rwn_10_1 who_n_10_1 wcm 2g
Xsyn_10_1 ahp10 ahn10 who_p_10_1 who_n_10_1 mop1 mon1 vdd vbsyn gsynR
Cwp_11_1 who_p_11_1 0 40p
Cwn_11_1 who_n_11_1 0 40p
Rwp_11_1 who_p_11_1 wcm 2g
Rwn_11_1 who_n_11_1 wcm 2g
Xsyn_11_1 ahp11 ahn11 who_p_11_1 who_n_11_1 mop1 mon1 vdd vbsyn gsynR
Cwp_12_1 who_p_12_1 0 40p
Cwn_12_1 who_n_12_1 0 40p
Rwp_12_1 who_p_12_1 wcm 2g
Rwn_12_1 who_n_12_1 wcm 2g
Xsyn_12_1 ahp12 ahn12 who_p_12_1 who_n_12_1 mop1 mon1 vdd vbsyn gsynR
Cwp_13_1 who_p_13_1 0 40p
Cwn_13_1 who_n_13_1 0 40p
Rwp_13_1 who_p_13_1 wcm 2g
Rwn_13_1 who_n_13_1 wcm 2g
Xsyn_13_1 ahp13 ahn13 who_p_13_1 who_n_13_1 mop1 mon1 vdd vbsyn gsynR
Cwp_14_1 who_p_14_1 0 40p
Cwn_14_1 who_n_14_1 0 40p
Rwp_14_1 who_p_14_1 wcm 2g
Rwn_14_1 who_n_14_1 wcm 2g
Xsyn_14_1 ahp14 ahn14 who_p_14_1 who_n_14_1 mop1 mon1 vdd vbsyn gsynR
Cwp_15_1 who_p_15_1 0 40p
Cwn_15_1 who_n_15_1 0 40p
Rwp_15_1 who_p_15_1 wcm 2g
Rwn_15_1 who_n_15_1 wcm 2g
Xsyn_15_1 ahp15 ahn15 who_p_15_1 who_n_15_1 mop1 mon1 vdd vbsyn gsynR
Cwp_16_1 who_p_16_1 0 40p
Cwn_16_1 who_n_16_1 0 40p
Rwp_16_1 who_p_16_1 wcm 2g
Rwn_16_1 who_n_16_1 wcm 2g
Xsyn_16_1 ahp16 ahn16 who_p_16_1 who_n_16_1 mop1 mon1 vdd vbsyn gsynR
Cwp_17_1 who_p_17_1 0 40p
Cwn_17_1 who_n_17_1 0 40p
Rwp_17_1 who_p_17_1 wcm 2g
Rwn_17_1 who_n_17_1 wcm 2g
Xsyn_17_1 ahp17 ahn17 who_p_17_1 who_n_17_1 mop1 mon1 vdd vbsyn gsynR
Cwp_18_1 who_p_18_1 0 40p
Cwn_18_1 who_n_18_1 0 40p
Rwp_18_1 who_p_18_1 wcm 2g
Rwn_18_1 who_n_18_1 wcm 2g
Xsyn_18_1 ahp18 ahn18 who_p_18_1 who_n_18_1 mop1 mon1 vdd vbsyn gsynR
Cwp_19_1 who_p_19_1 0 40p
Cwn_19_1 who_n_19_1 0 40p
Rwp_19_1 who_p_19_1 wcm 2g
Rwn_19_1 who_n_19_1 wcm 2g
Xsyn_19_1 ahp19 ahn19 who_p_19_1 who_n_19_1 mop1 mon1 vdd vbsyn gsynR
Cwp_20_1 who_p_20_1 0 40p
Cwn_20_1 who_n_20_1 0 40p
Rwp_20_1 who_p_20_1 wcm 2g
Rwn_20_1 who_n_20_1 wcm 2g
Xsyn_20_1 ahp20 ahn20 who_p_20_1 who_n_20_1 mop1 mon1 vdd vbsyn gsynR
Cwp_21_1 who_p_21_1 0 40p
Cwn_21_1 who_n_21_1 0 40p
Rwp_21_1 who_p_21_1 wcm 2g
Rwn_21_1 who_n_21_1 wcm 2g
Xsyn_21_1 ahp21 ahn21 who_p_21_1 who_n_21_1 mop1 mon1 vdd vbsyn gsynR
Cwp_22_1 who_p_22_1 0 40p
Cwn_22_1 who_n_22_1 0 40p
Rwp_22_1 who_p_22_1 wcm 2g
Rwn_22_1 who_n_22_1 wcm 2g
Xsyn_22_1 ahp22 ahn22 who_p_22_1 who_n_22_1 mop1 mon1 vdd vbsyn gsynR
Cwp_23_1 who_p_23_1 0 40p
Cwn_23_1 who_n_23_1 0 40p
Rwp_23_1 who_p_23_1 wcm 2g
Rwn_23_1 who_n_23_1 wcm 2g
Xsyn_23_1 ahp23 ahn23 who_p_23_1 who_n_23_1 mop1 mon1 vdd vbsyn gsynR
Cwp_24_1 who_p_24_1 0 40p
Cwn_24_1 who_n_24_1 0 40p
Rwp_24_1 who_p_24_1 wcm 2g
Rwn_24_1 who_n_24_1 wcm 2g
Xsyn_24_1 ahp24 ahn24 who_p_24_1 who_n_24_1 mop1 mon1 vdd vbsyn gsynR
Cwp_25_1 who_p_25_1 0 40p
Cwn_25_1 who_n_25_1 0 40p
Rwp_25_1 who_p_25_1 wcm 2g
Rwn_25_1 who_n_25_1 wcm 2g
Xsyn_25_1 ahp25 ahn25 who_p_25_1 who_n_25_1 mop1 mon1 vdd vbsyn gsynR
Cwp_26_1 who_p_26_1 0 40p
Cwn_26_1 who_n_26_1 0 40p
Rwp_26_1 who_p_26_1 wcm 2g
Rwn_26_1 who_n_26_1 wcm 2g
Xsyn_26_1 ahp26 ahn26 who_p_26_1 who_n_26_1 mop1 mon1 vdd vbsyn gsynR
Cwp_27_1 who_p_27_1 0 40p
Cwn_27_1 who_n_27_1 0 40p
Rwp_27_1 who_p_27_1 wcm 2g
Rwn_27_1 who_n_27_1 wcm 2g
Xsyn_27_1 ahp27 ahn27 who_p_27_1 who_n_27_1 mop1 mon1 vdd vbsyn gsynR
Cwp_28_1 who_p_28_1 0 40p
Cwn_28_1 who_n_28_1 0 40p
Rwp_28_1 who_p_28_1 wcm 2g
Rwn_28_1 who_n_28_1 wcm 2g
Xsyn_28_1 ahp28 ahn28 who_p_28_1 who_n_28_1 mop1 mon1 vdd vbsyn gsynR
Cwp_29_1 who_p_29_1 0 40p
Cwn_29_1 who_n_29_1 0 40p
Rwp_29_1 who_p_29_1 wcm 2g
Rwn_29_1 who_n_29_1 wcm 2g
Xsyn_29_1 ahp29 ahn29 who_p_29_1 who_n_29_1 mop1 mon1 vdd vbsyn gsynR
Cwp_30_1 who_p_30_1 0 40p
Cwn_30_1 who_n_30_1 0 40p
Rwp_30_1 who_p_30_1 wcm 2g
Rwn_30_1 who_n_30_1 wcm 2g
Xsyn_30_1 ahp30 ahn30 who_p_30_1 who_n_30_1 mop1 mon1 vdd vbsyn gsynR
Cwp_31_1 who_p_31_1 0 40p
Cwn_31_1 who_n_31_1 0 40p
Rwp_31_1 who_p_31_1 wcm 2g
Rwn_31_1 who_n_31_1 wcm 2g
Xsyn_31_1 ahp31 ahn31 who_p_31_1 who_n_31_1 mop1 mon1 vdd vbsyn gsynR
Cwp_32_1 who_p_32_1 0 40p
Cwn_32_1 who_n_32_1 0 40p
Rwp_32_1 who_p_32_1 wcm 2g
Rwn_32_1 who_n_32_1 wcm 2g
Xsyn_32_1 ahp32 ahn32 who_p_32_1 who_n_32_1 mop1 mon1 vdd vbsyn gsynR
Cwp_33_1 who_p_33_1 0 40p
Cwn_33_1 who_n_33_1 0 40p
Rwp_33_1 who_p_33_1 wcm 2g
Rwn_33_1 who_n_33_1 wcm 2g
Xsyn_33_1 ahp33 ahn33 who_p_33_1 who_n_33_1 mop1 mon1 vdd vbsyn gsynR
Cwp_34_1 who_p_34_1 0 40p
Cwn_34_1 who_n_34_1 0 40p
Rwp_34_1 who_p_34_1 wcm 2g
Rwn_34_1 who_n_34_1 wcm 2g
Xsyn_34_1 ahp34 ahn34 who_p_34_1 who_n_34_1 mop1 mon1 vdd vbsyn gsynR
Cwp_35_1 who_p_35_1 0 40p
Cwn_35_1 who_n_35_1 0 40p
Rwp_35_1 who_p_35_1 wcm 2g
Rwn_35_1 who_n_35_1 wcm 2g
Xsyn_35_1 ahp35 ahn35 who_p_35_1 who_n_35_1 mop1 mon1 vdd vbsyn gsynR
Cwp_36_1 who_p_36_1 0 40p
Cwn_36_1 who_n_36_1 0 40p
Rwp_36_1 who_p_36_1 wcm 2g
Rwn_36_1 who_n_36_1 wcm 2g
Xsyn_36_1 ahp36 ahn36 who_p_36_1 who_n_36_1 mop1 mon1 vdd vbsyn gsynR
Cwp_37_1 who_p_37_1 0 40p
Cwn_37_1 who_n_37_1 0 40p
Rwp_37_1 who_p_37_1 wcm 2g
Rwn_37_1 who_n_37_1 wcm 2g
Xsyn_37_1 ahp37 ahn37 who_p_37_1 who_n_37_1 mop1 mon1 vdd vbsyn gsynR
Cwp_38_1 who_p_38_1 0 40p
Cwn_38_1 who_n_38_1 0 40p
Rwp_38_1 who_p_38_1 wcm 2g
Rwn_38_1 who_n_38_1 wcm 2g
Xsyn_38_1 ahp38 ahn38 who_p_38_1 who_n_38_1 mop1 mon1 vdd vbsyn gsynR
Cwp_39_1 who_p_39_1 0 40p
Cwn_39_1 who_n_39_1 0 40p
Rwp_39_1 who_p_39_1 wcm 2g
Rwn_39_1 who_n_39_1 wcm 2g
Xsyn_39_1 ahp39 ahn39 who_p_39_1 who_n_39_1 mop1 mon1 vdd vbsyn gsynR
Cwp_40_1 who_p_40_1 0 40p
Cwn_40_1 who_n_40_1 0 40p
Rwp_40_1 who_p_40_1 wcm 2g
Rwn_40_1 who_n_40_1 wcm 2g
Xsyn_40_1 ahp40 ahn40 who_p_40_1 who_n_40_1 mop1 mon1 vdd vbsyn gsynR
Cwp_41_1 who_p_41_1 0 40p
Cwn_41_1 who_n_41_1 0 40p
Rwp_41_1 who_p_41_1 wcm 2g
Rwn_41_1 who_n_41_1 wcm 2g
Xsyn_41_1 ahp41 ahn41 who_p_41_1 who_n_41_1 mop1 mon1 vdd vbsyn gsynR
Cwp_42_1 who_p_42_1 0 40p
Cwn_42_1 who_n_42_1 0 40p
Rwp_42_1 who_p_42_1 wcm 2g
Rwn_42_1 who_n_42_1 wcm 2g
Xsyn_42_1 ahp42 ahn42 who_p_42_1 who_n_42_1 mop1 mon1 vdd vbsyn gsynR
Cwp_43_1 who_p_43_1 0 40p
Cwn_43_1 who_n_43_1 0 40p
Rwp_43_1 who_p_43_1 wcm 2g
Rwn_43_1 who_n_43_1 wcm 2g
Xsyn_43_1 ahp43 ahn43 who_p_43_1 who_n_43_1 mop1 mon1 vdd vbsyn gsynR
Cwp_44_1 who_p_44_1 0 40p
Cwn_44_1 who_n_44_1 0 40p
Rwp_44_1 who_p_44_1 wcm 2g
Rwn_44_1 who_n_44_1 wcm 2g
Xsyn_44_1 ahp44 ahn44 who_p_44_1 who_n_44_1 mop1 mon1 vdd vbsyn gsynR
Cwp_45_1 who_p_45_1 0 40p
Cwn_45_1 who_n_45_1 0 40p
Rwp_45_1 who_p_45_1 wcm 2g
Rwn_45_1 who_n_45_1 wcm 2g
Xsyn_45_1 ahp45 ahn45 who_p_45_1 who_n_45_1 mop1 mon1 vdd vbsyn gsynR
Cwp_46_1 who_p_46_1 0 40p
Cwn_46_1 who_n_46_1 0 40p
Rwp_46_1 who_p_46_1 wcm 2g
Rwn_46_1 who_n_46_1 wcm 2g
Xsyn_46_1 ahp46 ahn46 who_p_46_1 who_n_46_1 mop1 mon1 vdd vbsyn gsynR
Cwp_47_1 who_p_47_1 0 40p
Cwn_47_1 who_n_47_1 0 40p
Rwp_47_1 who_p_47_1 wcm 2g
Rwn_47_1 who_n_47_1 wcm 2g
Xsyn_47_1 ahp47 ahn47 who_p_47_1 who_n_47_1 mop1 mon1 vdd vbsyn gsynR
Cwp_48_1 who_p_48_1 0 40p
Cwn_48_1 who_n_48_1 0 40p
Rwp_48_1 who_p_48_1 wcm 2g
Rwn_48_1 who_n_48_1 wcm 2g
Xsyn_48_1 ahp48 ahn48 who_p_48_1 who_n_48_1 mop1 mon1 vdd vbsyn gsynR
Cwp_49_1 who_p_49_1 0 40p
Cwn_49_1 who_n_49_1 0 40p
Rwp_49_1 who_p_49_1 wcm 2g
Rwn_49_1 who_n_49_1 wcm 2g
Xsyn_49_1 ahp49 ahn49 who_p_49_1 who_n_49_1 mop1 mon1 vdd vbsyn gsynR
Cwp_50_1 who_p_50_1 0 40p
Cwn_50_1 who_n_50_1 0 40p
Rwp_50_1 who_p_50_1 wcm 2g
Rwn_50_1 who_n_50_1 wcm 2g
Xsyn_50_1 ahp50 ahn50 who_p_50_1 who_n_50_1 mop1 mon1 vdd vbsyn gsynR
Cwp_51_1 who_p_51_1 0 40p
Cwn_51_1 who_n_51_1 0 40p
Rwp_51_1 who_p_51_1 wcm 2g
Rwn_51_1 who_n_51_1 wcm 2g
Xsyn_51_1 ahp51 ahn51 who_p_51_1 who_n_51_1 mop1 mon1 vdd vbsyn gsynR
Cwp_52_1 who_p_52_1 0 40p
Cwn_52_1 who_n_52_1 0 40p
Rwp_52_1 who_p_52_1 wcm 2g
Rwn_52_1 who_n_52_1 wcm 2g
Xsyn_52_1 ahp52 ahn52 who_p_52_1 who_n_52_1 mop1 mon1 vdd vbsyn gsynR
Cwp_53_1 who_p_53_1 0 40p
Cwn_53_1 who_n_53_1 0 40p
Rwp_53_1 who_p_53_1 wcm 2g
Rwn_53_1 who_n_53_1 wcm 2g
Xsyn_53_1 ahp53 ahn53 who_p_53_1 who_n_53_1 mop1 mon1 vdd vbsyn gsynR
Cwp_54_1 who_p_54_1 0 40p
Cwn_54_1 who_n_54_1 0 40p
Rwp_54_1 who_p_54_1 wcm 2g
Rwn_54_1 who_n_54_1 wcm 2g
Xsyn_54_1 ahp54 ahn54 who_p_54_1 who_n_54_1 mop1 mon1 vdd vbsyn gsynR
Cwp_55_1 who_p_55_1 0 40p
Cwn_55_1 who_n_55_1 0 40p
Rwp_55_1 who_p_55_1 wcm 2g
Rwn_55_1 who_n_55_1 wcm 2g
Xsyn_55_1 ahp55 ahn55 who_p_55_1 who_n_55_1 mop1 mon1 vdd vbsyn gsynR
Cwp_56_1 who_p_56_1 0 40p
Cwn_56_1 who_n_56_1 0 40p
Rwp_56_1 who_p_56_1 wcm 2g
Rwn_56_1 who_n_56_1 wcm 2g
Xsyn_56_1 ahp56 ahn56 who_p_56_1 who_n_56_1 mop1 mon1 vdd vbsyn gsynR
Cwp_57_1 who_p_57_1 0 40p
Cwn_57_1 who_n_57_1 0 40p
Rwp_57_1 who_p_57_1 wcm 2g
Rwn_57_1 who_n_57_1 wcm 2g
Xsyn_57_1 ahp57 ahn57 who_p_57_1 who_n_57_1 mop1 mon1 vdd vbsyn gsynR
Cwp_58_1 who_p_58_1 0 40p
Cwn_58_1 who_n_58_1 0 40p
Rwp_58_1 who_p_58_1 wcm 2g
Rwn_58_1 who_n_58_1 wcm 2g
Xsyn_58_1 ahp58 ahn58 who_p_58_1 who_n_58_1 mop1 mon1 vdd vbsyn gsynR
Cwp_59_1 who_p_59_1 0 40p
Cwn_59_1 who_n_59_1 0 40p
Rwp_59_1 who_p_59_1 wcm 2g
Rwn_59_1 who_n_59_1 wcm 2g
Xsyn_59_1 ahp59 ahn59 who_p_59_1 who_n_59_1 mop1 mon1 vdd vbsyn gsynR
Cwp_60_1 who_p_60_1 0 40p
Cwn_60_1 who_n_60_1 0 40p
Rwp_60_1 who_p_60_1 wcm 2g
Rwn_60_1 who_n_60_1 wcm 2g
Xsyn_60_1 ahp60 ahn60 who_p_60_1 who_n_60_1 mop1 mon1 vdd vbsyn gsynR
Cwp_61_1 who_p_61_1 0 40p
Cwn_61_1 who_n_61_1 0 40p
Rwp_61_1 who_p_61_1 wcm 2g
Rwn_61_1 who_n_61_1 wcm 2g
Xsyn_61_1 ahp61 ahn61 who_p_61_1 who_n_61_1 mop1 mon1 vdd vbsyn gsynR
Cwp_62_1 who_p_62_1 0 40p
Cwn_62_1 who_n_62_1 0 40p
Rwp_62_1 who_p_62_1 wcm 2g
Rwn_62_1 who_n_62_1 wcm 2g
Xsyn_62_1 ahp62 ahn62 who_p_62_1 who_n_62_1 mop1 mon1 vdd vbsyn gsynR
Cwp_63_1 who_p_63_1 0 40p
Cwn_63_1 who_n_63_1 0 40p
Rwp_63_1 who_p_63_1 wcm 2g
Rwn_63_1 who_n_63_1 wcm 2g
Xsyn_63_1 ahp63 ahn63 who_p_63_1 who_n_63_1 mop1 mon1 vdd vbsyn gsynR
Cwp_64_1 who_p_64_1 0 40p
Cwn_64_1 who_n_64_1 0 40p
Rwp_64_1 who_p_64_1 wcm 2g
Rwn_64_1 who_n_64_1 wcm 2g
Xsyn_64_1 ahp64 ahn64 who_p_64_1 who_n_64_1 mop1 mon1 vdd vbsyn gsynR
Cwp_65_1 who_p_65_1 0 40p
Cwn_65_1 who_n_65_1 0 40p
Rwp_65_1 who_p_65_1 wcm 2g
Rwn_65_1 who_n_65_1 wcm 2g
Xsyn_65_1 ahp65 ahn65 who_p_65_1 who_n_65_1 mop1 mon1 vdd vbsyn gsynR
Cwp_66_1 who_p_66_1 0 40p
Cwn_66_1 who_n_66_1 0 40p
Rwp_66_1 who_p_66_1 wcm 2g
Rwn_66_1 who_n_66_1 wcm 2g
Xsyn_66_1 ahp66 ahn66 who_p_66_1 who_n_66_1 mop1 mon1 vdd vbsyn gsynR
Cwp_67_1 who_p_67_1 0 40p
Cwn_67_1 who_n_67_1 0 40p
Rwp_67_1 who_p_67_1 wcm 2g
Rwn_67_1 who_n_67_1 wcm 2g
Xsyn_67_1 ahp67 ahn67 who_p_67_1 who_n_67_1 mop1 mon1 vdd vbsyn gsynR
Cwp_68_1 who_p_68_1 0 40p
Cwn_68_1 who_n_68_1 0 40p
Rwp_68_1 who_p_68_1 wcm 2g
Rwn_68_1 who_n_68_1 wcm 2g
Xsyn_68_1 ahp68 ahn68 who_p_68_1 who_n_68_1 mop1 mon1 vdd vbsyn gsynR
Cwp_69_1 who_p_69_1 0 40p
Cwn_69_1 who_n_69_1 0 40p
Rwp_69_1 who_p_69_1 wcm 2g
Rwn_69_1 who_n_69_1 wcm 2g
Xsyn_69_1 ahp69 ahn69 who_p_69_1 who_n_69_1 mop1 mon1 vdd vbsyn gsynR
Cwp_70_1 who_p_70_1 0 40p
Cwn_70_1 who_n_70_1 0 40p
Rwp_70_1 who_p_70_1 wcm 2g
Rwn_70_1 who_n_70_1 wcm 2g
Xsyn_70_1 ahp70 ahn70 who_p_70_1 who_n_70_1 mop1 mon1 vdd vbsyn gsynR
Cwp_71_1 who_p_71_1 0 40p
Cwn_71_1 who_n_71_1 0 40p
Rwp_71_1 who_p_71_1 wcm 2g
Rwn_71_1 who_n_71_1 wcm 2g
Xsyn_71_1 ahp71 ahn71 who_p_71_1 who_n_71_1 mop1 mon1 vdd vbsyn gsynR
Cwp_72_1 who_p_72_1 0 40p
Cwn_72_1 who_n_72_1 0 40p
Rwp_72_1 who_p_72_1 wcm 2g
Rwn_72_1 who_n_72_1 wcm 2g
Xsyn_72_1 ahp72 ahn72 who_p_72_1 who_n_72_1 mop1 mon1 vdd vbsyn gsynR
Cwp_73_1 who_p_73_1 0 40p
Cwn_73_1 who_n_73_1 0 40p
Rwp_73_1 who_p_73_1 wcm 2g
Rwn_73_1 who_n_73_1 wcm 2g
Xsyn_73_1 ahp73 ahn73 who_p_73_1 who_n_73_1 mop1 mon1 vdd vbsyn gsynR
Cwp_74_1 who_p_74_1 0 40p
Cwn_74_1 who_n_74_1 0 40p
Rwp_74_1 who_p_74_1 wcm 2g
Rwn_74_1 who_n_74_1 wcm 2g
Xsyn_74_1 ahp74 ahn74 who_p_74_1 who_n_74_1 mop1 mon1 vdd vbsyn gsynR
Cwp_75_1 who_p_75_1 0 40p
Cwn_75_1 who_n_75_1 0 40p
Rwp_75_1 who_p_75_1 wcm 2g
Rwn_75_1 who_n_75_1 wcm 2g
Xsyn_75_1 ahp75 ahn75 who_p_75_1 who_n_75_1 mop1 mon1 vdd vbsyn gsynR
Cwp_76_1 who_p_76_1 0 40p
Cwn_76_1 who_n_76_1 0 40p
Rwp_76_1 who_p_76_1 wcm 2g
Rwn_76_1 who_n_76_1 wcm 2g
Xsyn_76_1 ahp76 ahn76 who_p_76_1 who_n_76_1 mop1 mon1 vdd vbsyn gsynR
Cwp_77_1 who_p_77_1 0 40p
Cwn_77_1 who_n_77_1 0 40p
Rwp_77_1 who_p_77_1 wcm 2g
Rwn_77_1 who_n_77_1 wcm 2g
Xsyn_77_1 ahp77 ahn77 who_p_77_1 who_n_77_1 mop1 mon1 vdd vbsyn gsynR
Cwp_78_1 who_p_78_1 0 40p
Cwn_78_1 who_n_78_1 0 40p
Rwp_78_1 who_p_78_1 wcm 2g
Rwn_78_1 who_n_78_1 wcm 2g
Xsyn_78_1 ahp78 ahn78 who_p_78_1 who_n_78_1 mop1 mon1 vdd vbsyn gsynR
Cwp_79_1 who_p_79_1 0 40p
Cwn_79_1 who_n_79_1 0 40p
Rwp_79_1 who_p_79_1 wcm 2g
Rwn_79_1 who_n_79_1 wcm 2g
Xsyn_79_1 ahp79 ahn79 who_p_79_1 who_n_79_1 mop1 mon1 vdd vbsyn gsynR
Cwp_80_1 who_p_80_1 0 40p
Cwn_80_1 who_n_80_1 0 40p
Rwp_80_1 who_p_80_1 wcm 2g
Rwn_80_1 who_n_80_1 wcm 2g
Xsyn_80_1 ahp80 ahn80 who_p_80_1 who_n_80_1 mop1 mon1 vdd vbsyn gsynR
Cwp_81_1 who_p_81_1 0 40p
Cwn_81_1 who_n_81_1 0 40p
Rwp_81_1 who_p_81_1 wcm 2g
Rwn_81_1 who_n_81_1 wcm 2g
Xsyn_81_1 ahp81 ahn81 who_p_81_1 who_n_81_1 mop1 mon1 vdd vbsyn gsynR
Cwp_82_1 who_p_82_1 0 40p
Cwn_82_1 who_n_82_1 0 40p
Rwp_82_1 who_p_82_1 wcm 2g
Rwn_82_1 who_n_82_1 wcm 2g
Xsyn_82_1 ahp82 ahn82 who_p_82_1 who_n_82_1 mop1 mon1 vdd vbsyn gsynR
Cwp_83_1 who_p_83_1 0 40p
Cwn_83_1 who_n_83_1 0 40p
Rwp_83_1 who_p_83_1 wcm 2g
Rwn_83_1 who_n_83_1 wcm 2g
Xsyn_83_1 ahp83 ahn83 who_p_83_1 who_n_83_1 mop1 mon1 vdd vbsyn gsynR
Cwp_84_1 who_p_84_1 0 40p
Cwn_84_1 who_n_84_1 0 40p
Rwp_84_1 who_p_84_1 wcm 2g
Rwn_84_1 who_n_84_1 wcm 2g
Xsyn_84_1 ahp84 ahn84 who_p_84_1 who_n_84_1 mop1 mon1 vdd vbsyn gsynR
Cwp_85_1 who_p_85_1 0 40p
Cwn_85_1 who_n_85_1 0 40p
Rwp_85_1 who_p_85_1 wcm 2g
Rwn_85_1 who_n_85_1 wcm 2g
Xsyn_85_1 ahp85 ahn85 who_p_85_1 who_n_85_1 mop1 mon1 vdd vbsyn gsynR
Cwp_86_1 who_p_86_1 0 40p
Cwn_86_1 who_n_86_1 0 40p
Rwp_86_1 who_p_86_1 wcm 2g
Rwn_86_1 who_n_86_1 wcm 2g
Xsyn_86_1 ahp86 ahn86 who_p_86_1 who_n_86_1 mop1 mon1 vdd vbsyn gsynR
Cwp_87_1 who_p_87_1 0 40p
Cwn_87_1 who_n_87_1 0 40p
Rwp_87_1 who_p_87_1 wcm 2g
Rwn_87_1 who_n_87_1 wcm 2g
Xsyn_87_1 ahp87 ahn87 who_p_87_1 who_n_87_1 mop1 mon1 vdd vbsyn gsynR
Cwp_88_1 who_p_88_1 0 40p
Cwn_88_1 who_n_88_1 0 40p
Rwp_88_1 who_p_88_1 wcm 2g
Rwn_88_1 who_n_88_1 wcm 2g
Xsyn_88_1 ahp88 ahn88 who_p_88_1 who_n_88_1 mop1 mon1 vdd vbsyn gsynR
Cwp_89_1 who_p_89_1 0 40p
Cwn_89_1 who_n_89_1 0 40p
Rwp_89_1 who_p_89_1 wcm 2g
Rwn_89_1 who_n_89_1 wcm 2g
Xsyn_89_1 ahp89 ahn89 who_p_89_1 who_n_89_1 mop1 mon1 vdd vbsyn gsynR
Cwp_90_1 who_p_90_1 0 40p
Cwn_90_1 who_n_90_1 0 40p
Rwp_90_1 who_p_90_1 wcm 2g
Rwn_90_1 who_n_90_1 wcm 2g
Xsyn_90_1 ahp90 ahn90 who_p_90_1 who_n_90_1 mop1 mon1 vdd vbsyn gsynR
Cwp_91_1 who_p_91_1 0 40p
Cwn_91_1 who_n_91_1 0 40p
Rwp_91_1 who_p_91_1 wcm 2g
Rwn_91_1 who_n_91_1 wcm 2g
Xsyn_91_1 ahp91 ahn91 who_p_91_1 who_n_91_1 mop1 mon1 vdd vbsyn gsynR
Cwp_92_1 who_p_92_1 0 40p
Cwn_92_1 who_n_92_1 0 40p
Rwp_92_1 who_p_92_1 wcm 2g
Rwn_92_1 who_n_92_1 wcm 2g
Xsyn_92_1 ahp92 ahn92 who_p_92_1 who_n_92_1 mop1 mon1 vdd vbsyn gsynR
Cwp_93_1 who_p_93_1 0 40p
Cwn_93_1 who_n_93_1 0 40p
Rwp_93_1 who_p_93_1 wcm 2g
Rwn_93_1 who_n_93_1 wcm 2g
Xsyn_93_1 ahp93 ahn93 who_p_93_1 who_n_93_1 mop1 mon1 vdd vbsyn gsynR
Cwp_94_1 who_p_94_1 0 40p
Cwn_94_1 who_n_94_1 0 40p
Rwp_94_1 who_p_94_1 wcm 2g
Rwn_94_1 who_n_94_1 wcm 2g
Xsyn_94_1 ahp94 ahn94 who_p_94_1 who_n_94_1 mop1 mon1 vdd vbsyn gsynR
Cwp_95_1 who_p_95_1 0 40p
Cwn_95_1 who_n_95_1 0 40p
Rwp_95_1 who_p_95_1 wcm 2g
Rwn_95_1 who_n_95_1 wcm 2g
Xsyn_95_1 ahp95 ahn95 who_p_95_1 who_n_95_1 mop1 mon1 vdd vbsyn gsynR
Cwp_96_1 who_p_96_1 0 40p
Cwn_96_1 who_n_96_1 0 40p
Rwp_96_1 who_p_96_1 wcm 2g
Rwn_96_1 who_n_96_1 wcm 2g
Xsyn_96_1 ahp96 ahn96 who_p_96_1 who_n_96_1 mop1 mon1 vdd vbsyn gsynR
Cwp_97_1 who_p_97_1 0 40p
Cwn_97_1 who_n_97_1 0 40p
Rwp_97_1 who_p_97_1 wcm 2g
Rwn_97_1 who_n_97_1 wcm 2g
Xsyn_97_1 ahp97 ahn97 who_p_97_1 who_n_97_1 mop1 mon1 vdd vbsyn gsynR
Cwp_98_1 who_p_98_1 0 40p
Cwn_98_1 who_n_98_1 0 40p
Rwp_98_1 who_p_98_1 wcm 2g
Rwn_98_1 who_n_98_1 wcm 2g
Xsyn_98_1 ahp98 ahn98 who_p_98_1 who_n_98_1 mop1 mon1 vdd vbsyn gsynR
Cwp_99_1 who_p_99_1 0 40p
Cwn_99_1 who_n_99_1 0 40p
Rwp_99_1 who_p_99_1 wcm 2g
Rwn_99_1 who_n_99_1 wcm 2g
Xsyn_99_1 ahp99 ahn99 who_p_99_1 who_n_99_1 mop1 mon1 vdd vbsyn gsynR
Cwp_100_1 who_p_100_1 0 40p
Cwn_100_1 who_n_100_1 0 40p
Rwp_100_1 who_p_100_1 wcm 2g
Rwn_100_1 who_n_100_1 wcm 2g
Xsyn_100_1 ahp100 ahn100 who_p_100_1 who_n_100_1 mop1 mon1 vdd vbsyn gsynR
Cwp_101_1 who_p_101_1 0 40p
Cwn_101_1 who_n_101_1 0 40p
Rwp_101_1 who_p_101_1 wcm 2g
Rwn_101_1 who_n_101_1 wcm 2g
Xsyn_101_1 ahp101 ahn101 who_p_101_1 who_n_101_1 mop1 mon1 vdd vbsyn gsynR
Cwp_102_1 who_p_102_1 0 40p
Cwn_102_1 who_n_102_1 0 40p
Rwp_102_1 who_p_102_1 wcm 2g
Rwn_102_1 who_n_102_1 wcm 2g
Xsyn_102_1 ahp102 ahn102 who_p_102_1 who_n_102_1 mop1 mon1 vdd vbsyn gsynR
Cwp_103_1 who_p_103_1 0 40p
Cwn_103_1 who_n_103_1 0 40p
Rwp_103_1 who_p_103_1 wcm 2g
Rwn_103_1 who_n_103_1 wcm 2g
Xsyn_103_1 ahp103 ahn103 who_p_103_1 who_n_103_1 mop1 mon1 vdd vbsyn gsynR
Cwp_104_1 who_p_104_1 0 40p
Cwn_104_1 who_n_104_1 0 40p
Rwp_104_1 who_p_104_1 wcm 2g
Rwn_104_1 who_n_104_1 wcm 2g
Xsyn_104_1 ahp104 ahn104 who_p_104_1 who_n_104_1 mop1 mon1 vdd vbsyn gsynR
Cwp_105_1 who_p_105_1 0 40p
Cwn_105_1 who_n_105_1 0 40p
Rwp_105_1 who_p_105_1 wcm 2g
Rwn_105_1 who_n_105_1 wcm 2g
Xsyn_105_1 ahp105 ahn105 who_p_105_1 who_n_105_1 mop1 mon1 vdd vbsyn gsynR
Cwp_106_1 who_p_106_1 0 40p
Cwn_106_1 who_n_106_1 0 40p
Rwp_106_1 who_p_106_1 wcm 2g
Rwn_106_1 who_n_106_1 wcm 2g
Xsyn_106_1 ahp106 ahn106 who_p_106_1 who_n_106_1 mop1 mon1 vdd vbsyn gsynR
Cwp_107_1 who_p_107_1 0 40p
Cwn_107_1 who_n_107_1 0 40p
Rwp_107_1 who_p_107_1 wcm 2g
Rwn_107_1 who_n_107_1 wcm 2g
Xsyn_107_1 ahp107 ahn107 who_p_107_1 who_n_107_1 mop1 mon1 vdd vbsyn gsynR
Cwp_108_1 who_p_108_1 0 40p
Cwn_108_1 who_n_108_1 0 40p
Rwp_108_1 who_p_108_1 wcm 2g
Rwn_108_1 who_n_108_1 wcm 2g
Xsyn_108_1 ahp108 ahn108 who_p_108_1 who_n_108_1 mop1 mon1 vdd vbsyn gsynR
Cwp_109_1 who_p_109_1 0 40p
Cwn_109_1 who_n_109_1 0 40p
Rwp_109_1 who_p_109_1 wcm 2g
Rwn_109_1 who_n_109_1 wcm 2g
Xsyn_109_1 ahp109 ahn109 who_p_109_1 who_n_109_1 mop1 mon1 vdd vbsyn gsynR
Cwp_110_1 who_p_110_1 0 40p
Cwn_110_1 who_n_110_1 0 40p
Rwp_110_1 who_p_110_1 wcm 2g
Rwn_110_1 who_n_110_1 wcm 2g
Xsyn_110_1 ahp110 ahn110 who_p_110_1 who_n_110_1 mop1 mon1 vdd vbsyn gsynR
Cwp_111_1 who_p_111_1 0 40p
Cwn_111_1 who_n_111_1 0 40p
Rwp_111_1 who_p_111_1 wcm 2g
Rwn_111_1 who_n_111_1 wcm 2g
Xsyn_111_1 ahp111 ahn111 who_p_111_1 who_n_111_1 mop1 mon1 vdd vbsyn gsynR
Cwp_112_1 who_p_112_1 0 40p
Cwn_112_1 who_n_112_1 0 40p
Rwp_112_1 who_p_112_1 wcm 2g
Rwn_112_1 who_n_112_1 wcm 2g
Xsyn_112_1 ahp112 ahn112 who_p_112_1 who_n_112_1 mop1 mon1 vdd vbsyn gsynR
Cwp_113_1 who_p_113_1 0 40p
Cwn_113_1 who_n_113_1 0 40p
Rwp_113_1 who_p_113_1 wcm 2g
Rwn_113_1 who_n_113_1 wcm 2g
Xsyn_113_1 ahp113 ahn113 who_p_113_1 who_n_113_1 mop1 mon1 vdd vbsyn gsynR
Cwp_114_1 who_p_114_1 0 40p
Cwn_114_1 who_n_114_1 0 40p
Rwp_114_1 who_p_114_1 wcm 2g
Rwn_114_1 who_n_114_1 wcm 2g
Xsyn_114_1 ahp114 ahn114 who_p_114_1 who_n_114_1 mop1 mon1 vdd vbsyn gsynR
Cwp_115_1 who_p_115_1 0 40p
Cwn_115_1 who_n_115_1 0 40p
Rwp_115_1 who_p_115_1 wcm 2g
Rwn_115_1 who_n_115_1 wcm 2g
Xsyn_115_1 ahp115 ahn115 who_p_115_1 who_n_115_1 mop1 mon1 vdd vbsyn gsynR
Cwp_116_1 who_p_116_1 0 40p
Cwn_116_1 who_n_116_1 0 40p
Rwp_116_1 who_p_116_1 wcm 2g
Rwn_116_1 who_n_116_1 wcm 2g
Xsyn_116_1 ahp116 ahn116 who_p_116_1 who_n_116_1 mop1 mon1 vdd vbsyn gsynR
Cwp_117_1 who_p_117_1 0 40p
Cwn_117_1 who_n_117_1 0 40p
Rwp_117_1 who_p_117_1 wcm 2g
Rwn_117_1 who_n_117_1 wcm 2g
Xsyn_117_1 ahp117 ahn117 who_p_117_1 who_n_117_1 mop1 mon1 vdd vbsyn gsynR
Cwp_118_1 who_p_118_1 0 40p
Cwn_118_1 who_n_118_1 0 40p
Rwp_118_1 who_p_118_1 wcm 2g
Rwn_118_1 who_n_118_1 wcm 2g
Xsyn_118_1 ahp118 ahn118 who_p_118_1 who_n_118_1 mop1 mon1 vdd vbsyn gsynR
Cwp_119_1 who_p_119_1 0 40p
Cwn_119_1 who_n_119_1 0 40p
Rwp_119_1 who_p_119_1 wcm 2g
Rwn_119_1 who_n_119_1 wcm 2g
Xsyn_119_1 ahp119 ahn119 who_p_119_1 who_n_119_1 mop1 mon1 vdd vbsyn gsynR
Cwp_120_1 who_p_120_1 0 40p
Cwn_120_1 who_n_120_1 0 40p
Rwp_120_1 who_p_120_1 wcm 2g
Rwn_120_1 who_n_120_1 wcm 2g
Xsyn_120_1 ahp120 ahn120 who_p_120_1 who_n_120_1 mop1 mon1 vdd vbsyn gsynR
Cwp_121_1 who_p_121_1 0 40p
Cwn_121_1 who_n_121_1 0 40p
Rwp_121_1 who_p_121_1 wcm 2g
Rwn_121_1 who_n_121_1 wcm 2g
Xsyn_121_1 ahp121 ahn121 who_p_121_1 who_n_121_1 mop1 mon1 vdd vbsyn gsynR
Cwp_122_1 who_p_122_1 0 40p
Cwn_122_1 who_n_122_1 0 40p
Rwp_122_1 who_p_122_1 wcm 2g
Rwn_122_1 who_n_122_1 wcm 2g
Xsyn_122_1 ahp122 ahn122 who_p_122_1 who_n_122_1 mop1 mon1 vdd vbsyn gsynR
Cwp_123_1 who_p_123_1 0 40p
Cwn_123_1 who_n_123_1 0 40p
Rwp_123_1 who_p_123_1 wcm 2g
Rwn_123_1 who_n_123_1 wcm 2g
Xsyn_123_1 ahp123 ahn123 who_p_123_1 who_n_123_1 mop1 mon1 vdd vbsyn gsynR
Cwp_124_1 who_p_124_1 0 40p
Cwn_124_1 who_n_124_1 0 40p
Rwp_124_1 who_p_124_1 wcm 2g
Rwn_124_1 who_n_124_1 wcm 2g
Xsyn_124_1 ahp124 ahn124 who_p_124_1 who_n_124_1 mop1 mon1 vdd vbsyn gsynR
Cwp_125_1 who_p_125_1 0 40p
Cwn_125_1 who_n_125_1 0 40p
Rwp_125_1 who_p_125_1 wcm 2g
Rwn_125_1 who_n_125_1 wcm 2g
Xsyn_125_1 ahp125 ahn125 who_p_125_1 who_n_125_1 mop1 mon1 vdd vbsyn gsynR
Cwp_126_1 who_p_126_1 0 40p
Cwn_126_1 who_n_126_1 0 40p
Rwp_126_1 who_p_126_1 wcm 2g
Rwn_126_1 who_n_126_1 wcm 2g
Xsyn_126_1 ahp126 ahn126 who_p_126_1 who_n_126_1 mop1 mon1 vdd vbsyn gsynR
Cwp_127_1 who_p_127_1 0 40p
Cwn_127_1 who_n_127_1 0 40p
Rwp_127_1 who_p_127_1 wcm 2g
Rwn_127_1 who_n_127_1 wcm 2g
Xsyn_127_1 ahp127 ahn127 who_p_127_1 who_n_127_1 mop1 mon1 vdd vbsyn gsynR
Cwp_128_1 who_p_128_1 0 40p
Cwn_128_1 who_n_128_1 0 40p
Rwp_128_1 who_p_128_1 wcm 2g
Rwn_128_1 who_n_128_1 wcm 2g
Xsyn_128_1 ahp128 ahn128 who_p_128_1 who_n_128_1 mop1 mon1 vdd vbsyn gsynR
Cwp_129_1 who_p_129_1 0 40p
Cwn_129_1 who_n_129_1 0 40p
Rwp_129_1 who_p_129_1 wcm 2g
Rwn_129_1 who_n_129_1 wcm 2g
Xsyn_129_1 ahp129 ahn129 who_p_129_1 who_n_129_1 mop1 mon1 vdd vbsyn gsynR
Cwp_130_1 who_p_130_1 0 40p
Cwn_130_1 who_n_130_1 0 40p
Rwp_130_1 who_p_130_1 wcm 2g
Rwn_130_1 who_n_130_1 wcm 2g
Xsyn_130_1 ahp130 ahn130 who_p_130_1 who_n_130_1 mop1 mon1 vdd vbsyn gsynR
Cwp_131_1 who_p_131_1 0 40p
Cwn_131_1 who_n_131_1 0 40p
Rwp_131_1 who_p_131_1 wcm 2g
Rwn_131_1 who_n_131_1 wcm 2g
Xsyn_131_1 ahp131 ahn131 who_p_131_1 who_n_131_1 mop1 mon1 vdd vbsyn gsynR
Cwp_132_1 who_p_132_1 0 40p
Cwn_132_1 who_n_132_1 0 40p
Rwp_132_1 who_p_132_1 wcm 2g
Rwn_132_1 who_n_132_1 wcm 2g
Xsyn_132_1 ahp132 ahn132 who_p_132_1 who_n_132_1 mop1 mon1 vdd vbsyn gsynR
Cwp_133_1 who_p_133_1 0 40p
Cwn_133_1 who_n_133_1 0 40p
Rwp_133_1 who_p_133_1 wcm 2g
Rwn_133_1 who_n_133_1 wcm 2g
Xsyn_133_1 ahp133 ahn133 who_p_133_1 who_n_133_1 mop1 mon1 vdd vbsyn gsynR
Cwp_134_1 who_p_134_1 0 40p
Cwn_134_1 who_n_134_1 0 40p
Rwp_134_1 who_p_134_1 wcm 2g
Rwn_134_1 who_n_134_1 wcm 2g
Xsyn_134_1 ahp134 ahn134 who_p_134_1 who_n_134_1 mop1 mon1 vdd vbsyn gsynR
Cwp_135_1 who_p_135_1 0 40p
Cwn_135_1 who_n_135_1 0 40p
Rwp_135_1 who_p_135_1 wcm 2g
Rwn_135_1 who_n_135_1 wcm 2g
Xsyn_135_1 ahp135 ahn135 who_p_135_1 who_n_135_1 mop1 mon1 vdd vbsyn gsynR
Cwp_136_1 who_p_136_1 0 40p
Cwn_136_1 who_n_136_1 0 40p
Rwp_136_1 who_p_136_1 wcm 2g
Rwn_136_1 who_n_136_1 wcm 2g
Xsyn_136_1 ahp136 ahn136 who_p_136_1 who_n_136_1 mop1 mon1 vdd vbsyn gsynR
Cwp_137_1 who_p_137_1 0 40p
Cwn_137_1 who_n_137_1 0 40p
Rwp_137_1 who_p_137_1 wcm 2g
Rwn_137_1 who_n_137_1 wcm 2g
Xsyn_137_1 ahp137 ahn137 who_p_137_1 who_n_137_1 mop1 mon1 vdd vbsyn gsynR
Cwp_138_1 who_p_138_1 0 40p
Cwn_138_1 who_n_138_1 0 40p
Rwp_138_1 who_p_138_1 wcm 2g
Rwn_138_1 who_n_138_1 wcm 2g
Xsyn_138_1 ahp138 ahn138 who_p_138_1 who_n_138_1 mop1 mon1 vdd vbsyn gsynR
Cwp_139_1 who_p_139_1 0 40p
Cwn_139_1 who_n_139_1 0 40p
Rwp_139_1 who_p_139_1 wcm 2g
Rwn_139_1 who_n_139_1 wcm 2g
Xsyn_139_1 ahp139 ahn139 who_p_139_1 who_n_139_1 mop1 mon1 vdd vbsyn gsynR
Cwp_140_1 who_p_140_1 0 40p
Cwn_140_1 who_n_140_1 0 40p
Rwp_140_1 who_p_140_1 wcm 2g
Rwn_140_1 who_n_140_1 wcm 2g
Xsyn_140_1 ahp140 ahn140 who_p_140_1 who_n_140_1 mop1 mon1 vdd vbsyn gsynR
Cwp_141_1 who_p_141_1 0 40p
Cwn_141_1 who_n_141_1 0 40p
Rwp_141_1 who_p_141_1 wcm 2g
Rwn_141_1 who_n_141_1 wcm 2g
Xsyn_141_1 ahp141 ahn141 who_p_141_1 who_n_141_1 mop1 mon1 vdd vbsyn gsynR
Cwp_142_1 who_p_142_1 0 40p
Cwn_142_1 who_n_142_1 0 40p
Rwp_142_1 who_p_142_1 wcm 2g
Rwn_142_1 who_n_142_1 wcm 2g
Xsyn_142_1 ahp142 ahn142 who_p_142_1 who_n_142_1 mop1 mon1 vdd vbsyn gsynR
Cwp_143_1 who_p_143_1 0 40p
Cwn_143_1 who_n_143_1 0 40p
Rwp_143_1 who_p_143_1 wcm 2g
Rwn_143_1 who_n_143_1 wcm 2g
Xsyn_143_1 ahp143 ahn143 who_p_143_1 who_n_143_1 mop1 mon1 vdd vbsyn gsynR
Cwp_144_1 who_p_144_1 0 40p
Cwn_144_1 who_n_144_1 0 40p
Rwp_144_1 who_p_144_1 wcm 2g
Rwn_144_1 who_n_144_1 wcm 2g
Xsyn_144_1 ahp144 ahn144 who_p_144_1 who_n_144_1 mop1 mon1 vdd vbsyn gsynR
Cwp_145_1 who_p_145_1 0 40p
Cwn_145_1 who_n_145_1 0 40p
Rwp_145_1 who_p_145_1 wcm 2g
Rwn_145_1 who_n_145_1 wcm 2g
Xsyn_145_1 ahp145 ahn145 who_p_145_1 who_n_145_1 mop1 mon1 vdd vbsyn gsynR
Cwp_146_1 who_p_146_1 0 40p
Cwn_146_1 who_n_146_1 0 40p
Rwp_146_1 who_p_146_1 wcm 2g
Rwn_146_1 who_n_146_1 wcm 2g
Xsyn_146_1 ahp146 ahn146 who_p_146_1 who_n_146_1 mop1 mon1 vdd vbsyn gsynR
Cwp_147_1 who_p_147_1 0 40p
Cwn_147_1 who_n_147_1 0 40p
Rwp_147_1 who_p_147_1 wcm 2g
Rwn_147_1 who_n_147_1 wcm 2g
Xsyn_147_1 ahp147 ahn147 who_p_147_1 who_n_147_1 mop1 mon1 vdd vbsyn gsynR
Cwp_148_1 who_p_148_1 0 40p
Cwn_148_1 who_n_148_1 0 40p
Rwp_148_1 who_p_148_1 wcm 2g
Rwn_148_1 who_n_148_1 wcm 2g
Xsyn_148_1 ahp148 ahn148 who_p_148_1 who_n_148_1 mop1 mon1 vdd vbsyn gsynR
Cwp_149_1 who_p_149_1 0 40p
Cwn_149_1 who_n_149_1 0 40p
Rwp_149_1 who_p_149_1 wcm 2g
Rwn_149_1 who_n_149_1 wcm 2g
Xsyn_149_1 ahp149 ahn149 who_p_149_1 who_n_149_1 mop1 mon1 vdd vbsyn gsynR
Cwp_150_1 who_p_150_1 0 40p
Cwn_150_1 who_n_150_1 0 40p
Rwp_150_1 who_p_150_1 wcm 2g
Rwn_150_1 who_n_150_1 wcm 2g
Xsyn_150_1 ahp150 ahn150 who_p_150_1 who_n_150_1 mop1 mon1 vdd vbsyn gsynR
Cwp_151_1 who_p_151_1 0 40p
Cwn_151_1 who_n_151_1 0 40p
Rwp_151_1 who_p_151_1 wcm 2g
Rwn_151_1 who_n_151_1 wcm 2g
Xsyn_151_1 ahp151 ahn151 who_p_151_1 who_n_151_1 mop1 mon1 vdd vbsyn gsynR
Cwp_152_1 who_p_152_1 0 40p
Cwn_152_1 who_n_152_1 0 40p
Rwp_152_1 who_p_152_1 wcm 2g
Rwn_152_1 who_n_152_1 wcm 2g
Xsyn_152_1 ahp152 ahn152 who_p_152_1 who_n_152_1 mop1 mon1 vdd vbsyn gsynR
Cwp_153_1 who_p_153_1 0 40p
Cwn_153_1 who_n_153_1 0 40p
Rwp_153_1 who_p_153_1 wcm 2g
Rwn_153_1 who_n_153_1 wcm 2g
Xsyn_153_1 ahp153 ahn153 who_p_153_1 who_n_153_1 mop1 mon1 vdd vbsyn gsynR
Cwp_154_1 who_p_154_1 0 40p
Cwn_154_1 who_n_154_1 0 40p
Rwp_154_1 who_p_154_1 wcm 2g
Rwn_154_1 who_n_154_1 wcm 2g
Xsyn_154_1 ahp154 ahn154 who_p_154_1 who_n_154_1 mop1 mon1 vdd vbsyn gsynR
Cwp_155_1 who_p_155_1 0 40p
Cwn_155_1 who_n_155_1 0 40p
Rwp_155_1 who_p_155_1 wcm 2g
Rwn_155_1 who_n_155_1 wcm 2g
Xsyn_155_1 ahp155 ahn155 who_p_155_1 who_n_155_1 mop1 mon1 vdd vbsyn gsynR
Cwp_156_1 who_p_156_1 0 40p
Cwn_156_1 who_n_156_1 0 40p
Rwp_156_1 who_p_156_1 wcm 2g
Rwn_156_1 who_n_156_1 wcm 2g
Xsyn_156_1 ahp156 ahn156 who_p_156_1 who_n_156_1 mop1 mon1 vdd vbsyn gsynR
Cwp_157_1 who_p_157_1 0 40p
Cwn_157_1 who_n_157_1 0 40p
Rwp_157_1 who_p_157_1 wcm 2g
Rwn_157_1 who_n_157_1 wcm 2g
Xsyn_157_1 ahp157 ahn157 who_p_157_1 who_n_157_1 mop1 mon1 vdd vbsyn gsynR
Cwp_158_1 who_p_158_1 0 40p
Cwn_158_1 who_n_158_1 0 40p
Rwp_158_1 who_p_158_1 wcm 2g
Rwn_158_1 who_n_158_1 wcm 2g
Xsyn_158_1 ahp158 ahn158 who_p_158_1 who_n_158_1 mop1 mon1 vdd vbsyn gsynR
Cwp_159_1 who_p_159_1 0 40p
Cwn_159_1 who_n_159_1 0 40p
Rwp_159_1 who_p_159_1 wcm 2g
Rwn_159_1 who_n_159_1 wcm 2g
Xsyn_159_1 ahp159 ahn159 who_p_159_1 who_n_159_1 mop1 mon1 vdd vbsyn gsynR
Cwp_160_1 who_p_160_1 0 40p
Cwn_160_1 who_n_160_1 0 40p
Rwp_160_1 who_p_160_1 wcm 2g
Rwn_160_1 who_n_160_1 wcm 2g
Xsyn_160_1 ahbias_p ahbias_n who_p_160_1 who_n_160_1 mop1 mon1 vdd vbsyn gsynR
Xeo1 xop1 xon1 mop1 mon1 eop1 eon1 vdd gm esub
Xsc0 xop0 xon0 mop0 mon0 sop son vdd vbsyn gsyn
Xsc1 xop1 xon1 mop1 mon1 sop son vdd vbsyn gsyn
Xcm_s sop son vdd cmld
Rs sop son 40k
Vth sref 0 PWL(0.0n 0.95000 129.9n 0.95000 130.0n 0.95000 259.9n 0.95000 260.0n 0.95000 389.9n 0.95000 390.0n 0.95000 519.9n 0.95000 520.0n 0.95000 649.9n 0.95000 650.0n 0.95000 779.9n 0.95000 780.0n 0.95000 909.9n 0.95000 910.0n 0.95000 1039.9n 0.95000 1040.0n 0.95000 1169.9n 0.95000 1170.0n 0.95000 1299.9n 0.95000 1300.0n 0.95000 1429.9n 0.95000 1430.0n 0.95000 1559.9n 0.95000 1560.0n 0.95000 1689.9n 0.95000 1690.0n 0.95000 1819.9n 0.95000 1820.0n 0.95000 1949.9n 0.95000 1950.0n 0.95000 2079.9n 0.95000 2080.0n 0.95000 2209.9n 0.95000 2210.0n 0.95000 2339.9n 0.95000 2340.0n 0.95000 2469.9n 0.95000 2470.0n 0.95000 2599.9n 0.95000 2600.0n 0.95000 2729.9n 0.95000 2730.0n 0.95000 2859.9n 0.95000 2860.0n 0.95000 2989.9n 0.95000 2990.0n 0.95000 3119.9n 0.95000 3120.0n 0.95000 3249.9n 0.95000 3250.0n 0.95000 3379.9n 0.95000 3380.0n 0.95000 3509.9n 0.95000 3510.0n 0.95000 3639.9n 0.95000 3640.0n 0.95000 3769.9n 0.95000 3770.0n 0.95000 3899.9n 0.95000 3900.0n 0.95000 4029.9n 0.95000 4030.0n 0.95000 4159.9n 0.95000 4160.0n 0.95000 4289.9n 0.95000 4290.0n 0.95000 4419.9n 0.95000 4420.0n 0.95000 4549.9n 0.95000 4550.0n 0.95000 4679.9n 0.95000 4680.0n 0.95000 4809.9n 0.95000 4810.0n 0.95000 4939.9n 0.95000 4940.0n 0.95000 5069.9n 0.95000 5070.0n 0.95000 5199.9n 0.95000 5200.0n 0.95000 5329.9n 0.95000 5330.0n 0.95000 5459.9n 0.95000 5460.0n 0.95000 5589.9n 0.95000 5590.0n 0.95000 5719.9n 0.95000 5720.0n 0.95000 5849.9n 0.95000 5850.0n 0.95000 5979.9n 0.95000 5980.0n 0.95000 6109.9n 0.95000 6110.0n 0.95000 6239.9n 0.95000 6240.0n 0.95000 6369.9n 0.95000 6370.0n 0.95000 6499.9n 0.95000 6500.0n 0.95000 6629.9n 0.95000 6630.0n 0.95000 6759.9n 0.95000 6760.0n 0.95000 6889.9n 0.95000 6890.0n 0.95000 7019.9n 0.95000 7020.0n 0.95000 7149.9n 0.95000 7150.0n 0.95000 7279.9n 0.95000 7280.0n 0.95000 7409.9n 0.95000 7410.0n 0.95000 7539.9n 0.95000 7540.0n 0.95000 7669.9n 0.95000 7670.0n 0.95000 7799.9n 0.95000 7800.0n 0.95000 7929.9n 0.95000 7930.0n 0.95000 8059.9n 0.95000 8060.0n 0.95000 8189.9n 0.95000 8190.0n 0.95000 8319.9n 0.95000 8320.0n 0.95000 8449.9n 0.95000 8450.0n 0.95000 8579.9n 0.95000 8580.0n 0.95000 8709.9n 0.95000 8710.0n 0.95000 8839.9n 0.95000 8840.0n 0.95000 8969.9n 0.95000 8970.0n 0.95000 9099.9n 0.95000 9100.0n 0.95000 9229.9n 0.95000 9230.0n 0.95000 9359.9n 0.95000 9360.0n 0.95000 9489.9n 0.95000 9490.0n 0.95000 9619.9n 0.95000 9620.0n 0.95000 9749.9n 0.95000 9750.0n 0.95000 9879.9n 0.95000 9880.0n 0.95000 10009.9n 0.95000 10010.0n 0.95000 10139.9n 0.95000 10140.0n 0.95000 10269.9n 0.95000 10270.0n 0.95000 10399.9n 0.95000 10400.0n 0.95000 10529.9n 0.95000 10530.0n 0.95000 10659.9n 0.95000 10660.0n 0.95000 10789.9n 0.95000 10790.0n 0.95000 10919.9n 0.95000 10920.0n 0.95000 11049.9n 0.95000 11050.0n 0.95000 11179.9n 0.95000 11180.0n 0.95000 11309.9n 0.95000 11310.0n 0.95000 11439.9n 0.95000 11440.0n 0.95000 11569.9n 0.95000 11570.0n 0.95000 11699.9n 0.95000 11700.0n 0.95000 11829.9n 0.95000 11830.0n 0.95000 11959.9n 0.95000 11960.0n 0.95000 12089.9n 0.95000 12090.0n 0.95000 12219.9n 0.95000 12220.0n 0.95000 12349.9n 0.95000 12350.0n 0.95000 12479.9n 0.95000 12480.0n 0.95000 12609.9n 0.95000 12610.0n 0.95000 12739.9n 0.95000 12740.0n 0.95000 12869.9n 0.95000 12870.0n 0.95000 12999.9n 0.95000 13000.0n 0.95000 13129.9n 0.95000 13130.0n 0.95000 13259.9n 0.95000 13260.0n 0.95000 13389.9n 0.95000 13390.0n 0.95000 13519.9n 0.95000 13520.0n 0.95000 13649.9n 0.95000 13650.0n 0.95000 13779.9n 0.95000 13780.0n 0.95000 13909.9n 0.95000 13910.0n 0.95000 14039.9n 0.95000 14040.0n 0.95000 14169.9n 0.95000 14170.0n 0.95000 14299.9n 0.95000 14300.0n 0.95000 14429.9n 0.95000 14430.0n 0.95000 14559.9n 0.95000 14560.0n 0.95000 14689.9n 0.95000 14690.0n 0.95000 14819.9n 0.95000 14820.0n 0.95000 14949.9n 0.95000 14950.0n 0.95000 15079.9n 0.95000 15080.0n 0.95000 15209.9n 0.95000 15210.0n 0.95000 15339.9n 0.95000 15340.0n 0.95000 15469.9n 0.95000 15470.0n 0.95000 15599.9n 0.95000 15600.0n 0.95000 15729.9n 0.95000 15730.0n 0.95000 15859.9n 0.95000 15860.0n 0.95000 15989.9n 0.95000 15990.0n 0.95000 16119.9n 0.95000 16120.0n 0.95000 16249.9n 0.95000 16250.0n 0.95000 16379.9n 0.95000 16380.0n 0.95000 16509.9n 0.95000 16510.0n 0.95000 16639.9n 0.95000 16640.0n 0.95000 16769.9n 0.95000 16770.0n 0.95000 16899.9n 0.95000 16900.0n 0.95000 17029.9n 0.95000 17030.0n 0.95000 17159.9n 0.95000 17160.0n 0.95000 17289.9n 0.95000 17290.0n 0.95000 17419.9n 0.95000 17420.0n 0.95000 17549.9n 0.95000 17550.0n 0.95000 17679.9n 0.95000 17680.0n 0.95000 17809.9n 0.95000 17810.0n 0.95000 17939.9n 0.95000 17940.0n 0.95000 18069.9n 0.95000 18070.0n 0.95000 18199.9n 0.95000 18200.0n 0.95000 18329.9n 0.95000 18330.0n 0.95000 18459.9n 0.95000 18460.0n 0.95000 18589.9n 0.95000 18590.0n 0.95000 18719.9n 0.95000 18720.0n 0.95000 18849.9n 0.95000 18850.0n 0.95000 18979.9n 0.95000 18980.0n 0.95000 19109.9n 0.95000 19110.0n 0.95000 19239.9n 0.95000 19240.0n 0.95000 19369.9n 0.95000 19370.0n 0.95000 19499.9n 0.95000 19500.0n 0.95000 19629.9n 0.95000 19630.0n 0.95000 19759.9n 0.95000 19760.0n 0.95000 19889.9n 0.95000 19890.0n 0.95000 20019.9n 0.95000 20020.0n 0.95000 20149.9n 0.95000 20150.0n 0.95000 20279.9n 0.95000 20280.0n 0.95000 20409.9n 0.95000 20410.0n 0.95000 20539.9n 0.95000 20540.0n 0.95000 20669.9n 0.95000 20670.0n 0.95000 20799.9n 0.95000 20800.0n 0.95000 20929.9n 0.95000 20930.0n 0.95000 21059.9n 0.95000 21060.0n 0.95000 21189.9n 0.95000 21190.0n 0.95000 21319.9n 0.95000 21320.0n 0.95000 21449.9n 0.95000 21450.0n 0.95000 21579.9n 0.95000 21580.0n 0.95000 21709.9n 0.95000 21710.0n 0.95000 21839.9n 0.95000 21840.0n 0.95000 21969.9n 0.95000 21970.0n 0.95000 22099.9n 0.95000 22100.0n 0.95000 22229.9n 0.95000 22230.0n 0.95000 22359.9n 0.95000 22360.0n 0.95000 22489.9n 0.95000 22490.0n 0.95000 22619.9n 0.95000 22620.0n 0.95000 22749.9n 0.95000 22750.0n 0.95000 22879.9n 0.95000 22880.0n 0.95000 23009.9n 0.95000 23010.0n 0.95000 23139.9n 0.95000 23140.0n 0.95000 23269.9n 0.95000 23270.0n 0.95000 23399.9n 0.95000 23400.0n 0.95000 23529.9n 0.95000 23530.0n 0.95000 23659.9n 0.95000 23660.0n 0.95000 23789.9n 0.95000 23790.0n 0.95000 23919.9n 0.95000 23920.0n 0.95000 24049.9n 0.95000 24050.0n 0.95000 24179.9n 0.95000 24180.0n 0.95000 24309.9n 0.95000 24310.0n 0.95000 24439.9n 0.95000 24440.0n 0.95000 24569.9n 0.95000 24570.0n 0.95000 24699.9n 0.95000 24700.0n 0.95000 24829.9n 0.95000 24830.0n 0.95000 24959.9n 0.95000 24960.0n 0.95000 25089.9n 0.95000 25090.0n 0.95000 25219.9n 0.95000 25220.0n 0.95000 25349.9n 0.95000 25350.0n 0.95000 25479.9n 0.95000 25480.0n 0.95000 25609.9n 0.95000 25610.0n 0.95000 25739.9n 0.95000 25740.0n 0.95000 25869.9n 0.95000 25870.0n 0.95000 25999.9n 0.95000 26000.0n 0.95000 26129.9n 0.95000 26130.0n 0.95000 26259.9n 0.95000 26260.0n 0.95000 26389.9n 0.95000 26390.0n 0.95000 26519.9n 0.95000 26520.0n 0.95000 26649.9n 0.95000 26650.0n 0.95000 26779.9n 0.95000 26780.0n 0.95000 26909.9n 0.95000 26910.0n 0.95000 27039.9n 0.95000 27040.0n 0.95000 27169.9n 0.95000 27170.0n 0.95000 27299.9n 0.95000 27300.0n 0.95000 27429.9n 0.95000 27430.0n 0.95000 27559.9n 0.95000 27560.0n 0.95000 27689.9n 0.95000 27690.0n 0.95000 27819.9n 0.95000 27820.0n 0.95000 27949.9n 0.95000 27950.0n 0.95000 28079.9n 0.95000 28080.0n 0.95000 28209.9n 0.95000 28210.0n 0.95000 28339.9n 0.95000 28340.0n 0.95000 28469.9n 0.95000 28470.0n 0.95000 28599.9n 0.95000 28600.0n 0.95000 28729.9n 0.95000 28730.0n 0.95000 28859.9n 0.95000 28860.0n 0.95000 28989.9n 0.95000 28990.0n 0.95000 29119.9n 0.95000 29120.0n 0.95000 29249.9n 0.95000 29250.0n 0.95000 29379.9n 0.95000 29380.0n 0.95000 29509.9n 0.95000 29510.0n 0.95000 29639.9n 0.95000 29640.0n 0.95000 29769.9n 0.95000 29770.0n 0.95000 29899.9n 0.95000 29900.0n 0.95000 30029.9n 0.95000 30030.0n 0.95000 30159.9n 0.95000 30160.0n 0.95000 30289.9n 0.95000 30290.0n 0.95000 30419.9n 0.95000 30420.0n 0.95000 30549.9n 0.95000 30550.0n 0.95000 30679.9n 0.95000 30680.0n 0.95000 30809.9n 0.95000 30810.0n 0.95000 30939.9n 0.95000 30940.0n 0.95000 31069.9n 0.95000 31070.0n 0.95000 31199.9n 0.95000 31200.0n 0.95000 31329.9n 0.95000 31330.0n 0.95000 31459.9n 0.95000 31460.0n 0.95000 31589.9n 0.95000 31590.0n 0.95000 31719.9n 0.95000 31720.0n 0.95000 31849.9n 0.95000 31850.0n 0.95000 31979.9n 0.95000 31980.0n 0.95000 32109.9n 0.95000 32110.0n 0.95000 32239.9n 0.95000 32240.0n 0.95000 32369.9n 0.95000 32370.0n 0.95000 32499.9n 0.95000 32500.0n 0.95000 32629.9n 0.95000 32630.0n 0.95000 32759.9n 0.95000 32760.0n 0.95000 32889.9n 0.95000 32890.0n 0.95000 33019.9n 0.95000 33020.0n 0.95000 33149.9n 0.95000 33150.0n 0.95000 33279.9n 0.95000 33280.0n 0.95000 33409.9n 0.95000 33410.0n 0.95000 33539.9n 0.95000 33540.0n 0.95000 33669.9n 0.95000 33670.0n 0.95000 33799.9n 0.95000 33800.0n 0.95000 33929.9n 0.95000 33930.0n 0.95000 34059.9n 0.95000 34060.0n 0.95000 34189.9n 0.95000 34190.0n 0.95000 34319.9n 0.95000 34320.0n 0.95000 34449.9n 0.95000 34450.0n 0.95000 34579.9n 0.95000 34580.0n 0.95000 34709.9n 0.95000 34710.0n 0.95000 34839.9n 0.95000 34840.0n 0.95000 34969.9n 0.95000 34970.0n 0.95000 35099.9n 0.95000 35100.0n 0.95000 35229.9n 0.95000 35230.0n 0.95000 35359.9n 0.95000 35360.0n 0.95000 35489.9n 0.95000 35490.0n 0.95000 35619.9n 0.95000 35620.0n 0.95000 35749.9n 0.95000 35750.0n 0.95000 35879.9n 0.95000 35880.0n 0.95000 36009.9n 0.95000 36010.0n 0.95000 36139.9n 0.95000 36140.0n 0.95000 36269.9n 0.95000 36270.0n 0.95000 36399.9n 0.95000 36400.0n 0.95000 36529.9n 0.95000 36530.0n 0.95000 36659.9n 0.95000 36660.0n 0.95000 36789.9n 0.95000 36790.0n 0.95000 36919.9n 0.95000 36920.0n 0.95000 37049.9n 0.95000 37050.0n 0.95000 37179.9n 0.95000 37180.0n 0.95000 37309.9n 0.95000 37310.0n 0.95000 37439.9n 0.95000 37440.0n 0.95000 37569.9n 0.95000 37570.0n 0.95000 37699.9n 0.95000 37700.0n 0.95000 37829.9n 0.95000 37830.0n 0.95000 37959.9n 0.95000 37960.0n 0.95000 38089.9n 0.95000 38090.0n 0.95000 38219.9n 0.95000 38220.0n 0.95000 38349.9n 0.95000 38350.0n 0.95000 38479.9n 0.95000 38480.0n 0.95000 38609.9n 0.95000 38610.0n 0.95000 38739.9n 0.95000 38740.0n 0.95000 38869.9n 0.95000 38870.0n 0.95000 38999.9n 0.95000 39000.0n 0.95000 39129.9n 0.95000 39130.0n 0.95000 39259.9n 0.95000 39260.0n 0.95000 39389.9n 0.95000 39390.0n 0.95000 39519.9n 0.95000 39520.0n 0.95000 39649.9n 0.95000 39650.0n 0.95000 39779.9n 0.95000 39780.0n 0.95000 39909.9n 0.95000 39910.0n 0.95000 40039.9n 0.95000 40040.0n 0.95000 40169.9n 0.95000 40170.0n 0.95000 40299.9n 0.95000 40300.0n 0.95000 40429.9n 0.95000 40430.0n 0.95000 40559.9n 0.95000 40560.0n 0.95000 40689.9n 0.95000 40690.0n 0.95000 40819.9n 0.95000 40820.0n 0.95000 40949.9n 0.95000 40950.0n 0.95000 41079.9n 0.95000 41080.0n 0.95000 41209.9n 0.95000 41210.0n 0.95000 41339.9n 0.95000 41340.0n 0.95000 41469.9n 0.95000 41470.0n 0.95000 41599.9n 0.95000 41600.0n 0.95000 41729.9n 0.95000 41730.0n 0.95000 41859.9n 0.95000 41860.0n 0.95000 41989.9n 0.95000 41990.0n 0.95000 42119.9n 0.95000 42120.0n 0.95000 42249.9n 0.95000 42250.0n 0.95000 42379.9n 0.95000 42380.0n 0.95000 42509.9n 0.95000 42510.0n 0.95000 42639.9n 0.95000 42640.0n 0.95000 42769.9n 0.95000 42770.0n 0.95000 42899.9n 0.95000 42900.0n 0.95000 43029.9n 0.95000 43030.0n 0.95000 43159.9n 0.95000 43160.0n 0.95000 43289.9n 0.95000 43290.0n 0.95000 43419.9n 0.95000 43420.0n 0.95000 43549.9n 0.95000 43550.0n 0.95000 43679.9n 0.95000 43680.0n 0.95000 43809.9n 0.95000 43810.0n 0.95000 43939.9n 0.95000 43940.0n 0.95000 44069.9n 0.95000 44070.0n 0.95000 44199.9n 0.95000 44200.0n 0.95000 44329.9n 0.95000 44330.0n 0.95000 44459.9n 0.95000 44460.0n 0.95000 44589.9n 0.95000 44590.0n 0.95000 44719.9n 0.95000 44720.0n 0.95000 44849.9n 0.95000 44850.0n 0.95000 44979.9n 0.95000 44980.0n 0.95000 45109.9n 0.95000 45110.0n 0.95000 45239.9n 0.95000 45240.0n 0.95000 45369.9n 0.95000 45370.0n 0.95000 45499.9n 0.95000 45500.0n 0.95000 45629.9n 0.95000 45630.0n 0.95000 45759.9n 0.95000 45760.0n 0.95000 45889.9n 0.95000 45890.0n 0.95000 46019.9n 0.95000 46020.0n 0.95000 46149.9n 0.95000 46150.0n 0.95000 46279.9n 0.95000 46280.0n 0.95000 46409.9n 0.95000 46410.0n 0.95000 46539.9n 0.95000 46540.0n 0.95000 46669.9n 0.95000 46670.0n 0.95000 46799.9n 0.95000 46800.0n 0.95000 46929.9n 0.95000 46930.0n 0.95000 47059.9n 0.95000 47060.0n 0.95000 47189.9n 0.95000 47190.0n 0.95000 47319.9n 0.95000 47320.0n 0.95000 47449.9n 0.95000 47450.0n 0.95000 47579.9n 0.95000 47580.0n 0.95000 47709.9n 0.95000 47710.0n 0.95000 47839.9n 0.95000 47840.0n 0.95000 47969.9n 0.95000 47970.0n 0.95000 48099.9n 0.95000 48100.0n 0.95000 48229.9n 0.95000 48230.0n 0.95000 48359.9n 0.95000 48360.0n 0.95000 48489.9n 0.95000 48490.0n 0.95000 48619.9n 0.95000 48620.0n 0.95000 48749.9n 0.95000 48750.0n 0.95000 48879.9n 0.95000 48880.0n 0.95000 49009.9n 0.95000 49010.0n 0.95000 49139.9n 0.95000 49140.0n 0.95000 49269.9n 0.95000 49270.0n 0.95000 49399.9n 0.95000 49400.0n 0.95000 49529.9n 0.95000 49530.0n 0.95000 49659.9n 0.95000 49660.0n 0.95000 49789.9n 0.95000 49790.0n 0.95000 49919.9n 0.95000 49920.0n 0.95000 50049.9n 0.95000 50050.0n 0.95000 50179.9n 0.95000 50180.0n 0.95000 50309.9n 0.95000 50310.0n 0.95000 50439.9n 0.95000 50440.0n 0.95000 50569.9n 0.95000 50570.0n 0.51500 50699.9n 0.51500 50700.0n 0.51500 50829.9n 0.51500 50830.0n 0.51500 50959.9n 0.51500 50960.0n 0.51500 51089.9n 0.51500 51090.0n 0.51500 51219.9n 0.51500 51220.0n 0.51500 51349.9n 0.51500 51350.0n 0.51500 51479.9n 0.51500 51480.0n 0.51500 51609.9n 0.51500 51610.0n 0.51500 51739.9n 0.51500 51740.0n 0.51500 51869.9n 0.51500 51870.0n 0.51500 51999.9n 0.51500 52000.0n 0.51500 52129.9n 0.51500 52130.0n 0.51500 52259.9n 0.51500 52260.0n 0.51500 52389.9n 0.51500 52390.0n 0.51500 52519.9n 0.51500 52520.0n 0.51500 52649.9n 0.51500 52650.0n 0.51500 52779.9n 0.51500 52780.0n 0.51500 52909.9n 0.51500 52910.0n 0.51500 53039.9n 0.51500 53040.0n 0.51500 53169.9n 0.51500 53170.0n 0.51500 53299.9n 0.51500 53300.0n 0.51500 53429.9n 0.51500 53430.0n 0.51500 53559.9n 0.51500 53560.0n 0.51500 53689.9n 0.51500 53690.0n 0.51500 53819.9n 0.51500 53820.0n 0.51500 53949.9n 0.51500 53950.0n 0.51500 54079.9n 0.51500 54080.0n 0.51500 54209.9n 0.51500 54210.0n 0.51500 54339.9n 0.51500 54340.0n 0.51500 54469.9n 0.51500 54470.0n 0.51500 54599.9n 0.51500 54600.0n 0.51500 54729.9n 0.51500 54730.0n 0.51500 54859.9n 0.51500 54860.0n 0.51500 54989.9n 0.51500 54990.0n 0.51500 55119.9n 0.51500 55120.0n 0.51500 55249.9n 0.51500 55250.0n 0.51500 55379.9n 0.51500 55380.0n 0.51500 55509.9n 0.51500 55510.0n 0.51500 55639.9n 0.51500 55640.0n 0.51500 55769.9n 0.51500 55770.0n 0.51500 55899.9n 0.51500 55900.0n 0.51500 56029.9n 0.51500 56030.0n 0.51500 56159.9n 0.51500 56160.0n 0.51500 56289.9n 0.51500 56290.0n 0.51500 56419.9n 0.51500 56420.0n 0.51500 56549.9n 0.51500 56550.0n 0.51500 56679.9n 0.51500 56680.0n 0.51500 56809.9n 0.51500 56810.0n 0.51500 56939.9n 0.51500 56940.0n 0.51500 57069.9n 0.51500 57070.0n 0.51500 57199.9n 0.51500 57200.0n 0.51500 57329.9n 0.51500 57330.0n 0.51500 57459.9n 0.51500 57460.0n 0.51500 57589.9n 0.51500 57590.0n 0.51500 57719.9n 0.51500 57720.0n 0.51500 57849.9n 0.51500 57850.0n 0.51500 57979.9n 0.51500 57980.0n 0.51500 58109.9n 0.51500 58110.0n 0.51500 58239.9n 0.51500 58240.0n 0.51500 58369.9n 0.51500 58370.0n 0.51500 58499.9n 0.51500 58500.0n 0.51500 58629.9n 0.51500 58630.0n 0.51500 58759.9n 0.51500 58760.0n 0.51500 58889.9n 0.51500 58890.0n 0.51500 59019.9n 0.51500 59020.0n 0.51500 59149.9n 0.51500 59150.0n 0.51500 59279.9n 0.51500 59280.0n 0.51500 59409.9n 0.51500 59410.0n 0.51500 59539.9n 0.51500 59540.0n 0.51500 59669.9n 0.51500 59670.0n 0.51500 59799.9n 0.51500 59800.0n 0.51500 59929.9n 0.51500 59930.0n 0.51500 60059.9n 0.51500 60060.0n 0.51500 60189.9n 0.51500 60190.0n 0.51500 60319.9n 0.51500 60320.0n 0.51500 60449.9n 0.51500 60450.0n 0.51500 60579.9n 0.51500 60580.0n 0.51500 60709.9n 0.51500 60710.0n 0.51500 60839.9n 0.51500 60840.0n 0.51500 60969.9n 0.51500 60970.0n 0.51500 61099.9n 0.51500 61100.0n 0.51500 61229.9n 0.51500 61230.0n 0.51500 61359.9n 0.51500 61360.0n 0.51500 61489.9n 0.51500 61490.0n 0.51500 61619.9n 0.51500 61620.0n 0.51500 61749.9n 0.51500 61750.0n 0.51500 61879.9n 0.51500 61880.0n 0.51500 62009.9n 0.51500 62010.0n 0.51500 62139.9n 0.51500 62140.0n 0.51500 62269.9n 0.51500 62270.0n 0.51500 62399.9n 0.51500 62400.0n 0.51500 62529.9n 0.51500 62530.0n 0.51500 62659.9n 0.51500 62660.0n 0.51500 62789.9n 0.51500 62790.0n 0.51500 62919.9n 0.51500 62920.0n 0.51500 63049.9n 0.51500 63050.0n 0.51500 63179.9n 0.51500 63180.0n 0.51500 63309.9n 0.51500 63310.0n 0.51500 63439.9n 0.51500 63440.0n 0.51500 63569.9n 0.51500 63570.0n 0.51500 63699.9n 0.51500 63700.0n 0.51500 63829.9n 0.51500 63830.0n 0.51500 63959.9n 0.51500 63960.0n 0.51500 64089.9n 0.51500 64090.0n 0.51500 64219.9n 0.51500 64220.0n 0.51500 64349.9n 0.51500 64350.0n 0.51500 64479.9n 0.51500 64480.0n 0.51500 64609.9n 0.51500 64610.0n 0.51500 64739.9n 0.51500 64740.0n 0.51500 64869.9n 0.51500 64870.0n 0.51500 64999.9n 0.51500 65000.0n 0.51500 65129.9n 0.51500 65130.0n 0.51500 65259.9n 0.51500 65260.0n 0.51500 65389.9n 0.51500 65390.0n 0.51500 65519.9n 0.51500 65520.0n 0.51500 65649.9n 0.51500 65650.0n 0.51500 65779.9n 0.51500 65780.0n 0.51500 65909.9n 0.51500 65910.0n 0.51500 66039.9n 0.51500 66040.0n 0.51500 66169.9n 0.51500 66170.0n 0.51500 66299.9n 0.51500 66300.0n 0.51500 66429.9n 0.51500 66430.0n 0.51500 66559.9n 0.51500 66560.0n 0.51500 66689.9n 0.51500 66690.0n 0.51500 66819.9n 0.51500 66820.0n 0.51500 66949.9n 0.51500 66950.0n 0.51500 67079.9n 0.51500 67080.0n 0.51500 67209.9n 0.51500 67210.0n 0.51500 67339.9n 0.51500 67340.0n 0.51500 67469.9n 0.51500 67470.0n 0.51500 67599.9n 0.51500 67600.0n 0.51500 67729.9n 0.51500 67730.0n 0.51500 67859.9n 0.51500 67860.0n 0.51500 67989.9n 0.51500 67990.0n 0.51500 68119.9n 0.51500 68120.0n 0.51500 68249.9n 0.51500 68250.0n 0.51500 68379.9n 0.51500 68380.0n 0.51500 68509.9n 0.51500 68510.0n 0.51500 68639.9n 0.51500 68640.0n 0.51500 68769.9n 0.51500 68770.0n 0.51500 68899.9n 0.51500 68900.0n 0.51500 69029.9n 0.51500 69030.0n 0.51500 69159.9n 0.51500 69160.0n 0.51500 69289.9n 0.51500 69290.0n 0.51500 69419.9n 0.51500 69420.0n 0.51500 69549.9n 0.51500 69550.0n 0.51500 69679.9n 0.51500 69680.0n 0.51500 69809.9n 0.51500 69810.0n 0.51500 69939.9n 0.51500 69940.0n 0.51500 70069.9n 0.51500 70070.0n 0.51500 70199.9n 0.51500 70200.0n 0.51500 70329.9n 0.51500 70330.0n 0.51500 70459.9n 0.51500 70460.0n 0.51500 70589.9n 0.51500 70590.0n 0.51500 70719.9n 0.51500 70720.0n 0.51500 70849.9n 0.51500 70850.0n 0.51500 70979.9n 0.51500 70980.0n 0.51500 71109.9n 0.51500 71110.0n 0.51500 71239.9n 0.51500 71240.0n 0.51500 71369.9n 0.51500 71370.0n 0.51500 71499.9n 0.51500 71500.0n 0.51500 71629.9n 0.51500 71630.0n 0.51500 71759.9n 0.51500 71760.0n 0.51500 71889.9n 0.51500 71890.0n 0.51500 72019.9n 0.51500 72020.0n 0.51500 72149.9n 0.51500 72150.0n 0.51500 72279.9n 0.51500 72280.0n 0.51500 72409.9n 0.51500 72410.0n 0.51500 72539.9n 0.51500 72540.0n 0.51500 72669.9n 0.51500 72670.0n 0.51500 72799.9n 0.51500 72800.0n 0.51500 72929.9n 0.51500 72930.0n 0.51500 73059.9n 0.51500 73060.0n 0.51500 73189.9n 0.51500 73190.0n 0.51500 73319.9n 0.51500 73320.0n 0.51500 73449.9n 0.51500 73450.0n 0.51500 73579.9n 0.51500 73580.0n 0.51500 73709.9n 0.51500 73710.0n 0.51500 73839.9n 0.51500 73840.0n 0.51500 73969.9n 0.51500 73970.0n 0.51500 74099.9n 0.51500 74100.0n 0.51500 74229.9n 0.51500 74230.0n 0.51500 74359.9n 0.51500 74360.0n 0.51500 74489.9n 0.51500 74490.0n 0.51500 74619.9n 0.51500 74620.0n 0.51500 74749.9n 0.51500 74750.0n 0.51500 74879.9n 0.51500 74880.0n 0.51500 75009.9n 0.51500 75010.0n 0.51500 75139.9n 0.51500 75140.0n 0.51500 75269.9n 0.51500 75270.0n 0.51500 75399.9n 0.51500 75400.0n 0.51500 75529.9n 0.51500 75530.0n 0.51500 75659.9n 0.51500 75660.0n 0.51500 75789.9n 0.51500 75790.0n 0.51500 75919.9n 0.51500 75920.0n 0.51500 76049.9n 0.51500 76050.0n 0.51500 76179.9n 0.51500 76180.0n 0.51500 76309.9n 0.51500 76310.0n 0.51500 76439.9n 0.51500 76440.0n 0.51500 76569.9n 0.51500 76570.0n 0.51500 76699.9n 0.51500 76700.0n 0.51500 76829.9n 0.51500 76830.0n 0.51500 76959.9n 0.51500 76960.0n 0.51500 77089.9n 0.51500 77090.0n 0.51500 77219.9n 0.51500 77220.0n 0.51500 77349.9n 0.51500 77350.0n 0.51500 77479.9n 0.51500 77480.0n 0.51500 77609.9n 0.51500 77610.0n 0.51500 77739.9n 0.51500 77740.0n 0.51500 77869.9n 0.51500 77870.0n 0.51500 77999.9n 0.51500 78000.0n 0.51500 78129.9n 0.51500 78130.0n 0.51500 78259.9n 0.51500 78260.0n 0.51500 78389.9n 0.51500 78390.0n 0.51500 78519.9n 0.51500 78520.0n 0.51500 78649.9n 0.51500 78650.0n 0.51500 78779.9n 0.51500 78780.0n 0.51500 78909.9n 0.51500 78910.0n 0.51500 79039.9n 0.51500 79040.0n 0.51500 79169.9n 0.51500 79170.0n 0.51500 79299.9n 0.51500 79300.0n 0.51500 79429.9n 0.51500 79430.0n 0.51500 79559.9n 0.51500 79560.0n 0.51500 79689.9n 0.51500 79690.0n 0.51500 79819.9n 0.51500 79820.0n 0.51500 79949.9n 0.51500 79950.0n 0.51500 80079.9n 0.51500 80080.0n 0.51500 80209.9n 0.51500 80210.0n 0.51500 80339.9n 0.51500 80340.0n 0.51500 80469.9n 0.51500 80470.0n 0.51500 80599.9n 0.51500 80600.0n 0.51500 80729.9n 0.51500 80730.0n 0.51500 80859.9n 0.51500 80860.0n 0.51500 80989.9n 0.51500 80990.0n 0.51500 81119.9n 0.51500 81120.0n 0.51500 81249.9n 0.51500 81250.0n 0.51500 81379.9n 0.51500 81380.0n 0.51500 81509.9n 0.51500 81510.0n 0.51500 81639.9n 0.51500 81640.0n 0.51500 81769.9n 0.51500 81770.0n 0.51500 81899.9n 0.51500 81900.0n 0.51500 82029.9n 0.51500 82030.0n 0.51500 82159.9n 0.51500 82160.0n 0.51500 82289.9n 0.51500 82290.0n 0.51500 82419.9n 0.51500 82420.0n 0.51500 82549.9n 0.51500 82550.0n 0.51500 82679.9n 0.51500 82680.0n 0.51500 82809.9n 0.51500 82810.0n 0.51500 82939.9n 0.51500 82940.0n 0.51500 83069.9n 0.51500 83070.0n 0.51500 83199.9n 0.51500 83200.0n 0.51500 83329.9n 0.51500 83330.0n 0.51500 83459.9n 0.51500 83460.0n 0.51500 83589.9n 0.51500 83590.0n 0.51500 83719.9n 0.51500 83720.0n 0.51500 83849.9n 0.51500 83850.0n 0.51500 83979.9n 0.51500 83980.0n 0.51500 84109.9n 0.51500 84110.0n 0.51500 84239.9n 0.51500 84240.0n 0.51500 84369.9n 0.51500 84370.0n 0.51500 84499.9n 0.51500 84500.0n 0.51500 84629.9n 0.51500 84630.0n 0.51500 84759.9n 0.51500 84760.0n 0.51500 84889.9n 0.51500 84890.0n 0.51500 85019.9n 0.51500 85020.0n 0.51500 85149.9n 0.51500 85150.0n 0.51500 85279.9n 0.51500 85280.0n 0.51500 85409.9n 0.51500 85410.0n 0.51500 85539.9n 0.51500 85540.0n 0.51500 85669.9n 0.51500 85670.0n 0.51500 85799.9n 0.51500 85800.0n 0.51500 85929.9n 0.51500 85930.0n 0.51500 86059.9n 0.51500 86060.0n 0.51500 86189.9n 0.51500 86190.0n 0.51500 86319.9n 0.51500 86320.0n 0.51500 86449.9n 0.51500 86450.0n 0.51500 86579.9n 0.51500 86580.0n 0.51500 86709.9n 0.51500 86710.0n 0.51500 86839.9n 0.51500 86840.0n 0.51500 86969.9n 0.51500 86970.0n 0.51500 87099.9n 0.51500 87100.0n 0.51500 87229.9n 0.51500 87230.0n 0.51500 87359.9n 0.51500 87360.0n 0.51500 87489.9n 0.51500 87490.0n 0.51500 87619.9n 0.51500 87620.0n 0.51500 87749.9n 0.51500 87750.0n 0.51500 87879.9n 0.51500 87880.0n 0.51500 88009.9n 0.51500 88010.0n 0.51500 88139.9n 0.51500 88140.0n 0.51500 88269.9n 0.51500 88270.0n 0.51500 88399.9n 0.51500 88400.0n 0.51500 88529.9n 0.51500 88530.0n 0.51500 88659.9n 0.51500 88660.0n 0.51500 88789.9n 0.51500 88790.0n 0.51500 88919.9n 0.51500 88920.0n 0.51500 89049.9n 0.51500 89050.0n 0.51500 89179.9n 0.51500 89180.0n 0.51500 89309.9n 0.51500 89310.0n 0.51500 89439.9n 0.51500 89440.0n 0.51500 89569.9n 0.51500 89570.0n 0.51500 89699.9n 0.51500 89700.0n 0.51500 89829.9n 0.51500 89830.0n 0.51500 89959.9n 0.51500 89960.0n 0.51500 90089.9n 0.51500 90090.0n 0.51500 90219.9n 0.51500 90220.0n 0.51500 90349.9n 0.51500 90350.0n 0.51500 90479.9n 0.51500 90480.0n 0.51500 90609.9n 0.51500 90610.0n 0.51500 90739.9n 0.51500 90740.0n 0.51500 90869.9n 0.51500 90870.0n 0.51500 90999.9n 0.51500 91000.0n 0.51500 91129.9n 0.51500 91130.0n 0.51500 91259.9n 0.51500 91260.0n 0.51500 91389.9n 0.51500 91390.0n 0.51500 91519.9n 0.51500 91520.0n 0.51500 91649.9n 0.51500 91650.0n 0.51500 91779.9n 0.51500 91780.0n 0.51500 91909.9n 0.51500 91910.0n 0.51500 92039.9n 0.51500 92040.0n 0.51500 92169.9n 0.51500 92170.0n 0.51500 92299.9n 0.51500 92300.0n 0.51500 92429.9n 0.51500 92430.0n 0.51500 92559.9n 0.51500 92560.0n 0.51500 92689.9n 0.51500 92690.0n 0.51500 92819.9n 0.51500 92820.0n 0.51500 92949.9n 0.51500 92950.0n 0.51500 93079.9n 0.51500 93080.0n 0.51500 93209.9n 0.51500 93210.0n 0.51500 93339.9n 0.51500 93340.0n 0.51500 93469.9n 0.51500 93470.0n 0.51500 93599.9n 0.51500 93600.0n 0.51500 93729.9n 0.51500 93730.0n 0.51500 93859.9n 0.51500 93860.0n 0.51500 93989.9n 0.51500 93990.0n 0.51500 94119.9n 0.51500 94120.0n 0.51500 94249.9n 0.51500 94250.0n 0.51500 94379.9n 0.51500 94380.0n 0.51500 94509.9n 0.51500 94510.0n 0.51500 94639.9n 0.51500 94640.0n 0.51500 94769.9n 0.51500 94770.0n 0.51500 94899.9n 0.51500 94900.0n 0.51500 95029.9n 0.51500 95030.0n 0.51500 95159.9n 0.51500 95160.0n 0.51500 95289.9n 0.51500 95290.0n 0.51500 95419.9n 0.51500 95420.0n 0.51500 95549.9n 0.51500 95550.0n 0.51500 95679.9n 0.51500 95680.0n 0.51500 95809.9n 0.51500 95810.0n 0.51500 95939.9n 0.51500 95940.0n 0.51500 96069.9n 0.51500 96070.0n 0.51500 96199.9n 0.51500 96200.0n 0.51500 96329.9n 0.51500 96330.0n 0.51500 96459.9n 0.51500 96460.0n 0.51500 96589.9n 0.51500 96590.0n 0.51500 96719.9n 0.51500 96720.0n 0.51500 96849.9n 0.51500 96850.0n 0.51500 96979.9n 0.51500 96980.0n 0.51500 97109.9n 0.51500 97110.0n 0.51500 97239.9n 0.51500 97240.0n 0.51500 97369.9n 0.51500 97370.0n 0.51500 97499.9n 0.51500 97500.0n 0.51500 97629.9n 0.51500 97630.0n 0.51500 97759.9n 0.51500 97760.0n 0.51500 97889.9n 0.51500 97890.0n 0.51500 98019.9n 0.51500 98020.0n 0.51500 98149.9n 0.51500 98150.0n 0.51500 98279.9n 0.51500 98280.0n 0.51500 98409.9n 0.51500 98410.0n 0.51500 98539.9n 0.51500 98540.0n 0.51500 98669.9n 0.51500 98670.0n 0.51500 98799.9n 0.51500 98800.0n 0.51500 98929.9n 0.51500 98930.0n 0.51500 99059.9n 0.51500 99060.0n 0.51500 99189.9n 0.51500 99190.0n 0.51500 99319.9n 0.51500 99320.0n 0.51500 99449.9n 0.51500 99450.0n 0.51500 99579.9n 0.51500 99580.0n 0.51500 99709.9n 0.51500 99710.0n 0.51500 99839.9n 0.51500 99840.0n 0.51500 99969.9n 0.51500 99970.0n 0.51500 100099.9n 0.51500 100100.0n 0.51500 100229.9n 0.51500 100230.0n 0.51500 100359.9n 0.51500 100360.0n 0.51500 100489.9n 0.51500 100490.0n 0.51500 100619.9n 0.51500 100620.0n 0.51500 100749.9n 0.51500 100750.0n 0.51500 100879.9n 0.51500 100880.0n 0.51500 101009.9n 0.51500 101010.0n 0.51500 101139.9n 0.51500 101140.0n 0.51500 101269.9n 0.51500 101270.0n 0.51500 101399.9n 0.51500 101400.0n 0.51500 101529.9n 0.51500 101530.0n 0.51500 101659.9n 0.51500 101660.0n 0.51500 101789.9n 0.51500 101790.0n 0.51500 101919.9n 0.51500 101920.0n 0.51500 102049.9n 0.51500 102050.0n 0.51500 102179.9n 0.51500 102180.0n 0.51500 102309.9n 0.51500 102310.0n 0.51500 102439.9n 0.51500 102440.0n 0.51500 102569.9n 0.51500 102570.0n 0.51500 102699.9n 0.51500 102700.0n 0.51500 102829.9n 0.51500 102830.0n 0.51500 102959.9n 0.51500 102960.0n 0.51500 103089.9n 0.51500 103090.0n 0.51500 103219.9n 0.51500 103220.0n 0.51500 103349.9n 0.51500 103350.0n 0.51500 103479.9n 0.51500 103480.0n 0.51500 103609.9n 0.51500 103610.0n 0.51500 103739.9n 0.51500 103740.0n 0.51500 103869.9n 0.51500 103870.0n 0.51500 103999.9n 0.51500 104000.0n 0.51500 104129.9n 0.51500 104130.0n 0.51500 104259.9n 0.51500 104260.0n 0.51500 104389.9n 0.51500 104390.0n 0.51500 104519.9n 0.51500 104520.0n 0.51500 104649.9n 0.51500 104650.0n 0.51500 104779.9n 0.51500 104780.0n 0.51500 104909.9n 0.51500 104910.0n 0.51500 105039.9n 0.51500 105040.0n 0.51500 105169.9n 0.51500 105170.0n 0.51500 105299.9n 0.51500 105300.0n 0.51500 105429.9n 0.51500 105430.0n 0.51500 105559.9n 0.51500 105560.0n 0.51500 105689.9n 0.51500 105690.0n 0.51500 105819.9n 0.51500 105820.0n 0.51500 105949.9n 0.51500 105950.0n 0.51500 106079.9n 0.51500 106080.0n 0.51500 106209.9n 0.51500 106210.0n 0.51500 106339.9n 0.51500 106340.0n 0.51500 106469.9n 0.51500 106470.0n 0.51500 106599.9n 0.51500 106600.0n 0.51500 106729.9n 0.51500 106730.0n 0.51500 106859.9n 0.51500 106860.0n 0.51500 106989.9n 0.51500 106990.0n 0.51500 107119.9n 0.51500 107120.0n 0.51500 107249.9n 0.51500 107250.0n 0.51500 107379.9n 0.51500 107380.0n 0.51500 107509.9n 0.51500 107510.0n 0.51500 107639.9n 0.51500 107640.0n 0.51500 107769.9n 0.51500 107770.0n 0.51500 107899.9n 0.51500 107900.0n 0.51500 108029.9n 0.51500 108030.0n 0.51500 108159.9n 0.51500 108160.0n 0.51500 108289.9n 0.51500 108290.0n 0.51500 108419.9n 0.51500 108420.0n 0.51500 108549.9n 0.51500 108550.0n 0.51500 108679.9n 0.51500 108680.0n 0.51500 108809.9n 0.51500 108810.0n 0.51500 108939.9n 0.51500 108940.0n 0.51500 109069.9n 0.51500 109070.0n 0.51500 109199.9n 0.51500 109200.0n 0.51500 109329.9n 0.51500 109330.0n 0.51500 109459.9n 0.51500 109460.0n 0.51500 109589.9n 0.51500 109590.0n 0.51500 109719.9n 0.51500 109720.0n 0.51500 109849.9n 0.51500 109850.0n 0.51500 109979.9n 0.51500 109980.0n 0.51500 110109.9n 0.51500 110110.0n 0.51500 110239.9n 0.51500 110240.0n 0.51500 110369.9n 0.51500 110370.0n 0.51500 110499.9n 0.51500 110500.0n 0.51500 110629.9n 0.51500 110630.0n 0.51500 110759.9n 0.51500 110760.0n 0.51500 110889.9n 0.51500 110890.0n 0.51500 111019.9n 0.51500 111020.0n 0.51500 111149.9n 0.51500 111150.0n 0.51500 111279.9n 0.51500 111280.0n 0.51500 111409.9n 0.51500 111410.0n 0.51500 111539.9n 0.51500 111540.0n 0.51500 111669.9n 0.51500 111670.0n 0.51500 111799.9n 0.51500 111800.0n 0.51500 111929.9n 0.51500 111930.0n 0.51500 112059.9n 0.51500 112060.0n 0.51500 112189.9n 0.51500 112190.0n 0.51500 112319.9n 0.51500 112320.0n 0.51500 112449.9n 0.51500 112450.0n 0.51500 112579.9n 0.51500 112580.0n 0.51500 112709.9n 0.51500 112710.0n 0.51500 112839.9n 0.51500 112840.0n 0.51500 112969.9n 0.51500 112970.0n 0.51500 113099.9n 0.51500 113100.0n 0.51500 113229.9n 0.51500 113230.0n 0.51500 113359.9n 0.51500 113360.0n 0.51500 113489.9n 0.51500 113490.0n 0.51500 113619.9n 0.51500 113620.0n 0.51500 113749.9n 0.51500 113750.0n 0.51500 113879.9n 0.51500 113880.0n 0.51500 114009.9n 0.51500 114010.0n 0.51500 114139.9n 0.51500 114140.0n 0.51500 114269.9n 0.51500 114270.0n 0.51500 114399.9n 0.51500 114400.0n 0.51500 114529.9n 0.51500 114530.0n 0.51500 114659.9n 0.51500 114660.0n 0.51500 114789.9n 0.51500 114790.0n 0.51500 114919.9n 0.51500 114920.0n 0.51500 115049.9n 0.51500 115050.0n 0.51500 115179.9n 0.51500 115180.0n 0.51500 115309.9n 0.51500 115310.0n 0.51500 115439.9n 0.51500 115440.0n 0.51500 115569.9n 0.51500 115570.0n 0.51500 115699.9n 0.51500 115700.0n 0.51500 115829.9n 0.51500 115830.0n 0.51500 115959.9n 0.51500 115960.0n 0.51500 116089.9n 0.51500 116090.0n 0.51500 116219.9n 0.51500 116220.0n 0.51500 116349.9n 0.51500 116350.0n 0.51500 116479.9n 0.51500 116480.0n 0.51500 116609.9n 0.51500 116610.0n 0.51500 116739.9n 0.51500 116740.0n 0.51500 116869.9n 0.51500 116870.0n 0.51500 116999.9n 0.51500 117000.0n 0.51500 117129.9n 0.51500 117130.0n 0.51500 117259.9n 0.51500 117260.0n 0.51500 117389.9n 0.51500 117390.0n 0.51500 117519.9n 0.51500 117520.0n 0.51500 117649.9n 0.51500 117650.0n 0.51500 117779.9n 0.51500 117780.0n 0.51500 117909.9n 0.51500 117910.0n 0.51500 118039.9n 0.51500 118040.0n 0.51500 118169.9n 0.51500 118170.0n 0.51500 118299.9n 0.51500 118300.0n 0.51500 118429.9n 0.51500 118430.0n 0.51500 118559.9n 0.51500 118560.0n 0.51500 118689.9n 0.51500 118690.0n 0.51500 118819.9n 0.51500 118820.0n 0.51500 118949.9n 0.51500 118950.0n 0.51500 119079.9n 0.51500 119080.0n 0.51500 119209.9n 0.51500 119210.0n 0.51500 119339.9n 0.51500 119340.0n 0.51500 119469.9n 0.51500 119470.0n 0.51500 119599.9n 0.51500 119600.0n 0.51500 119729.9n 0.51500 119730.0n 0.51500 119859.9n 0.51500 119860.0n 0.51500 119989.9n 0.51500 119990.0n 0.51500 120119.9n 0.51500 120120.0n 0.51500 120249.9n 0.51500 120250.0n 0.51500 120379.9n 0.51500 120380.0n 0.51500 120509.9n 0.51500 120510.0n 0.51500 120639.9n 0.51500 120640.0n 0.51500 120769.9n 0.51500 120770.0n 0.51500 120899.9n 0.51500 120900.0n 0.51500 121029.9n 0.51500 121030.0n 0.51500 121159.9n 0.51500 121160.0n 0.51500 121289.9n 0.51500 121290.0n 0.51500 121419.9n 0.51500 121420.0n 0.51500 121549.9n 0.51500 121550.0n 0.51500 121679.9n 0.51500 121680.0n 0.51500 121809.9n 0.51500 121810.0n 0.51500 121939.9n 0.51500 121940.0n 0.51500 122069.9n 0.51500 122070.0n 0.51500 122199.9n 0.51500 122200.0n 0.51500 122329.9n 0.51500 122330.0n 0.51500 122459.9n 0.51500 122460.0n 0.51500 122589.9n 0.51500 122590.0n 0.51500 122719.9n 0.51500 122720.0n 0.51500 122849.9n 0.51500 122850.0n 0.51500 122979.9n 0.51500 122980.0n 0.51500 123109.9n 0.51500 123110.0n 0.51500 123239.9n 0.51500 123240.0n 0.51500 123369.9n 0.51500 123370.0n 0.51500 123499.9n 0.51500 123500.0n 0.51500 123629.9n 0.51500 123630.0n 0.51500 123759.9n 0.51500 123760.0n 0.51500 123889.9n 0.51500 123890.0n 0.51500 124019.9n 0.51500 124020.0n 0.51500 124149.9n 0.51500 124150.0n 0.51500 124279.9n 0.51500 124280.0n 0.51500 124409.9n 0.51500 124410.0n 0.51500 124539.9n 0.51500 124540.0n 0.51500 124669.9n 0.51500 124670.0n 0.51500 124799.9n 0.51500 124800.0n 0.51500 124929.9n 0.51500 124930.0n 0.51500 125059.9n 0.51500 125060.0n 0.51500 125189.9n 0.51500 125190.0n 0.51500 125319.9n 0.51500 125320.0n 0.51500 125449.9n 0.51500 125450.0n 0.51500 125579.9n 0.51500 125580.0n 0.51500 125709.9n 0.51500 125710.0n 0.51500 125839.9n 0.51500 125840.0n 0.51500 125969.9n 0.51500 125970.0n 0.51500 126099.9n 0.51500 126100.0n 0.51500 126229.9n 0.51500 126230.0n 0.51500 126359.9n 0.51500 126360.0n 0.51500 126489.9n 0.51500 126490.0n 0.51500 126619.9n 0.51500 126620.0n 0.51500 126749.9n 0.51500 126750.0n 0.51500 126879.9n 0.51500 126880.0n 0.51500 127009.9n 0.51500 127010.0n 0.51500 127139.9n 0.51500 127140.0n 0.51500 127269.9n 0.51500 127270.0n 0.51500 127399.9n 0.51500 127400.0n 0.51500 127529.9n 0.51500 127530.0n 0.51500 127659.9n 0.51500 127660.0n 0.51500 127789.9n 0.51500 127790.0n 0.51500 127919.9n 0.51500 127920.0n 0.51500 128049.9n 0.51500 128050.0n 0.51500 128179.9n 0.51500 128180.0n 0.51500 128309.9n 0.51500 128310.0n 0.51500 128439.9n 0.51500 128440.0n 0.51500 128569.9n 0.51500 128570.0n 0.51500 128699.9n 0.51500 128700.0n 0.51500 128829.9n 0.51500 128830.0n 0.51500 128959.9n 0.51500 128960.0n 0.51500 129089.9n 0.51500 129090.0n 0.51500 129219.9n 0.51500 129220.0n 0.51500 129349.9n 0.51500 129350.0n 0.51500 129479.9n 0.51500 129480.0n 0.51500 129609.9n 0.51500 129610.0n 0.51500 129739.9n 0.51500 129740.0n 0.51500 129869.9n 0.51500 129870.0n 0.51500 129999.9n 0.51500 130000.0n 0.51500 130129.9n 0.51500 130130.0n 0.51500 130259.9n 0.51500 130260.0n 0.51500 130389.9n 0.51500 130390.0n 0.51500 130519.9n 0.51500 130520.0n 0.51500 130649.9n 0.51500 130650.0n 0.51500 130779.9n 0.51500 130780.0n 0.51500 130909.9n 0.51500 130910.0n 0.51500 131039.9n 0.51500 131040.0n 0.51500 131169.9n 0.51500 131170.0n 0.51500 131299.9n 0.51500 131300.0n 0.51500 131429.9n 0.51500 131430.0n 0.51500 131559.9n 0.51500 131560.0n 0.51500 131689.9n 0.51500 131690.0n 0.51500 131819.9n 0.51500 131820.0n 0.51500 131949.9n 0.51500 131950.0n 0.51500 132079.9n 0.51500 132080.0n 0.51500 132209.9n 0.51500 132210.0n 0.51500 132339.9n 0.51500 132340.0n 0.51500 132469.9n 0.51500 132470.0n 0.51500 132599.9n 0.51500 132600.0n 0.51500 132729.9n 0.51500 132730.0n 0.51500 132859.9n 0.51500 132860.0n 0.51500 132989.9n 0.51500 132990.0n 0.51500 133119.9n 0.51500 133120.0n 0.51500 133249.9n 0.51500 133250.0n 0.51500 133379.9n 0.51500 133380.0n 0.51500 133509.9n 0.51500 133510.0n 0.51500 133639.9n 0.51500 133640.0n 0.51500 133769.9n 0.51500 133770.0n 0.51500 133899.9n 0.51500 133900.0n 0.51500 134029.9n 0.51500 134030.0n 0.51500 134159.9n 0.51500 134160.0n 0.51500 134289.9n 0.51500 134290.0n 0.51500 134419.9n 0.51500 134420.0n 0.51500 134549.9n 0.51500 134550.0n 0.51500 134679.9n 0.51500 134680.0n 0.51500 134809.9n 0.51500 134810.0n 0.51500 134939.9n 0.51500 134940.0n 0.51500 135069.9n 0.51500 135070.0n 0.51500 135199.9n 0.51500 135200.0n 0.51500 135329.9n 0.51500 135330.0n 0.51500 135459.9n 0.51500 135460.0n 0.51500 135589.9n 0.51500 135590.0n 0.51500 135719.9n 0.51500 135720.0n 0.51500 135849.9n 0.51500 135850.0n 0.51500 135979.9n 0.51500 135980.0n 0.51500 136109.9n 0.51500 136110.0n 0.51500 136239.9n 0.51500 136240.0n 0.51500 136369.9n 0.51500 136370.0n 0.51500 136499.9n 0.51500 136500.0n 0.51500 136629.9n 0.51500 136630.0n 0.51500 136759.9n 0.51500 136760.0n 0.51500 136889.9n 0.51500 136890.0n 0.51500 137019.9n 0.51500 137020.0n 0.51500 137149.9n 0.51500 137150.0n 0.51500 137279.9n 0.51500 137280.0n 0.51500 137409.9n 0.51500 137410.0n 0.51500 137539.9n 0.51500 137540.0n 0.51500 137669.9n 0.51500 137670.0n 0.51500 137799.9n 0.51500 137800.0n 0.51500 137929.9n 0.51500 137930.0n 0.51500 138059.9n 0.51500 138060.0n 0.51500 138189.9n 0.51500 138190.0n 0.51500 138319.9n 0.51500 138320.0n 0.51500 138449.9n 0.51500 138450.0n 0.51500 138579.9n 0.51500 138580.0n 0.51500 138709.9n 0.51500 138710.0n 0.51500 138839.9n 0.51500 138840.0n 0.51500 138969.9n 0.51500 138970.0n 0.51500 139099.9n 0.51500 139100.0n 0.51500 139229.9n 0.51500 139230.0n 0.51500 139359.9n 0.51500 139360.0n 0.51500 139489.9n 0.51500 139490.0n 0.51500 139619.9n 0.51500 139620.0n 0.51500 139749.9n 0.51500 139750.0n 0.51500 139879.9n 0.51500 139880.0n 0.51500 140009.9n 0.51500 140010.0n 0.51500 140139.9n 0.51500 140140.0n 0.51500 140269.9n 0.51500 140270.0n 0.51500 140399.9n 0.51500 140400.0n 0.51500 140529.9n 0.51500 140530.0n 0.51500 140659.9n 0.51500 140660.0n 0.51500 140789.9n 0.51500 140790.0n 0.51500 140919.9n 0.51500 140920.0n 0.51500 141049.9n 0.51500 141050.0n 0.51500 141179.9n 0.51500 141180.0n 0.51500 141309.9n 0.51500 141310.0n 0.51500 141439.9n 0.51500 141440.0n 0.51500 141569.9n 0.51500 141570.0n 0.51500 141699.9n 0.51500 141700.0n 0.51500 141829.9n 0.51500 141830.0n 0.51500 141959.9n 0.51500 141960.0n 0.51500 142089.9n 0.51500 142090.0n 0.51500 142219.9n 0.51500 142220.0n 0.51500 142349.9n 0.51500 142350.0n 0.51500 142479.9n 0.51500 142480.0n 0.51500 142609.9n 0.51500 142610.0n 0.51500 142739.9n 0.51500 142740.0n 0.51500 142869.9n 0.51500 142870.0n 0.51500 142999.9n 0.51500 143000.0n 0.51500 143129.9n 0.51500 143130.0n 0.51500 143259.9n 0.51500 143260.0n 0.51500 143389.9n 0.51500 143390.0n 0.51500 143519.9n 0.51500 143520.0n 0.51500 143649.9n 0.51500 143650.0n 0.51500 143779.9n 0.51500 143780.0n 0.51500 143909.9n 0.51500 143910.0n 0.51500 144039.9n 0.51500 144040.0n 0.51500 144169.9n 0.51500 144170.0n 0.51500 144299.9n 0.51500 144300.0n 0.51500 144429.9n 0.51500 144430.0n 0.51500 144559.9n 0.51500 144560.0n 0.51500 144689.9n 0.51500 144690.0n 0.51500 144819.9n 0.51500 144820.0n 0.51500 144949.9n 0.51500 144950.0n 0.51500 145079.9n 0.51500 145080.0n 0.51500 145209.9n 0.51500 145210.0n 0.51500 145339.9n 0.51500 145340.0n 0.51500 145469.9n 0.51500 145470.0n 0.51500 145599.9n 0.51500 145600.0n 0.51500 145729.9n 0.51500 145730.0n 0.51500 145859.9n 0.51500 145860.0n 0.51500 145989.9n 0.51500 145990.0n 0.51500 146119.9n 0.51500 146120.0n 0.51500 146249.9n 0.51500 146250.0n 0.51500 146379.9n 0.51500 146380.0n 0.51500 146509.9n 0.51500 146510.0n 0.51500 146639.9n 0.51500 146640.0n 0.51500 146769.9n 0.51500 146770.0n 0.51500 146899.9n 0.51500 146900.0n 0.51500 147029.9n 0.51500 147030.0n 0.51500 147159.9n 0.51500 147160.0n 0.51500 147289.9n 0.51500 147290.0n 0.51500 147419.9n 0.51500 147420.0n 0.51500 147549.9n 0.51500 147550.0n 0.51500 147679.9n 0.51500 147680.0n 0.51500 147809.9n 0.51500 147810.0n 0.51500 147939.9n 0.51500 147940.0n 0.51500 148069.9n 0.51500 148070.0n 0.51500 148199.9n 0.51500 148200.0n 0.51500 148329.9n 0.51500 148330.0n 0.51500 148459.9n 0.51500 148460.0n 0.51500 148589.9n 0.51500 148590.0n 0.51500 148719.9n 0.51500 148720.0n 0.51500 148849.9n 0.51500 148850.0n 0.51500 148979.9n 0.51500 148980.0n 0.51500 149109.9n 0.51500 149110.0n 0.51500 149239.9n 0.51500 149240.0n 0.51500 149369.9n 0.51500 149370.0n 0.51500 149499.9n 0.51500 149500.0n 0.51500 149629.9n 0.51500 149630.0n 0.51500 149759.9n 0.51500 149760.0n 0.51500 149889.9n 0.51500 149890.0n 0.51500 150019.9n 0.51500 150020.0n 0.51500 150149.9n 0.51500 150150.0n 0.51500 150279.9n 0.51500 150280.0n 0.51500 150409.9n 0.51500 150410.0n 0.51500 150539.9n 0.51500 150540.0n 0.51500 150669.9n 0.51500 150670.0n 0.51500 150799.9n 0.51500 150800.0n 0.51500 150929.9n 0.51500 150930.0n 0.51500 151059.9n 0.51500 151060.0n 0.51500 151189.9n 0.51500 151190.0n 0.51500 151319.9n 0.51500 151320.0n 0.51500 151449.9n 0.51500 151450.0n 0.51500 151579.9n 0.51500 151580.0n 0.51500 151709.9n 0.51500 151710.0n 0.51500 151839.9n 0.51500 151840.0n 0.51500 151969.9n 0.51500 151970.0n 0.51500 152099.9n 0.51500 152100.0n 0.51500 152229.9n 0.51500 152230.0n 0.51500 152359.9n 0.51500 152360.0n 0.51500 152489.9n 0.51500 152490.0n 0.51500 152619.9n 0.51500 152620.0n 0.51500 152749.9n 0.51500 152750.0n 0.51500 152879.9n 0.51500 152880.0n 0.51500 153009.9n 0.51500 153010.0n 0.51500 153139.9n 0.51500 153140.0n 0.51500 153269.9n 0.51500 153270.0n 0.51500 153399.9n 0.51500 153400.0n 0.51500 153529.9n 0.51500 153530.0n 0.51500 153659.9n 0.51500 153660.0n 0.51500 153789.9n 0.51500 153790.0n 0.51500 153919.9n 0.51500 153920.0n 0.51500 154049.9n 0.51500 154050.0n 0.51500 154179.9n 0.51500 154180.0n 0.51500 154309.9n 0.51500 154310.0n 0.51500 154439.9n 0.51500 154440.0n 0.51500 154569.9n 0.51500 154570.0n 0.51500 154699.9n 0.51500 154700.0n 0.51500 154829.9n 0.51500 154830.0n 0.51500 154959.9n 0.51500 154960.0n 0.51500 155089.9n 0.51500 155090.0n 0.51500 155219.9n 0.51500 155220.0n 0.51500 155349.9n 0.51500 155350.0n 0.51500 155479.9n 0.51500 155480.0n 0.51500 155609.9n 0.51500 155610.0n 0.51500 155739.9n 0.51500 155740.0n 0.51500 155869.9n 0.51500 155870.0n 0.51500 155999.9n 0.51500 156000.0n 0.51500 156129.9n 0.51500 156130.0n 0.51500 156259.9n 0.51500 156260.0n 0.51500 156389.9n 0.51500 156390.0n 0.51500 156519.9n 0.51500 156520.0n 0.51500 156649.9n 0.51500 156650.0n 0.51500 156779.9n 0.51500 156780.0n 0.51500 156909.9n 0.51500 156910.0n 0.51500 157039.9n 0.51500 157040.0n 0.51500 157169.9n 0.51500 157170.0n 0.51500 157299.9n 0.51500 157300.0n 0.51500 157429.9n 0.51500 157430.0n 0.51500 157559.9n 0.51500 157560.0n 0.51500 157689.9n 0.51500 157690.0n 0.51500 157819.9n 0.51500 157820.0n 0.51500 157949.9n 0.51500 157950.0n 0.51500 158079.9n 0.51500 158080.0n 0.51500 158209.9n 0.51500 158210.0n 0.51500 158339.9n 0.51500 158340.0n 0.51500 158469.9n 0.51500 158470.0n 0.51500 158599.9n 0.51500 158600.0n 0.51500 158729.9n 0.51500 158730.0n 0.51500 158859.9n 0.51500 158860.0n 0.51500 158989.9n 0.51500 158990.0n 0.51500 159119.9n 0.51500 159120.0n 0.51500 159249.9n 0.51500 159250.0n 0.51500 159379.9n 0.51500 159380.0n 0.51500 159509.9n 0.51500 159510.0n 0.51500 159639.9n 0.51500 159640.0n 0.51500 159769.9n 0.51500 159770.0n 0.51500 159899.9n 0.51500 159900.0n 0.51500 160029.9n 0.51500 160030.0n 0.51500 160159.9n 0.51500 160160.0n 0.51500 160289.9n 0.51500 160290.0n 0.51500 160419.9n 0.51500 160420.0n 0.51500 160549.9n 0.51500 160550.0n 0.51500 160679.9n 0.51500 160680.0n 0.51500 160809.9n 0.51500 160810.0n 0.51500 160939.9n 0.51500 160940.0n 0.51500 161069.9n 0.51500 161070.0n 0.51500 161199.9n 0.51500 161200.0n 0.51500 161329.9n 0.51500 161330.0n 0.51500 161459.9n 0.51500 161460.0n 0.51500 161589.9n 0.51500 161590.0n 0.51500 161719.9n 0.51500 161720.0n 0.51500 161849.9n 0.51500 161850.0n 0.51500 161979.9n 0.51500 161980.0n 0.51500 162109.9n 0.51500 162110.0n 0.51500 162239.9n 0.51500 162240.0n 0.51500 162369.9n 0.51500 162370.0n 0.51500 162499.9n 0.51500 162500.0n 0.51500 162629.9n 0.51500 162630.0n 0.51500 162759.9n 0.51500 162760.0n 0.51500 162889.9n 0.51500 162890.0n 0.51500 163019.9n 0.51500 163020.0n 0.51500 163149.9n 0.51500 163150.0n 0.51500 163279.9n 0.51500 163280.0n 0.51500 163409.9n 0.51500 163410.0n 0.51500 163539.9n 0.51500 163540.0n 0.51500 163669.9n 0.51500 163670.0n 0.51500 163799.9n 0.51500 163800.0n 0.51500 163929.9n 0.51500 163930.0n 0.51500 164059.9n 0.51500 164060.0n 0.51500 164189.9n 0.51500 164190.0n 0.51500 164319.9n 0.51500 164320.0n 0.51500 164449.9n 0.51500 164450.0n 0.51500 164579.9n 0.51500 164580.0n 0.51500 164709.9n 0.51500 164710.0n 0.51500 164839.9n 0.51500 164840.0n 0.51500 164969.9n 0.51500 164970.0n 0.51500 165099.9n 0.51500 165100.0n 0.51500 165229.9n 0.51500 165230.0n 0.51500 165359.9n 0.51500 165360.0n 0.51500 165489.9n 0.51500 165490.0n 0.51500 165619.9n 0.51500 165620.0n 0.51500 165749.9n 0.51500 165750.0n 0.51500 165879.9n 0.51500 165880.0n 0.51500 166009.9n 0.51500 166010.0n 0.51500 166139.9n 0.51500 166140.0n 0.51500 166269.9n 0.51500 166270.0n 0.51500 166399.9n 0.51500 166400.0n 0.51500 166529.9n 0.51500 166530.0n 0.51500 166659.9n 0.51500 166660.0n 0.51500 166789.9n 0.51500 166790.0n 0.51500 166919.9n 0.51500 166920.0n 0.51500 167049.9n 0.51500 167050.0n 0.51500 167179.9n 0.51500 167180.0n 0.51500 167309.9n 0.51500 167310.0n 0.51500 167439.9n 0.51500 167440.0n 0.51500 167569.9n 0.51500 167570.0n 0.51500 167699.9n 0.51500 167700.0n 0.51500 167829.9n 0.51500 167830.0n 0.51500 167959.9n 0.51500 167960.0n 0.51500 168089.9n 0.51500 168090.0n 0.51500 168219.9n 0.51500 168220.0n 0.51500 168349.9n 0.51500 168350.0n 0.51500)
Xcomp sref sop cdum conf vdd vbneu dneuron
Rgbl gbl gblg 30k
Vmsrc msrc 0 0.18
Mgate gblg conf msrc 0 NNR W=600u L=100u
Cconf conf 0 2p
Csop sop 0 2p
Cgblg gblg 0 2p
Xlrn_0_0 eop0 eon0 ahp0 ahn0 who_p_0_0 who_n_0_0 vdd gblg gprod
Xlrn_1_0 eop0 eon0 ahp1 ahn1 who_p_1_0 who_n_1_0 vdd gblg gprod
Xlrn_2_0 eop0 eon0 ahp2 ahn2 who_p_2_0 who_n_2_0 vdd gblg gprod
Xlrn_3_0 eop0 eon0 ahp3 ahn3 who_p_3_0 who_n_3_0 vdd gblg gprod
Xlrn_4_0 eop0 eon0 ahp4 ahn4 who_p_4_0 who_n_4_0 vdd gblg gprod
Xlrn_5_0 eop0 eon0 ahp5 ahn5 who_p_5_0 who_n_5_0 vdd gblg gprod
Xlrn_6_0 eop0 eon0 ahp6 ahn6 who_p_6_0 who_n_6_0 vdd gblg gprod
Xlrn_7_0 eop0 eon0 ahp7 ahn7 who_p_7_0 who_n_7_0 vdd gblg gprod
Xlrn_8_0 eop0 eon0 ahp8 ahn8 who_p_8_0 who_n_8_0 vdd gblg gprod
Xlrn_9_0 eop0 eon0 ahp9 ahn9 who_p_9_0 who_n_9_0 vdd gblg gprod
Xlrn_10_0 eop0 eon0 ahp10 ahn10 who_p_10_0 who_n_10_0 vdd gblg gprod
Xlrn_11_0 eop0 eon0 ahp11 ahn11 who_p_11_0 who_n_11_0 vdd gblg gprod
Xlrn_12_0 eop0 eon0 ahp12 ahn12 who_p_12_0 who_n_12_0 vdd gblg gprod
Xlrn_13_0 eop0 eon0 ahp13 ahn13 who_p_13_0 who_n_13_0 vdd gblg gprod
Xlrn_14_0 eop0 eon0 ahp14 ahn14 who_p_14_0 who_n_14_0 vdd gblg gprod
Xlrn_15_0 eop0 eon0 ahp15 ahn15 who_p_15_0 who_n_15_0 vdd gblg gprod
Xlrn_16_0 eop0 eon0 ahp16 ahn16 who_p_16_0 who_n_16_0 vdd gblg gprod
Xlrn_17_0 eop0 eon0 ahp17 ahn17 who_p_17_0 who_n_17_0 vdd gblg gprod
Xlrn_18_0 eop0 eon0 ahp18 ahn18 who_p_18_0 who_n_18_0 vdd gblg gprod
Xlrn_19_0 eop0 eon0 ahp19 ahn19 who_p_19_0 who_n_19_0 vdd gblg gprod
Xlrn_20_0 eop0 eon0 ahp20 ahn20 who_p_20_0 who_n_20_0 vdd gblg gprod
Xlrn_21_0 eop0 eon0 ahp21 ahn21 who_p_21_0 who_n_21_0 vdd gblg gprod
Xlrn_22_0 eop0 eon0 ahp22 ahn22 who_p_22_0 who_n_22_0 vdd gblg gprod
Xlrn_23_0 eop0 eon0 ahp23 ahn23 who_p_23_0 who_n_23_0 vdd gblg gprod
Xlrn_24_0 eop0 eon0 ahp24 ahn24 who_p_24_0 who_n_24_0 vdd gblg gprod
Xlrn_25_0 eop0 eon0 ahp25 ahn25 who_p_25_0 who_n_25_0 vdd gblg gprod
Xlrn_26_0 eop0 eon0 ahp26 ahn26 who_p_26_0 who_n_26_0 vdd gblg gprod
Xlrn_27_0 eop0 eon0 ahp27 ahn27 who_p_27_0 who_n_27_0 vdd gblg gprod
Xlrn_28_0 eop0 eon0 ahp28 ahn28 who_p_28_0 who_n_28_0 vdd gblg gprod
Xlrn_29_0 eop0 eon0 ahp29 ahn29 who_p_29_0 who_n_29_0 vdd gblg gprod
Xlrn_30_0 eop0 eon0 ahp30 ahn30 who_p_30_0 who_n_30_0 vdd gblg gprod
Xlrn_31_0 eop0 eon0 ahp31 ahn31 who_p_31_0 who_n_31_0 vdd gblg gprod
Xlrn_32_0 eop0 eon0 ahp32 ahn32 who_p_32_0 who_n_32_0 vdd gblg gprod
Xlrn_33_0 eop0 eon0 ahp33 ahn33 who_p_33_0 who_n_33_0 vdd gblg gprod
Xlrn_34_0 eop0 eon0 ahp34 ahn34 who_p_34_0 who_n_34_0 vdd gblg gprod
Xlrn_35_0 eop0 eon0 ahp35 ahn35 who_p_35_0 who_n_35_0 vdd gblg gprod
Xlrn_36_0 eop0 eon0 ahp36 ahn36 who_p_36_0 who_n_36_0 vdd gblg gprod
Xlrn_37_0 eop0 eon0 ahp37 ahn37 who_p_37_0 who_n_37_0 vdd gblg gprod
Xlrn_38_0 eop0 eon0 ahp38 ahn38 who_p_38_0 who_n_38_0 vdd gblg gprod
Xlrn_39_0 eop0 eon0 ahp39 ahn39 who_p_39_0 who_n_39_0 vdd gblg gprod
Xlrn_40_0 eop0 eon0 ahp40 ahn40 who_p_40_0 who_n_40_0 vdd gblg gprod
Xlrn_41_0 eop0 eon0 ahp41 ahn41 who_p_41_0 who_n_41_0 vdd gblg gprod
Xlrn_42_0 eop0 eon0 ahp42 ahn42 who_p_42_0 who_n_42_0 vdd gblg gprod
Xlrn_43_0 eop0 eon0 ahp43 ahn43 who_p_43_0 who_n_43_0 vdd gblg gprod
Xlrn_44_0 eop0 eon0 ahp44 ahn44 who_p_44_0 who_n_44_0 vdd gblg gprod
Xlrn_45_0 eop0 eon0 ahp45 ahn45 who_p_45_0 who_n_45_0 vdd gblg gprod
Xlrn_46_0 eop0 eon0 ahp46 ahn46 who_p_46_0 who_n_46_0 vdd gblg gprod
Xlrn_47_0 eop0 eon0 ahp47 ahn47 who_p_47_0 who_n_47_0 vdd gblg gprod
Xlrn_48_0 eop0 eon0 ahp48 ahn48 who_p_48_0 who_n_48_0 vdd gblg gprod
Xlrn_49_0 eop0 eon0 ahp49 ahn49 who_p_49_0 who_n_49_0 vdd gblg gprod
Xlrn_50_0 eop0 eon0 ahp50 ahn50 who_p_50_0 who_n_50_0 vdd gblg gprod
Xlrn_51_0 eop0 eon0 ahp51 ahn51 who_p_51_0 who_n_51_0 vdd gblg gprod
Xlrn_52_0 eop0 eon0 ahp52 ahn52 who_p_52_0 who_n_52_0 vdd gblg gprod
Xlrn_53_0 eop0 eon0 ahp53 ahn53 who_p_53_0 who_n_53_0 vdd gblg gprod
Xlrn_54_0 eop0 eon0 ahp54 ahn54 who_p_54_0 who_n_54_0 vdd gblg gprod
Xlrn_55_0 eop0 eon0 ahp55 ahn55 who_p_55_0 who_n_55_0 vdd gblg gprod
Xlrn_56_0 eop0 eon0 ahp56 ahn56 who_p_56_0 who_n_56_0 vdd gblg gprod
Xlrn_57_0 eop0 eon0 ahp57 ahn57 who_p_57_0 who_n_57_0 vdd gblg gprod
Xlrn_58_0 eop0 eon0 ahp58 ahn58 who_p_58_0 who_n_58_0 vdd gblg gprod
Xlrn_59_0 eop0 eon0 ahp59 ahn59 who_p_59_0 who_n_59_0 vdd gblg gprod
Xlrn_60_0 eop0 eon0 ahp60 ahn60 who_p_60_0 who_n_60_0 vdd gblg gprod
Xlrn_61_0 eop0 eon0 ahp61 ahn61 who_p_61_0 who_n_61_0 vdd gblg gprod
Xlrn_62_0 eop0 eon0 ahp62 ahn62 who_p_62_0 who_n_62_0 vdd gblg gprod
Xlrn_63_0 eop0 eon0 ahp63 ahn63 who_p_63_0 who_n_63_0 vdd gblg gprod
Xlrn_64_0 eop0 eon0 ahp64 ahn64 who_p_64_0 who_n_64_0 vdd gblg gprod
Xlrn_65_0 eop0 eon0 ahp65 ahn65 who_p_65_0 who_n_65_0 vdd gblg gprod
Xlrn_66_0 eop0 eon0 ahp66 ahn66 who_p_66_0 who_n_66_0 vdd gblg gprod
Xlrn_67_0 eop0 eon0 ahp67 ahn67 who_p_67_0 who_n_67_0 vdd gblg gprod
Xlrn_68_0 eop0 eon0 ahp68 ahn68 who_p_68_0 who_n_68_0 vdd gblg gprod
Xlrn_69_0 eop0 eon0 ahp69 ahn69 who_p_69_0 who_n_69_0 vdd gblg gprod
Xlrn_70_0 eop0 eon0 ahp70 ahn70 who_p_70_0 who_n_70_0 vdd gblg gprod
Xlrn_71_0 eop0 eon0 ahp71 ahn71 who_p_71_0 who_n_71_0 vdd gblg gprod
Xlrn_72_0 eop0 eon0 ahp72 ahn72 who_p_72_0 who_n_72_0 vdd gblg gprod
Xlrn_73_0 eop0 eon0 ahp73 ahn73 who_p_73_0 who_n_73_0 vdd gblg gprod
Xlrn_74_0 eop0 eon0 ahp74 ahn74 who_p_74_0 who_n_74_0 vdd gblg gprod
Xlrn_75_0 eop0 eon0 ahp75 ahn75 who_p_75_0 who_n_75_0 vdd gblg gprod
Xlrn_76_0 eop0 eon0 ahp76 ahn76 who_p_76_0 who_n_76_0 vdd gblg gprod
Xlrn_77_0 eop0 eon0 ahp77 ahn77 who_p_77_0 who_n_77_0 vdd gblg gprod
Xlrn_78_0 eop0 eon0 ahp78 ahn78 who_p_78_0 who_n_78_0 vdd gblg gprod
Xlrn_79_0 eop0 eon0 ahp79 ahn79 who_p_79_0 who_n_79_0 vdd gblg gprod
Xlrn_80_0 eop0 eon0 ahp80 ahn80 who_p_80_0 who_n_80_0 vdd gblg gprod
Xlrn_81_0 eop0 eon0 ahp81 ahn81 who_p_81_0 who_n_81_0 vdd gblg gprod
Xlrn_82_0 eop0 eon0 ahp82 ahn82 who_p_82_0 who_n_82_0 vdd gblg gprod
Xlrn_83_0 eop0 eon0 ahp83 ahn83 who_p_83_0 who_n_83_0 vdd gblg gprod
Xlrn_84_0 eop0 eon0 ahp84 ahn84 who_p_84_0 who_n_84_0 vdd gblg gprod
Xlrn_85_0 eop0 eon0 ahp85 ahn85 who_p_85_0 who_n_85_0 vdd gblg gprod
Xlrn_86_0 eop0 eon0 ahp86 ahn86 who_p_86_0 who_n_86_0 vdd gblg gprod
Xlrn_87_0 eop0 eon0 ahp87 ahn87 who_p_87_0 who_n_87_0 vdd gblg gprod
Xlrn_88_0 eop0 eon0 ahp88 ahn88 who_p_88_0 who_n_88_0 vdd gblg gprod
Xlrn_89_0 eop0 eon0 ahp89 ahn89 who_p_89_0 who_n_89_0 vdd gblg gprod
Xlrn_90_0 eop0 eon0 ahp90 ahn90 who_p_90_0 who_n_90_0 vdd gblg gprod
Xlrn_91_0 eop0 eon0 ahp91 ahn91 who_p_91_0 who_n_91_0 vdd gblg gprod
Xlrn_92_0 eop0 eon0 ahp92 ahn92 who_p_92_0 who_n_92_0 vdd gblg gprod
Xlrn_93_0 eop0 eon0 ahp93 ahn93 who_p_93_0 who_n_93_0 vdd gblg gprod
Xlrn_94_0 eop0 eon0 ahp94 ahn94 who_p_94_0 who_n_94_0 vdd gblg gprod
Xlrn_95_0 eop0 eon0 ahp95 ahn95 who_p_95_0 who_n_95_0 vdd gblg gprod
Xlrn_96_0 eop0 eon0 ahp96 ahn96 who_p_96_0 who_n_96_0 vdd gblg gprod
Xlrn_97_0 eop0 eon0 ahp97 ahn97 who_p_97_0 who_n_97_0 vdd gblg gprod
Xlrn_98_0 eop0 eon0 ahp98 ahn98 who_p_98_0 who_n_98_0 vdd gblg gprod
Xlrn_99_0 eop0 eon0 ahp99 ahn99 who_p_99_0 who_n_99_0 vdd gblg gprod
Xlrn_100_0 eop0 eon0 ahp100 ahn100 who_p_100_0 who_n_100_0 vdd gblg gprod
Xlrn_101_0 eop0 eon0 ahp101 ahn101 who_p_101_0 who_n_101_0 vdd gblg gprod
Xlrn_102_0 eop0 eon0 ahp102 ahn102 who_p_102_0 who_n_102_0 vdd gblg gprod
Xlrn_103_0 eop0 eon0 ahp103 ahn103 who_p_103_0 who_n_103_0 vdd gblg gprod
Xlrn_104_0 eop0 eon0 ahp104 ahn104 who_p_104_0 who_n_104_0 vdd gblg gprod
Xlrn_105_0 eop0 eon0 ahp105 ahn105 who_p_105_0 who_n_105_0 vdd gblg gprod
Xlrn_106_0 eop0 eon0 ahp106 ahn106 who_p_106_0 who_n_106_0 vdd gblg gprod
Xlrn_107_0 eop0 eon0 ahp107 ahn107 who_p_107_0 who_n_107_0 vdd gblg gprod
Xlrn_108_0 eop0 eon0 ahp108 ahn108 who_p_108_0 who_n_108_0 vdd gblg gprod
Xlrn_109_0 eop0 eon0 ahp109 ahn109 who_p_109_0 who_n_109_0 vdd gblg gprod
Xlrn_110_0 eop0 eon0 ahp110 ahn110 who_p_110_0 who_n_110_0 vdd gblg gprod
Xlrn_111_0 eop0 eon0 ahp111 ahn111 who_p_111_0 who_n_111_0 vdd gblg gprod
Xlrn_112_0 eop0 eon0 ahp112 ahn112 who_p_112_0 who_n_112_0 vdd gblg gprod
Xlrn_113_0 eop0 eon0 ahp113 ahn113 who_p_113_0 who_n_113_0 vdd gblg gprod
Xlrn_114_0 eop0 eon0 ahp114 ahn114 who_p_114_0 who_n_114_0 vdd gblg gprod
Xlrn_115_0 eop0 eon0 ahp115 ahn115 who_p_115_0 who_n_115_0 vdd gblg gprod
Xlrn_116_0 eop0 eon0 ahp116 ahn116 who_p_116_0 who_n_116_0 vdd gblg gprod
Xlrn_117_0 eop0 eon0 ahp117 ahn117 who_p_117_0 who_n_117_0 vdd gblg gprod
Xlrn_118_0 eop0 eon0 ahp118 ahn118 who_p_118_0 who_n_118_0 vdd gblg gprod
Xlrn_119_0 eop0 eon0 ahp119 ahn119 who_p_119_0 who_n_119_0 vdd gblg gprod
Xlrn_120_0 eop0 eon0 ahp120 ahn120 who_p_120_0 who_n_120_0 vdd gblg gprod
Xlrn_121_0 eop0 eon0 ahp121 ahn121 who_p_121_0 who_n_121_0 vdd gblg gprod
Xlrn_122_0 eop0 eon0 ahp122 ahn122 who_p_122_0 who_n_122_0 vdd gblg gprod
Xlrn_123_0 eop0 eon0 ahp123 ahn123 who_p_123_0 who_n_123_0 vdd gblg gprod
Xlrn_124_0 eop0 eon0 ahp124 ahn124 who_p_124_0 who_n_124_0 vdd gblg gprod
Xlrn_125_0 eop0 eon0 ahp125 ahn125 who_p_125_0 who_n_125_0 vdd gblg gprod
Xlrn_126_0 eop0 eon0 ahp126 ahn126 who_p_126_0 who_n_126_0 vdd gblg gprod
Xlrn_127_0 eop0 eon0 ahp127 ahn127 who_p_127_0 who_n_127_0 vdd gblg gprod
Xlrn_128_0 eop0 eon0 ahp128 ahn128 who_p_128_0 who_n_128_0 vdd gblg gprod
Xlrn_129_0 eop0 eon0 ahp129 ahn129 who_p_129_0 who_n_129_0 vdd gblg gprod
Xlrn_130_0 eop0 eon0 ahp130 ahn130 who_p_130_0 who_n_130_0 vdd gblg gprod
Xlrn_131_0 eop0 eon0 ahp131 ahn131 who_p_131_0 who_n_131_0 vdd gblg gprod
Xlrn_132_0 eop0 eon0 ahp132 ahn132 who_p_132_0 who_n_132_0 vdd gblg gprod
Xlrn_133_0 eop0 eon0 ahp133 ahn133 who_p_133_0 who_n_133_0 vdd gblg gprod
Xlrn_134_0 eop0 eon0 ahp134 ahn134 who_p_134_0 who_n_134_0 vdd gblg gprod
Xlrn_135_0 eop0 eon0 ahp135 ahn135 who_p_135_0 who_n_135_0 vdd gblg gprod
Xlrn_136_0 eop0 eon0 ahp136 ahn136 who_p_136_0 who_n_136_0 vdd gblg gprod
Xlrn_137_0 eop0 eon0 ahp137 ahn137 who_p_137_0 who_n_137_0 vdd gblg gprod
Xlrn_138_0 eop0 eon0 ahp138 ahn138 who_p_138_0 who_n_138_0 vdd gblg gprod
Xlrn_139_0 eop0 eon0 ahp139 ahn139 who_p_139_0 who_n_139_0 vdd gblg gprod
Xlrn_140_0 eop0 eon0 ahp140 ahn140 who_p_140_0 who_n_140_0 vdd gblg gprod
Xlrn_141_0 eop0 eon0 ahp141 ahn141 who_p_141_0 who_n_141_0 vdd gblg gprod
Xlrn_142_0 eop0 eon0 ahp142 ahn142 who_p_142_0 who_n_142_0 vdd gblg gprod
Xlrn_143_0 eop0 eon0 ahp143 ahn143 who_p_143_0 who_n_143_0 vdd gblg gprod
Xlrn_144_0 eop0 eon0 ahp144 ahn144 who_p_144_0 who_n_144_0 vdd gblg gprod
Xlrn_145_0 eop0 eon0 ahp145 ahn145 who_p_145_0 who_n_145_0 vdd gblg gprod
Xlrn_146_0 eop0 eon0 ahp146 ahn146 who_p_146_0 who_n_146_0 vdd gblg gprod
Xlrn_147_0 eop0 eon0 ahp147 ahn147 who_p_147_0 who_n_147_0 vdd gblg gprod
Xlrn_148_0 eop0 eon0 ahp148 ahn148 who_p_148_0 who_n_148_0 vdd gblg gprod
Xlrn_149_0 eop0 eon0 ahp149 ahn149 who_p_149_0 who_n_149_0 vdd gblg gprod
Xlrn_150_0 eop0 eon0 ahp150 ahn150 who_p_150_0 who_n_150_0 vdd gblg gprod
Xlrn_151_0 eop0 eon0 ahp151 ahn151 who_p_151_0 who_n_151_0 vdd gblg gprod
Xlrn_152_0 eop0 eon0 ahp152 ahn152 who_p_152_0 who_n_152_0 vdd gblg gprod
Xlrn_153_0 eop0 eon0 ahp153 ahn153 who_p_153_0 who_n_153_0 vdd gblg gprod
Xlrn_154_0 eop0 eon0 ahp154 ahn154 who_p_154_0 who_n_154_0 vdd gblg gprod
Xlrn_155_0 eop0 eon0 ahp155 ahn155 who_p_155_0 who_n_155_0 vdd gblg gprod
Xlrn_156_0 eop0 eon0 ahp156 ahn156 who_p_156_0 who_n_156_0 vdd gblg gprod
Xlrn_157_0 eop0 eon0 ahp157 ahn157 who_p_157_0 who_n_157_0 vdd gblg gprod
Xlrn_158_0 eop0 eon0 ahp158 ahn158 who_p_158_0 who_n_158_0 vdd gblg gprod
Xlrn_159_0 eop0 eon0 ahp159 ahn159 who_p_159_0 who_n_159_0 vdd gblg gprod
Xlrn_160_0 eop0 eon0 ahbias_p ahbias_n who_p_160_0 who_n_160_0 vdd gblg gprod
Xlrn_0_1 eop1 eon1 ahp0 ahn0 who_p_0_1 who_n_0_1 vdd gblg gprod
Xlrn_1_1 eop1 eon1 ahp1 ahn1 who_p_1_1 who_n_1_1 vdd gblg gprod
Xlrn_2_1 eop1 eon1 ahp2 ahn2 who_p_2_1 who_n_2_1 vdd gblg gprod
Xlrn_3_1 eop1 eon1 ahp3 ahn3 who_p_3_1 who_n_3_1 vdd gblg gprod
Xlrn_4_1 eop1 eon1 ahp4 ahn4 who_p_4_1 who_n_4_1 vdd gblg gprod
Xlrn_5_1 eop1 eon1 ahp5 ahn5 who_p_5_1 who_n_5_1 vdd gblg gprod
Xlrn_6_1 eop1 eon1 ahp6 ahn6 who_p_6_1 who_n_6_1 vdd gblg gprod
Xlrn_7_1 eop1 eon1 ahp7 ahn7 who_p_7_1 who_n_7_1 vdd gblg gprod
Xlrn_8_1 eop1 eon1 ahp8 ahn8 who_p_8_1 who_n_8_1 vdd gblg gprod
Xlrn_9_1 eop1 eon1 ahp9 ahn9 who_p_9_1 who_n_9_1 vdd gblg gprod
Xlrn_10_1 eop1 eon1 ahp10 ahn10 who_p_10_1 who_n_10_1 vdd gblg gprod
Xlrn_11_1 eop1 eon1 ahp11 ahn11 who_p_11_1 who_n_11_1 vdd gblg gprod
Xlrn_12_1 eop1 eon1 ahp12 ahn12 who_p_12_1 who_n_12_1 vdd gblg gprod
Xlrn_13_1 eop1 eon1 ahp13 ahn13 who_p_13_1 who_n_13_1 vdd gblg gprod
Xlrn_14_1 eop1 eon1 ahp14 ahn14 who_p_14_1 who_n_14_1 vdd gblg gprod
Xlrn_15_1 eop1 eon1 ahp15 ahn15 who_p_15_1 who_n_15_1 vdd gblg gprod
Xlrn_16_1 eop1 eon1 ahp16 ahn16 who_p_16_1 who_n_16_1 vdd gblg gprod
Xlrn_17_1 eop1 eon1 ahp17 ahn17 who_p_17_1 who_n_17_1 vdd gblg gprod
Xlrn_18_1 eop1 eon1 ahp18 ahn18 who_p_18_1 who_n_18_1 vdd gblg gprod
Xlrn_19_1 eop1 eon1 ahp19 ahn19 who_p_19_1 who_n_19_1 vdd gblg gprod
Xlrn_20_1 eop1 eon1 ahp20 ahn20 who_p_20_1 who_n_20_1 vdd gblg gprod
Xlrn_21_1 eop1 eon1 ahp21 ahn21 who_p_21_1 who_n_21_1 vdd gblg gprod
Xlrn_22_1 eop1 eon1 ahp22 ahn22 who_p_22_1 who_n_22_1 vdd gblg gprod
Xlrn_23_1 eop1 eon1 ahp23 ahn23 who_p_23_1 who_n_23_1 vdd gblg gprod
Xlrn_24_1 eop1 eon1 ahp24 ahn24 who_p_24_1 who_n_24_1 vdd gblg gprod
Xlrn_25_1 eop1 eon1 ahp25 ahn25 who_p_25_1 who_n_25_1 vdd gblg gprod
Xlrn_26_1 eop1 eon1 ahp26 ahn26 who_p_26_1 who_n_26_1 vdd gblg gprod
Xlrn_27_1 eop1 eon1 ahp27 ahn27 who_p_27_1 who_n_27_1 vdd gblg gprod
Xlrn_28_1 eop1 eon1 ahp28 ahn28 who_p_28_1 who_n_28_1 vdd gblg gprod
Xlrn_29_1 eop1 eon1 ahp29 ahn29 who_p_29_1 who_n_29_1 vdd gblg gprod
Xlrn_30_1 eop1 eon1 ahp30 ahn30 who_p_30_1 who_n_30_1 vdd gblg gprod
Xlrn_31_1 eop1 eon1 ahp31 ahn31 who_p_31_1 who_n_31_1 vdd gblg gprod
Xlrn_32_1 eop1 eon1 ahp32 ahn32 who_p_32_1 who_n_32_1 vdd gblg gprod
Xlrn_33_1 eop1 eon1 ahp33 ahn33 who_p_33_1 who_n_33_1 vdd gblg gprod
Xlrn_34_1 eop1 eon1 ahp34 ahn34 who_p_34_1 who_n_34_1 vdd gblg gprod
Xlrn_35_1 eop1 eon1 ahp35 ahn35 who_p_35_1 who_n_35_1 vdd gblg gprod
Xlrn_36_1 eop1 eon1 ahp36 ahn36 who_p_36_1 who_n_36_1 vdd gblg gprod
Xlrn_37_1 eop1 eon1 ahp37 ahn37 who_p_37_1 who_n_37_1 vdd gblg gprod
Xlrn_38_1 eop1 eon1 ahp38 ahn38 who_p_38_1 who_n_38_1 vdd gblg gprod
Xlrn_39_1 eop1 eon1 ahp39 ahn39 who_p_39_1 who_n_39_1 vdd gblg gprod
Xlrn_40_1 eop1 eon1 ahp40 ahn40 who_p_40_1 who_n_40_1 vdd gblg gprod
Xlrn_41_1 eop1 eon1 ahp41 ahn41 who_p_41_1 who_n_41_1 vdd gblg gprod
Xlrn_42_1 eop1 eon1 ahp42 ahn42 who_p_42_1 who_n_42_1 vdd gblg gprod
Xlrn_43_1 eop1 eon1 ahp43 ahn43 who_p_43_1 who_n_43_1 vdd gblg gprod
Xlrn_44_1 eop1 eon1 ahp44 ahn44 who_p_44_1 who_n_44_1 vdd gblg gprod
Xlrn_45_1 eop1 eon1 ahp45 ahn45 who_p_45_1 who_n_45_1 vdd gblg gprod
Xlrn_46_1 eop1 eon1 ahp46 ahn46 who_p_46_1 who_n_46_1 vdd gblg gprod
Xlrn_47_1 eop1 eon1 ahp47 ahn47 who_p_47_1 who_n_47_1 vdd gblg gprod
Xlrn_48_1 eop1 eon1 ahp48 ahn48 who_p_48_1 who_n_48_1 vdd gblg gprod
Xlrn_49_1 eop1 eon1 ahp49 ahn49 who_p_49_1 who_n_49_1 vdd gblg gprod
Xlrn_50_1 eop1 eon1 ahp50 ahn50 who_p_50_1 who_n_50_1 vdd gblg gprod
Xlrn_51_1 eop1 eon1 ahp51 ahn51 who_p_51_1 who_n_51_1 vdd gblg gprod
Xlrn_52_1 eop1 eon1 ahp52 ahn52 who_p_52_1 who_n_52_1 vdd gblg gprod
Xlrn_53_1 eop1 eon1 ahp53 ahn53 who_p_53_1 who_n_53_1 vdd gblg gprod
Xlrn_54_1 eop1 eon1 ahp54 ahn54 who_p_54_1 who_n_54_1 vdd gblg gprod
Xlrn_55_1 eop1 eon1 ahp55 ahn55 who_p_55_1 who_n_55_1 vdd gblg gprod
Xlrn_56_1 eop1 eon1 ahp56 ahn56 who_p_56_1 who_n_56_1 vdd gblg gprod
Xlrn_57_1 eop1 eon1 ahp57 ahn57 who_p_57_1 who_n_57_1 vdd gblg gprod
Xlrn_58_1 eop1 eon1 ahp58 ahn58 who_p_58_1 who_n_58_1 vdd gblg gprod
Xlrn_59_1 eop1 eon1 ahp59 ahn59 who_p_59_1 who_n_59_1 vdd gblg gprod
Xlrn_60_1 eop1 eon1 ahp60 ahn60 who_p_60_1 who_n_60_1 vdd gblg gprod
Xlrn_61_1 eop1 eon1 ahp61 ahn61 who_p_61_1 who_n_61_1 vdd gblg gprod
Xlrn_62_1 eop1 eon1 ahp62 ahn62 who_p_62_1 who_n_62_1 vdd gblg gprod
Xlrn_63_1 eop1 eon1 ahp63 ahn63 who_p_63_1 who_n_63_1 vdd gblg gprod
Xlrn_64_1 eop1 eon1 ahp64 ahn64 who_p_64_1 who_n_64_1 vdd gblg gprod
Xlrn_65_1 eop1 eon1 ahp65 ahn65 who_p_65_1 who_n_65_1 vdd gblg gprod
Xlrn_66_1 eop1 eon1 ahp66 ahn66 who_p_66_1 who_n_66_1 vdd gblg gprod
Xlrn_67_1 eop1 eon1 ahp67 ahn67 who_p_67_1 who_n_67_1 vdd gblg gprod
Xlrn_68_1 eop1 eon1 ahp68 ahn68 who_p_68_1 who_n_68_1 vdd gblg gprod
Xlrn_69_1 eop1 eon1 ahp69 ahn69 who_p_69_1 who_n_69_1 vdd gblg gprod
Xlrn_70_1 eop1 eon1 ahp70 ahn70 who_p_70_1 who_n_70_1 vdd gblg gprod
Xlrn_71_1 eop1 eon1 ahp71 ahn71 who_p_71_1 who_n_71_1 vdd gblg gprod
Xlrn_72_1 eop1 eon1 ahp72 ahn72 who_p_72_1 who_n_72_1 vdd gblg gprod
Xlrn_73_1 eop1 eon1 ahp73 ahn73 who_p_73_1 who_n_73_1 vdd gblg gprod
Xlrn_74_1 eop1 eon1 ahp74 ahn74 who_p_74_1 who_n_74_1 vdd gblg gprod
Xlrn_75_1 eop1 eon1 ahp75 ahn75 who_p_75_1 who_n_75_1 vdd gblg gprod
Xlrn_76_1 eop1 eon1 ahp76 ahn76 who_p_76_1 who_n_76_1 vdd gblg gprod
Xlrn_77_1 eop1 eon1 ahp77 ahn77 who_p_77_1 who_n_77_1 vdd gblg gprod
Xlrn_78_1 eop1 eon1 ahp78 ahn78 who_p_78_1 who_n_78_1 vdd gblg gprod
Xlrn_79_1 eop1 eon1 ahp79 ahn79 who_p_79_1 who_n_79_1 vdd gblg gprod
Xlrn_80_1 eop1 eon1 ahp80 ahn80 who_p_80_1 who_n_80_1 vdd gblg gprod
Xlrn_81_1 eop1 eon1 ahp81 ahn81 who_p_81_1 who_n_81_1 vdd gblg gprod
Xlrn_82_1 eop1 eon1 ahp82 ahn82 who_p_82_1 who_n_82_1 vdd gblg gprod
Xlrn_83_1 eop1 eon1 ahp83 ahn83 who_p_83_1 who_n_83_1 vdd gblg gprod
Xlrn_84_1 eop1 eon1 ahp84 ahn84 who_p_84_1 who_n_84_1 vdd gblg gprod
Xlrn_85_1 eop1 eon1 ahp85 ahn85 who_p_85_1 who_n_85_1 vdd gblg gprod
Xlrn_86_1 eop1 eon1 ahp86 ahn86 who_p_86_1 who_n_86_1 vdd gblg gprod
Xlrn_87_1 eop1 eon1 ahp87 ahn87 who_p_87_1 who_n_87_1 vdd gblg gprod
Xlrn_88_1 eop1 eon1 ahp88 ahn88 who_p_88_1 who_n_88_1 vdd gblg gprod
Xlrn_89_1 eop1 eon1 ahp89 ahn89 who_p_89_1 who_n_89_1 vdd gblg gprod
Xlrn_90_1 eop1 eon1 ahp90 ahn90 who_p_90_1 who_n_90_1 vdd gblg gprod
Xlrn_91_1 eop1 eon1 ahp91 ahn91 who_p_91_1 who_n_91_1 vdd gblg gprod
Xlrn_92_1 eop1 eon1 ahp92 ahn92 who_p_92_1 who_n_92_1 vdd gblg gprod
Xlrn_93_1 eop1 eon1 ahp93 ahn93 who_p_93_1 who_n_93_1 vdd gblg gprod
Xlrn_94_1 eop1 eon1 ahp94 ahn94 who_p_94_1 who_n_94_1 vdd gblg gprod
Xlrn_95_1 eop1 eon1 ahp95 ahn95 who_p_95_1 who_n_95_1 vdd gblg gprod
Xlrn_96_1 eop1 eon1 ahp96 ahn96 who_p_96_1 who_n_96_1 vdd gblg gprod
Xlrn_97_1 eop1 eon1 ahp97 ahn97 who_p_97_1 who_n_97_1 vdd gblg gprod
Xlrn_98_1 eop1 eon1 ahp98 ahn98 who_p_98_1 who_n_98_1 vdd gblg gprod
Xlrn_99_1 eop1 eon1 ahp99 ahn99 who_p_99_1 who_n_99_1 vdd gblg gprod
Xlrn_100_1 eop1 eon1 ahp100 ahn100 who_p_100_1 who_n_100_1 vdd gblg gprod
Xlrn_101_1 eop1 eon1 ahp101 ahn101 who_p_101_1 who_n_101_1 vdd gblg gprod
Xlrn_102_1 eop1 eon1 ahp102 ahn102 who_p_102_1 who_n_102_1 vdd gblg gprod
Xlrn_103_1 eop1 eon1 ahp103 ahn103 who_p_103_1 who_n_103_1 vdd gblg gprod
Xlrn_104_1 eop1 eon1 ahp104 ahn104 who_p_104_1 who_n_104_1 vdd gblg gprod
Xlrn_105_1 eop1 eon1 ahp105 ahn105 who_p_105_1 who_n_105_1 vdd gblg gprod
Xlrn_106_1 eop1 eon1 ahp106 ahn106 who_p_106_1 who_n_106_1 vdd gblg gprod
Xlrn_107_1 eop1 eon1 ahp107 ahn107 who_p_107_1 who_n_107_1 vdd gblg gprod
Xlrn_108_1 eop1 eon1 ahp108 ahn108 who_p_108_1 who_n_108_1 vdd gblg gprod
Xlrn_109_1 eop1 eon1 ahp109 ahn109 who_p_109_1 who_n_109_1 vdd gblg gprod
Xlrn_110_1 eop1 eon1 ahp110 ahn110 who_p_110_1 who_n_110_1 vdd gblg gprod
Xlrn_111_1 eop1 eon1 ahp111 ahn111 who_p_111_1 who_n_111_1 vdd gblg gprod
Xlrn_112_1 eop1 eon1 ahp112 ahn112 who_p_112_1 who_n_112_1 vdd gblg gprod
Xlrn_113_1 eop1 eon1 ahp113 ahn113 who_p_113_1 who_n_113_1 vdd gblg gprod
Xlrn_114_1 eop1 eon1 ahp114 ahn114 who_p_114_1 who_n_114_1 vdd gblg gprod
Xlrn_115_1 eop1 eon1 ahp115 ahn115 who_p_115_1 who_n_115_1 vdd gblg gprod
Xlrn_116_1 eop1 eon1 ahp116 ahn116 who_p_116_1 who_n_116_1 vdd gblg gprod
Xlrn_117_1 eop1 eon1 ahp117 ahn117 who_p_117_1 who_n_117_1 vdd gblg gprod
Xlrn_118_1 eop1 eon1 ahp118 ahn118 who_p_118_1 who_n_118_1 vdd gblg gprod
Xlrn_119_1 eop1 eon1 ahp119 ahn119 who_p_119_1 who_n_119_1 vdd gblg gprod
Xlrn_120_1 eop1 eon1 ahp120 ahn120 who_p_120_1 who_n_120_1 vdd gblg gprod
Xlrn_121_1 eop1 eon1 ahp121 ahn121 who_p_121_1 who_n_121_1 vdd gblg gprod
Xlrn_122_1 eop1 eon1 ahp122 ahn122 who_p_122_1 who_n_122_1 vdd gblg gprod
Xlrn_123_1 eop1 eon1 ahp123 ahn123 who_p_123_1 who_n_123_1 vdd gblg gprod
Xlrn_124_1 eop1 eon1 ahp124 ahn124 who_p_124_1 who_n_124_1 vdd gblg gprod
Xlrn_125_1 eop1 eon1 ahp125 ahn125 who_p_125_1 who_n_125_1 vdd gblg gprod
Xlrn_126_1 eop1 eon1 ahp126 ahn126 who_p_126_1 who_n_126_1 vdd gblg gprod
Xlrn_127_1 eop1 eon1 ahp127 ahn127 who_p_127_1 who_n_127_1 vdd gblg gprod
Xlrn_128_1 eop1 eon1 ahp128 ahn128 who_p_128_1 who_n_128_1 vdd gblg gprod
Xlrn_129_1 eop1 eon1 ahp129 ahn129 who_p_129_1 who_n_129_1 vdd gblg gprod
Xlrn_130_1 eop1 eon1 ahp130 ahn130 who_p_130_1 who_n_130_1 vdd gblg gprod
Xlrn_131_1 eop1 eon1 ahp131 ahn131 who_p_131_1 who_n_131_1 vdd gblg gprod
Xlrn_132_1 eop1 eon1 ahp132 ahn132 who_p_132_1 who_n_132_1 vdd gblg gprod
Xlrn_133_1 eop1 eon1 ahp133 ahn133 who_p_133_1 who_n_133_1 vdd gblg gprod
Xlrn_134_1 eop1 eon1 ahp134 ahn134 who_p_134_1 who_n_134_1 vdd gblg gprod
Xlrn_135_1 eop1 eon1 ahp135 ahn135 who_p_135_1 who_n_135_1 vdd gblg gprod
Xlrn_136_1 eop1 eon1 ahp136 ahn136 who_p_136_1 who_n_136_1 vdd gblg gprod
Xlrn_137_1 eop1 eon1 ahp137 ahn137 who_p_137_1 who_n_137_1 vdd gblg gprod
Xlrn_138_1 eop1 eon1 ahp138 ahn138 who_p_138_1 who_n_138_1 vdd gblg gprod
Xlrn_139_1 eop1 eon1 ahp139 ahn139 who_p_139_1 who_n_139_1 vdd gblg gprod
Xlrn_140_1 eop1 eon1 ahp140 ahn140 who_p_140_1 who_n_140_1 vdd gblg gprod
Xlrn_141_1 eop1 eon1 ahp141 ahn141 who_p_141_1 who_n_141_1 vdd gblg gprod
Xlrn_142_1 eop1 eon1 ahp142 ahn142 who_p_142_1 who_n_142_1 vdd gblg gprod
Xlrn_143_1 eop1 eon1 ahp143 ahn143 who_p_143_1 who_n_143_1 vdd gblg gprod
Xlrn_144_1 eop1 eon1 ahp144 ahn144 who_p_144_1 who_n_144_1 vdd gblg gprod
Xlrn_145_1 eop1 eon1 ahp145 ahn145 who_p_145_1 who_n_145_1 vdd gblg gprod
Xlrn_146_1 eop1 eon1 ahp146 ahn146 who_p_146_1 who_n_146_1 vdd gblg gprod
Xlrn_147_1 eop1 eon1 ahp147 ahn147 who_p_147_1 who_n_147_1 vdd gblg gprod
Xlrn_148_1 eop1 eon1 ahp148 ahn148 who_p_148_1 who_n_148_1 vdd gblg gprod
Xlrn_149_1 eop1 eon1 ahp149 ahn149 who_p_149_1 who_n_149_1 vdd gblg gprod
Xlrn_150_1 eop1 eon1 ahp150 ahn150 who_p_150_1 who_n_150_1 vdd gblg gprod
Xlrn_151_1 eop1 eon1 ahp151 ahn151 who_p_151_1 who_n_151_1 vdd gblg gprod
Xlrn_152_1 eop1 eon1 ahp152 ahn152 who_p_152_1 who_n_152_1 vdd gblg gprod
Xlrn_153_1 eop1 eon1 ahp153 ahn153 who_p_153_1 who_n_153_1 vdd gblg gprod
Xlrn_154_1 eop1 eon1 ahp154 ahn154 who_p_154_1 who_n_154_1 vdd gblg gprod
Xlrn_155_1 eop1 eon1 ahp155 ahn155 who_p_155_1 who_n_155_1 vdd gblg gprod
Xlrn_156_1 eop1 eon1 ahp156 ahn156 who_p_156_1 who_n_156_1 vdd gblg gprod
Xlrn_157_1 eop1 eon1 ahp157 ahn157 who_p_157_1 who_n_157_1 vdd gblg gprod
Xlrn_158_1 eop1 eon1 ahp158 ahn158 who_p_158_1 who_n_158_1 vdd gblg gprod
Xlrn_159_1 eop1 eon1 ahp159 ahn159 who_p_159_1 who_n_159_1 vdd gblg gprod
Xlrn_160_1 eop1 eon1 ahbias_p ahbias_n who_p_160_1 who_n_160_1 vdd gblg gprod
.ic v(who_p_0_0)=0.5 v(who_n_0_0)=0.5
.ic v(who_p_1_0)=0.5 v(who_n_1_0)=0.5
.ic v(who_p_2_0)=0.5 v(who_n_2_0)=0.5
.ic v(who_p_3_0)=0.5 v(who_n_3_0)=0.5
.ic v(who_p_4_0)=0.5 v(who_n_4_0)=0.5
.ic v(who_p_5_0)=0.5 v(who_n_5_0)=0.5
.ic v(who_p_6_0)=0.5 v(who_n_6_0)=0.5
.ic v(who_p_7_0)=0.5 v(who_n_7_0)=0.5
.ic v(who_p_8_0)=0.5 v(who_n_8_0)=0.5
.ic v(who_p_9_0)=0.5 v(who_n_9_0)=0.5
.ic v(who_p_10_0)=0.5 v(who_n_10_0)=0.5
.ic v(who_p_11_0)=0.5 v(who_n_11_0)=0.5
.ic v(who_p_12_0)=0.5 v(who_n_12_0)=0.5
.ic v(who_p_13_0)=0.5 v(who_n_13_0)=0.5
.ic v(who_p_14_0)=0.5 v(who_n_14_0)=0.5
.ic v(who_p_15_0)=0.5 v(who_n_15_0)=0.5
.ic v(who_p_16_0)=0.5 v(who_n_16_0)=0.5
.ic v(who_p_17_0)=0.5 v(who_n_17_0)=0.5
.ic v(who_p_18_0)=0.5 v(who_n_18_0)=0.5
.ic v(who_p_19_0)=0.5 v(who_n_19_0)=0.5
.ic v(who_p_20_0)=0.5 v(who_n_20_0)=0.5
.ic v(who_p_21_0)=0.5 v(who_n_21_0)=0.5
.ic v(who_p_22_0)=0.5 v(who_n_22_0)=0.5
.ic v(who_p_23_0)=0.5 v(who_n_23_0)=0.5
.ic v(who_p_24_0)=0.5 v(who_n_24_0)=0.5
.ic v(who_p_25_0)=0.5 v(who_n_25_0)=0.5
.ic v(who_p_26_0)=0.5 v(who_n_26_0)=0.5
.ic v(who_p_27_0)=0.5 v(who_n_27_0)=0.5
.ic v(who_p_28_0)=0.5 v(who_n_28_0)=0.5
.ic v(who_p_29_0)=0.5 v(who_n_29_0)=0.5
.ic v(who_p_30_0)=0.5 v(who_n_30_0)=0.5
.ic v(who_p_31_0)=0.5 v(who_n_31_0)=0.5
.ic v(who_p_32_0)=0.5 v(who_n_32_0)=0.5
.ic v(who_p_33_0)=0.5 v(who_n_33_0)=0.5
.ic v(who_p_34_0)=0.5 v(who_n_34_0)=0.5
.ic v(who_p_35_0)=0.5 v(who_n_35_0)=0.5
.ic v(who_p_36_0)=0.5 v(who_n_36_0)=0.5
.ic v(who_p_37_0)=0.5 v(who_n_37_0)=0.5
.ic v(who_p_38_0)=0.5 v(who_n_38_0)=0.5
.ic v(who_p_39_0)=0.5 v(who_n_39_0)=0.5
.ic v(who_p_40_0)=0.5 v(who_n_40_0)=0.5
.ic v(who_p_41_0)=0.5 v(who_n_41_0)=0.5
.ic v(who_p_42_0)=0.5 v(who_n_42_0)=0.5
.ic v(who_p_43_0)=0.5 v(who_n_43_0)=0.5
.ic v(who_p_44_0)=0.5 v(who_n_44_0)=0.5
.ic v(who_p_45_0)=0.5 v(who_n_45_0)=0.5
.ic v(who_p_46_0)=0.5 v(who_n_46_0)=0.5
.ic v(who_p_47_0)=0.5 v(who_n_47_0)=0.5
.ic v(who_p_48_0)=0.5 v(who_n_48_0)=0.5
.ic v(who_p_49_0)=0.5 v(who_n_49_0)=0.5
.ic v(who_p_50_0)=0.5 v(who_n_50_0)=0.5
.ic v(who_p_51_0)=0.5 v(who_n_51_0)=0.5
.ic v(who_p_52_0)=0.5 v(who_n_52_0)=0.5
.ic v(who_p_53_0)=0.5 v(who_n_53_0)=0.5
.ic v(who_p_54_0)=0.5 v(who_n_54_0)=0.5
.ic v(who_p_55_0)=0.5 v(who_n_55_0)=0.5
.ic v(who_p_56_0)=0.5 v(who_n_56_0)=0.5
.ic v(who_p_57_0)=0.5 v(who_n_57_0)=0.5
.ic v(who_p_58_0)=0.5 v(who_n_58_0)=0.5
.ic v(who_p_59_0)=0.5 v(who_n_59_0)=0.5
.ic v(who_p_60_0)=0.5 v(who_n_60_0)=0.5
.ic v(who_p_61_0)=0.5 v(who_n_61_0)=0.5
.ic v(who_p_62_0)=0.5 v(who_n_62_0)=0.5
.ic v(who_p_63_0)=0.5 v(who_n_63_0)=0.5
.ic v(who_p_64_0)=0.5 v(who_n_64_0)=0.5
.ic v(who_p_65_0)=0.5 v(who_n_65_0)=0.5
.ic v(who_p_66_0)=0.5 v(who_n_66_0)=0.5
.ic v(who_p_67_0)=0.5 v(who_n_67_0)=0.5
.ic v(who_p_68_0)=0.5 v(who_n_68_0)=0.5
.ic v(who_p_69_0)=0.5 v(who_n_69_0)=0.5
.ic v(who_p_70_0)=0.5 v(who_n_70_0)=0.5
.ic v(who_p_71_0)=0.5 v(who_n_71_0)=0.5
.ic v(who_p_72_0)=0.5 v(who_n_72_0)=0.5
.ic v(who_p_73_0)=0.5 v(who_n_73_0)=0.5
.ic v(who_p_74_0)=0.5 v(who_n_74_0)=0.5
.ic v(who_p_75_0)=0.5 v(who_n_75_0)=0.5
.ic v(who_p_76_0)=0.5 v(who_n_76_0)=0.5
.ic v(who_p_77_0)=0.5 v(who_n_77_0)=0.5
.ic v(who_p_78_0)=0.5 v(who_n_78_0)=0.5
.ic v(who_p_79_0)=0.5 v(who_n_79_0)=0.5
.ic v(who_p_80_0)=0.5 v(who_n_80_0)=0.5
.ic v(who_p_81_0)=0.5 v(who_n_81_0)=0.5
.ic v(who_p_82_0)=0.5 v(who_n_82_0)=0.5
.ic v(who_p_83_0)=0.5 v(who_n_83_0)=0.5
.ic v(who_p_84_0)=0.5 v(who_n_84_0)=0.5
.ic v(who_p_85_0)=0.5 v(who_n_85_0)=0.5
.ic v(who_p_86_0)=0.5 v(who_n_86_0)=0.5
.ic v(who_p_87_0)=0.5 v(who_n_87_0)=0.5
.ic v(who_p_88_0)=0.5 v(who_n_88_0)=0.5
.ic v(who_p_89_0)=0.5 v(who_n_89_0)=0.5
.ic v(who_p_90_0)=0.5 v(who_n_90_0)=0.5
.ic v(who_p_91_0)=0.5 v(who_n_91_0)=0.5
.ic v(who_p_92_0)=0.5 v(who_n_92_0)=0.5
.ic v(who_p_93_0)=0.5 v(who_n_93_0)=0.5
.ic v(who_p_94_0)=0.5 v(who_n_94_0)=0.5
.ic v(who_p_95_0)=0.5 v(who_n_95_0)=0.5
.ic v(who_p_96_0)=0.5 v(who_n_96_0)=0.5
.ic v(who_p_97_0)=0.5 v(who_n_97_0)=0.5
.ic v(who_p_98_0)=0.5 v(who_n_98_0)=0.5
.ic v(who_p_99_0)=0.5 v(who_n_99_0)=0.5
.ic v(who_p_100_0)=0.5 v(who_n_100_0)=0.5
.ic v(who_p_101_0)=0.5 v(who_n_101_0)=0.5
.ic v(who_p_102_0)=0.5 v(who_n_102_0)=0.5
.ic v(who_p_103_0)=0.5 v(who_n_103_0)=0.5
.ic v(who_p_104_0)=0.5 v(who_n_104_0)=0.5
.ic v(who_p_105_0)=0.5 v(who_n_105_0)=0.5
.ic v(who_p_106_0)=0.5 v(who_n_106_0)=0.5
.ic v(who_p_107_0)=0.5 v(who_n_107_0)=0.5
.ic v(who_p_108_0)=0.5 v(who_n_108_0)=0.5
.ic v(who_p_109_0)=0.5 v(who_n_109_0)=0.5
.ic v(who_p_110_0)=0.5 v(who_n_110_0)=0.5
.ic v(who_p_111_0)=0.5 v(who_n_111_0)=0.5
.ic v(who_p_112_0)=0.5 v(who_n_112_0)=0.5
.ic v(who_p_113_0)=0.5 v(who_n_113_0)=0.5
.ic v(who_p_114_0)=0.5 v(who_n_114_0)=0.5
.ic v(who_p_115_0)=0.5 v(who_n_115_0)=0.5
.ic v(who_p_116_0)=0.5 v(who_n_116_0)=0.5
.ic v(who_p_117_0)=0.5 v(who_n_117_0)=0.5
.ic v(who_p_118_0)=0.5 v(who_n_118_0)=0.5
.ic v(who_p_119_0)=0.5 v(who_n_119_0)=0.5
.ic v(who_p_120_0)=0.5 v(who_n_120_0)=0.5
.ic v(who_p_121_0)=0.5 v(who_n_121_0)=0.5
.ic v(who_p_122_0)=0.5 v(who_n_122_0)=0.5
.ic v(who_p_123_0)=0.5 v(who_n_123_0)=0.5
.ic v(who_p_124_0)=0.5 v(who_n_124_0)=0.5
.ic v(who_p_125_0)=0.5 v(who_n_125_0)=0.5
.ic v(who_p_126_0)=0.5 v(who_n_126_0)=0.5
.ic v(who_p_127_0)=0.5 v(who_n_127_0)=0.5
.ic v(who_p_128_0)=0.5 v(who_n_128_0)=0.5
.ic v(who_p_129_0)=0.5 v(who_n_129_0)=0.5
.ic v(who_p_130_0)=0.5 v(who_n_130_0)=0.5
.ic v(who_p_131_0)=0.5 v(who_n_131_0)=0.5
.ic v(who_p_132_0)=0.5 v(who_n_132_0)=0.5
.ic v(who_p_133_0)=0.5 v(who_n_133_0)=0.5
.ic v(who_p_134_0)=0.5 v(who_n_134_0)=0.5
.ic v(who_p_135_0)=0.5 v(who_n_135_0)=0.5
.ic v(who_p_136_0)=0.5 v(who_n_136_0)=0.5
.ic v(who_p_137_0)=0.5 v(who_n_137_0)=0.5
.ic v(who_p_138_0)=0.5 v(who_n_138_0)=0.5
.ic v(who_p_139_0)=0.5 v(who_n_139_0)=0.5
.ic v(who_p_140_0)=0.5 v(who_n_140_0)=0.5
.ic v(who_p_141_0)=0.5 v(who_n_141_0)=0.5
.ic v(who_p_142_0)=0.5 v(who_n_142_0)=0.5
.ic v(who_p_143_0)=0.5 v(who_n_143_0)=0.5
.ic v(who_p_144_0)=0.5 v(who_n_144_0)=0.5
.ic v(who_p_145_0)=0.5 v(who_n_145_0)=0.5
.ic v(who_p_146_0)=0.5 v(who_n_146_0)=0.5
.ic v(who_p_147_0)=0.5 v(who_n_147_0)=0.5
.ic v(who_p_148_0)=0.5 v(who_n_148_0)=0.5
.ic v(who_p_149_0)=0.5 v(who_n_149_0)=0.5
.ic v(who_p_150_0)=0.5 v(who_n_150_0)=0.5
.ic v(who_p_151_0)=0.5 v(who_n_151_0)=0.5
.ic v(who_p_152_0)=0.5 v(who_n_152_0)=0.5
.ic v(who_p_153_0)=0.5 v(who_n_153_0)=0.5
.ic v(who_p_154_0)=0.5 v(who_n_154_0)=0.5
.ic v(who_p_155_0)=0.5 v(who_n_155_0)=0.5
.ic v(who_p_156_0)=0.5 v(who_n_156_0)=0.5
.ic v(who_p_157_0)=0.5 v(who_n_157_0)=0.5
.ic v(who_p_158_0)=0.5 v(who_n_158_0)=0.5
.ic v(who_p_159_0)=0.5 v(who_n_159_0)=0.5
.ic v(who_p_160_0)=0.5 v(who_n_160_0)=0.5
.ic v(who_p_0_1)=0.5 v(who_n_0_1)=0.5
.ic v(who_p_1_1)=0.5 v(who_n_1_1)=0.5
.ic v(who_p_2_1)=0.5 v(who_n_2_1)=0.5
.ic v(who_p_3_1)=0.5 v(who_n_3_1)=0.5
.ic v(who_p_4_1)=0.5 v(who_n_4_1)=0.5
.ic v(who_p_5_1)=0.5 v(who_n_5_1)=0.5
.ic v(who_p_6_1)=0.5 v(who_n_6_1)=0.5
.ic v(who_p_7_1)=0.5 v(who_n_7_1)=0.5
.ic v(who_p_8_1)=0.5 v(who_n_8_1)=0.5
.ic v(who_p_9_1)=0.5 v(who_n_9_1)=0.5
.ic v(who_p_10_1)=0.5 v(who_n_10_1)=0.5
.ic v(who_p_11_1)=0.5 v(who_n_11_1)=0.5
.ic v(who_p_12_1)=0.5 v(who_n_12_1)=0.5
.ic v(who_p_13_1)=0.5 v(who_n_13_1)=0.5
.ic v(who_p_14_1)=0.5 v(who_n_14_1)=0.5
.ic v(who_p_15_1)=0.5 v(who_n_15_1)=0.5
.ic v(who_p_16_1)=0.5 v(who_n_16_1)=0.5
.ic v(who_p_17_1)=0.5 v(who_n_17_1)=0.5
.ic v(who_p_18_1)=0.5 v(who_n_18_1)=0.5
.ic v(who_p_19_1)=0.5 v(who_n_19_1)=0.5
.ic v(who_p_20_1)=0.5 v(who_n_20_1)=0.5
.ic v(who_p_21_1)=0.5 v(who_n_21_1)=0.5
.ic v(who_p_22_1)=0.5 v(who_n_22_1)=0.5
.ic v(who_p_23_1)=0.5 v(who_n_23_1)=0.5
.ic v(who_p_24_1)=0.5 v(who_n_24_1)=0.5
.ic v(who_p_25_1)=0.5 v(who_n_25_1)=0.5
.ic v(who_p_26_1)=0.5 v(who_n_26_1)=0.5
.ic v(who_p_27_1)=0.5 v(who_n_27_1)=0.5
.ic v(who_p_28_1)=0.5 v(who_n_28_1)=0.5
.ic v(who_p_29_1)=0.5 v(who_n_29_1)=0.5
.ic v(who_p_30_1)=0.5 v(who_n_30_1)=0.5
.ic v(who_p_31_1)=0.5 v(who_n_31_1)=0.5
.ic v(who_p_32_1)=0.5 v(who_n_32_1)=0.5
.ic v(who_p_33_1)=0.5 v(who_n_33_1)=0.5
.ic v(who_p_34_1)=0.5 v(who_n_34_1)=0.5
.ic v(who_p_35_1)=0.5 v(who_n_35_1)=0.5
.ic v(who_p_36_1)=0.5 v(who_n_36_1)=0.5
.ic v(who_p_37_1)=0.5 v(who_n_37_1)=0.5
.ic v(who_p_38_1)=0.5 v(who_n_38_1)=0.5
.ic v(who_p_39_1)=0.5 v(who_n_39_1)=0.5
.ic v(who_p_40_1)=0.5 v(who_n_40_1)=0.5
.ic v(who_p_41_1)=0.5 v(who_n_41_1)=0.5
.ic v(who_p_42_1)=0.5 v(who_n_42_1)=0.5
.ic v(who_p_43_1)=0.5 v(who_n_43_1)=0.5
.ic v(who_p_44_1)=0.5 v(who_n_44_1)=0.5
.ic v(who_p_45_1)=0.5 v(who_n_45_1)=0.5
.ic v(who_p_46_1)=0.5 v(who_n_46_1)=0.5
.ic v(who_p_47_1)=0.5 v(who_n_47_1)=0.5
.ic v(who_p_48_1)=0.5 v(who_n_48_1)=0.5
.ic v(who_p_49_1)=0.5 v(who_n_49_1)=0.5
.ic v(who_p_50_1)=0.5 v(who_n_50_1)=0.5
.ic v(who_p_51_1)=0.5 v(who_n_51_1)=0.5
.ic v(who_p_52_1)=0.5 v(who_n_52_1)=0.5
.ic v(who_p_53_1)=0.5 v(who_n_53_1)=0.5
.ic v(who_p_54_1)=0.5 v(who_n_54_1)=0.5
.ic v(who_p_55_1)=0.5 v(who_n_55_1)=0.5
.ic v(who_p_56_1)=0.5 v(who_n_56_1)=0.5
.ic v(who_p_57_1)=0.5 v(who_n_57_1)=0.5
.ic v(who_p_58_1)=0.5 v(who_n_58_1)=0.5
.ic v(who_p_59_1)=0.5 v(who_n_59_1)=0.5
.ic v(who_p_60_1)=0.5 v(who_n_60_1)=0.5
.ic v(who_p_61_1)=0.5 v(who_n_61_1)=0.5
.ic v(who_p_62_1)=0.5 v(who_n_62_1)=0.5
.ic v(who_p_63_1)=0.5 v(who_n_63_1)=0.5
.ic v(who_p_64_1)=0.5 v(who_n_64_1)=0.5
.ic v(who_p_65_1)=0.5 v(who_n_65_1)=0.5
.ic v(who_p_66_1)=0.5 v(who_n_66_1)=0.5
.ic v(who_p_67_1)=0.5 v(who_n_67_1)=0.5
.ic v(who_p_68_1)=0.5 v(who_n_68_1)=0.5
.ic v(who_p_69_1)=0.5 v(who_n_69_1)=0.5
.ic v(who_p_70_1)=0.5 v(who_n_70_1)=0.5
.ic v(who_p_71_1)=0.5 v(who_n_71_1)=0.5
.ic v(who_p_72_1)=0.5 v(who_n_72_1)=0.5
.ic v(who_p_73_1)=0.5 v(who_n_73_1)=0.5
.ic v(who_p_74_1)=0.5 v(who_n_74_1)=0.5
.ic v(who_p_75_1)=0.5 v(who_n_75_1)=0.5
.ic v(who_p_76_1)=0.5 v(who_n_76_1)=0.5
.ic v(who_p_77_1)=0.5 v(who_n_77_1)=0.5
.ic v(who_p_78_1)=0.5 v(who_n_78_1)=0.5
.ic v(who_p_79_1)=0.5 v(who_n_79_1)=0.5
.ic v(who_p_80_1)=0.5 v(who_n_80_1)=0.5
.ic v(who_p_81_1)=0.5 v(who_n_81_1)=0.5
.ic v(who_p_82_1)=0.5 v(who_n_82_1)=0.5
.ic v(who_p_83_1)=0.5 v(who_n_83_1)=0.5
.ic v(who_p_84_1)=0.5 v(who_n_84_1)=0.5
.ic v(who_p_85_1)=0.5 v(who_n_85_1)=0.5
.ic v(who_p_86_1)=0.5 v(who_n_86_1)=0.5
.ic v(who_p_87_1)=0.5 v(who_n_87_1)=0.5
.ic v(who_p_88_1)=0.5 v(who_n_88_1)=0.5
.ic v(who_p_89_1)=0.5 v(who_n_89_1)=0.5
.ic v(who_p_90_1)=0.5 v(who_n_90_1)=0.5
.ic v(who_p_91_1)=0.5 v(who_n_91_1)=0.5
.ic v(who_p_92_1)=0.5 v(who_n_92_1)=0.5
.ic v(who_p_93_1)=0.5 v(who_n_93_1)=0.5
.ic v(who_p_94_1)=0.5 v(who_n_94_1)=0.5
.ic v(who_p_95_1)=0.5 v(who_n_95_1)=0.5
.ic v(who_p_96_1)=0.5 v(who_n_96_1)=0.5
.ic v(who_p_97_1)=0.5 v(who_n_97_1)=0.5
.ic v(who_p_98_1)=0.5 v(who_n_98_1)=0.5
.ic v(who_p_99_1)=0.5 v(who_n_99_1)=0.5
.ic v(who_p_100_1)=0.5 v(who_n_100_1)=0.5
.ic v(who_p_101_1)=0.5 v(who_n_101_1)=0.5
.ic v(who_p_102_1)=0.5 v(who_n_102_1)=0.5
.ic v(who_p_103_1)=0.5 v(who_n_103_1)=0.5
.ic v(who_p_104_1)=0.5 v(who_n_104_1)=0.5
.ic v(who_p_105_1)=0.5 v(who_n_105_1)=0.5
.ic v(who_p_106_1)=0.5 v(who_n_106_1)=0.5
.ic v(who_p_107_1)=0.5 v(who_n_107_1)=0.5
.ic v(who_p_108_1)=0.5 v(who_n_108_1)=0.5
.ic v(who_p_109_1)=0.5 v(who_n_109_1)=0.5
.ic v(who_p_110_1)=0.5 v(who_n_110_1)=0.5
.ic v(who_p_111_1)=0.5 v(who_n_111_1)=0.5
.ic v(who_p_112_1)=0.5 v(who_n_112_1)=0.5
.ic v(who_p_113_1)=0.5 v(who_n_113_1)=0.5
.ic v(who_p_114_1)=0.5 v(who_n_114_1)=0.5
.ic v(who_p_115_1)=0.5 v(who_n_115_1)=0.5
.ic v(who_p_116_1)=0.5 v(who_n_116_1)=0.5
.ic v(who_p_117_1)=0.5 v(who_n_117_1)=0.5
.ic v(who_p_118_1)=0.5 v(who_n_118_1)=0.5
.ic v(who_p_119_1)=0.5 v(who_n_119_1)=0.5
.ic v(who_p_120_1)=0.5 v(who_n_120_1)=0.5
.ic v(who_p_121_1)=0.5 v(who_n_121_1)=0.5
.ic v(who_p_122_1)=0.5 v(who_n_122_1)=0.5
.ic v(who_p_123_1)=0.5 v(who_n_123_1)=0.5
.ic v(who_p_124_1)=0.5 v(who_n_124_1)=0.5
.ic v(who_p_125_1)=0.5 v(who_n_125_1)=0.5
.ic v(who_p_126_1)=0.5 v(who_n_126_1)=0.5
.ic v(who_p_127_1)=0.5 v(who_n_127_1)=0.5
.ic v(who_p_128_1)=0.5 v(who_n_128_1)=0.5
.ic v(who_p_129_1)=0.5 v(who_n_129_1)=0.5
.ic v(who_p_130_1)=0.5 v(who_n_130_1)=0.5
.ic v(who_p_131_1)=0.5 v(who_n_131_1)=0.5
.ic v(who_p_132_1)=0.5 v(who_n_132_1)=0.5
.ic v(who_p_133_1)=0.5 v(who_n_133_1)=0.5
.ic v(who_p_134_1)=0.5 v(who_n_134_1)=0.5
.ic v(who_p_135_1)=0.5 v(who_n_135_1)=0.5
.ic v(who_p_136_1)=0.5 v(who_n_136_1)=0.5
.ic v(who_p_137_1)=0.5 v(who_n_137_1)=0.5
.ic v(who_p_138_1)=0.5 v(who_n_138_1)=0.5
.ic v(who_p_139_1)=0.5 v(who_n_139_1)=0.5
.ic v(who_p_140_1)=0.5 v(who_n_140_1)=0.5
.ic v(who_p_141_1)=0.5 v(who_n_141_1)=0.5
.ic v(who_p_142_1)=0.5 v(who_n_142_1)=0.5
.ic v(who_p_143_1)=0.5 v(who_n_143_1)=0.5
.ic v(who_p_144_1)=0.5 v(who_n_144_1)=0.5
.ic v(who_p_145_1)=0.5 v(who_n_145_1)=0.5
.ic v(who_p_146_1)=0.5 v(who_n_146_1)=0.5
.ic v(who_p_147_1)=0.5 v(who_n_147_1)=0.5
.ic v(who_p_148_1)=0.5 v(who_n_148_1)=0.5
.ic v(who_p_149_1)=0.5 v(who_n_149_1)=0.5
.ic v(who_p_150_1)=0.5 v(who_n_150_1)=0.5
.ic v(who_p_151_1)=0.5 v(who_n_151_1)=0.5
.ic v(who_p_152_1)=0.5 v(who_n_152_1)=0.5
.ic v(who_p_153_1)=0.5 v(who_n_153_1)=0.5
.ic v(who_p_154_1)=0.5 v(who_n_154_1)=0.5
.ic v(who_p_155_1)=0.5 v(who_n_155_1)=0.5
.ic v(who_p_156_1)=0.5 v(who_n_156_1)=0.5
.ic v(who_p_157_1)=0.5 v(who_n_157_1)=0.5
.ic v(who_p_158_1)=0.5 v(who_n_158_1)=0.5
.ic v(who_p_159_1)=0.5 v(who_n_159_1)=0.5
.ic v(who_p_160_1)=0.5 v(who_n_160_1)=0.5
.options gmin=1e-10 reltol=2e-3 cshunt=1e-14 method=gear
.control
save mop0 mon0 mop1 mon1
tran 2n 168480n uic
wrdata ps_h160.dat v(mop0) v(mon0) v(mop1) v(mon1)
.endc
.end
