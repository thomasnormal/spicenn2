pc orchestrated
.model NNR NMOS (LEVEL=1 VTO=0.2 KP=120u LAMBDA=0.02 GAMMA=0 PHI=0.7)
.model PNR PMOS (LEVEL=1 VTO=-0.2 KP=40u LAMBDA=0.02 GAMMA=0 PHI=0.7)
.subckt gsyn inp inn wp wn outp outn vdd vbn
Mtail nt vbn 0 0 NNR W=400u L=100u
M5 na wp nt 0 NNR W=200u L=100u
M6 nb wn nt 0 NNR W=200u L=100u
M1 outp inp na 0 NNR W=200u L=100u
M2 outn inn na 0 NNR W=200u L=100u
M3 outn inp nb 0 NNR W=200u L=100u
M4 outp inn nb 0 NNR W=200u L=100u
.ends
.subckt cmld p n vdd
Rcs1 p cmx 300k
Rcs2 n cmx 300k
MLp p cmx vdd vdd PNR W=1000u L=100u
MLn n cmx vdd vdd PNR W=1000u L=100u
.ends
.subckt dneuron up un ap an vdd vbn
M1 an up tn 0 NNR W=200u L=100u
M2 ap un tn 0 NNR W=200u L=100u
Mt tn vbn 0 0 NNR W=200u L=100u
Xcm ap an vdd cmld
.ends
.subckt esub xp xn mp mn ep en vdd vbn
Mt nt vbn 0 0 NNR W=400u L=100u
M1x ep xn nt 0 NNR W=200u L=100u
M2x en xp nt 0 NNR W=200u L=100u
M1m ep mp nt 0 NNR W=200u L=100u
M2m en mn nt 0 NNR W=200u L=100u
RLp vdd ep 50k
RLn vdd en 50k
.ends
Vdd vdd 0 1.0
Vbsyn vbsyn 0 0.45
Vbneu vbneu 0 0.35
Vgm gm 0 0.6
Vwcm wcm 0 0.5
Vxp0 a_xp0 0 0.5
Vxn0 a_xn0 0 0.5
Vxp1 a_xp1 0 0.5
Vxn1 a_xn1 0 0.5
Vxp2 a_xp2 0 0.5
Vxn2 a_xn2 0 0.5
Vxp3 a_xp3 0 0.5
Vxn3 a_xn3 0 0.5
Vxp4 a_xp4 0 0.5
Vxn4 a_xn4 0 0.5
Vxp5 a_xp5 0 0.5
Vxn5 a_xn5 0 0.5
Vxp6 a_xp6 0 0.5
Vxn6 a_xn6 0 0.5
Vxp7 a_xp7 0 0.5
Vxn7 a_xn7 0 0.5
Vxp8 a_xp8 0 0.5
Vxn8 a_xn8 0 0.5
Vxp9 a_xp9 0 0.5
Vxn9 a_xn9 0 0.5
Vxp10 a_xp10 0 0.5
Vxn10 a_xn10 0 0.5
Vxp11 a_xp11 0 0.5
Vxn11 a_xn11 0 0.5
Vxp12 a_xp12 0 0.5
Vxn12 a_xn12 0 0.5
Vxp13 a_xp13 0 0.5
Vxn13 a_xn13 0 0.5
Vxp14 a_xp14 0 0.5
Vxn14 a_xn14 0 0.5
Vxp15 a_xp15 0 0.5
Vxn15 a_xn15 0 0.5
Vwp_ih_0_0 wp_ih_0_0 0 0.324993378233611
Vwn_ih_0_0 wn_ih_0_0 0 0.675006621766389
Vwp_ih_1_0 wp_ih_1_0 0 0.3
Vwn_ih_1_0 wn_ih_1_0 0 0.713996195483743
Vwp_ih_2_0 wp_ih_2_0 0 0.3012161970999946
Vwn_ih_2_0 wn_ih_2_0 0 0.6987838029000054
Vwp_ih_3_0 wp_ih_3_0 0 0.433502278524717
Vwn_ih_3_0 wn_ih_3_0 0 0.566497721475283
Vwp_ih_4_0 wp_ih_4_0 0 0.6248810776517375
Vwn_ih_4_0 wn_ih_4_0 0 0.37511892234826255
Vwp_ih_5_0 wp_ih_5_0 0 0.5230512228324093
Vwn_ih_5_0 wn_ih_5_0 0 0.47694877716759065
Vwp_ih_6_0 wp_ih_6_0 0 0.4265257812845778
Vwn_ih_6_0 wn_ih_6_0 0 0.5734742187154223
Vwp_ih_7_0 wp_ih_7_0 0 0.37097267053170224
Vwn_ih_7_0 wn_ih_7_0 0 0.6290273294682978
Vwp_ih_8_0 wp_ih_8_0 0 0.436286791676877
Vwn_ih_8_0 wn_ih_8_0 0 0.563713208323123
Vwp_ih_9_0 wp_ih_9_0 0 0.45378196820891803
Vwn_ih_9_0 wn_ih_9_0 0 0.546218031791082
Vwp_ih_10_0 wp_ih_10_0 0 0.43058830577439533
Vwn_ih_10_0 wn_ih_10_0 0 0.5694116942256047
Vwp_ih_11_0 wp_ih_11_0 0 0.3243664646289862
Vwn_ih_11_0 wn_ih_11_0 0 0.6756335353710138
Vwp_ih_12_0 wp_ih_12_0 0 0.44158984571911336
Vwn_ih_12_0 wn_ih_12_0 0 0.5584101542808867
Vwp_ih_13_0 wp_ih_13_0 0 0.6217998451955034
Vwn_ih_13_0 wn_ih_13_0 0 0.37820015480449665
Vwp_ih_14_0 wp_ih_14_0 0 0.3
Vwn_ih_14_0 wn_ih_14_0 0 0.7638489457649608
Vwp_ih_15_0 wp_ih_15_0 0 0.4714507715258424
Vwn_ih_15_0 wn_ih_15_0 0 0.5285492284741575
Vwp_ho_0_0 wp_ho_0_0 0 0.36024615427887097
Vwn_ho_0_0 wn_ho_0_0 0 0.639753845721129
Vwp_ho_0_1 wp_ho_0_1 0 0.6131075827738846
Vwn_ho_0_1 wn_ho_0_1 0 0.38689241722611545
Vwp_ho_0_2 wp_ho_0_2 0 0.36828193411088594
Vwn_ho_0_2 wn_ho_0_2 0 0.631718065889114
Vwp_ho_0_3 wp_ho_0_3 0 0.4252071060155111
Vwn_ho_0_3 wn_ho_0_3 0 0.5747928939844889
Vwp_ho_0_4 wp_ho_0_4 0 0.5631997424089275
Vwn_ho_0_4 wn_ho_0_4 0 0.43680025759107255
Vwp_ih_0_1 wp_ih_0_1 0 0.3
Vwn_ih_0_1 wn_ih_0_1 0 0.7589683911664704
Vwp_ih_1_1 wp_ih_1_1 0 0.5197426242360544
Vwn_ih_1_1 wn_ih_1_1 0 0.48025737576394556
Vwp_ih_2_1 wp_ih_2_1 0 0.40859776868561004
Vwn_ih_2_1 wn_ih_2_1 0 0.59140223131439
Vwp_ih_3_1 wp_ih_3_1 0 0.3
Vwn_ih_3_1 wn_ih_3_1 0 0.7509872564607845
Vwp_ih_4_1 wp_ih_4_1 0 0.5123545120891803
Vwn_ih_4_1 wn_ih_4_1 0 0.48764548791081974
Vwp_ih_5_1 wp_ih_5_1 0 0.7218002648005383
Vwn_ih_5_1 wn_ih_5_1 0 0.3
Vwp_ih_6_1 wp_ih_6_1 0 0.5117200955318282
Vwn_ih_6_1 wn_ih_6_1 0 0.4882799044681718
Vwp_ih_7_1 wp_ih_7_1 0 0.6421381179246297
Vwn_ih_7_1 wn_ih_7_1 0 0.35786188207537023
Vwp_ih_8_1 wp_ih_8_1 0 0.49380085336827234
Vwn_ih_8_1 wn_ih_8_1 0 0.5061991466317277
Vwp_ih_9_1 wp_ih_9_1 0 0.3
Vwn_ih_9_1 wn_ih_9_1 0 0.75837960321973
Vwp_ih_10_1 wp_ih_10_1 0 0.5607161700893066
Vwn_ih_10_1 wn_ih_10_1 0 0.43928382991069337
Vwp_ih_11_1 wp_ih_11_1 0 0.4498242110777526
Vwn_ih_11_1 wn_ih_11_1 0 0.5501757889222474
Vwp_ih_12_1 wp_ih_12_1 0 0.32224890952469565
Vwn_ih_12_1 wn_ih_12_1 0 0.6777510904753044
Vwp_ih_13_1 wp_ih_13_1 0 0.5917051287124091
Vwn_ih_13_1 wn_ih_13_1 0 0.40829487128759084
Vwp_ih_14_1 wp_ih_14_1 0 0.5347536841114809
Vwn_ih_14_1 wn_ih_14_1 0 0.465246315888519
Vwp_ih_15_1 wp_ih_15_1 0 0.43599291764156733
Vwn_ih_15_1 wn_ih_15_1 0 0.5640070823584327
Vwp_ho_1_0 wp_ho_1_0 0 0.5014298583882172
Vwn_ho_1_0 wn_ho_1_0 0 0.4985701416117828
Vwp_ho_1_1 wp_ho_1_1 0 0.47070960180001437
Vwn_ho_1_1 wn_ho_1_1 0 0.5292903981999856
Vwp_ho_1_2 wp_ho_1_2 0 0.7047825256398933
Vwn_ho_1_2 wn_ho_1_2 0 0.3
Vwp_ho_1_3 wp_ho_1_3 0 0.5088450654957959
Vwn_ho_1_3 wn_ho_1_3 0 0.4911549345042041
Vwp_ho_1_4 wp_ho_1_4 0 0.5699044321101852
Vwn_ho_1_4 wn_ho_1_4 0 0.43009556788981484
Vwp_ih_0_2 wp_ih_0_2 0 0.6046684302585755
Vwn_ih_0_2 wn_ih_0_2 0 0.3953315697414245
Vwp_ih_1_2 wp_ih_1_2 0 0.39116979077076786
Vwn_ih_1_2 wn_ih_1_2 0 0.6088302092292321
Vwp_ih_2_2 wp_ih_2_2 0 0.580701999294242
Vwn_ih_2_2 wn_ih_2_2 0 0.419298000705758
Vwp_ih_3_2 wp_ih_3_2 0 0.3865657702007549
Vwn_ih_3_2 wn_ih_3_2 0 0.6134342297992451
Vwp_ih_4_2 wp_ih_4_2 0 0.5659166540864596
Vwn_ih_4_2 wn_ih_4_2 0 0.43408334591354036
Vwp_ih_5_2 wp_ih_5_2 0 0.3653243175926835
Vwn_ih_5_2 wn_ih_5_2 0 0.6346756824073165
Vwp_ih_6_2 wp_ih_6_2 0 0.6811150715292341
Vwn_ih_6_2 wn_ih_6_2 0 0.3188849284707659
Vwp_ih_7_2 wp_ih_7_2 0 0.5309198059989941
Vwn_ih_7_2 wn_ih_7_2 0 0.4690801940010059
Vwp_ih_8_2 wp_ih_8_2 0 0.67361115187792
Vwn_ih_8_2 wn_ih_8_2 0 0.32638884812208
Vwp_ih_9_2 wp_ih_9_2 0 0.3982184677816501
Vwn_ih_9_2 wn_ih_9_2 0 0.6017815322183498
Vwp_ih_10_2 wp_ih_10_2 0 0.4445777542971602
Vwn_ih_10_2 wn_ih_10_2 0 0.5554222457028398
Vwp_ih_11_2 wp_ih_11_2 0 0.6038836607324144
Vwn_ih_11_2 wn_ih_11_2 0 0.3961163392675856
Vwp_ih_12_2 wp_ih_12_2 0 0.3
Vwn_ih_12_2 wn_ih_12_2 0 0.8314363152979642
Vwp_ih_13_2 wp_ih_13_2 0 0.3672685224454422
Vwn_ih_13_2 wn_ih_13_2 0 0.6327314775545578
Vwp_ih_14_2 wp_ih_14_2 0 0.6262887506145494
Vwn_ih_14_2 wn_ih_14_2 0 0.37371124938545064
Vwp_ih_15_2 wp_ih_15_2 0 0.5555178676565344
Vwn_ih_15_2 wn_ih_15_2 0 0.4444821323434655
Vwp_ho_2_0 wp_ho_2_0 0 0.40064891818954484
Vwn_ho_2_0 wn_ho_2_0 0 0.5993510818104552
Vwp_ho_2_1 wp_ho_2_1 0 0.40396261715618553
Vwn_ho_2_1 wn_ho_2_1 0 0.5960373828438145
Vwp_ho_2_2 wp_ho_2_2 0 0.35710069453002546
Vwn_ho_2_2 wn_ho_2_2 0 0.6428993054699745
Vwp_ho_2_3 wp_ho_2_3 0 0.6065537148464004
Vwn_ho_2_3 wn_ho_2_3 0 0.3934462851535996
Vwp_ho_2_4 wp_ho_2_4 0 0.3590580508122989
Vwn_ho_2_4 wn_ho_2_4 0 0.6409419491877011
Vwp_ih_0_3 wp_ih_0_3 0 0.6211126218709228
Vwn_ih_0_3 wn_ih_0_3 0 0.37888737812907725
Vwp_ih_1_3 wp_ih_1_3 0 0.4659977267661133
Vwn_ih_1_3 wn_ih_1_3 0 0.5340022732338867
Vwp_ih_2_3 wp_ih_2_3 0 0.5705000549172418
Vwn_ih_2_3 wn_ih_2_3 0 0.42949994508275824
Vwp_ih_3_3 wp_ih_3_3 0 0.41228923597071393
Vwn_ih_3_3 wn_ih_3_3 0 0.5877107640292861
Vwp_ih_4_3 wp_ih_4_3 0 0.333009062561883
Vwn_ih_4_3 wn_ih_4_3 0 0.666990937438117
Vwp_ih_5_3 wp_ih_5_3 0 0.3
Vwn_ih_5_3 wn_ih_5_3 0 0.7099987256968049
Vwp_ih_6_3 wp_ih_6_3 0 0.43512708750902745
Vwn_ih_6_3 wn_ih_6_3 0 0.5648729124909725
Vwp_ih_7_3 wp_ih_7_3 0 0.4307435471936193
Vwn_ih_7_3 wn_ih_7_3 0 0.5692564528063807
Vwp_ih_8_3 wp_ih_8_3 0 0.4194032781317286
Vwn_ih_8_3 wn_ih_8_3 0 0.5805967218682714
Vwp_ih_9_3 wp_ih_9_3 0 0.3
Vwn_ih_9_3 wn_ih_9_3 0 0.9
Vwp_ih_10_3 wp_ih_10_3 0 0.3
Vwn_ih_10_3 wn_ih_10_3 0 0.7438570961364648
Vwp_ih_11_3 wp_ih_11_3 0 0.43486170243546185
Vwn_ih_11_3 wn_ih_11_3 0 0.5651382975645382
Vwp_ih_12_3 wp_ih_12_3 0 0.5356310126662776
Vwn_ih_12_3 wn_ih_12_3 0 0.46436898733372245
Vwp_ih_13_3 wp_ih_13_3 0 0.43419672967910783
Vwn_ih_13_3 wn_ih_13_3 0 0.5658032703208922
Vwp_ih_14_3 wp_ih_14_3 0 0.3946124817938272
Vwn_ih_14_3 wn_ih_14_3 0 0.6053875182061728
Vwp_ih_15_3 wp_ih_15_3 0 0.3
Vwn_ih_15_3 wn_ih_15_3 0 0.7767247203362162
Vwp_ho_3_0 wp_ho_3_0 0 0.46991664013701306
Vwn_ho_3_0 wn_ho_3_0 0 0.5300833598629869
Vwp_ho_3_1 wp_ho_3_1 0 0.3803626088079974
Vwn_ho_3_1 wn_ho_3_1 0 0.6196373911920027
Vwp_ho_3_2 wp_ho_3_2 0 0.46496172395368507
Vwn_ho_3_2 wn_ho_3_2 0 0.5350382760463149
Vwp_ho_3_3 wp_ho_3_3 0 0.5768613359315357
Vwn_ho_3_3 wn_ho_3_3 0 0.4231386640684643
Vwp_ho_3_4 wp_ho_3_4 0 0.6137071638707621
Vwn_ho_3_4 wn_ho_3_4 0 0.3862928361292379
Vwp_ih_0_4 wp_ih_0_4 0 0.7449884925132018
Vwn_ih_0_4 wn_ih_0_4 0 0.3
Vwp_ih_1_4 wp_ih_1_4 0 0.36528498969036793
Vwn_ih_1_4 wn_ih_1_4 0 0.6347150103096321
Vwp_ih_2_4 wp_ih_2_4 0 0.7078422594216178
Vwn_ih_2_4 wn_ih_2_4 0 0.3
Vwp_ih_3_4 wp_ih_3_4 0 0.6885659734211196
Vwn_ih_3_4 wn_ih_3_4 0 0.3114340265788805
Vwp_ih_4_4 wp_ih_4_4 0 0.5322328912448866
Vwn_ih_4_4 wn_ih_4_4 0 0.46776710875511346
Vwp_ih_5_4 wp_ih_5_4 0 0.42902259196869363
Vwn_ih_5_4 wn_ih_5_4 0 0.5709774080313064
Vwp_ih_6_4 wp_ih_6_4 0 0.5192950782455388
Vwn_ih_6_4 wn_ih_6_4 0 0.4807049217544612
Vwp_ih_7_4 wp_ih_7_4 0 0.36022326868093746
Vwn_ih_7_4 wn_ih_7_4 0 0.6397767313190625
Vwp_ih_8_4 wp_ih_8_4 0 0.5307476697454162
Vwn_ih_8_4 wn_ih_8_4 0 0.4692523302545838
Vwp_ih_9_4 wp_ih_9_4 0 0.49792622184392593
Vwn_ih_9_4 wn_ih_9_4 0 0.5020737781560741
Vwp_ih_10_4 wp_ih_10_4 0 0.5666950386870325
Vwn_ih_10_4 wn_ih_10_4 0 0.43330496131296753
Vwp_ih_11_4 wp_ih_11_4 0 0.6160103849817763
Vwn_ih_11_4 wn_ih_11_4 0 0.38398961501822365
Vwp_ih_12_4 wp_ih_12_4 0 0.7098840353560065
Vwn_ih_12_4 wn_ih_12_4 0 0.3
Vwp_ih_13_4 wp_ih_13_4 0 0.4508600753661782
Vwn_ih_13_4 wn_ih_13_4 0 0.5491399246338218
Vwp_ih_14_4 wp_ih_14_4 0 0.6265973898750657
Vwn_ih_14_4 wn_ih_14_4 0 0.37340261012493425
Vwp_ih_15_4 wp_ih_15_4 0 0.4028621002119657
Vwn_ih_15_4 wn_ih_15_4 0 0.5971378997880342
Vwp_ho_4_0 wp_ho_4_0 0 0.45268713369932284
Vwn_ho_4_0 wn_ho_4_0 0 0.5473128663006772
Vwp_ho_4_1 wp_ho_4_1 0 0.760871776243734
Vwn_ho_4_1 wn_ho_4_1 0 0.3
Vwp_ho_4_2 wp_ho_4_2 0 0.5814451980462337
Vwn_ho_4_2 wn_ho_4_2 0 0.4185548019537662
Vwp_ho_4_3 wp_ho_4_3 0 0.6088131554220795
Vwn_ho_4_3 wn_ho_4_3 0 0.3911868445779205
Vwp_ho_4_4 wp_ho_4_4 0 0.39629233265225977
Vwn_ho_4_4 wn_ho_4_4 0 0.6037076673477402
Vwp_ih_0_5 wp_ih_0_5 0 0.3887297784016733
Vwn_ih_0_5 wn_ih_0_5 0 0.6112702215983268
Vwp_ih_1_5 wp_ih_1_5 0 0.4234301174026284
Vwn_ih_1_5 wn_ih_1_5 0 0.5765698825973716
Vwp_ih_2_5 wp_ih_2_5 0 0.38082250527267003
Vwn_ih_2_5 wn_ih_2_5 0 0.61917749472733
Vwp_ih_3_5 wp_ih_3_5 0 0.6188396398327879
Vwn_ih_3_5 wn_ih_3_5 0 0.3811603601672121
Vwp_ih_4_5 wp_ih_4_5 0 0.6121173605628477
Vwn_ih_4_5 wn_ih_4_5 0 0.3878826394371523
Vwp_ih_5_5 wp_ih_5_5 0 0.6566312608453148
Vwn_ih_5_5 wn_ih_5_5 0 0.34336873915468524
Vwp_ih_6_5 wp_ih_6_5 0 0.4961959802284574
Vwn_ih_6_5 wn_ih_6_5 0 0.5038040197715427
Vwp_ih_7_5 wp_ih_7_5 0 0.535126707783633
Vwn_ih_7_5 wn_ih_7_5 0 0.46487329221636703
Vwp_ih_8_5 wp_ih_8_5 0 0.43197150100134174
Vwn_ih_8_5 wn_ih_8_5 0 0.5680284989986583
Vwp_ih_9_5 wp_ih_9_5 0 0.3629917689965748
Vwn_ih_9_5 wn_ih_9_5 0 0.6370082310034252
Vwp_ih_10_5 wp_ih_10_5 0 0.5555632395960741
Vwn_ih_10_5 wn_ih_10_5 0 0.4444367604039259
Vwp_ih_11_5 wp_ih_11_5 0 0.5323110178001571
Vwn_ih_11_5 wn_ih_11_5 0 0.46768898219984295
Vwp_ih_12_5 wp_ih_12_5 0 0.3647647087654896
Vwn_ih_12_5 wn_ih_12_5 0 0.6352352912345104
Vwp_ih_13_5 wp_ih_13_5 0 0.5670172552391802
Vwn_ih_13_5 wn_ih_13_5 0 0.43298274476081977
Vwp_ih_14_5 wp_ih_14_5 0 0.3
Vwn_ih_14_5 wn_ih_14_5 0 0.7118355265919395
Vwp_ih_15_5 wp_ih_15_5 0 0.4767116190474385
Vwn_ih_15_5 wn_ih_15_5 0 0.5232883809525615
Vwp_ho_5_0 wp_ho_5_0 0 0.3643037083961927
Vwn_ho_5_0 wn_ho_5_0 0 0.6356962916038074
Vwp_ho_5_1 wp_ho_5_1 0 0.6124566289670047
Vwn_ho_5_1 wn_ho_5_1 0 0.3875433710329953
Vwp_ho_5_2 wp_ho_5_2 0 0.39465283123336325
Vwn_ho_5_2 wn_ho_5_2 0 0.6053471687666367
Vwp_ho_5_3 wp_ho_5_3 0 0.4326785851530691
Vwn_ho_5_3 wn_ho_5_3 0 0.5673214148469309
Vwp_ho_5_4 wp_ho_5_4 0 0.35346301254321844
Vwn_ho_5_4 wn_ho_5_4 0 0.6465369874567816
Vwp_ih_0_6 wp_ih_0_6 0 0.42231693620641586
Vwn_ih_0_6 wn_ih_0_6 0 0.5776830637935841
Vwp_ih_1_6 wp_ih_1_6 0 0.43350442362402497
Vwn_ih_1_6 wn_ih_1_6 0 0.566495576375975
Vwp_ih_2_6 wp_ih_2_6 0 0.36931299528396144
Vwn_ih_2_6 wn_ih_2_6 0 0.6306870047160386
Vwp_ih_3_6 wp_ih_3_6 0 0.6148067416752365
Vwn_ih_3_6 wn_ih_3_6 0 0.3851932583247635
Vwp_ih_4_6 wp_ih_4_6 0 0.5681117327050532
Vwn_ih_4_6 wn_ih_4_6 0 0.4318882672949468
Vwp_ih_5_6 wp_ih_5_6 0 0.6448500793457671
Vwn_ih_5_6 wn_ih_5_6 0 0.3551499206542329
Vwp_ih_6_6 wp_ih_6_6 0 0.516055074166922
Vwn_ih_6_6 wn_ih_6_6 0 0.483944925833078
Vwp_ih_7_6 wp_ih_7_6 0 0.34371829340937415
Vwn_ih_7_6 wn_ih_7_6 0 0.6562817065906259
Vwp_ih_8_6 wp_ih_8_6 0 0.45485094130986464
Vwn_ih_8_6 wn_ih_8_6 0 0.5451490586901353
Vwp_ih_9_6 wp_ih_9_6 0 0.3565430561653765
Vwn_ih_9_6 wn_ih_9_6 0 0.6434569438346235
Vwp_ih_10_6 wp_ih_10_6 0 0.5563748283743912
Vwn_ih_10_6 wn_ih_10_6 0 0.44362517162560877
Vwp_ih_11_6 wp_ih_11_6 0 0.6449950545660585
Vwn_ih_11_6 wn_ih_11_6 0 0.35500494543394145
Vwp_ih_12_6 wp_ih_12_6 0 0.5370249677189438
Vwn_ih_12_6 wn_ih_12_6 0 0.4629750322810562
Vwp_ih_13_6 wp_ih_13_6 0 0.42250071348778956
Vwn_ih_13_6 wn_ih_13_6 0 0.5774992865122104
Vwp_ih_14_6 wp_ih_14_6 0 0.4536704796958904
Vwn_ih_14_6 wn_ih_14_6 0 0.5463295203041096
Vwp_ih_15_6 wp_ih_15_6 0 0.5228010579916997
Vwn_ih_15_6 wn_ih_15_6 0 0.47719894200830026
Vwp_ho_6_0 wp_ho_6_0 0 0.5761422998093544
Vwn_ho_6_0 wn_ho_6_0 0 0.42385770019064556
Vwp_ho_6_1 wp_ho_6_1 0 0.5688601723130191
Vwn_ho_6_1 wn_ho_6_1 0 0.4311398276869809
Vwp_ho_6_2 wp_ho_6_2 0 0.5848354187414834
Vwn_ho_6_2 wn_ho_6_2 0 0.41516458125851663
Vwp_ho_6_3 wp_ho_6_3 0 0.4056136514663686
Vwn_ho_6_3 wn_ho_6_3 0 0.5943863485336314
Vwp_ho_6_4 wp_ho_6_4 0 0.38134902210567456
Vwn_ho_6_4 wn_ho_6_4 0 0.6186509778943254
Vwp_ih_0_7 wp_ih_0_7 0 0.3207309403995643
Vwn_ih_0_7 wn_ih_0_7 0 0.6792690596004357
Vwp_ih_1_7 wp_ih_1_7 0 0.5126768536541392
Vwn_ih_1_7 wn_ih_1_7 0 0.4873231463458608
Vwp_ih_2_7 wp_ih_2_7 0 0.5216022991069582
Vwn_ih_2_7 wn_ih_2_7 0 0.47839770089304173
Vwp_ih_3_7 wp_ih_3_7 0 0.4320840554065688
Vwn_ih_3_7 wn_ih_3_7 0 0.5679159445934312
Vwp_ih_4_7 wp_ih_4_7 0 0.446264245985391
Vwn_ih_4_7 wn_ih_4_7 0 0.5537357540146091
Vwp_ih_5_7 wp_ih_5_7 0 0.5212929195809508
Vwn_ih_5_7 wn_ih_5_7 0 0.47870708041904925
Vwp_ih_6_7 wp_ih_6_7 0 0.39932437012396993
Vwn_ih_6_7 wn_ih_6_7 0 0.6006756298760301
Vwp_ih_7_7 wp_ih_7_7 0 0.399784020412512
Vwn_ih_7_7 wn_ih_7_7 0 0.6002159795874881
Vwp_ih_8_7 wp_ih_8_7 0 0.593400133453662
Vwn_ih_8_7 wn_ih_8_7 0 0.4065998665463379
Vwp_ih_9_7 wp_ih_9_7 0 0.5264029557054352
Vwn_ih_9_7 wn_ih_9_7 0 0.47359704429456484
Vwp_ih_10_7 wp_ih_10_7 0 0.7029710153011985
Vwn_ih_10_7 wn_ih_10_7 0 0.3
Vwp_ih_11_7 wp_ih_11_7 0 0.377123729563654
Vwn_ih_11_7 wn_ih_11_7 0 0.622876270436346
Vwp_ih_12_7 wp_ih_12_7 0 0.3
Vwn_ih_12_7 wn_ih_12_7 0 0.7179501272778891
Vwp_ih_13_7 wp_ih_13_7 0 0.6067718111689944
Vwn_ih_13_7 wn_ih_13_7 0 0.39322818883100563
Vwp_ih_14_7 wp_ih_14_7 0 0.6126864212713756
Vwn_ih_14_7 wn_ih_14_7 0 0.3873135787286243
Vwp_ih_15_7 wp_ih_15_7 0 0.40705543045309456
Vwn_ih_15_7 wn_ih_15_7 0 0.5929445695469054
Vwp_ho_7_0 wp_ho_7_0 0 0.35112603816172716
Vwn_ho_7_0 wn_ho_7_0 0 0.6488739618382728
Vwp_ho_7_1 wp_ho_7_1 0 0.4590181689372632
Vwn_ho_7_1 wn_ho_7_1 0 0.5409818310627368
Vwp_ho_7_2 wp_ho_7_2 0 0.3300290031585317
Vwn_ho_7_2 wn_ho_7_2 0 0.6699709968414683
Vwp_ho_7_3 wp_ho_7_3 0 0.7375472156959703
Vwn_ho_7_3 wn_ho_7_3 0 0.3
Vwp_ho_7_4 wp_ho_7_4 0 0.39930529853345587
Vwn_ho_7_4 wn_ho_7_4 0 0.6006947014665441
Vwp_ih_0_8 wp_ih_0_8 0 0.31391950380255645
Vwn_ih_0_8 wn_ih_0_8 0 0.6860804961974436
Vwp_ih_1_8 wp_ih_1_8 0 0.4836837734192989
Vwn_ih_1_8 wn_ih_1_8 0 0.5163162265807011
Vwp_ih_2_8 wp_ih_2_8 0 0.3
Vwn_ih_2_8 wn_ih_2_8 0 0.7175338006516273
Vwp_ih_3_8 wp_ih_3_8 0 0.45471347062510004
Vwn_ih_3_8 wn_ih_3_8 0 0.5452865293749
Vwp_ih_4_8 wp_ih_4_8 0 0.3
Vwn_ih_4_8 wn_ih_4_8 0 0.7678275082629261
Vwp_ih_5_8 wp_ih_5_8 0 0.47241020561679425
Vwn_ih_5_8 wn_ih_5_8 0 0.5275897943832057
Vwp_ih_6_8 wp_ih_6_8 0 0.3
Vwn_ih_6_8 wn_ih_6_8 0 0.7615222593337084
Vwp_ih_7_8 wp_ih_7_8 0 0.47137197628315247
Vwn_ih_7_8 wn_ih_7_8 0 0.5286280237168476
Vwp_ih_8_8 wp_ih_8_8 0 0.6842004927963832
Vwn_ih_8_8 wn_ih_8_8 0 0.31579950720361677
Vwp_ih_9_8 wp_ih_9_8 0 0.4672433972259369
Vwn_ih_9_8 wn_ih_9_8 0 0.5327566027740631
Vwp_ih_10_8 wp_ih_10_8 0 0.5939235729454533
Vwn_ih_10_8 wn_ih_10_8 0 0.4060764270545467
Vwp_ih_11_8 wp_ih_11_8 0 0.41836900831138013
Vwn_ih_11_8 wn_ih_11_8 0 0.5816309916886199
Vwp_ih_12_8 wp_ih_12_8 0 0.38637492717197175
Vwn_ih_12_8 wn_ih_12_8 0 0.6136250728280283
Vwp_ih_13_8 wp_ih_13_8 0 0.30745765423922666
Vwn_ih_13_8 wn_ih_13_8 0 0.6925423457607733
Vwp_ih_14_8 wp_ih_14_8 0 0.6204082503498998
Vwn_ih_14_8 wn_ih_14_8 0 0.37959174965010023
Vwp_ih_15_8 wp_ih_15_8 0 0.4868180536999822
Vwn_ih_15_8 wn_ih_15_8 0 0.5131819463000178
Vwp_ho_8_0 wp_ho_8_0 0 0.384264841982798
Vwn_ho_8_0 wn_ho_8_0 0 0.615735158017202
Vwp_ho_8_1 wp_ho_8_1 0 0.4767190406163889
Vwn_ho_8_1 wn_ho_8_1 0 0.5232809593836111
Vwp_ho_8_2 wp_ho_8_2 0 0.3
Vwn_ho_8_2 wn_ho_8_2 0 0.7260774233804879
Vwp_ho_8_3 wp_ho_8_3 0 0.4736407840001588
Vwn_ho_8_3 wn_ho_8_3 0 0.5263592159998413
Vwp_ho_8_4 wp_ho_8_4 0 0.5173500843220764
Vwn_ho_8_4 wn_ho_8_4 0 0.4826499156779236
Vwp_ih_0_9 wp_ih_0_9 0 0.6895941374926272
Vwn_ih_0_9 wn_ih_0_9 0 0.3104058625073728
Vwp_ih_1_9 wp_ih_1_9 0 0.3492370909474768
Vwn_ih_1_9 wn_ih_1_9 0 0.6507629090525232
Vwp_ih_2_9 wp_ih_2_9 0 0.4656153441730491
Vwn_ih_2_9 wn_ih_2_9 0 0.5343846558269509
Vwp_ih_3_9 wp_ih_3_9 0 0.5050128246861815
Vwn_ih_3_9 wn_ih_3_9 0 0.4949871753138185
Vwp_ih_4_9 wp_ih_4_9 0 0.6660693619285432
Vwn_ih_4_9 wn_ih_4_9 0 0.33393063807145684
Vwp_ih_5_9 wp_ih_5_9 0 0.7192447409417282
Vwn_ih_5_9 wn_ih_5_9 0 0.3
Vwp_ih_6_9 wp_ih_6_9 0 0.41680271000299096
Vwn_ih_6_9 wn_ih_6_9 0 0.583197289997009
Vwp_ih_7_9 wp_ih_7_9 0 0.3557321571765138
Vwn_ih_7_9 wn_ih_7_9 0 0.6442678428234863
Vwp_ih_8_9 wp_ih_8_9 0 0.3
Vwn_ih_8_9 wn_ih_8_9 0 0.7154909513074816
Vwp_ih_9_9 wp_ih_9_9 0 0.6588651716464338
Vwn_ih_9_9 wn_ih_9_9 0 0.3411348283535663
Vwp_ih_10_9 wp_ih_10_9 0 0.48636114858142004
Vwn_ih_10_9 wn_ih_10_9 0 0.5136388514185799
Vwp_ih_11_9 wp_ih_11_9 0 0.41213556243929456
Vwn_ih_11_9 wn_ih_11_9 0 0.5878644375607054
Vwp_ih_12_9 wp_ih_12_9 0 0.48533328360475375
Vwn_ih_12_9 wn_ih_12_9 0 0.5146667163952463
Vwp_ih_13_9 wp_ih_13_9 0 0.3
Vwn_ih_13_9 wn_ih_13_9 0 0.8190457392138527
Vwp_ih_14_9 wp_ih_14_9 0 0.3
Vwn_ih_14_9 wn_ih_14_9 0 0.7161962644678859
Vwp_ih_15_9 wp_ih_15_9 0 0.6067372331647976
Vwn_ih_15_9 wn_ih_15_9 0 0.39326276683520245
Vwp_ho_9_0 wp_ho_9_0 0 0.6035017396675877
Vwn_ho_9_0 wn_ho_9_0 0 0.3964982603324123
Vwp_ho_9_1 wp_ho_9_1 0 0.45511288609167666
Vwn_ho_9_1 wn_ho_9_1 0 0.5448871139083233
Vwp_ho_9_2 wp_ho_9_2 0 0.3403686949933702
Vwn_ho_9_2 wn_ho_9_2 0 0.6596313050066298
Vwp_ho_9_3 wp_ho_9_3 0 0.554872079338592
Vwn_ho_9_3 wn_ho_9_3 0 0.445127920661408
Vwp_ho_9_4 wp_ho_9_4 0 0.5948005204586216
Vwn_ho_9_4 wn_ho_9_4 0 0.40519947954137836
Vwp_ih_0_10 wp_ih_0_10 0 0.5430337893202055
Vwn_ih_0_10 wn_ih_0_10 0 0.4569662106797944
Vwp_ih_1_10 wp_ih_1_10 0 0.5129502038644697
Vwn_ih_1_10 wn_ih_1_10 0 0.48704979613553034
Vwp_ih_2_10 wp_ih_2_10 0 0.3718214423704812
Vwn_ih_2_10 wn_ih_2_10 0 0.6281785576295188
Vwp_ih_3_10 wp_ih_3_10 0 0.5640310725333906
Vwn_ih_3_10 wn_ih_3_10 0 0.43596892746660937
Vwp_ih_4_10 wp_ih_4_10 0 0.7094147139704752
Vwn_ih_4_10 wn_ih_4_10 0 0.3
Vwp_ih_5_10 wp_ih_5_10 0 0.3450240071422527
Vwn_ih_5_10 wn_ih_5_10 0 0.6549759928577473
Vwp_ih_6_10 wp_ih_6_10 0 0.49502052141556574
Vwn_ih_6_10 wn_ih_6_10 0 0.5049794785844343
Vwp_ih_7_10 wp_ih_7_10 0 0.44095975007744354
Vwn_ih_7_10 wn_ih_7_10 0 0.5590402499225564
Vwp_ih_8_10 wp_ih_8_10 0 0.5364921419813758
Vwn_ih_8_10 wn_ih_8_10 0 0.46350785801862415
Vwp_ih_9_10 wp_ih_9_10 0 0.4947775479867666
Vwn_ih_9_10 wn_ih_9_10 0 0.5052224520132335
Vwp_ih_10_10 wp_ih_10_10 0 0.47475528356586016
Vwn_ih_10_10 wn_ih_10_10 0 0.5252447164341398
Vwp_ih_11_10 wp_ih_11_10 0 0.3864894091828265
Vwn_ih_11_10 wn_ih_11_10 0 0.6135105908171735
Vwp_ih_12_10 wp_ih_12_10 0 0.49169105512333416
Vwn_ih_12_10 wn_ih_12_10 0 0.5083089448766658
Vwp_ih_13_10 wp_ih_13_10 0 0.4206101199595948
Vwn_ih_13_10 wn_ih_13_10 0 0.5793898800404051
Vwp_ih_14_10 wp_ih_14_10 0 0.4756443215170101
Vwn_ih_14_10 wn_ih_14_10 0 0.5243556784829899
Vwp_ih_15_10 wp_ih_15_10 0 0.48705500785329614
Vwn_ih_15_10 wn_ih_15_10 0 0.5129449921467039
Vwp_ho_10_0 wp_ho_10_0 0 0.6142895735993353
Vwn_ho_10_0 wn_ho_10_0 0 0.38571042640066466
Vwp_ho_10_1 wp_ho_10_1 0 0.46012603740921115
Vwn_ho_10_1 wn_ho_10_1 0 0.5398739625907888
Vwp_ho_10_2 wp_ho_10_2 0 0.30065301279246925
Vwn_ho_10_2 wn_ho_10_2 0 0.6993469872075307
Vwp_ho_10_3 wp_ho_10_3 0 0.5873056653203894
Vwn_ho_10_3 wn_ho_10_3 0 0.41269433467961053
Vwp_ho_10_4 wp_ho_10_4 0 0.3
Vwn_ho_10_4 wn_ho_10_4 0 0.7523169624232227
Vwp_ih_0_11 wp_ih_0_11 0 0.5735776471023734
Vwn_ih_0_11 wn_ih_0_11 0 0.42642235289762664
Vwp_ih_1_11 wp_ih_1_11 0 0.42593109186104144
Vwn_ih_1_11 wn_ih_1_11 0 0.5740689081389585
Vwp_ih_2_11 wp_ih_2_11 0 0.4545590222354434
Vwn_ih_2_11 wn_ih_2_11 0 0.5454409777645566
Vwp_ih_3_11 wp_ih_3_11 0 0.6228569038012084
Vwn_ih_3_11 wn_ih_3_11 0 0.37714309619879155
Vwp_ih_4_11 wp_ih_4_11 0 0.4674446427867611
Vwn_ih_4_11 wn_ih_4_11 0 0.5325553572132389
Vwp_ih_5_11 wp_ih_5_11 0 0.4605260739263517
Vwn_ih_5_11 wn_ih_5_11 0 0.5394739260736483
Vwp_ih_6_11 wp_ih_6_11 0 0.597305682717826
Vwn_ih_6_11 wn_ih_6_11 0 0.402694317282174
Vwp_ih_7_11 wp_ih_7_11 0 0.5260003277795382
Vwn_ih_7_11 wn_ih_7_11 0 0.4739996722204618
Vwp_ih_8_11 wp_ih_8_11 0 0.5036185862030367
Vwn_ih_8_11 wn_ih_8_11 0 0.49638141379696327
Vwp_ih_9_11 wp_ih_9_11 0 0.5200712713551803
Vwn_ih_9_11 wn_ih_9_11 0 0.47992872864481967
Vwp_ih_10_11 wp_ih_10_11 0 0.3418140231915312
Vwn_ih_10_11 wn_ih_10_11 0 0.6581859768084688
Vwp_ih_11_11 wp_ih_11_11 0 0.5492970001724554
Vwn_ih_11_11 wn_ih_11_11 0 0.4507029998275446
Vwp_ih_12_11 wp_ih_12_11 0 0.6544976662051795
Vwn_ih_12_11 wn_ih_12_11 0 0.34550233379482054
Vwp_ih_13_11 wp_ih_13_11 0 0.5667592684410544
Vwn_ih_13_11 wn_ih_13_11 0 0.43324073155894555
Vwp_ih_14_11 wp_ih_14_11 0 0.30538789278316214
Vwn_ih_14_11 wn_ih_14_11 0 0.6946121072168379
Vwp_ih_15_11 wp_ih_15_11 0 0.5281097677384904
Vwn_ih_15_11 wn_ih_15_11 0 0.4718902322615096
Vwp_ho_11_0 wp_ho_11_0 0 0.5772520038741867
Vwn_ho_11_0 wn_ho_11_0 0 0.42274799612581326
Vwp_ho_11_1 wp_ho_11_1 0 0.3
Vwn_ho_11_1 wn_ho_11_1 0 0.7891762160977704
Vwp_ho_11_2 wp_ho_11_2 0 0.49557041973475935
Vwn_ho_11_2 wn_ho_11_2 0 0.5044295802652407
Vwp_ho_11_3 wp_ho_11_3 0 0.6678816672791047
Vwn_ho_11_3 wn_ho_11_3 0 0.3321183327208953
Vwp_ho_11_4 wp_ho_11_4 0 0.43373561101395486
Vwn_ho_11_4 wn_ho_11_4 0 0.5662643889860451
Vwp_ih_0_12 wp_ih_0_12 0 0.38237425602295994
Vwn_ih_0_12 wn_ih_0_12 0 0.6176257439770401
Vwp_ih_1_12 wp_ih_1_12 0 0.4645502993402514
Vwn_ih_1_12 wn_ih_1_12 0 0.5354497006597486
Vwp_ih_2_12 wp_ih_2_12 0 0.5085392739792836
Vwn_ih_2_12 wn_ih_2_12 0 0.49146072602071644
Vwp_ih_3_12 wp_ih_3_12 0 0.350347620724039
Vwn_ih_3_12 wn_ih_3_12 0 0.649652379275961
Vwp_ih_4_12 wp_ih_4_12 0 0.6587504116321886
Vwn_ih_4_12 wn_ih_4_12 0 0.3412495883678114
Vwp_ih_5_12 wp_ih_5_12 0 0.48942165000842736
Vwn_ih_5_12 wn_ih_5_12 0 0.5105783499915726
Vwp_ih_6_12 wp_ih_6_12 0 0.588175332886274
Vwn_ih_6_12 wn_ih_6_12 0 0.41182466711372606
Vwp_ih_7_12 wp_ih_7_12 0 0.5744161665759279
Vwn_ih_7_12 wn_ih_7_12 0 0.42558383342407213
Vwp_ih_8_12 wp_ih_8_12 0 0.6611240202233123
Vwn_ih_8_12 wn_ih_8_12 0 0.3388759797766877
Vwp_ih_9_12 wp_ih_9_12 0 0.6414561982990269
Vwn_ih_9_12 wn_ih_9_12 0 0.3585438017009731
Vwp_ih_10_12 wp_ih_10_12 0 0.3167160997072934
Vwn_ih_10_12 wn_ih_10_12 0 0.6832839002927066
Vwp_ih_11_12 wp_ih_11_12 0 0.5022911257042353
Vwn_ih_11_12 wn_ih_11_12 0 0.4977088742957647
Vwp_ih_12_12 wp_ih_12_12 0 0.3
Vwn_ih_12_12 wn_ih_12_12 0 0.763311858642981
Vwp_ih_13_12 wp_ih_13_12 0 0.4395842403863587
Vwn_ih_13_12 wn_ih_13_12 0 0.5604157596136413
Vwp_ih_14_12 wp_ih_14_12 0 0.5815735460961925
Vwn_ih_14_12 wn_ih_14_12 0 0.4184264539038075
Vwp_ih_15_12 wp_ih_15_12 0 0.6048274123716137
Vwn_ih_15_12 wn_ih_15_12 0 0.3951725876283862
Vwp_ho_12_0 wp_ho_12_0 0 0.5378321002867367
Vwn_ho_12_0 wn_ho_12_0 0 0.4621678997132633
Vwp_ho_12_1 wp_ho_12_1 0 0.49111005899348814
Vwn_ho_12_1 wn_ho_12_1 0 0.5088899410065119
Vwp_ho_12_2 wp_ho_12_2 0 0.46060335298983035
Vwn_ho_12_2 wn_ho_12_2 0 0.5393966470101696
Vwp_ho_12_3 wp_ho_12_3 0 0.33912243829387734
Vwn_ho_12_3 wn_ho_12_3 0 0.6608775617061227
Vwp_ho_12_4 wp_ho_12_4 0 0.6059343291781307
Vwn_ho_12_4 wn_ho_12_4 0 0.39406567082186933
Vwp_ih_0_13 wp_ih_0_13 0 0.6497156154372634
Vwn_ih_0_13 wn_ih_0_13 0 0.35028438456273653
Vwp_ih_1_13 wp_ih_1_13 0 0.4476307416069454
Vwn_ih_1_13 wn_ih_1_13 0 0.5523692583930546
Vwp_ih_2_13 wp_ih_2_13 0 0.5346170924432425
Vwn_ih_2_13 wn_ih_2_13 0 0.4653829075567575
Vwp_ih_3_13 wp_ih_3_13 0 0.5079663180229507
Vwn_ih_3_13 wn_ih_3_13 0 0.4920336819770494
Vwp_ih_4_13 wp_ih_4_13 0 0.6507931919210637
Vwn_ih_4_13 wn_ih_4_13 0 0.34920680807893634
Vwp_ih_5_13 wp_ih_5_13 0 0.6898681943375686
Vwn_ih_5_13 wn_ih_5_13 0 0.31013180566243137
Vwp_ih_6_13 wp_ih_6_13 0 0.4516662808185993
Vwn_ih_6_13 wn_ih_6_13 0 0.5483337191814007
Vwp_ih_7_13 wp_ih_7_13 0 0.9
Vwn_ih_7_13 wn_ih_7_13 0 0.3
Vwp_ih_8_13 wp_ih_8_13 0 0.49929264930546535
Vwn_ih_8_13 wn_ih_8_13 0 0.5007073506945346
Vwp_ih_9_13 wp_ih_9_13 0 0.4526584312390134
Vwn_ih_9_13 wn_ih_9_13 0 0.5473415687609866
Vwp_ih_10_13 wp_ih_10_13 0 0.5706036790502266
Vwn_ih_10_13 wn_ih_10_13 0 0.4293963209497735
Vwp_ih_11_13 wp_ih_11_13 0 0.5900712748214606
Vwn_ih_11_13 wn_ih_11_13 0 0.4099287251785394
Vwp_ih_12_13 wp_ih_12_13 0 0.5615861690573142
Vwn_ih_12_13 wn_ih_12_13 0 0.4384138309426859
Vwp_ih_13_13 wp_ih_13_13 0 0.41476082853210494
Vwn_ih_13_13 wn_ih_13_13 0 0.5852391714678951
Vwp_ih_14_13 wp_ih_14_13 0 0.674735355328516
Vwn_ih_14_13 wn_ih_14_13 0 0.3252646446714839
Vwp_ih_15_13 wp_ih_15_13 0 0.5018949221908479
Vwn_ih_15_13 wn_ih_15_13 0 0.49810507780915214
Vwp_ho_13_0 wp_ho_13_0 0 0.7700624057859654
Vwn_ho_13_0 wn_ho_13_0 0 0.3
Vwp_ho_13_1 wp_ho_13_1 0 0.45257233250892587
Vwn_ho_13_1 wn_ho_13_1 0 0.5474276674910742
Vwp_ho_13_2 wp_ho_13_2 0 0.5375596026119843
Vwn_ho_13_2 wn_ho_13_2 0 0.4624403973880157
Vwp_ho_13_3 wp_ho_13_3 0 0.44125760551764165
Vwn_ho_13_3 wn_ho_13_3 0 0.5587423944823584
Vwp_ho_13_4 wp_ho_13_4 0 0.5231343848530915
Vwn_ho_13_4 wn_ho_13_4 0 0.47686561514690845
Vwp_ih_0_14 wp_ih_0_14 0 0.6853567965757332
Vwn_ih_0_14 wn_ih_0_14 0 0.31464320342426677
Vwp_ih_1_14 wp_ih_1_14 0 0.6683567650610694
Vwn_ih_1_14 wn_ih_1_14 0 0.33164323493893055
Vwp_ih_2_14 wp_ih_2_14 0 0.340960317671947
Vwn_ih_2_14 wn_ih_2_14 0 0.659039682328053
Vwp_ih_3_14 wp_ih_3_14 0 0.378624824398614
Vwn_ih_3_14 wn_ih_3_14 0 0.621375175601386
Vwp_ih_4_14 wp_ih_4_14 0 0.37513215286313845
Vwn_ih_4_14 wn_ih_4_14 0 0.6248678471368615
Vwp_ih_5_14 wp_ih_5_14 0 0.5257929025788329
Vwn_ih_5_14 wn_ih_5_14 0 0.47420709742116707
Vwp_ih_6_14 wp_ih_6_14 0 0.5042300578917035
Vwn_ih_6_14 wn_ih_6_14 0 0.4957699421082965
Vwp_ih_7_14 wp_ih_7_14 0 0.5265219899561361
Vwn_ih_7_14 wn_ih_7_14 0 0.4734780100438639
Vwp_ih_8_14 wp_ih_8_14 0 0.3963606643816664
Vwn_ih_8_14 wn_ih_8_14 0 0.6036393356183336
Vwp_ih_9_14 wp_ih_9_14 0 0.5487493244133067
Vwn_ih_9_14 wn_ih_9_14 0 0.4512506755866933
Vwp_ih_10_14 wp_ih_10_14 0 0.666687538946902
Vwn_ih_10_14 wn_ih_10_14 0 0.333312461053098
Vwp_ih_11_14 wp_ih_11_14 0 0.333668839255433
Vwn_ih_11_14 wn_ih_11_14 0 0.666331160744567
Vwp_ih_12_14 wp_ih_12_14 0 0.4753013769777327
Vwn_ih_12_14 wn_ih_12_14 0 0.5246986230222672
Vwp_ih_13_14 wp_ih_13_14 0 0.5315699168505069
Vwn_ih_13_14 wn_ih_13_14 0 0.4684300831494931
Vwp_ih_14_14 wp_ih_14_14 0 0.4828473270343145
Vwn_ih_14_14 wn_ih_14_14 0 0.5171526729656855
Vwp_ih_15_14 wp_ih_15_14 0 0.4773230240001395
Vwn_ih_15_14 wn_ih_15_14 0 0.5226769759998605
Vwp_ho_14_0 wp_ho_14_0 0 0.3546435741363846
Vwn_ho_14_0 wn_ho_14_0 0 0.6453564258636154
Vwp_ho_14_1 wp_ho_14_1 0 0.5331035874224372
Vwn_ho_14_1 wn_ho_14_1 0 0.46689641257756276
Vwp_ho_14_2 wp_ho_14_2 0 0.3747819653045362
Vwn_ho_14_2 wn_ho_14_2 0 0.6252180346954638
Vwp_ho_14_3 wp_ho_14_3 0 0.4472138406053228
Vwn_ho_14_3 wn_ho_14_3 0 0.5527861593946772
Vwp_ho_14_4 wp_ho_14_4 0 0.560326952279931
Vwn_ho_14_4 wn_ho_14_4 0 0.439673047720069
Vwp_ih_0_15 wp_ih_0_15 0 0.7131210761627967
Vwn_ih_0_15 wn_ih_0_15 0 0.3
Vwp_ih_1_15 wp_ih_1_15 0 0.6569788940254864
Vwn_ih_1_15 wn_ih_1_15 0 0.3430211059745136
Vwp_ih_2_15 wp_ih_2_15 0 0.5997949271388419
Vwn_ih_2_15 wn_ih_2_15 0 0.4002050728611582
Vwp_ih_3_15 wp_ih_3_15 0 0.406369966493447
Vwn_ih_3_15 wn_ih_3_15 0 0.5936300335065531
Vwp_ih_4_15 wp_ih_4_15 0 0.7703886674492769
Vwn_ih_4_15 wn_ih_4_15 0 0.3
Vwp_ih_5_15 wp_ih_5_15 0 0.5418475064444382
Vwn_ih_5_15 wn_ih_5_15 0 0.45815249355556176
Vwp_ih_6_15 wp_ih_6_15 0 0.4278994233619
Vwn_ih_6_15 wn_ih_6_15 0 0.5721005766381
Vwp_ih_7_15 wp_ih_7_15 0 0.4574549586462554
Vwn_ih_7_15 wn_ih_7_15 0 0.5425450413537446
Vwp_ih_8_15 wp_ih_8_15 0 0.43899615813386594
Vwn_ih_8_15 wn_ih_8_15 0 0.5610038418661341
Vwp_ih_9_15 wp_ih_9_15 0 0.7550937920768805
Vwn_ih_9_15 wn_ih_9_15 0 0.3
Vwp_ih_10_15 wp_ih_10_15 0 0.5199488675370039
Vwn_ih_10_15 wn_ih_10_15 0 0.4800511324629961
Vwp_ih_11_15 wp_ih_11_15 0 0.5059497627230694
Vwn_ih_11_15 wn_ih_11_15 0 0.4940502372769307
Vwp_ih_12_15 wp_ih_12_15 0 0.3
Vwn_ih_12_15 wn_ih_12_15 0 0.7609455482014957
Vwp_ih_13_15 wp_ih_13_15 0 0.5911343015629281
Vwn_ih_13_15 wn_ih_13_15 0 0.4088656984370719
Vwp_ih_14_15 wp_ih_14_15 0 0.36921438907177284
Vwn_ih_14_15 wn_ih_14_15 0 0.6307856109282272
Vwp_ih_15_15 wp_ih_15_15 0 0.3615503244059528
Vwn_ih_15_15 wn_ih_15_15 0 0.6384496755940472
Vwp_ho_15_0 wp_ho_15_0 0 0.4097352707931674
Vwn_ho_15_0 wn_ho_15_0 0 0.5902647292068326
Vwp_ho_15_1 wp_ho_15_1 0 0.524187857006116
Vwn_ho_15_1 wn_ho_15_1 0 0.47581214299388397
Vwp_ho_15_2 wp_ho_15_2 0 0.8010663644358311
Vwn_ho_15_2 wn_ho_15_2 0 0.3
Vwp_ho_15_3 wp_ho_15_3 0 0.4635626249195678
Vwn_ho_15_3 wn_ho_15_3 0 0.5364373750804322
Vwp_ho_15_4 wp_ho_15_4 0 0.32162566641304025
Vwn_ho_15_4 wn_ho_15_4 0 0.6783743335869598
Vwp_ih_0_16 wp_ih_0_16 0 0.5678963058818474
Vwn_ih_0_16 wn_ih_0_16 0 0.4321036941181527
Vwp_ih_1_16 wp_ih_1_16 0 0.3874726707660011
Vwn_ih_1_16 wn_ih_1_16 0 0.6125273292339989
Vwp_ih_2_16 wp_ih_2_16 0 0.6025359194918085
Vwn_ih_2_16 wn_ih_2_16 0 0.3974640805081915
Vwp_ih_3_16 wp_ih_3_16 0 0.6342023378120665
Vwn_ih_3_16 wn_ih_3_16 0 0.3657976621879335
Vwp_ih_4_16 wp_ih_4_16 0 0.3
Vwn_ih_4_16 wn_ih_4_16 0 0.7200392004939177
Vwp_ih_5_16 wp_ih_5_16 0 0.4833190631124898
Vwn_ih_5_16 wn_ih_5_16 0 0.5166809368875103
Vwp_ih_6_16 wp_ih_6_16 0 0.3104407585402028
Vwn_ih_6_16 wn_ih_6_16 0 0.6895592414597972
Vwp_ih_7_16 wp_ih_7_16 0 0.4934103414372416
Vwn_ih_7_16 wn_ih_7_16 0 0.5065896585627584
Vwp_ih_8_16 wp_ih_8_16 0 0.610620946286965
Vwn_ih_8_16 wn_ih_8_16 0 0.38937905371303505
Vwp_ih_9_16 wp_ih_9_16 0 0.3334882296208649
Vwn_ih_9_16 wn_ih_9_16 0 0.6665117703791351
Vwp_ih_10_16 wp_ih_10_16 0 0.7219889006310369
Vwn_ih_10_16 wn_ih_10_16 0 0.3
Vwp_ih_11_16 wp_ih_11_16 0 0.46124345243758336
Vwn_ih_11_16 wn_ih_11_16 0 0.5387565475624166
Vwp_ih_12_16 wp_ih_12_16 0 0.35448454618565095
Vwn_ih_12_16 wn_ih_12_16 0 0.645515453814349
Vwp_ih_13_16 wp_ih_13_16 0 0.47532732046984466
Vwn_ih_13_16 wn_ih_13_16 0 0.5246726795301553
Vwp_ih_14_16 wp_ih_14_16 0 0.593728185730398
Vwn_ih_14_16 wn_ih_14_16 0 0.40627181426960196
Vwp_ih_15_16 wp_ih_15_16 0 0.32856114412179405
Vwn_ih_15_16 wn_ih_15_16 0 0.671438855878206
Vwp_ho_16_0 wp_ho_16_0 0 0.3813807297503084
Vwn_ho_16_0 wn_ho_16_0 0 0.6186192702496915
Vwp_ho_16_1 wp_ho_16_1 0 0.6003300440240926
Vwn_ho_16_1 wn_ho_16_1 0 0.3996699559759074
Vwp_ho_16_2 wp_ho_16_2 0 0.4895788197616519
Vwn_ho_16_2 wn_ho_16_2 0 0.510421180238348
Vwp_ho_16_3 wp_ho_16_3 0 0.3
Vwn_ho_16_3 wn_ho_16_3 0 0.7881707545534787
Vwp_ho_16_4 wp_ho_16_4 0 0.6123935926171065
Vwn_ho_16_4 wn_ho_16_4 0 0.3876064073828935
Vwp_ih_0_17 wp_ih_0_17 0 0.4916263282434207
Vwn_ih_0_17 wn_ih_0_17 0 0.5083736717565793
Vwp_ih_1_17 wp_ih_1_17 0 0.3239772542456708
Vwn_ih_1_17 wn_ih_1_17 0 0.6760227457543292
Vwp_ih_2_17 wp_ih_2_17 0 0.6445260821710548
Vwn_ih_2_17 wn_ih_2_17 0 0.3554739178289453
Vwp_ih_3_17 wp_ih_3_17 0 0.5172034813952928
Vwn_ih_3_17 wn_ih_3_17 0 0.4827965186047072
Vwp_ih_4_17 wp_ih_4_17 0 0.4457655371599452
Vwn_ih_4_17 wn_ih_4_17 0 0.5542344628400547
Vwp_ih_5_17 wp_ih_5_17 0 0.6280216514122196
Vwn_ih_5_17 wn_ih_5_17 0 0.37197834858778045
Vwp_ih_6_17 wp_ih_6_17 0 0.3426742255819937
Vwn_ih_6_17 wn_ih_6_17 0 0.6573257744180063
Vwp_ih_7_17 wp_ih_7_17 0 0.4546426022439638
Vwn_ih_7_17 wn_ih_7_17 0 0.5453573977560362
Vwp_ih_8_17 wp_ih_8_17 0 0.7257667701308497
Vwn_ih_8_17 wn_ih_8_17 0 0.3
Vwp_ih_9_17 wp_ih_9_17 0 0.4860904462650261
Vwn_ih_9_17 wn_ih_9_17 0 0.5139095537349738
Vwp_ih_10_17 wp_ih_10_17 0 0.6677526932549194
Vwn_ih_10_17 wn_ih_10_17 0 0.3322473067450807
Vwp_ih_11_17 wp_ih_11_17 0 0.52267323765888
Vwn_ih_11_17 wn_ih_11_17 0 0.47732676234112
Vwp_ih_12_17 wp_ih_12_17 0 0.4114508619389127
Vwn_ih_12_17 wn_ih_12_17 0 0.5885491380610872
Vwp_ih_13_17 wp_ih_13_17 0 0.4582910205148244
Vwn_ih_13_17 wn_ih_13_17 0 0.5417089794851756
Vwp_ih_14_17 wp_ih_14_17 0 0.5055437046233203
Vwn_ih_14_17 wn_ih_14_17 0 0.4944562953766796
Vwp_ih_15_17 wp_ih_15_17 0 0.4430153727814726
Vwn_ih_15_17 wn_ih_15_17 0 0.5569846272185274
Vwp_ho_17_0 wp_ho_17_0 0 0.6053077759188079
Vwn_ho_17_0 wn_ho_17_0 0 0.3946922240811921
Vwp_ho_17_1 wp_ho_17_1 0 0.4965793567595733
Vwn_ho_17_1 wn_ho_17_1 0 0.5034206432404267
Vwp_ho_17_2 wp_ho_17_2 0 0.49376546063690047
Vwn_ho_17_2 wn_ho_17_2 0 0.5062345393630996
Vwp_ho_17_3 wp_ho_17_3 0 0.4874219719174174
Vwn_ho_17_3 wn_ho_17_3 0 0.5125780280825827
Vwp_ho_17_4 wp_ho_17_4 0 0.31201087415051454
Vwn_ho_17_4 wn_ho_17_4 0 0.6879891258494855
Vwp_ih_0_18 wp_ih_0_18 0 0.39760809304952555
Vwn_ih_0_18 wn_ih_0_18 0 0.6023919069504744
Vwp_ih_1_18 wp_ih_1_18 0 0.4042015813888373
Vwn_ih_1_18 wn_ih_1_18 0 0.5957984186111627
Vwp_ih_2_18 wp_ih_2_18 0 0.31517111578382107
Vwn_ih_2_18 wn_ih_2_18 0 0.6848288842161789
Vwp_ih_3_18 wp_ih_3_18 0 0.509872483574043
Vwn_ih_3_18 wn_ih_3_18 0 0.490127516425957
Vwp_ih_4_18 wp_ih_4_18 0 0.5463382294592789
Vwn_ih_4_18 wn_ih_4_18 0 0.4536617705407211
Vwp_ih_5_18 wp_ih_5_18 0 0.588699583251974
Vwn_ih_5_18 wn_ih_5_18 0 0.411300416748026
Vwp_ih_6_18 wp_ih_6_18 0 0.3
Vwn_ih_6_18 wn_ih_6_18 0 0.7237766276172897
Vwp_ih_7_18 wp_ih_7_18 0 0.59703078291514
Vwn_ih_7_18 wn_ih_7_18 0 0.40296921708486005
Vwp_ih_8_18 wp_ih_8_18 0 0.4975369726809127
Vwn_ih_8_18 wn_ih_8_18 0 0.5024630273190873
Vwp_ih_9_18 wp_ih_9_18 0 0.3251938895965475
Vwn_ih_9_18 wn_ih_9_18 0 0.6748061104034525
Vwp_ih_10_18 wp_ih_10_18 0 0.5076548911818424
Vwn_ih_10_18 wn_ih_10_18 0 0.49234510881815763
Vwp_ih_11_18 wp_ih_11_18 0 0.597603481066925
Vwn_ih_11_18 wn_ih_11_18 0 0.402396518933075
Vwp_ih_12_18 wp_ih_12_18 0 0.5604801343124631
Vwn_ih_12_18 wn_ih_12_18 0 0.43951986568753687
Vwp_ih_13_18 wp_ih_13_18 0 0.5850161945092374
Vwn_ih_13_18 wn_ih_13_18 0 0.4149838054907626
Vwp_ih_14_18 wp_ih_14_18 0 0.6127241713810165
Vwn_ih_14_18 wn_ih_14_18 0 0.3872758286189835
Vwp_ih_15_18 wp_ih_15_18 0 0.6074760770630745
Vwn_ih_15_18 wn_ih_15_18 0 0.3925239229369255
Vwp_ho_18_0 wp_ho_18_0 0 0.5318923837556165
Vwn_ho_18_0 wn_ho_18_0 0 0.46810761624438346
Vwp_ho_18_1 wp_ho_18_1 0 0.5930024236678418
Vwn_ho_18_1 wn_ho_18_1 0 0.40699757633215816
Vwp_ho_18_2 wp_ho_18_2 0 0.5525232323195267
Vwn_ho_18_2 wn_ho_18_2 0 0.4474767676804733
Vwp_ho_18_3 wp_ho_18_3 0 0.3
Vwn_ho_18_3 wn_ho_18_3 0 0.8471890147674978
Vwp_ho_18_4 wp_ho_18_4 0 0.5223424047977229
Vwn_ho_18_4 wn_ho_18_4 0 0.47765759520227713
Vwp_ih_0_19 wp_ih_0_19 0 0.48971320376788613
Vwn_ih_0_19 wn_ih_0_19 0 0.5102867962321138
Vwp_ih_1_19 wp_ih_1_19 0 0.3
Vwn_ih_1_19 wn_ih_1_19 0 0.7576595808996996
Vwp_ih_2_19 wp_ih_2_19 0 0.4056155837384805
Vwn_ih_2_19 wn_ih_2_19 0 0.5943844162615195
Vwp_ih_3_19 wp_ih_3_19 0 0.5405961970636336
Vwn_ih_3_19 wn_ih_3_19 0 0.4594038029363664
Vwp_ih_4_19 wp_ih_4_19 0 0.4403406334446368
Vwn_ih_4_19 wn_ih_4_19 0 0.5596593665553632
Vwp_ih_5_19 wp_ih_5_19 0 0.582542392132646
Vwn_ih_5_19 wn_ih_5_19 0 0.417457607867354
Vwp_ih_6_19 wp_ih_6_19 0 0.5939286843763625
Vwn_ih_6_19 wn_ih_6_19 0 0.4060713156236375
Vwp_ih_7_19 wp_ih_7_19 0 0.5047463978303397
Vwn_ih_7_19 wn_ih_7_19 0 0.4952536021696603
Vwp_ih_8_19 wp_ih_8_19 0 0.7259002727122467
Vwn_ih_8_19 wn_ih_8_19 0 0.3
Vwp_ih_9_19 wp_ih_9_19 0 0.38160352837288114
Vwn_ih_9_19 wn_ih_9_19 0 0.6183964716271189
Vwp_ih_10_19 wp_ih_10_19 0 0.6138483692019135
Vwn_ih_10_19 wn_ih_10_19 0 0.38615163079808645
Vwp_ih_11_19 wp_ih_11_19 0 0.44043580735056825
Vwn_ih_11_19 wn_ih_11_19 0 0.5595641926494317
Vwp_ih_12_19 wp_ih_12_19 0 0.4024873922689496
Vwn_ih_12_19 wn_ih_12_19 0 0.5975126077310504
Vwp_ih_13_19 wp_ih_13_19 0 0.5630198585309543
Vwn_ih_13_19 wn_ih_13_19 0 0.43698014146904574
Vwp_ih_14_19 wp_ih_14_19 0 0.4226571249132137
Vwn_ih_14_19 wn_ih_14_19 0 0.5773428750867863
Vwp_ih_15_19 wp_ih_15_19 0 0.5994531313742643
Vwn_ih_15_19 wn_ih_15_19 0 0.4005468686257357
Vwp_ho_19_0 wp_ho_19_0 0 0.6309134042078299
Vwn_ho_19_0 wn_ho_19_0 0 0.36908659579217007
Vwp_ho_19_1 wp_ho_19_1 0 0.3
Vwn_ho_19_1 wn_ho_19_1 0 0.8082051795808607
Vwp_ho_19_2 wp_ho_19_2 0 0.4694735098000579
Vwn_ho_19_2 wn_ho_19_2 0 0.5305264901999421
Vwp_ho_19_3 wp_ho_19_3 0 0.5342315327771028
Vwn_ho_19_3 wn_ho_19_3 0 0.4657684672228972
Vwp_ho_19_4 wp_ho_19_4 0 0.6618716604193449
Vwn_ho_19_4 wn_ho_19_4 0 0.33812833958065514
Xcm_mh0 mhp0 mhn0 vdd cmld
Xcm_xh0 xhp0 xhn0 vdd cmld
Rnd_mh0 mhp0 mhn0 20k
Rnd_xh0 xhp0 xhn0 20k
X_ihm_0_0 a_xp0 a_xn0 wp_ih_0_0 wn_ih_0_0 mhp0 mhn0 vdd vbsyn gsyn
X_ihx_0_0 a_xp0 a_xn0 wp_ih_0_0 wn_ih_0_0 xhp0 xhn0 vdd vbsyn gsyn
X_ihm_1_0 a_xp1 a_xn1 wp_ih_1_0 wn_ih_1_0 mhp0 mhn0 vdd vbsyn gsyn
X_ihx_1_0 a_xp1 a_xn1 wp_ih_1_0 wn_ih_1_0 xhp0 xhn0 vdd vbsyn gsyn
X_ihm_2_0 a_xp2 a_xn2 wp_ih_2_0 wn_ih_2_0 mhp0 mhn0 vdd vbsyn gsyn
X_ihx_2_0 a_xp2 a_xn2 wp_ih_2_0 wn_ih_2_0 xhp0 xhn0 vdd vbsyn gsyn
X_ihm_3_0 a_xp3 a_xn3 wp_ih_3_0 wn_ih_3_0 mhp0 mhn0 vdd vbsyn gsyn
X_ihx_3_0 a_xp3 a_xn3 wp_ih_3_0 wn_ih_3_0 xhp0 xhn0 vdd vbsyn gsyn
X_ihm_4_0 a_xp4 a_xn4 wp_ih_4_0 wn_ih_4_0 mhp0 mhn0 vdd vbsyn gsyn
X_ihx_4_0 a_xp4 a_xn4 wp_ih_4_0 wn_ih_4_0 xhp0 xhn0 vdd vbsyn gsyn
X_ihm_5_0 a_xp5 a_xn5 wp_ih_5_0 wn_ih_5_0 mhp0 mhn0 vdd vbsyn gsyn
X_ihx_5_0 a_xp5 a_xn5 wp_ih_5_0 wn_ih_5_0 xhp0 xhn0 vdd vbsyn gsyn
X_ihm_6_0 a_xp6 a_xn6 wp_ih_6_0 wn_ih_6_0 mhp0 mhn0 vdd vbsyn gsyn
X_ihx_6_0 a_xp6 a_xn6 wp_ih_6_0 wn_ih_6_0 xhp0 xhn0 vdd vbsyn gsyn
X_ihm_7_0 a_xp7 a_xn7 wp_ih_7_0 wn_ih_7_0 mhp0 mhn0 vdd vbsyn gsyn
X_ihx_7_0 a_xp7 a_xn7 wp_ih_7_0 wn_ih_7_0 xhp0 xhn0 vdd vbsyn gsyn
X_ihm_8_0 a_xp8 a_xn8 wp_ih_8_0 wn_ih_8_0 mhp0 mhn0 vdd vbsyn gsyn
X_ihx_8_0 a_xp8 a_xn8 wp_ih_8_0 wn_ih_8_0 xhp0 xhn0 vdd vbsyn gsyn
X_ihm_9_0 a_xp9 a_xn9 wp_ih_9_0 wn_ih_9_0 mhp0 mhn0 vdd vbsyn gsyn
X_ihx_9_0 a_xp9 a_xn9 wp_ih_9_0 wn_ih_9_0 xhp0 xhn0 vdd vbsyn gsyn
X_ihm_10_0 a_xp10 a_xn10 wp_ih_10_0 wn_ih_10_0 mhp0 mhn0 vdd vbsyn gsyn
X_ihx_10_0 a_xp10 a_xn10 wp_ih_10_0 wn_ih_10_0 xhp0 xhn0 vdd vbsyn gsyn
X_ihm_11_0 a_xp11 a_xn11 wp_ih_11_0 wn_ih_11_0 mhp0 mhn0 vdd vbsyn gsyn
X_ihx_11_0 a_xp11 a_xn11 wp_ih_11_0 wn_ih_11_0 xhp0 xhn0 vdd vbsyn gsyn
X_ihm_12_0 a_xp12 a_xn12 wp_ih_12_0 wn_ih_12_0 mhp0 mhn0 vdd vbsyn gsyn
X_ihx_12_0 a_xp12 a_xn12 wp_ih_12_0 wn_ih_12_0 xhp0 xhn0 vdd vbsyn gsyn
X_ihm_13_0 a_xp13 a_xn13 wp_ih_13_0 wn_ih_13_0 mhp0 mhn0 vdd vbsyn gsyn
X_ihx_13_0 a_xp13 a_xn13 wp_ih_13_0 wn_ih_13_0 xhp0 xhn0 vdd vbsyn gsyn
X_ihm_14_0 a_xp14 a_xn14 wp_ih_14_0 wn_ih_14_0 mhp0 mhn0 vdd vbsyn gsyn
X_ihx_14_0 a_xp14 a_xn14 wp_ih_14_0 wn_ih_14_0 xhp0 xhn0 vdd vbsyn gsyn
X_ihm_15_0 a_xp15 a_xn15 wp_ih_15_0 wn_ih_15_0 mhp0 mhn0 vdd vbsyn gsyn
X_ihx_15_0 a_xp15 a_xn15 wp_ih_15_0 wn_ih_15_0 xhp0 xhn0 vdd vbsyn gsyn
Xn0 xhp0 xhn0 ahp0 ahn0 vdd vbneu dneuron
Xeh0 xhp0 xhn0 mhp0 mhn0 ehp0 ehn0 vdd gm esub
Xcm_mh1 mhp1 mhn1 vdd cmld
Xcm_xh1 xhp1 xhn1 vdd cmld
Rnd_mh1 mhp1 mhn1 20k
Rnd_xh1 xhp1 xhn1 20k
X_ihm_0_1 a_xp0 a_xn0 wp_ih_0_1 wn_ih_0_1 mhp1 mhn1 vdd vbsyn gsyn
X_ihx_0_1 a_xp0 a_xn0 wp_ih_0_1 wn_ih_0_1 xhp1 xhn1 vdd vbsyn gsyn
X_ihm_1_1 a_xp1 a_xn1 wp_ih_1_1 wn_ih_1_1 mhp1 mhn1 vdd vbsyn gsyn
X_ihx_1_1 a_xp1 a_xn1 wp_ih_1_1 wn_ih_1_1 xhp1 xhn1 vdd vbsyn gsyn
X_ihm_2_1 a_xp2 a_xn2 wp_ih_2_1 wn_ih_2_1 mhp1 mhn1 vdd vbsyn gsyn
X_ihx_2_1 a_xp2 a_xn2 wp_ih_2_1 wn_ih_2_1 xhp1 xhn1 vdd vbsyn gsyn
X_ihm_3_1 a_xp3 a_xn3 wp_ih_3_1 wn_ih_3_1 mhp1 mhn1 vdd vbsyn gsyn
X_ihx_3_1 a_xp3 a_xn3 wp_ih_3_1 wn_ih_3_1 xhp1 xhn1 vdd vbsyn gsyn
X_ihm_4_1 a_xp4 a_xn4 wp_ih_4_1 wn_ih_4_1 mhp1 mhn1 vdd vbsyn gsyn
X_ihx_4_1 a_xp4 a_xn4 wp_ih_4_1 wn_ih_4_1 xhp1 xhn1 vdd vbsyn gsyn
X_ihm_5_1 a_xp5 a_xn5 wp_ih_5_1 wn_ih_5_1 mhp1 mhn1 vdd vbsyn gsyn
X_ihx_5_1 a_xp5 a_xn5 wp_ih_5_1 wn_ih_5_1 xhp1 xhn1 vdd vbsyn gsyn
X_ihm_6_1 a_xp6 a_xn6 wp_ih_6_1 wn_ih_6_1 mhp1 mhn1 vdd vbsyn gsyn
X_ihx_6_1 a_xp6 a_xn6 wp_ih_6_1 wn_ih_6_1 xhp1 xhn1 vdd vbsyn gsyn
X_ihm_7_1 a_xp7 a_xn7 wp_ih_7_1 wn_ih_7_1 mhp1 mhn1 vdd vbsyn gsyn
X_ihx_7_1 a_xp7 a_xn7 wp_ih_7_1 wn_ih_7_1 xhp1 xhn1 vdd vbsyn gsyn
X_ihm_8_1 a_xp8 a_xn8 wp_ih_8_1 wn_ih_8_1 mhp1 mhn1 vdd vbsyn gsyn
X_ihx_8_1 a_xp8 a_xn8 wp_ih_8_1 wn_ih_8_1 xhp1 xhn1 vdd vbsyn gsyn
X_ihm_9_1 a_xp9 a_xn9 wp_ih_9_1 wn_ih_9_1 mhp1 mhn1 vdd vbsyn gsyn
X_ihx_9_1 a_xp9 a_xn9 wp_ih_9_1 wn_ih_9_1 xhp1 xhn1 vdd vbsyn gsyn
X_ihm_10_1 a_xp10 a_xn10 wp_ih_10_1 wn_ih_10_1 mhp1 mhn1 vdd vbsyn gsyn
X_ihx_10_1 a_xp10 a_xn10 wp_ih_10_1 wn_ih_10_1 xhp1 xhn1 vdd vbsyn gsyn
X_ihm_11_1 a_xp11 a_xn11 wp_ih_11_1 wn_ih_11_1 mhp1 mhn1 vdd vbsyn gsyn
X_ihx_11_1 a_xp11 a_xn11 wp_ih_11_1 wn_ih_11_1 xhp1 xhn1 vdd vbsyn gsyn
X_ihm_12_1 a_xp12 a_xn12 wp_ih_12_1 wn_ih_12_1 mhp1 mhn1 vdd vbsyn gsyn
X_ihx_12_1 a_xp12 a_xn12 wp_ih_12_1 wn_ih_12_1 xhp1 xhn1 vdd vbsyn gsyn
X_ihm_13_1 a_xp13 a_xn13 wp_ih_13_1 wn_ih_13_1 mhp1 mhn1 vdd vbsyn gsyn
X_ihx_13_1 a_xp13 a_xn13 wp_ih_13_1 wn_ih_13_1 xhp1 xhn1 vdd vbsyn gsyn
X_ihm_14_1 a_xp14 a_xn14 wp_ih_14_1 wn_ih_14_1 mhp1 mhn1 vdd vbsyn gsyn
X_ihx_14_1 a_xp14 a_xn14 wp_ih_14_1 wn_ih_14_1 xhp1 xhn1 vdd vbsyn gsyn
X_ihm_15_1 a_xp15 a_xn15 wp_ih_15_1 wn_ih_15_1 mhp1 mhn1 vdd vbsyn gsyn
X_ihx_15_1 a_xp15 a_xn15 wp_ih_15_1 wn_ih_15_1 xhp1 xhn1 vdd vbsyn gsyn
Xn1 xhp1 xhn1 ahp1 ahn1 vdd vbneu dneuron
Xeh1 xhp1 xhn1 mhp1 mhn1 ehp1 ehn1 vdd gm esub
Xcm_mh2 mhp2 mhn2 vdd cmld
Xcm_xh2 xhp2 xhn2 vdd cmld
Rnd_mh2 mhp2 mhn2 20k
Rnd_xh2 xhp2 xhn2 20k
X_ihm_0_2 a_xp0 a_xn0 wp_ih_0_2 wn_ih_0_2 mhp2 mhn2 vdd vbsyn gsyn
X_ihx_0_2 a_xp0 a_xn0 wp_ih_0_2 wn_ih_0_2 xhp2 xhn2 vdd vbsyn gsyn
X_ihm_1_2 a_xp1 a_xn1 wp_ih_1_2 wn_ih_1_2 mhp2 mhn2 vdd vbsyn gsyn
X_ihx_1_2 a_xp1 a_xn1 wp_ih_1_2 wn_ih_1_2 xhp2 xhn2 vdd vbsyn gsyn
X_ihm_2_2 a_xp2 a_xn2 wp_ih_2_2 wn_ih_2_2 mhp2 mhn2 vdd vbsyn gsyn
X_ihx_2_2 a_xp2 a_xn2 wp_ih_2_2 wn_ih_2_2 xhp2 xhn2 vdd vbsyn gsyn
X_ihm_3_2 a_xp3 a_xn3 wp_ih_3_2 wn_ih_3_2 mhp2 mhn2 vdd vbsyn gsyn
X_ihx_3_2 a_xp3 a_xn3 wp_ih_3_2 wn_ih_3_2 xhp2 xhn2 vdd vbsyn gsyn
X_ihm_4_2 a_xp4 a_xn4 wp_ih_4_2 wn_ih_4_2 mhp2 mhn2 vdd vbsyn gsyn
X_ihx_4_2 a_xp4 a_xn4 wp_ih_4_2 wn_ih_4_2 xhp2 xhn2 vdd vbsyn gsyn
X_ihm_5_2 a_xp5 a_xn5 wp_ih_5_2 wn_ih_5_2 mhp2 mhn2 vdd vbsyn gsyn
X_ihx_5_2 a_xp5 a_xn5 wp_ih_5_2 wn_ih_5_2 xhp2 xhn2 vdd vbsyn gsyn
X_ihm_6_2 a_xp6 a_xn6 wp_ih_6_2 wn_ih_6_2 mhp2 mhn2 vdd vbsyn gsyn
X_ihx_6_2 a_xp6 a_xn6 wp_ih_6_2 wn_ih_6_2 xhp2 xhn2 vdd vbsyn gsyn
X_ihm_7_2 a_xp7 a_xn7 wp_ih_7_2 wn_ih_7_2 mhp2 mhn2 vdd vbsyn gsyn
X_ihx_7_2 a_xp7 a_xn7 wp_ih_7_2 wn_ih_7_2 xhp2 xhn2 vdd vbsyn gsyn
X_ihm_8_2 a_xp8 a_xn8 wp_ih_8_2 wn_ih_8_2 mhp2 mhn2 vdd vbsyn gsyn
X_ihx_8_2 a_xp8 a_xn8 wp_ih_8_2 wn_ih_8_2 xhp2 xhn2 vdd vbsyn gsyn
X_ihm_9_2 a_xp9 a_xn9 wp_ih_9_2 wn_ih_9_2 mhp2 mhn2 vdd vbsyn gsyn
X_ihx_9_2 a_xp9 a_xn9 wp_ih_9_2 wn_ih_9_2 xhp2 xhn2 vdd vbsyn gsyn
X_ihm_10_2 a_xp10 a_xn10 wp_ih_10_2 wn_ih_10_2 mhp2 mhn2 vdd vbsyn gsyn
X_ihx_10_2 a_xp10 a_xn10 wp_ih_10_2 wn_ih_10_2 xhp2 xhn2 vdd vbsyn gsyn
X_ihm_11_2 a_xp11 a_xn11 wp_ih_11_2 wn_ih_11_2 mhp2 mhn2 vdd vbsyn gsyn
X_ihx_11_2 a_xp11 a_xn11 wp_ih_11_2 wn_ih_11_2 xhp2 xhn2 vdd vbsyn gsyn
X_ihm_12_2 a_xp12 a_xn12 wp_ih_12_2 wn_ih_12_2 mhp2 mhn2 vdd vbsyn gsyn
X_ihx_12_2 a_xp12 a_xn12 wp_ih_12_2 wn_ih_12_2 xhp2 xhn2 vdd vbsyn gsyn
X_ihm_13_2 a_xp13 a_xn13 wp_ih_13_2 wn_ih_13_2 mhp2 mhn2 vdd vbsyn gsyn
X_ihx_13_2 a_xp13 a_xn13 wp_ih_13_2 wn_ih_13_2 xhp2 xhn2 vdd vbsyn gsyn
X_ihm_14_2 a_xp14 a_xn14 wp_ih_14_2 wn_ih_14_2 mhp2 mhn2 vdd vbsyn gsyn
X_ihx_14_2 a_xp14 a_xn14 wp_ih_14_2 wn_ih_14_2 xhp2 xhn2 vdd vbsyn gsyn
X_ihm_15_2 a_xp15 a_xn15 wp_ih_15_2 wn_ih_15_2 mhp2 mhn2 vdd vbsyn gsyn
X_ihx_15_2 a_xp15 a_xn15 wp_ih_15_2 wn_ih_15_2 xhp2 xhn2 vdd vbsyn gsyn
Xn2 xhp2 xhn2 ahp2 ahn2 vdd vbneu dneuron
Xeh2 xhp2 xhn2 mhp2 mhn2 ehp2 ehn2 vdd gm esub
Xcm_mh3 mhp3 mhn3 vdd cmld
Xcm_xh3 xhp3 xhn3 vdd cmld
Rnd_mh3 mhp3 mhn3 20k
Rnd_xh3 xhp3 xhn3 20k
X_ihm_0_3 a_xp0 a_xn0 wp_ih_0_3 wn_ih_0_3 mhp3 mhn3 vdd vbsyn gsyn
X_ihx_0_3 a_xp0 a_xn0 wp_ih_0_3 wn_ih_0_3 xhp3 xhn3 vdd vbsyn gsyn
X_ihm_1_3 a_xp1 a_xn1 wp_ih_1_3 wn_ih_1_3 mhp3 mhn3 vdd vbsyn gsyn
X_ihx_1_3 a_xp1 a_xn1 wp_ih_1_3 wn_ih_1_3 xhp3 xhn3 vdd vbsyn gsyn
X_ihm_2_3 a_xp2 a_xn2 wp_ih_2_3 wn_ih_2_3 mhp3 mhn3 vdd vbsyn gsyn
X_ihx_2_3 a_xp2 a_xn2 wp_ih_2_3 wn_ih_2_3 xhp3 xhn3 vdd vbsyn gsyn
X_ihm_3_3 a_xp3 a_xn3 wp_ih_3_3 wn_ih_3_3 mhp3 mhn3 vdd vbsyn gsyn
X_ihx_3_3 a_xp3 a_xn3 wp_ih_3_3 wn_ih_3_3 xhp3 xhn3 vdd vbsyn gsyn
X_ihm_4_3 a_xp4 a_xn4 wp_ih_4_3 wn_ih_4_3 mhp3 mhn3 vdd vbsyn gsyn
X_ihx_4_3 a_xp4 a_xn4 wp_ih_4_3 wn_ih_4_3 xhp3 xhn3 vdd vbsyn gsyn
X_ihm_5_3 a_xp5 a_xn5 wp_ih_5_3 wn_ih_5_3 mhp3 mhn3 vdd vbsyn gsyn
X_ihx_5_3 a_xp5 a_xn5 wp_ih_5_3 wn_ih_5_3 xhp3 xhn3 vdd vbsyn gsyn
X_ihm_6_3 a_xp6 a_xn6 wp_ih_6_3 wn_ih_6_3 mhp3 mhn3 vdd vbsyn gsyn
X_ihx_6_3 a_xp6 a_xn6 wp_ih_6_3 wn_ih_6_3 xhp3 xhn3 vdd vbsyn gsyn
X_ihm_7_3 a_xp7 a_xn7 wp_ih_7_3 wn_ih_7_3 mhp3 mhn3 vdd vbsyn gsyn
X_ihx_7_3 a_xp7 a_xn7 wp_ih_7_3 wn_ih_7_3 xhp3 xhn3 vdd vbsyn gsyn
X_ihm_8_3 a_xp8 a_xn8 wp_ih_8_3 wn_ih_8_3 mhp3 mhn3 vdd vbsyn gsyn
X_ihx_8_3 a_xp8 a_xn8 wp_ih_8_3 wn_ih_8_3 xhp3 xhn3 vdd vbsyn gsyn
X_ihm_9_3 a_xp9 a_xn9 wp_ih_9_3 wn_ih_9_3 mhp3 mhn3 vdd vbsyn gsyn
X_ihx_9_3 a_xp9 a_xn9 wp_ih_9_3 wn_ih_9_3 xhp3 xhn3 vdd vbsyn gsyn
X_ihm_10_3 a_xp10 a_xn10 wp_ih_10_3 wn_ih_10_3 mhp3 mhn3 vdd vbsyn gsyn
X_ihx_10_3 a_xp10 a_xn10 wp_ih_10_3 wn_ih_10_3 xhp3 xhn3 vdd vbsyn gsyn
X_ihm_11_3 a_xp11 a_xn11 wp_ih_11_3 wn_ih_11_3 mhp3 mhn3 vdd vbsyn gsyn
X_ihx_11_3 a_xp11 a_xn11 wp_ih_11_3 wn_ih_11_3 xhp3 xhn3 vdd vbsyn gsyn
X_ihm_12_3 a_xp12 a_xn12 wp_ih_12_3 wn_ih_12_3 mhp3 mhn3 vdd vbsyn gsyn
X_ihx_12_3 a_xp12 a_xn12 wp_ih_12_3 wn_ih_12_3 xhp3 xhn3 vdd vbsyn gsyn
X_ihm_13_3 a_xp13 a_xn13 wp_ih_13_3 wn_ih_13_3 mhp3 mhn3 vdd vbsyn gsyn
X_ihx_13_3 a_xp13 a_xn13 wp_ih_13_3 wn_ih_13_3 xhp3 xhn3 vdd vbsyn gsyn
X_ihm_14_3 a_xp14 a_xn14 wp_ih_14_3 wn_ih_14_3 mhp3 mhn3 vdd vbsyn gsyn
X_ihx_14_3 a_xp14 a_xn14 wp_ih_14_3 wn_ih_14_3 xhp3 xhn3 vdd vbsyn gsyn
X_ihm_15_3 a_xp15 a_xn15 wp_ih_15_3 wn_ih_15_3 mhp3 mhn3 vdd vbsyn gsyn
X_ihx_15_3 a_xp15 a_xn15 wp_ih_15_3 wn_ih_15_3 xhp3 xhn3 vdd vbsyn gsyn
Xn3 xhp3 xhn3 ahp3 ahn3 vdd vbneu dneuron
Xeh3 xhp3 xhn3 mhp3 mhn3 ehp3 ehn3 vdd gm esub
Xcm_mh4 mhp4 mhn4 vdd cmld
Xcm_xh4 xhp4 xhn4 vdd cmld
Rnd_mh4 mhp4 mhn4 20k
Rnd_xh4 xhp4 xhn4 20k
X_ihm_0_4 a_xp0 a_xn0 wp_ih_0_4 wn_ih_0_4 mhp4 mhn4 vdd vbsyn gsyn
X_ihx_0_4 a_xp0 a_xn0 wp_ih_0_4 wn_ih_0_4 xhp4 xhn4 vdd vbsyn gsyn
X_ihm_1_4 a_xp1 a_xn1 wp_ih_1_4 wn_ih_1_4 mhp4 mhn4 vdd vbsyn gsyn
X_ihx_1_4 a_xp1 a_xn1 wp_ih_1_4 wn_ih_1_4 xhp4 xhn4 vdd vbsyn gsyn
X_ihm_2_4 a_xp2 a_xn2 wp_ih_2_4 wn_ih_2_4 mhp4 mhn4 vdd vbsyn gsyn
X_ihx_2_4 a_xp2 a_xn2 wp_ih_2_4 wn_ih_2_4 xhp4 xhn4 vdd vbsyn gsyn
X_ihm_3_4 a_xp3 a_xn3 wp_ih_3_4 wn_ih_3_4 mhp4 mhn4 vdd vbsyn gsyn
X_ihx_3_4 a_xp3 a_xn3 wp_ih_3_4 wn_ih_3_4 xhp4 xhn4 vdd vbsyn gsyn
X_ihm_4_4 a_xp4 a_xn4 wp_ih_4_4 wn_ih_4_4 mhp4 mhn4 vdd vbsyn gsyn
X_ihx_4_4 a_xp4 a_xn4 wp_ih_4_4 wn_ih_4_4 xhp4 xhn4 vdd vbsyn gsyn
X_ihm_5_4 a_xp5 a_xn5 wp_ih_5_4 wn_ih_5_4 mhp4 mhn4 vdd vbsyn gsyn
X_ihx_5_4 a_xp5 a_xn5 wp_ih_5_4 wn_ih_5_4 xhp4 xhn4 vdd vbsyn gsyn
X_ihm_6_4 a_xp6 a_xn6 wp_ih_6_4 wn_ih_6_4 mhp4 mhn4 vdd vbsyn gsyn
X_ihx_6_4 a_xp6 a_xn6 wp_ih_6_4 wn_ih_6_4 xhp4 xhn4 vdd vbsyn gsyn
X_ihm_7_4 a_xp7 a_xn7 wp_ih_7_4 wn_ih_7_4 mhp4 mhn4 vdd vbsyn gsyn
X_ihx_7_4 a_xp7 a_xn7 wp_ih_7_4 wn_ih_7_4 xhp4 xhn4 vdd vbsyn gsyn
X_ihm_8_4 a_xp8 a_xn8 wp_ih_8_4 wn_ih_8_4 mhp4 mhn4 vdd vbsyn gsyn
X_ihx_8_4 a_xp8 a_xn8 wp_ih_8_4 wn_ih_8_4 xhp4 xhn4 vdd vbsyn gsyn
X_ihm_9_4 a_xp9 a_xn9 wp_ih_9_4 wn_ih_9_4 mhp4 mhn4 vdd vbsyn gsyn
X_ihx_9_4 a_xp9 a_xn9 wp_ih_9_4 wn_ih_9_4 xhp4 xhn4 vdd vbsyn gsyn
X_ihm_10_4 a_xp10 a_xn10 wp_ih_10_4 wn_ih_10_4 mhp4 mhn4 vdd vbsyn gsyn
X_ihx_10_4 a_xp10 a_xn10 wp_ih_10_4 wn_ih_10_4 xhp4 xhn4 vdd vbsyn gsyn
X_ihm_11_4 a_xp11 a_xn11 wp_ih_11_4 wn_ih_11_4 mhp4 mhn4 vdd vbsyn gsyn
X_ihx_11_4 a_xp11 a_xn11 wp_ih_11_4 wn_ih_11_4 xhp4 xhn4 vdd vbsyn gsyn
X_ihm_12_4 a_xp12 a_xn12 wp_ih_12_4 wn_ih_12_4 mhp4 mhn4 vdd vbsyn gsyn
X_ihx_12_4 a_xp12 a_xn12 wp_ih_12_4 wn_ih_12_4 xhp4 xhn4 vdd vbsyn gsyn
X_ihm_13_4 a_xp13 a_xn13 wp_ih_13_4 wn_ih_13_4 mhp4 mhn4 vdd vbsyn gsyn
X_ihx_13_4 a_xp13 a_xn13 wp_ih_13_4 wn_ih_13_4 xhp4 xhn4 vdd vbsyn gsyn
X_ihm_14_4 a_xp14 a_xn14 wp_ih_14_4 wn_ih_14_4 mhp4 mhn4 vdd vbsyn gsyn
X_ihx_14_4 a_xp14 a_xn14 wp_ih_14_4 wn_ih_14_4 xhp4 xhn4 vdd vbsyn gsyn
X_ihm_15_4 a_xp15 a_xn15 wp_ih_15_4 wn_ih_15_4 mhp4 mhn4 vdd vbsyn gsyn
X_ihx_15_4 a_xp15 a_xn15 wp_ih_15_4 wn_ih_15_4 xhp4 xhn4 vdd vbsyn gsyn
Xn4 xhp4 xhn4 ahp4 ahn4 vdd vbneu dneuron
Xeh4 xhp4 xhn4 mhp4 mhn4 ehp4 ehn4 vdd gm esub
Xcm_mh5 mhp5 mhn5 vdd cmld
Xcm_xh5 xhp5 xhn5 vdd cmld
Rnd_mh5 mhp5 mhn5 20k
Rnd_xh5 xhp5 xhn5 20k
X_ihm_0_5 a_xp0 a_xn0 wp_ih_0_5 wn_ih_0_5 mhp5 mhn5 vdd vbsyn gsyn
X_ihx_0_5 a_xp0 a_xn0 wp_ih_0_5 wn_ih_0_5 xhp5 xhn5 vdd vbsyn gsyn
X_ihm_1_5 a_xp1 a_xn1 wp_ih_1_5 wn_ih_1_5 mhp5 mhn5 vdd vbsyn gsyn
X_ihx_1_5 a_xp1 a_xn1 wp_ih_1_5 wn_ih_1_5 xhp5 xhn5 vdd vbsyn gsyn
X_ihm_2_5 a_xp2 a_xn2 wp_ih_2_5 wn_ih_2_5 mhp5 mhn5 vdd vbsyn gsyn
X_ihx_2_5 a_xp2 a_xn2 wp_ih_2_5 wn_ih_2_5 xhp5 xhn5 vdd vbsyn gsyn
X_ihm_3_5 a_xp3 a_xn3 wp_ih_3_5 wn_ih_3_5 mhp5 mhn5 vdd vbsyn gsyn
X_ihx_3_5 a_xp3 a_xn3 wp_ih_3_5 wn_ih_3_5 xhp5 xhn5 vdd vbsyn gsyn
X_ihm_4_5 a_xp4 a_xn4 wp_ih_4_5 wn_ih_4_5 mhp5 mhn5 vdd vbsyn gsyn
X_ihx_4_5 a_xp4 a_xn4 wp_ih_4_5 wn_ih_4_5 xhp5 xhn5 vdd vbsyn gsyn
X_ihm_5_5 a_xp5 a_xn5 wp_ih_5_5 wn_ih_5_5 mhp5 mhn5 vdd vbsyn gsyn
X_ihx_5_5 a_xp5 a_xn5 wp_ih_5_5 wn_ih_5_5 xhp5 xhn5 vdd vbsyn gsyn
X_ihm_6_5 a_xp6 a_xn6 wp_ih_6_5 wn_ih_6_5 mhp5 mhn5 vdd vbsyn gsyn
X_ihx_6_5 a_xp6 a_xn6 wp_ih_6_5 wn_ih_6_5 xhp5 xhn5 vdd vbsyn gsyn
X_ihm_7_5 a_xp7 a_xn7 wp_ih_7_5 wn_ih_7_5 mhp5 mhn5 vdd vbsyn gsyn
X_ihx_7_5 a_xp7 a_xn7 wp_ih_7_5 wn_ih_7_5 xhp5 xhn5 vdd vbsyn gsyn
X_ihm_8_5 a_xp8 a_xn8 wp_ih_8_5 wn_ih_8_5 mhp5 mhn5 vdd vbsyn gsyn
X_ihx_8_5 a_xp8 a_xn8 wp_ih_8_5 wn_ih_8_5 xhp5 xhn5 vdd vbsyn gsyn
X_ihm_9_5 a_xp9 a_xn9 wp_ih_9_5 wn_ih_9_5 mhp5 mhn5 vdd vbsyn gsyn
X_ihx_9_5 a_xp9 a_xn9 wp_ih_9_5 wn_ih_9_5 xhp5 xhn5 vdd vbsyn gsyn
X_ihm_10_5 a_xp10 a_xn10 wp_ih_10_5 wn_ih_10_5 mhp5 mhn5 vdd vbsyn gsyn
X_ihx_10_5 a_xp10 a_xn10 wp_ih_10_5 wn_ih_10_5 xhp5 xhn5 vdd vbsyn gsyn
X_ihm_11_5 a_xp11 a_xn11 wp_ih_11_5 wn_ih_11_5 mhp5 mhn5 vdd vbsyn gsyn
X_ihx_11_5 a_xp11 a_xn11 wp_ih_11_5 wn_ih_11_5 xhp5 xhn5 vdd vbsyn gsyn
X_ihm_12_5 a_xp12 a_xn12 wp_ih_12_5 wn_ih_12_5 mhp5 mhn5 vdd vbsyn gsyn
X_ihx_12_5 a_xp12 a_xn12 wp_ih_12_5 wn_ih_12_5 xhp5 xhn5 vdd vbsyn gsyn
X_ihm_13_5 a_xp13 a_xn13 wp_ih_13_5 wn_ih_13_5 mhp5 mhn5 vdd vbsyn gsyn
X_ihx_13_5 a_xp13 a_xn13 wp_ih_13_5 wn_ih_13_5 xhp5 xhn5 vdd vbsyn gsyn
X_ihm_14_5 a_xp14 a_xn14 wp_ih_14_5 wn_ih_14_5 mhp5 mhn5 vdd vbsyn gsyn
X_ihx_14_5 a_xp14 a_xn14 wp_ih_14_5 wn_ih_14_5 xhp5 xhn5 vdd vbsyn gsyn
X_ihm_15_5 a_xp15 a_xn15 wp_ih_15_5 wn_ih_15_5 mhp5 mhn5 vdd vbsyn gsyn
X_ihx_15_5 a_xp15 a_xn15 wp_ih_15_5 wn_ih_15_5 xhp5 xhn5 vdd vbsyn gsyn
Xn5 xhp5 xhn5 ahp5 ahn5 vdd vbneu dneuron
Xeh5 xhp5 xhn5 mhp5 mhn5 ehp5 ehn5 vdd gm esub
Xcm_mh6 mhp6 mhn6 vdd cmld
Xcm_xh6 xhp6 xhn6 vdd cmld
Rnd_mh6 mhp6 mhn6 20k
Rnd_xh6 xhp6 xhn6 20k
X_ihm_0_6 a_xp0 a_xn0 wp_ih_0_6 wn_ih_0_6 mhp6 mhn6 vdd vbsyn gsyn
X_ihx_0_6 a_xp0 a_xn0 wp_ih_0_6 wn_ih_0_6 xhp6 xhn6 vdd vbsyn gsyn
X_ihm_1_6 a_xp1 a_xn1 wp_ih_1_6 wn_ih_1_6 mhp6 mhn6 vdd vbsyn gsyn
X_ihx_1_6 a_xp1 a_xn1 wp_ih_1_6 wn_ih_1_6 xhp6 xhn6 vdd vbsyn gsyn
X_ihm_2_6 a_xp2 a_xn2 wp_ih_2_6 wn_ih_2_6 mhp6 mhn6 vdd vbsyn gsyn
X_ihx_2_6 a_xp2 a_xn2 wp_ih_2_6 wn_ih_2_6 xhp6 xhn6 vdd vbsyn gsyn
X_ihm_3_6 a_xp3 a_xn3 wp_ih_3_6 wn_ih_3_6 mhp6 mhn6 vdd vbsyn gsyn
X_ihx_3_6 a_xp3 a_xn3 wp_ih_3_6 wn_ih_3_6 xhp6 xhn6 vdd vbsyn gsyn
X_ihm_4_6 a_xp4 a_xn4 wp_ih_4_6 wn_ih_4_6 mhp6 mhn6 vdd vbsyn gsyn
X_ihx_4_6 a_xp4 a_xn4 wp_ih_4_6 wn_ih_4_6 xhp6 xhn6 vdd vbsyn gsyn
X_ihm_5_6 a_xp5 a_xn5 wp_ih_5_6 wn_ih_5_6 mhp6 mhn6 vdd vbsyn gsyn
X_ihx_5_6 a_xp5 a_xn5 wp_ih_5_6 wn_ih_5_6 xhp6 xhn6 vdd vbsyn gsyn
X_ihm_6_6 a_xp6 a_xn6 wp_ih_6_6 wn_ih_6_6 mhp6 mhn6 vdd vbsyn gsyn
X_ihx_6_6 a_xp6 a_xn6 wp_ih_6_6 wn_ih_6_6 xhp6 xhn6 vdd vbsyn gsyn
X_ihm_7_6 a_xp7 a_xn7 wp_ih_7_6 wn_ih_7_6 mhp6 mhn6 vdd vbsyn gsyn
X_ihx_7_6 a_xp7 a_xn7 wp_ih_7_6 wn_ih_7_6 xhp6 xhn6 vdd vbsyn gsyn
X_ihm_8_6 a_xp8 a_xn8 wp_ih_8_6 wn_ih_8_6 mhp6 mhn6 vdd vbsyn gsyn
X_ihx_8_6 a_xp8 a_xn8 wp_ih_8_6 wn_ih_8_6 xhp6 xhn6 vdd vbsyn gsyn
X_ihm_9_6 a_xp9 a_xn9 wp_ih_9_6 wn_ih_9_6 mhp6 mhn6 vdd vbsyn gsyn
X_ihx_9_6 a_xp9 a_xn9 wp_ih_9_6 wn_ih_9_6 xhp6 xhn6 vdd vbsyn gsyn
X_ihm_10_6 a_xp10 a_xn10 wp_ih_10_6 wn_ih_10_6 mhp6 mhn6 vdd vbsyn gsyn
X_ihx_10_6 a_xp10 a_xn10 wp_ih_10_6 wn_ih_10_6 xhp6 xhn6 vdd vbsyn gsyn
X_ihm_11_6 a_xp11 a_xn11 wp_ih_11_6 wn_ih_11_6 mhp6 mhn6 vdd vbsyn gsyn
X_ihx_11_6 a_xp11 a_xn11 wp_ih_11_6 wn_ih_11_6 xhp6 xhn6 vdd vbsyn gsyn
X_ihm_12_6 a_xp12 a_xn12 wp_ih_12_6 wn_ih_12_6 mhp6 mhn6 vdd vbsyn gsyn
X_ihx_12_6 a_xp12 a_xn12 wp_ih_12_6 wn_ih_12_6 xhp6 xhn6 vdd vbsyn gsyn
X_ihm_13_6 a_xp13 a_xn13 wp_ih_13_6 wn_ih_13_6 mhp6 mhn6 vdd vbsyn gsyn
X_ihx_13_6 a_xp13 a_xn13 wp_ih_13_6 wn_ih_13_6 xhp6 xhn6 vdd vbsyn gsyn
X_ihm_14_6 a_xp14 a_xn14 wp_ih_14_6 wn_ih_14_6 mhp6 mhn6 vdd vbsyn gsyn
X_ihx_14_6 a_xp14 a_xn14 wp_ih_14_6 wn_ih_14_6 xhp6 xhn6 vdd vbsyn gsyn
X_ihm_15_6 a_xp15 a_xn15 wp_ih_15_6 wn_ih_15_6 mhp6 mhn6 vdd vbsyn gsyn
X_ihx_15_6 a_xp15 a_xn15 wp_ih_15_6 wn_ih_15_6 xhp6 xhn6 vdd vbsyn gsyn
Xn6 xhp6 xhn6 ahp6 ahn6 vdd vbneu dneuron
Xeh6 xhp6 xhn6 mhp6 mhn6 ehp6 ehn6 vdd gm esub
Xcm_mh7 mhp7 mhn7 vdd cmld
Xcm_xh7 xhp7 xhn7 vdd cmld
Rnd_mh7 mhp7 mhn7 20k
Rnd_xh7 xhp7 xhn7 20k
X_ihm_0_7 a_xp0 a_xn0 wp_ih_0_7 wn_ih_0_7 mhp7 mhn7 vdd vbsyn gsyn
X_ihx_0_7 a_xp0 a_xn0 wp_ih_0_7 wn_ih_0_7 xhp7 xhn7 vdd vbsyn gsyn
X_ihm_1_7 a_xp1 a_xn1 wp_ih_1_7 wn_ih_1_7 mhp7 mhn7 vdd vbsyn gsyn
X_ihx_1_7 a_xp1 a_xn1 wp_ih_1_7 wn_ih_1_7 xhp7 xhn7 vdd vbsyn gsyn
X_ihm_2_7 a_xp2 a_xn2 wp_ih_2_7 wn_ih_2_7 mhp7 mhn7 vdd vbsyn gsyn
X_ihx_2_7 a_xp2 a_xn2 wp_ih_2_7 wn_ih_2_7 xhp7 xhn7 vdd vbsyn gsyn
X_ihm_3_7 a_xp3 a_xn3 wp_ih_3_7 wn_ih_3_7 mhp7 mhn7 vdd vbsyn gsyn
X_ihx_3_7 a_xp3 a_xn3 wp_ih_3_7 wn_ih_3_7 xhp7 xhn7 vdd vbsyn gsyn
X_ihm_4_7 a_xp4 a_xn4 wp_ih_4_7 wn_ih_4_7 mhp7 mhn7 vdd vbsyn gsyn
X_ihx_4_7 a_xp4 a_xn4 wp_ih_4_7 wn_ih_4_7 xhp7 xhn7 vdd vbsyn gsyn
X_ihm_5_7 a_xp5 a_xn5 wp_ih_5_7 wn_ih_5_7 mhp7 mhn7 vdd vbsyn gsyn
X_ihx_5_7 a_xp5 a_xn5 wp_ih_5_7 wn_ih_5_7 xhp7 xhn7 vdd vbsyn gsyn
X_ihm_6_7 a_xp6 a_xn6 wp_ih_6_7 wn_ih_6_7 mhp7 mhn7 vdd vbsyn gsyn
X_ihx_6_7 a_xp6 a_xn6 wp_ih_6_7 wn_ih_6_7 xhp7 xhn7 vdd vbsyn gsyn
X_ihm_7_7 a_xp7 a_xn7 wp_ih_7_7 wn_ih_7_7 mhp7 mhn7 vdd vbsyn gsyn
X_ihx_7_7 a_xp7 a_xn7 wp_ih_7_7 wn_ih_7_7 xhp7 xhn7 vdd vbsyn gsyn
X_ihm_8_7 a_xp8 a_xn8 wp_ih_8_7 wn_ih_8_7 mhp7 mhn7 vdd vbsyn gsyn
X_ihx_8_7 a_xp8 a_xn8 wp_ih_8_7 wn_ih_8_7 xhp7 xhn7 vdd vbsyn gsyn
X_ihm_9_7 a_xp9 a_xn9 wp_ih_9_7 wn_ih_9_7 mhp7 mhn7 vdd vbsyn gsyn
X_ihx_9_7 a_xp9 a_xn9 wp_ih_9_7 wn_ih_9_7 xhp7 xhn7 vdd vbsyn gsyn
X_ihm_10_7 a_xp10 a_xn10 wp_ih_10_7 wn_ih_10_7 mhp7 mhn7 vdd vbsyn gsyn
X_ihx_10_7 a_xp10 a_xn10 wp_ih_10_7 wn_ih_10_7 xhp7 xhn7 vdd vbsyn gsyn
X_ihm_11_7 a_xp11 a_xn11 wp_ih_11_7 wn_ih_11_7 mhp7 mhn7 vdd vbsyn gsyn
X_ihx_11_7 a_xp11 a_xn11 wp_ih_11_7 wn_ih_11_7 xhp7 xhn7 vdd vbsyn gsyn
X_ihm_12_7 a_xp12 a_xn12 wp_ih_12_7 wn_ih_12_7 mhp7 mhn7 vdd vbsyn gsyn
X_ihx_12_7 a_xp12 a_xn12 wp_ih_12_7 wn_ih_12_7 xhp7 xhn7 vdd vbsyn gsyn
X_ihm_13_7 a_xp13 a_xn13 wp_ih_13_7 wn_ih_13_7 mhp7 mhn7 vdd vbsyn gsyn
X_ihx_13_7 a_xp13 a_xn13 wp_ih_13_7 wn_ih_13_7 xhp7 xhn7 vdd vbsyn gsyn
X_ihm_14_7 a_xp14 a_xn14 wp_ih_14_7 wn_ih_14_7 mhp7 mhn7 vdd vbsyn gsyn
X_ihx_14_7 a_xp14 a_xn14 wp_ih_14_7 wn_ih_14_7 xhp7 xhn7 vdd vbsyn gsyn
X_ihm_15_7 a_xp15 a_xn15 wp_ih_15_7 wn_ih_15_7 mhp7 mhn7 vdd vbsyn gsyn
X_ihx_15_7 a_xp15 a_xn15 wp_ih_15_7 wn_ih_15_7 xhp7 xhn7 vdd vbsyn gsyn
Xn7 xhp7 xhn7 ahp7 ahn7 vdd vbneu dneuron
Xeh7 xhp7 xhn7 mhp7 mhn7 ehp7 ehn7 vdd gm esub
Xcm_mh8 mhp8 mhn8 vdd cmld
Xcm_xh8 xhp8 xhn8 vdd cmld
Rnd_mh8 mhp8 mhn8 20k
Rnd_xh8 xhp8 xhn8 20k
X_ihm_0_8 a_xp0 a_xn0 wp_ih_0_8 wn_ih_0_8 mhp8 mhn8 vdd vbsyn gsyn
X_ihx_0_8 a_xp0 a_xn0 wp_ih_0_8 wn_ih_0_8 xhp8 xhn8 vdd vbsyn gsyn
X_ihm_1_8 a_xp1 a_xn1 wp_ih_1_8 wn_ih_1_8 mhp8 mhn8 vdd vbsyn gsyn
X_ihx_1_8 a_xp1 a_xn1 wp_ih_1_8 wn_ih_1_8 xhp8 xhn8 vdd vbsyn gsyn
X_ihm_2_8 a_xp2 a_xn2 wp_ih_2_8 wn_ih_2_8 mhp8 mhn8 vdd vbsyn gsyn
X_ihx_2_8 a_xp2 a_xn2 wp_ih_2_8 wn_ih_2_8 xhp8 xhn8 vdd vbsyn gsyn
X_ihm_3_8 a_xp3 a_xn3 wp_ih_3_8 wn_ih_3_8 mhp8 mhn8 vdd vbsyn gsyn
X_ihx_3_8 a_xp3 a_xn3 wp_ih_3_8 wn_ih_3_8 xhp8 xhn8 vdd vbsyn gsyn
X_ihm_4_8 a_xp4 a_xn4 wp_ih_4_8 wn_ih_4_8 mhp8 mhn8 vdd vbsyn gsyn
X_ihx_4_8 a_xp4 a_xn4 wp_ih_4_8 wn_ih_4_8 xhp8 xhn8 vdd vbsyn gsyn
X_ihm_5_8 a_xp5 a_xn5 wp_ih_5_8 wn_ih_5_8 mhp8 mhn8 vdd vbsyn gsyn
X_ihx_5_8 a_xp5 a_xn5 wp_ih_5_8 wn_ih_5_8 xhp8 xhn8 vdd vbsyn gsyn
X_ihm_6_8 a_xp6 a_xn6 wp_ih_6_8 wn_ih_6_8 mhp8 mhn8 vdd vbsyn gsyn
X_ihx_6_8 a_xp6 a_xn6 wp_ih_6_8 wn_ih_6_8 xhp8 xhn8 vdd vbsyn gsyn
X_ihm_7_8 a_xp7 a_xn7 wp_ih_7_8 wn_ih_7_8 mhp8 mhn8 vdd vbsyn gsyn
X_ihx_7_8 a_xp7 a_xn7 wp_ih_7_8 wn_ih_7_8 xhp8 xhn8 vdd vbsyn gsyn
X_ihm_8_8 a_xp8 a_xn8 wp_ih_8_8 wn_ih_8_8 mhp8 mhn8 vdd vbsyn gsyn
X_ihx_8_8 a_xp8 a_xn8 wp_ih_8_8 wn_ih_8_8 xhp8 xhn8 vdd vbsyn gsyn
X_ihm_9_8 a_xp9 a_xn9 wp_ih_9_8 wn_ih_9_8 mhp8 mhn8 vdd vbsyn gsyn
X_ihx_9_8 a_xp9 a_xn9 wp_ih_9_8 wn_ih_9_8 xhp8 xhn8 vdd vbsyn gsyn
X_ihm_10_8 a_xp10 a_xn10 wp_ih_10_8 wn_ih_10_8 mhp8 mhn8 vdd vbsyn gsyn
X_ihx_10_8 a_xp10 a_xn10 wp_ih_10_8 wn_ih_10_8 xhp8 xhn8 vdd vbsyn gsyn
X_ihm_11_8 a_xp11 a_xn11 wp_ih_11_8 wn_ih_11_8 mhp8 mhn8 vdd vbsyn gsyn
X_ihx_11_8 a_xp11 a_xn11 wp_ih_11_8 wn_ih_11_8 xhp8 xhn8 vdd vbsyn gsyn
X_ihm_12_8 a_xp12 a_xn12 wp_ih_12_8 wn_ih_12_8 mhp8 mhn8 vdd vbsyn gsyn
X_ihx_12_8 a_xp12 a_xn12 wp_ih_12_8 wn_ih_12_8 xhp8 xhn8 vdd vbsyn gsyn
X_ihm_13_8 a_xp13 a_xn13 wp_ih_13_8 wn_ih_13_8 mhp8 mhn8 vdd vbsyn gsyn
X_ihx_13_8 a_xp13 a_xn13 wp_ih_13_8 wn_ih_13_8 xhp8 xhn8 vdd vbsyn gsyn
X_ihm_14_8 a_xp14 a_xn14 wp_ih_14_8 wn_ih_14_8 mhp8 mhn8 vdd vbsyn gsyn
X_ihx_14_8 a_xp14 a_xn14 wp_ih_14_8 wn_ih_14_8 xhp8 xhn8 vdd vbsyn gsyn
X_ihm_15_8 a_xp15 a_xn15 wp_ih_15_8 wn_ih_15_8 mhp8 mhn8 vdd vbsyn gsyn
X_ihx_15_8 a_xp15 a_xn15 wp_ih_15_8 wn_ih_15_8 xhp8 xhn8 vdd vbsyn gsyn
Xn8 xhp8 xhn8 ahp8 ahn8 vdd vbneu dneuron
Xeh8 xhp8 xhn8 mhp8 mhn8 ehp8 ehn8 vdd gm esub
Xcm_mh9 mhp9 mhn9 vdd cmld
Xcm_xh9 xhp9 xhn9 vdd cmld
Rnd_mh9 mhp9 mhn9 20k
Rnd_xh9 xhp9 xhn9 20k
X_ihm_0_9 a_xp0 a_xn0 wp_ih_0_9 wn_ih_0_9 mhp9 mhn9 vdd vbsyn gsyn
X_ihx_0_9 a_xp0 a_xn0 wp_ih_0_9 wn_ih_0_9 xhp9 xhn9 vdd vbsyn gsyn
X_ihm_1_9 a_xp1 a_xn1 wp_ih_1_9 wn_ih_1_9 mhp9 mhn9 vdd vbsyn gsyn
X_ihx_1_9 a_xp1 a_xn1 wp_ih_1_9 wn_ih_1_9 xhp9 xhn9 vdd vbsyn gsyn
X_ihm_2_9 a_xp2 a_xn2 wp_ih_2_9 wn_ih_2_9 mhp9 mhn9 vdd vbsyn gsyn
X_ihx_2_9 a_xp2 a_xn2 wp_ih_2_9 wn_ih_2_9 xhp9 xhn9 vdd vbsyn gsyn
X_ihm_3_9 a_xp3 a_xn3 wp_ih_3_9 wn_ih_3_9 mhp9 mhn9 vdd vbsyn gsyn
X_ihx_3_9 a_xp3 a_xn3 wp_ih_3_9 wn_ih_3_9 xhp9 xhn9 vdd vbsyn gsyn
X_ihm_4_9 a_xp4 a_xn4 wp_ih_4_9 wn_ih_4_9 mhp9 mhn9 vdd vbsyn gsyn
X_ihx_4_9 a_xp4 a_xn4 wp_ih_4_9 wn_ih_4_9 xhp9 xhn9 vdd vbsyn gsyn
X_ihm_5_9 a_xp5 a_xn5 wp_ih_5_9 wn_ih_5_9 mhp9 mhn9 vdd vbsyn gsyn
X_ihx_5_9 a_xp5 a_xn5 wp_ih_5_9 wn_ih_5_9 xhp9 xhn9 vdd vbsyn gsyn
X_ihm_6_9 a_xp6 a_xn6 wp_ih_6_9 wn_ih_6_9 mhp9 mhn9 vdd vbsyn gsyn
X_ihx_6_9 a_xp6 a_xn6 wp_ih_6_9 wn_ih_6_9 xhp9 xhn9 vdd vbsyn gsyn
X_ihm_7_9 a_xp7 a_xn7 wp_ih_7_9 wn_ih_7_9 mhp9 mhn9 vdd vbsyn gsyn
X_ihx_7_9 a_xp7 a_xn7 wp_ih_7_9 wn_ih_7_9 xhp9 xhn9 vdd vbsyn gsyn
X_ihm_8_9 a_xp8 a_xn8 wp_ih_8_9 wn_ih_8_9 mhp9 mhn9 vdd vbsyn gsyn
X_ihx_8_9 a_xp8 a_xn8 wp_ih_8_9 wn_ih_8_9 xhp9 xhn9 vdd vbsyn gsyn
X_ihm_9_9 a_xp9 a_xn9 wp_ih_9_9 wn_ih_9_9 mhp9 mhn9 vdd vbsyn gsyn
X_ihx_9_9 a_xp9 a_xn9 wp_ih_9_9 wn_ih_9_9 xhp9 xhn9 vdd vbsyn gsyn
X_ihm_10_9 a_xp10 a_xn10 wp_ih_10_9 wn_ih_10_9 mhp9 mhn9 vdd vbsyn gsyn
X_ihx_10_9 a_xp10 a_xn10 wp_ih_10_9 wn_ih_10_9 xhp9 xhn9 vdd vbsyn gsyn
X_ihm_11_9 a_xp11 a_xn11 wp_ih_11_9 wn_ih_11_9 mhp9 mhn9 vdd vbsyn gsyn
X_ihx_11_9 a_xp11 a_xn11 wp_ih_11_9 wn_ih_11_9 xhp9 xhn9 vdd vbsyn gsyn
X_ihm_12_9 a_xp12 a_xn12 wp_ih_12_9 wn_ih_12_9 mhp9 mhn9 vdd vbsyn gsyn
X_ihx_12_9 a_xp12 a_xn12 wp_ih_12_9 wn_ih_12_9 xhp9 xhn9 vdd vbsyn gsyn
X_ihm_13_9 a_xp13 a_xn13 wp_ih_13_9 wn_ih_13_9 mhp9 mhn9 vdd vbsyn gsyn
X_ihx_13_9 a_xp13 a_xn13 wp_ih_13_9 wn_ih_13_9 xhp9 xhn9 vdd vbsyn gsyn
X_ihm_14_9 a_xp14 a_xn14 wp_ih_14_9 wn_ih_14_9 mhp9 mhn9 vdd vbsyn gsyn
X_ihx_14_9 a_xp14 a_xn14 wp_ih_14_9 wn_ih_14_9 xhp9 xhn9 vdd vbsyn gsyn
X_ihm_15_9 a_xp15 a_xn15 wp_ih_15_9 wn_ih_15_9 mhp9 mhn9 vdd vbsyn gsyn
X_ihx_15_9 a_xp15 a_xn15 wp_ih_15_9 wn_ih_15_9 xhp9 xhn9 vdd vbsyn gsyn
Xn9 xhp9 xhn9 ahp9 ahn9 vdd vbneu dneuron
Xeh9 xhp9 xhn9 mhp9 mhn9 ehp9 ehn9 vdd gm esub
Xcm_mh10 mhp10 mhn10 vdd cmld
Xcm_xh10 xhp10 xhn10 vdd cmld
Rnd_mh10 mhp10 mhn10 20k
Rnd_xh10 xhp10 xhn10 20k
X_ihm_0_10 a_xp0 a_xn0 wp_ih_0_10 wn_ih_0_10 mhp10 mhn10 vdd vbsyn gsyn
X_ihx_0_10 a_xp0 a_xn0 wp_ih_0_10 wn_ih_0_10 xhp10 xhn10 vdd vbsyn gsyn
X_ihm_1_10 a_xp1 a_xn1 wp_ih_1_10 wn_ih_1_10 mhp10 mhn10 vdd vbsyn gsyn
X_ihx_1_10 a_xp1 a_xn1 wp_ih_1_10 wn_ih_1_10 xhp10 xhn10 vdd vbsyn gsyn
X_ihm_2_10 a_xp2 a_xn2 wp_ih_2_10 wn_ih_2_10 mhp10 mhn10 vdd vbsyn gsyn
X_ihx_2_10 a_xp2 a_xn2 wp_ih_2_10 wn_ih_2_10 xhp10 xhn10 vdd vbsyn gsyn
X_ihm_3_10 a_xp3 a_xn3 wp_ih_3_10 wn_ih_3_10 mhp10 mhn10 vdd vbsyn gsyn
X_ihx_3_10 a_xp3 a_xn3 wp_ih_3_10 wn_ih_3_10 xhp10 xhn10 vdd vbsyn gsyn
X_ihm_4_10 a_xp4 a_xn4 wp_ih_4_10 wn_ih_4_10 mhp10 mhn10 vdd vbsyn gsyn
X_ihx_4_10 a_xp4 a_xn4 wp_ih_4_10 wn_ih_4_10 xhp10 xhn10 vdd vbsyn gsyn
X_ihm_5_10 a_xp5 a_xn5 wp_ih_5_10 wn_ih_5_10 mhp10 mhn10 vdd vbsyn gsyn
X_ihx_5_10 a_xp5 a_xn5 wp_ih_5_10 wn_ih_5_10 xhp10 xhn10 vdd vbsyn gsyn
X_ihm_6_10 a_xp6 a_xn6 wp_ih_6_10 wn_ih_6_10 mhp10 mhn10 vdd vbsyn gsyn
X_ihx_6_10 a_xp6 a_xn6 wp_ih_6_10 wn_ih_6_10 xhp10 xhn10 vdd vbsyn gsyn
X_ihm_7_10 a_xp7 a_xn7 wp_ih_7_10 wn_ih_7_10 mhp10 mhn10 vdd vbsyn gsyn
X_ihx_7_10 a_xp7 a_xn7 wp_ih_7_10 wn_ih_7_10 xhp10 xhn10 vdd vbsyn gsyn
X_ihm_8_10 a_xp8 a_xn8 wp_ih_8_10 wn_ih_8_10 mhp10 mhn10 vdd vbsyn gsyn
X_ihx_8_10 a_xp8 a_xn8 wp_ih_8_10 wn_ih_8_10 xhp10 xhn10 vdd vbsyn gsyn
X_ihm_9_10 a_xp9 a_xn9 wp_ih_9_10 wn_ih_9_10 mhp10 mhn10 vdd vbsyn gsyn
X_ihx_9_10 a_xp9 a_xn9 wp_ih_9_10 wn_ih_9_10 xhp10 xhn10 vdd vbsyn gsyn
X_ihm_10_10 a_xp10 a_xn10 wp_ih_10_10 wn_ih_10_10 mhp10 mhn10 vdd vbsyn gsyn
X_ihx_10_10 a_xp10 a_xn10 wp_ih_10_10 wn_ih_10_10 xhp10 xhn10 vdd vbsyn gsyn
X_ihm_11_10 a_xp11 a_xn11 wp_ih_11_10 wn_ih_11_10 mhp10 mhn10 vdd vbsyn gsyn
X_ihx_11_10 a_xp11 a_xn11 wp_ih_11_10 wn_ih_11_10 xhp10 xhn10 vdd vbsyn gsyn
X_ihm_12_10 a_xp12 a_xn12 wp_ih_12_10 wn_ih_12_10 mhp10 mhn10 vdd vbsyn gsyn
X_ihx_12_10 a_xp12 a_xn12 wp_ih_12_10 wn_ih_12_10 xhp10 xhn10 vdd vbsyn gsyn
X_ihm_13_10 a_xp13 a_xn13 wp_ih_13_10 wn_ih_13_10 mhp10 mhn10 vdd vbsyn gsyn
X_ihx_13_10 a_xp13 a_xn13 wp_ih_13_10 wn_ih_13_10 xhp10 xhn10 vdd vbsyn gsyn
X_ihm_14_10 a_xp14 a_xn14 wp_ih_14_10 wn_ih_14_10 mhp10 mhn10 vdd vbsyn gsyn
X_ihx_14_10 a_xp14 a_xn14 wp_ih_14_10 wn_ih_14_10 xhp10 xhn10 vdd vbsyn gsyn
X_ihm_15_10 a_xp15 a_xn15 wp_ih_15_10 wn_ih_15_10 mhp10 mhn10 vdd vbsyn gsyn
X_ihx_15_10 a_xp15 a_xn15 wp_ih_15_10 wn_ih_15_10 xhp10 xhn10 vdd vbsyn gsyn
Xn10 xhp10 xhn10 ahp10 ahn10 vdd vbneu dneuron
Xeh10 xhp10 xhn10 mhp10 mhn10 ehp10 ehn10 vdd gm esub
Xcm_mh11 mhp11 mhn11 vdd cmld
Xcm_xh11 xhp11 xhn11 vdd cmld
Rnd_mh11 mhp11 mhn11 20k
Rnd_xh11 xhp11 xhn11 20k
X_ihm_0_11 a_xp0 a_xn0 wp_ih_0_11 wn_ih_0_11 mhp11 mhn11 vdd vbsyn gsyn
X_ihx_0_11 a_xp0 a_xn0 wp_ih_0_11 wn_ih_0_11 xhp11 xhn11 vdd vbsyn gsyn
X_ihm_1_11 a_xp1 a_xn1 wp_ih_1_11 wn_ih_1_11 mhp11 mhn11 vdd vbsyn gsyn
X_ihx_1_11 a_xp1 a_xn1 wp_ih_1_11 wn_ih_1_11 xhp11 xhn11 vdd vbsyn gsyn
X_ihm_2_11 a_xp2 a_xn2 wp_ih_2_11 wn_ih_2_11 mhp11 mhn11 vdd vbsyn gsyn
X_ihx_2_11 a_xp2 a_xn2 wp_ih_2_11 wn_ih_2_11 xhp11 xhn11 vdd vbsyn gsyn
X_ihm_3_11 a_xp3 a_xn3 wp_ih_3_11 wn_ih_3_11 mhp11 mhn11 vdd vbsyn gsyn
X_ihx_3_11 a_xp3 a_xn3 wp_ih_3_11 wn_ih_3_11 xhp11 xhn11 vdd vbsyn gsyn
X_ihm_4_11 a_xp4 a_xn4 wp_ih_4_11 wn_ih_4_11 mhp11 mhn11 vdd vbsyn gsyn
X_ihx_4_11 a_xp4 a_xn4 wp_ih_4_11 wn_ih_4_11 xhp11 xhn11 vdd vbsyn gsyn
X_ihm_5_11 a_xp5 a_xn5 wp_ih_5_11 wn_ih_5_11 mhp11 mhn11 vdd vbsyn gsyn
X_ihx_5_11 a_xp5 a_xn5 wp_ih_5_11 wn_ih_5_11 xhp11 xhn11 vdd vbsyn gsyn
X_ihm_6_11 a_xp6 a_xn6 wp_ih_6_11 wn_ih_6_11 mhp11 mhn11 vdd vbsyn gsyn
X_ihx_6_11 a_xp6 a_xn6 wp_ih_6_11 wn_ih_6_11 xhp11 xhn11 vdd vbsyn gsyn
X_ihm_7_11 a_xp7 a_xn7 wp_ih_7_11 wn_ih_7_11 mhp11 mhn11 vdd vbsyn gsyn
X_ihx_7_11 a_xp7 a_xn7 wp_ih_7_11 wn_ih_7_11 xhp11 xhn11 vdd vbsyn gsyn
X_ihm_8_11 a_xp8 a_xn8 wp_ih_8_11 wn_ih_8_11 mhp11 mhn11 vdd vbsyn gsyn
X_ihx_8_11 a_xp8 a_xn8 wp_ih_8_11 wn_ih_8_11 xhp11 xhn11 vdd vbsyn gsyn
X_ihm_9_11 a_xp9 a_xn9 wp_ih_9_11 wn_ih_9_11 mhp11 mhn11 vdd vbsyn gsyn
X_ihx_9_11 a_xp9 a_xn9 wp_ih_9_11 wn_ih_9_11 xhp11 xhn11 vdd vbsyn gsyn
X_ihm_10_11 a_xp10 a_xn10 wp_ih_10_11 wn_ih_10_11 mhp11 mhn11 vdd vbsyn gsyn
X_ihx_10_11 a_xp10 a_xn10 wp_ih_10_11 wn_ih_10_11 xhp11 xhn11 vdd vbsyn gsyn
X_ihm_11_11 a_xp11 a_xn11 wp_ih_11_11 wn_ih_11_11 mhp11 mhn11 vdd vbsyn gsyn
X_ihx_11_11 a_xp11 a_xn11 wp_ih_11_11 wn_ih_11_11 xhp11 xhn11 vdd vbsyn gsyn
X_ihm_12_11 a_xp12 a_xn12 wp_ih_12_11 wn_ih_12_11 mhp11 mhn11 vdd vbsyn gsyn
X_ihx_12_11 a_xp12 a_xn12 wp_ih_12_11 wn_ih_12_11 xhp11 xhn11 vdd vbsyn gsyn
X_ihm_13_11 a_xp13 a_xn13 wp_ih_13_11 wn_ih_13_11 mhp11 mhn11 vdd vbsyn gsyn
X_ihx_13_11 a_xp13 a_xn13 wp_ih_13_11 wn_ih_13_11 xhp11 xhn11 vdd vbsyn gsyn
X_ihm_14_11 a_xp14 a_xn14 wp_ih_14_11 wn_ih_14_11 mhp11 mhn11 vdd vbsyn gsyn
X_ihx_14_11 a_xp14 a_xn14 wp_ih_14_11 wn_ih_14_11 xhp11 xhn11 vdd vbsyn gsyn
X_ihm_15_11 a_xp15 a_xn15 wp_ih_15_11 wn_ih_15_11 mhp11 mhn11 vdd vbsyn gsyn
X_ihx_15_11 a_xp15 a_xn15 wp_ih_15_11 wn_ih_15_11 xhp11 xhn11 vdd vbsyn gsyn
Xn11 xhp11 xhn11 ahp11 ahn11 vdd vbneu dneuron
Xeh11 xhp11 xhn11 mhp11 mhn11 ehp11 ehn11 vdd gm esub
Xcm_mh12 mhp12 mhn12 vdd cmld
Xcm_xh12 xhp12 xhn12 vdd cmld
Rnd_mh12 mhp12 mhn12 20k
Rnd_xh12 xhp12 xhn12 20k
X_ihm_0_12 a_xp0 a_xn0 wp_ih_0_12 wn_ih_0_12 mhp12 mhn12 vdd vbsyn gsyn
X_ihx_0_12 a_xp0 a_xn0 wp_ih_0_12 wn_ih_0_12 xhp12 xhn12 vdd vbsyn gsyn
X_ihm_1_12 a_xp1 a_xn1 wp_ih_1_12 wn_ih_1_12 mhp12 mhn12 vdd vbsyn gsyn
X_ihx_1_12 a_xp1 a_xn1 wp_ih_1_12 wn_ih_1_12 xhp12 xhn12 vdd vbsyn gsyn
X_ihm_2_12 a_xp2 a_xn2 wp_ih_2_12 wn_ih_2_12 mhp12 mhn12 vdd vbsyn gsyn
X_ihx_2_12 a_xp2 a_xn2 wp_ih_2_12 wn_ih_2_12 xhp12 xhn12 vdd vbsyn gsyn
X_ihm_3_12 a_xp3 a_xn3 wp_ih_3_12 wn_ih_3_12 mhp12 mhn12 vdd vbsyn gsyn
X_ihx_3_12 a_xp3 a_xn3 wp_ih_3_12 wn_ih_3_12 xhp12 xhn12 vdd vbsyn gsyn
X_ihm_4_12 a_xp4 a_xn4 wp_ih_4_12 wn_ih_4_12 mhp12 mhn12 vdd vbsyn gsyn
X_ihx_4_12 a_xp4 a_xn4 wp_ih_4_12 wn_ih_4_12 xhp12 xhn12 vdd vbsyn gsyn
X_ihm_5_12 a_xp5 a_xn5 wp_ih_5_12 wn_ih_5_12 mhp12 mhn12 vdd vbsyn gsyn
X_ihx_5_12 a_xp5 a_xn5 wp_ih_5_12 wn_ih_5_12 xhp12 xhn12 vdd vbsyn gsyn
X_ihm_6_12 a_xp6 a_xn6 wp_ih_6_12 wn_ih_6_12 mhp12 mhn12 vdd vbsyn gsyn
X_ihx_6_12 a_xp6 a_xn6 wp_ih_6_12 wn_ih_6_12 xhp12 xhn12 vdd vbsyn gsyn
X_ihm_7_12 a_xp7 a_xn7 wp_ih_7_12 wn_ih_7_12 mhp12 mhn12 vdd vbsyn gsyn
X_ihx_7_12 a_xp7 a_xn7 wp_ih_7_12 wn_ih_7_12 xhp12 xhn12 vdd vbsyn gsyn
X_ihm_8_12 a_xp8 a_xn8 wp_ih_8_12 wn_ih_8_12 mhp12 mhn12 vdd vbsyn gsyn
X_ihx_8_12 a_xp8 a_xn8 wp_ih_8_12 wn_ih_8_12 xhp12 xhn12 vdd vbsyn gsyn
X_ihm_9_12 a_xp9 a_xn9 wp_ih_9_12 wn_ih_9_12 mhp12 mhn12 vdd vbsyn gsyn
X_ihx_9_12 a_xp9 a_xn9 wp_ih_9_12 wn_ih_9_12 xhp12 xhn12 vdd vbsyn gsyn
X_ihm_10_12 a_xp10 a_xn10 wp_ih_10_12 wn_ih_10_12 mhp12 mhn12 vdd vbsyn gsyn
X_ihx_10_12 a_xp10 a_xn10 wp_ih_10_12 wn_ih_10_12 xhp12 xhn12 vdd vbsyn gsyn
X_ihm_11_12 a_xp11 a_xn11 wp_ih_11_12 wn_ih_11_12 mhp12 mhn12 vdd vbsyn gsyn
X_ihx_11_12 a_xp11 a_xn11 wp_ih_11_12 wn_ih_11_12 xhp12 xhn12 vdd vbsyn gsyn
X_ihm_12_12 a_xp12 a_xn12 wp_ih_12_12 wn_ih_12_12 mhp12 mhn12 vdd vbsyn gsyn
X_ihx_12_12 a_xp12 a_xn12 wp_ih_12_12 wn_ih_12_12 xhp12 xhn12 vdd vbsyn gsyn
X_ihm_13_12 a_xp13 a_xn13 wp_ih_13_12 wn_ih_13_12 mhp12 mhn12 vdd vbsyn gsyn
X_ihx_13_12 a_xp13 a_xn13 wp_ih_13_12 wn_ih_13_12 xhp12 xhn12 vdd vbsyn gsyn
X_ihm_14_12 a_xp14 a_xn14 wp_ih_14_12 wn_ih_14_12 mhp12 mhn12 vdd vbsyn gsyn
X_ihx_14_12 a_xp14 a_xn14 wp_ih_14_12 wn_ih_14_12 xhp12 xhn12 vdd vbsyn gsyn
X_ihm_15_12 a_xp15 a_xn15 wp_ih_15_12 wn_ih_15_12 mhp12 mhn12 vdd vbsyn gsyn
X_ihx_15_12 a_xp15 a_xn15 wp_ih_15_12 wn_ih_15_12 xhp12 xhn12 vdd vbsyn gsyn
Xn12 xhp12 xhn12 ahp12 ahn12 vdd vbneu dneuron
Xeh12 xhp12 xhn12 mhp12 mhn12 ehp12 ehn12 vdd gm esub
Xcm_mh13 mhp13 mhn13 vdd cmld
Xcm_xh13 xhp13 xhn13 vdd cmld
Rnd_mh13 mhp13 mhn13 20k
Rnd_xh13 xhp13 xhn13 20k
X_ihm_0_13 a_xp0 a_xn0 wp_ih_0_13 wn_ih_0_13 mhp13 mhn13 vdd vbsyn gsyn
X_ihx_0_13 a_xp0 a_xn0 wp_ih_0_13 wn_ih_0_13 xhp13 xhn13 vdd vbsyn gsyn
X_ihm_1_13 a_xp1 a_xn1 wp_ih_1_13 wn_ih_1_13 mhp13 mhn13 vdd vbsyn gsyn
X_ihx_1_13 a_xp1 a_xn1 wp_ih_1_13 wn_ih_1_13 xhp13 xhn13 vdd vbsyn gsyn
X_ihm_2_13 a_xp2 a_xn2 wp_ih_2_13 wn_ih_2_13 mhp13 mhn13 vdd vbsyn gsyn
X_ihx_2_13 a_xp2 a_xn2 wp_ih_2_13 wn_ih_2_13 xhp13 xhn13 vdd vbsyn gsyn
X_ihm_3_13 a_xp3 a_xn3 wp_ih_3_13 wn_ih_3_13 mhp13 mhn13 vdd vbsyn gsyn
X_ihx_3_13 a_xp3 a_xn3 wp_ih_3_13 wn_ih_3_13 xhp13 xhn13 vdd vbsyn gsyn
X_ihm_4_13 a_xp4 a_xn4 wp_ih_4_13 wn_ih_4_13 mhp13 mhn13 vdd vbsyn gsyn
X_ihx_4_13 a_xp4 a_xn4 wp_ih_4_13 wn_ih_4_13 xhp13 xhn13 vdd vbsyn gsyn
X_ihm_5_13 a_xp5 a_xn5 wp_ih_5_13 wn_ih_5_13 mhp13 mhn13 vdd vbsyn gsyn
X_ihx_5_13 a_xp5 a_xn5 wp_ih_5_13 wn_ih_5_13 xhp13 xhn13 vdd vbsyn gsyn
X_ihm_6_13 a_xp6 a_xn6 wp_ih_6_13 wn_ih_6_13 mhp13 mhn13 vdd vbsyn gsyn
X_ihx_6_13 a_xp6 a_xn6 wp_ih_6_13 wn_ih_6_13 xhp13 xhn13 vdd vbsyn gsyn
X_ihm_7_13 a_xp7 a_xn7 wp_ih_7_13 wn_ih_7_13 mhp13 mhn13 vdd vbsyn gsyn
X_ihx_7_13 a_xp7 a_xn7 wp_ih_7_13 wn_ih_7_13 xhp13 xhn13 vdd vbsyn gsyn
X_ihm_8_13 a_xp8 a_xn8 wp_ih_8_13 wn_ih_8_13 mhp13 mhn13 vdd vbsyn gsyn
X_ihx_8_13 a_xp8 a_xn8 wp_ih_8_13 wn_ih_8_13 xhp13 xhn13 vdd vbsyn gsyn
X_ihm_9_13 a_xp9 a_xn9 wp_ih_9_13 wn_ih_9_13 mhp13 mhn13 vdd vbsyn gsyn
X_ihx_9_13 a_xp9 a_xn9 wp_ih_9_13 wn_ih_9_13 xhp13 xhn13 vdd vbsyn gsyn
X_ihm_10_13 a_xp10 a_xn10 wp_ih_10_13 wn_ih_10_13 mhp13 mhn13 vdd vbsyn gsyn
X_ihx_10_13 a_xp10 a_xn10 wp_ih_10_13 wn_ih_10_13 xhp13 xhn13 vdd vbsyn gsyn
X_ihm_11_13 a_xp11 a_xn11 wp_ih_11_13 wn_ih_11_13 mhp13 mhn13 vdd vbsyn gsyn
X_ihx_11_13 a_xp11 a_xn11 wp_ih_11_13 wn_ih_11_13 xhp13 xhn13 vdd vbsyn gsyn
X_ihm_12_13 a_xp12 a_xn12 wp_ih_12_13 wn_ih_12_13 mhp13 mhn13 vdd vbsyn gsyn
X_ihx_12_13 a_xp12 a_xn12 wp_ih_12_13 wn_ih_12_13 xhp13 xhn13 vdd vbsyn gsyn
X_ihm_13_13 a_xp13 a_xn13 wp_ih_13_13 wn_ih_13_13 mhp13 mhn13 vdd vbsyn gsyn
X_ihx_13_13 a_xp13 a_xn13 wp_ih_13_13 wn_ih_13_13 xhp13 xhn13 vdd vbsyn gsyn
X_ihm_14_13 a_xp14 a_xn14 wp_ih_14_13 wn_ih_14_13 mhp13 mhn13 vdd vbsyn gsyn
X_ihx_14_13 a_xp14 a_xn14 wp_ih_14_13 wn_ih_14_13 xhp13 xhn13 vdd vbsyn gsyn
X_ihm_15_13 a_xp15 a_xn15 wp_ih_15_13 wn_ih_15_13 mhp13 mhn13 vdd vbsyn gsyn
X_ihx_15_13 a_xp15 a_xn15 wp_ih_15_13 wn_ih_15_13 xhp13 xhn13 vdd vbsyn gsyn
Xn13 xhp13 xhn13 ahp13 ahn13 vdd vbneu dneuron
Xeh13 xhp13 xhn13 mhp13 mhn13 ehp13 ehn13 vdd gm esub
Xcm_mh14 mhp14 mhn14 vdd cmld
Xcm_xh14 xhp14 xhn14 vdd cmld
Rnd_mh14 mhp14 mhn14 20k
Rnd_xh14 xhp14 xhn14 20k
X_ihm_0_14 a_xp0 a_xn0 wp_ih_0_14 wn_ih_0_14 mhp14 mhn14 vdd vbsyn gsyn
X_ihx_0_14 a_xp0 a_xn0 wp_ih_0_14 wn_ih_0_14 xhp14 xhn14 vdd vbsyn gsyn
X_ihm_1_14 a_xp1 a_xn1 wp_ih_1_14 wn_ih_1_14 mhp14 mhn14 vdd vbsyn gsyn
X_ihx_1_14 a_xp1 a_xn1 wp_ih_1_14 wn_ih_1_14 xhp14 xhn14 vdd vbsyn gsyn
X_ihm_2_14 a_xp2 a_xn2 wp_ih_2_14 wn_ih_2_14 mhp14 mhn14 vdd vbsyn gsyn
X_ihx_2_14 a_xp2 a_xn2 wp_ih_2_14 wn_ih_2_14 xhp14 xhn14 vdd vbsyn gsyn
X_ihm_3_14 a_xp3 a_xn3 wp_ih_3_14 wn_ih_3_14 mhp14 mhn14 vdd vbsyn gsyn
X_ihx_3_14 a_xp3 a_xn3 wp_ih_3_14 wn_ih_3_14 xhp14 xhn14 vdd vbsyn gsyn
X_ihm_4_14 a_xp4 a_xn4 wp_ih_4_14 wn_ih_4_14 mhp14 mhn14 vdd vbsyn gsyn
X_ihx_4_14 a_xp4 a_xn4 wp_ih_4_14 wn_ih_4_14 xhp14 xhn14 vdd vbsyn gsyn
X_ihm_5_14 a_xp5 a_xn5 wp_ih_5_14 wn_ih_5_14 mhp14 mhn14 vdd vbsyn gsyn
X_ihx_5_14 a_xp5 a_xn5 wp_ih_5_14 wn_ih_5_14 xhp14 xhn14 vdd vbsyn gsyn
X_ihm_6_14 a_xp6 a_xn6 wp_ih_6_14 wn_ih_6_14 mhp14 mhn14 vdd vbsyn gsyn
X_ihx_6_14 a_xp6 a_xn6 wp_ih_6_14 wn_ih_6_14 xhp14 xhn14 vdd vbsyn gsyn
X_ihm_7_14 a_xp7 a_xn7 wp_ih_7_14 wn_ih_7_14 mhp14 mhn14 vdd vbsyn gsyn
X_ihx_7_14 a_xp7 a_xn7 wp_ih_7_14 wn_ih_7_14 xhp14 xhn14 vdd vbsyn gsyn
X_ihm_8_14 a_xp8 a_xn8 wp_ih_8_14 wn_ih_8_14 mhp14 mhn14 vdd vbsyn gsyn
X_ihx_8_14 a_xp8 a_xn8 wp_ih_8_14 wn_ih_8_14 xhp14 xhn14 vdd vbsyn gsyn
X_ihm_9_14 a_xp9 a_xn9 wp_ih_9_14 wn_ih_9_14 mhp14 mhn14 vdd vbsyn gsyn
X_ihx_9_14 a_xp9 a_xn9 wp_ih_9_14 wn_ih_9_14 xhp14 xhn14 vdd vbsyn gsyn
X_ihm_10_14 a_xp10 a_xn10 wp_ih_10_14 wn_ih_10_14 mhp14 mhn14 vdd vbsyn gsyn
X_ihx_10_14 a_xp10 a_xn10 wp_ih_10_14 wn_ih_10_14 xhp14 xhn14 vdd vbsyn gsyn
X_ihm_11_14 a_xp11 a_xn11 wp_ih_11_14 wn_ih_11_14 mhp14 mhn14 vdd vbsyn gsyn
X_ihx_11_14 a_xp11 a_xn11 wp_ih_11_14 wn_ih_11_14 xhp14 xhn14 vdd vbsyn gsyn
X_ihm_12_14 a_xp12 a_xn12 wp_ih_12_14 wn_ih_12_14 mhp14 mhn14 vdd vbsyn gsyn
X_ihx_12_14 a_xp12 a_xn12 wp_ih_12_14 wn_ih_12_14 xhp14 xhn14 vdd vbsyn gsyn
X_ihm_13_14 a_xp13 a_xn13 wp_ih_13_14 wn_ih_13_14 mhp14 mhn14 vdd vbsyn gsyn
X_ihx_13_14 a_xp13 a_xn13 wp_ih_13_14 wn_ih_13_14 xhp14 xhn14 vdd vbsyn gsyn
X_ihm_14_14 a_xp14 a_xn14 wp_ih_14_14 wn_ih_14_14 mhp14 mhn14 vdd vbsyn gsyn
X_ihx_14_14 a_xp14 a_xn14 wp_ih_14_14 wn_ih_14_14 xhp14 xhn14 vdd vbsyn gsyn
X_ihm_15_14 a_xp15 a_xn15 wp_ih_15_14 wn_ih_15_14 mhp14 mhn14 vdd vbsyn gsyn
X_ihx_15_14 a_xp15 a_xn15 wp_ih_15_14 wn_ih_15_14 xhp14 xhn14 vdd vbsyn gsyn
Xn14 xhp14 xhn14 ahp14 ahn14 vdd vbneu dneuron
Xeh14 xhp14 xhn14 mhp14 mhn14 ehp14 ehn14 vdd gm esub
Xcm_mh15 mhp15 mhn15 vdd cmld
Xcm_xh15 xhp15 xhn15 vdd cmld
Rnd_mh15 mhp15 mhn15 20k
Rnd_xh15 xhp15 xhn15 20k
X_ihm_0_15 a_xp0 a_xn0 wp_ih_0_15 wn_ih_0_15 mhp15 mhn15 vdd vbsyn gsyn
X_ihx_0_15 a_xp0 a_xn0 wp_ih_0_15 wn_ih_0_15 xhp15 xhn15 vdd vbsyn gsyn
X_ihm_1_15 a_xp1 a_xn1 wp_ih_1_15 wn_ih_1_15 mhp15 mhn15 vdd vbsyn gsyn
X_ihx_1_15 a_xp1 a_xn1 wp_ih_1_15 wn_ih_1_15 xhp15 xhn15 vdd vbsyn gsyn
X_ihm_2_15 a_xp2 a_xn2 wp_ih_2_15 wn_ih_2_15 mhp15 mhn15 vdd vbsyn gsyn
X_ihx_2_15 a_xp2 a_xn2 wp_ih_2_15 wn_ih_2_15 xhp15 xhn15 vdd vbsyn gsyn
X_ihm_3_15 a_xp3 a_xn3 wp_ih_3_15 wn_ih_3_15 mhp15 mhn15 vdd vbsyn gsyn
X_ihx_3_15 a_xp3 a_xn3 wp_ih_3_15 wn_ih_3_15 xhp15 xhn15 vdd vbsyn gsyn
X_ihm_4_15 a_xp4 a_xn4 wp_ih_4_15 wn_ih_4_15 mhp15 mhn15 vdd vbsyn gsyn
X_ihx_4_15 a_xp4 a_xn4 wp_ih_4_15 wn_ih_4_15 xhp15 xhn15 vdd vbsyn gsyn
X_ihm_5_15 a_xp5 a_xn5 wp_ih_5_15 wn_ih_5_15 mhp15 mhn15 vdd vbsyn gsyn
X_ihx_5_15 a_xp5 a_xn5 wp_ih_5_15 wn_ih_5_15 xhp15 xhn15 vdd vbsyn gsyn
X_ihm_6_15 a_xp6 a_xn6 wp_ih_6_15 wn_ih_6_15 mhp15 mhn15 vdd vbsyn gsyn
X_ihx_6_15 a_xp6 a_xn6 wp_ih_6_15 wn_ih_6_15 xhp15 xhn15 vdd vbsyn gsyn
X_ihm_7_15 a_xp7 a_xn7 wp_ih_7_15 wn_ih_7_15 mhp15 mhn15 vdd vbsyn gsyn
X_ihx_7_15 a_xp7 a_xn7 wp_ih_7_15 wn_ih_7_15 xhp15 xhn15 vdd vbsyn gsyn
X_ihm_8_15 a_xp8 a_xn8 wp_ih_8_15 wn_ih_8_15 mhp15 mhn15 vdd vbsyn gsyn
X_ihx_8_15 a_xp8 a_xn8 wp_ih_8_15 wn_ih_8_15 xhp15 xhn15 vdd vbsyn gsyn
X_ihm_9_15 a_xp9 a_xn9 wp_ih_9_15 wn_ih_9_15 mhp15 mhn15 vdd vbsyn gsyn
X_ihx_9_15 a_xp9 a_xn9 wp_ih_9_15 wn_ih_9_15 xhp15 xhn15 vdd vbsyn gsyn
X_ihm_10_15 a_xp10 a_xn10 wp_ih_10_15 wn_ih_10_15 mhp15 mhn15 vdd vbsyn gsyn
X_ihx_10_15 a_xp10 a_xn10 wp_ih_10_15 wn_ih_10_15 xhp15 xhn15 vdd vbsyn gsyn
X_ihm_11_15 a_xp11 a_xn11 wp_ih_11_15 wn_ih_11_15 mhp15 mhn15 vdd vbsyn gsyn
X_ihx_11_15 a_xp11 a_xn11 wp_ih_11_15 wn_ih_11_15 xhp15 xhn15 vdd vbsyn gsyn
X_ihm_12_15 a_xp12 a_xn12 wp_ih_12_15 wn_ih_12_15 mhp15 mhn15 vdd vbsyn gsyn
X_ihx_12_15 a_xp12 a_xn12 wp_ih_12_15 wn_ih_12_15 xhp15 xhn15 vdd vbsyn gsyn
X_ihm_13_15 a_xp13 a_xn13 wp_ih_13_15 wn_ih_13_15 mhp15 mhn15 vdd vbsyn gsyn
X_ihx_13_15 a_xp13 a_xn13 wp_ih_13_15 wn_ih_13_15 xhp15 xhn15 vdd vbsyn gsyn
X_ihm_14_15 a_xp14 a_xn14 wp_ih_14_15 wn_ih_14_15 mhp15 mhn15 vdd vbsyn gsyn
X_ihx_14_15 a_xp14 a_xn14 wp_ih_14_15 wn_ih_14_15 xhp15 xhn15 vdd vbsyn gsyn
X_ihm_15_15 a_xp15 a_xn15 wp_ih_15_15 wn_ih_15_15 mhp15 mhn15 vdd vbsyn gsyn
X_ihx_15_15 a_xp15 a_xn15 wp_ih_15_15 wn_ih_15_15 xhp15 xhn15 vdd vbsyn gsyn
Xn15 xhp15 xhn15 ahp15 ahn15 vdd vbneu dneuron
Xeh15 xhp15 xhn15 mhp15 mhn15 ehp15 ehn15 vdd gm esub
Xcm_mh16 mhp16 mhn16 vdd cmld
Xcm_xh16 xhp16 xhn16 vdd cmld
Rnd_mh16 mhp16 mhn16 20k
Rnd_xh16 xhp16 xhn16 20k
X_ihm_0_16 a_xp0 a_xn0 wp_ih_0_16 wn_ih_0_16 mhp16 mhn16 vdd vbsyn gsyn
X_ihx_0_16 a_xp0 a_xn0 wp_ih_0_16 wn_ih_0_16 xhp16 xhn16 vdd vbsyn gsyn
X_ihm_1_16 a_xp1 a_xn1 wp_ih_1_16 wn_ih_1_16 mhp16 mhn16 vdd vbsyn gsyn
X_ihx_1_16 a_xp1 a_xn1 wp_ih_1_16 wn_ih_1_16 xhp16 xhn16 vdd vbsyn gsyn
X_ihm_2_16 a_xp2 a_xn2 wp_ih_2_16 wn_ih_2_16 mhp16 mhn16 vdd vbsyn gsyn
X_ihx_2_16 a_xp2 a_xn2 wp_ih_2_16 wn_ih_2_16 xhp16 xhn16 vdd vbsyn gsyn
X_ihm_3_16 a_xp3 a_xn3 wp_ih_3_16 wn_ih_3_16 mhp16 mhn16 vdd vbsyn gsyn
X_ihx_3_16 a_xp3 a_xn3 wp_ih_3_16 wn_ih_3_16 xhp16 xhn16 vdd vbsyn gsyn
X_ihm_4_16 a_xp4 a_xn4 wp_ih_4_16 wn_ih_4_16 mhp16 mhn16 vdd vbsyn gsyn
X_ihx_4_16 a_xp4 a_xn4 wp_ih_4_16 wn_ih_4_16 xhp16 xhn16 vdd vbsyn gsyn
X_ihm_5_16 a_xp5 a_xn5 wp_ih_5_16 wn_ih_5_16 mhp16 mhn16 vdd vbsyn gsyn
X_ihx_5_16 a_xp5 a_xn5 wp_ih_5_16 wn_ih_5_16 xhp16 xhn16 vdd vbsyn gsyn
X_ihm_6_16 a_xp6 a_xn6 wp_ih_6_16 wn_ih_6_16 mhp16 mhn16 vdd vbsyn gsyn
X_ihx_6_16 a_xp6 a_xn6 wp_ih_6_16 wn_ih_6_16 xhp16 xhn16 vdd vbsyn gsyn
X_ihm_7_16 a_xp7 a_xn7 wp_ih_7_16 wn_ih_7_16 mhp16 mhn16 vdd vbsyn gsyn
X_ihx_7_16 a_xp7 a_xn7 wp_ih_7_16 wn_ih_7_16 xhp16 xhn16 vdd vbsyn gsyn
X_ihm_8_16 a_xp8 a_xn8 wp_ih_8_16 wn_ih_8_16 mhp16 mhn16 vdd vbsyn gsyn
X_ihx_8_16 a_xp8 a_xn8 wp_ih_8_16 wn_ih_8_16 xhp16 xhn16 vdd vbsyn gsyn
X_ihm_9_16 a_xp9 a_xn9 wp_ih_9_16 wn_ih_9_16 mhp16 mhn16 vdd vbsyn gsyn
X_ihx_9_16 a_xp9 a_xn9 wp_ih_9_16 wn_ih_9_16 xhp16 xhn16 vdd vbsyn gsyn
X_ihm_10_16 a_xp10 a_xn10 wp_ih_10_16 wn_ih_10_16 mhp16 mhn16 vdd vbsyn gsyn
X_ihx_10_16 a_xp10 a_xn10 wp_ih_10_16 wn_ih_10_16 xhp16 xhn16 vdd vbsyn gsyn
X_ihm_11_16 a_xp11 a_xn11 wp_ih_11_16 wn_ih_11_16 mhp16 mhn16 vdd vbsyn gsyn
X_ihx_11_16 a_xp11 a_xn11 wp_ih_11_16 wn_ih_11_16 xhp16 xhn16 vdd vbsyn gsyn
X_ihm_12_16 a_xp12 a_xn12 wp_ih_12_16 wn_ih_12_16 mhp16 mhn16 vdd vbsyn gsyn
X_ihx_12_16 a_xp12 a_xn12 wp_ih_12_16 wn_ih_12_16 xhp16 xhn16 vdd vbsyn gsyn
X_ihm_13_16 a_xp13 a_xn13 wp_ih_13_16 wn_ih_13_16 mhp16 mhn16 vdd vbsyn gsyn
X_ihx_13_16 a_xp13 a_xn13 wp_ih_13_16 wn_ih_13_16 xhp16 xhn16 vdd vbsyn gsyn
X_ihm_14_16 a_xp14 a_xn14 wp_ih_14_16 wn_ih_14_16 mhp16 mhn16 vdd vbsyn gsyn
X_ihx_14_16 a_xp14 a_xn14 wp_ih_14_16 wn_ih_14_16 xhp16 xhn16 vdd vbsyn gsyn
X_ihm_15_16 a_xp15 a_xn15 wp_ih_15_16 wn_ih_15_16 mhp16 mhn16 vdd vbsyn gsyn
X_ihx_15_16 a_xp15 a_xn15 wp_ih_15_16 wn_ih_15_16 xhp16 xhn16 vdd vbsyn gsyn
Xn16 xhp16 xhn16 ahp16 ahn16 vdd vbneu dneuron
Xeh16 xhp16 xhn16 mhp16 mhn16 ehp16 ehn16 vdd gm esub
Xcm_mh17 mhp17 mhn17 vdd cmld
Xcm_xh17 xhp17 xhn17 vdd cmld
Rnd_mh17 mhp17 mhn17 20k
Rnd_xh17 xhp17 xhn17 20k
X_ihm_0_17 a_xp0 a_xn0 wp_ih_0_17 wn_ih_0_17 mhp17 mhn17 vdd vbsyn gsyn
X_ihx_0_17 a_xp0 a_xn0 wp_ih_0_17 wn_ih_0_17 xhp17 xhn17 vdd vbsyn gsyn
X_ihm_1_17 a_xp1 a_xn1 wp_ih_1_17 wn_ih_1_17 mhp17 mhn17 vdd vbsyn gsyn
X_ihx_1_17 a_xp1 a_xn1 wp_ih_1_17 wn_ih_1_17 xhp17 xhn17 vdd vbsyn gsyn
X_ihm_2_17 a_xp2 a_xn2 wp_ih_2_17 wn_ih_2_17 mhp17 mhn17 vdd vbsyn gsyn
X_ihx_2_17 a_xp2 a_xn2 wp_ih_2_17 wn_ih_2_17 xhp17 xhn17 vdd vbsyn gsyn
X_ihm_3_17 a_xp3 a_xn3 wp_ih_3_17 wn_ih_3_17 mhp17 mhn17 vdd vbsyn gsyn
X_ihx_3_17 a_xp3 a_xn3 wp_ih_3_17 wn_ih_3_17 xhp17 xhn17 vdd vbsyn gsyn
X_ihm_4_17 a_xp4 a_xn4 wp_ih_4_17 wn_ih_4_17 mhp17 mhn17 vdd vbsyn gsyn
X_ihx_4_17 a_xp4 a_xn4 wp_ih_4_17 wn_ih_4_17 xhp17 xhn17 vdd vbsyn gsyn
X_ihm_5_17 a_xp5 a_xn5 wp_ih_5_17 wn_ih_5_17 mhp17 mhn17 vdd vbsyn gsyn
X_ihx_5_17 a_xp5 a_xn5 wp_ih_5_17 wn_ih_5_17 xhp17 xhn17 vdd vbsyn gsyn
X_ihm_6_17 a_xp6 a_xn6 wp_ih_6_17 wn_ih_6_17 mhp17 mhn17 vdd vbsyn gsyn
X_ihx_6_17 a_xp6 a_xn6 wp_ih_6_17 wn_ih_6_17 xhp17 xhn17 vdd vbsyn gsyn
X_ihm_7_17 a_xp7 a_xn7 wp_ih_7_17 wn_ih_7_17 mhp17 mhn17 vdd vbsyn gsyn
X_ihx_7_17 a_xp7 a_xn7 wp_ih_7_17 wn_ih_7_17 xhp17 xhn17 vdd vbsyn gsyn
X_ihm_8_17 a_xp8 a_xn8 wp_ih_8_17 wn_ih_8_17 mhp17 mhn17 vdd vbsyn gsyn
X_ihx_8_17 a_xp8 a_xn8 wp_ih_8_17 wn_ih_8_17 xhp17 xhn17 vdd vbsyn gsyn
X_ihm_9_17 a_xp9 a_xn9 wp_ih_9_17 wn_ih_9_17 mhp17 mhn17 vdd vbsyn gsyn
X_ihx_9_17 a_xp9 a_xn9 wp_ih_9_17 wn_ih_9_17 xhp17 xhn17 vdd vbsyn gsyn
X_ihm_10_17 a_xp10 a_xn10 wp_ih_10_17 wn_ih_10_17 mhp17 mhn17 vdd vbsyn gsyn
X_ihx_10_17 a_xp10 a_xn10 wp_ih_10_17 wn_ih_10_17 xhp17 xhn17 vdd vbsyn gsyn
X_ihm_11_17 a_xp11 a_xn11 wp_ih_11_17 wn_ih_11_17 mhp17 mhn17 vdd vbsyn gsyn
X_ihx_11_17 a_xp11 a_xn11 wp_ih_11_17 wn_ih_11_17 xhp17 xhn17 vdd vbsyn gsyn
X_ihm_12_17 a_xp12 a_xn12 wp_ih_12_17 wn_ih_12_17 mhp17 mhn17 vdd vbsyn gsyn
X_ihx_12_17 a_xp12 a_xn12 wp_ih_12_17 wn_ih_12_17 xhp17 xhn17 vdd vbsyn gsyn
X_ihm_13_17 a_xp13 a_xn13 wp_ih_13_17 wn_ih_13_17 mhp17 mhn17 vdd vbsyn gsyn
X_ihx_13_17 a_xp13 a_xn13 wp_ih_13_17 wn_ih_13_17 xhp17 xhn17 vdd vbsyn gsyn
X_ihm_14_17 a_xp14 a_xn14 wp_ih_14_17 wn_ih_14_17 mhp17 mhn17 vdd vbsyn gsyn
X_ihx_14_17 a_xp14 a_xn14 wp_ih_14_17 wn_ih_14_17 xhp17 xhn17 vdd vbsyn gsyn
X_ihm_15_17 a_xp15 a_xn15 wp_ih_15_17 wn_ih_15_17 mhp17 mhn17 vdd vbsyn gsyn
X_ihx_15_17 a_xp15 a_xn15 wp_ih_15_17 wn_ih_15_17 xhp17 xhn17 vdd vbsyn gsyn
Xn17 xhp17 xhn17 ahp17 ahn17 vdd vbneu dneuron
Xeh17 xhp17 xhn17 mhp17 mhn17 ehp17 ehn17 vdd gm esub
Xcm_mh18 mhp18 mhn18 vdd cmld
Xcm_xh18 xhp18 xhn18 vdd cmld
Rnd_mh18 mhp18 mhn18 20k
Rnd_xh18 xhp18 xhn18 20k
X_ihm_0_18 a_xp0 a_xn0 wp_ih_0_18 wn_ih_0_18 mhp18 mhn18 vdd vbsyn gsyn
X_ihx_0_18 a_xp0 a_xn0 wp_ih_0_18 wn_ih_0_18 xhp18 xhn18 vdd vbsyn gsyn
X_ihm_1_18 a_xp1 a_xn1 wp_ih_1_18 wn_ih_1_18 mhp18 mhn18 vdd vbsyn gsyn
X_ihx_1_18 a_xp1 a_xn1 wp_ih_1_18 wn_ih_1_18 xhp18 xhn18 vdd vbsyn gsyn
X_ihm_2_18 a_xp2 a_xn2 wp_ih_2_18 wn_ih_2_18 mhp18 mhn18 vdd vbsyn gsyn
X_ihx_2_18 a_xp2 a_xn2 wp_ih_2_18 wn_ih_2_18 xhp18 xhn18 vdd vbsyn gsyn
X_ihm_3_18 a_xp3 a_xn3 wp_ih_3_18 wn_ih_3_18 mhp18 mhn18 vdd vbsyn gsyn
X_ihx_3_18 a_xp3 a_xn3 wp_ih_3_18 wn_ih_3_18 xhp18 xhn18 vdd vbsyn gsyn
X_ihm_4_18 a_xp4 a_xn4 wp_ih_4_18 wn_ih_4_18 mhp18 mhn18 vdd vbsyn gsyn
X_ihx_4_18 a_xp4 a_xn4 wp_ih_4_18 wn_ih_4_18 xhp18 xhn18 vdd vbsyn gsyn
X_ihm_5_18 a_xp5 a_xn5 wp_ih_5_18 wn_ih_5_18 mhp18 mhn18 vdd vbsyn gsyn
X_ihx_5_18 a_xp5 a_xn5 wp_ih_5_18 wn_ih_5_18 xhp18 xhn18 vdd vbsyn gsyn
X_ihm_6_18 a_xp6 a_xn6 wp_ih_6_18 wn_ih_6_18 mhp18 mhn18 vdd vbsyn gsyn
X_ihx_6_18 a_xp6 a_xn6 wp_ih_6_18 wn_ih_6_18 xhp18 xhn18 vdd vbsyn gsyn
X_ihm_7_18 a_xp7 a_xn7 wp_ih_7_18 wn_ih_7_18 mhp18 mhn18 vdd vbsyn gsyn
X_ihx_7_18 a_xp7 a_xn7 wp_ih_7_18 wn_ih_7_18 xhp18 xhn18 vdd vbsyn gsyn
X_ihm_8_18 a_xp8 a_xn8 wp_ih_8_18 wn_ih_8_18 mhp18 mhn18 vdd vbsyn gsyn
X_ihx_8_18 a_xp8 a_xn8 wp_ih_8_18 wn_ih_8_18 xhp18 xhn18 vdd vbsyn gsyn
X_ihm_9_18 a_xp9 a_xn9 wp_ih_9_18 wn_ih_9_18 mhp18 mhn18 vdd vbsyn gsyn
X_ihx_9_18 a_xp9 a_xn9 wp_ih_9_18 wn_ih_9_18 xhp18 xhn18 vdd vbsyn gsyn
X_ihm_10_18 a_xp10 a_xn10 wp_ih_10_18 wn_ih_10_18 mhp18 mhn18 vdd vbsyn gsyn
X_ihx_10_18 a_xp10 a_xn10 wp_ih_10_18 wn_ih_10_18 xhp18 xhn18 vdd vbsyn gsyn
X_ihm_11_18 a_xp11 a_xn11 wp_ih_11_18 wn_ih_11_18 mhp18 mhn18 vdd vbsyn gsyn
X_ihx_11_18 a_xp11 a_xn11 wp_ih_11_18 wn_ih_11_18 xhp18 xhn18 vdd vbsyn gsyn
X_ihm_12_18 a_xp12 a_xn12 wp_ih_12_18 wn_ih_12_18 mhp18 mhn18 vdd vbsyn gsyn
X_ihx_12_18 a_xp12 a_xn12 wp_ih_12_18 wn_ih_12_18 xhp18 xhn18 vdd vbsyn gsyn
X_ihm_13_18 a_xp13 a_xn13 wp_ih_13_18 wn_ih_13_18 mhp18 mhn18 vdd vbsyn gsyn
X_ihx_13_18 a_xp13 a_xn13 wp_ih_13_18 wn_ih_13_18 xhp18 xhn18 vdd vbsyn gsyn
X_ihm_14_18 a_xp14 a_xn14 wp_ih_14_18 wn_ih_14_18 mhp18 mhn18 vdd vbsyn gsyn
X_ihx_14_18 a_xp14 a_xn14 wp_ih_14_18 wn_ih_14_18 xhp18 xhn18 vdd vbsyn gsyn
X_ihm_15_18 a_xp15 a_xn15 wp_ih_15_18 wn_ih_15_18 mhp18 mhn18 vdd vbsyn gsyn
X_ihx_15_18 a_xp15 a_xn15 wp_ih_15_18 wn_ih_15_18 xhp18 xhn18 vdd vbsyn gsyn
Xn18 xhp18 xhn18 ahp18 ahn18 vdd vbneu dneuron
Xeh18 xhp18 xhn18 mhp18 mhn18 ehp18 ehn18 vdd gm esub
Xcm_mh19 mhp19 mhn19 vdd cmld
Xcm_xh19 xhp19 xhn19 vdd cmld
Rnd_mh19 mhp19 mhn19 20k
Rnd_xh19 xhp19 xhn19 20k
X_ihm_0_19 a_xp0 a_xn0 wp_ih_0_19 wn_ih_0_19 mhp19 mhn19 vdd vbsyn gsyn
X_ihx_0_19 a_xp0 a_xn0 wp_ih_0_19 wn_ih_0_19 xhp19 xhn19 vdd vbsyn gsyn
X_ihm_1_19 a_xp1 a_xn1 wp_ih_1_19 wn_ih_1_19 mhp19 mhn19 vdd vbsyn gsyn
X_ihx_1_19 a_xp1 a_xn1 wp_ih_1_19 wn_ih_1_19 xhp19 xhn19 vdd vbsyn gsyn
X_ihm_2_19 a_xp2 a_xn2 wp_ih_2_19 wn_ih_2_19 mhp19 mhn19 vdd vbsyn gsyn
X_ihx_2_19 a_xp2 a_xn2 wp_ih_2_19 wn_ih_2_19 xhp19 xhn19 vdd vbsyn gsyn
X_ihm_3_19 a_xp3 a_xn3 wp_ih_3_19 wn_ih_3_19 mhp19 mhn19 vdd vbsyn gsyn
X_ihx_3_19 a_xp3 a_xn3 wp_ih_3_19 wn_ih_3_19 xhp19 xhn19 vdd vbsyn gsyn
X_ihm_4_19 a_xp4 a_xn4 wp_ih_4_19 wn_ih_4_19 mhp19 mhn19 vdd vbsyn gsyn
X_ihx_4_19 a_xp4 a_xn4 wp_ih_4_19 wn_ih_4_19 xhp19 xhn19 vdd vbsyn gsyn
X_ihm_5_19 a_xp5 a_xn5 wp_ih_5_19 wn_ih_5_19 mhp19 mhn19 vdd vbsyn gsyn
X_ihx_5_19 a_xp5 a_xn5 wp_ih_5_19 wn_ih_5_19 xhp19 xhn19 vdd vbsyn gsyn
X_ihm_6_19 a_xp6 a_xn6 wp_ih_6_19 wn_ih_6_19 mhp19 mhn19 vdd vbsyn gsyn
X_ihx_6_19 a_xp6 a_xn6 wp_ih_6_19 wn_ih_6_19 xhp19 xhn19 vdd vbsyn gsyn
X_ihm_7_19 a_xp7 a_xn7 wp_ih_7_19 wn_ih_7_19 mhp19 mhn19 vdd vbsyn gsyn
X_ihx_7_19 a_xp7 a_xn7 wp_ih_7_19 wn_ih_7_19 xhp19 xhn19 vdd vbsyn gsyn
X_ihm_8_19 a_xp8 a_xn8 wp_ih_8_19 wn_ih_8_19 mhp19 mhn19 vdd vbsyn gsyn
X_ihx_8_19 a_xp8 a_xn8 wp_ih_8_19 wn_ih_8_19 xhp19 xhn19 vdd vbsyn gsyn
X_ihm_9_19 a_xp9 a_xn9 wp_ih_9_19 wn_ih_9_19 mhp19 mhn19 vdd vbsyn gsyn
X_ihx_9_19 a_xp9 a_xn9 wp_ih_9_19 wn_ih_9_19 xhp19 xhn19 vdd vbsyn gsyn
X_ihm_10_19 a_xp10 a_xn10 wp_ih_10_19 wn_ih_10_19 mhp19 mhn19 vdd vbsyn gsyn
X_ihx_10_19 a_xp10 a_xn10 wp_ih_10_19 wn_ih_10_19 xhp19 xhn19 vdd vbsyn gsyn
X_ihm_11_19 a_xp11 a_xn11 wp_ih_11_19 wn_ih_11_19 mhp19 mhn19 vdd vbsyn gsyn
X_ihx_11_19 a_xp11 a_xn11 wp_ih_11_19 wn_ih_11_19 xhp19 xhn19 vdd vbsyn gsyn
X_ihm_12_19 a_xp12 a_xn12 wp_ih_12_19 wn_ih_12_19 mhp19 mhn19 vdd vbsyn gsyn
X_ihx_12_19 a_xp12 a_xn12 wp_ih_12_19 wn_ih_12_19 xhp19 xhn19 vdd vbsyn gsyn
X_ihm_13_19 a_xp13 a_xn13 wp_ih_13_19 wn_ih_13_19 mhp19 mhn19 vdd vbsyn gsyn
X_ihx_13_19 a_xp13 a_xn13 wp_ih_13_19 wn_ih_13_19 xhp19 xhn19 vdd vbsyn gsyn
X_ihm_14_19 a_xp14 a_xn14 wp_ih_14_19 wn_ih_14_19 mhp19 mhn19 vdd vbsyn gsyn
X_ihx_14_19 a_xp14 a_xn14 wp_ih_14_19 wn_ih_14_19 xhp19 xhn19 vdd vbsyn gsyn
X_ihm_15_19 a_xp15 a_xn15 wp_ih_15_19 wn_ih_15_19 mhp19 mhn19 vdd vbsyn gsyn
X_ihx_15_19 a_xp15 a_xn15 wp_ih_15_19 wn_ih_15_19 xhp19 xhn19 vdd vbsyn gsyn
Xn19 xhp19 xhn19 ahp19 ahn19 vdd vbneu dneuron
Xeh19 xhp19 xhn19 mhp19 mhn19 ehp19 ehn19 vdd gm esub
Xcm_mo0 mop0 mon0 vdd cmld
Rnd_mo0 mop0 mon0 20k
X_ho_0_0 ahp0 ahn0 wp_ho_0_0 wn_ho_0_0 mop0 mon0 vdd vbsyn gsyn
X_ho_1_0 ahp1 ahn1 wp_ho_1_0 wn_ho_1_0 mop0 mon0 vdd vbsyn gsyn
X_ho_2_0 ahp2 ahn2 wp_ho_2_0 wn_ho_2_0 mop0 mon0 vdd vbsyn gsyn
X_ho_3_0 ahp3 ahn3 wp_ho_3_0 wn_ho_3_0 mop0 mon0 vdd vbsyn gsyn
X_ho_4_0 ahp4 ahn4 wp_ho_4_0 wn_ho_4_0 mop0 mon0 vdd vbsyn gsyn
X_ho_5_0 ahp5 ahn5 wp_ho_5_0 wn_ho_5_0 mop0 mon0 vdd vbsyn gsyn
X_ho_6_0 ahp6 ahn6 wp_ho_6_0 wn_ho_6_0 mop0 mon0 vdd vbsyn gsyn
X_ho_7_0 ahp7 ahn7 wp_ho_7_0 wn_ho_7_0 mop0 mon0 vdd vbsyn gsyn
X_ho_8_0 ahp8 ahn8 wp_ho_8_0 wn_ho_8_0 mop0 mon0 vdd vbsyn gsyn
X_ho_9_0 ahp9 ahn9 wp_ho_9_0 wn_ho_9_0 mop0 mon0 vdd vbsyn gsyn
X_ho_10_0 ahp10 ahn10 wp_ho_10_0 wn_ho_10_0 mop0 mon0 vdd vbsyn gsyn
X_ho_11_0 ahp11 ahn11 wp_ho_11_0 wn_ho_11_0 mop0 mon0 vdd vbsyn gsyn
X_ho_12_0 ahp12 ahn12 wp_ho_12_0 wn_ho_12_0 mop0 mon0 vdd vbsyn gsyn
X_ho_13_0 ahp13 ahn13 wp_ho_13_0 wn_ho_13_0 mop0 mon0 vdd vbsyn gsyn
X_ho_14_0 ahp14 ahn14 wp_ho_14_0 wn_ho_14_0 mop0 mon0 vdd vbsyn gsyn
X_ho_15_0 ahp15 ahn15 wp_ho_15_0 wn_ho_15_0 mop0 mon0 vdd vbsyn gsyn
X_ho_16_0 ahp16 ahn16 wp_ho_16_0 wn_ho_16_0 mop0 mon0 vdd vbsyn gsyn
X_ho_17_0 ahp17 ahn17 wp_ho_17_0 wn_ho_17_0 mop0 mon0 vdd vbsyn gsyn
X_ho_18_0 ahp18 ahn18 wp_ho_18_0 wn_ho_18_0 mop0 mon0 vdd vbsyn gsyn
X_ho_19_0 ahp19 ahn19 wp_ho_19_0 wn_ho_19_0 mop0 mon0 vdd vbsyn gsyn
Xcm_mo1 mop1 mon1 vdd cmld
Rnd_mo1 mop1 mon1 20k
X_ho_0_1 ahp0 ahn0 wp_ho_0_1 wn_ho_0_1 mop1 mon1 vdd vbsyn gsyn
X_ho_1_1 ahp1 ahn1 wp_ho_1_1 wn_ho_1_1 mop1 mon1 vdd vbsyn gsyn
X_ho_2_1 ahp2 ahn2 wp_ho_2_1 wn_ho_2_1 mop1 mon1 vdd vbsyn gsyn
X_ho_3_1 ahp3 ahn3 wp_ho_3_1 wn_ho_3_1 mop1 mon1 vdd vbsyn gsyn
X_ho_4_1 ahp4 ahn4 wp_ho_4_1 wn_ho_4_1 mop1 mon1 vdd vbsyn gsyn
X_ho_5_1 ahp5 ahn5 wp_ho_5_1 wn_ho_5_1 mop1 mon1 vdd vbsyn gsyn
X_ho_6_1 ahp6 ahn6 wp_ho_6_1 wn_ho_6_1 mop1 mon1 vdd vbsyn gsyn
X_ho_7_1 ahp7 ahn7 wp_ho_7_1 wn_ho_7_1 mop1 mon1 vdd vbsyn gsyn
X_ho_8_1 ahp8 ahn8 wp_ho_8_1 wn_ho_8_1 mop1 mon1 vdd vbsyn gsyn
X_ho_9_1 ahp9 ahn9 wp_ho_9_1 wn_ho_9_1 mop1 mon1 vdd vbsyn gsyn
X_ho_10_1 ahp10 ahn10 wp_ho_10_1 wn_ho_10_1 mop1 mon1 vdd vbsyn gsyn
X_ho_11_1 ahp11 ahn11 wp_ho_11_1 wn_ho_11_1 mop1 mon1 vdd vbsyn gsyn
X_ho_12_1 ahp12 ahn12 wp_ho_12_1 wn_ho_12_1 mop1 mon1 vdd vbsyn gsyn
X_ho_13_1 ahp13 ahn13 wp_ho_13_1 wn_ho_13_1 mop1 mon1 vdd vbsyn gsyn
X_ho_14_1 ahp14 ahn14 wp_ho_14_1 wn_ho_14_1 mop1 mon1 vdd vbsyn gsyn
X_ho_15_1 ahp15 ahn15 wp_ho_15_1 wn_ho_15_1 mop1 mon1 vdd vbsyn gsyn
X_ho_16_1 ahp16 ahn16 wp_ho_16_1 wn_ho_16_1 mop1 mon1 vdd vbsyn gsyn
X_ho_17_1 ahp17 ahn17 wp_ho_17_1 wn_ho_17_1 mop1 mon1 vdd vbsyn gsyn
X_ho_18_1 ahp18 ahn18 wp_ho_18_1 wn_ho_18_1 mop1 mon1 vdd vbsyn gsyn
X_ho_19_1 ahp19 ahn19 wp_ho_19_1 wn_ho_19_1 mop1 mon1 vdd vbsyn gsyn
Xcm_mo2 mop2 mon2 vdd cmld
Rnd_mo2 mop2 mon2 20k
X_ho_0_2 ahp0 ahn0 wp_ho_0_2 wn_ho_0_2 mop2 mon2 vdd vbsyn gsyn
X_ho_1_2 ahp1 ahn1 wp_ho_1_2 wn_ho_1_2 mop2 mon2 vdd vbsyn gsyn
X_ho_2_2 ahp2 ahn2 wp_ho_2_2 wn_ho_2_2 mop2 mon2 vdd vbsyn gsyn
X_ho_3_2 ahp3 ahn3 wp_ho_3_2 wn_ho_3_2 mop2 mon2 vdd vbsyn gsyn
X_ho_4_2 ahp4 ahn4 wp_ho_4_2 wn_ho_4_2 mop2 mon2 vdd vbsyn gsyn
X_ho_5_2 ahp5 ahn5 wp_ho_5_2 wn_ho_5_2 mop2 mon2 vdd vbsyn gsyn
X_ho_6_2 ahp6 ahn6 wp_ho_6_2 wn_ho_6_2 mop2 mon2 vdd vbsyn gsyn
X_ho_7_2 ahp7 ahn7 wp_ho_7_2 wn_ho_7_2 mop2 mon2 vdd vbsyn gsyn
X_ho_8_2 ahp8 ahn8 wp_ho_8_2 wn_ho_8_2 mop2 mon2 vdd vbsyn gsyn
X_ho_9_2 ahp9 ahn9 wp_ho_9_2 wn_ho_9_2 mop2 mon2 vdd vbsyn gsyn
X_ho_10_2 ahp10 ahn10 wp_ho_10_2 wn_ho_10_2 mop2 mon2 vdd vbsyn gsyn
X_ho_11_2 ahp11 ahn11 wp_ho_11_2 wn_ho_11_2 mop2 mon2 vdd vbsyn gsyn
X_ho_12_2 ahp12 ahn12 wp_ho_12_2 wn_ho_12_2 mop2 mon2 vdd vbsyn gsyn
X_ho_13_2 ahp13 ahn13 wp_ho_13_2 wn_ho_13_2 mop2 mon2 vdd vbsyn gsyn
X_ho_14_2 ahp14 ahn14 wp_ho_14_2 wn_ho_14_2 mop2 mon2 vdd vbsyn gsyn
X_ho_15_2 ahp15 ahn15 wp_ho_15_2 wn_ho_15_2 mop2 mon2 vdd vbsyn gsyn
X_ho_16_2 ahp16 ahn16 wp_ho_16_2 wn_ho_16_2 mop2 mon2 vdd vbsyn gsyn
X_ho_17_2 ahp17 ahn17 wp_ho_17_2 wn_ho_17_2 mop2 mon2 vdd vbsyn gsyn
X_ho_18_2 ahp18 ahn18 wp_ho_18_2 wn_ho_18_2 mop2 mon2 vdd vbsyn gsyn
X_ho_19_2 ahp19 ahn19 wp_ho_19_2 wn_ho_19_2 mop2 mon2 vdd vbsyn gsyn
Xcm_mo3 mop3 mon3 vdd cmld
Rnd_mo3 mop3 mon3 20k
X_ho_0_3 ahp0 ahn0 wp_ho_0_3 wn_ho_0_3 mop3 mon3 vdd vbsyn gsyn
X_ho_1_3 ahp1 ahn1 wp_ho_1_3 wn_ho_1_3 mop3 mon3 vdd vbsyn gsyn
X_ho_2_3 ahp2 ahn2 wp_ho_2_3 wn_ho_2_3 mop3 mon3 vdd vbsyn gsyn
X_ho_3_3 ahp3 ahn3 wp_ho_3_3 wn_ho_3_3 mop3 mon3 vdd vbsyn gsyn
X_ho_4_3 ahp4 ahn4 wp_ho_4_3 wn_ho_4_3 mop3 mon3 vdd vbsyn gsyn
X_ho_5_3 ahp5 ahn5 wp_ho_5_3 wn_ho_5_3 mop3 mon3 vdd vbsyn gsyn
X_ho_6_3 ahp6 ahn6 wp_ho_6_3 wn_ho_6_3 mop3 mon3 vdd vbsyn gsyn
X_ho_7_3 ahp7 ahn7 wp_ho_7_3 wn_ho_7_3 mop3 mon3 vdd vbsyn gsyn
X_ho_8_3 ahp8 ahn8 wp_ho_8_3 wn_ho_8_3 mop3 mon3 vdd vbsyn gsyn
X_ho_9_3 ahp9 ahn9 wp_ho_9_3 wn_ho_9_3 mop3 mon3 vdd vbsyn gsyn
X_ho_10_3 ahp10 ahn10 wp_ho_10_3 wn_ho_10_3 mop3 mon3 vdd vbsyn gsyn
X_ho_11_3 ahp11 ahn11 wp_ho_11_3 wn_ho_11_3 mop3 mon3 vdd vbsyn gsyn
X_ho_12_3 ahp12 ahn12 wp_ho_12_3 wn_ho_12_3 mop3 mon3 vdd vbsyn gsyn
X_ho_13_3 ahp13 ahn13 wp_ho_13_3 wn_ho_13_3 mop3 mon3 vdd vbsyn gsyn
X_ho_14_3 ahp14 ahn14 wp_ho_14_3 wn_ho_14_3 mop3 mon3 vdd vbsyn gsyn
X_ho_15_3 ahp15 ahn15 wp_ho_15_3 wn_ho_15_3 mop3 mon3 vdd vbsyn gsyn
X_ho_16_3 ahp16 ahn16 wp_ho_16_3 wn_ho_16_3 mop3 mon3 vdd vbsyn gsyn
X_ho_17_3 ahp17 ahn17 wp_ho_17_3 wn_ho_17_3 mop3 mon3 vdd vbsyn gsyn
X_ho_18_3 ahp18 ahn18 wp_ho_18_3 wn_ho_18_3 mop3 mon3 vdd vbsyn gsyn
X_ho_19_3 ahp19 ahn19 wp_ho_19_3 wn_ho_19_3 mop3 mon3 vdd vbsyn gsyn
Xcm_mo4 mop4 mon4 vdd cmld
Rnd_mo4 mop4 mon4 20k
X_ho_0_4 ahp0 ahn0 wp_ho_0_4 wn_ho_0_4 mop4 mon4 vdd vbsyn gsyn
X_ho_1_4 ahp1 ahn1 wp_ho_1_4 wn_ho_1_4 mop4 mon4 vdd vbsyn gsyn
X_ho_2_4 ahp2 ahn2 wp_ho_2_4 wn_ho_2_4 mop4 mon4 vdd vbsyn gsyn
X_ho_3_4 ahp3 ahn3 wp_ho_3_4 wn_ho_3_4 mop4 mon4 vdd vbsyn gsyn
X_ho_4_4 ahp4 ahn4 wp_ho_4_4 wn_ho_4_4 mop4 mon4 vdd vbsyn gsyn
X_ho_5_4 ahp5 ahn5 wp_ho_5_4 wn_ho_5_4 mop4 mon4 vdd vbsyn gsyn
X_ho_6_4 ahp6 ahn6 wp_ho_6_4 wn_ho_6_4 mop4 mon4 vdd vbsyn gsyn
X_ho_7_4 ahp7 ahn7 wp_ho_7_4 wn_ho_7_4 mop4 mon4 vdd vbsyn gsyn
X_ho_8_4 ahp8 ahn8 wp_ho_8_4 wn_ho_8_4 mop4 mon4 vdd vbsyn gsyn
X_ho_9_4 ahp9 ahn9 wp_ho_9_4 wn_ho_9_4 mop4 mon4 vdd vbsyn gsyn
X_ho_10_4 ahp10 ahn10 wp_ho_10_4 wn_ho_10_4 mop4 mon4 vdd vbsyn gsyn
X_ho_11_4 ahp11 ahn11 wp_ho_11_4 wn_ho_11_4 mop4 mon4 vdd vbsyn gsyn
X_ho_12_4 ahp12 ahn12 wp_ho_12_4 wn_ho_12_4 mop4 mon4 vdd vbsyn gsyn
X_ho_13_4 ahp13 ahn13 wp_ho_13_4 wn_ho_13_4 mop4 mon4 vdd vbsyn gsyn
X_ho_14_4 ahp14 ahn14 wp_ho_14_4 wn_ho_14_4 mop4 mon4 vdd vbsyn gsyn
X_ho_15_4 ahp15 ahn15 wp_ho_15_4 wn_ho_15_4 mop4 mon4 vdd vbsyn gsyn
X_ho_16_4 ahp16 ahn16 wp_ho_16_4 wn_ho_16_4 mop4 mon4 vdd vbsyn gsyn
X_ho_17_4 ahp17 ahn17 wp_ho_17_4 wn_ho_17_4 mop4 mon4 vdd vbsyn gsyn
X_ho_18_4 ahp18 ahn18 wp_ho_18_4 wn_ho_18_4 mop4 mon4 vdd vbsyn gsyn
X_ho_19_4 ahp19 ahn19 wp_ho_19_4 wn_ho_19_4 mop4 mon4 vdd vbsyn gsyn
.options gmin=1e-10
.end
