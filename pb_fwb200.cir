batched
.model NNR NMOS (LEVEL=1 VTO=0.2 KP=120u LAMBDA=0.02 GAMMA=0 PHI=0.7)
.model PNR PMOS (LEVEL=1 VTO=-0.2 KP=40u LAMBDA=0.02 GAMMA=0 PHI=0.7)
.subckt gsyn inp inn wp wn outp outn vdd vbn
Mtail nt vbn 0 0 NNR W=400u L=100u
M5 na wp s5 0 NNR W=200u L=100u
Rd5 s5 nt 12k
M6 nb wn s6 0 NNR W=200u L=100u
Rd6 s6 nt 12k
M1 outp inp s1 0 NNR W=200u L=100u
Rd1 s1 na 12k
M2 outn inn s2 0 NNR W=200u L=100u
Rd2 s2 na 12k
M3 outn inp s3 0 NNR W=200u L=100u
Rd3 s3 nb 12k
M4 outp inn s4 0 NNR W=200u L=100u
Rd4 s4 nb 12k
.ends
.subckt cmld p n vdd
Rcs1 p cmx 300k
Rcs2 n cmx 300k
MLp p cmx vdd vdd PNR W=32000u L=100u
MLn n cmx vdd vdd PNR W=32000u L=100u
.ends
.subckt dneuron up un ap an vdd vbn
M1 an up tn 0 NNR W=200u L=100u
M2 ap un tn 0 NNR W=200u L=100u
Mt tn vbn 0 0 NNR W=200u L=100u
Xcm ap an vdd cmld
.ends

Vdd vdd 0 1.0
Vbsyn vbsyn 0 0.6
Vbbk vbbk 0 0.30
Vbneu vbneu 0 0.35
Vgm gm 0 0.6
Vxp0 a_xp0 0 PWL(0.01n 0.4841 14.00n 0.4841 14.01n 0.4640 28.00n 0.4640 28.01n 0.4840 42.00n 0.4840 42.01n 0.4537 56.00n 0.4537 56.01n 0.4028 70.00n 0.4028 70.01n 0.5442 84.00n 0.5442 84.01n 0.4306 98.00n 0.4306 98.01n 0.5050 112.00n 0.5050 112.01n 0.4248 126.00n 0.4248 126.01n 0.4673 140.00n 0.4673 140.01n 0.4183 154.00n 0.4183 154.01n 0.4605 168.00n 0.4605 168.01n 0.4717 182.00n 0.4717 182.01n 0.4492 196.00n 0.4492 196.01n 0.4512 210.00n 0.4512 210.01n 0.4017 224.00n 0.4017 224.01n 0.5409 238.00n 0.5409 238.01n 0.4413 252.00n 0.4413 252.01n 0.4639 266.00n 0.4639 266.01n 0.4405 280.00n 0.4405 280.01n 0.5430 294.00n 0.5430 294.01n 0.5054 308.00n 0.5054 308.01n 0.5167 322.00n 0.5167 322.01n 0.4509 336.00n 0.4509 336.01n 0.5471 350.00n 0.5471 350.01n 0.4557 364.00n 0.4557 364.01n 0.4762 378.00n 0.4762 378.01n 0.5350 392.00n 0.5350 392.01n 0.4655 406.00n 0.4655 406.01n 0.4543 420.00n 0.4543 420.01n 0.4436 434.00n 0.4436 434.01n 0.5486 448.00n 0.5486 448.01n 0.4490 462.00n 0.4490 462.01n 0.4224 476.00n 0.4224 476.01n 0.5120 490.00n 0.5120 490.01n 0.5684 504.00n 0.5684 504.01n 0.4039 518.00n 0.4039 518.01n 0.5800 532.00n 0.5800 532.01n 0.4872 546.00n 0.4872 546.01n 0.4457 560.00n 0.4457 560.01n 0.4568 574.00n 0.4568 574.01n 0.4999 588.00n 0.4999 588.01n 0.5459 602.00n 0.5459 602.01n 0.4185 616.00n 0.4185 616.01n 0.5368 630.00n 0.5368 630.01n 0.4777 644.00n 0.4777 644.01n 0.5582 658.00n 0.5582 658.01n 0.4826 672.00n 0.4826 672.01n 0.4836 686.00n 0.4836 686.01n 0.4272)
Vxn0 a_xn0 0 PWL(0.01n 0.5159 14.00n 0.5159 14.01n 0.5360 28.00n 0.5360 28.01n 0.5160 42.00n 0.5160 42.01n 0.5463 56.00n 0.5463 56.01n 0.5972 70.00n 0.5972 70.01n 0.4558 84.00n 0.4558 84.01n 0.5694 98.00n 0.5694 98.01n 0.4950 112.00n 0.4950 112.01n 0.5752 126.00n 0.5752 126.01n 0.5327 140.00n 0.5327 140.01n 0.5817 154.00n 0.5817 154.01n 0.5395 168.00n 0.5395 168.01n 0.5283 182.00n 0.5283 182.01n 0.5508 196.00n 0.5508 196.01n 0.5488 210.00n 0.5488 210.01n 0.5983 224.00n 0.5983 224.01n 0.4591 238.00n 0.4591 238.01n 0.5587 252.00n 0.5587 252.01n 0.5361 266.00n 0.5361 266.01n 0.5595 280.00n 0.5595 280.01n 0.4570 294.00n 0.4570 294.01n 0.4946 308.00n 0.4946 308.01n 0.4833 322.00n 0.4833 322.01n 0.5491 336.00n 0.5491 336.01n 0.4529 350.00n 0.4529 350.01n 0.5443 364.00n 0.5443 364.01n 0.5238 378.00n 0.5238 378.01n 0.4650 392.00n 0.4650 392.01n 0.5345 406.00n 0.5345 406.01n 0.5457 420.00n 0.5457 420.01n 0.5564 434.00n 0.5564 434.01n 0.4514 448.00n 0.4514 448.01n 0.5510 462.00n 0.5510 462.01n 0.5776 476.00n 0.5776 476.01n 0.4880 490.00n 0.4880 490.01n 0.4316 504.00n 0.4316 504.01n 0.5961 518.00n 0.5961 518.01n 0.4200 532.00n 0.4200 532.01n 0.5128 546.00n 0.5128 546.01n 0.5543 560.00n 0.5543 560.01n 0.5432 574.00n 0.5432 574.01n 0.5001 588.00n 0.5001 588.01n 0.4541 602.00n 0.4541 602.01n 0.5815 616.00n 0.5815 616.01n 0.4632 630.00n 0.4632 630.01n 0.5223 644.00n 0.5223 644.01n 0.4418 658.00n 0.4418 658.01n 0.5174 672.00n 0.5174 672.01n 0.5164 686.00n 0.5164 686.01n 0.5728)
Vxp1 a_xp1 0 PWL(0.01n 0.5682 14.00n 0.5682 14.01n 0.5677 28.00n 0.5677 28.01n 0.4414 42.00n 0.4414 42.01n 0.5418 56.00n 0.5418 56.01n 0.4645 70.00n 0.4645 70.01n 0.5423 84.00n 0.5423 84.01n 0.4426 98.00n 0.4426 98.01n 0.4338 112.00n 0.4338 112.01n 0.4393 126.00n 0.4393 126.01n 0.4389 140.00n 0.4389 140.01n 0.5171 154.00n 0.5171 154.01n 0.4623 168.00n 0.4623 168.01n 0.5577 182.00n 0.5577 182.01n 0.5763 196.00n 0.5763 196.01n 0.5346 210.00n 0.5346 210.01n 0.5121 224.00n 0.5121 224.01n 0.5172 238.00n 0.5172 238.01n 0.4707 252.00n 0.4707 252.01n 0.4112 266.00n 0.4112 266.01n 0.4983 280.00n 0.4983 280.01n 0.5184 294.00n 0.5184 294.01n 0.5529 308.00n 0.5529 308.01n 0.4410 322.00n 0.4410 322.01n 0.4385 336.00n 0.4385 336.01n 0.4696 350.00n 0.4696 350.01n 0.5756 364.00n 0.5756 364.01n 0.5464 378.00n 0.5464 378.01n 0.5287 392.00n 0.5287 392.01n 0.5421 406.00n 0.5421 406.01n 0.5686 420.00n 0.5686 420.01n 0.4357 434.00n 0.4357 434.01n 0.4561 448.00n 0.4561 448.01n 0.4282 462.00n 0.4282 462.01n 0.4842 476.00n 0.4842 476.01n 0.5489 490.00n 0.5489 490.01n 0.5499 504.00n 0.5499 504.01n 0.5230 518.00n 0.5230 518.01n 0.4951 532.00n 0.4951 532.01n 0.4530 546.00n 0.4530 546.01n 0.5705 560.00n 0.5705 560.01n 0.4490 574.00n 0.4490 574.01n 0.5651 588.00n 0.5651 588.01n 0.4657 602.00n 0.4657 602.01n 0.4446 616.00n 0.4446 616.01n 0.5501 630.00n 0.5501 630.01n 0.5550 644.00n 0.5550 644.01n 0.4368 658.00n 0.4368 658.01n 0.5659 672.00n 0.5659 672.01n 0.5792 686.00n 0.5792 686.01n 0.5075)
Vxn1 a_xn1 0 PWL(0.01n 0.4318 14.00n 0.4318 14.01n 0.4323 28.00n 0.4323 28.01n 0.5586 42.00n 0.5586 42.01n 0.4582 56.00n 0.4582 56.01n 0.5355 70.00n 0.5355 70.01n 0.4577 84.00n 0.4577 84.01n 0.5574 98.00n 0.5574 98.01n 0.5662 112.00n 0.5662 112.01n 0.5607 126.00n 0.5607 126.01n 0.5611 140.00n 0.5611 140.01n 0.4829 154.00n 0.4829 154.01n 0.5377 168.00n 0.5377 168.01n 0.4423 182.00n 0.4423 182.01n 0.4237 196.00n 0.4237 196.01n 0.4654 210.00n 0.4654 210.01n 0.4879 224.00n 0.4879 224.01n 0.4828 238.00n 0.4828 238.01n 0.5293 252.00n 0.5293 252.01n 0.5888 266.00n 0.5888 266.01n 0.5017 280.00n 0.5017 280.01n 0.4816 294.00n 0.4816 294.01n 0.4471 308.00n 0.4471 308.01n 0.5590 322.00n 0.5590 322.01n 0.5615 336.00n 0.5615 336.01n 0.5304 350.00n 0.5304 350.01n 0.4244 364.00n 0.4244 364.01n 0.4536 378.00n 0.4536 378.01n 0.4713 392.00n 0.4713 392.01n 0.4579 406.00n 0.4579 406.01n 0.4314 420.00n 0.4314 420.01n 0.5643 434.00n 0.5643 434.01n 0.5439 448.00n 0.5439 448.01n 0.5718 462.00n 0.5718 462.01n 0.5158 476.00n 0.5158 476.01n 0.4511 490.00n 0.4511 490.01n 0.4501 504.00n 0.4501 504.01n 0.4770 518.00n 0.4770 518.01n 0.5049 532.00n 0.5049 532.01n 0.5470 546.00n 0.5470 546.01n 0.4295 560.00n 0.4295 560.01n 0.5510 574.00n 0.5510 574.01n 0.4349 588.00n 0.4349 588.01n 0.5343 602.00n 0.5343 602.01n 0.5554 616.00n 0.5554 616.01n 0.4499 630.00n 0.4499 630.01n 0.4450 644.00n 0.4450 644.01n 0.5632 658.00n 0.5632 658.01n 0.4341 672.00n 0.4341 672.01n 0.4208 686.00n 0.4208 686.01n 0.4925)
Vxp2 a_xp2 0 PWL(0.01n 0.8000 14.00n 0.8000 14.01n 0.8000 28.00n 0.8000 28.01n 0.8000 42.00n 0.8000 42.01n 0.8000 56.00n 0.8000 56.01n 0.8000 70.00n 0.8000 70.01n 0.8000 84.00n 0.8000 84.01n 0.8000 98.00n 0.8000 98.01n 0.8000 112.00n 0.8000 112.01n 0.8000 126.00n 0.8000 126.01n 0.8000 140.00n 0.8000 140.01n 0.8000 154.00n 0.8000 154.01n 0.8000 168.00n 0.8000 168.01n 0.8000 182.00n 0.8000 182.01n 0.8000 196.00n 0.8000 196.01n 0.8000 210.00n 0.8000 210.01n 0.8000 224.00n 0.8000 224.01n 0.8000 238.00n 0.8000 238.01n 0.8000 252.00n 0.8000 252.01n 0.8000 266.00n 0.8000 266.01n 0.8000 280.00n 0.8000 280.01n 0.8000 294.00n 0.8000 294.01n 0.8000 308.00n 0.8000 308.01n 0.8000 322.00n 0.8000 322.01n 0.8000 336.00n 0.8000 336.01n 0.8000 350.00n 0.8000 350.01n 0.8000 364.00n 0.8000 364.01n 0.8000 378.00n 0.8000 378.01n 0.8000 392.00n 0.8000 392.01n 0.8000 406.00n 0.8000 406.01n 0.8000 420.00n 0.8000 420.01n 0.8000 434.00n 0.8000 434.01n 0.8000 448.00n 0.8000 448.01n 0.8000 462.00n 0.8000 462.01n 0.8000 476.00n 0.8000 476.01n 0.8000 490.00n 0.8000 490.01n 0.8000 504.00n 0.8000 504.01n 0.8000 518.00n 0.8000 518.01n 0.8000 532.00n 0.8000 532.01n 0.8000 546.00n 0.8000 546.01n 0.8000 560.00n 0.8000 560.01n 0.8000 574.00n 0.8000 574.01n 0.8000 588.00n 0.8000 588.01n 0.8000 602.00n 0.8000 602.01n 0.8000 616.00n 0.8000 616.01n 0.8000 630.00n 0.8000 630.01n 0.8000 644.00n 0.8000 644.01n 0.8000 658.00n 0.8000 658.01n 0.8000 672.00n 0.8000 672.01n 0.8000 686.00n 0.8000 686.01n 0.8000)
Vxn2 a_xn2 0 PWL(0.01n 0.2000 14.00n 0.2000 14.01n 0.2000 28.00n 0.2000 28.01n 0.2000 42.00n 0.2000 42.01n 0.2000 56.00n 0.2000 56.01n 0.2000 70.00n 0.2000 70.01n 0.2000 84.00n 0.2000 84.01n 0.2000 98.00n 0.2000 98.01n 0.2000 112.00n 0.2000 112.01n 0.2000 126.00n 0.2000 126.01n 0.2000 140.00n 0.2000 140.01n 0.2000 154.00n 0.2000 154.01n 0.2000 168.00n 0.2000 168.01n 0.2000 182.00n 0.2000 182.01n 0.2000 196.00n 0.2000 196.01n 0.2000 210.00n 0.2000 210.01n 0.2000 224.00n 0.2000 224.01n 0.2000 238.00n 0.2000 238.01n 0.2000 252.00n 0.2000 252.01n 0.2000 266.00n 0.2000 266.01n 0.2000 280.00n 0.2000 280.01n 0.2000 294.00n 0.2000 294.01n 0.2000 308.00n 0.2000 308.01n 0.2000 322.00n 0.2000 322.01n 0.2000 336.00n 0.2000 336.01n 0.2000 350.00n 0.2000 350.01n 0.2000 364.00n 0.2000 364.01n 0.2000 378.00n 0.2000 378.01n 0.2000 392.00n 0.2000 392.01n 0.2000 406.00n 0.2000 406.01n 0.2000 420.00n 0.2000 420.01n 0.2000 434.00n 0.2000 434.01n 0.2000 448.00n 0.2000 448.01n 0.2000 462.00n 0.2000 462.01n 0.2000 476.00n 0.2000 476.01n 0.2000 490.00n 0.2000 490.01n 0.2000 504.00n 0.2000 504.01n 0.2000 518.00n 0.2000 518.01n 0.2000 532.00n 0.2000 532.01n 0.2000 546.00n 0.2000 546.01n 0.2000 560.00n 0.2000 560.01n 0.2000 574.00n 0.2000 574.01n 0.2000 588.00n 0.2000 588.01n 0.2000 602.00n 0.2000 602.01n 0.2000 616.00n 0.2000 616.01n 0.2000 630.00n 0.2000 630.01n 0.2000 644.00n 0.2000 644.01n 0.2000 658.00n 0.2000 658.01n 0.2000 672.00n 0.2000 672.01n 0.2000 686.00n 0.2000 686.01n 0.2000)
Vwp_ih_0_0 wp_ih_0_0 0 0.5015961914121352
Vwn_ih_0_0 wn_ih_0_0 0 0.49840380858786476
Vwp_ih_1_0 wp_ih_1_0 0 0.4721913220181151
Vwn_ih_1_0 wn_ih_1_0 0 0.5278086779818849
Vwp_ih_2_0 wp_ih_2_0 0 0.5294517885057279
Vwn_ih_2_0 wn_ih_2_0 0 0.470548211494272
Vwp_ih_0_1 wp_ih_0_1 0 0.49965321126026296
Vwn_ih_0_1 wn_ih_0_1 0 0.500346788739737
Vwp_ih_1_1 wp_ih_1_1 0 0.49600621355531704
Vwn_ih_1_1 wn_ih_1_1 0 0.503993786444683
Vwp_ih_2_1 wp_ih_2_1 0 0.8563771059398373
Vwn_ih_2_1 wn_ih_2_1 0 0.3
Vwp_ih_0_2 wp_ih_0_2 0 0.5018039398595999
Vwn_ih_0_2 wn_ih_0_2 0 0.4981960601404
Vwp_ih_1_2 wp_ih_1_2 0 0.4844999124616263
Vwn_ih_1_2 wn_ih_1_2 0 0.5155000875383736
Vwp_ih_2_2 wp_ih_2_2 0 0.5883139904909326
Vwn_ih_2_2 wn_ih_2_2 0 0.4116860095090674
Vwp_ih_0_3 wp_ih_0_3 0 0.5221693899188388
Vwn_ih_0_3 wn_ih_0_3 0 0.4778306100811612
Vwp_ih_1_3 wp_ih_1_3 0 0.48118101366688937
Vwn_ih_1_3 wn_ih_1_3 0 0.5188189863331106
Vwp_ih_2_3 wp_ih_2_3 0 0.5256244745518766
Vwn_ih_2_3 wn_ih_2_3 0 0.4743755254481235
Vwp_ih_0_4 wp_ih_0_4 0 0.6193054834278936
Vwn_ih_0_4 wn_ih_0_4 0 0.38069451657210635
Vwp_ih_1_4 wp_ih_1_4 0 0.6199928792924294
Vwn_ih_1_4 wn_ih_1_4 0 0.38000712070757064
Vwp_ih_2_4 wp_ih_2_4 0 0.42437266812493346
Vwn_ih_2_4 wn_ih_2_4 0 0.5756273318750665
Vwp_ih_0_5 wp_ih_0_5 0 0.3
Vwn_ih_0_5 wn_ih_0_5 0 0.7127803368830876
Vwp_ih_1_5 wp_ih_1_5 0 0.43618094736728785
Vwn_ih_1_5 wn_ih_1_5 0 0.5638190526327121
Vwp_ih_2_5 wp_ih_2_5 0 0.7394435417519335
Vwn_ih_2_5 wn_ih_2_5 0 0.3
Vwp_ih_0_6 wp_ih_0_6 0 0.7122911518033954
Vwn_ih_0_6 wn_ih_0_6 0 0.3
Vwp_ih_1_6 wp_ih_1_6 0 0.3
Vwn_ih_1_6 wn_ih_1_6 0 0.7118663919561024
Vwp_ih_2_6 wp_ih_2_6 0 0.8989556356260399
Vwn_ih_2_6 wn_ih_2_6 0 0.3
Vwp_ih_0_7 wp_ih_0_7 0 0.899
Vwn_ih_0_7 wn_ih_0_7 0 0.3
Vwp_ih_1_7 wp_ih_1_7 0 0.3
Vwn_ih_1_7 wn_ih_1_7 0 0.7024679173045323
Vwp_ih_2_7 wp_ih_2_7 0 0.7529205324146118
Vwn_ih_2_7 wn_ih_2_7 0 0.3
Vwp_ih_0_8 wp_ih_0_8 0 0.3
Vwn_ih_0_8 wn_ih_0_8 0 0.8018026226080588
Vwp_ih_1_8 wp_ih_1_8 0 0.5790948816816694
Vwn_ih_1_8 wn_ih_1_8 0 0.4209051183183306
Vwp_ih_2_8 wp_ih_2_8 0 0.8986139538622874
Vwn_ih_2_8 wn_ih_2_8 0 0.3
Vwp_ih_0_9 wp_ih_0_9 0 0.6511415939318244
Vwn_ih_0_9 wn_ih_0_9 0 0.34885840606817564
Vwp_ih_1_9 wp_ih_1_9 0 0.34360778806389625
Vwn_ih_1_9 wn_ih_1_9 0 0.6563922119361038
Vwp_ih_2_9 wp_ih_2_9 0 0.7034455864825282
Vwn_ih_2_9 wn_ih_2_9 0 0.3
Vwp_ih_0_10 wp_ih_0_10 0 0.3
Vwn_ih_0_10 wn_ih_0_10 0 0.899
Vwp_ih_1_10 wp_ih_1_10 0 0.3
Vwn_ih_1_10 wn_ih_1_10 0 0.7068508090057325
Vwp_ih_2_10 wp_ih_2_10 0 0.7070887509081587
Vwn_ih_2_10 wn_ih_2_10 0 0.3
Vwp_ih_0_11 wp_ih_0_11 0 0.3595795270189186
Vwn_ih_0_11 wn_ih_0_11 0 0.6404204729810814
Vwp_ih_1_11 wp_ih_1_11 0 0.899
Vwn_ih_1_11 wn_ih_1_11 0 0.3
Vwp_ih_2_11 wp_ih_2_11 0 0.6858796499915715
Vwn_ih_2_11 wn_ih_2_11 0 0.31412035000842853
Vwp_ih_0_12 wp_ih_0_12 0 0.5149356891060468
Vwn_ih_0_12 wn_ih_0_12 0 0.4850643108939532
Vwp_ih_1_12 wp_ih_1_12 0 0.48872865749737515
Vwn_ih_1_12 wn_ih_1_12 0 0.5112713425026248
Vwp_ih_2_12 wp_ih_2_12 0 0.5332255961882026
Vwn_ih_2_12 wn_ih_2_12 0 0.46677440381179736
Vwp_ih_0_13 wp_ih_0_13 0 0.6904384478204506
Vwn_ih_0_13 wn_ih_0_13 0 0.30956155217954945
Vwp_ih_1_13 wp_ih_1_13 0 0.899
Vwn_ih_1_13 wn_ih_1_13 0 0.3
Vwp_ih_2_13 wp_ih_2_13 0 0.7002613312913651
Vwn_ih_2_13 wn_ih_2_13 0 0.3
Vwp_ih_0_14 wp_ih_0_14 0 0.3
Vwn_ih_0_14 wn_ih_0_14 0 0.8219384910858603
Vwp_ih_1_14 wp_ih_1_14 0 0.4763372667742629
Vwn_ih_1_14 wn_ih_1_14 0 0.5236627332257371
Vwp_ih_2_14 wp_ih_2_14 0 0.8985689255626176
Vwn_ih_2_14 wn_ih_2_14 0 0.3
Vwp_ih_0_15 wp_ih_0_15 0 0.3
Vwn_ih_0_15 wn_ih_0_15 0 0.8560568394344359
Vwp_ih_1_15 wp_ih_1_15 0 0.8942231918478987
Vwn_ih_1_15 wn_ih_1_15 0 0.3
Vwp_ih_2_15 wp_ih_2_15 0 0.7247685300228742
Vwn_ih_2_15 wn_ih_2_15 0 0.3
Vwp_ih_0_16 wp_ih_0_16 0 0.3
Vwn_ih_0_16 wn_ih_0_16 0 0.7353714060857697
Vwp_ih_1_16 wp_ih_1_16 0 0.3
Vwn_ih_1_16 wn_ih_1_16 0 0.8979326969515629
Vwp_ih_2_16 wp_ih_2_16 0 0.6988403856974688
Vwn_ih_2_16 wn_ih_2_16 0 0.3011596143025312
Vwp_ih_0_17 wp_ih_0_17 0 0.899
Vwn_ih_0_17 wn_ih_0_17 0 0.3
Vwp_ih_1_17 wp_ih_1_17 0 0.5847379600067851
Vwn_ih_1_17 wn_ih_1_17 0 0.41526203999321487
Vwp_ih_2_17 wp_ih_2_17 0 0.6730212084723664
Vwn_ih_2_17 wn_ih_2_17 0 0.32697879152763365
Vwp_ih_0_18 wp_ih_0_18 0 0.49953034189273476
Vwn_ih_0_18 wn_ih_0_18 0 0.5004696581072653
Vwp_ih_1_18 wp_ih_1_18 0 0.49308843699887794
Vwn_ih_1_18 wn_ih_1_18 0 0.5069115630011221
Vwp_ih_2_18 wp_ih_2_18 0 0.6805357461272175
Vwn_ih_2_18 wn_ih_2_18 0 0.31946425387278254
Vwp_ih_0_19 wp_ih_0_19 0 0.5001650690334711
Vwn_ih_0_19 wn_ih_0_19 0 0.4998349309665288
Vwp_ih_1_19 wp_ih_1_19 0 0.504232464745178
Vwn_ih_1_19 wn_ih_1_19 0 0.495767535254822
Vwp_ih_2_19 wp_ih_2_19 0 0.3
Vwn_ih_2_19 wn_ih_2_19 0 0.7810586488398557
Vwp_ih_0_20 wp_ih_0_20 0 0.4910631772006239
Vwn_ih_0_20 wn_ih_0_20 0 0.508936822799376
Vwp_ih_1_20 wp_ih_1_20 0 0.4938288182770894
Vwn_ih_1_20 wn_ih_1_20 0 0.5061711817229106
Vwp_ih_2_20 wp_ih_2_20 0 0.5171445248354164
Vwn_ih_2_20 wn_ih_2_20 0 0.48285547516458366
Vwp_ih_0_21 wp_ih_0_21 0 0.37387199536404486
Vwn_ih_0_21 wn_ih_0_21 0 0.6261280046359552
Vwp_ih_1_21 wp_ih_1_21 0 0.3
Vwn_ih_1_21 wn_ih_1_21 0 0.899
Vwp_ih_2_21 wp_ih_2_21 0 0.32312960199337726
Vwn_ih_2_21 wn_ih_2_21 0 0.6768703980066227
Vwp_ih_0_22 wp_ih_0_22 0 0.4685719104993739
Vwn_ih_0_22 wn_ih_0_22 0 0.531428089500626
Vwp_ih_1_22 wp_ih_1_22 0 0.5603647066994288
Vwn_ih_1_22 wn_ih_1_22 0 0.4396352933005711
Vwp_ih_2_22 wp_ih_2_22 0 0.4447148231951723
Vwn_ih_2_22 wn_ih_2_22 0 0.5552851768048277
Vwp_ih_0_23 wp_ih_0_23 0 0.5794994506612545
Vwn_ih_0_23 wn_ih_0_23 0 0.4205005493387455
Vwp_ih_1_23 wp_ih_1_23 0 0.3
Vwn_ih_1_23 wn_ih_1_23 0 0.8112661563883903
Vwp_ih_2_23 wp_ih_2_23 0 0.8988365816328003
Vwn_ih_2_23 wn_ih_2_23 0 0.3
Vwp_ih_0_24 wp_ih_0_24 0 0.4518541968243787
Vwn_ih_0_24 wn_ih_0_24 0 0.5481458031756213
Vwp_ih_1_24 wp_ih_1_24 0 0.41471205175626047
Vwn_ih_1_24 wn_ih_1_24 0 0.5852879482437395
Vwp_ih_2_24 wp_ih_2_24 0 0.5316387413826326
Vwn_ih_2_24 wn_ih_2_24 0 0.46836125861736744
Vwp_ih_0_25 wp_ih_0_25 0 0.5721427487060229
Vwn_ih_0_25 wn_ih_0_25 0 0.4278572512939771
Vwp_ih_1_25 wp_ih_1_25 0 0.4608282124150054
Vwn_ih_1_25 wn_ih_1_25 0 0.5391717875849946
Vwp_ih_2_25 wp_ih_2_25 0 0.5611917286519635
Vwn_ih_2_25 wn_ih_2_25 0 0.4388082713480364
Vwp_ih_0_26 wp_ih_0_26 0 0.3
Vwn_ih_0_26 wn_ih_0_26 0 0.711006428833458
Vwp_ih_1_26 wp_ih_1_26 0 0.4857923976506053
Vwn_ih_1_26 wn_ih_1_26 0 0.5142076023493947
Vwp_ih_2_26 wp_ih_2_26 0 0.7222958433163246
Vwn_ih_2_26 wn_ih_2_26 0 0.3
Vwp_ih_0_27 wp_ih_0_27 0 0.5007242001910995
Vwn_ih_0_27 wn_ih_0_27 0 0.49927579980890047
Vwp_ih_1_27 wp_ih_1_27 0 0.4872205004174196
Vwn_ih_1_27 wn_ih_1_27 0 0.5127794995825804
Vwp_ih_2_27 wp_ih_2_27 0 0.568876396662028
Vwn_ih_2_27 wn_ih_2_27 0 0.4311236033379719
Vwp_ih_0_28 wp_ih_0_28 0 0.6953673545424982
Vwn_ih_0_28 wn_ih_0_28 0 0.3046326454575018
Vwp_ih_1_28 wp_ih_1_28 0 0.3
Vwn_ih_1_28 wn_ih_1_28 0 0.8984012729335407
Vwp_ih_2_28 wp_ih_2_28 0 0.6521121204142244
Vwn_ih_2_28 wn_ih_2_28 0 0.3478878795857756
Vwp_ih_0_29 wp_ih_0_29 0 0.5005840617435902
Vwn_ih_0_29 wn_ih_0_29 0 0.4994159382564098
Vwp_ih_1_29 wp_ih_1_29 0 0.504369825937839
Vwn_ih_1_29 wn_ih_1_29 0 0.4956301740621611
Vwp_ih_2_29 wp_ih_2_29 0 0.3
Vwn_ih_2_29 wn_ih_2_29 0 0.7974435117065903
Vwp_ih_0_30 wp_ih_0_30 0 0.7520363832075572
Vwn_ih_0_30 wn_ih_0_30 0 0.3
Vwp_ih_1_30 wp_ih_1_30 0 0.6336124058556578
Vwn_ih_1_30 wn_ih_1_30 0 0.36638759414434224
Vwp_ih_2_30 wp_ih_2_30 0 0.899
Vwn_ih_2_30 wn_ih_2_30 0 0.3
Vwp_ih_0_31 wp_ih_0_31 0 0.5003344099477444
Vwn_ih_0_31 wn_ih_0_31 0 0.49966559005225564
Vwp_ih_1_31 wp_ih_1_31 0 0.5034993100535827
Vwn_ih_1_31 wn_ih_1_31 0 0.4965006899464173
Vwp_ih_2_31 wp_ih_2_31 0 0.3
Vwn_ih_2_31 wn_ih_2_31 0 0.899
Vwp_ih_0_32 wp_ih_0_32 0 0.3849045766556795
Vwn_ih_0_32 wn_ih_0_32 0 0.6150954233443205
Vwp_ih_1_32 wp_ih_1_32 0 0.3
Vwn_ih_1_32 wn_ih_1_32 0 0.7704648250672027
Vwp_ih_2_32 wp_ih_2_32 0 0.3
Vwn_ih_2_32 wn_ih_2_32 0 0.899
Vwp_ih_0_33 wp_ih_0_33 0 0.4820230018557805
Vwn_ih_0_33 wn_ih_0_33 0 0.5179769981442195
Vwp_ih_1_33 wp_ih_1_33 0 0.503176390960967
Vwn_ih_1_33 wn_ih_1_33 0 0.496823609039033
Vwp_ih_2_33 wp_ih_2_33 0 0.4620384024311953
Vwn_ih_2_33 wn_ih_2_33 0 0.5379615975688047
Vwp_ih_0_34 wp_ih_0_34 0 0.8958151462906112
Vwn_ih_0_34 wn_ih_0_34 0 0.3
Vwp_ih_1_34 wp_ih_1_34 0 0.8744068011355802
Vwn_ih_1_34 wn_ih_1_34 0 0.3
Vwp_ih_2_34 wp_ih_2_34 0 0.8032178073079654
Vwn_ih_2_34 wn_ih_2_34 0 0.3
Vwp_ih_0_35 wp_ih_0_35 0 0.5003102177658538
Vwn_ih_0_35 wn_ih_0_35 0 0.49968978223414623
Vwp_ih_1_35 wp_ih_1_35 0 0.4937565583373527
Vwn_ih_1_35 wn_ih_1_35 0 0.5062434416626472
Vwp_ih_2_35 wp_ih_2_35 0 0.5110899302772424
Vwn_ih_2_35 wn_ih_2_35 0 0.4889100697227577
Vwp_ih_0_36 wp_ih_0_36 0 0.7916652703536018
Vwn_ih_0_36 wn_ih_0_36 0 0.3
Vwp_ih_1_36 wp_ih_1_36 0 0.45298247167107863
Vwn_ih_1_36 wn_ih_1_36 0 0.5470175283289214
Vwp_ih_2_36 wp_ih_2_36 0 0.899
Vwn_ih_2_36 wn_ih_2_36 0 0.3
Vwp_ih_0_37 wp_ih_0_37 0 0.7008687387016486
Vwn_ih_0_37 wn_ih_0_37 0 0.3
Vwp_ih_1_37 wp_ih_1_37 0 0.3
Vwn_ih_1_37 wn_ih_1_37 0 0.7325445710193178
Vwp_ih_2_37 wp_ih_2_37 0 0.3
Vwn_ih_2_37 wn_ih_2_37 0 0.898125167165951
Vwp_ih_0_38 wp_ih_0_38 0 0.5727090426951428
Vwn_ih_0_38 wn_ih_0_38 0 0.4272909573048573
Vwp_ih_1_38 wp_ih_1_38 0 0.7869716726249724
Vwn_ih_1_38 wn_ih_1_38 0 0.3
Vwp_ih_2_38 wp_ih_2_38 0 0.3
Vwn_ih_2_38 wn_ih_2_38 0 0.8753287941209575
Vwp_ih_0_39 wp_ih_0_39 0 0.32079351561548763
Vwn_ih_0_39 wn_ih_0_39 0 0.6792064843845124
Vwp_ih_1_39 wp_ih_1_39 0 0.899
Vwn_ih_1_39 wn_ih_1_39 0 0.3
Vwp_ih_2_39 wp_ih_2_39 0 0.6954919560268344
Vwn_ih_2_39 wn_ih_2_39 0 0.30450804397316555
Vwp_ih_0_40 wp_ih_0_40 0 0.43421218021696634
Vwn_ih_0_40 wn_ih_0_40 0 0.5657878197830337
Vwp_ih_1_40 wp_ih_1_40 0 0.8971530234201165
Vwn_ih_1_40 wn_ih_1_40 0 0.3
Vwp_ih_2_40 wp_ih_2_40 0 0.34663030993518157
Vwn_ih_2_40 wn_ih_2_40 0 0.6533696900648185
Vwp_ih_0_41 wp_ih_0_41 0 0.43763765865264
Vwn_ih_0_41 wn_ih_0_41 0 0.5623623413473601
Vwp_ih_1_41 wp_ih_1_41 0 0.5012925720674879
Vwn_ih_1_41 wn_ih_1_41 0 0.49870742793251216
Vwp_ih_2_41 wp_ih_2_41 0 0.3072096708331403
Vwn_ih_2_41 wn_ih_2_41 0 0.6927903291668597
Vwp_ih_0_42 wp_ih_0_42 0 0.33135097033191474
Vwn_ih_0_42 wn_ih_0_42 0 0.6686490296680853
Vwp_ih_1_42 wp_ih_1_42 0 0.613270931293868
Vwn_ih_1_42 wn_ih_1_42 0 0.38672906870613205
Vwp_ih_2_42 wp_ih_2_42 0 0.3
Vwn_ih_2_42 wn_ih_2_42 0 0.7107426625368471
Vwp_ih_0_43 wp_ih_0_43 0 0.6427153195351933
Vwn_ih_0_43 wn_ih_0_43 0 0.35728468046480666
Vwp_ih_1_43 wp_ih_1_43 0 0.34739628075329476
Vwn_ih_1_43 wn_ih_1_43 0 0.6526037192467052
Vwp_ih_2_43 wp_ih_2_43 0 0.3082386065162567
Vwn_ih_2_43 wn_ih_2_43 0 0.6917613934837433
Vwp_ih_0_44 wp_ih_0_44 0 0.3
Vwn_ih_0_44 wn_ih_0_44 0 0.7633152649408086
Vwp_ih_1_44 wp_ih_1_44 0 0.3477100659487088
Vwn_ih_1_44 wn_ih_1_44 0 0.6522899340512912
Vwp_ih_2_44 wp_ih_2_44 0 0.898154780533275
Vwn_ih_2_44 wn_ih_2_44 0 0.3
Vwp_ih_0_45 wp_ih_0_45 0 0.5390250440868493
Vwn_ih_0_45 wn_ih_0_45 0 0.4609749559131508
Vwp_ih_1_45 wp_ih_1_45 0 0.5585048289168347
Vwn_ih_1_45 wn_ih_1_45 0 0.44149517108316527
Vwp_ih_2_45 wp_ih_2_45 0 0.5139980672550368
Vwn_ih_2_45 wn_ih_2_45 0 0.48600193274496317
Vwp_ih_0_46 wp_ih_0_46 0 0.5002320546288632
Vwn_ih_0_46 wn_ih_0_46 0 0.49976794537113683
Vwp_ih_1_46 wp_ih_1_46 0 0.5065064791521703
Vwn_ih_1_46 wn_ih_1_46 0 0.49349352084782977
Vwp_ih_2_46 wp_ih_2_46 0 0.3168364780634526
Vwn_ih_2_46 wn_ih_2_46 0 0.6831635219365474
Vwp_ih_0_47 wp_ih_0_47 0 0.5018192192444778
Vwn_ih_0_47 wn_ih_0_47 0 0.49818078075552225
Vwp_ih_1_47 wp_ih_1_47 0 0.4880143870278105
Vwn_ih_1_47 wn_ih_1_47 0 0.5119856129721895
Vwp_ih_2_47 wp_ih_2_47 0 0.547853161697683
Vwn_ih_2_47 wn_ih_2_47 0 0.45214683830231694
Vwp_ih_0_48 wp_ih_0_48 0 0.899
Vwn_ih_0_48 wn_ih_0_48 0 0.3
Vwp_ih_1_48 wp_ih_1_48 0 0.4409309844817166
Vwn_ih_1_48 wn_ih_1_48 0 0.5590690155182834
Vwp_ih_2_48 wp_ih_2_48 0 0.32274788383800457
Vwn_ih_2_48 wn_ih_2_48 0 0.6772521161619954
Vwp_ih_0_49 wp_ih_0_49 0 0.8980709131628901
Vwn_ih_0_49 wn_ih_0_49 0 0.3
Vwp_ih_1_49 wp_ih_1_49 0 0.3
Vwn_ih_1_49 wn_ih_1_49 0 0.7368879608937099
Vwp_ih_2_49 wp_ih_2_49 0 0.3127884625872171
Vwn_ih_2_49 wn_ih_2_49 0 0.687211537412783
Vwp_ih_0_50 wp_ih_0_50 0 0.7687056031355319
Vwn_ih_0_50 wn_ih_0_50 0 0.3
Vwp_ih_1_50 wp_ih_1_50 0 0.5723427021232057
Vwn_ih_1_50 wn_ih_1_50 0 0.4276572978767943
Vwp_ih_2_50 wp_ih_2_50 0 0.3
Vwn_ih_2_50 wn_ih_2_50 0 0.8513157370104658
Vwp_ih_0_51 wp_ih_0_51 0 0.5136490052739525
Vwn_ih_0_51 wn_ih_0_51 0 0.4863509947260475
Vwp_ih_1_51 wp_ih_1_51 0 0.8988086431017228
Vwn_ih_1_51 wn_ih_1_51 0 0.3
Vwp_ih_2_51 wp_ih_2_51 0 0.33207547488309797
Vwn_ih_2_51 wn_ih_2_51 0 0.667924525116902
Vwp_ih_0_52 wp_ih_0_52 0 0.5283122910651264
Vwn_ih_0_52 wn_ih_0_52 0 0.47168770893487355
Vwp_ih_1_52 wp_ih_1_52 0 0.899
Vwn_ih_1_52 wn_ih_1_52 0 0.3
Vwp_ih_2_52 wp_ih_2_52 0 0.6647880543435432
Vwn_ih_2_52 wn_ih_2_52 0 0.33521194565645684
Vwp_ih_0_53 wp_ih_0_53 0 0.3387337638660564
Vwn_ih_0_53 wn_ih_0_53 0 0.6612662361339436
Vwp_ih_1_53 wp_ih_1_53 0 0.4935714573817749
Vwn_ih_1_53 wn_ih_1_53 0 0.5064285426182251
Vwp_ih_2_53 wp_ih_2_53 0 0.35147872556571425
Vwn_ih_2_53 wn_ih_2_53 0 0.6485212744342858
Vwp_ih_0_54 wp_ih_0_54 0 0.4034158108989289
Vwn_ih_0_54 wn_ih_0_54 0 0.596584189101071
Vwp_ih_1_54 wp_ih_1_54 0 0.6489962348490215
Vwn_ih_1_54 wn_ih_1_54 0 0.3510037651509785
Vwp_ih_2_54 wp_ih_2_54 0 0.5692049288476572
Vwn_ih_2_54 wn_ih_2_54 0 0.43079507115234283
Vwp_ih_0_55 wp_ih_0_55 0 0.5023834852858395
Vwn_ih_0_55 wn_ih_0_55 0 0.49761651471416046
Vwp_ih_1_55 wp_ih_1_55 0 0.4908198703591647
Vwn_ih_1_55 wn_ih_1_55 0 0.5091801296408353
Vwp_ih_2_55 wp_ih_2_55 0 0.589158757252317
Vwn_ih_2_55 wn_ih_2_55 0 0.41084124274768297
Vwp_ih_0_56 wp_ih_0_56 0 0.3
Vwn_ih_0_56 wn_ih_0_56 0 0.899
Vwp_ih_1_56 wp_ih_1_56 0 0.6321151057679003
Vwn_ih_1_56 wn_ih_1_56 0 0.3678848942320997
Vwp_ih_2_56 wp_ih_2_56 0 0.6776767744926202
Vwn_ih_2_56 wn_ih_2_56 0 0.3223232255073798
Vwp_ih_0_57 wp_ih_0_57 0 0.4992568007034856
Vwn_ih_0_57 wn_ih_0_57 0 0.5007431992965145
Vwp_ih_1_57 wp_ih_1_57 0 0.49573522125476266
Vwn_ih_1_57 wn_ih_1_57 0 0.5042647787452373
Vwp_ih_2_57 wp_ih_2_57 0 0.81725637416167
Vwn_ih_2_57 wn_ih_2_57 0 0.3
Vwp_ih_0_58 wp_ih_0_58 0 0.8427226367596035
Vwn_ih_0_58 wn_ih_0_58 0 0.3
Vwp_ih_1_58 wp_ih_1_58 0 0.3
Vwn_ih_1_58 wn_ih_1_58 0 0.8970175604902948
Vwp_ih_2_58 wp_ih_2_58 0 0.3
Vwn_ih_2_58 wn_ih_2_58 0 0.7102075002007645
Vwp_ih_0_59 wp_ih_0_59 0 0.3250651770886459
Vwn_ih_0_59 wn_ih_0_59 0 0.6749348229113541
Vwp_ih_1_59 wp_ih_1_59 0 0.4207925818902132
Vwn_ih_1_59 wn_ih_1_59 0 0.5792074181097868
Vwp_ih_2_59 wp_ih_2_59 0 0.6595469358271188
Vwn_ih_2_59 wn_ih_2_59 0 0.34045306417288124
Vwp_ih_0_60 wp_ih_0_60 0 0.3
Vwn_ih_0_60 wn_ih_0_60 0 0.899
Vwp_ih_1_60 wp_ih_1_60 0 0.5698764175546001
Vwn_ih_1_60 wn_ih_1_60 0 0.43012358244539994
Vwp_ih_2_60 wp_ih_2_60 0 0.3314426205055421
Vwn_ih_2_60 wn_ih_2_60 0 0.6685573794944579
Vwp_ih_0_61 wp_ih_0_61 0 0.35985863268747886
Vwn_ih_0_61 wn_ih_0_61 0 0.6401413673125211
Vwp_ih_1_61 wp_ih_1_61 0 0.3
Vwn_ih_1_61 wn_ih_1_61 0 0.7092221419301544
Vwp_ih_2_61 wp_ih_2_61 0 0.43130226949834777
Vwn_ih_2_61 wn_ih_2_61 0 0.5686977305016522
Vwp_ih_0_62 wp_ih_0_62 0 0.5709538980704268
Vwn_ih_0_62 wn_ih_0_62 0 0.4290461019295732
Vwp_ih_1_62 wp_ih_1_62 0 0.3
Vwn_ih_1_62 wn_ih_1_62 0 0.898004034850276
Vwp_ih_2_62 wp_ih_2_62 0 0.6642172351542937
Vwn_ih_2_62 wn_ih_2_62 0 0.33578276484570635
Vwp_ih_0_63 wp_ih_0_63 0 0.3
Vwn_ih_0_63 wn_ih_0_63 0 0.8746465036693045
Vwp_ih_1_63 wp_ih_1_63 0 0.8821846838893075
Vwn_ih_1_63 wn_ih_1_63 0 0.3
Vwp_ih_2_63 wp_ih_2_63 0 0.3
Vwn_ih_2_63 wn_ih_2_63 0 0.7816923761198139
Vwp_ih_0_64 wp_ih_0_64 0 0.6516510307869451
Vwn_ih_0_64 wn_ih_0_64 0 0.3483489692130549
Vwp_ih_1_64 wp_ih_1_64 0 0.5308096160457471
Vwn_ih_1_64 wn_ih_1_64 0 0.4691903839542529
Vwp_ih_2_64 wp_ih_2_64 0 0.4301994165476476
Vwn_ih_2_64 wn_ih_2_64 0 0.5698005834523524
Vwp_ih_0_65 wp_ih_0_65 0 0.3
Vwn_ih_0_65 wn_ih_0_65 0 0.899
Vwp_ih_1_65 wp_ih_1_65 0 0.3168368911482613
Vwn_ih_1_65 wn_ih_1_65 0 0.6831631088517387
Vwp_ih_2_65 wp_ih_2_65 0 0.6891996962263648
Vwn_ih_2_65 wn_ih_2_65 0 0.3108003037736352
Vwp_ih_0_66 wp_ih_0_66 0 0.6868613982553347
Vwn_ih_0_66 wn_ih_0_66 0 0.31313860174466535
Vwp_ih_1_66 wp_ih_1_66 0 0.706736949509348
Vwn_ih_1_66 wn_ih_1_66 0 0.3
Vwp_ih_2_66 wp_ih_2_66 0 0.899
Vwn_ih_2_66 wn_ih_2_66 0 0.3
Vwp_ih_0_67 wp_ih_0_67 0 0.6788549420765505
Vwn_ih_0_67 wn_ih_0_67 0 0.3211450579234495
Vwp_ih_1_67 wp_ih_1_67 0 0.4726871364703018
Vwn_ih_1_67 wn_ih_1_67 0 0.5273128635296982
Vwp_ih_2_67 wp_ih_2_67 0 0.6790810214111368
Vwn_ih_2_67 wn_ih_2_67 0 0.3209189785888632
Vwp_ih_0_68 wp_ih_0_68 0 0.7844251082789886
Vwn_ih_0_68 wn_ih_0_68 0 0.3
Vwp_ih_1_68 wp_ih_1_68 0 0.899
Vwn_ih_1_68 wn_ih_1_68 0 0.3
Vwp_ih_2_68 wp_ih_2_68 0 0.7447361641114718
Vwn_ih_2_68 wn_ih_2_68 0 0.3
Vwp_ih_0_69 wp_ih_0_69 0 0.57840529121135
Vwn_ih_0_69 wn_ih_0_69 0 0.42159470878865
Vwp_ih_1_69 wp_ih_1_69 0 0.6420897137096309
Vwn_ih_1_69 wn_ih_1_69 0 0.3579102862903691
Vwp_ih_2_69 wp_ih_2_69 0 0.5748738152947562
Vwn_ih_2_69 wn_ih_2_69 0 0.42512618470524377
Vwp_ih_0_70 wp_ih_0_70 0 0.4982466029579566
Vwn_ih_0_70 wn_ih_0_70 0 0.5017533970420434
Vwp_ih_1_70 wp_ih_1_70 0 0.5127795931325742
Vwn_ih_1_70 wn_ih_1_70 0 0.48722040686742585
Vwp_ih_2_70 wp_ih_2_70 0 0.4506410484738152
Vwn_ih_2_70 wn_ih_2_70 0 0.5493589515261847
Vwp_ih_0_71 wp_ih_0_71 0 0.6417782523921034
Vwn_ih_0_71 wn_ih_0_71 0 0.35822174760789666
Vwp_ih_1_71 wp_ih_1_71 0 0.5831878584360175
Vwn_ih_1_71 wn_ih_1_71 0 0.4168121415639825
Vwp_ih_2_71 wp_ih_2_71 0 0.4050511892711888
Vwn_ih_2_71 wn_ih_2_71 0 0.5949488107288112
Vwp_ih_0_72 wp_ih_0_72 0 0.5010858399481546
Vwn_ih_0_72 wn_ih_0_72 0 0.4989141600518454
Vwp_ih_1_72 wp_ih_1_72 0 0.5077845267258635
Vwn_ih_1_72 wn_ih_1_72 0 0.4922154732741365
Vwp_ih_2_72 wp_ih_2_72 0 0.37075093373034257
Vwn_ih_2_72 wn_ih_2_72 0 0.6292490662696575
Vwp_ih_0_73 wp_ih_0_73 0 0.6864037550007764
Vwn_ih_0_73 wn_ih_0_73 0 0.31359624499922356
Vwp_ih_1_73 wp_ih_1_73 0 0.3
Vwn_ih_1_73 wn_ih_1_73 0 0.744228211932822
Vwp_ih_2_73 wp_ih_2_73 0 0.8986878216799092
Vwn_ih_2_73 wn_ih_2_73 0 0.3
Vwp_ih_0_74 wp_ih_0_74 0 0.49958915815143123
Vwn_ih_0_74 wn_ih_0_74 0 0.5004108418485688
Vwp_ih_1_74 wp_ih_1_74 0 0.5090433412539832
Vwn_ih_1_74 wn_ih_1_74 0 0.4909566587460168
Vwp_ih_2_74 wp_ih_2_74 0 0.3605580580541844
Vwn_ih_2_74 wn_ih_2_74 0 0.6394419419458156
Vwp_ih_0_75 wp_ih_0_75 0 0.49927619869394607
Vwn_ih_0_75 wn_ih_0_75 0 0.5007238013060539
Vwp_ih_1_75 wp_ih_1_75 0 0.4944388571917137
Vwn_ih_1_75 wn_ih_1_75 0 0.5055611428082863
Vwp_ih_2_75 wp_ih_2_75 0 0.7241511078348047
Vwn_ih_2_75 wn_ih_2_75 0 0.3
Vwp_ih_0_76 wp_ih_0_76 0 0.33334136130848624
Vwn_ih_0_76 wn_ih_0_76 0 0.6666586386915138
Vwp_ih_1_76 wp_ih_1_76 0 0.5151584194109502
Vwn_ih_1_76 wn_ih_1_76 0 0.48484158058904975
Vwp_ih_2_76 wp_ih_2_76 0 0.3733106822557025
Vwn_ih_2_76 wn_ih_2_76 0 0.6266893177442975
Vwp_ih_0_77 wp_ih_0_77 0 0.396561805290552
Vwn_ih_0_77 wn_ih_0_77 0 0.603438194709448
Vwp_ih_1_77 wp_ih_1_77 0 0.8981290971625343
Vwn_ih_1_77 wn_ih_1_77 0 0.3
Vwp_ih_2_77 wp_ih_2_77 0 0.32988503810978465
Vwn_ih_2_77 wn_ih_2_77 0 0.6701149618902154
Vwp_ih_0_78 wp_ih_0_78 0 0.3613293243656355
Vwn_ih_0_78 wn_ih_0_78 0 0.6386706756343645
Vwp_ih_1_78 wp_ih_1_78 0 0.3
Vwn_ih_1_78 wn_ih_1_78 0 0.750186492209107
Vwp_ih_2_78 wp_ih_2_78 0 0.3
Vwn_ih_2_78 wn_ih_2_78 0 0.899
Vwp_ih_0_79 wp_ih_0_79 0 0.4898726807089236
Vwn_ih_0_79 wn_ih_0_79 0 0.5101273192910765
Vwp_ih_1_79 wp_ih_1_79 0 0.4613151465352948
Vwn_ih_1_79 wn_ih_1_79 0 0.5386848534647052
Vwp_ih_2_79 wp_ih_2_79 0 0.6019020925372109
Vwn_ih_2_79 wn_ih_2_79 0 0.39809790746278906
Vwp_ih_0_80 wp_ih_0_80 0 0.5915340822695584
Vwn_ih_0_80 wn_ih_0_80 0 0.40846591773044155
Vwp_ih_1_80 wp_ih_1_80 0 0.3
Vwn_ih_1_80 wn_ih_1_80 0 0.8046040183318917
Vwp_ih_2_80 wp_ih_2_80 0 0.8987335545411583
Vwn_ih_2_80 wn_ih_2_80 0 0.3
Vwp_ih_0_81 wp_ih_0_81 0 0.6828854357681258
Vwn_ih_0_81 wn_ih_0_81 0 0.31711456423187423
Vwp_ih_1_81 wp_ih_1_81 0 0.49958976387909365
Vwn_ih_1_81 wn_ih_1_81 0 0.5004102361209064
Vwp_ih_2_81 wp_ih_2_81 0 0.6915329693190045
Vwn_ih_2_81 wn_ih_2_81 0 0.30846703068099546
Vwp_ih_0_82 wp_ih_0_82 0 0.7213683091788633
Vwn_ih_0_82 wn_ih_0_82 0 0.3
Vwp_ih_1_82 wp_ih_1_82 0 0.5442692241983287
Vwn_ih_1_82 wn_ih_1_82 0 0.4557307758016713
Vwp_ih_2_82 wp_ih_2_82 0 0.4873169751264261
Vwn_ih_2_82 wn_ih_2_82 0 0.512683024873574
Vwp_ih_0_83 wp_ih_0_83 0 0.4998063909201008
Vwn_ih_0_83 wn_ih_0_83 0 0.5001936090798992
Vwp_ih_1_83 wp_ih_1_83 0 0.4936663125103628
Vwn_ih_1_83 wn_ih_1_83 0 0.5063336874896373
Vwp_ih_2_83 wp_ih_2_83 0 0.6815093564285464
Vwn_ih_2_83 wn_ih_2_83 0 0.3184906435714536
Vwp_ih_0_84 wp_ih_0_84 0 0.5006819807991056
Vwn_ih_0_84 wn_ih_0_84 0 0.49931801920089436
Vwp_ih_1_84 wp_ih_1_84 0 0.5038075276788795
Vwn_ih_1_84 wn_ih_1_84 0 0.4961924723211205
Vwp_ih_2_84 wp_ih_2_84 0 0.3
Vwn_ih_2_84 wn_ih_2_84 0 0.8867213523790078
Vwp_ih_0_85 wp_ih_0_85 0 0.36386977860006564
Vwn_ih_0_85 wn_ih_0_85 0 0.6361302213999344
Vwp_ih_1_85 wp_ih_1_85 0 0.3631378193933402
Vwn_ih_1_85 wn_ih_1_85 0 0.6368621806066598
Vwp_ih_2_85 wp_ih_2_85 0 0.6489351325102704
Vwn_ih_2_85 wn_ih_2_85 0 0.3510648674897296
Vwp_ih_0_86 wp_ih_0_86 0 0.4961059849228237
Vwn_ih_0_86 wn_ih_0_86 0 0.5038940150771763
Vwp_ih_1_86 wp_ih_1_86 0 0.5161941875381142
Vwn_ih_1_86 wn_ih_1_86 0 0.4838058124618858
Vwp_ih_2_86 wp_ih_2_86 0 0.42153423408012003
Vwn_ih_2_86 wn_ih_2_86 0 0.57846576591988
Vwp_ih_0_87 wp_ih_0_87 0 0.34306485237551754
Vwn_ih_0_87 wn_ih_0_87 0 0.6569351476244825
Vwp_ih_1_87 wp_ih_1_87 0 0.6532202604652928
Vwn_ih_1_87 wn_ih_1_87 0 0.3467797395347072
Vwp_ih_2_87 wp_ih_2_87 0 0.7253789903699517
Vwn_ih_2_87 wn_ih_2_87 0 0.3
Vwp_ih_0_88 wp_ih_0_88 0 0.46947074729882354
Vwn_ih_0_88 wn_ih_0_88 0 0.5305292527011765
Vwp_ih_1_88 wp_ih_1_88 0 0.3
Vwn_ih_1_88 wn_ih_1_88 0 0.8184122680991605
Vwp_ih_2_88 wp_ih_2_88 0 0.3
Vwn_ih_2_88 wn_ih_2_88 0 0.899
Vwp_ih_0_89 wp_ih_0_89 0 0.32670065797405257
Vwn_ih_0_89 wn_ih_0_89 0 0.6732993420259474
Vwp_ih_1_89 wp_ih_1_89 0 0.48039542156554
Vwn_ih_1_89 wn_ih_1_89 0 0.51960457843446
Vwp_ih_2_89 wp_ih_2_89 0 0.330792454272937
Vwn_ih_2_89 wn_ih_2_89 0 0.669207545727063
Vwp_ih_0_90 wp_ih_0_90 0 0.6376855911936882
Vwn_ih_0_90 wn_ih_0_90 0 0.3623144088063118
Vwp_ih_1_90 wp_ih_1_90 0 0.6036213377002637
Vwn_ih_1_90 wn_ih_1_90 0 0.3963786622997363
Vwp_ih_2_90 wp_ih_2_90 0 0.41322728739531533
Vwn_ih_2_90 wn_ih_2_90 0 0.5867727126046847
Vwp_ih_0_91 wp_ih_0_91 0 0.3536313909807879
Vwn_ih_0_91 wn_ih_0_91 0 0.6463686090192121
Vwp_ih_1_91 wp_ih_1_91 0 0.4546907930103295
Vwn_ih_1_91 wn_ih_1_91 0 0.5453092069896706
Vwp_ih_2_91 wp_ih_2_91 0 0.5759052887447552
Vwn_ih_2_91 wn_ih_2_91 0 0.4240947112552447
Vwp_ih_0_92 wp_ih_0_92 0 0.4996287705218768
Vwn_ih_0_92 wn_ih_0_92 0 0.5003712294781232
Vwp_ih_1_92 wp_ih_1_92 0 0.4946295937904459
Vwn_ih_1_92 wn_ih_1_92 0 0.5053704062095541
Vwp_ih_2_92 wp_ih_2_92 0 0.736729608691473
Vwn_ih_2_92 wn_ih_2_92 0 0.3
Vwp_ih_0_93 wp_ih_0_93 0 0.4992952469890021
Vwn_ih_0_93 wn_ih_0_93 0 0.5007047530109979
Vwp_ih_1_93 wp_ih_1_93 0 0.4947549864116635
Vwn_ih_1_93 wn_ih_1_93 0 0.5052450135883365
Vwp_ih_2_93 wp_ih_2_93 0 0.7370073051046849
Vwn_ih_2_93 wn_ih_2_93 0 0.3
Vwp_ih_0_94 wp_ih_0_94 0 0.5793408619734843
Vwn_ih_0_94 wn_ih_0_94 0 0.42065913802651567
Vwp_ih_1_94 wp_ih_1_94 0 0.6943787663993751
Vwn_ih_1_94 wn_ih_1_94 0 0.3056212336006249
Vwp_ih_2_94 wp_ih_2_94 0 0.3
Vwn_ih_2_94 wn_ih_2_94 0 0.7002649428432067
Vwp_ih_0_95 wp_ih_0_95 0 0.3596859227131488
Vwn_ih_0_95 wn_ih_0_95 0 0.6403140772868512
Vwp_ih_1_95 wp_ih_1_95 0 0.6028119663960485
Vwn_ih_1_95 wn_ih_1_95 0 0.3971880336039515
Vwp_ih_2_95 wp_ih_2_95 0 0.6094037139423192
Vwn_ih_2_95 wn_ih_2_95 0 0.3905962860576809
Vwp_ih_0_96 wp_ih_0_96 0 0.5025687907804254
Vwn_ih_0_96 wn_ih_0_96 0 0.49743120921957457
Vwp_ih_1_96 wp_ih_1_96 0 0.49871887477211163
Vwn_ih_1_96 wn_ih_1_96 0 0.5012811252278884
Vwp_ih_2_96 wp_ih_2_96 0 0.506247547868543
Vwn_ih_2_96 wn_ih_2_96 0 0.4937524521314571
Vwp_ih_0_97 wp_ih_0_97 0 0.3172999849478716
Vwn_ih_0_97 wn_ih_0_97 0 0.6827000150521284
Vwp_ih_1_97 wp_ih_1_97 0 0.5131367680320591
Vwn_ih_1_97 wn_ih_1_97 0 0.48686323196794085
Vwp_ih_2_97 wp_ih_2_97 0 0.42475664664520346
Vwn_ih_2_97 wn_ih_2_97 0 0.5752433533547965
Vwp_ih_0_98 wp_ih_0_98 0 0.4994430240765781
Vwn_ih_0_98 wn_ih_0_98 0 0.5005569759234219
Vwp_ih_1_98 wp_ih_1_98 0 0.49629816133655696
Vwn_ih_1_98 wn_ih_1_98 0 0.5037018386634431
Vwp_ih_2_98 wp_ih_2_98 0 0.899
Vwn_ih_2_98 wn_ih_2_98 0 0.3
Vwp_ih_0_99 wp_ih_0_99 0 0.899
Vwn_ih_0_99 wn_ih_0_99 0 0.3
Vwp_ih_1_99 wp_ih_1_99 0 0.44297924638145497
Vwn_ih_1_99 wn_ih_1_99 0 0.5570207536185451
Vwp_ih_2_99 wp_ih_2_99 0 0.6657735024756823
Vwn_ih_2_99 wn_ih_2_99 0 0.33422649752431766
Vwp_ih_0_100 wp_ih_0_100 0 0.49619056677081835
Vwn_ih_0_100 wn_ih_0_100 0 0.5038094332291816
Vwp_ih_1_100 wp_ih_1_100 0 0.5110700430656887
Vwn_ih_1_100 wn_ih_1_100 0 0.48892995693431124
Vwp_ih_2_100 wp_ih_2_100 0 0.454110420557158
Vwn_ih_2_100 wn_ih_2_100 0 0.545889579442842
Vwp_ih_0_101 wp_ih_0_101 0 0.3186976976117354
Vwn_ih_0_101 wn_ih_0_101 0 0.6813023023882646
Vwp_ih_1_101 wp_ih_1_101 0 0.5405780875673625
Vwn_ih_1_101 wn_ih_1_101 0 0.4594219124326375
Vwp_ih_2_101 wp_ih_2_101 0 0.3159179787260403
Vwn_ih_2_101 wn_ih_2_101 0 0.6840820212739597
Vwp_ih_0_102 wp_ih_0_102 0 0.498984607657542
Vwn_ih_0_102 wn_ih_0_102 0 0.5010153923424581
Vwp_ih_1_102 wp_ih_1_102 0 0.493283072589217
Vwn_ih_1_102 wn_ih_1_102 0 0.506716927410783
Vwp_ih_2_102 wp_ih_2_102 0 0.6936279852580863
Vwn_ih_2_102 wn_ih_2_102 0 0.30637201474191367
Vwp_ih_0_103 wp_ih_0_103 0 0.6136461217732181
Vwn_ih_0_103 wn_ih_0_103 0 0.38635387822678185
Vwp_ih_1_103 wp_ih_1_103 0 0.5434166636671711
Vwn_ih_1_103 wn_ih_1_103 0 0.4565833363328289
Vwp_ih_2_103 wp_ih_2_103 0 0.4621918610473676
Vwn_ih_2_103 wn_ih_2_103 0 0.5378081389526324
Vwp_ih_0_104 wp_ih_0_104 0 0.3
Vwn_ih_0_104 wn_ih_0_104 0 0.7152469117175556
Vwp_ih_1_104 wp_ih_1_104 0 0.3463229594019861
Vwn_ih_1_104 wn_ih_1_104 0 0.6536770405980139
Vwp_ih_2_104 wp_ih_2_104 0 0.8456936170781018
Vwn_ih_2_104 wn_ih_2_104 0 0.3
Vwp_ih_0_105 wp_ih_0_105 0 0.49815231335202703
Vwn_ih_0_105 wn_ih_0_105 0 0.501847686647973
Vwp_ih_1_105 wp_ih_1_105 0 0.4887320334301449
Vwn_ih_1_105 wn_ih_1_105 0 0.5112679665698551
Vwp_ih_2_105 wp_ih_2_105 0 0.6134741505457074
Vwn_ih_2_105 wn_ih_2_105 0 0.38652584945429264
Vwp_ih_0_106 wp_ih_0_106 0 0.899
Vwn_ih_0_106 wn_ih_0_106 0 0.3
Vwp_ih_1_106 wp_ih_1_106 0 0.3765549715499177
Vwn_ih_1_106 wn_ih_1_106 0 0.6234450284500823
Vwp_ih_2_106 wp_ih_2_106 0 0.3239626711244772
Vwn_ih_2_106 wn_ih_2_106 0 0.6760373288755228
Vwp_ih_0_107 wp_ih_0_107 0 0.40118301807827095
Vwn_ih_0_107 wn_ih_0_107 0 0.598816981921729
Vwp_ih_1_107 wp_ih_1_107 0 0.3256118280481216
Vwn_ih_1_107 wn_ih_1_107 0 0.6743881719518784
Vwp_ih_2_107 wp_ih_2_107 0 0.4712092483459874
Vwn_ih_2_107 wn_ih_2_107 0 0.5287907516540127
Vwp_ih_0_108 wp_ih_0_108 0 0.3834352835569521
Vwn_ih_0_108 wn_ih_0_108 0 0.6165647164430479
Vwp_ih_1_108 wp_ih_1_108 0 0.3631361786990021
Vwn_ih_1_108 wn_ih_1_108 0 0.6368638213009978
Vwp_ih_2_108 wp_ih_2_108 0 0.6160238944536249
Vwn_ih_2_108 wn_ih_2_108 0 0.38397610554637507
Vwp_ih_0_109 wp_ih_0_109 0 0.472284300991572
Vwn_ih_0_109 wn_ih_0_109 0 0.527715699008428
Vwp_ih_1_109 wp_ih_1_109 0 0.3259365711449793
Vwn_ih_1_109 wn_ih_1_109 0 0.6740634288550207
Vwp_ih_2_109 wp_ih_2_109 0 0.5957715406560278
Vwn_ih_2_109 wn_ih_2_109 0 0.4042284593439722
Vwp_ih_0_110 wp_ih_0_110 0 0.5936353743728284
Vwn_ih_0_110 wn_ih_0_110 0 0.40636462562717157
Vwp_ih_1_110 wp_ih_1_110 0 0.3
Vwn_ih_1_110 wn_ih_1_110 0 0.899
Vwp_ih_2_110 wp_ih_2_110 0 0.3245826820111939
Vwn_ih_2_110 wn_ih_2_110 0 0.6754173179888061
Vwp_ih_0_111 wp_ih_0_111 0 0.4881820230613958
Vwn_ih_0_111 wn_ih_0_111 0 0.5118179769386042
Vwp_ih_1_111 wp_ih_1_111 0 0.5206434367962309
Vwn_ih_1_111 wn_ih_1_111 0 0.47935656320376907
Vwp_ih_2_111 wp_ih_2_111 0 0.44560939677183614
Vwn_ih_2_111 wn_ih_2_111 0 0.5543906032281638
Vwp_ih_0_112 wp_ih_0_112 0 0.7092815515786259
Vwn_ih_0_112 wn_ih_0_112 0 0.3
Vwp_ih_1_112 wp_ih_1_112 0 0.3984450757668295
Vwn_ih_1_112 wn_ih_1_112 0 0.6015549242331705
Vwp_ih_2_112 wp_ih_2_112 0 0.8020924172114452
Vwn_ih_2_112 wn_ih_2_112 0 0.3
Vwp_ih_0_113 wp_ih_0_113 0 0.49935921655074667
Vwn_ih_0_113 wn_ih_0_113 0 0.5006407834492533
Vwp_ih_1_113 wp_ih_1_113 0 0.4948842740418821
Vwn_ih_1_113 wn_ih_1_113 0 0.5051157259581179
Vwp_ih_2_113 wp_ih_2_113 0 0.7433273343406909
Vwn_ih_2_113 wn_ih_2_113 0 0.3
Vwp_ih_0_114 wp_ih_0_114 0 0.6419357683100952
Vwn_ih_0_114 wn_ih_0_114 0 0.3580642316899047
Vwp_ih_1_114 wp_ih_1_114 0 0.6070688934596257
Vwn_ih_1_114 wn_ih_1_114 0 0.39293110654037433
Vwp_ih_2_114 wp_ih_2_114 0 0.3934330200207945
Vwn_ih_2_114 wn_ih_2_114 0 0.6065669799792055
Vwp_ih_0_115 wp_ih_0_115 0 0.6965996826662235
Vwn_ih_0_115 wn_ih_0_115 0 0.3034003173337765
Vwp_ih_1_115 wp_ih_1_115 0 0.8976915111721269
Vwn_ih_1_115 wn_ih_1_115 0 0.3
Vwp_ih_2_115 wp_ih_2_115 0 0.34434289092319836
Vwn_ih_2_115 wn_ih_2_115 0 0.6556571090768016
Vwp_ih_0_116 wp_ih_0_116 0 0.49765747098291724
Vwn_ih_0_116 wn_ih_0_116 0 0.5023425290170828
Vwp_ih_1_116 wp_ih_1_116 0 0.5037526538084413
Vwn_ih_1_116 wn_ih_1_116 0 0.49624734619155875
Vwp_ih_2_116 wp_ih_2_116 0 0.48690569939551653
Vwn_ih_2_116 wn_ih_2_116 0 0.5130943006044835
Vwp_ih_0_117 wp_ih_0_117 0 0.62565200952316
Vwn_ih_0_117 wn_ih_0_117 0 0.37434799047684
Vwp_ih_1_117 wp_ih_1_117 0 0.3842266459654493
Vwn_ih_1_117 wn_ih_1_117 0 0.6157733540345507
Vwp_ih_2_117 wp_ih_2_117 0 0.6019059466330418
Vwn_ih_2_117 wn_ih_2_117 0 0.3980940533669582
Vwp_ih_0_118 wp_ih_0_118 0 0.4821980517615962
Vwn_ih_0_118 wn_ih_0_118 0 0.5178019482384039
Vwp_ih_1_118 wp_ih_1_118 0 0.6796694896021699
Vwn_ih_1_118 wn_ih_1_118 0 0.3203305103978301
Vwp_ih_2_118 wp_ih_2_118 0 0.5271890708697451
Vwn_ih_2_118 wn_ih_2_118 0 0.4728109291302549
Vwp_ih_0_119 wp_ih_0_119 0 0.3
Vwn_ih_0_119 wn_ih_0_119 0 0.899
Vwp_ih_1_119 wp_ih_1_119 0 0.36642656288079944
Vwn_ih_1_119 wn_ih_1_119 0 0.6335734371192006
Vwp_ih_2_119 wp_ih_2_119 0 0.6762388954727289
Vwn_ih_2_119 wn_ih_2_119 0 0.32376110452727114
Vwp_ih_0_120 wp_ih_0_120 0 0.4994594281681789
Vwn_ih_0_120 wn_ih_0_120 0 0.5005405718318211
Vwp_ih_1_120 wp_ih_1_120 0 0.4959793410485873
Vwn_ih_1_120 wn_ih_1_120 0 0.5040206589514127
Vwp_ih_2_120 wp_ih_2_120 0 0.7546202122647552
Vwn_ih_2_120 wn_ih_2_120 0 0.3
Vwp_ih_0_121 wp_ih_0_121 0 0.5476337261903808
Vwn_ih_0_121 wn_ih_0_121 0 0.4523662738096193
Vwp_ih_1_121 wp_ih_1_121 0 0.3
Vwn_ih_1_121 wn_ih_1_121 0 0.899
Vwp_ih_2_121 wp_ih_2_121 0 0.3321032226315005
Vwn_ih_2_121 wn_ih_2_121 0 0.6678967773684995
Vwp_ih_0_122 wp_ih_0_122 0 0.5026017929403638
Vwn_ih_0_122 wn_ih_0_122 0 0.49739820705963617
Vwp_ih_1_122 wp_ih_1_122 0 0.48524544557292315
Vwn_ih_1_122 wn_ih_1_122 0 0.5147545544270768
Vwp_ih_2_122 wp_ih_2_122 0 0.6055451664340834
Vwn_ih_2_122 wn_ih_2_122 0 0.39445483356591665
Vwp_ih_0_123 wp_ih_0_123 0 0.6165809883916998
Vwn_ih_0_123 wn_ih_0_123 0 0.3834190116083001
Vwp_ih_1_123 wp_ih_1_123 0 0.8984349953741082
Vwn_ih_1_123 wn_ih_1_123 0 0.3
Vwp_ih_2_123 wp_ih_2_123 0 0.3315611225886595
Vwn_ih_2_123 wn_ih_2_123 0 0.6684388774113406
Vwp_ih_0_124 wp_ih_0_124 0 0.3161584810218011
Vwn_ih_0_124 wn_ih_0_124 0 0.6838415189781989
Vwp_ih_1_124 wp_ih_1_124 0 0.35675461811924214
Vwn_ih_1_124 wn_ih_1_124 0 0.6432453818807579
Vwp_ih_2_124 wp_ih_2_124 0 0.3
Vwn_ih_2_124 wn_ih_2_124 0 0.8265114451496107
Vwp_ih_0_125 wp_ih_0_125 0 0.5008430504157743
Vwn_ih_0_125 wn_ih_0_125 0 0.4991569495842258
Vwp_ih_1_125 wp_ih_1_125 0 0.5058169787257905
Vwn_ih_1_125 wn_ih_1_125 0 0.49418302127420954
Vwp_ih_2_125 wp_ih_2_125 0 0.3
Vwn_ih_2_125 wn_ih_2_125 0 0.7161415840988897
Vwp_ih_0_126 wp_ih_0_126 0 0.3254691079958595
Vwn_ih_0_126 wn_ih_0_126 0 0.6745308920041405
Vwp_ih_1_126 wp_ih_1_126 0 0.4567982404732783
Vwn_ih_1_126 wn_ih_1_126 0 0.5432017595267217
Vwp_ih_2_126 wp_ih_2_126 0 0.6152114789921943
Vwn_ih_2_126 wn_ih_2_126 0 0.38478852100780575
Vwp_ih_0_127 wp_ih_0_127 0 0.6141478758549027
Vwn_ih_0_127 wn_ih_0_127 0 0.3858521241450973
Vwp_ih_1_127 wp_ih_1_127 0 0.6494147269406312
Vwn_ih_1_127 wn_ih_1_127 0 0.3505852730593688
Vwp_ih_2_127 wp_ih_2_127 0 0.647859613226295
Vwn_ih_2_127 wn_ih_2_127 0 0.3521403867737049
Vwp_ih_0_128 wp_ih_0_128 0 0.5016358561735754
Vwn_ih_0_128 wn_ih_0_128 0 0.4983641438264246
Vwp_ih_1_128 wp_ih_1_128 0 0.4843241913887716
Vwn_ih_1_128 wn_ih_1_128 0 0.5156758086112284
Vwp_ih_2_128 wp_ih_2_128 0 0.5854445182589767
Vwn_ih_2_128 wn_ih_2_128 0 0.41455548174102325
Vwp_ih_0_129 wp_ih_0_129 0 0.6613781355791489
Vwn_ih_0_129 wn_ih_0_129 0 0.33862186442085107
Vwp_ih_1_129 wp_ih_1_129 0 0.5023720123541693
Vwn_ih_1_129 wn_ih_1_129 0 0.49762798764583066
Vwp_ih_2_129 wp_ih_2_129 0 0.6327384575376174
Vwn_ih_2_129 wn_ih_2_129 0 0.3672615424623826
Vwp_ih_0_130 wp_ih_0_130 0 0.5002741175411893
Vwn_ih_0_130 wn_ih_0_130 0 0.49972588245881067
Vwp_ih_1_130 wp_ih_1_130 0 0.5039939767587102
Vwn_ih_1_130 wn_ih_1_130 0 0.4960060232412899
Vwp_ih_2_130 wp_ih_2_130 0 0.3
Vwn_ih_2_130 wn_ih_2_130 0 0.833979546172998
Vwp_ih_0_131 wp_ih_0_131 0 0.3
Vwn_ih_0_131 wn_ih_0_131 0 0.7135608721560487
Vwp_ih_1_131 wp_ih_1_131 0 0.3219303628170277
Vwn_ih_1_131 wn_ih_1_131 0 0.6780696371829723
Vwp_ih_2_131 wp_ih_2_131 0 0.3
Vwn_ih_2_131 wn_ih_2_131 0 0.899
Vwp_ih_0_132 wp_ih_0_132 0 0.899
Vwn_ih_0_132 wn_ih_0_132 0 0.3
Vwp_ih_1_132 wp_ih_1_132 0 0.8469272034649422
Vwn_ih_1_132 wn_ih_1_132 0 0.3
Vwp_ih_2_132 wp_ih_2_132 0 0.3
Vwn_ih_2_132 wn_ih_2_132 0 0.745667017154893
Vwp_ih_0_133 wp_ih_0_133 0 0.49919721221981167
Vwn_ih_0_133 wn_ih_0_133 0 0.5008027877801883
Vwp_ih_1_133 wp_ih_1_133 0 0.49630633636234867
Vwn_ih_1_133 wn_ih_1_133 0 0.5036936636376513
Vwp_ih_2_133 wp_ih_2_133 0 0.899
Vwn_ih_2_133 wn_ih_2_133 0 0.3
Vwp_ih_0_134 wp_ih_0_134 0 0.52497799214805
Vwn_ih_0_134 wn_ih_0_134 0 0.4750220078519501
Vwp_ih_1_134 wp_ih_1_134 0 0.6046121828037136
Vwn_ih_1_134 wn_ih_1_134 0 0.39538781719628635
Vwp_ih_2_134 wp_ih_2_134 0 0.5179886102441233
Vwn_ih_2_134 wn_ih_2_134 0 0.48201138975587665
Vwp_ih_0_135 wp_ih_0_135 0 0.520676758049259
Vwn_ih_0_135 wn_ih_0_135 0 0.47932324195074105
Vwp_ih_1_135 wp_ih_1_135 0 0.3
Vwn_ih_1_135 wn_ih_1_135 0 0.7173190221210296
Vwp_ih_2_135 wp_ih_2_135 0 0.7356781523873783
Vwn_ih_2_135 wn_ih_2_135 0 0.3
Vwp_ih_0_136 wp_ih_0_136 0 0.34063066410421183
Vwn_ih_0_136 wn_ih_0_136 0 0.6593693358957882
Vwp_ih_1_136 wp_ih_1_136 0 0.3
Vwn_ih_1_136 wn_ih_1_136 0 0.7351665724199917
Vwp_ih_2_136 wp_ih_2_136 0 0.3
Vwn_ih_2_136 wn_ih_2_136 0 0.899
Vwp_ih_0_137 wp_ih_0_137 0 0.5784576079485192
Vwn_ih_0_137 wn_ih_0_137 0 0.4215423920514808
Vwp_ih_1_137 wp_ih_1_137 0 0.8986073167962023
Vwn_ih_1_137 wn_ih_1_137 0 0.3
Vwp_ih_2_137 wp_ih_2_137 0 0.33020075813044825
Vwn_ih_2_137 wn_ih_2_137 0 0.6697992418695518
Vwp_ih_0_138 wp_ih_0_138 0 0.48754349085131377
Vwn_ih_0_138 wn_ih_0_138 0 0.5124565091486862
Vwp_ih_1_138 wp_ih_1_138 0 0.49347543781312986
Vwn_ih_1_138 wn_ih_1_138 0 0.5065245621868701
Vwp_ih_2_138 wp_ih_2_138 0 0.48340004654403645
Vwn_ih_2_138 wn_ih_2_138 0 0.5165999534559635
Vwp_ih_0_139 wp_ih_0_139 0 0.684043148093369
Vwn_ih_0_139 wn_ih_0_139 0 0.31595685190663103
Vwp_ih_1_139 wp_ih_1_139 0 0.4630042768484627
Vwn_ih_1_139 wn_ih_1_139 0 0.5369957231515373
Vwp_ih_2_139 wp_ih_2_139 0 0.33331619834653725
Vwn_ih_2_139 wn_ih_2_139 0 0.6666838016534627
Vwp_ih_0_140 wp_ih_0_140 0 0.3682367456573119
Vwn_ih_0_140 wn_ih_0_140 0 0.6317632543426881
Vwp_ih_1_140 wp_ih_1_140 0 0.6018066585948917
Vwn_ih_1_140 wn_ih_1_140 0 0.3981933414051083
Vwp_ih_2_140 wp_ih_2_140 0 0.5890342274290131
Vwn_ih_2_140 wn_ih_2_140 0 0.4109657725709868
Vwp_ih_0_141 wp_ih_0_141 0 0.34993749190152673
Vwn_ih_0_141 wn_ih_0_141 0 0.6500625080984732
Vwp_ih_1_141 wp_ih_1_141 0 0.3668012660187384
Vwn_ih_1_141 wn_ih_1_141 0 0.6331987339812616
Vwp_ih_2_141 wp_ih_2_141 0 0.3
Vwn_ih_2_141 wn_ih_2_141 0 0.7440543382645008
Vwp_ih_0_142 wp_ih_0_142 0 0.36431328466056
Vwn_ih_0_142 wn_ih_0_142 0 0.63568671533944
Vwp_ih_1_142 wp_ih_1_142 0 0.3225645718708381
Vwn_ih_1_142 wn_ih_1_142 0 0.6774354281291619
Vwp_ih_2_142 wp_ih_2_142 0 0.738805366864395
Vwn_ih_2_142 wn_ih_2_142 0 0.3
Vwp_ih_0_143 wp_ih_0_143 0 0.3201528670230964
Vwn_ih_0_143 wn_ih_0_143 0 0.6798471329769036
Vwp_ih_1_143 wp_ih_1_143 0 0.4397488943106004
Vwn_ih_1_143 wn_ih_1_143 0 0.5602511056893996
Vwp_ih_2_143 wp_ih_2_143 0 0.3
Vwn_ih_2_143 wn_ih_2_143 0 0.7111819723323451
Vwp_ih_0_144 wp_ih_0_144 0 0.5024386790311126
Vwn_ih_0_144 wn_ih_0_144 0 0.49756132096888744
Vwp_ih_1_144 wp_ih_1_144 0 0.48178487942949083
Vwn_ih_1_144 wn_ih_1_144 0 0.5182151205705091
Vwp_ih_2_144 wp_ih_2_144 0 0.5502998038909453
Vwn_ih_2_144 wn_ih_2_144 0 0.4497001961090546
Vwp_ih_0_145 wp_ih_0_145 0 0.5014976548964368
Vwn_ih_0_145 wn_ih_0_145 0 0.49850234510356317
Vwp_ih_1_145 wp_ih_1_145 0 0.48898592068865904
Vwn_ih_1_145 wn_ih_1_145 0 0.511014079311341
Vwp_ih_2_145 wp_ih_2_145 0 0.6065931218717266
Vwn_ih_2_145 wn_ih_2_145 0 0.39340687812827335
Vwp_ih_0_146 wp_ih_0_146 0 0.5073526919255402
Vwn_ih_0_146 wn_ih_0_146 0 0.4926473080744598
Vwp_ih_1_146 wp_ih_1_146 0 0.503188402810393
Vwn_ih_1_146 wn_ih_1_146 0 0.49681159718960705
Vwp_ih_2_146 wp_ih_2_146 0 0.5323637457419431
Vwn_ih_2_146 wn_ih_2_146 0 0.46763625425805694
Vwp_ih_0_147 wp_ih_0_147 0 0.5004853390971641
Vwn_ih_0_147 wn_ih_0_147 0 0.4995146609028359
Vwp_ih_1_147 wp_ih_1_147 0 0.5058887008340813
Vwn_ih_1_147 wn_ih_1_147 0 0.49411129916591867
Vwp_ih_2_147 wp_ih_2_147 0 0.3
Vwn_ih_2_147 wn_ih_2_147 0 0.7075868118980011
Vwp_ih_0_148 wp_ih_0_148 0 0.899
Vwn_ih_0_148 wn_ih_0_148 0 0.3
Vwp_ih_1_148 wp_ih_1_148 0 0.6233219076641026
Vwn_ih_1_148 wn_ih_1_148 0 0.37667809233589744
Vwp_ih_2_148 wp_ih_2_148 0 0.6840632767474252
Vwn_ih_2_148 wn_ih_2_148 0 0.3159367232525748
Vwp_ih_0_149 wp_ih_0_149 0 0.49928920612008904
Vwn_ih_0_149 wn_ih_0_149 0 0.5007107938799109
Vwp_ih_1_149 wp_ih_1_149 0 0.4946828062174599
Vwn_ih_1_149 wn_ih_1_149 0 0.5053171937825401
Vwp_ih_2_149 wp_ih_2_149 0 0.7311591046838852
Vwn_ih_2_149 wn_ih_2_149 0 0.3
Vwp_ih_0_150 wp_ih_0_150 0 0.3314006292903652
Vwn_ih_0_150 wn_ih_0_150 0 0.6685993707096348
Vwp_ih_1_150 wp_ih_1_150 0 0.4477742872120521
Vwn_ih_1_150 wn_ih_1_150 0 0.552225712787948
Vwp_ih_2_150 wp_ih_2_150 0 0.3239633980356915
Vwn_ih_2_150 wn_ih_2_150 0 0.6760366019643085
Vwp_ih_0_151 wp_ih_0_151 0 0.32764658758731185
Vwn_ih_0_151 wn_ih_0_151 0 0.6723534124126882
Vwp_ih_1_151 wp_ih_1_151 0 0.6034363652135397
Vwn_ih_1_151 wn_ih_1_151 0 0.39656363478646034
Vwp_ih_2_151 wp_ih_2_151 0 0.3
Vwn_ih_2_151 wn_ih_2_151 0 0.7073133788064994
Vwp_ih_0_152 wp_ih_0_152 0 0.324381712469365
Vwn_ih_0_152 wn_ih_0_152 0 0.675618287530635
Vwp_ih_1_152 wp_ih_1_152 0 0.757639459193044
Vwn_ih_1_152 wn_ih_1_152 0 0.3
Vwp_ih_2_152 wp_ih_2_152 0 0.3
Vwn_ih_2_152 wn_ih_2_152 0 0.8987337454153883
Vwp_ih_0_153 wp_ih_0_153 0 0.6885944094309806
Vwn_ih_0_153 wn_ih_0_153 0 0.3114055905690194
Vwp_ih_1_153 wp_ih_1_153 0 0.734549715458215
Vwn_ih_1_153 wn_ih_1_153 0 0.3
Vwp_ih_2_153 wp_ih_2_153 0 0.3
Vwn_ih_2_153 wn_ih_2_153 0 0.8974828687443539
Vwp_ih_0_154 wp_ih_0_154 0 0.4994647322780718
Vwn_ih_0_154 wn_ih_0_154 0 0.5005352677219282
Vwp_ih_1_154 wp_ih_1_154 0 0.4956396944363529
Vwn_ih_1_154 wn_ih_1_154 0 0.5043603055636471
Vwp_ih_2_154 wp_ih_2_154 0 0.7850548820499289
Vwn_ih_2_154 wn_ih_2_154 0 0.3
Vwp_ih_0_155 wp_ih_0_155 0 0.49894861602393825
Vwn_ih_0_155 wn_ih_0_155 0 0.5010513839760617
Vwp_ih_1_155 wp_ih_1_155 0 0.49377617415905817
Vwn_ih_1_155 wn_ih_1_155 0 0.5062238258409418
Vwp_ih_2_155 wp_ih_2_155 0 0.681479772526955
Vwn_ih_2_155 wn_ih_2_155 0 0.318520227473045
Vwp_ih_0_156 wp_ih_0_156 0 0.3
Vwn_ih_0_156 wn_ih_0_156 0 0.7668483214606645
Vwp_ih_1_156 wp_ih_1_156 0 0.6416263794569081
Vwn_ih_1_156 wn_ih_1_156 0 0.35837362054309185
Vwp_ih_2_156 wp_ih_2_156 0 0.8986649918056894
Vwn_ih_2_156 wn_ih_2_156 0 0.3
Vwp_ih_0_157 wp_ih_0_157 0 0.3332572016491057
Vwn_ih_0_157 wn_ih_0_157 0 0.6667427983508942
Vwp_ih_1_157 wp_ih_1_157 0 0.5846672250472765
Vwn_ih_1_157 wn_ih_1_157 0 0.41533277495272347
Vwp_ih_2_157 wp_ih_2_157 0 0.6624272237246744
Vwn_ih_2_157 wn_ih_2_157 0 0.33757277627532556
Vwp_ih_0_158 wp_ih_0_158 0 0.43153741658157413
Vwn_ih_0_158 wn_ih_0_158 0 0.5684625834184258
Vwp_ih_1_158 wp_ih_1_158 0 0.5224689000816253
Vwn_ih_1_158 wn_ih_1_158 0 0.47753109991837467
Vwp_ih_2_158 wp_ih_2_158 0 0.4632889918560359
Vwn_ih_2_158 wn_ih_2_158 0 0.5367110081439641
Vwp_ih_0_159 wp_ih_0_159 0 0.5007943903093837
Vwn_ih_0_159 wn_ih_0_159 0 0.49920560969061634
Vwp_ih_1_159 wp_ih_1_159 0 0.5050567118512846
Vwn_ih_1_159 wn_ih_1_159 0 0.49494328814871535
Vwp_ih_2_159 wp_ih_2_159 0 0.3
Vwn_ih_2_159 wn_ih_2_159 0 0.7503875395706463
Vwp_ih_0_160 wp_ih_0_160 0 0.6055485104963958
Vwn_ih_0_160 wn_ih_0_160 0 0.39445148950360426
Vwp_ih_1_160 wp_ih_1_160 0 0.6448313135947841
Vwn_ih_1_160 wn_ih_1_160 0 0.3551686864052159
Vwp_ih_2_160 wp_ih_2_160 0 0.6781417906060021
Vwn_ih_2_160 wn_ih_2_160 0 0.32185820939399784
Vwp_ih_0_161 wp_ih_0_161 0 0.5119834120043985
Vwn_ih_0_161 wn_ih_0_161 0 0.4880165879956016
Vwp_ih_1_161 wp_ih_1_161 0 0.534695070957473
Vwn_ih_1_161 wn_ih_1_161 0 0.46530492904252696
Vwp_ih_2_161 wp_ih_2_161 0 0.4546039054591773
Vwn_ih_2_161 wn_ih_2_161 0 0.5453960945408227
Vwp_ih_0_162 wp_ih_0_162 0 0.6526337943769116
Vwn_ih_0_162 wn_ih_0_162 0 0.3473662056230884
Vwp_ih_1_162 wp_ih_1_162 0 0.34980635209578714
Vwn_ih_1_162 wn_ih_1_162 0 0.6501936479042129
Vwp_ih_2_162 wp_ih_2_162 0 0.6964846451190628
Vwn_ih_2_162 wn_ih_2_162 0 0.30351535488093717
Vwp_ih_0_163 wp_ih_0_163 0 0.47958168802375717
Vwn_ih_0_163 wn_ih_0_163 0 0.5204183119762428
Vwp_ih_1_163 wp_ih_1_163 0 0.4474252634708989
Vwn_ih_1_163 wn_ih_1_163 0 0.552574736529101
Vwp_ih_2_163 wp_ih_2_163 0 0.5312681666330743
Vwn_ih_2_163 wn_ih_2_163 0 0.4687318333669257
Vwp_ih_0_164 wp_ih_0_164 0 0.6586469823534632
Vwn_ih_0_164 wn_ih_0_164 0 0.3413530176465368
Vwp_ih_1_164 wp_ih_1_164 0 0.6241713921196845
Vwn_ih_1_164 wn_ih_1_164 0 0.37582860788031547
Vwp_ih_2_164 wp_ih_2_164 0 0.34816339739080004
Vwn_ih_2_164 wn_ih_2_164 0 0.6518366026092
Vwp_ih_0_165 wp_ih_0_165 0 0.3
Vwn_ih_0_165 wn_ih_0_165 0 0.7203823409901963
Vwp_ih_1_165 wp_ih_1_165 0 0.3248603971723998
Vwn_ih_1_165 wn_ih_1_165 0 0.6751396028276002
Vwp_ih_2_165 wp_ih_2_165 0 0.49347946461532505
Vwn_ih_2_165 wn_ih_2_165 0 0.5065205353846749
Vwp_ih_0_166 wp_ih_0_166 0 0.5180674338193194
Vwn_ih_0_166 wn_ih_0_166 0 0.4819325661806806
Vwp_ih_1_166 wp_ih_1_166 0 0.3665759586363795
Vwn_ih_1_166 wn_ih_1_166 0 0.6334240413636205
Vwp_ih_2_166 wp_ih_2_166 0 0.5089701799045132
Vwn_ih_2_166 wn_ih_2_166 0 0.4910298200954868
Vwp_ih_0_167 wp_ih_0_167 0 0.5969559226740753
Vwn_ih_0_167 wn_ih_0_167 0 0.4030440773259247
Vwp_ih_1_167 wp_ih_1_167 0 0.4985159335324741
Vwn_ih_1_167 wn_ih_1_167 0 0.5014840664675259
Vwp_ih_2_167 wp_ih_2_167 0 0.5237558545560111
Vwn_ih_2_167 wn_ih_2_167 0 0.4762441454439888
Vwp_ih_0_168 wp_ih_0_168 0 0.3
Vwn_ih_0_168 wn_ih_0_168 0 0.7373702873964763
Vwp_ih_1_168 wp_ih_1_168 0 0.5668921182199933
Vwn_ih_1_168 wn_ih_1_168 0 0.43310788178000675
Vwp_ih_2_168 wp_ih_2_168 0 0.3
Vwn_ih_2_168 wn_ih_2_168 0 0.83364472306989
Vwp_ih_0_169 wp_ih_0_169 0 0.38551701564947977
Vwn_ih_0_169 wn_ih_0_169 0 0.6144829843505203
Vwp_ih_1_169 wp_ih_1_169 0 0.6559287469141908
Vwn_ih_1_169 wn_ih_1_169 0 0.3440712530858092
Vwp_ih_2_169 wp_ih_2_169 0 0.34595637169858995
Vwn_ih_2_169 wn_ih_2_169 0 0.65404362830141
Vwp_ih_0_170 wp_ih_0_170 0 0.4997228244886342
Vwn_ih_0_170 wn_ih_0_170 0 0.5002771755113659
Vwp_ih_1_170 wp_ih_1_170 0 0.492752779013383
Vwn_ih_1_170 wn_ih_1_170 0 0.507247220986617
Vwp_ih_2_170 wp_ih_2_170 0 0.6598011605533081
Vwn_ih_2_170 wn_ih_2_170 0 0.34019883944669194
Vwp_ih_0_171 wp_ih_0_171 0 0.899
Vwn_ih_0_171 wn_ih_0_171 0 0.3
Vwp_ih_1_171 wp_ih_1_171 0 0.4813487336717781
Vwn_ih_1_171 wn_ih_1_171 0 0.5186512663282219
Vwp_ih_2_171 wp_ih_2_171 0 0.656018789205642
Vwn_ih_2_171 wn_ih_2_171 0 0.34398121079435795
Vwp_ih_0_172 wp_ih_0_172 0 0.3869599748265939
Vwn_ih_0_172 wn_ih_0_172 0 0.6130400251734062
Vwp_ih_1_172 wp_ih_1_172 0 0.3
Vwn_ih_1_172 wn_ih_1_172 0 0.898471673373868
Vwp_ih_2_172 wp_ih_2_172 0 0.6682046697980384
Vwn_ih_2_172 wn_ih_2_172 0 0.33179533020196156
Vwp_ih_0_173 wp_ih_0_173 0 0.6559094262647845
Vwn_ih_0_173 wn_ih_0_173 0 0.34409057373521545
Vwp_ih_1_173 wp_ih_1_173 0 0.7138701695358516
Vwn_ih_1_173 wn_ih_1_173 0 0.3
Vwp_ih_2_173 wp_ih_2_173 0 0.3
Vwn_ih_2_173 wn_ih_2_173 0 0.8438005151063774
Vwp_ih_0_174 wp_ih_0_174 0 0.44231870018153274
Vwn_ih_0_174 wn_ih_0_174 0 0.5576812998184673
Vwp_ih_1_174 wp_ih_1_174 0 0.8205931325962379
Vwn_ih_1_174 wn_ih_1_174 0 0.3
Vwp_ih_2_174 wp_ih_2_174 0 0.899
Vwn_ih_2_174 wn_ih_2_174 0 0.3
Vwp_ih_0_175 wp_ih_0_175 0 0.5752205820251215
Vwn_ih_0_175 wn_ih_0_175 0 0.4247794179748785
Vwp_ih_1_175 wp_ih_1_175 0 0.6765253205350634
Vwn_ih_1_175 wn_ih_1_175 0 0.3234746794649366
Vwp_ih_2_175 wp_ih_2_175 0 0.34234567864552823
Vwn_ih_2_175 wn_ih_2_175 0 0.6576543213544718
Vwp_ih_0_176 wp_ih_0_176 0 0.41573682002619633
Vwn_ih_0_176 wn_ih_0_176 0 0.5842631799738037
Vwp_ih_1_176 wp_ih_1_176 0 0.3
Vwn_ih_1_176 wn_ih_1_176 0 0.7318556106954909
Vwp_ih_2_176 wp_ih_2_176 0 0.7862920988860403
Vwn_ih_2_176 wn_ih_2_176 0 0.3
Vwp_ih_0_177 wp_ih_0_177 0 0.4990475936611722
Vwn_ih_0_177 wn_ih_0_177 0 0.5009524063388279
Vwp_ih_1_177 wp_ih_1_177 0 0.49406838231603173
Vwn_ih_1_177 wn_ih_1_177 0 0.5059316176839683
Vwp_ih_2_177 wp_ih_2_177 0 0.7098962816545701
Vwn_ih_2_177 wn_ih_2_177 0 0.3
Vwp_ih_0_178 wp_ih_0_178 0 0.49914419309588703
Vwn_ih_0_178 wn_ih_0_178 0 0.500855806904113
Vwp_ih_1_178 wp_ih_1_178 0 0.6848799332725082
Vwn_ih_1_178 wn_ih_1_178 0 0.3151200667274918
Vwp_ih_2_178 wp_ih_2_178 0 0.36899348601644605
Vwn_ih_2_178 wn_ih_2_178 0 0.6310065139835539
Vwp_ih_0_179 wp_ih_0_179 0 0.6319836919787126
Vwn_ih_0_179 wn_ih_0_179 0 0.3680163080212874
Vwp_ih_1_179 wp_ih_1_179 0 0.3812302004561783
Vwn_ih_1_179 wn_ih_1_179 0 0.6187697995438217
Vwp_ih_2_179 wp_ih_2_179 0 0.3844403576165265
Vwn_ih_2_179 wn_ih_2_179 0 0.6155596423834735
Vwp_ih_0_180 wp_ih_0_180 0 0.3673418469623343
Vwn_ih_0_180 wn_ih_0_180 0 0.6326581530376657
Vwp_ih_1_180 wp_ih_1_180 0 0.40779465139145676
Vwn_ih_1_180 wn_ih_1_180 0 0.5922053486085432
Vwp_ih_2_180 wp_ih_2_180 0 0.47020534336020625
Vwn_ih_2_180 wn_ih_2_180 0 0.5297946566397937
Vwp_ih_0_181 wp_ih_0_181 0 0.7370952064419185
Vwn_ih_0_181 wn_ih_0_181 0 0.3
Vwp_ih_1_181 wp_ih_1_181 0 0.329773258028066
Vwn_ih_1_181 wn_ih_1_181 0 0.670226741971934
Vwp_ih_2_181 wp_ih_2_181 0 0.899
Vwn_ih_2_181 wn_ih_2_181 0 0.3
Vwp_ih_0_182 wp_ih_0_182 0 0.6663004927923413
Vwn_ih_0_182 wn_ih_0_182 0 0.33369950720765873
Vwp_ih_1_182 wp_ih_1_182 0 0.6149100761840998
Vwn_ih_1_182 wn_ih_1_182 0 0.38508992381590024
Vwp_ih_2_182 wp_ih_2_182 0 0.3090829350764224
Vwn_ih_2_182 wn_ih_2_182 0 0.6909170649235776
Vwp_ih_0_183 wp_ih_0_183 0 0.6202269068873882
Vwn_ih_0_183 wn_ih_0_183 0 0.3797730931126117
Vwp_ih_1_183 wp_ih_1_183 0 0.6776858617828491
Vwn_ih_1_183 wn_ih_1_183 0 0.32231413821715094
Vwp_ih_2_183 wp_ih_2_183 0 0.7741909532992823
Vwn_ih_2_183 wn_ih_2_183 0 0.3
Vwp_ih_0_184 wp_ih_0_184 0 0.499950462051443
Vwn_ih_0_184 wn_ih_0_184 0 0.500049537948557
Vwp_ih_1_184 wp_ih_1_184 0 0.492441364604458
Vwn_ih_1_184 wn_ih_1_184 0 0.507558635395542
Vwp_ih_2_184 wp_ih_2_184 0 0.6556384933764878
Vwn_ih_2_184 wn_ih_2_184 0 0.34436150662351217
Vwp_ih_0_185 wp_ih_0_185 0 0.50119743048643
Vwn_ih_0_185 wn_ih_0_185 0 0.4988025695135701
Vwp_ih_1_185 wp_ih_1_185 0 0.48971207223013
Vwn_ih_1_185 wn_ih_1_185 0 0.51028792776987
Vwp_ih_2_185 wp_ih_2_185 0 0.6324789610725041
Vwn_ih_2_185 wn_ih_2_185 0 0.36752103892749594
Vwp_ih_0_186 wp_ih_0_186 0 0.49930787475922034
Vwn_ih_0_186 wn_ih_0_186 0 0.5006921252407797
Vwp_ih_1_186 wp_ih_1_186 0 0.4963740485967046
Vwn_ih_1_186 wn_ih_1_186 0 0.5036259514032955
Vwp_ih_2_186 wp_ih_2_186 0 0.899
Vwn_ih_2_186 wn_ih_2_186 0 0.3
Vwp_ih_0_187 wp_ih_0_187 0 0.6435676241942366
Vwn_ih_0_187 wn_ih_0_187 0 0.35643237580576337
Vwp_ih_1_187 wp_ih_1_187 0 0.3957642849962842
Vwn_ih_1_187 wn_ih_1_187 0 0.6042357150037159
Vwp_ih_2_187 wp_ih_2_187 0 0.38728203709796816
Vwn_ih_2_187 wn_ih_2_187 0 0.6127179629020318
Vwp_ih_0_188 wp_ih_0_188 0 0.7310883777227619
Vwn_ih_0_188 wn_ih_0_188 0 0.3
Vwp_ih_1_188 wp_ih_1_188 0 0.3197647585223039
Vwn_ih_1_188 wn_ih_1_188 0 0.6802352414776961
Vwp_ih_2_188 wp_ih_2_188 0 0.899
Vwn_ih_2_188 wn_ih_2_188 0 0.3
Vwp_ih_0_189 wp_ih_0_189 0 0.49943324167288494
Vwn_ih_0_189 wn_ih_0_189 0 0.5005667583271151
Vwp_ih_1_189 wp_ih_1_189 0 0.4925625166726881
Vwn_ih_1_189 wn_ih_1_189 0 0.5074374833273119
Vwp_ih_2_189 wp_ih_2_189 0 0.6479582872277244
Vwn_ih_2_189 wn_ih_2_189 0 0.3520417127722756
Vwp_ih_0_190 wp_ih_0_190 0 0.899
Vwn_ih_0_190 wn_ih_0_190 0 0.3
Vwp_ih_1_190 wp_ih_1_190 0 0.40547715231432346
Vwn_ih_1_190 wn_ih_1_190 0 0.5945228476856765
Vwp_ih_2_190 wp_ih_2_190 0 0.3228648768772702
Vwn_ih_2_190 wn_ih_2_190 0 0.6771351231227298
Vwp_ih_0_191 wp_ih_0_191 0 0.4993536273747279
Vwn_ih_0_191 wn_ih_0_191 0 0.5006463726252721
Vwp_ih_1_191 wp_ih_1_191 0 0.496314015730569
Vwn_ih_1_191 wn_ih_1_191 0 0.503685984269431
Vwp_ih_2_191 wp_ih_2_191 0 0.899
Vwn_ih_2_191 wn_ih_2_191 0 0.3
Vwp_ih_0_192 wp_ih_0_192 0 0.3665611750559233
Vwn_ih_0_192 wn_ih_0_192 0 0.6334388249440768
Vwp_ih_1_192 wp_ih_1_192 0 0.4293568164877033
Vwn_ih_1_192 wn_ih_1_192 0 0.5706431835122967
Vwp_ih_2_192 wp_ih_2_192 0 0.3936718295541685
Vwn_ih_2_192 wn_ih_2_192 0 0.6063281704458314
Vwp_ih_0_193 wp_ih_0_193 0 0.3547211620346354
Vwn_ih_0_193 wn_ih_0_193 0 0.6452788379653647
Vwp_ih_1_193 wp_ih_1_193 0 0.7450065630841063
Vwn_ih_1_193 wn_ih_1_193 0 0.3
Vwp_ih_2_193 wp_ih_2_193 0 0.8699781057134734
Vwn_ih_2_193 wn_ih_2_193 0 0.3
Vwp_ih_0_194 wp_ih_0_194 0 0.6978311046329442
Vwn_ih_0_194 wn_ih_0_194 0 0.30216889536705577
Vwp_ih_1_194 wp_ih_1_194 0 0.4136114209056527
Vwn_ih_1_194 wn_ih_1_194 0 0.5863885790943473
Vwp_ih_2_194 wp_ih_2_194 0 0.3
Vwn_ih_2_194 wn_ih_2_194 0 0.7384299110874817
Vwp_ih_0_195 wp_ih_0_195 0 0.46656971104812284
Vwn_ih_0_195 wn_ih_0_195 0 0.5334302889518772
Vwp_ih_1_195 wp_ih_1_195 0 0.3427118750221876
Vwn_ih_1_195 wn_ih_1_195 0 0.6572881249778124
Vwp_ih_2_195 wp_ih_2_195 0 0.5825461985095094
Vwn_ih_2_195 wn_ih_2_195 0 0.4174538014904906
Vwp_ih_0_196 wp_ih_0_196 0 0.8731068215201068
Vwn_ih_0_196 wn_ih_0_196 0 0.3
Vwp_ih_1_196 wp_ih_1_196 0 0.3
Vwn_ih_1_196 wn_ih_1_196 0 0.8857912843819855
Vwp_ih_2_196 wp_ih_2_196 0 0.776238241260123
Vwn_ih_2_196 wn_ih_2_196 0 0.3
Vwp_ih_0_197 wp_ih_0_197 0 0.8473229409317508
Vwn_ih_0_197 wn_ih_0_197 0 0.3
Vwp_ih_1_197 wp_ih_1_197 0 0.3
Vwn_ih_1_197 wn_ih_1_197 0 0.8975499631160003
Vwp_ih_2_197 wp_ih_2_197 0 0.7750973478866796
Vwn_ih_2_197 wn_ih_2_197 0 0.3
Vwp_ih_0_198 wp_ih_0_198 0 0.338042483836638
Vwn_ih_0_198 wn_ih_0_198 0 0.661957516163362
Vwp_ih_1_198 wp_ih_1_198 0 0.3487643731681606
Vwn_ih_1_198 wn_ih_1_198 0 0.6512356268318393
Vwp_ih_2_198 wp_ih_2_198 0 0.7429547360785135
Vwn_ih_2_198 wn_ih_2_198 0 0.3
Vwp_ih_0_199 wp_ih_0_199 0 0.899
Vwn_ih_0_199 wn_ih_0_199 0 0.3
Vwp_ih_1_199 wp_ih_1_199 0 0.8153995820157376
Vwn_ih_1_199 wn_ih_1_199 0 0.3
Vwp_ih_2_199 wp_ih_2_199 0 0.3
Vwn_ih_2_199 wn_ih_2_199 0 0.7802108719480759
Vwp_ho_0_0 wp_ho_0_0 0 0.5101965896021101
Vwn_ho_0_0 wn_ho_0_0 0 0.4898034103978899
Vwp_ho_1_0 wp_ho_1_0 0 0.47785258749583864
Vwn_ho_1_0 wn_ho_1_0 0 0.5221474125041614
Vwp_ho_2_0 wp_ho_2_0 0 0.4997514418551939
Vwn_ho_2_0 wn_ho_2_0 0 0.5002485581448061
Vwp_ho_3_0 wp_ho_3_0 0 0.504322248963464
Vwn_ho_3_0 wn_ho_3_0 0 0.495677751036536
Vwp_ho_4_0 wp_ho_4_0 0 0.51026197514486
Vwn_ho_4_0 wn_ho_4_0 0 0.4897380248551399
Vwp_ho_5_0 wp_ho_5_0 0 0.42519091286621913
Vwn_ho_5_0 wn_ho_5_0 0 0.5748090871337809
Vwp_ho_6_0 wp_ho_6_0 0 0.39164698177799867
Vwn_ho_6_0 wn_ho_6_0 0 0.6083530182220013
Vwp_ho_7_0 wp_ho_7_0 0 0.5844812565153173
Vwn_ho_7_0 wn_ho_7_0 0 0.41551874348468265
Vwp_ho_8_0 wp_ho_8_0 0 0.4527115454222174
Vwn_ho_8_0 wn_ho_8_0 0 0.5472884545777826
Vwp_ho_9_0 wp_ho_9_0 0 0.49748078863705786
Vwn_ho_9_0 wn_ho_9_0 0 0.5025192113629422
Vwp_ho_10_0 wp_ho_10_0 0 0.53429505116045
Vwn_ho_10_0 wn_ho_10_0 0 0.46570494883955005
Vwp_ho_11_0 wp_ho_11_0 0 0.5785887059383916
Vwn_ho_11_0 wn_ho_11_0 0 0.4214112940616083
Vwp_ho_12_0 wp_ho_12_0 0 0.4984889932282262
Vwn_ho_12_0 wn_ho_12_0 0 0.5015110067717737
Vwp_ho_13_0 wp_ho_13_0 0 0.5682950655261002
Vwn_ho_13_0 wn_ho_13_0 0 0.4317049344738998
Vwp_ho_14_0 wp_ho_14_0 0 0.40900012190658475
Vwn_ho_14_0 wn_ho_14_0 0 0.5909998780934153
Vwp_ho_15_0 wp_ho_15_0 0 0.5551504990952434
Vwn_ho_15_0 wn_ho_15_0 0 0.4448495009047566
Vwp_ho_16_0 wp_ho_16_0 0 0.534817292283535
Vwn_ho_16_0 wn_ho_16_0 0 0.465182707716465
Vwp_ho_17_0 wp_ho_17_0 0 0.6084964902951199
Vwn_ho_17_0 wn_ho_17_0 0 0.39150350970488007
Vwp_ho_18_0 wp_ho_18_0 0 0.5183994423514736
Vwn_ho_18_0 wn_ho_18_0 0 0.4816005576485264
Vwp_ho_19_0 wp_ho_19_0 0 0.5317795081560502
Vwn_ho_19_0 wn_ho_19_0 0 0.46822049184394976
Vwp_ho_20_0 wp_ho_20_0 0 0.49440367054967943
Vwn_ho_20_0 wn_ho_20_0 0 0.5055963294503206
Vwp_ho_21_0 wp_ho_21_0 0 0.4129858428168859
Vwn_ho_21_0 wn_ho_21_0 0 0.5870141571831141
Vwp_ho_22_0 wp_ho_22_0 0 0.5250942567510777
Vwn_ho_22_0 wn_ho_22_0 0 0.47490574324892226
Vwp_ho_23_0 wp_ho_23_0 0 0.5087585767697067
Vwn_ho_23_0 wn_ho_23_0 0 0.49124142323029335
Vwp_ho_24_0 wp_ho_24_0 0 0.49525273428559313
Vwn_ho_24_0 wn_ho_24_0 0 0.5047472657144069
Vwp_ho_25_0 wp_ho_25_0 0 0.48388068229291764
Vwn_ho_25_0 wn_ho_25_0 0 0.5161193177070823
Vwp_ho_26_0 wp_ho_26_0 0 0.48709144309354774
Vwn_ho_26_0 wn_ho_26_0 0 0.5129085569064522
Vwp_ho_27_0 wp_ho_27_0 0 0.5015786521645498
Vwn_ho_27_0 wn_ho_27_0 0 0.4984213478354502
Vwp_ho_28_0 wp_ho_28_0 0 0.49686508934271606
Vwn_ho_28_0 wn_ho_28_0 0 0.503134910657284
Vwp_ho_29_0 wp_ho_29_0 0 0.500628226945991
Vwn_ho_29_0 wn_ho_29_0 0 0.49937177305400904
Vwp_ho_30_0 wp_ho_30_0 0 0.47138406101059743
Vwn_ho_30_0 wn_ho_30_0 0 0.5286159389894025
Vwp_ho_31_0 wp_ho_31_0 0 0.5275545319173296
Vwn_ho_31_0 wn_ho_31_0 0 0.4724454680826704
Vwp_ho_32_0 wp_ho_32_0 0 0.519553062052159
Vwn_ho_32_0 wn_ho_32_0 0 0.480446937947841
Vwp_ho_33_0 wp_ho_33_0 0 0.5144506217663491
Vwn_ho_33_0 wn_ho_33_0 0 0.4855493782336508
Vwp_ho_34_0 wp_ho_34_0 0 0.6126694993855879
Vwn_ho_34_0 wn_ho_34_0 0 0.3873305006144121
Vwp_ho_35_0 wp_ho_35_0 0 0.5023838703663203
Vwn_ho_35_0 wn_ho_35_0 0 0.49761612963367974
Vwp_ho_36_0 wp_ho_36_0 0 0.44889373682633965
Vwn_ho_36_0 wn_ho_36_0 0 0.5511062631736604
Vwp_ho_37_0 wp_ho_37_0 0 0.5659283912667323
Vwn_ho_37_0 wn_ho_37_0 0 0.4340716087332677
Vwp_ho_38_0 wp_ho_38_0 0 0.5378248241566079
Vwn_ho_38_0 wn_ho_38_0 0 0.46217517584339207
Vwp_ho_39_0 wp_ho_39_0 0 0.6116680641558278
Vwn_ho_39_0 wn_ho_39_0 0 0.38833193584417225
Vwp_ho_40_0 wp_ho_40_0 0 0.46140453057745506
Vwn_ho_40_0 wn_ho_40_0 0 0.5385954694225449
Vwp_ho_41_0 wp_ho_41_0 0 0.5244631090372179
Vwn_ho_41_0 wn_ho_41_0 0 0.47553689096278207
Vwp_ho_42_0 wp_ho_42_0 0 0.4615713011058726
Vwn_ho_42_0 wn_ho_42_0 0 0.5384286988941275
Vwp_ho_43_0 wp_ho_43_0 0 0.519227180847094
Vwn_ho_43_0 wn_ho_43_0 0 0.48077281915290604
Vwp_ho_44_0 wp_ho_44_0 0 0.45141934644004844
Vwn_ho_44_0 wn_ho_44_0 0 0.5485806535599516
Vwp_ho_45_0 wp_ho_45_0 0 0.5088767774304893
Vwn_ho_45_0 wn_ho_45_0 0 0.4911232225695107
Vwp_ho_46_0 wp_ho_46_0 0 0.5129889575175995
Vwn_ho_46_0 wn_ho_46_0 0 0.48701104248240046
Vwp_ho_47_0 wp_ho_47_0 0 0.4962434325090706
Vwn_ho_47_0 wn_ho_47_0 0 0.5037565674909295
Vwp_ho_48_0 wp_ho_48_0 0 0.39288767634924937
Vwn_ho_48_0 wn_ho_48_0 0 0.6071123236507506
Vwp_ho_49_0 wp_ho_49_0 0 0.4279632178424992
Vwn_ho_49_0 wn_ho_49_0 0 0.5720367821575008
Vwp_ho_50_0 wp_ho_50_0 0 0.5202604928588769
Vwn_ho_50_0 wn_ho_50_0 0 0.4797395071411232
Vwp_ho_51_0 wp_ho_51_0 0 0.4503584564083912
Vwn_ho_51_0 wn_ho_51_0 0 0.5496415435916089
Vwp_ho_52_0 wp_ho_52_0 0 0.5969949714091417
Vwn_ho_52_0 wn_ho_52_0 0 0.40300502859085835
Vwp_ho_53_0 wp_ho_53_0 0 0.49964147057139285
Vwn_ho_53_0 wn_ho_53_0 0 0.5003585294286071
Vwp_ho_54_0 wp_ho_54_0 0 0.4910349041527853
Vwn_ho_54_0 wn_ho_54_0 0 0.5089650958472147
Vwp_ho_55_0 wp_ho_55_0 0 0.4881019361141853
Vwn_ho_55_0 wn_ho_55_0 0 0.5118980638858147
Vwp_ho_56_0 wp_ho_56_0 0 0.5896266937522554
Vwn_ho_56_0 wn_ho_56_0 0 0.4103733062477446
Vwp_ho_57_0 wp_ho_57_0 0 0.521763875123435
Vwn_ho_57_0 wn_ho_57_0 0 0.47823612487656497
Vwp_ho_58_0 wp_ho_58_0 0 0.45958794454594376
Vwn_ho_58_0 wn_ho_58_0 0 0.5404120554540562
Vwp_ho_59_0 wp_ho_59_0 0 0.5036843513094393
Vwn_ho_59_0 wn_ho_59_0 0 0.4963156486905607
Vwp_ho_60_0 wp_ho_60_0 0 0.4201178664546002
Vwn_ho_60_0 wn_ho_60_0 0 0.5798821335453999
Vwp_ho_61_0 wp_ho_61_0 0 0.5065557255816
Vwn_ho_61_0 wn_ho_61_0 0 0.4934442744184
Vwp_ho_62_0 wp_ho_62_0 0 0.6157195607085479
Vwn_ho_62_0 wn_ho_62_0 0 0.38428043929145206
Vwp_ho_63_0 wp_ho_63_0 0 0.38402809526490317
Vwn_ho_63_0 wn_ho_63_0 0 0.6159719047350969
Vwp_ho_64_0 wp_ho_64_0 0 0.5302359397273109
Vwn_ho_64_0 wn_ho_64_0 0 0.4697640602726891
Vwp_ho_65_0 wp_ho_65_0 0 0.6073716232422783
Vwn_ho_65_0 wn_ho_65_0 0 0.39262837675772166
Vwp_ho_66_0 wp_ho_66_0 0 0.41723692554794767
Vwn_ho_66_0 wn_ho_66_0 0 0.5827630744520523
Vwp_ho_67_0 wp_ho_67_0 0 0.46716066035705783
Vwn_ho_67_0 wn_ho_67_0 0 0.5328393396429422
Vwp_ho_68_0 wp_ho_68_0 0 0.5937702215225071
Vwn_ho_68_0 wn_ho_68_0 0 0.40622977847749286
Vwp_ho_69_0 wp_ho_69_0 0 0.5207923772705638
Vwn_ho_69_0 wn_ho_69_0 0 0.4792076227294361
Vwp_ho_70_0 wp_ho_70_0 0 0.5008246808427176
Vwn_ho_70_0 wn_ho_70_0 0 0.4991753191572824
Vwp_ho_71_0 wp_ho_71_0 0 0.5101070762930433
Vwn_ho_71_0 wn_ho_71_0 0 0.48989292370695675
Vwp_ho_72_0 wp_ho_72_0 0 0.47567975749085345
Vwn_ho_72_0 wn_ho_72_0 0 0.5243202425091466
Vwp_ho_73_0 wp_ho_73_0 0 0.47202284918397547
Vwn_ho_73_0 wn_ho_73_0 0 0.5279771508160245
Vwp_ho_74_0 wp_ho_74_0 0 0.5008159897944916
Vwn_ho_74_0 wn_ho_74_0 0 0.49918401020550834
Vwp_ho_75_0 wp_ho_75_0 0 0.50581520616543
Vwn_ho_75_0 wn_ho_75_0 0 0.4941847938345701
Vwp_ho_76_0 wp_ho_76_0 0 0.4908695386866811
Vwn_ho_76_0 wn_ho_76_0 0 0.5091304613133188
Vwp_ho_77_0 wp_ho_77_0 0 0.42393254263624075
Vwn_ho_77_0 wn_ho_77_0 0 0.5760674573637593
Vwp_ho_78_0 wp_ho_78_0 0 0.5194665286376169
Vwn_ho_78_0 wn_ho_78_0 0 0.48053347136238306
Vwp_ho_79_0 wp_ho_79_0 0 0.5073045395509006
Vwn_ho_79_0 wn_ho_79_0 0 0.49269546044909945
Vwp_ho_80_0 wp_ho_80_0 0 0.4280570807537706
Vwn_ho_80_0 wn_ho_80_0 0 0.5719429192462294
Vwp_ho_81_0 wp_ho_81_0 0 0.48274878604306015
Vwn_ho_81_0 wn_ho_81_0 0 0.5172512139569398
Vwp_ho_82_0 wp_ho_82_0 0 0.5143283521127583
Vwn_ho_82_0 wn_ho_82_0 0 0.4856716478872417
Vwp_ho_83_0 wp_ho_83_0 0 0.501454547593714
Vwn_ho_83_0 wn_ho_83_0 0 0.49854545240628606
Vwp_ho_84_0 wp_ho_84_0 0 0.49328290373848965
Vwn_ho_84_0 wn_ho_84_0 0 0.5067170962615104
Vwp_ho_85_0 wp_ho_85_0 0 0.5047255357548741
Vwn_ho_85_0 wn_ho_85_0 0 0.4952744642451259
Vwp_ho_86_0 wp_ho_86_0 0 0.5035231151171883
Vwn_ho_86_0 wn_ho_86_0 0 0.49647688488281166
Vwp_ho_87_0 wp_ho_87_0 0 0.4700099289704927
Vwn_ho_87_0 wn_ho_87_0 0 0.5299900710295073
Vwp_ho_88_0 wp_ho_88_0 0 0.5327874600575372
Vwn_ho_88_0 wn_ho_88_0 0 0.4672125399424628
Vwp_ho_89_0 wp_ho_89_0 0 0.5076483788046979
Vwn_ho_89_0 wn_ho_89_0 0 0.492351621195302
Vwp_ho_90_0 wp_ho_90_0 0 0.4810284929170711
Vwn_ho_90_0 wn_ho_90_0 0 0.5189715070829289
Vwp_ho_91_0 wp_ho_91_0 0 0.4785916268808932
Vwn_ho_91_0 wn_ho_91_0 0 0.5214083731191068
Vwp_ho_92_0 wp_ho_92_0 0 0.48880438596288756
Vwn_ho_92_0 wn_ho_92_0 0 0.5111956140371124
Vwp_ho_93_0 wp_ho_93_0 0 0.5117430716814267
Vwn_ho_93_0 wn_ho_93_0 0 0.4882569283185732
Vwp_ho_94_0 wp_ho_94_0 0 0.514358780859947
Vwn_ho_94_0 wn_ho_94_0 0 0.4856412191400529
Vwp_ho_95_0 wp_ho_95_0 0 0.4863793788859161
Vwn_ho_95_0 wn_ho_95_0 0 0.5136206211140839
Vwp_ho_96_0 wp_ho_96_0 0 0.49472893139171603
Vwn_ho_96_0 wn_ho_96_0 0 0.505271068608284
Vwp_ho_97_0 wp_ho_97_0 0 0.4862370847362032
Vwn_ho_97_0 wn_ho_97_0 0 0.5137629152637968
Vwp_ho_98_0 wp_ho_98_0 0 0.4970945544203201
Vwn_ho_98_0 wn_ho_98_0 0 0.50290544557968
Vwp_ho_99_0 wp_ho_99_0 0 0.586121216802405
Vwn_ho_99_0 wn_ho_99_0 0 0.41387878319759497
Vwp_ho_100_0 wp_ho_100_0 0 0.5035847717529135
Vwn_ho_100_0 wn_ho_100_0 0 0.4964152282470865
Vwp_ho_101_0 wp_ho_101_0 0 0.5292619410985266
Vwn_ho_101_0 wn_ho_101_0 0 0.47073805890147336
Vwp_ho_102_0 wp_ho_102_0 0 0.5253038287471254
Vwn_ho_102_0 wn_ho_102_0 0 0.4746961712528746
Vwp_ho_103_0 wp_ho_103_0 0 0.502011679365429
Vwn_ho_103_0 wn_ho_103_0 0 0.49798832063457094
Vwp_ho_104_0 wp_ho_104_0 0 0.5194316397231832
Vwn_ho_104_0 wn_ho_104_0 0 0.48056836027681676
Vwp_ho_105_0 wp_ho_105_0 0 0.5192916392184089
Vwn_ho_105_0 wn_ho_105_0 0 0.4807083607815911
Vwp_ho_106_0 wp_ho_106_0 0 0.47061898560516024
Vwn_ho_106_0 wn_ho_106_0 0 0.5293810143948398
Vwp_ho_107_0 wp_ho_107_0 0 0.4875051308607182
Vwn_ho_107_0 wn_ho_107_0 0 0.5124948691392818
Vwp_ho_108_0 wp_ho_108_0 0 0.4742900030016954
Vwn_ho_108_0 wn_ho_108_0 0 0.5257099969983046
Vwp_ho_109_0 wp_ho_109_0 0 0.5145782175406162
Vwn_ho_109_0 wn_ho_109_0 0 0.48542178245938383
Vwp_ho_110_0 wp_ho_110_0 0 0.4586179664182256
Vwn_ho_110_0 wn_ho_110_0 0 0.5413820335817744
Vwp_ho_111_0 wp_ho_111_0 0 0.4920007553613971
Vwn_ho_111_0 wn_ho_111_0 0 0.5079992446386029
Vwp_ho_112_0 wp_ho_112_0 0 0.49949188057348354
Vwn_ho_112_0 wn_ho_112_0 0 0.5005081194265164
Vwp_ho_113_0 wp_ho_113_0 0 0.5018757937183385
Vwn_ho_113_0 wn_ho_113_0 0 0.49812420628166154
Vwp_ho_114_0 wp_ho_114_0 0 0.4875794194578893
Vwn_ho_114_0 wn_ho_114_0 0 0.5124205805421107
Vwp_ho_115_0 wp_ho_115_0 0 0.4612466547328656
Vwn_ho_115_0 wn_ho_115_0 0 0.5387533452671344
Vwp_ho_116_0 wp_ho_116_0 0 0.5004333173163644
Vwn_ho_116_0 wn_ho_116_0 0 0.49956668268363563
Vwp_ho_117_0 wp_ho_117_0 0 0.49361061491052927
Vwn_ho_117_0 wn_ho_117_0 0 0.5063893850894707
Vwp_ho_118_0 wp_ho_118_0 0 0.5215333420064778
Vwn_ho_118_0 wn_ho_118_0 0 0.4784666579935221
Vwp_ho_119_0 wp_ho_119_0 0 0.5873180719362893
Vwn_ho_119_0 wn_ho_119_0 0 0.41268192806371073
Vwp_ho_120_0 wp_ho_120_0 0 0.5120452802714304
Vwn_ho_120_0 wn_ho_120_0 0 0.4879547197285696
Vwp_ho_121_0 wp_ho_121_0 0 0.3984760150718536
Vwn_ho_121_0 wn_ho_121_0 0 0.6015239849281464
Vwp_ho_122_0 wp_ho_122_0 0 0.49113640221489735
Vwn_ho_122_0 wn_ho_122_0 0 0.5088635977851026
Vwp_ho_123_0 wp_ho_123_0 0 0.40603580529270816
Vwn_ho_123_0 wn_ho_123_0 0 0.5939641947072919
Vwp_ho_124_0 wp_ho_124_0 0 0.49795288494932066
Vwn_ho_124_0 wn_ho_124_0 0 0.5020471150506793
Vwp_ho_125_0 wp_ho_125_0 0 0.4684953558765237
Vwn_ho_125_0 wn_ho_125_0 0 0.5315046441234763
Vwp_ho_126_0 wp_ho_126_0 0 0.5183619733057141
Vwn_ho_126_0 wn_ho_126_0 0 0.4816380266942859
Vwp_ho_127_0 wp_ho_127_0 0 0.5221789735835511
Vwn_ho_127_0 wn_ho_127_0 0 0.47782102641644886
Vwp_ho_128_0 wp_ho_128_0 0 0.500712968513442
Vwn_ho_128_0 wn_ho_128_0 0 0.49928703148655795
Vwp_ho_129_0 wp_ho_129_0 0 0.48623787597436907
Vwn_ho_129_0 wn_ho_129_0 0 0.5137621240256309
Vwp_ho_130_0 wp_ho_130_0 0 0.5376682417518737
Vwn_ho_130_0 wn_ho_130_0 0 0.4623317582481264
Vwp_ho_131_0 wp_ho_131_0 0 0.5417341314272978
Vwn_ho_131_0 wn_ho_131_0 0 0.45826586857270224
Vwp_ho_132_0 wp_ho_132_0 0 0.41388209756454386
Vwn_ho_132_0 wn_ho_132_0 0 0.5861179024354561
Vwp_ho_133_0 wp_ho_133_0 0 0.5268414563074685
Vwn_ho_133_0 wn_ho_133_0 0 0.4731585436925315
Vwp_ho_134_0 wp_ho_134_0 0 0.4750157620018343
Vwn_ho_134_0 wn_ho_134_0 0 0.5249842379981657
Vwp_ho_135_0 wp_ho_135_0 0 0.5063242148749499
Vwn_ho_135_0 wn_ho_135_0 0 0.49367578512505006
Vwp_ho_136_0 wp_ho_136_0 0 0.5396660896468786
Vwn_ho_136_0 wn_ho_136_0 0 0.4603339103531214
Vwp_ho_137_0 wp_ho_137_0 0 0.4594725298729693
Vwn_ho_137_0 wn_ho_137_0 0 0.5405274701270306
Vwp_ho_138_0 wp_ho_138_0 0 0.5109766731337275
Vwn_ho_138_0 wn_ho_138_0 0 0.4890233268662725
Vwp_ho_139_0 wp_ho_139_0 0 0.5038989515763274
Vwn_ho_139_0 wn_ho_139_0 0 0.49610104842367264
Vwp_ho_140_0 wp_ho_140_0 0 0.5002585993423581
Vwn_ho_140_0 wn_ho_140_0 0 0.499741400657642
Vwp_ho_141_0 wp_ho_141_0 0 0.5283768968819503
Vwn_ho_141_0 wn_ho_141_0 0 0.4716231031180496
Vwp_ho_142_0 wp_ho_142_0 0 0.45872722541312405
Vwn_ho_142_0 wn_ho_142_0 0 0.541272774586876
Vwp_ho_143_0 wp_ho_143_0 0 0.5167637943362952
Vwn_ho_143_0 wn_ho_143_0 0 0.4832362056637049
Vwp_ho_144_0 wp_ho_144_0 0 0.5047253526551003
Vwn_ho_144_0 wn_ho_144_0 0 0.49527464734489973
Vwp_ho_145_0 wp_ho_145_0 0 0.5025682934567685
Vwn_ho_145_0 wn_ho_145_0 0 0.4974317065432315
Vwp_ho_146_0 wp_ho_146_0 0 0.48810334537965117
Vwn_ho_146_0 wn_ho_146_0 0 0.5118966546203488
Vwp_ho_147_0 wp_ho_147_0 0 0.5047859939396966
Vwn_ho_147_0 wn_ho_147_0 0 0.49521400606030347
Vwp_ho_148_0 wp_ho_148_0 0 0.6090722766203072
Vwn_ho_148_0 wn_ho_148_0 0 0.39092772337969284
Vwp_ho_149_0 wp_ho_149_0 0 0.5059683513353325
Vwn_ho_149_0 wn_ho_149_0 0 0.4940316486646676
Vwp_ho_150_0 wp_ho_150_0 0 0.5304019314543766
Vwn_ho_150_0 wn_ho_150_0 0 0.46959806854562336
Vwp_ho_151_0 wp_ho_151_0 0 0.5337259460712448
Vwn_ho_151_0 wn_ho_151_0 0 0.46627405392875526
Vwp_ho_152_0 wp_ho_152_0 0 0.5478453807849916
Vwn_ho_152_0 wn_ho_152_0 0 0.45215461921500844
Vwp_ho_153_0 wp_ho_153_0 0 0.5316057383415596
Vwn_ho_153_0 wn_ho_153_0 0 0.4683942616584405
Vwp_ho_154_0 wp_ho_154_0 0 0.4947721155028441
Vwn_ho_154_0 wn_ho_154_0 0 0.5052278844971559
Vwp_ho_155_0 wp_ho_155_0 0 0.5034845795857793
Vwn_ho_155_0 wn_ho_155_0 0 0.4965154204142207
Vwp_ho_156_0 wp_ho_156_0 0 0.45476825133222176
Vwn_ho_156_0 wn_ho_156_0 0 0.5452317486677782
Vwp_ho_157_0 wp_ho_157_0 0 0.5113603295704328
Vwn_ho_157_0 wn_ho_157_0 0 0.4886396704295672
Vwp_ho_158_0 wp_ho_158_0 0 0.4828953649640204
Vwn_ho_158_0 wn_ho_158_0 0 0.5171046350359796
Vwp_ho_159_0 wp_ho_159_0 0 0.4776275005035389
Vwn_ho_159_0 wn_ho_159_0 0 0.522372499496461
Vwp_ho_160_0 wp_ho_160_0 0 0.46005325806235986
Vwn_ho_160_0 wn_ho_160_0 0 0.5399467419376401
Vwp_ho_161_0 wp_ho_161_0 0 0.5166444822465602
Vwn_ho_161_0 wn_ho_161_0 0 0.48335551775343977
Vwp_ho_162_0 wp_ho_162_0 0 0.47835136192991484
Vwn_ho_162_0 wn_ho_162_0 0 0.5216486380700852
Vwp_ho_163_0 wp_ho_163_0 0 0.5036330032117277
Vwn_ho_163_0 wn_ho_163_0 0 0.49636699678827234
Vwp_ho_164_0 wp_ho_164_0 0 0.49191089046802333
Vwn_ho_164_0 wn_ho_164_0 0 0.5080891095319766
Vwp_ho_165_0 wp_ho_165_0 0 0.4958480761088896
Vwn_ho_165_0 wn_ho_165_0 0 0.5041519238911104
Vwp_ho_166_0 wp_ho_166_0 0 0.5028789787582272
Vwn_ho_166_0 wn_ho_166_0 0 0.4971210212417728
Vwp_ho_167_0 wp_ho_167_0 0 0.509009216689796
Vwn_ho_167_0 wn_ho_167_0 0 0.49099078331020396
Vwp_ho_168_0 wp_ho_168_0 0 0.4877878030376132
Vwn_ho_168_0 wn_ho_168_0 0 0.5122121969623867
Vwp_ho_169_0 wp_ho_169_0 0 0.5142790007370439
Vwn_ho_169_0 wn_ho_169_0 0 0.4857209992629561
Vwp_ho_170_0 wp_ho_170_0 0 0.5003948760400221
Vwn_ho_170_0 wn_ho_170_0 0 0.49960512395997786
Vwp_ho_171_0 wp_ho_171_0 0 0.5464569745530453
Vwn_ho_171_0 wn_ho_171_0 0 0.4535430254469547
Vwp_ho_172_0 wp_ho_172_0 0 0.5840952799843152
Vwn_ho_172_0 wn_ho_172_0 0 0.4159047200156848
Vwp_ho_173_0 wp_ho_173_0 0 0.5593355695367984
Vwn_ho_173_0 wn_ho_173_0 0 0.44066443046320164
Vwp_ho_174_0 wp_ho_174_0 0 0.41383138761654686
Vwn_ho_174_0 wn_ho_174_0 0 0.5861686123834531
Vwp_ho_175_0 wp_ho_175_0 0 0.5521145920049046
Vwn_ho_175_0 wn_ho_175_0 0 0.4478854079950953
Vwp_ho_176_0 wp_ho_176_0 0 0.45141550906621447
Vwn_ho_176_0 wn_ho_176_0 0 0.5485844909337855
Vwp_ho_177_0 wp_ho_177_0 0 0.5256374429167445
Vwn_ho_177_0 wn_ho_177_0 0 0.4743625570832554
Vwp_ho_178_0 wp_ho_178_0 0 0.513436404874077
Vwn_ho_178_0 wn_ho_178_0 0 0.48656359512592295
Vwp_ho_179_0 wp_ho_179_0 0 0.49619576685135297
Vwn_ho_179_0 wn_ho_179_0 0 0.503804233148647
Vwp_ho_180_0 wp_ho_180_0 0 0.528600184682555
Vwn_ho_180_0 wn_ho_180_0 0 0.471399815317445
Vwp_ho_181_0 wp_ho_181_0 0 0.48672825116325324
Vwn_ho_181_0 wn_ho_181_0 0 0.5132717488367468
Vwp_ho_182_0 wp_ho_182_0 0 0.5494613197722494
Vwn_ho_182_0 wn_ho_182_0 0 0.45053868022775057
Vwp_ho_183_0 wp_ho_183_0 0 0.4833669570085738
Vwn_ho_183_0 wn_ho_183_0 0 0.5166330429914262
Vwp_ho_184_0 wp_ho_184_0 0 0.49802693458788294
Vwn_ho_184_0 wn_ho_184_0 0 0.5019730654121171
Vwp_ho_185_0 wp_ho_185_0 0 0.4972006596206764
Vwn_ho_185_0 wn_ho_185_0 0 0.5027993403793236
Vwp_ho_186_0 wp_ho_186_0 0 0.5063525866588368
Vwn_ho_186_0 wn_ho_186_0 0 0.4936474133411632
Vwp_ho_187_0 wp_ho_187_0 0 0.49921404053302826
Vwn_ho_187_0 wn_ho_187_0 0 0.5007859594669717
Vwp_ho_188_0 wp_ho_188_0 0 0.45805325360146903
Vwn_ho_188_0 wn_ho_188_0 0 0.5419467463985309
Vwp_ho_189_0 wp_ho_189_0 0 0.515645704732716
Vwn_ho_189_0 wn_ho_189_0 0 0.484354295267284
Vwp_ho_190_0 wp_ho_190_0 0 0.3908305653623323
Vwn_ho_190_0 wn_ho_190_0 0 0.6091694346376677
Vwp_ho_191_0 wp_ho_191_0 0 0.5086921658639655
Vwn_ho_191_0 wn_ho_191_0 0 0.49130783413603457
Vwp_ho_192_0 wp_ho_192_0 0 0.5272617678798858
Vwn_ho_192_0 wn_ho_192_0 0 0.47273823212011423
Vwp_ho_193_0 wp_ho_193_0 0 0.43130044399688194
Vwn_ho_193_0 wn_ho_193_0 0 0.5686995560031181
Vwp_ho_194_0 wp_ho_194_0 0 0.5323657174311424
Vwn_ho_194_0 wn_ho_194_0 0 0.46763428256885764
Vwp_ho_195_0 wp_ho_195_0 0 0.505404544232163
Vwn_ho_195_0 wn_ho_195_0 0 0.494595455767837
Vwp_ho_196_0 wp_ho_196_0 0 0.6162516008530954
Vwn_ho_196_0 wn_ho_196_0 0 0.38374839914690456
Vwp_ho_197_0 wp_ho_197_0 0 0.5212066245830153
Vwn_ho_197_0 wn_ho_197_0 0 0.4787933754169848
Vwp_ho_198_0 wp_ho_198_0 0 0.5032294217753797
Vwn_ho_198_0 wn_ho_198_0 0 0.49677057822462034
Vwp_ho_199_0 wp_ho_199_0 0 0.44935233954987835
Vwn_ho_199_0 wn_ho_199_0 0 0.5506476604501216
Vwp_ho_0_1 wp_ho_0_1 0 0.4914973510363152
Vwn_ho_0_1 wn_ho_0_1 0 0.5085026489636848
Vwp_ho_1_1 wp_ho_1_1 0 0.406937402800003
Vwn_ho_1_1 wn_ho_1_1 0 0.593062597199997
Vwp_ho_2_1 wp_ho_2_1 0 0.47422607485533474
Vwn_ho_2_1 wn_ho_2_1 0 0.5257739251446653
Vwp_ho_3_1 wp_ho_3_1 0 0.4728761233822113
Vwn_ho_3_1 wn_ho_3_1 0 0.5271238766177887
Vwp_ho_4_1 wp_ho_4_1 0 0.4354987462539729
Vwn_ho_4_1 wn_ho_4_1 0 0.5645012537460271
Vwp_ho_5_1 wp_ho_5_1 0 0.5617824705920546
Vwn_ho_5_1 wn_ho_5_1 0 0.43821752940794545
Vwp_ho_6_1 wp_ho_6_1 0 0.6452067349816755
Vwn_ho_6_1 wn_ho_6_1 0 0.35479326501832453
Vwp_ho_7_1 wp_ho_7_1 0 0.3754179388649801
Vwn_ho_7_1 wn_ho_7_1 0 0.6245820611350199
Vwp_ho_8_1 wp_ho_8_1 0 0.6129675431604449
Vwn_ho_8_1 wn_ho_8_1 0 0.3870324568395551
Vwp_ho_9_1 wp_ho_9_1 0 0.5392507643356724
Vwn_ho_9_1 wn_ho_9_1 0 0.4607492356643275
Vwp_ho_10_1 wp_ho_10_1 0 0.3909216445714776
Vwn_ho_10_1 wn_ho_10_1 0 0.6090783554285224
Vwp_ho_11_1 wp_ho_11_1 0 0.39289113841661294
Vwn_ho_11_1 wn_ho_11_1 0 0.6071088615833871
Vwp_ho_12_1 wp_ho_12_1 0 0.4886327065580336
Vwn_ho_12_1 wn_ho_12_1 0 0.5113672934419664
Vwp_ho_13_1 wp_ho_13_1 0 0.3610415562282402
Vwn_ho_13_1 wn_ho_13_1 0 0.6389584437717598
Vwp_ho_14_1 wp_ho_14_1 0 0.6525897594070906
Vwn_ho_14_1 wn_ho_14_1 0 0.3474102405929094
Vwp_ho_15_1 wp_ho_15_1 0 0.3250878978207041
Vwn_ho_15_1 wn_ho_15_1 0 0.6749121021792959
Vwp_ho_16_1 wp_ho_16_1 0 0.38886811313242226
Vwn_ho_16_1 wn_ho_16_1 0 0.6111318868675777
Vwp_ho_17_1 wp_ho_17_1 0 0.34479325295092966
Vwn_ho_17_1 wn_ho_17_1 0 0.6552067470490703
Vwp_ho_18_1 wp_ho_18_1 0 0.3951437487956419
Vwn_ho_18_1 wn_ho_18_1 0 0.604856251204358
Vwp_ho_19_1 wp_ho_19_1 0 0.5905552600483126
Vwn_ho_19_1 wn_ho_19_1 0 0.4094447399516874
Vwp_ho_20_1 wp_ho_20_1 0 0.49488562288076743
Vwn_ho_20_1 wn_ho_20_1 0 0.5051143771192326
Vwp_ho_21_1 wp_ho_21_1 0 0.5871041861722304
Vwn_ho_21_1 wn_ho_21_1 0 0.41289581382776963
Vwp_ho_22_1 wp_ho_22_1 0 0.5239469176437708
Vwn_ho_22_1 wn_ho_22_1 0 0.47605308235622923
Vwp_ho_23_1 wp_ho_23_1 0 0.6178782830111831
Vwn_ho_23_1 wn_ho_23_1 0 0.38212171698881686
Vwp_ho_24_1 wp_ho_24_1 0 0.4969751902871911
Vwn_ho_24_1 wn_ho_24_1 0 0.5030248097128088
Vwp_ho_25_1 wp_ho_25_1 0 0.49256699303166074
Vwn_ho_25_1 wn_ho_25_1 0 0.5074330069683393
Vwp_ho_26_1 wp_ho_26_1 0 0.5540441862640065
Vwn_ho_26_1 wn_ho_26_1 0 0.4459558137359935
Vwp_ho_27_1 wp_ho_27_1 0 0.47300896875821874
Vwn_ho_27_1 wn_ho_27_1 0 0.5269910312417813
Vwp_ho_28_1 wp_ho_28_1 0 0.45011683417079895
Vwn_ho_28_1 wn_ho_28_1 0 0.549883165829201
Vwp_ho_29_1 wp_ho_29_1 0 0.573422714335344
Vwn_ho_29_1 wn_ho_29_1 0 0.426577285664656
Vwp_ho_30_1 wp_ho_30_1 0 0.6409920249774437
Vwn_ho_30_1 wn_ho_30_1 0 0.3590079750225563
Vwp_ho_31_1 wp_ho_31_1 0 0.5757748980096552
Vwn_ho_31_1 wn_ho_31_1 0 0.4242251019903448
Vwp_ho_32_1 wp_ho_32_1 0 0.4387013512416547
Vwn_ho_32_1 wn_ho_32_1 0 0.5612986487583452
Vwp_ho_33_1 wp_ho_33_1 0 0.512784212293846
Vwn_ho_33_1 wn_ho_33_1 0 0.4872157877061541
Vwp_ho_34_1 wp_ho_34_1 0 0.34027498644360393
Vwn_ho_34_1 wn_ho_34_1 0 0.6597250135563961
Vwp_ho_35_1 wp_ho_35_1 0 0.4968179494019135
Vwn_ho_35_1 wn_ho_35_1 0 0.5031820505980865
Vwp_ho_36_1 wp_ho_36_1 0 0.6010349480733594
Vwn_ho_36_1 wn_ho_36_1 0 0.3989650519266406
Vwp_ho_37_1 wp_ho_37_1 0 0.31871449124325135
Vwn_ho_37_1 wn_ho_37_1 0 0.6812855087567486
Vwp_ho_38_1 wp_ho_38_1 0 0.39410292556583876
Vwn_ho_38_1 wn_ho_38_1 0 0.6058970744341613
Vwp_ho_39_1 wp_ho_39_1 0 0.3750012370725596
Vwn_ho_39_1 wn_ho_39_1 0 0.6249987629274404
Vwp_ho_40_1 wp_ho_40_1 0 0.5386367186608292
Vwn_ho_40_1 wn_ho_40_1 0 0.46136328133917087
Vwp_ho_41_1 wp_ho_41_1 0 0.5076182485629149
Vwn_ho_41_1 wn_ho_41_1 0 0.4923817514370851
Vwp_ho_42_1 wp_ho_42_1 0 0.45350771403649653
Vwn_ho_42_1 wn_ho_42_1 0 0.5464922859635035
Vwp_ho_43_1 wp_ho_43_1 0 0.4003673364967386
Vwn_ho_43_1 wn_ho_43_1 0 0.5996326635032614
Vwp_ho_44_1 wp_ho_44_1 0 0.6287434385072417
Vwn_ho_44_1 wn_ho_44_1 0 0.3712565614927583
Vwp_ho_45_1 wp_ho_45_1 0 0.5083272700902163
Vwn_ho_45_1 wn_ho_45_1 0 0.4916727299097838
Vwp_ho_46_1 wp_ho_46_1 0 0.6245591173863383
Vwn_ho_46_1 wn_ho_46_1 0 0.3754408826136617
Vwp_ho_47_1 wp_ho_47_1 0 0.4748252783718715
Vwn_ho_47_1 wn_ho_47_1 0 0.5251747216281285
Vwp_ho_48_1 wp_ho_48_1 0 0.615992629686489
Vwn_ho_48_1 wn_ho_48_1 0 0.38400737031351095
Vwp_ho_49_1 wp_ho_49_1 0 0.5851603767718345
Vwn_ho_49_1 wn_ho_49_1 0 0.4148396232281655
Vwp_ho_50_1 wp_ho_50_1 0 0.41004226928271614
Vwn_ho_50_1 wn_ho_50_1 0 0.5899577307172839
Vwp_ho_51_1 wp_ho_51_1 0 0.6003941532166319
Vwn_ho_51_1 wn_ho_51_1 0 0.3996058467833681
Vwp_ho_52_1 wp_ho_52_1 0 0.38774410342568
Vwn_ho_52_1 wn_ho_52_1 0 0.61225589657432
Vwp_ho_53_1 wp_ho_53_1 0 0.480197646691621
Vwn_ho_53_1 wn_ho_53_1 0 0.519802353308379
Vwp_ho_54_1 wp_ho_54_1 0 0.5198639973056763
Vwn_ho_54_1 wn_ho_54_1 0 0.4801360026943237
Vwp_ho_55_1 wp_ho_55_1 0 0.457166879505095
Vwn_ho_55_1 wn_ho_55_1 0 0.542833120494905
Vwp_ho_56_1 wp_ho_56_1 0 0.35436235852452425
Vwn_ho_56_1 wn_ho_56_1 0 0.6456376414754758
Vwp_ho_57_1 wp_ho_57_1 0 0.3890350719376065
Vwn_ho_57_1 wn_ho_57_1 0 0.6109649280623934
Vwp_ho_58_1 wp_ho_58_1 0 0.5745827174107955
Vwn_ho_58_1 wn_ho_58_1 0 0.4254172825892045
Vwp_ho_59_1 wp_ho_59_1 0 0.5576308659540559
Vwn_ho_59_1 wn_ho_59_1 0 0.4423691340459441
Vwp_ho_60_1 wp_ho_60_1 0 0.595287185601456
Vwn_ho_60_1 wn_ho_60_1 0 0.404712814398544
Vwp_ho_61_1 wp_ho_61_1 0 0.5156045054968247
Vwn_ho_61_1 wn_ho_61_1 0 0.48439549450317526
Vwp_ho_62_1 wp_ho_62_1 0 0.4103289344767137
Vwn_ho_62_1 wn_ho_62_1 0 0.5896710655232863
Vwp_ho_63_1 wp_ho_63_1 0 0.6441368588169021
Vwn_ho_63_1 wn_ho_63_1 0 0.3558631411830979
Vwp_ho_64_1 wp_ho_64_1 0 0.46594473990491786
Vwn_ho_64_1 wn_ho_64_1 0 0.5340552600950821
Vwp_ho_65_1 wp_ho_65_1 0 0.38325852933241555
Vwn_ho_65_1 wn_ho_65_1 0 0.6167414706675844
Vwp_ho_66_1 wp_ho_66_1 0 0.6599784237017161
Vwn_ho_66_1 wn_ho_66_1 0 0.3400215762982839
Vwp_ho_67_1 wp_ho_67_1 0 0.541578355088608
Vwn_ho_67_1 wn_ho_67_1 0 0.4584216449113921
Vwp_ho_68_1 wp_ho_68_1 0 0.35657930163879736
Vwn_ho_68_1 wn_ho_68_1 0 0.6434206983612026
Vwp_ho_69_1 wp_ho_69_1 0 0.5412576831537711
Vwn_ho_69_1 wn_ho_69_1 0 0.4587423168462289
Vwp_ho_70_1 wp_ho_70_1 0 0.5135137252721106
Vwn_ho_70_1 wn_ho_70_1 0 0.4864862747278894
Vwp_ho_71_1 wp_ho_71_1 0 0.4765083675935148
Vwn_ho_71_1 wn_ho_71_1 0 0.5234916324064852
Vwp_ho_72_1 wp_ho_72_1 0 0.5666152781014306
Vwn_ho_72_1 wn_ho_72_1 0 0.4333847218985694
Vwp_ho_73_1 wp_ho_73_1 0 0.6198448446067523
Vwn_ho_73_1 wn_ho_73_1 0 0.38015515539324773
Vwp_ho_74_1 wp_ho_74_1 0 0.5645905226151738
Vwn_ho_74_1 wn_ho_74_1 0 0.43540947738482616
Vwp_ho_75_1 wp_ho_75_1 0 0.4365794802917894
Vwn_ho_75_1 wn_ho_75_1 0 0.5634205197082106
Vwp_ho_76_1 wp_ho_76_1 0 0.45149298685049644
Vwn_ho_76_1 wn_ho_76_1 0 0.5485070131495036
Vwp_ho_77_1 wp_ho_77_1 0 0.6089400562616434
Vwn_ho_77_1 wn_ho_77_1 0 0.3910599437383566
Vwp_ho_78_1 wp_ho_78_1 0 0.3915652013777142
Vwn_ho_78_1 wn_ho_78_1 0 0.6084347986222858
Vwp_ho_79_1 wp_ho_79_1 0 0.49104730737005325
Vwn_ho_79_1 wn_ho_79_1 0 0.5089526926299467
Vwp_ho_80_1 wp_ho_80_1 0 0.6239952446868228
Vwn_ho_80_1 wn_ho_80_1 0 0.37600475531317723
Vwp_ho_81_1 wp_ho_81_1 0 0.5304820525703231
Vwn_ho_81_1 wn_ho_81_1 0 0.4695179474296769
Vwp_ho_82_1 wp_ho_82_1 0 0.5004489214952086
Vwn_ho_82_1 wn_ho_82_1 0 0.4995510785047914
Vwp_ho_83_1 wp_ho_83_1 0 0.3922944688958049
Vwn_ho_83_1 wn_ho_83_1 0 0.6077055311041951
Vwp_ho_84_1 wp_ho_84_1 0 0.5942214930550659
Vwn_ho_84_1 wn_ho_84_1 0 0.4057785069449341
Vwp_ho_85_1 wp_ho_85_1 0 0.5476142989844685
Vwn_ho_85_1 wn_ho_85_1 0 0.4523857010155316
Vwp_ho_86_1 wp_ho_86_1 0 0.5345365862131822
Vwn_ho_86_1 wn_ho_86_1 0 0.4654634137868178
Vwp_ho_87_1 wp_ho_87_1 0 0.5882649850980478
Vwn_ho_87_1 wn_ho_87_1 0 0.41173501490195225
Vwp_ho_88_1 wp_ho_88_1 0 0.38491123060077165
Vwn_ho_88_1 wn_ho_88_1 0 0.6150887693992283
Vwp_ho_89_1 wp_ho_89_1 0 0.4513179748811414
Vwn_ho_89_1 wn_ho_89_1 0 0.5486820251188587
Vwp_ho_90_1 wp_ho_90_1 0 0.4775282235946049
Vwn_ho_90_1 wn_ho_90_1 0 0.5224717764053951
Vwp_ho_91_1 wp_ho_91_1 0 0.5283878497839175
Vwn_ho_91_1 wn_ho_91_1 0 0.4716121502160825
Vwp_ho_92_1 wp_ho_92_1 0 0.4415842075100688
Vwn_ho_92_1 wn_ho_92_1 0 0.5584157924899311
Vwp_ho_93_1 wp_ho_93_1 0 0.4088078222319892
Vwn_ho_93_1 wn_ho_93_1 0 0.5911921777680108
Vwp_ho_94_1 wp_ho_94_1 0 0.4518480312341694
Vwn_ho_94_1 wn_ho_94_1 0 0.5481519687658306
Vwp_ho_95_1 wp_ho_95_1 0 0.5512040524733833
Vwn_ho_95_1 wn_ho_95_1 0 0.4487959475266166
Vwp_ho_96_1 wp_ho_96_1 0 0.49786079125579796
Vwn_ho_96_1 wn_ho_96_1 0 0.502139208744202
Vwp_ho_97_1 wp_ho_97_1 0 0.5091408222253141
Vwn_ho_97_1 wn_ho_97_1 0 0.4908591777746859
Vwp_ho_98_1 wp_ho_98_1 0 0.3768238014964828
Vwn_ho_98_1 wn_ho_98_1 0 0.6231761985035171
Vwp_ho_99_1 wp_ho_99_1 0 0.3731390770512897
Vwn_ho_99_1 wn_ho_99_1 0 0.6268609229487103
Vwp_ho_100_1 wp_ho_100_1 0 0.5126751504924223
Vwn_ho_100_1 wn_ho_100_1 0 0.48732484950757765
Vwp_ho_101_1 wp_ho_101_1 0 0.4795040365303429
Vwn_ho_101_1 wn_ho_101_1 0 0.5204959634696571
Vwp_ho_102_1 wp_ho_102_1 0 0.4406963627156022
Vwn_ho_102_1 wn_ho_102_1 0 0.5593036372843978
Vwp_ho_103_1 wp_ho_103_1 0 0.47769476594668053
Vwn_ho_103_1 wn_ho_103_1 0 0.5223052340533194
Vwp_ho_104_1 wp_ho_104_1 0 0.5776530568797776
Vwn_ho_104_1 wn_ho_104_1 0 0.42234694312022236
Vwp_ho_105_1 wp_ho_105_1 0 0.4557863979089338
Vwn_ho_105_1 wn_ho_105_1 0 0.5442136020910662
Vwp_ho_106_1 wp_ho_106_1 0 0.6083234563737367
Vwn_ho_106_1 wn_ho_106_1 0 0.39167654362626325
Vwp_ho_107_1 wp_ho_107_1 0 0.49494792887528244
Vwn_ho_107_1 wn_ho_107_1 0 0.5050520711247175
Vwp_ho_108_1 wp_ho_108_1 0 0.5496633399582768
Vwn_ho_108_1 wn_ho_108_1 0 0.45033666004172324
Vwp_ho_109_1 wp_ho_109_1 0 0.5204134300298344
Vwn_ho_109_1 wn_ho_109_1 0 0.4795865699701656
Vwp_ho_110_1 wp_ho_110_1 0 0.5987263884915385
Vwn_ho_110_1 wn_ho_110_1 0 0.4012736115084615
Vwp_ho_111_1 wp_ho_111_1 0 0.5222231639087657
Vwn_ho_111_1 wn_ho_111_1 0 0.47777683609123434
Vwp_ho_112_1 wp_ho_112_1 0 0.555312741002969
Vwn_ho_112_1 wn_ho_112_1 0 0.444687258997031
Vwp_ho_113_1 wp_ho_113_1 0 0.4132920336520135
Vwn_ho_113_1 wn_ho_113_1 0 0.5867079663479865
Vwp_ho_114_1 wp_ho_114_1 0 0.4634697564633399
Vwn_ho_114_1 wn_ho_114_1 0 0.5365302435366601
Vwp_ho_115_1 wp_ho_115_1 0 0.536571403457242
Vwn_ho_115_1 wn_ho_115_1 0 0.46342859654275803
Vwp_ho_116_1 wp_ho_116_1 0 0.502267319862389
Vwn_ho_116_1 wn_ho_116_1 0 0.49773268013761096
Vwp_ho_117_1 wp_ho_117_1 0 0.5090237075822045
Vwn_ho_117_1 wn_ho_117_1 0 0.4909762924177955
Vwp_ho_118_1 wp_ho_118_1 0 0.5229758255230436
Vwn_ho_118_1 wn_ho_118_1 0 0.4770241744769564
Vwp_ho_119_1 wp_ho_119_1 0 0.3732260625863091
Vwn_ho_119_1 wn_ho_119_1 0 0.6267739374136909
Vwp_ho_120_1 wp_ho_120_1 0 0.4541210376418978
Vwn_ho_120_1 wn_ho_120_1 0 0.5458789623581022
Vwp_ho_121_1 wp_ho_121_1 0 0.6832757831170699
Vwn_ho_121_1 wn_ho_121_1 0 0.31672421688293007
Vwp_ho_122_1 wp_ho_122_1 0 0.4528904019979668
Vwn_ho_122_1 wn_ho_122_1 0 0.5471095980020332
Vwp_ho_123_1 wp_ho_123_1 0 0.6437338304875628
Vwn_ho_123_1 wn_ho_123_1 0 0.3562661695124372
Vwp_ho_124_1 wp_ho_124_1 0 0.43853819449895837
Vwn_ho_124_1 wn_ho_124_1 0 0.5614618055010416
Vwp_ho_125_1 wp_ho_125_1 0 0.6017900472710196
Vwn_ho_125_1 wn_ho_125_1 0 0.3982099527289804
Vwp_ho_126_1 wp_ho_126_1 0 0.5269770405801223
Vwn_ho_126_1 wn_ho_126_1 0 0.47302295941987765
Vwp_ho_127_1 wp_ho_127_1 0 0.5337503339356191
Vwn_ho_127_1 wn_ho_127_1 0 0.46624966606438095
Vwp_ho_128_1 wp_ho_128_1 0 0.4669127103325602
Vwn_ho_128_1 wn_ho_128_1 0 0.5330872896674398
Vwp_ho_129_1 wp_ho_129_1 0 0.5072365226318952
Vwn_ho_129_1 wn_ho_129_1 0 0.4927634773681048
Vwp_ho_130_1 wp_ho_130_1 0 0.6333624288734595
Vwn_ho_130_1 wn_ho_130_1 0 0.3666375711265405
Vwp_ho_131_1 wp_ho_131_1 0 0.3422052356174891
Vwn_ho_131_1 wn_ho_131_1 0 0.6577947643825108
Vwp_ho_132_1 wp_ho_132_1 0 0.6200697841553673
Vwn_ho_132_1 wn_ho_132_1 0 0.3799302158446327
Vwp_ho_133_1 wp_ho_133_1 0 0.4189629629934905
Vwn_ho_133_1 wn_ho_133_1 0 0.5810370370065095
Vwp_ho_134_1 wp_ho_134_1 0 0.501540831216653
Vwn_ho_134_1 wn_ho_134_1 0 0.49845916878334695
Vwp_ho_135_1 wp_ho_135_1 0 0.5664662831720892
Vwn_ho_135_1 wn_ho_135_1 0 0.43353371682791075
Vwp_ho_136_1 wp_ho_136_1 0 0.36167303551525376
Vwn_ho_136_1 wn_ho_136_1 0 0.6383269644847462
Vwp_ho_137_1 wp_ho_137_1 0 0.59746571268436
Vwn_ho_137_1 wn_ho_137_1 0 0.40253428731564
Vwp_ho_138_1 wp_ho_138_1 0 0.5083199160679785
Vwn_ho_138_1 wn_ho_138_1 0 0.49168008393202145
Vwp_ho_139_1 wp_ho_139_1 0 0.43984995494695645
Vwn_ho_139_1 wn_ho_139_1 0 0.5601500450530436
Vwp_ho_140_1 wp_ho_140_1 0 0.5254131154213191
Vwn_ho_140_1 wn_ho_140_1 0 0.474586884578681
Vwp_ho_141_1 wp_ho_141_1 0 0.4679323710012403
Vwn_ho_141_1 wn_ho_141_1 0 0.5320676289987597
Vwp_ho_142_1 wp_ho_142_1 0 0.6013021641995665
Vwn_ho_142_1 wn_ho_142_1 0 0.39869783580043344
Vwp_ho_143_1 wp_ho_143_1 0 0.4755708210883525
Vwn_ho_143_1 wn_ho_143_1 0 0.5244291789116475
Vwp_ho_144_1 wp_ho_144_1 0 0.4792029900481387
Vwn_ho_144_1 wn_ho_144_1 0 0.5207970099518613
Vwp_ho_145_1 wp_ho_145_1 0 0.44543353500449956
Vwn_ho_145_1 wn_ho_145_1 0 0.5545664649955004
Vwp_ho_146_1 wp_ho_146_1 0 0.4864789781643312
Vwn_ho_146_1 wn_ho_146_1 0 0.5135210218356687
Vwp_ho_147_1 wp_ho_147_1 0 0.5871960719723843
Vwn_ho_147_1 wn_ho_147_1 0 0.4128039280276157
Vwp_ho_148_1 wp_ho_148_1 0 0.3569049657451346
Vwn_ho_148_1 wn_ho_148_1 0 0.6430950342548654
Vwp_ho_149_1 wp_ho_149_1 0 0.42454996540576684
Vwn_ho_149_1 wn_ho_149_1 0 0.5754500345942332
Vwp_ho_150_1 wp_ho_150_1 0 0.45295496255672063
Vwn_ho_150_1 wn_ho_150_1 0 0.5470450374432794
Vwp_ho_151_1 wp_ho_151_1 0 0.46830753070941483
Vwn_ho_151_1 wn_ho_151_1 0 0.5316924692905852
Vwp_ho_152_1 wp_ho_152_1 0 0.3280617664635712
Vwn_ho_152_1 wn_ho_152_1 0 0.6719382335364288
Vwp_ho_153_1 wp_ho_153_1 0 0.3615649885700215
Vwn_ho_153_1 wn_ho_153_1 0 0.6384350114299785
Vwp_ho_154_1 wp_ho_154_1 0 0.4232599245137918
Vwn_ho_154_1 wn_ho_154_1 0 0.5767400754862082
Vwp_ho_155_1 wp_ho_155_1 0 0.44954296728365334
Vwn_ho_155_1 wn_ho_155_1 0 0.5504570327163467
Vwp_ho_156_1 wp_ho_156_1 0 0.6256482588433494
Vwn_ho_156_1 wn_ho_156_1 0 0.37435174115665065
Vwp_ho_157_1 wp_ho_157_1 0 0.5614988518928621
Vwn_ho_157_1 wn_ho_157_1 0 0.4385011481071379
Vwp_ho_158_1 wp_ho_158_1 0 0.497366698613872
Vwn_ho_158_1 wn_ho_158_1 0 0.502633301386128
Vwp_ho_159_1 wp_ho_159_1 0 0.6090388999131164
Vwn_ho_159_1 wn_ho_159_1 0 0.3909611000868836
Vwp_ho_160_1 wp_ho_160_1 0 0.550402287584698
Vwn_ho_160_1 wn_ho_160_1 0 0.44959771241530194
Vwp_ho_161_1 wp_ho_161_1 0 0.5256731766622873
Vwn_ho_161_1 wn_ho_161_1 0 0.47432682333771264
Vwp_ho_162_1 wp_ho_162_1 0 0.5561462308505181
Vwn_ho_162_1 wn_ho_162_1 0 0.44385376914948194
Vwp_ho_163_1 wp_ho_163_1 0 0.49466971142654503
Vwn_ho_163_1 wn_ho_163_1 0 0.505330288573455
Vwp_ho_164_1 wp_ho_164_1 0 0.4744456363261457
Vwn_ho_164_1 wn_ho_164_1 0 0.5255543636738542
Vwp_ho_165_1 wp_ho_165_1 0 0.5183796227680899
Vwn_ho_165_1 wn_ho_165_1 0 0.4816203772319101
Vwp_ho_166_1 wp_ho_166_1 0 0.48916305447697817
Vwn_ho_166_1 wn_ho_166_1 0 0.5108369455230218
Vwp_ho_167_1 wp_ho_167_1 0 0.5125567848748026
Vwn_ho_167_1 wn_ho_167_1 0 0.4874432151251974
Vwp_ho_168_1 wp_ho_168_1 0 0.43735507808450796
Vwn_ho_168_1 wn_ho_168_1 0 0.5626449219154921
Vwp_ho_169_1 wp_ho_169_1 0 0.4763536986010135
Vwn_ho_169_1 wn_ho_169_1 0 0.5236463013989865
Vwp_ho_170_1 wp_ho_170_1 0 0.4188122585693852
Vwn_ho_170_1 wn_ho_170_1 0 0.5811877414306148
Vwp_ho_171_1 wp_ho_171_1 0 0.42614806648971776
Vwn_ho_171_1 wn_ho_171_1 0 0.5738519335102822
Vwp_ho_172_1 wp_ho_172_1 0 0.3662046094478773
Vwn_ho_172_1 wn_ho_172_1 0 0.6337953905521228
Vwp_ho_173_1 wp_ho_173_1 0 0.38787858475548864
Vwn_ho_173_1 wn_ho_173_1 0 0.6121214152445114
Vwp_ho_174_1 wp_ho_174_1 0 0.668421901488804
Vwn_ho_174_1 wn_ho_174_1 0 0.331578098511196
Vwp_ho_175_1 wp_ho_175_1 0 0.4629094996523211
Vwn_ho_175_1 wn_ho_175_1 0 0.5370905003476789
Vwp_ho_176_1 wp_ho_176_1 0 0.5644664112313185
Vwn_ho_176_1 wn_ho_176_1 0 0.4355335887686815
Vwp_ho_177_1 wp_ho_177_1 0 0.4264319410503731
Vwn_ho_177_1 wn_ho_177_1 0 0.5735680589496269
Vwp_ho_178_1 wp_ho_178_1 0 0.462081031740783
Vwn_ho_178_1 wn_ho_178_1 0 0.5379189682592169
Vwp_ho_179_1 wp_ho_179_1 0 0.45956021279457493
Vwn_ho_179_1 wn_ho_179_1 0 0.5404397872054251
Vwp_ho_180_1 wp_ho_180_1 0 0.5015437725160201
Vwn_ho_180_1 wn_ho_180_1 0 0.4984562274839799
Vwp_ho_181_1 wp_ho_181_1 0 0.6514388035786003
Vwn_ho_181_1 wn_ho_181_1 0 0.3485611964213997
Vwp_ho_182_1 wp_ho_182_1 0 0.45070967747844287
Vwn_ho_182_1 wn_ho_182_1 0 0.5492903225215572
Vwp_ho_183_1 wp_ho_183_1 0 0.5530728947894331
Vwn_ho_183_1 wn_ho_183_1 0 0.4469271052105669
Vwp_ho_184_1 wp_ho_184_1 0 0.43507533252610586
Vwn_ho_184_1 wn_ho_184_1 0 0.5649246674738941
Vwp_ho_185_1 wp_ho_185_1 0 0.45501806787314647
Vwn_ho_185_1 wn_ho_185_1 0 0.5449819321268535
Vwp_ho_186_1 wp_ho_186_1 0 0.41683054931338503
Vwn_ho_186_1 wn_ho_186_1 0 0.583169450686615
Vwp_ho_187_1 wp_ho_187_1 0 0.4417645490979477
Vwn_ho_187_1 wn_ho_187_1 0 0.5582354509020523
Vwp_ho_188_1 wp_ho_188_1 0 0.6220645643622821
Vwn_ho_188_1 wn_ho_188_1 0 0.377935435637718
Vwp_ho_189_1 wp_ho_189_1 0 0.41832755625032014
Vwn_ho_189_1 wn_ho_189_1 0 0.5816724437496799
Vwp_ho_190_1 wp_ho_190_1 0 0.641043963629959
Vwn_ho_190_1 wn_ho_190_1 0 0.35895603637004103
Vwp_ho_191_1 wp_ho_191_1 0 0.3751611856867121
Vwn_ho_191_1 wn_ho_191_1 0 0.6248388143132879
Vwp_ho_192_1 wp_ho_192_1 0 0.4624538027897935
Vwn_ho_192_1 wn_ho_192_1 0 0.5375461972102065
Vwp_ho_193_1 wp_ho_193_1 0 0.6670232339077605
Vwn_ho_193_1 wn_ho_193_1 0 0.3329767660922395
Vwp_ho_194_1 wp_ho_194_1 0 0.44228974745922045
Vwn_ho_194_1 wn_ho_194_1 0 0.5577102525407795
Vwp_ho_195_1 wp_ho_195_1 0 0.5326690846468254
Vwn_ho_195_1 wn_ho_195_1 0 0.4673309153531746
Vwp_ho_196_1 wp_ho_196_1 0 0.33686503484177077
Vwn_ho_196_1 wn_ho_196_1 0 0.6631349651582292
Vwp_ho_197_1 wp_ho_197_1 0 0.3837451864000661
Vwn_ho_197_1 wn_ho_197_1 0 0.616254813599934
Vwp_ho_198_1 wp_ho_198_1 0 0.5657604424798391
Vwn_ho_198_1 wn_ho_198_1 0 0.43423955752016086
Vwp_ho_199_1 wp_ho_199_1 0 0.626255361888758
Vwn_ho_199_1 wn_ho_199_1 0 0.37374463811124203
Vwp_ho_0_2 wp_ho_0_2 0 0.4978639040729483
Vwn_ho_0_2 wn_ho_0_2 0 0.5021360959270517
Vwp_ho_1_2 wp_ho_1_2 0 0.5894897660702798
Vwn_ho_1_2 wn_ho_1_2 0 0.4105102339297202
Vwp_ho_2_2 wp_ho_2_2 0 0.5056496153464282
Vwn_ho_2_2 wn_ho_2_2 0 0.49435038465357184
Vwp_ho_3_2 wp_ho_3_2 0 0.48078923978804244
Vwn_ho_3_2 wn_ho_3_2 0 0.5192107602119576
Vwp_ho_4_2 wp_ho_4_2 0 0.5124622136879854
Vwn_ho_4_2 wn_ho_4_2 0 0.4875377863120146
Vwp_ho_5_2 wp_ho_5_2 0 0.4379955564682754
Vwn_ho_5_2 wn_ho_5_2 0 0.5620044435317245
Vwp_ho_6_2 wp_ho_6_2 0 0.4651131211965552
Vwn_ho_6_2 wn_ho_6_2 0 0.5348868788034449
Vwp_ho_7_2 wp_ho_7_2 0 0.5332464368291006
Vwn_ho_7_2 wn_ho_7_2 0 0.46675356317089944
Vwp_ho_8_2 wp_ho_8_2 0 0.4001483801028463
Vwn_ho_8_2 wn_ho_8_2 0 0.5998516198971536
Vwp_ho_9_2 wp_ho_9_2 0 0.48757510939475546
Vwn_ho_9_2 wn_ho_9_2 0 0.5124248906052445
Vwp_ho_10_2 wp_ho_10_2 0 0.5271172669780047
Vwn_ho_10_2 wn_ho_10_2 0 0.4728827330219954
Vwp_ho_11_2 wp_ho_11_2 0 0.5669301161800211
Vwn_ho_11_2 wn_ho_11_2 0 0.43306988381997896
Vwp_ho_12_2 wp_ho_12_2 0 0.4986165271153597
Vwn_ho_12_2 wn_ho_12_2 0 0.5013834728846404
Vwp_ho_13_2 wp_ho_13_2 0 0.5606673488696039
Vwn_ho_13_2 wn_ho_13_2 0 0.4393326511303961
Vwp_ho_14_2 wp_ho_14_2 0 0.36991414491327756
Vwn_ho_14_2 wn_ho_14_2 0 0.6300858550867224
Vwp_ho_15_2 wp_ho_15_2 0 0.5706686809632523
Vwn_ho_15_2 wn_ho_15_2 0 0.4293313190367477
Vwp_ho_16_2 wp_ho_16_2 0 0.5401130220276608
Vwn_ho_16_2 wn_ho_16_2 0 0.4598869779723393
Vwp_ho_17_2 wp_ho_17_2 0 0.5412518962030766
Vwn_ho_17_2 wn_ho_17_2 0 0.45874810379692343
Vwp_ho_18_2 wp_ho_18_2 0 0.5690576721678458
Vwn_ho_18_2 wn_ho_18_2 0 0.43094232783215425
Vwp_ho_19_2 wp_ho_19_2 0 0.4153854911225308
Vwn_ho_19_2 wn_ho_19_2 0 0.5846145088774692
Vwp_ho_20_2 wp_ho_20_2 0 0.509647190684566
Vwn_ho_20_2 wn_ho_20_2 0 0.490352809315434
Vwp_ho_21_2 wp_ho_21_2 0 0.47296650159607745
Vwn_ho_21_2 wn_ho_21_2 0 0.5270334984039226
Vwp_ho_22_2 wp_ho_22_2 0 0.5023626979415505
Vwn_ho_22_2 wn_ho_22_2 0 0.4976373020584495
Vwp_ho_23_2 wp_ho_23_2 0 0.43093165424706104
Vwn_ho_23_2 wn_ho_23_2 0 0.569068345752939
Vwp_ho_24_2 wp_ho_24_2 0 0.48985351939719735
Vwn_ho_24_2 wn_ho_24_2 0 0.5101464806028027
Vwp_ho_25_2 wp_ho_25_2 0 0.49541143218335765
Vwn_ho_25_2 wn_ho_25_2 0 0.5045885678166424
Vwp_ho_26_2 wp_ho_26_2 0 0.45486782115600355
Vwn_ho_26_2 wn_ho_26_2 0 0.5451321788439965
Vwp_ho_27_2 wp_ho_27_2 0 0.5003344834246701
Vwn_ho_27_2 wn_ho_27_2 0 0.4996655165753298
Vwp_ho_28_2 wp_ho_28_2 0 0.5355737398299285
Vwn_ho_28_2 wn_ho_28_2 0 0.4644262601700715
Vwp_ho_29_2 wp_ho_29_2 0 0.424127056229765
Vwn_ho_29_2 wn_ho_29_2 0 0.575872943770235
Vwp_ho_30_2 wp_ho_30_2 0 0.3958452580873921
Vwn_ho_30_2 wn_ho_30_2 0 0.6041547419126079
Vwp_ho_31_2 wp_ho_31_2 0 0.39315417001576525
Vwn_ho_31_2 wn_ho_31_2 0 0.6068458299842348
Vwp_ho_32_2 wp_ho_32_2 0 0.5351378747109106
Vwn_ho_32_2 wn_ho_32_2 0 0.46486212528908943
Vwp_ho_33_2 wp_ho_33_2 0 0.4927316276302114
Vwn_ho_33_2 wn_ho_33_2 0 0.5072683723697886
Vwp_ho_34_2 wp_ho_34_2 0 0.5477704248246348
Vwn_ho_34_2 wn_ho_34_2 0 0.4522295751753652
Vwp_ho_35_2 wp_ho_35_2 0 0.49687784242119676
Vwn_ho_35_2 wn_ho_35_2 0 0.5031221575788032
Vwp_ho_36_2 wp_ho_36_2 0 0.46506440320372044
Vwn_ho_36_2 wn_ho_36_2 0 0.5349355967962796
Vwp_ho_37_2 wp_ho_37_2 0 0.6734795993644547
Vwn_ho_37_2 wn_ho_37_2 0 0.3265204006355453
Vwp_ho_38_2 wp_ho_38_2 0 0.5910832702506178
Vwn_ho_38_2 wn_ho_38_2 0 0.4089167297493822
Vwp_ho_39_2 wp_ho_39_2 0 0.553972607235307
Vwn_ho_39_2 wn_ho_39_2 0 0.4460273927646931
Vwp_ho_40_2 wp_ho_40_2 0 0.4650299040541216
Vwn_ho_40_2 wn_ho_40_2 0 0.5349700959458784
Vwp_ho_41_2 wp_ho_41_2 0 0.46852480020986814
Vwn_ho_41_2 wn_ho_41_2 0 0.5314751997901319
Vwp_ho_42_2 wp_ho_42_2 0 0.5388548637103181
Vwn_ho_42_2 wn_ho_42_2 0 0.46114513628968196
Vwp_ho_43_2 wp_ho_43_2 0 0.5429521840898027
Vwn_ho_43_2 wn_ho_43_2 0 0.4570478159101972
Vwp_ho_44_2 wp_ho_44_2 0 0.4301405397690317
Vwn_ho_44_2 wn_ho_44_2 0 0.5698594602309683
Vwp_ho_45_2 wp_ho_45_2 0 0.49740608897283267
Vwn_ho_45_2 wn_ho_45_2 0 0.5025939110271673
Vwp_ho_46_2 wp_ho_46_2 0 0.44140587013775207
Vwn_ho_46_2 wn_ho_46_2 0 0.558594129862248
Vwp_ho_47_2 wp_ho_47_2 0 0.4987498685509128
Vwn_ho_47_2 wn_ho_47_2 0 0.5012501314490873
Vwp_ho_48_2 wp_ho_48_2 0 0.48069922498933493
Vwn_ho_48_2 wn_ho_48_2 0 0.5193007750106651
Vwp_ho_49_2 wp_ho_49_2 0 0.4906159785248517
Vwn_ho_49_2 wn_ho_49_2 0 0.5093840214751483
Vwp_ho_50_2 wp_ho_50_2 0 0.5496604331643576
Vwn_ho_50_2 wn_ho_50_2 0 0.4503395668356423
Vwp_ho_51_2 wp_ho_51_2 0 0.4647579144125924
Vwn_ho_51_2 wn_ho_51_2 0 0.5352420855874076
Vwp_ho_52_2 wp_ho_52_2 0 0.5486099715287097
Vwn_ho_52_2 wn_ho_52_2 0 0.45139002847129034
Vwp_ho_53_2 wp_ho_53_2 0 0.5198931496457063
Vwn_ho_53_2 wn_ho_53_2 0 0.4801068503542937
Vwp_ho_54_2 wp_ho_54_2 0 0.4748050713593005
Vwn_ho_54_2 wn_ho_54_2 0 0.5251949286406995
Vwp_ho_55_2 wp_ho_55_2 0 0.5156607461707416
Vwn_ho_55_2 wn_ho_55_2 0 0.4843392538292583
Vwp_ho_56_2 wp_ho_56_2 0 0.5918442030137081
Vwn_ho_56_2 wn_ho_56_2 0 0.4081557969862919
Vwp_ho_57_2 wp_ho_57_2 0 0.6039754503191385
Vwn_ho_57_2 wn_ho_57_2 0 0.39602454968086154
Vwp_ho_58_2 wp_ho_58_2 0 0.46391490296533217
Vwn_ho_58_2 wn_ho_58_2 0 0.5360850970346679
Vwp_ho_59_2 wp_ho_59_2 0 0.47146077944412645
Vwn_ho_59_2 wn_ho_59_2 0 0.5285392205558735
Vwp_ho_60_2 wp_ho_60_2 0 0.4460690887050198
Vwn_ho_60_2 wn_ho_60_2 0 0.5539309112949802
Vwp_ho_61_2 wp_ho_61_2 0 0.5360932918744344
Vwn_ho_61_2 wn_ho_61_2 0 0.46390670812556556
Vwp_ho_62_2 wp_ho_62_2 0 0.5392683510054431
Vwn_ho_62_2 wn_ho_62_2 0 0.46073164899455693
Vwp_ho_63_2 wp_ho_63_2 0 0.4233289237037474
Vwn_ho_63_2 wn_ho_63_2 0 0.5766710762962526
Vwp_ho_64_2 wp_ho_64_2 0 0.4968371472268799
Vwn_ho_64_2 wn_ho_64_2 0 0.5031628527731201
Vwp_ho_65_2 wp_ho_65_2 0 0.5341000333769689
Vwn_ho_65_2 wn_ho_65_2 0 0.4658999666230311
Vwp_ho_66_2 wp_ho_66_2 0 0.37214358401035696
Vwn_ho_66_2 wn_ho_66_2 0 0.627856415989643
Vwp_ho_67_2 wp_ho_67_2 0 0.4965306812633421
Vwn_ho_67_2 wn_ho_67_2 0 0.5034693187366579
Vwp_ho_68_2 wp_ho_68_2 0 0.5574860332838565
Vwn_ho_68_2 wn_ho_68_2 0 0.44251396671614357
Vwp_ho_69_2 wp_ho_69_2 0 0.4949665838036556
Vwn_ho_69_2 wn_ho_69_2 0 0.5050334161963443
Vwp_ho_70_2 wp_ho_70_2 0 0.5015893888785443
Vwn_ho_70_2 wn_ho_70_2 0 0.49841061112145574
Vwp_ho_71_2 wp_ho_71_2 0 0.5187308971042971
Vwn_ho_71_2 wn_ho_71_2 0 0.4812691028957029
Vwp_ho_72_2 wp_ho_72_2 0 0.4610466434987835
Vwn_ho_72_2 wn_ho_72_2 0 0.5389533565012166
Vwp_ho_73_2 wp_ho_73_2 0 0.41020451560081833
Vwn_ho_73_2 wn_ho_73_2 0 0.5897954843991816
Vwp_ho_74_2 wp_ho_74_2 0 0.4692659291642396
Vwn_ho_74_2 wn_ho_74_2 0 0.5307340708357604
Vwp_ho_75_2 wp_ho_75_2 0 0.5393476470174752
Vwn_ho_75_2 wn_ho_75_2 0 0.46065235298252477
Vwp_ho_76_2 wp_ho_76_2 0 0.47996679385533764
Vwn_ho_76_2 wn_ho_76_2 0 0.5200332061446624
Vwp_ho_77_2 wp_ho_77_2 0 0.48109194335204364
Vwn_ho_77_2 wn_ho_77_2 0 0.5189080566479564
Vwp_ho_78_2 wp_ho_78_2 0 0.615301639118236
Vwn_ho_78_2 wn_ho_78_2 0 0.38469836088176407
Vwp_ho_79_2 wp_ho_79_2 0 0.5378675214042268
Vwn_ho_79_2 wn_ho_79_2 0 0.4621324785957732
Vwp_ho_80_2 wp_ho_80_2 0 0.39216958452207146
Vwn_ho_80_2 wn_ho_80_2 0 0.6078304154779285
Vwp_ho_81_2 wp_ho_81_2 0 0.4667988060382462
Vwn_ho_81_2 wn_ho_81_2 0 0.5332011939617538
Vwp_ho_82_2 wp_ho_82_2 0 0.5045551990387094
Vwn_ho_82_2 wn_ho_82_2 0 0.49544480096129057
Vwp_ho_83_2 wp_ho_83_2 0 0.609952805774194
Vwn_ho_83_2 wn_ho_83_2 0 0.390047194225806
Vwp_ho_84_2 wp_ho_84_2 0 0.47552992224749424
Vwn_ho_84_2 wn_ho_84_2 0 0.5244700777525058
Vwp_ho_85_2 wp_ho_85_2 0 0.48083300728593154
Vwn_ho_85_2 wn_ho_85_2 0 0.5191669927140685
Vwp_ho_86_2 wp_ho_86_2 0 0.4940398066764488
Vwn_ho_86_2 wn_ho_86_2 0 0.5059601933235511
Vwp_ho_87_2 wp_ho_87_2 0 0.4423508161114987
Vwn_ho_87_2 wn_ho_87_2 0 0.5576491838885013
Vwp_ho_88_2 wp_ho_88_2 0 0.5920008403329169
Vwn_ho_88_2 wn_ho_88_2 0 0.4079991596670831
Vwp_ho_89_2 wp_ho_89_2 0 0.49196562752324496
Vwn_ho_89_2 wn_ho_89_2 0 0.5080343724767551
Vwp_ho_90_2 wp_ho_90_2 0 0.5256961583018972
Vwn_ho_90_2 wn_ho_90_2 0 0.4743038416981028
Vwp_ho_91_2 wp_ho_91_2 0 0.4928935645486209
Vwn_ho_91_2 wn_ho_91_2 0 0.5071064354513791
Vwp_ho_92_2 wp_ho_92_2 0 0.5676416151857683
Vwn_ho_92_2 wn_ho_92_2 0 0.4323583848142317
Vwp_ho_93_2 wp_ho_93_2 0 0.588695986024919
Vwn_ho_93_2 wn_ho_93_2 0 0.411304013975081
Vwp_ho_94_2 wp_ho_94_2 0 0.5391385371277732
Vwn_ho_94_2 wn_ho_94_2 0 0.46086146287222685
Vwp_ho_95_2 wp_ho_95_2 0 0.47998528919047967
Vwn_ho_95_2 wn_ho_95_2 0 0.5200147108095203
Vwp_ho_96_2 wp_ho_96_2 0 0.5012914242976741
Vwn_ho_96_2 wn_ho_96_2 0 0.49870857570232585
Vwp_ho_97_2 wp_ho_97_2 0 0.5417115211024889
Vwn_ho_97_2 wn_ho_97_2 0 0.4582884788975111
Vwp_ho_98_2 wp_ho_98_2 0 0.6125460123283932
Vwn_ho_98_2 wn_ho_98_2 0 0.3874539876716068
Vwp_ho_99_2 wp_ho_99_2 0 0.5518002232357088
Vwn_ho_99_2 wn_ho_99_2 0 0.4481997767642912
Vwp_ho_100_2 wp_ho_100_2 0 0.5006451177983082
Vwn_ho_100_2 wn_ho_100_2 0 0.4993548822016917
Vwp_ho_101_2 wp_ho_101_2 0 0.5115083603018831
Vwn_ho_101_2 wn_ho_101_2 0 0.48849163969811693
Vwp_ho_102_2 wp_ho_102_2 0 0.5412575448128315
Vwn_ho_102_2 wn_ho_102_2 0 0.4587424551871685
Vwp_ho_103_2 wp_ho_103_2 0 0.49957331672116295
Vwn_ho_103_2 wn_ho_103_2 0 0.500426683278837
Vwp_ho_104_2 wp_ho_104_2 0 0.45649434745456235
Vwn_ho_104_2 wn_ho_104_2 0 0.5435056525454377
Vwp_ho_105_2 wp_ho_105_2 0 0.5096336430179842
Vwn_ho_105_2 wn_ho_105_2 0 0.49036635698201586
Vwp_ho_106_2 wp_ho_106_2 0 0.4379816332797428
Vwn_ho_106_2 wn_ho_106_2 0 0.5620183667202572
Vwp_ho_107_2 wp_ho_107_2 0 0.4993402839687307
Vwn_ho_107_2 wn_ho_107_2 0 0.5006597160312694
Vwp_ho_108_2 wp_ho_108_2 0 0.4874438736135758
Vwn_ho_108_2 wn_ho_108_2 0 0.5125561263864242
Vwp_ho_109_2 wp_ho_109_2 0 0.4987331177258541
Vwn_ho_109_2 wn_ho_109_2 0 0.5012668822741458
Vwp_ho_110_2 wp_ho_110_2 0 0.49662289840482865
Vwn_ho_110_2 wn_ho_110_2 0 0.5033771015951714
Vwp_ho_111_2 wp_ho_111_2 0 0.5072227100934946
Vwn_ho_111_2 wn_ho_111_2 0 0.4927772899065054
Vwp_ho_112_2 wp_ho_112_2 0 0.4432211301734901
Vwn_ho_112_2 wn_ho_112_2 0 0.5567788698265099
Vwp_ho_113_2 wp_ho_113_2 0 0.5653654420495587
Vwn_ho_113_2 wn_ho_113_2 0 0.43463455795044126
Vwp_ho_114_2 wp_ho_114_2 0 0.5555316891046511
Vwn_ho_114_2 wn_ho_114_2 0 0.44446831089534883
Vwp_ho_115_2 wp_ho_115_2 0 0.5084173747502776
Vwn_ho_115_2 wn_ho_115_2 0 0.49158262524972246
Vwp_ho_116_2 wp_ho_116_2 0 0.5004096899384621
Vwn_ho_116_2 wn_ho_116_2 0 0.4995903100615379
Vwp_ho_117_2 wp_ho_117_2 0 0.47550609185047926
Vwn_ho_117_2 wn_ho_117_2 0 0.5244939081495207
Vwp_ho_118_2 wp_ho_118_2 0 0.5148178675851898
Vwn_ho_118_2 wn_ho_118_2 0 0.4851821324148102
Vwp_ho_119_2 wp_ho_119_2 0 0.5520463016116737
Vwn_ho_119_2 wn_ho_119_2 0 0.44795369838832627
Vwp_ho_120_2 wp_ho_120_2 0 0.5685573064994638
Vwn_ho_120_2 wn_ho_120_2 0 0.43144269350053627
Vwp_ho_121_2 wp_ho_121_2 0 0.4604706341934163
Vwn_ho_121_2 wn_ho_121_2 0 0.5395293658065837
Vwp_ho_122_2 wp_ho_122_2 0 0.5138574594962485
Vwn_ho_122_2 wn_ho_122_2 0 0.4861425405037515
Vwp_ho_123_2 wp_ho_123_2 0 0.44710343164879857
Vwn_ho_123_2 wn_ho_123_2 0 0.5528965683512015
Vwp_ho_124_2 wp_ho_124_2 0 0.5469756904291481
Vwn_ho_124_2 wn_ho_124_2 0 0.45302430957085194
Vwp_ho_125_2 wp_ho_125_2 0 0.4235173620372853
Vwn_ho_125_2 wn_ho_125_2 0 0.5764826379627147
Vwp_ho_126_2 wp_ho_126_2 0 0.4700522086771148
Vwn_ho_126_2 wn_ho_126_2 0 0.5299477913228853
Vwp_ho_127_2 wp_ho_127_2 0 0.49616565660236445
Vwn_ho_127_2 wn_ho_127_2 0 0.5038343433976356
Vwp_ho_128_2 wp_ho_128_2 0 0.5021767322798217
Vwn_ho_128_2 wn_ho_128_2 0 0.4978232677201783
Vwp_ho_129_2 wp_ho_129_2 0 0.464151435375168
Vwn_ho_129_2 wn_ho_129_2 0 0.535848564624832
Vwp_ho_130_2 wp_ho_130_2 0 0.38262300741582533
Vwn_ho_130_2 wn_ho_130_2 0 0.6173769925841747
Vwp_ho_131_2 wp_ho_131_2 0 0.6061400000268135
Vwn_ho_131_2 wn_ho_131_2 0 0.39385999997318655
Vwp_ho_132_2 wp_ho_132_2 0 0.41511343136480494
Vwn_ho_132_2 wn_ho_132_2 0 0.5848865686351951
Vwp_ho_133_2 wp_ho_133_2 0 0.5911808713816094
Vwn_ho_133_2 wn_ho_133_2 0 0.4088191286183907
Vwp_ho_134_2 wp_ho_134_2 0 0.4986187610252077
Vwn_ho_134_2 wn_ho_134_2 0 0.5013812389747924
Vwp_ho_135_2 wp_ho_135_2 0 0.45590912694125424
Vwn_ho_135_2 wn_ho_135_2 0 0.5440908730587457
Vwp_ho_136_2 wp_ho_136_2 0 0.5452283579724111
Vwn_ho_136_2 wn_ho_136_2 0 0.4547716420275889
Vwp_ho_137_2 wp_ho_137_2 0 0.4670572399287127
Vwn_ho_137_2 wn_ho_137_2 0 0.5329427600712873
Vwp_ho_138_2 wp_ho_138_2 0 0.4991826141826548
Vwn_ho_138_2 wn_ho_138_2 0 0.5008173858173453
Vwp_ho_139_2 wp_ho_139_2 0 0.5315350527730164
Vwn_ho_139_2 wn_ho_139_2 0 0.4684649472269837
Vwp_ho_140_2 wp_ho_140_2 0 0.4849471218992191
Vwn_ho_140_2 wn_ho_140_2 0 0.5150528781007808
Vwp_ho_141_2 wp_ho_141_2 0 0.5657467903130878
Vwn_ho_141_2 wn_ho_141_2 0 0.4342532096869122
Vwp_ho_142_2 wp_ho_142_2 0 0.4717963738800723
Vwn_ho_142_2 wn_ho_142_2 0 0.5282036261199277
Vwp_ho_143_2 wp_ho_143_2 0 0.5697184476280353
Vwn_ho_143_2 wn_ho_143_2 0 0.4302815523719648
Vwp_ho_144_2 wp_ho_144_2 0 0.49434255815810263
Vwn_ho_144_2 wn_ho_144_2 0 0.5056574418418974
Vwp_ho_145_2 wp_ho_145_2 0 0.5152887931001839
Vwn_ho_145_2 wn_ho_145_2 0 0.484711206899816
Vwp_ho_146_2 wp_ho_146_2 0 0.5006330417093714
Vwn_ho_146_2 wn_ho_146_2 0 0.4993669582906286
Vwp_ho_147_2 wp_ho_147_2 0 0.4468896343284676
Vwn_ho_147_2 wn_ho_147_2 0 0.5531103656715324
Vwp_ho_148_2 wp_ho_148_2 0 0.5609564174687043
Vwn_ho_148_2 wn_ho_148_2 0 0.4390435825312958
Vwp_ho_149_2 wp_ho_149_2 0 0.5763576539025734
Vwn_ho_149_2 wn_ho_149_2 0 0.42364234609742657
Vwp_ho_150_2 wp_ho_150_2 0 0.5362656446466778
Vwn_ho_150_2 wn_ho_150_2 0 0.46373435535332214
Vwp_ho_151_2 wp_ho_151_2 0 0.5702422554511615
Vwn_ho_151_2 wn_ho_151_2 0 0.4297577445488386
Vwp_ho_152_2 wp_ho_152_2 0 0.6021835994400874
Vwn_ho_152_2 wn_ho_152_2 0 0.39781640055991263
Vwp_ho_153_2 wp_ho_153_2 0 0.6108445171223665
Vwn_ho_153_2 wn_ho_153_2 0 0.38915548287763346
Vwp_ho_154_2 wp_ho_154_2 0 0.6102588829011394
Vwn_ho_154_2 wn_ho_154_2 0 0.3897411170988606
Vwp_ho_155_2 wp_ho_155_2 0 0.5580414259743526
Vwn_ho_155_2 wn_ho_155_2 0 0.4419585740256474
Vwp_ho_156_2 wp_ho_156_2 0 0.4183491514146723
Vwn_ho_156_2 wn_ho_156_2 0 0.5816508485853277
Vwp_ho_157_2 wp_ho_157_2 0 0.46417300345722967
Vwn_ho_157_2 wn_ho_157_2 0 0.5358269965427703
Vwp_ho_158_2 wp_ho_158_2 0 0.506429365695026
Vwn_ho_158_2 wn_ho_158_2 0 0.493570634304974
Vwp_ho_159_2 wp_ho_159_2 0 0.45049851342832825
Vwn_ho_159_2 wn_ho_159_2 0 0.5495014865716717
Vwp_ho_160_2 wp_ho_160_2 0 0.497801698711298
Vwn_ho_160_2 wn_ho_160_2 0 0.502198301288702
Vwp_ho_161_2 wp_ho_161_2 0 0.4913454345117761
Vwn_ho_161_2 wn_ho_161_2 0 0.508654565488224
Vwp_ho_162_2 wp_ho_162_2 0 0.4783888588033265
Vwn_ho_162_2 wn_ho_162_2 0 0.5216111411966735
Vwp_ho_163_2 wp_ho_163_2 0 0.49750568116176624
Vwn_ho_163_2 wn_ho_163_2 0 0.5024943188382338
Vwp_ho_164_2 wp_ho_164_2 0 0.5468406474924984
Vwn_ho_164_2 wn_ho_164_2 0 0.45315935250750156
Vwp_ho_165_2 wp_ho_165_2 0 0.48638552211214975
Vwn_ho_165_2 wn_ho_165_2 0 0.5136144778878502
Vwp_ho_166_2 wp_ho_166_2 0 0.483920716920162
Vwn_ho_166_2 wn_ho_166_2 0 0.5160792830798381
Vwp_ho_167_2 wp_ho_167_2 0 0.5094541087896661
Vwn_ho_167_2 wn_ho_167_2 0 0.4905458912103339
Vwp_ho_168_2 wp_ho_168_2 0 0.5571345539894109
Vwn_ho_168_2 wn_ho_168_2 0 0.4428654460105891
Vwp_ho_169_2 wp_ho_169_2 0 0.5131345622539426
Vwn_ho_169_2 wn_ho_169_2 0 0.48686543774605745
Vwp_ho_170_2 wp_ho_170_2 0 0.5679992375930688
Vwn_ho_170_2 wn_ho_170_2 0 0.4320007624069312
Vwp_ho_171_2 wp_ho_171_2 0 0.529642776788831
Vwn_ho_171_2 wn_ho_171_2 0 0.47035722321116896
Vwp_ho_172_2 wp_ho_172_2 0 0.5675306666088323
Vwn_ho_172_2 wn_ho_172_2 0 0.43246933339116767
Vwp_ho_173_2 wp_ho_173_2 0 0.5590489438935786
Vwn_ho_173_2 wn_ho_173_2 0 0.4409510561064213
Vwp_ho_174_2 wp_ho_174_2 0 0.37535558249625417
Vwn_ho_174_2 wn_ho_174_2 0 0.6246444175037458
Vwp_ho_175_2 wp_ho_175_2 0 0.49363192867888556
Vwn_ho_175_2 wn_ho_175_2 0 0.5063680713211145
Vwp_ho_176_2 wp_ho_176_2 0 0.44554931135025144
Vwn_ho_176_2 wn_ho_176_2 0 0.5544506886497486
Vwp_ho_177_2 wp_ho_177_2 0 0.567656646306328
Vwn_ho_177_2 wn_ho_177_2 0 0.43234335369367205
Vwp_ho_178_2 wp_ho_178_2 0 0.5470878883678403
Vwn_ho_178_2 wn_ho_178_2 0 0.45291211163215966
Vwp_ho_179_2 wp_ho_179_2 0 0.5123156171302431
Vwn_ho_179_2 wn_ho_179_2 0 0.4876843828697569
Vwp_ho_180_2 wp_ho_180_2 0 0.4883663970020911
Vwn_ho_180_2 wn_ho_180_2 0 0.5116336029979088
Vwp_ho_181_2 wp_ho_181_2 0 0.3797542607847785
Vwn_ho_181_2 wn_ho_181_2 0 0.6202457392152215
Vwp_ho_182_2 wp_ho_182_2 0 0.5561724860023136
Vwn_ho_182_2 wn_ho_182_2 0 0.44382751399768633
Vwp_ho_183_2 wp_ho_183_2 0 0.45769464940102217
Vwn_ho_183_2 wn_ho_183_2 0 0.5423053505989779
Vwp_ho_184_2 wp_ho_184_2 0 0.5362094330854786
Vwn_ho_184_2 wn_ho_184_2 0 0.46379056691452136
Vwp_ho_185_2 wp_ho_185_2 0 0.5118682570272862
Vwn_ho_185_2 wn_ho_185_2 0 0.4881317429727138
Vwp_ho_186_2 wp_ho_186_2 0 0.6239315655721918
Vwn_ho_186_2 wn_ho_186_2 0 0.3760684344278083
Vwp_ho_187_2 wp_ho_187_2 0 0.508146103756787
Vwn_ho_187_2 wn_ho_187_2 0 0.49185389624321296
Vwp_ho_188_2 wp_ho_188_2 0 0.41285208566677833
Vwn_ho_188_2 wn_ho_188_2 0 0.5871479143332217
Vwp_ho_189_2 wp_ho_189_2 0 0.5771050482354151
Vwn_ho_189_2 wn_ho_189_2 0 0.42289495176458497
Vwp_ho_190_2 wp_ho_190_2 0 0.4943414497836131
Vwn_ho_190_2 wn_ho_190_2 0 0.505658550216387
Vwp_ho_191_2 wp_ho_191_2 0 0.5956990227678798
Vwn_ho_191_2 wn_ho_191_2 0 0.40430097723212016
Vwp_ho_192_2 wp_ho_192_2 0 0.5138108579568322
Vwn_ho_192_2 wn_ho_192_2 0 0.4861891420431677
Vwp_ho_193_2 wp_ho_193_2 0 0.40432799036699335
Vwn_ho_193_2 wn_ho_193_2 0 0.5956720096330067
Vwp_ho_194_2 wp_ho_194_2 0 0.5334751875155268
Vwn_ho_194_2 wn_ho_194_2 0 0.4665248124844732
Vwp_ho_195_2 wp_ho_195_2 0 0.46123636408603785
Vwn_ho_195_2 wn_ho_195_2 0 0.5387636359139621
Vwp_ho_196_2 wp_ho_196_2 0 0.5752469680485753
Vwn_ho_196_2 wn_ho_196_2 0 0.42475303195142466
Vwp_ho_197_2 wp_ho_197_2 0 0.520492068956707
Vwn_ho_197_2 wn_ho_197_2 0 0.4795079310432931
Vwp_ho_198_2 wp_ho_198_2 0 0.4589317418390267
Vwn_ho_198_2 wn_ho_198_2 0 0.5410682581609733
Vwp_ho_199_2 wp_ho_199_2 0 0.4382195148898227
Vwn_ho_199_2 wn_ho_199_2 0 0.5617804851101773
Xcm_xh0 xhp0 xhn0 vdd cmld
Rnd_xh0 xhp0 xhn0 20k
Cxh0p xhp0 0 1e-13
Cxh0n xhn0 0 1e-13
Xihx_0_0 a_xp0 a_xn0 wp_ih_0_0 wn_ih_0_0 xhp0 xhn0 vdd vbsyn gsyn
Xihx_1_0 a_xp1 a_xn1 wp_ih_1_0 wn_ih_1_0 xhp0 xhn0 vdd vbsyn gsyn
Xihx_2_0 a_xp2 a_xn2 wp_ih_2_0 wn_ih_2_0 xhp0 xhn0 vdd vbsyn gsyn
Xn0 xhp0 xhn0 ahp0 ahn0 vdd vbneu dneuron
Xcm_xh1 xhp1 xhn1 vdd cmld
Rnd_xh1 xhp1 xhn1 20k
Cxh1p xhp1 0 1e-13
Cxh1n xhn1 0 1e-13
Xihx_0_1 a_xp0 a_xn0 wp_ih_0_1 wn_ih_0_1 xhp1 xhn1 vdd vbsyn gsyn
Xihx_1_1 a_xp1 a_xn1 wp_ih_1_1 wn_ih_1_1 xhp1 xhn1 vdd vbsyn gsyn
Xihx_2_1 a_xp2 a_xn2 wp_ih_2_1 wn_ih_2_1 xhp1 xhn1 vdd vbsyn gsyn
Xn1 xhp1 xhn1 ahp1 ahn1 vdd vbneu dneuron
Xcm_xh2 xhp2 xhn2 vdd cmld
Rnd_xh2 xhp2 xhn2 20k
Cxh2p xhp2 0 1e-13
Cxh2n xhn2 0 1e-13
Xihx_0_2 a_xp0 a_xn0 wp_ih_0_2 wn_ih_0_2 xhp2 xhn2 vdd vbsyn gsyn
Xihx_1_2 a_xp1 a_xn1 wp_ih_1_2 wn_ih_1_2 xhp2 xhn2 vdd vbsyn gsyn
Xihx_2_2 a_xp2 a_xn2 wp_ih_2_2 wn_ih_2_2 xhp2 xhn2 vdd vbsyn gsyn
Xn2 xhp2 xhn2 ahp2 ahn2 vdd vbneu dneuron
Xcm_xh3 xhp3 xhn3 vdd cmld
Rnd_xh3 xhp3 xhn3 20k
Cxh3p xhp3 0 1e-13
Cxh3n xhn3 0 1e-13
Xihx_0_3 a_xp0 a_xn0 wp_ih_0_3 wn_ih_0_3 xhp3 xhn3 vdd vbsyn gsyn
Xihx_1_3 a_xp1 a_xn1 wp_ih_1_3 wn_ih_1_3 xhp3 xhn3 vdd vbsyn gsyn
Xihx_2_3 a_xp2 a_xn2 wp_ih_2_3 wn_ih_2_3 xhp3 xhn3 vdd vbsyn gsyn
Xn3 xhp3 xhn3 ahp3 ahn3 vdd vbneu dneuron
Xcm_xh4 xhp4 xhn4 vdd cmld
Rnd_xh4 xhp4 xhn4 20k
Cxh4p xhp4 0 1e-13
Cxh4n xhn4 0 1e-13
Xihx_0_4 a_xp0 a_xn0 wp_ih_0_4 wn_ih_0_4 xhp4 xhn4 vdd vbsyn gsyn
Xihx_1_4 a_xp1 a_xn1 wp_ih_1_4 wn_ih_1_4 xhp4 xhn4 vdd vbsyn gsyn
Xihx_2_4 a_xp2 a_xn2 wp_ih_2_4 wn_ih_2_4 xhp4 xhn4 vdd vbsyn gsyn
Xn4 xhp4 xhn4 ahp4 ahn4 vdd vbneu dneuron
Xcm_xh5 xhp5 xhn5 vdd cmld
Rnd_xh5 xhp5 xhn5 20k
Cxh5p xhp5 0 1e-13
Cxh5n xhn5 0 1e-13
Xihx_0_5 a_xp0 a_xn0 wp_ih_0_5 wn_ih_0_5 xhp5 xhn5 vdd vbsyn gsyn
Xihx_1_5 a_xp1 a_xn1 wp_ih_1_5 wn_ih_1_5 xhp5 xhn5 vdd vbsyn gsyn
Xihx_2_5 a_xp2 a_xn2 wp_ih_2_5 wn_ih_2_5 xhp5 xhn5 vdd vbsyn gsyn
Xn5 xhp5 xhn5 ahp5 ahn5 vdd vbneu dneuron
Xcm_xh6 xhp6 xhn6 vdd cmld
Rnd_xh6 xhp6 xhn6 20k
Cxh6p xhp6 0 1e-13
Cxh6n xhn6 0 1e-13
Xihx_0_6 a_xp0 a_xn0 wp_ih_0_6 wn_ih_0_6 xhp6 xhn6 vdd vbsyn gsyn
Xihx_1_6 a_xp1 a_xn1 wp_ih_1_6 wn_ih_1_6 xhp6 xhn6 vdd vbsyn gsyn
Xihx_2_6 a_xp2 a_xn2 wp_ih_2_6 wn_ih_2_6 xhp6 xhn6 vdd vbsyn gsyn
Xn6 xhp6 xhn6 ahp6 ahn6 vdd vbneu dneuron
Xcm_xh7 xhp7 xhn7 vdd cmld
Rnd_xh7 xhp7 xhn7 20k
Cxh7p xhp7 0 1e-13
Cxh7n xhn7 0 1e-13
Xihx_0_7 a_xp0 a_xn0 wp_ih_0_7 wn_ih_0_7 xhp7 xhn7 vdd vbsyn gsyn
Xihx_1_7 a_xp1 a_xn1 wp_ih_1_7 wn_ih_1_7 xhp7 xhn7 vdd vbsyn gsyn
Xihx_2_7 a_xp2 a_xn2 wp_ih_2_7 wn_ih_2_7 xhp7 xhn7 vdd vbsyn gsyn
Xn7 xhp7 xhn7 ahp7 ahn7 vdd vbneu dneuron
Xcm_xh8 xhp8 xhn8 vdd cmld
Rnd_xh8 xhp8 xhn8 20k
Cxh8p xhp8 0 1e-13
Cxh8n xhn8 0 1e-13
Xihx_0_8 a_xp0 a_xn0 wp_ih_0_8 wn_ih_0_8 xhp8 xhn8 vdd vbsyn gsyn
Xihx_1_8 a_xp1 a_xn1 wp_ih_1_8 wn_ih_1_8 xhp8 xhn8 vdd vbsyn gsyn
Xihx_2_8 a_xp2 a_xn2 wp_ih_2_8 wn_ih_2_8 xhp8 xhn8 vdd vbsyn gsyn
Xn8 xhp8 xhn8 ahp8 ahn8 vdd vbneu dneuron
Xcm_xh9 xhp9 xhn9 vdd cmld
Rnd_xh9 xhp9 xhn9 20k
Cxh9p xhp9 0 1e-13
Cxh9n xhn9 0 1e-13
Xihx_0_9 a_xp0 a_xn0 wp_ih_0_9 wn_ih_0_9 xhp9 xhn9 vdd vbsyn gsyn
Xihx_1_9 a_xp1 a_xn1 wp_ih_1_9 wn_ih_1_9 xhp9 xhn9 vdd vbsyn gsyn
Xihx_2_9 a_xp2 a_xn2 wp_ih_2_9 wn_ih_2_9 xhp9 xhn9 vdd vbsyn gsyn
Xn9 xhp9 xhn9 ahp9 ahn9 vdd vbneu dneuron
Xcm_xh10 xhp10 xhn10 vdd cmld
Rnd_xh10 xhp10 xhn10 20k
Cxh10p xhp10 0 1e-13
Cxh10n xhn10 0 1e-13
Xihx_0_10 a_xp0 a_xn0 wp_ih_0_10 wn_ih_0_10 xhp10 xhn10 vdd vbsyn gsyn
Xihx_1_10 a_xp1 a_xn1 wp_ih_1_10 wn_ih_1_10 xhp10 xhn10 vdd vbsyn gsyn
Xihx_2_10 a_xp2 a_xn2 wp_ih_2_10 wn_ih_2_10 xhp10 xhn10 vdd vbsyn gsyn
Xn10 xhp10 xhn10 ahp10 ahn10 vdd vbneu dneuron
Xcm_xh11 xhp11 xhn11 vdd cmld
Rnd_xh11 xhp11 xhn11 20k
Cxh11p xhp11 0 1e-13
Cxh11n xhn11 0 1e-13
Xihx_0_11 a_xp0 a_xn0 wp_ih_0_11 wn_ih_0_11 xhp11 xhn11 vdd vbsyn gsyn
Xihx_1_11 a_xp1 a_xn1 wp_ih_1_11 wn_ih_1_11 xhp11 xhn11 vdd vbsyn gsyn
Xihx_2_11 a_xp2 a_xn2 wp_ih_2_11 wn_ih_2_11 xhp11 xhn11 vdd vbsyn gsyn
Xn11 xhp11 xhn11 ahp11 ahn11 vdd vbneu dneuron
Xcm_xh12 xhp12 xhn12 vdd cmld
Rnd_xh12 xhp12 xhn12 20k
Cxh12p xhp12 0 1e-13
Cxh12n xhn12 0 1e-13
Xihx_0_12 a_xp0 a_xn0 wp_ih_0_12 wn_ih_0_12 xhp12 xhn12 vdd vbsyn gsyn
Xihx_1_12 a_xp1 a_xn1 wp_ih_1_12 wn_ih_1_12 xhp12 xhn12 vdd vbsyn gsyn
Xihx_2_12 a_xp2 a_xn2 wp_ih_2_12 wn_ih_2_12 xhp12 xhn12 vdd vbsyn gsyn
Xn12 xhp12 xhn12 ahp12 ahn12 vdd vbneu dneuron
Xcm_xh13 xhp13 xhn13 vdd cmld
Rnd_xh13 xhp13 xhn13 20k
Cxh13p xhp13 0 1e-13
Cxh13n xhn13 0 1e-13
Xihx_0_13 a_xp0 a_xn0 wp_ih_0_13 wn_ih_0_13 xhp13 xhn13 vdd vbsyn gsyn
Xihx_1_13 a_xp1 a_xn1 wp_ih_1_13 wn_ih_1_13 xhp13 xhn13 vdd vbsyn gsyn
Xihx_2_13 a_xp2 a_xn2 wp_ih_2_13 wn_ih_2_13 xhp13 xhn13 vdd vbsyn gsyn
Xn13 xhp13 xhn13 ahp13 ahn13 vdd vbneu dneuron
Xcm_xh14 xhp14 xhn14 vdd cmld
Rnd_xh14 xhp14 xhn14 20k
Cxh14p xhp14 0 1e-13
Cxh14n xhn14 0 1e-13
Xihx_0_14 a_xp0 a_xn0 wp_ih_0_14 wn_ih_0_14 xhp14 xhn14 vdd vbsyn gsyn
Xihx_1_14 a_xp1 a_xn1 wp_ih_1_14 wn_ih_1_14 xhp14 xhn14 vdd vbsyn gsyn
Xihx_2_14 a_xp2 a_xn2 wp_ih_2_14 wn_ih_2_14 xhp14 xhn14 vdd vbsyn gsyn
Xn14 xhp14 xhn14 ahp14 ahn14 vdd vbneu dneuron
Xcm_xh15 xhp15 xhn15 vdd cmld
Rnd_xh15 xhp15 xhn15 20k
Cxh15p xhp15 0 1e-13
Cxh15n xhn15 0 1e-13
Xihx_0_15 a_xp0 a_xn0 wp_ih_0_15 wn_ih_0_15 xhp15 xhn15 vdd vbsyn gsyn
Xihx_1_15 a_xp1 a_xn1 wp_ih_1_15 wn_ih_1_15 xhp15 xhn15 vdd vbsyn gsyn
Xihx_2_15 a_xp2 a_xn2 wp_ih_2_15 wn_ih_2_15 xhp15 xhn15 vdd vbsyn gsyn
Xn15 xhp15 xhn15 ahp15 ahn15 vdd vbneu dneuron
Xcm_xh16 xhp16 xhn16 vdd cmld
Rnd_xh16 xhp16 xhn16 20k
Cxh16p xhp16 0 1e-13
Cxh16n xhn16 0 1e-13
Xihx_0_16 a_xp0 a_xn0 wp_ih_0_16 wn_ih_0_16 xhp16 xhn16 vdd vbsyn gsyn
Xihx_1_16 a_xp1 a_xn1 wp_ih_1_16 wn_ih_1_16 xhp16 xhn16 vdd vbsyn gsyn
Xihx_2_16 a_xp2 a_xn2 wp_ih_2_16 wn_ih_2_16 xhp16 xhn16 vdd vbsyn gsyn
Xn16 xhp16 xhn16 ahp16 ahn16 vdd vbneu dneuron
Xcm_xh17 xhp17 xhn17 vdd cmld
Rnd_xh17 xhp17 xhn17 20k
Cxh17p xhp17 0 1e-13
Cxh17n xhn17 0 1e-13
Xihx_0_17 a_xp0 a_xn0 wp_ih_0_17 wn_ih_0_17 xhp17 xhn17 vdd vbsyn gsyn
Xihx_1_17 a_xp1 a_xn1 wp_ih_1_17 wn_ih_1_17 xhp17 xhn17 vdd vbsyn gsyn
Xihx_2_17 a_xp2 a_xn2 wp_ih_2_17 wn_ih_2_17 xhp17 xhn17 vdd vbsyn gsyn
Xn17 xhp17 xhn17 ahp17 ahn17 vdd vbneu dneuron
Xcm_xh18 xhp18 xhn18 vdd cmld
Rnd_xh18 xhp18 xhn18 20k
Cxh18p xhp18 0 1e-13
Cxh18n xhn18 0 1e-13
Xihx_0_18 a_xp0 a_xn0 wp_ih_0_18 wn_ih_0_18 xhp18 xhn18 vdd vbsyn gsyn
Xihx_1_18 a_xp1 a_xn1 wp_ih_1_18 wn_ih_1_18 xhp18 xhn18 vdd vbsyn gsyn
Xihx_2_18 a_xp2 a_xn2 wp_ih_2_18 wn_ih_2_18 xhp18 xhn18 vdd vbsyn gsyn
Xn18 xhp18 xhn18 ahp18 ahn18 vdd vbneu dneuron
Xcm_xh19 xhp19 xhn19 vdd cmld
Rnd_xh19 xhp19 xhn19 20k
Cxh19p xhp19 0 1e-13
Cxh19n xhn19 0 1e-13
Xihx_0_19 a_xp0 a_xn0 wp_ih_0_19 wn_ih_0_19 xhp19 xhn19 vdd vbsyn gsyn
Xihx_1_19 a_xp1 a_xn1 wp_ih_1_19 wn_ih_1_19 xhp19 xhn19 vdd vbsyn gsyn
Xihx_2_19 a_xp2 a_xn2 wp_ih_2_19 wn_ih_2_19 xhp19 xhn19 vdd vbsyn gsyn
Xn19 xhp19 xhn19 ahp19 ahn19 vdd vbneu dneuron
Xcm_xh20 xhp20 xhn20 vdd cmld
Rnd_xh20 xhp20 xhn20 20k
Cxh20p xhp20 0 1e-13
Cxh20n xhn20 0 1e-13
Xihx_0_20 a_xp0 a_xn0 wp_ih_0_20 wn_ih_0_20 xhp20 xhn20 vdd vbsyn gsyn
Xihx_1_20 a_xp1 a_xn1 wp_ih_1_20 wn_ih_1_20 xhp20 xhn20 vdd vbsyn gsyn
Xihx_2_20 a_xp2 a_xn2 wp_ih_2_20 wn_ih_2_20 xhp20 xhn20 vdd vbsyn gsyn
Xn20 xhp20 xhn20 ahp20 ahn20 vdd vbneu dneuron
Xcm_xh21 xhp21 xhn21 vdd cmld
Rnd_xh21 xhp21 xhn21 20k
Cxh21p xhp21 0 1e-13
Cxh21n xhn21 0 1e-13
Xihx_0_21 a_xp0 a_xn0 wp_ih_0_21 wn_ih_0_21 xhp21 xhn21 vdd vbsyn gsyn
Xihx_1_21 a_xp1 a_xn1 wp_ih_1_21 wn_ih_1_21 xhp21 xhn21 vdd vbsyn gsyn
Xihx_2_21 a_xp2 a_xn2 wp_ih_2_21 wn_ih_2_21 xhp21 xhn21 vdd vbsyn gsyn
Xn21 xhp21 xhn21 ahp21 ahn21 vdd vbneu dneuron
Xcm_xh22 xhp22 xhn22 vdd cmld
Rnd_xh22 xhp22 xhn22 20k
Cxh22p xhp22 0 1e-13
Cxh22n xhn22 0 1e-13
Xihx_0_22 a_xp0 a_xn0 wp_ih_0_22 wn_ih_0_22 xhp22 xhn22 vdd vbsyn gsyn
Xihx_1_22 a_xp1 a_xn1 wp_ih_1_22 wn_ih_1_22 xhp22 xhn22 vdd vbsyn gsyn
Xihx_2_22 a_xp2 a_xn2 wp_ih_2_22 wn_ih_2_22 xhp22 xhn22 vdd vbsyn gsyn
Xn22 xhp22 xhn22 ahp22 ahn22 vdd vbneu dneuron
Xcm_xh23 xhp23 xhn23 vdd cmld
Rnd_xh23 xhp23 xhn23 20k
Cxh23p xhp23 0 1e-13
Cxh23n xhn23 0 1e-13
Xihx_0_23 a_xp0 a_xn0 wp_ih_0_23 wn_ih_0_23 xhp23 xhn23 vdd vbsyn gsyn
Xihx_1_23 a_xp1 a_xn1 wp_ih_1_23 wn_ih_1_23 xhp23 xhn23 vdd vbsyn gsyn
Xihx_2_23 a_xp2 a_xn2 wp_ih_2_23 wn_ih_2_23 xhp23 xhn23 vdd vbsyn gsyn
Xn23 xhp23 xhn23 ahp23 ahn23 vdd vbneu dneuron
Xcm_xh24 xhp24 xhn24 vdd cmld
Rnd_xh24 xhp24 xhn24 20k
Cxh24p xhp24 0 1e-13
Cxh24n xhn24 0 1e-13
Xihx_0_24 a_xp0 a_xn0 wp_ih_0_24 wn_ih_0_24 xhp24 xhn24 vdd vbsyn gsyn
Xihx_1_24 a_xp1 a_xn1 wp_ih_1_24 wn_ih_1_24 xhp24 xhn24 vdd vbsyn gsyn
Xihx_2_24 a_xp2 a_xn2 wp_ih_2_24 wn_ih_2_24 xhp24 xhn24 vdd vbsyn gsyn
Xn24 xhp24 xhn24 ahp24 ahn24 vdd vbneu dneuron
Xcm_xh25 xhp25 xhn25 vdd cmld
Rnd_xh25 xhp25 xhn25 20k
Cxh25p xhp25 0 1e-13
Cxh25n xhn25 0 1e-13
Xihx_0_25 a_xp0 a_xn0 wp_ih_0_25 wn_ih_0_25 xhp25 xhn25 vdd vbsyn gsyn
Xihx_1_25 a_xp1 a_xn1 wp_ih_1_25 wn_ih_1_25 xhp25 xhn25 vdd vbsyn gsyn
Xihx_2_25 a_xp2 a_xn2 wp_ih_2_25 wn_ih_2_25 xhp25 xhn25 vdd vbsyn gsyn
Xn25 xhp25 xhn25 ahp25 ahn25 vdd vbneu dneuron
Xcm_xh26 xhp26 xhn26 vdd cmld
Rnd_xh26 xhp26 xhn26 20k
Cxh26p xhp26 0 1e-13
Cxh26n xhn26 0 1e-13
Xihx_0_26 a_xp0 a_xn0 wp_ih_0_26 wn_ih_0_26 xhp26 xhn26 vdd vbsyn gsyn
Xihx_1_26 a_xp1 a_xn1 wp_ih_1_26 wn_ih_1_26 xhp26 xhn26 vdd vbsyn gsyn
Xihx_2_26 a_xp2 a_xn2 wp_ih_2_26 wn_ih_2_26 xhp26 xhn26 vdd vbsyn gsyn
Xn26 xhp26 xhn26 ahp26 ahn26 vdd vbneu dneuron
Xcm_xh27 xhp27 xhn27 vdd cmld
Rnd_xh27 xhp27 xhn27 20k
Cxh27p xhp27 0 1e-13
Cxh27n xhn27 0 1e-13
Xihx_0_27 a_xp0 a_xn0 wp_ih_0_27 wn_ih_0_27 xhp27 xhn27 vdd vbsyn gsyn
Xihx_1_27 a_xp1 a_xn1 wp_ih_1_27 wn_ih_1_27 xhp27 xhn27 vdd vbsyn gsyn
Xihx_2_27 a_xp2 a_xn2 wp_ih_2_27 wn_ih_2_27 xhp27 xhn27 vdd vbsyn gsyn
Xn27 xhp27 xhn27 ahp27 ahn27 vdd vbneu dneuron
Xcm_xh28 xhp28 xhn28 vdd cmld
Rnd_xh28 xhp28 xhn28 20k
Cxh28p xhp28 0 1e-13
Cxh28n xhn28 0 1e-13
Xihx_0_28 a_xp0 a_xn0 wp_ih_0_28 wn_ih_0_28 xhp28 xhn28 vdd vbsyn gsyn
Xihx_1_28 a_xp1 a_xn1 wp_ih_1_28 wn_ih_1_28 xhp28 xhn28 vdd vbsyn gsyn
Xihx_2_28 a_xp2 a_xn2 wp_ih_2_28 wn_ih_2_28 xhp28 xhn28 vdd vbsyn gsyn
Xn28 xhp28 xhn28 ahp28 ahn28 vdd vbneu dneuron
Xcm_xh29 xhp29 xhn29 vdd cmld
Rnd_xh29 xhp29 xhn29 20k
Cxh29p xhp29 0 1e-13
Cxh29n xhn29 0 1e-13
Xihx_0_29 a_xp0 a_xn0 wp_ih_0_29 wn_ih_0_29 xhp29 xhn29 vdd vbsyn gsyn
Xihx_1_29 a_xp1 a_xn1 wp_ih_1_29 wn_ih_1_29 xhp29 xhn29 vdd vbsyn gsyn
Xihx_2_29 a_xp2 a_xn2 wp_ih_2_29 wn_ih_2_29 xhp29 xhn29 vdd vbsyn gsyn
Xn29 xhp29 xhn29 ahp29 ahn29 vdd vbneu dneuron
Xcm_xh30 xhp30 xhn30 vdd cmld
Rnd_xh30 xhp30 xhn30 20k
Cxh30p xhp30 0 1e-13
Cxh30n xhn30 0 1e-13
Xihx_0_30 a_xp0 a_xn0 wp_ih_0_30 wn_ih_0_30 xhp30 xhn30 vdd vbsyn gsyn
Xihx_1_30 a_xp1 a_xn1 wp_ih_1_30 wn_ih_1_30 xhp30 xhn30 vdd vbsyn gsyn
Xihx_2_30 a_xp2 a_xn2 wp_ih_2_30 wn_ih_2_30 xhp30 xhn30 vdd vbsyn gsyn
Xn30 xhp30 xhn30 ahp30 ahn30 vdd vbneu dneuron
Xcm_xh31 xhp31 xhn31 vdd cmld
Rnd_xh31 xhp31 xhn31 20k
Cxh31p xhp31 0 1e-13
Cxh31n xhn31 0 1e-13
Xihx_0_31 a_xp0 a_xn0 wp_ih_0_31 wn_ih_0_31 xhp31 xhn31 vdd vbsyn gsyn
Xihx_1_31 a_xp1 a_xn1 wp_ih_1_31 wn_ih_1_31 xhp31 xhn31 vdd vbsyn gsyn
Xihx_2_31 a_xp2 a_xn2 wp_ih_2_31 wn_ih_2_31 xhp31 xhn31 vdd vbsyn gsyn
Xn31 xhp31 xhn31 ahp31 ahn31 vdd vbneu dneuron
Xcm_xh32 xhp32 xhn32 vdd cmld
Rnd_xh32 xhp32 xhn32 20k
Cxh32p xhp32 0 1e-13
Cxh32n xhn32 0 1e-13
Xihx_0_32 a_xp0 a_xn0 wp_ih_0_32 wn_ih_0_32 xhp32 xhn32 vdd vbsyn gsyn
Xihx_1_32 a_xp1 a_xn1 wp_ih_1_32 wn_ih_1_32 xhp32 xhn32 vdd vbsyn gsyn
Xihx_2_32 a_xp2 a_xn2 wp_ih_2_32 wn_ih_2_32 xhp32 xhn32 vdd vbsyn gsyn
Xn32 xhp32 xhn32 ahp32 ahn32 vdd vbneu dneuron
Xcm_xh33 xhp33 xhn33 vdd cmld
Rnd_xh33 xhp33 xhn33 20k
Cxh33p xhp33 0 1e-13
Cxh33n xhn33 0 1e-13
Xihx_0_33 a_xp0 a_xn0 wp_ih_0_33 wn_ih_0_33 xhp33 xhn33 vdd vbsyn gsyn
Xihx_1_33 a_xp1 a_xn1 wp_ih_1_33 wn_ih_1_33 xhp33 xhn33 vdd vbsyn gsyn
Xihx_2_33 a_xp2 a_xn2 wp_ih_2_33 wn_ih_2_33 xhp33 xhn33 vdd vbsyn gsyn
Xn33 xhp33 xhn33 ahp33 ahn33 vdd vbneu dneuron
Xcm_xh34 xhp34 xhn34 vdd cmld
Rnd_xh34 xhp34 xhn34 20k
Cxh34p xhp34 0 1e-13
Cxh34n xhn34 0 1e-13
Xihx_0_34 a_xp0 a_xn0 wp_ih_0_34 wn_ih_0_34 xhp34 xhn34 vdd vbsyn gsyn
Xihx_1_34 a_xp1 a_xn1 wp_ih_1_34 wn_ih_1_34 xhp34 xhn34 vdd vbsyn gsyn
Xihx_2_34 a_xp2 a_xn2 wp_ih_2_34 wn_ih_2_34 xhp34 xhn34 vdd vbsyn gsyn
Xn34 xhp34 xhn34 ahp34 ahn34 vdd vbneu dneuron
Xcm_xh35 xhp35 xhn35 vdd cmld
Rnd_xh35 xhp35 xhn35 20k
Cxh35p xhp35 0 1e-13
Cxh35n xhn35 0 1e-13
Xihx_0_35 a_xp0 a_xn0 wp_ih_0_35 wn_ih_0_35 xhp35 xhn35 vdd vbsyn gsyn
Xihx_1_35 a_xp1 a_xn1 wp_ih_1_35 wn_ih_1_35 xhp35 xhn35 vdd vbsyn gsyn
Xihx_2_35 a_xp2 a_xn2 wp_ih_2_35 wn_ih_2_35 xhp35 xhn35 vdd vbsyn gsyn
Xn35 xhp35 xhn35 ahp35 ahn35 vdd vbneu dneuron
Xcm_xh36 xhp36 xhn36 vdd cmld
Rnd_xh36 xhp36 xhn36 20k
Cxh36p xhp36 0 1e-13
Cxh36n xhn36 0 1e-13
Xihx_0_36 a_xp0 a_xn0 wp_ih_0_36 wn_ih_0_36 xhp36 xhn36 vdd vbsyn gsyn
Xihx_1_36 a_xp1 a_xn1 wp_ih_1_36 wn_ih_1_36 xhp36 xhn36 vdd vbsyn gsyn
Xihx_2_36 a_xp2 a_xn2 wp_ih_2_36 wn_ih_2_36 xhp36 xhn36 vdd vbsyn gsyn
Xn36 xhp36 xhn36 ahp36 ahn36 vdd vbneu dneuron
Xcm_xh37 xhp37 xhn37 vdd cmld
Rnd_xh37 xhp37 xhn37 20k
Cxh37p xhp37 0 1e-13
Cxh37n xhn37 0 1e-13
Xihx_0_37 a_xp0 a_xn0 wp_ih_0_37 wn_ih_0_37 xhp37 xhn37 vdd vbsyn gsyn
Xihx_1_37 a_xp1 a_xn1 wp_ih_1_37 wn_ih_1_37 xhp37 xhn37 vdd vbsyn gsyn
Xihx_2_37 a_xp2 a_xn2 wp_ih_2_37 wn_ih_2_37 xhp37 xhn37 vdd vbsyn gsyn
Xn37 xhp37 xhn37 ahp37 ahn37 vdd vbneu dneuron
Xcm_xh38 xhp38 xhn38 vdd cmld
Rnd_xh38 xhp38 xhn38 20k
Cxh38p xhp38 0 1e-13
Cxh38n xhn38 0 1e-13
Xihx_0_38 a_xp0 a_xn0 wp_ih_0_38 wn_ih_0_38 xhp38 xhn38 vdd vbsyn gsyn
Xihx_1_38 a_xp1 a_xn1 wp_ih_1_38 wn_ih_1_38 xhp38 xhn38 vdd vbsyn gsyn
Xihx_2_38 a_xp2 a_xn2 wp_ih_2_38 wn_ih_2_38 xhp38 xhn38 vdd vbsyn gsyn
Xn38 xhp38 xhn38 ahp38 ahn38 vdd vbneu dneuron
Xcm_xh39 xhp39 xhn39 vdd cmld
Rnd_xh39 xhp39 xhn39 20k
Cxh39p xhp39 0 1e-13
Cxh39n xhn39 0 1e-13
Xihx_0_39 a_xp0 a_xn0 wp_ih_0_39 wn_ih_0_39 xhp39 xhn39 vdd vbsyn gsyn
Xihx_1_39 a_xp1 a_xn1 wp_ih_1_39 wn_ih_1_39 xhp39 xhn39 vdd vbsyn gsyn
Xihx_2_39 a_xp2 a_xn2 wp_ih_2_39 wn_ih_2_39 xhp39 xhn39 vdd vbsyn gsyn
Xn39 xhp39 xhn39 ahp39 ahn39 vdd vbneu dneuron
Xcm_xh40 xhp40 xhn40 vdd cmld
Rnd_xh40 xhp40 xhn40 20k
Cxh40p xhp40 0 1e-13
Cxh40n xhn40 0 1e-13
Xihx_0_40 a_xp0 a_xn0 wp_ih_0_40 wn_ih_0_40 xhp40 xhn40 vdd vbsyn gsyn
Xihx_1_40 a_xp1 a_xn1 wp_ih_1_40 wn_ih_1_40 xhp40 xhn40 vdd vbsyn gsyn
Xihx_2_40 a_xp2 a_xn2 wp_ih_2_40 wn_ih_2_40 xhp40 xhn40 vdd vbsyn gsyn
Xn40 xhp40 xhn40 ahp40 ahn40 vdd vbneu dneuron
Xcm_xh41 xhp41 xhn41 vdd cmld
Rnd_xh41 xhp41 xhn41 20k
Cxh41p xhp41 0 1e-13
Cxh41n xhn41 0 1e-13
Xihx_0_41 a_xp0 a_xn0 wp_ih_0_41 wn_ih_0_41 xhp41 xhn41 vdd vbsyn gsyn
Xihx_1_41 a_xp1 a_xn1 wp_ih_1_41 wn_ih_1_41 xhp41 xhn41 vdd vbsyn gsyn
Xihx_2_41 a_xp2 a_xn2 wp_ih_2_41 wn_ih_2_41 xhp41 xhn41 vdd vbsyn gsyn
Xn41 xhp41 xhn41 ahp41 ahn41 vdd vbneu dneuron
Xcm_xh42 xhp42 xhn42 vdd cmld
Rnd_xh42 xhp42 xhn42 20k
Cxh42p xhp42 0 1e-13
Cxh42n xhn42 0 1e-13
Xihx_0_42 a_xp0 a_xn0 wp_ih_0_42 wn_ih_0_42 xhp42 xhn42 vdd vbsyn gsyn
Xihx_1_42 a_xp1 a_xn1 wp_ih_1_42 wn_ih_1_42 xhp42 xhn42 vdd vbsyn gsyn
Xihx_2_42 a_xp2 a_xn2 wp_ih_2_42 wn_ih_2_42 xhp42 xhn42 vdd vbsyn gsyn
Xn42 xhp42 xhn42 ahp42 ahn42 vdd vbneu dneuron
Xcm_xh43 xhp43 xhn43 vdd cmld
Rnd_xh43 xhp43 xhn43 20k
Cxh43p xhp43 0 1e-13
Cxh43n xhn43 0 1e-13
Xihx_0_43 a_xp0 a_xn0 wp_ih_0_43 wn_ih_0_43 xhp43 xhn43 vdd vbsyn gsyn
Xihx_1_43 a_xp1 a_xn1 wp_ih_1_43 wn_ih_1_43 xhp43 xhn43 vdd vbsyn gsyn
Xihx_2_43 a_xp2 a_xn2 wp_ih_2_43 wn_ih_2_43 xhp43 xhn43 vdd vbsyn gsyn
Xn43 xhp43 xhn43 ahp43 ahn43 vdd vbneu dneuron
Xcm_xh44 xhp44 xhn44 vdd cmld
Rnd_xh44 xhp44 xhn44 20k
Cxh44p xhp44 0 1e-13
Cxh44n xhn44 0 1e-13
Xihx_0_44 a_xp0 a_xn0 wp_ih_0_44 wn_ih_0_44 xhp44 xhn44 vdd vbsyn gsyn
Xihx_1_44 a_xp1 a_xn1 wp_ih_1_44 wn_ih_1_44 xhp44 xhn44 vdd vbsyn gsyn
Xihx_2_44 a_xp2 a_xn2 wp_ih_2_44 wn_ih_2_44 xhp44 xhn44 vdd vbsyn gsyn
Xn44 xhp44 xhn44 ahp44 ahn44 vdd vbneu dneuron
Xcm_xh45 xhp45 xhn45 vdd cmld
Rnd_xh45 xhp45 xhn45 20k
Cxh45p xhp45 0 1e-13
Cxh45n xhn45 0 1e-13
Xihx_0_45 a_xp0 a_xn0 wp_ih_0_45 wn_ih_0_45 xhp45 xhn45 vdd vbsyn gsyn
Xihx_1_45 a_xp1 a_xn1 wp_ih_1_45 wn_ih_1_45 xhp45 xhn45 vdd vbsyn gsyn
Xihx_2_45 a_xp2 a_xn2 wp_ih_2_45 wn_ih_2_45 xhp45 xhn45 vdd vbsyn gsyn
Xn45 xhp45 xhn45 ahp45 ahn45 vdd vbneu dneuron
Xcm_xh46 xhp46 xhn46 vdd cmld
Rnd_xh46 xhp46 xhn46 20k
Cxh46p xhp46 0 1e-13
Cxh46n xhn46 0 1e-13
Xihx_0_46 a_xp0 a_xn0 wp_ih_0_46 wn_ih_0_46 xhp46 xhn46 vdd vbsyn gsyn
Xihx_1_46 a_xp1 a_xn1 wp_ih_1_46 wn_ih_1_46 xhp46 xhn46 vdd vbsyn gsyn
Xihx_2_46 a_xp2 a_xn2 wp_ih_2_46 wn_ih_2_46 xhp46 xhn46 vdd vbsyn gsyn
Xn46 xhp46 xhn46 ahp46 ahn46 vdd vbneu dneuron
Xcm_xh47 xhp47 xhn47 vdd cmld
Rnd_xh47 xhp47 xhn47 20k
Cxh47p xhp47 0 1e-13
Cxh47n xhn47 0 1e-13
Xihx_0_47 a_xp0 a_xn0 wp_ih_0_47 wn_ih_0_47 xhp47 xhn47 vdd vbsyn gsyn
Xihx_1_47 a_xp1 a_xn1 wp_ih_1_47 wn_ih_1_47 xhp47 xhn47 vdd vbsyn gsyn
Xihx_2_47 a_xp2 a_xn2 wp_ih_2_47 wn_ih_2_47 xhp47 xhn47 vdd vbsyn gsyn
Xn47 xhp47 xhn47 ahp47 ahn47 vdd vbneu dneuron
Xcm_xh48 xhp48 xhn48 vdd cmld
Rnd_xh48 xhp48 xhn48 20k
Cxh48p xhp48 0 1e-13
Cxh48n xhn48 0 1e-13
Xihx_0_48 a_xp0 a_xn0 wp_ih_0_48 wn_ih_0_48 xhp48 xhn48 vdd vbsyn gsyn
Xihx_1_48 a_xp1 a_xn1 wp_ih_1_48 wn_ih_1_48 xhp48 xhn48 vdd vbsyn gsyn
Xihx_2_48 a_xp2 a_xn2 wp_ih_2_48 wn_ih_2_48 xhp48 xhn48 vdd vbsyn gsyn
Xn48 xhp48 xhn48 ahp48 ahn48 vdd vbneu dneuron
Xcm_xh49 xhp49 xhn49 vdd cmld
Rnd_xh49 xhp49 xhn49 20k
Cxh49p xhp49 0 1e-13
Cxh49n xhn49 0 1e-13
Xihx_0_49 a_xp0 a_xn0 wp_ih_0_49 wn_ih_0_49 xhp49 xhn49 vdd vbsyn gsyn
Xihx_1_49 a_xp1 a_xn1 wp_ih_1_49 wn_ih_1_49 xhp49 xhn49 vdd vbsyn gsyn
Xihx_2_49 a_xp2 a_xn2 wp_ih_2_49 wn_ih_2_49 xhp49 xhn49 vdd vbsyn gsyn
Xn49 xhp49 xhn49 ahp49 ahn49 vdd vbneu dneuron
Xcm_xh50 xhp50 xhn50 vdd cmld
Rnd_xh50 xhp50 xhn50 20k
Cxh50p xhp50 0 1e-13
Cxh50n xhn50 0 1e-13
Xihx_0_50 a_xp0 a_xn0 wp_ih_0_50 wn_ih_0_50 xhp50 xhn50 vdd vbsyn gsyn
Xihx_1_50 a_xp1 a_xn1 wp_ih_1_50 wn_ih_1_50 xhp50 xhn50 vdd vbsyn gsyn
Xihx_2_50 a_xp2 a_xn2 wp_ih_2_50 wn_ih_2_50 xhp50 xhn50 vdd vbsyn gsyn
Xn50 xhp50 xhn50 ahp50 ahn50 vdd vbneu dneuron
Xcm_xh51 xhp51 xhn51 vdd cmld
Rnd_xh51 xhp51 xhn51 20k
Cxh51p xhp51 0 1e-13
Cxh51n xhn51 0 1e-13
Xihx_0_51 a_xp0 a_xn0 wp_ih_0_51 wn_ih_0_51 xhp51 xhn51 vdd vbsyn gsyn
Xihx_1_51 a_xp1 a_xn1 wp_ih_1_51 wn_ih_1_51 xhp51 xhn51 vdd vbsyn gsyn
Xihx_2_51 a_xp2 a_xn2 wp_ih_2_51 wn_ih_2_51 xhp51 xhn51 vdd vbsyn gsyn
Xn51 xhp51 xhn51 ahp51 ahn51 vdd vbneu dneuron
Xcm_xh52 xhp52 xhn52 vdd cmld
Rnd_xh52 xhp52 xhn52 20k
Cxh52p xhp52 0 1e-13
Cxh52n xhn52 0 1e-13
Xihx_0_52 a_xp0 a_xn0 wp_ih_0_52 wn_ih_0_52 xhp52 xhn52 vdd vbsyn gsyn
Xihx_1_52 a_xp1 a_xn1 wp_ih_1_52 wn_ih_1_52 xhp52 xhn52 vdd vbsyn gsyn
Xihx_2_52 a_xp2 a_xn2 wp_ih_2_52 wn_ih_2_52 xhp52 xhn52 vdd vbsyn gsyn
Xn52 xhp52 xhn52 ahp52 ahn52 vdd vbneu dneuron
Xcm_xh53 xhp53 xhn53 vdd cmld
Rnd_xh53 xhp53 xhn53 20k
Cxh53p xhp53 0 1e-13
Cxh53n xhn53 0 1e-13
Xihx_0_53 a_xp0 a_xn0 wp_ih_0_53 wn_ih_0_53 xhp53 xhn53 vdd vbsyn gsyn
Xihx_1_53 a_xp1 a_xn1 wp_ih_1_53 wn_ih_1_53 xhp53 xhn53 vdd vbsyn gsyn
Xihx_2_53 a_xp2 a_xn2 wp_ih_2_53 wn_ih_2_53 xhp53 xhn53 vdd vbsyn gsyn
Xn53 xhp53 xhn53 ahp53 ahn53 vdd vbneu dneuron
Xcm_xh54 xhp54 xhn54 vdd cmld
Rnd_xh54 xhp54 xhn54 20k
Cxh54p xhp54 0 1e-13
Cxh54n xhn54 0 1e-13
Xihx_0_54 a_xp0 a_xn0 wp_ih_0_54 wn_ih_0_54 xhp54 xhn54 vdd vbsyn gsyn
Xihx_1_54 a_xp1 a_xn1 wp_ih_1_54 wn_ih_1_54 xhp54 xhn54 vdd vbsyn gsyn
Xihx_2_54 a_xp2 a_xn2 wp_ih_2_54 wn_ih_2_54 xhp54 xhn54 vdd vbsyn gsyn
Xn54 xhp54 xhn54 ahp54 ahn54 vdd vbneu dneuron
Xcm_xh55 xhp55 xhn55 vdd cmld
Rnd_xh55 xhp55 xhn55 20k
Cxh55p xhp55 0 1e-13
Cxh55n xhn55 0 1e-13
Xihx_0_55 a_xp0 a_xn0 wp_ih_0_55 wn_ih_0_55 xhp55 xhn55 vdd vbsyn gsyn
Xihx_1_55 a_xp1 a_xn1 wp_ih_1_55 wn_ih_1_55 xhp55 xhn55 vdd vbsyn gsyn
Xihx_2_55 a_xp2 a_xn2 wp_ih_2_55 wn_ih_2_55 xhp55 xhn55 vdd vbsyn gsyn
Xn55 xhp55 xhn55 ahp55 ahn55 vdd vbneu dneuron
Xcm_xh56 xhp56 xhn56 vdd cmld
Rnd_xh56 xhp56 xhn56 20k
Cxh56p xhp56 0 1e-13
Cxh56n xhn56 0 1e-13
Xihx_0_56 a_xp0 a_xn0 wp_ih_0_56 wn_ih_0_56 xhp56 xhn56 vdd vbsyn gsyn
Xihx_1_56 a_xp1 a_xn1 wp_ih_1_56 wn_ih_1_56 xhp56 xhn56 vdd vbsyn gsyn
Xihx_2_56 a_xp2 a_xn2 wp_ih_2_56 wn_ih_2_56 xhp56 xhn56 vdd vbsyn gsyn
Xn56 xhp56 xhn56 ahp56 ahn56 vdd vbneu dneuron
Xcm_xh57 xhp57 xhn57 vdd cmld
Rnd_xh57 xhp57 xhn57 20k
Cxh57p xhp57 0 1e-13
Cxh57n xhn57 0 1e-13
Xihx_0_57 a_xp0 a_xn0 wp_ih_0_57 wn_ih_0_57 xhp57 xhn57 vdd vbsyn gsyn
Xihx_1_57 a_xp1 a_xn1 wp_ih_1_57 wn_ih_1_57 xhp57 xhn57 vdd vbsyn gsyn
Xihx_2_57 a_xp2 a_xn2 wp_ih_2_57 wn_ih_2_57 xhp57 xhn57 vdd vbsyn gsyn
Xn57 xhp57 xhn57 ahp57 ahn57 vdd vbneu dneuron
Xcm_xh58 xhp58 xhn58 vdd cmld
Rnd_xh58 xhp58 xhn58 20k
Cxh58p xhp58 0 1e-13
Cxh58n xhn58 0 1e-13
Xihx_0_58 a_xp0 a_xn0 wp_ih_0_58 wn_ih_0_58 xhp58 xhn58 vdd vbsyn gsyn
Xihx_1_58 a_xp1 a_xn1 wp_ih_1_58 wn_ih_1_58 xhp58 xhn58 vdd vbsyn gsyn
Xihx_2_58 a_xp2 a_xn2 wp_ih_2_58 wn_ih_2_58 xhp58 xhn58 vdd vbsyn gsyn
Xn58 xhp58 xhn58 ahp58 ahn58 vdd vbneu dneuron
Xcm_xh59 xhp59 xhn59 vdd cmld
Rnd_xh59 xhp59 xhn59 20k
Cxh59p xhp59 0 1e-13
Cxh59n xhn59 0 1e-13
Xihx_0_59 a_xp0 a_xn0 wp_ih_0_59 wn_ih_0_59 xhp59 xhn59 vdd vbsyn gsyn
Xihx_1_59 a_xp1 a_xn1 wp_ih_1_59 wn_ih_1_59 xhp59 xhn59 vdd vbsyn gsyn
Xihx_2_59 a_xp2 a_xn2 wp_ih_2_59 wn_ih_2_59 xhp59 xhn59 vdd vbsyn gsyn
Xn59 xhp59 xhn59 ahp59 ahn59 vdd vbneu dneuron
Xcm_xh60 xhp60 xhn60 vdd cmld
Rnd_xh60 xhp60 xhn60 20k
Cxh60p xhp60 0 1e-13
Cxh60n xhn60 0 1e-13
Xihx_0_60 a_xp0 a_xn0 wp_ih_0_60 wn_ih_0_60 xhp60 xhn60 vdd vbsyn gsyn
Xihx_1_60 a_xp1 a_xn1 wp_ih_1_60 wn_ih_1_60 xhp60 xhn60 vdd vbsyn gsyn
Xihx_2_60 a_xp2 a_xn2 wp_ih_2_60 wn_ih_2_60 xhp60 xhn60 vdd vbsyn gsyn
Xn60 xhp60 xhn60 ahp60 ahn60 vdd vbneu dneuron
Xcm_xh61 xhp61 xhn61 vdd cmld
Rnd_xh61 xhp61 xhn61 20k
Cxh61p xhp61 0 1e-13
Cxh61n xhn61 0 1e-13
Xihx_0_61 a_xp0 a_xn0 wp_ih_0_61 wn_ih_0_61 xhp61 xhn61 vdd vbsyn gsyn
Xihx_1_61 a_xp1 a_xn1 wp_ih_1_61 wn_ih_1_61 xhp61 xhn61 vdd vbsyn gsyn
Xihx_2_61 a_xp2 a_xn2 wp_ih_2_61 wn_ih_2_61 xhp61 xhn61 vdd vbsyn gsyn
Xn61 xhp61 xhn61 ahp61 ahn61 vdd vbneu dneuron
Xcm_xh62 xhp62 xhn62 vdd cmld
Rnd_xh62 xhp62 xhn62 20k
Cxh62p xhp62 0 1e-13
Cxh62n xhn62 0 1e-13
Xihx_0_62 a_xp0 a_xn0 wp_ih_0_62 wn_ih_0_62 xhp62 xhn62 vdd vbsyn gsyn
Xihx_1_62 a_xp1 a_xn1 wp_ih_1_62 wn_ih_1_62 xhp62 xhn62 vdd vbsyn gsyn
Xihx_2_62 a_xp2 a_xn2 wp_ih_2_62 wn_ih_2_62 xhp62 xhn62 vdd vbsyn gsyn
Xn62 xhp62 xhn62 ahp62 ahn62 vdd vbneu dneuron
Xcm_xh63 xhp63 xhn63 vdd cmld
Rnd_xh63 xhp63 xhn63 20k
Cxh63p xhp63 0 1e-13
Cxh63n xhn63 0 1e-13
Xihx_0_63 a_xp0 a_xn0 wp_ih_0_63 wn_ih_0_63 xhp63 xhn63 vdd vbsyn gsyn
Xihx_1_63 a_xp1 a_xn1 wp_ih_1_63 wn_ih_1_63 xhp63 xhn63 vdd vbsyn gsyn
Xihx_2_63 a_xp2 a_xn2 wp_ih_2_63 wn_ih_2_63 xhp63 xhn63 vdd vbsyn gsyn
Xn63 xhp63 xhn63 ahp63 ahn63 vdd vbneu dneuron
Xcm_xh64 xhp64 xhn64 vdd cmld
Rnd_xh64 xhp64 xhn64 20k
Cxh64p xhp64 0 1e-13
Cxh64n xhn64 0 1e-13
Xihx_0_64 a_xp0 a_xn0 wp_ih_0_64 wn_ih_0_64 xhp64 xhn64 vdd vbsyn gsyn
Xihx_1_64 a_xp1 a_xn1 wp_ih_1_64 wn_ih_1_64 xhp64 xhn64 vdd vbsyn gsyn
Xihx_2_64 a_xp2 a_xn2 wp_ih_2_64 wn_ih_2_64 xhp64 xhn64 vdd vbsyn gsyn
Xn64 xhp64 xhn64 ahp64 ahn64 vdd vbneu dneuron
Xcm_xh65 xhp65 xhn65 vdd cmld
Rnd_xh65 xhp65 xhn65 20k
Cxh65p xhp65 0 1e-13
Cxh65n xhn65 0 1e-13
Xihx_0_65 a_xp0 a_xn0 wp_ih_0_65 wn_ih_0_65 xhp65 xhn65 vdd vbsyn gsyn
Xihx_1_65 a_xp1 a_xn1 wp_ih_1_65 wn_ih_1_65 xhp65 xhn65 vdd vbsyn gsyn
Xihx_2_65 a_xp2 a_xn2 wp_ih_2_65 wn_ih_2_65 xhp65 xhn65 vdd vbsyn gsyn
Xn65 xhp65 xhn65 ahp65 ahn65 vdd vbneu dneuron
Xcm_xh66 xhp66 xhn66 vdd cmld
Rnd_xh66 xhp66 xhn66 20k
Cxh66p xhp66 0 1e-13
Cxh66n xhn66 0 1e-13
Xihx_0_66 a_xp0 a_xn0 wp_ih_0_66 wn_ih_0_66 xhp66 xhn66 vdd vbsyn gsyn
Xihx_1_66 a_xp1 a_xn1 wp_ih_1_66 wn_ih_1_66 xhp66 xhn66 vdd vbsyn gsyn
Xihx_2_66 a_xp2 a_xn2 wp_ih_2_66 wn_ih_2_66 xhp66 xhn66 vdd vbsyn gsyn
Xn66 xhp66 xhn66 ahp66 ahn66 vdd vbneu dneuron
Xcm_xh67 xhp67 xhn67 vdd cmld
Rnd_xh67 xhp67 xhn67 20k
Cxh67p xhp67 0 1e-13
Cxh67n xhn67 0 1e-13
Xihx_0_67 a_xp0 a_xn0 wp_ih_0_67 wn_ih_0_67 xhp67 xhn67 vdd vbsyn gsyn
Xihx_1_67 a_xp1 a_xn1 wp_ih_1_67 wn_ih_1_67 xhp67 xhn67 vdd vbsyn gsyn
Xihx_2_67 a_xp2 a_xn2 wp_ih_2_67 wn_ih_2_67 xhp67 xhn67 vdd vbsyn gsyn
Xn67 xhp67 xhn67 ahp67 ahn67 vdd vbneu dneuron
Xcm_xh68 xhp68 xhn68 vdd cmld
Rnd_xh68 xhp68 xhn68 20k
Cxh68p xhp68 0 1e-13
Cxh68n xhn68 0 1e-13
Xihx_0_68 a_xp0 a_xn0 wp_ih_0_68 wn_ih_0_68 xhp68 xhn68 vdd vbsyn gsyn
Xihx_1_68 a_xp1 a_xn1 wp_ih_1_68 wn_ih_1_68 xhp68 xhn68 vdd vbsyn gsyn
Xihx_2_68 a_xp2 a_xn2 wp_ih_2_68 wn_ih_2_68 xhp68 xhn68 vdd vbsyn gsyn
Xn68 xhp68 xhn68 ahp68 ahn68 vdd vbneu dneuron
Xcm_xh69 xhp69 xhn69 vdd cmld
Rnd_xh69 xhp69 xhn69 20k
Cxh69p xhp69 0 1e-13
Cxh69n xhn69 0 1e-13
Xihx_0_69 a_xp0 a_xn0 wp_ih_0_69 wn_ih_0_69 xhp69 xhn69 vdd vbsyn gsyn
Xihx_1_69 a_xp1 a_xn1 wp_ih_1_69 wn_ih_1_69 xhp69 xhn69 vdd vbsyn gsyn
Xihx_2_69 a_xp2 a_xn2 wp_ih_2_69 wn_ih_2_69 xhp69 xhn69 vdd vbsyn gsyn
Xn69 xhp69 xhn69 ahp69 ahn69 vdd vbneu dneuron
Xcm_xh70 xhp70 xhn70 vdd cmld
Rnd_xh70 xhp70 xhn70 20k
Cxh70p xhp70 0 1e-13
Cxh70n xhn70 0 1e-13
Xihx_0_70 a_xp0 a_xn0 wp_ih_0_70 wn_ih_0_70 xhp70 xhn70 vdd vbsyn gsyn
Xihx_1_70 a_xp1 a_xn1 wp_ih_1_70 wn_ih_1_70 xhp70 xhn70 vdd vbsyn gsyn
Xihx_2_70 a_xp2 a_xn2 wp_ih_2_70 wn_ih_2_70 xhp70 xhn70 vdd vbsyn gsyn
Xn70 xhp70 xhn70 ahp70 ahn70 vdd vbneu dneuron
Xcm_xh71 xhp71 xhn71 vdd cmld
Rnd_xh71 xhp71 xhn71 20k
Cxh71p xhp71 0 1e-13
Cxh71n xhn71 0 1e-13
Xihx_0_71 a_xp0 a_xn0 wp_ih_0_71 wn_ih_0_71 xhp71 xhn71 vdd vbsyn gsyn
Xihx_1_71 a_xp1 a_xn1 wp_ih_1_71 wn_ih_1_71 xhp71 xhn71 vdd vbsyn gsyn
Xihx_2_71 a_xp2 a_xn2 wp_ih_2_71 wn_ih_2_71 xhp71 xhn71 vdd vbsyn gsyn
Xn71 xhp71 xhn71 ahp71 ahn71 vdd vbneu dneuron
Xcm_xh72 xhp72 xhn72 vdd cmld
Rnd_xh72 xhp72 xhn72 20k
Cxh72p xhp72 0 1e-13
Cxh72n xhn72 0 1e-13
Xihx_0_72 a_xp0 a_xn0 wp_ih_0_72 wn_ih_0_72 xhp72 xhn72 vdd vbsyn gsyn
Xihx_1_72 a_xp1 a_xn1 wp_ih_1_72 wn_ih_1_72 xhp72 xhn72 vdd vbsyn gsyn
Xihx_2_72 a_xp2 a_xn2 wp_ih_2_72 wn_ih_2_72 xhp72 xhn72 vdd vbsyn gsyn
Xn72 xhp72 xhn72 ahp72 ahn72 vdd vbneu dneuron
Xcm_xh73 xhp73 xhn73 vdd cmld
Rnd_xh73 xhp73 xhn73 20k
Cxh73p xhp73 0 1e-13
Cxh73n xhn73 0 1e-13
Xihx_0_73 a_xp0 a_xn0 wp_ih_0_73 wn_ih_0_73 xhp73 xhn73 vdd vbsyn gsyn
Xihx_1_73 a_xp1 a_xn1 wp_ih_1_73 wn_ih_1_73 xhp73 xhn73 vdd vbsyn gsyn
Xihx_2_73 a_xp2 a_xn2 wp_ih_2_73 wn_ih_2_73 xhp73 xhn73 vdd vbsyn gsyn
Xn73 xhp73 xhn73 ahp73 ahn73 vdd vbneu dneuron
Xcm_xh74 xhp74 xhn74 vdd cmld
Rnd_xh74 xhp74 xhn74 20k
Cxh74p xhp74 0 1e-13
Cxh74n xhn74 0 1e-13
Xihx_0_74 a_xp0 a_xn0 wp_ih_0_74 wn_ih_0_74 xhp74 xhn74 vdd vbsyn gsyn
Xihx_1_74 a_xp1 a_xn1 wp_ih_1_74 wn_ih_1_74 xhp74 xhn74 vdd vbsyn gsyn
Xihx_2_74 a_xp2 a_xn2 wp_ih_2_74 wn_ih_2_74 xhp74 xhn74 vdd vbsyn gsyn
Xn74 xhp74 xhn74 ahp74 ahn74 vdd vbneu dneuron
Xcm_xh75 xhp75 xhn75 vdd cmld
Rnd_xh75 xhp75 xhn75 20k
Cxh75p xhp75 0 1e-13
Cxh75n xhn75 0 1e-13
Xihx_0_75 a_xp0 a_xn0 wp_ih_0_75 wn_ih_0_75 xhp75 xhn75 vdd vbsyn gsyn
Xihx_1_75 a_xp1 a_xn1 wp_ih_1_75 wn_ih_1_75 xhp75 xhn75 vdd vbsyn gsyn
Xihx_2_75 a_xp2 a_xn2 wp_ih_2_75 wn_ih_2_75 xhp75 xhn75 vdd vbsyn gsyn
Xn75 xhp75 xhn75 ahp75 ahn75 vdd vbneu dneuron
Xcm_xh76 xhp76 xhn76 vdd cmld
Rnd_xh76 xhp76 xhn76 20k
Cxh76p xhp76 0 1e-13
Cxh76n xhn76 0 1e-13
Xihx_0_76 a_xp0 a_xn0 wp_ih_0_76 wn_ih_0_76 xhp76 xhn76 vdd vbsyn gsyn
Xihx_1_76 a_xp1 a_xn1 wp_ih_1_76 wn_ih_1_76 xhp76 xhn76 vdd vbsyn gsyn
Xihx_2_76 a_xp2 a_xn2 wp_ih_2_76 wn_ih_2_76 xhp76 xhn76 vdd vbsyn gsyn
Xn76 xhp76 xhn76 ahp76 ahn76 vdd vbneu dneuron
Xcm_xh77 xhp77 xhn77 vdd cmld
Rnd_xh77 xhp77 xhn77 20k
Cxh77p xhp77 0 1e-13
Cxh77n xhn77 0 1e-13
Xihx_0_77 a_xp0 a_xn0 wp_ih_0_77 wn_ih_0_77 xhp77 xhn77 vdd vbsyn gsyn
Xihx_1_77 a_xp1 a_xn1 wp_ih_1_77 wn_ih_1_77 xhp77 xhn77 vdd vbsyn gsyn
Xihx_2_77 a_xp2 a_xn2 wp_ih_2_77 wn_ih_2_77 xhp77 xhn77 vdd vbsyn gsyn
Xn77 xhp77 xhn77 ahp77 ahn77 vdd vbneu dneuron
Xcm_xh78 xhp78 xhn78 vdd cmld
Rnd_xh78 xhp78 xhn78 20k
Cxh78p xhp78 0 1e-13
Cxh78n xhn78 0 1e-13
Xihx_0_78 a_xp0 a_xn0 wp_ih_0_78 wn_ih_0_78 xhp78 xhn78 vdd vbsyn gsyn
Xihx_1_78 a_xp1 a_xn1 wp_ih_1_78 wn_ih_1_78 xhp78 xhn78 vdd vbsyn gsyn
Xihx_2_78 a_xp2 a_xn2 wp_ih_2_78 wn_ih_2_78 xhp78 xhn78 vdd vbsyn gsyn
Xn78 xhp78 xhn78 ahp78 ahn78 vdd vbneu dneuron
Xcm_xh79 xhp79 xhn79 vdd cmld
Rnd_xh79 xhp79 xhn79 20k
Cxh79p xhp79 0 1e-13
Cxh79n xhn79 0 1e-13
Xihx_0_79 a_xp0 a_xn0 wp_ih_0_79 wn_ih_0_79 xhp79 xhn79 vdd vbsyn gsyn
Xihx_1_79 a_xp1 a_xn1 wp_ih_1_79 wn_ih_1_79 xhp79 xhn79 vdd vbsyn gsyn
Xihx_2_79 a_xp2 a_xn2 wp_ih_2_79 wn_ih_2_79 xhp79 xhn79 vdd vbsyn gsyn
Xn79 xhp79 xhn79 ahp79 ahn79 vdd vbneu dneuron
Xcm_xh80 xhp80 xhn80 vdd cmld
Rnd_xh80 xhp80 xhn80 20k
Cxh80p xhp80 0 1e-13
Cxh80n xhn80 0 1e-13
Xihx_0_80 a_xp0 a_xn0 wp_ih_0_80 wn_ih_0_80 xhp80 xhn80 vdd vbsyn gsyn
Xihx_1_80 a_xp1 a_xn1 wp_ih_1_80 wn_ih_1_80 xhp80 xhn80 vdd vbsyn gsyn
Xihx_2_80 a_xp2 a_xn2 wp_ih_2_80 wn_ih_2_80 xhp80 xhn80 vdd vbsyn gsyn
Xn80 xhp80 xhn80 ahp80 ahn80 vdd vbneu dneuron
Xcm_xh81 xhp81 xhn81 vdd cmld
Rnd_xh81 xhp81 xhn81 20k
Cxh81p xhp81 0 1e-13
Cxh81n xhn81 0 1e-13
Xihx_0_81 a_xp0 a_xn0 wp_ih_0_81 wn_ih_0_81 xhp81 xhn81 vdd vbsyn gsyn
Xihx_1_81 a_xp1 a_xn1 wp_ih_1_81 wn_ih_1_81 xhp81 xhn81 vdd vbsyn gsyn
Xihx_2_81 a_xp2 a_xn2 wp_ih_2_81 wn_ih_2_81 xhp81 xhn81 vdd vbsyn gsyn
Xn81 xhp81 xhn81 ahp81 ahn81 vdd vbneu dneuron
Xcm_xh82 xhp82 xhn82 vdd cmld
Rnd_xh82 xhp82 xhn82 20k
Cxh82p xhp82 0 1e-13
Cxh82n xhn82 0 1e-13
Xihx_0_82 a_xp0 a_xn0 wp_ih_0_82 wn_ih_0_82 xhp82 xhn82 vdd vbsyn gsyn
Xihx_1_82 a_xp1 a_xn1 wp_ih_1_82 wn_ih_1_82 xhp82 xhn82 vdd vbsyn gsyn
Xihx_2_82 a_xp2 a_xn2 wp_ih_2_82 wn_ih_2_82 xhp82 xhn82 vdd vbsyn gsyn
Xn82 xhp82 xhn82 ahp82 ahn82 vdd vbneu dneuron
Xcm_xh83 xhp83 xhn83 vdd cmld
Rnd_xh83 xhp83 xhn83 20k
Cxh83p xhp83 0 1e-13
Cxh83n xhn83 0 1e-13
Xihx_0_83 a_xp0 a_xn0 wp_ih_0_83 wn_ih_0_83 xhp83 xhn83 vdd vbsyn gsyn
Xihx_1_83 a_xp1 a_xn1 wp_ih_1_83 wn_ih_1_83 xhp83 xhn83 vdd vbsyn gsyn
Xihx_2_83 a_xp2 a_xn2 wp_ih_2_83 wn_ih_2_83 xhp83 xhn83 vdd vbsyn gsyn
Xn83 xhp83 xhn83 ahp83 ahn83 vdd vbneu dneuron
Xcm_xh84 xhp84 xhn84 vdd cmld
Rnd_xh84 xhp84 xhn84 20k
Cxh84p xhp84 0 1e-13
Cxh84n xhn84 0 1e-13
Xihx_0_84 a_xp0 a_xn0 wp_ih_0_84 wn_ih_0_84 xhp84 xhn84 vdd vbsyn gsyn
Xihx_1_84 a_xp1 a_xn1 wp_ih_1_84 wn_ih_1_84 xhp84 xhn84 vdd vbsyn gsyn
Xihx_2_84 a_xp2 a_xn2 wp_ih_2_84 wn_ih_2_84 xhp84 xhn84 vdd vbsyn gsyn
Xn84 xhp84 xhn84 ahp84 ahn84 vdd vbneu dneuron
Xcm_xh85 xhp85 xhn85 vdd cmld
Rnd_xh85 xhp85 xhn85 20k
Cxh85p xhp85 0 1e-13
Cxh85n xhn85 0 1e-13
Xihx_0_85 a_xp0 a_xn0 wp_ih_0_85 wn_ih_0_85 xhp85 xhn85 vdd vbsyn gsyn
Xihx_1_85 a_xp1 a_xn1 wp_ih_1_85 wn_ih_1_85 xhp85 xhn85 vdd vbsyn gsyn
Xihx_2_85 a_xp2 a_xn2 wp_ih_2_85 wn_ih_2_85 xhp85 xhn85 vdd vbsyn gsyn
Xn85 xhp85 xhn85 ahp85 ahn85 vdd vbneu dneuron
Xcm_xh86 xhp86 xhn86 vdd cmld
Rnd_xh86 xhp86 xhn86 20k
Cxh86p xhp86 0 1e-13
Cxh86n xhn86 0 1e-13
Xihx_0_86 a_xp0 a_xn0 wp_ih_0_86 wn_ih_0_86 xhp86 xhn86 vdd vbsyn gsyn
Xihx_1_86 a_xp1 a_xn1 wp_ih_1_86 wn_ih_1_86 xhp86 xhn86 vdd vbsyn gsyn
Xihx_2_86 a_xp2 a_xn2 wp_ih_2_86 wn_ih_2_86 xhp86 xhn86 vdd vbsyn gsyn
Xn86 xhp86 xhn86 ahp86 ahn86 vdd vbneu dneuron
Xcm_xh87 xhp87 xhn87 vdd cmld
Rnd_xh87 xhp87 xhn87 20k
Cxh87p xhp87 0 1e-13
Cxh87n xhn87 0 1e-13
Xihx_0_87 a_xp0 a_xn0 wp_ih_0_87 wn_ih_0_87 xhp87 xhn87 vdd vbsyn gsyn
Xihx_1_87 a_xp1 a_xn1 wp_ih_1_87 wn_ih_1_87 xhp87 xhn87 vdd vbsyn gsyn
Xihx_2_87 a_xp2 a_xn2 wp_ih_2_87 wn_ih_2_87 xhp87 xhn87 vdd vbsyn gsyn
Xn87 xhp87 xhn87 ahp87 ahn87 vdd vbneu dneuron
Xcm_xh88 xhp88 xhn88 vdd cmld
Rnd_xh88 xhp88 xhn88 20k
Cxh88p xhp88 0 1e-13
Cxh88n xhn88 0 1e-13
Xihx_0_88 a_xp0 a_xn0 wp_ih_0_88 wn_ih_0_88 xhp88 xhn88 vdd vbsyn gsyn
Xihx_1_88 a_xp1 a_xn1 wp_ih_1_88 wn_ih_1_88 xhp88 xhn88 vdd vbsyn gsyn
Xihx_2_88 a_xp2 a_xn2 wp_ih_2_88 wn_ih_2_88 xhp88 xhn88 vdd vbsyn gsyn
Xn88 xhp88 xhn88 ahp88 ahn88 vdd vbneu dneuron
Xcm_xh89 xhp89 xhn89 vdd cmld
Rnd_xh89 xhp89 xhn89 20k
Cxh89p xhp89 0 1e-13
Cxh89n xhn89 0 1e-13
Xihx_0_89 a_xp0 a_xn0 wp_ih_0_89 wn_ih_0_89 xhp89 xhn89 vdd vbsyn gsyn
Xihx_1_89 a_xp1 a_xn1 wp_ih_1_89 wn_ih_1_89 xhp89 xhn89 vdd vbsyn gsyn
Xihx_2_89 a_xp2 a_xn2 wp_ih_2_89 wn_ih_2_89 xhp89 xhn89 vdd vbsyn gsyn
Xn89 xhp89 xhn89 ahp89 ahn89 vdd vbneu dneuron
Xcm_xh90 xhp90 xhn90 vdd cmld
Rnd_xh90 xhp90 xhn90 20k
Cxh90p xhp90 0 1e-13
Cxh90n xhn90 0 1e-13
Xihx_0_90 a_xp0 a_xn0 wp_ih_0_90 wn_ih_0_90 xhp90 xhn90 vdd vbsyn gsyn
Xihx_1_90 a_xp1 a_xn1 wp_ih_1_90 wn_ih_1_90 xhp90 xhn90 vdd vbsyn gsyn
Xihx_2_90 a_xp2 a_xn2 wp_ih_2_90 wn_ih_2_90 xhp90 xhn90 vdd vbsyn gsyn
Xn90 xhp90 xhn90 ahp90 ahn90 vdd vbneu dneuron
Xcm_xh91 xhp91 xhn91 vdd cmld
Rnd_xh91 xhp91 xhn91 20k
Cxh91p xhp91 0 1e-13
Cxh91n xhn91 0 1e-13
Xihx_0_91 a_xp0 a_xn0 wp_ih_0_91 wn_ih_0_91 xhp91 xhn91 vdd vbsyn gsyn
Xihx_1_91 a_xp1 a_xn1 wp_ih_1_91 wn_ih_1_91 xhp91 xhn91 vdd vbsyn gsyn
Xihx_2_91 a_xp2 a_xn2 wp_ih_2_91 wn_ih_2_91 xhp91 xhn91 vdd vbsyn gsyn
Xn91 xhp91 xhn91 ahp91 ahn91 vdd vbneu dneuron
Xcm_xh92 xhp92 xhn92 vdd cmld
Rnd_xh92 xhp92 xhn92 20k
Cxh92p xhp92 0 1e-13
Cxh92n xhn92 0 1e-13
Xihx_0_92 a_xp0 a_xn0 wp_ih_0_92 wn_ih_0_92 xhp92 xhn92 vdd vbsyn gsyn
Xihx_1_92 a_xp1 a_xn1 wp_ih_1_92 wn_ih_1_92 xhp92 xhn92 vdd vbsyn gsyn
Xihx_2_92 a_xp2 a_xn2 wp_ih_2_92 wn_ih_2_92 xhp92 xhn92 vdd vbsyn gsyn
Xn92 xhp92 xhn92 ahp92 ahn92 vdd vbneu dneuron
Xcm_xh93 xhp93 xhn93 vdd cmld
Rnd_xh93 xhp93 xhn93 20k
Cxh93p xhp93 0 1e-13
Cxh93n xhn93 0 1e-13
Xihx_0_93 a_xp0 a_xn0 wp_ih_0_93 wn_ih_0_93 xhp93 xhn93 vdd vbsyn gsyn
Xihx_1_93 a_xp1 a_xn1 wp_ih_1_93 wn_ih_1_93 xhp93 xhn93 vdd vbsyn gsyn
Xihx_2_93 a_xp2 a_xn2 wp_ih_2_93 wn_ih_2_93 xhp93 xhn93 vdd vbsyn gsyn
Xn93 xhp93 xhn93 ahp93 ahn93 vdd vbneu dneuron
Xcm_xh94 xhp94 xhn94 vdd cmld
Rnd_xh94 xhp94 xhn94 20k
Cxh94p xhp94 0 1e-13
Cxh94n xhn94 0 1e-13
Xihx_0_94 a_xp0 a_xn0 wp_ih_0_94 wn_ih_0_94 xhp94 xhn94 vdd vbsyn gsyn
Xihx_1_94 a_xp1 a_xn1 wp_ih_1_94 wn_ih_1_94 xhp94 xhn94 vdd vbsyn gsyn
Xihx_2_94 a_xp2 a_xn2 wp_ih_2_94 wn_ih_2_94 xhp94 xhn94 vdd vbsyn gsyn
Xn94 xhp94 xhn94 ahp94 ahn94 vdd vbneu dneuron
Xcm_xh95 xhp95 xhn95 vdd cmld
Rnd_xh95 xhp95 xhn95 20k
Cxh95p xhp95 0 1e-13
Cxh95n xhn95 0 1e-13
Xihx_0_95 a_xp0 a_xn0 wp_ih_0_95 wn_ih_0_95 xhp95 xhn95 vdd vbsyn gsyn
Xihx_1_95 a_xp1 a_xn1 wp_ih_1_95 wn_ih_1_95 xhp95 xhn95 vdd vbsyn gsyn
Xihx_2_95 a_xp2 a_xn2 wp_ih_2_95 wn_ih_2_95 xhp95 xhn95 vdd vbsyn gsyn
Xn95 xhp95 xhn95 ahp95 ahn95 vdd vbneu dneuron
Xcm_xh96 xhp96 xhn96 vdd cmld
Rnd_xh96 xhp96 xhn96 20k
Cxh96p xhp96 0 1e-13
Cxh96n xhn96 0 1e-13
Xihx_0_96 a_xp0 a_xn0 wp_ih_0_96 wn_ih_0_96 xhp96 xhn96 vdd vbsyn gsyn
Xihx_1_96 a_xp1 a_xn1 wp_ih_1_96 wn_ih_1_96 xhp96 xhn96 vdd vbsyn gsyn
Xihx_2_96 a_xp2 a_xn2 wp_ih_2_96 wn_ih_2_96 xhp96 xhn96 vdd vbsyn gsyn
Xn96 xhp96 xhn96 ahp96 ahn96 vdd vbneu dneuron
Xcm_xh97 xhp97 xhn97 vdd cmld
Rnd_xh97 xhp97 xhn97 20k
Cxh97p xhp97 0 1e-13
Cxh97n xhn97 0 1e-13
Xihx_0_97 a_xp0 a_xn0 wp_ih_0_97 wn_ih_0_97 xhp97 xhn97 vdd vbsyn gsyn
Xihx_1_97 a_xp1 a_xn1 wp_ih_1_97 wn_ih_1_97 xhp97 xhn97 vdd vbsyn gsyn
Xihx_2_97 a_xp2 a_xn2 wp_ih_2_97 wn_ih_2_97 xhp97 xhn97 vdd vbsyn gsyn
Xn97 xhp97 xhn97 ahp97 ahn97 vdd vbneu dneuron
Xcm_xh98 xhp98 xhn98 vdd cmld
Rnd_xh98 xhp98 xhn98 20k
Cxh98p xhp98 0 1e-13
Cxh98n xhn98 0 1e-13
Xihx_0_98 a_xp0 a_xn0 wp_ih_0_98 wn_ih_0_98 xhp98 xhn98 vdd vbsyn gsyn
Xihx_1_98 a_xp1 a_xn1 wp_ih_1_98 wn_ih_1_98 xhp98 xhn98 vdd vbsyn gsyn
Xihx_2_98 a_xp2 a_xn2 wp_ih_2_98 wn_ih_2_98 xhp98 xhn98 vdd vbsyn gsyn
Xn98 xhp98 xhn98 ahp98 ahn98 vdd vbneu dneuron
Xcm_xh99 xhp99 xhn99 vdd cmld
Rnd_xh99 xhp99 xhn99 20k
Cxh99p xhp99 0 1e-13
Cxh99n xhn99 0 1e-13
Xihx_0_99 a_xp0 a_xn0 wp_ih_0_99 wn_ih_0_99 xhp99 xhn99 vdd vbsyn gsyn
Xihx_1_99 a_xp1 a_xn1 wp_ih_1_99 wn_ih_1_99 xhp99 xhn99 vdd vbsyn gsyn
Xihx_2_99 a_xp2 a_xn2 wp_ih_2_99 wn_ih_2_99 xhp99 xhn99 vdd vbsyn gsyn
Xn99 xhp99 xhn99 ahp99 ahn99 vdd vbneu dneuron
Xcm_xh100 xhp100 xhn100 vdd cmld
Rnd_xh100 xhp100 xhn100 20k
Cxh100p xhp100 0 1e-13
Cxh100n xhn100 0 1e-13
Xihx_0_100 a_xp0 a_xn0 wp_ih_0_100 wn_ih_0_100 xhp100 xhn100 vdd vbsyn gsyn
Xihx_1_100 a_xp1 a_xn1 wp_ih_1_100 wn_ih_1_100 xhp100 xhn100 vdd vbsyn gsyn
Xihx_2_100 a_xp2 a_xn2 wp_ih_2_100 wn_ih_2_100 xhp100 xhn100 vdd vbsyn gsyn
Xn100 xhp100 xhn100 ahp100 ahn100 vdd vbneu dneuron
Xcm_xh101 xhp101 xhn101 vdd cmld
Rnd_xh101 xhp101 xhn101 20k
Cxh101p xhp101 0 1e-13
Cxh101n xhn101 0 1e-13
Xihx_0_101 a_xp0 a_xn0 wp_ih_0_101 wn_ih_0_101 xhp101 xhn101 vdd vbsyn gsyn
Xihx_1_101 a_xp1 a_xn1 wp_ih_1_101 wn_ih_1_101 xhp101 xhn101 vdd vbsyn gsyn
Xihx_2_101 a_xp2 a_xn2 wp_ih_2_101 wn_ih_2_101 xhp101 xhn101 vdd vbsyn gsyn
Xn101 xhp101 xhn101 ahp101 ahn101 vdd vbneu dneuron
Xcm_xh102 xhp102 xhn102 vdd cmld
Rnd_xh102 xhp102 xhn102 20k
Cxh102p xhp102 0 1e-13
Cxh102n xhn102 0 1e-13
Xihx_0_102 a_xp0 a_xn0 wp_ih_0_102 wn_ih_0_102 xhp102 xhn102 vdd vbsyn gsyn
Xihx_1_102 a_xp1 a_xn1 wp_ih_1_102 wn_ih_1_102 xhp102 xhn102 vdd vbsyn gsyn
Xihx_2_102 a_xp2 a_xn2 wp_ih_2_102 wn_ih_2_102 xhp102 xhn102 vdd vbsyn gsyn
Xn102 xhp102 xhn102 ahp102 ahn102 vdd vbneu dneuron
Xcm_xh103 xhp103 xhn103 vdd cmld
Rnd_xh103 xhp103 xhn103 20k
Cxh103p xhp103 0 1e-13
Cxh103n xhn103 0 1e-13
Xihx_0_103 a_xp0 a_xn0 wp_ih_0_103 wn_ih_0_103 xhp103 xhn103 vdd vbsyn gsyn
Xihx_1_103 a_xp1 a_xn1 wp_ih_1_103 wn_ih_1_103 xhp103 xhn103 vdd vbsyn gsyn
Xihx_2_103 a_xp2 a_xn2 wp_ih_2_103 wn_ih_2_103 xhp103 xhn103 vdd vbsyn gsyn
Xn103 xhp103 xhn103 ahp103 ahn103 vdd vbneu dneuron
Xcm_xh104 xhp104 xhn104 vdd cmld
Rnd_xh104 xhp104 xhn104 20k
Cxh104p xhp104 0 1e-13
Cxh104n xhn104 0 1e-13
Xihx_0_104 a_xp0 a_xn0 wp_ih_0_104 wn_ih_0_104 xhp104 xhn104 vdd vbsyn gsyn
Xihx_1_104 a_xp1 a_xn1 wp_ih_1_104 wn_ih_1_104 xhp104 xhn104 vdd vbsyn gsyn
Xihx_2_104 a_xp2 a_xn2 wp_ih_2_104 wn_ih_2_104 xhp104 xhn104 vdd vbsyn gsyn
Xn104 xhp104 xhn104 ahp104 ahn104 vdd vbneu dneuron
Xcm_xh105 xhp105 xhn105 vdd cmld
Rnd_xh105 xhp105 xhn105 20k
Cxh105p xhp105 0 1e-13
Cxh105n xhn105 0 1e-13
Xihx_0_105 a_xp0 a_xn0 wp_ih_0_105 wn_ih_0_105 xhp105 xhn105 vdd vbsyn gsyn
Xihx_1_105 a_xp1 a_xn1 wp_ih_1_105 wn_ih_1_105 xhp105 xhn105 vdd vbsyn gsyn
Xihx_2_105 a_xp2 a_xn2 wp_ih_2_105 wn_ih_2_105 xhp105 xhn105 vdd vbsyn gsyn
Xn105 xhp105 xhn105 ahp105 ahn105 vdd vbneu dneuron
Xcm_xh106 xhp106 xhn106 vdd cmld
Rnd_xh106 xhp106 xhn106 20k
Cxh106p xhp106 0 1e-13
Cxh106n xhn106 0 1e-13
Xihx_0_106 a_xp0 a_xn0 wp_ih_0_106 wn_ih_0_106 xhp106 xhn106 vdd vbsyn gsyn
Xihx_1_106 a_xp1 a_xn1 wp_ih_1_106 wn_ih_1_106 xhp106 xhn106 vdd vbsyn gsyn
Xihx_2_106 a_xp2 a_xn2 wp_ih_2_106 wn_ih_2_106 xhp106 xhn106 vdd vbsyn gsyn
Xn106 xhp106 xhn106 ahp106 ahn106 vdd vbneu dneuron
Xcm_xh107 xhp107 xhn107 vdd cmld
Rnd_xh107 xhp107 xhn107 20k
Cxh107p xhp107 0 1e-13
Cxh107n xhn107 0 1e-13
Xihx_0_107 a_xp0 a_xn0 wp_ih_0_107 wn_ih_0_107 xhp107 xhn107 vdd vbsyn gsyn
Xihx_1_107 a_xp1 a_xn1 wp_ih_1_107 wn_ih_1_107 xhp107 xhn107 vdd vbsyn gsyn
Xihx_2_107 a_xp2 a_xn2 wp_ih_2_107 wn_ih_2_107 xhp107 xhn107 vdd vbsyn gsyn
Xn107 xhp107 xhn107 ahp107 ahn107 vdd vbneu dneuron
Xcm_xh108 xhp108 xhn108 vdd cmld
Rnd_xh108 xhp108 xhn108 20k
Cxh108p xhp108 0 1e-13
Cxh108n xhn108 0 1e-13
Xihx_0_108 a_xp0 a_xn0 wp_ih_0_108 wn_ih_0_108 xhp108 xhn108 vdd vbsyn gsyn
Xihx_1_108 a_xp1 a_xn1 wp_ih_1_108 wn_ih_1_108 xhp108 xhn108 vdd vbsyn gsyn
Xihx_2_108 a_xp2 a_xn2 wp_ih_2_108 wn_ih_2_108 xhp108 xhn108 vdd vbsyn gsyn
Xn108 xhp108 xhn108 ahp108 ahn108 vdd vbneu dneuron
Xcm_xh109 xhp109 xhn109 vdd cmld
Rnd_xh109 xhp109 xhn109 20k
Cxh109p xhp109 0 1e-13
Cxh109n xhn109 0 1e-13
Xihx_0_109 a_xp0 a_xn0 wp_ih_0_109 wn_ih_0_109 xhp109 xhn109 vdd vbsyn gsyn
Xihx_1_109 a_xp1 a_xn1 wp_ih_1_109 wn_ih_1_109 xhp109 xhn109 vdd vbsyn gsyn
Xihx_2_109 a_xp2 a_xn2 wp_ih_2_109 wn_ih_2_109 xhp109 xhn109 vdd vbsyn gsyn
Xn109 xhp109 xhn109 ahp109 ahn109 vdd vbneu dneuron
Xcm_xh110 xhp110 xhn110 vdd cmld
Rnd_xh110 xhp110 xhn110 20k
Cxh110p xhp110 0 1e-13
Cxh110n xhn110 0 1e-13
Xihx_0_110 a_xp0 a_xn0 wp_ih_0_110 wn_ih_0_110 xhp110 xhn110 vdd vbsyn gsyn
Xihx_1_110 a_xp1 a_xn1 wp_ih_1_110 wn_ih_1_110 xhp110 xhn110 vdd vbsyn gsyn
Xihx_2_110 a_xp2 a_xn2 wp_ih_2_110 wn_ih_2_110 xhp110 xhn110 vdd vbsyn gsyn
Xn110 xhp110 xhn110 ahp110 ahn110 vdd vbneu dneuron
Xcm_xh111 xhp111 xhn111 vdd cmld
Rnd_xh111 xhp111 xhn111 20k
Cxh111p xhp111 0 1e-13
Cxh111n xhn111 0 1e-13
Xihx_0_111 a_xp0 a_xn0 wp_ih_0_111 wn_ih_0_111 xhp111 xhn111 vdd vbsyn gsyn
Xihx_1_111 a_xp1 a_xn1 wp_ih_1_111 wn_ih_1_111 xhp111 xhn111 vdd vbsyn gsyn
Xihx_2_111 a_xp2 a_xn2 wp_ih_2_111 wn_ih_2_111 xhp111 xhn111 vdd vbsyn gsyn
Xn111 xhp111 xhn111 ahp111 ahn111 vdd vbneu dneuron
Xcm_xh112 xhp112 xhn112 vdd cmld
Rnd_xh112 xhp112 xhn112 20k
Cxh112p xhp112 0 1e-13
Cxh112n xhn112 0 1e-13
Xihx_0_112 a_xp0 a_xn0 wp_ih_0_112 wn_ih_0_112 xhp112 xhn112 vdd vbsyn gsyn
Xihx_1_112 a_xp1 a_xn1 wp_ih_1_112 wn_ih_1_112 xhp112 xhn112 vdd vbsyn gsyn
Xihx_2_112 a_xp2 a_xn2 wp_ih_2_112 wn_ih_2_112 xhp112 xhn112 vdd vbsyn gsyn
Xn112 xhp112 xhn112 ahp112 ahn112 vdd vbneu dneuron
Xcm_xh113 xhp113 xhn113 vdd cmld
Rnd_xh113 xhp113 xhn113 20k
Cxh113p xhp113 0 1e-13
Cxh113n xhn113 0 1e-13
Xihx_0_113 a_xp0 a_xn0 wp_ih_0_113 wn_ih_0_113 xhp113 xhn113 vdd vbsyn gsyn
Xihx_1_113 a_xp1 a_xn1 wp_ih_1_113 wn_ih_1_113 xhp113 xhn113 vdd vbsyn gsyn
Xihx_2_113 a_xp2 a_xn2 wp_ih_2_113 wn_ih_2_113 xhp113 xhn113 vdd vbsyn gsyn
Xn113 xhp113 xhn113 ahp113 ahn113 vdd vbneu dneuron
Xcm_xh114 xhp114 xhn114 vdd cmld
Rnd_xh114 xhp114 xhn114 20k
Cxh114p xhp114 0 1e-13
Cxh114n xhn114 0 1e-13
Xihx_0_114 a_xp0 a_xn0 wp_ih_0_114 wn_ih_0_114 xhp114 xhn114 vdd vbsyn gsyn
Xihx_1_114 a_xp1 a_xn1 wp_ih_1_114 wn_ih_1_114 xhp114 xhn114 vdd vbsyn gsyn
Xihx_2_114 a_xp2 a_xn2 wp_ih_2_114 wn_ih_2_114 xhp114 xhn114 vdd vbsyn gsyn
Xn114 xhp114 xhn114 ahp114 ahn114 vdd vbneu dneuron
Xcm_xh115 xhp115 xhn115 vdd cmld
Rnd_xh115 xhp115 xhn115 20k
Cxh115p xhp115 0 1e-13
Cxh115n xhn115 0 1e-13
Xihx_0_115 a_xp0 a_xn0 wp_ih_0_115 wn_ih_0_115 xhp115 xhn115 vdd vbsyn gsyn
Xihx_1_115 a_xp1 a_xn1 wp_ih_1_115 wn_ih_1_115 xhp115 xhn115 vdd vbsyn gsyn
Xihx_2_115 a_xp2 a_xn2 wp_ih_2_115 wn_ih_2_115 xhp115 xhn115 vdd vbsyn gsyn
Xn115 xhp115 xhn115 ahp115 ahn115 vdd vbneu dneuron
Xcm_xh116 xhp116 xhn116 vdd cmld
Rnd_xh116 xhp116 xhn116 20k
Cxh116p xhp116 0 1e-13
Cxh116n xhn116 0 1e-13
Xihx_0_116 a_xp0 a_xn0 wp_ih_0_116 wn_ih_0_116 xhp116 xhn116 vdd vbsyn gsyn
Xihx_1_116 a_xp1 a_xn1 wp_ih_1_116 wn_ih_1_116 xhp116 xhn116 vdd vbsyn gsyn
Xihx_2_116 a_xp2 a_xn2 wp_ih_2_116 wn_ih_2_116 xhp116 xhn116 vdd vbsyn gsyn
Xn116 xhp116 xhn116 ahp116 ahn116 vdd vbneu dneuron
Xcm_xh117 xhp117 xhn117 vdd cmld
Rnd_xh117 xhp117 xhn117 20k
Cxh117p xhp117 0 1e-13
Cxh117n xhn117 0 1e-13
Xihx_0_117 a_xp0 a_xn0 wp_ih_0_117 wn_ih_0_117 xhp117 xhn117 vdd vbsyn gsyn
Xihx_1_117 a_xp1 a_xn1 wp_ih_1_117 wn_ih_1_117 xhp117 xhn117 vdd vbsyn gsyn
Xihx_2_117 a_xp2 a_xn2 wp_ih_2_117 wn_ih_2_117 xhp117 xhn117 vdd vbsyn gsyn
Xn117 xhp117 xhn117 ahp117 ahn117 vdd vbneu dneuron
Xcm_xh118 xhp118 xhn118 vdd cmld
Rnd_xh118 xhp118 xhn118 20k
Cxh118p xhp118 0 1e-13
Cxh118n xhn118 0 1e-13
Xihx_0_118 a_xp0 a_xn0 wp_ih_0_118 wn_ih_0_118 xhp118 xhn118 vdd vbsyn gsyn
Xihx_1_118 a_xp1 a_xn1 wp_ih_1_118 wn_ih_1_118 xhp118 xhn118 vdd vbsyn gsyn
Xihx_2_118 a_xp2 a_xn2 wp_ih_2_118 wn_ih_2_118 xhp118 xhn118 vdd vbsyn gsyn
Xn118 xhp118 xhn118 ahp118 ahn118 vdd vbneu dneuron
Xcm_xh119 xhp119 xhn119 vdd cmld
Rnd_xh119 xhp119 xhn119 20k
Cxh119p xhp119 0 1e-13
Cxh119n xhn119 0 1e-13
Xihx_0_119 a_xp0 a_xn0 wp_ih_0_119 wn_ih_0_119 xhp119 xhn119 vdd vbsyn gsyn
Xihx_1_119 a_xp1 a_xn1 wp_ih_1_119 wn_ih_1_119 xhp119 xhn119 vdd vbsyn gsyn
Xihx_2_119 a_xp2 a_xn2 wp_ih_2_119 wn_ih_2_119 xhp119 xhn119 vdd vbsyn gsyn
Xn119 xhp119 xhn119 ahp119 ahn119 vdd vbneu dneuron
Xcm_xh120 xhp120 xhn120 vdd cmld
Rnd_xh120 xhp120 xhn120 20k
Cxh120p xhp120 0 1e-13
Cxh120n xhn120 0 1e-13
Xihx_0_120 a_xp0 a_xn0 wp_ih_0_120 wn_ih_0_120 xhp120 xhn120 vdd vbsyn gsyn
Xihx_1_120 a_xp1 a_xn1 wp_ih_1_120 wn_ih_1_120 xhp120 xhn120 vdd vbsyn gsyn
Xihx_2_120 a_xp2 a_xn2 wp_ih_2_120 wn_ih_2_120 xhp120 xhn120 vdd vbsyn gsyn
Xn120 xhp120 xhn120 ahp120 ahn120 vdd vbneu dneuron
Xcm_xh121 xhp121 xhn121 vdd cmld
Rnd_xh121 xhp121 xhn121 20k
Cxh121p xhp121 0 1e-13
Cxh121n xhn121 0 1e-13
Xihx_0_121 a_xp0 a_xn0 wp_ih_0_121 wn_ih_0_121 xhp121 xhn121 vdd vbsyn gsyn
Xihx_1_121 a_xp1 a_xn1 wp_ih_1_121 wn_ih_1_121 xhp121 xhn121 vdd vbsyn gsyn
Xihx_2_121 a_xp2 a_xn2 wp_ih_2_121 wn_ih_2_121 xhp121 xhn121 vdd vbsyn gsyn
Xn121 xhp121 xhn121 ahp121 ahn121 vdd vbneu dneuron
Xcm_xh122 xhp122 xhn122 vdd cmld
Rnd_xh122 xhp122 xhn122 20k
Cxh122p xhp122 0 1e-13
Cxh122n xhn122 0 1e-13
Xihx_0_122 a_xp0 a_xn0 wp_ih_0_122 wn_ih_0_122 xhp122 xhn122 vdd vbsyn gsyn
Xihx_1_122 a_xp1 a_xn1 wp_ih_1_122 wn_ih_1_122 xhp122 xhn122 vdd vbsyn gsyn
Xihx_2_122 a_xp2 a_xn2 wp_ih_2_122 wn_ih_2_122 xhp122 xhn122 vdd vbsyn gsyn
Xn122 xhp122 xhn122 ahp122 ahn122 vdd vbneu dneuron
Xcm_xh123 xhp123 xhn123 vdd cmld
Rnd_xh123 xhp123 xhn123 20k
Cxh123p xhp123 0 1e-13
Cxh123n xhn123 0 1e-13
Xihx_0_123 a_xp0 a_xn0 wp_ih_0_123 wn_ih_0_123 xhp123 xhn123 vdd vbsyn gsyn
Xihx_1_123 a_xp1 a_xn1 wp_ih_1_123 wn_ih_1_123 xhp123 xhn123 vdd vbsyn gsyn
Xihx_2_123 a_xp2 a_xn2 wp_ih_2_123 wn_ih_2_123 xhp123 xhn123 vdd vbsyn gsyn
Xn123 xhp123 xhn123 ahp123 ahn123 vdd vbneu dneuron
Xcm_xh124 xhp124 xhn124 vdd cmld
Rnd_xh124 xhp124 xhn124 20k
Cxh124p xhp124 0 1e-13
Cxh124n xhn124 0 1e-13
Xihx_0_124 a_xp0 a_xn0 wp_ih_0_124 wn_ih_0_124 xhp124 xhn124 vdd vbsyn gsyn
Xihx_1_124 a_xp1 a_xn1 wp_ih_1_124 wn_ih_1_124 xhp124 xhn124 vdd vbsyn gsyn
Xihx_2_124 a_xp2 a_xn2 wp_ih_2_124 wn_ih_2_124 xhp124 xhn124 vdd vbsyn gsyn
Xn124 xhp124 xhn124 ahp124 ahn124 vdd vbneu dneuron
Xcm_xh125 xhp125 xhn125 vdd cmld
Rnd_xh125 xhp125 xhn125 20k
Cxh125p xhp125 0 1e-13
Cxh125n xhn125 0 1e-13
Xihx_0_125 a_xp0 a_xn0 wp_ih_0_125 wn_ih_0_125 xhp125 xhn125 vdd vbsyn gsyn
Xihx_1_125 a_xp1 a_xn1 wp_ih_1_125 wn_ih_1_125 xhp125 xhn125 vdd vbsyn gsyn
Xihx_2_125 a_xp2 a_xn2 wp_ih_2_125 wn_ih_2_125 xhp125 xhn125 vdd vbsyn gsyn
Xn125 xhp125 xhn125 ahp125 ahn125 vdd vbneu dneuron
Xcm_xh126 xhp126 xhn126 vdd cmld
Rnd_xh126 xhp126 xhn126 20k
Cxh126p xhp126 0 1e-13
Cxh126n xhn126 0 1e-13
Xihx_0_126 a_xp0 a_xn0 wp_ih_0_126 wn_ih_0_126 xhp126 xhn126 vdd vbsyn gsyn
Xihx_1_126 a_xp1 a_xn1 wp_ih_1_126 wn_ih_1_126 xhp126 xhn126 vdd vbsyn gsyn
Xihx_2_126 a_xp2 a_xn2 wp_ih_2_126 wn_ih_2_126 xhp126 xhn126 vdd vbsyn gsyn
Xn126 xhp126 xhn126 ahp126 ahn126 vdd vbneu dneuron
Xcm_xh127 xhp127 xhn127 vdd cmld
Rnd_xh127 xhp127 xhn127 20k
Cxh127p xhp127 0 1e-13
Cxh127n xhn127 0 1e-13
Xihx_0_127 a_xp0 a_xn0 wp_ih_0_127 wn_ih_0_127 xhp127 xhn127 vdd vbsyn gsyn
Xihx_1_127 a_xp1 a_xn1 wp_ih_1_127 wn_ih_1_127 xhp127 xhn127 vdd vbsyn gsyn
Xihx_2_127 a_xp2 a_xn2 wp_ih_2_127 wn_ih_2_127 xhp127 xhn127 vdd vbsyn gsyn
Xn127 xhp127 xhn127 ahp127 ahn127 vdd vbneu dneuron
Xcm_xh128 xhp128 xhn128 vdd cmld
Rnd_xh128 xhp128 xhn128 20k
Cxh128p xhp128 0 1e-13
Cxh128n xhn128 0 1e-13
Xihx_0_128 a_xp0 a_xn0 wp_ih_0_128 wn_ih_0_128 xhp128 xhn128 vdd vbsyn gsyn
Xihx_1_128 a_xp1 a_xn1 wp_ih_1_128 wn_ih_1_128 xhp128 xhn128 vdd vbsyn gsyn
Xihx_2_128 a_xp2 a_xn2 wp_ih_2_128 wn_ih_2_128 xhp128 xhn128 vdd vbsyn gsyn
Xn128 xhp128 xhn128 ahp128 ahn128 vdd vbneu dneuron
Xcm_xh129 xhp129 xhn129 vdd cmld
Rnd_xh129 xhp129 xhn129 20k
Cxh129p xhp129 0 1e-13
Cxh129n xhn129 0 1e-13
Xihx_0_129 a_xp0 a_xn0 wp_ih_0_129 wn_ih_0_129 xhp129 xhn129 vdd vbsyn gsyn
Xihx_1_129 a_xp1 a_xn1 wp_ih_1_129 wn_ih_1_129 xhp129 xhn129 vdd vbsyn gsyn
Xihx_2_129 a_xp2 a_xn2 wp_ih_2_129 wn_ih_2_129 xhp129 xhn129 vdd vbsyn gsyn
Xn129 xhp129 xhn129 ahp129 ahn129 vdd vbneu dneuron
Xcm_xh130 xhp130 xhn130 vdd cmld
Rnd_xh130 xhp130 xhn130 20k
Cxh130p xhp130 0 1e-13
Cxh130n xhn130 0 1e-13
Xihx_0_130 a_xp0 a_xn0 wp_ih_0_130 wn_ih_0_130 xhp130 xhn130 vdd vbsyn gsyn
Xihx_1_130 a_xp1 a_xn1 wp_ih_1_130 wn_ih_1_130 xhp130 xhn130 vdd vbsyn gsyn
Xihx_2_130 a_xp2 a_xn2 wp_ih_2_130 wn_ih_2_130 xhp130 xhn130 vdd vbsyn gsyn
Xn130 xhp130 xhn130 ahp130 ahn130 vdd vbneu dneuron
Xcm_xh131 xhp131 xhn131 vdd cmld
Rnd_xh131 xhp131 xhn131 20k
Cxh131p xhp131 0 1e-13
Cxh131n xhn131 0 1e-13
Xihx_0_131 a_xp0 a_xn0 wp_ih_0_131 wn_ih_0_131 xhp131 xhn131 vdd vbsyn gsyn
Xihx_1_131 a_xp1 a_xn1 wp_ih_1_131 wn_ih_1_131 xhp131 xhn131 vdd vbsyn gsyn
Xihx_2_131 a_xp2 a_xn2 wp_ih_2_131 wn_ih_2_131 xhp131 xhn131 vdd vbsyn gsyn
Xn131 xhp131 xhn131 ahp131 ahn131 vdd vbneu dneuron
Xcm_xh132 xhp132 xhn132 vdd cmld
Rnd_xh132 xhp132 xhn132 20k
Cxh132p xhp132 0 1e-13
Cxh132n xhn132 0 1e-13
Xihx_0_132 a_xp0 a_xn0 wp_ih_0_132 wn_ih_0_132 xhp132 xhn132 vdd vbsyn gsyn
Xihx_1_132 a_xp1 a_xn1 wp_ih_1_132 wn_ih_1_132 xhp132 xhn132 vdd vbsyn gsyn
Xihx_2_132 a_xp2 a_xn2 wp_ih_2_132 wn_ih_2_132 xhp132 xhn132 vdd vbsyn gsyn
Xn132 xhp132 xhn132 ahp132 ahn132 vdd vbneu dneuron
Xcm_xh133 xhp133 xhn133 vdd cmld
Rnd_xh133 xhp133 xhn133 20k
Cxh133p xhp133 0 1e-13
Cxh133n xhn133 0 1e-13
Xihx_0_133 a_xp0 a_xn0 wp_ih_0_133 wn_ih_0_133 xhp133 xhn133 vdd vbsyn gsyn
Xihx_1_133 a_xp1 a_xn1 wp_ih_1_133 wn_ih_1_133 xhp133 xhn133 vdd vbsyn gsyn
Xihx_2_133 a_xp2 a_xn2 wp_ih_2_133 wn_ih_2_133 xhp133 xhn133 vdd vbsyn gsyn
Xn133 xhp133 xhn133 ahp133 ahn133 vdd vbneu dneuron
Xcm_xh134 xhp134 xhn134 vdd cmld
Rnd_xh134 xhp134 xhn134 20k
Cxh134p xhp134 0 1e-13
Cxh134n xhn134 0 1e-13
Xihx_0_134 a_xp0 a_xn0 wp_ih_0_134 wn_ih_0_134 xhp134 xhn134 vdd vbsyn gsyn
Xihx_1_134 a_xp1 a_xn1 wp_ih_1_134 wn_ih_1_134 xhp134 xhn134 vdd vbsyn gsyn
Xihx_2_134 a_xp2 a_xn2 wp_ih_2_134 wn_ih_2_134 xhp134 xhn134 vdd vbsyn gsyn
Xn134 xhp134 xhn134 ahp134 ahn134 vdd vbneu dneuron
Xcm_xh135 xhp135 xhn135 vdd cmld
Rnd_xh135 xhp135 xhn135 20k
Cxh135p xhp135 0 1e-13
Cxh135n xhn135 0 1e-13
Xihx_0_135 a_xp0 a_xn0 wp_ih_0_135 wn_ih_0_135 xhp135 xhn135 vdd vbsyn gsyn
Xihx_1_135 a_xp1 a_xn1 wp_ih_1_135 wn_ih_1_135 xhp135 xhn135 vdd vbsyn gsyn
Xihx_2_135 a_xp2 a_xn2 wp_ih_2_135 wn_ih_2_135 xhp135 xhn135 vdd vbsyn gsyn
Xn135 xhp135 xhn135 ahp135 ahn135 vdd vbneu dneuron
Xcm_xh136 xhp136 xhn136 vdd cmld
Rnd_xh136 xhp136 xhn136 20k
Cxh136p xhp136 0 1e-13
Cxh136n xhn136 0 1e-13
Xihx_0_136 a_xp0 a_xn0 wp_ih_0_136 wn_ih_0_136 xhp136 xhn136 vdd vbsyn gsyn
Xihx_1_136 a_xp1 a_xn1 wp_ih_1_136 wn_ih_1_136 xhp136 xhn136 vdd vbsyn gsyn
Xihx_2_136 a_xp2 a_xn2 wp_ih_2_136 wn_ih_2_136 xhp136 xhn136 vdd vbsyn gsyn
Xn136 xhp136 xhn136 ahp136 ahn136 vdd vbneu dneuron
Xcm_xh137 xhp137 xhn137 vdd cmld
Rnd_xh137 xhp137 xhn137 20k
Cxh137p xhp137 0 1e-13
Cxh137n xhn137 0 1e-13
Xihx_0_137 a_xp0 a_xn0 wp_ih_0_137 wn_ih_0_137 xhp137 xhn137 vdd vbsyn gsyn
Xihx_1_137 a_xp1 a_xn1 wp_ih_1_137 wn_ih_1_137 xhp137 xhn137 vdd vbsyn gsyn
Xihx_2_137 a_xp2 a_xn2 wp_ih_2_137 wn_ih_2_137 xhp137 xhn137 vdd vbsyn gsyn
Xn137 xhp137 xhn137 ahp137 ahn137 vdd vbneu dneuron
Xcm_xh138 xhp138 xhn138 vdd cmld
Rnd_xh138 xhp138 xhn138 20k
Cxh138p xhp138 0 1e-13
Cxh138n xhn138 0 1e-13
Xihx_0_138 a_xp0 a_xn0 wp_ih_0_138 wn_ih_0_138 xhp138 xhn138 vdd vbsyn gsyn
Xihx_1_138 a_xp1 a_xn1 wp_ih_1_138 wn_ih_1_138 xhp138 xhn138 vdd vbsyn gsyn
Xihx_2_138 a_xp2 a_xn2 wp_ih_2_138 wn_ih_2_138 xhp138 xhn138 vdd vbsyn gsyn
Xn138 xhp138 xhn138 ahp138 ahn138 vdd vbneu dneuron
Xcm_xh139 xhp139 xhn139 vdd cmld
Rnd_xh139 xhp139 xhn139 20k
Cxh139p xhp139 0 1e-13
Cxh139n xhn139 0 1e-13
Xihx_0_139 a_xp0 a_xn0 wp_ih_0_139 wn_ih_0_139 xhp139 xhn139 vdd vbsyn gsyn
Xihx_1_139 a_xp1 a_xn1 wp_ih_1_139 wn_ih_1_139 xhp139 xhn139 vdd vbsyn gsyn
Xihx_2_139 a_xp2 a_xn2 wp_ih_2_139 wn_ih_2_139 xhp139 xhn139 vdd vbsyn gsyn
Xn139 xhp139 xhn139 ahp139 ahn139 vdd vbneu dneuron
Xcm_xh140 xhp140 xhn140 vdd cmld
Rnd_xh140 xhp140 xhn140 20k
Cxh140p xhp140 0 1e-13
Cxh140n xhn140 0 1e-13
Xihx_0_140 a_xp0 a_xn0 wp_ih_0_140 wn_ih_0_140 xhp140 xhn140 vdd vbsyn gsyn
Xihx_1_140 a_xp1 a_xn1 wp_ih_1_140 wn_ih_1_140 xhp140 xhn140 vdd vbsyn gsyn
Xihx_2_140 a_xp2 a_xn2 wp_ih_2_140 wn_ih_2_140 xhp140 xhn140 vdd vbsyn gsyn
Xn140 xhp140 xhn140 ahp140 ahn140 vdd vbneu dneuron
Xcm_xh141 xhp141 xhn141 vdd cmld
Rnd_xh141 xhp141 xhn141 20k
Cxh141p xhp141 0 1e-13
Cxh141n xhn141 0 1e-13
Xihx_0_141 a_xp0 a_xn0 wp_ih_0_141 wn_ih_0_141 xhp141 xhn141 vdd vbsyn gsyn
Xihx_1_141 a_xp1 a_xn1 wp_ih_1_141 wn_ih_1_141 xhp141 xhn141 vdd vbsyn gsyn
Xihx_2_141 a_xp2 a_xn2 wp_ih_2_141 wn_ih_2_141 xhp141 xhn141 vdd vbsyn gsyn
Xn141 xhp141 xhn141 ahp141 ahn141 vdd vbneu dneuron
Xcm_xh142 xhp142 xhn142 vdd cmld
Rnd_xh142 xhp142 xhn142 20k
Cxh142p xhp142 0 1e-13
Cxh142n xhn142 0 1e-13
Xihx_0_142 a_xp0 a_xn0 wp_ih_0_142 wn_ih_0_142 xhp142 xhn142 vdd vbsyn gsyn
Xihx_1_142 a_xp1 a_xn1 wp_ih_1_142 wn_ih_1_142 xhp142 xhn142 vdd vbsyn gsyn
Xihx_2_142 a_xp2 a_xn2 wp_ih_2_142 wn_ih_2_142 xhp142 xhn142 vdd vbsyn gsyn
Xn142 xhp142 xhn142 ahp142 ahn142 vdd vbneu dneuron
Xcm_xh143 xhp143 xhn143 vdd cmld
Rnd_xh143 xhp143 xhn143 20k
Cxh143p xhp143 0 1e-13
Cxh143n xhn143 0 1e-13
Xihx_0_143 a_xp0 a_xn0 wp_ih_0_143 wn_ih_0_143 xhp143 xhn143 vdd vbsyn gsyn
Xihx_1_143 a_xp1 a_xn1 wp_ih_1_143 wn_ih_1_143 xhp143 xhn143 vdd vbsyn gsyn
Xihx_2_143 a_xp2 a_xn2 wp_ih_2_143 wn_ih_2_143 xhp143 xhn143 vdd vbsyn gsyn
Xn143 xhp143 xhn143 ahp143 ahn143 vdd vbneu dneuron
Xcm_xh144 xhp144 xhn144 vdd cmld
Rnd_xh144 xhp144 xhn144 20k
Cxh144p xhp144 0 1e-13
Cxh144n xhn144 0 1e-13
Xihx_0_144 a_xp0 a_xn0 wp_ih_0_144 wn_ih_0_144 xhp144 xhn144 vdd vbsyn gsyn
Xihx_1_144 a_xp1 a_xn1 wp_ih_1_144 wn_ih_1_144 xhp144 xhn144 vdd vbsyn gsyn
Xihx_2_144 a_xp2 a_xn2 wp_ih_2_144 wn_ih_2_144 xhp144 xhn144 vdd vbsyn gsyn
Xn144 xhp144 xhn144 ahp144 ahn144 vdd vbneu dneuron
Xcm_xh145 xhp145 xhn145 vdd cmld
Rnd_xh145 xhp145 xhn145 20k
Cxh145p xhp145 0 1e-13
Cxh145n xhn145 0 1e-13
Xihx_0_145 a_xp0 a_xn0 wp_ih_0_145 wn_ih_0_145 xhp145 xhn145 vdd vbsyn gsyn
Xihx_1_145 a_xp1 a_xn1 wp_ih_1_145 wn_ih_1_145 xhp145 xhn145 vdd vbsyn gsyn
Xihx_2_145 a_xp2 a_xn2 wp_ih_2_145 wn_ih_2_145 xhp145 xhn145 vdd vbsyn gsyn
Xn145 xhp145 xhn145 ahp145 ahn145 vdd vbneu dneuron
Xcm_xh146 xhp146 xhn146 vdd cmld
Rnd_xh146 xhp146 xhn146 20k
Cxh146p xhp146 0 1e-13
Cxh146n xhn146 0 1e-13
Xihx_0_146 a_xp0 a_xn0 wp_ih_0_146 wn_ih_0_146 xhp146 xhn146 vdd vbsyn gsyn
Xihx_1_146 a_xp1 a_xn1 wp_ih_1_146 wn_ih_1_146 xhp146 xhn146 vdd vbsyn gsyn
Xihx_2_146 a_xp2 a_xn2 wp_ih_2_146 wn_ih_2_146 xhp146 xhn146 vdd vbsyn gsyn
Xn146 xhp146 xhn146 ahp146 ahn146 vdd vbneu dneuron
Xcm_xh147 xhp147 xhn147 vdd cmld
Rnd_xh147 xhp147 xhn147 20k
Cxh147p xhp147 0 1e-13
Cxh147n xhn147 0 1e-13
Xihx_0_147 a_xp0 a_xn0 wp_ih_0_147 wn_ih_0_147 xhp147 xhn147 vdd vbsyn gsyn
Xihx_1_147 a_xp1 a_xn1 wp_ih_1_147 wn_ih_1_147 xhp147 xhn147 vdd vbsyn gsyn
Xihx_2_147 a_xp2 a_xn2 wp_ih_2_147 wn_ih_2_147 xhp147 xhn147 vdd vbsyn gsyn
Xn147 xhp147 xhn147 ahp147 ahn147 vdd vbneu dneuron
Xcm_xh148 xhp148 xhn148 vdd cmld
Rnd_xh148 xhp148 xhn148 20k
Cxh148p xhp148 0 1e-13
Cxh148n xhn148 0 1e-13
Xihx_0_148 a_xp0 a_xn0 wp_ih_0_148 wn_ih_0_148 xhp148 xhn148 vdd vbsyn gsyn
Xihx_1_148 a_xp1 a_xn1 wp_ih_1_148 wn_ih_1_148 xhp148 xhn148 vdd vbsyn gsyn
Xihx_2_148 a_xp2 a_xn2 wp_ih_2_148 wn_ih_2_148 xhp148 xhn148 vdd vbsyn gsyn
Xn148 xhp148 xhn148 ahp148 ahn148 vdd vbneu dneuron
Xcm_xh149 xhp149 xhn149 vdd cmld
Rnd_xh149 xhp149 xhn149 20k
Cxh149p xhp149 0 1e-13
Cxh149n xhn149 0 1e-13
Xihx_0_149 a_xp0 a_xn0 wp_ih_0_149 wn_ih_0_149 xhp149 xhn149 vdd vbsyn gsyn
Xihx_1_149 a_xp1 a_xn1 wp_ih_1_149 wn_ih_1_149 xhp149 xhn149 vdd vbsyn gsyn
Xihx_2_149 a_xp2 a_xn2 wp_ih_2_149 wn_ih_2_149 xhp149 xhn149 vdd vbsyn gsyn
Xn149 xhp149 xhn149 ahp149 ahn149 vdd vbneu dneuron
Xcm_xh150 xhp150 xhn150 vdd cmld
Rnd_xh150 xhp150 xhn150 20k
Cxh150p xhp150 0 1e-13
Cxh150n xhn150 0 1e-13
Xihx_0_150 a_xp0 a_xn0 wp_ih_0_150 wn_ih_0_150 xhp150 xhn150 vdd vbsyn gsyn
Xihx_1_150 a_xp1 a_xn1 wp_ih_1_150 wn_ih_1_150 xhp150 xhn150 vdd vbsyn gsyn
Xihx_2_150 a_xp2 a_xn2 wp_ih_2_150 wn_ih_2_150 xhp150 xhn150 vdd vbsyn gsyn
Xn150 xhp150 xhn150 ahp150 ahn150 vdd vbneu dneuron
Xcm_xh151 xhp151 xhn151 vdd cmld
Rnd_xh151 xhp151 xhn151 20k
Cxh151p xhp151 0 1e-13
Cxh151n xhn151 0 1e-13
Xihx_0_151 a_xp0 a_xn0 wp_ih_0_151 wn_ih_0_151 xhp151 xhn151 vdd vbsyn gsyn
Xihx_1_151 a_xp1 a_xn1 wp_ih_1_151 wn_ih_1_151 xhp151 xhn151 vdd vbsyn gsyn
Xihx_2_151 a_xp2 a_xn2 wp_ih_2_151 wn_ih_2_151 xhp151 xhn151 vdd vbsyn gsyn
Xn151 xhp151 xhn151 ahp151 ahn151 vdd vbneu dneuron
Xcm_xh152 xhp152 xhn152 vdd cmld
Rnd_xh152 xhp152 xhn152 20k
Cxh152p xhp152 0 1e-13
Cxh152n xhn152 0 1e-13
Xihx_0_152 a_xp0 a_xn0 wp_ih_0_152 wn_ih_0_152 xhp152 xhn152 vdd vbsyn gsyn
Xihx_1_152 a_xp1 a_xn1 wp_ih_1_152 wn_ih_1_152 xhp152 xhn152 vdd vbsyn gsyn
Xihx_2_152 a_xp2 a_xn2 wp_ih_2_152 wn_ih_2_152 xhp152 xhn152 vdd vbsyn gsyn
Xn152 xhp152 xhn152 ahp152 ahn152 vdd vbneu dneuron
Xcm_xh153 xhp153 xhn153 vdd cmld
Rnd_xh153 xhp153 xhn153 20k
Cxh153p xhp153 0 1e-13
Cxh153n xhn153 0 1e-13
Xihx_0_153 a_xp0 a_xn0 wp_ih_0_153 wn_ih_0_153 xhp153 xhn153 vdd vbsyn gsyn
Xihx_1_153 a_xp1 a_xn1 wp_ih_1_153 wn_ih_1_153 xhp153 xhn153 vdd vbsyn gsyn
Xihx_2_153 a_xp2 a_xn2 wp_ih_2_153 wn_ih_2_153 xhp153 xhn153 vdd vbsyn gsyn
Xn153 xhp153 xhn153 ahp153 ahn153 vdd vbneu dneuron
Xcm_xh154 xhp154 xhn154 vdd cmld
Rnd_xh154 xhp154 xhn154 20k
Cxh154p xhp154 0 1e-13
Cxh154n xhn154 0 1e-13
Xihx_0_154 a_xp0 a_xn0 wp_ih_0_154 wn_ih_0_154 xhp154 xhn154 vdd vbsyn gsyn
Xihx_1_154 a_xp1 a_xn1 wp_ih_1_154 wn_ih_1_154 xhp154 xhn154 vdd vbsyn gsyn
Xihx_2_154 a_xp2 a_xn2 wp_ih_2_154 wn_ih_2_154 xhp154 xhn154 vdd vbsyn gsyn
Xn154 xhp154 xhn154 ahp154 ahn154 vdd vbneu dneuron
Xcm_xh155 xhp155 xhn155 vdd cmld
Rnd_xh155 xhp155 xhn155 20k
Cxh155p xhp155 0 1e-13
Cxh155n xhn155 0 1e-13
Xihx_0_155 a_xp0 a_xn0 wp_ih_0_155 wn_ih_0_155 xhp155 xhn155 vdd vbsyn gsyn
Xihx_1_155 a_xp1 a_xn1 wp_ih_1_155 wn_ih_1_155 xhp155 xhn155 vdd vbsyn gsyn
Xihx_2_155 a_xp2 a_xn2 wp_ih_2_155 wn_ih_2_155 xhp155 xhn155 vdd vbsyn gsyn
Xn155 xhp155 xhn155 ahp155 ahn155 vdd vbneu dneuron
Xcm_xh156 xhp156 xhn156 vdd cmld
Rnd_xh156 xhp156 xhn156 20k
Cxh156p xhp156 0 1e-13
Cxh156n xhn156 0 1e-13
Xihx_0_156 a_xp0 a_xn0 wp_ih_0_156 wn_ih_0_156 xhp156 xhn156 vdd vbsyn gsyn
Xihx_1_156 a_xp1 a_xn1 wp_ih_1_156 wn_ih_1_156 xhp156 xhn156 vdd vbsyn gsyn
Xihx_2_156 a_xp2 a_xn2 wp_ih_2_156 wn_ih_2_156 xhp156 xhn156 vdd vbsyn gsyn
Xn156 xhp156 xhn156 ahp156 ahn156 vdd vbneu dneuron
Xcm_xh157 xhp157 xhn157 vdd cmld
Rnd_xh157 xhp157 xhn157 20k
Cxh157p xhp157 0 1e-13
Cxh157n xhn157 0 1e-13
Xihx_0_157 a_xp0 a_xn0 wp_ih_0_157 wn_ih_0_157 xhp157 xhn157 vdd vbsyn gsyn
Xihx_1_157 a_xp1 a_xn1 wp_ih_1_157 wn_ih_1_157 xhp157 xhn157 vdd vbsyn gsyn
Xihx_2_157 a_xp2 a_xn2 wp_ih_2_157 wn_ih_2_157 xhp157 xhn157 vdd vbsyn gsyn
Xn157 xhp157 xhn157 ahp157 ahn157 vdd vbneu dneuron
Xcm_xh158 xhp158 xhn158 vdd cmld
Rnd_xh158 xhp158 xhn158 20k
Cxh158p xhp158 0 1e-13
Cxh158n xhn158 0 1e-13
Xihx_0_158 a_xp0 a_xn0 wp_ih_0_158 wn_ih_0_158 xhp158 xhn158 vdd vbsyn gsyn
Xihx_1_158 a_xp1 a_xn1 wp_ih_1_158 wn_ih_1_158 xhp158 xhn158 vdd vbsyn gsyn
Xihx_2_158 a_xp2 a_xn2 wp_ih_2_158 wn_ih_2_158 xhp158 xhn158 vdd vbsyn gsyn
Xn158 xhp158 xhn158 ahp158 ahn158 vdd vbneu dneuron
Xcm_xh159 xhp159 xhn159 vdd cmld
Rnd_xh159 xhp159 xhn159 20k
Cxh159p xhp159 0 1e-13
Cxh159n xhn159 0 1e-13
Xihx_0_159 a_xp0 a_xn0 wp_ih_0_159 wn_ih_0_159 xhp159 xhn159 vdd vbsyn gsyn
Xihx_1_159 a_xp1 a_xn1 wp_ih_1_159 wn_ih_1_159 xhp159 xhn159 vdd vbsyn gsyn
Xihx_2_159 a_xp2 a_xn2 wp_ih_2_159 wn_ih_2_159 xhp159 xhn159 vdd vbsyn gsyn
Xn159 xhp159 xhn159 ahp159 ahn159 vdd vbneu dneuron
Xcm_xh160 xhp160 xhn160 vdd cmld
Rnd_xh160 xhp160 xhn160 20k
Cxh160p xhp160 0 1e-13
Cxh160n xhn160 0 1e-13
Xihx_0_160 a_xp0 a_xn0 wp_ih_0_160 wn_ih_0_160 xhp160 xhn160 vdd vbsyn gsyn
Xihx_1_160 a_xp1 a_xn1 wp_ih_1_160 wn_ih_1_160 xhp160 xhn160 vdd vbsyn gsyn
Xihx_2_160 a_xp2 a_xn2 wp_ih_2_160 wn_ih_2_160 xhp160 xhn160 vdd vbsyn gsyn
Xn160 xhp160 xhn160 ahp160 ahn160 vdd vbneu dneuron
Xcm_xh161 xhp161 xhn161 vdd cmld
Rnd_xh161 xhp161 xhn161 20k
Cxh161p xhp161 0 1e-13
Cxh161n xhn161 0 1e-13
Xihx_0_161 a_xp0 a_xn0 wp_ih_0_161 wn_ih_0_161 xhp161 xhn161 vdd vbsyn gsyn
Xihx_1_161 a_xp1 a_xn1 wp_ih_1_161 wn_ih_1_161 xhp161 xhn161 vdd vbsyn gsyn
Xihx_2_161 a_xp2 a_xn2 wp_ih_2_161 wn_ih_2_161 xhp161 xhn161 vdd vbsyn gsyn
Xn161 xhp161 xhn161 ahp161 ahn161 vdd vbneu dneuron
Xcm_xh162 xhp162 xhn162 vdd cmld
Rnd_xh162 xhp162 xhn162 20k
Cxh162p xhp162 0 1e-13
Cxh162n xhn162 0 1e-13
Xihx_0_162 a_xp0 a_xn0 wp_ih_0_162 wn_ih_0_162 xhp162 xhn162 vdd vbsyn gsyn
Xihx_1_162 a_xp1 a_xn1 wp_ih_1_162 wn_ih_1_162 xhp162 xhn162 vdd vbsyn gsyn
Xihx_2_162 a_xp2 a_xn2 wp_ih_2_162 wn_ih_2_162 xhp162 xhn162 vdd vbsyn gsyn
Xn162 xhp162 xhn162 ahp162 ahn162 vdd vbneu dneuron
Xcm_xh163 xhp163 xhn163 vdd cmld
Rnd_xh163 xhp163 xhn163 20k
Cxh163p xhp163 0 1e-13
Cxh163n xhn163 0 1e-13
Xihx_0_163 a_xp0 a_xn0 wp_ih_0_163 wn_ih_0_163 xhp163 xhn163 vdd vbsyn gsyn
Xihx_1_163 a_xp1 a_xn1 wp_ih_1_163 wn_ih_1_163 xhp163 xhn163 vdd vbsyn gsyn
Xihx_2_163 a_xp2 a_xn2 wp_ih_2_163 wn_ih_2_163 xhp163 xhn163 vdd vbsyn gsyn
Xn163 xhp163 xhn163 ahp163 ahn163 vdd vbneu dneuron
Xcm_xh164 xhp164 xhn164 vdd cmld
Rnd_xh164 xhp164 xhn164 20k
Cxh164p xhp164 0 1e-13
Cxh164n xhn164 0 1e-13
Xihx_0_164 a_xp0 a_xn0 wp_ih_0_164 wn_ih_0_164 xhp164 xhn164 vdd vbsyn gsyn
Xihx_1_164 a_xp1 a_xn1 wp_ih_1_164 wn_ih_1_164 xhp164 xhn164 vdd vbsyn gsyn
Xihx_2_164 a_xp2 a_xn2 wp_ih_2_164 wn_ih_2_164 xhp164 xhn164 vdd vbsyn gsyn
Xn164 xhp164 xhn164 ahp164 ahn164 vdd vbneu dneuron
Xcm_xh165 xhp165 xhn165 vdd cmld
Rnd_xh165 xhp165 xhn165 20k
Cxh165p xhp165 0 1e-13
Cxh165n xhn165 0 1e-13
Xihx_0_165 a_xp0 a_xn0 wp_ih_0_165 wn_ih_0_165 xhp165 xhn165 vdd vbsyn gsyn
Xihx_1_165 a_xp1 a_xn1 wp_ih_1_165 wn_ih_1_165 xhp165 xhn165 vdd vbsyn gsyn
Xihx_2_165 a_xp2 a_xn2 wp_ih_2_165 wn_ih_2_165 xhp165 xhn165 vdd vbsyn gsyn
Xn165 xhp165 xhn165 ahp165 ahn165 vdd vbneu dneuron
Xcm_xh166 xhp166 xhn166 vdd cmld
Rnd_xh166 xhp166 xhn166 20k
Cxh166p xhp166 0 1e-13
Cxh166n xhn166 0 1e-13
Xihx_0_166 a_xp0 a_xn0 wp_ih_0_166 wn_ih_0_166 xhp166 xhn166 vdd vbsyn gsyn
Xihx_1_166 a_xp1 a_xn1 wp_ih_1_166 wn_ih_1_166 xhp166 xhn166 vdd vbsyn gsyn
Xihx_2_166 a_xp2 a_xn2 wp_ih_2_166 wn_ih_2_166 xhp166 xhn166 vdd vbsyn gsyn
Xn166 xhp166 xhn166 ahp166 ahn166 vdd vbneu dneuron
Xcm_xh167 xhp167 xhn167 vdd cmld
Rnd_xh167 xhp167 xhn167 20k
Cxh167p xhp167 0 1e-13
Cxh167n xhn167 0 1e-13
Xihx_0_167 a_xp0 a_xn0 wp_ih_0_167 wn_ih_0_167 xhp167 xhn167 vdd vbsyn gsyn
Xihx_1_167 a_xp1 a_xn1 wp_ih_1_167 wn_ih_1_167 xhp167 xhn167 vdd vbsyn gsyn
Xihx_2_167 a_xp2 a_xn2 wp_ih_2_167 wn_ih_2_167 xhp167 xhn167 vdd vbsyn gsyn
Xn167 xhp167 xhn167 ahp167 ahn167 vdd vbneu dneuron
Xcm_xh168 xhp168 xhn168 vdd cmld
Rnd_xh168 xhp168 xhn168 20k
Cxh168p xhp168 0 1e-13
Cxh168n xhn168 0 1e-13
Xihx_0_168 a_xp0 a_xn0 wp_ih_0_168 wn_ih_0_168 xhp168 xhn168 vdd vbsyn gsyn
Xihx_1_168 a_xp1 a_xn1 wp_ih_1_168 wn_ih_1_168 xhp168 xhn168 vdd vbsyn gsyn
Xihx_2_168 a_xp2 a_xn2 wp_ih_2_168 wn_ih_2_168 xhp168 xhn168 vdd vbsyn gsyn
Xn168 xhp168 xhn168 ahp168 ahn168 vdd vbneu dneuron
Xcm_xh169 xhp169 xhn169 vdd cmld
Rnd_xh169 xhp169 xhn169 20k
Cxh169p xhp169 0 1e-13
Cxh169n xhn169 0 1e-13
Xihx_0_169 a_xp0 a_xn0 wp_ih_0_169 wn_ih_0_169 xhp169 xhn169 vdd vbsyn gsyn
Xihx_1_169 a_xp1 a_xn1 wp_ih_1_169 wn_ih_1_169 xhp169 xhn169 vdd vbsyn gsyn
Xihx_2_169 a_xp2 a_xn2 wp_ih_2_169 wn_ih_2_169 xhp169 xhn169 vdd vbsyn gsyn
Xn169 xhp169 xhn169 ahp169 ahn169 vdd vbneu dneuron
Xcm_xh170 xhp170 xhn170 vdd cmld
Rnd_xh170 xhp170 xhn170 20k
Cxh170p xhp170 0 1e-13
Cxh170n xhn170 0 1e-13
Xihx_0_170 a_xp0 a_xn0 wp_ih_0_170 wn_ih_0_170 xhp170 xhn170 vdd vbsyn gsyn
Xihx_1_170 a_xp1 a_xn1 wp_ih_1_170 wn_ih_1_170 xhp170 xhn170 vdd vbsyn gsyn
Xihx_2_170 a_xp2 a_xn2 wp_ih_2_170 wn_ih_2_170 xhp170 xhn170 vdd vbsyn gsyn
Xn170 xhp170 xhn170 ahp170 ahn170 vdd vbneu dneuron
Xcm_xh171 xhp171 xhn171 vdd cmld
Rnd_xh171 xhp171 xhn171 20k
Cxh171p xhp171 0 1e-13
Cxh171n xhn171 0 1e-13
Xihx_0_171 a_xp0 a_xn0 wp_ih_0_171 wn_ih_0_171 xhp171 xhn171 vdd vbsyn gsyn
Xihx_1_171 a_xp1 a_xn1 wp_ih_1_171 wn_ih_1_171 xhp171 xhn171 vdd vbsyn gsyn
Xihx_2_171 a_xp2 a_xn2 wp_ih_2_171 wn_ih_2_171 xhp171 xhn171 vdd vbsyn gsyn
Xn171 xhp171 xhn171 ahp171 ahn171 vdd vbneu dneuron
Xcm_xh172 xhp172 xhn172 vdd cmld
Rnd_xh172 xhp172 xhn172 20k
Cxh172p xhp172 0 1e-13
Cxh172n xhn172 0 1e-13
Xihx_0_172 a_xp0 a_xn0 wp_ih_0_172 wn_ih_0_172 xhp172 xhn172 vdd vbsyn gsyn
Xihx_1_172 a_xp1 a_xn1 wp_ih_1_172 wn_ih_1_172 xhp172 xhn172 vdd vbsyn gsyn
Xihx_2_172 a_xp2 a_xn2 wp_ih_2_172 wn_ih_2_172 xhp172 xhn172 vdd vbsyn gsyn
Xn172 xhp172 xhn172 ahp172 ahn172 vdd vbneu dneuron
Xcm_xh173 xhp173 xhn173 vdd cmld
Rnd_xh173 xhp173 xhn173 20k
Cxh173p xhp173 0 1e-13
Cxh173n xhn173 0 1e-13
Xihx_0_173 a_xp0 a_xn0 wp_ih_0_173 wn_ih_0_173 xhp173 xhn173 vdd vbsyn gsyn
Xihx_1_173 a_xp1 a_xn1 wp_ih_1_173 wn_ih_1_173 xhp173 xhn173 vdd vbsyn gsyn
Xihx_2_173 a_xp2 a_xn2 wp_ih_2_173 wn_ih_2_173 xhp173 xhn173 vdd vbsyn gsyn
Xn173 xhp173 xhn173 ahp173 ahn173 vdd vbneu dneuron
Xcm_xh174 xhp174 xhn174 vdd cmld
Rnd_xh174 xhp174 xhn174 20k
Cxh174p xhp174 0 1e-13
Cxh174n xhn174 0 1e-13
Xihx_0_174 a_xp0 a_xn0 wp_ih_0_174 wn_ih_0_174 xhp174 xhn174 vdd vbsyn gsyn
Xihx_1_174 a_xp1 a_xn1 wp_ih_1_174 wn_ih_1_174 xhp174 xhn174 vdd vbsyn gsyn
Xihx_2_174 a_xp2 a_xn2 wp_ih_2_174 wn_ih_2_174 xhp174 xhn174 vdd vbsyn gsyn
Xn174 xhp174 xhn174 ahp174 ahn174 vdd vbneu dneuron
Xcm_xh175 xhp175 xhn175 vdd cmld
Rnd_xh175 xhp175 xhn175 20k
Cxh175p xhp175 0 1e-13
Cxh175n xhn175 0 1e-13
Xihx_0_175 a_xp0 a_xn0 wp_ih_0_175 wn_ih_0_175 xhp175 xhn175 vdd vbsyn gsyn
Xihx_1_175 a_xp1 a_xn1 wp_ih_1_175 wn_ih_1_175 xhp175 xhn175 vdd vbsyn gsyn
Xihx_2_175 a_xp2 a_xn2 wp_ih_2_175 wn_ih_2_175 xhp175 xhn175 vdd vbsyn gsyn
Xn175 xhp175 xhn175 ahp175 ahn175 vdd vbneu dneuron
Xcm_xh176 xhp176 xhn176 vdd cmld
Rnd_xh176 xhp176 xhn176 20k
Cxh176p xhp176 0 1e-13
Cxh176n xhn176 0 1e-13
Xihx_0_176 a_xp0 a_xn0 wp_ih_0_176 wn_ih_0_176 xhp176 xhn176 vdd vbsyn gsyn
Xihx_1_176 a_xp1 a_xn1 wp_ih_1_176 wn_ih_1_176 xhp176 xhn176 vdd vbsyn gsyn
Xihx_2_176 a_xp2 a_xn2 wp_ih_2_176 wn_ih_2_176 xhp176 xhn176 vdd vbsyn gsyn
Xn176 xhp176 xhn176 ahp176 ahn176 vdd vbneu dneuron
Xcm_xh177 xhp177 xhn177 vdd cmld
Rnd_xh177 xhp177 xhn177 20k
Cxh177p xhp177 0 1e-13
Cxh177n xhn177 0 1e-13
Xihx_0_177 a_xp0 a_xn0 wp_ih_0_177 wn_ih_0_177 xhp177 xhn177 vdd vbsyn gsyn
Xihx_1_177 a_xp1 a_xn1 wp_ih_1_177 wn_ih_1_177 xhp177 xhn177 vdd vbsyn gsyn
Xihx_2_177 a_xp2 a_xn2 wp_ih_2_177 wn_ih_2_177 xhp177 xhn177 vdd vbsyn gsyn
Xn177 xhp177 xhn177 ahp177 ahn177 vdd vbneu dneuron
Xcm_xh178 xhp178 xhn178 vdd cmld
Rnd_xh178 xhp178 xhn178 20k
Cxh178p xhp178 0 1e-13
Cxh178n xhn178 0 1e-13
Xihx_0_178 a_xp0 a_xn0 wp_ih_0_178 wn_ih_0_178 xhp178 xhn178 vdd vbsyn gsyn
Xihx_1_178 a_xp1 a_xn1 wp_ih_1_178 wn_ih_1_178 xhp178 xhn178 vdd vbsyn gsyn
Xihx_2_178 a_xp2 a_xn2 wp_ih_2_178 wn_ih_2_178 xhp178 xhn178 vdd vbsyn gsyn
Xn178 xhp178 xhn178 ahp178 ahn178 vdd vbneu dneuron
Xcm_xh179 xhp179 xhn179 vdd cmld
Rnd_xh179 xhp179 xhn179 20k
Cxh179p xhp179 0 1e-13
Cxh179n xhn179 0 1e-13
Xihx_0_179 a_xp0 a_xn0 wp_ih_0_179 wn_ih_0_179 xhp179 xhn179 vdd vbsyn gsyn
Xihx_1_179 a_xp1 a_xn1 wp_ih_1_179 wn_ih_1_179 xhp179 xhn179 vdd vbsyn gsyn
Xihx_2_179 a_xp2 a_xn2 wp_ih_2_179 wn_ih_2_179 xhp179 xhn179 vdd vbsyn gsyn
Xn179 xhp179 xhn179 ahp179 ahn179 vdd vbneu dneuron
Xcm_xh180 xhp180 xhn180 vdd cmld
Rnd_xh180 xhp180 xhn180 20k
Cxh180p xhp180 0 1e-13
Cxh180n xhn180 0 1e-13
Xihx_0_180 a_xp0 a_xn0 wp_ih_0_180 wn_ih_0_180 xhp180 xhn180 vdd vbsyn gsyn
Xihx_1_180 a_xp1 a_xn1 wp_ih_1_180 wn_ih_1_180 xhp180 xhn180 vdd vbsyn gsyn
Xihx_2_180 a_xp2 a_xn2 wp_ih_2_180 wn_ih_2_180 xhp180 xhn180 vdd vbsyn gsyn
Xn180 xhp180 xhn180 ahp180 ahn180 vdd vbneu dneuron
Xcm_xh181 xhp181 xhn181 vdd cmld
Rnd_xh181 xhp181 xhn181 20k
Cxh181p xhp181 0 1e-13
Cxh181n xhn181 0 1e-13
Xihx_0_181 a_xp0 a_xn0 wp_ih_0_181 wn_ih_0_181 xhp181 xhn181 vdd vbsyn gsyn
Xihx_1_181 a_xp1 a_xn1 wp_ih_1_181 wn_ih_1_181 xhp181 xhn181 vdd vbsyn gsyn
Xihx_2_181 a_xp2 a_xn2 wp_ih_2_181 wn_ih_2_181 xhp181 xhn181 vdd vbsyn gsyn
Xn181 xhp181 xhn181 ahp181 ahn181 vdd vbneu dneuron
Xcm_xh182 xhp182 xhn182 vdd cmld
Rnd_xh182 xhp182 xhn182 20k
Cxh182p xhp182 0 1e-13
Cxh182n xhn182 0 1e-13
Xihx_0_182 a_xp0 a_xn0 wp_ih_0_182 wn_ih_0_182 xhp182 xhn182 vdd vbsyn gsyn
Xihx_1_182 a_xp1 a_xn1 wp_ih_1_182 wn_ih_1_182 xhp182 xhn182 vdd vbsyn gsyn
Xihx_2_182 a_xp2 a_xn2 wp_ih_2_182 wn_ih_2_182 xhp182 xhn182 vdd vbsyn gsyn
Xn182 xhp182 xhn182 ahp182 ahn182 vdd vbneu dneuron
Xcm_xh183 xhp183 xhn183 vdd cmld
Rnd_xh183 xhp183 xhn183 20k
Cxh183p xhp183 0 1e-13
Cxh183n xhn183 0 1e-13
Xihx_0_183 a_xp0 a_xn0 wp_ih_0_183 wn_ih_0_183 xhp183 xhn183 vdd vbsyn gsyn
Xihx_1_183 a_xp1 a_xn1 wp_ih_1_183 wn_ih_1_183 xhp183 xhn183 vdd vbsyn gsyn
Xihx_2_183 a_xp2 a_xn2 wp_ih_2_183 wn_ih_2_183 xhp183 xhn183 vdd vbsyn gsyn
Xn183 xhp183 xhn183 ahp183 ahn183 vdd vbneu dneuron
Xcm_xh184 xhp184 xhn184 vdd cmld
Rnd_xh184 xhp184 xhn184 20k
Cxh184p xhp184 0 1e-13
Cxh184n xhn184 0 1e-13
Xihx_0_184 a_xp0 a_xn0 wp_ih_0_184 wn_ih_0_184 xhp184 xhn184 vdd vbsyn gsyn
Xihx_1_184 a_xp1 a_xn1 wp_ih_1_184 wn_ih_1_184 xhp184 xhn184 vdd vbsyn gsyn
Xihx_2_184 a_xp2 a_xn2 wp_ih_2_184 wn_ih_2_184 xhp184 xhn184 vdd vbsyn gsyn
Xn184 xhp184 xhn184 ahp184 ahn184 vdd vbneu dneuron
Xcm_xh185 xhp185 xhn185 vdd cmld
Rnd_xh185 xhp185 xhn185 20k
Cxh185p xhp185 0 1e-13
Cxh185n xhn185 0 1e-13
Xihx_0_185 a_xp0 a_xn0 wp_ih_0_185 wn_ih_0_185 xhp185 xhn185 vdd vbsyn gsyn
Xihx_1_185 a_xp1 a_xn1 wp_ih_1_185 wn_ih_1_185 xhp185 xhn185 vdd vbsyn gsyn
Xihx_2_185 a_xp2 a_xn2 wp_ih_2_185 wn_ih_2_185 xhp185 xhn185 vdd vbsyn gsyn
Xn185 xhp185 xhn185 ahp185 ahn185 vdd vbneu dneuron
Xcm_xh186 xhp186 xhn186 vdd cmld
Rnd_xh186 xhp186 xhn186 20k
Cxh186p xhp186 0 1e-13
Cxh186n xhn186 0 1e-13
Xihx_0_186 a_xp0 a_xn0 wp_ih_0_186 wn_ih_0_186 xhp186 xhn186 vdd vbsyn gsyn
Xihx_1_186 a_xp1 a_xn1 wp_ih_1_186 wn_ih_1_186 xhp186 xhn186 vdd vbsyn gsyn
Xihx_2_186 a_xp2 a_xn2 wp_ih_2_186 wn_ih_2_186 xhp186 xhn186 vdd vbsyn gsyn
Xn186 xhp186 xhn186 ahp186 ahn186 vdd vbneu dneuron
Xcm_xh187 xhp187 xhn187 vdd cmld
Rnd_xh187 xhp187 xhn187 20k
Cxh187p xhp187 0 1e-13
Cxh187n xhn187 0 1e-13
Xihx_0_187 a_xp0 a_xn0 wp_ih_0_187 wn_ih_0_187 xhp187 xhn187 vdd vbsyn gsyn
Xihx_1_187 a_xp1 a_xn1 wp_ih_1_187 wn_ih_1_187 xhp187 xhn187 vdd vbsyn gsyn
Xihx_2_187 a_xp2 a_xn2 wp_ih_2_187 wn_ih_2_187 xhp187 xhn187 vdd vbsyn gsyn
Xn187 xhp187 xhn187 ahp187 ahn187 vdd vbneu dneuron
Xcm_xh188 xhp188 xhn188 vdd cmld
Rnd_xh188 xhp188 xhn188 20k
Cxh188p xhp188 0 1e-13
Cxh188n xhn188 0 1e-13
Xihx_0_188 a_xp0 a_xn0 wp_ih_0_188 wn_ih_0_188 xhp188 xhn188 vdd vbsyn gsyn
Xihx_1_188 a_xp1 a_xn1 wp_ih_1_188 wn_ih_1_188 xhp188 xhn188 vdd vbsyn gsyn
Xihx_2_188 a_xp2 a_xn2 wp_ih_2_188 wn_ih_2_188 xhp188 xhn188 vdd vbsyn gsyn
Xn188 xhp188 xhn188 ahp188 ahn188 vdd vbneu dneuron
Xcm_xh189 xhp189 xhn189 vdd cmld
Rnd_xh189 xhp189 xhn189 20k
Cxh189p xhp189 0 1e-13
Cxh189n xhn189 0 1e-13
Xihx_0_189 a_xp0 a_xn0 wp_ih_0_189 wn_ih_0_189 xhp189 xhn189 vdd vbsyn gsyn
Xihx_1_189 a_xp1 a_xn1 wp_ih_1_189 wn_ih_1_189 xhp189 xhn189 vdd vbsyn gsyn
Xihx_2_189 a_xp2 a_xn2 wp_ih_2_189 wn_ih_2_189 xhp189 xhn189 vdd vbsyn gsyn
Xn189 xhp189 xhn189 ahp189 ahn189 vdd vbneu dneuron
Xcm_xh190 xhp190 xhn190 vdd cmld
Rnd_xh190 xhp190 xhn190 20k
Cxh190p xhp190 0 1e-13
Cxh190n xhn190 0 1e-13
Xihx_0_190 a_xp0 a_xn0 wp_ih_0_190 wn_ih_0_190 xhp190 xhn190 vdd vbsyn gsyn
Xihx_1_190 a_xp1 a_xn1 wp_ih_1_190 wn_ih_1_190 xhp190 xhn190 vdd vbsyn gsyn
Xihx_2_190 a_xp2 a_xn2 wp_ih_2_190 wn_ih_2_190 xhp190 xhn190 vdd vbsyn gsyn
Xn190 xhp190 xhn190 ahp190 ahn190 vdd vbneu dneuron
Xcm_xh191 xhp191 xhn191 vdd cmld
Rnd_xh191 xhp191 xhn191 20k
Cxh191p xhp191 0 1e-13
Cxh191n xhn191 0 1e-13
Xihx_0_191 a_xp0 a_xn0 wp_ih_0_191 wn_ih_0_191 xhp191 xhn191 vdd vbsyn gsyn
Xihx_1_191 a_xp1 a_xn1 wp_ih_1_191 wn_ih_1_191 xhp191 xhn191 vdd vbsyn gsyn
Xihx_2_191 a_xp2 a_xn2 wp_ih_2_191 wn_ih_2_191 xhp191 xhn191 vdd vbsyn gsyn
Xn191 xhp191 xhn191 ahp191 ahn191 vdd vbneu dneuron
Xcm_xh192 xhp192 xhn192 vdd cmld
Rnd_xh192 xhp192 xhn192 20k
Cxh192p xhp192 0 1e-13
Cxh192n xhn192 0 1e-13
Xihx_0_192 a_xp0 a_xn0 wp_ih_0_192 wn_ih_0_192 xhp192 xhn192 vdd vbsyn gsyn
Xihx_1_192 a_xp1 a_xn1 wp_ih_1_192 wn_ih_1_192 xhp192 xhn192 vdd vbsyn gsyn
Xihx_2_192 a_xp2 a_xn2 wp_ih_2_192 wn_ih_2_192 xhp192 xhn192 vdd vbsyn gsyn
Xn192 xhp192 xhn192 ahp192 ahn192 vdd vbneu dneuron
Xcm_xh193 xhp193 xhn193 vdd cmld
Rnd_xh193 xhp193 xhn193 20k
Cxh193p xhp193 0 1e-13
Cxh193n xhn193 0 1e-13
Xihx_0_193 a_xp0 a_xn0 wp_ih_0_193 wn_ih_0_193 xhp193 xhn193 vdd vbsyn gsyn
Xihx_1_193 a_xp1 a_xn1 wp_ih_1_193 wn_ih_1_193 xhp193 xhn193 vdd vbsyn gsyn
Xihx_2_193 a_xp2 a_xn2 wp_ih_2_193 wn_ih_2_193 xhp193 xhn193 vdd vbsyn gsyn
Xn193 xhp193 xhn193 ahp193 ahn193 vdd vbneu dneuron
Xcm_xh194 xhp194 xhn194 vdd cmld
Rnd_xh194 xhp194 xhn194 20k
Cxh194p xhp194 0 1e-13
Cxh194n xhn194 0 1e-13
Xihx_0_194 a_xp0 a_xn0 wp_ih_0_194 wn_ih_0_194 xhp194 xhn194 vdd vbsyn gsyn
Xihx_1_194 a_xp1 a_xn1 wp_ih_1_194 wn_ih_1_194 xhp194 xhn194 vdd vbsyn gsyn
Xihx_2_194 a_xp2 a_xn2 wp_ih_2_194 wn_ih_2_194 xhp194 xhn194 vdd vbsyn gsyn
Xn194 xhp194 xhn194 ahp194 ahn194 vdd vbneu dneuron
Xcm_xh195 xhp195 xhn195 vdd cmld
Rnd_xh195 xhp195 xhn195 20k
Cxh195p xhp195 0 1e-13
Cxh195n xhn195 0 1e-13
Xihx_0_195 a_xp0 a_xn0 wp_ih_0_195 wn_ih_0_195 xhp195 xhn195 vdd vbsyn gsyn
Xihx_1_195 a_xp1 a_xn1 wp_ih_1_195 wn_ih_1_195 xhp195 xhn195 vdd vbsyn gsyn
Xihx_2_195 a_xp2 a_xn2 wp_ih_2_195 wn_ih_2_195 xhp195 xhn195 vdd vbsyn gsyn
Xn195 xhp195 xhn195 ahp195 ahn195 vdd vbneu dneuron
Xcm_xh196 xhp196 xhn196 vdd cmld
Rnd_xh196 xhp196 xhn196 20k
Cxh196p xhp196 0 1e-13
Cxh196n xhn196 0 1e-13
Xihx_0_196 a_xp0 a_xn0 wp_ih_0_196 wn_ih_0_196 xhp196 xhn196 vdd vbsyn gsyn
Xihx_1_196 a_xp1 a_xn1 wp_ih_1_196 wn_ih_1_196 xhp196 xhn196 vdd vbsyn gsyn
Xihx_2_196 a_xp2 a_xn2 wp_ih_2_196 wn_ih_2_196 xhp196 xhn196 vdd vbsyn gsyn
Xn196 xhp196 xhn196 ahp196 ahn196 vdd vbneu dneuron
Xcm_xh197 xhp197 xhn197 vdd cmld
Rnd_xh197 xhp197 xhn197 20k
Cxh197p xhp197 0 1e-13
Cxh197n xhn197 0 1e-13
Xihx_0_197 a_xp0 a_xn0 wp_ih_0_197 wn_ih_0_197 xhp197 xhn197 vdd vbsyn gsyn
Xihx_1_197 a_xp1 a_xn1 wp_ih_1_197 wn_ih_1_197 xhp197 xhn197 vdd vbsyn gsyn
Xihx_2_197 a_xp2 a_xn2 wp_ih_2_197 wn_ih_2_197 xhp197 xhn197 vdd vbsyn gsyn
Xn197 xhp197 xhn197 ahp197 ahn197 vdd vbneu dneuron
Xcm_xh198 xhp198 xhn198 vdd cmld
Rnd_xh198 xhp198 xhn198 20k
Cxh198p xhp198 0 1e-13
Cxh198n xhn198 0 1e-13
Xihx_0_198 a_xp0 a_xn0 wp_ih_0_198 wn_ih_0_198 xhp198 xhn198 vdd vbsyn gsyn
Xihx_1_198 a_xp1 a_xn1 wp_ih_1_198 wn_ih_1_198 xhp198 xhn198 vdd vbsyn gsyn
Xihx_2_198 a_xp2 a_xn2 wp_ih_2_198 wn_ih_2_198 xhp198 xhn198 vdd vbsyn gsyn
Xn198 xhp198 xhn198 ahp198 ahn198 vdd vbneu dneuron
Xcm_xh199 xhp199 xhn199 vdd cmld
Rnd_xh199 xhp199 xhn199 20k
Cxh199p xhp199 0 1e-13
Cxh199n xhn199 0 1e-13
Xihx_0_199 a_xp0 a_xn0 wp_ih_0_199 wn_ih_0_199 xhp199 xhn199 vdd vbsyn gsyn
Xihx_1_199 a_xp1 a_xn1 wp_ih_1_199 wn_ih_1_199 xhp199 xhn199 vdd vbsyn gsyn
Xihx_2_199 a_xp2 a_xn2 wp_ih_2_199 wn_ih_2_199 xhp199 xhn199 vdd vbsyn gsyn
Xn199 xhp199 xhn199 ahp199 ahn199 vdd vbneu dneuron
Xcm_mo0 mop0 mon0 vdd cmld
Rnd_mo0 mop0 mon0 20k
Cmo0p mop0 0 1e-13
Cmo0n mon0 0 1e-13
Xho_0_0 ahp0 ahn0 wp_ho_0_0 wn_ho_0_0 mop0 mon0 vdd vbsyn gsyn
Xho_1_0 ahp1 ahn1 wp_ho_1_0 wn_ho_1_0 mop0 mon0 vdd vbsyn gsyn
Xho_2_0 ahp2 ahn2 wp_ho_2_0 wn_ho_2_0 mop0 mon0 vdd vbsyn gsyn
Xho_3_0 ahp3 ahn3 wp_ho_3_0 wn_ho_3_0 mop0 mon0 vdd vbsyn gsyn
Xho_4_0 ahp4 ahn4 wp_ho_4_0 wn_ho_4_0 mop0 mon0 vdd vbsyn gsyn
Xho_5_0 ahp5 ahn5 wp_ho_5_0 wn_ho_5_0 mop0 mon0 vdd vbsyn gsyn
Xho_6_0 ahp6 ahn6 wp_ho_6_0 wn_ho_6_0 mop0 mon0 vdd vbsyn gsyn
Xho_7_0 ahp7 ahn7 wp_ho_7_0 wn_ho_7_0 mop0 mon0 vdd vbsyn gsyn
Xho_8_0 ahp8 ahn8 wp_ho_8_0 wn_ho_8_0 mop0 mon0 vdd vbsyn gsyn
Xho_9_0 ahp9 ahn9 wp_ho_9_0 wn_ho_9_0 mop0 mon0 vdd vbsyn gsyn
Xho_10_0 ahp10 ahn10 wp_ho_10_0 wn_ho_10_0 mop0 mon0 vdd vbsyn gsyn
Xho_11_0 ahp11 ahn11 wp_ho_11_0 wn_ho_11_0 mop0 mon0 vdd vbsyn gsyn
Xho_12_0 ahp12 ahn12 wp_ho_12_0 wn_ho_12_0 mop0 mon0 vdd vbsyn gsyn
Xho_13_0 ahp13 ahn13 wp_ho_13_0 wn_ho_13_0 mop0 mon0 vdd vbsyn gsyn
Xho_14_0 ahp14 ahn14 wp_ho_14_0 wn_ho_14_0 mop0 mon0 vdd vbsyn gsyn
Xho_15_0 ahp15 ahn15 wp_ho_15_0 wn_ho_15_0 mop0 mon0 vdd vbsyn gsyn
Xho_16_0 ahp16 ahn16 wp_ho_16_0 wn_ho_16_0 mop0 mon0 vdd vbsyn gsyn
Xho_17_0 ahp17 ahn17 wp_ho_17_0 wn_ho_17_0 mop0 mon0 vdd vbsyn gsyn
Xho_18_0 ahp18 ahn18 wp_ho_18_0 wn_ho_18_0 mop0 mon0 vdd vbsyn gsyn
Xho_19_0 ahp19 ahn19 wp_ho_19_0 wn_ho_19_0 mop0 mon0 vdd vbsyn gsyn
Xho_20_0 ahp20 ahn20 wp_ho_20_0 wn_ho_20_0 mop0 mon0 vdd vbsyn gsyn
Xho_21_0 ahp21 ahn21 wp_ho_21_0 wn_ho_21_0 mop0 mon0 vdd vbsyn gsyn
Xho_22_0 ahp22 ahn22 wp_ho_22_0 wn_ho_22_0 mop0 mon0 vdd vbsyn gsyn
Xho_23_0 ahp23 ahn23 wp_ho_23_0 wn_ho_23_0 mop0 mon0 vdd vbsyn gsyn
Xho_24_0 ahp24 ahn24 wp_ho_24_0 wn_ho_24_0 mop0 mon0 vdd vbsyn gsyn
Xho_25_0 ahp25 ahn25 wp_ho_25_0 wn_ho_25_0 mop0 mon0 vdd vbsyn gsyn
Xho_26_0 ahp26 ahn26 wp_ho_26_0 wn_ho_26_0 mop0 mon0 vdd vbsyn gsyn
Xho_27_0 ahp27 ahn27 wp_ho_27_0 wn_ho_27_0 mop0 mon0 vdd vbsyn gsyn
Xho_28_0 ahp28 ahn28 wp_ho_28_0 wn_ho_28_0 mop0 mon0 vdd vbsyn gsyn
Xho_29_0 ahp29 ahn29 wp_ho_29_0 wn_ho_29_0 mop0 mon0 vdd vbsyn gsyn
Xho_30_0 ahp30 ahn30 wp_ho_30_0 wn_ho_30_0 mop0 mon0 vdd vbsyn gsyn
Xho_31_0 ahp31 ahn31 wp_ho_31_0 wn_ho_31_0 mop0 mon0 vdd vbsyn gsyn
Xho_32_0 ahp32 ahn32 wp_ho_32_0 wn_ho_32_0 mop0 mon0 vdd vbsyn gsyn
Xho_33_0 ahp33 ahn33 wp_ho_33_0 wn_ho_33_0 mop0 mon0 vdd vbsyn gsyn
Xho_34_0 ahp34 ahn34 wp_ho_34_0 wn_ho_34_0 mop0 mon0 vdd vbsyn gsyn
Xho_35_0 ahp35 ahn35 wp_ho_35_0 wn_ho_35_0 mop0 mon0 vdd vbsyn gsyn
Xho_36_0 ahp36 ahn36 wp_ho_36_0 wn_ho_36_0 mop0 mon0 vdd vbsyn gsyn
Xho_37_0 ahp37 ahn37 wp_ho_37_0 wn_ho_37_0 mop0 mon0 vdd vbsyn gsyn
Xho_38_0 ahp38 ahn38 wp_ho_38_0 wn_ho_38_0 mop0 mon0 vdd vbsyn gsyn
Xho_39_0 ahp39 ahn39 wp_ho_39_0 wn_ho_39_0 mop0 mon0 vdd vbsyn gsyn
Xho_40_0 ahp40 ahn40 wp_ho_40_0 wn_ho_40_0 mop0 mon0 vdd vbsyn gsyn
Xho_41_0 ahp41 ahn41 wp_ho_41_0 wn_ho_41_0 mop0 mon0 vdd vbsyn gsyn
Xho_42_0 ahp42 ahn42 wp_ho_42_0 wn_ho_42_0 mop0 mon0 vdd vbsyn gsyn
Xho_43_0 ahp43 ahn43 wp_ho_43_0 wn_ho_43_0 mop0 mon0 vdd vbsyn gsyn
Xho_44_0 ahp44 ahn44 wp_ho_44_0 wn_ho_44_0 mop0 mon0 vdd vbsyn gsyn
Xho_45_0 ahp45 ahn45 wp_ho_45_0 wn_ho_45_0 mop0 mon0 vdd vbsyn gsyn
Xho_46_0 ahp46 ahn46 wp_ho_46_0 wn_ho_46_0 mop0 mon0 vdd vbsyn gsyn
Xho_47_0 ahp47 ahn47 wp_ho_47_0 wn_ho_47_0 mop0 mon0 vdd vbsyn gsyn
Xho_48_0 ahp48 ahn48 wp_ho_48_0 wn_ho_48_0 mop0 mon0 vdd vbsyn gsyn
Xho_49_0 ahp49 ahn49 wp_ho_49_0 wn_ho_49_0 mop0 mon0 vdd vbsyn gsyn
Xho_50_0 ahp50 ahn50 wp_ho_50_0 wn_ho_50_0 mop0 mon0 vdd vbsyn gsyn
Xho_51_0 ahp51 ahn51 wp_ho_51_0 wn_ho_51_0 mop0 mon0 vdd vbsyn gsyn
Xho_52_0 ahp52 ahn52 wp_ho_52_0 wn_ho_52_0 mop0 mon0 vdd vbsyn gsyn
Xho_53_0 ahp53 ahn53 wp_ho_53_0 wn_ho_53_0 mop0 mon0 vdd vbsyn gsyn
Xho_54_0 ahp54 ahn54 wp_ho_54_0 wn_ho_54_0 mop0 mon0 vdd vbsyn gsyn
Xho_55_0 ahp55 ahn55 wp_ho_55_0 wn_ho_55_0 mop0 mon0 vdd vbsyn gsyn
Xho_56_0 ahp56 ahn56 wp_ho_56_0 wn_ho_56_0 mop0 mon0 vdd vbsyn gsyn
Xho_57_0 ahp57 ahn57 wp_ho_57_0 wn_ho_57_0 mop0 mon0 vdd vbsyn gsyn
Xho_58_0 ahp58 ahn58 wp_ho_58_0 wn_ho_58_0 mop0 mon0 vdd vbsyn gsyn
Xho_59_0 ahp59 ahn59 wp_ho_59_0 wn_ho_59_0 mop0 mon0 vdd vbsyn gsyn
Xho_60_0 ahp60 ahn60 wp_ho_60_0 wn_ho_60_0 mop0 mon0 vdd vbsyn gsyn
Xho_61_0 ahp61 ahn61 wp_ho_61_0 wn_ho_61_0 mop0 mon0 vdd vbsyn gsyn
Xho_62_0 ahp62 ahn62 wp_ho_62_0 wn_ho_62_0 mop0 mon0 vdd vbsyn gsyn
Xho_63_0 ahp63 ahn63 wp_ho_63_0 wn_ho_63_0 mop0 mon0 vdd vbsyn gsyn
Xho_64_0 ahp64 ahn64 wp_ho_64_0 wn_ho_64_0 mop0 mon0 vdd vbsyn gsyn
Xho_65_0 ahp65 ahn65 wp_ho_65_0 wn_ho_65_0 mop0 mon0 vdd vbsyn gsyn
Xho_66_0 ahp66 ahn66 wp_ho_66_0 wn_ho_66_0 mop0 mon0 vdd vbsyn gsyn
Xho_67_0 ahp67 ahn67 wp_ho_67_0 wn_ho_67_0 mop0 mon0 vdd vbsyn gsyn
Xho_68_0 ahp68 ahn68 wp_ho_68_0 wn_ho_68_0 mop0 mon0 vdd vbsyn gsyn
Xho_69_0 ahp69 ahn69 wp_ho_69_0 wn_ho_69_0 mop0 mon0 vdd vbsyn gsyn
Xho_70_0 ahp70 ahn70 wp_ho_70_0 wn_ho_70_0 mop0 mon0 vdd vbsyn gsyn
Xho_71_0 ahp71 ahn71 wp_ho_71_0 wn_ho_71_0 mop0 mon0 vdd vbsyn gsyn
Xho_72_0 ahp72 ahn72 wp_ho_72_0 wn_ho_72_0 mop0 mon0 vdd vbsyn gsyn
Xho_73_0 ahp73 ahn73 wp_ho_73_0 wn_ho_73_0 mop0 mon0 vdd vbsyn gsyn
Xho_74_0 ahp74 ahn74 wp_ho_74_0 wn_ho_74_0 mop0 mon0 vdd vbsyn gsyn
Xho_75_0 ahp75 ahn75 wp_ho_75_0 wn_ho_75_0 mop0 mon0 vdd vbsyn gsyn
Xho_76_0 ahp76 ahn76 wp_ho_76_0 wn_ho_76_0 mop0 mon0 vdd vbsyn gsyn
Xho_77_0 ahp77 ahn77 wp_ho_77_0 wn_ho_77_0 mop0 mon0 vdd vbsyn gsyn
Xho_78_0 ahp78 ahn78 wp_ho_78_0 wn_ho_78_0 mop0 mon0 vdd vbsyn gsyn
Xho_79_0 ahp79 ahn79 wp_ho_79_0 wn_ho_79_0 mop0 mon0 vdd vbsyn gsyn
Xho_80_0 ahp80 ahn80 wp_ho_80_0 wn_ho_80_0 mop0 mon0 vdd vbsyn gsyn
Xho_81_0 ahp81 ahn81 wp_ho_81_0 wn_ho_81_0 mop0 mon0 vdd vbsyn gsyn
Xho_82_0 ahp82 ahn82 wp_ho_82_0 wn_ho_82_0 mop0 mon0 vdd vbsyn gsyn
Xho_83_0 ahp83 ahn83 wp_ho_83_0 wn_ho_83_0 mop0 mon0 vdd vbsyn gsyn
Xho_84_0 ahp84 ahn84 wp_ho_84_0 wn_ho_84_0 mop0 mon0 vdd vbsyn gsyn
Xho_85_0 ahp85 ahn85 wp_ho_85_0 wn_ho_85_0 mop0 mon0 vdd vbsyn gsyn
Xho_86_0 ahp86 ahn86 wp_ho_86_0 wn_ho_86_0 mop0 mon0 vdd vbsyn gsyn
Xho_87_0 ahp87 ahn87 wp_ho_87_0 wn_ho_87_0 mop0 mon0 vdd vbsyn gsyn
Xho_88_0 ahp88 ahn88 wp_ho_88_0 wn_ho_88_0 mop0 mon0 vdd vbsyn gsyn
Xho_89_0 ahp89 ahn89 wp_ho_89_0 wn_ho_89_0 mop0 mon0 vdd vbsyn gsyn
Xho_90_0 ahp90 ahn90 wp_ho_90_0 wn_ho_90_0 mop0 mon0 vdd vbsyn gsyn
Xho_91_0 ahp91 ahn91 wp_ho_91_0 wn_ho_91_0 mop0 mon0 vdd vbsyn gsyn
Xho_92_0 ahp92 ahn92 wp_ho_92_0 wn_ho_92_0 mop0 mon0 vdd vbsyn gsyn
Xho_93_0 ahp93 ahn93 wp_ho_93_0 wn_ho_93_0 mop0 mon0 vdd vbsyn gsyn
Xho_94_0 ahp94 ahn94 wp_ho_94_0 wn_ho_94_0 mop0 mon0 vdd vbsyn gsyn
Xho_95_0 ahp95 ahn95 wp_ho_95_0 wn_ho_95_0 mop0 mon0 vdd vbsyn gsyn
Xho_96_0 ahp96 ahn96 wp_ho_96_0 wn_ho_96_0 mop0 mon0 vdd vbsyn gsyn
Xho_97_0 ahp97 ahn97 wp_ho_97_0 wn_ho_97_0 mop0 mon0 vdd vbsyn gsyn
Xho_98_0 ahp98 ahn98 wp_ho_98_0 wn_ho_98_0 mop0 mon0 vdd vbsyn gsyn
Xho_99_0 ahp99 ahn99 wp_ho_99_0 wn_ho_99_0 mop0 mon0 vdd vbsyn gsyn
Xho_100_0 ahp100 ahn100 wp_ho_100_0 wn_ho_100_0 mop0 mon0 vdd vbsyn gsyn
Xho_101_0 ahp101 ahn101 wp_ho_101_0 wn_ho_101_0 mop0 mon0 vdd vbsyn gsyn
Xho_102_0 ahp102 ahn102 wp_ho_102_0 wn_ho_102_0 mop0 mon0 vdd vbsyn gsyn
Xho_103_0 ahp103 ahn103 wp_ho_103_0 wn_ho_103_0 mop0 mon0 vdd vbsyn gsyn
Xho_104_0 ahp104 ahn104 wp_ho_104_0 wn_ho_104_0 mop0 mon0 vdd vbsyn gsyn
Xho_105_0 ahp105 ahn105 wp_ho_105_0 wn_ho_105_0 mop0 mon0 vdd vbsyn gsyn
Xho_106_0 ahp106 ahn106 wp_ho_106_0 wn_ho_106_0 mop0 mon0 vdd vbsyn gsyn
Xho_107_0 ahp107 ahn107 wp_ho_107_0 wn_ho_107_0 mop0 mon0 vdd vbsyn gsyn
Xho_108_0 ahp108 ahn108 wp_ho_108_0 wn_ho_108_0 mop0 mon0 vdd vbsyn gsyn
Xho_109_0 ahp109 ahn109 wp_ho_109_0 wn_ho_109_0 mop0 mon0 vdd vbsyn gsyn
Xho_110_0 ahp110 ahn110 wp_ho_110_0 wn_ho_110_0 mop0 mon0 vdd vbsyn gsyn
Xho_111_0 ahp111 ahn111 wp_ho_111_0 wn_ho_111_0 mop0 mon0 vdd vbsyn gsyn
Xho_112_0 ahp112 ahn112 wp_ho_112_0 wn_ho_112_0 mop0 mon0 vdd vbsyn gsyn
Xho_113_0 ahp113 ahn113 wp_ho_113_0 wn_ho_113_0 mop0 mon0 vdd vbsyn gsyn
Xho_114_0 ahp114 ahn114 wp_ho_114_0 wn_ho_114_0 mop0 mon0 vdd vbsyn gsyn
Xho_115_0 ahp115 ahn115 wp_ho_115_0 wn_ho_115_0 mop0 mon0 vdd vbsyn gsyn
Xho_116_0 ahp116 ahn116 wp_ho_116_0 wn_ho_116_0 mop0 mon0 vdd vbsyn gsyn
Xho_117_0 ahp117 ahn117 wp_ho_117_0 wn_ho_117_0 mop0 mon0 vdd vbsyn gsyn
Xho_118_0 ahp118 ahn118 wp_ho_118_0 wn_ho_118_0 mop0 mon0 vdd vbsyn gsyn
Xho_119_0 ahp119 ahn119 wp_ho_119_0 wn_ho_119_0 mop0 mon0 vdd vbsyn gsyn
Xho_120_0 ahp120 ahn120 wp_ho_120_0 wn_ho_120_0 mop0 mon0 vdd vbsyn gsyn
Xho_121_0 ahp121 ahn121 wp_ho_121_0 wn_ho_121_0 mop0 mon0 vdd vbsyn gsyn
Xho_122_0 ahp122 ahn122 wp_ho_122_0 wn_ho_122_0 mop0 mon0 vdd vbsyn gsyn
Xho_123_0 ahp123 ahn123 wp_ho_123_0 wn_ho_123_0 mop0 mon0 vdd vbsyn gsyn
Xho_124_0 ahp124 ahn124 wp_ho_124_0 wn_ho_124_0 mop0 mon0 vdd vbsyn gsyn
Xho_125_0 ahp125 ahn125 wp_ho_125_0 wn_ho_125_0 mop0 mon0 vdd vbsyn gsyn
Xho_126_0 ahp126 ahn126 wp_ho_126_0 wn_ho_126_0 mop0 mon0 vdd vbsyn gsyn
Xho_127_0 ahp127 ahn127 wp_ho_127_0 wn_ho_127_0 mop0 mon0 vdd vbsyn gsyn
Xho_128_0 ahp128 ahn128 wp_ho_128_0 wn_ho_128_0 mop0 mon0 vdd vbsyn gsyn
Xho_129_0 ahp129 ahn129 wp_ho_129_0 wn_ho_129_0 mop0 mon0 vdd vbsyn gsyn
Xho_130_0 ahp130 ahn130 wp_ho_130_0 wn_ho_130_0 mop0 mon0 vdd vbsyn gsyn
Xho_131_0 ahp131 ahn131 wp_ho_131_0 wn_ho_131_0 mop0 mon0 vdd vbsyn gsyn
Xho_132_0 ahp132 ahn132 wp_ho_132_0 wn_ho_132_0 mop0 mon0 vdd vbsyn gsyn
Xho_133_0 ahp133 ahn133 wp_ho_133_0 wn_ho_133_0 mop0 mon0 vdd vbsyn gsyn
Xho_134_0 ahp134 ahn134 wp_ho_134_0 wn_ho_134_0 mop0 mon0 vdd vbsyn gsyn
Xho_135_0 ahp135 ahn135 wp_ho_135_0 wn_ho_135_0 mop0 mon0 vdd vbsyn gsyn
Xho_136_0 ahp136 ahn136 wp_ho_136_0 wn_ho_136_0 mop0 mon0 vdd vbsyn gsyn
Xho_137_0 ahp137 ahn137 wp_ho_137_0 wn_ho_137_0 mop0 mon0 vdd vbsyn gsyn
Xho_138_0 ahp138 ahn138 wp_ho_138_0 wn_ho_138_0 mop0 mon0 vdd vbsyn gsyn
Xho_139_0 ahp139 ahn139 wp_ho_139_0 wn_ho_139_0 mop0 mon0 vdd vbsyn gsyn
Xho_140_0 ahp140 ahn140 wp_ho_140_0 wn_ho_140_0 mop0 mon0 vdd vbsyn gsyn
Xho_141_0 ahp141 ahn141 wp_ho_141_0 wn_ho_141_0 mop0 mon0 vdd vbsyn gsyn
Xho_142_0 ahp142 ahn142 wp_ho_142_0 wn_ho_142_0 mop0 mon0 vdd vbsyn gsyn
Xho_143_0 ahp143 ahn143 wp_ho_143_0 wn_ho_143_0 mop0 mon0 vdd vbsyn gsyn
Xho_144_0 ahp144 ahn144 wp_ho_144_0 wn_ho_144_0 mop0 mon0 vdd vbsyn gsyn
Xho_145_0 ahp145 ahn145 wp_ho_145_0 wn_ho_145_0 mop0 mon0 vdd vbsyn gsyn
Xho_146_0 ahp146 ahn146 wp_ho_146_0 wn_ho_146_0 mop0 mon0 vdd vbsyn gsyn
Xho_147_0 ahp147 ahn147 wp_ho_147_0 wn_ho_147_0 mop0 mon0 vdd vbsyn gsyn
Xho_148_0 ahp148 ahn148 wp_ho_148_0 wn_ho_148_0 mop0 mon0 vdd vbsyn gsyn
Xho_149_0 ahp149 ahn149 wp_ho_149_0 wn_ho_149_0 mop0 mon0 vdd vbsyn gsyn
Xho_150_0 ahp150 ahn150 wp_ho_150_0 wn_ho_150_0 mop0 mon0 vdd vbsyn gsyn
Xho_151_0 ahp151 ahn151 wp_ho_151_0 wn_ho_151_0 mop0 mon0 vdd vbsyn gsyn
Xho_152_0 ahp152 ahn152 wp_ho_152_0 wn_ho_152_0 mop0 mon0 vdd vbsyn gsyn
Xho_153_0 ahp153 ahn153 wp_ho_153_0 wn_ho_153_0 mop0 mon0 vdd vbsyn gsyn
Xho_154_0 ahp154 ahn154 wp_ho_154_0 wn_ho_154_0 mop0 mon0 vdd vbsyn gsyn
Xho_155_0 ahp155 ahn155 wp_ho_155_0 wn_ho_155_0 mop0 mon0 vdd vbsyn gsyn
Xho_156_0 ahp156 ahn156 wp_ho_156_0 wn_ho_156_0 mop0 mon0 vdd vbsyn gsyn
Xho_157_0 ahp157 ahn157 wp_ho_157_0 wn_ho_157_0 mop0 mon0 vdd vbsyn gsyn
Xho_158_0 ahp158 ahn158 wp_ho_158_0 wn_ho_158_0 mop0 mon0 vdd vbsyn gsyn
Xho_159_0 ahp159 ahn159 wp_ho_159_0 wn_ho_159_0 mop0 mon0 vdd vbsyn gsyn
Xho_160_0 ahp160 ahn160 wp_ho_160_0 wn_ho_160_0 mop0 mon0 vdd vbsyn gsyn
Xho_161_0 ahp161 ahn161 wp_ho_161_0 wn_ho_161_0 mop0 mon0 vdd vbsyn gsyn
Xho_162_0 ahp162 ahn162 wp_ho_162_0 wn_ho_162_0 mop0 mon0 vdd vbsyn gsyn
Xho_163_0 ahp163 ahn163 wp_ho_163_0 wn_ho_163_0 mop0 mon0 vdd vbsyn gsyn
Xho_164_0 ahp164 ahn164 wp_ho_164_0 wn_ho_164_0 mop0 mon0 vdd vbsyn gsyn
Xho_165_0 ahp165 ahn165 wp_ho_165_0 wn_ho_165_0 mop0 mon0 vdd vbsyn gsyn
Xho_166_0 ahp166 ahn166 wp_ho_166_0 wn_ho_166_0 mop0 mon0 vdd vbsyn gsyn
Xho_167_0 ahp167 ahn167 wp_ho_167_0 wn_ho_167_0 mop0 mon0 vdd vbsyn gsyn
Xho_168_0 ahp168 ahn168 wp_ho_168_0 wn_ho_168_0 mop0 mon0 vdd vbsyn gsyn
Xho_169_0 ahp169 ahn169 wp_ho_169_0 wn_ho_169_0 mop0 mon0 vdd vbsyn gsyn
Xho_170_0 ahp170 ahn170 wp_ho_170_0 wn_ho_170_0 mop0 mon0 vdd vbsyn gsyn
Xho_171_0 ahp171 ahn171 wp_ho_171_0 wn_ho_171_0 mop0 mon0 vdd vbsyn gsyn
Xho_172_0 ahp172 ahn172 wp_ho_172_0 wn_ho_172_0 mop0 mon0 vdd vbsyn gsyn
Xho_173_0 ahp173 ahn173 wp_ho_173_0 wn_ho_173_0 mop0 mon0 vdd vbsyn gsyn
Xho_174_0 ahp174 ahn174 wp_ho_174_0 wn_ho_174_0 mop0 mon0 vdd vbsyn gsyn
Xho_175_0 ahp175 ahn175 wp_ho_175_0 wn_ho_175_0 mop0 mon0 vdd vbsyn gsyn
Xho_176_0 ahp176 ahn176 wp_ho_176_0 wn_ho_176_0 mop0 mon0 vdd vbsyn gsyn
Xho_177_0 ahp177 ahn177 wp_ho_177_0 wn_ho_177_0 mop0 mon0 vdd vbsyn gsyn
Xho_178_0 ahp178 ahn178 wp_ho_178_0 wn_ho_178_0 mop0 mon0 vdd vbsyn gsyn
Xho_179_0 ahp179 ahn179 wp_ho_179_0 wn_ho_179_0 mop0 mon0 vdd vbsyn gsyn
Xho_180_0 ahp180 ahn180 wp_ho_180_0 wn_ho_180_0 mop0 mon0 vdd vbsyn gsyn
Xho_181_0 ahp181 ahn181 wp_ho_181_0 wn_ho_181_0 mop0 mon0 vdd vbsyn gsyn
Xho_182_0 ahp182 ahn182 wp_ho_182_0 wn_ho_182_0 mop0 mon0 vdd vbsyn gsyn
Xho_183_0 ahp183 ahn183 wp_ho_183_0 wn_ho_183_0 mop0 mon0 vdd vbsyn gsyn
Xho_184_0 ahp184 ahn184 wp_ho_184_0 wn_ho_184_0 mop0 mon0 vdd vbsyn gsyn
Xho_185_0 ahp185 ahn185 wp_ho_185_0 wn_ho_185_0 mop0 mon0 vdd vbsyn gsyn
Xho_186_0 ahp186 ahn186 wp_ho_186_0 wn_ho_186_0 mop0 mon0 vdd vbsyn gsyn
Xho_187_0 ahp187 ahn187 wp_ho_187_0 wn_ho_187_0 mop0 mon0 vdd vbsyn gsyn
Xho_188_0 ahp188 ahn188 wp_ho_188_0 wn_ho_188_0 mop0 mon0 vdd vbsyn gsyn
Xho_189_0 ahp189 ahn189 wp_ho_189_0 wn_ho_189_0 mop0 mon0 vdd vbsyn gsyn
Xho_190_0 ahp190 ahn190 wp_ho_190_0 wn_ho_190_0 mop0 mon0 vdd vbsyn gsyn
Xho_191_0 ahp191 ahn191 wp_ho_191_0 wn_ho_191_0 mop0 mon0 vdd vbsyn gsyn
Xho_192_0 ahp192 ahn192 wp_ho_192_0 wn_ho_192_0 mop0 mon0 vdd vbsyn gsyn
Xho_193_0 ahp193 ahn193 wp_ho_193_0 wn_ho_193_0 mop0 mon0 vdd vbsyn gsyn
Xho_194_0 ahp194 ahn194 wp_ho_194_0 wn_ho_194_0 mop0 mon0 vdd vbsyn gsyn
Xho_195_0 ahp195 ahn195 wp_ho_195_0 wn_ho_195_0 mop0 mon0 vdd vbsyn gsyn
Xho_196_0 ahp196 ahn196 wp_ho_196_0 wn_ho_196_0 mop0 mon0 vdd vbsyn gsyn
Xho_197_0 ahp197 ahn197 wp_ho_197_0 wn_ho_197_0 mop0 mon0 vdd vbsyn gsyn
Xho_198_0 ahp198 ahn198 wp_ho_198_0 wn_ho_198_0 mop0 mon0 vdd vbsyn gsyn
Xho_199_0 ahp199 ahn199 wp_ho_199_0 wn_ho_199_0 mop0 mon0 vdd vbsyn gsyn
Xcm_mo1 mop1 mon1 vdd cmld
Rnd_mo1 mop1 mon1 20k
Cmo1p mop1 0 1e-13
Cmo1n mon1 0 1e-13
Xho_0_1 ahp0 ahn0 wp_ho_0_1 wn_ho_0_1 mop1 mon1 vdd vbsyn gsyn
Xho_1_1 ahp1 ahn1 wp_ho_1_1 wn_ho_1_1 mop1 mon1 vdd vbsyn gsyn
Xho_2_1 ahp2 ahn2 wp_ho_2_1 wn_ho_2_1 mop1 mon1 vdd vbsyn gsyn
Xho_3_1 ahp3 ahn3 wp_ho_3_1 wn_ho_3_1 mop1 mon1 vdd vbsyn gsyn
Xho_4_1 ahp4 ahn4 wp_ho_4_1 wn_ho_4_1 mop1 mon1 vdd vbsyn gsyn
Xho_5_1 ahp5 ahn5 wp_ho_5_1 wn_ho_5_1 mop1 mon1 vdd vbsyn gsyn
Xho_6_1 ahp6 ahn6 wp_ho_6_1 wn_ho_6_1 mop1 mon1 vdd vbsyn gsyn
Xho_7_1 ahp7 ahn7 wp_ho_7_1 wn_ho_7_1 mop1 mon1 vdd vbsyn gsyn
Xho_8_1 ahp8 ahn8 wp_ho_8_1 wn_ho_8_1 mop1 mon1 vdd vbsyn gsyn
Xho_9_1 ahp9 ahn9 wp_ho_9_1 wn_ho_9_1 mop1 mon1 vdd vbsyn gsyn
Xho_10_1 ahp10 ahn10 wp_ho_10_1 wn_ho_10_1 mop1 mon1 vdd vbsyn gsyn
Xho_11_1 ahp11 ahn11 wp_ho_11_1 wn_ho_11_1 mop1 mon1 vdd vbsyn gsyn
Xho_12_1 ahp12 ahn12 wp_ho_12_1 wn_ho_12_1 mop1 mon1 vdd vbsyn gsyn
Xho_13_1 ahp13 ahn13 wp_ho_13_1 wn_ho_13_1 mop1 mon1 vdd vbsyn gsyn
Xho_14_1 ahp14 ahn14 wp_ho_14_1 wn_ho_14_1 mop1 mon1 vdd vbsyn gsyn
Xho_15_1 ahp15 ahn15 wp_ho_15_1 wn_ho_15_1 mop1 mon1 vdd vbsyn gsyn
Xho_16_1 ahp16 ahn16 wp_ho_16_1 wn_ho_16_1 mop1 mon1 vdd vbsyn gsyn
Xho_17_1 ahp17 ahn17 wp_ho_17_1 wn_ho_17_1 mop1 mon1 vdd vbsyn gsyn
Xho_18_1 ahp18 ahn18 wp_ho_18_1 wn_ho_18_1 mop1 mon1 vdd vbsyn gsyn
Xho_19_1 ahp19 ahn19 wp_ho_19_1 wn_ho_19_1 mop1 mon1 vdd vbsyn gsyn
Xho_20_1 ahp20 ahn20 wp_ho_20_1 wn_ho_20_1 mop1 mon1 vdd vbsyn gsyn
Xho_21_1 ahp21 ahn21 wp_ho_21_1 wn_ho_21_1 mop1 mon1 vdd vbsyn gsyn
Xho_22_1 ahp22 ahn22 wp_ho_22_1 wn_ho_22_1 mop1 mon1 vdd vbsyn gsyn
Xho_23_1 ahp23 ahn23 wp_ho_23_1 wn_ho_23_1 mop1 mon1 vdd vbsyn gsyn
Xho_24_1 ahp24 ahn24 wp_ho_24_1 wn_ho_24_1 mop1 mon1 vdd vbsyn gsyn
Xho_25_1 ahp25 ahn25 wp_ho_25_1 wn_ho_25_1 mop1 mon1 vdd vbsyn gsyn
Xho_26_1 ahp26 ahn26 wp_ho_26_1 wn_ho_26_1 mop1 mon1 vdd vbsyn gsyn
Xho_27_1 ahp27 ahn27 wp_ho_27_1 wn_ho_27_1 mop1 mon1 vdd vbsyn gsyn
Xho_28_1 ahp28 ahn28 wp_ho_28_1 wn_ho_28_1 mop1 mon1 vdd vbsyn gsyn
Xho_29_1 ahp29 ahn29 wp_ho_29_1 wn_ho_29_1 mop1 mon1 vdd vbsyn gsyn
Xho_30_1 ahp30 ahn30 wp_ho_30_1 wn_ho_30_1 mop1 mon1 vdd vbsyn gsyn
Xho_31_1 ahp31 ahn31 wp_ho_31_1 wn_ho_31_1 mop1 mon1 vdd vbsyn gsyn
Xho_32_1 ahp32 ahn32 wp_ho_32_1 wn_ho_32_1 mop1 mon1 vdd vbsyn gsyn
Xho_33_1 ahp33 ahn33 wp_ho_33_1 wn_ho_33_1 mop1 mon1 vdd vbsyn gsyn
Xho_34_1 ahp34 ahn34 wp_ho_34_1 wn_ho_34_1 mop1 mon1 vdd vbsyn gsyn
Xho_35_1 ahp35 ahn35 wp_ho_35_1 wn_ho_35_1 mop1 mon1 vdd vbsyn gsyn
Xho_36_1 ahp36 ahn36 wp_ho_36_1 wn_ho_36_1 mop1 mon1 vdd vbsyn gsyn
Xho_37_1 ahp37 ahn37 wp_ho_37_1 wn_ho_37_1 mop1 mon1 vdd vbsyn gsyn
Xho_38_1 ahp38 ahn38 wp_ho_38_1 wn_ho_38_1 mop1 mon1 vdd vbsyn gsyn
Xho_39_1 ahp39 ahn39 wp_ho_39_1 wn_ho_39_1 mop1 mon1 vdd vbsyn gsyn
Xho_40_1 ahp40 ahn40 wp_ho_40_1 wn_ho_40_1 mop1 mon1 vdd vbsyn gsyn
Xho_41_1 ahp41 ahn41 wp_ho_41_1 wn_ho_41_1 mop1 mon1 vdd vbsyn gsyn
Xho_42_1 ahp42 ahn42 wp_ho_42_1 wn_ho_42_1 mop1 mon1 vdd vbsyn gsyn
Xho_43_1 ahp43 ahn43 wp_ho_43_1 wn_ho_43_1 mop1 mon1 vdd vbsyn gsyn
Xho_44_1 ahp44 ahn44 wp_ho_44_1 wn_ho_44_1 mop1 mon1 vdd vbsyn gsyn
Xho_45_1 ahp45 ahn45 wp_ho_45_1 wn_ho_45_1 mop1 mon1 vdd vbsyn gsyn
Xho_46_1 ahp46 ahn46 wp_ho_46_1 wn_ho_46_1 mop1 mon1 vdd vbsyn gsyn
Xho_47_1 ahp47 ahn47 wp_ho_47_1 wn_ho_47_1 mop1 mon1 vdd vbsyn gsyn
Xho_48_1 ahp48 ahn48 wp_ho_48_1 wn_ho_48_1 mop1 mon1 vdd vbsyn gsyn
Xho_49_1 ahp49 ahn49 wp_ho_49_1 wn_ho_49_1 mop1 mon1 vdd vbsyn gsyn
Xho_50_1 ahp50 ahn50 wp_ho_50_1 wn_ho_50_1 mop1 mon1 vdd vbsyn gsyn
Xho_51_1 ahp51 ahn51 wp_ho_51_1 wn_ho_51_1 mop1 mon1 vdd vbsyn gsyn
Xho_52_1 ahp52 ahn52 wp_ho_52_1 wn_ho_52_1 mop1 mon1 vdd vbsyn gsyn
Xho_53_1 ahp53 ahn53 wp_ho_53_1 wn_ho_53_1 mop1 mon1 vdd vbsyn gsyn
Xho_54_1 ahp54 ahn54 wp_ho_54_1 wn_ho_54_1 mop1 mon1 vdd vbsyn gsyn
Xho_55_1 ahp55 ahn55 wp_ho_55_1 wn_ho_55_1 mop1 mon1 vdd vbsyn gsyn
Xho_56_1 ahp56 ahn56 wp_ho_56_1 wn_ho_56_1 mop1 mon1 vdd vbsyn gsyn
Xho_57_1 ahp57 ahn57 wp_ho_57_1 wn_ho_57_1 mop1 mon1 vdd vbsyn gsyn
Xho_58_1 ahp58 ahn58 wp_ho_58_1 wn_ho_58_1 mop1 mon1 vdd vbsyn gsyn
Xho_59_1 ahp59 ahn59 wp_ho_59_1 wn_ho_59_1 mop1 mon1 vdd vbsyn gsyn
Xho_60_1 ahp60 ahn60 wp_ho_60_1 wn_ho_60_1 mop1 mon1 vdd vbsyn gsyn
Xho_61_1 ahp61 ahn61 wp_ho_61_1 wn_ho_61_1 mop1 mon1 vdd vbsyn gsyn
Xho_62_1 ahp62 ahn62 wp_ho_62_1 wn_ho_62_1 mop1 mon1 vdd vbsyn gsyn
Xho_63_1 ahp63 ahn63 wp_ho_63_1 wn_ho_63_1 mop1 mon1 vdd vbsyn gsyn
Xho_64_1 ahp64 ahn64 wp_ho_64_1 wn_ho_64_1 mop1 mon1 vdd vbsyn gsyn
Xho_65_1 ahp65 ahn65 wp_ho_65_1 wn_ho_65_1 mop1 mon1 vdd vbsyn gsyn
Xho_66_1 ahp66 ahn66 wp_ho_66_1 wn_ho_66_1 mop1 mon1 vdd vbsyn gsyn
Xho_67_1 ahp67 ahn67 wp_ho_67_1 wn_ho_67_1 mop1 mon1 vdd vbsyn gsyn
Xho_68_1 ahp68 ahn68 wp_ho_68_1 wn_ho_68_1 mop1 mon1 vdd vbsyn gsyn
Xho_69_1 ahp69 ahn69 wp_ho_69_1 wn_ho_69_1 mop1 mon1 vdd vbsyn gsyn
Xho_70_1 ahp70 ahn70 wp_ho_70_1 wn_ho_70_1 mop1 mon1 vdd vbsyn gsyn
Xho_71_1 ahp71 ahn71 wp_ho_71_1 wn_ho_71_1 mop1 mon1 vdd vbsyn gsyn
Xho_72_1 ahp72 ahn72 wp_ho_72_1 wn_ho_72_1 mop1 mon1 vdd vbsyn gsyn
Xho_73_1 ahp73 ahn73 wp_ho_73_1 wn_ho_73_1 mop1 mon1 vdd vbsyn gsyn
Xho_74_1 ahp74 ahn74 wp_ho_74_1 wn_ho_74_1 mop1 mon1 vdd vbsyn gsyn
Xho_75_1 ahp75 ahn75 wp_ho_75_1 wn_ho_75_1 mop1 mon1 vdd vbsyn gsyn
Xho_76_1 ahp76 ahn76 wp_ho_76_1 wn_ho_76_1 mop1 mon1 vdd vbsyn gsyn
Xho_77_1 ahp77 ahn77 wp_ho_77_1 wn_ho_77_1 mop1 mon1 vdd vbsyn gsyn
Xho_78_1 ahp78 ahn78 wp_ho_78_1 wn_ho_78_1 mop1 mon1 vdd vbsyn gsyn
Xho_79_1 ahp79 ahn79 wp_ho_79_1 wn_ho_79_1 mop1 mon1 vdd vbsyn gsyn
Xho_80_1 ahp80 ahn80 wp_ho_80_1 wn_ho_80_1 mop1 mon1 vdd vbsyn gsyn
Xho_81_1 ahp81 ahn81 wp_ho_81_1 wn_ho_81_1 mop1 mon1 vdd vbsyn gsyn
Xho_82_1 ahp82 ahn82 wp_ho_82_1 wn_ho_82_1 mop1 mon1 vdd vbsyn gsyn
Xho_83_1 ahp83 ahn83 wp_ho_83_1 wn_ho_83_1 mop1 mon1 vdd vbsyn gsyn
Xho_84_1 ahp84 ahn84 wp_ho_84_1 wn_ho_84_1 mop1 mon1 vdd vbsyn gsyn
Xho_85_1 ahp85 ahn85 wp_ho_85_1 wn_ho_85_1 mop1 mon1 vdd vbsyn gsyn
Xho_86_1 ahp86 ahn86 wp_ho_86_1 wn_ho_86_1 mop1 mon1 vdd vbsyn gsyn
Xho_87_1 ahp87 ahn87 wp_ho_87_1 wn_ho_87_1 mop1 mon1 vdd vbsyn gsyn
Xho_88_1 ahp88 ahn88 wp_ho_88_1 wn_ho_88_1 mop1 mon1 vdd vbsyn gsyn
Xho_89_1 ahp89 ahn89 wp_ho_89_1 wn_ho_89_1 mop1 mon1 vdd vbsyn gsyn
Xho_90_1 ahp90 ahn90 wp_ho_90_1 wn_ho_90_1 mop1 mon1 vdd vbsyn gsyn
Xho_91_1 ahp91 ahn91 wp_ho_91_1 wn_ho_91_1 mop1 mon1 vdd vbsyn gsyn
Xho_92_1 ahp92 ahn92 wp_ho_92_1 wn_ho_92_1 mop1 mon1 vdd vbsyn gsyn
Xho_93_1 ahp93 ahn93 wp_ho_93_1 wn_ho_93_1 mop1 mon1 vdd vbsyn gsyn
Xho_94_1 ahp94 ahn94 wp_ho_94_1 wn_ho_94_1 mop1 mon1 vdd vbsyn gsyn
Xho_95_1 ahp95 ahn95 wp_ho_95_1 wn_ho_95_1 mop1 mon1 vdd vbsyn gsyn
Xho_96_1 ahp96 ahn96 wp_ho_96_1 wn_ho_96_1 mop1 mon1 vdd vbsyn gsyn
Xho_97_1 ahp97 ahn97 wp_ho_97_1 wn_ho_97_1 mop1 mon1 vdd vbsyn gsyn
Xho_98_1 ahp98 ahn98 wp_ho_98_1 wn_ho_98_1 mop1 mon1 vdd vbsyn gsyn
Xho_99_1 ahp99 ahn99 wp_ho_99_1 wn_ho_99_1 mop1 mon1 vdd vbsyn gsyn
Xho_100_1 ahp100 ahn100 wp_ho_100_1 wn_ho_100_1 mop1 mon1 vdd vbsyn gsyn
Xho_101_1 ahp101 ahn101 wp_ho_101_1 wn_ho_101_1 mop1 mon1 vdd vbsyn gsyn
Xho_102_1 ahp102 ahn102 wp_ho_102_1 wn_ho_102_1 mop1 mon1 vdd vbsyn gsyn
Xho_103_1 ahp103 ahn103 wp_ho_103_1 wn_ho_103_1 mop1 mon1 vdd vbsyn gsyn
Xho_104_1 ahp104 ahn104 wp_ho_104_1 wn_ho_104_1 mop1 mon1 vdd vbsyn gsyn
Xho_105_1 ahp105 ahn105 wp_ho_105_1 wn_ho_105_1 mop1 mon1 vdd vbsyn gsyn
Xho_106_1 ahp106 ahn106 wp_ho_106_1 wn_ho_106_1 mop1 mon1 vdd vbsyn gsyn
Xho_107_1 ahp107 ahn107 wp_ho_107_1 wn_ho_107_1 mop1 mon1 vdd vbsyn gsyn
Xho_108_1 ahp108 ahn108 wp_ho_108_1 wn_ho_108_1 mop1 mon1 vdd vbsyn gsyn
Xho_109_1 ahp109 ahn109 wp_ho_109_1 wn_ho_109_1 mop1 mon1 vdd vbsyn gsyn
Xho_110_1 ahp110 ahn110 wp_ho_110_1 wn_ho_110_1 mop1 mon1 vdd vbsyn gsyn
Xho_111_1 ahp111 ahn111 wp_ho_111_1 wn_ho_111_1 mop1 mon1 vdd vbsyn gsyn
Xho_112_1 ahp112 ahn112 wp_ho_112_1 wn_ho_112_1 mop1 mon1 vdd vbsyn gsyn
Xho_113_1 ahp113 ahn113 wp_ho_113_1 wn_ho_113_1 mop1 mon1 vdd vbsyn gsyn
Xho_114_1 ahp114 ahn114 wp_ho_114_1 wn_ho_114_1 mop1 mon1 vdd vbsyn gsyn
Xho_115_1 ahp115 ahn115 wp_ho_115_1 wn_ho_115_1 mop1 mon1 vdd vbsyn gsyn
Xho_116_1 ahp116 ahn116 wp_ho_116_1 wn_ho_116_1 mop1 mon1 vdd vbsyn gsyn
Xho_117_1 ahp117 ahn117 wp_ho_117_1 wn_ho_117_1 mop1 mon1 vdd vbsyn gsyn
Xho_118_1 ahp118 ahn118 wp_ho_118_1 wn_ho_118_1 mop1 mon1 vdd vbsyn gsyn
Xho_119_1 ahp119 ahn119 wp_ho_119_1 wn_ho_119_1 mop1 mon1 vdd vbsyn gsyn
Xho_120_1 ahp120 ahn120 wp_ho_120_1 wn_ho_120_1 mop1 mon1 vdd vbsyn gsyn
Xho_121_1 ahp121 ahn121 wp_ho_121_1 wn_ho_121_1 mop1 mon1 vdd vbsyn gsyn
Xho_122_1 ahp122 ahn122 wp_ho_122_1 wn_ho_122_1 mop1 mon1 vdd vbsyn gsyn
Xho_123_1 ahp123 ahn123 wp_ho_123_1 wn_ho_123_1 mop1 mon1 vdd vbsyn gsyn
Xho_124_1 ahp124 ahn124 wp_ho_124_1 wn_ho_124_1 mop1 mon1 vdd vbsyn gsyn
Xho_125_1 ahp125 ahn125 wp_ho_125_1 wn_ho_125_1 mop1 mon1 vdd vbsyn gsyn
Xho_126_1 ahp126 ahn126 wp_ho_126_1 wn_ho_126_1 mop1 mon1 vdd vbsyn gsyn
Xho_127_1 ahp127 ahn127 wp_ho_127_1 wn_ho_127_1 mop1 mon1 vdd vbsyn gsyn
Xho_128_1 ahp128 ahn128 wp_ho_128_1 wn_ho_128_1 mop1 mon1 vdd vbsyn gsyn
Xho_129_1 ahp129 ahn129 wp_ho_129_1 wn_ho_129_1 mop1 mon1 vdd vbsyn gsyn
Xho_130_1 ahp130 ahn130 wp_ho_130_1 wn_ho_130_1 mop1 mon1 vdd vbsyn gsyn
Xho_131_1 ahp131 ahn131 wp_ho_131_1 wn_ho_131_1 mop1 mon1 vdd vbsyn gsyn
Xho_132_1 ahp132 ahn132 wp_ho_132_1 wn_ho_132_1 mop1 mon1 vdd vbsyn gsyn
Xho_133_1 ahp133 ahn133 wp_ho_133_1 wn_ho_133_1 mop1 mon1 vdd vbsyn gsyn
Xho_134_1 ahp134 ahn134 wp_ho_134_1 wn_ho_134_1 mop1 mon1 vdd vbsyn gsyn
Xho_135_1 ahp135 ahn135 wp_ho_135_1 wn_ho_135_1 mop1 mon1 vdd vbsyn gsyn
Xho_136_1 ahp136 ahn136 wp_ho_136_1 wn_ho_136_1 mop1 mon1 vdd vbsyn gsyn
Xho_137_1 ahp137 ahn137 wp_ho_137_1 wn_ho_137_1 mop1 mon1 vdd vbsyn gsyn
Xho_138_1 ahp138 ahn138 wp_ho_138_1 wn_ho_138_1 mop1 mon1 vdd vbsyn gsyn
Xho_139_1 ahp139 ahn139 wp_ho_139_1 wn_ho_139_1 mop1 mon1 vdd vbsyn gsyn
Xho_140_1 ahp140 ahn140 wp_ho_140_1 wn_ho_140_1 mop1 mon1 vdd vbsyn gsyn
Xho_141_1 ahp141 ahn141 wp_ho_141_1 wn_ho_141_1 mop1 mon1 vdd vbsyn gsyn
Xho_142_1 ahp142 ahn142 wp_ho_142_1 wn_ho_142_1 mop1 mon1 vdd vbsyn gsyn
Xho_143_1 ahp143 ahn143 wp_ho_143_1 wn_ho_143_1 mop1 mon1 vdd vbsyn gsyn
Xho_144_1 ahp144 ahn144 wp_ho_144_1 wn_ho_144_1 mop1 mon1 vdd vbsyn gsyn
Xho_145_1 ahp145 ahn145 wp_ho_145_1 wn_ho_145_1 mop1 mon1 vdd vbsyn gsyn
Xho_146_1 ahp146 ahn146 wp_ho_146_1 wn_ho_146_1 mop1 mon1 vdd vbsyn gsyn
Xho_147_1 ahp147 ahn147 wp_ho_147_1 wn_ho_147_1 mop1 mon1 vdd vbsyn gsyn
Xho_148_1 ahp148 ahn148 wp_ho_148_1 wn_ho_148_1 mop1 mon1 vdd vbsyn gsyn
Xho_149_1 ahp149 ahn149 wp_ho_149_1 wn_ho_149_1 mop1 mon1 vdd vbsyn gsyn
Xho_150_1 ahp150 ahn150 wp_ho_150_1 wn_ho_150_1 mop1 mon1 vdd vbsyn gsyn
Xho_151_1 ahp151 ahn151 wp_ho_151_1 wn_ho_151_1 mop1 mon1 vdd vbsyn gsyn
Xho_152_1 ahp152 ahn152 wp_ho_152_1 wn_ho_152_1 mop1 mon1 vdd vbsyn gsyn
Xho_153_1 ahp153 ahn153 wp_ho_153_1 wn_ho_153_1 mop1 mon1 vdd vbsyn gsyn
Xho_154_1 ahp154 ahn154 wp_ho_154_1 wn_ho_154_1 mop1 mon1 vdd vbsyn gsyn
Xho_155_1 ahp155 ahn155 wp_ho_155_1 wn_ho_155_1 mop1 mon1 vdd vbsyn gsyn
Xho_156_1 ahp156 ahn156 wp_ho_156_1 wn_ho_156_1 mop1 mon1 vdd vbsyn gsyn
Xho_157_1 ahp157 ahn157 wp_ho_157_1 wn_ho_157_1 mop1 mon1 vdd vbsyn gsyn
Xho_158_1 ahp158 ahn158 wp_ho_158_1 wn_ho_158_1 mop1 mon1 vdd vbsyn gsyn
Xho_159_1 ahp159 ahn159 wp_ho_159_1 wn_ho_159_1 mop1 mon1 vdd vbsyn gsyn
Xho_160_1 ahp160 ahn160 wp_ho_160_1 wn_ho_160_1 mop1 mon1 vdd vbsyn gsyn
Xho_161_1 ahp161 ahn161 wp_ho_161_1 wn_ho_161_1 mop1 mon1 vdd vbsyn gsyn
Xho_162_1 ahp162 ahn162 wp_ho_162_1 wn_ho_162_1 mop1 mon1 vdd vbsyn gsyn
Xho_163_1 ahp163 ahn163 wp_ho_163_1 wn_ho_163_1 mop1 mon1 vdd vbsyn gsyn
Xho_164_1 ahp164 ahn164 wp_ho_164_1 wn_ho_164_1 mop1 mon1 vdd vbsyn gsyn
Xho_165_1 ahp165 ahn165 wp_ho_165_1 wn_ho_165_1 mop1 mon1 vdd vbsyn gsyn
Xho_166_1 ahp166 ahn166 wp_ho_166_1 wn_ho_166_1 mop1 mon1 vdd vbsyn gsyn
Xho_167_1 ahp167 ahn167 wp_ho_167_1 wn_ho_167_1 mop1 mon1 vdd vbsyn gsyn
Xho_168_1 ahp168 ahn168 wp_ho_168_1 wn_ho_168_1 mop1 mon1 vdd vbsyn gsyn
Xho_169_1 ahp169 ahn169 wp_ho_169_1 wn_ho_169_1 mop1 mon1 vdd vbsyn gsyn
Xho_170_1 ahp170 ahn170 wp_ho_170_1 wn_ho_170_1 mop1 mon1 vdd vbsyn gsyn
Xho_171_1 ahp171 ahn171 wp_ho_171_1 wn_ho_171_1 mop1 mon1 vdd vbsyn gsyn
Xho_172_1 ahp172 ahn172 wp_ho_172_1 wn_ho_172_1 mop1 mon1 vdd vbsyn gsyn
Xho_173_1 ahp173 ahn173 wp_ho_173_1 wn_ho_173_1 mop1 mon1 vdd vbsyn gsyn
Xho_174_1 ahp174 ahn174 wp_ho_174_1 wn_ho_174_1 mop1 mon1 vdd vbsyn gsyn
Xho_175_1 ahp175 ahn175 wp_ho_175_1 wn_ho_175_1 mop1 mon1 vdd vbsyn gsyn
Xho_176_1 ahp176 ahn176 wp_ho_176_1 wn_ho_176_1 mop1 mon1 vdd vbsyn gsyn
Xho_177_1 ahp177 ahn177 wp_ho_177_1 wn_ho_177_1 mop1 mon1 vdd vbsyn gsyn
Xho_178_1 ahp178 ahn178 wp_ho_178_1 wn_ho_178_1 mop1 mon1 vdd vbsyn gsyn
Xho_179_1 ahp179 ahn179 wp_ho_179_1 wn_ho_179_1 mop1 mon1 vdd vbsyn gsyn
Xho_180_1 ahp180 ahn180 wp_ho_180_1 wn_ho_180_1 mop1 mon1 vdd vbsyn gsyn
Xho_181_1 ahp181 ahn181 wp_ho_181_1 wn_ho_181_1 mop1 mon1 vdd vbsyn gsyn
Xho_182_1 ahp182 ahn182 wp_ho_182_1 wn_ho_182_1 mop1 mon1 vdd vbsyn gsyn
Xho_183_1 ahp183 ahn183 wp_ho_183_1 wn_ho_183_1 mop1 mon1 vdd vbsyn gsyn
Xho_184_1 ahp184 ahn184 wp_ho_184_1 wn_ho_184_1 mop1 mon1 vdd vbsyn gsyn
Xho_185_1 ahp185 ahn185 wp_ho_185_1 wn_ho_185_1 mop1 mon1 vdd vbsyn gsyn
Xho_186_1 ahp186 ahn186 wp_ho_186_1 wn_ho_186_1 mop1 mon1 vdd vbsyn gsyn
Xho_187_1 ahp187 ahn187 wp_ho_187_1 wn_ho_187_1 mop1 mon1 vdd vbsyn gsyn
Xho_188_1 ahp188 ahn188 wp_ho_188_1 wn_ho_188_1 mop1 mon1 vdd vbsyn gsyn
Xho_189_1 ahp189 ahn189 wp_ho_189_1 wn_ho_189_1 mop1 mon1 vdd vbsyn gsyn
Xho_190_1 ahp190 ahn190 wp_ho_190_1 wn_ho_190_1 mop1 mon1 vdd vbsyn gsyn
Xho_191_1 ahp191 ahn191 wp_ho_191_1 wn_ho_191_1 mop1 mon1 vdd vbsyn gsyn
Xho_192_1 ahp192 ahn192 wp_ho_192_1 wn_ho_192_1 mop1 mon1 vdd vbsyn gsyn
Xho_193_1 ahp193 ahn193 wp_ho_193_1 wn_ho_193_1 mop1 mon1 vdd vbsyn gsyn
Xho_194_1 ahp194 ahn194 wp_ho_194_1 wn_ho_194_1 mop1 mon1 vdd vbsyn gsyn
Xho_195_1 ahp195 ahn195 wp_ho_195_1 wn_ho_195_1 mop1 mon1 vdd vbsyn gsyn
Xho_196_1 ahp196 ahn196 wp_ho_196_1 wn_ho_196_1 mop1 mon1 vdd vbsyn gsyn
Xho_197_1 ahp197 ahn197 wp_ho_197_1 wn_ho_197_1 mop1 mon1 vdd vbsyn gsyn
Xho_198_1 ahp198 ahn198 wp_ho_198_1 wn_ho_198_1 mop1 mon1 vdd vbsyn gsyn
Xho_199_1 ahp199 ahn199 wp_ho_199_1 wn_ho_199_1 mop1 mon1 vdd vbsyn gsyn
Xcm_mo2 mop2 mon2 vdd cmld
Rnd_mo2 mop2 mon2 20k
Cmo2p mop2 0 1e-13
Cmo2n mon2 0 1e-13
Xho_0_2 ahp0 ahn0 wp_ho_0_2 wn_ho_0_2 mop2 mon2 vdd vbsyn gsyn
Xho_1_2 ahp1 ahn1 wp_ho_1_2 wn_ho_1_2 mop2 mon2 vdd vbsyn gsyn
Xho_2_2 ahp2 ahn2 wp_ho_2_2 wn_ho_2_2 mop2 mon2 vdd vbsyn gsyn
Xho_3_2 ahp3 ahn3 wp_ho_3_2 wn_ho_3_2 mop2 mon2 vdd vbsyn gsyn
Xho_4_2 ahp4 ahn4 wp_ho_4_2 wn_ho_4_2 mop2 mon2 vdd vbsyn gsyn
Xho_5_2 ahp5 ahn5 wp_ho_5_2 wn_ho_5_2 mop2 mon2 vdd vbsyn gsyn
Xho_6_2 ahp6 ahn6 wp_ho_6_2 wn_ho_6_2 mop2 mon2 vdd vbsyn gsyn
Xho_7_2 ahp7 ahn7 wp_ho_7_2 wn_ho_7_2 mop2 mon2 vdd vbsyn gsyn
Xho_8_2 ahp8 ahn8 wp_ho_8_2 wn_ho_8_2 mop2 mon2 vdd vbsyn gsyn
Xho_9_2 ahp9 ahn9 wp_ho_9_2 wn_ho_9_2 mop2 mon2 vdd vbsyn gsyn
Xho_10_2 ahp10 ahn10 wp_ho_10_2 wn_ho_10_2 mop2 mon2 vdd vbsyn gsyn
Xho_11_2 ahp11 ahn11 wp_ho_11_2 wn_ho_11_2 mop2 mon2 vdd vbsyn gsyn
Xho_12_2 ahp12 ahn12 wp_ho_12_2 wn_ho_12_2 mop2 mon2 vdd vbsyn gsyn
Xho_13_2 ahp13 ahn13 wp_ho_13_2 wn_ho_13_2 mop2 mon2 vdd vbsyn gsyn
Xho_14_2 ahp14 ahn14 wp_ho_14_2 wn_ho_14_2 mop2 mon2 vdd vbsyn gsyn
Xho_15_2 ahp15 ahn15 wp_ho_15_2 wn_ho_15_2 mop2 mon2 vdd vbsyn gsyn
Xho_16_2 ahp16 ahn16 wp_ho_16_2 wn_ho_16_2 mop2 mon2 vdd vbsyn gsyn
Xho_17_2 ahp17 ahn17 wp_ho_17_2 wn_ho_17_2 mop2 mon2 vdd vbsyn gsyn
Xho_18_2 ahp18 ahn18 wp_ho_18_2 wn_ho_18_2 mop2 mon2 vdd vbsyn gsyn
Xho_19_2 ahp19 ahn19 wp_ho_19_2 wn_ho_19_2 mop2 mon2 vdd vbsyn gsyn
Xho_20_2 ahp20 ahn20 wp_ho_20_2 wn_ho_20_2 mop2 mon2 vdd vbsyn gsyn
Xho_21_2 ahp21 ahn21 wp_ho_21_2 wn_ho_21_2 mop2 mon2 vdd vbsyn gsyn
Xho_22_2 ahp22 ahn22 wp_ho_22_2 wn_ho_22_2 mop2 mon2 vdd vbsyn gsyn
Xho_23_2 ahp23 ahn23 wp_ho_23_2 wn_ho_23_2 mop2 mon2 vdd vbsyn gsyn
Xho_24_2 ahp24 ahn24 wp_ho_24_2 wn_ho_24_2 mop2 mon2 vdd vbsyn gsyn
Xho_25_2 ahp25 ahn25 wp_ho_25_2 wn_ho_25_2 mop2 mon2 vdd vbsyn gsyn
Xho_26_2 ahp26 ahn26 wp_ho_26_2 wn_ho_26_2 mop2 mon2 vdd vbsyn gsyn
Xho_27_2 ahp27 ahn27 wp_ho_27_2 wn_ho_27_2 mop2 mon2 vdd vbsyn gsyn
Xho_28_2 ahp28 ahn28 wp_ho_28_2 wn_ho_28_2 mop2 mon2 vdd vbsyn gsyn
Xho_29_2 ahp29 ahn29 wp_ho_29_2 wn_ho_29_2 mop2 mon2 vdd vbsyn gsyn
Xho_30_2 ahp30 ahn30 wp_ho_30_2 wn_ho_30_2 mop2 mon2 vdd vbsyn gsyn
Xho_31_2 ahp31 ahn31 wp_ho_31_2 wn_ho_31_2 mop2 mon2 vdd vbsyn gsyn
Xho_32_2 ahp32 ahn32 wp_ho_32_2 wn_ho_32_2 mop2 mon2 vdd vbsyn gsyn
Xho_33_2 ahp33 ahn33 wp_ho_33_2 wn_ho_33_2 mop2 mon2 vdd vbsyn gsyn
Xho_34_2 ahp34 ahn34 wp_ho_34_2 wn_ho_34_2 mop2 mon2 vdd vbsyn gsyn
Xho_35_2 ahp35 ahn35 wp_ho_35_2 wn_ho_35_2 mop2 mon2 vdd vbsyn gsyn
Xho_36_2 ahp36 ahn36 wp_ho_36_2 wn_ho_36_2 mop2 mon2 vdd vbsyn gsyn
Xho_37_2 ahp37 ahn37 wp_ho_37_2 wn_ho_37_2 mop2 mon2 vdd vbsyn gsyn
Xho_38_2 ahp38 ahn38 wp_ho_38_2 wn_ho_38_2 mop2 mon2 vdd vbsyn gsyn
Xho_39_2 ahp39 ahn39 wp_ho_39_2 wn_ho_39_2 mop2 mon2 vdd vbsyn gsyn
Xho_40_2 ahp40 ahn40 wp_ho_40_2 wn_ho_40_2 mop2 mon2 vdd vbsyn gsyn
Xho_41_2 ahp41 ahn41 wp_ho_41_2 wn_ho_41_2 mop2 mon2 vdd vbsyn gsyn
Xho_42_2 ahp42 ahn42 wp_ho_42_2 wn_ho_42_2 mop2 mon2 vdd vbsyn gsyn
Xho_43_2 ahp43 ahn43 wp_ho_43_2 wn_ho_43_2 mop2 mon2 vdd vbsyn gsyn
Xho_44_2 ahp44 ahn44 wp_ho_44_2 wn_ho_44_2 mop2 mon2 vdd vbsyn gsyn
Xho_45_2 ahp45 ahn45 wp_ho_45_2 wn_ho_45_2 mop2 mon2 vdd vbsyn gsyn
Xho_46_2 ahp46 ahn46 wp_ho_46_2 wn_ho_46_2 mop2 mon2 vdd vbsyn gsyn
Xho_47_2 ahp47 ahn47 wp_ho_47_2 wn_ho_47_2 mop2 mon2 vdd vbsyn gsyn
Xho_48_2 ahp48 ahn48 wp_ho_48_2 wn_ho_48_2 mop2 mon2 vdd vbsyn gsyn
Xho_49_2 ahp49 ahn49 wp_ho_49_2 wn_ho_49_2 mop2 mon2 vdd vbsyn gsyn
Xho_50_2 ahp50 ahn50 wp_ho_50_2 wn_ho_50_2 mop2 mon2 vdd vbsyn gsyn
Xho_51_2 ahp51 ahn51 wp_ho_51_2 wn_ho_51_2 mop2 mon2 vdd vbsyn gsyn
Xho_52_2 ahp52 ahn52 wp_ho_52_2 wn_ho_52_2 mop2 mon2 vdd vbsyn gsyn
Xho_53_2 ahp53 ahn53 wp_ho_53_2 wn_ho_53_2 mop2 mon2 vdd vbsyn gsyn
Xho_54_2 ahp54 ahn54 wp_ho_54_2 wn_ho_54_2 mop2 mon2 vdd vbsyn gsyn
Xho_55_2 ahp55 ahn55 wp_ho_55_2 wn_ho_55_2 mop2 mon2 vdd vbsyn gsyn
Xho_56_2 ahp56 ahn56 wp_ho_56_2 wn_ho_56_2 mop2 mon2 vdd vbsyn gsyn
Xho_57_2 ahp57 ahn57 wp_ho_57_2 wn_ho_57_2 mop2 mon2 vdd vbsyn gsyn
Xho_58_2 ahp58 ahn58 wp_ho_58_2 wn_ho_58_2 mop2 mon2 vdd vbsyn gsyn
Xho_59_2 ahp59 ahn59 wp_ho_59_2 wn_ho_59_2 mop2 mon2 vdd vbsyn gsyn
Xho_60_2 ahp60 ahn60 wp_ho_60_2 wn_ho_60_2 mop2 mon2 vdd vbsyn gsyn
Xho_61_2 ahp61 ahn61 wp_ho_61_2 wn_ho_61_2 mop2 mon2 vdd vbsyn gsyn
Xho_62_2 ahp62 ahn62 wp_ho_62_2 wn_ho_62_2 mop2 mon2 vdd vbsyn gsyn
Xho_63_2 ahp63 ahn63 wp_ho_63_2 wn_ho_63_2 mop2 mon2 vdd vbsyn gsyn
Xho_64_2 ahp64 ahn64 wp_ho_64_2 wn_ho_64_2 mop2 mon2 vdd vbsyn gsyn
Xho_65_2 ahp65 ahn65 wp_ho_65_2 wn_ho_65_2 mop2 mon2 vdd vbsyn gsyn
Xho_66_2 ahp66 ahn66 wp_ho_66_2 wn_ho_66_2 mop2 mon2 vdd vbsyn gsyn
Xho_67_2 ahp67 ahn67 wp_ho_67_2 wn_ho_67_2 mop2 mon2 vdd vbsyn gsyn
Xho_68_2 ahp68 ahn68 wp_ho_68_2 wn_ho_68_2 mop2 mon2 vdd vbsyn gsyn
Xho_69_2 ahp69 ahn69 wp_ho_69_2 wn_ho_69_2 mop2 mon2 vdd vbsyn gsyn
Xho_70_2 ahp70 ahn70 wp_ho_70_2 wn_ho_70_2 mop2 mon2 vdd vbsyn gsyn
Xho_71_2 ahp71 ahn71 wp_ho_71_2 wn_ho_71_2 mop2 mon2 vdd vbsyn gsyn
Xho_72_2 ahp72 ahn72 wp_ho_72_2 wn_ho_72_2 mop2 mon2 vdd vbsyn gsyn
Xho_73_2 ahp73 ahn73 wp_ho_73_2 wn_ho_73_2 mop2 mon2 vdd vbsyn gsyn
Xho_74_2 ahp74 ahn74 wp_ho_74_2 wn_ho_74_2 mop2 mon2 vdd vbsyn gsyn
Xho_75_2 ahp75 ahn75 wp_ho_75_2 wn_ho_75_2 mop2 mon2 vdd vbsyn gsyn
Xho_76_2 ahp76 ahn76 wp_ho_76_2 wn_ho_76_2 mop2 mon2 vdd vbsyn gsyn
Xho_77_2 ahp77 ahn77 wp_ho_77_2 wn_ho_77_2 mop2 mon2 vdd vbsyn gsyn
Xho_78_2 ahp78 ahn78 wp_ho_78_2 wn_ho_78_2 mop2 mon2 vdd vbsyn gsyn
Xho_79_2 ahp79 ahn79 wp_ho_79_2 wn_ho_79_2 mop2 mon2 vdd vbsyn gsyn
Xho_80_2 ahp80 ahn80 wp_ho_80_2 wn_ho_80_2 mop2 mon2 vdd vbsyn gsyn
Xho_81_2 ahp81 ahn81 wp_ho_81_2 wn_ho_81_2 mop2 mon2 vdd vbsyn gsyn
Xho_82_2 ahp82 ahn82 wp_ho_82_2 wn_ho_82_2 mop2 mon2 vdd vbsyn gsyn
Xho_83_2 ahp83 ahn83 wp_ho_83_2 wn_ho_83_2 mop2 mon2 vdd vbsyn gsyn
Xho_84_2 ahp84 ahn84 wp_ho_84_2 wn_ho_84_2 mop2 mon2 vdd vbsyn gsyn
Xho_85_2 ahp85 ahn85 wp_ho_85_2 wn_ho_85_2 mop2 mon2 vdd vbsyn gsyn
Xho_86_2 ahp86 ahn86 wp_ho_86_2 wn_ho_86_2 mop2 mon2 vdd vbsyn gsyn
Xho_87_2 ahp87 ahn87 wp_ho_87_2 wn_ho_87_2 mop2 mon2 vdd vbsyn gsyn
Xho_88_2 ahp88 ahn88 wp_ho_88_2 wn_ho_88_2 mop2 mon2 vdd vbsyn gsyn
Xho_89_2 ahp89 ahn89 wp_ho_89_2 wn_ho_89_2 mop2 mon2 vdd vbsyn gsyn
Xho_90_2 ahp90 ahn90 wp_ho_90_2 wn_ho_90_2 mop2 mon2 vdd vbsyn gsyn
Xho_91_2 ahp91 ahn91 wp_ho_91_2 wn_ho_91_2 mop2 mon2 vdd vbsyn gsyn
Xho_92_2 ahp92 ahn92 wp_ho_92_2 wn_ho_92_2 mop2 mon2 vdd vbsyn gsyn
Xho_93_2 ahp93 ahn93 wp_ho_93_2 wn_ho_93_2 mop2 mon2 vdd vbsyn gsyn
Xho_94_2 ahp94 ahn94 wp_ho_94_2 wn_ho_94_2 mop2 mon2 vdd vbsyn gsyn
Xho_95_2 ahp95 ahn95 wp_ho_95_2 wn_ho_95_2 mop2 mon2 vdd vbsyn gsyn
Xho_96_2 ahp96 ahn96 wp_ho_96_2 wn_ho_96_2 mop2 mon2 vdd vbsyn gsyn
Xho_97_2 ahp97 ahn97 wp_ho_97_2 wn_ho_97_2 mop2 mon2 vdd vbsyn gsyn
Xho_98_2 ahp98 ahn98 wp_ho_98_2 wn_ho_98_2 mop2 mon2 vdd vbsyn gsyn
Xho_99_2 ahp99 ahn99 wp_ho_99_2 wn_ho_99_2 mop2 mon2 vdd vbsyn gsyn
Xho_100_2 ahp100 ahn100 wp_ho_100_2 wn_ho_100_2 mop2 mon2 vdd vbsyn gsyn
Xho_101_2 ahp101 ahn101 wp_ho_101_2 wn_ho_101_2 mop2 mon2 vdd vbsyn gsyn
Xho_102_2 ahp102 ahn102 wp_ho_102_2 wn_ho_102_2 mop2 mon2 vdd vbsyn gsyn
Xho_103_2 ahp103 ahn103 wp_ho_103_2 wn_ho_103_2 mop2 mon2 vdd vbsyn gsyn
Xho_104_2 ahp104 ahn104 wp_ho_104_2 wn_ho_104_2 mop2 mon2 vdd vbsyn gsyn
Xho_105_2 ahp105 ahn105 wp_ho_105_2 wn_ho_105_2 mop2 mon2 vdd vbsyn gsyn
Xho_106_2 ahp106 ahn106 wp_ho_106_2 wn_ho_106_2 mop2 mon2 vdd vbsyn gsyn
Xho_107_2 ahp107 ahn107 wp_ho_107_2 wn_ho_107_2 mop2 mon2 vdd vbsyn gsyn
Xho_108_2 ahp108 ahn108 wp_ho_108_2 wn_ho_108_2 mop2 mon2 vdd vbsyn gsyn
Xho_109_2 ahp109 ahn109 wp_ho_109_2 wn_ho_109_2 mop2 mon2 vdd vbsyn gsyn
Xho_110_2 ahp110 ahn110 wp_ho_110_2 wn_ho_110_2 mop2 mon2 vdd vbsyn gsyn
Xho_111_2 ahp111 ahn111 wp_ho_111_2 wn_ho_111_2 mop2 mon2 vdd vbsyn gsyn
Xho_112_2 ahp112 ahn112 wp_ho_112_2 wn_ho_112_2 mop2 mon2 vdd vbsyn gsyn
Xho_113_2 ahp113 ahn113 wp_ho_113_2 wn_ho_113_2 mop2 mon2 vdd vbsyn gsyn
Xho_114_2 ahp114 ahn114 wp_ho_114_2 wn_ho_114_2 mop2 mon2 vdd vbsyn gsyn
Xho_115_2 ahp115 ahn115 wp_ho_115_2 wn_ho_115_2 mop2 mon2 vdd vbsyn gsyn
Xho_116_2 ahp116 ahn116 wp_ho_116_2 wn_ho_116_2 mop2 mon2 vdd vbsyn gsyn
Xho_117_2 ahp117 ahn117 wp_ho_117_2 wn_ho_117_2 mop2 mon2 vdd vbsyn gsyn
Xho_118_2 ahp118 ahn118 wp_ho_118_2 wn_ho_118_2 mop2 mon2 vdd vbsyn gsyn
Xho_119_2 ahp119 ahn119 wp_ho_119_2 wn_ho_119_2 mop2 mon2 vdd vbsyn gsyn
Xho_120_2 ahp120 ahn120 wp_ho_120_2 wn_ho_120_2 mop2 mon2 vdd vbsyn gsyn
Xho_121_2 ahp121 ahn121 wp_ho_121_2 wn_ho_121_2 mop2 mon2 vdd vbsyn gsyn
Xho_122_2 ahp122 ahn122 wp_ho_122_2 wn_ho_122_2 mop2 mon2 vdd vbsyn gsyn
Xho_123_2 ahp123 ahn123 wp_ho_123_2 wn_ho_123_2 mop2 mon2 vdd vbsyn gsyn
Xho_124_2 ahp124 ahn124 wp_ho_124_2 wn_ho_124_2 mop2 mon2 vdd vbsyn gsyn
Xho_125_2 ahp125 ahn125 wp_ho_125_2 wn_ho_125_2 mop2 mon2 vdd vbsyn gsyn
Xho_126_2 ahp126 ahn126 wp_ho_126_2 wn_ho_126_2 mop2 mon2 vdd vbsyn gsyn
Xho_127_2 ahp127 ahn127 wp_ho_127_2 wn_ho_127_2 mop2 mon2 vdd vbsyn gsyn
Xho_128_2 ahp128 ahn128 wp_ho_128_2 wn_ho_128_2 mop2 mon2 vdd vbsyn gsyn
Xho_129_2 ahp129 ahn129 wp_ho_129_2 wn_ho_129_2 mop2 mon2 vdd vbsyn gsyn
Xho_130_2 ahp130 ahn130 wp_ho_130_2 wn_ho_130_2 mop2 mon2 vdd vbsyn gsyn
Xho_131_2 ahp131 ahn131 wp_ho_131_2 wn_ho_131_2 mop2 mon2 vdd vbsyn gsyn
Xho_132_2 ahp132 ahn132 wp_ho_132_2 wn_ho_132_2 mop2 mon2 vdd vbsyn gsyn
Xho_133_2 ahp133 ahn133 wp_ho_133_2 wn_ho_133_2 mop2 mon2 vdd vbsyn gsyn
Xho_134_2 ahp134 ahn134 wp_ho_134_2 wn_ho_134_2 mop2 mon2 vdd vbsyn gsyn
Xho_135_2 ahp135 ahn135 wp_ho_135_2 wn_ho_135_2 mop2 mon2 vdd vbsyn gsyn
Xho_136_2 ahp136 ahn136 wp_ho_136_2 wn_ho_136_2 mop2 mon2 vdd vbsyn gsyn
Xho_137_2 ahp137 ahn137 wp_ho_137_2 wn_ho_137_2 mop2 mon2 vdd vbsyn gsyn
Xho_138_2 ahp138 ahn138 wp_ho_138_2 wn_ho_138_2 mop2 mon2 vdd vbsyn gsyn
Xho_139_2 ahp139 ahn139 wp_ho_139_2 wn_ho_139_2 mop2 mon2 vdd vbsyn gsyn
Xho_140_2 ahp140 ahn140 wp_ho_140_2 wn_ho_140_2 mop2 mon2 vdd vbsyn gsyn
Xho_141_2 ahp141 ahn141 wp_ho_141_2 wn_ho_141_2 mop2 mon2 vdd vbsyn gsyn
Xho_142_2 ahp142 ahn142 wp_ho_142_2 wn_ho_142_2 mop2 mon2 vdd vbsyn gsyn
Xho_143_2 ahp143 ahn143 wp_ho_143_2 wn_ho_143_2 mop2 mon2 vdd vbsyn gsyn
Xho_144_2 ahp144 ahn144 wp_ho_144_2 wn_ho_144_2 mop2 mon2 vdd vbsyn gsyn
Xho_145_2 ahp145 ahn145 wp_ho_145_2 wn_ho_145_2 mop2 mon2 vdd vbsyn gsyn
Xho_146_2 ahp146 ahn146 wp_ho_146_2 wn_ho_146_2 mop2 mon2 vdd vbsyn gsyn
Xho_147_2 ahp147 ahn147 wp_ho_147_2 wn_ho_147_2 mop2 mon2 vdd vbsyn gsyn
Xho_148_2 ahp148 ahn148 wp_ho_148_2 wn_ho_148_2 mop2 mon2 vdd vbsyn gsyn
Xho_149_2 ahp149 ahn149 wp_ho_149_2 wn_ho_149_2 mop2 mon2 vdd vbsyn gsyn
Xho_150_2 ahp150 ahn150 wp_ho_150_2 wn_ho_150_2 mop2 mon2 vdd vbsyn gsyn
Xho_151_2 ahp151 ahn151 wp_ho_151_2 wn_ho_151_2 mop2 mon2 vdd vbsyn gsyn
Xho_152_2 ahp152 ahn152 wp_ho_152_2 wn_ho_152_2 mop2 mon2 vdd vbsyn gsyn
Xho_153_2 ahp153 ahn153 wp_ho_153_2 wn_ho_153_2 mop2 mon2 vdd vbsyn gsyn
Xho_154_2 ahp154 ahn154 wp_ho_154_2 wn_ho_154_2 mop2 mon2 vdd vbsyn gsyn
Xho_155_2 ahp155 ahn155 wp_ho_155_2 wn_ho_155_2 mop2 mon2 vdd vbsyn gsyn
Xho_156_2 ahp156 ahn156 wp_ho_156_2 wn_ho_156_2 mop2 mon2 vdd vbsyn gsyn
Xho_157_2 ahp157 ahn157 wp_ho_157_2 wn_ho_157_2 mop2 mon2 vdd vbsyn gsyn
Xho_158_2 ahp158 ahn158 wp_ho_158_2 wn_ho_158_2 mop2 mon2 vdd vbsyn gsyn
Xho_159_2 ahp159 ahn159 wp_ho_159_2 wn_ho_159_2 mop2 mon2 vdd vbsyn gsyn
Xho_160_2 ahp160 ahn160 wp_ho_160_2 wn_ho_160_2 mop2 mon2 vdd vbsyn gsyn
Xho_161_2 ahp161 ahn161 wp_ho_161_2 wn_ho_161_2 mop2 mon2 vdd vbsyn gsyn
Xho_162_2 ahp162 ahn162 wp_ho_162_2 wn_ho_162_2 mop2 mon2 vdd vbsyn gsyn
Xho_163_2 ahp163 ahn163 wp_ho_163_2 wn_ho_163_2 mop2 mon2 vdd vbsyn gsyn
Xho_164_2 ahp164 ahn164 wp_ho_164_2 wn_ho_164_2 mop2 mon2 vdd vbsyn gsyn
Xho_165_2 ahp165 ahn165 wp_ho_165_2 wn_ho_165_2 mop2 mon2 vdd vbsyn gsyn
Xho_166_2 ahp166 ahn166 wp_ho_166_2 wn_ho_166_2 mop2 mon2 vdd vbsyn gsyn
Xho_167_2 ahp167 ahn167 wp_ho_167_2 wn_ho_167_2 mop2 mon2 vdd vbsyn gsyn
Xho_168_2 ahp168 ahn168 wp_ho_168_2 wn_ho_168_2 mop2 mon2 vdd vbsyn gsyn
Xho_169_2 ahp169 ahn169 wp_ho_169_2 wn_ho_169_2 mop2 mon2 vdd vbsyn gsyn
Xho_170_2 ahp170 ahn170 wp_ho_170_2 wn_ho_170_2 mop2 mon2 vdd vbsyn gsyn
Xho_171_2 ahp171 ahn171 wp_ho_171_2 wn_ho_171_2 mop2 mon2 vdd vbsyn gsyn
Xho_172_2 ahp172 ahn172 wp_ho_172_2 wn_ho_172_2 mop2 mon2 vdd vbsyn gsyn
Xho_173_2 ahp173 ahn173 wp_ho_173_2 wn_ho_173_2 mop2 mon2 vdd vbsyn gsyn
Xho_174_2 ahp174 ahn174 wp_ho_174_2 wn_ho_174_2 mop2 mon2 vdd vbsyn gsyn
Xho_175_2 ahp175 ahn175 wp_ho_175_2 wn_ho_175_2 mop2 mon2 vdd vbsyn gsyn
Xho_176_2 ahp176 ahn176 wp_ho_176_2 wn_ho_176_2 mop2 mon2 vdd vbsyn gsyn
Xho_177_2 ahp177 ahn177 wp_ho_177_2 wn_ho_177_2 mop2 mon2 vdd vbsyn gsyn
Xho_178_2 ahp178 ahn178 wp_ho_178_2 wn_ho_178_2 mop2 mon2 vdd vbsyn gsyn
Xho_179_2 ahp179 ahn179 wp_ho_179_2 wn_ho_179_2 mop2 mon2 vdd vbsyn gsyn
Xho_180_2 ahp180 ahn180 wp_ho_180_2 wn_ho_180_2 mop2 mon2 vdd vbsyn gsyn
Xho_181_2 ahp181 ahn181 wp_ho_181_2 wn_ho_181_2 mop2 mon2 vdd vbsyn gsyn
Xho_182_2 ahp182 ahn182 wp_ho_182_2 wn_ho_182_2 mop2 mon2 vdd vbsyn gsyn
Xho_183_2 ahp183 ahn183 wp_ho_183_2 wn_ho_183_2 mop2 mon2 vdd vbsyn gsyn
Xho_184_2 ahp184 ahn184 wp_ho_184_2 wn_ho_184_2 mop2 mon2 vdd vbsyn gsyn
Xho_185_2 ahp185 ahn185 wp_ho_185_2 wn_ho_185_2 mop2 mon2 vdd vbsyn gsyn
Xho_186_2 ahp186 ahn186 wp_ho_186_2 wn_ho_186_2 mop2 mon2 vdd vbsyn gsyn
Xho_187_2 ahp187 ahn187 wp_ho_187_2 wn_ho_187_2 mop2 mon2 vdd vbsyn gsyn
Xho_188_2 ahp188 ahn188 wp_ho_188_2 wn_ho_188_2 mop2 mon2 vdd vbsyn gsyn
Xho_189_2 ahp189 ahn189 wp_ho_189_2 wn_ho_189_2 mop2 mon2 vdd vbsyn gsyn
Xho_190_2 ahp190 ahn190 wp_ho_190_2 wn_ho_190_2 mop2 mon2 vdd vbsyn gsyn
Xho_191_2 ahp191 ahn191 wp_ho_191_2 wn_ho_191_2 mop2 mon2 vdd vbsyn gsyn
Xho_192_2 ahp192 ahn192 wp_ho_192_2 wn_ho_192_2 mop2 mon2 vdd vbsyn gsyn
Xho_193_2 ahp193 ahn193 wp_ho_193_2 wn_ho_193_2 mop2 mon2 vdd vbsyn gsyn
Xho_194_2 ahp194 ahn194 wp_ho_194_2 wn_ho_194_2 mop2 mon2 vdd vbsyn gsyn
Xho_195_2 ahp195 ahn195 wp_ho_195_2 wn_ho_195_2 mop2 mon2 vdd vbsyn gsyn
Xho_196_2 ahp196 ahn196 wp_ho_196_2 wn_ho_196_2 mop2 mon2 vdd vbsyn gsyn
Xho_197_2 ahp197 ahn197 wp_ho_197_2 wn_ho_197_2 mop2 mon2 vdd vbsyn gsyn
Xho_198_2 ahp198 ahn198 wp_ho_198_2 wn_ho_198_2 mop2 mon2 vdd vbsyn gsyn
Xho_199_2 ahp199 ahn199 wp_ho_199_2 wn_ho_199_2 mop2 mon2 vdd vbsyn gsyn
.options gmin=1e-10 reltol=2e-3 cshunt=1e-15
.control
tran 3n 700.0n uic
wrdata pb_fwb200.dat v(ahp0) v(ahn0) v(ahp1) v(ahn1) v(ahp2) v(ahn2) v(ahp3) v(ahn3) v(ahp4) v(ahn4) v(ahp5) v(ahn5) v(ahp6) v(ahn6) v(ahp7) v(ahn7) v(ahp8) v(ahn8) v(ahp9) v(ahn9) v(ahp10) v(ahn10) v(ahp11) v(ahn11) v(ahp12) v(ahn12) v(ahp13) v(ahn13) v(ahp14) v(ahn14) v(ahp15) v(ahn15) v(ahp16) v(ahn16) v(ahp17) v(ahn17) v(ahp18) v(ahn18) v(ahp19) v(ahn19) v(ahp20) v(ahn20) v(ahp21) v(ahn21) v(ahp22) v(ahn22) v(ahp23) v(ahn23) v(ahp24) v(ahn24) v(ahp25) v(ahn25) v(ahp26) v(ahn26) v(ahp27) v(ahn27) v(ahp28) v(ahn28) v(ahp29) v(ahn29) v(ahp30) v(ahn30) v(ahp31) v(ahn31) v(ahp32) v(ahn32) v(ahp33) v(ahn33) v(ahp34) v(ahn34) v(ahp35) v(ahn35) v(ahp36) v(ahn36) v(ahp37) v(ahn37) v(ahp38) v(ahn38) v(ahp39) v(ahn39) v(ahp40) v(ahn40) v(ahp41) v(ahn41) v(ahp42) v(ahn42) v(ahp43) v(ahn43) v(ahp44) v(ahn44) v(ahp45) v(ahn45) v(ahp46) v(ahn46) v(ahp47) v(ahn47) v(ahp48) v(ahn48) v(ahp49) v(ahn49) v(ahp50) v(ahn50) v(ahp51) v(ahn51) v(ahp52) v(ahn52) v(ahp53) v(ahn53) v(ahp54) v(ahn54) v(ahp55) v(ahn55) v(ahp56) v(ahn56) v(ahp57) v(ahn57) v(ahp58) v(ahn58) v(ahp59) v(ahn59) v(ahp60) v(ahn60) v(ahp61) v(ahn61) v(ahp62) v(ahn62) v(ahp63) v(ahn63) v(ahp64) v(ahn64) v(ahp65) v(ahn65) v(ahp66) v(ahn66) v(ahp67) v(ahn67) v(ahp68) v(ahn68) v(ahp69) v(ahn69) v(ahp70) v(ahn70) v(ahp71) v(ahn71) v(ahp72) v(ahn72) v(ahp73) v(ahn73) v(ahp74) v(ahn74) v(ahp75) v(ahn75) v(ahp76) v(ahn76) v(ahp77) v(ahn77) v(ahp78) v(ahn78) v(ahp79) v(ahn79) v(ahp80) v(ahn80) v(ahp81) v(ahn81) v(ahp82) v(ahn82) v(ahp83) v(ahn83) v(ahp84) v(ahn84) v(ahp85) v(ahn85) v(ahp86) v(ahn86) v(ahp87) v(ahn87) v(ahp88) v(ahn88) v(ahp89) v(ahn89) v(ahp90) v(ahn90) v(ahp91) v(ahn91) v(ahp92) v(ahn92) v(ahp93) v(ahn93) v(ahp94) v(ahn94) v(ahp95) v(ahn95) v(ahp96) v(ahn96) v(ahp97) v(ahn97) v(ahp98) v(ahn98) v(ahp99) v(ahn99) v(ahp100) v(ahn100) v(ahp101) v(ahn101) v(ahp102) v(ahn102) v(ahp103) v(ahn103) v(ahp104) v(ahn104) v(ahp105) v(ahn105) v(ahp106) v(ahn106) v(ahp107) v(ahn107) v(ahp108) v(ahn108) v(ahp109) v(ahn109) v(ahp110) v(ahn110) v(ahp111) v(ahn111) v(ahp112) v(ahn112) v(ahp113) v(ahn113) v(ahp114) v(ahn114) v(ahp115) v(ahn115) v(ahp116) v(ahn116) v(ahp117) v(ahn117) v(ahp118) v(ahn118) v(ahp119) v(ahn119) v(ahp120) v(ahn120) v(ahp121) v(ahn121) v(ahp122) v(ahn122) v(ahp123) v(ahn123) v(ahp124) v(ahn124) v(ahp125) v(ahn125) v(ahp126) v(ahn126) v(ahp127) v(ahn127) v(ahp128) v(ahn128) v(ahp129) v(ahn129) v(ahp130) v(ahn130) v(ahp131) v(ahn131) v(ahp132) v(ahn132) v(ahp133) v(ahn133) v(ahp134) v(ahn134) v(ahp135) v(ahn135) v(ahp136) v(ahn136) v(ahp137) v(ahn137) v(ahp138) v(ahn138) v(ahp139) v(ahn139) v(ahp140) v(ahn140) v(ahp141) v(ahn141) v(ahp142) v(ahn142) v(ahp143) v(ahn143) v(ahp144) v(ahn144) v(ahp145) v(ahn145) v(ahp146) v(ahn146) v(ahp147) v(ahn147) v(ahp148) v(ahn148) v(ahp149) v(ahn149) v(ahp150) v(ahn150) v(ahp151) v(ahn151) v(ahp152) v(ahn152) v(ahp153) v(ahn153) v(ahp154) v(ahn154) v(ahp155) v(ahn155) v(ahp156) v(ahn156) v(ahp157) v(ahn157) v(ahp158) v(ahn158) v(ahp159) v(ahn159) v(ahp160) v(ahn160) v(ahp161) v(ahn161) v(ahp162) v(ahn162) v(ahp163) v(ahn163) v(ahp164) v(ahn164) v(ahp165) v(ahn165) v(ahp166) v(ahn166) v(ahp167) v(ahn167) v(ahp168) v(ahn168) v(ahp169) v(ahn169) v(ahp170) v(ahn170) v(ahp171) v(ahn171) v(ahp172) v(ahn172) v(ahp173) v(ahn173) v(ahp174) v(ahn174) v(ahp175) v(ahn175) v(ahp176) v(ahn176) v(ahp177) v(ahn177) v(ahp178) v(ahn178) v(ahp179) v(ahn179) v(ahp180) v(ahn180) v(ahp181) v(ahn181) v(ahp182) v(ahn182) v(ahp183) v(ahn183) v(ahp184) v(ahn184) v(ahp185) v(ahn185) v(ahp186) v(ahn186) v(ahp187) v(ahn187) v(ahp188) v(ahn188) v(ahp189) v(ahn189) v(ahp190) v(ahn190) v(ahp191) v(ahn191) v(ahp192) v(ahn192) v(ahp193) v(ahn193) v(ahp194) v(ahn194) v(ahp195) v(ahn195) v(ahp196) v(ahn196) v(ahp197) v(ahn197) v(ahp198) v(ahn198) v(ahp199) v(ahn199) v(mop0) v(mon0) v(mop1) v(mon1) v(mop2) v(mon2)
.endc
.end
