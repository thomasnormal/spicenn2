full continuous 2-layer PC
.model NNR NMOS (LEVEL=1 VTO=0.2 KP=120u LAMBDA=0.02 GAMMA=0 PHI=0.7)
.model PNR PMOS (LEVEL=1 VTO=-0.2 KP=40u LAMBDA=0.02 GAMMA=0 PHI=0.7)
.subckt gsyn inp inn wp wn outp outn vdd vbn
Mtail nt vbn 0 0 NNR W=400u L=100u
M5 na wp nt 0 NNR W=200u L=100u
M6 nb wn nt 0 NNR W=200u L=100u
M1 outp inp na 0 NNR W=200u L=100u
M2 outn inn na 0 NNR W=200u L=100u
M3 outn inp nb 0 NNR W=200u L=100u
M4 outp inn nb 0 NNR W=200u L=100u
.ends
.subckt cmld p n vdd
Rcs1 p cmx 300k
Rcs2 n cmx 300k
MLp p cmx vdd vdd PNR W=1000u L=100u
MLn n cmx vdd vdd PNR W=1000u L=100u
.ends
.subckt dneuron up un ap an vdd vbn
M1 an up tn 0 NNR W=200u L=100u
M2 ap un tn 0 NNR W=200u L=100u
Mt tn vbn 0 0 NNR W=200u L=100u
Xcm ap an vdd cmld
.ends
.subckt esub xp xn mp mn ep en vdd vbn
Mt nt vbn 0 0 NNR W=400u L=100u
M1x ep xn nt 0 NNR W=200u L=100u
M2x en xp nt 0 NNR W=200u L=100u
M1m ep mp nt 0 NNR W=200u L=100u
M2m en mn nt 0 NNR W=200u L=100u
RLp vdd ep 50k
RLn vdd en 50k
.ends
.subckt gprod xp xn yp yn wp wn vdd vbn
Mtail nt vbn 0 0 NNR W=400u L=100u
M5 na yp nt 0 NNR W=200u L=100u
M6 nb yn nt 0 NNR W=200u L=100u
M1 iop xp na 0 NNR W=200u L=100u
M2 ion xn na 0 NNR W=200u L=100u
M3 ion xp nb 0 NNR W=200u L=100u
M4 iop xn nb 0 NNR W=200u L=100u
Mlp iop iop vdd vdd PNR W=200u L=100u
Mln ion ion vdd vdd PNR W=200u L=100u
Mpu_wp wp iop vdd vdd PNR W=200u L=100u
MpRn nrn ion vdd vdd PNR W=200u L=100u
MnRn nrn nrn 0 0 NNR W=200u L=100u
Mpd_wp wp nrn 0 0 NNR W=200u L=100u
Mpu_wn wn ion vdd vdd PNR W=200u L=100u
MpRp nrp iop vdd vdd PNR W=200u L=100u
MnRp nrp nrp 0 0 NNR W=200u L=100u
Mpd_wn wn nrp 0 0 NNR W=200u L=100u
.ends
Vdd vdd 0 1.0
Vbsyn vbsyn 0 0.45
Vbneu vbneu 0 0.35
Vgm gm 0 0.6
Vgblh gblh 0 0.85
Vgblo gblo 0 0.85
Vwcm wcm 0 0.5
Vx1p a_xp1 0 PWL(0.0n 0.2000 249.9n 0.2000 250.0n 0.2000 499.9n 0.2000 500.0n 0.8000 749.9n 0.8000 750.0n 0.8000 999.9n 0.8000 1000.0n 0.2000 1249.9n 0.2000 1250.0n 0.2000 1499.9n 0.2000 1500.0n 0.8000 1749.9n 0.8000 1750.0n 0.8000 1999.9n 0.8000 2000.0n 0.2000 2249.9n 0.2000 2250.0n 0.2000 2499.9n 0.2000 2500.0n 0.8000 2749.9n 0.8000 2750.0n 0.8000 2999.9n 0.8000 3000.0n 0.2000 3249.9n 0.2000 3250.0n 0.2000 3499.9n 0.2000 3500.0n 0.8000 3749.9n 0.8000 3750.0n 0.8000 3999.9n 0.8000 4000.0n 0.2000 4249.9n 0.2000 4250.0n 0.2000 4499.9n 0.2000 4500.0n 0.8000 4749.9n 0.8000 4750.0n 0.8000 4999.9n 0.8000 5000.0n 0.2000 5249.9n 0.2000 5250.0n 0.2000 5499.9n 0.2000 5500.0n 0.8000 5749.9n 0.8000 5750.0n 0.8000 5999.9n 0.8000 6000.0n 0.2000 6249.9n 0.2000 6250.0n 0.2000 6499.9n 0.2000 6500.0n 0.8000 6749.9n 0.8000 6750.0n 0.8000 6999.9n 0.8000 7000.0n 0.2000 7249.9n 0.2000 7250.0n 0.2000 7499.9n 0.2000 7500.0n 0.8000 7749.9n 0.8000 7750.0n 0.8000 7999.9n 0.8000 8000.0n 0.2000 8249.9n 0.2000 8250.0n 0.2000 8499.9n 0.2000 8500.0n 0.8000 8749.9n 0.8000 8750.0n 0.8000 8999.9n 0.8000 9000.0n 0.2000 9249.9n 0.2000 9250.0n 0.2000 9499.9n 0.2000 9500.0n 0.8000 9749.9n 0.8000 9750.0n 0.8000 9999.9n 0.8000 10000.0n 0.2000 10249.9n 0.2000 10250.0n 0.2000 10499.9n 0.2000 10500.0n 0.8000 10749.9n 0.8000 10750.0n 0.8000 10999.9n 0.8000 11000.0n 0.2000 11249.9n 0.2000 11250.0n 0.2000 11499.9n 0.2000 11500.0n 0.8000 11749.9n 0.8000 11750.0n 0.8000 11999.9n 0.8000 12000.0n 0.2000 12249.9n 0.2000 12250.0n 0.2000 12499.9n 0.2000 12500.0n 0.8000 12749.9n 0.8000 12750.0n 0.8000 12999.9n 0.8000 13000.0n 0.2000 13249.9n 0.2000 13250.0n 0.2000 13499.9n 0.2000 13500.0n 0.8000 13749.9n 0.8000 13750.0n 0.8000 13999.9n 0.8000 14000.0n 0.2000 14249.9n 0.2000 14250.0n 0.2000 14499.9n 0.2000 14500.0n 0.8000 14749.9n 0.8000 14750.0n 0.8000 14999.9n 0.8000 15000.0n 0.2000 15249.9n 0.2000 15250.0n 0.2000 15499.9n 0.2000 15500.0n 0.8000 15749.9n 0.8000 15750.0n 0.8000 15999.9n 0.8000 16000.0n 0.2000 16249.9n 0.2000 16250.0n 0.2000 16499.9n 0.2000 16500.0n 0.8000 16749.9n 0.8000 16750.0n 0.8000 16999.9n 0.8000 17000.0n 0.2000 17249.9n 0.2000 17250.0n 0.2000 17499.9n 0.2000 17500.0n 0.8000 17749.9n 0.8000 17750.0n 0.8000 17999.9n 0.8000 18000.0n 0.2000 18249.9n 0.2000 18250.0n 0.2000 18499.9n 0.2000 18500.0n 0.8000 18749.9n 0.8000 18750.0n 0.8000 18999.9n 0.8000 19000.0n 0.2000 19249.9n 0.2000 19250.0n 0.2000 19499.9n 0.2000 19500.0n 0.8000 19749.9n 0.8000 19750.0n 0.8000 19999.9n 0.8000 20000.0n 0.2000 20249.9n 0.2000 20250.0n 0.2000 20499.9n 0.2000 20500.0n 0.8000 20749.9n 0.8000 20750.0n 0.8000 20999.9n 0.8000 21000.0n 0.2000 21249.9n 0.2000 21250.0n 0.2000 21499.9n 0.2000 21500.0n 0.8000 21749.9n 0.8000 21750.0n 0.8000 21999.9n 0.8000 22000.0n 0.2000 22249.9n 0.2000 22250.0n 0.2000 22499.9n 0.2000 22500.0n 0.8000 22749.9n 0.8000 22750.0n 0.8000 22999.9n 0.8000 23000.0n 0.2000 23249.9n 0.2000 23250.0n 0.2000 23499.9n 0.2000 23500.0n 0.8000 23749.9n 0.8000 23750.0n 0.8000 23999.9n 0.8000 24000.0n 0.2000 24249.9n 0.2000 24250.0n 0.2000 24499.9n 0.2000 24500.0n 0.8000 24749.9n 0.8000 24750.0n 0.8000 24999.9n 0.8000 25000.0n 0.2000 25249.9n 0.2000 25250.0n 0.2000 25499.9n 0.2000 25500.0n 0.8000 25749.9n 0.8000 25750.0n 0.8000 25999.9n 0.8000 26000.0n 0.2000 26249.9n 0.2000 26250.0n 0.2000 26499.9n 0.2000 26500.0n 0.8000 26749.9n 0.8000 26750.0n 0.8000 26999.9n 0.8000 27000.0n 0.2000 27249.9n 0.2000 27250.0n 0.2000 27499.9n 0.2000 27500.0n 0.8000 27749.9n 0.8000 27750.0n 0.8000 27999.9n 0.8000 28000.0n 0.2000 28249.9n 0.2000 28250.0n 0.2000 28499.9n 0.2000 28500.0n 0.8000 28749.9n 0.8000 28750.0n 0.8000 28999.9n 0.8000 29000.0n 0.2000 29249.9n 0.2000 29250.0n 0.2000 29499.9n 0.2000 29500.0n 0.8000 29749.9n 0.8000 29750.0n 0.8000 29999.9n 0.8000 30000.0n 0.2000 30249.9n 0.2000 30250.0n 0.2000 30499.9n 0.2000 30500.0n 0.8000 30749.9n 0.8000 30750.0n 0.8000 30999.9n 0.8000 31000.0n 0.2000 31249.9n 0.2000 31250.0n 0.2000 31499.9n 0.2000 31500.0n 0.8000 31749.9n 0.8000 31750.0n 0.8000 31999.9n 0.8000 32000.0n 0.2000 32249.9n 0.2000 32250.0n 0.2000 32499.9n 0.2000 32500.0n 0.8000 32749.9n 0.8000 32750.0n 0.8000 32999.9n 0.8000 33000.0n 0.2000 33249.9n 0.2000 33250.0n 0.2000 33499.9n 0.2000 33500.0n 0.8000 33749.9n 0.8000 33750.0n 0.8000 33999.9n 0.8000 34000.0n 0.2000 34249.9n 0.2000 34250.0n 0.2000 34499.9n 0.2000 34500.0n 0.8000 34749.9n 0.8000 34750.0n 0.8000 34999.9n 0.8000 35000.0n 0.2000 35249.9n 0.2000 35250.0n 0.2000 35499.9n 0.2000 35500.0n 0.8000 35749.9n 0.8000 35750.0n 0.8000 35999.9n 0.8000 36000.0n 0.2000 36249.9n 0.2000 36250.0n 0.2000 36499.9n 0.2000 36500.0n 0.8000 36749.9n 0.8000 36750.0n 0.8000 36999.9n 0.8000 37000.0n 0.2000 37249.9n 0.2000 37250.0n 0.2000 37499.9n 0.2000 37500.0n 0.8000 37749.9n 0.8000 37750.0n 0.8000 37999.9n 0.8000 38000.0n 0.2000 38249.9n 0.2000 38250.0n 0.2000 38499.9n 0.2000 38500.0n 0.8000 38749.9n 0.8000 38750.0n 0.8000 38999.9n 0.8000 39000.0n 0.2000 39249.9n 0.2000 39250.0n 0.2000 39499.9n 0.2000 39500.0n 0.8000 39749.9n 0.8000 39750.0n 0.8000 39999.9n 0.8000 40000.0n 0.2000 40249.9n 0.2000 40250.0n 0.2000 40499.9n 0.2000 40500.0n 0.8000 40749.9n 0.8000 40750.0n 0.8000 40999.9n 0.8000 41000.0n 0.2000 41249.9n 0.2000 41250.0n 0.2000 41499.9n 0.2000 41500.0n 0.8000 41749.9n 0.8000 41750.0n 0.8000 41999.9n 0.8000 42000.0n 0.2000 42249.9n 0.2000 42250.0n 0.2000 42499.9n 0.2000 42500.0n 0.8000 42749.9n 0.8000 42750.0n 0.8000 42999.9n 0.8000 43000.0n 0.2000 43249.9n 0.2000 43250.0n 0.2000 43499.9n 0.2000 43500.0n 0.8000 43749.9n 0.8000 43750.0n 0.8000 43999.9n 0.8000 44000.0n 0.2000 44249.9n 0.2000 44250.0n 0.2000 44499.9n 0.2000 44500.0n 0.8000 44749.9n 0.8000 44750.0n 0.8000 44999.9n 0.8000 45000.0n 0.2000 45249.9n 0.2000 45250.0n 0.2000 45499.9n 0.2000 45500.0n 0.8000 45749.9n 0.8000 45750.0n 0.8000 45999.9n 0.8000 46000.0n 0.2000 46249.9n 0.2000 46250.0n 0.2000 46499.9n 0.2000 46500.0n 0.8000 46749.9n 0.8000 46750.0n 0.8000 46999.9n 0.8000 47000.0n 0.2000 47249.9n 0.2000 47250.0n 0.2000 47499.9n 0.2000 47500.0n 0.8000 47749.9n 0.8000 47750.0n 0.8000 47999.9n 0.8000 48000.0n 0.2000 48249.9n 0.2000 48250.0n 0.2000 48499.9n 0.2000 48500.0n 0.8000 48749.9n 0.8000 48750.0n 0.8000 48999.9n 0.8000 49000.0n 0.2000 49249.9n 0.2000 49250.0n 0.2000 49499.9n 0.2000 49500.0n 0.8000 49749.9n 0.8000 49750.0n 0.8000 49999.9n 0.8000 50000.0n 0.2000 50249.9n 0.2000 50250.0n 0.2000 50499.9n 0.2000 50500.0n 0.8000 50749.9n 0.8000 50750.0n 0.8000 50999.9n 0.8000 51000.0n 0.2000 51249.9n 0.2000 51250.0n 0.2000 51499.9n 0.2000 51500.0n 0.8000 51749.9n 0.8000 51750.0n 0.8000 51999.9n 0.8000 52000.0n 0.2000 52249.9n 0.2000 52250.0n 0.2000 52499.9n 0.2000 52500.0n 0.8000 52749.9n 0.8000 52750.0n 0.8000 52999.9n 0.8000 53000.0n 0.2000 53249.9n 0.2000 53250.0n 0.2000 53499.9n 0.2000 53500.0n 0.8000 53749.9n 0.8000 53750.0n 0.8000 53999.9n 0.8000 54000.0n 0.2000 54249.9n 0.2000 54250.0n 0.2000 54499.9n 0.2000 54500.0n 0.8000 54749.9n 0.8000 54750.0n 0.8000 54999.9n 0.8000 55000.0n 0.2000 55249.9n 0.2000 55250.0n 0.2000 55499.9n 0.2000 55500.0n 0.8000 55749.9n 0.8000 55750.0n 0.8000 55999.9n 0.8000 56000.0n 0.2000 56249.9n 0.2000 56250.0n 0.2000 56499.9n 0.2000 56500.0n 0.8000 56749.9n 0.8000 56750.0n 0.8000 56999.9n 0.8000 57000.0n 0.2000 57249.9n 0.2000 57250.0n 0.2000 57499.9n 0.2000 57500.0n 0.8000 57749.9n 0.8000 57750.0n 0.8000 57999.9n 0.8000 58000.0n 0.2000 58249.9n 0.2000 58250.0n 0.2000 58499.9n 0.2000 58500.0n 0.8000 58749.9n 0.8000 58750.0n 0.8000 58999.9n 0.8000 59000.0n 0.2000 59249.9n 0.2000 59250.0n 0.2000 59499.9n 0.2000 59500.0n 0.8000 59749.9n 0.8000 59750.0n 0.8000 59999.9n 0.8000 60000.0n 0.2000 60249.9n 0.2000 60250.0n 0.2000 60499.9n 0.2000 60500.0n 0.8000 60749.9n 0.8000 60750.0n 0.8000 60999.9n 0.8000 61000.0n 0.2000 61249.9n 0.2000 61250.0n 0.2000 61499.9n 0.2000 61500.0n 0.8000 61749.9n 0.8000 61750.0n 0.8000 61999.9n 0.8000 62000.0n 0.2000 62249.9n 0.2000 62250.0n 0.2000 62499.9n 0.2000 62500.0n 0.8000 62749.9n 0.8000 62750.0n 0.8000 62999.9n 0.8000 63000.0n 0.2000 63249.9n 0.2000 63250.0n 0.2000 63499.9n 0.2000 63500.0n 0.8000 63749.9n 0.8000 63750.0n 0.8000 63999.9n 0.8000 64000.0n 0.2000 64249.9n 0.2000 64250.0n 0.2000 64499.9n 0.2000 64500.0n 0.8000 64749.9n 0.8000 64750.0n 0.8000 64999.9n 0.8000 65000.0n 0.2000 65249.9n 0.2000 65250.0n 0.2000 65499.9n 0.2000 65500.0n 0.8000 65749.9n 0.8000 65750.0n 0.8000 65999.9n 0.8000 66000.0n 0.2000 66249.9n 0.2000 66250.0n 0.2000 66499.9n 0.2000 66500.0n 0.8000 66749.9n 0.8000 66750.0n 0.8000 66999.9n 0.8000 67000.0n 0.2000 67249.9n 0.2000 67250.0n 0.2000 67499.9n 0.2000 67500.0n 0.8000 67749.9n 0.8000 67750.0n 0.8000 67999.9n 0.8000 68000.0n 0.2000 68249.9n 0.2000 68250.0n 0.2000 68499.9n 0.2000 68500.0n 0.8000 68749.9n 0.8000 68750.0n 0.8000 68999.9n 0.8000 69000.0n 0.2000 69249.9n 0.2000 69250.0n 0.2000 69499.9n 0.2000 69500.0n 0.8000 69749.9n 0.8000 69750.0n 0.8000 69999.9n 0.8000 70000.0n 0.2000 70249.9n 0.2000 70250.0n 0.2000 70499.9n 0.2000 70500.0n 0.8000 70749.9n 0.8000 70750.0n 0.8000 70999.9n 0.8000 71000.0n 0.2000 71249.9n 0.2000 71250.0n 0.2000 71499.9n 0.2000 71500.0n 0.8000 71749.9n 0.8000 71750.0n 0.8000 71999.9n 0.8000 72000.0n 0.2000 72249.9n 0.2000 72250.0n 0.2000 72499.9n 0.2000 72500.0n 0.8000 72749.9n 0.8000 72750.0n 0.8000 72999.9n 0.8000 73000.0n 0.2000 73249.9n 0.2000 73250.0n 0.2000 73499.9n 0.2000 73500.0n 0.8000 73749.9n 0.8000 73750.0n 0.8000 73999.9n 0.8000 74000.0n 0.2000 74249.9n 0.2000 74250.0n 0.2000 74499.9n 0.2000 74500.0n 0.8000 74749.9n 0.8000 74750.0n 0.8000 74999.9n 0.8000 75000.0n 0.2000 75249.9n 0.2000 75250.0n 0.2000 75499.9n 0.2000 75500.0n 0.8000 75749.9n 0.8000 75750.0n 0.8000 75999.9n 0.8000 76000.0n 0.2000 76249.9n 0.2000 76250.0n 0.2000 76499.9n 0.2000 76500.0n 0.8000 76749.9n 0.8000 76750.0n 0.8000 76999.9n 0.8000 77000.0n 0.2000 77249.9n 0.2000 77250.0n 0.2000 77499.9n 0.2000 77500.0n 0.8000 77749.9n 0.8000 77750.0n 0.8000 77999.9n 0.8000 78000.0n 0.2000 78249.9n 0.2000 78250.0n 0.2000 78499.9n 0.2000 78500.0n 0.8000 78749.9n 0.8000 78750.0n 0.8000 78999.9n 0.8000 79000.0n 0.2000 79249.9n 0.2000 79250.0n 0.2000 79499.9n 0.2000 79500.0n 0.8000 79749.9n 0.8000 79750.0n 0.8000 79999.9n 0.8000 80000.0n 0.2000 80249.9n 0.2000 80250.0n 0.2000 80499.9n 0.2000 80500.0n 0.8000 80749.9n 0.8000 80750.0n 0.8000 80999.9n 0.8000 81000.0n 0.2000 81249.9n 0.2000 81250.0n 0.2000 81499.9n 0.2000 81500.0n 0.8000 81749.9n 0.8000 81750.0n 0.8000 81999.9n 0.8000 82000.0n 0.2000 82249.9n 0.2000 82250.0n 0.2000 82499.9n 0.2000 82500.0n 0.8000 82749.9n 0.8000 82750.0n 0.8000 82999.9n 0.8000 83000.0n 0.2000 83249.9n 0.2000 83250.0n 0.2000 83499.9n 0.2000 83500.0n 0.8000 83749.9n 0.8000 83750.0n 0.8000 83999.9n 0.8000 84000.0n 0.2000 84249.9n 0.2000 84250.0n 0.2000 84499.9n 0.2000 84500.0n 0.8000 84749.9n 0.8000 84750.0n 0.8000 84999.9n 0.8000 85000.0n 0.2000 85249.9n 0.2000 85250.0n 0.2000 85499.9n 0.2000 85500.0n 0.8000 85749.9n 0.8000 85750.0n 0.8000 85999.9n 0.8000 86000.0n 0.2000 86249.9n 0.2000 86250.0n 0.2000 86499.9n 0.2000 86500.0n 0.8000 86749.9n 0.8000 86750.0n 0.8000 86999.9n 0.8000 87000.0n 0.2000 87249.9n 0.2000 87250.0n 0.2000 87499.9n 0.2000 87500.0n 0.8000 87749.9n 0.8000 87750.0n 0.8000 87999.9n 0.8000 88000.0n 0.2000 88249.9n 0.2000 88250.0n 0.2000 88499.9n 0.2000 88500.0n 0.8000 88749.9n 0.8000 88750.0n 0.8000 88999.9n 0.8000 89000.0n 0.2000 89249.9n 0.2000 89250.0n 0.2000 89499.9n 0.2000 89500.0n 0.8000 89749.9n 0.8000 89750.0n 0.8000 89999.9n 0.8000 90000.0n 0.2000 90249.9n 0.2000 90250.0n 0.2000 90499.9n 0.2000 90500.0n 0.8000 90749.9n 0.8000 90750.0n 0.8000 90999.9n 0.8000 91000.0n 0.2000 91249.9n 0.2000 91250.0n 0.2000 91499.9n 0.2000 91500.0n 0.8000 91749.9n 0.8000 91750.0n 0.8000 91999.9n 0.8000 92000.0n 0.2000 92249.9n 0.2000 92250.0n 0.2000 92499.9n 0.2000 92500.0n 0.8000 92749.9n 0.8000 92750.0n 0.8000 92999.9n 0.8000 93000.0n 0.2000 93249.9n 0.2000 93250.0n 0.2000 93499.9n 0.2000 93500.0n 0.8000 93749.9n 0.8000 93750.0n 0.8000 93999.9n 0.8000 94000.0n 0.2000 94249.9n 0.2000 94250.0n 0.2000 94499.9n 0.2000 94500.0n 0.8000 94749.9n 0.8000 94750.0n 0.8000 94999.9n 0.8000 95000.0n 0.2000 95249.9n 0.2000 95250.0n 0.2000 95499.9n 0.2000 95500.0n 0.8000 95749.9n 0.8000 95750.0n 0.8000 95999.9n 0.8000 96000.0n 0.2000 96249.9n 0.2000 96250.0n 0.2000 96499.9n 0.2000 96500.0n 0.8000 96749.9n 0.8000 96750.0n 0.8000 96999.9n 0.8000 97000.0n 0.2000 97249.9n 0.2000 97250.0n 0.2000 97499.9n 0.2000 97500.0n 0.8000 97749.9n 0.8000 97750.0n 0.8000 97999.9n 0.8000 98000.0n 0.2000 98249.9n 0.2000 98250.0n 0.2000 98499.9n 0.2000 98500.0n 0.8000 98749.9n 0.8000 98750.0n 0.8000 98999.9n 0.8000 99000.0n 0.2000 99249.9n 0.2000 99250.0n 0.2000 99499.9n 0.2000 99500.0n 0.8000 99749.9n 0.8000 99750.0n 0.8000 99999.9n 0.8000 100000.0n 0.2000 100249.9n 0.2000 100250.0n 0.2000 100499.9n 0.2000 100500.0n 0.8000 100749.9n 0.8000 100750.0n 0.8000 100999.9n 0.8000 101000.0n 0.2000 101249.9n 0.2000 101250.0n 0.2000 101499.9n 0.2000 101500.0n 0.8000 101749.9n 0.8000 101750.0n 0.8000 101999.9n 0.8000 102000.0n 0.2000 102249.9n 0.2000 102250.0n 0.2000 102499.9n 0.2000 102500.0n 0.8000 102749.9n 0.8000 102750.0n 0.8000 102999.9n 0.8000 103000.0n 0.2000 103249.9n 0.2000 103250.0n 0.2000 103499.9n 0.2000 103500.0n 0.8000 103749.9n 0.8000 103750.0n 0.8000 103999.9n 0.8000 104000.0n 0.2000 104249.9n 0.2000 104250.0n 0.2000 104499.9n 0.2000 104500.0n 0.8000 104749.9n 0.8000 104750.0n 0.8000 104999.9n 0.8000 105000.0n 0.2000 105249.9n 0.2000 105250.0n 0.2000 105499.9n 0.2000 105500.0n 0.8000 105749.9n 0.8000 105750.0n 0.8000 105999.9n 0.8000 106000.0n 0.2000 106249.9n 0.2000 106250.0n 0.2000 106499.9n 0.2000 106500.0n 0.8000 106749.9n 0.8000 106750.0n 0.8000 106999.9n 0.8000 107000.0n 0.2000 107249.9n 0.2000 107250.0n 0.2000 107499.9n 0.2000 107500.0n 0.8000 107749.9n 0.8000 107750.0n 0.8000 107999.9n 0.8000 108000.0n 0.2000 108249.9n 0.2000 108250.0n 0.2000 108499.9n 0.2000 108500.0n 0.8000 108749.9n 0.8000 108750.0n 0.8000 108999.9n 0.8000 109000.0n 0.2000 109249.9n 0.2000 109250.0n 0.2000 109499.9n 0.2000 109500.0n 0.8000 109749.9n 0.8000 109750.0n 0.8000 109999.9n 0.8000 110000.0n 0.2000 110249.9n 0.2000 110250.0n 0.2000 110499.9n 0.2000 110500.0n 0.8000 110749.9n 0.8000 110750.0n 0.8000 110999.9n 0.8000 111000.0n 0.2000 111249.9n 0.2000 111250.0n 0.2000 111499.9n 0.2000 111500.0n 0.8000 111749.9n 0.8000 111750.0n 0.8000 111999.9n 0.8000 112000.0n 0.2000 112249.9n 0.2000 112250.0n 0.2000 112499.9n 0.2000 112500.0n 0.8000 112749.9n 0.8000 112750.0n 0.8000 112999.9n 0.8000 113000.0n 0.2000 113249.9n 0.2000 113250.0n 0.2000 113499.9n 0.2000 113500.0n 0.8000 113749.9n 0.8000 113750.0n 0.8000 113999.9n 0.8000 114000.0n 0.2000 114249.9n 0.2000 114250.0n 0.2000 114499.9n 0.2000 114500.0n 0.8000 114749.9n 0.8000 114750.0n 0.8000 114999.9n 0.8000 115000.0n 0.2000 115249.9n 0.2000 115250.0n 0.2000 115499.9n 0.2000 115500.0n 0.8000 115749.9n 0.8000 115750.0n 0.8000 115999.9n 0.8000 116000.0n 0.2000 116249.9n 0.2000 116250.0n 0.2000 116499.9n 0.2000 116500.0n 0.8000 116749.9n 0.8000 116750.0n 0.8000 116999.9n 0.8000 117000.0n 0.2000 117249.9n 0.2000 117250.0n 0.2000 117499.9n 0.2000 117500.0n 0.8000 117749.9n 0.8000 117750.0n 0.8000 117999.9n 0.8000 118000.0n 0.2000 118249.9n 0.2000 118250.0n 0.2000 118499.9n 0.2000 118500.0n 0.8000 118749.9n 0.8000 118750.0n 0.8000 118999.9n 0.8000 119000.0n 0.2000 119249.9n 0.2000 119250.0n 0.2000 119499.9n 0.2000 119500.0n 0.8000 119749.9n 0.8000 119750.0n 0.8000 119999.9n 0.8000 120000.0n 0.2000 120249.9n 0.2000 120250.0n 0.2000 120499.9n 0.2000 120500.0n 0.8000 120749.9n 0.8000 120750.0n 0.8000 120999.9n 0.8000 121000.0n 0.2000 121249.9n 0.2000 121250.0n 0.2000 121499.9n 0.2000 121500.0n 0.8000 121749.9n 0.8000 121750.0n 0.8000 121999.9n 0.8000 122000.0n 0.2000 122249.9n 0.2000 122250.0n 0.2000 122499.9n 0.2000 122500.0n 0.8000 122749.9n 0.8000 122750.0n 0.8000 122999.9n 0.8000 123000.0n 0.2000 123249.9n 0.2000 123250.0n 0.2000 123499.9n 0.2000 123500.0n 0.8000 123749.9n 0.8000 123750.0n 0.8000 123999.9n 0.8000 124000.0n 0.2000 124249.9n 0.2000 124250.0n 0.2000 124499.9n 0.2000 124500.0n 0.8000 124749.9n 0.8000 124750.0n 0.8000 124999.9n 0.8000 125000.0n 0.2000 125249.9n 0.2000 125250.0n 0.2000 125499.9n 0.2000 125500.0n 0.8000 125749.9n 0.8000 125750.0n 0.8000 125999.9n 0.8000 126000.0n 0.2000 126249.9n 0.2000 126250.0n 0.2000 126499.9n 0.2000 126500.0n 0.8000 126749.9n 0.8000 126750.0n 0.8000 126999.9n 0.8000 127000.0n 0.2000 127249.9n 0.2000 127250.0n 0.2000 127499.9n 0.2000 127500.0n 0.8000 127749.9n 0.8000 127750.0n 0.8000 127999.9n 0.8000 128000.0n 0.2000 128249.9n 0.2000 128250.0n 0.2000 128499.9n 0.2000 128500.0n 0.8000 128749.9n 0.8000 128750.0n 0.8000 128999.9n 0.8000 129000.0n 0.2000 129249.9n 0.2000 129250.0n 0.2000 129499.9n 0.2000 129500.0n 0.8000 129749.9n 0.8000 129750.0n 0.8000 129999.9n 0.8000 130000.0n 0.2000 130249.9n 0.2000 130250.0n 0.2000 130499.9n 0.2000 130500.0n 0.8000 130749.9n 0.8000 130750.0n 0.8000 130999.9n 0.8000 131000.0n 0.2000 131249.9n 0.2000 131250.0n 0.2000 131499.9n 0.2000 131500.0n 0.8000 131749.9n 0.8000 131750.0n 0.8000 131999.9n 0.8000 132000.0n 0.2000 132249.9n 0.2000 132250.0n 0.2000 132499.9n 0.2000 132500.0n 0.8000 132749.9n 0.8000 132750.0n 0.8000 132999.9n 0.8000 133000.0n 0.2000 133249.9n 0.2000 133250.0n 0.2000 133499.9n 0.2000 133500.0n 0.8000 133749.9n 0.8000 133750.0n 0.8000 133999.9n 0.8000 134000.0n 0.2000 134249.9n 0.2000 134250.0n 0.2000 134499.9n 0.2000 134500.0n 0.8000 134749.9n 0.8000 134750.0n 0.8000 134999.9n 0.8000 135000.0n 0.2000 135249.9n 0.2000 135250.0n 0.2000 135499.9n 0.2000 135500.0n 0.8000 135749.9n 0.8000 135750.0n 0.8000 135999.9n 0.8000 136000.0n 0.2000 136249.9n 0.2000 136250.0n 0.2000 136499.9n 0.2000 136500.0n 0.8000 136749.9n 0.8000 136750.0n 0.8000 136999.9n 0.8000 137000.0n 0.2000 137249.9n 0.2000 137250.0n 0.2000 137499.9n 0.2000 137500.0n 0.8000 137749.9n 0.8000 137750.0n 0.8000 137999.9n 0.8000 138000.0n 0.2000 138249.9n 0.2000 138250.0n 0.2000 138499.9n 0.2000 138500.0n 0.8000 138749.9n 0.8000 138750.0n 0.8000 138999.9n 0.8000 139000.0n 0.2000 139249.9n 0.2000 139250.0n 0.2000 139499.9n 0.2000 139500.0n 0.8000 139749.9n 0.8000 139750.0n 0.8000 139999.9n 0.8000 140000.0n 0.2000 140249.9n 0.2000 140250.0n 0.2000 140499.9n 0.2000 140500.0n 0.8000 140749.9n 0.8000 140750.0n 0.8000 140999.9n 0.8000 141000.0n 0.2000 141249.9n 0.2000 141250.0n 0.2000 141499.9n 0.2000 141500.0n 0.8000 141749.9n 0.8000 141750.0n 0.8000 141999.9n 0.8000 142000.0n 0.2000 142249.9n 0.2000 142250.0n 0.2000 142499.9n 0.2000 142500.0n 0.8000 142749.9n 0.8000 142750.0n 0.8000 142999.9n 0.8000 143000.0n 0.2000 143249.9n 0.2000 143250.0n 0.2000 143499.9n 0.2000 143500.0n 0.8000 143749.9n 0.8000 143750.0n 0.8000 143999.9n 0.8000 144000.0n 0.2000 144249.9n 0.2000 144250.0n 0.2000 144499.9n 0.2000 144500.0n 0.8000 144749.9n 0.8000 144750.0n 0.8000 144999.9n 0.8000 145000.0n 0.2000 145249.9n 0.2000 145250.0n 0.2000 145499.9n 0.2000 145500.0n 0.8000 145749.9n 0.8000 145750.0n 0.8000 145999.9n 0.8000 146000.0n 0.2000 146249.9n 0.2000 146250.0n 0.2000 146499.9n 0.2000 146500.0n 0.8000 146749.9n 0.8000 146750.0n 0.8000 146999.9n 0.8000 147000.0n 0.2000 147249.9n 0.2000 147250.0n 0.2000 147499.9n 0.2000 147500.0n 0.8000 147749.9n 0.8000 147750.0n 0.8000 147999.9n 0.8000 148000.0n 0.2000 148249.9n 0.2000 148250.0n 0.2000 148499.9n 0.2000 148500.0n 0.8000 148749.9n 0.8000 148750.0n 0.8000 148999.9n 0.8000 149000.0n 0.2000 149249.9n 0.2000 149250.0n 0.2000 149499.9n 0.2000 149500.0n 0.8000 149749.9n 0.8000 149750.0n 0.8000 149999.9n 0.8000 150000.0n 0.2000 150249.9n 0.2000 150250.0n 0.2000 150499.9n 0.2000 150500.0n 0.8000 150749.9n 0.8000 150750.0n 0.8000 150999.9n 0.8000 151000.0n 0.2000 151249.9n 0.2000 151250.0n 0.2000 151499.9n 0.2000 151500.0n 0.8000 151749.9n 0.8000 151750.0n 0.8000 151999.9n 0.8000 152000.0n 0.2000 152249.9n 0.2000 152250.0n 0.2000 152499.9n 0.2000 152500.0n 0.8000 152749.9n 0.8000 152750.0n 0.8000 152999.9n 0.8000 153000.0n 0.2000 153249.9n 0.2000 153250.0n 0.2000 153499.9n 0.2000 153500.0n 0.8000 153749.9n 0.8000 153750.0n 0.8000 153999.9n 0.8000 154000.0n 0.2000 154249.9n 0.2000 154250.0n 0.2000 154499.9n 0.2000 154500.0n 0.8000 154749.9n 0.8000 154750.0n 0.8000 154999.9n 0.8000 155000.0n 0.2000 155249.9n 0.2000 155250.0n 0.2000 155499.9n 0.2000 155500.0n 0.8000 155749.9n 0.8000 155750.0n 0.8000 155999.9n 0.8000 156000.0n 0.2000 156249.9n 0.2000 156250.0n 0.2000 156499.9n 0.2000 156500.0n 0.8000 156749.9n 0.8000 156750.0n 0.8000 156999.9n 0.8000 157000.0n 0.2000 157249.9n 0.2000 157250.0n 0.2000 157499.9n 0.2000 157500.0n 0.8000 157749.9n 0.8000 157750.0n 0.8000 157999.9n 0.8000 158000.0n 0.2000 158249.9n 0.2000 158250.0n 0.2000 158499.9n 0.2000 158500.0n 0.8000 158749.9n 0.8000 158750.0n 0.8000 158999.9n 0.8000 159000.0n 0.2000 159249.9n 0.2000 159250.0n 0.2000 159499.9n 0.2000 159500.0n 0.8000 159749.9n 0.8000 159750.0n 0.8000)
Vx1n a_xn1 0 PWL(0.0n 0.8000 249.9n 0.8000 250.0n 0.8000 499.9n 0.8000 500.0n 0.2000 749.9n 0.2000 750.0n 0.2000 999.9n 0.2000 1000.0n 0.8000 1249.9n 0.8000 1250.0n 0.8000 1499.9n 0.8000 1500.0n 0.2000 1749.9n 0.2000 1750.0n 0.2000 1999.9n 0.2000 2000.0n 0.8000 2249.9n 0.8000 2250.0n 0.8000 2499.9n 0.8000 2500.0n 0.2000 2749.9n 0.2000 2750.0n 0.2000 2999.9n 0.2000 3000.0n 0.8000 3249.9n 0.8000 3250.0n 0.8000 3499.9n 0.8000 3500.0n 0.2000 3749.9n 0.2000 3750.0n 0.2000 3999.9n 0.2000 4000.0n 0.8000 4249.9n 0.8000 4250.0n 0.8000 4499.9n 0.8000 4500.0n 0.2000 4749.9n 0.2000 4750.0n 0.2000 4999.9n 0.2000 5000.0n 0.8000 5249.9n 0.8000 5250.0n 0.8000 5499.9n 0.8000 5500.0n 0.2000 5749.9n 0.2000 5750.0n 0.2000 5999.9n 0.2000 6000.0n 0.8000 6249.9n 0.8000 6250.0n 0.8000 6499.9n 0.8000 6500.0n 0.2000 6749.9n 0.2000 6750.0n 0.2000 6999.9n 0.2000 7000.0n 0.8000 7249.9n 0.8000 7250.0n 0.8000 7499.9n 0.8000 7500.0n 0.2000 7749.9n 0.2000 7750.0n 0.2000 7999.9n 0.2000 8000.0n 0.8000 8249.9n 0.8000 8250.0n 0.8000 8499.9n 0.8000 8500.0n 0.2000 8749.9n 0.2000 8750.0n 0.2000 8999.9n 0.2000 9000.0n 0.8000 9249.9n 0.8000 9250.0n 0.8000 9499.9n 0.8000 9500.0n 0.2000 9749.9n 0.2000 9750.0n 0.2000 9999.9n 0.2000 10000.0n 0.8000 10249.9n 0.8000 10250.0n 0.8000 10499.9n 0.8000 10500.0n 0.2000 10749.9n 0.2000 10750.0n 0.2000 10999.9n 0.2000 11000.0n 0.8000 11249.9n 0.8000 11250.0n 0.8000 11499.9n 0.8000 11500.0n 0.2000 11749.9n 0.2000 11750.0n 0.2000 11999.9n 0.2000 12000.0n 0.8000 12249.9n 0.8000 12250.0n 0.8000 12499.9n 0.8000 12500.0n 0.2000 12749.9n 0.2000 12750.0n 0.2000 12999.9n 0.2000 13000.0n 0.8000 13249.9n 0.8000 13250.0n 0.8000 13499.9n 0.8000 13500.0n 0.2000 13749.9n 0.2000 13750.0n 0.2000 13999.9n 0.2000 14000.0n 0.8000 14249.9n 0.8000 14250.0n 0.8000 14499.9n 0.8000 14500.0n 0.2000 14749.9n 0.2000 14750.0n 0.2000 14999.9n 0.2000 15000.0n 0.8000 15249.9n 0.8000 15250.0n 0.8000 15499.9n 0.8000 15500.0n 0.2000 15749.9n 0.2000 15750.0n 0.2000 15999.9n 0.2000 16000.0n 0.8000 16249.9n 0.8000 16250.0n 0.8000 16499.9n 0.8000 16500.0n 0.2000 16749.9n 0.2000 16750.0n 0.2000 16999.9n 0.2000 17000.0n 0.8000 17249.9n 0.8000 17250.0n 0.8000 17499.9n 0.8000 17500.0n 0.2000 17749.9n 0.2000 17750.0n 0.2000 17999.9n 0.2000 18000.0n 0.8000 18249.9n 0.8000 18250.0n 0.8000 18499.9n 0.8000 18500.0n 0.2000 18749.9n 0.2000 18750.0n 0.2000 18999.9n 0.2000 19000.0n 0.8000 19249.9n 0.8000 19250.0n 0.8000 19499.9n 0.8000 19500.0n 0.2000 19749.9n 0.2000 19750.0n 0.2000 19999.9n 0.2000 20000.0n 0.8000 20249.9n 0.8000 20250.0n 0.8000 20499.9n 0.8000 20500.0n 0.2000 20749.9n 0.2000 20750.0n 0.2000 20999.9n 0.2000 21000.0n 0.8000 21249.9n 0.8000 21250.0n 0.8000 21499.9n 0.8000 21500.0n 0.2000 21749.9n 0.2000 21750.0n 0.2000 21999.9n 0.2000 22000.0n 0.8000 22249.9n 0.8000 22250.0n 0.8000 22499.9n 0.8000 22500.0n 0.2000 22749.9n 0.2000 22750.0n 0.2000 22999.9n 0.2000 23000.0n 0.8000 23249.9n 0.8000 23250.0n 0.8000 23499.9n 0.8000 23500.0n 0.2000 23749.9n 0.2000 23750.0n 0.2000 23999.9n 0.2000 24000.0n 0.8000 24249.9n 0.8000 24250.0n 0.8000 24499.9n 0.8000 24500.0n 0.2000 24749.9n 0.2000 24750.0n 0.2000 24999.9n 0.2000 25000.0n 0.8000 25249.9n 0.8000 25250.0n 0.8000 25499.9n 0.8000 25500.0n 0.2000 25749.9n 0.2000 25750.0n 0.2000 25999.9n 0.2000 26000.0n 0.8000 26249.9n 0.8000 26250.0n 0.8000 26499.9n 0.8000 26500.0n 0.2000 26749.9n 0.2000 26750.0n 0.2000 26999.9n 0.2000 27000.0n 0.8000 27249.9n 0.8000 27250.0n 0.8000 27499.9n 0.8000 27500.0n 0.2000 27749.9n 0.2000 27750.0n 0.2000 27999.9n 0.2000 28000.0n 0.8000 28249.9n 0.8000 28250.0n 0.8000 28499.9n 0.8000 28500.0n 0.2000 28749.9n 0.2000 28750.0n 0.2000 28999.9n 0.2000 29000.0n 0.8000 29249.9n 0.8000 29250.0n 0.8000 29499.9n 0.8000 29500.0n 0.2000 29749.9n 0.2000 29750.0n 0.2000 29999.9n 0.2000 30000.0n 0.8000 30249.9n 0.8000 30250.0n 0.8000 30499.9n 0.8000 30500.0n 0.2000 30749.9n 0.2000 30750.0n 0.2000 30999.9n 0.2000 31000.0n 0.8000 31249.9n 0.8000 31250.0n 0.8000 31499.9n 0.8000 31500.0n 0.2000 31749.9n 0.2000 31750.0n 0.2000 31999.9n 0.2000 32000.0n 0.8000 32249.9n 0.8000 32250.0n 0.8000 32499.9n 0.8000 32500.0n 0.2000 32749.9n 0.2000 32750.0n 0.2000 32999.9n 0.2000 33000.0n 0.8000 33249.9n 0.8000 33250.0n 0.8000 33499.9n 0.8000 33500.0n 0.2000 33749.9n 0.2000 33750.0n 0.2000 33999.9n 0.2000 34000.0n 0.8000 34249.9n 0.8000 34250.0n 0.8000 34499.9n 0.8000 34500.0n 0.2000 34749.9n 0.2000 34750.0n 0.2000 34999.9n 0.2000 35000.0n 0.8000 35249.9n 0.8000 35250.0n 0.8000 35499.9n 0.8000 35500.0n 0.2000 35749.9n 0.2000 35750.0n 0.2000 35999.9n 0.2000 36000.0n 0.8000 36249.9n 0.8000 36250.0n 0.8000 36499.9n 0.8000 36500.0n 0.2000 36749.9n 0.2000 36750.0n 0.2000 36999.9n 0.2000 37000.0n 0.8000 37249.9n 0.8000 37250.0n 0.8000 37499.9n 0.8000 37500.0n 0.2000 37749.9n 0.2000 37750.0n 0.2000 37999.9n 0.2000 38000.0n 0.8000 38249.9n 0.8000 38250.0n 0.8000 38499.9n 0.8000 38500.0n 0.2000 38749.9n 0.2000 38750.0n 0.2000 38999.9n 0.2000 39000.0n 0.8000 39249.9n 0.8000 39250.0n 0.8000 39499.9n 0.8000 39500.0n 0.2000 39749.9n 0.2000 39750.0n 0.2000 39999.9n 0.2000 40000.0n 0.8000 40249.9n 0.8000 40250.0n 0.8000 40499.9n 0.8000 40500.0n 0.2000 40749.9n 0.2000 40750.0n 0.2000 40999.9n 0.2000 41000.0n 0.8000 41249.9n 0.8000 41250.0n 0.8000 41499.9n 0.8000 41500.0n 0.2000 41749.9n 0.2000 41750.0n 0.2000 41999.9n 0.2000 42000.0n 0.8000 42249.9n 0.8000 42250.0n 0.8000 42499.9n 0.8000 42500.0n 0.2000 42749.9n 0.2000 42750.0n 0.2000 42999.9n 0.2000 43000.0n 0.8000 43249.9n 0.8000 43250.0n 0.8000 43499.9n 0.8000 43500.0n 0.2000 43749.9n 0.2000 43750.0n 0.2000 43999.9n 0.2000 44000.0n 0.8000 44249.9n 0.8000 44250.0n 0.8000 44499.9n 0.8000 44500.0n 0.2000 44749.9n 0.2000 44750.0n 0.2000 44999.9n 0.2000 45000.0n 0.8000 45249.9n 0.8000 45250.0n 0.8000 45499.9n 0.8000 45500.0n 0.2000 45749.9n 0.2000 45750.0n 0.2000 45999.9n 0.2000 46000.0n 0.8000 46249.9n 0.8000 46250.0n 0.8000 46499.9n 0.8000 46500.0n 0.2000 46749.9n 0.2000 46750.0n 0.2000 46999.9n 0.2000 47000.0n 0.8000 47249.9n 0.8000 47250.0n 0.8000 47499.9n 0.8000 47500.0n 0.2000 47749.9n 0.2000 47750.0n 0.2000 47999.9n 0.2000 48000.0n 0.8000 48249.9n 0.8000 48250.0n 0.8000 48499.9n 0.8000 48500.0n 0.2000 48749.9n 0.2000 48750.0n 0.2000 48999.9n 0.2000 49000.0n 0.8000 49249.9n 0.8000 49250.0n 0.8000 49499.9n 0.8000 49500.0n 0.2000 49749.9n 0.2000 49750.0n 0.2000 49999.9n 0.2000 50000.0n 0.8000 50249.9n 0.8000 50250.0n 0.8000 50499.9n 0.8000 50500.0n 0.2000 50749.9n 0.2000 50750.0n 0.2000 50999.9n 0.2000 51000.0n 0.8000 51249.9n 0.8000 51250.0n 0.8000 51499.9n 0.8000 51500.0n 0.2000 51749.9n 0.2000 51750.0n 0.2000 51999.9n 0.2000 52000.0n 0.8000 52249.9n 0.8000 52250.0n 0.8000 52499.9n 0.8000 52500.0n 0.2000 52749.9n 0.2000 52750.0n 0.2000 52999.9n 0.2000 53000.0n 0.8000 53249.9n 0.8000 53250.0n 0.8000 53499.9n 0.8000 53500.0n 0.2000 53749.9n 0.2000 53750.0n 0.2000 53999.9n 0.2000 54000.0n 0.8000 54249.9n 0.8000 54250.0n 0.8000 54499.9n 0.8000 54500.0n 0.2000 54749.9n 0.2000 54750.0n 0.2000 54999.9n 0.2000 55000.0n 0.8000 55249.9n 0.8000 55250.0n 0.8000 55499.9n 0.8000 55500.0n 0.2000 55749.9n 0.2000 55750.0n 0.2000 55999.9n 0.2000 56000.0n 0.8000 56249.9n 0.8000 56250.0n 0.8000 56499.9n 0.8000 56500.0n 0.2000 56749.9n 0.2000 56750.0n 0.2000 56999.9n 0.2000 57000.0n 0.8000 57249.9n 0.8000 57250.0n 0.8000 57499.9n 0.8000 57500.0n 0.2000 57749.9n 0.2000 57750.0n 0.2000 57999.9n 0.2000 58000.0n 0.8000 58249.9n 0.8000 58250.0n 0.8000 58499.9n 0.8000 58500.0n 0.2000 58749.9n 0.2000 58750.0n 0.2000 58999.9n 0.2000 59000.0n 0.8000 59249.9n 0.8000 59250.0n 0.8000 59499.9n 0.8000 59500.0n 0.2000 59749.9n 0.2000 59750.0n 0.2000 59999.9n 0.2000 60000.0n 0.8000 60249.9n 0.8000 60250.0n 0.8000 60499.9n 0.8000 60500.0n 0.2000 60749.9n 0.2000 60750.0n 0.2000 60999.9n 0.2000 61000.0n 0.8000 61249.9n 0.8000 61250.0n 0.8000 61499.9n 0.8000 61500.0n 0.2000 61749.9n 0.2000 61750.0n 0.2000 61999.9n 0.2000 62000.0n 0.8000 62249.9n 0.8000 62250.0n 0.8000 62499.9n 0.8000 62500.0n 0.2000 62749.9n 0.2000 62750.0n 0.2000 62999.9n 0.2000 63000.0n 0.8000 63249.9n 0.8000 63250.0n 0.8000 63499.9n 0.8000 63500.0n 0.2000 63749.9n 0.2000 63750.0n 0.2000 63999.9n 0.2000 64000.0n 0.8000 64249.9n 0.8000 64250.0n 0.8000 64499.9n 0.8000 64500.0n 0.2000 64749.9n 0.2000 64750.0n 0.2000 64999.9n 0.2000 65000.0n 0.8000 65249.9n 0.8000 65250.0n 0.8000 65499.9n 0.8000 65500.0n 0.2000 65749.9n 0.2000 65750.0n 0.2000 65999.9n 0.2000 66000.0n 0.8000 66249.9n 0.8000 66250.0n 0.8000 66499.9n 0.8000 66500.0n 0.2000 66749.9n 0.2000 66750.0n 0.2000 66999.9n 0.2000 67000.0n 0.8000 67249.9n 0.8000 67250.0n 0.8000 67499.9n 0.8000 67500.0n 0.2000 67749.9n 0.2000 67750.0n 0.2000 67999.9n 0.2000 68000.0n 0.8000 68249.9n 0.8000 68250.0n 0.8000 68499.9n 0.8000 68500.0n 0.2000 68749.9n 0.2000 68750.0n 0.2000 68999.9n 0.2000 69000.0n 0.8000 69249.9n 0.8000 69250.0n 0.8000 69499.9n 0.8000 69500.0n 0.2000 69749.9n 0.2000 69750.0n 0.2000 69999.9n 0.2000 70000.0n 0.8000 70249.9n 0.8000 70250.0n 0.8000 70499.9n 0.8000 70500.0n 0.2000 70749.9n 0.2000 70750.0n 0.2000 70999.9n 0.2000 71000.0n 0.8000 71249.9n 0.8000 71250.0n 0.8000 71499.9n 0.8000 71500.0n 0.2000 71749.9n 0.2000 71750.0n 0.2000 71999.9n 0.2000 72000.0n 0.8000 72249.9n 0.8000 72250.0n 0.8000 72499.9n 0.8000 72500.0n 0.2000 72749.9n 0.2000 72750.0n 0.2000 72999.9n 0.2000 73000.0n 0.8000 73249.9n 0.8000 73250.0n 0.8000 73499.9n 0.8000 73500.0n 0.2000 73749.9n 0.2000 73750.0n 0.2000 73999.9n 0.2000 74000.0n 0.8000 74249.9n 0.8000 74250.0n 0.8000 74499.9n 0.8000 74500.0n 0.2000 74749.9n 0.2000 74750.0n 0.2000 74999.9n 0.2000 75000.0n 0.8000 75249.9n 0.8000 75250.0n 0.8000 75499.9n 0.8000 75500.0n 0.2000 75749.9n 0.2000 75750.0n 0.2000 75999.9n 0.2000 76000.0n 0.8000 76249.9n 0.8000 76250.0n 0.8000 76499.9n 0.8000 76500.0n 0.2000 76749.9n 0.2000 76750.0n 0.2000 76999.9n 0.2000 77000.0n 0.8000 77249.9n 0.8000 77250.0n 0.8000 77499.9n 0.8000 77500.0n 0.2000 77749.9n 0.2000 77750.0n 0.2000 77999.9n 0.2000 78000.0n 0.8000 78249.9n 0.8000 78250.0n 0.8000 78499.9n 0.8000 78500.0n 0.2000 78749.9n 0.2000 78750.0n 0.2000 78999.9n 0.2000 79000.0n 0.8000 79249.9n 0.8000 79250.0n 0.8000 79499.9n 0.8000 79500.0n 0.2000 79749.9n 0.2000 79750.0n 0.2000 79999.9n 0.2000 80000.0n 0.8000 80249.9n 0.8000 80250.0n 0.8000 80499.9n 0.8000 80500.0n 0.2000 80749.9n 0.2000 80750.0n 0.2000 80999.9n 0.2000 81000.0n 0.8000 81249.9n 0.8000 81250.0n 0.8000 81499.9n 0.8000 81500.0n 0.2000 81749.9n 0.2000 81750.0n 0.2000 81999.9n 0.2000 82000.0n 0.8000 82249.9n 0.8000 82250.0n 0.8000 82499.9n 0.8000 82500.0n 0.2000 82749.9n 0.2000 82750.0n 0.2000 82999.9n 0.2000 83000.0n 0.8000 83249.9n 0.8000 83250.0n 0.8000 83499.9n 0.8000 83500.0n 0.2000 83749.9n 0.2000 83750.0n 0.2000 83999.9n 0.2000 84000.0n 0.8000 84249.9n 0.8000 84250.0n 0.8000 84499.9n 0.8000 84500.0n 0.2000 84749.9n 0.2000 84750.0n 0.2000 84999.9n 0.2000 85000.0n 0.8000 85249.9n 0.8000 85250.0n 0.8000 85499.9n 0.8000 85500.0n 0.2000 85749.9n 0.2000 85750.0n 0.2000 85999.9n 0.2000 86000.0n 0.8000 86249.9n 0.8000 86250.0n 0.8000 86499.9n 0.8000 86500.0n 0.2000 86749.9n 0.2000 86750.0n 0.2000 86999.9n 0.2000 87000.0n 0.8000 87249.9n 0.8000 87250.0n 0.8000 87499.9n 0.8000 87500.0n 0.2000 87749.9n 0.2000 87750.0n 0.2000 87999.9n 0.2000 88000.0n 0.8000 88249.9n 0.8000 88250.0n 0.8000 88499.9n 0.8000 88500.0n 0.2000 88749.9n 0.2000 88750.0n 0.2000 88999.9n 0.2000 89000.0n 0.8000 89249.9n 0.8000 89250.0n 0.8000 89499.9n 0.8000 89500.0n 0.2000 89749.9n 0.2000 89750.0n 0.2000 89999.9n 0.2000 90000.0n 0.8000 90249.9n 0.8000 90250.0n 0.8000 90499.9n 0.8000 90500.0n 0.2000 90749.9n 0.2000 90750.0n 0.2000 90999.9n 0.2000 91000.0n 0.8000 91249.9n 0.8000 91250.0n 0.8000 91499.9n 0.8000 91500.0n 0.2000 91749.9n 0.2000 91750.0n 0.2000 91999.9n 0.2000 92000.0n 0.8000 92249.9n 0.8000 92250.0n 0.8000 92499.9n 0.8000 92500.0n 0.2000 92749.9n 0.2000 92750.0n 0.2000 92999.9n 0.2000 93000.0n 0.8000 93249.9n 0.8000 93250.0n 0.8000 93499.9n 0.8000 93500.0n 0.2000 93749.9n 0.2000 93750.0n 0.2000 93999.9n 0.2000 94000.0n 0.8000 94249.9n 0.8000 94250.0n 0.8000 94499.9n 0.8000 94500.0n 0.2000 94749.9n 0.2000 94750.0n 0.2000 94999.9n 0.2000 95000.0n 0.8000 95249.9n 0.8000 95250.0n 0.8000 95499.9n 0.8000 95500.0n 0.2000 95749.9n 0.2000 95750.0n 0.2000 95999.9n 0.2000 96000.0n 0.8000 96249.9n 0.8000 96250.0n 0.8000 96499.9n 0.8000 96500.0n 0.2000 96749.9n 0.2000 96750.0n 0.2000 96999.9n 0.2000 97000.0n 0.8000 97249.9n 0.8000 97250.0n 0.8000 97499.9n 0.8000 97500.0n 0.2000 97749.9n 0.2000 97750.0n 0.2000 97999.9n 0.2000 98000.0n 0.8000 98249.9n 0.8000 98250.0n 0.8000 98499.9n 0.8000 98500.0n 0.2000 98749.9n 0.2000 98750.0n 0.2000 98999.9n 0.2000 99000.0n 0.8000 99249.9n 0.8000 99250.0n 0.8000 99499.9n 0.8000 99500.0n 0.2000 99749.9n 0.2000 99750.0n 0.2000 99999.9n 0.2000 100000.0n 0.8000 100249.9n 0.8000 100250.0n 0.8000 100499.9n 0.8000 100500.0n 0.2000 100749.9n 0.2000 100750.0n 0.2000 100999.9n 0.2000 101000.0n 0.8000 101249.9n 0.8000 101250.0n 0.8000 101499.9n 0.8000 101500.0n 0.2000 101749.9n 0.2000 101750.0n 0.2000 101999.9n 0.2000 102000.0n 0.8000 102249.9n 0.8000 102250.0n 0.8000 102499.9n 0.8000 102500.0n 0.2000 102749.9n 0.2000 102750.0n 0.2000 102999.9n 0.2000 103000.0n 0.8000 103249.9n 0.8000 103250.0n 0.8000 103499.9n 0.8000 103500.0n 0.2000 103749.9n 0.2000 103750.0n 0.2000 103999.9n 0.2000 104000.0n 0.8000 104249.9n 0.8000 104250.0n 0.8000 104499.9n 0.8000 104500.0n 0.2000 104749.9n 0.2000 104750.0n 0.2000 104999.9n 0.2000 105000.0n 0.8000 105249.9n 0.8000 105250.0n 0.8000 105499.9n 0.8000 105500.0n 0.2000 105749.9n 0.2000 105750.0n 0.2000 105999.9n 0.2000 106000.0n 0.8000 106249.9n 0.8000 106250.0n 0.8000 106499.9n 0.8000 106500.0n 0.2000 106749.9n 0.2000 106750.0n 0.2000 106999.9n 0.2000 107000.0n 0.8000 107249.9n 0.8000 107250.0n 0.8000 107499.9n 0.8000 107500.0n 0.2000 107749.9n 0.2000 107750.0n 0.2000 107999.9n 0.2000 108000.0n 0.8000 108249.9n 0.8000 108250.0n 0.8000 108499.9n 0.8000 108500.0n 0.2000 108749.9n 0.2000 108750.0n 0.2000 108999.9n 0.2000 109000.0n 0.8000 109249.9n 0.8000 109250.0n 0.8000 109499.9n 0.8000 109500.0n 0.2000 109749.9n 0.2000 109750.0n 0.2000 109999.9n 0.2000 110000.0n 0.8000 110249.9n 0.8000 110250.0n 0.8000 110499.9n 0.8000 110500.0n 0.2000 110749.9n 0.2000 110750.0n 0.2000 110999.9n 0.2000 111000.0n 0.8000 111249.9n 0.8000 111250.0n 0.8000 111499.9n 0.8000 111500.0n 0.2000 111749.9n 0.2000 111750.0n 0.2000 111999.9n 0.2000 112000.0n 0.8000 112249.9n 0.8000 112250.0n 0.8000 112499.9n 0.8000 112500.0n 0.2000 112749.9n 0.2000 112750.0n 0.2000 112999.9n 0.2000 113000.0n 0.8000 113249.9n 0.8000 113250.0n 0.8000 113499.9n 0.8000 113500.0n 0.2000 113749.9n 0.2000 113750.0n 0.2000 113999.9n 0.2000 114000.0n 0.8000 114249.9n 0.8000 114250.0n 0.8000 114499.9n 0.8000 114500.0n 0.2000 114749.9n 0.2000 114750.0n 0.2000 114999.9n 0.2000 115000.0n 0.8000 115249.9n 0.8000 115250.0n 0.8000 115499.9n 0.8000 115500.0n 0.2000 115749.9n 0.2000 115750.0n 0.2000 115999.9n 0.2000 116000.0n 0.8000 116249.9n 0.8000 116250.0n 0.8000 116499.9n 0.8000 116500.0n 0.2000 116749.9n 0.2000 116750.0n 0.2000 116999.9n 0.2000 117000.0n 0.8000 117249.9n 0.8000 117250.0n 0.8000 117499.9n 0.8000 117500.0n 0.2000 117749.9n 0.2000 117750.0n 0.2000 117999.9n 0.2000 118000.0n 0.8000 118249.9n 0.8000 118250.0n 0.8000 118499.9n 0.8000 118500.0n 0.2000 118749.9n 0.2000 118750.0n 0.2000 118999.9n 0.2000 119000.0n 0.8000 119249.9n 0.8000 119250.0n 0.8000 119499.9n 0.8000 119500.0n 0.2000 119749.9n 0.2000 119750.0n 0.2000 119999.9n 0.2000 120000.0n 0.8000 120249.9n 0.8000 120250.0n 0.8000 120499.9n 0.8000 120500.0n 0.2000 120749.9n 0.2000 120750.0n 0.2000 120999.9n 0.2000 121000.0n 0.8000 121249.9n 0.8000 121250.0n 0.8000 121499.9n 0.8000 121500.0n 0.2000 121749.9n 0.2000 121750.0n 0.2000 121999.9n 0.2000 122000.0n 0.8000 122249.9n 0.8000 122250.0n 0.8000 122499.9n 0.8000 122500.0n 0.2000 122749.9n 0.2000 122750.0n 0.2000 122999.9n 0.2000 123000.0n 0.8000 123249.9n 0.8000 123250.0n 0.8000 123499.9n 0.8000 123500.0n 0.2000 123749.9n 0.2000 123750.0n 0.2000 123999.9n 0.2000 124000.0n 0.8000 124249.9n 0.8000 124250.0n 0.8000 124499.9n 0.8000 124500.0n 0.2000 124749.9n 0.2000 124750.0n 0.2000 124999.9n 0.2000 125000.0n 0.8000 125249.9n 0.8000 125250.0n 0.8000 125499.9n 0.8000 125500.0n 0.2000 125749.9n 0.2000 125750.0n 0.2000 125999.9n 0.2000 126000.0n 0.8000 126249.9n 0.8000 126250.0n 0.8000 126499.9n 0.8000 126500.0n 0.2000 126749.9n 0.2000 126750.0n 0.2000 126999.9n 0.2000 127000.0n 0.8000 127249.9n 0.8000 127250.0n 0.8000 127499.9n 0.8000 127500.0n 0.2000 127749.9n 0.2000 127750.0n 0.2000 127999.9n 0.2000 128000.0n 0.8000 128249.9n 0.8000 128250.0n 0.8000 128499.9n 0.8000 128500.0n 0.2000 128749.9n 0.2000 128750.0n 0.2000 128999.9n 0.2000 129000.0n 0.8000 129249.9n 0.8000 129250.0n 0.8000 129499.9n 0.8000 129500.0n 0.2000 129749.9n 0.2000 129750.0n 0.2000 129999.9n 0.2000 130000.0n 0.8000 130249.9n 0.8000 130250.0n 0.8000 130499.9n 0.8000 130500.0n 0.2000 130749.9n 0.2000 130750.0n 0.2000 130999.9n 0.2000 131000.0n 0.8000 131249.9n 0.8000 131250.0n 0.8000 131499.9n 0.8000 131500.0n 0.2000 131749.9n 0.2000 131750.0n 0.2000 131999.9n 0.2000 132000.0n 0.8000 132249.9n 0.8000 132250.0n 0.8000 132499.9n 0.8000 132500.0n 0.2000 132749.9n 0.2000 132750.0n 0.2000 132999.9n 0.2000 133000.0n 0.8000 133249.9n 0.8000 133250.0n 0.8000 133499.9n 0.8000 133500.0n 0.2000 133749.9n 0.2000 133750.0n 0.2000 133999.9n 0.2000 134000.0n 0.8000 134249.9n 0.8000 134250.0n 0.8000 134499.9n 0.8000 134500.0n 0.2000 134749.9n 0.2000 134750.0n 0.2000 134999.9n 0.2000 135000.0n 0.8000 135249.9n 0.8000 135250.0n 0.8000 135499.9n 0.8000 135500.0n 0.2000 135749.9n 0.2000 135750.0n 0.2000 135999.9n 0.2000 136000.0n 0.8000 136249.9n 0.8000 136250.0n 0.8000 136499.9n 0.8000 136500.0n 0.2000 136749.9n 0.2000 136750.0n 0.2000 136999.9n 0.2000 137000.0n 0.8000 137249.9n 0.8000 137250.0n 0.8000 137499.9n 0.8000 137500.0n 0.2000 137749.9n 0.2000 137750.0n 0.2000 137999.9n 0.2000 138000.0n 0.8000 138249.9n 0.8000 138250.0n 0.8000 138499.9n 0.8000 138500.0n 0.2000 138749.9n 0.2000 138750.0n 0.2000 138999.9n 0.2000 139000.0n 0.8000 139249.9n 0.8000 139250.0n 0.8000 139499.9n 0.8000 139500.0n 0.2000 139749.9n 0.2000 139750.0n 0.2000 139999.9n 0.2000 140000.0n 0.8000 140249.9n 0.8000 140250.0n 0.8000 140499.9n 0.8000 140500.0n 0.2000 140749.9n 0.2000 140750.0n 0.2000 140999.9n 0.2000 141000.0n 0.8000 141249.9n 0.8000 141250.0n 0.8000 141499.9n 0.8000 141500.0n 0.2000 141749.9n 0.2000 141750.0n 0.2000 141999.9n 0.2000 142000.0n 0.8000 142249.9n 0.8000 142250.0n 0.8000 142499.9n 0.8000 142500.0n 0.2000 142749.9n 0.2000 142750.0n 0.2000 142999.9n 0.2000 143000.0n 0.8000 143249.9n 0.8000 143250.0n 0.8000 143499.9n 0.8000 143500.0n 0.2000 143749.9n 0.2000 143750.0n 0.2000 143999.9n 0.2000 144000.0n 0.8000 144249.9n 0.8000 144250.0n 0.8000 144499.9n 0.8000 144500.0n 0.2000 144749.9n 0.2000 144750.0n 0.2000 144999.9n 0.2000 145000.0n 0.8000 145249.9n 0.8000 145250.0n 0.8000 145499.9n 0.8000 145500.0n 0.2000 145749.9n 0.2000 145750.0n 0.2000 145999.9n 0.2000 146000.0n 0.8000 146249.9n 0.8000 146250.0n 0.8000 146499.9n 0.8000 146500.0n 0.2000 146749.9n 0.2000 146750.0n 0.2000 146999.9n 0.2000 147000.0n 0.8000 147249.9n 0.8000 147250.0n 0.8000 147499.9n 0.8000 147500.0n 0.2000 147749.9n 0.2000 147750.0n 0.2000 147999.9n 0.2000 148000.0n 0.8000 148249.9n 0.8000 148250.0n 0.8000 148499.9n 0.8000 148500.0n 0.2000 148749.9n 0.2000 148750.0n 0.2000 148999.9n 0.2000 149000.0n 0.8000 149249.9n 0.8000 149250.0n 0.8000 149499.9n 0.8000 149500.0n 0.2000 149749.9n 0.2000 149750.0n 0.2000 149999.9n 0.2000 150000.0n 0.8000 150249.9n 0.8000 150250.0n 0.8000 150499.9n 0.8000 150500.0n 0.2000 150749.9n 0.2000 150750.0n 0.2000 150999.9n 0.2000 151000.0n 0.8000 151249.9n 0.8000 151250.0n 0.8000 151499.9n 0.8000 151500.0n 0.2000 151749.9n 0.2000 151750.0n 0.2000 151999.9n 0.2000 152000.0n 0.8000 152249.9n 0.8000 152250.0n 0.8000 152499.9n 0.8000 152500.0n 0.2000 152749.9n 0.2000 152750.0n 0.2000 152999.9n 0.2000 153000.0n 0.8000 153249.9n 0.8000 153250.0n 0.8000 153499.9n 0.8000 153500.0n 0.2000 153749.9n 0.2000 153750.0n 0.2000 153999.9n 0.2000 154000.0n 0.8000 154249.9n 0.8000 154250.0n 0.8000 154499.9n 0.8000 154500.0n 0.2000 154749.9n 0.2000 154750.0n 0.2000 154999.9n 0.2000 155000.0n 0.8000 155249.9n 0.8000 155250.0n 0.8000 155499.9n 0.8000 155500.0n 0.2000 155749.9n 0.2000 155750.0n 0.2000 155999.9n 0.2000 156000.0n 0.8000 156249.9n 0.8000 156250.0n 0.8000 156499.9n 0.8000 156500.0n 0.2000 156749.9n 0.2000 156750.0n 0.2000 156999.9n 0.2000 157000.0n 0.8000 157249.9n 0.8000 157250.0n 0.8000 157499.9n 0.8000 157500.0n 0.2000 157749.9n 0.2000 157750.0n 0.2000 157999.9n 0.2000 158000.0n 0.8000 158249.9n 0.8000 158250.0n 0.8000 158499.9n 0.8000 158500.0n 0.2000 158749.9n 0.2000 158750.0n 0.2000 158999.9n 0.2000 159000.0n 0.8000 159249.9n 0.8000 159250.0n 0.8000 159499.9n 0.8000 159500.0n 0.2000 159749.9n 0.2000 159750.0n 0.2000)
Vx2p a_xp2 0 PWL(0.0n 0.2000 249.9n 0.2000 250.0n 0.8000 499.9n 0.8000 500.0n 0.2000 749.9n 0.2000 750.0n 0.8000 999.9n 0.8000 1000.0n 0.2000 1249.9n 0.2000 1250.0n 0.8000 1499.9n 0.8000 1500.0n 0.2000 1749.9n 0.2000 1750.0n 0.8000 1999.9n 0.8000 2000.0n 0.2000 2249.9n 0.2000 2250.0n 0.8000 2499.9n 0.8000 2500.0n 0.2000 2749.9n 0.2000 2750.0n 0.8000 2999.9n 0.8000 3000.0n 0.2000 3249.9n 0.2000 3250.0n 0.8000 3499.9n 0.8000 3500.0n 0.2000 3749.9n 0.2000 3750.0n 0.8000 3999.9n 0.8000 4000.0n 0.2000 4249.9n 0.2000 4250.0n 0.8000 4499.9n 0.8000 4500.0n 0.2000 4749.9n 0.2000 4750.0n 0.8000 4999.9n 0.8000 5000.0n 0.2000 5249.9n 0.2000 5250.0n 0.8000 5499.9n 0.8000 5500.0n 0.2000 5749.9n 0.2000 5750.0n 0.8000 5999.9n 0.8000 6000.0n 0.2000 6249.9n 0.2000 6250.0n 0.8000 6499.9n 0.8000 6500.0n 0.2000 6749.9n 0.2000 6750.0n 0.8000 6999.9n 0.8000 7000.0n 0.2000 7249.9n 0.2000 7250.0n 0.8000 7499.9n 0.8000 7500.0n 0.2000 7749.9n 0.2000 7750.0n 0.8000 7999.9n 0.8000 8000.0n 0.2000 8249.9n 0.2000 8250.0n 0.8000 8499.9n 0.8000 8500.0n 0.2000 8749.9n 0.2000 8750.0n 0.8000 8999.9n 0.8000 9000.0n 0.2000 9249.9n 0.2000 9250.0n 0.8000 9499.9n 0.8000 9500.0n 0.2000 9749.9n 0.2000 9750.0n 0.8000 9999.9n 0.8000 10000.0n 0.2000 10249.9n 0.2000 10250.0n 0.8000 10499.9n 0.8000 10500.0n 0.2000 10749.9n 0.2000 10750.0n 0.8000 10999.9n 0.8000 11000.0n 0.2000 11249.9n 0.2000 11250.0n 0.8000 11499.9n 0.8000 11500.0n 0.2000 11749.9n 0.2000 11750.0n 0.8000 11999.9n 0.8000 12000.0n 0.2000 12249.9n 0.2000 12250.0n 0.8000 12499.9n 0.8000 12500.0n 0.2000 12749.9n 0.2000 12750.0n 0.8000 12999.9n 0.8000 13000.0n 0.2000 13249.9n 0.2000 13250.0n 0.8000 13499.9n 0.8000 13500.0n 0.2000 13749.9n 0.2000 13750.0n 0.8000 13999.9n 0.8000 14000.0n 0.2000 14249.9n 0.2000 14250.0n 0.8000 14499.9n 0.8000 14500.0n 0.2000 14749.9n 0.2000 14750.0n 0.8000 14999.9n 0.8000 15000.0n 0.2000 15249.9n 0.2000 15250.0n 0.8000 15499.9n 0.8000 15500.0n 0.2000 15749.9n 0.2000 15750.0n 0.8000 15999.9n 0.8000 16000.0n 0.2000 16249.9n 0.2000 16250.0n 0.8000 16499.9n 0.8000 16500.0n 0.2000 16749.9n 0.2000 16750.0n 0.8000 16999.9n 0.8000 17000.0n 0.2000 17249.9n 0.2000 17250.0n 0.8000 17499.9n 0.8000 17500.0n 0.2000 17749.9n 0.2000 17750.0n 0.8000 17999.9n 0.8000 18000.0n 0.2000 18249.9n 0.2000 18250.0n 0.8000 18499.9n 0.8000 18500.0n 0.2000 18749.9n 0.2000 18750.0n 0.8000 18999.9n 0.8000 19000.0n 0.2000 19249.9n 0.2000 19250.0n 0.8000 19499.9n 0.8000 19500.0n 0.2000 19749.9n 0.2000 19750.0n 0.8000 19999.9n 0.8000 20000.0n 0.2000 20249.9n 0.2000 20250.0n 0.8000 20499.9n 0.8000 20500.0n 0.2000 20749.9n 0.2000 20750.0n 0.8000 20999.9n 0.8000 21000.0n 0.2000 21249.9n 0.2000 21250.0n 0.8000 21499.9n 0.8000 21500.0n 0.2000 21749.9n 0.2000 21750.0n 0.8000 21999.9n 0.8000 22000.0n 0.2000 22249.9n 0.2000 22250.0n 0.8000 22499.9n 0.8000 22500.0n 0.2000 22749.9n 0.2000 22750.0n 0.8000 22999.9n 0.8000 23000.0n 0.2000 23249.9n 0.2000 23250.0n 0.8000 23499.9n 0.8000 23500.0n 0.2000 23749.9n 0.2000 23750.0n 0.8000 23999.9n 0.8000 24000.0n 0.2000 24249.9n 0.2000 24250.0n 0.8000 24499.9n 0.8000 24500.0n 0.2000 24749.9n 0.2000 24750.0n 0.8000 24999.9n 0.8000 25000.0n 0.2000 25249.9n 0.2000 25250.0n 0.8000 25499.9n 0.8000 25500.0n 0.2000 25749.9n 0.2000 25750.0n 0.8000 25999.9n 0.8000 26000.0n 0.2000 26249.9n 0.2000 26250.0n 0.8000 26499.9n 0.8000 26500.0n 0.2000 26749.9n 0.2000 26750.0n 0.8000 26999.9n 0.8000 27000.0n 0.2000 27249.9n 0.2000 27250.0n 0.8000 27499.9n 0.8000 27500.0n 0.2000 27749.9n 0.2000 27750.0n 0.8000 27999.9n 0.8000 28000.0n 0.2000 28249.9n 0.2000 28250.0n 0.8000 28499.9n 0.8000 28500.0n 0.2000 28749.9n 0.2000 28750.0n 0.8000 28999.9n 0.8000 29000.0n 0.2000 29249.9n 0.2000 29250.0n 0.8000 29499.9n 0.8000 29500.0n 0.2000 29749.9n 0.2000 29750.0n 0.8000 29999.9n 0.8000 30000.0n 0.2000 30249.9n 0.2000 30250.0n 0.8000 30499.9n 0.8000 30500.0n 0.2000 30749.9n 0.2000 30750.0n 0.8000 30999.9n 0.8000 31000.0n 0.2000 31249.9n 0.2000 31250.0n 0.8000 31499.9n 0.8000 31500.0n 0.2000 31749.9n 0.2000 31750.0n 0.8000 31999.9n 0.8000 32000.0n 0.2000 32249.9n 0.2000 32250.0n 0.8000 32499.9n 0.8000 32500.0n 0.2000 32749.9n 0.2000 32750.0n 0.8000 32999.9n 0.8000 33000.0n 0.2000 33249.9n 0.2000 33250.0n 0.8000 33499.9n 0.8000 33500.0n 0.2000 33749.9n 0.2000 33750.0n 0.8000 33999.9n 0.8000 34000.0n 0.2000 34249.9n 0.2000 34250.0n 0.8000 34499.9n 0.8000 34500.0n 0.2000 34749.9n 0.2000 34750.0n 0.8000 34999.9n 0.8000 35000.0n 0.2000 35249.9n 0.2000 35250.0n 0.8000 35499.9n 0.8000 35500.0n 0.2000 35749.9n 0.2000 35750.0n 0.8000 35999.9n 0.8000 36000.0n 0.2000 36249.9n 0.2000 36250.0n 0.8000 36499.9n 0.8000 36500.0n 0.2000 36749.9n 0.2000 36750.0n 0.8000 36999.9n 0.8000 37000.0n 0.2000 37249.9n 0.2000 37250.0n 0.8000 37499.9n 0.8000 37500.0n 0.2000 37749.9n 0.2000 37750.0n 0.8000 37999.9n 0.8000 38000.0n 0.2000 38249.9n 0.2000 38250.0n 0.8000 38499.9n 0.8000 38500.0n 0.2000 38749.9n 0.2000 38750.0n 0.8000 38999.9n 0.8000 39000.0n 0.2000 39249.9n 0.2000 39250.0n 0.8000 39499.9n 0.8000 39500.0n 0.2000 39749.9n 0.2000 39750.0n 0.8000 39999.9n 0.8000 40000.0n 0.2000 40249.9n 0.2000 40250.0n 0.8000 40499.9n 0.8000 40500.0n 0.2000 40749.9n 0.2000 40750.0n 0.8000 40999.9n 0.8000 41000.0n 0.2000 41249.9n 0.2000 41250.0n 0.8000 41499.9n 0.8000 41500.0n 0.2000 41749.9n 0.2000 41750.0n 0.8000 41999.9n 0.8000 42000.0n 0.2000 42249.9n 0.2000 42250.0n 0.8000 42499.9n 0.8000 42500.0n 0.2000 42749.9n 0.2000 42750.0n 0.8000 42999.9n 0.8000 43000.0n 0.2000 43249.9n 0.2000 43250.0n 0.8000 43499.9n 0.8000 43500.0n 0.2000 43749.9n 0.2000 43750.0n 0.8000 43999.9n 0.8000 44000.0n 0.2000 44249.9n 0.2000 44250.0n 0.8000 44499.9n 0.8000 44500.0n 0.2000 44749.9n 0.2000 44750.0n 0.8000 44999.9n 0.8000 45000.0n 0.2000 45249.9n 0.2000 45250.0n 0.8000 45499.9n 0.8000 45500.0n 0.2000 45749.9n 0.2000 45750.0n 0.8000 45999.9n 0.8000 46000.0n 0.2000 46249.9n 0.2000 46250.0n 0.8000 46499.9n 0.8000 46500.0n 0.2000 46749.9n 0.2000 46750.0n 0.8000 46999.9n 0.8000 47000.0n 0.2000 47249.9n 0.2000 47250.0n 0.8000 47499.9n 0.8000 47500.0n 0.2000 47749.9n 0.2000 47750.0n 0.8000 47999.9n 0.8000 48000.0n 0.2000 48249.9n 0.2000 48250.0n 0.8000 48499.9n 0.8000 48500.0n 0.2000 48749.9n 0.2000 48750.0n 0.8000 48999.9n 0.8000 49000.0n 0.2000 49249.9n 0.2000 49250.0n 0.8000 49499.9n 0.8000 49500.0n 0.2000 49749.9n 0.2000 49750.0n 0.8000 49999.9n 0.8000 50000.0n 0.2000 50249.9n 0.2000 50250.0n 0.8000 50499.9n 0.8000 50500.0n 0.2000 50749.9n 0.2000 50750.0n 0.8000 50999.9n 0.8000 51000.0n 0.2000 51249.9n 0.2000 51250.0n 0.8000 51499.9n 0.8000 51500.0n 0.2000 51749.9n 0.2000 51750.0n 0.8000 51999.9n 0.8000 52000.0n 0.2000 52249.9n 0.2000 52250.0n 0.8000 52499.9n 0.8000 52500.0n 0.2000 52749.9n 0.2000 52750.0n 0.8000 52999.9n 0.8000 53000.0n 0.2000 53249.9n 0.2000 53250.0n 0.8000 53499.9n 0.8000 53500.0n 0.2000 53749.9n 0.2000 53750.0n 0.8000 53999.9n 0.8000 54000.0n 0.2000 54249.9n 0.2000 54250.0n 0.8000 54499.9n 0.8000 54500.0n 0.2000 54749.9n 0.2000 54750.0n 0.8000 54999.9n 0.8000 55000.0n 0.2000 55249.9n 0.2000 55250.0n 0.8000 55499.9n 0.8000 55500.0n 0.2000 55749.9n 0.2000 55750.0n 0.8000 55999.9n 0.8000 56000.0n 0.2000 56249.9n 0.2000 56250.0n 0.8000 56499.9n 0.8000 56500.0n 0.2000 56749.9n 0.2000 56750.0n 0.8000 56999.9n 0.8000 57000.0n 0.2000 57249.9n 0.2000 57250.0n 0.8000 57499.9n 0.8000 57500.0n 0.2000 57749.9n 0.2000 57750.0n 0.8000 57999.9n 0.8000 58000.0n 0.2000 58249.9n 0.2000 58250.0n 0.8000 58499.9n 0.8000 58500.0n 0.2000 58749.9n 0.2000 58750.0n 0.8000 58999.9n 0.8000 59000.0n 0.2000 59249.9n 0.2000 59250.0n 0.8000 59499.9n 0.8000 59500.0n 0.2000 59749.9n 0.2000 59750.0n 0.8000 59999.9n 0.8000 60000.0n 0.2000 60249.9n 0.2000 60250.0n 0.8000 60499.9n 0.8000 60500.0n 0.2000 60749.9n 0.2000 60750.0n 0.8000 60999.9n 0.8000 61000.0n 0.2000 61249.9n 0.2000 61250.0n 0.8000 61499.9n 0.8000 61500.0n 0.2000 61749.9n 0.2000 61750.0n 0.8000 61999.9n 0.8000 62000.0n 0.2000 62249.9n 0.2000 62250.0n 0.8000 62499.9n 0.8000 62500.0n 0.2000 62749.9n 0.2000 62750.0n 0.8000 62999.9n 0.8000 63000.0n 0.2000 63249.9n 0.2000 63250.0n 0.8000 63499.9n 0.8000 63500.0n 0.2000 63749.9n 0.2000 63750.0n 0.8000 63999.9n 0.8000 64000.0n 0.2000 64249.9n 0.2000 64250.0n 0.8000 64499.9n 0.8000 64500.0n 0.2000 64749.9n 0.2000 64750.0n 0.8000 64999.9n 0.8000 65000.0n 0.2000 65249.9n 0.2000 65250.0n 0.8000 65499.9n 0.8000 65500.0n 0.2000 65749.9n 0.2000 65750.0n 0.8000 65999.9n 0.8000 66000.0n 0.2000 66249.9n 0.2000 66250.0n 0.8000 66499.9n 0.8000 66500.0n 0.2000 66749.9n 0.2000 66750.0n 0.8000 66999.9n 0.8000 67000.0n 0.2000 67249.9n 0.2000 67250.0n 0.8000 67499.9n 0.8000 67500.0n 0.2000 67749.9n 0.2000 67750.0n 0.8000 67999.9n 0.8000 68000.0n 0.2000 68249.9n 0.2000 68250.0n 0.8000 68499.9n 0.8000 68500.0n 0.2000 68749.9n 0.2000 68750.0n 0.8000 68999.9n 0.8000 69000.0n 0.2000 69249.9n 0.2000 69250.0n 0.8000 69499.9n 0.8000 69500.0n 0.2000 69749.9n 0.2000 69750.0n 0.8000 69999.9n 0.8000 70000.0n 0.2000 70249.9n 0.2000 70250.0n 0.8000 70499.9n 0.8000 70500.0n 0.2000 70749.9n 0.2000 70750.0n 0.8000 70999.9n 0.8000 71000.0n 0.2000 71249.9n 0.2000 71250.0n 0.8000 71499.9n 0.8000 71500.0n 0.2000 71749.9n 0.2000 71750.0n 0.8000 71999.9n 0.8000 72000.0n 0.2000 72249.9n 0.2000 72250.0n 0.8000 72499.9n 0.8000 72500.0n 0.2000 72749.9n 0.2000 72750.0n 0.8000 72999.9n 0.8000 73000.0n 0.2000 73249.9n 0.2000 73250.0n 0.8000 73499.9n 0.8000 73500.0n 0.2000 73749.9n 0.2000 73750.0n 0.8000 73999.9n 0.8000 74000.0n 0.2000 74249.9n 0.2000 74250.0n 0.8000 74499.9n 0.8000 74500.0n 0.2000 74749.9n 0.2000 74750.0n 0.8000 74999.9n 0.8000 75000.0n 0.2000 75249.9n 0.2000 75250.0n 0.8000 75499.9n 0.8000 75500.0n 0.2000 75749.9n 0.2000 75750.0n 0.8000 75999.9n 0.8000 76000.0n 0.2000 76249.9n 0.2000 76250.0n 0.8000 76499.9n 0.8000 76500.0n 0.2000 76749.9n 0.2000 76750.0n 0.8000 76999.9n 0.8000 77000.0n 0.2000 77249.9n 0.2000 77250.0n 0.8000 77499.9n 0.8000 77500.0n 0.2000 77749.9n 0.2000 77750.0n 0.8000 77999.9n 0.8000 78000.0n 0.2000 78249.9n 0.2000 78250.0n 0.8000 78499.9n 0.8000 78500.0n 0.2000 78749.9n 0.2000 78750.0n 0.8000 78999.9n 0.8000 79000.0n 0.2000 79249.9n 0.2000 79250.0n 0.8000 79499.9n 0.8000 79500.0n 0.2000 79749.9n 0.2000 79750.0n 0.8000 79999.9n 0.8000 80000.0n 0.2000 80249.9n 0.2000 80250.0n 0.8000 80499.9n 0.8000 80500.0n 0.2000 80749.9n 0.2000 80750.0n 0.8000 80999.9n 0.8000 81000.0n 0.2000 81249.9n 0.2000 81250.0n 0.8000 81499.9n 0.8000 81500.0n 0.2000 81749.9n 0.2000 81750.0n 0.8000 81999.9n 0.8000 82000.0n 0.2000 82249.9n 0.2000 82250.0n 0.8000 82499.9n 0.8000 82500.0n 0.2000 82749.9n 0.2000 82750.0n 0.8000 82999.9n 0.8000 83000.0n 0.2000 83249.9n 0.2000 83250.0n 0.8000 83499.9n 0.8000 83500.0n 0.2000 83749.9n 0.2000 83750.0n 0.8000 83999.9n 0.8000 84000.0n 0.2000 84249.9n 0.2000 84250.0n 0.8000 84499.9n 0.8000 84500.0n 0.2000 84749.9n 0.2000 84750.0n 0.8000 84999.9n 0.8000 85000.0n 0.2000 85249.9n 0.2000 85250.0n 0.8000 85499.9n 0.8000 85500.0n 0.2000 85749.9n 0.2000 85750.0n 0.8000 85999.9n 0.8000 86000.0n 0.2000 86249.9n 0.2000 86250.0n 0.8000 86499.9n 0.8000 86500.0n 0.2000 86749.9n 0.2000 86750.0n 0.8000 86999.9n 0.8000 87000.0n 0.2000 87249.9n 0.2000 87250.0n 0.8000 87499.9n 0.8000 87500.0n 0.2000 87749.9n 0.2000 87750.0n 0.8000 87999.9n 0.8000 88000.0n 0.2000 88249.9n 0.2000 88250.0n 0.8000 88499.9n 0.8000 88500.0n 0.2000 88749.9n 0.2000 88750.0n 0.8000 88999.9n 0.8000 89000.0n 0.2000 89249.9n 0.2000 89250.0n 0.8000 89499.9n 0.8000 89500.0n 0.2000 89749.9n 0.2000 89750.0n 0.8000 89999.9n 0.8000 90000.0n 0.2000 90249.9n 0.2000 90250.0n 0.8000 90499.9n 0.8000 90500.0n 0.2000 90749.9n 0.2000 90750.0n 0.8000 90999.9n 0.8000 91000.0n 0.2000 91249.9n 0.2000 91250.0n 0.8000 91499.9n 0.8000 91500.0n 0.2000 91749.9n 0.2000 91750.0n 0.8000 91999.9n 0.8000 92000.0n 0.2000 92249.9n 0.2000 92250.0n 0.8000 92499.9n 0.8000 92500.0n 0.2000 92749.9n 0.2000 92750.0n 0.8000 92999.9n 0.8000 93000.0n 0.2000 93249.9n 0.2000 93250.0n 0.8000 93499.9n 0.8000 93500.0n 0.2000 93749.9n 0.2000 93750.0n 0.8000 93999.9n 0.8000 94000.0n 0.2000 94249.9n 0.2000 94250.0n 0.8000 94499.9n 0.8000 94500.0n 0.2000 94749.9n 0.2000 94750.0n 0.8000 94999.9n 0.8000 95000.0n 0.2000 95249.9n 0.2000 95250.0n 0.8000 95499.9n 0.8000 95500.0n 0.2000 95749.9n 0.2000 95750.0n 0.8000 95999.9n 0.8000 96000.0n 0.2000 96249.9n 0.2000 96250.0n 0.8000 96499.9n 0.8000 96500.0n 0.2000 96749.9n 0.2000 96750.0n 0.8000 96999.9n 0.8000 97000.0n 0.2000 97249.9n 0.2000 97250.0n 0.8000 97499.9n 0.8000 97500.0n 0.2000 97749.9n 0.2000 97750.0n 0.8000 97999.9n 0.8000 98000.0n 0.2000 98249.9n 0.2000 98250.0n 0.8000 98499.9n 0.8000 98500.0n 0.2000 98749.9n 0.2000 98750.0n 0.8000 98999.9n 0.8000 99000.0n 0.2000 99249.9n 0.2000 99250.0n 0.8000 99499.9n 0.8000 99500.0n 0.2000 99749.9n 0.2000 99750.0n 0.8000 99999.9n 0.8000 100000.0n 0.2000 100249.9n 0.2000 100250.0n 0.8000 100499.9n 0.8000 100500.0n 0.2000 100749.9n 0.2000 100750.0n 0.8000 100999.9n 0.8000 101000.0n 0.2000 101249.9n 0.2000 101250.0n 0.8000 101499.9n 0.8000 101500.0n 0.2000 101749.9n 0.2000 101750.0n 0.8000 101999.9n 0.8000 102000.0n 0.2000 102249.9n 0.2000 102250.0n 0.8000 102499.9n 0.8000 102500.0n 0.2000 102749.9n 0.2000 102750.0n 0.8000 102999.9n 0.8000 103000.0n 0.2000 103249.9n 0.2000 103250.0n 0.8000 103499.9n 0.8000 103500.0n 0.2000 103749.9n 0.2000 103750.0n 0.8000 103999.9n 0.8000 104000.0n 0.2000 104249.9n 0.2000 104250.0n 0.8000 104499.9n 0.8000 104500.0n 0.2000 104749.9n 0.2000 104750.0n 0.8000 104999.9n 0.8000 105000.0n 0.2000 105249.9n 0.2000 105250.0n 0.8000 105499.9n 0.8000 105500.0n 0.2000 105749.9n 0.2000 105750.0n 0.8000 105999.9n 0.8000 106000.0n 0.2000 106249.9n 0.2000 106250.0n 0.8000 106499.9n 0.8000 106500.0n 0.2000 106749.9n 0.2000 106750.0n 0.8000 106999.9n 0.8000 107000.0n 0.2000 107249.9n 0.2000 107250.0n 0.8000 107499.9n 0.8000 107500.0n 0.2000 107749.9n 0.2000 107750.0n 0.8000 107999.9n 0.8000 108000.0n 0.2000 108249.9n 0.2000 108250.0n 0.8000 108499.9n 0.8000 108500.0n 0.2000 108749.9n 0.2000 108750.0n 0.8000 108999.9n 0.8000 109000.0n 0.2000 109249.9n 0.2000 109250.0n 0.8000 109499.9n 0.8000 109500.0n 0.2000 109749.9n 0.2000 109750.0n 0.8000 109999.9n 0.8000 110000.0n 0.2000 110249.9n 0.2000 110250.0n 0.8000 110499.9n 0.8000 110500.0n 0.2000 110749.9n 0.2000 110750.0n 0.8000 110999.9n 0.8000 111000.0n 0.2000 111249.9n 0.2000 111250.0n 0.8000 111499.9n 0.8000 111500.0n 0.2000 111749.9n 0.2000 111750.0n 0.8000 111999.9n 0.8000 112000.0n 0.2000 112249.9n 0.2000 112250.0n 0.8000 112499.9n 0.8000 112500.0n 0.2000 112749.9n 0.2000 112750.0n 0.8000 112999.9n 0.8000 113000.0n 0.2000 113249.9n 0.2000 113250.0n 0.8000 113499.9n 0.8000 113500.0n 0.2000 113749.9n 0.2000 113750.0n 0.8000 113999.9n 0.8000 114000.0n 0.2000 114249.9n 0.2000 114250.0n 0.8000 114499.9n 0.8000 114500.0n 0.2000 114749.9n 0.2000 114750.0n 0.8000 114999.9n 0.8000 115000.0n 0.2000 115249.9n 0.2000 115250.0n 0.8000 115499.9n 0.8000 115500.0n 0.2000 115749.9n 0.2000 115750.0n 0.8000 115999.9n 0.8000 116000.0n 0.2000 116249.9n 0.2000 116250.0n 0.8000 116499.9n 0.8000 116500.0n 0.2000 116749.9n 0.2000 116750.0n 0.8000 116999.9n 0.8000 117000.0n 0.2000 117249.9n 0.2000 117250.0n 0.8000 117499.9n 0.8000 117500.0n 0.2000 117749.9n 0.2000 117750.0n 0.8000 117999.9n 0.8000 118000.0n 0.2000 118249.9n 0.2000 118250.0n 0.8000 118499.9n 0.8000 118500.0n 0.2000 118749.9n 0.2000 118750.0n 0.8000 118999.9n 0.8000 119000.0n 0.2000 119249.9n 0.2000 119250.0n 0.8000 119499.9n 0.8000 119500.0n 0.2000 119749.9n 0.2000 119750.0n 0.8000 119999.9n 0.8000 120000.0n 0.2000 120249.9n 0.2000 120250.0n 0.8000 120499.9n 0.8000 120500.0n 0.2000 120749.9n 0.2000 120750.0n 0.8000 120999.9n 0.8000 121000.0n 0.2000 121249.9n 0.2000 121250.0n 0.8000 121499.9n 0.8000 121500.0n 0.2000 121749.9n 0.2000 121750.0n 0.8000 121999.9n 0.8000 122000.0n 0.2000 122249.9n 0.2000 122250.0n 0.8000 122499.9n 0.8000 122500.0n 0.2000 122749.9n 0.2000 122750.0n 0.8000 122999.9n 0.8000 123000.0n 0.2000 123249.9n 0.2000 123250.0n 0.8000 123499.9n 0.8000 123500.0n 0.2000 123749.9n 0.2000 123750.0n 0.8000 123999.9n 0.8000 124000.0n 0.2000 124249.9n 0.2000 124250.0n 0.8000 124499.9n 0.8000 124500.0n 0.2000 124749.9n 0.2000 124750.0n 0.8000 124999.9n 0.8000 125000.0n 0.2000 125249.9n 0.2000 125250.0n 0.8000 125499.9n 0.8000 125500.0n 0.2000 125749.9n 0.2000 125750.0n 0.8000 125999.9n 0.8000 126000.0n 0.2000 126249.9n 0.2000 126250.0n 0.8000 126499.9n 0.8000 126500.0n 0.2000 126749.9n 0.2000 126750.0n 0.8000 126999.9n 0.8000 127000.0n 0.2000 127249.9n 0.2000 127250.0n 0.8000 127499.9n 0.8000 127500.0n 0.2000 127749.9n 0.2000 127750.0n 0.8000 127999.9n 0.8000 128000.0n 0.2000 128249.9n 0.2000 128250.0n 0.8000 128499.9n 0.8000 128500.0n 0.2000 128749.9n 0.2000 128750.0n 0.8000 128999.9n 0.8000 129000.0n 0.2000 129249.9n 0.2000 129250.0n 0.8000 129499.9n 0.8000 129500.0n 0.2000 129749.9n 0.2000 129750.0n 0.8000 129999.9n 0.8000 130000.0n 0.2000 130249.9n 0.2000 130250.0n 0.8000 130499.9n 0.8000 130500.0n 0.2000 130749.9n 0.2000 130750.0n 0.8000 130999.9n 0.8000 131000.0n 0.2000 131249.9n 0.2000 131250.0n 0.8000 131499.9n 0.8000 131500.0n 0.2000 131749.9n 0.2000 131750.0n 0.8000 131999.9n 0.8000 132000.0n 0.2000 132249.9n 0.2000 132250.0n 0.8000 132499.9n 0.8000 132500.0n 0.2000 132749.9n 0.2000 132750.0n 0.8000 132999.9n 0.8000 133000.0n 0.2000 133249.9n 0.2000 133250.0n 0.8000 133499.9n 0.8000 133500.0n 0.2000 133749.9n 0.2000 133750.0n 0.8000 133999.9n 0.8000 134000.0n 0.2000 134249.9n 0.2000 134250.0n 0.8000 134499.9n 0.8000 134500.0n 0.2000 134749.9n 0.2000 134750.0n 0.8000 134999.9n 0.8000 135000.0n 0.2000 135249.9n 0.2000 135250.0n 0.8000 135499.9n 0.8000 135500.0n 0.2000 135749.9n 0.2000 135750.0n 0.8000 135999.9n 0.8000 136000.0n 0.2000 136249.9n 0.2000 136250.0n 0.8000 136499.9n 0.8000 136500.0n 0.2000 136749.9n 0.2000 136750.0n 0.8000 136999.9n 0.8000 137000.0n 0.2000 137249.9n 0.2000 137250.0n 0.8000 137499.9n 0.8000 137500.0n 0.2000 137749.9n 0.2000 137750.0n 0.8000 137999.9n 0.8000 138000.0n 0.2000 138249.9n 0.2000 138250.0n 0.8000 138499.9n 0.8000 138500.0n 0.2000 138749.9n 0.2000 138750.0n 0.8000 138999.9n 0.8000 139000.0n 0.2000 139249.9n 0.2000 139250.0n 0.8000 139499.9n 0.8000 139500.0n 0.2000 139749.9n 0.2000 139750.0n 0.8000 139999.9n 0.8000 140000.0n 0.2000 140249.9n 0.2000 140250.0n 0.8000 140499.9n 0.8000 140500.0n 0.2000 140749.9n 0.2000 140750.0n 0.8000 140999.9n 0.8000 141000.0n 0.2000 141249.9n 0.2000 141250.0n 0.8000 141499.9n 0.8000 141500.0n 0.2000 141749.9n 0.2000 141750.0n 0.8000 141999.9n 0.8000 142000.0n 0.2000 142249.9n 0.2000 142250.0n 0.8000 142499.9n 0.8000 142500.0n 0.2000 142749.9n 0.2000 142750.0n 0.8000 142999.9n 0.8000 143000.0n 0.2000 143249.9n 0.2000 143250.0n 0.8000 143499.9n 0.8000 143500.0n 0.2000 143749.9n 0.2000 143750.0n 0.8000 143999.9n 0.8000 144000.0n 0.2000 144249.9n 0.2000 144250.0n 0.8000 144499.9n 0.8000 144500.0n 0.2000 144749.9n 0.2000 144750.0n 0.8000 144999.9n 0.8000 145000.0n 0.2000 145249.9n 0.2000 145250.0n 0.8000 145499.9n 0.8000 145500.0n 0.2000 145749.9n 0.2000 145750.0n 0.8000 145999.9n 0.8000 146000.0n 0.2000 146249.9n 0.2000 146250.0n 0.8000 146499.9n 0.8000 146500.0n 0.2000 146749.9n 0.2000 146750.0n 0.8000 146999.9n 0.8000 147000.0n 0.2000 147249.9n 0.2000 147250.0n 0.8000 147499.9n 0.8000 147500.0n 0.2000 147749.9n 0.2000 147750.0n 0.8000 147999.9n 0.8000 148000.0n 0.2000 148249.9n 0.2000 148250.0n 0.8000 148499.9n 0.8000 148500.0n 0.2000 148749.9n 0.2000 148750.0n 0.8000 148999.9n 0.8000 149000.0n 0.2000 149249.9n 0.2000 149250.0n 0.8000 149499.9n 0.8000 149500.0n 0.2000 149749.9n 0.2000 149750.0n 0.8000 149999.9n 0.8000 150000.0n 0.2000 150249.9n 0.2000 150250.0n 0.8000 150499.9n 0.8000 150500.0n 0.2000 150749.9n 0.2000 150750.0n 0.8000 150999.9n 0.8000 151000.0n 0.2000 151249.9n 0.2000 151250.0n 0.8000 151499.9n 0.8000 151500.0n 0.2000 151749.9n 0.2000 151750.0n 0.8000 151999.9n 0.8000 152000.0n 0.2000 152249.9n 0.2000 152250.0n 0.8000 152499.9n 0.8000 152500.0n 0.2000 152749.9n 0.2000 152750.0n 0.8000 152999.9n 0.8000 153000.0n 0.2000 153249.9n 0.2000 153250.0n 0.8000 153499.9n 0.8000 153500.0n 0.2000 153749.9n 0.2000 153750.0n 0.8000 153999.9n 0.8000 154000.0n 0.2000 154249.9n 0.2000 154250.0n 0.8000 154499.9n 0.8000 154500.0n 0.2000 154749.9n 0.2000 154750.0n 0.8000 154999.9n 0.8000 155000.0n 0.2000 155249.9n 0.2000 155250.0n 0.8000 155499.9n 0.8000 155500.0n 0.2000 155749.9n 0.2000 155750.0n 0.8000 155999.9n 0.8000 156000.0n 0.2000 156249.9n 0.2000 156250.0n 0.8000 156499.9n 0.8000 156500.0n 0.2000 156749.9n 0.2000 156750.0n 0.8000 156999.9n 0.8000 157000.0n 0.2000 157249.9n 0.2000 157250.0n 0.8000 157499.9n 0.8000 157500.0n 0.2000 157749.9n 0.2000 157750.0n 0.8000 157999.9n 0.8000 158000.0n 0.2000 158249.9n 0.2000 158250.0n 0.8000 158499.9n 0.8000 158500.0n 0.2000 158749.9n 0.2000 158750.0n 0.8000 158999.9n 0.8000 159000.0n 0.2000 159249.9n 0.2000 159250.0n 0.8000 159499.9n 0.8000 159500.0n 0.2000 159749.9n 0.2000 159750.0n 0.8000)
Vx2n a_xn2 0 PWL(0.0n 0.8000 249.9n 0.8000 250.0n 0.2000 499.9n 0.2000 500.0n 0.8000 749.9n 0.8000 750.0n 0.2000 999.9n 0.2000 1000.0n 0.8000 1249.9n 0.8000 1250.0n 0.2000 1499.9n 0.2000 1500.0n 0.8000 1749.9n 0.8000 1750.0n 0.2000 1999.9n 0.2000 2000.0n 0.8000 2249.9n 0.8000 2250.0n 0.2000 2499.9n 0.2000 2500.0n 0.8000 2749.9n 0.8000 2750.0n 0.2000 2999.9n 0.2000 3000.0n 0.8000 3249.9n 0.8000 3250.0n 0.2000 3499.9n 0.2000 3500.0n 0.8000 3749.9n 0.8000 3750.0n 0.2000 3999.9n 0.2000 4000.0n 0.8000 4249.9n 0.8000 4250.0n 0.2000 4499.9n 0.2000 4500.0n 0.8000 4749.9n 0.8000 4750.0n 0.2000 4999.9n 0.2000 5000.0n 0.8000 5249.9n 0.8000 5250.0n 0.2000 5499.9n 0.2000 5500.0n 0.8000 5749.9n 0.8000 5750.0n 0.2000 5999.9n 0.2000 6000.0n 0.8000 6249.9n 0.8000 6250.0n 0.2000 6499.9n 0.2000 6500.0n 0.8000 6749.9n 0.8000 6750.0n 0.2000 6999.9n 0.2000 7000.0n 0.8000 7249.9n 0.8000 7250.0n 0.2000 7499.9n 0.2000 7500.0n 0.8000 7749.9n 0.8000 7750.0n 0.2000 7999.9n 0.2000 8000.0n 0.8000 8249.9n 0.8000 8250.0n 0.2000 8499.9n 0.2000 8500.0n 0.8000 8749.9n 0.8000 8750.0n 0.2000 8999.9n 0.2000 9000.0n 0.8000 9249.9n 0.8000 9250.0n 0.2000 9499.9n 0.2000 9500.0n 0.8000 9749.9n 0.8000 9750.0n 0.2000 9999.9n 0.2000 10000.0n 0.8000 10249.9n 0.8000 10250.0n 0.2000 10499.9n 0.2000 10500.0n 0.8000 10749.9n 0.8000 10750.0n 0.2000 10999.9n 0.2000 11000.0n 0.8000 11249.9n 0.8000 11250.0n 0.2000 11499.9n 0.2000 11500.0n 0.8000 11749.9n 0.8000 11750.0n 0.2000 11999.9n 0.2000 12000.0n 0.8000 12249.9n 0.8000 12250.0n 0.2000 12499.9n 0.2000 12500.0n 0.8000 12749.9n 0.8000 12750.0n 0.2000 12999.9n 0.2000 13000.0n 0.8000 13249.9n 0.8000 13250.0n 0.2000 13499.9n 0.2000 13500.0n 0.8000 13749.9n 0.8000 13750.0n 0.2000 13999.9n 0.2000 14000.0n 0.8000 14249.9n 0.8000 14250.0n 0.2000 14499.9n 0.2000 14500.0n 0.8000 14749.9n 0.8000 14750.0n 0.2000 14999.9n 0.2000 15000.0n 0.8000 15249.9n 0.8000 15250.0n 0.2000 15499.9n 0.2000 15500.0n 0.8000 15749.9n 0.8000 15750.0n 0.2000 15999.9n 0.2000 16000.0n 0.8000 16249.9n 0.8000 16250.0n 0.2000 16499.9n 0.2000 16500.0n 0.8000 16749.9n 0.8000 16750.0n 0.2000 16999.9n 0.2000 17000.0n 0.8000 17249.9n 0.8000 17250.0n 0.2000 17499.9n 0.2000 17500.0n 0.8000 17749.9n 0.8000 17750.0n 0.2000 17999.9n 0.2000 18000.0n 0.8000 18249.9n 0.8000 18250.0n 0.2000 18499.9n 0.2000 18500.0n 0.8000 18749.9n 0.8000 18750.0n 0.2000 18999.9n 0.2000 19000.0n 0.8000 19249.9n 0.8000 19250.0n 0.2000 19499.9n 0.2000 19500.0n 0.8000 19749.9n 0.8000 19750.0n 0.2000 19999.9n 0.2000 20000.0n 0.8000 20249.9n 0.8000 20250.0n 0.2000 20499.9n 0.2000 20500.0n 0.8000 20749.9n 0.8000 20750.0n 0.2000 20999.9n 0.2000 21000.0n 0.8000 21249.9n 0.8000 21250.0n 0.2000 21499.9n 0.2000 21500.0n 0.8000 21749.9n 0.8000 21750.0n 0.2000 21999.9n 0.2000 22000.0n 0.8000 22249.9n 0.8000 22250.0n 0.2000 22499.9n 0.2000 22500.0n 0.8000 22749.9n 0.8000 22750.0n 0.2000 22999.9n 0.2000 23000.0n 0.8000 23249.9n 0.8000 23250.0n 0.2000 23499.9n 0.2000 23500.0n 0.8000 23749.9n 0.8000 23750.0n 0.2000 23999.9n 0.2000 24000.0n 0.8000 24249.9n 0.8000 24250.0n 0.2000 24499.9n 0.2000 24500.0n 0.8000 24749.9n 0.8000 24750.0n 0.2000 24999.9n 0.2000 25000.0n 0.8000 25249.9n 0.8000 25250.0n 0.2000 25499.9n 0.2000 25500.0n 0.8000 25749.9n 0.8000 25750.0n 0.2000 25999.9n 0.2000 26000.0n 0.8000 26249.9n 0.8000 26250.0n 0.2000 26499.9n 0.2000 26500.0n 0.8000 26749.9n 0.8000 26750.0n 0.2000 26999.9n 0.2000 27000.0n 0.8000 27249.9n 0.8000 27250.0n 0.2000 27499.9n 0.2000 27500.0n 0.8000 27749.9n 0.8000 27750.0n 0.2000 27999.9n 0.2000 28000.0n 0.8000 28249.9n 0.8000 28250.0n 0.2000 28499.9n 0.2000 28500.0n 0.8000 28749.9n 0.8000 28750.0n 0.2000 28999.9n 0.2000 29000.0n 0.8000 29249.9n 0.8000 29250.0n 0.2000 29499.9n 0.2000 29500.0n 0.8000 29749.9n 0.8000 29750.0n 0.2000 29999.9n 0.2000 30000.0n 0.8000 30249.9n 0.8000 30250.0n 0.2000 30499.9n 0.2000 30500.0n 0.8000 30749.9n 0.8000 30750.0n 0.2000 30999.9n 0.2000 31000.0n 0.8000 31249.9n 0.8000 31250.0n 0.2000 31499.9n 0.2000 31500.0n 0.8000 31749.9n 0.8000 31750.0n 0.2000 31999.9n 0.2000 32000.0n 0.8000 32249.9n 0.8000 32250.0n 0.2000 32499.9n 0.2000 32500.0n 0.8000 32749.9n 0.8000 32750.0n 0.2000 32999.9n 0.2000 33000.0n 0.8000 33249.9n 0.8000 33250.0n 0.2000 33499.9n 0.2000 33500.0n 0.8000 33749.9n 0.8000 33750.0n 0.2000 33999.9n 0.2000 34000.0n 0.8000 34249.9n 0.8000 34250.0n 0.2000 34499.9n 0.2000 34500.0n 0.8000 34749.9n 0.8000 34750.0n 0.2000 34999.9n 0.2000 35000.0n 0.8000 35249.9n 0.8000 35250.0n 0.2000 35499.9n 0.2000 35500.0n 0.8000 35749.9n 0.8000 35750.0n 0.2000 35999.9n 0.2000 36000.0n 0.8000 36249.9n 0.8000 36250.0n 0.2000 36499.9n 0.2000 36500.0n 0.8000 36749.9n 0.8000 36750.0n 0.2000 36999.9n 0.2000 37000.0n 0.8000 37249.9n 0.8000 37250.0n 0.2000 37499.9n 0.2000 37500.0n 0.8000 37749.9n 0.8000 37750.0n 0.2000 37999.9n 0.2000 38000.0n 0.8000 38249.9n 0.8000 38250.0n 0.2000 38499.9n 0.2000 38500.0n 0.8000 38749.9n 0.8000 38750.0n 0.2000 38999.9n 0.2000 39000.0n 0.8000 39249.9n 0.8000 39250.0n 0.2000 39499.9n 0.2000 39500.0n 0.8000 39749.9n 0.8000 39750.0n 0.2000 39999.9n 0.2000 40000.0n 0.8000 40249.9n 0.8000 40250.0n 0.2000 40499.9n 0.2000 40500.0n 0.8000 40749.9n 0.8000 40750.0n 0.2000 40999.9n 0.2000 41000.0n 0.8000 41249.9n 0.8000 41250.0n 0.2000 41499.9n 0.2000 41500.0n 0.8000 41749.9n 0.8000 41750.0n 0.2000 41999.9n 0.2000 42000.0n 0.8000 42249.9n 0.8000 42250.0n 0.2000 42499.9n 0.2000 42500.0n 0.8000 42749.9n 0.8000 42750.0n 0.2000 42999.9n 0.2000 43000.0n 0.8000 43249.9n 0.8000 43250.0n 0.2000 43499.9n 0.2000 43500.0n 0.8000 43749.9n 0.8000 43750.0n 0.2000 43999.9n 0.2000 44000.0n 0.8000 44249.9n 0.8000 44250.0n 0.2000 44499.9n 0.2000 44500.0n 0.8000 44749.9n 0.8000 44750.0n 0.2000 44999.9n 0.2000 45000.0n 0.8000 45249.9n 0.8000 45250.0n 0.2000 45499.9n 0.2000 45500.0n 0.8000 45749.9n 0.8000 45750.0n 0.2000 45999.9n 0.2000 46000.0n 0.8000 46249.9n 0.8000 46250.0n 0.2000 46499.9n 0.2000 46500.0n 0.8000 46749.9n 0.8000 46750.0n 0.2000 46999.9n 0.2000 47000.0n 0.8000 47249.9n 0.8000 47250.0n 0.2000 47499.9n 0.2000 47500.0n 0.8000 47749.9n 0.8000 47750.0n 0.2000 47999.9n 0.2000 48000.0n 0.8000 48249.9n 0.8000 48250.0n 0.2000 48499.9n 0.2000 48500.0n 0.8000 48749.9n 0.8000 48750.0n 0.2000 48999.9n 0.2000 49000.0n 0.8000 49249.9n 0.8000 49250.0n 0.2000 49499.9n 0.2000 49500.0n 0.8000 49749.9n 0.8000 49750.0n 0.2000 49999.9n 0.2000 50000.0n 0.8000 50249.9n 0.8000 50250.0n 0.2000 50499.9n 0.2000 50500.0n 0.8000 50749.9n 0.8000 50750.0n 0.2000 50999.9n 0.2000 51000.0n 0.8000 51249.9n 0.8000 51250.0n 0.2000 51499.9n 0.2000 51500.0n 0.8000 51749.9n 0.8000 51750.0n 0.2000 51999.9n 0.2000 52000.0n 0.8000 52249.9n 0.8000 52250.0n 0.2000 52499.9n 0.2000 52500.0n 0.8000 52749.9n 0.8000 52750.0n 0.2000 52999.9n 0.2000 53000.0n 0.8000 53249.9n 0.8000 53250.0n 0.2000 53499.9n 0.2000 53500.0n 0.8000 53749.9n 0.8000 53750.0n 0.2000 53999.9n 0.2000 54000.0n 0.8000 54249.9n 0.8000 54250.0n 0.2000 54499.9n 0.2000 54500.0n 0.8000 54749.9n 0.8000 54750.0n 0.2000 54999.9n 0.2000 55000.0n 0.8000 55249.9n 0.8000 55250.0n 0.2000 55499.9n 0.2000 55500.0n 0.8000 55749.9n 0.8000 55750.0n 0.2000 55999.9n 0.2000 56000.0n 0.8000 56249.9n 0.8000 56250.0n 0.2000 56499.9n 0.2000 56500.0n 0.8000 56749.9n 0.8000 56750.0n 0.2000 56999.9n 0.2000 57000.0n 0.8000 57249.9n 0.8000 57250.0n 0.2000 57499.9n 0.2000 57500.0n 0.8000 57749.9n 0.8000 57750.0n 0.2000 57999.9n 0.2000 58000.0n 0.8000 58249.9n 0.8000 58250.0n 0.2000 58499.9n 0.2000 58500.0n 0.8000 58749.9n 0.8000 58750.0n 0.2000 58999.9n 0.2000 59000.0n 0.8000 59249.9n 0.8000 59250.0n 0.2000 59499.9n 0.2000 59500.0n 0.8000 59749.9n 0.8000 59750.0n 0.2000 59999.9n 0.2000 60000.0n 0.8000 60249.9n 0.8000 60250.0n 0.2000 60499.9n 0.2000 60500.0n 0.8000 60749.9n 0.8000 60750.0n 0.2000 60999.9n 0.2000 61000.0n 0.8000 61249.9n 0.8000 61250.0n 0.2000 61499.9n 0.2000 61500.0n 0.8000 61749.9n 0.8000 61750.0n 0.2000 61999.9n 0.2000 62000.0n 0.8000 62249.9n 0.8000 62250.0n 0.2000 62499.9n 0.2000 62500.0n 0.8000 62749.9n 0.8000 62750.0n 0.2000 62999.9n 0.2000 63000.0n 0.8000 63249.9n 0.8000 63250.0n 0.2000 63499.9n 0.2000 63500.0n 0.8000 63749.9n 0.8000 63750.0n 0.2000 63999.9n 0.2000 64000.0n 0.8000 64249.9n 0.8000 64250.0n 0.2000 64499.9n 0.2000 64500.0n 0.8000 64749.9n 0.8000 64750.0n 0.2000 64999.9n 0.2000 65000.0n 0.8000 65249.9n 0.8000 65250.0n 0.2000 65499.9n 0.2000 65500.0n 0.8000 65749.9n 0.8000 65750.0n 0.2000 65999.9n 0.2000 66000.0n 0.8000 66249.9n 0.8000 66250.0n 0.2000 66499.9n 0.2000 66500.0n 0.8000 66749.9n 0.8000 66750.0n 0.2000 66999.9n 0.2000 67000.0n 0.8000 67249.9n 0.8000 67250.0n 0.2000 67499.9n 0.2000 67500.0n 0.8000 67749.9n 0.8000 67750.0n 0.2000 67999.9n 0.2000 68000.0n 0.8000 68249.9n 0.8000 68250.0n 0.2000 68499.9n 0.2000 68500.0n 0.8000 68749.9n 0.8000 68750.0n 0.2000 68999.9n 0.2000 69000.0n 0.8000 69249.9n 0.8000 69250.0n 0.2000 69499.9n 0.2000 69500.0n 0.8000 69749.9n 0.8000 69750.0n 0.2000 69999.9n 0.2000 70000.0n 0.8000 70249.9n 0.8000 70250.0n 0.2000 70499.9n 0.2000 70500.0n 0.8000 70749.9n 0.8000 70750.0n 0.2000 70999.9n 0.2000 71000.0n 0.8000 71249.9n 0.8000 71250.0n 0.2000 71499.9n 0.2000 71500.0n 0.8000 71749.9n 0.8000 71750.0n 0.2000 71999.9n 0.2000 72000.0n 0.8000 72249.9n 0.8000 72250.0n 0.2000 72499.9n 0.2000 72500.0n 0.8000 72749.9n 0.8000 72750.0n 0.2000 72999.9n 0.2000 73000.0n 0.8000 73249.9n 0.8000 73250.0n 0.2000 73499.9n 0.2000 73500.0n 0.8000 73749.9n 0.8000 73750.0n 0.2000 73999.9n 0.2000 74000.0n 0.8000 74249.9n 0.8000 74250.0n 0.2000 74499.9n 0.2000 74500.0n 0.8000 74749.9n 0.8000 74750.0n 0.2000 74999.9n 0.2000 75000.0n 0.8000 75249.9n 0.8000 75250.0n 0.2000 75499.9n 0.2000 75500.0n 0.8000 75749.9n 0.8000 75750.0n 0.2000 75999.9n 0.2000 76000.0n 0.8000 76249.9n 0.8000 76250.0n 0.2000 76499.9n 0.2000 76500.0n 0.8000 76749.9n 0.8000 76750.0n 0.2000 76999.9n 0.2000 77000.0n 0.8000 77249.9n 0.8000 77250.0n 0.2000 77499.9n 0.2000 77500.0n 0.8000 77749.9n 0.8000 77750.0n 0.2000 77999.9n 0.2000 78000.0n 0.8000 78249.9n 0.8000 78250.0n 0.2000 78499.9n 0.2000 78500.0n 0.8000 78749.9n 0.8000 78750.0n 0.2000 78999.9n 0.2000 79000.0n 0.8000 79249.9n 0.8000 79250.0n 0.2000 79499.9n 0.2000 79500.0n 0.8000 79749.9n 0.8000 79750.0n 0.2000 79999.9n 0.2000 80000.0n 0.8000 80249.9n 0.8000 80250.0n 0.2000 80499.9n 0.2000 80500.0n 0.8000 80749.9n 0.8000 80750.0n 0.2000 80999.9n 0.2000 81000.0n 0.8000 81249.9n 0.8000 81250.0n 0.2000 81499.9n 0.2000 81500.0n 0.8000 81749.9n 0.8000 81750.0n 0.2000 81999.9n 0.2000 82000.0n 0.8000 82249.9n 0.8000 82250.0n 0.2000 82499.9n 0.2000 82500.0n 0.8000 82749.9n 0.8000 82750.0n 0.2000 82999.9n 0.2000 83000.0n 0.8000 83249.9n 0.8000 83250.0n 0.2000 83499.9n 0.2000 83500.0n 0.8000 83749.9n 0.8000 83750.0n 0.2000 83999.9n 0.2000 84000.0n 0.8000 84249.9n 0.8000 84250.0n 0.2000 84499.9n 0.2000 84500.0n 0.8000 84749.9n 0.8000 84750.0n 0.2000 84999.9n 0.2000 85000.0n 0.8000 85249.9n 0.8000 85250.0n 0.2000 85499.9n 0.2000 85500.0n 0.8000 85749.9n 0.8000 85750.0n 0.2000 85999.9n 0.2000 86000.0n 0.8000 86249.9n 0.8000 86250.0n 0.2000 86499.9n 0.2000 86500.0n 0.8000 86749.9n 0.8000 86750.0n 0.2000 86999.9n 0.2000 87000.0n 0.8000 87249.9n 0.8000 87250.0n 0.2000 87499.9n 0.2000 87500.0n 0.8000 87749.9n 0.8000 87750.0n 0.2000 87999.9n 0.2000 88000.0n 0.8000 88249.9n 0.8000 88250.0n 0.2000 88499.9n 0.2000 88500.0n 0.8000 88749.9n 0.8000 88750.0n 0.2000 88999.9n 0.2000 89000.0n 0.8000 89249.9n 0.8000 89250.0n 0.2000 89499.9n 0.2000 89500.0n 0.8000 89749.9n 0.8000 89750.0n 0.2000 89999.9n 0.2000 90000.0n 0.8000 90249.9n 0.8000 90250.0n 0.2000 90499.9n 0.2000 90500.0n 0.8000 90749.9n 0.8000 90750.0n 0.2000 90999.9n 0.2000 91000.0n 0.8000 91249.9n 0.8000 91250.0n 0.2000 91499.9n 0.2000 91500.0n 0.8000 91749.9n 0.8000 91750.0n 0.2000 91999.9n 0.2000 92000.0n 0.8000 92249.9n 0.8000 92250.0n 0.2000 92499.9n 0.2000 92500.0n 0.8000 92749.9n 0.8000 92750.0n 0.2000 92999.9n 0.2000 93000.0n 0.8000 93249.9n 0.8000 93250.0n 0.2000 93499.9n 0.2000 93500.0n 0.8000 93749.9n 0.8000 93750.0n 0.2000 93999.9n 0.2000 94000.0n 0.8000 94249.9n 0.8000 94250.0n 0.2000 94499.9n 0.2000 94500.0n 0.8000 94749.9n 0.8000 94750.0n 0.2000 94999.9n 0.2000 95000.0n 0.8000 95249.9n 0.8000 95250.0n 0.2000 95499.9n 0.2000 95500.0n 0.8000 95749.9n 0.8000 95750.0n 0.2000 95999.9n 0.2000 96000.0n 0.8000 96249.9n 0.8000 96250.0n 0.2000 96499.9n 0.2000 96500.0n 0.8000 96749.9n 0.8000 96750.0n 0.2000 96999.9n 0.2000 97000.0n 0.8000 97249.9n 0.8000 97250.0n 0.2000 97499.9n 0.2000 97500.0n 0.8000 97749.9n 0.8000 97750.0n 0.2000 97999.9n 0.2000 98000.0n 0.8000 98249.9n 0.8000 98250.0n 0.2000 98499.9n 0.2000 98500.0n 0.8000 98749.9n 0.8000 98750.0n 0.2000 98999.9n 0.2000 99000.0n 0.8000 99249.9n 0.8000 99250.0n 0.2000 99499.9n 0.2000 99500.0n 0.8000 99749.9n 0.8000 99750.0n 0.2000 99999.9n 0.2000 100000.0n 0.8000 100249.9n 0.8000 100250.0n 0.2000 100499.9n 0.2000 100500.0n 0.8000 100749.9n 0.8000 100750.0n 0.2000 100999.9n 0.2000 101000.0n 0.8000 101249.9n 0.8000 101250.0n 0.2000 101499.9n 0.2000 101500.0n 0.8000 101749.9n 0.8000 101750.0n 0.2000 101999.9n 0.2000 102000.0n 0.8000 102249.9n 0.8000 102250.0n 0.2000 102499.9n 0.2000 102500.0n 0.8000 102749.9n 0.8000 102750.0n 0.2000 102999.9n 0.2000 103000.0n 0.8000 103249.9n 0.8000 103250.0n 0.2000 103499.9n 0.2000 103500.0n 0.8000 103749.9n 0.8000 103750.0n 0.2000 103999.9n 0.2000 104000.0n 0.8000 104249.9n 0.8000 104250.0n 0.2000 104499.9n 0.2000 104500.0n 0.8000 104749.9n 0.8000 104750.0n 0.2000 104999.9n 0.2000 105000.0n 0.8000 105249.9n 0.8000 105250.0n 0.2000 105499.9n 0.2000 105500.0n 0.8000 105749.9n 0.8000 105750.0n 0.2000 105999.9n 0.2000 106000.0n 0.8000 106249.9n 0.8000 106250.0n 0.2000 106499.9n 0.2000 106500.0n 0.8000 106749.9n 0.8000 106750.0n 0.2000 106999.9n 0.2000 107000.0n 0.8000 107249.9n 0.8000 107250.0n 0.2000 107499.9n 0.2000 107500.0n 0.8000 107749.9n 0.8000 107750.0n 0.2000 107999.9n 0.2000 108000.0n 0.8000 108249.9n 0.8000 108250.0n 0.2000 108499.9n 0.2000 108500.0n 0.8000 108749.9n 0.8000 108750.0n 0.2000 108999.9n 0.2000 109000.0n 0.8000 109249.9n 0.8000 109250.0n 0.2000 109499.9n 0.2000 109500.0n 0.8000 109749.9n 0.8000 109750.0n 0.2000 109999.9n 0.2000 110000.0n 0.8000 110249.9n 0.8000 110250.0n 0.2000 110499.9n 0.2000 110500.0n 0.8000 110749.9n 0.8000 110750.0n 0.2000 110999.9n 0.2000 111000.0n 0.8000 111249.9n 0.8000 111250.0n 0.2000 111499.9n 0.2000 111500.0n 0.8000 111749.9n 0.8000 111750.0n 0.2000 111999.9n 0.2000 112000.0n 0.8000 112249.9n 0.8000 112250.0n 0.2000 112499.9n 0.2000 112500.0n 0.8000 112749.9n 0.8000 112750.0n 0.2000 112999.9n 0.2000 113000.0n 0.8000 113249.9n 0.8000 113250.0n 0.2000 113499.9n 0.2000 113500.0n 0.8000 113749.9n 0.8000 113750.0n 0.2000 113999.9n 0.2000 114000.0n 0.8000 114249.9n 0.8000 114250.0n 0.2000 114499.9n 0.2000 114500.0n 0.8000 114749.9n 0.8000 114750.0n 0.2000 114999.9n 0.2000 115000.0n 0.8000 115249.9n 0.8000 115250.0n 0.2000 115499.9n 0.2000 115500.0n 0.8000 115749.9n 0.8000 115750.0n 0.2000 115999.9n 0.2000 116000.0n 0.8000 116249.9n 0.8000 116250.0n 0.2000 116499.9n 0.2000 116500.0n 0.8000 116749.9n 0.8000 116750.0n 0.2000 116999.9n 0.2000 117000.0n 0.8000 117249.9n 0.8000 117250.0n 0.2000 117499.9n 0.2000 117500.0n 0.8000 117749.9n 0.8000 117750.0n 0.2000 117999.9n 0.2000 118000.0n 0.8000 118249.9n 0.8000 118250.0n 0.2000 118499.9n 0.2000 118500.0n 0.8000 118749.9n 0.8000 118750.0n 0.2000 118999.9n 0.2000 119000.0n 0.8000 119249.9n 0.8000 119250.0n 0.2000 119499.9n 0.2000 119500.0n 0.8000 119749.9n 0.8000 119750.0n 0.2000 119999.9n 0.2000 120000.0n 0.8000 120249.9n 0.8000 120250.0n 0.2000 120499.9n 0.2000 120500.0n 0.8000 120749.9n 0.8000 120750.0n 0.2000 120999.9n 0.2000 121000.0n 0.8000 121249.9n 0.8000 121250.0n 0.2000 121499.9n 0.2000 121500.0n 0.8000 121749.9n 0.8000 121750.0n 0.2000 121999.9n 0.2000 122000.0n 0.8000 122249.9n 0.8000 122250.0n 0.2000 122499.9n 0.2000 122500.0n 0.8000 122749.9n 0.8000 122750.0n 0.2000 122999.9n 0.2000 123000.0n 0.8000 123249.9n 0.8000 123250.0n 0.2000 123499.9n 0.2000 123500.0n 0.8000 123749.9n 0.8000 123750.0n 0.2000 123999.9n 0.2000 124000.0n 0.8000 124249.9n 0.8000 124250.0n 0.2000 124499.9n 0.2000 124500.0n 0.8000 124749.9n 0.8000 124750.0n 0.2000 124999.9n 0.2000 125000.0n 0.8000 125249.9n 0.8000 125250.0n 0.2000 125499.9n 0.2000 125500.0n 0.8000 125749.9n 0.8000 125750.0n 0.2000 125999.9n 0.2000 126000.0n 0.8000 126249.9n 0.8000 126250.0n 0.2000 126499.9n 0.2000 126500.0n 0.8000 126749.9n 0.8000 126750.0n 0.2000 126999.9n 0.2000 127000.0n 0.8000 127249.9n 0.8000 127250.0n 0.2000 127499.9n 0.2000 127500.0n 0.8000 127749.9n 0.8000 127750.0n 0.2000 127999.9n 0.2000 128000.0n 0.8000 128249.9n 0.8000 128250.0n 0.2000 128499.9n 0.2000 128500.0n 0.8000 128749.9n 0.8000 128750.0n 0.2000 128999.9n 0.2000 129000.0n 0.8000 129249.9n 0.8000 129250.0n 0.2000 129499.9n 0.2000 129500.0n 0.8000 129749.9n 0.8000 129750.0n 0.2000 129999.9n 0.2000 130000.0n 0.8000 130249.9n 0.8000 130250.0n 0.2000 130499.9n 0.2000 130500.0n 0.8000 130749.9n 0.8000 130750.0n 0.2000 130999.9n 0.2000 131000.0n 0.8000 131249.9n 0.8000 131250.0n 0.2000 131499.9n 0.2000 131500.0n 0.8000 131749.9n 0.8000 131750.0n 0.2000 131999.9n 0.2000 132000.0n 0.8000 132249.9n 0.8000 132250.0n 0.2000 132499.9n 0.2000 132500.0n 0.8000 132749.9n 0.8000 132750.0n 0.2000 132999.9n 0.2000 133000.0n 0.8000 133249.9n 0.8000 133250.0n 0.2000 133499.9n 0.2000 133500.0n 0.8000 133749.9n 0.8000 133750.0n 0.2000 133999.9n 0.2000 134000.0n 0.8000 134249.9n 0.8000 134250.0n 0.2000 134499.9n 0.2000 134500.0n 0.8000 134749.9n 0.8000 134750.0n 0.2000 134999.9n 0.2000 135000.0n 0.8000 135249.9n 0.8000 135250.0n 0.2000 135499.9n 0.2000 135500.0n 0.8000 135749.9n 0.8000 135750.0n 0.2000 135999.9n 0.2000 136000.0n 0.8000 136249.9n 0.8000 136250.0n 0.2000 136499.9n 0.2000 136500.0n 0.8000 136749.9n 0.8000 136750.0n 0.2000 136999.9n 0.2000 137000.0n 0.8000 137249.9n 0.8000 137250.0n 0.2000 137499.9n 0.2000 137500.0n 0.8000 137749.9n 0.8000 137750.0n 0.2000 137999.9n 0.2000 138000.0n 0.8000 138249.9n 0.8000 138250.0n 0.2000 138499.9n 0.2000 138500.0n 0.8000 138749.9n 0.8000 138750.0n 0.2000 138999.9n 0.2000 139000.0n 0.8000 139249.9n 0.8000 139250.0n 0.2000 139499.9n 0.2000 139500.0n 0.8000 139749.9n 0.8000 139750.0n 0.2000 139999.9n 0.2000 140000.0n 0.8000 140249.9n 0.8000 140250.0n 0.2000 140499.9n 0.2000 140500.0n 0.8000 140749.9n 0.8000 140750.0n 0.2000 140999.9n 0.2000 141000.0n 0.8000 141249.9n 0.8000 141250.0n 0.2000 141499.9n 0.2000 141500.0n 0.8000 141749.9n 0.8000 141750.0n 0.2000 141999.9n 0.2000 142000.0n 0.8000 142249.9n 0.8000 142250.0n 0.2000 142499.9n 0.2000 142500.0n 0.8000 142749.9n 0.8000 142750.0n 0.2000 142999.9n 0.2000 143000.0n 0.8000 143249.9n 0.8000 143250.0n 0.2000 143499.9n 0.2000 143500.0n 0.8000 143749.9n 0.8000 143750.0n 0.2000 143999.9n 0.2000 144000.0n 0.8000 144249.9n 0.8000 144250.0n 0.2000 144499.9n 0.2000 144500.0n 0.8000 144749.9n 0.8000 144750.0n 0.2000 144999.9n 0.2000 145000.0n 0.8000 145249.9n 0.8000 145250.0n 0.2000 145499.9n 0.2000 145500.0n 0.8000 145749.9n 0.8000 145750.0n 0.2000 145999.9n 0.2000 146000.0n 0.8000 146249.9n 0.8000 146250.0n 0.2000 146499.9n 0.2000 146500.0n 0.8000 146749.9n 0.8000 146750.0n 0.2000 146999.9n 0.2000 147000.0n 0.8000 147249.9n 0.8000 147250.0n 0.2000 147499.9n 0.2000 147500.0n 0.8000 147749.9n 0.8000 147750.0n 0.2000 147999.9n 0.2000 148000.0n 0.8000 148249.9n 0.8000 148250.0n 0.2000 148499.9n 0.2000 148500.0n 0.8000 148749.9n 0.8000 148750.0n 0.2000 148999.9n 0.2000 149000.0n 0.8000 149249.9n 0.8000 149250.0n 0.2000 149499.9n 0.2000 149500.0n 0.8000 149749.9n 0.8000 149750.0n 0.2000 149999.9n 0.2000 150000.0n 0.8000 150249.9n 0.8000 150250.0n 0.2000 150499.9n 0.2000 150500.0n 0.8000 150749.9n 0.8000 150750.0n 0.2000 150999.9n 0.2000 151000.0n 0.8000 151249.9n 0.8000 151250.0n 0.2000 151499.9n 0.2000 151500.0n 0.8000 151749.9n 0.8000 151750.0n 0.2000 151999.9n 0.2000 152000.0n 0.8000 152249.9n 0.8000 152250.0n 0.2000 152499.9n 0.2000 152500.0n 0.8000 152749.9n 0.8000 152750.0n 0.2000 152999.9n 0.2000 153000.0n 0.8000 153249.9n 0.8000 153250.0n 0.2000 153499.9n 0.2000 153500.0n 0.8000 153749.9n 0.8000 153750.0n 0.2000 153999.9n 0.2000 154000.0n 0.8000 154249.9n 0.8000 154250.0n 0.2000 154499.9n 0.2000 154500.0n 0.8000 154749.9n 0.8000 154750.0n 0.2000 154999.9n 0.2000 155000.0n 0.8000 155249.9n 0.8000 155250.0n 0.2000 155499.9n 0.2000 155500.0n 0.8000 155749.9n 0.8000 155750.0n 0.2000 155999.9n 0.2000 156000.0n 0.8000 156249.9n 0.8000 156250.0n 0.2000 156499.9n 0.2000 156500.0n 0.8000 156749.9n 0.8000 156750.0n 0.2000 156999.9n 0.2000 157000.0n 0.8000 157249.9n 0.8000 157250.0n 0.2000 157499.9n 0.2000 157500.0n 0.8000 157749.9n 0.8000 157750.0n 0.2000 157999.9n 0.2000 158000.0n 0.8000 158249.9n 0.8000 158250.0n 0.2000 158499.9n 0.2000 158500.0n 0.8000 158749.9n 0.8000 158750.0n 0.2000 158999.9n 0.2000 159000.0n 0.8000 159249.9n 0.8000 159250.0n 0.2000 159499.9n 0.2000 159500.0n 0.8000 159749.9n 0.8000 159750.0n 0.2000)
Vxop xop 0 PWL(0.0n 0.3000 249.9n 0.3000 250.0n 0.7000 499.9n 0.7000 500.0n 0.7000 749.9n 0.7000 750.0n 0.3000 999.9n 0.3000 1000.0n 0.3000 1249.9n 0.3000 1250.0n 0.7000 1499.9n 0.7000 1500.0n 0.7000 1749.9n 0.7000 1750.0n 0.3000 1999.9n 0.3000 2000.0n 0.3000 2249.9n 0.3000 2250.0n 0.7000 2499.9n 0.7000 2500.0n 0.7000 2749.9n 0.7000 2750.0n 0.3000 2999.9n 0.3000 3000.0n 0.3000 3249.9n 0.3000 3250.0n 0.7000 3499.9n 0.7000 3500.0n 0.7000 3749.9n 0.7000 3750.0n 0.3000 3999.9n 0.3000 4000.0n 0.3000 4249.9n 0.3000 4250.0n 0.7000 4499.9n 0.7000 4500.0n 0.7000 4749.9n 0.7000 4750.0n 0.3000 4999.9n 0.3000 5000.0n 0.3000 5249.9n 0.3000 5250.0n 0.7000 5499.9n 0.7000 5500.0n 0.7000 5749.9n 0.7000 5750.0n 0.3000 5999.9n 0.3000 6000.0n 0.3000 6249.9n 0.3000 6250.0n 0.7000 6499.9n 0.7000 6500.0n 0.7000 6749.9n 0.7000 6750.0n 0.3000 6999.9n 0.3000 7000.0n 0.3000 7249.9n 0.3000 7250.0n 0.7000 7499.9n 0.7000 7500.0n 0.7000 7749.9n 0.7000 7750.0n 0.3000 7999.9n 0.3000 8000.0n 0.3000 8249.9n 0.3000 8250.0n 0.7000 8499.9n 0.7000 8500.0n 0.7000 8749.9n 0.7000 8750.0n 0.3000 8999.9n 0.3000 9000.0n 0.3000 9249.9n 0.3000 9250.0n 0.7000 9499.9n 0.7000 9500.0n 0.7000 9749.9n 0.7000 9750.0n 0.3000 9999.9n 0.3000 10000.0n 0.3000 10249.9n 0.3000 10250.0n 0.7000 10499.9n 0.7000 10500.0n 0.7000 10749.9n 0.7000 10750.0n 0.3000 10999.9n 0.3000 11000.0n 0.3000 11249.9n 0.3000 11250.0n 0.7000 11499.9n 0.7000 11500.0n 0.7000 11749.9n 0.7000 11750.0n 0.3000 11999.9n 0.3000 12000.0n 0.3000 12249.9n 0.3000 12250.0n 0.7000 12499.9n 0.7000 12500.0n 0.7000 12749.9n 0.7000 12750.0n 0.3000 12999.9n 0.3000 13000.0n 0.3000 13249.9n 0.3000 13250.0n 0.7000 13499.9n 0.7000 13500.0n 0.7000 13749.9n 0.7000 13750.0n 0.3000 13999.9n 0.3000 14000.0n 0.3000 14249.9n 0.3000 14250.0n 0.7000 14499.9n 0.7000 14500.0n 0.7000 14749.9n 0.7000 14750.0n 0.3000 14999.9n 0.3000 15000.0n 0.3000 15249.9n 0.3000 15250.0n 0.7000 15499.9n 0.7000 15500.0n 0.7000 15749.9n 0.7000 15750.0n 0.3000 15999.9n 0.3000 16000.0n 0.3000 16249.9n 0.3000 16250.0n 0.7000 16499.9n 0.7000 16500.0n 0.7000 16749.9n 0.7000 16750.0n 0.3000 16999.9n 0.3000 17000.0n 0.3000 17249.9n 0.3000 17250.0n 0.7000 17499.9n 0.7000 17500.0n 0.7000 17749.9n 0.7000 17750.0n 0.3000 17999.9n 0.3000 18000.0n 0.3000 18249.9n 0.3000 18250.0n 0.7000 18499.9n 0.7000 18500.0n 0.7000 18749.9n 0.7000 18750.0n 0.3000 18999.9n 0.3000 19000.0n 0.3000 19249.9n 0.3000 19250.0n 0.7000 19499.9n 0.7000 19500.0n 0.7000 19749.9n 0.7000 19750.0n 0.3000 19999.9n 0.3000 20000.0n 0.3000 20249.9n 0.3000 20250.0n 0.7000 20499.9n 0.7000 20500.0n 0.7000 20749.9n 0.7000 20750.0n 0.3000 20999.9n 0.3000 21000.0n 0.3000 21249.9n 0.3000 21250.0n 0.7000 21499.9n 0.7000 21500.0n 0.7000 21749.9n 0.7000 21750.0n 0.3000 21999.9n 0.3000 22000.0n 0.3000 22249.9n 0.3000 22250.0n 0.7000 22499.9n 0.7000 22500.0n 0.7000 22749.9n 0.7000 22750.0n 0.3000 22999.9n 0.3000 23000.0n 0.3000 23249.9n 0.3000 23250.0n 0.7000 23499.9n 0.7000 23500.0n 0.7000 23749.9n 0.7000 23750.0n 0.3000 23999.9n 0.3000 24000.0n 0.3000 24249.9n 0.3000 24250.0n 0.7000 24499.9n 0.7000 24500.0n 0.7000 24749.9n 0.7000 24750.0n 0.3000 24999.9n 0.3000 25000.0n 0.3000 25249.9n 0.3000 25250.0n 0.7000 25499.9n 0.7000 25500.0n 0.7000 25749.9n 0.7000 25750.0n 0.3000 25999.9n 0.3000 26000.0n 0.3000 26249.9n 0.3000 26250.0n 0.7000 26499.9n 0.7000 26500.0n 0.7000 26749.9n 0.7000 26750.0n 0.3000 26999.9n 0.3000 27000.0n 0.3000 27249.9n 0.3000 27250.0n 0.7000 27499.9n 0.7000 27500.0n 0.7000 27749.9n 0.7000 27750.0n 0.3000 27999.9n 0.3000 28000.0n 0.3000 28249.9n 0.3000 28250.0n 0.7000 28499.9n 0.7000 28500.0n 0.7000 28749.9n 0.7000 28750.0n 0.3000 28999.9n 0.3000 29000.0n 0.3000 29249.9n 0.3000 29250.0n 0.7000 29499.9n 0.7000 29500.0n 0.7000 29749.9n 0.7000 29750.0n 0.3000 29999.9n 0.3000 30000.0n 0.3000 30249.9n 0.3000 30250.0n 0.7000 30499.9n 0.7000 30500.0n 0.7000 30749.9n 0.7000 30750.0n 0.3000 30999.9n 0.3000 31000.0n 0.3000 31249.9n 0.3000 31250.0n 0.7000 31499.9n 0.7000 31500.0n 0.7000 31749.9n 0.7000 31750.0n 0.3000 31999.9n 0.3000 32000.0n 0.3000 32249.9n 0.3000 32250.0n 0.7000 32499.9n 0.7000 32500.0n 0.7000 32749.9n 0.7000 32750.0n 0.3000 32999.9n 0.3000 33000.0n 0.3000 33249.9n 0.3000 33250.0n 0.7000 33499.9n 0.7000 33500.0n 0.7000 33749.9n 0.7000 33750.0n 0.3000 33999.9n 0.3000 34000.0n 0.3000 34249.9n 0.3000 34250.0n 0.7000 34499.9n 0.7000 34500.0n 0.7000 34749.9n 0.7000 34750.0n 0.3000 34999.9n 0.3000 35000.0n 0.3000 35249.9n 0.3000 35250.0n 0.7000 35499.9n 0.7000 35500.0n 0.7000 35749.9n 0.7000 35750.0n 0.3000 35999.9n 0.3000 36000.0n 0.3000 36249.9n 0.3000 36250.0n 0.7000 36499.9n 0.7000 36500.0n 0.7000 36749.9n 0.7000 36750.0n 0.3000 36999.9n 0.3000 37000.0n 0.3000 37249.9n 0.3000 37250.0n 0.7000 37499.9n 0.7000 37500.0n 0.7000 37749.9n 0.7000 37750.0n 0.3000 37999.9n 0.3000 38000.0n 0.3000 38249.9n 0.3000 38250.0n 0.7000 38499.9n 0.7000 38500.0n 0.7000 38749.9n 0.7000 38750.0n 0.3000 38999.9n 0.3000 39000.0n 0.3000 39249.9n 0.3000 39250.0n 0.7000 39499.9n 0.7000 39500.0n 0.7000 39749.9n 0.7000 39750.0n 0.3000 39999.9n 0.3000 40000.0n 0.3000 40249.9n 0.3000 40250.0n 0.7000 40499.9n 0.7000 40500.0n 0.7000 40749.9n 0.7000 40750.0n 0.3000 40999.9n 0.3000 41000.0n 0.3000 41249.9n 0.3000 41250.0n 0.7000 41499.9n 0.7000 41500.0n 0.7000 41749.9n 0.7000 41750.0n 0.3000 41999.9n 0.3000 42000.0n 0.3000 42249.9n 0.3000 42250.0n 0.7000 42499.9n 0.7000 42500.0n 0.7000 42749.9n 0.7000 42750.0n 0.3000 42999.9n 0.3000 43000.0n 0.3000 43249.9n 0.3000 43250.0n 0.7000 43499.9n 0.7000 43500.0n 0.7000 43749.9n 0.7000 43750.0n 0.3000 43999.9n 0.3000 44000.0n 0.3000 44249.9n 0.3000 44250.0n 0.7000 44499.9n 0.7000 44500.0n 0.7000 44749.9n 0.7000 44750.0n 0.3000 44999.9n 0.3000 45000.0n 0.3000 45249.9n 0.3000 45250.0n 0.7000 45499.9n 0.7000 45500.0n 0.7000 45749.9n 0.7000 45750.0n 0.3000 45999.9n 0.3000 46000.0n 0.3000 46249.9n 0.3000 46250.0n 0.7000 46499.9n 0.7000 46500.0n 0.7000 46749.9n 0.7000 46750.0n 0.3000 46999.9n 0.3000 47000.0n 0.3000 47249.9n 0.3000 47250.0n 0.7000 47499.9n 0.7000 47500.0n 0.7000 47749.9n 0.7000 47750.0n 0.3000 47999.9n 0.3000 48000.0n 0.3000 48249.9n 0.3000 48250.0n 0.7000 48499.9n 0.7000 48500.0n 0.7000 48749.9n 0.7000 48750.0n 0.3000 48999.9n 0.3000 49000.0n 0.3000 49249.9n 0.3000 49250.0n 0.7000 49499.9n 0.7000 49500.0n 0.7000 49749.9n 0.7000 49750.0n 0.3000 49999.9n 0.3000 50000.0n 0.3000 50249.9n 0.3000 50250.0n 0.7000 50499.9n 0.7000 50500.0n 0.7000 50749.9n 0.7000 50750.0n 0.3000 50999.9n 0.3000 51000.0n 0.3000 51249.9n 0.3000 51250.0n 0.7000 51499.9n 0.7000 51500.0n 0.7000 51749.9n 0.7000 51750.0n 0.3000 51999.9n 0.3000 52000.0n 0.3000 52249.9n 0.3000 52250.0n 0.7000 52499.9n 0.7000 52500.0n 0.7000 52749.9n 0.7000 52750.0n 0.3000 52999.9n 0.3000 53000.0n 0.3000 53249.9n 0.3000 53250.0n 0.7000 53499.9n 0.7000 53500.0n 0.7000 53749.9n 0.7000 53750.0n 0.3000 53999.9n 0.3000 54000.0n 0.3000 54249.9n 0.3000 54250.0n 0.7000 54499.9n 0.7000 54500.0n 0.7000 54749.9n 0.7000 54750.0n 0.3000 54999.9n 0.3000 55000.0n 0.3000 55249.9n 0.3000 55250.0n 0.7000 55499.9n 0.7000 55500.0n 0.7000 55749.9n 0.7000 55750.0n 0.3000 55999.9n 0.3000 56000.0n 0.3000 56249.9n 0.3000 56250.0n 0.7000 56499.9n 0.7000 56500.0n 0.7000 56749.9n 0.7000 56750.0n 0.3000 56999.9n 0.3000 57000.0n 0.3000 57249.9n 0.3000 57250.0n 0.7000 57499.9n 0.7000 57500.0n 0.7000 57749.9n 0.7000 57750.0n 0.3000 57999.9n 0.3000 58000.0n 0.3000 58249.9n 0.3000 58250.0n 0.7000 58499.9n 0.7000 58500.0n 0.7000 58749.9n 0.7000 58750.0n 0.3000 58999.9n 0.3000 59000.0n 0.3000 59249.9n 0.3000 59250.0n 0.7000 59499.9n 0.7000 59500.0n 0.7000 59749.9n 0.7000 59750.0n 0.3000 59999.9n 0.3000 60000.0n 0.3000 60249.9n 0.3000 60250.0n 0.7000 60499.9n 0.7000 60500.0n 0.7000 60749.9n 0.7000 60750.0n 0.3000 60999.9n 0.3000 61000.0n 0.3000 61249.9n 0.3000 61250.0n 0.7000 61499.9n 0.7000 61500.0n 0.7000 61749.9n 0.7000 61750.0n 0.3000 61999.9n 0.3000 62000.0n 0.3000 62249.9n 0.3000 62250.0n 0.7000 62499.9n 0.7000 62500.0n 0.7000 62749.9n 0.7000 62750.0n 0.3000 62999.9n 0.3000 63000.0n 0.3000 63249.9n 0.3000 63250.0n 0.7000 63499.9n 0.7000 63500.0n 0.7000 63749.9n 0.7000 63750.0n 0.3000 63999.9n 0.3000 64000.0n 0.3000 64249.9n 0.3000 64250.0n 0.7000 64499.9n 0.7000 64500.0n 0.7000 64749.9n 0.7000 64750.0n 0.3000 64999.9n 0.3000 65000.0n 0.3000 65249.9n 0.3000 65250.0n 0.7000 65499.9n 0.7000 65500.0n 0.7000 65749.9n 0.7000 65750.0n 0.3000 65999.9n 0.3000 66000.0n 0.3000 66249.9n 0.3000 66250.0n 0.7000 66499.9n 0.7000 66500.0n 0.7000 66749.9n 0.7000 66750.0n 0.3000 66999.9n 0.3000 67000.0n 0.3000 67249.9n 0.3000 67250.0n 0.7000 67499.9n 0.7000 67500.0n 0.7000 67749.9n 0.7000 67750.0n 0.3000 67999.9n 0.3000 68000.0n 0.3000 68249.9n 0.3000 68250.0n 0.7000 68499.9n 0.7000 68500.0n 0.7000 68749.9n 0.7000 68750.0n 0.3000 68999.9n 0.3000 69000.0n 0.3000 69249.9n 0.3000 69250.0n 0.7000 69499.9n 0.7000 69500.0n 0.7000 69749.9n 0.7000 69750.0n 0.3000 69999.9n 0.3000 70000.0n 0.3000 70249.9n 0.3000 70250.0n 0.7000 70499.9n 0.7000 70500.0n 0.7000 70749.9n 0.7000 70750.0n 0.3000 70999.9n 0.3000 71000.0n 0.3000 71249.9n 0.3000 71250.0n 0.7000 71499.9n 0.7000 71500.0n 0.7000 71749.9n 0.7000 71750.0n 0.3000 71999.9n 0.3000 72000.0n 0.3000 72249.9n 0.3000 72250.0n 0.7000 72499.9n 0.7000 72500.0n 0.7000 72749.9n 0.7000 72750.0n 0.3000 72999.9n 0.3000 73000.0n 0.3000 73249.9n 0.3000 73250.0n 0.7000 73499.9n 0.7000 73500.0n 0.7000 73749.9n 0.7000 73750.0n 0.3000 73999.9n 0.3000 74000.0n 0.3000 74249.9n 0.3000 74250.0n 0.7000 74499.9n 0.7000 74500.0n 0.7000 74749.9n 0.7000 74750.0n 0.3000 74999.9n 0.3000 75000.0n 0.3000 75249.9n 0.3000 75250.0n 0.7000 75499.9n 0.7000 75500.0n 0.7000 75749.9n 0.7000 75750.0n 0.3000 75999.9n 0.3000 76000.0n 0.3000 76249.9n 0.3000 76250.0n 0.7000 76499.9n 0.7000 76500.0n 0.7000 76749.9n 0.7000 76750.0n 0.3000 76999.9n 0.3000 77000.0n 0.3000 77249.9n 0.3000 77250.0n 0.7000 77499.9n 0.7000 77500.0n 0.7000 77749.9n 0.7000 77750.0n 0.3000 77999.9n 0.3000 78000.0n 0.3000 78249.9n 0.3000 78250.0n 0.7000 78499.9n 0.7000 78500.0n 0.7000 78749.9n 0.7000 78750.0n 0.3000 78999.9n 0.3000 79000.0n 0.3000 79249.9n 0.3000 79250.0n 0.7000 79499.9n 0.7000 79500.0n 0.7000 79749.9n 0.7000 79750.0n 0.3000 79999.9n 0.3000 80000.0n 0.3000 80249.9n 0.3000 80250.0n 0.7000 80499.9n 0.7000 80500.0n 0.7000 80749.9n 0.7000 80750.0n 0.3000 80999.9n 0.3000 81000.0n 0.3000 81249.9n 0.3000 81250.0n 0.7000 81499.9n 0.7000 81500.0n 0.7000 81749.9n 0.7000 81750.0n 0.3000 81999.9n 0.3000 82000.0n 0.3000 82249.9n 0.3000 82250.0n 0.7000 82499.9n 0.7000 82500.0n 0.7000 82749.9n 0.7000 82750.0n 0.3000 82999.9n 0.3000 83000.0n 0.3000 83249.9n 0.3000 83250.0n 0.7000 83499.9n 0.7000 83500.0n 0.7000 83749.9n 0.7000 83750.0n 0.3000 83999.9n 0.3000 84000.0n 0.3000 84249.9n 0.3000 84250.0n 0.7000 84499.9n 0.7000 84500.0n 0.7000 84749.9n 0.7000 84750.0n 0.3000 84999.9n 0.3000 85000.0n 0.3000 85249.9n 0.3000 85250.0n 0.7000 85499.9n 0.7000 85500.0n 0.7000 85749.9n 0.7000 85750.0n 0.3000 85999.9n 0.3000 86000.0n 0.3000 86249.9n 0.3000 86250.0n 0.7000 86499.9n 0.7000 86500.0n 0.7000 86749.9n 0.7000 86750.0n 0.3000 86999.9n 0.3000 87000.0n 0.3000 87249.9n 0.3000 87250.0n 0.7000 87499.9n 0.7000 87500.0n 0.7000 87749.9n 0.7000 87750.0n 0.3000 87999.9n 0.3000 88000.0n 0.3000 88249.9n 0.3000 88250.0n 0.7000 88499.9n 0.7000 88500.0n 0.7000 88749.9n 0.7000 88750.0n 0.3000 88999.9n 0.3000 89000.0n 0.3000 89249.9n 0.3000 89250.0n 0.7000 89499.9n 0.7000 89500.0n 0.7000 89749.9n 0.7000 89750.0n 0.3000 89999.9n 0.3000 90000.0n 0.3000 90249.9n 0.3000 90250.0n 0.7000 90499.9n 0.7000 90500.0n 0.7000 90749.9n 0.7000 90750.0n 0.3000 90999.9n 0.3000 91000.0n 0.3000 91249.9n 0.3000 91250.0n 0.7000 91499.9n 0.7000 91500.0n 0.7000 91749.9n 0.7000 91750.0n 0.3000 91999.9n 0.3000 92000.0n 0.3000 92249.9n 0.3000 92250.0n 0.7000 92499.9n 0.7000 92500.0n 0.7000 92749.9n 0.7000 92750.0n 0.3000 92999.9n 0.3000 93000.0n 0.3000 93249.9n 0.3000 93250.0n 0.7000 93499.9n 0.7000 93500.0n 0.7000 93749.9n 0.7000 93750.0n 0.3000 93999.9n 0.3000 94000.0n 0.3000 94249.9n 0.3000 94250.0n 0.7000 94499.9n 0.7000 94500.0n 0.7000 94749.9n 0.7000 94750.0n 0.3000 94999.9n 0.3000 95000.0n 0.3000 95249.9n 0.3000 95250.0n 0.7000 95499.9n 0.7000 95500.0n 0.7000 95749.9n 0.7000 95750.0n 0.3000 95999.9n 0.3000 96000.0n 0.3000 96249.9n 0.3000 96250.0n 0.7000 96499.9n 0.7000 96500.0n 0.7000 96749.9n 0.7000 96750.0n 0.3000 96999.9n 0.3000 97000.0n 0.3000 97249.9n 0.3000 97250.0n 0.7000 97499.9n 0.7000 97500.0n 0.7000 97749.9n 0.7000 97750.0n 0.3000 97999.9n 0.3000 98000.0n 0.3000 98249.9n 0.3000 98250.0n 0.7000 98499.9n 0.7000 98500.0n 0.7000 98749.9n 0.7000 98750.0n 0.3000 98999.9n 0.3000 99000.0n 0.3000 99249.9n 0.3000 99250.0n 0.7000 99499.9n 0.7000 99500.0n 0.7000 99749.9n 0.7000 99750.0n 0.3000 99999.9n 0.3000 100000.0n 0.3000 100249.9n 0.3000 100250.0n 0.7000 100499.9n 0.7000 100500.0n 0.7000 100749.9n 0.7000 100750.0n 0.3000 100999.9n 0.3000 101000.0n 0.3000 101249.9n 0.3000 101250.0n 0.7000 101499.9n 0.7000 101500.0n 0.7000 101749.9n 0.7000 101750.0n 0.3000 101999.9n 0.3000 102000.0n 0.3000 102249.9n 0.3000 102250.0n 0.7000 102499.9n 0.7000 102500.0n 0.7000 102749.9n 0.7000 102750.0n 0.3000 102999.9n 0.3000 103000.0n 0.3000 103249.9n 0.3000 103250.0n 0.7000 103499.9n 0.7000 103500.0n 0.7000 103749.9n 0.7000 103750.0n 0.3000 103999.9n 0.3000 104000.0n 0.3000 104249.9n 0.3000 104250.0n 0.7000 104499.9n 0.7000 104500.0n 0.7000 104749.9n 0.7000 104750.0n 0.3000 104999.9n 0.3000 105000.0n 0.3000 105249.9n 0.3000 105250.0n 0.7000 105499.9n 0.7000 105500.0n 0.7000 105749.9n 0.7000 105750.0n 0.3000 105999.9n 0.3000 106000.0n 0.3000 106249.9n 0.3000 106250.0n 0.7000 106499.9n 0.7000 106500.0n 0.7000 106749.9n 0.7000 106750.0n 0.3000 106999.9n 0.3000 107000.0n 0.3000 107249.9n 0.3000 107250.0n 0.7000 107499.9n 0.7000 107500.0n 0.7000 107749.9n 0.7000 107750.0n 0.3000 107999.9n 0.3000 108000.0n 0.3000 108249.9n 0.3000 108250.0n 0.7000 108499.9n 0.7000 108500.0n 0.7000 108749.9n 0.7000 108750.0n 0.3000 108999.9n 0.3000 109000.0n 0.3000 109249.9n 0.3000 109250.0n 0.7000 109499.9n 0.7000 109500.0n 0.7000 109749.9n 0.7000 109750.0n 0.3000 109999.9n 0.3000 110000.0n 0.3000 110249.9n 0.3000 110250.0n 0.7000 110499.9n 0.7000 110500.0n 0.7000 110749.9n 0.7000 110750.0n 0.3000 110999.9n 0.3000 111000.0n 0.3000 111249.9n 0.3000 111250.0n 0.7000 111499.9n 0.7000 111500.0n 0.7000 111749.9n 0.7000 111750.0n 0.3000 111999.9n 0.3000 112000.0n 0.3000 112249.9n 0.3000 112250.0n 0.7000 112499.9n 0.7000 112500.0n 0.7000 112749.9n 0.7000 112750.0n 0.3000 112999.9n 0.3000 113000.0n 0.3000 113249.9n 0.3000 113250.0n 0.7000 113499.9n 0.7000 113500.0n 0.7000 113749.9n 0.7000 113750.0n 0.3000 113999.9n 0.3000 114000.0n 0.3000 114249.9n 0.3000 114250.0n 0.7000 114499.9n 0.7000 114500.0n 0.7000 114749.9n 0.7000 114750.0n 0.3000 114999.9n 0.3000 115000.0n 0.3000 115249.9n 0.3000 115250.0n 0.7000 115499.9n 0.7000 115500.0n 0.7000 115749.9n 0.7000 115750.0n 0.3000 115999.9n 0.3000 116000.0n 0.3000 116249.9n 0.3000 116250.0n 0.7000 116499.9n 0.7000 116500.0n 0.7000 116749.9n 0.7000 116750.0n 0.3000 116999.9n 0.3000 117000.0n 0.3000 117249.9n 0.3000 117250.0n 0.7000 117499.9n 0.7000 117500.0n 0.7000 117749.9n 0.7000 117750.0n 0.3000 117999.9n 0.3000 118000.0n 0.3000 118249.9n 0.3000 118250.0n 0.7000 118499.9n 0.7000 118500.0n 0.7000 118749.9n 0.7000 118750.0n 0.3000 118999.9n 0.3000 119000.0n 0.3000 119249.9n 0.3000 119250.0n 0.7000 119499.9n 0.7000 119500.0n 0.7000 119749.9n 0.7000 119750.0n 0.3000 119999.9n 0.3000 120000.0n 0.3000 120249.9n 0.3000 120250.0n 0.7000 120499.9n 0.7000 120500.0n 0.7000 120749.9n 0.7000 120750.0n 0.3000 120999.9n 0.3000 121000.0n 0.3000 121249.9n 0.3000 121250.0n 0.7000 121499.9n 0.7000 121500.0n 0.7000 121749.9n 0.7000 121750.0n 0.3000 121999.9n 0.3000 122000.0n 0.3000 122249.9n 0.3000 122250.0n 0.7000 122499.9n 0.7000 122500.0n 0.7000 122749.9n 0.7000 122750.0n 0.3000 122999.9n 0.3000 123000.0n 0.3000 123249.9n 0.3000 123250.0n 0.7000 123499.9n 0.7000 123500.0n 0.7000 123749.9n 0.7000 123750.0n 0.3000 123999.9n 0.3000 124000.0n 0.3000 124249.9n 0.3000 124250.0n 0.7000 124499.9n 0.7000 124500.0n 0.7000 124749.9n 0.7000 124750.0n 0.3000 124999.9n 0.3000 125000.0n 0.3000 125249.9n 0.3000 125250.0n 0.7000 125499.9n 0.7000 125500.0n 0.7000 125749.9n 0.7000 125750.0n 0.3000 125999.9n 0.3000 126000.0n 0.3000 126249.9n 0.3000 126250.0n 0.7000 126499.9n 0.7000 126500.0n 0.7000 126749.9n 0.7000 126750.0n 0.3000 126999.9n 0.3000 127000.0n 0.3000 127249.9n 0.3000 127250.0n 0.7000 127499.9n 0.7000 127500.0n 0.7000 127749.9n 0.7000 127750.0n 0.3000 127999.9n 0.3000 128000.0n 0.3000 128249.9n 0.3000 128250.0n 0.7000 128499.9n 0.7000 128500.0n 0.7000 128749.9n 0.7000 128750.0n 0.3000 128999.9n 0.3000 129000.0n 0.3000 129249.9n 0.3000 129250.0n 0.7000 129499.9n 0.7000 129500.0n 0.7000 129749.9n 0.7000 129750.0n 0.3000 129999.9n 0.3000 130000.0n 0.3000 130249.9n 0.3000 130250.0n 0.7000 130499.9n 0.7000 130500.0n 0.7000 130749.9n 0.7000 130750.0n 0.3000 130999.9n 0.3000 131000.0n 0.3000 131249.9n 0.3000 131250.0n 0.7000 131499.9n 0.7000 131500.0n 0.7000 131749.9n 0.7000 131750.0n 0.3000 131999.9n 0.3000 132000.0n 0.3000 132249.9n 0.3000 132250.0n 0.7000 132499.9n 0.7000 132500.0n 0.7000 132749.9n 0.7000 132750.0n 0.3000 132999.9n 0.3000 133000.0n 0.3000 133249.9n 0.3000 133250.0n 0.7000 133499.9n 0.7000 133500.0n 0.7000 133749.9n 0.7000 133750.0n 0.3000 133999.9n 0.3000 134000.0n 0.3000 134249.9n 0.3000 134250.0n 0.7000 134499.9n 0.7000 134500.0n 0.7000 134749.9n 0.7000 134750.0n 0.3000 134999.9n 0.3000 135000.0n 0.3000 135249.9n 0.3000 135250.0n 0.7000 135499.9n 0.7000 135500.0n 0.7000 135749.9n 0.7000 135750.0n 0.3000 135999.9n 0.3000 136000.0n 0.3000 136249.9n 0.3000 136250.0n 0.7000 136499.9n 0.7000 136500.0n 0.7000 136749.9n 0.7000 136750.0n 0.3000 136999.9n 0.3000 137000.0n 0.3000 137249.9n 0.3000 137250.0n 0.7000 137499.9n 0.7000 137500.0n 0.7000 137749.9n 0.7000 137750.0n 0.3000 137999.9n 0.3000 138000.0n 0.3000 138249.9n 0.3000 138250.0n 0.7000 138499.9n 0.7000 138500.0n 0.7000 138749.9n 0.7000 138750.0n 0.3000 138999.9n 0.3000 139000.0n 0.3000 139249.9n 0.3000 139250.0n 0.7000 139499.9n 0.7000 139500.0n 0.7000 139749.9n 0.7000 139750.0n 0.3000 139999.9n 0.3000 140000.0n 0.3000 140249.9n 0.3000 140250.0n 0.7000 140499.9n 0.7000 140500.0n 0.7000 140749.9n 0.7000 140750.0n 0.3000 140999.9n 0.3000 141000.0n 0.3000 141249.9n 0.3000 141250.0n 0.7000 141499.9n 0.7000 141500.0n 0.7000 141749.9n 0.7000 141750.0n 0.3000 141999.9n 0.3000 142000.0n 0.3000 142249.9n 0.3000 142250.0n 0.7000 142499.9n 0.7000 142500.0n 0.7000 142749.9n 0.7000 142750.0n 0.3000 142999.9n 0.3000 143000.0n 0.3000 143249.9n 0.3000 143250.0n 0.7000 143499.9n 0.7000 143500.0n 0.7000 143749.9n 0.7000 143750.0n 0.3000 143999.9n 0.3000 144000.0n 0.3000 144249.9n 0.3000 144250.0n 0.7000 144499.9n 0.7000 144500.0n 0.7000 144749.9n 0.7000 144750.0n 0.3000 144999.9n 0.3000 145000.0n 0.3000 145249.9n 0.3000 145250.0n 0.7000 145499.9n 0.7000 145500.0n 0.7000 145749.9n 0.7000 145750.0n 0.3000 145999.9n 0.3000 146000.0n 0.3000 146249.9n 0.3000 146250.0n 0.7000 146499.9n 0.7000 146500.0n 0.7000 146749.9n 0.7000 146750.0n 0.3000 146999.9n 0.3000 147000.0n 0.3000 147249.9n 0.3000 147250.0n 0.7000 147499.9n 0.7000 147500.0n 0.7000 147749.9n 0.7000 147750.0n 0.3000 147999.9n 0.3000 148000.0n 0.3000 148249.9n 0.3000 148250.0n 0.7000 148499.9n 0.7000 148500.0n 0.7000 148749.9n 0.7000 148750.0n 0.3000 148999.9n 0.3000 149000.0n 0.3000 149249.9n 0.3000 149250.0n 0.7000 149499.9n 0.7000 149500.0n 0.7000 149749.9n 0.7000 149750.0n 0.3000 149999.9n 0.3000 150000.0n 0.3000 150249.9n 0.3000 150250.0n 0.7000 150499.9n 0.7000 150500.0n 0.7000 150749.9n 0.7000 150750.0n 0.3000 150999.9n 0.3000 151000.0n 0.3000 151249.9n 0.3000 151250.0n 0.7000 151499.9n 0.7000 151500.0n 0.7000 151749.9n 0.7000 151750.0n 0.3000 151999.9n 0.3000 152000.0n 0.3000 152249.9n 0.3000 152250.0n 0.7000 152499.9n 0.7000 152500.0n 0.7000 152749.9n 0.7000 152750.0n 0.3000 152999.9n 0.3000 153000.0n 0.3000 153249.9n 0.3000 153250.0n 0.7000 153499.9n 0.7000 153500.0n 0.7000 153749.9n 0.7000 153750.0n 0.3000 153999.9n 0.3000 154000.0n 0.3000 154249.9n 0.3000 154250.0n 0.7000 154499.9n 0.7000 154500.0n 0.7000 154749.9n 0.7000 154750.0n 0.3000 154999.9n 0.3000 155000.0n 0.3000 155249.9n 0.3000 155250.0n 0.7000 155499.9n 0.7000 155500.0n 0.7000 155749.9n 0.7000 155750.0n 0.3000 155999.9n 0.3000 156000.0n 0.3000 156249.9n 0.3000 156250.0n 0.7000 156499.9n 0.7000 156500.0n 0.7000 156749.9n 0.7000 156750.0n 0.3000 156999.9n 0.3000 157000.0n 0.3000 157249.9n 0.3000 157250.0n 0.7000 157499.9n 0.7000 157500.0n 0.7000 157749.9n 0.7000 157750.0n 0.3000 157999.9n 0.3000 158000.0n 0.3000 158249.9n 0.3000 158250.0n 0.7000 158499.9n 0.7000 158500.0n 0.7000 158749.9n 0.7000 158750.0n 0.3000 158999.9n 0.3000 159000.0n 0.3000 159249.9n 0.3000 159250.0n 0.7000 159499.9n 0.7000 159500.0n 0.7000 159749.9n 0.7000 159750.0n 0.3000)
Vxon xon 0 PWL(0.0n 0.7000 249.9n 0.7000 250.0n 0.3000 499.9n 0.3000 500.0n 0.3000 749.9n 0.3000 750.0n 0.7000 999.9n 0.7000 1000.0n 0.7000 1249.9n 0.7000 1250.0n 0.3000 1499.9n 0.3000 1500.0n 0.3000 1749.9n 0.3000 1750.0n 0.7000 1999.9n 0.7000 2000.0n 0.7000 2249.9n 0.7000 2250.0n 0.3000 2499.9n 0.3000 2500.0n 0.3000 2749.9n 0.3000 2750.0n 0.7000 2999.9n 0.7000 3000.0n 0.7000 3249.9n 0.7000 3250.0n 0.3000 3499.9n 0.3000 3500.0n 0.3000 3749.9n 0.3000 3750.0n 0.7000 3999.9n 0.7000 4000.0n 0.7000 4249.9n 0.7000 4250.0n 0.3000 4499.9n 0.3000 4500.0n 0.3000 4749.9n 0.3000 4750.0n 0.7000 4999.9n 0.7000 5000.0n 0.7000 5249.9n 0.7000 5250.0n 0.3000 5499.9n 0.3000 5500.0n 0.3000 5749.9n 0.3000 5750.0n 0.7000 5999.9n 0.7000 6000.0n 0.7000 6249.9n 0.7000 6250.0n 0.3000 6499.9n 0.3000 6500.0n 0.3000 6749.9n 0.3000 6750.0n 0.7000 6999.9n 0.7000 7000.0n 0.7000 7249.9n 0.7000 7250.0n 0.3000 7499.9n 0.3000 7500.0n 0.3000 7749.9n 0.3000 7750.0n 0.7000 7999.9n 0.7000 8000.0n 0.7000 8249.9n 0.7000 8250.0n 0.3000 8499.9n 0.3000 8500.0n 0.3000 8749.9n 0.3000 8750.0n 0.7000 8999.9n 0.7000 9000.0n 0.7000 9249.9n 0.7000 9250.0n 0.3000 9499.9n 0.3000 9500.0n 0.3000 9749.9n 0.3000 9750.0n 0.7000 9999.9n 0.7000 10000.0n 0.7000 10249.9n 0.7000 10250.0n 0.3000 10499.9n 0.3000 10500.0n 0.3000 10749.9n 0.3000 10750.0n 0.7000 10999.9n 0.7000 11000.0n 0.7000 11249.9n 0.7000 11250.0n 0.3000 11499.9n 0.3000 11500.0n 0.3000 11749.9n 0.3000 11750.0n 0.7000 11999.9n 0.7000 12000.0n 0.7000 12249.9n 0.7000 12250.0n 0.3000 12499.9n 0.3000 12500.0n 0.3000 12749.9n 0.3000 12750.0n 0.7000 12999.9n 0.7000 13000.0n 0.7000 13249.9n 0.7000 13250.0n 0.3000 13499.9n 0.3000 13500.0n 0.3000 13749.9n 0.3000 13750.0n 0.7000 13999.9n 0.7000 14000.0n 0.7000 14249.9n 0.7000 14250.0n 0.3000 14499.9n 0.3000 14500.0n 0.3000 14749.9n 0.3000 14750.0n 0.7000 14999.9n 0.7000 15000.0n 0.7000 15249.9n 0.7000 15250.0n 0.3000 15499.9n 0.3000 15500.0n 0.3000 15749.9n 0.3000 15750.0n 0.7000 15999.9n 0.7000 16000.0n 0.7000 16249.9n 0.7000 16250.0n 0.3000 16499.9n 0.3000 16500.0n 0.3000 16749.9n 0.3000 16750.0n 0.7000 16999.9n 0.7000 17000.0n 0.7000 17249.9n 0.7000 17250.0n 0.3000 17499.9n 0.3000 17500.0n 0.3000 17749.9n 0.3000 17750.0n 0.7000 17999.9n 0.7000 18000.0n 0.7000 18249.9n 0.7000 18250.0n 0.3000 18499.9n 0.3000 18500.0n 0.3000 18749.9n 0.3000 18750.0n 0.7000 18999.9n 0.7000 19000.0n 0.7000 19249.9n 0.7000 19250.0n 0.3000 19499.9n 0.3000 19500.0n 0.3000 19749.9n 0.3000 19750.0n 0.7000 19999.9n 0.7000 20000.0n 0.7000 20249.9n 0.7000 20250.0n 0.3000 20499.9n 0.3000 20500.0n 0.3000 20749.9n 0.3000 20750.0n 0.7000 20999.9n 0.7000 21000.0n 0.7000 21249.9n 0.7000 21250.0n 0.3000 21499.9n 0.3000 21500.0n 0.3000 21749.9n 0.3000 21750.0n 0.7000 21999.9n 0.7000 22000.0n 0.7000 22249.9n 0.7000 22250.0n 0.3000 22499.9n 0.3000 22500.0n 0.3000 22749.9n 0.3000 22750.0n 0.7000 22999.9n 0.7000 23000.0n 0.7000 23249.9n 0.7000 23250.0n 0.3000 23499.9n 0.3000 23500.0n 0.3000 23749.9n 0.3000 23750.0n 0.7000 23999.9n 0.7000 24000.0n 0.7000 24249.9n 0.7000 24250.0n 0.3000 24499.9n 0.3000 24500.0n 0.3000 24749.9n 0.3000 24750.0n 0.7000 24999.9n 0.7000 25000.0n 0.7000 25249.9n 0.7000 25250.0n 0.3000 25499.9n 0.3000 25500.0n 0.3000 25749.9n 0.3000 25750.0n 0.7000 25999.9n 0.7000 26000.0n 0.7000 26249.9n 0.7000 26250.0n 0.3000 26499.9n 0.3000 26500.0n 0.3000 26749.9n 0.3000 26750.0n 0.7000 26999.9n 0.7000 27000.0n 0.7000 27249.9n 0.7000 27250.0n 0.3000 27499.9n 0.3000 27500.0n 0.3000 27749.9n 0.3000 27750.0n 0.7000 27999.9n 0.7000 28000.0n 0.7000 28249.9n 0.7000 28250.0n 0.3000 28499.9n 0.3000 28500.0n 0.3000 28749.9n 0.3000 28750.0n 0.7000 28999.9n 0.7000 29000.0n 0.7000 29249.9n 0.7000 29250.0n 0.3000 29499.9n 0.3000 29500.0n 0.3000 29749.9n 0.3000 29750.0n 0.7000 29999.9n 0.7000 30000.0n 0.7000 30249.9n 0.7000 30250.0n 0.3000 30499.9n 0.3000 30500.0n 0.3000 30749.9n 0.3000 30750.0n 0.7000 30999.9n 0.7000 31000.0n 0.7000 31249.9n 0.7000 31250.0n 0.3000 31499.9n 0.3000 31500.0n 0.3000 31749.9n 0.3000 31750.0n 0.7000 31999.9n 0.7000 32000.0n 0.7000 32249.9n 0.7000 32250.0n 0.3000 32499.9n 0.3000 32500.0n 0.3000 32749.9n 0.3000 32750.0n 0.7000 32999.9n 0.7000 33000.0n 0.7000 33249.9n 0.7000 33250.0n 0.3000 33499.9n 0.3000 33500.0n 0.3000 33749.9n 0.3000 33750.0n 0.7000 33999.9n 0.7000 34000.0n 0.7000 34249.9n 0.7000 34250.0n 0.3000 34499.9n 0.3000 34500.0n 0.3000 34749.9n 0.3000 34750.0n 0.7000 34999.9n 0.7000 35000.0n 0.7000 35249.9n 0.7000 35250.0n 0.3000 35499.9n 0.3000 35500.0n 0.3000 35749.9n 0.3000 35750.0n 0.7000 35999.9n 0.7000 36000.0n 0.7000 36249.9n 0.7000 36250.0n 0.3000 36499.9n 0.3000 36500.0n 0.3000 36749.9n 0.3000 36750.0n 0.7000 36999.9n 0.7000 37000.0n 0.7000 37249.9n 0.7000 37250.0n 0.3000 37499.9n 0.3000 37500.0n 0.3000 37749.9n 0.3000 37750.0n 0.7000 37999.9n 0.7000 38000.0n 0.7000 38249.9n 0.7000 38250.0n 0.3000 38499.9n 0.3000 38500.0n 0.3000 38749.9n 0.3000 38750.0n 0.7000 38999.9n 0.7000 39000.0n 0.7000 39249.9n 0.7000 39250.0n 0.3000 39499.9n 0.3000 39500.0n 0.3000 39749.9n 0.3000 39750.0n 0.7000 39999.9n 0.7000 40000.0n 0.7000 40249.9n 0.7000 40250.0n 0.3000 40499.9n 0.3000 40500.0n 0.3000 40749.9n 0.3000 40750.0n 0.7000 40999.9n 0.7000 41000.0n 0.7000 41249.9n 0.7000 41250.0n 0.3000 41499.9n 0.3000 41500.0n 0.3000 41749.9n 0.3000 41750.0n 0.7000 41999.9n 0.7000 42000.0n 0.7000 42249.9n 0.7000 42250.0n 0.3000 42499.9n 0.3000 42500.0n 0.3000 42749.9n 0.3000 42750.0n 0.7000 42999.9n 0.7000 43000.0n 0.7000 43249.9n 0.7000 43250.0n 0.3000 43499.9n 0.3000 43500.0n 0.3000 43749.9n 0.3000 43750.0n 0.7000 43999.9n 0.7000 44000.0n 0.7000 44249.9n 0.7000 44250.0n 0.3000 44499.9n 0.3000 44500.0n 0.3000 44749.9n 0.3000 44750.0n 0.7000 44999.9n 0.7000 45000.0n 0.7000 45249.9n 0.7000 45250.0n 0.3000 45499.9n 0.3000 45500.0n 0.3000 45749.9n 0.3000 45750.0n 0.7000 45999.9n 0.7000 46000.0n 0.7000 46249.9n 0.7000 46250.0n 0.3000 46499.9n 0.3000 46500.0n 0.3000 46749.9n 0.3000 46750.0n 0.7000 46999.9n 0.7000 47000.0n 0.7000 47249.9n 0.7000 47250.0n 0.3000 47499.9n 0.3000 47500.0n 0.3000 47749.9n 0.3000 47750.0n 0.7000 47999.9n 0.7000 48000.0n 0.7000 48249.9n 0.7000 48250.0n 0.3000 48499.9n 0.3000 48500.0n 0.3000 48749.9n 0.3000 48750.0n 0.7000 48999.9n 0.7000 49000.0n 0.7000 49249.9n 0.7000 49250.0n 0.3000 49499.9n 0.3000 49500.0n 0.3000 49749.9n 0.3000 49750.0n 0.7000 49999.9n 0.7000 50000.0n 0.7000 50249.9n 0.7000 50250.0n 0.3000 50499.9n 0.3000 50500.0n 0.3000 50749.9n 0.3000 50750.0n 0.7000 50999.9n 0.7000 51000.0n 0.7000 51249.9n 0.7000 51250.0n 0.3000 51499.9n 0.3000 51500.0n 0.3000 51749.9n 0.3000 51750.0n 0.7000 51999.9n 0.7000 52000.0n 0.7000 52249.9n 0.7000 52250.0n 0.3000 52499.9n 0.3000 52500.0n 0.3000 52749.9n 0.3000 52750.0n 0.7000 52999.9n 0.7000 53000.0n 0.7000 53249.9n 0.7000 53250.0n 0.3000 53499.9n 0.3000 53500.0n 0.3000 53749.9n 0.3000 53750.0n 0.7000 53999.9n 0.7000 54000.0n 0.7000 54249.9n 0.7000 54250.0n 0.3000 54499.9n 0.3000 54500.0n 0.3000 54749.9n 0.3000 54750.0n 0.7000 54999.9n 0.7000 55000.0n 0.7000 55249.9n 0.7000 55250.0n 0.3000 55499.9n 0.3000 55500.0n 0.3000 55749.9n 0.3000 55750.0n 0.7000 55999.9n 0.7000 56000.0n 0.7000 56249.9n 0.7000 56250.0n 0.3000 56499.9n 0.3000 56500.0n 0.3000 56749.9n 0.3000 56750.0n 0.7000 56999.9n 0.7000 57000.0n 0.7000 57249.9n 0.7000 57250.0n 0.3000 57499.9n 0.3000 57500.0n 0.3000 57749.9n 0.3000 57750.0n 0.7000 57999.9n 0.7000 58000.0n 0.7000 58249.9n 0.7000 58250.0n 0.3000 58499.9n 0.3000 58500.0n 0.3000 58749.9n 0.3000 58750.0n 0.7000 58999.9n 0.7000 59000.0n 0.7000 59249.9n 0.7000 59250.0n 0.3000 59499.9n 0.3000 59500.0n 0.3000 59749.9n 0.3000 59750.0n 0.7000 59999.9n 0.7000 60000.0n 0.7000 60249.9n 0.7000 60250.0n 0.3000 60499.9n 0.3000 60500.0n 0.3000 60749.9n 0.3000 60750.0n 0.7000 60999.9n 0.7000 61000.0n 0.7000 61249.9n 0.7000 61250.0n 0.3000 61499.9n 0.3000 61500.0n 0.3000 61749.9n 0.3000 61750.0n 0.7000 61999.9n 0.7000 62000.0n 0.7000 62249.9n 0.7000 62250.0n 0.3000 62499.9n 0.3000 62500.0n 0.3000 62749.9n 0.3000 62750.0n 0.7000 62999.9n 0.7000 63000.0n 0.7000 63249.9n 0.7000 63250.0n 0.3000 63499.9n 0.3000 63500.0n 0.3000 63749.9n 0.3000 63750.0n 0.7000 63999.9n 0.7000 64000.0n 0.7000 64249.9n 0.7000 64250.0n 0.3000 64499.9n 0.3000 64500.0n 0.3000 64749.9n 0.3000 64750.0n 0.7000 64999.9n 0.7000 65000.0n 0.7000 65249.9n 0.7000 65250.0n 0.3000 65499.9n 0.3000 65500.0n 0.3000 65749.9n 0.3000 65750.0n 0.7000 65999.9n 0.7000 66000.0n 0.7000 66249.9n 0.7000 66250.0n 0.3000 66499.9n 0.3000 66500.0n 0.3000 66749.9n 0.3000 66750.0n 0.7000 66999.9n 0.7000 67000.0n 0.7000 67249.9n 0.7000 67250.0n 0.3000 67499.9n 0.3000 67500.0n 0.3000 67749.9n 0.3000 67750.0n 0.7000 67999.9n 0.7000 68000.0n 0.7000 68249.9n 0.7000 68250.0n 0.3000 68499.9n 0.3000 68500.0n 0.3000 68749.9n 0.3000 68750.0n 0.7000 68999.9n 0.7000 69000.0n 0.7000 69249.9n 0.7000 69250.0n 0.3000 69499.9n 0.3000 69500.0n 0.3000 69749.9n 0.3000 69750.0n 0.7000 69999.9n 0.7000 70000.0n 0.7000 70249.9n 0.7000 70250.0n 0.3000 70499.9n 0.3000 70500.0n 0.3000 70749.9n 0.3000 70750.0n 0.7000 70999.9n 0.7000 71000.0n 0.7000 71249.9n 0.7000 71250.0n 0.3000 71499.9n 0.3000 71500.0n 0.3000 71749.9n 0.3000 71750.0n 0.7000 71999.9n 0.7000 72000.0n 0.7000 72249.9n 0.7000 72250.0n 0.3000 72499.9n 0.3000 72500.0n 0.3000 72749.9n 0.3000 72750.0n 0.7000 72999.9n 0.7000 73000.0n 0.7000 73249.9n 0.7000 73250.0n 0.3000 73499.9n 0.3000 73500.0n 0.3000 73749.9n 0.3000 73750.0n 0.7000 73999.9n 0.7000 74000.0n 0.7000 74249.9n 0.7000 74250.0n 0.3000 74499.9n 0.3000 74500.0n 0.3000 74749.9n 0.3000 74750.0n 0.7000 74999.9n 0.7000 75000.0n 0.7000 75249.9n 0.7000 75250.0n 0.3000 75499.9n 0.3000 75500.0n 0.3000 75749.9n 0.3000 75750.0n 0.7000 75999.9n 0.7000 76000.0n 0.7000 76249.9n 0.7000 76250.0n 0.3000 76499.9n 0.3000 76500.0n 0.3000 76749.9n 0.3000 76750.0n 0.7000 76999.9n 0.7000 77000.0n 0.7000 77249.9n 0.7000 77250.0n 0.3000 77499.9n 0.3000 77500.0n 0.3000 77749.9n 0.3000 77750.0n 0.7000 77999.9n 0.7000 78000.0n 0.7000 78249.9n 0.7000 78250.0n 0.3000 78499.9n 0.3000 78500.0n 0.3000 78749.9n 0.3000 78750.0n 0.7000 78999.9n 0.7000 79000.0n 0.7000 79249.9n 0.7000 79250.0n 0.3000 79499.9n 0.3000 79500.0n 0.3000 79749.9n 0.3000 79750.0n 0.7000 79999.9n 0.7000 80000.0n 0.7000 80249.9n 0.7000 80250.0n 0.3000 80499.9n 0.3000 80500.0n 0.3000 80749.9n 0.3000 80750.0n 0.7000 80999.9n 0.7000 81000.0n 0.7000 81249.9n 0.7000 81250.0n 0.3000 81499.9n 0.3000 81500.0n 0.3000 81749.9n 0.3000 81750.0n 0.7000 81999.9n 0.7000 82000.0n 0.7000 82249.9n 0.7000 82250.0n 0.3000 82499.9n 0.3000 82500.0n 0.3000 82749.9n 0.3000 82750.0n 0.7000 82999.9n 0.7000 83000.0n 0.7000 83249.9n 0.7000 83250.0n 0.3000 83499.9n 0.3000 83500.0n 0.3000 83749.9n 0.3000 83750.0n 0.7000 83999.9n 0.7000 84000.0n 0.7000 84249.9n 0.7000 84250.0n 0.3000 84499.9n 0.3000 84500.0n 0.3000 84749.9n 0.3000 84750.0n 0.7000 84999.9n 0.7000 85000.0n 0.7000 85249.9n 0.7000 85250.0n 0.3000 85499.9n 0.3000 85500.0n 0.3000 85749.9n 0.3000 85750.0n 0.7000 85999.9n 0.7000 86000.0n 0.7000 86249.9n 0.7000 86250.0n 0.3000 86499.9n 0.3000 86500.0n 0.3000 86749.9n 0.3000 86750.0n 0.7000 86999.9n 0.7000 87000.0n 0.7000 87249.9n 0.7000 87250.0n 0.3000 87499.9n 0.3000 87500.0n 0.3000 87749.9n 0.3000 87750.0n 0.7000 87999.9n 0.7000 88000.0n 0.7000 88249.9n 0.7000 88250.0n 0.3000 88499.9n 0.3000 88500.0n 0.3000 88749.9n 0.3000 88750.0n 0.7000 88999.9n 0.7000 89000.0n 0.7000 89249.9n 0.7000 89250.0n 0.3000 89499.9n 0.3000 89500.0n 0.3000 89749.9n 0.3000 89750.0n 0.7000 89999.9n 0.7000 90000.0n 0.7000 90249.9n 0.7000 90250.0n 0.3000 90499.9n 0.3000 90500.0n 0.3000 90749.9n 0.3000 90750.0n 0.7000 90999.9n 0.7000 91000.0n 0.7000 91249.9n 0.7000 91250.0n 0.3000 91499.9n 0.3000 91500.0n 0.3000 91749.9n 0.3000 91750.0n 0.7000 91999.9n 0.7000 92000.0n 0.7000 92249.9n 0.7000 92250.0n 0.3000 92499.9n 0.3000 92500.0n 0.3000 92749.9n 0.3000 92750.0n 0.7000 92999.9n 0.7000 93000.0n 0.7000 93249.9n 0.7000 93250.0n 0.3000 93499.9n 0.3000 93500.0n 0.3000 93749.9n 0.3000 93750.0n 0.7000 93999.9n 0.7000 94000.0n 0.7000 94249.9n 0.7000 94250.0n 0.3000 94499.9n 0.3000 94500.0n 0.3000 94749.9n 0.3000 94750.0n 0.7000 94999.9n 0.7000 95000.0n 0.7000 95249.9n 0.7000 95250.0n 0.3000 95499.9n 0.3000 95500.0n 0.3000 95749.9n 0.3000 95750.0n 0.7000 95999.9n 0.7000 96000.0n 0.7000 96249.9n 0.7000 96250.0n 0.3000 96499.9n 0.3000 96500.0n 0.3000 96749.9n 0.3000 96750.0n 0.7000 96999.9n 0.7000 97000.0n 0.7000 97249.9n 0.7000 97250.0n 0.3000 97499.9n 0.3000 97500.0n 0.3000 97749.9n 0.3000 97750.0n 0.7000 97999.9n 0.7000 98000.0n 0.7000 98249.9n 0.7000 98250.0n 0.3000 98499.9n 0.3000 98500.0n 0.3000 98749.9n 0.3000 98750.0n 0.7000 98999.9n 0.7000 99000.0n 0.7000 99249.9n 0.7000 99250.0n 0.3000 99499.9n 0.3000 99500.0n 0.3000 99749.9n 0.3000 99750.0n 0.7000 99999.9n 0.7000 100000.0n 0.7000 100249.9n 0.7000 100250.0n 0.3000 100499.9n 0.3000 100500.0n 0.3000 100749.9n 0.3000 100750.0n 0.7000 100999.9n 0.7000 101000.0n 0.7000 101249.9n 0.7000 101250.0n 0.3000 101499.9n 0.3000 101500.0n 0.3000 101749.9n 0.3000 101750.0n 0.7000 101999.9n 0.7000 102000.0n 0.7000 102249.9n 0.7000 102250.0n 0.3000 102499.9n 0.3000 102500.0n 0.3000 102749.9n 0.3000 102750.0n 0.7000 102999.9n 0.7000 103000.0n 0.7000 103249.9n 0.7000 103250.0n 0.3000 103499.9n 0.3000 103500.0n 0.3000 103749.9n 0.3000 103750.0n 0.7000 103999.9n 0.7000 104000.0n 0.7000 104249.9n 0.7000 104250.0n 0.3000 104499.9n 0.3000 104500.0n 0.3000 104749.9n 0.3000 104750.0n 0.7000 104999.9n 0.7000 105000.0n 0.7000 105249.9n 0.7000 105250.0n 0.3000 105499.9n 0.3000 105500.0n 0.3000 105749.9n 0.3000 105750.0n 0.7000 105999.9n 0.7000 106000.0n 0.7000 106249.9n 0.7000 106250.0n 0.3000 106499.9n 0.3000 106500.0n 0.3000 106749.9n 0.3000 106750.0n 0.7000 106999.9n 0.7000 107000.0n 0.7000 107249.9n 0.7000 107250.0n 0.3000 107499.9n 0.3000 107500.0n 0.3000 107749.9n 0.3000 107750.0n 0.7000 107999.9n 0.7000 108000.0n 0.7000 108249.9n 0.7000 108250.0n 0.3000 108499.9n 0.3000 108500.0n 0.3000 108749.9n 0.3000 108750.0n 0.7000 108999.9n 0.7000 109000.0n 0.7000 109249.9n 0.7000 109250.0n 0.3000 109499.9n 0.3000 109500.0n 0.3000 109749.9n 0.3000 109750.0n 0.7000 109999.9n 0.7000 110000.0n 0.7000 110249.9n 0.7000 110250.0n 0.3000 110499.9n 0.3000 110500.0n 0.3000 110749.9n 0.3000 110750.0n 0.7000 110999.9n 0.7000 111000.0n 0.7000 111249.9n 0.7000 111250.0n 0.3000 111499.9n 0.3000 111500.0n 0.3000 111749.9n 0.3000 111750.0n 0.7000 111999.9n 0.7000 112000.0n 0.7000 112249.9n 0.7000 112250.0n 0.3000 112499.9n 0.3000 112500.0n 0.3000 112749.9n 0.3000 112750.0n 0.7000 112999.9n 0.7000 113000.0n 0.7000 113249.9n 0.7000 113250.0n 0.3000 113499.9n 0.3000 113500.0n 0.3000 113749.9n 0.3000 113750.0n 0.7000 113999.9n 0.7000 114000.0n 0.7000 114249.9n 0.7000 114250.0n 0.3000 114499.9n 0.3000 114500.0n 0.3000 114749.9n 0.3000 114750.0n 0.7000 114999.9n 0.7000 115000.0n 0.7000 115249.9n 0.7000 115250.0n 0.3000 115499.9n 0.3000 115500.0n 0.3000 115749.9n 0.3000 115750.0n 0.7000 115999.9n 0.7000 116000.0n 0.7000 116249.9n 0.7000 116250.0n 0.3000 116499.9n 0.3000 116500.0n 0.3000 116749.9n 0.3000 116750.0n 0.7000 116999.9n 0.7000 117000.0n 0.7000 117249.9n 0.7000 117250.0n 0.3000 117499.9n 0.3000 117500.0n 0.3000 117749.9n 0.3000 117750.0n 0.7000 117999.9n 0.7000 118000.0n 0.7000 118249.9n 0.7000 118250.0n 0.3000 118499.9n 0.3000 118500.0n 0.3000 118749.9n 0.3000 118750.0n 0.7000 118999.9n 0.7000 119000.0n 0.7000 119249.9n 0.7000 119250.0n 0.3000 119499.9n 0.3000 119500.0n 0.3000 119749.9n 0.3000 119750.0n 0.7000 119999.9n 0.7000 120000.0n 0.7000 120249.9n 0.7000 120250.0n 0.3000 120499.9n 0.3000 120500.0n 0.3000 120749.9n 0.3000 120750.0n 0.7000 120999.9n 0.7000 121000.0n 0.7000 121249.9n 0.7000 121250.0n 0.3000 121499.9n 0.3000 121500.0n 0.3000 121749.9n 0.3000 121750.0n 0.7000 121999.9n 0.7000 122000.0n 0.7000 122249.9n 0.7000 122250.0n 0.3000 122499.9n 0.3000 122500.0n 0.3000 122749.9n 0.3000 122750.0n 0.7000 122999.9n 0.7000 123000.0n 0.7000 123249.9n 0.7000 123250.0n 0.3000 123499.9n 0.3000 123500.0n 0.3000 123749.9n 0.3000 123750.0n 0.7000 123999.9n 0.7000 124000.0n 0.7000 124249.9n 0.7000 124250.0n 0.3000 124499.9n 0.3000 124500.0n 0.3000 124749.9n 0.3000 124750.0n 0.7000 124999.9n 0.7000 125000.0n 0.7000 125249.9n 0.7000 125250.0n 0.3000 125499.9n 0.3000 125500.0n 0.3000 125749.9n 0.3000 125750.0n 0.7000 125999.9n 0.7000 126000.0n 0.7000 126249.9n 0.7000 126250.0n 0.3000 126499.9n 0.3000 126500.0n 0.3000 126749.9n 0.3000 126750.0n 0.7000 126999.9n 0.7000 127000.0n 0.7000 127249.9n 0.7000 127250.0n 0.3000 127499.9n 0.3000 127500.0n 0.3000 127749.9n 0.3000 127750.0n 0.7000 127999.9n 0.7000 128000.0n 0.7000 128249.9n 0.7000 128250.0n 0.3000 128499.9n 0.3000 128500.0n 0.3000 128749.9n 0.3000 128750.0n 0.7000 128999.9n 0.7000 129000.0n 0.7000 129249.9n 0.7000 129250.0n 0.3000 129499.9n 0.3000 129500.0n 0.3000 129749.9n 0.3000 129750.0n 0.7000 129999.9n 0.7000 130000.0n 0.7000 130249.9n 0.7000 130250.0n 0.3000 130499.9n 0.3000 130500.0n 0.3000 130749.9n 0.3000 130750.0n 0.7000 130999.9n 0.7000 131000.0n 0.7000 131249.9n 0.7000 131250.0n 0.3000 131499.9n 0.3000 131500.0n 0.3000 131749.9n 0.3000 131750.0n 0.7000 131999.9n 0.7000 132000.0n 0.7000 132249.9n 0.7000 132250.0n 0.3000 132499.9n 0.3000 132500.0n 0.3000 132749.9n 0.3000 132750.0n 0.7000 132999.9n 0.7000 133000.0n 0.7000 133249.9n 0.7000 133250.0n 0.3000 133499.9n 0.3000 133500.0n 0.3000 133749.9n 0.3000 133750.0n 0.7000 133999.9n 0.7000 134000.0n 0.7000 134249.9n 0.7000 134250.0n 0.3000 134499.9n 0.3000 134500.0n 0.3000 134749.9n 0.3000 134750.0n 0.7000 134999.9n 0.7000 135000.0n 0.7000 135249.9n 0.7000 135250.0n 0.3000 135499.9n 0.3000 135500.0n 0.3000 135749.9n 0.3000 135750.0n 0.7000 135999.9n 0.7000 136000.0n 0.7000 136249.9n 0.7000 136250.0n 0.3000 136499.9n 0.3000 136500.0n 0.3000 136749.9n 0.3000 136750.0n 0.7000 136999.9n 0.7000 137000.0n 0.7000 137249.9n 0.7000 137250.0n 0.3000 137499.9n 0.3000 137500.0n 0.3000 137749.9n 0.3000 137750.0n 0.7000 137999.9n 0.7000 138000.0n 0.7000 138249.9n 0.7000 138250.0n 0.3000 138499.9n 0.3000 138500.0n 0.3000 138749.9n 0.3000 138750.0n 0.7000 138999.9n 0.7000 139000.0n 0.7000 139249.9n 0.7000 139250.0n 0.3000 139499.9n 0.3000 139500.0n 0.3000 139749.9n 0.3000 139750.0n 0.7000 139999.9n 0.7000 140000.0n 0.7000 140249.9n 0.7000 140250.0n 0.3000 140499.9n 0.3000 140500.0n 0.3000 140749.9n 0.3000 140750.0n 0.7000 140999.9n 0.7000 141000.0n 0.7000 141249.9n 0.7000 141250.0n 0.3000 141499.9n 0.3000 141500.0n 0.3000 141749.9n 0.3000 141750.0n 0.7000 141999.9n 0.7000 142000.0n 0.7000 142249.9n 0.7000 142250.0n 0.3000 142499.9n 0.3000 142500.0n 0.3000 142749.9n 0.3000 142750.0n 0.7000 142999.9n 0.7000 143000.0n 0.7000 143249.9n 0.7000 143250.0n 0.3000 143499.9n 0.3000 143500.0n 0.3000 143749.9n 0.3000 143750.0n 0.7000 143999.9n 0.7000 144000.0n 0.7000 144249.9n 0.7000 144250.0n 0.3000 144499.9n 0.3000 144500.0n 0.3000 144749.9n 0.3000 144750.0n 0.7000 144999.9n 0.7000 145000.0n 0.7000 145249.9n 0.7000 145250.0n 0.3000 145499.9n 0.3000 145500.0n 0.3000 145749.9n 0.3000 145750.0n 0.7000 145999.9n 0.7000 146000.0n 0.7000 146249.9n 0.7000 146250.0n 0.3000 146499.9n 0.3000 146500.0n 0.3000 146749.9n 0.3000 146750.0n 0.7000 146999.9n 0.7000 147000.0n 0.7000 147249.9n 0.7000 147250.0n 0.3000 147499.9n 0.3000 147500.0n 0.3000 147749.9n 0.3000 147750.0n 0.7000 147999.9n 0.7000 148000.0n 0.7000 148249.9n 0.7000 148250.0n 0.3000 148499.9n 0.3000 148500.0n 0.3000 148749.9n 0.3000 148750.0n 0.7000 148999.9n 0.7000 149000.0n 0.7000 149249.9n 0.7000 149250.0n 0.3000 149499.9n 0.3000 149500.0n 0.3000 149749.9n 0.3000 149750.0n 0.7000 149999.9n 0.7000 150000.0n 0.7000 150249.9n 0.7000 150250.0n 0.3000 150499.9n 0.3000 150500.0n 0.3000 150749.9n 0.3000 150750.0n 0.7000 150999.9n 0.7000 151000.0n 0.7000 151249.9n 0.7000 151250.0n 0.3000 151499.9n 0.3000 151500.0n 0.3000 151749.9n 0.3000 151750.0n 0.7000 151999.9n 0.7000 152000.0n 0.7000 152249.9n 0.7000 152250.0n 0.3000 152499.9n 0.3000 152500.0n 0.3000 152749.9n 0.3000 152750.0n 0.7000 152999.9n 0.7000 153000.0n 0.7000 153249.9n 0.7000 153250.0n 0.3000 153499.9n 0.3000 153500.0n 0.3000 153749.9n 0.3000 153750.0n 0.7000 153999.9n 0.7000 154000.0n 0.7000 154249.9n 0.7000 154250.0n 0.3000 154499.9n 0.3000 154500.0n 0.3000 154749.9n 0.3000 154750.0n 0.7000 154999.9n 0.7000 155000.0n 0.7000 155249.9n 0.7000 155250.0n 0.3000 155499.9n 0.3000 155500.0n 0.3000 155749.9n 0.3000 155750.0n 0.7000 155999.9n 0.7000 156000.0n 0.7000 156249.9n 0.7000 156250.0n 0.3000 156499.9n 0.3000 156500.0n 0.3000 156749.9n 0.3000 156750.0n 0.7000 156999.9n 0.7000 157000.0n 0.7000 157249.9n 0.7000 157250.0n 0.3000 157499.9n 0.3000 157500.0n 0.3000 157749.9n 0.3000 157750.0n 0.7000 157999.9n 0.7000 158000.0n 0.7000 158249.9n 0.7000 158250.0n 0.3000 158499.9n 0.3000 158500.0n 0.3000 158749.9n 0.3000 158750.0n 0.7000 158999.9n 0.7000 159000.0n 0.7000 159249.9n 0.7000 159250.0n 0.3000 159499.9n 0.3000 159500.0n 0.3000 159749.9n 0.3000 159750.0n 0.7000)
Cwp_wih_1_0 wp_wih_1_0 0 30p
Cwn_wih_1_0 wn_wih_1_0 0 30p
Rwp_wih_1_0 wp_wih_1_0 wcm 2g
Rwn_wih_1_0 wn_wih_1_0 wcm 2g
Cwp_wih_2_0 wp_wih_2_0 0 30p
Cwn_wih_2_0 wn_wih_2_0 0 30p
Rwp_wih_2_0 wp_wih_2_0 wcm 2g
Rwn_wih_2_0 wn_wih_2_0 wcm 2g
Cwp_who_0 wp_who_0 0 30p
Cwn_who_0 wn_who_0 0 30p
Rwp_who_0 wp_who_0 wcm 2g
Rwn_who_0 wn_who_0 wcm 2g
Cwp_wih_1_1 wp_wih_1_1 0 30p
Cwn_wih_1_1 wn_wih_1_1 0 30p
Rwp_wih_1_1 wp_wih_1_1 wcm 2g
Rwn_wih_1_1 wn_wih_1_1 wcm 2g
Cwp_wih_2_1 wp_wih_2_1 0 30p
Cwn_wih_2_1 wn_wih_2_1 0 30p
Rwp_wih_2_1 wp_wih_2_1 wcm 2g
Rwn_wih_2_1 wn_wih_2_1 wcm 2g
Cwp_who_1 wp_who_1 0 30p
Cwn_who_1 wn_who_1 0 30p
Rwp_who_1 wp_who_1 wcm 2g
Rwn_who_1 wn_who_1 wcm 2g
Cwp_wih_1_2 wp_wih_1_2 0 30p
Cwn_wih_1_2 wn_wih_1_2 0 30p
Rwp_wih_1_2 wp_wih_1_2 wcm 2g
Rwn_wih_1_2 wn_wih_1_2 wcm 2g
Cwp_wih_2_2 wp_wih_2_2 0 30p
Cwn_wih_2_2 wn_wih_2_2 0 30p
Rwp_wih_2_2 wp_wih_2_2 wcm 2g
Rwn_wih_2_2 wn_wih_2_2 wcm 2g
Cwp_who_2 wp_who_2 0 30p
Cwn_who_2 wn_who_2 0 30p
Rwp_who_2 wp_who_2 wcm 2g
Rwn_who_2 wn_who_2 wcm 2g
Cwp_wih_1_3 wp_wih_1_3 0 30p
Cwn_wih_1_3 wn_wih_1_3 0 30p
Rwp_wih_1_3 wp_wih_1_3 wcm 2g
Rwn_wih_1_3 wn_wih_1_3 wcm 2g
Cwp_wih_2_3 wp_wih_2_3 0 30p
Cwn_wih_2_3 wn_wih_2_3 0 30p
Rwp_wih_2_3 wp_wih_2_3 wcm 2g
Rwn_wih_2_3 wn_wih_2_3 wcm 2g
Cwp_who_3 wp_who_3 0 30p
Cwn_who_3 wn_who_3 0 30p
Rwp_who_3 wp_who_3 wcm 2g
Rwn_who_3 wn_who_3 wcm 2g
Xcm_mh0 mhp0 mhn0 vdd cmld
Xcm_xh0 xhp0 xhn0 vdd cmld
Rnd_mh0 mhp0 mhn0 20k
Rnd_xh0 xhp0 xhn0 20k
Cxhp0 xhp0 0 0.4p
Cxhn0 xhn0 0 0.4p
X_ihm_1_0 a_xp1 a_xn1 wp_wih_1_0 wn_wih_1_0 mhp0 mhn0 vdd vbsyn gsyn
X_ihx_1_0 a_xp1 a_xn1 wp_wih_1_0 wn_wih_1_0 xhp0 xhn0 vdd vbsyn gsyn
X_ihm_2_0 a_xp2 a_xn2 wp_wih_2_0 wn_wih_2_0 mhp0 mhn0 vdd vbsyn gsyn
X_ihx_2_0 a_xp2 a_xn2 wp_wih_2_0 wn_wih_2_0 xhp0 xhn0 vdd vbsyn gsyn
X_bk_0 eop eon wp_who_0 wn_who_0 xhp0 xhn0 vdd vbsyn gsyn
Xn0 xhp0 xhn0 ahp0 ahn0 vdd vbneu dneuron
Xeh0 xhp0 xhn0 mhp0 mhn0 ehp0 ehn0 vdd gm esub
Xcm_mh1 mhp1 mhn1 vdd cmld
Xcm_xh1 xhp1 xhn1 vdd cmld
Rnd_mh1 mhp1 mhn1 20k
Rnd_xh1 xhp1 xhn1 20k
Cxhp1 xhp1 0 0.4p
Cxhn1 xhn1 0 0.4p
X_ihm_1_1 a_xp1 a_xn1 wp_wih_1_1 wn_wih_1_1 mhp1 mhn1 vdd vbsyn gsyn
X_ihx_1_1 a_xp1 a_xn1 wp_wih_1_1 wn_wih_1_1 xhp1 xhn1 vdd vbsyn gsyn
X_ihm_2_1 a_xp2 a_xn2 wp_wih_2_1 wn_wih_2_1 mhp1 mhn1 vdd vbsyn gsyn
X_ihx_2_1 a_xp2 a_xn2 wp_wih_2_1 wn_wih_2_1 xhp1 xhn1 vdd vbsyn gsyn
X_bk_1 eop eon wp_who_1 wn_who_1 xhp1 xhn1 vdd vbsyn gsyn
Xn1 xhp1 xhn1 ahp1 ahn1 vdd vbneu dneuron
Xeh1 xhp1 xhn1 mhp1 mhn1 ehp1 ehn1 vdd gm esub
Xcm_mh2 mhp2 mhn2 vdd cmld
Xcm_xh2 xhp2 xhn2 vdd cmld
Rnd_mh2 mhp2 mhn2 20k
Rnd_xh2 xhp2 xhn2 20k
Cxhp2 xhp2 0 0.4p
Cxhn2 xhn2 0 0.4p
X_ihm_1_2 a_xp1 a_xn1 wp_wih_1_2 wn_wih_1_2 mhp2 mhn2 vdd vbsyn gsyn
X_ihx_1_2 a_xp1 a_xn1 wp_wih_1_2 wn_wih_1_2 xhp2 xhn2 vdd vbsyn gsyn
X_ihm_2_2 a_xp2 a_xn2 wp_wih_2_2 wn_wih_2_2 mhp2 mhn2 vdd vbsyn gsyn
X_ihx_2_2 a_xp2 a_xn2 wp_wih_2_2 wn_wih_2_2 xhp2 xhn2 vdd vbsyn gsyn
X_bk_2 eop eon wp_who_2 wn_who_2 xhp2 xhn2 vdd vbsyn gsyn
Xn2 xhp2 xhn2 ahp2 ahn2 vdd vbneu dneuron
Xeh2 xhp2 xhn2 mhp2 mhn2 ehp2 ehn2 vdd gm esub
Xcm_mh3 mhp3 mhn3 vdd cmld
Xcm_xh3 xhp3 xhn3 vdd cmld
Rnd_mh3 mhp3 mhn3 20k
Rnd_xh3 xhp3 xhn3 20k
Cxhp3 xhp3 0 0.4p
Cxhn3 xhn3 0 0.4p
X_ihm_1_3 a_xp1 a_xn1 wp_wih_1_3 wn_wih_1_3 mhp3 mhn3 vdd vbsyn gsyn
X_ihx_1_3 a_xp1 a_xn1 wp_wih_1_3 wn_wih_1_3 xhp3 xhn3 vdd vbsyn gsyn
X_ihm_2_3 a_xp2 a_xn2 wp_wih_2_3 wn_wih_2_3 mhp3 mhn3 vdd vbsyn gsyn
X_ihx_2_3 a_xp2 a_xn2 wp_wih_2_3 wn_wih_2_3 xhp3 xhn3 vdd vbsyn gsyn
X_bk_3 eop eon wp_who_3 wn_who_3 xhp3 xhn3 vdd vbsyn gsyn
Xn3 xhp3 xhn3 ahp3 ahn3 vdd vbneu dneuron
Xeh3 xhp3 xhn3 mhp3 mhn3 ehp3 ehn3 vdd gm esub
Xcm_mo mop mon vdd cmld
Rnd_mo mop mon 20k
X_ho_0 ahp0 ahn0 wp_who_0 wn_who_0 mop mon vdd vbsyn gsyn
X_ho_1 ahp1 ahn1 wp_who_1 wn_who_1 mop mon vdd vbsyn gsyn
X_ho_2 ahp2 ahn2 wp_who_2 wn_who_2 mop mon vdd vbsyn gsyn
X_ho_3 ahp3 ahn3 wp_who_3 wn_who_3 mop mon vdd vbsyn gsyn
Xeo xop xon mop mon eop eon vdd gm esub
Xlih_1_0 ehp0 ehn0 a_xp1 a_xn1 wp_wih_1_0 wn_wih_1_0 vdd gblh gprod
Xlih_2_0 ehp0 ehn0 a_xp2 a_xn2 wp_wih_2_0 wn_wih_2_0 vdd gblh gprod
Xlho_0 eon eop ahp0 ahn0 wp_who_0 wn_who_0 vdd gblo gprod
Xlih_1_1 ehp1 ehn1 a_xp1 a_xn1 wp_wih_1_1 wn_wih_1_1 vdd gblh gprod
Xlih_2_1 ehp1 ehn1 a_xp2 a_xn2 wp_wih_2_1 wn_wih_2_1 vdd gblh gprod
Xlho_1 eon eop ahp1 ahn1 wp_who_1 wn_who_1 vdd gblo gprod
Xlih_1_2 ehp2 ehn2 a_xp1 a_xn1 wp_wih_1_2 wn_wih_1_2 vdd gblh gprod
Xlih_2_2 ehp2 ehn2 a_xp2 a_xn2 wp_wih_2_2 wn_wih_2_2 vdd gblh gprod
Xlho_2 eon eop ahp2 ahn2 wp_who_2 wn_who_2 vdd gblo gprod
Xlih_1_3 ehp3 ehn3 a_xp1 a_xn1 wp_wih_1_3 wn_wih_1_3 vdd gblh gprod
Xlih_2_3 ehp3 ehn3 a_xp2 a_xn2 wp_wih_2_3 wn_wih_2_3 vdd gblh gprod
Xlho_3 eon eop ahp3 ahn3 wp_who_3 wn_who_3 vdd gblo gprod
.ic v(wp_wih_1_0)=0.6043 v(wn_wih_1_0)=0.3957
.ic v(wp_wih_2_0)=0.3531 v(wn_wih_2_0)=0.6469
.ic v(wp_who_0)=0.3000 v(wn_who_0)=0.7360
.ic v(wp_wih_1_1)=0.3000 v(wn_wih_1_1)=0.9000
.ic v(wp_wih_2_1)=0.4470 v(wn_wih_2_1)=0.5530
.ic v(wp_who_1)=0.6871 v(wn_who_1)=0.3129
.ic v(wp_wih_1_2)=0.5050 v(wn_wih_1_2)=0.4950
.ic v(wp_wih_2_2)=0.5768 v(wn_wih_2_2)=0.4232
.ic v(wp_who_2)=0.6535 v(wn_who_2)=0.3465
.ic v(wp_wih_1_3)=0.3677 v(wn_wih_1_3)=0.6323
.ic v(wp_wih_2_3)=0.8978 v(wn_wih_2_3)=0.3000
.ic v(wp_who_3)=0.3685 v(wn_who_3)=0.6315
.options cshunt=1e-14 gmin=1e-10 reltol=2e-3
.tran 2n 160000n uic
.control
run
wrdata pcLcf4_14.dat v(mop) v(mon) v(xop)
.endc
.end
