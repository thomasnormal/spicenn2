digits cds product run
.model NNR NMOS (LEVEL=1 VTO=0.2 KP=120u LAMBDA=0.02 GAMMA=0 PHI=0.7)
.model PNR PMOS (LEVEL=1 VTO=-0.2 KP=40u LAMBDA=0.02 GAMMA=0 PHI=0.7)
.subckt gprod xp xn yp yn wp wn vdd vbn
Mtail nt vbn 0 0 NNR W=400u L=100u
M5 na yp nt 0 NNR W=200u L=100u
M6 nb yn nt 0 NNR W=200u L=100u
M1 iop xp na 0 NNR W=200u L=100u
M2 ion xn na 0 NNR W=200u L=100u
M3 ion xp nb 0 NNR W=200u L=100u
M4 iop xn nb 0 NNR W=200u L=100u
Mlp iop iop vdd vdd PNR W=200u L=100u
Mln ion ion vdd vdd PNR W=200u L=100u
Mpu_wp wp iop vdd vdd PNR W=200u L=100u
MpRn nrn ion vdd vdd PNR W=200u L=100u
MnRn nrn nrn 0 0 NNR W=200u L=100u
Mpd_wp wp nrn 0 0 NNR W=200u L=100u
Mpu_wn wn ion vdd vdd PNR W=200u L=100u
MpRp nrp iop vdd vdd PNR W=200u L=100u
MnRp nrp nrp 0 0 NNR W=200u L=100u
Mpd_wn wn nrp 0 0 NNR W=200u L=100u
.ends
Vdd vdd 0 1.0
Vgbn gbn 0 1.1
Vxp_wih_0_0 xp_wih_0_0 0 PWL(0.0n 0.4942 599.5n 0.4942 600.0n 0.5558 1199.5n 0.5558 1200.0n 0.4708 1799.5n 0.4708 1800.0n 0.5235 2399.5n 0.5235 2400.0n 0.5350 2999.5n 0.5350 3000.0n 0.5172 3599.5n 0.5172 3600.0n 0.4702 4199.5n 0.4702 4200.0n 0.4867 4799.5n 0.4867 4800.0n 0.4970 5399.5n 0.4970 5400.0n 0.4986 5999.5n 0.4986 6000.0n 0.4751 6599.5n 0.4751 6600.0n 0.4870 7199.5n 0.4870 7200.0n 0.5502 7799.5n 0.5502 7800.0n 0.5521 8399.5n 0.5521 8400.0n 0.4638 8999.5n 0.4638 9000.0n 0.4982 9599.5n 0.4982 9600.0n 0.5131 10199.5n 0.5131 10200.0n 0.5386 10799.5n 0.5386 10800.0n 0.4592 11399.5n 0.4592 11400.0n 0.4950 11999.5n 0.4950 12000.0n 0.4559 12599.5n 0.4559 12600.0n 0.5162 13199.5n 0.5162 13200.0n 0.5038 13799.5n 0.5038 13800.0n 0.5333 14399.5n 0.5333 14400.0n 0.4991 14999.5n 0.4991 15000.0n 0.5298 15599.5n 0.5298 15600.0n 0.4823 16199.5n 0.4823 16200.0n 0.5239 16799.5n 0.5239 16800.0n 0.4592 17399.5n 0.4592 17400.0n 0.5094 17999.5n 0.5094 18000.0n 0.4337 18599.5n 0.4337 18600.0n 0.5977 19199.5n 0.5977 19200.0n 0.5364 19799.5n 0.5364 19800.0n 0.6122 20399.5n 0.6122 20400.0n 0.4856 20999.5n 0.4856 21000.0n 0.3861 21599.5n 0.3861 21600.0n 0.6094 22199.5n 0.6094 22200.0n 0.6364 22799.5n 0.6364 22800.0n 0.4807 23399.5n 0.4807 23400.0n 0.5614 23999.5n 0.5614 24000.0n 0.5913 24599.5n 0.5913 24600.0n 0.6295 25199.5n 0.6295 25200.0n 0.4496 25799.5n 0.4496 25800.0n 0.3792 26399.5n 0.3792 26400.0n 0.4434 26999.5n 0.4434 27000.0n 0.4340 27599.5n 0.4340 27600.0n 0.4461 28199.5n 0.4461 28200.0n 0.5791 28799.5n 0.5791 28800.0n 0.4777 29399.5n 0.4777 29400.0n 0.3878 29999.5n 0.3878 30000.0n 0.3832 30599.5n 0.3832 30600.0n 0.4022 31199.5n 0.4022 31200.0n 0.4482 31799.5n 0.4482 31800.0n 0.3662 32399.5n 0.3662 32400.0n 0.3857 32999.5n 0.3857 33000.0n 0.5584 33599.5n 0.5584 33600.0n 0.5284 34199.5n 0.5284 34200.0n 0.6034 34799.5n 0.6034 34800.0n 0.3469 35399.5n 0.3469 35400.0n 0.5290 35999.5n 0.5290)
Vxn_wih_0_0 xn_wih_0_0 0 PWL(0.0n 0.5058 599.5n 0.5058 600.0n 0.4442 1199.5n 0.4442 1200.0n 0.5292 1799.5n 0.5292 1800.0n 0.4765 2399.5n 0.4765 2400.0n 0.4650 2999.5n 0.4650 3000.0n 0.4828 3599.5n 0.4828 3600.0n 0.5298 4199.5n 0.5298 4200.0n 0.5133 4799.5n 0.5133 4800.0n 0.5030 5399.5n 0.5030 5400.0n 0.5014 5999.5n 0.5014 6000.0n 0.5249 6599.5n 0.5249 6600.0n 0.5130 7199.5n 0.5130 7200.0n 0.4498 7799.5n 0.4498 7800.0n 0.4479 8399.5n 0.4479 8400.0n 0.5362 8999.5n 0.5362 9000.0n 0.5018 9599.5n 0.5018 9600.0n 0.4869 10199.5n 0.4869 10200.0n 0.4614 10799.5n 0.4614 10800.0n 0.5408 11399.5n 0.5408 11400.0n 0.5050 11999.5n 0.5050 12000.0n 0.5441 12599.5n 0.5441 12600.0n 0.4838 13199.5n 0.4838 13200.0n 0.4962 13799.5n 0.4962 13800.0n 0.4667 14399.5n 0.4667 14400.0n 0.5009 14999.5n 0.5009 15000.0n 0.4702 15599.5n 0.4702 15600.0n 0.5177 16199.5n 0.5177 16200.0n 0.4761 16799.5n 0.4761 16800.0n 0.5408 17399.5n 0.5408 17400.0n 0.4906 17999.5n 0.4906 18000.0n 0.5663 18599.5n 0.5663 18600.0n 0.4023 19199.5n 0.4023 19200.0n 0.4636 19799.5n 0.4636 19800.0n 0.3878 20399.5n 0.3878 20400.0n 0.5144 20999.5n 0.5144 21000.0n 0.6139 21599.5n 0.6139 21600.0n 0.3906 22199.5n 0.3906 22200.0n 0.3636 22799.5n 0.3636 22800.0n 0.5193 23399.5n 0.5193 23400.0n 0.4386 23999.5n 0.4386 24000.0n 0.4087 24599.5n 0.4087 24600.0n 0.3705 25199.5n 0.3705 25200.0n 0.5504 25799.5n 0.5504 25800.0n 0.6208 26399.5n 0.6208 26400.0n 0.5566 26999.5n 0.5566 27000.0n 0.5660 27599.5n 0.5660 27600.0n 0.5539 28199.5n 0.5539 28200.0n 0.4209 28799.5n 0.4209 28800.0n 0.5223 29399.5n 0.5223 29400.0n 0.6122 29999.5n 0.6122 30000.0n 0.6168 30599.5n 0.6168 30600.0n 0.5978 31199.5n 0.5978 31200.0n 0.5518 31799.5n 0.5518 31800.0n 0.6338 32399.5n 0.6338 32400.0n 0.6143 32999.5n 0.6143 33000.0n 0.4416 33599.5n 0.4416 33600.0n 0.4716 34199.5n 0.4716 34200.0n 0.3966 34799.5n 0.3966 34800.0n 0.6531 35399.5n 0.6531 35400.0n 0.4710 35999.5n 0.4710)
Vyp_wih_0_0 yp_wih_0_0 0 PWL(0.0n 0.5612 599.5n 0.5612 600.0n 0.5536 1199.5n 0.5536 1200.0n 0.5574 1799.5n 0.5574 1800.0n 0.5491 2399.5n 0.5491 2400.0n 0.5500 2999.5n 0.5500 3000.0n 0.5567 3599.5n 0.5567 3600.0n 0.5589 4199.5n 0.5589 4200.0n 0.5619 4799.5n 0.5619 4800.0n 0.5578 5399.5n 0.5578 5400.0n 0.5576 5999.5n 0.5576 6000.0n 0.5561 6599.5n 0.5561 6600.0n 0.5592 7199.5n 0.5592 7200.0n 0.5530 7799.5n 0.5530 7800.0n 0.5523 8399.5n 0.5523 8400.0n 0.5629 8999.5n 0.5629 9000.0n 0.5577 9599.5n 0.5577 9600.0n 0.5555 10199.5n 0.5555 10200.0n 0.5529 10799.5n 0.5529 10800.0n 0.5587 11399.5n 0.5587 11400.0n 0.5583 11999.5n 0.5583 12000.0n 0.5643 12599.5n 0.5643 12600.0n 0.5551 13199.5n 0.5551 13200.0n 0.5607 13799.5n 0.5607 13800.0n 0.5569 14399.5n 0.5569 14400.0n 0.5582 14999.5n 0.5582 15000.0n 0.5523 15599.5n 0.5523 15600.0n 0.5611 16199.5n 0.5611 16200.0n 0.5591 16799.5n 0.5591 16800.0n 0.5630 17399.5n 0.5630 17400.0n 0.5599 17999.5n 0.5599 18000.0n 0.5530 18599.5n 0.5530 18600.0n 0.5457 19199.5n 0.5457 19200.0n 0.5409 19799.5n 0.5409 19800.0n 0.5354 20399.5n 0.5354 20400.0n 0.5437 20999.5n 0.5437 21000.0n 0.5669 21599.5n 0.5669 21600.0n 0.5397 22199.5n 0.5397 22200.0n 0.5449 22799.5n 0.5449 22800.0n 0.5440 23399.5n 0.5440 23400.0n 0.5648 23999.5n 0.5648 24000.0n 0.5304 24599.5n 0.5304 24600.0n 0.5466 25199.5n 0.5466 25200.0n 0.5482 25799.5n 0.5482 25800.0n 0.5551 26399.5n 0.5551 26400.0n 0.5479 26999.5n 0.5479 27000.0n 0.5508 27599.5n 0.5508 27600.0n 0.5475 28199.5n 0.5475 28200.0n 0.5601 28799.5n 0.5601 28800.0n 0.5442 29399.5n 0.5442 29400.0n 0.5683 29999.5n 0.5683 30000.0n 0.5708 30599.5n 0.5708 30600.0n 0.5834 31199.5n 0.5834 31200.0n 0.5758 31799.5n 0.5758 31800.0n 0.5566 32399.5n 0.5566 32400.0n 0.5552 32999.5n 0.5552 33000.0n 0.5367 33599.5n 0.5367 33600.0n 0.5403 34199.5n 0.5403 34200.0n 0.5481 34799.5n 0.5481 34800.0n 0.5751 35399.5n 0.5751 35400.0n 0.5403 35999.5n 0.5403)
Vyn_wih_0_0 yn_wih_0_0 0 PWL(0.0n 0.4388 599.5n 0.4388 600.0n 0.4464 1199.5n 0.4464 1200.0n 0.4426 1799.5n 0.4426 1800.0n 0.4509 2399.5n 0.4509 2400.0n 0.4500 2999.5n 0.4500 3000.0n 0.4433 3599.5n 0.4433 3600.0n 0.4411 4199.5n 0.4411 4200.0n 0.4381 4799.5n 0.4381 4800.0n 0.4422 5399.5n 0.4422 5400.0n 0.4424 5999.5n 0.4424 6000.0n 0.4439 6599.5n 0.4439 6600.0n 0.4408 7199.5n 0.4408 7200.0n 0.4470 7799.5n 0.4470 7800.0n 0.4477 8399.5n 0.4477 8400.0n 0.4371 8999.5n 0.4371 9000.0n 0.4423 9599.5n 0.4423 9600.0n 0.4445 10199.5n 0.4445 10200.0n 0.4471 10799.5n 0.4471 10800.0n 0.4413 11399.5n 0.4413 11400.0n 0.4417 11999.5n 0.4417 12000.0n 0.4357 12599.5n 0.4357 12600.0n 0.4449 13199.5n 0.4449 13200.0n 0.4393 13799.5n 0.4393 13800.0n 0.4431 14399.5n 0.4431 14400.0n 0.4418 14999.5n 0.4418 15000.0n 0.4477 15599.5n 0.4477 15600.0n 0.4389 16199.5n 0.4389 16200.0n 0.4409 16799.5n 0.4409 16800.0n 0.4370 17399.5n 0.4370 17400.0n 0.4401 17999.5n 0.4401 18000.0n 0.4470 18599.5n 0.4470 18600.0n 0.4543 19199.5n 0.4543 19200.0n 0.4591 19799.5n 0.4591 19800.0n 0.4646 20399.5n 0.4646 20400.0n 0.4563 20999.5n 0.4563 21000.0n 0.4331 21599.5n 0.4331 21600.0n 0.4603 22199.5n 0.4603 22200.0n 0.4551 22799.5n 0.4551 22800.0n 0.4560 23399.5n 0.4560 23400.0n 0.4352 23999.5n 0.4352 24000.0n 0.4696 24599.5n 0.4696 24600.0n 0.4534 25199.5n 0.4534 25200.0n 0.4518 25799.5n 0.4518 25800.0n 0.4449 26399.5n 0.4449 26400.0n 0.4521 26999.5n 0.4521 27000.0n 0.4492 27599.5n 0.4492 27600.0n 0.4525 28199.5n 0.4525 28200.0n 0.4399 28799.5n 0.4399 28800.0n 0.4558 29399.5n 0.4558 29400.0n 0.4317 29999.5n 0.4317 30000.0n 0.4292 30599.5n 0.4292 30600.0n 0.4166 31199.5n 0.4166 31200.0n 0.4242 31799.5n 0.4242 31800.0n 0.4434 32399.5n 0.4434 32400.0n 0.4448 32999.5n 0.4448 33000.0n 0.4633 33599.5n 0.4633 33600.0n 0.4597 34199.5n 0.4597 34200.0n 0.4519 34799.5n 0.4519 34800.0n 0.4249 35399.5n 0.4249 35400.0n 0.4597 35999.5n 0.4597)
Cwp_wih_0_0 wp_wih_0_0 0 400p
Cwn_wih_0_0 wn_wih_0_0 0 400p
Xu_wih_0_0 xp_wih_0_0 xn_wih_0_0 yp_wih_0_0 yn_wih_0_0 wp_wih_0_0 wn_wih_0_0 vdd gbn gprod
Vxp_wih_1_0 xp_wih_1_0 0 PWL(0.0n 0.5370 599.5n 0.5370 600.0n 0.5167 1199.5n 0.5167 1200.0n 0.4793 1799.5n 0.4793 1800.0n 0.4441 2399.5n 0.4441 2400.0n 0.4555 2999.5n 0.4555 3000.0n 0.5055 3599.5n 0.5055 3600.0n 0.4939 4199.5n 0.4939 4200.0n 0.5385 4799.5n 0.5385 4800.0n 0.5024 5399.5n 0.5024 5400.0n 0.5015 5999.5n 0.5015 6000.0n 0.4700 6599.5n 0.4700 6600.0n 0.5120 7199.5n 0.5120 7200.0n 0.5006 7799.5n 0.5006 7800.0n 0.4950 8399.5n 0.4950 8400.0n 0.5309 8999.5n 0.5309 9000.0n 0.5023 9599.5n 0.5023 9600.0n 0.4893 10199.5n 0.4893 10200.0n 0.4837 10799.5n 0.4837 10800.0n 0.4823 11399.5n 0.4823 11400.0n 0.5074 11999.5n 0.5074 12000.0n 0.5364 12599.5n 0.5364 12600.0n 0.4868 13199.5n 0.4868 13200.0n 0.5380 13799.5n 0.5380 13800.0n 0.5220 14399.5n 0.5220 14400.0n 0.5095 14999.5n 0.5095 15000.0n 0.4705 15599.5n 0.4705 15600.0n 0.5289 16199.5n 0.5289 16200.0n 0.5368 16799.5n 0.5368 16800.0n 0.5287 17399.5n 0.5287 17400.0n 0.5342 17999.5n 0.5342 18000.0n 0.4253 18599.5n 0.4253 18600.0n 0.5119 19199.5n 0.5119 19200.0n 0.4104 19799.5n 0.4104 19800.0n 0.4314 20399.5n 0.4314 20400.0n 0.4005 20999.5n 0.4005 21000.0n 0.4696 21599.5n 0.4696 21600.0n 0.4531 22199.5n 0.4531 22200.0n 0.5039 22799.5n 0.5039 22800.0n 0.3608 23399.5n 0.3608 23400.0n 0.6273 23999.5n 0.6273 24000.0n 0.3928 24599.5n 0.3928 24600.0n 0.5253 25199.5n 0.5253 25200.0n 0.4107 25799.5n 0.4107 25800.0n 0.3947 26399.5n 0.3947 26400.0n 0.3716 26999.5n 0.3716 27000.0n 0.4111 27599.5n 0.4111 27600.0n 0.3715 28199.5n 0.3715 28200.0n 0.5939 28799.5n 0.5939 28800.0n 0.3849 29399.5n 0.3849 29400.0n 0.4835 29999.5n 0.4835 30000.0n 0.5119 30599.5n 0.5119 30600.0n 0.6226 31199.5n 0.6226 31200.0n 0.6064 31799.5n 0.6064 31800.0n 0.4115 32399.5n 0.4115 32400.0n 0.3900 32999.5n 0.3900 33000.0n 0.3958 33599.5n 0.3958 33600.0n 0.3747 34199.5n 0.3747 34200.0n 0.5423 34799.5n 0.5423 34800.0n 0.5509 35399.5n 0.5509 35400.0n 0.3990 35999.5n 0.3990)
Vxn_wih_1_0 xn_wih_1_0 0 PWL(0.0n 0.4630 599.5n 0.4630 600.0n 0.4833 1199.5n 0.4833 1200.0n 0.5207 1799.5n 0.5207 1800.0n 0.5559 2399.5n 0.5559 2400.0n 0.5445 2999.5n 0.5445 3000.0n 0.4945 3599.5n 0.4945 3600.0n 0.5061 4199.5n 0.5061 4200.0n 0.4615 4799.5n 0.4615 4800.0n 0.4976 5399.5n 0.4976 5400.0n 0.4985 5999.5n 0.4985 6000.0n 0.5300 6599.5n 0.5300 6600.0n 0.4880 7199.5n 0.4880 7200.0n 0.4994 7799.5n 0.4994 7800.0n 0.5050 8399.5n 0.5050 8400.0n 0.4691 8999.5n 0.4691 9000.0n 0.4977 9599.5n 0.4977 9600.0n 0.5107 10199.5n 0.5107 10200.0n 0.5163 10799.5n 0.5163 10800.0n 0.5177 11399.5n 0.5177 11400.0n 0.4926 11999.5n 0.4926 12000.0n 0.4636 12599.5n 0.4636 12600.0n 0.5132 13199.5n 0.5132 13200.0n 0.4620 13799.5n 0.4620 13800.0n 0.4780 14399.5n 0.4780 14400.0n 0.4905 14999.5n 0.4905 15000.0n 0.5295 15599.5n 0.5295 15600.0n 0.4711 16199.5n 0.4711 16200.0n 0.4632 16799.5n 0.4632 16800.0n 0.4713 17399.5n 0.4713 17400.0n 0.4658 17999.5n 0.4658 18000.0n 0.5747 18599.5n 0.5747 18600.0n 0.4881 19199.5n 0.4881 19200.0n 0.5896 19799.5n 0.5896 19800.0n 0.5686 20399.5n 0.5686 20400.0n 0.5995 20999.5n 0.5995 21000.0n 0.5304 21599.5n 0.5304 21600.0n 0.5469 22199.5n 0.5469 22200.0n 0.4961 22799.5n 0.4961 22800.0n 0.6392 23399.5n 0.6392 23400.0n 0.3727 23999.5n 0.3727 24000.0n 0.6072 24599.5n 0.6072 24600.0n 0.4747 25199.5n 0.4747 25200.0n 0.5893 25799.5n 0.5893 25800.0n 0.6053 26399.5n 0.6053 26400.0n 0.6284 26999.5n 0.6284 27000.0n 0.5889 27599.5n 0.5889 27600.0n 0.6285 28199.5n 0.6285 28200.0n 0.4061 28799.5n 0.4061 28800.0n 0.6151 29399.5n 0.6151 29400.0n 0.5165 29999.5n 0.5165 30000.0n 0.4881 30599.5n 0.4881 30600.0n 0.3774 31199.5n 0.3774 31200.0n 0.3936 31799.5n 0.3936 31800.0n 0.5885 32399.5n 0.5885 32400.0n 0.6100 32999.5n 0.6100 33000.0n 0.6042 33599.5n 0.6042 33600.0n 0.6253 34199.5n 0.6253 34200.0n 0.4577 34799.5n 0.4577 34800.0n 0.4491 35399.5n 0.4491 35400.0n 0.6010 35999.5n 0.6010)
Vyp_wih_1_0 yp_wih_1_0 0 PWL(0.0n 0.5612 599.5n 0.5612 600.0n 0.5536 1199.5n 0.5536 1200.0n 0.5574 1799.5n 0.5574 1800.0n 0.5491 2399.5n 0.5491 2400.0n 0.5500 2999.5n 0.5500 3000.0n 0.5567 3599.5n 0.5567 3600.0n 0.5589 4199.5n 0.5589 4200.0n 0.5619 4799.5n 0.5619 4800.0n 0.5578 5399.5n 0.5578 5400.0n 0.5576 5999.5n 0.5576 6000.0n 0.5561 6599.5n 0.5561 6600.0n 0.5592 7199.5n 0.5592 7200.0n 0.5530 7799.5n 0.5530 7800.0n 0.5523 8399.5n 0.5523 8400.0n 0.5629 8999.5n 0.5629 9000.0n 0.5577 9599.5n 0.5577 9600.0n 0.5555 10199.5n 0.5555 10200.0n 0.5529 10799.5n 0.5529 10800.0n 0.5587 11399.5n 0.5587 11400.0n 0.5583 11999.5n 0.5583 12000.0n 0.5643 12599.5n 0.5643 12600.0n 0.5551 13199.5n 0.5551 13200.0n 0.5607 13799.5n 0.5607 13800.0n 0.5569 14399.5n 0.5569 14400.0n 0.5582 14999.5n 0.5582 15000.0n 0.5523 15599.5n 0.5523 15600.0n 0.5611 16199.5n 0.5611 16200.0n 0.5591 16799.5n 0.5591 16800.0n 0.5630 17399.5n 0.5630 17400.0n 0.5599 17999.5n 0.5599 18000.0n 0.5530 18599.5n 0.5530 18600.0n 0.5457 19199.5n 0.5457 19200.0n 0.5409 19799.5n 0.5409 19800.0n 0.5354 20399.5n 0.5354 20400.0n 0.5437 20999.5n 0.5437 21000.0n 0.5669 21599.5n 0.5669 21600.0n 0.5397 22199.5n 0.5397 22200.0n 0.5449 22799.5n 0.5449 22800.0n 0.5440 23399.5n 0.5440 23400.0n 0.5648 23999.5n 0.5648 24000.0n 0.5304 24599.5n 0.5304 24600.0n 0.5466 25199.5n 0.5466 25200.0n 0.5482 25799.5n 0.5482 25800.0n 0.5551 26399.5n 0.5551 26400.0n 0.5479 26999.5n 0.5479 27000.0n 0.5508 27599.5n 0.5508 27600.0n 0.5475 28199.5n 0.5475 28200.0n 0.5601 28799.5n 0.5601 28800.0n 0.5442 29399.5n 0.5442 29400.0n 0.5683 29999.5n 0.5683 30000.0n 0.5708 30599.5n 0.5708 30600.0n 0.5834 31199.5n 0.5834 31200.0n 0.5758 31799.5n 0.5758 31800.0n 0.5566 32399.5n 0.5566 32400.0n 0.5552 32999.5n 0.5552 33000.0n 0.5367 33599.5n 0.5367 33600.0n 0.5403 34199.5n 0.5403 34200.0n 0.5481 34799.5n 0.5481 34800.0n 0.5751 35399.5n 0.5751 35400.0n 0.5403 35999.5n 0.5403)
Vyn_wih_1_0 yn_wih_1_0 0 PWL(0.0n 0.4388 599.5n 0.4388 600.0n 0.4464 1199.5n 0.4464 1200.0n 0.4426 1799.5n 0.4426 1800.0n 0.4509 2399.5n 0.4509 2400.0n 0.4500 2999.5n 0.4500 3000.0n 0.4433 3599.5n 0.4433 3600.0n 0.4411 4199.5n 0.4411 4200.0n 0.4381 4799.5n 0.4381 4800.0n 0.4422 5399.5n 0.4422 5400.0n 0.4424 5999.5n 0.4424 6000.0n 0.4439 6599.5n 0.4439 6600.0n 0.4408 7199.5n 0.4408 7200.0n 0.4470 7799.5n 0.4470 7800.0n 0.4477 8399.5n 0.4477 8400.0n 0.4371 8999.5n 0.4371 9000.0n 0.4423 9599.5n 0.4423 9600.0n 0.4445 10199.5n 0.4445 10200.0n 0.4471 10799.5n 0.4471 10800.0n 0.4413 11399.5n 0.4413 11400.0n 0.4417 11999.5n 0.4417 12000.0n 0.4357 12599.5n 0.4357 12600.0n 0.4449 13199.5n 0.4449 13200.0n 0.4393 13799.5n 0.4393 13800.0n 0.4431 14399.5n 0.4431 14400.0n 0.4418 14999.5n 0.4418 15000.0n 0.4477 15599.5n 0.4477 15600.0n 0.4389 16199.5n 0.4389 16200.0n 0.4409 16799.5n 0.4409 16800.0n 0.4370 17399.5n 0.4370 17400.0n 0.4401 17999.5n 0.4401 18000.0n 0.4470 18599.5n 0.4470 18600.0n 0.4543 19199.5n 0.4543 19200.0n 0.4591 19799.5n 0.4591 19800.0n 0.4646 20399.5n 0.4646 20400.0n 0.4563 20999.5n 0.4563 21000.0n 0.4331 21599.5n 0.4331 21600.0n 0.4603 22199.5n 0.4603 22200.0n 0.4551 22799.5n 0.4551 22800.0n 0.4560 23399.5n 0.4560 23400.0n 0.4352 23999.5n 0.4352 24000.0n 0.4696 24599.5n 0.4696 24600.0n 0.4534 25199.5n 0.4534 25200.0n 0.4518 25799.5n 0.4518 25800.0n 0.4449 26399.5n 0.4449 26400.0n 0.4521 26999.5n 0.4521 27000.0n 0.4492 27599.5n 0.4492 27600.0n 0.4525 28199.5n 0.4525 28200.0n 0.4399 28799.5n 0.4399 28800.0n 0.4558 29399.5n 0.4558 29400.0n 0.4317 29999.5n 0.4317 30000.0n 0.4292 30599.5n 0.4292 30600.0n 0.4166 31199.5n 0.4166 31200.0n 0.4242 31799.5n 0.4242 31800.0n 0.4434 32399.5n 0.4434 32400.0n 0.4448 32999.5n 0.4448 33000.0n 0.4633 33599.5n 0.4633 33600.0n 0.4597 34199.5n 0.4597 34200.0n 0.4519 34799.5n 0.4519 34800.0n 0.4249 35399.5n 0.4249 35400.0n 0.4597 35999.5n 0.4597)
Cwp_wih_1_0 wp_wih_1_0 0 400p
Cwn_wih_1_0 wn_wih_1_0 0 400p
Xu_wih_1_0 xp_wih_1_0 xn_wih_1_0 yp_wih_1_0 yn_wih_1_0 wp_wih_1_0 wn_wih_1_0 vdd gbn gprod
Vxp_who_0_0 xp_who_0_0 0 PWL(0.0n 0.5612 599.5n 0.5612 600.0n 0.5536 1199.5n 0.5536 1200.0n 0.5574 1799.5n 0.5574 1800.0n 0.5491 2399.5n 0.5491 2400.0n 0.5500 2999.5n 0.5500 3000.0n 0.5567 3599.5n 0.5567 3600.0n 0.5589 4199.5n 0.5589 4200.0n 0.5619 4799.5n 0.5619 4800.0n 0.5578 5399.5n 0.5578 5400.0n 0.5576 5999.5n 0.5576 6000.0n 0.5561 6599.5n 0.5561 6600.0n 0.5592 7199.5n 0.5592 7200.0n 0.5530 7799.5n 0.5530 7800.0n 0.5523 8399.5n 0.5523 8400.0n 0.5629 8999.5n 0.5629 9000.0n 0.5577 9599.5n 0.5577 9600.0n 0.5555 10199.5n 0.5555 10200.0n 0.5529 10799.5n 0.5529 10800.0n 0.5587 11399.5n 0.5587 11400.0n 0.5583 11999.5n 0.5583 12000.0n 0.5643 12599.5n 0.5643 12600.0n 0.5551 13199.5n 0.5551 13200.0n 0.5607 13799.5n 0.5607 13800.0n 0.5569 14399.5n 0.5569 14400.0n 0.5582 14999.5n 0.5582 15000.0n 0.5523 15599.5n 0.5523 15600.0n 0.5611 16199.5n 0.5611 16200.0n 0.5591 16799.5n 0.5591 16800.0n 0.5630 17399.5n 0.5630 17400.0n 0.5599 17999.5n 0.5599 18000.0n 0.5530 18599.5n 0.5530 18600.0n 0.5457 19199.5n 0.5457 19200.0n 0.5409 19799.5n 0.5409 19800.0n 0.5354 20399.5n 0.5354 20400.0n 0.5437 20999.5n 0.5437 21000.0n 0.5669 21599.5n 0.5669 21600.0n 0.5397 22199.5n 0.5397 22200.0n 0.5449 22799.5n 0.5449 22800.0n 0.5440 23399.5n 0.5440 23400.0n 0.5648 23999.5n 0.5648 24000.0n 0.5304 24599.5n 0.5304 24600.0n 0.5466 25199.5n 0.5466 25200.0n 0.5482 25799.5n 0.5482 25800.0n 0.5551 26399.5n 0.5551 26400.0n 0.5479 26999.5n 0.5479 27000.0n 0.5508 27599.5n 0.5508 27600.0n 0.5475 28199.5n 0.5475 28200.0n 0.5601 28799.5n 0.5601 28800.0n 0.5442 29399.5n 0.5442 29400.0n 0.5683 29999.5n 0.5683 30000.0n 0.5708 30599.5n 0.5708 30600.0n 0.5834 31199.5n 0.5834 31200.0n 0.5758 31799.5n 0.5758 31800.0n 0.5566 32399.5n 0.5566 32400.0n 0.5552 32999.5n 0.5552 33000.0n 0.5367 33599.5n 0.5367 33600.0n 0.5403 34199.5n 0.5403 34200.0n 0.5481 34799.5n 0.5481 34800.0n 0.5751 35399.5n 0.5751 35400.0n 0.5403 35999.5n 0.5403)
Vxn_who_0_0 xn_who_0_0 0 PWL(0.0n 0.4388 599.5n 0.4388 600.0n 0.4464 1199.5n 0.4464 1200.0n 0.4426 1799.5n 0.4426 1800.0n 0.4509 2399.5n 0.4509 2400.0n 0.4500 2999.5n 0.4500 3000.0n 0.4433 3599.5n 0.4433 3600.0n 0.4411 4199.5n 0.4411 4200.0n 0.4381 4799.5n 0.4381 4800.0n 0.4422 5399.5n 0.4422 5400.0n 0.4424 5999.5n 0.4424 6000.0n 0.4439 6599.5n 0.4439 6600.0n 0.4408 7199.5n 0.4408 7200.0n 0.4470 7799.5n 0.4470 7800.0n 0.4477 8399.5n 0.4477 8400.0n 0.4371 8999.5n 0.4371 9000.0n 0.4423 9599.5n 0.4423 9600.0n 0.4445 10199.5n 0.4445 10200.0n 0.4471 10799.5n 0.4471 10800.0n 0.4413 11399.5n 0.4413 11400.0n 0.4417 11999.5n 0.4417 12000.0n 0.4357 12599.5n 0.4357 12600.0n 0.4449 13199.5n 0.4449 13200.0n 0.4393 13799.5n 0.4393 13800.0n 0.4431 14399.5n 0.4431 14400.0n 0.4418 14999.5n 0.4418 15000.0n 0.4477 15599.5n 0.4477 15600.0n 0.4389 16199.5n 0.4389 16200.0n 0.4409 16799.5n 0.4409 16800.0n 0.4370 17399.5n 0.4370 17400.0n 0.4401 17999.5n 0.4401 18000.0n 0.4470 18599.5n 0.4470 18600.0n 0.4543 19199.5n 0.4543 19200.0n 0.4591 19799.5n 0.4591 19800.0n 0.4646 20399.5n 0.4646 20400.0n 0.4563 20999.5n 0.4563 21000.0n 0.4331 21599.5n 0.4331 21600.0n 0.4603 22199.5n 0.4603 22200.0n 0.4551 22799.5n 0.4551 22800.0n 0.4560 23399.5n 0.4560 23400.0n 0.4352 23999.5n 0.4352 24000.0n 0.4696 24599.5n 0.4696 24600.0n 0.4534 25199.5n 0.4534 25200.0n 0.4518 25799.5n 0.4518 25800.0n 0.4449 26399.5n 0.4449 26400.0n 0.4521 26999.5n 0.4521 27000.0n 0.4492 27599.5n 0.4492 27600.0n 0.4525 28199.5n 0.4525 28200.0n 0.4399 28799.5n 0.4399 28800.0n 0.4558 29399.5n 0.4558 29400.0n 0.4317 29999.5n 0.4317 30000.0n 0.4292 30599.5n 0.4292 30600.0n 0.4166 31199.5n 0.4166 31200.0n 0.4242 31799.5n 0.4242 31800.0n 0.4434 32399.5n 0.4434 32400.0n 0.4448 32999.5n 0.4448 33000.0n 0.4633 33599.5n 0.4633 33600.0n 0.4597 34199.5n 0.4597 34200.0n 0.4519 34799.5n 0.4519 34800.0n 0.4249 35399.5n 0.4249 35400.0n 0.4597 35999.5n 0.4597)
Vyp_who_0_0 yp_who_0_0 0 PWL(0.0n 0.5031 599.5n 0.5031 600.0n 0.5023 1199.5n 0.5023 1200.0n 0.5052 1799.5n 0.5052 1800.0n 0.5048 2399.5n 0.5048 2400.0n 0.5043 2999.5n 0.5043 3000.0n 0.5034 3599.5n 0.5034 3600.0n 0.5048 4199.5n 0.5048 4200.0n 0.5031 4799.5n 0.5031 4800.0n 0.5040 5399.5n 0.5040 5400.0n 0.5040 5999.5n 0.5040 6000.0n 0.5054 6599.5n 0.5054 6600.0n 0.5040 7199.5n 0.5040 7200.0n 0.5027 7799.5n 0.5027 7800.0n 0.5027 8399.5n 0.5027 8400.0n 0.5038 8999.5n 0.5038 9000.0n 0.5040 9599.5n 0.5040 9600.0n 0.5039 10199.5n 0.5039 10200.0n 0.5033 10799.5n 0.5033 10800.0n 0.5056 11399.5n 0.5056 11400.0n 0.5040 11999.5n 0.5040 12000.0n 0.5036 12599.5n 0.5036 12600.0n 0.5039 13199.5n 0.5039 13200.0n 0.5029 13799.5n 0.5029 13800.0n 0.5025 14399.5n 0.5025 14400.0n 0.5038 14999.5n 0.5038 15000.0n 0.5041 15599.5n 0.5041 15600.0n 0.5036 16199.5n 0.5036 16200.0n 0.5025 16799.5n 0.5025 16800.0n 0.5040 17399.5n 0.5040 17400.0n 0.5029 17999.5n 0.5029 18000.0n 0.5057 18599.5n 0.5057 18600.0n 0.5010 19199.5n 0.5010 19200.0n 0.5041 19799.5n 0.5041 19800.0n 0.5021 20399.5n 0.5021 20400.0n 0.5044 20999.5n 0.5044 21000.0n 0.5056 21599.5n 0.5056 21600.0n 0.5016 22199.5n 0.5016 22200.0n 0.5006 22799.5n 0.5006 22800.0n 0.5041 23399.5n 0.5041 23400.0n 0.5027 23999.5n 0.5027 24000.0n 0.5029 24599.5n 0.5029 24600.0n 0.5006 25199.5n 0.5006 25200.0n 0.5047 25799.5n 0.5047 25800.0n 0.5046 26399.5n 0.5046 26400.0n 0.5039 26999.5n 0.5039 27000.0n 0.5049 27599.5n 0.5049 27600.0n 0.5039 28199.5n 0.5039 28200.0n 0.5017 28799.5n 0.5017 28800.0n 0.5042 29399.5n 0.5042 29400.0n 0.5056 29999.5n 0.5056 30000.0n 0.5051 30599.5n 0.5051 30600.0n 0.5039 31199.5n 0.5039 31200.0n 0.5033 31799.5n 0.5033 31800.0n 0.5049 32399.5n 0.5049 32400.0n 0.5045 32999.5n 0.5045 33000.0n 0.5036 33599.5n 0.5036 33600.0n 0.5042 34199.5n 0.5042 34200.0n 0.5012 34799.5n 0.5012 34800.0n 0.5036 35399.5n 0.5036 35400.0n 0.5042 35999.5n 0.5042)
Vyn_who_0_0 yn_who_0_0 0 PWL(0.0n 0.4969 599.5n 0.4969 600.0n 0.4977 1199.5n 0.4977 1200.0n 0.4948 1799.5n 0.4948 1800.0n 0.4952 2399.5n 0.4952 2400.0n 0.4957 2999.5n 0.4957 3000.0n 0.4966 3599.5n 0.4966 3600.0n 0.4952 4199.5n 0.4952 4200.0n 0.4969 4799.5n 0.4969 4800.0n 0.4960 5399.5n 0.4960 5400.0n 0.4960 5999.5n 0.4960 6000.0n 0.4946 6599.5n 0.4946 6600.0n 0.4960 7199.5n 0.4960 7200.0n 0.4973 7799.5n 0.4973 7800.0n 0.4973 8399.5n 0.4973 8400.0n 0.4962 8999.5n 0.4962 9000.0n 0.4960 9599.5n 0.4960 9600.0n 0.4961 10199.5n 0.4961 10200.0n 0.4967 10799.5n 0.4967 10800.0n 0.4944 11399.5n 0.4944 11400.0n 0.4960 11999.5n 0.4960 12000.0n 0.4964 12599.5n 0.4964 12600.0n 0.4961 13199.5n 0.4961 13200.0n 0.4971 13799.5n 0.4971 13800.0n 0.4975 14399.5n 0.4975 14400.0n 0.4962 14999.5n 0.4962 15000.0n 0.4959 15599.5n 0.4959 15600.0n 0.4964 16199.5n 0.4964 16200.0n 0.4975 16799.5n 0.4975 16800.0n 0.4960 17399.5n 0.4960 17400.0n 0.4971 17999.5n 0.4971 18000.0n 0.4943 18599.5n 0.4943 18600.0n 0.4990 19199.5n 0.4990 19200.0n 0.4959 19799.5n 0.4959 19800.0n 0.4979 20399.5n 0.4979 20400.0n 0.4956 20999.5n 0.4956 21000.0n 0.4944 21599.5n 0.4944 21600.0n 0.4984 22199.5n 0.4984 22200.0n 0.4994 22799.5n 0.4994 22800.0n 0.4959 23399.5n 0.4959 23400.0n 0.4973 23999.5n 0.4973 24000.0n 0.4971 24599.5n 0.4971 24600.0n 0.4994 25199.5n 0.4994 25200.0n 0.4953 25799.5n 0.4953 25800.0n 0.4954 26399.5n 0.4954 26400.0n 0.4961 26999.5n 0.4961 27000.0n 0.4951 27599.5n 0.4951 27600.0n 0.4961 28199.5n 0.4961 28200.0n 0.4983 28799.5n 0.4983 28800.0n 0.4958 29399.5n 0.4958 29400.0n 0.4944 29999.5n 0.4944 30000.0n 0.4949 30599.5n 0.4949 30600.0n 0.4961 31199.5n 0.4961 31200.0n 0.4967 31799.5n 0.4967 31800.0n 0.4951 32399.5n 0.4951 32400.0n 0.4955 32999.5n 0.4955 33000.0n 0.4964 33599.5n 0.4964 33600.0n 0.4958 34199.5n 0.4958 34200.0n 0.4988 34799.5n 0.4988 34800.0n 0.4964 35399.5n 0.4964 35400.0n 0.4958 35999.5n 0.4958)
Cwp_who_0_0 wp_who_0_0 0 400p
Cwn_who_0_0 wn_who_0_0 0 400p
Xu_who_0_0 xp_who_0_0 xn_who_0_0 yp_who_0_0 yn_who_0_0 wp_who_0_0 wn_who_0_0 vdd gbn gprod
Vxp_who_0_1 xp_who_0_1 0 PWL(0.0n 0.5612 599.5n 0.5612 600.0n 0.5536 1199.5n 0.5536 1200.0n 0.5574 1799.5n 0.5574 1800.0n 0.5491 2399.5n 0.5491 2400.0n 0.5500 2999.5n 0.5500 3000.0n 0.5567 3599.5n 0.5567 3600.0n 0.5589 4199.5n 0.5589 4200.0n 0.5619 4799.5n 0.5619 4800.0n 0.5578 5399.5n 0.5578 5400.0n 0.5576 5999.5n 0.5576 6000.0n 0.5561 6599.5n 0.5561 6600.0n 0.5592 7199.5n 0.5592 7200.0n 0.5530 7799.5n 0.5530 7800.0n 0.5523 8399.5n 0.5523 8400.0n 0.5629 8999.5n 0.5629 9000.0n 0.5577 9599.5n 0.5577 9600.0n 0.5555 10199.5n 0.5555 10200.0n 0.5529 10799.5n 0.5529 10800.0n 0.5587 11399.5n 0.5587 11400.0n 0.5583 11999.5n 0.5583 12000.0n 0.5643 12599.5n 0.5643 12600.0n 0.5551 13199.5n 0.5551 13200.0n 0.5607 13799.5n 0.5607 13800.0n 0.5569 14399.5n 0.5569 14400.0n 0.5582 14999.5n 0.5582 15000.0n 0.5523 15599.5n 0.5523 15600.0n 0.5611 16199.5n 0.5611 16200.0n 0.5591 16799.5n 0.5591 16800.0n 0.5630 17399.5n 0.5630 17400.0n 0.5599 17999.5n 0.5599 18000.0n 0.5530 18599.5n 0.5530 18600.0n 0.5457 19199.5n 0.5457 19200.0n 0.5409 19799.5n 0.5409 19800.0n 0.5354 20399.5n 0.5354 20400.0n 0.5437 20999.5n 0.5437 21000.0n 0.5669 21599.5n 0.5669 21600.0n 0.5397 22199.5n 0.5397 22200.0n 0.5449 22799.5n 0.5449 22800.0n 0.5440 23399.5n 0.5440 23400.0n 0.5648 23999.5n 0.5648 24000.0n 0.5304 24599.5n 0.5304 24600.0n 0.5466 25199.5n 0.5466 25200.0n 0.5482 25799.5n 0.5482 25800.0n 0.5551 26399.5n 0.5551 26400.0n 0.5479 26999.5n 0.5479 27000.0n 0.5508 27599.5n 0.5508 27600.0n 0.5475 28199.5n 0.5475 28200.0n 0.5601 28799.5n 0.5601 28800.0n 0.5442 29399.5n 0.5442 29400.0n 0.5683 29999.5n 0.5683 30000.0n 0.5708 30599.5n 0.5708 30600.0n 0.5834 31199.5n 0.5834 31200.0n 0.5758 31799.5n 0.5758 31800.0n 0.5566 32399.5n 0.5566 32400.0n 0.5552 32999.5n 0.5552 33000.0n 0.5367 33599.5n 0.5367 33600.0n 0.5403 34199.5n 0.5403 34200.0n 0.5481 34799.5n 0.5481 34800.0n 0.5751 35399.5n 0.5751 35400.0n 0.5403 35999.5n 0.5403)
Vxn_who_0_1 xn_who_0_1 0 PWL(0.0n 0.4388 599.5n 0.4388 600.0n 0.4464 1199.5n 0.4464 1200.0n 0.4426 1799.5n 0.4426 1800.0n 0.4509 2399.5n 0.4509 2400.0n 0.4500 2999.5n 0.4500 3000.0n 0.4433 3599.5n 0.4433 3600.0n 0.4411 4199.5n 0.4411 4200.0n 0.4381 4799.5n 0.4381 4800.0n 0.4422 5399.5n 0.4422 5400.0n 0.4424 5999.5n 0.4424 6000.0n 0.4439 6599.5n 0.4439 6600.0n 0.4408 7199.5n 0.4408 7200.0n 0.4470 7799.5n 0.4470 7800.0n 0.4477 8399.5n 0.4477 8400.0n 0.4371 8999.5n 0.4371 9000.0n 0.4423 9599.5n 0.4423 9600.0n 0.4445 10199.5n 0.4445 10200.0n 0.4471 10799.5n 0.4471 10800.0n 0.4413 11399.5n 0.4413 11400.0n 0.4417 11999.5n 0.4417 12000.0n 0.4357 12599.5n 0.4357 12600.0n 0.4449 13199.5n 0.4449 13200.0n 0.4393 13799.5n 0.4393 13800.0n 0.4431 14399.5n 0.4431 14400.0n 0.4418 14999.5n 0.4418 15000.0n 0.4477 15599.5n 0.4477 15600.0n 0.4389 16199.5n 0.4389 16200.0n 0.4409 16799.5n 0.4409 16800.0n 0.4370 17399.5n 0.4370 17400.0n 0.4401 17999.5n 0.4401 18000.0n 0.4470 18599.5n 0.4470 18600.0n 0.4543 19199.5n 0.4543 19200.0n 0.4591 19799.5n 0.4591 19800.0n 0.4646 20399.5n 0.4646 20400.0n 0.4563 20999.5n 0.4563 21000.0n 0.4331 21599.5n 0.4331 21600.0n 0.4603 22199.5n 0.4603 22200.0n 0.4551 22799.5n 0.4551 22800.0n 0.4560 23399.5n 0.4560 23400.0n 0.4352 23999.5n 0.4352 24000.0n 0.4696 24599.5n 0.4696 24600.0n 0.4534 25199.5n 0.4534 25200.0n 0.4518 25799.5n 0.4518 25800.0n 0.4449 26399.5n 0.4449 26400.0n 0.4521 26999.5n 0.4521 27000.0n 0.4492 27599.5n 0.4492 27600.0n 0.4525 28199.5n 0.4525 28200.0n 0.4399 28799.5n 0.4399 28800.0n 0.4558 29399.5n 0.4558 29400.0n 0.4317 29999.5n 0.4317 30000.0n 0.4292 30599.5n 0.4292 30600.0n 0.4166 31199.5n 0.4166 31200.0n 0.4242 31799.5n 0.4242 31800.0n 0.4434 32399.5n 0.4434 32400.0n 0.4448 32999.5n 0.4448 33000.0n 0.4633 33599.5n 0.4633 33600.0n 0.4597 34199.5n 0.4597 34200.0n 0.4519 34799.5n 0.4519 34800.0n 0.4249 35399.5n 0.4249 35400.0n 0.4597 35999.5n 0.4597)
Vyp_who_0_1 yp_who_0_1 0 PWL(0.0n 0.5071 599.5n 0.5071 600.0n 0.5053 1199.5n 0.5053 1200.0n 0.5052 1799.5n 0.5052 1800.0n 0.5027 2399.5n 0.5027 2400.0n 0.5034 2999.5n 0.5034 3000.0n 0.5055 3599.5n 0.5055 3600.0n 0.5056 4199.5n 0.5056 4200.0n 0.5071 4799.5n 0.5071 4800.0n 0.5056 5399.5n 0.5056 5400.0n 0.5056 5999.5n 0.5056 6000.0n 0.5048 6599.5n 0.5048 6600.0n 0.5060 7199.5n 0.5060 7200.0n 0.5048 7799.5n 0.5048 7800.0n 0.5046 8399.5n 0.5046 8400.0n 0.5066 8999.5n 0.5066 9000.0n 0.5056 9599.5n 0.5056 9600.0n 0.5051 10199.5n 0.5051 10200.0n 0.5046 10799.5n 0.5046 10800.0n 0.5056 11399.5n 0.5056 11400.0n 0.5058 11999.5n 0.5058 12000.0n 0.5068 12599.5n 0.5068 12600.0n 0.5050 13199.5n 0.5050 13200.0n 0.5071 13799.5n 0.5071 13800.0n 0.5059 14399.5n 0.5059 14400.0n 0.5058 14999.5n 0.5058 15000.0n 0.5043 15599.5n 0.5043 15600.0n 0.5067 16199.5n 0.5067 16200.0n 0.5068 16799.5n 0.5068 16800.0n 0.5066 17399.5n 0.5066 17400.0n 0.5069 17999.5n 0.5069 18000.0n 0.5061 18599.5n 0.5061 18600.0n 0.5034 19199.5n 0.5034 19200.0n 0.5010 19799.5n 0.5010 19800.0n 0.4989 20399.5n 0.4989 20400.0n 0.5022 20999.5n 0.5022 21000.0n 0.5086 21599.5n 0.5086 21600.0n 0.5007 22199.5n 0.5007 22200.0n 0.5023 22799.5n 0.5023 22800.0n 0.5021 23399.5n 0.5021 23400.0n 0.5077 23999.5n 0.5077 24000.0n 0.4979 24599.5n 0.4979 24600.0n 0.5035 25199.5n 0.5035 25200.0n 0.5041 25799.5n 0.5041 25800.0n 0.5075 26399.5n 0.5075 26400.0n 0.5041 26999.5n 0.5041 27000.0n 0.5056 27599.5n 0.5056 27600.0n 0.5039 28199.5n 0.5039 28200.0n 0.5059 28799.5n 0.5059 28800.0n 0.5023 29399.5n 0.5023 29400.0n 0.5086 29999.5n 0.5086 30000.0n 0.5084 30599.5n 0.5084 30600.0n 0.5085 31199.5n 0.5085 31200.0n 0.5088 31799.5n 0.5088 31800.0n 0.5078 32399.5n 0.5078 32400.0n 0.5074 32999.5n 0.5074 33000.0n 0.4996 33599.5n 0.4996 33600.0n 0.5010 34199.5n 0.5010 34200.0n 0.5044 34799.5n 0.5044 34800.0n 0.5084 35399.5n 0.5084 35400.0n 0.5012 35999.5n 0.5012)
Vyn_who_0_1 yn_who_0_1 0 PWL(0.0n 0.4929 599.5n 0.4929 600.0n 0.4947 1199.5n 0.4947 1200.0n 0.4948 1799.5n 0.4948 1800.0n 0.4973 2399.5n 0.4973 2400.0n 0.4966 2999.5n 0.4966 3000.0n 0.4945 3599.5n 0.4945 3600.0n 0.4944 4199.5n 0.4944 4200.0n 0.4929 4799.5n 0.4929 4800.0n 0.4944 5399.5n 0.4944 5400.0n 0.4944 5999.5n 0.4944 6000.0n 0.4952 6599.5n 0.4952 6600.0n 0.4940 7199.5n 0.4940 7200.0n 0.4952 7799.5n 0.4952 7800.0n 0.4954 8399.5n 0.4954 8400.0n 0.4934 8999.5n 0.4934 9000.0n 0.4944 9599.5n 0.4944 9600.0n 0.4949 10199.5n 0.4949 10200.0n 0.4954 10799.5n 0.4954 10800.0n 0.4944 11399.5n 0.4944 11400.0n 0.4942 11999.5n 0.4942 12000.0n 0.4932 12599.5n 0.4932 12600.0n 0.4950 13199.5n 0.4950 13200.0n 0.4929 13799.5n 0.4929 13800.0n 0.4941 14399.5n 0.4941 14400.0n 0.4942 14999.5n 0.4942 15000.0n 0.4957 15599.5n 0.4957 15600.0n 0.4933 16199.5n 0.4933 16200.0n 0.4932 16799.5n 0.4932 16800.0n 0.4934 17399.5n 0.4934 17400.0n 0.4931 17999.5n 0.4931 18000.0n 0.4939 18599.5n 0.4939 18600.0n 0.4966 19199.5n 0.4966 19200.0n 0.4990 19799.5n 0.4990 19800.0n 0.5011 20399.5n 0.5011 20400.0n 0.4978 20999.5n 0.4978 21000.0n 0.4914 21599.5n 0.4914 21600.0n 0.4993 22199.5n 0.4993 22200.0n 0.4977 22799.5n 0.4977 22800.0n 0.4979 23399.5n 0.4979 23400.0n 0.4923 23999.5n 0.4923 24000.0n 0.5021 24599.5n 0.5021 24600.0n 0.4965 25199.5n 0.4965 25200.0n 0.4959 25799.5n 0.4959 25800.0n 0.4925 26399.5n 0.4925 26400.0n 0.4959 26999.5n 0.4959 27000.0n 0.4944 27599.5n 0.4944 27600.0n 0.4961 28199.5n 0.4961 28200.0n 0.4941 28799.5n 0.4941 28800.0n 0.4977 29399.5n 0.4977 29400.0n 0.4914 29999.5n 0.4914 30000.0n 0.4916 30599.5n 0.4916 30600.0n 0.4915 31199.5n 0.4915 31200.0n 0.4912 31799.5n 0.4912 31800.0n 0.4922 32399.5n 0.4922 32400.0n 0.4926 32999.5n 0.4926 33000.0n 0.5004 33599.5n 0.5004 33600.0n 0.4990 34199.5n 0.4990 34200.0n 0.4956 34799.5n 0.4956 34800.0n 0.4916 35399.5n 0.4916 35400.0n 0.4988 35999.5n 0.4988)
Cwp_who_0_1 wp_who_0_1 0 400p
Cwn_who_0_1 wn_who_0_1 0 400p
Xu_who_0_1 xp_who_0_1 xn_who_0_1 yp_who_0_1 yn_who_0_1 wp_who_0_1 wn_who_0_1 vdd gbn gprod
Vxp_bh_0 xp_bh_0 0 PWL(0.0n 0.7100 599.5n 0.7100 600.0n 0.7100 1199.5n 0.7100 1200.0n 0.7100 1799.5n 0.7100 1800.0n 0.7100 2399.5n 0.7100 2400.0n 0.7100 2999.5n 0.7100 3000.0n 0.7100 3599.5n 0.7100 3600.0n 0.7100 4199.5n 0.7100 4200.0n 0.7100 4799.5n 0.7100 4800.0n 0.7100 5399.5n 0.7100 5400.0n 0.7100 5999.5n 0.7100 6000.0n 0.7100 6599.5n 0.7100 6600.0n 0.7100 7199.5n 0.7100 7200.0n 0.7100 7799.5n 0.7100 7800.0n 0.7100 8399.5n 0.7100 8400.0n 0.7100 8999.5n 0.7100 9000.0n 0.7100 9599.5n 0.7100 9600.0n 0.7100 10199.5n 0.7100 10200.0n 0.7100 10799.5n 0.7100 10800.0n 0.7100 11399.5n 0.7100 11400.0n 0.7100 11999.5n 0.7100 12000.0n 0.7100 12599.5n 0.7100 12600.0n 0.7100 13199.5n 0.7100 13200.0n 0.7100 13799.5n 0.7100 13800.0n 0.7100 14399.5n 0.7100 14400.0n 0.7100 14999.5n 0.7100 15000.0n 0.7100 15599.5n 0.7100 15600.0n 0.7100 16199.5n 0.7100 16200.0n 0.7100 16799.5n 0.7100 16800.0n 0.7100 17399.5n 0.7100 17400.0n 0.7100 17999.5n 0.7100 18000.0n 0.7100 18599.5n 0.7100 18600.0n 0.7100 19199.5n 0.7100 19200.0n 0.7100 19799.5n 0.7100 19800.0n 0.7100 20399.5n 0.7100 20400.0n 0.7100 20999.5n 0.7100 21000.0n 0.7100 21599.5n 0.7100 21600.0n 0.7100 22199.5n 0.7100 22200.0n 0.7100 22799.5n 0.7100 22800.0n 0.7100 23399.5n 0.7100 23400.0n 0.7100 23999.5n 0.7100 24000.0n 0.7100 24599.5n 0.7100 24600.0n 0.7100 25199.5n 0.7100 25200.0n 0.7100 25799.5n 0.7100 25800.0n 0.7100 26399.5n 0.7100 26400.0n 0.7100 26999.5n 0.7100 27000.0n 0.7100 27599.5n 0.7100 27600.0n 0.7100 28199.5n 0.7100 28200.0n 0.7100 28799.5n 0.7100 28800.0n 0.7100 29399.5n 0.7100 29400.0n 0.7100 29999.5n 0.7100 30000.0n 0.7100 30599.5n 0.7100 30600.0n 0.7100 31199.5n 0.7100 31200.0n 0.7100 31799.5n 0.7100 31800.0n 0.7100 32399.5n 0.7100 32400.0n 0.7100 32999.5n 0.7100 33000.0n 0.7100 33599.5n 0.7100 33600.0n 0.7100 34199.5n 0.7100 34200.0n 0.7100 34799.5n 0.7100 34800.0n 0.7100 35399.5n 0.7100 35400.0n 0.7100 35999.5n 0.7100)
Vxn_bh_0 xn_bh_0 0 PWL(0.0n 0.2900 599.5n 0.2900 600.0n 0.2900 1199.5n 0.2900 1200.0n 0.2900 1799.5n 0.2900 1800.0n 0.2900 2399.5n 0.2900 2400.0n 0.2900 2999.5n 0.2900 3000.0n 0.2900 3599.5n 0.2900 3600.0n 0.2900 4199.5n 0.2900 4200.0n 0.2900 4799.5n 0.2900 4800.0n 0.2900 5399.5n 0.2900 5400.0n 0.2900 5999.5n 0.2900 6000.0n 0.2900 6599.5n 0.2900 6600.0n 0.2900 7199.5n 0.2900 7200.0n 0.2900 7799.5n 0.2900 7800.0n 0.2900 8399.5n 0.2900 8400.0n 0.2900 8999.5n 0.2900 9000.0n 0.2900 9599.5n 0.2900 9600.0n 0.2900 10199.5n 0.2900 10200.0n 0.2900 10799.5n 0.2900 10800.0n 0.2900 11399.5n 0.2900 11400.0n 0.2900 11999.5n 0.2900 12000.0n 0.2900 12599.5n 0.2900 12600.0n 0.2900 13199.5n 0.2900 13200.0n 0.2900 13799.5n 0.2900 13800.0n 0.2900 14399.5n 0.2900 14400.0n 0.2900 14999.5n 0.2900 15000.0n 0.2900 15599.5n 0.2900 15600.0n 0.2900 16199.5n 0.2900 16200.0n 0.2900 16799.5n 0.2900 16800.0n 0.2900 17399.5n 0.2900 17400.0n 0.2900 17999.5n 0.2900 18000.0n 0.2900 18599.5n 0.2900 18600.0n 0.2900 19199.5n 0.2900 19200.0n 0.2900 19799.5n 0.2900 19800.0n 0.2900 20399.5n 0.2900 20400.0n 0.2900 20999.5n 0.2900 21000.0n 0.2900 21599.5n 0.2900 21600.0n 0.2900 22199.5n 0.2900 22200.0n 0.2900 22799.5n 0.2900 22800.0n 0.2900 23399.5n 0.2900 23400.0n 0.2900 23999.5n 0.2900 24000.0n 0.2900 24599.5n 0.2900 24600.0n 0.2900 25199.5n 0.2900 25200.0n 0.2900 25799.5n 0.2900 25800.0n 0.2900 26399.5n 0.2900 26400.0n 0.2900 26999.5n 0.2900 27000.0n 0.2900 27599.5n 0.2900 27600.0n 0.2900 28199.5n 0.2900 28200.0n 0.2900 28799.5n 0.2900 28800.0n 0.2900 29399.5n 0.2900 29400.0n 0.2900 29999.5n 0.2900 30000.0n 0.2900 30599.5n 0.2900 30600.0n 0.2900 31199.5n 0.2900 31200.0n 0.2900 31799.5n 0.2900 31800.0n 0.2900 32399.5n 0.2900 32400.0n 0.2900 32999.5n 0.2900 33000.0n 0.2900 33599.5n 0.2900 33600.0n 0.2900 34199.5n 0.2900 34200.0n 0.2900 34799.5n 0.2900 34800.0n 0.2900 35399.5n 0.2900 35400.0n 0.2900 35999.5n 0.2900)
Vyp_bh_0 yp_bh_0 0 PWL(0.0n 0.5612 599.5n 0.5612 600.0n 0.5536 1199.5n 0.5536 1200.0n 0.5574 1799.5n 0.5574 1800.0n 0.5491 2399.5n 0.5491 2400.0n 0.5500 2999.5n 0.5500 3000.0n 0.5567 3599.5n 0.5567 3600.0n 0.5589 4199.5n 0.5589 4200.0n 0.5619 4799.5n 0.5619 4800.0n 0.5578 5399.5n 0.5578 5400.0n 0.5576 5999.5n 0.5576 6000.0n 0.5561 6599.5n 0.5561 6600.0n 0.5592 7199.5n 0.5592 7200.0n 0.5530 7799.5n 0.5530 7800.0n 0.5523 8399.5n 0.5523 8400.0n 0.5629 8999.5n 0.5629 9000.0n 0.5577 9599.5n 0.5577 9600.0n 0.5555 10199.5n 0.5555 10200.0n 0.5529 10799.5n 0.5529 10800.0n 0.5587 11399.5n 0.5587 11400.0n 0.5583 11999.5n 0.5583 12000.0n 0.5643 12599.5n 0.5643 12600.0n 0.5551 13199.5n 0.5551 13200.0n 0.5607 13799.5n 0.5607 13800.0n 0.5569 14399.5n 0.5569 14400.0n 0.5582 14999.5n 0.5582 15000.0n 0.5523 15599.5n 0.5523 15600.0n 0.5611 16199.5n 0.5611 16200.0n 0.5591 16799.5n 0.5591 16800.0n 0.5630 17399.5n 0.5630 17400.0n 0.5599 17999.5n 0.5599 18000.0n 0.5530 18599.5n 0.5530 18600.0n 0.5457 19199.5n 0.5457 19200.0n 0.5409 19799.5n 0.5409 19800.0n 0.5354 20399.5n 0.5354 20400.0n 0.5437 20999.5n 0.5437 21000.0n 0.5669 21599.5n 0.5669 21600.0n 0.5397 22199.5n 0.5397 22200.0n 0.5449 22799.5n 0.5449 22800.0n 0.5440 23399.5n 0.5440 23400.0n 0.5648 23999.5n 0.5648 24000.0n 0.5304 24599.5n 0.5304 24600.0n 0.5466 25199.5n 0.5466 25200.0n 0.5482 25799.5n 0.5482 25800.0n 0.5551 26399.5n 0.5551 26400.0n 0.5479 26999.5n 0.5479 27000.0n 0.5508 27599.5n 0.5508 27600.0n 0.5475 28199.5n 0.5475 28200.0n 0.5601 28799.5n 0.5601 28800.0n 0.5442 29399.5n 0.5442 29400.0n 0.5683 29999.5n 0.5683 30000.0n 0.5708 30599.5n 0.5708 30600.0n 0.5834 31199.5n 0.5834 31200.0n 0.5758 31799.5n 0.5758 31800.0n 0.5566 32399.5n 0.5566 32400.0n 0.5552 32999.5n 0.5552 33000.0n 0.5367 33599.5n 0.5367 33600.0n 0.5403 34199.5n 0.5403 34200.0n 0.5481 34799.5n 0.5481 34800.0n 0.5751 35399.5n 0.5751 35400.0n 0.5403 35999.5n 0.5403)
Vyn_bh_0 yn_bh_0 0 PWL(0.0n 0.4388 599.5n 0.4388 600.0n 0.4464 1199.5n 0.4464 1200.0n 0.4426 1799.5n 0.4426 1800.0n 0.4509 2399.5n 0.4509 2400.0n 0.4500 2999.5n 0.4500 3000.0n 0.4433 3599.5n 0.4433 3600.0n 0.4411 4199.5n 0.4411 4200.0n 0.4381 4799.5n 0.4381 4800.0n 0.4422 5399.5n 0.4422 5400.0n 0.4424 5999.5n 0.4424 6000.0n 0.4439 6599.5n 0.4439 6600.0n 0.4408 7199.5n 0.4408 7200.0n 0.4470 7799.5n 0.4470 7800.0n 0.4477 8399.5n 0.4477 8400.0n 0.4371 8999.5n 0.4371 9000.0n 0.4423 9599.5n 0.4423 9600.0n 0.4445 10199.5n 0.4445 10200.0n 0.4471 10799.5n 0.4471 10800.0n 0.4413 11399.5n 0.4413 11400.0n 0.4417 11999.5n 0.4417 12000.0n 0.4357 12599.5n 0.4357 12600.0n 0.4449 13199.5n 0.4449 13200.0n 0.4393 13799.5n 0.4393 13800.0n 0.4431 14399.5n 0.4431 14400.0n 0.4418 14999.5n 0.4418 15000.0n 0.4477 15599.5n 0.4477 15600.0n 0.4389 16199.5n 0.4389 16200.0n 0.4409 16799.5n 0.4409 16800.0n 0.4370 17399.5n 0.4370 17400.0n 0.4401 17999.5n 0.4401 18000.0n 0.4470 18599.5n 0.4470 18600.0n 0.4543 19199.5n 0.4543 19200.0n 0.4591 19799.5n 0.4591 19800.0n 0.4646 20399.5n 0.4646 20400.0n 0.4563 20999.5n 0.4563 21000.0n 0.4331 21599.5n 0.4331 21600.0n 0.4603 22199.5n 0.4603 22200.0n 0.4551 22799.5n 0.4551 22800.0n 0.4560 23399.5n 0.4560 23400.0n 0.4352 23999.5n 0.4352 24000.0n 0.4696 24599.5n 0.4696 24600.0n 0.4534 25199.5n 0.4534 25200.0n 0.4518 25799.5n 0.4518 25800.0n 0.4449 26399.5n 0.4449 26400.0n 0.4521 26999.5n 0.4521 27000.0n 0.4492 27599.5n 0.4492 27600.0n 0.4525 28199.5n 0.4525 28200.0n 0.4399 28799.5n 0.4399 28800.0n 0.4558 29399.5n 0.4558 29400.0n 0.4317 29999.5n 0.4317 30000.0n 0.4292 30599.5n 0.4292 30600.0n 0.4166 31199.5n 0.4166 31200.0n 0.4242 31799.5n 0.4242 31800.0n 0.4434 32399.5n 0.4434 32400.0n 0.4448 32999.5n 0.4448 33000.0n 0.4633 33599.5n 0.4633 33600.0n 0.4597 34199.5n 0.4597 34200.0n 0.4519 34799.5n 0.4519 34800.0n 0.4249 35399.5n 0.4249 35400.0n 0.4597 35999.5n 0.4597)
Cwp_bh_0 wp_bh_0 0 400p
Cwn_bh_0 wn_bh_0 0 400p
Xu_bh_0 xp_bh_0 xn_bh_0 yp_bh_0 yn_bh_0 wp_bh_0 wn_bh_0 vdd gbn gprod
Vxp_wih_0_1 xp_wih_0_1 0 PWL(0.0n 0.4942 599.5n 0.4942 600.0n 0.5558 1199.5n 0.5558 1200.0n 0.4708 1799.5n 0.4708 1800.0n 0.5235 2399.5n 0.5235 2400.0n 0.5350 2999.5n 0.5350 3000.0n 0.5172 3599.5n 0.5172 3600.0n 0.4702 4199.5n 0.4702 4200.0n 0.4867 4799.5n 0.4867 4800.0n 0.4970 5399.5n 0.4970 5400.0n 0.4986 5999.5n 0.4986 6000.0n 0.4751 6599.5n 0.4751 6600.0n 0.4870 7199.5n 0.4870 7200.0n 0.5502 7799.5n 0.5502 7800.0n 0.5521 8399.5n 0.5521 8400.0n 0.4638 8999.5n 0.4638 9000.0n 0.4982 9599.5n 0.4982 9600.0n 0.5131 10199.5n 0.5131 10200.0n 0.5386 10799.5n 0.5386 10800.0n 0.4592 11399.5n 0.4592 11400.0n 0.4950 11999.5n 0.4950 12000.0n 0.4559 12599.5n 0.4559 12600.0n 0.5162 13199.5n 0.5162 13200.0n 0.5038 13799.5n 0.5038 13800.0n 0.5333 14399.5n 0.5333 14400.0n 0.4991 14999.5n 0.4991 15000.0n 0.5298 15599.5n 0.5298 15600.0n 0.4823 16199.5n 0.4823 16200.0n 0.5239 16799.5n 0.5239 16800.0n 0.4592 17399.5n 0.4592 17400.0n 0.5094 17999.5n 0.5094 18000.0n 0.4337 18599.5n 0.4337 18600.0n 0.5977 19199.5n 0.5977 19200.0n 0.5364 19799.5n 0.5364 19800.0n 0.6122 20399.5n 0.6122 20400.0n 0.4856 20999.5n 0.4856 21000.0n 0.3861 21599.5n 0.3861 21600.0n 0.6094 22199.5n 0.6094 22200.0n 0.6364 22799.5n 0.6364 22800.0n 0.4807 23399.5n 0.4807 23400.0n 0.5614 23999.5n 0.5614 24000.0n 0.5913 24599.5n 0.5913 24600.0n 0.6295 25199.5n 0.6295 25200.0n 0.4496 25799.5n 0.4496 25800.0n 0.3792 26399.5n 0.3792 26400.0n 0.4434 26999.5n 0.4434 27000.0n 0.4340 27599.5n 0.4340 27600.0n 0.4461 28199.5n 0.4461 28200.0n 0.5791 28799.5n 0.5791 28800.0n 0.4777 29399.5n 0.4777 29400.0n 0.3878 29999.5n 0.3878 30000.0n 0.3832 30599.5n 0.3832 30600.0n 0.4022 31199.5n 0.4022 31200.0n 0.4482 31799.5n 0.4482 31800.0n 0.3662 32399.5n 0.3662 32400.0n 0.3857 32999.5n 0.3857 33000.0n 0.5584 33599.5n 0.5584 33600.0n 0.5284 34199.5n 0.5284 34200.0n 0.6034 34799.5n 0.6034 34800.0n 0.3469 35399.5n 0.3469 35400.0n 0.5290 35999.5n 0.5290)
Vxn_wih_0_1 xn_wih_0_1 0 PWL(0.0n 0.5058 599.5n 0.5058 600.0n 0.4442 1199.5n 0.4442 1200.0n 0.5292 1799.5n 0.5292 1800.0n 0.4765 2399.5n 0.4765 2400.0n 0.4650 2999.5n 0.4650 3000.0n 0.4828 3599.5n 0.4828 3600.0n 0.5298 4199.5n 0.5298 4200.0n 0.5133 4799.5n 0.5133 4800.0n 0.5030 5399.5n 0.5030 5400.0n 0.5014 5999.5n 0.5014 6000.0n 0.5249 6599.5n 0.5249 6600.0n 0.5130 7199.5n 0.5130 7200.0n 0.4498 7799.5n 0.4498 7800.0n 0.4479 8399.5n 0.4479 8400.0n 0.5362 8999.5n 0.5362 9000.0n 0.5018 9599.5n 0.5018 9600.0n 0.4869 10199.5n 0.4869 10200.0n 0.4614 10799.5n 0.4614 10800.0n 0.5408 11399.5n 0.5408 11400.0n 0.5050 11999.5n 0.5050 12000.0n 0.5441 12599.5n 0.5441 12600.0n 0.4838 13199.5n 0.4838 13200.0n 0.4962 13799.5n 0.4962 13800.0n 0.4667 14399.5n 0.4667 14400.0n 0.5009 14999.5n 0.5009 15000.0n 0.4702 15599.5n 0.4702 15600.0n 0.5177 16199.5n 0.5177 16200.0n 0.4761 16799.5n 0.4761 16800.0n 0.5408 17399.5n 0.5408 17400.0n 0.4906 17999.5n 0.4906 18000.0n 0.5663 18599.5n 0.5663 18600.0n 0.4023 19199.5n 0.4023 19200.0n 0.4636 19799.5n 0.4636 19800.0n 0.3878 20399.5n 0.3878 20400.0n 0.5144 20999.5n 0.5144 21000.0n 0.6139 21599.5n 0.6139 21600.0n 0.3906 22199.5n 0.3906 22200.0n 0.3636 22799.5n 0.3636 22800.0n 0.5193 23399.5n 0.5193 23400.0n 0.4386 23999.5n 0.4386 24000.0n 0.4087 24599.5n 0.4087 24600.0n 0.3705 25199.5n 0.3705 25200.0n 0.5504 25799.5n 0.5504 25800.0n 0.6208 26399.5n 0.6208 26400.0n 0.5566 26999.5n 0.5566 27000.0n 0.5660 27599.5n 0.5660 27600.0n 0.5539 28199.5n 0.5539 28200.0n 0.4209 28799.5n 0.4209 28800.0n 0.5223 29399.5n 0.5223 29400.0n 0.6122 29999.5n 0.6122 30000.0n 0.6168 30599.5n 0.6168 30600.0n 0.5978 31199.5n 0.5978 31200.0n 0.5518 31799.5n 0.5518 31800.0n 0.6338 32399.5n 0.6338 32400.0n 0.6143 32999.5n 0.6143 33000.0n 0.4416 33599.5n 0.4416 33600.0n 0.4716 34199.5n 0.4716 34200.0n 0.3966 34799.5n 0.3966 34800.0n 0.6531 35399.5n 0.6531 35400.0n 0.4710 35999.5n 0.4710)
Vyp_wih_0_1 yp_wih_0_1 0 PWL(0.0n 0.6060 599.5n 0.6060 600.0n 0.6087 1199.5n 0.6087 1200.0n 0.6511 1799.5n 0.6511 1800.0n 0.6603 2399.5n 0.6603 2400.0n 0.6549 2999.5n 0.6549 3000.0n 0.6301 3599.5n 0.6301 3600.0n 0.6459 4199.5n 0.6459 4200.0n 0.6058 4799.5n 0.6058 4800.0n 0.6367 5399.5n 0.6367 5400.0n 0.6371 5999.5n 0.6371 6000.0n 0.6537 6599.5n 0.6537 6600.0n 0.6311 7199.5n 0.6311 7200.0n 0.6244 7799.5n 0.6244 7800.0n 0.6279 8399.5n 0.6279 8400.0n 0.6193 8999.5n 0.6193 9000.0n 0.6365 9599.5n 0.6365 9600.0n 0.6428 10199.5n 0.6428 10200.0n 0.6416 10799.5n 0.6416 10800.0n 0.6514 11399.5n 0.6514 11400.0n 0.6332 11999.5n 0.6332 12000.0n 0.6158 12599.5n 0.6158 12600.0n 0.6437 13199.5n 0.6437 13200.0n 0.6029 13799.5n 0.6029 13800.0n 0.6123 14399.5n 0.6123 14400.0n 0.6306 14999.5n 0.6306 15000.0n 0.6493 15599.5n 0.6493 15600.0n 0.6170 16199.5n 0.6170 16200.0n 0.5998 16799.5n 0.5998 16800.0n 0.6229 17399.5n 0.6229 17400.0n 0.6061 17999.5n 0.6061 18000.0n 0.6725 18599.5n 0.6725 18600.0n 0.5917 19199.5n 0.5917 19200.0n 0.6698 19799.5n 0.6698 19800.0n 0.6592 20399.5n 0.6592 20400.0n 0.6726 20999.5n 0.6726 21000.0n 0.6634 21599.5n 0.6634 21600.0n 0.6441 22199.5n 0.6441 22200.0n 0.5958 22799.5n 0.5958 22800.0n 0.6762 23399.5n 0.6762 23400.0n 0.4882 23999.5n 0.4882 24000.0n 0.6681 24599.5n 0.6681 24600.0n 0.5774 25199.5n 0.5774 25200.0n 0.6736 25799.5n 0.6736 25800.0n 0.6799 26399.5n 0.6799 26400.0n 0.6779 26999.5n 0.6779 27000.0n 0.6751 27599.5n 0.6751 27600.0n 0.6777 28199.5n 0.6777 28200.0n 0.4928 28799.5n 0.4928 28800.0n 0.6746 29399.5n 0.6746 29400.0n 0.6603 29999.5n 0.6603 30000.0n 0.6536 30599.5n 0.6536 30600.0n 0.5459 31199.5n 0.5459 31200.0n 0.5320 31799.5n 0.5320 31800.0n 0.6781 32399.5n 0.6781 32400.0n 0.6803 32999.5n 0.6803 33000.0n 0.6705 33599.5n 0.6705 33600.0n 0.6738 34199.5n 0.6738 34200.0n 0.5593 34799.5n 0.5593 34800.0n 0.6231 35399.5n 0.6231 35400.0n 0.6714 35999.5n 0.6714)
Vyn_wih_0_1 yn_wih_0_1 0 PWL(0.0n 0.3940 599.5n 0.3940 600.0n 0.3913 1199.5n 0.3913 1200.0n 0.3489 1799.5n 0.3489 1800.0n 0.3397 2399.5n 0.3397 2400.0n 0.3451 2999.5n 0.3451 3000.0n 0.3699 3599.5n 0.3699 3600.0n 0.3541 4199.5n 0.3541 4200.0n 0.3942 4799.5n 0.3942 4800.0n 0.3633 5399.5n 0.3633 5400.0n 0.3629 5999.5n 0.3629 6000.0n 0.3463 6599.5n 0.3463 6600.0n 0.3689 7199.5n 0.3689 7200.0n 0.3756 7799.5n 0.3756 7800.0n 0.3721 8399.5n 0.3721 8400.0n 0.3807 8999.5n 0.3807 9000.0n 0.3635 9599.5n 0.3635 9600.0n 0.3572 10199.5n 0.3572 10200.0n 0.3584 10799.5n 0.3584 10800.0n 0.3486 11399.5n 0.3486 11400.0n 0.3668 11999.5n 0.3668 12000.0n 0.3842 12599.5n 0.3842 12600.0n 0.3563 13199.5n 0.3563 13200.0n 0.3971 13799.5n 0.3971 13800.0n 0.3877 14399.5n 0.3877 14400.0n 0.3694 14999.5n 0.3694 15000.0n 0.3507 15599.5n 0.3507 15600.0n 0.3830 16199.5n 0.3830 16200.0n 0.4002 16799.5n 0.4002 16800.0n 0.3771 17399.5n 0.3771 17400.0n 0.3939 17999.5n 0.3939 18000.0n 0.3275 18599.5n 0.3275 18600.0n 0.4083 19199.5n 0.4083 19200.0n 0.3302 19799.5n 0.3302 19800.0n 0.3408 20399.5n 0.3408 20400.0n 0.3274 20999.5n 0.3274 21000.0n 0.3366 21599.5n 0.3366 21600.0n 0.3559 22199.5n 0.3559 22200.0n 0.4042 22799.5n 0.4042 22800.0n 0.3238 23399.5n 0.3238 23400.0n 0.5118 23999.5n 0.5118 24000.0n 0.3319 24599.5n 0.3319 24600.0n 0.4226 25199.5n 0.4226 25200.0n 0.3264 25799.5n 0.3264 25800.0n 0.3201 26399.5n 0.3201 26400.0n 0.3221 26999.5n 0.3221 27000.0n 0.3249 27599.5n 0.3249 27600.0n 0.3223 28199.5n 0.3223 28200.0n 0.5072 28799.5n 0.5072 28800.0n 0.3254 29399.5n 0.3254 29400.0n 0.3397 29999.5n 0.3397 30000.0n 0.3464 30599.5n 0.3464 30600.0n 0.4541 31199.5n 0.4541 31200.0n 0.4680 31799.5n 0.4680 31800.0n 0.3219 32399.5n 0.3219 32400.0n 0.3197 32999.5n 0.3197 33000.0n 0.3295 33599.5n 0.3295 33600.0n 0.3262 34199.5n 0.3262 34200.0n 0.4407 34799.5n 0.4407 34800.0n 0.3769 35399.5n 0.3769 35400.0n 0.3286 35999.5n 0.3286)
Cwp_wih_0_1 wp_wih_0_1 0 400p
Cwn_wih_0_1 wn_wih_0_1 0 400p
Xu_wih_0_1 xp_wih_0_1 xn_wih_0_1 yp_wih_0_1 yn_wih_0_1 wp_wih_0_1 wn_wih_0_1 vdd gbn gprod
Vxp_wih_1_1 xp_wih_1_1 0 PWL(0.0n 0.5370 599.5n 0.5370 600.0n 0.5167 1199.5n 0.5167 1200.0n 0.4793 1799.5n 0.4793 1800.0n 0.4441 2399.5n 0.4441 2400.0n 0.4555 2999.5n 0.4555 3000.0n 0.5055 3599.5n 0.5055 3600.0n 0.4939 4199.5n 0.4939 4200.0n 0.5385 4799.5n 0.5385 4800.0n 0.5024 5399.5n 0.5024 5400.0n 0.5015 5999.5n 0.5015 6000.0n 0.4700 6599.5n 0.4700 6600.0n 0.5120 7199.5n 0.5120 7200.0n 0.5006 7799.5n 0.5006 7800.0n 0.4950 8399.5n 0.4950 8400.0n 0.5309 8999.5n 0.5309 9000.0n 0.5023 9599.5n 0.5023 9600.0n 0.4893 10199.5n 0.4893 10200.0n 0.4837 10799.5n 0.4837 10800.0n 0.4823 11399.5n 0.4823 11400.0n 0.5074 11999.5n 0.5074 12000.0n 0.5364 12599.5n 0.5364 12600.0n 0.4868 13199.5n 0.4868 13200.0n 0.5380 13799.5n 0.5380 13800.0n 0.5220 14399.5n 0.5220 14400.0n 0.5095 14999.5n 0.5095 15000.0n 0.4705 15599.5n 0.4705 15600.0n 0.5289 16199.5n 0.5289 16200.0n 0.5368 16799.5n 0.5368 16800.0n 0.5287 17399.5n 0.5287 17400.0n 0.5342 17999.5n 0.5342 18000.0n 0.4253 18599.5n 0.4253 18600.0n 0.5119 19199.5n 0.5119 19200.0n 0.4104 19799.5n 0.4104 19800.0n 0.4314 20399.5n 0.4314 20400.0n 0.4005 20999.5n 0.4005 21000.0n 0.4696 21599.5n 0.4696 21600.0n 0.4531 22199.5n 0.4531 22200.0n 0.5039 22799.5n 0.5039 22800.0n 0.3608 23399.5n 0.3608 23400.0n 0.6273 23999.5n 0.6273 24000.0n 0.3928 24599.5n 0.3928 24600.0n 0.5253 25199.5n 0.5253 25200.0n 0.4107 25799.5n 0.4107 25800.0n 0.3947 26399.5n 0.3947 26400.0n 0.3716 26999.5n 0.3716 27000.0n 0.4111 27599.5n 0.4111 27600.0n 0.3715 28199.5n 0.3715 28200.0n 0.5939 28799.5n 0.5939 28800.0n 0.3849 29399.5n 0.3849 29400.0n 0.4835 29999.5n 0.4835 30000.0n 0.5119 30599.5n 0.5119 30600.0n 0.6226 31199.5n 0.6226 31200.0n 0.6064 31799.5n 0.6064 31800.0n 0.4115 32399.5n 0.4115 32400.0n 0.3900 32999.5n 0.3900 33000.0n 0.3958 33599.5n 0.3958 33600.0n 0.3747 34199.5n 0.3747 34200.0n 0.5423 34799.5n 0.5423 34800.0n 0.5509 35399.5n 0.5509 35400.0n 0.3990 35999.5n 0.3990)
Vxn_wih_1_1 xn_wih_1_1 0 PWL(0.0n 0.4630 599.5n 0.4630 600.0n 0.4833 1199.5n 0.4833 1200.0n 0.5207 1799.5n 0.5207 1800.0n 0.5559 2399.5n 0.5559 2400.0n 0.5445 2999.5n 0.5445 3000.0n 0.4945 3599.5n 0.4945 3600.0n 0.5061 4199.5n 0.5061 4200.0n 0.4615 4799.5n 0.4615 4800.0n 0.4976 5399.5n 0.4976 5400.0n 0.4985 5999.5n 0.4985 6000.0n 0.5300 6599.5n 0.5300 6600.0n 0.4880 7199.5n 0.4880 7200.0n 0.4994 7799.5n 0.4994 7800.0n 0.5050 8399.5n 0.5050 8400.0n 0.4691 8999.5n 0.4691 9000.0n 0.4977 9599.5n 0.4977 9600.0n 0.5107 10199.5n 0.5107 10200.0n 0.5163 10799.5n 0.5163 10800.0n 0.5177 11399.5n 0.5177 11400.0n 0.4926 11999.5n 0.4926 12000.0n 0.4636 12599.5n 0.4636 12600.0n 0.5132 13199.5n 0.5132 13200.0n 0.4620 13799.5n 0.4620 13800.0n 0.4780 14399.5n 0.4780 14400.0n 0.4905 14999.5n 0.4905 15000.0n 0.5295 15599.5n 0.5295 15600.0n 0.4711 16199.5n 0.4711 16200.0n 0.4632 16799.5n 0.4632 16800.0n 0.4713 17399.5n 0.4713 17400.0n 0.4658 17999.5n 0.4658 18000.0n 0.5747 18599.5n 0.5747 18600.0n 0.4881 19199.5n 0.4881 19200.0n 0.5896 19799.5n 0.5896 19800.0n 0.5686 20399.5n 0.5686 20400.0n 0.5995 20999.5n 0.5995 21000.0n 0.5304 21599.5n 0.5304 21600.0n 0.5469 22199.5n 0.5469 22200.0n 0.4961 22799.5n 0.4961 22800.0n 0.6392 23399.5n 0.6392 23400.0n 0.3727 23999.5n 0.3727 24000.0n 0.6072 24599.5n 0.6072 24600.0n 0.4747 25199.5n 0.4747 25200.0n 0.5893 25799.5n 0.5893 25800.0n 0.6053 26399.5n 0.6053 26400.0n 0.6284 26999.5n 0.6284 27000.0n 0.5889 27599.5n 0.5889 27600.0n 0.6285 28199.5n 0.6285 28200.0n 0.4061 28799.5n 0.4061 28800.0n 0.6151 29399.5n 0.6151 29400.0n 0.5165 29999.5n 0.5165 30000.0n 0.4881 30599.5n 0.4881 30600.0n 0.3774 31199.5n 0.3774 31200.0n 0.3936 31799.5n 0.3936 31800.0n 0.5885 32399.5n 0.5885 32400.0n 0.6100 32999.5n 0.6100 33000.0n 0.6042 33599.5n 0.6042 33600.0n 0.6253 34199.5n 0.6253 34200.0n 0.4577 34799.5n 0.4577 34800.0n 0.4491 35399.5n 0.4491 35400.0n 0.6010 35999.5n 0.6010)
Vyp_wih_1_1 yp_wih_1_1 0 PWL(0.0n 0.6060 599.5n 0.6060 600.0n 0.6087 1199.5n 0.6087 1200.0n 0.6511 1799.5n 0.6511 1800.0n 0.6603 2399.5n 0.6603 2400.0n 0.6549 2999.5n 0.6549 3000.0n 0.6301 3599.5n 0.6301 3600.0n 0.6459 4199.5n 0.6459 4200.0n 0.6058 4799.5n 0.6058 4800.0n 0.6367 5399.5n 0.6367 5400.0n 0.6371 5999.5n 0.6371 6000.0n 0.6537 6599.5n 0.6537 6600.0n 0.6311 7199.5n 0.6311 7200.0n 0.6244 7799.5n 0.6244 7800.0n 0.6279 8399.5n 0.6279 8400.0n 0.6193 8999.5n 0.6193 9000.0n 0.6365 9599.5n 0.6365 9600.0n 0.6428 10199.5n 0.6428 10200.0n 0.6416 10799.5n 0.6416 10800.0n 0.6514 11399.5n 0.6514 11400.0n 0.6332 11999.5n 0.6332 12000.0n 0.6158 12599.5n 0.6158 12600.0n 0.6437 13199.5n 0.6437 13200.0n 0.6029 13799.5n 0.6029 13800.0n 0.6123 14399.5n 0.6123 14400.0n 0.6306 14999.5n 0.6306 15000.0n 0.6493 15599.5n 0.6493 15600.0n 0.6170 16199.5n 0.6170 16200.0n 0.5998 16799.5n 0.5998 16800.0n 0.6229 17399.5n 0.6229 17400.0n 0.6061 17999.5n 0.6061 18000.0n 0.6725 18599.5n 0.6725 18600.0n 0.5917 19199.5n 0.5917 19200.0n 0.6698 19799.5n 0.6698 19800.0n 0.6592 20399.5n 0.6592 20400.0n 0.6726 20999.5n 0.6726 21000.0n 0.6634 21599.5n 0.6634 21600.0n 0.6441 22199.5n 0.6441 22200.0n 0.5958 22799.5n 0.5958 22800.0n 0.6762 23399.5n 0.6762 23400.0n 0.4882 23999.5n 0.4882 24000.0n 0.6681 24599.5n 0.6681 24600.0n 0.5774 25199.5n 0.5774 25200.0n 0.6736 25799.5n 0.6736 25800.0n 0.6799 26399.5n 0.6799 26400.0n 0.6779 26999.5n 0.6779 27000.0n 0.6751 27599.5n 0.6751 27600.0n 0.6777 28199.5n 0.6777 28200.0n 0.4928 28799.5n 0.4928 28800.0n 0.6746 29399.5n 0.6746 29400.0n 0.6603 29999.5n 0.6603 30000.0n 0.6536 30599.5n 0.6536 30600.0n 0.5459 31199.5n 0.5459 31200.0n 0.5320 31799.5n 0.5320 31800.0n 0.6781 32399.5n 0.6781 32400.0n 0.6803 32999.5n 0.6803 33000.0n 0.6705 33599.5n 0.6705 33600.0n 0.6738 34199.5n 0.6738 34200.0n 0.5593 34799.5n 0.5593 34800.0n 0.6231 35399.5n 0.6231 35400.0n 0.6714 35999.5n 0.6714)
Vyn_wih_1_1 yn_wih_1_1 0 PWL(0.0n 0.3940 599.5n 0.3940 600.0n 0.3913 1199.5n 0.3913 1200.0n 0.3489 1799.5n 0.3489 1800.0n 0.3397 2399.5n 0.3397 2400.0n 0.3451 2999.5n 0.3451 3000.0n 0.3699 3599.5n 0.3699 3600.0n 0.3541 4199.5n 0.3541 4200.0n 0.3942 4799.5n 0.3942 4800.0n 0.3633 5399.5n 0.3633 5400.0n 0.3629 5999.5n 0.3629 6000.0n 0.3463 6599.5n 0.3463 6600.0n 0.3689 7199.5n 0.3689 7200.0n 0.3756 7799.5n 0.3756 7800.0n 0.3721 8399.5n 0.3721 8400.0n 0.3807 8999.5n 0.3807 9000.0n 0.3635 9599.5n 0.3635 9600.0n 0.3572 10199.5n 0.3572 10200.0n 0.3584 10799.5n 0.3584 10800.0n 0.3486 11399.5n 0.3486 11400.0n 0.3668 11999.5n 0.3668 12000.0n 0.3842 12599.5n 0.3842 12600.0n 0.3563 13199.5n 0.3563 13200.0n 0.3971 13799.5n 0.3971 13800.0n 0.3877 14399.5n 0.3877 14400.0n 0.3694 14999.5n 0.3694 15000.0n 0.3507 15599.5n 0.3507 15600.0n 0.3830 16199.5n 0.3830 16200.0n 0.4002 16799.5n 0.4002 16800.0n 0.3771 17399.5n 0.3771 17400.0n 0.3939 17999.5n 0.3939 18000.0n 0.3275 18599.5n 0.3275 18600.0n 0.4083 19199.5n 0.4083 19200.0n 0.3302 19799.5n 0.3302 19800.0n 0.3408 20399.5n 0.3408 20400.0n 0.3274 20999.5n 0.3274 21000.0n 0.3366 21599.5n 0.3366 21600.0n 0.3559 22199.5n 0.3559 22200.0n 0.4042 22799.5n 0.4042 22800.0n 0.3238 23399.5n 0.3238 23400.0n 0.5118 23999.5n 0.5118 24000.0n 0.3319 24599.5n 0.3319 24600.0n 0.4226 25199.5n 0.4226 25200.0n 0.3264 25799.5n 0.3264 25800.0n 0.3201 26399.5n 0.3201 26400.0n 0.3221 26999.5n 0.3221 27000.0n 0.3249 27599.5n 0.3249 27600.0n 0.3223 28199.5n 0.3223 28200.0n 0.5072 28799.5n 0.5072 28800.0n 0.3254 29399.5n 0.3254 29400.0n 0.3397 29999.5n 0.3397 30000.0n 0.3464 30599.5n 0.3464 30600.0n 0.4541 31199.5n 0.4541 31200.0n 0.4680 31799.5n 0.4680 31800.0n 0.3219 32399.5n 0.3219 32400.0n 0.3197 32999.5n 0.3197 33000.0n 0.3295 33599.5n 0.3295 33600.0n 0.3262 34199.5n 0.3262 34200.0n 0.4407 34799.5n 0.4407 34800.0n 0.3769 35399.5n 0.3769 35400.0n 0.3286 35999.5n 0.3286)
Cwp_wih_1_1 wp_wih_1_1 0 400p
Cwn_wih_1_1 wn_wih_1_1 0 400p
Xu_wih_1_1 xp_wih_1_1 xn_wih_1_1 yp_wih_1_1 yn_wih_1_1 wp_wih_1_1 wn_wih_1_1 vdd gbn gprod
Vxp_who_1_0 xp_who_1_0 0 PWL(0.0n 0.6060 599.5n 0.6060 600.0n 0.6087 1199.5n 0.6087 1200.0n 0.6511 1799.5n 0.6511 1800.0n 0.6603 2399.5n 0.6603 2400.0n 0.6549 2999.5n 0.6549 3000.0n 0.6301 3599.5n 0.6301 3600.0n 0.6459 4199.5n 0.6459 4200.0n 0.6058 4799.5n 0.6058 4800.0n 0.6367 5399.5n 0.6367 5400.0n 0.6371 5999.5n 0.6371 6000.0n 0.6537 6599.5n 0.6537 6600.0n 0.6311 7199.5n 0.6311 7200.0n 0.6244 7799.5n 0.6244 7800.0n 0.6279 8399.5n 0.6279 8400.0n 0.6193 8999.5n 0.6193 9000.0n 0.6365 9599.5n 0.6365 9600.0n 0.6428 10199.5n 0.6428 10200.0n 0.6416 10799.5n 0.6416 10800.0n 0.6514 11399.5n 0.6514 11400.0n 0.6332 11999.5n 0.6332 12000.0n 0.6158 12599.5n 0.6158 12600.0n 0.6437 13199.5n 0.6437 13200.0n 0.6029 13799.5n 0.6029 13800.0n 0.6123 14399.5n 0.6123 14400.0n 0.6306 14999.5n 0.6306 15000.0n 0.6493 15599.5n 0.6493 15600.0n 0.6170 16199.5n 0.6170 16200.0n 0.5998 16799.5n 0.5998 16800.0n 0.6229 17399.5n 0.6229 17400.0n 0.6061 17999.5n 0.6061 18000.0n 0.6725 18599.5n 0.6725 18600.0n 0.5917 19199.5n 0.5917 19200.0n 0.6698 19799.5n 0.6698 19800.0n 0.6592 20399.5n 0.6592 20400.0n 0.6726 20999.5n 0.6726 21000.0n 0.6634 21599.5n 0.6634 21600.0n 0.6441 22199.5n 0.6441 22200.0n 0.5958 22799.5n 0.5958 22800.0n 0.6762 23399.5n 0.6762 23400.0n 0.4882 23999.5n 0.4882 24000.0n 0.6681 24599.5n 0.6681 24600.0n 0.5774 25199.5n 0.5774 25200.0n 0.6736 25799.5n 0.6736 25800.0n 0.6799 26399.5n 0.6799 26400.0n 0.6779 26999.5n 0.6779 27000.0n 0.6751 27599.5n 0.6751 27600.0n 0.6777 28199.5n 0.6777 28200.0n 0.4928 28799.5n 0.4928 28800.0n 0.6746 29399.5n 0.6746 29400.0n 0.6603 29999.5n 0.6603 30000.0n 0.6536 30599.5n 0.6536 30600.0n 0.5459 31199.5n 0.5459 31200.0n 0.5320 31799.5n 0.5320 31800.0n 0.6781 32399.5n 0.6781 32400.0n 0.6803 32999.5n 0.6803 33000.0n 0.6705 33599.5n 0.6705 33600.0n 0.6738 34199.5n 0.6738 34200.0n 0.5593 34799.5n 0.5593 34800.0n 0.6231 35399.5n 0.6231 35400.0n 0.6714 35999.5n 0.6714)
Vxn_who_1_0 xn_who_1_0 0 PWL(0.0n 0.3940 599.5n 0.3940 600.0n 0.3913 1199.5n 0.3913 1200.0n 0.3489 1799.5n 0.3489 1800.0n 0.3397 2399.5n 0.3397 2400.0n 0.3451 2999.5n 0.3451 3000.0n 0.3699 3599.5n 0.3699 3600.0n 0.3541 4199.5n 0.3541 4200.0n 0.3942 4799.5n 0.3942 4800.0n 0.3633 5399.5n 0.3633 5400.0n 0.3629 5999.5n 0.3629 6000.0n 0.3463 6599.5n 0.3463 6600.0n 0.3689 7199.5n 0.3689 7200.0n 0.3756 7799.5n 0.3756 7800.0n 0.3721 8399.5n 0.3721 8400.0n 0.3807 8999.5n 0.3807 9000.0n 0.3635 9599.5n 0.3635 9600.0n 0.3572 10199.5n 0.3572 10200.0n 0.3584 10799.5n 0.3584 10800.0n 0.3486 11399.5n 0.3486 11400.0n 0.3668 11999.5n 0.3668 12000.0n 0.3842 12599.5n 0.3842 12600.0n 0.3563 13199.5n 0.3563 13200.0n 0.3971 13799.5n 0.3971 13800.0n 0.3877 14399.5n 0.3877 14400.0n 0.3694 14999.5n 0.3694 15000.0n 0.3507 15599.5n 0.3507 15600.0n 0.3830 16199.5n 0.3830 16200.0n 0.4002 16799.5n 0.4002 16800.0n 0.3771 17399.5n 0.3771 17400.0n 0.3939 17999.5n 0.3939 18000.0n 0.3275 18599.5n 0.3275 18600.0n 0.4083 19199.5n 0.4083 19200.0n 0.3302 19799.5n 0.3302 19800.0n 0.3408 20399.5n 0.3408 20400.0n 0.3274 20999.5n 0.3274 21000.0n 0.3366 21599.5n 0.3366 21600.0n 0.3559 22199.5n 0.3559 22200.0n 0.4042 22799.5n 0.4042 22800.0n 0.3238 23399.5n 0.3238 23400.0n 0.5118 23999.5n 0.5118 24000.0n 0.3319 24599.5n 0.3319 24600.0n 0.4226 25199.5n 0.4226 25200.0n 0.3264 25799.5n 0.3264 25800.0n 0.3201 26399.5n 0.3201 26400.0n 0.3221 26999.5n 0.3221 27000.0n 0.3249 27599.5n 0.3249 27600.0n 0.3223 28199.5n 0.3223 28200.0n 0.5072 28799.5n 0.5072 28800.0n 0.3254 29399.5n 0.3254 29400.0n 0.3397 29999.5n 0.3397 30000.0n 0.3464 30599.5n 0.3464 30600.0n 0.4541 31199.5n 0.4541 31200.0n 0.4680 31799.5n 0.4680 31800.0n 0.3219 32399.5n 0.3219 32400.0n 0.3197 32999.5n 0.3197 33000.0n 0.3295 33599.5n 0.3295 33600.0n 0.3262 34199.5n 0.3262 34200.0n 0.4407 34799.5n 0.4407 34800.0n 0.3769 35399.5n 0.3769 35400.0n 0.3286 35999.5n 0.3286)
Vyp_who_1_0 yp_who_1_0 0 PWL(0.0n 0.5031 599.5n 0.5031 600.0n 0.5023 1199.5n 0.5023 1200.0n 0.5052 1799.5n 0.5052 1800.0n 0.5048 2399.5n 0.5048 2400.0n 0.5043 2999.5n 0.5043 3000.0n 0.5034 3599.5n 0.5034 3600.0n 0.5048 4199.5n 0.5048 4200.0n 0.5031 4799.5n 0.5031 4800.0n 0.5040 5399.5n 0.5040 5400.0n 0.5040 5999.5n 0.5040 6000.0n 0.5054 6599.5n 0.5054 6600.0n 0.5040 7199.5n 0.5040 7200.0n 0.5027 7799.5n 0.5027 7800.0n 0.5027 8399.5n 0.5027 8400.0n 0.5038 8999.5n 0.5038 9000.0n 0.5040 9599.5n 0.5040 9600.0n 0.5039 10199.5n 0.5039 10200.0n 0.5033 10799.5n 0.5033 10800.0n 0.5056 11399.5n 0.5056 11400.0n 0.5040 11999.5n 0.5040 12000.0n 0.5036 12599.5n 0.5036 12600.0n 0.5039 13199.5n 0.5039 13200.0n 0.5029 13799.5n 0.5029 13800.0n 0.5025 14399.5n 0.5025 14400.0n 0.5038 14999.5n 0.5038 15000.0n 0.5041 15599.5n 0.5041 15600.0n 0.5036 16199.5n 0.5036 16200.0n 0.5025 16799.5n 0.5025 16800.0n 0.5040 17399.5n 0.5040 17400.0n 0.5029 17999.5n 0.5029 18000.0n 0.5057 18599.5n 0.5057 18600.0n 0.5010 19199.5n 0.5010 19200.0n 0.5041 19799.5n 0.5041 19800.0n 0.5021 20399.5n 0.5021 20400.0n 0.5044 20999.5n 0.5044 21000.0n 0.5056 21599.5n 0.5056 21600.0n 0.5016 22199.5n 0.5016 22200.0n 0.5006 22799.5n 0.5006 22800.0n 0.5041 23399.5n 0.5041 23400.0n 0.5027 23999.5n 0.5027 24000.0n 0.5029 24599.5n 0.5029 24600.0n 0.5006 25199.5n 0.5006 25200.0n 0.5047 25799.5n 0.5047 25800.0n 0.5046 26399.5n 0.5046 26400.0n 0.5039 26999.5n 0.5039 27000.0n 0.5049 27599.5n 0.5049 27600.0n 0.5039 28199.5n 0.5039 28200.0n 0.5017 28799.5n 0.5017 28800.0n 0.5042 29399.5n 0.5042 29400.0n 0.5056 29999.5n 0.5056 30000.0n 0.5051 30599.5n 0.5051 30600.0n 0.5039 31199.5n 0.5039 31200.0n 0.5033 31799.5n 0.5033 31800.0n 0.5049 32399.5n 0.5049 32400.0n 0.5045 32999.5n 0.5045 33000.0n 0.5036 33599.5n 0.5036 33600.0n 0.5042 34199.5n 0.5042 34200.0n 0.5012 34799.5n 0.5012 34800.0n 0.5036 35399.5n 0.5036 35400.0n 0.5042 35999.5n 0.5042)
Vyn_who_1_0 yn_who_1_0 0 PWL(0.0n 0.4969 599.5n 0.4969 600.0n 0.4977 1199.5n 0.4977 1200.0n 0.4948 1799.5n 0.4948 1800.0n 0.4952 2399.5n 0.4952 2400.0n 0.4957 2999.5n 0.4957 3000.0n 0.4966 3599.5n 0.4966 3600.0n 0.4952 4199.5n 0.4952 4200.0n 0.4969 4799.5n 0.4969 4800.0n 0.4960 5399.5n 0.4960 5400.0n 0.4960 5999.5n 0.4960 6000.0n 0.4946 6599.5n 0.4946 6600.0n 0.4960 7199.5n 0.4960 7200.0n 0.4973 7799.5n 0.4973 7800.0n 0.4973 8399.5n 0.4973 8400.0n 0.4962 8999.5n 0.4962 9000.0n 0.4960 9599.5n 0.4960 9600.0n 0.4961 10199.5n 0.4961 10200.0n 0.4967 10799.5n 0.4967 10800.0n 0.4944 11399.5n 0.4944 11400.0n 0.4960 11999.5n 0.4960 12000.0n 0.4964 12599.5n 0.4964 12600.0n 0.4961 13199.5n 0.4961 13200.0n 0.4971 13799.5n 0.4971 13800.0n 0.4975 14399.5n 0.4975 14400.0n 0.4962 14999.5n 0.4962 15000.0n 0.4959 15599.5n 0.4959 15600.0n 0.4964 16199.5n 0.4964 16200.0n 0.4975 16799.5n 0.4975 16800.0n 0.4960 17399.5n 0.4960 17400.0n 0.4971 17999.5n 0.4971 18000.0n 0.4943 18599.5n 0.4943 18600.0n 0.4990 19199.5n 0.4990 19200.0n 0.4959 19799.5n 0.4959 19800.0n 0.4979 20399.5n 0.4979 20400.0n 0.4956 20999.5n 0.4956 21000.0n 0.4944 21599.5n 0.4944 21600.0n 0.4984 22199.5n 0.4984 22200.0n 0.4994 22799.5n 0.4994 22800.0n 0.4959 23399.5n 0.4959 23400.0n 0.4973 23999.5n 0.4973 24000.0n 0.4971 24599.5n 0.4971 24600.0n 0.4994 25199.5n 0.4994 25200.0n 0.4953 25799.5n 0.4953 25800.0n 0.4954 26399.5n 0.4954 26400.0n 0.4961 26999.5n 0.4961 27000.0n 0.4951 27599.5n 0.4951 27600.0n 0.4961 28199.5n 0.4961 28200.0n 0.4983 28799.5n 0.4983 28800.0n 0.4958 29399.5n 0.4958 29400.0n 0.4944 29999.5n 0.4944 30000.0n 0.4949 30599.5n 0.4949 30600.0n 0.4961 31199.5n 0.4961 31200.0n 0.4967 31799.5n 0.4967 31800.0n 0.4951 32399.5n 0.4951 32400.0n 0.4955 32999.5n 0.4955 33000.0n 0.4964 33599.5n 0.4964 33600.0n 0.4958 34199.5n 0.4958 34200.0n 0.4988 34799.5n 0.4988 34800.0n 0.4964 35399.5n 0.4964 35400.0n 0.4958 35999.5n 0.4958)
Cwp_who_1_0 wp_who_1_0 0 400p
Cwn_who_1_0 wn_who_1_0 0 400p
Xu_who_1_0 xp_who_1_0 xn_who_1_0 yp_who_1_0 yn_who_1_0 wp_who_1_0 wn_who_1_0 vdd gbn gprod
Vxp_who_1_1 xp_who_1_1 0 PWL(0.0n 0.6060 599.5n 0.6060 600.0n 0.6087 1199.5n 0.6087 1200.0n 0.6511 1799.5n 0.6511 1800.0n 0.6603 2399.5n 0.6603 2400.0n 0.6549 2999.5n 0.6549 3000.0n 0.6301 3599.5n 0.6301 3600.0n 0.6459 4199.5n 0.6459 4200.0n 0.6058 4799.5n 0.6058 4800.0n 0.6367 5399.5n 0.6367 5400.0n 0.6371 5999.5n 0.6371 6000.0n 0.6537 6599.5n 0.6537 6600.0n 0.6311 7199.5n 0.6311 7200.0n 0.6244 7799.5n 0.6244 7800.0n 0.6279 8399.5n 0.6279 8400.0n 0.6193 8999.5n 0.6193 9000.0n 0.6365 9599.5n 0.6365 9600.0n 0.6428 10199.5n 0.6428 10200.0n 0.6416 10799.5n 0.6416 10800.0n 0.6514 11399.5n 0.6514 11400.0n 0.6332 11999.5n 0.6332 12000.0n 0.6158 12599.5n 0.6158 12600.0n 0.6437 13199.5n 0.6437 13200.0n 0.6029 13799.5n 0.6029 13800.0n 0.6123 14399.5n 0.6123 14400.0n 0.6306 14999.5n 0.6306 15000.0n 0.6493 15599.5n 0.6493 15600.0n 0.6170 16199.5n 0.6170 16200.0n 0.5998 16799.5n 0.5998 16800.0n 0.6229 17399.5n 0.6229 17400.0n 0.6061 17999.5n 0.6061 18000.0n 0.6725 18599.5n 0.6725 18600.0n 0.5917 19199.5n 0.5917 19200.0n 0.6698 19799.5n 0.6698 19800.0n 0.6592 20399.5n 0.6592 20400.0n 0.6726 20999.5n 0.6726 21000.0n 0.6634 21599.5n 0.6634 21600.0n 0.6441 22199.5n 0.6441 22200.0n 0.5958 22799.5n 0.5958 22800.0n 0.6762 23399.5n 0.6762 23400.0n 0.4882 23999.5n 0.4882 24000.0n 0.6681 24599.5n 0.6681 24600.0n 0.5774 25199.5n 0.5774 25200.0n 0.6736 25799.5n 0.6736 25800.0n 0.6799 26399.5n 0.6799 26400.0n 0.6779 26999.5n 0.6779 27000.0n 0.6751 27599.5n 0.6751 27600.0n 0.6777 28199.5n 0.6777 28200.0n 0.4928 28799.5n 0.4928 28800.0n 0.6746 29399.5n 0.6746 29400.0n 0.6603 29999.5n 0.6603 30000.0n 0.6536 30599.5n 0.6536 30600.0n 0.5459 31199.5n 0.5459 31200.0n 0.5320 31799.5n 0.5320 31800.0n 0.6781 32399.5n 0.6781 32400.0n 0.6803 32999.5n 0.6803 33000.0n 0.6705 33599.5n 0.6705 33600.0n 0.6738 34199.5n 0.6738 34200.0n 0.5593 34799.5n 0.5593 34800.0n 0.6231 35399.5n 0.6231 35400.0n 0.6714 35999.5n 0.6714)
Vxn_who_1_1 xn_who_1_1 0 PWL(0.0n 0.3940 599.5n 0.3940 600.0n 0.3913 1199.5n 0.3913 1200.0n 0.3489 1799.5n 0.3489 1800.0n 0.3397 2399.5n 0.3397 2400.0n 0.3451 2999.5n 0.3451 3000.0n 0.3699 3599.5n 0.3699 3600.0n 0.3541 4199.5n 0.3541 4200.0n 0.3942 4799.5n 0.3942 4800.0n 0.3633 5399.5n 0.3633 5400.0n 0.3629 5999.5n 0.3629 6000.0n 0.3463 6599.5n 0.3463 6600.0n 0.3689 7199.5n 0.3689 7200.0n 0.3756 7799.5n 0.3756 7800.0n 0.3721 8399.5n 0.3721 8400.0n 0.3807 8999.5n 0.3807 9000.0n 0.3635 9599.5n 0.3635 9600.0n 0.3572 10199.5n 0.3572 10200.0n 0.3584 10799.5n 0.3584 10800.0n 0.3486 11399.5n 0.3486 11400.0n 0.3668 11999.5n 0.3668 12000.0n 0.3842 12599.5n 0.3842 12600.0n 0.3563 13199.5n 0.3563 13200.0n 0.3971 13799.5n 0.3971 13800.0n 0.3877 14399.5n 0.3877 14400.0n 0.3694 14999.5n 0.3694 15000.0n 0.3507 15599.5n 0.3507 15600.0n 0.3830 16199.5n 0.3830 16200.0n 0.4002 16799.5n 0.4002 16800.0n 0.3771 17399.5n 0.3771 17400.0n 0.3939 17999.5n 0.3939 18000.0n 0.3275 18599.5n 0.3275 18600.0n 0.4083 19199.5n 0.4083 19200.0n 0.3302 19799.5n 0.3302 19800.0n 0.3408 20399.5n 0.3408 20400.0n 0.3274 20999.5n 0.3274 21000.0n 0.3366 21599.5n 0.3366 21600.0n 0.3559 22199.5n 0.3559 22200.0n 0.4042 22799.5n 0.4042 22800.0n 0.3238 23399.5n 0.3238 23400.0n 0.5118 23999.5n 0.5118 24000.0n 0.3319 24599.5n 0.3319 24600.0n 0.4226 25199.5n 0.4226 25200.0n 0.3264 25799.5n 0.3264 25800.0n 0.3201 26399.5n 0.3201 26400.0n 0.3221 26999.5n 0.3221 27000.0n 0.3249 27599.5n 0.3249 27600.0n 0.3223 28199.5n 0.3223 28200.0n 0.5072 28799.5n 0.5072 28800.0n 0.3254 29399.5n 0.3254 29400.0n 0.3397 29999.5n 0.3397 30000.0n 0.3464 30599.5n 0.3464 30600.0n 0.4541 31199.5n 0.4541 31200.0n 0.4680 31799.5n 0.4680 31800.0n 0.3219 32399.5n 0.3219 32400.0n 0.3197 32999.5n 0.3197 33000.0n 0.3295 33599.5n 0.3295 33600.0n 0.3262 34199.5n 0.3262 34200.0n 0.4407 34799.5n 0.4407 34800.0n 0.3769 35399.5n 0.3769 35400.0n 0.3286 35999.5n 0.3286)
Vyp_who_1_1 yp_who_1_1 0 PWL(0.0n 0.5071 599.5n 0.5071 600.0n 0.5053 1199.5n 0.5053 1200.0n 0.5052 1799.5n 0.5052 1800.0n 0.5027 2399.5n 0.5027 2400.0n 0.5034 2999.5n 0.5034 3000.0n 0.5055 3599.5n 0.5055 3600.0n 0.5056 4199.5n 0.5056 4200.0n 0.5071 4799.5n 0.5071 4800.0n 0.5056 5399.5n 0.5056 5400.0n 0.5056 5999.5n 0.5056 6000.0n 0.5048 6599.5n 0.5048 6600.0n 0.5060 7199.5n 0.5060 7200.0n 0.5048 7799.5n 0.5048 7800.0n 0.5046 8399.5n 0.5046 8400.0n 0.5066 8999.5n 0.5066 9000.0n 0.5056 9599.5n 0.5056 9600.0n 0.5051 10199.5n 0.5051 10200.0n 0.5046 10799.5n 0.5046 10800.0n 0.5056 11399.5n 0.5056 11400.0n 0.5058 11999.5n 0.5058 12000.0n 0.5068 12599.5n 0.5068 12600.0n 0.5050 13199.5n 0.5050 13200.0n 0.5071 13799.5n 0.5071 13800.0n 0.5059 14399.5n 0.5059 14400.0n 0.5058 14999.5n 0.5058 15000.0n 0.5043 15599.5n 0.5043 15600.0n 0.5067 16199.5n 0.5067 16200.0n 0.5068 16799.5n 0.5068 16800.0n 0.5066 17399.5n 0.5066 17400.0n 0.5069 17999.5n 0.5069 18000.0n 0.5061 18599.5n 0.5061 18600.0n 0.5034 19199.5n 0.5034 19200.0n 0.5010 19799.5n 0.5010 19800.0n 0.4989 20399.5n 0.4989 20400.0n 0.5022 20999.5n 0.5022 21000.0n 0.5086 21599.5n 0.5086 21600.0n 0.5007 22199.5n 0.5007 22200.0n 0.5023 22799.5n 0.5023 22800.0n 0.5021 23399.5n 0.5021 23400.0n 0.5077 23999.5n 0.5077 24000.0n 0.4979 24599.5n 0.4979 24600.0n 0.5035 25199.5n 0.5035 25200.0n 0.5041 25799.5n 0.5041 25800.0n 0.5075 26399.5n 0.5075 26400.0n 0.5041 26999.5n 0.5041 27000.0n 0.5056 27599.5n 0.5056 27600.0n 0.5039 28199.5n 0.5039 28200.0n 0.5059 28799.5n 0.5059 28800.0n 0.5023 29399.5n 0.5023 29400.0n 0.5086 29999.5n 0.5086 30000.0n 0.5084 30599.5n 0.5084 30600.0n 0.5085 31199.5n 0.5085 31200.0n 0.5088 31799.5n 0.5088 31800.0n 0.5078 32399.5n 0.5078 32400.0n 0.5074 32999.5n 0.5074 33000.0n 0.4996 33599.5n 0.4996 33600.0n 0.5010 34199.5n 0.5010 34200.0n 0.5044 34799.5n 0.5044 34800.0n 0.5084 35399.5n 0.5084 35400.0n 0.5012 35999.5n 0.5012)
Vyn_who_1_1 yn_who_1_1 0 PWL(0.0n 0.4929 599.5n 0.4929 600.0n 0.4947 1199.5n 0.4947 1200.0n 0.4948 1799.5n 0.4948 1800.0n 0.4973 2399.5n 0.4973 2400.0n 0.4966 2999.5n 0.4966 3000.0n 0.4945 3599.5n 0.4945 3600.0n 0.4944 4199.5n 0.4944 4200.0n 0.4929 4799.5n 0.4929 4800.0n 0.4944 5399.5n 0.4944 5400.0n 0.4944 5999.5n 0.4944 6000.0n 0.4952 6599.5n 0.4952 6600.0n 0.4940 7199.5n 0.4940 7200.0n 0.4952 7799.5n 0.4952 7800.0n 0.4954 8399.5n 0.4954 8400.0n 0.4934 8999.5n 0.4934 9000.0n 0.4944 9599.5n 0.4944 9600.0n 0.4949 10199.5n 0.4949 10200.0n 0.4954 10799.5n 0.4954 10800.0n 0.4944 11399.5n 0.4944 11400.0n 0.4942 11999.5n 0.4942 12000.0n 0.4932 12599.5n 0.4932 12600.0n 0.4950 13199.5n 0.4950 13200.0n 0.4929 13799.5n 0.4929 13800.0n 0.4941 14399.5n 0.4941 14400.0n 0.4942 14999.5n 0.4942 15000.0n 0.4957 15599.5n 0.4957 15600.0n 0.4933 16199.5n 0.4933 16200.0n 0.4932 16799.5n 0.4932 16800.0n 0.4934 17399.5n 0.4934 17400.0n 0.4931 17999.5n 0.4931 18000.0n 0.4939 18599.5n 0.4939 18600.0n 0.4966 19199.5n 0.4966 19200.0n 0.4990 19799.5n 0.4990 19800.0n 0.5011 20399.5n 0.5011 20400.0n 0.4978 20999.5n 0.4978 21000.0n 0.4914 21599.5n 0.4914 21600.0n 0.4993 22199.5n 0.4993 22200.0n 0.4977 22799.5n 0.4977 22800.0n 0.4979 23399.5n 0.4979 23400.0n 0.4923 23999.5n 0.4923 24000.0n 0.5021 24599.5n 0.5021 24600.0n 0.4965 25199.5n 0.4965 25200.0n 0.4959 25799.5n 0.4959 25800.0n 0.4925 26399.5n 0.4925 26400.0n 0.4959 26999.5n 0.4959 27000.0n 0.4944 27599.5n 0.4944 27600.0n 0.4961 28199.5n 0.4961 28200.0n 0.4941 28799.5n 0.4941 28800.0n 0.4977 29399.5n 0.4977 29400.0n 0.4914 29999.5n 0.4914 30000.0n 0.4916 30599.5n 0.4916 30600.0n 0.4915 31199.5n 0.4915 31200.0n 0.4912 31799.5n 0.4912 31800.0n 0.4922 32399.5n 0.4922 32400.0n 0.4926 32999.5n 0.4926 33000.0n 0.5004 33599.5n 0.5004 33600.0n 0.4990 34199.5n 0.4990 34200.0n 0.4956 34799.5n 0.4956 34800.0n 0.4916 35399.5n 0.4916 35400.0n 0.4988 35999.5n 0.4988)
Cwp_who_1_1 wp_who_1_1 0 400p
Cwn_who_1_1 wn_who_1_1 0 400p
Xu_who_1_1 xp_who_1_1 xn_who_1_1 yp_who_1_1 yn_who_1_1 wp_who_1_1 wn_who_1_1 vdd gbn gprod
Vxp_bh_1 xp_bh_1 0 PWL(0.0n 0.7100 599.5n 0.7100 600.0n 0.7100 1199.5n 0.7100 1200.0n 0.7100 1799.5n 0.7100 1800.0n 0.7100 2399.5n 0.7100 2400.0n 0.7100 2999.5n 0.7100 3000.0n 0.7100 3599.5n 0.7100 3600.0n 0.7100 4199.5n 0.7100 4200.0n 0.7100 4799.5n 0.7100 4800.0n 0.7100 5399.5n 0.7100 5400.0n 0.7100 5999.5n 0.7100 6000.0n 0.7100 6599.5n 0.7100 6600.0n 0.7100 7199.5n 0.7100 7200.0n 0.7100 7799.5n 0.7100 7800.0n 0.7100 8399.5n 0.7100 8400.0n 0.7100 8999.5n 0.7100 9000.0n 0.7100 9599.5n 0.7100 9600.0n 0.7100 10199.5n 0.7100 10200.0n 0.7100 10799.5n 0.7100 10800.0n 0.7100 11399.5n 0.7100 11400.0n 0.7100 11999.5n 0.7100 12000.0n 0.7100 12599.5n 0.7100 12600.0n 0.7100 13199.5n 0.7100 13200.0n 0.7100 13799.5n 0.7100 13800.0n 0.7100 14399.5n 0.7100 14400.0n 0.7100 14999.5n 0.7100 15000.0n 0.7100 15599.5n 0.7100 15600.0n 0.7100 16199.5n 0.7100 16200.0n 0.7100 16799.5n 0.7100 16800.0n 0.7100 17399.5n 0.7100 17400.0n 0.7100 17999.5n 0.7100 18000.0n 0.7100 18599.5n 0.7100 18600.0n 0.7100 19199.5n 0.7100 19200.0n 0.7100 19799.5n 0.7100 19800.0n 0.7100 20399.5n 0.7100 20400.0n 0.7100 20999.5n 0.7100 21000.0n 0.7100 21599.5n 0.7100 21600.0n 0.7100 22199.5n 0.7100 22200.0n 0.7100 22799.5n 0.7100 22800.0n 0.7100 23399.5n 0.7100 23400.0n 0.7100 23999.5n 0.7100 24000.0n 0.7100 24599.5n 0.7100 24600.0n 0.7100 25199.5n 0.7100 25200.0n 0.7100 25799.5n 0.7100 25800.0n 0.7100 26399.5n 0.7100 26400.0n 0.7100 26999.5n 0.7100 27000.0n 0.7100 27599.5n 0.7100 27600.0n 0.7100 28199.5n 0.7100 28200.0n 0.7100 28799.5n 0.7100 28800.0n 0.7100 29399.5n 0.7100 29400.0n 0.7100 29999.5n 0.7100 30000.0n 0.7100 30599.5n 0.7100 30600.0n 0.7100 31199.5n 0.7100 31200.0n 0.7100 31799.5n 0.7100 31800.0n 0.7100 32399.5n 0.7100 32400.0n 0.7100 32999.5n 0.7100 33000.0n 0.7100 33599.5n 0.7100 33600.0n 0.7100 34199.5n 0.7100 34200.0n 0.7100 34799.5n 0.7100 34800.0n 0.7100 35399.5n 0.7100 35400.0n 0.7100 35999.5n 0.7100)
Vxn_bh_1 xn_bh_1 0 PWL(0.0n 0.2900 599.5n 0.2900 600.0n 0.2900 1199.5n 0.2900 1200.0n 0.2900 1799.5n 0.2900 1800.0n 0.2900 2399.5n 0.2900 2400.0n 0.2900 2999.5n 0.2900 3000.0n 0.2900 3599.5n 0.2900 3600.0n 0.2900 4199.5n 0.2900 4200.0n 0.2900 4799.5n 0.2900 4800.0n 0.2900 5399.5n 0.2900 5400.0n 0.2900 5999.5n 0.2900 6000.0n 0.2900 6599.5n 0.2900 6600.0n 0.2900 7199.5n 0.2900 7200.0n 0.2900 7799.5n 0.2900 7800.0n 0.2900 8399.5n 0.2900 8400.0n 0.2900 8999.5n 0.2900 9000.0n 0.2900 9599.5n 0.2900 9600.0n 0.2900 10199.5n 0.2900 10200.0n 0.2900 10799.5n 0.2900 10800.0n 0.2900 11399.5n 0.2900 11400.0n 0.2900 11999.5n 0.2900 12000.0n 0.2900 12599.5n 0.2900 12600.0n 0.2900 13199.5n 0.2900 13200.0n 0.2900 13799.5n 0.2900 13800.0n 0.2900 14399.5n 0.2900 14400.0n 0.2900 14999.5n 0.2900 15000.0n 0.2900 15599.5n 0.2900 15600.0n 0.2900 16199.5n 0.2900 16200.0n 0.2900 16799.5n 0.2900 16800.0n 0.2900 17399.5n 0.2900 17400.0n 0.2900 17999.5n 0.2900 18000.0n 0.2900 18599.5n 0.2900 18600.0n 0.2900 19199.5n 0.2900 19200.0n 0.2900 19799.5n 0.2900 19800.0n 0.2900 20399.5n 0.2900 20400.0n 0.2900 20999.5n 0.2900 21000.0n 0.2900 21599.5n 0.2900 21600.0n 0.2900 22199.5n 0.2900 22200.0n 0.2900 22799.5n 0.2900 22800.0n 0.2900 23399.5n 0.2900 23400.0n 0.2900 23999.5n 0.2900 24000.0n 0.2900 24599.5n 0.2900 24600.0n 0.2900 25199.5n 0.2900 25200.0n 0.2900 25799.5n 0.2900 25800.0n 0.2900 26399.5n 0.2900 26400.0n 0.2900 26999.5n 0.2900 27000.0n 0.2900 27599.5n 0.2900 27600.0n 0.2900 28199.5n 0.2900 28200.0n 0.2900 28799.5n 0.2900 28800.0n 0.2900 29399.5n 0.2900 29400.0n 0.2900 29999.5n 0.2900 30000.0n 0.2900 30599.5n 0.2900 30600.0n 0.2900 31199.5n 0.2900 31200.0n 0.2900 31799.5n 0.2900 31800.0n 0.2900 32399.5n 0.2900 32400.0n 0.2900 32999.5n 0.2900 33000.0n 0.2900 33599.5n 0.2900 33600.0n 0.2900 34199.5n 0.2900 34200.0n 0.2900 34799.5n 0.2900 34800.0n 0.2900 35399.5n 0.2900 35400.0n 0.2900 35999.5n 0.2900)
Vyp_bh_1 yp_bh_1 0 PWL(0.0n 0.6060 599.5n 0.6060 600.0n 0.6087 1199.5n 0.6087 1200.0n 0.6511 1799.5n 0.6511 1800.0n 0.6603 2399.5n 0.6603 2400.0n 0.6549 2999.5n 0.6549 3000.0n 0.6301 3599.5n 0.6301 3600.0n 0.6459 4199.5n 0.6459 4200.0n 0.6058 4799.5n 0.6058 4800.0n 0.6367 5399.5n 0.6367 5400.0n 0.6371 5999.5n 0.6371 6000.0n 0.6537 6599.5n 0.6537 6600.0n 0.6311 7199.5n 0.6311 7200.0n 0.6244 7799.5n 0.6244 7800.0n 0.6279 8399.5n 0.6279 8400.0n 0.6193 8999.5n 0.6193 9000.0n 0.6365 9599.5n 0.6365 9600.0n 0.6428 10199.5n 0.6428 10200.0n 0.6416 10799.5n 0.6416 10800.0n 0.6514 11399.5n 0.6514 11400.0n 0.6332 11999.5n 0.6332 12000.0n 0.6158 12599.5n 0.6158 12600.0n 0.6437 13199.5n 0.6437 13200.0n 0.6029 13799.5n 0.6029 13800.0n 0.6123 14399.5n 0.6123 14400.0n 0.6306 14999.5n 0.6306 15000.0n 0.6493 15599.5n 0.6493 15600.0n 0.6170 16199.5n 0.6170 16200.0n 0.5998 16799.5n 0.5998 16800.0n 0.6229 17399.5n 0.6229 17400.0n 0.6061 17999.5n 0.6061 18000.0n 0.6725 18599.5n 0.6725 18600.0n 0.5917 19199.5n 0.5917 19200.0n 0.6698 19799.5n 0.6698 19800.0n 0.6592 20399.5n 0.6592 20400.0n 0.6726 20999.5n 0.6726 21000.0n 0.6634 21599.5n 0.6634 21600.0n 0.6441 22199.5n 0.6441 22200.0n 0.5958 22799.5n 0.5958 22800.0n 0.6762 23399.5n 0.6762 23400.0n 0.4882 23999.5n 0.4882 24000.0n 0.6681 24599.5n 0.6681 24600.0n 0.5774 25199.5n 0.5774 25200.0n 0.6736 25799.5n 0.6736 25800.0n 0.6799 26399.5n 0.6799 26400.0n 0.6779 26999.5n 0.6779 27000.0n 0.6751 27599.5n 0.6751 27600.0n 0.6777 28199.5n 0.6777 28200.0n 0.4928 28799.5n 0.4928 28800.0n 0.6746 29399.5n 0.6746 29400.0n 0.6603 29999.5n 0.6603 30000.0n 0.6536 30599.5n 0.6536 30600.0n 0.5459 31199.5n 0.5459 31200.0n 0.5320 31799.5n 0.5320 31800.0n 0.6781 32399.5n 0.6781 32400.0n 0.6803 32999.5n 0.6803 33000.0n 0.6705 33599.5n 0.6705 33600.0n 0.6738 34199.5n 0.6738 34200.0n 0.5593 34799.5n 0.5593 34800.0n 0.6231 35399.5n 0.6231 35400.0n 0.6714 35999.5n 0.6714)
Vyn_bh_1 yn_bh_1 0 PWL(0.0n 0.3940 599.5n 0.3940 600.0n 0.3913 1199.5n 0.3913 1200.0n 0.3489 1799.5n 0.3489 1800.0n 0.3397 2399.5n 0.3397 2400.0n 0.3451 2999.5n 0.3451 3000.0n 0.3699 3599.5n 0.3699 3600.0n 0.3541 4199.5n 0.3541 4200.0n 0.3942 4799.5n 0.3942 4800.0n 0.3633 5399.5n 0.3633 5400.0n 0.3629 5999.5n 0.3629 6000.0n 0.3463 6599.5n 0.3463 6600.0n 0.3689 7199.5n 0.3689 7200.0n 0.3756 7799.5n 0.3756 7800.0n 0.3721 8399.5n 0.3721 8400.0n 0.3807 8999.5n 0.3807 9000.0n 0.3635 9599.5n 0.3635 9600.0n 0.3572 10199.5n 0.3572 10200.0n 0.3584 10799.5n 0.3584 10800.0n 0.3486 11399.5n 0.3486 11400.0n 0.3668 11999.5n 0.3668 12000.0n 0.3842 12599.5n 0.3842 12600.0n 0.3563 13199.5n 0.3563 13200.0n 0.3971 13799.5n 0.3971 13800.0n 0.3877 14399.5n 0.3877 14400.0n 0.3694 14999.5n 0.3694 15000.0n 0.3507 15599.5n 0.3507 15600.0n 0.3830 16199.5n 0.3830 16200.0n 0.4002 16799.5n 0.4002 16800.0n 0.3771 17399.5n 0.3771 17400.0n 0.3939 17999.5n 0.3939 18000.0n 0.3275 18599.5n 0.3275 18600.0n 0.4083 19199.5n 0.4083 19200.0n 0.3302 19799.5n 0.3302 19800.0n 0.3408 20399.5n 0.3408 20400.0n 0.3274 20999.5n 0.3274 21000.0n 0.3366 21599.5n 0.3366 21600.0n 0.3559 22199.5n 0.3559 22200.0n 0.4042 22799.5n 0.4042 22800.0n 0.3238 23399.5n 0.3238 23400.0n 0.5118 23999.5n 0.5118 24000.0n 0.3319 24599.5n 0.3319 24600.0n 0.4226 25199.5n 0.4226 25200.0n 0.3264 25799.5n 0.3264 25800.0n 0.3201 26399.5n 0.3201 26400.0n 0.3221 26999.5n 0.3221 27000.0n 0.3249 27599.5n 0.3249 27600.0n 0.3223 28199.5n 0.3223 28200.0n 0.5072 28799.5n 0.5072 28800.0n 0.3254 29399.5n 0.3254 29400.0n 0.3397 29999.5n 0.3397 30000.0n 0.3464 30599.5n 0.3464 30600.0n 0.4541 31199.5n 0.4541 31200.0n 0.4680 31799.5n 0.4680 31800.0n 0.3219 32399.5n 0.3219 32400.0n 0.3197 32999.5n 0.3197 33000.0n 0.3295 33599.5n 0.3295 33600.0n 0.3262 34199.5n 0.3262 34200.0n 0.4407 34799.5n 0.4407 34800.0n 0.3769 35399.5n 0.3769 35400.0n 0.3286 35999.5n 0.3286)
Cwp_bh_1 wp_bh_1 0 400p
Cwn_bh_1 wn_bh_1 0 400p
Xu_bh_1 xp_bh_1 xn_bh_1 yp_bh_1 yn_bh_1 wp_bh_1 wn_bh_1 vdd gbn gprod
Vxp_wih_0_2 xp_wih_0_2 0 PWL(0.0n 0.4942 599.5n 0.4942 600.0n 0.5558 1199.5n 0.5558 1200.0n 0.4708 1799.5n 0.4708 1800.0n 0.5235 2399.5n 0.5235 2400.0n 0.5350 2999.5n 0.5350 3000.0n 0.5172 3599.5n 0.5172 3600.0n 0.4702 4199.5n 0.4702 4200.0n 0.4867 4799.5n 0.4867 4800.0n 0.4970 5399.5n 0.4970 5400.0n 0.4986 5999.5n 0.4986 6000.0n 0.4751 6599.5n 0.4751 6600.0n 0.4870 7199.5n 0.4870 7200.0n 0.5502 7799.5n 0.5502 7800.0n 0.5521 8399.5n 0.5521 8400.0n 0.4638 8999.5n 0.4638 9000.0n 0.4982 9599.5n 0.4982 9600.0n 0.5131 10199.5n 0.5131 10200.0n 0.5386 10799.5n 0.5386 10800.0n 0.4592 11399.5n 0.4592 11400.0n 0.4950 11999.5n 0.4950 12000.0n 0.4559 12599.5n 0.4559 12600.0n 0.5162 13199.5n 0.5162 13200.0n 0.5038 13799.5n 0.5038 13800.0n 0.5333 14399.5n 0.5333 14400.0n 0.4991 14999.5n 0.4991 15000.0n 0.5298 15599.5n 0.5298 15600.0n 0.4823 16199.5n 0.4823 16200.0n 0.5239 16799.5n 0.5239 16800.0n 0.4592 17399.5n 0.4592 17400.0n 0.5094 17999.5n 0.5094 18000.0n 0.4337 18599.5n 0.4337 18600.0n 0.5977 19199.5n 0.5977 19200.0n 0.5364 19799.5n 0.5364 19800.0n 0.6122 20399.5n 0.6122 20400.0n 0.4856 20999.5n 0.4856 21000.0n 0.3861 21599.5n 0.3861 21600.0n 0.6094 22199.5n 0.6094 22200.0n 0.6364 22799.5n 0.6364 22800.0n 0.4807 23399.5n 0.4807 23400.0n 0.5614 23999.5n 0.5614 24000.0n 0.5913 24599.5n 0.5913 24600.0n 0.6295 25199.5n 0.6295 25200.0n 0.4496 25799.5n 0.4496 25800.0n 0.3792 26399.5n 0.3792 26400.0n 0.4434 26999.5n 0.4434 27000.0n 0.4340 27599.5n 0.4340 27600.0n 0.4461 28199.5n 0.4461 28200.0n 0.5791 28799.5n 0.5791 28800.0n 0.4777 29399.5n 0.4777 29400.0n 0.3878 29999.5n 0.3878 30000.0n 0.3832 30599.5n 0.3832 30600.0n 0.4022 31199.5n 0.4022 31200.0n 0.4482 31799.5n 0.4482 31800.0n 0.3662 32399.5n 0.3662 32400.0n 0.3857 32999.5n 0.3857 33000.0n 0.5584 33599.5n 0.5584 33600.0n 0.5284 34199.5n 0.5284 34200.0n 0.6034 34799.5n 0.6034 34800.0n 0.3469 35399.5n 0.3469 35400.0n 0.5290 35999.5n 0.5290)
Vxn_wih_0_2 xn_wih_0_2 0 PWL(0.0n 0.5058 599.5n 0.5058 600.0n 0.4442 1199.5n 0.4442 1200.0n 0.5292 1799.5n 0.5292 1800.0n 0.4765 2399.5n 0.4765 2400.0n 0.4650 2999.5n 0.4650 3000.0n 0.4828 3599.5n 0.4828 3600.0n 0.5298 4199.5n 0.5298 4200.0n 0.5133 4799.5n 0.5133 4800.0n 0.5030 5399.5n 0.5030 5400.0n 0.5014 5999.5n 0.5014 6000.0n 0.5249 6599.5n 0.5249 6600.0n 0.5130 7199.5n 0.5130 7200.0n 0.4498 7799.5n 0.4498 7800.0n 0.4479 8399.5n 0.4479 8400.0n 0.5362 8999.5n 0.5362 9000.0n 0.5018 9599.5n 0.5018 9600.0n 0.4869 10199.5n 0.4869 10200.0n 0.4614 10799.5n 0.4614 10800.0n 0.5408 11399.5n 0.5408 11400.0n 0.5050 11999.5n 0.5050 12000.0n 0.5441 12599.5n 0.5441 12600.0n 0.4838 13199.5n 0.4838 13200.0n 0.4962 13799.5n 0.4962 13800.0n 0.4667 14399.5n 0.4667 14400.0n 0.5009 14999.5n 0.5009 15000.0n 0.4702 15599.5n 0.4702 15600.0n 0.5177 16199.5n 0.5177 16200.0n 0.4761 16799.5n 0.4761 16800.0n 0.5408 17399.5n 0.5408 17400.0n 0.4906 17999.5n 0.4906 18000.0n 0.5663 18599.5n 0.5663 18600.0n 0.4023 19199.5n 0.4023 19200.0n 0.4636 19799.5n 0.4636 19800.0n 0.3878 20399.5n 0.3878 20400.0n 0.5144 20999.5n 0.5144 21000.0n 0.6139 21599.5n 0.6139 21600.0n 0.3906 22199.5n 0.3906 22200.0n 0.3636 22799.5n 0.3636 22800.0n 0.5193 23399.5n 0.5193 23400.0n 0.4386 23999.5n 0.4386 24000.0n 0.4087 24599.5n 0.4087 24600.0n 0.3705 25199.5n 0.3705 25200.0n 0.5504 25799.5n 0.5504 25800.0n 0.6208 26399.5n 0.6208 26400.0n 0.5566 26999.5n 0.5566 27000.0n 0.5660 27599.5n 0.5660 27600.0n 0.5539 28199.5n 0.5539 28200.0n 0.4209 28799.5n 0.4209 28800.0n 0.5223 29399.5n 0.5223 29400.0n 0.6122 29999.5n 0.6122 30000.0n 0.6168 30599.5n 0.6168 30600.0n 0.5978 31199.5n 0.5978 31200.0n 0.5518 31799.5n 0.5518 31800.0n 0.6338 32399.5n 0.6338 32400.0n 0.6143 32999.5n 0.6143 33000.0n 0.4416 33599.5n 0.4416 33600.0n 0.4716 34199.5n 0.4716 34200.0n 0.3966 34799.5n 0.3966 34800.0n 0.6531 35399.5n 0.6531 35400.0n 0.4710 35999.5n 0.4710)
Vyp_wih_0_2 yp_wih_0_2 0 PWL(0.0n 0.6382 599.5n 0.6382 600.0n 0.6529 1199.5n 0.6529 1200.0n 0.6332 1799.5n 0.6332 1800.0n 0.6482 2399.5n 0.6482 2400.0n 0.6499 2999.5n 0.6499 3000.0n 0.6450 3599.5n 0.6450 3600.0n 0.6322 4199.5n 0.6322 4200.0n 0.6353 4799.5n 0.6353 4800.0n 0.6410 5399.5n 0.6410 5400.0n 0.6415 5999.5n 0.6415 6000.0n 0.6355 6599.5n 0.6355 6600.0n 0.6377 7199.5n 0.6377 7200.0n 0.6517 7799.5n 0.6517 7800.0n 0.6523 8399.5n 0.6523 8400.0n 0.6265 8999.5n 0.6265 9000.0n 0.6413 9599.5n 0.6413 9600.0n 0.6448 10199.5n 0.6448 10200.0n 0.6495 10799.5n 0.6495 10800.0n 0.6278 11399.5n 0.6278 11400.0n 0.6404 11999.5n 0.6404 12000.0n 0.6215 12599.5n 0.6215 12600.0n 0.6454 13199.5n 0.6454 13200.0n 0.6409 13799.5n 0.6409 13800.0n 0.6476 14399.5n 0.6476 14400.0n 0.6413 14999.5n 0.6413 15000.0n 0.6484 15599.5n 0.6484 15600.0n 0.6347 16199.5n 0.6347 16200.0n 0.6454 16799.5n 0.6454 16800.0n 0.6243 17399.5n 0.6243 17400.0n 0.6425 17999.5n 0.6425 18000.0n 0.6088 18599.5n 0.6088 18600.0n 0.6615 19199.5n 0.6615 19200.0n 0.6514 19799.5n 0.6514 19800.0n 0.6641 20399.5n 0.6641 20400.0n 0.6406 20999.5n 0.6406 21000.0n 0.5806 21599.5n 0.5806 21600.0n 0.6632 22199.5n 0.6632 22200.0n 0.6630 22799.5n 0.6630 22800.0n 0.6382 23399.5n 0.6382 23400.0n 0.6544 23999.5n 0.6544 24000.0n 0.6635 24599.5n 0.6635 24600.0n 0.6630 25199.5n 0.6630 25200.0n 0.6227 25799.5n 0.6227 25800.0n 0.5809 26399.5n 0.5809 26400.0n 0.6171 26999.5n 0.6171 27000.0n 0.6084 27599.5n 0.6084 27600.0n 0.6193 28199.5n 0.6193 28200.0n 0.6596 28799.5n 0.6596 28800.0n 0.6372 29399.5n 0.6372 29400.0n 0.5806 29999.5n 0.5806 30000.0n 0.5783 30599.5n 0.5783 30600.0n 0.5765 31199.5n 0.5765 31200.0n 0.6117 31799.5n 0.6117 31800.0n 0.5801 32399.5n 0.5801 32400.0n 0.5819 32999.5n 0.5819 33000.0n 0.6564 33599.5n 0.6564 33600.0n 0.6500 34199.5n 0.6500 34200.0n 0.6621 34799.5n 0.6621 34800.0n 0.5729 35399.5n 0.5729 35400.0n 0.6502 35999.5n 0.6502)
Vyn_wih_0_2 yn_wih_0_2 0 PWL(0.0n 0.3618 599.5n 0.3618 600.0n 0.3471 1199.5n 0.3471 1200.0n 0.3668 1799.5n 0.3668 1800.0n 0.3518 2399.5n 0.3518 2400.0n 0.3501 2999.5n 0.3501 3000.0n 0.3550 3599.5n 0.3550 3600.0n 0.3678 4199.5n 0.3678 4200.0n 0.3647 4799.5n 0.3647 4800.0n 0.3590 5399.5n 0.3590 5400.0n 0.3585 5999.5n 0.3585 6000.0n 0.3645 6599.5n 0.3645 6600.0n 0.3623 7199.5n 0.3623 7200.0n 0.3483 7799.5n 0.3483 7800.0n 0.3477 8399.5n 0.3477 8400.0n 0.3735 8999.5n 0.3735 9000.0n 0.3587 9599.5n 0.3587 9600.0n 0.3552 10199.5n 0.3552 10200.0n 0.3505 10799.5n 0.3505 10800.0n 0.3722 11399.5n 0.3722 11400.0n 0.3596 11999.5n 0.3596 12000.0n 0.3785 12599.5n 0.3785 12600.0n 0.3546 13199.5n 0.3546 13200.0n 0.3591 13799.5n 0.3591 13800.0n 0.3524 14399.5n 0.3524 14400.0n 0.3587 14999.5n 0.3587 15000.0n 0.3516 15599.5n 0.3516 15600.0n 0.3653 16199.5n 0.3653 16200.0n 0.3546 16799.5n 0.3546 16800.0n 0.3757 17399.5n 0.3757 17400.0n 0.3575 17999.5n 0.3575 18000.0n 0.3912 18599.5n 0.3912 18600.0n 0.3385 19199.5n 0.3385 19200.0n 0.3486 19799.5n 0.3486 19800.0n 0.3359 20399.5n 0.3359 20400.0n 0.3594 20999.5n 0.3594 21000.0n 0.4194 21599.5n 0.4194 21600.0n 0.3368 22199.5n 0.3368 22200.0n 0.3370 22799.5n 0.3370 22800.0n 0.3618 23399.5n 0.3618 23400.0n 0.3456 23999.5n 0.3456 24000.0n 0.3365 24599.5n 0.3365 24600.0n 0.3370 25199.5n 0.3370 25200.0n 0.3773 25799.5n 0.3773 25800.0n 0.4191 26399.5n 0.4191 26400.0n 0.3829 26999.5n 0.3829 27000.0n 0.3916 27599.5n 0.3916 27600.0n 0.3807 28199.5n 0.3807 28200.0n 0.3404 28799.5n 0.3404 28800.0n 0.3628 29399.5n 0.3628 29400.0n 0.4194 29999.5n 0.4194 30000.0n 0.4217 30599.5n 0.4217 30600.0n 0.4235 31199.5n 0.4235 31200.0n 0.3883 31799.5n 0.3883 31800.0n 0.4199 32399.5n 0.4199 32400.0n 0.4181 32999.5n 0.4181 33000.0n 0.3436 33599.5n 0.3436 33600.0n 0.3500 34199.5n 0.3500 34200.0n 0.3379 34799.5n 0.3379 34800.0n 0.4271 35399.5n 0.4271 35400.0n 0.3498 35999.5n 0.3498)
Cwp_wih_0_2 wp_wih_0_2 0 400p
Cwn_wih_0_2 wn_wih_0_2 0 400p
Xu_wih_0_2 xp_wih_0_2 xn_wih_0_2 yp_wih_0_2 yn_wih_0_2 wp_wih_0_2 wn_wih_0_2 vdd gbn gprod
Vxp_wih_1_2 xp_wih_1_2 0 PWL(0.0n 0.5370 599.5n 0.5370 600.0n 0.5167 1199.5n 0.5167 1200.0n 0.4793 1799.5n 0.4793 1800.0n 0.4441 2399.5n 0.4441 2400.0n 0.4555 2999.5n 0.4555 3000.0n 0.5055 3599.5n 0.5055 3600.0n 0.4939 4199.5n 0.4939 4200.0n 0.5385 4799.5n 0.5385 4800.0n 0.5024 5399.5n 0.5024 5400.0n 0.5015 5999.5n 0.5015 6000.0n 0.4700 6599.5n 0.4700 6600.0n 0.5120 7199.5n 0.5120 7200.0n 0.5006 7799.5n 0.5006 7800.0n 0.4950 8399.5n 0.4950 8400.0n 0.5309 8999.5n 0.5309 9000.0n 0.5023 9599.5n 0.5023 9600.0n 0.4893 10199.5n 0.4893 10200.0n 0.4837 10799.5n 0.4837 10800.0n 0.4823 11399.5n 0.4823 11400.0n 0.5074 11999.5n 0.5074 12000.0n 0.5364 12599.5n 0.5364 12600.0n 0.4868 13199.5n 0.4868 13200.0n 0.5380 13799.5n 0.5380 13800.0n 0.5220 14399.5n 0.5220 14400.0n 0.5095 14999.5n 0.5095 15000.0n 0.4705 15599.5n 0.4705 15600.0n 0.5289 16199.5n 0.5289 16200.0n 0.5368 16799.5n 0.5368 16800.0n 0.5287 17399.5n 0.5287 17400.0n 0.5342 17999.5n 0.5342 18000.0n 0.4253 18599.5n 0.4253 18600.0n 0.5119 19199.5n 0.5119 19200.0n 0.4104 19799.5n 0.4104 19800.0n 0.4314 20399.5n 0.4314 20400.0n 0.4005 20999.5n 0.4005 21000.0n 0.4696 21599.5n 0.4696 21600.0n 0.4531 22199.5n 0.4531 22200.0n 0.5039 22799.5n 0.5039 22800.0n 0.3608 23399.5n 0.3608 23400.0n 0.6273 23999.5n 0.6273 24000.0n 0.3928 24599.5n 0.3928 24600.0n 0.5253 25199.5n 0.5253 25200.0n 0.4107 25799.5n 0.4107 25800.0n 0.3947 26399.5n 0.3947 26400.0n 0.3716 26999.5n 0.3716 27000.0n 0.4111 27599.5n 0.4111 27600.0n 0.3715 28199.5n 0.3715 28200.0n 0.5939 28799.5n 0.5939 28800.0n 0.3849 29399.5n 0.3849 29400.0n 0.4835 29999.5n 0.4835 30000.0n 0.5119 30599.5n 0.5119 30600.0n 0.6226 31199.5n 0.6226 31200.0n 0.6064 31799.5n 0.6064 31800.0n 0.4115 32399.5n 0.4115 32400.0n 0.3900 32999.5n 0.3900 33000.0n 0.3958 33599.5n 0.3958 33600.0n 0.3747 34199.5n 0.3747 34200.0n 0.5423 34799.5n 0.5423 34800.0n 0.5509 35399.5n 0.5509 35400.0n 0.3990 35999.5n 0.3990)
Vxn_wih_1_2 xn_wih_1_2 0 PWL(0.0n 0.4630 599.5n 0.4630 600.0n 0.4833 1199.5n 0.4833 1200.0n 0.5207 1799.5n 0.5207 1800.0n 0.5559 2399.5n 0.5559 2400.0n 0.5445 2999.5n 0.5445 3000.0n 0.4945 3599.5n 0.4945 3600.0n 0.5061 4199.5n 0.5061 4200.0n 0.4615 4799.5n 0.4615 4800.0n 0.4976 5399.5n 0.4976 5400.0n 0.4985 5999.5n 0.4985 6000.0n 0.5300 6599.5n 0.5300 6600.0n 0.4880 7199.5n 0.4880 7200.0n 0.4994 7799.5n 0.4994 7800.0n 0.5050 8399.5n 0.5050 8400.0n 0.4691 8999.5n 0.4691 9000.0n 0.4977 9599.5n 0.4977 9600.0n 0.5107 10199.5n 0.5107 10200.0n 0.5163 10799.5n 0.5163 10800.0n 0.5177 11399.5n 0.5177 11400.0n 0.4926 11999.5n 0.4926 12000.0n 0.4636 12599.5n 0.4636 12600.0n 0.5132 13199.5n 0.5132 13200.0n 0.4620 13799.5n 0.4620 13800.0n 0.4780 14399.5n 0.4780 14400.0n 0.4905 14999.5n 0.4905 15000.0n 0.5295 15599.5n 0.5295 15600.0n 0.4711 16199.5n 0.4711 16200.0n 0.4632 16799.5n 0.4632 16800.0n 0.4713 17399.5n 0.4713 17400.0n 0.4658 17999.5n 0.4658 18000.0n 0.5747 18599.5n 0.5747 18600.0n 0.4881 19199.5n 0.4881 19200.0n 0.5896 19799.5n 0.5896 19800.0n 0.5686 20399.5n 0.5686 20400.0n 0.5995 20999.5n 0.5995 21000.0n 0.5304 21599.5n 0.5304 21600.0n 0.5469 22199.5n 0.5469 22200.0n 0.4961 22799.5n 0.4961 22800.0n 0.6392 23399.5n 0.6392 23400.0n 0.3727 23999.5n 0.3727 24000.0n 0.6072 24599.5n 0.6072 24600.0n 0.4747 25199.5n 0.4747 25200.0n 0.5893 25799.5n 0.5893 25800.0n 0.6053 26399.5n 0.6053 26400.0n 0.6284 26999.5n 0.6284 27000.0n 0.5889 27599.5n 0.5889 27600.0n 0.6285 28199.5n 0.6285 28200.0n 0.4061 28799.5n 0.4061 28800.0n 0.6151 29399.5n 0.6151 29400.0n 0.5165 29999.5n 0.5165 30000.0n 0.4881 30599.5n 0.4881 30600.0n 0.3774 31199.5n 0.3774 31200.0n 0.3936 31799.5n 0.3936 31800.0n 0.5885 32399.5n 0.5885 32400.0n 0.6100 32999.5n 0.6100 33000.0n 0.6042 33599.5n 0.6042 33600.0n 0.6253 34199.5n 0.6253 34200.0n 0.4577 34799.5n 0.4577 34800.0n 0.4491 35399.5n 0.4491 35400.0n 0.6010 35999.5n 0.6010)
Vyp_wih_1_2 yp_wih_1_2 0 PWL(0.0n 0.6382 599.5n 0.6382 600.0n 0.6529 1199.5n 0.6529 1200.0n 0.6332 1799.5n 0.6332 1800.0n 0.6482 2399.5n 0.6482 2400.0n 0.6499 2999.5n 0.6499 3000.0n 0.6450 3599.5n 0.6450 3600.0n 0.6322 4199.5n 0.6322 4200.0n 0.6353 4799.5n 0.6353 4800.0n 0.6410 5399.5n 0.6410 5400.0n 0.6415 5999.5n 0.6415 6000.0n 0.6355 6599.5n 0.6355 6600.0n 0.6377 7199.5n 0.6377 7200.0n 0.6517 7799.5n 0.6517 7800.0n 0.6523 8399.5n 0.6523 8400.0n 0.6265 8999.5n 0.6265 9000.0n 0.6413 9599.5n 0.6413 9600.0n 0.6448 10199.5n 0.6448 10200.0n 0.6495 10799.5n 0.6495 10800.0n 0.6278 11399.5n 0.6278 11400.0n 0.6404 11999.5n 0.6404 12000.0n 0.6215 12599.5n 0.6215 12600.0n 0.6454 13199.5n 0.6454 13200.0n 0.6409 13799.5n 0.6409 13800.0n 0.6476 14399.5n 0.6476 14400.0n 0.6413 14999.5n 0.6413 15000.0n 0.6484 15599.5n 0.6484 15600.0n 0.6347 16199.5n 0.6347 16200.0n 0.6454 16799.5n 0.6454 16800.0n 0.6243 17399.5n 0.6243 17400.0n 0.6425 17999.5n 0.6425 18000.0n 0.6088 18599.5n 0.6088 18600.0n 0.6615 19199.5n 0.6615 19200.0n 0.6514 19799.5n 0.6514 19800.0n 0.6641 20399.5n 0.6641 20400.0n 0.6406 20999.5n 0.6406 21000.0n 0.5806 21599.5n 0.5806 21600.0n 0.6632 22199.5n 0.6632 22200.0n 0.6630 22799.5n 0.6630 22800.0n 0.6382 23399.5n 0.6382 23400.0n 0.6544 23999.5n 0.6544 24000.0n 0.6635 24599.5n 0.6635 24600.0n 0.6630 25199.5n 0.6630 25200.0n 0.6227 25799.5n 0.6227 25800.0n 0.5809 26399.5n 0.5809 26400.0n 0.6171 26999.5n 0.6171 27000.0n 0.6084 27599.5n 0.6084 27600.0n 0.6193 28199.5n 0.6193 28200.0n 0.6596 28799.5n 0.6596 28800.0n 0.6372 29399.5n 0.6372 29400.0n 0.5806 29999.5n 0.5806 30000.0n 0.5783 30599.5n 0.5783 30600.0n 0.5765 31199.5n 0.5765 31200.0n 0.6117 31799.5n 0.6117 31800.0n 0.5801 32399.5n 0.5801 32400.0n 0.5819 32999.5n 0.5819 33000.0n 0.6564 33599.5n 0.6564 33600.0n 0.6500 34199.5n 0.6500 34200.0n 0.6621 34799.5n 0.6621 34800.0n 0.5729 35399.5n 0.5729 35400.0n 0.6502 35999.5n 0.6502)
Vyn_wih_1_2 yn_wih_1_2 0 PWL(0.0n 0.3618 599.5n 0.3618 600.0n 0.3471 1199.5n 0.3471 1200.0n 0.3668 1799.5n 0.3668 1800.0n 0.3518 2399.5n 0.3518 2400.0n 0.3501 2999.5n 0.3501 3000.0n 0.3550 3599.5n 0.3550 3600.0n 0.3678 4199.5n 0.3678 4200.0n 0.3647 4799.5n 0.3647 4800.0n 0.3590 5399.5n 0.3590 5400.0n 0.3585 5999.5n 0.3585 6000.0n 0.3645 6599.5n 0.3645 6600.0n 0.3623 7199.5n 0.3623 7200.0n 0.3483 7799.5n 0.3483 7800.0n 0.3477 8399.5n 0.3477 8400.0n 0.3735 8999.5n 0.3735 9000.0n 0.3587 9599.5n 0.3587 9600.0n 0.3552 10199.5n 0.3552 10200.0n 0.3505 10799.5n 0.3505 10800.0n 0.3722 11399.5n 0.3722 11400.0n 0.3596 11999.5n 0.3596 12000.0n 0.3785 12599.5n 0.3785 12600.0n 0.3546 13199.5n 0.3546 13200.0n 0.3591 13799.5n 0.3591 13800.0n 0.3524 14399.5n 0.3524 14400.0n 0.3587 14999.5n 0.3587 15000.0n 0.3516 15599.5n 0.3516 15600.0n 0.3653 16199.5n 0.3653 16200.0n 0.3546 16799.5n 0.3546 16800.0n 0.3757 17399.5n 0.3757 17400.0n 0.3575 17999.5n 0.3575 18000.0n 0.3912 18599.5n 0.3912 18600.0n 0.3385 19199.5n 0.3385 19200.0n 0.3486 19799.5n 0.3486 19800.0n 0.3359 20399.5n 0.3359 20400.0n 0.3594 20999.5n 0.3594 21000.0n 0.4194 21599.5n 0.4194 21600.0n 0.3368 22199.5n 0.3368 22200.0n 0.3370 22799.5n 0.3370 22800.0n 0.3618 23399.5n 0.3618 23400.0n 0.3456 23999.5n 0.3456 24000.0n 0.3365 24599.5n 0.3365 24600.0n 0.3370 25199.5n 0.3370 25200.0n 0.3773 25799.5n 0.3773 25800.0n 0.4191 26399.5n 0.4191 26400.0n 0.3829 26999.5n 0.3829 27000.0n 0.3916 27599.5n 0.3916 27600.0n 0.3807 28199.5n 0.3807 28200.0n 0.3404 28799.5n 0.3404 28800.0n 0.3628 29399.5n 0.3628 29400.0n 0.4194 29999.5n 0.4194 30000.0n 0.4217 30599.5n 0.4217 30600.0n 0.4235 31199.5n 0.4235 31200.0n 0.3883 31799.5n 0.3883 31800.0n 0.4199 32399.5n 0.4199 32400.0n 0.4181 32999.5n 0.4181 33000.0n 0.3436 33599.5n 0.3436 33600.0n 0.3500 34199.5n 0.3500 34200.0n 0.3379 34799.5n 0.3379 34800.0n 0.4271 35399.5n 0.4271 35400.0n 0.3498 35999.5n 0.3498)
Cwp_wih_1_2 wp_wih_1_2 0 400p
Cwn_wih_1_2 wn_wih_1_2 0 400p
Xu_wih_1_2 xp_wih_1_2 xn_wih_1_2 yp_wih_1_2 yn_wih_1_2 wp_wih_1_2 wn_wih_1_2 vdd gbn gprod
Vxp_who_2_0 xp_who_2_0 0 PWL(0.0n 0.6382 599.5n 0.6382 600.0n 0.6529 1199.5n 0.6529 1200.0n 0.6332 1799.5n 0.6332 1800.0n 0.6482 2399.5n 0.6482 2400.0n 0.6499 2999.5n 0.6499 3000.0n 0.6450 3599.5n 0.6450 3600.0n 0.6322 4199.5n 0.6322 4200.0n 0.6353 4799.5n 0.6353 4800.0n 0.6410 5399.5n 0.6410 5400.0n 0.6415 5999.5n 0.6415 6000.0n 0.6355 6599.5n 0.6355 6600.0n 0.6377 7199.5n 0.6377 7200.0n 0.6517 7799.5n 0.6517 7800.0n 0.6523 8399.5n 0.6523 8400.0n 0.6265 8999.5n 0.6265 9000.0n 0.6413 9599.5n 0.6413 9600.0n 0.6448 10199.5n 0.6448 10200.0n 0.6495 10799.5n 0.6495 10800.0n 0.6278 11399.5n 0.6278 11400.0n 0.6404 11999.5n 0.6404 12000.0n 0.6215 12599.5n 0.6215 12600.0n 0.6454 13199.5n 0.6454 13200.0n 0.6409 13799.5n 0.6409 13800.0n 0.6476 14399.5n 0.6476 14400.0n 0.6413 14999.5n 0.6413 15000.0n 0.6484 15599.5n 0.6484 15600.0n 0.6347 16199.5n 0.6347 16200.0n 0.6454 16799.5n 0.6454 16800.0n 0.6243 17399.5n 0.6243 17400.0n 0.6425 17999.5n 0.6425 18000.0n 0.6088 18599.5n 0.6088 18600.0n 0.6615 19199.5n 0.6615 19200.0n 0.6514 19799.5n 0.6514 19800.0n 0.6641 20399.5n 0.6641 20400.0n 0.6406 20999.5n 0.6406 21000.0n 0.5806 21599.5n 0.5806 21600.0n 0.6632 22199.5n 0.6632 22200.0n 0.6630 22799.5n 0.6630 22800.0n 0.6382 23399.5n 0.6382 23400.0n 0.6544 23999.5n 0.6544 24000.0n 0.6635 24599.5n 0.6635 24600.0n 0.6630 25199.5n 0.6630 25200.0n 0.6227 25799.5n 0.6227 25800.0n 0.5809 26399.5n 0.5809 26400.0n 0.6171 26999.5n 0.6171 27000.0n 0.6084 27599.5n 0.6084 27600.0n 0.6193 28199.5n 0.6193 28200.0n 0.6596 28799.5n 0.6596 28800.0n 0.6372 29399.5n 0.6372 29400.0n 0.5806 29999.5n 0.5806 30000.0n 0.5783 30599.5n 0.5783 30600.0n 0.5765 31199.5n 0.5765 31200.0n 0.6117 31799.5n 0.6117 31800.0n 0.5801 32399.5n 0.5801 32400.0n 0.5819 32999.5n 0.5819 33000.0n 0.6564 33599.5n 0.6564 33600.0n 0.6500 34199.5n 0.6500 34200.0n 0.6621 34799.5n 0.6621 34800.0n 0.5729 35399.5n 0.5729 35400.0n 0.6502 35999.5n 0.6502)
Vxn_who_2_0 xn_who_2_0 0 PWL(0.0n 0.3618 599.5n 0.3618 600.0n 0.3471 1199.5n 0.3471 1200.0n 0.3668 1799.5n 0.3668 1800.0n 0.3518 2399.5n 0.3518 2400.0n 0.3501 2999.5n 0.3501 3000.0n 0.3550 3599.5n 0.3550 3600.0n 0.3678 4199.5n 0.3678 4200.0n 0.3647 4799.5n 0.3647 4800.0n 0.3590 5399.5n 0.3590 5400.0n 0.3585 5999.5n 0.3585 6000.0n 0.3645 6599.5n 0.3645 6600.0n 0.3623 7199.5n 0.3623 7200.0n 0.3483 7799.5n 0.3483 7800.0n 0.3477 8399.5n 0.3477 8400.0n 0.3735 8999.5n 0.3735 9000.0n 0.3587 9599.5n 0.3587 9600.0n 0.3552 10199.5n 0.3552 10200.0n 0.3505 10799.5n 0.3505 10800.0n 0.3722 11399.5n 0.3722 11400.0n 0.3596 11999.5n 0.3596 12000.0n 0.3785 12599.5n 0.3785 12600.0n 0.3546 13199.5n 0.3546 13200.0n 0.3591 13799.5n 0.3591 13800.0n 0.3524 14399.5n 0.3524 14400.0n 0.3587 14999.5n 0.3587 15000.0n 0.3516 15599.5n 0.3516 15600.0n 0.3653 16199.5n 0.3653 16200.0n 0.3546 16799.5n 0.3546 16800.0n 0.3757 17399.5n 0.3757 17400.0n 0.3575 17999.5n 0.3575 18000.0n 0.3912 18599.5n 0.3912 18600.0n 0.3385 19199.5n 0.3385 19200.0n 0.3486 19799.5n 0.3486 19800.0n 0.3359 20399.5n 0.3359 20400.0n 0.3594 20999.5n 0.3594 21000.0n 0.4194 21599.5n 0.4194 21600.0n 0.3368 22199.5n 0.3368 22200.0n 0.3370 22799.5n 0.3370 22800.0n 0.3618 23399.5n 0.3618 23400.0n 0.3456 23999.5n 0.3456 24000.0n 0.3365 24599.5n 0.3365 24600.0n 0.3370 25199.5n 0.3370 25200.0n 0.3773 25799.5n 0.3773 25800.0n 0.4191 26399.5n 0.4191 26400.0n 0.3829 26999.5n 0.3829 27000.0n 0.3916 27599.5n 0.3916 27600.0n 0.3807 28199.5n 0.3807 28200.0n 0.3404 28799.5n 0.3404 28800.0n 0.3628 29399.5n 0.3628 29400.0n 0.4194 29999.5n 0.4194 30000.0n 0.4217 30599.5n 0.4217 30600.0n 0.4235 31199.5n 0.4235 31200.0n 0.3883 31799.5n 0.3883 31800.0n 0.4199 32399.5n 0.4199 32400.0n 0.4181 32999.5n 0.4181 33000.0n 0.3436 33599.5n 0.3436 33600.0n 0.3500 34199.5n 0.3500 34200.0n 0.3379 34799.5n 0.3379 34800.0n 0.4271 35399.5n 0.4271 35400.0n 0.3498 35999.5n 0.3498)
Vyp_who_2_0 yp_who_2_0 0 PWL(0.0n 0.5031 599.5n 0.5031 600.0n 0.5023 1199.5n 0.5023 1200.0n 0.5052 1799.5n 0.5052 1800.0n 0.5048 2399.5n 0.5048 2400.0n 0.5043 2999.5n 0.5043 3000.0n 0.5034 3599.5n 0.5034 3600.0n 0.5048 4199.5n 0.5048 4200.0n 0.5031 4799.5n 0.5031 4800.0n 0.5040 5399.5n 0.5040 5400.0n 0.5040 5999.5n 0.5040 6000.0n 0.5054 6599.5n 0.5054 6600.0n 0.5040 7199.5n 0.5040 7200.0n 0.5027 7799.5n 0.5027 7800.0n 0.5027 8399.5n 0.5027 8400.0n 0.5038 8999.5n 0.5038 9000.0n 0.5040 9599.5n 0.5040 9600.0n 0.5039 10199.5n 0.5039 10200.0n 0.5033 10799.5n 0.5033 10800.0n 0.5056 11399.5n 0.5056 11400.0n 0.5040 11999.5n 0.5040 12000.0n 0.5036 12599.5n 0.5036 12600.0n 0.5039 13199.5n 0.5039 13200.0n 0.5029 13799.5n 0.5029 13800.0n 0.5025 14399.5n 0.5025 14400.0n 0.5038 14999.5n 0.5038 15000.0n 0.5041 15599.5n 0.5041 15600.0n 0.5036 16199.5n 0.5036 16200.0n 0.5025 16799.5n 0.5025 16800.0n 0.5040 17399.5n 0.5040 17400.0n 0.5029 17999.5n 0.5029 18000.0n 0.5057 18599.5n 0.5057 18600.0n 0.5010 19199.5n 0.5010 19200.0n 0.5041 19799.5n 0.5041 19800.0n 0.5021 20399.5n 0.5021 20400.0n 0.5044 20999.5n 0.5044 21000.0n 0.5056 21599.5n 0.5056 21600.0n 0.5016 22199.5n 0.5016 22200.0n 0.5006 22799.5n 0.5006 22800.0n 0.5041 23399.5n 0.5041 23400.0n 0.5027 23999.5n 0.5027 24000.0n 0.5029 24599.5n 0.5029 24600.0n 0.5006 25199.5n 0.5006 25200.0n 0.5047 25799.5n 0.5047 25800.0n 0.5046 26399.5n 0.5046 26400.0n 0.5039 26999.5n 0.5039 27000.0n 0.5049 27599.5n 0.5049 27600.0n 0.5039 28199.5n 0.5039 28200.0n 0.5017 28799.5n 0.5017 28800.0n 0.5042 29399.5n 0.5042 29400.0n 0.5056 29999.5n 0.5056 30000.0n 0.5051 30599.5n 0.5051 30600.0n 0.5039 31199.5n 0.5039 31200.0n 0.5033 31799.5n 0.5033 31800.0n 0.5049 32399.5n 0.5049 32400.0n 0.5045 32999.5n 0.5045 33000.0n 0.5036 33599.5n 0.5036 33600.0n 0.5042 34199.5n 0.5042 34200.0n 0.5012 34799.5n 0.5012 34800.0n 0.5036 35399.5n 0.5036 35400.0n 0.5042 35999.5n 0.5042)
Vyn_who_2_0 yn_who_2_0 0 PWL(0.0n 0.4969 599.5n 0.4969 600.0n 0.4977 1199.5n 0.4977 1200.0n 0.4948 1799.5n 0.4948 1800.0n 0.4952 2399.5n 0.4952 2400.0n 0.4957 2999.5n 0.4957 3000.0n 0.4966 3599.5n 0.4966 3600.0n 0.4952 4199.5n 0.4952 4200.0n 0.4969 4799.5n 0.4969 4800.0n 0.4960 5399.5n 0.4960 5400.0n 0.4960 5999.5n 0.4960 6000.0n 0.4946 6599.5n 0.4946 6600.0n 0.4960 7199.5n 0.4960 7200.0n 0.4973 7799.5n 0.4973 7800.0n 0.4973 8399.5n 0.4973 8400.0n 0.4962 8999.5n 0.4962 9000.0n 0.4960 9599.5n 0.4960 9600.0n 0.4961 10199.5n 0.4961 10200.0n 0.4967 10799.5n 0.4967 10800.0n 0.4944 11399.5n 0.4944 11400.0n 0.4960 11999.5n 0.4960 12000.0n 0.4964 12599.5n 0.4964 12600.0n 0.4961 13199.5n 0.4961 13200.0n 0.4971 13799.5n 0.4971 13800.0n 0.4975 14399.5n 0.4975 14400.0n 0.4962 14999.5n 0.4962 15000.0n 0.4959 15599.5n 0.4959 15600.0n 0.4964 16199.5n 0.4964 16200.0n 0.4975 16799.5n 0.4975 16800.0n 0.4960 17399.5n 0.4960 17400.0n 0.4971 17999.5n 0.4971 18000.0n 0.4943 18599.5n 0.4943 18600.0n 0.4990 19199.5n 0.4990 19200.0n 0.4959 19799.5n 0.4959 19800.0n 0.4979 20399.5n 0.4979 20400.0n 0.4956 20999.5n 0.4956 21000.0n 0.4944 21599.5n 0.4944 21600.0n 0.4984 22199.5n 0.4984 22200.0n 0.4994 22799.5n 0.4994 22800.0n 0.4959 23399.5n 0.4959 23400.0n 0.4973 23999.5n 0.4973 24000.0n 0.4971 24599.5n 0.4971 24600.0n 0.4994 25199.5n 0.4994 25200.0n 0.4953 25799.5n 0.4953 25800.0n 0.4954 26399.5n 0.4954 26400.0n 0.4961 26999.5n 0.4961 27000.0n 0.4951 27599.5n 0.4951 27600.0n 0.4961 28199.5n 0.4961 28200.0n 0.4983 28799.5n 0.4983 28800.0n 0.4958 29399.5n 0.4958 29400.0n 0.4944 29999.5n 0.4944 30000.0n 0.4949 30599.5n 0.4949 30600.0n 0.4961 31199.5n 0.4961 31200.0n 0.4967 31799.5n 0.4967 31800.0n 0.4951 32399.5n 0.4951 32400.0n 0.4955 32999.5n 0.4955 33000.0n 0.4964 33599.5n 0.4964 33600.0n 0.4958 34199.5n 0.4958 34200.0n 0.4988 34799.5n 0.4988 34800.0n 0.4964 35399.5n 0.4964 35400.0n 0.4958 35999.5n 0.4958)
Cwp_who_2_0 wp_who_2_0 0 400p
Cwn_who_2_0 wn_who_2_0 0 400p
Xu_who_2_0 xp_who_2_0 xn_who_2_0 yp_who_2_0 yn_who_2_0 wp_who_2_0 wn_who_2_0 vdd gbn gprod
Vxp_who_2_1 xp_who_2_1 0 PWL(0.0n 0.6382 599.5n 0.6382 600.0n 0.6529 1199.5n 0.6529 1200.0n 0.6332 1799.5n 0.6332 1800.0n 0.6482 2399.5n 0.6482 2400.0n 0.6499 2999.5n 0.6499 3000.0n 0.6450 3599.5n 0.6450 3600.0n 0.6322 4199.5n 0.6322 4200.0n 0.6353 4799.5n 0.6353 4800.0n 0.6410 5399.5n 0.6410 5400.0n 0.6415 5999.5n 0.6415 6000.0n 0.6355 6599.5n 0.6355 6600.0n 0.6377 7199.5n 0.6377 7200.0n 0.6517 7799.5n 0.6517 7800.0n 0.6523 8399.5n 0.6523 8400.0n 0.6265 8999.5n 0.6265 9000.0n 0.6413 9599.5n 0.6413 9600.0n 0.6448 10199.5n 0.6448 10200.0n 0.6495 10799.5n 0.6495 10800.0n 0.6278 11399.5n 0.6278 11400.0n 0.6404 11999.5n 0.6404 12000.0n 0.6215 12599.5n 0.6215 12600.0n 0.6454 13199.5n 0.6454 13200.0n 0.6409 13799.5n 0.6409 13800.0n 0.6476 14399.5n 0.6476 14400.0n 0.6413 14999.5n 0.6413 15000.0n 0.6484 15599.5n 0.6484 15600.0n 0.6347 16199.5n 0.6347 16200.0n 0.6454 16799.5n 0.6454 16800.0n 0.6243 17399.5n 0.6243 17400.0n 0.6425 17999.5n 0.6425 18000.0n 0.6088 18599.5n 0.6088 18600.0n 0.6615 19199.5n 0.6615 19200.0n 0.6514 19799.5n 0.6514 19800.0n 0.6641 20399.5n 0.6641 20400.0n 0.6406 20999.5n 0.6406 21000.0n 0.5806 21599.5n 0.5806 21600.0n 0.6632 22199.5n 0.6632 22200.0n 0.6630 22799.5n 0.6630 22800.0n 0.6382 23399.5n 0.6382 23400.0n 0.6544 23999.5n 0.6544 24000.0n 0.6635 24599.5n 0.6635 24600.0n 0.6630 25199.5n 0.6630 25200.0n 0.6227 25799.5n 0.6227 25800.0n 0.5809 26399.5n 0.5809 26400.0n 0.6171 26999.5n 0.6171 27000.0n 0.6084 27599.5n 0.6084 27600.0n 0.6193 28199.5n 0.6193 28200.0n 0.6596 28799.5n 0.6596 28800.0n 0.6372 29399.5n 0.6372 29400.0n 0.5806 29999.5n 0.5806 30000.0n 0.5783 30599.5n 0.5783 30600.0n 0.5765 31199.5n 0.5765 31200.0n 0.6117 31799.5n 0.6117 31800.0n 0.5801 32399.5n 0.5801 32400.0n 0.5819 32999.5n 0.5819 33000.0n 0.6564 33599.5n 0.6564 33600.0n 0.6500 34199.5n 0.6500 34200.0n 0.6621 34799.5n 0.6621 34800.0n 0.5729 35399.5n 0.5729 35400.0n 0.6502 35999.5n 0.6502)
Vxn_who_2_1 xn_who_2_1 0 PWL(0.0n 0.3618 599.5n 0.3618 600.0n 0.3471 1199.5n 0.3471 1200.0n 0.3668 1799.5n 0.3668 1800.0n 0.3518 2399.5n 0.3518 2400.0n 0.3501 2999.5n 0.3501 3000.0n 0.3550 3599.5n 0.3550 3600.0n 0.3678 4199.5n 0.3678 4200.0n 0.3647 4799.5n 0.3647 4800.0n 0.3590 5399.5n 0.3590 5400.0n 0.3585 5999.5n 0.3585 6000.0n 0.3645 6599.5n 0.3645 6600.0n 0.3623 7199.5n 0.3623 7200.0n 0.3483 7799.5n 0.3483 7800.0n 0.3477 8399.5n 0.3477 8400.0n 0.3735 8999.5n 0.3735 9000.0n 0.3587 9599.5n 0.3587 9600.0n 0.3552 10199.5n 0.3552 10200.0n 0.3505 10799.5n 0.3505 10800.0n 0.3722 11399.5n 0.3722 11400.0n 0.3596 11999.5n 0.3596 12000.0n 0.3785 12599.5n 0.3785 12600.0n 0.3546 13199.5n 0.3546 13200.0n 0.3591 13799.5n 0.3591 13800.0n 0.3524 14399.5n 0.3524 14400.0n 0.3587 14999.5n 0.3587 15000.0n 0.3516 15599.5n 0.3516 15600.0n 0.3653 16199.5n 0.3653 16200.0n 0.3546 16799.5n 0.3546 16800.0n 0.3757 17399.5n 0.3757 17400.0n 0.3575 17999.5n 0.3575 18000.0n 0.3912 18599.5n 0.3912 18600.0n 0.3385 19199.5n 0.3385 19200.0n 0.3486 19799.5n 0.3486 19800.0n 0.3359 20399.5n 0.3359 20400.0n 0.3594 20999.5n 0.3594 21000.0n 0.4194 21599.5n 0.4194 21600.0n 0.3368 22199.5n 0.3368 22200.0n 0.3370 22799.5n 0.3370 22800.0n 0.3618 23399.5n 0.3618 23400.0n 0.3456 23999.5n 0.3456 24000.0n 0.3365 24599.5n 0.3365 24600.0n 0.3370 25199.5n 0.3370 25200.0n 0.3773 25799.5n 0.3773 25800.0n 0.4191 26399.5n 0.4191 26400.0n 0.3829 26999.5n 0.3829 27000.0n 0.3916 27599.5n 0.3916 27600.0n 0.3807 28199.5n 0.3807 28200.0n 0.3404 28799.5n 0.3404 28800.0n 0.3628 29399.5n 0.3628 29400.0n 0.4194 29999.5n 0.4194 30000.0n 0.4217 30599.5n 0.4217 30600.0n 0.4235 31199.5n 0.4235 31200.0n 0.3883 31799.5n 0.3883 31800.0n 0.4199 32399.5n 0.4199 32400.0n 0.4181 32999.5n 0.4181 33000.0n 0.3436 33599.5n 0.3436 33600.0n 0.3500 34199.5n 0.3500 34200.0n 0.3379 34799.5n 0.3379 34800.0n 0.4271 35399.5n 0.4271 35400.0n 0.3498 35999.5n 0.3498)
Vyp_who_2_1 yp_who_2_1 0 PWL(0.0n 0.5071 599.5n 0.5071 600.0n 0.5053 1199.5n 0.5053 1200.0n 0.5052 1799.5n 0.5052 1800.0n 0.5027 2399.5n 0.5027 2400.0n 0.5034 2999.5n 0.5034 3000.0n 0.5055 3599.5n 0.5055 3600.0n 0.5056 4199.5n 0.5056 4200.0n 0.5071 4799.5n 0.5071 4800.0n 0.5056 5399.5n 0.5056 5400.0n 0.5056 5999.5n 0.5056 6000.0n 0.5048 6599.5n 0.5048 6600.0n 0.5060 7199.5n 0.5060 7200.0n 0.5048 7799.5n 0.5048 7800.0n 0.5046 8399.5n 0.5046 8400.0n 0.5066 8999.5n 0.5066 9000.0n 0.5056 9599.5n 0.5056 9600.0n 0.5051 10199.5n 0.5051 10200.0n 0.5046 10799.5n 0.5046 10800.0n 0.5056 11399.5n 0.5056 11400.0n 0.5058 11999.5n 0.5058 12000.0n 0.5068 12599.5n 0.5068 12600.0n 0.5050 13199.5n 0.5050 13200.0n 0.5071 13799.5n 0.5071 13800.0n 0.5059 14399.5n 0.5059 14400.0n 0.5058 14999.5n 0.5058 15000.0n 0.5043 15599.5n 0.5043 15600.0n 0.5067 16199.5n 0.5067 16200.0n 0.5068 16799.5n 0.5068 16800.0n 0.5066 17399.5n 0.5066 17400.0n 0.5069 17999.5n 0.5069 18000.0n 0.5061 18599.5n 0.5061 18600.0n 0.5034 19199.5n 0.5034 19200.0n 0.5010 19799.5n 0.5010 19800.0n 0.4989 20399.5n 0.4989 20400.0n 0.5022 20999.5n 0.5022 21000.0n 0.5086 21599.5n 0.5086 21600.0n 0.5007 22199.5n 0.5007 22200.0n 0.5023 22799.5n 0.5023 22800.0n 0.5021 23399.5n 0.5021 23400.0n 0.5077 23999.5n 0.5077 24000.0n 0.4979 24599.5n 0.4979 24600.0n 0.5035 25199.5n 0.5035 25200.0n 0.5041 25799.5n 0.5041 25800.0n 0.5075 26399.5n 0.5075 26400.0n 0.5041 26999.5n 0.5041 27000.0n 0.5056 27599.5n 0.5056 27600.0n 0.5039 28199.5n 0.5039 28200.0n 0.5059 28799.5n 0.5059 28800.0n 0.5023 29399.5n 0.5023 29400.0n 0.5086 29999.5n 0.5086 30000.0n 0.5084 30599.5n 0.5084 30600.0n 0.5085 31199.5n 0.5085 31200.0n 0.5088 31799.5n 0.5088 31800.0n 0.5078 32399.5n 0.5078 32400.0n 0.5074 32999.5n 0.5074 33000.0n 0.4996 33599.5n 0.4996 33600.0n 0.5010 34199.5n 0.5010 34200.0n 0.5044 34799.5n 0.5044 34800.0n 0.5084 35399.5n 0.5084 35400.0n 0.5012 35999.5n 0.5012)
Vyn_who_2_1 yn_who_2_1 0 PWL(0.0n 0.4929 599.5n 0.4929 600.0n 0.4947 1199.5n 0.4947 1200.0n 0.4948 1799.5n 0.4948 1800.0n 0.4973 2399.5n 0.4973 2400.0n 0.4966 2999.5n 0.4966 3000.0n 0.4945 3599.5n 0.4945 3600.0n 0.4944 4199.5n 0.4944 4200.0n 0.4929 4799.5n 0.4929 4800.0n 0.4944 5399.5n 0.4944 5400.0n 0.4944 5999.5n 0.4944 6000.0n 0.4952 6599.5n 0.4952 6600.0n 0.4940 7199.5n 0.4940 7200.0n 0.4952 7799.5n 0.4952 7800.0n 0.4954 8399.5n 0.4954 8400.0n 0.4934 8999.5n 0.4934 9000.0n 0.4944 9599.5n 0.4944 9600.0n 0.4949 10199.5n 0.4949 10200.0n 0.4954 10799.5n 0.4954 10800.0n 0.4944 11399.5n 0.4944 11400.0n 0.4942 11999.5n 0.4942 12000.0n 0.4932 12599.5n 0.4932 12600.0n 0.4950 13199.5n 0.4950 13200.0n 0.4929 13799.5n 0.4929 13800.0n 0.4941 14399.5n 0.4941 14400.0n 0.4942 14999.5n 0.4942 15000.0n 0.4957 15599.5n 0.4957 15600.0n 0.4933 16199.5n 0.4933 16200.0n 0.4932 16799.5n 0.4932 16800.0n 0.4934 17399.5n 0.4934 17400.0n 0.4931 17999.5n 0.4931 18000.0n 0.4939 18599.5n 0.4939 18600.0n 0.4966 19199.5n 0.4966 19200.0n 0.4990 19799.5n 0.4990 19800.0n 0.5011 20399.5n 0.5011 20400.0n 0.4978 20999.5n 0.4978 21000.0n 0.4914 21599.5n 0.4914 21600.0n 0.4993 22199.5n 0.4993 22200.0n 0.4977 22799.5n 0.4977 22800.0n 0.4979 23399.5n 0.4979 23400.0n 0.4923 23999.5n 0.4923 24000.0n 0.5021 24599.5n 0.5021 24600.0n 0.4965 25199.5n 0.4965 25200.0n 0.4959 25799.5n 0.4959 25800.0n 0.4925 26399.5n 0.4925 26400.0n 0.4959 26999.5n 0.4959 27000.0n 0.4944 27599.5n 0.4944 27600.0n 0.4961 28199.5n 0.4961 28200.0n 0.4941 28799.5n 0.4941 28800.0n 0.4977 29399.5n 0.4977 29400.0n 0.4914 29999.5n 0.4914 30000.0n 0.4916 30599.5n 0.4916 30600.0n 0.4915 31199.5n 0.4915 31200.0n 0.4912 31799.5n 0.4912 31800.0n 0.4922 32399.5n 0.4922 32400.0n 0.4926 32999.5n 0.4926 33000.0n 0.5004 33599.5n 0.5004 33600.0n 0.4990 34199.5n 0.4990 34200.0n 0.4956 34799.5n 0.4956 34800.0n 0.4916 35399.5n 0.4916 35400.0n 0.4988 35999.5n 0.4988)
Cwp_who_2_1 wp_who_2_1 0 400p
Cwn_who_2_1 wn_who_2_1 0 400p
Xu_who_2_1 xp_who_2_1 xn_who_2_1 yp_who_2_1 yn_who_2_1 wp_who_2_1 wn_who_2_1 vdd gbn gprod
Vxp_bh_2 xp_bh_2 0 PWL(0.0n 0.7100 599.5n 0.7100 600.0n 0.7100 1199.5n 0.7100 1200.0n 0.7100 1799.5n 0.7100 1800.0n 0.7100 2399.5n 0.7100 2400.0n 0.7100 2999.5n 0.7100 3000.0n 0.7100 3599.5n 0.7100 3600.0n 0.7100 4199.5n 0.7100 4200.0n 0.7100 4799.5n 0.7100 4800.0n 0.7100 5399.5n 0.7100 5400.0n 0.7100 5999.5n 0.7100 6000.0n 0.7100 6599.5n 0.7100 6600.0n 0.7100 7199.5n 0.7100 7200.0n 0.7100 7799.5n 0.7100 7800.0n 0.7100 8399.5n 0.7100 8400.0n 0.7100 8999.5n 0.7100 9000.0n 0.7100 9599.5n 0.7100 9600.0n 0.7100 10199.5n 0.7100 10200.0n 0.7100 10799.5n 0.7100 10800.0n 0.7100 11399.5n 0.7100 11400.0n 0.7100 11999.5n 0.7100 12000.0n 0.7100 12599.5n 0.7100 12600.0n 0.7100 13199.5n 0.7100 13200.0n 0.7100 13799.5n 0.7100 13800.0n 0.7100 14399.5n 0.7100 14400.0n 0.7100 14999.5n 0.7100 15000.0n 0.7100 15599.5n 0.7100 15600.0n 0.7100 16199.5n 0.7100 16200.0n 0.7100 16799.5n 0.7100 16800.0n 0.7100 17399.5n 0.7100 17400.0n 0.7100 17999.5n 0.7100 18000.0n 0.7100 18599.5n 0.7100 18600.0n 0.7100 19199.5n 0.7100 19200.0n 0.7100 19799.5n 0.7100 19800.0n 0.7100 20399.5n 0.7100 20400.0n 0.7100 20999.5n 0.7100 21000.0n 0.7100 21599.5n 0.7100 21600.0n 0.7100 22199.5n 0.7100 22200.0n 0.7100 22799.5n 0.7100 22800.0n 0.7100 23399.5n 0.7100 23400.0n 0.7100 23999.5n 0.7100 24000.0n 0.7100 24599.5n 0.7100 24600.0n 0.7100 25199.5n 0.7100 25200.0n 0.7100 25799.5n 0.7100 25800.0n 0.7100 26399.5n 0.7100 26400.0n 0.7100 26999.5n 0.7100 27000.0n 0.7100 27599.5n 0.7100 27600.0n 0.7100 28199.5n 0.7100 28200.0n 0.7100 28799.5n 0.7100 28800.0n 0.7100 29399.5n 0.7100 29400.0n 0.7100 29999.5n 0.7100 30000.0n 0.7100 30599.5n 0.7100 30600.0n 0.7100 31199.5n 0.7100 31200.0n 0.7100 31799.5n 0.7100 31800.0n 0.7100 32399.5n 0.7100 32400.0n 0.7100 32999.5n 0.7100 33000.0n 0.7100 33599.5n 0.7100 33600.0n 0.7100 34199.5n 0.7100 34200.0n 0.7100 34799.5n 0.7100 34800.0n 0.7100 35399.5n 0.7100 35400.0n 0.7100 35999.5n 0.7100)
Vxn_bh_2 xn_bh_2 0 PWL(0.0n 0.2900 599.5n 0.2900 600.0n 0.2900 1199.5n 0.2900 1200.0n 0.2900 1799.5n 0.2900 1800.0n 0.2900 2399.5n 0.2900 2400.0n 0.2900 2999.5n 0.2900 3000.0n 0.2900 3599.5n 0.2900 3600.0n 0.2900 4199.5n 0.2900 4200.0n 0.2900 4799.5n 0.2900 4800.0n 0.2900 5399.5n 0.2900 5400.0n 0.2900 5999.5n 0.2900 6000.0n 0.2900 6599.5n 0.2900 6600.0n 0.2900 7199.5n 0.2900 7200.0n 0.2900 7799.5n 0.2900 7800.0n 0.2900 8399.5n 0.2900 8400.0n 0.2900 8999.5n 0.2900 9000.0n 0.2900 9599.5n 0.2900 9600.0n 0.2900 10199.5n 0.2900 10200.0n 0.2900 10799.5n 0.2900 10800.0n 0.2900 11399.5n 0.2900 11400.0n 0.2900 11999.5n 0.2900 12000.0n 0.2900 12599.5n 0.2900 12600.0n 0.2900 13199.5n 0.2900 13200.0n 0.2900 13799.5n 0.2900 13800.0n 0.2900 14399.5n 0.2900 14400.0n 0.2900 14999.5n 0.2900 15000.0n 0.2900 15599.5n 0.2900 15600.0n 0.2900 16199.5n 0.2900 16200.0n 0.2900 16799.5n 0.2900 16800.0n 0.2900 17399.5n 0.2900 17400.0n 0.2900 17999.5n 0.2900 18000.0n 0.2900 18599.5n 0.2900 18600.0n 0.2900 19199.5n 0.2900 19200.0n 0.2900 19799.5n 0.2900 19800.0n 0.2900 20399.5n 0.2900 20400.0n 0.2900 20999.5n 0.2900 21000.0n 0.2900 21599.5n 0.2900 21600.0n 0.2900 22199.5n 0.2900 22200.0n 0.2900 22799.5n 0.2900 22800.0n 0.2900 23399.5n 0.2900 23400.0n 0.2900 23999.5n 0.2900 24000.0n 0.2900 24599.5n 0.2900 24600.0n 0.2900 25199.5n 0.2900 25200.0n 0.2900 25799.5n 0.2900 25800.0n 0.2900 26399.5n 0.2900 26400.0n 0.2900 26999.5n 0.2900 27000.0n 0.2900 27599.5n 0.2900 27600.0n 0.2900 28199.5n 0.2900 28200.0n 0.2900 28799.5n 0.2900 28800.0n 0.2900 29399.5n 0.2900 29400.0n 0.2900 29999.5n 0.2900 30000.0n 0.2900 30599.5n 0.2900 30600.0n 0.2900 31199.5n 0.2900 31200.0n 0.2900 31799.5n 0.2900 31800.0n 0.2900 32399.5n 0.2900 32400.0n 0.2900 32999.5n 0.2900 33000.0n 0.2900 33599.5n 0.2900 33600.0n 0.2900 34199.5n 0.2900 34200.0n 0.2900 34799.5n 0.2900 34800.0n 0.2900 35399.5n 0.2900 35400.0n 0.2900 35999.5n 0.2900)
Vyp_bh_2 yp_bh_2 0 PWL(0.0n 0.6382 599.5n 0.6382 600.0n 0.6529 1199.5n 0.6529 1200.0n 0.6332 1799.5n 0.6332 1800.0n 0.6482 2399.5n 0.6482 2400.0n 0.6499 2999.5n 0.6499 3000.0n 0.6450 3599.5n 0.6450 3600.0n 0.6322 4199.5n 0.6322 4200.0n 0.6353 4799.5n 0.6353 4800.0n 0.6410 5399.5n 0.6410 5400.0n 0.6415 5999.5n 0.6415 6000.0n 0.6355 6599.5n 0.6355 6600.0n 0.6377 7199.5n 0.6377 7200.0n 0.6517 7799.5n 0.6517 7800.0n 0.6523 8399.5n 0.6523 8400.0n 0.6265 8999.5n 0.6265 9000.0n 0.6413 9599.5n 0.6413 9600.0n 0.6448 10199.5n 0.6448 10200.0n 0.6495 10799.5n 0.6495 10800.0n 0.6278 11399.5n 0.6278 11400.0n 0.6404 11999.5n 0.6404 12000.0n 0.6215 12599.5n 0.6215 12600.0n 0.6454 13199.5n 0.6454 13200.0n 0.6409 13799.5n 0.6409 13800.0n 0.6476 14399.5n 0.6476 14400.0n 0.6413 14999.5n 0.6413 15000.0n 0.6484 15599.5n 0.6484 15600.0n 0.6347 16199.5n 0.6347 16200.0n 0.6454 16799.5n 0.6454 16800.0n 0.6243 17399.5n 0.6243 17400.0n 0.6425 17999.5n 0.6425 18000.0n 0.6088 18599.5n 0.6088 18600.0n 0.6615 19199.5n 0.6615 19200.0n 0.6514 19799.5n 0.6514 19800.0n 0.6641 20399.5n 0.6641 20400.0n 0.6406 20999.5n 0.6406 21000.0n 0.5806 21599.5n 0.5806 21600.0n 0.6632 22199.5n 0.6632 22200.0n 0.6630 22799.5n 0.6630 22800.0n 0.6382 23399.5n 0.6382 23400.0n 0.6544 23999.5n 0.6544 24000.0n 0.6635 24599.5n 0.6635 24600.0n 0.6630 25199.5n 0.6630 25200.0n 0.6227 25799.5n 0.6227 25800.0n 0.5809 26399.5n 0.5809 26400.0n 0.6171 26999.5n 0.6171 27000.0n 0.6084 27599.5n 0.6084 27600.0n 0.6193 28199.5n 0.6193 28200.0n 0.6596 28799.5n 0.6596 28800.0n 0.6372 29399.5n 0.6372 29400.0n 0.5806 29999.5n 0.5806 30000.0n 0.5783 30599.5n 0.5783 30600.0n 0.5765 31199.5n 0.5765 31200.0n 0.6117 31799.5n 0.6117 31800.0n 0.5801 32399.5n 0.5801 32400.0n 0.5819 32999.5n 0.5819 33000.0n 0.6564 33599.5n 0.6564 33600.0n 0.6500 34199.5n 0.6500 34200.0n 0.6621 34799.5n 0.6621 34800.0n 0.5729 35399.5n 0.5729 35400.0n 0.6502 35999.5n 0.6502)
Vyn_bh_2 yn_bh_2 0 PWL(0.0n 0.3618 599.5n 0.3618 600.0n 0.3471 1199.5n 0.3471 1200.0n 0.3668 1799.5n 0.3668 1800.0n 0.3518 2399.5n 0.3518 2400.0n 0.3501 2999.5n 0.3501 3000.0n 0.3550 3599.5n 0.3550 3600.0n 0.3678 4199.5n 0.3678 4200.0n 0.3647 4799.5n 0.3647 4800.0n 0.3590 5399.5n 0.3590 5400.0n 0.3585 5999.5n 0.3585 6000.0n 0.3645 6599.5n 0.3645 6600.0n 0.3623 7199.5n 0.3623 7200.0n 0.3483 7799.5n 0.3483 7800.0n 0.3477 8399.5n 0.3477 8400.0n 0.3735 8999.5n 0.3735 9000.0n 0.3587 9599.5n 0.3587 9600.0n 0.3552 10199.5n 0.3552 10200.0n 0.3505 10799.5n 0.3505 10800.0n 0.3722 11399.5n 0.3722 11400.0n 0.3596 11999.5n 0.3596 12000.0n 0.3785 12599.5n 0.3785 12600.0n 0.3546 13199.5n 0.3546 13200.0n 0.3591 13799.5n 0.3591 13800.0n 0.3524 14399.5n 0.3524 14400.0n 0.3587 14999.5n 0.3587 15000.0n 0.3516 15599.5n 0.3516 15600.0n 0.3653 16199.5n 0.3653 16200.0n 0.3546 16799.5n 0.3546 16800.0n 0.3757 17399.5n 0.3757 17400.0n 0.3575 17999.5n 0.3575 18000.0n 0.3912 18599.5n 0.3912 18600.0n 0.3385 19199.5n 0.3385 19200.0n 0.3486 19799.5n 0.3486 19800.0n 0.3359 20399.5n 0.3359 20400.0n 0.3594 20999.5n 0.3594 21000.0n 0.4194 21599.5n 0.4194 21600.0n 0.3368 22199.5n 0.3368 22200.0n 0.3370 22799.5n 0.3370 22800.0n 0.3618 23399.5n 0.3618 23400.0n 0.3456 23999.5n 0.3456 24000.0n 0.3365 24599.5n 0.3365 24600.0n 0.3370 25199.5n 0.3370 25200.0n 0.3773 25799.5n 0.3773 25800.0n 0.4191 26399.5n 0.4191 26400.0n 0.3829 26999.5n 0.3829 27000.0n 0.3916 27599.5n 0.3916 27600.0n 0.3807 28199.5n 0.3807 28200.0n 0.3404 28799.5n 0.3404 28800.0n 0.3628 29399.5n 0.3628 29400.0n 0.4194 29999.5n 0.4194 30000.0n 0.4217 30599.5n 0.4217 30600.0n 0.4235 31199.5n 0.4235 31200.0n 0.3883 31799.5n 0.3883 31800.0n 0.4199 32399.5n 0.4199 32400.0n 0.4181 32999.5n 0.4181 33000.0n 0.3436 33599.5n 0.3436 33600.0n 0.3500 34199.5n 0.3500 34200.0n 0.3379 34799.5n 0.3379 34800.0n 0.4271 35399.5n 0.4271 35400.0n 0.3498 35999.5n 0.3498)
Cwp_bh_2 wp_bh_2 0 400p
Cwn_bh_2 wn_bh_2 0 400p
Xu_bh_2 xp_bh_2 xn_bh_2 yp_bh_2 yn_bh_2 wp_bh_2 wn_bh_2 vdd gbn gprod
Vxp_wih_0_3 xp_wih_0_3 0 PWL(0.0n 0.4942 599.5n 0.4942 600.0n 0.5558 1199.5n 0.5558 1200.0n 0.4708 1799.5n 0.4708 1800.0n 0.5235 2399.5n 0.5235 2400.0n 0.5350 2999.5n 0.5350 3000.0n 0.5172 3599.5n 0.5172 3600.0n 0.4702 4199.5n 0.4702 4200.0n 0.4867 4799.5n 0.4867 4800.0n 0.4970 5399.5n 0.4970 5400.0n 0.4986 5999.5n 0.4986 6000.0n 0.4751 6599.5n 0.4751 6600.0n 0.4870 7199.5n 0.4870 7200.0n 0.5502 7799.5n 0.5502 7800.0n 0.5521 8399.5n 0.5521 8400.0n 0.4638 8999.5n 0.4638 9000.0n 0.4982 9599.5n 0.4982 9600.0n 0.5131 10199.5n 0.5131 10200.0n 0.5386 10799.5n 0.5386 10800.0n 0.4592 11399.5n 0.4592 11400.0n 0.4950 11999.5n 0.4950 12000.0n 0.4559 12599.5n 0.4559 12600.0n 0.5162 13199.5n 0.5162 13200.0n 0.5038 13799.5n 0.5038 13800.0n 0.5333 14399.5n 0.5333 14400.0n 0.4991 14999.5n 0.4991 15000.0n 0.5298 15599.5n 0.5298 15600.0n 0.4823 16199.5n 0.4823 16200.0n 0.5239 16799.5n 0.5239 16800.0n 0.4592 17399.5n 0.4592 17400.0n 0.5094 17999.5n 0.5094 18000.0n 0.4337 18599.5n 0.4337 18600.0n 0.5977 19199.5n 0.5977 19200.0n 0.5364 19799.5n 0.5364 19800.0n 0.6122 20399.5n 0.6122 20400.0n 0.4856 20999.5n 0.4856 21000.0n 0.3861 21599.5n 0.3861 21600.0n 0.6094 22199.5n 0.6094 22200.0n 0.6364 22799.5n 0.6364 22800.0n 0.4807 23399.5n 0.4807 23400.0n 0.5614 23999.5n 0.5614 24000.0n 0.5913 24599.5n 0.5913 24600.0n 0.6295 25199.5n 0.6295 25200.0n 0.4496 25799.5n 0.4496 25800.0n 0.3792 26399.5n 0.3792 26400.0n 0.4434 26999.5n 0.4434 27000.0n 0.4340 27599.5n 0.4340 27600.0n 0.4461 28199.5n 0.4461 28200.0n 0.5791 28799.5n 0.5791 28800.0n 0.4777 29399.5n 0.4777 29400.0n 0.3878 29999.5n 0.3878 30000.0n 0.3832 30599.5n 0.3832 30600.0n 0.4022 31199.5n 0.4022 31200.0n 0.4482 31799.5n 0.4482 31800.0n 0.3662 32399.5n 0.3662 32400.0n 0.3857 32999.5n 0.3857 33000.0n 0.5584 33599.5n 0.5584 33600.0n 0.5284 34199.5n 0.5284 34200.0n 0.6034 34799.5n 0.6034 34800.0n 0.3469 35399.5n 0.3469 35400.0n 0.5290 35999.5n 0.5290)
Vxn_wih_0_3 xn_wih_0_3 0 PWL(0.0n 0.5058 599.5n 0.5058 600.0n 0.4442 1199.5n 0.4442 1200.0n 0.5292 1799.5n 0.5292 1800.0n 0.4765 2399.5n 0.4765 2400.0n 0.4650 2999.5n 0.4650 3000.0n 0.4828 3599.5n 0.4828 3600.0n 0.5298 4199.5n 0.5298 4200.0n 0.5133 4799.5n 0.5133 4800.0n 0.5030 5399.5n 0.5030 5400.0n 0.5014 5999.5n 0.5014 6000.0n 0.5249 6599.5n 0.5249 6600.0n 0.5130 7199.5n 0.5130 7200.0n 0.4498 7799.5n 0.4498 7800.0n 0.4479 8399.5n 0.4479 8400.0n 0.5362 8999.5n 0.5362 9000.0n 0.5018 9599.5n 0.5018 9600.0n 0.4869 10199.5n 0.4869 10200.0n 0.4614 10799.5n 0.4614 10800.0n 0.5408 11399.5n 0.5408 11400.0n 0.5050 11999.5n 0.5050 12000.0n 0.5441 12599.5n 0.5441 12600.0n 0.4838 13199.5n 0.4838 13200.0n 0.4962 13799.5n 0.4962 13800.0n 0.4667 14399.5n 0.4667 14400.0n 0.5009 14999.5n 0.5009 15000.0n 0.4702 15599.5n 0.4702 15600.0n 0.5177 16199.5n 0.5177 16200.0n 0.4761 16799.5n 0.4761 16800.0n 0.5408 17399.5n 0.5408 17400.0n 0.4906 17999.5n 0.4906 18000.0n 0.5663 18599.5n 0.5663 18600.0n 0.4023 19199.5n 0.4023 19200.0n 0.4636 19799.5n 0.4636 19800.0n 0.3878 20399.5n 0.3878 20400.0n 0.5144 20999.5n 0.5144 21000.0n 0.6139 21599.5n 0.6139 21600.0n 0.3906 22199.5n 0.3906 22200.0n 0.3636 22799.5n 0.3636 22800.0n 0.5193 23399.5n 0.5193 23400.0n 0.4386 23999.5n 0.4386 24000.0n 0.4087 24599.5n 0.4087 24600.0n 0.3705 25199.5n 0.3705 25200.0n 0.5504 25799.5n 0.5504 25800.0n 0.6208 26399.5n 0.6208 26400.0n 0.5566 26999.5n 0.5566 27000.0n 0.5660 27599.5n 0.5660 27600.0n 0.5539 28199.5n 0.5539 28200.0n 0.4209 28799.5n 0.4209 28800.0n 0.5223 29399.5n 0.5223 29400.0n 0.6122 29999.5n 0.6122 30000.0n 0.6168 30599.5n 0.6168 30600.0n 0.5978 31199.5n 0.5978 31200.0n 0.5518 31799.5n 0.5518 31800.0n 0.6338 32399.5n 0.6338 32400.0n 0.6143 32999.5n 0.6143 33000.0n 0.4416 33599.5n 0.4416 33600.0n 0.4716 34199.5n 0.4716 34200.0n 0.3966 34799.5n 0.3966 34800.0n 0.6531 35399.5n 0.6531 35400.0n 0.4710 35999.5n 0.4710)
Vyp_wih_0_3 yp_wih_0_3 0 PWL(0.0n 0.3959 599.5n 0.3959 600.0n 0.4245 1199.5n 0.4245 1200.0n 0.3656 1799.5n 0.3656 1800.0n 0.3736 2399.5n 0.3736 2400.0n 0.3865 2999.5n 0.3865 3000.0n 0.3948 3599.5n 0.3948 3600.0n 0.3699 4199.5n 0.3699 4200.0n 0.3933 4799.5n 0.3933 4800.0n 0.3849 5399.5n 0.3849 5400.0n 0.3853 5999.5n 0.3853 6000.0n 0.3645 6599.5n 0.3645 6600.0n 0.3835 7199.5n 0.3835 7200.0n 0.4139 7799.5n 0.4139 7800.0n 0.4139 8399.5n 0.4139 8400.0n 0.3785 8999.5n 0.3785 9000.0n 0.3854 9599.5n 0.3854 9600.0n 0.3879 10199.5n 0.3879 10200.0n 0.3997 10799.5n 0.3997 10800.0n 0.3599 11399.5n 0.3599 11400.0n 0.3855 11999.5n 0.3855 12000.0n 0.3757 12599.5n 0.3757 12600.0n 0.3885 13199.5n 0.3885 13200.0n 0.4006 13799.5n 0.4006 13800.0n 0.4088 14399.5n 0.4088 14400.0n 0.3880 14999.5n 0.3880 15000.0n 0.3899 15599.5n 0.3899 15600.0n 0.3873 16199.5n 0.3873 16200.0n 0.4095 16799.5n 0.4095 16800.0n 0.3748 17399.5n 0.3748 17400.0n 0.4014 17999.5n 0.4014 18000.0n 0.3363 18599.5n 0.3363 18600.0n 0.4604 19199.5n 0.4604 19200.0n 0.3563 19799.5n 0.3563 19800.0n 0.4264 20399.5n 0.4264 20400.0n 0.3439 20999.5n 0.3439 21000.0n 0.3368 21599.5n 0.3368 21600.0n 0.4426 22199.5n 0.4426 22200.0n 0.4668 22799.5n 0.4668 22800.0n 0.3417 23399.5n 0.3417 23400.0n 0.4846 23999.5n 0.4846 24000.0n 0.4003 24599.5n 0.4003 24600.0n 0.4735 25199.5n 0.4735 25200.0n 0.3386 25799.5n 0.3386 25800.0n 0.3269 26399.5n 0.3269 26400.0n 0.3352 26999.5n 0.3352 27000.0n 0.3345 27599.5n 0.3345 27600.0n 0.3358 28199.5n 0.3358 28200.0n 0.5002 28799.5n 0.5002 28800.0n 0.3416 29399.5n 0.3416 29400.0n 0.3382 29999.5n 0.3382 30000.0n 0.3402 30599.5n 0.3402 30600.0n 0.3757 31199.5n 0.3757 31200.0n 0.4118 31799.5n 0.4118 31800.0n 0.3277 32399.5n 0.3277 32400.0n 0.3270 32999.5n 0.3270 33000.0n 0.3699 33599.5n 0.3699 33600.0n 0.3494 34199.5n 0.3494 34200.0n 0.4748 34799.5n 0.4748 34800.0n 0.3438 35399.5n 0.3438 35400.0n 0.3514 35999.5n 0.3514)
Vyn_wih_0_3 yn_wih_0_3 0 PWL(0.0n 0.6041 599.5n 0.6041 600.0n 0.5755 1199.5n 0.5755 1200.0n 0.6344 1799.5n 0.6344 1800.0n 0.6264 2399.5n 0.6264 2400.0n 0.6135 2999.5n 0.6135 3000.0n 0.6052 3599.5n 0.6052 3600.0n 0.6301 4199.5n 0.6301 4200.0n 0.6067 4799.5n 0.6067 4800.0n 0.6151 5399.5n 0.6151 5400.0n 0.6147 5999.5n 0.6147 6000.0n 0.6355 6599.5n 0.6355 6600.0n 0.6165 7199.5n 0.6165 7200.0n 0.5861 7799.5n 0.5861 7800.0n 0.5861 8399.5n 0.5861 8400.0n 0.6215 8999.5n 0.6215 9000.0n 0.6146 9599.5n 0.6146 9600.0n 0.6121 10199.5n 0.6121 10200.0n 0.6003 10799.5n 0.6003 10800.0n 0.6401 11399.5n 0.6401 11400.0n 0.6145 11999.5n 0.6145 12000.0n 0.6243 12599.5n 0.6243 12600.0n 0.6115 13199.5n 0.6115 13200.0n 0.5994 13799.5n 0.5994 13800.0n 0.5912 14399.5n 0.5912 14400.0n 0.6120 14999.5n 0.6120 15000.0n 0.6101 15599.5n 0.6101 15600.0n 0.6127 16199.5n 0.6127 16200.0n 0.5905 16799.5n 0.5905 16800.0n 0.6252 17399.5n 0.6252 17400.0n 0.5986 17999.5n 0.5986 18000.0n 0.6637 18599.5n 0.6637 18600.0n 0.5396 19199.5n 0.5396 19200.0n 0.6437 19799.5n 0.6437 19800.0n 0.5736 20399.5n 0.5736 20400.0n 0.6561 20999.5n 0.6561 21000.0n 0.6632 21599.5n 0.6632 21600.0n 0.5574 22199.5n 0.5574 22200.0n 0.5332 22799.5n 0.5332 22800.0n 0.6583 23399.5n 0.6583 23400.0n 0.5154 23999.5n 0.5154 24000.0n 0.5997 24599.5n 0.5997 24600.0n 0.5265 25199.5n 0.5265 25200.0n 0.6614 25799.5n 0.6614 25800.0n 0.6731 26399.5n 0.6731 26400.0n 0.6648 26999.5n 0.6648 27000.0n 0.6655 27599.5n 0.6655 27600.0n 0.6642 28199.5n 0.6642 28200.0n 0.4998 28799.5n 0.4998 28800.0n 0.6584 29399.5n 0.6584 29400.0n 0.6618 29999.5n 0.6618 30000.0n 0.6598 30599.5n 0.6598 30600.0n 0.6243 31199.5n 0.6243 31200.0n 0.5882 31799.5n 0.5882 31800.0n 0.6723 32399.5n 0.6723 32400.0n 0.6730 32999.5n 0.6730 33000.0n 0.6301 33599.5n 0.6301 33600.0n 0.6506 34199.5n 0.6506 34200.0n 0.5252 34799.5n 0.5252 34800.0n 0.6562 35399.5n 0.6562 35400.0n 0.6486 35999.5n 0.6486)
Cwp_wih_0_3 wp_wih_0_3 0 400p
Cwn_wih_0_3 wn_wih_0_3 0 400p
Xu_wih_0_3 xp_wih_0_3 xn_wih_0_3 yp_wih_0_3 yn_wih_0_3 wp_wih_0_3 wn_wih_0_3 vdd gbn gprod
Vxp_wih_1_3 xp_wih_1_3 0 PWL(0.0n 0.5370 599.5n 0.5370 600.0n 0.5167 1199.5n 0.5167 1200.0n 0.4793 1799.5n 0.4793 1800.0n 0.4441 2399.5n 0.4441 2400.0n 0.4555 2999.5n 0.4555 3000.0n 0.5055 3599.5n 0.5055 3600.0n 0.4939 4199.5n 0.4939 4200.0n 0.5385 4799.5n 0.5385 4800.0n 0.5024 5399.5n 0.5024 5400.0n 0.5015 5999.5n 0.5015 6000.0n 0.4700 6599.5n 0.4700 6600.0n 0.5120 7199.5n 0.5120 7200.0n 0.5006 7799.5n 0.5006 7800.0n 0.4950 8399.5n 0.4950 8400.0n 0.5309 8999.5n 0.5309 9000.0n 0.5023 9599.5n 0.5023 9600.0n 0.4893 10199.5n 0.4893 10200.0n 0.4837 10799.5n 0.4837 10800.0n 0.4823 11399.5n 0.4823 11400.0n 0.5074 11999.5n 0.5074 12000.0n 0.5364 12599.5n 0.5364 12600.0n 0.4868 13199.5n 0.4868 13200.0n 0.5380 13799.5n 0.5380 13800.0n 0.5220 14399.5n 0.5220 14400.0n 0.5095 14999.5n 0.5095 15000.0n 0.4705 15599.5n 0.4705 15600.0n 0.5289 16199.5n 0.5289 16200.0n 0.5368 16799.5n 0.5368 16800.0n 0.5287 17399.5n 0.5287 17400.0n 0.5342 17999.5n 0.5342 18000.0n 0.4253 18599.5n 0.4253 18600.0n 0.5119 19199.5n 0.5119 19200.0n 0.4104 19799.5n 0.4104 19800.0n 0.4314 20399.5n 0.4314 20400.0n 0.4005 20999.5n 0.4005 21000.0n 0.4696 21599.5n 0.4696 21600.0n 0.4531 22199.5n 0.4531 22200.0n 0.5039 22799.5n 0.5039 22800.0n 0.3608 23399.5n 0.3608 23400.0n 0.6273 23999.5n 0.6273 24000.0n 0.3928 24599.5n 0.3928 24600.0n 0.5253 25199.5n 0.5253 25200.0n 0.4107 25799.5n 0.4107 25800.0n 0.3947 26399.5n 0.3947 26400.0n 0.3716 26999.5n 0.3716 27000.0n 0.4111 27599.5n 0.4111 27600.0n 0.3715 28199.5n 0.3715 28200.0n 0.5939 28799.5n 0.5939 28800.0n 0.3849 29399.5n 0.3849 29400.0n 0.4835 29999.5n 0.4835 30000.0n 0.5119 30599.5n 0.5119 30600.0n 0.6226 31199.5n 0.6226 31200.0n 0.6064 31799.5n 0.6064 31800.0n 0.4115 32399.5n 0.4115 32400.0n 0.3900 32999.5n 0.3900 33000.0n 0.3958 33599.5n 0.3958 33600.0n 0.3747 34199.5n 0.3747 34200.0n 0.5423 34799.5n 0.5423 34800.0n 0.5509 35399.5n 0.5509 35400.0n 0.3990 35999.5n 0.3990)
Vxn_wih_1_3 xn_wih_1_3 0 PWL(0.0n 0.4630 599.5n 0.4630 600.0n 0.4833 1199.5n 0.4833 1200.0n 0.5207 1799.5n 0.5207 1800.0n 0.5559 2399.5n 0.5559 2400.0n 0.5445 2999.5n 0.5445 3000.0n 0.4945 3599.5n 0.4945 3600.0n 0.5061 4199.5n 0.5061 4200.0n 0.4615 4799.5n 0.4615 4800.0n 0.4976 5399.5n 0.4976 5400.0n 0.4985 5999.5n 0.4985 6000.0n 0.5300 6599.5n 0.5300 6600.0n 0.4880 7199.5n 0.4880 7200.0n 0.4994 7799.5n 0.4994 7800.0n 0.5050 8399.5n 0.5050 8400.0n 0.4691 8999.5n 0.4691 9000.0n 0.4977 9599.5n 0.4977 9600.0n 0.5107 10199.5n 0.5107 10200.0n 0.5163 10799.5n 0.5163 10800.0n 0.5177 11399.5n 0.5177 11400.0n 0.4926 11999.5n 0.4926 12000.0n 0.4636 12599.5n 0.4636 12600.0n 0.5132 13199.5n 0.5132 13200.0n 0.4620 13799.5n 0.4620 13800.0n 0.4780 14399.5n 0.4780 14400.0n 0.4905 14999.5n 0.4905 15000.0n 0.5295 15599.5n 0.5295 15600.0n 0.4711 16199.5n 0.4711 16200.0n 0.4632 16799.5n 0.4632 16800.0n 0.4713 17399.5n 0.4713 17400.0n 0.4658 17999.5n 0.4658 18000.0n 0.5747 18599.5n 0.5747 18600.0n 0.4881 19199.5n 0.4881 19200.0n 0.5896 19799.5n 0.5896 19800.0n 0.5686 20399.5n 0.5686 20400.0n 0.5995 20999.5n 0.5995 21000.0n 0.5304 21599.5n 0.5304 21600.0n 0.5469 22199.5n 0.5469 22200.0n 0.4961 22799.5n 0.4961 22800.0n 0.6392 23399.5n 0.6392 23400.0n 0.3727 23999.5n 0.3727 24000.0n 0.6072 24599.5n 0.6072 24600.0n 0.4747 25199.5n 0.4747 25200.0n 0.5893 25799.5n 0.5893 25800.0n 0.6053 26399.5n 0.6053 26400.0n 0.6284 26999.5n 0.6284 27000.0n 0.5889 27599.5n 0.5889 27600.0n 0.6285 28199.5n 0.6285 28200.0n 0.4061 28799.5n 0.4061 28800.0n 0.6151 29399.5n 0.6151 29400.0n 0.5165 29999.5n 0.5165 30000.0n 0.4881 30599.5n 0.4881 30600.0n 0.3774 31199.5n 0.3774 31200.0n 0.3936 31799.5n 0.3936 31800.0n 0.5885 32399.5n 0.5885 32400.0n 0.6100 32999.5n 0.6100 33000.0n 0.6042 33599.5n 0.6042 33600.0n 0.6253 34199.5n 0.6253 34200.0n 0.4577 34799.5n 0.4577 34800.0n 0.4491 35399.5n 0.4491 35400.0n 0.6010 35999.5n 0.6010)
Vyp_wih_1_3 yp_wih_1_3 0 PWL(0.0n 0.3959 599.5n 0.3959 600.0n 0.4245 1199.5n 0.4245 1200.0n 0.3656 1799.5n 0.3656 1800.0n 0.3736 2399.5n 0.3736 2400.0n 0.3865 2999.5n 0.3865 3000.0n 0.3948 3599.5n 0.3948 3600.0n 0.3699 4199.5n 0.3699 4200.0n 0.3933 4799.5n 0.3933 4800.0n 0.3849 5399.5n 0.3849 5400.0n 0.3853 5999.5n 0.3853 6000.0n 0.3645 6599.5n 0.3645 6600.0n 0.3835 7199.5n 0.3835 7200.0n 0.4139 7799.5n 0.4139 7800.0n 0.4139 8399.5n 0.4139 8400.0n 0.3785 8999.5n 0.3785 9000.0n 0.3854 9599.5n 0.3854 9600.0n 0.3879 10199.5n 0.3879 10200.0n 0.3997 10799.5n 0.3997 10800.0n 0.3599 11399.5n 0.3599 11400.0n 0.3855 11999.5n 0.3855 12000.0n 0.3757 12599.5n 0.3757 12600.0n 0.3885 13199.5n 0.3885 13200.0n 0.4006 13799.5n 0.4006 13800.0n 0.4088 14399.5n 0.4088 14400.0n 0.3880 14999.5n 0.3880 15000.0n 0.3899 15599.5n 0.3899 15600.0n 0.3873 16199.5n 0.3873 16200.0n 0.4095 16799.5n 0.4095 16800.0n 0.3748 17399.5n 0.3748 17400.0n 0.4014 17999.5n 0.4014 18000.0n 0.3363 18599.5n 0.3363 18600.0n 0.4604 19199.5n 0.4604 19200.0n 0.3563 19799.5n 0.3563 19800.0n 0.4264 20399.5n 0.4264 20400.0n 0.3439 20999.5n 0.3439 21000.0n 0.3368 21599.5n 0.3368 21600.0n 0.4426 22199.5n 0.4426 22200.0n 0.4668 22799.5n 0.4668 22800.0n 0.3417 23399.5n 0.3417 23400.0n 0.4846 23999.5n 0.4846 24000.0n 0.4003 24599.5n 0.4003 24600.0n 0.4735 25199.5n 0.4735 25200.0n 0.3386 25799.5n 0.3386 25800.0n 0.3269 26399.5n 0.3269 26400.0n 0.3352 26999.5n 0.3352 27000.0n 0.3345 27599.5n 0.3345 27600.0n 0.3358 28199.5n 0.3358 28200.0n 0.5002 28799.5n 0.5002 28800.0n 0.3416 29399.5n 0.3416 29400.0n 0.3382 29999.5n 0.3382 30000.0n 0.3402 30599.5n 0.3402 30600.0n 0.3757 31199.5n 0.3757 31200.0n 0.4118 31799.5n 0.4118 31800.0n 0.3277 32399.5n 0.3277 32400.0n 0.3270 32999.5n 0.3270 33000.0n 0.3699 33599.5n 0.3699 33600.0n 0.3494 34199.5n 0.3494 34200.0n 0.4748 34799.5n 0.4748 34800.0n 0.3438 35399.5n 0.3438 35400.0n 0.3514 35999.5n 0.3514)
Vyn_wih_1_3 yn_wih_1_3 0 PWL(0.0n 0.6041 599.5n 0.6041 600.0n 0.5755 1199.5n 0.5755 1200.0n 0.6344 1799.5n 0.6344 1800.0n 0.6264 2399.5n 0.6264 2400.0n 0.6135 2999.5n 0.6135 3000.0n 0.6052 3599.5n 0.6052 3600.0n 0.6301 4199.5n 0.6301 4200.0n 0.6067 4799.5n 0.6067 4800.0n 0.6151 5399.5n 0.6151 5400.0n 0.6147 5999.5n 0.6147 6000.0n 0.6355 6599.5n 0.6355 6600.0n 0.6165 7199.5n 0.6165 7200.0n 0.5861 7799.5n 0.5861 7800.0n 0.5861 8399.5n 0.5861 8400.0n 0.6215 8999.5n 0.6215 9000.0n 0.6146 9599.5n 0.6146 9600.0n 0.6121 10199.5n 0.6121 10200.0n 0.6003 10799.5n 0.6003 10800.0n 0.6401 11399.5n 0.6401 11400.0n 0.6145 11999.5n 0.6145 12000.0n 0.6243 12599.5n 0.6243 12600.0n 0.6115 13199.5n 0.6115 13200.0n 0.5994 13799.5n 0.5994 13800.0n 0.5912 14399.5n 0.5912 14400.0n 0.6120 14999.5n 0.6120 15000.0n 0.6101 15599.5n 0.6101 15600.0n 0.6127 16199.5n 0.6127 16200.0n 0.5905 16799.5n 0.5905 16800.0n 0.6252 17399.5n 0.6252 17400.0n 0.5986 17999.5n 0.5986 18000.0n 0.6637 18599.5n 0.6637 18600.0n 0.5396 19199.5n 0.5396 19200.0n 0.6437 19799.5n 0.6437 19800.0n 0.5736 20399.5n 0.5736 20400.0n 0.6561 20999.5n 0.6561 21000.0n 0.6632 21599.5n 0.6632 21600.0n 0.5574 22199.5n 0.5574 22200.0n 0.5332 22799.5n 0.5332 22800.0n 0.6583 23399.5n 0.6583 23400.0n 0.5154 23999.5n 0.5154 24000.0n 0.5997 24599.5n 0.5997 24600.0n 0.5265 25199.5n 0.5265 25200.0n 0.6614 25799.5n 0.6614 25800.0n 0.6731 26399.5n 0.6731 26400.0n 0.6648 26999.5n 0.6648 27000.0n 0.6655 27599.5n 0.6655 27600.0n 0.6642 28199.5n 0.6642 28200.0n 0.4998 28799.5n 0.4998 28800.0n 0.6584 29399.5n 0.6584 29400.0n 0.6618 29999.5n 0.6618 30000.0n 0.6598 30599.5n 0.6598 30600.0n 0.6243 31199.5n 0.6243 31200.0n 0.5882 31799.5n 0.5882 31800.0n 0.6723 32399.5n 0.6723 32400.0n 0.6730 32999.5n 0.6730 33000.0n 0.6301 33599.5n 0.6301 33600.0n 0.6506 34199.5n 0.6506 34200.0n 0.5252 34799.5n 0.5252 34800.0n 0.6562 35399.5n 0.6562 35400.0n 0.6486 35999.5n 0.6486)
Cwp_wih_1_3 wp_wih_1_3 0 400p
Cwn_wih_1_3 wn_wih_1_3 0 400p
Xu_wih_1_3 xp_wih_1_3 xn_wih_1_3 yp_wih_1_3 yn_wih_1_3 wp_wih_1_3 wn_wih_1_3 vdd gbn gprod
Vxp_who_3_0 xp_who_3_0 0 PWL(0.0n 0.3959 599.5n 0.3959 600.0n 0.4245 1199.5n 0.4245 1200.0n 0.3656 1799.5n 0.3656 1800.0n 0.3736 2399.5n 0.3736 2400.0n 0.3865 2999.5n 0.3865 3000.0n 0.3948 3599.5n 0.3948 3600.0n 0.3699 4199.5n 0.3699 4200.0n 0.3933 4799.5n 0.3933 4800.0n 0.3849 5399.5n 0.3849 5400.0n 0.3853 5999.5n 0.3853 6000.0n 0.3645 6599.5n 0.3645 6600.0n 0.3835 7199.5n 0.3835 7200.0n 0.4139 7799.5n 0.4139 7800.0n 0.4139 8399.5n 0.4139 8400.0n 0.3785 8999.5n 0.3785 9000.0n 0.3854 9599.5n 0.3854 9600.0n 0.3879 10199.5n 0.3879 10200.0n 0.3997 10799.5n 0.3997 10800.0n 0.3599 11399.5n 0.3599 11400.0n 0.3855 11999.5n 0.3855 12000.0n 0.3757 12599.5n 0.3757 12600.0n 0.3885 13199.5n 0.3885 13200.0n 0.4006 13799.5n 0.4006 13800.0n 0.4088 14399.5n 0.4088 14400.0n 0.3880 14999.5n 0.3880 15000.0n 0.3899 15599.5n 0.3899 15600.0n 0.3873 16199.5n 0.3873 16200.0n 0.4095 16799.5n 0.4095 16800.0n 0.3748 17399.5n 0.3748 17400.0n 0.4014 17999.5n 0.4014 18000.0n 0.3363 18599.5n 0.3363 18600.0n 0.4604 19199.5n 0.4604 19200.0n 0.3563 19799.5n 0.3563 19800.0n 0.4264 20399.5n 0.4264 20400.0n 0.3439 20999.5n 0.3439 21000.0n 0.3368 21599.5n 0.3368 21600.0n 0.4426 22199.5n 0.4426 22200.0n 0.4668 22799.5n 0.4668 22800.0n 0.3417 23399.5n 0.3417 23400.0n 0.4846 23999.5n 0.4846 24000.0n 0.4003 24599.5n 0.4003 24600.0n 0.4735 25199.5n 0.4735 25200.0n 0.3386 25799.5n 0.3386 25800.0n 0.3269 26399.5n 0.3269 26400.0n 0.3352 26999.5n 0.3352 27000.0n 0.3345 27599.5n 0.3345 27600.0n 0.3358 28199.5n 0.3358 28200.0n 0.5002 28799.5n 0.5002 28800.0n 0.3416 29399.5n 0.3416 29400.0n 0.3382 29999.5n 0.3382 30000.0n 0.3402 30599.5n 0.3402 30600.0n 0.3757 31199.5n 0.3757 31200.0n 0.4118 31799.5n 0.4118 31800.0n 0.3277 32399.5n 0.3277 32400.0n 0.3270 32999.5n 0.3270 33000.0n 0.3699 33599.5n 0.3699 33600.0n 0.3494 34199.5n 0.3494 34200.0n 0.4748 34799.5n 0.4748 34800.0n 0.3438 35399.5n 0.3438 35400.0n 0.3514 35999.5n 0.3514)
Vxn_who_3_0 xn_who_3_0 0 PWL(0.0n 0.6041 599.5n 0.6041 600.0n 0.5755 1199.5n 0.5755 1200.0n 0.6344 1799.5n 0.6344 1800.0n 0.6264 2399.5n 0.6264 2400.0n 0.6135 2999.5n 0.6135 3000.0n 0.6052 3599.5n 0.6052 3600.0n 0.6301 4199.5n 0.6301 4200.0n 0.6067 4799.5n 0.6067 4800.0n 0.6151 5399.5n 0.6151 5400.0n 0.6147 5999.5n 0.6147 6000.0n 0.6355 6599.5n 0.6355 6600.0n 0.6165 7199.5n 0.6165 7200.0n 0.5861 7799.5n 0.5861 7800.0n 0.5861 8399.5n 0.5861 8400.0n 0.6215 8999.5n 0.6215 9000.0n 0.6146 9599.5n 0.6146 9600.0n 0.6121 10199.5n 0.6121 10200.0n 0.6003 10799.5n 0.6003 10800.0n 0.6401 11399.5n 0.6401 11400.0n 0.6145 11999.5n 0.6145 12000.0n 0.6243 12599.5n 0.6243 12600.0n 0.6115 13199.5n 0.6115 13200.0n 0.5994 13799.5n 0.5994 13800.0n 0.5912 14399.5n 0.5912 14400.0n 0.6120 14999.5n 0.6120 15000.0n 0.6101 15599.5n 0.6101 15600.0n 0.6127 16199.5n 0.6127 16200.0n 0.5905 16799.5n 0.5905 16800.0n 0.6252 17399.5n 0.6252 17400.0n 0.5986 17999.5n 0.5986 18000.0n 0.6637 18599.5n 0.6637 18600.0n 0.5396 19199.5n 0.5396 19200.0n 0.6437 19799.5n 0.6437 19800.0n 0.5736 20399.5n 0.5736 20400.0n 0.6561 20999.5n 0.6561 21000.0n 0.6632 21599.5n 0.6632 21600.0n 0.5574 22199.5n 0.5574 22200.0n 0.5332 22799.5n 0.5332 22800.0n 0.6583 23399.5n 0.6583 23400.0n 0.5154 23999.5n 0.5154 24000.0n 0.5997 24599.5n 0.5997 24600.0n 0.5265 25199.5n 0.5265 25200.0n 0.6614 25799.5n 0.6614 25800.0n 0.6731 26399.5n 0.6731 26400.0n 0.6648 26999.5n 0.6648 27000.0n 0.6655 27599.5n 0.6655 27600.0n 0.6642 28199.5n 0.6642 28200.0n 0.4998 28799.5n 0.4998 28800.0n 0.6584 29399.5n 0.6584 29400.0n 0.6618 29999.5n 0.6618 30000.0n 0.6598 30599.5n 0.6598 30600.0n 0.6243 31199.5n 0.6243 31200.0n 0.5882 31799.5n 0.5882 31800.0n 0.6723 32399.5n 0.6723 32400.0n 0.6730 32999.5n 0.6730 33000.0n 0.6301 33599.5n 0.6301 33600.0n 0.6506 34199.5n 0.6506 34200.0n 0.5252 34799.5n 0.5252 34800.0n 0.6562 35399.5n 0.6562 35400.0n 0.6486 35999.5n 0.6486)
Vyp_who_3_0 yp_who_3_0 0 PWL(0.0n 0.5031 599.5n 0.5031 600.0n 0.5023 1199.5n 0.5023 1200.0n 0.5052 1799.5n 0.5052 1800.0n 0.5048 2399.5n 0.5048 2400.0n 0.5043 2999.5n 0.5043 3000.0n 0.5034 3599.5n 0.5034 3600.0n 0.5048 4199.5n 0.5048 4200.0n 0.5031 4799.5n 0.5031 4800.0n 0.5040 5399.5n 0.5040 5400.0n 0.5040 5999.5n 0.5040 6000.0n 0.5054 6599.5n 0.5054 6600.0n 0.5040 7199.5n 0.5040 7200.0n 0.5027 7799.5n 0.5027 7800.0n 0.5027 8399.5n 0.5027 8400.0n 0.5038 8999.5n 0.5038 9000.0n 0.5040 9599.5n 0.5040 9600.0n 0.5039 10199.5n 0.5039 10200.0n 0.5033 10799.5n 0.5033 10800.0n 0.5056 11399.5n 0.5056 11400.0n 0.5040 11999.5n 0.5040 12000.0n 0.5036 12599.5n 0.5036 12600.0n 0.5039 13199.5n 0.5039 13200.0n 0.5029 13799.5n 0.5029 13800.0n 0.5025 14399.5n 0.5025 14400.0n 0.5038 14999.5n 0.5038 15000.0n 0.5041 15599.5n 0.5041 15600.0n 0.5036 16199.5n 0.5036 16200.0n 0.5025 16799.5n 0.5025 16800.0n 0.5040 17399.5n 0.5040 17400.0n 0.5029 17999.5n 0.5029 18000.0n 0.5057 18599.5n 0.5057 18600.0n 0.5010 19199.5n 0.5010 19200.0n 0.5041 19799.5n 0.5041 19800.0n 0.5021 20399.5n 0.5021 20400.0n 0.5044 20999.5n 0.5044 21000.0n 0.5056 21599.5n 0.5056 21600.0n 0.5016 22199.5n 0.5016 22200.0n 0.5006 22799.5n 0.5006 22800.0n 0.5041 23399.5n 0.5041 23400.0n 0.5027 23999.5n 0.5027 24000.0n 0.5029 24599.5n 0.5029 24600.0n 0.5006 25199.5n 0.5006 25200.0n 0.5047 25799.5n 0.5047 25800.0n 0.5046 26399.5n 0.5046 26400.0n 0.5039 26999.5n 0.5039 27000.0n 0.5049 27599.5n 0.5049 27600.0n 0.5039 28199.5n 0.5039 28200.0n 0.5017 28799.5n 0.5017 28800.0n 0.5042 29399.5n 0.5042 29400.0n 0.5056 29999.5n 0.5056 30000.0n 0.5051 30599.5n 0.5051 30600.0n 0.5039 31199.5n 0.5039 31200.0n 0.5033 31799.5n 0.5033 31800.0n 0.5049 32399.5n 0.5049 32400.0n 0.5045 32999.5n 0.5045 33000.0n 0.5036 33599.5n 0.5036 33600.0n 0.5042 34199.5n 0.5042 34200.0n 0.5012 34799.5n 0.5012 34800.0n 0.5036 35399.5n 0.5036 35400.0n 0.5042 35999.5n 0.5042)
Vyn_who_3_0 yn_who_3_0 0 PWL(0.0n 0.4969 599.5n 0.4969 600.0n 0.4977 1199.5n 0.4977 1200.0n 0.4948 1799.5n 0.4948 1800.0n 0.4952 2399.5n 0.4952 2400.0n 0.4957 2999.5n 0.4957 3000.0n 0.4966 3599.5n 0.4966 3600.0n 0.4952 4199.5n 0.4952 4200.0n 0.4969 4799.5n 0.4969 4800.0n 0.4960 5399.5n 0.4960 5400.0n 0.4960 5999.5n 0.4960 6000.0n 0.4946 6599.5n 0.4946 6600.0n 0.4960 7199.5n 0.4960 7200.0n 0.4973 7799.5n 0.4973 7800.0n 0.4973 8399.5n 0.4973 8400.0n 0.4962 8999.5n 0.4962 9000.0n 0.4960 9599.5n 0.4960 9600.0n 0.4961 10199.5n 0.4961 10200.0n 0.4967 10799.5n 0.4967 10800.0n 0.4944 11399.5n 0.4944 11400.0n 0.4960 11999.5n 0.4960 12000.0n 0.4964 12599.5n 0.4964 12600.0n 0.4961 13199.5n 0.4961 13200.0n 0.4971 13799.5n 0.4971 13800.0n 0.4975 14399.5n 0.4975 14400.0n 0.4962 14999.5n 0.4962 15000.0n 0.4959 15599.5n 0.4959 15600.0n 0.4964 16199.5n 0.4964 16200.0n 0.4975 16799.5n 0.4975 16800.0n 0.4960 17399.5n 0.4960 17400.0n 0.4971 17999.5n 0.4971 18000.0n 0.4943 18599.5n 0.4943 18600.0n 0.4990 19199.5n 0.4990 19200.0n 0.4959 19799.5n 0.4959 19800.0n 0.4979 20399.5n 0.4979 20400.0n 0.4956 20999.5n 0.4956 21000.0n 0.4944 21599.5n 0.4944 21600.0n 0.4984 22199.5n 0.4984 22200.0n 0.4994 22799.5n 0.4994 22800.0n 0.4959 23399.5n 0.4959 23400.0n 0.4973 23999.5n 0.4973 24000.0n 0.4971 24599.5n 0.4971 24600.0n 0.4994 25199.5n 0.4994 25200.0n 0.4953 25799.5n 0.4953 25800.0n 0.4954 26399.5n 0.4954 26400.0n 0.4961 26999.5n 0.4961 27000.0n 0.4951 27599.5n 0.4951 27600.0n 0.4961 28199.5n 0.4961 28200.0n 0.4983 28799.5n 0.4983 28800.0n 0.4958 29399.5n 0.4958 29400.0n 0.4944 29999.5n 0.4944 30000.0n 0.4949 30599.5n 0.4949 30600.0n 0.4961 31199.5n 0.4961 31200.0n 0.4967 31799.5n 0.4967 31800.0n 0.4951 32399.5n 0.4951 32400.0n 0.4955 32999.5n 0.4955 33000.0n 0.4964 33599.5n 0.4964 33600.0n 0.4958 34199.5n 0.4958 34200.0n 0.4988 34799.5n 0.4988 34800.0n 0.4964 35399.5n 0.4964 35400.0n 0.4958 35999.5n 0.4958)
Cwp_who_3_0 wp_who_3_0 0 400p
Cwn_who_3_0 wn_who_3_0 0 400p
Xu_who_3_0 xp_who_3_0 xn_who_3_0 yp_who_3_0 yn_who_3_0 wp_who_3_0 wn_who_3_0 vdd gbn gprod
Vxp_who_3_1 xp_who_3_1 0 PWL(0.0n 0.3959 599.5n 0.3959 600.0n 0.4245 1199.5n 0.4245 1200.0n 0.3656 1799.5n 0.3656 1800.0n 0.3736 2399.5n 0.3736 2400.0n 0.3865 2999.5n 0.3865 3000.0n 0.3948 3599.5n 0.3948 3600.0n 0.3699 4199.5n 0.3699 4200.0n 0.3933 4799.5n 0.3933 4800.0n 0.3849 5399.5n 0.3849 5400.0n 0.3853 5999.5n 0.3853 6000.0n 0.3645 6599.5n 0.3645 6600.0n 0.3835 7199.5n 0.3835 7200.0n 0.4139 7799.5n 0.4139 7800.0n 0.4139 8399.5n 0.4139 8400.0n 0.3785 8999.5n 0.3785 9000.0n 0.3854 9599.5n 0.3854 9600.0n 0.3879 10199.5n 0.3879 10200.0n 0.3997 10799.5n 0.3997 10800.0n 0.3599 11399.5n 0.3599 11400.0n 0.3855 11999.5n 0.3855 12000.0n 0.3757 12599.5n 0.3757 12600.0n 0.3885 13199.5n 0.3885 13200.0n 0.4006 13799.5n 0.4006 13800.0n 0.4088 14399.5n 0.4088 14400.0n 0.3880 14999.5n 0.3880 15000.0n 0.3899 15599.5n 0.3899 15600.0n 0.3873 16199.5n 0.3873 16200.0n 0.4095 16799.5n 0.4095 16800.0n 0.3748 17399.5n 0.3748 17400.0n 0.4014 17999.5n 0.4014 18000.0n 0.3363 18599.5n 0.3363 18600.0n 0.4604 19199.5n 0.4604 19200.0n 0.3563 19799.5n 0.3563 19800.0n 0.4264 20399.5n 0.4264 20400.0n 0.3439 20999.5n 0.3439 21000.0n 0.3368 21599.5n 0.3368 21600.0n 0.4426 22199.5n 0.4426 22200.0n 0.4668 22799.5n 0.4668 22800.0n 0.3417 23399.5n 0.3417 23400.0n 0.4846 23999.5n 0.4846 24000.0n 0.4003 24599.5n 0.4003 24600.0n 0.4735 25199.5n 0.4735 25200.0n 0.3386 25799.5n 0.3386 25800.0n 0.3269 26399.5n 0.3269 26400.0n 0.3352 26999.5n 0.3352 27000.0n 0.3345 27599.5n 0.3345 27600.0n 0.3358 28199.5n 0.3358 28200.0n 0.5002 28799.5n 0.5002 28800.0n 0.3416 29399.5n 0.3416 29400.0n 0.3382 29999.5n 0.3382 30000.0n 0.3402 30599.5n 0.3402 30600.0n 0.3757 31199.5n 0.3757 31200.0n 0.4118 31799.5n 0.4118 31800.0n 0.3277 32399.5n 0.3277 32400.0n 0.3270 32999.5n 0.3270 33000.0n 0.3699 33599.5n 0.3699 33600.0n 0.3494 34199.5n 0.3494 34200.0n 0.4748 34799.5n 0.4748 34800.0n 0.3438 35399.5n 0.3438 35400.0n 0.3514 35999.5n 0.3514)
Vxn_who_3_1 xn_who_3_1 0 PWL(0.0n 0.6041 599.5n 0.6041 600.0n 0.5755 1199.5n 0.5755 1200.0n 0.6344 1799.5n 0.6344 1800.0n 0.6264 2399.5n 0.6264 2400.0n 0.6135 2999.5n 0.6135 3000.0n 0.6052 3599.5n 0.6052 3600.0n 0.6301 4199.5n 0.6301 4200.0n 0.6067 4799.5n 0.6067 4800.0n 0.6151 5399.5n 0.6151 5400.0n 0.6147 5999.5n 0.6147 6000.0n 0.6355 6599.5n 0.6355 6600.0n 0.6165 7199.5n 0.6165 7200.0n 0.5861 7799.5n 0.5861 7800.0n 0.5861 8399.5n 0.5861 8400.0n 0.6215 8999.5n 0.6215 9000.0n 0.6146 9599.5n 0.6146 9600.0n 0.6121 10199.5n 0.6121 10200.0n 0.6003 10799.5n 0.6003 10800.0n 0.6401 11399.5n 0.6401 11400.0n 0.6145 11999.5n 0.6145 12000.0n 0.6243 12599.5n 0.6243 12600.0n 0.6115 13199.5n 0.6115 13200.0n 0.5994 13799.5n 0.5994 13800.0n 0.5912 14399.5n 0.5912 14400.0n 0.6120 14999.5n 0.6120 15000.0n 0.6101 15599.5n 0.6101 15600.0n 0.6127 16199.5n 0.6127 16200.0n 0.5905 16799.5n 0.5905 16800.0n 0.6252 17399.5n 0.6252 17400.0n 0.5986 17999.5n 0.5986 18000.0n 0.6637 18599.5n 0.6637 18600.0n 0.5396 19199.5n 0.5396 19200.0n 0.6437 19799.5n 0.6437 19800.0n 0.5736 20399.5n 0.5736 20400.0n 0.6561 20999.5n 0.6561 21000.0n 0.6632 21599.5n 0.6632 21600.0n 0.5574 22199.5n 0.5574 22200.0n 0.5332 22799.5n 0.5332 22800.0n 0.6583 23399.5n 0.6583 23400.0n 0.5154 23999.5n 0.5154 24000.0n 0.5997 24599.5n 0.5997 24600.0n 0.5265 25199.5n 0.5265 25200.0n 0.6614 25799.5n 0.6614 25800.0n 0.6731 26399.5n 0.6731 26400.0n 0.6648 26999.5n 0.6648 27000.0n 0.6655 27599.5n 0.6655 27600.0n 0.6642 28199.5n 0.6642 28200.0n 0.4998 28799.5n 0.4998 28800.0n 0.6584 29399.5n 0.6584 29400.0n 0.6618 29999.5n 0.6618 30000.0n 0.6598 30599.5n 0.6598 30600.0n 0.6243 31199.5n 0.6243 31200.0n 0.5882 31799.5n 0.5882 31800.0n 0.6723 32399.5n 0.6723 32400.0n 0.6730 32999.5n 0.6730 33000.0n 0.6301 33599.5n 0.6301 33600.0n 0.6506 34199.5n 0.6506 34200.0n 0.5252 34799.5n 0.5252 34800.0n 0.6562 35399.5n 0.6562 35400.0n 0.6486 35999.5n 0.6486)
Vyp_who_3_1 yp_who_3_1 0 PWL(0.0n 0.5071 599.5n 0.5071 600.0n 0.5053 1199.5n 0.5053 1200.0n 0.5052 1799.5n 0.5052 1800.0n 0.5027 2399.5n 0.5027 2400.0n 0.5034 2999.5n 0.5034 3000.0n 0.5055 3599.5n 0.5055 3600.0n 0.5056 4199.5n 0.5056 4200.0n 0.5071 4799.5n 0.5071 4800.0n 0.5056 5399.5n 0.5056 5400.0n 0.5056 5999.5n 0.5056 6000.0n 0.5048 6599.5n 0.5048 6600.0n 0.5060 7199.5n 0.5060 7200.0n 0.5048 7799.5n 0.5048 7800.0n 0.5046 8399.5n 0.5046 8400.0n 0.5066 8999.5n 0.5066 9000.0n 0.5056 9599.5n 0.5056 9600.0n 0.5051 10199.5n 0.5051 10200.0n 0.5046 10799.5n 0.5046 10800.0n 0.5056 11399.5n 0.5056 11400.0n 0.5058 11999.5n 0.5058 12000.0n 0.5068 12599.5n 0.5068 12600.0n 0.5050 13199.5n 0.5050 13200.0n 0.5071 13799.5n 0.5071 13800.0n 0.5059 14399.5n 0.5059 14400.0n 0.5058 14999.5n 0.5058 15000.0n 0.5043 15599.5n 0.5043 15600.0n 0.5067 16199.5n 0.5067 16200.0n 0.5068 16799.5n 0.5068 16800.0n 0.5066 17399.5n 0.5066 17400.0n 0.5069 17999.5n 0.5069 18000.0n 0.5061 18599.5n 0.5061 18600.0n 0.5034 19199.5n 0.5034 19200.0n 0.5010 19799.5n 0.5010 19800.0n 0.4989 20399.5n 0.4989 20400.0n 0.5022 20999.5n 0.5022 21000.0n 0.5086 21599.5n 0.5086 21600.0n 0.5007 22199.5n 0.5007 22200.0n 0.5023 22799.5n 0.5023 22800.0n 0.5021 23399.5n 0.5021 23400.0n 0.5077 23999.5n 0.5077 24000.0n 0.4979 24599.5n 0.4979 24600.0n 0.5035 25199.5n 0.5035 25200.0n 0.5041 25799.5n 0.5041 25800.0n 0.5075 26399.5n 0.5075 26400.0n 0.5041 26999.5n 0.5041 27000.0n 0.5056 27599.5n 0.5056 27600.0n 0.5039 28199.5n 0.5039 28200.0n 0.5059 28799.5n 0.5059 28800.0n 0.5023 29399.5n 0.5023 29400.0n 0.5086 29999.5n 0.5086 30000.0n 0.5084 30599.5n 0.5084 30600.0n 0.5085 31199.5n 0.5085 31200.0n 0.5088 31799.5n 0.5088 31800.0n 0.5078 32399.5n 0.5078 32400.0n 0.5074 32999.5n 0.5074 33000.0n 0.4996 33599.5n 0.4996 33600.0n 0.5010 34199.5n 0.5010 34200.0n 0.5044 34799.5n 0.5044 34800.0n 0.5084 35399.5n 0.5084 35400.0n 0.5012 35999.5n 0.5012)
Vyn_who_3_1 yn_who_3_1 0 PWL(0.0n 0.4929 599.5n 0.4929 600.0n 0.4947 1199.5n 0.4947 1200.0n 0.4948 1799.5n 0.4948 1800.0n 0.4973 2399.5n 0.4973 2400.0n 0.4966 2999.5n 0.4966 3000.0n 0.4945 3599.5n 0.4945 3600.0n 0.4944 4199.5n 0.4944 4200.0n 0.4929 4799.5n 0.4929 4800.0n 0.4944 5399.5n 0.4944 5400.0n 0.4944 5999.5n 0.4944 6000.0n 0.4952 6599.5n 0.4952 6600.0n 0.4940 7199.5n 0.4940 7200.0n 0.4952 7799.5n 0.4952 7800.0n 0.4954 8399.5n 0.4954 8400.0n 0.4934 8999.5n 0.4934 9000.0n 0.4944 9599.5n 0.4944 9600.0n 0.4949 10199.5n 0.4949 10200.0n 0.4954 10799.5n 0.4954 10800.0n 0.4944 11399.5n 0.4944 11400.0n 0.4942 11999.5n 0.4942 12000.0n 0.4932 12599.5n 0.4932 12600.0n 0.4950 13199.5n 0.4950 13200.0n 0.4929 13799.5n 0.4929 13800.0n 0.4941 14399.5n 0.4941 14400.0n 0.4942 14999.5n 0.4942 15000.0n 0.4957 15599.5n 0.4957 15600.0n 0.4933 16199.5n 0.4933 16200.0n 0.4932 16799.5n 0.4932 16800.0n 0.4934 17399.5n 0.4934 17400.0n 0.4931 17999.5n 0.4931 18000.0n 0.4939 18599.5n 0.4939 18600.0n 0.4966 19199.5n 0.4966 19200.0n 0.4990 19799.5n 0.4990 19800.0n 0.5011 20399.5n 0.5011 20400.0n 0.4978 20999.5n 0.4978 21000.0n 0.4914 21599.5n 0.4914 21600.0n 0.4993 22199.5n 0.4993 22200.0n 0.4977 22799.5n 0.4977 22800.0n 0.4979 23399.5n 0.4979 23400.0n 0.4923 23999.5n 0.4923 24000.0n 0.5021 24599.5n 0.5021 24600.0n 0.4965 25199.5n 0.4965 25200.0n 0.4959 25799.5n 0.4959 25800.0n 0.4925 26399.5n 0.4925 26400.0n 0.4959 26999.5n 0.4959 27000.0n 0.4944 27599.5n 0.4944 27600.0n 0.4961 28199.5n 0.4961 28200.0n 0.4941 28799.5n 0.4941 28800.0n 0.4977 29399.5n 0.4977 29400.0n 0.4914 29999.5n 0.4914 30000.0n 0.4916 30599.5n 0.4916 30600.0n 0.4915 31199.5n 0.4915 31200.0n 0.4912 31799.5n 0.4912 31800.0n 0.4922 32399.5n 0.4922 32400.0n 0.4926 32999.5n 0.4926 33000.0n 0.5004 33599.5n 0.5004 33600.0n 0.4990 34199.5n 0.4990 34200.0n 0.4956 34799.5n 0.4956 34800.0n 0.4916 35399.5n 0.4916 35400.0n 0.4988 35999.5n 0.4988)
Cwp_who_3_1 wp_who_3_1 0 400p
Cwn_who_3_1 wn_who_3_1 0 400p
Xu_who_3_1 xp_who_3_1 xn_who_3_1 yp_who_3_1 yn_who_3_1 wp_who_3_1 wn_who_3_1 vdd gbn gprod
Vxp_bh_3 xp_bh_3 0 PWL(0.0n 0.7100 599.5n 0.7100 600.0n 0.7100 1199.5n 0.7100 1200.0n 0.7100 1799.5n 0.7100 1800.0n 0.7100 2399.5n 0.7100 2400.0n 0.7100 2999.5n 0.7100 3000.0n 0.7100 3599.5n 0.7100 3600.0n 0.7100 4199.5n 0.7100 4200.0n 0.7100 4799.5n 0.7100 4800.0n 0.7100 5399.5n 0.7100 5400.0n 0.7100 5999.5n 0.7100 6000.0n 0.7100 6599.5n 0.7100 6600.0n 0.7100 7199.5n 0.7100 7200.0n 0.7100 7799.5n 0.7100 7800.0n 0.7100 8399.5n 0.7100 8400.0n 0.7100 8999.5n 0.7100 9000.0n 0.7100 9599.5n 0.7100 9600.0n 0.7100 10199.5n 0.7100 10200.0n 0.7100 10799.5n 0.7100 10800.0n 0.7100 11399.5n 0.7100 11400.0n 0.7100 11999.5n 0.7100 12000.0n 0.7100 12599.5n 0.7100 12600.0n 0.7100 13199.5n 0.7100 13200.0n 0.7100 13799.5n 0.7100 13800.0n 0.7100 14399.5n 0.7100 14400.0n 0.7100 14999.5n 0.7100 15000.0n 0.7100 15599.5n 0.7100 15600.0n 0.7100 16199.5n 0.7100 16200.0n 0.7100 16799.5n 0.7100 16800.0n 0.7100 17399.5n 0.7100 17400.0n 0.7100 17999.5n 0.7100 18000.0n 0.7100 18599.5n 0.7100 18600.0n 0.7100 19199.5n 0.7100 19200.0n 0.7100 19799.5n 0.7100 19800.0n 0.7100 20399.5n 0.7100 20400.0n 0.7100 20999.5n 0.7100 21000.0n 0.7100 21599.5n 0.7100 21600.0n 0.7100 22199.5n 0.7100 22200.0n 0.7100 22799.5n 0.7100 22800.0n 0.7100 23399.5n 0.7100 23400.0n 0.7100 23999.5n 0.7100 24000.0n 0.7100 24599.5n 0.7100 24600.0n 0.7100 25199.5n 0.7100 25200.0n 0.7100 25799.5n 0.7100 25800.0n 0.7100 26399.5n 0.7100 26400.0n 0.7100 26999.5n 0.7100 27000.0n 0.7100 27599.5n 0.7100 27600.0n 0.7100 28199.5n 0.7100 28200.0n 0.7100 28799.5n 0.7100 28800.0n 0.7100 29399.5n 0.7100 29400.0n 0.7100 29999.5n 0.7100 30000.0n 0.7100 30599.5n 0.7100 30600.0n 0.7100 31199.5n 0.7100 31200.0n 0.7100 31799.5n 0.7100 31800.0n 0.7100 32399.5n 0.7100 32400.0n 0.7100 32999.5n 0.7100 33000.0n 0.7100 33599.5n 0.7100 33600.0n 0.7100 34199.5n 0.7100 34200.0n 0.7100 34799.5n 0.7100 34800.0n 0.7100 35399.5n 0.7100 35400.0n 0.7100 35999.5n 0.7100)
Vxn_bh_3 xn_bh_3 0 PWL(0.0n 0.2900 599.5n 0.2900 600.0n 0.2900 1199.5n 0.2900 1200.0n 0.2900 1799.5n 0.2900 1800.0n 0.2900 2399.5n 0.2900 2400.0n 0.2900 2999.5n 0.2900 3000.0n 0.2900 3599.5n 0.2900 3600.0n 0.2900 4199.5n 0.2900 4200.0n 0.2900 4799.5n 0.2900 4800.0n 0.2900 5399.5n 0.2900 5400.0n 0.2900 5999.5n 0.2900 6000.0n 0.2900 6599.5n 0.2900 6600.0n 0.2900 7199.5n 0.2900 7200.0n 0.2900 7799.5n 0.2900 7800.0n 0.2900 8399.5n 0.2900 8400.0n 0.2900 8999.5n 0.2900 9000.0n 0.2900 9599.5n 0.2900 9600.0n 0.2900 10199.5n 0.2900 10200.0n 0.2900 10799.5n 0.2900 10800.0n 0.2900 11399.5n 0.2900 11400.0n 0.2900 11999.5n 0.2900 12000.0n 0.2900 12599.5n 0.2900 12600.0n 0.2900 13199.5n 0.2900 13200.0n 0.2900 13799.5n 0.2900 13800.0n 0.2900 14399.5n 0.2900 14400.0n 0.2900 14999.5n 0.2900 15000.0n 0.2900 15599.5n 0.2900 15600.0n 0.2900 16199.5n 0.2900 16200.0n 0.2900 16799.5n 0.2900 16800.0n 0.2900 17399.5n 0.2900 17400.0n 0.2900 17999.5n 0.2900 18000.0n 0.2900 18599.5n 0.2900 18600.0n 0.2900 19199.5n 0.2900 19200.0n 0.2900 19799.5n 0.2900 19800.0n 0.2900 20399.5n 0.2900 20400.0n 0.2900 20999.5n 0.2900 21000.0n 0.2900 21599.5n 0.2900 21600.0n 0.2900 22199.5n 0.2900 22200.0n 0.2900 22799.5n 0.2900 22800.0n 0.2900 23399.5n 0.2900 23400.0n 0.2900 23999.5n 0.2900 24000.0n 0.2900 24599.5n 0.2900 24600.0n 0.2900 25199.5n 0.2900 25200.0n 0.2900 25799.5n 0.2900 25800.0n 0.2900 26399.5n 0.2900 26400.0n 0.2900 26999.5n 0.2900 27000.0n 0.2900 27599.5n 0.2900 27600.0n 0.2900 28199.5n 0.2900 28200.0n 0.2900 28799.5n 0.2900 28800.0n 0.2900 29399.5n 0.2900 29400.0n 0.2900 29999.5n 0.2900 30000.0n 0.2900 30599.5n 0.2900 30600.0n 0.2900 31199.5n 0.2900 31200.0n 0.2900 31799.5n 0.2900 31800.0n 0.2900 32399.5n 0.2900 32400.0n 0.2900 32999.5n 0.2900 33000.0n 0.2900 33599.5n 0.2900 33600.0n 0.2900 34199.5n 0.2900 34200.0n 0.2900 34799.5n 0.2900 34800.0n 0.2900 35399.5n 0.2900 35400.0n 0.2900 35999.5n 0.2900)
Vyp_bh_3 yp_bh_3 0 PWL(0.0n 0.3959 599.5n 0.3959 600.0n 0.4245 1199.5n 0.4245 1200.0n 0.3656 1799.5n 0.3656 1800.0n 0.3736 2399.5n 0.3736 2400.0n 0.3865 2999.5n 0.3865 3000.0n 0.3948 3599.5n 0.3948 3600.0n 0.3699 4199.5n 0.3699 4200.0n 0.3933 4799.5n 0.3933 4800.0n 0.3849 5399.5n 0.3849 5400.0n 0.3853 5999.5n 0.3853 6000.0n 0.3645 6599.5n 0.3645 6600.0n 0.3835 7199.5n 0.3835 7200.0n 0.4139 7799.5n 0.4139 7800.0n 0.4139 8399.5n 0.4139 8400.0n 0.3785 8999.5n 0.3785 9000.0n 0.3854 9599.5n 0.3854 9600.0n 0.3879 10199.5n 0.3879 10200.0n 0.3997 10799.5n 0.3997 10800.0n 0.3599 11399.5n 0.3599 11400.0n 0.3855 11999.5n 0.3855 12000.0n 0.3757 12599.5n 0.3757 12600.0n 0.3885 13199.5n 0.3885 13200.0n 0.4006 13799.5n 0.4006 13800.0n 0.4088 14399.5n 0.4088 14400.0n 0.3880 14999.5n 0.3880 15000.0n 0.3899 15599.5n 0.3899 15600.0n 0.3873 16199.5n 0.3873 16200.0n 0.4095 16799.5n 0.4095 16800.0n 0.3748 17399.5n 0.3748 17400.0n 0.4014 17999.5n 0.4014 18000.0n 0.3363 18599.5n 0.3363 18600.0n 0.4604 19199.5n 0.4604 19200.0n 0.3563 19799.5n 0.3563 19800.0n 0.4264 20399.5n 0.4264 20400.0n 0.3439 20999.5n 0.3439 21000.0n 0.3368 21599.5n 0.3368 21600.0n 0.4426 22199.5n 0.4426 22200.0n 0.4668 22799.5n 0.4668 22800.0n 0.3417 23399.5n 0.3417 23400.0n 0.4846 23999.5n 0.4846 24000.0n 0.4003 24599.5n 0.4003 24600.0n 0.4735 25199.5n 0.4735 25200.0n 0.3386 25799.5n 0.3386 25800.0n 0.3269 26399.5n 0.3269 26400.0n 0.3352 26999.5n 0.3352 27000.0n 0.3345 27599.5n 0.3345 27600.0n 0.3358 28199.5n 0.3358 28200.0n 0.5002 28799.5n 0.5002 28800.0n 0.3416 29399.5n 0.3416 29400.0n 0.3382 29999.5n 0.3382 30000.0n 0.3402 30599.5n 0.3402 30600.0n 0.3757 31199.5n 0.3757 31200.0n 0.4118 31799.5n 0.4118 31800.0n 0.3277 32399.5n 0.3277 32400.0n 0.3270 32999.5n 0.3270 33000.0n 0.3699 33599.5n 0.3699 33600.0n 0.3494 34199.5n 0.3494 34200.0n 0.4748 34799.5n 0.4748 34800.0n 0.3438 35399.5n 0.3438 35400.0n 0.3514 35999.5n 0.3514)
Vyn_bh_3 yn_bh_3 0 PWL(0.0n 0.6041 599.5n 0.6041 600.0n 0.5755 1199.5n 0.5755 1200.0n 0.6344 1799.5n 0.6344 1800.0n 0.6264 2399.5n 0.6264 2400.0n 0.6135 2999.5n 0.6135 3000.0n 0.6052 3599.5n 0.6052 3600.0n 0.6301 4199.5n 0.6301 4200.0n 0.6067 4799.5n 0.6067 4800.0n 0.6151 5399.5n 0.6151 5400.0n 0.6147 5999.5n 0.6147 6000.0n 0.6355 6599.5n 0.6355 6600.0n 0.6165 7199.5n 0.6165 7200.0n 0.5861 7799.5n 0.5861 7800.0n 0.5861 8399.5n 0.5861 8400.0n 0.6215 8999.5n 0.6215 9000.0n 0.6146 9599.5n 0.6146 9600.0n 0.6121 10199.5n 0.6121 10200.0n 0.6003 10799.5n 0.6003 10800.0n 0.6401 11399.5n 0.6401 11400.0n 0.6145 11999.5n 0.6145 12000.0n 0.6243 12599.5n 0.6243 12600.0n 0.6115 13199.5n 0.6115 13200.0n 0.5994 13799.5n 0.5994 13800.0n 0.5912 14399.5n 0.5912 14400.0n 0.6120 14999.5n 0.6120 15000.0n 0.6101 15599.5n 0.6101 15600.0n 0.6127 16199.5n 0.6127 16200.0n 0.5905 16799.5n 0.5905 16800.0n 0.6252 17399.5n 0.6252 17400.0n 0.5986 17999.5n 0.5986 18000.0n 0.6637 18599.5n 0.6637 18600.0n 0.5396 19199.5n 0.5396 19200.0n 0.6437 19799.5n 0.6437 19800.0n 0.5736 20399.5n 0.5736 20400.0n 0.6561 20999.5n 0.6561 21000.0n 0.6632 21599.5n 0.6632 21600.0n 0.5574 22199.5n 0.5574 22200.0n 0.5332 22799.5n 0.5332 22800.0n 0.6583 23399.5n 0.6583 23400.0n 0.5154 23999.5n 0.5154 24000.0n 0.5997 24599.5n 0.5997 24600.0n 0.5265 25199.5n 0.5265 25200.0n 0.6614 25799.5n 0.6614 25800.0n 0.6731 26399.5n 0.6731 26400.0n 0.6648 26999.5n 0.6648 27000.0n 0.6655 27599.5n 0.6655 27600.0n 0.6642 28199.5n 0.6642 28200.0n 0.4998 28799.5n 0.4998 28800.0n 0.6584 29399.5n 0.6584 29400.0n 0.6618 29999.5n 0.6618 30000.0n 0.6598 30599.5n 0.6598 30600.0n 0.6243 31199.5n 0.6243 31200.0n 0.5882 31799.5n 0.5882 31800.0n 0.6723 32399.5n 0.6723 32400.0n 0.6730 32999.5n 0.6730 33000.0n 0.6301 33599.5n 0.6301 33600.0n 0.6506 34199.5n 0.6506 34200.0n 0.5252 34799.5n 0.5252 34800.0n 0.6562 35399.5n 0.6562 35400.0n 0.6486 35999.5n 0.6486)
Cwp_bh_3 wp_bh_3 0 400p
Cwn_bh_3 wn_bh_3 0 400p
Xu_bh_3 xp_bh_3 xn_bh_3 yp_bh_3 yn_bh_3 wp_bh_3 wn_bh_3 vdd gbn gprod
Vxp_wih_0_4 xp_wih_0_4 0 PWL(0.0n 0.4942 599.5n 0.4942 600.0n 0.5558 1199.5n 0.5558 1200.0n 0.4708 1799.5n 0.4708 1800.0n 0.5235 2399.5n 0.5235 2400.0n 0.5350 2999.5n 0.5350 3000.0n 0.5172 3599.5n 0.5172 3600.0n 0.4702 4199.5n 0.4702 4200.0n 0.4867 4799.5n 0.4867 4800.0n 0.4970 5399.5n 0.4970 5400.0n 0.4986 5999.5n 0.4986 6000.0n 0.4751 6599.5n 0.4751 6600.0n 0.4870 7199.5n 0.4870 7200.0n 0.5502 7799.5n 0.5502 7800.0n 0.5521 8399.5n 0.5521 8400.0n 0.4638 8999.5n 0.4638 9000.0n 0.4982 9599.5n 0.4982 9600.0n 0.5131 10199.5n 0.5131 10200.0n 0.5386 10799.5n 0.5386 10800.0n 0.4592 11399.5n 0.4592 11400.0n 0.4950 11999.5n 0.4950 12000.0n 0.4559 12599.5n 0.4559 12600.0n 0.5162 13199.5n 0.5162 13200.0n 0.5038 13799.5n 0.5038 13800.0n 0.5333 14399.5n 0.5333 14400.0n 0.4991 14999.5n 0.4991 15000.0n 0.5298 15599.5n 0.5298 15600.0n 0.4823 16199.5n 0.4823 16200.0n 0.5239 16799.5n 0.5239 16800.0n 0.4592 17399.5n 0.4592 17400.0n 0.5094 17999.5n 0.5094 18000.0n 0.4337 18599.5n 0.4337 18600.0n 0.5977 19199.5n 0.5977 19200.0n 0.5364 19799.5n 0.5364 19800.0n 0.6122 20399.5n 0.6122 20400.0n 0.4856 20999.5n 0.4856 21000.0n 0.3861 21599.5n 0.3861 21600.0n 0.6094 22199.5n 0.6094 22200.0n 0.6364 22799.5n 0.6364 22800.0n 0.4807 23399.5n 0.4807 23400.0n 0.5614 23999.5n 0.5614 24000.0n 0.5913 24599.5n 0.5913 24600.0n 0.6295 25199.5n 0.6295 25200.0n 0.4496 25799.5n 0.4496 25800.0n 0.3792 26399.5n 0.3792 26400.0n 0.4434 26999.5n 0.4434 27000.0n 0.4340 27599.5n 0.4340 27600.0n 0.4461 28199.5n 0.4461 28200.0n 0.5791 28799.5n 0.5791 28800.0n 0.4777 29399.5n 0.4777 29400.0n 0.3878 29999.5n 0.3878 30000.0n 0.3832 30599.5n 0.3832 30600.0n 0.4022 31199.5n 0.4022 31200.0n 0.4482 31799.5n 0.4482 31800.0n 0.3662 32399.5n 0.3662 32400.0n 0.3857 32999.5n 0.3857 33000.0n 0.5584 33599.5n 0.5584 33600.0n 0.5284 34199.5n 0.5284 34200.0n 0.6034 34799.5n 0.6034 34800.0n 0.3469 35399.5n 0.3469 35400.0n 0.5290 35999.5n 0.5290)
Vxn_wih_0_4 xn_wih_0_4 0 PWL(0.0n 0.5058 599.5n 0.5058 600.0n 0.4442 1199.5n 0.4442 1200.0n 0.5292 1799.5n 0.5292 1800.0n 0.4765 2399.5n 0.4765 2400.0n 0.4650 2999.5n 0.4650 3000.0n 0.4828 3599.5n 0.4828 3600.0n 0.5298 4199.5n 0.5298 4200.0n 0.5133 4799.5n 0.5133 4800.0n 0.5030 5399.5n 0.5030 5400.0n 0.5014 5999.5n 0.5014 6000.0n 0.5249 6599.5n 0.5249 6600.0n 0.5130 7199.5n 0.5130 7200.0n 0.4498 7799.5n 0.4498 7800.0n 0.4479 8399.5n 0.4479 8400.0n 0.5362 8999.5n 0.5362 9000.0n 0.5018 9599.5n 0.5018 9600.0n 0.4869 10199.5n 0.4869 10200.0n 0.4614 10799.5n 0.4614 10800.0n 0.5408 11399.5n 0.5408 11400.0n 0.5050 11999.5n 0.5050 12000.0n 0.5441 12599.5n 0.5441 12600.0n 0.4838 13199.5n 0.4838 13200.0n 0.4962 13799.5n 0.4962 13800.0n 0.4667 14399.5n 0.4667 14400.0n 0.5009 14999.5n 0.5009 15000.0n 0.4702 15599.5n 0.4702 15600.0n 0.5177 16199.5n 0.5177 16200.0n 0.4761 16799.5n 0.4761 16800.0n 0.5408 17399.5n 0.5408 17400.0n 0.4906 17999.5n 0.4906 18000.0n 0.5663 18599.5n 0.5663 18600.0n 0.4023 19199.5n 0.4023 19200.0n 0.4636 19799.5n 0.4636 19800.0n 0.3878 20399.5n 0.3878 20400.0n 0.5144 20999.5n 0.5144 21000.0n 0.6139 21599.5n 0.6139 21600.0n 0.3906 22199.5n 0.3906 22200.0n 0.3636 22799.5n 0.3636 22800.0n 0.5193 23399.5n 0.5193 23400.0n 0.4386 23999.5n 0.4386 24000.0n 0.4087 24599.5n 0.4087 24600.0n 0.3705 25199.5n 0.3705 25200.0n 0.5504 25799.5n 0.5504 25800.0n 0.6208 26399.5n 0.6208 26400.0n 0.5566 26999.5n 0.5566 27000.0n 0.5660 27599.5n 0.5660 27600.0n 0.5539 28199.5n 0.5539 28200.0n 0.4209 28799.5n 0.4209 28800.0n 0.5223 29399.5n 0.5223 29400.0n 0.6122 29999.5n 0.6122 30000.0n 0.6168 30599.5n 0.6168 30600.0n 0.5978 31199.5n 0.5978 31200.0n 0.5518 31799.5n 0.5518 31800.0n 0.6338 32399.5n 0.6338 32400.0n 0.6143 32999.5n 0.6143 33000.0n 0.4416 33599.5n 0.4416 33600.0n 0.4716 34199.5n 0.4716 34200.0n 0.3966 34799.5n 0.3966 34800.0n 0.6531 35399.5n 0.6531 35400.0n 0.4710 35999.5n 0.4710)
Vyp_wih_0_4 yp_wih_0_4 0 PWL(0.0n 0.3640 599.5n 0.3640 600.0n 0.3914 1199.5n 0.3914 1200.0n 0.4181 1799.5n 0.4181 1800.0n 0.4709 2399.5n 0.4709 2400.0n 0.4520 2999.5n 0.4520 3000.0n 0.3972 3599.5n 0.3972 3600.0n 0.4043 4199.5n 0.4043 4200.0n 0.3616 4799.5n 0.3616 4800.0n 0.3986 5399.5n 0.3986 5400.0n 0.3994 5999.5n 0.3994 6000.0n 0.4284 6599.5n 0.4284 6600.0n 0.3893 7199.5n 0.3893 7200.0n 0.4051 7799.5n 0.4051 7800.0n 0.4104 8399.5n 0.4104 8400.0n 0.3689 8999.5n 0.3689 9000.0n 0.3987 9599.5n 0.3987 9600.0n 0.4115 10199.5n 0.4115 10200.0n 0.4190 10799.5n 0.4190 10800.0n 0.4142 11399.5n 0.4142 11400.0n 0.3940 11999.5n 0.3940 12000.0n 0.3618 12599.5n 0.3618 12600.0n 0.4141 13199.5n 0.4141 13200.0n 0.3633 13799.5n 0.3633 13800.0n 0.3833 14399.5n 0.3833 14400.0n 0.3924 14999.5n 0.3924 15000.0n 0.4319 15599.5n 0.4319 15600.0n 0.3724 16199.5n 0.3724 16200.0n 0.3663 16799.5n 0.3663 16800.0n 0.3709 17399.5n 0.3709 17400.0n 0.3683 17999.5n 0.3683 18000.0n 0.4957 18599.5n 0.4957 18600.0n 0.4039 19199.5n 0.4039 19200.0n 0.5231 19799.5n 0.5231 19800.0n 0.5078 20399.5n 0.5078 20400.0n 0.5249 20999.5n 0.5249 21000.0n 0.4170 21599.5n 0.4170 21600.0n 0.4664 22199.5n 0.4664 22200.0n 0.4115 22799.5n 0.4115 22800.0n 0.5434 23399.5n 0.5434 23400.0n 0.3308 23999.5n 0.3308 24000.0n 0.5431 24599.5n 0.5431 24600.0n 0.3915 25199.5n 0.3915 25200.0n 0.5145 25799.5n 0.5145 25800.0n 0.5143 26399.5n 0.5143 26400.0n 0.5344 26999.5n 0.5344 27000.0n 0.5111 27599.5n 0.5111 27600.0n 0.5349 28199.5n 0.5349 28200.0n 0.3354 28799.5n 0.3354 28800.0n 0.5327 29399.5n 0.5327 29400.0n 0.4028 29999.5n 0.4028 30000.0n 0.3778 30599.5n 0.3778 30600.0n 0.3273 31199.5n 0.3273 31200.0n 0.3312 31799.5n 0.3312 31800.0n 0.5041 32399.5n 0.5041 32400.0n 0.5168 32999.5n 0.5168 33000.0n 0.5349 33599.5n 0.5349 33600.0n 0.5419 34199.5n 0.5419 34200.0n 0.3720 34799.5n 0.3720 34800.0n 0.3455 35399.5n 0.3455 35400.0n 0.5294 35999.5n 0.5294)
Vyn_wih_0_4 yn_wih_0_4 0 PWL(0.0n 0.6360 599.5n 0.6360 600.0n 0.6086 1199.5n 0.6086 1200.0n 0.5819 1799.5n 0.5819 1800.0n 0.5291 2399.5n 0.5291 2400.0n 0.5480 2999.5n 0.5480 3000.0n 0.6028 3599.5n 0.6028 3600.0n 0.5957 4199.5n 0.5957 4200.0n 0.6384 4799.5n 0.6384 4800.0n 0.6014 5399.5n 0.6014 5400.0n 0.6006 5999.5n 0.6006 6000.0n 0.5716 6599.5n 0.5716 6600.0n 0.6107 7199.5n 0.6107 7200.0n 0.5949 7799.5n 0.5949 7800.0n 0.5896 8399.5n 0.5896 8400.0n 0.6311 8999.5n 0.6311 9000.0n 0.6013 9599.5n 0.6013 9600.0n 0.5885 10199.5n 0.5885 10200.0n 0.5810 10799.5n 0.5810 10800.0n 0.5858 11399.5n 0.5858 11400.0n 0.6060 11999.5n 0.6060 12000.0n 0.6382 12599.5n 0.6382 12600.0n 0.5859 13199.5n 0.5859 13200.0n 0.6367 13799.5n 0.6367 13800.0n 0.6167 14399.5n 0.6167 14400.0n 0.6076 14999.5n 0.6076 15000.0n 0.5681 15599.5n 0.5681 15600.0n 0.6276 16199.5n 0.6276 16200.0n 0.6337 16799.5n 0.6337 16800.0n 0.6291 17399.5n 0.6291 17400.0n 0.6317 17999.5n 0.6317 18000.0n 0.5043 18599.5n 0.5043 18600.0n 0.5961 19199.5n 0.5961 19200.0n 0.4769 19799.5n 0.4769 19800.0n 0.4922 20399.5n 0.4922 20400.0n 0.4751 20999.5n 0.4751 21000.0n 0.5830 21599.5n 0.5830 21600.0n 0.5336 22199.5n 0.5336 22200.0n 0.5885 22799.5n 0.5885 22800.0n 0.4566 23399.5n 0.4566 23400.0n 0.6692 23999.5n 0.6692 24000.0n 0.4569 24599.5n 0.4569 24600.0n 0.6085 25199.5n 0.6085 25200.0n 0.4855 25799.5n 0.4855 25800.0n 0.4857 26399.5n 0.4857 26400.0n 0.4656 26999.5n 0.4656 27000.0n 0.4889 27599.5n 0.4889 27600.0n 0.4651 28199.5n 0.4651 28200.0n 0.6646 28799.5n 0.6646 28800.0n 0.4673 29399.5n 0.4673 29400.0n 0.5972 29999.5n 0.5972 30000.0n 0.6222 30599.5n 0.6222 30600.0n 0.6727 31199.5n 0.6727 31200.0n 0.6688 31799.5n 0.6688 31800.0n 0.4959 32399.5n 0.4959 32400.0n 0.4832 32999.5n 0.4832 33000.0n 0.4651 33599.5n 0.4651 33600.0n 0.4581 34199.5n 0.4581 34200.0n 0.6280 34799.5n 0.6280 34800.0n 0.6545 35399.5n 0.6545 35400.0n 0.4706 35999.5n 0.4706)
Cwp_wih_0_4 wp_wih_0_4 0 400p
Cwn_wih_0_4 wn_wih_0_4 0 400p
Xu_wih_0_4 xp_wih_0_4 xn_wih_0_4 yp_wih_0_4 yn_wih_0_4 wp_wih_0_4 wn_wih_0_4 vdd gbn gprod
Vxp_wih_1_4 xp_wih_1_4 0 PWL(0.0n 0.5370 599.5n 0.5370 600.0n 0.5167 1199.5n 0.5167 1200.0n 0.4793 1799.5n 0.4793 1800.0n 0.4441 2399.5n 0.4441 2400.0n 0.4555 2999.5n 0.4555 3000.0n 0.5055 3599.5n 0.5055 3600.0n 0.4939 4199.5n 0.4939 4200.0n 0.5385 4799.5n 0.5385 4800.0n 0.5024 5399.5n 0.5024 5400.0n 0.5015 5999.5n 0.5015 6000.0n 0.4700 6599.5n 0.4700 6600.0n 0.5120 7199.5n 0.5120 7200.0n 0.5006 7799.5n 0.5006 7800.0n 0.4950 8399.5n 0.4950 8400.0n 0.5309 8999.5n 0.5309 9000.0n 0.5023 9599.5n 0.5023 9600.0n 0.4893 10199.5n 0.4893 10200.0n 0.4837 10799.5n 0.4837 10800.0n 0.4823 11399.5n 0.4823 11400.0n 0.5074 11999.5n 0.5074 12000.0n 0.5364 12599.5n 0.5364 12600.0n 0.4868 13199.5n 0.4868 13200.0n 0.5380 13799.5n 0.5380 13800.0n 0.5220 14399.5n 0.5220 14400.0n 0.5095 14999.5n 0.5095 15000.0n 0.4705 15599.5n 0.4705 15600.0n 0.5289 16199.5n 0.5289 16200.0n 0.5368 16799.5n 0.5368 16800.0n 0.5287 17399.5n 0.5287 17400.0n 0.5342 17999.5n 0.5342 18000.0n 0.4253 18599.5n 0.4253 18600.0n 0.5119 19199.5n 0.5119 19200.0n 0.4104 19799.5n 0.4104 19800.0n 0.4314 20399.5n 0.4314 20400.0n 0.4005 20999.5n 0.4005 21000.0n 0.4696 21599.5n 0.4696 21600.0n 0.4531 22199.5n 0.4531 22200.0n 0.5039 22799.5n 0.5039 22800.0n 0.3608 23399.5n 0.3608 23400.0n 0.6273 23999.5n 0.6273 24000.0n 0.3928 24599.5n 0.3928 24600.0n 0.5253 25199.5n 0.5253 25200.0n 0.4107 25799.5n 0.4107 25800.0n 0.3947 26399.5n 0.3947 26400.0n 0.3716 26999.5n 0.3716 27000.0n 0.4111 27599.5n 0.4111 27600.0n 0.3715 28199.5n 0.3715 28200.0n 0.5939 28799.5n 0.5939 28800.0n 0.3849 29399.5n 0.3849 29400.0n 0.4835 29999.5n 0.4835 30000.0n 0.5119 30599.5n 0.5119 30600.0n 0.6226 31199.5n 0.6226 31200.0n 0.6064 31799.5n 0.6064 31800.0n 0.4115 32399.5n 0.4115 32400.0n 0.3900 32999.5n 0.3900 33000.0n 0.3958 33599.5n 0.3958 33600.0n 0.3747 34199.5n 0.3747 34200.0n 0.5423 34799.5n 0.5423 34800.0n 0.5509 35399.5n 0.5509 35400.0n 0.3990 35999.5n 0.3990)
Vxn_wih_1_4 xn_wih_1_4 0 PWL(0.0n 0.4630 599.5n 0.4630 600.0n 0.4833 1199.5n 0.4833 1200.0n 0.5207 1799.5n 0.5207 1800.0n 0.5559 2399.5n 0.5559 2400.0n 0.5445 2999.5n 0.5445 3000.0n 0.4945 3599.5n 0.4945 3600.0n 0.5061 4199.5n 0.5061 4200.0n 0.4615 4799.5n 0.4615 4800.0n 0.4976 5399.5n 0.4976 5400.0n 0.4985 5999.5n 0.4985 6000.0n 0.5300 6599.5n 0.5300 6600.0n 0.4880 7199.5n 0.4880 7200.0n 0.4994 7799.5n 0.4994 7800.0n 0.5050 8399.5n 0.5050 8400.0n 0.4691 8999.5n 0.4691 9000.0n 0.4977 9599.5n 0.4977 9600.0n 0.5107 10199.5n 0.5107 10200.0n 0.5163 10799.5n 0.5163 10800.0n 0.5177 11399.5n 0.5177 11400.0n 0.4926 11999.5n 0.4926 12000.0n 0.4636 12599.5n 0.4636 12600.0n 0.5132 13199.5n 0.5132 13200.0n 0.4620 13799.5n 0.4620 13800.0n 0.4780 14399.5n 0.4780 14400.0n 0.4905 14999.5n 0.4905 15000.0n 0.5295 15599.5n 0.5295 15600.0n 0.4711 16199.5n 0.4711 16200.0n 0.4632 16799.5n 0.4632 16800.0n 0.4713 17399.5n 0.4713 17400.0n 0.4658 17999.5n 0.4658 18000.0n 0.5747 18599.5n 0.5747 18600.0n 0.4881 19199.5n 0.4881 19200.0n 0.5896 19799.5n 0.5896 19800.0n 0.5686 20399.5n 0.5686 20400.0n 0.5995 20999.5n 0.5995 21000.0n 0.5304 21599.5n 0.5304 21600.0n 0.5469 22199.5n 0.5469 22200.0n 0.4961 22799.5n 0.4961 22800.0n 0.6392 23399.5n 0.6392 23400.0n 0.3727 23999.5n 0.3727 24000.0n 0.6072 24599.5n 0.6072 24600.0n 0.4747 25199.5n 0.4747 25200.0n 0.5893 25799.5n 0.5893 25800.0n 0.6053 26399.5n 0.6053 26400.0n 0.6284 26999.5n 0.6284 27000.0n 0.5889 27599.5n 0.5889 27600.0n 0.6285 28199.5n 0.6285 28200.0n 0.4061 28799.5n 0.4061 28800.0n 0.6151 29399.5n 0.6151 29400.0n 0.5165 29999.5n 0.5165 30000.0n 0.4881 30599.5n 0.4881 30600.0n 0.3774 31199.5n 0.3774 31200.0n 0.3936 31799.5n 0.3936 31800.0n 0.5885 32399.5n 0.5885 32400.0n 0.6100 32999.5n 0.6100 33000.0n 0.6042 33599.5n 0.6042 33600.0n 0.6253 34199.5n 0.6253 34200.0n 0.4577 34799.5n 0.4577 34800.0n 0.4491 35399.5n 0.4491 35400.0n 0.6010 35999.5n 0.6010)
Vyp_wih_1_4 yp_wih_1_4 0 PWL(0.0n 0.3640 599.5n 0.3640 600.0n 0.3914 1199.5n 0.3914 1200.0n 0.4181 1799.5n 0.4181 1800.0n 0.4709 2399.5n 0.4709 2400.0n 0.4520 2999.5n 0.4520 3000.0n 0.3972 3599.5n 0.3972 3600.0n 0.4043 4199.5n 0.4043 4200.0n 0.3616 4799.5n 0.3616 4800.0n 0.3986 5399.5n 0.3986 5400.0n 0.3994 5999.5n 0.3994 6000.0n 0.4284 6599.5n 0.4284 6600.0n 0.3893 7199.5n 0.3893 7200.0n 0.4051 7799.5n 0.4051 7800.0n 0.4104 8399.5n 0.4104 8400.0n 0.3689 8999.5n 0.3689 9000.0n 0.3987 9599.5n 0.3987 9600.0n 0.4115 10199.5n 0.4115 10200.0n 0.4190 10799.5n 0.4190 10800.0n 0.4142 11399.5n 0.4142 11400.0n 0.3940 11999.5n 0.3940 12000.0n 0.3618 12599.5n 0.3618 12600.0n 0.4141 13199.5n 0.4141 13200.0n 0.3633 13799.5n 0.3633 13800.0n 0.3833 14399.5n 0.3833 14400.0n 0.3924 14999.5n 0.3924 15000.0n 0.4319 15599.5n 0.4319 15600.0n 0.3724 16199.5n 0.3724 16200.0n 0.3663 16799.5n 0.3663 16800.0n 0.3709 17399.5n 0.3709 17400.0n 0.3683 17999.5n 0.3683 18000.0n 0.4957 18599.5n 0.4957 18600.0n 0.4039 19199.5n 0.4039 19200.0n 0.5231 19799.5n 0.5231 19800.0n 0.5078 20399.5n 0.5078 20400.0n 0.5249 20999.5n 0.5249 21000.0n 0.4170 21599.5n 0.4170 21600.0n 0.4664 22199.5n 0.4664 22200.0n 0.4115 22799.5n 0.4115 22800.0n 0.5434 23399.5n 0.5434 23400.0n 0.3308 23999.5n 0.3308 24000.0n 0.5431 24599.5n 0.5431 24600.0n 0.3915 25199.5n 0.3915 25200.0n 0.5145 25799.5n 0.5145 25800.0n 0.5143 26399.5n 0.5143 26400.0n 0.5344 26999.5n 0.5344 27000.0n 0.5111 27599.5n 0.5111 27600.0n 0.5349 28199.5n 0.5349 28200.0n 0.3354 28799.5n 0.3354 28800.0n 0.5327 29399.5n 0.5327 29400.0n 0.4028 29999.5n 0.4028 30000.0n 0.3778 30599.5n 0.3778 30600.0n 0.3273 31199.5n 0.3273 31200.0n 0.3312 31799.5n 0.3312 31800.0n 0.5041 32399.5n 0.5041 32400.0n 0.5168 32999.5n 0.5168 33000.0n 0.5349 33599.5n 0.5349 33600.0n 0.5419 34199.5n 0.5419 34200.0n 0.3720 34799.5n 0.3720 34800.0n 0.3455 35399.5n 0.3455 35400.0n 0.5294 35999.5n 0.5294)
Vyn_wih_1_4 yn_wih_1_4 0 PWL(0.0n 0.6360 599.5n 0.6360 600.0n 0.6086 1199.5n 0.6086 1200.0n 0.5819 1799.5n 0.5819 1800.0n 0.5291 2399.5n 0.5291 2400.0n 0.5480 2999.5n 0.5480 3000.0n 0.6028 3599.5n 0.6028 3600.0n 0.5957 4199.5n 0.5957 4200.0n 0.6384 4799.5n 0.6384 4800.0n 0.6014 5399.5n 0.6014 5400.0n 0.6006 5999.5n 0.6006 6000.0n 0.5716 6599.5n 0.5716 6600.0n 0.6107 7199.5n 0.6107 7200.0n 0.5949 7799.5n 0.5949 7800.0n 0.5896 8399.5n 0.5896 8400.0n 0.6311 8999.5n 0.6311 9000.0n 0.6013 9599.5n 0.6013 9600.0n 0.5885 10199.5n 0.5885 10200.0n 0.5810 10799.5n 0.5810 10800.0n 0.5858 11399.5n 0.5858 11400.0n 0.6060 11999.5n 0.6060 12000.0n 0.6382 12599.5n 0.6382 12600.0n 0.5859 13199.5n 0.5859 13200.0n 0.6367 13799.5n 0.6367 13800.0n 0.6167 14399.5n 0.6167 14400.0n 0.6076 14999.5n 0.6076 15000.0n 0.5681 15599.5n 0.5681 15600.0n 0.6276 16199.5n 0.6276 16200.0n 0.6337 16799.5n 0.6337 16800.0n 0.6291 17399.5n 0.6291 17400.0n 0.6317 17999.5n 0.6317 18000.0n 0.5043 18599.5n 0.5043 18600.0n 0.5961 19199.5n 0.5961 19200.0n 0.4769 19799.5n 0.4769 19800.0n 0.4922 20399.5n 0.4922 20400.0n 0.4751 20999.5n 0.4751 21000.0n 0.5830 21599.5n 0.5830 21600.0n 0.5336 22199.5n 0.5336 22200.0n 0.5885 22799.5n 0.5885 22800.0n 0.4566 23399.5n 0.4566 23400.0n 0.6692 23999.5n 0.6692 24000.0n 0.4569 24599.5n 0.4569 24600.0n 0.6085 25199.5n 0.6085 25200.0n 0.4855 25799.5n 0.4855 25800.0n 0.4857 26399.5n 0.4857 26400.0n 0.4656 26999.5n 0.4656 27000.0n 0.4889 27599.5n 0.4889 27600.0n 0.4651 28199.5n 0.4651 28200.0n 0.6646 28799.5n 0.6646 28800.0n 0.4673 29399.5n 0.4673 29400.0n 0.5972 29999.5n 0.5972 30000.0n 0.6222 30599.5n 0.6222 30600.0n 0.6727 31199.5n 0.6727 31200.0n 0.6688 31799.5n 0.6688 31800.0n 0.4959 32399.5n 0.4959 32400.0n 0.4832 32999.5n 0.4832 33000.0n 0.4651 33599.5n 0.4651 33600.0n 0.4581 34199.5n 0.4581 34200.0n 0.6280 34799.5n 0.6280 34800.0n 0.6545 35399.5n 0.6545 35400.0n 0.4706 35999.5n 0.4706)
Cwp_wih_1_4 wp_wih_1_4 0 400p
Cwn_wih_1_4 wn_wih_1_4 0 400p
Xu_wih_1_4 xp_wih_1_4 xn_wih_1_4 yp_wih_1_4 yn_wih_1_4 wp_wih_1_4 wn_wih_1_4 vdd gbn gprod
Vxp_who_4_0 xp_who_4_0 0 PWL(0.0n 0.3640 599.5n 0.3640 600.0n 0.3914 1199.5n 0.3914 1200.0n 0.4181 1799.5n 0.4181 1800.0n 0.4709 2399.5n 0.4709 2400.0n 0.4520 2999.5n 0.4520 3000.0n 0.3972 3599.5n 0.3972 3600.0n 0.4043 4199.5n 0.4043 4200.0n 0.3616 4799.5n 0.3616 4800.0n 0.3986 5399.5n 0.3986 5400.0n 0.3994 5999.5n 0.3994 6000.0n 0.4284 6599.5n 0.4284 6600.0n 0.3893 7199.5n 0.3893 7200.0n 0.4051 7799.5n 0.4051 7800.0n 0.4104 8399.5n 0.4104 8400.0n 0.3689 8999.5n 0.3689 9000.0n 0.3987 9599.5n 0.3987 9600.0n 0.4115 10199.5n 0.4115 10200.0n 0.4190 10799.5n 0.4190 10800.0n 0.4142 11399.5n 0.4142 11400.0n 0.3940 11999.5n 0.3940 12000.0n 0.3618 12599.5n 0.3618 12600.0n 0.4141 13199.5n 0.4141 13200.0n 0.3633 13799.5n 0.3633 13800.0n 0.3833 14399.5n 0.3833 14400.0n 0.3924 14999.5n 0.3924 15000.0n 0.4319 15599.5n 0.4319 15600.0n 0.3724 16199.5n 0.3724 16200.0n 0.3663 16799.5n 0.3663 16800.0n 0.3709 17399.5n 0.3709 17400.0n 0.3683 17999.5n 0.3683 18000.0n 0.4957 18599.5n 0.4957 18600.0n 0.4039 19199.5n 0.4039 19200.0n 0.5231 19799.5n 0.5231 19800.0n 0.5078 20399.5n 0.5078 20400.0n 0.5249 20999.5n 0.5249 21000.0n 0.4170 21599.5n 0.4170 21600.0n 0.4664 22199.5n 0.4664 22200.0n 0.4115 22799.5n 0.4115 22800.0n 0.5434 23399.5n 0.5434 23400.0n 0.3308 23999.5n 0.3308 24000.0n 0.5431 24599.5n 0.5431 24600.0n 0.3915 25199.5n 0.3915 25200.0n 0.5145 25799.5n 0.5145 25800.0n 0.5143 26399.5n 0.5143 26400.0n 0.5344 26999.5n 0.5344 27000.0n 0.5111 27599.5n 0.5111 27600.0n 0.5349 28199.5n 0.5349 28200.0n 0.3354 28799.5n 0.3354 28800.0n 0.5327 29399.5n 0.5327 29400.0n 0.4028 29999.5n 0.4028 30000.0n 0.3778 30599.5n 0.3778 30600.0n 0.3273 31199.5n 0.3273 31200.0n 0.3312 31799.5n 0.3312 31800.0n 0.5041 32399.5n 0.5041 32400.0n 0.5168 32999.5n 0.5168 33000.0n 0.5349 33599.5n 0.5349 33600.0n 0.5419 34199.5n 0.5419 34200.0n 0.3720 34799.5n 0.3720 34800.0n 0.3455 35399.5n 0.3455 35400.0n 0.5294 35999.5n 0.5294)
Vxn_who_4_0 xn_who_4_0 0 PWL(0.0n 0.6360 599.5n 0.6360 600.0n 0.6086 1199.5n 0.6086 1200.0n 0.5819 1799.5n 0.5819 1800.0n 0.5291 2399.5n 0.5291 2400.0n 0.5480 2999.5n 0.5480 3000.0n 0.6028 3599.5n 0.6028 3600.0n 0.5957 4199.5n 0.5957 4200.0n 0.6384 4799.5n 0.6384 4800.0n 0.6014 5399.5n 0.6014 5400.0n 0.6006 5999.5n 0.6006 6000.0n 0.5716 6599.5n 0.5716 6600.0n 0.6107 7199.5n 0.6107 7200.0n 0.5949 7799.5n 0.5949 7800.0n 0.5896 8399.5n 0.5896 8400.0n 0.6311 8999.5n 0.6311 9000.0n 0.6013 9599.5n 0.6013 9600.0n 0.5885 10199.5n 0.5885 10200.0n 0.5810 10799.5n 0.5810 10800.0n 0.5858 11399.5n 0.5858 11400.0n 0.6060 11999.5n 0.6060 12000.0n 0.6382 12599.5n 0.6382 12600.0n 0.5859 13199.5n 0.5859 13200.0n 0.6367 13799.5n 0.6367 13800.0n 0.6167 14399.5n 0.6167 14400.0n 0.6076 14999.5n 0.6076 15000.0n 0.5681 15599.5n 0.5681 15600.0n 0.6276 16199.5n 0.6276 16200.0n 0.6337 16799.5n 0.6337 16800.0n 0.6291 17399.5n 0.6291 17400.0n 0.6317 17999.5n 0.6317 18000.0n 0.5043 18599.5n 0.5043 18600.0n 0.5961 19199.5n 0.5961 19200.0n 0.4769 19799.5n 0.4769 19800.0n 0.4922 20399.5n 0.4922 20400.0n 0.4751 20999.5n 0.4751 21000.0n 0.5830 21599.5n 0.5830 21600.0n 0.5336 22199.5n 0.5336 22200.0n 0.5885 22799.5n 0.5885 22800.0n 0.4566 23399.5n 0.4566 23400.0n 0.6692 23999.5n 0.6692 24000.0n 0.4569 24599.5n 0.4569 24600.0n 0.6085 25199.5n 0.6085 25200.0n 0.4855 25799.5n 0.4855 25800.0n 0.4857 26399.5n 0.4857 26400.0n 0.4656 26999.5n 0.4656 27000.0n 0.4889 27599.5n 0.4889 27600.0n 0.4651 28199.5n 0.4651 28200.0n 0.6646 28799.5n 0.6646 28800.0n 0.4673 29399.5n 0.4673 29400.0n 0.5972 29999.5n 0.5972 30000.0n 0.6222 30599.5n 0.6222 30600.0n 0.6727 31199.5n 0.6727 31200.0n 0.6688 31799.5n 0.6688 31800.0n 0.4959 32399.5n 0.4959 32400.0n 0.4832 32999.5n 0.4832 33000.0n 0.4651 33599.5n 0.4651 33600.0n 0.4581 34199.5n 0.4581 34200.0n 0.6280 34799.5n 0.6280 34800.0n 0.6545 35399.5n 0.6545 35400.0n 0.4706 35999.5n 0.4706)
Vyp_who_4_0 yp_who_4_0 0 PWL(0.0n 0.5031 599.5n 0.5031 600.0n 0.5023 1199.5n 0.5023 1200.0n 0.5052 1799.5n 0.5052 1800.0n 0.5048 2399.5n 0.5048 2400.0n 0.5043 2999.5n 0.5043 3000.0n 0.5034 3599.5n 0.5034 3600.0n 0.5048 4199.5n 0.5048 4200.0n 0.5031 4799.5n 0.5031 4800.0n 0.5040 5399.5n 0.5040 5400.0n 0.5040 5999.5n 0.5040 6000.0n 0.5054 6599.5n 0.5054 6600.0n 0.5040 7199.5n 0.5040 7200.0n 0.5027 7799.5n 0.5027 7800.0n 0.5027 8399.5n 0.5027 8400.0n 0.5038 8999.5n 0.5038 9000.0n 0.5040 9599.5n 0.5040 9600.0n 0.5039 10199.5n 0.5039 10200.0n 0.5033 10799.5n 0.5033 10800.0n 0.5056 11399.5n 0.5056 11400.0n 0.5040 11999.5n 0.5040 12000.0n 0.5036 12599.5n 0.5036 12600.0n 0.5039 13199.5n 0.5039 13200.0n 0.5029 13799.5n 0.5029 13800.0n 0.5025 14399.5n 0.5025 14400.0n 0.5038 14999.5n 0.5038 15000.0n 0.5041 15599.5n 0.5041 15600.0n 0.5036 16199.5n 0.5036 16200.0n 0.5025 16799.5n 0.5025 16800.0n 0.5040 17399.5n 0.5040 17400.0n 0.5029 17999.5n 0.5029 18000.0n 0.5057 18599.5n 0.5057 18600.0n 0.5010 19199.5n 0.5010 19200.0n 0.5041 19799.5n 0.5041 19800.0n 0.5021 20399.5n 0.5021 20400.0n 0.5044 20999.5n 0.5044 21000.0n 0.5056 21599.5n 0.5056 21600.0n 0.5016 22199.5n 0.5016 22200.0n 0.5006 22799.5n 0.5006 22800.0n 0.5041 23399.5n 0.5041 23400.0n 0.5027 23999.5n 0.5027 24000.0n 0.5029 24599.5n 0.5029 24600.0n 0.5006 25199.5n 0.5006 25200.0n 0.5047 25799.5n 0.5047 25800.0n 0.5046 26399.5n 0.5046 26400.0n 0.5039 26999.5n 0.5039 27000.0n 0.5049 27599.5n 0.5049 27600.0n 0.5039 28199.5n 0.5039 28200.0n 0.5017 28799.5n 0.5017 28800.0n 0.5042 29399.5n 0.5042 29400.0n 0.5056 29999.5n 0.5056 30000.0n 0.5051 30599.5n 0.5051 30600.0n 0.5039 31199.5n 0.5039 31200.0n 0.5033 31799.5n 0.5033 31800.0n 0.5049 32399.5n 0.5049 32400.0n 0.5045 32999.5n 0.5045 33000.0n 0.5036 33599.5n 0.5036 33600.0n 0.5042 34199.5n 0.5042 34200.0n 0.5012 34799.5n 0.5012 34800.0n 0.5036 35399.5n 0.5036 35400.0n 0.5042 35999.5n 0.5042)
Vyn_who_4_0 yn_who_4_0 0 PWL(0.0n 0.4969 599.5n 0.4969 600.0n 0.4977 1199.5n 0.4977 1200.0n 0.4948 1799.5n 0.4948 1800.0n 0.4952 2399.5n 0.4952 2400.0n 0.4957 2999.5n 0.4957 3000.0n 0.4966 3599.5n 0.4966 3600.0n 0.4952 4199.5n 0.4952 4200.0n 0.4969 4799.5n 0.4969 4800.0n 0.4960 5399.5n 0.4960 5400.0n 0.4960 5999.5n 0.4960 6000.0n 0.4946 6599.5n 0.4946 6600.0n 0.4960 7199.5n 0.4960 7200.0n 0.4973 7799.5n 0.4973 7800.0n 0.4973 8399.5n 0.4973 8400.0n 0.4962 8999.5n 0.4962 9000.0n 0.4960 9599.5n 0.4960 9600.0n 0.4961 10199.5n 0.4961 10200.0n 0.4967 10799.5n 0.4967 10800.0n 0.4944 11399.5n 0.4944 11400.0n 0.4960 11999.5n 0.4960 12000.0n 0.4964 12599.5n 0.4964 12600.0n 0.4961 13199.5n 0.4961 13200.0n 0.4971 13799.5n 0.4971 13800.0n 0.4975 14399.5n 0.4975 14400.0n 0.4962 14999.5n 0.4962 15000.0n 0.4959 15599.5n 0.4959 15600.0n 0.4964 16199.5n 0.4964 16200.0n 0.4975 16799.5n 0.4975 16800.0n 0.4960 17399.5n 0.4960 17400.0n 0.4971 17999.5n 0.4971 18000.0n 0.4943 18599.5n 0.4943 18600.0n 0.4990 19199.5n 0.4990 19200.0n 0.4959 19799.5n 0.4959 19800.0n 0.4979 20399.5n 0.4979 20400.0n 0.4956 20999.5n 0.4956 21000.0n 0.4944 21599.5n 0.4944 21600.0n 0.4984 22199.5n 0.4984 22200.0n 0.4994 22799.5n 0.4994 22800.0n 0.4959 23399.5n 0.4959 23400.0n 0.4973 23999.5n 0.4973 24000.0n 0.4971 24599.5n 0.4971 24600.0n 0.4994 25199.5n 0.4994 25200.0n 0.4953 25799.5n 0.4953 25800.0n 0.4954 26399.5n 0.4954 26400.0n 0.4961 26999.5n 0.4961 27000.0n 0.4951 27599.5n 0.4951 27600.0n 0.4961 28199.5n 0.4961 28200.0n 0.4983 28799.5n 0.4983 28800.0n 0.4958 29399.5n 0.4958 29400.0n 0.4944 29999.5n 0.4944 30000.0n 0.4949 30599.5n 0.4949 30600.0n 0.4961 31199.5n 0.4961 31200.0n 0.4967 31799.5n 0.4967 31800.0n 0.4951 32399.5n 0.4951 32400.0n 0.4955 32999.5n 0.4955 33000.0n 0.4964 33599.5n 0.4964 33600.0n 0.4958 34199.5n 0.4958 34200.0n 0.4988 34799.5n 0.4988 34800.0n 0.4964 35399.5n 0.4964 35400.0n 0.4958 35999.5n 0.4958)
Cwp_who_4_0 wp_who_4_0 0 400p
Cwn_who_4_0 wn_who_4_0 0 400p
Xu_who_4_0 xp_who_4_0 xn_who_4_0 yp_who_4_0 yn_who_4_0 wp_who_4_0 wn_who_4_0 vdd gbn gprod
Vxp_who_4_1 xp_who_4_1 0 PWL(0.0n 0.3640 599.5n 0.3640 600.0n 0.3914 1199.5n 0.3914 1200.0n 0.4181 1799.5n 0.4181 1800.0n 0.4709 2399.5n 0.4709 2400.0n 0.4520 2999.5n 0.4520 3000.0n 0.3972 3599.5n 0.3972 3600.0n 0.4043 4199.5n 0.4043 4200.0n 0.3616 4799.5n 0.3616 4800.0n 0.3986 5399.5n 0.3986 5400.0n 0.3994 5999.5n 0.3994 6000.0n 0.4284 6599.5n 0.4284 6600.0n 0.3893 7199.5n 0.3893 7200.0n 0.4051 7799.5n 0.4051 7800.0n 0.4104 8399.5n 0.4104 8400.0n 0.3689 8999.5n 0.3689 9000.0n 0.3987 9599.5n 0.3987 9600.0n 0.4115 10199.5n 0.4115 10200.0n 0.4190 10799.5n 0.4190 10800.0n 0.4142 11399.5n 0.4142 11400.0n 0.3940 11999.5n 0.3940 12000.0n 0.3618 12599.5n 0.3618 12600.0n 0.4141 13199.5n 0.4141 13200.0n 0.3633 13799.5n 0.3633 13800.0n 0.3833 14399.5n 0.3833 14400.0n 0.3924 14999.5n 0.3924 15000.0n 0.4319 15599.5n 0.4319 15600.0n 0.3724 16199.5n 0.3724 16200.0n 0.3663 16799.5n 0.3663 16800.0n 0.3709 17399.5n 0.3709 17400.0n 0.3683 17999.5n 0.3683 18000.0n 0.4957 18599.5n 0.4957 18600.0n 0.4039 19199.5n 0.4039 19200.0n 0.5231 19799.5n 0.5231 19800.0n 0.5078 20399.5n 0.5078 20400.0n 0.5249 20999.5n 0.5249 21000.0n 0.4170 21599.5n 0.4170 21600.0n 0.4664 22199.5n 0.4664 22200.0n 0.4115 22799.5n 0.4115 22800.0n 0.5434 23399.5n 0.5434 23400.0n 0.3308 23999.5n 0.3308 24000.0n 0.5431 24599.5n 0.5431 24600.0n 0.3915 25199.5n 0.3915 25200.0n 0.5145 25799.5n 0.5145 25800.0n 0.5143 26399.5n 0.5143 26400.0n 0.5344 26999.5n 0.5344 27000.0n 0.5111 27599.5n 0.5111 27600.0n 0.5349 28199.5n 0.5349 28200.0n 0.3354 28799.5n 0.3354 28800.0n 0.5327 29399.5n 0.5327 29400.0n 0.4028 29999.5n 0.4028 30000.0n 0.3778 30599.5n 0.3778 30600.0n 0.3273 31199.5n 0.3273 31200.0n 0.3312 31799.5n 0.3312 31800.0n 0.5041 32399.5n 0.5041 32400.0n 0.5168 32999.5n 0.5168 33000.0n 0.5349 33599.5n 0.5349 33600.0n 0.5419 34199.5n 0.5419 34200.0n 0.3720 34799.5n 0.3720 34800.0n 0.3455 35399.5n 0.3455 35400.0n 0.5294 35999.5n 0.5294)
Vxn_who_4_1 xn_who_4_1 0 PWL(0.0n 0.6360 599.5n 0.6360 600.0n 0.6086 1199.5n 0.6086 1200.0n 0.5819 1799.5n 0.5819 1800.0n 0.5291 2399.5n 0.5291 2400.0n 0.5480 2999.5n 0.5480 3000.0n 0.6028 3599.5n 0.6028 3600.0n 0.5957 4199.5n 0.5957 4200.0n 0.6384 4799.5n 0.6384 4800.0n 0.6014 5399.5n 0.6014 5400.0n 0.6006 5999.5n 0.6006 6000.0n 0.5716 6599.5n 0.5716 6600.0n 0.6107 7199.5n 0.6107 7200.0n 0.5949 7799.5n 0.5949 7800.0n 0.5896 8399.5n 0.5896 8400.0n 0.6311 8999.5n 0.6311 9000.0n 0.6013 9599.5n 0.6013 9600.0n 0.5885 10199.5n 0.5885 10200.0n 0.5810 10799.5n 0.5810 10800.0n 0.5858 11399.5n 0.5858 11400.0n 0.6060 11999.5n 0.6060 12000.0n 0.6382 12599.5n 0.6382 12600.0n 0.5859 13199.5n 0.5859 13200.0n 0.6367 13799.5n 0.6367 13800.0n 0.6167 14399.5n 0.6167 14400.0n 0.6076 14999.5n 0.6076 15000.0n 0.5681 15599.5n 0.5681 15600.0n 0.6276 16199.5n 0.6276 16200.0n 0.6337 16799.5n 0.6337 16800.0n 0.6291 17399.5n 0.6291 17400.0n 0.6317 17999.5n 0.6317 18000.0n 0.5043 18599.5n 0.5043 18600.0n 0.5961 19199.5n 0.5961 19200.0n 0.4769 19799.5n 0.4769 19800.0n 0.4922 20399.5n 0.4922 20400.0n 0.4751 20999.5n 0.4751 21000.0n 0.5830 21599.5n 0.5830 21600.0n 0.5336 22199.5n 0.5336 22200.0n 0.5885 22799.5n 0.5885 22800.0n 0.4566 23399.5n 0.4566 23400.0n 0.6692 23999.5n 0.6692 24000.0n 0.4569 24599.5n 0.4569 24600.0n 0.6085 25199.5n 0.6085 25200.0n 0.4855 25799.5n 0.4855 25800.0n 0.4857 26399.5n 0.4857 26400.0n 0.4656 26999.5n 0.4656 27000.0n 0.4889 27599.5n 0.4889 27600.0n 0.4651 28199.5n 0.4651 28200.0n 0.6646 28799.5n 0.6646 28800.0n 0.4673 29399.5n 0.4673 29400.0n 0.5972 29999.5n 0.5972 30000.0n 0.6222 30599.5n 0.6222 30600.0n 0.6727 31199.5n 0.6727 31200.0n 0.6688 31799.5n 0.6688 31800.0n 0.4959 32399.5n 0.4959 32400.0n 0.4832 32999.5n 0.4832 33000.0n 0.4651 33599.5n 0.4651 33600.0n 0.4581 34199.5n 0.4581 34200.0n 0.6280 34799.5n 0.6280 34800.0n 0.6545 35399.5n 0.6545 35400.0n 0.4706 35999.5n 0.4706)
Vyp_who_4_1 yp_who_4_1 0 PWL(0.0n 0.5071 599.5n 0.5071 600.0n 0.5053 1199.5n 0.5053 1200.0n 0.5052 1799.5n 0.5052 1800.0n 0.5027 2399.5n 0.5027 2400.0n 0.5034 2999.5n 0.5034 3000.0n 0.5055 3599.5n 0.5055 3600.0n 0.5056 4199.5n 0.5056 4200.0n 0.5071 4799.5n 0.5071 4800.0n 0.5056 5399.5n 0.5056 5400.0n 0.5056 5999.5n 0.5056 6000.0n 0.5048 6599.5n 0.5048 6600.0n 0.5060 7199.5n 0.5060 7200.0n 0.5048 7799.5n 0.5048 7800.0n 0.5046 8399.5n 0.5046 8400.0n 0.5066 8999.5n 0.5066 9000.0n 0.5056 9599.5n 0.5056 9600.0n 0.5051 10199.5n 0.5051 10200.0n 0.5046 10799.5n 0.5046 10800.0n 0.5056 11399.5n 0.5056 11400.0n 0.5058 11999.5n 0.5058 12000.0n 0.5068 12599.5n 0.5068 12600.0n 0.5050 13199.5n 0.5050 13200.0n 0.5071 13799.5n 0.5071 13800.0n 0.5059 14399.5n 0.5059 14400.0n 0.5058 14999.5n 0.5058 15000.0n 0.5043 15599.5n 0.5043 15600.0n 0.5067 16199.5n 0.5067 16200.0n 0.5068 16799.5n 0.5068 16800.0n 0.5066 17399.5n 0.5066 17400.0n 0.5069 17999.5n 0.5069 18000.0n 0.5061 18599.5n 0.5061 18600.0n 0.5034 19199.5n 0.5034 19200.0n 0.5010 19799.5n 0.5010 19800.0n 0.4989 20399.5n 0.4989 20400.0n 0.5022 20999.5n 0.5022 21000.0n 0.5086 21599.5n 0.5086 21600.0n 0.5007 22199.5n 0.5007 22200.0n 0.5023 22799.5n 0.5023 22800.0n 0.5021 23399.5n 0.5021 23400.0n 0.5077 23999.5n 0.5077 24000.0n 0.4979 24599.5n 0.4979 24600.0n 0.5035 25199.5n 0.5035 25200.0n 0.5041 25799.5n 0.5041 25800.0n 0.5075 26399.5n 0.5075 26400.0n 0.5041 26999.5n 0.5041 27000.0n 0.5056 27599.5n 0.5056 27600.0n 0.5039 28199.5n 0.5039 28200.0n 0.5059 28799.5n 0.5059 28800.0n 0.5023 29399.5n 0.5023 29400.0n 0.5086 29999.5n 0.5086 30000.0n 0.5084 30599.5n 0.5084 30600.0n 0.5085 31199.5n 0.5085 31200.0n 0.5088 31799.5n 0.5088 31800.0n 0.5078 32399.5n 0.5078 32400.0n 0.5074 32999.5n 0.5074 33000.0n 0.4996 33599.5n 0.4996 33600.0n 0.5010 34199.5n 0.5010 34200.0n 0.5044 34799.5n 0.5044 34800.0n 0.5084 35399.5n 0.5084 35400.0n 0.5012 35999.5n 0.5012)
Vyn_who_4_1 yn_who_4_1 0 PWL(0.0n 0.4929 599.5n 0.4929 600.0n 0.4947 1199.5n 0.4947 1200.0n 0.4948 1799.5n 0.4948 1800.0n 0.4973 2399.5n 0.4973 2400.0n 0.4966 2999.5n 0.4966 3000.0n 0.4945 3599.5n 0.4945 3600.0n 0.4944 4199.5n 0.4944 4200.0n 0.4929 4799.5n 0.4929 4800.0n 0.4944 5399.5n 0.4944 5400.0n 0.4944 5999.5n 0.4944 6000.0n 0.4952 6599.5n 0.4952 6600.0n 0.4940 7199.5n 0.4940 7200.0n 0.4952 7799.5n 0.4952 7800.0n 0.4954 8399.5n 0.4954 8400.0n 0.4934 8999.5n 0.4934 9000.0n 0.4944 9599.5n 0.4944 9600.0n 0.4949 10199.5n 0.4949 10200.0n 0.4954 10799.5n 0.4954 10800.0n 0.4944 11399.5n 0.4944 11400.0n 0.4942 11999.5n 0.4942 12000.0n 0.4932 12599.5n 0.4932 12600.0n 0.4950 13199.5n 0.4950 13200.0n 0.4929 13799.5n 0.4929 13800.0n 0.4941 14399.5n 0.4941 14400.0n 0.4942 14999.5n 0.4942 15000.0n 0.4957 15599.5n 0.4957 15600.0n 0.4933 16199.5n 0.4933 16200.0n 0.4932 16799.5n 0.4932 16800.0n 0.4934 17399.5n 0.4934 17400.0n 0.4931 17999.5n 0.4931 18000.0n 0.4939 18599.5n 0.4939 18600.0n 0.4966 19199.5n 0.4966 19200.0n 0.4990 19799.5n 0.4990 19800.0n 0.5011 20399.5n 0.5011 20400.0n 0.4978 20999.5n 0.4978 21000.0n 0.4914 21599.5n 0.4914 21600.0n 0.4993 22199.5n 0.4993 22200.0n 0.4977 22799.5n 0.4977 22800.0n 0.4979 23399.5n 0.4979 23400.0n 0.4923 23999.5n 0.4923 24000.0n 0.5021 24599.5n 0.5021 24600.0n 0.4965 25199.5n 0.4965 25200.0n 0.4959 25799.5n 0.4959 25800.0n 0.4925 26399.5n 0.4925 26400.0n 0.4959 26999.5n 0.4959 27000.0n 0.4944 27599.5n 0.4944 27600.0n 0.4961 28199.5n 0.4961 28200.0n 0.4941 28799.5n 0.4941 28800.0n 0.4977 29399.5n 0.4977 29400.0n 0.4914 29999.5n 0.4914 30000.0n 0.4916 30599.5n 0.4916 30600.0n 0.4915 31199.5n 0.4915 31200.0n 0.4912 31799.5n 0.4912 31800.0n 0.4922 32399.5n 0.4922 32400.0n 0.4926 32999.5n 0.4926 33000.0n 0.5004 33599.5n 0.5004 33600.0n 0.4990 34199.5n 0.4990 34200.0n 0.4956 34799.5n 0.4956 34800.0n 0.4916 35399.5n 0.4916 35400.0n 0.4988 35999.5n 0.4988)
Cwp_who_4_1 wp_who_4_1 0 400p
Cwn_who_4_1 wn_who_4_1 0 400p
Xu_who_4_1 xp_who_4_1 xn_who_4_1 yp_who_4_1 yn_who_4_1 wp_who_4_1 wn_who_4_1 vdd gbn gprod
Vxp_bh_4 xp_bh_4 0 PWL(0.0n 0.7100 599.5n 0.7100 600.0n 0.7100 1199.5n 0.7100 1200.0n 0.7100 1799.5n 0.7100 1800.0n 0.7100 2399.5n 0.7100 2400.0n 0.7100 2999.5n 0.7100 3000.0n 0.7100 3599.5n 0.7100 3600.0n 0.7100 4199.5n 0.7100 4200.0n 0.7100 4799.5n 0.7100 4800.0n 0.7100 5399.5n 0.7100 5400.0n 0.7100 5999.5n 0.7100 6000.0n 0.7100 6599.5n 0.7100 6600.0n 0.7100 7199.5n 0.7100 7200.0n 0.7100 7799.5n 0.7100 7800.0n 0.7100 8399.5n 0.7100 8400.0n 0.7100 8999.5n 0.7100 9000.0n 0.7100 9599.5n 0.7100 9600.0n 0.7100 10199.5n 0.7100 10200.0n 0.7100 10799.5n 0.7100 10800.0n 0.7100 11399.5n 0.7100 11400.0n 0.7100 11999.5n 0.7100 12000.0n 0.7100 12599.5n 0.7100 12600.0n 0.7100 13199.5n 0.7100 13200.0n 0.7100 13799.5n 0.7100 13800.0n 0.7100 14399.5n 0.7100 14400.0n 0.7100 14999.5n 0.7100 15000.0n 0.7100 15599.5n 0.7100 15600.0n 0.7100 16199.5n 0.7100 16200.0n 0.7100 16799.5n 0.7100 16800.0n 0.7100 17399.5n 0.7100 17400.0n 0.7100 17999.5n 0.7100 18000.0n 0.7100 18599.5n 0.7100 18600.0n 0.7100 19199.5n 0.7100 19200.0n 0.7100 19799.5n 0.7100 19800.0n 0.7100 20399.5n 0.7100 20400.0n 0.7100 20999.5n 0.7100 21000.0n 0.7100 21599.5n 0.7100 21600.0n 0.7100 22199.5n 0.7100 22200.0n 0.7100 22799.5n 0.7100 22800.0n 0.7100 23399.5n 0.7100 23400.0n 0.7100 23999.5n 0.7100 24000.0n 0.7100 24599.5n 0.7100 24600.0n 0.7100 25199.5n 0.7100 25200.0n 0.7100 25799.5n 0.7100 25800.0n 0.7100 26399.5n 0.7100 26400.0n 0.7100 26999.5n 0.7100 27000.0n 0.7100 27599.5n 0.7100 27600.0n 0.7100 28199.5n 0.7100 28200.0n 0.7100 28799.5n 0.7100 28800.0n 0.7100 29399.5n 0.7100 29400.0n 0.7100 29999.5n 0.7100 30000.0n 0.7100 30599.5n 0.7100 30600.0n 0.7100 31199.5n 0.7100 31200.0n 0.7100 31799.5n 0.7100 31800.0n 0.7100 32399.5n 0.7100 32400.0n 0.7100 32999.5n 0.7100 33000.0n 0.7100 33599.5n 0.7100 33600.0n 0.7100 34199.5n 0.7100 34200.0n 0.7100 34799.5n 0.7100 34800.0n 0.7100 35399.5n 0.7100 35400.0n 0.7100 35999.5n 0.7100)
Vxn_bh_4 xn_bh_4 0 PWL(0.0n 0.2900 599.5n 0.2900 600.0n 0.2900 1199.5n 0.2900 1200.0n 0.2900 1799.5n 0.2900 1800.0n 0.2900 2399.5n 0.2900 2400.0n 0.2900 2999.5n 0.2900 3000.0n 0.2900 3599.5n 0.2900 3600.0n 0.2900 4199.5n 0.2900 4200.0n 0.2900 4799.5n 0.2900 4800.0n 0.2900 5399.5n 0.2900 5400.0n 0.2900 5999.5n 0.2900 6000.0n 0.2900 6599.5n 0.2900 6600.0n 0.2900 7199.5n 0.2900 7200.0n 0.2900 7799.5n 0.2900 7800.0n 0.2900 8399.5n 0.2900 8400.0n 0.2900 8999.5n 0.2900 9000.0n 0.2900 9599.5n 0.2900 9600.0n 0.2900 10199.5n 0.2900 10200.0n 0.2900 10799.5n 0.2900 10800.0n 0.2900 11399.5n 0.2900 11400.0n 0.2900 11999.5n 0.2900 12000.0n 0.2900 12599.5n 0.2900 12600.0n 0.2900 13199.5n 0.2900 13200.0n 0.2900 13799.5n 0.2900 13800.0n 0.2900 14399.5n 0.2900 14400.0n 0.2900 14999.5n 0.2900 15000.0n 0.2900 15599.5n 0.2900 15600.0n 0.2900 16199.5n 0.2900 16200.0n 0.2900 16799.5n 0.2900 16800.0n 0.2900 17399.5n 0.2900 17400.0n 0.2900 17999.5n 0.2900 18000.0n 0.2900 18599.5n 0.2900 18600.0n 0.2900 19199.5n 0.2900 19200.0n 0.2900 19799.5n 0.2900 19800.0n 0.2900 20399.5n 0.2900 20400.0n 0.2900 20999.5n 0.2900 21000.0n 0.2900 21599.5n 0.2900 21600.0n 0.2900 22199.5n 0.2900 22200.0n 0.2900 22799.5n 0.2900 22800.0n 0.2900 23399.5n 0.2900 23400.0n 0.2900 23999.5n 0.2900 24000.0n 0.2900 24599.5n 0.2900 24600.0n 0.2900 25199.5n 0.2900 25200.0n 0.2900 25799.5n 0.2900 25800.0n 0.2900 26399.5n 0.2900 26400.0n 0.2900 26999.5n 0.2900 27000.0n 0.2900 27599.5n 0.2900 27600.0n 0.2900 28199.5n 0.2900 28200.0n 0.2900 28799.5n 0.2900 28800.0n 0.2900 29399.5n 0.2900 29400.0n 0.2900 29999.5n 0.2900 30000.0n 0.2900 30599.5n 0.2900 30600.0n 0.2900 31199.5n 0.2900 31200.0n 0.2900 31799.5n 0.2900 31800.0n 0.2900 32399.5n 0.2900 32400.0n 0.2900 32999.5n 0.2900 33000.0n 0.2900 33599.5n 0.2900 33600.0n 0.2900 34199.5n 0.2900 34200.0n 0.2900 34799.5n 0.2900 34800.0n 0.2900 35399.5n 0.2900 35400.0n 0.2900 35999.5n 0.2900)
Vyp_bh_4 yp_bh_4 0 PWL(0.0n 0.3640 599.5n 0.3640 600.0n 0.3914 1199.5n 0.3914 1200.0n 0.4181 1799.5n 0.4181 1800.0n 0.4709 2399.5n 0.4709 2400.0n 0.4520 2999.5n 0.4520 3000.0n 0.3972 3599.5n 0.3972 3600.0n 0.4043 4199.5n 0.4043 4200.0n 0.3616 4799.5n 0.3616 4800.0n 0.3986 5399.5n 0.3986 5400.0n 0.3994 5999.5n 0.3994 6000.0n 0.4284 6599.5n 0.4284 6600.0n 0.3893 7199.5n 0.3893 7200.0n 0.4051 7799.5n 0.4051 7800.0n 0.4104 8399.5n 0.4104 8400.0n 0.3689 8999.5n 0.3689 9000.0n 0.3987 9599.5n 0.3987 9600.0n 0.4115 10199.5n 0.4115 10200.0n 0.4190 10799.5n 0.4190 10800.0n 0.4142 11399.5n 0.4142 11400.0n 0.3940 11999.5n 0.3940 12000.0n 0.3618 12599.5n 0.3618 12600.0n 0.4141 13199.5n 0.4141 13200.0n 0.3633 13799.5n 0.3633 13800.0n 0.3833 14399.5n 0.3833 14400.0n 0.3924 14999.5n 0.3924 15000.0n 0.4319 15599.5n 0.4319 15600.0n 0.3724 16199.5n 0.3724 16200.0n 0.3663 16799.5n 0.3663 16800.0n 0.3709 17399.5n 0.3709 17400.0n 0.3683 17999.5n 0.3683 18000.0n 0.4957 18599.5n 0.4957 18600.0n 0.4039 19199.5n 0.4039 19200.0n 0.5231 19799.5n 0.5231 19800.0n 0.5078 20399.5n 0.5078 20400.0n 0.5249 20999.5n 0.5249 21000.0n 0.4170 21599.5n 0.4170 21600.0n 0.4664 22199.5n 0.4664 22200.0n 0.4115 22799.5n 0.4115 22800.0n 0.5434 23399.5n 0.5434 23400.0n 0.3308 23999.5n 0.3308 24000.0n 0.5431 24599.5n 0.5431 24600.0n 0.3915 25199.5n 0.3915 25200.0n 0.5145 25799.5n 0.5145 25800.0n 0.5143 26399.5n 0.5143 26400.0n 0.5344 26999.5n 0.5344 27000.0n 0.5111 27599.5n 0.5111 27600.0n 0.5349 28199.5n 0.5349 28200.0n 0.3354 28799.5n 0.3354 28800.0n 0.5327 29399.5n 0.5327 29400.0n 0.4028 29999.5n 0.4028 30000.0n 0.3778 30599.5n 0.3778 30600.0n 0.3273 31199.5n 0.3273 31200.0n 0.3312 31799.5n 0.3312 31800.0n 0.5041 32399.5n 0.5041 32400.0n 0.5168 32999.5n 0.5168 33000.0n 0.5349 33599.5n 0.5349 33600.0n 0.5419 34199.5n 0.5419 34200.0n 0.3720 34799.5n 0.3720 34800.0n 0.3455 35399.5n 0.3455 35400.0n 0.5294 35999.5n 0.5294)
Vyn_bh_4 yn_bh_4 0 PWL(0.0n 0.6360 599.5n 0.6360 600.0n 0.6086 1199.5n 0.6086 1200.0n 0.5819 1799.5n 0.5819 1800.0n 0.5291 2399.5n 0.5291 2400.0n 0.5480 2999.5n 0.5480 3000.0n 0.6028 3599.5n 0.6028 3600.0n 0.5957 4199.5n 0.5957 4200.0n 0.6384 4799.5n 0.6384 4800.0n 0.6014 5399.5n 0.6014 5400.0n 0.6006 5999.5n 0.6006 6000.0n 0.5716 6599.5n 0.5716 6600.0n 0.6107 7199.5n 0.6107 7200.0n 0.5949 7799.5n 0.5949 7800.0n 0.5896 8399.5n 0.5896 8400.0n 0.6311 8999.5n 0.6311 9000.0n 0.6013 9599.5n 0.6013 9600.0n 0.5885 10199.5n 0.5885 10200.0n 0.5810 10799.5n 0.5810 10800.0n 0.5858 11399.5n 0.5858 11400.0n 0.6060 11999.5n 0.6060 12000.0n 0.6382 12599.5n 0.6382 12600.0n 0.5859 13199.5n 0.5859 13200.0n 0.6367 13799.5n 0.6367 13800.0n 0.6167 14399.5n 0.6167 14400.0n 0.6076 14999.5n 0.6076 15000.0n 0.5681 15599.5n 0.5681 15600.0n 0.6276 16199.5n 0.6276 16200.0n 0.6337 16799.5n 0.6337 16800.0n 0.6291 17399.5n 0.6291 17400.0n 0.6317 17999.5n 0.6317 18000.0n 0.5043 18599.5n 0.5043 18600.0n 0.5961 19199.5n 0.5961 19200.0n 0.4769 19799.5n 0.4769 19800.0n 0.4922 20399.5n 0.4922 20400.0n 0.4751 20999.5n 0.4751 21000.0n 0.5830 21599.5n 0.5830 21600.0n 0.5336 22199.5n 0.5336 22200.0n 0.5885 22799.5n 0.5885 22800.0n 0.4566 23399.5n 0.4566 23400.0n 0.6692 23999.5n 0.6692 24000.0n 0.4569 24599.5n 0.4569 24600.0n 0.6085 25199.5n 0.6085 25200.0n 0.4855 25799.5n 0.4855 25800.0n 0.4857 26399.5n 0.4857 26400.0n 0.4656 26999.5n 0.4656 27000.0n 0.4889 27599.5n 0.4889 27600.0n 0.4651 28199.5n 0.4651 28200.0n 0.6646 28799.5n 0.6646 28800.0n 0.4673 29399.5n 0.4673 29400.0n 0.5972 29999.5n 0.5972 30000.0n 0.6222 30599.5n 0.6222 30600.0n 0.6727 31199.5n 0.6727 31200.0n 0.6688 31799.5n 0.6688 31800.0n 0.4959 32399.5n 0.4959 32400.0n 0.4832 32999.5n 0.4832 33000.0n 0.4651 33599.5n 0.4651 33600.0n 0.4581 34199.5n 0.4581 34200.0n 0.6280 34799.5n 0.6280 34800.0n 0.6545 35399.5n 0.6545 35400.0n 0.4706 35999.5n 0.4706)
Cwp_bh_4 wp_bh_4 0 400p
Cwn_bh_4 wn_bh_4 0 400p
Xu_bh_4 xp_bh_4 xn_bh_4 yp_bh_4 yn_bh_4 wp_bh_4 wn_bh_4 vdd gbn gprod
Vxp_wih_0_5 xp_wih_0_5 0 PWL(0.0n 0.4942 599.5n 0.4942 600.0n 0.5558 1199.5n 0.5558 1200.0n 0.4708 1799.5n 0.4708 1800.0n 0.5235 2399.5n 0.5235 2400.0n 0.5350 2999.5n 0.5350 3000.0n 0.5172 3599.5n 0.5172 3600.0n 0.4702 4199.5n 0.4702 4200.0n 0.4867 4799.5n 0.4867 4800.0n 0.4970 5399.5n 0.4970 5400.0n 0.4986 5999.5n 0.4986 6000.0n 0.4751 6599.5n 0.4751 6600.0n 0.4870 7199.5n 0.4870 7200.0n 0.5502 7799.5n 0.5502 7800.0n 0.5521 8399.5n 0.5521 8400.0n 0.4638 8999.5n 0.4638 9000.0n 0.4982 9599.5n 0.4982 9600.0n 0.5131 10199.5n 0.5131 10200.0n 0.5386 10799.5n 0.5386 10800.0n 0.4592 11399.5n 0.4592 11400.0n 0.4950 11999.5n 0.4950 12000.0n 0.4559 12599.5n 0.4559 12600.0n 0.5162 13199.5n 0.5162 13200.0n 0.5038 13799.5n 0.5038 13800.0n 0.5333 14399.5n 0.5333 14400.0n 0.4991 14999.5n 0.4991 15000.0n 0.5298 15599.5n 0.5298 15600.0n 0.4823 16199.5n 0.4823 16200.0n 0.5239 16799.5n 0.5239 16800.0n 0.4592 17399.5n 0.4592 17400.0n 0.5094 17999.5n 0.5094 18000.0n 0.4337 18599.5n 0.4337 18600.0n 0.5977 19199.5n 0.5977 19200.0n 0.5364 19799.5n 0.5364 19800.0n 0.6122 20399.5n 0.6122 20400.0n 0.4856 20999.5n 0.4856 21000.0n 0.3861 21599.5n 0.3861 21600.0n 0.6094 22199.5n 0.6094 22200.0n 0.6364 22799.5n 0.6364 22800.0n 0.4807 23399.5n 0.4807 23400.0n 0.5614 23999.5n 0.5614 24000.0n 0.5913 24599.5n 0.5913 24600.0n 0.6295 25199.5n 0.6295 25200.0n 0.4496 25799.5n 0.4496 25800.0n 0.3792 26399.5n 0.3792 26400.0n 0.4434 26999.5n 0.4434 27000.0n 0.4340 27599.5n 0.4340 27600.0n 0.4461 28199.5n 0.4461 28200.0n 0.5791 28799.5n 0.5791 28800.0n 0.4777 29399.5n 0.4777 29400.0n 0.3878 29999.5n 0.3878 30000.0n 0.3832 30599.5n 0.3832 30600.0n 0.4022 31199.5n 0.4022 31200.0n 0.4482 31799.5n 0.4482 31800.0n 0.3662 32399.5n 0.3662 32400.0n 0.3857 32999.5n 0.3857 33000.0n 0.5584 33599.5n 0.5584 33600.0n 0.5284 34199.5n 0.5284 34200.0n 0.6034 34799.5n 0.6034 34800.0n 0.3469 35399.5n 0.3469 35400.0n 0.5290 35999.5n 0.5290)
Vxn_wih_0_5 xn_wih_0_5 0 PWL(0.0n 0.5058 599.5n 0.5058 600.0n 0.4442 1199.5n 0.4442 1200.0n 0.5292 1799.5n 0.5292 1800.0n 0.4765 2399.5n 0.4765 2400.0n 0.4650 2999.5n 0.4650 3000.0n 0.4828 3599.5n 0.4828 3600.0n 0.5298 4199.5n 0.5298 4200.0n 0.5133 4799.5n 0.5133 4800.0n 0.5030 5399.5n 0.5030 5400.0n 0.5014 5999.5n 0.5014 6000.0n 0.5249 6599.5n 0.5249 6600.0n 0.5130 7199.5n 0.5130 7200.0n 0.4498 7799.5n 0.4498 7800.0n 0.4479 8399.5n 0.4479 8400.0n 0.5362 8999.5n 0.5362 9000.0n 0.5018 9599.5n 0.5018 9600.0n 0.4869 10199.5n 0.4869 10200.0n 0.4614 10799.5n 0.4614 10800.0n 0.5408 11399.5n 0.5408 11400.0n 0.5050 11999.5n 0.5050 12000.0n 0.5441 12599.5n 0.5441 12600.0n 0.4838 13199.5n 0.4838 13200.0n 0.4962 13799.5n 0.4962 13800.0n 0.4667 14399.5n 0.4667 14400.0n 0.5009 14999.5n 0.5009 15000.0n 0.4702 15599.5n 0.4702 15600.0n 0.5177 16199.5n 0.5177 16200.0n 0.4761 16799.5n 0.4761 16800.0n 0.5408 17399.5n 0.5408 17400.0n 0.4906 17999.5n 0.4906 18000.0n 0.5663 18599.5n 0.5663 18600.0n 0.4023 19199.5n 0.4023 19200.0n 0.4636 19799.5n 0.4636 19800.0n 0.3878 20399.5n 0.3878 20400.0n 0.5144 20999.5n 0.5144 21000.0n 0.6139 21599.5n 0.6139 21600.0n 0.3906 22199.5n 0.3906 22200.0n 0.3636 22799.5n 0.3636 22800.0n 0.5193 23399.5n 0.5193 23400.0n 0.4386 23999.5n 0.4386 24000.0n 0.4087 24599.5n 0.4087 24600.0n 0.3705 25199.5n 0.3705 25200.0n 0.5504 25799.5n 0.5504 25800.0n 0.6208 26399.5n 0.6208 26400.0n 0.5566 26999.5n 0.5566 27000.0n 0.5660 27599.5n 0.5660 27600.0n 0.5539 28199.5n 0.5539 28200.0n 0.4209 28799.5n 0.4209 28800.0n 0.5223 29399.5n 0.5223 29400.0n 0.6122 29999.5n 0.6122 30000.0n 0.6168 30599.5n 0.6168 30600.0n 0.5978 31199.5n 0.5978 31200.0n 0.5518 31799.5n 0.5518 31800.0n 0.6338 32399.5n 0.6338 32400.0n 0.6143 32999.5n 0.6143 33000.0n 0.4416 33599.5n 0.4416 33600.0n 0.4716 34199.5n 0.4716 34200.0n 0.3966 34799.5n 0.3966 34800.0n 0.6531 35399.5n 0.6531 35400.0n 0.4710 35999.5n 0.4710)
Vyp_wih_0_5 yp_wih_0_5 0 PWL(0.0n 0.4988 599.5n 0.4988 600.0n 0.4819 1199.5n 0.4819 1200.0n 0.4717 1799.5n 0.4717 1800.0n 0.4426 2399.5n 0.4426 2400.0n 0.4521 2999.5n 0.4521 3000.0n 0.4804 3599.5n 0.4804 3600.0n 0.4787 4199.5n 0.4787 4200.0n 0.5003 4799.5n 0.5003 4800.0n 0.4805 5399.5n 0.4805 5400.0n 0.4800 5999.5n 0.4800 6000.0n 0.4663 6599.5n 0.4663 6600.0n 0.4857 7199.5n 0.4857 7200.0n 0.4750 7799.5n 0.4750 7800.0n 0.4722 8399.5n 0.4722 8400.0n 0.4973 8999.5n 0.4973 9000.0n 0.4803 9599.5n 0.4803 9600.0n 0.4733 10199.5n 0.4733 10200.0n 0.4684 10799.5n 0.4684 10800.0n 0.4745 11399.5n 0.4745 11400.0n 0.4829 11999.5n 0.4829 12000.0n 0.5013 12599.5n 0.5013 12600.0n 0.4719 13199.5n 0.4719 13200.0n 0.4988 13799.5n 0.4988 13800.0n 0.4869 14399.5n 0.4869 14400.0n 0.4836 14999.5n 0.4836 15000.0n 0.4625 15599.5n 0.4625 15600.0n 0.4947 16199.5n 0.4947 16200.0n 0.4965 16799.5n 0.4965 16800.0n 0.4964 17399.5n 0.4964 17400.0n 0.4959 17999.5n 0.4959 18000.0n 0.4277 18599.5n 0.4277 18600.0n 0.4725 19199.5n 0.4725 19200.0n 0.4076 19799.5n 0.4076 19800.0n 0.4156 20399.5n 0.4156 20400.0n 0.4071 20999.5n 0.4071 21000.0n 0.4764 21599.5n 0.4764 21600.0n 0.4403 22199.5n 0.4403 22200.0n 0.4680 22799.5n 0.4680 22800.0n 0.3993 23399.5n 0.3993 23400.0n 0.5545 23999.5n 0.5545 24000.0n 0.3935 24599.5n 0.3935 24600.0n 0.4788 25199.5n 0.4788 25200.0n 0.4148 25799.5n 0.4148 25800.0n 0.4167 26399.5n 0.4167 26400.0n 0.4039 26999.5n 0.4039 27000.0n 0.4177 27599.5n 0.4177 27600.0n 0.4035 28199.5n 0.4035 28200.0n 0.5406 28799.5n 0.5406 28800.0n 0.4028 29399.5n 0.4028 29400.0n 0.4838 29999.5n 0.4838 30000.0n 0.4966 30599.5n 0.4966 30600.0n 0.5692 31199.5n 0.5692 31200.0n 0.5589 31799.5n 0.5589 31800.0n 0.4233 32399.5n 0.4233 32400.0n 0.4152 32999.5n 0.4152 33000.0n 0.3996 33599.5n 0.3996 33600.0n 0.3976 34199.5n 0.3976 34200.0n 0.4900 34799.5n 0.4900 34800.0n 0.5203 35399.5n 0.5203 35400.0n 0.4038 35999.5n 0.4038)
Vyn_wih_0_5 yn_wih_0_5 0 PWL(0.0n 0.5012 599.5n 0.5012 600.0n 0.5181 1199.5n 0.5181 1200.0n 0.5283 1799.5n 0.5283 1800.0n 0.5574 2399.5n 0.5574 2400.0n 0.5479 2999.5n 0.5479 3000.0n 0.5196 3599.5n 0.5196 3600.0n 0.5213 4199.5n 0.5213 4200.0n 0.4997 4799.5n 0.4997 4800.0n 0.5195 5399.5n 0.5195 5400.0n 0.5200 5999.5n 0.5200 6000.0n 0.5337 6599.5n 0.5337 6600.0n 0.5143 7199.5n 0.5143 7200.0n 0.5250 7799.5n 0.5250 7800.0n 0.5278 8399.5n 0.5278 8400.0n 0.5027 8999.5n 0.5027 9000.0n 0.5197 9599.5n 0.5197 9600.0n 0.5267 10199.5n 0.5267 10200.0n 0.5316 10799.5n 0.5316 10800.0n 0.5255 11399.5n 0.5255 11400.0n 0.5171 11999.5n 0.5171 12000.0n 0.4987 12599.5n 0.4987 12600.0n 0.5281 13199.5n 0.5281 13200.0n 0.5012 13799.5n 0.5012 13800.0n 0.5131 14399.5n 0.5131 14400.0n 0.5164 14999.5n 0.5164 15000.0n 0.5375 15599.5n 0.5375 15600.0n 0.5053 16199.5n 0.5053 16200.0n 0.5035 16799.5n 0.5035 16800.0n 0.5036 17399.5n 0.5036 17400.0n 0.5041 17999.5n 0.5041 18000.0n 0.5723 18599.5n 0.5723 18600.0n 0.5275 19199.5n 0.5275 19200.0n 0.5924 19799.5n 0.5924 19800.0n 0.5844 20399.5n 0.5844 20400.0n 0.5929 20999.5n 0.5929 21000.0n 0.5236 21599.5n 0.5236 21600.0n 0.5597 22199.5n 0.5597 22200.0n 0.5320 22799.5n 0.5320 22800.0n 0.6007 23399.5n 0.6007 23400.0n 0.4455 23999.5n 0.4455 24000.0n 0.6065 24599.5n 0.6065 24600.0n 0.5212 25199.5n 0.5212 25200.0n 0.5852 25799.5n 0.5852 25800.0n 0.5833 26399.5n 0.5833 26400.0n 0.5961 26999.5n 0.5961 27000.0n 0.5823 27599.5n 0.5823 27600.0n 0.5965 28199.5n 0.5965 28200.0n 0.4594 28799.5n 0.4594 28800.0n 0.5972 29399.5n 0.5972 29400.0n 0.5162 29999.5n 0.5162 30000.0n 0.5034 30599.5n 0.5034 30600.0n 0.4308 31199.5n 0.4308 31200.0n 0.4411 31799.5n 0.4411 31800.0n 0.5767 32399.5n 0.5767 32400.0n 0.5848 32999.5n 0.5848 33000.0n 0.6004 33599.5n 0.6004 33600.0n 0.6024 34199.5n 0.6024 34200.0n 0.5100 34799.5n 0.5100 34800.0n 0.4797 35399.5n 0.4797 35400.0n 0.5962 35999.5n 0.5962)
Cwp_wih_0_5 wp_wih_0_5 0 400p
Cwn_wih_0_5 wn_wih_0_5 0 400p
Xu_wih_0_5 xp_wih_0_5 xn_wih_0_5 yp_wih_0_5 yn_wih_0_5 wp_wih_0_5 wn_wih_0_5 vdd gbn gprod
Vxp_wih_1_5 xp_wih_1_5 0 PWL(0.0n 0.5370 599.5n 0.5370 600.0n 0.5167 1199.5n 0.5167 1200.0n 0.4793 1799.5n 0.4793 1800.0n 0.4441 2399.5n 0.4441 2400.0n 0.4555 2999.5n 0.4555 3000.0n 0.5055 3599.5n 0.5055 3600.0n 0.4939 4199.5n 0.4939 4200.0n 0.5385 4799.5n 0.5385 4800.0n 0.5024 5399.5n 0.5024 5400.0n 0.5015 5999.5n 0.5015 6000.0n 0.4700 6599.5n 0.4700 6600.0n 0.5120 7199.5n 0.5120 7200.0n 0.5006 7799.5n 0.5006 7800.0n 0.4950 8399.5n 0.4950 8400.0n 0.5309 8999.5n 0.5309 9000.0n 0.5023 9599.5n 0.5023 9600.0n 0.4893 10199.5n 0.4893 10200.0n 0.4837 10799.5n 0.4837 10800.0n 0.4823 11399.5n 0.4823 11400.0n 0.5074 11999.5n 0.5074 12000.0n 0.5364 12599.5n 0.5364 12600.0n 0.4868 13199.5n 0.4868 13200.0n 0.5380 13799.5n 0.5380 13800.0n 0.5220 14399.5n 0.5220 14400.0n 0.5095 14999.5n 0.5095 15000.0n 0.4705 15599.5n 0.4705 15600.0n 0.5289 16199.5n 0.5289 16200.0n 0.5368 16799.5n 0.5368 16800.0n 0.5287 17399.5n 0.5287 17400.0n 0.5342 17999.5n 0.5342 18000.0n 0.4253 18599.5n 0.4253 18600.0n 0.5119 19199.5n 0.5119 19200.0n 0.4104 19799.5n 0.4104 19800.0n 0.4314 20399.5n 0.4314 20400.0n 0.4005 20999.5n 0.4005 21000.0n 0.4696 21599.5n 0.4696 21600.0n 0.4531 22199.5n 0.4531 22200.0n 0.5039 22799.5n 0.5039 22800.0n 0.3608 23399.5n 0.3608 23400.0n 0.6273 23999.5n 0.6273 24000.0n 0.3928 24599.5n 0.3928 24600.0n 0.5253 25199.5n 0.5253 25200.0n 0.4107 25799.5n 0.4107 25800.0n 0.3947 26399.5n 0.3947 26400.0n 0.3716 26999.5n 0.3716 27000.0n 0.4111 27599.5n 0.4111 27600.0n 0.3715 28199.5n 0.3715 28200.0n 0.5939 28799.5n 0.5939 28800.0n 0.3849 29399.5n 0.3849 29400.0n 0.4835 29999.5n 0.4835 30000.0n 0.5119 30599.5n 0.5119 30600.0n 0.6226 31199.5n 0.6226 31200.0n 0.6064 31799.5n 0.6064 31800.0n 0.4115 32399.5n 0.4115 32400.0n 0.3900 32999.5n 0.3900 33000.0n 0.3958 33599.5n 0.3958 33600.0n 0.3747 34199.5n 0.3747 34200.0n 0.5423 34799.5n 0.5423 34800.0n 0.5509 35399.5n 0.5509 35400.0n 0.3990 35999.5n 0.3990)
Vxn_wih_1_5 xn_wih_1_5 0 PWL(0.0n 0.4630 599.5n 0.4630 600.0n 0.4833 1199.5n 0.4833 1200.0n 0.5207 1799.5n 0.5207 1800.0n 0.5559 2399.5n 0.5559 2400.0n 0.5445 2999.5n 0.5445 3000.0n 0.4945 3599.5n 0.4945 3600.0n 0.5061 4199.5n 0.5061 4200.0n 0.4615 4799.5n 0.4615 4800.0n 0.4976 5399.5n 0.4976 5400.0n 0.4985 5999.5n 0.4985 6000.0n 0.5300 6599.5n 0.5300 6600.0n 0.4880 7199.5n 0.4880 7200.0n 0.4994 7799.5n 0.4994 7800.0n 0.5050 8399.5n 0.5050 8400.0n 0.4691 8999.5n 0.4691 9000.0n 0.4977 9599.5n 0.4977 9600.0n 0.5107 10199.5n 0.5107 10200.0n 0.5163 10799.5n 0.5163 10800.0n 0.5177 11399.5n 0.5177 11400.0n 0.4926 11999.5n 0.4926 12000.0n 0.4636 12599.5n 0.4636 12600.0n 0.5132 13199.5n 0.5132 13200.0n 0.4620 13799.5n 0.4620 13800.0n 0.4780 14399.5n 0.4780 14400.0n 0.4905 14999.5n 0.4905 15000.0n 0.5295 15599.5n 0.5295 15600.0n 0.4711 16199.5n 0.4711 16200.0n 0.4632 16799.5n 0.4632 16800.0n 0.4713 17399.5n 0.4713 17400.0n 0.4658 17999.5n 0.4658 18000.0n 0.5747 18599.5n 0.5747 18600.0n 0.4881 19199.5n 0.4881 19200.0n 0.5896 19799.5n 0.5896 19800.0n 0.5686 20399.5n 0.5686 20400.0n 0.5995 20999.5n 0.5995 21000.0n 0.5304 21599.5n 0.5304 21600.0n 0.5469 22199.5n 0.5469 22200.0n 0.4961 22799.5n 0.4961 22800.0n 0.6392 23399.5n 0.6392 23400.0n 0.3727 23999.5n 0.3727 24000.0n 0.6072 24599.5n 0.6072 24600.0n 0.4747 25199.5n 0.4747 25200.0n 0.5893 25799.5n 0.5893 25800.0n 0.6053 26399.5n 0.6053 26400.0n 0.6284 26999.5n 0.6284 27000.0n 0.5889 27599.5n 0.5889 27600.0n 0.6285 28199.5n 0.6285 28200.0n 0.4061 28799.5n 0.4061 28800.0n 0.6151 29399.5n 0.6151 29400.0n 0.5165 29999.5n 0.5165 30000.0n 0.4881 30599.5n 0.4881 30600.0n 0.3774 31199.5n 0.3774 31200.0n 0.3936 31799.5n 0.3936 31800.0n 0.5885 32399.5n 0.5885 32400.0n 0.6100 32999.5n 0.6100 33000.0n 0.6042 33599.5n 0.6042 33600.0n 0.6253 34199.5n 0.6253 34200.0n 0.4577 34799.5n 0.4577 34800.0n 0.4491 35399.5n 0.4491 35400.0n 0.6010 35999.5n 0.6010)
Vyp_wih_1_5 yp_wih_1_5 0 PWL(0.0n 0.4988 599.5n 0.4988 600.0n 0.4819 1199.5n 0.4819 1200.0n 0.4717 1799.5n 0.4717 1800.0n 0.4426 2399.5n 0.4426 2400.0n 0.4521 2999.5n 0.4521 3000.0n 0.4804 3599.5n 0.4804 3600.0n 0.4787 4199.5n 0.4787 4200.0n 0.5003 4799.5n 0.5003 4800.0n 0.4805 5399.5n 0.4805 5400.0n 0.4800 5999.5n 0.4800 6000.0n 0.4663 6599.5n 0.4663 6600.0n 0.4857 7199.5n 0.4857 7200.0n 0.4750 7799.5n 0.4750 7800.0n 0.4722 8399.5n 0.4722 8400.0n 0.4973 8999.5n 0.4973 9000.0n 0.4803 9599.5n 0.4803 9600.0n 0.4733 10199.5n 0.4733 10200.0n 0.4684 10799.5n 0.4684 10800.0n 0.4745 11399.5n 0.4745 11400.0n 0.4829 11999.5n 0.4829 12000.0n 0.5013 12599.5n 0.5013 12600.0n 0.4719 13199.5n 0.4719 13200.0n 0.4988 13799.5n 0.4988 13800.0n 0.4869 14399.5n 0.4869 14400.0n 0.4836 14999.5n 0.4836 15000.0n 0.4625 15599.5n 0.4625 15600.0n 0.4947 16199.5n 0.4947 16200.0n 0.4965 16799.5n 0.4965 16800.0n 0.4964 17399.5n 0.4964 17400.0n 0.4959 17999.5n 0.4959 18000.0n 0.4277 18599.5n 0.4277 18600.0n 0.4725 19199.5n 0.4725 19200.0n 0.4076 19799.5n 0.4076 19800.0n 0.4156 20399.5n 0.4156 20400.0n 0.4071 20999.5n 0.4071 21000.0n 0.4764 21599.5n 0.4764 21600.0n 0.4403 22199.5n 0.4403 22200.0n 0.4680 22799.5n 0.4680 22800.0n 0.3993 23399.5n 0.3993 23400.0n 0.5545 23999.5n 0.5545 24000.0n 0.3935 24599.5n 0.3935 24600.0n 0.4788 25199.5n 0.4788 25200.0n 0.4148 25799.5n 0.4148 25800.0n 0.4167 26399.5n 0.4167 26400.0n 0.4039 26999.5n 0.4039 27000.0n 0.4177 27599.5n 0.4177 27600.0n 0.4035 28199.5n 0.4035 28200.0n 0.5406 28799.5n 0.5406 28800.0n 0.4028 29399.5n 0.4028 29400.0n 0.4838 29999.5n 0.4838 30000.0n 0.4966 30599.5n 0.4966 30600.0n 0.5692 31199.5n 0.5692 31200.0n 0.5589 31799.5n 0.5589 31800.0n 0.4233 32399.5n 0.4233 32400.0n 0.4152 32999.5n 0.4152 33000.0n 0.3996 33599.5n 0.3996 33600.0n 0.3976 34199.5n 0.3976 34200.0n 0.4900 34799.5n 0.4900 34800.0n 0.5203 35399.5n 0.5203 35400.0n 0.4038 35999.5n 0.4038)
Vyn_wih_1_5 yn_wih_1_5 0 PWL(0.0n 0.5012 599.5n 0.5012 600.0n 0.5181 1199.5n 0.5181 1200.0n 0.5283 1799.5n 0.5283 1800.0n 0.5574 2399.5n 0.5574 2400.0n 0.5479 2999.5n 0.5479 3000.0n 0.5196 3599.5n 0.5196 3600.0n 0.5213 4199.5n 0.5213 4200.0n 0.4997 4799.5n 0.4997 4800.0n 0.5195 5399.5n 0.5195 5400.0n 0.5200 5999.5n 0.5200 6000.0n 0.5337 6599.5n 0.5337 6600.0n 0.5143 7199.5n 0.5143 7200.0n 0.5250 7799.5n 0.5250 7800.0n 0.5278 8399.5n 0.5278 8400.0n 0.5027 8999.5n 0.5027 9000.0n 0.5197 9599.5n 0.5197 9600.0n 0.5267 10199.5n 0.5267 10200.0n 0.5316 10799.5n 0.5316 10800.0n 0.5255 11399.5n 0.5255 11400.0n 0.5171 11999.5n 0.5171 12000.0n 0.4987 12599.5n 0.4987 12600.0n 0.5281 13199.5n 0.5281 13200.0n 0.5012 13799.5n 0.5012 13800.0n 0.5131 14399.5n 0.5131 14400.0n 0.5164 14999.5n 0.5164 15000.0n 0.5375 15599.5n 0.5375 15600.0n 0.5053 16199.5n 0.5053 16200.0n 0.5035 16799.5n 0.5035 16800.0n 0.5036 17399.5n 0.5036 17400.0n 0.5041 17999.5n 0.5041 18000.0n 0.5723 18599.5n 0.5723 18600.0n 0.5275 19199.5n 0.5275 19200.0n 0.5924 19799.5n 0.5924 19800.0n 0.5844 20399.5n 0.5844 20400.0n 0.5929 20999.5n 0.5929 21000.0n 0.5236 21599.5n 0.5236 21600.0n 0.5597 22199.5n 0.5597 22200.0n 0.5320 22799.5n 0.5320 22800.0n 0.6007 23399.5n 0.6007 23400.0n 0.4455 23999.5n 0.4455 24000.0n 0.6065 24599.5n 0.6065 24600.0n 0.5212 25199.5n 0.5212 25200.0n 0.5852 25799.5n 0.5852 25800.0n 0.5833 26399.5n 0.5833 26400.0n 0.5961 26999.5n 0.5961 27000.0n 0.5823 27599.5n 0.5823 27600.0n 0.5965 28199.5n 0.5965 28200.0n 0.4594 28799.5n 0.4594 28800.0n 0.5972 29399.5n 0.5972 29400.0n 0.5162 29999.5n 0.5162 30000.0n 0.5034 30599.5n 0.5034 30600.0n 0.4308 31199.5n 0.4308 31200.0n 0.4411 31799.5n 0.4411 31800.0n 0.5767 32399.5n 0.5767 32400.0n 0.5848 32999.5n 0.5848 33000.0n 0.6004 33599.5n 0.6004 33600.0n 0.6024 34199.5n 0.6024 34200.0n 0.5100 34799.5n 0.5100 34800.0n 0.4797 35399.5n 0.4797 35400.0n 0.5962 35999.5n 0.5962)
Cwp_wih_1_5 wp_wih_1_5 0 400p
Cwn_wih_1_5 wn_wih_1_5 0 400p
Xu_wih_1_5 xp_wih_1_5 xn_wih_1_5 yp_wih_1_5 yn_wih_1_5 wp_wih_1_5 wn_wih_1_5 vdd gbn gprod
Vxp_who_5_0 xp_who_5_0 0 PWL(0.0n 0.4988 599.5n 0.4988 600.0n 0.4819 1199.5n 0.4819 1200.0n 0.4717 1799.5n 0.4717 1800.0n 0.4426 2399.5n 0.4426 2400.0n 0.4521 2999.5n 0.4521 3000.0n 0.4804 3599.5n 0.4804 3600.0n 0.4787 4199.5n 0.4787 4200.0n 0.5003 4799.5n 0.5003 4800.0n 0.4805 5399.5n 0.4805 5400.0n 0.4800 5999.5n 0.4800 6000.0n 0.4663 6599.5n 0.4663 6600.0n 0.4857 7199.5n 0.4857 7200.0n 0.4750 7799.5n 0.4750 7800.0n 0.4722 8399.5n 0.4722 8400.0n 0.4973 8999.5n 0.4973 9000.0n 0.4803 9599.5n 0.4803 9600.0n 0.4733 10199.5n 0.4733 10200.0n 0.4684 10799.5n 0.4684 10800.0n 0.4745 11399.5n 0.4745 11400.0n 0.4829 11999.5n 0.4829 12000.0n 0.5013 12599.5n 0.5013 12600.0n 0.4719 13199.5n 0.4719 13200.0n 0.4988 13799.5n 0.4988 13800.0n 0.4869 14399.5n 0.4869 14400.0n 0.4836 14999.5n 0.4836 15000.0n 0.4625 15599.5n 0.4625 15600.0n 0.4947 16199.5n 0.4947 16200.0n 0.4965 16799.5n 0.4965 16800.0n 0.4964 17399.5n 0.4964 17400.0n 0.4959 17999.5n 0.4959 18000.0n 0.4277 18599.5n 0.4277 18600.0n 0.4725 19199.5n 0.4725 19200.0n 0.4076 19799.5n 0.4076 19800.0n 0.4156 20399.5n 0.4156 20400.0n 0.4071 20999.5n 0.4071 21000.0n 0.4764 21599.5n 0.4764 21600.0n 0.4403 22199.5n 0.4403 22200.0n 0.4680 22799.5n 0.4680 22800.0n 0.3993 23399.5n 0.3993 23400.0n 0.5545 23999.5n 0.5545 24000.0n 0.3935 24599.5n 0.3935 24600.0n 0.4788 25199.5n 0.4788 25200.0n 0.4148 25799.5n 0.4148 25800.0n 0.4167 26399.5n 0.4167 26400.0n 0.4039 26999.5n 0.4039 27000.0n 0.4177 27599.5n 0.4177 27600.0n 0.4035 28199.5n 0.4035 28200.0n 0.5406 28799.5n 0.5406 28800.0n 0.4028 29399.5n 0.4028 29400.0n 0.4838 29999.5n 0.4838 30000.0n 0.4966 30599.5n 0.4966 30600.0n 0.5692 31199.5n 0.5692 31200.0n 0.5589 31799.5n 0.5589 31800.0n 0.4233 32399.5n 0.4233 32400.0n 0.4152 32999.5n 0.4152 33000.0n 0.3996 33599.5n 0.3996 33600.0n 0.3976 34199.5n 0.3976 34200.0n 0.4900 34799.5n 0.4900 34800.0n 0.5203 35399.5n 0.5203 35400.0n 0.4038 35999.5n 0.4038)
Vxn_who_5_0 xn_who_5_0 0 PWL(0.0n 0.5012 599.5n 0.5012 600.0n 0.5181 1199.5n 0.5181 1200.0n 0.5283 1799.5n 0.5283 1800.0n 0.5574 2399.5n 0.5574 2400.0n 0.5479 2999.5n 0.5479 3000.0n 0.5196 3599.5n 0.5196 3600.0n 0.5213 4199.5n 0.5213 4200.0n 0.4997 4799.5n 0.4997 4800.0n 0.5195 5399.5n 0.5195 5400.0n 0.5200 5999.5n 0.5200 6000.0n 0.5337 6599.5n 0.5337 6600.0n 0.5143 7199.5n 0.5143 7200.0n 0.5250 7799.5n 0.5250 7800.0n 0.5278 8399.5n 0.5278 8400.0n 0.5027 8999.5n 0.5027 9000.0n 0.5197 9599.5n 0.5197 9600.0n 0.5267 10199.5n 0.5267 10200.0n 0.5316 10799.5n 0.5316 10800.0n 0.5255 11399.5n 0.5255 11400.0n 0.5171 11999.5n 0.5171 12000.0n 0.4987 12599.5n 0.4987 12600.0n 0.5281 13199.5n 0.5281 13200.0n 0.5012 13799.5n 0.5012 13800.0n 0.5131 14399.5n 0.5131 14400.0n 0.5164 14999.5n 0.5164 15000.0n 0.5375 15599.5n 0.5375 15600.0n 0.5053 16199.5n 0.5053 16200.0n 0.5035 16799.5n 0.5035 16800.0n 0.5036 17399.5n 0.5036 17400.0n 0.5041 17999.5n 0.5041 18000.0n 0.5723 18599.5n 0.5723 18600.0n 0.5275 19199.5n 0.5275 19200.0n 0.5924 19799.5n 0.5924 19800.0n 0.5844 20399.5n 0.5844 20400.0n 0.5929 20999.5n 0.5929 21000.0n 0.5236 21599.5n 0.5236 21600.0n 0.5597 22199.5n 0.5597 22200.0n 0.5320 22799.5n 0.5320 22800.0n 0.6007 23399.5n 0.6007 23400.0n 0.4455 23999.5n 0.4455 24000.0n 0.6065 24599.5n 0.6065 24600.0n 0.5212 25199.5n 0.5212 25200.0n 0.5852 25799.5n 0.5852 25800.0n 0.5833 26399.5n 0.5833 26400.0n 0.5961 26999.5n 0.5961 27000.0n 0.5823 27599.5n 0.5823 27600.0n 0.5965 28199.5n 0.5965 28200.0n 0.4594 28799.5n 0.4594 28800.0n 0.5972 29399.5n 0.5972 29400.0n 0.5162 29999.5n 0.5162 30000.0n 0.5034 30599.5n 0.5034 30600.0n 0.4308 31199.5n 0.4308 31200.0n 0.4411 31799.5n 0.4411 31800.0n 0.5767 32399.5n 0.5767 32400.0n 0.5848 32999.5n 0.5848 33000.0n 0.6004 33599.5n 0.6004 33600.0n 0.6024 34199.5n 0.6024 34200.0n 0.5100 34799.5n 0.5100 34800.0n 0.4797 35399.5n 0.4797 35400.0n 0.5962 35999.5n 0.5962)
Vyp_who_5_0 yp_who_5_0 0 PWL(0.0n 0.5031 599.5n 0.5031 600.0n 0.5023 1199.5n 0.5023 1200.0n 0.5052 1799.5n 0.5052 1800.0n 0.5048 2399.5n 0.5048 2400.0n 0.5043 2999.5n 0.5043 3000.0n 0.5034 3599.5n 0.5034 3600.0n 0.5048 4199.5n 0.5048 4200.0n 0.5031 4799.5n 0.5031 4800.0n 0.5040 5399.5n 0.5040 5400.0n 0.5040 5999.5n 0.5040 6000.0n 0.5054 6599.5n 0.5054 6600.0n 0.5040 7199.5n 0.5040 7200.0n 0.5027 7799.5n 0.5027 7800.0n 0.5027 8399.5n 0.5027 8400.0n 0.5038 8999.5n 0.5038 9000.0n 0.5040 9599.5n 0.5040 9600.0n 0.5039 10199.5n 0.5039 10200.0n 0.5033 10799.5n 0.5033 10800.0n 0.5056 11399.5n 0.5056 11400.0n 0.5040 11999.5n 0.5040 12000.0n 0.5036 12599.5n 0.5036 12600.0n 0.5039 13199.5n 0.5039 13200.0n 0.5029 13799.5n 0.5029 13800.0n 0.5025 14399.5n 0.5025 14400.0n 0.5038 14999.5n 0.5038 15000.0n 0.5041 15599.5n 0.5041 15600.0n 0.5036 16199.5n 0.5036 16200.0n 0.5025 16799.5n 0.5025 16800.0n 0.5040 17399.5n 0.5040 17400.0n 0.5029 17999.5n 0.5029 18000.0n 0.5057 18599.5n 0.5057 18600.0n 0.5010 19199.5n 0.5010 19200.0n 0.5041 19799.5n 0.5041 19800.0n 0.5021 20399.5n 0.5021 20400.0n 0.5044 20999.5n 0.5044 21000.0n 0.5056 21599.5n 0.5056 21600.0n 0.5016 22199.5n 0.5016 22200.0n 0.5006 22799.5n 0.5006 22800.0n 0.5041 23399.5n 0.5041 23400.0n 0.5027 23999.5n 0.5027 24000.0n 0.5029 24599.5n 0.5029 24600.0n 0.5006 25199.5n 0.5006 25200.0n 0.5047 25799.5n 0.5047 25800.0n 0.5046 26399.5n 0.5046 26400.0n 0.5039 26999.5n 0.5039 27000.0n 0.5049 27599.5n 0.5049 27600.0n 0.5039 28199.5n 0.5039 28200.0n 0.5017 28799.5n 0.5017 28800.0n 0.5042 29399.5n 0.5042 29400.0n 0.5056 29999.5n 0.5056 30000.0n 0.5051 30599.5n 0.5051 30600.0n 0.5039 31199.5n 0.5039 31200.0n 0.5033 31799.5n 0.5033 31800.0n 0.5049 32399.5n 0.5049 32400.0n 0.5045 32999.5n 0.5045 33000.0n 0.5036 33599.5n 0.5036 33600.0n 0.5042 34199.5n 0.5042 34200.0n 0.5012 34799.5n 0.5012 34800.0n 0.5036 35399.5n 0.5036 35400.0n 0.5042 35999.5n 0.5042)
Vyn_who_5_0 yn_who_5_0 0 PWL(0.0n 0.4969 599.5n 0.4969 600.0n 0.4977 1199.5n 0.4977 1200.0n 0.4948 1799.5n 0.4948 1800.0n 0.4952 2399.5n 0.4952 2400.0n 0.4957 2999.5n 0.4957 3000.0n 0.4966 3599.5n 0.4966 3600.0n 0.4952 4199.5n 0.4952 4200.0n 0.4969 4799.5n 0.4969 4800.0n 0.4960 5399.5n 0.4960 5400.0n 0.4960 5999.5n 0.4960 6000.0n 0.4946 6599.5n 0.4946 6600.0n 0.4960 7199.5n 0.4960 7200.0n 0.4973 7799.5n 0.4973 7800.0n 0.4973 8399.5n 0.4973 8400.0n 0.4962 8999.5n 0.4962 9000.0n 0.4960 9599.5n 0.4960 9600.0n 0.4961 10199.5n 0.4961 10200.0n 0.4967 10799.5n 0.4967 10800.0n 0.4944 11399.5n 0.4944 11400.0n 0.4960 11999.5n 0.4960 12000.0n 0.4964 12599.5n 0.4964 12600.0n 0.4961 13199.5n 0.4961 13200.0n 0.4971 13799.5n 0.4971 13800.0n 0.4975 14399.5n 0.4975 14400.0n 0.4962 14999.5n 0.4962 15000.0n 0.4959 15599.5n 0.4959 15600.0n 0.4964 16199.5n 0.4964 16200.0n 0.4975 16799.5n 0.4975 16800.0n 0.4960 17399.5n 0.4960 17400.0n 0.4971 17999.5n 0.4971 18000.0n 0.4943 18599.5n 0.4943 18600.0n 0.4990 19199.5n 0.4990 19200.0n 0.4959 19799.5n 0.4959 19800.0n 0.4979 20399.5n 0.4979 20400.0n 0.4956 20999.5n 0.4956 21000.0n 0.4944 21599.5n 0.4944 21600.0n 0.4984 22199.5n 0.4984 22200.0n 0.4994 22799.5n 0.4994 22800.0n 0.4959 23399.5n 0.4959 23400.0n 0.4973 23999.5n 0.4973 24000.0n 0.4971 24599.5n 0.4971 24600.0n 0.4994 25199.5n 0.4994 25200.0n 0.4953 25799.5n 0.4953 25800.0n 0.4954 26399.5n 0.4954 26400.0n 0.4961 26999.5n 0.4961 27000.0n 0.4951 27599.5n 0.4951 27600.0n 0.4961 28199.5n 0.4961 28200.0n 0.4983 28799.5n 0.4983 28800.0n 0.4958 29399.5n 0.4958 29400.0n 0.4944 29999.5n 0.4944 30000.0n 0.4949 30599.5n 0.4949 30600.0n 0.4961 31199.5n 0.4961 31200.0n 0.4967 31799.5n 0.4967 31800.0n 0.4951 32399.5n 0.4951 32400.0n 0.4955 32999.5n 0.4955 33000.0n 0.4964 33599.5n 0.4964 33600.0n 0.4958 34199.5n 0.4958 34200.0n 0.4988 34799.5n 0.4988 34800.0n 0.4964 35399.5n 0.4964 35400.0n 0.4958 35999.5n 0.4958)
Cwp_who_5_0 wp_who_5_0 0 400p
Cwn_who_5_0 wn_who_5_0 0 400p
Xu_who_5_0 xp_who_5_0 xn_who_5_0 yp_who_5_0 yn_who_5_0 wp_who_5_0 wn_who_5_0 vdd gbn gprod
Vxp_who_5_1 xp_who_5_1 0 PWL(0.0n 0.4988 599.5n 0.4988 600.0n 0.4819 1199.5n 0.4819 1200.0n 0.4717 1799.5n 0.4717 1800.0n 0.4426 2399.5n 0.4426 2400.0n 0.4521 2999.5n 0.4521 3000.0n 0.4804 3599.5n 0.4804 3600.0n 0.4787 4199.5n 0.4787 4200.0n 0.5003 4799.5n 0.5003 4800.0n 0.4805 5399.5n 0.4805 5400.0n 0.4800 5999.5n 0.4800 6000.0n 0.4663 6599.5n 0.4663 6600.0n 0.4857 7199.5n 0.4857 7200.0n 0.4750 7799.5n 0.4750 7800.0n 0.4722 8399.5n 0.4722 8400.0n 0.4973 8999.5n 0.4973 9000.0n 0.4803 9599.5n 0.4803 9600.0n 0.4733 10199.5n 0.4733 10200.0n 0.4684 10799.5n 0.4684 10800.0n 0.4745 11399.5n 0.4745 11400.0n 0.4829 11999.5n 0.4829 12000.0n 0.5013 12599.5n 0.5013 12600.0n 0.4719 13199.5n 0.4719 13200.0n 0.4988 13799.5n 0.4988 13800.0n 0.4869 14399.5n 0.4869 14400.0n 0.4836 14999.5n 0.4836 15000.0n 0.4625 15599.5n 0.4625 15600.0n 0.4947 16199.5n 0.4947 16200.0n 0.4965 16799.5n 0.4965 16800.0n 0.4964 17399.5n 0.4964 17400.0n 0.4959 17999.5n 0.4959 18000.0n 0.4277 18599.5n 0.4277 18600.0n 0.4725 19199.5n 0.4725 19200.0n 0.4076 19799.5n 0.4076 19800.0n 0.4156 20399.5n 0.4156 20400.0n 0.4071 20999.5n 0.4071 21000.0n 0.4764 21599.5n 0.4764 21600.0n 0.4403 22199.5n 0.4403 22200.0n 0.4680 22799.5n 0.4680 22800.0n 0.3993 23399.5n 0.3993 23400.0n 0.5545 23999.5n 0.5545 24000.0n 0.3935 24599.5n 0.3935 24600.0n 0.4788 25199.5n 0.4788 25200.0n 0.4148 25799.5n 0.4148 25800.0n 0.4167 26399.5n 0.4167 26400.0n 0.4039 26999.5n 0.4039 27000.0n 0.4177 27599.5n 0.4177 27600.0n 0.4035 28199.5n 0.4035 28200.0n 0.5406 28799.5n 0.5406 28800.0n 0.4028 29399.5n 0.4028 29400.0n 0.4838 29999.5n 0.4838 30000.0n 0.4966 30599.5n 0.4966 30600.0n 0.5692 31199.5n 0.5692 31200.0n 0.5589 31799.5n 0.5589 31800.0n 0.4233 32399.5n 0.4233 32400.0n 0.4152 32999.5n 0.4152 33000.0n 0.3996 33599.5n 0.3996 33600.0n 0.3976 34199.5n 0.3976 34200.0n 0.4900 34799.5n 0.4900 34800.0n 0.5203 35399.5n 0.5203 35400.0n 0.4038 35999.5n 0.4038)
Vxn_who_5_1 xn_who_5_1 0 PWL(0.0n 0.5012 599.5n 0.5012 600.0n 0.5181 1199.5n 0.5181 1200.0n 0.5283 1799.5n 0.5283 1800.0n 0.5574 2399.5n 0.5574 2400.0n 0.5479 2999.5n 0.5479 3000.0n 0.5196 3599.5n 0.5196 3600.0n 0.5213 4199.5n 0.5213 4200.0n 0.4997 4799.5n 0.4997 4800.0n 0.5195 5399.5n 0.5195 5400.0n 0.5200 5999.5n 0.5200 6000.0n 0.5337 6599.5n 0.5337 6600.0n 0.5143 7199.5n 0.5143 7200.0n 0.5250 7799.5n 0.5250 7800.0n 0.5278 8399.5n 0.5278 8400.0n 0.5027 8999.5n 0.5027 9000.0n 0.5197 9599.5n 0.5197 9600.0n 0.5267 10199.5n 0.5267 10200.0n 0.5316 10799.5n 0.5316 10800.0n 0.5255 11399.5n 0.5255 11400.0n 0.5171 11999.5n 0.5171 12000.0n 0.4987 12599.5n 0.4987 12600.0n 0.5281 13199.5n 0.5281 13200.0n 0.5012 13799.5n 0.5012 13800.0n 0.5131 14399.5n 0.5131 14400.0n 0.5164 14999.5n 0.5164 15000.0n 0.5375 15599.5n 0.5375 15600.0n 0.5053 16199.5n 0.5053 16200.0n 0.5035 16799.5n 0.5035 16800.0n 0.5036 17399.5n 0.5036 17400.0n 0.5041 17999.5n 0.5041 18000.0n 0.5723 18599.5n 0.5723 18600.0n 0.5275 19199.5n 0.5275 19200.0n 0.5924 19799.5n 0.5924 19800.0n 0.5844 20399.5n 0.5844 20400.0n 0.5929 20999.5n 0.5929 21000.0n 0.5236 21599.5n 0.5236 21600.0n 0.5597 22199.5n 0.5597 22200.0n 0.5320 22799.5n 0.5320 22800.0n 0.6007 23399.5n 0.6007 23400.0n 0.4455 23999.5n 0.4455 24000.0n 0.6065 24599.5n 0.6065 24600.0n 0.5212 25199.5n 0.5212 25200.0n 0.5852 25799.5n 0.5852 25800.0n 0.5833 26399.5n 0.5833 26400.0n 0.5961 26999.5n 0.5961 27000.0n 0.5823 27599.5n 0.5823 27600.0n 0.5965 28199.5n 0.5965 28200.0n 0.4594 28799.5n 0.4594 28800.0n 0.5972 29399.5n 0.5972 29400.0n 0.5162 29999.5n 0.5162 30000.0n 0.5034 30599.5n 0.5034 30600.0n 0.4308 31199.5n 0.4308 31200.0n 0.4411 31799.5n 0.4411 31800.0n 0.5767 32399.5n 0.5767 32400.0n 0.5848 32999.5n 0.5848 33000.0n 0.6004 33599.5n 0.6004 33600.0n 0.6024 34199.5n 0.6024 34200.0n 0.5100 34799.5n 0.5100 34800.0n 0.4797 35399.5n 0.4797 35400.0n 0.5962 35999.5n 0.5962)
Vyp_who_5_1 yp_who_5_1 0 PWL(0.0n 0.5071 599.5n 0.5071 600.0n 0.5053 1199.5n 0.5053 1200.0n 0.5052 1799.5n 0.5052 1800.0n 0.5027 2399.5n 0.5027 2400.0n 0.5034 2999.5n 0.5034 3000.0n 0.5055 3599.5n 0.5055 3600.0n 0.5056 4199.5n 0.5056 4200.0n 0.5071 4799.5n 0.5071 4800.0n 0.5056 5399.5n 0.5056 5400.0n 0.5056 5999.5n 0.5056 6000.0n 0.5048 6599.5n 0.5048 6600.0n 0.5060 7199.5n 0.5060 7200.0n 0.5048 7799.5n 0.5048 7800.0n 0.5046 8399.5n 0.5046 8400.0n 0.5066 8999.5n 0.5066 9000.0n 0.5056 9599.5n 0.5056 9600.0n 0.5051 10199.5n 0.5051 10200.0n 0.5046 10799.5n 0.5046 10800.0n 0.5056 11399.5n 0.5056 11400.0n 0.5058 11999.5n 0.5058 12000.0n 0.5068 12599.5n 0.5068 12600.0n 0.5050 13199.5n 0.5050 13200.0n 0.5071 13799.5n 0.5071 13800.0n 0.5059 14399.5n 0.5059 14400.0n 0.5058 14999.5n 0.5058 15000.0n 0.5043 15599.5n 0.5043 15600.0n 0.5067 16199.5n 0.5067 16200.0n 0.5068 16799.5n 0.5068 16800.0n 0.5066 17399.5n 0.5066 17400.0n 0.5069 17999.5n 0.5069 18000.0n 0.5061 18599.5n 0.5061 18600.0n 0.5034 19199.5n 0.5034 19200.0n 0.5010 19799.5n 0.5010 19800.0n 0.4989 20399.5n 0.4989 20400.0n 0.5022 20999.5n 0.5022 21000.0n 0.5086 21599.5n 0.5086 21600.0n 0.5007 22199.5n 0.5007 22200.0n 0.5023 22799.5n 0.5023 22800.0n 0.5021 23399.5n 0.5021 23400.0n 0.5077 23999.5n 0.5077 24000.0n 0.4979 24599.5n 0.4979 24600.0n 0.5035 25199.5n 0.5035 25200.0n 0.5041 25799.5n 0.5041 25800.0n 0.5075 26399.5n 0.5075 26400.0n 0.5041 26999.5n 0.5041 27000.0n 0.5056 27599.5n 0.5056 27600.0n 0.5039 28199.5n 0.5039 28200.0n 0.5059 28799.5n 0.5059 28800.0n 0.5023 29399.5n 0.5023 29400.0n 0.5086 29999.5n 0.5086 30000.0n 0.5084 30599.5n 0.5084 30600.0n 0.5085 31199.5n 0.5085 31200.0n 0.5088 31799.5n 0.5088 31800.0n 0.5078 32399.5n 0.5078 32400.0n 0.5074 32999.5n 0.5074 33000.0n 0.4996 33599.5n 0.4996 33600.0n 0.5010 34199.5n 0.5010 34200.0n 0.5044 34799.5n 0.5044 34800.0n 0.5084 35399.5n 0.5084 35400.0n 0.5012 35999.5n 0.5012)
Vyn_who_5_1 yn_who_5_1 0 PWL(0.0n 0.4929 599.5n 0.4929 600.0n 0.4947 1199.5n 0.4947 1200.0n 0.4948 1799.5n 0.4948 1800.0n 0.4973 2399.5n 0.4973 2400.0n 0.4966 2999.5n 0.4966 3000.0n 0.4945 3599.5n 0.4945 3600.0n 0.4944 4199.5n 0.4944 4200.0n 0.4929 4799.5n 0.4929 4800.0n 0.4944 5399.5n 0.4944 5400.0n 0.4944 5999.5n 0.4944 6000.0n 0.4952 6599.5n 0.4952 6600.0n 0.4940 7199.5n 0.4940 7200.0n 0.4952 7799.5n 0.4952 7800.0n 0.4954 8399.5n 0.4954 8400.0n 0.4934 8999.5n 0.4934 9000.0n 0.4944 9599.5n 0.4944 9600.0n 0.4949 10199.5n 0.4949 10200.0n 0.4954 10799.5n 0.4954 10800.0n 0.4944 11399.5n 0.4944 11400.0n 0.4942 11999.5n 0.4942 12000.0n 0.4932 12599.5n 0.4932 12600.0n 0.4950 13199.5n 0.4950 13200.0n 0.4929 13799.5n 0.4929 13800.0n 0.4941 14399.5n 0.4941 14400.0n 0.4942 14999.5n 0.4942 15000.0n 0.4957 15599.5n 0.4957 15600.0n 0.4933 16199.5n 0.4933 16200.0n 0.4932 16799.5n 0.4932 16800.0n 0.4934 17399.5n 0.4934 17400.0n 0.4931 17999.5n 0.4931 18000.0n 0.4939 18599.5n 0.4939 18600.0n 0.4966 19199.5n 0.4966 19200.0n 0.4990 19799.5n 0.4990 19800.0n 0.5011 20399.5n 0.5011 20400.0n 0.4978 20999.5n 0.4978 21000.0n 0.4914 21599.5n 0.4914 21600.0n 0.4993 22199.5n 0.4993 22200.0n 0.4977 22799.5n 0.4977 22800.0n 0.4979 23399.5n 0.4979 23400.0n 0.4923 23999.5n 0.4923 24000.0n 0.5021 24599.5n 0.5021 24600.0n 0.4965 25199.5n 0.4965 25200.0n 0.4959 25799.5n 0.4959 25800.0n 0.4925 26399.5n 0.4925 26400.0n 0.4959 26999.5n 0.4959 27000.0n 0.4944 27599.5n 0.4944 27600.0n 0.4961 28199.5n 0.4961 28200.0n 0.4941 28799.5n 0.4941 28800.0n 0.4977 29399.5n 0.4977 29400.0n 0.4914 29999.5n 0.4914 30000.0n 0.4916 30599.5n 0.4916 30600.0n 0.4915 31199.5n 0.4915 31200.0n 0.4912 31799.5n 0.4912 31800.0n 0.4922 32399.5n 0.4922 32400.0n 0.4926 32999.5n 0.4926 33000.0n 0.5004 33599.5n 0.5004 33600.0n 0.4990 34199.5n 0.4990 34200.0n 0.4956 34799.5n 0.4956 34800.0n 0.4916 35399.5n 0.4916 35400.0n 0.4988 35999.5n 0.4988)
Cwp_who_5_1 wp_who_5_1 0 400p
Cwn_who_5_1 wn_who_5_1 0 400p
Xu_who_5_1 xp_who_5_1 xn_who_5_1 yp_who_5_1 yn_who_5_1 wp_who_5_1 wn_who_5_1 vdd gbn gprod
Vxp_bh_5 xp_bh_5 0 PWL(0.0n 0.7100 599.5n 0.7100 600.0n 0.7100 1199.5n 0.7100 1200.0n 0.7100 1799.5n 0.7100 1800.0n 0.7100 2399.5n 0.7100 2400.0n 0.7100 2999.5n 0.7100 3000.0n 0.7100 3599.5n 0.7100 3600.0n 0.7100 4199.5n 0.7100 4200.0n 0.7100 4799.5n 0.7100 4800.0n 0.7100 5399.5n 0.7100 5400.0n 0.7100 5999.5n 0.7100 6000.0n 0.7100 6599.5n 0.7100 6600.0n 0.7100 7199.5n 0.7100 7200.0n 0.7100 7799.5n 0.7100 7800.0n 0.7100 8399.5n 0.7100 8400.0n 0.7100 8999.5n 0.7100 9000.0n 0.7100 9599.5n 0.7100 9600.0n 0.7100 10199.5n 0.7100 10200.0n 0.7100 10799.5n 0.7100 10800.0n 0.7100 11399.5n 0.7100 11400.0n 0.7100 11999.5n 0.7100 12000.0n 0.7100 12599.5n 0.7100 12600.0n 0.7100 13199.5n 0.7100 13200.0n 0.7100 13799.5n 0.7100 13800.0n 0.7100 14399.5n 0.7100 14400.0n 0.7100 14999.5n 0.7100 15000.0n 0.7100 15599.5n 0.7100 15600.0n 0.7100 16199.5n 0.7100 16200.0n 0.7100 16799.5n 0.7100 16800.0n 0.7100 17399.5n 0.7100 17400.0n 0.7100 17999.5n 0.7100 18000.0n 0.7100 18599.5n 0.7100 18600.0n 0.7100 19199.5n 0.7100 19200.0n 0.7100 19799.5n 0.7100 19800.0n 0.7100 20399.5n 0.7100 20400.0n 0.7100 20999.5n 0.7100 21000.0n 0.7100 21599.5n 0.7100 21600.0n 0.7100 22199.5n 0.7100 22200.0n 0.7100 22799.5n 0.7100 22800.0n 0.7100 23399.5n 0.7100 23400.0n 0.7100 23999.5n 0.7100 24000.0n 0.7100 24599.5n 0.7100 24600.0n 0.7100 25199.5n 0.7100 25200.0n 0.7100 25799.5n 0.7100 25800.0n 0.7100 26399.5n 0.7100 26400.0n 0.7100 26999.5n 0.7100 27000.0n 0.7100 27599.5n 0.7100 27600.0n 0.7100 28199.5n 0.7100 28200.0n 0.7100 28799.5n 0.7100 28800.0n 0.7100 29399.5n 0.7100 29400.0n 0.7100 29999.5n 0.7100 30000.0n 0.7100 30599.5n 0.7100 30600.0n 0.7100 31199.5n 0.7100 31200.0n 0.7100 31799.5n 0.7100 31800.0n 0.7100 32399.5n 0.7100 32400.0n 0.7100 32999.5n 0.7100 33000.0n 0.7100 33599.5n 0.7100 33600.0n 0.7100 34199.5n 0.7100 34200.0n 0.7100 34799.5n 0.7100 34800.0n 0.7100 35399.5n 0.7100 35400.0n 0.7100 35999.5n 0.7100)
Vxn_bh_5 xn_bh_5 0 PWL(0.0n 0.2900 599.5n 0.2900 600.0n 0.2900 1199.5n 0.2900 1200.0n 0.2900 1799.5n 0.2900 1800.0n 0.2900 2399.5n 0.2900 2400.0n 0.2900 2999.5n 0.2900 3000.0n 0.2900 3599.5n 0.2900 3600.0n 0.2900 4199.5n 0.2900 4200.0n 0.2900 4799.5n 0.2900 4800.0n 0.2900 5399.5n 0.2900 5400.0n 0.2900 5999.5n 0.2900 6000.0n 0.2900 6599.5n 0.2900 6600.0n 0.2900 7199.5n 0.2900 7200.0n 0.2900 7799.5n 0.2900 7800.0n 0.2900 8399.5n 0.2900 8400.0n 0.2900 8999.5n 0.2900 9000.0n 0.2900 9599.5n 0.2900 9600.0n 0.2900 10199.5n 0.2900 10200.0n 0.2900 10799.5n 0.2900 10800.0n 0.2900 11399.5n 0.2900 11400.0n 0.2900 11999.5n 0.2900 12000.0n 0.2900 12599.5n 0.2900 12600.0n 0.2900 13199.5n 0.2900 13200.0n 0.2900 13799.5n 0.2900 13800.0n 0.2900 14399.5n 0.2900 14400.0n 0.2900 14999.5n 0.2900 15000.0n 0.2900 15599.5n 0.2900 15600.0n 0.2900 16199.5n 0.2900 16200.0n 0.2900 16799.5n 0.2900 16800.0n 0.2900 17399.5n 0.2900 17400.0n 0.2900 17999.5n 0.2900 18000.0n 0.2900 18599.5n 0.2900 18600.0n 0.2900 19199.5n 0.2900 19200.0n 0.2900 19799.5n 0.2900 19800.0n 0.2900 20399.5n 0.2900 20400.0n 0.2900 20999.5n 0.2900 21000.0n 0.2900 21599.5n 0.2900 21600.0n 0.2900 22199.5n 0.2900 22200.0n 0.2900 22799.5n 0.2900 22800.0n 0.2900 23399.5n 0.2900 23400.0n 0.2900 23999.5n 0.2900 24000.0n 0.2900 24599.5n 0.2900 24600.0n 0.2900 25199.5n 0.2900 25200.0n 0.2900 25799.5n 0.2900 25800.0n 0.2900 26399.5n 0.2900 26400.0n 0.2900 26999.5n 0.2900 27000.0n 0.2900 27599.5n 0.2900 27600.0n 0.2900 28199.5n 0.2900 28200.0n 0.2900 28799.5n 0.2900 28800.0n 0.2900 29399.5n 0.2900 29400.0n 0.2900 29999.5n 0.2900 30000.0n 0.2900 30599.5n 0.2900 30600.0n 0.2900 31199.5n 0.2900 31200.0n 0.2900 31799.5n 0.2900 31800.0n 0.2900 32399.5n 0.2900 32400.0n 0.2900 32999.5n 0.2900 33000.0n 0.2900 33599.5n 0.2900 33600.0n 0.2900 34199.5n 0.2900 34200.0n 0.2900 34799.5n 0.2900 34800.0n 0.2900 35399.5n 0.2900 35400.0n 0.2900 35999.5n 0.2900)
Vyp_bh_5 yp_bh_5 0 PWL(0.0n 0.4988 599.5n 0.4988 600.0n 0.4819 1199.5n 0.4819 1200.0n 0.4717 1799.5n 0.4717 1800.0n 0.4426 2399.5n 0.4426 2400.0n 0.4521 2999.5n 0.4521 3000.0n 0.4804 3599.5n 0.4804 3600.0n 0.4787 4199.5n 0.4787 4200.0n 0.5003 4799.5n 0.5003 4800.0n 0.4805 5399.5n 0.4805 5400.0n 0.4800 5999.5n 0.4800 6000.0n 0.4663 6599.5n 0.4663 6600.0n 0.4857 7199.5n 0.4857 7200.0n 0.4750 7799.5n 0.4750 7800.0n 0.4722 8399.5n 0.4722 8400.0n 0.4973 8999.5n 0.4973 9000.0n 0.4803 9599.5n 0.4803 9600.0n 0.4733 10199.5n 0.4733 10200.0n 0.4684 10799.5n 0.4684 10800.0n 0.4745 11399.5n 0.4745 11400.0n 0.4829 11999.5n 0.4829 12000.0n 0.5013 12599.5n 0.5013 12600.0n 0.4719 13199.5n 0.4719 13200.0n 0.4988 13799.5n 0.4988 13800.0n 0.4869 14399.5n 0.4869 14400.0n 0.4836 14999.5n 0.4836 15000.0n 0.4625 15599.5n 0.4625 15600.0n 0.4947 16199.5n 0.4947 16200.0n 0.4965 16799.5n 0.4965 16800.0n 0.4964 17399.5n 0.4964 17400.0n 0.4959 17999.5n 0.4959 18000.0n 0.4277 18599.5n 0.4277 18600.0n 0.4725 19199.5n 0.4725 19200.0n 0.4076 19799.5n 0.4076 19800.0n 0.4156 20399.5n 0.4156 20400.0n 0.4071 20999.5n 0.4071 21000.0n 0.4764 21599.5n 0.4764 21600.0n 0.4403 22199.5n 0.4403 22200.0n 0.4680 22799.5n 0.4680 22800.0n 0.3993 23399.5n 0.3993 23400.0n 0.5545 23999.5n 0.5545 24000.0n 0.3935 24599.5n 0.3935 24600.0n 0.4788 25199.5n 0.4788 25200.0n 0.4148 25799.5n 0.4148 25800.0n 0.4167 26399.5n 0.4167 26400.0n 0.4039 26999.5n 0.4039 27000.0n 0.4177 27599.5n 0.4177 27600.0n 0.4035 28199.5n 0.4035 28200.0n 0.5406 28799.5n 0.5406 28800.0n 0.4028 29399.5n 0.4028 29400.0n 0.4838 29999.5n 0.4838 30000.0n 0.4966 30599.5n 0.4966 30600.0n 0.5692 31199.5n 0.5692 31200.0n 0.5589 31799.5n 0.5589 31800.0n 0.4233 32399.5n 0.4233 32400.0n 0.4152 32999.5n 0.4152 33000.0n 0.3996 33599.5n 0.3996 33600.0n 0.3976 34199.5n 0.3976 34200.0n 0.4900 34799.5n 0.4900 34800.0n 0.5203 35399.5n 0.5203 35400.0n 0.4038 35999.5n 0.4038)
Vyn_bh_5 yn_bh_5 0 PWL(0.0n 0.5012 599.5n 0.5012 600.0n 0.5181 1199.5n 0.5181 1200.0n 0.5283 1799.5n 0.5283 1800.0n 0.5574 2399.5n 0.5574 2400.0n 0.5479 2999.5n 0.5479 3000.0n 0.5196 3599.5n 0.5196 3600.0n 0.5213 4199.5n 0.5213 4200.0n 0.4997 4799.5n 0.4997 4800.0n 0.5195 5399.5n 0.5195 5400.0n 0.5200 5999.5n 0.5200 6000.0n 0.5337 6599.5n 0.5337 6600.0n 0.5143 7199.5n 0.5143 7200.0n 0.5250 7799.5n 0.5250 7800.0n 0.5278 8399.5n 0.5278 8400.0n 0.5027 8999.5n 0.5027 9000.0n 0.5197 9599.5n 0.5197 9600.0n 0.5267 10199.5n 0.5267 10200.0n 0.5316 10799.5n 0.5316 10800.0n 0.5255 11399.5n 0.5255 11400.0n 0.5171 11999.5n 0.5171 12000.0n 0.4987 12599.5n 0.4987 12600.0n 0.5281 13199.5n 0.5281 13200.0n 0.5012 13799.5n 0.5012 13800.0n 0.5131 14399.5n 0.5131 14400.0n 0.5164 14999.5n 0.5164 15000.0n 0.5375 15599.5n 0.5375 15600.0n 0.5053 16199.5n 0.5053 16200.0n 0.5035 16799.5n 0.5035 16800.0n 0.5036 17399.5n 0.5036 17400.0n 0.5041 17999.5n 0.5041 18000.0n 0.5723 18599.5n 0.5723 18600.0n 0.5275 19199.5n 0.5275 19200.0n 0.5924 19799.5n 0.5924 19800.0n 0.5844 20399.5n 0.5844 20400.0n 0.5929 20999.5n 0.5929 21000.0n 0.5236 21599.5n 0.5236 21600.0n 0.5597 22199.5n 0.5597 22200.0n 0.5320 22799.5n 0.5320 22800.0n 0.6007 23399.5n 0.6007 23400.0n 0.4455 23999.5n 0.4455 24000.0n 0.6065 24599.5n 0.6065 24600.0n 0.5212 25199.5n 0.5212 25200.0n 0.5852 25799.5n 0.5852 25800.0n 0.5833 26399.5n 0.5833 26400.0n 0.5961 26999.5n 0.5961 27000.0n 0.5823 27599.5n 0.5823 27600.0n 0.5965 28199.5n 0.5965 28200.0n 0.4594 28799.5n 0.4594 28800.0n 0.5972 29399.5n 0.5972 29400.0n 0.5162 29999.5n 0.5162 30000.0n 0.5034 30599.5n 0.5034 30600.0n 0.4308 31199.5n 0.4308 31200.0n 0.4411 31799.5n 0.4411 31800.0n 0.5767 32399.5n 0.5767 32400.0n 0.5848 32999.5n 0.5848 33000.0n 0.6004 33599.5n 0.6004 33600.0n 0.6024 34199.5n 0.6024 34200.0n 0.5100 34799.5n 0.5100 34800.0n 0.4797 35399.5n 0.4797 35400.0n 0.5962 35999.5n 0.5962)
Cwp_bh_5 wp_bh_5 0 400p
Cwn_bh_5 wn_bh_5 0 400p
Xu_bh_5 xp_bh_5 xn_bh_5 yp_bh_5 yn_bh_5 wp_bh_5 wn_bh_5 vdd gbn gprod
Vxp_wih_0_6 xp_wih_0_6 0 PWL(0.0n 0.4942 599.5n 0.4942 600.0n 0.5558 1199.5n 0.5558 1200.0n 0.4708 1799.5n 0.4708 1800.0n 0.5235 2399.5n 0.5235 2400.0n 0.5350 2999.5n 0.5350 3000.0n 0.5172 3599.5n 0.5172 3600.0n 0.4702 4199.5n 0.4702 4200.0n 0.4867 4799.5n 0.4867 4800.0n 0.4970 5399.5n 0.4970 5400.0n 0.4986 5999.5n 0.4986 6000.0n 0.4751 6599.5n 0.4751 6600.0n 0.4870 7199.5n 0.4870 7200.0n 0.5502 7799.5n 0.5502 7800.0n 0.5521 8399.5n 0.5521 8400.0n 0.4638 8999.5n 0.4638 9000.0n 0.4982 9599.5n 0.4982 9600.0n 0.5131 10199.5n 0.5131 10200.0n 0.5386 10799.5n 0.5386 10800.0n 0.4592 11399.5n 0.4592 11400.0n 0.4950 11999.5n 0.4950 12000.0n 0.4559 12599.5n 0.4559 12600.0n 0.5162 13199.5n 0.5162 13200.0n 0.5038 13799.5n 0.5038 13800.0n 0.5333 14399.5n 0.5333 14400.0n 0.4991 14999.5n 0.4991 15000.0n 0.5298 15599.5n 0.5298 15600.0n 0.4823 16199.5n 0.4823 16200.0n 0.5239 16799.5n 0.5239 16800.0n 0.4592 17399.5n 0.4592 17400.0n 0.5094 17999.5n 0.5094 18000.0n 0.4337 18599.5n 0.4337 18600.0n 0.5977 19199.5n 0.5977 19200.0n 0.5364 19799.5n 0.5364 19800.0n 0.6122 20399.5n 0.6122 20400.0n 0.4856 20999.5n 0.4856 21000.0n 0.3861 21599.5n 0.3861 21600.0n 0.6094 22199.5n 0.6094 22200.0n 0.6364 22799.5n 0.6364 22800.0n 0.4807 23399.5n 0.4807 23400.0n 0.5614 23999.5n 0.5614 24000.0n 0.5913 24599.5n 0.5913 24600.0n 0.6295 25199.5n 0.6295 25200.0n 0.4496 25799.5n 0.4496 25800.0n 0.3792 26399.5n 0.3792 26400.0n 0.4434 26999.5n 0.4434 27000.0n 0.4340 27599.5n 0.4340 27600.0n 0.4461 28199.5n 0.4461 28200.0n 0.5791 28799.5n 0.5791 28800.0n 0.4777 29399.5n 0.4777 29400.0n 0.3878 29999.5n 0.3878 30000.0n 0.3832 30599.5n 0.3832 30600.0n 0.4022 31199.5n 0.4022 31200.0n 0.4482 31799.5n 0.4482 31800.0n 0.3662 32399.5n 0.3662 32400.0n 0.3857 32999.5n 0.3857 33000.0n 0.5584 33599.5n 0.5584 33600.0n 0.5284 34199.5n 0.5284 34200.0n 0.6034 34799.5n 0.6034 34800.0n 0.3469 35399.5n 0.3469 35400.0n 0.5290 35999.5n 0.5290)
Vxn_wih_0_6 xn_wih_0_6 0 PWL(0.0n 0.5058 599.5n 0.5058 600.0n 0.4442 1199.5n 0.4442 1200.0n 0.5292 1799.5n 0.5292 1800.0n 0.4765 2399.5n 0.4765 2400.0n 0.4650 2999.5n 0.4650 3000.0n 0.4828 3599.5n 0.4828 3600.0n 0.5298 4199.5n 0.5298 4200.0n 0.5133 4799.5n 0.5133 4800.0n 0.5030 5399.5n 0.5030 5400.0n 0.5014 5999.5n 0.5014 6000.0n 0.5249 6599.5n 0.5249 6600.0n 0.5130 7199.5n 0.5130 7200.0n 0.4498 7799.5n 0.4498 7800.0n 0.4479 8399.5n 0.4479 8400.0n 0.5362 8999.5n 0.5362 9000.0n 0.5018 9599.5n 0.5018 9600.0n 0.4869 10199.5n 0.4869 10200.0n 0.4614 10799.5n 0.4614 10800.0n 0.5408 11399.5n 0.5408 11400.0n 0.5050 11999.5n 0.5050 12000.0n 0.5441 12599.5n 0.5441 12600.0n 0.4838 13199.5n 0.4838 13200.0n 0.4962 13799.5n 0.4962 13800.0n 0.4667 14399.5n 0.4667 14400.0n 0.5009 14999.5n 0.5009 15000.0n 0.4702 15599.5n 0.4702 15600.0n 0.5177 16199.5n 0.5177 16200.0n 0.4761 16799.5n 0.4761 16800.0n 0.5408 17399.5n 0.5408 17400.0n 0.4906 17999.5n 0.4906 18000.0n 0.5663 18599.5n 0.5663 18600.0n 0.4023 19199.5n 0.4023 19200.0n 0.4636 19799.5n 0.4636 19800.0n 0.3878 20399.5n 0.3878 20400.0n 0.5144 20999.5n 0.5144 21000.0n 0.6139 21599.5n 0.6139 21600.0n 0.3906 22199.5n 0.3906 22200.0n 0.3636 22799.5n 0.3636 22800.0n 0.5193 23399.5n 0.5193 23400.0n 0.4386 23999.5n 0.4386 24000.0n 0.4087 24599.5n 0.4087 24600.0n 0.3705 25199.5n 0.3705 25200.0n 0.5504 25799.5n 0.5504 25800.0n 0.6208 26399.5n 0.6208 26400.0n 0.5566 26999.5n 0.5566 27000.0n 0.5660 27599.5n 0.5660 27600.0n 0.5539 28199.5n 0.5539 28200.0n 0.4209 28799.5n 0.4209 28800.0n 0.5223 29399.5n 0.5223 29400.0n 0.6122 29999.5n 0.6122 30000.0n 0.6168 30599.5n 0.6168 30600.0n 0.5978 31199.5n 0.5978 31200.0n 0.5518 31799.5n 0.5518 31800.0n 0.6338 32399.5n 0.6338 32400.0n 0.6143 32999.5n 0.6143 33000.0n 0.4416 33599.5n 0.4416 33600.0n 0.4716 34199.5n 0.4716 34200.0n 0.3966 34799.5n 0.3966 34800.0n 0.6531 35399.5n 0.6531 35400.0n 0.4710 35999.5n 0.4710)
Vyp_wih_0_6 yp_wih_0_6 0 PWL(0.0n 0.4757 599.5n 0.4757 600.0n 0.5257 1199.5n 0.5257 1200.0n 0.4520 1799.5n 0.4520 1800.0n 0.4821 2399.5n 0.4821 2400.0n 0.4940 2999.5n 0.4940 3000.0n 0.4867 3599.5n 0.4867 3600.0n 0.4533 4199.5n 0.4533 4200.0n 0.4711 4799.5n 0.4711 4800.0n 0.4730 5399.5n 0.4730 5400.0n 0.4740 5999.5n 0.4740 6000.0n 0.4541 6599.5n 0.4541 6600.0n 0.4676 7199.5n 0.4676 7200.0n 0.5162 7799.5n 0.5162 7800.0n 0.5181 8399.5n 0.5181 8400.0n 0.4524 8999.5n 0.4524 9000.0n 0.4738 9599.5n 0.4738 9600.0n 0.4820 10199.5n 0.4820 10200.0n 0.5014 10799.5n 0.5014 10800.0n 0.4419 11399.5n 0.4419 11400.0n 0.4723 11999.5n 0.4723 12000.0n 0.4455 12599.5n 0.4455 12600.0n 0.4838 13199.5n 0.4838 13200.0n 0.4820 13799.5n 0.4820 13800.0n 0.5012 14399.5n 0.5012 14400.0n 0.4752 14999.5n 0.4752 15000.0n 0.4919 15599.5n 0.4919 15600.0n 0.4666 16199.5n 0.4666 16200.0n 0.4956 16799.5n 0.4956 16800.0n 0.4477 17399.5n 0.4477 17400.0n 0.4851 17999.5n 0.4851 18000.0n 0.3936 18599.5n 0.3936 18600.0n 0.5717 19199.5n 0.5717 19200.0n 0.4820 19799.5n 0.4820 19800.0n 0.5639 20399.5n 0.5639 20400.0n 0.4443 20999.5n 0.4443 21000.0n 0.3704 21599.5n 0.3704 21600.0n 0.5689 22199.5n 0.5689 22200.0n 0.5843 22799.5n 0.5843 22800.0n 0.4404 23399.5n 0.4404 23400.0n 0.5544 23999.5n 0.5544 24000.0n 0.5456 24599.5n 0.5456 24600.0n 0.5851 25199.5n 0.5851 25200.0n 0.4143 25799.5n 0.4143 25800.0n 0.3529 26399.5n 0.3529 26400.0n 0.4038 26999.5n 0.4038 27000.0n 0.3906 27599.5n 0.3906 27600.0n 0.4077 28199.5n 0.4077 28200.0n 0.5789 28799.5n 0.5789 28800.0n 0.4382 29399.5n 0.4382 29400.0n 0.3728 29999.5n 0.3728 30000.0n 0.3746 30599.5n 0.3746 30600.0n 0.4037 31199.5n 0.4037 31200.0n 0.4540 31799.5n 0.4540 31800.0n 0.3521 32399.5n 0.3521 32400.0n 0.3543 32999.5n 0.3543 33000.0n 0.5063 33599.5n 0.5063 33600.0n 0.4728 34199.5n 0.4728 34200.0n 0.5785 34799.5n 0.5785 34800.0n 0.3743 35399.5n 0.3743 35400.0n 0.4737 35999.5n 0.4737)
Vyn_wih_0_6 yn_wih_0_6 0 PWL(0.0n 0.5243 599.5n 0.5243 600.0n 0.4743 1199.5n 0.4743 1200.0n 0.5480 1799.5n 0.5480 1800.0n 0.5179 2399.5n 0.5179 2400.0n 0.5060 2999.5n 0.5060 3000.0n 0.5133 3599.5n 0.5133 3600.0n 0.5467 4199.5n 0.5467 4200.0n 0.5289 4799.5n 0.5289 4800.0n 0.5270 5399.5n 0.5270 5400.0n 0.5260 5999.5n 0.5260 6000.0n 0.5459 6599.5n 0.5459 6600.0n 0.5324 7199.5n 0.5324 7200.0n 0.4838 7799.5n 0.4838 7800.0n 0.4819 8399.5n 0.4819 8400.0n 0.5476 8999.5n 0.5476 9000.0n 0.5262 9599.5n 0.5262 9600.0n 0.5180 10199.5n 0.5180 10200.0n 0.4986 10799.5n 0.4986 10800.0n 0.5581 11399.5n 0.5581 11400.0n 0.5277 11999.5n 0.5277 12000.0n 0.5545 12599.5n 0.5545 12600.0n 0.5162 13199.5n 0.5162 13200.0n 0.5180 13799.5n 0.5180 13800.0n 0.4988 14399.5n 0.4988 14400.0n 0.5248 14999.5n 0.5248 15000.0n 0.5081 15599.5n 0.5081 15600.0n 0.5334 16199.5n 0.5334 16200.0n 0.5044 16799.5n 0.5044 16800.0n 0.5523 17399.5n 0.5523 17400.0n 0.5149 17999.5n 0.5149 18000.0n 0.6064 18599.5n 0.6064 18600.0n 0.4283 19199.5n 0.4283 19200.0n 0.5180 19799.5n 0.5180 19800.0n 0.4361 20399.5n 0.4361 20400.0n 0.5557 20999.5n 0.5557 21000.0n 0.6296 21599.5n 0.6296 21600.0n 0.4311 22199.5n 0.4311 22200.0n 0.4157 22799.5n 0.4157 22800.0n 0.5596 23399.5n 0.5596 23400.0n 0.4456 23999.5n 0.4456 24000.0n 0.4544 24599.5n 0.4544 24600.0n 0.4149 25199.5n 0.4149 25200.0n 0.5857 25799.5n 0.5857 25800.0n 0.6471 26399.5n 0.6471 26400.0n 0.5962 26999.5n 0.5962 27000.0n 0.6094 27599.5n 0.6094 27600.0n 0.5923 28199.5n 0.5923 28200.0n 0.4211 28799.5n 0.4211 28800.0n 0.5618 29399.5n 0.5618 29400.0n 0.6272 29999.5n 0.6272 30000.0n 0.6254 30599.5n 0.6254 30600.0n 0.5963 31199.5n 0.5963 31200.0n 0.5460 31799.5n 0.5460 31800.0n 0.6479 32399.5n 0.6479 32400.0n 0.6457 32999.5n 0.6457 33000.0n 0.4937 33599.5n 0.4937 33600.0n 0.5272 34199.5n 0.5272 34200.0n 0.4215 34799.5n 0.4215 34800.0n 0.6257 35399.5n 0.6257 35400.0n 0.5263 35999.5n 0.5263)
Cwp_wih_0_6 wp_wih_0_6 0 400p
Cwn_wih_0_6 wn_wih_0_6 0 400p
Xu_wih_0_6 xp_wih_0_6 xn_wih_0_6 yp_wih_0_6 yn_wih_0_6 wp_wih_0_6 wn_wih_0_6 vdd gbn gprod
Vxp_wih_1_6 xp_wih_1_6 0 PWL(0.0n 0.5370 599.5n 0.5370 600.0n 0.5167 1199.5n 0.5167 1200.0n 0.4793 1799.5n 0.4793 1800.0n 0.4441 2399.5n 0.4441 2400.0n 0.4555 2999.5n 0.4555 3000.0n 0.5055 3599.5n 0.5055 3600.0n 0.4939 4199.5n 0.4939 4200.0n 0.5385 4799.5n 0.5385 4800.0n 0.5024 5399.5n 0.5024 5400.0n 0.5015 5999.5n 0.5015 6000.0n 0.4700 6599.5n 0.4700 6600.0n 0.5120 7199.5n 0.5120 7200.0n 0.5006 7799.5n 0.5006 7800.0n 0.4950 8399.5n 0.4950 8400.0n 0.5309 8999.5n 0.5309 9000.0n 0.5023 9599.5n 0.5023 9600.0n 0.4893 10199.5n 0.4893 10200.0n 0.4837 10799.5n 0.4837 10800.0n 0.4823 11399.5n 0.4823 11400.0n 0.5074 11999.5n 0.5074 12000.0n 0.5364 12599.5n 0.5364 12600.0n 0.4868 13199.5n 0.4868 13200.0n 0.5380 13799.5n 0.5380 13800.0n 0.5220 14399.5n 0.5220 14400.0n 0.5095 14999.5n 0.5095 15000.0n 0.4705 15599.5n 0.4705 15600.0n 0.5289 16199.5n 0.5289 16200.0n 0.5368 16799.5n 0.5368 16800.0n 0.5287 17399.5n 0.5287 17400.0n 0.5342 17999.5n 0.5342 18000.0n 0.4253 18599.5n 0.4253 18600.0n 0.5119 19199.5n 0.5119 19200.0n 0.4104 19799.5n 0.4104 19800.0n 0.4314 20399.5n 0.4314 20400.0n 0.4005 20999.5n 0.4005 21000.0n 0.4696 21599.5n 0.4696 21600.0n 0.4531 22199.5n 0.4531 22200.0n 0.5039 22799.5n 0.5039 22800.0n 0.3608 23399.5n 0.3608 23400.0n 0.6273 23999.5n 0.6273 24000.0n 0.3928 24599.5n 0.3928 24600.0n 0.5253 25199.5n 0.5253 25200.0n 0.4107 25799.5n 0.4107 25800.0n 0.3947 26399.5n 0.3947 26400.0n 0.3716 26999.5n 0.3716 27000.0n 0.4111 27599.5n 0.4111 27600.0n 0.3715 28199.5n 0.3715 28200.0n 0.5939 28799.5n 0.5939 28800.0n 0.3849 29399.5n 0.3849 29400.0n 0.4835 29999.5n 0.4835 30000.0n 0.5119 30599.5n 0.5119 30600.0n 0.6226 31199.5n 0.6226 31200.0n 0.6064 31799.5n 0.6064 31800.0n 0.4115 32399.5n 0.4115 32400.0n 0.3900 32999.5n 0.3900 33000.0n 0.3958 33599.5n 0.3958 33600.0n 0.3747 34199.5n 0.3747 34200.0n 0.5423 34799.5n 0.5423 34800.0n 0.5509 35399.5n 0.5509 35400.0n 0.3990 35999.5n 0.3990)
Vxn_wih_1_6 xn_wih_1_6 0 PWL(0.0n 0.4630 599.5n 0.4630 600.0n 0.4833 1199.5n 0.4833 1200.0n 0.5207 1799.5n 0.5207 1800.0n 0.5559 2399.5n 0.5559 2400.0n 0.5445 2999.5n 0.5445 3000.0n 0.4945 3599.5n 0.4945 3600.0n 0.5061 4199.5n 0.5061 4200.0n 0.4615 4799.5n 0.4615 4800.0n 0.4976 5399.5n 0.4976 5400.0n 0.4985 5999.5n 0.4985 6000.0n 0.5300 6599.5n 0.5300 6600.0n 0.4880 7199.5n 0.4880 7200.0n 0.4994 7799.5n 0.4994 7800.0n 0.5050 8399.5n 0.5050 8400.0n 0.4691 8999.5n 0.4691 9000.0n 0.4977 9599.5n 0.4977 9600.0n 0.5107 10199.5n 0.5107 10200.0n 0.5163 10799.5n 0.5163 10800.0n 0.5177 11399.5n 0.5177 11400.0n 0.4926 11999.5n 0.4926 12000.0n 0.4636 12599.5n 0.4636 12600.0n 0.5132 13199.5n 0.5132 13200.0n 0.4620 13799.5n 0.4620 13800.0n 0.4780 14399.5n 0.4780 14400.0n 0.4905 14999.5n 0.4905 15000.0n 0.5295 15599.5n 0.5295 15600.0n 0.4711 16199.5n 0.4711 16200.0n 0.4632 16799.5n 0.4632 16800.0n 0.4713 17399.5n 0.4713 17400.0n 0.4658 17999.5n 0.4658 18000.0n 0.5747 18599.5n 0.5747 18600.0n 0.4881 19199.5n 0.4881 19200.0n 0.5896 19799.5n 0.5896 19800.0n 0.5686 20399.5n 0.5686 20400.0n 0.5995 20999.5n 0.5995 21000.0n 0.5304 21599.5n 0.5304 21600.0n 0.5469 22199.5n 0.5469 22200.0n 0.4961 22799.5n 0.4961 22800.0n 0.6392 23399.5n 0.6392 23400.0n 0.3727 23999.5n 0.3727 24000.0n 0.6072 24599.5n 0.6072 24600.0n 0.4747 25199.5n 0.4747 25200.0n 0.5893 25799.5n 0.5893 25800.0n 0.6053 26399.5n 0.6053 26400.0n 0.6284 26999.5n 0.6284 27000.0n 0.5889 27599.5n 0.5889 27600.0n 0.6285 28199.5n 0.6285 28200.0n 0.4061 28799.5n 0.4061 28800.0n 0.6151 29399.5n 0.6151 29400.0n 0.5165 29999.5n 0.5165 30000.0n 0.4881 30599.5n 0.4881 30600.0n 0.3774 31199.5n 0.3774 31200.0n 0.3936 31799.5n 0.3936 31800.0n 0.5885 32399.5n 0.5885 32400.0n 0.6100 32999.5n 0.6100 33000.0n 0.6042 33599.5n 0.6042 33600.0n 0.6253 34199.5n 0.6253 34200.0n 0.4577 34799.5n 0.4577 34800.0n 0.4491 35399.5n 0.4491 35400.0n 0.6010 35999.5n 0.6010)
Vyp_wih_1_6 yp_wih_1_6 0 PWL(0.0n 0.4757 599.5n 0.4757 600.0n 0.5257 1199.5n 0.5257 1200.0n 0.4520 1799.5n 0.4520 1800.0n 0.4821 2399.5n 0.4821 2400.0n 0.4940 2999.5n 0.4940 3000.0n 0.4867 3599.5n 0.4867 3600.0n 0.4533 4199.5n 0.4533 4200.0n 0.4711 4799.5n 0.4711 4800.0n 0.4730 5399.5n 0.4730 5400.0n 0.4740 5999.5n 0.4740 6000.0n 0.4541 6599.5n 0.4541 6600.0n 0.4676 7199.5n 0.4676 7200.0n 0.5162 7799.5n 0.5162 7800.0n 0.5181 8399.5n 0.5181 8400.0n 0.4524 8999.5n 0.4524 9000.0n 0.4738 9599.5n 0.4738 9600.0n 0.4820 10199.5n 0.4820 10200.0n 0.5014 10799.5n 0.5014 10800.0n 0.4419 11399.5n 0.4419 11400.0n 0.4723 11999.5n 0.4723 12000.0n 0.4455 12599.5n 0.4455 12600.0n 0.4838 13199.5n 0.4838 13200.0n 0.4820 13799.5n 0.4820 13800.0n 0.5012 14399.5n 0.5012 14400.0n 0.4752 14999.5n 0.4752 15000.0n 0.4919 15599.5n 0.4919 15600.0n 0.4666 16199.5n 0.4666 16200.0n 0.4956 16799.5n 0.4956 16800.0n 0.4477 17399.5n 0.4477 17400.0n 0.4851 17999.5n 0.4851 18000.0n 0.3936 18599.5n 0.3936 18600.0n 0.5717 19199.5n 0.5717 19200.0n 0.4820 19799.5n 0.4820 19800.0n 0.5639 20399.5n 0.5639 20400.0n 0.4443 20999.5n 0.4443 21000.0n 0.3704 21599.5n 0.3704 21600.0n 0.5689 22199.5n 0.5689 22200.0n 0.5843 22799.5n 0.5843 22800.0n 0.4404 23399.5n 0.4404 23400.0n 0.5544 23999.5n 0.5544 24000.0n 0.5456 24599.5n 0.5456 24600.0n 0.5851 25199.5n 0.5851 25200.0n 0.4143 25799.5n 0.4143 25800.0n 0.3529 26399.5n 0.3529 26400.0n 0.4038 26999.5n 0.4038 27000.0n 0.3906 27599.5n 0.3906 27600.0n 0.4077 28199.5n 0.4077 28200.0n 0.5789 28799.5n 0.5789 28800.0n 0.4382 29399.5n 0.4382 29400.0n 0.3728 29999.5n 0.3728 30000.0n 0.3746 30599.5n 0.3746 30600.0n 0.4037 31199.5n 0.4037 31200.0n 0.4540 31799.5n 0.4540 31800.0n 0.3521 32399.5n 0.3521 32400.0n 0.3543 32999.5n 0.3543 33000.0n 0.5063 33599.5n 0.5063 33600.0n 0.4728 34199.5n 0.4728 34200.0n 0.5785 34799.5n 0.5785 34800.0n 0.3743 35399.5n 0.3743 35400.0n 0.4737 35999.5n 0.4737)
Vyn_wih_1_6 yn_wih_1_6 0 PWL(0.0n 0.5243 599.5n 0.5243 600.0n 0.4743 1199.5n 0.4743 1200.0n 0.5480 1799.5n 0.5480 1800.0n 0.5179 2399.5n 0.5179 2400.0n 0.5060 2999.5n 0.5060 3000.0n 0.5133 3599.5n 0.5133 3600.0n 0.5467 4199.5n 0.5467 4200.0n 0.5289 4799.5n 0.5289 4800.0n 0.5270 5399.5n 0.5270 5400.0n 0.5260 5999.5n 0.5260 6000.0n 0.5459 6599.5n 0.5459 6600.0n 0.5324 7199.5n 0.5324 7200.0n 0.4838 7799.5n 0.4838 7800.0n 0.4819 8399.5n 0.4819 8400.0n 0.5476 8999.5n 0.5476 9000.0n 0.5262 9599.5n 0.5262 9600.0n 0.5180 10199.5n 0.5180 10200.0n 0.4986 10799.5n 0.4986 10800.0n 0.5581 11399.5n 0.5581 11400.0n 0.5277 11999.5n 0.5277 12000.0n 0.5545 12599.5n 0.5545 12600.0n 0.5162 13199.5n 0.5162 13200.0n 0.5180 13799.5n 0.5180 13800.0n 0.4988 14399.5n 0.4988 14400.0n 0.5248 14999.5n 0.5248 15000.0n 0.5081 15599.5n 0.5081 15600.0n 0.5334 16199.5n 0.5334 16200.0n 0.5044 16799.5n 0.5044 16800.0n 0.5523 17399.5n 0.5523 17400.0n 0.5149 17999.5n 0.5149 18000.0n 0.6064 18599.5n 0.6064 18600.0n 0.4283 19199.5n 0.4283 19200.0n 0.5180 19799.5n 0.5180 19800.0n 0.4361 20399.5n 0.4361 20400.0n 0.5557 20999.5n 0.5557 21000.0n 0.6296 21599.5n 0.6296 21600.0n 0.4311 22199.5n 0.4311 22200.0n 0.4157 22799.5n 0.4157 22800.0n 0.5596 23399.5n 0.5596 23400.0n 0.4456 23999.5n 0.4456 24000.0n 0.4544 24599.5n 0.4544 24600.0n 0.4149 25199.5n 0.4149 25200.0n 0.5857 25799.5n 0.5857 25800.0n 0.6471 26399.5n 0.6471 26400.0n 0.5962 26999.5n 0.5962 27000.0n 0.6094 27599.5n 0.6094 27600.0n 0.5923 28199.5n 0.5923 28200.0n 0.4211 28799.5n 0.4211 28800.0n 0.5618 29399.5n 0.5618 29400.0n 0.6272 29999.5n 0.6272 30000.0n 0.6254 30599.5n 0.6254 30600.0n 0.5963 31199.5n 0.5963 31200.0n 0.5460 31799.5n 0.5460 31800.0n 0.6479 32399.5n 0.6479 32400.0n 0.6457 32999.5n 0.6457 33000.0n 0.4937 33599.5n 0.4937 33600.0n 0.5272 34199.5n 0.5272 34200.0n 0.4215 34799.5n 0.4215 34800.0n 0.6257 35399.5n 0.6257 35400.0n 0.5263 35999.5n 0.5263)
Cwp_wih_1_6 wp_wih_1_6 0 400p
Cwn_wih_1_6 wn_wih_1_6 0 400p
Xu_wih_1_6 xp_wih_1_6 xn_wih_1_6 yp_wih_1_6 yn_wih_1_6 wp_wih_1_6 wn_wih_1_6 vdd gbn gprod
Vxp_who_6_0 xp_who_6_0 0 PWL(0.0n 0.4757 599.5n 0.4757 600.0n 0.5257 1199.5n 0.5257 1200.0n 0.4520 1799.5n 0.4520 1800.0n 0.4821 2399.5n 0.4821 2400.0n 0.4940 2999.5n 0.4940 3000.0n 0.4867 3599.5n 0.4867 3600.0n 0.4533 4199.5n 0.4533 4200.0n 0.4711 4799.5n 0.4711 4800.0n 0.4730 5399.5n 0.4730 5400.0n 0.4740 5999.5n 0.4740 6000.0n 0.4541 6599.5n 0.4541 6600.0n 0.4676 7199.5n 0.4676 7200.0n 0.5162 7799.5n 0.5162 7800.0n 0.5181 8399.5n 0.5181 8400.0n 0.4524 8999.5n 0.4524 9000.0n 0.4738 9599.5n 0.4738 9600.0n 0.4820 10199.5n 0.4820 10200.0n 0.5014 10799.5n 0.5014 10800.0n 0.4419 11399.5n 0.4419 11400.0n 0.4723 11999.5n 0.4723 12000.0n 0.4455 12599.5n 0.4455 12600.0n 0.4838 13199.5n 0.4838 13200.0n 0.4820 13799.5n 0.4820 13800.0n 0.5012 14399.5n 0.5012 14400.0n 0.4752 14999.5n 0.4752 15000.0n 0.4919 15599.5n 0.4919 15600.0n 0.4666 16199.5n 0.4666 16200.0n 0.4956 16799.5n 0.4956 16800.0n 0.4477 17399.5n 0.4477 17400.0n 0.4851 17999.5n 0.4851 18000.0n 0.3936 18599.5n 0.3936 18600.0n 0.5717 19199.5n 0.5717 19200.0n 0.4820 19799.5n 0.4820 19800.0n 0.5639 20399.5n 0.5639 20400.0n 0.4443 20999.5n 0.4443 21000.0n 0.3704 21599.5n 0.3704 21600.0n 0.5689 22199.5n 0.5689 22200.0n 0.5843 22799.5n 0.5843 22800.0n 0.4404 23399.5n 0.4404 23400.0n 0.5544 23999.5n 0.5544 24000.0n 0.5456 24599.5n 0.5456 24600.0n 0.5851 25199.5n 0.5851 25200.0n 0.4143 25799.5n 0.4143 25800.0n 0.3529 26399.5n 0.3529 26400.0n 0.4038 26999.5n 0.4038 27000.0n 0.3906 27599.5n 0.3906 27600.0n 0.4077 28199.5n 0.4077 28200.0n 0.5789 28799.5n 0.5789 28800.0n 0.4382 29399.5n 0.4382 29400.0n 0.3728 29999.5n 0.3728 30000.0n 0.3746 30599.5n 0.3746 30600.0n 0.4037 31199.5n 0.4037 31200.0n 0.4540 31799.5n 0.4540 31800.0n 0.3521 32399.5n 0.3521 32400.0n 0.3543 32999.5n 0.3543 33000.0n 0.5063 33599.5n 0.5063 33600.0n 0.4728 34199.5n 0.4728 34200.0n 0.5785 34799.5n 0.5785 34800.0n 0.3743 35399.5n 0.3743 35400.0n 0.4737 35999.5n 0.4737)
Vxn_who_6_0 xn_who_6_0 0 PWL(0.0n 0.5243 599.5n 0.5243 600.0n 0.4743 1199.5n 0.4743 1200.0n 0.5480 1799.5n 0.5480 1800.0n 0.5179 2399.5n 0.5179 2400.0n 0.5060 2999.5n 0.5060 3000.0n 0.5133 3599.5n 0.5133 3600.0n 0.5467 4199.5n 0.5467 4200.0n 0.5289 4799.5n 0.5289 4800.0n 0.5270 5399.5n 0.5270 5400.0n 0.5260 5999.5n 0.5260 6000.0n 0.5459 6599.5n 0.5459 6600.0n 0.5324 7199.5n 0.5324 7200.0n 0.4838 7799.5n 0.4838 7800.0n 0.4819 8399.5n 0.4819 8400.0n 0.5476 8999.5n 0.5476 9000.0n 0.5262 9599.5n 0.5262 9600.0n 0.5180 10199.5n 0.5180 10200.0n 0.4986 10799.5n 0.4986 10800.0n 0.5581 11399.5n 0.5581 11400.0n 0.5277 11999.5n 0.5277 12000.0n 0.5545 12599.5n 0.5545 12600.0n 0.5162 13199.5n 0.5162 13200.0n 0.5180 13799.5n 0.5180 13800.0n 0.4988 14399.5n 0.4988 14400.0n 0.5248 14999.5n 0.5248 15000.0n 0.5081 15599.5n 0.5081 15600.0n 0.5334 16199.5n 0.5334 16200.0n 0.5044 16799.5n 0.5044 16800.0n 0.5523 17399.5n 0.5523 17400.0n 0.5149 17999.5n 0.5149 18000.0n 0.6064 18599.5n 0.6064 18600.0n 0.4283 19199.5n 0.4283 19200.0n 0.5180 19799.5n 0.5180 19800.0n 0.4361 20399.5n 0.4361 20400.0n 0.5557 20999.5n 0.5557 21000.0n 0.6296 21599.5n 0.6296 21600.0n 0.4311 22199.5n 0.4311 22200.0n 0.4157 22799.5n 0.4157 22800.0n 0.5596 23399.5n 0.5596 23400.0n 0.4456 23999.5n 0.4456 24000.0n 0.4544 24599.5n 0.4544 24600.0n 0.4149 25199.5n 0.4149 25200.0n 0.5857 25799.5n 0.5857 25800.0n 0.6471 26399.5n 0.6471 26400.0n 0.5962 26999.5n 0.5962 27000.0n 0.6094 27599.5n 0.6094 27600.0n 0.5923 28199.5n 0.5923 28200.0n 0.4211 28799.5n 0.4211 28800.0n 0.5618 29399.5n 0.5618 29400.0n 0.6272 29999.5n 0.6272 30000.0n 0.6254 30599.5n 0.6254 30600.0n 0.5963 31199.5n 0.5963 31200.0n 0.5460 31799.5n 0.5460 31800.0n 0.6479 32399.5n 0.6479 32400.0n 0.6457 32999.5n 0.6457 33000.0n 0.4937 33599.5n 0.4937 33600.0n 0.5272 34199.5n 0.5272 34200.0n 0.4215 34799.5n 0.4215 34800.0n 0.6257 35399.5n 0.6257 35400.0n 0.5263 35999.5n 0.5263)
Vyp_who_6_0 yp_who_6_0 0 PWL(0.0n 0.5031 599.5n 0.5031 600.0n 0.5023 1199.5n 0.5023 1200.0n 0.5052 1799.5n 0.5052 1800.0n 0.5048 2399.5n 0.5048 2400.0n 0.5043 2999.5n 0.5043 3000.0n 0.5034 3599.5n 0.5034 3600.0n 0.5048 4199.5n 0.5048 4200.0n 0.5031 4799.5n 0.5031 4800.0n 0.5040 5399.5n 0.5040 5400.0n 0.5040 5999.5n 0.5040 6000.0n 0.5054 6599.5n 0.5054 6600.0n 0.5040 7199.5n 0.5040 7200.0n 0.5027 7799.5n 0.5027 7800.0n 0.5027 8399.5n 0.5027 8400.0n 0.5038 8999.5n 0.5038 9000.0n 0.5040 9599.5n 0.5040 9600.0n 0.5039 10199.5n 0.5039 10200.0n 0.5033 10799.5n 0.5033 10800.0n 0.5056 11399.5n 0.5056 11400.0n 0.5040 11999.5n 0.5040 12000.0n 0.5036 12599.5n 0.5036 12600.0n 0.5039 13199.5n 0.5039 13200.0n 0.5029 13799.5n 0.5029 13800.0n 0.5025 14399.5n 0.5025 14400.0n 0.5038 14999.5n 0.5038 15000.0n 0.5041 15599.5n 0.5041 15600.0n 0.5036 16199.5n 0.5036 16200.0n 0.5025 16799.5n 0.5025 16800.0n 0.5040 17399.5n 0.5040 17400.0n 0.5029 17999.5n 0.5029 18000.0n 0.5057 18599.5n 0.5057 18600.0n 0.5010 19199.5n 0.5010 19200.0n 0.5041 19799.5n 0.5041 19800.0n 0.5021 20399.5n 0.5021 20400.0n 0.5044 20999.5n 0.5044 21000.0n 0.5056 21599.5n 0.5056 21600.0n 0.5016 22199.5n 0.5016 22200.0n 0.5006 22799.5n 0.5006 22800.0n 0.5041 23399.5n 0.5041 23400.0n 0.5027 23999.5n 0.5027 24000.0n 0.5029 24599.5n 0.5029 24600.0n 0.5006 25199.5n 0.5006 25200.0n 0.5047 25799.5n 0.5047 25800.0n 0.5046 26399.5n 0.5046 26400.0n 0.5039 26999.5n 0.5039 27000.0n 0.5049 27599.5n 0.5049 27600.0n 0.5039 28199.5n 0.5039 28200.0n 0.5017 28799.5n 0.5017 28800.0n 0.5042 29399.5n 0.5042 29400.0n 0.5056 29999.5n 0.5056 30000.0n 0.5051 30599.5n 0.5051 30600.0n 0.5039 31199.5n 0.5039 31200.0n 0.5033 31799.5n 0.5033 31800.0n 0.5049 32399.5n 0.5049 32400.0n 0.5045 32999.5n 0.5045 33000.0n 0.5036 33599.5n 0.5036 33600.0n 0.5042 34199.5n 0.5042 34200.0n 0.5012 34799.5n 0.5012 34800.0n 0.5036 35399.5n 0.5036 35400.0n 0.5042 35999.5n 0.5042)
Vyn_who_6_0 yn_who_6_0 0 PWL(0.0n 0.4969 599.5n 0.4969 600.0n 0.4977 1199.5n 0.4977 1200.0n 0.4948 1799.5n 0.4948 1800.0n 0.4952 2399.5n 0.4952 2400.0n 0.4957 2999.5n 0.4957 3000.0n 0.4966 3599.5n 0.4966 3600.0n 0.4952 4199.5n 0.4952 4200.0n 0.4969 4799.5n 0.4969 4800.0n 0.4960 5399.5n 0.4960 5400.0n 0.4960 5999.5n 0.4960 6000.0n 0.4946 6599.5n 0.4946 6600.0n 0.4960 7199.5n 0.4960 7200.0n 0.4973 7799.5n 0.4973 7800.0n 0.4973 8399.5n 0.4973 8400.0n 0.4962 8999.5n 0.4962 9000.0n 0.4960 9599.5n 0.4960 9600.0n 0.4961 10199.5n 0.4961 10200.0n 0.4967 10799.5n 0.4967 10800.0n 0.4944 11399.5n 0.4944 11400.0n 0.4960 11999.5n 0.4960 12000.0n 0.4964 12599.5n 0.4964 12600.0n 0.4961 13199.5n 0.4961 13200.0n 0.4971 13799.5n 0.4971 13800.0n 0.4975 14399.5n 0.4975 14400.0n 0.4962 14999.5n 0.4962 15000.0n 0.4959 15599.5n 0.4959 15600.0n 0.4964 16199.5n 0.4964 16200.0n 0.4975 16799.5n 0.4975 16800.0n 0.4960 17399.5n 0.4960 17400.0n 0.4971 17999.5n 0.4971 18000.0n 0.4943 18599.5n 0.4943 18600.0n 0.4990 19199.5n 0.4990 19200.0n 0.4959 19799.5n 0.4959 19800.0n 0.4979 20399.5n 0.4979 20400.0n 0.4956 20999.5n 0.4956 21000.0n 0.4944 21599.5n 0.4944 21600.0n 0.4984 22199.5n 0.4984 22200.0n 0.4994 22799.5n 0.4994 22800.0n 0.4959 23399.5n 0.4959 23400.0n 0.4973 23999.5n 0.4973 24000.0n 0.4971 24599.5n 0.4971 24600.0n 0.4994 25199.5n 0.4994 25200.0n 0.4953 25799.5n 0.4953 25800.0n 0.4954 26399.5n 0.4954 26400.0n 0.4961 26999.5n 0.4961 27000.0n 0.4951 27599.5n 0.4951 27600.0n 0.4961 28199.5n 0.4961 28200.0n 0.4983 28799.5n 0.4983 28800.0n 0.4958 29399.5n 0.4958 29400.0n 0.4944 29999.5n 0.4944 30000.0n 0.4949 30599.5n 0.4949 30600.0n 0.4961 31199.5n 0.4961 31200.0n 0.4967 31799.5n 0.4967 31800.0n 0.4951 32399.5n 0.4951 32400.0n 0.4955 32999.5n 0.4955 33000.0n 0.4964 33599.5n 0.4964 33600.0n 0.4958 34199.5n 0.4958 34200.0n 0.4988 34799.5n 0.4988 34800.0n 0.4964 35399.5n 0.4964 35400.0n 0.4958 35999.5n 0.4958)
Cwp_who_6_0 wp_who_6_0 0 400p
Cwn_who_6_0 wn_who_6_0 0 400p
Xu_who_6_0 xp_who_6_0 xn_who_6_0 yp_who_6_0 yn_who_6_0 wp_who_6_0 wn_who_6_0 vdd gbn gprod
Vxp_who_6_1 xp_who_6_1 0 PWL(0.0n 0.4757 599.5n 0.4757 600.0n 0.5257 1199.5n 0.5257 1200.0n 0.4520 1799.5n 0.4520 1800.0n 0.4821 2399.5n 0.4821 2400.0n 0.4940 2999.5n 0.4940 3000.0n 0.4867 3599.5n 0.4867 3600.0n 0.4533 4199.5n 0.4533 4200.0n 0.4711 4799.5n 0.4711 4800.0n 0.4730 5399.5n 0.4730 5400.0n 0.4740 5999.5n 0.4740 6000.0n 0.4541 6599.5n 0.4541 6600.0n 0.4676 7199.5n 0.4676 7200.0n 0.5162 7799.5n 0.5162 7800.0n 0.5181 8399.5n 0.5181 8400.0n 0.4524 8999.5n 0.4524 9000.0n 0.4738 9599.5n 0.4738 9600.0n 0.4820 10199.5n 0.4820 10200.0n 0.5014 10799.5n 0.5014 10800.0n 0.4419 11399.5n 0.4419 11400.0n 0.4723 11999.5n 0.4723 12000.0n 0.4455 12599.5n 0.4455 12600.0n 0.4838 13199.5n 0.4838 13200.0n 0.4820 13799.5n 0.4820 13800.0n 0.5012 14399.5n 0.5012 14400.0n 0.4752 14999.5n 0.4752 15000.0n 0.4919 15599.5n 0.4919 15600.0n 0.4666 16199.5n 0.4666 16200.0n 0.4956 16799.5n 0.4956 16800.0n 0.4477 17399.5n 0.4477 17400.0n 0.4851 17999.5n 0.4851 18000.0n 0.3936 18599.5n 0.3936 18600.0n 0.5717 19199.5n 0.5717 19200.0n 0.4820 19799.5n 0.4820 19800.0n 0.5639 20399.5n 0.5639 20400.0n 0.4443 20999.5n 0.4443 21000.0n 0.3704 21599.5n 0.3704 21600.0n 0.5689 22199.5n 0.5689 22200.0n 0.5843 22799.5n 0.5843 22800.0n 0.4404 23399.5n 0.4404 23400.0n 0.5544 23999.5n 0.5544 24000.0n 0.5456 24599.5n 0.5456 24600.0n 0.5851 25199.5n 0.5851 25200.0n 0.4143 25799.5n 0.4143 25800.0n 0.3529 26399.5n 0.3529 26400.0n 0.4038 26999.5n 0.4038 27000.0n 0.3906 27599.5n 0.3906 27600.0n 0.4077 28199.5n 0.4077 28200.0n 0.5789 28799.5n 0.5789 28800.0n 0.4382 29399.5n 0.4382 29400.0n 0.3728 29999.5n 0.3728 30000.0n 0.3746 30599.5n 0.3746 30600.0n 0.4037 31199.5n 0.4037 31200.0n 0.4540 31799.5n 0.4540 31800.0n 0.3521 32399.5n 0.3521 32400.0n 0.3543 32999.5n 0.3543 33000.0n 0.5063 33599.5n 0.5063 33600.0n 0.4728 34199.5n 0.4728 34200.0n 0.5785 34799.5n 0.5785 34800.0n 0.3743 35399.5n 0.3743 35400.0n 0.4737 35999.5n 0.4737)
Vxn_who_6_1 xn_who_6_1 0 PWL(0.0n 0.5243 599.5n 0.5243 600.0n 0.4743 1199.5n 0.4743 1200.0n 0.5480 1799.5n 0.5480 1800.0n 0.5179 2399.5n 0.5179 2400.0n 0.5060 2999.5n 0.5060 3000.0n 0.5133 3599.5n 0.5133 3600.0n 0.5467 4199.5n 0.5467 4200.0n 0.5289 4799.5n 0.5289 4800.0n 0.5270 5399.5n 0.5270 5400.0n 0.5260 5999.5n 0.5260 6000.0n 0.5459 6599.5n 0.5459 6600.0n 0.5324 7199.5n 0.5324 7200.0n 0.4838 7799.5n 0.4838 7800.0n 0.4819 8399.5n 0.4819 8400.0n 0.5476 8999.5n 0.5476 9000.0n 0.5262 9599.5n 0.5262 9600.0n 0.5180 10199.5n 0.5180 10200.0n 0.4986 10799.5n 0.4986 10800.0n 0.5581 11399.5n 0.5581 11400.0n 0.5277 11999.5n 0.5277 12000.0n 0.5545 12599.5n 0.5545 12600.0n 0.5162 13199.5n 0.5162 13200.0n 0.5180 13799.5n 0.5180 13800.0n 0.4988 14399.5n 0.4988 14400.0n 0.5248 14999.5n 0.5248 15000.0n 0.5081 15599.5n 0.5081 15600.0n 0.5334 16199.5n 0.5334 16200.0n 0.5044 16799.5n 0.5044 16800.0n 0.5523 17399.5n 0.5523 17400.0n 0.5149 17999.5n 0.5149 18000.0n 0.6064 18599.5n 0.6064 18600.0n 0.4283 19199.5n 0.4283 19200.0n 0.5180 19799.5n 0.5180 19800.0n 0.4361 20399.5n 0.4361 20400.0n 0.5557 20999.5n 0.5557 21000.0n 0.6296 21599.5n 0.6296 21600.0n 0.4311 22199.5n 0.4311 22200.0n 0.4157 22799.5n 0.4157 22800.0n 0.5596 23399.5n 0.5596 23400.0n 0.4456 23999.5n 0.4456 24000.0n 0.4544 24599.5n 0.4544 24600.0n 0.4149 25199.5n 0.4149 25200.0n 0.5857 25799.5n 0.5857 25800.0n 0.6471 26399.5n 0.6471 26400.0n 0.5962 26999.5n 0.5962 27000.0n 0.6094 27599.5n 0.6094 27600.0n 0.5923 28199.5n 0.5923 28200.0n 0.4211 28799.5n 0.4211 28800.0n 0.5618 29399.5n 0.5618 29400.0n 0.6272 29999.5n 0.6272 30000.0n 0.6254 30599.5n 0.6254 30600.0n 0.5963 31199.5n 0.5963 31200.0n 0.5460 31799.5n 0.5460 31800.0n 0.6479 32399.5n 0.6479 32400.0n 0.6457 32999.5n 0.6457 33000.0n 0.4937 33599.5n 0.4937 33600.0n 0.5272 34199.5n 0.5272 34200.0n 0.4215 34799.5n 0.4215 34800.0n 0.6257 35399.5n 0.6257 35400.0n 0.5263 35999.5n 0.5263)
Vyp_who_6_1 yp_who_6_1 0 PWL(0.0n 0.5071 599.5n 0.5071 600.0n 0.5053 1199.5n 0.5053 1200.0n 0.5052 1799.5n 0.5052 1800.0n 0.5027 2399.5n 0.5027 2400.0n 0.5034 2999.5n 0.5034 3000.0n 0.5055 3599.5n 0.5055 3600.0n 0.5056 4199.5n 0.5056 4200.0n 0.5071 4799.5n 0.5071 4800.0n 0.5056 5399.5n 0.5056 5400.0n 0.5056 5999.5n 0.5056 6000.0n 0.5048 6599.5n 0.5048 6600.0n 0.5060 7199.5n 0.5060 7200.0n 0.5048 7799.5n 0.5048 7800.0n 0.5046 8399.5n 0.5046 8400.0n 0.5066 8999.5n 0.5066 9000.0n 0.5056 9599.5n 0.5056 9600.0n 0.5051 10199.5n 0.5051 10200.0n 0.5046 10799.5n 0.5046 10800.0n 0.5056 11399.5n 0.5056 11400.0n 0.5058 11999.5n 0.5058 12000.0n 0.5068 12599.5n 0.5068 12600.0n 0.5050 13199.5n 0.5050 13200.0n 0.5071 13799.5n 0.5071 13800.0n 0.5059 14399.5n 0.5059 14400.0n 0.5058 14999.5n 0.5058 15000.0n 0.5043 15599.5n 0.5043 15600.0n 0.5067 16199.5n 0.5067 16200.0n 0.5068 16799.5n 0.5068 16800.0n 0.5066 17399.5n 0.5066 17400.0n 0.5069 17999.5n 0.5069 18000.0n 0.5061 18599.5n 0.5061 18600.0n 0.5034 19199.5n 0.5034 19200.0n 0.5010 19799.5n 0.5010 19800.0n 0.4989 20399.5n 0.4989 20400.0n 0.5022 20999.5n 0.5022 21000.0n 0.5086 21599.5n 0.5086 21600.0n 0.5007 22199.5n 0.5007 22200.0n 0.5023 22799.5n 0.5023 22800.0n 0.5021 23399.5n 0.5021 23400.0n 0.5077 23999.5n 0.5077 24000.0n 0.4979 24599.5n 0.4979 24600.0n 0.5035 25199.5n 0.5035 25200.0n 0.5041 25799.5n 0.5041 25800.0n 0.5075 26399.5n 0.5075 26400.0n 0.5041 26999.5n 0.5041 27000.0n 0.5056 27599.5n 0.5056 27600.0n 0.5039 28199.5n 0.5039 28200.0n 0.5059 28799.5n 0.5059 28800.0n 0.5023 29399.5n 0.5023 29400.0n 0.5086 29999.5n 0.5086 30000.0n 0.5084 30599.5n 0.5084 30600.0n 0.5085 31199.5n 0.5085 31200.0n 0.5088 31799.5n 0.5088 31800.0n 0.5078 32399.5n 0.5078 32400.0n 0.5074 32999.5n 0.5074 33000.0n 0.4996 33599.5n 0.4996 33600.0n 0.5010 34199.5n 0.5010 34200.0n 0.5044 34799.5n 0.5044 34800.0n 0.5084 35399.5n 0.5084 35400.0n 0.5012 35999.5n 0.5012)
Vyn_who_6_1 yn_who_6_1 0 PWL(0.0n 0.4929 599.5n 0.4929 600.0n 0.4947 1199.5n 0.4947 1200.0n 0.4948 1799.5n 0.4948 1800.0n 0.4973 2399.5n 0.4973 2400.0n 0.4966 2999.5n 0.4966 3000.0n 0.4945 3599.5n 0.4945 3600.0n 0.4944 4199.5n 0.4944 4200.0n 0.4929 4799.5n 0.4929 4800.0n 0.4944 5399.5n 0.4944 5400.0n 0.4944 5999.5n 0.4944 6000.0n 0.4952 6599.5n 0.4952 6600.0n 0.4940 7199.5n 0.4940 7200.0n 0.4952 7799.5n 0.4952 7800.0n 0.4954 8399.5n 0.4954 8400.0n 0.4934 8999.5n 0.4934 9000.0n 0.4944 9599.5n 0.4944 9600.0n 0.4949 10199.5n 0.4949 10200.0n 0.4954 10799.5n 0.4954 10800.0n 0.4944 11399.5n 0.4944 11400.0n 0.4942 11999.5n 0.4942 12000.0n 0.4932 12599.5n 0.4932 12600.0n 0.4950 13199.5n 0.4950 13200.0n 0.4929 13799.5n 0.4929 13800.0n 0.4941 14399.5n 0.4941 14400.0n 0.4942 14999.5n 0.4942 15000.0n 0.4957 15599.5n 0.4957 15600.0n 0.4933 16199.5n 0.4933 16200.0n 0.4932 16799.5n 0.4932 16800.0n 0.4934 17399.5n 0.4934 17400.0n 0.4931 17999.5n 0.4931 18000.0n 0.4939 18599.5n 0.4939 18600.0n 0.4966 19199.5n 0.4966 19200.0n 0.4990 19799.5n 0.4990 19800.0n 0.5011 20399.5n 0.5011 20400.0n 0.4978 20999.5n 0.4978 21000.0n 0.4914 21599.5n 0.4914 21600.0n 0.4993 22199.5n 0.4993 22200.0n 0.4977 22799.5n 0.4977 22800.0n 0.4979 23399.5n 0.4979 23400.0n 0.4923 23999.5n 0.4923 24000.0n 0.5021 24599.5n 0.5021 24600.0n 0.4965 25199.5n 0.4965 25200.0n 0.4959 25799.5n 0.4959 25800.0n 0.4925 26399.5n 0.4925 26400.0n 0.4959 26999.5n 0.4959 27000.0n 0.4944 27599.5n 0.4944 27600.0n 0.4961 28199.5n 0.4961 28200.0n 0.4941 28799.5n 0.4941 28800.0n 0.4977 29399.5n 0.4977 29400.0n 0.4914 29999.5n 0.4914 30000.0n 0.4916 30599.5n 0.4916 30600.0n 0.4915 31199.5n 0.4915 31200.0n 0.4912 31799.5n 0.4912 31800.0n 0.4922 32399.5n 0.4922 32400.0n 0.4926 32999.5n 0.4926 33000.0n 0.5004 33599.5n 0.5004 33600.0n 0.4990 34199.5n 0.4990 34200.0n 0.4956 34799.5n 0.4956 34800.0n 0.4916 35399.5n 0.4916 35400.0n 0.4988 35999.5n 0.4988)
Cwp_who_6_1 wp_who_6_1 0 400p
Cwn_who_6_1 wn_who_6_1 0 400p
Xu_who_6_1 xp_who_6_1 xn_who_6_1 yp_who_6_1 yn_who_6_1 wp_who_6_1 wn_who_6_1 vdd gbn gprod
Vxp_bh_6 xp_bh_6 0 PWL(0.0n 0.7100 599.5n 0.7100 600.0n 0.7100 1199.5n 0.7100 1200.0n 0.7100 1799.5n 0.7100 1800.0n 0.7100 2399.5n 0.7100 2400.0n 0.7100 2999.5n 0.7100 3000.0n 0.7100 3599.5n 0.7100 3600.0n 0.7100 4199.5n 0.7100 4200.0n 0.7100 4799.5n 0.7100 4800.0n 0.7100 5399.5n 0.7100 5400.0n 0.7100 5999.5n 0.7100 6000.0n 0.7100 6599.5n 0.7100 6600.0n 0.7100 7199.5n 0.7100 7200.0n 0.7100 7799.5n 0.7100 7800.0n 0.7100 8399.5n 0.7100 8400.0n 0.7100 8999.5n 0.7100 9000.0n 0.7100 9599.5n 0.7100 9600.0n 0.7100 10199.5n 0.7100 10200.0n 0.7100 10799.5n 0.7100 10800.0n 0.7100 11399.5n 0.7100 11400.0n 0.7100 11999.5n 0.7100 12000.0n 0.7100 12599.5n 0.7100 12600.0n 0.7100 13199.5n 0.7100 13200.0n 0.7100 13799.5n 0.7100 13800.0n 0.7100 14399.5n 0.7100 14400.0n 0.7100 14999.5n 0.7100 15000.0n 0.7100 15599.5n 0.7100 15600.0n 0.7100 16199.5n 0.7100 16200.0n 0.7100 16799.5n 0.7100 16800.0n 0.7100 17399.5n 0.7100 17400.0n 0.7100 17999.5n 0.7100 18000.0n 0.7100 18599.5n 0.7100 18600.0n 0.7100 19199.5n 0.7100 19200.0n 0.7100 19799.5n 0.7100 19800.0n 0.7100 20399.5n 0.7100 20400.0n 0.7100 20999.5n 0.7100 21000.0n 0.7100 21599.5n 0.7100 21600.0n 0.7100 22199.5n 0.7100 22200.0n 0.7100 22799.5n 0.7100 22800.0n 0.7100 23399.5n 0.7100 23400.0n 0.7100 23999.5n 0.7100 24000.0n 0.7100 24599.5n 0.7100 24600.0n 0.7100 25199.5n 0.7100 25200.0n 0.7100 25799.5n 0.7100 25800.0n 0.7100 26399.5n 0.7100 26400.0n 0.7100 26999.5n 0.7100 27000.0n 0.7100 27599.5n 0.7100 27600.0n 0.7100 28199.5n 0.7100 28200.0n 0.7100 28799.5n 0.7100 28800.0n 0.7100 29399.5n 0.7100 29400.0n 0.7100 29999.5n 0.7100 30000.0n 0.7100 30599.5n 0.7100 30600.0n 0.7100 31199.5n 0.7100 31200.0n 0.7100 31799.5n 0.7100 31800.0n 0.7100 32399.5n 0.7100 32400.0n 0.7100 32999.5n 0.7100 33000.0n 0.7100 33599.5n 0.7100 33600.0n 0.7100 34199.5n 0.7100 34200.0n 0.7100 34799.5n 0.7100 34800.0n 0.7100 35399.5n 0.7100 35400.0n 0.7100 35999.5n 0.7100)
Vxn_bh_6 xn_bh_6 0 PWL(0.0n 0.2900 599.5n 0.2900 600.0n 0.2900 1199.5n 0.2900 1200.0n 0.2900 1799.5n 0.2900 1800.0n 0.2900 2399.5n 0.2900 2400.0n 0.2900 2999.5n 0.2900 3000.0n 0.2900 3599.5n 0.2900 3600.0n 0.2900 4199.5n 0.2900 4200.0n 0.2900 4799.5n 0.2900 4800.0n 0.2900 5399.5n 0.2900 5400.0n 0.2900 5999.5n 0.2900 6000.0n 0.2900 6599.5n 0.2900 6600.0n 0.2900 7199.5n 0.2900 7200.0n 0.2900 7799.5n 0.2900 7800.0n 0.2900 8399.5n 0.2900 8400.0n 0.2900 8999.5n 0.2900 9000.0n 0.2900 9599.5n 0.2900 9600.0n 0.2900 10199.5n 0.2900 10200.0n 0.2900 10799.5n 0.2900 10800.0n 0.2900 11399.5n 0.2900 11400.0n 0.2900 11999.5n 0.2900 12000.0n 0.2900 12599.5n 0.2900 12600.0n 0.2900 13199.5n 0.2900 13200.0n 0.2900 13799.5n 0.2900 13800.0n 0.2900 14399.5n 0.2900 14400.0n 0.2900 14999.5n 0.2900 15000.0n 0.2900 15599.5n 0.2900 15600.0n 0.2900 16199.5n 0.2900 16200.0n 0.2900 16799.5n 0.2900 16800.0n 0.2900 17399.5n 0.2900 17400.0n 0.2900 17999.5n 0.2900 18000.0n 0.2900 18599.5n 0.2900 18600.0n 0.2900 19199.5n 0.2900 19200.0n 0.2900 19799.5n 0.2900 19800.0n 0.2900 20399.5n 0.2900 20400.0n 0.2900 20999.5n 0.2900 21000.0n 0.2900 21599.5n 0.2900 21600.0n 0.2900 22199.5n 0.2900 22200.0n 0.2900 22799.5n 0.2900 22800.0n 0.2900 23399.5n 0.2900 23400.0n 0.2900 23999.5n 0.2900 24000.0n 0.2900 24599.5n 0.2900 24600.0n 0.2900 25199.5n 0.2900 25200.0n 0.2900 25799.5n 0.2900 25800.0n 0.2900 26399.5n 0.2900 26400.0n 0.2900 26999.5n 0.2900 27000.0n 0.2900 27599.5n 0.2900 27600.0n 0.2900 28199.5n 0.2900 28200.0n 0.2900 28799.5n 0.2900 28800.0n 0.2900 29399.5n 0.2900 29400.0n 0.2900 29999.5n 0.2900 30000.0n 0.2900 30599.5n 0.2900 30600.0n 0.2900 31199.5n 0.2900 31200.0n 0.2900 31799.5n 0.2900 31800.0n 0.2900 32399.5n 0.2900 32400.0n 0.2900 32999.5n 0.2900 33000.0n 0.2900 33599.5n 0.2900 33600.0n 0.2900 34199.5n 0.2900 34200.0n 0.2900 34799.5n 0.2900 34800.0n 0.2900 35399.5n 0.2900 35400.0n 0.2900 35999.5n 0.2900)
Vyp_bh_6 yp_bh_6 0 PWL(0.0n 0.4757 599.5n 0.4757 600.0n 0.5257 1199.5n 0.5257 1200.0n 0.4520 1799.5n 0.4520 1800.0n 0.4821 2399.5n 0.4821 2400.0n 0.4940 2999.5n 0.4940 3000.0n 0.4867 3599.5n 0.4867 3600.0n 0.4533 4199.5n 0.4533 4200.0n 0.4711 4799.5n 0.4711 4800.0n 0.4730 5399.5n 0.4730 5400.0n 0.4740 5999.5n 0.4740 6000.0n 0.4541 6599.5n 0.4541 6600.0n 0.4676 7199.5n 0.4676 7200.0n 0.5162 7799.5n 0.5162 7800.0n 0.5181 8399.5n 0.5181 8400.0n 0.4524 8999.5n 0.4524 9000.0n 0.4738 9599.5n 0.4738 9600.0n 0.4820 10199.5n 0.4820 10200.0n 0.5014 10799.5n 0.5014 10800.0n 0.4419 11399.5n 0.4419 11400.0n 0.4723 11999.5n 0.4723 12000.0n 0.4455 12599.5n 0.4455 12600.0n 0.4838 13199.5n 0.4838 13200.0n 0.4820 13799.5n 0.4820 13800.0n 0.5012 14399.5n 0.5012 14400.0n 0.4752 14999.5n 0.4752 15000.0n 0.4919 15599.5n 0.4919 15600.0n 0.4666 16199.5n 0.4666 16200.0n 0.4956 16799.5n 0.4956 16800.0n 0.4477 17399.5n 0.4477 17400.0n 0.4851 17999.5n 0.4851 18000.0n 0.3936 18599.5n 0.3936 18600.0n 0.5717 19199.5n 0.5717 19200.0n 0.4820 19799.5n 0.4820 19800.0n 0.5639 20399.5n 0.5639 20400.0n 0.4443 20999.5n 0.4443 21000.0n 0.3704 21599.5n 0.3704 21600.0n 0.5689 22199.5n 0.5689 22200.0n 0.5843 22799.5n 0.5843 22800.0n 0.4404 23399.5n 0.4404 23400.0n 0.5544 23999.5n 0.5544 24000.0n 0.5456 24599.5n 0.5456 24600.0n 0.5851 25199.5n 0.5851 25200.0n 0.4143 25799.5n 0.4143 25800.0n 0.3529 26399.5n 0.3529 26400.0n 0.4038 26999.5n 0.4038 27000.0n 0.3906 27599.5n 0.3906 27600.0n 0.4077 28199.5n 0.4077 28200.0n 0.5789 28799.5n 0.5789 28800.0n 0.4382 29399.5n 0.4382 29400.0n 0.3728 29999.5n 0.3728 30000.0n 0.3746 30599.5n 0.3746 30600.0n 0.4037 31199.5n 0.4037 31200.0n 0.4540 31799.5n 0.4540 31800.0n 0.3521 32399.5n 0.3521 32400.0n 0.3543 32999.5n 0.3543 33000.0n 0.5063 33599.5n 0.5063 33600.0n 0.4728 34199.5n 0.4728 34200.0n 0.5785 34799.5n 0.5785 34800.0n 0.3743 35399.5n 0.3743 35400.0n 0.4737 35999.5n 0.4737)
Vyn_bh_6 yn_bh_6 0 PWL(0.0n 0.5243 599.5n 0.5243 600.0n 0.4743 1199.5n 0.4743 1200.0n 0.5480 1799.5n 0.5480 1800.0n 0.5179 2399.5n 0.5179 2400.0n 0.5060 2999.5n 0.5060 3000.0n 0.5133 3599.5n 0.5133 3600.0n 0.5467 4199.5n 0.5467 4200.0n 0.5289 4799.5n 0.5289 4800.0n 0.5270 5399.5n 0.5270 5400.0n 0.5260 5999.5n 0.5260 6000.0n 0.5459 6599.5n 0.5459 6600.0n 0.5324 7199.5n 0.5324 7200.0n 0.4838 7799.5n 0.4838 7800.0n 0.4819 8399.5n 0.4819 8400.0n 0.5476 8999.5n 0.5476 9000.0n 0.5262 9599.5n 0.5262 9600.0n 0.5180 10199.5n 0.5180 10200.0n 0.4986 10799.5n 0.4986 10800.0n 0.5581 11399.5n 0.5581 11400.0n 0.5277 11999.5n 0.5277 12000.0n 0.5545 12599.5n 0.5545 12600.0n 0.5162 13199.5n 0.5162 13200.0n 0.5180 13799.5n 0.5180 13800.0n 0.4988 14399.5n 0.4988 14400.0n 0.5248 14999.5n 0.5248 15000.0n 0.5081 15599.5n 0.5081 15600.0n 0.5334 16199.5n 0.5334 16200.0n 0.5044 16799.5n 0.5044 16800.0n 0.5523 17399.5n 0.5523 17400.0n 0.5149 17999.5n 0.5149 18000.0n 0.6064 18599.5n 0.6064 18600.0n 0.4283 19199.5n 0.4283 19200.0n 0.5180 19799.5n 0.5180 19800.0n 0.4361 20399.5n 0.4361 20400.0n 0.5557 20999.5n 0.5557 21000.0n 0.6296 21599.5n 0.6296 21600.0n 0.4311 22199.5n 0.4311 22200.0n 0.4157 22799.5n 0.4157 22800.0n 0.5596 23399.5n 0.5596 23400.0n 0.4456 23999.5n 0.4456 24000.0n 0.4544 24599.5n 0.4544 24600.0n 0.4149 25199.5n 0.4149 25200.0n 0.5857 25799.5n 0.5857 25800.0n 0.6471 26399.5n 0.6471 26400.0n 0.5962 26999.5n 0.5962 27000.0n 0.6094 27599.5n 0.6094 27600.0n 0.5923 28199.5n 0.5923 28200.0n 0.4211 28799.5n 0.4211 28800.0n 0.5618 29399.5n 0.5618 29400.0n 0.6272 29999.5n 0.6272 30000.0n 0.6254 30599.5n 0.6254 30600.0n 0.5963 31199.5n 0.5963 31200.0n 0.5460 31799.5n 0.5460 31800.0n 0.6479 32399.5n 0.6479 32400.0n 0.6457 32999.5n 0.6457 33000.0n 0.4937 33599.5n 0.4937 33600.0n 0.5272 34199.5n 0.5272 34200.0n 0.4215 34799.5n 0.4215 34800.0n 0.6257 35399.5n 0.6257 35400.0n 0.5263 35999.5n 0.5263)
Cwp_bh_6 wp_bh_6 0 400p
Cwn_bh_6 wn_bh_6 0 400p
Xu_bh_6 xp_bh_6 xn_bh_6 yp_bh_6 yn_bh_6 wp_bh_6 wn_bh_6 vdd gbn gprod
Vxp_wih_0_7 xp_wih_0_7 0 PWL(0.0n 0.4942 599.5n 0.4942 600.0n 0.5558 1199.5n 0.5558 1200.0n 0.4708 1799.5n 0.4708 1800.0n 0.5235 2399.5n 0.5235 2400.0n 0.5350 2999.5n 0.5350 3000.0n 0.5172 3599.5n 0.5172 3600.0n 0.4702 4199.5n 0.4702 4200.0n 0.4867 4799.5n 0.4867 4800.0n 0.4970 5399.5n 0.4970 5400.0n 0.4986 5999.5n 0.4986 6000.0n 0.4751 6599.5n 0.4751 6600.0n 0.4870 7199.5n 0.4870 7200.0n 0.5502 7799.5n 0.5502 7800.0n 0.5521 8399.5n 0.5521 8400.0n 0.4638 8999.5n 0.4638 9000.0n 0.4982 9599.5n 0.4982 9600.0n 0.5131 10199.5n 0.5131 10200.0n 0.5386 10799.5n 0.5386 10800.0n 0.4592 11399.5n 0.4592 11400.0n 0.4950 11999.5n 0.4950 12000.0n 0.4559 12599.5n 0.4559 12600.0n 0.5162 13199.5n 0.5162 13200.0n 0.5038 13799.5n 0.5038 13800.0n 0.5333 14399.5n 0.5333 14400.0n 0.4991 14999.5n 0.4991 15000.0n 0.5298 15599.5n 0.5298 15600.0n 0.4823 16199.5n 0.4823 16200.0n 0.5239 16799.5n 0.5239 16800.0n 0.4592 17399.5n 0.4592 17400.0n 0.5094 17999.5n 0.5094 18000.0n 0.4337 18599.5n 0.4337 18600.0n 0.5977 19199.5n 0.5977 19200.0n 0.5364 19799.5n 0.5364 19800.0n 0.6122 20399.5n 0.6122 20400.0n 0.4856 20999.5n 0.4856 21000.0n 0.3861 21599.5n 0.3861 21600.0n 0.6094 22199.5n 0.6094 22200.0n 0.6364 22799.5n 0.6364 22800.0n 0.4807 23399.5n 0.4807 23400.0n 0.5614 23999.5n 0.5614 24000.0n 0.5913 24599.5n 0.5913 24600.0n 0.6295 25199.5n 0.6295 25200.0n 0.4496 25799.5n 0.4496 25800.0n 0.3792 26399.5n 0.3792 26400.0n 0.4434 26999.5n 0.4434 27000.0n 0.4340 27599.5n 0.4340 27600.0n 0.4461 28199.5n 0.4461 28200.0n 0.5791 28799.5n 0.5791 28800.0n 0.4777 29399.5n 0.4777 29400.0n 0.3878 29999.5n 0.3878 30000.0n 0.3832 30599.5n 0.3832 30600.0n 0.4022 31199.5n 0.4022 31200.0n 0.4482 31799.5n 0.4482 31800.0n 0.3662 32399.5n 0.3662 32400.0n 0.3857 32999.5n 0.3857 33000.0n 0.5584 33599.5n 0.5584 33600.0n 0.5284 34199.5n 0.5284 34200.0n 0.6034 34799.5n 0.6034 34800.0n 0.3469 35399.5n 0.3469 35400.0n 0.5290 35999.5n 0.5290)
Vxn_wih_0_7 xn_wih_0_7 0 PWL(0.0n 0.5058 599.5n 0.5058 600.0n 0.4442 1199.5n 0.4442 1200.0n 0.5292 1799.5n 0.5292 1800.0n 0.4765 2399.5n 0.4765 2400.0n 0.4650 2999.5n 0.4650 3000.0n 0.4828 3599.5n 0.4828 3600.0n 0.5298 4199.5n 0.5298 4200.0n 0.5133 4799.5n 0.5133 4800.0n 0.5030 5399.5n 0.5030 5400.0n 0.5014 5999.5n 0.5014 6000.0n 0.5249 6599.5n 0.5249 6600.0n 0.5130 7199.5n 0.5130 7200.0n 0.4498 7799.5n 0.4498 7800.0n 0.4479 8399.5n 0.4479 8400.0n 0.5362 8999.5n 0.5362 9000.0n 0.5018 9599.5n 0.5018 9600.0n 0.4869 10199.5n 0.4869 10200.0n 0.4614 10799.5n 0.4614 10800.0n 0.5408 11399.5n 0.5408 11400.0n 0.5050 11999.5n 0.5050 12000.0n 0.5441 12599.5n 0.5441 12600.0n 0.4838 13199.5n 0.4838 13200.0n 0.4962 13799.5n 0.4962 13800.0n 0.4667 14399.5n 0.4667 14400.0n 0.5009 14999.5n 0.5009 15000.0n 0.4702 15599.5n 0.4702 15600.0n 0.5177 16199.5n 0.5177 16200.0n 0.4761 16799.5n 0.4761 16800.0n 0.5408 17399.5n 0.5408 17400.0n 0.4906 17999.5n 0.4906 18000.0n 0.5663 18599.5n 0.5663 18600.0n 0.4023 19199.5n 0.4023 19200.0n 0.4636 19799.5n 0.4636 19800.0n 0.3878 20399.5n 0.3878 20400.0n 0.5144 20999.5n 0.5144 21000.0n 0.6139 21599.5n 0.6139 21600.0n 0.3906 22199.5n 0.3906 22200.0n 0.3636 22799.5n 0.3636 22800.0n 0.5193 23399.5n 0.5193 23400.0n 0.4386 23999.5n 0.4386 24000.0n 0.4087 24599.5n 0.4087 24600.0n 0.3705 25199.5n 0.3705 25200.0n 0.5504 25799.5n 0.5504 25800.0n 0.6208 26399.5n 0.6208 26400.0n 0.5566 26999.5n 0.5566 27000.0n 0.5660 27599.5n 0.5660 27600.0n 0.5539 28199.5n 0.5539 28200.0n 0.4209 28799.5n 0.4209 28800.0n 0.5223 29399.5n 0.5223 29400.0n 0.6122 29999.5n 0.6122 30000.0n 0.6168 30599.5n 0.6168 30600.0n 0.5978 31199.5n 0.5978 31200.0n 0.5518 31799.5n 0.5518 31800.0n 0.6338 32399.5n 0.6338 32400.0n 0.6143 32999.5n 0.6143 33000.0n 0.4416 33599.5n 0.4416 33600.0n 0.4716 34199.5n 0.4716 34200.0n 0.3966 34799.5n 0.3966 34800.0n 0.6531 35399.5n 0.6531 35400.0n 0.4710 35999.5n 0.4710)
Vyp_wih_0_7 yp_wih_0_7 0 PWL(0.0n 0.3550 599.5n 0.3550 600.0n 0.3443 1199.5n 0.3443 1200.0n 0.3468 1799.5n 0.3468 1800.0n 0.3378 2399.5n 0.3378 2400.0n 0.3391 2999.5n 0.3391 3000.0n 0.3470 3599.5n 0.3470 3600.0n 0.3490 4199.5n 0.3490 4200.0n 0.3567 4799.5n 0.3567 4800.0n 0.3481 5399.5n 0.3481 5400.0n 0.3478 5999.5n 0.3478 6000.0n 0.3451 6599.5n 0.3451 6600.0n 0.3503 7199.5n 0.3503 7200.0n 0.3432 7799.5n 0.3432 7800.0n 0.3424 8399.5n 0.3424 8400.0n 0.3582 8999.5n 0.3582 9000.0n 0.3480 9599.5n 0.3480 9600.0n 0.3453 10199.5n 0.3453 10200.0n 0.3426 10799.5n 0.3426 10800.0n 0.3484 11399.5n 0.3484 11400.0n 0.3489 11999.5n 0.3489 12000.0n 0.3635 12599.5n 0.3635 12600.0n 0.3447 13199.5n 0.3447 13200.0n 0.3542 13799.5n 0.3542 13800.0n 0.3478 14399.5n 0.3478 14400.0n 0.3489 14999.5n 0.3489 15000.0n 0.3417 15599.5n 0.3417 15600.0n 0.3542 16199.5n 0.3542 16200.0n 0.3516 16799.5n 0.3516 16800.0n 0.3586 17399.5n 0.3586 17400.0n 0.3525 17999.5n 0.3525 18000.0n 0.3378 18599.5n 0.3378 18600.0n 0.3381 19199.5n 0.3381 19200.0n 0.3306 19799.5n 0.3306 19800.0n 0.3278 20399.5n 0.3278 20400.0n 0.3320 20999.5n 0.3320 21000.0n 0.3619 21599.5n 0.3619 21600.0n 0.3318 22199.5n 0.3318 22200.0n 0.3369 22799.5n 0.3369 22800.0n 0.3308 23399.5n 0.3308 23400.0n 0.3882 23999.5n 0.3882 24000.0n 0.3245 24599.5n 0.3245 24600.0n 0.3387 25199.5n 0.3387 25200.0n 0.3343 25799.5n 0.3343 25800.0n 0.3374 26399.5n 0.3374 26400.0n 0.3324 26999.5n 0.3324 27000.0n 0.3356 27599.5n 0.3356 27600.0n 0.3322 28199.5n 0.3322 28200.0n 0.3694 28799.5n 0.3694 28800.0n 0.3313 29399.5n 0.3313 29400.0n 0.3677 29999.5n 0.3677 30000.0n 0.3788 30599.5n 0.3788 30600.0n 0.4412 31199.5n 0.4412 31200.0n 0.4152 31799.5n 0.4152 31800.0n 0.3391 32399.5n 0.3391 32400.0n 0.3370 32999.5n 0.3370 33000.0n 0.3278 33599.5n 0.3278 33600.0n 0.3290 34199.5n 0.3290 34200.0n 0.3412 34799.5n 0.3412 34800.0n 0.3994 35399.5n 0.3994 35400.0n 0.3301 35999.5n 0.3301)
Vyn_wih_0_7 yn_wih_0_7 0 PWL(0.0n 0.6450 599.5n 0.6450 600.0n 0.6557 1199.5n 0.6557 1200.0n 0.6532 1799.5n 0.6532 1800.0n 0.6622 2399.5n 0.6622 2400.0n 0.6609 2999.5n 0.6609 3000.0n 0.6530 3599.5n 0.6530 3600.0n 0.6510 4199.5n 0.6510 4200.0n 0.6433 4799.5n 0.6433 4800.0n 0.6519 5399.5n 0.6519 5400.0n 0.6522 5999.5n 0.6522 6000.0n 0.6549 6599.5n 0.6549 6600.0n 0.6497 7199.5n 0.6497 7200.0n 0.6568 7799.5n 0.6568 7800.0n 0.6576 8399.5n 0.6576 8400.0n 0.6418 8999.5n 0.6418 9000.0n 0.6520 9599.5n 0.6520 9600.0n 0.6547 10199.5n 0.6547 10200.0n 0.6574 10799.5n 0.6574 10800.0n 0.6516 11399.5n 0.6516 11400.0n 0.6511 11999.5n 0.6511 12000.0n 0.6365 12599.5n 0.6365 12600.0n 0.6553 13199.5n 0.6553 13200.0n 0.6458 13799.5n 0.6458 13800.0n 0.6522 14399.5n 0.6522 14400.0n 0.6511 14999.5n 0.6511 15000.0n 0.6583 15599.5n 0.6583 15600.0n 0.6458 16199.5n 0.6458 16200.0n 0.6484 16799.5n 0.6484 16800.0n 0.6414 17399.5n 0.6414 17400.0n 0.6475 17999.5n 0.6475 18000.0n 0.6622 18599.5n 0.6622 18600.0n 0.6619 19199.5n 0.6619 19200.0n 0.6694 19799.5n 0.6694 19800.0n 0.6722 20399.5n 0.6722 20400.0n 0.6680 20999.5n 0.6680 21000.0n 0.6381 21599.5n 0.6381 21600.0n 0.6682 22199.5n 0.6682 22200.0n 0.6631 22799.5n 0.6631 22800.0n 0.6692 23399.5n 0.6692 23400.0n 0.6118 23999.5n 0.6118 24000.0n 0.6755 24599.5n 0.6755 24600.0n 0.6613 25199.5n 0.6613 25200.0n 0.6657 25799.5n 0.6657 25800.0n 0.6626 26399.5n 0.6626 26400.0n 0.6676 26999.5n 0.6676 27000.0n 0.6644 27599.5n 0.6644 27600.0n 0.6678 28199.5n 0.6678 28200.0n 0.6306 28799.5n 0.6306 28800.0n 0.6687 29399.5n 0.6687 29400.0n 0.6323 29999.5n 0.6323 30000.0n 0.6212 30599.5n 0.6212 30600.0n 0.5588 31199.5n 0.5588 31200.0n 0.5848 31799.5n 0.5848 31800.0n 0.6609 32399.5n 0.6609 32400.0n 0.6630 32999.5n 0.6630 33000.0n 0.6722 33599.5n 0.6722 33600.0n 0.6710 34199.5n 0.6710 34200.0n 0.6588 34799.5n 0.6588 34800.0n 0.6006 35399.5n 0.6006 35400.0n 0.6699 35999.5n 0.6699)
Cwp_wih_0_7 wp_wih_0_7 0 400p
Cwn_wih_0_7 wn_wih_0_7 0 400p
Xu_wih_0_7 xp_wih_0_7 xn_wih_0_7 yp_wih_0_7 yn_wih_0_7 wp_wih_0_7 wn_wih_0_7 vdd gbn gprod
Vxp_wih_1_7 xp_wih_1_7 0 PWL(0.0n 0.5370 599.5n 0.5370 600.0n 0.5167 1199.5n 0.5167 1200.0n 0.4793 1799.5n 0.4793 1800.0n 0.4441 2399.5n 0.4441 2400.0n 0.4555 2999.5n 0.4555 3000.0n 0.5055 3599.5n 0.5055 3600.0n 0.4939 4199.5n 0.4939 4200.0n 0.5385 4799.5n 0.5385 4800.0n 0.5024 5399.5n 0.5024 5400.0n 0.5015 5999.5n 0.5015 6000.0n 0.4700 6599.5n 0.4700 6600.0n 0.5120 7199.5n 0.5120 7200.0n 0.5006 7799.5n 0.5006 7800.0n 0.4950 8399.5n 0.4950 8400.0n 0.5309 8999.5n 0.5309 9000.0n 0.5023 9599.5n 0.5023 9600.0n 0.4893 10199.5n 0.4893 10200.0n 0.4837 10799.5n 0.4837 10800.0n 0.4823 11399.5n 0.4823 11400.0n 0.5074 11999.5n 0.5074 12000.0n 0.5364 12599.5n 0.5364 12600.0n 0.4868 13199.5n 0.4868 13200.0n 0.5380 13799.5n 0.5380 13800.0n 0.5220 14399.5n 0.5220 14400.0n 0.5095 14999.5n 0.5095 15000.0n 0.4705 15599.5n 0.4705 15600.0n 0.5289 16199.5n 0.5289 16200.0n 0.5368 16799.5n 0.5368 16800.0n 0.5287 17399.5n 0.5287 17400.0n 0.5342 17999.5n 0.5342 18000.0n 0.4253 18599.5n 0.4253 18600.0n 0.5119 19199.5n 0.5119 19200.0n 0.4104 19799.5n 0.4104 19800.0n 0.4314 20399.5n 0.4314 20400.0n 0.4005 20999.5n 0.4005 21000.0n 0.4696 21599.5n 0.4696 21600.0n 0.4531 22199.5n 0.4531 22200.0n 0.5039 22799.5n 0.5039 22800.0n 0.3608 23399.5n 0.3608 23400.0n 0.6273 23999.5n 0.6273 24000.0n 0.3928 24599.5n 0.3928 24600.0n 0.5253 25199.5n 0.5253 25200.0n 0.4107 25799.5n 0.4107 25800.0n 0.3947 26399.5n 0.3947 26400.0n 0.3716 26999.5n 0.3716 27000.0n 0.4111 27599.5n 0.4111 27600.0n 0.3715 28199.5n 0.3715 28200.0n 0.5939 28799.5n 0.5939 28800.0n 0.3849 29399.5n 0.3849 29400.0n 0.4835 29999.5n 0.4835 30000.0n 0.5119 30599.5n 0.5119 30600.0n 0.6226 31199.5n 0.6226 31200.0n 0.6064 31799.5n 0.6064 31800.0n 0.4115 32399.5n 0.4115 32400.0n 0.3900 32999.5n 0.3900 33000.0n 0.3958 33599.5n 0.3958 33600.0n 0.3747 34199.5n 0.3747 34200.0n 0.5423 34799.5n 0.5423 34800.0n 0.5509 35399.5n 0.5509 35400.0n 0.3990 35999.5n 0.3990)
Vxn_wih_1_7 xn_wih_1_7 0 PWL(0.0n 0.4630 599.5n 0.4630 600.0n 0.4833 1199.5n 0.4833 1200.0n 0.5207 1799.5n 0.5207 1800.0n 0.5559 2399.5n 0.5559 2400.0n 0.5445 2999.5n 0.5445 3000.0n 0.4945 3599.5n 0.4945 3600.0n 0.5061 4199.5n 0.5061 4200.0n 0.4615 4799.5n 0.4615 4800.0n 0.4976 5399.5n 0.4976 5400.0n 0.4985 5999.5n 0.4985 6000.0n 0.5300 6599.5n 0.5300 6600.0n 0.4880 7199.5n 0.4880 7200.0n 0.4994 7799.5n 0.4994 7800.0n 0.5050 8399.5n 0.5050 8400.0n 0.4691 8999.5n 0.4691 9000.0n 0.4977 9599.5n 0.4977 9600.0n 0.5107 10199.5n 0.5107 10200.0n 0.5163 10799.5n 0.5163 10800.0n 0.5177 11399.5n 0.5177 11400.0n 0.4926 11999.5n 0.4926 12000.0n 0.4636 12599.5n 0.4636 12600.0n 0.5132 13199.5n 0.5132 13200.0n 0.4620 13799.5n 0.4620 13800.0n 0.4780 14399.5n 0.4780 14400.0n 0.4905 14999.5n 0.4905 15000.0n 0.5295 15599.5n 0.5295 15600.0n 0.4711 16199.5n 0.4711 16200.0n 0.4632 16799.5n 0.4632 16800.0n 0.4713 17399.5n 0.4713 17400.0n 0.4658 17999.5n 0.4658 18000.0n 0.5747 18599.5n 0.5747 18600.0n 0.4881 19199.5n 0.4881 19200.0n 0.5896 19799.5n 0.5896 19800.0n 0.5686 20399.5n 0.5686 20400.0n 0.5995 20999.5n 0.5995 21000.0n 0.5304 21599.5n 0.5304 21600.0n 0.5469 22199.5n 0.5469 22200.0n 0.4961 22799.5n 0.4961 22800.0n 0.6392 23399.5n 0.6392 23400.0n 0.3727 23999.5n 0.3727 24000.0n 0.6072 24599.5n 0.6072 24600.0n 0.4747 25199.5n 0.4747 25200.0n 0.5893 25799.5n 0.5893 25800.0n 0.6053 26399.5n 0.6053 26400.0n 0.6284 26999.5n 0.6284 27000.0n 0.5889 27599.5n 0.5889 27600.0n 0.6285 28199.5n 0.6285 28200.0n 0.4061 28799.5n 0.4061 28800.0n 0.6151 29399.5n 0.6151 29400.0n 0.5165 29999.5n 0.5165 30000.0n 0.4881 30599.5n 0.4881 30600.0n 0.3774 31199.5n 0.3774 31200.0n 0.3936 31799.5n 0.3936 31800.0n 0.5885 32399.5n 0.5885 32400.0n 0.6100 32999.5n 0.6100 33000.0n 0.6042 33599.5n 0.6042 33600.0n 0.6253 34199.5n 0.6253 34200.0n 0.4577 34799.5n 0.4577 34800.0n 0.4491 35399.5n 0.4491 35400.0n 0.6010 35999.5n 0.6010)
Vyp_wih_1_7 yp_wih_1_7 0 PWL(0.0n 0.3550 599.5n 0.3550 600.0n 0.3443 1199.5n 0.3443 1200.0n 0.3468 1799.5n 0.3468 1800.0n 0.3378 2399.5n 0.3378 2400.0n 0.3391 2999.5n 0.3391 3000.0n 0.3470 3599.5n 0.3470 3600.0n 0.3490 4199.5n 0.3490 4200.0n 0.3567 4799.5n 0.3567 4800.0n 0.3481 5399.5n 0.3481 5400.0n 0.3478 5999.5n 0.3478 6000.0n 0.3451 6599.5n 0.3451 6600.0n 0.3503 7199.5n 0.3503 7200.0n 0.3432 7799.5n 0.3432 7800.0n 0.3424 8399.5n 0.3424 8400.0n 0.3582 8999.5n 0.3582 9000.0n 0.3480 9599.5n 0.3480 9600.0n 0.3453 10199.5n 0.3453 10200.0n 0.3426 10799.5n 0.3426 10800.0n 0.3484 11399.5n 0.3484 11400.0n 0.3489 11999.5n 0.3489 12000.0n 0.3635 12599.5n 0.3635 12600.0n 0.3447 13199.5n 0.3447 13200.0n 0.3542 13799.5n 0.3542 13800.0n 0.3478 14399.5n 0.3478 14400.0n 0.3489 14999.5n 0.3489 15000.0n 0.3417 15599.5n 0.3417 15600.0n 0.3542 16199.5n 0.3542 16200.0n 0.3516 16799.5n 0.3516 16800.0n 0.3586 17399.5n 0.3586 17400.0n 0.3525 17999.5n 0.3525 18000.0n 0.3378 18599.5n 0.3378 18600.0n 0.3381 19199.5n 0.3381 19200.0n 0.3306 19799.5n 0.3306 19800.0n 0.3278 20399.5n 0.3278 20400.0n 0.3320 20999.5n 0.3320 21000.0n 0.3619 21599.5n 0.3619 21600.0n 0.3318 22199.5n 0.3318 22200.0n 0.3369 22799.5n 0.3369 22800.0n 0.3308 23399.5n 0.3308 23400.0n 0.3882 23999.5n 0.3882 24000.0n 0.3245 24599.5n 0.3245 24600.0n 0.3387 25199.5n 0.3387 25200.0n 0.3343 25799.5n 0.3343 25800.0n 0.3374 26399.5n 0.3374 26400.0n 0.3324 26999.5n 0.3324 27000.0n 0.3356 27599.5n 0.3356 27600.0n 0.3322 28199.5n 0.3322 28200.0n 0.3694 28799.5n 0.3694 28800.0n 0.3313 29399.5n 0.3313 29400.0n 0.3677 29999.5n 0.3677 30000.0n 0.3788 30599.5n 0.3788 30600.0n 0.4412 31199.5n 0.4412 31200.0n 0.4152 31799.5n 0.4152 31800.0n 0.3391 32399.5n 0.3391 32400.0n 0.3370 32999.5n 0.3370 33000.0n 0.3278 33599.5n 0.3278 33600.0n 0.3290 34199.5n 0.3290 34200.0n 0.3412 34799.5n 0.3412 34800.0n 0.3994 35399.5n 0.3994 35400.0n 0.3301 35999.5n 0.3301)
Vyn_wih_1_7 yn_wih_1_7 0 PWL(0.0n 0.6450 599.5n 0.6450 600.0n 0.6557 1199.5n 0.6557 1200.0n 0.6532 1799.5n 0.6532 1800.0n 0.6622 2399.5n 0.6622 2400.0n 0.6609 2999.5n 0.6609 3000.0n 0.6530 3599.5n 0.6530 3600.0n 0.6510 4199.5n 0.6510 4200.0n 0.6433 4799.5n 0.6433 4800.0n 0.6519 5399.5n 0.6519 5400.0n 0.6522 5999.5n 0.6522 6000.0n 0.6549 6599.5n 0.6549 6600.0n 0.6497 7199.5n 0.6497 7200.0n 0.6568 7799.5n 0.6568 7800.0n 0.6576 8399.5n 0.6576 8400.0n 0.6418 8999.5n 0.6418 9000.0n 0.6520 9599.5n 0.6520 9600.0n 0.6547 10199.5n 0.6547 10200.0n 0.6574 10799.5n 0.6574 10800.0n 0.6516 11399.5n 0.6516 11400.0n 0.6511 11999.5n 0.6511 12000.0n 0.6365 12599.5n 0.6365 12600.0n 0.6553 13199.5n 0.6553 13200.0n 0.6458 13799.5n 0.6458 13800.0n 0.6522 14399.5n 0.6522 14400.0n 0.6511 14999.5n 0.6511 15000.0n 0.6583 15599.5n 0.6583 15600.0n 0.6458 16199.5n 0.6458 16200.0n 0.6484 16799.5n 0.6484 16800.0n 0.6414 17399.5n 0.6414 17400.0n 0.6475 17999.5n 0.6475 18000.0n 0.6622 18599.5n 0.6622 18600.0n 0.6619 19199.5n 0.6619 19200.0n 0.6694 19799.5n 0.6694 19800.0n 0.6722 20399.5n 0.6722 20400.0n 0.6680 20999.5n 0.6680 21000.0n 0.6381 21599.5n 0.6381 21600.0n 0.6682 22199.5n 0.6682 22200.0n 0.6631 22799.5n 0.6631 22800.0n 0.6692 23399.5n 0.6692 23400.0n 0.6118 23999.5n 0.6118 24000.0n 0.6755 24599.5n 0.6755 24600.0n 0.6613 25199.5n 0.6613 25200.0n 0.6657 25799.5n 0.6657 25800.0n 0.6626 26399.5n 0.6626 26400.0n 0.6676 26999.5n 0.6676 27000.0n 0.6644 27599.5n 0.6644 27600.0n 0.6678 28199.5n 0.6678 28200.0n 0.6306 28799.5n 0.6306 28800.0n 0.6687 29399.5n 0.6687 29400.0n 0.6323 29999.5n 0.6323 30000.0n 0.6212 30599.5n 0.6212 30600.0n 0.5588 31199.5n 0.5588 31200.0n 0.5848 31799.5n 0.5848 31800.0n 0.6609 32399.5n 0.6609 32400.0n 0.6630 32999.5n 0.6630 33000.0n 0.6722 33599.5n 0.6722 33600.0n 0.6710 34199.5n 0.6710 34200.0n 0.6588 34799.5n 0.6588 34800.0n 0.6006 35399.5n 0.6006 35400.0n 0.6699 35999.5n 0.6699)
Cwp_wih_1_7 wp_wih_1_7 0 400p
Cwn_wih_1_7 wn_wih_1_7 0 400p
Xu_wih_1_7 xp_wih_1_7 xn_wih_1_7 yp_wih_1_7 yn_wih_1_7 wp_wih_1_7 wn_wih_1_7 vdd gbn gprod
Vxp_who_7_0 xp_who_7_0 0 PWL(0.0n 0.3550 599.5n 0.3550 600.0n 0.3443 1199.5n 0.3443 1200.0n 0.3468 1799.5n 0.3468 1800.0n 0.3378 2399.5n 0.3378 2400.0n 0.3391 2999.5n 0.3391 3000.0n 0.3470 3599.5n 0.3470 3600.0n 0.3490 4199.5n 0.3490 4200.0n 0.3567 4799.5n 0.3567 4800.0n 0.3481 5399.5n 0.3481 5400.0n 0.3478 5999.5n 0.3478 6000.0n 0.3451 6599.5n 0.3451 6600.0n 0.3503 7199.5n 0.3503 7200.0n 0.3432 7799.5n 0.3432 7800.0n 0.3424 8399.5n 0.3424 8400.0n 0.3582 8999.5n 0.3582 9000.0n 0.3480 9599.5n 0.3480 9600.0n 0.3453 10199.5n 0.3453 10200.0n 0.3426 10799.5n 0.3426 10800.0n 0.3484 11399.5n 0.3484 11400.0n 0.3489 11999.5n 0.3489 12000.0n 0.3635 12599.5n 0.3635 12600.0n 0.3447 13199.5n 0.3447 13200.0n 0.3542 13799.5n 0.3542 13800.0n 0.3478 14399.5n 0.3478 14400.0n 0.3489 14999.5n 0.3489 15000.0n 0.3417 15599.5n 0.3417 15600.0n 0.3542 16199.5n 0.3542 16200.0n 0.3516 16799.5n 0.3516 16800.0n 0.3586 17399.5n 0.3586 17400.0n 0.3525 17999.5n 0.3525 18000.0n 0.3378 18599.5n 0.3378 18600.0n 0.3381 19199.5n 0.3381 19200.0n 0.3306 19799.5n 0.3306 19800.0n 0.3278 20399.5n 0.3278 20400.0n 0.3320 20999.5n 0.3320 21000.0n 0.3619 21599.5n 0.3619 21600.0n 0.3318 22199.5n 0.3318 22200.0n 0.3369 22799.5n 0.3369 22800.0n 0.3308 23399.5n 0.3308 23400.0n 0.3882 23999.5n 0.3882 24000.0n 0.3245 24599.5n 0.3245 24600.0n 0.3387 25199.5n 0.3387 25200.0n 0.3343 25799.5n 0.3343 25800.0n 0.3374 26399.5n 0.3374 26400.0n 0.3324 26999.5n 0.3324 27000.0n 0.3356 27599.5n 0.3356 27600.0n 0.3322 28199.5n 0.3322 28200.0n 0.3694 28799.5n 0.3694 28800.0n 0.3313 29399.5n 0.3313 29400.0n 0.3677 29999.5n 0.3677 30000.0n 0.3788 30599.5n 0.3788 30600.0n 0.4412 31199.5n 0.4412 31200.0n 0.4152 31799.5n 0.4152 31800.0n 0.3391 32399.5n 0.3391 32400.0n 0.3370 32999.5n 0.3370 33000.0n 0.3278 33599.5n 0.3278 33600.0n 0.3290 34199.5n 0.3290 34200.0n 0.3412 34799.5n 0.3412 34800.0n 0.3994 35399.5n 0.3994 35400.0n 0.3301 35999.5n 0.3301)
Vxn_who_7_0 xn_who_7_0 0 PWL(0.0n 0.6450 599.5n 0.6450 600.0n 0.6557 1199.5n 0.6557 1200.0n 0.6532 1799.5n 0.6532 1800.0n 0.6622 2399.5n 0.6622 2400.0n 0.6609 2999.5n 0.6609 3000.0n 0.6530 3599.5n 0.6530 3600.0n 0.6510 4199.5n 0.6510 4200.0n 0.6433 4799.5n 0.6433 4800.0n 0.6519 5399.5n 0.6519 5400.0n 0.6522 5999.5n 0.6522 6000.0n 0.6549 6599.5n 0.6549 6600.0n 0.6497 7199.5n 0.6497 7200.0n 0.6568 7799.5n 0.6568 7800.0n 0.6576 8399.5n 0.6576 8400.0n 0.6418 8999.5n 0.6418 9000.0n 0.6520 9599.5n 0.6520 9600.0n 0.6547 10199.5n 0.6547 10200.0n 0.6574 10799.5n 0.6574 10800.0n 0.6516 11399.5n 0.6516 11400.0n 0.6511 11999.5n 0.6511 12000.0n 0.6365 12599.5n 0.6365 12600.0n 0.6553 13199.5n 0.6553 13200.0n 0.6458 13799.5n 0.6458 13800.0n 0.6522 14399.5n 0.6522 14400.0n 0.6511 14999.5n 0.6511 15000.0n 0.6583 15599.5n 0.6583 15600.0n 0.6458 16199.5n 0.6458 16200.0n 0.6484 16799.5n 0.6484 16800.0n 0.6414 17399.5n 0.6414 17400.0n 0.6475 17999.5n 0.6475 18000.0n 0.6622 18599.5n 0.6622 18600.0n 0.6619 19199.5n 0.6619 19200.0n 0.6694 19799.5n 0.6694 19800.0n 0.6722 20399.5n 0.6722 20400.0n 0.6680 20999.5n 0.6680 21000.0n 0.6381 21599.5n 0.6381 21600.0n 0.6682 22199.5n 0.6682 22200.0n 0.6631 22799.5n 0.6631 22800.0n 0.6692 23399.5n 0.6692 23400.0n 0.6118 23999.5n 0.6118 24000.0n 0.6755 24599.5n 0.6755 24600.0n 0.6613 25199.5n 0.6613 25200.0n 0.6657 25799.5n 0.6657 25800.0n 0.6626 26399.5n 0.6626 26400.0n 0.6676 26999.5n 0.6676 27000.0n 0.6644 27599.5n 0.6644 27600.0n 0.6678 28199.5n 0.6678 28200.0n 0.6306 28799.5n 0.6306 28800.0n 0.6687 29399.5n 0.6687 29400.0n 0.6323 29999.5n 0.6323 30000.0n 0.6212 30599.5n 0.6212 30600.0n 0.5588 31199.5n 0.5588 31200.0n 0.5848 31799.5n 0.5848 31800.0n 0.6609 32399.5n 0.6609 32400.0n 0.6630 32999.5n 0.6630 33000.0n 0.6722 33599.5n 0.6722 33600.0n 0.6710 34199.5n 0.6710 34200.0n 0.6588 34799.5n 0.6588 34800.0n 0.6006 35399.5n 0.6006 35400.0n 0.6699 35999.5n 0.6699)
Vyp_who_7_0 yp_who_7_0 0 PWL(0.0n 0.5031 599.5n 0.5031 600.0n 0.5023 1199.5n 0.5023 1200.0n 0.5052 1799.5n 0.5052 1800.0n 0.5048 2399.5n 0.5048 2400.0n 0.5043 2999.5n 0.5043 3000.0n 0.5034 3599.5n 0.5034 3600.0n 0.5048 4199.5n 0.5048 4200.0n 0.5031 4799.5n 0.5031 4800.0n 0.5040 5399.5n 0.5040 5400.0n 0.5040 5999.5n 0.5040 6000.0n 0.5054 6599.5n 0.5054 6600.0n 0.5040 7199.5n 0.5040 7200.0n 0.5027 7799.5n 0.5027 7800.0n 0.5027 8399.5n 0.5027 8400.0n 0.5038 8999.5n 0.5038 9000.0n 0.5040 9599.5n 0.5040 9600.0n 0.5039 10199.5n 0.5039 10200.0n 0.5033 10799.5n 0.5033 10800.0n 0.5056 11399.5n 0.5056 11400.0n 0.5040 11999.5n 0.5040 12000.0n 0.5036 12599.5n 0.5036 12600.0n 0.5039 13199.5n 0.5039 13200.0n 0.5029 13799.5n 0.5029 13800.0n 0.5025 14399.5n 0.5025 14400.0n 0.5038 14999.5n 0.5038 15000.0n 0.5041 15599.5n 0.5041 15600.0n 0.5036 16199.5n 0.5036 16200.0n 0.5025 16799.5n 0.5025 16800.0n 0.5040 17399.5n 0.5040 17400.0n 0.5029 17999.5n 0.5029 18000.0n 0.5057 18599.5n 0.5057 18600.0n 0.5010 19199.5n 0.5010 19200.0n 0.5041 19799.5n 0.5041 19800.0n 0.5021 20399.5n 0.5021 20400.0n 0.5044 20999.5n 0.5044 21000.0n 0.5056 21599.5n 0.5056 21600.0n 0.5016 22199.5n 0.5016 22200.0n 0.5006 22799.5n 0.5006 22800.0n 0.5041 23399.5n 0.5041 23400.0n 0.5027 23999.5n 0.5027 24000.0n 0.5029 24599.5n 0.5029 24600.0n 0.5006 25199.5n 0.5006 25200.0n 0.5047 25799.5n 0.5047 25800.0n 0.5046 26399.5n 0.5046 26400.0n 0.5039 26999.5n 0.5039 27000.0n 0.5049 27599.5n 0.5049 27600.0n 0.5039 28199.5n 0.5039 28200.0n 0.5017 28799.5n 0.5017 28800.0n 0.5042 29399.5n 0.5042 29400.0n 0.5056 29999.5n 0.5056 30000.0n 0.5051 30599.5n 0.5051 30600.0n 0.5039 31199.5n 0.5039 31200.0n 0.5033 31799.5n 0.5033 31800.0n 0.5049 32399.5n 0.5049 32400.0n 0.5045 32999.5n 0.5045 33000.0n 0.5036 33599.5n 0.5036 33600.0n 0.5042 34199.5n 0.5042 34200.0n 0.5012 34799.5n 0.5012 34800.0n 0.5036 35399.5n 0.5036 35400.0n 0.5042 35999.5n 0.5042)
Vyn_who_7_0 yn_who_7_0 0 PWL(0.0n 0.4969 599.5n 0.4969 600.0n 0.4977 1199.5n 0.4977 1200.0n 0.4948 1799.5n 0.4948 1800.0n 0.4952 2399.5n 0.4952 2400.0n 0.4957 2999.5n 0.4957 3000.0n 0.4966 3599.5n 0.4966 3600.0n 0.4952 4199.5n 0.4952 4200.0n 0.4969 4799.5n 0.4969 4800.0n 0.4960 5399.5n 0.4960 5400.0n 0.4960 5999.5n 0.4960 6000.0n 0.4946 6599.5n 0.4946 6600.0n 0.4960 7199.5n 0.4960 7200.0n 0.4973 7799.5n 0.4973 7800.0n 0.4973 8399.5n 0.4973 8400.0n 0.4962 8999.5n 0.4962 9000.0n 0.4960 9599.5n 0.4960 9600.0n 0.4961 10199.5n 0.4961 10200.0n 0.4967 10799.5n 0.4967 10800.0n 0.4944 11399.5n 0.4944 11400.0n 0.4960 11999.5n 0.4960 12000.0n 0.4964 12599.5n 0.4964 12600.0n 0.4961 13199.5n 0.4961 13200.0n 0.4971 13799.5n 0.4971 13800.0n 0.4975 14399.5n 0.4975 14400.0n 0.4962 14999.5n 0.4962 15000.0n 0.4959 15599.5n 0.4959 15600.0n 0.4964 16199.5n 0.4964 16200.0n 0.4975 16799.5n 0.4975 16800.0n 0.4960 17399.5n 0.4960 17400.0n 0.4971 17999.5n 0.4971 18000.0n 0.4943 18599.5n 0.4943 18600.0n 0.4990 19199.5n 0.4990 19200.0n 0.4959 19799.5n 0.4959 19800.0n 0.4979 20399.5n 0.4979 20400.0n 0.4956 20999.5n 0.4956 21000.0n 0.4944 21599.5n 0.4944 21600.0n 0.4984 22199.5n 0.4984 22200.0n 0.4994 22799.5n 0.4994 22800.0n 0.4959 23399.5n 0.4959 23400.0n 0.4973 23999.5n 0.4973 24000.0n 0.4971 24599.5n 0.4971 24600.0n 0.4994 25199.5n 0.4994 25200.0n 0.4953 25799.5n 0.4953 25800.0n 0.4954 26399.5n 0.4954 26400.0n 0.4961 26999.5n 0.4961 27000.0n 0.4951 27599.5n 0.4951 27600.0n 0.4961 28199.5n 0.4961 28200.0n 0.4983 28799.5n 0.4983 28800.0n 0.4958 29399.5n 0.4958 29400.0n 0.4944 29999.5n 0.4944 30000.0n 0.4949 30599.5n 0.4949 30600.0n 0.4961 31199.5n 0.4961 31200.0n 0.4967 31799.5n 0.4967 31800.0n 0.4951 32399.5n 0.4951 32400.0n 0.4955 32999.5n 0.4955 33000.0n 0.4964 33599.5n 0.4964 33600.0n 0.4958 34199.5n 0.4958 34200.0n 0.4988 34799.5n 0.4988 34800.0n 0.4964 35399.5n 0.4964 35400.0n 0.4958 35999.5n 0.4958)
Cwp_who_7_0 wp_who_7_0 0 400p
Cwn_who_7_0 wn_who_7_0 0 400p
Xu_who_7_0 xp_who_7_0 xn_who_7_0 yp_who_7_0 yn_who_7_0 wp_who_7_0 wn_who_7_0 vdd gbn gprod
Vxp_who_7_1 xp_who_7_1 0 PWL(0.0n 0.3550 599.5n 0.3550 600.0n 0.3443 1199.5n 0.3443 1200.0n 0.3468 1799.5n 0.3468 1800.0n 0.3378 2399.5n 0.3378 2400.0n 0.3391 2999.5n 0.3391 3000.0n 0.3470 3599.5n 0.3470 3600.0n 0.3490 4199.5n 0.3490 4200.0n 0.3567 4799.5n 0.3567 4800.0n 0.3481 5399.5n 0.3481 5400.0n 0.3478 5999.5n 0.3478 6000.0n 0.3451 6599.5n 0.3451 6600.0n 0.3503 7199.5n 0.3503 7200.0n 0.3432 7799.5n 0.3432 7800.0n 0.3424 8399.5n 0.3424 8400.0n 0.3582 8999.5n 0.3582 9000.0n 0.3480 9599.5n 0.3480 9600.0n 0.3453 10199.5n 0.3453 10200.0n 0.3426 10799.5n 0.3426 10800.0n 0.3484 11399.5n 0.3484 11400.0n 0.3489 11999.5n 0.3489 12000.0n 0.3635 12599.5n 0.3635 12600.0n 0.3447 13199.5n 0.3447 13200.0n 0.3542 13799.5n 0.3542 13800.0n 0.3478 14399.5n 0.3478 14400.0n 0.3489 14999.5n 0.3489 15000.0n 0.3417 15599.5n 0.3417 15600.0n 0.3542 16199.5n 0.3542 16200.0n 0.3516 16799.5n 0.3516 16800.0n 0.3586 17399.5n 0.3586 17400.0n 0.3525 17999.5n 0.3525 18000.0n 0.3378 18599.5n 0.3378 18600.0n 0.3381 19199.5n 0.3381 19200.0n 0.3306 19799.5n 0.3306 19800.0n 0.3278 20399.5n 0.3278 20400.0n 0.3320 20999.5n 0.3320 21000.0n 0.3619 21599.5n 0.3619 21600.0n 0.3318 22199.5n 0.3318 22200.0n 0.3369 22799.5n 0.3369 22800.0n 0.3308 23399.5n 0.3308 23400.0n 0.3882 23999.5n 0.3882 24000.0n 0.3245 24599.5n 0.3245 24600.0n 0.3387 25199.5n 0.3387 25200.0n 0.3343 25799.5n 0.3343 25800.0n 0.3374 26399.5n 0.3374 26400.0n 0.3324 26999.5n 0.3324 27000.0n 0.3356 27599.5n 0.3356 27600.0n 0.3322 28199.5n 0.3322 28200.0n 0.3694 28799.5n 0.3694 28800.0n 0.3313 29399.5n 0.3313 29400.0n 0.3677 29999.5n 0.3677 30000.0n 0.3788 30599.5n 0.3788 30600.0n 0.4412 31199.5n 0.4412 31200.0n 0.4152 31799.5n 0.4152 31800.0n 0.3391 32399.5n 0.3391 32400.0n 0.3370 32999.5n 0.3370 33000.0n 0.3278 33599.5n 0.3278 33600.0n 0.3290 34199.5n 0.3290 34200.0n 0.3412 34799.5n 0.3412 34800.0n 0.3994 35399.5n 0.3994 35400.0n 0.3301 35999.5n 0.3301)
Vxn_who_7_1 xn_who_7_1 0 PWL(0.0n 0.6450 599.5n 0.6450 600.0n 0.6557 1199.5n 0.6557 1200.0n 0.6532 1799.5n 0.6532 1800.0n 0.6622 2399.5n 0.6622 2400.0n 0.6609 2999.5n 0.6609 3000.0n 0.6530 3599.5n 0.6530 3600.0n 0.6510 4199.5n 0.6510 4200.0n 0.6433 4799.5n 0.6433 4800.0n 0.6519 5399.5n 0.6519 5400.0n 0.6522 5999.5n 0.6522 6000.0n 0.6549 6599.5n 0.6549 6600.0n 0.6497 7199.5n 0.6497 7200.0n 0.6568 7799.5n 0.6568 7800.0n 0.6576 8399.5n 0.6576 8400.0n 0.6418 8999.5n 0.6418 9000.0n 0.6520 9599.5n 0.6520 9600.0n 0.6547 10199.5n 0.6547 10200.0n 0.6574 10799.5n 0.6574 10800.0n 0.6516 11399.5n 0.6516 11400.0n 0.6511 11999.5n 0.6511 12000.0n 0.6365 12599.5n 0.6365 12600.0n 0.6553 13199.5n 0.6553 13200.0n 0.6458 13799.5n 0.6458 13800.0n 0.6522 14399.5n 0.6522 14400.0n 0.6511 14999.5n 0.6511 15000.0n 0.6583 15599.5n 0.6583 15600.0n 0.6458 16199.5n 0.6458 16200.0n 0.6484 16799.5n 0.6484 16800.0n 0.6414 17399.5n 0.6414 17400.0n 0.6475 17999.5n 0.6475 18000.0n 0.6622 18599.5n 0.6622 18600.0n 0.6619 19199.5n 0.6619 19200.0n 0.6694 19799.5n 0.6694 19800.0n 0.6722 20399.5n 0.6722 20400.0n 0.6680 20999.5n 0.6680 21000.0n 0.6381 21599.5n 0.6381 21600.0n 0.6682 22199.5n 0.6682 22200.0n 0.6631 22799.5n 0.6631 22800.0n 0.6692 23399.5n 0.6692 23400.0n 0.6118 23999.5n 0.6118 24000.0n 0.6755 24599.5n 0.6755 24600.0n 0.6613 25199.5n 0.6613 25200.0n 0.6657 25799.5n 0.6657 25800.0n 0.6626 26399.5n 0.6626 26400.0n 0.6676 26999.5n 0.6676 27000.0n 0.6644 27599.5n 0.6644 27600.0n 0.6678 28199.5n 0.6678 28200.0n 0.6306 28799.5n 0.6306 28800.0n 0.6687 29399.5n 0.6687 29400.0n 0.6323 29999.5n 0.6323 30000.0n 0.6212 30599.5n 0.6212 30600.0n 0.5588 31199.5n 0.5588 31200.0n 0.5848 31799.5n 0.5848 31800.0n 0.6609 32399.5n 0.6609 32400.0n 0.6630 32999.5n 0.6630 33000.0n 0.6722 33599.5n 0.6722 33600.0n 0.6710 34199.5n 0.6710 34200.0n 0.6588 34799.5n 0.6588 34800.0n 0.6006 35399.5n 0.6006 35400.0n 0.6699 35999.5n 0.6699)
Vyp_who_7_1 yp_who_7_1 0 PWL(0.0n 0.5071 599.5n 0.5071 600.0n 0.5053 1199.5n 0.5053 1200.0n 0.5052 1799.5n 0.5052 1800.0n 0.5027 2399.5n 0.5027 2400.0n 0.5034 2999.5n 0.5034 3000.0n 0.5055 3599.5n 0.5055 3600.0n 0.5056 4199.5n 0.5056 4200.0n 0.5071 4799.5n 0.5071 4800.0n 0.5056 5399.5n 0.5056 5400.0n 0.5056 5999.5n 0.5056 6000.0n 0.5048 6599.5n 0.5048 6600.0n 0.5060 7199.5n 0.5060 7200.0n 0.5048 7799.5n 0.5048 7800.0n 0.5046 8399.5n 0.5046 8400.0n 0.5066 8999.5n 0.5066 9000.0n 0.5056 9599.5n 0.5056 9600.0n 0.5051 10199.5n 0.5051 10200.0n 0.5046 10799.5n 0.5046 10800.0n 0.5056 11399.5n 0.5056 11400.0n 0.5058 11999.5n 0.5058 12000.0n 0.5068 12599.5n 0.5068 12600.0n 0.5050 13199.5n 0.5050 13200.0n 0.5071 13799.5n 0.5071 13800.0n 0.5059 14399.5n 0.5059 14400.0n 0.5058 14999.5n 0.5058 15000.0n 0.5043 15599.5n 0.5043 15600.0n 0.5067 16199.5n 0.5067 16200.0n 0.5068 16799.5n 0.5068 16800.0n 0.5066 17399.5n 0.5066 17400.0n 0.5069 17999.5n 0.5069 18000.0n 0.5061 18599.5n 0.5061 18600.0n 0.5034 19199.5n 0.5034 19200.0n 0.5010 19799.5n 0.5010 19800.0n 0.4989 20399.5n 0.4989 20400.0n 0.5022 20999.5n 0.5022 21000.0n 0.5086 21599.5n 0.5086 21600.0n 0.5007 22199.5n 0.5007 22200.0n 0.5023 22799.5n 0.5023 22800.0n 0.5021 23399.5n 0.5021 23400.0n 0.5077 23999.5n 0.5077 24000.0n 0.4979 24599.5n 0.4979 24600.0n 0.5035 25199.5n 0.5035 25200.0n 0.5041 25799.5n 0.5041 25800.0n 0.5075 26399.5n 0.5075 26400.0n 0.5041 26999.5n 0.5041 27000.0n 0.5056 27599.5n 0.5056 27600.0n 0.5039 28199.5n 0.5039 28200.0n 0.5059 28799.5n 0.5059 28800.0n 0.5023 29399.5n 0.5023 29400.0n 0.5086 29999.5n 0.5086 30000.0n 0.5084 30599.5n 0.5084 30600.0n 0.5085 31199.5n 0.5085 31200.0n 0.5088 31799.5n 0.5088 31800.0n 0.5078 32399.5n 0.5078 32400.0n 0.5074 32999.5n 0.5074 33000.0n 0.4996 33599.5n 0.4996 33600.0n 0.5010 34199.5n 0.5010 34200.0n 0.5044 34799.5n 0.5044 34800.0n 0.5084 35399.5n 0.5084 35400.0n 0.5012 35999.5n 0.5012)
Vyn_who_7_1 yn_who_7_1 0 PWL(0.0n 0.4929 599.5n 0.4929 600.0n 0.4947 1199.5n 0.4947 1200.0n 0.4948 1799.5n 0.4948 1800.0n 0.4973 2399.5n 0.4973 2400.0n 0.4966 2999.5n 0.4966 3000.0n 0.4945 3599.5n 0.4945 3600.0n 0.4944 4199.5n 0.4944 4200.0n 0.4929 4799.5n 0.4929 4800.0n 0.4944 5399.5n 0.4944 5400.0n 0.4944 5999.5n 0.4944 6000.0n 0.4952 6599.5n 0.4952 6600.0n 0.4940 7199.5n 0.4940 7200.0n 0.4952 7799.5n 0.4952 7800.0n 0.4954 8399.5n 0.4954 8400.0n 0.4934 8999.5n 0.4934 9000.0n 0.4944 9599.5n 0.4944 9600.0n 0.4949 10199.5n 0.4949 10200.0n 0.4954 10799.5n 0.4954 10800.0n 0.4944 11399.5n 0.4944 11400.0n 0.4942 11999.5n 0.4942 12000.0n 0.4932 12599.5n 0.4932 12600.0n 0.4950 13199.5n 0.4950 13200.0n 0.4929 13799.5n 0.4929 13800.0n 0.4941 14399.5n 0.4941 14400.0n 0.4942 14999.5n 0.4942 15000.0n 0.4957 15599.5n 0.4957 15600.0n 0.4933 16199.5n 0.4933 16200.0n 0.4932 16799.5n 0.4932 16800.0n 0.4934 17399.5n 0.4934 17400.0n 0.4931 17999.5n 0.4931 18000.0n 0.4939 18599.5n 0.4939 18600.0n 0.4966 19199.5n 0.4966 19200.0n 0.4990 19799.5n 0.4990 19800.0n 0.5011 20399.5n 0.5011 20400.0n 0.4978 20999.5n 0.4978 21000.0n 0.4914 21599.5n 0.4914 21600.0n 0.4993 22199.5n 0.4993 22200.0n 0.4977 22799.5n 0.4977 22800.0n 0.4979 23399.5n 0.4979 23400.0n 0.4923 23999.5n 0.4923 24000.0n 0.5021 24599.5n 0.5021 24600.0n 0.4965 25199.5n 0.4965 25200.0n 0.4959 25799.5n 0.4959 25800.0n 0.4925 26399.5n 0.4925 26400.0n 0.4959 26999.5n 0.4959 27000.0n 0.4944 27599.5n 0.4944 27600.0n 0.4961 28199.5n 0.4961 28200.0n 0.4941 28799.5n 0.4941 28800.0n 0.4977 29399.5n 0.4977 29400.0n 0.4914 29999.5n 0.4914 30000.0n 0.4916 30599.5n 0.4916 30600.0n 0.4915 31199.5n 0.4915 31200.0n 0.4912 31799.5n 0.4912 31800.0n 0.4922 32399.5n 0.4922 32400.0n 0.4926 32999.5n 0.4926 33000.0n 0.5004 33599.5n 0.5004 33600.0n 0.4990 34199.5n 0.4990 34200.0n 0.4956 34799.5n 0.4956 34800.0n 0.4916 35399.5n 0.4916 35400.0n 0.4988 35999.5n 0.4988)
Cwp_who_7_1 wp_who_7_1 0 400p
Cwn_who_7_1 wn_who_7_1 0 400p
Xu_who_7_1 xp_who_7_1 xn_who_7_1 yp_who_7_1 yn_who_7_1 wp_who_7_1 wn_who_7_1 vdd gbn gprod
Vxp_bh_7 xp_bh_7 0 PWL(0.0n 0.7100 599.5n 0.7100 600.0n 0.7100 1199.5n 0.7100 1200.0n 0.7100 1799.5n 0.7100 1800.0n 0.7100 2399.5n 0.7100 2400.0n 0.7100 2999.5n 0.7100 3000.0n 0.7100 3599.5n 0.7100 3600.0n 0.7100 4199.5n 0.7100 4200.0n 0.7100 4799.5n 0.7100 4800.0n 0.7100 5399.5n 0.7100 5400.0n 0.7100 5999.5n 0.7100 6000.0n 0.7100 6599.5n 0.7100 6600.0n 0.7100 7199.5n 0.7100 7200.0n 0.7100 7799.5n 0.7100 7800.0n 0.7100 8399.5n 0.7100 8400.0n 0.7100 8999.5n 0.7100 9000.0n 0.7100 9599.5n 0.7100 9600.0n 0.7100 10199.5n 0.7100 10200.0n 0.7100 10799.5n 0.7100 10800.0n 0.7100 11399.5n 0.7100 11400.0n 0.7100 11999.5n 0.7100 12000.0n 0.7100 12599.5n 0.7100 12600.0n 0.7100 13199.5n 0.7100 13200.0n 0.7100 13799.5n 0.7100 13800.0n 0.7100 14399.5n 0.7100 14400.0n 0.7100 14999.5n 0.7100 15000.0n 0.7100 15599.5n 0.7100 15600.0n 0.7100 16199.5n 0.7100 16200.0n 0.7100 16799.5n 0.7100 16800.0n 0.7100 17399.5n 0.7100 17400.0n 0.7100 17999.5n 0.7100 18000.0n 0.7100 18599.5n 0.7100 18600.0n 0.7100 19199.5n 0.7100 19200.0n 0.7100 19799.5n 0.7100 19800.0n 0.7100 20399.5n 0.7100 20400.0n 0.7100 20999.5n 0.7100 21000.0n 0.7100 21599.5n 0.7100 21600.0n 0.7100 22199.5n 0.7100 22200.0n 0.7100 22799.5n 0.7100 22800.0n 0.7100 23399.5n 0.7100 23400.0n 0.7100 23999.5n 0.7100 24000.0n 0.7100 24599.5n 0.7100 24600.0n 0.7100 25199.5n 0.7100 25200.0n 0.7100 25799.5n 0.7100 25800.0n 0.7100 26399.5n 0.7100 26400.0n 0.7100 26999.5n 0.7100 27000.0n 0.7100 27599.5n 0.7100 27600.0n 0.7100 28199.5n 0.7100 28200.0n 0.7100 28799.5n 0.7100 28800.0n 0.7100 29399.5n 0.7100 29400.0n 0.7100 29999.5n 0.7100 30000.0n 0.7100 30599.5n 0.7100 30600.0n 0.7100 31199.5n 0.7100 31200.0n 0.7100 31799.5n 0.7100 31800.0n 0.7100 32399.5n 0.7100 32400.0n 0.7100 32999.5n 0.7100 33000.0n 0.7100 33599.5n 0.7100 33600.0n 0.7100 34199.5n 0.7100 34200.0n 0.7100 34799.5n 0.7100 34800.0n 0.7100 35399.5n 0.7100 35400.0n 0.7100 35999.5n 0.7100)
Vxn_bh_7 xn_bh_7 0 PWL(0.0n 0.2900 599.5n 0.2900 600.0n 0.2900 1199.5n 0.2900 1200.0n 0.2900 1799.5n 0.2900 1800.0n 0.2900 2399.5n 0.2900 2400.0n 0.2900 2999.5n 0.2900 3000.0n 0.2900 3599.5n 0.2900 3600.0n 0.2900 4199.5n 0.2900 4200.0n 0.2900 4799.5n 0.2900 4800.0n 0.2900 5399.5n 0.2900 5400.0n 0.2900 5999.5n 0.2900 6000.0n 0.2900 6599.5n 0.2900 6600.0n 0.2900 7199.5n 0.2900 7200.0n 0.2900 7799.5n 0.2900 7800.0n 0.2900 8399.5n 0.2900 8400.0n 0.2900 8999.5n 0.2900 9000.0n 0.2900 9599.5n 0.2900 9600.0n 0.2900 10199.5n 0.2900 10200.0n 0.2900 10799.5n 0.2900 10800.0n 0.2900 11399.5n 0.2900 11400.0n 0.2900 11999.5n 0.2900 12000.0n 0.2900 12599.5n 0.2900 12600.0n 0.2900 13199.5n 0.2900 13200.0n 0.2900 13799.5n 0.2900 13800.0n 0.2900 14399.5n 0.2900 14400.0n 0.2900 14999.5n 0.2900 15000.0n 0.2900 15599.5n 0.2900 15600.0n 0.2900 16199.5n 0.2900 16200.0n 0.2900 16799.5n 0.2900 16800.0n 0.2900 17399.5n 0.2900 17400.0n 0.2900 17999.5n 0.2900 18000.0n 0.2900 18599.5n 0.2900 18600.0n 0.2900 19199.5n 0.2900 19200.0n 0.2900 19799.5n 0.2900 19800.0n 0.2900 20399.5n 0.2900 20400.0n 0.2900 20999.5n 0.2900 21000.0n 0.2900 21599.5n 0.2900 21600.0n 0.2900 22199.5n 0.2900 22200.0n 0.2900 22799.5n 0.2900 22800.0n 0.2900 23399.5n 0.2900 23400.0n 0.2900 23999.5n 0.2900 24000.0n 0.2900 24599.5n 0.2900 24600.0n 0.2900 25199.5n 0.2900 25200.0n 0.2900 25799.5n 0.2900 25800.0n 0.2900 26399.5n 0.2900 26400.0n 0.2900 26999.5n 0.2900 27000.0n 0.2900 27599.5n 0.2900 27600.0n 0.2900 28199.5n 0.2900 28200.0n 0.2900 28799.5n 0.2900 28800.0n 0.2900 29399.5n 0.2900 29400.0n 0.2900 29999.5n 0.2900 30000.0n 0.2900 30599.5n 0.2900 30600.0n 0.2900 31199.5n 0.2900 31200.0n 0.2900 31799.5n 0.2900 31800.0n 0.2900 32399.5n 0.2900 32400.0n 0.2900 32999.5n 0.2900 33000.0n 0.2900 33599.5n 0.2900 33600.0n 0.2900 34199.5n 0.2900 34200.0n 0.2900 34799.5n 0.2900 34800.0n 0.2900 35399.5n 0.2900 35400.0n 0.2900 35999.5n 0.2900)
Vyp_bh_7 yp_bh_7 0 PWL(0.0n 0.3550 599.5n 0.3550 600.0n 0.3443 1199.5n 0.3443 1200.0n 0.3468 1799.5n 0.3468 1800.0n 0.3378 2399.5n 0.3378 2400.0n 0.3391 2999.5n 0.3391 3000.0n 0.3470 3599.5n 0.3470 3600.0n 0.3490 4199.5n 0.3490 4200.0n 0.3567 4799.5n 0.3567 4800.0n 0.3481 5399.5n 0.3481 5400.0n 0.3478 5999.5n 0.3478 6000.0n 0.3451 6599.5n 0.3451 6600.0n 0.3503 7199.5n 0.3503 7200.0n 0.3432 7799.5n 0.3432 7800.0n 0.3424 8399.5n 0.3424 8400.0n 0.3582 8999.5n 0.3582 9000.0n 0.3480 9599.5n 0.3480 9600.0n 0.3453 10199.5n 0.3453 10200.0n 0.3426 10799.5n 0.3426 10800.0n 0.3484 11399.5n 0.3484 11400.0n 0.3489 11999.5n 0.3489 12000.0n 0.3635 12599.5n 0.3635 12600.0n 0.3447 13199.5n 0.3447 13200.0n 0.3542 13799.5n 0.3542 13800.0n 0.3478 14399.5n 0.3478 14400.0n 0.3489 14999.5n 0.3489 15000.0n 0.3417 15599.5n 0.3417 15600.0n 0.3542 16199.5n 0.3542 16200.0n 0.3516 16799.5n 0.3516 16800.0n 0.3586 17399.5n 0.3586 17400.0n 0.3525 17999.5n 0.3525 18000.0n 0.3378 18599.5n 0.3378 18600.0n 0.3381 19199.5n 0.3381 19200.0n 0.3306 19799.5n 0.3306 19800.0n 0.3278 20399.5n 0.3278 20400.0n 0.3320 20999.5n 0.3320 21000.0n 0.3619 21599.5n 0.3619 21600.0n 0.3318 22199.5n 0.3318 22200.0n 0.3369 22799.5n 0.3369 22800.0n 0.3308 23399.5n 0.3308 23400.0n 0.3882 23999.5n 0.3882 24000.0n 0.3245 24599.5n 0.3245 24600.0n 0.3387 25199.5n 0.3387 25200.0n 0.3343 25799.5n 0.3343 25800.0n 0.3374 26399.5n 0.3374 26400.0n 0.3324 26999.5n 0.3324 27000.0n 0.3356 27599.5n 0.3356 27600.0n 0.3322 28199.5n 0.3322 28200.0n 0.3694 28799.5n 0.3694 28800.0n 0.3313 29399.5n 0.3313 29400.0n 0.3677 29999.5n 0.3677 30000.0n 0.3788 30599.5n 0.3788 30600.0n 0.4412 31199.5n 0.4412 31200.0n 0.4152 31799.5n 0.4152 31800.0n 0.3391 32399.5n 0.3391 32400.0n 0.3370 32999.5n 0.3370 33000.0n 0.3278 33599.5n 0.3278 33600.0n 0.3290 34199.5n 0.3290 34200.0n 0.3412 34799.5n 0.3412 34800.0n 0.3994 35399.5n 0.3994 35400.0n 0.3301 35999.5n 0.3301)
Vyn_bh_7 yn_bh_7 0 PWL(0.0n 0.6450 599.5n 0.6450 600.0n 0.6557 1199.5n 0.6557 1200.0n 0.6532 1799.5n 0.6532 1800.0n 0.6622 2399.5n 0.6622 2400.0n 0.6609 2999.5n 0.6609 3000.0n 0.6530 3599.5n 0.6530 3600.0n 0.6510 4199.5n 0.6510 4200.0n 0.6433 4799.5n 0.6433 4800.0n 0.6519 5399.5n 0.6519 5400.0n 0.6522 5999.5n 0.6522 6000.0n 0.6549 6599.5n 0.6549 6600.0n 0.6497 7199.5n 0.6497 7200.0n 0.6568 7799.5n 0.6568 7800.0n 0.6576 8399.5n 0.6576 8400.0n 0.6418 8999.5n 0.6418 9000.0n 0.6520 9599.5n 0.6520 9600.0n 0.6547 10199.5n 0.6547 10200.0n 0.6574 10799.5n 0.6574 10800.0n 0.6516 11399.5n 0.6516 11400.0n 0.6511 11999.5n 0.6511 12000.0n 0.6365 12599.5n 0.6365 12600.0n 0.6553 13199.5n 0.6553 13200.0n 0.6458 13799.5n 0.6458 13800.0n 0.6522 14399.5n 0.6522 14400.0n 0.6511 14999.5n 0.6511 15000.0n 0.6583 15599.5n 0.6583 15600.0n 0.6458 16199.5n 0.6458 16200.0n 0.6484 16799.5n 0.6484 16800.0n 0.6414 17399.5n 0.6414 17400.0n 0.6475 17999.5n 0.6475 18000.0n 0.6622 18599.5n 0.6622 18600.0n 0.6619 19199.5n 0.6619 19200.0n 0.6694 19799.5n 0.6694 19800.0n 0.6722 20399.5n 0.6722 20400.0n 0.6680 20999.5n 0.6680 21000.0n 0.6381 21599.5n 0.6381 21600.0n 0.6682 22199.5n 0.6682 22200.0n 0.6631 22799.5n 0.6631 22800.0n 0.6692 23399.5n 0.6692 23400.0n 0.6118 23999.5n 0.6118 24000.0n 0.6755 24599.5n 0.6755 24600.0n 0.6613 25199.5n 0.6613 25200.0n 0.6657 25799.5n 0.6657 25800.0n 0.6626 26399.5n 0.6626 26400.0n 0.6676 26999.5n 0.6676 27000.0n 0.6644 27599.5n 0.6644 27600.0n 0.6678 28199.5n 0.6678 28200.0n 0.6306 28799.5n 0.6306 28800.0n 0.6687 29399.5n 0.6687 29400.0n 0.6323 29999.5n 0.6323 30000.0n 0.6212 30599.5n 0.6212 30600.0n 0.5588 31199.5n 0.5588 31200.0n 0.5848 31799.5n 0.5848 31800.0n 0.6609 32399.5n 0.6609 32400.0n 0.6630 32999.5n 0.6630 33000.0n 0.6722 33599.5n 0.6722 33600.0n 0.6710 34199.5n 0.6710 34200.0n 0.6588 34799.5n 0.6588 34800.0n 0.6006 35399.5n 0.6006 35400.0n 0.6699 35999.5n 0.6699)
Cwp_bh_7 wp_bh_7 0 400p
Cwn_bh_7 wn_bh_7 0 400p
Xu_bh_7 xp_bh_7 xn_bh_7 yp_bh_7 yn_bh_7 wp_bh_7 wn_bh_7 vdd gbn gprod
Vxp_wih_0_8 xp_wih_0_8 0 PWL(0.0n 0.4942 599.5n 0.4942 600.0n 0.5558 1199.5n 0.5558 1200.0n 0.4708 1799.5n 0.4708 1800.0n 0.5235 2399.5n 0.5235 2400.0n 0.5350 2999.5n 0.5350 3000.0n 0.5172 3599.5n 0.5172 3600.0n 0.4702 4199.5n 0.4702 4200.0n 0.4867 4799.5n 0.4867 4800.0n 0.4970 5399.5n 0.4970 5400.0n 0.4986 5999.5n 0.4986 6000.0n 0.4751 6599.5n 0.4751 6600.0n 0.4870 7199.5n 0.4870 7200.0n 0.5502 7799.5n 0.5502 7800.0n 0.5521 8399.5n 0.5521 8400.0n 0.4638 8999.5n 0.4638 9000.0n 0.4982 9599.5n 0.4982 9600.0n 0.5131 10199.5n 0.5131 10200.0n 0.5386 10799.5n 0.5386 10800.0n 0.4592 11399.5n 0.4592 11400.0n 0.4950 11999.5n 0.4950 12000.0n 0.4559 12599.5n 0.4559 12600.0n 0.5162 13199.5n 0.5162 13200.0n 0.5038 13799.5n 0.5038 13800.0n 0.5333 14399.5n 0.5333 14400.0n 0.4991 14999.5n 0.4991 15000.0n 0.5298 15599.5n 0.5298 15600.0n 0.4823 16199.5n 0.4823 16200.0n 0.5239 16799.5n 0.5239 16800.0n 0.4592 17399.5n 0.4592 17400.0n 0.5094 17999.5n 0.5094 18000.0n 0.4337 18599.5n 0.4337 18600.0n 0.5977 19199.5n 0.5977 19200.0n 0.5364 19799.5n 0.5364 19800.0n 0.6122 20399.5n 0.6122 20400.0n 0.4856 20999.5n 0.4856 21000.0n 0.3861 21599.5n 0.3861 21600.0n 0.6094 22199.5n 0.6094 22200.0n 0.6364 22799.5n 0.6364 22800.0n 0.4807 23399.5n 0.4807 23400.0n 0.5614 23999.5n 0.5614 24000.0n 0.5913 24599.5n 0.5913 24600.0n 0.6295 25199.5n 0.6295 25200.0n 0.4496 25799.5n 0.4496 25800.0n 0.3792 26399.5n 0.3792 26400.0n 0.4434 26999.5n 0.4434 27000.0n 0.4340 27599.5n 0.4340 27600.0n 0.4461 28199.5n 0.4461 28200.0n 0.5791 28799.5n 0.5791 28800.0n 0.4777 29399.5n 0.4777 29400.0n 0.3878 29999.5n 0.3878 30000.0n 0.3832 30599.5n 0.3832 30600.0n 0.4022 31199.5n 0.4022 31200.0n 0.4482 31799.5n 0.4482 31800.0n 0.3662 32399.5n 0.3662 32400.0n 0.3857 32999.5n 0.3857 33000.0n 0.5584 33599.5n 0.5584 33600.0n 0.5284 34199.5n 0.5284 34200.0n 0.6034 34799.5n 0.6034 34800.0n 0.3469 35399.5n 0.3469 35400.0n 0.5290 35999.5n 0.5290)
Vxn_wih_0_8 xn_wih_0_8 0 PWL(0.0n 0.5058 599.5n 0.5058 600.0n 0.4442 1199.5n 0.4442 1200.0n 0.5292 1799.5n 0.5292 1800.0n 0.4765 2399.5n 0.4765 2400.0n 0.4650 2999.5n 0.4650 3000.0n 0.4828 3599.5n 0.4828 3600.0n 0.5298 4199.5n 0.5298 4200.0n 0.5133 4799.5n 0.5133 4800.0n 0.5030 5399.5n 0.5030 5400.0n 0.5014 5999.5n 0.5014 6000.0n 0.5249 6599.5n 0.5249 6600.0n 0.5130 7199.5n 0.5130 7200.0n 0.4498 7799.5n 0.4498 7800.0n 0.4479 8399.5n 0.4479 8400.0n 0.5362 8999.5n 0.5362 9000.0n 0.5018 9599.5n 0.5018 9600.0n 0.4869 10199.5n 0.4869 10200.0n 0.4614 10799.5n 0.4614 10800.0n 0.5408 11399.5n 0.5408 11400.0n 0.5050 11999.5n 0.5050 12000.0n 0.5441 12599.5n 0.5441 12600.0n 0.4838 13199.5n 0.4838 13200.0n 0.4962 13799.5n 0.4962 13800.0n 0.4667 14399.5n 0.4667 14400.0n 0.5009 14999.5n 0.5009 15000.0n 0.4702 15599.5n 0.4702 15600.0n 0.5177 16199.5n 0.5177 16200.0n 0.4761 16799.5n 0.4761 16800.0n 0.5408 17399.5n 0.5408 17400.0n 0.4906 17999.5n 0.4906 18000.0n 0.5663 18599.5n 0.5663 18600.0n 0.4023 19199.5n 0.4023 19200.0n 0.4636 19799.5n 0.4636 19800.0n 0.3878 20399.5n 0.3878 20400.0n 0.5144 20999.5n 0.5144 21000.0n 0.6139 21599.5n 0.6139 21600.0n 0.3906 22199.5n 0.3906 22200.0n 0.3636 22799.5n 0.3636 22800.0n 0.5193 23399.5n 0.5193 23400.0n 0.4386 23999.5n 0.4386 24000.0n 0.4087 24599.5n 0.4087 24600.0n 0.3705 25199.5n 0.3705 25200.0n 0.5504 25799.5n 0.5504 25800.0n 0.6208 26399.5n 0.6208 26400.0n 0.5566 26999.5n 0.5566 27000.0n 0.5660 27599.5n 0.5660 27600.0n 0.5539 28199.5n 0.5539 28200.0n 0.4209 28799.5n 0.4209 28800.0n 0.5223 29399.5n 0.5223 29400.0n 0.6122 29999.5n 0.6122 30000.0n 0.6168 30599.5n 0.6168 30600.0n 0.5978 31199.5n 0.5978 31200.0n 0.5518 31799.5n 0.5518 31800.0n 0.6338 32399.5n 0.6338 32400.0n 0.6143 32999.5n 0.6143 33000.0n 0.4416 33599.5n 0.4416 33600.0n 0.4716 34199.5n 0.4716 34200.0n 0.3966 34799.5n 0.3966 34800.0n 0.6531 35399.5n 0.6531 35400.0n 0.4710 35999.5n 0.4710)
Vyp_wih_0_8 yp_wih_0_8 0 PWL(0.0n 0.4173 599.5n 0.4173 600.0n 0.5111 1199.5n 0.5111 1200.0n 0.4589 1799.5n 0.4589 1800.0n 0.5617 2399.5n 0.5617 2400.0n 0.5516 2999.5n 0.5516 3000.0n 0.4737 3599.5n 0.4737 3600.0n 0.4429 4199.5n 0.4429 4200.0n 0.4089 4799.5n 0.4089 4800.0n 0.4591 5399.5n 0.4591 5400.0n 0.4614 5999.5n 0.4614 6000.0n 0.4744 6599.5n 0.4744 6600.0n 0.4406 7199.5n 0.4406 7200.0n 0.5181 7799.5n 0.5181 7800.0n 0.5271 8399.5n 0.5271 8400.0n 0.3967 8999.5n 0.3967 9000.0n 0.4603 9599.5n 0.4603 9600.0n 0.4865 10199.5n 0.4865 10200.0n 0.5191 10799.5n 0.5191 10800.0n 0.4418 11399.5n 0.4418 11400.0n 0.4523 11999.5n 0.4523 12000.0n 0.3800 12599.5n 0.3800 12600.0n 0.4920 13199.5n 0.4920 13200.0n 0.4239 13799.5n 0.4239 13800.0n 0.4727 14399.5n 0.4727 14400.0n 0.4536 14999.5n 0.4536 15000.0n 0.5239 15599.5n 0.5239 15600.0n 0.4175 16199.5n 0.4175 16200.0n 0.4437 16799.5n 0.4437 16800.0n 0.3939 17399.5n 0.3939 17400.0n 0.4340 17999.5n 0.4340 18000.0n 0.4925 18599.5n 0.4925 18600.0n 0.5719 19199.5n 0.5719 19200.0n 0.6283 19799.5n 0.6283 19800.0n 0.6599 20399.5n 0.6599 20400.0n 0.5895 20999.5n 0.5895 21000.0n 0.3725 21599.5n 0.3725 21600.0n 0.6441 22199.5n 0.6441 22200.0n 0.5979 22799.5n 0.5979 22800.0n 0.6059 23399.5n 0.6059 23400.0n 0.3876 23999.5n 0.3876 24000.0n 0.6660 24599.5n 0.6660 24600.0n 0.5727 25199.5n 0.5727 25200.0n 0.5414 25799.5n 0.5414 25800.0n 0.4757 26399.5n 0.4757 26400.0n 0.5545 26999.5n 0.5545 27000.0n 0.5111 27599.5n 0.5111 27600.0n 0.5595 28199.5n 0.5595 28200.0n 0.4361 28799.5n 0.4361 28800.0n 0.5917 29399.5n 0.5917 29400.0n 0.3583 29999.5n 0.3583 30000.0n 0.3456 30599.5n 0.3456 30600.0n 0.3216 31199.5n 0.3216 31200.0n 0.3333 31799.5n 0.3333 31800.0n 0.4590 32399.5n 0.4590 32400.0n 0.4816 32999.5n 0.4816 33000.0n 0.6542 33599.5n 0.6542 33600.0n 0.6396 34199.5n 0.6396 34200.0n 0.5367 34799.5n 0.5367 34800.0n 0.3315 35399.5n 0.3315 35400.0n 0.6274 35999.5n 0.6274)
Vyn_wih_0_8 yn_wih_0_8 0 PWL(0.0n 0.5827 599.5n 0.5827 600.0n 0.4889 1199.5n 0.4889 1200.0n 0.5411 1799.5n 0.5411 1800.0n 0.4383 2399.5n 0.4383 2400.0n 0.4484 2999.5n 0.4484 3000.0n 0.5263 3599.5n 0.5263 3600.0n 0.5571 4199.5n 0.5571 4200.0n 0.5911 4799.5n 0.5911 4800.0n 0.5409 5399.5n 0.5409 5400.0n 0.5386 5999.5n 0.5386 6000.0n 0.5256 6599.5n 0.5256 6600.0n 0.5594 7199.5n 0.5594 7200.0n 0.4819 7799.5n 0.4819 7800.0n 0.4729 8399.5n 0.4729 8400.0n 0.6033 8999.5n 0.6033 9000.0n 0.5397 9599.5n 0.5397 9600.0n 0.5135 10199.5n 0.5135 10200.0n 0.4809 10799.5n 0.4809 10800.0n 0.5582 11399.5n 0.5582 11400.0n 0.5477 11999.5n 0.5477 12000.0n 0.6200 12599.5n 0.6200 12600.0n 0.5080 13199.5n 0.5080 13200.0n 0.5761 13799.5n 0.5761 13800.0n 0.5273 14399.5n 0.5273 14400.0n 0.5464 14999.5n 0.5464 15000.0n 0.4761 15599.5n 0.4761 15600.0n 0.5825 16199.5n 0.5825 16200.0n 0.5563 16799.5n 0.5563 16800.0n 0.6061 17399.5n 0.6061 17400.0n 0.5660 17999.5n 0.5660 18000.0n 0.5075 18599.5n 0.5075 18600.0n 0.4281 19199.5n 0.4281 19200.0n 0.3717 19799.5n 0.3717 19800.0n 0.3401 20399.5n 0.3401 20400.0n 0.4105 20999.5n 0.4105 21000.0n 0.6275 21599.5n 0.6275 21600.0n 0.3559 22199.5n 0.3559 22200.0n 0.4021 22799.5n 0.4021 22800.0n 0.3941 23399.5n 0.3941 23400.0n 0.6124 23999.5n 0.6124 24000.0n 0.3340 24599.5n 0.3340 24600.0n 0.4273 25199.5n 0.4273 25200.0n 0.4586 25799.5n 0.4586 25800.0n 0.5243 26399.5n 0.5243 26400.0n 0.4455 26999.5n 0.4455 27000.0n 0.4889 27599.5n 0.4889 27600.0n 0.4405 28199.5n 0.4405 28200.0n 0.5639 28799.5n 0.5639 28800.0n 0.4083 29399.5n 0.4083 29400.0n 0.6417 29999.5n 0.6417 30000.0n 0.6544 30599.5n 0.6544 30600.0n 0.6784 31199.5n 0.6784 31200.0n 0.6667 31799.5n 0.6667 31800.0n 0.5410 32399.5n 0.5410 32400.0n 0.5184 32999.5n 0.5184 33000.0n 0.3458 33599.5n 0.3458 33600.0n 0.3604 34199.5n 0.3604 34200.0n 0.4633 34799.5n 0.4633 34800.0n 0.6685 35399.5n 0.6685 35400.0n 0.3726 35999.5n 0.3726)
Cwp_wih_0_8 wp_wih_0_8 0 400p
Cwn_wih_0_8 wn_wih_0_8 0 400p
Xu_wih_0_8 xp_wih_0_8 xn_wih_0_8 yp_wih_0_8 yn_wih_0_8 wp_wih_0_8 wn_wih_0_8 vdd gbn gprod
Vxp_wih_1_8 xp_wih_1_8 0 PWL(0.0n 0.5370 599.5n 0.5370 600.0n 0.5167 1199.5n 0.5167 1200.0n 0.4793 1799.5n 0.4793 1800.0n 0.4441 2399.5n 0.4441 2400.0n 0.4555 2999.5n 0.4555 3000.0n 0.5055 3599.5n 0.5055 3600.0n 0.4939 4199.5n 0.4939 4200.0n 0.5385 4799.5n 0.5385 4800.0n 0.5024 5399.5n 0.5024 5400.0n 0.5015 5999.5n 0.5015 6000.0n 0.4700 6599.5n 0.4700 6600.0n 0.5120 7199.5n 0.5120 7200.0n 0.5006 7799.5n 0.5006 7800.0n 0.4950 8399.5n 0.4950 8400.0n 0.5309 8999.5n 0.5309 9000.0n 0.5023 9599.5n 0.5023 9600.0n 0.4893 10199.5n 0.4893 10200.0n 0.4837 10799.5n 0.4837 10800.0n 0.4823 11399.5n 0.4823 11400.0n 0.5074 11999.5n 0.5074 12000.0n 0.5364 12599.5n 0.5364 12600.0n 0.4868 13199.5n 0.4868 13200.0n 0.5380 13799.5n 0.5380 13800.0n 0.5220 14399.5n 0.5220 14400.0n 0.5095 14999.5n 0.5095 15000.0n 0.4705 15599.5n 0.4705 15600.0n 0.5289 16199.5n 0.5289 16200.0n 0.5368 16799.5n 0.5368 16800.0n 0.5287 17399.5n 0.5287 17400.0n 0.5342 17999.5n 0.5342 18000.0n 0.4253 18599.5n 0.4253 18600.0n 0.5119 19199.5n 0.5119 19200.0n 0.4104 19799.5n 0.4104 19800.0n 0.4314 20399.5n 0.4314 20400.0n 0.4005 20999.5n 0.4005 21000.0n 0.4696 21599.5n 0.4696 21600.0n 0.4531 22199.5n 0.4531 22200.0n 0.5039 22799.5n 0.5039 22800.0n 0.3608 23399.5n 0.3608 23400.0n 0.6273 23999.5n 0.6273 24000.0n 0.3928 24599.5n 0.3928 24600.0n 0.5253 25199.5n 0.5253 25200.0n 0.4107 25799.5n 0.4107 25800.0n 0.3947 26399.5n 0.3947 26400.0n 0.3716 26999.5n 0.3716 27000.0n 0.4111 27599.5n 0.4111 27600.0n 0.3715 28199.5n 0.3715 28200.0n 0.5939 28799.5n 0.5939 28800.0n 0.3849 29399.5n 0.3849 29400.0n 0.4835 29999.5n 0.4835 30000.0n 0.5119 30599.5n 0.5119 30600.0n 0.6226 31199.5n 0.6226 31200.0n 0.6064 31799.5n 0.6064 31800.0n 0.4115 32399.5n 0.4115 32400.0n 0.3900 32999.5n 0.3900 33000.0n 0.3958 33599.5n 0.3958 33600.0n 0.3747 34199.5n 0.3747 34200.0n 0.5423 34799.5n 0.5423 34800.0n 0.5509 35399.5n 0.5509 35400.0n 0.3990 35999.5n 0.3990)
Vxn_wih_1_8 xn_wih_1_8 0 PWL(0.0n 0.4630 599.5n 0.4630 600.0n 0.4833 1199.5n 0.4833 1200.0n 0.5207 1799.5n 0.5207 1800.0n 0.5559 2399.5n 0.5559 2400.0n 0.5445 2999.5n 0.5445 3000.0n 0.4945 3599.5n 0.4945 3600.0n 0.5061 4199.5n 0.5061 4200.0n 0.4615 4799.5n 0.4615 4800.0n 0.4976 5399.5n 0.4976 5400.0n 0.4985 5999.5n 0.4985 6000.0n 0.5300 6599.5n 0.5300 6600.0n 0.4880 7199.5n 0.4880 7200.0n 0.4994 7799.5n 0.4994 7800.0n 0.5050 8399.5n 0.5050 8400.0n 0.4691 8999.5n 0.4691 9000.0n 0.4977 9599.5n 0.4977 9600.0n 0.5107 10199.5n 0.5107 10200.0n 0.5163 10799.5n 0.5163 10800.0n 0.5177 11399.5n 0.5177 11400.0n 0.4926 11999.5n 0.4926 12000.0n 0.4636 12599.5n 0.4636 12600.0n 0.5132 13199.5n 0.5132 13200.0n 0.4620 13799.5n 0.4620 13800.0n 0.4780 14399.5n 0.4780 14400.0n 0.4905 14999.5n 0.4905 15000.0n 0.5295 15599.5n 0.5295 15600.0n 0.4711 16199.5n 0.4711 16200.0n 0.4632 16799.5n 0.4632 16800.0n 0.4713 17399.5n 0.4713 17400.0n 0.4658 17999.5n 0.4658 18000.0n 0.5747 18599.5n 0.5747 18600.0n 0.4881 19199.5n 0.4881 19200.0n 0.5896 19799.5n 0.5896 19800.0n 0.5686 20399.5n 0.5686 20400.0n 0.5995 20999.5n 0.5995 21000.0n 0.5304 21599.5n 0.5304 21600.0n 0.5469 22199.5n 0.5469 22200.0n 0.4961 22799.5n 0.4961 22800.0n 0.6392 23399.5n 0.6392 23400.0n 0.3727 23999.5n 0.3727 24000.0n 0.6072 24599.5n 0.6072 24600.0n 0.4747 25199.5n 0.4747 25200.0n 0.5893 25799.5n 0.5893 25800.0n 0.6053 26399.5n 0.6053 26400.0n 0.6284 26999.5n 0.6284 27000.0n 0.5889 27599.5n 0.5889 27600.0n 0.6285 28199.5n 0.6285 28200.0n 0.4061 28799.5n 0.4061 28800.0n 0.6151 29399.5n 0.6151 29400.0n 0.5165 29999.5n 0.5165 30000.0n 0.4881 30599.5n 0.4881 30600.0n 0.3774 31199.5n 0.3774 31200.0n 0.3936 31799.5n 0.3936 31800.0n 0.5885 32399.5n 0.5885 32400.0n 0.6100 32999.5n 0.6100 33000.0n 0.6042 33599.5n 0.6042 33600.0n 0.6253 34199.5n 0.6253 34200.0n 0.4577 34799.5n 0.4577 34800.0n 0.4491 35399.5n 0.4491 35400.0n 0.6010 35999.5n 0.6010)
Vyp_wih_1_8 yp_wih_1_8 0 PWL(0.0n 0.4173 599.5n 0.4173 600.0n 0.5111 1199.5n 0.5111 1200.0n 0.4589 1799.5n 0.4589 1800.0n 0.5617 2399.5n 0.5617 2400.0n 0.5516 2999.5n 0.5516 3000.0n 0.4737 3599.5n 0.4737 3600.0n 0.4429 4199.5n 0.4429 4200.0n 0.4089 4799.5n 0.4089 4800.0n 0.4591 5399.5n 0.4591 5400.0n 0.4614 5999.5n 0.4614 6000.0n 0.4744 6599.5n 0.4744 6600.0n 0.4406 7199.5n 0.4406 7200.0n 0.5181 7799.5n 0.5181 7800.0n 0.5271 8399.5n 0.5271 8400.0n 0.3967 8999.5n 0.3967 9000.0n 0.4603 9599.5n 0.4603 9600.0n 0.4865 10199.5n 0.4865 10200.0n 0.5191 10799.5n 0.5191 10800.0n 0.4418 11399.5n 0.4418 11400.0n 0.4523 11999.5n 0.4523 12000.0n 0.3800 12599.5n 0.3800 12600.0n 0.4920 13199.5n 0.4920 13200.0n 0.4239 13799.5n 0.4239 13800.0n 0.4727 14399.5n 0.4727 14400.0n 0.4536 14999.5n 0.4536 15000.0n 0.5239 15599.5n 0.5239 15600.0n 0.4175 16199.5n 0.4175 16200.0n 0.4437 16799.5n 0.4437 16800.0n 0.3939 17399.5n 0.3939 17400.0n 0.4340 17999.5n 0.4340 18000.0n 0.4925 18599.5n 0.4925 18600.0n 0.5719 19199.5n 0.5719 19200.0n 0.6283 19799.5n 0.6283 19800.0n 0.6599 20399.5n 0.6599 20400.0n 0.5895 20999.5n 0.5895 21000.0n 0.3725 21599.5n 0.3725 21600.0n 0.6441 22199.5n 0.6441 22200.0n 0.5979 22799.5n 0.5979 22800.0n 0.6059 23399.5n 0.6059 23400.0n 0.3876 23999.5n 0.3876 24000.0n 0.6660 24599.5n 0.6660 24600.0n 0.5727 25199.5n 0.5727 25200.0n 0.5414 25799.5n 0.5414 25800.0n 0.4757 26399.5n 0.4757 26400.0n 0.5545 26999.5n 0.5545 27000.0n 0.5111 27599.5n 0.5111 27600.0n 0.5595 28199.5n 0.5595 28200.0n 0.4361 28799.5n 0.4361 28800.0n 0.5917 29399.5n 0.5917 29400.0n 0.3583 29999.5n 0.3583 30000.0n 0.3456 30599.5n 0.3456 30600.0n 0.3216 31199.5n 0.3216 31200.0n 0.3333 31799.5n 0.3333 31800.0n 0.4590 32399.5n 0.4590 32400.0n 0.4816 32999.5n 0.4816 33000.0n 0.6542 33599.5n 0.6542 33600.0n 0.6396 34199.5n 0.6396 34200.0n 0.5367 34799.5n 0.5367 34800.0n 0.3315 35399.5n 0.3315 35400.0n 0.6274 35999.5n 0.6274)
Vyn_wih_1_8 yn_wih_1_8 0 PWL(0.0n 0.5827 599.5n 0.5827 600.0n 0.4889 1199.5n 0.4889 1200.0n 0.5411 1799.5n 0.5411 1800.0n 0.4383 2399.5n 0.4383 2400.0n 0.4484 2999.5n 0.4484 3000.0n 0.5263 3599.5n 0.5263 3600.0n 0.5571 4199.5n 0.5571 4200.0n 0.5911 4799.5n 0.5911 4800.0n 0.5409 5399.5n 0.5409 5400.0n 0.5386 5999.5n 0.5386 6000.0n 0.5256 6599.5n 0.5256 6600.0n 0.5594 7199.5n 0.5594 7200.0n 0.4819 7799.5n 0.4819 7800.0n 0.4729 8399.5n 0.4729 8400.0n 0.6033 8999.5n 0.6033 9000.0n 0.5397 9599.5n 0.5397 9600.0n 0.5135 10199.5n 0.5135 10200.0n 0.4809 10799.5n 0.4809 10800.0n 0.5582 11399.5n 0.5582 11400.0n 0.5477 11999.5n 0.5477 12000.0n 0.6200 12599.5n 0.6200 12600.0n 0.5080 13199.5n 0.5080 13200.0n 0.5761 13799.5n 0.5761 13800.0n 0.5273 14399.5n 0.5273 14400.0n 0.5464 14999.5n 0.5464 15000.0n 0.4761 15599.5n 0.4761 15600.0n 0.5825 16199.5n 0.5825 16200.0n 0.5563 16799.5n 0.5563 16800.0n 0.6061 17399.5n 0.6061 17400.0n 0.5660 17999.5n 0.5660 18000.0n 0.5075 18599.5n 0.5075 18600.0n 0.4281 19199.5n 0.4281 19200.0n 0.3717 19799.5n 0.3717 19800.0n 0.3401 20399.5n 0.3401 20400.0n 0.4105 20999.5n 0.4105 21000.0n 0.6275 21599.5n 0.6275 21600.0n 0.3559 22199.5n 0.3559 22200.0n 0.4021 22799.5n 0.4021 22800.0n 0.3941 23399.5n 0.3941 23400.0n 0.6124 23999.5n 0.6124 24000.0n 0.3340 24599.5n 0.3340 24600.0n 0.4273 25199.5n 0.4273 25200.0n 0.4586 25799.5n 0.4586 25800.0n 0.5243 26399.5n 0.5243 26400.0n 0.4455 26999.5n 0.4455 27000.0n 0.4889 27599.5n 0.4889 27600.0n 0.4405 28199.5n 0.4405 28200.0n 0.5639 28799.5n 0.5639 28800.0n 0.4083 29399.5n 0.4083 29400.0n 0.6417 29999.5n 0.6417 30000.0n 0.6544 30599.5n 0.6544 30600.0n 0.6784 31199.5n 0.6784 31200.0n 0.6667 31799.5n 0.6667 31800.0n 0.5410 32399.5n 0.5410 32400.0n 0.5184 32999.5n 0.5184 33000.0n 0.3458 33599.5n 0.3458 33600.0n 0.3604 34199.5n 0.3604 34200.0n 0.4633 34799.5n 0.4633 34800.0n 0.6685 35399.5n 0.6685 35400.0n 0.3726 35999.5n 0.3726)
Cwp_wih_1_8 wp_wih_1_8 0 400p
Cwn_wih_1_8 wn_wih_1_8 0 400p
Xu_wih_1_8 xp_wih_1_8 xn_wih_1_8 yp_wih_1_8 yn_wih_1_8 wp_wih_1_8 wn_wih_1_8 vdd gbn gprod
Vxp_who_8_0 xp_who_8_0 0 PWL(0.0n 0.4173 599.5n 0.4173 600.0n 0.5111 1199.5n 0.5111 1200.0n 0.4589 1799.5n 0.4589 1800.0n 0.5617 2399.5n 0.5617 2400.0n 0.5516 2999.5n 0.5516 3000.0n 0.4737 3599.5n 0.4737 3600.0n 0.4429 4199.5n 0.4429 4200.0n 0.4089 4799.5n 0.4089 4800.0n 0.4591 5399.5n 0.4591 5400.0n 0.4614 5999.5n 0.4614 6000.0n 0.4744 6599.5n 0.4744 6600.0n 0.4406 7199.5n 0.4406 7200.0n 0.5181 7799.5n 0.5181 7800.0n 0.5271 8399.5n 0.5271 8400.0n 0.3967 8999.5n 0.3967 9000.0n 0.4603 9599.5n 0.4603 9600.0n 0.4865 10199.5n 0.4865 10200.0n 0.5191 10799.5n 0.5191 10800.0n 0.4418 11399.5n 0.4418 11400.0n 0.4523 11999.5n 0.4523 12000.0n 0.3800 12599.5n 0.3800 12600.0n 0.4920 13199.5n 0.4920 13200.0n 0.4239 13799.5n 0.4239 13800.0n 0.4727 14399.5n 0.4727 14400.0n 0.4536 14999.5n 0.4536 15000.0n 0.5239 15599.5n 0.5239 15600.0n 0.4175 16199.5n 0.4175 16200.0n 0.4437 16799.5n 0.4437 16800.0n 0.3939 17399.5n 0.3939 17400.0n 0.4340 17999.5n 0.4340 18000.0n 0.4925 18599.5n 0.4925 18600.0n 0.5719 19199.5n 0.5719 19200.0n 0.6283 19799.5n 0.6283 19800.0n 0.6599 20399.5n 0.6599 20400.0n 0.5895 20999.5n 0.5895 21000.0n 0.3725 21599.5n 0.3725 21600.0n 0.6441 22199.5n 0.6441 22200.0n 0.5979 22799.5n 0.5979 22800.0n 0.6059 23399.5n 0.6059 23400.0n 0.3876 23999.5n 0.3876 24000.0n 0.6660 24599.5n 0.6660 24600.0n 0.5727 25199.5n 0.5727 25200.0n 0.5414 25799.5n 0.5414 25800.0n 0.4757 26399.5n 0.4757 26400.0n 0.5545 26999.5n 0.5545 27000.0n 0.5111 27599.5n 0.5111 27600.0n 0.5595 28199.5n 0.5595 28200.0n 0.4361 28799.5n 0.4361 28800.0n 0.5917 29399.5n 0.5917 29400.0n 0.3583 29999.5n 0.3583 30000.0n 0.3456 30599.5n 0.3456 30600.0n 0.3216 31199.5n 0.3216 31200.0n 0.3333 31799.5n 0.3333 31800.0n 0.4590 32399.5n 0.4590 32400.0n 0.4816 32999.5n 0.4816 33000.0n 0.6542 33599.5n 0.6542 33600.0n 0.6396 34199.5n 0.6396 34200.0n 0.5367 34799.5n 0.5367 34800.0n 0.3315 35399.5n 0.3315 35400.0n 0.6274 35999.5n 0.6274)
Vxn_who_8_0 xn_who_8_0 0 PWL(0.0n 0.5827 599.5n 0.5827 600.0n 0.4889 1199.5n 0.4889 1200.0n 0.5411 1799.5n 0.5411 1800.0n 0.4383 2399.5n 0.4383 2400.0n 0.4484 2999.5n 0.4484 3000.0n 0.5263 3599.5n 0.5263 3600.0n 0.5571 4199.5n 0.5571 4200.0n 0.5911 4799.5n 0.5911 4800.0n 0.5409 5399.5n 0.5409 5400.0n 0.5386 5999.5n 0.5386 6000.0n 0.5256 6599.5n 0.5256 6600.0n 0.5594 7199.5n 0.5594 7200.0n 0.4819 7799.5n 0.4819 7800.0n 0.4729 8399.5n 0.4729 8400.0n 0.6033 8999.5n 0.6033 9000.0n 0.5397 9599.5n 0.5397 9600.0n 0.5135 10199.5n 0.5135 10200.0n 0.4809 10799.5n 0.4809 10800.0n 0.5582 11399.5n 0.5582 11400.0n 0.5477 11999.5n 0.5477 12000.0n 0.6200 12599.5n 0.6200 12600.0n 0.5080 13199.5n 0.5080 13200.0n 0.5761 13799.5n 0.5761 13800.0n 0.5273 14399.5n 0.5273 14400.0n 0.5464 14999.5n 0.5464 15000.0n 0.4761 15599.5n 0.4761 15600.0n 0.5825 16199.5n 0.5825 16200.0n 0.5563 16799.5n 0.5563 16800.0n 0.6061 17399.5n 0.6061 17400.0n 0.5660 17999.5n 0.5660 18000.0n 0.5075 18599.5n 0.5075 18600.0n 0.4281 19199.5n 0.4281 19200.0n 0.3717 19799.5n 0.3717 19800.0n 0.3401 20399.5n 0.3401 20400.0n 0.4105 20999.5n 0.4105 21000.0n 0.6275 21599.5n 0.6275 21600.0n 0.3559 22199.5n 0.3559 22200.0n 0.4021 22799.5n 0.4021 22800.0n 0.3941 23399.5n 0.3941 23400.0n 0.6124 23999.5n 0.6124 24000.0n 0.3340 24599.5n 0.3340 24600.0n 0.4273 25199.5n 0.4273 25200.0n 0.4586 25799.5n 0.4586 25800.0n 0.5243 26399.5n 0.5243 26400.0n 0.4455 26999.5n 0.4455 27000.0n 0.4889 27599.5n 0.4889 27600.0n 0.4405 28199.5n 0.4405 28200.0n 0.5639 28799.5n 0.5639 28800.0n 0.4083 29399.5n 0.4083 29400.0n 0.6417 29999.5n 0.6417 30000.0n 0.6544 30599.5n 0.6544 30600.0n 0.6784 31199.5n 0.6784 31200.0n 0.6667 31799.5n 0.6667 31800.0n 0.5410 32399.5n 0.5410 32400.0n 0.5184 32999.5n 0.5184 33000.0n 0.3458 33599.5n 0.3458 33600.0n 0.3604 34199.5n 0.3604 34200.0n 0.4633 34799.5n 0.4633 34800.0n 0.6685 35399.5n 0.6685 35400.0n 0.3726 35999.5n 0.3726)
Vyp_who_8_0 yp_who_8_0 0 PWL(0.0n 0.5031 599.5n 0.5031 600.0n 0.5023 1199.5n 0.5023 1200.0n 0.5052 1799.5n 0.5052 1800.0n 0.5048 2399.5n 0.5048 2400.0n 0.5043 2999.5n 0.5043 3000.0n 0.5034 3599.5n 0.5034 3600.0n 0.5048 4199.5n 0.5048 4200.0n 0.5031 4799.5n 0.5031 4800.0n 0.5040 5399.5n 0.5040 5400.0n 0.5040 5999.5n 0.5040 6000.0n 0.5054 6599.5n 0.5054 6600.0n 0.5040 7199.5n 0.5040 7200.0n 0.5027 7799.5n 0.5027 7800.0n 0.5027 8399.5n 0.5027 8400.0n 0.5038 8999.5n 0.5038 9000.0n 0.5040 9599.5n 0.5040 9600.0n 0.5039 10199.5n 0.5039 10200.0n 0.5033 10799.5n 0.5033 10800.0n 0.5056 11399.5n 0.5056 11400.0n 0.5040 11999.5n 0.5040 12000.0n 0.5036 12599.5n 0.5036 12600.0n 0.5039 13199.5n 0.5039 13200.0n 0.5029 13799.5n 0.5029 13800.0n 0.5025 14399.5n 0.5025 14400.0n 0.5038 14999.5n 0.5038 15000.0n 0.5041 15599.5n 0.5041 15600.0n 0.5036 16199.5n 0.5036 16200.0n 0.5025 16799.5n 0.5025 16800.0n 0.5040 17399.5n 0.5040 17400.0n 0.5029 17999.5n 0.5029 18000.0n 0.5057 18599.5n 0.5057 18600.0n 0.5010 19199.5n 0.5010 19200.0n 0.5041 19799.5n 0.5041 19800.0n 0.5021 20399.5n 0.5021 20400.0n 0.5044 20999.5n 0.5044 21000.0n 0.5056 21599.5n 0.5056 21600.0n 0.5016 22199.5n 0.5016 22200.0n 0.5006 22799.5n 0.5006 22800.0n 0.5041 23399.5n 0.5041 23400.0n 0.5027 23999.5n 0.5027 24000.0n 0.5029 24599.5n 0.5029 24600.0n 0.5006 25199.5n 0.5006 25200.0n 0.5047 25799.5n 0.5047 25800.0n 0.5046 26399.5n 0.5046 26400.0n 0.5039 26999.5n 0.5039 27000.0n 0.5049 27599.5n 0.5049 27600.0n 0.5039 28199.5n 0.5039 28200.0n 0.5017 28799.5n 0.5017 28800.0n 0.5042 29399.5n 0.5042 29400.0n 0.5056 29999.5n 0.5056 30000.0n 0.5051 30599.5n 0.5051 30600.0n 0.5039 31199.5n 0.5039 31200.0n 0.5033 31799.5n 0.5033 31800.0n 0.5049 32399.5n 0.5049 32400.0n 0.5045 32999.5n 0.5045 33000.0n 0.5036 33599.5n 0.5036 33600.0n 0.5042 34199.5n 0.5042 34200.0n 0.5012 34799.5n 0.5012 34800.0n 0.5036 35399.5n 0.5036 35400.0n 0.5042 35999.5n 0.5042)
Vyn_who_8_0 yn_who_8_0 0 PWL(0.0n 0.4969 599.5n 0.4969 600.0n 0.4977 1199.5n 0.4977 1200.0n 0.4948 1799.5n 0.4948 1800.0n 0.4952 2399.5n 0.4952 2400.0n 0.4957 2999.5n 0.4957 3000.0n 0.4966 3599.5n 0.4966 3600.0n 0.4952 4199.5n 0.4952 4200.0n 0.4969 4799.5n 0.4969 4800.0n 0.4960 5399.5n 0.4960 5400.0n 0.4960 5999.5n 0.4960 6000.0n 0.4946 6599.5n 0.4946 6600.0n 0.4960 7199.5n 0.4960 7200.0n 0.4973 7799.5n 0.4973 7800.0n 0.4973 8399.5n 0.4973 8400.0n 0.4962 8999.5n 0.4962 9000.0n 0.4960 9599.5n 0.4960 9600.0n 0.4961 10199.5n 0.4961 10200.0n 0.4967 10799.5n 0.4967 10800.0n 0.4944 11399.5n 0.4944 11400.0n 0.4960 11999.5n 0.4960 12000.0n 0.4964 12599.5n 0.4964 12600.0n 0.4961 13199.5n 0.4961 13200.0n 0.4971 13799.5n 0.4971 13800.0n 0.4975 14399.5n 0.4975 14400.0n 0.4962 14999.5n 0.4962 15000.0n 0.4959 15599.5n 0.4959 15600.0n 0.4964 16199.5n 0.4964 16200.0n 0.4975 16799.5n 0.4975 16800.0n 0.4960 17399.5n 0.4960 17400.0n 0.4971 17999.5n 0.4971 18000.0n 0.4943 18599.5n 0.4943 18600.0n 0.4990 19199.5n 0.4990 19200.0n 0.4959 19799.5n 0.4959 19800.0n 0.4979 20399.5n 0.4979 20400.0n 0.4956 20999.5n 0.4956 21000.0n 0.4944 21599.5n 0.4944 21600.0n 0.4984 22199.5n 0.4984 22200.0n 0.4994 22799.5n 0.4994 22800.0n 0.4959 23399.5n 0.4959 23400.0n 0.4973 23999.5n 0.4973 24000.0n 0.4971 24599.5n 0.4971 24600.0n 0.4994 25199.5n 0.4994 25200.0n 0.4953 25799.5n 0.4953 25800.0n 0.4954 26399.5n 0.4954 26400.0n 0.4961 26999.5n 0.4961 27000.0n 0.4951 27599.5n 0.4951 27600.0n 0.4961 28199.5n 0.4961 28200.0n 0.4983 28799.5n 0.4983 28800.0n 0.4958 29399.5n 0.4958 29400.0n 0.4944 29999.5n 0.4944 30000.0n 0.4949 30599.5n 0.4949 30600.0n 0.4961 31199.5n 0.4961 31200.0n 0.4967 31799.5n 0.4967 31800.0n 0.4951 32399.5n 0.4951 32400.0n 0.4955 32999.5n 0.4955 33000.0n 0.4964 33599.5n 0.4964 33600.0n 0.4958 34199.5n 0.4958 34200.0n 0.4988 34799.5n 0.4988 34800.0n 0.4964 35399.5n 0.4964 35400.0n 0.4958 35999.5n 0.4958)
Cwp_who_8_0 wp_who_8_0 0 400p
Cwn_who_8_0 wn_who_8_0 0 400p
Xu_who_8_0 xp_who_8_0 xn_who_8_0 yp_who_8_0 yn_who_8_0 wp_who_8_0 wn_who_8_0 vdd gbn gprod
Vxp_who_8_1 xp_who_8_1 0 PWL(0.0n 0.4173 599.5n 0.4173 600.0n 0.5111 1199.5n 0.5111 1200.0n 0.4589 1799.5n 0.4589 1800.0n 0.5617 2399.5n 0.5617 2400.0n 0.5516 2999.5n 0.5516 3000.0n 0.4737 3599.5n 0.4737 3600.0n 0.4429 4199.5n 0.4429 4200.0n 0.4089 4799.5n 0.4089 4800.0n 0.4591 5399.5n 0.4591 5400.0n 0.4614 5999.5n 0.4614 6000.0n 0.4744 6599.5n 0.4744 6600.0n 0.4406 7199.5n 0.4406 7200.0n 0.5181 7799.5n 0.5181 7800.0n 0.5271 8399.5n 0.5271 8400.0n 0.3967 8999.5n 0.3967 9000.0n 0.4603 9599.5n 0.4603 9600.0n 0.4865 10199.5n 0.4865 10200.0n 0.5191 10799.5n 0.5191 10800.0n 0.4418 11399.5n 0.4418 11400.0n 0.4523 11999.5n 0.4523 12000.0n 0.3800 12599.5n 0.3800 12600.0n 0.4920 13199.5n 0.4920 13200.0n 0.4239 13799.5n 0.4239 13800.0n 0.4727 14399.5n 0.4727 14400.0n 0.4536 14999.5n 0.4536 15000.0n 0.5239 15599.5n 0.5239 15600.0n 0.4175 16199.5n 0.4175 16200.0n 0.4437 16799.5n 0.4437 16800.0n 0.3939 17399.5n 0.3939 17400.0n 0.4340 17999.5n 0.4340 18000.0n 0.4925 18599.5n 0.4925 18600.0n 0.5719 19199.5n 0.5719 19200.0n 0.6283 19799.5n 0.6283 19800.0n 0.6599 20399.5n 0.6599 20400.0n 0.5895 20999.5n 0.5895 21000.0n 0.3725 21599.5n 0.3725 21600.0n 0.6441 22199.5n 0.6441 22200.0n 0.5979 22799.5n 0.5979 22800.0n 0.6059 23399.5n 0.6059 23400.0n 0.3876 23999.5n 0.3876 24000.0n 0.6660 24599.5n 0.6660 24600.0n 0.5727 25199.5n 0.5727 25200.0n 0.5414 25799.5n 0.5414 25800.0n 0.4757 26399.5n 0.4757 26400.0n 0.5545 26999.5n 0.5545 27000.0n 0.5111 27599.5n 0.5111 27600.0n 0.5595 28199.5n 0.5595 28200.0n 0.4361 28799.5n 0.4361 28800.0n 0.5917 29399.5n 0.5917 29400.0n 0.3583 29999.5n 0.3583 30000.0n 0.3456 30599.5n 0.3456 30600.0n 0.3216 31199.5n 0.3216 31200.0n 0.3333 31799.5n 0.3333 31800.0n 0.4590 32399.5n 0.4590 32400.0n 0.4816 32999.5n 0.4816 33000.0n 0.6542 33599.5n 0.6542 33600.0n 0.6396 34199.5n 0.6396 34200.0n 0.5367 34799.5n 0.5367 34800.0n 0.3315 35399.5n 0.3315 35400.0n 0.6274 35999.5n 0.6274)
Vxn_who_8_1 xn_who_8_1 0 PWL(0.0n 0.5827 599.5n 0.5827 600.0n 0.4889 1199.5n 0.4889 1200.0n 0.5411 1799.5n 0.5411 1800.0n 0.4383 2399.5n 0.4383 2400.0n 0.4484 2999.5n 0.4484 3000.0n 0.5263 3599.5n 0.5263 3600.0n 0.5571 4199.5n 0.5571 4200.0n 0.5911 4799.5n 0.5911 4800.0n 0.5409 5399.5n 0.5409 5400.0n 0.5386 5999.5n 0.5386 6000.0n 0.5256 6599.5n 0.5256 6600.0n 0.5594 7199.5n 0.5594 7200.0n 0.4819 7799.5n 0.4819 7800.0n 0.4729 8399.5n 0.4729 8400.0n 0.6033 8999.5n 0.6033 9000.0n 0.5397 9599.5n 0.5397 9600.0n 0.5135 10199.5n 0.5135 10200.0n 0.4809 10799.5n 0.4809 10800.0n 0.5582 11399.5n 0.5582 11400.0n 0.5477 11999.5n 0.5477 12000.0n 0.6200 12599.5n 0.6200 12600.0n 0.5080 13199.5n 0.5080 13200.0n 0.5761 13799.5n 0.5761 13800.0n 0.5273 14399.5n 0.5273 14400.0n 0.5464 14999.5n 0.5464 15000.0n 0.4761 15599.5n 0.4761 15600.0n 0.5825 16199.5n 0.5825 16200.0n 0.5563 16799.5n 0.5563 16800.0n 0.6061 17399.5n 0.6061 17400.0n 0.5660 17999.5n 0.5660 18000.0n 0.5075 18599.5n 0.5075 18600.0n 0.4281 19199.5n 0.4281 19200.0n 0.3717 19799.5n 0.3717 19800.0n 0.3401 20399.5n 0.3401 20400.0n 0.4105 20999.5n 0.4105 21000.0n 0.6275 21599.5n 0.6275 21600.0n 0.3559 22199.5n 0.3559 22200.0n 0.4021 22799.5n 0.4021 22800.0n 0.3941 23399.5n 0.3941 23400.0n 0.6124 23999.5n 0.6124 24000.0n 0.3340 24599.5n 0.3340 24600.0n 0.4273 25199.5n 0.4273 25200.0n 0.4586 25799.5n 0.4586 25800.0n 0.5243 26399.5n 0.5243 26400.0n 0.4455 26999.5n 0.4455 27000.0n 0.4889 27599.5n 0.4889 27600.0n 0.4405 28199.5n 0.4405 28200.0n 0.5639 28799.5n 0.5639 28800.0n 0.4083 29399.5n 0.4083 29400.0n 0.6417 29999.5n 0.6417 30000.0n 0.6544 30599.5n 0.6544 30600.0n 0.6784 31199.5n 0.6784 31200.0n 0.6667 31799.5n 0.6667 31800.0n 0.5410 32399.5n 0.5410 32400.0n 0.5184 32999.5n 0.5184 33000.0n 0.3458 33599.5n 0.3458 33600.0n 0.3604 34199.5n 0.3604 34200.0n 0.4633 34799.5n 0.4633 34800.0n 0.6685 35399.5n 0.6685 35400.0n 0.3726 35999.5n 0.3726)
Vyp_who_8_1 yp_who_8_1 0 PWL(0.0n 0.5071 599.5n 0.5071 600.0n 0.5053 1199.5n 0.5053 1200.0n 0.5052 1799.5n 0.5052 1800.0n 0.5027 2399.5n 0.5027 2400.0n 0.5034 2999.5n 0.5034 3000.0n 0.5055 3599.5n 0.5055 3600.0n 0.5056 4199.5n 0.5056 4200.0n 0.5071 4799.5n 0.5071 4800.0n 0.5056 5399.5n 0.5056 5400.0n 0.5056 5999.5n 0.5056 6000.0n 0.5048 6599.5n 0.5048 6600.0n 0.5060 7199.5n 0.5060 7200.0n 0.5048 7799.5n 0.5048 7800.0n 0.5046 8399.5n 0.5046 8400.0n 0.5066 8999.5n 0.5066 9000.0n 0.5056 9599.5n 0.5056 9600.0n 0.5051 10199.5n 0.5051 10200.0n 0.5046 10799.5n 0.5046 10800.0n 0.5056 11399.5n 0.5056 11400.0n 0.5058 11999.5n 0.5058 12000.0n 0.5068 12599.5n 0.5068 12600.0n 0.5050 13199.5n 0.5050 13200.0n 0.5071 13799.5n 0.5071 13800.0n 0.5059 14399.5n 0.5059 14400.0n 0.5058 14999.5n 0.5058 15000.0n 0.5043 15599.5n 0.5043 15600.0n 0.5067 16199.5n 0.5067 16200.0n 0.5068 16799.5n 0.5068 16800.0n 0.5066 17399.5n 0.5066 17400.0n 0.5069 17999.5n 0.5069 18000.0n 0.5061 18599.5n 0.5061 18600.0n 0.5034 19199.5n 0.5034 19200.0n 0.5010 19799.5n 0.5010 19800.0n 0.4989 20399.5n 0.4989 20400.0n 0.5022 20999.5n 0.5022 21000.0n 0.5086 21599.5n 0.5086 21600.0n 0.5007 22199.5n 0.5007 22200.0n 0.5023 22799.5n 0.5023 22800.0n 0.5021 23399.5n 0.5021 23400.0n 0.5077 23999.5n 0.5077 24000.0n 0.4979 24599.5n 0.4979 24600.0n 0.5035 25199.5n 0.5035 25200.0n 0.5041 25799.5n 0.5041 25800.0n 0.5075 26399.5n 0.5075 26400.0n 0.5041 26999.5n 0.5041 27000.0n 0.5056 27599.5n 0.5056 27600.0n 0.5039 28199.5n 0.5039 28200.0n 0.5059 28799.5n 0.5059 28800.0n 0.5023 29399.5n 0.5023 29400.0n 0.5086 29999.5n 0.5086 30000.0n 0.5084 30599.5n 0.5084 30600.0n 0.5085 31199.5n 0.5085 31200.0n 0.5088 31799.5n 0.5088 31800.0n 0.5078 32399.5n 0.5078 32400.0n 0.5074 32999.5n 0.5074 33000.0n 0.4996 33599.5n 0.4996 33600.0n 0.5010 34199.5n 0.5010 34200.0n 0.5044 34799.5n 0.5044 34800.0n 0.5084 35399.5n 0.5084 35400.0n 0.5012 35999.5n 0.5012)
Vyn_who_8_1 yn_who_8_1 0 PWL(0.0n 0.4929 599.5n 0.4929 600.0n 0.4947 1199.5n 0.4947 1200.0n 0.4948 1799.5n 0.4948 1800.0n 0.4973 2399.5n 0.4973 2400.0n 0.4966 2999.5n 0.4966 3000.0n 0.4945 3599.5n 0.4945 3600.0n 0.4944 4199.5n 0.4944 4200.0n 0.4929 4799.5n 0.4929 4800.0n 0.4944 5399.5n 0.4944 5400.0n 0.4944 5999.5n 0.4944 6000.0n 0.4952 6599.5n 0.4952 6600.0n 0.4940 7199.5n 0.4940 7200.0n 0.4952 7799.5n 0.4952 7800.0n 0.4954 8399.5n 0.4954 8400.0n 0.4934 8999.5n 0.4934 9000.0n 0.4944 9599.5n 0.4944 9600.0n 0.4949 10199.5n 0.4949 10200.0n 0.4954 10799.5n 0.4954 10800.0n 0.4944 11399.5n 0.4944 11400.0n 0.4942 11999.5n 0.4942 12000.0n 0.4932 12599.5n 0.4932 12600.0n 0.4950 13199.5n 0.4950 13200.0n 0.4929 13799.5n 0.4929 13800.0n 0.4941 14399.5n 0.4941 14400.0n 0.4942 14999.5n 0.4942 15000.0n 0.4957 15599.5n 0.4957 15600.0n 0.4933 16199.5n 0.4933 16200.0n 0.4932 16799.5n 0.4932 16800.0n 0.4934 17399.5n 0.4934 17400.0n 0.4931 17999.5n 0.4931 18000.0n 0.4939 18599.5n 0.4939 18600.0n 0.4966 19199.5n 0.4966 19200.0n 0.4990 19799.5n 0.4990 19800.0n 0.5011 20399.5n 0.5011 20400.0n 0.4978 20999.5n 0.4978 21000.0n 0.4914 21599.5n 0.4914 21600.0n 0.4993 22199.5n 0.4993 22200.0n 0.4977 22799.5n 0.4977 22800.0n 0.4979 23399.5n 0.4979 23400.0n 0.4923 23999.5n 0.4923 24000.0n 0.5021 24599.5n 0.5021 24600.0n 0.4965 25199.5n 0.4965 25200.0n 0.4959 25799.5n 0.4959 25800.0n 0.4925 26399.5n 0.4925 26400.0n 0.4959 26999.5n 0.4959 27000.0n 0.4944 27599.5n 0.4944 27600.0n 0.4961 28199.5n 0.4961 28200.0n 0.4941 28799.5n 0.4941 28800.0n 0.4977 29399.5n 0.4977 29400.0n 0.4914 29999.5n 0.4914 30000.0n 0.4916 30599.5n 0.4916 30600.0n 0.4915 31199.5n 0.4915 31200.0n 0.4912 31799.5n 0.4912 31800.0n 0.4922 32399.5n 0.4922 32400.0n 0.4926 32999.5n 0.4926 33000.0n 0.5004 33599.5n 0.5004 33600.0n 0.4990 34199.5n 0.4990 34200.0n 0.4956 34799.5n 0.4956 34800.0n 0.4916 35399.5n 0.4916 35400.0n 0.4988 35999.5n 0.4988)
Cwp_who_8_1 wp_who_8_1 0 400p
Cwn_who_8_1 wn_who_8_1 0 400p
Xu_who_8_1 xp_who_8_1 xn_who_8_1 yp_who_8_1 yn_who_8_1 wp_who_8_1 wn_who_8_1 vdd gbn gprod
Vxp_bh_8 xp_bh_8 0 PWL(0.0n 0.7100 599.5n 0.7100 600.0n 0.7100 1199.5n 0.7100 1200.0n 0.7100 1799.5n 0.7100 1800.0n 0.7100 2399.5n 0.7100 2400.0n 0.7100 2999.5n 0.7100 3000.0n 0.7100 3599.5n 0.7100 3600.0n 0.7100 4199.5n 0.7100 4200.0n 0.7100 4799.5n 0.7100 4800.0n 0.7100 5399.5n 0.7100 5400.0n 0.7100 5999.5n 0.7100 6000.0n 0.7100 6599.5n 0.7100 6600.0n 0.7100 7199.5n 0.7100 7200.0n 0.7100 7799.5n 0.7100 7800.0n 0.7100 8399.5n 0.7100 8400.0n 0.7100 8999.5n 0.7100 9000.0n 0.7100 9599.5n 0.7100 9600.0n 0.7100 10199.5n 0.7100 10200.0n 0.7100 10799.5n 0.7100 10800.0n 0.7100 11399.5n 0.7100 11400.0n 0.7100 11999.5n 0.7100 12000.0n 0.7100 12599.5n 0.7100 12600.0n 0.7100 13199.5n 0.7100 13200.0n 0.7100 13799.5n 0.7100 13800.0n 0.7100 14399.5n 0.7100 14400.0n 0.7100 14999.5n 0.7100 15000.0n 0.7100 15599.5n 0.7100 15600.0n 0.7100 16199.5n 0.7100 16200.0n 0.7100 16799.5n 0.7100 16800.0n 0.7100 17399.5n 0.7100 17400.0n 0.7100 17999.5n 0.7100 18000.0n 0.7100 18599.5n 0.7100 18600.0n 0.7100 19199.5n 0.7100 19200.0n 0.7100 19799.5n 0.7100 19800.0n 0.7100 20399.5n 0.7100 20400.0n 0.7100 20999.5n 0.7100 21000.0n 0.7100 21599.5n 0.7100 21600.0n 0.7100 22199.5n 0.7100 22200.0n 0.7100 22799.5n 0.7100 22800.0n 0.7100 23399.5n 0.7100 23400.0n 0.7100 23999.5n 0.7100 24000.0n 0.7100 24599.5n 0.7100 24600.0n 0.7100 25199.5n 0.7100 25200.0n 0.7100 25799.5n 0.7100 25800.0n 0.7100 26399.5n 0.7100 26400.0n 0.7100 26999.5n 0.7100 27000.0n 0.7100 27599.5n 0.7100 27600.0n 0.7100 28199.5n 0.7100 28200.0n 0.7100 28799.5n 0.7100 28800.0n 0.7100 29399.5n 0.7100 29400.0n 0.7100 29999.5n 0.7100 30000.0n 0.7100 30599.5n 0.7100 30600.0n 0.7100 31199.5n 0.7100 31200.0n 0.7100 31799.5n 0.7100 31800.0n 0.7100 32399.5n 0.7100 32400.0n 0.7100 32999.5n 0.7100 33000.0n 0.7100 33599.5n 0.7100 33600.0n 0.7100 34199.5n 0.7100 34200.0n 0.7100 34799.5n 0.7100 34800.0n 0.7100 35399.5n 0.7100 35400.0n 0.7100 35999.5n 0.7100)
Vxn_bh_8 xn_bh_8 0 PWL(0.0n 0.2900 599.5n 0.2900 600.0n 0.2900 1199.5n 0.2900 1200.0n 0.2900 1799.5n 0.2900 1800.0n 0.2900 2399.5n 0.2900 2400.0n 0.2900 2999.5n 0.2900 3000.0n 0.2900 3599.5n 0.2900 3600.0n 0.2900 4199.5n 0.2900 4200.0n 0.2900 4799.5n 0.2900 4800.0n 0.2900 5399.5n 0.2900 5400.0n 0.2900 5999.5n 0.2900 6000.0n 0.2900 6599.5n 0.2900 6600.0n 0.2900 7199.5n 0.2900 7200.0n 0.2900 7799.5n 0.2900 7800.0n 0.2900 8399.5n 0.2900 8400.0n 0.2900 8999.5n 0.2900 9000.0n 0.2900 9599.5n 0.2900 9600.0n 0.2900 10199.5n 0.2900 10200.0n 0.2900 10799.5n 0.2900 10800.0n 0.2900 11399.5n 0.2900 11400.0n 0.2900 11999.5n 0.2900 12000.0n 0.2900 12599.5n 0.2900 12600.0n 0.2900 13199.5n 0.2900 13200.0n 0.2900 13799.5n 0.2900 13800.0n 0.2900 14399.5n 0.2900 14400.0n 0.2900 14999.5n 0.2900 15000.0n 0.2900 15599.5n 0.2900 15600.0n 0.2900 16199.5n 0.2900 16200.0n 0.2900 16799.5n 0.2900 16800.0n 0.2900 17399.5n 0.2900 17400.0n 0.2900 17999.5n 0.2900 18000.0n 0.2900 18599.5n 0.2900 18600.0n 0.2900 19199.5n 0.2900 19200.0n 0.2900 19799.5n 0.2900 19800.0n 0.2900 20399.5n 0.2900 20400.0n 0.2900 20999.5n 0.2900 21000.0n 0.2900 21599.5n 0.2900 21600.0n 0.2900 22199.5n 0.2900 22200.0n 0.2900 22799.5n 0.2900 22800.0n 0.2900 23399.5n 0.2900 23400.0n 0.2900 23999.5n 0.2900 24000.0n 0.2900 24599.5n 0.2900 24600.0n 0.2900 25199.5n 0.2900 25200.0n 0.2900 25799.5n 0.2900 25800.0n 0.2900 26399.5n 0.2900 26400.0n 0.2900 26999.5n 0.2900 27000.0n 0.2900 27599.5n 0.2900 27600.0n 0.2900 28199.5n 0.2900 28200.0n 0.2900 28799.5n 0.2900 28800.0n 0.2900 29399.5n 0.2900 29400.0n 0.2900 29999.5n 0.2900 30000.0n 0.2900 30599.5n 0.2900 30600.0n 0.2900 31199.5n 0.2900 31200.0n 0.2900 31799.5n 0.2900 31800.0n 0.2900 32399.5n 0.2900 32400.0n 0.2900 32999.5n 0.2900 33000.0n 0.2900 33599.5n 0.2900 33600.0n 0.2900 34199.5n 0.2900 34200.0n 0.2900 34799.5n 0.2900 34800.0n 0.2900 35399.5n 0.2900 35400.0n 0.2900 35999.5n 0.2900)
Vyp_bh_8 yp_bh_8 0 PWL(0.0n 0.4173 599.5n 0.4173 600.0n 0.5111 1199.5n 0.5111 1200.0n 0.4589 1799.5n 0.4589 1800.0n 0.5617 2399.5n 0.5617 2400.0n 0.5516 2999.5n 0.5516 3000.0n 0.4737 3599.5n 0.4737 3600.0n 0.4429 4199.5n 0.4429 4200.0n 0.4089 4799.5n 0.4089 4800.0n 0.4591 5399.5n 0.4591 5400.0n 0.4614 5999.5n 0.4614 6000.0n 0.4744 6599.5n 0.4744 6600.0n 0.4406 7199.5n 0.4406 7200.0n 0.5181 7799.5n 0.5181 7800.0n 0.5271 8399.5n 0.5271 8400.0n 0.3967 8999.5n 0.3967 9000.0n 0.4603 9599.5n 0.4603 9600.0n 0.4865 10199.5n 0.4865 10200.0n 0.5191 10799.5n 0.5191 10800.0n 0.4418 11399.5n 0.4418 11400.0n 0.4523 11999.5n 0.4523 12000.0n 0.3800 12599.5n 0.3800 12600.0n 0.4920 13199.5n 0.4920 13200.0n 0.4239 13799.5n 0.4239 13800.0n 0.4727 14399.5n 0.4727 14400.0n 0.4536 14999.5n 0.4536 15000.0n 0.5239 15599.5n 0.5239 15600.0n 0.4175 16199.5n 0.4175 16200.0n 0.4437 16799.5n 0.4437 16800.0n 0.3939 17399.5n 0.3939 17400.0n 0.4340 17999.5n 0.4340 18000.0n 0.4925 18599.5n 0.4925 18600.0n 0.5719 19199.5n 0.5719 19200.0n 0.6283 19799.5n 0.6283 19800.0n 0.6599 20399.5n 0.6599 20400.0n 0.5895 20999.5n 0.5895 21000.0n 0.3725 21599.5n 0.3725 21600.0n 0.6441 22199.5n 0.6441 22200.0n 0.5979 22799.5n 0.5979 22800.0n 0.6059 23399.5n 0.6059 23400.0n 0.3876 23999.5n 0.3876 24000.0n 0.6660 24599.5n 0.6660 24600.0n 0.5727 25199.5n 0.5727 25200.0n 0.5414 25799.5n 0.5414 25800.0n 0.4757 26399.5n 0.4757 26400.0n 0.5545 26999.5n 0.5545 27000.0n 0.5111 27599.5n 0.5111 27600.0n 0.5595 28199.5n 0.5595 28200.0n 0.4361 28799.5n 0.4361 28800.0n 0.5917 29399.5n 0.5917 29400.0n 0.3583 29999.5n 0.3583 30000.0n 0.3456 30599.5n 0.3456 30600.0n 0.3216 31199.5n 0.3216 31200.0n 0.3333 31799.5n 0.3333 31800.0n 0.4590 32399.5n 0.4590 32400.0n 0.4816 32999.5n 0.4816 33000.0n 0.6542 33599.5n 0.6542 33600.0n 0.6396 34199.5n 0.6396 34200.0n 0.5367 34799.5n 0.5367 34800.0n 0.3315 35399.5n 0.3315 35400.0n 0.6274 35999.5n 0.6274)
Vyn_bh_8 yn_bh_8 0 PWL(0.0n 0.5827 599.5n 0.5827 600.0n 0.4889 1199.5n 0.4889 1200.0n 0.5411 1799.5n 0.5411 1800.0n 0.4383 2399.5n 0.4383 2400.0n 0.4484 2999.5n 0.4484 3000.0n 0.5263 3599.5n 0.5263 3600.0n 0.5571 4199.5n 0.5571 4200.0n 0.5911 4799.5n 0.5911 4800.0n 0.5409 5399.5n 0.5409 5400.0n 0.5386 5999.5n 0.5386 6000.0n 0.5256 6599.5n 0.5256 6600.0n 0.5594 7199.5n 0.5594 7200.0n 0.4819 7799.5n 0.4819 7800.0n 0.4729 8399.5n 0.4729 8400.0n 0.6033 8999.5n 0.6033 9000.0n 0.5397 9599.5n 0.5397 9600.0n 0.5135 10199.5n 0.5135 10200.0n 0.4809 10799.5n 0.4809 10800.0n 0.5582 11399.5n 0.5582 11400.0n 0.5477 11999.5n 0.5477 12000.0n 0.6200 12599.5n 0.6200 12600.0n 0.5080 13199.5n 0.5080 13200.0n 0.5761 13799.5n 0.5761 13800.0n 0.5273 14399.5n 0.5273 14400.0n 0.5464 14999.5n 0.5464 15000.0n 0.4761 15599.5n 0.4761 15600.0n 0.5825 16199.5n 0.5825 16200.0n 0.5563 16799.5n 0.5563 16800.0n 0.6061 17399.5n 0.6061 17400.0n 0.5660 17999.5n 0.5660 18000.0n 0.5075 18599.5n 0.5075 18600.0n 0.4281 19199.5n 0.4281 19200.0n 0.3717 19799.5n 0.3717 19800.0n 0.3401 20399.5n 0.3401 20400.0n 0.4105 20999.5n 0.4105 21000.0n 0.6275 21599.5n 0.6275 21600.0n 0.3559 22199.5n 0.3559 22200.0n 0.4021 22799.5n 0.4021 22800.0n 0.3941 23399.5n 0.3941 23400.0n 0.6124 23999.5n 0.6124 24000.0n 0.3340 24599.5n 0.3340 24600.0n 0.4273 25199.5n 0.4273 25200.0n 0.4586 25799.5n 0.4586 25800.0n 0.5243 26399.5n 0.5243 26400.0n 0.4455 26999.5n 0.4455 27000.0n 0.4889 27599.5n 0.4889 27600.0n 0.4405 28199.5n 0.4405 28200.0n 0.5639 28799.5n 0.5639 28800.0n 0.4083 29399.5n 0.4083 29400.0n 0.6417 29999.5n 0.6417 30000.0n 0.6544 30599.5n 0.6544 30600.0n 0.6784 31199.5n 0.6784 31200.0n 0.6667 31799.5n 0.6667 31800.0n 0.5410 32399.5n 0.5410 32400.0n 0.5184 32999.5n 0.5184 33000.0n 0.3458 33599.5n 0.3458 33600.0n 0.3604 34199.5n 0.3604 34200.0n 0.4633 34799.5n 0.4633 34800.0n 0.6685 35399.5n 0.6685 35400.0n 0.3726 35999.5n 0.3726)
Cwp_bh_8 wp_bh_8 0 400p
Cwn_bh_8 wn_bh_8 0 400p
Xu_bh_8 xp_bh_8 xn_bh_8 yp_bh_8 yn_bh_8 wp_bh_8 wn_bh_8 vdd gbn gprod
Vxp_wih_0_9 xp_wih_0_9 0 PWL(0.0n 0.4942 599.5n 0.4942 600.0n 0.5558 1199.5n 0.5558 1200.0n 0.4708 1799.5n 0.4708 1800.0n 0.5235 2399.5n 0.5235 2400.0n 0.5350 2999.5n 0.5350 3000.0n 0.5172 3599.5n 0.5172 3600.0n 0.4702 4199.5n 0.4702 4200.0n 0.4867 4799.5n 0.4867 4800.0n 0.4970 5399.5n 0.4970 5400.0n 0.4986 5999.5n 0.4986 6000.0n 0.4751 6599.5n 0.4751 6600.0n 0.4870 7199.5n 0.4870 7200.0n 0.5502 7799.5n 0.5502 7800.0n 0.5521 8399.5n 0.5521 8400.0n 0.4638 8999.5n 0.4638 9000.0n 0.4982 9599.5n 0.4982 9600.0n 0.5131 10199.5n 0.5131 10200.0n 0.5386 10799.5n 0.5386 10800.0n 0.4592 11399.5n 0.4592 11400.0n 0.4950 11999.5n 0.4950 12000.0n 0.4559 12599.5n 0.4559 12600.0n 0.5162 13199.5n 0.5162 13200.0n 0.5038 13799.5n 0.5038 13800.0n 0.5333 14399.5n 0.5333 14400.0n 0.4991 14999.5n 0.4991 15000.0n 0.5298 15599.5n 0.5298 15600.0n 0.4823 16199.5n 0.4823 16200.0n 0.5239 16799.5n 0.5239 16800.0n 0.4592 17399.5n 0.4592 17400.0n 0.5094 17999.5n 0.5094 18000.0n 0.4337 18599.5n 0.4337 18600.0n 0.5977 19199.5n 0.5977 19200.0n 0.5364 19799.5n 0.5364 19800.0n 0.6122 20399.5n 0.6122 20400.0n 0.4856 20999.5n 0.4856 21000.0n 0.3861 21599.5n 0.3861 21600.0n 0.6094 22199.5n 0.6094 22200.0n 0.6364 22799.5n 0.6364 22800.0n 0.4807 23399.5n 0.4807 23400.0n 0.5614 23999.5n 0.5614 24000.0n 0.5913 24599.5n 0.5913 24600.0n 0.6295 25199.5n 0.6295 25200.0n 0.4496 25799.5n 0.4496 25800.0n 0.3792 26399.5n 0.3792 26400.0n 0.4434 26999.5n 0.4434 27000.0n 0.4340 27599.5n 0.4340 27600.0n 0.4461 28199.5n 0.4461 28200.0n 0.5791 28799.5n 0.5791 28800.0n 0.4777 29399.5n 0.4777 29400.0n 0.3878 29999.5n 0.3878 30000.0n 0.3832 30599.5n 0.3832 30600.0n 0.4022 31199.5n 0.4022 31200.0n 0.4482 31799.5n 0.4482 31800.0n 0.3662 32399.5n 0.3662 32400.0n 0.3857 32999.5n 0.3857 33000.0n 0.5584 33599.5n 0.5584 33600.0n 0.5284 34199.5n 0.5284 34200.0n 0.6034 34799.5n 0.6034 34800.0n 0.3469 35399.5n 0.3469 35400.0n 0.5290 35999.5n 0.5290)
Vxn_wih_0_9 xn_wih_0_9 0 PWL(0.0n 0.5058 599.5n 0.5058 600.0n 0.4442 1199.5n 0.4442 1200.0n 0.5292 1799.5n 0.5292 1800.0n 0.4765 2399.5n 0.4765 2400.0n 0.4650 2999.5n 0.4650 3000.0n 0.4828 3599.5n 0.4828 3600.0n 0.5298 4199.5n 0.5298 4200.0n 0.5133 4799.5n 0.5133 4800.0n 0.5030 5399.5n 0.5030 5400.0n 0.5014 5999.5n 0.5014 6000.0n 0.5249 6599.5n 0.5249 6600.0n 0.5130 7199.5n 0.5130 7200.0n 0.4498 7799.5n 0.4498 7800.0n 0.4479 8399.5n 0.4479 8400.0n 0.5362 8999.5n 0.5362 9000.0n 0.5018 9599.5n 0.5018 9600.0n 0.4869 10199.5n 0.4869 10200.0n 0.4614 10799.5n 0.4614 10800.0n 0.5408 11399.5n 0.5408 11400.0n 0.5050 11999.5n 0.5050 12000.0n 0.5441 12599.5n 0.5441 12600.0n 0.4838 13199.5n 0.4838 13200.0n 0.4962 13799.5n 0.4962 13800.0n 0.4667 14399.5n 0.4667 14400.0n 0.5009 14999.5n 0.5009 15000.0n 0.4702 15599.5n 0.4702 15600.0n 0.5177 16199.5n 0.5177 16200.0n 0.4761 16799.5n 0.4761 16800.0n 0.5408 17399.5n 0.5408 17400.0n 0.4906 17999.5n 0.4906 18000.0n 0.5663 18599.5n 0.5663 18600.0n 0.4023 19199.5n 0.4023 19200.0n 0.4636 19799.5n 0.4636 19800.0n 0.3878 20399.5n 0.3878 20400.0n 0.5144 20999.5n 0.5144 21000.0n 0.6139 21599.5n 0.6139 21600.0n 0.3906 22199.5n 0.3906 22200.0n 0.3636 22799.5n 0.3636 22800.0n 0.5193 23399.5n 0.5193 23400.0n 0.4386 23999.5n 0.4386 24000.0n 0.4087 24599.5n 0.4087 24600.0n 0.3705 25199.5n 0.3705 25200.0n 0.5504 25799.5n 0.5504 25800.0n 0.6208 26399.5n 0.6208 26400.0n 0.5566 26999.5n 0.5566 27000.0n 0.5660 27599.5n 0.5660 27600.0n 0.5539 28199.5n 0.5539 28200.0n 0.4209 28799.5n 0.4209 28800.0n 0.5223 29399.5n 0.5223 29400.0n 0.6122 29999.5n 0.6122 30000.0n 0.6168 30599.5n 0.6168 30600.0n 0.5978 31199.5n 0.5978 31200.0n 0.5518 31799.5n 0.5518 31800.0n 0.6338 32399.5n 0.6338 32400.0n 0.6143 32999.5n 0.6143 33000.0n 0.4416 33599.5n 0.4416 33600.0n 0.4716 34199.5n 0.4716 34200.0n 0.3966 34799.5n 0.3966 34800.0n 0.6531 35399.5n 0.6531 35400.0n 0.4710 35999.5n 0.4710)
Vyp_wih_0_9 yp_wih_0_9 0 PWL(0.0n 0.3412 599.5n 0.3412 600.0n 0.3524 1199.5n 0.3524 1200.0n 0.3586 1799.5n 0.3586 1800.0n 0.4217 2399.5n 0.4217 2400.0n 0.4032 2999.5n 0.4032 3000.0n 0.3521 3599.5n 0.3521 3600.0n 0.3520 4199.5n 0.3520 4200.0n 0.3404 4799.5n 0.3404 4800.0n 0.3515 5399.5n 0.3515 5400.0n 0.3519 5999.5n 0.3519 6000.0n 0.3684 6599.5n 0.3684 6600.0n 0.3478 7199.5n 0.3478 7200.0n 0.3589 7799.5n 0.3589 7800.0n 0.3639 8399.5n 0.3639 8400.0n 0.3412 8999.5n 0.3412 9000.0n 0.3516 9599.5n 0.3516 9600.0n 0.3586 10199.5n 0.3586 10200.0n 0.3695 10799.5n 0.3695 10800.0n 0.3549 11399.5n 0.3549 11400.0n 0.3498 11999.5n 0.3498 12000.0n 0.3392 12599.5n 0.3392 12600.0n 0.3607 13199.5n 0.3607 13200.0n 0.3413 13799.5n 0.3413 13800.0n 0.3481 14399.5n 0.3481 14400.0n 0.3494 14999.5n 0.3494 15000.0n 0.3807 15599.5n 0.3807 15600.0n 0.3429 16199.5n 0.3429 16200.0n 0.3427 16799.5n 0.3427 16800.0n 0.3414 17399.5n 0.3414 17400.0n 0.3428 17999.5n 0.3428 18000.0n 0.4286 18599.5n 0.4286 18600.0n 0.3716 19199.5n 0.3716 19200.0n 0.4809 19799.5n 0.4809 19800.0n 0.4858 20399.5n 0.4858 20400.0n 0.4749 20999.5n 0.4749 21000.0n 0.3488 21599.5n 0.3488 21600.0n 0.4411 22199.5n 0.4411 22200.0n 0.3827 22799.5n 0.3827 22800.0n 0.4955 23399.5n 0.4955 23400.0n 0.3241 23999.5n 0.3241 24000.0n 0.5209 24599.5n 0.5209 24600.0n 0.3607 25199.5n 0.3607 25200.0n 0.4564 25799.5n 0.4564 25800.0n 0.4409 26399.5n 0.4409 26400.0n 0.4780 26999.5n 0.4780 27000.0n 0.4470 27599.5n 0.4470 27600.0n 0.4794 28199.5n 0.4794 28200.0n 0.3293 28799.5n 0.3293 28800.0n 0.4828 29399.5n 0.4828 29400.0n 0.3444 29999.5n 0.3444 30000.0n 0.3384 30599.5n 0.3384 30600.0n 0.3174 31199.5n 0.3174 31200.0n 0.3222 31799.5n 0.3222 31800.0n 0.4291 32399.5n 0.4291 32400.0n 0.4439 32999.5n 0.4439 33000.0n 0.5002 33599.5n 0.5002 33600.0n 0.4999 34199.5n 0.4999 34200.0n 0.3486 34799.5n 0.3486 34800.0n 0.3297 35399.5n 0.3297 35400.0n 0.4862 35999.5n 0.4862)
Vyn_wih_0_9 yn_wih_0_9 0 PWL(0.0n 0.6588 599.5n 0.6588 600.0n 0.6476 1199.5n 0.6476 1200.0n 0.6414 1799.5n 0.6414 1800.0n 0.5783 2399.5n 0.5783 2400.0n 0.5968 2999.5n 0.5968 3000.0n 0.6479 3599.5n 0.6479 3600.0n 0.6480 4199.5n 0.6480 4200.0n 0.6596 4799.5n 0.6596 4800.0n 0.6485 5399.5n 0.6485 5400.0n 0.6481 5999.5n 0.6481 6000.0n 0.6316 6599.5n 0.6316 6600.0n 0.6522 7199.5n 0.6522 7200.0n 0.6411 7799.5n 0.6411 7800.0n 0.6361 8399.5n 0.6361 8400.0n 0.6588 8999.5n 0.6588 9000.0n 0.6484 9599.5n 0.6484 9600.0n 0.6414 10199.5n 0.6414 10200.0n 0.6305 10799.5n 0.6305 10800.0n 0.6451 11399.5n 0.6451 11400.0n 0.6502 11999.5n 0.6502 12000.0n 0.6608 12599.5n 0.6608 12600.0n 0.6393 13199.5n 0.6393 13200.0n 0.6587 13799.5n 0.6587 13800.0n 0.6519 14399.5n 0.6519 14400.0n 0.6506 14999.5n 0.6506 15000.0n 0.6193 15599.5n 0.6193 15600.0n 0.6571 16199.5n 0.6571 16200.0n 0.6573 16799.5n 0.6573 16800.0n 0.6586 17399.5n 0.6586 17400.0n 0.6572 17999.5n 0.6572 18000.0n 0.5714 18599.5n 0.5714 18600.0n 0.6284 19199.5n 0.6284 19200.0n 0.5191 19799.5n 0.5191 19800.0n 0.5142 20399.5n 0.5142 20400.0n 0.5251 20999.5n 0.5251 21000.0n 0.6512 21599.5n 0.6512 21600.0n 0.5589 22199.5n 0.5589 22200.0n 0.6173 22799.5n 0.6173 22800.0n 0.5045 23399.5n 0.5045 23400.0n 0.6759 23999.5n 0.6759 24000.0n 0.4791 24599.5n 0.4791 24600.0n 0.6393 25199.5n 0.6393 25200.0n 0.5436 25799.5n 0.5436 25800.0n 0.5591 26399.5n 0.5591 26400.0n 0.5220 26999.5n 0.5220 27000.0n 0.5530 27599.5n 0.5530 27600.0n 0.5206 28199.5n 0.5206 28200.0n 0.6707 28799.5n 0.6707 28800.0n 0.5172 29399.5n 0.5172 29400.0n 0.6556 29999.5n 0.6556 30000.0n 0.6616 30599.5n 0.6616 30600.0n 0.6826 31199.5n 0.6826 31200.0n 0.6778 31799.5n 0.6778 31800.0n 0.5709 32399.5n 0.5709 32400.0n 0.5561 32999.5n 0.5561 33000.0n 0.4998 33599.5n 0.4998 33600.0n 0.5001 34199.5n 0.5001 34200.0n 0.6514 34799.5n 0.6514 34800.0n 0.6703 35399.5n 0.6703 35400.0n 0.5138 35999.5n 0.5138)
Cwp_wih_0_9 wp_wih_0_9 0 400p
Cwn_wih_0_9 wn_wih_0_9 0 400p
Xu_wih_0_9 xp_wih_0_9 xn_wih_0_9 yp_wih_0_9 yn_wih_0_9 wp_wih_0_9 wn_wih_0_9 vdd gbn gprod
Vxp_wih_1_9 xp_wih_1_9 0 PWL(0.0n 0.5370 599.5n 0.5370 600.0n 0.5167 1199.5n 0.5167 1200.0n 0.4793 1799.5n 0.4793 1800.0n 0.4441 2399.5n 0.4441 2400.0n 0.4555 2999.5n 0.4555 3000.0n 0.5055 3599.5n 0.5055 3600.0n 0.4939 4199.5n 0.4939 4200.0n 0.5385 4799.5n 0.5385 4800.0n 0.5024 5399.5n 0.5024 5400.0n 0.5015 5999.5n 0.5015 6000.0n 0.4700 6599.5n 0.4700 6600.0n 0.5120 7199.5n 0.5120 7200.0n 0.5006 7799.5n 0.5006 7800.0n 0.4950 8399.5n 0.4950 8400.0n 0.5309 8999.5n 0.5309 9000.0n 0.5023 9599.5n 0.5023 9600.0n 0.4893 10199.5n 0.4893 10200.0n 0.4837 10799.5n 0.4837 10800.0n 0.4823 11399.5n 0.4823 11400.0n 0.5074 11999.5n 0.5074 12000.0n 0.5364 12599.5n 0.5364 12600.0n 0.4868 13199.5n 0.4868 13200.0n 0.5380 13799.5n 0.5380 13800.0n 0.5220 14399.5n 0.5220 14400.0n 0.5095 14999.5n 0.5095 15000.0n 0.4705 15599.5n 0.4705 15600.0n 0.5289 16199.5n 0.5289 16200.0n 0.5368 16799.5n 0.5368 16800.0n 0.5287 17399.5n 0.5287 17400.0n 0.5342 17999.5n 0.5342 18000.0n 0.4253 18599.5n 0.4253 18600.0n 0.5119 19199.5n 0.5119 19200.0n 0.4104 19799.5n 0.4104 19800.0n 0.4314 20399.5n 0.4314 20400.0n 0.4005 20999.5n 0.4005 21000.0n 0.4696 21599.5n 0.4696 21600.0n 0.4531 22199.5n 0.4531 22200.0n 0.5039 22799.5n 0.5039 22800.0n 0.3608 23399.5n 0.3608 23400.0n 0.6273 23999.5n 0.6273 24000.0n 0.3928 24599.5n 0.3928 24600.0n 0.5253 25199.5n 0.5253 25200.0n 0.4107 25799.5n 0.4107 25800.0n 0.3947 26399.5n 0.3947 26400.0n 0.3716 26999.5n 0.3716 27000.0n 0.4111 27599.5n 0.4111 27600.0n 0.3715 28199.5n 0.3715 28200.0n 0.5939 28799.5n 0.5939 28800.0n 0.3849 29399.5n 0.3849 29400.0n 0.4835 29999.5n 0.4835 30000.0n 0.5119 30599.5n 0.5119 30600.0n 0.6226 31199.5n 0.6226 31200.0n 0.6064 31799.5n 0.6064 31800.0n 0.4115 32399.5n 0.4115 32400.0n 0.3900 32999.5n 0.3900 33000.0n 0.3958 33599.5n 0.3958 33600.0n 0.3747 34199.5n 0.3747 34200.0n 0.5423 34799.5n 0.5423 34800.0n 0.5509 35399.5n 0.5509 35400.0n 0.3990 35999.5n 0.3990)
Vxn_wih_1_9 xn_wih_1_9 0 PWL(0.0n 0.4630 599.5n 0.4630 600.0n 0.4833 1199.5n 0.4833 1200.0n 0.5207 1799.5n 0.5207 1800.0n 0.5559 2399.5n 0.5559 2400.0n 0.5445 2999.5n 0.5445 3000.0n 0.4945 3599.5n 0.4945 3600.0n 0.5061 4199.5n 0.5061 4200.0n 0.4615 4799.5n 0.4615 4800.0n 0.4976 5399.5n 0.4976 5400.0n 0.4985 5999.5n 0.4985 6000.0n 0.5300 6599.5n 0.5300 6600.0n 0.4880 7199.5n 0.4880 7200.0n 0.4994 7799.5n 0.4994 7800.0n 0.5050 8399.5n 0.5050 8400.0n 0.4691 8999.5n 0.4691 9000.0n 0.4977 9599.5n 0.4977 9600.0n 0.5107 10199.5n 0.5107 10200.0n 0.5163 10799.5n 0.5163 10800.0n 0.5177 11399.5n 0.5177 11400.0n 0.4926 11999.5n 0.4926 12000.0n 0.4636 12599.5n 0.4636 12600.0n 0.5132 13199.5n 0.5132 13200.0n 0.4620 13799.5n 0.4620 13800.0n 0.4780 14399.5n 0.4780 14400.0n 0.4905 14999.5n 0.4905 15000.0n 0.5295 15599.5n 0.5295 15600.0n 0.4711 16199.5n 0.4711 16200.0n 0.4632 16799.5n 0.4632 16800.0n 0.4713 17399.5n 0.4713 17400.0n 0.4658 17999.5n 0.4658 18000.0n 0.5747 18599.5n 0.5747 18600.0n 0.4881 19199.5n 0.4881 19200.0n 0.5896 19799.5n 0.5896 19800.0n 0.5686 20399.5n 0.5686 20400.0n 0.5995 20999.5n 0.5995 21000.0n 0.5304 21599.5n 0.5304 21600.0n 0.5469 22199.5n 0.5469 22200.0n 0.4961 22799.5n 0.4961 22800.0n 0.6392 23399.5n 0.6392 23400.0n 0.3727 23999.5n 0.3727 24000.0n 0.6072 24599.5n 0.6072 24600.0n 0.4747 25199.5n 0.4747 25200.0n 0.5893 25799.5n 0.5893 25800.0n 0.6053 26399.5n 0.6053 26400.0n 0.6284 26999.5n 0.6284 27000.0n 0.5889 27599.5n 0.5889 27600.0n 0.6285 28199.5n 0.6285 28200.0n 0.4061 28799.5n 0.4061 28800.0n 0.6151 29399.5n 0.6151 29400.0n 0.5165 29999.5n 0.5165 30000.0n 0.4881 30599.5n 0.4881 30600.0n 0.3774 31199.5n 0.3774 31200.0n 0.3936 31799.5n 0.3936 31800.0n 0.5885 32399.5n 0.5885 32400.0n 0.6100 32999.5n 0.6100 33000.0n 0.6042 33599.5n 0.6042 33600.0n 0.6253 34199.5n 0.6253 34200.0n 0.4577 34799.5n 0.4577 34800.0n 0.4491 35399.5n 0.4491 35400.0n 0.6010 35999.5n 0.6010)
Vyp_wih_1_9 yp_wih_1_9 0 PWL(0.0n 0.3412 599.5n 0.3412 600.0n 0.3524 1199.5n 0.3524 1200.0n 0.3586 1799.5n 0.3586 1800.0n 0.4217 2399.5n 0.4217 2400.0n 0.4032 2999.5n 0.4032 3000.0n 0.3521 3599.5n 0.3521 3600.0n 0.3520 4199.5n 0.3520 4200.0n 0.3404 4799.5n 0.3404 4800.0n 0.3515 5399.5n 0.3515 5400.0n 0.3519 5999.5n 0.3519 6000.0n 0.3684 6599.5n 0.3684 6600.0n 0.3478 7199.5n 0.3478 7200.0n 0.3589 7799.5n 0.3589 7800.0n 0.3639 8399.5n 0.3639 8400.0n 0.3412 8999.5n 0.3412 9000.0n 0.3516 9599.5n 0.3516 9600.0n 0.3586 10199.5n 0.3586 10200.0n 0.3695 10799.5n 0.3695 10800.0n 0.3549 11399.5n 0.3549 11400.0n 0.3498 11999.5n 0.3498 12000.0n 0.3392 12599.5n 0.3392 12600.0n 0.3607 13199.5n 0.3607 13200.0n 0.3413 13799.5n 0.3413 13800.0n 0.3481 14399.5n 0.3481 14400.0n 0.3494 14999.5n 0.3494 15000.0n 0.3807 15599.5n 0.3807 15600.0n 0.3429 16199.5n 0.3429 16200.0n 0.3427 16799.5n 0.3427 16800.0n 0.3414 17399.5n 0.3414 17400.0n 0.3428 17999.5n 0.3428 18000.0n 0.4286 18599.5n 0.4286 18600.0n 0.3716 19199.5n 0.3716 19200.0n 0.4809 19799.5n 0.4809 19800.0n 0.4858 20399.5n 0.4858 20400.0n 0.4749 20999.5n 0.4749 21000.0n 0.3488 21599.5n 0.3488 21600.0n 0.4411 22199.5n 0.4411 22200.0n 0.3827 22799.5n 0.3827 22800.0n 0.4955 23399.5n 0.4955 23400.0n 0.3241 23999.5n 0.3241 24000.0n 0.5209 24599.5n 0.5209 24600.0n 0.3607 25199.5n 0.3607 25200.0n 0.4564 25799.5n 0.4564 25800.0n 0.4409 26399.5n 0.4409 26400.0n 0.4780 26999.5n 0.4780 27000.0n 0.4470 27599.5n 0.4470 27600.0n 0.4794 28199.5n 0.4794 28200.0n 0.3293 28799.5n 0.3293 28800.0n 0.4828 29399.5n 0.4828 29400.0n 0.3444 29999.5n 0.3444 30000.0n 0.3384 30599.5n 0.3384 30600.0n 0.3174 31199.5n 0.3174 31200.0n 0.3222 31799.5n 0.3222 31800.0n 0.4291 32399.5n 0.4291 32400.0n 0.4439 32999.5n 0.4439 33000.0n 0.5002 33599.5n 0.5002 33600.0n 0.4999 34199.5n 0.4999 34200.0n 0.3486 34799.5n 0.3486 34800.0n 0.3297 35399.5n 0.3297 35400.0n 0.4862 35999.5n 0.4862)
Vyn_wih_1_9 yn_wih_1_9 0 PWL(0.0n 0.6588 599.5n 0.6588 600.0n 0.6476 1199.5n 0.6476 1200.0n 0.6414 1799.5n 0.6414 1800.0n 0.5783 2399.5n 0.5783 2400.0n 0.5968 2999.5n 0.5968 3000.0n 0.6479 3599.5n 0.6479 3600.0n 0.6480 4199.5n 0.6480 4200.0n 0.6596 4799.5n 0.6596 4800.0n 0.6485 5399.5n 0.6485 5400.0n 0.6481 5999.5n 0.6481 6000.0n 0.6316 6599.5n 0.6316 6600.0n 0.6522 7199.5n 0.6522 7200.0n 0.6411 7799.5n 0.6411 7800.0n 0.6361 8399.5n 0.6361 8400.0n 0.6588 8999.5n 0.6588 9000.0n 0.6484 9599.5n 0.6484 9600.0n 0.6414 10199.5n 0.6414 10200.0n 0.6305 10799.5n 0.6305 10800.0n 0.6451 11399.5n 0.6451 11400.0n 0.6502 11999.5n 0.6502 12000.0n 0.6608 12599.5n 0.6608 12600.0n 0.6393 13199.5n 0.6393 13200.0n 0.6587 13799.5n 0.6587 13800.0n 0.6519 14399.5n 0.6519 14400.0n 0.6506 14999.5n 0.6506 15000.0n 0.6193 15599.5n 0.6193 15600.0n 0.6571 16199.5n 0.6571 16200.0n 0.6573 16799.5n 0.6573 16800.0n 0.6586 17399.5n 0.6586 17400.0n 0.6572 17999.5n 0.6572 18000.0n 0.5714 18599.5n 0.5714 18600.0n 0.6284 19199.5n 0.6284 19200.0n 0.5191 19799.5n 0.5191 19800.0n 0.5142 20399.5n 0.5142 20400.0n 0.5251 20999.5n 0.5251 21000.0n 0.6512 21599.5n 0.6512 21600.0n 0.5589 22199.5n 0.5589 22200.0n 0.6173 22799.5n 0.6173 22800.0n 0.5045 23399.5n 0.5045 23400.0n 0.6759 23999.5n 0.6759 24000.0n 0.4791 24599.5n 0.4791 24600.0n 0.6393 25199.5n 0.6393 25200.0n 0.5436 25799.5n 0.5436 25800.0n 0.5591 26399.5n 0.5591 26400.0n 0.5220 26999.5n 0.5220 27000.0n 0.5530 27599.5n 0.5530 27600.0n 0.5206 28199.5n 0.5206 28200.0n 0.6707 28799.5n 0.6707 28800.0n 0.5172 29399.5n 0.5172 29400.0n 0.6556 29999.5n 0.6556 30000.0n 0.6616 30599.5n 0.6616 30600.0n 0.6826 31199.5n 0.6826 31200.0n 0.6778 31799.5n 0.6778 31800.0n 0.5709 32399.5n 0.5709 32400.0n 0.5561 32999.5n 0.5561 33000.0n 0.4998 33599.5n 0.4998 33600.0n 0.5001 34199.5n 0.5001 34200.0n 0.6514 34799.5n 0.6514 34800.0n 0.6703 35399.5n 0.6703 35400.0n 0.5138 35999.5n 0.5138)
Cwp_wih_1_9 wp_wih_1_9 0 400p
Cwn_wih_1_9 wn_wih_1_9 0 400p
Xu_wih_1_9 xp_wih_1_9 xn_wih_1_9 yp_wih_1_9 yn_wih_1_9 wp_wih_1_9 wn_wih_1_9 vdd gbn gprod
Vxp_who_9_0 xp_who_9_0 0 PWL(0.0n 0.3412 599.5n 0.3412 600.0n 0.3524 1199.5n 0.3524 1200.0n 0.3586 1799.5n 0.3586 1800.0n 0.4217 2399.5n 0.4217 2400.0n 0.4032 2999.5n 0.4032 3000.0n 0.3521 3599.5n 0.3521 3600.0n 0.3520 4199.5n 0.3520 4200.0n 0.3404 4799.5n 0.3404 4800.0n 0.3515 5399.5n 0.3515 5400.0n 0.3519 5999.5n 0.3519 6000.0n 0.3684 6599.5n 0.3684 6600.0n 0.3478 7199.5n 0.3478 7200.0n 0.3589 7799.5n 0.3589 7800.0n 0.3639 8399.5n 0.3639 8400.0n 0.3412 8999.5n 0.3412 9000.0n 0.3516 9599.5n 0.3516 9600.0n 0.3586 10199.5n 0.3586 10200.0n 0.3695 10799.5n 0.3695 10800.0n 0.3549 11399.5n 0.3549 11400.0n 0.3498 11999.5n 0.3498 12000.0n 0.3392 12599.5n 0.3392 12600.0n 0.3607 13199.5n 0.3607 13200.0n 0.3413 13799.5n 0.3413 13800.0n 0.3481 14399.5n 0.3481 14400.0n 0.3494 14999.5n 0.3494 15000.0n 0.3807 15599.5n 0.3807 15600.0n 0.3429 16199.5n 0.3429 16200.0n 0.3427 16799.5n 0.3427 16800.0n 0.3414 17399.5n 0.3414 17400.0n 0.3428 17999.5n 0.3428 18000.0n 0.4286 18599.5n 0.4286 18600.0n 0.3716 19199.5n 0.3716 19200.0n 0.4809 19799.5n 0.4809 19800.0n 0.4858 20399.5n 0.4858 20400.0n 0.4749 20999.5n 0.4749 21000.0n 0.3488 21599.5n 0.3488 21600.0n 0.4411 22199.5n 0.4411 22200.0n 0.3827 22799.5n 0.3827 22800.0n 0.4955 23399.5n 0.4955 23400.0n 0.3241 23999.5n 0.3241 24000.0n 0.5209 24599.5n 0.5209 24600.0n 0.3607 25199.5n 0.3607 25200.0n 0.4564 25799.5n 0.4564 25800.0n 0.4409 26399.5n 0.4409 26400.0n 0.4780 26999.5n 0.4780 27000.0n 0.4470 27599.5n 0.4470 27600.0n 0.4794 28199.5n 0.4794 28200.0n 0.3293 28799.5n 0.3293 28800.0n 0.4828 29399.5n 0.4828 29400.0n 0.3444 29999.5n 0.3444 30000.0n 0.3384 30599.5n 0.3384 30600.0n 0.3174 31199.5n 0.3174 31200.0n 0.3222 31799.5n 0.3222 31800.0n 0.4291 32399.5n 0.4291 32400.0n 0.4439 32999.5n 0.4439 33000.0n 0.5002 33599.5n 0.5002 33600.0n 0.4999 34199.5n 0.4999 34200.0n 0.3486 34799.5n 0.3486 34800.0n 0.3297 35399.5n 0.3297 35400.0n 0.4862 35999.5n 0.4862)
Vxn_who_9_0 xn_who_9_0 0 PWL(0.0n 0.6588 599.5n 0.6588 600.0n 0.6476 1199.5n 0.6476 1200.0n 0.6414 1799.5n 0.6414 1800.0n 0.5783 2399.5n 0.5783 2400.0n 0.5968 2999.5n 0.5968 3000.0n 0.6479 3599.5n 0.6479 3600.0n 0.6480 4199.5n 0.6480 4200.0n 0.6596 4799.5n 0.6596 4800.0n 0.6485 5399.5n 0.6485 5400.0n 0.6481 5999.5n 0.6481 6000.0n 0.6316 6599.5n 0.6316 6600.0n 0.6522 7199.5n 0.6522 7200.0n 0.6411 7799.5n 0.6411 7800.0n 0.6361 8399.5n 0.6361 8400.0n 0.6588 8999.5n 0.6588 9000.0n 0.6484 9599.5n 0.6484 9600.0n 0.6414 10199.5n 0.6414 10200.0n 0.6305 10799.5n 0.6305 10800.0n 0.6451 11399.5n 0.6451 11400.0n 0.6502 11999.5n 0.6502 12000.0n 0.6608 12599.5n 0.6608 12600.0n 0.6393 13199.5n 0.6393 13200.0n 0.6587 13799.5n 0.6587 13800.0n 0.6519 14399.5n 0.6519 14400.0n 0.6506 14999.5n 0.6506 15000.0n 0.6193 15599.5n 0.6193 15600.0n 0.6571 16199.5n 0.6571 16200.0n 0.6573 16799.5n 0.6573 16800.0n 0.6586 17399.5n 0.6586 17400.0n 0.6572 17999.5n 0.6572 18000.0n 0.5714 18599.5n 0.5714 18600.0n 0.6284 19199.5n 0.6284 19200.0n 0.5191 19799.5n 0.5191 19800.0n 0.5142 20399.5n 0.5142 20400.0n 0.5251 20999.5n 0.5251 21000.0n 0.6512 21599.5n 0.6512 21600.0n 0.5589 22199.5n 0.5589 22200.0n 0.6173 22799.5n 0.6173 22800.0n 0.5045 23399.5n 0.5045 23400.0n 0.6759 23999.5n 0.6759 24000.0n 0.4791 24599.5n 0.4791 24600.0n 0.6393 25199.5n 0.6393 25200.0n 0.5436 25799.5n 0.5436 25800.0n 0.5591 26399.5n 0.5591 26400.0n 0.5220 26999.5n 0.5220 27000.0n 0.5530 27599.5n 0.5530 27600.0n 0.5206 28199.5n 0.5206 28200.0n 0.6707 28799.5n 0.6707 28800.0n 0.5172 29399.5n 0.5172 29400.0n 0.6556 29999.5n 0.6556 30000.0n 0.6616 30599.5n 0.6616 30600.0n 0.6826 31199.5n 0.6826 31200.0n 0.6778 31799.5n 0.6778 31800.0n 0.5709 32399.5n 0.5709 32400.0n 0.5561 32999.5n 0.5561 33000.0n 0.4998 33599.5n 0.4998 33600.0n 0.5001 34199.5n 0.5001 34200.0n 0.6514 34799.5n 0.6514 34800.0n 0.6703 35399.5n 0.6703 35400.0n 0.5138 35999.5n 0.5138)
Vyp_who_9_0 yp_who_9_0 0 PWL(0.0n 0.5031 599.5n 0.5031 600.0n 0.5023 1199.5n 0.5023 1200.0n 0.5052 1799.5n 0.5052 1800.0n 0.5048 2399.5n 0.5048 2400.0n 0.5043 2999.5n 0.5043 3000.0n 0.5034 3599.5n 0.5034 3600.0n 0.5048 4199.5n 0.5048 4200.0n 0.5031 4799.5n 0.5031 4800.0n 0.5040 5399.5n 0.5040 5400.0n 0.5040 5999.5n 0.5040 6000.0n 0.5054 6599.5n 0.5054 6600.0n 0.5040 7199.5n 0.5040 7200.0n 0.5027 7799.5n 0.5027 7800.0n 0.5027 8399.5n 0.5027 8400.0n 0.5038 8999.5n 0.5038 9000.0n 0.5040 9599.5n 0.5040 9600.0n 0.5039 10199.5n 0.5039 10200.0n 0.5033 10799.5n 0.5033 10800.0n 0.5056 11399.5n 0.5056 11400.0n 0.5040 11999.5n 0.5040 12000.0n 0.5036 12599.5n 0.5036 12600.0n 0.5039 13199.5n 0.5039 13200.0n 0.5029 13799.5n 0.5029 13800.0n 0.5025 14399.5n 0.5025 14400.0n 0.5038 14999.5n 0.5038 15000.0n 0.5041 15599.5n 0.5041 15600.0n 0.5036 16199.5n 0.5036 16200.0n 0.5025 16799.5n 0.5025 16800.0n 0.5040 17399.5n 0.5040 17400.0n 0.5029 17999.5n 0.5029 18000.0n 0.5057 18599.5n 0.5057 18600.0n 0.5010 19199.5n 0.5010 19200.0n 0.5041 19799.5n 0.5041 19800.0n 0.5021 20399.5n 0.5021 20400.0n 0.5044 20999.5n 0.5044 21000.0n 0.5056 21599.5n 0.5056 21600.0n 0.5016 22199.5n 0.5016 22200.0n 0.5006 22799.5n 0.5006 22800.0n 0.5041 23399.5n 0.5041 23400.0n 0.5027 23999.5n 0.5027 24000.0n 0.5029 24599.5n 0.5029 24600.0n 0.5006 25199.5n 0.5006 25200.0n 0.5047 25799.5n 0.5047 25800.0n 0.5046 26399.5n 0.5046 26400.0n 0.5039 26999.5n 0.5039 27000.0n 0.5049 27599.5n 0.5049 27600.0n 0.5039 28199.5n 0.5039 28200.0n 0.5017 28799.5n 0.5017 28800.0n 0.5042 29399.5n 0.5042 29400.0n 0.5056 29999.5n 0.5056 30000.0n 0.5051 30599.5n 0.5051 30600.0n 0.5039 31199.5n 0.5039 31200.0n 0.5033 31799.5n 0.5033 31800.0n 0.5049 32399.5n 0.5049 32400.0n 0.5045 32999.5n 0.5045 33000.0n 0.5036 33599.5n 0.5036 33600.0n 0.5042 34199.5n 0.5042 34200.0n 0.5012 34799.5n 0.5012 34800.0n 0.5036 35399.5n 0.5036 35400.0n 0.5042 35999.5n 0.5042)
Vyn_who_9_0 yn_who_9_0 0 PWL(0.0n 0.4969 599.5n 0.4969 600.0n 0.4977 1199.5n 0.4977 1200.0n 0.4948 1799.5n 0.4948 1800.0n 0.4952 2399.5n 0.4952 2400.0n 0.4957 2999.5n 0.4957 3000.0n 0.4966 3599.5n 0.4966 3600.0n 0.4952 4199.5n 0.4952 4200.0n 0.4969 4799.5n 0.4969 4800.0n 0.4960 5399.5n 0.4960 5400.0n 0.4960 5999.5n 0.4960 6000.0n 0.4946 6599.5n 0.4946 6600.0n 0.4960 7199.5n 0.4960 7200.0n 0.4973 7799.5n 0.4973 7800.0n 0.4973 8399.5n 0.4973 8400.0n 0.4962 8999.5n 0.4962 9000.0n 0.4960 9599.5n 0.4960 9600.0n 0.4961 10199.5n 0.4961 10200.0n 0.4967 10799.5n 0.4967 10800.0n 0.4944 11399.5n 0.4944 11400.0n 0.4960 11999.5n 0.4960 12000.0n 0.4964 12599.5n 0.4964 12600.0n 0.4961 13199.5n 0.4961 13200.0n 0.4971 13799.5n 0.4971 13800.0n 0.4975 14399.5n 0.4975 14400.0n 0.4962 14999.5n 0.4962 15000.0n 0.4959 15599.5n 0.4959 15600.0n 0.4964 16199.5n 0.4964 16200.0n 0.4975 16799.5n 0.4975 16800.0n 0.4960 17399.5n 0.4960 17400.0n 0.4971 17999.5n 0.4971 18000.0n 0.4943 18599.5n 0.4943 18600.0n 0.4990 19199.5n 0.4990 19200.0n 0.4959 19799.5n 0.4959 19800.0n 0.4979 20399.5n 0.4979 20400.0n 0.4956 20999.5n 0.4956 21000.0n 0.4944 21599.5n 0.4944 21600.0n 0.4984 22199.5n 0.4984 22200.0n 0.4994 22799.5n 0.4994 22800.0n 0.4959 23399.5n 0.4959 23400.0n 0.4973 23999.5n 0.4973 24000.0n 0.4971 24599.5n 0.4971 24600.0n 0.4994 25199.5n 0.4994 25200.0n 0.4953 25799.5n 0.4953 25800.0n 0.4954 26399.5n 0.4954 26400.0n 0.4961 26999.5n 0.4961 27000.0n 0.4951 27599.5n 0.4951 27600.0n 0.4961 28199.5n 0.4961 28200.0n 0.4983 28799.5n 0.4983 28800.0n 0.4958 29399.5n 0.4958 29400.0n 0.4944 29999.5n 0.4944 30000.0n 0.4949 30599.5n 0.4949 30600.0n 0.4961 31199.5n 0.4961 31200.0n 0.4967 31799.5n 0.4967 31800.0n 0.4951 32399.5n 0.4951 32400.0n 0.4955 32999.5n 0.4955 33000.0n 0.4964 33599.5n 0.4964 33600.0n 0.4958 34199.5n 0.4958 34200.0n 0.4988 34799.5n 0.4988 34800.0n 0.4964 35399.5n 0.4964 35400.0n 0.4958 35999.5n 0.4958)
Cwp_who_9_0 wp_who_9_0 0 400p
Cwn_who_9_0 wn_who_9_0 0 400p
Xu_who_9_0 xp_who_9_0 xn_who_9_0 yp_who_9_0 yn_who_9_0 wp_who_9_0 wn_who_9_0 vdd gbn gprod
Vxp_who_9_1 xp_who_9_1 0 PWL(0.0n 0.3412 599.5n 0.3412 600.0n 0.3524 1199.5n 0.3524 1200.0n 0.3586 1799.5n 0.3586 1800.0n 0.4217 2399.5n 0.4217 2400.0n 0.4032 2999.5n 0.4032 3000.0n 0.3521 3599.5n 0.3521 3600.0n 0.3520 4199.5n 0.3520 4200.0n 0.3404 4799.5n 0.3404 4800.0n 0.3515 5399.5n 0.3515 5400.0n 0.3519 5999.5n 0.3519 6000.0n 0.3684 6599.5n 0.3684 6600.0n 0.3478 7199.5n 0.3478 7200.0n 0.3589 7799.5n 0.3589 7800.0n 0.3639 8399.5n 0.3639 8400.0n 0.3412 8999.5n 0.3412 9000.0n 0.3516 9599.5n 0.3516 9600.0n 0.3586 10199.5n 0.3586 10200.0n 0.3695 10799.5n 0.3695 10800.0n 0.3549 11399.5n 0.3549 11400.0n 0.3498 11999.5n 0.3498 12000.0n 0.3392 12599.5n 0.3392 12600.0n 0.3607 13199.5n 0.3607 13200.0n 0.3413 13799.5n 0.3413 13800.0n 0.3481 14399.5n 0.3481 14400.0n 0.3494 14999.5n 0.3494 15000.0n 0.3807 15599.5n 0.3807 15600.0n 0.3429 16199.5n 0.3429 16200.0n 0.3427 16799.5n 0.3427 16800.0n 0.3414 17399.5n 0.3414 17400.0n 0.3428 17999.5n 0.3428 18000.0n 0.4286 18599.5n 0.4286 18600.0n 0.3716 19199.5n 0.3716 19200.0n 0.4809 19799.5n 0.4809 19800.0n 0.4858 20399.5n 0.4858 20400.0n 0.4749 20999.5n 0.4749 21000.0n 0.3488 21599.5n 0.3488 21600.0n 0.4411 22199.5n 0.4411 22200.0n 0.3827 22799.5n 0.3827 22800.0n 0.4955 23399.5n 0.4955 23400.0n 0.3241 23999.5n 0.3241 24000.0n 0.5209 24599.5n 0.5209 24600.0n 0.3607 25199.5n 0.3607 25200.0n 0.4564 25799.5n 0.4564 25800.0n 0.4409 26399.5n 0.4409 26400.0n 0.4780 26999.5n 0.4780 27000.0n 0.4470 27599.5n 0.4470 27600.0n 0.4794 28199.5n 0.4794 28200.0n 0.3293 28799.5n 0.3293 28800.0n 0.4828 29399.5n 0.4828 29400.0n 0.3444 29999.5n 0.3444 30000.0n 0.3384 30599.5n 0.3384 30600.0n 0.3174 31199.5n 0.3174 31200.0n 0.3222 31799.5n 0.3222 31800.0n 0.4291 32399.5n 0.4291 32400.0n 0.4439 32999.5n 0.4439 33000.0n 0.5002 33599.5n 0.5002 33600.0n 0.4999 34199.5n 0.4999 34200.0n 0.3486 34799.5n 0.3486 34800.0n 0.3297 35399.5n 0.3297 35400.0n 0.4862 35999.5n 0.4862)
Vxn_who_9_1 xn_who_9_1 0 PWL(0.0n 0.6588 599.5n 0.6588 600.0n 0.6476 1199.5n 0.6476 1200.0n 0.6414 1799.5n 0.6414 1800.0n 0.5783 2399.5n 0.5783 2400.0n 0.5968 2999.5n 0.5968 3000.0n 0.6479 3599.5n 0.6479 3600.0n 0.6480 4199.5n 0.6480 4200.0n 0.6596 4799.5n 0.6596 4800.0n 0.6485 5399.5n 0.6485 5400.0n 0.6481 5999.5n 0.6481 6000.0n 0.6316 6599.5n 0.6316 6600.0n 0.6522 7199.5n 0.6522 7200.0n 0.6411 7799.5n 0.6411 7800.0n 0.6361 8399.5n 0.6361 8400.0n 0.6588 8999.5n 0.6588 9000.0n 0.6484 9599.5n 0.6484 9600.0n 0.6414 10199.5n 0.6414 10200.0n 0.6305 10799.5n 0.6305 10800.0n 0.6451 11399.5n 0.6451 11400.0n 0.6502 11999.5n 0.6502 12000.0n 0.6608 12599.5n 0.6608 12600.0n 0.6393 13199.5n 0.6393 13200.0n 0.6587 13799.5n 0.6587 13800.0n 0.6519 14399.5n 0.6519 14400.0n 0.6506 14999.5n 0.6506 15000.0n 0.6193 15599.5n 0.6193 15600.0n 0.6571 16199.5n 0.6571 16200.0n 0.6573 16799.5n 0.6573 16800.0n 0.6586 17399.5n 0.6586 17400.0n 0.6572 17999.5n 0.6572 18000.0n 0.5714 18599.5n 0.5714 18600.0n 0.6284 19199.5n 0.6284 19200.0n 0.5191 19799.5n 0.5191 19800.0n 0.5142 20399.5n 0.5142 20400.0n 0.5251 20999.5n 0.5251 21000.0n 0.6512 21599.5n 0.6512 21600.0n 0.5589 22199.5n 0.5589 22200.0n 0.6173 22799.5n 0.6173 22800.0n 0.5045 23399.5n 0.5045 23400.0n 0.6759 23999.5n 0.6759 24000.0n 0.4791 24599.5n 0.4791 24600.0n 0.6393 25199.5n 0.6393 25200.0n 0.5436 25799.5n 0.5436 25800.0n 0.5591 26399.5n 0.5591 26400.0n 0.5220 26999.5n 0.5220 27000.0n 0.5530 27599.5n 0.5530 27600.0n 0.5206 28199.5n 0.5206 28200.0n 0.6707 28799.5n 0.6707 28800.0n 0.5172 29399.5n 0.5172 29400.0n 0.6556 29999.5n 0.6556 30000.0n 0.6616 30599.5n 0.6616 30600.0n 0.6826 31199.5n 0.6826 31200.0n 0.6778 31799.5n 0.6778 31800.0n 0.5709 32399.5n 0.5709 32400.0n 0.5561 32999.5n 0.5561 33000.0n 0.4998 33599.5n 0.4998 33600.0n 0.5001 34199.5n 0.5001 34200.0n 0.6514 34799.5n 0.6514 34800.0n 0.6703 35399.5n 0.6703 35400.0n 0.5138 35999.5n 0.5138)
Vyp_who_9_1 yp_who_9_1 0 PWL(0.0n 0.5071 599.5n 0.5071 600.0n 0.5053 1199.5n 0.5053 1200.0n 0.5052 1799.5n 0.5052 1800.0n 0.5027 2399.5n 0.5027 2400.0n 0.5034 2999.5n 0.5034 3000.0n 0.5055 3599.5n 0.5055 3600.0n 0.5056 4199.5n 0.5056 4200.0n 0.5071 4799.5n 0.5071 4800.0n 0.5056 5399.5n 0.5056 5400.0n 0.5056 5999.5n 0.5056 6000.0n 0.5048 6599.5n 0.5048 6600.0n 0.5060 7199.5n 0.5060 7200.0n 0.5048 7799.5n 0.5048 7800.0n 0.5046 8399.5n 0.5046 8400.0n 0.5066 8999.5n 0.5066 9000.0n 0.5056 9599.5n 0.5056 9600.0n 0.5051 10199.5n 0.5051 10200.0n 0.5046 10799.5n 0.5046 10800.0n 0.5056 11399.5n 0.5056 11400.0n 0.5058 11999.5n 0.5058 12000.0n 0.5068 12599.5n 0.5068 12600.0n 0.5050 13199.5n 0.5050 13200.0n 0.5071 13799.5n 0.5071 13800.0n 0.5059 14399.5n 0.5059 14400.0n 0.5058 14999.5n 0.5058 15000.0n 0.5043 15599.5n 0.5043 15600.0n 0.5067 16199.5n 0.5067 16200.0n 0.5068 16799.5n 0.5068 16800.0n 0.5066 17399.5n 0.5066 17400.0n 0.5069 17999.5n 0.5069 18000.0n 0.5061 18599.5n 0.5061 18600.0n 0.5034 19199.5n 0.5034 19200.0n 0.5010 19799.5n 0.5010 19800.0n 0.4989 20399.5n 0.4989 20400.0n 0.5022 20999.5n 0.5022 21000.0n 0.5086 21599.5n 0.5086 21600.0n 0.5007 22199.5n 0.5007 22200.0n 0.5023 22799.5n 0.5023 22800.0n 0.5021 23399.5n 0.5021 23400.0n 0.5077 23999.5n 0.5077 24000.0n 0.4979 24599.5n 0.4979 24600.0n 0.5035 25199.5n 0.5035 25200.0n 0.5041 25799.5n 0.5041 25800.0n 0.5075 26399.5n 0.5075 26400.0n 0.5041 26999.5n 0.5041 27000.0n 0.5056 27599.5n 0.5056 27600.0n 0.5039 28199.5n 0.5039 28200.0n 0.5059 28799.5n 0.5059 28800.0n 0.5023 29399.5n 0.5023 29400.0n 0.5086 29999.5n 0.5086 30000.0n 0.5084 30599.5n 0.5084 30600.0n 0.5085 31199.5n 0.5085 31200.0n 0.5088 31799.5n 0.5088 31800.0n 0.5078 32399.5n 0.5078 32400.0n 0.5074 32999.5n 0.5074 33000.0n 0.4996 33599.5n 0.4996 33600.0n 0.5010 34199.5n 0.5010 34200.0n 0.5044 34799.5n 0.5044 34800.0n 0.5084 35399.5n 0.5084 35400.0n 0.5012 35999.5n 0.5012)
Vyn_who_9_1 yn_who_9_1 0 PWL(0.0n 0.4929 599.5n 0.4929 600.0n 0.4947 1199.5n 0.4947 1200.0n 0.4948 1799.5n 0.4948 1800.0n 0.4973 2399.5n 0.4973 2400.0n 0.4966 2999.5n 0.4966 3000.0n 0.4945 3599.5n 0.4945 3600.0n 0.4944 4199.5n 0.4944 4200.0n 0.4929 4799.5n 0.4929 4800.0n 0.4944 5399.5n 0.4944 5400.0n 0.4944 5999.5n 0.4944 6000.0n 0.4952 6599.5n 0.4952 6600.0n 0.4940 7199.5n 0.4940 7200.0n 0.4952 7799.5n 0.4952 7800.0n 0.4954 8399.5n 0.4954 8400.0n 0.4934 8999.5n 0.4934 9000.0n 0.4944 9599.5n 0.4944 9600.0n 0.4949 10199.5n 0.4949 10200.0n 0.4954 10799.5n 0.4954 10800.0n 0.4944 11399.5n 0.4944 11400.0n 0.4942 11999.5n 0.4942 12000.0n 0.4932 12599.5n 0.4932 12600.0n 0.4950 13199.5n 0.4950 13200.0n 0.4929 13799.5n 0.4929 13800.0n 0.4941 14399.5n 0.4941 14400.0n 0.4942 14999.5n 0.4942 15000.0n 0.4957 15599.5n 0.4957 15600.0n 0.4933 16199.5n 0.4933 16200.0n 0.4932 16799.5n 0.4932 16800.0n 0.4934 17399.5n 0.4934 17400.0n 0.4931 17999.5n 0.4931 18000.0n 0.4939 18599.5n 0.4939 18600.0n 0.4966 19199.5n 0.4966 19200.0n 0.4990 19799.5n 0.4990 19800.0n 0.5011 20399.5n 0.5011 20400.0n 0.4978 20999.5n 0.4978 21000.0n 0.4914 21599.5n 0.4914 21600.0n 0.4993 22199.5n 0.4993 22200.0n 0.4977 22799.5n 0.4977 22800.0n 0.4979 23399.5n 0.4979 23400.0n 0.4923 23999.5n 0.4923 24000.0n 0.5021 24599.5n 0.5021 24600.0n 0.4965 25199.5n 0.4965 25200.0n 0.4959 25799.5n 0.4959 25800.0n 0.4925 26399.5n 0.4925 26400.0n 0.4959 26999.5n 0.4959 27000.0n 0.4944 27599.5n 0.4944 27600.0n 0.4961 28199.5n 0.4961 28200.0n 0.4941 28799.5n 0.4941 28800.0n 0.4977 29399.5n 0.4977 29400.0n 0.4914 29999.5n 0.4914 30000.0n 0.4916 30599.5n 0.4916 30600.0n 0.4915 31199.5n 0.4915 31200.0n 0.4912 31799.5n 0.4912 31800.0n 0.4922 32399.5n 0.4922 32400.0n 0.4926 32999.5n 0.4926 33000.0n 0.5004 33599.5n 0.5004 33600.0n 0.4990 34199.5n 0.4990 34200.0n 0.4956 34799.5n 0.4956 34800.0n 0.4916 35399.5n 0.4916 35400.0n 0.4988 35999.5n 0.4988)
Cwp_who_9_1 wp_who_9_1 0 400p
Cwn_who_9_1 wn_who_9_1 0 400p
Xu_who_9_1 xp_who_9_1 xn_who_9_1 yp_who_9_1 yn_who_9_1 wp_who_9_1 wn_who_9_1 vdd gbn gprod
Vxp_bh_9 xp_bh_9 0 PWL(0.0n 0.7100 599.5n 0.7100 600.0n 0.7100 1199.5n 0.7100 1200.0n 0.7100 1799.5n 0.7100 1800.0n 0.7100 2399.5n 0.7100 2400.0n 0.7100 2999.5n 0.7100 3000.0n 0.7100 3599.5n 0.7100 3600.0n 0.7100 4199.5n 0.7100 4200.0n 0.7100 4799.5n 0.7100 4800.0n 0.7100 5399.5n 0.7100 5400.0n 0.7100 5999.5n 0.7100 6000.0n 0.7100 6599.5n 0.7100 6600.0n 0.7100 7199.5n 0.7100 7200.0n 0.7100 7799.5n 0.7100 7800.0n 0.7100 8399.5n 0.7100 8400.0n 0.7100 8999.5n 0.7100 9000.0n 0.7100 9599.5n 0.7100 9600.0n 0.7100 10199.5n 0.7100 10200.0n 0.7100 10799.5n 0.7100 10800.0n 0.7100 11399.5n 0.7100 11400.0n 0.7100 11999.5n 0.7100 12000.0n 0.7100 12599.5n 0.7100 12600.0n 0.7100 13199.5n 0.7100 13200.0n 0.7100 13799.5n 0.7100 13800.0n 0.7100 14399.5n 0.7100 14400.0n 0.7100 14999.5n 0.7100 15000.0n 0.7100 15599.5n 0.7100 15600.0n 0.7100 16199.5n 0.7100 16200.0n 0.7100 16799.5n 0.7100 16800.0n 0.7100 17399.5n 0.7100 17400.0n 0.7100 17999.5n 0.7100 18000.0n 0.7100 18599.5n 0.7100 18600.0n 0.7100 19199.5n 0.7100 19200.0n 0.7100 19799.5n 0.7100 19800.0n 0.7100 20399.5n 0.7100 20400.0n 0.7100 20999.5n 0.7100 21000.0n 0.7100 21599.5n 0.7100 21600.0n 0.7100 22199.5n 0.7100 22200.0n 0.7100 22799.5n 0.7100 22800.0n 0.7100 23399.5n 0.7100 23400.0n 0.7100 23999.5n 0.7100 24000.0n 0.7100 24599.5n 0.7100 24600.0n 0.7100 25199.5n 0.7100 25200.0n 0.7100 25799.5n 0.7100 25800.0n 0.7100 26399.5n 0.7100 26400.0n 0.7100 26999.5n 0.7100 27000.0n 0.7100 27599.5n 0.7100 27600.0n 0.7100 28199.5n 0.7100 28200.0n 0.7100 28799.5n 0.7100 28800.0n 0.7100 29399.5n 0.7100 29400.0n 0.7100 29999.5n 0.7100 30000.0n 0.7100 30599.5n 0.7100 30600.0n 0.7100 31199.5n 0.7100 31200.0n 0.7100 31799.5n 0.7100 31800.0n 0.7100 32399.5n 0.7100 32400.0n 0.7100 32999.5n 0.7100 33000.0n 0.7100 33599.5n 0.7100 33600.0n 0.7100 34199.5n 0.7100 34200.0n 0.7100 34799.5n 0.7100 34800.0n 0.7100 35399.5n 0.7100 35400.0n 0.7100 35999.5n 0.7100)
Vxn_bh_9 xn_bh_9 0 PWL(0.0n 0.2900 599.5n 0.2900 600.0n 0.2900 1199.5n 0.2900 1200.0n 0.2900 1799.5n 0.2900 1800.0n 0.2900 2399.5n 0.2900 2400.0n 0.2900 2999.5n 0.2900 3000.0n 0.2900 3599.5n 0.2900 3600.0n 0.2900 4199.5n 0.2900 4200.0n 0.2900 4799.5n 0.2900 4800.0n 0.2900 5399.5n 0.2900 5400.0n 0.2900 5999.5n 0.2900 6000.0n 0.2900 6599.5n 0.2900 6600.0n 0.2900 7199.5n 0.2900 7200.0n 0.2900 7799.5n 0.2900 7800.0n 0.2900 8399.5n 0.2900 8400.0n 0.2900 8999.5n 0.2900 9000.0n 0.2900 9599.5n 0.2900 9600.0n 0.2900 10199.5n 0.2900 10200.0n 0.2900 10799.5n 0.2900 10800.0n 0.2900 11399.5n 0.2900 11400.0n 0.2900 11999.5n 0.2900 12000.0n 0.2900 12599.5n 0.2900 12600.0n 0.2900 13199.5n 0.2900 13200.0n 0.2900 13799.5n 0.2900 13800.0n 0.2900 14399.5n 0.2900 14400.0n 0.2900 14999.5n 0.2900 15000.0n 0.2900 15599.5n 0.2900 15600.0n 0.2900 16199.5n 0.2900 16200.0n 0.2900 16799.5n 0.2900 16800.0n 0.2900 17399.5n 0.2900 17400.0n 0.2900 17999.5n 0.2900 18000.0n 0.2900 18599.5n 0.2900 18600.0n 0.2900 19199.5n 0.2900 19200.0n 0.2900 19799.5n 0.2900 19800.0n 0.2900 20399.5n 0.2900 20400.0n 0.2900 20999.5n 0.2900 21000.0n 0.2900 21599.5n 0.2900 21600.0n 0.2900 22199.5n 0.2900 22200.0n 0.2900 22799.5n 0.2900 22800.0n 0.2900 23399.5n 0.2900 23400.0n 0.2900 23999.5n 0.2900 24000.0n 0.2900 24599.5n 0.2900 24600.0n 0.2900 25199.5n 0.2900 25200.0n 0.2900 25799.5n 0.2900 25800.0n 0.2900 26399.5n 0.2900 26400.0n 0.2900 26999.5n 0.2900 27000.0n 0.2900 27599.5n 0.2900 27600.0n 0.2900 28199.5n 0.2900 28200.0n 0.2900 28799.5n 0.2900 28800.0n 0.2900 29399.5n 0.2900 29400.0n 0.2900 29999.5n 0.2900 30000.0n 0.2900 30599.5n 0.2900 30600.0n 0.2900 31199.5n 0.2900 31200.0n 0.2900 31799.5n 0.2900 31800.0n 0.2900 32399.5n 0.2900 32400.0n 0.2900 32999.5n 0.2900 33000.0n 0.2900 33599.5n 0.2900 33600.0n 0.2900 34199.5n 0.2900 34200.0n 0.2900 34799.5n 0.2900 34800.0n 0.2900 35399.5n 0.2900 35400.0n 0.2900 35999.5n 0.2900)
Vyp_bh_9 yp_bh_9 0 PWL(0.0n 0.3412 599.5n 0.3412 600.0n 0.3524 1199.5n 0.3524 1200.0n 0.3586 1799.5n 0.3586 1800.0n 0.4217 2399.5n 0.4217 2400.0n 0.4032 2999.5n 0.4032 3000.0n 0.3521 3599.5n 0.3521 3600.0n 0.3520 4199.5n 0.3520 4200.0n 0.3404 4799.5n 0.3404 4800.0n 0.3515 5399.5n 0.3515 5400.0n 0.3519 5999.5n 0.3519 6000.0n 0.3684 6599.5n 0.3684 6600.0n 0.3478 7199.5n 0.3478 7200.0n 0.3589 7799.5n 0.3589 7800.0n 0.3639 8399.5n 0.3639 8400.0n 0.3412 8999.5n 0.3412 9000.0n 0.3516 9599.5n 0.3516 9600.0n 0.3586 10199.5n 0.3586 10200.0n 0.3695 10799.5n 0.3695 10800.0n 0.3549 11399.5n 0.3549 11400.0n 0.3498 11999.5n 0.3498 12000.0n 0.3392 12599.5n 0.3392 12600.0n 0.3607 13199.5n 0.3607 13200.0n 0.3413 13799.5n 0.3413 13800.0n 0.3481 14399.5n 0.3481 14400.0n 0.3494 14999.5n 0.3494 15000.0n 0.3807 15599.5n 0.3807 15600.0n 0.3429 16199.5n 0.3429 16200.0n 0.3427 16799.5n 0.3427 16800.0n 0.3414 17399.5n 0.3414 17400.0n 0.3428 17999.5n 0.3428 18000.0n 0.4286 18599.5n 0.4286 18600.0n 0.3716 19199.5n 0.3716 19200.0n 0.4809 19799.5n 0.4809 19800.0n 0.4858 20399.5n 0.4858 20400.0n 0.4749 20999.5n 0.4749 21000.0n 0.3488 21599.5n 0.3488 21600.0n 0.4411 22199.5n 0.4411 22200.0n 0.3827 22799.5n 0.3827 22800.0n 0.4955 23399.5n 0.4955 23400.0n 0.3241 23999.5n 0.3241 24000.0n 0.5209 24599.5n 0.5209 24600.0n 0.3607 25199.5n 0.3607 25200.0n 0.4564 25799.5n 0.4564 25800.0n 0.4409 26399.5n 0.4409 26400.0n 0.4780 26999.5n 0.4780 27000.0n 0.4470 27599.5n 0.4470 27600.0n 0.4794 28199.5n 0.4794 28200.0n 0.3293 28799.5n 0.3293 28800.0n 0.4828 29399.5n 0.4828 29400.0n 0.3444 29999.5n 0.3444 30000.0n 0.3384 30599.5n 0.3384 30600.0n 0.3174 31199.5n 0.3174 31200.0n 0.3222 31799.5n 0.3222 31800.0n 0.4291 32399.5n 0.4291 32400.0n 0.4439 32999.5n 0.4439 33000.0n 0.5002 33599.5n 0.5002 33600.0n 0.4999 34199.5n 0.4999 34200.0n 0.3486 34799.5n 0.3486 34800.0n 0.3297 35399.5n 0.3297 35400.0n 0.4862 35999.5n 0.4862)
Vyn_bh_9 yn_bh_9 0 PWL(0.0n 0.6588 599.5n 0.6588 600.0n 0.6476 1199.5n 0.6476 1200.0n 0.6414 1799.5n 0.6414 1800.0n 0.5783 2399.5n 0.5783 2400.0n 0.5968 2999.5n 0.5968 3000.0n 0.6479 3599.5n 0.6479 3600.0n 0.6480 4199.5n 0.6480 4200.0n 0.6596 4799.5n 0.6596 4800.0n 0.6485 5399.5n 0.6485 5400.0n 0.6481 5999.5n 0.6481 6000.0n 0.6316 6599.5n 0.6316 6600.0n 0.6522 7199.5n 0.6522 7200.0n 0.6411 7799.5n 0.6411 7800.0n 0.6361 8399.5n 0.6361 8400.0n 0.6588 8999.5n 0.6588 9000.0n 0.6484 9599.5n 0.6484 9600.0n 0.6414 10199.5n 0.6414 10200.0n 0.6305 10799.5n 0.6305 10800.0n 0.6451 11399.5n 0.6451 11400.0n 0.6502 11999.5n 0.6502 12000.0n 0.6608 12599.5n 0.6608 12600.0n 0.6393 13199.5n 0.6393 13200.0n 0.6587 13799.5n 0.6587 13800.0n 0.6519 14399.5n 0.6519 14400.0n 0.6506 14999.5n 0.6506 15000.0n 0.6193 15599.5n 0.6193 15600.0n 0.6571 16199.5n 0.6571 16200.0n 0.6573 16799.5n 0.6573 16800.0n 0.6586 17399.5n 0.6586 17400.0n 0.6572 17999.5n 0.6572 18000.0n 0.5714 18599.5n 0.5714 18600.0n 0.6284 19199.5n 0.6284 19200.0n 0.5191 19799.5n 0.5191 19800.0n 0.5142 20399.5n 0.5142 20400.0n 0.5251 20999.5n 0.5251 21000.0n 0.6512 21599.5n 0.6512 21600.0n 0.5589 22199.5n 0.5589 22200.0n 0.6173 22799.5n 0.6173 22800.0n 0.5045 23399.5n 0.5045 23400.0n 0.6759 23999.5n 0.6759 24000.0n 0.4791 24599.5n 0.4791 24600.0n 0.6393 25199.5n 0.6393 25200.0n 0.5436 25799.5n 0.5436 25800.0n 0.5591 26399.5n 0.5591 26400.0n 0.5220 26999.5n 0.5220 27000.0n 0.5530 27599.5n 0.5530 27600.0n 0.5206 28199.5n 0.5206 28200.0n 0.6707 28799.5n 0.6707 28800.0n 0.5172 29399.5n 0.5172 29400.0n 0.6556 29999.5n 0.6556 30000.0n 0.6616 30599.5n 0.6616 30600.0n 0.6826 31199.5n 0.6826 31200.0n 0.6778 31799.5n 0.6778 31800.0n 0.5709 32399.5n 0.5709 32400.0n 0.5561 32999.5n 0.5561 33000.0n 0.4998 33599.5n 0.4998 33600.0n 0.5001 34199.5n 0.5001 34200.0n 0.6514 34799.5n 0.6514 34800.0n 0.6703 35399.5n 0.6703 35400.0n 0.5138 35999.5n 0.5138)
Cwp_bh_9 wp_bh_9 0 400p
Cwn_bh_9 wn_bh_9 0 400p
Xu_bh_9 xp_bh_9 xn_bh_9 yp_bh_9 yn_bh_9 wp_bh_9 wn_bh_9 vdd gbn gprod
Vxp_wih_0_10 xp_wih_0_10 0 PWL(0.0n 0.4942 599.5n 0.4942 600.0n 0.5558 1199.5n 0.5558 1200.0n 0.4708 1799.5n 0.4708 1800.0n 0.5235 2399.5n 0.5235 2400.0n 0.5350 2999.5n 0.5350 3000.0n 0.5172 3599.5n 0.5172 3600.0n 0.4702 4199.5n 0.4702 4200.0n 0.4867 4799.5n 0.4867 4800.0n 0.4970 5399.5n 0.4970 5400.0n 0.4986 5999.5n 0.4986 6000.0n 0.4751 6599.5n 0.4751 6600.0n 0.4870 7199.5n 0.4870 7200.0n 0.5502 7799.5n 0.5502 7800.0n 0.5521 8399.5n 0.5521 8400.0n 0.4638 8999.5n 0.4638 9000.0n 0.4982 9599.5n 0.4982 9600.0n 0.5131 10199.5n 0.5131 10200.0n 0.5386 10799.5n 0.5386 10800.0n 0.4592 11399.5n 0.4592 11400.0n 0.4950 11999.5n 0.4950 12000.0n 0.4559 12599.5n 0.4559 12600.0n 0.5162 13199.5n 0.5162 13200.0n 0.5038 13799.5n 0.5038 13800.0n 0.5333 14399.5n 0.5333 14400.0n 0.4991 14999.5n 0.4991 15000.0n 0.5298 15599.5n 0.5298 15600.0n 0.4823 16199.5n 0.4823 16200.0n 0.5239 16799.5n 0.5239 16800.0n 0.4592 17399.5n 0.4592 17400.0n 0.5094 17999.5n 0.5094 18000.0n 0.4337 18599.5n 0.4337 18600.0n 0.5977 19199.5n 0.5977 19200.0n 0.5364 19799.5n 0.5364 19800.0n 0.6122 20399.5n 0.6122 20400.0n 0.4856 20999.5n 0.4856 21000.0n 0.3861 21599.5n 0.3861 21600.0n 0.6094 22199.5n 0.6094 22200.0n 0.6364 22799.5n 0.6364 22800.0n 0.4807 23399.5n 0.4807 23400.0n 0.5614 23999.5n 0.5614 24000.0n 0.5913 24599.5n 0.5913 24600.0n 0.6295 25199.5n 0.6295 25200.0n 0.4496 25799.5n 0.4496 25800.0n 0.3792 26399.5n 0.3792 26400.0n 0.4434 26999.5n 0.4434 27000.0n 0.4340 27599.5n 0.4340 27600.0n 0.4461 28199.5n 0.4461 28200.0n 0.5791 28799.5n 0.5791 28800.0n 0.4777 29399.5n 0.4777 29400.0n 0.3878 29999.5n 0.3878 30000.0n 0.3832 30599.5n 0.3832 30600.0n 0.4022 31199.5n 0.4022 31200.0n 0.4482 31799.5n 0.4482 31800.0n 0.3662 32399.5n 0.3662 32400.0n 0.3857 32999.5n 0.3857 33000.0n 0.5584 33599.5n 0.5584 33600.0n 0.5284 34199.5n 0.5284 34200.0n 0.6034 34799.5n 0.6034 34800.0n 0.3469 35399.5n 0.3469 35400.0n 0.5290 35999.5n 0.5290)
Vxn_wih_0_10 xn_wih_0_10 0 PWL(0.0n 0.5058 599.5n 0.5058 600.0n 0.4442 1199.5n 0.4442 1200.0n 0.5292 1799.5n 0.5292 1800.0n 0.4765 2399.5n 0.4765 2400.0n 0.4650 2999.5n 0.4650 3000.0n 0.4828 3599.5n 0.4828 3600.0n 0.5298 4199.5n 0.5298 4200.0n 0.5133 4799.5n 0.5133 4800.0n 0.5030 5399.5n 0.5030 5400.0n 0.5014 5999.5n 0.5014 6000.0n 0.5249 6599.5n 0.5249 6600.0n 0.5130 7199.5n 0.5130 7200.0n 0.4498 7799.5n 0.4498 7800.0n 0.4479 8399.5n 0.4479 8400.0n 0.5362 8999.5n 0.5362 9000.0n 0.5018 9599.5n 0.5018 9600.0n 0.4869 10199.5n 0.4869 10200.0n 0.4614 10799.5n 0.4614 10800.0n 0.5408 11399.5n 0.5408 11400.0n 0.5050 11999.5n 0.5050 12000.0n 0.5441 12599.5n 0.5441 12600.0n 0.4838 13199.5n 0.4838 13200.0n 0.4962 13799.5n 0.4962 13800.0n 0.4667 14399.5n 0.4667 14400.0n 0.5009 14999.5n 0.5009 15000.0n 0.4702 15599.5n 0.4702 15600.0n 0.5177 16199.5n 0.5177 16200.0n 0.4761 16799.5n 0.4761 16800.0n 0.5408 17399.5n 0.5408 17400.0n 0.4906 17999.5n 0.4906 18000.0n 0.5663 18599.5n 0.5663 18600.0n 0.4023 19199.5n 0.4023 19200.0n 0.4636 19799.5n 0.4636 19800.0n 0.3878 20399.5n 0.3878 20400.0n 0.5144 20999.5n 0.5144 21000.0n 0.6139 21599.5n 0.6139 21600.0n 0.3906 22199.5n 0.3906 22200.0n 0.3636 22799.5n 0.3636 22800.0n 0.5193 23399.5n 0.5193 23400.0n 0.4386 23999.5n 0.4386 24000.0n 0.4087 24599.5n 0.4087 24600.0n 0.3705 25199.5n 0.3705 25200.0n 0.5504 25799.5n 0.5504 25800.0n 0.6208 26399.5n 0.6208 26400.0n 0.5566 26999.5n 0.5566 27000.0n 0.5660 27599.5n 0.5660 27600.0n 0.5539 28199.5n 0.5539 28200.0n 0.4209 28799.5n 0.4209 28800.0n 0.5223 29399.5n 0.5223 29400.0n 0.6122 29999.5n 0.6122 30000.0n 0.6168 30599.5n 0.6168 30600.0n 0.5978 31199.5n 0.5978 31200.0n 0.5518 31799.5n 0.5518 31800.0n 0.6338 32399.5n 0.6338 32400.0n 0.6143 32999.5n 0.6143 33000.0n 0.4416 33599.5n 0.4416 33600.0n 0.4716 34199.5n 0.4716 34200.0n 0.3966 34799.5n 0.3966 34800.0n 0.6531 35399.5n 0.6531 35400.0n 0.4710 35999.5n 0.4710)
Vyp_wih_0_10 yp_wih_0_10 0 PWL(0.0n 0.6543 599.5n 0.6543 600.0n 0.6347 1199.5n 0.6347 1200.0n 0.6282 1799.5n 0.6282 1800.0n 0.5762 2399.5n 0.5762 2400.0n 0.5898 2999.5n 0.5898 3000.0n 0.6383 3599.5n 0.6383 3600.0n 0.6396 4199.5n 0.6396 4200.0n 0.6553 4799.5n 0.6553 4800.0n 0.6402 5399.5n 0.6402 5400.0n 0.6393 5999.5n 0.6393 6000.0n 0.6191 6599.5n 0.6191 6600.0n 0.6463 7199.5n 0.6463 7200.0n 0.6251 7799.5n 0.6251 7800.0n 0.6202 8399.5n 0.6202 8400.0n 0.6548 8999.5n 0.6548 9000.0n 0.6399 9599.5n 0.6399 9600.0n 0.6273 10199.5n 0.6273 10200.0n 0.6165 10799.5n 0.6165 10800.0n 0.6337 11399.5n 0.6337 11400.0n 0.6433 11999.5n 0.6433 12000.0n 0.6572 12599.5n 0.6572 12600.0n 0.6246 13199.5n 0.6246 13200.0n 0.6540 13799.5n 0.6540 13800.0n 0.6451 14399.5n 0.6451 14400.0n 0.6438 14999.5n 0.6438 15000.0n 0.6076 15599.5n 0.6076 15600.0n 0.6525 16199.5n 0.6525 16200.0n 0.6522 16799.5n 0.6522 16800.0n 0.6546 17399.5n 0.6546 17400.0n 0.6523 17999.5n 0.6523 18000.0n 0.5693 18599.5n 0.5693 18600.0n 0.6112 19199.5n 0.6112 19200.0n 0.5263 19799.5n 0.5263 19800.0n 0.5206 20399.5n 0.5206 20400.0n 0.5320 20999.5n 0.5320 21000.0n 0.6464 21599.5n 0.6464 21600.0n 0.5573 22199.5n 0.5573 22200.0n 0.6032 22799.5n 0.6032 22800.0n 0.5163 23399.5n 0.5163 23400.0n 0.6717 23999.5n 0.6717 24000.0n 0.4913 24599.5n 0.4913 24600.0n 0.6197 25199.5n 0.6197 25200.0n 0.5475 25799.5n 0.5475 25800.0n 0.5620 26399.5n 0.5620 26400.0n 0.5309 26999.5n 0.5309 27000.0n 0.5552 27599.5n 0.5552 27600.0n 0.5297 28199.5n 0.5297 28200.0n 0.6664 28799.5n 0.6664 28800.0n 0.5259 29399.5n 0.5259 29400.0n 0.6521 29999.5n 0.6521 30000.0n 0.6590 30599.5n 0.6590 30600.0n 0.6800 31199.5n 0.6800 31200.0n 0.6747 31799.5n 0.6747 31800.0n 0.5714 32399.5n 0.5714 32400.0n 0.5596 32999.5n 0.5596 33000.0n 0.5100 33599.5n 0.5100 33600.0n 0.5106 34199.5n 0.5106 34200.0n 0.6376 34799.5n 0.6376 34800.0n 0.6680 35399.5n 0.6680 35400.0n 0.5218 35999.5n 0.5218)
Vyn_wih_0_10 yn_wih_0_10 0 PWL(0.0n 0.3457 599.5n 0.3457 600.0n 0.3653 1199.5n 0.3653 1200.0n 0.3718 1799.5n 0.3718 1800.0n 0.4238 2399.5n 0.4238 2400.0n 0.4102 2999.5n 0.4102 3000.0n 0.3617 3599.5n 0.3617 3600.0n 0.3604 4199.5n 0.3604 4200.0n 0.3447 4799.5n 0.3447 4800.0n 0.3598 5399.5n 0.3598 5400.0n 0.3607 5999.5n 0.3607 6000.0n 0.3809 6599.5n 0.3809 6600.0n 0.3537 7199.5n 0.3537 7200.0n 0.3749 7799.5n 0.3749 7800.0n 0.3798 8399.5n 0.3798 8400.0n 0.3452 8999.5n 0.3452 9000.0n 0.3601 9599.5n 0.3601 9600.0n 0.3727 10199.5n 0.3727 10200.0n 0.3835 10799.5n 0.3835 10800.0n 0.3663 11399.5n 0.3663 11400.0n 0.3567 11999.5n 0.3567 12000.0n 0.3428 12599.5n 0.3428 12600.0n 0.3754 13199.5n 0.3754 13200.0n 0.3460 13799.5n 0.3460 13800.0n 0.3549 14399.5n 0.3549 14400.0n 0.3562 14999.5n 0.3562 15000.0n 0.3924 15599.5n 0.3924 15600.0n 0.3475 16199.5n 0.3475 16200.0n 0.3478 16799.5n 0.3478 16800.0n 0.3454 17399.5n 0.3454 17400.0n 0.3477 17999.5n 0.3477 18000.0n 0.4307 18599.5n 0.4307 18600.0n 0.3888 19199.5n 0.3888 19200.0n 0.4737 19799.5n 0.4737 19800.0n 0.4794 20399.5n 0.4794 20400.0n 0.4680 20999.5n 0.4680 21000.0n 0.3536 21599.5n 0.3536 21600.0n 0.4427 22199.5n 0.4427 22200.0n 0.3968 22799.5n 0.3968 22800.0n 0.4837 23399.5n 0.4837 23400.0n 0.3283 23999.5n 0.3283 24000.0n 0.5087 24599.5n 0.5087 24600.0n 0.3803 25199.5n 0.3803 25200.0n 0.4525 25799.5n 0.4525 25800.0n 0.4380 26399.5n 0.4380 26400.0n 0.4691 26999.5n 0.4691 27000.0n 0.4448 27599.5n 0.4448 27600.0n 0.4703 28199.5n 0.4703 28200.0n 0.3336 28799.5n 0.3336 28800.0n 0.4741 29399.5n 0.4741 29400.0n 0.3479 29999.5n 0.3479 30000.0n 0.3410 30599.5n 0.3410 30600.0n 0.3200 31199.5n 0.3200 31200.0n 0.3253 31799.5n 0.3253 31800.0n 0.4286 32399.5n 0.4286 32400.0n 0.4404 32999.5n 0.4404 33000.0n 0.4900 33599.5n 0.4900 33600.0n 0.4894 34199.5n 0.4894 34200.0n 0.3624 34799.5n 0.3624 34800.0n 0.3320 35399.5n 0.3320 35400.0n 0.4782 35999.5n 0.4782)
Cwp_wih_0_10 wp_wih_0_10 0 400p
Cwn_wih_0_10 wn_wih_0_10 0 400p
Xu_wih_0_10 xp_wih_0_10 xn_wih_0_10 yp_wih_0_10 yn_wih_0_10 wp_wih_0_10 wn_wih_0_10 vdd gbn gprod
Vxp_wih_1_10 xp_wih_1_10 0 PWL(0.0n 0.5370 599.5n 0.5370 600.0n 0.5167 1199.5n 0.5167 1200.0n 0.4793 1799.5n 0.4793 1800.0n 0.4441 2399.5n 0.4441 2400.0n 0.4555 2999.5n 0.4555 3000.0n 0.5055 3599.5n 0.5055 3600.0n 0.4939 4199.5n 0.4939 4200.0n 0.5385 4799.5n 0.5385 4800.0n 0.5024 5399.5n 0.5024 5400.0n 0.5015 5999.5n 0.5015 6000.0n 0.4700 6599.5n 0.4700 6600.0n 0.5120 7199.5n 0.5120 7200.0n 0.5006 7799.5n 0.5006 7800.0n 0.4950 8399.5n 0.4950 8400.0n 0.5309 8999.5n 0.5309 9000.0n 0.5023 9599.5n 0.5023 9600.0n 0.4893 10199.5n 0.4893 10200.0n 0.4837 10799.5n 0.4837 10800.0n 0.4823 11399.5n 0.4823 11400.0n 0.5074 11999.5n 0.5074 12000.0n 0.5364 12599.5n 0.5364 12600.0n 0.4868 13199.5n 0.4868 13200.0n 0.5380 13799.5n 0.5380 13800.0n 0.5220 14399.5n 0.5220 14400.0n 0.5095 14999.5n 0.5095 15000.0n 0.4705 15599.5n 0.4705 15600.0n 0.5289 16199.5n 0.5289 16200.0n 0.5368 16799.5n 0.5368 16800.0n 0.5287 17399.5n 0.5287 17400.0n 0.5342 17999.5n 0.5342 18000.0n 0.4253 18599.5n 0.4253 18600.0n 0.5119 19199.5n 0.5119 19200.0n 0.4104 19799.5n 0.4104 19800.0n 0.4314 20399.5n 0.4314 20400.0n 0.4005 20999.5n 0.4005 21000.0n 0.4696 21599.5n 0.4696 21600.0n 0.4531 22199.5n 0.4531 22200.0n 0.5039 22799.5n 0.5039 22800.0n 0.3608 23399.5n 0.3608 23400.0n 0.6273 23999.5n 0.6273 24000.0n 0.3928 24599.5n 0.3928 24600.0n 0.5253 25199.5n 0.5253 25200.0n 0.4107 25799.5n 0.4107 25800.0n 0.3947 26399.5n 0.3947 26400.0n 0.3716 26999.5n 0.3716 27000.0n 0.4111 27599.5n 0.4111 27600.0n 0.3715 28199.5n 0.3715 28200.0n 0.5939 28799.5n 0.5939 28800.0n 0.3849 29399.5n 0.3849 29400.0n 0.4835 29999.5n 0.4835 30000.0n 0.5119 30599.5n 0.5119 30600.0n 0.6226 31199.5n 0.6226 31200.0n 0.6064 31799.5n 0.6064 31800.0n 0.4115 32399.5n 0.4115 32400.0n 0.3900 32999.5n 0.3900 33000.0n 0.3958 33599.5n 0.3958 33600.0n 0.3747 34199.5n 0.3747 34200.0n 0.5423 34799.5n 0.5423 34800.0n 0.5509 35399.5n 0.5509 35400.0n 0.3990 35999.5n 0.3990)
Vxn_wih_1_10 xn_wih_1_10 0 PWL(0.0n 0.4630 599.5n 0.4630 600.0n 0.4833 1199.5n 0.4833 1200.0n 0.5207 1799.5n 0.5207 1800.0n 0.5559 2399.5n 0.5559 2400.0n 0.5445 2999.5n 0.5445 3000.0n 0.4945 3599.5n 0.4945 3600.0n 0.5061 4199.5n 0.5061 4200.0n 0.4615 4799.5n 0.4615 4800.0n 0.4976 5399.5n 0.4976 5400.0n 0.4985 5999.5n 0.4985 6000.0n 0.5300 6599.5n 0.5300 6600.0n 0.4880 7199.5n 0.4880 7200.0n 0.4994 7799.5n 0.4994 7800.0n 0.5050 8399.5n 0.5050 8400.0n 0.4691 8999.5n 0.4691 9000.0n 0.4977 9599.5n 0.4977 9600.0n 0.5107 10199.5n 0.5107 10200.0n 0.5163 10799.5n 0.5163 10800.0n 0.5177 11399.5n 0.5177 11400.0n 0.4926 11999.5n 0.4926 12000.0n 0.4636 12599.5n 0.4636 12600.0n 0.5132 13199.5n 0.5132 13200.0n 0.4620 13799.5n 0.4620 13800.0n 0.4780 14399.5n 0.4780 14400.0n 0.4905 14999.5n 0.4905 15000.0n 0.5295 15599.5n 0.5295 15600.0n 0.4711 16199.5n 0.4711 16200.0n 0.4632 16799.5n 0.4632 16800.0n 0.4713 17399.5n 0.4713 17400.0n 0.4658 17999.5n 0.4658 18000.0n 0.5747 18599.5n 0.5747 18600.0n 0.4881 19199.5n 0.4881 19200.0n 0.5896 19799.5n 0.5896 19800.0n 0.5686 20399.5n 0.5686 20400.0n 0.5995 20999.5n 0.5995 21000.0n 0.5304 21599.5n 0.5304 21600.0n 0.5469 22199.5n 0.5469 22200.0n 0.4961 22799.5n 0.4961 22800.0n 0.6392 23399.5n 0.6392 23400.0n 0.3727 23999.5n 0.3727 24000.0n 0.6072 24599.5n 0.6072 24600.0n 0.4747 25199.5n 0.4747 25200.0n 0.5893 25799.5n 0.5893 25800.0n 0.6053 26399.5n 0.6053 26400.0n 0.6284 26999.5n 0.6284 27000.0n 0.5889 27599.5n 0.5889 27600.0n 0.6285 28199.5n 0.6285 28200.0n 0.4061 28799.5n 0.4061 28800.0n 0.6151 29399.5n 0.6151 29400.0n 0.5165 29999.5n 0.5165 30000.0n 0.4881 30599.5n 0.4881 30600.0n 0.3774 31199.5n 0.3774 31200.0n 0.3936 31799.5n 0.3936 31800.0n 0.5885 32399.5n 0.5885 32400.0n 0.6100 32999.5n 0.6100 33000.0n 0.6042 33599.5n 0.6042 33600.0n 0.6253 34199.5n 0.6253 34200.0n 0.4577 34799.5n 0.4577 34800.0n 0.4491 35399.5n 0.4491 35400.0n 0.6010 35999.5n 0.6010)
Vyp_wih_1_10 yp_wih_1_10 0 PWL(0.0n 0.6543 599.5n 0.6543 600.0n 0.6347 1199.5n 0.6347 1200.0n 0.6282 1799.5n 0.6282 1800.0n 0.5762 2399.5n 0.5762 2400.0n 0.5898 2999.5n 0.5898 3000.0n 0.6383 3599.5n 0.6383 3600.0n 0.6396 4199.5n 0.6396 4200.0n 0.6553 4799.5n 0.6553 4800.0n 0.6402 5399.5n 0.6402 5400.0n 0.6393 5999.5n 0.6393 6000.0n 0.6191 6599.5n 0.6191 6600.0n 0.6463 7199.5n 0.6463 7200.0n 0.6251 7799.5n 0.6251 7800.0n 0.6202 8399.5n 0.6202 8400.0n 0.6548 8999.5n 0.6548 9000.0n 0.6399 9599.5n 0.6399 9600.0n 0.6273 10199.5n 0.6273 10200.0n 0.6165 10799.5n 0.6165 10800.0n 0.6337 11399.5n 0.6337 11400.0n 0.6433 11999.5n 0.6433 12000.0n 0.6572 12599.5n 0.6572 12600.0n 0.6246 13199.5n 0.6246 13200.0n 0.6540 13799.5n 0.6540 13800.0n 0.6451 14399.5n 0.6451 14400.0n 0.6438 14999.5n 0.6438 15000.0n 0.6076 15599.5n 0.6076 15600.0n 0.6525 16199.5n 0.6525 16200.0n 0.6522 16799.5n 0.6522 16800.0n 0.6546 17399.5n 0.6546 17400.0n 0.6523 17999.5n 0.6523 18000.0n 0.5693 18599.5n 0.5693 18600.0n 0.6112 19199.5n 0.6112 19200.0n 0.5263 19799.5n 0.5263 19800.0n 0.5206 20399.5n 0.5206 20400.0n 0.5320 20999.5n 0.5320 21000.0n 0.6464 21599.5n 0.6464 21600.0n 0.5573 22199.5n 0.5573 22200.0n 0.6032 22799.5n 0.6032 22800.0n 0.5163 23399.5n 0.5163 23400.0n 0.6717 23999.5n 0.6717 24000.0n 0.4913 24599.5n 0.4913 24600.0n 0.6197 25199.5n 0.6197 25200.0n 0.5475 25799.5n 0.5475 25800.0n 0.5620 26399.5n 0.5620 26400.0n 0.5309 26999.5n 0.5309 27000.0n 0.5552 27599.5n 0.5552 27600.0n 0.5297 28199.5n 0.5297 28200.0n 0.6664 28799.5n 0.6664 28800.0n 0.5259 29399.5n 0.5259 29400.0n 0.6521 29999.5n 0.6521 30000.0n 0.6590 30599.5n 0.6590 30600.0n 0.6800 31199.5n 0.6800 31200.0n 0.6747 31799.5n 0.6747 31800.0n 0.5714 32399.5n 0.5714 32400.0n 0.5596 32999.5n 0.5596 33000.0n 0.5100 33599.5n 0.5100 33600.0n 0.5106 34199.5n 0.5106 34200.0n 0.6376 34799.5n 0.6376 34800.0n 0.6680 35399.5n 0.6680 35400.0n 0.5218 35999.5n 0.5218)
Vyn_wih_1_10 yn_wih_1_10 0 PWL(0.0n 0.3457 599.5n 0.3457 600.0n 0.3653 1199.5n 0.3653 1200.0n 0.3718 1799.5n 0.3718 1800.0n 0.4238 2399.5n 0.4238 2400.0n 0.4102 2999.5n 0.4102 3000.0n 0.3617 3599.5n 0.3617 3600.0n 0.3604 4199.5n 0.3604 4200.0n 0.3447 4799.5n 0.3447 4800.0n 0.3598 5399.5n 0.3598 5400.0n 0.3607 5999.5n 0.3607 6000.0n 0.3809 6599.5n 0.3809 6600.0n 0.3537 7199.5n 0.3537 7200.0n 0.3749 7799.5n 0.3749 7800.0n 0.3798 8399.5n 0.3798 8400.0n 0.3452 8999.5n 0.3452 9000.0n 0.3601 9599.5n 0.3601 9600.0n 0.3727 10199.5n 0.3727 10200.0n 0.3835 10799.5n 0.3835 10800.0n 0.3663 11399.5n 0.3663 11400.0n 0.3567 11999.5n 0.3567 12000.0n 0.3428 12599.5n 0.3428 12600.0n 0.3754 13199.5n 0.3754 13200.0n 0.3460 13799.5n 0.3460 13800.0n 0.3549 14399.5n 0.3549 14400.0n 0.3562 14999.5n 0.3562 15000.0n 0.3924 15599.5n 0.3924 15600.0n 0.3475 16199.5n 0.3475 16200.0n 0.3478 16799.5n 0.3478 16800.0n 0.3454 17399.5n 0.3454 17400.0n 0.3477 17999.5n 0.3477 18000.0n 0.4307 18599.5n 0.4307 18600.0n 0.3888 19199.5n 0.3888 19200.0n 0.4737 19799.5n 0.4737 19800.0n 0.4794 20399.5n 0.4794 20400.0n 0.4680 20999.5n 0.4680 21000.0n 0.3536 21599.5n 0.3536 21600.0n 0.4427 22199.5n 0.4427 22200.0n 0.3968 22799.5n 0.3968 22800.0n 0.4837 23399.5n 0.4837 23400.0n 0.3283 23999.5n 0.3283 24000.0n 0.5087 24599.5n 0.5087 24600.0n 0.3803 25199.5n 0.3803 25200.0n 0.4525 25799.5n 0.4525 25800.0n 0.4380 26399.5n 0.4380 26400.0n 0.4691 26999.5n 0.4691 27000.0n 0.4448 27599.5n 0.4448 27600.0n 0.4703 28199.5n 0.4703 28200.0n 0.3336 28799.5n 0.3336 28800.0n 0.4741 29399.5n 0.4741 29400.0n 0.3479 29999.5n 0.3479 30000.0n 0.3410 30599.5n 0.3410 30600.0n 0.3200 31199.5n 0.3200 31200.0n 0.3253 31799.5n 0.3253 31800.0n 0.4286 32399.5n 0.4286 32400.0n 0.4404 32999.5n 0.4404 33000.0n 0.4900 33599.5n 0.4900 33600.0n 0.4894 34199.5n 0.4894 34200.0n 0.3624 34799.5n 0.3624 34800.0n 0.3320 35399.5n 0.3320 35400.0n 0.4782 35999.5n 0.4782)
Cwp_wih_1_10 wp_wih_1_10 0 400p
Cwn_wih_1_10 wn_wih_1_10 0 400p
Xu_wih_1_10 xp_wih_1_10 xn_wih_1_10 yp_wih_1_10 yn_wih_1_10 wp_wih_1_10 wn_wih_1_10 vdd gbn gprod
Vxp_who_10_0 xp_who_10_0 0 PWL(0.0n 0.6543 599.5n 0.6543 600.0n 0.6347 1199.5n 0.6347 1200.0n 0.6282 1799.5n 0.6282 1800.0n 0.5762 2399.5n 0.5762 2400.0n 0.5898 2999.5n 0.5898 3000.0n 0.6383 3599.5n 0.6383 3600.0n 0.6396 4199.5n 0.6396 4200.0n 0.6553 4799.5n 0.6553 4800.0n 0.6402 5399.5n 0.6402 5400.0n 0.6393 5999.5n 0.6393 6000.0n 0.6191 6599.5n 0.6191 6600.0n 0.6463 7199.5n 0.6463 7200.0n 0.6251 7799.5n 0.6251 7800.0n 0.6202 8399.5n 0.6202 8400.0n 0.6548 8999.5n 0.6548 9000.0n 0.6399 9599.5n 0.6399 9600.0n 0.6273 10199.5n 0.6273 10200.0n 0.6165 10799.5n 0.6165 10800.0n 0.6337 11399.5n 0.6337 11400.0n 0.6433 11999.5n 0.6433 12000.0n 0.6572 12599.5n 0.6572 12600.0n 0.6246 13199.5n 0.6246 13200.0n 0.6540 13799.5n 0.6540 13800.0n 0.6451 14399.5n 0.6451 14400.0n 0.6438 14999.5n 0.6438 15000.0n 0.6076 15599.5n 0.6076 15600.0n 0.6525 16199.5n 0.6525 16200.0n 0.6522 16799.5n 0.6522 16800.0n 0.6546 17399.5n 0.6546 17400.0n 0.6523 17999.5n 0.6523 18000.0n 0.5693 18599.5n 0.5693 18600.0n 0.6112 19199.5n 0.6112 19200.0n 0.5263 19799.5n 0.5263 19800.0n 0.5206 20399.5n 0.5206 20400.0n 0.5320 20999.5n 0.5320 21000.0n 0.6464 21599.5n 0.6464 21600.0n 0.5573 22199.5n 0.5573 22200.0n 0.6032 22799.5n 0.6032 22800.0n 0.5163 23399.5n 0.5163 23400.0n 0.6717 23999.5n 0.6717 24000.0n 0.4913 24599.5n 0.4913 24600.0n 0.6197 25199.5n 0.6197 25200.0n 0.5475 25799.5n 0.5475 25800.0n 0.5620 26399.5n 0.5620 26400.0n 0.5309 26999.5n 0.5309 27000.0n 0.5552 27599.5n 0.5552 27600.0n 0.5297 28199.5n 0.5297 28200.0n 0.6664 28799.5n 0.6664 28800.0n 0.5259 29399.5n 0.5259 29400.0n 0.6521 29999.5n 0.6521 30000.0n 0.6590 30599.5n 0.6590 30600.0n 0.6800 31199.5n 0.6800 31200.0n 0.6747 31799.5n 0.6747 31800.0n 0.5714 32399.5n 0.5714 32400.0n 0.5596 32999.5n 0.5596 33000.0n 0.5100 33599.5n 0.5100 33600.0n 0.5106 34199.5n 0.5106 34200.0n 0.6376 34799.5n 0.6376 34800.0n 0.6680 35399.5n 0.6680 35400.0n 0.5218 35999.5n 0.5218)
Vxn_who_10_0 xn_who_10_0 0 PWL(0.0n 0.3457 599.5n 0.3457 600.0n 0.3653 1199.5n 0.3653 1200.0n 0.3718 1799.5n 0.3718 1800.0n 0.4238 2399.5n 0.4238 2400.0n 0.4102 2999.5n 0.4102 3000.0n 0.3617 3599.5n 0.3617 3600.0n 0.3604 4199.5n 0.3604 4200.0n 0.3447 4799.5n 0.3447 4800.0n 0.3598 5399.5n 0.3598 5400.0n 0.3607 5999.5n 0.3607 6000.0n 0.3809 6599.5n 0.3809 6600.0n 0.3537 7199.5n 0.3537 7200.0n 0.3749 7799.5n 0.3749 7800.0n 0.3798 8399.5n 0.3798 8400.0n 0.3452 8999.5n 0.3452 9000.0n 0.3601 9599.5n 0.3601 9600.0n 0.3727 10199.5n 0.3727 10200.0n 0.3835 10799.5n 0.3835 10800.0n 0.3663 11399.5n 0.3663 11400.0n 0.3567 11999.5n 0.3567 12000.0n 0.3428 12599.5n 0.3428 12600.0n 0.3754 13199.5n 0.3754 13200.0n 0.3460 13799.5n 0.3460 13800.0n 0.3549 14399.5n 0.3549 14400.0n 0.3562 14999.5n 0.3562 15000.0n 0.3924 15599.5n 0.3924 15600.0n 0.3475 16199.5n 0.3475 16200.0n 0.3478 16799.5n 0.3478 16800.0n 0.3454 17399.5n 0.3454 17400.0n 0.3477 17999.5n 0.3477 18000.0n 0.4307 18599.5n 0.4307 18600.0n 0.3888 19199.5n 0.3888 19200.0n 0.4737 19799.5n 0.4737 19800.0n 0.4794 20399.5n 0.4794 20400.0n 0.4680 20999.5n 0.4680 21000.0n 0.3536 21599.5n 0.3536 21600.0n 0.4427 22199.5n 0.4427 22200.0n 0.3968 22799.5n 0.3968 22800.0n 0.4837 23399.5n 0.4837 23400.0n 0.3283 23999.5n 0.3283 24000.0n 0.5087 24599.5n 0.5087 24600.0n 0.3803 25199.5n 0.3803 25200.0n 0.4525 25799.5n 0.4525 25800.0n 0.4380 26399.5n 0.4380 26400.0n 0.4691 26999.5n 0.4691 27000.0n 0.4448 27599.5n 0.4448 27600.0n 0.4703 28199.5n 0.4703 28200.0n 0.3336 28799.5n 0.3336 28800.0n 0.4741 29399.5n 0.4741 29400.0n 0.3479 29999.5n 0.3479 30000.0n 0.3410 30599.5n 0.3410 30600.0n 0.3200 31199.5n 0.3200 31200.0n 0.3253 31799.5n 0.3253 31800.0n 0.4286 32399.5n 0.4286 32400.0n 0.4404 32999.5n 0.4404 33000.0n 0.4900 33599.5n 0.4900 33600.0n 0.4894 34199.5n 0.4894 34200.0n 0.3624 34799.5n 0.3624 34800.0n 0.3320 35399.5n 0.3320 35400.0n 0.4782 35999.5n 0.4782)
Vyp_who_10_0 yp_who_10_0 0 PWL(0.0n 0.5031 599.5n 0.5031 600.0n 0.5023 1199.5n 0.5023 1200.0n 0.5052 1799.5n 0.5052 1800.0n 0.5048 2399.5n 0.5048 2400.0n 0.5043 2999.5n 0.5043 3000.0n 0.5034 3599.5n 0.5034 3600.0n 0.5048 4199.5n 0.5048 4200.0n 0.5031 4799.5n 0.5031 4800.0n 0.5040 5399.5n 0.5040 5400.0n 0.5040 5999.5n 0.5040 6000.0n 0.5054 6599.5n 0.5054 6600.0n 0.5040 7199.5n 0.5040 7200.0n 0.5027 7799.5n 0.5027 7800.0n 0.5027 8399.5n 0.5027 8400.0n 0.5038 8999.5n 0.5038 9000.0n 0.5040 9599.5n 0.5040 9600.0n 0.5039 10199.5n 0.5039 10200.0n 0.5033 10799.5n 0.5033 10800.0n 0.5056 11399.5n 0.5056 11400.0n 0.5040 11999.5n 0.5040 12000.0n 0.5036 12599.5n 0.5036 12600.0n 0.5039 13199.5n 0.5039 13200.0n 0.5029 13799.5n 0.5029 13800.0n 0.5025 14399.5n 0.5025 14400.0n 0.5038 14999.5n 0.5038 15000.0n 0.5041 15599.5n 0.5041 15600.0n 0.5036 16199.5n 0.5036 16200.0n 0.5025 16799.5n 0.5025 16800.0n 0.5040 17399.5n 0.5040 17400.0n 0.5029 17999.5n 0.5029 18000.0n 0.5057 18599.5n 0.5057 18600.0n 0.5010 19199.5n 0.5010 19200.0n 0.5041 19799.5n 0.5041 19800.0n 0.5021 20399.5n 0.5021 20400.0n 0.5044 20999.5n 0.5044 21000.0n 0.5056 21599.5n 0.5056 21600.0n 0.5016 22199.5n 0.5016 22200.0n 0.5006 22799.5n 0.5006 22800.0n 0.5041 23399.5n 0.5041 23400.0n 0.5027 23999.5n 0.5027 24000.0n 0.5029 24599.5n 0.5029 24600.0n 0.5006 25199.5n 0.5006 25200.0n 0.5047 25799.5n 0.5047 25800.0n 0.5046 26399.5n 0.5046 26400.0n 0.5039 26999.5n 0.5039 27000.0n 0.5049 27599.5n 0.5049 27600.0n 0.5039 28199.5n 0.5039 28200.0n 0.5017 28799.5n 0.5017 28800.0n 0.5042 29399.5n 0.5042 29400.0n 0.5056 29999.5n 0.5056 30000.0n 0.5051 30599.5n 0.5051 30600.0n 0.5039 31199.5n 0.5039 31200.0n 0.5033 31799.5n 0.5033 31800.0n 0.5049 32399.5n 0.5049 32400.0n 0.5045 32999.5n 0.5045 33000.0n 0.5036 33599.5n 0.5036 33600.0n 0.5042 34199.5n 0.5042 34200.0n 0.5012 34799.5n 0.5012 34800.0n 0.5036 35399.5n 0.5036 35400.0n 0.5042 35999.5n 0.5042)
Vyn_who_10_0 yn_who_10_0 0 PWL(0.0n 0.4969 599.5n 0.4969 600.0n 0.4977 1199.5n 0.4977 1200.0n 0.4948 1799.5n 0.4948 1800.0n 0.4952 2399.5n 0.4952 2400.0n 0.4957 2999.5n 0.4957 3000.0n 0.4966 3599.5n 0.4966 3600.0n 0.4952 4199.5n 0.4952 4200.0n 0.4969 4799.5n 0.4969 4800.0n 0.4960 5399.5n 0.4960 5400.0n 0.4960 5999.5n 0.4960 6000.0n 0.4946 6599.5n 0.4946 6600.0n 0.4960 7199.5n 0.4960 7200.0n 0.4973 7799.5n 0.4973 7800.0n 0.4973 8399.5n 0.4973 8400.0n 0.4962 8999.5n 0.4962 9000.0n 0.4960 9599.5n 0.4960 9600.0n 0.4961 10199.5n 0.4961 10200.0n 0.4967 10799.5n 0.4967 10800.0n 0.4944 11399.5n 0.4944 11400.0n 0.4960 11999.5n 0.4960 12000.0n 0.4964 12599.5n 0.4964 12600.0n 0.4961 13199.5n 0.4961 13200.0n 0.4971 13799.5n 0.4971 13800.0n 0.4975 14399.5n 0.4975 14400.0n 0.4962 14999.5n 0.4962 15000.0n 0.4959 15599.5n 0.4959 15600.0n 0.4964 16199.5n 0.4964 16200.0n 0.4975 16799.5n 0.4975 16800.0n 0.4960 17399.5n 0.4960 17400.0n 0.4971 17999.5n 0.4971 18000.0n 0.4943 18599.5n 0.4943 18600.0n 0.4990 19199.5n 0.4990 19200.0n 0.4959 19799.5n 0.4959 19800.0n 0.4979 20399.5n 0.4979 20400.0n 0.4956 20999.5n 0.4956 21000.0n 0.4944 21599.5n 0.4944 21600.0n 0.4984 22199.5n 0.4984 22200.0n 0.4994 22799.5n 0.4994 22800.0n 0.4959 23399.5n 0.4959 23400.0n 0.4973 23999.5n 0.4973 24000.0n 0.4971 24599.5n 0.4971 24600.0n 0.4994 25199.5n 0.4994 25200.0n 0.4953 25799.5n 0.4953 25800.0n 0.4954 26399.5n 0.4954 26400.0n 0.4961 26999.5n 0.4961 27000.0n 0.4951 27599.5n 0.4951 27600.0n 0.4961 28199.5n 0.4961 28200.0n 0.4983 28799.5n 0.4983 28800.0n 0.4958 29399.5n 0.4958 29400.0n 0.4944 29999.5n 0.4944 30000.0n 0.4949 30599.5n 0.4949 30600.0n 0.4961 31199.5n 0.4961 31200.0n 0.4967 31799.5n 0.4967 31800.0n 0.4951 32399.5n 0.4951 32400.0n 0.4955 32999.5n 0.4955 33000.0n 0.4964 33599.5n 0.4964 33600.0n 0.4958 34199.5n 0.4958 34200.0n 0.4988 34799.5n 0.4988 34800.0n 0.4964 35399.5n 0.4964 35400.0n 0.4958 35999.5n 0.4958)
Cwp_who_10_0 wp_who_10_0 0 400p
Cwn_who_10_0 wn_who_10_0 0 400p
Xu_who_10_0 xp_who_10_0 xn_who_10_0 yp_who_10_0 yn_who_10_0 wp_who_10_0 wn_who_10_0 vdd gbn gprod
Vxp_who_10_1 xp_who_10_1 0 PWL(0.0n 0.6543 599.5n 0.6543 600.0n 0.6347 1199.5n 0.6347 1200.0n 0.6282 1799.5n 0.6282 1800.0n 0.5762 2399.5n 0.5762 2400.0n 0.5898 2999.5n 0.5898 3000.0n 0.6383 3599.5n 0.6383 3600.0n 0.6396 4199.5n 0.6396 4200.0n 0.6553 4799.5n 0.6553 4800.0n 0.6402 5399.5n 0.6402 5400.0n 0.6393 5999.5n 0.6393 6000.0n 0.6191 6599.5n 0.6191 6600.0n 0.6463 7199.5n 0.6463 7200.0n 0.6251 7799.5n 0.6251 7800.0n 0.6202 8399.5n 0.6202 8400.0n 0.6548 8999.5n 0.6548 9000.0n 0.6399 9599.5n 0.6399 9600.0n 0.6273 10199.5n 0.6273 10200.0n 0.6165 10799.5n 0.6165 10800.0n 0.6337 11399.5n 0.6337 11400.0n 0.6433 11999.5n 0.6433 12000.0n 0.6572 12599.5n 0.6572 12600.0n 0.6246 13199.5n 0.6246 13200.0n 0.6540 13799.5n 0.6540 13800.0n 0.6451 14399.5n 0.6451 14400.0n 0.6438 14999.5n 0.6438 15000.0n 0.6076 15599.5n 0.6076 15600.0n 0.6525 16199.5n 0.6525 16200.0n 0.6522 16799.5n 0.6522 16800.0n 0.6546 17399.5n 0.6546 17400.0n 0.6523 17999.5n 0.6523 18000.0n 0.5693 18599.5n 0.5693 18600.0n 0.6112 19199.5n 0.6112 19200.0n 0.5263 19799.5n 0.5263 19800.0n 0.5206 20399.5n 0.5206 20400.0n 0.5320 20999.5n 0.5320 21000.0n 0.6464 21599.5n 0.6464 21600.0n 0.5573 22199.5n 0.5573 22200.0n 0.6032 22799.5n 0.6032 22800.0n 0.5163 23399.5n 0.5163 23400.0n 0.6717 23999.5n 0.6717 24000.0n 0.4913 24599.5n 0.4913 24600.0n 0.6197 25199.5n 0.6197 25200.0n 0.5475 25799.5n 0.5475 25800.0n 0.5620 26399.5n 0.5620 26400.0n 0.5309 26999.5n 0.5309 27000.0n 0.5552 27599.5n 0.5552 27600.0n 0.5297 28199.5n 0.5297 28200.0n 0.6664 28799.5n 0.6664 28800.0n 0.5259 29399.5n 0.5259 29400.0n 0.6521 29999.5n 0.6521 30000.0n 0.6590 30599.5n 0.6590 30600.0n 0.6800 31199.5n 0.6800 31200.0n 0.6747 31799.5n 0.6747 31800.0n 0.5714 32399.5n 0.5714 32400.0n 0.5596 32999.5n 0.5596 33000.0n 0.5100 33599.5n 0.5100 33600.0n 0.5106 34199.5n 0.5106 34200.0n 0.6376 34799.5n 0.6376 34800.0n 0.6680 35399.5n 0.6680 35400.0n 0.5218 35999.5n 0.5218)
Vxn_who_10_1 xn_who_10_1 0 PWL(0.0n 0.3457 599.5n 0.3457 600.0n 0.3653 1199.5n 0.3653 1200.0n 0.3718 1799.5n 0.3718 1800.0n 0.4238 2399.5n 0.4238 2400.0n 0.4102 2999.5n 0.4102 3000.0n 0.3617 3599.5n 0.3617 3600.0n 0.3604 4199.5n 0.3604 4200.0n 0.3447 4799.5n 0.3447 4800.0n 0.3598 5399.5n 0.3598 5400.0n 0.3607 5999.5n 0.3607 6000.0n 0.3809 6599.5n 0.3809 6600.0n 0.3537 7199.5n 0.3537 7200.0n 0.3749 7799.5n 0.3749 7800.0n 0.3798 8399.5n 0.3798 8400.0n 0.3452 8999.5n 0.3452 9000.0n 0.3601 9599.5n 0.3601 9600.0n 0.3727 10199.5n 0.3727 10200.0n 0.3835 10799.5n 0.3835 10800.0n 0.3663 11399.5n 0.3663 11400.0n 0.3567 11999.5n 0.3567 12000.0n 0.3428 12599.5n 0.3428 12600.0n 0.3754 13199.5n 0.3754 13200.0n 0.3460 13799.5n 0.3460 13800.0n 0.3549 14399.5n 0.3549 14400.0n 0.3562 14999.5n 0.3562 15000.0n 0.3924 15599.5n 0.3924 15600.0n 0.3475 16199.5n 0.3475 16200.0n 0.3478 16799.5n 0.3478 16800.0n 0.3454 17399.5n 0.3454 17400.0n 0.3477 17999.5n 0.3477 18000.0n 0.4307 18599.5n 0.4307 18600.0n 0.3888 19199.5n 0.3888 19200.0n 0.4737 19799.5n 0.4737 19800.0n 0.4794 20399.5n 0.4794 20400.0n 0.4680 20999.5n 0.4680 21000.0n 0.3536 21599.5n 0.3536 21600.0n 0.4427 22199.5n 0.4427 22200.0n 0.3968 22799.5n 0.3968 22800.0n 0.4837 23399.5n 0.4837 23400.0n 0.3283 23999.5n 0.3283 24000.0n 0.5087 24599.5n 0.5087 24600.0n 0.3803 25199.5n 0.3803 25200.0n 0.4525 25799.5n 0.4525 25800.0n 0.4380 26399.5n 0.4380 26400.0n 0.4691 26999.5n 0.4691 27000.0n 0.4448 27599.5n 0.4448 27600.0n 0.4703 28199.5n 0.4703 28200.0n 0.3336 28799.5n 0.3336 28800.0n 0.4741 29399.5n 0.4741 29400.0n 0.3479 29999.5n 0.3479 30000.0n 0.3410 30599.5n 0.3410 30600.0n 0.3200 31199.5n 0.3200 31200.0n 0.3253 31799.5n 0.3253 31800.0n 0.4286 32399.5n 0.4286 32400.0n 0.4404 32999.5n 0.4404 33000.0n 0.4900 33599.5n 0.4900 33600.0n 0.4894 34199.5n 0.4894 34200.0n 0.3624 34799.5n 0.3624 34800.0n 0.3320 35399.5n 0.3320 35400.0n 0.4782 35999.5n 0.4782)
Vyp_who_10_1 yp_who_10_1 0 PWL(0.0n 0.5071 599.5n 0.5071 600.0n 0.5053 1199.5n 0.5053 1200.0n 0.5052 1799.5n 0.5052 1800.0n 0.5027 2399.5n 0.5027 2400.0n 0.5034 2999.5n 0.5034 3000.0n 0.5055 3599.5n 0.5055 3600.0n 0.5056 4199.5n 0.5056 4200.0n 0.5071 4799.5n 0.5071 4800.0n 0.5056 5399.5n 0.5056 5400.0n 0.5056 5999.5n 0.5056 6000.0n 0.5048 6599.5n 0.5048 6600.0n 0.5060 7199.5n 0.5060 7200.0n 0.5048 7799.5n 0.5048 7800.0n 0.5046 8399.5n 0.5046 8400.0n 0.5066 8999.5n 0.5066 9000.0n 0.5056 9599.5n 0.5056 9600.0n 0.5051 10199.5n 0.5051 10200.0n 0.5046 10799.5n 0.5046 10800.0n 0.5056 11399.5n 0.5056 11400.0n 0.5058 11999.5n 0.5058 12000.0n 0.5068 12599.5n 0.5068 12600.0n 0.5050 13199.5n 0.5050 13200.0n 0.5071 13799.5n 0.5071 13800.0n 0.5059 14399.5n 0.5059 14400.0n 0.5058 14999.5n 0.5058 15000.0n 0.5043 15599.5n 0.5043 15600.0n 0.5067 16199.5n 0.5067 16200.0n 0.5068 16799.5n 0.5068 16800.0n 0.5066 17399.5n 0.5066 17400.0n 0.5069 17999.5n 0.5069 18000.0n 0.5061 18599.5n 0.5061 18600.0n 0.5034 19199.5n 0.5034 19200.0n 0.5010 19799.5n 0.5010 19800.0n 0.4989 20399.5n 0.4989 20400.0n 0.5022 20999.5n 0.5022 21000.0n 0.5086 21599.5n 0.5086 21600.0n 0.5007 22199.5n 0.5007 22200.0n 0.5023 22799.5n 0.5023 22800.0n 0.5021 23399.5n 0.5021 23400.0n 0.5077 23999.5n 0.5077 24000.0n 0.4979 24599.5n 0.4979 24600.0n 0.5035 25199.5n 0.5035 25200.0n 0.5041 25799.5n 0.5041 25800.0n 0.5075 26399.5n 0.5075 26400.0n 0.5041 26999.5n 0.5041 27000.0n 0.5056 27599.5n 0.5056 27600.0n 0.5039 28199.5n 0.5039 28200.0n 0.5059 28799.5n 0.5059 28800.0n 0.5023 29399.5n 0.5023 29400.0n 0.5086 29999.5n 0.5086 30000.0n 0.5084 30599.5n 0.5084 30600.0n 0.5085 31199.5n 0.5085 31200.0n 0.5088 31799.5n 0.5088 31800.0n 0.5078 32399.5n 0.5078 32400.0n 0.5074 32999.5n 0.5074 33000.0n 0.4996 33599.5n 0.4996 33600.0n 0.5010 34199.5n 0.5010 34200.0n 0.5044 34799.5n 0.5044 34800.0n 0.5084 35399.5n 0.5084 35400.0n 0.5012 35999.5n 0.5012)
Vyn_who_10_1 yn_who_10_1 0 PWL(0.0n 0.4929 599.5n 0.4929 600.0n 0.4947 1199.5n 0.4947 1200.0n 0.4948 1799.5n 0.4948 1800.0n 0.4973 2399.5n 0.4973 2400.0n 0.4966 2999.5n 0.4966 3000.0n 0.4945 3599.5n 0.4945 3600.0n 0.4944 4199.5n 0.4944 4200.0n 0.4929 4799.5n 0.4929 4800.0n 0.4944 5399.5n 0.4944 5400.0n 0.4944 5999.5n 0.4944 6000.0n 0.4952 6599.5n 0.4952 6600.0n 0.4940 7199.5n 0.4940 7200.0n 0.4952 7799.5n 0.4952 7800.0n 0.4954 8399.5n 0.4954 8400.0n 0.4934 8999.5n 0.4934 9000.0n 0.4944 9599.5n 0.4944 9600.0n 0.4949 10199.5n 0.4949 10200.0n 0.4954 10799.5n 0.4954 10800.0n 0.4944 11399.5n 0.4944 11400.0n 0.4942 11999.5n 0.4942 12000.0n 0.4932 12599.5n 0.4932 12600.0n 0.4950 13199.5n 0.4950 13200.0n 0.4929 13799.5n 0.4929 13800.0n 0.4941 14399.5n 0.4941 14400.0n 0.4942 14999.5n 0.4942 15000.0n 0.4957 15599.5n 0.4957 15600.0n 0.4933 16199.5n 0.4933 16200.0n 0.4932 16799.5n 0.4932 16800.0n 0.4934 17399.5n 0.4934 17400.0n 0.4931 17999.5n 0.4931 18000.0n 0.4939 18599.5n 0.4939 18600.0n 0.4966 19199.5n 0.4966 19200.0n 0.4990 19799.5n 0.4990 19800.0n 0.5011 20399.5n 0.5011 20400.0n 0.4978 20999.5n 0.4978 21000.0n 0.4914 21599.5n 0.4914 21600.0n 0.4993 22199.5n 0.4993 22200.0n 0.4977 22799.5n 0.4977 22800.0n 0.4979 23399.5n 0.4979 23400.0n 0.4923 23999.5n 0.4923 24000.0n 0.5021 24599.5n 0.5021 24600.0n 0.4965 25199.5n 0.4965 25200.0n 0.4959 25799.5n 0.4959 25800.0n 0.4925 26399.5n 0.4925 26400.0n 0.4959 26999.5n 0.4959 27000.0n 0.4944 27599.5n 0.4944 27600.0n 0.4961 28199.5n 0.4961 28200.0n 0.4941 28799.5n 0.4941 28800.0n 0.4977 29399.5n 0.4977 29400.0n 0.4914 29999.5n 0.4914 30000.0n 0.4916 30599.5n 0.4916 30600.0n 0.4915 31199.5n 0.4915 31200.0n 0.4912 31799.5n 0.4912 31800.0n 0.4922 32399.5n 0.4922 32400.0n 0.4926 32999.5n 0.4926 33000.0n 0.5004 33599.5n 0.5004 33600.0n 0.4990 34199.5n 0.4990 34200.0n 0.4956 34799.5n 0.4956 34800.0n 0.4916 35399.5n 0.4916 35400.0n 0.4988 35999.5n 0.4988)
Cwp_who_10_1 wp_who_10_1 0 400p
Cwn_who_10_1 wn_who_10_1 0 400p
Xu_who_10_1 xp_who_10_1 xn_who_10_1 yp_who_10_1 yn_who_10_1 wp_who_10_1 wn_who_10_1 vdd gbn gprod
Vxp_bh_10 xp_bh_10 0 PWL(0.0n 0.7100 599.5n 0.7100 600.0n 0.7100 1199.5n 0.7100 1200.0n 0.7100 1799.5n 0.7100 1800.0n 0.7100 2399.5n 0.7100 2400.0n 0.7100 2999.5n 0.7100 3000.0n 0.7100 3599.5n 0.7100 3600.0n 0.7100 4199.5n 0.7100 4200.0n 0.7100 4799.5n 0.7100 4800.0n 0.7100 5399.5n 0.7100 5400.0n 0.7100 5999.5n 0.7100 6000.0n 0.7100 6599.5n 0.7100 6600.0n 0.7100 7199.5n 0.7100 7200.0n 0.7100 7799.5n 0.7100 7800.0n 0.7100 8399.5n 0.7100 8400.0n 0.7100 8999.5n 0.7100 9000.0n 0.7100 9599.5n 0.7100 9600.0n 0.7100 10199.5n 0.7100 10200.0n 0.7100 10799.5n 0.7100 10800.0n 0.7100 11399.5n 0.7100 11400.0n 0.7100 11999.5n 0.7100 12000.0n 0.7100 12599.5n 0.7100 12600.0n 0.7100 13199.5n 0.7100 13200.0n 0.7100 13799.5n 0.7100 13800.0n 0.7100 14399.5n 0.7100 14400.0n 0.7100 14999.5n 0.7100 15000.0n 0.7100 15599.5n 0.7100 15600.0n 0.7100 16199.5n 0.7100 16200.0n 0.7100 16799.5n 0.7100 16800.0n 0.7100 17399.5n 0.7100 17400.0n 0.7100 17999.5n 0.7100 18000.0n 0.7100 18599.5n 0.7100 18600.0n 0.7100 19199.5n 0.7100 19200.0n 0.7100 19799.5n 0.7100 19800.0n 0.7100 20399.5n 0.7100 20400.0n 0.7100 20999.5n 0.7100 21000.0n 0.7100 21599.5n 0.7100 21600.0n 0.7100 22199.5n 0.7100 22200.0n 0.7100 22799.5n 0.7100 22800.0n 0.7100 23399.5n 0.7100 23400.0n 0.7100 23999.5n 0.7100 24000.0n 0.7100 24599.5n 0.7100 24600.0n 0.7100 25199.5n 0.7100 25200.0n 0.7100 25799.5n 0.7100 25800.0n 0.7100 26399.5n 0.7100 26400.0n 0.7100 26999.5n 0.7100 27000.0n 0.7100 27599.5n 0.7100 27600.0n 0.7100 28199.5n 0.7100 28200.0n 0.7100 28799.5n 0.7100 28800.0n 0.7100 29399.5n 0.7100 29400.0n 0.7100 29999.5n 0.7100 30000.0n 0.7100 30599.5n 0.7100 30600.0n 0.7100 31199.5n 0.7100 31200.0n 0.7100 31799.5n 0.7100 31800.0n 0.7100 32399.5n 0.7100 32400.0n 0.7100 32999.5n 0.7100 33000.0n 0.7100 33599.5n 0.7100 33600.0n 0.7100 34199.5n 0.7100 34200.0n 0.7100 34799.5n 0.7100 34800.0n 0.7100 35399.5n 0.7100 35400.0n 0.7100 35999.5n 0.7100)
Vxn_bh_10 xn_bh_10 0 PWL(0.0n 0.2900 599.5n 0.2900 600.0n 0.2900 1199.5n 0.2900 1200.0n 0.2900 1799.5n 0.2900 1800.0n 0.2900 2399.5n 0.2900 2400.0n 0.2900 2999.5n 0.2900 3000.0n 0.2900 3599.5n 0.2900 3600.0n 0.2900 4199.5n 0.2900 4200.0n 0.2900 4799.5n 0.2900 4800.0n 0.2900 5399.5n 0.2900 5400.0n 0.2900 5999.5n 0.2900 6000.0n 0.2900 6599.5n 0.2900 6600.0n 0.2900 7199.5n 0.2900 7200.0n 0.2900 7799.5n 0.2900 7800.0n 0.2900 8399.5n 0.2900 8400.0n 0.2900 8999.5n 0.2900 9000.0n 0.2900 9599.5n 0.2900 9600.0n 0.2900 10199.5n 0.2900 10200.0n 0.2900 10799.5n 0.2900 10800.0n 0.2900 11399.5n 0.2900 11400.0n 0.2900 11999.5n 0.2900 12000.0n 0.2900 12599.5n 0.2900 12600.0n 0.2900 13199.5n 0.2900 13200.0n 0.2900 13799.5n 0.2900 13800.0n 0.2900 14399.5n 0.2900 14400.0n 0.2900 14999.5n 0.2900 15000.0n 0.2900 15599.5n 0.2900 15600.0n 0.2900 16199.5n 0.2900 16200.0n 0.2900 16799.5n 0.2900 16800.0n 0.2900 17399.5n 0.2900 17400.0n 0.2900 17999.5n 0.2900 18000.0n 0.2900 18599.5n 0.2900 18600.0n 0.2900 19199.5n 0.2900 19200.0n 0.2900 19799.5n 0.2900 19800.0n 0.2900 20399.5n 0.2900 20400.0n 0.2900 20999.5n 0.2900 21000.0n 0.2900 21599.5n 0.2900 21600.0n 0.2900 22199.5n 0.2900 22200.0n 0.2900 22799.5n 0.2900 22800.0n 0.2900 23399.5n 0.2900 23400.0n 0.2900 23999.5n 0.2900 24000.0n 0.2900 24599.5n 0.2900 24600.0n 0.2900 25199.5n 0.2900 25200.0n 0.2900 25799.5n 0.2900 25800.0n 0.2900 26399.5n 0.2900 26400.0n 0.2900 26999.5n 0.2900 27000.0n 0.2900 27599.5n 0.2900 27600.0n 0.2900 28199.5n 0.2900 28200.0n 0.2900 28799.5n 0.2900 28800.0n 0.2900 29399.5n 0.2900 29400.0n 0.2900 29999.5n 0.2900 30000.0n 0.2900 30599.5n 0.2900 30600.0n 0.2900 31199.5n 0.2900 31200.0n 0.2900 31799.5n 0.2900 31800.0n 0.2900 32399.5n 0.2900 32400.0n 0.2900 32999.5n 0.2900 33000.0n 0.2900 33599.5n 0.2900 33600.0n 0.2900 34199.5n 0.2900 34200.0n 0.2900 34799.5n 0.2900 34800.0n 0.2900 35399.5n 0.2900 35400.0n 0.2900 35999.5n 0.2900)
Vyp_bh_10 yp_bh_10 0 PWL(0.0n 0.6543 599.5n 0.6543 600.0n 0.6347 1199.5n 0.6347 1200.0n 0.6282 1799.5n 0.6282 1800.0n 0.5762 2399.5n 0.5762 2400.0n 0.5898 2999.5n 0.5898 3000.0n 0.6383 3599.5n 0.6383 3600.0n 0.6396 4199.5n 0.6396 4200.0n 0.6553 4799.5n 0.6553 4800.0n 0.6402 5399.5n 0.6402 5400.0n 0.6393 5999.5n 0.6393 6000.0n 0.6191 6599.5n 0.6191 6600.0n 0.6463 7199.5n 0.6463 7200.0n 0.6251 7799.5n 0.6251 7800.0n 0.6202 8399.5n 0.6202 8400.0n 0.6548 8999.5n 0.6548 9000.0n 0.6399 9599.5n 0.6399 9600.0n 0.6273 10199.5n 0.6273 10200.0n 0.6165 10799.5n 0.6165 10800.0n 0.6337 11399.5n 0.6337 11400.0n 0.6433 11999.5n 0.6433 12000.0n 0.6572 12599.5n 0.6572 12600.0n 0.6246 13199.5n 0.6246 13200.0n 0.6540 13799.5n 0.6540 13800.0n 0.6451 14399.5n 0.6451 14400.0n 0.6438 14999.5n 0.6438 15000.0n 0.6076 15599.5n 0.6076 15600.0n 0.6525 16199.5n 0.6525 16200.0n 0.6522 16799.5n 0.6522 16800.0n 0.6546 17399.5n 0.6546 17400.0n 0.6523 17999.5n 0.6523 18000.0n 0.5693 18599.5n 0.5693 18600.0n 0.6112 19199.5n 0.6112 19200.0n 0.5263 19799.5n 0.5263 19800.0n 0.5206 20399.5n 0.5206 20400.0n 0.5320 20999.5n 0.5320 21000.0n 0.6464 21599.5n 0.6464 21600.0n 0.5573 22199.5n 0.5573 22200.0n 0.6032 22799.5n 0.6032 22800.0n 0.5163 23399.5n 0.5163 23400.0n 0.6717 23999.5n 0.6717 24000.0n 0.4913 24599.5n 0.4913 24600.0n 0.6197 25199.5n 0.6197 25200.0n 0.5475 25799.5n 0.5475 25800.0n 0.5620 26399.5n 0.5620 26400.0n 0.5309 26999.5n 0.5309 27000.0n 0.5552 27599.5n 0.5552 27600.0n 0.5297 28199.5n 0.5297 28200.0n 0.6664 28799.5n 0.6664 28800.0n 0.5259 29399.5n 0.5259 29400.0n 0.6521 29999.5n 0.6521 30000.0n 0.6590 30599.5n 0.6590 30600.0n 0.6800 31199.5n 0.6800 31200.0n 0.6747 31799.5n 0.6747 31800.0n 0.5714 32399.5n 0.5714 32400.0n 0.5596 32999.5n 0.5596 33000.0n 0.5100 33599.5n 0.5100 33600.0n 0.5106 34199.5n 0.5106 34200.0n 0.6376 34799.5n 0.6376 34800.0n 0.6680 35399.5n 0.6680 35400.0n 0.5218 35999.5n 0.5218)
Vyn_bh_10 yn_bh_10 0 PWL(0.0n 0.3457 599.5n 0.3457 600.0n 0.3653 1199.5n 0.3653 1200.0n 0.3718 1799.5n 0.3718 1800.0n 0.4238 2399.5n 0.4238 2400.0n 0.4102 2999.5n 0.4102 3000.0n 0.3617 3599.5n 0.3617 3600.0n 0.3604 4199.5n 0.3604 4200.0n 0.3447 4799.5n 0.3447 4800.0n 0.3598 5399.5n 0.3598 5400.0n 0.3607 5999.5n 0.3607 6000.0n 0.3809 6599.5n 0.3809 6600.0n 0.3537 7199.5n 0.3537 7200.0n 0.3749 7799.5n 0.3749 7800.0n 0.3798 8399.5n 0.3798 8400.0n 0.3452 8999.5n 0.3452 9000.0n 0.3601 9599.5n 0.3601 9600.0n 0.3727 10199.5n 0.3727 10200.0n 0.3835 10799.5n 0.3835 10800.0n 0.3663 11399.5n 0.3663 11400.0n 0.3567 11999.5n 0.3567 12000.0n 0.3428 12599.5n 0.3428 12600.0n 0.3754 13199.5n 0.3754 13200.0n 0.3460 13799.5n 0.3460 13800.0n 0.3549 14399.5n 0.3549 14400.0n 0.3562 14999.5n 0.3562 15000.0n 0.3924 15599.5n 0.3924 15600.0n 0.3475 16199.5n 0.3475 16200.0n 0.3478 16799.5n 0.3478 16800.0n 0.3454 17399.5n 0.3454 17400.0n 0.3477 17999.5n 0.3477 18000.0n 0.4307 18599.5n 0.4307 18600.0n 0.3888 19199.5n 0.3888 19200.0n 0.4737 19799.5n 0.4737 19800.0n 0.4794 20399.5n 0.4794 20400.0n 0.4680 20999.5n 0.4680 21000.0n 0.3536 21599.5n 0.3536 21600.0n 0.4427 22199.5n 0.4427 22200.0n 0.3968 22799.5n 0.3968 22800.0n 0.4837 23399.5n 0.4837 23400.0n 0.3283 23999.5n 0.3283 24000.0n 0.5087 24599.5n 0.5087 24600.0n 0.3803 25199.5n 0.3803 25200.0n 0.4525 25799.5n 0.4525 25800.0n 0.4380 26399.5n 0.4380 26400.0n 0.4691 26999.5n 0.4691 27000.0n 0.4448 27599.5n 0.4448 27600.0n 0.4703 28199.5n 0.4703 28200.0n 0.3336 28799.5n 0.3336 28800.0n 0.4741 29399.5n 0.4741 29400.0n 0.3479 29999.5n 0.3479 30000.0n 0.3410 30599.5n 0.3410 30600.0n 0.3200 31199.5n 0.3200 31200.0n 0.3253 31799.5n 0.3253 31800.0n 0.4286 32399.5n 0.4286 32400.0n 0.4404 32999.5n 0.4404 33000.0n 0.4900 33599.5n 0.4900 33600.0n 0.4894 34199.5n 0.4894 34200.0n 0.3624 34799.5n 0.3624 34800.0n 0.3320 35399.5n 0.3320 35400.0n 0.4782 35999.5n 0.4782)
Cwp_bh_10 wp_bh_10 0 400p
Cwn_bh_10 wn_bh_10 0 400p
Xu_bh_10 xp_bh_10 xn_bh_10 yp_bh_10 yn_bh_10 wp_bh_10 wn_bh_10 vdd gbn gprod
Vxp_wih_0_11 xp_wih_0_11 0 PWL(0.0n 0.4942 599.5n 0.4942 600.0n 0.5558 1199.5n 0.5558 1200.0n 0.4708 1799.5n 0.4708 1800.0n 0.5235 2399.5n 0.5235 2400.0n 0.5350 2999.5n 0.5350 3000.0n 0.5172 3599.5n 0.5172 3600.0n 0.4702 4199.5n 0.4702 4200.0n 0.4867 4799.5n 0.4867 4800.0n 0.4970 5399.5n 0.4970 5400.0n 0.4986 5999.5n 0.4986 6000.0n 0.4751 6599.5n 0.4751 6600.0n 0.4870 7199.5n 0.4870 7200.0n 0.5502 7799.5n 0.5502 7800.0n 0.5521 8399.5n 0.5521 8400.0n 0.4638 8999.5n 0.4638 9000.0n 0.4982 9599.5n 0.4982 9600.0n 0.5131 10199.5n 0.5131 10200.0n 0.5386 10799.5n 0.5386 10800.0n 0.4592 11399.5n 0.4592 11400.0n 0.4950 11999.5n 0.4950 12000.0n 0.4559 12599.5n 0.4559 12600.0n 0.5162 13199.5n 0.5162 13200.0n 0.5038 13799.5n 0.5038 13800.0n 0.5333 14399.5n 0.5333 14400.0n 0.4991 14999.5n 0.4991 15000.0n 0.5298 15599.5n 0.5298 15600.0n 0.4823 16199.5n 0.4823 16200.0n 0.5239 16799.5n 0.5239 16800.0n 0.4592 17399.5n 0.4592 17400.0n 0.5094 17999.5n 0.5094 18000.0n 0.4337 18599.5n 0.4337 18600.0n 0.5977 19199.5n 0.5977 19200.0n 0.5364 19799.5n 0.5364 19800.0n 0.6122 20399.5n 0.6122 20400.0n 0.4856 20999.5n 0.4856 21000.0n 0.3861 21599.5n 0.3861 21600.0n 0.6094 22199.5n 0.6094 22200.0n 0.6364 22799.5n 0.6364 22800.0n 0.4807 23399.5n 0.4807 23400.0n 0.5614 23999.5n 0.5614 24000.0n 0.5913 24599.5n 0.5913 24600.0n 0.6295 25199.5n 0.6295 25200.0n 0.4496 25799.5n 0.4496 25800.0n 0.3792 26399.5n 0.3792 26400.0n 0.4434 26999.5n 0.4434 27000.0n 0.4340 27599.5n 0.4340 27600.0n 0.4461 28199.5n 0.4461 28200.0n 0.5791 28799.5n 0.5791 28800.0n 0.4777 29399.5n 0.4777 29400.0n 0.3878 29999.5n 0.3878 30000.0n 0.3832 30599.5n 0.3832 30600.0n 0.4022 31199.5n 0.4022 31200.0n 0.4482 31799.5n 0.4482 31800.0n 0.3662 32399.5n 0.3662 32400.0n 0.3857 32999.5n 0.3857 33000.0n 0.5584 33599.5n 0.5584 33600.0n 0.5284 34199.5n 0.5284 34200.0n 0.6034 34799.5n 0.6034 34800.0n 0.3469 35399.5n 0.3469 35400.0n 0.5290 35999.5n 0.5290)
Vxn_wih_0_11 xn_wih_0_11 0 PWL(0.0n 0.5058 599.5n 0.5058 600.0n 0.4442 1199.5n 0.4442 1200.0n 0.5292 1799.5n 0.5292 1800.0n 0.4765 2399.5n 0.4765 2400.0n 0.4650 2999.5n 0.4650 3000.0n 0.4828 3599.5n 0.4828 3600.0n 0.5298 4199.5n 0.5298 4200.0n 0.5133 4799.5n 0.5133 4800.0n 0.5030 5399.5n 0.5030 5400.0n 0.5014 5999.5n 0.5014 6000.0n 0.5249 6599.5n 0.5249 6600.0n 0.5130 7199.5n 0.5130 7200.0n 0.4498 7799.5n 0.4498 7800.0n 0.4479 8399.5n 0.4479 8400.0n 0.5362 8999.5n 0.5362 9000.0n 0.5018 9599.5n 0.5018 9600.0n 0.4869 10199.5n 0.4869 10200.0n 0.4614 10799.5n 0.4614 10800.0n 0.5408 11399.5n 0.5408 11400.0n 0.5050 11999.5n 0.5050 12000.0n 0.5441 12599.5n 0.5441 12600.0n 0.4838 13199.5n 0.4838 13200.0n 0.4962 13799.5n 0.4962 13800.0n 0.4667 14399.5n 0.4667 14400.0n 0.5009 14999.5n 0.5009 15000.0n 0.4702 15599.5n 0.4702 15600.0n 0.5177 16199.5n 0.5177 16200.0n 0.4761 16799.5n 0.4761 16800.0n 0.5408 17399.5n 0.5408 17400.0n 0.4906 17999.5n 0.4906 18000.0n 0.5663 18599.5n 0.5663 18600.0n 0.4023 19199.5n 0.4023 19200.0n 0.4636 19799.5n 0.4636 19800.0n 0.3878 20399.5n 0.3878 20400.0n 0.5144 20999.5n 0.5144 21000.0n 0.6139 21599.5n 0.6139 21600.0n 0.3906 22199.5n 0.3906 22200.0n 0.3636 22799.5n 0.3636 22800.0n 0.5193 23399.5n 0.5193 23400.0n 0.4386 23999.5n 0.4386 24000.0n 0.4087 24599.5n 0.4087 24600.0n 0.3705 25199.5n 0.3705 25200.0n 0.5504 25799.5n 0.5504 25800.0n 0.6208 26399.5n 0.6208 26400.0n 0.5566 26999.5n 0.5566 27000.0n 0.5660 27599.5n 0.5660 27600.0n 0.5539 28199.5n 0.5539 28200.0n 0.4209 28799.5n 0.4209 28800.0n 0.5223 29399.5n 0.5223 29400.0n 0.6122 29999.5n 0.6122 30000.0n 0.6168 30599.5n 0.6168 30600.0n 0.5978 31199.5n 0.5978 31200.0n 0.5518 31799.5n 0.5518 31800.0n 0.6338 32399.5n 0.6338 32400.0n 0.6143 32999.5n 0.6143 33000.0n 0.4416 33599.5n 0.4416 33600.0n 0.4716 34199.5n 0.4716 34200.0n 0.3966 34799.5n 0.3966 34800.0n 0.6531 35399.5n 0.6531 35400.0n 0.4710 35999.5n 0.4710)
Vyp_wih_0_11 yp_wih_0_11 0 PWL(0.0n 0.5678 599.5n 0.5678 600.0n 0.5538 1199.5n 0.5538 1200.0n 0.5879 1799.5n 0.5879 1800.0n 0.5865 2399.5n 0.5865 2400.0n 0.5783 2999.5n 0.5783 3000.0n 0.5704 3599.5n 0.5704 3600.0n 0.5846 4199.5n 0.5846 4200.0n 0.5690 4799.5n 0.5690 4800.0n 0.5760 5399.5n 0.5760 5400.0n 0.5758 5999.5n 0.5758 6000.0n 0.5891 6599.5n 0.5891 6600.0n 0.5761 7199.5n 0.5761 7200.0n 0.5604 7799.5n 0.5604 7800.0n 0.5608 8399.5n 0.5608 8400.0n 0.5774 8999.5n 0.5774 9000.0n 0.5757 9599.5n 0.5757 9600.0n 0.5751 10199.5n 0.5751 10200.0n 0.5691 10799.5n 0.5691 10800.0n 0.5908 11399.5n 0.5908 11400.0n 0.5753 11999.5n 0.5753 12000.0n 0.5784 12599.5n 0.5784 12600.0n 0.5749 13199.5n 0.5749 13200.0n 0.5652 13799.5n 0.5652 13800.0n 0.5619 14399.5n 0.5619 14400.0n 0.5738 14999.5n 0.5738 15000.0n 0.5753 15599.5n 0.5753 15600.0n 0.5730 16199.5n 0.5730 16200.0n 0.5605 16799.5n 0.5605 16800.0n 0.5795 17399.5n 0.5795 17400.0n 0.5651 17999.5n 0.5651 18000.0n 0.6316 18599.5n 0.6316 18600.0n 0.5313 19199.5n 0.5313 19200.0n 0.6028 19799.5n 0.6028 19800.0n 0.5567 20399.5n 0.5567 20400.0n 0.6191 20999.5n 0.6191 21000.0n 0.6265 21599.5n 0.6265 21600.0n 0.5448 22199.5n 0.5448 22200.0n 0.5299 22799.5n 0.5299 22800.0n 0.6229 23399.5n 0.6229 23400.0n 0.5089 23999.5n 0.5089 24000.0n 0.5763 24599.5n 0.5763 24600.0n 0.5249 25199.5n 0.5249 25200.0n 0.6283 25799.5n 0.6283 25800.0n 0.6529 26399.5n 0.6529 26400.0n 0.6366 26999.5n 0.6366 27000.0n 0.6375 27599.5n 0.6375 27600.0n 0.6351 28199.5n 0.6351 28200.0n 0.4989 28799.5n 0.4989 28800.0n 0.6234 29399.5n 0.6234 29400.0n 0.6225 29999.5n 0.6225 30000.0n 0.6157 30599.5n 0.6157 30600.0n 0.5699 31199.5n 0.5699 31200.0n 0.5478 31799.5n 0.5478 31800.0n 0.6511 32399.5n 0.6511 32400.0n 0.6531 32999.5n 0.6531 33000.0n 0.5962 33599.5n 0.5962 33600.0n 0.6105 34199.5n 0.6105 34200.0n 0.5209 34799.5n 0.5209 34800.0n 0.6028 35399.5n 0.6028 35400.0n 0.6081 35999.5n 0.6081)
Vyn_wih_0_11 yn_wih_0_11 0 PWL(0.0n 0.4322 599.5n 0.4322 600.0n 0.4462 1199.5n 0.4462 1200.0n 0.4121 1799.5n 0.4121 1800.0n 0.4135 2399.5n 0.4135 2400.0n 0.4217 2999.5n 0.4217 3000.0n 0.4296 3599.5n 0.4296 3600.0n 0.4154 4199.5n 0.4154 4200.0n 0.4310 4799.5n 0.4310 4800.0n 0.4240 5399.5n 0.4240 5400.0n 0.4242 5999.5n 0.4242 6000.0n 0.4109 6599.5n 0.4109 6600.0n 0.4239 7199.5n 0.4239 7200.0n 0.4396 7799.5n 0.4396 7800.0n 0.4392 8399.5n 0.4392 8400.0n 0.4226 8999.5n 0.4226 9000.0n 0.4243 9599.5n 0.4243 9600.0n 0.4249 10199.5n 0.4249 10200.0n 0.4309 10799.5n 0.4309 10800.0n 0.4092 11399.5n 0.4092 11400.0n 0.4247 11999.5n 0.4247 12000.0n 0.4216 12599.5n 0.4216 12600.0n 0.4251 13199.5n 0.4251 13200.0n 0.4348 13799.5n 0.4348 13800.0n 0.4381 14399.5n 0.4381 14400.0n 0.4262 14999.5n 0.4262 15000.0n 0.4247 15599.5n 0.4247 15600.0n 0.4270 16199.5n 0.4270 16200.0n 0.4395 16799.5n 0.4395 16800.0n 0.4205 17399.5n 0.4205 17400.0n 0.4349 17999.5n 0.4349 18000.0n 0.3684 18599.5n 0.3684 18600.0n 0.4687 19199.5n 0.4687 19200.0n 0.3972 19799.5n 0.3972 19800.0n 0.4433 20399.5n 0.4433 20400.0n 0.3809 20999.5n 0.3809 21000.0n 0.3735 21599.5n 0.3735 21600.0n 0.4552 22199.5n 0.4552 22200.0n 0.4701 22799.5n 0.4701 22800.0n 0.3771 23399.5n 0.3771 23400.0n 0.4911 23999.5n 0.4911 24000.0n 0.4237 24599.5n 0.4237 24600.0n 0.4751 25199.5n 0.4751 25200.0n 0.3717 25799.5n 0.3717 25800.0n 0.3471 26399.5n 0.3471 26400.0n 0.3634 26999.5n 0.3634 27000.0n 0.3625 27599.5n 0.3625 27600.0n 0.3649 28199.5n 0.3649 28200.0n 0.5011 28799.5n 0.5011 28800.0n 0.3766 29399.5n 0.3766 29400.0n 0.3775 29999.5n 0.3775 30000.0n 0.3843 30599.5n 0.3843 30600.0n 0.4301 31199.5n 0.4301 31200.0n 0.4522 31799.5n 0.4522 31800.0n 0.3489 32399.5n 0.3489 32400.0n 0.3469 32999.5n 0.3469 33000.0n 0.4038 33599.5n 0.4038 33600.0n 0.3895 34199.5n 0.3895 34200.0n 0.4791 34799.5n 0.4791 34800.0n 0.3972 35399.5n 0.3972 35400.0n 0.3919 35999.5n 0.3919)
Cwp_wih_0_11 wp_wih_0_11 0 400p
Cwn_wih_0_11 wn_wih_0_11 0 400p
Xu_wih_0_11 xp_wih_0_11 xn_wih_0_11 yp_wih_0_11 yn_wih_0_11 wp_wih_0_11 wn_wih_0_11 vdd gbn gprod
Vxp_wih_1_11 xp_wih_1_11 0 PWL(0.0n 0.5370 599.5n 0.5370 600.0n 0.5167 1199.5n 0.5167 1200.0n 0.4793 1799.5n 0.4793 1800.0n 0.4441 2399.5n 0.4441 2400.0n 0.4555 2999.5n 0.4555 3000.0n 0.5055 3599.5n 0.5055 3600.0n 0.4939 4199.5n 0.4939 4200.0n 0.5385 4799.5n 0.5385 4800.0n 0.5024 5399.5n 0.5024 5400.0n 0.5015 5999.5n 0.5015 6000.0n 0.4700 6599.5n 0.4700 6600.0n 0.5120 7199.5n 0.5120 7200.0n 0.5006 7799.5n 0.5006 7800.0n 0.4950 8399.5n 0.4950 8400.0n 0.5309 8999.5n 0.5309 9000.0n 0.5023 9599.5n 0.5023 9600.0n 0.4893 10199.5n 0.4893 10200.0n 0.4837 10799.5n 0.4837 10800.0n 0.4823 11399.5n 0.4823 11400.0n 0.5074 11999.5n 0.5074 12000.0n 0.5364 12599.5n 0.5364 12600.0n 0.4868 13199.5n 0.4868 13200.0n 0.5380 13799.5n 0.5380 13800.0n 0.5220 14399.5n 0.5220 14400.0n 0.5095 14999.5n 0.5095 15000.0n 0.4705 15599.5n 0.4705 15600.0n 0.5289 16199.5n 0.5289 16200.0n 0.5368 16799.5n 0.5368 16800.0n 0.5287 17399.5n 0.5287 17400.0n 0.5342 17999.5n 0.5342 18000.0n 0.4253 18599.5n 0.4253 18600.0n 0.5119 19199.5n 0.5119 19200.0n 0.4104 19799.5n 0.4104 19800.0n 0.4314 20399.5n 0.4314 20400.0n 0.4005 20999.5n 0.4005 21000.0n 0.4696 21599.5n 0.4696 21600.0n 0.4531 22199.5n 0.4531 22200.0n 0.5039 22799.5n 0.5039 22800.0n 0.3608 23399.5n 0.3608 23400.0n 0.6273 23999.5n 0.6273 24000.0n 0.3928 24599.5n 0.3928 24600.0n 0.5253 25199.5n 0.5253 25200.0n 0.4107 25799.5n 0.4107 25800.0n 0.3947 26399.5n 0.3947 26400.0n 0.3716 26999.5n 0.3716 27000.0n 0.4111 27599.5n 0.4111 27600.0n 0.3715 28199.5n 0.3715 28200.0n 0.5939 28799.5n 0.5939 28800.0n 0.3849 29399.5n 0.3849 29400.0n 0.4835 29999.5n 0.4835 30000.0n 0.5119 30599.5n 0.5119 30600.0n 0.6226 31199.5n 0.6226 31200.0n 0.6064 31799.5n 0.6064 31800.0n 0.4115 32399.5n 0.4115 32400.0n 0.3900 32999.5n 0.3900 33000.0n 0.3958 33599.5n 0.3958 33600.0n 0.3747 34199.5n 0.3747 34200.0n 0.5423 34799.5n 0.5423 34800.0n 0.5509 35399.5n 0.5509 35400.0n 0.3990 35999.5n 0.3990)
Vxn_wih_1_11 xn_wih_1_11 0 PWL(0.0n 0.4630 599.5n 0.4630 600.0n 0.4833 1199.5n 0.4833 1200.0n 0.5207 1799.5n 0.5207 1800.0n 0.5559 2399.5n 0.5559 2400.0n 0.5445 2999.5n 0.5445 3000.0n 0.4945 3599.5n 0.4945 3600.0n 0.5061 4199.5n 0.5061 4200.0n 0.4615 4799.5n 0.4615 4800.0n 0.4976 5399.5n 0.4976 5400.0n 0.4985 5999.5n 0.4985 6000.0n 0.5300 6599.5n 0.5300 6600.0n 0.4880 7199.5n 0.4880 7200.0n 0.4994 7799.5n 0.4994 7800.0n 0.5050 8399.5n 0.5050 8400.0n 0.4691 8999.5n 0.4691 9000.0n 0.4977 9599.5n 0.4977 9600.0n 0.5107 10199.5n 0.5107 10200.0n 0.5163 10799.5n 0.5163 10800.0n 0.5177 11399.5n 0.5177 11400.0n 0.4926 11999.5n 0.4926 12000.0n 0.4636 12599.5n 0.4636 12600.0n 0.5132 13199.5n 0.5132 13200.0n 0.4620 13799.5n 0.4620 13800.0n 0.4780 14399.5n 0.4780 14400.0n 0.4905 14999.5n 0.4905 15000.0n 0.5295 15599.5n 0.5295 15600.0n 0.4711 16199.5n 0.4711 16200.0n 0.4632 16799.5n 0.4632 16800.0n 0.4713 17399.5n 0.4713 17400.0n 0.4658 17999.5n 0.4658 18000.0n 0.5747 18599.5n 0.5747 18600.0n 0.4881 19199.5n 0.4881 19200.0n 0.5896 19799.5n 0.5896 19800.0n 0.5686 20399.5n 0.5686 20400.0n 0.5995 20999.5n 0.5995 21000.0n 0.5304 21599.5n 0.5304 21600.0n 0.5469 22199.5n 0.5469 22200.0n 0.4961 22799.5n 0.4961 22800.0n 0.6392 23399.5n 0.6392 23400.0n 0.3727 23999.5n 0.3727 24000.0n 0.6072 24599.5n 0.6072 24600.0n 0.4747 25199.5n 0.4747 25200.0n 0.5893 25799.5n 0.5893 25800.0n 0.6053 26399.5n 0.6053 26400.0n 0.6284 26999.5n 0.6284 27000.0n 0.5889 27599.5n 0.5889 27600.0n 0.6285 28199.5n 0.6285 28200.0n 0.4061 28799.5n 0.4061 28800.0n 0.6151 29399.5n 0.6151 29400.0n 0.5165 29999.5n 0.5165 30000.0n 0.4881 30599.5n 0.4881 30600.0n 0.3774 31199.5n 0.3774 31200.0n 0.3936 31799.5n 0.3936 31800.0n 0.5885 32399.5n 0.5885 32400.0n 0.6100 32999.5n 0.6100 33000.0n 0.6042 33599.5n 0.6042 33600.0n 0.6253 34199.5n 0.6253 34200.0n 0.4577 34799.5n 0.4577 34800.0n 0.4491 35399.5n 0.4491 35400.0n 0.6010 35999.5n 0.6010)
Vyp_wih_1_11 yp_wih_1_11 0 PWL(0.0n 0.5678 599.5n 0.5678 600.0n 0.5538 1199.5n 0.5538 1200.0n 0.5879 1799.5n 0.5879 1800.0n 0.5865 2399.5n 0.5865 2400.0n 0.5783 2999.5n 0.5783 3000.0n 0.5704 3599.5n 0.5704 3600.0n 0.5846 4199.5n 0.5846 4200.0n 0.5690 4799.5n 0.5690 4800.0n 0.5760 5399.5n 0.5760 5400.0n 0.5758 5999.5n 0.5758 6000.0n 0.5891 6599.5n 0.5891 6600.0n 0.5761 7199.5n 0.5761 7200.0n 0.5604 7799.5n 0.5604 7800.0n 0.5608 8399.5n 0.5608 8400.0n 0.5774 8999.5n 0.5774 9000.0n 0.5757 9599.5n 0.5757 9600.0n 0.5751 10199.5n 0.5751 10200.0n 0.5691 10799.5n 0.5691 10800.0n 0.5908 11399.5n 0.5908 11400.0n 0.5753 11999.5n 0.5753 12000.0n 0.5784 12599.5n 0.5784 12600.0n 0.5749 13199.5n 0.5749 13200.0n 0.5652 13799.5n 0.5652 13800.0n 0.5619 14399.5n 0.5619 14400.0n 0.5738 14999.5n 0.5738 15000.0n 0.5753 15599.5n 0.5753 15600.0n 0.5730 16199.5n 0.5730 16200.0n 0.5605 16799.5n 0.5605 16800.0n 0.5795 17399.5n 0.5795 17400.0n 0.5651 17999.5n 0.5651 18000.0n 0.6316 18599.5n 0.6316 18600.0n 0.5313 19199.5n 0.5313 19200.0n 0.6028 19799.5n 0.6028 19800.0n 0.5567 20399.5n 0.5567 20400.0n 0.6191 20999.5n 0.6191 21000.0n 0.6265 21599.5n 0.6265 21600.0n 0.5448 22199.5n 0.5448 22200.0n 0.5299 22799.5n 0.5299 22800.0n 0.6229 23399.5n 0.6229 23400.0n 0.5089 23999.5n 0.5089 24000.0n 0.5763 24599.5n 0.5763 24600.0n 0.5249 25199.5n 0.5249 25200.0n 0.6283 25799.5n 0.6283 25800.0n 0.6529 26399.5n 0.6529 26400.0n 0.6366 26999.5n 0.6366 27000.0n 0.6375 27599.5n 0.6375 27600.0n 0.6351 28199.5n 0.6351 28200.0n 0.4989 28799.5n 0.4989 28800.0n 0.6234 29399.5n 0.6234 29400.0n 0.6225 29999.5n 0.6225 30000.0n 0.6157 30599.5n 0.6157 30600.0n 0.5699 31199.5n 0.5699 31200.0n 0.5478 31799.5n 0.5478 31800.0n 0.6511 32399.5n 0.6511 32400.0n 0.6531 32999.5n 0.6531 33000.0n 0.5962 33599.5n 0.5962 33600.0n 0.6105 34199.5n 0.6105 34200.0n 0.5209 34799.5n 0.5209 34800.0n 0.6028 35399.5n 0.6028 35400.0n 0.6081 35999.5n 0.6081)
Vyn_wih_1_11 yn_wih_1_11 0 PWL(0.0n 0.4322 599.5n 0.4322 600.0n 0.4462 1199.5n 0.4462 1200.0n 0.4121 1799.5n 0.4121 1800.0n 0.4135 2399.5n 0.4135 2400.0n 0.4217 2999.5n 0.4217 3000.0n 0.4296 3599.5n 0.4296 3600.0n 0.4154 4199.5n 0.4154 4200.0n 0.4310 4799.5n 0.4310 4800.0n 0.4240 5399.5n 0.4240 5400.0n 0.4242 5999.5n 0.4242 6000.0n 0.4109 6599.5n 0.4109 6600.0n 0.4239 7199.5n 0.4239 7200.0n 0.4396 7799.5n 0.4396 7800.0n 0.4392 8399.5n 0.4392 8400.0n 0.4226 8999.5n 0.4226 9000.0n 0.4243 9599.5n 0.4243 9600.0n 0.4249 10199.5n 0.4249 10200.0n 0.4309 10799.5n 0.4309 10800.0n 0.4092 11399.5n 0.4092 11400.0n 0.4247 11999.5n 0.4247 12000.0n 0.4216 12599.5n 0.4216 12600.0n 0.4251 13199.5n 0.4251 13200.0n 0.4348 13799.5n 0.4348 13800.0n 0.4381 14399.5n 0.4381 14400.0n 0.4262 14999.5n 0.4262 15000.0n 0.4247 15599.5n 0.4247 15600.0n 0.4270 16199.5n 0.4270 16200.0n 0.4395 16799.5n 0.4395 16800.0n 0.4205 17399.5n 0.4205 17400.0n 0.4349 17999.5n 0.4349 18000.0n 0.3684 18599.5n 0.3684 18600.0n 0.4687 19199.5n 0.4687 19200.0n 0.3972 19799.5n 0.3972 19800.0n 0.4433 20399.5n 0.4433 20400.0n 0.3809 20999.5n 0.3809 21000.0n 0.3735 21599.5n 0.3735 21600.0n 0.4552 22199.5n 0.4552 22200.0n 0.4701 22799.5n 0.4701 22800.0n 0.3771 23399.5n 0.3771 23400.0n 0.4911 23999.5n 0.4911 24000.0n 0.4237 24599.5n 0.4237 24600.0n 0.4751 25199.5n 0.4751 25200.0n 0.3717 25799.5n 0.3717 25800.0n 0.3471 26399.5n 0.3471 26400.0n 0.3634 26999.5n 0.3634 27000.0n 0.3625 27599.5n 0.3625 27600.0n 0.3649 28199.5n 0.3649 28200.0n 0.5011 28799.5n 0.5011 28800.0n 0.3766 29399.5n 0.3766 29400.0n 0.3775 29999.5n 0.3775 30000.0n 0.3843 30599.5n 0.3843 30600.0n 0.4301 31199.5n 0.4301 31200.0n 0.4522 31799.5n 0.4522 31800.0n 0.3489 32399.5n 0.3489 32400.0n 0.3469 32999.5n 0.3469 33000.0n 0.4038 33599.5n 0.4038 33600.0n 0.3895 34199.5n 0.3895 34200.0n 0.4791 34799.5n 0.4791 34800.0n 0.3972 35399.5n 0.3972 35400.0n 0.3919 35999.5n 0.3919)
Cwp_wih_1_11 wp_wih_1_11 0 400p
Cwn_wih_1_11 wn_wih_1_11 0 400p
Xu_wih_1_11 xp_wih_1_11 xn_wih_1_11 yp_wih_1_11 yn_wih_1_11 wp_wih_1_11 wn_wih_1_11 vdd gbn gprod
Vxp_who_11_0 xp_who_11_0 0 PWL(0.0n 0.5678 599.5n 0.5678 600.0n 0.5538 1199.5n 0.5538 1200.0n 0.5879 1799.5n 0.5879 1800.0n 0.5865 2399.5n 0.5865 2400.0n 0.5783 2999.5n 0.5783 3000.0n 0.5704 3599.5n 0.5704 3600.0n 0.5846 4199.5n 0.5846 4200.0n 0.5690 4799.5n 0.5690 4800.0n 0.5760 5399.5n 0.5760 5400.0n 0.5758 5999.5n 0.5758 6000.0n 0.5891 6599.5n 0.5891 6600.0n 0.5761 7199.5n 0.5761 7200.0n 0.5604 7799.5n 0.5604 7800.0n 0.5608 8399.5n 0.5608 8400.0n 0.5774 8999.5n 0.5774 9000.0n 0.5757 9599.5n 0.5757 9600.0n 0.5751 10199.5n 0.5751 10200.0n 0.5691 10799.5n 0.5691 10800.0n 0.5908 11399.5n 0.5908 11400.0n 0.5753 11999.5n 0.5753 12000.0n 0.5784 12599.5n 0.5784 12600.0n 0.5749 13199.5n 0.5749 13200.0n 0.5652 13799.5n 0.5652 13800.0n 0.5619 14399.5n 0.5619 14400.0n 0.5738 14999.5n 0.5738 15000.0n 0.5753 15599.5n 0.5753 15600.0n 0.5730 16199.5n 0.5730 16200.0n 0.5605 16799.5n 0.5605 16800.0n 0.5795 17399.5n 0.5795 17400.0n 0.5651 17999.5n 0.5651 18000.0n 0.6316 18599.5n 0.6316 18600.0n 0.5313 19199.5n 0.5313 19200.0n 0.6028 19799.5n 0.6028 19800.0n 0.5567 20399.5n 0.5567 20400.0n 0.6191 20999.5n 0.6191 21000.0n 0.6265 21599.5n 0.6265 21600.0n 0.5448 22199.5n 0.5448 22200.0n 0.5299 22799.5n 0.5299 22800.0n 0.6229 23399.5n 0.6229 23400.0n 0.5089 23999.5n 0.5089 24000.0n 0.5763 24599.5n 0.5763 24600.0n 0.5249 25199.5n 0.5249 25200.0n 0.6283 25799.5n 0.6283 25800.0n 0.6529 26399.5n 0.6529 26400.0n 0.6366 26999.5n 0.6366 27000.0n 0.6375 27599.5n 0.6375 27600.0n 0.6351 28199.5n 0.6351 28200.0n 0.4989 28799.5n 0.4989 28800.0n 0.6234 29399.5n 0.6234 29400.0n 0.6225 29999.5n 0.6225 30000.0n 0.6157 30599.5n 0.6157 30600.0n 0.5699 31199.5n 0.5699 31200.0n 0.5478 31799.5n 0.5478 31800.0n 0.6511 32399.5n 0.6511 32400.0n 0.6531 32999.5n 0.6531 33000.0n 0.5962 33599.5n 0.5962 33600.0n 0.6105 34199.5n 0.6105 34200.0n 0.5209 34799.5n 0.5209 34800.0n 0.6028 35399.5n 0.6028 35400.0n 0.6081 35999.5n 0.6081)
Vxn_who_11_0 xn_who_11_0 0 PWL(0.0n 0.4322 599.5n 0.4322 600.0n 0.4462 1199.5n 0.4462 1200.0n 0.4121 1799.5n 0.4121 1800.0n 0.4135 2399.5n 0.4135 2400.0n 0.4217 2999.5n 0.4217 3000.0n 0.4296 3599.5n 0.4296 3600.0n 0.4154 4199.5n 0.4154 4200.0n 0.4310 4799.5n 0.4310 4800.0n 0.4240 5399.5n 0.4240 5400.0n 0.4242 5999.5n 0.4242 6000.0n 0.4109 6599.5n 0.4109 6600.0n 0.4239 7199.5n 0.4239 7200.0n 0.4396 7799.5n 0.4396 7800.0n 0.4392 8399.5n 0.4392 8400.0n 0.4226 8999.5n 0.4226 9000.0n 0.4243 9599.5n 0.4243 9600.0n 0.4249 10199.5n 0.4249 10200.0n 0.4309 10799.5n 0.4309 10800.0n 0.4092 11399.5n 0.4092 11400.0n 0.4247 11999.5n 0.4247 12000.0n 0.4216 12599.5n 0.4216 12600.0n 0.4251 13199.5n 0.4251 13200.0n 0.4348 13799.5n 0.4348 13800.0n 0.4381 14399.5n 0.4381 14400.0n 0.4262 14999.5n 0.4262 15000.0n 0.4247 15599.5n 0.4247 15600.0n 0.4270 16199.5n 0.4270 16200.0n 0.4395 16799.5n 0.4395 16800.0n 0.4205 17399.5n 0.4205 17400.0n 0.4349 17999.5n 0.4349 18000.0n 0.3684 18599.5n 0.3684 18600.0n 0.4687 19199.5n 0.4687 19200.0n 0.3972 19799.5n 0.3972 19800.0n 0.4433 20399.5n 0.4433 20400.0n 0.3809 20999.5n 0.3809 21000.0n 0.3735 21599.5n 0.3735 21600.0n 0.4552 22199.5n 0.4552 22200.0n 0.4701 22799.5n 0.4701 22800.0n 0.3771 23399.5n 0.3771 23400.0n 0.4911 23999.5n 0.4911 24000.0n 0.4237 24599.5n 0.4237 24600.0n 0.4751 25199.5n 0.4751 25200.0n 0.3717 25799.5n 0.3717 25800.0n 0.3471 26399.5n 0.3471 26400.0n 0.3634 26999.5n 0.3634 27000.0n 0.3625 27599.5n 0.3625 27600.0n 0.3649 28199.5n 0.3649 28200.0n 0.5011 28799.5n 0.5011 28800.0n 0.3766 29399.5n 0.3766 29400.0n 0.3775 29999.5n 0.3775 30000.0n 0.3843 30599.5n 0.3843 30600.0n 0.4301 31199.5n 0.4301 31200.0n 0.4522 31799.5n 0.4522 31800.0n 0.3489 32399.5n 0.3489 32400.0n 0.3469 32999.5n 0.3469 33000.0n 0.4038 33599.5n 0.4038 33600.0n 0.3895 34199.5n 0.3895 34200.0n 0.4791 34799.5n 0.4791 34800.0n 0.3972 35399.5n 0.3972 35400.0n 0.3919 35999.5n 0.3919)
Vyp_who_11_0 yp_who_11_0 0 PWL(0.0n 0.5031 599.5n 0.5031 600.0n 0.5023 1199.5n 0.5023 1200.0n 0.5052 1799.5n 0.5052 1800.0n 0.5048 2399.5n 0.5048 2400.0n 0.5043 2999.5n 0.5043 3000.0n 0.5034 3599.5n 0.5034 3600.0n 0.5048 4199.5n 0.5048 4200.0n 0.5031 4799.5n 0.5031 4800.0n 0.5040 5399.5n 0.5040 5400.0n 0.5040 5999.5n 0.5040 6000.0n 0.5054 6599.5n 0.5054 6600.0n 0.5040 7199.5n 0.5040 7200.0n 0.5027 7799.5n 0.5027 7800.0n 0.5027 8399.5n 0.5027 8400.0n 0.5038 8999.5n 0.5038 9000.0n 0.5040 9599.5n 0.5040 9600.0n 0.5039 10199.5n 0.5039 10200.0n 0.5033 10799.5n 0.5033 10800.0n 0.5056 11399.5n 0.5056 11400.0n 0.5040 11999.5n 0.5040 12000.0n 0.5036 12599.5n 0.5036 12600.0n 0.5039 13199.5n 0.5039 13200.0n 0.5029 13799.5n 0.5029 13800.0n 0.5025 14399.5n 0.5025 14400.0n 0.5038 14999.5n 0.5038 15000.0n 0.5041 15599.5n 0.5041 15600.0n 0.5036 16199.5n 0.5036 16200.0n 0.5025 16799.5n 0.5025 16800.0n 0.5040 17399.5n 0.5040 17400.0n 0.5029 17999.5n 0.5029 18000.0n 0.5057 18599.5n 0.5057 18600.0n 0.5010 19199.5n 0.5010 19200.0n 0.5041 19799.5n 0.5041 19800.0n 0.5021 20399.5n 0.5021 20400.0n 0.5044 20999.5n 0.5044 21000.0n 0.5056 21599.5n 0.5056 21600.0n 0.5016 22199.5n 0.5016 22200.0n 0.5006 22799.5n 0.5006 22800.0n 0.5041 23399.5n 0.5041 23400.0n 0.5027 23999.5n 0.5027 24000.0n 0.5029 24599.5n 0.5029 24600.0n 0.5006 25199.5n 0.5006 25200.0n 0.5047 25799.5n 0.5047 25800.0n 0.5046 26399.5n 0.5046 26400.0n 0.5039 26999.5n 0.5039 27000.0n 0.5049 27599.5n 0.5049 27600.0n 0.5039 28199.5n 0.5039 28200.0n 0.5017 28799.5n 0.5017 28800.0n 0.5042 29399.5n 0.5042 29400.0n 0.5056 29999.5n 0.5056 30000.0n 0.5051 30599.5n 0.5051 30600.0n 0.5039 31199.5n 0.5039 31200.0n 0.5033 31799.5n 0.5033 31800.0n 0.5049 32399.5n 0.5049 32400.0n 0.5045 32999.5n 0.5045 33000.0n 0.5036 33599.5n 0.5036 33600.0n 0.5042 34199.5n 0.5042 34200.0n 0.5012 34799.5n 0.5012 34800.0n 0.5036 35399.5n 0.5036 35400.0n 0.5042 35999.5n 0.5042)
Vyn_who_11_0 yn_who_11_0 0 PWL(0.0n 0.4969 599.5n 0.4969 600.0n 0.4977 1199.5n 0.4977 1200.0n 0.4948 1799.5n 0.4948 1800.0n 0.4952 2399.5n 0.4952 2400.0n 0.4957 2999.5n 0.4957 3000.0n 0.4966 3599.5n 0.4966 3600.0n 0.4952 4199.5n 0.4952 4200.0n 0.4969 4799.5n 0.4969 4800.0n 0.4960 5399.5n 0.4960 5400.0n 0.4960 5999.5n 0.4960 6000.0n 0.4946 6599.5n 0.4946 6600.0n 0.4960 7199.5n 0.4960 7200.0n 0.4973 7799.5n 0.4973 7800.0n 0.4973 8399.5n 0.4973 8400.0n 0.4962 8999.5n 0.4962 9000.0n 0.4960 9599.5n 0.4960 9600.0n 0.4961 10199.5n 0.4961 10200.0n 0.4967 10799.5n 0.4967 10800.0n 0.4944 11399.5n 0.4944 11400.0n 0.4960 11999.5n 0.4960 12000.0n 0.4964 12599.5n 0.4964 12600.0n 0.4961 13199.5n 0.4961 13200.0n 0.4971 13799.5n 0.4971 13800.0n 0.4975 14399.5n 0.4975 14400.0n 0.4962 14999.5n 0.4962 15000.0n 0.4959 15599.5n 0.4959 15600.0n 0.4964 16199.5n 0.4964 16200.0n 0.4975 16799.5n 0.4975 16800.0n 0.4960 17399.5n 0.4960 17400.0n 0.4971 17999.5n 0.4971 18000.0n 0.4943 18599.5n 0.4943 18600.0n 0.4990 19199.5n 0.4990 19200.0n 0.4959 19799.5n 0.4959 19800.0n 0.4979 20399.5n 0.4979 20400.0n 0.4956 20999.5n 0.4956 21000.0n 0.4944 21599.5n 0.4944 21600.0n 0.4984 22199.5n 0.4984 22200.0n 0.4994 22799.5n 0.4994 22800.0n 0.4959 23399.5n 0.4959 23400.0n 0.4973 23999.5n 0.4973 24000.0n 0.4971 24599.5n 0.4971 24600.0n 0.4994 25199.5n 0.4994 25200.0n 0.4953 25799.5n 0.4953 25800.0n 0.4954 26399.5n 0.4954 26400.0n 0.4961 26999.5n 0.4961 27000.0n 0.4951 27599.5n 0.4951 27600.0n 0.4961 28199.5n 0.4961 28200.0n 0.4983 28799.5n 0.4983 28800.0n 0.4958 29399.5n 0.4958 29400.0n 0.4944 29999.5n 0.4944 30000.0n 0.4949 30599.5n 0.4949 30600.0n 0.4961 31199.5n 0.4961 31200.0n 0.4967 31799.5n 0.4967 31800.0n 0.4951 32399.5n 0.4951 32400.0n 0.4955 32999.5n 0.4955 33000.0n 0.4964 33599.5n 0.4964 33600.0n 0.4958 34199.5n 0.4958 34200.0n 0.4988 34799.5n 0.4988 34800.0n 0.4964 35399.5n 0.4964 35400.0n 0.4958 35999.5n 0.4958)
Cwp_who_11_0 wp_who_11_0 0 400p
Cwn_who_11_0 wn_who_11_0 0 400p
Xu_who_11_0 xp_who_11_0 xn_who_11_0 yp_who_11_0 yn_who_11_0 wp_who_11_0 wn_who_11_0 vdd gbn gprod
Vxp_who_11_1 xp_who_11_1 0 PWL(0.0n 0.5678 599.5n 0.5678 600.0n 0.5538 1199.5n 0.5538 1200.0n 0.5879 1799.5n 0.5879 1800.0n 0.5865 2399.5n 0.5865 2400.0n 0.5783 2999.5n 0.5783 3000.0n 0.5704 3599.5n 0.5704 3600.0n 0.5846 4199.5n 0.5846 4200.0n 0.5690 4799.5n 0.5690 4800.0n 0.5760 5399.5n 0.5760 5400.0n 0.5758 5999.5n 0.5758 6000.0n 0.5891 6599.5n 0.5891 6600.0n 0.5761 7199.5n 0.5761 7200.0n 0.5604 7799.5n 0.5604 7800.0n 0.5608 8399.5n 0.5608 8400.0n 0.5774 8999.5n 0.5774 9000.0n 0.5757 9599.5n 0.5757 9600.0n 0.5751 10199.5n 0.5751 10200.0n 0.5691 10799.5n 0.5691 10800.0n 0.5908 11399.5n 0.5908 11400.0n 0.5753 11999.5n 0.5753 12000.0n 0.5784 12599.5n 0.5784 12600.0n 0.5749 13199.5n 0.5749 13200.0n 0.5652 13799.5n 0.5652 13800.0n 0.5619 14399.5n 0.5619 14400.0n 0.5738 14999.5n 0.5738 15000.0n 0.5753 15599.5n 0.5753 15600.0n 0.5730 16199.5n 0.5730 16200.0n 0.5605 16799.5n 0.5605 16800.0n 0.5795 17399.5n 0.5795 17400.0n 0.5651 17999.5n 0.5651 18000.0n 0.6316 18599.5n 0.6316 18600.0n 0.5313 19199.5n 0.5313 19200.0n 0.6028 19799.5n 0.6028 19800.0n 0.5567 20399.5n 0.5567 20400.0n 0.6191 20999.5n 0.6191 21000.0n 0.6265 21599.5n 0.6265 21600.0n 0.5448 22199.5n 0.5448 22200.0n 0.5299 22799.5n 0.5299 22800.0n 0.6229 23399.5n 0.6229 23400.0n 0.5089 23999.5n 0.5089 24000.0n 0.5763 24599.5n 0.5763 24600.0n 0.5249 25199.5n 0.5249 25200.0n 0.6283 25799.5n 0.6283 25800.0n 0.6529 26399.5n 0.6529 26400.0n 0.6366 26999.5n 0.6366 27000.0n 0.6375 27599.5n 0.6375 27600.0n 0.6351 28199.5n 0.6351 28200.0n 0.4989 28799.5n 0.4989 28800.0n 0.6234 29399.5n 0.6234 29400.0n 0.6225 29999.5n 0.6225 30000.0n 0.6157 30599.5n 0.6157 30600.0n 0.5699 31199.5n 0.5699 31200.0n 0.5478 31799.5n 0.5478 31800.0n 0.6511 32399.5n 0.6511 32400.0n 0.6531 32999.5n 0.6531 33000.0n 0.5962 33599.5n 0.5962 33600.0n 0.6105 34199.5n 0.6105 34200.0n 0.5209 34799.5n 0.5209 34800.0n 0.6028 35399.5n 0.6028 35400.0n 0.6081 35999.5n 0.6081)
Vxn_who_11_1 xn_who_11_1 0 PWL(0.0n 0.4322 599.5n 0.4322 600.0n 0.4462 1199.5n 0.4462 1200.0n 0.4121 1799.5n 0.4121 1800.0n 0.4135 2399.5n 0.4135 2400.0n 0.4217 2999.5n 0.4217 3000.0n 0.4296 3599.5n 0.4296 3600.0n 0.4154 4199.5n 0.4154 4200.0n 0.4310 4799.5n 0.4310 4800.0n 0.4240 5399.5n 0.4240 5400.0n 0.4242 5999.5n 0.4242 6000.0n 0.4109 6599.5n 0.4109 6600.0n 0.4239 7199.5n 0.4239 7200.0n 0.4396 7799.5n 0.4396 7800.0n 0.4392 8399.5n 0.4392 8400.0n 0.4226 8999.5n 0.4226 9000.0n 0.4243 9599.5n 0.4243 9600.0n 0.4249 10199.5n 0.4249 10200.0n 0.4309 10799.5n 0.4309 10800.0n 0.4092 11399.5n 0.4092 11400.0n 0.4247 11999.5n 0.4247 12000.0n 0.4216 12599.5n 0.4216 12600.0n 0.4251 13199.5n 0.4251 13200.0n 0.4348 13799.5n 0.4348 13800.0n 0.4381 14399.5n 0.4381 14400.0n 0.4262 14999.5n 0.4262 15000.0n 0.4247 15599.5n 0.4247 15600.0n 0.4270 16199.5n 0.4270 16200.0n 0.4395 16799.5n 0.4395 16800.0n 0.4205 17399.5n 0.4205 17400.0n 0.4349 17999.5n 0.4349 18000.0n 0.3684 18599.5n 0.3684 18600.0n 0.4687 19199.5n 0.4687 19200.0n 0.3972 19799.5n 0.3972 19800.0n 0.4433 20399.5n 0.4433 20400.0n 0.3809 20999.5n 0.3809 21000.0n 0.3735 21599.5n 0.3735 21600.0n 0.4552 22199.5n 0.4552 22200.0n 0.4701 22799.5n 0.4701 22800.0n 0.3771 23399.5n 0.3771 23400.0n 0.4911 23999.5n 0.4911 24000.0n 0.4237 24599.5n 0.4237 24600.0n 0.4751 25199.5n 0.4751 25200.0n 0.3717 25799.5n 0.3717 25800.0n 0.3471 26399.5n 0.3471 26400.0n 0.3634 26999.5n 0.3634 27000.0n 0.3625 27599.5n 0.3625 27600.0n 0.3649 28199.5n 0.3649 28200.0n 0.5011 28799.5n 0.5011 28800.0n 0.3766 29399.5n 0.3766 29400.0n 0.3775 29999.5n 0.3775 30000.0n 0.3843 30599.5n 0.3843 30600.0n 0.4301 31199.5n 0.4301 31200.0n 0.4522 31799.5n 0.4522 31800.0n 0.3489 32399.5n 0.3489 32400.0n 0.3469 32999.5n 0.3469 33000.0n 0.4038 33599.5n 0.4038 33600.0n 0.3895 34199.5n 0.3895 34200.0n 0.4791 34799.5n 0.4791 34800.0n 0.3972 35399.5n 0.3972 35400.0n 0.3919 35999.5n 0.3919)
Vyp_who_11_1 yp_who_11_1 0 PWL(0.0n 0.5071 599.5n 0.5071 600.0n 0.5053 1199.5n 0.5053 1200.0n 0.5052 1799.5n 0.5052 1800.0n 0.5027 2399.5n 0.5027 2400.0n 0.5034 2999.5n 0.5034 3000.0n 0.5055 3599.5n 0.5055 3600.0n 0.5056 4199.5n 0.5056 4200.0n 0.5071 4799.5n 0.5071 4800.0n 0.5056 5399.5n 0.5056 5400.0n 0.5056 5999.5n 0.5056 6000.0n 0.5048 6599.5n 0.5048 6600.0n 0.5060 7199.5n 0.5060 7200.0n 0.5048 7799.5n 0.5048 7800.0n 0.5046 8399.5n 0.5046 8400.0n 0.5066 8999.5n 0.5066 9000.0n 0.5056 9599.5n 0.5056 9600.0n 0.5051 10199.5n 0.5051 10200.0n 0.5046 10799.5n 0.5046 10800.0n 0.5056 11399.5n 0.5056 11400.0n 0.5058 11999.5n 0.5058 12000.0n 0.5068 12599.5n 0.5068 12600.0n 0.5050 13199.5n 0.5050 13200.0n 0.5071 13799.5n 0.5071 13800.0n 0.5059 14399.5n 0.5059 14400.0n 0.5058 14999.5n 0.5058 15000.0n 0.5043 15599.5n 0.5043 15600.0n 0.5067 16199.5n 0.5067 16200.0n 0.5068 16799.5n 0.5068 16800.0n 0.5066 17399.5n 0.5066 17400.0n 0.5069 17999.5n 0.5069 18000.0n 0.5061 18599.5n 0.5061 18600.0n 0.5034 19199.5n 0.5034 19200.0n 0.5010 19799.5n 0.5010 19800.0n 0.4989 20399.5n 0.4989 20400.0n 0.5022 20999.5n 0.5022 21000.0n 0.5086 21599.5n 0.5086 21600.0n 0.5007 22199.5n 0.5007 22200.0n 0.5023 22799.5n 0.5023 22800.0n 0.5021 23399.5n 0.5021 23400.0n 0.5077 23999.5n 0.5077 24000.0n 0.4979 24599.5n 0.4979 24600.0n 0.5035 25199.5n 0.5035 25200.0n 0.5041 25799.5n 0.5041 25800.0n 0.5075 26399.5n 0.5075 26400.0n 0.5041 26999.5n 0.5041 27000.0n 0.5056 27599.5n 0.5056 27600.0n 0.5039 28199.5n 0.5039 28200.0n 0.5059 28799.5n 0.5059 28800.0n 0.5023 29399.5n 0.5023 29400.0n 0.5086 29999.5n 0.5086 30000.0n 0.5084 30599.5n 0.5084 30600.0n 0.5085 31199.5n 0.5085 31200.0n 0.5088 31799.5n 0.5088 31800.0n 0.5078 32399.5n 0.5078 32400.0n 0.5074 32999.5n 0.5074 33000.0n 0.4996 33599.5n 0.4996 33600.0n 0.5010 34199.5n 0.5010 34200.0n 0.5044 34799.5n 0.5044 34800.0n 0.5084 35399.5n 0.5084 35400.0n 0.5012 35999.5n 0.5012)
Vyn_who_11_1 yn_who_11_1 0 PWL(0.0n 0.4929 599.5n 0.4929 600.0n 0.4947 1199.5n 0.4947 1200.0n 0.4948 1799.5n 0.4948 1800.0n 0.4973 2399.5n 0.4973 2400.0n 0.4966 2999.5n 0.4966 3000.0n 0.4945 3599.5n 0.4945 3600.0n 0.4944 4199.5n 0.4944 4200.0n 0.4929 4799.5n 0.4929 4800.0n 0.4944 5399.5n 0.4944 5400.0n 0.4944 5999.5n 0.4944 6000.0n 0.4952 6599.5n 0.4952 6600.0n 0.4940 7199.5n 0.4940 7200.0n 0.4952 7799.5n 0.4952 7800.0n 0.4954 8399.5n 0.4954 8400.0n 0.4934 8999.5n 0.4934 9000.0n 0.4944 9599.5n 0.4944 9600.0n 0.4949 10199.5n 0.4949 10200.0n 0.4954 10799.5n 0.4954 10800.0n 0.4944 11399.5n 0.4944 11400.0n 0.4942 11999.5n 0.4942 12000.0n 0.4932 12599.5n 0.4932 12600.0n 0.4950 13199.5n 0.4950 13200.0n 0.4929 13799.5n 0.4929 13800.0n 0.4941 14399.5n 0.4941 14400.0n 0.4942 14999.5n 0.4942 15000.0n 0.4957 15599.5n 0.4957 15600.0n 0.4933 16199.5n 0.4933 16200.0n 0.4932 16799.5n 0.4932 16800.0n 0.4934 17399.5n 0.4934 17400.0n 0.4931 17999.5n 0.4931 18000.0n 0.4939 18599.5n 0.4939 18600.0n 0.4966 19199.5n 0.4966 19200.0n 0.4990 19799.5n 0.4990 19800.0n 0.5011 20399.5n 0.5011 20400.0n 0.4978 20999.5n 0.4978 21000.0n 0.4914 21599.5n 0.4914 21600.0n 0.4993 22199.5n 0.4993 22200.0n 0.4977 22799.5n 0.4977 22800.0n 0.4979 23399.5n 0.4979 23400.0n 0.4923 23999.5n 0.4923 24000.0n 0.5021 24599.5n 0.5021 24600.0n 0.4965 25199.5n 0.4965 25200.0n 0.4959 25799.5n 0.4959 25800.0n 0.4925 26399.5n 0.4925 26400.0n 0.4959 26999.5n 0.4959 27000.0n 0.4944 27599.5n 0.4944 27600.0n 0.4961 28199.5n 0.4961 28200.0n 0.4941 28799.5n 0.4941 28800.0n 0.4977 29399.5n 0.4977 29400.0n 0.4914 29999.5n 0.4914 30000.0n 0.4916 30599.5n 0.4916 30600.0n 0.4915 31199.5n 0.4915 31200.0n 0.4912 31799.5n 0.4912 31800.0n 0.4922 32399.5n 0.4922 32400.0n 0.4926 32999.5n 0.4926 33000.0n 0.5004 33599.5n 0.5004 33600.0n 0.4990 34199.5n 0.4990 34200.0n 0.4956 34799.5n 0.4956 34800.0n 0.4916 35399.5n 0.4916 35400.0n 0.4988 35999.5n 0.4988)
Cwp_who_11_1 wp_who_11_1 0 400p
Cwn_who_11_1 wn_who_11_1 0 400p
Xu_who_11_1 xp_who_11_1 xn_who_11_1 yp_who_11_1 yn_who_11_1 wp_who_11_1 wn_who_11_1 vdd gbn gprod
Vxp_bh_11 xp_bh_11 0 PWL(0.0n 0.7100 599.5n 0.7100 600.0n 0.7100 1199.5n 0.7100 1200.0n 0.7100 1799.5n 0.7100 1800.0n 0.7100 2399.5n 0.7100 2400.0n 0.7100 2999.5n 0.7100 3000.0n 0.7100 3599.5n 0.7100 3600.0n 0.7100 4199.5n 0.7100 4200.0n 0.7100 4799.5n 0.7100 4800.0n 0.7100 5399.5n 0.7100 5400.0n 0.7100 5999.5n 0.7100 6000.0n 0.7100 6599.5n 0.7100 6600.0n 0.7100 7199.5n 0.7100 7200.0n 0.7100 7799.5n 0.7100 7800.0n 0.7100 8399.5n 0.7100 8400.0n 0.7100 8999.5n 0.7100 9000.0n 0.7100 9599.5n 0.7100 9600.0n 0.7100 10199.5n 0.7100 10200.0n 0.7100 10799.5n 0.7100 10800.0n 0.7100 11399.5n 0.7100 11400.0n 0.7100 11999.5n 0.7100 12000.0n 0.7100 12599.5n 0.7100 12600.0n 0.7100 13199.5n 0.7100 13200.0n 0.7100 13799.5n 0.7100 13800.0n 0.7100 14399.5n 0.7100 14400.0n 0.7100 14999.5n 0.7100 15000.0n 0.7100 15599.5n 0.7100 15600.0n 0.7100 16199.5n 0.7100 16200.0n 0.7100 16799.5n 0.7100 16800.0n 0.7100 17399.5n 0.7100 17400.0n 0.7100 17999.5n 0.7100 18000.0n 0.7100 18599.5n 0.7100 18600.0n 0.7100 19199.5n 0.7100 19200.0n 0.7100 19799.5n 0.7100 19800.0n 0.7100 20399.5n 0.7100 20400.0n 0.7100 20999.5n 0.7100 21000.0n 0.7100 21599.5n 0.7100 21600.0n 0.7100 22199.5n 0.7100 22200.0n 0.7100 22799.5n 0.7100 22800.0n 0.7100 23399.5n 0.7100 23400.0n 0.7100 23999.5n 0.7100 24000.0n 0.7100 24599.5n 0.7100 24600.0n 0.7100 25199.5n 0.7100 25200.0n 0.7100 25799.5n 0.7100 25800.0n 0.7100 26399.5n 0.7100 26400.0n 0.7100 26999.5n 0.7100 27000.0n 0.7100 27599.5n 0.7100 27600.0n 0.7100 28199.5n 0.7100 28200.0n 0.7100 28799.5n 0.7100 28800.0n 0.7100 29399.5n 0.7100 29400.0n 0.7100 29999.5n 0.7100 30000.0n 0.7100 30599.5n 0.7100 30600.0n 0.7100 31199.5n 0.7100 31200.0n 0.7100 31799.5n 0.7100 31800.0n 0.7100 32399.5n 0.7100 32400.0n 0.7100 32999.5n 0.7100 33000.0n 0.7100 33599.5n 0.7100 33600.0n 0.7100 34199.5n 0.7100 34200.0n 0.7100 34799.5n 0.7100 34800.0n 0.7100 35399.5n 0.7100 35400.0n 0.7100 35999.5n 0.7100)
Vxn_bh_11 xn_bh_11 0 PWL(0.0n 0.2900 599.5n 0.2900 600.0n 0.2900 1199.5n 0.2900 1200.0n 0.2900 1799.5n 0.2900 1800.0n 0.2900 2399.5n 0.2900 2400.0n 0.2900 2999.5n 0.2900 3000.0n 0.2900 3599.5n 0.2900 3600.0n 0.2900 4199.5n 0.2900 4200.0n 0.2900 4799.5n 0.2900 4800.0n 0.2900 5399.5n 0.2900 5400.0n 0.2900 5999.5n 0.2900 6000.0n 0.2900 6599.5n 0.2900 6600.0n 0.2900 7199.5n 0.2900 7200.0n 0.2900 7799.5n 0.2900 7800.0n 0.2900 8399.5n 0.2900 8400.0n 0.2900 8999.5n 0.2900 9000.0n 0.2900 9599.5n 0.2900 9600.0n 0.2900 10199.5n 0.2900 10200.0n 0.2900 10799.5n 0.2900 10800.0n 0.2900 11399.5n 0.2900 11400.0n 0.2900 11999.5n 0.2900 12000.0n 0.2900 12599.5n 0.2900 12600.0n 0.2900 13199.5n 0.2900 13200.0n 0.2900 13799.5n 0.2900 13800.0n 0.2900 14399.5n 0.2900 14400.0n 0.2900 14999.5n 0.2900 15000.0n 0.2900 15599.5n 0.2900 15600.0n 0.2900 16199.5n 0.2900 16200.0n 0.2900 16799.5n 0.2900 16800.0n 0.2900 17399.5n 0.2900 17400.0n 0.2900 17999.5n 0.2900 18000.0n 0.2900 18599.5n 0.2900 18600.0n 0.2900 19199.5n 0.2900 19200.0n 0.2900 19799.5n 0.2900 19800.0n 0.2900 20399.5n 0.2900 20400.0n 0.2900 20999.5n 0.2900 21000.0n 0.2900 21599.5n 0.2900 21600.0n 0.2900 22199.5n 0.2900 22200.0n 0.2900 22799.5n 0.2900 22800.0n 0.2900 23399.5n 0.2900 23400.0n 0.2900 23999.5n 0.2900 24000.0n 0.2900 24599.5n 0.2900 24600.0n 0.2900 25199.5n 0.2900 25200.0n 0.2900 25799.5n 0.2900 25800.0n 0.2900 26399.5n 0.2900 26400.0n 0.2900 26999.5n 0.2900 27000.0n 0.2900 27599.5n 0.2900 27600.0n 0.2900 28199.5n 0.2900 28200.0n 0.2900 28799.5n 0.2900 28800.0n 0.2900 29399.5n 0.2900 29400.0n 0.2900 29999.5n 0.2900 30000.0n 0.2900 30599.5n 0.2900 30600.0n 0.2900 31199.5n 0.2900 31200.0n 0.2900 31799.5n 0.2900 31800.0n 0.2900 32399.5n 0.2900 32400.0n 0.2900 32999.5n 0.2900 33000.0n 0.2900 33599.5n 0.2900 33600.0n 0.2900 34199.5n 0.2900 34200.0n 0.2900 34799.5n 0.2900 34800.0n 0.2900 35399.5n 0.2900 35400.0n 0.2900 35999.5n 0.2900)
Vyp_bh_11 yp_bh_11 0 PWL(0.0n 0.5678 599.5n 0.5678 600.0n 0.5538 1199.5n 0.5538 1200.0n 0.5879 1799.5n 0.5879 1800.0n 0.5865 2399.5n 0.5865 2400.0n 0.5783 2999.5n 0.5783 3000.0n 0.5704 3599.5n 0.5704 3600.0n 0.5846 4199.5n 0.5846 4200.0n 0.5690 4799.5n 0.5690 4800.0n 0.5760 5399.5n 0.5760 5400.0n 0.5758 5999.5n 0.5758 6000.0n 0.5891 6599.5n 0.5891 6600.0n 0.5761 7199.5n 0.5761 7200.0n 0.5604 7799.5n 0.5604 7800.0n 0.5608 8399.5n 0.5608 8400.0n 0.5774 8999.5n 0.5774 9000.0n 0.5757 9599.5n 0.5757 9600.0n 0.5751 10199.5n 0.5751 10200.0n 0.5691 10799.5n 0.5691 10800.0n 0.5908 11399.5n 0.5908 11400.0n 0.5753 11999.5n 0.5753 12000.0n 0.5784 12599.5n 0.5784 12600.0n 0.5749 13199.5n 0.5749 13200.0n 0.5652 13799.5n 0.5652 13800.0n 0.5619 14399.5n 0.5619 14400.0n 0.5738 14999.5n 0.5738 15000.0n 0.5753 15599.5n 0.5753 15600.0n 0.5730 16199.5n 0.5730 16200.0n 0.5605 16799.5n 0.5605 16800.0n 0.5795 17399.5n 0.5795 17400.0n 0.5651 17999.5n 0.5651 18000.0n 0.6316 18599.5n 0.6316 18600.0n 0.5313 19199.5n 0.5313 19200.0n 0.6028 19799.5n 0.6028 19800.0n 0.5567 20399.5n 0.5567 20400.0n 0.6191 20999.5n 0.6191 21000.0n 0.6265 21599.5n 0.6265 21600.0n 0.5448 22199.5n 0.5448 22200.0n 0.5299 22799.5n 0.5299 22800.0n 0.6229 23399.5n 0.6229 23400.0n 0.5089 23999.5n 0.5089 24000.0n 0.5763 24599.5n 0.5763 24600.0n 0.5249 25199.5n 0.5249 25200.0n 0.6283 25799.5n 0.6283 25800.0n 0.6529 26399.5n 0.6529 26400.0n 0.6366 26999.5n 0.6366 27000.0n 0.6375 27599.5n 0.6375 27600.0n 0.6351 28199.5n 0.6351 28200.0n 0.4989 28799.5n 0.4989 28800.0n 0.6234 29399.5n 0.6234 29400.0n 0.6225 29999.5n 0.6225 30000.0n 0.6157 30599.5n 0.6157 30600.0n 0.5699 31199.5n 0.5699 31200.0n 0.5478 31799.5n 0.5478 31800.0n 0.6511 32399.5n 0.6511 32400.0n 0.6531 32999.5n 0.6531 33000.0n 0.5962 33599.5n 0.5962 33600.0n 0.6105 34199.5n 0.6105 34200.0n 0.5209 34799.5n 0.5209 34800.0n 0.6028 35399.5n 0.6028 35400.0n 0.6081 35999.5n 0.6081)
Vyn_bh_11 yn_bh_11 0 PWL(0.0n 0.4322 599.5n 0.4322 600.0n 0.4462 1199.5n 0.4462 1200.0n 0.4121 1799.5n 0.4121 1800.0n 0.4135 2399.5n 0.4135 2400.0n 0.4217 2999.5n 0.4217 3000.0n 0.4296 3599.5n 0.4296 3600.0n 0.4154 4199.5n 0.4154 4200.0n 0.4310 4799.5n 0.4310 4800.0n 0.4240 5399.5n 0.4240 5400.0n 0.4242 5999.5n 0.4242 6000.0n 0.4109 6599.5n 0.4109 6600.0n 0.4239 7199.5n 0.4239 7200.0n 0.4396 7799.5n 0.4396 7800.0n 0.4392 8399.5n 0.4392 8400.0n 0.4226 8999.5n 0.4226 9000.0n 0.4243 9599.5n 0.4243 9600.0n 0.4249 10199.5n 0.4249 10200.0n 0.4309 10799.5n 0.4309 10800.0n 0.4092 11399.5n 0.4092 11400.0n 0.4247 11999.5n 0.4247 12000.0n 0.4216 12599.5n 0.4216 12600.0n 0.4251 13199.5n 0.4251 13200.0n 0.4348 13799.5n 0.4348 13800.0n 0.4381 14399.5n 0.4381 14400.0n 0.4262 14999.5n 0.4262 15000.0n 0.4247 15599.5n 0.4247 15600.0n 0.4270 16199.5n 0.4270 16200.0n 0.4395 16799.5n 0.4395 16800.0n 0.4205 17399.5n 0.4205 17400.0n 0.4349 17999.5n 0.4349 18000.0n 0.3684 18599.5n 0.3684 18600.0n 0.4687 19199.5n 0.4687 19200.0n 0.3972 19799.5n 0.3972 19800.0n 0.4433 20399.5n 0.4433 20400.0n 0.3809 20999.5n 0.3809 21000.0n 0.3735 21599.5n 0.3735 21600.0n 0.4552 22199.5n 0.4552 22200.0n 0.4701 22799.5n 0.4701 22800.0n 0.3771 23399.5n 0.3771 23400.0n 0.4911 23999.5n 0.4911 24000.0n 0.4237 24599.5n 0.4237 24600.0n 0.4751 25199.5n 0.4751 25200.0n 0.3717 25799.5n 0.3717 25800.0n 0.3471 26399.5n 0.3471 26400.0n 0.3634 26999.5n 0.3634 27000.0n 0.3625 27599.5n 0.3625 27600.0n 0.3649 28199.5n 0.3649 28200.0n 0.5011 28799.5n 0.5011 28800.0n 0.3766 29399.5n 0.3766 29400.0n 0.3775 29999.5n 0.3775 30000.0n 0.3843 30599.5n 0.3843 30600.0n 0.4301 31199.5n 0.4301 31200.0n 0.4522 31799.5n 0.4522 31800.0n 0.3489 32399.5n 0.3489 32400.0n 0.3469 32999.5n 0.3469 33000.0n 0.4038 33599.5n 0.4038 33600.0n 0.3895 34199.5n 0.3895 34200.0n 0.4791 34799.5n 0.4791 34800.0n 0.3972 35399.5n 0.3972 35400.0n 0.3919 35999.5n 0.3919)
Cwp_bh_11 wp_bh_11 0 400p
Cwn_bh_11 wn_bh_11 0 400p
Xu_bh_11 xp_bh_11 xn_bh_11 yp_bh_11 yn_bh_11 wp_bh_11 wn_bh_11 vdd gbn gprod
Vxp_wih_0_12 xp_wih_0_12 0 PWL(0.0n 0.4942 599.5n 0.4942 600.0n 0.5558 1199.5n 0.5558 1200.0n 0.4708 1799.5n 0.4708 1800.0n 0.5235 2399.5n 0.5235 2400.0n 0.5350 2999.5n 0.5350 3000.0n 0.5172 3599.5n 0.5172 3600.0n 0.4702 4199.5n 0.4702 4200.0n 0.4867 4799.5n 0.4867 4800.0n 0.4970 5399.5n 0.4970 5400.0n 0.4986 5999.5n 0.4986 6000.0n 0.4751 6599.5n 0.4751 6600.0n 0.4870 7199.5n 0.4870 7200.0n 0.5502 7799.5n 0.5502 7800.0n 0.5521 8399.5n 0.5521 8400.0n 0.4638 8999.5n 0.4638 9000.0n 0.4982 9599.5n 0.4982 9600.0n 0.5131 10199.5n 0.5131 10200.0n 0.5386 10799.5n 0.5386 10800.0n 0.4592 11399.5n 0.4592 11400.0n 0.4950 11999.5n 0.4950 12000.0n 0.4559 12599.5n 0.4559 12600.0n 0.5162 13199.5n 0.5162 13200.0n 0.5038 13799.5n 0.5038 13800.0n 0.5333 14399.5n 0.5333 14400.0n 0.4991 14999.5n 0.4991 15000.0n 0.5298 15599.5n 0.5298 15600.0n 0.4823 16199.5n 0.4823 16200.0n 0.5239 16799.5n 0.5239 16800.0n 0.4592 17399.5n 0.4592 17400.0n 0.5094 17999.5n 0.5094 18000.0n 0.4337 18599.5n 0.4337 18600.0n 0.5977 19199.5n 0.5977 19200.0n 0.5364 19799.5n 0.5364 19800.0n 0.6122 20399.5n 0.6122 20400.0n 0.4856 20999.5n 0.4856 21000.0n 0.3861 21599.5n 0.3861 21600.0n 0.6094 22199.5n 0.6094 22200.0n 0.6364 22799.5n 0.6364 22800.0n 0.4807 23399.5n 0.4807 23400.0n 0.5614 23999.5n 0.5614 24000.0n 0.5913 24599.5n 0.5913 24600.0n 0.6295 25199.5n 0.6295 25200.0n 0.4496 25799.5n 0.4496 25800.0n 0.3792 26399.5n 0.3792 26400.0n 0.4434 26999.5n 0.4434 27000.0n 0.4340 27599.5n 0.4340 27600.0n 0.4461 28199.5n 0.4461 28200.0n 0.5791 28799.5n 0.5791 28800.0n 0.4777 29399.5n 0.4777 29400.0n 0.3878 29999.5n 0.3878 30000.0n 0.3832 30599.5n 0.3832 30600.0n 0.4022 31199.5n 0.4022 31200.0n 0.4482 31799.5n 0.4482 31800.0n 0.3662 32399.5n 0.3662 32400.0n 0.3857 32999.5n 0.3857 33000.0n 0.5584 33599.5n 0.5584 33600.0n 0.5284 34199.5n 0.5284 34200.0n 0.6034 34799.5n 0.6034 34800.0n 0.3469 35399.5n 0.3469 35400.0n 0.5290 35999.5n 0.5290)
Vxn_wih_0_12 xn_wih_0_12 0 PWL(0.0n 0.5058 599.5n 0.5058 600.0n 0.4442 1199.5n 0.4442 1200.0n 0.5292 1799.5n 0.5292 1800.0n 0.4765 2399.5n 0.4765 2400.0n 0.4650 2999.5n 0.4650 3000.0n 0.4828 3599.5n 0.4828 3600.0n 0.5298 4199.5n 0.5298 4200.0n 0.5133 4799.5n 0.5133 4800.0n 0.5030 5399.5n 0.5030 5400.0n 0.5014 5999.5n 0.5014 6000.0n 0.5249 6599.5n 0.5249 6600.0n 0.5130 7199.5n 0.5130 7200.0n 0.4498 7799.5n 0.4498 7800.0n 0.4479 8399.5n 0.4479 8400.0n 0.5362 8999.5n 0.5362 9000.0n 0.5018 9599.5n 0.5018 9600.0n 0.4869 10199.5n 0.4869 10200.0n 0.4614 10799.5n 0.4614 10800.0n 0.5408 11399.5n 0.5408 11400.0n 0.5050 11999.5n 0.5050 12000.0n 0.5441 12599.5n 0.5441 12600.0n 0.4838 13199.5n 0.4838 13200.0n 0.4962 13799.5n 0.4962 13800.0n 0.4667 14399.5n 0.4667 14400.0n 0.5009 14999.5n 0.5009 15000.0n 0.4702 15599.5n 0.4702 15600.0n 0.5177 16199.5n 0.5177 16200.0n 0.4761 16799.5n 0.4761 16800.0n 0.5408 17399.5n 0.5408 17400.0n 0.4906 17999.5n 0.4906 18000.0n 0.5663 18599.5n 0.5663 18600.0n 0.4023 19199.5n 0.4023 19200.0n 0.4636 19799.5n 0.4636 19800.0n 0.3878 20399.5n 0.3878 20400.0n 0.5144 20999.5n 0.5144 21000.0n 0.6139 21599.5n 0.6139 21600.0n 0.3906 22199.5n 0.3906 22200.0n 0.3636 22799.5n 0.3636 22800.0n 0.5193 23399.5n 0.5193 23400.0n 0.4386 23999.5n 0.4386 24000.0n 0.4087 24599.5n 0.4087 24600.0n 0.3705 25199.5n 0.3705 25200.0n 0.5504 25799.5n 0.5504 25800.0n 0.6208 26399.5n 0.6208 26400.0n 0.5566 26999.5n 0.5566 27000.0n 0.5660 27599.5n 0.5660 27600.0n 0.5539 28199.5n 0.5539 28200.0n 0.4209 28799.5n 0.4209 28800.0n 0.5223 29399.5n 0.5223 29400.0n 0.6122 29999.5n 0.6122 30000.0n 0.6168 30599.5n 0.6168 30600.0n 0.5978 31199.5n 0.5978 31200.0n 0.5518 31799.5n 0.5518 31800.0n 0.6338 32399.5n 0.6338 32400.0n 0.6143 32999.5n 0.6143 33000.0n 0.4416 33599.5n 0.4416 33600.0n 0.4716 34199.5n 0.4716 34200.0n 0.3966 34799.5n 0.3966 34800.0n 0.6531 35399.5n 0.6531 35400.0n 0.4710 35999.5n 0.4710)
Vyp_wih_0_12 yp_wih_0_12 0 PWL(0.0n 0.4921 599.5n 0.4921 600.0n 0.4953 1199.5n 0.4953 1200.0n 0.4340 1799.5n 0.4340 1800.0n 0.4081 2399.5n 0.4081 2400.0n 0.4291 2999.5n 0.4291 3000.0n 0.4697 3599.5n 0.4697 3600.0n 0.4459 4199.5n 0.4459 4200.0n 0.4917 4799.5n 0.4917 4800.0n 0.4611 5399.5n 0.4611 5400.0n 0.4609 5999.5n 0.4609 6000.0n 0.4267 6599.5n 0.4267 6600.0n 0.4659 7199.5n 0.4659 7200.0n 0.4789 7799.5n 0.4789 7800.0n 0.4756 8399.5n 0.4756 8400.0n 0.4756 8999.5n 0.4756 9000.0n 0.4614 9599.5n 0.4614 9600.0n 0.4554 10199.5n 0.4554 10200.0n 0.4598 10799.5n 0.4598 10800.0n 0.4321 11399.5n 0.4321 11400.0n 0.4645 11999.5n 0.4645 12000.0n 0.4784 12599.5n 0.4784 12600.0n 0.4543 13199.5n 0.4543 13200.0n 0.4961 13799.5n 0.4961 13800.0n 0.4893 14399.5n 0.4893 14400.0n 0.4674 14999.5n 0.4674 15000.0n 0.4441 15599.5n 0.4441 15600.0n 0.4798 16199.5n 0.4798 16200.0n 0.5009 16799.5n 0.5009 16800.0n 0.4714 17399.5n 0.4714 17400.0n 0.4934 17999.5n 0.4934 18000.0n 0.3511 18599.5n 0.3511 18600.0n 0.5174 19199.5n 0.5174 19200.0n 0.3683 19799.5n 0.3683 19800.0n 0.4286 20399.5n 0.4286 20400.0n 0.3529 20999.5n 0.3529 21000.0n 0.3880 21599.5n 0.3880 21600.0n 0.4655 22199.5n 0.4655 22200.0n 0.5148 22799.5n 0.5148 22800.0n 0.3460 23399.5n 0.3460 23400.0n 0.6065 23999.5n 0.6065 24000.0n 0.3914 24599.5n 0.3914 24600.0n 0.5324 25199.5n 0.5324 25200.0n 0.3499 25799.5n 0.3499 25800.0n 0.3379 26399.5n 0.3379 26400.0n 0.3425 26999.5n 0.3425 27000.0n 0.3464 27599.5n 0.3464 27600.0n 0.3430 28199.5n 0.3430 28200.0n 0.6067 28799.5n 0.6067 28800.0n 0.3488 29399.5n 0.3488 29400.0n 0.4000 29999.5n 0.4000 30000.0n 0.4213 30599.5n 0.4213 30600.0n 0.5367 31199.5n 0.5367 31200.0n 0.5575 31799.5n 0.5575 31800.0n 0.3404 32399.5n 0.3404 32400.0n 0.3375 32999.5n 0.3375 33000.0n 0.3716 33599.5n 0.3716 33600.0n 0.3527 34199.5n 0.3527 34200.0n 0.5475 34799.5n 0.5475 34800.0n 0.4629 35399.5n 0.4629 35400.0n 0.3599 35999.5n 0.3599)
Vyn_wih_0_12 yn_wih_0_12 0 PWL(0.0n 0.5079 599.5n 0.5079 600.0n 0.5047 1199.5n 0.5047 1200.0n 0.5660 1799.5n 0.5660 1800.0n 0.5919 2399.5n 0.5919 2400.0n 0.5709 2999.5n 0.5709 3000.0n 0.5303 3599.5n 0.5303 3600.0n 0.5541 4199.5n 0.5541 4200.0n 0.5083 4799.5n 0.5083 4800.0n 0.5389 5399.5n 0.5389 5400.0n 0.5391 5999.5n 0.5391 6000.0n 0.5733 6599.5n 0.5733 6600.0n 0.5341 7199.5n 0.5341 7200.0n 0.5211 7799.5n 0.5211 7800.0n 0.5244 8399.5n 0.5244 8400.0n 0.5244 8999.5n 0.5244 9000.0n 0.5386 9599.5n 0.5386 9600.0n 0.5446 10199.5n 0.5446 10200.0n 0.5402 10799.5n 0.5402 10800.0n 0.5679 11399.5n 0.5679 11400.0n 0.5355 11999.5n 0.5355 12000.0n 0.5216 12599.5n 0.5216 12600.0n 0.5457 13199.5n 0.5457 13200.0n 0.5039 13799.5n 0.5039 13800.0n 0.5107 14399.5n 0.5107 14400.0n 0.5326 14999.5n 0.5326 15000.0n 0.5559 15599.5n 0.5559 15600.0n 0.5202 16199.5n 0.5202 16200.0n 0.4991 16799.5n 0.4991 16800.0n 0.5286 17399.5n 0.5286 17400.0n 0.5066 17999.5n 0.5066 18000.0n 0.6489 18599.5n 0.6489 18600.0n 0.4826 19199.5n 0.4826 19200.0n 0.6317 19799.5n 0.6317 19800.0n 0.5714 20399.5n 0.5714 20400.0n 0.6471 20999.5n 0.6471 21000.0n 0.6120 21599.5n 0.6120 21600.0n 0.5345 22199.5n 0.5345 22200.0n 0.4852 22799.5n 0.4852 22800.0n 0.6540 23399.5n 0.6540 23400.0n 0.3935 23999.5n 0.3935 24000.0n 0.6086 24599.5n 0.6086 24600.0n 0.4676 25199.5n 0.4676 25200.0n 0.6501 25799.5n 0.6501 25800.0n 0.6621 26399.5n 0.6621 26400.0n 0.6575 26999.5n 0.6575 27000.0n 0.6536 27599.5n 0.6536 27600.0n 0.6570 28199.5n 0.6570 28200.0n 0.3933 28799.5n 0.3933 28800.0n 0.6512 29399.5n 0.6512 29400.0n 0.6000 29999.5n 0.6000 30000.0n 0.5787 30599.5n 0.5787 30600.0n 0.4633 31199.5n 0.4633 31200.0n 0.4425 31799.5n 0.4425 31800.0n 0.6596 32399.5n 0.6596 32400.0n 0.6625 32999.5n 0.6625 33000.0n 0.6284 33599.5n 0.6284 33600.0n 0.6473 34199.5n 0.6473 34200.0n 0.4525 34799.5n 0.4525 34800.0n 0.5371 35399.5n 0.5371 35400.0n 0.6401 35999.5n 0.6401)
Cwp_wih_0_12 wp_wih_0_12 0 400p
Cwn_wih_0_12 wn_wih_0_12 0 400p
Xu_wih_0_12 xp_wih_0_12 xn_wih_0_12 yp_wih_0_12 yn_wih_0_12 wp_wih_0_12 wn_wih_0_12 vdd gbn gprod
Vxp_wih_1_12 xp_wih_1_12 0 PWL(0.0n 0.5370 599.5n 0.5370 600.0n 0.5167 1199.5n 0.5167 1200.0n 0.4793 1799.5n 0.4793 1800.0n 0.4441 2399.5n 0.4441 2400.0n 0.4555 2999.5n 0.4555 3000.0n 0.5055 3599.5n 0.5055 3600.0n 0.4939 4199.5n 0.4939 4200.0n 0.5385 4799.5n 0.5385 4800.0n 0.5024 5399.5n 0.5024 5400.0n 0.5015 5999.5n 0.5015 6000.0n 0.4700 6599.5n 0.4700 6600.0n 0.5120 7199.5n 0.5120 7200.0n 0.5006 7799.5n 0.5006 7800.0n 0.4950 8399.5n 0.4950 8400.0n 0.5309 8999.5n 0.5309 9000.0n 0.5023 9599.5n 0.5023 9600.0n 0.4893 10199.5n 0.4893 10200.0n 0.4837 10799.5n 0.4837 10800.0n 0.4823 11399.5n 0.4823 11400.0n 0.5074 11999.5n 0.5074 12000.0n 0.5364 12599.5n 0.5364 12600.0n 0.4868 13199.5n 0.4868 13200.0n 0.5380 13799.5n 0.5380 13800.0n 0.5220 14399.5n 0.5220 14400.0n 0.5095 14999.5n 0.5095 15000.0n 0.4705 15599.5n 0.4705 15600.0n 0.5289 16199.5n 0.5289 16200.0n 0.5368 16799.5n 0.5368 16800.0n 0.5287 17399.5n 0.5287 17400.0n 0.5342 17999.5n 0.5342 18000.0n 0.4253 18599.5n 0.4253 18600.0n 0.5119 19199.5n 0.5119 19200.0n 0.4104 19799.5n 0.4104 19800.0n 0.4314 20399.5n 0.4314 20400.0n 0.4005 20999.5n 0.4005 21000.0n 0.4696 21599.5n 0.4696 21600.0n 0.4531 22199.5n 0.4531 22200.0n 0.5039 22799.5n 0.5039 22800.0n 0.3608 23399.5n 0.3608 23400.0n 0.6273 23999.5n 0.6273 24000.0n 0.3928 24599.5n 0.3928 24600.0n 0.5253 25199.5n 0.5253 25200.0n 0.4107 25799.5n 0.4107 25800.0n 0.3947 26399.5n 0.3947 26400.0n 0.3716 26999.5n 0.3716 27000.0n 0.4111 27599.5n 0.4111 27600.0n 0.3715 28199.5n 0.3715 28200.0n 0.5939 28799.5n 0.5939 28800.0n 0.3849 29399.5n 0.3849 29400.0n 0.4835 29999.5n 0.4835 30000.0n 0.5119 30599.5n 0.5119 30600.0n 0.6226 31199.5n 0.6226 31200.0n 0.6064 31799.5n 0.6064 31800.0n 0.4115 32399.5n 0.4115 32400.0n 0.3900 32999.5n 0.3900 33000.0n 0.3958 33599.5n 0.3958 33600.0n 0.3747 34199.5n 0.3747 34200.0n 0.5423 34799.5n 0.5423 34800.0n 0.5509 35399.5n 0.5509 35400.0n 0.3990 35999.5n 0.3990)
Vxn_wih_1_12 xn_wih_1_12 0 PWL(0.0n 0.4630 599.5n 0.4630 600.0n 0.4833 1199.5n 0.4833 1200.0n 0.5207 1799.5n 0.5207 1800.0n 0.5559 2399.5n 0.5559 2400.0n 0.5445 2999.5n 0.5445 3000.0n 0.4945 3599.5n 0.4945 3600.0n 0.5061 4199.5n 0.5061 4200.0n 0.4615 4799.5n 0.4615 4800.0n 0.4976 5399.5n 0.4976 5400.0n 0.4985 5999.5n 0.4985 6000.0n 0.5300 6599.5n 0.5300 6600.0n 0.4880 7199.5n 0.4880 7200.0n 0.4994 7799.5n 0.4994 7800.0n 0.5050 8399.5n 0.5050 8400.0n 0.4691 8999.5n 0.4691 9000.0n 0.4977 9599.5n 0.4977 9600.0n 0.5107 10199.5n 0.5107 10200.0n 0.5163 10799.5n 0.5163 10800.0n 0.5177 11399.5n 0.5177 11400.0n 0.4926 11999.5n 0.4926 12000.0n 0.4636 12599.5n 0.4636 12600.0n 0.5132 13199.5n 0.5132 13200.0n 0.4620 13799.5n 0.4620 13800.0n 0.4780 14399.5n 0.4780 14400.0n 0.4905 14999.5n 0.4905 15000.0n 0.5295 15599.5n 0.5295 15600.0n 0.4711 16199.5n 0.4711 16200.0n 0.4632 16799.5n 0.4632 16800.0n 0.4713 17399.5n 0.4713 17400.0n 0.4658 17999.5n 0.4658 18000.0n 0.5747 18599.5n 0.5747 18600.0n 0.4881 19199.5n 0.4881 19200.0n 0.5896 19799.5n 0.5896 19800.0n 0.5686 20399.5n 0.5686 20400.0n 0.5995 20999.5n 0.5995 21000.0n 0.5304 21599.5n 0.5304 21600.0n 0.5469 22199.5n 0.5469 22200.0n 0.4961 22799.5n 0.4961 22800.0n 0.6392 23399.5n 0.6392 23400.0n 0.3727 23999.5n 0.3727 24000.0n 0.6072 24599.5n 0.6072 24600.0n 0.4747 25199.5n 0.4747 25200.0n 0.5893 25799.5n 0.5893 25800.0n 0.6053 26399.5n 0.6053 26400.0n 0.6284 26999.5n 0.6284 27000.0n 0.5889 27599.5n 0.5889 27600.0n 0.6285 28199.5n 0.6285 28200.0n 0.4061 28799.5n 0.4061 28800.0n 0.6151 29399.5n 0.6151 29400.0n 0.5165 29999.5n 0.5165 30000.0n 0.4881 30599.5n 0.4881 30600.0n 0.3774 31199.5n 0.3774 31200.0n 0.3936 31799.5n 0.3936 31800.0n 0.5885 32399.5n 0.5885 32400.0n 0.6100 32999.5n 0.6100 33000.0n 0.6042 33599.5n 0.6042 33600.0n 0.6253 34199.5n 0.6253 34200.0n 0.4577 34799.5n 0.4577 34800.0n 0.4491 35399.5n 0.4491 35400.0n 0.6010 35999.5n 0.6010)
Vyp_wih_1_12 yp_wih_1_12 0 PWL(0.0n 0.4921 599.5n 0.4921 600.0n 0.4953 1199.5n 0.4953 1200.0n 0.4340 1799.5n 0.4340 1800.0n 0.4081 2399.5n 0.4081 2400.0n 0.4291 2999.5n 0.4291 3000.0n 0.4697 3599.5n 0.4697 3600.0n 0.4459 4199.5n 0.4459 4200.0n 0.4917 4799.5n 0.4917 4800.0n 0.4611 5399.5n 0.4611 5400.0n 0.4609 5999.5n 0.4609 6000.0n 0.4267 6599.5n 0.4267 6600.0n 0.4659 7199.5n 0.4659 7200.0n 0.4789 7799.5n 0.4789 7800.0n 0.4756 8399.5n 0.4756 8400.0n 0.4756 8999.5n 0.4756 9000.0n 0.4614 9599.5n 0.4614 9600.0n 0.4554 10199.5n 0.4554 10200.0n 0.4598 10799.5n 0.4598 10800.0n 0.4321 11399.5n 0.4321 11400.0n 0.4645 11999.5n 0.4645 12000.0n 0.4784 12599.5n 0.4784 12600.0n 0.4543 13199.5n 0.4543 13200.0n 0.4961 13799.5n 0.4961 13800.0n 0.4893 14399.5n 0.4893 14400.0n 0.4674 14999.5n 0.4674 15000.0n 0.4441 15599.5n 0.4441 15600.0n 0.4798 16199.5n 0.4798 16200.0n 0.5009 16799.5n 0.5009 16800.0n 0.4714 17399.5n 0.4714 17400.0n 0.4934 17999.5n 0.4934 18000.0n 0.3511 18599.5n 0.3511 18600.0n 0.5174 19199.5n 0.5174 19200.0n 0.3683 19799.5n 0.3683 19800.0n 0.4286 20399.5n 0.4286 20400.0n 0.3529 20999.5n 0.3529 21000.0n 0.3880 21599.5n 0.3880 21600.0n 0.4655 22199.5n 0.4655 22200.0n 0.5148 22799.5n 0.5148 22800.0n 0.3460 23399.5n 0.3460 23400.0n 0.6065 23999.5n 0.6065 24000.0n 0.3914 24599.5n 0.3914 24600.0n 0.5324 25199.5n 0.5324 25200.0n 0.3499 25799.5n 0.3499 25800.0n 0.3379 26399.5n 0.3379 26400.0n 0.3425 26999.5n 0.3425 27000.0n 0.3464 27599.5n 0.3464 27600.0n 0.3430 28199.5n 0.3430 28200.0n 0.6067 28799.5n 0.6067 28800.0n 0.3488 29399.5n 0.3488 29400.0n 0.4000 29999.5n 0.4000 30000.0n 0.4213 30599.5n 0.4213 30600.0n 0.5367 31199.5n 0.5367 31200.0n 0.5575 31799.5n 0.5575 31800.0n 0.3404 32399.5n 0.3404 32400.0n 0.3375 32999.5n 0.3375 33000.0n 0.3716 33599.5n 0.3716 33600.0n 0.3527 34199.5n 0.3527 34200.0n 0.5475 34799.5n 0.5475 34800.0n 0.4629 35399.5n 0.4629 35400.0n 0.3599 35999.5n 0.3599)
Vyn_wih_1_12 yn_wih_1_12 0 PWL(0.0n 0.5079 599.5n 0.5079 600.0n 0.5047 1199.5n 0.5047 1200.0n 0.5660 1799.5n 0.5660 1800.0n 0.5919 2399.5n 0.5919 2400.0n 0.5709 2999.5n 0.5709 3000.0n 0.5303 3599.5n 0.5303 3600.0n 0.5541 4199.5n 0.5541 4200.0n 0.5083 4799.5n 0.5083 4800.0n 0.5389 5399.5n 0.5389 5400.0n 0.5391 5999.5n 0.5391 6000.0n 0.5733 6599.5n 0.5733 6600.0n 0.5341 7199.5n 0.5341 7200.0n 0.5211 7799.5n 0.5211 7800.0n 0.5244 8399.5n 0.5244 8400.0n 0.5244 8999.5n 0.5244 9000.0n 0.5386 9599.5n 0.5386 9600.0n 0.5446 10199.5n 0.5446 10200.0n 0.5402 10799.5n 0.5402 10800.0n 0.5679 11399.5n 0.5679 11400.0n 0.5355 11999.5n 0.5355 12000.0n 0.5216 12599.5n 0.5216 12600.0n 0.5457 13199.5n 0.5457 13200.0n 0.5039 13799.5n 0.5039 13800.0n 0.5107 14399.5n 0.5107 14400.0n 0.5326 14999.5n 0.5326 15000.0n 0.5559 15599.5n 0.5559 15600.0n 0.5202 16199.5n 0.5202 16200.0n 0.4991 16799.5n 0.4991 16800.0n 0.5286 17399.5n 0.5286 17400.0n 0.5066 17999.5n 0.5066 18000.0n 0.6489 18599.5n 0.6489 18600.0n 0.4826 19199.5n 0.4826 19200.0n 0.6317 19799.5n 0.6317 19800.0n 0.5714 20399.5n 0.5714 20400.0n 0.6471 20999.5n 0.6471 21000.0n 0.6120 21599.5n 0.6120 21600.0n 0.5345 22199.5n 0.5345 22200.0n 0.4852 22799.5n 0.4852 22800.0n 0.6540 23399.5n 0.6540 23400.0n 0.3935 23999.5n 0.3935 24000.0n 0.6086 24599.5n 0.6086 24600.0n 0.4676 25199.5n 0.4676 25200.0n 0.6501 25799.5n 0.6501 25800.0n 0.6621 26399.5n 0.6621 26400.0n 0.6575 26999.5n 0.6575 27000.0n 0.6536 27599.5n 0.6536 27600.0n 0.6570 28199.5n 0.6570 28200.0n 0.3933 28799.5n 0.3933 28800.0n 0.6512 29399.5n 0.6512 29400.0n 0.6000 29999.5n 0.6000 30000.0n 0.5787 30599.5n 0.5787 30600.0n 0.4633 31199.5n 0.4633 31200.0n 0.4425 31799.5n 0.4425 31800.0n 0.6596 32399.5n 0.6596 32400.0n 0.6625 32999.5n 0.6625 33000.0n 0.6284 33599.5n 0.6284 33600.0n 0.6473 34199.5n 0.6473 34200.0n 0.4525 34799.5n 0.4525 34800.0n 0.5371 35399.5n 0.5371 35400.0n 0.6401 35999.5n 0.6401)
Cwp_wih_1_12 wp_wih_1_12 0 400p
Cwn_wih_1_12 wn_wih_1_12 0 400p
Xu_wih_1_12 xp_wih_1_12 xn_wih_1_12 yp_wih_1_12 yn_wih_1_12 wp_wih_1_12 wn_wih_1_12 vdd gbn gprod
Vxp_who_12_0 xp_who_12_0 0 PWL(0.0n 0.4921 599.5n 0.4921 600.0n 0.4953 1199.5n 0.4953 1200.0n 0.4340 1799.5n 0.4340 1800.0n 0.4081 2399.5n 0.4081 2400.0n 0.4291 2999.5n 0.4291 3000.0n 0.4697 3599.5n 0.4697 3600.0n 0.4459 4199.5n 0.4459 4200.0n 0.4917 4799.5n 0.4917 4800.0n 0.4611 5399.5n 0.4611 5400.0n 0.4609 5999.5n 0.4609 6000.0n 0.4267 6599.5n 0.4267 6600.0n 0.4659 7199.5n 0.4659 7200.0n 0.4789 7799.5n 0.4789 7800.0n 0.4756 8399.5n 0.4756 8400.0n 0.4756 8999.5n 0.4756 9000.0n 0.4614 9599.5n 0.4614 9600.0n 0.4554 10199.5n 0.4554 10200.0n 0.4598 10799.5n 0.4598 10800.0n 0.4321 11399.5n 0.4321 11400.0n 0.4645 11999.5n 0.4645 12000.0n 0.4784 12599.5n 0.4784 12600.0n 0.4543 13199.5n 0.4543 13200.0n 0.4961 13799.5n 0.4961 13800.0n 0.4893 14399.5n 0.4893 14400.0n 0.4674 14999.5n 0.4674 15000.0n 0.4441 15599.5n 0.4441 15600.0n 0.4798 16199.5n 0.4798 16200.0n 0.5009 16799.5n 0.5009 16800.0n 0.4714 17399.5n 0.4714 17400.0n 0.4934 17999.5n 0.4934 18000.0n 0.3511 18599.5n 0.3511 18600.0n 0.5174 19199.5n 0.5174 19200.0n 0.3683 19799.5n 0.3683 19800.0n 0.4286 20399.5n 0.4286 20400.0n 0.3529 20999.5n 0.3529 21000.0n 0.3880 21599.5n 0.3880 21600.0n 0.4655 22199.5n 0.4655 22200.0n 0.5148 22799.5n 0.5148 22800.0n 0.3460 23399.5n 0.3460 23400.0n 0.6065 23999.5n 0.6065 24000.0n 0.3914 24599.5n 0.3914 24600.0n 0.5324 25199.5n 0.5324 25200.0n 0.3499 25799.5n 0.3499 25800.0n 0.3379 26399.5n 0.3379 26400.0n 0.3425 26999.5n 0.3425 27000.0n 0.3464 27599.5n 0.3464 27600.0n 0.3430 28199.5n 0.3430 28200.0n 0.6067 28799.5n 0.6067 28800.0n 0.3488 29399.5n 0.3488 29400.0n 0.4000 29999.5n 0.4000 30000.0n 0.4213 30599.5n 0.4213 30600.0n 0.5367 31199.5n 0.5367 31200.0n 0.5575 31799.5n 0.5575 31800.0n 0.3404 32399.5n 0.3404 32400.0n 0.3375 32999.5n 0.3375 33000.0n 0.3716 33599.5n 0.3716 33600.0n 0.3527 34199.5n 0.3527 34200.0n 0.5475 34799.5n 0.5475 34800.0n 0.4629 35399.5n 0.4629 35400.0n 0.3599 35999.5n 0.3599)
Vxn_who_12_0 xn_who_12_0 0 PWL(0.0n 0.5079 599.5n 0.5079 600.0n 0.5047 1199.5n 0.5047 1200.0n 0.5660 1799.5n 0.5660 1800.0n 0.5919 2399.5n 0.5919 2400.0n 0.5709 2999.5n 0.5709 3000.0n 0.5303 3599.5n 0.5303 3600.0n 0.5541 4199.5n 0.5541 4200.0n 0.5083 4799.5n 0.5083 4800.0n 0.5389 5399.5n 0.5389 5400.0n 0.5391 5999.5n 0.5391 6000.0n 0.5733 6599.5n 0.5733 6600.0n 0.5341 7199.5n 0.5341 7200.0n 0.5211 7799.5n 0.5211 7800.0n 0.5244 8399.5n 0.5244 8400.0n 0.5244 8999.5n 0.5244 9000.0n 0.5386 9599.5n 0.5386 9600.0n 0.5446 10199.5n 0.5446 10200.0n 0.5402 10799.5n 0.5402 10800.0n 0.5679 11399.5n 0.5679 11400.0n 0.5355 11999.5n 0.5355 12000.0n 0.5216 12599.5n 0.5216 12600.0n 0.5457 13199.5n 0.5457 13200.0n 0.5039 13799.5n 0.5039 13800.0n 0.5107 14399.5n 0.5107 14400.0n 0.5326 14999.5n 0.5326 15000.0n 0.5559 15599.5n 0.5559 15600.0n 0.5202 16199.5n 0.5202 16200.0n 0.4991 16799.5n 0.4991 16800.0n 0.5286 17399.5n 0.5286 17400.0n 0.5066 17999.5n 0.5066 18000.0n 0.6489 18599.5n 0.6489 18600.0n 0.4826 19199.5n 0.4826 19200.0n 0.6317 19799.5n 0.6317 19800.0n 0.5714 20399.5n 0.5714 20400.0n 0.6471 20999.5n 0.6471 21000.0n 0.6120 21599.5n 0.6120 21600.0n 0.5345 22199.5n 0.5345 22200.0n 0.4852 22799.5n 0.4852 22800.0n 0.6540 23399.5n 0.6540 23400.0n 0.3935 23999.5n 0.3935 24000.0n 0.6086 24599.5n 0.6086 24600.0n 0.4676 25199.5n 0.4676 25200.0n 0.6501 25799.5n 0.6501 25800.0n 0.6621 26399.5n 0.6621 26400.0n 0.6575 26999.5n 0.6575 27000.0n 0.6536 27599.5n 0.6536 27600.0n 0.6570 28199.5n 0.6570 28200.0n 0.3933 28799.5n 0.3933 28800.0n 0.6512 29399.5n 0.6512 29400.0n 0.6000 29999.5n 0.6000 30000.0n 0.5787 30599.5n 0.5787 30600.0n 0.4633 31199.5n 0.4633 31200.0n 0.4425 31799.5n 0.4425 31800.0n 0.6596 32399.5n 0.6596 32400.0n 0.6625 32999.5n 0.6625 33000.0n 0.6284 33599.5n 0.6284 33600.0n 0.6473 34199.5n 0.6473 34200.0n 0.4525 34799.5n 0.4525 34800.0n 0.5371 35399.5n 0.5371 35400.0n 0.6401 35999.5n 0.6401)
Vyp_who_12_0 yp_who_12_0 0 PWL(0.0n 0.5031 599.5n 0.5031 600.0n 0.5023 1199.5n 0.5023 1200.0n 0.5052 1799.5n 0.5052 1800.0n 0.5048 2399.5n 0.5048 2400.0n 0.5043 2999.5n 0.5043 3000.0n 0.5034 3599.5n 0.5034 3600.0n 0.5048 4199.5n 0.5048 4200.0n 0.5031 4799.5n 0.5031 4800.0n 0.5040 5399.5n 0.5040 5400.0n 0.5040 5999.5n 0.5040 6000.0n 0.5054 6599.5n 0.5054 6600.0n 0.5040 7199.5n 0.5040 7200.0n 0.5027 7799.5n 0.5027 7800.0n 0.5027 8399.5n 0.5027 8400.0n 0.5038 8999.5n 0.5038 9000.0n 0.5040 9599.5n 0.5040 9600.0n 0.5039 10199.5n 0.5039 10200.0n 0.5033 10799.5n 0.5033 10800.0n 0.5056 11399.5n 0.5056 11400.0n 0.5040 11999.5n 0.5040 12000.0n 0.5036 12599.5n 0.5036 12600.0n 0.5039 13199.5n 0.5039 13200.0n 0.5029 13799.5n 0.5029 13800.0n 0.5025 14399.5n 0.5025 14400.0n 0.5038 14999.5n 0.5038 15000.0n 0.5041 15599.5n 0.5041 15600.0n 0.5036 16199.5n 0.5036 16200.0n 0.5025 16799.5n 0.5025 16800.0n 0.5040 17399.5n 0.5040 17400.0n 0.5029 17999.5n 0.5029 18000.0n 0.5057 18599.5n 0.5057 18600.0n 0.5010 19199.5n 0.5010 19200.0n 0.5041 19799.5n 0.5041 19800.0n 0.5021 20399.5n 0.5021 20400.0n 0.5044 20999.5n 0.5044 21000.0n 0.5056 21599.5n 0.5056 21600.0n 0.5016 22199.5n 0.5016 22200.0n 0.5006 22799.5n 0.5006 22800.0n 0.5041 23399.5n 0.5041 23400.0n 0.5027 23999.5n 0.5027 24000.0n 0.5029 24599.5n 0.5029 24600.0n 0.5006 25199.5n 0.5006 25200.0n 0.5047 25799.5n 0.5047 25800.0n 0.5046 26399.5n 0.5046 26400.0n 0.5039 26999.5n 0.5039 27000.0n 0.5049 27599.5n 0.5049 27600.0n 0.5039 28199.5n 0.5039 28200.0n 0.5017 28799.5n 0.5017 28800.0n 0.5042 29399.5n 0.5042 29400.0n 0.5056 29999.5n 0.5056 30000.0n 0.5051 30599.5n 0.5051 30600.0n 0.5039 31199.5n 0.5039 31200.0n 0.5033 31799.5n 0.5033 31800.0n 0.5049 32399.5n 0.5049 32400.0n 0.5045 32999.5n 0.5045 33000.0n 0.5036 33599.5n 0.5036 33600.0n 0.5042 34199.5n 0.5042 34200.0n 0.5012 34799.5n 0.5012 34800.0n 0.5036 35399.5n 0.5036 35400.0n 0.5042 35999.5n 0.5042)
Vyn_who_12_0 yn_who_12_0 0 PWL(0.0n 0.4969 599.5n 0.4969 600.0n 0.4977 1199.5n 0.4977 1200.0n 0.4948 1799.5n 0.4948 1800.0n 0.4952 2399.5n 0.4952 2400.0n 0.4957 2999.5n 0.4957 3000.0n 0.4966 3599.5n 0.4966 3600.0n 0.4952 4199.5n 0.4952 4200.0n 0.4969 4799.5n 0.4969 4800.0n 0.4960 5399.5n 0.4960 5400.0n 0.4960 5999.5n 0.4960 6000.0n 0.4946 6599.5n 0.4946 6600.0n 0.4960 7199.5n 0.4960 7200.0n 0.4973 7799.5n 0.4973 7800.0n 0.4973 8399.5n 0.4973 8400.0n 0.4962 8999.5n 0.4962 9000.0n 0.4960 9599.5n 0.4960 9600.0n 0.4961 10199.5n 0.4961 10200.0n 0.4967 10799.5n 0.4967 10800.0n 0.4944 11399.5n 0.4944 11400.0n 0.4960 11999.5n 0.4960 12000.0n 0.4964 12599.5n 0.4964 12600.0n 0.4961 13199.5n 0.4961 13200.0n 0.4971 13799.5n 0.4971 13800.0n 0.4975 14399.5n 0.4975 14400.0n 0.4962 14999.5n 0.4962 15000.0n 0.4959 15599.5n 0.4959 15600.0n 0.4964 16199.5n 0.4964 16200.0n 0.4975 16799.5n 0.4975 16800.0n 0.4960 17399.5n 0.4960 17400.0n 0.4971 17999.5n 0.4971 18000.0n 0.4943 18599.5n 0.4943 18600.0n 0.4990 19199.5n 0.4990 19200.0n 0.4959 19799.5n 0.4959 19800.0n 0.4979 20399.5n 0.4979 20400.0n 0.4956 20999.5n 0.4956 21000.0n 0.4944 21599.5n 0.4944 21600.0n 0.4984 22199.5n 0.4984 22200.0n 0.4994 22799.5n 0.4994 22800.0n 0.4959 23399.5n 0.4959 23400.0n 0.4973 23999.5n 0.4973 24000.0n 0.4971 24599.5n 0.4971 24600.0n 0.4994 25199.5n 0.4994 25200.0n 0.4953 25799.5n 0.4953 25800.0n 0.4954 26399.5n 0.4954 26400.0n 0.4961 26999.5n 0.4961 27000.0n 0.4951 27599.5n 0.4951 27600.0n 0.4961 28199.5n 0.4961 28200.0n 0.4983 28799.5n 0.4983 28800.0n 0.4958 29399.5n 0.4958 29400.0n 0.4944 29999.5n 0.4944 30000.0n 0.4949 30599.5n 0.4949 30600.0n 0.4961 31199.5n 0.4961 31200.0n 0.4967 31799.5n 0.4967 31800.0n 0.4951 32399.5n 0.4951 32400.0n 0.4955 32999.5n 0.4955 33000.0n 0.4964 33599.5n 0.4964 33600.0n 0.4958 34199.5n 0.4958 34200.0n 0.4988 34799.5n 0.4988 34800.0n 0.4964 35399.5n 0.4964 35400.0n 0.4958 35999.5n 0.4958)
Cwp_who_12_0 wp_who_12_0 0 400p
Cwn_who_12_0 wn_who_12_0 0 400p
Xu_who_12_0 xp_who_12_0 xn_who_12_0 yp_who_12_0 yn_who_12_0 wp_who_12_0 wn_who_12_0 vdd gbn gprod
Vxp_who_12_1 xp_who_12_1 0 PWL(0.0n 0.4921 599.5n 0.4921 600.0n 0.4953 1199.5n 0.4953 1200.0n 0.4340 1799.5n 0.4340 1800.0n 0.4081 2399.5n 0.4081 2400.0n 0.4291 2999.5n 0.4291 3000.0n 0.4697 3599.5n 0.4697 3600.0n 0.4459 4199.5n 0.4459 4200.0n 0.4917 4799.5n 0.4917 4800.0n 0.4611 5399.5n 0.4611 5400.0n 0.4609 5999.5n 0.4609 6000.0n 0.4267 6599.5n 0.4267 6600.0n 0.4659 7199.5n 0.4659 7200.0n 0.4789 7799.5n 0.4789 7800.0n 0.4756 8399.5n 0.4756 8400.0n 0.4756 8999.5n 0.4756 9000.0n 0.4614 9599.5n 0.4614 9600.0n 0.4554 10199.5n 0.4554 10200.0n 0.4598 10799.5n 0.4598 10800.0n 0.4321 11399.5n 0.4321 11400.0n 0.4645 11999.5n 0.4645 12000.0n 0.4784 12599.5n 0.4784 12600.0n 0.4543 13199.5n 0.4543 13200.0n 0.4961 13799.5n 0.4961 13800.0n 0.4893 14399.5n 0.4893 14400.0n 0.4674 14999.5n 0.4674 15000.0n 0.4441 15599.5n 0.4441 15600.0n 0.4798 16199.5n 0.4798 16200.0n 0.5009 16799.5n 0.5009 16800.0n 0.4714 17399.5n 0.4714 17400.0n 0.4934 17999.5n 0.4934 18000.0n 0.3511 18599.5n 0.3511 18600.0n 0.5174 19199.5n 0.5174 19200.0n 0.3683 19799.5n 0.3683 19800.0n 0.4286 20399.5n 0.4286 20400.0n 0.3529 20999.5n 0.3529 21000.0n 0.3880 21599.5n 0.3880 21600.0n 0.4655 22199.5n 0.4655 22200.0n 0.5148 22799.5n 0.5148 22800.0n 0.3460 23399.5n 0.3460 23400.0n 0.6065 23999.5n 0.6065 24000.0n 0.3914 24599.5n 0.3914 24600.0n 0.5324 25199.5n 0.5324 25200.0n 0.3499 25799.5n 0.3499 25800.0n 0.3379 26399.5n 0.3379 26400.0n 0.3425 26999.5n 0.3425 27000.0n 0.3464 27599.5n 0.3464 27600.0n 0.3430 28199.5n 0.3430 28200.0n 0.6067 28799.5n 0.6067 28800.0n 0.3488 29399.5n 0.3488 29400.0n 0.4000 29999.5n 0.4000 30000.0n 0.4213 30599.5n 0.4213 30600.0n 0.5367 31199.5n 0.5367 31200.0n 0.5575 31799.5n 0.5575 31800.0n 0.3404 32399.5n 0.3404 32400.0n 0.3375 32999.5n 0.3375 33000.0n 0.3716 33599.5n 0.3716 33600.0n 0.3527 34199.5n 0.3527 34200.0n 0.5475 34799.5n 0.5475 34800.0n 0.4629 35399.5n 0.4629 35400.0n 0.3599 35999.5n 0.3599)
Vxn_who_12_1 xn_who_12_1 0 PWL(0.0n 0.5079 599.5n 0.5079 600.0n 0.5047 1199.5n 0.5047 1200.0n 0.5660 1799.5n 0.5660 1800.0n 0.5919 2399.5n 0.5919 2400.0n 0.5709 2999.5n 0.5709 3000.0n 0.5303 3599.5n 0.5303 3600.0n 0.5541 4199.5n 0.5541 4200.0n 0.5083 4799.5n 0.5083 4800.0n 0.5389 5399.5n 0.5389 5400.0n 0.5391 5999.5n 0.5391 6000.0n 0.5733 6599.5n 0.5733 6600.0n 0.5341 7199.5n 0.5341 7200.0n 0.5211 7799.5n 0.5211 7800.0n 0.5244 8399.5n 0.5244 8400.0n 0.5244 8999.5n 0.5244 9000.0n 0.5386 9599.5n 0.5386 9600.0n 0.5446 10199.5n 0.5446 10200.0n 0.5402 10799.5n 0.5402 10800.0n 0.5679 11399.5n 0.5679 11400.0n 0.5355 11999.5n 0.5355 12000.0n 0.5216 12599.5n 0.5216 12600.0n 0.5457 13199.5n 0.5457 13200.0n 0.5039 13799.5n 0.5039 13800.0n 0.5107 14399.5n 0.5107 14400.0n 0.5326 14999.5n 0.5326 15000.0n 0.5559 15599.5n 0.5559 15600.0n 0.5202 16199.5n 0.5202 16200.0n 0.4991 16799.5n 0.4991 16800.0n 0.5286 17399.5n 0.5286 17400.0n 0.5066 17999.5n 0.5066 18000.0n 0.6489 18599.5n 0.6489 18600.0n 0.4826 19199.5n 0.4826 19200.0n 0.6317 19799.5n 0.6317 19800.0n 0.5714 20399.5n 0.5714 20400.0n 0.6471 20999.5n 0.6471 21000.0n 0.6120 21599.5n 0.6120 21600.0n 0.5345 22199.5n 0.5345 22200.0n 0.4852 22799.5n 0.4852 22800.0n 0.6540 23399.5n 0.6540 23400.0n 0.3935 23999.5n 0.3935 24000.0n 0.6086 24599.5n 0.6086 24600.0n 0.4676 25199.5n 0.4676 25200.0n 0.6501 25799.5n 0.6501 25800.0n 0.6621 26399.5n 0.6621 26400.0n 0.6575 26999.5n 0.6575 27000.0n 0.6536 27599.5n 0.6536 27600.0n 0.6570 28199.5n 0.6570 28200.0n 0.3933 28799.5n 0.3933 28800.0n 0.6512 29399.5n 0.6512 29400.0n 0.6000 29999.5n 0.6000 30000.0n 0.5787 30599.5n 0.5787 30600.0n 0.4633 31199.5n 0.4633 31200.0n 0.4425 31799.5n 0.4425 31800.0n 0.6596 32399.5n 0.6596 32400.0n 0.6625 32999.5n 0.6625 33000.0n 0.6284 33599.5n 0.6284 33600.0n 0.6473 34199.5n 0.6473 34200.0n 0.4525 34799.5n 0.4525 34800.0n 0.5371 35399.5n 0.5371 35400.0n 0.6401 35999.5n 0.6401)
Vyp_who_12_1 yp_who_12_1 0 PWL(0.0n 0.5071 599.5n 0.5071 600.0n 0.5053 1199.5n 0.5053 1200.0n 0.5052 1799.5n 0.5052 1800.0n 0.5027 2399.5n 0.5027 2400.0n 0.5034 2999.5n 0.5034 3000.0n 0.5055 3599.5n 0.5055 3600.0n 0.5056 4199.5n 0.5056 4200.0n 0.5071 4799.5n 0.5071 4800.0n 0.5056 5399.5n 0.5056 5400.0n 0.5056 5999.5n 0.5056 6000.0n 0.5048 6599.5n 0.5048 6600.0n 0.5060 7199.5n 0.5060 7200.0n 0.5048 7799.5n 0.5048 7800.0n 0.5046 8399.5n 0.5046 8400.0n 0.5066 8999.5n 0.5066 9000.0n 0.5056 9599.5n 0.5056 9600.0n 0.5051 10199.5n 0.5051 10200.0n 0.5046 10799.5n 0.5046 10800.0n 0.5056 11399.5n 0.5056 11400.0n 0.5058 11999.5n 0.5058 12000.0n 0.5068 12599.5n 0.5068 12600.0n 0.5050 13199.5n 0.5050 13200.0n 0.5071 13799.5n 0.5071 13800.0n 0.5059 14399.5n 0.5059 14400.0n 0.5058 14999.5n 0.5058 15000.0n 0.5043 15599.5n 0.5043 15600.0n 0.5067 16199.5n 0.5067 16200.0n 0.5068 16799.5n 0.5068 16800.0n 0.5066 17399.5n 0.5066 17400.0n 0.5069 17999.5n 0.5069 18000.0n 0.5061 18599.5n 0.5061 18600.0n 0.5034 19199.5n 0.5034 19200.0n 0.5010 19799.5n 0.5010 19800.0n 0.4989 20399.5n 0.4989 20400.0n 0.5022 20999.5n 0.5022 21000.0n 0.5086 21599.5n 0.5086 21600.0n 0.5007 22199.5n 0.5007 22200.0n 0.5023 22799.5n 0.5023 22800.0n 0.5021 23399.5n 0.5021 23400.0n 0.5077 23999.5n 0.5077 24000.0n 0.4979 24599.5n 0.4979 24600.0n 0.5035 25199.5n 0.5035 25200.0n 0.5041 25799.5n 0.5041 25800.0n 0.5075 26399.5n 0.5075 26400.0n 0.5041 26999.5n 0.5041 27000.0n 0.5056 27599.5n 0.5056 27600.0n 0.5039 28199.5n 0.5039 28200.0n 0.5059 28799.5n 0.5059 28800.0n 0.5023 29399.5n 0.5023 29400.0n 0.5086 29999.5n 0.5086 30000.0n 0.5084 30599.5n 0.5084 30600.0n 0.5085 31199.5n 0.5085 31200.0n 0.5088 31799.5n 0.5088 31800.0n 0.5078 32399.5n 0.5078 32400.0n 0.5074 32999.5n 0.5074 33000.0n 0.4996 33599.5n 0.4996 33600.0n 0.5010 34199.5n 0.5010 34200.0n 0.5044 34799.5n 0.5044 34800.0n 0.5084 35399.5n 0.5084 35400.0n 0.5012 35999.5n 0.5012)
Vyn_who_12_1 yn_who_12_1 0 PWL(0.0n 0.4929 599.5n 0.4929 600.0n 0.4947 1199.5n 0.4947 1200.0n 0.4948 1799.5n 0.4948 1800.0n 0.4973 2399.5n 0.4973 2400.0n 0.4966 2999.5n 0.4966 3000.0n 0.4945 3599.5n 0.4945 3600.0n 0.4944 4199.5n 0.4944 4200.0n 0.4929 4799.5n 0.4929 4800.0n 0.4944 5399.5n 0.4944 5400.0n 0.4944 5999.5n 0.4944 6000.0n 0.4952 6599.5n 0.4952 6600.0n 0.4940 7199.5n 0.4940 7200.0n 0.4952 7799.5n 0.4952 7800.0n 0.4954 8399.5n 0.4954 8400.0n 0.4934 8999.5n 0.4934 9000.0n 0.4944 9599.5n 0.4944 9600.0n 0.4949 10199.5n 0.4949 10200.0n 0.4954 10799.5n 0.4954 10800.0n 0.4944 11399.5n 0.4944 11400.0n 0.4942 11999.5n 0.4942 12000.0n 0.4932 12599.5n 0.4932 12600.0n 0.4950 13199.5n 0.4950 13200.0n 0.4929 13799.5n 0.4929 13800.0n 0.4941 14399.5n 0.4941 14400.0n 0.4942 14999.5n 0.4942 15000.0n 0.4957 15599.5n 0.4957 15600.0n 0.4933 16199.5n 0.4933 16200.0n 0.4932 16799.5n 0.4932 16800.0n 0.4934 17399.5n 0.4934 17400.0n 0.4931 17999.5n 0.4931 18000.0n 0.4939 18599.5n 0.4939 18600.0n 0.4966 19199.5n 0.4966 19200.0n 0.4990 19799.5n 0.4990 19800.0n 0.5011 20399.5n 0.5011 20400.0n 0.4978 20999.5n 0.4978 21000.0n 0.4914 21599.5n 0.4914 21600.0n 0.4993 22199.5n 0.4993 22200.0n 0.4977 22799.5n 0.4977 22800.0n 0.4979 23399.5n 0.4979 23400.0n 0.4923 23999.5n 0.4923 24000.0n 0.5021 24599.5n 0.5021 24600.0n 0.4965 25199.5n 0.4965 25200.0n 0.4959 25799.5n 0.4959 25800.0n 0.4925 26399.5n 0.4925 26400.0n 0.4959 26999.5n 0.4959 27000.0n 0.4944 27599.5n 0.4944 27600.0n 0.4961 28199.5n 0.4961 28200.0n 0.4941 28799.5n 0.4941 28800.0n 0.4977 29399.5n 0.4977 29400.0n 0.4914 29999.5n 0.4914 30000.0n 0.4916 30599.5n 0.4916 30600.0n 0.4915 31199.5n 0.4915 31200.0n 0.4912 31799.5n 0.4912 31800.0n 0.4922 32399.5n 0.4922 32400.0n 0.4926 32999.5n 0.4926 33000.0n 0.5004 33599.5n 0.5004 33600.0n 0.4990 34199.5n 0.4990 34200.0n 0.4956 34799.5n 0.4956 34800.0n 0.4916 35399.5n 0.4916 35400.0n 0.4988 35999.5n 0.4988)
Cwp_who_12_1 wp_who_12_1 0 400p
Cwn_who_12_1 wn_who_12_1 0 400p
Xu_who_12_1 xp_who_12_1 xn_who_12_1 yp_who_12_1 yn_who_12_1 wp_who_12_1 wn_who_12_1 vdd gbn gprod
Vxp_bh_12 xp_bh_12 0 PWL(0.0n 0.7100 599.5n 0.7100 600.0n 0.7100 1199.5n 0.7100 1200.0n 0.7100 1799.5n 0.7100 1800.0n 0.7100 2399.5n 0.7100 2400.0n 0.7100 2999.5n 0.7100 3000.0n 0.7100 3599.5n 0.7100 3600.0n 0.7100 4199.5n 0.7100 4200.0n 0.7100 4799.5n 0.7100 4800.0n 0.7100 5399.5n 0.7100 5400.0n 0.7100 5999.5n 0.7100 6000.0n 0.7100 6599.5n 0.7100 6600.0n 0.7100 7199.5n 0.7100 7200.0n 0.7100 7799.5n 0.7100 7800.0n 0.7100 8399.5n 0.7100 8400.0n 0.7100 8999.5n 0.7100 9000.0n 0.7100 9599.5n 0.7100 9600.0n 0.7100 10199.5n 0.7100 10200.0n 0.7100 10799.5n 0.7100 10800.0n 0.7100 11399.5n 0.7100 11400.0n 0.7100 11999.5n 0.7100 12000.0n 0.7100 12599.5n 0.7100 12600.0n 0.7100 13199.5n 0.7100 13200.0n 0.7100 13799.5n 0.7100 13800.0n 0.7100 14399.5n 0.7100 14400.0n 0.7100 14999.5n 0.7100 15000.0n 0.7100 15599.5n 0.7100 15600.0n 0.7100 16199.5n 0.7100 16200.0n 0.7100 16799.5n 0.7100 16800.0n 0.7100 17399.5n 0.7100 17400.0n 0.7100 17999.5n 0.7100 18000.0n 0.7100 18599.5n 0.7100 18600.0n 0.7100 19199.5n 0.7100 19200.0n 0.7100 19799.5n 0.7100 19800.0n 0.7100 20399.5n 0.7100 20400.0n 0.7100 20999.5n 0.7100 21000.0n 0.7100 21599.5n 0.7100 21600.0n 0.7100 22199.5n 0.7100 22200.0n 0.7100 22799.5n 0.7100 22800.0n 0.7100 23399.5n 0.7100 23400.0n 0.7100 23999.5n 0.7100 24000.0n 0.7100 24599.5n 0.7100 24600.0n 0.7100 25199.5n 0.7100 25200.0n 0.7100 25799.5n 0.7100 25800.0n 0.7100 26399.5n 0.7100 26400.0n 0.7100 26999.5n 0.7100 27000.0n 0.7100 27599.5n 0.7100 27600.0n 0.7100 28199.5n 0.7100 28200.0n 0.7100 28799.5n 0.7100 28800.0n 0.7100 29399.5n 0.7100 29400.0n 0.7100 29999.5n 0.7100 30000.0n 0.7100 30599.5n 0.7100 30600.0n 0.7100 31199.5n 0.7100 31200.0n 0.7100 31799.5n 0.7100 31800.0n 0.7100 32399.5n 0.7100 32400.0n 0.7100 32999.5n 0.7100 33000.0n 0.7100 33599.5n 0.7100 33600.0n 0.7100 34199.5n 0.7100 34200.0n 0.7100 34799.5n 0.7100 34800.0n 0.7100 35399.5n 0.7100 35400.0n 0.7100 35999.5n 0.7100)
Vxn_bh_12 xn_bh_12 0 PWL(0.0n 0.2900 599.5n 0.2900 600.0n 0.2900 1199.5n 0.2900 1200.0n 0.2900 1799.5n 0.2900 1800.0n 0.2900 2399.5n 0.2900 2400.0n 0.2900 2999.5n 0.2900 3000.0n 0.2900 3599.5n 0.2900 3600.0n 0.2900 4199.5n 0.2900 4200.0n 0.2900 4799.5n 0.2900 4800.0n 0.2900 5399.5n 0.2900 5400.0n 0.2900 5999.5n 0.2900 6000.0n 0.2900 6599.5n 0.2900 6600.0n 0.2900 7199.5n 0.2900 7200.0n 0.2900 7799.5n 0.2900 7800.0n 0.2900 8399.5n 0.2900 8400.0n 0.2900 8999.5n 0.2900 9000.0n 0.2900 9599.5n 0.2900 9600.0n 0.2900 10199.5n 0.2900 10200.0n 0.2900 10799.5n 0.2900 10800.0n 0.2900 11399.5n 0.2900 11400.0n 0.2900 11999.5n 0.2900 12000.0n 0.2900 12599.5n 0.2900 12600.0n 0.2900 13199.5n 0.2900 13200.0n 0.2900 13799.5n 0.2900 13800.0n 0.2900 14399.5n 0.2900 14400.0n 0.2900 14999.5n 0.2900 15000.0n 0.2900 15599.5n 0.2900 15600.0n 0.2900 16199.5n 0.2900 16200.0n 0.2900 16799.5n 0.2900 16800.0n 0.2900 17399.5n 0.2900 17400.0n 0.2900 17999.5n 0.2900 18000.0n 0.2900 18599.5n 0.2900 18600.0n 0.2900 19199.5n 0.2900 19200.0n 0.2900 19799.5n 0.2900 19800.0n 0.2900 20399.5n 0.2900 20400.0n 0.2900 20999.5n 0.2900 21000.0n 0.2900 21599.5n 0.2900 21600.0n 0.2900 22199.5n 0.2900 22200.0n 0.2900 22799.5n 0.2900 22800.0n 0.2900 23399.5n 0.2900 23400.0n 0.2900 23999.5n 0.2900 24000.0n 0.2900 24599.5n 0.2900 24600.0n 0.2900 25199.5n 0.2900 25200.0n 0.2900 25799.5n 0.2900 25800.0n 0.2900 26399.5n 0.2900 26400.0n 0.2900 26999.5n 0.2900 27000.0n 0.2900 27599.5n 0.2900 27600.0n 0.2900 28199.5n 0.2900 28200.0n 0.2900 28799.5n 0.2900 28800.0n 0.2900 29399.5n 0.2900 29400.0n 0.2900 29999.5n 0.2900 30000.0n 0.2900 30599.5n 0.2900 30600.0n 0.2900 31199.5n 0.2900 31200.0n 0.2900 31799.5n 0.2900 31800.0n 0.2900 32399.5n 0.2900 32400.0n 0.2900 32999.5n 0.2900 33000.0n 0.2900 33599.5n 0.2900 33600.0n 0.2900 34199.5n 0.2900 34200.0n 0.2900 34799.5n 0.2900 34800.0n 0.2900 35399.5n 0.2900 35400.0n 0.2900 35999.5n 0.2900)
Vyp_bh_12 yp_bh_12 0 PWL(0.0n 0.4921 599.5n 0.4921 600.0n 0.4953 1199.5n 0.4953 1200.0n 0.4340 1799.5n 0.4340 1800.0n 0.4081 2399.5n 0.4081 2400.0n 0.4291 2999.5n 0.4291 3000.0n 0.4697 3599.5n 0.4697 3600.0n 0.4459 4199.5n 0.4459 4200.0n 0.4917 4799.5n 0.4917 4800.0n 0.4611 5399.5n 0.4611 5400.0n 0.4609 5999.5n 0.4609 6000.0n 0.4267 6599.5n 0.4267 6600.0n 0.4659 7199.5n 0.4659 7200.0n 0.4789 7799.5n 0.4789 7800.0n 0.4756 8399.5n 0.4756 8400.0n 0.4756 8999.5n 0.4756 9000.0n 0.4614 9599.5n 0.4614 9600.0n 0.4554 10199.5n 0.4554 10200.0n 0.4598 10799.5n 0.4598 10800.0n 0.4321 11399.5n 0.4321 11400.0n 0.4645 11999.5n 0.4645 12000.0n 0.4784 12599.5n 0.4784 12600.0n 0.4543 13199.5n 0.4543 13200.0n 0.4961 13799.5n 0.4961 13800.0n 0.4893 14399.5n 0.4893 14400.0n 0.4674 14999.5n 0.4674 15000.0n 0.4441 15599.5n 0.4441 15600.0n 0.4798 16199.5n 0.4798 16200.0n 0.5009 16799.5n 0.5009 16800.0n 0.4714 17399.5n 0.4714 17400.0n 0.4934 17999.5n 0.4934 18000.0n 0.3511 18599.5n 0.3511 18600.0n 0.5174 19199.5n 0.5174 19200.0n 0.3683 19799.5n 0.3683 19800.0n 0.4286 20399.5n 0.4286 20400.0n 0.3529 20999.5n 0.3529 21000.0n 0.3880 21599.5n 0.3880 21600.0n 0.4655 22199.5n 0.4655 22200.0n 0.5148 22799.5n 0.5148 22800.0n 0.3460 23399.5n 0.3460 23400.0n 0.6065 23999.5n 0.6065 24000.0n 0.3914 24599.5n 0.3914 24600.0n 0.5324 25199.5n 0.5324 25200.0n 0.3499 25799.5n 0.3499 25800.0n 0.3379 26399.5n 0.3379 26400.0n 0.3425 26999.5n 0.3425 27000.0n 0.3464 27599.5n 0.3464 27600.0n 0.3430 28199.5n 0.3430 28200.0n 0.6067 28799.5n 0.6067 28800.0n 0.3488 29399.5n 0.3488 29400.0n 0.4000 29999.5n 0.4000 30000.0n 0.4213 30599.5n 0.4213 30600.0n 0.5367 31199.5n 0.5367 31200.0n 0.5575 31799.5n 0.5575 31800.0n 0.3404 32399.5n 0.3404 32400.0n 0.3375 32999.5n 0.3375 33000.0n 0.3716 33599.5n 0.3716 33600.0n 0.3527 34199.5n 0.3527 34200.0n 0.5475 34799.5n 0.5475 34800.0n 0.4629 35399.5n 0.4629 35400.0n 0.3599 35999.5n 0.3599)
Vyn_bh_12 yn_bh_12 0 PWL(0.0n 0.5079 599.5n 0.5079 600.0n 0.5047 1199.5n 0.5047 1200.0n 0.5660 1799.5n 0.5660 1800.0n 0.5919 2399.5n 0.5919 2400.0n 0.5709 2999.5n 0.5709 3000.0n 0.5303 3599.5n 0.5303 3600.0n 0.5541 4199.5n 0.5541 4200.0n 0.5083 4799.5n 0.5083 4800.0n 0.5389 5399.5n 0.5389 5400.0n 0.5391 5999.5n 0.5391 6000.0n 0.5733 6599.5n 0.5733 6600.0n 0.5341 7199.5n 0.5341 7200.0n 0.5211 7799.5n 0.5211 7800.0n 0.5244 8399.5n 0.5244 8400.0n 0.5244 8999.5n 0.5244 9000.0n 0.5386 9599.5n 0.5386 9600.0n 0.5446 10199.5n 0.5446 10200.0n 0.5402 10799.5n 0.5402 10800.0n 0.5679 11399.5n 0.5679 11400.0n 0.5355 11999.5n 0.5355 12000.0n 0.5216 12599.5n 0.5216 12600.0n 0.5457 13199.5n 0.5457 13200.0n 0.5039 13799.5n 0.5039 13800.0n 0.5107 14399.5n 0.5107 14400.0n 0.5326 14999.5n 0.5326 15000.0n 0.5559 15599.5n 0.5559 15600.0n 0.5202 16199.5n 0.5202 16200.0n 0.4991 16799.5n 0.4991 16800.0n 0.5286 17399.5n 0.5286 17400.0n 0.5066 17999.5n 0.5066 18000.0n 0.6489 18599.5n 0.6489 18600.0n 0.4826 19199.5n 0.4826 19200.0n 0.6317 19799.5n 0.6317 19800.0n 0.5714 20399.5n 0.5714 20400.0n 0.6471 20999.5n 0.6471 21000.0n 0.6120 21599.5n 0.6120 21600.0n 0.5345 22199.5n 0.5345 22200.0n 0.4852 22799.5n 0.4852 22800.0n 0.6540 23399.5n 0.6540 23400.0n 0.3935 23999.5n 0.3935 24000.0n 0.6086 24599.5n 0.6086 24600.0n 0.4676 25199.5n 0.4676 25200.0n 0.6501 25799.5n 0.6501 25800.0n 0.6621 26399.5n 0.6621 26400.0n 0.6575 26999.5n 0.6575 27000.0n 0.6536 27599.5n 0.6536 27600.0n 0.6570 28199.5n 0.6570 28200.0n 0.3933 28799.5n 0.3933 28800.0n 0.6512 29399.5n 0.6512 29400.0n 0.6000 29999.5n 0.6000 30000.0n 0.5787 30599.5n 0.5787 30600.0n 0.4633 31199.5n 0.4633 31200.0n 0.4425 31799.5n 0.4425 31800.0n 0.6596 32399.5n 0.6596 32400.0n 0.6625 32999.5n 0.6625 33000.0n 0.6284 33599.5n 0.6284 33600.0n 0.6473 34199.5n 0.6473 34200.0n 0.4525 34799.5n 0.4525 34800.0n 0.5371 35399.5n 0.5371 35400.0n 0.6401 35999.5n 0.6401)
Cwp_bh_12 wp_bh_12 0 400p
Cwn_bh_12 wn_bh_12 0 400p
Xu_bh_12 xp_bh_12 xn_bh_12 yp_bh_12 yn_bh_12 wp_bh_12 wn_bh_12 vdd gbn gprod
Vxp_wih_0_13 xp_wih_0_13 0 PWL(0.0n 0.4942 599.5n 0.4942 600.0n 0.5558 1199.5n 0.5558 1200.0n 0.4708 1799.5n 0.4708 1800.0n 0.5235 2399.5n 0.5235 2400.0n 0.5350 2999.5n 0.5350 3000.0n 0.5172 3599.5n 0.5172 3600.0n 0.4702 4199.5n 0.4702 4200.0n 0.4867 4799.5n 0.4867 4800.0n 0.4970 5399.5n 0.4970 5400.0n 0.4986 5999.5n 0.4986 6000.0n 0.4751 6599.5n 0.4751 6600.0n 0.4870 7199.5n 0.4870 7200.0n 0.5502 7799.5n 0.5502 7800.0n 0.5521 8399.5n 0.5521 8400.0n 0.4638 8999.5n 0.4638 9000.0n 0.4982 9599.5n 0.4982 9600.0n 0.5131 10199.5n 0.5131 10200.0n 0.5386 10799.5n 0.5386 10800.0n 0.4592 11399.5n 0.4592 11400.0n 0.4950 11999.5n 0.4950 12000.0n 0.4559 12599.5n 0.4559 12600.0n 0.5162 13199.5n 0.5162 13200.0n 0.5038 13799.5n 0.5038 13800.0n 0.5333 14399.5n 0.5333 14400.0n 0.4991 14999.5n 0.4991 15000.0n 0.5298 15599.5n 0.5298 15600.0n 0.4823 16199.5n 0.4823 16200.0n 0.5239 16799.5n 0.5239 16800.0n 0.4592 17399.5n 0.4592 17400.0n 0.5094 17999.5n 0.5094 18000.0n 0.4337 18599.5n 0.4337 18600.0n 0.5977 19199.5n 0.5977 19200.0n 0.5364 19799.5n 0.5364 19800.0n 0.6122 20399.5n 0.6122 20400.0n 0.4856 20999.5n 0.4856 21000.0n 0.3861 21599.5n 0.3861 21600.0n 0.6094 22199.5n 0.6094 22200.0n 0.6364 22799.5n 0.6364 22800.0n 0.4807 23399.5n 0.4807 23400.0n 0.5614 23999.5n 0.5614 24000.0n 0.5913 24599.5n 0.5913 24600.0n 0.6295 25199.5n 0.6295 25200.0n 0.4496 25799.5n 0.4496 25800.0n 0.3792 26399.5n 0.3792 26400.0n 0.4434 26999.5n 0.4434 27000.0n 0.4340 27599.5n 0.4340 27600.0n 0.4461 28199.5n 0.4461 28200.0n 0.5791 28799.5n 0.5791 28800.0n 0.4777 29399.5n 0.4777 29400.0n 0.3878 29999.5n 0.3878 30000.0n 0.3832 30599.5n 0.3832 30600.0n 0.4022 31199.5n 0.4022 31200.0n 0.4482 31799.5n 0.4482 31800.0n 0.3662 32399.5n 0.3662 32400.0n 0.3857 32999.5n 0.3857 33000.0n 0.5584 33599.5n 0.5584 33600.0n 0.5284 34199.5n 0.5284 34200.0n 0.6034 34799.5n 0.6034 34800.0n 0.3469 35399.5n 0.3469 35400.0n 0.5290 35999.5n 0.5290)
Vxn_wih_0_13 xn_wih_0_13 0 PWL(0.0n 0.5058 599.5n 0.5058 600.0n 0.4442 1199.5n 0.4442 1200.0n 0.5292 1799.5n 0.5292 1800.0n 0.4765 2399.5n 0.4765 2400.0n 0.4650 2999.5n 0.4650 3000.0n 0.4828 3599.5n 0.4828 3600.0n 0.5298 4199.5n 0.5298 4200.0n 0.5133 4799.5n 0.5133 4800.0n 0.5030 5399.5n 0.5030 5400.0n 0.5014 5999.5n 0.5014 6000.0n 0.5249 6599.5n 0.5249 6600.0n 0.5130 7199.5n 0.5130 7200.0n 0.4498 7799.5n 0.4498 7800.0n 0.4479 8399.5n 0.4479 8400.0n 0.5362 8999.5n 0.5362 9000.0n 0.5018 9599.5n 0.5018 9600.0n 0.4869 10199.5n 0.4869 10200.0n 0.4614 10799.5n 0.4614 10800.0n 0.5408 11399.5n 0.5408 11400.0n 0.5050 11999.5n 0.5050 12000.0n 0.5441 12599.5n 0.5441 12600.0n 0.4838 13199.5n 0.4838 13200.0n 0.4962 13799.5n 0.4962 13800.0n 0.4667 14399.5n 0.4667 14400.0n 0.5009 14999.5n 0.5009 15000.0n 0.4702 15599.5n 0.4702 15600.0n 0.5177 16199.5n 0.5177 16200.0n 0.4761 16799.5n 0.4761 16800.0n 0.5408 17399.5n 0.5408 17400.0n 0.4906 17999.5n 0.4906 18000.0n 0.5663 18599.5n 0.5663 18600.0n 0.4023 19199.5n 0.4023 19200.0n 0.4636 19799.5n 0.4636 19800.0n 0.3878 20399.5n 0.3878 20400.0n 0.5144 20999.5n 0.5144 21000.0n 0.6139 21599.5n 0.6139 21600.0n 0.3906 22199.5n 0.3906 22200.0n 0.3636 22799.5n 0.3636 22800.0n 0.5193 23399.5n 0.5193 23400.0n 0.4386 23999.5n 0.4386 24000.0n 0.4087 24599.5n 0.4087 24600.0n 0.3705 25199.5n 0.3705 25200.0n 0.5504 25799.5n 0.5504 25800.0n 0.6208 26399.5n 0.6208 26400.0n 0.5566 26999.5n 0.5566 27000.0n 0.5660 27599.5n 0.5660 27600.0n 0.5539 28199.5n 0.5539 28200.0n 0.4209 28799.5n 0.4209 28800.0n 0.5223 29399.5n 0.5223 29400.0n 0.6122 29999.5n 0.6122 30000.0n 0.6168 30599.5n 0.6168 30600.0n 0.5978 31199.5n 0.5978 31200.0n 0.5518 31799.5n 0.5518 31800.0n 0.6338 32399.5n 0.6338 32400.0n 0.6143 32999.5n 0.6143 33000.0n 0.4416 33599.5n 0.4416 33600.0n 0.4716 34199.5n 0.4716 34200.0n 0.3966 34799.5n 0.3966 34800.0n 0.6531 35399.5n 0.6531 35400.0n 0.4710 35999.5n 0.4710)
Vyp_wih_0_13 yp_wih_0_13 0 PWL(0.0n 0.6588 599.5n 0.6588 600.0n 0.6672 1199.5n 0.6672 1200.0n 0.6705 1799.5n 0.6705 1800.0n 0.6797 2399.5n 0.6797 2400.0n 0.6771 2999.5n 0.6771 3000.0n 0.6671 3599.5n 0.6671 3600.0n 0.6678 4199.5n 0.6678 4200.0n 0.6580 4799.5n 0.6580 4800.0n 0.6669 5399.5n 0.6669 5400.0n 0.6671 5999.5n 0.6671 6000.0n 0.6722 6599.5n 0.6722 6600.0n 0.6649 7199.5n 0.6649 7200.0n 0.6696 7799.5n 0.6696 7800.0n 0.6707 8399.5n 0.6707 8400.0n 0.6596 8999.5n 0.6596 9000.0n 0.6670 9599.5n 0.6670 9600.0n 0.6697 10199.5n 0.6697 10200.0n 0.6717 10799.5n 0.6717 10800.0n 0.6695 11399.5n 0.6695 11400.0n 0.6660 11999.5n 0.6660 12000.0n 0.6574 12599.5n 0.6574 12600.0n 0.6702 13199.5n 0.6702 13200.0n 0.6589 13799.5n 0.6589 13800.0n 0.6647 14399.5n 0.6647 14400.0n 0.6657 14999.5n 0.6657 15000.0n 0.6736 15599.5n 0.6736 15600.0n 0.6609 16199.5n 0.6609 16200.0n 0.6602 16799.5n 0.6602 16800.0n 0.6601 17399.5n 0.6601 17400.0n 0.6604 17999.5n 0.6604 18000.0n 0.6826 18599.5n 0.6826 18600.0n 0.6715 19199.5n 0.6715 19200.0n 0.6872 19799.5n 0.6872 19800.0n 0.6873 20399.5n 0.6873 20400.0n 0.6870 20999.5n 0.6870 21000.0n 0.6694 21599.5n 0.6694 21600.0n 0.6818 22199.5n 0.6818 22200.0n 0.6731 22799.5n 0.6731 22800.0n 0.6901 23399.5n 0.6901 23400.0n 0.5883 23999.5n 0.5883 24000.0n 0.6921 24599.5n 0.6921 24600.0n 0.6694 25199.5n 0.6694 25200.0n 0.6855 25799.5n 0.6855 25800.0n 0.6858 26399.5n 0.6858 26400.0n 0.6891 26999.5n 0.6891 27000.0n 0.6850 27599.5n 0.6850 27600.0n 0.6891 28199.5n 0.6891 28200.0n 0.6180 28799.5n 0.6180 28800.0n 0.6884 29399.5n 0.6884 29400.0n 0.6663 29999.5n 0.6663 30000.0n 0.6600 30599.5n 0.6600 30600.0n 0.5502 31199.5n 0.5502 31200.0n 0.5768 31799.5n 0.5768 31800.0n 0.6840 32399.5n 0.6840 32400.0n 0.6863 32999.5n 0.6863 33000.0n 0.6898 33599.5n 0.6898 33600.0n 0.6901 34199.5n 0.6901 34200.0n 0.6649 34799.5n 0.6649 34800.0n 0.6329 35399.5n 0.6329 35400.0n 0.6881 35999.5n 0.6881)
Vyn_wih_0_13 yn_wih_0_13 0 PWL(0.0n 0.3412 599.5n 0.3412 600.0n 0.3328 1199.5n 0.3328 1200.0n 0.3295 1799.5n 0.3295 1800.0n 0.3203 2399.5n 0.3203 2400.0n 0.3229 2999.5n 0.3229 3000.0n 0.3329 3599.5n 0.3329 3600.0n 0.3322 4199.5n 0.3322 4200.0n 0.3420 4799.5n 0.3420 4800.0n 0.3331 5399.5n 0.3331 5400.0n 0.3329 5999.5n 0.3329 6000.0n 0.3278 6599.5n 0.3278 6600.0n 0.3351 7199.5n 0.3351 7200.0n 0.3304 7799.5n 0.3304 7800.0n 0.3293 8399.5n 0.3293 8400.0n 0.3404 8999.5n 0.3404 9000.0n 0.3330 9599.5n 0.3330 9600.0n 0.3303 10199.5n 0.3303 10200.0n 0.3283 10799.5n 0.3283 10800.0n 0.3305 11399.5n 0.3305 11400.0n 0.3340 11999.5n 0.3340 12000.0n 0.3426 12599.5n 0.3426 12600.0n 0.3298 13199.5n 0.3298 13200.0n 0.3411 13799.5n 0.3411 13800.0n 0.3353 14399.5n 0.3353 14400.0n 0.3343 14999.5n 0.3343 15000.0n 0.3264 15599.5n 0.3264 15600.0n 0.3391 16199.5n 0.3391 16200.0n 0.3398 16799.5n 0.3398 16800.0n 0.3399 17399.5n 0.3399 17400.0n 0.3396 17999.5n 0.3396 18000.0n 0.3174 18599.5n 0.3174 18600.0n 0.3285 19199.5n 0.3285 19200.0n 0.3128 19799.5n 0.3128 19800.0n 0.3127 20399.5n 0.3127 20400.0n 0.3130 20999.5n 0.3130 21000.0n 0.3306 21599.5n 0.3306 21600.0n 0.3182 22199.5n 0.3182 22200.0n 0.3269 22799.5n 0.3269 22800.0n 0.3099 23399.5n 0.3099 23400.0n 0.4117 23999.5n 0.4117 24000.0n 0.3079 24599.5n 0.3079 24600.0n 0.3306 25199.5n 0.3306 25200.0n 0.3145 25799.5n 0.3145 25800.0n 0.3142 26399.5n 0.3142 26400.0n 0.3109 26999.5n 0.3109 27000.0n 0.3150 27599.5n 0.3150 27600.0n 0.3109 28199.5n 0.3109 28200.0n 0.3820 28799.5n 0.3820 28800.0n 0.3116 29399.5n 0.3116 29400.0n 0.3337 29999.5n 0.3337 30000.0n 0.3400 30599.5n 0.3400 30600.0n 0.4498 31199.5n 0.4498 31200.0n 0.4232 31799.5n 0.4232 31800.0n 0.3160 32399.5n 0.3160 32400.0n 0.3137 32999.5n 0.3137 33000.0n 0.3102 33599.5n 0.3102 33600.0n 0.3099 34199.5n 0.3099 34200.0n 0.3351 34799.5n 0.3351 34800.0n 0.3671 35399.5n 0.3671 35400.0n 0.3119 35999.5n 0.3119)
Cwp_wih_0_13 wp_wih_0_13 0 400p
Cwn_wih_0_13 wn_wih_0_13 0 400p
Xu_wih_0_13 xp_wih_0_13 xn_wih_0_13 yp_wih_0_13 yn_wih_0_13 wp_wih_0_13 wn_wih_0_13 vdd gbn gprod
Vxp_wih_1_13 xp_wih_1_13 0 PWL(0.0n 0.5370 599.5n 0.5370 600.0n 0.5167 1199.5n 0.5167 1200.0n 0.4793 1799.5n 0.4793 1800.0n 0.4441 2399.5n 0.4441 2400.0n 0.4555 2999.5n 0.4555 3000.0n 0.5055 3599.5n 0.5055 3600.0n 0.4939 4199.5n 0.4939 4200.0n 0.5385 4799.5n 0.5385 4800.0n 0.5024 5399.5n 0.5024 5400.0n 0.5015 5999.5n 0.5015 6000.0n 0.4700 6599.5n 0.4700 6600.0n 0.5120 7199.5n 0.5120 7200.0n 0.5006 7799.5n 0.5006 7800.0n 0.4950 8399.5n 0.4950 8400.0n 0.5309 8999.5n 0.5309 9000.0n 0.5023 9599.5n 0.5023 9600.0n 0.4893 10199.5n 0.4893 10200.0n 0.4837 10799.5n 0.4837 10800.0n 0.4823 11399.5n 0.4823 11400.0n 0.5074 11999.5n 0.5074 12000.0n 0.5364 12599.5n 0.5364 12600.0n 0.4868 13199.5n 0.4868 13200.0n 0.5380 13799.5n 0.5380 13800.0n 0.5220 14399.5n 0.5220 14400.0n 0.5095 14999.5n 0.5095 15000.0n 0.4705 15599.5n 0.4705 15600.0n 0.5289 16199.5n 0.5289 16200.0n 0.5368 16799.5n 0.5368 16800.0n 0.5287 17399.5n 0.5287 17400.0n 0.5342 17999.5n 0.5342 18000.0n 0.4253 18599.5n 0.4253 18600.0n 0.5119 19199.5n 0.5119 19200.0n 0.4104 19799.5n 0.4104 19800.0n 0.4314 20399.5n 0.4314 20400.0n 0.4005 20999.5n 0.4005 21000.0n 0.4696 21599.5n 0.4696 21600.0n 0.4531 22199.5n 0.4531 22200.0n 0.5039 22799.5n 0.5039 22800.0n 0.3608 23399.5n 0.3608 23400.0n 0.6273 23999.5n 0.6273 24000.0n 0.3928 24599.5n 0.3928 24600.0n 0.5253 25199.5n 0.5253 25200.0n 0.4107 25799.5n 0.4107 25800.0n 0.3947 26399.5n 0.3947 26400.0n 0.3716 26999.5n 0.3716 27000.0n 0.4111 27599.5n 0.4111 27600.0n 0.3715 28199.5n 0.3715 28200.0n 0.5939 28799.5n 0.5939 28800.0n 0.3849 29399.5n 0.3849 29400.0n 0.4835 29999.5n 0.4835 30000.0n 0.5119 30599.5n 0.5119 30600.0n 0.6226 31199.5n 0.6226 31200.0n 0.6064 31799.5n 0.6064 31800.0n 0.4115 32399.5n 0.4115 32400.0n 0.3900 32999.5n 0.3900 33000.0n 0.3958 33599.5n 0.3958 33600.0n 0.3747 34199.5n 0.3747 34200.0n 0.5423 34799.5n 0.5423 34800.0n 0.5509 35399.5n 0.5509 35400.0n 0.3990 35999.5n 0.3990)
Vxn_wih_1_13 xn_wih_1_13 0 PWL(0.0n 0.4630 599.5n 0.4630 600.0n 0.4833 1199.5n 0.4833 1200.0n 0.5207 1799.5n 0.5207 1800.0n 0.5559 2399.5n 0.5559 2400.0n 0.5445 2999.5n 0.5445 3000.0n 0.4945 3599.5n 0.4945 3600.0n 0.5061 4199.5n 0.5061 4200.0n 0.4615 4799.5n 0.4615 4800.0n 0.4976 5399.5n 0.4976 5400.0n 0.4985 5999.5n 0.4985 6000.0n 0.5300 6599.5n 0.5300 6600.0n 0.4880 7199.5n 0.4880 7200.0n 0.4994 7799.5n 0.4994 7800.0n 0.5050 8399.5n 0.5050 8400.0n 0.4691 8999.5n 0.4691 9000.0n 0.4977 9599.5n 0.4977 9600.0n 0.5107 10199.5n 0.5107 10200.0n 0.5163 10799.5n 0.5163 10800.0n 0.5177 11399.5n 0.5177 11400.0n 0.4926 11999.5n 0.4926 12000.0n 0.4636 12599.5n 0.4636 12600.0n 0.5132 13199.5n 0.5132 13200.0n 0.4620 13799.5n 0.4620 13800.0n 0.4780 14399.5n 0.4780 14400.0n 0.4905 14999.5n 0.4905 15000.0n 0.5295 15599.5n 0.5295 15600.0n 0.4711 16199.5n 0.4711 16200.0n 0.4632 16799.5n 0.4632 16800.0n 0.4713 17399.5n 0.4713 17400.0n 0.4658 17999.5n 0.4658 18000.0n 0.5747 18599.5n 0.5747 18600.0n 0.4881 19199.5n 0.4881 19200.0n 0.5896 19799.5n 0.5896 19800.0n 0.5686 20399.5n 0.5686 20400.0n 0.5995 20999.5n 0.5995 21000.0n 0.5304 21599.5n 0.5304 21600.0n 0.5469 22199.5n 0.5469 22200.0n 0.4961 22799.5n 0.4961 22800.0n 0.6392 23399.5n 0.6392 23400.0n 0.3727 23999.5n 0.3727 24000.0n 0.6072 24599.5n 0.6072 24600.0n 0.4747 25199.5n 0.4747 25200.0n 0.5893 25799.5n 0.5893 25800.0n 0.6053 26399.5n 0.6053 26400.0n 0.6284 26999.5n 0.6284 27000.0n 0.5889 27599.5n 0.5889 27600.0n 0.6285 28199.5n 0.6285 28200.0n 0.4061 28799.5n 0.4061 28800.0n 0.6151 29399.5n 0.6151 29400.0n 0.5165 29999.5n 0.5165 30000.0n 0.4881 30599.5n 0.4881 30600.0n 0.3774 31199.5n 0.3774 31200.0n 0.3936 31799.5n 0.3936 31800.0n 0.5885 32399.5n 0.5885 32400.0n 0.6100 32999.5n 0.6100 33000.0n 0.6042 33599.5n 0.6042 33600.0n 0.6253 34199.5n 0.6253 34200.0n 0.4577 34799.5n 0.4577 34800.0n 0.4491 35399.5n 0.4491 35400.0n 0.6010 35999.5n 0.6010)
Vyp_wih_1_13 yp_wih_1_13 0 PWL(0.0n 0.6588 599.5n 0.6588 600.0n 0.6672 1199.5n 0.6672 1200.0n 0.6705 1799.5n 0.6705 1800.0n 0.6797 2399.5n 0.6797 2400.0n 0.6771 2999.5n 0.6771 3000.0n 0.6671 3599.5n 0.6671 3600.0n 0.6678 4199.5n 0.6678 4200.0n 0.6580 4799.5n 0.6580 4800.0n 0.6669 5399.5n 0.6669 5400.0n 0.6671 5999.5n 0.6671 6000.0n 0.6722 6599.5n 0.6722 6600.0n 0.6649 7199.5n 0.6649 7200.0n 0.6696 7799.5n 0.6696 7800.0n 0.6707 8399.5n 0.6707 8400.0n 0.6596 8999.5n 0.6596 9000.0n 0.6670 9599.5n 0.6670 9600.0n 0.6697 10199.5n 0.6697 10200.0n 0.6717 10799.5n 0.6717 10800.0n 0.6695 11399.5n 0.6695 11400.0n 0.6660 11999.5n 0.6660 12000.0n 0.6574 12599.5n 0.6574 12600.0n 0.6702 13199.5n 0.6702 13200.0n 0.6589 13799.5n 0.6589 13800.0n 0.6647 14399.5n 0.6647 14400.0n 0.6657 14999.5n 0.6657 15000.0n 0.6736 15599.5n 0.6736 15600.0n 0.6609 16199.5n 0.6609 16200.0n 0.6602 16799.5n 0.6602 16800.0n 0.6601 17399.5n 0.6601 17400.0n 0.6604 17999.5n 0.6604 18000.0n 0.6826 18599.5n 0.6826 18600.0n 0.6715 19199.5n 0.6715 19200.0n 0.6872 19799.5n 0.6872 19800.0n 0.6873 20399.5n 0.6873 20400.0n 0.6870 20999.5n 0.6870 21000.0n 0.6694 21599.5n 0.6694 21600.0n 0.6818 22199.5n 0.6818 22200.0n 0.6731 22799.5n 0.6731 22800.0n 0.6901 23399.5n 0.6901 23400.0n 0.5883 23999.5n 0.5883 24000.0n 0.6921 24599.5n 0.6921 24600.0n 0.6694 25199.5n 0.6694 25200.0n 0.6855 25799.5n 0.6855 25800.0n 0.6858 26399.5n 0.6858 26400.0n 0.6891 26999.5n 0.6891 27000.0n 0.6850 27599.5n 0.6850 27600.0n 0.6891 28199.5n 0.6891 28200.0n 0.6180 28799.5n 0.6180 28800.0n 0.6884 29399.5n 0.6884 29400.0n 0.6663 29999.5n 0.6663 30000.0n 0.6600 30599.5n 0.6600 30600.0n 0.5502 31199.5n 0.5502 31200.0n 0.5768 31799.5n 0.5768 31800.0n 0.6840 32399.5n 0.6840 32400.0n 0.6863 32999.5n 0.6863 33000.0n 0.6898 33599.5n 0.6898 33600.0n 0.6901 34199.5n 0.6901 34200.0n 0.6649 34799.5n 0.6649 34800.0n 0.6329 35399.5n 0.6329 35400.0n 0.6881 35999.5n 0.6881)
Vyn_wih_1_13 yn_wih_1_13 0 PWL(0.0n 0.3412 599.5n 0.3412 600.0n 0.3328 1199.5n 0.3328 1200.0n 0.3295 1799.5n 0.3295 1800.0n 0.3203 2399.5n 0.3203 2400.0n 0.3229 2999.5n 0.3229 3000.0n 0.3329 3599.5n 0.3329 3600.0n 0.3322 4199.5n 0.3322 4200.0n 0.3420 4799.5n 0.3420 4800.0n 0.3331 5399.5n 0.3331 5400.0n 0.3329 5999.5n 0.3329 6000.0n 0.3278 6599.5n 0.3278 6600.0n 0.3351 7199.5n 0.3351 7200.0n 0.3304 7799.5n 0.3304 7800.0n 0.3293 8399.5n 0.3293 8400.0n 0.3404 8999.5n 0.3404 9000.0n 0.3330 9599.5n 0.3330 9600.0n 0.3303 10199.5n 0.3303 10200.0n 0.3283 10799.5n 0.3283 10800.0n 0.3305 11399.5n 0.3305 11400.0n 0.3340 11999.5n 0.3340 12000.0n 0.3426 12599.5n 0.3426 12600.0n 0.3298 13199.5n 0.3298 13200.0n 0.3411 13799.5n 0.3411 13800.0n 0.3353 14399.5n 0.3353 14400.0n 0.3343 14999.5n 0.3343 15000.0n 0.3264 15599.5n 0.3264 15600.0n 0.3391 16199.5n 0.3391 16200.0n 0.3398 16799.5n 0.3398 16800.0n 0.3399 17399.5n 0.3399 17400.0n 0.3396 17999.5n 0.3396 18000.0n 0.3174 18599.5n 0.3174 18600.0n 0.3285 19199.5n 0.3285 19200.0n 0.3128 19799.5n 0.3128 19800.0n 0.3127 20399.5n 0.3127 20400.0n 0.3130 20999.5n 0.3130 21000.0n 0.3306 21599.5n 0.3306 21600.0n 0.3182 22199.5n 0.3182 22200.0n 0.3269 22799.5n 0.3269 22800.0n 0.3099 23399.5n 0.3099 23400.0n 0.4117 23999.5n 0.4117 24000.0n 0.3079 24599.5n 0.3079 24600.0n 0.3306 25199.5n 0.3306 25200.0n 0.3145 25799.5n 0.3145 25800.0n 0.3142 26399.5n 0.3142 26400.0n 0.3109 26999.5n 0.3109 27000.0n 0.3150 27599.5n 0.3150 27600.0n 0.3109 28199.5n 0.3109 28200.0n 0.3820 28799.5n 0.3820 28800.0n 0.3116 29399.5n 0.3116 29400.0n 0.3337 29999.5n 0.3337 30000.0n 0.3400 30599.5n 0.3400 30600.0n 0.4498 31199.5n 0.4498 31200.0n 0.4232 31799.5n 0.4232 31800.0n 0.3160 32399.5n 0.3160 32400.0n 0.3137 32999.5n 0.3137 33000.0n 0.3102 33599.5n 0.3102 33600.0n 0.3099 34199.5n 0.3099 34200.0n 0.3351 34799.5n 0.3351 34800.0n 0.3671 35399.5n 0.3671 35400.0n 0.3119 35999.5n 0.3119)
Cwp_wih_1_13 wp_wih_1_13 0 400p
Cwn_wih_1_13 wn_wih_1_13 0 400p
Xu_wih_1_13 xp_wih_1_13 xn_wih_1_13 yp_wih_1_13 yn_wih_1_13 wp_wih_1_13 wn_wih_1_13 vdd gbn gprod
Vxp_who_13_0 xp_who_13_0 0 PWL(0.0n 0.6588 599.5n 0.6588 600.0n 0.6672 1199.5n 0.6672 1200.0n 0.6705 1799.5n 0.6705 1800.0n 0.6797 2399.5n 0.6797 2400.0n 0.6771 2999.5n 0.6771 3000.0n 0.6671 3599.5n 0.6671 3600.0n 0.6678 4199.5n 0.6678 4200.0n 0.6580 4799.5n 0.6580 4800.0n 0.6669 5399.5n 0.6669 5400.0n 0.6671 5999.5n 0.6671 6000.0n 0.6722 6599.5n 0.6722 6600.0n 0.6649 7199.5n 0.6649 7200.0n 0.6696 7799.5n 0.6696 7800.0n 0.6707 8399.5n 0.6707 8400.0n 0.6596 8999.5n 0.6596 9000.0n 0.6670 9599.5n 0.6670 9600.0n 0.6697 10199.5n 0.6697 10200.0n 0.6717 10799.5n 0.6717 10800.0n 0.6695 11399.5n 0.6695 11400.0n 0.6660 11999.5n 0.6660 12000.0n 0.6574 12599.5n 0.6574 12600.0n 0.6702 13199.5n 0.6702 13200.0n 0.6589 13799.5n 0.6589 13800.0n 0.6647 14399.5n 0.6647 14400.0n 0.6657 14999.5n 0.6657 15000.0n 0.6736 15599.5n 0.6736 15600.0n 0.6609 16199.5n 0.6609 16200.0n 0.6602 16799.5n 0.6602 16800.0n 0.6601 17399.5n 0.6601 17400.0n 0.6604 17999.5n 0.6604 18000.0n 0.6826 18599.5n 0.6826 18600.0n 0.6715 19199.5n 0.6715 19200.0n 0.6872 19799.5n 0.6872 19800.0n 0.6873 20399.5n 0.6873 20400.0n 0.6870 20999.5n 0.6870 21000.0n 0.6694 21599.5n 0.6694 21600.0n 0.6818 22199.5n 0.6818 22200.0n 0.6731 22799.5n 0.6731 22800.0n 0.6901 23399.5n 0.6901 23400.0n 0.5883 23999.5n 0.5883 24000.0n 0.6921 24599.5n 0.6921 24600.0n 0.6694 25199.5n 0.6694 25200.0n 0.6855 25799.5n 0.6855 25800.0n 0.6858 26399.5n 0.6858 26400.0n 0.6891 26999.5n 0.6891 27000.0n 0.6850 27599.5n 0.6850 27600.0n 0.6891 28199.5n 0.6891 28200.0n 0.6180 28799.5n 0.6180 28800.0n 0.6884 29399.5n 0.6884 29400.0n 0.6663 29999.5n 0.6663 30000.0n 0.6600 30599.5n 0.6600 30600.0n 0.5502 31199.5n 0.5502 31200.0n 0.5768 31799.5n 0.5768 31800.0n 0.6840 32399.5n 0.6840 32400.0n 0.6863 32999.5n 0.6863 33000.0n 0.6898 33599.5n 0.6898 33600.0n 0.6901 34199.5n 0.6901 34200.0n 0.6649 34799.5n 0.6649 34800.0n 0.6329 35399.5n 0.6329 35400.0n 0.6881 35999.5n 0.6881)
Vxn_who_13_0 xn_who_13_0 0 PWL(0.0n 0.3412 599.5n 0.3412 600.0n 0.3328 1199.5n 0.3328 1200.0n 0.3295 1799.5n 0.3295 1800.0n 0.3203 2399.5n 0.3203 2400.0n 0.3229 2999.5n 0.3229 3000.0n 0.3329 3599.5n 0.3329 3600.0n 0.3322 4199.5n 0.3322 4200.0n 0.3420 4799.5n 0.3420 4800.0n 0.3331 5399.5n 0.3331 5400.0n 0.3329 5999.5n 0.3329 6000.0n 0.3278 6599.5n 0.3278 6600.0n 0.3351 7199.5n 0.3351 7200.0n 0.3304 7799.5n 0.3304 7800.0n 0.3293 8399.5n 0.3293 8400.0n 0.3404 8999.5n 0.3404 9000.0n 0.3330 9599.5n 0.3330 9600.0n 0.3303 10199.5n 0.3303 10200.0n 0.3283 10799.5n 0.3283 10800.0n 0.3305 11399.5n 0.3305 11400.0n 0.3340 11999.5n 0.3340 12000.0n 0.3426 12599.5n 0.3426 12600.0n 0.3298 13199.5n 0.3298 13200.0n 0.3411 13799.5n 0.3411 13800.0n 0.3353 14399.5n 0.3353 14400.0n 0.3343 14999.5n 0.3343 15000.0n 0.3264 15599.5n 0.3264 15600.0n 0.3391 16199.5n 0.3391 16200.0n 0.3398 16799.5n 0.3398 16800.0n 0.3399 17399.5n 0.3399 17400.0n 0.3396 17999.5n 0.3396 18000.0n 0.3174 18599.5n 0.3174 18600.0n 0.3285 19199.5n 0.3285 19200.0n 0.3128 19799.5n 0.3128 19800.0n 0.3127 20399.5n 0.3127 20400.0n 0.3130 20999.5n 0.3130 21000.0n 0.3306 21599.5n 0.3306 21600.0n 0.3182 22199.5n 0.3182 22200.0n 0.3269 22799.5n 0.3269 22800.0n 0.3099 23399.5n 0.3099 23400.0n 0.4117 23999.5n 0.4117 24000.0n 0.3079 24599.5n 0.3079 24600.0n 0.3306 25199.5n 0.3306 25200.0n 0.3145 25799.5n 0.3145 25800.0n 0.3142 26399.5n 0.3142 26400.0n 0.3109 26999.5n 0.3109 27000.0n 0.3150 27599.5n 0.3150 27600.0n 0.3109 28199.5n 0.3109 28200.0n 0.3820 28799.5n 0.3820 28800.0n 0.3116 29399.5n 0.3116 29400.0n 0.3337 29999.5n 0.3337 30000.0n 0.3400 30599.5n 0.3400 30600.0n 0.4498 31199.5n 0.4498 31200.0n 0.4232 31799.5n 0.4232 31800.0n 0.3160 32399.5n 0.3160 32400.0n 0.3137 32999.5n 0.3137 33000.0n 0.3102 33599.5n 0.3102 33600.0n 0.3099 34199.5n 0.3099 34200.0n 0.3351 34799.5n 0.3351 34800.0n 0.3671 35399.5n 0.3671 35400.0n 0.3119 35999.5n 0.3119)
Vyp_who_13_0 yp_who_13_0 0 PWL(0.0n 0.5031 599.5n 0.5031 600.0n 0.5023 1199.5n 0.5023 1200.0n 0.5052 1799.5n 0.5052 1800.0n 0.5048 2399.5n 0.5048 2400.0n 0.5043 2999.5n 0.5043 3000.0n 0.5034 3599.5n 0.5034 3600.0n 0.5048 4199.5n 0.5048 4200.0n 0.5031 4799.5n 0.5031 4800.0n 0.5040 5399.5n 0.5040 5400.0n 0.5040 5999.5n 0.5040 6000.0n 0.5054 6599.5n 0.5054 6600.0n 0.5040 7199.5n 0.5040 7200.0n 0.5027 7799.5n 0.5027 7800.0n 0.5027 8399.5n 0.5027 8400.0n 0.5038 8999.5n 0.5038 9000.0n 0.5040 9599.5n 0.5040 9600.0n 0.5039 10199.5n 0.5039 10200.0n 0.5033 10799.5n 0.5033 10800.0n 0.5056 11399.5n 0.5056 11400.0n 0.5040 11999.5n 0.5040 12000.0n 0.5036 12599.5n 0.5036 12600.0n 0.5039 13199.5n 0.5039 13200.0n 0.5029 13799.5n 0.5029 13800.0n 0.5025 14399.5n 0.5025 14400.0n 0.5038 14999.5n 0.5038 15000.0n 0.5041 15599.5n 0.5041 15600.0n 0.5036 16199.5n 0.5036 16200.0n 0.5025 16799.5n 0.5025 16800.0n 0.5040 17399.5n 0.5040 17400.0n 0.5029 17999.5n 0.5029 18000.0n 0.5057 18599.5n 0.5057 18600.0n 0.5010 19199.5n 0.5010 19200.0n 0.5041 19799.5n 0.5041 19800.0n 0.5021 20399.5n 0.5021 20400.0n 0.5044 20999.5n 0.5044 21000.0n 0.5056 21599.5n 0.5056 21600.0n 0.5016 22199.5n 0.5016 22200.0n 0.5006 22799.5n 0.5006 22800.0n 0.5041 23399.5n 0.5041 23400.0n 0.5027 23999.5n 0.5027 24000.0n 0.5029 24599.5n 0.5029 24600.0n 0.5006 25199.5n 0.5006 25200.0n 0.5047 25799.5n 0.5047 25800.0n 0.5046 26399.5n 0.5046 26400.0n 0.5039 26999.5n 0.5039 27000.0n 0.5049 27599.5n 0.5049 27600.0n 0.5039 28199.5n 0.5039 28200.0n 0.5017 28799.5n 0.5017 28800.0n 0.5042 29399.5n 0.5042 29400.0n 0.5056 29999.5n 0.5056 30000.0n 0.5051 30599.5n 0.5051 30600.0n 0.5039 31199.5n 0.5039 31200.0n 0.5033 31799.5n 0.5033 31800.0n 0.5049 32399.5n 0.5049 32400.0n 0.5045 32999.5n 0.5045 33000.0n 0.5036 33599.5n 0.5036 33600.0n 0.5042 34199.5n 0.5042 34200.0n 0.5012 34799.5n 0.5012 34800.0n 0.5036 35399.5n 0.5036 35400.0n 0.5042 35999.5n 0.5042)
Vyn_who_13_0 yn_who_13_0 0 PWL(0.0n 0.4969 599.5n 0.4969 600.0n 0.4977 1199.5n 0.4977 1200.0n 0.4948 1799.5n 0.4948 1800.0n 0.4952 2399.5n 0.4952 2400.0n 0.4957 2999.5n 0.4957 3000.0n 0.4966 3599.5n 0.4966 3600.0n 0.4952 4199.5n 0.4952 4200.0n 0.4969 4799.5n 0.4969 4800.0n 0.4960 5399.5n 0.4960 5400.0n 0.4960 5999.5n 0.4960 6000.0n 0.4946 6599.5n 0.4946 6600.0n 0.4960 7199.5n 0.4960 7200.0n 0.4973 7799.5n 0.4973 7800.0n 0.4973 8399.5n 0.4973 8400.0n 0.4962 8999.5n 0.4962 9000.0n 0.4960 9599.5n 0.4960 9600.0n 0.4961 10199.5n 0.4961 10200.0n 0.4967 10799.5n 0.4967 10800.0n 0.4944 11399.5n 0.4944 11400.0n 0.4960 11999.5n 0.4960 12000.0n 0.4964 12599.5n 0.4964 12600.0n 0.4961 13199.5n 0.4961 13200.0n 0.4971 13799.5n 0.4971 13800.0n 0.4975 14399.5n 0.4975 14400.0n 0.4962 14999.5n 0.4962 15000.0n 0.4959 15599.5n 0.4959 15600.0n 0.4964 16199.5n 0.4964 16200.0n 0.4975 16799.5n 0.4975 16800.0n 0.4960 17399.5n 0.4960 17400.0n 0.4971 17999.5n 0.4971 18000.0n 0.4943 18599.5n 0.4943 18600.0n 0.4990 19199.5n 0.4990 19200.0n 0.4959 19799.5n 0.4959 19800.0n 0.4979 20399.5n 0.4979 20400.0n 0.4956 20999.5n 0.4956 21000.0n 0.4944 21599.5n 0.4944 21600.0n 0.4984 22199.5n 0.4984 22200.0n 0.4994 22799.5n 0.4994 22800.0n 0.4959 23399.5n 0.4959 23400.0n 0.4973 23999.5n 0.4973 24000.0n 0.4971 24599.5n 0.4971 24600.0n 0.4994 25199.5n 0.4994 25200.0n 0.4953 25799.5n 0.4953 25800.0n 0.4954 26399.5n 0.4954 26400.0n 0.4961 26999.5n 0.4961 27000.0n 0.4951 27599.5n 0.4951 27600.0n 0.4961 28199.5n 0.4961 28200.0n 0.4983 28799.5n 0.4983 28800.0n 0.4958 29399.5n 0.4958 29400.0n 0.4944 29999.5n 0.4944 30000.0n 0.4949 30599.5n 0.4949 30600.0n 0.4961 31199.5n 0.4961 31200.0n 0.4967 31799.5n 0.4967 31800.0n 0.4951 32399.5n 0.4951 32400.0n 0.4955 32999.5n 0.4955 33000.0n 0.4964 33599.5n 0.4964 33600.0n 0.4958 34199.5n 0.4958 34200.0n 0.4988 34799.5n 0.4988 34800.0n 0.4964 35399.5n 0.4964 35400.0n 0.4958 35999.5n 0.4958)
Cwp_who_13_0 wp_who_13_0 0 400p
Cwn_who_13_0 wn_who_13_0 0 400p
Xu_who_13_0 xp_who_13_0 xn_who_13_0 yp_who_13_0 yn_who_13_0 wp_who_13_0 wn_who_13_0 vdd gbn gprod
Vxp_who_13_1 xp_who_13_1 0 PWL(0.0n 0.6588 599.5n 0.6588 600.0n 0.6672 1199.5n 0.6672 1200.0n 0.6705 1799.5n 0.6705 1800.0n 0.6797 2399.5n 0.6797 2400.0n 0.6771 2999.5n 0.6771 3000.0n 0.6671 3599.5n 0.6671 3600.0n 0.6678 4199.5n 0.6678 4200.0n 0.6580 4799.5n 0.6580 4800.0n 0.6669 5399.5n 0.6669 5400.0n 0.6671 5999.5n 0.6671 6000.0n 0.6722 6599.5n 0.6722 6600.0n 0.6649 7199.5n 0.6649 7200.0n 0.6696 7799.5n 0.6696 7800.0n 0.6707 8399.5n 0.6707 8400.0n 0.6596 8999.5n 0.6596 9000.0n 0.6670 9599.5n 0.6670 9600.0n 0.6697 10199.5n 0.6697 10200.0n 0.6717 10799.5n 0.6717 10800.0n 0.6695 11399.5n 0.6695 11400.0n 0.6660 11999.5n 0.6660 12000.0n 0.6574 12599.5n 0.6574 12600.0n 0.6702 13199.5n 0.6702 13200.0n 0.6589 13799.5n 0.6589 13800.0n 0.6647 14399.5n 0.6647 14400.0n 0.6657 14999.5n 0.6657 15000.0n 0.6736 15599.5n 0.6736 15600.0n 0.6609 16199.5n 0.6609 16200.0n 0.6602 16799.5n 0.6602 16800.0n 0.6601 17399.5n 0.6601 17400.0n 0.6604 17999.5n 0.6604 18000.0n 0.6826 18599.5n 0.6826 18600.0n 0.6715 19199.5n 0.6715 19200.0n 0.6872 19799.5n 0.6872 19800.0n 0.6873 20399.5n 0.6873 20400.0n 0.6870 20999.5n 0.6870 21000.0n 0.6694 21599.5n 0.6694 21600.0n 0.6818 22199.5n 0.6818 22200.0n 0.6731 22799.5n 0.6731 22800.0n 0.6901 23399.5n 0.6901 23400.0n 0.5883 23999.5n 0.5883 24000.0n 0.6921 24599.5n 0.6921 24600.0n 0.6694 25199.5n 0.6694 25200.0n 0.6855 25799.5n 0.6855 25800.0n 0.6858 26399.5n 0.6858 26400.0n 0.6891 26999.5n 0.6891 27000.0n 0.6850 27599.5n 0.6850 27600.0n 0.6891 28199.5n 0.6891 28200.0n 0.6180 28799.5n 0.6180 28800.0n 0.6884 29399.5n 0.6884 29400.0n 0.6663 29999.5n 0.6663 30000.0n 0.6600 30599.5n 0.6600 30600.0n 0.5502 31199.5n 0.5502 31200.0n 0.5768 31799.5n 0.5768 31800.0n 0.6840 32399.5n 0.6840 32400.0n 0.6863 32999.5n 0.6863 33000.0n 0.6898 33599.5n 0.6898 33600.0n 0.6901 34199.5n 0.6901 34200.0n 0.6649 34799.5n 0.6649 34800.0n 0.6329 35399.5n 0.6329 35400.0n 0.6881 35999.5n 0.6881)
Vxn_who_13_1 xn_who_13_1 0 PWL(0.0n 0.3412 599.5n 0.3412 600.0n 0.3328 1199.5n 0.3328 1200.0n 0.3295 1799.5n 0.3295 1800.0n 0.3203 2399.5n 0.3203 2400.0n 0.3229 2999.5n 0.3229 3000.0n 0.3329 3599.5n 0.3329 3600.0n 0.3322 4199.5n 0.3322 4200.0n 0.3420 4799.5n 0.3420 4800.0n 0.3331 5399.5n 0.3331 5400.0n 0.3329 5999.5n 0.3329 6000.0n 0.3278 6599.5n 0.3278 6600.0n 0.3351 7199.5n 0.3351 7200.0n 0.3304 7799.5n 0.3304 7800.0n 0.3293 8399.5n 0.3293 8400.0n 0.3404 8999.5n 0.3404 9000.0n 0.3330 9599.5n 0.3330 9600.0n 0.3303 10199.5n 0.3303 10200.0n 0.3283 10799.5n 0.3283 10800.0n 0.3305 11399.5n 0.3305 11400.0n 0.3340 11999.5n 0.3340 12000.0n 0.3426 12599.5n 0.3426 12600.0n 0.3298 13199.5n 0.3298 13200.0n 0.3411 13799.5n 0.3411 13800.0n 0.3353 14399.5n 0.3353 14400.0n 0.3343 14999.5n 0.3343 15000.0n 0.3264 15599.5n 0.3264 15600.0n 0.3391 16199.5n 0.3391 16200.0n 0.3398 16799.5n 0.3398 16800.0n 0.3399 17399.5n 0.3399 17400.0n 0.3396 17999.5n 0.3396 18000.0n 0.3174 18599.5n 0.3174 18600.0n 0.3285 19199.5n 0.3285 19200.0n 0.3128 19799.5n 0.3128 19800.0n 0.3127 20399.5n 0.3127 20400.0n 0.3130 20999.5n 0.3130 21000.0n 0.3306 21599.5n 0.3306 21600.0n 0.3182 22199.5n 0.3182 22200.0n 0.3269 22799.5n 0.3269 22800.0n 0.3099 23399.5n 0.3099 23400.0n 0.4117 23999.5n 0.4117 24000.0n 0.3079 24599.5n 0.3079 24600.0n 0.3306 25199.5n 0.3306 25200.0n 0.3145 25799.5n 0.3145 25800.0n 0.3142 26399.5n 0.3142 26400.0n 0.3109 26999.5n 0.3109 27000.0n 0.3150 27599.5n 0.3150 27600.0n 0.3109 28199.5n 0.3109 28200.0n 0.3820 28799.5n 0.3820 28800.0n 0.3116 29399.5n 0.3116 29400.0n 0.3337 29999.5n 0.3337 30000.0n 0.3400 30599.5n 0.3400 30600.0n 0.4498 31199.5n 0.4498 31200.0n 0.4232 31799.5n 0.4232 31800.0n 0.3160 32399.5n 0.3160 32400.0n 0.3137 32999.5n 0.3137 33000.0n 0.3102 33599.5n 0.3102 33600.0n 0.3099 34199.5n 0.3099 34200.0n 0.3351 34799.5n 0.3351 34800.0n 0.3671 35399.5n 0.3671 35400.0n 0.3119 35999.5n 0.3119)
Vyp_who_13_1 yp_who_13_1 0 PWL(0.0n 0.5071 599.5n 0.5071 600.0n 0.5053 1199.5n 0.5053 1200.0n 0.5052 1799.5n 0.5052 1800.0n 0.5027 2399.5n 0.5027 2400.0n 0.5034 2999.5n 0.5034 3000.0n 0.5055 3599.5n 0.5055 3600.0n 0.5056 4199.5n 0.5056 4200.0n 0.5071 4799.5n 0.5071 4800.0n 0.5056 5399.5n 0.5056 5400.0n 0.5056 5999.5n 0.5056 6000.0n 0.5048 6599.5n 0.5048 6600.0n 0.5060 7199.5n 0.5060 7200.0n 0.5048 7799.5n 0.5048 7800.0n 0.5046 8399.5n 0.5046 8400.0n 0.5066 8999.5n 0.5066 9000.0n 0.5056 9599.5n 0.5056 9600.0n 0.5051 10199.5n 0.5051 10200.0n 0.5046 10799.5n 0.5046 10800.0n 0.5056 11399.5n 0.5056 11400.0n 0.5058 11999.5n 0.5058 12000.0n 0.5068 12599.5n 0.5068 12600.0n 0.5050 13199.5n 0.5050 13200.0n 0.5071 13799.5n 0.5071 13800.0n 0.5059 14399.5n 0.5059 14400.0n 0.5058 14999.5n 0.5058 15000.0n 0.5043 15599.5n 0.5043 15600.0n 0.5067 16199.5n 0.5067 16200.0n 0.5068 16799.5n 0.5068 16800.0n 0.5066 17399.5n 0.5066 17400.0n 0.5069 17999.5n 0.5069 18000.0n 0.5061 18599.5n 0.5061 18600.0n 0.5034 19199.5n 0.5034 19200.0n 0.5010 19799.5n 0.5010 19800.0n 0.4989 20399.5n 0.4989 20400.0n 0.5022 20999.5n 0.5022 21000.0n 0.5086 21599.5n 0.5086 21600.0n 0.5007 22199.5n 0.5007 22200.0n 0.5023 22799.5n 0.5023 22800.0n 0.5021 23399.5n 0.5021 23400.0n 0.5077 23999.5n 0.5077 24000.0n 0.4979 24599.5n 0.4979 24600.0n 0.5035 25199.5n 0.5035 25200.0n 0.5041 25799.5n 0.5041 25800.0n 0.5075 26399.5n 0.5075 26400.0n 0.5041 26999.5n 0.5041 27000.0n 0.5056 27599.5n 0.5056 27600.0n 0.5039 28199.5n 0.5039 28200.0n 0.5059 28799.5n 0.5059 28800.0n 0.5023 29399.5n 0.5023 29400.0n 0.5086 29999.5n 0.5086 30000.0n 0.5084 30599.5n 0.5084 30600.0n 0.5085 31199.5n 0.5085 31200.0n 0.5088 31799.5n 0.5088 31800.0n 0.5078 32399.5n 0.5078 32400.0n 0.5074 32999.5n 0.5074 33000.0n 0.4996 33599.5n 0.4996 33600.0n 0.5010 34199.5n 0.5010 34200.0n 0.5044 34799.5n 0.5044 34800.0n 0.5084 35399.5n 0.5084 35400.0n 0.5012 35999.5n 0.5012)
Vyn_who_13_1 yn_who_13_1 0 PWL(0.0n 0.4929 599.5n 0.4929 600.0n 0.4947 1199.5n 0.4947 1200.0n 0.4948 1799.5n 0.4948 1800.0n 0.4973 2399.5n 0.4973 2400.0n 0.4966 2999.5n 0.4966 3000.0n 0.4945 3599.5n 0.4945 3600.0n 0.4944 4199.5n 0.4944 4200.0n 0.4929 4799.5n 0.4929 4800.0n 0.4944 5399.5n 0.4944 5400.0n 0.4944 5999.5n 0.4944 6000.0n 0.4952 6599.5n 0.4952 6600.0n 0.4940 7199.5n 0.4940 7200.0n 0.4952 7799.5n 0.4952 7800.0n 0.4954 8399.5n 0.4954 8400.0n 0.4934 8999.5n 0.4934 9000.0n 0.4944 9599.5n 0.4944 9600.0n 0.4949 10199.5n 0.4949 10200.0n 0.4954 10799.5n 0.4954 10800.0n 0.4944 11399.5n 0.4944 11400.0n 0.4942 11999.5n 0.4942 12000.0n 0.4932 12599.5n 0.4932 12600.0n 0.4950 13199.5n 0.4950 13200.0n 0.4929 13799.5n 0.4929 13800.0n 0.4941 14399.5n 0.4941 14400.0n 0.4942 14999.5n 0.4942 15000.0n 0.4957 15599.5n 0.4957 15600.0n 0.4933 16199.5n 0.4933 16200.0n 0.4932 16799.5n 0.4932 16800.0n 0.4934 17399.5n 0.4934 17400.0n 0.4931 17999.5n 0.4931 18000.0n 0.4939 18599.5n 0.4939 18600.0n 0.4966 19199.5n 0.4966 19200.0n 0.4990 19799.5n 0.4990 19800.0n 0.5011 20399.5n 0.5011 20400.0n 0.4978 20999.5n 0.4978 21000.0n 0.4914 21599.5n 0.4914 21600.0n 0.4993 22199.5n 0.4993 22200.0n 0.4977 22799.5n 0.4977 22800.0n 0.4979 23399.5n 0.4979 23400.0n 0.4923 23999.5n 0.4923 24000.0n 0.5021 24599.5n 0.5021 24600.0n 0.4965 25199.5n 0.4965 25200.0n 0.4959 25799.5n 0.4959 25800.0n 0.4925 26399.5n 0.4925 26400.0n 0.4959 26999.5n 0.4959 27000.0n 0.4944 27599.5n 0.4944 27600.0n 0.4961 28199.5n 0.4961 28200.0n 0.4941 28799.5n 0.4941 28800.0n 0.4977 29399.5n 0.4977 29400.0n 0.4914 29999.5n 0.4914 30000.0n 0.4916 30599.5n 0.4916 30600.0n 0.4915 31199.5n 0.4915 31200.0n 0.4912 31799.5n 0.4912 31800.0n 0.4922 32399.5n 0.4922 32400.0n 0.4926 32999.5n 0.4926 33000.0n 0.5004 33599.5n 0.5004 33600.0n 0.4990 34199.5n 0.4990 34200.0n 0.4956 34799.5n 0.4956 34800.0n 0.4916 35399.5n 0.4916 35400.0n 0.4988 35999.5n 0.4988)
Cwp_who_13_1 wp_who_13_1 0 400p
Cwn_who_13_1 wn_who_13_1 0 400p
Xu_who_13_1 xp_who_13_1 xn_who_13_1 yp_who_13_1 yn_who_13_1 wp_who_13_1 wn_who_13_1 vdd gbn gprod
Vxp_bh_13 xp_bh_13 0 PWL(0.0n 0.7100 599.5n 0.7100 600.0n 0.7100 1199.5n 0.7100 1200.0n 0.7100 1799.5n 0.7100 1800.0n 0.7100 2399.5n 0.7100 2400.0n 0.7100 2999.5n 0.7100 3000.0n 0.7100 3599.5n 0.7100 3600.0n 0.7100 4199.5n 0.7100 4200.0n 0.7100 4799.5n 0.7100 4800.0n 0.7100 5399.5n 0.7100 5400.0n 0.7100 5999.5n 0.7100 6000.0n 0.7100 6599.5n 0.7100 6600.0n 0.7100 7199.5n 0.7100 7200.0n 0.7100 7799.5n 0.7100 7800.0n 0.7100 8399.5n 0.7100 8400.0n 0.7100 8999.5n 0.7100 9000.0n 0.7100 9599.5n 0.7100 9600.0n 0.7100 10199.5n 0.7100 10200.0n 0.7100 10799.5n 0.7100 10800.0n 0.7100 11399.5n 0.7100 11400.0n 0.7100 11999.5n 0.7100 12000.0n 0.7100 12599.5n 0.7100 12600.0n 0.7100 13199.5n 0.7100 13200.0n 0.7100 13799.5n 0.7100 13800.0n 0.7100 14399.5n 0.7100 14400.0n 0.7100 14999.5n 0.7100 15000.0n 0.7100 15599.5n 0.7100 15600.0n 0.7100 16199.5n 0.7100 16200.0n 0.7100 16799.5n 0.7100 16800.0n 0.7100 17399.5n 0.7100 17400.0n 0.7100 17999.5n 0.7100 18000.0n 0.7100 18599.5n 0.7100 18600.0n 0.7100 19199.5n 0.7100 19200.0n 0.7100 19799.5n 0.7100 19800.0n 0.7100 20399.5n 0.7100 20400.0n 0.7100 20999.5n 0.7100 21000.0n 0.7100 21599.5n 0.7100 21600.0n 0.7100 22199.5n 0.7100 22200.0n 0.7100 22799.5n 0.7100 22800.0n 0.7100 23399.5n 0.7100 23400.0n 0.7100 23999.5n 0.7100 24000.0n 0.7100 24599.5n 0.7100 24600.0n 0.7100 25199.5n 0.7100 25200.0n 0.7100 25799.5n 0.7100 25800.0n 0.7100 26399.5n 0.7100 26400.0n 0.7100 26999.5n 0.7100 27000.0n 0.7100 27599.5n 0.7100 27600.0n 0.7100 28199.5n 0.7100 28200.0n 0.7100 28799.5n 0.7100 28800.0n 0.7100 29399.5n 0.7100 29400.0n 0.7100 29999.5n 0.7100 30000.0n 0.7100 30599.5n 0.7100 30600.0n 0.7100 31199.5n 0.7100 31200.0n 0.7100 31799.5n 0.7100 31800.0n 0.7100 32399.5n 0.7100 32400.0n 0.7100 32999.5n 0.7100 33000.0n 0.7100 33599.5n 0.7100 33600.0n 0.7100 34199.5n 0.7100 34200.0n 0.7100 34799.5n 0.7100 34800.0n 0.7100 35399.5n 0.7100 35400.0n 0.7100 35999.5n 0.7100)
Vxn_bh_13 xn_bh_13 0 PWL(0.0n 0.2900 599.5n 0.2900 600.0n 0.2900 1199.5n 0.2900 1200.0n 0.2900 1799.5n 0.2900 1800.0n 0.2900 2399.5n 0.2900 2400.0n 0.2900 2999.5n 0.2900 3000.0n 0.2900 3599.5n 0.2900 3600.0n 0.2900 4199.5n 0.2900 4200.0n 0.2900 4799.5n 0.2900 4800.0n 0.2900 5399.5n 0.2900 5400.0n 0.2900 5999.5n 0.2900 6000.0n 0.2900 6599.5n 0.2900 6600.0n 0.2900 7199.5n 0.2900 7200.0n 0.2900 7799.5n 0.2900 7800.0n 0.2900 8399.5n 0.2900 8400.0n 0.2900 8999.5n 0.2900 9000.0n 0.2900 9599.5n 0.2900 9600.0n 0.2900 10199.5n 0.2900 10200.0n 0.2900 10799.5n 0.2900 10800.0n 0.2900 11399.5n 0.2900 11400.0n 0.2900 11999.5n 0.2900 12000.0n 0.2900 12599.5n 0.2900 12600.0n 0.2900 13199.5n 0.2900 13200.0n 0.2900 13799.5n 0.2900 13800.0n 0.2900 14399.5n 0.2900 14400.0n 0.2900 14999.5n 0.2900 15000.0n 0.2900 15599.5n 0.2900 15600.0n 0.2900 16199.5n 0.2900 16200.0n 0.2900 16799.5n 0.2900 16800.0n 0.2900 17399.5n 0.2900 17400.0n 0.2900 17999.5n 0.2900 18000.0n 0.2900 18599.5n 0.2900 18600.0n 0.2900 19199.5n 0.2900 19200.0n 0.2900 19799.5n 0.2900 19800.0n 0.2900 20399.5n 0.2900 20400.0n 0.2900 20999.5n 0.2900 21000.0n 0.2900 21599.5n 0.2900 21600.0n 0.2900 22199.5n 0.2900 22200.0n 0.2900 22799.5n 0.2900 22800.0n 0.2900 23399.5n 0.2900 23400.0n 0.2900 23999.5n 0.2900 24000.0n 0.2900 24599.5n 0.2900 24600.0n 0.2900 25199.5n 0.2900 25200.0n 0.2900 25799.5n 0.2900 25800.0n 0.2900 26399.5n 0.2900 26400.0n 0.2900 26999.5n 0.2900 27000.0n 0.2900 27599.5n 0.2900 27600.0n 0.2900 28199.5n 0.2900 28200.0n 0.2900 28799.5n 0.2900 28800.0n 0.2900 29399.5n 0.2900 29400.0n 0.2900 29999.5n 0.2900 30000.0n 0.2900 30599.5n 0.2900 30600.0n 0.2900 31199.5n 0.2900 31200.0n 0.2900 31799.5n 0.2900 31800.0n 0.2900 32399.5n 0.2900 32400.0n 0.2900 32999.5n 0.2900 33000.0n 0.2900 33599.5n 0.2900 33600.0n 0.2900 34199.5n 0.2900 34200.0n 0.2900 34799.5n 0.2900 34800.0n 0.2900 35399.5n 0.2900 35400.0n 0.2900 35999.5n 0.2900)
Vyp_bh_13 yp_bh_13 0 PWL(0.0n 0.6588 599.5n 0.6588 600.0n 0.6672 1199.5n 0.6672 1200.0n 0.6705 1799.5n 0.6705 1800.0n 0.6797 2399.5n 0.6797 2400.0n 0.6771 2999.5n 0.6771 3000.0n 0.6671 3599.5n 0.6671 3600.0n 0.6678 4199.5n 0.6678 4200.0n 0.6580 4799.5n 0.6580 4800.0n 0.6669 5399.5n 0.6669 5400.0n 0.6671 5999.5n 0.6671 6000.0n 0.6722 6599.5n 0.6722 6600.0n 0.6649 7199.5n 0.6649 7200.0n 0.6696 7799.5n 0.6696 7800.0n 0.6707 8399.5n 0.6707 8400.0n 0.6596 8999.5n 0.6596 9000.0n 0.6670 9599.5n 0.6670 9600.0n 0.6697 10199.5n 0.6697 10200.0n 0.6717 10799.5n 0.6717 10800.0n 0.6695 11399.5n 0.6695 11400.0n 0.6660 11999.5n 0.6660 12000.0n 0.6574 12599.5n 0.6574 12600.0n 0.6702 13199.5n 0.6702 13200.0n 0.6589 13799.5n 0.6589 13800.0n 0.6647 14399.5n 0.6647 14400.0n 0.6657 14999.5n 0.6657 15000.0n 0.6736 15599.5n 0.6736 15600.0n 0.6609 16199.5n 0.6609 16200.0n 0.6602 16799.5n 0.6602 16800.0n 0.6601 17399.5n 0.6601 17400.0n 0.6604 17999.5n 0.6604 18000.0n 0.6826 18599.5n 0.6826 18600.0n 0.6715 19199.5n 0.6715 19200.0n 0.6872 19799.5n 0.6872 19800.0n 0.6873 20399.5n 0.6873 20400.0n 0.6870 20999.5n 0.6870 21000.0n 0.6694 21599.5n 0.6694 21600.0n 0.6818 22199.5n 0.6818 22200.0n 0.6731 22799.5n 0.6731 22800.0n 0.6901 23399.5n 0.6901 23400.0n 0.5883 23999.5n 0.5883 24000.0n 0.6921 24599.5n 0.6921 24600.0n 0.6694 25199.5n 0.6694 25200.0n 0.6855 25799.5n 0.6855 25800.0n 0.6858 26399.5n 0.6858 26400.0n 0.6891 26999.5n 0.6891 27000.0n 0.6850 27599.5n 0.6850 27600.0n 0.6891 28199.5n 0.6891 28200.0n 0.6180 28799.5n 0.6180 28800.0n 0.6884 29399.5n 0.6884 29400.0n 0.6663 29999.5n 0.6663 30000.0n 0.6600 30599.5n 0.6600 30600.0n 0.5502 31199.5n 0.5502 31200.0n 0.5768 31799.5n 0.5768 31800.0n 0.6840 32399.5n 0.6840 32400.0n 0.6863 32999.5n 0.6863 33000.0n 0.6898 33599.5n 0.6898 33600.0n 0.6901 34199.5n 0.6901 34200.0n 0.6649 34799.5n 0.6649 34800.0n 0.6329 35399.5n 0.6329 35400.0n 0.6881 35999.5n 0.6881)
Vyn_bh_13 yn_bh_13 0 PWL(0.0n 0.3412 599.5n 0.3412 600.0n 0.3328 1199.5n 0.3328 1200.0n 0.3295 1799.5n 0.3295 1800.0n 0.3203 2399.5n 0.3203 2400.0n 0.3229 2999.5n 0.3229 3000.0n 0.3329 3599.5n 0.3329 3600.0n 0.3322 4199.5n 0.3322 4200.0n 0.3420 4799.5n 0.3420 4800.0n 0.3331 5399.5n 0.3331 5400.0n 0.3329 5999.5n 0.3329 6000.0n 0.3278 6599.5n 0.3278 6600.0n 0.3351 7199.5n 0.3351 7200.0n 0.3304 7799.5n 0.3304 7800.0n 0.3293 8399.5n 0.3293 8400.0n 0.3404 8999.5n 0.3404 9000.0n 0.3330 9599.5n 0.3330 9600.0n 0.3303 10199.5n 0.3303 10200.0n 0.3283 10799.5n 0.3283 10800.0n 0.3305 11399.5n 0.3305 11400.0n 0.3340 11999.5n 0.3340 12000.0n 0.3426 12599.5n 0.3426 12600.0n 0.3298 13199.5n 0.3298 13200.0n 0.3411 13799.5n 0.3411 13800.0n 0.3353 14399.5n 0.3353 14400.0n 0.3343 14999.5n 0.3343 15000.0n 0.3264 15599.5n 0.3264 15600.0n 0.3391 16199.5n 0.3391 16200.0n 0.3398 16799.5n 0.3398 16800.0n 0.3399 17399.5n 0.3399 17400.0n 0.3396 17999.5n 0.3396 18000.0n 0.3174 18599.5n 0.3174 18600.0n 0.3285 19199.5n 0.3285 19200.0n 0.3128 19799.5n 0.3128 19800.0n 0.3127 20399.5n 0.3127 20400.0n 0.3130 20999.5n 0.3130 21000.0n 0.3306 21599.5n 0.3306 21600.0n 0.3182 22199.5n 0.3182 22200.0n 0.3269 22799.5n 0.3269 22800.0n 0.3099 23399.5n 0.3099 23400.0n 0.4117 23999.5n 0.4117 24000.0n 0.3079 24599.5n 0.3079 24600.0n 0.3306 25199.5n 0.3306 25200.0n 0.3145 25799.5n 0.3145 25800.0n 0.3142 26399.5n 0.3142 26400.0n 0.3109 26999.5n 0.3109 27000.0n 0.3150 27599.5n 0.3150 27600.0n 0.3109 28199.5n 0.3109 28200.0n 0.3820 28799.5n 0.3820 28800.0n 0.3116 29399.5n 0.3116 29400.0n 0.3337 29999.5n 0.3337 30000.0n 0.3400 30599.5n 0.3400 30600.0n 0.4498 31199.5n 0.4498 31200.0n 0.4232 31799.5n 0.4232 31800.0n 0.3160 32399.5n 0.3160 32400.0n 0.3137 32999.5n 0.3137 33000.0n 0.3102 33599.5n 0.3102 33600.0n 0.3099 34199.5n 0.3099 34200.0n 0.3351 34799.5n 0.3351 34800.0n 0.3671 35399.5n 0.3671 35400.0n 0.3119 35999.5n 0.3119)
Cwp_bh_13 wp_bh_13 0 400p
Cwn_bh_13 wn_bh_13 0 400p
Xu_bh_13 xp_bh_13 xn_bh_13 yp_bh_13 yn_bh_13 wp_bh_13 wn_bh_13 vdd gbn gprod
Vxp_wih_0_14 xp_wih_0_14 0 PWL(0.0n 0.4942 599.5n 0.4942 600.0n 0.5558 1199.5n 0.5558 1200.0n 0.4708 1799.5n 0.4708 1800.0n 0.5235 2399.5n 0.5235 2400.0n 0.5350 2999.5n 0.5350 3000.0n 0.5172 3599.5n 0.5172 3600.0n 0.4702 4199.5n 0.4702 4200.0n 0.4867 4799.5n 0.4867 4800.0n 0.4970 5399.5n 0.4970 5400.0n 0.4986 5999.5n 0.4986 6000.0n 0.4751 6599.5n 0.4751 6600.0n 0.4870 7199.5n 0.4870 7200.0n 0.5502 7799.5n 0.5502 7800.0n 0.5521 8399.5n 0.5521 8400.0n 0.4638 8999.5n 0.4638 9000.0n 0.4982 9599.5n 0.4982 9600.0n 0.5131 10199.5n 0.5131 10200.0n 0.5386 10799.5n 0.5386 10800.0n 0.4592 11399.5n 0.4592 11400.0n 0.4950 11999.5n 0.4950 12000.0n 0.4559 12599.5n 0.4559 12600.0n 0.5162 13199.5n 0.5162 13200.0n 0.5038 13799.5n 0.5038 13800.0n 0.5333 14399.5n 0.5333 14400.0n 0.4991 14999.5n 0.4991 15000.0n 0.5298 15599.5n 0.5298 15600.0n 0.4823 16199.5n 0.4823 16200.0n 0.5239 16799.5n 0.5239 16800.0n 0.4592 17399.5n 0.4592 17400.0n 0.5094 17999.5n 0.5094 18000.0n 0.4337 18599.5n 0.4337 18600.0n 0.5977 19199.5n 0.5977 19200.0n 0.5364 19799.5n 0.5364 19800.0n 0.6122 20399.5n 0.6122 20400.0n 0.4856 20999.5n 0.4856 21000.0n 0.3861 21599.5n 0.3861 21600.0n 0.6094 22199.5n 0.6094 22200.0n 0.6364 22799.5n 0.6364 22800.0n 0.4807 23399.5n 0.4807 23400.0n 0.5614 23999.5n 0.5614 24000.0n 0.5913 24599.5n 0.5913 24600.0n 0.6295 25199.5n 0.6295 25200.0n 0.4496 25799.5n 0.4496 25800.0n 0.3792 26399.5n 0.3792 26400.0n 0.4434 26999.5n 0.4434 27000.0n 0.4340 27599.5n 0.4340 27600.0n 0.4461 28199.5n 0.4461 28200.0n 0.5791 28799.5n 0.5791 28800.0n 0.4777 29399.5n 0.4777 29400.0n 0.3878 29999.5n 0.3878 30000.0n 0.3832 30599.5n 0.3832 30600.0n 0.4022 31199.5n 0.4022 31200.0n 0.4482 31799.5n 0.4482 31800.0n 0.3662 32399.5n 0.3662 32400.0n 0.3857 32999.5n 0.3857 33000.0n 0.5584 33599.5n 0.5584 33600.0n 0.5284 34199.5n 0.5284 34200.0n 0.6034 34799.5n 0.6034 34800.0n 0.3469 35399.5n 0.3469 35400.0n 0.5290 35999.5n 0.5290)
Vxn_wih_0_14 xn_wih_0_14 0 PWL(0.0n 0.5058 599.5n 0.5058 600.0n 0.4442 1199.5n 0.4442 1200.0n 0.5292 1799.5n 0.5292 1800.0n 0.4765 2399.5n 0.4765 2400.0n 0.4650 2999.5n 0.4650 3000.0n 0.4828 3599.5n 0.4828 3600.0n 0.5298 4199.5n 0.5298 4200.0n 0.5133 4799.5n 0.5133 4800.0n 0.5030 5399.5n 0.5030 5400.0n 0.5014 5999.5n 0.5014 6000.0n 0.5249 6599.5n 0.5249 6600.0n 0.5130 7199.5n 0.5130 7200.0n 0.4498 7799.5n 0.4498 7800.0n 0.4479 8399.5n 0.4479 8400.0n 0.5362 8999.5n 0.5362 9000.0n 0.5018 9599.5n 0.5018 9600.0n 0.4869 10199.5n 0.4869 10200.0n 0.4614 10799.5n 0.4614 10800.0n 0.5408 11399.5n 0.5408 11400.0n 0.5050 11999.5n 0.5050 12000.0n 0.5441 12599.5n 0.5441 12600.0n 0.4838 13199.5n 0.4838 13200.0n 0.4962 13799.5n 0.4962 13800.0n 0.4667 14399.5n 0.4667 14400.0n 0.5009 14999.5n 0.5009 15000.0n 0.4702 15599.5n 0.4702 15600.0n 0.5177 16199.5n 0.5177 16200.0n 0.4761 16799.5n 0.4761 16800.0n 0.5408 17399.5n 0.5408 17400.0n 0.4906 17999.5n 0.4906 18000.0n 0.5663 18599.5n 0.5663 18600.0n 0.4023 19199.5n 0.4023 19200.0n 0.4636 19799.5n 0.4636 19800.0n 0.3878 20399.5n 0.3878 20400.0n 0.5144 20999.5n 0.5144 21000.0n 0.6139 21599.5n 0.6139 21600.0n 0.3906 22199.5n 0.3906 22200.0n 0.3636 22799.5n 0.3636 22800.0n 0.5193 23399.5n 0.5193 23400.0n 0.4386 23999.5n 0.4386 24000.0n 0.4087 24599.5n 0.4087 24600.0n 0.3705 25199.5n 0.3705 25200.0n 0.5504 25799.5n 0.5504 25800.0n 0.6208 26399.5n 0.6208 26400.0n 0.5566 26999.5n 0.5566 27000.0n 0.5660 27599.5n 0.5660 27600.0n 0.5539 28199.5n 0.5539 28200.0n 0.4209 28799.5n 0.4209 28800.0n 0.5223 29399.5n 0.5223 29400.0n 0.6122 29999.5n 0.6122 30000.0n 0.6168 30599.5n 0.6168 30600.0n 0.5978 31199.5n 0.5978 31200.0n 0.5518 31799.5n 0.5518 31800.0n 0.6338 32399.5n 0.6338 32400.0n 0.6143 32999.5n 0.6143 33000.0n 0.4416 33599.5n 0.4416 33600.0n 0.4716 34199.5n 0.4716 34200.0n 0.3966 34799.5n 0.3966 34800.0n 0.6531 35399.5n 0.6531 35400.0n 0.4710 35999.5n 0.4710)
Vyp_wih_0_14 yp_wih_0_14 0 PWL(0.0n 0.3348 599.5n 0.3348 600.0n 0.3359 1199.5n 0.3359 1200.0n 0.3401 1799.5n 0.3401 1800.0n 0.3454 2399.5n 0.3454 2400.0n 0.3427 2999.5n 0.3427 3000.0n 0.3377 3599.5n 0.3377 3600.0n 0.3387 4199.5n 0.3387 4200.0n 0.3346 4799.5n 0.3346 4800.0n 0.3381 5399.5n 0.3381 5400.0n 0.3381 5999.5n 0.3381 6000.0n 0.3411 6599.5n 0.3411 6600.0n 0.3372 7199.5n 0.3372 7200.0n 0.3375 7799.5n 0.3375 7800.0n 0.3379 8399.5n 0.3379 8400.0n 0.3354 8999.5n 0.3354 9000.0n 0.3381 9599.5n 0.3381 9600.0n 0.3391 10199.5n 0.3391 10200.0n 0.3392 10799.5n 0.3392 10800.0n 0.3398 11399.5n 0.3398 11400.0n 0.3376 11999.5n 0.3376 12000.0n 0.3347 12599.5n 0.3347 12600.0n 0.3393 13199.5n 0.3393 13200.0n 0.3346 13799.5n 0.3346 13800.0n 0.3360 14399.5n 0.3360 14400.0n 0.3374 14999.5n 0.3374 15000.0n 0.3407 15599.5n 0.3407 15600.0n 0.3356 16199.5n 0.3356 16200.0n 0.3346 16799.5n 0.3346 16800.0n 0.3356 17399.5n 0.3356 17400.0n 0.3350 17999.5n 0.3350 18000.0n 0.3607 18599.5n 0.3607 18600.0n 0.3351 19199.5n 0.3351 19200.0n 0.3644 19799.5n 0.3644 19800.0n 0.3490 20399.5n 0.3490 20400.0n 0.3697 20999.5n 0.3697 21000.0n 0.3420 21599.5n 0.3420 21600.0n 0.3413 22199.5n 0.3413 22200.0n 0.3358 22799.5n 0.3358 22800.0n 0.3770 23399.5n 0.3770 23400.0n 0.3232 23999.5n 0.3232 24000.0n 0.3675 24599.5n 0.3675 24600.0n 0.3338 25199.5n 0.3338 25200.0n 0.3681 25799.5n 0.3681 25800.0n 0.3794 26399.5n 0.3794 26400.0n 0.3796 26999.5n 0.3796 27000.0n 0.3698 27599.5n 0.3698 27600.0n 0.3793 28199.5n 0.3793 28200.0n 0.3242 28799.5n 0.3242 28800.0n 0.3747 29399.5n 0.3747 29400.0n 0.3403 29999.5n 0.3403 30000.0n 0.3375 30599.5n 0.3375 30600.0n 0.3239 31199.5n 0.3239 31200.0n 0.3249 31799.5n 0.3249 31800.0n 0.3731 32399.5n 0.3731 32400.0n 0.3807 32999.5n 0.3807 33000.0n 0.3688 33599.5n 0.3688 33600.0n 0.3745 34199.5n 0.3745 34200.0n 0.3318 34799.5n 0.3318 34800.0n 0.3327 35399.5n 0.3327 35400.0n 0.3688 35999.5n 0.3688)
Vyn_wih_0_14 yn_wih_0_14 0 PWL(0.0n 0.6652 599.5n 0.6652 600.0n 0.6641 1199.5n 0.6641 1200.0n 0.6599 1799.5n 0.6599 1800.0n 0.6546 2399.5n 0.6546 2400.0n 0.6573 2999.5n 0.6573 3000.0n 0.6623 3599.5n 0.6623 3600.0n 0.6613 4199.5n 0.6613 4200.0n 0.6654 4799.5n 0.6654 4800.0n 0.6619 5399.5n 0.6619 5400.0n 0.6619 5999.5n 0.6619 6000.0n 0.6589 6599.5n 0.6589 6600.0n 0.6628 7199.5n 0.6628 7200.0n 0.6625 7799.5n 0.6625 7800.0n 0.6621 8399.5n 0.6621 8400.0n 0.6646 8999.5n 0.6646 9000.0n 0.6619 9599.5n 0.6619 9600.0n 0.6609 10199.5n 0.6609 10200.0n 0.6608 10799.5n 0.6608 10800.0n 0.6602 11399.5n 0.6602 11400.0n 0.6624 11999.5n 0.6624 12000.0n 0.6653 12599.5n 0.6653 12600.0n 0.6607 13199.5n 0.6607 13200.0n 0.6654 13799.5n 0.6654 13800.0n 0.6640 14399.5n 0.6640 14400.0n 0.6626 14999.5n 0.6626 15000.0n 0.6593 15599.5n 0.6593 15600.0n 0.6644 16199.5n 0.6644 16200.0n 0.6654 16799.5n 0.6654 16800.0n 0.6644 17399.5n 0.6644 17400.0n 0.6650 17999.5n 0.6650 18000.0n 0.6393 18599.5n 0.6393 18600.0n 0.6649 19199.5n 0.6649 19200.0n 0.6356 19799.5n 0.6356 19800.0n 0.6510 20399.5n 0.6510 20400.0n 0.6303 20999.5n 0.6303 21000.0n 0.6580 21599.5n 0.6580 21600.0n 0.6587 22199.5n 0.6587 22200.0n 0.6642 22799.5n 0.6642 22800.0n 0.6230 23399.5n 0.6230 23400.0n 0.6768 23999.5n 0.6768 24000.0n 0.6325 24599.5n 0.6325 24600.0n 0.6662 25199.5n 0.6662 25200.0n 0.6319 25799.5n 0.6319 25800.0n 0.6206 26399.5n 0.6206 26400.0n 0.6204 26999.5n 0.6204 27000.0n 0.6302 27599.5n 0.6302 27600.0n 0.6207 28199.5n 0.6207 28200.0n 0.6758 28799.5n 0.6758 28800.0n 0.6253 29399.5n 0.6253 29400.0n 0.6597 29999.5n 0.6597 30000.0n 0.6625 30599.5n 0.6625 30600.0n 0.6761 31199.5n 0.6761 31200.0n 0.6751 31799.5n 0.6751 31800.0n 0.6269 32399.5n 0.6269 32400.0n 0.6193 32999.5n 0.6193 33000.0n 0.6312 33599.5n 0.6312 33600.0n 0.6255 34199.5n 0.6255 34200.0n 0.6682 34799.5n 0.6682 34800.0n 0.6673 35399.5n 0.6673 35400.0n 0.6312 35999.5n 0.6312)
Cwp_wih_0_14 wp_wih_0_14 0 400p
Cwn_wih_0_14 wn_wih_0_14 0 400p
Xu_wih_0_14 xp_wih_0_14 xn_wih_0_14 yp_wih_0_14 yn_wih_0_14 wp_wih_0_14 wn_wih_0_14 vdd gbn gprod
Vxp_wih_1_14 xp_wih_1_14 0 PWL(0.0n 0.5370 599.5n 0.5370 600.0n 0.5167 1199.5n 0.5167 1200.0n 0.4793 1799.5n 0.4793 1800.0n 0.4441 2399.5n 0.4441 2400.0n 0.4555 2999.5n 0.4555 3000.0n 0.5055 3599.5n 0.5055 3600.0n 0.4939 4199.5n 0.4939 4200.0n 0.5385 4799.5n 0.5385 4800.0n 0.5024 5399.5n 0.5024 5400.0n 0.5015 5999.5n 0.5015 6000.0n 0.4700 6599.5n 0.4700 6600.0n 0.5120 7199.5n 0.5120 7200.0n 0.5006 7799.5n 0.5006 7800.0n 0.4950 8399.5n 0.4950 8400.0n 0.5309 8999.5n 0.5309 9000.0n 0.5023 9599.5n 0.5023 9600.0n 0.4893 10199.5n 0.4893 10200.0n 0.4837 10799.5n 0.4837 10800.0n 0.4823 11399.5n 0.4823 11400.0n 0.5074 11999.5n 0.5074 12000.0n 0.5364 12599.5n 0.5364 12600.0n 0.4868 13199.5n 0.4868 13200.0n 0.5380 13799.5n 0.5380 13800.0n 0.5220 14399.5n 0.5220 14400.0n 0.5095 14999.5n 0.5095 15000.0n 0.4705 15599.5n 0.4705 15600.0n 0.5289 16199.5n 0.5289 16200.0n 0.5368 16799.5n 0.5368 16800.0n 0.5287 17399.5n 0.5287 17400.0n 0.5342 17999.5n 0.5342 18000.0n 0.4253 18599.5n 0.4253 18600.0n 0.5119 19199.5n 0.5119 19200.0n 0.4104 19799.5n 0.4104 19800.0n 0.4314 20399.5n 0.4314 20400.0n 0.4005 20999.5n 0.4005 21000.0n 0.4696 21599.5n 0.4696 21600.0n 0.4531 22199.5n 0.4531 22200.0n 0.5039 22799.5n 0.5039 22800.0n 0.3608 23399.5n 0.3608 23400.0n 0.6273 23999.5n 0.6273 24000.0n 0.3928 24599.5n 0.3928 24600.0n 0.5253 25199.5n 0.5253 25200.0n 0.4107 25799.5n 0.4107 25800.0n 0.3947 26399.5n 0.3947 26400.0n 0.3716 26999.5n 0.3716 27000.0n 0.4111 27599.5n 0.4111 27600.0n 0.3715 28199.5n 0.3715 28200.0n 0.5939 28799.5n 0.5939 28800.0n 0.3849 29399.5n 0.3849 29400.0n 0.4835 29999.5n 0.4835 30000.0n 0.5119 30599.5n 0.5119 30600.0n 0.6226 31199.5n 0.6226 31200.0n 0.6064 31799.5n 0.6064 31800.0n 0.4115 32399.5n 0.4115 32400.0n 0.3900 32999.5n 0.3900 33000.0n 0.3958 33599.5n 0.3958 33600.0n 0.3747 34199.5n 0.3747 34200.0n 0.5423 34799.5n 0.5423 34800.0n 0.5509 35399.5n 0.5509 35400.0n 0.3990 35999.5n 0.3990)
Vxn_wih_1_14 xn_wih_1_14 0 PWL(0.0n 0.4630 599.5n 0.4630 600.0n 0.4833 1199.5n 0.4833 1200.0n 0.5207 1799.5n 0.5207 1800.0n 0.5559 2399.5n 0.5559 2400.0n 0.5445 2999.5n 0.5445 3000.0n 0.4945 3599.5n 0.4945 3600.0n 0.5061 4199.5n 0.5061 4200.0n 0.4615 4799.5n 0.4615 4800.0n 0.4976 5399.5n 0.4976 5400.0n 0.4985 5999.5n 0.4985 6000.0n 0.5300 6599.5n 0.5300 6600.0n 0.4880 7199.5n 0.4880 7200.0n 0.4994 7799.5n 0.4994 7800.0n 0.5050 8399.5n 0.5050 8400.0n 0.4691 8999.5n 0.4691 9000.0n 0.4977 9599.5n 0.4977 9600.0n 0.5107 10199.5n 0.5107 10200.0n 0.5163 10799.5n 0.5163 10800.0n 0.5177 11399.5n 0.5177 11400.0n 0.4926 11999.5n 0.4926 12000.0n 0.4636 12599.5n 0.4636 12600.0n 0.5132 13199.5n 0.5132 13200.0n 0.4620 13799.5n 0.4620 13800.0n 0.4780 14399.5n 0.4780 14400.0n 0.4905 14999.5n 0.4905 15000.0n 0.5295 15599.5n 0.5295 15600.0n 0.4711 16199.5n 0.4711 16200.0n 0.4632 16799.5n 0.4632 16800.0n 0.4713 17399.5n 0.4713 17400.0n 0.4658 17999.5n 0.4658 18000.0n 0.5747 18599.5n 0.5747 18600.0n 0.4881 19199.5n 0.4881 19200.0n 0.5896 19799.5n 0.5896 19800.0n 0.5686 20399.5n 0.5686 20400.0n 0.5995 20999.5n 0.5995 21000.0n 0.5304 21599.5n 0.5304 21600.0n 0.5469 22199.5n 0.5469 22200.0n 0.4961 22799.5n 0.4961 22800.0n 0.6392 23399.5n 0.6392 23400.0n 0.3727 23999.5n 0.3727 24000.0n 0.6072 24599.5n 0.6072 24600.0n 0.4747 25199.5n 0.4747 25200.0n 0.5893 25799.5n 0.5893 25800.0n 0.6053 26399.5n 0.6053 26400.0n 0.6284 26999.5n 0.6284 27000.0n 0.5889 27599.5n 0.5889 27600.0n 0.6285 28199.5n 0.6285 28200.0n 0.4061 28799.5n 0.4061 28800.0n 0.6151 29399.5n 0.6151 29400.0n 0.5165 29999.5n 0.5165 30000.0n 0.4881 30599.5n 0.4881 30600.0n 0.3774 31199.5n 0.3774 31200.0n 0.3936 31799.5n 0.3936 31800.0n 0.5885 32399.5n 0.5885 32400.0n 0.6100 32999.5n 0.6100 33000.0n 0.6042 33599.5n 0.6042 33600.0n 0.6253 34199.5n 0.6253 34200.0n 0.4577 34799.5n 0.4577 34800.0n 0.4491 35399.5n 0.4491 35400.0n 0.6010 35999.5n 0.6010)
Vyp_wih_1_14 yp_wih_1_14 0 PWL(0.0n 0.3348 599.5n 0.3348 600.0n 0.3359 1199.5n 0.3359 1200.0n 0.3401 1799.5n 0.3401 1800.0n 0.3454 2399.5n 0.3454 2400.0n 0.3427 2999.5n 0.3427 3000.0n 0.3377 3599.5n 0.3377 3600.0n 0.3387 4199.5n 0.3387 4200.0n 0.3346 4799.5n 0.3346 4800.0n 0.3381 5399.5n 0.3381 5400.0n 0.3381 5999.5n 0.3381 6000.0n 0.3411 6599.5n 0.3411 6600.0n 0.3372 7199.5n 0.3372 7200.0n 0.3375 7799.5n 0.3375 7800.0n 0.3379 8399.5n 0.3379 8400.0n 0.3354 8999.5n 0.3354 9000.0n 0.3381 9599.5n 0.3381 9600.0n 0.3391 10199.5n 0.3391 10200.0n 0.3392 10799.5n 0.3392 10800.0n 0.3398 11399.5n 0.3398 11400.0n 0.3376 11999.5n 0.3376 12000.0n 0.3347 12599.5n 0.3347 12600.0n 0.3393 13199.5n 0.3393 13200.0n 0.3346 13799.5n 0.3346 13800.0n 0.3360 14399.5n 0.3360 14400.0n 0.3374 14999.5n 0.3374 15000.0n 0.3407 15599.5n 0.3407 15600.0n 0.3356 16199.5n 0.3356 16200.0n 0.3346 16799.5n 0.3346 16800.0n 0.3356 17399.5n 0.3356 17400.0n 0.3350 17999.5n 0.3350 18000.0n 0.3607 18599.5n 0.3607 18600.0n 0.3351 19199.5n 0.3351 19200.0n 0.3644 19799.5n 0.3644 19800.0n 0.3490 20399.5n 0.3490 20400.0n 0.3697 20999.5n 0.3697 21000.0n 0.3420 21599.5n 0.3420 21600.0n 0.3413 22199.5n 0.3413 22200.0n 0.3358 22799.5n 0.3358 22800.0n 0.3770 23399.5n 0.3770 23400.0n 0.3232 23999.5n 0.3232 24000.0n 0.3675 24599.5n 0.3675 24600.0n 0.3338 25199.5n 0.3338 25200.0n 0.3681 25799.5n 0.3681 25800.0n 0.3794 26399.5n 0.3794 26400.0n 0.3796 26999.5n 0.3796 27000.0n 0.3698 27599.5n 0.3698 27600.0n 0.3793 28199.5n 0.3793 28200.0n 0.3242 28799.5n 0.3242 28800.0n 0.3747 29399.5n 0.3747 29400.0n 0.3403 29999.5n 0.3403 30000.0n 0.3375 30599.5n 0.3375 30600.0n 0.3239 31199.5n 0.3239 31200.0n 0.3249 31799.5n 0.3249 31800.0n 0.3731 32399.5n 0.3731 32400.0n 0.3807 32999.5n 0.3807 33000.0n 0.3688 33599.5n 0.3688 33600.0n 0.3745 34199.5n 0.3745 34200.0n 0.3318 34799.5n 0.3318 34800.0n 0.3327 35399.5n 0.3327 35400.0n 0.3688 35999.5n 0.3688)
Vyn_wih_1_14 yn_wih_1_14 0 PWL(0.0n 0.6652 599.5n 0.6652 600.0n 0.6641 1199.5n 0.6641 1200.0n 0.6599 1799.5n 0.6599 1800.0n 0.6546 2399.5n 0.6546 2400.0n 0.6573 2999.5n 0.6573 3000.0n 0.6623 3599.5n 0.6623 3600.0n 0.6613 4199.5n 0.6613 4200.0n 0.6654 4799.5n 0.6654 4800.0n 0.6619 5399.5n 0.6619 5400.0n 0.6619 5999.5n 0.6619 6000.0n 0.6589 6599.5n 0.6589 6600.0n 0.6628 7199.5n 0.6628 7200.0n 0.6625 7799.5n 0.6625 7800.0n 0.6621 8399.5n 0.6621 8400.0n 0.6646 8999.5n 0.6646 9000.0n 0.6619 9599.5n 0.6619 9600.0n 0.6609 10199.5n 0.6609 10200.0n 0.6608 10799.5n 0.6608 10800.0n 0.6602 11399.5n 0.6602 11400.0n 0.6624 11999.5n 0.6624 12000.0n 0.6653 12599.5n 0.6653 12600.0n 0.6607 13199.5n 0.6607 13200.0n 0.6654 13799.5n 0.6654 13800.0n 0.6640 14399.5n 0.6640 14400.0n 0.6626 14999.5n 0.6626 15000.0n 0.6593 15599.5n 0.6593 15600.0n 0.6644 16199.5n 0.6644 16200.0n 0.6654 16799.5n 0.6654 16800.0n 0.6644 17399.5n 0.6644 17400.0n 0.6650 17999.5n 0.6650 18000.0n 0.6393 18599.5n 0.6393 18600.0n 0.6649 19199.5n 0.6649 19200.0n 0.6356 19799.5n 0.6356 19800.0n 0.6510 20399.5n 0.6510 20400.0n 0.6303 20999.5n 0.6303 21000.0n 0.6580 21599.5n 0.6580 21600.0n 0.6587 22199.5n 0.6587 22200.0n 0.6642 22799.5n 0.6642 22800.0n 0.6230 23399.5n 0.6230 23400.0n 0.6768 23999.5n 0.6768 24000.0n 0.6325 24599.5n 0.6325 24600.0n 0.6662 25199.5n 0.6662 25200.0n 0.6319 25799.5n 0.6319 25800.0n 0.6206 26399.5n 0.6206 26400.0n 0.6204 26999.5n 0.6204 27000.0n 0.6302 27599.5n 0.6302 27600.0n 0.6207 28199.5n 0.6207 28200.0n 0.6758 28799.5n 0.6758 28800.0n 0.6253 29399.5n 0.6253 29400.0n 0.6597 29999.5n 0.6597 30000.0n 0.6625 30599.5n 0.6625 30600.0n 0.6761 31199.5n 0.6761 31200.0n 0.6751 31799.5n 0.6751 31800.0n 0.6269 32399.5n 0.6269 32400.0n 0.6193 32999.5n 0.6193 33000.0n 0.6312 33599.5n 0.6312 33600.0n 0.6255 34199.5n 0.6255 34200.0n 0.6682 34799.5n 0.6682 34800.0n 0.6673 35399.5n 0.6673 35400.0n 0.6312 35999.5n 0.6312)
Cwp_wih_1_14 wp_wih_1_14 0 400p
Cwn_wih_1_14 wn_wih_1_14 0 400p
Xu_wih_1_14 xp_wih_1_14 xn_wih_1_14 yp_wih_1_14 yn_wih_1_14 wp_wih_1_14 wn_wih_1_14 vdd gbn gprod
Vxp_who_14_0 xp_who_14_0 0 PWL(0.0n 0.3348 599.5n 0.3348 600.0n 0.3359 1199.5n 0.3359 1200.0n 0.3401 1799.5n 0.3401 1800.0n 0.3454 2399.5n 0.3454 2400.0n 0.3427 2999.5n 0.3427 3000.0n 0.3377 3599.5n 0.3377 3600.0n 0.3387 4199.5n 0.3387 4200.0n 0.3346 4799.5n 0.3346 4800.0n 0.3381 5399.5n 0.3381 5400.0n 0.3381 5999.5n 0.3381 6000.0n 0.3411 6599.5n 0.3411 6600.0n 0.3372 7199.5n 0.3372 7200.0n 0.3375 7799.5n 0.3375 7800.0n 0.3379 8399.5n 0.3379 8400.0n 0.3354 8999.5n 0.3354 9000.0n 0.3381 9599.5n 0.3381 9600.0n 0.3391 10199.5n 0.3391 10200.0n 0.3392 10799.5n 0.3392 10800.0n 0.3398 11399.5n 0.3398 11400.0n 0.3376 11999.5n 0.3376 12000.0n 0.3347 12599.5n 0.3347 12600.0n 0.3393 13199.5n 0.3393 13200.0n 0.3346 13799.5n 0.3346 13800.0n 0.3360 14399.5n 0.3360 14400.0n 0.3374 14999.5n 0.3374 15000.0n 0.3407 15599.5n 0.3407 15600.0n 0.3356 16199.5n 0.3356 16200.0n 0.3346 16799.5n 0.3346 16800.0n 0.3356 17399.5n 0.3356 17400.0n 0.3350 17999.5n 0.3350 18000.0n 0.3607 18599.5n 0.3607 18600.0n 0.3351 19199.5n 0.3351 19200.0n 0.3644 19799.5n 0.3644 19800.0n 0.3490 20399.5n 0.3490 20400.0n 0.3697 20999.5n 0.3697 21000.0n 0.3420 21599.5n 0.3420 21600.0n 0.3413 22199.5n 0.3413 22200.0n 0.3358 22799.5n 0.3358 22800.0n 0.3770 23399.5n 0.3770 23400.0n 0.3232 23999.5n 0.3232 24000.0n 0.3675 24599.5n 0.3675 24600.0n 0.3338 25199.5n 0.3338 25200.0n 0.3681 25799.5n 0.3681 25800.0n 0.3794 26399.5n 0.3794 26400.0n 0.3796 26999.5n 0.3796 27000.0n 0.3698 27599.5n 0.3698 27600.0n 0.3793 28199.5n 0.3793 28200.0n 0.3242 28799.5n 0.3242 28800.0n 0.3747 29399.5n 0.3747 29400.0n 0.3403 29999.5n 0.3403 30000.0n 0.3375 30599.5n 0.3375 30600.0n 0.3239 31199.5n 0.3239 31200.0n 0.3249 31799.5n 0.3249 31800.0n 0.3731 32399.5n 0.3731 32400.0n 0.3807 32999.5n 0.3807 33000.0n 0.3688 33599.5n 0.3688 33600.0n 0.3745 34199.5n 0.3745 34200.0n 0.3318 34799.5n 0.3318 34800.0n 0.3327 35399.5n 0.3327 35400.0n 0.3688 35999.5n 0.3688)
Vxn_who_14_0 xn_who_14_0 0 PWL(0.0n 0.6652 599.5n 0.6652 600.0n 0.6641 1199.5n 0.6641 1200.0n 0.6599 1799.5n 0.6599 1800.0n 0.6546 2399.5n 0.6546 2400.0n 0.6573 2999.5n 0.6573 3000.0n 0.6623 3599.5n 0.6623 3600.0n 0.6613 4199.5n 0.6613 4200.0n 0.6654 4799.5n 0.6654 4800.0n 0.6619 5399.5n 0.6619 5400.0n 0.6619 5999.5n 0.6619 6000.0n 0.6589 6599.5n 0.6589 6600.0n 0.6628 7199.5n 0.6628 7200.0n 0.6625 7799.5n 0.6625 7800.0n 0.6621 8399.5n 0.6621 8400.0n 0.6646 8999.5n 0.6646 9000.0n 0.6619 9599.5n 0.6619 9600.0n 0.6609 10199.5n 0.6609 10200.0n 0.6608 10799.5n 0.6608 10800.0n 0.6602 11399.5n 0.6602 11400.0n 0.6624 11999.5n 0.6624 12000.0n 0.6653 12599.5n 0.6653 12600.0n 0.6607 13199.5n 0.6607 13200.0n 0.6654 13799.5n 0.6654 13800.0n 0.6640 14399.5n 0.6640 14400.0n 0.6626 14999.5n 0.6626 15000.0n 0.6593 15599.5n 0.6593 15600.0n 0.6644 16199.5n 0.6644 16200.0n 0.6654 16799.5n 0.6654 16800.0n 0.6644 17399.5n 0.6644 17400.0n 0.6650 17999.5n 0.6650 18000.0n 0.6393 18599.5n 0.6393 18600.0n 0.6649 19199.5n 0.6649 19200.0n 0.6356 19799.5n 0.6356 19800.0n 0.6510 20399.5n 0.6510 20400.0n 0.6303 20999.5n 0.6303 21000.0n 0.6580 21599.5n 0.6580 21600.0n 0.6587 22199.5n 0.6587 22200.0n 0.6642 22799.5n 0.6642 22800.0n 0.6230 23399.5n 0.6230 23400.0n 0.6768 23999.5n 0.6768 24000.0n 0.6325 24599.5n 0.6325 24600.0n 0.6662 25199.5n 0.6662 25200.0n 0.6319 25799.5n 0.6319 25800.0n 0.6206 26399.5n 0.6206 26400.0n 0.6204 26999.5n 0.6204 27000.0n 0.6302 27599.5n 0.6302 27600.0n 0.6207 28199.5n 0.6207 28200.0n 0.6758 28799.5n 0.6758 28800.0n 0.6253 29399.5n 0.6253 29400.0n 0.6597 29999.5n 0.6597 30000.0n 0.6625 30599.5n 0.6625 30600.0n 0.6761 31199.5n 0.6761 31200.0n 0.6751 31799.5n 0.6751 31800.0n 0.6269 32399.5n 0.6269 32400.0n 0.6193 32999.5n 0.6193 33000.0n 0.6312 33599.5n 0.6312 33600.0n 0.6255 34199.5n 0.6255 34200.0n 0.6682 34799.5n 0.6682 34800.0n 0.6673 35399.5n 0.6673 35400.0n 0.6312 35999.5n 0.6312)
Vyp_who_14_0 yp_who_14_0 0 PWL(0.0n 0.5031 599.5n 0.5031 600.0n 0.5023 1199.5n 0.5023 1200.0n 0.5052 1799.5n 0.5052 1800.0n 0.5048 2399.5n 0.5048 2400.0n 0.5043 2999.5n 0.5043 3000.0n 0.5034 3599.5n 0.5034 3600.0n 0.5048 4199.5n 0.5048 4200.0n 0.5031 4799.5n 0.5031 4800.0n 0.5040 5399.5n 0.5040 5400.0n 0.5040 5999.5n 0.5040 6000.0n 0.5054 6599.5n 0.5054 6600.0n 0.5040 7199.5n 0.5040 7200.0n 0.5027 7799.5n 0.5027 7800.0n 0.5027 8399.5n 0.5027 8400.0n 0.5038 8999.5n 0.5038 9000.0n 0.5040 9599.5n 0.5040 9600.0n 0.5039 10199.5n 0.5039 10200.0n 0.5033 10799.5n 0.5033 10800.0n 0.5056 11399.5n 0.5056 11400.0n 0.5040 11999.5n 0.5040 12000.0n 0.5036 12599.5n 0.5036 12600.0n 0.5039 13199.5n 0.5039 13200.0n 0.5029 13799.5n 0.5029 13800.0n 0.5025 14399.5n 0.5025 14400.0n 0.5038 14999.5n 0.5038 15000.0n 0.5041 15599.5n 0.5041 15600.0n 0.5036 16199.5n 0.5036 16200.0n 0.5025 16799.5n 0.5025 16800.0n 0.5040 17399.5n 0.5040 17400.0n 0.5029 17999.5n 0.5029 18000.0n 0.5057 18599.5n 0.5057 18600.0n 0.5010 19199.5n 0.5010 19200.0n 0.5041 19799.5n 0.5041 19800.0n 0.5021 20399.5n 0.5021 20400.0n 0.5044 20999.5n 0.5044 21000.0n 0.5056 21599.5n 0.5056 21600.0n 0.5016 22199.5n 0.5016 22200.0n 0.5006 22799.5n 0.5006 22800.0n 0.5041 23399.5n 0.5041 23400.0n 0.5027 23999.5n 0.5027 24000.0n 0.5029 24599.5n 0.5029 24600.0n 0.5006 25199.5n 0.5006 25200.0n 0.5047 25799.5n 0.5047 25800.0n 0.5046 26399.5n 0.5046 26400.0n 0.5039 26999.5n 0.5039 27000.0n 0.5049 27599.5n 0.5049 27600.0n 0.5039 28199.5n 0.5039 28200.0n 0.5017 28799.5n 0.5017 28800.0n 0.5042 29399.5n 0.5042 29400.0n 0.5056 29999.5n 0.5056 30000.0n 0.5051 30599.5n 0.5051 30600.0n 0.5039 31199.5n 0.5039 31200.0n 0.5033 31799.5n 0.5033 31800.0n 0.5049 32399.5n 0.5049 32400.0n 0.5045 32999.5n 0.5045 33000.0n 0.5036 33599.5n 0.5036 33600.0n 0.5042 34199.5n 0.5042 34200.0n 0.5012 34799.5n 0.5012 34800.0n 0.5036 35399.5n 0.5036 35400.0n 0.5042 35999.5n 0.5042)
Vyn_who_14_0 yn_who_14_0 0 PWL(0.0n 0.4969 599.5n 0.4969 600.0n 0.4977 1199.5n 0.4977 1200.0n 0.4948 1799.5n 0.4948 1800.0n 0.4952 2399.5n 0.4952 2400.0n 0.4957 2999.5n 0.4957 3000.0n 0.4966 3599.5n 0.4966 3600.0n 0.4952 4199.5n 0.4952 4200.0n 0.4969 4799.5n 0.4969 4800.0n 0.4960 5399.5n 0.4960 5400.0n 0.4960 5999.5n 0.4960 6000.0n 0.4946 6599.5n 0.4946 6600.0n 0.4960 7199.5n 0.4960 7200.0n 0.4973 7799.5n 0.4973 7800.0n 0.4973 8399.5n 0.4973 8400.0n 0.4962 8999.5n 0.4962 9000.0n 0.4960 9599.5n 0.4960 9600.0n 0.4961 10199.5n 0.4961 10200.0n 0.4967 10799.5n 0.4967 10800.0n 0.4944 11399.5n 0.4944 11400.0n 0.4960 11999.5n 0.4960 12000.0n 0.4964 12599.5n 0.4964 12600.0n 0.4961 13199.5n 0.4961 13200.0n 0.4971 13799.5n 0.4971 13800.0n 0.4975 14399.5n 0.4975 14400.0n 0.4962 14999.5n 0.4962 15000.0n 0.4959 15599.5n 0.4959 15600.0n 0.4964 16199.5n 0.4964 16200.0n 0.4975 16799.5n 0.4975 16800.0n 0.4960 17399.5n 0.4960 17400.0n 0.4971 17999.5n 0.4971 18000.0n 0.4943 18599.5n 0.4943 18600.0n 0.4990 19199.5n 0.4990 19200.0n 0.4959 19799.5n 0.4959 19800.0n 0.4979 20399.5n 0.4979 20400.0n 0.4956 20999.5n 0.4956 21000.0n 0.4944 21599.5n 0.4944 21600.0n 0.4984 22199.5n 0.4984 22200.0n 0.4994 22799.5n 0.4994 22800.0n 0.4959 23399.5n 0.4959 23400.0n 0.4973 23999.5n 0.4973 24000.0n 0.4971 24599.5n 0.4971 24600.0n 0.4994 25199.5n 0.4994 25200.0n 0.4953 25799.5n 0.4953 25800.0n 0.4954 26399.5n 0.4954 26400.0n 0.4961 26999.5n 0.4961 27000.0n 0.4951 27599.5n 0.4951 27600.0n 0.4961 28199.5n 0.4961 28200.0n 0.4983 28799.5n 0.4983 28800.0n 0.4958 29399.5n 0.4958 29400.0n 0.4944 29999.5n 0.4944 30000.0n 0.4949 30599.5n 0.4949 30600.0n 0.4961 31199.5n 0.4961 31200.0n 0.4967 31799.5n 0.4967 31800.0n 0.4951 32399.5n 0.4951 32400.0n 0.4955 32999.5n 0.4955 33000.0n 0.4964 33599.5n 0.4964 33600.0n 0.4958 34199.5n 0.4958 34200.0n 0.4988 34799.5n 0.4988 34800.0n 0.4964 35399.5n 0.4964 35400.0n 0.4958 35999.5n 0.4958)
Cwp_who_14_0 wp_who_14_0 0 400p
Cwn_who_14_0 wn_who_14_0 0 400p
Xu_who_14_0 xp_who_14_0 xn_who_14_0 yp_who_14_0 yn_who_14_0 wp_who_14_0 wn_who_14_0 vdd gbn gprod
Vxp_who_14_1 xp_who_14_1 0 PWL(0.0n 0.3348 599.5n 0.3348 600.0n 0.3359 1199.5n 0.3359 1200.0n 0.3401 1799.5n 0.3401 1800.0n 0.3454 2399.5n 0.3454 2400.0n 0.3427 2999.5n 0.3427 3000.0n 0.3377 3599.5n 0.3377 3600.0n 0.3387 4199.5n 0.3387 4200.0n 0.3346 4799.5n 0.3346 4800.0n 0.3381 5399.5n 0.3381 5400.0n 0.3381 5999.5n 0.3381 6000.0n 0.3411 6599.5n 0.3411 6600.0n 0.3372 7199.5n 0.3372 7200.0n 0.3375 7799.5n 0.3375 7800.0n 0.3379 8399.5n 0.3379 8400.0n 0.3354 8999.5n 0.3354 9000.0n 0.3381 9599.5n 0.3381 9600.0n 0.3391 10199.5n 0.3391 10200.0n 0.3392 10799.5n 0.3392 10800.0n 0.3398 11399.5n 0.3398 11400.0n 0.3376 11999.5n 0.3376 12000.0n 0.3347 12599.5n 0.3347 12600.0n 0.3393 13199.5n 0.3393 13200.0n 0.3346 13799.5n 0.3346 13800.0n 0.3360 14399.5n 0.3360 14400.0n 0.3374 14999.5n 0.3374 15000.0n 0.3407 15599.5n 0.3407 15600.0n 0.3356 16199.5n 0.3356 16200.0n 0.3346 16799.5n 0.3346 16800.0n 0.3356 17399.5n 0.3356 17400.0n 0.3350 17999.5n 0.3350 18000.0n 0.3607 18599.5n 0.3607 18600.0n 0.3351 19199.5n 0.3351 19200.0n 0.3644 19799.5n 0.3644 19800.0n 0.3490 20399.5n 0.3490 20400.0n 0.3697 20999.5n 0.3697 21000.0n 0.3420 21599.5n 0.3420 21600.0n 0.3413 22199.5n 0.3413 22200.0n 0.3358 22799.5n 0.3358 22800.0n 0.3770 23399.5n 0.3770 23400.0n 0.3232 23999.5n 0.3232 24000.0n 0.3675 24599.5n 0.3675 24600.0n 0.3338 25199.5n 0.3338 25200.0n 0.3681 25799.5n 0.3681 25800.0n 0.3794 26399.5n 0.3794 26400.0n 0.3796 26999.5n 0.3796 27000.0n 0.3698 27599.5n 0.3698 27600.0n 0.3793 28199.5n 0.3793 28200.0n 0.3242 28799.5n 0.3242 28800.0n 0.3747 29399.5n 0.3747 29400.0n 0.3403 29999.5n 0.3403 30000.0n 0.3375 30599.5n 0.3375 30600.0n 0.3239 31199.5n 0.3239 31200.0n 0.3249 31799.5n 0.3249 31800.0n 0.3731 32399.5n 0.3731 32400.0n 0.3807 32999.5n 0.3807 33000.0n 0.3688 33599.5n 0.3688 33600.0n 0.3745 34199.5n 0.3745 34200.0n 0.3318 34799.5n 0.3318 34800.0n 0.3327 35399.5n 0.3327 35400.0n 0.3688 35999.5n 0.3688)
Vxn_who_14_1 xn_who_14_1 0 PWL(0.0n 0.6652 599.5n 0.6652 600.0n 0.6641 1199.5n 0.6641 1200.0n 0.6599 1799.5n 0.6599 1800.0n 0.6546 2399.5n 0.6546 2400.0n 0.6573 2999.5n 0.6573 3000.0n 0.6623 3599.5n 0.6623 3600.0n 0.6613 4199.5n 0.6613 4200.0n 0.6654 4799.5n 0.6654 4800.0n 0.6619 5399.5n 0.6619 5400.0n 0.6619 5999.5n 0.6619 6000.0n 0.6589 6599.5n 0.6589 6600.0n 0.6628 7199.5n 0.6628 7200.0n 0.6625 7799.5n 0.6625 7800.0n 0.6621 8399.5n 0.6621 8400.0n 0.6646 8999.5n 0.6646 9000.0n 0.6619 9599.5n 0.6619 9600.0n 0.6609 10199.5n 0.6609 10200.0n 0.6608 10799.5n 0.6608 10800.0n 0.6602 11399.5n 0.6602 11400.0n 0.6624 11999.5n 0.6624 12000.0n 0.6653 12599.5n 0.6653 12600.0n 0.6607 13199.5n 0.6607 13200.0n 0.6654 13799.5n 0.6654 13800.0n 0.6640 14399.5n 0.6640 14400.0n 0.6626 14999.5n 0.6626 15000.0n 0.6593 15599.5n 0.6593 15600.0n 0.6644 16199.5n 0.6644 16200.0n 0.6654 16799.5n 0.6654 16800.0n 0.6644 17399.5n 0.6644 17400.0n 0.6650 17999.5n 0.6650 18000.0n 0.6393 18599.5n 0.6393 18600.0n 0.6649 19199.5n 0.6649 19200.0n 0.6356 19799.5n 0.6356 19800.0n 0.6510 20399.5n 0.6510 20400.0n 0.6303 20999.5n 0.6303 21000.0n 0.6580 21599.5n 0.6580 21600.0n 0.6587 22199.5n 0.6587 22200.0n 0.6642 22799.5n 0.6642 22800.0n 0.6230 23399.5n 0.6230 23400.0n 0.6768 23999.5n 0.6768 24000.0n 0.6325 24599.5n 0.6325 24600.0n 0.6662 25199.5n 0.6662 25200.0n 0.6319 25799.5n 0.6319 25800.0n 0.6206 26399.5n 0.6206 26400.0n 0.6204 26999.5n 0.6204 27000.0n 0.6302 27599.5n 0.6302 27600.0n 0.6207 28199.5n 0.6207 28200.0n 0.6758 28799.5n 0.6758 28800.0n 0.6253 29399.5n 0.6253 29400.0n 0.6597 29999.5n 0.6597 30000.0n 0.6625 30599.5n 0.6625 30600.0n 0.6761 31199.5n 0.6761 31200.0n 0.6751 31799.5n 0.6751 31800.0n 0.6269 32399.5n 0.6269 32400.0n 0.6193 32999.5n 0.6193 33000.0n 0.6312 33599.5n 0.6312 33600.0n 0.6255 34199.5n 0.6255 34200.0n 0.6682 34799.5n 0.6682 34800.0n 0.6673 35399.5n 0.6673 35400.0n 0.6312 35999.5n 0.6312)
Vyp_who_14_1 yp_who_14_1 0 PWL(0.0n 0.5071 599.5n 0.5071 600.0n 0.5053 1199.5n 0.5053 1200.0n 0.5052 1799.5n 0.5052 1800.0n 0.5027 2399.5n 0.5027 2400.0n 0.5034 2999.5n 0.5034 3000.0n 0.5055 3599.5n 0.5055 3600.0n 0.5056 4199.5n 0.5056 4200.0n 0.5071 4799.5n 0.5071 4800.0n 0.5056 5399.5n 0.5056 5400.0n 0.5056 5999.5n 0.5056 6000.0n 0.5048 6599.5n 0.5048 6600.0n 0.5060 7199.5n 0.5060 7200.0n 0.5048 7799.5n 0.5048 7800.0n 0.5046 8399.5n 0.5046 8400.0n 0.5066 8999.5n 0.5066 9000.0n 0.5056 9599.5n 0.5056 9600.0n 0.5051 10199.5n 0.5051 10200.0n 0.5046 10799.5n 0.5046 10800.0n 0.5056 11399.5n 0.5056 11400.0n 0.5058 11999.5n 0.5058 12000.0n 0.5068 12599.5n 0.5068 12600.0n 0.5050 13199.5n 0.5050 13200.0n 0.5071 13799.5n 0.5071 13800.0n 0.5059 14399.5n 0.5059 14400.0n 0.5058 14999.5n 0.5058 15000.0n 0.5043 15599.5n 0.5043 15600.0n 0.5067 16199.5n 0.5067 16200.0n 0.5068 16799.5n 0.5068 16800.0n 0.5066 17399.5n 0.5066 17400.0n 0.5069 17999.5n 0.5069 18000.0n 0.5061 18599.5n 0.5061 18600.0n 0.5034 19199.5n 0.5034 19200.0n 0.5010 19799.5n 0.5010 19800.0n 0.4989 20399.5n 0.4989 20400.0n 0.5022 20999.5n 0.5022 21000.0n 0.5086 21599.5n 0.5086 21600.0n 0.5007 22199.5n 0.5007 22200.0n 0.5023 22799.5n 0.5023 22800.0n 0.5021 23399.5n 0.5021 23400.0n 0.5077 23999.5n 0.5077 24000.0n 0.4979 24599.5n 0.4979 24600.0n 0.5035 25199.5n 0.5035 25200.0n 0.5041 25799.5n 0.5041 25800.0n 0.5075 26399.5n 0.5075 26400.0n 0.5041 26999.5n 0.5041 27000.0n 0.5056 27599.5n 0.5056 27600.0n 0.5039 28199.5n 0.5039 28200.0n 0.5059 28799.5n 0.5059 28800.0n 0.5023 29399.5n 0.5023 29400.0n 0.5086 29999.5n 0.5086 30000.0n 0.5084 30599.5n 0.5084 30600.0n 0.5085 31199.5n 0.5085 31200.0n 0.5088 31799.5n 0.5088 31800.0n 0.5078 32399.5n 0.5078 32400.0n 0.5074 32999.5n 0.5074 33000.0n 0.4996 33599.5n 0.4996 33600.0n 0.5010 34199.5n 0.5010 34200.0n 0.5044 34799.5n 0.5044 34800.0n 0.5084 35399.5n 0.5084 35400.0n 0.5012 35999.5n 0.5012)
Vyn_who_14_1 yn_who_14_1 0 PWL(0.0n 0.4929 599.5n 0.4929 600.0n 0.4947 1199.5n 0.4947 1200.0n 0.4948 1799.5n 0.4948 1800.0n 0.4973 2399.5n 0.4973 2400.0n 0.4966 2999.5n 0.4966 3000.0n 0.4945 3599.5n 0.4945 3600.0n 0.4944 4199.5n 0.4944 4200.0n 0.4929 4799.5n 0.4929 4800.0n 0.4944 5399.5n 0.4944 5400.0n 0.4944 5999.5n 0.4944 6000.0n 0.4952 6599.5n 0.4952 6600.0n 0.4940 7199.5n 0.4940 7200.0n 0.4952 7799.5n 0.4952 7800.0n 0.4954 8399.5n 0.4954 8400.0n 0.4934 8999.5n 0.4934 9000.0n 0.4944 9599.5n 0.4944 9600.0n 0.4949 10199.5n 0.4949 10200.0n 0.4954 10799.5n 0.4954 10800.0n 0.4944 11399.5n 0.4944 11400.0n 0.4942 11999.5n 0.4942 12000.0n 0.4932 12599.5n 0.4932 12600.0n 0.4950 13199.5n 0.4950 13200.0n 0.4929 13799.5n 0.4929 13800.0n 0.4941 14399.5n 0.4941 14400.0n 0.4942 14999.5n 0.4942 15000.0n 0.4957 15599.5n 0.4957 15600.0n 0.4933 16199.5n 0.4933 16200.0n 0.4932 16799.5n 0.4932 16800.0n 0.4934 17399.5n 0.4934 17400.0n 0.4931 17999.5n 0.4931 18000.0n 0.4939 18599.5n 0.4939 18600.0n 0.4966 19199.5n 0.4966 19200.0n 0.4990 19799.5n 0.4990 19800.0n 0.5011 20399.5n 0.5011 20400.0n 0.4978 20999.5n 0.4978 21000.0n 0.4914 21599.5n 0.4914 21600.0n 0.4993 22199.5n 0.4993 22200.0n 0.4977 22799.5n 0.4977 22800.0n 0.4979 23399.5n 0.4979 23400.0n 0.4923 23999.5n 0.4923 24000.0n 0.5021 24599.5n 0.5021 24600.0n 0.4965 25199.5n 0.4965 25200.0n 0.4959 25799.5n 0.4959 25800.0n 0.4925 26399.5n 0.4925 26400.0n 0.4959 26999.5n 0.4959 27000.0n 0.4944 27599.5n 0.4944 27600.0n 0.4961 28199.5n 0.4961 28200.0n 0.4941 28799.5n 0.4941 28800.0n 0.4977 29399.5n 0.4977 29400.0n 0.4914 29999.5n 0.4914 30000.0n 0.4916 30599.5n 0.4916 30600.0n 0.4915 31199.5n 0.4915 31200.0n 0.4912 31799.5n 0.4912 31800.0n 0.4922 32399.5n 0.4922 32400.0n 0.4926 32999.5n 0.4926 33000.0n 0.5004 33599.5n 0.5004 33600.0n 0.4990 34199.5n 0.4990 34200.0n 0.4956 34799.5n 0.4956 34800.0n 0.4916 35399.5n 0.4916 35400.0n 0.4988 35999.5n 0.4988)
Cwp_who_14_1 wp_who_14_1 0 400p
Cwn_who_14_1 wn_who_14_1 0 400p
Xu_who_14_1 xp_who_14_1 xn_who_14_1 yp_who_14_1 yn_who_14_1 wp_who_14_1 wn_who_14_1 vdd gbn gprod
Vxp_bh_14 xp_bh_14 0 PWL(0.0n 0.7100 599.5n 0.7100 600.0n 0.7100 1199.5n 0.7100 1200.0n 0.7100 1799.5n 0.7100 1800.0n 0.7100 2399.5n 0.7100 2400.0n 0.7100 2999.5n 0.7100 3000.0n 0.7100 3599.5n 0.7100 3600.0n 0.7100 4199.5n 0.7100 4200.0n 0.7100 4799.5n 0.7100 4800.0n 0.7100 5399.5n 0.7100 5400.0n 0.7100 5999.5n 0.7100 6000.0n 0.7100 6599.5n 0.7100 6600.0n 0.7100 7199.5n 0.7100 7200.0n 0.7100 7799.5n 0.7100 7800.0n 0.7100 8399.5n 0.7100 8400.0n 0.7100 8999.5n 0.7100 9000.0n 0.7100 9599.5n 0.7100 9600.0n 0.7100 10199.5n 0.7100 10200.0n 0.7100 10799.5n 0.7100 10800.0n 0.7100 11399.5n 0.7100 11400.0n 0.7100 11999.5n 0.7100 12000.0n 0.7100 12599.5n 0.7100 12600.0n 0.7100 13199.5n 0.7100 13200.0n 0.7100 13799.5n 0.7100 13800.0n 0.7100 14399.5n 0.7100 14400.0n 0.7100 14999.5n 0.7100 15000.0n 0.7100 15599.5n 0.7100 15600.0n 0.7100 16199.5n 0.7100 16200.0n 0.7100 16799.5n 0.7100 16800.0n 0.7100 17399.5n 0.7100 17400.0n 0.7100 17999.5n 0.7100 18000.0n 0.7100 18599.5n 0.7100 18600.0n 0.7100 19199.5n 0.7100 19200.0n 0.7100 19799.5n 0.7100 19800.0n 0.7100 20399.5n 0.7100 20400.0n 0.7100 20999.5n 0.7100 21000.0n 0.7100 21599.5n 0.7100 21600.0n 0.7100 22199.5n 0.7100 22200.0n 0.7100 22799.5n 0.7100 22800.0n 0.7100 23399.5n 0.7100 23400.0n 0.7100 23999.5n 0.7100 24000.0n 0.7100 24599.5n 0.7100 24600.0n 0.7100 25199.5n 0.7100 25200.0n 0.7100 25799.5n 0.7100 25800.0n 0.7100 26399.5n 0.7100 26400.0n 0.7100 26999.5n 0.7100 27000.0n 0.7100 27599.5n 0.7100 27600.0n 0.7100 28199.5n 0.7100 28200.0n 0.7100 28799.5n 0.7100 28800.0n 0.7100 29399.5n 0.7100 29400.0n 0.7100 29999.5n 0.7100 30000.0n 0.7100 30599.5n 0.7100 30600.0n 0.7100 31199.5n 0.7100 31200.0n 0.7100 31799.5n 0.7100 31800.0n 0.7100 32399.5n 0.7100 32400.0n 0.7100 32999.5n 0.7100 33000.0n 0.7100 33599.5n 0.7100 33600.0n 0.7100 34199.5n 0.7100 34200.0n 0.7100 34799.5n 0.7100 34800.0n 0.7100 35399.5n 0.7100 35400.0n 0.7100 35999.5n 0.7100)
Vxn_bh_14 xn_bh_14 0 PWL(0.0n 0.2900 599.5n 0.2900 600.0n 0.2900 1199.5n 0.2900 1200.0n 0.2900 1799.5n 0.2900 1800.0n 0.2900 2399.5n 0.2900 2400.0n 0.2900 2999.5n 0.2900 3000.0n 0.2900 3599.5n 0.2900 3600.0n 0.2900 4199.5n 0.2900 4200.0n 0.2900 4799.5n 0.2900 4800.0n 0.2900 5399.5n 0.2900 5400.0n 0.2900 5999.5n 0.2900 6000.0n 0.2900 6599.5n 0.2900 6600.0n 0.2900 7199.5n 0.2900 7200.0n 0.2900 7799.5n 0.2900 7800.0n 0.2900 8399.5n 0.2900 8400.0n 0.2900 8999.5n 0.2900 9000.0n 0.2900 9599.5n 0.2900 9600.0n 0.2900 10199.5n 0.2900 10200.0n 0.2900 10799.5n 0.2900 10800.0n 0.2900 11399.5n 0.2900 11400.0n 0.2900 11999.5n 0.2900 12000.0n 0.2900 12599.5n 0.2900 12600.0n 0.2900 13199.5n 0.2900 13200.0n 0.2900 13799.5n 0.2900 13800.0n 0.2900 14399.5n 0.2900 14400.0n 0.2900 14999.5n 0.2900 15000.0n 0.2900 15599.5n 0.2900 15600.0n 0.2900 16199.5n 0.2900 16200.0n 0.2900 16799.5n 0.2900 16800.0n 0.2900 17399.5n 0.2900 17400.0n 0.2900 17999.5n 0.2900 18000.0n 0.2900 18599.5n 0.2900 18600.0n 0.2900 19199.5n 0.2900 19200.0n 0.2900 19799.5n 0.2900 19800.0n 0.2900 20399.5n 0.2900 20400.0n 0.2900 20999.5n 0.2900 21000.0n 0.2900 21599.5n 0.2900 21600.0n 0.2900 22199.5n 0.2900 22200.0n 0.2900 22799.5n 0.2900 22800.0n 0.2900 23399.5n 0.2900 23400.0n 0.2900 23999.5n 0.2900 24000.0n 0.2900 24599.5n 0.2900 24600.0n 0.2900 25199.5n 0.2900 25200.0n 0.2900 25799.5n 0.2900 25800.0n 0.2900 26399.5n 0.2900 26400.0n 0.2900 26999.5n 0.2900 27000.0n 0.2900 27599.5n 0.2900 27600.0n 0.2900 28199.5n 0.2900 28200.0n 0.2900 28799.5n 0.2900 28800.0n 0.2900 29399.5n 0.2900 29400.0n 0.2900 29999.5n 0.2900 30000.0n 0.2900 30599.5n 0.2900 30600.0n 0.2900 31199.5n 0.2900 31200.0n 0.2900 31799.5n 0.2900 31800.0n 0.2900 32399.5n 0.2900 32400.0n 0.2900 32999.5n 0.2900 33000.0n 0.2900 33599.5n 0.2900 33600.0n 0.2900 34199.5n 0.2900 34200.0n 0.2900 34799.5n 0.2900 34800.0n 0.2900 35399.5n 0.2900 35400.0n 0.2900 35999.5n 0.2900)
Vyp_bh_14 yp_bh_14 0 PWL(0.0n 0.3348 599.5n 0.3348 600.0n 0.3359 1199.5n 0.3359 1200.0n 0.3401 1799.5n 0.3401 1800.0n 0.3454 2399.5n 0.3454 2400.0n 0.3427 2999.5n 0.3427 3000.0n 0.3377 3599.5n 0.3377 3600.0n 0.3387 4199.5n 0.3387 4200.0n 0.3346 4799.5n 0.3346 4800.0n 0.3381 5399.5n 0.3381 5400.0n 0.3381 5999.5n 0.3381 6000.0n 0.3411 6599.5n 0.3411 6600.0n 0.3372 7199.5n 0.3372 7200.0n 0.3375 7799.5n 0.3375 7800.0n 0.3379 8399.5n 0.3379 8400.0n 0.3354 8999.5n 0.3354 9000.0n 0.3381 9599.5n 0.3381 9600.0n 0.3391 10199.5n 0.3391 10200.0n 0.3392 10799.5n 0.3392 10800.0n 0.3398 11399.5n 0.3398 11400.0n 0.3376 11999.5n 0.3376 12000.0n 0.3347 12599.5n 0.3347 12600.0n 0.3393 13199.5n 0.3393 13200.0n 0.3346 13799.5n 0.3346 13800.0n 0.3360 14399.5n 0.3360 14400.0n 0.3374 14999.5n 0.3374 15000.0n 0.3407 15599.5n 0.3407 15600.0n 0.3356 16199.5n 0.3356 16200.0n 0.3346 16799.5n 0.3346 16800.0n 0.3356 17399.5n 0.3356 17400.0n 0.3350 17999.5n 0.3350 18000.0n 0.3607 18599.5n 0.3607 18600.0n 0.3351 19199.5n 0.3351 19200.0n 0.3644 19799.5n 0.3644 19800.0n 0.3490 20399.5n 0.3490 20400.0n 0.3697 20999.5n 0.3697 21000.0n 0.3420 21599.5n 0.3420 21600.0n 0.3413 22199.5n 0.3413 22200.0n 0.3358 22799.5n 0.3358 22800.0n 0.3770 23399.5n 0.3770 23400.0n 0.3232 23999.5n 0.3232 24000.0n 0.3675 24599.5n 0.3675 24600.0n 0.3338 25199.5n 0.3338 25200.0n 0.3681 25799.5n 0.3681 25800.0n 0.3794 26399.5n 0.3794 26400.0n 0.3796 26999.5n 0.3796 27000.0n 0.3698 27599.5n 0.3698 27600.0n 0.3793 28199.5n 0.3793 28200.0n 0.3242 28799.5n 0.3242 28800.0n 0.3747 29399.5n 0.3747 29400.0n 0.3403 29999.5n 0.3403 30000.0n 0.3375 30599.5n 0.3375 30600.0n 0.3239 31199.5n 0.3239 31200.0n 0.3249 31799.5n 0.3249 31800.0n 0.3731 32399.5n 0.3731 32400.0n 0.3807 32999.5n 0.3807 33000.0n 0.3688 33599.5n 0.3688 33600.0n 0.3745 34199.5n 0.3745 34200.0n 0.3318 34799.5n 0.3318 34800.0n 0.3327 35399.5n 0.3327 35400.0n 0.3688 35999.5n 0.3688)
Vyn_bh_14 yn_bh_14 0 PWL(0.0n 0.6652 599.5n 0.6652 600.0n 0.6641 1199.5n 0.6641 1200.0n 0.6599 1799.5n 0.6599 1800.0n 0.6546 2399.5n 0.6546 2400.0n 0.6573 2999.5n 0.6573 3000.0n 0.6623 3599.5n 0.6623 3600.0n 0.6613 4199.5n 0.6613 4200.0n 0.6654 4799.5n 0.6654 4800.0n 0.6619 5399.5n 0.6619 5400.0n 0.6619 5999.5n 0.6619 6000.0n 0.6589 6599.5n 0.6589 6600.0n 0.6628 7199.5n 0.6628 7200.0n 0.6625 7799.5n 0.6625 7800.0n 0.6621 8399.5n 0.6621 8400.0n 0.6646 8999.5n 0.6646 9000.0n 0.6619 9599.5n 0.6619 9600.0n 0.6609 10199.5n 0.6609 10200.0n 0.6608 10799.5n 0.6608 10800.0n 0.6602 11399.5n 0.6602 11400.0n 0.6624 11999.5n 0.6624 12000.0n 0.6653 12599.5n 0.6653 12600.0n 0.6607 13199.5n 0.6607 13200.0n 0.6654 13799.5n 0.6654 13800.0n 0.6640 14399.5n 0.6640 14400.0n 0.6626 14999.5n 0.6626 15000.0n 0.6593 15599.5n 0.6593 15600.0n 0.6644 16199.5n 0.6644 16200.0n 0.6654 16799.5n 0.6654 16800.0n 0.6644 17399.5n 0.6644 17400.0n 0.6650 17999.5n 0.6650 18000.0n 0.6393 18599.5n 0.6393 18600.0n 0.6649 19199.5n 0.6649 19200.0n 0.6356 19799.5n 0.6356 19800.0n 0.6510 20399.5n 0.6510 20400.0n 0.6303 20999.5n 0.6303 21000.0n 0.6580 21599.5n 0.6580 21600.0n 0.6587 22199.5n 0.6587 22200.0n 0.6642 22799.5n 0.6642 22800.0n 0.6230 23399.5n 0.6230 23400.0n 0.6768 23999.5n 0.6768 24000.0n 0.6325 24599.5n 0.6325 24600.0n 0.6662 25199.5n 0.6662 25200.0n 0.6319 25799.5n 0.6319 25800.0n 0.6206 26399.5n 0.6206 26400.0n 0.6204 26999.5n 0.6204 27000.0n 0.6302 27599.5n 0.6302 27600.0n 0.6207 28199.5n 0.6207 28200.0n 0.6758 28799.5n 0.6758 28800.0n 0.6253 29399.5n 0.6253 29400.0n 0.6597 29999.5n 0.6597 30000.0n 0.6625 30599.5n 0.6625 30600.0n 0.6761 31199.5n 0.6761 31200.0n 0.6751 31799.5n 0.6751 31800.0n 0.6269 32399.5n 0.6269 32400.0n 0.6193 32999.5n 0.6193 33000.0n 0.6312 33599.5n 0.6312 33600.0n 0.6255 34199.5n 0.6255 34200.0n 0.6682 34799.5n 0.6682 34800.0n 0.6673 35399.5n 0.6673 35400.0n 0.6312 35999.5n 0.6312)
Cwp_bh_14 wp_bh_14 0 400p
Cwn_bh_14 wn_bh_14 0 400p
Xu_bh_14 xp_bh_14 xn_bh_14 yp_bh_14 yn_bh_14 wp_bh_14 wn_bh_14 vdd gbn gprod
Vxp_wih_0_15 xp_wih_0_15 0 PWL(0.0n 0.4942 599.5n 0.4942 600.0n 0.5558 1199.5n 0.5558 1200.0n 0.4708 1799.5n 0.4708 1800.0n 0.5235 2399.5n 0.5235 2400.0n 0.5350 2999.5n 0.5350 3000.0n 0.5172 3599.5n 0.5172 3600.0n 0.4702 4199.5n 0.4702 4200.0n 0.4867 4799.5n 0.4867 4800.0n 0.4970 5399.5n 0.4970 5400.0n 0.4986 5999.5n 0.4986 6000.0n 0.4751 6599.5n 0.4751 6600.0n 0.4870 7199.5n 0.4870 7200.0n 0.5502 7799.5n 0.5502 7800.0n 0.5521 8399.5n 0.5521 8400.0n 0.4638 8999.5n 0.4638 9000.0n 0.4982 9599.5n 0.4982 9600.0n 0.5131 10199.5n 0.5131 10200.0n 0.5386 10799.5n 0.5386 10800.0n 0.4592 11399.5n 0.4592 11400.0n 0.4950 11999.5n 0.4950 12000.0n 0.4559 12599.5n 0.4559 12600.0n 0.5162 13199.5n 0.5162 13200.0n 0.5038 13799.5n 0.5038 13800.0n 0.5333 14399.5n 0.5333 14400.0n 0.4991 14999.5n 0.4991 15000.0n 0.5298 15599.5n 0.5298 15600.0n 0.4823 16199.5n 0.4823 16200.0n 0.5239 16799.5n 0.5239 16800.0n 0.4592 17399.5n 0.4592 17400.0n 0.5094 17999.5n 0.5094 18000.0n 0.4337 18599.5n 0.4337 18600.0n 0.5977 19199.5n 0.5977 19200.0n 0.5364 19799.5n 0.5364 19800.0n 0.6122 20399.5n 0.6122 20400.0n 0.4856 20999.5n 0.4856 21000.0n 0.3861 21599.5n 0.3861 21600.0n 0.6094 22199.5n 0.6094 22200.0n 0.6364 22799.5n 0.6364 22800.0n 0.4807 23399.5n 0.4807 23400.0n 0.5614 23999.5n 0.5614 24000.0n 0.5913 24599.5n 0.5913 24600.0n 0.6295 25199.5n 0.6295 25200.0n 0.4496 25799.5n 0.4496 25800.0n 0.3792 26399.5n 0.3792 26400.0n 0.4434 26999.5n 0.4434 27000.0n 0.4340 27599.5n 0.4340 27600.0n 0.4461 28199.5n 0.4461 28200.0n 0.5791 28799.5n 0.5791 28800.0n 0.4777 29399.5n 0.4777 29400.0n 0.3878 29999.5n 0.3878 30000.0n 0.3832 30599.5n 0.3832 30600.0n 0.4022 31199.5n 0.4022 31200.0n 0.4482 31799.5n 0.4482 31800.0n 0.3662 32399.5n 0.3662 32400.0n 0.3857 32999.5n 0.3857 33000.0n 0.5584 33599.5n 0.5584 33600.0n 0.5284 34199.5n 0.5284 34200.0n 0.6034 34799.5n 0.6034 34800.0n 0.3469 35399.5n 0.3469 35400.0n 0.5290 35999.5n 0.5290)
Vxn_wih_0_15 xn_wih_0_15 0 PWL(0.0n 0.5058 599.5n 0.5058 600.0n 0.4442 1199.5n 0.4442 1200.0n 0.5292 1799.5n 0.5292 1800.0n 0.4765 2399.5n 0.4765 2400.0n 0.4650 2999.5n 0.4650 3000.0n 0.4828 3599.5n 0.4828 3600.0n 0.5298 4199.5n 0.5298 4200.0n 0.5133 4799.5n 0.5133 4800.0n 0.5030 5399.5n 0.5030 5400.0n 0.5014 5999.5n 0.5014 6000.0n 0.5249 6599.5n 0.5249 6600.0n 0.5130 7199.5n 0.5130 7200.0n 0.4498 7799.5n 0.4498 7800.0n 0.4479 8399.5n 0.4479 8400.0n 0.5362 8999.5n 0.5362 9000.0n 0.5018 9599.5n 0.5018 9600.0n 0.4869 10199.5n 0.4869 10200.0n 0.4614 10799.5n 0.4614 10800.0n 0.5408 11399.5n 0.5408 11400.0n 0.5050 11999.5n 0.5050 12000.0n 0.5441 12599.5n 0.5441 12600.0n 0.4838 13199.5n 0.4838 13200.0n 0.4962 13799.5n 0.4962 13800.0n 0.4667 14399.5n 0.4667 14400.0n 0.5009 14999.5n 0.5009 15000.0n 0.4702 15599.5n 0.4702 15600.0n 0.5177 16199.5n 0.5177 16200.0n 0.4761 16799.5n 0.4761 16800.0n 0.5408 17399.5n 0.5408 17400.0n 0.4906 17999.5n 0.4906 18000.0n 0.5663 18599.5n 0.5663 18600.0n 0.4023 19199.5n 0.4023 19200.0n 0.4636 19799.5n 0.4636 19800.0n 0.3878 20399.5n 0.3878 20400.0n 0.5144 20999.5n 0.5144 21000.0n 0.6139 21599.5n 0.6139 21600.0n 0.3906 22199.5n 0.3906 22200.0n 0.3636 22799.5n 0.3636 22800.0n 0.5193 23399.5n 0.5193 23400.0n 0.4386 23999.5n 0.4386 24000.0n 0.4087 24599.5n 0.4087 24600.0n 0.3705 25199.5n 0.3705 25200.0n 0.5504 25799.5n 0.5504 25800.0n 0.6208 26399.5n 0.6208 26400.0n 0.5566 26999.5n 0.5566 27000.0n 0.5660 27599.5n 0.5660 27600.0n 0.5539 28199.5n 0.5539 28200.0n 0.4209 28799.5n 0.4209 28800.0n 0.5223 29399.5n 0.5223 29400.0n 0.6122 29999.5n 0.6122 30000.0n 0.6168 30599.5n 0.6168 30600.0n 0.5978 31199.5n 0.5978 31200.0n 0.5518 31799.5n 0.5518 31800.0n 0.6338 32399.5n 0.6338 32400.0n 0.6143 32999.5n 0.6143 33000.0n 0.4416 33599.5n 0.4416 33600.0n 0.4716 34199.5n 0.4716 34200.0n 0.3966 34799.5n 0.3966 34800.0n 0.6531 35399.5n 0.6531 35400.0n 0.4710 35999.5n 0.4710)
Vyp_wih_0_15 yp_wih_0_15 0 PWL(0.0n 0.3365 599.5n 0.3365 600.0n 0.3553 1199.5n 0.3553 1200.0n 0.3280 1799.5n 0.3280 1800.0n 0.3319 2399.5n 0.3319 2400.0n 0.3361 2999.5n 0.3361 3000.0n 0.3378 3599.5n 0.3378 3600.0n 0.3290 4199.5n 0.3290 4200.0n 0.3354 4799.5n 0.3354 4800.0n 0.3341 5399.5n 0.3341 5400.0n 0.3343 5999.5n 0.3343 6000.0n 0.3281 6599.5n 0.3281 6600.0n 0.3331 7199.5n 0.3331 7200.0n 0.3475 7799.5n 0.3475 7800.0n 0.3479 8399.5n 0.3479 8400.0n 0.3304 8999.5n 0.3304 9000.0n 0.3343 9599.5n 0.3343 9600.0n 0.3356 10199.5n 0.3356 10200.0n 0.3407 10799.5n 0.3407 10800.0n 0.3262 11399.5n 0.3262 11400.0n 0.3341 11999.5n 0.3341 12000.0n 0.3291 12599.5n 0.3291 12600.0n 0.3360 13199.5n 0.3360 13200.0n 0.3384 13799.5n 0.3384 13800.0n 0.3433 14399.5n 0.3433 14400.0n 0.3350 14999.5n 0.3350 15000.0n 0.3369 15599.5n 0.3369 15600.0n 0.3336 16199.5n 0.3336 16200.0n 0.3426 16799.5n 0.3426 16800.0n 0.3293 17399.5n 0.3293 17400.0n 0.3390 17999.5n 0.3390 18000.0n 0.3140 18599.5n 0.3140 18600.0n 0.4063 19199.5n 0.4063 19200.0n 0.3285 19799.5n 0.3285 19800.0n 0.3669 20399.5n 0.3669 20400.0n 0.3212 20999.5n 0.3212 21000.0n 0.3131 21599.5n 0.3131 21600.0n 0.3861 22199.5n 0.3861 22200.0n 0.4220 22799.5n 0.4220 22800.0n 0.3195 23399.5n 0.3195 23400.0n 0.4287 23999.5n 0.4287 24000.0n 0.3438 24599.5n 0.3438 24600.0n 0.4283 25199.5n 0.4283 25200.0n 0.3164 25799.5n 0.3164 25800.0n 0.3060 26399.5n 0.3060 26400.0n 0.3135 26999.5n 0.3135 27000.0n 0.3129 27599.5n 0.3129 27600.0n 0.3141 28199.5n 0.3141 28200.0n 0.4493 28799.5n 0.4493 28800.0n 0.3195 29399.5n 0.3195 29400.0n 0.3141 29999.5n 0.3141 30000.0n 0.3151 30599.5n 0.3151 30600.0n 0.3238 31199.5n 0.3238 31200.0n 0.3350 31799.5n 0.3350 31800.0n 0.3061 32399.5n 0.3061 32400.0n 0.3062 32999.5n 0.3062 33000.0n 0.3330 33599.5n 0.3330 33600.0n 0.3253 34199.5n 0.3253 34200.0n 0.4244 34799.5n 0.4244 34800.0n 0.3153 35399.5n 0.3153 35400.0n 0.3264 35999.5n 0.3264)
Vyn_wih_0_15 yn_wih_0_15 0 PWL(0.0n 0.6635 599.5n 0.6635 600.0n 0.6447 1199.5n 0.6447 1200.0n 0.6720 1799.5n 0.6720 1800.0n 0.6681 2399.5n 0.6681 2400.0n 0.6639 2999.5n 0.6639 3000.0n 0.6622 3599.5n 0.6622 3600.0n 0.6710 4199.5n 0.6710 4200.0n 0.6646 4799.5n 0.6646 4800.0n 0.6659 5399.5n 0.6659 5400.0n 0.6657 5999.5n 0.6657 6000.0n 0.6719 6599.5n 0.6719 6600.0n 0.6669 7199.5n 0.6669 7200.0n 0.6525 7799.5n 0.6525 7800.0n 0.6521 8399.5n 0.6521 8400.0n 0.6696 8999.5n 0.6696 9000.0n 0.6657 9599.5n 0.6657 9600.0n 0.6644 10199.5n 0.6644 10200.0n 0.6593 10799.5n 0.6593 10800.0n 0.6738 11399.5n 0.6738 11400.0n 0.6659 11999.5n 0.6659 12000.0n 0.6709 12599.5n 0.6709 12600.0n 0.6640 13199.5n 0.6640 13200.0n 0.6616 13799.5n 0.6616 13800.0n 0.6567 14399.5n 0.6567 14400.0n 0.6650 14999.5n 0.6650 15000.0n 0.6631 15599.5n 0.6631 15600.0n 0.6664 16199.5n 0.6664 16200.0n 0.6574 16799.5n 0.6574 16800.0n 0.6707 17399.5n 0.6707 17400.0n 0.6610 17999.5n 0.6610 18000.0n 0.6860 18599.5n 0.6860 18600.0n 0.5937 19199.5n 0.5937 19200.0n 0.6715 19799.5n 0.6715 19800.0n 0.6331 20399.5n 0.6331 20400.0n 0.6788 20999.5n 0.6788 21000.0n 0.6869 21599.5n 0.6869 21600.0n 0.6139 22199.5n 0.6139 22200.0n 0.5780 22799.5n 0.5780 22800.0n 0.6805 23399.5n 0.6805 23400.0n 0.5713 23999.5n 0.5713 24000.0n 0.6562 24599.5n 0.6562 24600.0n 0.5717 25199.5n 0.5717 25200.0n 0.6836 25799.5n 0.6836 25800.0n 0.6940 26399.5n 0.6940 26400.0n 0.6865 26999.5n 0.6865 27000.0n 0.6871 27599.5n 0.6871 27600.0n 0.6859 28199.5n 0.6859 28200.0n 0.5507 28799.5n 0.5507 28800.0n 0.6805 29399.5n 0.6805 29400.0n 0.6859 29999.5n 0.6859 30000.0n 0.6849 30599.5n 0.6849 30600.0n 0.6762 31199.5n 0.6762 31200.0n 0.6650 31799.5n 0.6650 31800.0n 0.6939 32399.5n 0.6939 32400.0n 0.6938 32999.5n 0.6938 33000.0n 0.6670 33599.5n 0.6670 33600.0n 0.6747 34199.5n 0.6747 34200.0n 0.5756 34799.5n 0.5756 34800.0n 0.6847 35399.5n 0.6847 35400.0n 0.6736 35999.5n 0.6736)
Cwp_wih_0_15 wp_wih_0_15 0 400p
Cwn_wih_0_15 wn_wih_0_15 0 400p
Xu_wih_0_15 xp_wih_0_15 xn_wih_0_15 yp_wih_0_15 yn_wih_0_15 wp_wih_0_15 wn_wih_0_15 vdd gbn gprod
Vxp_wih_1_15 xp_wih_1_15 0 PWL(0.0n 0.5370 599.5n 0.5370 600.0n 0.5167 1199.5n 0.5167 1200.0n 0.4793 1799.5n 0.4793 1800.0n 0.4441 2399.5n 0.4441 2400.0n 0.4555 2999.5n 0.4555 3000.0n 0.5055 3599.5n 0.5055 3600.0n 0.4939 4199.5n 0.4939 4200.0n 0.5385 4799.5n 0.5385 4800.0n 0.5024 5399.5n 0.5024 5400.0n 0.5015 5999.5n 0.5015 6000.0n 0.4700 6599.5n 0.4700 6600.0n 0.5120 7199.5n 0.5120 7200.0n 0.5006 7799.5n 0.5006 7800.0n 0.4950 8399.5n 0.4950 8400.0n 0.5309 8999.5n 0.5309 9000.0n 0.5023 9599.5n 0.5023 9600.0n 0.4893 10199.5n 0.4893 10200.0n 0.4837 10799.5n 0.4837 10800.0n 0.4823 11399.5n 0.4823 11400.0n 0.5074 11999.5n 0.5074 12000.0n 0.5364 12599.5n 0.5364 12600.0n 0.4868 13199.5n 0.4868 13200.0n 0.5380 13799.5n 0.5380 13800.0n 0.5220 14399.5n 0.5220 14400.0n 0.5095 14999.5n 0.5095 15000.0n 0.4705 15599.5n 0.4705 15600.0n 0.5289 16199.5n 0.5289 16200.0n 0.5368 16799.5n 0.5368 16800.0n 0.5287 17399.5n 0.5287 17400.0n 0.5342 17999.5n 0.5342 18000.0n 0.4253 18599.5n 0.4253 18600.0n 0.5119 19199.5n 0.5119 19200.0n 0.4104 19799.5n 0.4104 19800.0n 0.4314 20399.5n 0.4314 20400.0n 0.4005 20999.5n 0.4005 21000.0n 0.4696 21599.5n 0.4696 21600.0n 0.4531 22199.5n 0.4531 22200.0n 0.5039 22799.5n 0.5039 22800.0n 0.3608 23399.5n 0.3608 23400.0n 0.6273 23999.5n 0.6273 24000.0n 0.3928 24599.5n 0.3928 24600.0n 0.5253 25199.5n 0.5253 25200.0n 0.4107 25799.5n 0.4107 25800.0n 0.3947 26399.5n 0.3947 26400.0n 0.3716 26999.5n 0.3716 27000.0n 0.4111 27599.5n 0.4111 27600.0n 0.3715 28199.5n 0.3715 28200.0n 0.5939 28799.5n 0.5939 28800.0n 0.3849 29399.5n 0.3849 29400.0n 0.4835 29999.5n 0.4835 30000.0n 0.5119 30599.5n 0.5119 30600.0n 0.6226 31199.5n 0.6226 31200.0n 0.6064 31799.5n 0.6064 31800.0n 0.4115 32399.5n 0.4115 32400.0n 0.3900 32999.5n 0.3900 33000.0n 0.3958 33599.5n 0.3958 33600.0n 0.3747 34199.5n 0.3747 34200.0n 0.5423 34799.5n 0.5423 34800.0n 0.5509 35399.5n 0.5509 35400.0n 0.3990 35999.5n 0.3990)
Vxn_wih_1_15 xn_wih_1_15 0 PWL(0.0n 0.4630 599.5n 0.4630 600.0n 0.4833 1199.5n 0.4833 1200.0n 0.5207 1799.5n 0.5207 1800.0n 0.5559 2399.5n 0.5559 2400.0n 0.5445 2999.5n 0.5445 3000.0n 0.4945 3599.5n 0.4945 3600.0n 0.5061 4199.5n 0.5061 4200.0n 0.4615 4799.5n 0.4615 4800.0n 0.4976 5399.5n 0.4976 5400.0n 0.4985 5999.5n 0.4985 6000.0n 0.5300 6599.5n 0.5300 6600.0n 0.4880 7199.5n 0.4880 7200.0n 0.4994 7799.5n 0.4994 7800.0n 0.5050 8399.5n 0.5050 8400.0n 0.4691 8999.5n 0.4691 9000.0n 0.4977 9599.5n 0.4977 9600.0n 0.5107 10199.5n 0.5107 10200.0n 0.5163 10799.5n 0.5163 10800.0n 0.5177 11399.5n 0.5177 11400.0n 0.4926 11999.5n 0.4926 12000.0n 0.4636 12599.5n 0.4636 12600.0n 0.5132 13199.5n 0.5132 13200.0n 0.4620 13799.5n 0.4620 13800.0n 0.4780 14399.5n 0.4780 14400.0n 0.4905 14999.5n 0.4905 15000.0n 0.5295 15599.5n 0.5295 15600.0n 0.4711 16199.5n 0.4711 16200.0n 0.4632 16799.5n 0.4632 16800.0n 0.4713 17399.5n 0.4713 17400.0n 0.4658 17999.5n 0.4658 18000.0n 0.5747 18599.5n 0.5747 18600.0n 0.4881 19199.5n 0.4881 19200.0n 0.5896 19799.5n 0.5896 19800.0n 0.5686 20399.5n 0.5686 20400.0n 0.5995 20999.5n 0.5995 21000.0n 0.5304 21599.5n 0.5304 21600.0n 0.5469 22199.5n 0.5469 22200.0n 0.4961 22799.5n 0.4961 22800.0n 0.6392 23399.5n 0.6392 23400.0n 0.3727 23999.5n 0.3727 24000.0n 0.6072 24599.5n 0.6072 24600.0n 0.4747 25199.5n 0.4747 25200.0n 0.5893 25799.5n 0.5893 25800.0n 0.6053 26399.5n 0.6053 26400.0n 0.6284 26999.5n 0.6284 27000.0n 0.5889 27599.5n 0.5889 27600.0n 0.6285 28199.5n 0.6285 28200.0n 0.4061 28799.5n 0.4061 28800.0n 0.6151 29399.5n 0.6151 29400.0n 0.5165 29999.5n 0.5165 30000.0n 0.4881 30599.5n 0.4881 30600.0n 0.3774 31199.5n 0.3774 31200.0n 0.3936 31799.5n 0.3936 31800.0n 0.5885 32399.5n 0.5885 32400.0n 0.6100 32999.5n 0.6100 33000.0n 0.6042 33599.5n 0.6042 33600.0n 0.6253 34199.5n 0.6253 34200.0n 0.4577 34799.5n 0.4577 34800.0n 0.4491 35399.5n 0.4491 35400.0n 0.6010 35999.5n 0.6010)
Vyp_wih_1_15 yp_wih_1_15 0 PWL(0.0n 0.3365 599.5n 0.3365 600.0n 0.3553 1199.5n 0.3553 1200.0n 0.3280 1799.5n 0.3280 1800.0n 0.3319 2399.5n 0.3319 2400.0n 0.3361 2999.5n 0.3361 3000.0n 0.3378 3599.5n 0.3378 3600.0n 0.3290 4199.5n 0.3290 4200.0n 0.3354 4799.5n 0.3354 4800.0n 0.3341 5399.5n 0.3341 5400.0n 0.3343 5999.5n 0.3343 6000.0n 0.3281 6599.5n 0.3281 6600.0n 0.3331 7199.5n 0.3331 7200.0n 0.3475 7799.5n 0.3475 7800.0n 0.3479 8399.5n 0.3479 8400.0n 0.3304 8999.5n 0.3304 9000.0n 0.3343 9599.5n 0.3343 9600.0n 0.3356 10199.5n 0.3356 10200.0n 0.3407 10799.5n 0.3407 10800.0n 0.3262 11399.5n 0.3262 11400.0n 0.3341 11999.5n 0.3341 12000.0n 0.3291 12599.5n 0.3291 12600.0n 0.3360 13199.5n 0.3360 13200.0n 0.3384 13799.5n 0.3384 13800.0n 0.3433 14399.5n 0.3433 14400.0n 0.3350 14999.5n 0.3350 15000.0n 0.3369 15599.5n 0.3369 15600.0n 0.3336 16199.5n 0.3336 16200.0n 0.3426 16799.5n 0.3426 16800.0n 0.3293 17399.5n 0.3293 17400.0n 0.3390 17999.5n 0.3390 18000.0n 0.3140 18599.5n 0.3140 18600.0n 0.4063 19199.5n 0.4063 19200.0n 0.3285 19799.5n 0.3285 19800.0n 0.3669 20399.5n 0.3669 20400.0n 0.3212 20999.5n 0.3212 21000.0n 0.3131 21599.5n 0.3131 21600.0n 0.3861 22199.5n 0.3861 22200.0n 0.4220 22799.5n 0.4220 22800.0n 0.3195 23399.5n 0.3195 23400.0n 0.4287 23999.5n 0.4287 24000.0n 0.3438 24599.5n 0.3438 24600.0n 0.4283 25199.5n 0.4283 25200.0n 0.3164 25799.5n 0.3164 25800.0n 0.3060 26399.5n 0.3060 26400.0n 0.3135 26999.5n 0.3135 27000.0n 0.3129 27599.5n 0.3129 27600.0n 0.3141 28199.5n 0.3141 28200.0n 0.4493 28799.5n 0.4493 28800.0n 0.3195 29399.5n 0.3195 29400.0n 0.3141 29999.5n 0.3141 30000.0n 0.3151 30599.5n 0.3151 30600.0n 0.3238 31199.5n 0.3238 31200.0n 0.3350 31799.5n 0.3350 31800.0n 0.3061 32399.5n 0.3061 32400.0n 0.3062 32999.5n 0.3062 33000.0n 0.3330 33599.5n 0.3330 33600.0n 0.3253 34199.5n 0.3253 34200.0n 0.4244 34799.5n 0.4244 34800.0n 0.3153 35399.5n 0.3153 35400.0n 0.3264 35999.5n 0.3264)
Vyn_wih_1_15 yn_wih_1_15 0 PWL(0.0n 0.6635 599.5n 0.6635 600.0n 0.6447 1199.5n 0.6447 1200.0n 0.6720 1799.5n 0.6720 1800.0n 0.6681 2399.5n 0.6681 2400.0n 0.6639 2999.5n 0.6639 3000.0n 0.6622 3599.5n 0.6622 3600.0n 0.6710 4199.5n 0.6710 4200.0n 0.6646 4799.5n 0.6646 4800.0n 0.6659 5399.5n 0.6659 5400.0n 0.6657 5999.5n 0.6657 6000.0n 0.6719 6599.5n 0.6719 6600.0n 0.6669 7199.5n 0.6669 7200.0n 0.6525 7799.5n 0.6525 7800.0n 0.6521 8399.5n 0.6521 8400.0n 0.6696 8999.5n 0.6696 9000.0n 0.6657 9599.5n 0.6657 9600.0n 0.6644 10199.5n 0.6644 10200.0n 0.6593 10799.5n 0.6593 10800.0n 0.6738 11399.5n 0.6738 11400.0n 0.6659 11999.5n 0.6659 12000.0n 0.6709 12599.5n 0.6709 12600.0n 0.6640 13199.5n 0.6640 13200.0n 0.6616 13799.5n 0.6616 13800.0n 0.6567 14399.5n 0.6567 14400.0n 0.6650 14999.5n 0.6650 15000.0n 0.6631 15599.5n 0.6631 15600.0n 0.6664 16199.5n 0.6664 16200.0n 0.6574 16799.5n 0.6574 16800.0n 0.6707 17399.5n 0.6707 17400.0n 0.6610 17999.5n 0.6610 18000.0n 0.6860 18599.5n 0.6860 18600.0n 0.5937 19199.5n 0.5937 19200.0n 0.6715 19799.5n 0.6715 19800.0n 0.6331 20399.5n 0.6331 20400.0n 0.6788 20999.5n 0.6788 21000.0n 0.6869 21599.5n 0.6869 21600.0n 0.6139 22199.5n 0.6139 22200.0n 0.5780 22799.5n 0.5780 22800.0n 0.6805 23399.5n 0.6805 23400.0n 0.5713 23999.5n 0.5713 24000.0n 0.6562 24599.5n 0.6562 24600.0n 0.5717 25199.5n 0.5717 25200.0n 0.6836 25799.5n 0.6836 25800.0n 0.6940 26399.5n 0.6940 26400.0n 0.6865 26999.5n 0.6865 27000.0n 0.6871 27599.5n 0.6871 27600.0n 0.6859 28199.5n 0.6859 28200.0n 0.5507 28799.5n 0.5507 28800.0n 0.6805 29399.5n 0.6805 29400.0n 0.6859 29999.5n 0.6859 30000.0n 0.6849 30599.5n 0.6849 30600.0n 0.6762 31199.5n 0.6762 31200.0n 0.6650 31799.5n 0.6650 31800.0n 0.6939 32399.5n 0.6939 32400.0n 0.6938 32999.5n 0.6938 33000.0n 0.6670 33599.5n 0.6670 33600.0n 0.6747 34199.5n 0.6747 34200.0n 0.5756 34799.5n 0.5756 34800.0n 0.6847 35399.5n 0.6847 35400.0n 0.6736 35999.5n 0.6736)
Cwp_wih_1_15 wp_wih_1_15 0 400p
Cwn_wih_1_15 wn_wih_1_15 0 400p
Xu_wih_1_15 xp_wih_1_15 xn_wih_1_15 yp_wih_1_15 yn_wih_1_15 wp_wih_1_15 wn_wih_1_15 vdd gbn gprod
Vxp_who_15_0 xp_who_15_0 0 PWL(0.0n 0.3365 599.5n 0.3365 600.0n 0.3553 1199.5n 0.3553 1200.0n 0.3280 1799.5n 0.3280 1800.0n 0.3319 2399.5n 0.3319 2400.0n 0.3361 2999.5n 0.3361 3000.0n 0.3378 3599.5n 0.3378 3600.0n 0.3290 4199.5n 0.3290 4200.0n 0.3354 4799.5n 0.3354 4800.0n 0.3341 5399.5n 0.3341 5400.0n 0.3343 5999.5n 0.3343 6000.0n 0.3281 6599.5n 0.3281 6600.0n 0.3331 7199.5n 0.3331 7200.0n 0.3475 7799.5n 0.3475 7800.0n 0.3479 8399.5n 0.3479 8400.0n 0.3304 8999.5n 0.3304 9000.0n 0.3343 9599.5n 0.3343 9600.0n 0.3356 10199.5n 0.3356 10200.0n 0.3407 10799.5n 0.3407 10800.0n 0.3262 11399.5n 0.3262 11400.0n 0.3341 11999.5n 0.3341 12000.0n 0.3291 12599.5n 0.3291 12600.0n 0.3360 13199.5n 0.3360 13200.0n 0.3384 13799.5n 0.3384 13800.0n 0.3433 14399.5n 0.3433 14400.0n 0.3350 14999.5n 0.3350 15000.0n 0.3369 15599.5n 0.3369 15600.0n 0.3336 16199.5n 0.3336 16200.0n 0.3426 16799.5n 0.3426 16800.0n 0.3293 17399.5n 0.3293 17400.0n 0.3390 17999.5n 0.3390 18000.0n 0.3140 18599.5n 0.3140 18600.0n 0.4063 19199.5n 0.4063 19200.0n 0.3285 19799.5n 0.3285 19800.0n 0.3669 20399.5n 0.3669 20400.0n 0.3212 20999.5n 0.3212 21000.0n 0.3131 21599.5n 0.3131 21600.0n 0.3861 22199.5n 0.3861 22200.0n 0.4220 22799.5n 0.4220 22800.0n 0.3195 23399.5n 0.3195 23400.0n 0.4287 23999.5n 0.4287 24000.0n 0.3438 24599.5n 0.3438 24600.0n 0.4283 25199.5n 0.4283 25200.0n 0.3164 25799.5n 0.3164 25800.0n 0.3060 26399.5n 0.3060 26400.0n 0.3135 26999.5n 0.3135 27000.0n 0.3129 27599.5n 0.3129 27600.0n 0.3141 28199.5n 0.3141 28200.0n 0.4493 28799.5n 0.4493 28800.0n 0.3195 29399.5n 0.3195 29400.0n 0.3141 29999.5n 0.3141 30000.0n 0.3151 30599.5n 0.3151 30600.0n 0.3238 31199.5n 0.3238 31200.0n 0.3350 31799.5n 0.3350 31800.0n 0.3061 32399.5n 0.3061 32400.0n 0.3062 32999.5n 0.3062 33000.0n 0.3330 33599.5n 0.3330 33600.0n 0.3253 34199.5n 0.3253 34200.0n 0.4244 34799.5n 0.4244 34800.0n 0.3153 35399.5n 0.3153 35400.0n 0.3264 35999.5n 0.3264)
Vxn_who_15_0 xn_who_15_0 0 PWL(0.0n 0.6635 599.5n 0.6635 600.0n 0.6447 1199.5n 0.6447 1200.0n 0.6720 1799.5n 0.6720 1800.0n 0.6681 2399.5n 0.6681 2400.0n 0.6639 2999.5n 0.6639 3000.0n 0.6622 3599.5n 0.6622 3600.0n 0.6710 4199.5n 0.6710 4200.0n 0.6646 4799.5n 0.6646 4800.0n 0.6659 5399.5n 0.6659 5400.0n 0.6657 5999.5n 0.6657 6000.0n 0.6719 6599.5n 0.6719 6600.0n 0.6669 7199.5n 0.6669 7200.0n 0.6525 7799.5n 0.6525 7800.0n 0.6521 8399.5n 0.6521 8400.0n 0.6696 8999.5n 0.6696 9000.0n 0.6657 9599.5n 0.6657 9600.0n 0.6644 10199.5n 0.6644 10200.0n 0.6593 10799.5n 0.6593 10800.0n 0.6738 11399.5n 0.6738 11400.0n 0.6659 11999.5n 0.6659 12000.0n 0.6709 12599.5n 0.6709 12600.0n 0.6640 13199.5n 0.6640 13200.0n 0.6616 13799.5n 0.6616 13800.0n 0.6567 14399.5n 0.6567 14400.0n 0.6650 14999.5n 0.6650 15000.0n 0.6631 15599.5n 0.6631 15600.0n 0.6664 16199.5n 0.6664 16200.0n 0.6574 16799.5n 0.6574 16800.0n 0.6707 17399.5n 0.6707 17400.0n 0.6610 17999.5n 0.6610 18000.0n 0.6860 18599.5n 0.6860 18600.0n 0.5937 19199.5n 0.5937 19200.0n 0.6715 19799.5n 0.6715 19800.0n 0.6331 20399.5n 0.6331 20400.0n 0.6788 20999.5n 0.6788 21000.0n 0.6869 21599.5n 0.6869 21600.0n 0.6139 22199.5n 0.6139 22200.0n 0.5780 22799.5n 0.5780 22800.0n 0.6805 23399.5n 0.6805 23400.0n 0.5713 23999.5n 0.5713 24000.0n 0.6562 24599.5n 0.6562 24600.0n 0.5717 25199.5n 0.5717 25200.0n 0.6836 25799.5n 0.6836 25800.0n 0.6940 26399.5n 0.6940 26400.0n 0.6865 26999.5n 0.6865 27000.0n 0.6871 27599.5n 0.6871 27600.0n 0.6859 28199.5n 0.6859 28200.0n 0.5507 28799.5n 0.5507 28800.0n 0.6805 29399.5n 0.6805 29400.0n 0.6859 29999.5n 0.6859 30000.0n 0.6849 30599.5n 0.6849 30600.0n 0.6762 31199.5n 0.6762 31200.0n 0.6650 31799.5n 0.6650 31800.0n 0.6939 32399.5n 0.6939 32400.0n 0.6938 32999.5n 0.6938 33000.0n 0.6670 33599.5n 0.6670 33600.0n 0.6747 34199.5n 0.6747 34200.0n 0.5756 34799.5n 0.5756 34800.0n 0.6847 35399.5n 0.6847 35400.0n 0.6736 35999.5n 0.6736)
Vyp_who_15_0 yp_who_15_0 0 PWL(0.0n 0.5031 599.5n 0.5031 600.0n 0.5023 1199.5n 0.5023 1200.0n 0.5052 1799.5n 0.5052 1800.0n 0.5048 2399.5n 0.5048 2400.0n 0.5043 2999.5n 0.5043 3000.0n 0.5034 3599.5n 0.5034 3600.0n 0.5048 4199.5n 0.5048 4200.0n 0.5031 4799.5n 0.5031 4800.0n 0.5040 5399.5n 0.5040 5400.0n 0.5040 5999.5n 0.5040 6000.0n 0.5054 6599.5n 0.5054 6600.0n 0.5040 7199.5n 0.5040 7200.0n 0.5027 7799.5n 0.5027 7800.0n 0.5027 8399.5n 0.5027 8400.0n 0.5038 8999.5n 0.5038 9000.0n 0.5040 9599.5n 0.5040 9600.0n 0.5039 10199.5n 0.5039 10200.0n 0.5033 10799.5n 0.5033 10800.0n 0.5056 11399.5n 0.5056 11400.0n 0.5040 11999.5n 0.5040 12000.0n 0.5036 12599.5n 0.5036 12600.0n 0.5039 13199.5n 0.5039 13200.0n 0.5029 13799.5n 0.5029 13800.0n 0.5025 14399.5n 0.5025 14400.0n 0.5038 14999.5n 0.5038 15000.0n 0.5041 15599.5n 0.5041 15600.0n 0.5036 16199.5n 0.5036 16200.0n 0.5025 16799.5n 0.5025 16800.0n 0.5040 17399.5n 0.5040 17400.0n 0.5029 17999.5n 0.5029 18000.0n 0.5057 18599.5n 0.5057 18600.0n 0.5010 19199.5n 0.5010 19200.0n 0.5041 19799.5n 0.5041 19800.0n 0.5021 20399.5n 0.5021 20400.0n 0.5044 20999.5n 0.5044 21000.0n 0.5056 21599.5n 0.5056 21600.0n 0.5016 22199.5n 0.5016 22200.0n 0.5006 22799.5n 0.5006 22800.0n 0.5041 23399.5n 0.5041 23400.0n 0.5027 23999.5n 0.5027 24000.0n 0.5029 24599.5n 0.5029 24600.0n 0.5006 25199.5n 0.5006 25200.0n 0.5047 25799.5n 0.5047 25800.0n 0.5046 26399.5n 0.5046 26400.0n 0.5039 26999.5n 0.5039 27000.0n 0.5049 27599.5n 0.5049 27600.0n 0.5039 28199.5n 0.5039 28200.0n 0.5017 28799.5n 0.5017 28800.0n 0.5042 29399.5n 0.5042 29400.0n 0.5056 29999.5n 0.5056 30000.0n 0.5051 30599.5n 0.5051 30600.0n 0.5039 31199.5n 0.5039 31200.0n 0.5033 31799.5n 0.5033 31800.0n 0.5049 32399.5n 0.5049 32400.0n 0.5045 32999.5n 0.5045 33000.0n 0.5036 33599.5n 0.5036 33600.0n 0.5042 34199.5n 0.5042 34200.0n 0.5012 34799.5n 0.5012 34800.0n 0.5036 35399.5n 0.5036 35400.0n 0.5042 35999.5n 0.5042)
Vyn_who_15_0 yn_who_15_0 0 PWL(0.0n 0.4969 599.5n 0.4969 600.0n 0.4977 1199.5n 0.4977 1200.0n 0.4948 1799.5n 0.4948 1800.0n 0.4952 2399.5n 0.4952 2400.0n 0.4957 2999.5n 0.4957 3000.0n 0.4966 3599.5n 0.4966 3600.0n 0.4952 4199.5n 0.4952 4200.0n 0.4969 4799.5n 0.4969 4800.0n 0.4960 5399.5n 0.4960 5400.0n 0.4960 5999.5n 0.4960 6000.0n 0.4946 6599.5n 0.4946 6600.0n 0.4960 7199.5n 0.4960 7200.0n 0.4973 7799.5n 0.4973 7800.0n 0.4973 8399.5n 0.4973 8400.0n 0.4962 8999.5n 0.4962 9000.0n 0.4960 9599.5n 0.4960 9600.0n 0.4961 10199.5n 0.4961 10200.0n 0.4967 10799.5n 0.4967 10800.0n 0.4944 11399.5n 0.4944 11400.0n 0.4960 11999.5n 0.4960 12000.0n 0.4964 12599.5n 0.4964 12600.0n 0.4961 13199.5n 0.4961 13200.0n 0.4971 13799.5n 0.4971 13800.0n 0.4975 14399.5n 0.4975 14400.0n 0.4962 14999.5n 0.4962 15000.0n 0.4959 15599.5n 0.4959 15600.0n 0.4964 16199.5n 0.4964 16200.0n 0.4975 16799.5n 0.4975 16800.0n 0.4960 17399.5n 0.4960 17400.0n 0.4971 17999.5n 0.4971 18000.0n 0.4943 18599.5n 0.4943 18600.0n 0.4990 19199.5n 0.4990 19200.0n 0.4959 19799.5n 0.4959 19800.0n 0.4979 20399.5n 0.4979 20400.0n 0.4956 20999.5n 0.4956 21000.0n 0.4944 21599.5n 0.4944 21600.0n 0.4984 22199.5n 0.4984 22200.0n 0.4994 22799.5n 0.4994 22800.0n 0.4959 23399.5n 0.4959 23400.0n 0.4973 23999.5n 0.4973 24000.0n 0.4971 24599.5n 0.4971 24600.0n 0.4994 25199.5n 0.4994 25200.0n 0.4953 25799.5n 0.4953 25800.0n 0.4954 26399.5n 0.4954 26400.0n 0.4961 26999.5n 0.4961 27000.0n 0.4951 27599.5n 0.4951 27600.0n 0.4961 28199.5n 0.4961 28200.0n 0.4983 28799.5n 0.4983 28800.0n 0.4958 29399.5n 0.4958 29400.0n 0.4944 29999.5n 0.4944 30000.0n 0.4949 30599.5n 0.4949 30600.0n 0.4961 31199.5n 0.4961 31200.0n 0.4967 31799.5n 0.4967 31800.0n 0.4951 32399.5n 0.4951 32400.0n 0.4955 32999.5n 0.4955 33000.0n 0.4964 33599.5n 0.4964 33600.0n 0.4958 34199.5n 0.4958 34200.0n 0.4988 34799.5n 0.4988 34800.0n 0.4964 35399.5n 0.4964 35400.0n 0.4958 35999.5n 0.4958)
Cwp_who_15_0 wp_who_15_0 0 400p
Cwn_who_15_0 wn_who_15_0 0 400p
Xu_who_15_0 xp_who_15_0 xn_who_15_0 yp_who_15_0 yn_who_15_0 wp_who_15_0 wn_who_15_0 vdd gbn gprod
Vxp_who_15_1 xp_who_15_1 0 PWL(0.0n 0.3365 599.5n 0.3365 600.0n 0.3553 1199.5n 0.3553 1200.0n 0.3280 1799.5n 0.3280 1800.0n 0.3319 2399.5n 0.3319 2400.0n 0.3361 2999.5n 0.3361 3000.0n 0.3378 3599.5n 0.3378 3600.0n 0.3290 4199.5n 0.3290 4200.0n 0.3354 4799.5n 0.3354 4800.0n 0.3341 5399.5n 0.3341 5400.0n 0.3343 5999.5n 0.3343 6000.0n 0.3281 6599.5n 0.3281 6600.0n 0.3331 7199.5n 0.3331 7200.0n 0.3475 7799.5n 0.3475 7800.0n 0.3479 8399.5n 0.3479 8400.0n 0.3304 8999.5n 0.3304 9000.0n 0.3343 9599.5n 0.3343 9600.0n 0.3356 10199.5n 0.3356 10200.0n 0.3407 10799.5n 0.3407 10800.0n 0.3262 11399.5n 0.3262 11400.0n 0.3341 11999.5n 0.3341 12000.0n 0.3291 12599.5n 0.3291 12600.0n 0.3360 13199.5n 0.3360 13200.0n 0.3384 13799.5n 0.3384 13800.0n 0.3433 14399.5n 0.3433 14400.0n 0.3350 14999.5n 0.3350 15000.0n 0.3369 15599.5n 0.3369 15600.0n 0.3336 16199.5n 0.3336 16200.0n 0.3426 16799.5n 0.3426 16800.0n 0.3293 17399.5n 0.3293 17400.0n 0.3390 17999.5n 0.3390 18000.0n 0.3140 18599.5n 0.3140 18600.0n 0.4063 19199.5n 0.4063 19200.0n 0.3285 19799.5n 0.3285 19800.0n 0.3669 20399.5n 0.3669 20400.0n 0.3212 20999.5n 0.3212 21000.0n 0.3131 21599.5n 0.3131 21600.0n 0.3861 22199.5n 0.3861 22200.0n 0.4220 22799.5n 0.4220 22800.0n 0.3195 23399.5n 0.3195 23400.0n 0.4287 23999.5n 0.4287 24000.0n 0.3438 24599.5n 0.3438 24600.0n 0.4283 25199.5n 0.4283 25200.0n 0.3164 25799.5n 0.3164 25800.0n 0.3060 26399.5n 0.3060 26400.0n 0.3135 26999.5n 0.3135 27000.0n 0.3129 27599.5n 0.3129 27600.0n 0.3141 28199.5n 0.3141 28200.0n 0.4493 28799.5n 0.4493 28800.0n 0.3195 29399.5n 0.3195 29400.0n 0.3141 29999.5n 0.3141 30000.0n 0.3151 30599.5n 0.3151 30600.0n 0.3238 31199.5n 0.3238 31200.0n 0.3350 31799.5n 0.3350 31800.0n 0.3061 32399.5n 0.3061 32400.0n 0.3062 32999.5n 0.3062 33000.0n 0.3330 33599.5n 0.3330 33600.0n 0.3253 34199.5n 0.3253 34200.0n 0.4244 34799.5n 0.4244 34800.0n 0.3153 35399.5n 0.3153 35400.0n 0.3264 35999.5n 0.3264)
Vxn_who_15_1 xn_who_15_1 0 PWL(0.0n 0.6635 599.5n 0.6635 600.0n 0.6447 1199.5n 0.6447 1200.0n 0.6720 1799.5n 0.6720 1800.0n 0.6681 2399.5n 0.6681 2400.0n 0.6639 2999.5n 0.6639 3000.0n 0.6622 3599.5n 0.6622 3600.0n 0.6710 4199.5n 0.6710 4200.0n 0.6646 4799.5n 0.6646 4800.0n 0.6659 5399.5n 0.6659 5400.0n 0.6657 5999.5n 0.6657 6000.0n 0.6719 6599.5n 0.6719 6600.0n 0.6669 7199.5n 0.6669 7200.0n 0.6525 7799.5n 0.6525 7800.0n 0.6521 8399.5n 0.6521 8400.0n 0.6696 8999.5n 0.6696 9000.0n 0.6657 9599.5n 0.6657 9600.0n 0.6644 10199.5n 0.6644 10200.0n 0.6593 10799.5n 0.6593 10800.0n 0.6738 11399.5n 0.6738 11400.0n 0.6659 11999.5n 0.6659 12000.0n 0.6709 12599.5n 0.6709 12600.0n 0.6640 13199.5n 0.6640 13200.0n 0.6616 13799.5n 0.6616 13800.0n 0.6567 14399.5n 0.6567 14400.0n 0.6650 14999.5n 0.6650 15000.0n 0.6631 15599.5n 0.6631 15600.0n 0.6664 16199.5n 0.6664 16200.0n 0.6574 16799.5n 0.6574 16800.0n 0.6707 17399.5n 0.6707 17400.0n 0.6610 17999.5n 0.6610 18000.0n 0.6860 18599.5n 0.6860 18600.0n 0.5937 19199.5n 0.5937 19200.0n 0.6715 19799.5n 0.6715 19800.0n 0.6331 20399.5n 0.6331 20400.0n 0.6788 20999.5n 0.6788 21000.0n 0.6869 21599.5n 0.6869 21600.0n 0.6139 22199.5n 0.6139 22200.0n 0.5780 22799.5n 0.5780 22800.0n 0.6805 23399.5n 0.6805 23400.0n 0.5713 23999.5n 0.5713 24000.0n 0.6562 24599.5n 0.6562 24600.0n 0.5717 25199.5n 0.5717 25200.0n 0.6836 25799.5n 0.6836 25800.0n 0.6940 26399.5n 0.6940 26400.0n 0.6865 26999.5n 0.6865 27000.0n 0.6871 27599.5n 0.6871 27600.0n 0.6859 28199.5n 0.6859 28200.0n 0.5507 28799.5n 0.5507 28800.0n 0.6805 29399.5n 0.6805 29400.0n 0.6859 29999.5n 0.6859 30000.0n 0.6849 30599.5n 0.6849 30600.0n 0.6762 31199.5n 0.6762 31200.0n 0.6650 31799.5n 0.6650 31800.0n 0.6939 32399.5n 0.6939 32400.0n 0.6938 32999.5n 0.6938 33000.0n 0.6670 33599.5n 0.6670 33600.0n 0.6747 34199.5n 0.6747 34200.0n 0.5756 34799.5n 0.5756 34800.0n 0.6847 35399.5n 0.6847 35400.0n 0.6736 35999.5n 0.6736)
Vyp_who_15_1 yp_who_15_1 0 PWL(0.0n 0.5071 599.5n 0.5071 600.0n 0.5053 1199.5n 0.5053 1200.0n 0.5052 1799.5n 0.5052 1800.0n 0.5027 2399.5n 0.5027 2400.0n 0.5034 2999.5n 0.5034 3000.0n 0.5055 3599.5n 0.5055 3600.0n 0.5056 4199.5n 0.5056 4200.0n 0.5071 4799.5n 0.5071 4800.0n 0.5056 5399.5n 0.5056 5400.0n 0.5056 5999.5n 0.5056 6000.0n 0.5048 6599.5n 0.5048 6600.0n 0.5060 7199.5n 0.5060 7200.0n 0.5048 7799.5n 0.5048 7800.0n 0.5046 8399.5n 0.5046 8400.0n 0.5066 8999.5n 0.5066 9000.0n 0.5056 9599.5n 0.5056 9600.0n 0.5051 10199.5n 0.5051 10200.0n 0.5046 10799.5n 0.5046 10800.0n 0.5056 11399.5n 0.5056 11400.0n 0.5058 11999.5n 0.5058 12000.0n 0.5068 12599.5n 0.5068 12600.0n 0.5050 13199.5n 0.5050 13200.0n 0.5071 13799.5n 0.5071 13800.0n 0.5059 14399.5n 0.5059 14400.0n 0.5058 14999.5n 0.5058 15000.0n 0.5043 15599.5n 0.5043 15600.0n 0.5067 16199.5n 0.5067 16200.0n 0.5068 16799.5n 0.5068 16800.0n 0.5066 17399.5n 0.5066 17400.0n 0.5069 17999.5n 0.5069 18000.0n 0.5061 18599.5n 0.5061 18600.0n 0.5034 19199.5n 0.5034 19200.0n 0.5010 19799.5n 0.5010 19800.0n 0.4989 20399.5n 0.4989 20400.0n 0.5022 20999.5n 0.5022 21000.0n 0.5086 21599.5n 0.5086 21600.0n 0.5007 22199.5n 0.5007 22200.0n 0.5023 22799.5n 0.5023 22800.0n 0.5021 23399.5n 0.5021 23400.0n 0.5077 23999.5n 0.5077 24000.0n 0.4979 24599.5n 0.4979 24600.0n 0.5035 25199.5n 0.5035 25200.0n 0.5041 25799.5n 0.5041 25800.0n 0.5075 26399.5n 0.5075 26400.0n 0.5041 26999.5n 0.5041 27000.0n 0.5056 27599.5n 0.5056 27600.0n 0.5039 28199.5n 0.5039 28200.0n 0.5059 28799.5n 0.5059 28800.0n 0.5023 29399.5n 0.5023 29400.0n 0.5086 29999.5n 0.5086 30000.0n 0.5084 30599.5n 0.5084 30600.0n 0.5085 31199.5n 0.5085 31200.0n 0.5088 31799.5n 0.5088 31800.0n 0.5078 32399.5n 0.5078 32400.0n 0.5074 32999.5n 0.5074 33000.0n 0.4996 33599.5n 0.4996 33600.0n 0.5010 34199.5n 0.5010 34200.0n 0.5044 34799.5n 0.5044 34800.0n 0.5084 35399.5n 0.5084 35400.0n 0.5012 35999.5n 0.5012)
Vyn_who_15_1 yn_who_15_1 0 PWL(0.0n 0.4929 599.5n 0.4929 600.0n 0.4947 1199.5n 0.4947 1200.0n 0.4948 1799.5n 0.4948 1800.0n 0.4973 2399.5n 0.4973 2400.0n 0.4966 2999.5n 0.4966 3000.0n 0.4945 3599.5n 0.4945 3600.0n 0.4944 4199.5n 0.4944 4200.0n 0.4929 4799.5n 0.4929 4800.0n 0.4944 5399.5n 0.4944 5400.0n 0.4944 5999.5n 0.4944 6000.0n 0.4952 6599.5n 0.4952 6600.0n 0.4940 7199.5n 0.4940 7200.0n 0.4952 7799.5n 0.4952 7800.0n 0.4954 8399.5n 0.4954 8400.0n 0.4934 8999.5n 0.4934 9000.0n 0.4944 9599.5n 0.4944 9600.0n 0.4949 10199.5n 0.4949 10200.0n 0.4954 10799.5n 0.4954 10800.0n 0.4944 11399.5n 0.4944 11400.0n 0.4942 11999.5n 0.4942 12000.0n 0.4932 12599.5n 0.4932 12600.0n 0.4950 13199.5n 0.4950 13200.0n 0.4929 13799.5n 0.4929 13800.0n 0.4941 14399.5n 0.4941 14400.0n 0.4942 14999.5n 0.4942 15000.0n 0.4957 15599.5n 0.4957 15600.0n 0.4933 16199.5n 0.4933 16200.0n 0.4932 16799.5n 0.4932 16800.0n 0.4934 17399.5n 0.4934 17400.0n 0.4931 17999.5n 0.4931 18000.0n 0.4939 18599.5n 0.4939 18600.0n 0.4966 19199.5n 0.4966 19200.0n 0.4990 19799.5n 0.4990 19800.0n 0.5011 20399.5n 0.5011 20400.0n 0.4978 20999.5n 0.4978 21000.0n 0.4914 21599.5n 0.4914 21600.0n 0.4993 22199.5n 0.4993 22200.0n 0.4977 22799.5n 0.4977 22800.0n 0.4979 23399.5n 0.4979 23400.0n 0.4923 23999.5n 0.4923 24000.0n 0.5021 24599.5n 0.5021 24600.0n 0.4965 25199.5n 0.4965 25200.0n 0.4959 25799.5n 0.4959 25800.0n 0.4925 26399.5n 0.4925 26400.0n 0.4959 26999.5n 0.4959 27000.0n 0.4944 27599.5n 0.4944 27600.0n 0.4961 28199.5n 0.4961 28200.0n 0.4941 28799.5n 0.4941 28800.0n 0.4977 29399.5n 0.4977 29400.0n 0.4914 29999.5n 0.4914 30000.0n 0.4916 30599.5n 0.4916 30600.0n 0.4915 31199.5n 0.4915 31200.0n 0.4912 31799.5n 0.4912 31800.0n 0.4922 32399.5n 0.4922 32400.0n 0.4926 32999.5n 0.4926 33000.0n 0.5004 33599.5n 0.5004 33600.0n 0.4990 34199.5n 0.4990 34200.0n 0.4956 34799.5n 0.4956 34800.0n 0.4916 35399.5n 0.4916 35400.0n 0.4988 35999.5n 0.4988)
Cwp_who_15_1 wp_who_15_1 0 400p
Cwn_who_15_1 wn_who_15_1 0 400p
Xu_who_15_1 xp_who_15_1 xn_who_15_1 yp_who_15_1 yn_who_15_1 wp_who_15_1 wn_who_15_1 vdd gbn gprod
Vxp_bh_15 xp_bh_15 0 PWL(0.0n 0.7100 599.5n 0.7100 600.0n 0.7100 1199.5n 0.7100 1200.0n 0.7100 1799.5n 0.7100 1800.0n 0.7100 2399.5n 0.7100 2400.0n 0.7100 2999.5n 0.7100 3000.0n 0.7100 3599.5n 0.7100 3600.0n 0.7100 4199.5n 0.7100 4200.0n 0.7100 4799.5n 0.7100 4800.0n 0.7100 5399.5n 0.7100 5400.0n 0.7100 5999.5n 0.7100 6000.0n 0.7100 6599.5n 0.7100 6600.0n 0.7100 7199.5n 0.7100 7200.0n 0.7100 7799.5n 0.7100 7800.0n 0.7100 8399.5n 0.7100 8400.0n 0.7100 8999.5n 0.7100 9000.0n 0.7100 9599.5n 0.7100 9600.0n 0.7100 10199.5n 0.7100 10200.0n 0.7100 10799.5n 0.7100 10800.0n 0.7100 11399.5n 0.7100 11400.0n 0.7100 11999.5n 0.7100 12000.0n 0.7100 12599.5n 0.7100 12600.0n 0.7100 13199.5n 0.7100 13200.0n 0.7100 13799.5n 0.7100 13800.0n 0.7100 14399.5n 0.7100 14400.0n 0.7100 14999.5n 0.7100 15000.0n 0.7100 15599.5n 0.7100 15600.0n 0.7100 16199.5n 0.7100 16200.0n 0.7100 16799.5n 0.7100 16800.0n 0.7100 17399.5n 0.7100 17400.0n 0.7100 17999.5n 0.7100 18000.0n 0.7100 18599.5n 0.7100 18600.0n 0.7100 19199.5n 0.7100 19200.0n 0.7100 19799.5n 0.7100 19800.0n 0.7100 20399.5n 0.7100 20400.0n 0.7100 20999.5n 0.7100 21000.0n 0.7100 21599.5n 0.7100 21600.0n 0.7100 22199.5n 0.7100 22200.0n 0.7100 22799.5n 0.7100 22800.0n 0.7100 23399.5n 0.7100 23400.0n 0.7100 23999.5n 0.7100 24000.0n 0.7100 24599.5n 0.7100 24600.0n 0.7100 25199.5n 0.7100 25200.0n 0.7100 25799.5n 0.7100 25800.0n 0.7100 26399.5n 0.7100 26400.0n 0.7100 26999.5n 0.7100 27000.0n 0.7100 27599.5n 0.7100 27600.0n 0.7100 28199.5n 0.7100 28200.0n 0.7100 28799.5n 0.7100 28800.0n 0.7100 29399.5n 0.7100 29400.0n 0.7100 29999.5n 0.7100 30000.0n 0.7100 30599.5n 0.7100 30600.0n 0.7100 31199.5n 0.7100 31200.0n 0.7100 31799.5n 0.7100 31800.0n 0.7100 32399.5n 0.7100 32400.0n 0.7100 32999.5n 0.7100 33000.0n 0.7100 33599.5n 0.7100 33600.0n 0.7100 34199.5n 0.7100 34200.0n 0.7100 34799.5n 0.7100 34800.0n 0.7100 35399.5n 0.7100 35400.0n 0.7100 35999.5n 0.7100)
Vxn_bh_15 xn_bh_15 0 PWL(0.0n 0.2900 599.5n 0.2900 600.0n 0.2900 1199.5n 0.2900 1200.0n 0.2900 1799.5n 0.2900 1800.0n 0.2900 2399.5n 0.2900 2400.0n 0.2900 2999.5n 0.2900 3000.0n 0.2900 3599.5n 0.2900 3600.0n 0.2900 4199.5n 0.2900 4200.0n 0.2900 4799.5n 0.2900 4800.0n 0.2900 5399.5n 0.2900 5400.0n 0.2900 5999.5n 0.2900 6000.0n 0.2900 6599.5n 0.2900 6600.0n 0.2900 7199.5n 0.2900 7200.0n 0.2900 7799.5n 0.2900 7800.0n 0.2900 8399.5n 0.2900 8400.0n 0.2900 8999.5n 0.2900 9000.0n 0.2900 9599.5n 0.2900 9600.0n 0.2900 10199.5n 0.2900 10200.0n 0.2900 10799.5n 0.2900 10800.0n 0.2900 11399.5n 0.2900 11400.0n 0.2900 11999.5n 0.2900 12000.0n 0.2900 12599.5n 0.2900 12600.0n 0.2900 13199.5n 0.2900 13200.0n 0.2900 13799.5n 0.2900 13800.0n 0.2900 14399.5n 0.2900 14400.0n 0.2900 14999.5n 0.2900 15000.0n 0.2900 15599.5n 0.2900 15600.0n 0.2900 16199.5n 0.2900 16200.0n 0.2900 16799.5n 0.2900 16800.0n 0.2900 17399.5n 0.2900 17400.0n 0.2900 17999.5n 0.2900 18000.0n 0.2900 18599.5n 0.2900 18600.0n 0.2900 19199.5n 0.2900 19200.0n 0.2900 19799.5n 0.2900 19800.0n 0.2900 20399.5n 0.2900 20400.0n 0.2900 20999.5n 0.2900 21000.0n 0.2900 21599.5n 0.2900 21600.0n 0.2900 22199.5n 0.2900 22200.0n 0.2900 22799.5n 0.2900 22800.0n 0.2900 23399.5n 0.2900 23400.0n 0.2900 23999.5n 0.2900 24000.0n 0.2900 24599.5n 0.2900 24600.0n 0.2900 25199.5n 0.2900 25200.0n 0.2900 25799.5n 0.2900 25800.0n 0.2900 26399.5n 0.2900 26400.0n 0.2900 26999.5n 0.2900 27000.0n 0.2900 27599.5n 0.2900 27600.0n 0.2900 28199.5n 0.2900 28200.0n 0.2900 28799.5n 0.2900 28800.0n 0.2900 29399.5n 0.2900 29400.0n 0.2900 29999.5n 0.2900 30000.0n 0.2900 30599.5n 0.2900 30600.0n 0.2900 31199.5n 0.2900 31200.0n 0.2900 31799.5n 0.2900 31800.0n 0.2900 32399.5n 0.2900 32400.0n 0.2900 32999.5n 0.2900 33000.0n 0.2900 33599.5n 0.2900 33600.0n 0.2900 34199.5n 0.2900 34200.0n 0.2900 34799.5n 0.2900 34800.0n 0.2900 35399.5n 0.2900 35400.0n 0.2900 35999.5n 0.2900)
Vyp_bh_15 yp_bh_15 0 PWL(0.0n 0.3365 599.5n 0.3365 600.0n 0.3553 1199.5n 0.3553 1200.0n 0.3280 1799.5n 0.3280 1800.0n 0.3319 2399.5n 0.3319 2400.0n 0.3361 2999.5n 0.3361 3000.0n 0.3378 3599.5n 0.3378 3600.0n 0.3290 4199.5n 0.3290 4200.0n 0.3354 4799.5n 0.3354 4800.0n 0.3341 5399.5n 0.3341 5400.0n 0.3343 5999.5n 0.3343 6000.0n 0.3281 6599.5n 0.3281 6600.0n 0.3331 7199.5n 0.3331 7200.0n 0.3475 7799.5n 0.3475 7800.0n 0.3479 8399.5n 0.3479 8400.0n 0.3304 8999.5n 0.3304 9000.0n 0.3343 9599.5n 0.3343 9600.0n 0.3356 10199.5n 0.3356 10200.0n 0.3407 10799.5n 0.3407 10800.0n 0.3262 11399.5n 0.3262 11400.0n 0.3341 11999.5n 0.3341 12000.0n 0.3291 12599.5n 0.3291 12600.0n 0.3360 13199.5n 0.3360 13200.0n 0.3384 13799.5n 0.3384 13800.0n 0.3433 14399.5n 0.3433 14400.0n 0.3350 14999.5n 0.3350 15000.0n 0.3369 15599.5n 0.3369 15600.0n 0.3336 16199.5n 0.3336 16200.0n 0.3426 16799.5n 0.3426 16800.0n 0.3293 17399.5n 0.3293 17400.0n 0.3390 17999.5n 0.3390 18000.0n 0.3140 18599.5n 0.3140 18600.0n 0.4063 19199.5n 0.4063 19200.0n 0.3285 19799.5n 0.3285 19800.0n 0.3669 20399.5n 0.3669 20400.0n 0.3212 20999.5n 0.3212 21000.0n 0.3131 21599.5n 0.3131 21600.0n 0.3861 22199.5n 0.3861 22200.0n 0.4220 22799.5n 0.4220 22800.0n 0.3195 23399.5n 0.3195 23400.0n 0.4287 23999.5n 0.4287 24000.0n 0.3438 24599.5n 0.3438 24600.0n 0.4283 25199.5n 0.4283 25200.0n 0.3164 25799.5n 0.3164 25800.0n 0.3060 26399.5n 0.3060 26400.0n 0.3135 26999.5n 0.3135 27000.0n 0.3129 27599.5n 0.3129 27600.0n 0.3141 28199.5n 0.3141 28200.0n 0.4493 28799.5n 0.4493 28800.0n 0.3195 29399.5n 0.3195 29400.0n 0.3141 29999.5n 0.3141 30000.0n 0.3151 30599.5n 0.3151 30600.0n 0.3238 31199.5n 0.3238 31200.0n 0.3350 31799.5n 0.3350 31800.0n 0.3061 32399.5n 0.3061 32400.0n 0.3062 32999.5n 0.3062 33000.0n 0.3330 33599.5n 0.3330 33600.0n 0.3253 34199.5n 0.3253 34200.0n 0.4244 34799.5n 0.4244 34800.0n 0.3153 35399.5n 0.3153 35400.0n 0.3264 35999.5n 0.3264)
Vyn_bh_15 yn_bh_15 0 PWL(0.0n 0.6635 599.5n 0.6635 600.0n 0.6447 1199.5n 0.6447 1200.0n 0.6720 1799.5n 0.6720 1800.0n 0.6681 2399.5n 0.6681 2400.0n 0.6639 2999.5n 0.6639 3000.0n 0.6622 3599.5n 0.6622 3600.0n 0.6710 4199.5n 0.6710 4200.0n 0.6646 4799.5n 0.6646 4800.0n 0.6659 5399.5n 0.6659 5400.0n 0.6657 5999.5n 0.6657 6000.0n 0.6719 6599.5n 0.6719 6600.0n 0.6669 7199.5n 0.6669 7200.0n 0.6525 7799.5n 0.6525 7800.0n 0.6521 8399.5n 0.6521 8400.0n 0.6696 8999.5n 0.6696 9000.0n 0.6657 9599.5n 0.6657 9600.0n 0.6644 10199.5n 0.6644 10200.0n 0.6593 10799.5n 0.6593 10800.0n 0.6738 11399.5n 0.6738 11400.0n 0.6659 11999.5n 0.6659 12000.0n 0.6709 12599.5n 0.6709 12600.0n 0.6640 13199.5n 0.6640 13200.0n 0.6616 13799.5n 0.6616 13800.0n 0.6567 14399.5n 0.6567 14400.0n 0.6650 14999.5n 0.6650 15000.0n 0.6631 15599.5n 0.6631 15600.0n 0.6664 16199.5n 0.6664 16200.0n 0.6574 16799.5n 0.6574 16800.0n 0.6707 17399.5n 0.6707 17400.0n 0.6610 17999.5n 0.6610 18000.0n 0.6860 18599.5n 0.6860 18600.0n 0.5937 19199.5n 0.5937 19200.0n 0.6715 19799.5n 0.6715 19800.0n 0.6331 20399.5n 0.6331 20400.0n 0.6788 20999.5n 0.6788 21000.0n 0.6869 21599.5n 0.6869 21600.0n 0.6139 22199.5n 0.6139 22200.0n 0.5780 22799.5n 0.5780 22800.0n 0.6805 23399.5n 0.6805 23400.0n 0.5713 23999.5n 0.5713 24000.0n 0.6562 24599.5n 0.6562 24600.0n 0.5717 25199.5n 0.5717 25200.0n 0.6836 25799.5n 0.6836 25800.0n 0.6940 26399.5n 0.6940 26400.0n 0.6865 26999.5n 0.6865 27000.0n 0.6871 27599.5n 0.6871 27600.0n 0.6859 28199.5n 0.6859 28200.0n 0.5507 28799.5n 0.5507 28800.0n 0.6805 29399.5n 0.6805 29400.0n 0.6859 29999.5n 0.6859 30000.0n 0.6849 30599.5n 0.6849 30600.0n 0.6762 31199.5n 0.6762 31200.0n 0.6650 31799.5n 0.6650 31800.0n 0.6939 32399.5n 0.6939 32400.0n 0.6938 32999.5n 0.6938 33000.0n 0.6670 33599.5n 0.6670 33600.0n 0.6747 34199.5n 0.6747 34200.0n 0.5756 34799.5n 0.5756 34800.0n 0.6847 35399.5n 0.6847 35400.0n 0.6736 35999.5n 0.6736)
Cwp_bh_15 wp_bh_15 0 400p
Cwn_bh_15 wn_bh_15 0 400p
Xu_bh_15 xp_bh_15 xn_bh_15 yp_bh_15 yn_bh_15 wp_bh_15 wn_bh_15 vdd gbn gprod
Vxp_wih_0_16 xp_wih_0_16 0 PWL(0.0n 0.4942 599.5n 0.4942 600.0n 0.5558 1199.5n 0.5558 1200.0n 0.4708 1799.5n 0.4708 1800.0n 0.5235 2399.5n 0.5235 2400.0n 0.5350 2999.5n 0.5350 3000.0n 0.5172 3599.5n 0.5172 3600.0n 0.4702 4199.5n 0.4702 4200.0n 0.4867 4799.5n 0.4867 4800.0n 0.4970 5399.5n 0.4970 5400.0n 0.4986 5999.5n 0.4986 6000.0n 0.4751 6599.5n 0.4751 6600.0n 0.4870 7199.5n 0.4870 7200.0n 0.5502 7799.5n 0.5502 7800.0n 0.5521 8399.5n 0.5521 8400.0n 0.4638 8999.5n 0.4638 9000.0n 0.4982 9599.5n 0.4982 9600.0n 0.5131 10199.5n 0.5131 10200.0n 0.5386 10799.5n 0.5386 10800.0n 0.4592 11399.5n 0.4592 11400.0n 0.4950 11999.5n 0.4950 12000.0n 0.4559 12599.5n 0.4559 12600.0n 0.5162 13199.5n 0.5162 13200.0n 0.5038 13799.5n 0.5038 13800.0n 0.5333 14399.5n 0.5333 14400.0n 0.4991 14999.5n 0.4991 15000.0n 0.5298 15599.5n 0.5298 15600.0n 0.4823 16199.5n 0.4823 16200.0n 0.5239 16799.5n 0.5239 16800.0n 0.4592 17399.5n 0.4592 17400.0n 0.5094 17999.5n 0.5094 18000.0n 0.4337 18599.5n 0.4337 18600.0n 0.5977 19199.5n 0.5977 19200.0n 0.5364 19799.5n 0.5364 19800.0n 0.6122 20399.5n 0.6122 20400.0n 0.4856 20999.5n 0.4856 21000.0n 0.3861 21599.5n 0.3861 21600.0n 0.6094 22199.5n 0.6094 22200.0n 0.6364 22799.5n 0.6364 22800.0n 0.4807 23399.5n 0.4807 23400.0n 0.5614 23999.5n 0.5614 24000.0n 0.5913 24599.5n 0.5913 24600.0n 0.6295 25199.5n 0.6295 25200.0n 0.4496 25799.5n 0.4496 25800.0n 0.3792 26399.5n 0.3792 26400.0n 0.4434 26999.5n 0.4434 27000.0n 0.4340 27599.5n 0.4340 27600.0n 0.4461 28199.5n 0.4461 28200.0n 0.5791 28799.5n 0.5791 28800.0n 0.4777 29399.5n 0.4777 29400.0n 0.3878 29999.5n 0.3878 30000.0n 0.3832 30599.5n 0.3832 30600.0n 0.4022 31199.5n 0.4022 31200.0n 0.4482 31799.5n 0.4482 31800.0n 0.3662 32399.5n 0.3662 32400.0n 0.3857 32999.5n 0.3857 33000.0n 0.5584 33599.5n 0.5584 33600.0n 0.5284 34199.5n 0.5284 34200.0n 0.6034 34799.5n 0.6034 34800.0n 0.3469 35399.5n 0.3469 35400.0n 0.5290 35999.5n 0.5290)
Vxn_wih_0_16 xn_wih_0_16 0 PWL(0.0n 0.5058 599.5n 0.5058 600.0n 0.4442 1199.5n 0.4442 1200.0n 0.5292 1799.5n 0.5292 1800.0n 0.4765 2399.5n 0.4765 2400.0n 0.4650 2999.5n 0.4650 3000.0n 0.4828 3599.5n 0.4828 3600.0n 0.5298 4199.5n 0.5298 4200.0n 0.5133 4799.5n 0.5133 4800.0n 0.5030 5399.5n 0.5030 5400.0n 0.5014 5999.5n 0.5014 6000.0n 0.5249 6599.5n 0.5249 6600.0n 0.5130 7199.5n 0.5130 7200.0n 0.4498 7799.5n 0.4498 7800.0n 0.4479 8399.5n 0.4479 8400.0n 0.5362 8999.5n 0.5362 9000.0n 0.5018 9599.5n 0.5018 9600.0n 0.4869 10199.5n 0.4869 10200.0n 0.4614 10799.5n 0.4614 10800.0n 0.5408 11399.5n 0.5408 11400.0n 0.5050 11999.5n 0.5050 12000.0n 0.5441 12599.5n 0.5441 12600.0n 0.4838 13199.5n 0.4838 13200.0n 0.4962 13799.5n 0.4962 13800.0n 0.4667 14399.5n 0.4667 14400.0n 0.5009 14999.5n 0.5009 15000.0n 0.4702 15599.5n 0.4702 15600.0n 0.5177 16199.5n 0.5177 16200.0n 0.4761 16799.5n 0.4761 16800.0n 0.5408 17399.5n 0.5408 17400.0n 0.4906 17999.5n 0.4906 18000.0n 0.5663 18599.5n 0.5663 18600.0n 0.4023 19199.5n 0.4023 19200.0n 0.4636 19799.5n 0.4636 19800.0n 0.3878 20399.5n 0.3878 20400.0n 0.5144 20999.5n 0.5144 21000.0n 0.6139 21599.5n 0.6139 21600.0n 0.3906 22199.5n 0.3906 22200.0n 0.3636 22799.5n 0.3636 22800.0n 0.5193 23399.5n 0.5193 23400.0n 0.4386 23999.5n 0.4386 24000.0n 0.4087 24599.5n 0.4087 24600.0n 0.3705 25199.5n 0.3705 25200.0n 0.5504 25799.5n 0.5504 25800.0n 0.6208 26399.5n 0.6208 26400.0n 0.5566 26999.5n 0.5566 27000.0n 0.5660 27599.5n 0.5660 27600.0n 0.5539 28199.5n 0.5539 28200.0n 0.4209 28799.5n 0.4209 28800.0n 0.5223 29399.5n 0.5223 29400.0n 0.6122 29999.5n 0.6122 30000.0n 0.6168 30599.5n 0.6168 30600.0n 0.5978 31199.5n 0.5978 31200.0n 0.5518 31799.5n 0.5518 31800.0n 0.6338 32399.5n 0.6338 32400.0n 0.6143 32999.5n 0.6143 33000.0n 0.4416 33599.5n 0.4416 33600.0n 0.4716 34199.5n 0.4716 34200.0n 0.3966 34799.5n 0.3966 34800.0n 0.6531 35399.5n 0.6531 35400.0n 0.4710 35999.5n 0.4710)
Vyp_wih_0_16 yp_wih_0_16 0 PWL(0.0n 0.6510 599.5n 0.6510 600.0n 0.6401 1199.5n 0.6401 1200.0n 0.6382 1799.5n 0.6382 1800.0n 0.6101 2399.5n 0.6101 2400.0n 0.6173 2999.5n 0.6173 3000.0n 0.6424 3599.5n 0.6424 3600.0n 0.6434 4199.5n 0.6434 4200.0n 0.6517 4799.5n 0.6517 4800.0n 0.6433 5399.5n 0.6433 5400.0n 0.6430 5999.5n 0.6430 6000.0n 0.6334 6599.5n 0.6334 6600.0n 0.6462 7199.5n 0.6462 7200.0n 0.6353 7799.5n 0.6353 7800.0n 0.6326 8399.5n 0.6326 8400.0n 0.6513 8999.5n 0.6513 9000.0n 0.6432 9599.5n 0.6432 9600.0n 0.6372 10199.5n 0.6372 10200.0n 0.6311 10799.5n 0.6311 10800.0n 0.6412 11399.5n 0.6412 11400.0n 0.6447 11999.5n 0.6447 12000.0n 0.6529 12599.5n 0.6529 12600.0n 0.6358 13199.5n 0.6358 13200.0n 0.6508 13799.5n 0.6508 13800.0n 0.6453 14399.5n 0.6453 14400.0n 0.6449 14999.5n 0.6449 15000.0n 0.6268 15599.5n 0.6268 15600.0n 0.6499 16199.5n 0.6499 16200.0n 0.6496 16799.5n 0.6496 16800.0n 0.6512 17399.5n 0.6512 17400.0n 0.6497 17999.5n 0.6497 18000.0n 0.6048 18599.5n 0.6048 18600.0n 0.6254 19199.5n 0.6254 19200.0n 0.5771 19799.5n 0.5771 19800.0n 0.5751 20399.5n 0.5751 20400.0n 0.5805 20999.5n 0.5805 21000.0n 0.6483 21599.5n 0.6483 21600.0n 0.5971 22199.5n 0.5971 22200.0n 0.6209 22799.5n 0.6209 22800.0n 0.5747 23399.5n 0.5747 23400.0n 0.6641 23999.5n 0.6641 24000.0n 0.5544 24599.5n 0.5544 24600.0n 0.6299 25199.5n 0.6299 25200.0n 0.5906 25799.5n 0.5906 25800.0n 0.5996 26399.5n 0.5996 26400.0n 0.5820 26999.5n 0.5820 27000.0n 0.5956 27599.5n 0.5956 27600.0n 0.5812 28199.5n 0.5812 28200.0n 0.6604 28799.5n 0.6604 28800.0n 0.5772 29399.5n 0.5772 29400.0n 0.6510 29999.5n 0.6510 30000.0n 0.6549 30599.5n 0.6549 30600.0n 0.6704 31199.5n 0.6704 31200.0n 0.6667 31799.5n 0.6667 31800.0n 0.6057 32399.5n 0.6057 32400.0n 0.5982 32999.5n 0.5982 33000.0n 0.5664 33599.5n 0.5664 33600.0n 0.5689 34199.5n 0.5689 34200.0n 0.6389 34799.5n 0.6389 34800.0n 0.6607 35399.5n 0.6607 35400.0n 0.5742 35999.5n 0.5742)
Vyn_wih_0_16 yn_wih_0_16 0 PWL(0.0n 0.3490 599.5n 0.3490 600.0n 0.3599 1199.5n 0.3599 1200.0n 0.3618 1799.5n 0.3618 1800.0n 0.3899 2399.5n 0.3899 2400.0n 0.3827 2999.5n 0.3827 3000.0n 0.3576 3599.5n 0.3576 3600.0n 0.3566 4199.5n 0.3566 4200.0n 0.3483 4799.5n 0.3483 4800.0n 0.3567 5399.5n 0.3567 5400.0n 0.3570 5999.5n 0.3570 6000.0n 0.3666 6599.5n 0.3666 6600.0n 0.3538 7199.5n 0.3538 7200.0n 0.3647 7799.5n 0.3647 7800.0n 0.3674 8399.5n 0.3674 8400.0n 0.3487 8999.5n 0.3487 9000.0n 0.3568 9599.5n 0.3568 9600.0n 0.3628 10199.5n 0.3628 10200.0n 0.3689 10799.5n 0.3689 10800.0n 0.3588 11399.5n 0.3588 11400.0n 0.3553 11999.5n 0.3553 12000.0n 0.3471 12599.5n 0.3471 12600.0n 0.3642 13199.5n 0.3642 13200.0n 0.3492 13799.5n 0.3492 13800.0n 0.3547 14399.5n 0.3547 14400.0n 0.3551 14999.5n 0.3551 15000.0n 0.3732 15599.5n 0.3732 15600.0n 0.3501 16199.5n 0.3501 16200.0n 0.3504 16799.5n 0.3504 16800.0n 0.3488 17399.5n 0.3488 17400.0n 0.3503 17999.5n 0.3503 18000.0n 0.3952 18599.5n 0.3952 18600.0n 0.3746 19199.5n 0.3746 19200.0n 0.4229 19799.5n 0.4229 19800.0n 0.4249 20399.5n 0.4249 20400.0n 0.4195 20999.5n 0.4195 21000.0n 0.3517 21599.5n 0.3517 21600.0n 0.4029 22199.5n 0.4029 22200.0n 0.3791 22799.5n 0.3791 22800.0n 0.4253 23399.5n 0.4253 23400.0n 0.3359 23999.5n 0.3359 24000.0n 0.4456 24599.5n 0.4456 24600.0n 0.3701 25199.5n 0.3701 25200.0n 0.4094 25799.5n 0.4094 25800.0n 0.4004 26399.5n 0.4004 26400.0n 0.4180 26999.5n 0.4180 27000.0n 0.4044 27599.5n 0.4044 27600.0n 0.4188 28199.5n 0.4188 28200.0n 0.3396 28799.5n 0.3396 28800.0n 0.4228 29399.5n 0.4228 29400.0n 0.3490 29999.5n 0.3490 30000.0n 0.3451 30599.5n 0.3451 30600.0n 0.3296 31199.5n 0.3296 31200.0n 0.3333 31799.5n 0.3333 31800.0n 0.3943 32399.5n 0.3943 32400.0n 0.4018 32999.5n 0.4018 33000.0n 0.4336 33599.5n 0.4336 33600.0n 0.4311 34199.5n 0.4311 34200.0n 0.3611 34799.5n 0.3611 34800.0n 0.3393 35399.5n 0.3393 35400.0n 0.4258 35999.5n 0.4258)
Cwp_wih_0_16 wp_wih_0_16 0 400p
Cwn_wih_0_16 wn_wih_0_16 0 400p
Xu_wih_0_16 xp_wih_0_16 xn_wih_0_16 yp_wih_0_16 yn_wih_0_16 wp_wih_0_16 wn_wih_0_16 vdd gbn gprod
Vxp_wih_1_16 xp_wih_1_16 0 PWL(0.0n 0.5370 599.5n 0.5370 600.0n 0.5167 1199.5n 0.5167 1200.0n 0.4793 1799.5n 0.4793 1800.0n 0.4441 2399.5n 0.4441 2400.0n 0.4555 2999.5n 0.4555 3000.0n 0.5055 3599.5n 0.5055 3600.0n 0.4939 4199.5n 0.4939 4200.0n 0.5385 4799.5n 0.5385 4800.0n 0.5024 5399.5n 0.5024 5400.0n 0.5015 5999.5n 0.5015 6000.0n 0.4700 6599.5n 0.4700 6600.0n 0.5120 7199.5n 0.5120 7200.0n 0.5006 7799.5n 0.5006 7800.0n 0.4950 8399.5n 0.4950 8400.0n 0.5309 8999.5n 0.5309 9000.0n 0.5023 9599.5n 0.5023 9600.0n 0.4893 10199.5n 0.4893 10200.0n 0.4837 10799.5n 0.4837 10800.0n 0.4823 11399.5n 0.4823 11400.0n 0.5074 11999.5n 0.5074 12000.0n 0.5364 12599.5n 0.5364 12600.0n 0.4868 13199.5n 0.4868 13200.0n 0.5380 13799.5n 0.5380 13800.0n 0.5220 14399.5n 0.5220 14400.0n 0.5095 14999.5n 0.5095 15000.0n 0.4705 15599.5n 0.4705 15600.0n 0.5289 16199.5n 0.5289 16200.0n 0.5368 16799.5n 0.5368 16800.0n 0.5287 17399.5n 0.5287 17400.0n 0.5342 17999.5n 0.5342 18000.0n 0.4253 18599.5n 0.4253 18600.0n 0.5119 19199.5n 0.5119 19200.0n 0.4104 19799.5n 0.4104 19800.0n 0.4314 20399.5n 0.4314 20400.0n 0.4005 20999.5n 0.4005 21000.0n 0.4696 21599.5n 0.4696 21600.0n 0.4531 22199.5n 0.4531 22200.0n 0.5039 22799.5n 0.5039 22800.0n 0.3608 23399.5n 0.3608 23400.0n 0.6273 23999.5n 0.6273 24000.0n 0.3928 24599.5n 0.3928 24600.0n 0.5253 25199.5n 0.5253 25200.0n 0.4107 25799.5n 0.4107 25800.0n 0.3947 26399.5n 0.3947 26400.0n 0.3716 26999.5n 0.3716 27000.0n 0.4111 27599.5n 0.4111 27600.0n 0.3715 28199.5n 0.3715 28200.0n 0.5939 28799.5n 0.5939 28800.0n 0.3849 29399.5n 0.3849 29400.0n 0.4835 29999.5n 0.4835 30000.0n 0.5119 30599.5n 0.5119 30600.0n 0.6226 31199.5n 0.6226 31200.0n 0.6064 31799.5n 0.6064 31800.0n 0.4115 32399.5n 0.4115 32400.0n 0.3900 32999.5n 0.3900 33000.0n 0.3958 33599.5n 0.3958 33600.0n 0.3747 34199.5n 0.3747 34200.0n 0.5423 34799.5n 0.5423 34800.0n 0.5509 35399.5n 0.5509 35400.0n 0.3990 35999.5n 0.3990)
Vxn_wih_1_16 xn_wih_1_16 0 PWL(0.0n 0.4630 599.5n 0.4630 600.0n 0.4833 1199.5n 0.4833 1200.0n 0.5207 1799.5n 0.5207 1800.0n 0.5559 2399.5n 0.5559 2400.0n 0.5445 2999.5n 0.5445 3000.0n 0.4945 3599.5n 0.4945 3600.0n 0.5061 4199.5n 0.5061 4200.0n 0.4615 4799.5n 0.4615 4800.0n 0.4976 5399.5n 0.4976 5400.0n 0.4985 5999.5n 0.4985 6000.0n 0.5300 6599.5n 0.5300 6600.0n 0.4880 7199.5n 0.4880 7200.0n 0.4994 7799.5n 0.4994 7800.0n 0.5050 8399.5n 0.5050 8400.0n 0.4691 8999.5n 0.4691 9000.0n 0.4977 9599.5n 0.4977 9600.0n 0.5107 10199.5n 0.5107 10200.0n 0.5163 10799.5n 0.5163 10800.0n 0.5177 11399.5n 0.5177 11400.0n 0.4926 11999.5n 0.4926 12000.0n 0.4636 12599.5n 0.4636 12600.0n 0.5132 13199.5n 0.5132 13200.0n 0.4620 13799.5n 0.4620 13800.0n 0.4780 14399.5n 0.4780 14400.0n 0.4905 14999.5n 0.4905 15000.0n 0.5295 15599.5n 0.5295 15600.0n 0.4711 16199.5n 0.4711 16200.0n 0.4632 16799.5n 0.4632 16800.0n 0.4713 17399.5n 0.4713 17400.0n 0.4658 17999.5n 0.4658 18000.0n 0.5747 18599.5n 0.5747 18600.0n 0.4881 19199.5n 0.4881 19200.0n 0.5896 19799.5n 0.5896 19800.0n 0.5686 20399.5n 0.5686 20400.0n 0.5995 20999.5n 0.5995 21000.0n 0.5304 21599.5n 0.5304 21600.0n 0.5469 22199.5n 0.5469 22200.0n 0.4961 22799.5n 0.4961 22800.0n 0.6392 23399.5n 0.6392 23400.0n 0.3727 23999.5n 0.3727 24000.0n 0.6072 24599.5n 0.6072 24600.0n 0.4747 25199.5n 0.4747 25200.0n 0.5893 25799.5n 0.5893 25800.0n 0.6053 26399.5n 0.6053 26400.0n 0.6284 26999.5n 0.6284 27000.0n 0.5889 27599.5n 0.5889 27600.0n 0.6285 28199.5n 0.6285 28200.0n 0.4061 28799.5n 0.4061 28800.0n 0.6151 29399.5n 0.6151 29400.0n 0.5165 29999.5n 0.5165 30000.0n 0.4881 30599.5n 0.4881 30600.0n 0.3774 31199.5n 0.3774 31200.0n 0.3936 31799.5n 0.3936 31800.0n 0.5885 32399.5n 0.5885 32400.0n 0.6100 32999.5n 0.6100 33000.0n 0.6042 33599.5n 0.6042 33600.0n 0.6253 34199.5n 0.6253 34200.0n 0.4577 34799.5n 0.4577 34800.0n 0.4491 35399.5n 0.4491 35400.0n 0.6010 35999.5n 0.6010)
Vyp_wih_1_16 yp_wih_1_16 0 PWL(0.0n 0.6510 599.5n 0.6510 600.0n 0.6401 1199.5n 0.6401 1200.0n 0.6382 1799.5n 0.6382 1800.0n 0.6101 2399.5n 0.6101 2400.0n 0.6173 2999.5n 0.6173 3000.0n 0.6424 3599.5n 0.6424 3600.0n 0.6434 4199.5n 0.6434 4200.0n 0.6517 4799.5n 0.6517 4800.0n 0.6433 5399.5n 0.6433 5400.0n 0.6430 5999.5n 0.6430 6000.0n 0.6334 6599.5n 0.6334 6600.0n 0.6462 7199.5n 0.6462 7200.0n 0.6353 7799.5n 0.6353 7800.0n 0.6326 8399.5n 0.6326 8400.0n 0.6513 8999.5n 0.6513 9000.0n 0.6432 9599.5n 0.6432 9600.0n 0.6372 10199.5n 0.6372 10200.0n 0.6311 10799.5n 0.6311 10800.0n 0.6412 11399.5n 0.6412 11400.0n 0.6447 11999.5n 0.6447 12000.0n 0.6529 12599.5n 0.6529 12600.0n 0.6358 13199.5n 0.6358 13200.0n 0.6508 13799.5n 0.6508 13800.0n 0.6453 14399.5n 0.6453 14400.0n 0.6449 14999.5n 0.6449 15000.0n 0.6268 15599.5n 0.6268 15600.0n 0.6499 16199.5n 0.6499 16200.0n 0.6496 16799.5n 0.6496 16800.0n 0.6512 17399.5n 0.6512 17400.0n 0.6497 17999.5n 0.6497 18000.0n 0.6048 18599.5n 0.6048 18600.0n 0.6254 19199.5n 0.6254 19200.0n 0.5771 19799.5n 0.5771 19800.0n 0.5751 20399.5n 0.5751 20400.0n 0.5805 20999.5n 0.5805 21000.0n 0.6483 21599.5n 0.6483 21600.0n 0.5971 22199.5n 0.5971 22200.0n 0.6209 22799.5n 0.6209 22800.0n 0.5747 23399.5n 0.5747 23400.0n 0.6641 23999.5n 0.6641 24000.0n 0.5544 24599.5n 0.5544 24600.0n 0.6299 25199.5n 0.6299 25200.0n 0.5906 25799.5n 0.5906 25800.0n 0.5996 26399.5n 0.5996 26400.0n 0.5820 26999.5n 0.5820 27000.0n 0.5956 27599.5n 0.5956 27600.0n 0.5812 28199.5n 0.5812 28200.0n 0.6604 28799.5n 0.6604 28800.0n 0.5772 29399.5n 0.5772 29400.0n 0.6510 29999.5n 0.6510 30000.0n 0.6549 30599.5n 0.6549 30600.0n 0.6704 31199.5n 0.6704 31200.0n 0.6667 31799.5n 0.6667 31800.0n 0.6057 32399.5n 0.6057 32400.0n 0.5982 32999.5n 0.5982 33000.0n 0.5664 33599.5n 0.5664 33600.0n 0.5689 34199.5n 0.5689 34200.0n 0.6389 34799.5n 0.6389 34800.0n 0.6607 35399.5n 0.6607 35400.0n 0.5742 35999.5n 0.5742)
Vyn_wih_1_16 yn_wih_1_16 0 PWL(0.0n 0.3490 599.5n 0.3490 600.0n 0.3599 1199.5n 0.3599 1200.0n 0.3618 1799.5n 0.3618 1800.0n 0.3899 2399.5n 0.3899 2400.0n 0.3827 2999.5n 0.3827 3000.0n 0.3576 3599.5n 0.3576 3600.0n 0.3566 4199.5n 0.3566 4200.0n 0.3483 4799.5n 0.3483 4800.0n 0.3567 5399.5n 0.3567 5400.0n 0.3570 5999.5n 0.3570 6000.0n 0.3666 6599.5n 0.3666 6600.0n 0.3538 7199.5n 0.3538 7200.0n 0.3647 7799.5n 0.3647 7800.0n 0.3674 8399.5n 0.3674 8400.0n 0.3487 8999.5n 0.3487 9000.0n 0.3568 9599.5n 0.3568 9600.0n 0.3628 10199.5n 0.3628 10200.0n 0.3689 10799.5n 0.3689 10800.0n 0.3588 11399.5n 0.3588 11400.0n 0.3553 11999.5n 0.3553 12000.0n 0.3471 12599.5n 0.3471 12600.0n 0.3642 13199.5n 0.3642 13200.0n 0.3492 13799.5n 0.3492 13800.0n 0.3547 14399.5n 0.3547 14400.0n 0.3551 14999.5n 0.3551 15000.0n 0.3732 15599.5n 0.3732 15600.0n 0.3501 16199.5n 0.3501 16200.0n 0.3504 16799.5n 0.3504 16800.0n 0.3488 17399.5n 0.3488 17400.0n 0.3503 17999.5n 0.3503 18000.0n 0.3952 18599.5n 0.3952 18600.0n 0.3746 19199.5n 0.3746 19200.0n 0.4229 19799.5n 0.4229 19800.0n 0.4249 20399.5n 0.4249 20400.0n 0.4195 20999.5n 0.4195 21000.0n 0.3517 21599.5n 0.3517 21600.0n 0.4029 22199.5n 0.4029 22200.0n 0.3791 22799.5n 0.3791 22800.0n 0.4253 23399.5n 0.4253 23400.0n 0.3359 23999.5n 0.3359 24000.0n 0.4456 24599.5n 0.4456 24600.0n 0.3701 25199.5n 0.3701 25200.0n 0.4094 25799.5n 0.4094 25800.0n 0.4004 26399.5n 0.4004 26400.0n 0.4180 26999.5n 0.4180 27000.0n 0.4044 27599.5n 0.4044 27600.0n 0.4188 28199.5n 0.4188 28200.0n 0.3396 28799.5n 0.3396 28800.0n 0.4228 29399.5n 0.4228 29400.0n 0.3490 29999.5n 0.3490 30000.0n 0.3451 30599.5n 0.3451 30600.0n 0.3296 31199.5n 0.3296 31200.0n 0.3333 31799.5n 0.3333 31800.0n 0.3943 32399.5n 0.3943 32400.0n 0.4018 32999.5n 0.4018 33000.0n 0.4336 33599.5n 0.4336 33600.0n 0.4311 34199.5n 0.4311 34200.0n 0.3611 34799.5n 0.3611 34800.0n 0.3393 35399.5n 0.3393 35400.0n 0.4258 35999.5n 0.4258)
Cwp_wih_1_16 wp_wih_1_16 0 400p
Cwn_wih_1_16 wn_wih_1_16 0 400p
Xu_wih_1_16 xp_wih_1_16 xn_wih_1_16 yp_wih_1_16 yn_wih_1_16 wp_wih_1_16 wn_wih_1_16 vdd gbn gprod
Vxp_who_16_0 xp_who_16_0 0 PWL(0.0n 0.6510 599.5n 0.6510 600.0n 0.6401 1199.5n 0.6401 1200.0n 0.6382 1799.5n 0.6382 1800.0n 0.6101 2399.5n 0.6101 2400.0n 0.6173 2999.5n 0.6173 3000.0n 0.6424 3599.5n 0.6424 3600.0n 0.6434 4199.5n 0.6434 4200.0n 0.6517 4799.5n 0.6517 4800.0n 0.6433 5399.5n 0.6433 5400.0n 0.6430 5999.5n 0.6430 6000.0n 0.6334 6599.5n 0.6334 6600.0n 0.6462 7199.5n 0.6462 7200.0n 0.6353 7799.5n 0.6353 7800.0n 0.6326 8399.5n 0.6326 8400.0n 0.6513 8999.5n 0.6513 9000.0n 0.6432 9599.5n 0.6432 9600.0n 0.6372 10199.5n 0.6372 10200.0n 0.6311 10799.5n 0.6311 10800.0n 0.6412 11399.5n 0.6412 11400.0n 0.6447 11999.5n 0.6447 12000.0n 0.6529 12599.5n 0.6529 12600.0n 0.6358 13199.5n 0.6358 13200.0n 0.6508 13799.5n 0.6508 13800.0n 0.6453 14399.5n 0.6453 14400.0n 0.6449 14999.5n 0.6449 15000.0n 0.6268 15599.5n 0.6268 15600.0n 0.6499 16199.5n 0.6499 16200.0n 0.6496 16799.5n 0.6496 16800.0n 0.6512 17399.5n 0.6512 17400.0n 0.6497 17999.5n 0.6497 18000.0n 0.6048 18599.5n 0.6048 18600.0n 0.6254 19199.5n 0.6254 19200.0n 0.5771 19799.5n 0.5771 19800.0n 0.5751 20399.5n 0.5751 20400.0n 0.5805 20999.5n 0.5805 21000.0n 0.6483 21599.5n 0.6483 21600.0n 0.5971 22199.5n 0.5971 22200.0n 0.6209 22799.5n 0.6209 22800.0n 0.5747 23399.5n 0.5747 23400.0n 0.6641 23999.5n 0.6641 24000.0n 0.5544 24599.5n 0.5544 24600.0n 0.6299 25199.5n 0.6299 25200.0n 0.5906 25799.5n 0.5906 25800.0n 0.5996 26399.5n 0.5996 26400.0n 0.5820 26999.5n 0.5820 27000.0n 0.5956 27599.5n 0.5956 27600.0n 0.5812 28199.5n 0.5812 28200.0n 0.6604 28799.5n 0.6604 28800.0n 0.5772 29399.5n 0.5772 29400.0n 0.6510 29999.5n 0.6510 30000.0n 0.6549 30599.5n 0.6549 30600.0n 0.6704 31199.5n 0.6704 31200.0n 0.6667 31799.5n 0.6667 31800.0n 0.6057 32399.5n 0.6057 32400.0n 0.5982 32999.5n 0.5982 33000.0n 0.5664 33599.5n 0.5664 33600.0n 0.5689 34199.5n 0.5689 34200.0n 0.6389 34799.5n 0.6389 34800.0n 0.6607 35399.5n 0.6607 35400.0n 0.5742 35999.5n 0.5742)
Vxn_who_16_0 xn_who_16_0 0 PWL(0.0n 0.3490 599.5n 0.3490 600.0n 0.3599 1199.5n 0.3599 1200.0n 0.3618 1799.5n 0.3618 1800.0n 0.3899 2399.5n 0.3899 2400.0n 0.3827 2999.5n 0.3827 3000.0n 0.3576 3599.5n 0.3576 3600.0n 0.3566 4199.5n 0.3566 4200.0n 0.3483 4799.5n 0.3483 4800.0n 0.3567 5399.5n 0.3567 5400.0n 0.3570 5999.5n 0.3570 6000.0n 0.3666 6599.5n 0.3666 6600.0n 0.3538 7199.5n 0.3538 7200.0n 0.3647 7799.5n 0.3647 7800.0n 0.3674 8399.5n 0.3674 8400.0n 0.3487 8999.5n 0.3487 9000.0n 0.3568 9599.5n 0.3568 9600.0n 0.3628 10199.5n 0.3628 10200.0n 0.3689 10799.5n 0.3689 10800.0n 0.3588 11399.5n 0.3588 11400.0n 0.3553 11999.5n 0.3553 12000.0n 0.3471 12599.5n 0.3471 12600.0n 0.3642 13199.5n 0.3642 13200.0n 0.3492 13799.5n 0.3492 13800.0n 0.3547 14399.5n 0.3547 14400.0n 0.3551 14999.5n 0.3551 15000.0n 0.3732 15599.5n 0.3732 15600.0n 0.3501 16199.5n 0.3501 16200.0n 0.3504 16799.5n 0.3504 16800.0n 0.3488 17399.5n 0.3488 17400.0n 0.3503 17999.5n 0.3503 18000.0n 0.3952 18599.5n 0.3952 18600.0n 0.3746 19199.5n 0.3746 19200.0n 0.4229 19799.5n 0.4229 19800.0n 0.4249 20399.5n 0.4249 20400.0n 0.4195 20999.5n 0.4195 21000.0n 0.3517 21599.5n 0.3517 21600.0n 0.4029 22199.5n 0.4029 22200.0n 0.3791 22799.5n 0.3791 22800.0n 0.4253 23399.5n 0.4253 23400.0n 0.3359 23999.5n 0.3359 24000.0n 0.4456 24599.5n 0.4456 24600.0n 0.3701 25199.5n 0.3701 25200.0n 0.4094 25799.5n 0.4094 25800.0n 0.4004 26399.5n 0.4004 26400.0n 0.4180 26999.5n 0.4180 27000.0n 0.4044 27599.5n 0.4044 27600.0n 0.4188 28199.5n 0.4188 28200.0n 0.3396 28799.5n 0.3396 28800.0n 0.4228 29399.5n 0.4228 29400.0n 0.3490 29999.5n 0.3490 30000.0n 0.3451 30599.5n 0.3451 30600.0n 0.3296 31199.5n 0.3296 31200.0n 0.3333 31799.5n 0.3333 31800.0n 0.3943 32399.5n 0.3943 32400.0n 0.4018 32999.5n 0.4018 33000.0n 0.4336 33599.5n 0.4336 33600.0n 0.4311 34199.5n 0.4311 34200.0n 0.3611 34799.5n 0.3611 34800.0n 0.3393 35399.5n 0.3393 35400.0n 0.4258 35999.5n 0.4258)
Vyp_who_16_0 yp_who_16_0 0 PWL(0.0n 0.5031 599.5n 0.5031 600.0n 0.5023 1199.5n 0.5023 1200.0n 0.5052 1799.5n 0.5052 1800.0n 0.5048 2399.5n 0.5048 2400.0n 0.5043 2999.5n 0.5043 3000.0n 0.5034 3599.5n 0.5034 3600.0n 0.5048 4199.5n 0.5048 4200.0n 0.5031 4799.5n 0.5031 4800.0n 0.5040 5399.5n 0.5040 5400.0n 0.5040 5999.5n 0.5040 6000.0n 0.5054 6599.5n 0.5054 6600.0n 0.5040 7199.5n 0.5040 7200.0n 0.5027 7799.5n 0.5027 7800.0n 0.5027 8399.5n 0.5027 8400.0n 0.5038 8999.5n 0.5038 9000.0n 0.5040 9599.5n 0.5040 9600.0n 0.5039 10199.5n 0.5039 10200.0n 0.5033 10799.5n 0.5033 10800.0n 0.5056 11399.5n 0.5056 11400.0n 0.5040 11999.5n 0.5040 12000.0n 0.5036 12599.5n 0.5036 12600.0n 0.5039 13199.5n 0.5039 13200.0n 0.5029 13799.5n 0.5029 13800.0n 0.5025 14399.5n 0.5025 14400.0n 0.5038 14999.5n 0.5038 15000.0n 0.5041 15599.5n 0.5041 15600.0n 0.5036 16199.5n 0.5036 16200.0n 0.5025 16799.5n 0.5025 16800.0n 0.5040 17399.5n 0.5040 17400.0n 0.5029 17999.5n 0.5029 18000.0n 0.5057 18599.5n 0.5057 18600.0n 0.5010 19199.5n 0.5010 19200.0n 0.5041 19799.5n 0.5041 19800.0n 0.5021 20399.5n 0.5021 20400.0n 0.5044 20999.5n 0.5044 21000.0n 0.5056 21599.5n 0.5056 21600.0n 0.5016 22199.5n 0.5016 22200.0n 0.5006 22799.5n 0.5006 22800.0n 0.5041 23399.5n 0.5041 23400.0n 0.5027 23999.5n 0.5027 24000.0n 0.5029 24599.5n 0.5029 24600.0n 0.5006 25199.5n 0.5006 25200.0n 0.5047 25799.5n 0.5047 25800.0n 0.5046 26399.5n 0.5046 26400.0n 0.5039 26999.5n 0.5039 27000.0n 0.5049 27599.5n 0.5049 27600.0n 0.5039 28199.5n 0.5039 28200.0n 0.5017 28799.5n 0.5017 28800.0n 0.5042 29399.5n 0.5042 29400.0n 0.5056 29999.5n 0.5056 30000.0n 0.5051 30599.5n 0.5051 30600.0n 0.5039 31199.5n 0.5039 31200.0n 0.5033 31799.5n 0.5033 31800.0n 0.5049 32399.5n 0.5049 32400.0n 0.5045 32999.5n 0.5045 33000.0n 0.5036 33599.5n 0.5036 33600.0n 0.5042 34199.5n 0.5042 34200.0n 0.5012 34799.5n 0.5012 34800.0n 0.5036 35399.5n 0.5036 35400.0n 0.5042 35999.5n 0.5042)
Vyn_who_16_0 yn_who_16_0 0 PWL(0.0n 0.4969 599.5n 0.4969 600.0n 0.4977 1199.5n 0.4977 1200.0n 0.4948 1799.5n 0.4948 1800.0n 0.4952 2399.5n 0.4952 2400.0n 0.4957 2999.5n 0.4957 3000.0n 0.4966 3599.5n 0.4966 3600.0n 0.4952 4199.5n 0.4952 4200.0n 0.4969 4799.5n 0.4969 4800.0n 0.4960 5399.5n 0.4960 5400.0n 0.4960 5999.5n 0.4960 6000.0n 0.4946 6599.5n 0.4946 6600.0n 0.4960 7199.5n 0.4960 7200.0n 0.4973 7799.5n 0.4973 7800.0n 0.4973 8399.5n 0.4973 8400.0n 0.4962 8999.5n 0.4962 9000.0n 0.4960 9599.5n 0.4960 9600.0n 0.4961 10199.5n 0.4961 10200.0n 0.4967 10799.5n 0.4967 10800.0n 0.4944 11399.5n 0.4944 11400.0n 0.4960 11999.5n 0.4960 12000.0n 0.4964 12599.5n 0.4964 12600.0n 0.4961 13199.5n 0.4961 13200.0n 0.4971 13799.5n 0.4971 13800.0n 0.4975 14399.5n 0.4975 14400.0n 0.4962 14999.5n 0.4962 15000.0n 0.4959 15599.5n 0.4959 15600.0n 0.4964 16199.5n 0.4964 16200.0n 0.4975 16799.5n 0.4975 16800.0n 0.4960 17399.5n 0.4960 17400.0n 0.4971 17999.5n 0.4971 18000.0n 0.4943 18599.5n 0.4943 18600.0n 0.4990 19199.5n 0.4990 19200.0n 0.4959 19799.5n 0.4959 19800.0n 0.4979 20399.5n 0.4979 20400.0n 0.4956 20999.5n 0.4956 21000.0n 0.4944 21599.5n 0.4944 21600.0n 0.4984 22199.5n 0.4984 22200.0n 0.4994 22799.5n 0.4994 22800.0n 0.4959 23399.5n 0.4959 23400.0n 0.4973 23999.5n 0.4973 24000.0n 0.4971 24599.5n 0.4971 24600.0n 0.4994 25199.5n 0.4994 25200.0n 0.4953 25799.5n 0.4953 25800.0n 0.4954 26399.5n 0.4954 26400.0n 0.4961 26999.5n 0.4961 27000.0n 0.4951 27599.5n 0.4951 27600.0n 0.4961 28199.5n 0.4961 28200.0n 0.4983 28799.5n 0.4983 28800.0n 0.4958 29399.5n 0.4958 29400.0n 0.4944 29999.5n 0.4944 30000.0n 0.4949 30599.5n 0.4949 30600.0n 0.4961 31199.5n 0.4961 31200.0n 0.4967 31799.5n 0.4967 31800.0n 0.4951 32399.5n 0.4951 32400.0n 0.4955 32999.5n 0.4955 33000.0n 0.4964 33599.5n 0.4964 33600.0n 0.4958 34199.5n 0.4958 34200.0n 0.4988 34799.5n 0.4988 34800.0n 0.4964 35399.5n 0.4964 35400.0n 0.4958 35999.5n 0.4958)
Cwp_who_16_0 wp_who_16_0 0 400p
Cwn_who_16_0 wn_who_16_0 0 400p
Xu_who_16_0 xp_who_16_0 xn_who_16_0 yp_who_16_0 yn_who_16_0 wp_who_16_0 wn_who_16_0 vdd gbn gprod
Vxp_who_16_1 xp_who_16_1 0 PWL(0.0n 0.6510 599.5n 0.6510 600.0n 0.6401 1199.5n 0.6401 1200.0n 0.6382 1799.5n 0.6382 1800.0n 0.6101 2399.5n 0.6101 2400.0n 0.6173 2999.5n 0.6173 3000.0n 0.6424 3599.5n 0.6424 3600.0n 0.6434 4199.5n 0.6434 4200.0n 0.6517 4799.5n 0.6517 4800.0n 0.6433 5399.5n 0.6433 5400.0n 0.6430 5999.5n 0.6430 6000.0n 0.6334 6599.5n 0.6334 6600.0n 0.6462 7199.5n 0.6462 7200.0n 0.6353 7799.5n 0.6353 7800.0n 0.6326 8399.5n 0.6326 8400.0n 0.6513 8999.5n 0.6513 9000.0n 0.6432 9599.5n 0.6432 9600.0n 0.6372 10199.5n 0.6372 10200.0n 0.6311 10799.5n 0.6311 10800.0n 0.6412 11399.5n 0.6412 11400.0n 0.6447 11999.5n 0.6447 12000.0n 0.6529 12599.5n 0.6529 12600.0n 0.6358 13199.5n 0.6358 13200.0n 0.6508 13799.5n 0.6508 13800.0n 0.6453 14399.5n 0.6453 14400.0n 0.6449 14999.5n 0.6449 15000.0n 0.6268 15599.5n 0.6268 15600.0n 0.6499 16199.5n 0.6499 16200.0n 0.6496 16799.5n 0.6496 16800.0n 0.6512 17399.5n 0.6512 17400.0n 0.6497 17999.5n 0.6497 18000.0n 0.6048 18599.5n 0.6048 18600.0n 0.6254 19199.5n 0.6254 19200.0n 0.5771 19799.5n 0.5771 19800.0n 0.5751 20399.5n 0.5751 20400.0n 0.5805 20999.5n 0.5805 21000.0n 0.6483 21599.5n 0.6483 21600.0n 0.5971 22199.5n 0.5971 22200.0n 0.6209 22799.5n 0.6209 22800.0n 0.5747 23399.5n 0.5747 23400.0n 0.6641 23999.5n 0.6641 24000.0n 0.5544 24599.5n 0.5544 24600.0n 0.6299 25199.5n 0.6299 25200.0n 0.5906 25799.5n 0.5906 25800.0n 0.5996 26399.5n 0.5996 26400.0n 0.5820 26999.5n 0.5820 27000.0n 0.5956 27599.5n 0.5956 27600.0n 0.5812 28199.5n 0.5812 28200.0n 0.6604 28799.5n 0.6604 28800.0n 0.5772 29399.5n 0.5772 29400.0n 0.6510 29999.5n 0.6510 30000.0n 0.6549 30599.5n 0.6549 30600.0n 0.6704 31199.5n 0.6704 31200.0n 0.6667 31799.5n 0.6667 31800.0n 0.6057 32399.5n 0.6057 32400.0n 0.5982 32999.5n 0.5982 33000.0n 0.5664 33599.5n 0.5664 33600.0n 0.5689 34199.5n 0.5689 34200.0n 0.6389 34799.5n 0.6389 34800.0n 0.6607 35399.5n 0.6607 35400.0n 0.5742 35999.5n 0.5742)
Vxn_who_16_1 xn_who_16_1 0 PWL(0.0n 0.3490 599.5n 0.3490 600.0n 0.3599 1199.5n 0.3599 1200.0n 0.3618 1799.5n 0.3618 1800.0n 0.3899 2399.5n 0.3899 2400.0n 0.3827 2999.5n 0.3827 3000.0n 0.3576 3599.5n 0.3576 3600.0n 0.3566 4199.5n 0.3566 4200.0n 0.3483 4799.5n 0.3483 4800.0n 0.3567 5399.5n 0.3567 5400.0n 0.3570 5999.5n 0.3570 6000.0n 0.3666 6599.5n 0.3666 6600.0n 0.3538 7199.5n 0.3538 7200.0n 0.3647 7799.5n 0.3647 7800.0n 0.3674 8399.5n 0.3674 8400.0n 0.3487 8999.5n 0.3487 9000.0n 0.3568 9599.5n 0.3568 9600.0n 0.3628 10199.5n 0.3628 10200.0n 0.3689 10799.5n 0.3689 10800.0n 0.3588 11399.5n 0.3588 11400.0n 0.3553 11999.5n 0.3553 12000.0n 0.3471 12599.5n 0.3471 12600.0n 0.3642 13199.5n 0.3642 13200.0n 0.3492 13799.5n 0.3492 13800.0n 0.3547 14399.5n 0.3547 14400.0n 0.3551 14999.5n 0.3551 15000.0n 0.3732 15599.5n 0.3732 15600.0n 0.3501 16199.5n 0.3501 16200.0n 0.3504 16799.5n 0.3504 16800.0n 0.3488 17399.5n 0.3488 17400.0n 0.3503 17999.5n 0.3503 18000.0n 0.3952 18599.5n 0.3952 18600.0n 0.3746 19199.5n 0.3746 19200.0n 0.4229 19799.5n 0.4229 19800.0n 0.4249 20399.5n 0.4249 20400.0n 0.4195 20999.5n 0.4195 21000.0n 0.3517 21599.5n 0.3517 21600.0n 0.4029 22199.5n 0.4029 22200.0n 0.3791 22799.5n 0.3791 22800.0n 0.4253 23399.5n 0.4253 23400.0n 0.3359 23999.5n 0.3359 24000.0n 0.4456 24599.5n 0.4456 24600.0n 0.3701 25199.5n 0.3701 25200.0n 0.4094 25799.5n 0.4094 25800.0n 0.4004 26399.5n 0.4004 26400.0n 0.4180 26999.5n 0.4180 27000.0n 0.4044 27599.5n 0.4044 27600.0n 0.4188 28199.5n 0.4188 28200.0n 0.3396 28799.5n 0.3396 28800.0n 0.4228 29399.5n 0.4228 29400.0n 0.3490 29999.5n 0.3490 30000.0n 0.3451 30599.5n 0.3451 30600.0n 0.3296 31199.5n 0.3296 31200.0n 0.3333 31799.5n 0.3333 31800.0n 0.3943 32399.5n 0.3943 32400.0n 0.4018 32999.5n 0.4018 33000.0n 0.4336 33599.5n 0.4336 33600.0n 0.4311 34199.5n 0.4311 34200.0n 0.3611 34799.5n 0.3611 34800.0n 0.3393 35399.5n 0.3393 35400.0n 0.4258 35999.5n 0.4258)
Vyp_who_16_1 yp_who_16_1 0 PWL(0.0n 0.5071 599.5n 0.5071 600.0n 0.5053 1199.5n 0.5053 1200.0n 0.5052 1799.5n 0.5052 1800.0n 0.5027 2399.5n 0.5027 2400.0n 0.5034 2999.5n 0.5034 3000.0n 0.5055 3599.5n 0.5055 3600.0n 0.5056 4199.5n 0.5056 4200.0n 0.5071 4799.5n 0.5071 4800.0n 0.5056 5399.5n 0.5056 5400.0n 0.5056 5999.5n 0.5056 6000.0n 0.5048 6599.5n 0.5048 6600.0n 0.5060 7199.5n 0.5060 7200.0n 0.5048 7799.5n 0.5048 7800.0n 0.5046 8399.5n 0.5046 8400.0n 0.5066 8999.5n 0.5066 9000.0n 0.5056 9599.5n 0.5056 9600.0n 0.5051 10199.5n 0.5051 10200.0n 0.5046 10799.5n 0.5046 10800.0n 0.5056 11399.5n 0.5056 11400.0n 0.5058 11999.5n 0.5058 12000.0n 0.5068 12599.5n 0.5068 12600.0n 0.5050 13199.5n 0.5050 13200.0n 0.5071 13799.5n 0.5071 13800.0n 0.5059 14399.5n 0.5059 14400.0n 0.5058 14999.5n 0.5058 15000.0n 0.5043 15599.5n 0.5043 15600.0n 0.5067 16199.5n 0.5067 16200.0n 0.5068 16799.5n 0.5068 16800.0n 0.5066 17399.5n 0.5066 17400.0n 0.5069 17999.5n 0.5069 18000.0n 0.5061 18599.5n 0.5061 18600.0n 0.5034 19199.5n 0.5034 19200.0n 0.5010 19799.5n 0.5010 19800.0n 0.4989 20399.5n 0.4989 20400.0n 0.5022 20999.5n 0.5022 21000.0n 0.5086 21599.5n 0.5086 21600.0n 0.5007 22199.5n 0.5007 22200.0n 0.5023 22799.5n 0.5023 22800.0n 0.5021 23399.5n 0.5021 23400.0n 0.5077 23999.5n 0.5077 24000.0n 0.4979 24599.5n 0.4979 24600.0n 0.5035 25199.5n 0.5035 25200.0n 0.5041 25799.5n 0.5041 25800.0n 0.5075 26399.5n 0.5075 26400.0n 0.5041 26999.5n 0.5041 27000.0n 0.5056 27599.5n 0.5056 27600.0n 0.5039 28199.5n 0.5039 28200.0n 0.5059 28799.5n 0.5059 28800.0n 0.5023 29399.5n 0.5023 29400.0n 0.5086 29999.5n 0.5086 30000.0n 0.5084 30599.5n 0.5084 30600.0n 0.5085 31199.5n 0.5085 31200.0n 0.5088 31799.5n 0.5088 31800.0n 0.5078 32399.5n 0.5078 32400.0n 0.5074 32999.5n 0.5074 33000.0n 0.4996 33599.5n 0.4996 33600.0n 0.5010 34199.5n 0.5010 34200.0n 0.5044 34799.5n 0.5044 34800.0n 0.5084 35399.5n 0.5084 35400.0n 0.5012 35999.5n 0.5012)
Vyn_who_16_1 yn_who_16_1 0 PWL(0.0n 0.4929 599.5n 0.4929 600.0n 0.4947 1199.5n 0.4947 1200.0n 0.4948 1799.5n 0.4948 1800.0n 0.4973 2399.5n 0.4973 2400.0n 0.4966 2999.5n 0.4966 3000.0n 0.4945 3599.5n 0.4945 3600.0n 0.4944 4199.5n 0.4944 4200.0n 0.4929 4799.5n 0.4929 4800.0n 0.4944 5399.5n 0.4944 5400.0n 0.4944 5999.5n 0.4944 6000.0n 0.4952 6599.5n 0.4952 6600.0n 0.4940 7199.5n 0.4940 7200.0n 0.4952 7799.5n 0.4952 7800.0n 0.4954 8399.5n 0.4954 8400.0n 0.4934 8999.5n 0.4934 9000.0n 0.4944 9599.5n 0.4944 9600.0n 0.4949 10199.5n 0.4949 10200.0n 0.4954 10799.5n 0.4954 10800.0n 0.4944 11399.5n 0.4944 11400.0n 0.4942 11999.5n 0.4942 12000.0n 0.4932 12599.5n 0.4932 12600.0n 0.4950 13199.5n 0.4950 13200.0n 0.4929 13799.5n 0.4929 13800.0n 0.4941 14399.5n 0.4941 14400.0n 0.4942 14999.5n 0.4942 15000.0n 0.4957 15599.5n 0.4957 15600.0n 0.4933 16199.5n 0.4933 16200.0n 0.4932 16799.5n 0.4932 16800.0n 0.4934 17399.5n 0.4934 17400.0n 0.4931 17999.5n 0.4931 18000.0n 0.4939 18599.5n 0.4939 18600.0n 0.4966 19199.5n 0.4966 19200.0n 0.4990 19799.5n 0.4990 19800.0n 0.5011 20399.5n 0.5011 20400.0n 0.4978 20999.5n 0.4978 21000.0n 0.4914 21599.5n 0.4914 21600.0n 0.4993 22199.5n 0.4993 22200.0n 0.4977 22799.5n 0.4977 22800.0n 0.4979 23399.5n 0.4979 23400.0n 0.4923 23999.5n 0.4923 24000.0n 0.5021 24599.5n 0.5021 24600.0n 0.4965 25199.5n 0.4965 25200.0n 0.4959 25799.5n 0.4959 25800.0n 0.4925 26399.5n 0.4925 26400.0n 0.4959 26999.5n 0.4959 27000.0n 0.4944 27599.5n 0.4944 27600.0n 0.4961 28199.5n 0.4961 28200.0n 0.4941 28799.5n 0.4941 28800.0n 0.4977 29399.5n 0.4977 29400.0n 0.4914 29999.5n 0.4914 30000.0n 0.4916 30599.5n 0.4916 30600.0n 0.4915 31199.5n 0.4915 31200.0n 0.4912 31799.5n 0.4912 31800.0n 0.4922 32399.5n 0.4922 32400.0n 0.4926 32999.5n 0.4926 33000.0n 0.5004 33599.5n 0.5004 33600.0n 0.4990 34199.5n 0.4990 34200.0n 0.4956 34799.5n 0.4956 34800.0n 0.4916 35399.5n 0.4916 35400.0n 0.4988 35999.5n 0.4988)
Cwp_who_16_1 wp_who_16_1 0 400p
Cwn_who_16_1 wn_who_16_1 0 400p
Xu_who_16_1 xp_who_16_1 xn_who_16_1 yp_who_16_1 yn_who_16_1 wp_who_16_1 wn_who_16_1 vdd gbn gprod
Vxp_bh_16 xp_bh_16 0 PWL(0.0n 0.7100 599.5n 0.7100 600.0n 0.7100 1199.5n 0.7100 1200.0n 0.7100 1799.5n 0.7100 1800.0n 0.7100 2399.5n 0.7100 2400.0n 0.7100 2999.5n 0.7100 3000.0n 0.7100 3599.5n 0.7100 3600.0n 0.7100 4199.5n 0.7100 4200.0n 0.7100 4799.5n 0.7100 4800.0n 0.7100 5399.5n 0.7100 5400.0n 0.7100 5999.5n 0.7100 6000.0n 0.7100 6599.5n 0.7100 6600.0n 0.7100 7199.5n 0.7100 7200.0n 0.7100 7799.5n 0.7100 7800.0n 0.7100 8399.5n 0.7100 8400.0n 0.7100 8999.5n 0.7100 9000.0n 0.7100 9599.5n 0.7100 9600.0n 0.7100 10199.5n 0.7100 10200.0n 0.7100 10799.5n 0.7100 10800.0n 0.7100 11399.5n 0.7100 11400.0n 0.7100 11999.5n 0.7100 12000.0n 0.7100 12599.5n 0.7100 12600.0n 0.7100 13199.5n 0.7100 13200.0n 0.7100 13799.5n 0.7100 13800.0n 0.7100 14399.5n 0.7100 14400.0n 0.7100 14999.5n 0.7100 15000.0n 0.7100 15599.5n 0.7100 15600.0n 0.7100 16199.5n 0.7100 16200.0n 0.7100 16799.5n 0.7100 16800.0n 0.7100 17399.5n 0.7100 17400.0n 0.7100 17999.5n 0.7100 18000.0n 0.7100 18599.5n 0.7100 18600.0n 0.7100 19199.5n 0.7100 19200.0n 0.7100 19799.5n 0.7100 19800.0n 0.7100 20399.5n 0.7100 20400.0n 0.7100 20999.5n 0.7100 21000.0n 0.7100 21599.5n 0.7100 21600.0n 0.7100 22199.5n 0.7100 22200.0n 0.7100 22799.5n 0.7100 22800.0n 0.7100 23399.5n 0.7100 23400.0n 0.7100 23999.5n 0.7100 24000.0n 0.7100 24599.5n 0.7100 24600.0n 0.7100 25199.5n 0.7100 25200.0n 0.7100 25799.5n 0.7100 25800.0n 0.7100 26399.5n 0.7100 26400.0n 0.7100 26999.5n 0.7100 27000.0n 0.7100 27599.5n 0.7100 27600.0n 0.7100 28199.5n 0.7100 28200.0n 0.7100 28799.5n 0.7100 28800.0n 0.7100 29399.5n 0.7100 29400.0n 0.7100 29999.5n 0.7100 30000.0n 0.7100 30599.5n 0.7100 30600.0n 0.7100 31199.5n 0.7100 31200.0n 0.7100 31799.5n 0.7100 31800.0n 0.7100 32399.5n 0.7100 32400.0n 0.7100 32999.5n 0.7100 33000.0n 0.7100 33599.5n 0.7100 33600.0n 0.7100 34199.5n 0.7100 34200.0n 0.7100 34799.5n 0.7100 34800.0n 0.7100 35399.5n 0.7100 35400.0n 0.7100 35999.5n 0.7100)
Vxn_bh_16 xn_bh_16 0 PWL(0.0n 0.2900 599.5n 0.2900 600.0n 0.2900 1199.5n 0.2900 1200.0n 0.2900 1799.5n 0.2900 1800.0n 0.2900 2399.5n 0.2900 2400.0n 0.2900 2999.5n 0.2900 3000.0n 0.2900 3599.5n 0.2900 3600.0n 0.2900 4199.5n 0.2900 4200.0n 0.2900 4799.5n 0.2900 4800.0n 0.2900 5399.5n 0.2900 5400.0n 0.2900 5999.5n 0.2900 6000.0n 0.2900 6599.5n 0.2900 6600.0n 0.2900 7199.5n 0.2900 7200.0n 0.2900 7799.5n 0.2900 7800.0n 0.2900 8399.5n 0.2900 8400.0n 0.2900 8999.5n 0.2900 9000.0n 0.2900 9599.5n 0.2900 9600.0n 0.2900 10199.5n 0.2900 10200.0n 0.2900 10799.5n 0.2900 10800.0n 0.2900 11399.5n 0.2900 11400.0n 0.2900 11999.5n 0.2900 12000.0n 0.2900 12599.5n 0.2900 12600.0n 0.2900 13199.5n 0.2900 13200.0n 0.2900 13799.5n 0.2900 13800.0n 0.2900 14399.5n 0.2900 14400.0n 0.2900 14999.5n 0.2900 15000.0n 0.2900 15599.5n 0.2900 15600.0n 0.2900 16199.5n 0.2900 16200.0n 0.2900 16799.5n 0.2900 16800.0n 0.2900 17399.5n 0.2900 17400.0n 0.2900 17999.5n 0.2900 18000.0n 0.2900 18599.5n 0.2900 18600.0n 0.2900 19199.5n 0.2900 19200.0n 0.2900 19799.5n 0.2900 19800.0n 0.2900 20399.5n 0.2900 20400.0n 0.2900 20999.5n 0.2900 21000.0n 0.2900 21599.5n 0.2900 21600.0n 0.2900 22199.5n 0.2900 22200.0n 0.2900 22799.5n 0.2900 22800.0n 0.2900 23399.5n 0.2900 23400.0n 0.2900 23999.5n 0.2900 24000.0n 0.2900 24599.5n 0.2900 24600.0n 0.2900 25199.5n 0.2900 25200.0n 0.2900 25799.5n 0.2900 25800.0n 0.2900 26399.5n 0.2900 26400.0n 0.2900 26999.5n 0.2900 27000.0n 0.2900 27599.5n 0.2900 27600.0n 0.2900 28199.5n 0.2900 28200.0n 0.2900 28799.5n 0.2900 28800.0n 0.2900 29399.5n 0.2900 29400.0n 0.2900 29999.5n 0.2900 30000.0n 0.2900 30599.5n 0.2900 30600.0n 0.2900 31199.5n 0.2900 31200.0n 0.2900 31799.5n 0.2900 31800.0n 0.2900 32399.5n 0.2900 32400.0n 0.2900 32999.5n 0.2900 33000.0n 0.2900 33599.5n 0.2900 33600.0n 0.2900 34199.5n 0.2900 34200.0n 0.2900 34799.5n 0.2900 34800.0n 0.2900 35399.5n 0.2900 35400.0n 0.2900 35999.5n 0.2900)
Vyp_bh_16 yp_bh_16 0 PWL(0.0n 0.6510 599.5n 0.6510 600.0n 0.6401 1199.5n 0.6401 1200.0n 0.6382 1799.5n 0.6382 1800.0n 0.6101 2399.5n 0.6101 2400.0n 0.6173 2999.5n 0.6173 3000.0n 0.6424 3599.5n 0.6424 3600.0n 0.6434 4199.5n 0.6434 4200.0n 0.6517 4799.5n 0.6517 4800.0n 0.6433 5399.5n 0.6433 5400.0n 0.6430 5999.5n 0.6430 6000.0n 0.6334 6599.5n 0.6334 6600.0n 0.6462 7199.5n 0.6462 7200.0n 0.6353 7799.5n 0.6353 7800.0n 0.6326 8399.5n 0.6326 8400.0n 0.6513 8999.5n 0.6513 9000.0n 0.6432 9599.5n 0.6432 9600.0n 0.6372 10199.5n 0.6372 10200.0n 0.6311 10799.5n 0.6311 10800.0n 0.6412 11399.5n 0.6412 11400.0n 0.6447 11999.5n 0.6447 12000.0n 0.6529 12599.5n 0.6529 12600.0n 0.6358 13199.5n 0.6358 13200.0n 0.6508 13799.5n 0.6508 13800.0n 0.6453 14399.5n 0.6453 14400.0n 0.6449 14999.5n 0.6449 15000.0n 0.6268 15599.5n 0.6268 15600.0n 0.6499 16199.5n 0.6499 16200.0n 0.6496 16799.5n 0.6496 16800.0n 0.6512 17399.5n 0.6512 17400.0n 0.6497 17999.5n 0.6497 18000.0n 0.6048 18599.5n 0.6048 18600.0n 0.6254 19199.5n 0.6254 19200.0n 0.5771 19799.5n 0.5771 19800.0n 0.5751 20399.5n 0.5751 20400.0n 0.5805 20999.5n 0.5805 21000.0n 0.6483 21599.5n 0.6483 21600.0n 0.5971 22199.5n 0.5971 22200.0n 0.6209 22799.5n 0.6209 22800.0n 0.5747 23399.5n 0.5747 23400.0n 0.6641 23999.5n 0.6641 24000.0n 0.5544 24599.5n 0.5544 24600.0n 0.6299 25199.5n 0.6299 25200.0n 0.5906 25799.5n 0.5906 25800.0n 0.5996 26399.5n 0.5996 26400.0n 0.5820 26999.5n 0.5820 27000.0n 0.5956 27599.5n 0.5956 27600.0n 0.5812 28199.5n 0.5812 28200.0n 0.6604 28799.5n 0.6604 28800.0n 0.5772 29399.5n 0.5772 29400.0n 0.6510 29999.5n 0.6510 30000.0n 0.6549 30599.5n 0.6549 30600.0n 0.6704 31199.5n 0.6704 31200.0n 0.6667 31799.5n 0.6667 31800.0n 0.6057 32399.5n 0.6057 32400.0n 0.5982 32999.5n 0.5982 33000.0n 0.5664 33599.5n 0.5664 33600.0n 0.5689 34199.5n 0.5689 34200.0n 0.6389 34799.5n 0.6389 34800.0n 0.6607 35399.5n 0.6607 35400.0n 0.5742 35999.5n 0.5742)
Vyn_bh_16 yn_bh_16 0 PWL(0.0n 0.3490 599.5n 0.3490 600.0n 0.3599 1199.5n 0.3599 1200.0n 0.3618 1799.5n 0.3618 1800.0n 0.3899 2399.5n 0.3899 2400.0n 0.3827 2999.5n 0.3827 3000.0n 0.3576 3599.5n 0.3576 3600.0n 0.3566 4199.5n 0.3566 4200.0n 0.3483 4799.5n 0.3483 4800.0n 0.3567 5399.5n 0.3567 5400.0n 0.3570 5999.5n 0.3570 6000.0n 0.3666 6599.5n 0.3666 6600.0n 0.3538 7199.5n 0.3538 7200.0n 0.3647 7799.5n 0.3647 7800.0n 0.3674 8399.5n 0.3674 8400.0n 0.3487 8999.5n 0.3487 9000.0n 0.3568 9599.5n 0.3568 9600.0n 0.3628 10199.5n 0.3628 10200.0n 0.3689 10799.5n 0.3689 10800.0n 0.3588 11399.5n 0.3588 11400.0n 0.3553 11999.5n 0.3553 12000.0n 0.3471 12599.5n 0.3471 12600.0n 0.3642 13199.5n 0.3642 13200.0n 0.3492 13799.5n 0.3492 13800.0n 0.3547 14399.5n 0.3547 14400.0n 0.3551 14999.5n 0.3551 15000.0n 0.3732 15599.5n 0.3732 15600.0n 0.3501 16199.5n 0.3501 16200.0n 0.3504 16799.5n 0.3504 16800.0n 0.3488 17399.5n 0.3488 17400.0n 0.3503 17999.5n 0.3503 18000.0n 0.3952 18599.5n 0.3952 18600.0n 0.3746 19199.5n 0.3746 19200.0n 0.4229 19799.5n 0.4229 19800.0n 0.4249 20399.5n 0.4249 20400.0n 0.4195 20999.5n 0.4195 21000.0n 0.3517 21599.5n 0.3517 21600.0n 0.4029 22199.5n 0.4029 22200.0n 0.3791 22799.5n 0.3791 22800.0n 0.4253 23399.5n 0.4253 23400.0n 0.3359 23999.5n 0.3359 24000.0n 0.4456 24599.5n 0.4456 24600.0n 0.3701 25199.5n 0.3701 25200.0n 0.4094 25799.5n 0.4094 25800.0n 0.4004 26399.5n 0.4004 26400.0n 0.4180 26999.5n 0.4180 27000.0n 0.4044 27599.5n 0.4044 27600.0n 0.4188 28199.5n 0.4188 28200.0n 0.3396 28799.5n 0.3396 28800.0n 0.4228 29399.5n 0.4228 29400.0n 0.3490 29999.5n 0.3490 30000.0n 0.3451 30599.5n 0.3451 30600.0n 0.3296 31199.5n 0.3296 31200.0n 0.3333 31799.5n 0.3333 31800.0n 0.3943 32399.5n 0.3943 32400.0n 0.4018 32999.5n 0.4018 33000.0n 0.4336 33599.5n 0.4336 33600.0n 0.4311 34199.5n 0.4311 34200.0n 0.3611 34799.5n 0.3611 34800.0n 0.3393 35399.5n 0.3393 35400.0n 0.4258 35999.5n 0.4258)
Cwp_bh_16 wp_bh_16 0 400p
Cwn_bh_16 wn_bh_16 0 400p
Xu_bh_16 xp_bh_16 xn_bh_16 yp_bh_16 yn_bh_16 wp_bh_16 wn_bh_16 vdd gbn gprod
Vxp_wih_0_17 xp_wih_0_17 0 PWL(0.0n 0.4942 599.5n 0.4942 600.0n 0.5558 1199.5n 0.5558 1200.0n 0.4708 1799.5n 0.4708 1800.0n 0.5235 2399.5n 0.5235 2400.0n 0.5350 2999.5n 0.5350 3000.0n 0.5172 3599.5n 0.5172 3600.0n 0.4702 4199.5n 0.4702 4200.0n 0.4867 4799.5n 0.4867 4800.0n 0.4970 5399.5n 0.4970 5400.0n 0.4986 5999.5n 0.4986 6000.0n 0.4751 6599.5n 0.4751 6600.0n 0.4870 7199.5n 0.4870 7200.0n 0.5502 7799.5n 0.5502 7800.0n 0.5521 8399.5n 0.5521 8400.0n 0.4638 8999.5n 0.4638 9000.0n 0.4982 9599.5n 0.4982 9600.0n 0.5131 10199.5n 0.5131 10200.0n 0.5386 10799.5n 0.5386 10800.0n 0.4592 11399.5n 0.4592 11400.0n 0.4950 11999.5n 0.4950 12000.0n 0.4559 12599.5n 0.4559 12600.0n 0.5162 13199.5n 0.5162 13200.0n 0.5038 13799.5n 0.5038 13800.0n 0.5333 14399.5n 0.5333 14400.0n 0.4991 14999.5n 0.4991 15000.0n 0.5298 15599.5n 0.5298 15600.0n 0.4823 16199.5n 0.4823 16200.0n 0.5239 16799.5n 0.5239 16800.0n 0.4592 17399.5n 0.4592 17400.0n 0.5094 17999.5n 0.5094 18000.0n 0.4337 18599.5n 0.4337 18600.0n 0.5977 19199.5n 0.5977 19200.0n 0.5364 19799.5n 0.5364 19800.0n 0.6122 20399.5n 0.6122 20400.0n 0.4856 20999.5n 0.4856 21000.0n 0.3861 21599.5n 0.3861 21600.0n 0.6094 22199.5n 0.6094 22200.0n 0.6364 22799.5n 0.6364 22800.0n 0.4807 23399.5n 0.4807 23400.0n 0.5614 23999.5n 0.5614 24000.0n 0.5913 24599.5n 0.5913 24600.0n 0.6295 25199.5n 0.6295 25200.0n 0.4496 25799.5n 0.4496 25800.0n 0.3792 26399.5n 0.3792 26400.0n 0.4434 26999.5n 0.4434 27000.0n 0.4340 27599.5n 0.4340 27600.0n 0.4461 28199.5n 0.4461 28200.0n 0.5791 28799.5n 0.5791 28800.0n 0.4777 29399.5n 0.4777 29400.0n 0.3878 29999.5n 0.3878 30000.0n 0.3832 30599.5n 0.3832 30600.0n 0.4022 31199.5n 0.4022 31200.0n 0.4482 31799.5n 0.4482 31800.0n 0.3662 32399.5n 0.3662 32400.0n 0.3857 32999.5n 0.3857 33000.0n 0.5584 33599.5n 0.5584 33600.0n 0.5284 34199.5n 0.5284 34200.0n 0.6034 34799.5n 0.6034 34800.0n 0.3469 35399.5n 0.3469 35400.0n 0.5290 35999.5n 0.5290)
Vxn_wih_0_17 xn_wih_0_17 0 PWL(0.0n 0.5058 599.5n 0.5058 600.0n 0.4442 1199.5n 0.4442 1200.0n 0.5292 1799.5n 0.5292 1800.0n 0.4765 2399.5n 0.4765 2400.0n 0.4650 2999.5n 0.4650 3000.0n 0.4828 3599.5n 0.4828 3600.0n 0.5298 4199.5n 0.5298 4200.0n 0.5133 4799.5n 0.5133 4800.0n 0.5030 5399.5n 0.5030 5400.0n 0.5014 5999.5n 0.5014 6000.0n 0.5249 6599.5n 0.5249 6600.0n 0.5130 7199.5n 0.5130 7200.0n 0.4498 7799.5n 0.4498 7800.0n 0.4479 8399.5n 0.4479 8400.0n 0.5362 8999.5n 0.5362 9000.0n 0.5018 9599.5n 0.5018 9600.0n 0.4869 10199.5n 0.4869 10200.0n 0.4614 10799.5n 0.4614 10800.0n 0.5408 11399.5n 0.5408 11400.0n 0.5050 11999.5n 0.5050 12000.0n 0.5441 12599.5n 0.5441 12600.0n 0.4838 13199.5n 0.4838 13200.0n 0.4962 13799.5n 0.4962 13800.0n 0.4667 14399.5n 0.4667 14400.0n 0.5009 14999.5n 0.5009 15000.0n 0.4702 15599.5n 0.4702 15600.0n 0.5177 16199.5n 0.5177 16200.0n 0.4761 16799.5n 0.4761 16800.0n 0.5408 17399.5n 0.5408 17400.0n 0.4906 17999.5n 0.4906 18000.0n 0.5663 18599.5n 0.5663 18600.0n 0.4023 19199.5n 0.4023 19200.0n 0.4636 19799.5n 0.4636 19800.0n 0.3878 20399.5n 0.3878 20400.0n 0.5144 20999.5n 0.5144 21000.0n 0.6139 21599.5n 0.6139 21600.0n 0.3906 22199.5n 0.3906 22200.0n 0.3636 22799.5n 0.3636 22800.0n 0.5193 23399.5n 0.5193 23400.0n 0.4386 23999.5n 0.4386 24000.0n 0.4087 24599.5n 0.4087 24600.0n 0.3705 25199.5n 0.3705 25200.0n 0.5504 25799.5n 0.5504 25800.0n 0.6208 26399.5n 0.6208 26400.0n 0.5566 26999.5n 0.5566 27000.0n 0.5660 27599.5n 0.5660 27600.0n 0.5539 28199.5n 0.5539 28200.0n 0.4209 28799.5n 0.4209 28800.0n 0.5223 29399.5n 0.5223 29400.0n 0.6122 29999.5n 0.6122 30000.0n 0.6168 30599.5n 0.6168 30600.0n 0.5978 31199.5n 0.5978 31200.0n 0.5518 31799.5n 0.5518 31800.0n 0.6338 32399.5n 0.6338 32400.0n 0.6143 32999.5n 0.6143 33000.0n 0.4416 33599.5n 0.4416 33600.0n 0.4716 34199.5n 0.4716 34200.0n 0.3966 34799.5n 0.3966 34800.0n 0.6531 35399.5n 0.6531 35400.0n 0.4710 35999.5n 0.4710)
Vyp_wih_0_17 yp_wih_0_17 0 PWL(0.0n 0.3392 599.5n 0.3392 600.0n 0.3343 1199.5n 0.3343 1200.0n 0.3470 1799.5n 0.3470 1800.0n 0.3457 2399.5n 0.3457 2400.0n 0.3421 2999.5n 0.3421 3000.0n 0.3400 3599.5n 0.3400 3600.0n 0.3456 4199.5n 0.3456 4200.0n 0.3396 4799.5n 0.3396 4800.0n 0.3420 5399.5n 0.3420 5400.0n 0.3420 5999.5n 0.3420 6000.0n 0.3475 6599.5n 0.3475 6600.0n 0.3421 7199.5n 0.3421 7200.0n 0.3363 7799.5n 0.3363 7800.0n 0.3363 8399.5n 0.3363 8400.0n 0.3428 8999.5n 0.3428 9000.0n 0.3419 9599.5n 0.3419 9600.0n 0.3415 10199.5n 0.3415 10200.0n 0.3391 10799.5n 0.3391 10800.0n 0.3486 11399.5n 0.3486 11400.0n 0.3418 11999.5n 0.3418 12000.0n 0.3432 12599.5n 0.3432 12600.0n 0.3414 13199.5n 0.3414 13200.0n 0.3383 13799.5n 0.3383 13800.0n 0.3371 14399.5n 0.3371 14400.0n 0.3413 14999.5n 0.3413 15000.0n 0.3412 15599.5n 0.3412 15600.0n 0.3410 16199.5n 0.3410 16200.0n 0.3367 16799.5n 0.3367 16800.0n 0.3437 17399.5n 0.3437 17400.0n 0.3382 17999.5n 0.3382 18000.0n 0.4007 18599.5n 0.4007 18600.0n 0.3283 19199.5n 0.3283 19200.0n 0.3551 19799.5n 0.3551 19800.0n 0.3338 20399.5n 0.3338 20400.0n 0.3781 20999.5n 0.3781 21000.0n 0.3940 21599.5n 0.3940 21600.0n 0.3309 22199.5n 0.3309 22200.0n 0.3274 22799.5n 0.3274 22800.0n 0.3854 23399.5n 0.3854 23400.0n 0.3230 23999.5n 0.3230 24000.0n 0.3395 24599.5n 0.3395 24600.0n 0.3262 25199.5n 0.3262 25200.0n 0.3936 25799.5n 0.3936 25800.0n 0.4432 26399.5n 0.4432 26400.0n 0.4078 26999.5n 0.4078 27000.0n 0.4088 27599.5n 0.4088 27600.0n 0.4054 28199.5n 0.4054 28200.0n 0.3213 28799.5n 0.3213 28800.0n 0.3853 29399.5n 0.3853 29400.0n 0.3881 29999.5n 0.3881 30000.0n 0.3795 30599.5n 0.3795 30600.0n 0.3400 31199.5n 0.3400 31200.0n 0.3334 31799.5n 0.3334 31800.0n 0.4385 32399.5n 0.4385 32400.0n 0.4432 32999.5n 0.4432 33000.0n 0.3491 33599.5n 0.3491 33600.0n 0.3665 34199.5n 0.3665 34200.0n 0.3257 34799.5n 0.3257 34800.0n 0.3651 35399.5n 0.3651 35400.0n 0.3618 35999.5n 0.3618)
Vyn_wih_0_17 yn_wih_0_17 0 PWL(0.0n 0.6608 599.5n 0.6608 600.0n 0.6657 1199.5n 0.6657 1200.0n 0.6530 1799.5n 0.6530 1800.0n 0.6543 2399.5n 0.6543 2400.0n 0.6579 2999.5n 0.6579 3000.0n 0.6600 3599.5n 0.6600 3600.0n 0.6544 4199.5n 0.6544 4200.0n 0.6604 4799.5n 0.6604 4800.0n 0.6580 5399.5n 0.6580 5400.0n 0.6580 5999.5n 0.6580 6000.0n 0.6525 6599.5n 0.6525 6600.0n 0.6579 7199.5n 0.6579 7200.0n 0.6637 7799.5n 0.6637 7800.0n 0.6637 8399.5n 0.6637 8400.0n 0.6572 8999.5n 0.6572 9000.0n 0.6581 9599.5n 0.6581 9600.0n 0.6585 10199.5n 0.6585 10200.0n 0.6609 10799.5n 0.6609 10800.0n 0.6514 11399.5n 0.6514 11400.0n 0.6582 11999.5n 0.6582 12000.0n 0.6568 12599.5n 0.6568 12600.0n 0.6586 13199.5n 0.6586 13200.0n 0.6617 13799.5n 0.6617 13800.0n 0.6629 14399.5n 0.6629 14400.0n 0.6587 14999.5n 0.6587 15000.0n 0.6588 15599.5n 0.6588 15600.0n 0.6590 16199.5n 0.6590 16200.0n 0.6633 16799.5n 0.6633 16800.0n 0.6563 17399.5n 0.6563 17400.0n 0.6618 17999.5n 0.6618 18000.0n 0.5993 18599.5n 0.5993 18600.0n 0.6717 19199.5n 0.6717 19200.0n 0.6449 19799.5n 0.6449 19800.0n 0.6662 20399.5n 0.6662 20400.0n 0.6219 20999.5n 0.6219 21000.0n 0.6060 21599.5n 0.6060 21600.0n 0.6691 22199.5n 0.6691 22200.0n 0.6726 22799.5n 0.6726 22800.0n 0.6146 23399.5n 0.6146 23400.0n 0.6770 23999.5n 0.6770 24000.0n 0.6605 24599.5n 0.6605 24600.0n 0.6738 25199.5n 0.6738 25200.0n 0.6064 25799.5n 0.6064 25800.0n 0.5568 26399.5n 0.5568 26400.0n 0.5922 26999.5n 0.5922 27000.0n 0.5912 27599.5n 0.5912 27600.0n 0.5946 28199.5n 0.5946 28200.0n 0.6787 28799.5n 0.6787 28800.0n 0.6147 29399.5n 0.6147 29400.0n 0.6119 29999.5n 0.6119 30000.0n 0.6205 30599.5n 0.6205 30600.0n 0.6600 31199.5n 0.6600 31200.0n 0.6666 31799.5n 0.6666 31800.0n 0.5615 32399.5n 0.5615 32400.0n 0.5568 32999.5n 0.5568 33000.0n 0.6509 33599.5n 0.6509 33600.0n 0.6335 34199.5n 0.6335 34200.0n 0.6743 34799.5n 0.6743 34800.0n 0.6349 35399.5n 0.6349 35400.0n 0.6382 35999.5n 0.6382)
Cwp_wih_0_17 wp_wih_0_17 0 400p
Cwn_wih_0_17 wn_wih_0_17 0 400p
Xu_wih_0_17 xp_wih_0_17 xn_wih_0_17 yp_wih_0_17 yn_wih_0_17 wp_wih_0_17 wn_wih_0_17 vdd gbn gprod
Vxp_wih_1_17 xp_wih_1_17 0 PWL(0.0n 0.5370 599.5n 0.5370 600.0n 0.5167 1199.5n 0.5167 1200.0n 0.4793 1799.5n 0.4793 1800.0n 0.4441 2399.5n 0.4441 2400.0n 0.4555 2999.5n 0.4555 3000.0n 0.5055 3599.5n 0.5055 3600.0n 0.4939 4199.5n 0.4939 4200.0n 0.5385 4799.5n 0.5385 4800.0n 0.5024 5399.5n 0.5024 5400.0n 0.5015 5999.5n 0.5015 6000.0n 0.4700 6599.5n 0.4700 6600.0n 0.5120 7199.5n 0.5120 7200.0n 0.5006 7799.5n 0.5006 7800.0n 0.4950 8399.5n 0.4950 8400.0n 0.5309 8999.5n 0.5309 9000.0n 0.5023 9599.5n 0.5023 9600.0n 0.4893 10199.5n 0.4893 10200.0n 0.4837 10799.5n 0.4837 10800.0n 0.4823 11399.5n 0.4823 11400.0n 0.5074 11999.5n 0.5074 12000.0n 0.5364 12599.5n 0.5364 12600.0n 0.4868 13199.5n 0.4868 13200.0n 0.5380 13799.5n 0.5380 13800.0n 0.5220 14399.5n 0.5220 14400.0n 0.5095 14999.5n 0.5095 15000.0n 0.4705 15599.5n 0.4705 15600.0n 0.5289 16199.5n 0.5289 16200.0n 0.5368 16799.5n 0.5368 16800.0n 0.5287 17399.5n 0.5287 17400.0n 0.5342 17999.5n 0.5342 18000.0n 0.4253 18599.5n 0.4253 18600.0n 0.5119 19199.5n 0.5119 19200.0n 0.4104 19799.5n 0.4104 19800.0n 0.4314 20399.5n 0.4314 20400.0n 0.4005 20999.5n 0.4005 21000.0n 0.4696 21599.5n 0.4696 21600.0n 0.4531 22199.5n 0.4531 22200.0n 0.5039 22799.5n 0.5039 22800.0n 0.3608 23399.5n 0.3608 23400.0n 0.6273 23999.5n 0.6273 24000.0n 0.3928 24599.5n 0.3928 24600.0n 0.5253 25199.5n 0.5253 25200.0n 0.4107 25799.5n 0.4107 25800.0n 0.3947 26399.5n 0.3947 26400.0n 0.3716 26999.5n 0.3716 27000.0n 0.4111 27599.5n 0.4111 27600.0n 0.3715 28199.5n 0.3715 28200.0n 0.5939 28799.5n 0.5939 28800.0n 0.3849 29399.5n 0.3849 29400.0n 0.4835 29999.5n 0.4835 30000.0n 0.5119 30599.5n 0.5119 30600.0n 0.6226 31199.5n 0.6226 31200.0n 0.6064 31799.5n 0.6064 31800.0n 0.4115 32399.5n 0.4115 32400.0n 0.3900 32999.5n 0.3900 33000.0n 0.3958 33599.5n 0.3958 33600.0n 0.3747 34199.5n 0.3747 34200.0n 0.5423 34799.5n 0.5423 34800.0n 0.5509 35399.5n 0.5509 35400.0n 0.3990 35999.5n 0.3990)
Vxn_wih_1_17 xn_wih_1_17 0 PWL(0.0n 0.4630 599.5n 0.4630 600.0n 0.4833 1199.5n 0.4833 1200.0n 0.5207 1799.5n 0.5207 1800.0n 0.5559 2399.5n 0.5559 2400.0n 0.5445 2999.5n 0.5445 3000.0n 0.4945 3599.5n 0.4945 3600.0n 0.5061 4199.5n 0.5061 4200.0n 0.4615 4799.5n 0.4615 4800.0n 0.4976 5399.5n 0.4976 5400.0n 0.4985 5999.5n 0.4985 6000.0n 0.5300 6599.5n 0.5300 6600.0n 0.4880 7199.5n 0.4880 7200.0n 0.4994 7799.5n 0.4994 7800.0n 0.5050 8399.5n 0.5050 8400.0n 0.4691 8999.5n 0.4691 9000.0n 0.4977 9599.5n 0.4977 9600.0n 0.5107 10199.5n 0.5107 10200.0n 0.5163 10799.5n 0.5163 10800.0n 0.5177 11399.5n 0.5177 11400.0n 0.4926 11999.5n 0.4926 12000.0n 0.4636 12599.5n 0.4636 12600.0n 0.5132 13199.5n 0.5132 13200.0n 0.4620 13799.5n 0.4620 13800.0n 0.4780 14399.5n 0.4780 14400.0n 0.4905 14999.5n 0.4905 15000.0n 0.5295 15599.5n 0.5295 15600.0n 0.4711 16199.5n 0.4711 16200.0n 0.4632 16799.5n 0.4632 16800.0n 0.4713 17399.5n 0.4713 17400.0n 0.4658 17999.5n 0.4658 18000.0n 0.5747 18599.5n 0.5747 18600.0n 0.4881 19199.5n 0.4881 19200.0n 0.5896 19799.5n 0.5896 19800.0n 0.5686 20399.5n 0.5686 20400.0n 0.5995 20999.5n 0.5995 21000.0n 0.5304 21599.5n 0.5304 21600.0n 0.5469 22199.5n 0.5469 22200.0n 0.4961 22799.5n 0.4961 22800.0n 0.6392 23399.5n 0.6392 23400.0n 0.3727 23999.5n 0.3727 24000.0n 0.6072 24599.5n 0.6072 24600.0n 0.4747 25199.5n 0.4747 25200.0n 0.5893 25799.5n 0.5893 25800.0n 0.6053 26399.5n 0.6053 26400.0n 0.6284 26999.5n 0.6284 27000.0n 0.5889 27599.5n 0.5889 27600.0n 0.6285 28199.5n 0.6285 28200.0n 0.4061 28799.5n 0.4061 28800.0n 0.6151 29399.5n 0.6151 29400.0n 0.5165 29999.5n 0.5165 30000.0n 0.4881 30599.5n 0.4881 30600.0n 0.3774 31199.5n 0.3774 31200.0n 0.3936 31799.5n 0.3936 31800.0n 0.5885 32399.5n 0.5885 32400.0n 0.6100 32999.5n 0.6100 33000.0n 0.6042 33599.5n 0.6042 33600.0n 0.6253 34199.5n 0.6253 34200.0n 0.4577 34799.5n 0.4577 34800.0n 0.4491 35399.5n 0.4491 35400.0n 0.6010 35999.5n 0.6010)
Vyp_wih_1_17 yp_wih_1_17 0 PWL(0.0n 0.3392 599.5n 0.3392 600.0n 0.3343 1199.5n 0.3343 1200.0n 0.3470 1799.5n 0.3470 1800.0n 0.3457 2399.5n 0.3457 2400.0n 0.3421 2999.5n 0.3421 3000.0n 0.3400 3599.5n 0.3400 3600.0n 0.3456 4199.5n 0.3456 4200.0n 0.3396 4799.5n 0.3396 4800.0n 0.3420 5399.5n 0.3420 5400.0n 0.3420 5999.5n 0.3420 6000.0n 0.3475 6599.5n 0.3475 6600.0n 0.3421 7199.5n 0.3421 7200.0n 0.3363 7799.5n 0.3363 7800.0n 0.3363 8399.5n 0.3363 8400.0n 0.3428 8999.5n 0.3428 9000.0n 0.3419 9599.5n 0.3419 9600.0n 0.3415 10199.5n 0.3415 10200.0n 0.3391 10799.5n 0.3391 10800.0n 0.3486 11399.5n 0.3486 11400.0n 0.3418 11999.5n 0.3418 12000.0n 0.3432 12599.5n 0.3432 12600.0n 0.3414 13199.5n 0.3414 13200.0n 0.3383 13799.5n 0.3383 13800.0n 0.3371 14399.5n 0.3371 14400.0n 0.3413 14999.5n 0.3413 15000.0n 0.3412 15599.5n 0.3412 15600.0n 0.3410 16199.5n 0.3410 16200.0n 0.3367 16799.5n 0.3367 16800.0n 0.3437 17399.5n 0.3437 17400.0n 0.3382 17999.5n 0.3382 18000.0n 0.4007 18599.5n 0.4007 18600.0n 0.3283 19199.5n 0.3283 19200.0n 0.3551 19799.5n 0.3551 19800.0n 0.3338 20399.5n 0.3338 20400.0n 0.3781 20999.5n 0.3781 21000.0n 0.3940 21599.5n 0.3940 21600.0n 0.3309 22199.5n 0.3309 22200.0n 0.3274 22799.5n 0.3274 22800.0n 0.3854 23399.5n 0.3854 23400.0n 0.3230 23999.5n 0.3230 24000.0n 0.3395 24599.5n 0.3395 24600.0n 0.3262 25199.5n 0.3262 25200.0n 0.3936 25799.5n 0.3936 25800.0n 0.4432 26399.5n 0.4432 26400.0n 0.4078 26999.5n 0.4078 27000.0n 0.4088 27599.5n 0.4088 27600.0n 0.4054 28199.5n 0.4054 28200.0n 0.3213 28799.5n 0.3213 28800.0n 0.3853 29399.5n 0.3853 29400.0n 0.3881 29999.5n 0.3881 30000.0n 0.3795 30599.5n 0.3795 30600.0n 0.3400 31199.5n 0.3400 31200.0n 0.3334 31799.5n 0.3334 31800.0n 0.4385 32399.5n 0.4385 32400.0n 0.4432 32999.5n 0.4432 33000.0n 0.3491 33599.5n 0.3491 33600.0n 0.3665 34199.5n 0.3665 34200.0n 0.3257 34799.5n 0.3257 34800.0n 0.3651 35399.5n 0.3651 35400.0n 0.3618 35999.5n 0.3618)
Vyn_wih_1_17 yn_wih_1_17 0 PWL(0.0n 0.6608 599.5n 0.6608 600.0n 0.6657 1199.5n 0.6657 1200.0n 0.6530 1799.5n 0.6530 1800.0n 0.6543 2399.5n 0.6543 2400.0n 0.6579 2999.5n 0.6579 3000.0n 0.6600 3599.5n 0.6600 3600.0n 0.6544 4199.5n 0.6544 4200.0n 0.6604 4799.5n 0.6604 4800.0n 0.6580 5399.5n 0.6580 5400.0n 0.6580 5999.5n 0.6580 6000.0n 0.6525 6599.5n 0.6525 6600.0n 0.6579 7199.5n 0.6579 7200.0n 0.6637 7799.5n 0.6637 7800.0n 0.6637 8399.5n 0.6637 8400.0n 0.6572 8999.5n 0.6572 9000.0n 0.6581 9599.5n 0.6581 9600.0n 0.6585 10199.5n 0.6585 10200.0n 0.6609 10799.5n 0.6609 10800.0n 0.6514 11399.5n 0.6514 11400.0n 0.6582 11999.5n 0.6582 12000.0n 0.6568 12599.5n 0.6568 12600.0n 0.6586 13199.5n 0.6586 13200.0n 0.6617 13799.5n 0.6617 13800.0n 0.6629 14399.5n 0.6629 14400.0n 0.6587 14999.5n 0.6587 15000.0n 0.6588 15599.5n 0.6588 15600.0n 0.6590 16199.5n 0.6590 16200.0n 0.6633 16799.5n 0.6633 16800.0n 0.6563 17399.5n 0.6563 17400.0n 0.6618 17999.5n 0.6618 18000.0n 0.5993 18599.5n 0.5993 18600.0n 0.6717 19199.5n 0.6717 19200.0n 0.6449 19799.5n 0.6449 19800.0n 0.6662 20399.5n 0.6662 20400.0n 0.6219 20999.5n 0.6219 21000.0n 0.6060 21599.5n 0.6060 21600.0n 0.6691 22199.5n 0.6691 22200.0n 0.6726 22799.5n 0.6726 22800.0n 0.6146 23399.5n 0.6146 23400.0n 0.6770 23999.5n 0.6770 24000.0n 0.6605 24599.5n 0.6605 24600.0n 0.6738 25199.5n 0.6738 25200.0n 0.6064 25799.5n 0.6064 25800.0n 0.5568 26399.5n 0.5568 26400.0n 0.5922 26999.5n 0.5922 27000.0n 0.5912 27599.5n 0.5912 27600.0n 0.5946 28199.5n 0.5946 28200.0n 0.6787 28799.5n 0.6787 28800.0n 0.6147 29399.5n 0.6147 29400.0n 0.6119 29999.5n 0.6119 30000.0n 0.6205 30599.5n 0.6205 30600.0n 0.6600 31199.5n 0.6600 31200.0n 0.6666 31799.5n 0.6666 31800.0n 0.5615 32399.5n 0.5615 32400.0n 0.5568 32999.5n 0.5568 33000.0n 0.6509 33599.5n 0.6509 33600.0n 0.6335 34199.5n 0.6335 34200.0n 0.6743 34799.5n 0.6743 34800.0n 0.6349 35399.5n 0.6349 35400.0n 0.6382 35999.5n 0.6382)
Cwp_wih_1_17 wp_wih_1_17 0 400p
Cwn_wih_1_17 wn_wih_1_17 0 400p
Xu_wih_1_17 xp_wih_1_17 xn_wih_1_17 yp_wih_1_17 yn_wih_1_17 wp_wih_1_17 wn_wih_1_17 vdd gbn gprod
Vxp_who_17_0 xp_who_17_0 0 PWL(0.0n 0.3392 599.5n 0.3392 600.0n 0.3343 1199.5n 0.3343 1200.0n 0.3470 1799.5n 0.3470 1800.0n 0.3457 2399.5n 0.3457 2400.0n 0.3421 2999.5n 0.3421 3000.0n 0.3400 3599.5n 0.3400 3600.0n 0.3456 4199.5n 0.3456 4200.0n 0.3396 4799.5n 0.3396 4800.0n 0.3420 5399.5n 0.3420 5400.0n 0.3420 5999.5n 0.3420 6000.0n 0.3475 6599.5n 0.3475 6600.0n 0.3421 7199.5n 0.3421 7200.0n 0.3363 7799.5n 0.3363 7800.0n 0.3363 8399.5n 0.3363 8400.0n 0.3428 8999.5n 0.3428 9000.0n 0.3419 9599.5n 0.3419 9600.0n 0.3415 10199.5n 0.3415 10200.0n 0.3391 10799.5n 0.3391 10800.0n 0.3486 11399.5n 0.3486 11400.0n 0.3418 11999.5n 0.3418 12000.0n 0.3432 12599.5n 0.3432 12600.0n 0.3414 13199.5n 0.3414 13200.0n 0.3383 13799.5n 0.3383 13800.0n 0.3371 14399.5n 0.3371 14400.0n 0.3413 14999.5n 0.3413 15000.0n 0.3412 15599.5n 0.3412 15600.0n 0.3410 16199.5n 0.3410 16200.0n 0.3367 16799.5n 0.3367 16800.0n 0.3437 17399.5n 0.3437 17400.0n 0.3382 17999.5n 0.3382 18000.0n 0.4007 18599.5n 0.4007 18600.0n 0.3283 19199.5n 0.3283 19200.0n 0.3551 19799.5n 0.3551 19800.0n 0.3338 20399.5n 0.3338 20400.0n 0.3781 20999.5n 0.3781 21000.0n 0.3940 21599.5n 0.3940 21600.0n 0.3309 22199.5n 0.3309 22200.0n 0.3274 22799.5n 0.3274 22800.0n 0.3854 23399.5n 0.3854 23400.0n 0.3230 23999.5n 0.3230 24000.0n 0.3395 24599.5n 0.3395 24600.0n 0.3262 25199.5n 0.3262 25200.0n 0.3936 25799.5n 0.3936 25800.0n 0.4432 26399.5n 0.4432 26400.0n 0.4078 26999.5n 0.4078 27000.0n 0.4088 27599.5n 0.4088 27600.0n 0.4054 28199.5n 0.4054 28200.0n 0.3213 28799.5n 0.3213 28800.0n 0.3853 29399.5n 0.3853 29400.0n 0.3881 29999.5n 0.3881 30000.0n 0.3795 30599.5n 0.3795 30600.0n 0.3400 31199.5n 0.3400 31200.0n 0.3334 31799.5n 0.3334 31800.0n 0.4385 32399.5n 0.4385 32400.0n 0.4432 32999.5n 0.4432 33000.0n 0.3491 33599.5n 0.3491 33600.0n 0.3665 34199.5n 0.3665 34200.0n 0.3257 34799.5n 0.3257 34800.0n 0.3651 35399.5n 0.3651 35400.0n 0.3618 35999.5n 0.3618)
Vxn_who_17_0 xn_who_17_0 0 PWL(0.0n 0.6608 599.5n 0.6608 600.0n 0.6657 1199.5n 0.6657 1200.0n 0.6530 1799.5n 0.6530 1800.0n 0.6543 2399.5n 0.6543 2400.0n 0.6579 2999.5n 0.6579 3000.0n 0.6600 3599.5n 0.6600 3600.0n 0.6544 4199.5n 0.6544 4200.0n 0.6604 4799.5n 0.6604 4800.0n 0.6580 5399.5n 0.6580 5400.0n 0.6580 5999.5n 0.6580 6000.0n 0.6525 6599.5n 0.6525 6600.0n 0.6579 7199.5n 0.6579 7200.0n 0.6637 7799.5n 0.6637 7800.0n 0.6637 8399.5n 0.6637 8400.0n 0.6572 8999.5n 0.6572 9000.0n 0.6581 9599.5n 0.6581 9600.0n 0.6585 10199.5n 0.6585 10200.0n 0.6609 10799.5n 0.6609 10800.0n 0.6514 11399.5n 0.6514 11400.0n 0.6582 11999.5n 0.6582 12000.0n 0.6568 12599.5n 0.6568 12600.0n 0.6586 13199.5n 0.6586 13200.0n 0.6617 13799.5n 0.6617 13800.0n 0.6629 14399.5n 0.6629 14400.0n 0.6587 14999.5n 0.6587 15000.0n 0.6588 15599.5n 0.6588 15600.0n 0.6590 16199.5n 0.6590 16200.0n 0.6633 16799.5n 0.6633 16800.0n 0.6563 17399.5n 0.6563 17400.0n 0.6618 17999.5n 0.6618 18000.0n 0.5993 18599.5n 0.5993 18600.0n 0.6717 19199.5n 0.6717 19200.0n 0.6449 19799.5n 0.6449 19800.0n 0.6662 20399.5n 0.6662 20400.0n 0.6219 20999.5n 0.6219 21000.0n 0.6060 21599.5n 0.6060 21600.0n 0.6691 22199.5n 0.6691 22200.0n 0.6726 22799.5n 0.6726 22800.0n 0.6146 23399.5n 0.6146 23400.0n 0.6770 23999.5n 0.6770 24000.0n 0.6605 24599.5n 0.6605 24600.0n 0.6738 25199.5n 0.6738 25200.0n 0.6064 25799.5n 0.6064 25800.0n 0.5568 26399.5n 0.5568 26400.0n 0.5922 26999.5n 0.5922 27000.0n 0.5912 27599.5n 0.5912 27600.0n 0.5946 28199.5n 0.5946 28200.0n 0.6787 28799.5n 0.6787 28800.0n 0.6147 29399.5n 0.6147 29400.0n 0.6119 29999.5n 0.6119 30000.0n 0.6205 30599.5n 0.6205 30600.0n 0.6600 31199.5n 0.6600 31200.0n 0.6666 31799.5n 0.6666 31800.0n 0.5615 32399.5n 0.5615 32400.0n 0.5568 32999.5n 0.5568 33000.0n 0.6509 33599.5n 0.6509 33600.0n 0.6335 34199.5n 0.6335 34200.0n 0.6743 34799.5n 0.6743 34800.0n 0.6349 35399.5n 0.6349 35400.0n 0.6382 35999.5n 0.6382)
Vyp_who_17_0 yp_who_17_0 0 PWL(0.0n 0.5031 599.5n 0.5031 600.0n 0.5023 1199.5n 0.5023 1200.0n 0.5052 1799.5n 0.5052 1800.0n 0.5048 2399.5n 0.5048 2400.0n 0.5043 2999.5n 0.5043 3000.0n 0.5034 3599.5n 0.5034 3600.0n 0.5048 4199.5n 0.5048 4200.0n 0.5031 4799.5n 0.5031 4800.0n 0.5040 5399.5n 0.5040 5400.0n 0.5040 5999.5n 0.5040 6000.0n 0.5054 6599.5n 0.5054 6600.0n 0.5040 7199.5n 0.5040 7200.0n 0.5027 7799.5n 0.5027 7800.0n 0.5027 8399.5n 0.5027 8400.0n 0.5038 8999.5n 0.5038 9000.0n 0.5040 9599.5n 0.5040 9600.0n 0.5039 10199.5n 0.5039 10200.0n 0.5033 10799.5n 0.5033 10800.0n 0.5056 11399.5n 0.5056 11400.0n 0.5040 11999.5n 0.5040 12000.0n 0.5036 12599.5n 0.5036 12600.0n 0.5039 13199.5n 0.5039 13200.0n 0.5029 13799.5n 0.5029 13800.0n 0.5025 14399.5n 0.5025 14400.0n 0.5038 14999.5n 0.5038 15000.0n 0.5041 15599.5n 0.5041 15600.0n 0.5036 16199.5n 0.5036 16200.0n 0.5025 16799.5n 0.5025 16800.0n 0.5040 17399.5n 0.5040 17400.0n 0.5029 17999.5n 0.5029 18000.0n 0.5057 18599.5n 0.5057 18600.0n 0.5010 19199.5n 0.5010 19200.0n 0.5041 19799.5n 0.5041 19800.0n 0.5021 20399.5n 0.5021 20400.0n 0.5044 20999.5n 0.5044 21000.0n 0.5056 21599.5n 0.5056 21600.0n 0.5016 22199.5n 0.5016 22200.0n 0.5006 22799.5n 0.5006 22800.0n 0.5041 23399.5n 0.5041 23400.0n 0.5027 23999.5n 0.5027 24000.0n 0.5029 24599.5n 0.5029 24600.0n 0.5006 25199.5n 0.5006 25200.0n 0.5047 25799.5n 0.5047 25800.0n 0.5046 26399.5n 0.5046 26400.0n 0.5039 26999.5n 0.5039 27000.0n 0.5049 27599.5n 0.5049 27600.0n 0.5039 28199.5n 0.5039 28200.0n 0.5017 28799.5n 0.5017 28800.0n 0.5042 29399.5n 0.5042 29400.0n 0.5056 29999.5n 0.5056 30000.0n 0.5051 30599.5n 0.5051 30600.0n 0.5039 31199.5n 0.5039 31200.0n 0.5033 31799.5n 0.5033 31800.0n 0.5049 32399.5n 0.5049 32400.0n 0.5045 32999.5n 0.5045 33000.0n 0.5036 33599.5n 0.5036 33600.0n 0.5042 34199.5n 0.5042 34200.0n 0.5012 34799.5n 0.5012 34800.0n 0.5036 35399.5n 0.5036 35400.0n 0.5042 35999.5n 0.5042)
Vyn_who_17_0 yn_who_17_0 0 PWL(0.0n 0.4969 599.5n 0.4969 600.0n 0.4977 1199.5n 0.4977 1200.0n 0.4948 1799.5n 0.4948 1800.0n 0.4952 2399.5n 0.4952 2400.0n 0.4957 2999.5n 0.4957 3000.0n 0.4966 3599.5n 0.4966 3600.0n 0.4952 4199.5n 0.4952 4200.0n 0.4969 4799.5n 0.4969 4800.0n 0.4960 5399.5n 0.4960 5400.0n 0.4960 5999.5n 0.4960 6000.0n 0.4946 6599.5n 0.4946 6600.0n 0.4960 7199.5n 0.4960 7200.0n 0.4973 7799.5n 0.4973 7800.0n 0.4973 8399.5n 0.4973 8400.0n 0.4962 8999.5n 0.4962 9000.0n 0.4960 9599.5n 0.4960 9600.0n 0.4961 10199.5n 0.4961 10200.0n 0.4967 10799.5n 0.4967 10800.0n 0.4944 11399.5n 0.4944 11400.0n 0.4960 11999.5n 0.4960 12000.0n 0.4964 12599.5n 0.4964 12600.0n 0.4961 13199.5n 0.4961 13200.0n 0.4971 13799.5n 0.4971 13800.0n 0.4975 14399.5n 0.4975 14400.0n 0.4962 14999.5n 0.4962 15000.0n 0.4959 15599.5n 0.4959 15600.0n 0.4964 16199.5n 0.4964 16200.0n 0.4975 16799.5n 0.4975 16800.0n 0.4960 17399.5n 0.4960 17400.0n 0.4971 17999.5n 0.4971 18000.0n 0.4943 18599.5n 0.4943 18600.0n 0.4990 19199.5n 0.4990 19200.0n 0.4959 19799.5n 0.4959 19800.0n 0.4979 20399.5n 0.4979 20400.0n 0.4956 20999.5n 0.4956 21000.0n 0.4944 21599.5n 0.4944 21600.0n 0.4984 22199.5n 0.4984 22200.0n 0.4994 22799.5n 0.4994 22800.0n 0.4959 23399.5n 0.4959 23400.0n 0.4973 23999.5n 0.4973 24000.0n 0.4971 24599.5n 0.4971 24600.0n 0.4994 25199.5n 0.4994 25200.0n 0.4953 25799.5n 0.4953 25800.0n 0.4954 26399.5n 0.4954 26400.0n 0.4961 26999.5n 0.4961 27000.0n 0.4951 27599.5n 0.4951 27600.0n 0.4961 28199.5n 0.4961 28200.0n 0.4983 28799.5n 0.4983 28800.0n 0.4958 29399.5n 0.4958 29400.0n 0.4944 29999.5n 0.4944 30000.0n 0.4949 30599.5n 0.4949 30600.0n 0.4961 31199.5n 0.4961 31200.0n 0.4967 31799.5n 0.4967 31800.0n 0.4951 32399.5n 0.4951 32400.0n 0.4955 32999.5n 0.4955 33000.0n 0.4964 33599.5n 0.4964 33600.0n 0.4958 34199.5n 0.4958 34200.0n 0.4988 34799.5n 0.4988 34800.0n 0.4964 35399.5n 0.4964 35400.0n 0.4958 35999.5n 0.4958)
Cwp_who_17_0 wp_who_17_0 0 400p
Cwn_who_17_0 wn_who_17_0 0 400p
Xu_who_17_0 xp_who_17_0 xn_who_17_0 yp_who_17_0 yn_who_17_0 wp_who_17_0 wn_who_17_0 vdd gbn gprod
Vxp_who_17_1 xp_who_17_1 0 PWL(0.0n 0.3392 599.5n 0.3392 600.0n 0.3343 1199.5n 0.3343 1200.0n 0.3470 1799.5n 0.3470 1800.0n 0.3457 2399.5n 0.3457 2400.0n 0.3421 2999.5n 0.3421 3000.0n 0.3400 3599.5n 0.3400 3600.0n 0.3456 4199.5n 0.3456 4200.0n 0.3396 4799.5n 0.3396 4800.0n 0.3420 5399.5n 0.3420 5400.0n 0.3420 5999.5n 0.3420 6000.0n 0.3475 6599.5n 0.3475 6600.0n 0.3421 7199.5n 0.3421 7200.0n 0.3363 7799.5n 0.3363 7800.0n 0.3363 8399.5n 0.3363 8400.0n 0.3428 8999.5n 0.3428 9000.0n 0.3419 9599.5n 0.3419 9600.0n 0.3415 10199.5n 0.3415 10200.0n 0.3391 10799.5n 0.3391 10800.0n 0.3486 11399.5n 0.3486 11400.0n 0.3418 11999.5n 0.3418 12000.0n 0.3432 12599.5n 0.3432 12600.0n 0.3414 13199.5n 0.3414 13200.0n 0.3383 13799.5n 0.3383 13800.0n 0.3371 14399.5n 0.3371 14400.0n 0.3413 14999.5n 0.3413 15000.0n 0.3412 15599.5n 0.3412 15600.0n 0.3410 16199.5n 0.3410 16200.0n 0.3367 16799.5n 0.3367 16800.0n 0.3437 17399.5n 0.3437 17400.0n 0.3382 17999.5n 0.3382 18000.0n 0.4007 18599.5n 0.4007 18600.0n 0.3283 19199.5n 0.3283 19200.0n 0.3551 19799.5n 0.3551 19800.0n 0.3338 20399.5n 0.3338 20400.0n 0.3781 20999.5n 0.3781 21000.0n 0.3940 21599.5n 0.3940 21600.0n 0.3309 22199.5n 0.3309 22200.0n 0.3274 22799.5n 0.3274 22800.0n 0.3854 23399.5n 0.3854 23400.0n 0.3230 23999.5n 0.3230 24000.0n 0.3395 24599.5n 0.3395 24600.0n 0.3262 25199.5n 0.3262 25200.0n 0.3936 25799.5n 0.3936 25800.0n 0.4432 26399.5n 0.4432 26400.0n 0.4078 26999.5n 0.4078 27000.0n 0.4088 27599.5n 0.4088 27600.0n 0.4054 28199.5n 0.4054 28200.0n 0.3213 28799.5n 0.3213 28800.0n 0.3853 29399.5n 0.3853 29400.0n 0.3881 29999.5n 0.3881 30000.0n 0.3795 30599.5n 0.3795 30600.0n 0.3400 31199.5n 0.3400 31200.0n 0.3334 31799.5n 0.3334 31800.0n 0.4385 32399.5n 0.4385 32400.0n 0.4432 32999.5n 0.4432 33000.0n 0.3491 33599.5n 0.3491 33600.0n 0.3665 34199.5n 0.3665 34200.0n 0.3257 34799.5n 0.3257 34800.0n 0.3651 35399.5n 0.3651 35400.0n 0.3618 35999.5n 0.3618)
Vxn_who_17_1 xn_who_17_1 0 PWL(0.0n 0.6608 599.5n 0.6608 600.0n 0.6657 1199.5n 0.6657 1200.0n 0.6530 1799.5n 0.6530 1800.0n 0.6543 2399.5n 0.6543 2400.0n 0.6579 2999.5n 0.6579 3000.0n 0.6600 3599.5n 0.6600 3600.0n 0.6544 4199.5n 0.6544 4200.0n 0.6604 4799.5n 0.6604 4800.0n 0.6580 5399.5n 0.6580 5400.0n 0.6580 5999.5n 0.6580 6000.0n 0.6525 6599.5n 0.6525 6600.0n 0.6579 7199.5n 0.6579 7200.0n 0.6637 7799.5n 0.6637 7800.0n 0.6637 8399.5n 0.6637 8400.0n 0.6572 8999.5n 0.6572 9000.0n 0.6581 9599.5n 0.6581 9600.0n 0.6585 10199.5n 0.6585 10200.0n 0.6609 10799.5n 0.6609 10800.0n 0.6514 11399.5n 0.6514 11400.0n 0.6582 11999.5n 0.6582 12000.0n 0.6568 12599.5n 0.6568 12600.0n 0.6586 13199.5n 0.6586 13200.0n 0.6617 13799.5n 0.6617 13800.0n 0.6629 14399.5n 0.6629 14400.0n 0.6587 14999.5n 0.6587 15000.0n 0.6588 15599.5n 0.6588 15600.0n 0.6590 16199.5n 0.6590 16200.0n 0.6633 16799.5n 0.6633 16800.0n 0.6563 17399.5n 0.6563 17400.0n 0.6618 17999.5n 0.6618 18000.0n 0.5993 18599.5n 0.5993 18600.0n 0.6717 19199.5n 0.6717 19200.0n 0.6449 19799.5n 0.6449 19800.0n 0.6662 20399.5n 0.6662 20400.0n 0.6219 20999.5n 0.6219 21000.0n 0.6060 21599.5n 0.6060 21600.0n 0.6691 22199.5n 0.6691 22200.0n 0.6726 22799.5n 0.6726 22800.0n 0.6146 23399.5n 0.6146 23400.0n 0.6770 23999.5n 0.6770 24000.0n 0.6605 24599.5n 0.6605 24600.0n 0.6738 25199.5n 0.6738 25200.0n 0.6064 25799.5n 0.6064 25800.0n 0.5568 26399.5n 0.5568 26400.0n 0.5922 26999.5n 0.5922 27000.0n 0.5912 27599.5n 0.5912 27600.0n 0.5946 28199.5n 0.5946 28200.0n 0.6787 28799.5n 0.6787 28800.0n 0.6147 29399.5n 0.6147 29400.0n 0.6119 29999.5n 0.6119 30000.0n 0.6205 30599.5n 0.6205 30600.0n 0.6600 31199.5n 0.6600 31200.0n 0.6666 31799.5n 0.6666 31800.0n 0.5615 32399.5n 0.5615 32400.0n 0.5568 32999.5n 0.5568 33000.0n 0.6509 33599.5n 0.6509 33600.0n 0.6335 34199.5n 0.6335 34200.0n 0.6743 34799.5n 0.6743 34800.0n 0.6349 35399.5n 0.6349 35400.0n 0.6382 35999.5n 0.6382)
Vyp_who_17_1 yp_who_17_1 0 PWL(0.0n 0.5071 599.5n 0.5071 600.0n 0.5053 1199.5n 0.5053 1200.0n 0.5052 1799.5n 0.5052 1800.0n 0.5027 2399.5n 0.5027 2400.0n 0.5034 2999.5n 0.5034 3000.0n 0.5055 3599.5n 0.5055 3600.0n 0.5056 4199.5n 0.5056 4200.0n 0.5071 4799.5n 0.5071 4800.0n 0.5056 5399.5n 0.5056 5400.0n 0.5056 5999.5n 0.5056 6000.0n 0.5048 6599.5n 0.5048 6600.0n 0.5060 7199.5n 0.5060 7200.0n 0.5048 7799.5n 0.5048 7800.0n 0.5046 8399.5n 0.5046 8400.0n 0.5066 8999.5n 0.5066 9000.0n 0.5056 9599.5n 0.5056 9600.0n 0.5051 10199.5n 0.5051 10200.0n 0.5046 10799.5n 0.5046 10800.0n 0.5056 11399.5n 0.5056 11400.0n 0.5058 11999.5n 0.5058 12000.0n 0.5068 12599.5n 0.5068 12600.0n 0.5050 13199.5n 0.5050 13200.0n 0.5071 13799.5n 0.5071 13800.0n 0.5059 14399.5n 0.5059 14400.0n 0.5058 14999.5n 0.5058 15000.0n 0.5043 15599.5n 0.5043 15600.0n 0.5067 16199.5n 0.5067 16200.0n 0.5068 16799.5n 0.5068 16800.0n 0.5066 17399.5n 0.5066 17400.0n 0.5069 17999.5n 0.5069 18000.0n 0.5061 18599.5n 0.5061 18600.0n 0.5034 19199.5n 0.5034 19200.0n 0.5010 19799.5n 0.5010 19800.0n 0.4989 20399.5n 0.4989 20400.0n 0.5022 20999.5n 0.5022 21000.0n 0.5086 21599.5n 0.5086 21600.0n 0.5007 22199.5n 0.5007 22200.0n 0.5023 22799.5n 0.5023 22800.0n 0.5021 23399.5n 0.5021 23400.0n 0.5077 23999.5n 0.5077 24000.0n 0.4979 24599.5n 0.4979 24600.0n 0.5035 25199.5n 0.5035 25200.0n 0.5041 25799.5n 0.5041 25800.0n 0.5075 26399.5n 0.5075 26400.0n 0.5041 26999.5n 0.5041 27000.0n 0.5056 27599.5n 0.5056 27600.0n 0.5039 28199.5n 0.5039 28200.0n 0.5059 28799.5n 0.5059 28800.0n 0.5023 29399.5n 0.5023 29400.0n 0.5086 29999.5n 0.5086 30000.0n 0.5084 30599.5n 0.5084 30600.0n 0.5085 31199.5n 0.5085 31200.0n 0.5088 31799.5n 0.5088 31800.0n 0.5078 32399.5n 0.5078 32400.0n 0.5074 32999.5n 0.5074 33000.0n 0.4996 33599.5n 0.4996 33600.0n 0.5010 34199.5n 0.5010 34200.0n 0.5044 34799.5n 0.5044 34800.0n 0.5084 35399.5n 0.5084 35400.0n 0.5012 35999.5n 0.5012)
Vyn_who_17_1 yn_who_17_1 0 PWL(0.0n 0.4929 599.5n 0.4929 600.0n 0.4947 1199.5n 0.4947 1200.0n 0.4948 1799.5n 0.4948 1800.0n 0.4973 2399.5n 0.4973 2400.0n 0.4966 2999.5n 0.4966 3000.0n 0.4945 3599.5n 0.4945 3600.0n 0.4944 4199.5n 0.4944 4200.0n 0.4929 4799.5n 0.4929 4800.0n 0.4944 5399.5n 0.4944 5400.0n 0.4944 5999.5n 0.4944 6000.0n 0.4952 6599.5n 0.4952 6600.0n 0.4940 7199.5n 0.4940 7200.0n 0.4952 7799.5n 0.4952 7800.0n 0.4954 8399.5n 0.4954 8400.0n 0.4934 8999.5n 0.4934 9000.0n 0.4944 9599.5n 0.4944 9600.0n 0.4949 10199.5n 0.4949 10200.0n 0.4954 10799.5n 0.4954 10800.0n 0.4944 11399.5n 0.4944 11400.0n 0.4942 11999.5n 0.4942 12000.0n 0.4932 12599.5n 0.4932 12600.0n 0.4950 13199.5n 0.4950 13200.0n 0.4929 13799.5n 0.4929 13800.0n 0.4941 14399.5n 0.4941 14400.0n 0.4942 14999.5n 0.4942 15000.0n 0.4957 15599.5n 0.4957 15600.0n 0.4933 16199.5n 0.4933 16200.0n 0.4932 16799.5n 0.4932 16800.0n 0.4934 17399.5n 0.4934 17400.0n 0.4931 17999.5n 0.4931 18000.0n 0.4939 18599.5n 0.4939 18600.0n 0.4966 19199.5n 0.4966 19200.0n 0.4990 19799.5n 0.4990 19800.0n 0.5011 20399.5n 0.5011 20400.0n 0.4978 20999.5n 0.4978 21000.0n 0.4914 21599.5n 0.4914 21600.0n 0.4993 22199.5n 0.4993 22200.0n 0.4977 22799.5n 0.4977 22800.0n 0.4979 23399.5n 0.4979 23400.0n 0.4923 23999.5n 0.4923 24000.0n 0.5021 24599.5n 0.5021 24600.0n 0.4965 25199.5n 0.4965 25200.0n 0.4959 25799.5n 0.4959 25800.0n 0.4925 26399.5n 0.4925 26400.0n 0.4959 26999.5n 0.4959 27000.0n 0.4944 27599.5n 0.4944 27600.0n 0.4961 28199.5n 0.4961 28200.0n 0.4941 28799.5n 0.4941 28800.0n 0.4977 29399.5n 0.4977 29400.0n 0.4914 29999.5n 0.4914 30000.0n 0.4916 30599.5n 0.4916 30600.0n 0.4915 31199.5n 0.4915 31200.0n 0.4912 31799.5n 0.4912 31800.0n 0.4922 32399.5n 0.4922 32400.0n 0.4926 32999.5n 0.4926 33000.0n 0.5004 33599.5n 0.5004 33600.0n 0.4990 34199.5n 0.4990 34200.0n 0.4956 34799.5n 0.4956 34800.0n 0.4916 35399.5n 0.4916 35400.0n 0.4988 35999.5n 0.4988)
Cwp_who_17_1 wp_who_17_1 0 400p
Cwn_who_17_1 wn_who_17_1 0 400p
Xu_who_17_1 xp_who_17_1 xn_who_17_1 yp_who_17_1 yn_who_17_1 wp_who_17_1 wn_who_17_1 vdd gbn gprod
Vxp_bh_17 xp_bh_17 0 PWL(0.0n 0.7100 599.5n 0.7100 600.0n 0.7100 1199.5n 0.7100 1200.0n 0.7100 1799.5n 0.7100 1800.0n 0.7100 2399.5n 0.7100 2400.0n 0.7100 2999.5n 0.7100 3000.0n 0.7100 3599.5n 0.7100 3600.0n 0.7100 4199.5n 0.7100 4200.0n 0.7100 4799.5n 0.7100 4800.0n 0.7100 5399.5n 0.7100 5400.0n 0.7100 5999.5n 0.7100 6000.0n 0.7100 6599.5n 0.7100 6600.0n 0.7100 7199.5n 0.7100 7200.0n 0.7100 7799.5n 0.7100 7800.0n 0.7100 8399.5n 0.7100 8400.0n 0.7100 8999.5n 0.7100 9000.0n 0.7100 9599.5n 0.7100 9600.0n 0.7100 10199.5n 0.7100 10200.0n 0.7100 10799.5n 0.7100 10800.0n 0.7100 11399.5n 0.7100 11400.0n 0.7100 11999.5n 0.7100 12000.0n 0.7100 12599.5n 0.7100 12600.0n 0.7100 13199.5n 0.7100 13200.0n 0.7100 13799.5n 0.7100 13800.0n 0.7100 14399.5n 0.7100 14400.0n 0.7100 14999.5n 0.7100 15000.0n 0.7100 15599.5n 0.7100 15600.0n 0.7100 16199.5n 0.7100 16200.0n 0.7100 16799.5n 0.7100 16800.0n 0.7100 17399.5n 0.7100 17400.0n 0.7100 17999.5n 0.7100 18000.0n 0.7100 18599.5n 0.7100 18600.0n 0.7100 19199.5n 0.7100 19200.0n 0.7100 19799.5n 0.7100 19800.0n 0.7100 20399.5n 0.7100 20400.0n 0.7100 20999.5n 0.7100 21000.0n 0.7100 21599.5n 0.7100 21600.0n 0.7100 22199.5n 0.7100 22200.0n 0.7100 22799.5n 0.7100 22800.0n 0.7100 23399.5n 0.7100 23400.0n 0.7100 23999.5n 0.7100 24000.0n 0.7100 24599.5n 0.7100 24600.0n 0.7100 25199.5n 0.7100 25200.0n 0.7100 25799.5n 0.7100 25800.0n 0.7100 26399.5n 0.7100 26400.0n 0.7100 26999.5n 0.7100 27000.0n 0.7100 27599.5n 0.7100 27600.0n 0.7100 28199.5n 0.7100 28200.0n 0.7100 28799.5n 0.7100 28800.0n 0.7100 29399.5n 0.7100 29400.0n 0.7100 29999.5n 0.7100 30000.0n 0.7100 30599.5n 0.7100 30600.0n 0.7100 31199.5n 0.7100 31200.0n 0.7100 31799.5n 0.7100 31800.0n 0.7100 32399.5n 0.7100 32400.0n 0.7100 32999.5n 0.7100 33000.0n 0.7100 33599.5n 0.7100 33600.0n 0.7100 34199.5n 0.7100 34200.0n 0.7100 34799.5n 0.7100 34800.0n 0.7100 35399.5n 0.7100 35400.0n 0.7100 35999.5n 0.7100)
Vxn_bh_17 xn_bh_17 0 PWL(0.0n 0.2900 599.5n 0.2900 600.0n 0.2900 1199.5n 0.2900 1200.0n 0.2900 1799.5n 0.2900 1800.0n 0.2900 2399.5n 0.2900 2400.0n 0.2900 2999.5n 0.2900 3000.0n 0.2900 3599.5n 0.2900 3600.0n 0.2900 4199.5n 0.2900 4200.0n 0.2900 4799.5n 0.2900 4800.0n 0.2900 5399.5n 0.2900 5400.0n 0.2900 5999.5n 0.2900 6000.0n 0.2900 6599.5n 0.2900 6600.0n 0.2900 7199.5n 0.2900 7200.0n 0.2900 7799.5n 0.2900 7800.0n 0.2900 8399.5n 0.2900 8400.0n 0.2900 8999.5n 0.2900 9000.0n 0.2900 9599.5n 0.2900 9600.0n 0.2900 10199.5n 0.2900 10200.0n 0.2900 10799.5n 0.2900 10800.0n 0.2900 11399.5n 0.2900 11400.0n 0.2900 11999.5n 0.2900 12000.0n 0.2900 12599.5n 0.2900 12600.0n 0.2900 13199.5n 0.2900 13200.0n 0.2900 13799.5n 0.2900 13800.0n 0.2900 14399.5n 0.2900 14400.0n 0.2900 14999.5n 0.2900 15000.0n 0.2900 15599.5n 0.2900 15600.0n 0.2900 16199.5n 0.2900 16200.0n 0.2900 16799.5n 0.2900 16800.0n 0.2900 17399.5n 0.2900 17400.0n 0.2900 17999.5n 0.2900 18000.0n 0.2900 18599.5n 0.2900 18600.0n 0.2900 19199.5n 0.2900 19200.0n 0.2900 19799.5n 0.2900 19800.0n 0.2900 20399.5n 0.2900 20400.0n 0.2900 20999.5n 0.2900 21000.0n 0.2900 21599.5n 0.2900 21600.0n 0.2900 22199.5n 0.2900 22200.0n 0.2900 22799.5n 0.2900 22800.0n 0.2900 23399.5n 0.2900 23400.0n 0.2900 23999.5n 0.2900 24000.0n 0.2900 24599.5n 0.2900 24600.0n 0.2900 25199.5n 0.2900 25200.0n 0.2900 25799.5n 0.2900 25800.0n 0.2900 26399.5n 0.2900 26400.0n 0.2900 26999.5n 0.2900 27000.0n 0.2900 27599.5n 0.2900 27600.0n 0.2900 28199.5n 0.2900 28200.0n 0.2900 28799.5n 0.2900 28800.0n 0.2900 29399.5n 0.2900 29400.0n 0.2900 29999.5n 0.2900 30000.0n 0.2900 30599.5n 0.2900 30600.0n 0.2900 31199.5n 0.2900 31200.0n 0.2900 31799.5n 0.2900 31800.0n 0.2900 32399.5n 0.2900 32400.0n 0.2900 32999.5n 0.2900 33000.0n 0.2900 33599.5n 0.2900 33600.0n 0.2900 34199.5n 0.2900 34200.0n 0.2900 34799.5n 0.2900 34800.0n 0.2900 35399.5n 0.2900 35400.0n 0.2900 35999.5n 0.2900)
Vyp_bh_17 yp_bh_17 0 PWL(0.0n 0.3392 599.5n 0.3392 600.0n 0.3343 1199.5n 0.3343 1200.0n 0.3470 1799.5n 0.3470 1800.0n 0.3457 2399.5n 0.3457 2400.0n 0.3421 2999.5n 0.3421 3000.0n 0.3400 3599.5n 0.3400 3600.0n 0.3456 4199.5n 0.3456 4200.0n 0.3396 4799.5n 0.3396 4800.0n 0.3420 5399.5n 0.3420 5400.0n 0.3420 5999.5n 0.3420 6000.0n 0.3475 6599.5n 0.3475 6600.0n 0.3421 7199.5n 0.3421 7200.0n 0.3363 7799.5n 0.3363 7800.0n 0.3363 8399.5n 0.3363 8400.0n 0.3428 8999.5n 0.3428 9000.0n 0.3419 9599.5n 0.3419 9600.0n 0.3415 10199.5n 0.3415 10200.0n 0.3391 10799.5n 0.3391 10800.0n 0.3486 11399.5n 0.3486 11400.0n 0.3418 11999.5n 0.3418 12000.0n 0.3432 12599.5n 0.3432 12600.0n 0.3414 13199.5n 0.3414 13200.0n 0.3383 13799.5n 0.3383 13800.0n 0.3371 14399.5n 0.3371 14400.0n 0.3413 14999.5n 0.3413 15000.0n 0.3412 15599.5n 0.3412 15600.0n 0.3410 16199.5n 0.3410 16200.0n 0.3367 16799.5n 0.3367 16800.0n 0.3437 17399.5n 0.3437 17400.0n 0.3382 17999.5n 0.3382 18000.0n 0.4007 18599.5n 0.4007 18600.0n 0.3283 19199.5n 0.3283 19200.0n 0.3551 19799.5n 0.3551 19800.0n 0.3338 20399.5n 0.3338 20400.0n 0.3781 20999.5n 0.3781 21000.0n 0.3940 21599.5n 0.3940 21600.0n 0.3309 22199.5n 0.3309 22200.0n 0.3274 22799.5n 0.3274 22800.0n 0.3854 23399.5n 0.3854 23400.0n 0.3230 23999.5n 0.3230 24000.0n 0.3395 24599.5n 0.3395 24600.0n 0.3262 25199.5n 0.3262 25200.0n 0.3936 25799.5n 0.3936 25800.0n 0.4432 26399.5n 0.4432 26400.0n 0.4078 26999.5n 0.4078 27000.0n 0.4088 27599.5n 0.4088 27600.0n 0.4054 28199.5n 0.4054 28200.0n 0.3213 28799.5n 0.3213 28800.0n 0.3853 29399.5n 0.3853 29400.0n 0.3881 29999.5n 0.3881 30000.0n 0.3795 30599.5n 0.3795 30600.0n 0.3400 31199.5n 0.3400 31200.0n 0.3334 31799.5n 0.3334 31800.0n 0.4385 32399.5n 0.4385 32400.0n 0.4432 32999.5n 0.4432 33000.0n 0.3491 33599.5n 0.3491 33600.0n 0.3665 34199.5n 0.3665 34200.0n 0.3257 34799.5n 0.3257 34800.0n 0.3651 35399.5n 0.3651 35400.0n 0.3618 35999.5n 0.3618)
Vyn_bh_17 yn_bh_17 0 PWL(0.0n 0.6608 599.5n 0.6608 600.0n 0.6657 1199.5n 0.6657 1200.0n 0.6530 1799.5n 0.6530 1800.0n 0.6543 2399.5n 0.6543 2400.0n 0.6579 2999.5n 0.6579 3000.0n 0.6600 3599.5n 0.6600 3600.0n 0.6544 4199.5n 0.6544 4200.0n 0.6604 4799.5n 0.6604 4800.0n 0.6580 5399.5n 0.6580 5400.0n 0.6580 5999.5n 0.6580 6000.0n 0.6525 6599.5n 0.6525 6600.0n 0.6579 7199.5n 0.6579 7200.0n 0.6637 7799.5n 0.6637 7800.0n 0.6637 8399.5n 0.6637 8400.0n 0.6572 8999.5n 0.6572 9000.0n 0.6581 9599.5n 0.6581 9600.0n 0.6585 10199.5n 0.6585 10200.0n 0.6609 10799.5n 0.6609 10800.0n 0.6514 11399.5n 0.6514 11400.0n 0.6582 11999.5n 0.6582 12000.0n 0.6568 12599.5n 0.6568 12600.0n 0.6586 13199.5n 0.6586 13200.0n 0.6617 13799.5n 0.6617 13800.0n 0.6629 14399.5n 0.6629 14400.0n 0.6587 14999.5n 0.6587 15000.0n 0.6588 15599.5n 0.6588 15600.0n 0.6590 16199.5n 0.6590 16200.0n 0.6633 16799.5n 0.6633 16800.0n 0.6563 17399.5n 0.6563 17400.0n 0.6618 17999.5n 0.6618 18000.0n 0.5993 18599.5n 0.5993 18600.0n 0.6717 19199.5n 0.6717 19200.0n 0.6449 19799.5n 0.6449 19800.0n 0.6662 20399.5n 0.6662 20400.0n 0.6219 20999.5n 0.6219 21000.0n 0.6060 21599.5n 0.6060 21600.0n 0.6691 22199.5n 0.6691 22200.0n 0.6726 22799.5n 0.6726 22800.0n 0.6146 23399.5n 0.6146 23400.0n 0.6770 23999.5n 0.6770 24000.0n 0.6605 24599.5n 0.6605 24600.0n 0.6738 25199.5n 0.6738 25200.0n 0.6064 25799.5n 0.6064 25800.0n 0.5568 26399.5n 0.5568 26400.0n 0.5922 26999.5n 0.5922 27000.0n 0.5912 27599.5n 0.5912 27600.0n 0.5946 28199.5n 0.5946 28200.0n 0.6787 28799.5n 0.6787 28800.0n 0.6147 29399.5n 0.6147 29400.0n 0.6119 29999.5n 0.6119 30000.0n 0.6205 30599.5n 0.6205 30600.0n 0.6600 31199.5n 0.6600 31200.0n 0.6666 31799.5n 0.6666 31800.0n 0.5615 32399.5n 0.5615 32400.0n 0.5568 32999.5n 0.5568 33000.0n 0.6509 33599.5n 0.6509 33600.0n 0.6335 34199.5n 0.6335 34200.0n 0.6743 34799.5n 0.6743 34800.0n 0.6349 35399.5n 0.6349 35400.0n 0.6382 35999.5n 0.6382)
Cwp_bh_17 wp_bh_17 0 400p
Cwn_bh_17 wn_bh_17 0 400p
Xu_bh_17 xp_bh_17 xn_bh_17 yp_bh_17 yn_bh_17 wp_bh_17 wn_bh_17 vdd gbn gprod
Vxp_wih_0_18 xp_wih_0_18 0 PWL(0.0n 0.4942 599.5n 0.4942 600.0n 0.5558 1199.5n 0.5558 1200.0n 0.4708 1799.5n 0.4708 1800.0n 0.5235 2399.5n 0.5235 2400.0n 0.5350 2999.5n 0.5350 3000.0n 0.5172 3599.5n 0.5172 3600.0n 0.4702 4199.5n 0.4702 4200.0n 0.4867 4799.5n 0.4867 4800.0n 0.4970 5399.5n 0.4970 5400.0n 0.4986 5999.5n 0.4986 6000.0n 0.4751 6599.5n 0.4751 6600.0n 0.4870 7199.5n 0.4870 7200.0n 0.5502 7799.5n 0.5502 7800.0n 0.5521 8399.5n 0.5521 8400.0n 0.4638 8999.5n 0.4638 9000.0n 0.4982 9599.5n 0.4982 9600.0n 0.5131 10199.5n 0.5131 10200.0n 0.5386 10799.5n 0.5386 10800.0n 0.4592 11399.5n 0.4592 11400.0n 0.4950 11999.5n 0.4950 12000.0n 0.4559 12599.5n 0.4559 12600.0n 0.5162 13199.5n 0.5162 13200.0n 0.5038 13799.5n 0.5038 13800.0n 0.5333 14399.5n 0.5333 14400.0n 0.4991 14999.5n 0.4991 15000.0n 0.5298 15599.5n 0.5298 15600.0n 0.4823 16199.5n 0.4823 16200.0n 0.5239 16799.5n 0.5239 16800.0n 0.4592 17399.5n 0.4592 17400.0n 0.5094 17999.5n 0.5094 18000.0n 0.4337 18599.5n 0.4337 18600.0n 0.5977 19199.5n 0.5977 19200.0n 0.5364 19799.5n 0.5364 19800.0n 0.6122 20399.5n 0.6122 20400.0n 0.4856 20999.5n 0.4856 21000.0n 0.3861 21599.5n 0.3861 21600.0n 0.6094 22199.5n 0.6094 22200.0n 0.6364 22799.5n 0.6364 22800.0n 0.4807 23399.5n 0.4807 23400.0n 0.5614 23999.5n 0.5614 24000.0n 0.5913 24599.5n 0.5913 24600.0n 0.6295 25199.5n 0.6295 25200.0n 0.4496 25799.5n 0.4496 25800.0n 0.3792 26399.5n 0.3792 26400.0n 0.4434 26999.5n 0.4434 27000.0n 0.4340 27599.5n 0.4340 27600.0n 0.4461 28199.5n 0.4461 28200.0n 0.5791 28799.5n 0.5791 28800.0n 0.4777 29399.5n 0.4777 29400.0n 0.3878 29999.5n 0.3878 30000.0n 0.3832 30599.5n 0.3832 30600.0n 0.4022 31199.5n 0.4022 31200.0n 0.4482 31799.5n 0.4482 31800.0n 0.3662 32399.5n 0.3662 32400.0n 0.3857 32999.5n 0.3857 33000.0n 0.5584 33599.5n 0.5584 33600.0n 0.5284 34199.5n 0.5284 34200.0n 0.6034 34799.5n 0.6034 34800.0n 0.3469 35399.5n 0.3469 35400.0n 0.5290 35999.5n 0.5290)
Vxn_wih_0_18 xn_wih_0_18 0 PWL(0.0n 0.5058 599.5n 0.5058 600.0n 0.4442 1199.5n 0.4442 1200.0n 0.5292 1799.5n 0.5292 1800.0n 0.4765 2399.5n 0.4765 2400.0n 0.4650 2999.5n 0.4650 3000.0n 0.4828 3599.5n 0.4828 3600.0n 0.5298 4199.5n 0.5298 4200.0n 0.5133 4799.5n 0.5133 4800.0n 0.5030 5399.5n 0.5030 5400.0n 0.5014 5999.5n 0.5014 6000.0n 0.5249 6599.5n 0.5249 6600.0n 0.5130 7199.5n 0.5130 7200.0n 0.4498 7799.5n 0.4498 7800.0n 0.4479 8399.5n 0.4479 8400.0n 0.5362 8999.5n 0.5362 9000.0n 0.5018 9599.5n 0.5018 9600.0n 0.4869 10199.5n 0.4869 10200.0n 0.4614 10799.5n 0.4614 10800.0n 0.5408 11399.5n 0.5408 11400.0n 0.5050 11999.5n 0.5050 12000.0n 0.5441 12599.5n 0.5441 12600.0n 0.4838 13199.5n 0.4838 13200.0n 0.4962 13799.5n 0.4962 13800.0n 0.4667 14399.5n 0.4667 14400.0n 0.5009 14999.5n 0.5009 15000.0n 0.4702 15599.5n 0.4702 15600.0n 0.5177 16199.5n 0.5177 16200.0n 0.4761 16799.5n 0.4761 16800.0n 0.5408 17399.5n 0.5408 17400.0n 0.4906 17999.5n 0.4906 18000.0n 0.5663 18599.5n 0.5663 18600.0n 0.4023 19199.5n 0.4023 19200.0n 0.4636 19799.5n 0.4636 19800.0n 0.3878 20399.5n 0.3878 20400.0n 0.5144 20999.5n 0.5144 21000.0n 0.6139 21599.5n 0.6139 21600.0n 0.3906 22199.5n 0.3906 22200.0n 0.3636 22799.5n 0.3636 22800.0n 0.5193 23399.5n 0.5193 23400.0n 0.4386 23999.5n 0.4386 24000.0n 0.4087 24599.5n 0.4087 24600.0n 0.3705 25199.5n 0.3705 25200.0n 0.5504 25799.5n 0.5504 25800.0n 0.6208 26399.5n 0.6208 26400.0n 0.5566 26999.5n 0.5566 27000.0n 0.5660 27599.5n 0.5660 27600.0n 0.5539 28199.5n 0.5539 28200.0n 0.4209 28799.5n 0.4209 28800.0n 0.5223 29399.5n 0.5223 29400.0n 0.6122 29999.5n 0.6122 30000.0n 0.6168 30599.5n 0.6168 30600.0n 0.5978 31199.5n 0.5978 31200.0n 0.5518 31799.5n 0.5518 31800.0n 0.6338 32399.5n 0.6338 32400.0n 0.6143 32999.5n 0.6143 33000.0n 0.4416 33599.5n 0.4416 33600.0n 0.4716 34199.5n 0.4716 34200.0n 0.3966 34799.5n 0.3966 34800.0n 0.6531 35399.5n 0.6531 35400.0n 0.4710 35999.5n 0.4710)
Vyp_wih_0_18 yp_wih_0_18 0 PWL(0.0n 0.4313 599.5n 0.4313 600.0n 0.4701 1199.5n 0.4701 1200.0n 0.4928 1799.5n 0.4928 1800.0n 0.5577 2399.5n 0.5577 2400.0n 0.5374 2999.5n 0.5374 3000.0n 0.4725 3599.5n 0.4725 3600.0n 0.4766 4199.5n 0.4766 4200.0n 0.4277 4799.5n 0.4277 4800.0n 0.4725 5399.5n 0.4725 5400.0n 0.4736 5999.5n 0.4736 6000.0n 0.5051 6599.5n 0.5051 6600.0n 0.4606 7199.5n 0.4606 7200.0n 0.4854 7799.5n 0.4854 7800.0n 0.4918 8399.5n 0.4918 8400.0n 0.4338 8999.5n 0.4338 9000.0n 0.4727 9599.5n 0.4727 9600.0n 0.4890 10199.5n 0.4890 10200.0n 0.5002 10799.5n 0.5002 10800.0n 0.4868 11399.5n 0.4868 11400.0n 0.4669 11999.5n 0.4669 12000.0n 0.4242 12599.5n 0.4242 12600.0n 0.4923 13199.5n 0.4923 13200.0n 0.4314 13799.5n 0.4314 13800.0n 0.4577 14399.5n 0.4577 14400.0n 0.4653 14999.5n 0.4653 15000.0n 0.5141 15599.5n 0.5141 15600.0n 0.4402 16199.5n 0.4402 16200.0n 0.4366 16799.5n 0.4366 16800.0n 0.4356 17399.5n 0.4356 17400.0n 0.4378 17999.5n 0.4378 18000.0n 0.5731 18599.5n 0.5731 18600.0n 0.4916 19199.5n 0.4916 19200.0n 0.6124 19799.5n 0.6124 19800.0n 0.6070 20399.5n 0.6070 20400.0n 0.6102 20999.5n 0.6102 21000.0n 0.4801 21599.5n 0.4801 21600.0n 0.5641 22199.5n 0.5641 22200.0n 0.5012 22799.5n 0.5012 22800.0n 0.6295 23399.5n 0.6295 23400.0n 0.3477 23999.5n 0.3477 24000.0n 0.6411 24599.5n 0.6411 24600.0n 0.4779 25199.5n 0.4779 25200.0n 0.5960 25799.5n 0.5960 25800.0n 0.5870 26399.5n 0.5870 26400.0n 0.6160 26999.5n 0.6160 27000.0n 0.5897 27599.5n 0.5897 27600.0n 0.6169 28199.5n 0.6169 28200.0n 0.3679 28799.5n 0.3679 28800.0n 0.6177 29399.5n 0.6177 29400.0n 0.4632 29999.5n 0.4632 30000.0n 0.4331 30599.5n 0.4331 30600.0n 0.3356 31199.5n 0.3356 31200.0n 0.3435 31799.5n 0.3435 31800.0n 0.5763 32399.5n 0.5763 32400.0n 0.5896 32999.5n 0.5896 33000.0n 0.6269 33599.5n 0.6269 33600.0n 0.6311 34199.5n 0.6311 34200.0n 0.4538 34799.5n 0.4538 34800.0n 0.3794 35399.5n 0.3794 35400.0n 0.6181 35999.5n 0.6181)
Vyn_wih_0_18 yn_wih_0_18 0 PWL(0.0n 0.5687 599.5n 0.5687 600.0n 0.5299 1199.5n 0.5299 1200.0n 0.5072 1799.5n 0.5072 1800.0n 0.4423 2399.5n 0.4423 2400.0n 0.4626 2999.5n 0.4626 3000.0n 0.5275 3599.5n 0.5275 3600.0n 0.5234 4199.5n 0.5234 4200.0n 0.5723 4799.5n 0.5723 4800.0n 0.5275 5399.5n 0.5275 5400.0n 0.5264 5999.5n 0.5264 6000.0n 0.4949 6599.5n 0.4949 6600.0n 0.5394 7199.5n 0.5394 7200.0n 0.5146 7799.5n 0.5146 7800.0n 0.5082 8399.5n 0.5082 8400.0n 0.5662 8999.5n 0.5662 9000.0n 0.5273 9599.5n 0.5273 9600.0n 0.5110 10199.5n 0.5110 10200.0n 0.4998 10799.5n 0.4998 10800.0n 0.5132 11399.5n 0.5132 11400.0n 0.5331 11999.5n 0.5331 12000.0n 0.5758 12599.5n 0.5758 12600.0n 0.5077 13199.5n 0.5077 13200.0n 0.5686 13799.5n 0.5686 13800.0n 0.5423 14399.5n 0.5423 14400.0n 0.5347 14999.5n 0.5347 15000.0n 0.4859 15599.5n 0.4859 15600.0n 0.5598 16199.5n 0.5598 16200.0n 0.5634 16799.5n 0.5634 16800.0n 0.5644 17399.5n 0.5644 17400.0n 0.5622 17999.5n 0.5622 18000.0n 0.4269 18599.5n 0.4269 18600.0n 0.5084 19199.5n 0.5084 19200.0n 0.3876 19799.5n 0.3876 19800.0n 0.3930 20399.5n 0.3930 20400.0n 0.3898 20999.5n 0.3898 21000.0n 0.5199 21599.5n 0.5199 21600.0n 0.4359 22199.5n 0.4359 22200.0n 0.4988 22799.5n 0.4988 22800.0n 0.3705 23399.5n 0.3705 23400.0n 0.6523 23999.5n 0.6523 24000.0n 0.3589 24599.5n 0.3589 24600.0n 0.5221 25199.5n 0.5221 25200.0n 0.4040 25799.5n 0.4040 25800.0n 0.4130 26399.5n 0.4130 26400.0n 0.3840 26999.5n 0.3840 27000.0n 0.4103 27599.5n 0.4103 27600.0n 0.3831 28199.5n 0.3831 28200.0n 0.6321 28799.5n 0.6321 28800.0n 0.3823 29399.5n 0.3823 29400.0n 0.5368 29999.5n 0.5368 30000.0n 0.5669 30599.5n 0.5669 30600.0n 0.6644 31199.5n 0.6644 31200.0n 0.6565 31799.5n 0.6565 31800.0n 0.4237 32399.5n 0.4237 32400.0n 0.4104 32999.5n 0.4104 33000.0n 0.3731 33599.5n 0.3731 33600.0n 0.3689 34199.5n 0.3689 34200.0n 0.5462 34799.5n 0.5462 34800.0n 0.6206 35399.5n 0.6206 35400.0n 0.3819 35999.5n 0.3819)
Cwp_wih_0_18 wp_wih_0_18 0 400p
Cwn_wih_0_18 wn_wih_0_18 0 400p
Xu_wih_0_18 xp_wih_0_18 xn_wih_0_18 yp_wih_0_18 yn_wih_0_18 wp_wih_0_18 wn_wih_0_18 vdd gbn gprod
Vxp_wih_1_18 xp_wih_1_18 0 PWL(0.0n 0.5370 599.5n 0.5370 600.0n 0.5167 1199.5n 0.5167 1200.0n 0.4793 1799.5n 0.4793 1800.0n 0.4441 2399.5n 0.4441 2400.0n 0.4555 2999.5n 0.4555 3000.0n 0.5055 3599.5n 0.5055 3600.0n 0.4939 4199.5n 0.4939 4200.0n 0.5385 4799.5n 0.5385 4800.0n 0.5024 5399.5n 0.5024 5400.0n 0.5015 5999.5n 0.5015 6000.0n 0.4700 6599.5n 0.4700 6600.0n 0.5120 7199.5n 0.5120 7200.0n 0.5006 7799.5n 0.5006 7800.0n 0.4950 8399.5n 0.4950 8400.0n 0.5309 8999.5n 0.5309 9000.0n 0.5023 9599.5n 0.5023 9600.0n 0.4893 10199.5n 0.4893 10200.0n 0.4837 10799.5n 0.4837 10800.0n 0.4823 11399.5n 0.4823 11400.0n 0.5074 11999.5n 0.5074 12000.0n 0.5364 12599.5n 0.5364 12600.0n 0.4868 13199.5n 0.4868 13200.0n 0.5380 13799.5n 0.5380 13800.0n 0.5220 14399.5n 0.5220 14400.0n 0.5095 14999.5n 0.5095 15000.0n 0.4705 15599.5n 0.4705 15600.0n 0.5289 16199.5n 0.5289 16200.0n 0.5368 16799.5n 0.5368 16800.0n 0.5287 17399.5n 0.5287 17400.0n 0.5342 17999.5n 0.5342 18000.0n 0.4253 18599.5n 0.4253 18600.0n 0.5119 19199.5n 0.5119 19200.0n 0.4104 19799.5n 0.4104 19800.0n 0.4314 20399.5n 0.4314 20400.0n 0.4005 20999.5n 0.4005 21000.0n 0.4696 21599.5n 0.4696 21600.0n 0.4531 22199.5n 0.4531 22200.0n 0.5039 22799.5n 0.5039 22800.0n 0.3608 23399.5n 0.3608 23400.0n 0.6273 23999.5n 0.6273 24000.0n 0.3928 24599.5n 0.3928 24600.0n 0.5253 25199.5n 0.5253 25200.0n 0.4107 25799.5n 0.4107 25800.0n 0.3947 26399.5n 0.3947 26400.0n 0.3716 26999.5n 0.3716 27000.0n 0.4111 27599.5n 0.4111 27600.0n 0.3715 28199.5n 0.3715 28200.0n 0.5939 28799.5n 0.5939 28800.0n 0.3849 29399.5n 0.3849 29400.0n 0.4835 29999.5n 0.4835 30000.0n 0.5119 30599.5n 0.5119 30600.0n 0.6226 31199.5n 0.6226 31200.0n 0.6064 31799.5n 0.6064 31800.0n 0.4115 32399.5n 0.4115 32400.0n 0.3900 32999.5n 0.3900 33000.0n 0.3958 33599.5n 0.3958 33600.0n 0.3747 34199.5n 0.3747 34200.0n 0.5423 34799.5n 0.5423 34800.0n 0.5509 35399.5n 0.5509 35400.0n 0.3990 35999.5n 0.3990)
Vxn_wih_1_18 xn_wih_1_18 0 PWL(0.0n 0.4630 599.5n 0.4630 600.0n 0.4833 1199.5n 0.4833 1200.0n 0.5207 1799.5n 0.5207 1800.0n 0.5559 2399.5n 0.5559 2400.0n 0.5445 2999.5n 0.5445 3000.0n 0.4945 3599.5n 0.4945 3600.0n 0.5061 4199.5n 0.5061 4200.0n 0.4615 4799.5n 0.4615 4800.0n 0.4976 5399.5n 0.4976 5400.0n 0.4985 5999.5n 0.4985 6000.0n 0.5300 6599.5n 0.5300 6600.0n 0.4880 7199.5n 0.4880 7200.0n 0.4994 7799.5n 0.4994 7800.0n 0.5050 8399.5n 0.5050 8400.0n 0.4691 8999.5n 0.4691 9000.0n 0.4977 9599.5n 0.4977 9600.0n 0.5107 10199.5n 0.5107 10200.0n 0.5163 10799.5n 0.5163 10800.0n 0.5177 11399.5n 0.5177 11400.0n 0.4926 11999.5n 0.4926 12000.0n 0.4636 12599.5n 0.4636 12600.0n 0.5132 13199.5n 0.5132 13200.0n 0.4620 13799.5n 0.4620 13800.0n 0.4780 14399.5n 0.4780 14400.0n 0.4905 14999.5n 0.4905 15000.0n 0.5295 15599.5n 0.5295 15600.0n 0.4711 16199.5n 0.4711 16200.0n 0.4632 16799.5n 0.4632 16800.0n 0.4713 17399.5n 0.4713 17400.0n 0.4658 17999.5n 0.4658 18000.0n 0.5747 18599.5n 0.5747 18600.0n 0.4881 19199.5n 0.4881 19200.0n 0.5896 19799.5n 0.5896 19800.0n 0.5686 20399.5n 0.5686 20400.0n 0.5995 20999.5n 0.5995 21000.0n 0.5304 21599.5n 0.5304 21600.0n 0.5469 22199.5n 0.5469 22200.0n 0.4961 22799.5n 0.4961 22800.0n 0.6392 23399.5n 0.6392 23400.0n 0.3727 23999.5n 0.3727 24000.0n 0.6072 24599.5n 0.6072 24600.0n 0.4747 25199.5n 0.4747 25200.0n 0.5893 25799.5n 0.5893 25800.0n 0.6053 26399.5n 0.6053 26400.0n 0.6284 26999.5n 0.6284 27000.0n 0.5889 27599.5n 0.5889 27600.0n 0.6285 28199.5n 0.6285 28200.0n 0.4061 28799.5n 0.4061 28800.0n 0.6151 29399.5n 0.6151 29400.0n 0.5165 29999.5n 0.5165 30000.0n 0.4881 30599.5n 0.4881 30600.0n 0.3774 31199.5n 0.3774 31200.0n 0.3936 31799.5n 0.3936 31800.0n 0.5885 32399.5n 0.5885 32400.0n 0.6100 32999.5n 0.6100 33000.0n 0.6042 33599.5n 0.6042 33600.0n 0.6253 34199.5n 0.6253 34200.0n 0.4577 34799.5n 0.4577 34800.0n 0.4491 35399.5n 0.4491 35400.0n 0.6010 35999.5n 0.6010)
Vyp_wih_1_18 yp_wih_1_18 0 PWL(0.0n 0.4313 599.5n 0.4313 600.0n 0.4701 1199.5n 0.4701 1200.0n 0.4928 1799.5n 0.4928 1800.0n 0.5577 2399.5n 0.5577 2400.0n 0.5374 2999.5n 0.5374 3000.0n 0.4725 3599.5n 0.4725 3600.0n 0.4766 4199.5n 0.4766 4200.0n 0.4277 4799.5n 0.4277 4800.0n 0.4725 5399.5n 0.4725 5400.0n 0.4736 5999.5n 0.4736 6000.0n 0.5051 6599.5n 0.5051 6600.0n 0.4606 7199.5n 0.4606 7200.0n 0.4854 7799.5n 0.4854 7800.0n 0.4918 8399.5n 0.4918 8400.0n 0.4338 8999.5n 0.4338 9000.0n 0.4727 9599.5n 0.4727 9600.0n 0.4890 10199.5n 0.4890 10200.0n 0.5002 10799.5n 0.5002 10800.0n 0.4868 11399.5n 0.4868 11400.0n 0.4669 11999.5n 0.4669 12000.0n 0.4242 12599.5n 0.4242 12600.0n 0.4923 13199.5n 0.4923 13200.0n 0.4314 13799.5n 0.4314 13800.0n 0.4577 14399.5n 0.4577 14400.0n 0.4653 14999.5n 0.4653 15000.0n 0.5141 15599.5n 0.5141 15600.0n 0.4402 16199.5n 0.4402 16200.0n 0.4366 16799.5n 0.4366 16800.0n 0.4356 17399.5n 0.4356 17400.0n 0.4378 17999.5n 0.4378 18000.0n 0.5731 18599.5n 0.5731 18600.0n 0.4916 19199.5n 0.4916 19200.0n 0.6124 19799.5n 0.6124 19800.0n 0.6070 20399.5n 0.6070 20400.0n 0.6102 20999.5n 0.6102 21000.0n 0.4801 21599.5n 0.4801 21600.0n 0.5641 22199.5n 0.5641 22200.0n 0.5012 22799.5n 0.5012 22800.0n 0.6295 23399.5n 0.6295 23400.0n 0.3477 23999.5n 0.3477 24000.0n 0.6411 24599.5n 0.6411 24600.0n 0.4779 25199.5n 0.4779 25200.0n 0.5960 25799.5n 0.5960 25800.0n 0.5870 26399.5n 0.5870 26400.0n 0.6160 26999.5n 0.6160 27000.0n 0.5897 27599.5n 0.5897 27600.0n 0.6169 28199.5n 0.6169 28200.0n 0.3679 28799.5n 0.3679 28800.0n 0.6177 29399.5n 0.6177 29400.0n 0.4632 29999.5n 0.4632 30000.0n 0.4331 30599.5n 0.4331 30600.0n 0.3356 31199.5n 0.3356 31200.0n 0.3435 31799.5n 0.3435 31800.0n 0.5763 32399.5n 0.5763 32400.0n 0.5896 32999.5n 0.5896 33000.0n 0.6269 33599.5n 0.6269 33600.0n 0.6311 34199.5n 0.6311 34200.0n 0.4538 34799.5n 0.4538 34800.0n 0.3794 35399.5n 0.3794 35400.0n 0.6181 35999.5n 0.6181)
Vyn_wih_1_18 yn_wih_1_18 0 PWL(0.0n 0.5687 599.5n 0.5687 600.0n 0.5299 1199.5n 0.5299 1200.0n 0.5072 1799.5n 0.5072 1800.0n 0.4423 2399.5n 0.4423 2400.0n 0.4626 2999.5n 0.4626 3000.0n 0.5275 3599.5n 0.5275 3600.0n 0.5234 4199.5n 0.5234 4200.0n 0.5723 4799.5n 0.5723 4800.0n 0.5275 5399.5n 0.5275 5400.0n 0.5264 5999.5n 0.5264 6000.0n 0.4949 6599.5n 0.4949 6600.0n 0.5394 7199.5n 0.5394 7200.0n 0.5146 7799.5n 0.5146 7800.0n 0.5082 8399.5n 0.5082 8400.0n 0.5662 8999.5n 0.5662 9000.0n 0.5273 9599.5n 0.5273 9600.0n 0.5110 10199.5n 0.5110 10200.0n 0.4998 10799.5n 0.4998 10800.0n 0.5132 11399.5n 0.5132 11400.0n 0.5331 11999.5n 0.5331 12000.0n 0.5758 12599.5n 0.5758 12600.0n 0.5077 13199.5n 0.5077 13200.0n 0.5686 13799.5n 0.5686 13800.0n 0.5423 14399.5n 0.5423 14400.0n 0.5347 14999.5n 0.5347 15000.0n 0.4859 15599.5n 0.4859 15600.0n 0.5598 16199.5n 0.5598 16200.0n 0.5634 16799.5n 0.5634 16800.0n 0.5644 17399.5n 0.5644 17400.0n 0.5622 17999.5n 0.5622 18000.0n 0.4269 18599.5n 0.4269 18600.0n 0.5084 19199.5n 0.5084 19200.0n 0.3876 19799.5n 0.3876 19800.0n 0.3930 20399.5n 0.3930 20400.0n 0.3898 20999.5n 0.3898 21000.0n 0.5199 21599.5n 0.5199 21600.0n 0.4359 22199.5n 0.4359 22200.0n 0.4988 22799.5n 0.4988 22800.0n 0.3705 23399.5n 0.3705 23400.0n 0.6523 23999.5n 0.6523 24000.0n 0.3589 24599.5n 0.3589 24600.0n 0.5221 25199.5n 0.5221 25200.0n 0.4040 25799.5n 0.4040 25800.0n 0.4130 26399.5n 0.4130 26400.0n 0.3840 26999.5n 0.3840 27000.0n 0.4103 27599.5n 0.4103 27600.0n 0.3831 28199.5n 0.3831 28200.0n 0.6321 28799.5n 0.6321 28800.0n 0.3823 29399.5n 0.3823 29400.0n 0.5368 29999.5n 0.5368 30000.0n 0.5669 30599.5n 0.5669 30600.0n 0.6644 31199.5n 0.6644 31200.0n 0.6565 31799.5n 0.6565 31800.0n 0.4237 32399.5n 0.4237 32400.0n 0.4104 32999.5n 0.4104 33000.0n 0.3731 33599.5n 0.3731 33600.0n 0.3689 34199.5n 0.3689 34200.0n 0.5462 34799.5n 0.5462 34800.0n 0.6206 35399.5n 0.6206 35400.0n 0.3819 35999.5n 0.3819)
Cwp_wih_1_18 wp_wih_1_18 0 400p
Cwn_wih_1_18 wn_wih_1_18 0 400p
Xu_wih_1_18 xp_wih_1_18 xn_wih_1_18 yp_wih_1_18 yn_wih_1_18 wp_wih_1_18 wn_wih_1_18 vdd gbn gprod
Vxp_who_18_0 xp_who_18_0 0 PWL(0.0n 0.4313 599.5n 0.4313 600.0n 0.4701 1199.5n 0.4701 1200.0n 0.4928 1799.5n 0.4928 1800.0n 0.5577 2399.5n 0.5577 2400.0n 0.5374 2999.5n 0.5374 3000.0n 0.4725 3599.5n 0.4725 3600.0n 0.4766 4199.5n 0.4766 4200.0n 0.4277 4799.5n 0.4277 4800.0n 0.4725 5399.5n 0.4725 5400.0n 0.4736 5999.5n 0.4736 6000.0n 0.5051 6599.5n 0.5051 6600.0n 0.4606 7199.5n 0.4606 7200.0n 0.4854 7799.5n 0.4854 7800.0n 0.4918 8399.5n 0.4918 8400.0n 0.4338 8999.5n 0.4338 9000.0n 0.4727 9599.5n 0.4727 9600.0n 0.4890 10199.5n 0.4890 10200.0n 0.5002 10799.5n 0.5002 10800.0n 0.4868 11399.5n 0.4868 11400.0n 0.4669 11999.5n 0.4669 12000.0n 0.4242 12599.5n 0.4242 12600.0n 0.4923 13199.5n 0.4923 13200.0n 0.4314 13799.5n 0.4314 13800.0n 0.4577 14399.5n 0.4577 14400.0n 0.4653 14999.5n 0.4653 15000.0n 0.5141 15599.5n 0.5141 15600.0n 0.4402 16199.5n 0.4402 16200.0n 0.4366 16799.5n 0.4366 16800.0n 0.4356 17399.5n 0.4356 17400.0n 0.4378 17999.5n 0.4378 18000.0n 0.5731 18599.5n 0.5731 18600.0n 0.4916 19199.5n 0.4916 19200.0n 0.6124 19799.5n 0.6124 19800.0n 0.6070 20399.5n 0.6070 20400.0n 0.6102 20999.5n 0.6102 21000.0n 0.4801 21599.5n 0.4801 21600.0n 0.5641 22199.5n 0.5641 22200.0n 0.5012 22799.5n 0.5012 22800.0n 0.6295 23399.5n 0.6295 23400.0n 0.3477 23999.5n 0.3477 24000.0n 0.6411 24599.5n 0.6411 24600.0n 0.4779 25199.5n 0.4779 25200.0n 0.5960 25799.5n 0.5960 25800.0n 0.5870 26399.5n 0.5870 26400.0n 0.6160 26999.5n 0.6160 27000.0n 0.5897 27599.5n 0.5897 27600.0n 0.6169 28199.5n 0.6169 28200.0n 0.3679 28799.5n 0.3679 28800.0n 0.6177 29399.5n 0.6177 29400.0n 0.4632 29999.5n 0.4632 30000.0n 0.4331 30599.5n 0.4331 30600.0n 0.3356 31199.5n 0.3356 31200.0n 0.3435 31799.5n 0.3435 31800.0n 0.5763 32399.5n 0.5763 32400.0n 0.5896 32999.5n 0.5896 33000.0n 0.6269 33599.5n 0.6269 33600.0n 0.6311 34199.5n 0.6311 34200.0n 0.4538 34799.5n 0.4538 34800.0n 0.3794 35399.5n 0.3794 35400.0n 0.6181 35999.5n 0.6181)
Vxn_who_18_0 xn_who_18_0 0 PWL(0.0n 0.5687 599.5n 0.5687 600.0n 0.5299 1199.5n 0.5299 1200.0n 0.5072 1799.5n 0.5072 1800.0n 0.4423 2399.5n 0.4423 2400.0n 0.4626 2999.5n 0.4626 3000.0n 0.5275 3599.5n 0.5275 3600.0n 0.5234 4199.5n 0.5234 4200.0n 0.5723 4799.5n 0.5723 4800.0n 0.5275 5399.5n 0.5275 5400.0n 0.5264 5999.5n 0.5264 6000.0n 0.4949 6599.5n 0.4949 6600.0n 0.5394 7199.5n 0.5394 7200.0n 0.5146 7799.5n 0.5146 7800.0n 0.5082 8399.5n 0.5082 8400.0n 0.5662 8999.5n 0.5662 9000.0n 0.5273 9599.5n 0.5273 9600.0n 0.5110 10199.5n 0.5110 10200.0n 0.4998 10799.5n 0.4998 10800.0n 0.5132 11399.5n 0.5132 11400.0n 0.5331 11999.5n 0.5331 12000.0n 0.5758 12599.5n 0.5758 12600.0n 0.5077 13199.5n 0.5077 13200.0n 0.5686 13799.5n 0.5686 13800.0n 0.5423 14399.5n 0.5423 14400.0n 0.5347 14999.5n 0.5347 15000.0n 0.4859 15599.5n 0.4859 15600.0n 0.5598 16199.5n 0.5598 16200.0n 0.5634 16799.5n 0.5634 16800.0n 0.5644 17399.5n 0.5644 17400.0n 0.5622 17999.5n 0.5622 18000.0n 0.4269 18599.5n 0.4269 18600.0n 0.5084 19199.5n 0.5084 19200.0n 0.3876 19799.5n 0.3876 19800.0n 0.3930 20399.5n 0.3930 20400.0n 0.3898 20999.5n 0.3898 21000.0n 0.5199 21599.5n 0.5199 21600.0n 0.4359 22199.5n 0.4359 22200.0n 0.4988 22799.5n 0.4988 22800.0n 0.3705 23399.5n 0.3705 23400.0n 0.6523 23999.5n 0.6523 24000.0n 0.3589 24599.5n 0.3589 24600.0n 0.5221 25199.5n 0.5221 25200.0n 0.4040 25799.5n 0.4040 25800.0n 0.4130 26399.5n 0.4130 26400.0n 0.3840 26999.5n 0.3840 27000.0n 0.4103 27599.5n 0.4103 27600.0n 0.3831 28199.5n 0.3831 28200.0n 0.6321 28799.5n 0.6321 28800.0n 0.3823 29399.5n 0.3823 29400.0n 0.5368 29999.5n 0.5368 30000.0n 0.5669 30599.5n 0.5669 30600.0n 0.6644 31199.5n 0.6644 31200.0n 0.6565 31799.5n 0.6565 31800.0n 0.4237 32399.5n 0.4237 32400.0n 0.4104 32999.5n 0.4104 33000.0n 0.3731 33599.5n 0.3731 33600.0n 0.3689 34199.5n 0.3689 34200.0n 0.5462 34799.5n 0.5462 34800.0n 0.6206 35399.5n 0.6206 35400.0n 0.3819 35999.5n 0.3819)
Vyp_who_18_0 yp_who_18_0 0 PWL(0.0n 0.5031 599.5n 0.5031 600.0n 0.5023 1199.5n 0.5023 1200.0n 0.5052 1799.5n 0.5052 1800.0n 0.5048 2399.5n 0.5048 2400.0n 0.5043 2999.5n 0.5043 3000.0n 0.5034 3599.5n 0.5034 3600.0n 0.5048 4199.5n 0.5048 4200.0n 0.5031 4799.5n 0.5031 4800.0n 0.5040 5399.5n 0.5040 5400.0n 0.5040 5999.5n 0.5040 6000.0n 0.5054 6599.5n 0.5054 6600.0n 0.5040 7199.5n 0.5040 7200.0n 0.5027 7799.5n 0.5027 7800.0n 0.5027 8399.5n 0.5027 8400.0n 0.5038 8999.5n 0.5038 9000.0n 0.5040 9599.5n 0.5040 9600.0n 0.5039 10199.5n 0.5039 10200.0n 0.5033 10799.5n 0.5033 10800.0n 0.5056 11399.5n 0.5056 11400.0n 0.5040 11999.5n 0.5040 12000.0n 0.5036 12599.5n 0.5036 12600.0n 0.5039 13199.5n 0.5039 13200.0n 0.5029 13799.5n 0.5029 13800.0n 0.5025 14399.5n 0.5025 14400.0n 0.5038 14999.5n 0.5038 15000.0n 0.5041 15599.5n 0.5041 15600.0n 0.5036 16199.5n 0.5036 16200.0n 0.5025 16799.5n 0.5025 16800.0n 0.5040 17399.5n 0.5040 17400.0n 0.5029 17999.5n 0.5029 18000.0n 0.5057 18599.5n 0.5057 18600.0n 0.5010 19199.5n 0.5010 19200.0n 0.5041 19799.5n 0.5041 19800.0n 0.5021 20399.5n 0.5021 20400.0n 0.5044 20999.5n 0.5044 21000.0n 0.5056 21599.5n 0.5056 21600.0n 0.5016 22199.5n 0.5016 22200.0n 0.5006 22799.5n 0.5006 22800.0n 0.5041 23399.5n 0.5041 23400.0n 0.5027 23999.5n 0.5027 24000.0n 0.5029 24599.5n 0.5029 24600.0n 0.5006 25199.5n 0.5006 25200.0n 0.5047 25799.5n 0.5047 25800.0n 0.5046 26399.5n 0.5046 26400.0n 0.5039 26999.5n 0.5039 27000.0n 0.5049 27599.5n 0.5049 27600.0n 0.5039 28199.5n 0.5039 28200.0n 0.5017 28799.5n 0.5017 28800.0n 0.5042 29399.5n 0.5042 29400.0n 0.5056 29999.5n 0.5056 30000.0n 0.5051 30599.5n 0.5051 30600.0n 0.5039 31199.5n 0.5039 31200.0n 0.5033 31799.5n 0.5033 31800.0n 0.5049 32399.5n 0.5049 32400.0n 0.5045 32999.5n 0.5045 33000.0n 0.5036 33599.5n 0.5036 33600.0n 0.5042 34199.5n 0.5042 34200.0n 0.5012 34799.5n 0.5012 34800.0n 0.5036 35399.5n 0.5036 35400.0n 0.5042 35999.5n 0.5042)
Vyn_who_18_0 yn_who_18_0 0 PWL(0.0n 0.4969 599.5n 0.4969 600.0n 0.4977 1199.5n 0.4977 1200.0n 0.4948 1799.5n 0.4948 1800.0n 0.4952 2399.5n 0.4952 2400.0n 0.4957 2999.5n 0.4957 3000.0n 0.4966 3599.5n 0.4966 3600.0n 0.4952 4199.5n 0.4952 4200.0n 0.4969 4799.5n 0.4969 4800.0n 0.4960 5399.5n 0.4960 5400.0n 0.4960 5999.5n 0.4960 6000.0n 0.4946 6599.5n 0.4946 6600.0n 0.4960 7199.5n 0.4960 7200.0n 0.4973 7799.5n 0.4973 7800.0n 0.4973 8399.5n 0.4973 8400.0n 0.4962 8999.5n 0.4962 9000.0n 0.4960 9599.5n 0.4960 9600.0n 0.4961 10199.5n 0.4961 10200.0n 0.4967 10799.5n 0.4967 10800.0n 0.4944 11399.5n 0.4944 11400.0n 0.4960 11999.5n 0.4960 12000.0n 0.4964 12599.5n 0.4964 12600.0n 0.4961 13199.5n 0.4961 13200.0n 0.4971 13799.5n 0.4971 13800.0n 0.4975 14399.5n 0.4975 14400.0n 0.4962 14999.5n 0.4962 15000.0n 0.4959 15599.5n 0.4959 15600.0n 0.4964 16199.5n 0.4964 16200.0n 0.4975 16799.5n 0.4975 16800.0n 0.4960 17399.5n 0.4960 17400.0n 0.4971 17999.5n 0.4971 18000.0n 0.4943 18599.5n 0.4943 18600.0n 0.4990 19199.5n 0.4990 19200.0n 0.4959 19799.5n 0.4959 19800.0n 0.4979 20399.5n 0.4979 20400.0n 0.4956 20999.5n 0.4956 21000.0n 0.4944 21599.5n 0.4944 21600.0n 0.4984 22199.5n 0.4984 22200.0n 0.4994 22799.5n 0.4994 22800.0n 0.4959 23399.5n 0.4959 23400.0n 0.4973 23999.5n 0.4973 24000.0n 0.4971 24599.5n 0.4971 24600.0n 0.4994 25199.5n 0.4994 25200.0n 0.4953 25799.5n 0.4953 25800.0n 0.4954 26399.5n 0.4954 26400.0n 0.4961 26999.5n 0.4961 27000.0n 0.4951 27599.5n 0.4951 27600.0n 0.4961 28199.5n 0.4961 28200.0n 0.4983 28799.5n 0.4983 28800.0n 0.4958 29399.5n 0.4958 29400.0n 0.4944 29999.5n 0.4944 30000.0n 0.4949 30599.5n 0.4949 30600.0n 0.4961 31199.5n 0.4961 31200.0n 0.4967 31799.5n 0.4967 31800.0n 0.4951 32399.5n 0.4951 32400.0n 0.4955 32999.5n 0.4955 33000.0n 0.4964 33599.5n 0.4964 33600.0n 0.4958 34199.5n 0.4958 34200.0n 0.4988 34799.5n 0.4988 34800.0n 0.4964 35399.5n 0.4964 35400.0n 0.4958 35999.5n 0.4958)
Cwp_who_18_0 wp_who_18_0 0 400p
Cwn_who_18_0 wn_who_18_0 0 400p
Xu_who_18_0 xp_who_18_0 xn_who_18_0 yp_who_18_0 yn_who_18_0 wp_who_18_0 wn_who_18_0 vdd gbn gprod
Vxp_who_18_1 xp_who_18_1 0 PWL(0.0n 0.4313 599.5n 0.4313 600.0n 0.4701 1199.5n 0.4701 1200.0n 0.4928 1799.5n 0.4928 1800.0n 0.5577 2399.5n 0.5577 2400.0n 0.5374 2999.5n 0.5374 3000.0n 0.4725 3599.5n 0.4725 3600.0n 0.4766 4199.5n 0.4766 4200.0n 0.4277 4799.5n 0.4277 4800.0n 0.4725 5399.5n 0.4725 5400.0n 0.4736 5999.5n 0.4736 6000.0n 0.5051 6599.5n 0.5051 6600.0n 0.4606 7199.5n 0.4606 7200.0n 0.4854 7799.5n 0.4854 7800.0n 0.4918 8399.5n 0.4918 8400.0n 0.4338 8999.5n 0.4338 9000.0n 0.4727 9599.5n 0.4727 9600.0n 0.4890 10199.5n 0.4890 10200.0n 0.5002 10799.5n 0.5002 10800.0n 0.4868 11399.5n 0.4868 11400.0n 0.4669 11999.5n 0.4669 12000.0n 0.4242 12599.5n 0.4242 12600.0n 0.4923 13199.5n 0.4923 13200.0n 0.4314 13799.5n 0.4314 13800.0n 0.4577 14399.5n 0.4577 14400.0n 0.4653 14999.5n 0.4653 15000.0n 0.5141 15599.5n 0.5141 15600.0n 0.4402 16199.5n 0.4402 16200.0n 0.4366 16799.5n 0.4366 16800.0n 0.4356 17399.5n 0.4356 17400.0n 0.4378 17999.5n 0.4378 18000.0n 0.5731 18599.5n 0.5731 18600.0n 0.4916 19199.5n 0.4916 19200.0n 0.6124 19799.5n 0.6124 19800.0n 0.6070 20399.5n 0.6070 20400.0n 0.6102 20999.5n 0.6102 21000.0n 0.4801 21599.5n 0.4801 21600.0n 0.5641 22199.5n 0.5641 22200.0n 0.5012 22799.5n 0.5012 22800.0n 0.6295 23399.5n 0.6295 23400.0n 0.3477 23999.5n 0.3477 24000.0n 0.6411 24599.5n 0.6411 24600.0n 0.4779 25199.5n 0.4779 25200.0n 0.5960 25799.5n 0.5960 25800.0n 0.5870 26399.5n 0.5870 26400.0n 0.6160 26999.5n 0.6160 27000.0n 0.5897 27599.5n 0.5897 27600.0n 0.6169 28199.5n 0.6169 28200.0n 0.3679 28799.5n 0.3679 28800.0n 0.6177 29399.5n 0.6177 29400.0n 0.4632 29999.5n 0.4632 30000.0n 0.4331 30599.5n 0.4331 30600.0n 0.3356 31199.5n 0.3356 31200.0n 0.3435 31799.5n 0.3435 31800.0n 0.5763 32399.5n 0.5763 32400.0n 0.5896 32999.5n 0.5896 33000.0n 0.6269 33599.5n 0.6269 33600.0n 0.6311 34199.5n 0.6311 34200.0n 0.4538 34799.5n 0.4538 34800.0n 0.3794 35399.5n 0.3794 35400.0n 0.6181 35999.5n 0.6181)
Vxn_who_18_1 xn_who_18_1 0 PWL(0.0n 0.5687 599.5n 0.5687 600.0n 0.5299 1199.5n 0.5299 1200.0n 0.5072 1799.5n 0.5072 1800.0n 0.4423 2399.5n 0.4423 2400.0n 0.4626 2999.5n 0.4626 3000.0n 0.5275 3599.5n 0.5275 3600.0n 0.5234 4199.5n 0.5234 4200.0n 0.5723 4799.5n 0.5723 4800.0n 0.5275 5399.5n 0.5275 5400.0n 0.5264 5999.5n 0.5264 6000.0n 0.4949 6599.5n 0.4949 6600.0n 0.5394 7199.5n 0.5394 7200.0n 0.5146 7799.5n 0.5146 7800.0n 0.5082 8399.5n 0.5082 8400.0n 0.5662 8999.5n 0.5662 9000.0n 0.5273 9599.5n 0.5273 9600.0n 0.5110 10199.5n 0.5110 10200.0n 0.4998 10799.5n 0.4998 10800.0n 0.5132 11399.5n 0.5132 11400.0n 0.5331 11999.5n 0.5331 12000.0n 0.5758 12599.5n 0.5758 12600.0n 0.5077 13199.5n 0.5077 13200.0n 0.5686 13799.5n 0.5686 13800.0n 0.5423 14399.5n 0.5423 14400.0n 0.5347 14999.5n 0.5347 15000.0n 0.4859 15599.5n 0.4859 15600.0n 0.5598 16199.5n 0.5598 16200.0n 0.5634 16799.5n 0.5634 16800.0n 0.5644 17399.5n 0.5644 17400.0n 0.5622 17999.5n 0.5622 18000.0n 0.4269 18599.5n 0.4269 18600.0n 0.5084 19199.5n 0.5084 19200.0n 0.3876 19799.5n 0.3876 19800.0n 0.3930 20399.5n 0.3930 20400.0n 0.3898 20999.5n 0.3898 21000.0n 0.5199 21599.5n 0.5199 21600.0n 0.4359 22199.5n 0.4359 22200.0n 0.4988 22799.5n 0.4988 22800.0n 0.3705 23399.5n 0.3705 23400.0n 0.6523 23999.5n 0.6523 24000.0n 0.3589 24599.5n 0.3589 24600.0n 0.5221 25199.5n 0.5221 25200.0n 0.4040 25799.5n 0.4040 25800.0n 0.4130 26399.5n 0.4130 26400.0n 0.3840 26999.5n 0.3840 27000.0n 0.4103 27599.5n 0.4103 27600.0n 0.3831 28199.5n 0.3831 28200.0n 0.6321 28799.5n 0.6321 28800.0n 0.3823 29399.5n 0.3823 29400.0n 0.5368 29999.5n 0.5368 30000.0n 0.5669 30599.5n 0.5669 30600.0n 0.6644 31199.5n 0.6644 31200.0n 0.6565 31799.5n 0.6565 31800.0n 0.4237 32399.5n 0.4237 32400.0n 0.4104 32999.5n 0.4104 33000.0n 0.3731 33599.5n 0.3731 33600.0n 0.3689 34199.5n 0.3689 34200.0n 0.5462 34799.5n 0.5462 34800.0n 0.6206 35399.5n 0.6206 35400.0n 0.3819 35999.5n 0.3819)
Vyp_who_18_1 yp_who_18_1 0 PWL(0.0n 0.5071 599.5n 0.5071 600.0n 0.5053 1199.5n 0.5053 1200.0n 0.5052 1799.5n 0.5052 1800.0n 0.5027 2399.5n 0.5027 2400.0n 0.5034 2999.5n 0.5034 3000.0n 0.5055 3599.5n 0.5055 3600.0n 0.5056 4199.5n 0.5056 4200.0n 0.5071 4799.5n 0.5071 4800.0n 0.5056 5399.5n 0.5056 5400.0n 0.5056 5999.5n 0.5056 6000.0n 0.5048 6599.5n 0.5048 6600.0n 0.5060 7199.5n 0.5060 7200.0n 0.5048 7799.5n 0.5048 7800.0n 0.5046 8399.5n 0.5046 8400.0n 0.5066 8999.5n 0.5066 9000.0n 0.5056 9599.5n 0.5056 9600.0n 0.5051 10199.5n 0.5051 10200.0n 0.5046 10799.5n 0.5046 10800.0n 0.5056 11399.5n 0.5056 11400.0n 0.5058 11999.5n 0.5058 12000.0n 0.5068 12599.5n 0.5068 12600.0n 0.5050 13199.5n 0.5050 13200.0n 0.5071 13799.5n 0.5071 13800.0n 0.5059 14399.5n 0.5059 14400.0n 0.5058 14999.5n 0.5058 15000.0n 0.5043 15599.5n 0.5043 15600.0n 0.5067 16199.5n 0.5067 16200.0n 0.5068 16799.5n 0.5068 16800.0n 0.5066 17399.5n 0.5066 17400.0n 0.5069 17999.5n 0.5069 18000.0n 0.5061 18599.5n 0.5061 18600.0n 0.5034 19199.5n 0.5034 19200.0n 0.5010 19799.5n 0.5010 19800.0n 0.4989 20399.5n 0.4989 20400.0n 0.5022 20999.5n 0.5022 21000.0n 0.5086 21599.5n 0.5086 21600.0n 0.5007 22199.5n 0.5007 22200.0n 0.5023 22799.5n 0.5023 22800.0n 0.5021 23399.5n 0.5021 23400.0n 0.5077 23999.5n 0.5077 24000.0n 0.4979 24599.5n 0.4979 24600.0n 0.5035 25199.5n 0.5035 25200.0n 0.5041 25799.5n 0.5041 25800.0n 0.5075 26399.5n 0.5075 26400.0n 0.5041 26999.5n 0.5041 27000.0n 0.5056 27599.5n 0.5056 27600.0n 0.5039 28199.5n 0.5039 28200.0n 0.5059 28799.5n 0.5059 28800.0n 0.5023 29399.5n 0.5023 29400.0n 0.5086 29999.5n 0.5086 30000.0n 0.5084 30599.5n 0.5084 30600.0n 0.5085 31199.5n 0.5085 31200.0n 0.5088 31799.5n 0.5088 31800.0n 0.5078 32399.5n 0.5078 32400.0n 0.5074 32999.5n 0.5074 33000.0n 0.4996 33599.5n 0.4996 33600.0n 0.5010 34199.5n 0.5010 34200.0n 0.5044 34799.5n 0.5044 34800.0n 0.5084 35399.5n 0.5084 35400.0n 0.5012 35999.5n 0.5012)
Vyn_who_18_1 yn_who_18_1 0 PWL(0.0n 0.4929 599.5n 0.4929 600.0n 0.4947 1199.5n 0.4947 1200.0n 0.4948 1799.5n 0.4948 1800.0n 0.4973 2399.5n 0.4973 2400.0n 0.4966 2999.5n 0.4966 3000.0n 0.4945 3599.5n 0.4945 3600.0n 0.4944 4199.5n 0.4944 4200.0n 0.4929 4799.5n 0.4929 4800.0n 0.4944 5399.5n 0.4944 5400.0n 0.4944 5999.5n 0.4944 6000.0n 0.4952 6599.5n 0.4952 6600.0n 0.4940 7199.5n 0.4940 7200.0n 0.4952 7799.5n 0.4952 7800.0n 0.4954 8399.5n 0.4954 8400.0n 0.4934 8999.5n 0.4934 9000.0n 0.4944 9599.5n 0.4944 9600.0n 0.4949 10199.5n 0.4949 10200.0n 0.4954 10799.5n 0.4954 10800.0n 0.4944 11399.5n 0.4944 11400.0n 0.4942 11999.5n 0.4942 12000.0n 0.4932 12599.5n 0.4932 12600.0n 0.4950 13199.5n 0.4950 13200.0n 0.4929 13799.5n 0.4929 13800.0n 0.4941 14399.5n 0.4941 14400.0n 0.4942 14999.5n 0.4942 15000.0n 0.4957 15599.5n 0.4957 15600.0n 0.4933 16199.5n 0.4933 16200.0n 0.4932 16799.5n 0.4932 16800.0n 0.4934 17399.5n 0.4934 17400.0n 0.4931 17999.5n 0.4931 18000.0n 0.4939 18599.5n 0.4939 18600.0n 0.4966 19199.5n 0.4966 19200.0n 0.4990 19799.5n 0.4990 19800.0n 0.5011 20399.5n 0.5011 20400.0n 0.4978 20999.5n 0.4978 21000.0n 0.4914 21599.5n 0.4914 21600.0n 0.4993 22199.5n 0.4993 22200.0n 0.4977 22799.5n 0.4977 22800.0n 0.4979 23399.5n 0.4979 23400.0n 0.4923 23999.5n 0.4923 24000.0n 0.5021 24599.5n 0.5021 24600.0n 0.4965 25199.5n 0.4965 25200.0n 0.4959 25799.5n 0.4959 25800.0n 0.4925 26399.5n 0.4925 26400.0n 0.4959 26999.5n 0.4959 27000.0n 0.4944 27599.5n 0.4944 27600.0n 0.4961 28199.5n 0.4961 28200.0n 0.4941 28799.5n 0.4941 28800.0n 0.4977 29399.5n 0.4977 29400.0n 0.4914 29999.5n 0.4914 30000.0n 0.4916 30599.5n 0.4916 30600.0n 0.4915 31199.5n 0.4915 31200.0n 0.4912 31799.5n 0.4912 31800.0n 0.4922 32399.5n 0.4922 32400.0n 0.4926 32999.5n 0.4926 33000.0n 0.5004 33599.5n 0.5004 33600.0n 0.4990 34199.5n 0.4990 34200.0n 0.4956 34799.5n 0.4956 34800.0n 0.4916 35399.5n 0.4916 35400.0n 0.4988 35999.5n 0.4988)
Cwp_who_18_1 wp_who_18_1 0 400p
Cwn_who_18_1 wn_who_18_1 0 400p
Xu_who_18_1 xp_who_18_1 xn_who_18_1 yp_who_18_1 yn_who_18_1 wp_who_18_1 wn_who_18_1 vdd gbn gprod
Vxp_bh_18 xp_bh_18 0 PWL(0.0n 0.7100 599.5n 0.7100 600.0n 0.7100 1199.5n 0.7100 1200.0n 0.7100 1799.5n 0.7100 1800.0n 0.7100 2399.5n 0.7100 2400.0n 0.7100 2999.5n 0.7100 3000.0n 0.7100 3599.5n 0.7100 3600.0n 0.7100 4199.5n 0.7100 4200.0n 0.7100 4799.5n 0.7100 4800.0n 0.7100 5399.5n 0.7100 5400.0n 0.7100 5999.5n 0.7100 6000.0n 0.7100 6599.5n 0.7100 6600.0n 0.7100 7199.5n 0.7100 7200.0n 0.7100 7799.5n 0.7100 7800.0n 0.7100 8399.5n 0.7100 8400.0n 0.7100 8999.5n 0.7100 9000.0n 0.7100 9599.5n 0.7100 9600.0n 0.7100 10199.5n 0.7100 10200.0n 0.7100 10799.5n 0.7100 10800.0n 0.7100 11399.5n 0.7100 11400.0n 0.7100 11999.5n 0.7100 12000.0n 0.7100 12599.5n 0.7100 12600.0n 0.7100 13199.5n 0.7100 13200.0n 0.7100 13799.5n 0.7100 13800.0n 0.7100 14399.5n 0.7100 14400.0n 0.7100 14999.5n 0.7100 15000.0n 0.7100 15599.5n 0.7100 15600.0n 0.7100 16199.5n 0.7100 16200.0n 0.7100 16799.5n 0.7100 16800.0n 0.7100 17399.5n 0.7100 17400.0n 0.7100 17999.5n 0.7100 18000.0n 0.7100 18599.5n 0.7100 18600.0n 0.7100 19199.5n 0.7100 19200.0n 0.7100 19799.5n 0.7100 19800.0n 0.7100 20399.5n 0.7100 20400.0n 0.7100 20999.5n 0.7100 21000.0n 0.7100 21599.5n 0.7100 21600.0n 0.7100 22199.5n 0.7100 22200.0n 0.7100 22799.5n 0.7100 22800.0n 0.7100 23399.5n 0.7100 23400.0n 0.7100 23999.5n 0.7100 24000.0n 0.7100 24599.5n 0.7100 24600.0n 0.7100 25199.5n 0.7100 25200.0n 0.7100 25799.5n 0.7100 25800.0n 0.7100 26399.5n 0.7100 26400.0n 0.7100 26999.5n 0.7100 27000.0n 0.7100 27599.5n 0.7100 27600.0n 0.7100 28199.5n 0.7100 28200.0n 0.7100 28799.5n 0.7100 28800.0n 0.7100 29399.5n 0.7100 29400.0n 0.7100 29999.5n 0.7100 30000.0n 0.7100 30599.5n 0.7100 30600.0n 0.7100 31199.5n 0.7100 31200.0n 0.7100 31799.5n 0.7100 31800.0n 0.7100 32399.5n 0.7100 32400.0n 0.7100 32999.5n 0.7100 33000.0n 0.7100 33599.5n 0.7100 33600.0n 0.7100 34199.5n 0.7100 34200.0n 0.7100 34799.5n 0.7100 34800.0n 0.7100 35399.5n 0.7100 35400.0n 0.7100 35999.5n 0.7100)
Vxn_bh_18 xn_bh_18 0 PWL(0.0n 0.2900 599.5n 0.2900 600.0n 0.2900 1199.5n 0.2900 1200.0n 0.2900 1799.5n 0.2900 1800.0n 0.2900 2399.5n 0.2900 2400.0n 0.2900 2999.5n 0.2900 3000.0n 0.2900 3599.5n 0.2900 3600.0n 0.2900 4199.5n 0.2900 4200.0n 0.2900 4799.5n 0.2900 4800.0n 0.2900 5399.5n 0.2900 5400.0n 0.2900 5999.5n 0.2900 6000.0n 0.2900 6599.5n 0.2900 6600.0n 0.2900 7199.5n 0.2900 7200.0n 0.2900 7799.5n 0.2900 7800.0n 0.2900 8399.5n 0.2900 8400.0n 0.2900 8999.5n 0.2900 9000.0n 0.2900 9599.5n 0.2900 9600.0n 0.2900 10199.5n 0.2900 10200.0n 0.2900 10799.5n 0.2900 10800.0n 0.2900 11399.5n 0.2900 11400.0n 0.2900 11999.5n 0.2900 12000.0n 0.2900 12599.5n 0.2900 12600.0n 0.2900 13199.5n 0.2900 13200.0n 0.2900 13799.5n 0.2900 13800.0n 0.2900 14399.5n 0.2900 14400.0n 0.2900 14999.5n 0.2900 15000.0n 0.2900 15599.5n 0.2900 15600.0n 0.2900 16199.5n 0.2900 16200.0n 0.2900 16799.5n 0.2900 16800.0n 0.2900 17399.5n 0.2900 17400.0n 0.2900 17999.5n 0.2900 18000.0n 0.2900 18599.5n 0.2900 18600.0n 0.2900 19199.5n 0.2900 19200.0n 0.2900 19799.5n 0.2900 19800.0n 0.2900 20399.5n 0.2900 20400.0n 0.2900 20999.5n 0.2900 21000.0n 0.2900 21599.5n 0.2900 21600.0n 0.2900 22199.5n 0.2900 22200.0n 0.2900 22799.5n 0.2900 22800.0n 0.2900 23399.5n 0.2900 23400.0n 0.2900 23999.5n 0.2900 24000.0n 0.2900 24599.5n 0.2900 24600.0n 0.2900 25199.5n 0.2900 25200.0n 0.2900 25799.5n 0.2900 25800.0n 0.2900 26399.5n 0.2900 26400.0n 0.2900 26999.5n 0.2900 27000.0n 0.2900 27599.5n 0.2900 27600.0n 0.2900 28199.5n 0.2900 28200.0n 0.2900 28799.5n 0.2900 28800.0n 0.2900 29399.5n 0.2900 29400.0n 0.2900 29999.5n 0.2900 30000.0n 0.2900 30599.5n 0.2900 30600.0n 0.2900 31199.5n 0.2900 31200.0n 0.2900 31799.5n 0.2900 31800.0n 0.2900 32399.5n 0.2900 32400.0n 0.2900 32999.5n 0.2900 33000.0n 0.2900 33599.5n 0.2900 33600.0n 0.2900 34199.5n 0.2900 34200.0n 0.2900 34799.5n 0.2900 34800.0n 0.2900 35399.5n 0.2900 35400.0n 0.2900 35999.5n 0.2900)
Vyp_bh_18 yp_bh_18 0 PWL(0.0n 0.4313 599.5n 0.4313 600.0n 0.4701 1199.5n 0.4701 1200.0n 0.4928 1799.5n 0.4928 1800.0n 0.5577 2399.5n 0.5577 2400.0n 0.5374 2999.5n 0.5374 3000.0n 0.4725 3599.5n 0.4725 3600.0n 0.4766 4199.5n 0.4766 4200.0n 0.4277 4799.5n 0.4277 4800.0n 0.4725 5399.5n 0.4725 5400.0n 0.4736 5999.5n 0.4736 6000.0n 0.5051 6599.5n 0.5051 6600.0n 0.4606 7199.5n 0.4606 7200.0n 0.4854 7799.5n 0.4854 7800.0n 0.4918 8399.5n 0.4918 8400.0n 0.4338 8999.5n 0.4338 9000.0n 0.4727 9599.5n 0.4727 9600.0n 0.4890 10199.5n 0.4890 10200.0n 0.5002 10799.5n 0.5002 10800.0n 0.4868 11399.5n 0.4868 11400.0n 0.4669 11999.5n 0.4669 12000.0n 0.4242 12599.5n 0.4242 12600.0n 0.4923 13199.5n 0.4923 13200.0n 0.4314 13799.5n 0.4314 13800.0n 0.4577 14399.5n 0.4577 14400.0n 0.4653 14999.5n 0.4653 15000.0n 0.5141 15599.5n 0.5141 15600.0n 0.4402 16199.5n 0.4402 16200.0n 0.4366 16799.5n 0.4366 16800.0n 0.4356 17399.5n 0.4356 17400.0n 0.4378 17999.5n 0.4378 18000.0n 0.5731 18599.5n 0.5731 18600.0n 0.4916 19199.5n 0.4916 19200.0n 0.6124 19799.5n 0.6124 19800.0n 0.6070 20399.5n 0.6070 20400.0n 0.6102 20999.5n 0.6102 21000.0n 0.4801 21599.5n 0.4801 21600.0n 0.5641 22199.5n 0.5641 22200.0n 0.5012 22799.5n 0.5012 22800.0n 0.6295 23399.5n 0.6295 23400.0n 0.3477 23999.5n 0.3477 24000.0n 0.6411 24599.5n 0.6411 24600.0n 0.4779 25199.5n 0.4779 25200.0n 0.5960 25799.5n 0.5960 25800.0n 0.5870 26399.5n 0.5870 26400.0n 0.6160 26999.5n 0.6160 27000.0n 0.5897 27599.5n 0.5897 27600.0n 0.6169 28199.5n 0.6169 28200.0n 0.3679 28799.5n 0.3679 28800.0n 0.6177 29399.5n 0.6177 29400.0n 0.4632 29999.5n 0.4632 30000.0n 0.4331 30599.5n 0.4331 30600.0n 0.3356 31199.5n 0.3356 31200.0n 0.3435 31799.5n 0.3435 31800.0n 0.5763 32399.5n 0.5763 32400.0n 0.5896 32999.5n 0.5896 33000.0n 0.6269 33599.5n 0.6269 33600.0n 0.6311 34199.5n 0.6311 34200.0n 0.4538 34799.5n 0.4538 34800.0n 0.3794 35399.5n 0.3794 35400.0n 0.6181 35999.5n 0.6181)
Vyn_bh_18 yn_bh_18 0 PWL(0.0n 0.5687 599.5n 0.5687 600.0n 0.5299 1199.5n 0.5299 1200.0n 0.5072 1799.5n 0.5072 1800.0n 0.4423 2399.5n 0.4423 2400.0n 0.4626 2999.5n 0.4626 3000.0n 0.5275 3599.5n 0.5275 3600.0n 0.5234 4199.5n 0.5234 4200.0n 0.5723 4799.5n 0.5723 4800.0n 0.5275 5399.5n 0.5275 5400.0n 0.5264 5999.5n 0.5264 6000.0n 0.4949 6599.5n 0.4949 6600.0n 0.5394 7199.5n 0.5394 7200.0n 0.5146 7799.5n 0.5146 7800.0n 0.5082 8399.5n 0.5082 8400.0n 0.5662 8999.5n 0.5662 9000.0n 0.5273 9599.5n 0.5273 9600.0n 0.5110 10199.5n 0.5110 10200.0n 0.4998 10799.5n 0.4998 10800.0n 0.5132 11399.5n 0.5132 11400.0n 0.5331 11999.5n 0.5331 12000.0n 0.5758 12599.5n 0.5758 12600.0n 0.5077 13199.5n 0.5077 13200.0n 0.5686 13799.5n 0.5686 13800.0n 0.5423 14399.5n 0.5423 14400.0n 0.5347 14999.5n 0.5347 15000.0n 0.4859 15599.5n 0.4859 15600.0n 0.5598 16199.5n 0.5598 16200.0n 0.5634 16799.5n 0.5634 16800.0n 0.5644 17399.5n 0.5644 17400.0n 0.5622 17999.5n 0.5622 18000.0n 0.4269 18599.5n 0.4269 18600.0n 0.5084 19199.5n 0.5084 19200.0n 0.3876 19799.5n 0.3876 19800.0n 0.3930 20399.5n 0.3930 20400.0n 0.3898 20999.5n 0.3898 21000.0n 0.5199 21599.5n 0.5199 21600.0n 0.4359 22199.5n 0.4359 22200.0n 0.4988 22799.5n 0.4988 22800.0n 0.3705 23399.5n 0.3705 23400.0n 0.6523 23999.5n 0.6523 24000.0n 0.3589 24599.5n 0.3589 24600.0n 0.5221 25199.5n 0.5221 25200.0n 0.4040 25799.5n 0.4040 25800.0n 0.4130 26399.5n 0.4130 26400.0n 0.3840 26999.5n 0.3840 27000.0n 0.4103 27599.5n 0.4103 27600.0n 0.3831 28199.5n 0.3831 28200.0n 0.6321 28799.5n 0.6321 28800.0n 0.3823 29399.5n 0.3823 29400.0n 0.5368 29999.5n 0.5368 30000.0n 0.5669 30599.5n 0.5669 30600.0n 0.6644 31199.5n 0.6644 31200.0n 0.6565 31799.5n 0.6565 31800.0n 0.4237 32399.5n 0.4237 32400.0n 0.4104 32999.5n 0.4104 33000.0n 0.3731 33599.5n 0.3731 33600.0n 0.3689 34199.5n 0.3689 34200.0n 0.5462 34799.5n 0.5462 34800.0n 0.6206 35399.5n 0.6206 35400.0n 0.3819 35999.5n 0.3819)
Cwp_bh_18 wp_bh_18 0 400p
Cwn_bh_18 wn_bh_18 0 400p
Xu_bh_18 xp_bh_18 xn_bh_18 yp_bh_18 yn_bh_18 wp_bh_18 wn_bh_18 vdd gbn gprod
Vxp_wih_0_19 xp_wih_0_19 0 PWL(0.0n 0.4942 599.5n 0.4942 600.0n 0.5558 1199.5n 0.5558 1200.0n 0.4708 1799.5n 0.4708 1800.0n 0.5235 2399.5n 0.5235 2400.0n 0.5350 2999.5n 0.5350 3000.0n 0.5172 3599.5n 0.5172 3600.0n 0.4702 4199.5n 0.4702 4200.0n 0.4867 4799.5n 0.4867 4800.0n 0.4970 5399.5n 0.4970 5400.0n 0.4986 5999.5n 0.4986 6000.0n 0.4751 6599.5n 0.4751 6600.0n 0.4870 7199.5n 0.4870 7200.0n 0.5502 7799.5n 0.5502 7800.0n 0.5521 8399.5n 0.5521 8400.0n 0.4638 8999.5n 0.4638 9000.0n 0.4982 9599.5n 0.4982 9600.0n 0.5131 10199.5n 0.5131 10200.0n 0.5386 10799.5n 0.5386 10800.0n 0.4592 11399.5n 0.4592 11400.0n 0.4950 11999.5n 0.4950 12000.0n 0.4559 12599.5n 0.4559 12600.0n 0.5162 13199.5n 0.5162 13200.0n 0.5038 13799.5n 0.5038 13800.0n 0.5333 14399.5n 0.5333 14400.0n 0.4991 14999.5n 0.4991 15000.0n 0.5298 15599.5n 0.5298 15600.0n 0.4823 16199.5n 0.4823 16200.0n 0.5239 16799.5n 0.5239 16800.0n 0.4592 17399.5n 0.4592 17400.0n 0.5094 17999.5n 0.5094 18000.0n 0.4337 18599.5n 0.4337 18600.0n 0.5977 19199.5n 0.5977 19200.0n 0.5364 19799.5n 0.5364 19800.0n 0.6122 20399.5n 0.6122 20400.0n 0.4856 20999.5n 0.4856 21000.0n 0.3861 21599.5n 0.3861 21600.0n 0.6094 22199.5n 0.6094 22200.0n 0.6364 22799.5n 0.6364 22800.0n 0.4807 23399.5n 0.4807 23400.0n 0.5614 23999.5n 0.5614 24000.0n 0.5913 24599.5n 0.5913 24600.0n 0.6295 25199.5n 0.6295 25200.0n 0.4496 25799.5n 0.4496 25800.0n 0.3792 26399.5n 0.3792 26400.0n 0.4434 26999.5n 0.4434 27000.0n 0.4340 27599.5n 0.4340 27600.0n 0.4461 28199.5n 0.4461 28200.0n 0.5791 28799.5n 0.5791 28800.0n 0.4777 29399.5n 0.4777 29400.0n 0.3878 29999.5n 0.3878 30000.0n 0.3832 30599.5n 0.3832 30600.0n 0.4022 31199.5n 0.4022 31200.0n 0.4482 31799.5n 0.4482 31800.0n 0.3662 32399.5n 0.3662 32400.0n 0.3857 32999.5n 0.3857 33000.0n 0.5584 33599.5n 0.5584 33600.0n 0.5284 34199.5n 0.5284 34200.0n 0.6034 34799.5n 0.6034 34800.0n 0.3469 35399.5n 0.3469 35400.0n 0.5290 35999.5n 0.5290)
Vxn_wih_0_19 xn_wih_0_19 0 PWL(0.0n 0.5058 599.5n 0.5058 600.0n 0.4442 1199.5n 0.4442 1200.0n 0.5292 1799.5n 0.5292 1800.0n 0.4765 2399.5n 0.4765 2400.0n 0.4650 2999.5n 0.4650 3000.0n 0.4828 3599.5n 0.4828 3600.0n 0.5298 4199.5n 0.5298 4200.0n 0.5133 4799.5n 0.5133 4800.0n 0.5030 5399.5n 0.5030 5400.0n 0.5014 5999.5n 0.5014 6000.0n 0.5249 6599.5n 0.5249 6600.0n 0.5130 7199.5n 0.5130 7200.0n 0.4498 7799.5n 0.4498 7800.0n 0.4479 8399.5n 0.4479 8400.0n 0.5362 8999.5n 0.5362 9000.0n 0.5018 9599.5n 0.5018 9600.0n 0.4869 10199.5n 0.4869 10200.0n 0.4614 10799.5n 0.4614 10800.0n 0.5408 11399.5n 0.5408 11400.0n 0.5050 11999.5n 0.5050 12000.0n 0.5441 12599.5n 0.5441 12600.0n 0.4838 13199.5n 0.4838 13200.0n 0.4962 13799.5n 0.4962 13800.0n 0.4667 14399.5n 0.4667 14400.0n 0.5009 14999.5n 0.5009 15000.0n 0.4702 15599.5n 0.4702 15600.0n 0.5177 16199.5n 0.5177 16200.0n 0.4761 16799.5n 0.4761 16800.0n 0.5408 17399.5n 0.5408 17400.0n 0.4906 17999.5n 0.4906 18000.0n 0.5663 18599.5n 0.5663 18600.0n 0.4023 19199.5n 0.4023 19200.0n 0.4636 19799.5n 0.4636 19800.0n 0.3878 20399.5n 0.3878 20400.0n 0.5144 20999.5n 0.5144 21000.0n 0.6139 21599.5n 0.6139 21600.0n 0.3906 22199.5n 0.3906 22200.0n 0.3636 22799.5n 0.3636 22800.0n 0.5193 23399.5n 0.5193 23400.0n 0.4386 23999.5n 0.4386 24000.0n 0.4087 24599.5n 0.4087 24600.0n 0.3705 25199.5n 0.3705 25200.0n 0.5504 25799.5n 0.5504 25800.0n 0.6208 26399.5n 0.6208 26400.0n 0.5566 26999.5n 0.5566 27000.0n 0.5660 27599.5n 0.5660 27600.0n 0.5539 28199.5n 0.5539 28200.0n 0.4209 28799.5n 0.4209 28800.0n 0.5223 29399.5n 0.5223 29400.0n 0.6122 29999.5n 0.6122 30000.0n 0.6168 30599.5n 0.6168 30600.0n 0.5978 31199.5n 0.5978 31200.0n 0.5518 31799.5n 0.5518 31800.0n 0.6338 32399.5n 0.6338 32400.0n 0.6143 32999.5n 0.6143 33000.0n 0.4416 33599.5n 0.4416 33600.0n 0.4716 34199.5n 0.4716 34200.0n 0.3966 34799.5n 0.3966 34800.0n 0.6531 35399.5n 0.6531 35400.0n 0.4710 35999.5n 0.4710)
Vyp_wih_0_19 yp_wih_0_19 0 PWL(0.0n 0.6503 599.5n 0.6503 600.0n 0.6076 1199.5n 0.6076 1200.0n 0.6570 1799.5n 0.6570 1800.0n 0.6450 2399.5n 0.6450 2400.0n 0.6360 2999.5n 0.6360 3000.0n 0.6443 3599.5n 0.6443 3600.0n 0.6567 4199.5n 0.6567 4200.0n 0.6520 4799.5n 0.6520 4800.0n 0.6505 5399.5n 0.6505 5400.0n 0.6501 5999.5n 0.6501 6000.0n 0.6563 6599.5n 0.6563 6600.0n 0.6526 7199.5n 0.6526 7200.0n 0.6165 7799.5n 0.6165 7800.0n 0.6143 8399.5n 0.6143 8400.0n 0.6575 8999.5n 0.6575 9000.0n 0.6502 9599.5n 0.6502 9600.0n 0.6465 10199.5n 0.6465 10200.0n 0.6305 10799.5n 0.6305 10800.0n 0.6596 11399.5n 0.6596 11400.0n 0.6509 11999.5n 0.6509 12000.0n 0.6594 12599.5n 0.6594 12600.0n 0.6455 13199.5n 0.6455 13200.0n 0.6477 13799.5n 0.6477 13800.0n 0.6323 14399.5n 0.6323 14400.0n 0.6498 14999.5n 0.6498 15000.0n 0.6393 15599.5n 0.6393 15600.0n 0.6533 16199.5n 0.6533 16200.0n 0.6386 16799.5n 0.6386 16800.0n 0.6586 17399.5n 0.6586 17400.0n 0.6461 17999.5n 0.6461 18000.0n 0.6700 18599.5n 0.6700 18600.0n 0.5592 19199.5n 0.5592 19200.0n 0.6420 19799.5n 0.6420 19800.0n 0.5602 20399.5n 0.5602 20400.0n 0.6582 20999.5n 0.6582 21000.0n 0.6746 21599.5n 0.6746 21600.0n 0.5580 22199.5n 0.5580 22200.0n 0.5445 22799.5n 0.5445 22800.0n 0.6591 23399.5n 0.6591 23400.0n 0.5844 23999.5n 0.5844 24000.0n 0.5764 24599.5n 0.5764 24600.0n 0.5449 25199.5n 0.5449 25200.0n 0.6656 25799.5n 0.6656 25800.0n 0.6780 26399.5n 0.6780 26400.0n 0.6677 26999.5n 0.6677 27000.0n 0.6704 27599.5n 0.6704 27600.0n 0.6669 28199.5n 0.6669 28200.0n 0.5576 28799.5n 0.5576 28800.0n 0.6597 29399.5n 0.6597 29400.0n 0.6741 29999.5n 0.6741 30000.0n 0.6739 30599.5n 0.6739 30600.0n 0.6710 31199.5n 0.6710 31200.0n 0.6596 31799.5n 0.6596 31800.0n 0.6784 32399.5n 0.6784 32400.0n 0.6776 32999.5n 0.6776 33000.0n 0.6169 33599.5n 0.6169 33600.0n 0.6477 34199.5n 0.6477 34200.0n 0.5535 34799.5n 0.5535 34800.0n 0.6751 35399.5n 0.6751 35400.0n 0.6474 35999.5n 0.6474)
Vyn_wih_0_19 yn_wih_0_19 0 PWL(0.0n 0.3497 599.5n 0.3497 600.0n 0.3924 1199.5n 0.3924 1200.0n 0.3430 1799.5n 0.3430 1800.0n 0.3550 2399.5n 0.3550 2400.0n 0.3640 2999.5n 0.3640 3000.0n 0.3557 3599.5n 0.3557 3600.0n 0.3433 4199.5n 0.3433 4200.0n 0.3480 4799.5n 0.3480 4800.0n 0.3495 5399.5n 0.3495 5400.0n 0.3499 5999.5n 0.3499 6000.0n 0.3437 6599.5n 0.3437 6600.0n 0.3474 7199.5n 0.3474 7200.0n 0.3835 7799.5n 0.3835 7800.0n 0.3857 8399.5n 0.3857 8400.0n 0.3425 8999.5n 0.3425 9000.0n 0.3498 9599.5n 0.3498 9600.0n 0.3535 10199.5n 0.3535 10200.0n 0.3695 10799.5n 0.3695 10800.0n 0.3404 11399.5n 0.3404 11400.0n 0.3491 11999.5n 0.3491 12000.0n 0.3406 12599.5n 0.3406 12600.0n 0.3545 13199.5n 0.3545 13200.0n 0.3523 13799.5n 0.3523 13800.0n 0.3677 14399.5n 0.3677 14400.0n 0.3502 14999.5n 0.3502 15000.0n 0.3607 15599.5n 0.3607 15600.0n 0.3467 16199.5n 0.3467 16200.0n 0.3614 16799.5n 0.3614 16800.0n 0.3414 17399.5n 0.3414 17400.0n 0.3539 17999.5n 0.3539 18000.0n 0.3300 18599.5n 0.3300 18600.0n 0.4408 19199.5n 0.4408 19200.0n 0.3580 19799.5n 0.3580 19800.0n 0.4398 20399.5n 0.4398 20400.0n 0.3418 20999.5n 0.3418 21000.0n 0.3254 21599.5n 0.3254 21600.0n 0.4420 22199.5n 0.4420 22200.0n 0.4555 22799.5n 0.4555 22800.0n 0.3409 23399.5n 0.3409 23400.0n 0.4156 23999.5n 0.4156 24000.0n 0.4236 24599.5n 0.4236 24600.0n 0.4551 25199.5n 0.4551 25200.0n 0.3344 25799.5n 0.3344 25800.0n 0.3220 26399.5n 0.3220 26400.0n 0.3323 26999.5n 0.3323 27000.0n 0.3296 27599.5n 0.3296 27600.0n 0.3331 28199.5n 0.3331 28200.0n 0.4424 28799.5n 0.4424 28800.0n 0.3403 29399.5n 0.3403 29400.0n 0.3259 29999.5n 0.3259 30000.0n 0.3261 30599.5n 0.3261 30600.0n 0.3290 31199.5n 0.3290 31200.0n 0.3404 31799.5n 0.3404 31800.0n 0.3216 32399.5n 0.3216 32400.0n 0.3224 32999.5n 0.3224 33000.0n 0.3831 33599.5n 0.3831 33600.0n 0.3523 34199.5n 0.3523 34200.0n 0.4465 34799.5n 0.4465 34800.0n 0.3249 35399.5n 0.3249 35400.0n 0.3526 35999.5n 0.3526)
Cwp_wih_0_19 wp_wih_0_19 0 400p
Cwn_wih_0_19 wn_wih_0_19 0 400p
Xu_wih_0_19 xp_wih_0_19 xn_wih_0_19 yp_wih_0_19 yn_wih_0_19 wp_wih_0_19 wn_wih_0_19 vdd gbn gprod
Vxp_wih_1_19 xp_wih_1_19 0 PWL(0.0n 0.5370 599.5n 0.5370 600.0n 0.5167 1199.5n 0.5167 1200.0n 0.4793 1799.5n 0.4793 1800.0n 0.4441 2399.5n 0.4441 2400.0n 0.4555 2999.5n 0.4555 3000.0n 0.5055 3599.5n 0.5055 3600.0n 0.4939 4199.5n 0.4939 4200.0n 0.5385 4799.5n 0.5385 4800.0n 0.5024 5399.5n 0.5024 5400.0n 0.5015 5999.5n 0.5015 6000.0n 0.4700 6599.5n 0.4700 6600.0n 0.5120 7199.5n 0.5120 7200.0n 0.5006 7799.5n 0.5006 7800.0n 0.4950 8399.5n 0.4950 8400.0n 0.5309 8999.5n 0.5309 9000.0n 0.5023 9599.5n 0.5023 9600.0n 0.4893 10199.5n 0.4893 10200.0n 0.4837 10799.5n 0.4837 10800.0n 0.4823 11399.5n 0.4823 11400.0n 0.5074 11999.5n 0.5074 12000.0n 0.5364 12599.5n 0.5364 12600.0n 0.4868 13199.5n 0.4868 13200.0n 0.5380 13799.5n 0.5380 13800.0n 0.5220 14399.5n 0.5220 14400.0n 0.5095 14999.5n 0.5095 15000.0n 0.4705 15599.5n 0.4705 15600.0n 0.5289 16199.5n 0.5289 16200.0n 0.5368 16799.5n 0.5368 16800.0n 0.5287 17399.5n 0.5287 17400.0n 0.5342 17999.5n 0.5342 18000.0n 0.4253 18599.5n 0.4253 18600.0n 0.5119 19199.5n 0.5119 19200.0n 0.4104 19799.5n 0.4104 19800.0n 0.4314 20399.5n 0.4314 20400.0n 0.4005 20999.5n 0.4005 21000.0n 0.4696 21599.5n 0.4696 21600.0n 0.4531 22199.5n 0.4531 22200.0n 0.5039 22799.5n 0.5039 22800.0n 0.3608 23399.5n 0.3608 23400.0n 0.6273 23999.5n 0.6273 24000.0n 0.3928 24599.5n 0.3928 24600.0n 0.5253 25199.5n 0.5253 25200.0n 0.4107 25799.5n 0.4107 25800.0n 0.3947 26399.5n 0.3947 26400.0n 0.3716 26999.5n 0.3716 27000.0n 0.4111 27599.5n 0.4111 27600.0n 0.3715 28199.5n 0.3715 28200.0n 0.5939 28799.5n 0.5939 28800.0n 0.3849 29399.5n 0.3849 29400.0n 0.4835 29999.5n 0.4835 30000.0n 0.5119 30599.5n 0.5119 30600.0n 0.6226 31199.5n 0.6226 31200.0n 0.6064 31799.5n 0.6064 31800.0n 0.4115 32399.5n 0.4115 32400.0n 0.3900 32999.5n 0.3900 33000.0n 0.3958 33599.5n 0.3958 33600.0n 0.3747 34199.5n 0.3747 34200.0n 0.5423 34799.5n 0.5423 34800.0n 0.5509 35399.5n 0.5509 35400.0n 0.3990 35999.5n 0.3990)
Vxn_wih_1_19 xn_wih_1_19 0 PWL(0.0n 0.4630 599.5n 0.4630 600.0n 0.4833 1199.5n 0.4833 1200.0n 0.5207 1799.5n 0.5207 1800.0n 0.5559 2399.5n 0.5559 2400.0n 0.5445 2999.5n 0.5445 3000.0n 0.4945 3599.5n 0.4945 3600.0n 0.5061 4199.5n 0.5061 4200.0n 0.4615 4799.5n 0.4615 4800.0n 0.4976 5399.5n 0.4976 5400.0n 0.4985 5999.5n 0.4985 6000.0n 0.5300 6599.5n 0.5300 6600.0n 0.4880 7199.5n 0.4880 7200.0n 0.4994 7799.5n 0.4994 7800.0n 0.5050 8399.5n 0.5050 8400.0n 0.4691 8999.5n 0.4691 9000.0n 0.4977 9599.5n 0.4977 9600.0n 0.5107 10199.5n 0.5107 10200.0n 0.5163 10799.5n 0.5163 10800.0n 0.5177 11399.5n 0.5177 11400.0n 0.4926 11999.5n 0.4926 12000.0n 0.4636 12599.5n 0.4636 12600.0n 0.5132 13199.5n 0.5132 13200.0n 0.4620 13799.5n 0.4620 13800.0n 0.4780 14399.5n 0.4780 14400.0n 0.4905 14999.5n 0.4905 15000.0n 0.5295 15599.5n 0.5295 15600.0n 0.4711 16199.5n 0.4711 16200.0n 0.4632 16799.5n 0.4632 16800.0n 0.4713 17399.5n 0.4713 17400.0n 0.4658 17999.5n 0.4658 18000.0n 0.5747 18599.5n 0.5747 18600.0n 0.4881 19199.5n 0.4881 19200.0n 0.5896 19799.5n 0.5896 19800.0n 0.5686 20399.5n 0.5686 20400.0n 0.5995 20999.5n 0.5995 21000.0n 0.5304 21599.5n 0.5304 21600.0n 0.5469 22199.5n 0.5469 22200.0n 0.4961 22799.5n 0.4961 22800.0n 0.6392 23399.5n 0.6392 23400.0n 0.3727 23999.5n 0.3727 24000.0n 0.6072 24599.5n 0.6072 24600.0n 0.4747 25199.5n 0.4747 25200.0n 0.5893 25799.5n 0.5893 25800.0n 0.6053 26399.5n 0.6053 26400.0n 0.6284 26999.5n 0.6284 27000.0n 0.5889 27599.5n 0.5889 27600.0n 0.6285 28199.5n 0.6285 28200.0n 0.4061 28799.5n 0.4061 28800.0n 0.6151 29399.5n 0.6151 29400.0n 0.5165 29999.5n 0.5165 30000.0n 0.4881 30599.5n 0.4881 30600.0n 0.3774 31199.5n 0.3774 31200.0n 0.3936 31799.5n 0.3936 31800.0n 0.5885 32399.5n 0.5885 32400.0n 0.6100 32999.5n 0.6100 33000.0n 0.6042 33599.5n 0.6042 33600.0n 0.6253 34199.5n 0.6253 34200.0n 0.4577 34799.5n 0.4577 34800.0n 0.4491 35399.5n 0.4491 35400.0n 0.6010 35999.5n 0.6010)
Vyp_wih_1_19 yp_wih_1_19 0 PWL(0.0n 0.6503 599.5n 0.6503 600.0n 0.6076 1199.5n 0.6076 1200.0n 0.6570 1799.5n 0.6570 1800.0n 0.6450 2399.5n 0.6450 2400.0n 0.6360 2999.5n 0.6360 3000.0n 0.6443 3599.5n 0.6443 3600.0n 0.6567 4199.5n 0.6567 4200.0n 0.6520 4799.5n 0.6520 4800.0n 0.6505 5399.5n 0.6505 5400.0n 0.6501 5999.5n 0.6501 6000.0n 0.6563 6599.5n 0.6563 6600.0n 0.6526 7199.5n 0.6526 7200.0n 0.6165 7799.5n 0.6165 7800.0n 0.6143 8399.5n 0.6143 8400.0n 0.6575 8999.5n 0.6575 9000.0n 0.6502 9599.5n 0.6502 9600.0n 0.6465 10199.5n 0.6465 10200.0n 0.6305 10799.5n 0.6305 10800.0n 0.6596 11399.5n 0.6596 11400.0n 0.6509 11999.5n 0.6509 12000.0n 0.6594 12599.5n 0.6594 12600.0n 0.6455 13199.5n 0.6455 13200.0n 0.6477 13799.5n 0.6477 13800.0n 0.6323 14399.5n 0.6323 14400.0n 0.6498 14999.5n 0.6498 15000.0n 0.6393 15599.5n 0.6393 15600.0n 0.6533 16199.5n 0.6533 16200.0n 0.6386 16799.5n 0.6386 16800.0n 0.6586 17399.5n 0.6586 17400.0n 0.6461 17999.5n 0.6461 18000.0n 0.6700 18599.5n 0.6700 18600.0n 0.5592 19199.5n 0.5592 19200.0n 0.6420 19799.5n 0.6420 19800.0n 0.5602 20399.5n 0.5602 20400.0n 0.6582 20999.5n 0.6582 21000.0n 0.6746 21599.5n 0.6746 21600.0n 0.5580 22199.5n 0.5580 22200.0n 0.5445 22799.5n 0.5445 22800.0n 0.6591 23399.5n 0.6591 23400.0n 0.5844 23999.5n 0.5844 24000.0n 0.5764 24599.5n 0.5764 24600.0n 0.5449 25199.5n 0.5449 25200.0n 0.6656 25799.5n 0.6656 25800.0n 0.6780 26399.5n 0.6780 26400.0n 0.6677 26999.5n 0.6677 27000.0n 0.6704 27599.5n 0.6704 27600.0n 0.6669 28199.5n 0.6669 28200.0n 0.5576 28799.5n 0.5576 28800.0n 0.6597 29399.5n 0.6597 29400.0n 0.6741 29999.5n 0.6741 30000.0n 0.6739 30599.5n 0.6739 30600.0n 0.6710 31199.5n 0.6710 31200.0n 0.6596 31799.5n 0.6596 31800.0n 0.6784 32399.5n 0.6784 32400.0n 0.6776 32999.5n 0.6776 33000.0n 0.6169 33599.5n 0.6169 33600.0n 0.6477 34199.5n 0.6477 34200.0n 0.5535 34799.5n 0.5535 34800.0n 0.6751 35399.5n 0.6751 35400.0n 0.6474 35999.5n 0.6474)
Vyn_wih_1_19 yn_wih_1_19 0 PWL(0.0n 0.3497 599.5n 0.3497 600.0n 0.3924 1199.5n 0.3924 1200.0n 0.3430 1799.5n 0.3430 1800.0n 0.3550 2399.5n 0.3550 2400.0n 0.3640 2999.5n 0.3640 3000.0n 0.3557 3599.5n 0.3557 3600.0n 0.3433 4199.5n 0.3433 4200.0n 0.3480 4799.5n 0.3480 4800.0n 0.3495 5399.5n 0.3495 5400.0n 0.3499 5999.5n 0.3499 6000.0n 0.3437 6599.5n 0.3437 6600.0n 0.3474 7199.5n 0.3474 7200.0n 0.3835 7799.5n 0.3835 7800.0n 0.3857 8399.5n 0.3857 8400.0n 0.3425 8999.5n 0.3425 9000.0n 0.3498 9599.5n 0.3498 9600.0n 0.3535 10199.5n 0.3535 10200.0n 0.3695 10799.5n 0.3695 10800.0n 0.3404 11399.5n 0.3404 11400.0n 0.3491 11999.5n 0.3491 12000.0n 0.3406 12599.5n 0.3406 12600.0n 0.3545 13199.5n 0.3545 13200.0n 0.3523 13799.5n 0.3523 13800.0n 0.3677 14399.5n 0.3677 14400.0n 0.3502 14999.5n 0.3502 15000.0n 0.3607 15599.5n 0.3607 15600.0n 0.3467 16199.5n 0.3467 16200.0n 0.3614 16799.5n 0.3614 16800.0n 0.3414 17399.5n 0.3414 17400.0n 0.3539 17999.5n 0.3539 18000.0n 0.3300 18599.5n 0.3300 18600.0n 0.4408 19199.5n 0.4408 19200.0n 0.3580 19799.5n 0.3580 19800.0n 0.4398 20399.5n 0.4398 20400.0n 0.3418 20999.5n 0.3418 21000.0n 0.3254 21599.5n 0.3254 21600.0n 0.4420 22199.5n 0.4420 22200.0n 0.4555 22799.5n 0.4555 22800.0n 0.3409 23399.5n 0.3409 23400.0n 0.4156 23999.5n 0.4156 24000.0n 0.4236 24599.5n 0.4236 24600.0n 0.4551 25199.5n 0.4551 25200.0n 0.3344 25799.5n 0.3344 25800.0n 0.3220 26399.5n 0.3220 26400.0n 0.3323 26999.5n 0.3323 27000.0n 0.3296 27599.5n 0.3296 27600.0n 0.3331 28199.5n 0.3331 28200.0n 0.4424 28799.5n 0.4424 28800.0n 0.3403 29399.5n 0.3403 29400.0n 0.3259 29999.5n 0.3259 30000.0n 0.3261 30599.5n 0.3261 30600.0n 0.3290 31199.5n 0.3290 31200.0n 0.3404 31799.5n 0.3404 31800.0n 0.3216 32399.5n 0.3216 32400.0n 0.3224 32999.5n 0.3224 33000.0n 0.3831 33599.5n 0.3831 33600.0n 0.3523 34199.5n 0.3523 34200.0n 0.4465 34799.5n 0.4465 34800.0n 0.3249 35399.5n 0.3249 35400.0n 0.3526 35999.5n 0.3526)
Cwp_wih_1_19 wp_wih_1_19 0 400p
Cwn_wih_1_19 wn_wih_1_19 0 400p
Xu_wih_1_19 xp_wih_1_19 xn_wih_1_19 yp_wih_1_19 yn_wih_1_19 wp_wih_1_19 wn_wih_1_19 vdd gbn gprod
Vxp_who_19_0 xp_who_19_0 0 PWL(0.0n 0.6503 599.5n 0.6503 600.0n 0.6076 1199.5n 0.6076 1200.0n 0.6570 1799.5n 0.6570 1800.0n 0.6450 2399.5n 0.6450 2400.0n 0.6360 2999.5n 0.6360 3000.0n 0.6443 3599.5n 0.6443 3600.0n 0.6567 4199.5n 0.6567 4200.0n 0.6520 4799.5n 0.6520 4800.0n 0.6505 5399.5n 0.6505 5400.0n 0.6501 5999.5n 0.6501 6000.0n 0.6563 6599.5n 0.6563 6600.0n 0.6526 7199.5n 0.6526 7200.0n 0.6165 7799.5n 0.6165 7800.0n 0.6143 8399.5n 0.6143 8400.0n 0.6575 8999.5n 0.6575 9000.0n 0.6502 9599.5n 0.6502 9600.0n 0.6465 10199.5n 0.6465 10200.0n 0.6305 10799.5n 0.6305 10800.0n 0.6596 11399.5n 0.6596 11400.0n 0.6509 11999.5n 0.6509 12000.0n 0.6594 12599.5n 0.6594 12600.0n 0.6455 13199.5n 0.6455 13200.0n 0.6477 13799.5n 0.6477 13800.0n 0.6323 14399.5n 0.6323 14400.0n 0.6498 14999.5n 0.6498 15000.0n 0.6393 15599.5n 0.6393 15600.0n 0.6533 16199.5n 0.6533 16200.0n 0.6386 16799.5n 0.6386 16800.0n 0.6586 17399.5n 0.6586 17400.0n 0.6461 17999.5n 0.6461 18000.0n 0.6700 18599.5n 0.6700 18600.0n 0.5592 19199.5n 0.5592 19200.0n 0.6420 19799.5n 0.6420 19800.0n 0.5602 20399.5n 0.5602 20400.0n 0.6582 20999.5n 0.6582 21000.0n 0.6746 21599.5n 0.6746 21600.0n 0.5580 22199.5n 0.5580 22200.0n 0.5445 22799.5n 0.5445 22800.0n 0.6591 23399.5n 0.6591 23400.0n 0.5844 23999.5n 0.5844 24000.0n 0.5764 24599.5n 0.5764 24600.0n 0.5449 25199.5n 0.5449 25200.0n 0.6656 25799.5n 0.6656 25800.0n 0.6780 26399.5n 0.6780 26400.0n 0.6677 26999.5n 0.6677 27000.0n 0.6704 27599.5n 0.6704 27600.0n 0.6669 28199.5n 0.6669 28200.0n 0.5576 28799.5n 0.5576 28800.0n 0.6597 29399.5n 0.6597 29400.0n 0.6741 29999.5n 0.6741 30000.0n 0.6739 30599.5n 0.6739 30600.0n 0.6710 31199.5n 0.6710 31200.0n 0.6596 31799.5n 0.6596 31800.0n 0.6784 32399.5n 0.6784 32400.0n 0.6776 32999.5n 0.6776 33000.0n 0.6169 33599.5n 0.6169 33600.0n 0.6477 34199.5n 0.6477 34200.0n 0.5535 34799.5n 0.5535 34800.0n 0.6751 35399.5n 0.6751 35400.0n 0.6474 35999.5n 0.6474)
Vxn_who_19_0 xn_who_19_0 0 PWL(0.0n 0.3497 599.5n 0.3497 600.0n 0.3924 1199.5n 0.3924 1200.0n 0.3430 1799.5n 0.3430 1800.0n 0.3550 2399.5n 0.3550 2400.0n 0.3640 2999.5n 0.3640 3000.0n 0.3557 3599.5n 0.3557 3600.0n 0.3433 4199.5n 0.3433 4200.0n 0.3480 4799.5n 0.3480 4800.0n 0.3495 5399.5n 0.3495 5400.0n 0.3499 5999.5n 0.3499 6000.0n 0.3437 6599.5n 0.3437 6600.0n 0.3474 7199.5n 0.3474 7200.0n 0.3835 7799.5n 0.3835 7800.0n 0.3857 8399.5n 0.3857 8400.0n 0.3425 8999.5n 0.3425 9000.0n 0.3498 9599.5n 0.3498 9600.0n 0.3535 10199.5n 0.3535 10200.0n 0.3695 10799.5n 0.3695 10800.0n 0.3404 11399.5n 0.3404 11400.0n 0.3491 11999.5n 0.3491 12000.0n 0.3406 12599.5n 0.3406 12600.0n 0.3545 13199.5n 0.3545 13200.0n 0.3523 13799.5n 0.3523 13800.0n 0.3677 14399.5n 0.3677 14400.0n 0.3502 14999.5n 0.3502 15000.0n 0.3607 15599.5n 0.3607 15600.0n 0.3467 16199.5n 0.3467 16200.0n 0.3614 16799.5n 0.3614 16800.0n 0.3414 17399.5n 0.3414 17400.0n 0.3539 17999.5n 0.3539 18000.0n 0.3300 18599.5n 0.3300 18600.0n 0.4408 19199.5n 0.4408 19200.0n 0.3580 19799.5n 0.3580 19800.0n 0.4398 20399.5n 0.4398 20400.0n 0.3418 20999.5n 0.3418 21000.0n 0.3254 21599.5n 0.3254 21600.0n 0.4420 22199.5n 0.4420 22200.0n 0.4555 22799.5n 0.4555 22800.0n 0.3409 23399.5n 0.3409 23400.0n 0.4156 23999.5n 0.4156 24000.0n 0.4236 24599.5n 0.4236 24600.0n 0.4551 25199.5n 0.4551 25200.0n 0.3344 25799.5n 0.3344 25800.0n 0.3220 26399.5n 0.3220 26400.0n 0.3323 26999.5n 0.3323 27000.0n 0.3296 27599.5n 0.3296 27600.0n 0.3331 28199.5n 0.3331 28200.0n 0.4424 28799.5n 0.4424 28800.0n 0.3403 29399.5n 0.3403 29400.0n 0.3259 29999.5n 0.3259 30000.0n 0.3261 30599.5n 0.3261 30600.0n 0.3290 31199.5n 0.3290 31200.0n 0.3404 31799.5n 0.3404 31800.0n 0.3216 32399.5n 0.3216 32400.0n 0.3224 32999.5n 0.3224 33000.0n 0.3831 33599.5n 0.3831 33600.0n 0.3523 34199.5n 0.3523 34200.0n 0.4465 34799.5n 0.4465 34800.0n 0.3249 35399.5n 0.3249 35400.0n 0.3526 35999.5n 0.3526)
Vyp_who_19_0 yp_who_19_0 0 PWL(0.0n 0.5031 599.5n 0.5031 600.0n 0.5023 1199.5n 0.5023 1200.0n 0.5052 1799.5n 0.5052 1800.0n 0.5048 2399.5n 0.5048 2400.0n 0.5043 2999.5n 0.5043 3000.0n 0.5034 3599.5n 0.5034 3600.0n 0.5048 4199.5n 0.5048 4200.0n 0.5031 4799.5n 0.5031 4800.0n 0.5040 5399.5n 0.5040 5400.0n 0.5040 5999.5n 0.5040 6000.0n 0.5054 6599.5n 0.5054 6600.0n 0.5040 7199.5n 0.5040 7200.0n 0.5027 7799.5n 0.5027 7800.0n 0.5027 8399.5n 0.5027 8400.0n 0.5038 8999.5n 0.5038 9000.0n 0.5040 9599.5n 0.5040 9600.0n 0.5039 10199.5n 0.5039 10200.0n 0.5033 10799.5n 0.5033 10800.0n 0.5056 11399.5n 0.5056 11400.0n 0.5040 11999.5n 0.5040 12000.0n 0.5036 12599.5n 0.5036 12600.0n 0.5039 13199.5n 0.5039 13200.0n 0.5029 13799.5n 0.5029 13800.0n 0.5025 14399.5n 0.5025 14400.0n 0.5038 14999.5n 0.5038 15000.0n 0.5041 15599.5n 0.5041 15600.0n 0.5036 16199.5n 0.5036 16200.0n 0.5025 16799.5n 0.5025 16800.0n 0.5040 17399.5n 0.5040 17400.0n 0.5029 17999.5n 0.5029 18000.0n 0.5057 18599.5n 0.5057 18600.0n 0.5010 19199.5n 0.5010 19200.0n 0.5041 19799.5n 0.5041 19800.0n 0.5021 20399.5n 0.5021 20400.0n 0.5044 20999.5n 0.5044 21000.0n 0.5056 21599.5n 0.5056 21600.0n 0.5016 22199.5n 0.5016 22200.0n 0.5006 22799.5n 0.5006 22800.0n 0.5041 23399.5n 0.5041 23400.0n 0.5027 23999.5n 0.5027 24000.0n 0.5029 24599.5n 0.5029 24600.0n 0.5006 25199.5n 0.5006 25200.0n 0.5047 25799.5n 0.5047 25800.0n 0.5046 26399.5n 0.5046 26400.0n 0.5039 26999.5n 0.5039 27000.0n 0.5049 27599.5n 0.5049 27600.0n 0.5039 28199.5n 0.5039 28200.0n 0.5017 28799.5n 0.5017 28800.0n 0.5042 29399.5n 0.5042 29400.0n 0.5056 29999.5n 0.5056 30000.0n 0.5051 30599.5n 0.5051 30600.0n 0.5039 31199.5n 0.5039 31200.0n 0.5033 31799.5n 0.5033 31800.0n 0.5049 32399.5n 0.5049 32400.0n 0.5045 32999.5n 0.5045 33000.0n 0.5036 33599.5n 0.5036 33600.0n 0.5042 34199.5n 0.5042 34200.0n 0.5012 34799.5n 0.5012 34800.0n 0.5036 35399.5n 0.5036 35400.0n 0.5042 35999.5n 0.5042)
Vyn_who_19_0 yn_who_19_0 0 PWL(0.0n 0.4969 599.5n 0.4969 600.0n 0.4977 1199.5n 0.4977 1200.0n 0.4948 1799.5n 0.4948 1800.0n 0.4952 2399.5n 0.4952 2400.0n 0.4957 2999.5n 0.4957 3000.0n 0.4966 3599.5n 0.4966 3600.0n 0.4952 4199.5n 0.4952 4200.0n 0.4969 4799.5n 0.4969 4800.0n 0.4960 5399.5n 0.4960 5400.0n 0.4960 5999.5n 0.4960 6000.0n 0.4946 6599.5n 0.4946 6600.0n 0.4960 7199.5n 0.4960 7200.0n 0.4973 7799.5n 0.4973 7800.0n 0.4973 8399.5n 0.4973 8400.0n 0.4962 8999.5n 0.4962 9000.0n 0.4960 9599.5n 0.4960 9600.0n 0.4961 10199.5n 0.4961 10200.0n 0.4967 10799.5n 0.4967 10800.0n 0.4944 11399.5n 0.4944 11400.0n 0.4960 11999.5n 0.4960 12000.0n 0.4964 12599.5n 0.4964 12600.0n 0.4961 13199.5n 0.4961 13200.0n 0.4971 13799.5n 0.4971 13800.0n 0.4975 14399.5n 0.4975 14400.0n 0.4962 14999.5n 0.4962 15000.0n 0.4959 15599.5n 0.4959 15600.0n 0.4964 16199.5n 0.4964 16200.0n 0.4975 16799.5n 0.4975 16800.0n 0.4960 17399.5n 0.4960 17400.0n 0.4971 17999.5n 0.4971 18000.0n 0.4943 18599.5n 0.4943 18600.0n 0.4990 19199.5n 0.4990 19200.0n 0.4959 19799.5n 0.4959 19800.0n 0.4979 20399.5n 0.4979 20400.0n 0.4956 20999.5n 0.4956 21000.0n 0.4944 21599.5n 0.4944 21600.0n 0.4984 22199.5n 0.4984 22200.0n 0.4994 22799.5n 0.4994 22800.0n 0.4959 23399.5n 0.4959 23400.0n 0.4973 23999.5n 0.4973 24000.0n 0.4971 24599.5n 0.4971 24600.0n 0.4994 25199.5n 0.4994 25200.0n 0.4953 25799.5n 0.4953 25800.0n 0.4954 26399.5n 0.4954 26400.0n 0.4961 26999.5n 0.4961 27000.0n 0.4951 27599.5n 0.4951 27600.0n 0.4961 28199.5n 0.4961 28200.0n 0.4983 28799.5n 0.4983 28800.0n 0.4958 29399.5n 0.4958 29400.0n 0.4944 29999.5n 0.4944 30000.0n 0.4949 30599.5n 0.4949 30600.0n 0.4961 31199.5n 0.4961 31200.0n 0.4967 31799.5n 0.4967 31800.0n 0.4951 32399.5n 0.4951 32400.0n 0.4955 32999.5n 0.4955 33000.0n 0.4964 33599.5n 0.4964 33600.0n 0.4958 34199.5n 0.4958 34200.0n 0.4988 34799.5n 0.4988 34800.0n 0.4964 35399.5n 0.4964 35400.0n 0.4958 35999.5n 0.4958)
Cwp_who_19_0 wp_who_19_0 0 400p
Cwn_who_19_0 wn_who_19_0 0 400p
Xu_who_19_0 xp_who_19_0 xn_who_19_0 yp_who_19_0 yn_who_19_0 wp_who_19_0 wn_who_19_0 vdd gbn gprod
Vxp_who_19_1 xp_who_19_1 0 PWL(0.0n 0.6503 599.5n 0.6503 600.0n 0.6076 1199.5n 0.6076 1200.0n 0.6570 1799.5n 0.6570 1800.0n 0.6450 2399.5n 0.6450 2400.0n 0.6360 2999.5n 0.6360 3000.0n 0.6443 3599.5n 0.6443 3600.0n 0.6567 4199.5n 0.6567 4200.0n 0.6520 4799.5n 0.6520 4800.0n 0.6505 5399.5n 0.6505 5400.0n 0.6501 5999.5n 0.6501 6000.0n 0.6563 6599.5n 0.6563 6600.0n 0.6526 7199.5n 0.6526 7200.0n 0.6165 7799.5n 0.6165 7800.0n 0.6143 8399.5n 0.6143 8400.0n 0.6575 8999.5n 0.6575 9000.0n 0.6502 9599.5n 0.6502 9600.0n 0.6465 10199.5n 0.6465 10200.0n 0.6305 10799.5n 0.6305 10800.0n 0.6596 11399.5n 0.6596 11400.0n 0.6509 11999.5n 0.6509 12000.0n 0.6594 12599.5n 0.6594 12600.0n 0.6455 13199.5n 0.6455 13200.0n 0.6477 13799.5n 0.6477 13800.0n 0.6323 14399.5n 0.6323 14400.0n 0.6498 14999.5n 0.6498 15000.0n 0.6393 15599.5n 0.6393 15600.0n 0.6533 16199.5n 0.6533 16200.0n 0.6386 16799.5n 0.6386 16800.0n 0.6586 17399.5n 0.6586 17400.0n 0.6461 17999.5n 0.6461 18000.0n 0.6700 18599.5n 0.6700 18600.0n 0.5592 19199.5n 0.5592 19200.0n 0.6420 19799.5n 0.6420 19800.0n 0.5602 20399.5n 0.5602 20400.0n 0.6582 20999.5n 0.6582 21000.0n 0.6746 21599.5n 0.6746 21600.0n 0.5580 22199.5n 0.5580 22200.0n 0.5445 22799.5n 0.5445 22800.0n 0.6591 23399.5n 0.6591 23400.0n 0.5844 23999.5n 0.5844 24000.0n 0.5764 24599.5n 0.5764 24600.0n 0.5449 25199.5n 0.5449 25200.0n 0.6656 25799.5n 0.6656 25800.0n 0.6780 26399.5n 0.6780 26400.0n 0.6677 26999.5n 0.6677 27000.0n 0.6704 27599.5n 0.6704 27600.0n 0.6669 28199.5n 0.6669 28200.0n 0.5576 28799.5n 0.5576 28800.0n 0.6597 29399.5n 0.6597 29400.0n 0.6741 29999.5n 0.6741 30000.0n 0.6739 30599.5n 0.6739 30600.0n 0.6710 31199.5n 0.6710 31200.0n 0.6596 31799.5n 0.6596 31800.0n 0.6784 32399.5n 0.6784 32400.0n 0.6776 32999.5n 0.6776 33000.0n 0.6169 33599.5n 0.6169 33600.0n 0.6477 34199.5n 0.6477 34200.0n 0.5535 34799.5n 0.5535 34800.0n 0.6751 35399.5n 0.6751 35400.0n 0.6474 35999.5n 0.6474)
Vxn_who_19_1 xn_who_19_1 0 PWL(0.0n 0.3497 599.5n 0.3497 600.0n 0.3924 1199.5n 0.3924 1200.0n 0.3430 1799.5n 0.3430 1800.0n 0.3550 2399.5n 0.3550 2400.0n 0.3640 2999.5n 0.3640 3000.0n 0.3557 3599.5n 0.3557 3600.0n 0.3433 4199.5n 0.3433 4200.0n 0.3480 4799.5n 0.3480 4800.0n 0.3495 5399.5n 0.3495 5400.0n 0.3499 5999.5n 0.3499 6000.0n 0.3437 6599.5n 0.3437 6600.0n 0.3474 7199.5n 0.3474 7200.0n 0.3835 7799.5n 0.3835 7800.0n 0.3857 8399.5n 0.3857 8400.0n 0.3425 8999.5n 0.3425 9000.0n 0.3498 9599.5n 0.3498 9600.0n 0.3535 10199.5n 0.3535 10200.0n 0.3695 10799.5n 0.3695 10800.0n 0.3404 11399.5n 0.3404 11400.0n 0.3491 11999.5n 0.3491 12000.0n 0.3406 12599.5n 0.3406 12600.0n 0.3545 13199.5n 0.3545 13200.0n 0.3523 13799.5n 0.3523 13800.0n 0.3677 14399.5n 0.3677 14400.0n 0.3502 14999.5n 0.3502 15000.0n 0.3607 15599.5n 0.3607 15600.0n 0.3467 16199.5n 0.3467 16200.0n 0.3614 16799.5n 0.3614 16800.0n 0.3414 17399.5n 0.3414 17400.0n 0.3539 17999.5n 0.3539 18000.0n 0.3300 18599.5n 0.3300 18600.0n 0.4408 19199.5n 0.4408 19200.0n 0.3580 19799.5n 0.3580 19800.0n 0.4398 20399.5n 0.4398 20400.0n 0.3418 20999.5n 0.3418 21000.0n 0.3254 21599.5n 0.3254 21600.0n 0.4420 22199.5n 0.4420 22200.0n 0.4555 22799.5n 0.4555 22800.0n 0.3409 23399.5n 0.3409 23400.0n 0.4156 23999.5n 0.4156 24000.0n 0.4236 24599.5n 0.4236 24600.0n 0.4551 25199.5n 0.4551 25200.0n 0.3344 25799.5n 0.3344 25800.0n 0.3220 26399.5n 0.3220 26400.0n 0.3323 26999.5n 0.3323 27000.0n 0.3296 27599.5n 0.3296 27600.0n 0.3331 28199.5n 0.3331 28200.0n 0.4424 28799.5n 0.4424 28800.0n 0.3403 29399.5n 0.3403 29400.0n 0.3259 29999.5n 0.3259 30000.0n 0.3261 30599.5n 0.3261 30600.0n 0.3290 31199.5n 0.3290 31200.0n 0.3404 31799.5n 0.3404 31800.0n 0.3216 32399.5n 0.3216 32400.0n 0.3224 32999.5n 0.3224 33000.0n 0.3831 33599.5n 0.3831 33600.0n 0.3523 34199.5n 0.3523 34200.0n 0.4465 34799.5n 0.4465 34800.0n 0.3249 35399.5n 0.3249 35400.0n 0.3526 35999.5n 0.3526)
Vyp_who_19_1 yp_who_19_1 0 PWL(0.0n 0.5071 599.5n 0.5071 600.0n 0.5053 1199.5n 0.5053 1200.0n 0.5052 1799.5n 0.5052 1800.0n 0.5027 2399.5n 0.5027 2400.0n 0.5034 2999.5n 0.5034 3000.0n 0.5055 3599.5n 0.5055 3600.0n 0.5056 4199.5n 0.5056 4200.0n 0.5071 4799.5n 0.5071 4800.0n 0.5056 5399.5n 0.5056 5400.0n 0.5056 5999.5n 0.5056 6000.0n 0.5048 6599.5n 0.5048 6600.0n 0.5060 7199.5n 0.5060 7200.0n 0.5048 7799.5n 0.5048 7800.0n 0.5046 8399.5n 0.5046 8400.0n 0.5066 8999.5n 0.5066 9000.0n 0.5056 9599.5n 0.5056 9600.0n 0.5051 10199.5n 0.5051 10200.0n 0.5046 10799.5n 0.5046 10800.0n 0.5056 11399.5n 0.5056 11400.0n 0.5058 11999.5n 0.5058 12000.0n 0.5068 12599.5n 0.5068 12600.0n 0.5050 13199.5n 0.5050 13200.0n 0.5071 13799.5n 0.5071 13800.0n 0.5059 14399.5n 0.5059 14400.0n 0.5058 14999.5n 0.5058 15000.0n 0.5043 15599.5n 0.5043 15600.0n 0.5067 16199.5n 0.5067 16200.0n 0.5068 16799.5n 0.5068 16800.0n 0.5066 17399.5n 0.5066 17400.0n 0.5069 17999.5n 0.5069 18000.0n 0.5061 18599.5n 0.5061 18600.0n 0.5034 19199.5n 0.5034 19200.0n 0.5010 19799.5n 0.5010 19800.0n 0.4989 20399.5n 0.4989 20400.0n 0.5022 20999.5n 0.5022 21000.0n 0.5086 21599.5n 0.5086 21600.0n 0.5007 22199.5n 0.5007 22200.0n 0.5023 22799.5n 0.5023 22800.0n 0.5021 23399.5n 0.5021 23400.0n 0.5077 23999.5n 0.5077 24000.0n 0.4979 24599.5n 0.4979 24600.0n 0.5035 25199.5n 0.5035 25200.0n 0.5041 25799.5n 0.5041 25800.0n 0.5075 26399.5n 0.5075 26400.0n 0.5041 26999.5n 0.5041 27000.0n 0.5056 27599.5n 0.5056 27600.0n 0.5039 28199.5n 0.5039 28200.0n 0.5059 28799.5n 0.5059 28800.0n 0.5023 29399.5n 0.5023 29400.0n 0.5086 29999.5n 0.5086 30000.0n 0.5084 30599.5n 0.5084 30600.0n 0.5085 31199.5n 0.5085 31200.0n 0.5088 31799.5n 0.5088 31800.0n 0.5078 32399.5n 0.5078 32400.0n 0.5074 32999.5n 0.5074 33000.0n 0.4996 33599.5n 0.4996 33600.0n 0.5010 34199.5n 0.5010 34200.0n 0.5044 34799.5n 0.5044 34800.0n 0.5084 35399.5n 0.5084 35400.0n 0.5012 35999.5n 0.5012)
Vyn_who_19_1 yn_who_19_1 0 PWL(0.0n 0.4929 599.5n 0.4929 600.0n 0.4947 1199.5n 0.4947 1200.0n 0.4948 1799.5n 0.4948 1800.0n 0.4973 2399.5n 0.4973 2400.0n 0.4966 2999.5n 0.4966 3000.0n 0.4945 3599.5n 0.4945 3600.0n 0.4944 4199.5n 0.4944 4200.0n 0.4929 4799.5n 0.4929 4800.0n 0.4944 5399.5n 0.4944 5400.0n 0.4944 5999.5n 0.4944 6000.0n 0.4952 6599.5n 0.4952 6600.0n 0.4940 7199.5n 0.4940 7200.0n 0.4952 7799.5n 0.4952 7800.0n 0.4954 8399.5n 0.4954 8400.0n 0.4934 8999.5n 0.4934 9000.0n 0.4944 9599.5n 0.4944 9600.0n 0.4949 10199.5n 0.4949 10200.0n 0.4954 10799.5n 0.4954 10800.0n 0.4944 11399.5n 0.4944 11400.0n 0.4942 11999.5n 0.4942 12000.0n 0.4932 12599.5n 0.4932 12600.0n 0.4950 13199.5n 0.4950 13200.0n 0.4929 13799.5n 0.4929 13800.0n 0.4941 14399.5n 0.4941 14400.0n 0.4942 14999.5n 0.4942 15000.0n 0.4957 15599.5n 0.4957 15600.0n 0.4933 16199.5n 0.4933 16200.0n 0.4932 16799.5n 0.4932 16800.0n 0.4934 17399.5n 0.4934 17400.0n 0.4931 17999.5n 0.4931 18000.0n 0.4939 18599.5n 0.4939 18600.0n 0.4966 19199.5n 0.4966 19200.0n 0.4990 19799.5n 0.4990 19800.0n 0.5011 20399.5n 0.5011 20400.0n 0.4978 20999.5n 0.4978 21000.0n 0.4914 21599.5n 0.4914 21600.0n 0.4993 22199.5n 0.4993 22200.0n 0.4977 22799.5n 0.4977 22800.0n 0.4979 23399.5n 0.4979 23400.0n 0.4923 23999.5n 0.4923 24000.0n 0.5021 24599.5n 0.5021 24600.0n 0.4965 25199.5n 0.4965 25200.0n 0.4959 25799.5n 0.4959 25800.0n 0.4925 26399.5n 0.4925 26400.0n 0.4959 26999.5n 0.4959 27000.0n 0.4944 27599.5n 0.4944 27600.0n 0.4961 28199.5n 0.4961 28200.0n 0.4941 28799.5n 0.4941 28800.0n 0.4977 29399.5n 0.4977 29400.0n 0.4914 29999.5n 0.4914 30000.0n 0.4916 30599.5n 0.4916 30600.0n 0.4915 31199.5n 0.4915 31200.0n 0.4912 31799.5n 0.4912 31800.0n 0.4922 32399.5n 0.4922 32400.0n 0.4926 32999.5n 0.4926 33000.0n 0.5004 33599.5n 0.5004 33600.0n 0.4990 34199.5n 0.4990 34200.0n 0.4956 34799.5n 0.4956 34800.0n 0.4916 35399.5n 0.4916 35400.0n 0.4988 35999.5n 0.4988)
Cwp_who_19_1 wp_who_19_1 0 400p
Cwn_who_19_1 wn_who_19_1 0 400p
Xu_who_19_1 xp_who_19_1 xn_who_19_1 yp_who_19_1 yn_who_19_1 wp_who_19_1 wn_who_19_1 vdd gbn gprod
Vxp_bh_19 xp_bh_19 0 PWL(0.0n 0.7100 599.5n 0.7100 600.0n 0.7100 1199.5n 0.7100 1200.0n 0.7100 1799.5n 0.7100 1800.0n 0.7100 2399.5n 0.7100 2400.0n 0.7100 2999.5n 0.7100 3000.0n 0.7100 3599.5n 0.7100 3600.0n 0.7100 4199.5n 0.7100 4200.0n 0.7100 4799.5n 0.7100 4800.0n 0.7100 5399.5n 0.7100 5400.0n 0.7100 5999.5n 0.7100 6000.0n 0.7100 6599.5n 0.7100 6600.0n 0.7100 7199.5n 0.7100 7200.0n 0.7100 7799.5n 0.7100 7800.0n 0.7100 8399.5n 0.7100 8400.0n 0.7100 8999.5n 0.7100 9000.0n 0.7100 9599.5n 0.7100 9600.0n 0.7100 10199.5n 0.7100 10200.0n 0.7100 10799.5n 0.7100 10800.0n 0.7100 11399.5n 0.7100 11400.0n 0.7100 11999.5n 0.7100 12000.0n 0.7100 12599.5n 0.7100 12600.0n 0.7100 13199.5n 0.7100 13200.0n 0.7100 13799.5n 0.7100 13800.0n 0.7100 14399.5n 0.7100 14400.0n 0.7100 14999.5n 0.7100 15000.0n 0.7100 15599.5n 0.7100 15600.0n 0.7100 16199.5n 0.7100 16200.0n 0.7100 16799.5n 0.7100 16800.0n 0.7100 17399.5n 0.7100 17400.0n 0.7100 17999.5n 0.7100 18000.0n 0.7100 18599.5n 0.7100 18600.0n 0.7100 19199.5n 0.7100 19200.0n 0.7100 19799.5n 0.7100 19800.0n 0.7100 20399.5n 0.7100 20400.0n 0.7100 20999.5n 0.7100 21000.0n 0.7100 21599.5n 0.7100 21600.0n 0.7100 22199.5n 0.7100 22200.0n 0.7100 22799.5n 0.7100 22800.0n 0.7100 23399.5n 0.7100 23400.0n 0.7100 23999.5n 0.7100 24000.0n 0.7100 24599.5n 0.7100 24600.0n 0.7100 25199.5n 0.7100 25200.0n 0.7100 25799.5n 0.7100 25800.0n 0.7100 26399.5n 0.7100 26400.0n 0.7100 26999.5n 0.7100 27000.0n 0.7100 27599.5n 0.7100 27600.0n 0.7100 28199.5n 0.7100 28200.0n 0.7100 28799.5n 0.7100 28800.0n 0.7100 29399.5n 0.7100 29400.0n 0.7100 29999.5n 0.7100 30000.0n 0.7100 30599.5n 0.7100 30600.0n 0.7100 31199.5n 0.7100 31200.0n 0.7100 31799.5n 0.7100 31800.0n 0.7100 32399.5n 0.7100 32400.0n 0.7100 32999.5n 0.7100 33000.0n 0.7100 33599.5n 0.7100 33600.0n 0.7100 34199.5n 0.7100 34200.0n 0.7100 34799.5n 0.7100 34800.0n 0.7100 35399.5n 0.7100 35400.0n 0.7100 35999.5n 0.7100)
Vxn_bh_19 xn_bh_19 0 PWL(0.0n 0.2900 599.5n 0.2900 600.0n 0.2900 1199.5n 0.2900 1200.0n 0.2900 1799.5n 0.2900 1800.0n 0.2900 2399.5n 0.2900 2400.0n 0.2900 2999.5n 0.2900 3000.0n 0.2900 3599.5n 0.2900 3600.0n 0.2900 4199.5n 0.2900 4200.0n 0.2900 4799.5n 0.2900 4800.0n 0.2900 5399.5n 0.2900 5400.0n 0.2900 5999.5n 0.2900 6000.0n 0.2900 6599.5n 0.2900 6600.0n 0.2900 7199.5n 0.2900 7200.0n 0.2900 7799.5n 0.2900 7800.0n 0.2900 8399.5n 0.2900 8400.0n 0.2900 8999.5n 0.2900 9000.0n 0.2900 9599.5n 0.2900 9600.0n 0.2900 10199.5n 0.2900 10200.0n 0.2900 10799.5n 0.2900 10800.0n 0.2900 11399.5n 0.2900 11400.0n 0.2900 11999.5n 0.2900 12000.0n 0.2900 12599.5n 0.2900 12600.0n 0.2900 13199.5n 0.2900 13200.0n 0.2900 13799.5n 0.2900 13800.0n 0.2900 14399.5n 0.2900 14400.0n 0.2900 14999.5n 0.2900 15000.0n 0.2900 15599.5n 0.2900 15600.0n 0.2900 16199.5n 0.2900 16200.0n 0.2900 16799.5n 0.2900 16800.0n 0.2900 17399.5n 0.2900 17400.0n 0.2900 17999.5n 0.2900 18000.0n 0.2900 18599.5n 0.2900 18600.0n 0.2900 19199.5n 0.2900 19200.0n 0.2900 19799.5n 0.2900 19800.0n 0.2900 20399.5n 0.2900 20400.0n 0.2900 20999.5n 0.2900 21000.0n 0.2900 21599.5n 0.2900 21600.0n 0.2900 22199.5n 0.2900 22200.0n 0.2900 22799.5n 0.2900 22800.0n 0.2900 23399.5n 0.2900 23400.0n 0.2900 23999.5n 0.2900 24000.0n 0.2900 24599.5n 0.2900 24600.0n 0.2900 25199.5n 0.2900 25200.0n 0.2900 25799.5n 0.2900 25800.0n 0.2900 26399.5n 0.2900 26400.0n 0.2900 26999.5n 0.2900 27000.0n 0.2900 27599.5n 0.2900 27600.0n 0.2900 28199.5n 0.2900 28200.0n 0.2900 28799.5n 0.2900 28800.0n 0.2900 29399.5n 0.2900 29400.0n 0.2900 29999.5n 0.2900 30000.0n 0.2900 30599.5n 0.2900 30600.0n 0.2900 31199.5n 0.2900 31200.0n 0.2900 31799.5n 0.2900 31800.0n 0.2900 32399.5n 0.2900 32400.0n 0.2900 32999.5n 0.2900 33000.0n 0.2900 33599.5n 0.2900 33600.0n 0.2900 34199.5n 0.2900 34200.0n 0.2900 34799.5n 0.2900 34800.0n 0.2900 35399.5n 0.2900 35400.0n 0.2900 35999.5n 0.2900)
Vyp_bh_19 yp_bh_19 0 PWL(0.0n 0.6503 599.5n 0.6503 600.0n 0.6076 1199.5n 0.6076 1200.0n 0.6570 1799.5n 0.6570 1800.0n 0.6450 2399.5n 0.6450 2400.0n 0.6360 2999.5n 0.6360 3000.0n 0.6443 3599.5n 0.6443 3600.0n 0.6567 4199.5n 0.6567 4200.0n 0.6520 4799.5n 0.6520 4800.0n 0.6505 5399.5n 0.6505 5400.0n 0.6501 5999.5n 0.6501 6000.0n 0.6563 6599.5n 0.6563 6600.0n 0.6526 7199.5n 0.6526 7200.0n 0.6165 7799.5n 0.6165 7800.0n 0.6143 8399.5n 0.6143 8400.0n 0.6575 8999.5n 0.6575 9000.0n 0.6502 9599.5n 0.6502 9600.0n 0.6465 10199.5n 0.6465 10200.0n 0.6305 10799.5n 0.6305 10800.0n 0.6596 11399.5n 0.6596 11400.0n 0.6509 11999.5n 0.6509 12000.0n 0.6594 12599.5n 0.6594 12600.0n 0.6455 13199.5n 0.6455 13200.0n 0.6477 13799.5n 0.6477 13800.0n 0.6323 14399.5n 0.6323 14400.0n 0.6498 14999.5n 0.6498 15000.0n 0.6393 15599.5n 0.6393 15600.0n 0.6533 16199.5n 0.6533 16200.0n 0.6386 16799.5n 0.6386 16800.0n 0.6586 17399.5n 0.6586 17400.0n 0.6461 17999.5n 0.6461 18000.0n 0.6700 18599.5n 0.6700 18600.0n 0.5592 19199.5n 0.5592 19200.0n 0.6420 19799.5n 0.6420 19800.0n 0.5602 20399.5n 0.5602 20400.0n 0.6582 20999.5n 0.6582 21000.0n 0.6746 21599.5n 0.6746 21600.0n 0.5580 22199.5n 0.5580 22200.0n 0.5445 22799.5n 0.5445 22800.0n 0.6591 23399.5n 0.6591 23400.0n 0.5844 23999.5n 0.5844 24000.0n 0.5764 24599.5n 0.5764 24600.0n 0.5449 25199.5n 0.5449 25200.0n 0.6656 25799.5n 0.6656 25800.0n 0.6780 26399.5n 0.6780 26400.0n 0.6677 26999.5n 0.6677 27000.0n 0.6704 27599.5n 0.6704 27600.0n 0.6669 28199.5n 0.6669 28200.0n 0.5576 28799.5n 0.5576 28800.0n 0.6597 29399.5n 0.6597 29400.0n 0.6741 29999.5n 0.6741 30000.0n 0.6739 30599.5n 0.6739 30600.0n 0.6710 31199.5n 0.6710 31200.0n 0.6596 31799.5n 0.6596 31800.0n 0.6784 32399.5n 0.6784 32400.0n 0.6776 32999.5n 0.6776 33000.0n 0.6169 33599.5n 0.6169 33600.0n 0.6477 34199.5n 0.6477 34200.0n 0.5535 34799.5n 0.5535 34800.0n 0.6751 35399.5n 0.6751 35400.0n 0.6474 35999.5n 0.6474)
Vyn_bh_19 yn_bh_19 0 PWL(0.0n 0.3497 599.5n 0.3497 600.0n 0.3924 1199.5n 0.3924 1200.0n 0.3430 1799.5n 0.3430 1800.0n 0.3550 2399.5n 0.3550 2400.0n 0.3640 2999.5n 0.3640 3000.0n 0.3557 3599.5n 0.3557 3600.0n 0.3433 4199.5n 0.3433 4200.0n 0.3480 4799.5n 0.3480 4800.0n 0.3495 5399.5n 0.3495 5400.0n 0.3499 5999.5n 0.3499 6000.0n 0.3437 6599.5n 0.3437 6600.0n 0.3474 7199.5n 0.3474 7200.0n 0.3835 7799.5n 0.3835 7800.0n 0.3857 8399.5n 0.3857 8400.0n 0.3425 8999.5n 0.3425 9000.0n 0.3498 9599.5n 0.3498 9600.0n 0.3535 10199.5n 0.3535 10200.0n 0.3695 10799.5n 0.3695 10800.0n 0.3404 11399.5n 0.3404 11400.0n 0.3491 11999.5n 0.3491 12000.0n 0.3406 12599.5n 0.3406 12600.0n 0.3545 13199.5n 0.3545 13200.0n 0.3523 13799.5n 0.3523 13800.0n 0.3677 14399.5n 0.3677 14400.0n 0.3502 14999.5n 0.3502 15000.0n 0.3607 15599.5n 0.3607 15600.0n 0.3467 16199.5n 0.3467 16200.0n 0.3614 16799.5n 0.3614 16800.0n 0.3414 17399.5n 0.3414 17400.0n 0.3539 17999.5n 0.3539 18000.0n 0.3300 18599.5n 0.3300 18600.0n 0.4408 19199.5n 0.4408 19200.0n 0.3580 19799.5n 0.3580 19800.0n 0.4398 20399.5n 0.4398 20400.0n 0.3418 20999.5n 0.3418 21000.0n 0.3254 21599.5n 0.3254 21600.0n 0.4420 22199.5n 0.4420 22200.0n 0.4555 22799.5n 0.4555 22800.0n 0.3409 23399.5n 0.3409 23400.0n 0.4156 23999.5n 0.4156 24000.0n 0.4236 24599.5n 0.4236 24600.0n 0.4551 25199.5n 0.4551 25200.0n 0.3344 25799.5n 0.3344 25800.0n 0.3220 26399.5n 0.3220 26400.0n 0.3323 26999.5n 0.3323 27000.0n 0.3296 27599.5n 0.3296 27600.0n 0.3331 28199.5n 0.3331 28200.0n 0.4424 28799.5n 0.4424 28800.0n 0.3403 29399.5n 0.3403 29400.0n 0.3259 29999.5n 0.3259 30000.0n 0.3261 30599.5n 0.3261 30600.0n 0.3290 31199.5n 0.3290 31200.0n 0.3404 31799.5n 0.3404 31800.0n 0.3216 32399.5n 0.3216 32400.0n 0.3224 32999.5n 0.3224 33000.0n 0.3831 33599.5n 0.3831 33600.0n 0.3523 34199.5n 0.3523 34200.0n 0.4465 34799.5n 0.4465 34800.0n 0.3249 35399.5n 0.3249 35400.0n 0.3526 35999.5n 0.3526)
Cwp_bh_19 wp_bh_19 0 400p
Cwn_bh_19 wn_bh_19 0 400p
Xu_bh_19 xp_bh_19 xn_bh_19 yp_bh_19 yn_bh_19 wp_bh_19 wn_bh_19 vdd gbn gprod
Vxp_wih_0_20 xp_wih_0_20 0 PWL(0.0n 0.4942 599.5n 0.4942 600.0n 0.5558 1199.5n 0.5558 1200.0n 0.4708 1799.5n 0.4708 1800.0n 0.5235 2399.5n 0.5235 2400.0n 0.5350 2999.5n 0.5350 3000.0n 0.5172 3599.5n 0.5172 3600.0n 0.4702 4199.5n 0.4702 4200.0n 0.4867 4799.5n 0.4867 4800.0n 0.4970 5399.5n 0.4970 5400.0n 0.4986 5999.5n 0.4986 6000.0n 0.4751 6599.5n 0.4751 6600.0n 0.4870 7199.5n 0.4870 7200.0n 0.5502 7799.5n 0.5502 7800.0n 0.5521 8399.5n 0.5521 8400.0n 0.4638 8999.5n 0.4638 9000.0n 0.4982 9599.5n 0.4982 9600.0n 0.5131 10199.5n 0.5131 10200.0n 0.5386 10799.5n 0.5386 10800.0n 0.4592 11399.5n 0.4592 11400.0n 0.4950 11999.5n 0.4950 12000.0n 0.4559 12599.5n 0.4559 12600.0n 0.5162 13199.5n 0.5162 13200.0n 0.5038 13799.5n 0.5038 13800.0n 0.5333 14399.5n 0.5333 14400.0n 0.4991 14999.5n 0.4991 15000.0n 0.5298 15599.5n 0.5298 15600.0n 0.4823 16199.5n 0.4823 16200.0n 0.5239 16799.5n 0.5239 16800.0n 0.4592 17399.5n 0.4592 17400.0n 0.5094 17999.5n 0.5094 18000.0n 0.4337 18599.5n 0.4337 18600.0n 0.5977 19199.5n 0.5977 19200.0n 0.5364 19799.5n 0.5364 19800.0n 0.6122 20399.5n 0.6122 20400.0n 0.4856 20999.5n 0.4856 21000.0n 0.3861 21599.5n 0.3861 21600.0n 0.6094 22199.5n 0.6094 22200.0n 0.6364 22799.5n 0.6364 22800.0n 0.4807 23399.5n 0.4807 23400.0n 0.5614 23999.5n 0.5614 24000.0n 0.5913 24599.5n 0.5913 24600.0n 0.6295 25199.5n 0.6295 25200.0n 0.4496 25799.5n 0.4496 25800.0n 0.3792 26399.5n 0.3792 26400.0n 0.4434 26999.5n 0.4434 27000.0n 0.4340 27599.5n 0.4340 27600.0n 0.4461 28199.5n 0.4461 28200.0n 0.5791 28799.5n 0.5791 28800.0n 0.4777 29399.5n 0.4777 29400.0n 0.3878 29999.5n 0.3878 30000.0n 0.3832 30599.5n 0.3832 30600.0n 0.4022 31199.5n 0.4022 31200.0n 0.4482 31799.5n 0.4482 31800.0n 0.3662 32399.5n 0.3662 32400.0n 0.3857 32999.5n 0.3857 33000.0n 0.5584 33599.5n 0.5584 33600.0n 0.5284 34199.5n 0.5284 34200.0n 0.6034 34799.5n 0.6034 34800.0n 0.3469 35399.5n 0.3469 35400.0n 0.5290 35999.5n 0.5290)
Vxn_wih_0_20 xn_wih_0_20 0 PWL(0.0n 0.5058 599.5n 0.5058 600.0n 0.4442 1199.5n 0.4442 1200.0n 0.5292 1799.5n 0.5292 1800.0n 0.4765 2399.5n 0.4765 2400.0n 0.4650 2999.5n 0.4650 3000.0n 0.4828 3599.5n 0.4828 3600.0n 0.5298 4199.5n 0.5298 4200.0n 0.5133 4799.5n 0.5133 4800.0n 0.5030 5399.5n 0.5030 5400.0n 0.5014 5999.5n 0.5014 6000.0n 0.5249 6599.5n 0.5249 6600.0n 0.5130 7199.5n 0.5130 7200.0n 0.4498 7799.5n 0.4498 7800.0n 0.4479 8399.5n 0.4479 8400.0n 0.5362 8999.5n 0.5362 9000.0n 0.5018 9599.5n 0.5018 9600.0n 0.4869 10199.5n 0.4869 10200.0n 0.4614 10799.5n 0.4614 10800.0n 0.5408 11399.5n 0.5408 11400.0n 0.5050 11999.5n 0.5050 12000.0n 0.5441 12599.5n 0.5441 12600.0n 0.4838 13199.5n 0.4838 13200.0n 0.4962 13799.5n 0.4962 13800.0n 0.4667 14399.5n 0.4667 14400.0n 0.5009 14999.5n 0.5009 15000.0n 0.4702 15599.5n 0.4702 15600.0n 0.5177 16199.5n 0.5177 16200.0n 0.4761 16799.5n 0.4761 16800.0n 0.5408 17399.5n 0.5408 17400.0n 0.4906 17999.5n 0.4906 18000.0n 0.5663 18599.5n 0.5663 18600.0n 0.4023 19199.5n 0.4023 19200.0n 0.4636 19799.5n 0.4636 19800.0n 0.3878 20399.5n 0.3878 20400.0n 0.5144 20999.5n 0.5144 21000.0n 0.6139 21599.5n 0.6139 21600.0n 0.3906 22199.5n 0.3906 22200.0n 0.3636 22799.5n 0.3636 22800.0n 0.5193 23399.5n 0.5193 23400.0n 0.4386 23999.5n 0.4386 24000.0n 0.4087 24599.5n 0.4087 24600.0n 0.3705 25199.5n 0.3705 25200.0n 0.5504 25799.5n 0.5504 25800.0n 0.6208 26399.5n 0.6208 26400.0n 0.5566 26999.5n 0.5566 27000.0n 0.5660 27599.5n 0.5660 27600.0n 0.5539 28199.5n 0.5539 28200.0n 0.4209 28799.5n 0.4209 28800.0n 0.5223 29399.5n 0.5223 29400.0n 0.6122 29999.5n 0.6122 30000.0n 0.6168 30599.5n 0.6168 30600.0n 0.5978 31199.5n 0.5978 31200.0n 0.5518 31799.5n 0.5518 31800.0n 0.6338 32399.5n 0.6338 32400.0n 0.6143 32999.5n 0.6143 33000.0n 0.4416 33599.5n 0.4416 33600.0n 0.4716 34199.5n 0.4716 34200.0n 0.3966 34799.5n 0.3966 34800.0n 0.6531 35399.5n 0.6531 35400.0n 0.4710 35999.5n 0.4710)
Vyp_wih_0_20 yp_wih_0_20 0 PWL(0.0n 0.3848 599.5n 0.3848 600.0n 0.3752 1199.5n 0.3752 1200.0n 0.4305 1799.5n 0.4305 1800.0n 0.4461 2399.5n 0.4461 2400.0n 0.4282 2999.5n 0.4282 3000.0n 0.3989 3599.5n 0.3989 3600.0n 0.4213 4199.5n 0.4213 4200.0n 0.3857 4799.5n 0.3857 4800.0n 0.4071 5399.5n 0.4071 5400.0n 0.4071 5999.5n 0.4071 6000.0n 0.4356 6599.5n 0.4356 6600.0n 0.4045 7199.5n 0.4045 7200.0n 0.3882 7799.5n 0.3882 7800.0n 0.3903 8399.5n 0.3903 8400.0n 0.4000 8999.5n 0.4000 9000.0n 0.4068 9599.5n 0.4068 9600.0n 0.4100 10199.5n 0.4100 10200.0n 0.4042 10799.5n 0.4042 10800.0n 0.4336 11399.5n 0.4336 11400.0n 0.4048 11999.5n 0.4048 12000.0n 0.3992 12599.5n 0.3992 12600.0n 0.4106 13199.5n 0.4106 13200.0n 0.3810 13799.5n 0.3810 13800.0n 0.3830 14399.5n 0.3830 14400.0n 0.4022 14999.5n 0.4022 15000.0n 0.4170 15599.5n 0.4170 15600.0n 0.3948 16199.5n 0.3948 16200.0n 0.3757 16799.5n 0.3757 16800.0n 0.4038 17399.5n 0.4038 17400.0n 0.3825 17999.5n 0.3825 18000.0n 0.5169 18599.5n 0.5169 18600.0n 0.3534 19199.5n 0.3534 19200.0n 0.4818 19799.5n 0.4818 19800.0n 0.4187 20399.5n 0.4187 20400.0n 0.5047 20999.5n 0.5047 21000.0n 0.4850 21599.5n 0.4850 21600.0n 0.3889 22199.5n 0.3889 22200.0n 0.3534 22799.5n 0.3534 22800.0n 0.5192 23399.5n 0.5192 23400.0n 0.3328 23999.5n 0.3328 24000.0n 0.4525 24599.5n 0.4525 24600.0n 0.3476 25199.5n 0.3476 25200.0n 0.5157 25799.5n 0.5157 25800.0n 0.5604 26399.5n 0.5604 26400.0n 0.5353 26999.5n 0.5353 27000.0n 0.5282 27599.5n 0.5282 27600.0n 0.5334 28199.5n 0.5334 28200.0n 0.3322 28799.5n 0.3322 28800.0n 0.5139 29399.5n 0.5139 29400.0n 0.4745 29999.5n 0.4745 30000.0n 0.4570 30599.5n 0.4570 30600.0n 0.3615 31199.5n 0.3615 31200.0n 0.3468 31799.5n 0.3468 31800.0n 0.5528 32399.5n 0.5528 32400.0n 0.5615 32999.5n 0.5615 33000.0n 0.4760 33599.5n 0.4760 33600.0n 0.5001 34199.5n 0.5001 34200.0n 0.3440 34799.5n 0.3440 34800.0n 0.4244 35399.5n 0.4244 35400.0n 0.4907 35999.5n 0.4907)
Vyn_wih_0_20 yn_wih_0_20 0 PWL(0.0n 0.6152 599.5n 0.6152 600.0n 0.6248 1199.5n 0.6248 1200.0n 0.5695 1799.5n 0.5695 1800.0n 0.5539 2399.5n 0.5539 2400.0n 0.5718 2999.5n 0.5718 3000.0n 0.6011 3599.5n 0.6011 3600.0n 0.5787 4199.5n 0.5787 4200.0n 0.6143 4799.5n 0.6143 4800.0n 0.5929 5399.5n 0.5929 5400.0n 0.5929 5999.5n 0.5929 6000.0n 0.5644 6599.5n 0.5644 6600.0n 0.5955 7199.5n 0.5955 7200.0n 0.6118 7799.5n 0.6118 7800.0n 0.6097 8399.5n 0.6097 8400.0n 0.6000 8999.5n 0.6000 9000.0n 0.5932 9599.5n 0.5932 9600.0n 0.5900 10199.5n 0.5900 10200.0n 0.5958 10799.5n 0.5958 10800.0n 0.5664 11399.5n 0.5664 11400.0n 0.5952 11999.5n 0.5952 12000.0n 0.6008 12599.5n 0.6008 12600.0n 0.5894 13199.5n 0.5894 13200.0n 0.6190 13799.5n 0.6190 13800.0n 0.6170 14399.5n 0.6170 14400.0n 0.5978 14999.5n 0.5978 15000.0n 0.5830 15599.5n 0.5830 15600.0n 0.6052 16199.5n 0.6052 16200.0n 0.6243 16799.5n 0.6243 16800.0n 0.5962 17399.5n 0.5962 17400.0n 0.6175 17999.5n 0.6175 18000.0n 0.4831 18599.5n 0.4831 18600.0n 0.6466 19199.5n 0.6466 19200.0n 0.5182 19799.5n 0.5182 19800.0n 0.5813 20399.5n 0.5813 20400.0n 0.4953 20999.5n 0.4953 21000.0n 0.5150 21599.5n 0.5150 21600.0n 0.6111 22199.5n 0.6111 22200.0n 0.6466 22799.5n 0.6466 22800.0n 0.4808 23399.5n 0.4808 23400.0n 0.6672 23999.5n 0.6672 24000.0n 0.5475 24599.5n 0.5475 24600.0n 0.6524 25199.5n 0.6524 25200.0n 0.4843 25799.5n 0.4843 25800.0n 0.4396 26399.5n 0.4396 26400.0n 0.4647 26999.5n 0.4647 27000.0n 0.4718 27599.5n 0.4718 27600.0n 0.4666 28199.5n 0.4666 28200.0n 0.6678 28799.5n 0.6678 28800.0n 0.4861 29399.5n 0.4861 29400.0n 0.5255 29999.5n 0.5255 30000.0n 0.5430 30599.5n 0.5430 30600.0n 0.6385 31199.5n 0.6385 31200.0n 0.6532 31799.5n 0.6532 31800.0n 0.4472 32399.5n 0.4472 32400.0n 0.4385 32999.5n 0.4385 33000.0n 0.5240 33599.5n 0.5240 33600.0n 0.4999 34199.5n 0.4999 34200.0n 0.6560 34799.5n 0.6560 34800.0n 0.5756 35399.5n 0.5756 35400.0n 0.5093 35999.5n 0.5093)
Cwp_wih_0_20 wp_wih_0_20 0 400p
Cwn_wih_0_20 wn_wih_0_20 0 400p
Xu_wih_0_20 xp_wih_0_20 xn_wih_0_20 yp_wih_0_20 yn_wih_0_20 wp_wih_0_20 wn_wih_0_20 vdd gbn gprod
Vxp_wih_1_20 xp_wih_1_20 0 PWL(0.0n 0.5370 599.5n 0.5370 600.0n 0.5167 1199.5n 0.5167 1200.0n 0.4793 1799.5n 0.4793 1800.0n 0.4441 2399.5n 0.4441 2400.0n 0.4555 2999.5n 0.4555 3000.0n 0.5055 3599.5n 0.5055 3600.0n 0.4939 4199.5n 0.4939 4200.0n 0.5385 4799.5n 0.5385 4800.0n 0.5024 5399.5n 0.5024 5400.0n 0.5015 5999.5n 0.5015 6000.0n 0.4700 6599.5n 0.4700 6600.0n 0.5120 7199.5n 0.5120 7200.0n 0.5006 7799.5n 0.5006 7800.0n 0.4950 8399.5n 0.4950 8400.0n 0.5309 8999.5n 0.5309 9000.0n 0.5023 9599.5n 0.5023 9600.0n 0.4893 10199.5n 0.4893 10200.0n 0.4837 10799.5n 0.4837 10800.0n 0.4823 11399.5n 0.4823 11400.0n 0.5074 11999.5n 0.5074 12000.0n 0.5364 12599.5n 0.5364 12600.0n 0.4868 13199.5n 0.4868 13200.0n 0.5380 13799.5n 0.5380 13800.0n 0.5220 14399.5n 0.5220 14400.0n 0.5095 14999.5n 0.5095 15000.0n 0.4705 15599.5n 0.4705 15600.0n 0.5289 16199.5n 0.5289 16200.0n 0.5368 16799.5n 0.5368 16800.0n 0.5287 17399.5n 0.5287 17400.0n 0.5342 17999.5n 0.5342 18000.0n 0.4253 18599.5n 0.4253 18600.0n 0.5119 19199.5n 0.5119 19200.0n 0.4104 19799.5n 0.4104 19800.0n 0.4314 20399.5n 0.4314 20400.0n 0.4005 20999.5n 0.4005 21000.0n 0.4696 21599.5n 0.4696 21600.0n 0.4531 22199.5n 0.4531 22200.0n 0.5039 22799.5n 0.5039 22800.0n 0.3608 23399.5n 0.3608 23400.0n 0.6273 23999.5n 0.6273 24000.0n 0.3928 24599.5n 0.3928 24600.0n 0.5253 25199.5n 0.5253 25200.0n 0.4107 25799.5n 0.4107 25800.0n 0.3947 26399.5n 0.3947 26400.0n 0.3716 26999.5n 0.3716 27000.0n 0.4111 27599.5n 0.4111 27600.0n 0.3715 28199.5n 0.3715 28200.0n 0.5939 28799.5n 0.5939 28800.0n 0.3849 29399.5n 0.3849 29400.0n 0.4835 29999.5n 0.4835 30000.0n 0.5119 30599.5n 0.5119 30600.0n 0.6226 31199.5n 0.6226 31200.0n 0.6064 31799.5n 0.6064 31800.0n 0.4115 32399.5n 0.4115 32400.0n 0.3900 32999.5n 0.3900 33000.0n 0.3958 33599.5n 0.3958 33600.0n 0.3747 34199.5n 0.3747 34200.0n 0.5423 34799.5n 0.5423 34800.0n 0.5509 35399.5n 0.5509 35400.0n 0.3990 35999.5n 0.3990)
Vxn_wih_1_20 xn_wih_1_20 0 PWL(0.0n 0.4630 599.5n 0.4630 600.0n 0.4833 1199.5n 0.4833 1200.0n 0.5207 1799.5n 0.5207 1800.0n 0.5559 2399.5n 0.5559 2400.0n 0.5445 2999.5n 0.5445 3000.0n 0.4945 3599.5n 0.4945 3600.0n 0.5061 4199.5n 0.5061 4200.0n 0.4615 4799.5n 0.4615 4800.0n 0.4976 5399.5n 0.4976 5400.0n 0.4985 5999.5n 0.4985 6000.0n 0.5300 6599.5n 0.5300 6600.0n 0.4880 7199.5n 0.4880 7200.0n 0.4994 7799.5n 0.4994 7800.0n 0.5050 8399.5n 0.5050 8400.0n 0.4691 8999.5n 0.4691 9000.0n 0.4977 9599.5n 0.4977 9600.0n 0.5107 10199.5n 0.5107 10200.0n 0.5163 10799.5n 0.5163 10800.0n 0.5177 11399.5n 0.5177 11400.0n 0.4926 11999.5n 0.4926 12000.0n 0.4636 12599.5n 0.4636 12600.0n 0.5132 13199.5n 0.5132 13200.0n 0.4620 13799.5n 0.4620 13800.0n 0.4780 14399.5n 0.4780 14400.0n 0.4905 14999.5n 0.4905 15000.0n 0.5295 15599.5n 0.5295 15600.0n 0.4711 16199.5n 0.4711 16200.0n 0.4632 16799.5n 0.4632 16800.0n 0.4713 17399.5n 0.4713 17400.0n 0.4658 17999.5n 0.4658 18000.0n 0.5747 18599.5n 0.5747 18600.0n 0.4881 19199.5n 0.4881 19200.0n 0.5896 19799.5n 0.5896 19800.0n 0.5686 20399.5n 0.5686 20400.0n 0.5995 20999.5n 0.5995 21000.0n 0.5304 21599.5n 0.5304 21600.0n 0.5469 22199.5n 0.5469 22200.0n 0.4961 22799.5n 0.4961 22800.0n 0.6392 23399.5n 0.6392 23400.0n 0.3727 23999.5n 0.3727 24000.0n 0.6072 24599.5n 0.6072 24600.0n 0.4747 25199.5n 0.4747 25200.0n 0.5893 25799.5n 0.5893 25800.0n 0.6053 26399.5n 0.6053 26400.0n 0.6284 26999.5n 0.6284 27000.0n 0.5889 27599.5n 0.5889 27600.0n 0.6285 28199.5n 0.6285 28200.0n 0.4061 28799.5n 0.4061 28800.0n 0.6151 29399.5n 0.6151 29400.0n 0.5165 29999.5n 0.5165 30000.0n 0.4881 30599.5n 0.4881 30600.0n 0.3774 31199.5n 0.3774 31200.0n 0.3936 31799.5n 0.3936 31800.0n 0.5885 32399.5n 0.5885 32400.0n 0.6100 32999.5n 0.6100 33000.0n 0.6042 33599.5n 0.6042 33600.0n 0.6253 34199.5n 0.6253 34200.0n 0.4577 34799.5n 0.4577 34800.0n 0.4491 35399.5n 0.4491 35400.0n 0.6010 35999.5n 0.6010)
Vyp_wih_1_20 yp_wih_1_20 0 PWL(0.0n 0.3848 599.5n 0.3848 600.0n 0.3752 1199.5n 0.3752 1200.0n 0.4305 1799.5n 0.4305 1800.0n 0.4461 2399.5n 0.4461 2400.0n 0.4282 2999.5n 0.4282 3000.0n 0.3989 3599.5n 0.3989 3600.0n 0.4213 4199.5n 0.4213 4200.0n 0.3857 4799.5n 0.3857 4800.0n 0.4071 5399.5n 0.4071 5400.0n 0.4071 5999.5n 0.4071 6000.0n 0.4356 6599.5n 0.4356 6600.0n 0.4045 7199.5n 0.4045 7200.0n 0.3882 7799.5n 0.3882 7800.0n 0.3903 8399.5n 0.3903 8400.0n 0.4000 8999.5n 0.4000 9000.0n 0.4068 9599.5n 0.4068 9600.0n 0.4100 10199.5n 0.4100 10200.0n 0.4042 10799.5n 0.4042 10800.0n 0.4336 11399.5n 0.4336 11400.0n 0.4048 11999.5n 0.4048 12000.0n 0.3992 12599.5n 0.3992 12600.0n 0.4106 13199.5n 0.4106 13200.0n 0.3810 13799.5n 0.3810 13800.0n 0.3830 14399.5n 0.3830 14400.0n 0.4022 14999.5n 0.4022 15000.0n 0.4170 15599.5n 0.4170 15600.0n 0.3948 16199.5n 0.3948 16200.0n 0.3757 16799.5n 0.3757 16800.0n 0.4038 17399.5n 0.4038 17400.0n 0.3825 17999.5n 0.3825 18000.0n 0.5169 18599.5n 0.5169 18600.0n 0.3534 19199.5n 0.3534 19200.0n 0.4818 19799.5n 0.4818 19800.0n 0.4187 20399.5n 0.4187 20400.0n 0.5047 20999.5n 0.5047 21000.0n 0.4850 21599.5n 0.4850 21600.0n 0.3889 22199.5n 0.3889 22200.0n 0.3534 22799.5n 0.3534 22800.0n 0.5192 23399.5n 0.5192 23400.0n 0.3328 23999.5n 0.3328 24000.0n 0.4525 24599.5n 0.4525 24600.0n 0.3476 25199.5n 0.3476 25200.0n 0.5157 25799.5n 0.5157 25800.0n 0.5604 26399.5n 0.5604 26400.0n 0.5353 26999.5n 0.5353 27000.0n 0.5282 27599.5n 0.5282 27600.0n 0.5334 28199.5n 0.5334 28200.0n 0.3322 28799.5n 0.3322 28800.0n 0.5139 29399.5n 0.5139 29400.0n 0.4745 29999.5n 0.4745 30000.0n 0.4570 30599.5n 0.4570 30600.0n 0.3615 31199.5n 0.3615 31200.0n 0.3468 31799.5n 0.3468 31800.0n 0.5528 32399.5n 0.5528 32400.0n 0.5615 32999.5n 0.5615 33000.0n 0.4760 33599.5n 0.4760 33600.0n 0.5001 34199.5n 0.5001 34200.0n 0.3440 34799.5n 0.3440 34800.0n 0.4244 35399.5n 0.4244 35400.0n 0.4907 35999.5n 0.4907)
Vyn_wih_1_20 yn_wih_1_20 0 PWL(0.0n 0.6152 599.5n 0.6152 600.0n 0.6248 1199.5n 0.6248 1200.0n 0.5695 1799.5n 0.5695 1800.0n 0.5539 2399.5n 0.5539 2400.0n 0.5718 2999.5n 0.5718 3000.0n 0.6011 3599.5n 0.6011 3600.0n 0.5787 4199.5n 0.5787 4200.0n 0.6143 4799.5n 0.6143 4800.0n 0.5929 5399.5n 0.5929 5400.0n 0.5929 5999.5n 0.5929 6000.0n 0.5644 6599.5n 0.5644 6600.0n 0.5955 7199.5n 0.5955 7200.0n 0.6118 7799.5n 0.6118 7800.0n 0.6097 8399.5n 0.6097 8400.0n 0.6000 8999.5n 0.6000 9000.0n 0.5932 9599.5n 0.5932 9600.0n 0.5900 10199.5n 0.5900 10200.0n 0.5958 10799.5n 0.5958 10800.0n 0.5664 11399.5n 0.5664 11400.0n 0.5952 11999.5n 0.5952 12000.0n 0.6008 12599.5n 0.6008 12600.0n 0.5894 13199.5n 0.5894 13200.0n 0.6190 13799.5n 0.6190 13800.0n 0.6170 14399.5n 0.6170 14400.0n 0.5978 14999.5n 0.5978 15000.0n 0.5830 15599.5n 0.5830 15600.0n 0.6052 16199.5n 0.6052 16200.0n 0.6243 16799.5n 0.6243 16800.0n 0.5962 17399.5n 0.5962 17400.0n 0.6175 17999.5n 0.6175 18000.0n 0.4831 18599.5n 0.4831 18600.0n 0.6466 19199.5n 0.6466 19200.0n 0.5182 19799.5n 0.5182 19800.0n 0.5813 20399.5n 0.5813 20400.0n 0.4953 20999.5n 0.4953 21000.0n 0.5150 21599.5n 0.5150 21600.0n 0.6111 22199.5n 0.6111 22200.0n 0.6466 22799.5n 0.6466 22800.0n 0.4808 23399.5n 0.4808 23400.0n 0.6672 23999.5n 0.6672 24000.0n 0.5475 24599.5n 0.5475 24600.0n 0.6524 25199.5n 0.6524 25200.0n 0.4843 25799.5n 0.4843 25800.0n 0.4396 26399.5n 0.4396 26400.0n 0.4647 26999.5n 0.4647 27000.0n 0.4718 27599.5n 0.4718 27600.0n 0.4666 28199.5n 0.4666 28200.0n 0.6678 28799.5n 0.6678 28800.0n 0.4861 29399.5n 0.4861 29400.0n 0.5255 29999.5n 0.5255 30000.0n 0.5430 30599.5n 0.5430 30600.0n 0.6385 31199.5n 0.6385 31200.0n 0.6532 31799.5n 0.6532 31800.0n 0.4472 32399.5n 0.4472 32400.0n 0.4385 32999.5n 0.4385 33000.0n 0.5240 33599.5n 0.5240 33600.0n 0.4999 34199.5n 0.4999 34200.0n 0.6560 34799.5n 0.6560 34800.0n 0.5756 35399.5n 0.5756 35400.0n 0.5093 35999.5n 0.5093)
Cwp_wih_1_20 wp_wih_1_20 0 400p
Cwn_wih_1_20 wn_wih_1_20 0 400p
Xu_wih_1_20 xp_wih_1_20 xn_wih_1_20 yp_wih_1_20 yn_wih_1_20 wp_wih_1_20 wn_wih_1_20 vdd gbn gprod
Vxp_who_20_0 xp_who_20_0 0 PWL(0.0n 0.3848 599.5n 0.3848 600.0n 0.3752 1199.5n 0.3752 1200.0n 0.4305 1799.5n 0.4305 1800.0n 0.4461 2399.5n 0.4461 2400.0n 0.4282 2999.5n 0.4282 3000.0n 0.3989 3599.5n 0.3989 3600.0n 0.4213 4199.5n 0.4213 4200.0n 0.3857 4799.5n 0.3857 4800.0n 0.4071 5399.5n 0.4071 5400.0n 0.4071 5999.5n 0.4071 6000.0n 0.4356 6599.5n 0.4356 6600.0n 0.4045 7199.5n 0.4045 7200.0n 0.3882 7799.5n 0.3882 7800.0n 0.3903 8399.5n 0.3903 8400.0n 0.4000 8999.5n 0.4000 9000.0n 0.4068 9599.5n 0.4068 9600.0n 0.4100 10199.5n 0.4100 10200.0n 0.4042 10799.5n 0.4042 10800.0n 0.4336 11399.5n 0.4336 11400.0n 0.4048 11999.5n 0.4048 12000.0n 0.3992 12599.5n 0.3992 12600.0n 0.4106 13199.5n 0.4106 13200.0n 0.3810 13799.5n 0.3810 13800.0n 0.3830 14399.5n 0.3830 14400.0n 0.4022 14999.5n 0.4022 15000.0n 0.4170 15599.5n 0.4170 15600.0n 0.3948 16199.5n 0.3948 16200.0n 0.3757 16799.5n 0.3757 16800.0n 0.4038 17399.5n 0.4038 17400.0n 0.3825 17999.5n 0.3825 18000.0n 0.5169 18599.5n 0.5169 18600.0n 0.3534 19199.5n 0.3534 19200.0n 0.4818 19799.5n 0.4818 19800.0n 0.4187 20399.5n 0.4187 20400.0n 0.5047 20999.5n 0.5047 21000.0n 0.4850 21599.5n 0.4850 21600.0n 0.3889 22199.5n 0.3889 22200.0n 0.3534 22799.5n 0.3534 22800.0n 0.5192 23399.5n 0.5192 23400.0n 0.3328 23999.5n 0.3328 24000.0n 0.4525 24599.5n 0.4525 24600.0n 0.3476 25199.5n 0.3476 25200.0n 0.5157 25799.5n 0.5157 25800.0n 0.5604 26399.5n 0.5604 26400.0n 0.5353 26999.5n 0.5353 27000.0n 0.5282 27599.5n 0.5282 27600.0n 0.5334 28199.5n 0.5334 28200.0n 0.3322 28799.5n 0.3322 28800.0n 0.5139 29399.5n 0.5139 29400.0n 0.4745 29999.5n 0.4745 30000.0n 0.4570 30599.5n 0.4570 30600.0n 0.3615 31199.5n 0.3615 31200.0n 0.3468 31799.5n 0.3468 31800.0n 0.5528 32399.5n 0.5528 32400.0n 0.5615 32999.5n 0.5615 33000.0n 0.4760 33599.5n 0.4760 33600.0n 0.5001 34199.5n 0.5001 34200.0n 0.3440 34799.5n 0.3440 34800.0n 0.4244 35399.5n 0.4244 35400.0n 0.4907 35999.5n 0.4907)
Vxn_who_20_0 xn_who_20_0 0 PWL(0.0n 0.6152 599.5n 0.6152 600.0n 0.6248 1199.5n 0.6248 1200.0n 0.5695 1799.5n 0.5695 1800.0n 0.5539 2399.5n 0.5539 2400.0n 0.5718 2999.5n 0.5718 3000.0n 0.6011 3599.5n 0.6011 3600.0n 0.5787 4199.5n 0.5787 4200.0n 0.6143 4799.5n 0.6143 4800.0n 0.5929 5399.5n 0.5929 5400.0n 0.5929 5999.5n 0.5929 6000.0n 0.5644 6599.5n 0.5644 6600.0n 0.5955 7199.5n 0.5955 7200.0n 0.6118 7799.5n 0.6118 7800.0n 0.6097 8399.5n 0.6097 8400.0n 0.6000 8999.5n 0.6000 9000.0n 0.5932 9599.5n 0.5932 9600.0n 0.5900 10199.5n 0.5900 10200.0n 0.5958 10799.5n 0.5958 10800.0n 0.5664 11399.5n 0.5664 11400.0n 0.5952 11999.5n 0.5952 12000.0n 0.6008 12599.5n 0.6008 12600.0n 0.5894 13199.5n 0.5894 13200.0n 0.6190 13799.5n 0.6190 13800.0n 0.6170 14399.5n 0.6170 14400.0n 0.5978 14999.5n 0.5978 15000.0n 0.5830 15599.5n 0.5830 15600.0n 0.6052 16199.5n 0.6052 16200.0n 0.6243 16799.5n 0.6243 16800.0n 0.5962 17399.5n 0.5962 17400.0n 0.6175 17999.5n 0.6175 18000.0n 0.4831 18599.5n 0.4831 18600.0n 0.6466 19199.5n 0.6466 19200.0n 0.5182 19799.5n 0.5182 19800.0n 0.5813 20399.5n 0.5813 20400.0n 0.4953 20999.5n 0.4953 21000.0n 0.5150 21599.5n 0.5150 21600.0n 0.6111 22199.5n 0.6111 22200.0n 0.6466 22799.5n 0.6466 22800.0n 0.4808 23399.5n 0.4808 23400.0n 0.6672 23999.5n 0.6672 24000.0n 0.5475 24599.5n 0.5475 24600.0n 0.6524 25199.5n 0.6524 25200.0n 0.4843 25799.5n 0.4843 25800.0n 0.4396 26399.5n 0.4396 26400.0n 0.4647 26999.5n 0.4647 27000.0n 0.4718 27599.5n 0.4718 27600.0n 0.4666 28199.5n 0.4666 28200.0n 0.6678 28799.5n 0.6678 28800.0n 0.4861 29399.5n 0.4861 29400.0n 0.5255 29999.5n 0.5255 30000.0n 0.5430 30599.5n 0.5430 30600.0n 0.6385 31199.5n 0.6385 31200.0n 0.6532 31799.5n 0.6532 31800.0n 0.4472 32399.5n 0.4472 32400.0n 0.4385 32999.5n 0.4385 33000.0n 0.5240 33599.5n 0.5240 33600.0n 0.4999 34199.5n 0.4999 34200.0n 0.6560 34799.5n 0.6560 34800.0n 0.5756 35399.5n 0.5756 35400.0n 0.5093 35999.5n 0.5093)
Vyp_who_20_0 yp_who_20_0 0 PWL(0.0n 0.5031 599.5n 0.5031 600.0n 0.5023 1199.5n 0.5023 1200.0n 0.5052 1799.5n 0.5052 1800.0n 0.5048 2399.5n 0.5048 2400.0n 0.5043 2999.5n 0.5043 3000.0n 0.5034 3599.5n 0.5034 3600.0n 0.5048 4199.5n 0.5048 4200.0n 0.5031 4799.5n 0.5031 4800.0n 0.5040 5399.5n 0.5040 5400.0n 0.5040 5999.5n 0.5040 6000.0n 0.5054 6599.5n 0.5054 6600.0n 0.5040 7199.5n 0.5040 7200.0n 0.5027 7799.5n 0.5027 7800.0n 0.5027 8399.5n 0.5027 8400.0n 0.5038 8999.5n 0.5038 9000.0n 0.5040 9599.5n 0.5040 9600.0n 0.5039 10199.5n 0.5039 10200.0n 0.5033 10799.5n 0.5033 10800.0n 0.5056 11399.5n 0.5056 11400.0n 0.5040 11999.5n 0.5040 12000.0n 0.5036 12599.5n 0.5036 12600.0n 0.5039 13199.5n 0.5039 13200.0n 0.5029 13799.5n 0.5029 13800.0n 0.5025 14399.5n 0.5025 14400.0n 0.5038 14999.5n 0.5038 15000.0n 0.5041 15599.5n 0.5041 15600.0n 0.5036 16199.5n 0.5036 16200.0n 0.5025 16799.5n 0.5025 16800.0n 0.5040 17399.5n 0.5040 17400.0n 0.5029 17999.5n 0.5029 18000.0n 0.5057 18599.5n 0.5057 18600.0n 0.5010 19199.5n 0.5010 19200.0n 0.5041 19799.5n 0.5041 19800.0n 0.5021 20399.5n 0.5021 20400.0n 0.5044 20999.5n 0.5044 21000.0n 0.5056 21599.5n 0.5056 21600.0n 0.5016 22199.5n 0.5016 22200.0n 0.5006 22799.5n 0.5006 22800.0n 0.5041 23399.5n 0.5041 23400.0n 0.5027 23999.5n 0.5027 24000.0n 0.5029 24599.5n 0.5029 24600.0n 0.5006 25199.5n 0.5006 25200.0n 0.5047 25799.5n 0.5047 25800.0n 0.5046 26399.5n 0.5046 26400.0n 0.5039 26999.5n 0.5039 27000.0n 0.5049 27599.5n 0.5049 27600.0n 0.5039 28199.5n 0.5039 28200.0n 0.5017 28799.5n 0.5017 28800.0n 0.5042 29399.5n 0.5042 29400.0n 0.5056 29999.5n 0.5056 30000.0n 0.5051 30599.5n 0.5051 30600.0n 0.5039 31199.5n 0.5039 31200.0n 0.5033 31799.5n 0.5033 31800.0n 0.5049 32399.5n 0.5049 32400.0n 0.5045 32999.5n 0.5045 33000.0n 0.5036 33599.5n 0.5036 33600.0n 0.5042 34199.5n 0.5042 34200.0n 0.5012 34799.5n 0.5012 34800.0n 0.5036 35399.5n 0.5036 35400.0n 0.5042 35999.5n 0.5042)
Vyn_who_20_0 yn_who_20_0 0 PWL(0.0n 0.4969 599.5n 0.4969 600.0n 0.4977 1199.5n 0.4977 1200.0n 0.4948 1799.5n 0.4948 1800.0n 0.4952 2399.5n 0.4952 2400.0n 0.4957 2999.5n 0.4957 3000.0n 0.4966 3599.5n 0.4966 3600.0n 0.4952 4199.5n 0.4952 4200.0n 0.4969 4799.5n 0.4969 4800.0n 0.4960 5399.5n 0.4960 5400.0n 0.4960 5999.5n 0.4960 6000.0n 0.4946 6599.5n 0.4946 6600.0n 0.4960 7199.5n 0.4960 7200.0n 0.4973 7799.5n 0.4973 7800.0n 0.4973 8399.5n 0.4973 8400.0n 0.4962 8999.5n 0.4962 9000.0n 0.4960 9599.5n 0.4960 9600.0n 0.4961 10199.5n 0.4961 10200.0n 0.4967 10799.5n 0.4967 10800.0n 0.4944 11399.5n 0.4944 11400.0n 0.4960 11999.5n 0.4960 12000.0n 0.4964 12599.5n 0.4964 12600.0n 0.4961 13199.5n 0.4961 13200.0n 0.4971 13799.5n 0.4971 13800.0n 0.4975 14399.5n 0.4975 14400.0n 0.4962 14999.5n 0.4962 15000.0n 0.4959 15599.5n 0.4959 15600.0n 0.4964 16199.5n 0.4964 16200.0n 0.4975 16799.5n 0.4975 16800.0n 0.4960 17399.5n 0.4960 17400.0n 0.4971 17999.5n 0.4971 18000.0n 0.4943 18599.5n 0.4943 18600.0n 0.4990 19199.5n 0.4990 19200.0n 0.4959 19799.5n 0.4959 19800.0n 0.4979 20399.5n 0.4979 20400.0n 0.4956 20999.5n 0.4956 21000.0n 0.4944 21599.5n 0.4944 21600.0n 0.4984 22199.5n 0.4984 22200.0n 0.4994 22799.5n 0.4994 22800.0n 0.4959 23399.5n 0.4959 23400.0n 0.4973 23999.5n 0.4973 24000.0n 0.4971 24599.5n 0.4971 24600.0n 0.4994 25199.5n 0.4994 25200.0n 0.4953 25799.5n 0.4953 25800.0n 0.4954 26399.5n 0.4954 26400.0n 0.4961 26999.5n 0.4961 27000.0n 0.4951 27599.5n 0.4951 27600.0n 0.4961 28199.5n 0.4961 28200.0n 0.4983 28799.5n 0.4983 28800.0n 0.4958 29399.5n 0.4958 29400.0n 0.4944 29999.5n 0.4944 30000.0n 0.4949 30599.5n 0.4949 30600.0n 0.4961 31199.5n 0.4961 31200.0n 0.4967 31799.5n 0.4967 31800.0n 0.4951 32399.5n 0.4951 32400.0n 0.4955 32999.5n 0.4955 33000.0n 0.4964 33599.5n 0.4964 33600.0n 0.4958 34199.5n 0.4958 34200.0n 0.4988 34799.5n 0.4988 34800.0n 0.4964 35399.5n 0.4964 35400.0n 0.4958 35999.5n 0.4958)
Cwp_who_20_0 wp_who_20_0 0 400p
Cwn_who_20_0 wn_who_20_0 0 400p
Xu_who_20_0 xp_who_20_0 xn_who_20_0 yp_who_20_0 yn_who_20_0 wp_who_20_0 wn_who_20_0 vdd gbn gprod
Vxp_who_20_1 xp_who_20_1 0 PWL(0.0n 0.3848 599.5n 0.3848 600.0n 0.3752 1199.5n 0.3752 1200.0n 0.4305 1799.5n 0.4305 1800.0n 0.4461 2399.5n 0.4461 2400.0n 0.4282 2999.5n 0.4282 3000.0n 0.3989 3599.5n 0.3989 3600.0n 0.4213 4199.5n 0.4213 4200.0n 0.3857 4799.5n 0.3857 4800.0n 0.4071 5399.5n 0.4071 5400.0n 0.4071 5999.5n 0.4071 6000.0n 0.4356 6599.5n 0.4356 6600.0n 0.4045 7199.5n 0.4045 7200.0n 0.3882 7799.5n 0.3882 7800.0n 0.3903 8399.5n 0.3903 8400.0n 0.4000 8999.5n 0.4000 9000.0n 0.4068 9599.5n 0.4068 9600.0n 0.4100 10199.5n 0.4100 10200.0n 0.4042 10799.5n 0.4042 10800.0n 0.4336 11399.5n 0.4336 11400.0n 0.4048 11999.5n 0.4048 12000.0n 0.3992 12599.5n 0.3992 12600.0n 0.4106 13199.5n 0.4106 13200.0n 0.3810 13799.5n 0.3810 13800.0n 0.3830 14399.5n 0.3830 14400.0n 0.4022 14999.5n 0.4022 15000.0n 0.4170 15599.5n 0.4170 15600.0n 0.3948 16199.5n 0.3948 16200.0n 0.3757 16799.5n 0.3757 16800.0n 0.4038 17399.5n 0.4038 17400.0n 0.3825 17999.5n 0.3825 18000.0n 0.5169 18599.5n 0.5169 18600.0n 0.3534 19199.5n 0.3534 19200.0n 0.4818 19799.5n 0.4818 19800.0n 0.4187 20399.5n 0.4187 20400.0n 0.5047 20999.5n 0.5047 21000.0n 0.4850 21599.5n 0.4850 21600.0n 0.3889 22199.5n 0.3889 22200.0n 0.3534 22799.5n 0.3534 22800.0n 0.5192 23399.5n 0.5192 23400.0n 0.3328 23999.5n 0.3328 24000.0n 0.4525 24599.5n 0.4525 24600.0n 0.3476 25199.5n 0.3476 25200.0n 0.5157 25799.5n 0.5157 25800.0n 0.5604 26399.5n 0.5604 26400.0n 0.5353 26999.5n 0.5353 27000.0n 0.5282 27599.5n 0.5282 27600.0n 0.5334 28199.5n 0.5334 28200.0n 0.3322 28799.5n 0.3322 28800.0n 0.5139 29399.5n 0.5139 29400.0n 0.4745 29999.5n 0.4745 30000.0n 0.4570 30599.5n 0.4570 30600.0n 0.3615 31199.5n 0.3615 31200.0n 0.3468 31799.5n 0.3468 31800.0n 0.5528 32399.5n 0.5528 32400.0n 0.5615 32999.5n 0.5615 33000.0n 0.4760 33599.5n 0.4760 33600.0n 0.5001 34199.5n 0.5001 34200.0n 0.3440 34799.5n 0.3440 34800.0n 0.4244 35399.5n 0.4244 35400.0n 0.4907 35999.5n 0.4907)
Vxn_who_20_1 xn_who_20_1 0 PWL(0.0n 0.6152 599.5n 0.6152 600.0n 0.6248 1199.5n 0.6248 1200.0n 0.5695 1799.5n 0.5695 1800.0n 0.5539 2399.5n 0.5539 2400.0n 0.5718 2999.5n 0.5718 3000.0n 0.6011 3599.5n 0.6011 3600.0n 0.5787 4199.5n 0.5787 4200.0n 0.6143 4799.5n 0.6143 4800.0n 0.5929 5399.5n 0.5929 5400.0n 0.5929 5999.5n 0.5929 6000.0n 0.5644 6599.5n 0.5644 6600.0n 0.5955 7199.5n 0.5955 7200.0n 0.6118 7799.5n 0.6118 7800.0n 0.6097 8399.5n 0.6097 8400.0n 0.6000 8999.5n 0.6000 9000.0n 0.5932 9599.5n 0.5932 9600.0n 0.5900 10199.5n 0.5900 10200.0n 0.5958 10799.5n 0.5958 10800.0n 0.5664 11399.5n 0.5664 11400.0n 0.5952 11999.5n 0.5952 12000.0n 0.6008 12599.5n 0.6008 12600.0n 0.5894 13199.5n 0.5894 13200.0n 0.6190 13799.5n 0.6190 13800.0n 0.6170 14399.5n 0.6170 14400.0n 0.5978 14999.5n 0.5978 15000.0n 0.5830 15599.5n 0.5830 15600.0n 0.6052 16199.5n 0.6052 16200.0n 0.6243 16799.5n 0.6243 16800.0n 0.5962 17399.5n 0.5962 17400.0n 0.6175 17999.5n 0.6175 18000.0n 0.4831 18599.5n 0.4831 18600.0n 0.6466 19199.5n 0.6466 19200.0n 0.5182 19799.5n 0.5182 19800.0n 0.5813 20399.5n 0.5813 20400.0n 0.4953 20999.5n 0.4953 21000.0n 0.5150 21599.5n 0.5150 21600.0n 0.6111 22199.5n 0.6111 22200.0n 0.6466 22799.5n 0.6466 22800.0n 0.4808 23399.5n 0.4808 23400.0n 0.6672 23999.5n 0.6672 24000.0n 0.5475 24599.5n 0.5475 24600.0n 0.6524 25199.5n 0.6524 25200.0n 0.4843 25799.5n 0.4843 25800.0n 0.4396 26399.5n 0.4396 26400.0n 0.4647 26999.5n 0.4647 27000.0n 0.4718 27599.5n 0.4718 27600.0n 0.4666 28199.5n 0.4666 28200.0n 0.6678 28799.5n 0.6678 28800.0n 0.4861 29399.5n 0.4861 29400.0n 0.5255 29999.5n 0.5255 30000.0n 0.5430 30599.5n 0.5430 30600.0n 0.6385 31199.5n 0.6385 31200.0n 0.6532 31799.5n 0.6532 31800.0n 0.4472 32399.5n 0.4472 32400.0n 0.4385 32999.5n 0.4385 33000.0n 0.5240 33599.5n 0.5240 33600.0n 0.4999 34199.5n 0.4999 34200.0n 0.6560 34799.5n 0.6560 34800.0n 0.5756 35399.5n 0.5756 35400.0n 0.5093 35999.5n 0.5093)
Vyp_who_20_1 yp_who_20_1 0 PWL(0.0n 0.5071 599.5n 0.5071 600.0n 0.5053 1199.5n 0.5053 1200.0n 0.5052 1799.5n 0.5052 1800.0n 0.5027 2399.5n 0.5027 2400.0n 0.5034 2999.5n 0.5034 3000.0n 0.5055 3599.5n 0.5055 3600.0n 0.5056 4199.5n 0.5056 4200.0n 0.5071 4799.5n 0.5071 4800.0n 0.5056 5399.5n 0.5056 5400.0n 0.5056 5999.5n 0.5056 6000.0n 0.5048 6599.5n 0.5048 6600.0n 0.5060 7199.5n 0.5060 7200.0n 0.5048 7799.5n 0.5048 7800.0n 0.5046 8399.5n 0.5046 8400.0n 0.5066 8999.5n 0.5066 9000.0n 0.5056 9599.5n 0.5056 9600.0n 0.5051 10199.5n 0.5051 10200.0n 0.5046 10799.5n 0.5046 10800.0n 0.5056 11399.5n 0.5056 11400.0n 0.5058 11999.5n 0.5058 12000.0n 0.5068 12599.5n 0.5068 12600.0n 0.5050 13199.5n 0.5050 13200.0n 0.5071 13799.5n 0.5071 13800.0n 0.5059 14399.5n 0.5059 14400.0n 0.5058 14999.5n 0.5058 15000.0n 0.5043 15599.5n 0.5043 15600.0n 0.5067 16199.5n 0.5067 16200.0n 0.5068 16799.5n 0.5068 16800.0n 0.5066 17399.5n 0.5066 17400.0n 0.5069 17999.5n 0.5069 18000.0n 0.5061 18599.5n 0.5061 18600.0n 0.5034 19199.5n 0.5034 19200.0n 0.5010 19799.5n 0.5010 19800.0n 0.4989 20399.5n 0.4989 20400.0n 0.5022 20999.5n 0.5022 21000.0n 0.5086 21599.5n 0.5086 21600.0n 0.5007 22199.5n 0.5007 22200.0n 0.5023 22799.5n 0.5023 22800.0n 0.5021 23399.5n 0.5021 23400.0n 0.5077 23999.5n 0.5077 24000.0n 0.4979 24599.5n 0.4979 24600.0n 0.5035 25199.5n 0.5035 25200.0n 0.5041 25799.5n 0.5041 25800.0n 0.5075 26399.5n 0.5075 26400.0n 0.5041 26999.5n 0.5041 27000.0n 0.5056 27599.5n 0.5056 27600.0n 0.5039 28199.5n 0.5039 28200.0n 0.5059 28799.5n 0.5059 28800.0n 0.5023 29399.5n 0.5023 29400.0n 0.5086 29999.5n 0.5086 30000.0n 0.5084 30599.5n 0.5084 30600.0n 0.5085 31199.5n 0.5085 31200.0n 0.5088 31799.5n 0.5088 31800.0n 0.5078 32399.5n 0.5078 32400.0n 0.5074 32999.5n 0.5074 33000.0n 0.4996 33599.5n 0.4996 33600.0n 0.5010 34199.5n 0.5010 34200.0n 0.5044 34799.5n 0.5044 34800.0n 0.5084 35399.5n 0.5084 35400.0n 0.5012 35999.5n 0.5012)
Vyn_who_20_1 yn_who_20_1 0 PWL(0.0n 0.4929 599.5n 0.4929 600.0n 0.4947 1199.5n 0.4947 1200.0n 0.4948 1799.5n 0.4948 1800.0n 0.4973 2399.5n 0.4973 2400.0n 0.4966 2999.5n 0.4966 3000.0n 0.4945 3599.5n 0.4945 3600.0n 0.4944 4199.5n 0.4944 4200.0n 0.4929 4799.5n 0.4929 4800.0n 0.4944 5399.5n 0.4944 5400.0n 0.4944 5999.5n 0.4944 6000.0n 0.4952 6599.5n 0.4952 6600.0n 0.4940 7199.5n 0.4940 7200.0n 0.4952 7799.5n 0.4952 7800.0n 0.4954 8399.5n 0.4954 8400.0n 0.4934 8999.5n 0.4934 9000.0n 0.4944 9599.5n 0.4944 9600.0n 0.4949 10199.5n 0.4949 10200.0n 0.4954 10799.5n 0.4954 10800.0n 0.4944 11399.5n 0.4944 11400.0n 0.4942 11999.5n 0.4942 12000.0n 0.4932 12599.5n 0.4932 12600.0n 0.4950 13199.5n 0.4950 13200.0n 0.4929 13799.5n 0.4929 13800.0n 0.4941 14399.5n 0.4941 14400.0n 0.4942 14999.5n 0.4942 15000.0n 0.4957 15599.5n 0.4957 15600.0n 0.4933 16199.5n 0.4933 16200.0n 0.4932 16799.5n 0.4932 16800.0n 0.4934 17399.5n 0.4934 17400.0n 0.4931 17999.5n 0.4931 18000.0n 0.4939 18599.5n 0.4939 18600.0n 0.4966 19199.5n 0.4966 19200.0n 0.4990 19799.5n 0.4990 19800.0n 0.5011 20399.5n 0.5011 20400.0n 0.4978 20999.5n 0.4978 21000.0n 0.4914 21599.5n 0.4914 21600.0n 0.4993 22199.5n 0.4993 22200.0n 0.4977 22799.5n 0.4977 22800.0n 0.4979 23399.5n 0.4979 23400.0n 0.4923 23999.5n 0.4923 24000.0n 0.5021 24599.5n 0.5021 24600.0n 0.4965 25199.5n 0.4965 25200.0n 0.4959 25799.5n 0.4959 25800.0n 0.4925 26399.5n 0.4925 26400.0n 0.4959 26999.5n 0.4959 27000.0n 0.4944 27599.5n 0.4944 27600.0n 0.4961 28199.5n 0.4961 28200.0n 0.4941 28799.5n 0.4941 28800.0n 0.4977 29399.5n 0.4977 29400.0n 0.4914 29999.5n 0.4914 30000.0n 0.4916 30599.5n 0.4916 30600.0n 0.4915 31199.5n 0.4915 31200.0n 0.4912 31799.5n 0.4912 31800.0n 0.4922 32399.5n 0.4922 32400.0n 0.4926 32999.5n 0.4926 33000.0n 0.5004 33599.5n 0.5004 33600.0n 0.4990 34199.5n 0.4990 34200.0n 0.4956 34799.5n 0.4956 34800.0n 0.4916 35399.5n 0.4916 35400.0n 0.4988 35999.5n 0.4988)
Cwp_who_20_1 wp_who_20_1 0 400p
Cwn_who_20_1 wn_who_20_1 0 400p
Xu_who_20_1 xp_who_20_1 xn_who_20_1 yp_who_20_1 yn_who_20_1 wp_who_20_1 wn_who_20_1 vdd gbn gprod
Vxp_bh_20 xp_bh_20 0 PWL(0.0n 0.7100 599.5n 0.7100 600.0n 0.7100 1199.5n 0.7100 1200.0n 0.7100 1799.5n 0.7100 1800.0n 0.7100 2399.5n 0.7100 2400.0n 0.7100 2999.5n 0.7100 3000.0n 0.7100 3599.5n 0.7100 3600.0n 0.7100 4199.5n 0.7100 4200.0n 0.7100 4799.5n 0.7100 4800.0n 0.7100 5399.5n 0.7100 5400.0n 0.7100 5999.5n 0.7100 6000.0n 0.7100 6599.5n 0.7100 6600.0n 0.7100 7199.5n 0.7100 7200.0n 0.7100 7799.5n 0.7100 7800.0n 0.7100 8399.5n 0.7100 8400.0n 0.7100 8999.5n 0.7100 9000.0n 0.7100 9599.5n 0.7100 9600.0n 0.7100 10199.5n 0.7100 10200.0n 0.7100 10799.5n 0.7100 10800.0n 0.7100 11399.5n 0.7100 11400.0n 0.7100 11999.5n 0.7100 12000.0n 0.7100 12599.5n 0.7100 12600.0n 0.7100 13199.5n 0.7100 13200.0n 0.7100 13799.5n 0.7100 13800.0n 0.7100 14399.5n 0.7100 14400.0n 0.7100 14999.5n 0.7100 15000.0n 0.7100 15599.5n 0.7100 15600.0n 0.7100 16199.5n 0.7100 16200.0n 0.7100 16799.5n 0.7100 16800.0n 0.7100 17399.5n 0.7100 17400.0n 0.7100 17999.5n 0.7100 18000.0n 0.7100 18599.5n 0.7100 18600.0n 0.7100 19199.5n 0.7100 19200.0n 0.7100 19799.5n 0.7100 19800.0n 0.7100 20399.5n 0.7100 20400.0n 0.7100 20999.5n 0.7100 21000.0n 0.7100 21599.5n 0.7100 21600.0n 0.7100 22199.5n 0.7100 22200.0n 0.7100 22799.5n 0.7100 22800.0n 0.7100 23399.5n 0.7100 23400.0n 0.7100 23999.5n 0.7100 24000.0n 0.7100 24599.5n 0.7100 24600.0n 0.7100 25199.5n 0.7100 25200.0n 0.7100 25799.5n 0.7100 25800.0n 0.7100 26399.5n 0.7100 26400.0n 0.7100 26999.5n 0.7100 27000.0n 0.7100 27599.5n 0.7100 27600.0n 0.7100 28199.5n 0.7100 28200.0n 0.7100 28799.5n 0.7100 28800.0n 0.7100 29399.5n 0.7100 29400.0n 0.7100 29999.5n 0.7100 30000.0n 0.7100 30599.5n 0.7100 30600.0n 0.7100 31199.5n 0.7100 31200.0n 0.7100 31799.5n 0.7100 31800.0n 0.7100 32399.5n 0.7100 32400.0n 0.7100 32999.5n 0.7100 33000.0n 0.7100 33599.5n 0.7100 33600.0n 0.7100 34199.5n 0.7100 34200.0n 0.7100 34799.5n 0.7100 34800.0n 0.7100 35399.5n 0.7100 35400.0n 0.7100 35999.5n 0.7100)
Vxn_bh_20 xn_bh_20 0 PWL(0.0n 0.2900 599.5n 0.2900 600.0n 0.2900 1199.5n 0.2900 1200.0n 0.2900 1799.5n 0.2900 1800.0n 0.2900 2399.5n 0.2900 2400.0n 0.2900 2999.5n 0.2900 3000.0n 0.2900 3599.5n 0.2900 3600.0n 0.2900 4199.5n 0.2900 4200.0n 0.2900 4799.5n 0.2900 4800.0n 0.2900 5399.5n 0.2900 5400.0n 0.2900 5999.5n 0.2900 6000.0n 0.2900 6599.5n 0.2900 6600.0n 0.2900 7199.5n 0.2900 7200.0n 0.2900 7799.5n 0.2900 7800.0n 0.2900 8399.5n 0.2900 8400.0n 0.2900 8999.5n 0.2900 9000.0n 0.2900 9599.5n 0.2900 9600.0n 0.2900 10199.5n 0.2900 10200.0n 0.2900 10799.5n 0.2900 10800.0n 0.2900 11399.5n 0.2900 11400.0n 0.2900 11999.5n 0.2900 12000.0n 0.2900 12599.5n 0.2900 12600.0n 0.2900 13199.5n 0.2900 13200.0n 0.2900 13799.5n 0.2900 13800.0n 0.2900 14399.5n 0.2900 14400.0n 0.2900 14999.5n 0.2900 15000.0n 0.2900 15599.5n 0.2900 15600.0n 0.2900 16199.5n 0.2900 16200.0n 0.2900 16799.5n 0.2900 16800.0n 0.2900 17399.5n 0.2900 17400.0n 0.2900 17999.5n 0.2900 18000.0n 0.2900 18599.5n 0.2900 18600.0n 0.2900 19199.5n 0.2900 19200.0n 0.2900 19799.5n 0.2900 19800.0n 0.2900 20399.5n 0.2900 20400.0n 0.2900 20999.5n 0.2900 21000.0n 0.2900 21599.5n 0.2900 21600.0n 0.2900 22199.5n 0.2900 22200.0n 0.2900 22799.5n 0.2900 22800.0n 0.2900 23399.5n 0.2900 23400.0n 0.2900 23999.5n 0.2900 24000.0n 0.2900 24599.5n 0.2900 24600.0n 0.2900 25199.5n 0.2900 25200.0n 0.2900 25799.5n 0.2900 25800.0n 0.2900 26399.5n 0.2900 26400.0n 0.2900 26999.5n 0.2900 27000.0n 0.2900 27599.5n 0.2900 27600.0n 0.2900 28199.5n 0.2900 28200.0n 0.2900 28799.5n 0.2900 28800.0n 0.2900 29399.5n 0.2900 29400.0n 0.2900 29999.5n 0.2900 30000.0n 0.2900 30599.5n 0.2900 30600.0n 0.2900 31199.5n 0.2900 31200.0n 0.2900 31799.5n 0.2900 31800.0n 0.2900 32399.5n 0.2900 32400.0n 0.2900 32999.5n 0.2900 33000.0n 0.2900 33599.5n 0.2900 33600.0n 0.2900 34199.5n 0.2900 34200.0n 0.2900 34799.5n 0.2900 34800.0n 0.2900 35399.5n 0.2900 35400.0n 0.2900 35999.5n 0.2900)
Vyp_bh_20 yp_bh_20 0 PWL(0.0n 0.3848 599.5n 0.3848 600.0n 0.3752 1199.5n 0.3752 1200.0n 0.4305 1799.5n 0.4305 1800.0n 0.4461 2399.5n 0.4461 2400.0n 0.4282 2999.5n 0.4282 3000.0n 0.3989 3599.5n 0.3989 3600.0n 0.4213 4199.5n 0.4213 4200.0n 0.3857 4799.5n 0.3857 4800.0n 0.4071 5399.5n 0.4071 5400.0n 0.4071 5999.5n 0.4071 6000.0n 0.4356 6599.5n 0.4356 6600.0n 0.4045 7199.5n 0.4045 7200.0n 0.3882 7799.5n 0.3882 7800.0n 0.3903 8399.5n 0.3903 8400.0n 0.4000 8999.5n 0.4000 9000.0n 0.4068 9599.5n 0.4068 9600.0n 0.4100 10199.5n 0.4100 10200.0n 0.4042 10799.5n 0.4042 10800.0n 0.4336 11399.5n 0.4336 11400.0n 0.4048 11999.5n 0.4048 12000.0n 0.3992 12599.5n 0.3992 12600.0n 0.4106 13199.5n 0.4106 13200.0n 0.3810 13799.5n 0.3810 13800.0n 0.3830 14399.5n 0.3830 14400.0n 0.4022 14999.5n 0.4022 15000.0n 0.4170 15599.5n 0.4170 15600.0n 0.3948 16199.5n 0.3948 16200.0n 0.3757 16799.5n 0.3757 16800.0n 0.4038 17399.5n 0.4038 17400.0n 0.3825 17999.5n 0.3825 18000.0n 0.5169 18599.5n 0.5169 18600.0n 0.3534 19199.5n 0.3534 19200.0n 0.4818 19799.5n 0.4818 19800.0n 0.4187 20399.5n 0.4187 20400.0n 0.5047 20999.5n 0.5047 21000.0n 0.4850 21599.5n 0.4850 21600.0n 0.3889 22199.5n 0.3889 22200.0n 0.3534 22799.5n 0.3534 22800.0n 0.5192 23399.5n 0.5192 23400.0n 0.3328 23999.5n 0.3328 24000.0n 0.4525 24599.5n 0.4525 24600.0n 0.3476 25199.5n 0.3476 25200.0n 0.5157 25799.5n 0.5157 25800.0n 0.5604 26399.5n 0.5604 26400.0n 0.5353 26999.5n 0.5353 27000.0n 0.5282 27599.5n 0.5282 27600.0n 0.5334 28199.5n 0.5334 28200.0n 0.3322 28799.5n 0.3322 28800.0n 0.5139 29399.5n 0.5139 29400.0n 0.4745 29999.5n 0.4745 30000.0n 0.4570 30599.5n 0.4570 30600.0n 0.3615 31199.5n 0.3615 31200.0n 0.3468 31799.5n 0.3468 31800.0n 0.5528 32399.5n 0.5528 32400.0n 0.5615 32999.5n 0.5615 33000.0n 0.4760 33599.5n 0.4760 33600.0n 0.5001 34199.5n 0.5001 34200.0n 0.3440 34799.5n 0.3440 34800.0n 0.4244 35399.5n 0.4244 35400.0n 0.4907 35999.5n 0.4907)
Vyn_bh_20 yn_bh_20 0 PWL(0.0n 0.6152 599.5n 0.6152 600.0n 0.6248 1199.5n 0.6248 1200.0n 0.5695 1799.5n 0.5695 1800.0n 0.5539 2399.5n 0.5539 2400.0n 0.5718 2999.5n 0.5718 3000.0n 0.6011 3599.5n 0.6011 3600.0n 0.5787 4199.5n 0.5787 4200.0n 0.6143 4799.5n 0.6143 4800.0n 0.5929 5399.5n 0.5929 5400.0n 0.5929 5999.5n 0.5929 6000.0n 0.5644 6599.5n 0.5644 6600.0n 0.5955 7199.5n 0.5955 7200.0n 0.6118 7799.5n 0.6118 7800.0n 0.6097 8399.5n 0.6097 8400.0n 0.6000 8999.5n 0.6000 9000.0n 0.5932 9599.5n 0.5932 9600.0n 0.5900 10199.5n 0.5900 10200.0n 0.5958 10799.5n 0.5958 10800.0n 0.5664 11399.5n 0.5664 11400.0n 0.5952 11999.5n 0.5952 12000.0n 0.6008 12599.5n 0.6008 12600.0n 0.5894 13199.5n 0.5894 13200.0n 0.6190 13799.5n 0.6190 13800.0n 0.6170 14399.5n 0.6170 14400.0n 0.5978 14999.5n 0.5978 15000.0n 0.5830 15599.5n 0.5830 15600.0n 0.6052 16199.5n 0.6052 16200.0n 0.6243 16799.5n 0.6243 16800.0n 0.5962 17399.5n 0.5962 17400.0n 0.6175 17999.5n 0.6175 18000.0n 0.4831 18599.5n 0.4831 18600.0n 0.6466 19199.5n 0.6466 19200.0n 0.5182 19799.5n 0.5182 19800.0n 0.5813 20399.5n 0.5813 20400.0n 0.4953 20999.5n 0.4953 21000.0n 0.5150 21599.5n 0.5150 21600.0n 0.6111 22199.5n 0.6111 22200.0n 0.6466 22799.5n 0.6466 22800.0n 0.4808 23399.5n 0.4808 23400.0n 0.6672 23999.5n 0.6672 24000.0n 0.5475 24599.5n 0.5475 24600.0n 0.6524 25199.5n 0.6524 25200.0n 0.4843 25799.5n 0.4843 25800.0n 0.4396 26399.5n 0.4396 26400.0n 0.4647 26999.5n 0.4647 27000.0n 0.4718 27599.5n 0.4718 27600.0n 0.4666 28199.5n 0.4666 28200.0n 0.6678 28799.5n 0.6678 28800.0n 0.4861 29399.5n 0.4861 29400.0n 0.5255 29999.5n 0.5255 30000.0n 0.5430 30599.5n 0.5430 30600.0n 0.6385 31199.5n 0.6385 31200.0n 0.6532 31799.5n 0.6532 31800.0n 0.4472 32399.5n 0.4472 32400.0n 0.4385 32999.5n 0.4385 33000.0n 0.5240 33599.5n 0.5240 33600.0n 0.4999 34199.5n 0.4999 34200.0n 0.6560 34799.5n 0.6560 34800.0n 0.5756 35399.5n 0.5756 35400.0n 0.5093 35999.5n 0.5093)
Cwp_bh_20 wp_bh_20 0 400p
Cwn_bh_20 wn_bh_20 0 400p
Xu_bh_20 xp_bh_20 xn_bh_20 yp_bh_20 yn_bh_20 wp_bh_20 wn_bh_20 vdd gbn gprod
Vxp_wih_0_21 xp_wih_0_21 0 PWL(0.0n 0.4942 599.5n 0.4942 600.0n 0.5558 1199.5n 0.5558 1200.0n 0.4708 1799.5n 0.4708 1800.0n 0.5235 2399.5n 0.5235 2400.0n 0.5350 2999.5n 0.5350 3000.0n 0.5172 3599.5n 0.5172 3600.0n 0.4702 4199.5n 0.4702 4200.0n 0.4867 4799.5n 0.4867 4800.0n 0.4970 5399.5n 0.4970 5400.0n 0.4986 5999.5n 0.4986 6000.0n 0.4751 6599.5n 0.4751 6600.0n 0.4870 7199.5n 0.4870 7200.0n 0.5502 7799.5n 0.5502 7800.0n 0.5521 8399.5n 0.5521 8400.0n 0.4638 8999.5n 0.4638 9000.0n 0.4982 9599.5n 0.4982 9600.0n 0.5131 10199.5n 0.5131 10200.0n 0.5386 10799.5n 0.5386 10800.0n 0.4592 11399.5n 0.4592 11400.0n 0.4950 11999.5n 0.4950 12000.0n 0.4559 12599.5n 0.4559 12600.0n 0.5162 13199.5n 0.5162 13200.0n 0.5038 13799.5n 0.5038 13800.0n 0.5333 14399.5n 0.5333 14400.0n 0.4991 14999.5n 0.4991 15000.0n 0.5298 15599.5n 0.5298 15600.0n 0.4823 16199.5n 0.4823 16200.0n 0.5239 16799.5n 0.5239 16800.0n 0.4592 17399.5n 0.4592 17400.0n 0.5094 17999.5n 0.5094 18000.0n 0.4337 18599.5n 0.4337 18600.0n 0.5977 19199.5n 0.5977 19200.0n 0.5364 19799.5n 0.5364 19800.0n 0.6122 20399.5n 0.6122 20400.0n 0.4856 20999.5n 0.4856 21000.0n 0.3861 21599.5n 0.3861 21600.0n 0.6094 22199.5n 0.6094 22200.0n 0.6364 22799.5n 0.6364 22800.0n 0.4807 23399.5n 0.4807 23400.0n 0.5614 23999.5n 0.5614 24000.0n 0.5913 24599.5n 0.5913 24600.0n 0.6295 25199.5n 0.6295 25200.0n 0.4496 25799.5n 0.4496 25800.0n 0.3792 26399.5n 0.3792 26400.0n 0.4434 26999.5n 0.4434 27000.0n 0.4340 27599.5n 0.4340 27600.0n 0.4461 28199.5n 0.4461 28200.0n 0.5791 28799.5n 0.5791 28800.0n 0.4777 29399.5n 0.4777 29400.0n 0.3878 29999.5n 0.3878 30000.0n 0.3832 30599.5n 0.3832 30600.0n 0.4022 31199.5n 0.4022 31200.0n 0.4482 31799.5n 0.4482 31800.0n 0.3662 32399.5n 0.3662 32400.0n 0.3857 32999.5n 0.3857 33000.0n 0.5584 33599.5n 0.5584 33600.0n 0.5284 34199.5n 0.5284 34200.0n 0.6034 34799.5n 0.6034 34800.0n 0.3469 35399.5n 0.3469 35400.0n 0.5290 35999.5n 0.5290)
Vxn_wih_0_21 xn_wih_0_21 0 PWL(0.0n 0.5058 599.5n 0.5058 600.0n 0.4442 1199.5n 0.4442 1200.0n 0.5292 1799.5n 0.5292 1800.0n 0.4765 2399.5n 0.4765 2400.0n 0.4650 2999.5n 0.4650 3000.0n 0.4828 3599.5n 0.4828 3600.0n 0.5298 4199.5n 0.5298 4200.0n 0.5133 4799.5n 0.5133 4800.0n 0.5030 5399.5n 0.5030 5400.0n 0.5014 5999.5n 0.5014 6000.0n 0.5249 6599.5n 0.5249 6600.0n 0.5130 7199.5n 0.5130 7200.0n 0.4498 7799.5n 0.4498 7800.0n 0.4479 8399.5n 0.4479 8400.0n 0.5362 8999.5n 0.5362 9000.0n 0.5018 9599.5n 0.5018 9600.0n 0.4869 10199.5n 0.4869 10200.0n 0.4614 10799.5n 0.4614 10800.0n 0.5408 11399.5n 0.5408 11400.0n 0.5050 11999.5n 0.5050 12000.0n 0.5441 12599.5n 0.5441 12600.0n 0.4838 13199.5n 0.4838 13200.0n 0.4962 13799.5n 0.4962 13800.0n 0.4667 14399.5n 0.4667 14400.0n 0.5009 14999.5n 0.5009 15000.0n 0.4702 15599.5n 0.4702 15600.0n 0.5177 16199.5n 0.5177 16200.0n 0.4761 16799.5n 0.4761 16800.0n 0.5408 17399.5n 0.5408 17400.0n 0.4906 17999.5n 0.4906 18000.0n 0.5663 18599.5n 0.5663 18600.0n 0.4023 19199.5n 0.4023 19200.0n 0.4636 19799.5n 0.4636 19800.0n 0.3878 20399.5n 0.3878 20400.0n 0.5144 20999.5n 0.5144 21000.0n 0.6139 21599.5n 0.6139 21600.0n 0.3906 22199.5n 0.3906 22200.0n 0.3636 22799.5n 0.3636 22800.0n 0.5193 23399.5n 0.5193 23400.0n 0.4386 23999.5n 0.4386 24000.0n 0.4087 24599.5n 0.4087 24600.0n 0.3705 25199.5n 0.3705 25200.0n 0.5504 25799.5n 0.5504 25800.0n 0.6208 26399.5n 0.6208 26400.0n 0.5566 26999.5n 0.5566 27000.0n 0.5660 27599.5n 0.5660 27600.0n 0.5539 28199.5n 0.5539 28200.0n 0.4209 28799.5n 0.4209 28800.0n 0.5223 29399.5n 0.5223 29400.0n 0.6122 29999.5n 0.6122 30000.0n 0.6168 30599.5n 0.6168 30600.0n 0.5978 31199.5n 0.5978 31200.0n 0.5518 31799.5n 0.5518 31800.0n 0.6338 32399.5n 0.6338 32400.0n 0.6143 32999.5n 0.6143 33000.0n 0.4416 33599.5n 0.4416 33600.0n 0.4716 34199.5n 0.4716 34200.0n 0.3966 34799.5n 0.3966 34800.0n 0.6531 35399.5n 0.6531 35400.0n 0.4710 35999.5n 0.4710)
Vyp_wih_0_21 yp_wih_0_21 0 PWL(0.0n 0.4795 599.5n 0.4795 600.0n 0.5348 1199.5n 0.5348 1200.0n 0.4262 1799.5n 0.4262 1800.0n 0.4458 2399.5n 0.4458 2400.0n 0.4693 2999.5n 0.4693 3000.0n 0.4806 3599.5n 0.4806 3600.0n 0.4330 4199.5n 0.4330 4200.0n 0.4741 4799.5n 0.4741 4800.0n 0.4617 5399.5n 0.4617 5400.0n 0.4626 5999.5n 0.4626 6000.0n 0.4251 6599.5n 0.4251 6600.0n 0.4580 7199.5n 0.4580 7200.0n 0.5168 7799.5n 0.5168 7800.0n 0.5172 8399.5n 0.5172 8400.0n 0.4455 8999.5n 0.4455 9000.0n 0.4627 9599.5n 0.4627 9600.0n 0.4689 10199.5n 0.4689 10200.0n 0.4921 10799.5n 0.4921 10800.0n 0.4149 11399.5n 0.4149 11400.0n 0.4625 11999.5n 0.4625 12000.0n 0.4391 12599.5n 0.4391 12600.0n 0.4704 13199.5n 0.4704 13200.0n 0.4885 13799.5n 0.4885 13800.0n 0.5057 14399.5n 0.5057 14400.0n 0.4671 14999.5n 0.4671 15000.0n 0.4745 15599.5n 0.4745 15600.0n 0.4635 16199.5n 0.4635 16200.0n 0.5055 16799.5n 0.5055 16800.0n 0.4384 17399.5n 0.4384 17400.0n 0.4905 17999.5n 0.4905 18000.0n 0.3454 18599.5n 0.3454 18600.0n 0.5842 19199.5n 0.5842 19200.0n 0.4242 19799.5n 0.4242 19800.0n 0.5301 20399.5n 0.5301 20400.0n 0.3765 20999.5n 0.3765 21000.0n 0.3462 21599.5n 0.3462 21600.0n 0.5557 22199.5n 0.5557 22200.0n 0.5965 22799.5n 0.5965 22800.0n 0.3651 23399.5n 0.3651 23400.0n 0.6178 23999.5n 0.6178 24000.0n 0.4927 24599.5n 0.4927 24600.0n 0.6055 25199.5n 0.6055 25200.0n 0.3511 25799.5n 0.3511 25800.0n 0.3313 26399.5n 0.3313 26400.0n 0.3438 26999.5n 0.3438 27000.0n 0.3427 27599.5n 0.3427 27600.0n 0.3452 28199.5n 0.3452 28200.0n 0.6344 28799.5n 0.6344 28800.0n 0.3655 29399.5n 0.3655 29400.0n 0.3488 29999.5n 0.3488 30000.0n 0.3528 30599.5n 0.3528 30600.0n 0.4289 31199.5n 0.4289 31200.0n 0.4863 31799.5n 0.4863 31800.0n 0.3316 32399.5n 0.3316 32400.0n 0.3316 32999.5n 0.3316 33000.0n 0.4504 33599.5n 0.4504 33600.0n 0.4051 34199.5n 0.4051 34200.0n 0.6047 34799.5n 0.6047 34800.0n 0.3606 35399.5n 0.3606 35400.0n 0.4119 35999.5n 0.4119)
Vyn_wih_0_21 yn_wih_0_21 0 PWL(0.0n 0.5205 599.5n 0.5205 600.0n 0.4652 1199.5n 0.4652 1200.0n 0.5738 1799.5n 0.5738 1800.0n 0.5542 2399.5n 0.5542 2400.0n 0.5307 2999.5n 0.5307 3000.0n 0.5194 3599.5n 0.5194 3600.0n 0.5670 4199.5n 0.5670 4200.0n 0.5259 4799.5n 0.5259 4800.0n 0.5383 5399.5n 0.5383 5400.0n 0.5374 5999.5n 0.5374 6000.0n 0.5749 6599.5n 0.5749 6600.0n 0.5420 7199.5n 0.5420 7200.0n 0.4832 7799.5n 0.4832 7800.0n 0.4828 8399.5n 0.4828 8400.0n 0.5545 8999.5n 0.5545 9000.0n 0.5373 9599.5n 0.5373 9600.0n 0.5311 10199.5n 0.5311 10200.0n 0.5079 10799.5n 0.5079 10800.0n 0.5851 11399.5n 0.5851 11400.0n 0.5375 11999.5n 0.5375 12000.0n 0.5609 12599.5n 0.5609 12600.0n 0.5296 13199.5n 0.5296 13200.0n 0.5115 13799.5n 0.5115 13800.0n 0.4943 14399.5n 0.4943 14400.0n 0.5329 14999.5n 0.5329 15000.0n 0.5255 15599.5n 0.5255 15600.0n 0.5365 16199.5n 0.5365 16200.0n 0.4945 16799.5n 0.4945 16800.0n 0.5616 17399.5n 0.5616 17400.0n 0.5095 17999.5n 0.5095 18000.0n 0.6546 18599.5n 0.6546 18600.0n 0.4158 19199.5n 0.4158 19200.0n 0.5758 19799.5n 0.5758 19800.0n 0.4699 20399.5n 0.4699 20400.0n 0.6235 20999.5n 0.6235 21000.0n 0.6538 21599.5n 0.6538 21600.0n 0.4443 22199.5n 0.4443 22200.0n 0.4035 22799.5n 0.4035 22800.0n 0.6349 23399.5n 0.6349 23400.0n 0.3822 23999.5n 0.3822 24000.0n 0.5073 24599.5n 0.5073 24600.0n 0.3945 25199.5n 0.3945 25200.0n 0.6489 25799.5n 0.6489 25800.0n 0.6687 26399.5n 0.6687 26400.0n 0.6562 26999.5n 0.6562 27000.0n 0.6573 27599.5n 0.6573 27600.0n 0.6548 28199.5n 0.6548 28200.0n 0.3656 28799.5n 0.3656 28800.0n 0.6345 29399.5n 0.6345 29400.0n 0.6512 29999.5n 0.6512 30000.0n 0.6472 30599.5n 0.6472 30600.0n 0.5711 31199.5n 0.5711 31200.0n 0.5137 31799.5n 0.5137 31800.0n 0.6684 32399.5n 0.6684 32400.0n 0.6684 32999.5n 0.6684 33000.0n 0.5496 33599.5n 0.5496 33600.0n 0.5949 34199.5n 0.5949 34200.0n 0.3953 34799.5n 0.3953 34800.0n 0.6394 35399.5n 0.6394 35400.0n 0.5881 35999.5n 0.5881)
Cwp_wih_0_21 wp_wih_0_21 0 400p
Cwn_wih_0_21 wn_wih_0_21 0 400p
Xu_wih_0_21 xp_wih_0_21 xn_wih_0_21 yp_wih_0_21 yn_wih_0_21 wp_wih_0_21 wn_wih_0_21 vdd gbn gprod
Vxp_wih_1_21 xp_wih_1_21 0 PWL(0.0n 0.5370 599.5n 0.5370 600.0n 0.5167 1199.5n 0.5167 1200.0n 0.4793 1799.5n 0.4793 1800.0n 0.4441 2399.5n 0.4441 2400.0n 0.4555 2999.5n 0.4555 3000.0n 0.5055 3599.5n 0.5055 3600.0n 0.4939 4199.5n 0.4939 4200.0n 0.5385 4799.5n 0.5385 4800.0n 0.5024 5399.5n 0.5024 5400.0n 0.5015 5999.5n 0.5015 6000.0n 0.4700 6599.5n 0.4700 6600.0n 0.5120 7199.5n 0.5120 7200.0n 0.5006 7799.5n 0.5006 7800.0n 0.4950 8399.5n 0.4950 8400.0n 0.5309 8999.5n 0.5309 9000.0n 0.5023 9599.5n 0.5023 9600.0n 0.4893 10199.5n 0.4893 10200.0n 0.4837 10799.5n 0.4837 10800.0n 0.4823 11399.5n 0.4823 11400.0n 0.5074 11999.5n 0.5074 12000.0n 0.5364 12599.5n 0.5364 12600.0n 0.4868 13199.5n 0.4868 13200.0n 0.5380 13799.5n 0.5380 13800.0n 0.5220 14399.5n 0.5220 14400.0n 0.5095 14999.5n 0.5095 15000.0n 0.4705 15599.5n 0.4705 15600.0n 0.5289 16199.5n 0.5289 16200.0n 0.5368 16799.5n 0.5368 16800.0n 0.5287 17399.5n 0.5287 17400.0n 0.5342 17999.5n 0.5342 18000.0n 0.4253 18599.5n 0.4253 18600.0n 0.5119 19199.5n 0.5119 19200.0n 0.4104 19799.5n 0.4104 19800.0n 0.4314 20399.5n 0.4314 20400.0n 0.4005 20999.5n 0.4005 21000.0n 0.4696 21599.5n 0.4696 21600.0n 0.4531 22199.5n 0.4531 22200.0n 0.5039 22799.5n 0.5039 22800.0n 0.3608 23399.5n 0.3608 23400.0n 0.6273 23999.5n 0.6273 24000.0n 0.3928 24599.5n 0.3928 24600.0n 0.5253 25199.5n 0.5253 25200.0n 0.4107 25799.5n 0.4107 25800.0n 0.3947 26399.5n 0.3947 26400.0n 0.3716 26999.5n 0.3716 27000.0n 0.4111 27599.5n 0.4111 27600.0n 0.3715 28199.5n 0.3715 28200.0n 0.5939 28799.5n 0.5939 28800.0n 0.3849 29399.5n 0.3849 29400.0n 0.4835 29999.5n 0.4835 30000.0n 0.5119 30599.5n 0.5119 30600.0n 0.6226 31199.5n 0.6226 31200.0n 0.6064 31799.5n 0.6064 31800.0n 0.4115 32399.5n 0.4115 32400.0n 0.3900 32999.5n 0.3900 33000.0n 0.3958 33599.5n 0.3958 33600.0n 0.3747 34199.5n 0.3747 34200.0n 0.5423 34799.5n 0.5423 34800.0n 0.5509 35399.5n 0.5509 35400.0n 0.3990 35999.5n 0.3990)
Vxn_wih_1_21 xn_wih_1_21 0 PWL(0.0n 0.4630 599.5n 0.4630 600.0n 0.4833 1199.5n 0.4833 1200.0n 0.5207 1799.5n 0.5207 1800.0n 0.5559 2399.5n 0.5559 2400.0n 0.5445 2999.5n 0.5445 3000.0n 0.4945 3599.5n 0.4945 3600.0n 0.5061 4199.5n 0.5061 4200.0n 0.4615 4799.5n 0.4615 4800.0n 0.4976 5399.5n 0.4976 5400.0n 0.4985 5999.5n 0.4985 6000.0n 0.5300 6599.5n 0.5300 6600.0n 0.4880 7199.5n 0.4880 7200.0n 0.4994 7799.5n 0.4994 7800.0n 0.5050 8399.5n 0.5050 8400.0n 0.4691 8999.5n 0.4691 9000.0n 0.4977 9599.5n 0.4977 9600.0n 0.5107 10199.5n 0.5107 10200.0n 0.5163 10799.5n 0.5163 10800.0n 0.5177 11399.5n 0.5177 11400.0n 0.4926 11999.5n 0.4926 12000.0n 0.4636 12599.5n 0.4636 12600.0n 0.5132 13199.5n 0.5132 13200.0n 0.4620 13799.5n 0.4620 13800.0n 0.4780 14399.5n 0.4780 14400.0n 0.4905 14999.5n 0.4905 15000.0n 0.5295 15599.5n 0.5295 15600.0n 0.4711 16199.5n 0.4711 16200.0n 0.4632 16799.5n 0.4632 16800.0n 0.4713 17399.5n 0.4713 17400.0n 0.4658 17999.5n 0.4658 18000.0n 0.5747 18599.5n 0.5747 18600.0n 0.4881 19199.5n 0.4881 19200.0n 0.5896 19799.5n 0.5896 19800.0n 0.5686 20399.5n 0.5686 20400.0n 0.5995 20999.5n 0.5995 21000.0n 0.5304 21599.5n 0.5304 21600.0n 0.5469 22199.5n 0.5469 22200.0n 0.4961 22799.5n 0.4961 22800.0n 0.6392 23399.5n 0.6392 23400.0n 0.3727 23999.5n 0.3727 24000.0n 0.6072 24599.5n 0.6072 24600.0n 0.4747 25199.5n 0.4747 25200.0n 0.5893 25799.5n 0.5893 25800.0n 0.6053 26399.5n 0.6053 26400.0n 0.6284 26999.5n 0.6284 27000.0n 0.5889 27599.5n 0.5889 27600.0n 0.6285 28199.5n 0.6285 28200.0n 0.4061 28799.5n 0.4061 28800.0n 0.6151 29399.5n 0.6151 29400.0n 0.5165 29999.5n 0.5165 30000.0n 0.4881 30599.5n 0.4881 30600.0n 0.3774 31199.5n 0.3774 31200.0n 0.3936 31799.5n 0.3936 31800.0n 0.5885 32399.5n 0.5885 32400.0n 0.6100 32999.5n 0.6100 33000.0n 0.6042 33599.5n 0.6042 33600.0n 0.6253 34199.5n 0.6253 34200.0n 0.4577 34799.5n 0.4577 34800.0n 0.4491 35399.5n 0.4491 35400.0n 0.6010 35999.5n 0.6010)
Vyp_wih_1_21 yp_wih_1_21 0 PWL(0.0n 0.4795 599.5n 0.4795 600.0n 0.5348 1199.5n 0.5348 1200.0n 0.4262 1799.5n 0.4262 1800.0n 0.4458 2399.5n 0.4458 2400.0n 0.4693 2999.5n 0.4693 3000.0n 0.4806 3599.5n 0.4806 3600.0n 0.4330 4199.5n 0.4330 4200.0n 0.4741 4799.5n 0.4741 4800.0n 0.4617 5399.5n 0.4617 5400.0n 0.4626 5999.5n 0.4626 6000.0n 0.4251 6599.5n 0.4251 6600.0n 0.4580 7199.5n 0.4580 7200.0n 0.5168 7799.5n 0.5168 7800.0n 0.5172 8399.5n 0.5172 8400.0n 0.4455 8999.5n 0.4455 9000.0n 0.4627 9599.5n 0.4627 9600.0n 0.4689 10199.5n 0.4689 10200.0n 0.4921 10799.5n 0.4921 10800.0n 0.4149 11399.5n 0.4149 11400.0n 0.4625 11999.5n 0.4625 12000.0n 0.4391 12599.5n 0.4391 12600.0n 0.4704 13199.5n 0.4704 13200.0n 0.4885 13799.5n 0.4885 13800.0n 0.5057 14399.5n 0.5057 14400.0n 0.4671 14999.5n 0.4671 15000.0n 0.4745 15599.5n 0.4745 15600.0n 0.4635 16199.5n 0.4635 16200.0n 0.5055 16799.5n 0.5055 16800.0n 0.4384 17399.5n 0.4384 17400.0n 0.4905 17999.5n 0.4905 18000.0n 0.3454 18599.5n 0.3454 18600.0n 0.5842 19199.5n 0.5842 19200.0n 0.4242 19799.5n 0.4242 19800.0n 0.5301 20399.5n 0.5301 20400.0n 0.3765 20999.5n 0.3765 21000.0n 0.3462 21599.5n 0.3462 21600.0n 0.5557 22199.5n 0.5557 22200.0n 0.5965 22799.5n 0.5965 22800.0n 0.3651 23399.5n 0.3651 23400.0n 0.6178 23999.5n 0.6178 24000.0n 0.4927 24599.5n 0.4927 24600.0n 0.6055 25199.5n 0.6055 25200.0n 0.3511 25799.5n 0.3511 25800.0n 0.3313 26399.5n 0.3313 26400.0n 0.3438 26999.5n 0.3438 27000.0n 0.3427 27599.5n 0.3427 27600.0n 0.3452 28199.5n 0.3452 28200.0n 0.6344 28799.5n 0.6344 28800.0n 0.3655 29399.5n 0.3655 29400.0n 0.3488 29999.5n 0.3488 30000.0n 0.3528 30599.5n 0.3528 30600.0n 0.4289 31199.5n 0.4289 31200.0n 0.4863 31799.5n 0.4863 31800.0n 0.3316 32399.5n 0.3316 32400.0n 0.3316 32999.5n 0.3316 33000.0n 0.4504 33599.5n 0.4504 33600.0n 0.4051 34199.5n 0.4051 34200.0n 0.6047 34799.5n 0.6047 34800.0n 0.3606 35399.5n 0.3606 35400.0n 0.4119 35999.5n 0.4119)
Vyn_wih_1_21 yn_wih_1_21 0 PWL(0.0n 0.5205 599.5n 0.5205 600.0n 0.4652 1199.5n 0.4652 1200.0n 0.5738 1799.5n 0.5738 1800.0n 0.5542 2399.5n 0.5542 2400.0n 0.5307 2999.5n 0.5307 3000.0n 0.5194 3599.5n 0.5194 3600.0n 0.5670 4199.5n 0.5670 4200.0n 0.5259 4799.5n 0.5259 4800.0n 0.5383 5399.5n 0.5383 5400.0n 0.5374 5999.5n 0.5374 6000.0n 0.5749 6599.5n 0.5749 6600.0n 0.5420 7199.5n 0.5420 7200.0n 0.4832 7799.5n 0.4832 7800.0n 0.4828 8399.5n 0.4828 8400.0n 0.5545 8999.5n 0.5545 9000.0n 0.5373 9599.5n 0.5373 9600.0n 0.5311 10199.5n 0.5311 10200.0n 0.5079 10799.5n 0.5079 10800.0n 0.5851 11399.5n 0.5851 11400.0n 0.5375 11999.5n 0.5375 12000.0n 0.5609 12599.5n 0.5609 12600.0n 0.5296 13199.5n 0.5296 13200.0n 0.5115 13799.5n 0.5115 13800.0n 0.4943 14399.5n 0.4943 14400.0n 0.5329 14999.5n 0.5329 15000.0n 0.5255 15599.5n 0.5255 15600.0n 0.5365 16199.5n 0.5365 16200.0n 0.4945 16799.5n 0.4945 16800.0n 0.5616 17399.5n 0.5616 17400.0n 0.5095 17999.5n 0.5095 18000.0n 0.6546 18599.5n 0.6546 18600.0n 0.4158 19199.5n 0.4158 19200.0n 0.5758 19799.5n 0.5758 19800.0n 0.4699 20399.5n 0.4699 20400.0n 0.6235 20999.5n 0.6235 21000.0n 0.6538 21599.5n 0.6538 21600.0n 0.4443 22199.5n 0.4443 22200.0n 0.4035 22799.5n 0.4035 22800.0n 0.6349 23399.5n 0.6349 23400.0n 0.3822 23999.5n 0.3822 24000.0n 0.5073 24599.5n 0.5073 24600.0n 0.3945 25199.5n 0.3945 25200.0n 0.6489 25799.5n 0.6489 25800.0n 0.6687 26399.5n 0.6687 26400.0n 0.6562 26999.5n 0.6562 27000.0n 0.6573 27599.5n 0.6573 27600.0n 0.6548 28199.5n 0.6548 28200.0n 0.3656 28799.5n 0.3656 28800.0n 0.6345 29399.5n 0.6345 29400.0n 0.6512 29999.5n 0.6512 30000.0n 0.6472 30599.5n 0.6472 30600.0n 0.5711 31199.5n 0.5711 31200.0n 0.5137 31799.5n 0.5137 31800.0n 0.6684 32399.5n 0.6684 32400.0n 0.6684 32999.5n 0.6684 33000.0n 0.5496 33599.5n 0.5496 33600.0n 0.5949 34199.5n 0.5949 34200.0n 0.3953 34799.5n 0.3953 34800.0n 0.6394 35399.5n 0.6394 35400.0n 0.5881 35999.5n 0.5881)
Cwp_wih_1_21 wp_wih_1_21 0 400p
Cwn_wih_1_21 wn_wih_1_21 0 400p
Xu_wih_1_21 xp_wih_1_21 xn_wih_1_21 yp_wih_1_21 yn_wih_1_21 wp_wih_1_21 wn_wih_1_21 vdd gbn gprod
Vxp_who_21_0 xp_who_21_0 0 PWL(0.0n 0.4795 599.5n 0.4795 600.0n 0.5348 1199.5n 0.5348 1200.0n 0.4262 1799.5n 0.4262 1800.0n 0.4458 2399.5n 0.4458 2400.0n 0.4693 2999.5n 0.4693 3000.0n 0.4806 3599.5n 0.4806 3600.0n 0.4330 4199.5n 0.4330 4200.0n 0.4741 4799.5n 0.4741 4800.0n 0.4617 5399.5n 0.4617 5400.0n 0.4626 5999.5n 0.4626 6000.0n 0.4251 6599.5n 0.4251 6600.0n 0.4580 7199.5n 0.4580 7200.0n 0.5168 7799.5n 0.5168 7800.0n 0.5172 8399.5n 0.5172 8400.0n 0.4455 8999.5n 0.4455 9000.0n 0.4627 9599.5n 0.4627 9600.0n 0.4689 10199.5n 0.4689 10200.0n 0.4921 10799.5n 0.4921 10800.0n 0.4149 11399.5n 0.4149 11400.0n 0.4625 11999.5n 0.4625 12000.0n 0.4391 12599.5n 0.4391 12600.0n 0.4704 13199.5n 0.4704 13200.0n 0.4885 13799.5n 0.4885 13800.0n 0.5057 14399.5n 0.5057 14400.0n 0.4671 14999.5n 0.4671 15000.0n 0.4745 15599.5n 0.4745 15600.0n 0.4635 16199.5n 0.4635 16200.0n 0.5055 16799.5n 0.5055 16800.0n 0.4384 17399.5n 0.4384 17400.0n 0.4905 17999.5n 0.4905 18000.0n 0.3454 18599.5n 0.3454 18600.0n 0.5842 19199.5n 0.5842 19200.0n 0.4242 19799.5n 0.4242 19800.0n 0.5301 20399.5n 0.5301 20400.0n 0.3765 20999.5n 0.3765 21000.0n 0.3462 21599.5n 0.3462 21600.0n 0.5557 22199.5n 0.5557 22200.0n 0.5965 22799.5n 0.5965 22800.0n 0.3651 23399.5n 0.3651 23400.0n 0.6178 23999.5n 0.6178 24000.0n 0.4927 24599.5n 0.4927 24600.0n 0.6055 25199.5n 0.6055 25200.0n 0.3511 25799.5n 0.3511 25800.0n 0.3313 26399.5n 0.3313 26400.0n 0.3438 26999.5n 0.3438 27000.0n 0.3427 27599.5n 0.3427 27600.0n 0.3452 28199.5n 0.3452 28200.0n 0.6344 28799.5n 0.6344 28800.0n 0.3655 29399.5n 0.3655 29400.0n 0.3488 29999.5n 0.3488 30000.0n 0.3528 30599.5n 0.3528 30600.0n 0.4289 31199.5n 0.4289 31200.0n 0.4863 31799.5n 0.4863 31800.0n 0.3316 32399.5n 0.3316 32400.0n 0.3316 32999.5n 0.3316 33000.0n 0.4504 33599.5n 0.4504 33600.0n 0.4051 34199.5n 0.4051 34200.0n 0.6047 34799.5n 0.6047 34800.0n 0.3606 35399.5n 0.3606 35400.0n 0.4119 35999.5n 0.4119)
Vxn_who_21_0 xn_who_21_0 0 PWL(0.0n 0.5205 599.5n 0.5205 600.0n 0.4652 1199.5n 0.4652 1200.0n 0.5738 1799.5n 0.5738 1800.0n 0.5542 2399.5n 0.5542 2400.0n 0.5307 2999.5n 0.5307 3000.0n 0.5194 3599.5n 0.5194 3600.0n 0.5670 4199.5n 0.5670 4200.0n 0.5259 4799.5n 0.5259 4800.0n 0.5383 5399.5n 0.5383 5400.0n 0.5374 5999.5n 0.5374 6000.0n 0.5749 6599.5n 0.5749 6600.0n 0.5420 7199.5n 0.5420 7200.0n 0.4832 7799.5n 0.4832 7800.0n 0.4828 8399.5n 0.4828 8400.0n 0.5545 8999.5n 0.5545 9000.0n 0.5373 9599.5n 0.5373 9600.0n 0.5311 10199.5n 0.5311 10200.0n 0.5079 10799.5n 0.5079 10800.0n 0.5851 11399.5n 0.5851 11400.0n 0.5375 11999.5n 0.5375 12000.0n 0.5609 12599.5n 0.5609 12600.0n 0.5296 13199.5n 0.5296 13200.0n 0.5115 13799.5n 0.5115 13800.0n 0.4943 14399.5n 0.4943 14400.0n 0.5329 14999.5n 0.5329 15000.0n 0.5255 15599.5n 0.5255 15600.0n 0.5365 16199.5n 0.5365 16200.0n 0.4945 16799.5n 0.4945 16800.0n 0.5616 17399.5n 0.5616 17400.0n 0.5095 17999.5n 0.5095 18000.0n 0.6546 18599.5n 0.6546 18600.0n 0.4158 19199.5n 0.4158 19200.0n 0.5758 19799.5n 0.5758 19800.0n 0.4699 20399.5n 0.4699 20400.0n 0.6235 20999.5n 0.6235 21000.0n 0.6538 21599.5n 0.6538 21600.0n 0.4443 22199.5n 0.4443 22200.0n 0.4035 22799.5n 0.4035 22800.0n 0.6349 23399.5n 0.6349 23400.0n 0.3822 23999.5n 0.3822 24000.0n 0.5073 24599.5n 0.5073 24600.0n 0.3945 25199.5n 0.3945 25200.0n 0.6489 25799.5n 0.6489 25800.0n 0.6687 26399.5n 0.6687 26400.0n 0.6562 26999.5n 0.6562 27000.0n 0.6573 27599.5n 0.6573 27600.0n 0.6548 28199.5n 0.6548 28200.0n 0.3656 28799.5n 0.3656 28800.0n 0.6345 29399.5n 0.6345 29400.0n 0.6512 29999.5n 0.6512 30000.0n 0.6472 30599.5n 0.6472 30600.0n 0.5711 31199.5n 0.5711 31200.0n 0.5137 31799.5n 0.5137 31800.0n 0.6684 32399.5n 0.6684 32400.0n 0.6684 32999.5n 0.6684 33000.0n 0.5496 33599.5n 0.5496 33600.0n 0.5949 34199.5n 0.5949 34200.0n 0.3953 34799.5n 0.3953 34800.0n 0.6394 35399.5n 0.6394 35400.0n 0.5881 35999.5n 0.5881)
Vyp_who_21_0 yp_who_21_0 0 PWL(0.0n 0.5031 599.5n 0.5031 600.0n 0.5023 1199.5n 0.5023 1200.0n 0.5052 1799.5n 0.5052 1800.0n 0.5048 2399.5n 0.5048 2400.0n 0.5043 2999.5n 0.5043 3000.0n 0.5034 3599.5n 0.5034 3600.0n 0.5048 4199.5n 0.5048 4200.0n 0.5031 4799.5n 0.5031 4800.0n 0.5040 5399.5n 0.5040 5400.0n 0.5040 5999.5n 0.5040 6000.0n 0.5054 6599.5n 0.5054 6600.0n 0.5040 7199.5n 0.5040 7200.0n 0.5027 7799.5n 0.5027 7800.0n 0.5027 8399.5n 0.5027 8400.0n 0.5038 8999.5n 0.5038 9000.0n 0.5040 9599.5n 0.5040 9600.0n 0.5039 10199.5n 0.5039 10200.0n 0.5033 10799.5n 0.5033 10800.0n 0.5056 11399.5n 0.5056 11400.0n 0.5040 11999.5n 0.5040 12000.0n 0.5036 12599.5n 0.5036 12600.0n 0.5039 13199.5n 0.5039 13200.0n 0.5029 13799.5n 0.5029 13800.0n 0.5025 14399.5n 0.5025 14400.0n 0.5038 14999.5n 0.5038 15000.0n 0.5041 15599.5n 0.5041 15600.0n 0.5036 16199.5n 0.5036 16200.0n 0.5025 16799.5n 0.5025 16800.0n 0.5040 17399.5n 0.5040 17400.0n 0.5029 17999.5n 0.5029 18000.0n 0.5057 18599.5n 0.5057 18600.0n 0.5010 19199.5n 0.5010 19200.0n 0.5041 19799.5n 0.5041 19800.0n 0.5021 20399.5n 0.5021 20400.0n 0.5044 20999.5n 0.5044 21000.0n 0.5056 21599.5n 0.5056 21600.0n 0.5016 22199.5n 0.5016 22200.0n 0.5006 22799.5n 0.5006 22800.0n 0.5041 23399.5n 0.5041 23400.0n 0.5027 23999.5n 0.5027 24000.0n 0.5029 24599.5n 0.5029 24600.0n 0.5006 25199.5n 0.5006 25200.0n 0.5047 25799.5n 0.5047 25800.0n 0.5046 26399.5n 0.5046 26400.0n 0.5039 26999.5n 0.5039 27000.0n 0.5049 27599.5n 0.5049 27600.0n 0.5039 28199.5n 0.5039 28200.0n 0.5017 28799.5n 0.5017 28800.0n 0.5042 29399.5n 0.5042 29400.0n 0.5056 29999.5n 0.5056 30000.0n 0.5051 30599.5n 0.5051 30600.0n 0.5039 31199.5n 0.5039 31200.0n 0.5033 31799.5n 0.5033 31800.0n 0.5049 32399.5n 0.5049 32400.0n 0.5045 32999.5n 0.5045 33000.0n 0.5036 33599.5n 0.5036 33600.0n 0.5042 34199.5n 0.5042 34200.0n 0.5012 34799.5n 0.5012 34800.0n 0.5036 35399.5n 0.5036 35400.0n 0.5042 35999.5n 0.5042)
Vyn_who_21_0 yn_who_21_0 0 PWL(0.0n 0.4969 599.5n 0.4969 600.0n 0.4977 1199.5n 0.4977 1200.0n 0.4948 1799.5n 0.4948 1800.0n 0.4952 2399.5n 0.4952 2400.0n 0.4957 2999.5n 0.4957 3000.0n 0.4966 3599.5n 0.4966 3600.0n 0.4952 4199.5n 0.4952 4200.0n 0.4969 4799.5n 0.4969 4800.0n 0.4960 5399.5n 0.4960 5400.0n 0.4960 5999.5n 0.4960 6000.0n 0.4946 6599.5n 0.4946 6600.0n 0.4960 7199.5n 0.4960 7200.0n 0.4973 7799.5n 0.4973 7800.0n 0.4973 8399.5n 0.4973 8400.0n 0.4962 8999.5n 0.4962 9000.0n 0.4960 9599.5n 0.4960 9600.0n 0.4961 10199.5n 0.4961 10200.0n 0.4967 10799.5n 0.4967 10800.0n 0.4944 11399.5n 0.4944 11400.0n 0.4960 11999.5n 0.4960 12000.0n 0.4964 12599.5n 0.4964 12600.0n 0.4961 13199.5n 0.4961 13200.0n 0.4971 13799.5n 0.4971 13800.0n 0.4975 14399.5n 0.4975 14400.0n 0.4962 14999.5n 0.4962 15000.0n 0.4959 15599.5n 0.4959 15600.0n 0.4964 16199.5n 0.4964 16200.0n 0.4975 16799.5n 0.4975 16800.0n 0.4960 17399.5n 0.4960 17400.0n 0.4971 17999.5n 0.4971 18000.0n 0.4943 18599.5n 0.4943 18600.0n 0.4990 19199.5n 0.4990 19200.0n 0.4959 19799.5n 0.4959 19800.0n 0.4979 20399.5n 0.4979 20400.0n 0.4956 20999.5n 0.4956 21000.0n 0.4944 21599.5n 0.4944 21600.0n 0.4984 22199.5n 0.4984 22200.0n 0.4994 22799.5n 0.4994 22800.0n 0.4959 23399.5n 0.4959 23400.0n 0.4973 23999.5n 0.4973 24000.0n 0.4971 24599.5n 0.4971 24600.0n 0.4994 25199.5n 0.4994 25200.0n 0.4953 25799.5n 0.4953 25800.0n 0.4954 26399.5n 0.4954 26400.0n 0.4961 26999.5n 0.4961 27000.0n 0.4951 27599.5n 0.4951 27600.0n 0.4961 28199.5n 0.4961 28200.0n 0.4983 28799.5n 0.4983 28800.0n 0.4958 29399.5n 0.4958 29400.0n 0.4944 29999.5n 0.4944 30000.0n 0.4949 30599.5n 0.4949 30600.0n 0.4961 31199.5n 0.4961 31200.0n 0.4967 31799.5n 0.4967 31800.0n 0.4951 32399.5n 0.4951 32400.0n 0.4955 32999.5n 0.4955 33000.0n 0.4964 33599.5n 0.4964 33600.0n 0.4958 34199.5n 0.4958 34200.0n 0.4988 34799.5n 0.4988 34800.0n 0.4964 35399.5n 0.4964 35400.0n 0.4958 35999.5n 0.4958)
Cwp_who_21_0 wp_who_21_0 0 400p
Cwn_who_21_0 wn_who_21_0 0 400p
Xu_who_21_0 xp_who_21_0 xn_who_21_0 yp_who_21_0 yn_who_21_0 wp_who_21_0 wn_who_21_0 vdd gbn gprod
Vxp_who_21_1 xp_who_21_1 0 PWL(0.0n 0.4795 599.5n 0.4795 600.0n 0.5348 1199.5n 0.5348 1200.0n 0.4262 1799.5n 0.4262 1800.0n 0.4458 2399.5n 0.4458 2400.0n 0.4693 2999.5n 0.4693 3000.0n 0.4806 3599.5n 0.4806 3600.0n 0.4330 4199.5n 0.4330 4200.0n 0.4741 4799.5n 0.4741 4800.0n 0.4617 5399.5n 0.4617 5400.0n 0.4626 5999.5n 0.4626 6000.0n 0.4251 6599.5n 0.4251 6600.0n 0.4580 7199.5n 0.4580 7200.0n 0.5168 7799.5n 0.5168 7800.0n 0.5172 8399.5n 0.5172 8400.0n 0.4455 8999.5n 0.4455 9000.0n 0.4627 9599.5n 0.4627 9600.0n 0.4689 10199.5n 0.4689 10200.0n 0.4921 10799.5n 0.4921 10800.0n 0.4149 11399.5n 0.4149 11400.0n 0.4625 11999.5n 0.4625 12000.0n 0.4391 12599.5n 0.4391 12600.0n 0.4704 13199.5n 0.4704 13200.0n 0.4885 13799.5n 0.4885 13800.0n 0.5057 14399.5n 0.5057 14400.0n 0.4671 14999.5n 0.4671 15000.0n 0.4745 15599.5n 0.4745 15600.0n 0.4635 16199.5n 0.4635 16200.0n 0.5055 16799.5n 0.5055 16800.0n 0.4384 17399.5n 0.4384 17400.0n 0.4905 17999.5n 0.4905 18000.0n 0.3454 18599.5n 0.3454 18600.0n 0.5842 19199.5n 0.5842 19200.0n 0.4242 19799.5n 0.4242 19800.0n 0.5301 20399.5n 0.5301 20400.0n 0.3765 20999.5n 0.3765 21000.0n 0.3462 21599.5n 0.3462 21600.0n 0.5557 22199.5n 0.5557 22200.0n 0.5965 22799.5n 0.5965 22800.0n 0.3651 23399.5n 0.3651 23400.0n 0.6178 23999.5n 0.6178 24000.0n 0.4927 24599.5n 0.4927 24600.0n 0.6055 25199.5n 0.6055 25200.0n 0.3511 25799.5n 0.3511 25800.0n 0.3313 26399.5n 0.3313 26400.0n 0.3438 26999.5n 0.3438 27000.0n 0.3427 27599.5n 0.3427 27600.0n 0.3452 28199.5n 0.3452 28200.0n 0.6344 28799.5n 0.6344 28800.0n 0.3655 29399.5n 0.3655 29400.0n 0.3488 29999.5n 0.3488 30000.0n 0.3528 30599.5n 0.3528 30600.0n 0.4289 31199.5n 0.4289 31200.0n 0.4863 31799.5n 0.4863 31800.0n 0.3316 32399.5n 0.3316 32400.0n 0.3316 32999.5n 0.3316 33000.0n 0.4504 33599.5n 0.4504 33600.0n 0.4051 34199.5n 0.4051 34200.0n 0.6047 34799.5n 0.6047 34800.0n 0.3606 35399.5n 0.3606 35400.0n 0.4119 35999.5n 0.4119)
Vxn_who_21_1 xn_who_21_1 0 PWL(0.0n 0.5205 599.5n 0.5205 600.0n 0.4652 1199.5n 0.4652 1200.0n 0.5738 1799.5n 0.5738 1800.0n 0.5542 2399.5n 0.5542 2400.0n 0.5307 2999.5n 0.5307 3000.0n 0.5194 3599.5n 0.5194 3600.0n 0.5670 4199.5n 0.5670 4200.0n 0.5259 4799.5n 0.5259 4800.0n 0.5383 5399.5n 0.5383 5400.0n 0.5374 5999.5n 0.5374 6000.0n 0.5749 6599.5n 0.5749 6600.0n 0.5420 7199.5n 0.5420 7200.0n 0.4832 7799.5n 0.4832 7800.0n 0.4828 8399.5n 0.4828 8400.0n 0.5545 8999.5n 0.5545 9000.0n 0.5373 9599.5n 0.5373 9600.0n 0.5311 10199.5n 0.5311 10200.0n 0.5079 10799.5n 0.5079 10800.0n 0.5851 11399.5n 0.5851 11400.0n 0.5375 11999.5n 0.5375 12000.0n 0.5609 12599.5n 0.5609 12600.0n 0.5296 13199.5n 0.5296 13200.0n 0.5115 13799.5n 0.5115 13800.0n 0.4943 14399.5n 0.4943 14400.0n 0.5329 14999.5n 0.5329 15000.0n 0.5255 15599.5n 0.5255 15600.0n 0.5365 16199.5n 0.5365 16200.0n 0.4945 16799.5n 0.4945 16800.0n 0.5616 17399.5n 0.5616 17400.0n 0.5095 17999.5n 0.5095 18000.0n 0.6546 18599.5n 0.6546 18600.0n 0.4158 19199.5n 0.4158 19200.0n 0.5758 19799.5n 0.5758 19800.0n 0.4699 20399.5n 0.4699 20400.0n 0.6235 20999.5n 0.6235 21000.0n 0.6538 21599.5n 0.6538 21600.0n 0.4443 22199.5n 0.4443 22200.0n 0.4035 22799.5n 0.4035 22800.0n 0.6349 23399.5n 0.6349 23400.0n 0.3822 23999.5n 0.3822 24000.0n 0.5073 24599.5n 0.5073 24600.0n 0.3945 25199.5n 0.3945 25200.0n 0.6489 25799.5n 0.6489 25800.0n 0.6687 26399.5n 0.6687 26400.0n 0.6562 26999.5n 0.6562 27000.0n 0.6573 27599.5n 0.6573 27600.0n 0.6548 28199.5n 0.6548 28200.0n 0.3656 28799.5n 0.3656 28800.0n 0.6345 29399.5n 0.6345 29400.0n 0.6512 29999.5n 0.6512 30000.0n 0.6472 30599.5n 0.6472 30600.0n 0.5711 31199.5n 0.5711 31200.0n 0.5137 31799.5n 0.5137 31800.0n 0.6684 32399.5n 0.6684 32400.0n 0.6684 32999.5n 0.6684 33000.0n 0.5496 33599.5n 0.5496 33600.0n 0.5949 34199.5n 0.5949 34200.0n 0.3953 34799.5n 0.3953 34800.0n 0.6394 35399.5n 0.6394 35400.0n 0.5881 35999.5n 0.5881)
Vyp_who_21_1 yp_who_21_1 0 PWL(0.0n 0.5071 599.5n 0.5071 600.0n 0.5053 1199.5n 0.5053 1200.0n 0.5052 1799.5n 0.5052 1800.0n 0.5027 2399.5n 0.5027 2400.0n 0.5034 2999.5n 0.5034 3000.0n 0.5055 3599.5n 0.5055 3600.0n 0.5056 4199.5n 0.5056 4200.0n 0.5071 4799.5n 0.5071 4800.0n 0.5056 5399.5n 0.5056 5400.0n 0.5056 5999.5n 0.5056 6000.0n 0.5048 6599.5n 0.5048 6600.0n 0.5060 7199.5n 0.5060 7200.0n 0.5048 7799.5n 0.5048 7800.0n 0.5046 8399.5n 0.5046 8400.0n 0.5066 8999.5n 0.5066 9000.0n 0.5056 9599.5n 0.5056 9600.0n 0.5051 10199.5n 0.5051 10200.0n 0.5046 10799.5n 0.5046 10800.0n 0.5056 11399.5n 0.5056 11400.0n 0.5058 11999.5n 0.5058 12000.0n 0.5068 12599.5n 0.5068 12600.0n 0.5050 13199.5n 0.5050 13200.0n 0.5071 13799.5n 0.5071 13800.0n 0.5059 14399.5n 0.5059 14400.0n 0.5058 14999.5n 0.5058 15000.0n 0.5043 15599.5n 0.5043 15600.0n 0.5067 16199.5n 0.5067 16200.0n 0.5068 16799.5n 0.5068 16800.0n 0.5066 17399.5n 0.5066 17400.0n 0.5069 17999.5n 0.5069 18000.0n 0.5061 18599.5n 0.5061 18600.0n 0.5034 19199.5n 0.5034 19200.0n 0.5010 19799.5n 0.5010 19800.0n 0.4989 20399.5n 0.4989 20400.0n 0.5022 20999.5n 0.5022 21000.0n 0.5086 21599.5n 0.5086 21600.0n 0.5007 22199.5n 0.5007 22200.0n 0.5023 22799.5n 0.5023 22800.0n 0.5021 23399.5n 0.5021 23400.0n 0.5077 23999.5n 0.5077 24000.0n 0.4979 24599.5n 0.4979 24600.0n 0.5035 25199.5n 0.5035 25200.0n 0.5041 25799.5n 0.5041 25800.0n 0.5075 26399.5n 0.5075 26400.0n 0.5041 26999.5n 0.5041 27000.0n 0.5056 27599.5n 0.5056 27600.0n 0.5039 28199.5n 0.5039 28200.0n 0.5059 28799.5n 0.5059 28800.0n 0.5023 29399.5n 0.5023 29400.0n 0.5086 29999.5n 0.5086 30000.0n 0.5084 30599.5n 0.5084 30600.0n 0.5085 31199.5n 0.5085 31200.0n 0.5088 31799.5n 0.5088 31800.0n 0.5078 32399.5n 0.5078 32400.0n 0.5074 32999.5n 0.5074 33000.0n 0.4996 33599.5n 0.4996 33600.0n 0.5010 34199.5n 0.5010 34200.0n 0.5044 34799.5n 0.5044 34800.0n 0.5084 35399.5n 0.5084 35400.0n 0.5012 35999.5n 0.5012)
Vyn_who_21_1 yn_who_21_1 0 PWL(0.0n 0.4929 599.5n 0.4929 600.0n 0.4947 1199.5n 0.4947 1200.0n 0.4948 1799.5n 0.4948 1800.0n 0.4973 2399.5n 0.4973 2400.0n 0.4966 2999.5n 0.4966 3000.0n 0.4945 3599.5n 0.4945 3600.0n 0.4944 4199.5n 0.4944 4200.0n 0.4929 4799.5n 0.4929 4800.0n 0.4944 5399.5n 0.4944 5400.0n 0.4944 5999.5n 0.4944 6000.0n 0.4952 6599.5n 0.4952 6600.0n 0.4940 7199.5n 0.4940 7200.0n 0.4952 7799.5n 0.4952 7800.0n 0.4954 8399.5n 0.4954 8400.0n 0.4934 8999.5n 0.4934 9000.0n 0.4944 9599.5n 0.4944 9600.0n 0.4949 10199.5n 0.4949 10200.0n 0.4954 10799.5n 0.4954 10800.0n 0.4944 11399.5n 0.4944 11400.0n 0.4942 11999.5n 0.4942 12000.0n 0.4932 12599.5n 0.4932 12600.0n 0.4950 13199.5n 0.4950 13200.0n 0.4929 13799.5n 0.4929 13800.0n 0.4941 14399.5n 0.4941 14400.0n 0.4942 14999.5n 0.4942 15000.0n 0.4957 15599.5n 0.4957 15600.0n 0.4933 16199.5n 0.4933 16200.0n 0.4932 16799.5n 0.4932 16800.0n 0.4934 17399.5n 0.4934 17400.0n 0.4931 17999.5n 0.4931 18000.0n 0.4939 18599.5n 0.4939 18600.0n 0.4966 19199.5n 0.4966 19200.0n 0.4990 19799.5n 0.4990 19800.0n 0.5011 20399.5n 0.5011 20400.0n 0.4978 20999.5n 0.4978 21000.0n 0.4914 21599.5n 0.4914 21600.0n 0.4993 22199.5n 0.4993 22200.0n 0.4977 22799.5n 0.4977 22800.0n 0.4979 23399.5n 0.4979 23400.0n 0.4923 23999.5n 0.4923 24000.0n 0.5021 24599.5n 0.5021 24600.0n 0.4965 25199.5n 0.4965 25200.0n 0.4959 25799.5n 0.4959 25800.0n 0.4925 26399.5n 0.4925 26400.0n 0.4959 26999.5n 0.4959 27000.0n 0.4944 27599.5n 0.4944 27600.0n 0.4961 28199.5n 0.4961 28200.0n 0.4941 28799.5n 0.4941 28800.0n 0.4977 29399.5n 0.4977 29400.0n 0.4914 29999.5n 0.4914 30000.0n 0.4916 30599.5n 0.4916 30600.0n 0.4915 31199.5n 0.4915 31200.0n 0.4912 31799.5n 0.4912 31800.0n 0.4922 32399.5n 0.4922 32400.0n 0.4926 32999.5n 0.4926 33000.0n 0.5004 33599.5n 0.5004 33600.0n 0.4990 34199.5n 0.4990 34200.0n 0.4956 34799.5n 0.4956 34800.0n 0.4916 35399.5n 0.4916 35400.0n 0.4988 35999.5n 0.4988)
Cwp_who_21_1 wp_who_21_1 0 400p
Cwn_who_21_1 wn_who_21_1 0 400p
Xu_who_21_1 xp_who_21_1 xn_who_21_1 yp_who_21_1 yn_who_21_1 wp_who_21_1 wn_who_21_1 vdd gbn gprod
Vxp_bh_21 xp_bh_21 0 PWL(0.0n 0.7100 599.5n 0.7100 600.0n 0.7100 1199.5n 0.7100 1200.0n 0.7100 1799.5n 0.7100 1800.0n 0.7100 2399.5n 0.7100 2400.0n 0.7100 2999.5n 0.7100 3000.0n 0.7100 3599.5n 0.7100 3600.0n 0.7100 4199.5n 0.7100 4200.0n 0.7100 4799.5n 0.7100 4800.0n 0.7100 5399.5n 0.7100 5400.0n 0.7100 5999.5n 0.7100 6000.0n 0.7100 6599.5n 0.7100 6600.0n 0.7100 7199.5n 0.7100 7200.0n 0.7100 7799.5n 0.7100 7800.0n 0.7100 8399.5n 0.7100 8400.0n 0.7100 8999.5n 0.7100 9000.0n 0.7100 9599.5n 0.7100 9600.0n 0.7100 10199.5n 0.7100 10200.0n 0.7100 10799.5n 0.7100 10800.0n 0.7100 11399.5n 0.7100 11400.0n 0.7100 11999.5n 0.7100 12000.0n 0.7100 12599.5n 0.7100 12600.0n 0.7100 13199.5n 0.7100 13200.0n 0.7100 13799.5n 0.7100 13800.0n 0.7100 14399.5n 0.7100 14400.0n 0.7100 14999.5n 0.7100 15000.0n 0.7100 15599.5n 0.7100 15600.0n 0.7100 16199.5n 0.7100 16200.0n 0.7100 16799.5n 0.7100 16800.0n 0.7100 17399.5n 0.7100 17400.0n 0.7100 17999.5n 0.7100 18000.0n 0.7100 18599.5n 0.7100 18600.0n 0.7100 19199.5n 0.7100 19200.0n 0.7100 19799.5n 0.7100 19800.0n 0.7100 20399.5n 0.7100 20400.0n 0.7100 20999.5n 0.7100 21000.0n 0.7100 21599.5n 0.7100 21600.0n 0.7100 22199.5n 0.7100 22200.0n 0.7100 22799.5n 0.7100 22800.0n 0.7100 23399.5n 0.7100 23400.0n 0.7100 23999.5n 0.7100 24000.0n 0.7100 24599.5n 0.7100 24600.0n 0.7100 25199.5n 0.7100 25200.0n 0.7100 25799.5n 0.7100 25800.0n 0.7100 26399.5n 0.7100 26400.0n 0.7100 26999.5n 0.7100 27000.0n 0.7100 27599.5n 0.7100 27600.0n 0.7100 28199.5n 0.7100 28200.0n 0.7100 28799.5n 0.7100 28800.0n 0.7100 29399.5n 0.7100 29400.0n 0.7100 29999.5n 0.7100 30000.0n 0.7100 30599.5n 0.7100 30600.0n 0.7100 31199.5n 0.7100 31200.0n 0.7100 31799.5n 0.7100 31800.0n 0.7100 32399.5n 0.7100 32400.0n 0.7100 32999.5n 0.7100 33000.0n 0.7100 33599.5n 0.7100 33600.0n 0.7100 34199.5n 0.7100 34200.0n 0.7100 34799.5n 0.7100 34800.0n 0.7100 35399.5n 0.7100 35400.0n 0.7100 35999.5n 0.7100)
Vxn_bh_21 xn_bh_21 0 PWL(0.0n 0.2900 599.5n 0.2900 600.0n 0.2900 1199.5n 0.2900 1200.0n 0.2900 1799.5n 0.2900 1800.0n 0.2900 2399.5n 0.2900 2400.0n 0.2900 2999.5n 0.2900 3000.0n 0.2900 3599.5n 0.2900 3600.0n 0.2900 4199.5n 0.2900 4200.0n 0.2900 4799.5n 0.2900 4800.0n 0.2900 5399.5n 0.2900 5400.0n 0.2900 5999.5n 0.2900 6000.0n 0.2900 6599.5n 0.2900 6600.0n 0.2900 7199.5n 0.2900 7200.0n 0.2900 7799.5n 0.2900 7800.0n 0.2900 8399.5n 0.2900 8400.0n 0.2900 8999.5n 0.2900 9000.0n 0.2900 9599.5n 0.2900 9600.0n 0.2900 10199.5n 0.2900 10200.0n 0.2900 10799.5n 0.2900 10800.0n 0.2900 11399.5n 0.2900 11400.0n 0.2900 11999.5n 0.2900 12000.0n 0.2900 12599.5n 0.2900 12600.0n 0.2900 13199.5n 0.2900 13200.0n 0.2900 13799.5n 0.2900 13800.0n 0.2900 14399.5n 0.2900 14400.0n 0.2900 14999.5n 0.2900 15000.0n 0.2900 15599.5n 0.2900 15600.0n 0.2900 16199.5n 0.2900 16200.0n 0.2900 16799.5n 0.2900 16800.0n 0.2900 17399.5n 0.2900 17400.0n 0.2900 17999.5n 0.2900 18000.0n 0.2900 18599.5n 0.2900 18600.0n 0.2900 19199.5n 0.2900 19200.0n 0.2900 19799.5n 0.2900 19800.0n 0.2900 20399.5n 0.2900 20400.0n 0.2900 20999.5n 0.2900 21000.0n 0.2900 21599.5n 0.2900 21600.0n 0.2900 22199.5n 0.2900 22200.0n 0.2900 22799.5n 0.2900 22800.0n 0.2900 23399.5n 0.2900 23400.0n 0.2900 23999.5n 0.2900 24000.0n 0.2900 24599.5n 0.2900 24600.0n 0.2900 25199.5n 0.2900 25200.0n 0.2900 25799.5n 0.2900 25800.0n 0.2900 26399.5n 0.2900 26400.0n 0.2900 26999.5n 0.2900 27000.0n 0.2900 27599.5n 0.2900 27600.0n 0.2900 28199.5n 0.2900 28200.0n 0.2900 28799.5n 0.2900 28800.0n 0.2900 29399.5n 0.2900 29400.0n 0.2900 29999.5n 0.2900 30000.0n 0.2900 30599.5n 0.2900 30600.0n 0.2900 31199.5n 0.2900 31200.0n 0.2900 31799.5n 0.2900 31800.0n 0.2900 32399.5n 0.2900 32400.0n 0.2900 32999.5n 0.2900 33000.0n 0.2900 33599.5n 0.2900 33600.0n 0.2900 34199.5n 0.2900 34200.0n 0.2900 34799.5n 0.2900 34800.0n 0.2900 35399.5n 0.2900 35400.0n 0.2900 35999.5n 0.2900)
Vyp_bh_21 yp_bh_21 0 PWL(0.0n 0.4795 599.5n 0.4795 600.0n 0.5348 1199.5n 0.5348 1200.0n 0.4262 1799.5n 0.4262 1800.0n 0.4458 2399.5n 0.4458 2400.0n 0.4693 2999.5n 0.4693 3000.0n 0.4806 3599.5n 0.4806 3600.0n 0.4330 4199.5n 0.4330 4200.0n 0.4741 4799.5n 0.4741 4800.0n 0.4617 5399.5n 0.4617 5400.0n 0.4626 5999.5n 0.4626 6000.0n 0.4251 6599.5n 0.4251 6600.0n 0.4580 7199.5n 0.4580 7200.0n 0.5168 7799.5n 0.5168 7800.0n 0.5172 8399.5n 0.5172 8400.0n 0.4455 8999.5n 0.4455 9000.0n 0.4627 9599.5n 0.4627 9600.0n 0.4689 10199.5n 0.4689 10200.0n 0.4921 10799.5n 0.4921 10800.0n 0.4149 11399.5n 0.4149 11400.0n 0.4625 11999.5n 0.4625 12000.0n 0.4391 12599.5n 0.4391 12600.0n 0.4704 13199.5n 0.4704 13200.0n 0.4885 13799.5n 0.4885 13800.0n 0.5057 14399.5n 0.5057 14400.0n 0.4671 14999.5n 0.4671 15000.0n 0.4745 15599.5n 0.4745 15600.0n 0.4635 16199.5n 0.4635 16200.0n 0.5055 16799.5n 0.5055 16800.0n 0.4384 17399.5n 0.4384 17400.0n 0.4905 17999.5n 0.4905 18000.0n 0.3454 18599.5n 0.3454 18600.0n 0.5842 19199.5n 0.5842 19200.0n 0.4242 19799.5n 0.4242 19800.0n 0.5301 20399.5n 0.5301 20400.0n 0.3765 20999.5n 0.3765 21000.0n 0.3462 21599.5n 0.3462 21600.0n 0.5557 22199.5n 0.5557 22200.0n 0.5965 22799.5n 0.5965 22800.0n 0.3651 23399.5n 0.3651 23400.0n 0.6178 23999.5n 0.6178 24000.0n 0.4927 24599.5n 0.4927 24600.0n 0.6055 25199.5n 0.6055 25200.0n 0.3511 25799.5n 0.3511 25800.0n 0.3313 26399.5n 0.3313 26400.0n 0.3438 26999.5n 0.3438 27000.0n 0.3427 27599.5n 0.3427 27600.0n 0.3452 28199.5n 0.3452 28200.0n 0.6344 28799.5n 0.6344 28800.0n 0.3655 29399.5n 0.3655 29400.0n 0.3488 29999.5n 0.3488 30000.0n 0.3528 30599.5n 0.3528 30600.0n 0.4289 31199.5n 0.4289 31200.0n 0.4863 31799.5n 0.4863 31800.0n 0.3316 32399.5n 0.3316 32400.0n 0.3316 32999.5n 0.3316 33000.0n 0.4504 33599.5n 0.4504 33600.0n 0.4051 34199.5n 0.4051 34200.0n 0.6047 34799.5n 0.6047 34800.0n 0.3606 35399.5n 0.3606 35400.0n 0.4119 35999.5n 0.4119)
Vyn_bh_21 yn_bh_21 0 PWL(0.0n 0.5205 599.5n 0.5205 600.0n 0.4652 1199.5n 0.4652 1200.0n 0.5738 1799.5n 0.5738 1800.0n 0.5542 2399.5n 0.5542 2400.0n 0.5307 2999.5n 0.5307 3000.0n 0.5194 3599.5n 0.5194 3600.0n 0.5670 4199.5n 0.5670 4200.0n 0.5259 4799.5n 0.5259 4800.0n 0.5383 5399.5n 0.5383 5400.0n 0.5374 5999.5n 0.5374 6000.0n 0.5749 6599.5n 0.5749 6600.0n 0.5420 7199.5n 0.5420 7200.0n 0.4832 7799.5n 0.4832 7800.0n 0.4828 8399.5n 0.4828 8400.0n 0.5545 8999.5n 0.5545 9000.0n 0.5373 9599.5n 0.5373 9600.0n 0.5311 10199.5n 0.5311 10200.0n 0.5079 10799.5n 0.5079 10800.0n 0.5851 11399.5n 0.5851 11400.0n 0.5375 11999.5n 0.5375 12000.0n 0.5609 12599.5n 0.5609 12600.0n 0.5296 13199.5n 0.5296 13200.0n 0.5115 13799.5n 0.5115 13800.0n 0.4943 14399.5n 0.4943 14400.0n 0.5329 14999.5n 0.5329 15000.0n 0.5255 15599.5n 0.5255 15600.0n 0.5365 16199.5n 0.5365 16200.0n 0.4945 16799.5n 0.4945 16800.0n 0.5616 17399.5n 0.5616 17400.0n 0.5095 17999.5n 0.5095 18000.0n 0.6546 18599.5n 0.6546 18600.0n 0.4158 19199.5n 0.4158 19200.0n 0.5758 19799.5n 0.5758 19800.0n 0.4699 20399.5n 0.4699 20400.0n 0.6235 20999.5n 0.6235 21000.0n 0.6538 21599.5n 0.6538 21600.0n 0.4443 22199.5n 0.4443 22200.0n 0.4035 22799.5n 0.4035 22800.0n 0.6349 23399.5n 0.6349 23400.0n 0.3822 23999.5n 0.3822 24000.0n 0.5073 24599.5n 0.5073 24600.0n 0.3945 25199.5n 0.3945 25200.0n 0.6489 25799.5n 0.6489 25800.0n 0.6687 26399.5n 0.6687 26400.0n 0.6562 26999.5n 0.6562 27000.0n 0.6573 27599.5n 0.6573 27600.0n 0.6548 28199.5n 0.6548 28200.0n 0.3656 28799.5n 0.3656 28800.0n 0.6345 29399.5n 0.6345 29400.0n 0.6512 29999.5n 0.6512 30000.0n 0.6472 30599.5n 0.6472 30600.0n 0.5711 31199.5n 0.5711 31200.0n 0.5137 31799.5n 0.5137 31800.0n 0.6684 32399.5n 0.6684 32400.0n 0.6684 32999.5n 0.6684 33000.0n 0.5496 33599.5n 0.5496 33600.0n 0.5949 34199.5n 0.5949 34200.0n 0.3953 34799.5n 0.3953 34800.0n 0.6394 35399.5n 0.6394 35400.0n 0.5881 35999.5n 0.5881)
Cwp_bh_21 wp_bh_21 0 400p
Cwn_bh_21 wn_bh_21 0 400p
Xu_bh_21 xp_bh_21 xn_bh_21 yp_bh_21 yn_bh_21 wp_bh_21 wn_bh_21 vdd gbn gprod
Vxp_wih_0_22 xp_wih_0_22 0 PWL(0.0n 0.4942 599.5n 0.4942 600.0n 0.5558 1199.5n 0.5558 1200.0n 0.4708 1799.5n 0.4708 1800.0n 0.5235 2399.5n 0.5235 2400.0n 0.5350 2999.5n 0.5350 3000.0n 0.5172 3599.5n 0.5172 3600.0n 0.4702 4199.5n 0.4702 4200.0n 0.4867 4799.5n 0.4867 4800.0n 0.4970 5399.5n 0.4970 5400.0n 0.4986 5999.5n 0.4986 6000.0n 0.4751 6599.5n 0.4751 6600.0n 0.4870 7199.5n 0.4870 7200.0n 0.5502 7799.5n 0.5502 7800.0n 0.5521 8399.5n 0.5521 8400.0n 0.4638 8999.5n 0.4638 9000.0n 0.4982 9599.5n 0.4982 9600.0n 0.5131 10199.5n 0.5131 10200.0n 0.5386 10799.5n 0.5386 10800.0n 0.4592 11399.5n 0.4592 11400.0n 0.4950 11999.5n 0.4950 12000.0n 0.4559 12599.5n 0.4559 12600.0n 0.5162 13199.5n 0.5162 13200.0n 0.5038 13799.5n 0.5038 13800.0n 0.5333 14399.5n 0.5333 14400.0n 0.4991 14999.5n 0.4991 15000.0n 0.5298 15599.5n 0.5298 15600.0n 0.4823 16199.5n 0.4823 16200.0n 0.5239 16799.5n 0.5239 16800.0n 0.4592 17399.5n 0.4592 17400.0n 0.5094 17999.5n 0.5094 18000.0n 0.4337 18599.5n 0.4337 18600.0n 0.5977 19199.5n 0.5977 19200.0n 0.5364 19799.5n 0.5364 19800.0n 0.6122 20399.5n 0.6122 20400.0n 0.4856 20999.5n 0.4856 21000.0n 0.3861 21599.5n 0.3861 21600.0n 0.6094 22199.5n 0.6094 22200.0n 0.6364 22799.5n 0.6364 22800.0n 0.4807 23399.5n 0.4807 23400.0n 0.5614 23999.5n 0.5614 24000.0n 0.5913 24599.5n 0.5913 24600.0n 0.6295 25199.5n 0.6295 25200.0n 0.4496 25799.5n 0.4496 25800.0n 0.3792 26399.5n 0.3792 26400.0n 0.4434 26999.5n 0.4434 27000.0n 0.4340 27599.5n 0.4340 27600.0n 0.4461 28199.5n 0.4461 28200.0n 0.5791 28799.5n 0.5791 28800.0n 0.4777 29399.5n 0.4777 29400.0n 0.3878 29999.5n 0.3878 30000.0n 0.3832 30599.5n 0.3832 30600.0n 0.4022 31199.5n 0.4022 31200.0n 0.4482 31799.5n 0.4482 31800.0n 0.3662 32399.5n 0.3662 32400.0n 0.3857 32999.5n 0.3857 33000.0n 0.5584 33599.5n 0.5584 33600.0n 0.5284 34199.5n 0.5284 34200.0n 0.6034 34799.5n 0.6034 34800.0n 0.3469 35399.5n 0.3469 35400.0n 0.5290 35999.5n 0.5290)
Vxn_wih_0_22 xn_wih_0_22 0 PWL(0.0n 0.5058 599.5n 0.5058 600.0n 0.4442 1199.5n 0.4442 1200.0n 0.5292 1799.5n 0.5292 1800.0n 0.4765 2399.5n 0.4765 2400.0n 0.4650 2999.5n 0.4650 3000.0n 0.4828 3599.5n 0.4828 3600.0n 0.5298 4199.5n 0.5298 4200.0n 0.5133 4799.5n 0.5133 4800.0n 0.5030 5399.5n 0.5030 5400.0n 0.5014 5999.5n 0.5014 6000.0n 0.5249 6599.5n 0.5249 6600.0n 0.5130 7199.5n 0.5130 7200.0n 0.4498 7799.5n 0.4498 7800.0n 0.4479 8399.5n 0.4479 8400.0n 0.5362 8999.5n 0.5362 9000.0n 0.5018 9599.5n 0.5018 9600.0n 0.4869 10199.5n 0.4869 10200.0n 0.4614 10799.5n 0.4614 10800.0n 0.5408 11399.5n 0.5408 11400.0n 0.5050 11999.5n 0.5050 12000.0n 0.5441 12599.5n 0.5441 12600.0n 0.4838 13199.5n 0.4838 13200.0n 0.4962 13799.5n 0.4962 13800.0n 0.4667 14399.5n 0.4667 14400.0n 0.5009 14999.5n 0.5009 15000.0n 0.4702 15599.5n 0.4702 15600.0n 0.5177 16199.5n 0.5177 16200.0n 0.4761 16799.5n 0.4761 16800.0n 0.5408 17399.5n 0.5408 17400.0n 0.4906 17999.5n 0.4906 18000.0n 0.5663 18599.5n 0.5663 18600.0n 0.4023 19199.5n 0.4023 19200.0n 0.4636 19799.5n 0.4636 19800.0n 0.3878 20399.5n 0.3878 20400.0n 0.5144 20999.5n 0.5144 21000.0n 0.6139 21599.5n 0.6139 21600.0n 0.3906 22199.5n 0.3906 22200.0n 0.3636 22799.5n 0.3636 22800.0n 0.5193 23399.5n 0.5193 23400.0n 0.4386 23999.5n 0.4386 24000.0n 0.4087 24599.5n 0.4087 24600.0n 0.3705 25199.5n 0.3705 25200.0n 0.5504 25799.5n 0.5504 25800.0n 0.6208 26399.5n 0.6208 26400.0n 0.5566 26999.5n 0.5566 27000.0n 0.5660 27599.5n 0.5660 27600.0n 0.5539 28199.5n 0.5539 28200.0n 0.4209 28799.5n 0.4209 28800.0n 0.5223 29399.5n 0.5223 29400.0n 0.6122 29999.5n 0.6122 30000.0n 0.6168 30599.5n 0.6168 30600.0n 0.5978 31199.5n 0.5978 31200.0n 0.5518 31799.5n 0.5518 31800.0n 0.6338 32399.5n 0.6338 32400.0n 0.6143 32999.5n 0.6143 33000.0n 0.4416 33599.5n 0.4416 33600.0n 0.4716 34199.5n 0.4716 34200.0n 0.3966 34799.5n 0.3966 34800.0n 0.6531 35399.5n 0.6531 35400.0n 0.4710 35999.5n 0.4710)
Vyp_wih_0_22 yp_wih_0_22 0 PWL(0.0n 0.4181 599.5n 0.4181 600.0n 0.4485 1199.5n 0.4485 1200.0n 0.4136 1799.5n 0.4136 1800.0n 0.4372 2399.5n 0.4372 2400.0n 0.4407 2999.5n 0.4407 3000.0n 0.4287 3599.5n 0.4287 3600.0n 0.4122 4199.5n 0.4122 4200.0n 0.4153 4799.5n 0.4153 4800.0n 0.4217 5399.5n 0.4217 5400.0n 0.4223 5999.5n 0.4223 6000.0n 0.4162 6599.5n 0.4162 6600.0n 0.4175 7199.5n 0.4175 7200.0n 0.4455 7799.5n 0.4455 7800.0n 0.4473 8399.5n 0.4473 8400.0n 0.4067 8999.5n 0.4067 9000.0n 0.4221 9599.5n 0.4221 9600.0n 0.4284 10199.5n 0.4284 10200.0n 0.4398 10799.5n 0.4398 10800.0n 0.4079 11399.5n 0.4079 11400.0n 0.4206 11999.5n 0.4206 12000.0n 0.4022 12599.5n 0.4022 12600.0n 0.4297 13199.5n 0.4297 13200.0n 0.4214 13799.5n 0.4214 13800.0n 0.4344 14399.5n 0.4344 14400.0n 0.4219 14999.5n 0.4219 15000.0n 0.4367 15599.5n 0.4367 15600.0n 0.4145 16199.5n 0.4145 16200.0n 0.4290 16799.5n 0.4290 16800.0n 0.4046 17399.5n 0.4046 17400.0n 0.4237 17999.5n 0.4237 18000.0n 0.3965 18599.5n 0.3965 18600.0n 0.4806 19199.5n 0.4806 19200.0n 0.4493 19799.5n 0.4493 19800.0n 0.4930 20399.5n 0.4930 20400.0n 0.4307 20999.5n 0.4307 21000.0n 0.3659 21599.5n 0.3659 21600.0n 0.4887 22199.5n 0.4887 22200.0n 0.4871 22799.5n 0.4871 22800.0n 0.4290 23399.5n 0.4290 23400.0n 0.4429 23999.5n 0.4429 24000.0n 0.4920 24599.5n 0.4920 24600.0n 0.4854 25199.5n 0.4854 25200.0n 0.4126 25799.5n 0.4126 25800.0n 0.3753 26399.5n 0.3753 26400.0n 0.4093 26999.5n 0.4093 27000.0n 0.3990 27599.5n 0.3990 27600.0n 0.4114 28199.5n 0.4114 28200.0n 0.4624 28799.5n 0.4624 28800.0n 0.4278 29399.5n 0.4278 29400.0n 0.3650 29999.5n 0.3650 30000.0n 0.3625 30599.5n 0.3625 30600.0n 0.3573 31199.5n 0.3573 31200.0n 0.3889 31799.5n 0.3889 31800.0n 0.3734 32399.5n 0.3734 32400.0n 0.3762 32999.5n 0.3762 33000.0n 0.4650 33599.5n 0.4650 33600.0n 0.4468 34199.5n 0.4468 34200.0n 0.4798 34799.5n 0.4798 34800.0n 0.3586 35399.5n 0.3586 35400.0n 0.4470 35999.5n 0.4470)
Vyn_wih_0_22 yn_wih_0_22 0 PWL(0.0n 0.5819 599.5n 0.5819 600.0n 0.5515 1199.5n 0.5515 1200.0n 0.5864 1799.5n 0.5864 1800.0n 0.5628 2399.5n 0.5628 2400.0n 0.5593 2999.5n 0.5593 3000.0n 0.5713 3599.5n 0.5713 3600.0n 0.5878 4199.5n 0.5878 4200.0n 0.5847 4799.5n 0.5847 4800.0n 0.5783 5399.5n 0.5783 5400.0n 0.5777 5999.5n 0.5777 6000.0n 0.5838 6599.5n 0.5838 6600.0n 0.5825 7199.5n 0.5825 7200.0n 0.5545 7799.5n 0.5545 7800.0n 0.5527 8399.5n 0.5527 8400.0n 0.5933 8999.5n 0.5933 9000.0n 0.5779 9599.5n 0.5779 9600.0n 0.5716 10199.5n 0.5716 10200.0n 0.5602 10799.5n 0.5602 10800.0n 0.5921 11399.5n 0.5921 11400.0n 0.5794 11999.5n 0.5794 12000.0n 0.5978 12599.5n 0.5978 12600.0n 0.5703 13199.5n 0.5703 13200.0n 0.5786 13799.5n 0.5786 13800.0n 0.5656 14399.5n 0.5656 14400.0n 0.5781 14999.5n 0.5781 15000.0n 0.5633 15599.5n 0.5633 15600.0n 0.5855 16199.5n 0.5855 16200.0n 0.5710 16799.5n 0.5710 16800.0n 0.5954 17399.5n 0.5954 17400.0n 0.5763 17999.5n 0.5763 18000.0n 0.6035 18599.5n 0.6035 18600.0n 0.5194 19199.5n 0.5194 19200.0n 0.5507 19799.5n 0.5507 19800.0n 0.5070 20399.5n 0.5070 20400.0n 0.5693 20999.5n 0.5693 21000.0n 0.6341 21599.5n 0.6341 21600.0n 0.5113 22199.5n 0.5113 22200.0n 0.5129 22799.5n 0.5129 22800.0n 0.5710 23399.5n 0.5710 23400.0n 0.5571 23999.5n 0.5571 24000.0n 0.5080 24599.5n 0.5080 24600.0n 0.5146 25199.5n 0.5146 25200.0n 0.5874 25799.5n 0.5874 25800.0n 0.6247 26399.5n 0.6247 26400.0n 0.5907 26999.5n 0.5907 27000.0n 0.6010 27599.5n 0.6010 27600.0n 0.5886 28199.5n 0.5886 28200.0n 0.5376 28799.5n 0.5376 28800.0n 0.5722 29399.5n 0.5722 29400.0n 0.6350 29999.5n 0.6350 30000.0n 0.6375 30599.5n 0.6375 30600.0n 0.6427 31199.5n 0.6427 31200.0n 0.6111 31799.5n 0.6111 31800.0n 0.6266 32399.5n 0.6266 32400.0n 0.6238 32999.5n 0.6238 33000.0n 0.5350 33599.5n 0.5350 33600.0n 0.5532 34199.5n 0.5532 34200.0n 0.5202 34799.5n 0.5202 34800.0n 0.6414 35399.5n 0.6414 35400.0n 0.5530 35999.5n 0.5530)
Cwp_wih_0_22 wp_wih_0_22 0 400p
Cwn_wih_0_22 wn_wih_0_22 0 400p
Xu_wih_0_22 xp_wih_0_22 xn_wih_0_22 yp_wih_0_22 yn_wih_0_22 wp_wih_0_22 wn_wih_0_22 vdd gbn gprod
Vxp_wih_1_22 xp_wih_1_22 0 PWL(0.0n 0.5370 599.5n 0.5370 600.0n 0.5167 1199.5n 0.5167 1200.0n 0.4793 1799.5n 0.4793 1800.0n 0.4441 2399.5n 0.4441 2400.0n 0.4555 2999.5n 0.4555 3000.0n 0.5055 3599.5n 0.5055 3600.0n 0.4939 4199.5n 0.4939 4200.0n 0.5385 4799.5n 0.5385 4800.0n 0.5024 5399.5n 0.5024 5400.0n 0.5015 5999.5n 0.5015 6000.0n 0.4700 6599.5n 0.4700 6600.0n 0.5120 7199.5n 0.5120 7200.0n 0.5006 7799.5n 0.5006 7800.0n 0.4950 8399.5n 0.4950 8400.0n 0.5309 8999.5n 0.5309 9000.0n 0.5023 9599.5n 0.5023 9600.0n 0.4893 10199.5n 0.4893 10200.0n 0.4837 10799.5n 0.4837 10800.0n 0.4823 11399.5n 0.4823 11400.0n 0.5074 11999.5n 0.5074 12000.0n 0.5364 12599.5n 0.5364 12600.0n 0.4868 13199.5n 0.4868 13200.0n 0.5380 13799.5n 0.5380 13800.0n 0.5220 14399.5n 0.5220 14400.0n 0.5095 14999.5n 0.5095 15000.0n 0.4705 15599.5n 0.4705 15600.0n 0.5289 16199.5n 0.5289 16200.0n 0.5368 16799.5n 0.5368 16800.0n 0.5287 17399.5n 0.5287 17400.0n 0.5342 17999.5n 0.5342 18000.0n 0.4253 18599.5n 0.4253 18600.0n 0.5119 19199.5n 0.5119 19200.0n 0.4104 19799.5n 0.4104 19800.0n 0.4314 20399.5n 0.4314 20400.0n 0.4005 20999.5n 0.4005 21000.0n 0.4696 21599.5n 0.4696 21600.0n 0.4531 22199.5n 0.4531 22200.0n 0.5039 22799.5n 0.5039 22800.0n 0.3608 23399.5n 0.3608 23400.0n 0.6273 23999.5n 0.6273 24000.0n 0.3928 24599.5n 0.3928 24600.0n 0.5253 25199.5n 0.5253 25200.0n 0.4107 25799.5n 0.4107 25800.0n 0.3947 26399.5n 0.3947 26400.0n 0.3716 26999.5n 0.3716 27000.0n 0.4111 27599.5n 0.4111 27600.0n 0.3715 28199.5n 0.3715 28200.0n 0.5939 28799.5n 0.5939 28800.0n 0.3849 29399.5n 0.3849 29400.0n 0.4835 29999.5n 0.4835 30000.0n 0.5119 30599.5n 0.5119 30600.0n 0.6226 31199.5n 0.6226 31200.0n 0.6064 31799.5n 0.6064 31800.0n 0.4115 32399.5n 0.4115 32400.0n 0.3900 32999.5n 0.3900 33000.0n 0.3958 33599.5n 0.3958 33600.0n 0.3747 34199.5n 0.3747 34200.0n 0.5423 34799.5n 0.5423 34800.0n 0.5509 35399.5n 0.5509 35400.0n 0.3990 35999.5n 0.3990)
Vxn_wih_1_22 xn_wih_1_22 0 PWL(0.0n 0.4630 599.5n 0.4630 600.0n 0.4833 1199.5n 0.4833 1200.0n 0.5207 1799.5n 0.5207 1800.0n 0.5559 2399.5n 0.5559 2400.0n 0.5445 2999.5n 0.5445 3000.0n 0.4945 3599.5n 0.4945 3600.0n 0.5061 4199.5n 0.5061 4200.0n 0.4615 4799.5n 0.4615 4800.0n 0.4976 5399.5n 0.4976 5400.0n 0.4985 5999.5n 0.4985 6000.0n 0.5300 6599.5n 0.5300 6600.0n 0.4880 7199.5n 0.4880 7200.0n 0.4994 7799.5n 0.4994 7800.0n 0.5050 8399.5n 0.5050 8400.0n 0.4691 8999.5n 0.4691 9000.0n 0.4977 9599.5n 0.4977 9600.0n 0.5107 10199.5n 0.5107 10200.0n 0.5163 10799.5n 0.5163 10800.0n 0.5177 11399.5n 0.5177 11400.0n 0.4926 11999.5n 0.4926 12000.0n 0.4636 12599.5n 0.4636 12600.0n 0.5132 13199.5n 0.5132 13200.0n 0.4620 13799.5n 0.4620 13800.0n 0.4780 14399.5n 0.4780 14400.0n 0.4905 14999.5n 0.4905 15000.0n 0.5295 15599.5n 0.5295 15600.0n 0.4711 16199.5n 0.4711 16200.0n 0.4632 16799.5n 0.4632 16800.0n 0.4713 17399.5n 0.4713 17400.0n 0.4658 17999.5n 0.4658 18000.0n 0.5747 18599.5n 0.5747 18600.0n 0.4881 19199.5n 0.4881 19200.0n 0.5896 19799.5n 0.5896 19800.0n 0.5686 20399.5n 0.5686 20400.0n 0.5995 20999.5n 0.5995 21000.0n 0.5304 21599.5n 0.5304 21600.0n 0.5469 22199.5n 0.5469 22200.0n 0.4961 22799.5n 0.4961 22800.0n 0.6392 23399.5n 0.6392 23400.0n 0.3727 23999.5n 0.3727 24000.0n 0.6072 24599.5n 0.6072 24600.0n 0.4747 25199.5n 0.4747 25200.0n 0.5893 25799.5n 0.5893 25800.0n 0.6053 26399.5n 0.6053 26400.0n 0.6284 26999.5n 0.6284 27000.0n 0.5889 27599.5n 0.5889 27600.0n 0.6285 28199.5n 0.6285 28200.0n 0.4061 28799.5n 0.4061 28800.0n 0.6151 29399.5n 0.6151 29400.0n 0.5165 29999.5n 0.5165 30000.0n 0.4881 30599.5n 0.4881 30600.0n 0.3774 31199.5n 0.3774 31200.0n 0.3936 31799.5n 0.3936 31800.0n 0.5885 32399.5n 0.5885 32400.0n 0.6100 32999.5n 0.6100 33000.0n 0.6042 33599.5n 0.6042 33600.0n 0.6253 34199.5n 0.6253 34200.0n 0.4577 34799.5n 0.4577 34800.0n 0.4491 35399.5n 0.4491 35400.0n 0.6010 35999.5n 0.6010)
Vyp_wih_1_22 yp_wih_1_22 0 PWL(0.0n 0.4181 599.5n 0.4181 600.0n 0.4485 1199.5n 0.4485 1200.0n 0.4136 1799.5n 0.4136 1800.0n 0.4372 2399.5n 0.4372 2400.0n 0.4407 2999.5n 0.4407 3000.0n 0.4287 3599.5n 0.4287 3600.0n 0.4122 4199.5n 0.4122 4200.0n 0.4153 4799.5n 0.4153 4800.0n 0.4217 5399.5n 0.4217 5400.0n 0.4223 5999.5n 0.4223 6000.0n 0.4162 6599.5n 0.4162 6600.0n 0.4175 7199.5n 0.4175 7200.0n 0.4455 7799.5n 0.4455 7800.0n 0.4473 8399.5n 0.4473 8400.0n 0.4067 8999.5n 0.4067 9000.0n 0.4221 9599.5n 0.4221 9600.0n 0.4284 10199.5n 0.4284 10200.0n 0.4398 10799.5n 0.4398 10800.0n 0.4079 11399.5n 0.4079 11400.0n 0.4206 11999.5n 0.4206 12000.0n 0.4022 12599.5n 0.4022 12600.0n 0.4297 13199.5n 0.4297 13200.0n 0.4214 13799.5n 0.4214 13800.0n 0.4344 14399.5n 0.4344 14400.0n 0.4219 14999.5n 0.4219 15000.0n 0.4367 15599.5n 0.4367 15600.0n 0.4145 16199.5n 0.4145 16200.0n 0.4290 16799.5n 0.4290 16800.0n 0.4046 17399.5n 0.4046 17400.0n 0.4237 17999.5n 0.4237 18000.0n 0.3965 18599.5n 0.3965 18600.0n 0.4806 19199.5n 0.4806 19200.0n 0.4493 19799.5n 0.4493 19800.0n 0.4930 20399.5n 0.4930 20400.0n 0.4307 20999.5n 0.4307 21000.0n 0.3659 21599.5n 0.3659 21600.0n 0.4887 22199.5n 0.4887 22200.0n 0.4871 22799.5n 0.4871 22800.0n 0.4290 23399.5n 0.4290 23400.0n 0.4429 23999.5n 0.4429 24000.0n 0.4920 24599.5n 0.4920 24600.0n 0.4854 25199.5n 0.4854 25200.0n 0.4126 25799.5n 0.4126 25800.0n 0.3753 26399.5n 0.3753 26400.0n 0.4093 26999.5n 0.4093 27000.0n 0.3990 27599.5n 0.3990 27600.0n 0.4114 28199.5n 0.4114 28200.0n 0.4624 28799.5n 0.4624 28800.0n 0.4278 29399.5n 0.4278 29400.0n 0.3650 29999.5n 0.3650 30000.0n 0.3625 30599.5n 0.3625 30600.0n 0.3573 31199.5n 0.3573 31200.0n 0.3889 31799.5n 0.3889 31800.0n 0.3734 32399.5n 0.3734 32400.0n 0.3762 32999.5n 0.3762 33000.0n 0.4650 33599.5n 0.4650 33600.0n 0.4468 34199.5n 0.4468 34200.0n 0.4798 34799.5n 0.4798 34800.0n 0.3586 35399.5n 0.3586 35400.0n 0.4470 35999.5n 0.4470)
Vyn_wih_1_22 yn_wih_1_22 0 PWL(0.0n 0.5819 599.5n 0.5819 600.0n 0.5515 1199.5n 0.5515 1200.0n 0.5864 1799.5n 0.5864 1800.0n 0.5628 2399.5n 0.5628 2400.0n 0.5593 2999.5n 0.5593 3000.0n 0.5713 3599.5n 0.5713 3600.0n 0.5878 4199.5n 0.5878 4200.0n 0.5847 4799.5n 0.5847 4800.0n 0.5783 5399.5n 0.5783 5400.0n 0.5777 5999.5n 0.5777 6000.0n 0.5838 6599.5n 0.5838 6600.0n 0.5825 7199.5n 0.5825 7200.0n 0.5545 7799.5n 0.5545 7800.0n 0.5527 8399.5n 0.5527 8400.0n 0.5933 8999.5n 0.5933 9000.0n 0.5779 9599.5n 0.5779 9600.0n 0.5716 10199.5n 0.5716 10200.0n 0.5602 10799.5n 0.5602 10800.0n 0.5921 11399.5n 0.5921 11400.0n 0.5794 11999.5n 0.5794 12000.0n 0.5978 12599.5n 0.5978 12600.0n 0.5703 13199.5n 0.5703 13200.0n 0.5786 13799.5n 0.5786 13800.0n 0.5656 14399.5n 0.5656 14400.0n 0.5781 14999.5n 0.5781 15000.0n 0.5633 15599.5n 0.5633 15600.0n 0.5855 16199.5n 0.5855 16200.0n 0.5710 16799.5n 0.5710 16800.0n 0.5954 17399.5n 0.5954 17400.0n 0.5763 17999.5n 0.5763 18000.0n 0.6035 18599.5n 0.6035 18600.0n 0.5194 19199.5n 0.5194 19200.0n 0.5507 19799.5n 0.5507 19800.0n 0.5070 20399.5n 0.5070 20400.0n 0.5693 20999.5n 0.5693 21000.0n 0.6341 21599.5n 0.6341 21600.0n 0.5113 22199.5n 0.5113 22200.0n 0.5129 22799.5n 0.5129 22800.0n 0.5710 23399.5n 0.5710 23400.0n 0.5571 23999.5n 0.5571 24000.0n 0.5080 24599.5n 0.5080 24600.0n 0.5146 25199.5n 0.5146 25200.0n 0.5874 25799.5n 0.5874 25800.0n 0.6247 26399.5n 0.6247 26400.0n 0.5907 26999.5n 0.5907 27000.0n 0.6010 27599.5n 0.6010 27600.0n 0.5886 28199.5n 0.5886 28200.0n 0.5376 28799.5n 0.5376 28800.0n 0.5722 29399.5n 0.5722 29400.0n 0.6350 29999.5n 0.6350 30000.0n 0.6375 30599.5n 0.6375 30600.0n 0.6427 31199.5n 0.6427 31200.0n 0.6111 31799.5n 0.6111 31800.0n 0.6266 32399.5n 0.6266 32400.0n 0.6238 32999.5n 0.6238 33000.0n 0.5350 33599.5n 0.5350 33600.0n 0.5532 34199.5n 0.5532 34200.0n 0.5202 34799.5n 0.5202 34800.0n 0.6414 35399.5n 0.6414 35400.0n 0.5530 35999.5n 0.5530)
Cwp_wih_1_22 wp_wih_1_22 0 400p
Cwn_wih_1_22 wn_wih_1_22 0 400p
Xu_wih_1_22 xp_wih_1_22 xn_wih_1_22 yp_wih_1_22 yn_wih_1_22 wp_wih_1_22 wn_wih_1_22 vdd gbn gprod
Vxp_who_22_0 xp_who_22_0 0 PWL(0.0n 0.4181 599.5n 0.4181 600.0n 0.4485 1199.5n 0.4485 1200.0n 0.4136 1799.5n 0.4136 1800.0n 0.4372 2399.5n 0.4372 2400.0n 0.4407 2999.5n 0.4407 3000.0n 0.4287 3599.5n 0.4287 3600.0n 0.4122 4199.5n 0.4122 4200.0n 0.4153 4799.5n 0.4153 4800.0n 0.4217 5399.5n 0.4217 5400.0n 0.4223 5999.5n 0.4223 6000.0n 0.4162 6599.5n 0.4162 6600.0n 0.4175 7199.5n 0.4175 7200.0n 0.4455 7799.5n 0.4455 7800.0n 0.4473 8399.5n 0.4473 8400.0n 0.4067 8999.5n 0.4067 9000.0n 0.4221 9599.5n 0.4221 9600.0n 0.4284 10199.5n 0.4284 10200.0n 0.4398 10799.5n 0.4398 10800.0n 0.4079 11399.5n 0.4079 11400.0n 0.4206 11999.5n 0.4206 12000.0n 0.4022 12599.5n 0.4022 12600.0n 0.4297 13199.5n 0.4297 13200.0n 0.4214 13799.5n 0.4214 13800.0n 0.4344 14399.5n 0.4344 14400.0n 0.4219 14999.5n 0.4219 15000.0n 0.4367 15599.5n 0.4367 15600.0n 0.4145 16199.5n 0.4145 16200.0n 0.4290 16799.5n 0.4290 16800.0n 0.4046 17399.5n 0.4046 17400.0n 0.4237 17999.5n 0.4237 18000.0n 0.3965 18599.5n 0.3965 18600.0n 0.4806 19199.5n 0.4806 19200.0n 0.4493 19799.5n 0.4493 19800.0n 0.4930 20399.5n 0.4930 20400.0n 0.4307 20999.5n 0.4307 21000.0n 0.3659 21599.5n 0.3659 21600.0n 0.4887 22199.5n 0.4887 22200.0n 0.4871 22799.5n 0.4871 22800.0n 0.4290 23399.5n 0.4290 23400.0n 0.4429 23999.5n 0.4429 24000.0n 0.4920 24599.5n 0.4920 24600.0n 0.4854 25199.5n 0.4854 25200.0n 0.4126 25799.5n 0.4126 25800.0n 0.3753 26399.5n 0.3753 26400.0n 0.4093 26999.5n 0.4093 27000.0n 0.3990 27599.5n 0.3990 27600.0n 0.4114 28199.5n 0.4114 28200.0n 0.4624 28799.5n 0.4624 28800.0n 0.4278 29399.5n 0.4278 29400.0n 0.3650 29999.5n 0.3650 30000.0n 0.3625 30599.5n 0.3625 30600.0n 0.3573 31199.5n 0.3573 31200.0n 0.3889 31799.5n 0.3889 31800.0n 0.3734 32399.5n 0.3734 32400.0n 0.3762 32999.5n 0.3762 33000.0n 0.4650 33599.5n 0.4650 33600.0n 0.4468 34199.5n 0.4468 34200.0n 0.4798 34799.5n 0.4798 34800.0n 0.3586 35399.5n 0.3586 35400.0n 0.4470 35999.5n 0.4470)
Vxn_who_22_0 xn_who_22_0 0 PWL(0.0n 0.5819 599.5n 0.5819 600.0n 0.5515 1199.5n 0.5515 1200.0n 0.5864 1799.5n 0.5864 1800.0n 0.5628 2399.5n 0.5628 2400.0n 0.5593 2999.5n 0.5593 3000.0n 0.5713 3599.5n 0.5713 3600.0n 0.5878 4199.5n 0.5878 4200.0n 0.5847 4799.5n 0.5847 4800.0n 0.5783 5399.5n 0.5783 5400.0n 0.5777 5999.5n 0.5777 6000.0n 0.5838 6599.5n 0.5838 6600.0n 0.5825 7199.5n 0.5825 7200.0n 0.5545 7799.5n 0.5545 7800.0n 0.5527 8399.5n 0.5527 8400.0n 0.5933 8999.5n 0.5933 9000.0n 0.5779 9599.5n 0.5779 9600.0n 0.5716 10199.5n 0.5716 10200.0n 0.5602 10799.5n 0.5602 10800.0n 0.5921 11399.5n 0.5921 11400.0n 0.5794 11999.5n 0.5794 12000.0n 0.5978 12599.5n 0.5978 12600.0n 0.5703 13199.5n 0.5703 13200.0n 0.5786 13799.5n 0.5786 13800.0n 0.5656 14399.5n 0.5656 14400.0n 0.5781 14999.5n 0.5781 15000.0n 0.5633 15599.5n 0.5633 15600.0n 0.5855 16199.5n 0.5855 16200.0n 0.5710 16799.5n 0.5710 16800.0n 0.5954 17399.5n 0.5954 17400.0n 0.5763 17999.5n 0.5763 18000.0n 0.6035 18599.5n 0.6035 18600.0n 0.5194 19199.5n 0.5194 19200.0n 0.5507 19799.5n 0.5507 19800.0n 0.5070 20399.5n 0.5070 20400.0n 0.5693 20999.5n 0.5693 21000.0n 0.6341 21599.5n 0.6341 21600.0n 0.5113 22199.5n 0.5113 22200.0n 0.5129 22799.5n 0.5129 22800.0n 0.5710 23399.5n 0.5710 23400.0n 0.5571 23999.5n 0.5571 24000.0n 0.5080 24599.5n 0.5080 24600.0n 0.5146 25199.5n 0.5146 25200.0n 0.5874 25799.5n 0.5874 25800.0n 0.6247 26399.5n 0.6247 26400.0n 0.5907 26999.5n 0.5907 27000.0n 0.6010 27599.5n 0.6010 27600.0n 0.5886 28199.5n 0.5886 28200.0n 0.5376 28799.5n 0.5376 28800.0n 0.5722 29399.5n 0.5722 29400.0n 0.6350 29999.5n 0.6350 30000.0n 0.6375 30599.5n 0.6375 30600.0n 0.6427 31199.5n 0.6427 31200.0n 0.6111 31799.5n 0.6111 31800.0n 0.6266 32399.5n 0.6266 32400.0n 0.6238 32999.5n 0.6238 33000.0n 0.5350 33599.5n 0.5350 33600.0n 0.5532 34199.5n 0.5532 34200.0n 0.5202 34799.5n 0.5202 34800.0n 0.6414 35399.5n 0.6414 35400.0n 0.5530 35999.5n 0.5530)
Vyp_who_22_0 yp_who_22_0 0 PWL(0.0n 0.5031 599.5n 0.5031 600.0n 0.5023 1199.5n 0.5023 1200.0n 0.5052 1799.5n 0.5052 1800.0n 0.5048 2399.5n 0.5048 2400.0n 0.5043 2999.5n 0.5043 3000.0n 0.5034 3599.5n 0.5034 3600.0n 0.5048 4199.5n 0.5048 4200.0n 0.5031 4799.5n 0.5031 4800.0n 0.5040 5399.5n 0.5040 5400.0n 0.5040 5999.5n 0.5040 6000.0n 0.5054 6599.5n 0.5054 6600.0n 0.5040 7199.5n 0.5040 7200.0n 0.5027 7799.5n 0.5027 7800.0n 0.5027 8399.5n 0.5027 8400.0n 0.5038 8999.5n 0.5038 9000.0n 0.5040 9599.5n 0.5040 9600.0n 0.5039 10199.5n 0.5039 10200.0n 0.5033 10799.5n 0.5033 10800.0n 0.5056 11399.5n 0.5056 11400.0n 0.5040 11999.5n 0.5040 12000.0n 0.5036 12599.5n 0.5036 12600.0n 0.5039 13199.5n 0.5039 13200.0n 0.5029 13799.5n 0.5029 13800.0n 0.5025 14399.5n 0.5025 14400.0n 0.5038 14999.5n 0.5038 15000.0n 0.5041 15599.5n 0.5041 15600.0n 0.5036 16199.5n 0.5036 16200.0n 0.5025 16799.5n 0.5025 16800.0n 0.5040 17399.5n 0.5040 17400.0n 0.5029 17999.5n 0.5029 18000.0n 0.5057 18599.5n 0.5057 18600.0n 0.5010 19199.5n 0.5010 19200.0n 0.5041 19799.5n 0.5041 19800.0n 0.5021 20399.5n 0.5021 20400.0n 0.5044 20999.5n 0.5044 21000.0n 0.5056 21599.5n 0.5056 21600.0n 0.5016 22199.5n 0.5016 22200.0n 0.5006 22799.5n 0.5006 22800.0n 0.5041 23399.5n 0.5041 23400.0n 0.5027 23999.5n 0.5027 24000.0n 0.5029 24599.5n 0.5029 24600.0n 0.5006 25199.5n 0.5006 25200.0n 0.5047 25799.5n 0.5047 25800.0n 0.5046 26399.5n 0.5046 26400.0n 0.5039 26999.5n 0.5039 27000.0n 0.5049 27599.5n 0.5049 27600.0n 0.5039 28199.5n 0.5039 28200.0n 0.5017 28799.5n 0.5017 28800.0n 0.5042 29399.5n 0.5042 29400.0n 0.5056 29999.5n 0.5056 30000.0n 0.5051 30599.5n 0.5051 30600.0n 0.5039 31199.5n 0.5039 31200.0n 0.5033 31799.5n 0.5033 31800.0n 0.5049 32399.5n 0.5049 32400.0n 0.5045 32999.5n 0.5045 33000.0n 0.5036 33599.5n 0.5036 33600.0n 0.5042 34199.5n 0.5042 34200.0n 0.5012 34799.5n 0.5012 34800.0n 0.5036 35399.5n 0.5036 35400.0n 0.5042 35999.5n 0.5042)
Vyn_who_22_0 yn_who_22_0 0 PWL(0.0n 0.4969 599.5n 0.4969 600.0n 0.4977 1199.5n 0.4977 1200.0n 0.4948 1799.5n 0.4948 1800.0n 0.4952 2399.5n 0.4952 2400.0n 0.4957 2999.5n 0.4957 3000.0n 0.4966 3599.5n 0.4966 3600.0n 0.4952 4199.5n 0.4952 4200.0n 0.4969 4799.5n 0.4969 4800.0n 0.4960 5399.5n 0.4960 5400.0n 0.4960 5999.5n 0.4960 6000.0n 0.4946 6599.5n 0.4946 6600.0n 0.4960 7199.5n 0.4960 7200.0n 0.4973 7799.5n 0.4973 7800.0n 0.4973 8399.5n 0.4973 8400.0n 0.4962 8999.5n 0.4962 9000.0n 0.4960 9599.5n 0.4960 9600.0n 0.4961 10199.5n 0.4961 10200.0n 0.4967 10799.5n 0.4967 10800.0n 0.4944 11399.5n 0.4944 11400.0n 0.4960 11999.5n 0.4960 12000.0n 0.4964 12599.5n 0.4964 12600.0n 0.4961 13199.5n 0.4961 13200.0n 0.4971 13799.5n 0.4971 13800.0n 0.4975 14399.5n 0.4975 14400.0n 0.4962 14999.5n 0.4962 15000.0n 0.4959 15599.5n 0.4959 15600.0n 0.4964 16199.5n 0.4964 16200.0n 0.4975 16799.5n 0.4975 16800.0n 0.4960 17399.5n 0.4960 17400.0n 0.4971 17999.5n 0.4971 18000.0n 0.4943 18599.5n 0.4943 18600.0n 0.4990 19199.5n 0.4990 19200.0n 0.4959 19799.5n 0.4959 19800.0n 0.4979 20399.5n 0.4979 20400.0n 0.4956 20999.5n 0.4956 21000.0n 0.4944 21599.5n 0.4944 21600.0n 0.4984 22199.5n 0.4984 22200.0n 0.4994 22799.5n 0.4994 22800.0n 0.4959 23399.5n 0.4959 23400.0n 0.4973 23999.5n 0.4973 24000.0n 0.4971 24599.5n 0.4971 24600.0n 0.4994 25199.5n 0.4994 25200.0n 0.4953 25799.5n 0.4953 25800.0n 0.4954 26399.5n 0.4954 26400.0n 0.4961 26999.5n 0.4961 27000.0n 0.4951 27599.5n 0.4951 27600.0n 0.4961 28199.5n 0.4961 28200.0n 0.4983 28799.5n 0.4983 28800.0n 0.4958 29399.5n 0.4958 29400.0n 0.4944 29999.5n 0.4944 30000.0n 0.4949 30599.5n 0.4949 30600.0n 0.4961 31199.5n 0.4961 31200.0n 0.4967 31799.5n 0.4967 31800.0n 0.4951 32399.5n 0.4951 32400.0n 0.4955 32999.5n 0.4955 33000.0n 0.4964 33599.5n 0.4964 33600.0n 0.4958 34199.5n 0.4958 34200.0n 0.4988 34799.5n 0.4988 34800.0n 0.4964 35399.5n 0.4964 35400.0n 0.4958 35999.5n 0.4958)
Cwp_who_22_0 wp_who_22_0 0 400p
Cwn_who_22_0 wn_who_22_0 0 400p
Xu_who_22_0 xp_who_22_0 xn_who_22_0 yp_who_22_0 yn_who_22_0 wp_who_22_0 wn_who_22_0 vdd gbn gprod
Vxp_who_22_1 xp_who_22_1 0 PWL(0.0n 0.4181 599.5n 0.4181 600.0n 0.4485 1199.5n 0.4485 1200.0n 0.4136 1799.5n 0.4136 1800.0n 0.4372 2399.5n 0.4372 2400.0n 0.4407 2999.5n 0.4407 3000.0n 0.4287 3599.5n 0.4287 3600.0n 0.4122 4199.5n 0.4122 4200.0n 0.4153 4799.5n 0.4153 4800.0n 0.4217 5399.5n 0.4217 5400.0n 0.4223 5999.5n 0.4223 6000.0n 0.4162 6599.5n 0.4162 6600.0n 0.4175 7199.5n 0.4175 7200.0n 0.4455 7799.5n 0.4455 7800.0n 0.4473 8399.5n 0.4473 8400.0n 0.4067 8999.5n 0.4067 9000.0n 0.4221 9599.5n 0.4221 9600.0n 0.4284 10199.5n 0.4284 10200.0n 0.4398 10799.5n 0.4398 10800.0n 0.4079 11399.5n 0.4079 11400.0n 0.4206 11999.5n 0.4206 12000.0n 0.4022 12599.5n 0.4022 12600.0n 0.4297 13199.5n 0.4297 13200.0n 0.4214 13799.5n 0.4214 13800.0n 0.4344 14399.5n 0.4344 14400.0n 0.4219 14999.5n 0.4219 15000.0n 0.4367 15599.5n 0.4367 15600.0n 0.4145 16199.5n 0.4145 16200.0n 0.4290 16799.5n 0.4290 16800.0n 0.4046 17399.5n 0.4046 17400.0n 0.4237 17999.5n 0.4237 18000.0n 0.3965 18599.5n 0.3965 18600.0n 0.4806 19199.5n 0.4806 19200.0n 0.4493 19799.5n 0.4493 19800.0n 0.4930 20399.5n 0.4930 20400.0n 0.4307 20999.5n 0.4307 21000.0n 0.3659 21599.5n 0.3659 21600.0n 0.4887 22199.5n 0.4887 22200.0n 0.4871 22799.5n 0.4871 22800.0n 0.4290 23399.5n 0.4290 23400.0n 0.4429 23999.5n 0.4429 24000.0n 0.4920 24599.5n 0.4920 24600.0n 0.4854 25199.5n 0.4854 25200.0n 0.4126 25799.5n 0.4126 25800.0n 0.3753 26399.5n 0.3753 26400.0n 0.4093 26999.5n 0.4093 27000.0n 0.3990 27599.5n 0.3990 27600.0n 0.4114 28199.5n 0.4114 28200.0n 0.4624 28799.5n 0.4624 28800.0n 0.4278 29399.5n 0.4278 29400.0n 0.3650 29999.5n 0.3650 30000.0n 0.3625 30599.5n 0.3625 30600.0n 0.3573 31199.5n 0.3573 31200.0n 0.3889 31799.5n 0.3889 31800.0n 0.3734 32399.5n 0.3734 32400.0n 0.3762 32999.5n 0.3762 33000.0n 0.4650 33599.5n 0.4650 33600.0n 0.4468 34199.5n 0.4468 34200.0n 0.4798 34799.5n 0.4798 34800.0n 0.3586 35399.5n 0.3586 35400.0n 0.4470 35999.5n 0.4470)
Vxn_who_22_1 xn_who_22_1 0 PWL(0.0n 0.5819 599.5n 0.5819 600.0n 0.5515 1199.5n 0.5515 1200.0n 0.5864 1799.5n 0.5864 1800.0n 0.5628 2399.5n 0.5628 2400.0n 0.5593 2999.5n 0.5593 3000.0n 0.5713 3599.5n 0.5713 3600.0n 0.5878 4199.5n 0.5878 4200.0n 0.5847 4799.5n 0.5847 4800.0n 0.5783 5399.5n 0.5783 5400.0n 0.5777 5999.5n 0.5777 6000.0n 0.5838 6599.5n 0.5838 6600.0n 0.5825 7199.5n 0.5825 7200.0n 0.5545 7799.5n 0.5545 7800.0n 0.5527 8399.5n 0.5527 8400.0n 0.5933 8999.5n 0.5933 9000.0n 0.5779 9599.5n 0.5779 9600.0n 0.5716 10199.5n 0.5716 10200.0n 0.5602 10799.5n 0.5602 10800.0n 0.5921 11399.5n 0.5921 11400.0n 0.5794 11999.5n 0.5794 12000.0n 0.5978 12599.5n 0.5978 12600.0n 0.5703 13199.5n 0.5703 13200.0n 0.5786 13799.5n 0.5786 13800.0n 0.5656 14399.5n 0.5656 14400.0n 0.5781 14999.5n 0.5781 15000.0n 0.5633 15599.5n 0.5633 15600.0n 0.5855 16199.5n 0.5855 16200.0n 0.5710 16799.5n 0.5710 16800.0n 0.5954 17399.5n 0.5954 17400.0n 0.5763 17999.5n 0.5763 18000.0n 0.6035 18599.5n 0.6035 18600.0n 0.5194 19199.5n 0.5194 19200.0n 0.5507 19799.5n 0.5507 19800.0n 0.5070 20399.5n 0.5070 20400.0n 0.5693 20999.5n 0.5693 21000.0n 0.6341 21599.5n 0.6341 21600.0n 0.5113 22199.5n 0.5113 22200.0n 0.5129 22799.5n 0.5129 22800.0n 0.5710 23399.5n 0.5710 23400.0n 0.5571 23999.5n 0.5571 24000.0n 0.5080 24599.5n 0.5080 24600.0n 0.5146 25199.5n 0.5146 25200.0n 0.5874 25799.5n 0.5874 25800.0n 0.6247 26399.5n 0.6247 26400.0n 0.5907 26999.5n 0.5907 27000.0n 0.6010 27599.5n 0.6010 27600.0n 0.5886 28199.5n 0.5886 28200.0n 0.5376 28799.5n 0.5376 28800.0n 0.5722 29399.5n 0.5722 29400.0n 0.6350 29999.5n 0.6350 30000.0n 0.6375 30599.5n 0.6375 30600.0n 0.6427 31199.5n 0.6427 31200.0n 0.6111 31799.5n 0.6111 31800.0n 0.6266 32399.5n 0.6266 32400.0n 0.6238 32999.5n 0.6238 33000.0n 0.5350 33599.5n 0.5350 33600.0n 0.5532 34199.5n 0.5532 34200.0n 0.5202 34799.5n 0.5202 34800.0n 0.6414 35399.5n 0.6414 35400.0n 0.5530 35999.5n 0.5530)
Vyp_who_22_1 yp_who_22_1 0 PWL(0.0n 0.5071 599.5n 0.5071 600.0n 0.5053 1199.5n 0.5053 1200.0n 0.5052 1799.5n 0.5052 1800.0n 0.5027 2399.5n 0.5027 2400.0n 0.5034 2999.5n 0.5034 3000.0n 0.5055 3599.5n 0.5055 3600.0n 0.5056 4199.5n 0.5056 4200.0n 0.5071 4799.5n 0.5071 4800.0n 0.5056 5399.5n 0.5056 5400.0n 0.5056 5999.5n 0.5056 6000.0n 0.5048 6599.5n 0.5048 6600.0n 0.5060 7199.5n 0.5060 7200.0n 0.5048 7799.5n 0.5048 7800.0n 0.5046 8399.5n 0.5046 8400.0n 0.5066 8999.5n 0.5066 9000.0n 0.5056 9599.5n 0.5056 9600.0n 0.5051 10199.5n 0.5051 10200.0n 0.5046 10799.5n 0.5046 10800.0n 0.5056 11399.5n 0.5056 11400.0n 0.5058 11999.5n 0.5058 12000.0n 0.5068 12599.5n 0.5068 12600.0n 0.5050 13199.5n 0.5050 13200.0n 0.5071 13799.5n 0.5071 13800.0n 0.5059 14399.5n 0.5059 14400.0n 0.5058 14999.5n 0.5058 15000.0n 0.5043 15599.5n 0.5043 15600.0n 0.5067 16199.5n 0.5067 16200.0n 0.5068 16799.5n 0.5068 16800.0n 0.5066 17399.5n 0.5066 17400.0n 0.5069 17999.5n 0.5069 18000.0n 0.5061 18599.5n 0.5061 18600.0n 0.5034 19199.5n 0.5034 19200.0n 0.5010 19799.5n 0.5010 19800.0n 0.4989 20399.5n 0.4989 20400.0n 0.5022 20999.5n 0.5022 21000.0n 0.5086 21599.5n 0.5086 21600.0n 0.5007 22199.5n 0.5007 22200.0n 0.5023 22799.5n 0.5023 22800.0n 0.5021 23399.5n 0.5021 23400.0n 0.5077 23999.5n 0.5077 24000.0n 0.4979 24599.5n 0.4979 24600.0n 0.5035 25199.5n 0.5035 25200.0n 0.5041 25799.5n 0.5041 25800.0n 0.5075 26399.5n 0.5075 26400.0n 0.5041 26999.5n 0.5041 27000.0n 0.5056 27599.5n 0.5056 27600.0n 0.5039 28199.5n 0.5039 28200.0n 0.5059 28799.5n 0.5059 28800.0n 0.5023 29399.5n 0.5023 29400.0n 0.5086 29999.5n 0.5086 30000.0n 0.5084 30599.5n 0.5084 30600.0n 0.5085 31199.5n 0.5085 31200.0n 0.5088 31799.5n 0.5088 31800.0n 0.5078 32399.5n 0.5078 32400.0n 0.5074 32999.5n 0.5074 33000.0n 0.4996 33599.5n 0.4996 33600.0n 0.5010 34199.5n 0.5010 34200.0n 0.5044 34799.5n 0.5044 34800.0n 0.5084 35399.5n 0.5084 35400.0n 0.5012 35999.5n 0.5012)
Vyn_who_22_1 yn_who_22_1 0 PWL(0.0n 0.4929 599.5n 0.4929 600.0n 0.4947 1199.5n 0.4947 1200.0n 0.4948 1799.5n 0.4948 1800.0n 0.4973 2399.5n 0.4973 2400.0n 0.4966 2999.5n 0.4966 3000.0n 0.4945 3599.5n 0.4945 3600.0n 0.4944 4199.5n 0.4944 4200.0n 0.4929 4799.5n 0.4929 4800.0n 0.4944 5399.5n 0.4944 5400.0n 0.4944 5999.5n 0.4944 6000.0n 0.4952 6599.5n 0.4952 6600.0n 0.4940 7199.5n 0.4940 7200.0n 0.4952 7799.5n 0.4952 7800.0n 0.4954 8399.5n 0.4954 8400.0n 0.4934 8999.5n 0.4934 9000.0n 0.4944 9599.5n 0.4944 9600.0n 0.4949 10199.5n 0.4949 10200.0n 0.4954 10799.5n 0.4954 10800.0n 0.4944 11399.5n 0.4944 11400.0n 0.4942 11999.5n 0.4942 12000.0n 0.4932 12599.5n 0.4932 12600.0n 0.4950 13199.5n 0.4950 13200.0n 0.4929 13799.5n 0.4929 13800.0n 0.4941 14399.5n 0.4941 14400.0n 0.4942 14999.5n 0.4942 15000.0n 0.4957 15599.5n 0.4957 15600.0n 0.4933 16199.5n 0.4933 16200.0n 0.4932 16799.5n 0.4932 16800.0n 0.4934 17399.5n 0.4934 17400.0n 0.4931 17999.5n 0.4931 18000.0n 0.4939 18599.5n 0.4939 18600.0n 0.4966 19199.5n 0.4966 19200.0n 0.4990 19799.5n 0.4990 19800.0n 0.5011 20399.5n 0.5011 20400.0n 0.4978 20999.5n 0.4978 21000.0n 0.4914 21599.5n 0.4914 21600.0n 0.4993 22199.5n 0.4993 22200.0n 0.4977 22799.5n 0.4977 22800.0n 0.4979 23399.5n 0.4979 23400.0n 0.4923 23999.5n 0.4923 24000.0n 0.5021 24599.5n 0.5021 24600.0n 0.4965 25199.5n 0.4965 25200.0n 0.4959 25799.5n 0.4959 25800.0n 0.4925 26399.5n 0.4925 26400.0n 0.4959 26999.5n 0.4959 27000.0n 0.4944 27599.5n 0.4944 27600.0n 0.4961 28199.5n 0.4961 28200.0n 0.4941 28799.5n 0.4941 28800.0n 0.4977 29399.5n 0.4977 29400.0n 0.4914 29999.5n 0.4914 30000.0n 0.4916 30599.5n 0.4916 30600.0n 0.4915 31199.5n 0.4915 31200.0n 0.4912 31799.5n 0.4912 31800.0n 0.4922 32399.5n 0.4922 32400.0n 0.4926 32999.5n 0.4926 33000.0n 0.5004 33599.5n 0.5004 33600.0n 0.4990 34199.5n 0.4990 34200.0n 0.4956 34799.5n 0.4956 34800.0n 0.4916 35399.5n 0.4916 35400.0n 0.4988 35999.5n 0.4988)
Cwp_who_22_1 wp_who_22_1 0 400p
Cwn_who_22_1 wn_who_22_1 0 400p
Xu_who_22_1 xp_who_22_1 xn_who_22_1 yp_who_22_1 yn_who_22_1 wp_who_22_1 wn_who_22_1 vdd gbn gprod
Vxp_bh_22 xp_bh_22 0 PWL(0.0n 0.7100 599.5n 0.7100 600.0n 0.7100 1199.5n 0.7100 1200.0n 0.7100 1799.5n 0.7100 1800.0n 0.7100 2399.5n 0.7100 2400.0n 0.7100 2999.5n 0.7100 3000.0n 0.7100 3599.5n 0.7100 3600.0n 0.7100 4199.5n 0.7100 4200.0n 0.7100 4799.5n 0.7100 4800.0n 0.7100 5399.5n 0.7100 5400.0n 0.7100 5999.5n 0.7100 6000.0n 0.7100 6599.5n 0.7100 6600.0n 0.7100 7199.5n 0.7100 7200.0n 0.7100 7799.5n 0.7100 7800.0n 0.7100 8399.5n 0.7100 8400.0n 0.7100 8999.5n 0.7100 9000.0n 0.7100 9599.5n 0.7100 9600.0n 0.7100 10199.5n 0.7100 10200.0n 0.7100 10799.5n 0.7100 10800.0n 0.7100 11399.5n 0.7100 11400.0n 0.7100 11999.5n 0.7100 12000.0n 0.7100 12599.5n 0.7100 12600.0n 0.7100 13199.5n 0.7100 13200.0n 0.7100 13799.5n 0.7100 13800.0n 0.7100 14399.5n 0.7100 14400.0n 0.7100 14999.5n 0.7100 15000.0n 0.7100 15599.5n 0.7100 15600.0n 0.7100 16199.5n 0.7100 16200.0n 0.7100 16799.5n 0.7100 16800.0n 0.7100 17399.5n 0.7100 17400.0n 0.7100 17999.5n 0.7100 18000.0n 0.7100 18599.5n 0.7100 18600.0n 0.7100 19199.5n 0.7100 19200.0n 0.7100 19799.5n 0.7100 19800.0n 0.7100 20399.5n 0.7100 20400.0n 0.7100 20999.5n 0.7100 21000.0n 0.7100 21599.5n 0.7100 21600.0n 0.7100 22199.5n 0.7100 22200.0n 0.7100 22799.5n 0.7100 22800.0n 0.7100 23399.5n 0.7100 23400.0n 0.7100 23999.5n 0.7100 24000.0n 0.7100 24599.5n 0.7100 24600.0n 0.7100 25199.5n 0.7100 25200.0n 0.7100 25799.5n 0.7100 25800.0n 0.7100 26399.5n 0.7100 26400.0n 0.7100 26999.5n 0.7100 27000.0n 0.7100 27599.5n 0.7100 27600.0n 0.7100 28199.5n 0.7100 28200.0n 0.7100 28799.5n 0.7100 28800.0n 0.7100 29399.5n 0.7100 29400.0n 0.7100 29999.5n 0.7100 30000.0n 0.7100 30599.5n 0.7100 30600.0n 0.7100 31199.5n 0.7100 31200.0n 0.7100 31799.5n 0.7100 31800.0n 0.7100 32399.5n 0.7100 32400.0n 0.7100 32999.5n 0.7100 33000.0n 0.7100 33599.5n 0.7100 33600.0n 0.7100 34199.5n 0.7100 34200.0n 0.7100 34799.5n 0.7100 34800.0n 0.7100 35399.5n 0.7100 35400.0n 0.7100 35999.5n 0.7100)
Vxn_bh_22 xn_bh_22 0 PWL(0.0n 0.2900 599.5n 0.2900 600.0n 0.2900 1199.5n 0.2900 1200.0n 0.2900 1799.5n 0.2900 1800.0n 0.2900 2399.5n 0.2900 2400.0n 0.2900 2999.5n 0.2900 3000.0n 0.2900 3599.5n 0.2900 3600.0n 0.2900 4199.5n 0.2900 4200.0n 0.2900 4799.5n 0.2900 4800.0n 0.2900 5399.5n 0.2900 5400.0n 0.2900 5999.5n 0.2900 6000.0n 0.2900 6599.5n 0.2900 6600.0n 0.2900 7199.5n 0.2900 7200.0n 0.2900 7799.5n 0.2900 7800.0n 0.2900 8399.5n 0.2900 8400.0n 0.2900 8999.5n 0.2900 9000.0n 0.2900 9599.5n 0.2900 9600.0n 0.2900 10199.5n 0.2900 10200.0n 0.2900 10799.5n 0.2900 10800.0n 0.2900 11399.5n 0.2900 11400.0n 0.2900 11999.5n 0.2900 12000.0n 0.2900 12599.5n 0.2900 12600.0n 0.2900 13199.5n 0.2900 13200.0n 0.2900 13799.5n 0.2900 13800.0n 0.2900 14399.5n 0.2900 14400.0n 0.2900 14999.5n 0.2900 15000.0n 0.2900 15599.5n 0.2900 15600.0n 0.2900 16199.5n 0.2900 16200.0n 0.2900 16799.5n 0.2900 16800.0n 0.2900 17399.5n 0.2900 17400.0n 0.2900 17999.5n 0.2900 18000.0n 0.2900 18599.5n 0.2900 18600.0n 0.2900 19199.5n 0.2900 19200.0n 0.2900 19799.5n 0.2900 19800.0n 0.2900 20399.5n 0.2900 20400.0n 0.2900 20999.5n 0.2900 21000.0n 0.2900 21599.5n 0.2900 21600.0n 0.2900 22199.5n 0.2900 22200.0n 0.2900 22799.5n 0.2900 22800.0n 0.2900 23399.5n 0.2900 23400.0n 0.2900 23999.5n 0.2900 24000.0n 0.2900 24599.5n 0.2900 24600.0n 0.2900 25199.5n 0.2900 25200.0n 0.2900 25799.5n 0.2900 25800.0n 0.2900 26399.5n 0.2900 26400.0n 0.2900 26999.5n 0.2900 27000.0n 0.2900 27599.5n 0.2900 27600.0n 0.2900 28199.5n 0.2900 28200.0n 0.2900 28799.5n 0.2900 28800.0n 0.2900 29399.5n 0.2900 29400.0n 0.2900 29999.5n 0.2900 30000.0n 0.2900 30599.5n 0.2900 30600.0n 0.2900 31199.5n 0.2900 31200.0n 0.2900 31799.5n 0.2900 31800.0n 0.2900 32399.5n 0.2900 32400.0n 0.2900 32999.5n 0.2900 33000.0n 0.2900 33599.5n 0.2900 33600.0n 0.2900 34199.5n 0.2900 34200.0n 0.2900 34799.5n 0.2900 34800.0n 0.2900 35399.5n 0.2900 35400.0n 0.2900 35999.5n 0.2900)
Vyp_bh_22 yp_bh_22 0 PWL(0.0n 0.4181 599.5n 0.4181 600.0n 0.4485 1199.5n 0.4485 1200.0n 0.4136 1799.5n 0.4136 1800.0n 0.4372 2399.5n 0.4372 2400.0n 0.4407 2999.5n 0.4407 3000.0n 0.4287 3599.5n 0.4287 3600.0n 0.4122 4199.5n 0.4122 4200.0n 0.4153 4799.5n 0.4153 4800.0n 0.4217 5399.5n 0.4217 5400.0n 0.4223 5999.5n 0.4223 6000.0n 0.4162 6599.5n 0.4162 6600.0n 0.4175 7199.5n 0.4175 7200.0n 0.4455 7799.5n 0.4455 7800.0n 0.4473 8399.5n 0.4473 8400.0n 0.4067 8999.5n 0.4067 9000.0n 0.4221 9599.5n 0.4221 9600.0n 0.4284 10199.5n 0.4284 10200.0n 0.4398 10799.5n 0.4398 10800.0n 0.4079 11399.5n 0.4079 11400.0n 0.4206 11999.5n 0.4206 12000.0n 0.4022 12599.5n 0.4022 12600.0n 0.4297 13199.5n 0.4297 13200.0n 0.4214 13799.5n 0.4214 13800.0n 0.4344 14399.5n 0.4344 14400.0n 0.4219 14999.5n 0.4219 15000.0n 0.4367 15599.5n 0.4367 15600.0n 0.4145 16199.5n 0.4145 16200.0n 0.4290 16799.5n 0.4290 16800.0n 0.4046 17399.5n 0.4046 17400.0n 0.4237 17999.5n 0.4237 18000.0n 0.3965 18599.5n 0.3965 18600.0n 0.4806 19199.5n 0.4806 19200.0n 0.4493 19799.5n 0.4493 19800.0n 0.4930 20399.5n 0.4930 20400.0n 0.4307 20999.5n 0.4307 21000.0n 0.3659 21599.5n 0.3659 21600.0n 0.4887 22199.5n 0.4887 22200.0n 0.4871 22799.5n 0.4871 22800.0n 0.4290 23399.5n 0.4290 23400.0n 0.4429 23999.5n 0.4429 24000.0n 0.4920 24599.5n 0.4920 24600.0n 0.4854 25199.5n 0.4854 25200.0n 0.4126 25799.5n 0.4126 25800.0n 0.3753 26399.5n 0.3753 26400.0n 0.4093 26999.5n 0.4093 27000.0n 0.3990 27599.5n 0.3990 27600.0n 0.4114 28199.5n 0.4114 28200.0n 0.4624 28799.5n 0.4624 28800.0n 0.4278 29399.5n 0.4278 29400.0n 0.3650 29999.5n 0.3650 30000.0n 0.3625 30599.5n 0.3625 30600.0n 0.3573 31199.5n 0.3573 31200.0n 0.3889 31799.5n 0.3889 31800.0n 0.3734 32399.5n 0.3734 32400.0n 0.3762 32999.5n 0.3762 33000.0n 0.4650 33599.5n 0.4650 33600.0n 0.4468 34199.5n 0.4468 34200.0n 0.4798 34799.5n 0.4798 34800.0n 0.3586 35399.5n 0.3586 35400.0n 0.4470 35999.5n 0.4470)
Vyn_bh_22 yn_bh_22 0 PWL(0.0n 0.5819 599.5n 0.5819 600.0n 0.5515 1199.5n 0.5515 1200.0n 0.5864 1799.5n 0.5864 1800.0n 0.5628 2399.5n 0.5628 2400.0n 0.5593 2999.5n 0.5593 3000.0n 0.5713 3599.5n 0.5713 3600.0n 0.5878 4199.5n 0.5878 4200.0n 0.5847 4799.5n 0.5847 4800.0n 0.5783 5399.5n 0.5783 5400.0n 0.5777 5999.5n 0.5777 6000.0n 0.5838 6599.5n 0.5838 6600.0n 0.5825 7199.5n 0.5825 7200.0n 0.5545 7799.5n 0.5545 7800.0n 0.5527 8399.5n 0.5527 8400.0n 0.5933 8999.5n 0.5933 9000.0n 0.5779 9599.5n 0.5779 9600.0n 0.5716 10199.5n 0.5716 10200.0n 0.5602 10799.5n 0.5602 10800.0n 0.5921 11399.5n 0.5921 11400.0n 0.5794 11999.5n 0.5794 12000.0n 0.5978 12599.5n 0.5978 12600.0n 0.5703 13199.5n 0.5703 13200.0n 0.5786 13799.5n 0.5786 13800.0n 0.5656 14399.5n 0.5656 14400.0n 0.5781 14999.5n 0.5781 15000.0n 0.5633 15599.5n 0.5633 15600.0n 0.5855 16199.5n 0.5855 16200.0n 0.5710 16799.5n 0.5710 16800.0n 0.5954 17399.5n 0.5954 17400.0n 0.5763 17999.5n 0.5763 18000.0n 0.6035 18599.5n 0.6035 18600.0n 0.5194 19199.5n 0.5194 19200.0n 0.5507 19799.5n 0.5507 19800.0n 0.5070 20399.5n 0.5070 20400.0n 0.5693 20999.5n 0.5693 21000.0n 0.6341 21599.5n 0.6341 21600.0n 0.5113 22199.5n 0.5113 22200.0n 0.5129 22799.5n 0.5129 22800.0n 0.5710 23399.5n 0.5710 23400.0n 0.5571 23999.5n 0.5571 24000.0n 0.5080 24599.5n 0.5080 24600.0n 0.5146 25199.5n 0.5146 25200.0n 0.5874 25799.5n 0.5874 25800.0n 0.6247 26399.5n 0.6247 26400.0n 0.5907 26999.5n 0.5907 27000.0n 0.6010 27599.5n 0.6010 27600.0n 0.5886 28199.5n 0.5886 28200.0n 0.5376 28799.5n 0.5376 28800.0n 0.5722 29399.5n 0.5722 29400.0n 0.6350 29999.5n 0.6350 30000.0n 0.6375 30599.5n 0.6375 30600.0n 0.6427 31199.5n 0.6427 31200.0n 0.6111 31799.5n 0.6111 31800.0n 0.6266 32399.5n 0.6266 32400.0n 0.6238 32999.5n 0.6238 33000.0n 0.5350 33599.5n 0.5350 33600.0n 0.5532 34199.5n 0.5532 34200.0n 0.5202 34799.5n 0.5202 34800.0n 0.6414 35399.5n 0.6414 35400.0n 0.5530 35999.5n 0.5530)
Cwp_bh_22 wp_bh_22 0 400p
Cwn_bh_22 wn_bh_22 0 400p
Xu_bh_22 xp_bh_22 xn_bh_22 yp_bh_22 yn_bh_22 wp_bh_22 wn_bh_22 vdd gbn gprod
Vxp_wih_0_23 xp_wih_0_23 0 PWL(0.0n 0.4942 599.5n 0.4942 600.0n 0.5558 1199.5n 0.5558 1200.0n 0.4708 1799.5n 0.4708 1800.0n 0.5235 2399.5n 0.5235 2400.0n 0.5350 2999.5n 0.5350 3000.0n 0.5172 3599.5n 0.5172 3600.0n 0.4702 4199.5n 0.4702 4200.0n 0.4867 4799.5n 0.4867 4800.0n 0.4970 5399.5n 0.4970 5400.0n 0.4986 5999.5n 0.4986 6000.0n 0.4751 6599.5n 0.4751 6600.0n 0.4870 7199.5n 0.4870 7200.0n 0.5502 7799.5n 0.5502 7800.0n 0.5521 8399.5n 0.5521 8400.0n 0.4638 8999.5n 0.4638 9000.0n 0.4982 9599.5n 0.4982 9600.0n 0.5131 10199.5n 0.5131 10200.0n 0.5386 10799.5n 0.5386 10800.0n 0.4592 11399.5n 0.4592 11400.0n 0.4950 11999.5n 0.4950 12000.0n 0.4559 12599.5n 0.4559 12600.0n 0.5162 13199.5n 0.5162 13200.0n 0.5038 13799.5n 0.5038 13800.0n 0.5333 14399.5n 0.5333 14400.0n 0.4991 14999.5n 0.4991 15000.0n 0.5298 15599.5n 0.5298 15600.0n 0.4823 16199.5n 0.4823 16200.0n 0.5239 16799.5n 0.5239 16800.0n 0.4592 17399.5n 0.4592 17400.0n 0.5094 17999.5n 0.5094 18000.0n 0.4337 18599.5n 0.4337 18600.0n 0.5977 19199.5n 0.5977 19200.0n 0.5364 19799.5n 0.5364 19800.0n 0.6122 20399.5n 0.6122 20400.0n 0.4856 20999.5n 0.4856 21000.0n 0.3861 21599.5n 0.3861 21600.0n 0.6094 22199.5n 0.6094 22200.0n 0.6364 22799.5n 0.6364 22800.0n 0.4807 23399.5n 0.4807 23400.0n 0.5614 23999.5n 0.5614 24000.0n 0.5913 24599.5n 0.5913 24600.0n 0.6295 25199.5n 0.6295 25200.0n 0.4496 25799.5n 0.4496 25800.0n 0.3792 26399.5n 0.3792 26400.0n 0.4434 26999.5n 0.4434 27000.0n 0.4340 27599.5n 0.4340 27600.0n 0.4461 28199.5n 0.4461 28200.0n 0.5791 28799.5n 0.5791 28800.0n 0.4777 29399.5n 0.4777 29400.0n 0.3878 29999.5n 0.3878 30000.0n 0.3832 30599.5n 0.3832 30600.0n 0.4022 31199.5n 0.4022 31200.0n 0.4482 31799.5n 0.4482 31800.0n 0.3662 32399.5n 0.3662 32400.0n 0.3857 32999.5n 0.3857 33000.0n 0.5584 33599.5n 0.5584 33600.0n 0.5284 34199.5n 0.5284 34200.0n 0.6034 34799.5n 0.6034 34800.0n 0.3469 35399.5n 0.3469 35400.0n 0.5290 35999.5n 0.5290)
Vxn_wih_0_23 xn_wih_0_23 0 PWL(0.0n 0.5058 599.5n 0.5058 600.0n 0.4442 1199.5n 0.4442 1200.0n 0.5292 1799.5n 0.5292 1800.0n 0.4765 2399.5n 0.4765 2400.0n 0.4650 2999.5n 0.4650 3000.0n 0.4828 3599.5n 0.4828 3600.0n 0.5298 4199.5n 0.5298 4200.0n 0.5133 4799.5n 0.5133 4800.0n 0.5030 5399.5n 0.5030 5400.0n 0.5014 5999.5n 0.5014 6000.0n 0.5249 6599.5n 0.5249 6600.0n 0.5130 7199.5n 0.5130 7200.0n 0.4498 7799.5n 0.4498 7800.0n 0.4479 8399.5n 0.4479 8400.0n 0.5362 8999.5n 0.5362 9000.0n 0.5018 9599.5n 0.5018 9600.0n 0.4869 10199.5n 0.4869 10200.0n 0.4614 10799.5n 0.4614 10800.0n 0.5408 11399.5n 0.5408 11400.0n 0.5050 11999.5n 0.5050 12000.0n 0.5441 12599.5n 0.5441 12600.0n 0.4838 13199.5n 0.4838 13200.0n 0.4962 13799.5n 0.4962 13800.0n 0.4667 14399.5n 0.4667 14400.0n 0.5009 14999.5n 0.5009 15000.0n 0.4702 15599.5n 0.4702 15600.0n 0.5177 16199.5n 0.5177 16200.0n 0.4761 16799.5n 0.4761 16800.0n 0.5408 17399.5n 0.5408 17400.0n 0.4906 17999.5n 0.4906 18000.0n 0.5663 18599.5n 0.5663 18600.0n 0.4023 19199.5n 0.4023 19200.0n 0.4636 19799.5n 0.4636 19800.0n 0.3878 20399.5n 0.3878 20400.0n 0.5144 20999.5n 0.5144 21000.0n 0.6139 21599.5n 0.6139 21600.0n 0.3906 22199.5n 0.3906 22200.0n 0.3636 22799.5n 0.3636 22800.0n 0.5193 23399.5n 0.5193 23400.0n 0.4386 23999.5n 0.4386 24000.0n 0.4087 24599.5n 0.4087 24600.0n 0.3705 25199.5n 0.3705 25200.0n 0.5504 25799.5n 0.5504 25800.0n 0.6208 26399.5n 0.6208 26400.0n 0.5566 26999.5n 0.5566 27000.0n 0.5660 27599.5n 0.5660 27600.0n 0.5539 28199.5n 0.5539 28200.0n 0.4209 28799.5n 0.4209 28800.0n 0.5223 29399.5n 0.5223 29400.0n 0.6122 29999.5n 0.6122 30000.0n 0.6168 30599.5n 0.6168 30600.0n 0.5978 31199.5n 0.5978 31200.0n 0.5518 31799.5n 0.5518 31800.0n 0.6338 32399.5n 0.6338 32400.0n 0.6143 32999.5n 0.6143 33000.0n 0.4416 33599.5n 0.4416 33600.0n 0.4716 34199.5n 0.4716 34200.0n 0.3966 34799.5n 0.3966 34800.0n 0.6531 35399.5n 0.6531 35400.0n 0.4710 35999.5n 0.4710)
Vyp_wih_0_23 yp_wih_0_23 0 PWL(0.0n 0.3457 599.5n 0.3457 600.0n 0.3882 1199.5n 0.3882 1200.0n 0.3729 1799.5n 0.3729 1800.0n 0.4496 2399.5n 0.4496 2400.0n 0.4358 2999.5n 0.4358 3000.0n 0.3712 3599.5n 0.3712 3600.0n 0.3592 4199.5n 0.3592 4200.0n 0.3441 4799.5n 0.3441 4800.0n 0.3645 5399.5n 0.3645 5400.0n 0.3660 5999.5n 0.3660 6000.0n 0.3853 6599.5n 0.3853 6600.0n 0.3545 7199.5n 0.3545 7200.0n 0.3976 7799.5n 0.3976 7800.0n 0.4047 8399.5n 0.4047 8400.0n 0.3432 8999.5n 0.3432 9000.0n 0.3651 9599.5n 0.3651 9600.0n 0.3839 10199.5n 0.3839 10200.0n 0.4040 10799.5n 0.4040 10800.0n 0.3626 11399.5n 0.3626 11400.0n 0.3594 11999.5n 0.3594 12000.0n 0.3401 12599.5n 0.3401 12600.0n 0.3879 13199.5n 0.3879 13200.0n 0.3466 13799.5n 0.3466 13800.0n 0.3648 14399.5n 0.3648 14400.0n 0.3593 14999.5n 0.3593 15000.0n 0.4122 15599.5n 0.4122 15600.0n 0.3469 16199.5n 0.3469 16200.0n 0.3505 16799.5n 0.3505 16800.0n 0.3430 17399.5n 0.3430 17400.0n 0.3491 17999.5n 0.3491 18000.0n 0.4227 18599.5n 0.4227 18600.0n 0.4323 19199.5n 0.4323 19200.0n 0.5105 19799.5n 0.5105 19800.0n 0.5452 20399.5n 0.5452 20400.0n 0.4900 20999.5n 0.4900 21000.0n 0.3422 21599.5n 0.3422 21600.0n 0.5020 22199.5n 0.5020 22200.0n 0.4500 22799.5n 0.4500 22800.0n 0.5079 23399.5n 0.5079 23400.0n 0.3307 23999.5n 0.3307 24000.0n 0.5742 24599.5n 0.5742 24600.0n 0.4279 25199.5n 0.4279 25200.0n 0.4593 25799.5n 0.4593 25800.0n 0.4183 26399.5n 0.4183 26400.0n 0.4757 26999.5n 0.4757 27000.0n 0.4398 27599.5n 0.4398 27600.0n 0.4787 28199.5n 0.4787 28200.0n 0.3396 28799.5n 0.3396 28800.0n 0.4950 29399.5n 0.4950 29400.0n 0.3388 29999.5n 0.3388 30000.0n 0.3333 30599.5n 0.3333 30600.0n 0.3146 31199.5n 0.3146 31200.0n 0.3220 31799.5n 0.3220 31800.0n 0.4056 32399.5n 0.4056 32400.0n 0.4225 32999.5n 0.4225 33000.0n 0.5396 33599.5n 0.5396 33600.0n 0.5258 34199.5n 0.5258 34200.0n 0.3998 34799.5n 0.3998 34800.0n 0.3248 35399.5n 0.3248 35400.0n 0.5129 35999.5n 0.5129)
Vyn_wih_0_23 yn_wih_0_23 0 PWL(0.0n 0.6543 599.5n 0.6543 600.0n 0.6118 1199.5n 0.6118 1200.0n 0.6271 1799.5n 0.6271 1800.0n 0.5504 2399.5n 0.5504 2400.0n 0.5642 2999.5n 0.5642 3000.0n 0.6288 3599.5n 0.6288 3600.0n 0.6408 4199.5n 0.6408 4200.0n 0.6559 4799.5n 0.6559 4800.0n 0.6355 5399.5n 0.6355 5400.0n 0.6340 5999.5n 0.6340 6000.0n 0.6147 6599.5n 0.6147 6600.0n 0.6455 7199.5n 0.6455 7200.0n 0.6024 7799.5n 0.6024 7800.0n 0.5953 8399.5n 0.5953 8400.0n 0.6568 8999.5n 0.6568 9000.0n 0.6349 9599.5n 0.6349 9600.0n 0.6161 10199.5n 0.6161 10200.0n 0.5960 10799.5n 0.5960 10800.0n 0.6374 11399.5n 0.6374 11400.0n 0.6406 11999.5n 0.6406 12000.0n 0.6599 12599.5n 0.6599 12600.0n 0.6121 13199.5n 0.6121 13200.0n 0.6534 13799.5n 0.6534 13800.0n 0.6352 14399.5n 0.6352 14400.0n 0.6407 14999.5n 0.6407 15000.0n 0.5878 15599.5n 0.5878 15600.0n 0.6531 16199.5n 0.6531 16200.0n 0.6495 16799.5n 0.6495 16800.0n 0.6570 17399.5n 0.6570 17400.0n 0.6509 17999.5n 0.6509 18000.0n 0.5773 18599.5n 0.5773 18600.0n 0.5677 19199.5n 0.5677 19200.0n 0.4895 19799.5n 0.4895 19800.0n 0.4548 20399.5n 0.4548 20400.0n 0.5100 20999.5n 0.5100 21000.0n 0.6578 21599.5n 0.6578 21600.0n 0.4980 22199.5n 0.4980 22200.0n 0.5500 22799.5n 0.5500 22800.0n 0.4921 23399.5n 0.4921 23400.0n 0.6693 23999.5n 0.6693 24000.0n 0.4258 24599.5n 0.4258 24600.0n 0.5721 25199.5n 0.5721 25200.0n 0.5407 25799.5n 0.5407 25800.0n 0.5817 26399.5n 0.5817 26400.0n 0.5243 26999.5n 0.5243 27000.0n 0.5602 27599.5n 0.5602 27600.0n 0.5213 28199.5n 0.5213 28200.0n 0.6604 28799.5n 0.6604 28800.0n 0.5050 29399.5n 0.5050 29400.0n 0.6612 29999.5n 0.6612 30000.0n 0.6667 30599.5n 0.6667 30600.0n 0.6854 31199.5n 0.6854 31200.0n 0.6780 31799.5n 0.6780 31800.0n 0.5944 32399.5n 0.5944 32400.0n 0.5775 32999.5n 0.5775 33000.0n 0.4604 33599.5n 0.4604 33600.0n 0.4742 34199.5n 0.4742 34200.0n 0.6002 34799.5n 0.6002 34800.0n 0.6752 35399.5n 0.6752 35400.0n 0.4871 35999.5n 0.4871)
Cwp_wih_0_23 wp_wih_0_23 0 400p
Cwn_wih_0_23 wn_wih_0_23 0 400p
Xu_wih_0_23 xp_wih_0_23 xn_wih_0_23 yp_wih_0_23 yn_wih_0_23 wp_wih_0_23 wn_wih_0_23 vdd gbn gprod
Vxp_wih_1_23 xp_wih_1_23 0 PWL(0.0n 0.5370 599.5n 0.5370 600.0n 0.5167 1199.5n 0.5167 1200.0n 0.4793 1799.5n 0.4793 1800.0n 0.4441 2399.5n 0.4441 2400.0n 0.4555 2999.5n 0.4555 3000.0n 0.5055 3599.5n 0.5055 3600.0n 0.4939 4199.5n 0.4939 4200.0n 0.5385 4799.5n 0.5385 4800.0n 0.5024 5399.5n 0.5024 5400.0n 0.5015 5999.5n 0.5015 6000.0n 0.4700 6599.5n 0.4700 6600.0n 0.5120 7199.5n 0.5120 7200.0n 0.5006 7799.5n 0.5006 7800.0n 0.4950 8399.5n 0.4950 8400.0n 0.5309 8999.5n 0.5309 9000.0n 0.5023 9599.5n 0.5023 9600.0n 0.4893 10199.5n 0.4893 10200.0n 0.4837 10799.5n 0.4837 10800.0n 0.4823 11399.5n 0.4823 11400.0n 0.5074 11999.5n 0.5074 12000.0n 0.5364 12599.5n 0.5364 12600.0n 0.4868 13199.5n 0.4868 13200.0n 0.5380 13799.5n 0.5380 13800.0n 0.5220 14399.5n 0.5220 14400.0n 0.5095 14999.5n 0.5095 15000.0n 0.4705 15599.5n 0.4705 15600.0n 0.5289 16199.5n 0.5289 16200.0n 0.5368 16799.5n 0.5368 16800.0n 0.5287 17399.5n 0.5287 17400.0n 0.5342 17999.5n 0.5342 18000.0n 0.4253 18599.5n 0.4253 18600.0n 0.5119 19199.5n 0.5119 19200.0n 0.4104 19799.5n 0.4104 19800.0n 0.4314 20399.5n 0.4314 20400.0n 0.4005 20999.5n 0.4005 21000.0n 0.4696 21599.5n 0.4696 21600.0n 0.4531 22199.5n 0.4531 22200.0n 0.5039 22799.5n 0.5039 22800.0n 0.3608 23399.5n 0.3608 23400.0n 0.6273 23999.5n 0.6273 24000.0n 0.3928 24599.5n 0.3928 24600.0n 0.5253 25199.5n 0.5253 25200.0n 0.4107 25799.5n 0.4107 25800.0n 0.3947 26399.5n 0.3947 26400.0n 0.3716 26999.5n 0.3716 27000.0n 0.4111 27599.5n 0.4111 27600.0n 0.3715 28199.5n 0.3715 28200.0n 0.5939 28799.5n 0.5939 28800.0n 0.3849 29399.5n 0.3849 29400.0n 0.4835 29999.5n 0.4835 30000.0n 0.5119 30599.5n 0.5119 30600.0n 0.6226 31199.5n 0.6226 31200.0n 0.6064 31799.5n 0.6064 31800.0n 0.4115 32399.5n 0.4115 32400.0n 0.3900 32999.5n 0.3900 33000.0n 0.3958 33599.5n 0.3958 33600.0n 0.3747 34199.5n 0.3747 34200.0n 0.5423 34799.5n 0.5423 34800.0n 0.5509 35399.5n 0.5509 35400.0n 0.3990 35999.5n 0.3990)
Vxn_wih_1_23 xn_wih_1_23 0 PWL(0.0n 0.4630 599.5n 0.4630 600.0n 0.4833 1199.5n 0.4833 1200.0n 0.5207 1799.5n 0.5207 1800.0n 0.5559 2399.5n 0.5559 2400.0n 0.5445 2999.5n 0.5445 3000.0n 0.4945 3599.5n 0.4945 3600.0n 0.5061 4199.5n 0.5061 4200.0n 0.4615 4799.5n 0.4615 4800.0n 0.4976 5399.5n 0.4976 5400.0n 0.4985 5999.5n 0.4985 6000.0n 0.5300 6599.5n 0.5300 6600.0n 0.4880 7199.5n 0.4880 7200.0n 0.4994 7799.5n 0.4994 7800.0n 0.5050 8399.5n 0.5050 8400.0n 0.4691 8999.5n 0.4691 9000.0n 0.4977 9599.5n 0.4977 9600.0n 0.5107 10199.5n 0.5107 10200.0n 0.5163 10799.5n 0.5163 10800.0n 0.5177 11399.5n 0.5177 11400.0n 0.4926 11999.5n 0.4926 12000.0n 0.4636 12599.5n 0.4636 12600.0n 0.5132 13199.5n 0.5132 13200.0n 0.4620 13799.5n 0.4620 13800.0n 0.4780 14399.5n 0.4780 14400.0n 0.4905 14999.5n 0.4905 15000.0n 0.5295 15599.5n 0.5295 15600.0n 0.4711 16199.5n 0.4711 16200.0n 0.4632 16799.5n 0.4632 16800.0n 0.4713 17399.5n 0.4713 17400.0n 0.4658 17999.5n 0.4658 18000.0n 0.5747 18599.5n 0.5747 18600.0n 0.4881 19199.5n 0.4881 19200.0n 0.5896 19799.5n 0.5896 19800.0n 0.5686 20399.5n 0.5686 20400.0n 0.5995 20999.5n 0.5995 21000.0n 0.5304 21599.5n 0.5304 21600.0n 0.5469 22199.5n 0.5469 22200.0n 0.4961 22799.5n 0.4961 22800.0n 0.6392 23399.5n 0.6392 23400.0n 0.3727 23999.5n 0.3727 24000.0n 0.6072 24599.5n 0.6072 24600.0n 0.4747 25199.5n 0.4747 25200.0n 0.5893 25799.5n 0.5893 25800.0n 0.6053 26399.5n 0.6053 26400.0n 0.6284 26999.5n 0.6284 27000.0n 0.5889 27599.5n 0.5889 27600.0n 0.6285 28199.5n 0.6285 28200.0n 0.4061 28799.5n 0.4061 28800.0n 0.6151 29399.5n 0.6151 29400.0n 0.5165 29999.5n 0.5165 30000.0n 0.4881 30599.5n 0.4881 30600.0n 0.3774 31199.5n 0.3774 31200.0n 0.3936 31799.5n 0.3936 31800.0n 0.5885 32399.5n 0.5885 32400.0n 0.6100 32999.5n 0.6100 33000.0n 0.6042 33599.5n 0.6042 33600.0n 0.6253 34199.5n 0.6253 34200.0n 0.4577 34799.5n 0.4577 34800.0n 0.4491 35399.5n 0.4491 35400.0n 0.6010 35999.5n 0.6010)
Vyp_wih_1_23 yp_wih_1_23 0 PWL(0.0n 0.3457 599.5n 0.3457 600.0n 0.3882 1199.5n 0.3882 1200.0n 0.3729 1799.5n 0.3729 1800.0n 0.4496 2399.5n 0.4496 2400.0n 0.4358 2999.5n 0.4358 3000.0n 0.3712 3599.5n 0.3712 3600.0n 0.3592 4199.5n 0.3592 4200.0n 0.3441 4799.5n 0.3441 4800.0n 0.3645 5399.5n 0.3645 5400.0n 0.3660 5999.5n 0.3660 6000.0n 0.3853 6599.5n 0.3853 6600.0n 0.3545 7199.5n 0.3545 7200.0n 0.3976 7799.5n 0.3976 7800.0n 0.4047 8399.5n 0.4047 8400.0n 0.3432 8999.5n 0.3432 9000.0n 0.3651 9599.5n 0.3651 9600.0n 0.3839 10199.5n 0.3839 10200.0n 0.4040 10799.5n 0.4040 10800.0n 0.3626 11399.5n 0.3626 11400.0n 0.3594 11999.5n 0.3594 12000.0n 0.3401 12599.5n 0.3401 12600.0n 0.3879 13199.5n 0.3879 13200.0n 0.3466 13799.5n 0.3466 13800.0n 0.3648 14399.5n 0.3648 14400.0n 0.3593 14999.5n 0.3593 15000.0n 0.4122 15599.5n 0.4122 15600.0n 0.3469 16199.5n 0.3469 16200.0n 0.3505 16799.5n 0.3505 16800.0n 0.3430 17399.5n 0.3430 17400.0n 0.3491 17999.5n 0.3491 18000.0n 0.4227 18599.5n 0.4227 18600.0n 0.4323 19199.5n 0.4323 19200.0n 0.5105 19799.5n 0.5105 19800.0n 0.5452 20399.5n 0.5452 20400.0n 0.4900 20999.5n 0.4900 21000.0n 0.3422 21599.5n 0.3422 21600.0n 0.5020 22199.5n 0.5020 22200.0n 0.4500 22799.5n 0.4500 22800.0n 0.5079 23399.5n 0.5079 23400.0n 0.3307 23999.5n 0.3307 24000.0n 0.5742 24599.5n 0.5742 24600.0n 0.4279 25199.5n 0.4279 25200.0n 0.4593 25799.5n 0.4593 25800.0n 0.4183 26399.5n 0.4183 26400.0n 0.4757 26999.5n 0.4757 27000.0n 0.4398 27599.5n 0.4398 27600.0n 0.4787 28199.5n 0.4787 28200.0n 0.3396 28799.5n 0.3396 28800.0n 0.4950 29399.5n 0.4950 29400.0n 0.3388 29999.5n 0.3388 30000.0n 0.3333 30599.5n 0.3333 30600.0n 0.3146 31199.5n 0.3146 31200.0n 0.3220 31799.5n 0.3220 31800.0n 0.4056 32399.5n 0.4056 32400.0n 0.4225 32999.5n 0.4225 33000.0n 0.5396 33599.5n 0.5396 33600.0n 0.5258 34199.5n 0.5258 34200.0n 0.3998 34799.5n 0.3998 34800.0n 0.3248 35399.5n 0.3248 35400.0n 0.5129 35999.5n 0.5129)
Vyn_wih_1_23 yn_wih_1_23 0 PWL(0.0n 0.6543 599.5n 0.6543 600.0n 0.6118 1199.5n 0.6118 1200.0n 0.6271 1799.5n 0.6271 1800.0n 0.5504 2399.5n 0.5504 2400.0n 0.5642 2999.5n 0.5642 3000.0n 0.6288 3599.5n 0.6288 3600.0n 0.6408 4199.5n 0.6408 4200.0n 0.6559 4799.5n 0.6559 4800.0n 0.6355 5399.5n 0.6355 5400.0n 0.6340 5999.5n 0.6340 6000.0n 0.6147 6599.5n 0.6147 6600.0n 0.6455 7199.5n 0.6455 7200.0n 0.6024 7799.5n 0.6024 7800.0n 0.5953 8399.5n 0.5953 8400.0n 0.6568 8999.5n 0.6568 9000.0n 0.6349 9599.5n 0.6349 9600.0n 0.6161 10199.5n 0.6161 10200.0n 0.5960 10799.5n 0.5960 10800.0n 0.6374 11399.5n 0.6374 11400.0n 0.6406 11999.5n 0.6406 12000.0n 0.6599 12599.5n 0.6599 12600.0n 0.6121 13199.5n 0.6121 13200.0n 0.6534 13799.5n 0.6534 13800.0n 0.6352 14399.5n 0.6352 14400.0n 0.6407 14999.5n 0.6407 15000.0n 0.5878 15599.5n 0.5878 15600.0n 0.6531 16199.5n 0.6531 16200.0n 0.6495 16799.5n 0.6495 16800.0n 0.6570 17399.5n 0.6570 17400.0n 0.6509 17999.5n 0.6509 18000.0n 0.5773 18599.5n 0.5773 18600.0n 0.5677 19199.5n 0.5677 19200.0n 0.4895 19799.5n 0.4895 19800.0n 0.4548 20399.5n 0.4548 20400.0n 0.5100 20999.5n 0.5100 21000.0n 0.6578 21599.5n 0.6578 21600.0n 0.4980 22199.5n 0.4980 22200.0n 0.5500 22799.5n 0.5500 22800.0n 0.4921 23399.5n 0.4921 23400.0n 0.6693 23999.5n 0.6693 24000.0n 0.4258 24599.5n 0.4258 24600.0n 0.5721 25199.5n 0.5721 25200.0n 0.5407 25799.5n 0.5407 25800.0n 0.5817 26399.5n 0.5817 26400.0n 0.5243 26999.5n 0.5243 27000.0n 0.5602 27599.5n 0.5602 27600.0n 0.5213 28199.5n 0.5213 28200.0n 0.6604 28799.5n 0.6604 28800.0n 0.5050 29399.5n 0.5050 29400.0n 0.6612 29999.5n 0.6612 30000.0n 0.6667 30599.5n 0.6667 30600.0n 0.6854 31199.5n 0.6854 31200.0n 0.6780 31799.5n 0.6780 31800.0n 0.5944 32399.5n 0.5944 32400.0n 0.5775 32999.5n 0.5775 33000.0n 0.4604 33599.5n 0.4604 33600.0n 0.4742 34199.5n 0.4742 34200.0n 0.6002 34799.5n 0.6002 34800.0n 0.6752 35399.5n 0.6752 35400.0n 0.4871 35999.5n 0.4871)
Cwp_wih_1_23 wp_wih_1_23 0 400p
Cwn_wih_1_23 wn_wih_1_23 0 400p
Xu_wih_1_23 xp_wih_1_23 xn_wih_1_23 yp_wih_1_23 yn_wih_1_23 wp_wih_1_23 wn_wih_1_23 vdd gbn gprod
Vxp_who_23_0 xp_who_23_0 0 PWL(0.0n 0.3457 599.5n 0.3457 600.0n 0.3882 1199.5n 0.3882 1200.0n 0.3729 1799.5n 0.3729 1800.0n 0.4496 2399.5n 0.4496 2400.0n 0.4358 2999.5n 0.4358 3000.0n 0.3712 3599.5n 0.3712 3600.0n 0.3592 4199.5n 0.3592 4200.0n 0.3441 4799.5n 0.3441 4800.0n 0.3645 5399.5n 0.3645 5400.0n 0.3660 5999.5n 0.3660 6000.0n 0.3853 6599.5n 0.3853 6600.0n 0.3545 7199.5n 0.3545 7200.0n 0.3976 7799.5n 0.3976 7800.0n 0.4047 8399.5n 0.4047 8400.0n 0.3432 8999.5n 0.3432 9000.0n 0.3651 9599.5n 0.3651 9600.0n 0.3839 10199.5n 0.3839 10200.0n 0.4040 10799.5n 0.4040 10800.0n 0.3626 11399.5n 0.3626 11400.0n 0.3594 11999.5n 0.3594 12000.0n 0.3401 12599.5n 0.3401 12600.0n 0.3879 13199.5n 0.3879 13200.0n 0.3466 13799.5n 0.3466 13800.0n 0.3648 14399.5n 0.3648 14400.0n 0.3593 14999.5n 0.3593 15000.0n 0.4122 15599.5n 0.4122 15600.0n 0.3469 16199.5n 0.3469 16200.0n 0.3505 16799.5n 0.3505 16800.0n 0.3430 17399.5n 0.3430 17400.0n 0.3491 17999.5n 0.3491 18000.0n 0.4227 18599.5n 0.4227 18600.0n 0.4323 19199.5n 0.4323 19200.0n 0.5105 19799.5n 0.5105 19800.0n 0.5452 20399.5n 0.5452 20400.0n 0.4900 20999.5n 0.4900 21000.0n 0.3422 21599.5n 0.3422 21600.0n 0.5020 22199.5n 0.5020 22200.0n 0.4500 22799.5n 0.4500 22800.0n 0.5079 23399.5n 0.5079 23400.0n 0.3307 23999.5n 0.3307 24000.0n 0.5742 24599.5n 0.5742 24600.0n 0.4279 25199.5n 0.4279 25200.0n 0.4593 25799.5n 0.4593 25800.0n 0.4183 26399.5n 0.4183 26400.0n 0.4757 26999.5n 0.4757 27000.0n 0.4398 27599.5n 0.4398 27600.0n 0.4787 28199.5n 0.4787 28200.0n 0.3396 28799.5n 0.3396 28800.0n 0.4950 29399.5n 0.4950 29400.0n 0.3388 29999.5n 0.3388 30000.0n 0.3333 30599.5n 0.3333 30600.0n 0.3146 31199.5n 0.3146 31200.0n 0.3220 31799.5n 0.3220 31800.0n 0.4056 32399.5n 0.4056 32400.0n 0.4225 32999.5n 0.4225 33000.0n 0.5396 33599.5n 0.5396 33600.0n 0.5258 34199.5n 0.5258 34200.0n 0.3998 34799.5n 0.3998 34800.0n 0.3248 35399.5n 0.3248 35400.0n 0.5129 35999.5n 0.5129)
Vxn_who_23_0 xn_who_23_0 0 PWL(0.0n 0.6543 599.5n 0.6543 600.0n 0.6118 1199.5n 0.6118 1200.0n 0.6271 1799.5n 0.6271 1800.0n 0.5504 2399.5n 0.5504 2400.0n 0.5642 2999.5n 0.5642 3000.0n 0.6288 3599.5n 0.6288 3600.0n 0.6408 4199.5n 0.6408 4200.0n 0.6559 4799.5n 0.6559 4800.0n 0.6355 5399.5n 0.6355 5400.0n 0.6340 5999.5n 0.6340 6000.0n 0.6147 6599.5n 0.6147 6600.0n 0.6455 7199.5n 0.6455 7200.0n 0.6024 7799.5n 0.6024 7800.0n 0.5953 8399.5n 0.5953 8400.0n 0.6568 8999.5n 0.6568 9000.0n 0.6349 9599.5n 0.6349 9600.0n 0.6161 10199.5n 0.6161 10200.0n 0.5960 10799.5n 0.5960 10800.0n 0.6374 11399.5n 0.6374 11400.0n 0.6406 11999.5n 0.6406 12000.0n 0.6599 12599.5n 0.6599 12600.0n 0.6121 13199.5n 0.6121 13200.0n 0.6534 13799.5n 0.6534 13800.0n 0.6352 14399.5n 0.6352 14400.0n 0.6407 14999.5n 0.6407 15000.0n 0.5878 15599.5n 0.5878 15600.0n 0.6531 16199.5n 0.6531 16200.0n 0.6495 16799.5n 0.6495 16800.0n 0.6570 17399.5n 0.6570 17400.0n 0.6509 17999.5n 0.6509 18000.0n 0.5773 18599.5n 0.5773 18600.0n 0.5677 19199.5n 0.5677 19200.0n 0.4895 19799.5n 0.4895 19800.0n 0.4548 20399.5n 0.4548 20400.0n 0.5100 20999.5n 0.5100 21000.0n 0.6578 21599.5n 0.6578 21600.0n 0.4980 22199.5n 0.4980 22200.0n 0.5500 22799.5n 0.5500 22800.0n 0.4921 23399.5n 0.4921 23400.0n 0.6693 23999.5n 0.6693 24000.0n 0.4258 24599.5n 0.4258 24600.0n 0.5721 25199.5n 0.5721 25200.0n 0.5407 25799.5n 0.5407 25800.0n 0.5817 26399.5n 0.5817 26400.0n 0.5243 26999.5n 0.5243 27000.0n 0.5602 27599.5n 0.5602 27600.0n 0.5213 28199.5n 0.5213 28200.0n 0.6604 28799.5n 0.6604 28800.0n 0.5050 29399.5n 0.5050 29400.0n 0.6612 29999.5n 0.6612 30000.0n 0.6667 30599.5n 0.6667 30600.0n 0.6854 31199.5n 0.6854 31200.0n 0.6780 31799.5n 0.6780 31800.0n 0.5944 32399.5n 0.5944 32400.0n 0.5775 32999.5n 0.5775 33000.0n 0.4604 33599.5n 0.4604 33600.0n 0.4742 34199.5n 0.4742 34200.0n 0.6002 34799.5n 0.6002 34800.0n 0.6752 35399.5n 0.6752 35400.0n 0.4871 35999.5n 0.4871)
Vyp_who_23_0 yp_who_23_0 0 PWL(0.0n 0.5031 599.5n 0.5031 600.0n 0.5023 1199.5n 0.5023 1200.0n 0.5052 1799.5n 0.5052 1800.0n 0.5048 2399.5n 0.5048 2400.0n 0.5043 2999.5n 0.5043 3000.0n 0.5034 3599.5n 0.5034 3600.0n 0.5048 4199.5n 0.5048 4200.0n 0.5031 4799.5n 0.5031 4800.0n 0.5040 5399.5n 0.5040 5400.0n 0.5040 5999.5n 0.5040 6000.0n 0.5054 6599.5n 0.5054 6600.0n 0.5040 7199.5n 0.5040 7200.0n 0.5027 7799.5n 0.5027 7800.0n 0.5027 8399.5n 0.5027 8400.0n 0.5038 8999.5n 0.5038 9000.0n 0.5040 9599.5n 0.5040 9600.0n 0.5039 10199.5n 0.5039 10200.0n 0.5033 10799.5n 0.5033 10800.0n 0.5056 11399.5n 0.5056 11400.0n 0.5040 11999.5n 0.5040 12000.0n 0.5036 12599.5n 0.5036 12600.0n 0.5039 13199.5n 0.5039 13200.0n 0.5029 13799.5n 0.5029 13800.0n 0.5025 14399.5n 0.5025 14400.0n 0.5038 14999.5n 0.5038 15000.0n 0.5041 15599.5n 0.5041 15600.0n 0.5036 16199.5n 0.5036 16200.0n 0.5025 16799.5n 0.5025 16800.0n 0.5040 17399.5n 0.5040 17400.0n 0.5029 17999.5n 0.5029 18000.0n 0.5057 18599.5n 0.5057 18600.0n 0.5010 19199.5n 0.5010 19200.0n 0.5041 19799.5n 0.5041 19800.0n 0.5021 20399.5n 0.5021 20400.0n 0.5044 20999.5n 0.5044 21000.0n 0.5056 21599.5n 0.5056 21600.0n 0.5016 22199.5n 0.5016 22200.0n 0.5006 22799.5n 0.5006 22800.0n 0.5041 23399.5n 0.5041 23400.0n 0.5027 23999.5n 0.5027 24000.0n 0.5029 24599.5n 0.5029 24600.0n 0.5006 25199.5n 0.5006 25200.0n 0.5047 25799.5n 0.5047 25800.0n 0.5046 26399.5n 0.5046 26400.0n 0.5039 26999.5n 0.5039 27000.0n 0.5049 27599.5n 0.5049 27600.0n 0.5039 28199.5n 0.5039 28200.0n 0.5017 28799.5n 0.5017 28800.0n 0.5042 29399.5n 0.5042 29400.0n 0.5056 29999.5n 0.5056 30000.0n 0.5051 30599.5n 0.5051 30600.0n 0.5039 31199.5n 0.5039 31200.0n 0.5033 31799.5n 0.5033 31800.0n 0.5049 32399.5n 0.5049 32400.0n 0.5045 32999.5n 0.5045 33000.0n 0.5036 33599.5n 0.5036 33600.0n 0.5042 34199.5n 0.5042 34200.0n 0.5012 34799.5n 0.5012 34800.0n 0.5036 35399.5n 0.5036 35400.0n 0.5042 35999.5n 0.5042)
Vyn_who_23_0 yn_who_23_0 0 PWL(0.0n 0.4969 599.5n 0.4969 600.0n 0.4977 1199.5n 0.4977 1200.0n 0.4948 1799.5n 0.4948 1800.0n 0.4952 2399.5n 0.4952 2400.0n 0.4957 2999.5n 0.4957 3000.0n 0.4966 3599.5n 0.4966 3600.0n 0.4952 4199.5n 0.4952 4200.0n 0.4969 4799.5n 0.4969 4800.0n 0.4960 5399.5n 0.4960 5400.0n 0.4960 5999.5n 0.4960 6000.0n 0.4946 6599.5n 0.4946 6600.0n 0.4960 7199.5n 0.4960 7200.0n 0.4973 7799.5n 0.4973 7800.0n 0.4973 8399.5n 0.4973 8400.0n 0.4962 8999.5n 0.4962 9000.0n 0.4960 9599.5n 0.4960 9600.0n 0.4961 10199.5n 0.4961 10200.0n 0.4967 10799.5n 0.4967 10800.0n 0.4944 11399.5n 0.4944 11400.0n 0.4960 11999.5n 0.4960 12000.0n 0.4964 12599.5n 0.4964 12600.0n 0.4961 13199.5n 0.4961 13200.0n 0.4971 13799.5n 0.4971 13800.0n 0.4975 14399.5n 0.4975 14400.0n 0.4962 14999.5n 0.4962 15000.0n 0.4959 15599.5n 0.4959 15600.0n 0.4964 16199.5n 0.4964 16200.0n 0.4975 16799.5n 0.4975 16800.0n 0.4960 17399.5n 0.4960 17400.0n 0.4971 17999.5n 0.4971 18000.0n 0.4943 18599.5n 0.4943 18600.0n 0.4990 19199.5n 0.4990 19200.0n 0.4959 19799.5n 0.4959 19800.0n 0.4979 20399.5n 0.4979 20400.0n 0.4956 20999.5n 0.4956 21000.0n 0.4944 21599.5n 0.4944 21600.0n 0.4984 22199.5n 0.4984 22200.0n 0.4994 22799.5n 0.4994 22800.0n 0.4959 23399.5n 0.4959 23400.0n 0.4973 23999.5n 0.4973 24000.0n 0.4971 24599.5n 0.4971 24600.0n 0.4994 25199.5n 0.4994 25200.0n 0.4953 25799.5n 0.4953 25800.0n 0.4954 26399.5n 0.4954 26400.0n 0.4961 26999.5n 0.4961 27000.0n 0.4951 27599.5n 0.4951 27600.0n 0.4961 28199.5n 0.4961 28200.0n 0.4983 28799.5n 0.4983 28800.0n 0.4958 29399.5n 0.4958 29400.0n 0.4944 29999.5n 0.4944 30000.0n 0.4949 30599.5n 0.4949 30600.0n 0.4961 31199.5n 0.4961 31200.0n 0.4967 31799.5n 0.4967 31800.0n 0.4951 32399.5n 0.4951 32400.0n 0.4955 32999.5n 0.4955 33000.0n 0.4964 33599.5n 0.4964 33600.0n 0.4958 34199.5n 0.4958 34200.0n 0.4988 34799.5n 0.4988 34800.0n 0.4964 35399.5n 0.4964 35400.0n 0.4958 35999.5n 0.4958)
Cwp_who_23_0 wp_who_23_0 0 400p
Cwn_who_23_0 wn_who_23_0 0 400p
Xu_who_23_0 xp_who_23_0 xn_who_23_0 yp_who_23_0 yn_who_23_0 wp_who_23_0 wn_who_23_0 vdd gbn gprod
Vxp_who_23_1 xp_who_23_1 0 PWL(0.0n 0.3457 599.5n 0.3457 600.0n 0.3882 1199.5n 0.3882 1200.0n 0.3729 1799.5n 0.3729 1800.0n 0.4496 2399.5n 0.4496 2400.0n 0.4358 2999.5n 0.4358 3000.0n 0.3712 3599.5n 0.3712 3600.0n 0.3592 4199.5n 0.3592 4200.0n 0.3441 4799.5n 0.3441 4800.0n 0.3645 5399.5n 0.3645 5400.0n 0.3660 5999.5n 0.3660 6000.0n 0.3853 6599.5n 0.3853 6600.0n 0.3545 7199.5n 0.3545 7200.0n 0.3976 7799.5n 0.3976 7800.0n 0.4047 8399.5n 0.4047 8400.0n 0.3432 8999.5n 0.3432 9000.0n 0.3651 9599.5n 0.3651 9600.0n 0.3839 10199.5n 0.3839 10200.0n 0.4040 10799.5n 0.4040 10800.0n 0.3626 11399.5n 0.3626 11400.0n 0.3594 11999.5n 0.3594 12000.0n 0.3401 12599.5n 0.3401 12600.0n 0.3879 13199.5n 0.3879 13200.0n 0.3466 13799.5n 0.3466 13800.0n 0.3648 14399.5n 0.3648 14400.0n 0.3593 14999.5n 0.3593 15000.0n 0.4122 15599.5n 0.4122 15600.0n 0.3469 16199.5n 0.3469 16200.0n 0.3505 16799.5n 0.3505 16800.0n 0.3430 17399.5n 0.3430 17400.0n 0.3491 17999.5n 0.3491 18000.0n 0.4227 18599.5n 0.4227 18600.0n 0.4323 19199.5n 0.4323 19200.0n 0.5105 19799.5n 0.5105 19800.0n 0.5452 20399.5n 0.5452 20400.0n 0.4900 20999.5n 0.4900 21000.0n 0.3422 21599.5n 0.3422 21600.0n 0.5020 22199.5n 0.5020 22200.0n 0.4500 22799.5n 0.4500 22800.0n 0.5079 23399.5n 0.5079 23400.0n 0.3307 23999.5n 0.3307 24000.0n 0.5742 24599.5n 0.5742 24600.0n 0.4279 25199.5n 0.4279 25200.0n 0.4593 25799.5n 0.4593 25800.0n 0.4183 26399.5n 0.4183 26400.0n 0.4757 26999.5n 0.4757 27000.0n 0.4398 27599.5n 0.4398 27600.0n 0.4787 28199.5n 0.4787 28200.0n 0.3396 28799.5n 0.3396 28800.0n 0.4950 29399.5n 0.4950 29400.0n 0.3388 29999.5n 0.3388 30000.0n 0.3333 30599.5n 0.3333 30600.0n 0.3146 31199.5n 0.3146 31200.0n 0.3220 31799.5n 0.3220 31800.0n 0.4056 32399.5n 0.4056 32400.0n 0.4225 32999.5n 0.4225 33000.0n 0.5396 33599.5n 0.5396 33600.0n 0.5258 34199.5n 0.5258 34200.0n 0.3998 34799.5n 0.3998 34800.0n 0.3248 35399.5n 0.3248 35400.0n 0.5129 35999.5n 0.5129)
Vxn_who_23_1 xn_who_23_1 0 PWL(0.0n 0.6543 599.5n 0.6543 600.0n 0.6118 1199.5n 0.6118 1200.0n 0.6271 1799.5n 0.6271 1800.0n 0.5504 2399.5n 0.5504 2400.0n 0.5642 2999.5n 0.5642 3000.0n 0.6288 3599.5n 0.6288 3600.0n 0.6408 4199.5n 0.6408 4200.0n 0.6559 4799.5n 0.6559 4800.0n 0.6355 5399.5n 0.6355 5400.0n 0.6340 5999.5n 0.6340 6000.0n 0.6147 6599.5n 0.6147 6600.0n 0.6455 7199.5n 0.6455 7200.0n 0.6024 7799.5n 0.6024 7800.0n 0.5953 8399.5n 0.5953 8400.0n 0.6568 8999.5n 0.6568 9000.0n 0.6349 9599.5n 0.6349 9600.0n 0.6161 10199.5n 0.6161 10200.0n 0.5960 10799.5n 0.5960 10800.0n 0.6374 11399.5n 0.6374 11400.0n 0.6406 11999.5n 0.6406 12000.0n 0.6599 12599.5n 0.6599 12600.0n 0.6121 13199.5n 0.6121 13200.0n 0.6534 13799.5n 0.6534 13800.0n 0.6352 14399.5n 0.6352 14400.0n 0.6407 14999.5n 0.6407 15000.0n 0.5878 15599.5n 0.5878 15600.0n 0.6531 16199.5n 0.6531 16200.0n 0.6495 16799.5n 0.6495 16800.0n 0.6570 17399.5n 0.6570 17400.0n 0.6509 17999.5n 0.6509 18000.0n 0.5773 18599.5n 0.5773 18600.0n 0.5677 19199.5n 0.5677 19200.0n 0.4895 19799.5n 0.4895 19800.0n 0.4548 20399.5n 0.4548 20400.0n 0.5100 20999.5n 0.5100 21000.0n 0.6578 21599.5n 0.6578 21600.0n 0.4980 22199.5n 0.4980 22200.0n 0.5500 22799.5n 0.5500 22800.0n 0.4921 23399.5n 0.4921 23400.0n 0.6693 23999.5n 0.6693 24000.0n 0.4258 24599.5n 0.4258 24600.0n 0.5721 25199.5n 0.5721 25200.0n 0.5407 25799.5n 0.5407 25800.0n 0.5817 26399.5n 0.5817 26400.0n 0.5243 26999.5n 0.5243 27000.0n 0.5602 27599.5n 0.5602 27600.0n 0.5213 28199.5n 0.5213 28200.0n 0.6604 28799.5n 0.6604 28800.0n 0.5050 29399.5n 0.5050 29400.0n 0.6612 29999.5n 0.6612 30000.0n 0.6667 30599.5n 0.6667 30600.0n 0.6854 31199.5n 0.6854 31200.0n 0.6780 31799.5n 0.6780 31800.0n 0.5944 32399.5n 0.5944 32400.0n 0.5775 32999.5n 0.5775 33000.0n 0.4604 33599.5n 0.4604 33600.0n 0.4742 34199.5n 0.4742 34200.0n 0.6002 34799.5n 0.6002 34800.0n 0.6752 35399.5n 0.6752 35400.0n 0.4871 35999.5n 0.4871)
Vyp_who_23_1 yp_who_23_1 0 PWL(0.0n 0.5071 599.5n 0.5071 600.0n 0.5053 1199.5n 0.5053 1200.0n 0.5052 1799.5n 0.5052 1800.0n 0.5027 2399.5n 0.5027 2400.0n 0.5034 2999.5n 0.5034 3000.0n 0.5055 3599.5n 0.5055 3600.0n 0.5056 4199.5n 0.5056 4200.0n 0.5071 4799.5n 0.5071 4800.0n 0.5056 5399.5n 0.5056 5400.0n 0.5056 5999.5n 0.5056 6000.0n 0.5048 6599.5n 0.5048 6600.0n 0.5060 7199.5n 0.5060 7200.0n 0.5048 7799.5n 0.5048 7800.0n 0.5046 8399.5n 0.5046 8400.0n 0.5066 8999.5n 0.5066 9000.0n 0.5056 9599.5n 0.5056 9600.0n 0.5051 10199.5n 0.5051 10200.0n 0.5046 10799.5n 0.5046 10800.0n 0.5056 11399.5n 0.5056 11400.0n 0.5058 11999.5n 0.5058 12000.0n 0.5068 12599.5n 0.5068 12600.0n 0.5050 13199.5n 0.5050 13200.0n 0.5071 13799.5n 0.5071 13800.0n 0.5059 14399.5n 0.5059 14400.0n 0.5058 14999.5n 0.5058 15000.0n 0.5043 15599.5n 0.5043 15600.0n 0.5067 16199.5n 0.5067 16200.0n 0.5068 16799.5n 0.5068 16800.0n 0.5066 17399.5n 0.5066 17400.0n 0.5069 17999.5n 0.5069 18000.0n 0.5061 18599.5n 0.5061 18600.0n 0.5034 19199.5n 0.5034 19200.0n 0.5010 19799.5n 0.5010 19800.0n 0.4989 20399.5n 0.4989 20400.0n 0.5022 20999.5n 0.5022 21000.0n 0.5086 21599.5n 0.5086 21600.0n 0.5007 22199.5n 0.5007 22200.0n 0.5023 22799.5n 0.5023 22800.0n 0.5021 23399.5n 0.5021 23400.0n 0.5077 23999.5n 0.5077 24000.0n 0.4979 24599.5n 0.4979 24600.0n 0.5035 25199.5n 0.5035 25200.0n 0.5041 25799.5n 0.5041 25800.0n 0.5075 26399.5n 0.5075 26400.0n 0.5041 26999.5n 0.5041 27000.0n 0.5056 27599.5n 0.5056 27600.0n 0.5039 28199.5n 0.5039 28200.0n 0.5059 28799.5n 0.5059 28800.0n 0.5023 29399.5n 0.5023 29400.0n 0.5086 29999.5n 0.5086 30000.0n 0.5084 30599.5n 0.5084 30600.0n 0.5085 31199.5n 0.5085 31200.0n 0.5088 31799.5n 0.5088 31800.0n 0.5078 32399.5n 0.5078 32400.0n 0.5074 32999.5n 0.5074 33000.0n 0.4996 33599.5n 0.4996 33600.0n 0.5010 34199.5n 0.5010 34200.0n 0.5044 34799.5n 0.5044 34800.0n 0.5084 35399.5n 0.5084 35400.0n 0.5012 35999.5n 0.5012)
Vyn_who_23_1 yn_who_23_1 0 PWL(0.0n 0.4929 599.5n 0.4929 600.0n 0.4947 1199.5n 0.4947 1200.0n 0.4948 1799.5n 0.4948 1800.0n 0.4973 2399.5n 0.4973 2400.0n 0.4966 2999.5n 0.4966 3000.0n 0.4945 3599.5n 0.4945 3600.0n 0.4944 4199.5n 0.4944 4200.0n 0.4929 4799.5n 0.4929 4800.0n 0.4944 5399.5n 0.4944 5400.0n 0.4944 5999.5n 0.4944 6000.0n 0.4952 6599.5n 0.4952 6600.0n 0.4940 7199.5n 0.4940 7200.0n 0.4952 7799.5n 0.4952 7800.0n 0.4954 8399.5n 0.4954 8400.0n 0.4934 8999.5n 0.4934 9000.0n 0.4944 9599.5n 0.4944 9600.0n 0.4949 10199.5n 0.4949 10200.0n 0.4954 10799.5n 0.4954 10800.0n 0.4944 11399.5n 0.4944 11400.0n 0.4942 11999.5n 0.4942 12000.0n 0.4932 12599.5n 0.4932 12600.0n 0.4950 13199.5n 0.4950 13200.0n 0.4929 13799.5n 0.4929 13800.0n 0.4941 14399.5n 0.4941 14400.0n 0.4942 14999.5n 0.4942 15000.0n 0.4957 15599.5n 0.4957 15600.0n 0.4933 16199.5n 0.4933 16200.0n 0.4932 16799.5n 0.4932 16800.0n 0.4934 17399.5n 0.4934 17400.0n 0.4931 17999.5n 0.4931 18000.0n 0.4939 18599.5n 0.4939 18600.0n 0.4966 19199.5n 0.4966 19200.0n 0.4990 19799.5n 0.4990 19800.0n 0.5011 20399.5n 0.5011 20400.0n 0.4978 20999.5n 0.4978 21000.0n 0.4914 21599.5n 0.4914 21600.0n 0.4993 22199.5n 0.4993 22200.0n 0.4977 22799.5n 0.4977 22800.0n 0.4979 23399.5n 0.4979 23400.0n 0.4923 23999.5n 0.4923 24000.0n 0.5021 24599.5n 0.5021 24600.0n 0.4965 25199.5n 0.4965 25200.0n 0.4959 25799.5n 0.4959 25800.0n 0.4925 26399.5n 0.4925 26400.0n 0.4959 26999.5n 0.4959 27000.0n 0.4944 27599.5n 0.4944 27600.0n 0.4961 28199.5n 0.4961 28200.0n 0.4941 28799.5n 0.4941 28800.0n 0.4977 29399.5n 0.4977 29400.0n 0.4914 29999.5n 0.4914 30000.0n 0.4916 30599.5n 0.4916 30600.0n 0.4915 31199.5n 0.4915 31200.0n 0.4912 31799.5n 0.4912 31800.0n 0.4922 32399.5n 0.4922 32400.0n 0.4926 32999.5n 0.4926 33000.0n 0.5004 33599.5n 0.5004 33600.0n 0.4990 34199.5n 0.4990 34200.0n 0.4956 34799.5n 0.4956 34800.0n 0.4916 35399.5n 0.4916 35400.0n 0.4988 35999.5n 0.4988)
Cwp_who_23_1 wp_who_23_1 0 400p
Cwn_who_23_1 wn_who_23_1 0 400p
Xu_who_23_1 xp_who_23_1 xn_who_23_1 yp_who_23_1 yn_who_23_1 wp_who_23_1 wn_who_23_1 vdd gbn gprod
Vxp_bh_23 xp_bh_23 0 PWL(0.0n 0.7100 599.5n 0.7100 600.0n 0.7100 1199.5n 0.7100 1200.0n 0.7100 1799.5n 0.7100 1800.0n 0.7100 2399.5n 0.7100 2400.0n 0.7100 2999.5n 0.7100 3000.0n 0.7100 3599.5n 0.7100 3600.0n 0.7100 4199.5n 0.7100 4200.0n 0.7100 4799.5n 0.7100 4800.0n 0.7100 5399.5n 0.7100 5400.0n 0.7100 5999.5n 0.7100 6000.0n 0.7100 6599.5n 0.7100 6600.0n 0.7100 7199.5n 0.7100 7200.0n 0.7100 7799.5n 0.7100 7800.0n 0.7100 8399.5n 0.7100 8400.0n 0.7100 8999.5n 0.7100 9000.0n 0.7100 9599.5n 0.7100 9600.0n 0.7100 10199.5n 0.7100 10200.0n 0.7100 10799.5n 0.7100 10800.0n 0.7100 11399.5n 0.7100 11400.0n 0.7100 11999.5n 0.7100 12000.0n 0.7100 12599.5n 0.7100 12600.0n 0.7100 13199.5n 0.7100 13200.0n 0.7100 13799.5n 0.7100 13800.0n 0.7100 14399.5n 0.7100 14400.0n 0.7100 14999.5n 0.7100 15000.0n 0.7100 15599.5n 0.7100 15600.0n 0.7100 16199.5n 0.7100 16200.0n 0.7100 16799.5n 0.7100 16800.0n 0.7100 17399.5n 0.7100 17400.0n 0.7100 17999.5n 0.7100 18000.0n 0.7100 18599.5n 0.7100 18600.0n 0.7100 19199.5n 0.7100 19200.0n 0.7100 19799.5n 0.7100 19800.0n 0.7100 20399.5n 0.7100 20400.0n 0.7100 20999.5n 0.7100 21000.0n 0.7100 21599.5n 0.7100 21600.0n 0.7100 22199.5n 0.7100 22200.0n 0.7100 22799.5n 0.7100 22800.0n 0.7100 23399.5n 0.7100 23400.0n 0.7100 23999.5n 0.7100 24000.0n 0.7100 24599.5n 0.7100 24600.0n 0.7100 25199.5n 0.7100 25200.0n 0.7100 25799.5n 0.7100 25800.0n 0.7100 26399.5n 0.7100 26400.0n 0.7100 26999.5n 0.7100 27000.0n 0.7100 27599.5n 0.7100 27600.0n 0.7100 28199.5n 0.7100 28200.0n 0.7100 28799.5n 0.7100 28800.0n 0.7100 29399.5n 0.7100 29400.0n 0.7100 29999.5n 0.7100 30000.0n 0.7100 30599.5n 0.7100 30600.0n 0.7100 31199.5n 0.7100 31200.0n 0.7100 31799.5n 0.7100 31800.0n 0.7100 32399.5n 0.7100 32400.0n 0.7100 32999.5n 0.7100 33000.0n 0.7100 33599.5n 0.7100 33600.0n 0.7100 34199.5n 0.7100 34200.0n 0.7100 34799.5n 0.7100 34800.0n 0.7100 35399.5n 0.7100 35400.0n 0.7100 35999.5n 0.7100)
Vxn_bh_23 xn_bh_23 0 PWL(0.0n 0.2900 599.5n 0.2900 600.0n 0.2900 1199.5n 0.2900 1200.0n 0.2900 1799.5n 0.2900 1800.0n 0.2900 2399.5n 0.2900 2400.0n 0.2900 2999.5n 0.2900 3000.0n 0.2900 3599.5n 0.2900 3600.0n 0.2900 4199.5n 0.2900 4200.0n 0.2900 4799.5n 0.2900 4800.0n 0.2900 5399.5n 0.2900 5400.0n 0.2900 5999.5n 0.2900 6000.0n 0.2900 6599.5n 0.2900 6600.0n 0.2900 7199.5n 0.2900 7200.0n 0.2900 7799.5n 0.2900 7800.0n 0.2900 8399.5n 0.2900 8400.0n 0.2900 8999.5n 0.2900 9000.0n 0.2900 9599.5n 0.2900 9600.0n 0.2900 10199.5n 0.2900 10200.0n 0.2900 10799.5n 0.2900 10800.0n 0.2900 11399.5n 0.2900 11400.0n 0.2900 11999.5n 0.2900 12000.0n 0.2900 12599.5n 0.2900 12600.0n 0.2900 13199.5n 0.2900 13200.0n 0.2900 13799.5n 0.2900 13800.0n 0.2900 14399.5n 0.2900 14400.0n 0.2900 14999.5n 0.2900 15000.0n 0.2900 15599.5n 0.2900 15600.0n 0.2900 16199.5n 0.2900 16200.0n 0.2900 16799.5n 0.2900 16800.0n 0.2900 17399.5n 0.2900 17400.0n 0.2900 17999.5n 0.2900 18000.0n 0.2900 18599.5n 0.2900 18600.0n 0.2900 19199.5n 0.2900 19200.0n 0.2900 19799.5n 0.2900 19800.0n 0.2900 20399.5n 0.2900 20400.0n 0.2900 20999.5n 0.2900 21000.0n 0.2900 21599.5n 0.2900 21600.0n 0.2900 22199.5n 0.2900 22200.0n 0.2900 22799.5n 0.2900 22800.0n 0.2900 23399.5n 0.2900 23400.0n 0.2900 23999.5n 0.2900 24000.0n 0.2900 24599.5n 0.2900 24600.0n 0.2900 25199.5n 0.2900 25200.0n 0.2900 25799.5n 0.2900 25800.0n 0.2900 26399.5n 0.2900 26400.0n 0.2900 26999.5n 0.2900 27000.0n 0.2900 27599.5n 0.2900 27600.0n 0.2900 28199.5n 0.2900 28200.0n 0.2900 28799.5n 0.2900 28800.0n 0.2900 29399.5n 0.2900 29400.0n 0.2900 29999.5n 0.2900 30000.0n 0.2900 30599.5n 0.2900 30600.0n 0.2900 31199.5n 0.2900 31200.0n 0.2900 31799.5n 0.2900 31800.0n 0.2900 32399.5n 0.2900 32400.0n 0.2900 32999.5n 0.2900 33000.0n 0.2900 33599.5n 0.2900 33600.0n 0.2900 34199.5n 0.2900 34200.0n 0.2900 34799.5n 0.2900 34800.0n 0.2900 35399.5n 0.2900 35400.0n 0.2900 35999.5n 0.2900)
Vyp_bh_23 yp_bh_23 0 PWL(0.0n 0.3457 599.5n 0.3457 600.0n 0.3882 1199.5n 0.3882 1200.0n 0.3729 1799.5n 0.3729 1800.0n 0.4496 2399.5n 0.4496 2400.0n 0.4358 2999.5n 0.4358 3000.0n 0.3712 3599.5n 0.3712 3600.0n 0.3592 4199.5n 0.3592 4200.0n 0.3441 4799.5n 0.3441 4800.0n 0.3645 5399.5n 0.3645 5400.0n 0.3660 5999.5n 0.3660 6000.0n 0.3853 6599.5n 0.3853 6600.0n 0.3545 7199.5n 0.3545 7200.0n 0.3976 7799.5n 0.3976 7800.0n 0.4047 8399.5n 0.4047 8400.0n 0.3432 8999.5n 0.3432 9000.0n 0.3651 9599.5n 0.3651 9600.0n 0.3839 10199.5n 0.3839 10200.0n 0.4040 10799.5n 0.4040 10800.0n 0.3626 11399.5n 0.3626 11400.0n 0.3594 11999.5n 0.3594 12000.0n 0.3401 12599.5n 0.3401 12600.0n 0.3879 13199.5n 0.3879 13200.0n 0.3466 13799.5n 0.3466 13800.0n 0.3648 14399.5n 0.3648 14400.0n 0.3593 14999.5n 0.3593 15000.0n 0.4122 15599.5n 0.4122 15600.0n 0.3469 16199.5n 0.3469 16200.0n 0.3505 16799.5n 0.3505 16800.0n 0.3430 17399.5n 0.3430 17400.0n 0.3491 17999.5n 0.3491 18000.0n 0.4227 18599.5n 0.4227 18600.0n 0.4323 19199.5n 0.4323 19200.0n 0.5105 19799.5n 0.5105 19800.0n 0.5452 20399.5n 0.5452 20400.0n 0.4900 20999.5n 0.4900 21000.0n 0.3422 21599.5n 0.3422 21600.0n 0.5020 22199.5n 0.5020 22200.0n 0.4500 22799.5n 0.4500 22800.0n 0.5079 23399.5n 0.5079 23400.0n 0.3307 23999.5n 0.3307 24000.0n 0.5742 24599.5n 0.5742 24600.0n 0.4279 25199.5n 0.4279 25200.0n 0.4593 25799.5n 0.4593 25800.0n 0.4183 26399.5n 0.4183 26400.0n 0.4757 26999.5n 0.4757 27000.0n 0.4398 27599.5n 0.4398 27600.0n 0.4787 28199.5n 0.4787 28200.0n 0.3396 28799.5n 0.3396 28800.0n 0.4950 29399.5n 0.4950 29400.0n 0.3388 29999.5n 0.3388 30000.0n 0.3333 30599.5n 0.3333 30600.0n 0.3146 31199.5n 0.3146 31200.0n 0.3220 31799.5n 0.3220 31800.0n 0.4056 32399.5n 0.4056 32400.0n 0.4225 32999.5n 0.4225 33000.0n 0.5396 33599.5n 0.5396 33600.0n 0.5258 34199.5n 0.5258 34200.0n 0.3998 34799.5n 0.3998 34800.0n 0.3248 35399.5n 0.3248 35400.0n 0.5129 35999.5n 0.5129)
Vyn_bh_23 yn_bh_23 0 PWL(0.0n 0.6543 599.5n 0.6543 600.0n 0.6118 1199.5n 0.6118 1200.0n 0.6271 1799.5n 0.6271 1800.0n 0.5504 2399.5n 0.5504 2400.0n 0.5642 2999.5n 0.5642 3000.0n 0.6288 3599.5n 0.6288 3600.0n 0.6408 4199.5n 0.6408 4200.0n 0.6559 4799.5n 0.6559 4800.0n 0.6355 5399.5n 0.6355 5400.0n 0.6340 5999.5n 0.6340 6000.0n 0.6147 6599.5n 0.6147 6600.0n 0.6455 7199.5n 0.6455 7200.0n 0.6024 7799.5n 0.6024 7800.0n 0.5953 8399.5n 0.5953 8400.0n 0.6568 8999.5n 0.6568 9000.0n 0.6349 9599.5n 0.6349 9600.0n 0.6161 10199.5n 0.6161 10200.0n 0.5960 10799.5n 0.5960 10800.0n 0.6374 11399.5n 0.6374 11400.0n 0.6406 11999.5n 0.6406 12000.0n 0.6599 12599.5n 0.6599 12600.0n 0.6121 13199.5n 0.6121 13200.0n 0.6534 13799.5n 0.6534 13800.0n 0.6352 14399.5n 0.6352 14400.0n 0.6407 14999.5n 0.6407 15000.0n 0.5878 15599.5n 0.5878 15600.0n 0.6531 16199.5n 0.6531 16200.0n 0.6495 16799.5n 0.6495 16800.0n 0.6570 17399.5n 0.6570 17400.0n 0.6509 17999.5n 0.6509 18000.0n 0.5773 18599.5n 0.5773 18600.0n 0.5677 19199.5n 0.5677 19200.0n 0.4895 19799.5n 0.4895 19800.0n 0.4548 20399.5n 0.4548 20400.0n 0.5100 20999.5n 0.5100 21000.0n 0.6578 21599.5n 0.6578 21600.0n 0.4980 22199.5n 0.4980 22200.0n 0.5500 22799.5n 0.5500 22800.0n 0.4921 23399.5n 0.4921 23400.0n 0.6693 23999.5n 0.6693 24000.0n 0.4258 24599.5n 0.4258 24600.0n 0.5721 25199.5n 0.5721 25200.0n 0.5407 25799.5n 0.5407 25800.0n 0.5817 26399.5n 0.5817 26400.0n 0.5243 26999.5n 0.5243 27000.0n 0.5602 27599.5n 0.5602 27600.0n 0.5213 28199.5n 0.5213 28200.0n 0.6604 28799.5n 0.6604 28800.0n 0.5050 29399.5n 0.5050 29400.0n 0.6612 29999.5n 0.6612 30000.0n 0.6667 30599.5n 0.6667 30600.0n 0.6854 31199.5n 0.6854 31200.0n 0.6780 31799.5n 0.6780 31800.0n 0.5944 32399.5n 0.5944 32400.0n 0.5775 32999.5n 0.5775 33000.0n 0.4604 33599.5n 0.4604 33600.0n 0.4742 34199.5n 0.4742 34200.0n 0.6002 34799.5n 0.6002 34800.0n 0.6752 35399.5n 0.6752 35400.0n 0.4871 35999.5n 0.4871)
Cwp_bh_23 wp_bh_23 0 400p
Cwn_bh_23 wn_bh_23 0 400p
Xu_bh_23 xp_bh_23 xn_bh_23 yp_bh_23 yn_bh_23 wp_bh_23 wn_bh_23 vdd gbn gprod
Vxp_wih_0_24 xp_wih_0_24 0 PWL(0.0n 0.4942 599.5n 0.4942 600.0n 0.5558 1199.5n 0.5558 1200.0n 0.4708 1799.5n 0.4708 1800.0n 0.5235 2399.5n 0.5235 2400.0n 0.5350 2999.5n 0.5350 3000.0n 0.5172 3599.5n 0.5172 3600.0n 0.4702 4199.5n 0.4702 4200.0n 0.4867 4799.5n 0.4867 4800.0n 0.4970 5399.5n 0.4970 5400.0n 0.4986 5999.5n 0.4986 6000.0n 0.4751 6599.5n 0.4751 6600.0n 0.4870 7199.5n 0.4870 7200.0n 0.5502 7799.5n 0.5502 7800.0n 0.5521 8399.5n 0.5521 8400.0n 0.4638 8999.5n 0.4638 9000.0n 0.4982 9599.5n 0.4982 9600.0n 0.5131 10199.5n 0.5131 10200.0n 0.5386 10799.5n 0.5386 10800.0n 0.4592 11399.5n 0.4592 11400.0n 0.4950 11999.5n 0.4950 12000.0n 0.4559 12599.5n 0.4559 12600.0n 0.5162 13199.5n 0.5162 13200.0n 0.5038 13799.5n 0.5038 13800.0n 0.5333 14399.5n 0.5333 14400.0n 0.4991 14999.5n 0.4991 15000.0n 0.5298 15599.5n 0.5298 15600.0n 0.4823 16199.5n 0.4823 16200.0n 0.5239 16799.5n 0.5239 16800.0n 0.4592 17399.5n 0.4592 17400.0n 0.5094 17999.5n 0.5094 18000.0n 0.4337 18599.5n 0.4337 18600.0n 0.5977 19199.5n 0.5977 19200.0n 0.5364 19799.5n 0.5364 19800.0n 0.6122 20399.5n 0.6122 20400.0n 0.4856 20999.5n 0.4856 21000.0n 0.3861 21599.5n 0.3861 21600.0n 0.6094 22199.5n 0.6094 22200.0n 0.6364 22799.5n 0.6364 22800.0n 0.4807 23399.5n 0.4807 23400.0n 0.5614 23999.5n 0.5614 24000.0n 0.5913 24599.5n 0.5913 24600.0n 0.6295 25199.5n 0.6295 25200.0n 0.4496 25799.5n 0.4496 25800.0n 0.3792 26399.5n 0.3792 26400.0n 0.4434 26999.5n 0.4434 27000.0n 0.4340 27599.5n 0.4340 27600.0n 0.4461 28199.5n 0.4461 28200.0n 0.5791 28799.5n 0.5791 28800.0n 0.4777 29399.5n 0.4777 29400.0n 0.3878 29999.5n 0.3878 30000.0n 0.3832 30599.5n 0.3832 30600.0n 0.4022 31199.5n 0.4022 31200.0n 0.4482 31799.5n 0.4482 31800.0n 0.3662 32399.5n 0.3662 32400.0n 0.3857 32999.5n 0.3857 33000.0n 0.5584 33599.5n 0.5584 33600.0n 0.5284 34199.5n 0.5284 34200.0n 0.6034 34799.5n 0.6034 34800.0n 0.3469 35399.5n 0.3469 35400.0n 0.5290 35999.5n 0.5290)
Vxn_wih_0_24 xn_wih_0_24 0 PWL(0.0n 0.5058 599.5n 0.5058 600.0n 0.4442 1199.5n 0.4442 1200.0n 0.5292 1799.5n 0.5292 1800.0n 0.4765 2399.5n 0.4765 2400.0n 0.4650 2999.5n 0.4650 3000.0n 0.4828 3599.5n 0.4828 3600.0n 0.5298 4199.5n 0.5298 4200.0n 0.5133 4799.5n 0.5133 4800.0n 0.5030 5399.5n 0.5030 5400.0n 0.5014 5999.5n 0.5014 6000.0n 0.5249 6599.5n 0.5249 6600.0n 0.5130 7199.5n 0.5130 7200.0n 0.4498 7799.5n 0.4498 7800.0n 0.4479 8399.5n 0.4479 8400.0n 0.5362 8999.5n 0.5362 9000.0n 0.5018 9599.5n 0.5018 9600.0n 0.4869 10199.5n 0.4869 10200.0n 0.4614 10799.5n 0.4614 10800.0n 0.5408 11399.5n 0.5408 11400.0n 0.5050 11999.5n 0.5050 12000.0n 0.5441 12599.5n 0.5441 12600.0n 0.4838 13199.5n 0.4838 13200.0n 0.4962 13799.5n 0.4962 13800.0n 0.4667 14399.5n 0.4667 14400.0n 0.5009 14999.5n 0.5009 15000.0n 0.4702 15599.5n 0.4702 15600.0n 0.5177 16199.5n 0.5177 16200.0n 0.4761 16799.5n 0.4761 16800.0n 0.5408 17399.5n 0.5408 17400.0n 0.4906 17999.5n 0.4906 18000.0n 0.5663 18599.5n 0.5663 18600.0n 0.4023 19199.5n 0.4023 19200.0n 0.4636 19799.5n 0.4636 19800.0n 0.3878 20399.5n 0.3878 20400.0n 0.5144 20999.5n 0.5144 21000.0n 0.6139 21599.5n 0.6139 21600.0n 0.3906 22199.5n 0.3906 22200.0n 0.3636 22799.5n 0.3636 22800.0n 0.5193 23399.5n 0.5193 23400.0n 0.4386 23999.5n 0.4386 24000.0n 0.4087 24599.5n 0.4087 24600.0n 0.3705 25199.5n 0.3705 25200.0n 0.5504 25799.5n 0.5504 25800.0n 0.6208 26399.5n 0.6208 26400.0n 0.5566 26999.5n 0.5566 27000.0n 0.5660 27599.5n 0.5660 27600.0n 0.5539 28199.5n 0.5539 28200.0n 0.4209 28799.5n 0.4209 28800.0n 0.5223 29399.5n 0.5223 29400.0n 0.6122 29999.5n 0.6122 30000.0n 0.6168 30599.5n 0.6168 30600.0n 0.5978 31199.5n 0.5978 31200.0n 0.5518 31799.5n 0.5518 31800.0n 0.6338 32399.5n 0.6338 32400.0n 0.6143 32999.5n 0.6143 33000.0n 0.4416 33599.5n 0.4416 33600.0n 0.4716 34199.5n 0.4716 34200.0n 0.3966 34799.5n 0.3966 34800.0n 0.6531 35399.5n 0.6531 35400.0n 0.4710 35999.5n 0.4710)
Vyp_wih_0_24 yp_wih_0_24 0 PWL(0.0n 0.5019 599.5n 0.5019 600.0n 0.4731 1199.5n 0.4731 1200.0n 0.5465 1799.5n 0.5465 1800.0n 0.5458 2399.5n 0.5458 2400.0n 0.5272 2999.5n 0.5272 3000.0n 0.5083 3599.5n 0.5083 3600.0n 0.5391 4199.5n 0.5391 4200.0n 0.5045 4799.5n 0.5045 4800.0n 0.5203 5399.5n 0.5203 5400.0n 0.5199 5999.5n 0.5199 6000.0n 0.5495 6599.5n 0.5495 6600.0n 0.5204 7199.5n 0.5204 7200.0n 0.4874 7799.5n 0.4874 7800.0n 0.4882 8399.5n 0.4882 8400.0n 0.5231 8999.5n 0.5231 9000.0n 0.5197 9599.5n 0.5197 9600.0n 0.5187 10199.5n 0.5187 10200.0n 0.5062 10799.5n 0.5062 10800.0n 0.5530 11399.5n 0.5530 11400.0n 0.5188 11999.5n 0.5188 12000.0n 0.5252 12599.5n 0.5252 12600.0n 0.5184 13199.5n 0.5184 13200.0n 0.4964 13799.5n 0.4964 13800.0n 0.4899 14399.5n 0.4899 14400.0n 0.5156 14999.5n 0.5156 15000.0n 0.5199 15599.5n 0.5199 15600.0n 0.5134 16199.5n 0.5134 16200.0n 0.4865 16799.5n 0.4865 16800.0n 0.5279 17399.5n 0.5279 17400.0n 0.4963 17999.5n 0.4963 18000.0n 0.6358 18599.5n 0.6358 18600.0n 0.4349 19199.5n 0.4349 19200.0n 0.5732 19799.5n 0.5732 19800.0n 0.4907 20399.5n 0.4907 20400.0n 0.6054 20999.5n 0.6054 21000.0n 0.6204 21599.5n 0.6204 21600.0n 0.4651 22199.5n 0.4651 22200.0n 0.4286 22799.5n 0.4286 22800.0n 0.6174 23399.5n 0.6174 23400.0n 0.3880 23999.5n 0.3880 24000.0n 0.5243 24599.5n 0.5243 24600.0n 0.4186 25199.5n 0.4186 25200.0n 0.6257 25799.5n 0.6257 25800.0n 0.6601 26399.5n 0.6601 26400.0n 0.6437 26999.5n 0.6437 27000.0n 0.6440 27599.5n 0.6440 27600.0n 0.6412 28199.5n 0.6412 28200.0n 0.3754 28799.5n 0.3754 28800.0n 0.6148 29399.5n 0.6148 29400.0n 0.6118 29999.5n 0.6118 30000.0n 0.5982 30599.5n 0.5982 30600.0n 0.5087 31199.5n 0.5087 31200.0n 0.4704 31799.5n 0.4704 31800.0n 0.6587 32399.5n 0.6587 32400.0n 0.6601 32999.5n 0.6601 33000.0n 0.5582 33599.5n 0.5582 33600.0n 0.5907 34199.5n 0.5907 34200.0n 0.4140 34799.5n 0.4140 34800.0n 0.5739 35399.5n 0.5739 35400.0n 0.5831 35999.5n 0.5831)
Vyn_wih_0_24 yn_wih_0_24 0 PWL(0.0n 0.4981 599.5n 0.4981 600.0n 0.5269 1199.5n 0.5269 1200.0n 0.4535 1799.5n 0.4535 1800.0n 0.4542 2399.5n 0.4542 2400.0n 0.4728 2999.5n 0.4728 3000.0n 0.4917 3599.5n 0.4917 3600.0n 0.4609 4199.5n 0.4609 4200.0n 0.4955 4799.5n 0.4955 4800.0n 0.4797 5399.5n 0.4797 5400.0n 0.4801 5999.5n 0.4801 6000.0n 0.4505 6599.5n 0.4505 6600.0n 0.4796 7199.5n 0.4796 7200.0n 0.5126 7799.5n 0.5126 7800.0n 0.5118 8399.5n 0.5118 8400.0n 0.4769 8999.5n 0.4769 9000.0n 0.4803 9599.5n 0.4803 9600.0n 0.4813 10199.5n 0.4813 10200.0n 0.4938 10799.5n 0.4938 10800.0n 0.4470 11399.5n 0.4470 11400.0n 0.4812 11999.5n 0.4812 12000.0n 0.4748 12599.5n 0.4748 12600.0n 0.4816 13199.5n 0.4816 13200.0n 0.5036 13799.5n 0.5036 13800.0n 0.5101 14399.5n 0.5101 14400.0n 0.4844 14999.5n 0.4844 15000.0n 0.4801 15599.5n 0.4801 15600.0n 0.4866 16199.5n 0.4866 16200.0n 0.5135 16799.5n 0.5135 16800.0n 0.4721 17399.5n 0.4721 17400.0n 0.5037 17999.5n 0.5037 18000.0n 0.3642 18599.5n 0.3642 18600.0n 0.5651 19199.5n 0.5651 19200.0n 0.4268 19799.5n 0.4268 19800.0n 0.5093 20399.5n 0.5093 20400.0n 0.3946 20999.5n 0.3946 21000.0n 0.3796 21599.5n 0.3796 21600.0n 0.5349 22199.5n 0.5349 22200.0n 0.5714 22799.5n 0.5714 22800.0n 0.3826 23399.5n 0.3826 23400.0n 0.6120 23999.5n 0.6120 24000.0n 0.4757 24599.5n 0.4757 24600.0n 0.5814 25199.5n 0.5814 25200.0n 0.3743 25799.5n 0.3743 25800.0n 0.3399 26399.5n 0.3399 26400.0n 0.3563 26999.5n 0.3563 27000.0n 0.3560 27599.5n 0.3560 27600.0n 0.3588 28199.5n 0.3588 28200.0n 0.6246 28799.5n 0.6246 28800.0n 0.3852 29399.5n 0.3852 29400.0n 0.3882 29999.5n 0.3882 30000.0n 0.4018 30599.5n 0.4018 30600.0n 0.4913 31199.5n 0.4913 31200.0n 0.5296 31799.5n 0.5296 31800.0n 0.3413 32399.5n 0.3413 32400.0n 0.3399 32999.5n 0.3399 33000.0n 0.4418 33599.5n 0.4418 33600.0n 0.4093 34199.5n 0.4093 34200.0n 0.5860 34799.5n 0.5860 34800.0n 0.4261 35399.5n 0.4261 35400.0n 0.4169 35999.5n 0.4169)
Cwp_wih_0_24 wp_wih_0_24 0 400p
Cwn_wih_0_24 wn_wih_0_24 0 400p
Xu_wih_0_24 xp_wih_0_24 xn_wih_0_24 yp_wih_0_24 yn_wih_0_24 wp_wih_0_24 wn_wih_0_24 vdd gbn gprod
Vxp_wih_1_24 xp_wih_1_24 0 PWL(0.0n 0.5370 599.5n 0.5370 600.0n 0.5167 1199.5n 0.5167 1200.0n 0.4793 1799.5n 0.4793 1800.0n 0.4441 2399.5n 0.4441 2400.0n 0.4555 2999.5n 0.4555 3000.0n 0.5055 3599.5n 0.5055 3600.0n 0.4939 4199.5n 0.4939 4200.0n 0.5385 4799.5n 0.5385 4800.0n 0.5024 5399.5n 0.5024 5400.0n 0.5015 5999.5n 0.5015 6000.0n 0.4700 6599.5n 0.4700 6600.0n 0.5120 7199.5n 0.5120 7200.0n 0.5006 7799.5n 0.5006 7800.0n 0.4950 8399.5n 0.4950 8400.0n 0.5309 8999.5n 0.5309 9000.0n 0.5023 9599.5n 0.5023 9600.0n 0.4893 10199.5n 0.4893 10200.0n 0.4837 10799.5n 0.4837 10800.0n 0.4823 11399.5n 0.4823 11400.0n 0.5074 11999.5n 0.5074 12000.0n 0.5364 12599.5n 0.5364 12600.0n 0.4868 13199.5n 0.4868 13200.0n 0.5380 13799.5n 0.5380 13800.0n 0.5220 14399.5n 0.5220 14400.0n 0.5095 14999.5n 0.5095 15000.0n 0.4705 15599.5n 0.4705 15600.0n 0.5289 16199.5n 0.5289 16200.0n 0.5368 16799.5n 0.5368 16800.0n 0.5287 17399.5n 0.5287 17400.0n 0.5342 17999.5n 0.5342 18000.0n 0.4253 18599.5n 0.4253 18600.0n 0.5119 19199.5n 0.5119 19200.0n 0.4104 19799.5n 0.4104 19800.0n 0.4314 20399.5n 0.4314 20400.0n 0.4005 20999.5n 0.4005 21000.0n 0.4696 21599.5n 0.4696 21600.0n 0.4531 22199.5n 0.4531 22200.0n 0.5039 22799.5n 0.5039 22800.0n 0.3608 23399.5n 0.3608 23400.0n 0.6273 23999.5n 0.6273 24000.0n 0.3928 24599.5n 0.3928 24600.0n 0.5253 25199.5n 0.5253 25200.0n 0.4107 25799.5n 0.4107 25800.0n 0.3947 26399.5n 0.3947 26400.0n 0.3716 26999.5n 0.3716 27000.0n 0.4111 27599.5n 0.4111 27600.0n 0.3715 28199.5n 0.3715 28200.0n 0.5939 28799.5n 0.5939 28800.0n 0.3849 29399.5n 0.3849 29400.0n 0.4835 29999.5n 0.4835 30000.0n 0.5119 30599.5n 0.5119 30600.0n 0.6226 31199.5n 0.6226 31200.0n 0.6064 31799.5n 0.6064 31800.0n 0.4115 32399.5n 0.4115 32400.0n 0.3900 32999.5n 0.3900 33000.0n 0.3958 33599.5n 0.3958 33600.0n 0.3747 34199.5n 0.3747 34200.0n 0.5423 34799.5n 0.5423 34800.0n 0.5509 35399.5n 0.5509 35400.0n 0.3990 35999.5n 0.3990)
Vxn_wih_1_24 xn_wih_1_24 0 PWL(0.0n 0.4630 599.5n 0.4630 600.0n 0.4833 1199.5n 0.4833 1200.0n 0.5207 1799.5n 0.5207 1800.0n 0.5559 2399.5n 0.5559 2400.0n 0.5445 2999.5n 0.5445 3000.0n 0.4945 3599.5n 0.4945 3600.0n 0.5061 4199.5n 0.5061 4200.0n 0.4615 4799.5n 0.4615 4800.0n 0.4976 5399.5n 0.4976 5400.0n 0.4985 5999.5n 0.4985 6000.0n 0.5300 6599.5n 0.5300 6600.0n 0.4880 7199.5n 0.4880 7200.0n 0.4994 7799.5n 0.4994 7800.0n 0.5050 8399.5n 0.5050 8400.0n 0.4691 8999.5n 0.4691 9000.0n 0.4977 9599.5n 0.4977 9600.0n 0.5107 10199.5n 0.5107 10200.0n 0.5163 10799.5n 0.5163 10800.0n 0.5177 11399.5n 0.5177 11400.0n 0.4926 11999.5n 0.4926 12000.0n 0.4636 12599.5n 0.4636 12600.0n 0.5132 13199.5n 0.5132 13200.0n 0.4620 13799.5n 0.4620 13800.0n 0.4780 14399.5n 0.4780 14400.0n 0.4905 14999.5n 0.4905 15000.0n 0.5295 15599.5n 0.5295 15600.0n 0.4711 16199.5n 0.4711 16200.0n 0.4632 16799.5n 0.4632 16800.0n 0.4713 17399.5n 0.4713 17400.0n 0.4658 17999.5n 0.4658 18000.0n 0.5747 18599.5n 0.5747 18600.0n 0.4881 19199.5n 0.4881 19200.0n 0.5896 19799.5n 0.5896 19800.0n 0.5686 20399.5n 0.5686 20400.0n 0.5995 20999.5n 0.5995 21000.0n 0.5304 21599.5n 0.5304 21600.0n 0.5469 22199.5n 0.5469 22200.0n 0.4961 22799.5n 0.4961 22800.0n 0.6392 23399.5n 0.6392 23400.0n 0.3727 23999.5n 0.3727 24000.0n 0.6072 24599.5n 0.6072 24600.0n 0.4747 25199.5n 0.4747 25200.0n 0.5893 25799.5n 0.5893 25800.0n 0.6053 26399.5n 0.6053 26400.0n 0.6284 26999.5n 0.6284 27000.0n 0.5889 27599.5n 0.5889 27600.0n 0.6285 28199.5n 0.6285 28200.0n 0.4061 28799.5n 0.4061 28800.0n 0.6151 29399.5n 0.6151 29400.0n 0.5165 29999.5n 0.5165 30000.0n 0.4881 30599.5n 0.4881 30600.0n 0.3774 31199.5n 0.3774 31200.0n 0.3936 31799.5n 0.3936 31800.0n 0.5885 32399.5n 0.5885 32400.0n 0.6100 32999.5n 0.6100 33000.0n 0.6042 33599.5n 0.6042 33600.0n 0.6253 34199.5n 0.6253 34200.0n 0.4577 34799.5n 0.4577 34800.0n 0.4491 35399.5n 0.4491 35400.0n 0.6010 35999.5n 0.6010)
Vyp_wih_1_24 yp_wih_1_24 0 PWL(0.0n 0.5019 599.5n 0.5019 600.0n 0.4731 1199.5n 0.4731 1200.0n 0.5465 1799.5n 0.5465 1800.0n 0.5458 2399.5n 0.5458 2400.0n 0.5272 2999.5n 0.5272 3000.0n 0.5083 3599.5n 0.5083 3600.0n 0.5391 4199.5n 0.5391 4200.0n 0.5045 4799.5n 0.5045 4800.0n 0.5203 5399.5n 0.5203 5400.0n 0.5199 5999.5n 0.5199 6000.0n 0.5495 6599.5n 0.5495 6600.0n 0.5204 7199.5n 0.5204 7200.0n 0.4874 7799.5n 0.4874 7800.0n 0.4882 8399.5n 0.4882 8400.0n 0.5231 8999.5n 0.5231 9000.0n 0.5197 9599.5n 0.5197 9600.0n 0.5187 10199.5n 0.5187 10200.0n 0.5062 10799.5n 0.5062 10800.0n 0.5530 11399.5n 0.5530 11400.0n 0.5188 11999.5n 0.5188 12000.0n 0.5252 12599.5n 0.5252 12600.0n 0.5184 13199.5n 0.5184 13200.0n 0.4964 13799.5n 0.4964 13800.0n 0.4899 14399.5n 0.4899 14400.0n 0.5156 14999.5n 0.5156 15000.0n 0.5199 15599.5n 0.5199 15600.0n 0.5134 16199.5n 0.5134 16200.0n 0.4865 16799.5n 0.4865 16800.0n 0.5279 17399.5n 0.5279 17400.0n 0.4963 17999.5n 0.4963 18000.0n 0.6358 18599.5n 0.6358 18600.0n 0.4349 19199.5n 0.4349 19200.0n 0.5732 19799.5n 0.5732 19800.0n 0.4907 20399.5n 0.4907 20400.0n 0.6054 20999.5n 0.6054 21000.0n 0.6204 21599.5n 0.6204 21600.0n 0.4651 22199.5n 0.4651 22200.0n 0.4286 22799.5n 0.4286 22800.0n 0.6174 23399.5n 0.6174 23400.0n 0.3880 23999.5n 0.3880 24000.0n 0.5243 24599.5n 0.5243 24600.0n 0.4186 25199.5n 0.4186 25200.0n 0.6257 25799.5n 0.6257 25800.0n 0.6601 26399.5n 0.6601 26400.0n 0.6437 26999.5n 0.6437 27000.0n 0.6440 27599.5n 0.6440 27600.0n 0.6412 28199.5n 0.6412 28200.0n 0.3754 28799.5n 0.3754 28800.0n 0.6148 29399.5n 0.6148 29400.0n 0.6118 29999.5n 0.6118 30000.0n 0.5982 30599.5n 0.5982 30600.0n 0.5087 31199.5n 0.5087 31200.0n 0.4704 31799.5n 0.4704 31800.0n 0.6587 32399.5n 0.6587 32400.0n 0.6601 32999.5n 0.6601 33000.0n 0.5582 33599.5n 0.5582 33600.0n 0.5907 34199.5n 0.5907 34200.0n 0.4140 34799.5n 0.4140 34800.0n 0.5739 35399.5n 0.5739 35400.0n 0.5831 35999.5n 0.5831)
Vyn_wih_1_24 yn_wih_1_24 0 PWL(0.0n 0.4981 599.5n 0.4981 600.0n 0.5269 1199.5n 0.5269 1200.0n 0.4535 1799.5n 0.4535 1800.0n 0.4542 2399.5n 0.4542 2400.0n 0.4728 2999.5n 0.4728 3000.0n 0.4917 3599.5n 0.4917 3600.0n 0.4609 4199.5n 0.4609 4200.0n 0.4955 4799.5n 0.4955 4800.0n 0.4797 5399.5n 0.4797 5400.0n 0.4801 5999.5n 0.4801 6000.0n 0.4505 6599.5n 0.4505 6600.0n 0.4796 7199.5n 0.4796 7200.0n 0.5126 7799.5n 0.5126 7800.0n 0.5118 8399.5n 0.5118 8400.0n 0.4769 8999.5n 0.4769 9000.0n 0.4803 9599.5n 0.4803 9600.0n 0.4813 10199.5n 0.4813 10200.0n 0.4938 10799.5n 0.4938 10800.0n 0.4470 11399.5n 0.4470 11400.0n 0.4812 11999.5n 0.4812 12000.0n 0.4748 12599.5n 0.4748 12600.0n 0.4816 13199.5n 0.4816 13200.0n 0.5036 13799.5n 0.5036 13800.0n 0.5101 14399.5n 0.5101 14400.0n 0.4844 14999.5n 0.4844 15000.0n 0.4801 15599.5n 0.4801 15600.0n 0.4866 16199.5n 0.4866 16200.0n 0.5135 16799.5n 0.5135 16800.0n 0.4721 17399.5n 0.4721 17400.0n 0.5037 17999.5n 0.5037 18000.0n 0.3642 18599.5n 0.3642 18600.0n 0.5651 19199.5n 0.5651 19200.0n 0.4268 19799.5n 0.4268 19800.0n 0.5093 20399.5n 0.5093 20400.0n 0.3946 20999.5n 0.3946 21000.0n 0.3796 21599.5n 0.3796 21600.0n 0.5349 22199.5n 0.5349 22200.0n 0.5714 22799.5n 0.5714 22800.0n 0.3826 23399.5n 0.3826 23400.0n 0.6120 23999.5n 0.6120 24000.0n 0.4757 24599.5n 0.4757 24600.0n 0.5814 25199.5n 0.5814 25200.0n 0.3743 25799.5n 0.3743 25800.0n 0.3399 26399.5n 0.3399 26400.0n 0.3563 26999.5n 0.3563 27000.0n 0.3560 27599.5n 0.3560 27600.0n 0.3588 28199.5n 0.3588 28200.0n 0.6246 28799.5n 0.6246 28800.0n 0.3852 29399.5n 0.3852 29400.0n 0.3882 29999.5n 0.3882 30000.0n 0.4018 30599.5n 0.4018 30600.0n 0.4913 31199.5n 0.4913 31200.0n 0.5296 31799.5n 0.5296 31800.0n 0.3413 32399.5n 0.3413 32400.0n 0.3399 32999.5n 0.3399 33000.0n 0.4418 33599.5n 0.4418 33600.0n 0.4093 34199.5n 0.4093 34200.0n 0.5860 34799.5n 0.5860 34800.0n 0.4261 35399.5n 0.4261 35400.0n 0.4169 35999.5n 0.4169)
Cwp_wih_1_24 wp_wih_1_24 0 400p
Cwn_wih_1_24 wn_wih_1_24 0 400p
Xu_wih_1_24 xp_wih_1_24 xn_wih_1_24 yp_wih_1_24 yn_wih_1_24 wp_wih_1_24 wn_wih_1_24 vdd gbn gprod
Vxp_who_24_0 xp_who_24_0 0 PWL(0.0n 0.5019 599.5n 0.5019 600.0n 0.4731 1199.5n 0.4731 1200.0n 0.5465 1799.5n 0.5465 1800.0n 0.5458 2399.5n 0.5458 2400.0n 0.5272 2999.5n 0.5272 3000.0n 0.5083 3599.5n 0.5083 3600.0n 0.5391 4199.5n 0.5391 4200.0n 0.5045 4799.5n 0.5045 4800.0n 0.5203 5399.5n 0.5203 5400.0n 0.5199 5999.5n 0.5199 6000.0n 0.5495 6599.5n 0.5495 6600.0n 0.5204 7199.5n 0.5204 7200.0n 0.4874 7799.5n 0.4874 7800.0n 0.4882 8399.5n 0.4882 8400.0n 0.5231 8999.5n 0.5231 9000.0n 0.5197 9599.5n 0.5197 9600.0n 0.5187 10199.5n 0.5187 10200.0n 0.5062 10799.5n 0.5062 10800.0n 0.5530 11399.5n 0.5530 11400.0n 0.5188 11999.5n 0.5188 12000.0n 0.5252 12599.5n 0.5252 12600.0n 0.5184 13199.5n 0.5184 13200.0n 0.4964 13799.5n 0.4964 13800.0n 0.4899 14399.5n 0.4899 14400.0n 0.5156 14999.5n 0.5156 15000.0n 0.5199 15599.5n 0.5199 15600.0n 0.5134 16199.5n 0.5134 16200.0n 0.4865 16799.5n 0.4865 16800.0n 0.5279 17399.5n 0.5279 17400.0n 0.4963 17999.5n 0.4963 18000.0n 0.6358 18599.5n 0.6358 18600.0n 0.4349 19199.5n 0.4349 19200.0n 0.5732 19799.5n 0.5732 19800.0n 0.4907 20399.5n 0.4907 20400.0n 0.6054 20999.5n 0.6054 21000.0n 0.6204 21599.5n 0.6204 21600.0n 0.4651 22199.5n 0.4651 22200.0n 0.4286 22799.5n 0.4286 22800.0n 0.6174 23399.5n 0.6174 23400.0n 0.3880 23999.5n 0.3880 24000.0n 0.5243 24599.5n 0.5243 24600.0n 0.4186 25199.5n 0.4186 25200.0n 0.6257 25799.5n 0.6257 25800.0n 0.6601 26399.5n 0.6601 26400.0n 0.6437 26999.5n 0.6437 27000.0n 0.6440 27599.5n 0.6440 27600.0n 0.6412 28199.5n 0.6412 28200.0n 0.3754 28799.5n 0.3754 28800.0n 0.6148 29399.5n 0.6148 29400.0n 0.6118 29999.5n 0.6118 30000.0n 0.5982 30599.5n 0.5982 30600.0n 0.5087 31199.5n 0.5087 31200.0n 0.4704 31799.5n 0.4704 31800.0n 0.6587 32399.5n 0.6587 32400.0n 0.6601 32999.5n 0.6601 33000.0n 0.5582 33599.5n 0.5582 33600.0n 0.5907 34199.5n 0.5907 34200.0n 0.4140 34799.5n 0.4140 34800.0n 0.5739 35399.5n 0.5739 35400.0n 0.5831 35999.5n 0.5831)
Vxn_who_24_0 xn_who_24_0 0 PWL(0.0n 0.4981 599.5n 0.4981 600.0n 0.5269 1199.5n 0.5269 1200.0n 0.4535 1799.5n 0.4535 1800.0n 0.4542 2399.5n 0.4542 2400.0n 0.4728 2999.5n 0.4728 3000.0n 0.4917 3599.5n 0.4917 3600.0n 0.4609 4199.5n 0.4609 4200.0n 0.4955 4799.5n 0.4955 4800.0n 0.4797 5399.5n 0.4797 5400.0n 0.4801 5999.5n 0.4801 6000.0n 0.4505 6599.5n 0.4505 6600.0n 0.4796 7199.5n 0.4796 7200.0n 0.5126 7799.5n 0.5126 7800.0n 0.5118 8399.5n 0.5118 8400.0n 0.4769 8999.5n 0.4769 9000.0n 0.4803 9599.5n 0.4803 9600.0n 0.4813 10199.5n 0.4813 10200.0n 0.4938 10799.5n 0.4938 10800.0n 0.4470 11399.5n 0.4470 11400.0n 0.4812 11999.5n 0.4812 12000.0n 0.4748 12599.5n 0.4748 12600.0n 0.4816 13199.5n 0.4816 13200.0n 0.5036 13799.5n 0.5036 13800.0n 0.5101 14399.5n 0.5101 14400.0n 0.4844 14999.5n 0.4844 15000.0n 0.4801 15599.5n 0.4801 15600.0n 0.4866 16199.5n 0.4866 16200.0n 0.5135 16799.5n 0.5135 16800.0n 0.4721 17399.5n 0.4721 17400.0n 0.5037 17999.5n 0.5037 18000.0n 0.3642 18599.5n 0.3642 18600.0n 0.5651 19199.5n 0.5651 19200.0n 0.4268 19799.5n 0.4268 19800.0n 0.5093 20399.5n 0.5093 20400.0n 0.3946 20999.5n 0.3946 21000.0n 0.3796 21599.5n 0.3796 21600.0n 0.5349 22199.5n 0.5349 22200.0n 0.5714 22799.5n 0.5714 22800.0n 0.3826 23399.5n 0.3826 23400.0n 0.6120 23999.5n 0.6120 24000.0n 0.4757 24599.5n 0.4757 24600.0n 0.5814 25199.5n 0.5814 25200.0n 0.3743 25799.5n 0.3743 25800.0n 0.3399 26399.5n 0.3399 26400.0n 0.3563 26999.5n 0.3563 27000.0n 0.3560 27599.5n 0.3560 27600.0n 0.3588 28199.5n 0.3588 28200.0n 0.6246 28799.5n 0.6246 28800.0n 0.3852 29399.5n 0.3852 29400.0n 0.3882 29999.5n 0.3882 30000.0n 0.4018 30599.5n 0.4018 30600.0n 0.4913 31199.5n 0.4913 31200.0n 0.5296 31799.5n 0.5296 31800.0n 0.3413 32399.5n 0.3413 32400.0n 0.3399 32999.5n 0.3399 33000.0n 0.4418 33599.5n 0.4418 33600.0n 0.4093 34199.5n 0.4093 34200.0n 0.5860 34799.5n 0.5860 34800.0n 0.4261 35399.5n 0.4261 35400.0n 0.4169 35999.5n 0.4169)
Vyp_who_24_0 yp_who_24_0 0 PWL(0.0n 0.5031 599.5n 0.5031 600.0n 0.5023 1199.5n 0.5023 1200.0n 0.5052 1799.5n 0.5052 1800.0n 0.5048 2399.5n 0.5048 2400.0n 0.5043 2999.5n 0.5043 3000.0n 0.5034 3599.5n 0.5034 3600.0n 0.5048 4199.5n 0.5048 4200.0n 0.5031 4799.5n 0.5031 4800.0n 0.5040 5399.5n 0.5040 5400.0n 0.5040 5999.5n 0.5040 6000.0n 0.5054 6599.5n 0.5054 6600.0n 0.5040 7199.5n 0.5040 7200.0n 0.5027 7799.5n 0.5027 7800.0n 0.5027 8399.5n 0.5027 8400.0n 0.5038 8999.5n 0.5038 9000.0n 0.5040 9599.5n 0.5040 9600.0n 0.5039 10199.5n 0.5039 10200.0n 0.5033 10799.5n 0.5033 10800.0n 0.5056 11399.5n 0.5056 11400.0n 0.5040 11999.5n 0.5040 12000.0n 0.5036 12599.5n 0.5036 12600.0n 0.5039 13199.5n 0.5039 13200.0n 0.5029 13799.5n 0.5029 13800.0n 0.5025 14399.5n 0.5025 14400.0n 0.5038 14999.5n 0.5038 15000.0n 0.5041 15599.5n 0.5041 15600.0n 0.5036 16199.5n 0.5036 16200.0n 0.5025 16799.5n 0.5025 16800.0n 0.5040 17399.5n 0.5040 17400.0n 0.5029 17999.5n 0.5029 18000.0n 0.5057 18599.5n 0.5057 18600.0n 0.5010 19199.5n 0.5010 19200.0n 0.5041 19799.5n 0.5041 19800.0n 0.5021 20399.5n 0.5021 20400.0n 0.5044 20999.5n 0.5044 21000.0n 0.5056 21599.5n 0.5056 21600.0n 0.5016 22199.5n 0.5016 22200.0n 0.5006 22799.5n 0.5006 22800.0n 0.5041 23399.5n 0.5041 23400.0n 0.5027 23999.5n 0.5027 24000.0n 0.5029 24599.5n 0.5029 24600.0n 0.5006 25199.5n 0.5006 25200.0n 0.5047 25799.5n 0.5047 25800.0n 0.5046 26399.5n 0.5046 26400.0n 0.5039 26999.5n 0.5039 27000.0n 0.5049 27599.5n 0.5049 27600.0n 0.5039 28199.5n 0.5039 28200.0n 0.5017 28799.5n 0.5017 28800.0n 0.5042 29399.5n 0.5042 29400.0n 0.5056 29999.5n 0.5056 30000.0n 0.5051 30599.5n 0.5051 30600.0n 0.5039 31199.5n 0.5039 31200.0n 0.5033 31799.5n 0.5033 31800.0n 0.5049 32399.5n 0.5049 32400.0n 0.5045 32999.5n 0.5045 33000.0n 0.5036 33599.5n 0.5036 33600.0n 0.5042 34199.5n 0.5042 34200.0n 0.5012 34799.5n 0.5012 34800.0n 0.5036 35399.5n 0.5036 35400.0n 0.5042 35999.5n 0.5042)
Vyn_who_24_0 yn_who_24_0 0 PWL(0.0n 0.4969 599.5n 0.4969 600.0n 0.4977 1199.5n 0.4977 1200.0n 0.4948 1799.5n 0.4948 1800.0n 0.4952 2399.5n 0.4952 2400.0n 0.4957 2999.5n 0.4957 3000.0n 0.4966 3599.5n 0.4966 3600.0n 0.4952 4199.5n 0.4952 4200.0n 0.4969 4799.5n 0.4969 4800.0n 0.4960 5399.5n 0.4960 5400.0n 0.4960 5999.5n 0.4960 6000.0n 0.4946 6599.5n 0.4946 6600.0n 0.4960 7199.5n 0.4960 7200.0n 0.4973 7799.5n 0.4973 7800.0n 0.4973 8399.5n 0.4973 8400.0n 0.4962 8999.5n 0.4962 9000.0n 0.4960 9599.5n 0.4960 9600.0n 0.4961 10199.5n 0.4961 10200.0n 0.4967 10799.5n 0.4967 10800.0n 0.4944 11399.5n 0.4944 11400.0n 0.4960 11999.5n 0.4960 12000.0n 0.4964 12599.5n 0.4964 12600.0n 0.4961 13199.5n 0.4961 13200.0n 0.4971 13799.5n 0.4971 13800.0n 0.4975 14399.5n 0.4975 14400.0n 0.4962 14999.5n 0.4962 15000.0n 0.4959 15599.5n 0.4959 15600.0n 0.4964 16199.5n 0.4964 16200.0n 0.4975 16799.5n 0.4975 16800.0n 0.4960 17399.5n 0.4960 17400.0n 0.4971 17999.5n 0.4971 18000.0n 0.4943 18599.5n 0.4943 18600.0n 0.4990 19199.5n 0.4990 19200.0n 0.4959 19799.5n 0.4959 19800.0n 0.4979 20399.5n 0.4979 20400.0n 0.4956 20999.5n 0.4956 21000.0n 0.4944 21599.5n 0.4944 21600.0n 0.4984 22199.5n 0.4984 22200.0n 0.4994 22799.5n 0.4994 22800.0n 0.4959 23399.5n 0.4959 23400.0n 0.4973 23999.5n 0.4973 24000.0n 0.4971 24599.5n 0.4971 24600.0n 0.4994 25199.5n 0.4994 25200.0n 0.4953 25799.5n 0.4953 25800.0n 0.4954 26399.5n 0.4954 26400.0n 0.4961 26999.5n 0.4961 27000.0n 0.4951 27599.5n 0.4951 27600.0n 0.4961 28199.5n 0.4961 28200.0n 0.4983 28799.5n 0.4983 28800.0n 0.4958 29399.5n 0.4958 29400.0n 0.4944 29999.5n 0.4944 30000.0n 0.4949 30599.5n 0.4949 30600.0n 0.4961 31199.5n 0.4961 31200.0n 0.4967 31799.5n 0.4967 31800.0n 0.4951 32399.5n 0.4951 32400.0n 0.4955 32999.5n 0.4955 33000.0n 0.4964 33599.5n 0.4964 33600.0n 0.4958 34199.5n 0.4958 34200.0n 0.4988 34799.5n 0.4988 34800.0n 0.4964 35399.5n 0.4964 35400.0n 0.4958 35999.5n 0.4958)
Cwp_who_24_0 wp_who_24_0 0 400p
Cwn_who_24_0 wn_who_24_0 0 400p
Xu_who_24_0 xp_who_24_0 xn_who_24_0 yp_who_24_0 yn_who_24_0 wp_who_24_0 wn_who_24_0 vdd gbn gprod
Vxp_who_24_1 xp_who_24_1 0 PWL(0.0n 0.5019 599.5n 0.5019 600.0n 0.4731 1199.5n 0.4731 1200.0n 0.5465 1799.5n 0.5465 1800.0n 0.5458 2399.5n 0.5458 2400.0n 0.5272 2999.5n 0.5272 3000.0n 0.5083 3599.5n 0.5083 3600.0n 0.5391 4199.5n 0.5391 4200.0n 0.5045 4799.5n 0.5045 4800.0n 0.5203 5399.5n 0.5203 5400.0n 0.5199 5999.5n 0.5199 6000.0n 0.5495 6599.5n 0.5495 6600.0n 0.5204 7199.5n 0.5204 7200.0n 0.4874 7799.5n 0.4874 7800.0n 0.4882 8399.5n 0.4882 8400.0n 0.5231 8999.5n 0.5231 9000.0n 0.5197 9599.5n 0.5197 9600.0n 0.5187 10199.5n 0.5187 10200.0n 0.5062 10799.5n 0.5062 10800.0n 0.5530 11399.5n 0.5530 11400.0n 0.5188 11999.5n 0.5188 12000.0n 0.5252 12599.5n 0.5252 12600.0n 0.5184 13199.5n 0.5184 13200.0n 0.4964 13799.5n 0.4964 13800.0n 0.4899 14399.5n 0.4899 14400.0n 0.5156 14999.5n 0.5156 15000.0n 0.5199 15599.5n 0.5199 15600.0n 0.5134 16199.5n 0.5134 16200.0n 0.4865 16799.5n 0.4865 16800.0n 0.5279 17399.5n 0.5279 17400.0n 0.4963 17999.5n 0.4963 18000.0n 0.6358 18599.5n 0.6358 18600.0n 0.4349 19199.5n 0.4349 19200.0n 0.5732 19799.5n 0.5732 19800.0n 0.4907 20399.5n 0.4907 20400.0n 0.6054 20999.5n 0.6054 21000.0n 0.6204 21599.5n 0.6204 21600.0n 0.4651 22199.5n 0.4651 22200.0n 0.4286 22799.5n 0.4286 22800.0n 0.6174 23399.5n 0.6174 23400.0n 0.3880 23999.5n 0.3880 24000.0n 0.5243 24599.5n 0.5243 24600.0n 0.4186 25199.5n 0.4186 25200.0n 0.6257 25799.5n 0.6257 25800.0n 0.6601 26399.5n 0.6601 26400.0n 0.6437 26999.5n 0.6437 27000.0n 0.6440 27599.5n 0.6440 27600.0n 0.6412 28199.5n 0.6412 28200.0n 0.3754 28799.5n 0.3754 28800.0n 0.6148 29399.5n 0.6148 29400.0n 0.6118 29999.5n 0.6118 30000.0n 0.5982 30599.5n 0.5982 30600.0n 0.5087 31199.5n 0.5087 31200.0n 0.4704 31799.5n 0.4704 31800.0n 0.6587 32399.5n 0.6587 32400.0n 0.6601 32999.5n 0.6601 33000.0n 0.5582 33599.5n 0.5582 33600.0n 0.5907 34199.5n 0.5907 34200.0n 0.4140 34799.5n 0.4140 34800.0n 0.5739 35399.5n 0.5739 35400.0n 0.5831 35999.5n 0.5831)
Vxn_who_24_1 xn_who_24_1 0 PWL(0.0n 0.4981 599.5n 0.4981 600.0n 0.5269 1199.5n 0.5269 1200.0n 0.4535 1799.5n 0.4535 1800.0n 0.4542 2399.5n 0.4542 2400.0n 0.4728 2999.5n 0.4728 3000.0n 0.4917 3599.5n 0.4917 3600.0n 0.4609 4199.5n 0.4609 4200.0n 0.4955 4799.5n 0.4955 4800.0n 0.4797 5399.5n 0.4797 5400.0n 0.4801 5999.5n 0.4801 6000.0n 0.4505 6599.5n 0.4505 6600.0n 0.4796 7199.5n 0.4796 7200.0n 0.5126 7799.5n 0.5126 7800.0n 0.5118 8399.5n 0.5118 8400.0n 0.4769 8999.5n 0.4769 9000.0n 0.4803 9599.5n 0.4803 9600.0n 0.4813 10199.5n 0.4813 10200.0n 0.4938 10799.5n 0.4938 10800.0n 0.4470 11399.5n 0.4470 11400.0n 0.4812 11999.5n 0.4812 12000.0n 0.4748 12599.5n 0.4748 12600.0n 0.4816 13199.5n 0.4816 13200.0n 0.5036 13799.5n 0.5036 13800.0n 0.5101 14399.5n 0.5101 14400.0n 0.4844 14999.5n 0.4844 15000.0n 0.4801 15599.5n 0.4801 15600.0n 0.4866 16199.5n 0.4866 16200.0n 0.5135 16799.5n 0.5135 16800.0n 0.4721 17399.5n 0.4721 17400.0n 0.5037 17999.5n 0.5037 18000.0n 0.3642 18599.5n 0.3642 18600.0n 0.5651 19199.5n 0.5651 19200.0n 0.4268 19799.5n 0.4268 19800.0n 0.5093 20399.5n 0.5093 20400.0n 0.3946 20999.5n 0.3946 21000.0n 0.3796 21599.5n 0.3796 21600.0n 0.5349 22199.5n 0.5349 22200.0n 0.5714 22799.5n 0.5714 22800.0n 0.3826 23399.5n 0.3826 23400.0n 0.6120 23999.5n 0.6120 24000.0n 0.4757 24599.5n 0.4757 24600.0n 0.5814 25199.5n 0.5814 25200.0n 0.3743 25799.5n 0.3743 25800.0n 0.3399 26399.5n 0.3399 26400.0n 0.3563 26999.5n 0.3563 27000.0n 0.3560 27599.5n 0.3560 27600.0n 0.3588 28199.5n 0.3588 28200.0n 0.6246 28799.5n 0.6246 28800.0n 0.3852 29399.5n 0.3852 29400.0n 0.3882 29999.5n 0.3882 30000.0n 0.4018 30599.5n 0.4018 30600.0n 0.4913 31199.5n 0.4913 31200.0n 0.5296 31799.5n 0.5296 31800.0n 0.3413 32399.5n 0.3413 32400.0n 0.3399 32999.5n 0.3399 33000.0n 0.4418 33599.5n 0.4418 33600.0n 0.4093 34199.5n 0.4093 34200.0n 0.5860 34799.5n 0.5860 34800.0n 0.4261 35399.5n 0.4261 35400.0n 0.4169 35999.5n 0.4169)
Vyp_who_24_1 yp_who_24_1 0 PWL(0.0n 0.5071 599.5n 0.5071 600.0n 0.5053 1199.5n 0.5053 1200.0n 0.5052 1799.5n 0.5052 1800.0n 0.5027 2399.5n 0.5027 2400.0n 0.5034 2999.5n 0.5034 3000.0n 0.5055 3599.5n 0.5055 3600.0n 0.5056 4199.5n 0.5056 4200.0n 0.5071 4799.5n 0.5071 4800.0n 0.5056 5399.5n 0.5056 5400.0n 0.5056 5999.5n 0.5056 6000.0n 0.5048 6599.5n 0.5048 6600.0n 0.5060 7199.5n 0.5060 7200.0n 0.5048 7799.5n 0.5048 7800.0n 0.5046 8399.5n 0.5046 8400.0n 0.5066 8999.5n 0.5066 9000.0n 0.5056 9599.5n 0.5056 9600.0n 0.5051 10199.5n 0.5051 10200.0n 0.5046 10799.5n 0.5046 10800.0n 0.5056 11399.5n 0.5056 11400.0n 0.5058 11999.5n 0.5058 12000.0n 0.5068 12599.5n 0.5068 12600.0n 0.5050 13199.5n 0.5050 13200.0n 0.5071 13799.5n 0.5071 13800.0n 0.5059 14399.5n 0.5059 14400.0n 0.5058 14999.5n 0.5058 15000.0n 0.5043 15599.5n 0.5043 15600.0n 0.5067 16199.5n 0.5067 16200.0n 0.5068 16799.5n 0.5068 16800.0n 0.5066 17399.5n 0.5066 17400.0n 0.5069 17999.5n 0.5069 18000.0n 0.5061 18599.5n 0.5061 18600.0n 0.5034 19199.5n 0.5034 19200.0n 0.5010 19799.5n 0.5010 19800.0n 0.4989 20399.5n 0.4989 20400.0n 0.5022 20999.5n 0.5022 21000.0n 0.5086 21599.5n 0.5086 21600.0n 0.5007 22199.5n 0.5007 22200.0n 0.5023 22799.5n 0.5023 22800.0n 0.5021 23399.5n 0.5021 23400.0n 0.5077 23999.5n 0.5077 24000.0n 0.4979 24599.5n 0.4979 24600.0n 0.5035 25199.5n 0.5035 25200.0n 0.5041 25799.5n 0.5041 25800.0n 0.5075 26399.5n 0.5075 26400.0n 0.5041 26999.5n 0.5041 27000.0n 0.5056 27599.5n 0.5056 27600.0n 0.5039 28199.5n 0.5039 28200.0n 0.5059 28799.5n 0.5059 28800.0n 0.5023 29399.5n 0.5023 29400.0n 0.5086 29999.5n 0.5086 30000.0n 0.5084 30599.5n 0.5084 30600.0n 0.5085 31199.5n 0.5085 31200.0n 0.5088 31799.5n 0.5088 31800.0n 0.5078 32399.5n 0.5078 32400.0n 0.5074 32999.5n 0.5074 33000.0n 0.4996 33599.5n 0.4996 33600.0n 0.5010 34199.5n 0.5010 34200.0n 0.5044 34799.5n 0.5044 34800.0n 0.5084 35399.5n 0.5084 35400.0n 0.5012 35999.5n 0.5012)
Vyn_who_24_1 yn_who_24_1 0 PWL(0.0n 0.4929 599.5n 0.4929 600.0n 0.4947 1199.5n 0.4947 1200.0n 0.4948 1799.5n 0.4948 1800.0n 0.4973 2399.5n 0.4973 2400.0n 0.4966 2999.5n 0.4966 3000.0n 0.4945 3599.5n 0.4945 3600.0n 0.4944 4199.5n 0.4944 4200.0n 0.4929 4799.5n 0.4929 4800.0n 0.4944 5399.5n 0.4944 5400.0n 0.4944 5999.5n 0.4944 6000.0n 0.4952 6599.5n 0.4952 6600.0n 0.4940 7199.5n 0.4940 7200.0n 0.4952 7799.5n 0.4952 7800.0n 0.4954 8399.5n 0.4954 8400.0n 0.4934 8999.5n 0.4934 9000.0n 0.4944 9599.5n 0.4944 9600.0n 0.4949 10199.5n 0.4949 10200.0n 0.4954 10799.5n 0.4954 10800.0n 0.4944 11399.5n 0.4944 11400.0n 0.4942 11999.5n 0.4942 12000.0n 0.4932 12599.5n 0.4932 12600.0n 0.4950 13199.5n 0.4950 13200.0n 0.4929 13799.5n 0.4929 13800.0n 0.4941 14399.5n 0.4941 14400.0n 0.4942 14999.5n 0.4942 15000.0n 0.4957 15599.5n 0.4957 15600.0n 0.4933 16199.5n 0.4933 16200.0n 0.4932 16799.5n 0.4932 16800.0n 0.4934 17399.5n 0.4934 17400.0n 0.4931 17999.5n 0.4931 18000.0n 0.4939 18599.5n 0.4939 18600.0n 0.4966 19199.5n 0.4966 19200.0n 0.4990 19799.5n 0.4990 19800.0n 0.5011 20399.5n 0.5011 20400.0n 0.4978 20999.5n 0.4978 21000.0n 0.4914 21599.5n 0.4914 21600.0n 0.4993 22199.5n 0.4993 22200.0n 0.4977 22799.5n 0.4977 22800.0n 0.4979 23399.5n 0.4979 23400.0n 0.4923 23999.5n 0.4923 24000.0n 0.5021 24599.5n 0.5021 24600.0n 0.4965 25199.5n 0.4965 25200.0n 0.4959 25799.5n 0.4959 25800.0n 0.4925 26399.5n 0.4925 26400.0n 0.4959 26999.5n 0.4959 27000.0n 0.4944 27599.5n 0.4944 27600.0n 0.4961 28199.5n 0.4961 28200.0n 0.4941 28799.5n 0.4941 28800.0n 0.4977 29399.5n 0.4977 29400.0n 0.4914 29999.5n 0.4914 30000.0n 0.4916 30599.5n 0.4916 30600.0n 0.4915 31199.5n 0.4915 31200.0n 0.4912 31799.5n 0.4912 31800.0n 0.4922 32399.5n 0.4922 32400.0n 0.4926 32999.5n 0.4926 33000.0n 0.5004 33599.5n 0.5004 33600.0n 0.4990 34199.5n 0.4990 34200.0n 0.4956 34799.5n 0.4956 34800.0n 0.4916 35399.5n 0.4916 35400.0n 0.4988 35999.5n 0.4988)
Cwp_who_24_1 wp_who_24_1 0 400p
Cwn_who_24_1 wn_who_24_1 0 400p
Xu_who_24_1 xp_who_24_1 xn_who_24_1 yp_who_24_1 yn_who_24_1 wp_who_24_1 wn_who_24_1 vdd gbn gprod
Vxp_bh_24 xp_bh_24 0 PWL(0.0n 0.7100 599.5n 0.7100 600.0n 0.7100 1199.5n 0.7100 1200.0n 0.7100 1799.5n 0.7100 1800.0n 0.7100 2399.5n 0.7100 2400.0n 0.7100 2999.5n 0.7100 3000.0n 0.7100 3599.5n 0.7100 3600.0n 0.7100 4199.5n 0.7100 4200.0n 0.7100 4799.5n 0.7100 4800.0n 0.7100 5399.5n 0.7100 5400.0n 0.7100 5999.5n 0.7100 6000.0n 0.7100 6599.5n 0.7100 6600.0n 0.7100 7199.5n 0.7100 7200.0n 0.7100 7799.5n 0.7100 7800.0n 0.7100 8399.5n 0.7100 8400.0n 0.7100 8999.5n 0.7100 9000.0n 0.7100 9599.5n 0.7100 9600.0n 0.7100 10199.5n 0.7100 10200.0n 0.7100 10799.5n 0.7100 10800.0n 0.7100 11399.5n 0.7100 11400.0n 0.7100 11999.5n 0.7100 12000.0n 0.7100 12599.5n 0.7100 12600.0n 0.7100 13199.5n 0.7100 13200.0n 0.7100 13799.5n 0.7100 13800.0n 0.7100 14399.5n 0.7100 14400.0n 0.7100 14999.5n 0.7100 15000.0n 0.7100 15599.5n 0.7100 15600.0n 0.7100 16199.5n 0.7100 16200.0n 0.7100 16799.5n 0.7100 16800.0n 0.7100 17399.5n 0.7100 17400.0n 0.7100 17999.5n 0.7100 18000.0n 0.7100 18599.5n 0.7100 18600.0n 0.7100 19199.5n 0.7100 19200.0n 0.7100 19799.5n 0.7100 19800.0n 0.7100 20399.5n 0.7100 20400.0n 0.7100 20999.5n 0.7100 21000.0n 0.7100 21599.5n 0.7100 21600.0n 0.7100 22199.5n 0.7100 22200.0n 0.7100 22799.5n 0.7100 22800.0n 0.7100 23399.5n 0.7100 23400.0n 0.7100 23999.5n 0.7100 24000.0n 0.7100 24599.5n 0.7100 24600.0n 0.7100 25199.5n 0.7100 25200.0n 0.7100 25799.5n 0.7100 25800.0n 0.7100 26399.5n 0.7100 26400.0n 0.7100 26999.5n 0.7100 27000.0n 0.7100 27599.5n 0.7100 27600.0n 0.7100 28199.5n 0.7100 28200.0n 0.7100 28799.5n 0.7100 28800.0n 0.7100 29399.5n 0.7100 29400.0n 0.7100 29999.5n 0.7100 30000.0n 0.7100 30599.5n 0.7100 30600.0n 0.7100 31199.5n 0.7100 31200.0n 0.7100 31799.5n 0.7100 31800.0n 0.7100 32399.5n 0.7100 32400.0n 0.7100 32999.5n 0.7100 33000.0n 0.7100 33599.5n 0.7100 33600.0n 0.7100 34199.5n 0.7100 34200.0n 0.7100 34799.5n 0.7100 34800.0n 0.7100 35399.5n 0.7100 35400.0n 0.7100 35999.5n 0.7100)
Vxn_bh_24 xn_bh_24 0 PWL(0.0n 0.2900 599.5n 0.2900 600.0n 0.2900 1199.5n 0.2900 1200.0n 0.2900 1799.5n 0.2900 1800.0n 0.2900 2399.5n 0.2900 2400.0n 0.2900 2999.5n 0.2900 3000.0n 0.2900 3599.5n 0.2900 3600.0n 0.2900 4199.5n 0.2900 4200.0n 0.2900 4799.5n 0.2900 4800.0n 0.2900 5399.5n 0.2900 5400.0n 0.2900 5999.5n 0.2900 6000.0n 0.2900 6599.5n 0.2900 6600.0n 0.2900 7199.5n 0.2900 7200.0n 0.2900 7799.5n 0.2900 7800.0n 0.2900 8399.5n 0.2900 8400.0n 0.2900 8999.5n 0.2900 9000.0n 0.2900 9599.5n 0.2900 9600.0n 0.2900 10199.5n 0.2900 10200.0n 0.2900 10799.5n 0.2900 10800.0n 0.2900 11399.5n 0.2900 11400.0n 0.2900 11999.5n 0.2900 12000.0n 0.2900 12599.5n 0.2900 12600.0n 0.2900 13199.5n 0.2900 13200.0n 0.2900 13799.5n 0.2900 13800.0n 0.2900 14399.5n 0.2900 14400.0n 0.2900 14999.5n 0.2900 15000.0n 0.2900 15599.5n 0.2900 15600.0n 0.2900 16199.5n 0.2900 16200.0n 0.2900 16799.5n 0.2900 16800.0n 0.2900 17399.5n 0.2900 17400.0n 0.2900 17999.5n 0.2900 18000.0n 0.2900 18599.5n 0.2900 18600.0n 0.2900 19199.5n 0.2900 19200.0n 0.2900 19799.5n 0.2900 19800.0n 0.2900 20399.5n 0.2900 20400.0n 0.2900 20999.5n 0.2900 21000.0n 0.2900 21599.5n 0.2900 21600.0n 0.2900 22199.5n 0.2900 22200.0n 0.2900 22799.5n 0.2900 22800.0n 0.2900 23399.5n 0.2900 23400.0n 0.2900 23999.5n 0.2900 24000.0n 0.2900 24599.5n 0.2900 24600.0n 0.2900 25199.5n 0.2900 25200.0n 0.2900 25799.5n 0.2900 25800.0n 0.2900 26399.5n 0.2900 26400.0n 0.2900 26999.5n 0.2900 27000.0n 0.2900 27599.5n 0.2900 27600.0n 0.2900 28199.5n 0.2900 28200.0n 0.2900 28799.5n 0.2900 28800.0n 0.2900 29399.5n 0.2900 29400.0n 0.2900 29999.5n 0.2900 30000.0n 0.2900 30599.5n 0.2900 30600.0n 0.2900 31199.5n 0.2900 31200.0n 0.2900 31799.5n 0.2900 31800.0n 0.2900 32399.5n 0.2900 32400.0n 0.2900 32999.5n 0.2900 33000.0n 0.2900 33599.5n 0.2900 33600.0n 0.2900 34199.5n 0.2900 34200.0n 0.2900 34799.5n 0.2900 34800.0n 0.2900 35399.5n 0.2900 35400.0n 0.2900 35999.5n 0.2900)
Vyp_bh_24 yp_bh_24 0 PWL(0.0n 0.5019 599.5n 0.5019 600.0n 0.4731 1199.5n 0.4731 1200.0n 0.5465 1799.5n 0.5465 1800.0n 0.5458 2399.5n 0.5458 2400.0n 0.5272 2999.5n 0.5272 3000.0n 0.5083 3599.5n 0.5083 3600.0n 0.5391 4199.5n 0.5391 4200.0n 0.5045 4799.5n 0.5045 4800.0n 0.5203 5399.5n 0.5203 5400.0n 0.5199 5999.5n 0.5199 6000.0n 0.5495 6599.5n 0.5495 6600.0n 0.5204 7199.5n 0.5204 7200.0n 0.4874 7799.5n 0.4874 7800.0n 0.4882 8399.5n 0.4882 8400.0n 0.5231 8999.5n 0.5231 9000.0n 0.5197 9599.5n 0.5197 9600.0n 0.5187 10199.5n 0.5187 10200.0n 0.5062 10799.5n 0.5062 10800.0n 0.5530 11399.5n 0.5530 11400.0n 0.5188 11999.5n 0.5188 12000.0n 0.5252 12599.5n 0.5252 12600.0n 0.5184 13199.5n 0.5184 13200.0n 0.4964 13799.5n 0.4964 13800.0n 0.4899 14399.5n 0.4899 14400.0n 0.5156 14999.5n 0.5156 15000.0n 0.5199 15599.5n 0.5199 15600.0n 0.5134 16199.5n 0.5134 16200.0n 0.4865 16799.5n 0.4865 16800.0n 0.5279 17399.5n 0.5279 17400.0n 0.4963 17999.5n 0.4963 18000.0n 0.6358 18599.5n 0.6358 18600.0n 0.4349 19199.5n 0.4349 19200.0n 0.5732 19799.5n 0.5732 19800.0n 0.4907 20399.5n 0.4907 20400.0n 0.6054 20999.5n 0.6054 21000.0n 0.6204 21599.5n 0.6204 21600.0n 0.4651 22199.5n 0.4651 22200.0n 0.4286 22799.5n 0.4286 22800.0n 0.6174 23399.5n 0.6174 23400.0n 0.3880 23999.5n 0.3880 24000.0n 0.5243 24599.5n 0.5243 24600.0n 0.4186 25199.5n 0.4186 25200.0n 0.6257 25799.5n 0.6257 25800.0n 0.6601 26399.5n 0.6601 26400.0n 0.6437 26999.5n 0.6437 27000.0n 0.6440 27599.5n 0.6440 27600.0n 0.6412 28199.5n 0.6412 28200.0n 0.3754 28799.5n 0.3754 28800.0n 0.6148 29399.5n 0.6148 29400.0n 0.6118 29999.5n 0.6118 30000.0n 0.5982 30599.5n 0.5982 30600.0n 0.5087 31199.5n 0.5087 31200.0n 0.4704 31799.5n 0.4704 31800.0n 0.6587 32399.5n 0.6587 32400.0n 0.6601 32999.5n 0.6601 33000.0n 0.5582 33599.5n 0.5582 33600.0n 0.5907 34199.5n 0.5907 34200.0n 0.4140 34799.5n 0.4140 34800.0n 0.5739 35399.5n 0.5739 35400.0n 0.5831 35999.5n 0.5831)
Vyn_bh_24 yn_bh_24 0 PWL(0.0n 0.4981 599.5n 0.4981 600.0n 0.5269 1199.5n 0.5269 1200.0n 0.4535 1799.5n 0.4535 1800.0n 0.4542 2399.5n 0.4542 2400.0n 0.4728 2999.5n 0.4728 3000.0n 0.4917 3599.5n 0.4917 3600.0n 0.4609 4199.5n 0.4609 4200.0n 0.4955 4799.5n 0.4955 4800.0n 0.4797 5399.5n 0.4797 5400.0n 0.4801 5999.5n 0.4801 6000.0n 0.4505 6599.5n 0.4505 6600.0n 0.4796 7199.5n 0.4796 7200.0n 0.5126 7799.5n 0.5126 7800.0n 0.5118 8399.5n 0.5118 8400.0n 0.4769 8999.5n 0.4769 9000.0n 0.4803 9599.5n 0.4803 9600.0n 0.4813 10199.5n 0.4813 10200.0n 0.4938 10799.5n 0.4938 10800.0n 0.4470 11399.5n 0.4470 11400.0n 0.4812 11999.5n 0.4812 12000.0n 0.4748 12599.5n 0.4748 12600.0n 0.4816 13199.5n 0.4816 13200.0n 0.5036 13799.5n 0.5036 13800.0n 0.5101 14399.5n 0.5101 14400.0n 0.4844 14999.5n 0.4844 15000.0n 0.4801 15599.5n 0.4801 15600.0n 0.4866 16199.5n 0.4866 16200.0n 0.5135 16799.5n 0.5135 16800.0n 0.4721 17399.5n 0.4721 17400.0n 0.5037 17999.5n 0.5037 18000.0n 0.3642 18599.5n 0.3642 18600.0n 0.5651 19199.5n 0.5651 19200.0n 0.4268 19799.5n 0.4268 19800.0n 0.5093 20399.5n 0.5093 20400.0n 0.3946 20999.5n 0.3946 21000.0n 0.3796 21599.5n 0.3796 21600.0n 0.5349 22199.5n 0.5349 22200.0n 0.5714 22799.5n 0.5714 22800.0n 0.3826 23399.5n 0.3826 23400.0n 0.6120 23999.5n 0.6120 24000.0n 0.4757 24599.5n 0.4757 24600.0n 0.5814 25199.5n 0.5814 25200.0n 0.3743 25799.5n 0.3743 25800.0n 0.3399 26399.5n 0.3399 26400.0n 0.3563 26999.5n 0.3563 27000.0n 0.3560 27599.5n 0.3560 27600.0n 0.3588 28199.5n 0.3588 28200.0n 0.6246 28799.5n 0.6246 28800.0n 0.3852 29399.5n 0.3852 29400.0n 0.3882 29999.5n 0.3882 30000.0n 0.4018 30599.5n 0.4018 30600.0n 0.4913 31199.5n 0.4913 31200.0n 0.5296 31799.5n 0.5296 31800.0n 0.3413 32399.5n 0.3413 32400.0n 0.3399 32999.5n 0.3399 33000.0n 0.4418 33599.5n 0.4418 33600.0n 0.4093 34199.5n 0.4093 34200.0n 0.5860 34799.5n 0.5860 34800.0n 0.4261 35399.5n 0.4261 35400.0n 0.4169 35999.5n 0.4169)
Cwp_bh_24 wp_bh_24 0 400p
Cwn_bh_24 wn_bh_24 0 400p
Xu_bh_24 xp_bh_24 xn_bh_24 yp_bh_24 yn_bh_24 wp_bh_24 wn_bh_24 vdd gbn gprod
Vxp_wih_0_25 xp_wih_0_25 0 PWL(0.0n 0.4942 599.5n 0.4942 600.0n 0.5558 1199.5n 0.5558 1200.0n 0.4708 1799.5n 0.4708 1800.0n 0.5235 2399.5n 0.5235 2400.0n 0.5350 2999.5n 0.5350 3000.0n 0.5172 3599.5n 0.5172 3600.0n 0.4702 4199.5n 0.4702 4200.0n 0.4867 4799.5n 0.4867 4800.0n 0.4970 5399.5n 0.4970 5400.0n 0.4986 5999.5n 0.4986 6000.0n 0.4751 6599.5n 0.4751 6600.0n 0.4870 7199.5n 0.4870 7200.0n 0.5502 7799.5n 0.5502 7800.0n 0.5521 8399.5n 0.5521 8400.0n 0.4638 8999.5n 0.4638 9000.0n 0.4982 9599.5n 0.4982 9600.0n 0.5131 10199.5n 0.5131 10200.0n 0.5386 10799.5n 0.5386 10800.0n 0.4592 11399.5n 0.4592 11400.0n 0.4950 11999.5n 0.4950 12000.0n 0.4559 12599.5n 0.4559 12600.0n 0.5162 13199.5n 0.5162 13200.0n 0.5038 13799.5n 0.5038 13800.0n 0.5333 14399.5n 0.5333 14400.0n 0.4991 14999.5n 0.4991 15000.0n 0.5298 15599.5n 0.5298 15600.0n 0.4823 16199.5n 0.4823 16200.0n 0.5239 16799.5n 0.5239 16800.0n 0.4592 17399.5n 0.4592 17400.0n 0.5094 17999.5n 0.5094 18000.0n 0.4337 18599.5n 0.4337 18600.0n 0.5977 19199.5n 0.5977 19200.0n 0.5364 19799.5n 0.5364 19800.0n 0.6122 20399.5n 0.6122 20400.0n 0.4856 20999.5n 0.4856 21000.0n 0.3861 21599.5n 0.3861 21600.0n 0.6094 22199.5n 0.6094 22200.0n 0.6364 22799.5n 0.6364 22800.0n 0.4807 23399.5n 0.4807 23400.0n 0.5614 23999.5n 0.5614 24000.0n 0.5913 24599.5n 0.5913 24600.0n 0.6295 25199.5n 0.6295 25200.0n 0.4496 25799.5n 0.4496 25800.0n 0.3792 26399.5n 0.3792 26400.0n 0.4434 26999.5n 0.4434 27000.0n 0.4340 27599.5n 0.4340 27600.0n 0.4461 28199.5n 0.4461 28200.0n 0.5791 28799.5n 0.5791 28800.0n 0.4777 29399.5n 0.4777 29400.0n 0.3878 29999.5n 0.3878 30000.0n 0.3832 30599.5n 0.3832 30600.0n 0.4022 31199.5n 0.4022 31200.0n 0.4482 31799.5n 0.4482 31800.0n 0.3662 32399.5n 0.3662 32400.0n 0.3857 32999.5n 0.3857 33000.0n 0.5584 33599.5n 0.5584 33600.0n 0.5284 34199.5n 0.5284 34200.0n 0.6034 34799.5n 0.6034 34800.0n 0.3469 35399.5n 0.3469 35400.0n 0.5290 35999.5n 0.5290)
Vxn_wih_0_25 xn_wih_0_25 0 PWL(0.0n 0.5058 599.5n 0.5058 600.0n 0.4442 1199.5n 0.4442 1200.0n 0.5292 1799.5n 0.5292 1800.0n 0.4765 2399.5n 0.4765 2400.0n 0.4650 2999.5n 0.4650 3000.0n 0.4828 3599.5n 0.4828 3600.0n 0.5298 4199.5n 0.5298 4200.0n 0.5133 4799.5n 0.5133 4800.0n 0.5030 5399.5n 0.5030 5400.0n 0.5014 5999.5n 0.5014 6000.0n 0.5249 6599.5n 0.5249 6600.0n 0.5130 7199.5n 0.5130 7200.0n 0.4498 7799.5n 0.4498 7800.0n 0.4479 8399.5n 0.4479 8400.0n 0.5362 8999.5n 0.5362 9000.0n 0.5018 9599.5n 0.5018 9600.0n 0.4869 10199.5n 0.4869 10200.0n 0.4614 10799.5n 0.4614 10800.0n 0.5408 11399.5n 0.5408 11400.0n 0.5050 11999.5n 0.5050 12000.0n 0.5441 12599.5n 0.5441 12600.0n 0.4838 13199.5n 0.4838 13200.0n 0.4962 13799.5n 0.4962 13800.0n 0.4667 14399.5n 0.4667 14400.0n 0.5009 14999.5n 0.5009 15000.0n 0.4702 15599.5n 0.4702 15600.0n 0.5177 16199.5n 0.5177 16200.0n 0.4761 16799.5n 0.4761 16800.0n 0.5408 17399.5n 0.5408 17400.0n 0.4906 17999.5n 0.4906 18000.0n 0.5663 18599.5n 0.5663 18600.0n 0.4023 19199.5n 0.4023 19200.0n 0.4636 19799.5n 0.4636 19800.0n 0.3878 20399.5n 0.3878 20400.0n 0.5144 20999.5n 0.5144 21000.0n 0.6139 21599.5n 0.6139 21600.0n 0.3906 22199.5n 0.3906 22200.0n 0.3636 22799.5n 0.3636 22800.0n 0.5193 23399.5n 0.5193 23400.0n 0.4386 23999.5n 0.4386 24000.0n 0.4087 24599.5n 0.4087 24600.0n 0.3705 25199.5n 0.3705 25200.0n 0.5504 25799.5n 0.5504 25800.0n 0.6208 26399.5n 0.6208 26400.0n 0.5566 26999.5n 0.5566 27000.0n 0.5660 27599.5n 0.5660 27600.0n 0.5539 28199.5n 0.5539 28200.0n 0.4209 28799.5n 0.4209 28800.0n 0.5223 29399.5n 0.5223 29400.0n 0.6122 29999.5n 0.6122 30000.0n 0.6168 30599.5n 0.6168 30600.0n 0.5978 31199.5n 0.5978 31200.0n 0.5518 31799.5n 0.5518 31800.0n 0.6338 32399.5n 0.6338 32400.0n 0.6143 32999.5n 0.6143 33000.0n 0.4416 33599.5n 0.4416 33600.0n 0.4716 34199.5n 0.4716 34200.0n 0.3966 34799.5n 0.3966 34800.0n 0.6531 35399.5n 0.6531 35400.0n 0.4710 35999.5n 0.4710)
Vyp_wih_0_25 yp_wih_0_25 0 PWL(0.0n 0.6460 599.5n 0.6460 600.0n 0.6522 1199.5n 0.6522 1200.0n 0.5797 1799.5n 0.5797 1800.0n 0.5554 2399.5n 0.5554 2400.0n 0.5829 2999.5n 0.5829 3000.0n 0.6275 3599.5n 0.6275 3600.0n 0.5937 4199.5n 0.5937 4200.0n 0.6453 4799.5n 0.6453 4800.0n 0.6153 5399.5n 0.6153 5400.0n 0.6152 5999.5n 0.6152 6000.0n 0.5718 6599.5n 0.5718 6600.0n 0.6194 7199.5n 0.6194 7200.0n 0.6428 7799.5n 0.6428 7800.0n 0.6404 8399.5n 0.6404 8400.0n 0.6261 8999.5n 0.6261 9000.0n 0.6158 9599.5n 0.6158 9600.0n 0.6107 10199.5n 0.6107 10200.0n 0.6193 10799.5n 0.6193 10800.0n 0.5752 11399.5n 0.5752 11400.0n 0.6189 11999.5n 0.6189 12000.0n 0.6271 12599.5n 0.6271 12600.0n 0.6098 13199.5n 0.6098 13200.0n 0.6487 13799.5n 0.6487 13800.0n 0.6472 14399.5n 0.6472 14400.0n 0.6228 14999.5n 0.6228 15000.0n 0.5999 15599.5n 0.5999 15600.0n 0.6343 16199.5n 0.6343 16200.0n 0.6518 16799.5n 0.6518 16800.0n 0.6203 17399.5n 0.6203 17400.0n 0.6477 17999.5n 0.6477 18000.0n 0.4594 18599.5n 0.4594 18600.0n 0.6617 19199.5n 0.6617 19200.0n 0.5108 19799.5n 0.5108 19800.0n 0.5958 20399.5n 0.5958 20400.0n 0.4783 20999.5n 0.4783 21000.0n 0.5041 21599.5n 0.5041 21600.0n 0.6360 22199.5n 0.6360 22200.0n 0.6623 22799.5n 0.6623 22800.0n 0.4560 23399.5n 0.4560 23400.0n 0.6793 23999.5n 0.6793 24000.0n 0.5509 24599.5n 0.5509 24600.0n 0.6665 25199.5n 0.6665 25200.0n 0.4618 25799.5n 0.4618 25800.0n 0.4034 26399.5n 0.4034 26400.0n 0.4341 26999.5n 0.4341 27000.0n 0.4439 27599.5n 0.4439 27600.0n 0.4369 28199.5n 0.4369 28200.0n 0.6792 28799.5n 0.6792 28800.0n 0.4654 29399.5n 0.4654 29400.0n 0.5197 29999.5n 0.5197 30000.0n 0.5452 30599.5n 0.5452 30600.0n 0.6586 31199.5n 0.6586 31200.0n 0.6656 31799.5n 0.6656 31800.0n 0.4115 32399.5n 0.4115 32400.0n 0.4024 32999.5n 0.4024 33000.0n 0.5206 33599.5n 0.5206 33600.0n 0.4852 34199.5n 0.4852 34200.0n 0.6690 34799.5n 0.6690 34800.0n 0.5903 35399.5n 0.5903 35400.0n 0.4988 35999.5n 0.4988)
Vyn_wih_0_25 yn_wih_0_25 0 PWL(0.0n 0.3540 599.5n 0.3540 600.0n 0.3478 1199.5n 0.3478 1200.0n 0.4203 1799.5n 0.4203 1800.0n 0.4446 2399.5n 0.4446 2400.0n 0.4171 2999.5n 0.4171 3000.0n 0.3725 3599.5n 0.3725 3600.0n 0.4063 4199.5n 0.4063 4200.0n 0.3547 4799.5n 0.3547 4800.0n 0.3847 5399.5n 0.3847 5400.0n 0.3848 5999.5n 0.3848 6000.0n 0.4282 6599.5n 0.4282 6600.0n 0.3806 7199.5n 0.3806 7200.0n 0.3572 7799.5n 0.3572 7800.0n 0.3596 8399.5n 0.3596 8400.0n 0.3739 8999.5n 0.3739 9000.0n 0.3842 9599.5n 0.3842 9600.0n 0.3893 10199.5n 0.3893 10200.0n 0.3807 10799.5n 0.3807 10800.0n 0.4248 11399.5n 0.4248 11400.0n 0.3811 11999.5n 0.3811 12000.0n 0.3729 12599.5n 0.3729 12600.0n 0.3902 13199.5n 0.3902 13200.0n 0.3513 13799.5n 0.3513 13800.0n 0.3528 14399.5n 0.3528 14400.0n 0.3772 14999.5n 0.3772 15000.0n 0.4001 15599.5n 0.4001 15600.0n 0.3657 16199.5n 0.3657 16200.0n 0.3482 16799.5n 0.3482 16800.0n 0.3797 17399.5n 0.3797 17400.0n 0.3523 17999.5n 0.3523 18000.0n 0.5406 18599.5n 0.5406 18600.0n 0.3383 19199.5n 0.3383 19200.0n 0.4892 19799.5n 0.4892 19800.0n 0.4042 20399.5n 0.4042 20400.0n 0.5217 20999.5n 0.5217 21000.0n 0.4959 21599.5n 0.4959 21600.0n 0.3640 22199.5n 0.3640 22200.0n 0.3377 22799.5n 0.3377 22800.0n 0.5440 23399.5n 0.5440 23400.0n 0.3207 23999.5n 0.3207 24000.0n 0.4491 24599.5n 0.4491 24600.0n 0.3335 25199.5n 0.3335 25200.0n 0.5382 25799.5n 0.5382 25800.0n 0.5966 26399.5n 0.5966 26400.0n 0.5659 26999.5n 0.5659 27000.0n 0.5561 27599.5n 0.5561 27600.0n 0.5631 28199.5n 0.5631 28200.0n 0.3208 28799.5n 0.3208 28800.0n 0.5346 29399.5n 0.5346 29400.0n 0.4803 29999.5n 0.4803 30000.0n 0.4548 30599.5n 0.4548 30600.0n 0.3414 31199.5n 0.3414 31200.0n 0.3344 31799.5n 0.3344 31800.0n 0.5885 32399.5n 0.5885 32400.0n 0.5976 32999.5n 0.5976 33000.0n 0.4794 33599.5n 0.4794 33600.0n 0.5148 34199.5n 0.5148 34200.0n 0.3310 34799.5n 0.3310 34800.0n 0.4097 35399.5n 0.4097 35400.0n 0.5012 35999.5n 0.5012)
Cwp_wih_0_25 wp_wih_0_25 0 400p
Cwn_wih_0_25 wn_wih_0_25 0 400p
Xu_wih_0_25 xp_wih_0_25 xn_wih_0_25 yp_wih_0_25 yn_wih_0_25 wp_wih_0_25 wn_wih_0_25 vdd gbn gprod
Vxp_wih_1_25 xp_wih_1_25 0 PWL(0.0n 0.5370 599.5n 0.5370 600.0n 0.5167 1199.5n 0.5167 1200.0n 0.4793 1799.5n 0.4793 1800.0n 0.4441 2399.5n 0.4441 2400.0n 0.4555 2999.5n 0.4555 3000.0n 0.5055 3599.5n 0.5055 3600.0n 0.4939 4199.5n 0.4939 4200.0n 0.5385 4799.5n 0.5385 4800.0n 0.5024 5399.5n 0.5024 5400.0n 0.5015 5999.5n 0.5015 6000.0n 0.4700 6599.5n 0.4700 6600.0n 0.5120 7199.5n 0.5120 7200.0n 0.5006 7799.5n 0.5006 7800.0n 0.4950 8399.5n 0.4950 8400.0n 0.5309 8999.5n 0.5309 9000.0n 0.5023 9599.5n 0.5023 9600.0n 0.4893 10199.5n 0.4893 10200.0n 0.4837 10799.5n 0.4837 10800.0n 0.4823 11399.5n 0.4823 11400.0n 0.5074 11999.5n 0.5074 12000.0n 0.5364 12599.5n 0.5364 12600.0n 0.4868 13199.5n 0.4868 13200.0n 0.5380 13799.5n 0.5380 13800.0n 0.5220 14399.5n 0.5220 14400.0n 0.5095 14999.5n 0.5095 15000.0n 0.4705 15599.5n 0.4705 15600.0n 0.5289 16199.5n 0.5289 16200.0n 0.5368 16799.5n 0.5368 16800.0n 0.5287 17399.5n 0.5287 17400.0n 0.5342 17999.5n 0.5342 18000.0n 0.4253 18599.5n 0.4253 18600.0n 0.5119 19199.5n 0.5119 19200.0n 0.4104 19799.5n 0.4104 19800.0n 0.4314 20399.5n 0.4314 20400.0n 0.4005 20999.5n 0.4005 21000.0n 0.4696 21599.5n 0.4696 21600.0n 0.4531 22199.5n 0.4531 22200.0n 0.5039 22799.5n 0.5039 22800.0n 0.3608 23399.5n 0.3608 23400.0n 0.6273 23999.5n 0.6273 24000.0n 0.3928 24599.5n 0.3928 24600.0n 0.5253 25199.5n 0.5253 25200.0n 0.4107 25799.5n 0.4107 25800.0n 0.3947 26399.5n 0.3947 26400.0n 0.3716 26999.5n 0.3716 27000.0n 0.4111 27599.5n 0.4111 27600.0n 0.3715 28199.5n 0.3715 28200.0n 0.5939 28799.5n 0.5939 28800.0n 0.3849 29399.5n 0.3849 29400.0n 0.4835 29999.5n 0.4835 30000.0n 0.5119 30599.5n 0.5119 30600.0n 0.6226 31199.5n 0.6226 31200.0n 0.6064 31799.5n 0.6064 31800.0n 0.4115 32399.5n 0.4115 32400.0n 0.3900 32999.5n 0.3900 33000.0n 0.3958 33599.5n 0.3958 33600.0n 0.3747 34199.5n 0.3747 34200.0n 0.5423 34799.5n 0.5423 34800.0n 0.5509 35399.5n 0.5509 35400.0n 0.3990 35999.5n 0.3990)
Vxn_wih_1_25 xn_wih_1_25 0 PWL(0.0n 0.4630 599.5n 0.4630 600.0n 0.4833 1199.5n 0.4833 1200.0n 0.5207 1799.5n 0.5207 1800.0n 0.5559 2399.5n 0.5559 2400.0n 0.5445 2999.5n 0.5445 3000.0n 0.4945 3599.5n 0.4945 3600.0n 0.5061 4199.5n 0.5061 4200.0n 0.4615 4799.5n 0.4615 4800.0n 0.4976 5399.5n 0.4976 5400.0n 0.4985 5999.5n 0.4985 6000.0n 0.5300 6599.5n 0.5300 6600.0n 0.4880 7199.5n 0.4880 7200.0n 0.4994 7799.5n 0.4994 7800.0n 0.5050 8399.5n 0.5050 8400.0n 0.4691 8999.5n 0.4691 9000.0n 0.4977 9599.5n 0.4977 9600.0n 0.5107 10199.5n 0.5107 10200.0n 0.5163 10799.5n 0.5163 10800.0n 0.5177 11399.5n 0.5177 11400.0n 0.4926 11999.5n 0.4926 12000.0n 0.4636 12599.5n 0.4636 12600.0n 0.5132 13199.5n 0.5132 13200.0n 0.4620 13799.5n 0.4620 13800.0n 0.4780 14399.5n 0.4780 14400.0n 0.4905 14999.5n 0.4905 15000.0n 0.5295 15599.5n 0.5295 15600.0n 0.4711 16199.5n 0.4711 16200.0n 0.4632 16799.5n 0.4632 16800.0n 0.4713 17399.5n 0.4713 17400.0n 0.4658 17999.5n 0.4658 18000.0n 0.5747 18599.5n 0.5747 18600.0n 0.4881 19199.5n 0.4881 19200.0n 0.5896 19799.5n 0.5896 19800.0n 0.5686 20399.5n 0.5686 20400.0n 0.5995 20999.5n 0.5995 21000.0n 0.5304 21599.5n 0.5304 21600.0n 0.5469 22199.5n 0.5469 22200.0n 0.4961 22799.5n 0.4961 22800.0n 0.6392 23399.5n 0.6392 23400.0n 0.3727 23999.5n 0.3727 24000.0n 0.6072 24599.5n 0.6072 24600.0n 0.4747 25199.5n 0.4747 25200.0n 0.5893 25799.5n 0.5893 25800.0n 0.6053 26399.5n 0.6053 26400.0n 0.6284 26999.5n 0.6284 27000.0n 0.5889 27599.5n 0.5889 27600.0n 0.6285 28199.5n 0.6285 28200.0n 0.4061 28799.5n 0.4061 28800.0n 0.6151 29399.5n 0.6151 29400.0n 0.5165 29999.5n 0.5165 30000.0n 0.4881 30599.5n 0.4881 30600.0n 0.3774 31199.5n 0.3774 31200.0n 0.3936 31799.5n 0.3936 31800.0n 0.5885 32399.5n 0.5885 32400.0n 0.6100 32999.5n 0.6100 33000.0n 0.6042 33599.5n 0.6042 33600.0n 0.6253 34199.5n 0.6253 34200.0n 0.4577 34799.5n 0.4577 34800.0n 0.4491 35399.5n 0.4491 35400.0n 0.6010 35999.5n 0.6010)
Vyp_wih_1_25 yp_wih_1_25 0 PWL(0.0n 0.6460 599.5n 0.6460 600.0n 0.6522 1199.5n 0.6522 1200.0n 0.5797 1799.5n 0.5797 1800.0n 0.5554 2399.5n 0.5554 2400.0n 0.5829 2999.5n 0.5829 3000.0n 0.6275 3599.5n 0.6275 3600.0n 0.5937 4199.5n 0.5937 4200.0n 0.6453 4799.5n 0.6453 4800.0n 0.6153 5399.5n 0.6153 5400.0n 0.6152 5999.5n 0.6152 6000.0n 0.5718 6599.5n 0.5718 6600.0n 0.6194 7199.5n 0.6194 7200.0n 0.6428 7799.5n 0.6428 7800.0n 0.6404 8399.5n 0.6404 8400.0n 0.6261 8999.5n 0.6261 9000.0n 0.6158 9599.5n 0.6158 9600.0n 0.6107 10199.5n 0.6107 10200.0n 0.6193 10799.5n 0.6193 10800.0n 0.5752 11399.5n 0.5752 11400.0n 0.6189 11999.5n 0.6189 12000.0n 0.6271 12599.5n 0.6271 12600.0n 0.6098 13199.5n 0.6098 13200.0n 0.6487 13799.5n 0.6487 13800.0n 0.6472 14399.5n 0.6472 14400.0n 0.6228 14999.5n 0.6228 15000.0n 0.5999 15599.5n 0.5999 15600.0n 0.6343 16199.5n 0.6343 16200.0n 0.6518 16799.5n 0.6518 16800.0n 0.6203 17399.5n 0.6203 17400.0n 0.6477 17999.5n 0.6477 18000.0n 0.4594 18599.5n 0.4594 18600.0n 0.6617 19199.5n 0.6617 19200.0n 0.5108 19799.5n 0.5108 19800.0n 0.5958 20399.5n 0.5958 20400.0n 0.4783 20999.5n 0.4783 21000.0n 0.5041 21599.5n 0.5041 21600.0n 0.6360 22199.5n 0.6360 22200.0n 0.6623 22799.5n 0.6623 22800.0n 0.4560 23399.5n 0.4560 23400.0n 0.6793 23999.5n 0.6793 24000.0n 0.5509 24599.5n 0.5509 24600.0n 0.6665 25199.5n 0.6665 25200.0n 0.4618 25799.5n 0.4618 25800.0n 0.4034 26399.5n 0.4034 26400.0n 0.4341 26999.5n 0.4341 27000.0n 0.4439 27599.5n 0.4439 27600.0n 0.4369 28199.5n 0.4369 28200.0n 0.6792 28799.5n 0.6792 28800.0n 0.4654 29399.5n 0.4654 29400.0n 0.5197 29999.5n 0.5197 30000.0n 0.5452 30599.5n 0.5452 30600.0n 0.6586 31199.5n 0.6586 31200.0n 0.6656 31799.5n 0.6656 31800.0n 0.4115 32399.5n 0.4115 32400.0n 0.4024 32999.5n 0.4024 33000.0n 0.5206 33599.5n 0.5206 33600.0n 0.4852 34199.5n 0.4852 34200.0n 0.6690 34799.5n 0.6690 34800.0n 0.5903 35399.5n 0.5903 35400.0n 0.4988 35999.5n 0.4988)
Vyn_wih_1_25 yn_wih_1_25 0 PWL(0.0n 0.3540 599.5n 0.3540 600.0n 0.3478 1199.5n 0.3478 1200.0n 0.4203 1799.5n 0.4203 1800.0n 0.4446 2399.5n 0.4446 2400.0n 0.4171 2999.5n 0.4171 3000.0n 0.3725 3599.5n 0.3725 3600.0n 0.4063 4199.5n 0.4063 4200.0n 0.3547 4799.5n 0.3547 4800.0n 0.3847 5399.5n 0.3847 5400.0n 0.3848 5999.5n 0.3848 6000.0n 0.4282 6599.5n 0.4282 6600.0n 0.3806 7199.5n 0.3806 7200.0n 0.3572 7799.5n 0.3572 7800.0n 0.3596 8399.5n 0.3596 8400.0n 0.3739 8999.5n 0.3739 9000.0n 0.3842 9599.5n 0.3842 9600.0n 0.3893 10199.5n 0.3893 10200.0n 0.3807 10799.5n 0.3807 10800.0n 0.4248 11399.5n 0.4248 11400.0n 0.3811 11999.5n 0.3811 12000.0n 0.3729 12599.5n 0.3729 12600.0n 0.3902 13199.5n 0.3902 13200.0n 0.3513 13799.5n 0.3513 13800.0n 0.3528 14399.5n 0.3528 14400.0n 0.3772 14999.5n 0.3772 15000.0n 0.4001 15599.5n 0.4001 15600.0n 0.3657 16199.5n 0.3657 16200.0n 0.3482 16799.5n 0.3482 16800.0n 0.3797 17399.5n 0.3797 17400.0n 0.3523 17999.5n 0.3523 18000.0n 0.5406 18599.5n 0.5406 18600.0n 0.3383 19199.5n 0.3383 19200.0n 0.4892 19799.5n 0.4892 19800.0n 0.4042 20399.5n 0.4042 20400.0n 0.5217 20999.5n 0.5217 21000.0n 0.4959 21599.5n 0.4959 21600.0n 0.3640 22199.5n 0.3640 22200.0n 0.3377 22799.5n 0.3377 22800.0n 0.5440 23399.5n 0.5440 23400.0n 0.3207 23999.5n 0.3207 24000.0n 0.4491 24599.5n 0.4491 24600.0n 0.3335 25199.5n 0.3335 25200.0n 0.5382 25799.5n 0.5382 25800.0n 0.5966 26399.5n 0.5966 26400.0n 0.5659 26999.5n 0.5659 27000.0n 0.5561 27599.5n 0.5561 27600.0n 0.5631 28199.5n 0.5631 28200.0n 0.3208 28799.5n 0.3208 28800.0n 0.5346 29399.5n 0.5346 29400.0n 0.4803 29999.5n 0.4803 30000.0n 0.4548 30599.5n 0.4548 30600.0n 0.3414 31199.5n 0.3414 31200.0n 0.3344 31799.5n 0.3344 31800.0n 0.5885 32399.5n 0.5885 32400.0n 0.5976 32999.5n 0.5976 33000.0n 0.4794 33599.5n 0.4794 33600.0n 0.5148 34199.5n 0.5148 34200.0n 0.3310 34799.5n 0.3310 34800.0n 0.4097 35399.5n 0.4097 35400.0n 0.5012 35999.5n 0.5012)
Cwp_wih_1_25 wp_wih_1_25 0 400p
Cwn_wih_1_25 wn_wih_1_25 0 400p
Xu_wih_1_25 xp_wih_1_25 xn_wih_1_25 yp_wih_1_25 yn_wih_1_25 wp_wih_1_25 wn_wih_1_25 vdd gbn gprod
Vxp_who_25_0 xp_who_25_0 0 PWL(0.0n 0.6460 599.5n 0.6460 600.0n 0.6522 1199.5n 0.6522 1200.0n 0.5797 1799.5n 0.5797 1800.0n 0.5554 2399.5n 0.5554 2400.0n 0.5829 2999.5n 0.5829 3000.0n 0.6275 3599.5n 0.6275 3600.0n 0.5937 4199.5n 0.5937 4200.0n 0.6453 4799.5n 0.6453 4800.0n 0.6153 5399.5n 0.6153 5400.0n 0.6152 5999.5n 0.6152 6000.0n 0.5718 6599.5n 0.5718 6600.0n 0.6194 7199.5n 0.6194 7200.0n 0.6428 7799.5n 0.6428 7800.0n 0.6404 8399.5n 0.6404 8400.0n 0.6261 8999.5n 0.6261 9000.0n 0.6158 9599.5n 0.6158 9600.0n 0.6107 10199.5n 0.6107 10200.0n 0.6193 10799.5n 0.6193 10800.0n 0.5752 11399.5n 0.5752 11400.0n 0.6189 11999.5n 0.6189 12000.0n 0.6271 12599.5n 0.6271 12600.0n 0.6098 13199.5n 0.6098 13200.0n 0.6487 13799.5n 0.6487 13800.0n 0.6472 14399.5n 0.6472 14400.0n 0.6228 14999.5n 0.6228 15000.0n 0.5999 15599.5n 0.5999 15600.0n 0.6343 16199.5n 0.6343 16200.0n 0.6518 16799.5n 0.6518 16800.0n 0.6203 17399.5n 0.6203 17400.0n 0.6477 17999.5n 0.6477 18000.0n 0.4594 18599.5n 0.4594 18600.0n 0.6617 19199.5n 0.6617 19200.0n 0.5108 19799.5n 0.5108 19800.0n 0.5958 20399.5n 0.5958 20400.0n 0.4783 20999.5n 0.4783 21000.0n 0.5041 21599.5n 0.5041 21600.0n 0.6360 22199.5n 0.6360 22200.0n 0.6623 22799.5n 0.6623 22800.0n 0.4560 23399.5n 0.4560 23400.0n 0.6793 23999.5n 0.6793 24000.0n 0.5509 24599.5n 0.5509 24600.0n 0.6665 25199.5n 0.6665 25200.0n 0.4618 25799.5n 0.4618 25800.0n 0.4034 26399.5n 0.4034 26400.0n 0.4341 26999.5n 0.4341 27000.0n 0.4439 27599.5n 0.4439 27600.0n 0.4369 28199.5n 0.4369 28200.0n 0.6792 28799.5n 0.6792 28800.0n 0.4654 29399.5n 0.4654 29400.0n 0.5197 29999.5n 0.5197 30000.0n 0.5452 30599.5n 0.5452 30600.0n 0.6586 31199.5n 0.6586 31200.0n 0.6656 31799.5n 0.6656 31800.0n 0.4115 32399.5n 0.4115 32400.0n 0.4024 32999.5n 0.4024 33000.0n 0.5206 33599.5n 0.5206 33600.0n 0.4852 34199.5n 0.4852 34200.0n 0.6690 34799.5n 0.6690 34800.0n 0.5903 35399.5n 0.5903 35400.0n 0.4988 35999.5n 0.4988)
Vxn_who_25_0 xn_who_25_0 0 PWL(0.0n 0.3540 599.5n 0.3540 600.0n 0.3478 1199.5n 0.3478 1200.0n 0.4203 1799.5n 0.4203 1800.0n 0.4446 2399.5n 0.4446 2400.0n 0.4171 2999.5n 0.4171 3000.0n 0.3725 3599.5n 0.3725 3600.0n 0.4063 4199.5n 0.4063 4200.0n 0.3547 4799.5n 0.3547 4800.0n 0.3847 5399.5n 0.3847 5400.0n 0.3848 5999.5n 0.3848 6000.0n 0.4282 6599.5n 0.4282 6600.0n 0.3806 7199.5n 0.3806 7200.0n 0.3572 7799.5n 0.3572 7800.0n 0.3596 8399.5n 0.3596 8400.0n 0.3739 8999.5n 0.3739 9000.0n 0.3842 9599.5n 0.3842 9600.0n 0.3893 10199.5n 0.3893 10200.0n 0.3807 10799.5n 0.3807 10800.0n 0.4248 11399.5n 0.4248 11400.0n 0.3811 11999.5n 0.3811 12000.0n 0.3729 12599.5n 0.3729 12600.0n 0.3902 13199.5n 0.3902 13200.0n 0.3513 13799.5n 0.3513 13800.0n 0.3528 14399.5n 0.3528 14400.0n 0.3772 14999.5n 0.3772 15000.0n 0.4001 15599.5n 0.4001 15600.0n 0.3657 16199.5n 0.3657 16200.0n 0.3482 16799.5n 0.3482 16800.0n 0.3797 17399.5n 0.3797 17400.0n 0.3523 17999.5n 0.3523 18000.0n 0.5406 18599.5n 0.5406 18600.0n 0.3383 19199.5n 0.3383 19200.0n 0.4892 19799.5n 0.4892 19800.0n 0.4042 20399.5n 0.4042 20400.0n 0.5217 20999.5n 0.5217 21000.0n 0.4959 21599.5n 0.4959 21600.0n 0.3640 22199.5n 0.3640 22200.0n 0.3377 22799.5n 0.3377 22800.0n 0.5440 23399.5n 0.5440 23400.0n 0.3207 23999.5n 0.3207 24000.0n 0.4491 24599.5n 0.4491 24600.0n 0.3335 25199.5n 0.3335 25200.0n 0.5382 25799.5n 0.5382 25800.0n 0.5966 26399.5n 0.5966 26400.0n 0.5659 26999.5n 0.5659 27000.0n 0.5561 27599.5n 0.5561 27600.0n 0.5631 28199.5n 0.5631 28200.0n 0.3208 28799.5n 0.3208 28800.0n 0.5346 29399.5n 0.5346 29400.0n 0.4803 29999.5n 0.4803 30000.0n 0.4548 30599.5n 0.4548 30600.0n 0.3414 31199.5n 0.3414 31200.0n 0.3344 31799.5n 0.3344 31800.0n 0.5885 32399.5n 0.5885 32400.0n 0.5976 32999.5n 0.5976 33000.0n 0.4794 33599.5n 0.4794 33600.0n 0.5148 34199.5n 0.5148 34200.0n 0.3310 34799.5n 0.3310 34800.0n 0.4097 35399.5n 0.4097 35400.0n 0.5012 35999.5n 0.5012)
Vyp_who_25_0 yp_who_25_0 0 PWL(0.0n 0.5031 599.5n 0.5031 600.0n 0.5023 1199.5n 0.5023 1200.0n 0.5052 1799.5n 0.5052 1800.0n 0.5048 2399.5n 0.5048 2400.0n 0.5043 2999.5n 0.5043 3000.0n 0.5034 3599.5n 0.5034 3600.0n 0.5048 4199.5n 0.5048 4200.0n 0.5031 4799.5n 0.5031 4800.0n 0.5040 5399.5n 0.5040 5400.0n 0.5040 5999.5n 0.5040 6000.0n 0.5054 6599.5n 0.5054 6600.0n 0.5040 7199.5n 0.5040 7200.0n 0.5027 7799.5n 0.5027 7800.0n 0.5027 8399.5n 0.5027 8400.0n 0.5038 8999.5n 0.5038 9000.0n 0.5040 9599.5n 0.5040 9600.0n 0.5039 10199.5n 0.5039 10200.0n 0.5033 10799.5n 0.5033 10800.0n 0.5056 11399.5n 0.5056 11400.0n 0.5040 11999.5n 0.5040 12000.0n 0.5036 12599.5n 0.5036 12600.0n 0.5039 13199.5n 0.5039 13200.0n 0.5029 13799.5n 0.5029 13800.0n 0.5025 14399.5n 0.5025 14400.0n 0.5038 14999.5n 0.5038 15000.0n 0.5041 15599.5n 0.5041 15600.0n 0.5036 16199.5n 0.5036 16200.0n 0.5025 16799.5n 0.5025 16800.0n 0.5040 17399.5n 0.5040 17400.0n 0.5029 17999.5n 0.5029 18000.0n 0.5057 18599.5n 0.5057 18600.0n 0.5010 19199.5n 0.5010 19200.0n 0.5041 19799.5n 0.5041 19800.0n 0.5021 20399.5n 0.5021 20400.0n 0.5044 20999.5n 0.5044 21000.0n 0.5056 21599.5n 0.5056 21600.0n 0.5016 22199.5n 0.5016 22200.0n 0.5006 22799.5n 0.5006 22800.0n 0.5041 23399.5n 0.5041 23400.0n 0.5027 23999.5n 0.5027 24000.0n 0.5029 24599.5n 0.5029 24600.0n 0.5006 25199.5n 0.5006 25200.0n 0.5047 25799.5n 0.5047 25800.0n 0.5046 26399.5n 0.5046 26400.0n 0.5039 26999.5n 0.5039 27000.0n 0.5049 27599.5n 0.5049 27600.0n 0.5039 28199.5n 0.5039 28200.0n 0.5017 28799.5n 0.5017 28800.0n 0.5042 29399.5n 0.5042 29400.0n 0.5056 29999.5n 0.5056 30000.0n 0.5051 30599.5n 0.5051 30600.0n 0.5039 31199.5n 0.5039 31200.0n 0.5033 31799.5n 0.5033 31800.0n 0.5049 32399.5n 0.5049 32400.0n 0.5045 32999.5n 0.5045 33000.0n 0.5036 33599.5n 0.5036 33600.0n 0.5042 34199.5n 0.5042 34200.0n 0.5012 34799.5n 0.5012 34800.0n 0.5036 35399.5n 0.5036 35400.0n 0.5042 35999.5n 0.5042)
Vyn_who_25_0 yn_who_25_0 0 PWL(0.0n 0.4969 599.5n 0.4969 600.0n 0.4977 1199.5n 0.4977 1200.0n 0.4948 1799.5n 0.4948 1800.0n 0.4952 2399.5n 0.4952 2400.0n 0.4957 2999.5n 0.4957 3000.0n 0.4966 3599.5n 0.4966 3600.0n 0.4952 4199.5n 0.4952 4200.0n 0.4969 4799.5n 0.4969 4800.0n 0.4960 5399.5n 0.4960 5400.0n 0.4960 5999.5n 0.4960 6000.0n 0.4946 6599.5n 0.4946 6600.0n 0.4960 7199.5n 0.4960 7200.0n 0.4973 7799.5n 0.4973 7800.0n 0.4973 8399.5n 0.4973 8400.0n 0.4962 8999.5n 0.4962 9000.0n 0.4960 9599.5n 0.4960 9600.0n 0.4961 10199.5n 0.4961 10200.0n 0.4967 10799.5n 0.4967 10800.0n 0.4944 11399.5n 0.4944 11400.0n 0.4960 11999.5n 0.4960 12000.0n 0.4964 12599.5n 0.4964 12600.0n 0.4961 13199.5n 0.4961 13200.0n 0.4971 13799.5n 0.4971 13800.0n 0.4975 14399.5n 0.4975 14400.0n 0.4962 14999.5n 0.4962 15000.0n 0.4959 15599.5n 0.4959 15600.0n 0.4964 16199.5n 0.4964 16200.0n 0.4975 16799.5n 0.4975 16800.0n 0.4960 17399.5n 0.4960 17400.0n 0.4971 17999.5n 0.4971 18000.0n 0.4943 18599.5n 0.4943 18600.0n 0.4990 19199.5n 0.4990 19200.0n 0.4959 19799.5n 0.4959 19800.0n 0.4979 20399.5n 0.4979 20400.0n 0.4956 20999.5n 0.4956 21000.0n 0.4944 21599.5n 0.4944 21600.0n 0.4984 22199.5n 0.4984 22200.0n 0.4994 22799.5n 0.4994 22800.0n 0.4959 23399.5n 0.4959 23400.0n 0.4973 23999.5n 0.4973 24000.0n 0.4971 24599.5n 0.4971 24600.0n 0.4994 25199.5n 0.4994 25200.0n 0.4953 25799.5n 0.4953 25800.0n 0.4954 26399.5n 0.4954 26400.0n 0.4961 26999.5n 0.4961 27000.0n 0.4951 27599.5n 0.4951 27600.0n 0.4961 28199.5n 0.4961 28200.0n 0.4983 28799.5n 0.4983 28800.0n 0.4958 29399.5n 0.4958 29400.0n 0.4944 29999.5n 0.4944 30000.0n 0.4949 30599.5n 0.4949 30600.0n 0.4961 31199.5n 0.4961 31200.0n 0.4967 31799.5n 0.4967 31800.0n 0.4951 32399.5n 0.4951 32400.0n 0.4955 32999.5n 0.4955 33000.0n 0.4964 33599.5n 0.4964 33600.0n 0.4958 34199.5n 0.4958 34200.0n 0.4988 34799.5n 0.4988 34800.0n 0.4964 35399.5n 0.4964 35400.0n 0.4958 35999.5n 0.4958)
Cwp_who_25_0 wp_who_25_0 0 400p
Cwn_who_25_0 wn_who_25_0 0 400p
Xu_who_25_0 xp_who_25_0 xn_who_25_0 yp_who_25_0 yn_who_25_0 wp_who_25_0 wn_who_25_0 vdd gbn gprod
Vxp_who_25_1 xp_who_25_1 0 PWL(0.0n 0.6460 599.5n 0.6460 600.0n 0.6522 1199.5n 0.6522 1200.0n 0.5797 1799.5n 0.5797 1800.0n 0.5554 2399.5n 0.5554 2400.0n 0.5829 2999.5n 0.5829 3000.0n 0.6275 3599.5n 0.6275 3600.0n 0.5937 4199.5n 0.5937 4200.0n 0.6453 4799.5n 0.6453 4800.0n 0.6153 5399.5n 0.6153 5400.0n 0.6152 5999.5n 0.6152 6000.0n 0.5718 6599.5n 0.5718 6600.0n 0.6194 7199.5n 0.6194 7200.0n 0.6428 7799.5n 0.6428 7800.0n 0.6404 8399.5n 0.6404 8400.0n 0.6261 8999.5n 0.6261 9000.0n 0.6158 9599.5n 0.6158 9600.0n 0.6107 10199.5n 0.6107 10200.0n 0.6193 10799.5n 0.6193 10800.0n 0.5752 11399.5n 0.5752 11400.0n 0.6189 11999.5n 0.6189 12000.0n 0.6271 12599.5n 0.6271 12600.0n 0.6098 13199.5n 0.6098 13200.0n 0.6487 13799.5n 0.6487 13800.0n 0.6472 14399.5n 0.6472 14400.0n 0.6228 14999.5n 0.6228 15000.0n 0.5999 15599.5n 0.5999 15600.0n 0.6343 16199.5n 0.6343 16200.0n 0.6518 16799.5n 0.6518 16800.0n 0.6203 17399.5n 0.6203 17400.0n 0.6477 17999.5n 0.6477 18000.0n 0.4594 18599.5n 0.4594 18600.0n 0.6617 19199.5n 0.6617 19200.0n 0.5108 19799.5n 0.5108 19800.0n 0.5958 20399.5n 0.5958 20400.0n 0.4783 20999.5n 0.4783 21000.0n 0.5041 21599.5n 0.5041 21600.0n 0.6360 22199.5n 0.6360 22200.0n 0.6623 22799.5n 0.6623 22800.0n 0.4560 23399.5n 0.4560 23400.0n 0.6793 23999.5n 0.6793 24000.0n 0.5509 24599.5n 0.5509 24600.0n 0.6665 25199.5n 0.6665 25200.0n 0.4618 25799.5n 0.4618 25800.0n 0.4034 26399.5n 0.4034 26400.0n 0.4341 26999.5n 0.4341 27000.0n 0.4439 27599.5n 0.4439 27600.0n 0.4369 28199.5n 0.4369 28200.0n 0.6792 28799.5n 0.6792 28800.0n 0.4654 29399.5n 0.4654 29400.0n 0.5197 29999.5n 0.5197 30000.0n 0.5452 30599.5n 0.5452 30600.0n 0.6586 31199.5n 0.6586 31200.0n 0.6656 31799.5n 0.6656 31800.0n 0.4115 32399.5n 0.4115 32400.0n 0.4024 32999.5n 0.4024 33000.0n 0.5206 33599.5n 0.5206 33600.0n 0.4852 34199.5n 0.4852 34200.0n 0.6690 34799.5n 0.6690 34800.0n 0.5903 35399.5n 0.5903 35400.0n 0.4988 35999.5n 0.4988)
Vxn_who_25_1 xn_who_25_1 0 PWL(0.0n 0.3540 599.5n 0.3540 600.0n 0.3478 1199.5n 0.3478 1200.0n 0.4203 1799.5n 0.4203 1800.0n 0.4446 2399.5n 0.4446 2400.0n 0.4171 2999.5n 0.4171 3000.0n 0.3725 3599.5n 0.3725 3600.0n 0.4063 4199.5n 0.4063 4200.0n 0.3547 4799.5n 0.3547 4800.0n 0.3847 5399.5n 0.3847 5400.0n 0.3848 5999.5n 0.3848 6000.0n 0.4282 6599.5n 0.4282 6600.0n 0.3806 7199.5n 0.3806 7200.0n 0.3572 7799.5n 0.3572 7800.0n 0.3596 8399.5n 0.3596 8400.0n 0.3739 8999.5n 0.3739 9000.0n 0.3842 9599.5n 0.3842 9600.0n 0.3893 10199.5n 0.3893 10200.0n 0.3807 10799.5n 0.3807 10800.0n 0.4248 11399.5n 0.4248 11400.0n 0.3811 11999.5n 0.3811 12000.0n 0.3729 12599.5n 0.3729 12600.0n 0.3902 13199.5n 0.3902 13200.0n 0.3513 13799.5n 0.3513 13800.0n 0.3528 14399.5n 0.3528 14400.0n 0.3772 14999.5n 0.3772 15000.0n 0.4001 15599.5n 0.4001 15600.0n 0.3657 16199.5n 0.3657 16200.0n 0.3482 16799.5n 0.3482 16800.0n 0.3797 17399.5n 0.3797 17400.0n 0.3523 17999.5n 0.3523 18000.0n 0.5406 18599.5n 0.5406 18600.0n 0.3383 19199.5n 0.3383 19200.0n 0.4892 19799.5n 0.4892 19800.0n 0.4042 20399.5n 0.4042 20400.0n 0.5217 20999.5n 0.5217 21000.0n 0.4959 21599.5n 0.4959 21600.0n 0.3640 22199.5n 0.3640 22200.0n 0.3377 22799.5n 0.3377 22800.0n 0.5440 23399.5n 0.5440 23400.0n 0.3207 23999.5n 0.3207 24000.0n 0.4491 24599.5n 0.4491 24600.0n 0.3335 25199.5n 0.3335 25200.0n 0.5382 25799.5n 0.5382 25800.0n 0.5966 26399.5n 0.5966 26400.0n 0.5659 26999.5n 0.5659 27000.0n 0.5561 27599.5n 0.5561 27600.0n 0.5631 28199.5n 0.5631 28200.0n 0.3208 28799.5n 0.3208 28800.0n 0.5346 29399.5n 0.5346 29400.0n 0.4803 29999.5n 0.4803 30000.0n 0.4548 30599.5n 0.4548 30600.0n 0.3414 31199.5n 0.3414 31200.0n 0.3344 31799.5n 0.3344 31800.0n 0.5885 32399.5n 0.5885 32400.0n 0.5976 32999.5n 0.5976 33000.0n 0.4794 33599.5n 0.4794 33600.0n 0.5148 34199.5n 0.5148 34200.0n 0.3310 34799.5n 0.3310 34800.0n 0.4097 35399.5n 0.4097 35400.0n 0.5012 35999.5n 0.5012)
Vyp_who_25_1 yp_who_25_1 0 PWL(0.0n 0.5071 599.5n 0.5071 600.0n 0.5053 1199.5n 0.5053 1200.0n 0.5052 1799.5n 0.5052 1800.0n 0.5027 2399.5n 0.5027 2400.0n 0.5034 2999.5n 0.5034 3000.0n 0.5055 3599.5n 0.5055 3600.0n 0.5056 4199.5n 0.5056 4200.0n 0.5071 4799.5n 0.5071 4800.0n 0.5056 5399.5n 0.5056 5400.0n 0.5056 5999.5n 0.5056 6000.0n 0.5048 6599.5n 0.5048 6600.0n 0.5060 7199.5n 0.5060 7200.0n 0.5048 7799.5n 0.5048 7800.0n 0.5046 8399.5n 0.5046 8400.0n 0.5066 8999.5n 0.5066 9000.0n 0.5056 9599.5n 0.5056 9600.0n 0.5051 10199.5n 0.5051 10200.0n 0.5046 10799.5n 0.5046 10800.0n 0.5056 11399.5n 0.5056 11400.0n 0.5058 11999.5n 0.5058 12000.0n 0.5068 12599.5n 0.5068 12600.0n 0.5050 13199.5n 0.5050 13200.0n 0.5071 13799.5n 0.5071 13800.0n 0.5059 14399.5n 0.5059 14400.0n 0.5058 14999.5n 0.5058 15000.0n 0.5043 15599.5n 0.5043 15600.0n 0.5067 16199.5n 0.5067 16200.0n 0.5068 16799.5n 0.5068 16800.0n 0.5066 17399.5n 0.5066 17400.0n 0.5069 17999.5n 0.5069 18000.0n 0.5061 18599.5n 0.5061 18600.0n 0.5034 19199.5n 0.5034 19200.0n 0.5010 19799.5n 0.5010 19800.0n 0.4989 20399.5n 0.4989 20400.0n 0.5022 20999.5n 0.5022 21000.0n 0.5086 21599.5n 0.5086 21600.0n 0.5007 22199.5n 0.5007 22200.0n 0.5023 22799.5n 0.5023 22800.0n 0.5021 23399.5n 0.5021 23400.0n 0.5077 23999.5n 0.5077 24000.0n 0.4979 24599.5n 0.4979 24600.0n 0.5035 25199.5n 0.5035 25200.0n 0.5041 25799.5n 0.5041 25800.0n 0.5075 26399.5n 0.5075 26400.0n 0.5041 26999.5n 0.5041 27000.0n 0.5056 27599.5n 0.5056 27600.0n 0.5039 28199.5n 0.5039 28200.0n 0.5059 28799.5n 0.5059 28800.0n 0.5023 29399.5n 0.5023 29400.0n 0.5086 29999.5n 0.5086 30000.0n 0.5084 30599.5n 0.5084 30600.0n 0.5085 31199.5n 0.5085 31200.0n 0.5088 31799.5n 0.5088 31800.0n 0.5078 32399.5n 0.5078 32400.0n 0.5074 32999.5n 0.5074 33000.0n 0.4996 33599.5n 0.4996 33600.0n 0.5010 34199.5n 0.5010 34200.0n 0.5044 34799.5n 0.5044 34800.0n 0.5084 35399.5n 0.5084 35400.0n 0.5012 35999.5n 0.5012)
Vyn_who_25_1 yn_who_25_1 0 PWL(0.0n 0.4929 599.5n 0.4929 600.0n 0.4947 1199.5n 0.4947 1200.0n 0.4948 1799.5n 0.4948 1800.0n 0.4973 2399.5n 0.4973 2400.0n 0.4966 2999.5n 0.4966 3000.0n 0.4945 3599.5n 0.4945 3600.0n 0.4944 4199.5n 0.4944 4200.0n 0.4929 4799.5n 0.4929 4800.0n 0.4944 5399.5n 0.4944 5400.0n 0.4944 5999.5n 0.4944 6000.0n 0.4952 6599.5n 0.4952 6600.0n 0.4940 7199.5n 0.4940 7200.0n 0.4952 7799.5n 0.4952 7800.0n 0.4954 8399.5n 0.4954 8400.0n 0.4934 8999.5n 0.4934 9000.0n 0.4944 9599.5n 0.4944 9600.0n 0.4949 10199.5n 0.4949 10200.0n 0.4954 10799.5n 0.4954 10800.0n 0.4944 11399.5n 0.4944 11400.0n 0.4942 11999.5n 0.4942 12000.0n 0.4932 12599.5n 0.4932 12600.0n 0.4950 13199.5n 0.4950 13200.0n 0.4929 13799.5n 0.4929 13800.0n 0.4941 14399.5n 0.4941 14400.0n 0.4942 14999.5n 0.4942 15000.0n 0.4957 15599.5n 0.4957 15600.0n 0.4933 16199.5n 0.4933 16200.0n 0.4932 16799.5n 0.4932 16800.0n 0.4934 17399.5n 0.4934 17400.0n 0.4931 17999.5n 0.4931 18000.0n 0.4939 18599.5n 0.4939 18600.0n 0.4966 19199.5n 0.4966 19200.0n 0.4990 19799.5n 0.4990 19800.0n 0.5011 20399.5n 0.5011 20400.0n 0.4978 20999.5n 0.4978 21000.0n 0.4914 21599.5n 0.4914 21600.0n 0.4993 22199.5n 0.4993 22200.0n 0.4977 22799.5n 0.4977 22800.0n 0.4979 23399.5n 0.4979 23400.0n 0.4923 23999.5n 0.4923 24000.0n 0.5021 24599.5n 0.5021 24600.0n 0.4965 25199.5n 0.4965 25200.0n 0.4959 25799.5n 0.4959 25800.0n 0.4925 26399.5n 0.4925 26400.0n 0.4959 26999.5n 0.4959 27000.0n 0.4944 27599.5n 0.4944 27600.0n 0.4961 28199.5n 0.4961 28200.0n 0.4941 28799.5n 0.4941 28800.0n 0.4977 29399.5n 0.4977 29400.0n 0.4914 29999.5n 0.4914 30000.0n 0.4916 30599.5n 0.4916 30600.0n 0.4915 31199.5n 0.4915 31200.0n 0.4912 31799.5n 0.4912 31800.0n 0.4922 32399.5n 0.4922 32400.0n 0.4926 32999.5n 0.4926 33000.0n 0.5004 33599.5n 0.5004 33600.0n 0.4990 34199.5n 0.4990 34200.0n 0.4956 34799.5n 0.4956 34800.0n 0.4916 35399.5n 0.4916 35400.0n 0.4988 35999.5n 0.4988)
Cwp_who_25_1 wp_who_25_1 0 400p
Cwn_who_25_1 wn_who_25_1 0 400p
Xu_who_25_1 xp_who_25_1 xn_who_25_1 yp_who_25_1 yn_who_25_1 wp_who_25_1 wn_who_25_1 vdd gbn gprod
Vxp_bh_25 xp_bh_25 0 PWL(0.0n 0.7100 599.5n 0.7100 600.0n 0.7100 1199.5n 0.7100 1200.0n 0.7100 1799.5n 0.7100 1800.0n 0.7100 2399.5n 0.7100 2400.0n 0.7100 2999.5n 0.7100 3000.0n 0.7100 3599.5n 0.7100 3600.0n 0.7100 4199.5n 0.7100 4200.0n 0.7100 4799.5n 0.7100 4800.0n 0.7100 5399.5n 0.7100 5400.0n 0.7100 5999.5n 0.7100 6000.0n 0.7100 6599.5n 0.7100 6600.0n 0.7100 7199.5n 0.7100 7200.0n 0.7100 7799.5n 0.7100 7800.0n 0.7100 8399.5n 0.7100 8400.0n 0.7100 8999.5n 0.7100 9000.0n 0.7100 9599.5n 0.7100 9600.0n 0.7100 10199.5n 0.7100 10200.0n 0.7100 10799.5n 0.7100 10800.0n 0.7100 11399.5n 0.7100 11400.0n 0.7100 11999.5n 0.7100 12000.0n 0.7100 12599.5n 0.7100 12600.0n 0.7100 13199.5n 0.7100 13200.0n 0.7100 13799.5n 0.7100 13800.0n 0.7100 14399.5n 0.7100 14400.0n 0.7100 14999.5n 0.7100 15000.0n 0.7100 15599.5n 0.7100 15600.0n 0.7100 16199.5n 0.7100 16200.0n 0.7100 16799.5n 0.7100 16800.0n 0.7100 17399.5n 0.7100 17400.0n 0.7100 17999.5n 0.7100 18000.0n 0.7100 18599.5n 0.7100 18600.0n 0.7100 19199.5n 0.7100 19200.0n 0.7100 19799.5n 0.7100 19800.0n 0.7100 20399.5n 0.7100 20400.0n 0.7100 20999.5n 0.7100 21000.0n 0.7100 21599.5n 0.7100 21600.0n 0.7100 22199.5n 0.7100 22200.0n 0.7100 22799.5n 0.7100 22800.0n 0.7100 23399.5n 0.7100 23400.0n 0.7100 23999.5n 0.7100 24000.0n 0.7100 24599.5n 0.7100 24600.0n 0.7100 25199.5n 0.7100 25200.0n 0.7100 25799.5n 0.7100 25800.0n 0.7100 26399.5n 0.7100 26400.0n 0.7100 26999.5n 0.7100 27000.0n 0.7100 27599.5n 0.7100 27600.0n 0.7100 28199.5n 0.7100 28200.0n 0.7100 28799.5n 0.7100 28800.0n 0.7100 29399.5n 0.7100 29400.0n 0.7100 29999.5n 0.7100 30000.0n 0.7100 30599.5n 0.7100 30600.0n 0.7100 31199.5n 0.7100 31200.0n 0.7100 31799.5n 0.7100 31800.0n 0.7100 32399.5n 0.7100 32400.0n 0.7100 32999.5n 0.7100 33000.0n 0.7100 33599.5n 0.7100 33600.0n 0.7100 34199.5n 0.7100 34200.0n 0.7100 34799.5n 0.7100 34800.0n 0.7100 35399.5n 0.7100 35400.0n 0.7100 35999.5n 0.7100)
Vxn_bh_25 xn_bh_25 0 PWL(0.0n 0.2900 599.5n 0.2900 600.0n 0.2900 1199.5n 0.2900 1200.0n 0.2900 1799.5n 0.2900 1800.0n 0.2900 2399.5n 0.2900 2400.0n 0.2900 2999.5n 0.2900 3000.0n 0.2900 3599.5n 0.2900 3600.0n 0.2900 4199.5n 0.2900 4200.0n 0.2900 4799.5n 0.2900 4800.0n 0.2900 5399.5n 0.2900 5400.0n 0.2900 5999.5n 0.2900 6000.0n 0.2900 6599.5n 0.2900 6600.0n 0.2900 7199.5n 0.2900 7200.0n 0.2900 7799.5n 0.2900 7800.0n 0.2900 8399.5n 0.2900 8400.0n 0.2900 8999.5n 0.2900 9000.0n 0.2900 9599.5n 0.2900 9600.0n 0.2900 10199.5n 0.2900 10200.0n 0.2900 10799.5n 0.2900 10800.0n 0.2900 11399.5n 0.2900 11400.0n 0.2900 11999.5n 0.2900 12000.0n 0.2900 12599.5n 0.2900 12600.0n 0.2900 13199.5n 0.2900 13200.0n 0.2900 13799.5n 0.2900 13800.0n 0.2900 14399.5n 0.2900 14400.0n 0.2900 14999.5n 0.2900 15000.0n 0.2900 15599.5n 0.2900 15600.0n 0.2900 16199.5n 0.2900 16200.0n 0.2900 16799.5n 0.2900 16800.0n 0.2900 17399.5n 0.2900 17400.0n 0.2900 17999.5n 0.2900 18000.0n 0.2900 18599.5n 0.2900 18600.0n 0.2900 19199.5n 0.2900 19200.0n 0.2900 19799.5n 0.2900 19800.0n 0.2900 20399.5n 0.2900 20400.0n 0.2900 20999.5n 0.2900 21000.0n 0.2900 21599.5n 0.2900 21600.0n 0.2900 22199.5n 0.2900 22200.0n 0.2900 22799.5n 0.2900 22800.0n 0.2900 23399.5n 0.2900 23400.0n 0.2900 23999.5n 0.2900 24000.0n 0.2900 24599.5n 0.2900 24600.0n 0.2900 25199.5n 0.2900 25200.0n 0.2900 25799.5n 0.2900 25800.0n 0.2900 26399.5n 0.2900 26400.0n 0.2900 26999.5n 0.2900 27000.0n 0.2900 27599.5n 0.2900 27600.0n 0.2900 28199.5n 0.2900 28200.0n 0.2900 28799.5n 0.2900 28800.0n 0.2900 29399.5n 0.2900 29400.0n 0.2900 29999.5n 0.2900 30000.0n 0.2900 30599.5n 0.2900 30600.0n 0.2900 31199.5n 0.2900 31200.0n 0.2900 31799.5n 0.2900 31800.0n 0.2900 32399.5n 0.2900 32400.0n 0.2900 32999.5n 0.2900 33000.0n 0.2900 33599.5n 0.2900 33600.0n 0.2900 34199.5n 0.2900 34200.0n 0.2900 34799.5n 0.2900 34800.0n 0.2900 35399.5n 0.2900 35400.0n 0.2900 35999.5n 0.2900)
Vyp_bh_25 yp_bh_25 0 PWL(0.0n 0.6460 599.5n 0.6460 600.0n 0.6522 1199.5n 0.6522 1200.0n 0.5797 1799.5n 0.5797 1800.0n 0.5554 2399.5n 0.5554 2400.0n 0.5829 2999.5n 0.5829 3000.0n 0.6275 3599.5n 0.6275 3600.0n 0.5937 4199.5n 0.5937 4200.0n 0.6453 4799.5n 0.6453 4800.0n 0.6153 5399.5n 0.6153 5400.0n 0.6152 5999.5n 0.6152 6000.0n 0.5718 6599.5n 0.5718 6600.0n 0.6194 7199.5n 0.6194 7200.0n 0.6428 7799.5n 0.6428 7800.0n 0.6404 8399.5n 0.6404 8400.0n 0.6261 8999.5n 0.6261 9000.0n 0.6158 9599.5n 0.6158 9600.0n 0.6107 10199.5n 0.6107 10200.0n 0.6193 10799.5n 0.6193 10800.0n 0.5752 11399.5n 0.5752 11400.0n 0.6189 11999.5n 0.6189 12000.0n 0.6271 12599.5n 0.6271 12600.0n 0.6098 13199.5n 0.6098 13200.0n 0.6487 13799.5n 0.6487 13800.0n 0.6472 14399.5n 0.6472 14400.0n 0.6228 14999.5n 0.6228 15000.0n 0.5999 15599.5n 0.5999 15600.0n 0.6343 16199.5n 0.6343 16200.0n 0.6518 16799.5n 0.6518 16800.0n 0.6203 17399.5n 0.6203 17400.0n 0.6477 17999.5n 0.6477 18000.0n 0.4594 18599.5n 0.4594 18600.0n 0.6617 19199.5n 0.6617 19200.0n 0.5108 19799.5n 0.5108 19800.0n 0.5958 20399.5n 0.5958 20400.0n 0.4783 20999.5n 0.4783 21000.0n 0.5041 21599.5n 0.5041 21600.0n 0.6360 22199.5n 0.6360 22200.0n 0.6623 22799.5n 0.6623 22800.0n 0.4560 23399.5n 0.4560 23400.0n 0.6793 23999.5n 0.6793 24000.0n 0.5509 24599.5n 0.5509 24600.0n 0.6665 25199.5n 0.6665 25200.0n 0.4618 25799.5n 0.4618 25800.0n 0.4034 26399.5n 0.4034 26400.0n 0.4341 26999.5n 0.4341 27000.0n 0.4439 27599.5n 0.4439 27600.0n 0.4369 28199.5n 0.4369 28200.0n 0.6792 28799.5n 0.6792 28800.0n 0.4654 29399.5n 0.4654 29400.0n 0.5197 29999.5n 0.5197 30000.0n 0.5452 30599.5n 0.5452 30600.0n 0.6586 31199.5n 0.6586 31200.0n 0.6656 31799.5n 0.6656 31800.0n 0.4115 32399.5n 0.4115 32400.0n 0.4024 32999.5n 0.4024 33000.0n 0.5206 33599.5n 0.5206 33600.0n 0.4852 34199.5n 0.4852 34200.0n 0.6690 34799.5n 0.6690 34800.0n 0.5903 35399.5n 0.5903 35400.0n 0.4988 35999.5n 0.4988)
Vyn_bh_25 yn_bh_25 0 PWL(0.0n 0.3540 599.5n 0.3540 600.0n 0.3478 1199.5n 0.3478 1200.0n 0.4203 1799.5n 0.4203 1800.0n 0.4446 2399.5n 0.4446 2400.0n 0.4171 2999.5n 0.4171 3000.0n 0.3725 3599.5n 0.3725 3600.0n 0.4063 4199.5n 0.4063 4200.0n 0.3547 4799.5n 0.3547 4800.0n 0.3847 5399.5n 0.3847 5400.0n 0.3848 5999.5n 0.3848 6000.0n 0.4282 6599.5n 0.4282 6600.0n 0.3806 7199.5n 0.3806 7200.0n 0.3572 7799.5n 0.3572 7800.0n 0.3596 8399.5n 0.3596 8400.0n 0.3739 8999.5n 0.3739 9000.0n 0.3842 9599.5n 0.3842 9600.0n 0.3893 10199.5n 0.3893 10200.0n 0.3807 10799.5n 0.3807 10800.0n 0.4248 11399.5n 0.4248 11400.0n 0.3811 11999.5n 0.3811 12000.0n 0.3729 12599.5n 0.3729 12600.0n 0.3902 13199.5n 0.3902 13200.0n 0.3513 13799.5n 0.3513 13800.0n 0.3528 14399.5n 0.3528 14400.0n 0.3772 14999.5n 0.3772 15000.0n 0.4001 15599.5n 0.4001 15600.0n 0.3657 16199.5n 0.3657 16200.0n 0.3482 16799.5n 0.3482 16800.0n 0.3797 17399.5n 0.3797 17400.0n 0.3523 17999.5n 0.3523 18000.0n 0.5406 18599.5n 0.5406 18600.0n 0.3383 19199.5n 0.3383 19200.0n 0.4892 19799.5n 0.4892 19800.0n 0.4042 20399.5n 0.4042 20400.0n 0.5217 20999.5n 0.5217 21000.0n 0.4959 21599.5n 0.4959 21600.0n 0.3640 22199.5n 0.3640 22200.0n 0.3377 22799.5n 0.3377 22800.0n 0.5440 23399.5n 0.5440 23400.0n 0.3207 23999.5n 0.3207 24000.0n 0.4491 24599.5n 0.4491 24600.0n 0.3335 25199.5n 0.3335 25200.0n 0.5382 25799.5n 0.5382 25800.0n 0.5966 26399.5n 0.5966 26400.0n 0.5659 26999.5n 0.5659 27000.0n 0.5561 27599.5n 0.5561 27600.0n 0.5631 28199.5n 0.5631 28200.0n 0.3208 28799.5n 0.3208 28800.0n 0.5346 29399.5n 0.5346 29400.0n 0.4803 29999.5n 0.4803 30000.0n 0.4548 30599.5n 0.4548 30600.0n 0.3414 31199.5n 0.3414 31200.0n 0.3344 31799.5n 0.3344 31800.0n 0.5885 32399.5n 0.5885 32400.0n 0.5976 32999.5n 0.5976 33000.0n 0.4794 33599.5n 0.4794 33600.0n 0.5148 34199.5n 0.5148 34200.0n 0.3310 34799.5n 0.3310 34800.0n 0.4097 35399.5n 0.4097 35400.0n 0.5012 35999.5n 0.5012)
Cwp_bh_25 wp_bh_25 0 400p
Cwn_bh_25 wn_bh_25 0 400p
Xu_bh_25 xp_bh_25 xn_bh_25 yp_bh_25 yn_bh_25 wp_bh_25 wn_bh_25 vdd gbn gprod
Vxp_wih_0_26 xp_wih_0_26 0 PWL(0.0n 0.4942 599.5n 0.4942 600.0n 0.5558 1199.5n 0.5558 1200.0n 0.4708 1799.5n 0.4708 1800.0n 0.5235 2399.5n 0.5235 2400.0n 0.5350 2999.5n 0.5350 3000.0n 0.5172 3599.5n 0.5172 3600.0n 0.4702 4199.5n 0.4702 4200.0n 0.4867 4799.5n 0.4867 4800.0n 0.4970 5399.5n 0.4970 5400.0n 0.4986 5999.5n 0.4986 6000.0n 0.4751 6599.5n 0.4751 6600.0n 0.4870 7199.5n 0.4870 7200.0n 0.5502 7799.5n 0.5502 7800.0n 0.5521 8399.5n 0.5521 8400.0n 0.4638 8999.5n 0.4638 9000.0n 0.4982 9599.5n 0.4982 9600.0n 0.5131 10199.5n 0.5131 10200.0n 0.5386 10799.5n 0.5386 10800.0n 0.4592 11399.5n 0.4592 11400.0n 0.4950 11999.5n 0.4950 12000.0n 0.4559 12599.5n 0.4559 12600.0n 0.5162 13199.5n 0.5162 13200.0n 0.5038 13799.5n 0.5038 13800.0n 0.5333 14399.5n 0.5333 14400.0n 0.4991 14999.5n 0.4991 15000.0n 0.5298 15599.5n 0.5298 15600.0n 0.4823 16199.5n 0.4823 16200.0n 0.5239 16799.5n 0.5239 16800.0n 0.4592 17399.5n 0.4592 17400.0n 0.5094 17999.5n 0.5094 18000.0n 0.4337 18599.5n 0.4337 18600.0n 0.5977 19199.5n 0.5977 19200.0n 0.5364 19799.5n 0.5364 19800.0n 0.6122 20399.5n 0.6122 20400.0n 0.4856 20999.5n 0.4856 21000.0n 0.3861 21599.5n 0.3861 21600.0n 0.6094 22199.5n 0.6094 22200.0n 0.6364 22799.5n 0.6364 22800.0n 0.4807 23399.5n 0.4807 23400.0n 0.5614 23999.5n 0.5614 24000.0n 0.5913 24599.5n 0.5913 24600.0n 0.6295 25199.5n 0.6295 25200.0n 0.4496 25799.5n 0.4496 25800.0n 0.3792 26399.5n 0.3792 26400.0n 0.4434 26999.5n 0.4434 27000.0n 0.4340 27599.5n 0.4340 27600.0n 0.4461 28199.5n 0.4461 28200.0n 0.5791 28799.5n 0.5791 28800.0n 0.4777 29399.5n 0.4777 29400.0n 0.3878 29999.5n 0.3878 30000.0n 0.3832 30599.5n 0.3832 30600.0n 0.4022 31199.5n 0.4022 31200.0n 0.4482 31799.5n 0.4482 31800.0n 0.3662 32399.5n 0.3662 32400.0n 0.3857 32999.5n 0.3857 33000.0n 0.5584 33599.5n 0.5584 33600.0n 0.5284 34199.5n 0.5284 34200.0n 0.6034 34799.5n 0.6034 34800.0n 0.3469 35399.5n 0.3469 35400.0n 0.5290 35999.5n 0.5290)
Vxn_wih_0_26 xn_wih_0_26 0 PWL(0.0n 0.5058 599.5n 0.5058 600.0n 0.4442 1199.5n 0.4442 1200.0n 0.5292 1799.5n 0.5292 1800.0n 0.4765 2399.5n 0.4765 2400.0n 0.4650 2999.5n 0.4650 3000.0n 0.4828 3599.5n 0.4828 3600.0n 0.5298 4199.5n 0.5298 4200.0n 0.5133 4799.5n 0.5133 4800.0n 0.5030 5399.5n 0.5030 5400.0n 0.5014 5999.5n 0.5014 6000.0n 0.5249 6599.5n 0.5249 6600.0n 0.5130 7199.5n 0.5130 7200.0n 0.4498 7799.5n 0.4498 7800.0n 0.4479 8399.5n 0.4479 8400.0n 0.5362 8999.5n 0.5362 9000.0n 0.5018 9599.5n 0.5018 9600.0n 0.4869 10199.5n 0.4869 10200.0n 0.4614 10799.5n 0.4614 10800.0n 0.5408 11399.5n 0.5408 11400.0n 0.5050 11999.5n 0.5050 12000.0n 0.5441 12599.5n 0.5441 12600.0n 0.4838 13199.5n 0.4838 13200.0n 0.4962 13799.5n 0.4962 13800.0n 0.4667 14399.5n 0.4667 14400.0n 0.5009 14999.5n 0.5009 15000.0n 0.4702 15599.5n 0.4702 15600.0n 0.5177 16199.5n 0.5177 16200.0n 0.4761 16799.5n 0.4761 16800.0n 0.5408 17399.5n 0.5408 17400.0n 0.4906 17999.5n 0.4906 18000.0n 0.5663 18599.5n 0.5663 18600.0n 0.4023 19199.5n 0.4023 19200.0n 0.4636 19799.5n 0.4636 19800.0n 0.3878 20399.5n 0.3878 20400.0n 0.5144 20999.5n 0.5144 21000.0n 0.6139 21599.5n 0.6139 21600.0n 0.3906 22199.5n 0.3906 22200.0n 0.3636 22799.5n 0.3636 22800.0n 0.5193 23399.5n 0.5193 23400.0n 0.4386 23999.5n 0.4386 24000.0n 0.4087 24599.5n 0.4087 24600.0n 0.3705 25199.5n 0.3705 25200.0n 0.5504 25799.5n 0.5504 25800.0n 0.6208 26399.5n 0.6208 26400.0n 0.5566 26999.5n 0.5566 27000.0n 0.5660 27599.5n 0.5660 27600.0n 0.5539 28199.5n 0.5539 28200.0n 0.4209 28799.5n 0.4209 28800.0n 0.5223 29399.5n 0.5223 29400.0n 0.6122 29999.5n 0.6122 30000.0n 0.6168 30599.5n 0.6168 30600.0n 0.5978 31199.5n 0.5978 31200.0n 0.5518 31799.5n 0.5518 31800.0n 0.6338 32399.5n 0.6338 32400.0n 0.6143 32999.5n 0.6143 33000.0n 0.4416 33599.5n 0.4416 33600.0n 0.4716 34199.5n 0.4716 34200.0n 0.3966 34799.5n 0.3966 34800.0n 0.6531 35399.5n 0.6531 35400.0n 0.4710 35999.5n 0.4710)
Vyp_wih_0_26 yp_wih_0_26 0 PWL(0.0n 0.4845 599.5n 0.4845 600.0n 0.5448 1199.5n 0.5448 1200.0n 0.4786 1799.5n 0.4786 1800.0n 0.5270 2399.5n 0.5270 2400.0n 0.5328 2999.5n 0.5328 3000.0n 0.5073 3599.5n 0.5073 3600.0n 0.4754 4199.5n 0.4754 4200.0n 0.4790 4799.5n 0.4790 4800.0n 0.4938 5399.5n 0.4938 5400.0n 0.4950 5999.5n 0.4950 6000.0n 0.4842 6599.5n 0.4842 6600.0n 0.4850 7199.5n 0.4850 7200.0n 0.5399 7799.5n 0.5399 7800.0n 0.5436 8399.5n 0.5436 8400.0n 0.4625 8999.5n 0.4625 9000.0n 0.4946 9599.5n 0.4946 9600.0n 0.5073 10199.5n 0.5073 10200.0n 0.5296 10799.5n 0.5296 10800.0n 0.4668 11399.5n 0.4668 11400.0n 0.4915 11999.5n 0.4915 12000.0n 0.4532 12599.5n 0.4532 12600.0n 0.5100 13199.5n 0.5100 13200.0n 0.4907 13799.5n 0.4907 13800.0n 0.5173 14399.5n 0.5173 14400.0n 0.4939 14999.5n 0.4939 15000.0n 0.5241 15599.5n 0.5241 15600.0n 0.4781 16199.5n 0.4781 16200.0n 0.5056 16799.5n 0.5056 16800.0n 0.4584 17399.5n 0.4584 17400.0n 0.4955 17999.5n 0.4955 18000.0n 0.4489 18599.5n 0.4489 18600.0n 0.5942 19199.5n 0.5942 19200.0n 0.5538 19799.5n 0.5538 19800.0n 0.6219 20399.5n 0.6219 20400.0n 0.5177 20999.5n 0.5177 21000.0n 0.3947 21599.5n 0.3947 21600.0n 0.6117 22199.5n 0.6117 22200.0n 0.6099 22799.5n 0.6099 22800.0n 0.5155 23399.5n 0.5155 23400.0n 0.5249 23999.5n 0.5249 24000.0n 0.6239 24599.5n 0.6239 24600.0n 0.6038 25199.5n 0.6038 25200.0n 0.4809 25799.5n 0.4809 25800.0n 0.4171 26399.5n 0.4171 26400.0n 0.4755 26999.5n 0.4755 27000.0n 0.4547 27599.5n 0.4547 27600.0n 0.4797 28199.5n 0.4797 28200.0n 0.5549 28799.5n 0.5549 28800.0n 0.5129 29399.5n 0.5129 29400.0n 0.3927 29999.5n 0.3927 30000.0n 0.3868 30599.5n 0.3868 30600.0n 0.3697 31199.5n 0.3697 31200.0n 0.4204 31799.5n 0.4204 31800.0n 0.4102 32399.5n 0.4102 32400.0n 0.4198 32999.5n 0.4198 33000.0n 0.5839 33599.5n 0.5839 33600.0n 0.5496 34199.5n 0.5496 34200.0n 0.5899 34799.5n 0.5899 34800.0n 0.3720 35399.5n 0.3720 35400.0n 0.5492 35999.5n 0.5492)
Vyn_wih_0_26 yn_wih_0_26 0 PWL(0.0n 0.5155 599.5n 0.5155 600.0n 0.4552 1199.5n 0.4552 1200.0n 0.5214 1799.5n 0.5214 1800.0n 0.4730 2399.5n 0.4730 2400.0n 0.4672 2999.5n 0.4672 3000.0n 0.4927 3599.5n 0.4927 3600.0n 0.5246 4199.5n 0.5246 4200.0n 0.5210 4799.5n 0.5210 4800.0n 0.5062 5399.5n 0.5062 5400.0n 0.5050 5999.5n 0.5050 6000.0n 0.5158 6599.5n 0.5158 6600.0n 0.5150 7199.5n 0.5150 7200.0n 0.4601 7799.5n 0.4601 7800.0n 0.4564 8399.5n 0.4564 8400.0n 0.5375 8999.5n 0.5375 9000.0n 0.5054 9599.5n 0.5054 9600.0n 0.4927 10199.5n 0.4927 10200.0n 0.4704 10799.5n 0.4704 10800.0n 0.5332 11399.5n 0.5332 11400.0n 0.5085 11999.5n 0.5085 12000.0n 0.5468 12599.5n 0.5468 12600.0n 0.4900 13199.5n 0.4900 13200.0n 0.5093 13799.5n 0.5093 13800.0n 0.4827 14399.5n 0.4827 14400.0n 0.5061 14999.5n 0.5061 15000.0n 0.4759 15599.5n 0.4759 15600.0n 0.5219 16199.5n 0.5219 16200.0n 0.4944 16799.5n 0.4944 16800.0n 0.5416 17399.5n 0.5416 17400.0n 0.5045 17999.5n 0.5045 18000.0n 0.5511 18599.5n 0.5511 18600.0n 0.4058 19199.5n 0.4058 19200.0n 0.4462 19799.5n 0.4462 19800.0n 0.3781 20399.5n 0.3781 20400.0n 0.4823 20999.5n 0.4823 21000.0n 0.6053 21599.5n 0.6053 21600.0n 0.3883 22199.5n 0.3883 22200.0n 0.3901 22799.5n 0.3901 22800.0n 0.4845 23399.5n 0.4845 23400.0n 0.4751 23999.5n 0.4751 24000.0n 0.3761 24599.5n 0.3761 24600.0n 0.3962 25199.5n 0.3962 25200.0n 0.5191 25799.5n 0.5191 25800.0n 0.5829 26399.5n 0.5829 26400.0n 0.5245 26999.5n 0.5245 27000.0n 0.5453 27599.5n 0.5453 27600.0n 0.5203 28199.5n 0.5203 28200.0n 0.4451 28799.5n 0.4451 28800.0n 0.4871 29399.5n 0.4871 29400.0n 0.6073 29999.5n 0.6073 30000.0n 0.6132 30599.5n 0.6132 30600.0n 0.6303 31199.5n 0.6303 31200.0n 0.5796 31799.5n 0.5796 31800.0n 0.5898 32399.5n 0.5898 32400.0n 0.5802 32999.5n 0.5802 33000.0n 0.4161 33599.5n 0.4161 33600.0n 0.4504 34199.5n 0.4504 34200.0n 0.4101 34799.5n 0.4101 34800.0n 0.6280 35399.5n 0.6280 35400.0n 0.4508 35999.5n 0.4508)
Cwp_wih_0_26 wp_wih_0_26 0 400p
Cwn_wih_0_26 wn_wih_0_26 0 400p
Xu_wih_0_26 xp_wih_0_26 xn_wih_0_26 yp_wih_0_26 yn_wih_0_26 wp_wih_0_26 wn_wih_0_26 vdd gbn gprod
Vxp_wih_1_26 xp_wih_1_26 0 PWL(0.0n 0.5370 599.5n 0.5370 600.0n 0.5167 1199.5n 0.5167 1200.0n 0.4793 1799.5n 0.4793 1800.0n 0.4441 2399.5n 0.4441 2400.0n 0.4555 2999.5n 0.4555 3000.0n 0.5055 3599.5n 0.5055 3600.0n 0.4939 4199.5n 0.4939 4200.0n 0.5385 4799.5n 0.5385 4800.0n 0.5024 5399.5n 0.5024 5400.0n 0.5015 5999.5n 0.5015 6000.0n 0.4700 6599.5n 0.4700 6600.0n 0.5120 7199.5n 0.5120 7200.0n 0.5006 7799.5n 0.5006 7800.0n 0.4950 8399.5n 0.4950 8400.0n 0.5309 8999.5n 0.5309 9000.0n 0.5023 9599.5n 0.5023 9600.0n 0.4893 10199.5n 0.4893 10200.0n 0.4837 10799.5n 0.4837 10800.0n 0.4823 11399.5n 0.4823 11400.0n 0.5074 11999.5n 0.5074 12000.0n 0.5364 12599.5n 0.5364 12600.0n 0.4868 13199.5n 0.4868 13200.0n 0.5380 13799.5n 0.5380 13800.0n 0.5220 14399.5n 0.5220 14400.0n 0.5095 14999.5n 0.5095 15000.0n 0.4705 15599.5n 0.4705 15600.0n 0.5289 16199.5n 0.5289 16200.0n 0.5368 16799.5n 0.5368 16800.0n 0.5287 17399.5n 0.5287 17400.0n 0.5342 17999.5n 0.5342 18000.0n 0.4253 18599.5n 0.4253 18600.0n 0.5119 19199.5n 0.5119 19200.0n 0.4104 19799.5n 0.4104 19800.0n 0.4314 20399.5n 0.4314 20400.0n 0.4005 20999.5n 0.4005 21000.0n 0.4696 21599.5n 0.4696 21600.0n 0.4531 22199.5n 0.4531 22200.0n 0.5039 22799.5n 0.5039 22800.0n 0.3608 23399.5n 0.3608 23400.0n 0.6273 23999.5n 0.6273 24000.0n 0.3928 24599.5n 0.3928 24600.0n 0.5253 25199.5n 0.5253 25200.0n 0.4107 25799.5n 0.4107 25800.0n 0.3947 26399.5n 0.3947 26400.0n 0.3716 26999.5n 0.3716 27000.0n 0.4111 27599.5n 0.4111 27600.0n 0.3715 28199.5n 0.3715 28200.0n 0.5939 28799.5n 0.5939 28800.0n 0.3849 29399.5n 0.3849 29400.0n 0.4835 29999.5n 0.4835 30000.0n 0.5119 30599.5n 0.5119 30600.0n 0.6226 31199.5n 0.6226 31200.0n 0.6064 31799.5n 0.6064 31800.0n 0.4115 32399.5n 0.4115 32400.0n 0.3900 32999.5n 0.3900 33000.0n 0.3958 33599.5n 0.3958 33600.0n 0.3747 34199.5n 0.3747 34200.0n 0.5423 34799.5n 0.5423 34800.0n 0.5509 35399.5n 0.5509 35400.0n 0.3990 35999.5n 0.3990)
Vxn_wih_1_26 xn_wih_1_26 0 PWL(0.0n 0.4630 599.5n 0.4630 600.0n 0.4833 1199.5n 0.4833 1200.0n 0.5207 1799.5n 0.5207 1800.0n 0.5559 2399.5n 0.5559 2400.0n 0.5445 2999.5n 0.5445 3000.0n 0.4945 3599.5n 0.4945 3600.0n 0.5061 4199.5n 0.5061 4200.0n 0.4615 4799.5n 0.4615 4800.0n 0.4976 5399.5n 0.4976 5400.0n 0.4985 5999.5n 0.4985 6000.0n 0.5300 6599.5n 0.5300 6600.0n 0.4880 7199.5n 0.4880 7200.0n 0.4994 7799.5n 0.4994 7800.0n 0.5050 8399.5n 0.5050 8400.0n 0.4691 8999.5n 0.4691 9000.0n 0.4977 9599.5n 0.4977 9600.0n 0.5107 10199.5n 0.5107 10200.0n 0.5163 10799.5n 0.5163 10800.0n 0.5177 11399.5n 0.5177 11400.0n 0.4926 11999.5n 0.4926 12000.0n 0.4636 12599.5n 0.4636 12600.0n 0.5132 13199.5n 0.5132 13200.0n 0.4620 13799.5n 0.4620 13800.0n 0.4780 14399.5n 0.4780 14400.0n 0.4905 14999.5n 0.4905 15000.0n 0.5295 15599.5n 0.5295 15600.0n 0.4711 16199.5n 0.4711 16200.0n 0.4632 16799.5n 0.4632 16800.0n 0.4713 17399.5n 0.4713 17400.0n 0.4658 17999.5n 0.4658 18000.0n 0.5747 18599.5n 0.5747 18600.0n 0.4881 19199.5n 0.4881 19200.0n 0.5896 19799.5n 0.5896 19800.0n 0.5686 20399.5n 0.5686 20400.0n 0.5995 20999.5n 0.5995 21000.0n 0.5304 21599.5n 0.5304 21600.0n 0.5469 22199.5n 0.5469 22200.0n 0.4961 22799.5n 0.4961 22800.0n 0.6392 23399.5n 0.6392 23400.0n 0.3727 23999.5n 0.3727 24000.0n 0.6072 24599.5n 0.6072 24600.0n 0.4747 25199.5n 0.4747 25200.0n 0.5893 25799.5n 0.5893 25800.0n 0.6053 26399.5n 0.6053 26400.0n 0.6284 26999.5n 0.6284 27000.0n 0.5889 27599.5n 0.5889 27600.0n 0.6285 28199.5n 0.6285 28200.0n 0.4061 28799.5n 0.4061 28800.0n 0.6151 29399.5n 0.6151 29400.0n 0.5165 29999.5n 0.5165 30000.0n 0.4881 30599.5n 0.4881 30600.0n 0.3774 31199.5n 0.3774 31200.0n 0.3936 31799.5n 0.3936 31800.0n 0.5885 32399.5n 0.5885 32400.0n 0.6100 32999.5n 0.6100 33000.0n 0.6042 33599.5n 0.6042 33600.0n 0.6253 34199.5n 0.6253 34200.0n 0.4577 34799.5n 0.4577 34800.0n 0.4491 35399.5n 0.4491 35400.0n 0.6010 35999.5n 0.6010)
Vyp_wih_1_26 yp_wih_1_26 0 PWL(0.0n 0.4845 599.5n 0.4845 600.0n 0.5448 1199.5n 0.5448 1200.0n 0.4786 1799.5n 0.4786 1800.0n 0.5270 2399.5n 0.5270 2400.0n 0.5328 2999.5n 0.5328 3000.0n 0.5073 3599.5n 0.5073 3600.0n 0.4754 4199.5n 0.4754 4200.0n 0.4790 4799.5n 0.4790 4800.0n 0.4938 5399.5n 0.4938 5400.0n 0.4950 5999.5n 0.4950 6000.0n 0.4842 6599.5n 0.4842 6600.0n 0.4850 7199.5n 0.4850 7200.0n 0.5399 7799.5n 0.5399 7800.0n 0.5436 8399.5n 0.5436 8400.0n 0.4625 8999.5n 0.4625 9000.0n 0.4946 9599.5n 0.4946 9600.0n 0.5073 10199.5n 0.5073 10200.0n 0.5296 10799.5n 0.5296 10800.0n 0.4668 11399.5n 0.4668 11400.0n 0.4915 11999.5n 0.4915 12000.0n 0.4532 12599.5n 0.4532 12600.0n 0.5100 13199.5n 0.5100 13200.0n 0.4907 13799.5n 0.4907 13800.0n 0.5173 14399.5n 0.5173 14400.0n 0.4939 14999.5n 0.4939 15000.0n 0.5241 15599.5n 0.5241 15600.0n 0.4781 16199.5n 0.4781 16200.0n 0.5056 16799.5n 0.5056 16800.0n 0.4584 17399.5n 0.4584 17400.0n 0.4955 17999.5n 0.4955 18000.0n 0.4489 18599.5n 0.4489 18600.0n 0.5942 19199.5n 0.5942 19200.0n 0.5538 19799.5n 0.5538 19800.0n 0.6219 20399.5n 0.6219 20400.0n 0.5177 20999.5n 0.5177 21000.0n 0.3947 21599.5n 0.3947 21600.0n 0.6117 22199.5n 0.6117 22200.0n 0.6099 22799.5n 0.6099 22800.0n 0.5155 23399.5n 0.5155 23400.0n 0.5249 23999.5n 0.5249 24000.0n 0.6239 24599.5n 0.6239 24600.0n 0.6038 25199.5n 0.6038 25200.0n 0.4809 25799.5n 0.4809 25800.0n 0.4171 26399.5n 0.4171 26400.0n 0.4755 26999.5n 0.4755 27000.0n 0.4547 27599.5n 0.4547 27600.0n 0.4797 28199.5n 0.4797 28200.0n 0.5549 28799.5n 0.5549 28800.0n 0.5129 29399.5n 0.5129 29400.0n 0.3927 29999.5n 0.3927 30000.0n 0.3868 30599.5n 0.3868 30600.0n 0.3697 31199.5n 0.3697 31200.0n 0.4204 31799.5n 0.4204 31800.0n 0.4102 32399.5n 0.4102 32400.0n 0.4198 32999.5n 0.4198 33000.0n 0.5839 33599.5n 0.5839 33600.0n 0.5496 34199.5n 0.5496 34200.0n 0.5899 34799.5n 0.5899 34800.0n 0.3720 35399.5n 0.3720 35400.0n 0.5492 35999.5n 0.5492)
Vyn_wih_1_26 yn_wih_1_26 0 PWL(0.0n 0.5155 599.5n 0.5155 600.0n 0.4552 1199.5n 0.4552 1200.0n 0.5214 1799.5n 0.5214 1800.0n 0.4730 2399.5n 0.4730 2400.0n 0.4672 2999.5n 0.4672 3000.0n 0.4927 3599.5n 0.4927 3600.0n 0.5246 4199.5n 0.5246 4200.0n 0.5210 4799.5n 0.5210 4800.0n 0.5062 5399.5n 0.5062 5400.0n 0.5050 5999.5n 0.5050 6000.0n 0.5158 6599.5n 0.5158 6600.0n 0.5150 7199.5n 0.5150 7200.0n 0.4601 7799.5n 0.4601 7800.0n 0.4564 8399.5n 0.4564 8400.0n 0.5375 8999.5n 0.5375 9000.0n 0.5054 9599.5n 0.5054 9600.0n 0.4927 10199.5n 0.4927 10200.0n 0.4704 10799.5n 0.4704 10800.0n 0.5332 11399.5n 0.5332 11400.0n 0.5085 11999.5n 0.5085 12000.0n 0.5468 12599.5n 0.5468 12600.0n 0.4900 13199.5n 0.4900 13200.0n 0.5093 13799.5n 0.5093 13800.0n 0.4827 14399.5n 0.4827 14400.0n 0.5061 14999.5n 0.5061 15000.0n 0.4759 15599.5n 0.4759 15600.0n 0.5219 16199.5n 0.5219 16200.0n 0.4944 16799.5n 0.4944 16800.0n 0.5416 17399.5n 0.5416 17400.0n 0.5045 17999.5n 0.5045 18000.0n 0.5511 18599.5n 0.5511 18600.0n 0.4058 19199.5n 0.4058 19200.0n 0.4462 19799.5n 0.4462 19800.0n 0.3781 20399.5n 0.3781 20400.0n 0.4823 20999.5n 0.4823 21000.0n 0.6053 21599.5n 0.6053 21600.0n 0.3883 22199.5n 0.3883 22200.0n 0.3901 22799.5n 0.3901 22800.0n 0.4845 23399.5n 0.4845 23400.0n 0.4751 23999.5n 0.4751 24000.0n 0.3761 24599.5n 0.3761 24600.0n 0.3962 25199.5n 0.3962 25200.0n 0.5191 25799.5n 0.5191 25800.0n 0.5829 26399.5n 0.5829 26400.0n 0.5245 26999.5n 0.5245 27000.0n 0.5453 27599.5n 0.5453 27600.0n 0.5203 28199.5n 0.5203 28200.0n 0.4451 28799.5n 0.4451 28800.0n 0.4871 29399.5n 0.4871 29400.0n 0.6073 29999.5n 0.6073 30000.0n 0.6132 30599.5n 0.6132 30600.0n 0.6303 31199.5n 0.6303 31200.0n 0.5796 31799.5n 0.5796 31800.0n 0.5898 32399.5n 0.5898 32400.0n 0.5802 32999.5n 0.5802 33000.0n 0.4161 33599.5n 0.4161 33600.0n 0.4504 34199.5n 0.4504 34200.0n 0.4101 34799.5n 0.4101 34800.0n 0.6280 35399.5n 0.6280 35400.0n 0.4508 35999.5n 0.4508)
Cwp_wih_1_26 wp_wih_1_26 0 400p
Cwn_wih_1_26 wn_wih_1_26 0 400p
Xu_wih_1_26 xp_wih_1_26 xn_wih_1_26 yp_wih_1_26 yn_wih_1_26 wp_wih_1_26 wn_wih_1_26 vdd gbn gprod
Vxp_who_26_0 xp_who_26_0 0 PWL(0.0n 0.4845 599.5n 0.4845 600.0n 0.5448 1199.5n 0.5448 1200.0n 0.4786 1799.5n 0.4786 1800.0n 0.5270 2399.5n 0.5270 2400.0n 0.5328 2999.5n 0.5328 3000.0n 0.5073 3599.5n 0.5073 3600.0n 0.4754 4199.5n 0.4754 4200.0n 0.4790 4799.5n 0.4790 4800.0n 0.4938 5399.5n 0.4938 5400.0n 0.4950 5999.5n 0.4950 6000.0n 0.4842 6599.5n 0.4842 6600.0n 0.4850 7199.5n 0.4850 7200.0n 0.5399 7799.5n 0.5399 7800.0n 0.5436 8399.5n 0.5436 8400.0n 0.4625 8999.5n 0.4625 9000.0n 0.4946 9599.5n 0.4946 9600.0n 0.5073 10199.5n 0.5073 10200.0n 0.5296 10799.5n 0.5296 10800.0n 0.4668 11399.5n 0.4668 11400.0n 0.4915 11999.5n 0.4915 12000.0n 0.4532 12599.5n 0.4532 12600.0n 0.5100 13199.5n 0.5100 13200.0n 0.4907 13799.5n 0.4907 13800.0n 0.5173 14399.5n 0.5173 14400.0n 0.4939 14999.5n 0.4939 15000.0n 0.5241 15599.5n 0.5241 15600.0n 0.4781 16199.5n 0.4781 16200.0n 0.5056 16799.5n 0.5056 16800.0n 0.4584 17399.5n 0.4584 17400.0n 0.4955 17999.5n 0.4955 18000.0n 0.4489 18599.5n 0.4489 18600.0n 0.5942 19199.5n 0.5942 19200.0n 0.5538 19799.5n 0.5538 19800.0n 0.6219 20399.5n 0.6219 20400.0n 0.5177 20999.5n 0.5177 21000.0n 0.3947 21599.5n 0.3947 21600.0n 0.6117 22199.5n 0.6117 22200.0n 0.6099 22799.5n 0.6099 22800.0n 0.5155 23399.5n 0.5155 23400.0n 0.5249 23999.5n 0.5249 24000.0n 0.6239 24599.5n 0.6239 24600.0n 0.6038 25199.5n 0.6038 25200.0n 0.4809 25799.5n 0.4809 25800.0n 0.4171 26399.5n 0.4171 26400.0n 0.4755 26999.5n 0.4755 27000.0n 0.4547 27599.5n 0.4547 27600.0n 0.4797 28199.5n 0.4797 28200.0n 0.5549 28799.5n 0.5549 28800.0n 0.5129 29399.5n 0.5129 29400.0n 0.3927 29999.5n 0.3927 30000.0n 0.3868 30599.5n 0.3868 30600.0n 0.3697 31199.5n 0.3697 31200.0n 0.4204 31799.5n 0.4204 31800.0n 0.4102 32399.5n 0.4102 32400.0n 0.4198 32999.5n 0.4198 33000.0n 0.5839 33599.5n 0.5839 33600.0n 0.5496 34199.5n 0.5496 34200.0n 0.5899 34799.5n 0.5899 34800.0n 0.3720 35399.5n 0.3720 35400.0n 0.5492 35999.5n 0.5492)
Vxn_who_26_0 xn_who_26_0 0 PWL(0.0n 0.5155 599.5n 0.5155 600.0n 0.4552 1199.5n 0.4552 1200.0n 0.5214 1799.5n 0.5214 1800.0n 0.4730 2399.5n 0.4730 2400.0n 0.4672 2999.5n 0.4672 3000.0n 0.4927 3599.5n 0.4927 3600.0n 0.5246 4199.5n 0.5246 4200.0n 0.5210 4799.5n 0.5210 4800.0n 0.5062 5399.5n 0.5062 5400.0n 0.5050 5999.5n 0.5050 6000.0n 0.5158 6599.5n 0.5158 6600.0n 0.5150 7199.5n 0.5150 7200.0n 0.4601 7799.5n 0.4601 7800.0n 0.4564 8399.5n 0.4564 8400.0n 0.5375 8999.5n 0.5375 9000.0n 0.5054 9599.5n 0.5054 9600.0n 0.4927 10199.5n 0.4927 10200.0n 0.4704 10799.5n 0.4704 10800.0n 0.5332 11399.5n 0.5332 11400.0n 0.5085 11999.5n 0.5085 12000.0n 0.5468 12599.5n 0.5468 12600.0n 0.4900 13199.5n 0.4900 13200.0n 0.5093 13799.5n 0.5093 13800.0n 0.4827 14399.5n 0.4827 14400.0n 0.5061 14999.5n 0.5061 15000.0n 0.4759 15599.5n 0.4759 15600.0n 0.5219 16199.5n 0.5219 16200.0n 0.4944 16799.5n 0.4944 16800.0n 0.5416 17399.5n 0.5416 17400.0n 0.5045 17999.5n 0.5045 18000.0n 0.5511 18599.5n 0.5511 18600.0n 0.4058 19199.5n 0.4058 19200.0n 0.4462 19799.5n 0.4462 19800.0n 0.3781 20399.5n 0.3781 20400.0n 0.4823 20999.5n 0.4823 21000.0n 0.6053 21599.5n 0.6053 21600.0n 0.3883 22199.5n 0.3883 22200.0n 0.3901 22799.5n 0.3901 22800.0n 0.4845 23399.5n 0.4845 23400.0n 0.4751 23999.5n 0.4751 24000.0n 0.3761 24599.5n 0.3761 24600.0n 0.3962 25199.5n 0.3962 25200.0n 0.5191 25799.5n 0.5191 25800.0n 0.5829 26399.5n 0.5829 26400.0n 0.5245 26999.5n 0.5245 27000.0n 0.5453 27599.5n 0.5453 27600.0n 0.5203 28199.5n 0.5203 28200.0n 0.4451 28799.5n 0.4451 28800.0n 0.4871 29399.5n 0.4871 29400.0n 0.6073 29999.5n 0.6073 30000.0n 0.6132 30599.5n 0.6132 30600.0n 0.6303 31199.5n 0.6303 31200.0n 0.5796 31799.5n 0.5796 31800.0n 0.5898 32399.5n 0.5898 32400.0n 0.5802 32999.5n 0.5802 33000.0n 0.4161 33599.5n 0.4161 33600.0n 0.4504 34199.5n 0.4504 34200.0n 0.4101 34799.5n 0.4101 34800.0n 0.6280 35399.5n 0.6280 35400.0n 0.4508 35999.5n 0.4508)
Vyp_who_26_0 yp_who_26_0 0 PWL(0.0n 0.5031 599.5n 0.5031 600.0n 0.5023 1199.5n 0.5023 1200.0n 0.5052 1799.5n 0.5052 1800.0n 0.5048 2399.5n 0.5048 2400.0n 0.5043 2999.5n 0.5043 3000.0n 0.5034 3599.5n 0.5034 3600.0n 0.5048 4199.5n 0.5048 4200.0n 0.5031 4799.5n 0.5031 4800.0n 0.5040 5399.5n 0.5040 5400.0n 0.5040 5999.5n 0.5040 6000.0n 0.5054 6599.5n 0.5054 6600.0n 0.5040 7199.5n 0.5040 7200.0n 0.5027 7799.5n 0.5027 7800.0n 0.5027 8399.5n 0.5027 8400.0n 0.5038 8999.5n 0.5038 9000.0n 0.5040 9599.5n 0.5040 9600.0n 0.5039 10199.5n 0.5039 10200.0n 0.5033 10799.5n 0.5033 10800.0n 0.5056 11399.5n 0.5056 11400.0n 0.5040 11999.5n 0.5040 12000.0n 0.5036 12599.5n 0.5036 12600.0n 0.5039 13199.5n 0.5039 13200.0n 0.5029 13799.5n 0.5029 13800.0n 0.5025 14399.5n 0.5025 14400.0n 0.5038 14999.5n 0.5038 15000.0n 0.5041 15599.5n 0.5041 15600.0n 0.5036 16199.5n 0.5036 16200.0n 0.5025 16799.5n 0.5025 16800.0n 0.5040 17399.5n 0.5040 17400.0n 0.5029 17999.5n 0.5029 18000.0n 0.5057 18599.5n 0.5057 18600.0n 0.5010 19199.5n 0.5010 19200.0n 0.5041 19799.5n 0.5041 19800.0n 0.5021 20399.5n 0.5021 20400.0n 0.5044 20999.5n 0.5044 21000.0n 0.5056 21599.5n 0.5056 21600.0n 0.5016 22199.5n 0.5016 22200.0n 0.5006 22799.5n 0.5006 22800.0n 0.5041 23399.5n 0.5041 23400.0n 0.5027 23999.5n 0.5027 24000.0n 0.5029 24599.5n 0.5029 24600.0n 0.5006 25199.5n 0.5006 25200.0n 0.5047 25799.5n 0.5047 25800.0n 0.5046 26399.5n 0.5046 26400.0n 0.5039 26999.5n 0.5039 27000.0n 0.5049 27599.5n 0.5049 27600.0n 0.5039 28199.5n 0.5039 28200.0n 0.5017 28799.5n 0.5017 28800.0n 0.5042 29399.5n 0.5042 29400.0n 0.5056 29999.5n 0.5056 30000.0n 0.5051 30599.5n 0.5051 30600.0n 0.5039 31199.5n 0.5039 31200.0n 0.5033 31799.5n 0.5033 31800.0n 0.5049 32399.5n 0.5049 32400.0n 0.5045 32999.5n 0.5045 33000.0n 0.5036 33599.5n 0.5036 33600.0n 0.5042 34199.5n 0.5042 34200.0n 0.5012 34799.5n 0.5012 34800.0n 0.5036 35399.5n 0.5036 35400.0n 0.5042 35999.5n 0.5042)
Vyn_who_26_0 yn_who_26_0 0 PWL(0.0n 0.4969 599.5n 0.4969 600.0n 0.4977 1199.5n 0.4977 1200.0n 0.4948 1799.5n 0.4948 1800.0n 0.4952 2399.5n 0.4952 2400.0n 0.4957 2999.5n 0.4957 3000.0n 0.4966 3599.5n 0.4966 3600.0n 0.4952 4199.5n 0.4952 4200.0n 0.4969 4799.5n 0.4969 4800.0n 0.4960 5399.5n 0.4960 5400.0n 0.4960 5999.5n 0.4960 6000.0n 0.4946 6599.5n 0.4946 6600.0n 0.4960 7199.5n 0.4960 7200.0n 0.4973 7799.5n 0.4973 7800.0n 0.4973 8399.5n 0.4973 8400.0n 0.4962 8999.5n 0.4962 9000.0n 0.4960 9599.5n 0.4960 9600.0n 0.4961 10199.5n 0.4961 10200.0n 0.4967 10799.5n 0.4967 10800.0n 0.4944 11399.5n 0.4944 11400.0n 0.4960 11999.5n 0.4960 12000.0n 0.4964 12599.5n 0.4964 12600.0n 0.4961 13199.5n 0.4961 13200.0n 0.4971 13799.5n 0.4971 13800.0n 0.4975 14399.5n 0.4975 14400.0n 0.4962 14999.5n 0.4962 15000.0n 0.4959 15599.5n 0.4959 15600.0n 0.4964 16199.5n 0.4964 16200.0n 0.4975 16799.5n 0.4975 16800.0n 0.4960 17399.5n 0.4960 17400.0n 0.4971 17999.5n 0.4971 18000.0n 0.4943 18599.5n 0.4943 18600.0n 0.4990 19199.5n 0.4990 19200.0n 0.4959 19799.5n 0.4959 19800.0n 0.4979 20399.5n 0.4979 20400.0n 0.4956 20999.5n 0.4956 21000.0n 0.4944 21599.5n 0.4944 21600.0n 0.4984 22199.5n 0.4984 22200.0n 0.4994 22799.5n 0.4994 22800.0n 0.4959 23399.5n 0.4959 23400.0n 0.4973 23999.5n 0.4973 24000.0n 0.4971 24599.5n 0.4971 24600.0n 0.4994 25199.5n 0.4994 25200.0n 0.4953 25799.5n 0.4953 25800.0n 0.4954 26399.5n 0.4954 26400.0n 0.4961 26999.5n 0.4961 27000.0n 0.4951 27599.5n 0.4951 27600.0n 0.4961 28199.5n 0.4961 28200.0n 0.4983 28799.5n 0.4983 28800.0n 0.4958 29399.5n 0.4958 29400.0n 0.4944 29999.5n 0.4944 30000.0n 0.4949 30599.5n 0.4949 30600.0n 0.4961 31199.5n 0.4961 31200.0n 0.4967 31799.5n 0.4967 31800.0n 0.4951 32399.5n 0.4951 32400.0n 0.4955 32999.5n 0.4955 33000.0n 0.4964 33599.5n 0.4964 33600.0n 0.4958 34199.5n 0.4958 34200.0n 0.4988 34799.5n 0.4988 34800.0n 0.4964 35399.5n 0.4964 35400.0n 0.4958 35999.5n 0.4958)
Cwp_who_26_0 wp_who_26_0 0 400p
Cwn_who_26_0 wn_who_26_0 0 400p
Xu_who_26_0 xp_who_26_0 xn_who_26_0 yp_who_26_0 yn_who_26_0 wp_who_26_0 wn_who_26_0 vdd gbn gprod
Vxp_who_26_1 xp_who_26_1 0 PWL(0.0n 0.4845 599.5n 0.4845 600.0n 0.5448 1199.5n 0.5448 1200.0n 0.4786 1799.5n 0.4786 1800.0n 0.5270 2399.5n 0.5270 2400.0n 0.5328 2999.5n 0.5328 3000.0n 0.5073 3599.5n 0.5073 3600.0n 0.4754 4199.5n 0.4754 4200.0n 0.4790 4799.5n 0.4790 4800.0n 0.4938 5399.5n 0.4938 5400.0n 0.4950 5999.5n 0.4950 6000.0n 0.4842 6599.5n 0.4842 6600.0n 0.4850 7199.5n 0.4850 7200.0n 0.5399 7799.5n 0.5399 7800.0n 0.5436 8399.5n 0.5436 8400.0n 0.4625 8999.5n 0.4625 9000.0n 0.4946 9599.5n 0.4946 9600.0n 0.5073 10199.5n 0.5073 10200.0n 0.5296 10799.5n 0.5296 10800.0n 0.4668 11399.5n 0.4668 11400.0n 0.4915 11999.5n 0.4915 12000.0n 0.4532 12599.5n 0.4532 12600.0n 0.5100 13199.5n 0.5100 13200.0n 0.4907 13799.5n 0.4907 13800.0n 0.5173 14399.5n 0.5173 14400.0n 0.4939 14999.5n 0.4939 15000.0n 0.5241 15599.5n 0.5241 15600.0n 0.4781 16199.5n 0.4781 16200.0n 0.5056 16799.5n 0.5056 16800.0n 0.4584 17399.5n 0.4584 17400.0n 0.4955 17999.5n 0.4955 18000.0n 0.4489 18599.5n 0.4489 18600.0n 0.5942 19199.5n 0.5942 19200.0n 0.5538 19799.5n 0.5538 19800.0n 0.6219 20399.5n 0.6219 20400.0n 0.5177 20999.5n 0.5177 21000.0n 0.3947 21599.5n 0.3947 21600.0n 0.6117 22199.5n 0.6117 22200.0n 0.6099 22799.5n 0.6099 22800.0n 0.5155 23399.5n 0.5155 23400.0n 0.5249 23999.5n 0.5249 24000.0n 0.6239 24599.5n 0.6239 24600.0n 0.6038 25199.5n 0.6038 25200.0n 0.4809 25799.5n 0.4809 25800.0n 0.4171 26399.5n 0.4171 26400.0n 0.4755 26999.5n 0.4755 27000.0n 0.4547 27599.5n 0.4547 27600.0n 0.4797 28199.5n 0.4797 28200.0n 0.5549 28799.5n 0.5549 28800.0n 0.5129 29399.5n 0.5129 29400.0n 0.3927 29999.5n 0.3927 30000.0n 0.3868 30599.5n 0.3868 30600.0n 0.3697 31199.5n 0.3697 31200.0n 0.4204 31799.5n 0.4204 31800.0n 0.4102 32399.5n 0.4102 32400.0n 0.4198 32999.5n 0.4198 33000.0n 0.5839 33599.5n 0.5839 33600.0n 0.5496 34199.5n 0.5496 34200.0n 0.5899 34799.5n 0.5899 34800.0n 0.3720 35399.5n 0.3720 35400.0n 0.5492 35999.5n 0.5492)
Vxn_who_26_1 xn_who_26_1 0 PWL(0.0n 0.5155 599.5n 0.5155 600.0n 0.4552 1199.5n 0.4552 1200.0n 0.5214 1799.5n 0.5214 1800.0n 0.4730 2399.5n 0.4730 2400.0n 0.4672 2999.5n 0.4672 3000.0n 0.4927 3599.5n 0.4927 3600.0n 0.5246 4199.5n 0.5246 4200.0n 0.5210 4799.5n 0.5210 4800.0n 0.5062 5399.5n 0.5062 5400.0n 0.5050 5999.5n 0.5050 6000.0n 0.5158 6599.5n 0.5158 6600.0n 0.5150 7199.5n 0.5150 7200.0n 0.4601 7799.5n 0.4601 7800.0n 0.4564 8399.5n 0.4564 8400.0n 0.5375 8999.5n 0.5375 9000.0n 0.5054 9599.5n 0.5054 9600.0n 0.4927 10199.5n 0.4927 10200.0n 0.4704 10799.5n 0.4704 10800.0n 0.5332 11399.5n 0.5332 11400.0n 0.5085 11999.5n 0.5085 12000.0n 0.5468 12599.5n 0.5468 12600.0n 0.4900 13199.5n 0.4900 13200.0n 0.5093 13799.5n 0.5093 13800.0n 0.4827 14399.5n 0.4827 14400.0n 0.5061 14999.5n 0.5061 15000.0n 0.4759 15599.5n 0.4759 15600.0n 0.5219 16199.5n 0.5219 16200.0n 0.4944 16799.5n 0.4944 16800.0n 0.5416 17399.5n 0.5416 17400.0n 0.5045 17999.5n 0.5045 18000.0n 0.5511 18599.5n 0.5511 18600.0n 0.4058 19199.5n 0.4058 19200.0n 0.4462 19799.5n 0.4462 19800.0n 0.3781 20399.5n 0.3781 20400.0n 0.4823 20999.5n 0.4823 21000.0n 0.6053 21599.5n 0.6053 21600.0n 0.3883 22199.5n 0.3883 22200.0n 0.3901 22799.5n 0.3901 22800.0n 0.4845 23399.5n 0.4845 23400.0n 0.4751 23999.5n 0.4751 24000.0n 0.3761 24599.5n 0.3761 24600.0n 0.3962 25199.5n 0.3962 25200.0n 0.5191 25799.5n 0.5191 25800.0n 0.5829 26399.5n 0.5829 26400.0n 0.5245 26999.5n 0.5245 27000.0n 0.5453 27599.5n 0.5453 27600.0n 0.5203 28199.5n 0.5203 28200.0n 0.4451 28799.5n 0.4451 28800.0n 0.4871 29399.5n 0.4871 29400.0n 0.6073 29999.5n 0.6073 30000.0n 0.6132 30599.5n 0.6132 30600.0n 0.6303 31199.5n 0.6303 31200.0n 0.5796 31799.5n 0.5796 31800.0n 0.5898 32399.5n 0.5898 32400.0n 0.5802 32999.5n 0.5802 33000.0n 0.4161 33599.5n 0.4161 33600.0n 0.4504 34199.5n 0.4504 34200.0n 0.4101 34799.5n 0.4101 34800.0n 0.6280 35399.5n 0.6280 35400.0n 0.4508 35999.5n 0.4508)
Vyp_who_26_1 yp_who_26_1 0 PWL(0.0n 0.5071 599.5n 0.5071 600.0n 0.5053 1199.5n 0.5053 1200.0n 0.5052 1799.5n 0.5052 1800.0n 0.5027 2399.5n 0.5027 2400.0n 0.5034 2999.5n 0.5034 3000.0n 0.5055 3599.5n 0.5055 3600.0n 0.5056 4199.5n 0.5056 4200.0n 0.5071 4799.5n 0.5071 4800.0n 0.5056 5399.5n 0.5056 5400.0n 0.5056 5999.5n 0.5056 6000.0n 0.5048 6599.5n 0.5048 6600.0n 0.5060 7199.5n 0.5060 7200.0n 0.5048 7799.5n 0.5048 7800.0n 0.5046 8399.5n 0.5046 8400.0n 0.5066 8999.5n 0.5066 9000.0n 0.5056 9599.5n 0.5056 9600.0n 0.5051 10199.5n 0.5051 10200.0n 0.5046 10799.5n 0.5046 10800.0n 0.5056 11399.5n 0.5056 11400.0n 0.5058 11999.5n 0.5058 12000.0n 0.5068 12599.5n 0.5068 12600.0n 0.5050 13199.5n 0.5050 13200.0n 0.5071 13799.5n 0.5071 13800.0n 0.5059 14399.5n 0.5059 14400.0n 0.5058 14999.5n 0.5058 15000.0n 0.5043 15599.5n 0.5043 15600.0n 0.5067 16199.5n 0.5067 16200.0n 0.5068 16799.5n 0.5068 16800.0n 0.5066 17399.5n 0.5066 17400.0n 0.5069 17999.5n 0.5069 18000.0n 0.5061 18599.5n 0.5061 18600.0n 0.5034 19199.5n 0.5034 19200.0n 0.5010 19799.5n 0.5010 19800.0n 0.4989 20399.5n 0.4989 20400.0n 0.5022 20999.5n 0.5022 21000.0n 0.5086 21599.5n 0.5086 21600.0n 0.5007 22199.5n 0.5007 22200.0n 0.5023 22799.5n 0.5023 22800.0n 0.5021 23399.5n 0.5021 23400.0n 0.5077 23999.5n 0.5077 24000.0n 0.4979 24599.5n 0.4979 24600.0n 0.5035 25199.5n 0.5035 25200.0n 0.5041 25799.5n 0.5041 25800.0n 0.5075 26399.5n 0.5075 26400.0n 0.5041 26999.5n 0.5041 27000.0n 0.5056 27599.5n 0.5056 27600.0n 0.5039 28199.5n 0.5039 28200.0n 0.5059 28799.5n 0.5059 28800.0n 0.5023 29399.5n 0.5023 29400.0n 0.5086 29999.5n 0.5086 30000.0n 0.5084 30599.5n 0.5084 30600.0n 0.5085 31199.5n 0.5085 31200.0n 0.5088 31799.5n 0.5088 31800.0n 0.5078 32399.5n 0.5078 32400.0n 0.5074 32999.5n 0.5074 33000.0n 0.4996 33599.5n 0.4996 33600.0n 0.5010 34199.5n 0.5010 34200.0n 0.5044 34799.5n 0.5044 34800.0n 0.5084 35399.5n 0.5084 35400.0n 0.5012 35999.5n 0.5012)
Vyn_who_26_1 yn_who_26_1 0 PWL(0.0n 0.4929 599.5n 0.4929 600.0n 0.4947 1199.5n 0.4947 1200.0n 0.4948 1799.5n 0.4948 1800.0n 0.4973 2399.5n 0.4973 2400.0n 0.4966 2999.5n 0.4966 3000.0n 0.4945 3599.5n 0.4945 3600.0n 0.4944 4199.5n 0.4944 4200.0n 0.4929 4799.5n 0.4929 4800.0n 0.4944 5399.5n 0.4944 5400.0n 0.4944 5999.5n 0.4944 6000.0n 0.4952 6599.5n 0.4952 6600.0n 0.4940 7199.5n 0.4940 7200.0n 0.4952 7799.5n 0.4952 7800.0n 0.4954 8399.5n 0.4954 8400.0n 0.4934 8999.5n 0.4934 9000.0n 0.4944 9599.5n 0.4944 9600.0n 0.4949 10199.5n 0.4949 10200.0n 0.4954 10799.5n 0.4954 10800.0n 0.4944 11399.5n 0.4944 11400.0n 0.4942 11999.5n 0.4942 12000.0n 0.4932 12599.5n 0.4932 12600.0n 0.4950 13199.5n 0.4950 13200.0n 0.4929 13799.5n 0.4929 13800.0n 0.4941 14399.5n 0.4941 14400.0n 0.4942 14999.5n 0.4942 15000.0n 0.4957 15599.5n 0.4957 15600.0n 0.4933 16199.5n 0.4933 16200.0n 0.4932 16799.5n 0.4932 16800.0n 0.4934 17399.5n 0.4934 17400.0n 0.4931 17999.5n 0.4931 18000.0n 0.4939 18599.5n 0.4939 18600.0n 0.4966 19199.5n 0.4966 19200.0n 0.4990 19799.5n 0.4990 19800.0n 0.5011 20399.5n 0.5011 20400.0n 0.4978 20999.5n 0.4978 21000.0n 0.4914 21599.5n 0.4914 21600.0n 0.4993 22199.5n 0.4993 22200.0n 0.4977 22799.5n 0.4977 22800.0n 0.4979 23399.5n 0.4979 23400.0n 0.4923 23999.5n 0.4923 24000.0n 0.5021 24599.5n 0.5021 24600.0n 0.4965 25199.5n 0.4965 25200.0n 0.4959 25799.5n 0.4959 25800.0n 0.4925 26399.5n 0.4925 26400.0n 0.4959 26999.5n 0.4959 27000.0n 0.4944 27599.5n 0.4944 27600.0n 0.4961 28199.5n 0.4961 28200.0n 0.4941 28799.5n 0.4941 28800.0n 0.4977 29399.5n 0.4977 29400.0n 0.4914 29999.5n 0.4914 30000.0n 0.4916 30599.5n 0.4916 30600.0n 0.4915 31199.5n 0.4915 31200.0n 0.4912 31799.5n 0.4912 31800.0n 0.4922 32399.5n 0.4922 32400.0n 0.4926 32999.5n 0.4926 33000.0n 0.5004 33599.5n 0.5004 33600.0n 0.4990 34199.5n 0.4990 34200.0n 0.4956 34799.5n 0.4956 34800.0n 0.4916 35399.5n 0.4916 35400.0n 0.4988 35999.5n 0.4988)
Cwp_who_26_1 wp_who_26_1 0 400p
Cwn_who_26_1 wn_who_26_1 0 400p
Xu_who_26_1 xp_who_26_1 xn_who_26_1 yp_who_26_1 yn_who_26_1 wp_who_26_1 wn_who_26_1 vdd gbn gprod
Vxp_bh_26 xp_bh_26 0 PWL(0.0n 0.7100 599.5n 0.7100 600.0n 0.7100 1199.5n 0.7100 1200.0n 0.7100 1799.5n 0.7100 1800.0n 0.7100 2399.5n 0.7100 2400.0n 0.7100 2999.5n 0.7100 3000.0n 0.7100 3599.5n 0.7100 3600.0n 0.7100 4199.5n 0.7100 4200.0n 0.7100 4799.5n 0.7100 4800.0n 0.7100 5399.5n 0.7100 5400.0n 0.7100 5999.5n 0.7100 6000.0n 0.7100 6599.5n 0.7100 6600.0n 0.7100 7199.5n 0.7100 7200.0n 0.7100 7799.5n 0.7100 7800.0n 0.7100 8399.5n 0.7100 8400.0n 0.7100 8999.5n 0.7100 9000.0n 0.7100 9599.5n 0.7100 9600.0n 0.7100 10199.5n 0.7100 10200.0n 0.7100 10799.5n 0.7100 10800.0n 0.7100 11399.5n 0.7100 11400.0n 0.7100 11999.5n 0.7100 12000.0n 0.7100 12599.5n 0.7100 12600.0n 0.7100 13199.5n 0.7100 13200.0n 0.7100 13799.5n 0.7100 13800.0n 0.7100 14399.5n 0.7100 14400.0n 0.7100 14999.5n 0.7100 15000.0n 0.7100 15599.5n 0.7100 15600.0n 0.7100 16199.5n 0.7100 16200.0n 0.7100 16799.5n 0.7100 16800.0n 0.7100 17399.5n 0.7100 17400.0n 0.7100 17999.5n 0.7100 18000.0n 0.7100 18599.5n 0.7100 18600.0n 0.7100 19199.5n 0.7100 19200.0n 0.7100 19799.5n 0.7100 19800.0n 0.7100 20399.5n 0.7100 20400.0n 0.7100 20999.5n 0.7100 21000.0n 0.7100 21599.5n 0.7100 21600.0n 0.7100 22199.5n 0.7100 22200.0n 0.7100 22799.5n 0.7100 22800.0n 0.7100 23399.5n 0.7100 23400.0n 0.7100 23999.5n 0.7100 24000.0n 0.7100 24599.5n 0.7100 24600.0n 0.7100 25199.5n 0.7100 25200.0n 0.7100 25799.5n 0.7100 25800.0n 0.7100 26399.5n 0.7100 26400.0n 0.7100 26999.5n 0.7100 27000.0n 0.7100 27599.5n 0.7100 27600.0n 0.7100 28199.5n 0.7100 28200.0n 0.7100 28799.5n 0.7100 28800.0n 0.7100 29399.5n 0.7100 29400.0n 0.7100 29999.5n 0.7100 30000.0n 0.7100 30599.5n 0.7100 30600.0n 0.7100 31199.5n 0.7100 31200.0n 0.7100 31799.5n 0.7100 31800.0n 0.7100 32399.5n 0.7100 32400.0n 0.7100 32999.5n 0.7100 33000.0n 0.7100 33599.5n 0.7100 33600.0n 0.7100 34199.5n 0.7100 34200.0n 0.7100 34799.5n 0.7100 34800.0n 0.7100 35399.5n 0.7100 35400.0n 0.7100 35999.5n 0.7100)
Vxn_bh_26 xn_bh_26 0 PWL(0.0n 0.2900 599.5n 0.2900 600.0n 0.2900 1199.5n 0.2900 1200.0n 0.2900 1799.5n 0.2900 1800.0n 0.2900 2399.5n 0.2900 2400.0n 0.2900 2999.5n 0.2900 3000.0n 0.2900 3599.5n 0.2900 3600.0n 0.2900 4199.5n 0.2900 4200.0n 0.2900 4799.5n 0.2900 4800.0n 0.2900 5399.5n 0.2900 5400.0n 0.2900 5999.5n 0.2900 6000.0n 0.2900 6599.5n 0.2900 6600.0n 0.2900 7199.5n 0.2900 7200.0n 0.2900 7799.5n 0.2900 7800.0n 0.2900 8399.5n 0.2900 8400.0n 0.2900 8999.5n 0.2900 9000.0n 0.2900 9599.5n 0.2900 9600.0n 0.2900 10199.5n 0.2900 10200.0n 0.2900 10799.5n 0.2900 10800.0n 0.2900 11399.5n 0.2900 11400.0n 0.2900 11999.5n 0.2900 12000.0n 0.2900 12599.5n 0.2900 12600.0n 0.2900 13199.5n 0.2900 13200.0n 0.2900 13799.5n 0.2900 13800.0n 0.2900 14399.5n 0.2900 14400.0n 0.2900 14999.5n 0.2900 15000.0n 0.2900 15599.5n 0.2900 15600.0n 0.2900 16199.5n 0.2900 16200.0n 0.2900 16799.5n 0.2900 16800.0n 0.2900 17399.5n 0.2900 17400.0n 0.2900 17999.5n 0.2900 18000.0n 0.2900 18599.5n 0.2900 18600.0n 0.2900 19199.5n 0.2900 19200.0n 0.2900 19799.5n 0.2900 19800.0n 0.2900 20399.5n 0.2900 20400.0n 0.2900 20999.5n 0.2900 21000.0n 0.2900 21599.5n 0.2900 21600.0n 0.2900 22199.5n 0.2900 22200.0n 0.2900 22799.5n 0.2900 22800.0n 0.2900 23399.5n 0.2900 23400.0n 0.2900 23999.5n 0.2900 24000.0n 0.2900 24599.5n 0.2900 24600.0n 0.2900 25199.5n 0.2900 25200.0n 0.2900 25799.5n 0.2900 25800.0n 0.2900 26399.5n 0.2900 26400.0n 0.2900 26999.5n 0.2900 27000.0n 0.2900 27599.5n 0.2900 27600.0n 0.2900 28199.5n 0.2900 28200.0n 0.2900 28799.5n 0.2900 28800.0n 0.2900 29399.5n 0.2900 29400.0n 0.2900 29999.5n 0.2900 30000.0n 0.2900 30599.5n 0.2900 30600.0n 0.2900 31199.5n 0.2900 31200.0n 0.2900 31799.5n 0.2900 31800.0n 0.2900 32399.5n 0.2900 32400.0n 0.2900 32999.5n 0.2900 33000.0n 0.2900 33599.5n 0.2900 33600.0n 0.2900 34199.5n 0.2900 34200.0n 0.2900 34799.5n 0.2900 34800.0n 0.2900 35399.5n 0.2900 35400.0n 0.2900 35999.5n 0.2900)
Vyp_bh_26 yp_bh_26 0 PWL(0.0n 0.4845 599.5n 0.4845 600.0n 0.5448 1199.5n 0.5448 1200.0n 0.4786 1799.5n 0.4786 1800.0n 0.5270 2399.5n 0.5270 2400.0n 0.5328 2999.5n 0.5328 3000.0n 0.5073 3599.5n 0.5073 3600.0n 0.4754 4199.5n 0.4754 4200.0n 0.4790 4799.5n 0.4790 4800.0n 0.4938 5399.5n 0.4938 5400.0n 0.4950 5999.5n 0.4950 6000.0n 0.4842 6599.5n 0.4842 6600.0n 0.4850 7199.5n 0.4850 7200.0n 0.5399 7799.5n 0.5399 7800.0n 0.5436 8399.5n 0.5436 8400.0n 0.4625 8999.5n 0.4625 9000.0n 0.4946 9599.5n 0.4946 9600.0n 0.5073 10199.5n 0.5073 10200.0n 0.5296 10799.5n 0.5296 10800.0n 0.4668 11399.5n 0.4668 11400.0n 0.4915 11999.5n 0.4915 12000.0n 0.4532 12599.5n 0.4532 12600.0n 0.5100 13199.5n 0.5100 13200.0n 0.4907 13799.5n 0.4907 13800.0n 0.5173 14399.5n 0.5173 14400.0n 0.4939 14999.5n 0.4939 15000.0n 0.5241 15599.5n 0.5241 15600.0n 0.4781 16199.5n 0.4781 16200.0n 0.5056 16799.5n 0.5056 16800.0n 0.4584 17399.5n 0.4584 17400.0n 0.4955 17999.5n 0.4955 18000.0n 0.4489 18599.5n 0.4489 18600.0n 0.5942 19199.5n 0.5942 19200.0n 0.5538 19799.5n 0.5538 19800.0n 0.6219 20399.5n 0.6219 20400.0n 0.5177 20999.5n 0.5177 21000.0n 0.3947 21599.5n 0.3947 21600.0n 0.6117 22199.5n 0.6117 22200.0n 0.6099 22799.5n 0.6099 22800.0n 0.5155 23399.5n 0.5155 23400.0n 0.5249 23999.5n 0.5249 24000.0n 0.6239 24599.5n 0.6239 24600.0n 0.6038 25199.5n 0.6038 25200.0n 0.4809 25799.5n 0.4809 25800.0n 0.4171 26399.5n 0.4171 26400.0n 0.4755 26999.5n 0.4755 27000.0n 0.4547 27599.5n 0.4547 27600.0n 0.4797 28199.5n 0.4797 28200.0n 0.5549 28799.5n 0.5549 28800.0n 0.5129 29399.5n 0.5129 29400.0n 0.3927 29999.5n 0.3927 30000.0n 0.3868 30599.5n 0.3868 30600.0n 0.3697 31199.5n 0.3697 31200.0n 0.4204 31799.5n 0.4204 31800.0n 0.4102 32399.5n 0.4102 32400.0n 0.4198 32999.5n 0.4198 33000.0n 0.5839 33599.5n 0.5839 33600.0n 0.5496 34199.5n 0.5496 34200.0n 0.5899 34799.5n 0.5899 34800.0n 0.3720 35399.5n 0.3720 35400.0n 0.5492 35999.5n 0.5492)
Vyn_bh_26 yn_bh_26 0 PWL(0.0n 0.5155 599.5n 0.5155 600.0n 0.4552 1199.5n 0.4552 1200.0n 0.5214 1799.5n 0.5214 1800.0n 0.4730 2399.5n 0.4730 2400.0n 0.4672 2999.5n 0.4672 3000.0n 0.4927 3599.5n 0.4927 3600.0n 0.5246 4199.5n 0.5246 4200.0n 0.5210 4799.5n 0.5210 4800.0n 0.5062 5399.5n 0.5062 5400.0n 0.5050 5999.5n 0.5050 6000.0n 0.5158 6599.5n 0.5158 6600.0n 0.5150 7199.5n 0.5150 7200.0n 0.4601 7799.5n 0.4601 7800.0n 0.4564 8399.5n 0.4564 8400.0n 0.5375 8999.5n 0.5375 9000.0n 0.5054 9599.5n 0.5054 9600.0n 0.4927 10199.5n 0.4927 10200.0n 0.4704 10799.5n 0.4704 10800.0n 0.5332 11399.5n 0.5332 11400.0n 0.5085 11999.5n 0.5085 12000.0n 0.5468 12599.5n 0.5468 12600.0n 0.4900 13199.5n 0.4900 13200.0n 0.5093 13799.5n 0.5093 13800.0n 0.4827 14399.5n 0.4827 14400.0n 0.5061 14999.5n 0.5061 15000.0n 0.4759 15599.5n 0.4759 15600.0n 0.5219 16199.5n 0.5219 16200.0n 0.4944 16799.5n 0.4944 16800.0n 0.5416 17399.5n 0.5416 17400.0n 0.5045 17999.5n 0.5045 18000.0n 0.5511 18599.5n 0.5511 18600.0n 0.4058 19199.5n 0.4058 19200.0n 0.4462 19799.5n 0.4462 19800.0n 0.3781 20399.5n 0.3781 20400.0n 0.4823 20999.5n 0.4823 21000.0n 0.6053 21599.5n 0.6053 21600.0n 0.3883 22199.5n 0.3883 22200.0n 0.3901 22799.5n 0.3901 22800.0n 0.4845 23399.5n 0.4845 23400.0n 0.4751 23999.5n 0.4751 24000.0n 0.3761 24599.5n 0.3761 24600.0n 0.3962 25199.5n 0.3962 25200.0n 0.5191 25799.5n 0.5191 25800.0n 0.5829 26399.5n 0.5829 26400.0n 0.5245 26999.5n 0.5245 27000.0n 0.5453 27599.5n 0.5453 27600.0n 0.5203 28199.5n 0.5203 28200.0n 0.4451 28799.5n 0.4451 28800.0n 0.4871 29399.5n 0.4871 29400.0n 0.6073 29999.5n 0.6073 30000.0n 0.6132 30599.5n 0.6132 30600.0n 0.6303 31199.5n 0.6303 31200.0n 0.5796 31799.5n 0.5796 31800.0n 0.5898 32399.5n 0.5898 32400.0n 0.5802 32999.5n 0.5802 33000.0n 0.4161 33599.5n 0.4161 33600.0n 0.4504 34199.5n 0.4504 34200.0n 0.4101 34799.5n 0.4101 34800.0n 0.6280 35399.5n 0.6280 35400.0n 0.4508 35999.5n 0.4508)
Cwp_bh_26 wp_bh_26 0 400p
Cwn_bh_26 wn_bh_26 0 400p
Xu_bh_26 xp_bh_26 xn_bh_26 yp_bh_26 yn_bh_26 wp_bh_26 wn_bh_26 vdd gbn gprod
Vxp_wih_0_27 xp_wih_0_27 0 PWL(0.0n 0.4942 599.5n 0.4942 600.0n 0.5558 1199.5n 0.5558 1200.0n 0.4708 1799.5n 0.4708 1800.0n 0.5235 2399.5n 0.5235 2400.0n 0.5350 2999.5n 0.5350 3000.0n 0.5172 3599.5n 0.5172 3600.0n 0.4702 4199.5n 0.4702 4200.0n 0.4867 4799.5n 0.4867 4800.0n 0.4970 5399.5n 0.4970 5400.0n 0.4986 5999.5n 0.4986 6000.0n 0.4751 6599.5n 0.4751 6600.0n 0.4870 7199.5n 0.4870 7200.0n 0.5502 7799.5n 0.5502 7800.0n 0.5521 8399.5n 0.5521 8400.0n 0.4638 8999.5n 0.4638 9000.0n 0.4982 9599.5n 0.4982 9600.0n 0.5131 10199.5n 0.5131 10200.0n 0.5386 10799.5n 0.5386 10800.0n 0.4592 11399.5n 0.4592 11400.0n 0.4950 11999.5n 0.4950 12000.0n 0.4559 12599.5n 0.4559 12600.0n 0.5162 13199.5n 0.5162 13200.0n 0.5038 13799.5n 0.5038 13800.0n 0.5333 14399.5n 0.5333 14400.0n 0.4991 14999.5n 0.4991 15000.0n 0.5298 15599.5n 0.5298 15600.0n 0.4823 16199.5n 0.4823 16200.0n 0.5239 16799.5n 0.5239 16800.0n 0.4592 17399.5n 0.4592 17400.0n 0.5094 17999.5n 0.5094 18000.0n 0.4337 18599.5n 0.4337 18600.0n 0.5977 19199.5n 0.5977 19200.0n 0.5364 19799.5n 0.5364 19800.0n 0.6122 20399.5n 0.6122 20400.0n 0.4856 20999.5n 0.4856 21000.0n 0.3861 21599.5n 0.3861 21600.0n 0.6094 22199.5n 0.6094 22200.0n 0.6364 22799.5n 0.6364 22800.0n 0.4807 23399.5n 0.4807 23400.0n 0.5614 23999.5n 0.5614 24000.0n 0.5913 24599.5n 0.5913 24600.0n 0.6295 25199.5n 0.6295 25200.0n 0.4496 25799.5n 0.4496 25800.0n 0.3792 26399.5n 0.3792 26400.0n 0.4434 26999.5n 0.4434 27000.0n 0.4340 27599.5n 0.4340 27600.0n 0.4461 28199.5n 0.4461 28200.0n 0.5791 28799.5n 0.5791 28800.0n 0.4777 29399.5n 0.4777 29400.0n 0.3878 29999.5n 0.3878 30000.0n 0.3832 30599.5n 0.3832 30600.0n 0.4022 31199.5n 0.4022 31200.0n 0.4482 31799.5n 0.4482 31800.0n 0.3662 32399.5n 0.3662 32400.0n 0.3857 32999.5n 0.3857 33000.0n 0.5584 33599.5n 0.5584 33600.0n 0.5284 34199.5n 0.5284 34200.0n 0.6034 34799.5n 0.6034 34800.0n 0.3469 35399.5n 0.3469 35400.0n 0.5290 35999.5n 0.5290)
Vxn_wih_0_27 xn_wih_0_27 0 PWL(0.0n 0.5058 599.5n 0.5058 600.0n 0.4442 1199.5n 0.4442 1200.0n 0.5292 1799.5n 0.5292 1800.0n 0.4765 2399.5n 0.4765 2400.0n 0.4650 2999.5n 0.4650 3000.0n 0.4828 3599.5n 0.4828 3600.0n 0.5298 4199.5n 0.5298 4200.0n 0.5133 4799.5n 0.5133 4800.0n 0.5030 5399.5n 0.5030 5400.0n 0.5014 5999.5n 0.5014 6000.0n 0.5249 6599.5n 0.5249 6600.0n 0.5130 7199.5n 0.5130 7200.0n 0.4498 7799.5n 0.4498 7800.0n 0.4479 8399.5n 0.4479 8400.0n 0.5362 8999.5n 0.5362 9000.0n 0.5018 9599.5n 0.5018 9600.0n 0.4869 10199.5n 0.4869 10200.0n 0.4614 10799.5n 0.4614 10800.0n 0.5408 11399.5n 0.5408 11400.0n 0.5050 11999.5n 0.5050 12000.0n 0.5441 12599.5n 0.5441 12600.0n 0.4838 13199.5n 0.4838 13200.0n 0.4962 13799.5n 0.4962 13800.0n 0.4667 14399.5n 0.4667 14400.0n 0.5009 14999.5n 0.5009 15000.0n 0.4702 15599.5n 0.4702 15600.0n 0.5177 16199.5n 0.5177 16200.0n 0.4761 16799.5n 0.4761 16800.0n 0.5408 17399.5n 0.5408 17400.0n 0.4906 17999.5n 0.4906 18000.0n 0.5663 18599.5n 0.5663 18600.0n 0.4023 19199.5n 0.4023 19200.0n 0.4636 19799.5n 0.4636 19800.0n 0.3878 20399.5n 0.3878 20400.0n 0.5144 20999.5n 0.5144 21000.0n 0.6139 21599.5n 0.6139 21600.0n 0.3906 22199.5n 0.3906 22200.0n 0.3636 22799.5n 0.3636 22800.0n 0.5193 23399.5n 0.5193 23400.0n 0.4386 23999.5n 0.4386 24000.0n 0.4087 24599.5n 0.4087 24600.0n 0.3705 25199.5n 0.3705 25200.0n 0.5504 25799.5n 0.5504 25800.0n 0.6208 26399.5n 0.6208 26400.0n 0.5566 26999.5n 0.5566 27000.0n 0.5660 27599.5n 0.5660 27600.0n 0.5539 28199.5n 0.5539 28200.0n 0.4209 28799.5n 0.4209 28800.0n 0.5223 29399.5n 0.5223 29400.0n 0.6122 29999.5n 0.6122 30000.0n 0.6168 30599.5n 0.6168 30600.0n 0.5978 31199.5n 0.5978 31200.0n 0.5518 31799.5n 0.5518 31800.0n 0.6338 32399.5n 0.6338 32400.0n 0.6143 32999.5n 0.6143 33000.0n 0.4416 33599.5n 0.4416 33600.0n 0.4716 34199.5n 0.4716 34200.0n 0.3966 34799.5n 0.3966 34800.0n 0.6531 35399.5n 0.6531 35400.0n 0.4710 35999.5n 0.4710)
Vyp_wih_0_27 yp_wih_0_27 0 PWL(0.0n 0.3509 599.5n 0.3509 600.0n 0.3418 1199.5n 0.3418 1200.0n 0.4084 1799.5n 0.4084 1800.0n 0.4173 2399.5n 0.4173 2400.0n 0.3891 2999.5n 0.3891 3000.0n 0.3570 3599.5n 0.3570 3600.0n 0.3956 4199.5n 0.3956 4200.0n 0.3519 4799.5n 0.3519 4800.0n 0.3694 5399.5n 0.3694 5400.0n 0.3691 5999.5n 0.3691 6000.0n 0.4143 6599.5n 0.4143 6600.0n 0.3679 7199.5n 0.3679 7200.0n 0.3472 7799.5n 0.3472 7800.0n 0.3478 8399.5n 0.3478 8400.0n 0.3680 8999.5n 0.3680 9000.0n 0.3687 9599.5n 0.3687 9600.0n 0.3701 10199.5n 0.3701 10200.0n 0.3577 10799.5n 0.3577 10800.0n 0.4165 11399.5n 0.4165 11400.0n 0.3666 11999.5n 0.3666 12000.0n 0.3697 12599.5n 0.3697 12600.0n 0.3701 13199.5n 0.3701 13200.0n 0.3485 13799.5n 0.3485 13800.0n 0.3471 14399.5n 0.3471 14400.0n 0.3623 14999.5n 0.3623 15000.0n 0.3755 15599.5n 0.3755 15600.0n 0.3579 16199.5n 0.3579 16200.0n 0.3450 16799.5n 0.3450 16800.0n 0.3747 17399.5n 0.3747 17400.0n 0.3488 17999.5n 0.3488 18000.0n 0.5427 18599.5n 0.5427 18600.0n 0.3326 19199.5n 0.3326 19200.0n 0.4562 19799.5n 0.4562 19800.0n 0.3553 20399.5n 0.3553 20400.0n 0.5017 20999.5n 0.5017 21000.0n 0.5097 21599.5n 0.5097 21600.0n 0.3425 22199.5n 0.3425 22200.0n 0.3306 22799.5n 0.3306 22800.0n 0.5252 23399.5n 0.5252 23400.0n 0.3194 23999.5n 0.3194 24000.0n 0.3977 24599.5n 0.3977 24600.0n 0.3280 25199.5n 0.3280 25200.0n 0.5311 25799.5n 0.5311 25800.0n 0.6096 26399.5n 0.6096 26400.0n 0.5620 26999.5n 0.5620 27000.0n 0.5579 27599.5n 0.5579 27600.0n 0.5577 28199.5n 0.5577 28200.0n 0.3188 28799.5n 0.3188 28800.0n 0.5167 29399.5n 0.5167 29400.0n 0.4940 29999.5n 0.4940 30000.0n 0.4690 30599.5n 0.4690 30600.0n 0.3471 31199.5n 0.3471 31200.0n 0.3370 31799.5n 0.3370 31800.0n 0.6035 32399.5n 0.6035 32400.0n 0.6096 32999.5n 0.6096 33000.0n 0.4370 33599.5n 0.4370 33600.0n 0.4840 34199.5n 0.4840 34200.0n 0.3269 34799.5n 0.3269 34800.0n 0.4301 35399.5n 0.4301 35400.0n 0.4704 35999.5n 0.4704)
Vyn_wih_0_27 yn_wih_0_27 0 PWL(0.0n 0.6491 599.5n 0.6491 600.0n 0.6582 1199.5n 0.6582 1200.0n 0.5916 1799.5n 0.5916 1800.0n 0.5827 2399.5n 0.5827 2400.0n 0.6109 2999.5n 0.6109 3000.0n 0.6430 3599.5n 0.6430 3600.0n 0.6044 4199.5n 0.6044 4200.0n 0.6481 4799.5n 0.6481 4800.0n 0.6306 5399.5n 0.6306 5400.0n 0.6309 5999.5n 0.6309 6000.0n 0.5857 6599.5n 0.5857 6600.0n 0.6321 7199.5n 0.6321 7200.0n 0.6528 7799.5n 0.6528 7800.0n 0.6522 8399.5n 0.6522 8400.0n 0.6320 8999.5n 0.6320 9000.0n 0.6313 9599.5n 0.6313 9600.0n 0.6299 10199.5n 0.6299 10200.0n 0.6423 10799.5n 0.6423 10800.0n 0.5835 11399.5n 0.5835 11400.0n 0.6334 11999.5n 0.6334 12000.0n 0.6303 12599.5n 0.6303 12600.0n 0.6299 13199.5n 0.6299 13200.0n 0.6515 13799.5n 0.6515 13800.0n 0.6529 14399.5n 0.6529 14400.0n 0.6377 14999.5n 0.6377 15000.0n 0.6245 15599.5n 0.6245 15600.0n 0.6421 16199.5n 0.6421 16200.0n 0.6550 16799.5n 0.6550 16800.0n 0.6253 17399.5n 0.6253 17400.0n 0.6512 17999.5n 0.6512 18000.0n 0.4573 18599.5n 0.4573 18600.0n 0.6674 19199.5n 0.6674 19200.0n 0.5438 19799.5n 0.5438 19800.0n 0.6447 20399.5n 0.6447 20400.0n 0.4983 20999.5n 0.4983 21000.0n 0.4903 21599.5n 0.4903 21600.0n 0.6575 22199.5n 0.6575 22200.0n 0.6694 22799.5n 0.6694 22800.0n 0.4748 23399.5n 0.4748 23400.0n 0.6806 23999.5n 0.6806 24000.0n 0.6023 24599.5n 0.6023 24600.0n 0.6720 25199.5n 0.6720 25200.0n 0.4689 25799.5n 0.4689 25800.0n 0.3904 26399.5n 0.3904 26400.0n 0.4380 26999.5n 0.4380 27000.0n 0.4421 27599.5n 0.4421 27600.0n 0.4423 28199.5n 0.4423 28200.0n 0.6812 28799.5n 0.6812 28800.0n 0.4833 29399.5n 0.4833 29400.0n 0.5060 29999.5n 0.5060 30000.0n 0.5310 30599.5n 0.5310 30600.0n 0.6529 31199.5n 0.6529 31200.0n 0.6630 31799.5n 0.6630 31800.0n 0.3965 32399.5n 0.3965 32400.0n 0.3904 32999.5n 0.3904 33000.0n 0.5630 33599.5n 0.5630 33600.0n 0.5160 34199.5n 0.5160 34200.0n 0.6731 34799.5n 0.6731 34800.0n 0.5699 35399.5n 0.5699 35400.0n 0.5296 35999.5n 0.5296)
Cwp_wih_0_27 wp_wih_0_27 0 400p
Cwn_wih_0_27 wn_wih_0_27 0 400p
Xu_wih_0_27 xp_wih_0_27 xn_wih_0_27 yp_wih_0_27 yn_wih_0_27 wp_wih_0_27 wn_wih_0_27 vdd gbn gprod
Vxp_wih_1_27 xp_wih_1_27 0 PWL(0.0n 0.5370 599.5n 0.5370 600.0n 0.5167 1199.5n 0.5167 1200.0n 0.4793 1799.5n 0.4793 1800.0n 0.4441 2399.5n 0.4441 2400.0n 0.4555 2999.5n 0.4555 3000.0n 0.5055 3599.5n 0.5055 3600.0n 0.4939 4199.5n 0.4939 4200.0n 0.5385 4799.5n 0.5385 4800.0n 0.5024 5399.5n 0.5024 5400.0n 0.5015 5999.5n 0.5015 6000.0n 0.4700 6599.5n 0.4700 6600.0n 0.5120 7199.5n 0.5120 7200.0n 0.5006 7799.5n 0.5006 7800.0n 0.4950 8399.5n 0.4950 8400.0n 0.5309 8999.5n 0.5309 9000.0n 0.5023 9599.5n 0.5023 9600.0n 0.4893 10199.5n 0.4893 10200.0n 0.4837 10799.5n 0.4837 10800.0n 0.4823 11399.5n 0.4823 11400.0n 0.5074 11999.5n 0.5074 12000.0n 0.5364 12599.5n 0.5364 12600.0n 0.4868 13199.5n 0.4868 13200.0n 0.5380 13799.5n 0.5380 13800.0n 0.5220 14399.5n 0.5220 14400.0n 0.5095 14999.5n 0.5095 15000.0n 0.4705 15599.5n 0.4705 15600.0n 0.5289 16199.5n 0.5289 16200.0n 0.5368 16799.5n 0.5368 16800.0n 0.5287 17399.5n 0.5287 17400.0n 0.5342 17999.5n 0.5342 18000.0n 0.4253 18599.5n 0.4253 18600.0n 0.5119 19199.5n 0.5119 19200.0n 0.4104 19799.5n 0.4104 19800.0n 0.4314 20399.5n 0.4314 20400.0n 0.4005 20999.5n 0.4005 21000.0n 0.4696 21599.5n 0.4696 21600.0n 0.4531 22199.5n 0.4531 22200.0n 0.5039 22799.5n 0.5039 22800.0n 0.3608 23399.5n 0.3608 23400.0n 0.6273 23999.5n 0.6273 24000.0n 0.3928 24599.5n 0.3928 24600.0n 0.5253 25199.5n 0.5253 25200.0n 0.4107 25799.5n 0.4107 25800.0n 0.3947 26399.5n 0.3947 26400.0n 0.3716 26999.5n 0.3716 27000.0n 0.4111 27599.5n 0.4111 27600.0n 0.3715 28199.5n 0.3715 28200.0n 0.5939 28799.5n 0.5939 28800.0n 0.3849 29399.5n 0.3849 29400.0n 0.4835 29999.5n 0.4835 30000.0n 0.5119 30599.5n 0.5119 30600.0n 0.6226 31199.5n 0.6226 31200.0n 0.6064 31799.5n 0.6064 31800.0n 0.4115 32399.5n 0.4115 32400.0n 0.3900 32999.5n 0.3900 33000.0n 0.3958 33599.5n 0.3958 33600.0n 0.3747 34199.5n 0.3747 34200.0n 0.5423 34799.5n 0.5423 34800.0n 0.5509 35399.5n 0.5509 35400.0n 0.3990 35999.5n 0.3990)
Vxn_wih_1_27 xn_wih_1_27 0 PWL(0.0n 0.4630 599.5n 0.4630 600.0n 0.4833 1199.5n 0.4833 1200.0n 0.5207 1799.5n 0.5207 1800.0n 0.5559 2399.5n 0.5559 2400.0n 0.5445 2999.5n 0.5445 3000.0n 0.4945 3599.5n 0.4945 3600.0n 0.5061 4199.5n 0.5061 4200.0n 0.4615 4799.5n 0.4615 4800.0n 0.4976 5399.5n 0.4976 5400.0n 0.4985 5999.5n 0.4985 6000.0n 0.5300 6599.5n 0.5300 6600.0n 0.4880 7199.5n 0.4880 7200.0n 0.4994 7799.5n 0.4994 7800.0n 0.5050 8399.5n 0.5050 8400.0n 0.4691 8999.5n 0.4691 9000.0n 0.4977 9599.5n 0.4977 9600.0n 0.5107 10199.5n 0.5107 10200.0n 0.5163 10799.5n 0.5163 10800.0n 0.5177 11399.5n 0.5177 11400.0n 0.4926 11999.5n 0.4926 12000.0n 0.4636 12599.5n 0.4636 12600.0n 0.5132 13199.5n 0.5132 13200.0n 0.4620 13799.5n 0.4620 13800.0n 0.4780 14399.5n 0.4780 14400.0n 0.4905 14999.5n 0.4905 15000.0n 0.5295 15599.5n 0.5295 15600.0n 0.4711 16199.5n 0.4711 16200.0n 0.4632 16799.5n 0.4632 16800.0n 0.4713 17399.5n 0.4713 17400.0n 0.4658 17999.5n 0.4658 18000.0n 0.5747 18599.5n 0.5747 18600.0n 0.4881 19199.5n 0.4881 19200.0n 0.5896 19799.5n 0.5896 19800.0n 0.5686 20399.5n 0.5686 20400.0n 0.5995 20999.5n 0.5995 21000.0n 0.5304 21599.5n 0.5304 21600.0n 0.5469 22199.5n 0.5469 22200.0n 0.4961 22799.5n 0.4961 22800.0n 0.6392 23399.5n 0.6392 23400.0n 0.3727 23999.5n 0.3727 24000.0n 0.6072 24599.5n 0.6072 24600.0n 0.4747 25199.5n 0.4747 25200.0n 0.5893 25799.5n 0.5893 25800.0n 0.6053 26399.5n 0.6053 26400.0n 0.6284 26999.5n 0.6284 27000.0n 0.5889 27599.5n 0.5889 27600.0n 0.6285 28199.5n 0.6285 28200.0n 0.4061 28799.5n 0.4061 28800.0n 0.6151 29399.5n 0.6151 29400.0n 0.5165 29999.5n 0.5165 30000.0n 0.4881 30599.5n 0.4881 30600.0n 0.3774 31199.5n 0.3774 31200.0n 0.3936 31799.5n 0.3936 31800.0n 0.5885 32399.5n 0.5885 32400.0n 0.6100 32999.5n 0.6100 33000.0n 0.6042 33599.5n 0.6042 33600.0n 0.6253 34199.5n 0.6253 34200.0n 0.4577 34799.5n 0.4577 34800.0n 0.4491 35399.5n 0.4491 35400.0n 0.6010 35999.5n 0.6010)
Vyp_wih_1_27 yp_wih_1_27 0 PWL(0.0n 0.3509 599.5n 0.3509 600.0n 0.3418 1199.5n 0.3418 1200.0n 0.4084 1799.5n 0.4084 1800.0n 0.4173 2399.5n 0.4173 2400.0n 0.3891 2999.5n 0.3891 3000.0n 0.3570 3599.5n 0.3570 3600.0n 0.3956 4199.5n 0.3956 4200.0n 0.3519 4799.5n 0.3519 4800.0n 0.3694 5399.5n 0.3694 5400.0n 0.3691 5999.5n 0.3691 6000.0n 0.4143 6599.5n 0.4143 6600.0n 0.3679 7199.5n 0.3679 7200.0n 0.3472 7799.5n 0.3472 7800.0n 0.3478 8399.5n 0.3478 8400.0n 0.3680 8999.5n 0.3680 9000.0n 0.3687 9599.5n 0.3687 9600.0n 0.3701 10199.5n 0.3701 10200.0n 0.3577 10799.5n 0.3577 10800.0n 0.4165 11399.5n 0.4165 11400.0n 0.3666 11999.5n 0.3666 12000.0n 0.3697 12599.5n 0.3697 12600.0n 0.3701 13199.5n 0.3701 13200.0n 0.3485 13799.5n 0.3485 13800.0n 0.3471 14399.5n 0.3471 14400.0n 0.3623 14999.5n 0.3623 15000.0n 0.3755 15599.5n 0.3755 15600.0n 0.3579 16199.5n 0.3579 16200.0n 0.3450 16799.5n 0.3450 16800.0n 0.3747 17399.5n 0.3747 17400.0n 0.3488 17999.5n 0.3488 18000.0n 0.5427 18599.5n 0.5427 18600.0n 0.3326 19199.5n 0.3326 19200.0n 0.4562 19799.5n 0.4562 19800.0n 0.3553 20399.5n 0.3553 20400.0n 0.5017 20999.5n 0.5017 21000.0n 0.5097 21599.5n 0.5097 21600.0n 0.3425 22199.5n 0.3425 22200.0n 0.3306 22799.5n 0.3306 22800.0n 0.5252 23399.5n 0.5252 23400.0n 0.3194 23999.5n 0.3194 24000.0n 0.3977 24599.5n 0.3977 24600.0n 0.3280 25199.5n 0.3280 25200.0n 0.5311 25799.5n 0.5311 25800.0n 0.6096 26399.5n 0.6096 26400.0n 0.5620 26999.5n 0.5620 27000.0n 0.5579 27599.5n 0.5579 27600.0n 0.5577 28199.5n 0.5577 28200.0n 0.3188 28799.5n 0.3188 28800.0n 0.5167 29399.5n 0.5167 29400.0n 0.4940 29999.5n 0.4940 30000.0n 0.4690 30599.5n 0.4690 30600.0n 0.3471 31199.5n 0.3471 31200.0n 0.3370 31799.5n 0.3370 31800.0n 0.6035 32399.5n 0.6035 32400.0n 0.6096 32999.5n 0.6096 33000.0n 0.4370 33599.5n 0.4370 33600.0n 0.4840 34199.5n 0.4840 34200.0n 0.3269 34799.5n 0.3269 34800.0n 0.4301 35399.5n 0.4301 35400.0n 0.4704 35999.5n 0.4704)
Vyn_wih_1_27 yn_wih_1_27 0 PWL(0.0n 0.6491 599.5n 0.6491 600.0n 0.6582 1199.5n 0.6582 1200.0n 0.5916 1799.5n 0.5916 1800.0n 0.5827 2399.5n 0.5827 2400.0n 0.6109 2999.5n 0.6109 3000.0n 0.6430 3599.5n 0.6430 3600.0n 0.6044 4199.5n 0.6044 4200.0n 0.6481 4799.5n 0.6481 4800.0n 0.6306 5399.5n 0.6306 5400.0n 0.6309 5999.5n 0.6309 6000.0n 0.5857 6599.5n 0.5857 6600.0n 0.6321 7199.5n 0.6321 7200.0n 0.6528 7799.5n 0.6528 7800.0n 0.6522 8399.5n 0.6522 8400.0n 0.6320 8999.5n 0.6320 9000.0n 0.6313 9599.5n 0.6313 9600.0n 0.6299 10199.5n 0.6299 10200.0n 0.6423 10799.5n 0.6423 10800.0n 0.5835 11399.5n 0.5835 11400.0n 0.6334 11999.5n 0.6334 12000.0n 0.6303 12599.5n 0.6303 12600.0n 0.6299 13199.5n 0.6299 13200.0n 0.6515 13799.5n 0.6515 13800.0n 0.6529 14399.5n 0.6529 14400.0n 0.6377 14999.5n 0.6377 15000.0n 0.6245 15599.5n 0.6245 15600.0n 0.6421 16199.5n 0.6421 16200.0n 0.6550 16799.5n 0.6550 16800.0n 0.6253 17399.5n 0.6253 17400.0n 0.6512 17999.5n 0.6512 18000.0n 0.4573 18599.5n 0.4573 18600.0n 0.6674 19199.5n 0.6674 19200.0n 0.5438 19799.5n 0.5438 19800.0n 0.6447 20399.5n 0.6447 20400.0n 0.4983 20999.5n 0.4983 21000.0n 0.4903 21599.5n 0.4903 21600.0n 0.6575 22199.5n 0.6575 22200.0n 0.6694 22799.5n 0.6694 22800.0n 0.4748 23399.5n 0.4748 23400.0n 0.6806 23999.5n 0.6806 24000.0n 0.6023 24599.5n 0.6023 24600.0n 0.6720 25199.5n 0.6720 25200.0n 0.4689 25799.5n 0.4689 25800.0n 0.3904 26399.5n 0.3904 26400.0n 0.4380 26999.5n 0.4380 27000.0n 0.4421 27599.5n 0.4421 27600.0n 0.4423 28199.5n 0.4423 28200.0n 0.6812 28799.5n 0.6812 28800.0n 0.4833 29399.5n 0.4833 29400.0n 0.5060 29999.5n 0.5060 30000.0n 0.5310 30599.5n 0.5310 30600.0n 0.6529 31199.5n 0.6529 31200.0n 0.6630 31799.5n 0.6630 31800.0n 0.3965 32399.5n 0.3965 32400.0n 0.3904 32999.5n 0.3904 33000.0n 0.5630 33599.5n 0.5630 33600.0n 0.5160 34199.5n 0.5160 34200.0n 0.6731 34799.5n 0.6731 34800.0n 0.5699 35399.5n 0.5699 35400.0n 0.5296 35999.5n 0.5296)
Cwp_wih_1_27 wp_wih_1_27 0 400p
Cwn_wih_1_27 wn_wih_1_27 0 400p
Xu_wih_1_27 xp_wih_1_27 xn_wih_1_27 yp_wih_1_27 yn_wih_1_27 wp_wih_1_27 wn_wih_1_27 vdd gbn gprod
Vxp_who_27_0 xp_who_27_0 0 PWL(0.0n 0.3509 599.5n 0.3509 600.0n 0.3418 1199.5n 0.3418 1200.0n 0.4084 1799.5n 0.4084 1800.0n 0.4173 2399.5n 0.4173 2400.0n 0.3891 2999.5n 0.3891 3000.0n 0.3570 3599.5n 0.3570 3600.0n 0.3956 4199.5n 0.3956 4200.0n 0.3519 4799.5n 0.3519 4800.0n 0.3694 5399.5n 0.3694 5400.0n 0.3691 5999.5n 0.3691 6000.0n 0.4143 6599.5n 0.4143 6600.0n 0.3679 7199.5n 0.3679 7200.0n 0.3472 7799.5n 0.3472 7800.0n 0.3478 8399.5n 0.3478 8400.0n 0.3680 8999.5n 0.3680 9000.0n 0.3687 9599.5n 0.3687 9600.0n 0.3701 10199.5n 0.3701 10200.0n 0.3577 10799.5n 0.3577 10800.0n 0.4165 11399.5n 0.4165 11400.0n 0.3666 11999.5n 0.3666 12000.0n 0.3697 12599.5n 0.3697 12600.0n 0.3701 13199.5n 0.3701 13200.0n 0.3485 13799.5n 0.3485 13800.0n 0.3471 14399.5n 0.3471 14400.0n 0.3623 14999.5n 0.3623 15000.0n 0.3755 15599.5n 0.3755 15600.0n 0.3579 16199.5n 0.3579 16200.0n 0.3450 16799.5n 0.3450 16800.0n 0.3747 17399.5n 0.3747 17400.0n 0.3488 17999.5n 0.3488 18000.0n 0.5427 18599.5n 0.5427 18600.0n 0.3326 19199.5n 0.3326 19200.0n 0.4562 19799.5n 0.4562 19800.0n 0.3553 20399.5n 0.3553 20400.0n 0.5017 20999.5n 0.5017 21000.0n 0.5097 21599.5n 0.5097 21600.0n 0.3425 22199.5n 0.3425 22200.0n 0.3306 22799.5n 0.3306 22800.0n 0.5252 23399.5n 0.5252 23400.0n 0.3194 23999.5n 0.3194 24000.0n 0.3977 24599.5n 0.3977 24600.0n 0.3280 25199.5n 0.3280 25200.0n 0.5311 25799.5n 0.5311 25800.0n 0.6096 26399.5n 0.6096 26400.0n 0.5620 26999.5n 0.5620 27000.0n 0.5579 27599.5n 0.5579 27600.0n 0.5577 28199.5n 0.5577 28200.0n 0.3188 28799.5n 0.3188 28800.0n 0.5167 29399.5n 0.5167 29400.0n 0.4940 29999.5n 0.4940 30000.0n 0.4690 30599.5n 0.4690 30600.0n 0.3471 31199.5n 0.3471 31200.0n 0.3370 31799.5n 0.3370 31800.0n 0.6035 32399.5n 0.6035 32400.0n 0.6096 32999.5n 0.6096 33000.0n 0.4370 33599.5n 0.4370 33600.0n 0.4840 34199.5n 0.4840 34200.0n 0.3269 34799.5n 0.3269 34800.0n 0.4301 35399.5n 0.4301 35400.0n 0.4704 35999.5n 0.4704)
Vxn_who_27_0 xn_who_27_0 0 PWL(0.0n 0.6491 599.5n 0.6491 600.0n 0.6582 1199.5n 0.6582 1200.0n 0.5916 1799.5n 0.5916 1800.0n 0.5827 2399.5n 0.5827 2400.0n 0.6109 2999.5n 0.6109 3000.0n 0.6430 3599.5n 0.6430 3600.0n 0.6044 4199.5n 0.6044 4200.0n 0.6481 4799.5n 0.6481 4800.0n 0.6306 5399.5n 0.6306 5400.0n 0.6309 5999.5n 0.6309 6000.0n 0.5857 6599.5n 0.5857 6600.0n 0.6321 7199.5n 0.6321 7200.0n 0.6528 7799.5n 0.6528 7800.0n 0.6522 8399.5n 0.6522 8400.0n 0.6320 8999.5n 0.6320 9000.0n 0.6313 9599.5n 0.6313 9600.0n 0.6299 10199.5n 0.6299 10200.0n 0.6423 10799.5n 0.6423 10800.0n 0.5835 11399.5n 0.5835 11400.0n 0.6334 11999.5n 0.6334 12000.0n 0.6303 12599.5n 0.6303 12600.0n 0.6299 13199.5n 0.6299 13200.0n 0.6515 13799.5n 0.6515 13800.0n 0.6529 14399.5n 0.6529 14400.0n 0.6377 14999.5n 0.6377 15000.0n 0.6245 15599.5n 0.6245 15600.0n 0.6421 16199.5n 0.6421 16200.0n 0.6550 16799.5n 0.6550 16800.0n 0.6253 17399.5n 0.6253 17400.0n 0.6512 17999.5n 0.6512 18000.0n 0.4573 18599.5n 0.4573 18600.0n 0.6674 19199.5n 0.6674 19200.0n 0.5438 19799.5n 0.5438 19800.0n 0.6447 20399.5n 0.6447 20400.0n 0.4983 20999.5n 0.4983 21000.0n 0.4903 21599.5n 0.4903 21600.0n 0.6575 22199.5n 0.6575 22200.0n 0.6694 22799.5n 0.6694 22800.0n 0.4748 23399.5n 0.4748 23400.0n 0.6806 23999.5n 0.6806 24000.0n 0.6023 24599.5n 0.6023 24600.0n 0.6720 25199.5n 0.6720 25200.0n 0.4689 25799.5n 0.4689 25800.0n 0.3904 26399.5n 0.3904 26400.0n 0.4380 26999.5n 0.4380 27000.0n 0.4421 27599.5n 0.4421 27600.0n 0.4423 28199.5n 0.4423 28200.0n 0.6812 28799.5n 0.6812 28800.0n 0.4833 29399.5n 0.4833 29400.0n 0.5060 29999.5n 0.5060 30000.0n 0.5310 30599.5n 0.5310 30600.0n 0.6529 31199.5n 0.6529 31200.0n 0.6630 31799.5n 0.6630 31800.0n 0.3965 32399.5n 0.3965 32400.0n 0.3904 32999.5n 0.3904 33000.0n 0.5630 33599.5n 0.5630 33600.0n 0.5160 34199.5n 0.5160 34200.0n 0.6731 34799.5n 0.6731 34800.0n 0.5699 35399.5n 0.5699 35400.0n 0.5296 35999.5n 0.5296)
Vyp_who_27_0 yp_who_27_0 0 PWL(0.0n 0.5031 599.5n 0.5031 600.0n 0.5023 1199.5n 0.5023 1200.0n 0.5052 1799.5n 0.5052 1800.0n 0.5048 2399.5n 0.5048 2400.0n 0.5043 2999.5n 0.5043 3000.0n 0.5034 3599.5n 0.5034 3600.0n 0.5048 4199.5n 0.5048 4200.0n 0.5031 4799.5n 0.5031 4800.0n 0.5040 5399.5n 0.5040 5400.0n 0.5040 5999.5n 0.5040 6000.0n 0.5054 6599.5n 0.5054 6600.0n 0.5040 7199.5n 0.5040 7200.0n 0.5027 7799.5n 0.5027 7800.0n 0.5027 8399.5n 0.5027 8400.0n 0.5038 8999.5n 0.5038 9000.0n 0.5040 9599.5n 0.5040 9600.0n 0.5039 10199.5n 0.5039 10200.0n 0.5033 10799.5n 0.5033 10800.0n 0.5056 11399.5n 0.5056 11400.0n 0.5040 11999.5n 0.5040 12000.0n 0.5036 12599.5n 0.5036 12600.0n 0.5039 13199.5n 0.5039 13200.0n 0.5029 13799.5n 0.5029 13800.0n 0.5025 14399.5n 0.5025 14400.0n 0.5038 14999.5n 0.5038 15000.0n 0.5041 15599.5n 0.5041 15600.0n 0.5036 16199.5n 0.5036 16200.0n 0.5025 16799.5n 0.5025 16800.0n 0.5040 17399.5n 0.5040 17400.0n 0.5029 17999.5n 0.5029 18000.0n 0.5057 18599.5n 0.5057 18600.0n 0.5010 19199.5n 0.5010 19200.0n 0.5041 19799.5n 0.5041 19800.0n 0.5021 20399.5n 0.5021 20400.0n 0.5044 20999.5n 0.5044 21000.0n 0.5056 21599.5n 0.5056 21600.0n 0.5016 22199.5n 0.5016 22200.0n 0.5006 22799.5n 0.5006 22800.0n 0.5041 23399.5n 0.5041 23400.0n 0.5027 23999.5n 0.5027 24000.0n 0.5029 24599.5n 0.5029 24600.0n 0.5006 25199.5n 0.5006 25200.0n 0.5047 25799.5n 0.5047 25800.0n 0.5046 26399.5n 0.5046 26400.0n 0.5039 26999.5n 0.5039 27000.0n 0.5049 27599.5n 0.5049 27600.0n 0.5039 28199.5n 0.5039 28200.0n 0.5017 28799.5n 0.5017 28800.0n 0.5042 29399.5n 0.5042 29400.0n 0.5056 29999.5n 0.5056 30000.0n 0.5051 30599.5n 0.5051 30600.0n 0.5039 31199.5n 0.5039 31200.0n 0.5033 31799.5n 0.5033 31800.0n 0.5049 32399.5n 0.5049 32400.0n 0.5045 32999.5n 0.5045 33000.0n 0.5036 33599.5n 0.5036 33600.0n 0.5042 34199.5n 0.5042 34200.0n 0.5012 34799.5n 0.5012 34800.0n 0.5036 35399.5n 0.5036 35400.0n 0.5042 35999.5n 0.5042)
Vyn_who_27_0 yn_who_27_0 0 PWL(0.0n 0.4969 599.5n 0.4969 600.0n 0.4977 1199.5n 0.4977 1200.0n 0.4948 1799.5n 0.4948 1800.0n 0.4952 2399.5n 0.4952 2400.0n 0.4957 2999.5n 0.4957 3000.0n 0.4966 3599.5n 0.4966 3600.0n 0.4952 4199.5n 0.4952 4200.0n 0.4969 4799.5n 0.4969 4800.0n 0.4960 5399.5n 0.4960 5400.0n 0.4960 5999.5n 0.4960 6000.0n 0.4946 6599.5n 0.4946 6600.0n 0.4960 7199.5n 0.4960 7200.0n 0.4973 7799.5n 0.4973 7800.0n 0.4973 8399.5n 0.4973 8400.0n 0.4962 8999.5n 0.4962 9000.0n 0.4960 9599.5n 0.4960 9600.0n 0.4961 10199.5n 0.4961 10200.0n 0.4967 10799.5n 0.4967 10800.0n 0.4944 11399.5n 0.4944 11400.0n 0.4960 11999.5n 0.4960 12000.0n 0.4964 12599.5n 0.4964 12600.0n 0.4961 13199.5n 0.4961 13200.0n 0.4971 13799.5n 0.4971 13800.0n 0.4975 14399.5n 0.4975 14400.0n 0.4962 14999.5n 0.4962 15000.0n 0.4959 15599.5n 0.4959 15600.0n 0.4964 16199.5n 0.4964 16200.0n 0.4975 16799.5n 0.4975 16800.0n 0.4960 17399.5n 0.4960 17400.0n 0.4971 17999.5n 0.4971 18000.0n 0.4943 18599.5n 0.4943 18600.0n 0.4990 19199.5n 0.4990 19200.0n 0.4959 19799.5n 0.4959 19800.0n 0.4979 20399.5n 0.4979 20400.0n 0.4956 20999.5n 0.4956 21000.0n 0.4944 21599.5n 0.4944 21600.0n 0.4984 22199.5n 0.4984 22200.0n 0.4994 22799.5n 0.4994 22800.0n 0.4959 23399.5n 0.4959 23400.0n 0.4973 23999.5n 0.4973 24000.0n 0.4971 24599.5n 0.4971 24600.0n 0.4994 25199.5n 0.4994 25200.0n 0.4953 25799.5n 0.4953 25800.0n 0.4954 26399.5n 0.4954 26400.0n 0.4961 26999.5n 0.4961 27000.0n 0.4951 27599.5n 0.4951 27600.0n 0.4961 28199.5n 0.4961 28200.0n 0.4983 28799.5n 0.4983 28800.0n 0.4958 29399.5n 0.4958 29400.0n 0.4944 29999.5n 0.4944 30000.0n 0.4949 30599.5n 0.4949 30600.0n 0.4961 31199.5n 0.4961 31200.0n 0.4967 31799.5n 0.4967 31800.0n 0.4951 32399.5n 0.4951 32400.0n 0.4955 32999.5n 0.4955 33000.0n 0.4964 33599.5n 0.4964 33600.0n 0.4958 34199.5n 0.4958 34200.0n 0.4988 34799.5n 0.4988 34800.0n 0.4964 35399.5n 0.4964 35400.0n 0.4958 35999.5n 0.4958)
Cwp_who_27_0 wp_who_27_0 0 400p
Cwn_who_27_0 wn_who_27_0 0 400p
Xu_who_27_0 xp_who_27_0 xn_who_27_0 yp_who_27_0 yn_who_27_0 wp_who_27_0 wn_who_27_0 vdd gbn gprod
Vxp_who_27_1 xp_who_27_1 0 PWL(0.0n 0.3509 599.5n 0.3509 600.0n 0.3418 1199.5n 0.3418 1200.0n 0.4084 1799.5n 0.4084 1800.0n 0.4173 2399.5n 0.4173 2400.0n 0.3891 2999.5n 0.3891 3000.0n 0.3570 3599.5n 0.3570 3600.0n 0.3956 4199.5n 0.3956 4200.0n 0.3519 4799.5n 0.3519 4800.0n 0.3694 5399.5n 0.3694 5400.0n 0.3691 5999.5n 0.3691 6000.0n 0.4143 6599.5n 0.4143 6600.0n 0.3679 7199.5n 0.3679 7200.0n 0.3472 7799.5n 0.3472 7800.0n 0.3478 8399.5n 0.3478 8400.0n 0.3680 8999.5n 0.3680 9000.0n 0.3687 9599.5n 0.3687 9600.0n 0.3701 10199.5n 0.3701 10200.0n 0.3577 10799.5n 0.3577 10800.0n 0.4165 11399.5n 0.4165 11400.0n 0.3666 11999.5n 0.3666 12000.0n 0.3697 12599.5n 0.3697 12600.0n 0.3701 13199.5n 0.3701 13200.0n 0.3485 13799.5n 0.3485 13800.0n 0.3471 14399.5n 0.3471 14400.0n 0.3623 14999.5n 0.3623 15000.0n 0.3755 15599.5n 0.3755 15600.0n 0.3579 16199.5n 0.3579 16200.0n 0.3450 16799.5n 0.3450 16800.0n 0.3747 17399.5n 0.3747 17400.0n 0.3488 17999.5n 0.3488 18000.0n 0.5427 18599.5n 0.5427 18600.0n 0.3326 19199.5n 0.3326 19200.0n 0.4562 19799.5n 0.4562 19800.0n 0.3553 20399.5n 0.3553 20400.0n 0.5017 20999.5n 0.5017 21000.0n 0.5097 21599.5n 0.5097 21600.0n 0.3425 22199.5n 0.3425 22200.0n 0.3306 22799.5n 0.3306 22800.0n 0.5252 23399.5n 0.5252 23400.0n 0.3194 23999.5n 0.3194 24000.0n 0.3977 24599.5n 0.3977 24600.0n 0.3280 25199.5n 0.3280 25200.0n 0.5311 25799.5n 0.5311 25800.0n 0.6096 26399.5n 0.6096 26400.0n 0.5620 26999.5n 0.5620 27000.0n 0.5579 27599.5n 0.5579 27600.0n 0.5577 28199.5n 0.5577 28200.0n 0.3188 28799.5n 0.3188 28800.0n 0.5167 29399.5n 0.5167 29400.0n 0.4940 29999.5n 0.4940 30000.0n 0.4690 30599.5n 0.4690 30600.0n 0.3471 31199.5n 0.3471 31200.0n 0.3370 31799.5n 0.3370 31800.0n 0.6035 32399.5n 0.6035 32400.0n 0.6096 32999.5n 0.6096 33000.0n 0.4370 33599.5n 0.4370 33600.0n 0.4840 34199.5n 0.4840 34200.0n 0.3269 34799.5n 0.3269 34800.0n 0.4301 35399.5n 0.4301 35400.0n 0.4704 35999.5n 0.4704)
Vxn_who_27_1 xn_who_27_1 0 PWL(0.0n 0.6491 599.5n 0.6491 600.0n 0.6582 1199.5n 0.6582 1200.0n 0.5916 1799.5n 0.5916 1800.0n 0.5827 2399.5n 0.5827 2400.0n 0.6109 2999.5n 0.6109 3000.0n 0.6430 3599.5n 0.6430 3600.0n 0.6044 4199.5n 0.6044 4200.0n 0.6481 4799.5n 0.6481 4800.0n 0.6306 5399.5n 0.6306 5400.0n 0.6309 5999.5n 0.6309 6000.0n 0.5857 6599.5n 0.5857 6600.0n 0.6321 7199.5n 0.6321 7200.0n 0.6528 7799.5n 0.6528 7800.0n 0.6522 8399.5n 0.6522 8400.0n 0.6320 8999.5n 0.6320 9000.0n 0.6313 9599.5n 0.6313 9600.0n 0.6299 10199.5n 0.6299 10200.0n 0.6423 10799.5n 0.6423 10800.0n 0.5835 11399.5n 0.5835 11400.0n 0.6334 11999.5n 0.6334 12000.0n 0.6303 12599.5n 0.6303 12600.0n 0.6299 13199.5n 0.6299 13200.0n 0.6515 13799.5n 0.6515 13800.0n 0.6529 14399.5n 0.6529 14400.0n 0.6377 14999.5n 0.6377 15000.0n 0.6245 15599.5n 0.6245 15600.0n 0.6421 16199.5n 0.6421 16200.0n 0.6550 16799.5n 0.6550 16800.0n 0.6253 17399.5n 0.6253 17400.0n 0.6512 17999.5n 0.6512 18000.0n 0.4573 18599.5n 0.4573 18600.0n 0.6674 19199.5n 0.6674 19200.0n 0.5438 19799.5n 0.5438 19800.0n 0.6447 20399.5n 0.6447 20400.0n 0.4983 20999.5n 0.4983 21000.0n 0.4903 21599.5n 0.4903 21600.0n 0.6575 22199.5n 0.6575 22200.0n 0.6694 22799.5n 0.6694 22800.0n 0.4748 23399.5n 0.4748 23400.0n 0.6806 23999.5n 0.6806 24000.0n 0.6023 24599.5n 0.6023 24600.0n 0.6720 25199.5n 0.6720 25200.0n 0.4689 25799.5n 0.4689 25800.0n 0.3904 26399.5n 0.3904 26400.0n 0.4380 26999.5n 0.4380 27000.0n 0.4421 27599.5n 0.4421 27600.0n 0.4423 28199.5n 0.4423 28200.0n 0.6812 28799.5n 0.6812 28800.0n 0.4833 29399.5n 0.4833 29400.0n 0.5060 29999.5n 0.5060 30000.0n 0.5310 30599.5n 0.5310 30600.0n 0.6529 31199.5n 0.6529 31200.0n 0.6630 31799.5n 0.6630 31800.0n 0.3965 32399.5n 0.3965 32400.0n 0.3904 32999.5n 0.3904 33000.0n 0.5630 33599.5n 0.5630 33600.0n 0.5160 34199.5n 0.5160 34200.0n 0.6731 34799.5n 0.6731 34800.0n 0.5699 35399.5n 0.5699 35400.0n 0.5296 35999.5n 0.5296)
Vyp_who_27_1 yp_who_27_1 0 PWL(0.0n 0.5071 599.5n 0.5071 600.0n 0.5053 1199.5n 0.5053 1200.0n 0.5052 1799.5n 0.5052 1800.0n 0.5027 2399.5n 0.5027 2400.0n 0.5034 2999.5n 0.5034 3000.0n 0.5055 3599.5n 0.5055 3600.0n 0.5056 4199.5n 0.5056 4200.0n 0.5071 4799.5n 0.5071 4800.0n 0.5056 5399.5n 0.5056 5400.0n 0.5056 5999.5n 0.5056 6000.0n 0.5048 6599.5n 0.5048 6600.0n 0.5060 7199.5n 0.5060 7200.0n 0.5048 7799.5n 0.5048 7800.0n 0.5046 8399.5n 0.5046 8400.0n 0.5066 8999.5n 0.5066 9000.0n 0.5056 9599.5n 0.5056 9600.0n 0.5051 10199.5n 0.5051 10200.0n 0.5046 10799.5n 0.5046 10800.0n 0.5056 11399.5n 0.5056 11400.0n 0.5058 11999.5n 0.5058 12000.0n 0.5068 12599.5n 0.5068 12600.0n 0.5050 13199.5n 0.5050 13200.0n 0.5071 13799.5n 0.5071 13800.0n 0.5059 14399.5n 0.5059 14400.0n 0.5058 14999.5n 0.5058 15000.0n 0.5043 15599.5n 0.5043 15600.0n 0.5067 16199.5n 0.5067 16200.0n 0.5068 16799.5n 0.5068 16800.0n 0.5066 17399.5n 0.5066 17400.0n 0.5069 17999.5n 0.5069 18000.0n 0.5061 18599.5n 0.5061 18600.0n 0.5034 19199.5n 0.5034 19200.0n 0.5010 19799.5n 0.5010 19800.0n 0.4989 20399.5n 0.4989 20400.0n 0.5022 20999.5n 0.5022 21000.0n 0.5086 21599.5n 0.5086 21600.0n 0.5007 22199.5n 0.5007 22200.0n 0.5023 22799.5n 0.5023 22800.0n 0.5021 23399.5n 0.5021 23400.0n 0.5077 23999.5n 0.5077 24000.0n 0.4979 24599.5n 0.4979 24600.0n 0.5035 25199.5n 0.5035 25200.0n 0.5041 25799.5n 0.5041 25800.0n 0.5075 26399.5n 0.5075 26400.0n 0.5041 26999.5n 0.5041 27000.0n 0.5056 27599.5n 0.5056 27600.0n 0.5039 28199.5n 0.5039 28200.0n 0.5059 28799.5n 0.5059 28800.0n 0.5023 29399.5n 0.5023 29400.0n 0.5086 29999.5n 0.5086 30000.0n 0.5084 30599.5n 0.5084 30600.0n 0.5085 31199.5n 0.5085 31200.0n 0.5088 31799.5n 0.5088 31800.0n 0.5078 32399.5n 0.5078 32400.0n 0.5074 32999.5n 0.5074 33000.0n 0.4996 33599.5n 0.4996 33600.0n 0.5010 34199.5n 0.5010 34200.0n 0.5044 34799.5n 0.5044 34800.0n 0.5084 35399.5n 0.5084 35400.0n 0.5012 35999.5n 0.5012)
Vyn_who_27_1 yn_who_27_1 0 PWL(0.0n 0.4929 599.5n 0.4929 600.0n 0.4947 1199.5n 0.4947 1200.0n 0.4948 1799.5n 0.4948 1800.0n 0.4973 2399.5n 0.4973 2400.0n 0.4966 2999.5n 0.4966 3000.0n 0.4945 3599.5n 0.4945 3600.0n 0.4944 4199.5n 0.4944 4200.0n 0.4929 4799.5n 0.4929 4800.0n 0.4944 5399.5n 0.4944 5400.0n 0.4944 5999.5n 0.4944 6000.0n 0.4952 6599.5n 0.4952 6600.0n 0.4940 7199.5n 0.4940 7200.0n 0.4952 7799.5n 0.4952 7800.0n 0.4954 8399.5n 0.4954 8400.0n 0.4934 8999.5n 0.4934 9000.0n 0.4944 9599.5n 0.4944 9600.0n 0.4949 10199.5n 0.4949 10200.0n 0.4954 10799.5n 0.4954 10800.0n 0.4944 11399.5n 0.4944 11400.0n 0.4942 11999.5n 0.4942 12000.0n 0.4932 12599.5n 0.4932 12600.0n 0.4950 13199.5n 0.4950 13200.0n 0.4929 13799.5n 0.4929 13800.0n 0.4941 14399.5n 0.4941 14400.0n 0.4942 14999.5n 0.4942 15000.0n 0.4957 15599.5n 0.4957 15600.0n 0.4933 16199.5n 0.4933 16200.0n 0.4932 16799.5n 0.4932 16800.0n 0.4934 17399.5n 0.4934 17400.0n 0.4931 17999.5n 0.4931 18000.0n 0.4939 18599.5n 0.4939 18600.0n 0.4966 19199.5n 0.4966 19200.0n 0.4990 19799.5n 0.4990 19800.0n 0.5011 20399.5n 0.5011 20400.0n 0.4978 20999.5n 0.4978 21000.0n 0.4914 21599.5n 0.4914 21600.0n 0.4993 22199.5n 0.4993 22200.0n 0.4977 22799.5n 0.4977 22800.0n 0.4979 23399.5n 0.4979 23400.0n 0.4923 23999.5n 0.4923 24000.0n 0.5021 24599.5n 0.5021 24600.0n 0.4965 25199.5n 0.4965 25200.0n 0.4959 25799.5n 0.4959 25800.0n 0.4925 26399.5n 0.4925 26400.0n 0.4959 26999.5n 0.4959 27000.0n 0.4944 27599.5n 0.4944 27600.0n 0.4961 28199.5n 0.4961 28200.0n 0.4941 28799.5n 0.4941 28800.0n 0.4977 29399.5n 0.4977 29400.0n 0.4914 29999.5n 0.4914 30000.0n 0.4916 30599.5n 0.4916 30600.0n 0.4915 31199.5n 0.4915 31200.0n 0.4912 31799.5n 0.4912 31800.0n 0.4922 32399.5n 0.4922 32400.0n 0.4926 32999.5n 0.4926 33000.0n 0.5004 33599.5n 0.5004 33600.0n 0.4990 34199.5n 0.4990 34200.0n 0.4956 34799.5n 0.4956 34800.0n 0.4916 35399.5n 0.4916 35400.0n 0.4988 35999.5n 0.4988)
Cwp_who_27_1 wp_who_27_1 0 400p
Cwn_who_27_1 wn_who_27_1 0 400p
Xu_who_27_1 xp_who_27_1 xn_who_27_1 yp_who_27_1 yn_who_27_1 wp_who_27_1 wn_who_27_1 vdd gbn gprod
Vxp_bh_27 xp_bh_27 0 PWL(0.0n 0.7100 599.5n 0.7100 600.0n 0.7100 1199.5n 0.7100 1200.0n 0.7100 1799.5n 0.7100 1800.0n 0.7100 2399.5n 0.7100 2400.0n 0.7100 2999.5n 0.7100 3000.0n 0.7100 3599.5n 0.7100 3600.0n 0.7100 4199.5n 0.7100 4200.0n 0.7100 4799.5n 0.7100 4800.0n 0.7100 5399.5n 0.7100 5400.0n 0.7100 5999.5n 0.7100 6000.0n 0.7100 6599.5n 0.7100 6600.0n 0.7100 7199.5n 0.7100 7200.0n 0.7100 7799.5n 0.7100 7800.0n 0.7100 8399.5n 0.7100 8400.0n 0.7100 8999.5n 0.7100 9000.0n 0.7100 9599.5n 0.7100 9600.0n 0.7100 10199.5n 0.7100 10200.0n 0.7100 10799.5n 0.7100 10800.0n 0.7100 11399.5n 0.7100 11400.0n 0.7100 11999.5n 0.7100 12000.0n 0.7100 12599.5n 0.7100 12600.0n 0.7100 13199.5n 0.7100 13200.0n 0.7100 13799.5n 0.7100 13800.0n 0.7100 14399.5n 0.7100 14400.0n 0.7100 14999.5n 0.7100 15000.0n 0.7100 15599.5n 0.7100 15600.0n 0.7100 16199.5n 0.7100 16200.0n 0.7100 16799.5n 0.7100 16800.0n 0.7100 17399.5n 0.7100 17400.0n 0.7100 17999.5n 0.7100 18000.0n 0.7100 18599.5n 0.7100 18600.0n 0.7100 19199.5n 0.7100 19200.0n 0.7100 19799.5n 0.7100 19800.0n 0.7100 20399.5n 0.7100 20400.0n 0.7100 20999.5n 0.7100 21000.0n 0.7100 21599.5n 0.7100 21600.0n 0.7100 22199.5n 0.7100 22200.0n 0.7100 22799.5n 0.7100 22800.0n 0.7100 23399.5n 0.7100 23400.0n 0.7100 23999.5n 0.7100 24000.0n 0.7100 24599.5n 0.7100 24600.0n 0.7100 25199.5n 0.7100 25200.0n 0.7100 25799.5n 0.7100 25800.0n 0.7100 26399.5n 0.7100 26400.0n 0.7100 26999.5n 0.7100 27000.0n 0.7100 27599.5n 0.7100 27600.0n 0.7100 28199.5n 0.7100 28200.0n 0.7100 28799.5n 0.7100 28800.0n 0.7100 29399.5n 0.7100 29400.0n 0.7100 29999.5n 0.7100 30000.0n 0.7100 30599.5n 0.7100 30600.0n 0.7100 31199.5n 0.7100 31200.0n 0.7100 31799.5n 0.7100 31800.0n 0.7100 32399.5n 0.7100 32400.0n 0.7100 32999.5n 0.7100 33000.0n 0.7100 33599.5n 0.7100 33600.0n 0.7100 34199.5n 0.7100 34200.0n 0.7100 34799.5n 0.7100 34800.0n 0.7100 35399.5n 0.7100 35400.0n 0.7100 35999.5n 0.7100)
Vxn_bh_27 xn_bh_27 0 PWL(0.0n 0.2900 599.5n 0.2900 600.0n 0.2900 1199.5n 0.2900 1200.0n 0.2900 1799.5n 0.2900 1800.0n 0.2900 2399.5n 0.2900 2400.0n 0.2900 2999.5n 0.2900 3000.0n 0.2900 3599.5n 0.2900 3600.0n 0.2900 4199.5n 0.2900 4200.0n 0.2900 4799.5n 0.2900 4800.0n 0.2900 5399.5n 0.2900 5400.0n 0.2900 5999.5n 0.2900 6000.0n 0.2900 6599.5n 0.2900 6600.0n 0.2900 7199.5n 0.2900 7200.0n 0.2900 7799.5n 0.2900 7800.0n 0.2900 8399.5n 0.2900 8400.0n 0.2900 8999.5n 0.2900 9000.0n 0.2900 9599.5n 0.2900 9600.0n 0.2900 10199.5n 0.2900 10200.0n 0.2900 10799.5n 0.2900 10800.0n 0.2900 11399.5n 0.2900 11400.0n 0.2900 11999.5n 0.2900 12000.0n 0.2900 12599.5n 0.2900 12600.0n 0.2900 13199.5n 0.2900 13200.0n 0.2900 13799.5n 0.2900 13800.0n 0.2900 14399.5n 0.2900 14400.0n 0.2900 14999.5n 0.2900 15000.0n 0.2900 15599.5n 0.2900 15600.0n 0.2900 16199.5n 0.2900 16200.0n 0.2900 16799.5n 0.2900 16800.0n 0.2900 17399.5n 0.2900 17400.0n 0.2900 17999.5n 0.2900 18000.0n 0.2900 18599.5n 0.2900 18600.0n 0.2900 19199.5n 0.2900 19200.0n 0.2900 19799.5n 0.2900 19800.0n 0.2900 20399.5n 0.2900 20400.0n 0.2900 20999.5n 0.2900 21000.0n 0.2900 21599.5n 0.2900 21600.0n 0.2900 22199.5n 0.2900 22200.0n 0.2900 22799.5n 0.2900 22800.0n 0.2900 23399.5n 0.2900 23400.0n 0.2900 23999.5n 0.2900 24000.0n 0.2900 24599.5n 0.2900 24600.0n 0.2900 25199.5n 0.2900 25200.0n 0.2900 25799.5n 0.2900 25800.0n 0.2900 26399.5n 0.2900 26400.0n 0.2900 26999.5n 0.2900 27000.0n 0.2900 27599.5n 0.2900 27600.0n 0.2900 28199.5n 0.2900 28200.0n 0.2900 28799.5n 0.2900 28800.0n 0.2900 29399.5n 0.2900 29400.0n 0.2900 29999.5n 0.2900 30000.0n 0.2900 30599.5n 0.2900 30600.0n 0.2900 31199.5n 0.2900 31200.0n 0.2900 31799.5n 0.2900 31800.0n 0.2900 32399.5n 0.2900 32400.0n 0.2900 32999.5n 0.2900 33000.0n 0.2900 33599.5n 0.2900 33600.0n 0.2900 34199.5n 0.2900 34200.0n 0.2900 34799.5n 0.2900 34800.0n 0.2900 35399.5n 0.2900 35400.0n 0.2900 35999.5n 0.2900)
Vyp_bh_27 yp_bh_27 0 PWL(0.0n 0.3509 599.5n 0.3509 600.0n 0.3418 1199.5n 0.3418 1200.0n 0.4084 1799.5n 0.4084 1800.0n 0.4173 2399.5n 0.4173 2400.0n 0.3891 2999.5n 0.3891 3000.0n 0.3570 3599.5n 0.3570 3600.0n 0.3956 4199.5n 0.3956 4200.0n 0.3519 4799.5n 0.3519 4800.0n 0.3694 5399.5n 0.3694 5400.0n 0.3691 5999.5n 0.3691 6000.0n 0.4143 6599.5n 0.4143 6600.0n 0.3679 7199.5n 0.3679 7200.0n 0.3472 7799.5n 0.3472 7800.0n 0.3478 8399.5n 0.3478 8400.0n 0.3680 8999.5n 0.3680 9000.0n 0.3687 9599.5n 0.3687 9600.0n 0.3701 10199.5n 0.3701 10200.0n 0.3577 10799.5n 0.3577 10800.0n 0.4165 11399.5n 0.4165 11400.0n 0.3666 11999.5n 0.3666 12000.0n 0.3697 12599.5n 0.3697 12600.0n 0.3701 13199.5n 0.3701 13200.0n 0.3485 13799.5n 0.3485 13800.0n 0.3471 14399.5n 0.3471 14400.0n 0.3623 14999.5n 0.3623 15000.0n 0.3755 15599.5n 0.3755 15600.0n 0.3579 16199.5n 0.3579 16200.0n 0.3450 16799.5n 0.3450 16800.0n 0.3747 17399.5n 0.3747 17400.0n 0.3488 17999.5n 0.3488 18000.0n 0.5427 18599.5n 0.5427 18600.0n 0.3326 19199.5n 0.3326 19200.0n 0.4562 19799.5n 0.4562 19800.0n 0.3553 20399.5n 0.3553 20400.0n 0.5017 20999.5n 0.5017 21000.0n 0.5097 21599.5n 0.5097 21600.0n 0.3425 22199.5n 0.3425 22200.0n 0.3306 22799.5n 0.3306 22800.0n 0.5252 23399.5n 0.5252 23400.0n 0.3194 23999.5n 0.3194 24000.0n 0.3977 24599.5n 0.3977 24600.0n 0.3280 25199.5n 0.3280 25200.0n 0.5311 25799.5n 0.5311 25800.0n 0.6096 26399.5n 0.6096 26400.0n 0.5620 26999.5n 0.5620 27000.0n 0.5579 27599.5n 0.5579 27600.0n 0.5577 28199.5n 0.5577 28200.0n 0.3188 28799.5n 0.3188 28800.0n 0.5167 29399.5n 0.5167 29400.0n 0.4940 29999.5n 0.4940 30000.0n 0.4690 30599.5n 0.4690 30600.0n 0.3471 31199.5n 0.3471 31200.0n 0.3370 31799.5n 0.3370 31800.0n 0.6035 32399.5n 0.6035 32400.0n 0.6096 32999.5n 0.6096 33000.0n 0.4370 33599.5n 0.4370 33600.0n 0.4840 34199.5n 0.4840 34200.0n 0.3269 34799.5n 0.3269 34800.0n 0.4301 35399.5n 0.4301 35400.0n 0.4704 35999.5n 0.4704)
Vyn_bh_27 yn_bh_27 0 PWL(0.0n 0.6491 599.5n 0.6491 600.0n 0.6582 1199.5n 0.6582 1200.0n 0.5916 1799.5n 0.5916 1800.0n 0.5827 2399.5n 0.5827 2400.0n 0.6109 2999.5n 0.6109 3000.0n 0.6430 3599.5n 0.6430 3600.0n 0.6044 4199.5n 0.6044 4200.0n 0.6481 4799.5n 0.6481 4800.0n 0.6306 5399.5n 0.6306 5400.0n 0.6309 5999.5n 0.6309 6000.0n 0.5857 6599.5n 0.5857 6600.0n 0.6321 7199.5n 0.6321 7200.0n 0.6528 7799.5n 0.6528 7800.0n 0.6522 8399.5n 0.6522 8400.0n 0.6320 8999.5n 0.6320 9000.0n 0.6313 9599.5n 0.6313 9600.0n 0.6299 10199.5n 0.6299 10200.0n 0.6423 10799.5n 0.6423 10800.0n 0.5835 11399.5n 0.5835 11400.0n 0.6334 11999.5n 0.6334 12000.0n 0.6303 12599.5n 0.6303 12600.0n 0.6299 13199.5n 0.6299 13200.0n 0.6515 13799.5n 0.6515 13800.0n 0.6529 14399.5n 0.6529 14400.0n 0.6377 14999.5n 0.6377 15000.0n 0.6245 15599.5n 0.6245 15600.0n 0.6421 16199.5n 0.6421 16200.0n 0.6550 16799.5n 0.6550 16800.0n 0.6253 17399.5n 0.6253 17400.0n 0.6512 17999.5n 0.6512 18000.0n 0.4573 18599.5n 0.4573 18600.0n 0.6674 19199.5n 0.6674 19200.0n 0.5438 19799.5n 0.5438 19800.0n 0.6447 20399.5n 0.6447 20400.0n 0.4983 20999.5n 0.4983 21000.0n 0.4903 21599.5n 0.4903 21600.0n 0.6575 22199.5n 0.6575 22200.0n 0.6694 22799.5n 0.6694 22800.0n 0.4748 23399.5n 0.4748 23400.0n 0.6806 23999.5n 0.6806 24000.0n 0.6023 24599.5n 0.6023 24600.0n 0.6720 25199.5n 0.6720 25200.0n 0.4689 25799.5n 0.4689 25800.0n 0.3904 26399.5n 0.3904 26400.0n 0.4380 26999.5n 0.4380 27000.0n 0.4421 27599.5n 0.4421 27600.0n 0.4423 28199.5n 0.4423 28200.0n 0.6812 28799.5n 0.6812 28800.0n 0.4833 29399.5n 0.4833 29400.0n 0.5060 29999.5n 0.5060 30000.0n 0.5310 30599.5n 0.5310 30600.0n 0.6529 31199.5n 0.6529 31200.0n 0.6630 31799.5n 0.6630 31800.0n 0.3965 32399.5n 0.3965 32400.0n 0.3904 32999.5n 0.3904 33000.0n 0.5630 33599.5n 0.5630 33600.0n 0.5160 34199.5n 0.5160 34200.0n 0.6731 34799.5n 0.6731 34800.0n 0.5699 35399.5n 0.5699 35400.0n 0.5296 35999.5n 0.5296)
Cwp_bh_27 wp_bh_27 0 400p
Cwn_bh_27 wn_bh_27 0 400p
Xu_bh_27 xp_bh_27 xn_bh_27 yp_bh_27 yn_bh_27 wp_bh_27 wn_bh_27 vdd gbn gprod
Vxp_wih_0_28 xp_wih_0_28 0 PWL(0.0n 0.4942 599.5n 0.4942 600.0n 0.5558 1199.5n 0.5558 1200.0n 0.4708 1799.5n 0.4708 1800.0n 0.5235 2399.5n 0.5235 2400.0n 0.5350 2999.5n 0.5350 3000.0n 0.5172 3599.5n 0.5172 3600.0n 0.4702 4199.5n 0.4702 4200.0n 0.4867 4799.5n 0.4867 4800.0n 0.4970 5399.5n 0.4970 5400.0n 0.4986 5999.5n 0.4986 6000.0n 0.4751 6599.5n 0.4751 6600.0n 0.4870 7199.5n 0.4870 7200.0n 0.5502 7799.5n 0.5502 7800.0n 0.5521 8399.5n 0.5521 8400.0n 0.4638 8999.5n 0.4638 9000.0n 0.4982 9599.5n 0.4982 9600.0n 0.5131 10199.5n 0.5131 10200.0n 0.5386 10799.5n 0.5386 10800.0n 0.4592 11399.5n 0.4592 11400.0n 0.4950 11999.5n 0.4950 12000.0n 0.4559 12599.5n 0.4559 12600.0n 0.5162 13199.5n 0.5162 13200.0n 0.5038 13799.5n 0.5038 13800.0n 0.5333 14399.5n 0.5333 14400.0n 0.4991 14999.5n 0.4991 15000.0n 0.5298 15599.5n 0.5298 15600.0n 0.4823 16199.5n 0.4823 16200.0n 0.5239 16799.5n 0.5239 16800.0n 0.4592 17399.5n 0.4592 17400.0n 0.5094 17999.5n 0.5094 18000.0n 0.4337 18599.5n 0.4337 18600.0n 0.5977 19199.5n 0.5977 19200.0n 0.5364 19799.5n 0.5364 19800.0n 0.6122 20399.5n 0.6122 20400.0n 0.4856 20999.5n 0.4856 21000.0n 0.3861 21599.5n 0.3861 21600.0n 0.6094 22199.5n 0.6094 22200.0n 0.6364 22799.5n 0.6364 22800.0n 0.4807 23399.5n 0.4807 23400.0n 0.5614 23999.5n 0.5614 24000.0n 0.5913 24599.5n 0.5913 24600.0n 0.6295 25199.5n 0.6295 25200.0n 0.4496 25799.5n 0.4496 25800.0n 0.3792 26399.5n 0.3792 26400.0n 0.4434 26999.5n 0.4434 27000.0n 0.4340 27599.5n 0.4340 27600.0n 0.4461 28199.5n 0.4461 28200.0n 0.5791 28799.5n 0.5791 28800.0n 0.4777 29399.5n 0.4777 29400.0n 0.3878 29999.5n 0.3878 30000.0n 0.3832 30599.5n 0.3832 30600.0n 0.4022 31199.5n 0.4022 31200.0n 0.4482 31799.5n 0.4482 31800.0n 0.3662 32399.5n 0.3662 32400.0n 0.3857 32999.5n 0.3857 33000.0n 0.5584 33599.5n 0.5584 33600.0n 0.5284 34199.5n 0.5284 34200.0n 0.6034 34799.5n 0.6034 34800.0n 0.3469 35399.5n 0.3469 35400.0n 0.5290 35999.5n 0.5290)
Vxn_wih_0_28 xn_wih_0_28 0 PWL(0.0n 0.5058 599.5n 0.5058 600.0n 0.4442 1199.5n 0.4442 1200.0n 0.5292 1799.5n 0.5292 1800.0n 0.4765 2399.5n 0.4765 2400.0n 0.4650 2999.5n 0.4650 3000.0n 0.4828 3599.5n 0.4828 3600.0n 0.5298 4199.5n 0.5298 4200.0n 0.5133 4799.5n 0.5133 4800.0n 0.5030 5399.5n 0.5030 5400.0n 0.5014 5999.5n 0.5014 6000.0n 0.5249 6599.5n 0.5249 6600.0n 0.5130 7199.5n 0.5130 7200.0n 0.4498 7799.5n 0.4498 7800.0n 0.4479 8399.5n 0.4479 8400.0n 0.5362 8999.5n 0.5362 9000.0n 0.5018 9599.5n 0.5018 9600.0n 0.4869 10199.5n 0.4869 10200.0n 0.4614 10799.5n 0.4614 10800.0n 0.5408 11399.5n 0.5408 11400.0n 0.5050 11999.5n 0.5050 12000.0n 0.5441 12599.5n 0.5441 12600.0n 0.4838 13199.5n 0.4838 13200.0n 0.4962 13799.5n 0.4962 13800.0n 0.4667 14399.5n 0.4667 14400.0n 0.5009 14999.5n 0.5009 15000.0n 0.4702 15599.5n 0.4702 15600.0n 0.5177 16199.5n 0.5177 16200.0n 0.4761 16799.5n 0.4761 16800.0n 0.5408 17399.5n 0.5408 17400.0n 0.4906 17999.5n 0.4906 18000.0n 0.5663 18599.5n 0.5663 18600.0n 0.4023 19199.5n 0.4023 19200.0n 0.4636 19799.5n 0.4636 19800.0n 0.3878 20399.5n 0.3878 20400.0n 0.5144 20999.5n 0.5144 21000.0n 0.6139 21599.5n 0.6139 21600.0n 0.3906 22199.5n 0.3906 22200.0n 0.3636 22799.5n 0.3636 22800.0n 0.5193 23399.5n 0.5193 23400.0n 0.4386 23999.5n 0.4386 24000.0n 0.4087 24599.5n 0.4087 24600.0n 0.3705 25199.5n 0.3705 25200.0n 0.5504 25799.5n 0.5504 25800.0n 0.6208 26399.5n 0.6208 26400.0n 0.5566 26999.5n 0.5566 27000.0n 0.5660 27599.5n 0.5660 27600.0n 0.5539 28199.5n 0.5539 28200.0n 0.4209 28799.5n 0.4209 28800.0n 0.5223 29399.5n 0.5223 29400.0n 0.6122 29999.5n 0.6122 30000.0n 0.6168 30599.5n 0.6168 30600.0n 0.5978 31199.5n 0.5978 31200.0n 0.5518 31799.5n 0.5518 31800.0n 0.6338 32399.5n 0.6338 32400.0n 0.6143 32999.5n 0.6143 33000.0n 0.4416 33599.5n 0.4416 33600.0n 0.4716 34199.5n 0.4716 34200.0n 0.3966 34799.5n 0.3966 34800.0n 0.6531 35399.5n 0.6531 35400.0n 0.4710 35999.5n 0.4710)
Vyp_wih_0_28 yp_wih_0_28 0 PWL(0.0n 0.4528 599.5n 0.4528 600.0n 0.4434 1199.5n 0.4434 1200.0n 0.4743 1799.5n 0.4743 1800.0n 0.4773 2399.5n 0.4773 2400.0n 0.4687 2999.5n 0.4687 3000.0n 0.4575 3599.5n 0.4575 3600.0n 0.4705 4199.5n 0.4705 4200.0n 0.4538 4799.5n 0.4538 4800.0n 0.4624 5399.5n 0.4624 5400.0n 0.4623 5999.5n 0.4623 6000.0n 0.4761 6599.5n 0.4761 6600.0n 0.4619 7199.5n 0.4619 7200.0n 0.4499 7799.5n 0.4499 7800.0n 0.4506 8399.5n 0.4506 8400.0n 0.4620 8999.5n 0.4620 9000.0n 0.4622 9599.5n 0.4622 9600.0n 0.4626 10199.5n 0.4626 10200.0n 0.4581 10799.5n 0.4581 10800.0n 0.4766 11399.5n 0.4766 11400.0n 0.4615 11999.5n 0.4615 12000.0n 0.4626 12599.5n 0.4626 12600.0n 0.4626 13199.5n 0.4626 13200.0n 0.4505 13799.5n 0.4505 13800.0n 0.4493 14399.5n 0.4493 14400.0n 0.4601 14999.5n 0.4601 15000.0n 0.4643 15599.5n 0.4643 15600.0n 0.4580 16199.5n 0.4580 16200.0n 0.4468 16799.5n 0.4468 16800.0n 0.4641 17399.5n 0.4641 17400.0n 0.4508 17999.5n 0.4508 18000.0n 0.5174 18599.5n 0.5174 18600.0n 0.4259 19199.5n 0.4259 19200.0n 0.4965 19799.5n 0.4965 19800.0n 0.4563 20399.5n 0.4563 20400.0n 0.5102 20999.5n 0.5102 21000.0n 0.5074 21599.5n 0.5074 21600.0n 0.4424 22199.5n 0.4424 22200.0n 0.4263 22799.5n 0.4263 22800.0n 0.5142 23399.5n 0.5142 23400.0n 0.3995 23999.5n 0.3995 24000.0n 0.4766 24599.5n 0.4766 24600.0n 0.4204 25199.5n 0.4204 25200.0n 0.5169 25799.5n 0.5169 25800.0n 0.5440 26399.5n 0.5440 26400.0n 0.5252 26999.5n 0.5252 27000.0n 0.5241 27599.5n 0.5241 27600.0n 0.5240 28199.5n 0.5240 28200.0n 0.3929 28799.5n 0.3929 28800.0n 0.5145 29399.5n 0.5145 29400.0n 0.5032 29999.5n 0.5032 30000.0n 0.4961 30599.5n 0.4961 30600.0n 0.4513 31199.5n 0.4513 31200.0n 0.4311 31799.5n 0.4311 31800.0n 0.5397 32399.5n 0.5397 32400.0n 0.5448 32999.5n 0.5448 33000.0n 0.4925 33599.5n 0.4925 33600.0n 0.5041 34199.5n 0.5041 34200.0n 0.4154 34799.5n 0.4154 34800.0n 0.4830 35399.5n 0.4830 35400.0n 0.5015 35999.5n 0.5015)
Vyn_wih_0_28 yn_wih_0_28 0 PWL(0.0n 0.5472 599.5n 0.5472 600.0n 0.5566 1199.5n 0.5566 1200.0n 0.5257 1799.5n 0.5257 1800.0n 0.5227 2399.5n 0.5227 2400.0n 0.5313 2999.5n 0.5313 3000.0n 0.5425 3599.5n 0.5425 3600.0n 0.5295 4199.5n 0.5295 4200.0n 0.5462 4799.5n 0.5462 4800.0n 0.5376 5399.5n 0.5376 5400.0n 0.5377 5999.5n 0.5377 6000.0n 0.5239 6599.5n 0.5239 6600.0n 0.5381 7199.5n 0.5381 7200.0n 0.5501 7799.5n 0.5501 7800.0n 0.5494 8399.5n 0.5494 8400.0n 0.5380 8999.5n 0.5380 9000.0n 0.5378 9599.5n 0.5378 9600.0n 0.5374 10199.5n 0.5374 10200.0n 0.5419 10799.5n 0.5419 10800.0n 0.5234 11399.5n 0.5234 11400.0n 0.5385 11999.5n 0.5385 12000.0n 0.5374 12599.5n 0.5374 12600.0n 0.5374 13199.5n 0.5374 13200.0n 0.5495 13799.5n 0.5495 13800.0n 0.5507 14399.5n 0.5507 14400.0n 0.5399 14999.5n 0.5399 15000.0n 0.5357 15599.5n 0.5357 15600.0n 0.5420 16199.5n 0.5420 16200.0n 0.5532 16799.5n 0.5532 16800.0n 0.5359 17399.5n 0.5359 17400.0n 0.5492 17999.5n 0.5492 18000.0n 0.4826 18599.5n 0.4826 18600.0n 0.5741 19199.5n 0.5741 19200.0n 0.5035 19799.5n 0.5035 19800.0n 0.5437 20399.5n 0.5437 20400.0n 0.4898 20999.5n 0.4898 21000.0n 0.4926 21599.5n 0.4926 21600.0n 0.5576 22199.5n 0.5576 22200.0n 0.5737 22799.5n 0.5737 22800.0n 0.4858 23399.5n 0.4858 23400.0n 0.6005 23999.5n 0.6005 24000.0n 0.5234 24599.5n 0.5234 24600.0n 0.5796 25199.5n 0.5796 25200.0n 0.4831 25799.5n 0.4831 25800.0n 0.4560 26399.5n 0.4560 26400.0n 0.4748 26999.5n 0.4748 27000.0n 0.4759 27599.5n 0.4759 27600.0n 0.4760 28199.5n 0.4760 28200.0n 0.6071 28799.5n 0.6071 28800.0n 0.4855 29399.5n 0.4855 29400.0n 0.4968 29999.5n 0.4968 30000.0n 0.5039 30599.5n 0.5039 30600.0n 0.5487 31199.5n 0.5487 31200.0n 0.5689 31799.5n 0.5689 31800.0n 0.4603 32399.5n 0.4603 32400.0n 0.4552 32999.5n 0.4552 33000.0n 0.5075 33599.5n 0.5075 33600.0n 0.4959 34199.5n 0.4959 34200.0n 0.5846 34799.5n 0.5846 34800.0n 0.5170 35399.5n 0.5170 35400.0n 0.4985 35999.5n 0.4985)
Cwp_wih_0_28 wp_wih_0_28 0 400p
Cwn_wih_0_28 wn_wih_0_28 0 400p
Xu_wih_0_28 xp_wih_0_28 xn_wih_0_28 yp_wih_0_28 yn_wih_0_28 wp_wih_0_28 wn_wih_0_28 vdd gbn gprod
Vxp_wih_1_28 xp_wih_1_28 0 PWL(0.0n 0.5370 599.5n 0.5370 600.0n 0.5167 1199.5n 0.5167 1200.0n 0.4793 1799.5n 0.4793 1800.0n 0.4441 2399.5n 0.4441 2400.0n 0.4555 2999.5n 0.4555 3000.0n 0.5055 3599.5n 0.5055 3600.0n 0.4939 4199.5n 0.4939 4200.0n 0.5385 4799.5n 0.5385 4800.0n 0.5024 5399.5n 0.5024 5400.0n 0.5015 5999.5n 0.5015 6000.0n 0.4700 6599.5n 0.4700 6600.0n 0.5120 7199.5n 0.5120 7200.0n 0.5006 7799.5n 0.5006 7800.0n 0.4950 8399.5n 0.4950 8400.0n 0.5309 8999.5n 0.5309 9000.0n 0.5023 9599.5n 0.5023 9600.0n 0.4893 10199.5n 0.4893 10200.0n 0.4837 10799.5n 0.4837 10800.0n 0.4823 11399.5n 0.4823 11400.0n 0.5074 11999.5n 0.5074 12000.0n 0.5364 12599.5n 0.5364 12600.0n 0.4868 13199.5n 0.4868 13200.0n 0.5380 13799.5n 0.5380 13800.0n 0.5220 14399.5n 0.5220 14400.0n 0.5095 14999.5n 0.5095 15000.0n 0.4705 15599.5n 0.4705 15600.0n 0.5289 16199.5n 0.5289 16200.0n 0.5368 16799.5n 0.5368 16800.0n 0.5287 17399.5n 0.5287 17400.0n 0.5342 17999.5n 0.5342 18000.0n 0.4253 18599.5n 0.4253 18600.0n 0.5119 19199.5n 0.5119 19200.0n 0.4104 19799.5n 0.4104 19800.0n 0.4314 20399.5n 0.4314 20400.0n 0.4005 20999.5n 0.4005 21000.0n 0.4696 21599.5n 0.4696 21600.0n 0.4531 22199.5n 0.4531 22200.0n 0.5039 22799.5n 0.5039 22800.0n 0.3608 23399.5n 0.3608 23400.0n 0.6273 23999.5n 0.6273 24000.0n 0.3928 24599.5n 0.3928 24600.0n 0.5253 25199.5n 0.5253 25200.0n 0.4107 25799.5n 0.4107 25800.0n 0.3947 26399.5n 0.3947 26400.0n 0.3716 26999.5n 0.3716 27000.0n 0.4111 27599.5n 0.4111 27600.0n 0.3715 28199.5n 0.3715 28200.0n 0.5939 28799.5n 0.5939 28800.0n 0.3849 29399.5n 0.3849 29400.0n 0.4835 29999.5n 0.4835 30000.0n 0.5119 30599.5n 0.5119 30600.0n 0.6226 31199.5n 0.6226 31200.0n 0.6064 31799.5n 0.6064 31800.0n 0.4115 32399.5n 0.4115 32400.0n 0.3900 32999.5n 0.3900 33000.0n 0.3958 33599.5n 0.3958 33600.0n 0.3747 34199.5n 0.3747 34200.0n 0.5423 34799.5n 0.5423 34800.0n 0.5509 35399.5n 0.5509 35400.0n 0.3990 35999.5n 0.3990)
Vxn_wih_1_28 xn_wih_1_28 0 PWL(0.0n 0.4630 599.5n 0.4630 600.0n 0.4833 1199.5n 0.4833 1200.0n 0.5207 1799.5n 0.5207 1800.0n 0.5559 2399.5n 0.5559 2400.0n 0.5445 2999.5n 0.5445 3000.0n 0.4945 3599.5n 0.4945 3600.0n 0.5061 4199.5n 0.5061 4200.0n 0.4615 4799.5n 0.4615 4800.0n 0.4976 5399.5n 0.4976 5400.0n 0.4985 5999.5n 0.4985 6000.0n 0.5300 6599.5n 0.5300 6600.0n 0.4880 7199.5n 0.4880 7200.0n 0.4994 7799.5n 0.4994 7800.0n 0.5050 8399.5n 0.5050 8400.0n 0.4691 8999.5n 0.4691 9000.0n 0.4977 9599.5n 0.4977 9600.0n 0.5107 10199.5n 0.5107 10200.0n 0.5163 10799.5n 0.5163 10800.0n 0.5177 11399.5n 0.5177 11400.0n 0.4926 11999.5n 0.4926 12000.0n 0.4636 12599.5n 0.4636 12600.0n 0.5132 13199.5n 0.5132 13200.0n 0.4620 13799.5n 0.4620 13800.0n 0.4780 14399.5n 0.4780 14400.0n 0.4905 14999.5n 0.4905 15000.0n 0.5295 15599.5n 0.5295 15600.0n 0.4711 16199.5n 0.4711 16200.0n 0.4632 16799.5n 0.4632 16800.0n 0.4713 17399.5n 0.4713 17400.0n 0.4658 17999.5n 0.4658 18000.0n 0.5747 18599.5n 0.5747 18600.0n 0.4881 19199.5n 0.4881 19200.0n 0.5896 19799.5n 0.5896 19800.0n 0.5686 20399.5n 0.5686 20400.0n 0.5995 20999.5n 0.5995 21000.0n 0.5304 21599.5n 0.5304 21600.0n 0.5469 22199.5n 0.5469 22200.0n 0.4961 22799.5n 0.4961 22800.0n 0.6392 23399.5n 0.6392 23400.0n 0.3727 23999.5n 0.3727 24000.0n 0.6072 24599.5n 0.6072 24600.0n 0.4747 25199.5n 0.4747 25200.0n 0.5893 25799.5n 0.5893 25800.0n 0.6053 26399.5n 0.6053 26400.0n 0.6284 26999.5n 0.6284 27000.0n 0.5889 27599.5n 0.5889 27600.0n 0.6285 28199.5n 0.6285 28200.0n 0.4061 28799.5n 0.4061 28800.0n 0.6151 29399.5n 0.6151 29400.0n 0.5165 29999.5n 0.5165 30000.0n 0.4881 30599.5n 0.4881 30600.0n 0.3774 31199.5n 0.3774 31200.0n 0.3936 31799.5n 0.3936 31800.0n 0.5885 32399.5n 0.5885 32400.0n 0.6100 32999.5n 0.6100 33000.0n 0.6042 33599.5n 0.6042 33600.0n 0.6253 34199.5n 0.6253 34200.0n 0.4577 34799.5n 0.4577 34800.0n 0.4491 35399.5n 0.4491 35400.0n 0.6010 35999.5n 0.6010)
Vyp_wih_1_28 yp_wih_1_28 0 PWL(0.0n 0.4528 599.5n 0.4528 600.0n 0.4434 1199.5n 0.4434 1200.0n 0.4743 1799.5n 0.4743 1800.0n 0.4773 2399.5n 0.4773 2400.0n 0.4687 2999.5n 0.4687 3000.0n 0.4575 3599.5n 0.4575 3600.0n 0.4705 4199.5n 0.4705 4200.0n 0.4538 4799.5n 0.4538 4800.0n 0.4624 5399.5n 0.4624 5400.0n 0.4623 5999.5n 0.4623 6000.0n 0.4761 6599.5n 0.4761 6600.0n 0.4619 7199.5n 0.4619 7200.0n 0.4499 7799.5n 0.4499 7800.0n 0.4506 8399.5n 0.4506 8400.0n 0.4620 8999.5n 0.4620 9000.0n 0.4622 9599.5n 0.4622 9600.0n 0.4626 10199.5n 0.4626 10200.0n 0.4581 10799.5n 0.4581 10800.0n 0.4766 11399.5n 0.4766 11400.0n 0.4615 11999.5n 0.4615 12000.0n 0.4626 12599.5n 0.4626 12600.0n 0.4626 13199.5n 0.4626 13200.0n 0.4505 13799.5n 0.4505 13800.0n 0.4493 14399.5n 0.4493 14400.0n 0.4601 14999.5n 0.4601 15000.0n 0.4643 15599.5n 0.4643 15600.0n 0.4580 16199.5n 0.4580 16200.0n 0.4468 16799.5n 0.4468 16800.0n 0.4641 17399.5n 0.4641 17400.0n 0.4508 17999.5n 0.4508 18000.0n 0.5174 18599.5n 0.5174 18600.0n 0.4259 19199.5n 0.4259 19200.0n 0.4965 19799.5n 0.4965 19800.0n 0.4563 20399.5n 0.4563 20400.0n 0.5102 20999.5n 0.5102 21000.0n 0.5074 21599.5n 0.5074 21600.0n 0.4424 22199.5n 0.4424 22200.0n 0.4263 22799.5n 0.4263 22800.0n 0.5142 23399.5n 0.5142 23400.0n 0.3995 23999.5n 0.3995 24000.0n 0.4766 24599.5n 0.4766 24600.0n 0.4204 25199.5n 0.4204 25200.0n 0.5169 25799.5n 0.5169 25800.0n 0.5440 26399.5n 0.5440 26400.0n 0.5252 26999.5n 0.5252 27000.0n 0.5241 27599.5n 0.5241 27600.0n 0.5240 28199.5n 0.5240 28200.0n 0.3929 28799.5n 0.3929 28800.0n 0.5145 29399.5n 0.5145 29400.0n 0.5032 29999.5n 0.5032 30000.0n 0.4961 30599.5n 0.4961 30600.0n 0.4513 31199.5n 0.4513 31200.0n 0.4311 31799.5n 0.4311 31800.0n 0.5397 32399.5n 0.5397 32400.0n 0.5448 32999.5n 0.5448 33000.0n 0.4925 33599.5n 0.4925 33600.0n 0.5041 34199.5n 0.5041 34200.0n 0.4154 34799.5n 0.4154 34800.0n 0.4830 35399.5n 0.4830 35400.0n 0.5015 35999.5n 0.5015)
Vyn_wih_1_28 yn_wih_1_28 0 PWL(0.0n 0.5472 599.5n 0.5472 600.0n 0.5566 1199.5n 0.5566 1200.0n 0.5257 1799.5n 0.5257 1800.0n 0.5227 2399.5n 0.5227 2400.0n 0.5313 2999.5n 0.5313 3000.0n 0.5425 3599.5n 0.5425 3600.0n 0.5295 4199.5n 0.5295 4200.0n 0.5462 4799.5n 0.5462 4800.0n 0.5376 5399.5n 0.5376 5400.0n 0.5377 5999.5n 0.5377 6000.0n 0.5239 6599.5n 0.5239 6600.0n 0.5381 7199.5n 0.5381 7200.0n 0.5501 7799.5n 0.5501 7800.0n 0.5494 8399.5n 0.5494 8400.0n 0.5380 8999.5n 0.5380 9000.0n 0.5378 9599.5n 0.5378 9600.0n 0.5374 10199.5n 0.5374 10200.0n 0.5419 10799.5n 0.5419 10800.0n 0.5234 11399.5n 0.5234 11400.0n 0.5385 11999.5n 0.5385 12000.0n 0.5374 12599.5n 0.5374 12600.0n 0.5374 13199.5n 0.5374 13200.0n 0.5495 13799.5n 0.5495 13800.0n 0.5507 14399.5n 0.5507 14400.0n 0.5399 14999.5n 0.5399 15000.0n 0.5357 15599.5n 0.5357 15600.0n 0.5420 16199.5n 0.5420 16200.0n 0.5532 16799.5n 0.5532 16800.0n 0.5359 17399.5n 0.5359 17400.0n 0.5492 17999.5n 0.5492 18000.0n 0.4826 18599.5n 0.4826 18600.0n 0.5741 19199.5n 0.5741 19200.0n 0.5035 19799.5n 0.5035 19800.0n 0.5437 20399.5n 0.5437 20400.0n 0.4898 20999.5n 0.4898 21000.0n 0.4926 21599.5n 0.4926 21600.0n 0.5576 22199.5n 0.5576 22200.0n 0.5737 22799.5n 0.5737 22800.0n 0.4858 23399.5n 0.4858 23400.0n 0.6005 23999.5n 0.6005 24000.0n 0.5234 24599.5n 0.5234 24600.0n 0.5796 25199.5n 0.5796 25200.0n 0.4831 25799.5n 0.4831 25800.0n 0.4560 26399.5n 0.4560 26400.0n 0.4748 26999.5n 0.4748 27000.0n 0.4759 27599.5n 0.4759 27600.0n 0.4760 28199.5n 0.4760 28200.0n 0.6071 28799.5n 0.6071 28800.0n 0.4855 29399.5n 0.4855 29400.0n 0.4968 29999.5n 0.4968 30000.0n 0.5039 30599.5n 0.5039 30600.0n 0.5487 31199.5n 0.5487 31200.0n 0.5689 31799.5n 0.5689 31800.0n 0.4603 32399.5n 0.4603 32400.0n 0.4552 32999.5n 0.4552 33000.0n 0.5075 33599.5n 0.5075 33600.0n 0.4959 34199.5n 0.4959 34200.0n 0.5846 34799.5n 0.5846 34800.0n 0.5170 35399.5n 0.5170 35400.0n 0.4985 35999.5n 0.4985)
Cwp_wih_1_28 wp_wih_1_28 0 400p
Cwn_wih_1_28 wn_wih_1_28 0 400p
Xu_wih_1_28 xp_wih_1_28 xn_wih_1_28 yp_wih_1_28 yn_wih_1_28 wp_wih_1_28 wn_wih_1_28 vdd gbn gprod
Vxp_who_28_0 xp_who_28_0 0 PWL(0.0n 0.4528 599.5n 0.4528 600.0n 0.4434 1199.5n 0.4434 1200.0n 0.4743 1799.5n 0.4743 1800.0n 0.4773 2399.5n 0.4773 2400.0n 0.4687 2999.5n 0.4687 3000.0n 0.4575 3599.5n 0.4575 3600.0n 0.4705 4199.5n 0.4705 4200.0n 0.4538 4799.5n 0.4538 4800.0n 0.4624 5399.5n 0.4624 5400.0n 0.4623 5999.5n 0.4623 6000.0n 0.4761 6599.5n 0.4761 6600.0n 0.4619 7199.5n 0.4619 7200.0n 0.4499 7799.5n 0.4499 7800.0n 0.4506 8399.5n 0.4506 8400.0n 0.4620 8999.5n 0.4620 9000.0n 0.4622 9599.5n 0.4622 9600.0n 0.4626 10199.5n 0.4626 10200.0n 0.4581 10799.5n 0.4581 10800.0n 0.4766 11399.5n 0.4766 11400.0n 0.4615 11999.5n 0.4615 12000.0n 0.4626 12599.5n 0.4626 12600.0n 0.4626 13199.5n 0.4626 13200.0n 0.4505 13799.5n 0.4505 13800.0n 0.4493 14399.5n 0.4493 14400.0n 0.4601 14999.5n 0.4601 15000.0n 0.4643 15599.5n 0.4643 15600.0n 0.4580 16199.5n 0.4580 16200.0n 0.4468 16799.5n 0.4468 16800.0n 0.4641 17399.5n 0.4641 17400.0n 0.4508 17999.5n 0.4508 18000.0n 0.5174 18599.5n 0.5174 18600.0n 0.4259 19199.5n 0.4259 19200.0n 0.4965 19799.5n 0.4965 19800.0n 0.4563 20399.5n 0.4563 20400.0n 0.5102 20999.5n 0.5102 21000.0n 0.5074 21599.5n 0.5074 21600.0n 0.4424 22199.5n 0.4424 22200.0n 0.4263 22799.5n 0.4263 22800.0n 0.5142 23399.5n 0.5142 23400.0n 0.3995 23999.5n 0.3995 24000.0n 0.4766 24599.5n 0.4766 24600.0n 0.4204 25199.5n 0.4204 25200.0n 0.5169 25799.5n 0.5169 25800.0n 0.5440 26399.5n 0.5440 26400.0n 0.5252 26999.5n 0.5252 27000.0n 0.5241 27599.5n 0.5241 27600.0n 0.5240 28199.5n 0.5240 28200.0n 0.3929 28799.5n 0.3929 28800.0n 0.5145 29399.5n 0.5145 29400.0n 0.5032 29999.5n 0.5032 30000.0n 0.4961 30599.5n 0.4961 30600.0n 0.4513 31199.5n 0.4513 31200.0n 0.4311 31799.5n 0.4311 31800.0n 0.5397 32399.5n 0.5397 32400.0n 0.5448 32999.5n 0.5448 33000.0n 0.4925 33599.5n 0.4925 33600.0n 0.5041 34199.5n 0.5041 34200.0n 0.4154 34799.5n 0.4154 34800.0n 0.4830 35399.5n 0.4830 35400.0n 0.5015 35999.5n 0.5015)
Vxn_who_28_0 xn_who_28_0 0 PWL(0.0n 0.5472 599.5n 0.5472 600.0n 0.5566 1199.5n 0.5566 1200.0n 0.5257 1799.5n 0.5257 1800.0n 0.5227 2399.5n 0.5227 2400.0n 0.5313 2999.5n 0.5313 3000.0n 0.5425 3599.5n 0.5425 3600.0n 0.5295 4199.5n 0.5295 4200.0n 0.5462 4799.5n 0.5462 4800.0n 0.5376 5399.5n 0.5376 5400.0n 0.5377 5999.5n 0.5377 6000.0n 0.5239 6599.5n 0.5239 6600.0n 0.5381 7199.5n 0.5381 7200.0n 0.5501 7799.5n 0.5501 7800.0n 0.5494 8399.5n 0.5494 8400.0n 0.5380 8999.5n 0.5380 9000.0n 0.5378 9599.5n 0.5378 9600.0n 0.5374 10199.5n 0.5374 10200.0n 0.5419 10799.5n 0.5419 10800.0n 0.5234 11399.5n 0.5234 11400.0n 0.5385 11999.5n 0.5385 12000.0n 0.5374 12599.5n 0.5374 12600.0n 0.5374 13199.5n 0.5374 13200.0n 0.5495 13799.5n 0.5495 13800.0n 0.5507 14399.5n 0.5507 14400.0n 0.5399 14999.5n 0.5399 15000.0n 0.5357 15599.5n 0.5357 15600.0n 0.5420 16199.5n 0.5420 16200.0n 0.5532 16799.5n 0.5532 16800.0n 0.5359 17399.5n 0.5359 17400.0n 0.5492 17999.5n 0.5492 18000.0n 0.4826 18599.5n 0.4826 18600.0n 0.5741 19199.5n 0.5741 19200.0n 0.5035 19799.5n 0.5035 19800.0n 0.5437 20399.5n 0.5437 20400.0n 0.4898 20999.5n 0.4898 21000.0n 0.4926 21599.5n 0.4926 21600.0n 0.5576 22199.5n 0.5576 22200.0n 0.5737 22799.5n 0.5737 22800.0n 0.4858 23399.5n 0.4858 23400.0n 0.6005 23999.5n 0.6005 24000.0n 0.5234 24599.5n 0.5234 24600.0n 0.5796 25199.5n 0.5796 25200.0n 0.4831 25799.5n 0.4831 25800.0n 0.4560 26399.5n 0.4560 26400.0n 0.4748 26999.5n 0.4748 27000.0n 0.4759 27599.5n 0.4759 27600.0n 0.4760 28199.5n 0.4760 28200.0n 0.6071 28799.5n 0.6071 28800.0n 0.4855 29399.5n 0.4855 29400.0n 0.4968 29999.5n 0.4968 30000.0n 0.5039 30599.5n 0.5039 30600.0n 0.5487 31199.5n 0.5487 31200.0n 0.5689 31799.5n 0.5689 31800.0n 0.4603 32399.5n 0.4603 32400.0n 0.4552 32999.5n 0.4552 33000.0n 0.5075 33599.5n 0.5075 33600.0n 0.4959 34199.5n 0.4959 34200.0n 0.5846 34799.5n 0.5846 34800.0n 0.5170 35399.5n 0.5170 35400.0n 0.4985 35999.5n 0.4985)
Vyp_who_28_0 yp_who_28_0 0 PWL(0.0n 0.5031 599.5n 0.5031 600.0n 0.5023 1199.5n 0.5023 1200.0n 0.5052 1799.5n 0.5052 1800.0n 0.5048 2399.5n 0.5048 2400.0n 0.5043 2999.5n 0.5043 3000.0n 0.5034 3599.5n 0.5034 3600.0n 0.5048 4199.5n 0.5048 4200.0n 0.5031 4799.5n 0.5031 4800.0n 0.5040 5399.5n 0.5040 5400.0n 0.5040 5999.5n 0.5040 6000.0n 0.5054 6599.5n 0.5054 6600.0n 0.5040 7199.5n 0.5040 7200.0n 0.5027 7799.5n 0.5027 7800.0n 0.5027 8399.5n 0.5027 8400.0n 0.5038 8999.5n 0.5038 9000.0n 0.5040 9599.5n 0.5040 9600.0n 0.5039 10199.5n 0.5039 10200.0n 0.5033 10799.5n 0.5033 10800.0n 0.5056 11399.5n 0.5056 11400.0n 0.5040 11999.5n 0.5040 12000.0n 0.5036 12599.5n 0.5036 12600.0n 0.5039 13199.5n 0.5039 13200.0n 0.5029 13799.5n 0.5029 13800.0n 0.5025 14399.5n 0.5025 14400.0n 0.5038 14999.5n 0.5038 15000.0n 0.5041 15599.5n 0.5041 15600.0n 0.5036 16199.5n 0.5036 16200.0n 0.5025 16799.5n 0.5025 16800.0n 0.5040 17399.5n 0.5040 17400.0n 0.5029 17999.5n 0.5029 18000.0n 0.5057 18599.5n 0.5057 18600.0n 0.5010 19199.5n 0.5010 19200.0n 0.5041 19799.5n 0.5041 19800.0n 0.5021 20399.5n 0.5021 20400.0n 0.5044 20999.5n 0.5044 21000.0n 0.5056 21599.5n 0.5056 21600.0n 0.5016 22199.5n 0.5016 22200.0n 0.5006 22799.5n 0.5006 22800.0n 0.5041 23399.5n 0.5041 23400.0n 0.5027 23999.5n 0.5027 24000.0n 0.5029 24599.5n 0.5029 24600.0n 0.5006 25199.5n 0.5006 25200.0n 0.5047 25799.5n 0.5047 25800.0n 0.5046 26399.5n 0.5046 26400.0n 0.5039 26999.5n 0.5039 27000.0n 0.5049 27599.5n 0.5049 27600.0n 0.5039 28199.5n 0.5039 28200.0n 0.5017 28799.5n 0.5017 28800.0n 0.5042 29399.5n 0.5042 29400.0n 0.5056 29999.5n 0.5056 30000.0n 0.5051 30599.5n 0.5051 30600.0n 0.5039 31199.5n 0.5039 31200.0n 0.5033 31799.5n 0.5033 31800.0n 0.5049 32399.5n 0.5049 32400.0n 0.5045 32999.5n 0.5045 33000.0n 0.5036 33599.5n 0.5036 33600.0n 0.5042 34199.5n 0.5042 34200.0n 0.5012 34799.5n 0.5012 34800.0n 0.5036 35399.5n 0.5036 35400.0n 0.5042 35999.5n 0.5042)
Vyn_who_28_0 yn_who_28_0 0 PWL(0.0n 0.4969 599.5n 0.4969 600.0n 0.4977 1199.5n 0.4977 1200.0n 0.4948 1799.5n 0.4948 1800.0n 0.4952 2399.5n 0.4952 2400.0n 0.4957 2999.5n 0.4957 3000.0n 0.4966 3599.5n 0.4966 3600.0n 0.4952 4199.5n 0.4952 4200.0n 0.4969 4799.5n 0.4969 4800.0n 0.4960 5399.5n 0.4960 5400.0n 0.4960 5999.5n 0.4960 6000.0n 0.4946 6599.5n 0.4946 6600.0n 0.4960 7199.5n 0.4960 7200.0n 0.4973 7799.5n 0.4973 7800.0n 0.4973 8399.5n 0.4973 8400.0n 0.4962 8999.5n 0.4962 9000.0n 0.4960 9599.5n 0.4960 9600.0n 0.4961 10199.5n 0.4961 10200.0n 0.4967 10799.5n 0.4967 10800.0n 0.4944 11399.5n 0.4944 11400.0n 0.4960 11999.5n 0.4960 12000.0n 0.4964 12599.5n 0.4964 12600.0n 0.4961 13199.5n 0.4961 13200.0n 0.4971 13799.5n 0.4971 13800.0n 0.4975 14399.5n 0.4975 14400.0n 0.4962 14999.5n 0.4962 15000.0n 0.4959 15599.5n 0.4959 15600.0n 0.4964 16199.5n 0.4964 16200.0n 0.4975 16799.5n 0.4975 16800.0n 0.4960 17399.5n 0.4960 17400.0n 0.4971 17999.5n 0.4971 18000.0n 0.4943 18599.5n 0.4943 18600.0n 0.4990 19199.5n 0.4990 19200.0n 0.4959 19799.5n 0.4959 19800.0n 0.4979 20399.5n 0.4979 20400.0n 0.4956 20999.5n 0.4956 21000.0n 0.4944 21599.5n 0.4944 21600.0n 0.4984 22199.5n 0.4984 22200.0n 0.4994 22799.5n 0.4994 22800.0n 0.4959 23399.5n 0.4959 23400.0n 0.4973 23999.5n 0.4973 24000.0n 0.4971 24599.5n 0.4971 24600.0n 0.4994 25199.5n 0.4994 25200.0n 0.4953 25799.5n 0.4953 25800.0n 0.4954 26399.5n 0.4954 26400.0n 0.4961 26999.5n 0.4961 27000.0n 0.4951 27599.5n 0.4951 27600.0n 0.4961 28199.5n 0.4961 28200.0n 0.4983 28799.5n 0.4983 28800.0n 0.4958 29399.5n 0.4958 29400.0n 0.4944 29999.5n 0.4944 30000.0n 0.4949 30599.5n 0.4949 30600.0n 0.4961 31199.5n 0.4961 31200.0n 0.4967 31799.5n 0.4967 31800.0n 0.4951 32399.5n 0.4951 32400.0n 0.4955 32999.5n 0.4955 33000.0n 0.4964 33599.5n 0.4964 33600.0n 0.4958 34199.5n 0.4958 34200.0n 0.4988 34799.5n 0.4988 34800.0n 0.4964 35399.5n 0.4964 35400.0n 0.4958 35999.5n 0.4958)
Cwp_who_28_0 wp_who_28_0 0 400p
Cwn_who_28_0 wn_who_28_0 0 400p
Xu_who_28_0 xp_who_28_0 xn_who_28_0 yp_who_28_0 yn_who_28_0 wp_who_28_0 wn_who_28_0 vdd gbn gprod
Vxp_who_28_1 xp_who_28_1 0 PWL(0.0n 0.4528 599.5n 0.4528 600.0n 0.4434 1199.5n 0.4434 1200.0n 0.4743 1799.5n 0.4743 1800.0n 0.4773 2399.5n 0.4773 2400.0n 0.4687 2999.5n 0.4687 3000.0n 0.4575 3599.5n 0.4575 3600.0n 0.4705 4199.5n 0.4705 4200.0n 0.4538 4799.5n 0.4538 4800.0n 0.4624 5399.5n 0.4624 5400.0n 0.4623 5999.5n 0.4623 6000.0n 0.4761 6599.5n 0.4761 6600.0n 0.4619 7199.5n 0.4619 7200.0n 0.4499 7799.5n 0.4499 7800.0n 0.4506 8399.5n 0.4506 8400.0n 0.4620 8999.5n 0.4620 9000.0n 0.4622 9599.5n 0.4622 9600.0n 0.4626 10199.5n 0.4626 10200.0n 0.4581 10799.5n 0.4581 10800.0n 0.4766 11399.5n 0.4766 11400.0n 0.4615 11999.5n 0.4615 12000.0n 0.4626 12599.5n 0.4626 12600.0n 0.4626 13199.5n 0.4626 13200.0n 0.4505 13799.5n 0.4505 13800.0n 0.4493 14399.5n 0.4493 14400.0n 0.4601 14999.5n 0.4601 15000.0n 0.4643 15599.5n 0.4643 15600.0n 0.4580 16199.5n 0.4580 16200.0n 0.4468 16799.5n 0.4468 16800.0n 0.4641 17399.5n 0.4641 17400.0n 0.4508 17999.5n 0.4508 18000.0n 0.5174 18599.5n 0.5174 18600.0n 0.4259 19199.5n 0.4259 19200.0n 0.4965 19799.5n 0.4965 19800.0n 0.4563 20399.5n 0.4563 20400.0n 0.5102 20999.5n 0.5102 21000.0n 0.5074 21599.5n 0.5074 21600.0n 0.4424 22199.5n 0.4424 22200.0n 0.4263 22799.5n 0.4263 22800.0n 0.5142 23399.5n 0.5142 23400.0n 0.3995 23999.5n 0.3995 24000.0n 0.4766 24599.5n 0.4766 24600.0n 0.4204 25199.5n 0.4204 25200.0n 0.5169 25799.5n 0.5169 25800.0n 0.5440 26399.5n 0.5440 26400.0n 0.5252 26999.5n 0.5252 27000.0n 0.5241 27599.5n 0.5241 27600.0n 0.5240 28199.5n 0.5240 28200.0n 0.3929 28799.5n 0.3929 28800.0n 0.5145 29399.5n 0.5145 29400.0n 0.5032 29999.5n 0.5032 30000.0n 0.4961 30599.5n 0.4961 30600.0n 0.4513 31199.5n 0.4513 31200.0n 0.4311 31799.5n 0.4311 31800.0n 0.5397 32399.5n 0.5397 32400.0n 0.5448 32999.5n 0.5448 33000.0n 0.4925 33599.5n 0.4925 33600.0n 0.5041 34199.5n 0.5041 34200.0n 0.4154 34799.5n 0.4154 34800.0n 0.4830 35399.5n 0.4830 35400.0n 0.5015 35999.5n 0.5015)
Vxn_who_28_1 xn_who_28_1 0 PWL(0.0n 0.5472 599.5n 0.5472 600.0n 0.5566 1199.5n 0.5566 1200.0n 0.5257 1799.5n 0.5257 1800.0n 0.5227 2399.5n 0.5227 2400.0n 0.5313 2999.5n 0.5313 3000.0n 0.5425 3599.5n 0.5425 3600.0n 0.5295 4199.5n 0.5295 4200.0n 0.5462 4799.5n 0.5462 4800.0n 0.5376 5399.5n 0.5376 5400.0n 0.5377 5999.5n 0.5377 6000.0n 0.5239 6599.5n 0.5239 6600.0n 0.5381 7199.5n 0.5381 7200.0n 0.5501 7799.5n 0.5501 7800.0n 0.5494 8399.5n 0.5494 8400.0n 0.5380 8999.5n 0.5380 9000.0n 0.5378 9599.5n 0.5378 9600.0n 0.5374 10199.5n 0.5374 10200.0n 0.5419 10799.5n 0.5419 10800.0n 0.5234 11399.5n 0.5234 11400.0n 0.5385 11999.5n 0.5385 12000.0n 0.5374 12599.5n 0.5374 12600.0n 0.5374 13199.5n 0.5374 13200.0n 0.5495 13799.5n 0.5495 13800.0n 0.5507 14399.5n 0.5507 14400.0n 0.5399 14999.5n 0.5399 15000.0n 0.5357 15599.5n 0.5357 15600.0n 0.5420 16199.5n 0.5420 16200.0n 0.5532 16799.5n 0.5532 16800.0n 0.5359 17399.5n 0.5359 17400.0n 0.5492 17999.5n 0.5492 18000.0n 0.4826 18599.5n 0.4826 18600.0n 0.5741 19199.5n 0.5741 19200.0n 0.5035 19799.5n 0.5035 19800.0n 0.5437 20399.5n 0.5437 20400.0n 0.4898 20999.5n 0.4898 21000.0n 0.4926 21599.5n 0.4926 21600.0n 0.5576 22199.5n 0.5576 22200.0n 0.5737 22799.5n 0.5737 22800.0n 0.4858 23399.5n 0.4858 23400.0n 0.6005 23999.5n 0.6005 24000.0n 0.5234 24599.5n 0.5234 24600.0n 0.5796 25199.5n 0.5796 25200.0n 0.4831 25799.5n 0.4831 25800.0n 0.4560 26399.5n 0.4560 26400.0n 0.4748 26999.5n 0.4748 27000.0n 0.4759 27599.5n 0.4759 27600.0n 0.4760 28199.5n 0.4760 28200.0n 0.6071 28799.5n 0.6071 28800.0n 0.4855 29399.5n 0.4855 29400.0n 0.4968 29999.5n 0.4968 30000.0n 0.5039 30599.5n 0.5039 30600.0n 0.5487 31199.5n 0.5487 31200.0n 0.5689 31799.5n 0.5689 31800.0n 0.4603 32399.5n 0.4603 32400.0n 0.4552 32999.5n 0.4552 33000.0n 0.5075 33599.5n 0.5075 33600.0n 0.4959 34199.5n 0.4959 34200.0n 0.5846 34799.5n 0.5846 34800.0n 0.5170 35399.5n 0.5170 35400.0n 0.4985 35999.5n 0.4985)
Vyp_who_28_1 yp_who_28_1 0 PWL(0.0n 0.5071 599.5n 0.5071 600.0n 0.5053 1199.5n 0.5053 1200.0n 0.5052 1799.5n 0.5052 1800.0n 0.5027 2399.5n 0.5027 2400.0n 0.5034 2999.5n 0.5034 3000.0n 0.5055 3599.5n 0.5055 3600.0n 0.5056 4199.5n 0.5056 4200.0n 0.5071 4799.5n 0.5071 4800.0n 0.5056 5399.5n 0.5056 5400.0n 0.5056 5999.5n 0.5056 6000.0n 0.5048 6599.5n 0.5048 6600.0n 0.5060 7199.5n 0.5060 7200.0n 0.5048 7799.5n 0.5048 7800.0n 0.5046 8399.5n 0.5046 8400.0n 0.5066 8999.5n 0.5066 9000.0n 0.5056 9599.5n 0.5056 9600.0n 0.5051 10199.5n 0.5051 10200.0n 0.5046 10799.5n 0.5046 10800.0n 0.5056 11399.5n 0.5056 11400.0n 0.5058 11999.5n 0.5058 12000.0n 0.5068 12599.5n 0.5068 12600.0n 0.5050 13199.5n 0.5050 13200.0n 0.5071 13799.5n 0.5071 13800.0n 0.5059 14399.5n 0.5059 14400.0n 0.5058 14999.5n 0.5058 15000.0n 0.5043 15599.5n 0.5043 15600.0n 0.5067 16199.5n 0.5067 16200.0n 0.5068 16799.5n 0.5068 16800.0n 0.5066 17399.5n 0.5066 17400.0n 0.5069 17999.5n 0.5069 18000.0n 0.5061 18599.5n 0.5061 18600.0n 0.5034 19199.5n 0.5034 19200.0n 0.5010 19799.5n 0.5010 19800.0n 0.4989 20399.5n 0.4989 20400.0n 0.5022 20999.5n 0.5022 21000.0n 0.5086 21599.5n 0.5086 21600.0n 0.5007 22199.5n 0.5007 22200.0n 0.5023 22799.5n 0.5023 22800.0n 0.5021 23399.5n 0.5021 23400.0n 0.5077 23999.5n 0.5077 24000.0n 0.4979 24599.5n 0.4979 24600.0n 0.5035 25199.5n 0.5035 25200.0n 0.5041 25799.5n 0.5041 25800.0n 0.5075 26399.5n 0.5075 26400.0n 0.5041 26999.5n 0.5041 27000.0n 0.5056 27599.5n 0.5056 27600.0n 0.5039 28199.5n 0.5039 28200.0n 0.5059 28799.5n 0.5059 28800.0n 0.5023 29399.5n 0.5023 29400.0n 0.5086 29999.5n 0.5086 30000.0n 0.5084 30599.5n 0.5084 30600.0n 0.5085 31199.5n 0.5085 31200.0n 0.5088 31799.5n 0.5088 31800.0n 0.5078 32399.5n 0.5078 32400.0n 0.5074 32999.5n 0.5074 33000.0n 0.4996 33599.5n 0.4996 33600.0n 0.5010 34199.5n 0.5010 34200.0n 0.5044 34799.5n 0.5044 34800.0n 0.5084 35399.5n 0.5084 35400.0n 0.5012 35999.5n 0.5012)
Vyn_who_28_1 yn_who_28_1 0 PWL(0.0n 0.4929 599.5n 0.4929 600.0n 0.4947 1199.5n 0.4947 1200.0n 0.4948 1799.5n 0.4948 1800.0n 0.4973 2399.5n 0.4973 2400.0n 0.4966 2999.5n 0.4966 3000.0n 0.4945 3599.5n 0.4945 3600.0n 0.4944 4199.5n 0.4944 4200.0n 0.4929 4799.5n 0.4929 4800.0n 0.4944 5399.5n 0.4944 5400.0n 0.4944 5999.5n 0.4944 6000.0n 0.4952 6599.5n 0.4952 6600.0n 0.4940 7199.5n 0.4940 7200.0n 0.4952 7799.5n 0.4952 7800.0n 0.4954 8399.5n 0.4954 8400.0n 0.4934 8999.5n 0.4934 9000.0n 0.4944 9599.5n 0.4944 9600.0n 0.4949 10199.5n 0.4949 10200.0n 0.4954 10799.5n 0.4954 10800.0n 0.4944 11399.5n 0.4944 11400.0n 0.4942 11999.5n 0.4942 12000.0n 0.4932 12599.5n 0.4932 12600.0n 0.4950 13199.5n 0.4950 13200.0n 0.4929 13799.5n 0.4929 13800.0n 0.4941 14399.5n 0.4941 14400.0n 0.4942 14999.5n 0.4942 15000.0n 0.4957 15599.5n 0.4957 15600.0n 0.4933 16199.5n 0.4933 16200.0n 0.4932 16799.5n 0.4932 16800.0n 0.4934 17399.5n 0.4934 17400.0n 0.4931 17999.5n 0.4931 18000.0n 0.4939 18599.5n 0.4939 18600.0n 0.4966 19199.5n 0.4966 19200.0n 0.4990 19799.5n 0.4990 19800.0n 0.5011 20399.5n 0.5011 20400.0n 0.4978 20999.5n 0.4978 21000.0n 0.4914 21599.5n 0.4914 21600.0n 0.4993 22199.5n 0.4993 22200.0n 0.4977 22799.5n 0.4977 22800.0n 0.4979 23399.5n 0.4979 23400.0n 0.4923 23999.5n 0.4923 24000.0n 0.5021 24599.5n 0.5021 24600.0n 0.4965 25199.5n 0.4965 25200.0n 0.4959 25799.5n 0.4959 25800.0n 0.4925 26399.5n 0.4925 26400.0n 0.4959 26999.5n 0.4959 27000.0n 0.4944 27599.5n 0.4944 27600.0n 0.4961 28199.5n 0.4961 28200.0n 0.4941 28799.5n 0.4941 28800.0n 0.4977 29399.5n 0.4977 29400.0n 0.4914 29999.5n 0.4914 30000.0n 0.4916 30599.5n 0.4916 30600.0n 0.4915 31199.5n 0.4915 31200.0n 0.4912 31799.5n 0.4912 31800.0n 0.4922 32399.5n 0.4922 32400.0n 0.4926 32999.5n 0.4926 33000.0n 0.5004 33599.5n 0.5004 33600.0n 0.4990 34199.5n 0.4990 34200.0n 0.4956 34799.5n 0.4956 34800.0n 0.4916 35399.5n 0.4916 35400.0n 0.4988 35999.5n 0.4988)
Cwp_who_28_1 wp_who_28_1 0 400p
Cwn_who_28_1 wn_who_28_1 0 400p
Xu_who_28_1 xp_who_28_1 xn_who_28_1 yp_who_28_1 yn_who_28_1 wp_who_28_1 wn_who_28_1 vdd gbn gprod
Vxp_bh_28 xp_bh_28 0 PWL(0.0n 0.7100 599.5n 0.7100 600.0n 0.7100 1199.5n 0.7100 1200.0n 0.7100 1799.5n 0.7100 1800.0n 0.7100 2399.5n 0.7100 2400.0n 0.7100 2999.5n 0.7100 3000.0n 0.7100 3599.5n 0.7100 3600.0n 0.7100 4199.5n 0.7100 4200.0n 0.7100 4799.5n 0.7100 4800.0n 0.7100 5399.5n 0.7100 5400.0n 0.7100 5999.5n 0.7100 6000.0n 0.7100 6599.5n 0.7100 6600.0n 0.7100 7199.5n 0.7100 7200.0n 0.7100 7799.5n 0.7100 7800.0n 0.7100 8399.5n 0.7100 8400.0n 0.7100 8999.5n 0.7100 9000.0n 0.7100 9599.5n 0.7100 9600.0n 0.7100 10199.5n 0.7100 10200.0n 0.7100 10799.5n 0.7100 10800.0n 0.7100 11399.5n 0.7100 11400.0n 0.7100 11999.5n 0.7100 12000.0n 0.7100 12599.5n 0.7100 12600.0n 0.7100 13199.5n 0.7100 13200.0n 0.7100 13799.5n 0.7100 13800.0n 0.7100 14399.5n 0.7100 14400.0n 0.7100 14999.5n 0.7100 15000.0n 0.7100 15599.5n 0.7100 15600.0n 0.7100 16199.5n 0.7100 16200.0n 0.7100 16799.5n 0.7100 16800.0n 0.7100 17399.5n 0.7100 17400.0n 0.7100 17999.5n 0.7100 18000.0n 0.7100 18599.5n 0.7100 18600.0n 0.7100 19199.5n 0.7100 19200.0n 0.7100 19799.5n 0.7100 19800.0n 0.7100 20399.5n 0.7100 20400.0n 0.7100 20999.5n 0.7100 21000.0n 0.7100 21599.5n 0.7100 21600.0n 0.7100 22199.5n 0.7100 22200.0n 0.7100 22799.5n 0.7100 22800.0n 0.7100 23399.5n 0.7100 23400.0n 0.7100 23999.5n 0.7100 24000.0n 0.7100 24599.5n 0.7100 24600.0n 0.7100 25199.5n 0.7100 25200.0n 0.7100 25799.5n 0.7100 25800.0n 0.7100 26399.5n 0.7100 26400.0n 0.7100 26999.5n 0.7100 27000.0n 0.7100 27599.5n 0.7100 27600.0n 0.7100 28199.5n 0.7100 28200.0n 0.7100 28799.5n 0.7100 28800.0n 0.7100 29399.5n 0.7100 29400.0n 0.7100 29999.5n 0.7100 30000.0n 0.7100 30599.5n 0.7100 30600.0n 0.7100 31199.5n 0.7100 31200.0n 0.7100 31799.5n 0.7100 31800.0n 0.7100 32399.5n 0.7100 32400.0n 0.7100 32999.5n 0.7100 33000.0n 0.7100 33599.5n 0.7100 33600.0n 0.7100 34199.5n 0.7100 34200.0n 0.7100 34799.5n 0.7100 34800.0n 0.7100 35399.5n 0.7100 35400.0n 0.7100 35999.5n 0.7100)
Vxn_bh_28 xn_bh_28 0 PWL(0.0n 0.2900 599.5n 0.2900 600.0n 0.2900 1199.5n 0.2900 1200.0n 0.2900 1799.5n 0.2900 1800.0n 0.2900 2399.5n 0.2900 2400.0n 0.2900 2999.5n 0.2900 3000.0n 0.2900 3599.5n 0.2900 3600.0n 0.2900 4199.5n 0.2900 4200.0n 0.2900 4799.5n 0.2900 4800.0n 0.2900 5399.5n 0.2900 5400.0n 0.2900 5999.5n 0.2900 6000.0n 0.2900 6599.5n 0.2900 6600.0n 0.2900 7199.5n 0.2900 7200.0n 0.2900 7799.5n 0.2900 7800.0n 0.2900 8399.5n 0.2900 8400.0n 0.2900 8999.5n 0.2900 9000.0n 0.2900 9599.5n 0.2900 9600.0n 0.2900 10199.5n 0.2900 10200.0n 0.2900 10799.5n 0.2900 10800.0n 0.2900 11399.5n 0.2900 11400.0n 0.2900 11999.5n 0.2900 12000.0n 0.2900 12599.5n 0.2900 12600.0n 0.2900 13199.5n 0.2900 13200.0n 0.2900 13799.5n 0.2900 13800.0n 0.2900 14399.5n 0.2900 14400.0n 0.2900 14999.5n 0.2900 15000.0n 0.2900 15599.5n 0.2900 15600.0n 0.2900 16199.5n 0.2900 16200.0n 0.2900 16799.5n 0.2900 16800.0n 0.2900 17399.5n 0.2900 17400.0n 0.2900 17999.5n 0.2900 18000.0n 0.2900 18599.5n 0.2900 18600.0n 0.2900 19199.5n 0.2900 19200.0n 0.2900 19799.5n 0.2900 19800.0n 0.2900 20399.5n 0.2900 20400.0n 0.2900 20999.5n 0.2900 21000.0n 0.2900 21599.5n 0.2900 21600.0n 0.2900 22199.5n 0.2900 22200.0n 0.2900 22799.5n 0.2900 22800.0n 0.2900 23399.5n 0.2900 23400.0n 0.2900 23999.5n 0.2900 24000.0n 0.2900 24599.5n 0.2900 24600.0n 0.2900 25199.5n 0.2900 25200.0n 0.2900 25799.5n 0.2900 25800.0n 0.2900 26399.5n 0.2900 26400.0n 0.2900 26999.5n 0.2900 27000.0n 0.2900 27599.5n 0.2900 27600.0n 0.2900 28199.5n 0.2900 28200.0n 0.2900 28799.5n 0.2900 28800.0n 0.2900 29399.5n 0.2900 29400.0n 0.2900 29999.5n 0.2900 30000.0n 0.2900 30599.5n 0.2900 30600.0n 0.2900 31199.5n 0.2900 31200.0n 0.2900 31799.5n 0.2900 31800.0n 0.2900 32399.5n 0.2900 32400.0n 0.2900 32999.5n 0.2900 33000.0n 0.2900 33599.5n 0.2900 33600.0n 0.2900 34199.5n 0.2900 34200.0n 0.2900 34799.5n 0.2900 34800.0n 0.2900 35399.5n 0.2900 35400.0n 0.2900 35999.5n 0.2900)
Vyp_bh_28 yp_bh_28 0 PWL(0.0n 0.4528 599.5n 0.4528 600.0n 0.4434 1199.5n 0.4434 1200.0n 0.4743 1799.5n 0.4743 1800.0n 0.4773 2399.5n 0.4773 2400.0n 0.4687 2999.5n 0.4687 3000.0n 0.4575 3599.5n 0.4575 3600.0n 0.4705 4199.5n 0.4705 4200.0n 0.4538 4799.5n 0.4538 4800.0n 0.4624 5399.5n 0.4624 5400.0n 0.4623 5999.5n 0.4623 6000.0n 0.4761 6599.5n 0.4761 6600.0n 0.4619 7199.5n 0.4619 7200.0n 0.4499 7799.5n 0.4499 7800.0n 0.4506 8399.5n 0.4506 8400.0n 0.4620 8999.5n 0.4620 9000.0n 0.4622 9599.5n 0.4622 9600.0n 0.4626 10199.5n 0.4626 10200.0n 0.4581 10799.5n 0.4581 10800.0n 0.4766 11399.5n 0.4766 11400.0n 0.4615 11999.5n 0.4615 12000.0n 0.4626 12599.5n 0.4626 12600.0n 0.4626 13199.5n 0.4626 13200.0n 0.4505 13799.5n 0.4505 13800.0n 0.4493 14399.5n 0.4493 14400.0n 0.4601 14999.5n 0.4601 15000.0n 0.4643 15599.5n 0.4643 15600.0n 0.4580 16199.5n 0.4580 16200.0n 0.4468 16799.5n 0.4468 16800.0n 0.4641 17399.5n 0.4641 17400.0n 0.4508 17999.5n 0.4508 18000.0n 0.5174 18599.5n 0.5174 18600.0n 0.4259 19199.5n 0.4259 19200.0n 0.4965 19799.5n 0.4965 19800.0n 0.4563 20399.5n 0.4563 20400.0n 0.5102 20999.5n 0.5102 21000.0n 0.5074 21599.5n 0.5074 21600.0n 0.4424 22199.5n 0.4424 22200.0n 0.4263 22799.5n 0.4263 22800.0n 0.5142 23399.5n 0.5142 23400.0n 0.3995 23999.5n 0.3995 24000.0n 0.4766 24599.5n 0.4766 24600.0n 0.4204 25199.5n 0.4204 25200.0n 0.5169 25799.5n 0.5169 25800.0n 0.5440 26399.5n 0.5440 26400.0n 0.5252 26999.5n 0.5252 27000.0n 0.5241 27599.5n 0.5241 27600.0n 0.5240 28199.5n 0.5240 28200.0n 0.3929 28799.5n 0.3929 28800.0n 0.5145 29399.5n 0.5145 29400.0n 0.5032 29999.5n 0.5032 30000.0n 0.4961 30599.5n 0.4961 30600.0n 0.4513 31199.5n 0.4513 31200.0n 0.4311 31799.5n 0.4311 31800.0n 0.5397 32399.5n 0.5397 32400.0n 0.5448 32999.5n 0.5448 33000.0n 0.4925 33599.5n 0.4925 33600.0n 0.5041 34199.5n 0.5041 34200.0n 0.4154 34799.5n 0.4154 34800.0n 0.4830 35399.5n 0.4830 35400.0n 0.5015 35999.5n 0.5015)
Vyn_bh_28 yn_bh_28 0 PWL(0.0n 0.5472 599.5n 0.5472 600.0n 0.5566 1199.5n 0.5566 1200.0n 0.5257 1799.5n 0.5257 1800.0n 0.5227 2399.5n 0.5227 2400.0n 0.5313 2999.5n 0.5313 3000.0n 0.5425 3599.5n 0.5425 3600.0n 0.5295 4199.5n 0.5295 4200.0n 0.5462 4799.5n 0.5462 4800.0n 0.5376 5399.5n 0.5376 5400.0n 0.5377 5999.5n 0.5377 6000.0n 0.5239 6599.5n 0.5239 6600.0n 0.5381 7199.5n 0.5381 7200.0n 0.5501 7799.5n 0.5501 7800.0n 0.5494 8399.5n 0.5494 8400.0n 0.5380 8999.5n 0.5380 9000.0n 0.5378 9599.5n 0.5378 9600.0n 0.5374 10199.5n 0.5374 10200.0n 0.5419 10799.5n 0.5419 10800.0n 0.5234 11399.5n 0.5234 11400.0n 0.5385 11999.5n 0.5385 12000.0n 0.5374 12599.5n 0.5374 12600.0n 0.5374 13199.5n 0.5374 13200.0n 0.5495 13799.5n 0.5495 13800.0n 0.5507 14399.5n 0.5507 14400.0n 0.5399 14999.5n 0.5399 15000.0n 0.5357 15599.5n 0.5357 15600.0n 0.5420 16199.5n 0.5420 16200.0n 0.5532 16799.5n 0.5532 16800.0n 0.5359 17399.5n 0.5359 17400.0n 0.5492 17999.5n 0.5492 18000.0n 0.4826 18599.5n 0.4826 18600.0n 0.5741 19199.5n 0.5741 19200.0n 0.5035 19799.5n 0.5035 19800.0n 0.5437 20399.5n 0.5437 20400.0n 0.4898 20999.5n 0.4898 21000.0n 0.4926 21599.5n 0.4926 21600.0n 0.5576 22199.5n 0.5576 22200.0n 0.5737 22799.5n 0.5737 22800.0n 0.4858 23399.5n 0.4858 23400.0n 0.6005 23999.5n 0.6005 24000.0n 0.5234 24599.5n 0.5234 24600.0n 0.5796 25199.5n 0.5796 25200.0n 0.4831 25799.5n 0.4831 25800.0n 0.4560 26399.5n 0.4560 26400.0n 0.4748 26999.5n 0.4748 27000.0n 0.4759 27599.5n 0.4759 27600.0n 0.4760 28199.5n 0.4760 28200.0n 0.6071 28799.5n 0.6071 28800.0n 0.4855 29399.5n 0.4855 29400.0n 0.4968 29999.5n 0.4968 30000.0n 0.5039 30599.5n 0.5039 30600.0n 0.5487 31199.5n 0.5487 31200.0n 0.5689 31799.5n 0.5689 31800.0n 0.4603 32399.5n 0.4603 32400.0n 0.4552 32999.5n 0.4552 33000.0n 0.5075 33599.5n 0.5075 33600.0n 0.4959 34199.5n 0.4959 34200.0n 0.5846 34799.5n 0.5846 34800.0n 0.5170 35399.5n 0.5170 35400.0n 0.4985 35999.5n 0.4985)
Cwp_bh_28 wp_bh_28 0 400p
Cwn_bh_28 wn_bh_28 0 400p
Xu_bh_28 xp_bh_28 xn_bh_28 yp_bh_28 yn_bh_28 wp_bh_28 wn_bh_28 vdd gbn gprod
Vxp_wih_0_29 xp_wih_0_29 0 PWL(0.0n 0.4942 599.5n 0.4942 600.0n 0.5558 1199.5n 0.5558 1200.0n 0.4708 1799.5n 0.4708 1800.0n 0.5235 2399.5n 0.5235 2400.0n 0.5350 2999.5n 0.5350 3000.0n 0.5172 3599.5n 0.5172 3600.0n 0.4702 4199.5n 0.4702 4200.0n 0.4867 4799.5n 0.4867 4800.0n 0.4970 5399.5n 0.4970 5400.0n 0.4986 5999.5n 0.4986 6000.0n 0.4751 6599.5n 0.4751 6600.0n 0.4870 7199.5n 0.4870 7200.0n 0.5502 7799.5n 0.5502 7800.0n 0.5521 8399.5n 0.5521 8400.0n 0.4638 8999.5n 0.4638 9000.0n 0.4982 9599.5n 0.4982 9600.0n 0.5131 10199.5n 0.5131 10200.0n 0.5386 10799.5n 0.5386 10800.0n 0.4592 11399.5n 0.4592 11400.0n 0.4950 11999.5n 0.4950 12000.0n 0.4559 12599.5n 0.4559 12600.0n 0.5162 13199.5n 0.5162 13200.0n 0.5038 13799.5n 0.5038 13800.0n 0.5333 14399.5n 0.5333 14400.0n 0.4991 14999.5n 0.4991 15000.0n 0.5298 15599.5n 0.5298 15600.0n 0.4823 16199.5n 0.4823 16200.0n 0.5239 16799.5n 0.5239 16800.0n 0.4592 17399.5n 0.4592 17400.0n 0.5094 17999.5n 0.5094 18000.0n 0.4337 18599.5n 0.4337 18600.0n 0.5977 19199.5n 0.5977 19200.0n 0.5364 19799.5n 0.5364 19800.0n 0.6122 20399.5n 0.6122 20400.0n 0.4856 20999.5n 0.4856 21000.0n 0.3861 21599.5n 0.3861 21600.0n 0.6094 22199.5n 0.6094 22200.0n 0.6364 22799.5n 0.6364 22800.0n 0.4807 23399.5n 0.4807 23400.0n 0.5614 23999.5n 0.5614 24000.0n 0.5913 24599.5n 0.5913 24600.0n 0.6295 25199.5n 0.6295 25200.0n 0.4496 25799.5n 0.4496 25800.0n 0.3792 26399.5n 0.3792 26400.0n 0.4434 26999.5n 0.4434 27000.0n 0.4340 27599.5n 0.4340 27600.0n 0.4461 28199.5n 0.4461 28200.0n 0.5791 28799.5n 0.5791 28800.0n 0.4777 29399.5n 0.4777 29400.0n 0.3878 29999.5n 0.3878 30000.0n 0.3832 30599.5n 0.3832 30600.0n 0.4022 31199.5n 0.4022 31200.0n 0.4482 31799.5n 0.4482 31800.0n 0.3662 32399.5n 0.3662 32400.0n 0.3857 32999.5n 0.3857 33000.0n 0.5584 33599.5n 0.5584 33600.0n 0.5284 34199.5n 0.5284 34200.0n 0.6034 34799.5n 0.6034 34800.0n 0.3469 35399.5n 0.3469 35400.0n 0.5290 35999.5n 0.5290)
Vxn_wih_0_29 xn_wih_0_29 0 PWL(0.0n 0.5058 599.5n 0.5058 600.0n 0.4442 1199.5n 0.4442 1200.0n 0.5292 1799.5n 0.5292 1800.0n 0.4765 2399.5n 0.4765 2400.0n 0.4650 2999.5n 0.4650 3000.0n 0.4828 3599.5n 0.4828 3600.0n 0.5298 4199.5n 0.5298 4200.0n 0.5133 4799.5n 0.5133 4800.0n 0.5030 5399.5n 0.5030 5400.0n 0.5014 5999.5n 0.5014 6000.0n 0.5249 6599.5n 0.5249 6600.0n 0.5130 7199.5n 0.5130 7200.0n 0.4498 7799.5n 0.4498 7800.0n 0.4479 8399.5n 0.4479 8400.0n 0.5362 8999.5n 0.5362 9000.0n 0.5018 9599.5n 0.5018 9600.0n 0.4869 10199.5n 0.4869 10200.0n 0.4614 10799.5n 0.4614 10800.0n 0.5408 11399.5n 0.5408 11400.0n 0.5050 11999.5n 0.5050 12000.0n 0.5441 12599.5n 0.5441 12600.0n 0.4838 13199.5n 0.4838 13200.0n 0.4962 13799.5n 0.4962 13800.0n 0.4667 14399.5n 0.4667 14400.0n 0.5009 14999.5n 0.5009 15000.0n 0.4702 15599.5n 0.4702 15600.0n 0.5177 16199.5n 0.5177 16200.0n 0.4761 16799.5n 0.4761 16800.0n 0.5408 17399.5n 0.5408 17400.0n 0.4906 17999.5n 0.4906 18000.0n 0.5663 18599.5n 0.5663 18600.0n 0.4023 19199.5n 0.4023 19200.0n 0.4636 19799.5n 0.4636 19800.0n 0.3878 20399.5n 0.3878 20400.0n 0.5144 20999.5n 0.5144 21000.0n 0.6139 21599.5n 0.6139 21600.0n 0.3906 22199.5n 0.3906 22200.0n 0.3636 22799.5n 0.3636 22800.0n 0.5193 23399.5n 0.5193 23400.0n 0.4386 23999.5n 0.4386 24000.0n 0.4087 24599.5n 0.4087 24600.0n 0.3705 25199.5n 0.3705 25200.0n 0.5504 25799.5n 0.5504 25800.0n 0.6208 26399.5n 0.6208 26400.0n 0.5566 26999.5n 0.5566 27000.0n 0.5660 27599.5n 0.5660 27600.0n 0.5539 28199.5n 0.5539 28200.0n 0.4209 28799.5n 0.4209 28800.0n 0.5223 29399.5n 0.5223 29400.0n 0.6122 29999.5n 0.6122 30000.0n 0.6168 30599.5n 0.6168 30600.0n 0.5978 31199.5n 0.5978 31200.0n 0.5518 31799.5n 0.5518 31800.0n 0.6338 32399.5n 0.6338 32400.0n 0.6143 32999.5n 0.6143 33000.0n 0.4416 33599.5n 0.4416 33600.0n 0.4716 34199.5n 0.4716 34200.0n 0.3966 34799.5n 0.3966 34800.0n 0.6531 35399.5n 0.6531 35400.0n 0.4710 35999.5n 0.4710)
Vyp_wih_0_29 yp_wih_0_29 0 PWL(0.0n 0.4356 599.5n 0.4356 600.0n 0.4213 1199.5n 0.4213 1200.0n 0.3546 1799.5n 0.3546 1800.0n 0.3378 2399.5n 0.3378 2400.0n 0.3450 2999.5n 0.3450 3000.0n 0.3945 3599.5n 0.3945 3600.0n 0.3700 4199.5n 0.3700 4200.0n 0.4368 4799.5n 0.4368 4800.0n 0.3863 5399.5n 0.3863 5400.0n 0.3856 5999.5n 0.3856 6000.0n 0.3493 6599.5n 0.3493 6600.0n 0.3963 7199.5n 0.3963 7200.0n 0.3980 7799.5n 0.3980 7800.0n 0.3918 8399.5n 0.3918 8400.0n 0.4178 8999.5n 0.4178 9000.0n 0.3864 9599.5n 0.3864 9600.0n 0.3734 10199.5n 0.3734 10200.0n 0.3727 10799.5n 0.3727 10800.0n 0.3551 11399.5n 0.3551 11400.0n 0.3921 11999.5n 0.3921 12000.0n 0.4247 12599.5n 0.4247 12600.0n 0.3709 13199.5n 0.3709 13200.0n 0.4396 13799.5n 0.4396 13800.0n 0.4204 14399.5n 0.4204 14400.0n 0.3957 14999.5n 0.3957 15000.0n 0.3547 15599.5n 0.3547 15600.0n 0.4193 16199.5n 0.4193 16200.0n 0.4419 16799.5n 0.4419 16800.0n 0.4129 17399.5n 0.4129 17400.0n 0.4339 17999.5n 0.4339 18000.0n 0.3260 18599.5n 0.3260 18600.0n 0.4352 19199.5n 0.4352 19200.0n 0.3272 19799.5n 0.3272 19800.0n 0.3374 20399.5n 0.3374 20400.0n 0.3244 20999.5n 0.3244 21000.0n 0.3394 21599.5n 0.3394 21600.0n 0.3534 22199.5n 0.3534 22200.0n 0.4269 22799.5n 0.4269 22800.0n 0.3197 23399.5n 0.3197 23400.0n 0.5836 23999.5n 0.5836 24000.0n 0.3274 24599.5n 0.3274 24600.0n 0.4560 25199.5n 0.4560 25200.0n 0.3241 25799.5n 0.3241 25800.0n 0.3180 26399.5n 0.3180 26400.0n 0.3187 26999.5n 0.3187 27000.0n 0.3228 27599.5n 0.3228 27600.0n 0.3189 28199.5n 0.3189 28200.0n 0.5723 28799.5n 0.5723 28800.0n 0.3221 29399.5n 0.3221 29400.0n 0.3448 29999.5n 0.3448 30000.0n 0.3632 30599.5n 0.3632 30600.0n 0.5258 31199.5n 0.5258 31200.0n 0.5376 31799.5n 0.5376 31800.0n 0.3202 32399.5n 0.3202 32400.0n 0.3174 32999.5n 0.3174 33000.0n 0.3258 33599.5n 0.3258 33600.0n 0.3222 34199.5n 0.3222 34200.0n 0.4845 34799.5n 0.4845 34800.0n 0.4285 35399.5n 0.4285 35400.0n 0.3253 35999.5n 0.3253)
Vyn_wih_0_29 yn_wih_0_29 0 PWL(0.0n 0.5644 599.5n 0.5644 600.0n 0.5787 1199.5n 0.5787 1200.0n 0.6454 1799.5n 0.6454 1800.0n 0.6622 2399.5n 0.6622 2400.0n 0.6550 2999.5n 0.6550 3000.0n 0.6055 3599.5n 0.6055 3600.0n 0.6300 4199.5n 0.6300 4200.0n 0.5632 4799.5n 0.5632 4800.0n 0.6137 5399.5n 0.6137 5400.0n 0.6144 5999.5n 0.6144 6000.0n 0.6507 6599.5n 0.6507 6600.0n 0.6037 7199.5n 0.6037 7200.0n 0.6020 7799.5n 0.6020 7800.0n 0.6082 8399.5n 0.6082 8400.0n 0.5822 8999.5n 0.5822 9000.0n 0.6136 9599.5n 0.6136 9600.0n 0.6266 10199.5n 0.6266 10200.0n 0.6273 10799.5n 0.6273 10800.0n 0.6449 11399.5n 0.6449 11400.0n 0.6079 11999.5n 0.6079 12000.0n 0.5753 12599.5n 0.5753 12600.0n 0.6291 13199.5n 0.6291 13200.0n 0.5604 13799.5n 0.5604 13800.0n 0.5796 14399.5n 0.5796 14400.0n 0.6043 14999.5n 0.6043 15000.0n 0.6453 15599.5n 0.6453 15600.0n 0.5807 16199.5n 0.5807 16200.0n 0.5581 16799.5n 0.5581 16800.0n 0.5871 17399.5n 0.5871 17400.0n 0.5661 17999.5n 0.5661 18000.0n 0.6740 18599.5n 0.6740 18600.0n 0.5648 19199.5n 0.5648 19200.0n 0.6728 19799.5n 0.6728 19800.0n 0.6626 20399.5n 0.6626 20400.0n 0.6756 20999.5n 0.6756 21000.0n 0.6606 21599.5n 0.6606 21600.0n 0.6466 22199.5n 0.6466 22200.0n 0.5731 22799.5n 0.5731 22800.0n 0.6803 23399.5n 0.6803 23400.0n 0.4164 23999.5n 0.4164 24000.0n 0.6726 24599.5n 0.6726 24600.0n 0.5440 25199.5n 0.5440 25200.0n 0.6759 25799.5n 0.6759 25800.0n 0.6820 26399.5n 0.6820 26400.0n 0.6813 26999.5n 0.6813 27000.0n 0.6772 27599.5n 0.6772 27600.0n 0.6811 28199.5n 0.6811 28200.0n 0.4277 28799.5n 0.4277 28800.0n 0.6779 29399.5n 0.6779 29400.0n 0.6552 29999.5n 0.6552 30000.0n 0.6368 30599.5n 0.6368 30600.0n 0.4742 31199.5n 0.4742 31200.0n 0.4624 31799.5n 0.4624 31800.0n 0.6798 32399.5n 0.6798 32400.0n 0.6826 32999.5n 0.6826 33000.0n 0.6742 33599.5n 0.6742 33600.0n 0.6778 34199.5n 0.6778 34200.0n 0.5155 34799.5n 0.5155 34800.0n 0.5715 35399.5n 0.5715 35400.0n 0.6747 35999.5n 0.6747)
Cwp_wih_0_29 wp_wih_0_29 0 400p
Cwn_wih_0_29 wn_wih_0_29 0 400p
Xu_wih_0_29 xp_wih_0_29 xn_wih_0_29 yp_wih_0_29 yn_wih_0_29 wp_wih_0_29 wn_wih_0_29 vdd gbn gprod
Vxp_wih_1_29 xp_wih_1_29 0 PWL(0.0n 0.5370 599.5n 0.5370 600.0n 0.5167 1199.5n 0.5167 1200.0n 0.4793 1799.5n 0.4793 1800.0n 0.4441 2399.5n 0.4441 2400.0n 0.4555 2999.5n 0.4555 3000.0n 0.5055 3599.5n 0.5055 3600.0n 0.4939 4199.5n 0.4939 4200.0n 0.5385 4799.5n 0.5385 4800.0n 0.5024 5399.5n 0.5024 5400.0n 0.5015 5999.5n 0.5015 6000.0n 0.4700 6599.5n 0.4700 6600.0n 0.5120 7199.5n 0.5120 7200.0n 0.5006 7799.5n 0.5006 7800.0n 0.4950 8399.5n 0.4950 8400.0n 0.5309 8999.5n 0.5309 9000.0n 0.5023 9599.5n 0.5023 9600.0n 0.4893 10199.5n 0.4893 10200.0n 0.4837 10799.5n 0.4837 10800.0n 0.4823 11399.5n 0.4823 11400.0n 0.5074 11999.5n 0.5074 12000.0n 0.5364 12599.5n 0.5364 12600.0n 0.4868 13199.5n 0.4868 13200.0n 0.5380 13799.5n 0.5380 13800.0n 0.5220 14399.5n 0.5220 14400.0n 0.5095 14999.5n 0.5095 15000.0n 0.4705 15599.5n 0.4705 15600.0n 0.5289 16199.5n 0.5289 16200.0n 0.5368 16799.5n 0.5368 16800.0n 0.5287 17399.5n 0.5287 17400.0n 0.5342 17999.5n 0.5342 18000.0n 0.4253 18599.5n 0.4253 18600.0n 0.5119 19199.5n 0.5119 19200.0n 0.4104 19799.5n 0.4104 19800.0n 0.4314 20399.5n 0.4314 20400.0n 0.4005 20999.5n 0.4005 21000.0n 0.4696 21599.5n 0.4696 21600.0n 0.4531 22199.5n 0.4531 22200.0n 0.5039 22799.5n 0.5039 22800.0n 0.3608 23399.5n 0.3608 23400.0n 0.6273 23999.5n 0.6273 24000.0n 0.3928 24599.5n 0.3928 24600.0n 0.5253 25199.5n 0.5253 25200.0n 0.4107 25799.5n 0.4107 25800.0n 0.3947 26399.5n 0.3947 26400.0n 0.3716 26999.5n 0.3716 27000.0n 0.4111 27599.5n 0.4111 27600.0n 0.3715 28199.5n 0.3715 28200.0n 0.5939 28799.5n 0.5939 28800.0n 0.3849 29399.5n 0.3849 29400.0n 0.4835 29999.5n 0.4835 30000.0n 0.5119 30599.5n 0.5119 30600.0n 0.6226 31199.5n 0.6226 31200.0n 0.6064 31799.5n 0.6064 31800.0n 0.4115 32399.5n 0.4115 32400.0n 0.3900 32999.5n 0.3900 33000.0n 0.3958 33599.5n 0.3958 33600.0n 0.3747 34199.5n 0.3747 34200.0n 0.5423 34799.5n 0.5423 34800.0n 0.5509 35399.5n 0.5509 35400.0n 0.3990 35999.5n 0.3990)
Vxn_wih_1_29 xn_wih_1_29 0 PWL(0.0n 0.4630 599.5n 0.4630 600.0n 0.4833 1199.5n 0.4833 1200.0n 0.5207 1799.5n 0.5207 1800.0n 0.5559 2399.5n 0.5559 2400.0n 0.5445 2999.5n 0.5445 3000.0n 0.4945 3599.5n 0.4945 3600.0n 0.5061 4199.5n 0.5061 4200.0n 0.4615 4799.5n 0.4615 4800.0n 0.4976 5399.5n 0.4976 5400.0n 0.4985 5999.5n 0.4985 6000.0n 0.5300 6599.5n 0.5300 6600.0n 0.4880 7199.5n 0.4880 7200.0n 0.4994 7799.5n 0.4994 7800.0n 0.5050 8399.5n 0.5050 8400.0n 0.4691 8999.5n 0.4691 9000.0n 0.4977 9599.5n 0.4977 9600.0n 0.5107 10199.5n 0.5107 10200.0n 0.5163 10799.5n 0.5163 10800.0n 0.5177 11399.5n 0.5177 11400.0n 0.4926 11999.5n 0.4926 12000.0n 0.4636 12599.5n 0.4636 12600.0n 0.5132 13199.5n 0.5132 13200.0n 0.4620 13799.5n 0.4620 13800.0n 0.4780 14399.5n 0.4780 14400.0n 0.4905 14999.5n 0.4905 15000.0n 0.5295 15599.5n 0.5295 15600.0n 0.4711 16199.5n 0.4711 16200.0n 0.4632 16799.5n 0.4632 16800.0n 0.4713 17399.5n 0.4713 17400.0n 0.4658 17999.5n 0.4658 18000.0n 0.5747 18599.5n 0.5747 18600.0n 0.4881 19199.5n 0.4881 19200.0n 0.5896 19799.5n 0.5896 19800.0n 0.5686 20399.5n 0.5686 20400.0n 0.5995 20999.5n 0.5995 21000.0n 0.5304 21599.5n 0.5304 21600.0n 0.5469 22199.5n 0.5469 22200.0n 0.4961 22799.5n 0.4961 22800.0n 0.6392 23399.5n 0.6392 23400.0n 0.3727 23999.5n 0.3727 24000.0n 0.6072 24599.5n 0.6072 24600.0n 0.4747 25199.5n 0.4747 25200.0n 0.5893 25799.5n 0.5893 25800.0n 0.6053 26399.5n 0.6053 26400.0n 0.6284 26999.5n 0.6284 27000.0n 0.5889 27599.5n 0.5889 27600.0n 0.6285 28199.5n 0.6285 28200.0n 0.4061 28799.5n 0.4061 28800.0n 0.6151 29399.5n 0.6151 29400.0n 0.5165 29999.5n 0.5165 30000.0n 0.4881 30599.5n 0.4881 30600.0n 0.3774 31199.5n 0.3774 31200.0n 0.3936 31799.5n 0.3936 31800.0n 0.5885 32399.5n 0.5885 32400.0n 0.6100 32999.5n 0.6100 33000.0n 0.6042 33599.5n 0.6042 33600.0n 0.6253 34199.5n 0.6253 34200.0n 0.4577 34799.5n 0.4577 34800.0n 0.4491 35399.5n 0.4491 35400.0n 0.6010 35999.5n 0.6010)
Vyp_wih_1_29 yp_wih_1_29 0 PWL(0.0n 0.4356 599.5n 0.4356 600.0n 0.4213 1199.5n 0.4213 1200.0n 0.3546 1799.5n 0.3546 1800.0n 0.3378 2399.5n 0.3378 2400.0n 0.3450 2999.5n 0.3450 3000.0n 0.3945 3599.5n 0.3945 3600.0n 0.3700 4199.5n 0.3700 4200.0n 0.4368 4799.5n 0.4368 4800.0n 0.3863 5399.5n 0.3863 5400.0n 0.3856 5999.5n 0.3856 6000.0n 0.3493 6599.5n 0.3493 6600.0n 0.3963 7199.5n 0.3963 7200.0n 0.3980 7799.5n 0.3980 7800.0n 0.3918 8399.5n 0.3918 8400.0n 0.4178 8999.5n 0.4178 9000.0n 0.3864 9599.5n 0.3864 9600.0n 0.3734 10199.5n 0.3734 10200.0n 0.3727 10799.5n 0.3727 10800.0n 0.3551 11399.5n 0.3551 11400.0n 0.3921 11999.5n 0.3921 12000.0n 0.4247 12599.5n 0.4247 12600.0n 0.3709 13199.5n 0.3709 13200.0n 0.4396 13799.5n 0.4396 13800.0n 0.4204 14399.5n 0.4204 14400.0n 0.3957 14999.5n 0.3957 15000.0n 0.3547 15599.5n 0.3547 15600.0n 0.4193 16199.5n 0.4193 16200.0n 0.4419 16799.5n 0.4419 16800.0n 0.4129 17399.5n 0.4129 17400.0n 0.4339 17999.5n 0.4339 18000.0n 0.3260 18599.5n 0.3260 18600.0n 0.4352 19199.5n 0.4352 19200.0n 0.3272 19799.5n 0.3272 19800.0n 0.3374 20399.5n 0.3374 20400.0n 0.3244 20999.5n 0.3244 21000.0n 0.3394 21599.5n 0.3394 21600.0n 0.3534 22199.5n 0.3534 22200.0n 0.4269 22799.5n 0.4269 22800.0n 0.3197 23399.5n 0.3197 23400.0n 0.5836 23999.5n 0.5836 24000.0n 0.3274 24599.5n 0.3274 24600.0n 0.4560 25199.5n 0.4560 25200.0n 0.3241 25799.5n 0.3241 25800.0n 0.3180 26399.5n 0.3180 26400.0n 0.3187 26999.5n 0.3187 27000.0n 0.3228 27599.5n 0.3228 27600.0n 0.3189 28199.5n 0.3189 28200.0n 0.5723 28799.5n 0.5723 28800.0n 0.3221 29399.5n 0.3221 29400.0n 0.3448 29999.5n 0.3448 30000.0n 0.3632 30599.5n 0.3632 30600.0n 0.5258 31199.5n 0.5258 31200.0n 0.5376 31799.5n 0.5376 31800.0n 0.3202 32399.5n 0.3202 32400.0n 0.3174 32999.5n 0.3174 33000.0n 0.3258 33599.5n 0.3258 33600.0n 0.3222 34199.5n 0.3222 34200.0n 0.4845 34799.5n 0.4845 34800.0n 0.4285 35399.5n 0.4285 35400.0n 0.3253 35999.5n 0.3253)
Vyn_wih_1_29 yn_wih_1_29 0 PWL(0.0n 0.5644 599.5n 0.5644 600.0n 0.5787 1199.5n 0.5787 1200.0n 0.6454 1799.5n 0.6454 1800.0n 0.6622 2399.5n 0.6622 2400.0n 0.6550 2999.5n 0.6550 3000.0n 0.6055 3599.5n 0.6055 3600.0n 0.6300 4199.5n 0.6300 4200.0n 0.5632 4799.5n 0.5632 4800.0n 0.6137 5399.5n 0.6137 5400.0n 0.6144 5999.5n 0.6144 6000.0n 0.6507 6599.5n 0.6507 6600.0n 0.6037 7199.5n 0.6037 7200.0n 0.6020 7799.5n 0.6020 7800.0n 0.6082 8399.5n 0.6082 8400.0n 0.5822 8999.5n 0.5822 9000.0n 0.6136 9599.5n 0.6136 9600.0n 0.6266 10199.5n 0.6266 10200.0n 0.6273 10799.5n 0.6273 10800.0n 0.6449 11399.5n 0.6449 11400.0n 0.6079 11999.5n 0.6079 12000.0n 0.5753 12599.5n 0.5753 12600.0n 0.6291 13199.5n 0.6291 13200.0n 0.5604 13799.5n 0.5604 13800.0n 0.5796 14399.5n 0.5796 14400.0n 0.6043 14999.5n 0.6043 15000.0n 0.6453 15599.5n 0.6453 15600.0n 0.5807 16199.5n 0.5807 16200.0n 0.5581 16799.5n 0.5581 16800.0n 0.5871 17399.5n 0.5871 17400.0n 0.5661 17999.5n 0.5661 18000.0n 0.6740 18599.5n 0.6740 18600.0n 0.5648 19199.5n 0.5648 19200.0n 0.6728 19799.5n 0.6728 19800.0n 0.6626 20399.5n 0.6626 20400.0n 0.6756 20999.5n 0.6756 21000.0n 0.6606 21599.5n 0.6606 21600.0n 0.6466 22199.5n 0.6466 22200.0n 0.5731 22799.5n 0.5731 22800.0n 0.6803 23399.5n 0.6803 23400.0n 0.4164 23999.5n 0.4164 24000.0n 0.6726 24599.5n 0.6726 24600.0n 0.5440 25199.5n 0.5440 25200.0n 0.6759 25799.5n 0.6759 25800.0n 0.6820 26399.5n 0.6820 26400.0n 0.6813 26999.5n 0.6813 27000.0n 0.6772 27599.5n 0.6772 27600.0n 0.6811 28199.5n 0.6811 28200.0n 0.4277 28799.5n 0.4277 28800.0n 0.6779 29399.5n 0.6779 29400.0n 0.6552 29999.5n 0.6552 30000.0n 0.6368 30599.5n 0.6368 30600.0n 0.4742 31199.5n 0.4742 31200.0n 0.4624 31799.5n 0.4624 31800.0n 0.6798 32399.5n 0.6798 32400.0n 0.6826 32999.5n 0.6826 33000.0n 0.6742 33599.5n 0.6742 33600.0n 0.6778 34199.5n 0.6778 34200.0n 0.5155 34799.5n 0.5155 34800.0n 0.5715 35399.5n 0.5715 35400.0n 0.6747 35999.5n 0.6747)
Cwp_wih_1_29 wp_wih_1_29 0 400p
Cwn_wih_1_29 wn_wih_1_29 0 400p
Xu_wih_1_29 xp_wih_1_29 xn_wih_1_29 yp_wih_1_29 yn_wih_1_29 wp_wih_1_29 wn_wih_1_29 vdd gbn gprod
Vxp_who_29_0 xp_who_29_0 0 PWL(0.0n 0.4356 599.5n 0.4356 600.0n 0.4213 1199.5n 0.4213 1200.0n 0.3546 1799.5n 0.3546 1800.0n 0.3378 2399.5n 0.3378 2400.0n 0.3450 2999.5n 0.3450 3000.0n 0.3945 3599.5n 0.3945 3600.0n 0.3700 4199.5n 0.3700 4200.0n 0.4368 4799.5n 0.4368 4800.0n 0.3863 5399.5n 0.3863 5400.0n 0.3856 5999.5n 0.3856 6000.0n 0.3493 6599.5n 0.3493 6600.0n 0.3963 7199.5n 0.3963 7200.0n 0.3980 7799.5n 0.3980 7800.0n 0.3918 8399.5n 0.3918 8400.0n 0.4178 8999.5n 0.4178 9000.0n 0.3864 9599.5n 0.3864 9600.0n 0.3734 10199.5n 0.3734 10200.0n 0.3727 10799.5n 0.3727 10800.0n 0.3551 11399.5n 0.3551 11400.0n 0.3921 11999.5n 0.3921 12000.0n 0.4247 12599.5n 0.4247 12600.0n 0.3709 13199.5n 0.3709 13200.0n 0.4396 13799.5n 0.4396 13800.0n 0.4204 14399.5n 0.4204 14400.0n 0.3957 14999.5n 0.3957 15000.0n 0.3547 15599.5n 0.3547 15600.0n 0.4193 16199.5n 0.4193 16200.0n 0.4419 16799.5n 0.4419 16800.0n 0.4129 17399.5n 0.4129 17400.0n 0.4339 17999.5n 0.4339 18000.0n 0.3260 18599.5n 0.3260 18600.0n 0.4352 19199.5n 0.4352 19200.0n 0.3272 19799.5n 0.3272 19800.0n 0.3374 20399.5n 0.3374 20400.0n 0.3244 20999.5n 0.3244 21000.0n 0.3394 21599.5n 0.3394 21600.0n 0.3534 22199.5n 0.3534 22200.0n 0.4269 22799.5n 0.4269 22800.0n 0.3197 23399.5n 0.3197 23400.0n 0.5836 23999.5n 0.5836 24000.0n 0.3274 24599.5n 0.3274 24600.0n 0.4560 25199.5n 0.4560 25200.0n 0.3241 25799.5n 0.3241 25800.0n 0.3180 26399.5n 0.3180 26400.0n 0.3187 26999.5n 0.3187 27000.0n 0.3228 27599.5n 0.3228 27600.0n 0.3189 28199.5n 0.3189 28200.0n 0.5723 28799.5n 0.5723 28800.0n 0.3221 29399.5n 0.3221 29400.0n 0.3448 29999.5n 0.3448 30000.0n 0.3632 30599.5n 0.3632 30600.0n 0.5258 31199.5n 0.5258 31200.0n 0.5376 31799.5n 0.5376 31800.0n 0.3202 32399.5n 0.3202 32400.0n 0.3174 32999.5n 0.3174 33000.0n 0.3258 33599.5n 0.3258 33600.0n 0.3222 34199.5n 0.3222 34200.0n 0.4845 34799.5n 0.4845 34800.0n 0.4285 35399.5n 0.4285 35400.0n 0.3253 35999.5n 0.3253)
Vxn_who_29_0 xn_who_29_0 0 PWL(0.0n 0.5644 599.5n 0.5644 600.0n 0.5787 1199.5n 0.5787 1200.0n 0.6454 1799.5n 0.6454 1800.0n 0.6622 2399.5n 0.6622 2400.0n 0.6550 2999.5n 0.6550 3000.0n 0.6055 3599.5n 0.6055 3600.0n 0.6300 4199.5n 0.6300 4200.0n 0.5632 4799.5n 0.5632 4800.0n 0.6137 5399.5n 0.6137 5400.0n 0.6144 5999.5n 0.6144 6000.0n 0.6507 6599.5n 0.6507 6600.0n 0.6037 7199.5n 0.6037 7200.0n 0.6020 7799.5n 0.6020 7800.0n 0.6082 8399.5n 0.6082 8400.0n 0.5822 8999.5n 0.5822 9000.0n 0.6136 9599.5n 0.6136 9600.0n 0.6266 10199.5n 0.6266 10200.0n 0.6273 10799.5n 0.6273 10800.0n 0.6449 11399.5n 0.6449 11400.0n 0.6079 11999.5n 0.6079 12000.0n 0.5753 12599.5n 0.5753 12600.0n 0.6291 13199.5n 0.6291 13200.0n 0.5604 13799.5n 0.5604 13800.0n 0.5796 14399.5n 0.5796 14400.0n 0.6043 14999.5n 0.6043 15000.0n 0.6453 15599.5n 0.6453 15600.0n 0.5807 16199.5n 0.5807 16200.0n 0.5581 16799.5n 0.5581 16800.0n 0.5871 17399.5n 0.5871 17400.0n 0.5661 17999.5n 0.5661 18000.0n 0.6740 18599.5n 0.6740 18600.0n 0.5648 19199.5n 0.5648 19200.0n 0.6728 19799.5n 0.6728 19800.0n 0.6626 20399.5n 0.6626 20400.0n 0.6756 20999.5n 0.6756 21000.0n 0.6606 21599.5n 0.6606 21600.0n 0.6466 22199.5n 0.6466 22200.0n 0.5731 22799.5n 0.5731 22800.0n 0.6803 23399.5n 0.6803 23400.0n 0.4164 23999.5n 0.4164 24000.0n 0.6726 24599.5n 0.6726 24600.0n 0.5440 25199.5n 0.5440 25200.0n 0.6759 25799.5n 0.6759 25800.0n 0.6820 26399.5n 0.6820 26400.0n 0.6813 26999.5n 0.6813 27000.0n 0.6772 27599.5n 0.6772 27600.0n 0.6811 28199.5n 0.6811 28200.0n 0.4277 28799.5n 0.4277 28800.0n 0.6779 29399.5n 0.6779 29400.0n 0.6552 29999.5n 0.6552 30000.0n 0.6368 30599.5n 0.6368 30600.0n 0.4742 31199.5n 0.4742 31200.0n 0.4624 31799.5n 0.4624 31800.0n 0.6798 32399.5n 0.6798 32400.0n 0.6826 32999.5n 0.6826 33000.0n 0.6742 33599.5n 0.6742 33600.0n 0.6778 34199.5n 0.6778 34200.0n 0.5155 34799.5n 0.5155 34800.0n 0.5715 35399.5n 0.5715 35400.0n 0.6747 35999.5n 0.6747)
Vyp_who_29_0 yp_who_29_0 0 PWL(0.0n 0.5031 599.5n 0.5031 600.0n 0.5023 1199.5n 0.5023 1200.0n 0.5052 1799.5n 0.5052 1800.0n 0.5048 2399.5n 0.5048 2400.0n 0.5043 2999.5n 0.5043 3000.0n 0.5034 3599.5n 0.5034 3600.0n 0.5048 4199.5n 0.5048 4200.0n 0.5031 4799.5n 0.5031 4800.0n 0.5040 5399.5n 0.5040 5400.0n 0.5040 5999.5n 0.5040 6000.0n 0.5054 6599.5n 0.5054 6600.0n 0.5040 7199.5n 0.5040 7200.0n 0.5027 7799.5n 0.5027 7800.0n 0.5027 8399.5n 0.5027 8400.0n 0.5038 8999.5n 0.5038 9000.0n 0.5040 9599.5n 0.5040 9600.0n 0.5039 10199.5n 0.5039 10200.0n 0.5033 10799.5n 0.5033 10800.0n 0.5056 11399.5n 0.5056 11400.0n 0.5040 11999.5n 0.5040 12000.0n 0.5036 12599.5n 0.5036 12600.0n 0.5039 13199.5n 0.5039 13200.0n 0.5029 13799.5n 0.5029 13800.0n 0.5025 14399.5n 0.5025 14400.0n 0.5038 14999.5n 0.5038 15000.0n 0.5041 15599.5n 0.5041 15600.0n 0.5036 16199.5n 0.5036 16200.0n 0.5025 16799.5n 0.5025 16800.0n 0.5040 17399.5n 0.5040 17400.0n 0.5029 17999.5n 0.5029 18000.0n 0.5057 18599.5n 0.5057 18600.0n 0.5010 19199.5n 0.5010 19200.0n 0.5041 19799.5n 0.5041 19800.0n 0.5021 20399.5n 0.5021 20400.0n 0.5044 20999.5n 0.5044 21000.0n 0.5056 21599.5n 0.5056 21600.0n 0.5016 22199.5n 0.5016 22200.0n 0.5006 22799.5n 0.5006 22800.0n 0.5041 23399.5n 0.5041 23400.0n 0.5027 23999.5n 0.5027 24000.0n 0.5029 24599.5n 0.5029 24600.0n 0.5006 25199.5n 0.5006 25200.0n 0.5047 25799.5n 0.5047 25800.0n 0.5046 26399.5n 0.5046 26400.0n 0.5039 26999.5n 0.5039 27000.0n 0.5049 27599.5n 0.5049 27600.0n 0.5039 28199.5n 0.5039 28200.0n 0.5017 28799.5n 0.5017 28800.0n 0.5042 29399.5n 0.5042 29400.0n 0.5056 29999.5n 0.5056 30000.0n 0.5051 30599.5n 0.5051 30600.0n 0.5039 31199.5n 0.5039 31200.0n 0.5033 31799.5n 0.5033 31800.0n 0.5049 32399.5n 0.5049 32400.0n 0.5045 32999.5n 0.5045 33000.0n 0.5036 33599.5n 0.5036 33600.0n 0.5042 34199.5n 0.5042 34200.0n 0.5012 34799.5n 0.5012 34800.0n 0.5036 35399.5n 0.5036 35400.0n 0.5042 35999.5n 0.5042)
Vyn_who_29_0 yn_who_29_0 0 PWL(0.0n 0.4969 599.5n 0.4969 600.0n 0.4977 1199.5n 0.4977 1200.0n 0.4948 1799.5n 0.4948 1800.0n 0.4952 2399.5n 0.4952 2400.0n 0.4957 2999.5n 0.4957 3000.0n 0.4966 3599.5n 0.4966 3600.0n 0.4952 4199.5n 0.4952 4200.0n 0.4969 4799.5n 0.4969 4800.0n 0.4960 5399.5n 0.4960 5400.0n 0.4960 5999.5n 0.4960 6000.0n 0.4946 6599.5n 0.4946 6600.0n 0.4960 7199.5n 0.4960 7200.0n 0.4973 7799.5n 0.4973 7800.0n 0.4973 8399.5n 0.4973 8400.0n 0.4962 8999.5n 0.4962 9000.0n 0.4960 9599.5n 0.4960 9600.0n 0.4961 10199.5n 0.4961 10200.0n 0.4967 10799.5n 0.4967 10800.0n 0.4944 11399.5n 0.4944 11400.0n 0.4960 11999.5n 0.4960 12000.0n 0.4964 12599.5n 0.4964 12600.0n 0.4961 13199.5n 0.4961 13200.0n 0.4971 13799.5n 0.4971 13800.0n 0.4975 14399.5n 0.4975 14400.0n 0.4962 14999.5n 0.4962 15000.0n 0.4959 15599.5n 0.4959 15600.0n 0.4964 16199.5n 0.4964 16200.0n 0.4975 16799.5n 0.4975 16800.0n 0.4960 17399.5n 0.4960 17400.0n 0.4971 17999.5n 0.4971 18000.0n 0.4943 18599.5n 0.4943 18600.0n 0.4990 19199.5n 0.4990 19200.0n 0.4959 19799.5n 0.4959 19800.0n 0.4979 20399.5n 0.4979 20400.0n 0.4956 20999.5n 0.4956 21000.0n 0.4944 21599.5n 0.4944 21600.0n 0.4984 22199.5n 0.4984 22200.0n 0.4994 22799.5n 0.4994 22800.0n 0.4959 23399.5n 0.4959 23400.0n 0.4973 23999.5n 0.4973 24000.0n 0.4971 24599.5n 0.4971 24600.0n 0.4994 25199.5n 0.4994 25200.0n 0.4953 25799.5n 0.4953 25800.0n 0.4954 26399.5n 0.4954 26400.0n 0.4961 26999.5n 0.4961 27000.0n 0.4951 27599.5n 0.4951 27600.0n 0.4961 28199.5n 0.4961 28200.0n 0.4983 28799.5n 0.4983 28800.0n 0.4958 29399.5n 0.4958 29400.0n 0.4944 29999.5n 0.4944 30000.0n 0.4949 30599.5n 0.4949 30600.0n 0.4961 31199.5n 0.4961 31200.0n 0.4967 31799.5n 0.4967 31800.0n 0.4951 32399.5n 0.4951 32400.0n 0.4955 32999.5n 0.4955 33000.0n 0.4964 33599.5n 0.4964 33600.0n 0.4958 34199.5n 0.4958 34200.0n 0.4988 34799.5n 0.4988 34800.0n 0.4964 35399.5n 0.4964 35400.0n 0.4958 35999.5n 0.4958)
Cwp_who_29_0 wp_who_29_0 0 400p
Cwn_who_29_0 wn_who_29_0 0 400p
Xu_who_29_0 xp_who_29_0 xn_who_29_0 yp_who_29_0 yn_who_29_0 wp_who_29_0 wn_who_29_0 vdd gbn gprod
Vxp_who_29_1 xp_who_29_1 0 PWL(0.0n 0.4356 599.5n 0.4356 600.0n 0.4213 1199.5n 0.4213 1200.0n 0.3546 1799.5n 0.3546 1800.0n 0.3378 2399.5n 0.3378 2400.0n 0.3450 2999.5n 0.3450 3000.0n 0.3945 3599.5n 0.3945 3600.0n 0.3700 4199.5n 0.3700 4200.0n 0.4368 4799.5n 0.4368 4800.0n 0.3863 5399.5n 0.3863 5400.0n 0.3856 5999.5n 0.3856 6000.0n 0.3493 6599.5n 0.3493 6600.0n 0.3963 7199.5n 0.3963 7200.0n 0.3980 7799.5n 0.3980 7800.0n 0.3918 8399.5n 0.3918 8400.0n 0.4178 8999.5n 0.4178 9000.0n 0.3864 9599.5n 0.3864 9600.0n 0.3734 10199.5n 0.3734 10200.0n 0.3727 10799.5n 0.3727 10800.0n 0.3551 11399.5n 0.3551 11400.0n 0.3921 11999.5n 0.3921 12000.0n 0.4247 12599.5n 0.4247 12600.0n 0.3709 13199.5n 0.3709 13200.0n 0.4396 13799.5n 0.4396 13800.0n 0.4204 14399.5n 0.4204 14400.0n 0.3957 14999.5n 0.3957 15000.0n 0.3547 15599.5n 0.3547 15600.0n 0.4193 16199.5n 0.4193 16200.0n 0.4419 16799.5n 0.4419 16800.0n 0.4129 17399.5n 0.4129 17400.0n 0.4339 17999.5n 0.4339 18000.0n 0.3260 18599.5n 0.3260 18600.0n 0.4352 19199.5n 0.4352 19200.0n 0.3272 19799.5n 0.3272 19800.0n 0.3374 20399.5n 0.3374 20400.0n 0.3244 20999.5n 0.3244 21000.0n 0.3394 21599.5n 0.3394 21600.0n 0.3534 22199.5n 0.3534 22200.0n 0.4269 22799.5n 0.4269 22800.0n 0.3197 23399.5n 0.3197 23400.0n 0.5836 23999.5n 0.5836 24000.0n 0.3274 24599.5n 0.3274 24600.0n 0.4560 25199.5n 0.4560 25200.0n 0.3241 25799.5n 0.3241 25800.0n 0.3180 26399.5n 0.3180 26400.0n 0.3187 26999.5n 0.3187 27000.0n 0.3228 27599.5n 0.3228 27600.0n 0.3189 28199.5n 0.3189 28200.0n 0.5723 28799.5n 0.5723 28800.0n 0.3221 29399.5n 0.3221 29400.0n 0.3448 29999.5n 0.3448 30000.0n 0.3632 30599.5n 0.3632 30600.0n 0.5258 31199.5n 0.5258 31200.0n 0.5376 31799.5n 0.5376 31800.0n 0.3202 32399.5n 0.3202 32400.0n 0.3174 32999.5n 0.3174 33000.0n 0.3258 33599.5n 0.3258 33600.0n 0.3222 34199.5n 0.3222 34200.0n 0.4845 34799.5n 0.4845 34800.0n 0.4285 35399.5n 0.4285 35400.0n 0.3253 35999.5n 0.3253)
Vxn_who_29_1 xn_who_29_1 0 PWL(0.0n 0.5644 599.5n 0.5644 600.0n 0.5787 1199.5n 0.5787 1200.0n 0.6454 1799.5n 0.6454 1800.0n 0.6622 2399.5n 0.6622 2400.0n 0.6550 2999.5n 0.6550 3000.0n 0.6055 3599.5n 0.6055 3600.0n 0.6300 4199.5n 0.6300 4200.0n 0.5632 4799.5n 0.5632 4800.0n 0.6137 5399.5n 0.6137 5400.0n 0.6144 5999.5n 0.6144 6000.0n 0.6507 6599.5n 0.6507 6600.0n 0.6037 7199.5n 0.6037 7200.0n 0.6020 7799.5n 0.6020 7800.0n 0.6082 8399.5n 0.6082 8400.0n 0.5822 8999.5n 0.5822 9000.0n 0.6136 9599.5n 0.6136 9600.0n 0.6266 10199.5n 0.6266 10200.0n 0.6273 10799.5n 0.6273 10800.0n 0.6449 11399.5n 0.6449 11400.0n 0.6079 11999.5n 0.6079 12000.0n 0.5753 12599.5n 0.5753 12600.0n 0.6291 13199.5n 0.6291 13200.0n 0.5604 13799.5n 0.5604 13800.0n 0.5796 14399.5n 0.5796 14400.0n 0.6043 14999.5n 0.6043 15000.0n 0.6453 15599.5n 0.6453 15600.0n 0.5807 16199.5n 0.5807 16200.0n 0.5581 16799.5n 0.5581 16800.0n 0.5871 17399.5n 0.5871 17400.0n 0.5661 17999.5n 0.5661 18000.0n 0.6740 18599.5n 0.6740 18600.0n 0.5648 19199.5n 0.5648 19200.0n 0.6728 19799.5n 0.6728 19800.0n 0.6626 20399.5n 0.6626 20400.0n 0.6756 20999.5n 0.6756 21000.0n 0.6606 21599.5n 0.6606 21600.0n 0.6466 22199.5n 0.6466 22200.0n 0.5731 22799.5n 0.5731 22800.0n 0.6803 23399.5n 0.6803 23400.0n 0.4164 23999.5n 0.4164 24000.0n 0.6726 24599.5n 0.6726 24600.0n 0.5440 25199.5n 0.5440 25200.0n 0.6759 25799.5n 0.6759 25800.0n 0.6820 26399.5n 0.6820 26400.0n 0.6813 26999.5n 0.6813 27000.0n 0.6772 27599.5n 0.6772 27600.0n 0.6811 28199.5n 0.6811 28200.0n 0.4277 28799.5n 0.4277 28800.0n 0.6779 29399.5n 0.6779 29400.0n 0.6552 29999.5n 0.6552 30000.0n 0.6368 30599.5n 0.6368 30600.0n 0.4742 31199.5n 0.4742 31200.0n 0.4624 31799.5n 0.4624 31800.0n 0.6798 32399.5n 0.6798 32400.0n 0.6826 32999.5n 0.6826 33000.0n 0.6742 33599.5n 0.6742 33600.0n 0.6778 34199.5n 0.6778 34200.0n 0.5155 34799.5n 0.5155 34800.0n 0.5715 35399.5n 0.5715 35400.0n 0.6747 35999.5n 0.6747)
Vyp_who_29_1 yp_who_29_1 0 PWL(0.0n 0.5071 599.5n 0.5071 600.0n 0.5053 1199.5n 0.5053 1200.0n 0.5052 1799.5n 0.5052 1800.0n 0.5027 2399.5n 0.5027 2400.0n 0.5034 2999.5n 0.5034 3000.0n 0.5055 3599.5n 0.5055 3600.0n 0.5056 4199.5n 0.5056 4200.0n 0.5071 4799.5n 0.5071 4800.0n 0.5056 5399.5n 0.5056 5400.0n 0.5056 5999.5n 0.5056 6000.0n 0.5048 6599.5n 0.5048 6600.0n 0.5060 7199.5n 0.5060 7200.0n 0.5048 7799.5n 0.5048 7800.0n 0.5046 8399.5n 0.5046 8400.0n 0.5066 8999.5n 0.5066 9000.0n 0.5056 9599.5n 0.5056 9600.0n 0.5051 10199.5n 0.5051 10200.0n 0.5046 10799.5n 0.5046 10800.0n 0.5056 11399.5n 0.5056 11400.0n 0.5058 11999.5n 0.5058 12000.0n 0.5068 12599.5n 0.5068 12600.0n 0.5050 13199.5n 0.5050 13200.0n 0.5071 13799.5n 0.5071 13800.0n 0.5059 14399.5n 0.5059 14400.0n 0.5058 14999.5n 0.5058 15000.0n 0.5043 15599.5n 0.5043 15600.0n 0.5067 16199.5n 0.5067 16200.0n 0.5068 16799.5n 0.5068 16800.0n 0.5066 17399.5n 0.5066 17400.0n 0.5069 17999.5n 0.5069 18000.0n 0.5061 18599.5n 0.5061 18600.0n 0.5034 19199.5n 0.5034 19200.0n 0.5010 19799.5n 0.5010 19800.0n 0.4989 20399.5n 0.4989 20400.0n 0.5022 20999.5n 0.5022 21000.0n 0.5086 21599.5n 0.5086 21600.0n 0.5007 22199.5n 0.5007 22200.0n 0.5023 22799.5n 0.5023 22800.0n 0.5021 23399.5n 0.5021 23400.0n 0.5077 23999.5n 0.5077 24000.0n 0.4979 24599.5n 0.4979 24600.0n 0.5035 25199.5n 0.5035 25200.0n 0.5041 25799.5n 0.5041 25800.0n 0.5075 26399.5n 0.5075 26400.0n 0.5041 26999.5n 0.5041 27000.0n 0.5056 27599.5n 0.5056 27600.0n 0.5039 28199.5n 0.5039 28200.0n 0.5059 28799.5n 0.5059 28800.0n 0.5023 29399.5n 0.5023 29400.0n 0.5086 29999.5n 0.5086 30000.0n 0.5084 30599.5n 0.5084 30600.0n 0.5085 31199.5n 0.5085 31200.0n 0.5088 31799.5n 0.5088 31800.0n 0.5078 32399.5n 0.5078 32400.0n 0.5074 32999.5n 0.5074 33000.0n 0.4996 33599.5n 0.4996 33600.0n 0.5010 34199.5n 0.5010 34200.0n 0.5044 34799.5n 0.5044 34800.0n 0.5084 35399.5n 0.5084 35400.0n 0.5012 35999.5n 0.5012)
Vyn_who_29_1 yn_who_29_1 0 PWL(0.0n 0.4929 599.5n 0.4929 600.0n 0.4947 1199.5n 0.4947 1200.0n 0.4948 1799.5n 0.4948 1800.0n 0.4973 2399.5n 0.4973 2400.0n 0.4966 2999.5n 0.4966 3000.0n 0.4945 3599.5n 0.4945 3600.0n 0.4944 4199.5n 0.4944 4200.0n 0.4929 4799.5n 0.4929 4800.0n 0.4944 5399.5n 0.4944 5400.0n 0.4944 5999.5n 0.4944 6000.0n 0.4952 6599.5n 0.4952 6600.0n 0.4940 7199.5n 0.4940 7200.0n 0.4952 7799.5n 0.4952 7800.0n 0.4954 8399.5n 0.4954 8400.0n 0.4934 8999.5n 0.4934 9000.0n 0.4944 9599.5n 0.4944 9600.0n 0.4949 10199.5n 0.4949 10200.0n 0.4954 10799.5n 0.4954 10800.0n 0.4944 11399.5n 0.4944 11400.0n 0.4942 11999.5n 0.4942 12000.0n 0.4932 12599.5n 0.4932 12600.0n 0.4950 13199.5n 0.4950 13200.0n 0.4929 13799.5n 0.4929 13800.0n 0.4941 14399.5n 0.4941 14400.0n 0.4942 14999.5n 0.4942 15000.0n 0.4957 15599.5n 0.4957 15600.0n 0.4933 16199.5n 0.4933 16200.0n 0.4932 16799.5n 0.4932 16800.0n 0.4934 17399.5n 0.4934 17400.0n 0.4931 17999.5n 0.4931 18000.0n 0.4939 18599.5n 0.4939 18600.0n 0.4966 19199.5n 0.4966 19200.0n 0.4990 19799.5n 0.4990 19800.0n 0.5011 20399.5n 0.5011 20400.0n 0.4978 20999.5n 0.4978 21000.0n 0.4914 21599.5n 0.4914 21600.0n 0.4993 22199.5n 0.4993 22200.0n 0.4977 22799.5n 0.4977 22800.0n 0.4979 23399.5n 0.4979 23400.0n 0.4923 23999.5n 0.4923 24000.0n 0.5021 24599.5n 0.5021 24600.0n 0.4965 25199.5n 0.4965 25200.0n 0.4959 25799.5n 0.4959 25800.0n 0.4925 26399.5n 0.4925 26400.0n 0.4959 26999.5n 0.4959 27000.0n 0.4944 27599.5n 0.4944 27600.0n 0.4961 28199.5n 0.4961 28200.0n 0.4941 28799.5n 0.4941 28800.0n 0.4977 29399.5n 0.4977 29400.0n 0.4914 29999.5n 0.4914 30000.0n 0.4916 30599.5n 0.4916 30600.0n 0.4915 31199.5n 0.4915 31200.0n 0.4912 31799.5n 0.4912 31800.0n 0.4922 32399.5n 0.4922 32400.0n 0.4926 32999.5n 0.4926 33000.0n 0.5004 33599.5n 0.5004 33600.0n 0.4990 34199.5n 0.4990 34200.0n 0.4956 34799.5n 0.4956 34800.0n 0.4916 35399.5n 0.4916 35400.0n 0.4988 35999.5n 0.4988)
Cwp_who_29_1 wp_who_29_1 0 400p
Cwn_who_29_1 wn_who_29_1 0 400p
Xu_who_29_1 xp_who_29_1 xn_who_29_1 yp_who_29_1 yn_who_29_1 wp_who_29_1 wn_who_29_1 vdd gbn gprod
Vxp_bh_29 xp_bh_29 0 PWL(0.0n 0.7100 599.5n 0.7100 600.0n 0.7100 1199.5n 0.7100 1200.0n 0.7100 1799.5n 0.7100 1800.0n 0.7100 2399.5n 0.7100 2400.0n 0.7100 2999.5n 0.7100 3000.0n 0.7100 3599.5n 0.7100 3600.0n 0.7100 4199.5n 0.7100 4200.0n 0.7100 4799.5n 0.7100 4800.0n 0.7100 5399.5n 0.7100 5400.0n 0.7100 5999.5n 0.7100 6000.0n 0.7100 6599.5n 0.7100 6600.0n 0.7100 7199.5n 0.7100 7200.0n 0.7100 7799.5n 0.7100 7800.0n 0.7100 8399.5n 0.7100 8400.0n 0.7100 8999.5n 0.7100 9000.0n 0.7100 9599.5n 0.7100 9600.0n 0.7100 10199.5n 0.7100 10200.0n 0.7100 10799.5n 0.7100 10800.0n 0.7100 11399.5n 0.7100 11400.0n 0.7100 11999.5n 0.7100 12000.0n 0.7100 12599.5n 0.7100 12600.0n 0.7100 13199.5n 0.7100 13200.0n 0.7100 13799.5n 0.7100 13800.0n 0.7100 14399.5n 0.7100 14400.0n 0.7100 14999.5n 0.7100 15000.0n 0.7100 15599.5n 0.7100 15600.0n 0.7100 16199.5n 0.7100 16200.0n 0.7100 16799.5n 0.7100 16800.0n 0.7100 17399.5n 0.7100 17400.0n 0.7100 17999.5n 0.7100 18000.0n 0.7100 18599.5n 0.7100 18600.0n 0.7100 19199.5n 0.7100 19200.0n 0.7100 19799.5n 0.7100 19800.0n 0.7100 20399.5n 0.7100 20400.0n 0.7100 20999.5n 0.7100 21000.0n 0.7100 21599.5n 0.7100 21600.0n 0.7100 22199.5n 0.7100 22200.0n 0.7100 22799.5n 0.7100 22800.0n 0.7100 23399.5n 0.7100 23400.0n 0.7100 23999.5n 0.7100 24000.0n 0.7100 24599.5n 0.7100 24600.0n 0.7100 25199.5n 0.7100 25200.0n 0.7100 25799.5n 0.7100 25800.0n 0.7100 26399.5n 0.7100 26400.0n 0.7100 26999.5n 0.7100 27000.0n 0.7100 27599.5n 0.7100 27600.0n 0.7100 28199.5n 0.7100 28200.0n 0.7100 28799.5n 0.7100 28800.0n 0.7100 29399.5n 0.7100 29400.0n 0.7100 29999.5n 0.7100 30000.0n 0.7100 30599.5n 0.7100 30600.0n 0.7100 31199.5n 0.7100 31200.0n 0.7100 31799.5n 0.7100 31800.0n 0.7100 32399.5n 0.7100 32400.0n 0.7100 32999.5n 0.7100 33000.0n 0.7100 33599.5n 0.7100 33600.0n 0.7100 34199.5n 0.7100 34200.0n 0.7100 34799.5n 0.7100 34800.0n 0.7100 35399.5n 0.7100 35400.0n 0.7100 35999.5n 0.7100)
Vxn_bh_29 xn_bh_29 0 PWL(0.0n 0.2900 599.5n 0.2900 600.0n 0.2900 1199.5n 0.2900 1200.0n 0.2900 1799.5n 0.2900 1800.0n 0.2900 2399.5n 0.2900 2400.0n 0.2900 2999.5n 0.2900 3000.0n 0.2900 3599.5n 0.2900 3600.0n 0.2900 4199.5n 0.2900 4200.0n 0.2900 4799.5n 0.2900 4800.0n 0.2900 5399.5n 0.2900 5400.0n 0.2900 5999.5n 0.2900 6000.0n 0.2900 6599.5n 0.2900 6600.0n 0.2900 7199.5n 0.2900 7200.0n 0.2900 7799.5n 0.2900 7800.0n 0.2900 8399.5n 0.2900 8400.0n 0.2900 8999.5n 0.2900 9000.0n 0.2900 9599.5n 0.2900 9600.0n 0.2900 10199.5n 0.2900 10200.0n 0.2900 10799.5n 0.2900 10800.0n 0.2900 11399.5n 0.2900 11400.0n 0.2900 11999.5n 0.2900 12000.0n 0.2900 12599.5n 0.2900 12600.0n 0.2900 13199.5n 0.2900 13200.0n 0.2900 13799.5n 0.2900 13800.0n 0.2900 14399.5n 0.2900 14400.0n 0.2900 14999.5n 0.2900 15000.0n 0.2900 15599.5n 0.2900 15600.0n 0.2900 16199.5n 0.2900 16200.0n 0.2900 16799.5n 0.2900 16800.0n 0.2900 17399.5n 0.2900 17400.0n 0.2900 17999.5n 0.2900 18000.0n 0.2900 18599.5n 0.2900 18600.0n 0.2900 19199.5n 0.2900 19200.0n 0.2900 19799.5n 0.2900 19800.0n 0.2900 20399.5n 0.2900 20400.0n 0.2900 20999.5n 0.2900 21000.0n 0.2900 21599.5n 0.2900 21600.0n 0.2900 22199.5n 0.2900 22200.0n 0.2900 22799.5n 0.2900 22800.0n 0.2900 23399.5n 0.2900 23400.0n 0.2900 23999.5n 0.2900 24000.0n 0.2900 24599.5n 0.2900 24600.0n 0.2900 25199.5n 0.2900 25200.0n 0.2900 25799.5n 0.2900 25800.0n 0.2900 26399.5n 0.2900 26400.0n 0.2900 26999.5n 0.2900 27000.0n 0.2900 27599.5n 0.2900 27600.0n 0.2900 28199.5n 0.2900 28200.0n 0.2900 28799.5n 0.2900 28800.0n 0.2900 29399.5n 0.2900 29400.0n 0.2900 29999.5n 0.2900 30000.0n 0.2900 30599.5n 0.2900 30600.0n 0.2900 31199.5n 0.2900 31200.0n 0.2900 31799.5n 0.2900 31800.0n 0.2900 32399.5n 0.2900 32400.0n 0.2900 32999.5n 0.2900 33000.0n 0.2900 33599.5n 0.2900 33600.0n 0.2900 34199.5n 0.2900 34200.0n 0.2900 34799.5n 0.2900 34800.0n 0.2900 35399.5n 0.2900 35400.0n 0.2900 35999.5n 0.2900)
Vyp_bh_29 yp_bh_29 0 PWL(0.0n 0.4356 599.5n 0.4356 600.0n 0.4213 1199.5n 0.4213 1200.0n 0.3546 1799.5n 0.3546 1800.0n 0.3378 2399.5n 0.3378 2400.0n 0.3450 2999.5n 0.3450 3000.0n 0.3945 3599.5n 0.3945 3600.0n 0.3700 4199.5n 0.3700 4200.0n 0.4368 4799.5n 0.4368 4800.0n 0.3863 5399.5n 0.3863 5400.0n 0.3856 5999.5n 0.3856 6000.0n 0.3493 6599.5n 0.3493 6600.0n 0.3963 7199.5n 0.3963 7200.0n 0.3980 7799.5n 0.3980 7800.0n 0.3918 8399.5n 0.3918 8400.0n 0.4178 8999.5n 0.4178 9000.0n 0.3864 9599.5n 0.3864 9600.0n 0.3734 10199.5n 0.3734 10200.0n 0.3727 10799.5n 0.3727 10800.0n 0.3551 11399.5n 0.3551 11400.0n 0.3921 11999.5n 0.3921 12000.0n 0.4247 12599.5n 0.4247 12600.0n 0.3709 13199.5n 0.3709 13200.0n 0.4396 13799.5n 0.4396 13800.0n 0.4204 14399.5n 0.4204 14400.0n 0.3957 14999.5n 0.3957 15000.0n 0.3547 15599.5n 0.3547 15600.0n 0.4193 16199.5n 0.4193 16200.0n 0.4419 16799.5n 0.4419 16800.0n 0.4129 17399.5n 0.4129 17400.0n 0.4339 17999.5n 0.4339 18000.0n 0.3260 18599.5n 0.3260 18600.0n 0.4352 19199.5n 0.4352 19200.0n 0.3272 19799.5n 0.3272 19800.0n 0.3374 20399.5n 0.3374 20400.0n 0.3244 20999.5n 0.3244 21000.0n 0.3394 21599.5n 0.3394 21600.0n 0.3534 22199.5n 0.3534 22200.0n 0.4269 22799.5n 0.4269 22800.0n 0.3197 23399.5n 0.3197 23400.0n 0.5836 23999.5n 0.5836 24000.0n 0.3274 24599.5n 0.3274 24600.0n 0.4560 25199.5n 0.4560 25200.0n 0.3241 25799.5n 0.3241 25800.0n 0.3180 26399.5n 0.3180 26400.0n 0.3187 26999.5n 0.3187 27000.0n 0.3228 27599.5n 0.3228 27600.0n 0.3189 28199.5n 0.3189 28200.0n 0.5723 28799.5n 0.5723 28800.0n 0.3221 29399.5n 0.3221 29400.0n 0.3448 29999.5n 0.3448 30000.0n 0.3632 30599.5n 0.3632 30600.0n 0.5258 31199.5n 0.5258 31200.0n 0.5376 31799.5n 0.5376 31800.0n 0.3202 32399.5n 0.3202 32400.0n 0.3174 32999.5n 0.3174 33000.0n 0.3258 33599.5n 0.3258 33600.0n 0.3222 34199.5n 0.3222 34200.0n 0.4845 34799.5n 0.4845 34800.0n 0.4285 35399.5n 0.4285 35400.0n 0.3253 35999.5n 0.3253)
Vyn_bh_29 yn_bh_29 0 PWL(0.0n 0.5644 599.5n 0.5644 600.0n 0.5787 1199.5n 0.5787 1200.0n 0.6454 1799.5n 0.6454 1800.0n 0.6622 2399.5n 0.6622 2400.0n 0.6550 2999.5n 0.6550 3000.0n 0.6055 3599.5n 0.6055 3600.0n 0.6300 4199.5n 0.6300 4200.0n 0.5632 4799.5n 0.5632 4800.0n 0.6137 5399.5n 0.6137 5400.0n 0.6144 5999.5n 0.6144 6000.0n 0.6507 6599.5n 0.6507 6600.0n 0.6037 7199.5n 0.6037 7200.0n 0.6020 7799.5n 0.6020 7800.0n 0.6082 8399.5n 0.6082 8400.0n 0.5822 8999.5n 0.5822 9000.0n 0.6136 9599.5n 0.6136 9600.0n 0.6266 10199.5n 0.6266 10200.0n 0.6273 10799.5n 0.6273 10800.0n 0.6449 11399.5n 0.6449 11400.0n 0.6079 11999.5n 0.6079 12000.0n 0.5753 12599.5n 0.5753 12600.0n 0.6291 13199.5n 0.6291 13200.0n 0.5604 13799.5n 0.5604 13800.0n 0.5796 14399.5n 0.5796 14400.0n 0.6043 14999.5n 0.6043 15000.0n 0.6453 15599.5n 0.6453 15600.0n 0.5807 16199.5n 0.5807 16200.0n 0.5581 16799.5n 0.5581 16800.0n 0.5871 17399.5n 0.5871 17400.0n 0.5661 17999.5n 0.5661 18000.0n 0.6740 18599.5n 0.6740 18600.0n 0.5648 19199.5n 0.5648 19200.0n 0.6728 19799.5n 0.6728 19800.0n 0.6626 20399.5n 0.6626 20400.0n 0.6756 20999.5n 0.6756 21000.0n 0.6606 21599.5n 0.6606 21600.0n 0.6466 22199.5n 0.6466 22200.0n 0.5731 22799.5n 0.5731 22800.0n 0.6803 23399.5n 0.6803 23400.0n 0.4164 23999.5n 0.4164 24000.0n 0.6726 24599.5n 0.6726 24600.0n 0.5440 25199.5n 0.5440 25200.0n 0.6759 25799.5n 0.6759 25800.0n 0.6820 26399.5n 0.6820 26400.0n 0.6813 26999.5n 0.6813 27000.0n 0.6772 27599.5n 0.6772 27600.0n 0.6811 28199.5n 0.6811 28200.0n 0.4277 28799.5n 0.4277 28800.0n 0.6779 29399.5n 0.6779 29400.0n 0.6552 29999.5n 0.6552 30000.0n 0.6368 30599.5n 0.6368 30600.0n 0.4742 31199.5n 0.4742 31200.0n 0.4624 31799.5n 0.4624 31800.0n 0.6798 32399.5n 0.6798 32400.0n 0.6826 32999.5n 0.6826 33000.0n 0.6742 33599.5n 0.6742 33600.0n 0.6778 34199.5n 0.6778 34200.0n 0.5155 34799.5n 0.5155 34800.0n 0.5715 35399.5n 0.5715 35400.0n 0.6747 35999.5n 0.6747)
Cwp_bh_29 wp_bh_29 0 400p
Cwn_bh_29 wn_bh_29 0 400p
Xu_bh_29 xp_bh_29 xn_bh_29 yp_bh_29 yn_bh_29 wp_bh_29 wn_bh_29 vdd gbn gprod
Vxp_wih_0_30 xp_wih_0_30 0 PWL(0.0n 0.4942 599.5n 0.4942 600.0n 0.5558 1199.5n 0.5558 1200.0n 0.4708 1799.5n 0.4708 1800.0n 0.5235 2399.5n 0.5235 2400.0n 0.5350 2999.5n 0.5350 3000.0n 0.5172 3599.5n 0.5172 3600.0n 0.4702 4199.5n 0.4702 4200.0n 0.4867 4799.5n 0.4867 4800.0n 0.4970 5399.5n 0.4970 5400.0n 0.4986 5999.5n 0.4986 6000.0n 0.4751 6599.5n 0.4751 6600.0n 0.4870 7199.5n 0.4870 7200.0n 0.5502 7799.5n 0.5502 7800.0n 0.5521 8399.5n 0.5521 8400.0n 0.4638 8999.5n 0.4638 9000.0n 0.4982 9599.5n 0.4982 9600.0n 0.5131 10199.5n 0.5131 10200.0n 0.5386 10799.5n 0.5386 10800.0n 0.4592 11399.5n 0.4592 11400.0n 0.4950 11999.5n 0.4950 12000.0n 0.4559 12599.5n 0.4559 12600.0n 0.5162 13199.5n 0.5162 13200.0n 0.5038 13799.5n 0.5038 13800.0n 0.5333 14399.5n 0.5333 14400.0n 0.4991 14999.5n 0.4991 15000.0n 0.5298 15599.5n 0.5298 15600.0n 0.4823 16199.5n 0.4823 16200.0n 0.5239 16799.5n 0.5239 16800.0n 0.4592 17399.5n 0.4592 17400.0n 0.5094 17999.5n 0.5094 18000.0n 0.4337 18599.5n 0.4337 18600.0n 0.5977 19199.5n 0.5977 19200.0n 0.5364 19799.5n 0.5364 19800.0n 0.6122 20399.5n 0.6122 20400.0n 0.4856 20999.5n 0.4856 21000.0n 0.3861 21599.5n 0.3861 21600.0n 0.6094 22199.5n 0.6094 22200.0n 0.6364 22799.5n 0.6364 22800.0n 0.4807 23399.5n 0.4807 23400.0n 0.5614 23999.5n 0.5614 24000.0n 0.5913 24599.5n 0.5913 24600.0n 0.6295 25199.5n 0.6295 25200.0n 0.4496 25799.5n 0.4496 25800.0n 0.3792 26399.5n 0.3792 26400.0n 0.4434 26999.5n 0.4434 27000.0n 0.4340 27599.5n 0.4340 27600.0n 0.4461 28199.5n 0.4461 28200.0n 0.5791 28799.5n 0.5791 28800.0n 0.4777 29399.5n 0.4777 29400.0n 0.3878 29999.5n 0.3878 30000.0n 0.3832 30599.5n 0.3832 30600.0n 0.4022 31199.5n 0.4022 31200.0n 0.4482 31799.5n 0.4482 31800.0n 0.3662 32399.5n 0.3662 32400.0n 0.3857 32999.5n 0.3857 33000.0n 0.5584 33599.5n 0.5584 33600.0n 0.5284 34199.5n 0.5284 34200.0n 0.6034 34799.5n 0.6034 34800.0n 0.3469 35399.5n 0.3469 35400.0n 0.5290 35999.5n 0.5290)
Vxn_wih_0_30 xn_wih_0_30 0 PWL(0.0n 0.5058 599.5n 0.5058 600.0n 0.4442 1199.5n 0.4442 1200.0n 0.5292 1799.5n 0.5292 1800.0n 0.4765 2399.5n 0.4765 2400.0n 0.4650 2999.5n 0.4650 3000.0n 0.4828 3599.5n 0.4828 3600.0n 0.5298 4199.5n 0.5298 4200.0n 0.5133 4799.5n 0.5133 4800.0n 0.5030 5399.5n 0.5030 5400.0n 0.5014 5999.5n 0.5014 6000.0n 0.5249 6599.5n 0.5249 6600.0n 0.5130 7199.5n 0.5130 7200.0n 0.4498 7799.5n 0.4498 7800.0n 0.4479 8399.5n 0.4479 8400.0n 0.5362 8999.5n 0.5362 9000.0n 0.5018 9599.5n 0.5018 9600.0n 0.4869 10199.5n 0.4869 10200.0n 0.4614 10799.5n 0.4614 10800.0n 0.5408 11399.5n 0.5408 11400.0n 0.5050 11999.5n 0.5050 12000.0n 0.5441 12599.5n 0.5441 12600.0n 0.4838 13199.5n 0.4838 13200.0n 0.4962 13799.5n 0.4962 13800.0n 0.4667 14399.5n 0.4667 14400.0n 0.5009 14999.5n 0.5009 15000.0n 0.4702 15599.5n 0.4702 15600.0n 0.5177 16199.5n 0.5177 16200.0n 0.4761 16799.5n 0.4761 16800.0n 0.5408 17399.5n 0.5408 17400.0n 0.4906 17999.5n 0.4906 18000.0n 0.5663 18599.5n 0.5663 18600.0n 0.4023 19199.5n 0.4023 19200.0n 0.4636 19799.5n 0.4636 19800.0n 0.3878 20399.5n 0.3878 20400.0n 0.5144 20999.5n 0.5144 21000.0n 0.6139 21599.5n 0.6139 21600.0n 0.3906 22199.5n 0.3906 22200.0n 0.3636 22799.5n 0.3636 22800.0n 0.5193 23399.5n 0.5193 23400.0n 0.4386 23999.5n 0.4386 24000.0n 0.4087 24599.5n 0.4087 24600.0n 0.3705 25199.5n 0.3705 25200.0n 0.5504 25799.5n 0.5504 25800.0n 0.6208 26399.5n 0.6208 26400.0n 0.5566 26999.5n 0.5566 27000.0n 0.5660 27599.5n 0.5660 27600.0n 0.5539 28199.5n 0.5539 28200.0n 0.4209 28799.5n 0.4209 28800.0n 0.5223 29399.5n 0.5223 29400.0n 0.6122 29999.5n 0.6122 30000.0n 0.6168 30599.5n 0.6168 30600.0n 0.5978 31199.5n 0.5978 31200.0n 0.5518 31799.5n 0.5518 31800.0n 0.6338 32399.5n 0.6338 32400.0n 0.6143 32999.5n 0.6143 33000.0n 0.4416 33599.5n 0.4416 33600.0n 0.4716 34199.5n 0.4716 34200.0n 0.3966 34799.5n 0.3966 34800.0n 0.6531 35399.5n 0.6531 35400.0n 0.4710 35999.5n 0.4710)
Vyp_wih_0_30 yp_wih_0_30 0 PWL(0.0n 0.5020 599.5n 0.5020 600.0n 0.5163 1199.5n 0.5163 1200.0n 0.5011 1799.5n 0.5011 1800.0n 0.5126 2399.5n 0.5126 2400.0n 0.5141 2999.5n 0.5141 3000.0n 0.5075 3599.5n 0.5075 3600.0n 0.5002 4199.5n 0.5002 4200.0n 0.5005 4799.5n 0.5005 4800.0n 0.5044 5399.5n 0.5044 5400.0n 0.5047 5999.5n 0.5047 6000.0n 0.5025 6599.5n 0.5025 6600.0n 0.5023 7199.5n 0.5023 7200.0n 0.5152 7799.5n 0.5152 7800.0n 0.5161 8399.5n 0.5161 8400.0n 0.4964 8999.5n 0.4964 9000.0n 0.5046 9599.5n 0.5046 9600.0n 0.5078 10199.5n 0.5078 10200.0n 0.5130 10799.5n 0.5130 10800.0n 0.4985 11399.5n 0.4985 11400.0n 0.5039 11999.5n 0.5039 12000.0n 0.4940 12599.5n 0.4940 12600.0n 0.5084 13199.5n 0.5084 13200.0n 0.5035 13799.5n 0.5035 13800.0n 0.5097 14399.5n 0.5097 14400.0n 0.5044 14999.5n 0.5044 15000.0n 0.5120 15599.5n 0.5120 15600.0n 0.5005 16199.5n 0.5005 16200.0n 0.5070 16799.5n 0.5070 16800.0n 0.4955 17399.5n 0.4955 17400.0n 0.5046 17999.5n 0.5046 18000.0n 0.4948 18599.5n 0.4948 18600.0n 0.5326 19199.5n 0.5326 19200.0n 0.5190 19799.5n 0.5190 19800.0n 0.5390 20399.5n 0.5390 20400.0n 0.5107 20999.5n 0.5107 21000.0n 0.4765 21599.5n 0.4765 21600.0n 0.5368 22199.5n 0.5368 22200.0n 0.5340 22799.5n 0.5340 22800.0n 0.5096 23399.5n 0.5096 23400.0n 0.5112 23999.5n 0.5112 24000.0n 0.5398 24599.5n 0.5398 24600.0n 0.5332 25199.5n 0.5332 25200.0n 0.5020 25799.5n 0.5020 25800.0n 0.4832 26399.5n 0.4832 26400.0n 0.5003 26999.5n 0.5003 27000.0n 0.4959 27599.5n 0.4959 27600.0n 0.5013 28199.5n 0.5013 28200.0n 0.5206 28799.5n 0.5206 28800.0n 0.5092 29399.5n 0.5092 29400.0n 0.4757 29999.5n 0.4757 30000.0n 0.4739 30599.5n 0.4739 30600.0n 0.4667 31199.5n 0.4667 31200.0n 0.4850 31799.5n 0.4850 31800.0n 0.4825 32399.5n 0.4825 32400.0n 0.4831 32999.5n 0.4831 33000.0n 0.5260 33599.5n 0.5260 33600.0n 0.5181 34199.5n 0.5181 34200.0n 0.5319 34799.5n 0.5319 34800.0n 0.4706 35399.5n 0.4706 35400.0n 0.5183 35999.5n 0.5183)
Vyn_wih_0_30 yn_wih_0_30 0 PWL(0.0n 0.4980 599.5n 0.4980 600.0n 0.4837 1199.5n 0.4837 1200.0n 0.4989 1799.5n 0.4989 1800.0n 0.4874 2399.5n 0.4874 2400.0n 0.4859 2999.5n 0.4859 3000.0n 0.4925 3599.5n 0.4925 3600.0n 0.4998 4199.5n 0.4998 4200.0n 0.4995 4799.5n 0.4995 4800.0n 0.4956 5399.5n 0.4956 5400.0n 0.4953 5999.5n 0.4953 6000.0n 0.4975 6599.5n 0.4975 6600.0n 0.4977 7199.5n 0.4977 7200.0n 0.4848 7799.5n 0.4848 7800.0n 0.4839 8399.5n 0.4839 8400.0n 0.5036 8999.5n 0.5036 9000.0n 0.4954 9599.5n 0.4954 9600.0n 0.4922 10199.5n 0.4922 10200.0n 0.4870 10799.5n 0.4870 10800.0n 0.5015 11399.5n 0.5015 11400.0n 0.4961 11999.5n 0.4961 12000.0n 0.5060 12599.5n 0.5060 12600.0n 0.4916 13199.5n 0.4916 13200.0n 0.4965 13799.5n 0.4965 13800.0n 0.4903 14399.5n 0.4903 14400.0n 0.4956 14999.5n 0.4956 15000.0n 0.4880 15599.5n 0.4880 15600.0n 0.4995 16199.5n 0.4995 16200.0n 0.4930 16799.5n 0.4930 16800.0n 0.5045 17399.5n 0.5045 17400.0n 0.4954 17999.5n 0.4954 18000.0n 0.5052 18599.5n 0.5052 18600.0n 0.4674 19199.5n 0.4674 19200.0n 0.4810 19799.5n 0.4810 19800.0n 0.4610 20399.5n 0.4610 20400.0n 0.4893 20999.5n 0.4893 21000.0n 0.5235 21599.5n 0.5235 21600.0n 0.4632 22199.5n 0.4632 22200.0n 0.4660 22799.5n 0.4660 22800.0n 0.4904 23399.5n 0.4904 23400.0n 0.4888 23999.5n 0.4888 24000.0n 0.4602 24599.5n 0.4602 24600.0n 0.4668 25199.5n 0.4668 25200.0n 0.4980 25799.5n 0.4980 25800.0n 0.5168 26399.5n 0.5168 26400.0n 0.4997 26999.5n 0.4997 27000.0n 0.5041 27599.5n 0.5041 27600.0n 0.4987 28199.5n 0.4987 28200.0n 0.4794 28799.5n 0.4794 28800.0n 0.4908 29399.5n 0.4908 29400.0n 0.5243 29999.5n 0.5243 30000.0n 0.5261 30599.5n 0.5261 30600.0n 0.5333 31199.5n 0.5333 31200.0n 0.5150 31799.5n 0.5150 31800.0n 0.5175 32399.5n 0.5175 32400.0n 0.5169 32999.5n 0.5169 33000.0n 0.4740 33599.5n 0.4740 33600.0n 0.4819 34199.5n 0.4819 34200.0n 0.4681 34799.5n 0.4681 34800.0n 0.5294 35399.5n 0.5294 35400.0n 0.4817 35999.5n 0.4817)
Cwp_wih_0_30 wp_wih_0_30 0 400p
Cwn_wih_0_30 wn_wih_0_30 0 400p
Xu_wih_0_30 xp_wih_0_30 xn_wih_0_30 yp_wih_0_30 yn_wih_0_30 wp_wih_0_30 wn_wih_0_30 vdd gbn gprod
Vxp_wih_1_30 xp_wih_1_30 0 PWL(0.0n 0.5370 599.5n 0.5370 600.0n 0.5167 1199.5n 0.5167 1200.0n 0.4793 1799.5n 0.4793 1800.0n 0.4441 2399.5n 0.4441 2400.0n 0.4555 2999.5n 0.4555 3000.0n 0.5055 3599.5n 0.5055 3600.0n 0.4939 4199.5n 0.4939 4200.0n 0.5385 4799.5n 0.5385 4800.0n 0.5024 5399.5n 0.5024 5400.0n 0.5015 5999.5n 0.5015 6000.0n 0.4700 6599.5n 0.4700 6600.0n 0.5120 7199.5n 0.5120 7200.0n 0.5006 7799.5n 0.5006 7800.0n 0.4950 8399.5n 0.4950 8400.0n 0.5309 8999.5n 0.5309 9000.0n 0.5023 9599.5n 0.5023 9600.0n 0.4893 10199.5n 0.4893 10200.0n 0.4837 10799.5n 0.4837 10800.0n 0.4823 11399.5n 0.4823 11400.0n 0.5074 11999.5n 0.5074 12000.0n 0.5364 12599.5n 0.5364 12600.0n 0.4868 13199.5n 0.4868 13200.0n 0.5380 13799.5n 0.5380 13800.0n 0.5220 14399.5n 0.5220 14400.0n 0.5095 14999.5n 0.5095 15000.0n 0.4705 15599.5n 0.4705 15600.0n 0.5289 16199.5n 0.5289 16200.0n 0.5368 16799.5n 0.5368 16800.0n 0.5287 17399.5n 0.5287 17400.0n 0.5342 17999.5n 0.5342 18000.0n 0.4253 18599.5n 0.4253 18600.0n 0.5119 19199.5n 0.5119 19200.0n 0.4104 19799.5n 0.4104 19800.0n 0.4314 20399.5n 0.4314 20400.0n 0.4005 20999.5n 0.4005 21000.0n 0.4696 21599.5n 0.4696 21600.0n 0.4531 22199.5n 0.4531 22200.0n 0.5039 22799.5n 0.5039 22800.0n 0.3608 23399.5n 0.3608 23400.0n 0.6273 23999.5n 0.6273 24000.0n 0.3928 24599.5n 0.3928 24600.0n 0.5253 25199.5n 0.5253 25200.0n 0.4107 25799.5n 0.4107 25800.0n 0.3947 26399.5n 0.3947 26400.0n 0.3716 26999.5n 0.3716 27000.0n 0.4111 27599.5n 0.4111 27600.0n 0.3715 28199.5n 0.3715 28200.0n 0.5939 28799.5n 0.5939 28800.0n 0.3849 29399.5n 0.3849 29400.0n 0.4835 29999.5n 0.4835 30000.0n 0.5119 30599.5n 0.5119 30600.0n 0.6226 31199.5n 0.6226 31200.0n 0.6064 31799.5n 0.6064 31800.0n 0.4115 32399.5n 0.4115 32400.0n 0.3900 32999.5n 0.3900 33000.0n 0.3958 33599.5n 0.3958 33600.0n 0.3747 34199.5n 0.3747 34200.0n 0.5423 34799.5n 0.5423 34800.0n 0.5509 35399.5n 0.5509 35400.0n 0.3990 35999.5n 0.3990)
Vxn_wih_1_30 xn_wih_1_30 0 PWL(0.0n 0.4630 599.5n 0.4630 600.0n 0.4833 1199.5n 0.4833 1200.0n 0.5207 1799.5n 0.5207 1800.0n 0.5559 2399.5n 0.5559 2400.0n 0.5445 2999.5n 0.5445 3000.0n 0.4945 3599.5n 0.4945 3600.0n 0.5061 4199.5n 0.5061 4200.0n 0.4615 4799.5n 0.4615 4800.0n 0.4976 5399.5n 0.4976 5400.0n 0.4985 5999.5n 0.4985 6000.0n 0.5300 6599.5n 0.5300 6600.0n 0.4880 7199.5n 0.4880 7200.0n 0.4994 7799.5n 0.4994 7800.0n 0.5050 8399.5n 0.5050 8400.0n 0.4691 8999.5n 0.4691 9000.0n 0.4977 9599.5n 0.4977 9600.0n 0.5107 10199.5n 0.5107 10200.0n 0.5163 10799.5n 0.5163 10800.0n 0.5177 11399.5n 0.5177 11400.0n 0.4926 11999.5n 0.4926 12000.0n 0.4636 12599.5n 0.4636 12600.0n 0.5132 13199.5n 0.5132 13200.0n 0.4620 13799.5n 0.4620 13800.0n 0.4780 14399.5n 0.4780 14400.0n 0.4905 14999.5n 0.4905 15000.0n 0.5295 15599.5n 0.5295 15600.0n 0.4711 16199.5n 0.4711 16200.0n 0.4632 16799.5n 0.4632 16800.0n 0.4713 17399.5n 0.4713 17400.0n 0.4658 17999.5n 0.4658 18000.0n 0.5747 18599.5n 0.5747 18600.0n 0.4881 19199.5n 0.4881 19200.0n 0.5896 19799.5n 0.5896 19800.0n 0.5686 20399.5n 0.5686 20400.0n 0.5995 20999.5n 0.5995 21000.0n 0.5304 21599.5n 0.5304 21600.0n 0.5469 22199.5n 0.5469 22200.0n 0.4961 22799.5n 0.4961 22800.0n 0.6392 23399.5n 0.6392 23400.0n 0.3727 23999.5n 0.3727 24000.0n 0.6072 24599.5n 0.6072 24600.0n 0.4747 25199.5n 0.4747 25200.0n 0.5893 25799.5n 0.5893 25800.0n 0.6053 26399.5n 0.6053 26400.0n 0.6284 26999.5n 0.6284 27000.0n 0.5889 27599.5n 0.5889 27600.0n 0.6285 28199.5n 0.6285 28200.0n 0.4061 28799.5n 0.4061 28800.0n 0.6151 29399.5n 0.6151 29400.0n 0.5165 29999.5n 0.5165 30000.0n 0.4881 30599.5n 0.4881 30600.0n 0.3774 31199.5n 0.3774 31200.0n 0.3936 31799.5n 0.3936 31800.0n 0.5885 32399.5n 0.5885 32400.0n 0.6100 32999.5n 0.6100 33000.0n 0.6042 33599.5n 0.6042 33600.0n 0.6253 34199.5n 0.6253 34200.0n 0.4577 34799.5n 0.4577 34800.0n 0.4491 35399.5n 0.4491 35400.0n 0.6010 35999.5n 0.6010)
Vyp_wih_1_30 yp_wih_1_30 0 PWL(0.0n 0.5020 599.5n 0.5020 600.0n 0.5163 1199.5n 0.5163 1200.0n 0.5011 1799.5n 0.5011 1800.0n 0.5126 2399.5n 0.5126 2400.0n 0.5141 2999.5n 0.5141 3000.0n 0.5075 3599.5n 0.5075 3600.0n 0.5002 4199.5n 0.5002 4200.0n 0.5005 4799.5n 0.5005 4800.0n 0.5044 5399.5n 0.5044 5400.0n 0.5047 5999.5n 0.5047 6000.0n 0.5025 6599.5n 0.5025 6600.0n 0.5023 7199.5n 0.5023 7200.0n 0.5152 7799.5n 0.5152 7800.0n 0.5161 8399.5n 0.5161 8400.0n 0.4964 8999.5n 0.4964 9000.0n 0.5046 9599.5n 0.5046 9600.0n 0.5078 10199.5n 0.5078 10200.0n 0.5130 10799.5n 0.5130 10800.0n 0.4985 11399.5n 0.4985 11400.0n 0.5039 11999.5n 0.5039 12000.0n 0.4940 12599.5n 0.4940 12600.0n 0.5084 13199.5n 0.5084 13200.0n 0.5035 13799.5n 0.5035 13800.0n 0.5097 14399.5n 0.5097 14400.0n 0.5044 14999.5n 0.5044 15000.0n 0.5120 15599.5n 0.5120 15600.0n 0.5005 16199.5n 0.5005 16200.0n 0.5070 16799.5n 0.5070 16800.0n 0.4955 17399.5n 0.4955 17400.0n 0.5046 17999.5n 0.5046 18000.0n 0.4948 18599.5n 0.4948 18600.0n 0.5326 19199.5n 0.5326 19200.0n 0.5190 19799.5n 0.5190 19800.0n 0.5390 20399.5n 0.5390 20400.0n 0.5107 20999.5n 0.5107 21000.0n 0.4765 21599.5n 0.4765 21600.0n 0.5368 22199.5n 0.5368 22200.0n 0.5340 22799.5n 0.5340 22800.0n 0.5096 23399.5n 0.5096 23400.0n 0.5112 23999.5n 0.5112 24000.0n 0.5398 24599.5n 0.5398 24600.0n 0.5332 25199.5n 0.5332 25200.0n 0.5020 25799.5n 0.5020 25800.0n 0.4832 26399.5n 0.4832 26400.0n 0.5003 26999.5n 0.5003 27000.0n 0.4959 27599.5n 0.4959 27600.0n 0.5013 28199.5n 0.5013 28200.0n 0.5206 28799.5n 0.5206 28800.0n 0.5092 29399.5n 0.5092 29400.0n 0.4757 29999.5n 0.4757 30000.0n 0.4739 30599.5n 0.4739 30600.0n 0.4667 31199.5n 0.4667 31200.0n 0.4850 31799.5n 0.4850 31800.0n 0.4825 32399.5n 0.4825 32400.0n 0.4831 32999.5n 0.4831 33000.0n 0.5260 33599.5n 0.5260 33600.0n 0.5181 34199.5n 0.5181 34200.0n 0.5319 34799.5n 0.5319 34800.0n 0.4706 35399.5n 0.4706 35400.0n 0.5183 35999.5n 0.5183)
Vyn_wih_1_30 yn_wih_1_30 0 PWL(0.0n 0.4980 599.5n 0.4980 600.0n 0.4837 1199.5n 0.4837 1200.0n 0.4989 1799.5n 0.4989 1800.0n 0.4874 2399.5n 0.4874 2400.0n 0.4859 2999.5n 0.4859 3000.0n 0.4925 3599.5n 0.4925 3600.0n 0.4998 4199.5n 0.4998 4200.0n 0.4995 4799.5n 0.4995 4800.0n 0.4956 5399.5n 0.4956 5400.0n 0.4953 5999.5n 0.4953 6000.0n 0.4975 6599.5n 0.4975 6600.0n 0.4977 7199.5n 0.4977 7200.0n 0.4848 7799.5n 0.4848 7800.0n 0.4839 8399.5n 0.4839 8400.0n 0.5036 8999.5n 0.5036 9000.0n 0.4954 9599.5n 0.4954 9600.0n 0.4922 10199.5n 0.4922 10200.0n 0.4870 10799.5n 0.4870 10800.0n 0.5015 11399.5n 0.5015 11400.0n 0.4961 11999.5n 0.4961 12000.0n 0.5060 12599.5n 0.5060 12600.0n 0.4916 13199.5n 0.4916 13200.0n 0.4965 13799.5n 0.4965 13800.0n 0.4903 14399.5n 0.4903 14400.0n 0.4956 14999.5n 0.4956 15000.0n 0.4880 15599.5n 0.4880 15600.0n 0.4995 16199.5n 0.4995 16200.0n 0.4930 16799.5n 0.4930 16800.0n 0.5045 17399.5n 0.5045 17400.0n 0.4954 17999.5n 0.4954 18000.0n 0.5052 18599.5n 0.5052 18600.0n 0.4674 19199.5n 0.4674 19200.0n 0.4810 19799.5n 0.4810 19800.0n 0.4610 20399.5n 0.4610 20400.0n 0.4893 20999.5n 0.4893 21000.0n 0.5235 21599.5n 0.5235 21600.0n 0.4632 22199.5n 0.4632 22200.0n 0.4660 22799.5n 0.4660 22800.0n 0.4904 23399.5n 0.4904 23400.0n 0.4888 23999.5n 0.4888 24000.0n 0.4602 24599.5n 0.4602 24600.0n 0.4668 25199.5n 0.4668 25200.0n 0.4980 25799.5n 0.4980 25800.0n 0.5168 26399.5n 0.5168 26400.0n 0.4997 26999.5n 0.4997 27000.0n 0.5041 27599.5n 0.5041 27600.0n 0.4987 28199.5n 0.4987 28200.0n 0.4794 28799.5n 0.4794 28800.0n 0.4908 29399.5n 0.4908 29400.0n 0.5243 29999.5n 0.5243 30000.0n 0.5261 30599.5n 0.5261 30600.0n 0.5333 31199.5n 0.5333 31200.0n 0.5150 31799.5n 0.5150 31800.0n 0.5175 32399.5n 0.5175 32400.0n 0.5169 32999.5n 0.5169 33000.0n 0.4740 33599.5n 0.4740 33600.0n 0.4819 34199.5n 0.4819 34200.0n 0.4681 34799.5n 0.4681 34800.0n 0.5294 35399.5n 0.5294 35400.0n 0.4817 35999.5n 0.4817)
Cwp_wih_1_30 wp_wih_1_30 0 400p
Cwn_wih_1_30 wn_wih_1_30 0 400p
Xu_wih_1_30 xp_wih_1_30 xn_wih_1_30 yp_wih_1_30 yn_wih_1_30 wp_wih_1_30 wn_wih_1_30 vdd gbn gprod
Vxp_who_30_0 xp_who_30_0 0 PWL(0.0n 0.5020 599.5n 0.5020 600.0n 0.5163 1199.5n 0.5163 1200.0n 0.5011 1799.5n 0.5011 1800.0n 0.5126 2399.5n 0.5126 2400.0n 0.5141 2999.5n 0.5141 3000.0n 0.5075 3599.5n 0.5075 3600.0n 0.5002 4199.5n 0.5002 4200.0n 0.5005 4799.5n 0.5005 4800.0n 0.5044 5399.5n 0.5044 5400.0n 0.5047 5999.5n 0.5047 6000.0n 0.5025 6599.5n 0.5025 6600.0n 0.5023 7199.5n 0.5023 7200.0n 0.5152 7799.5n 0.5152 7800.0n 0.5161 8399.5n 0.5161 8400.0n 0.4964 8999.5n 0.4964 9000.0n 0.5046 9599.5n 0.5046 9600.0n 0.5078 10199.5n 0.5078 10200.0n 0.5130 10799.5n 0.5130 10800.0n 0.4985 11399.5n 0.4985 11400.0n 0.5039 11999.5n 0.5039 12000.0n 0.4940 12599.5n 0.4940 12600.0n 0.5084 13199.5n 0.5084 13200.0n 0.5035 13799.5n 0.5035 13800.0n 0.5097 14399.5n 0.5097 14400.0n 0.5044 14999.5n 0.5044 15000.0n 0.5120 15599.5n 0.5120 15600.0n 0.5005 16199.5n 0.5005 16200.0n 0.5070 16799.5n 0.5070 16800.0n 0.4955 17399.5n 0.4955 17400.0n 0.5046 17999.5n 0.5046 18000.0n 0.4948 18599.5n 0.4948 18600.0n 0.5326 19199.5n 0.5326 19200.0n 0.5190 19799.5n 0.5190 19800.0n 0.5390 20399.5n 0.5390 20400.0n 0.5107 20999.5n 0.5107 21000.0n 0.4765 21599.5n 0.4765 21600.0n 0.5368 22199.5n 0.5368 22200.0n 0.5340 22799.5n 0.5340 22800.0n 0.5096 23399.5n 0.5096 23400.0n 0.5112 23999.5n 0.5112 24000.0n 0.5398 24599.5n 0.5398 24600.0n 0.5332 25199.5n 0.5332 25200.0n 0.5020 25799.5n 0.5020 25800.0n 0.4832 26399.5n 0.4832 26400.0n 0.5003 26999.5n 0.5003 27000.0n 0.4959 27599.5n 0.4959 27600.0n 0.5013 28199.5n 0.5013 28200.0n 0.5206 28799.5n 0.5206 28800.0n 0.5092 29399.5n 0.5092 29400.0n 0.4757 29999.5n 0.4757 30000.0n 0.4739 30599.5n 0.4739 30600.0n 0.4667 31199.5n 0.4667 31200.0n 0.4850 31799.5n 0.4850 31800.0n 0.4825 32399.5n 0.4825 32400.0n 0.4831 32999.5n 0.4831 33000.0n 0.5260 33599.5n 0.5260 33600.0n 0.5181 34199.5n 0.5181 34200.0n 0.5319 34799.5n 0.5319 34800.0n 0.4706 35399.5n 0.4706 35400.0n 0.5183 35999.5n 0.5183)
Vxn_who_30_0 xn_who_30_0 0 PWL(0.0n 0.4980 599.5n 0.4980 600.0n 0.4837 1199.5n 0.4837 1200.0n 0.4989 1799.5n 0.4989 1800.0n 0.4874 2399.5n 0.4874 2400.0n 0.4859 2999.5n 0.4859 3000.0n 0.4925 3599.5n 0.4925 3600.0n 0.4998 4199.5n 0.4998 4200.0n 0.4995 4799.5n 0.4995 4800.0n 0.4956 5399.5n 0.4956 5400.0n 0.4953 5999.5n 0.4953 6000.0n 0.4975 6599.5n 0.4975 6600.0n 0.4977 7199.5n 0.4977 7200.0n 0.4848 7799.5n 0.4848 7800.0n 0.4839 8399.5n 0.4839 8400.0n 0.5036 8999.5n 0.5036 9000.0n 0.4954 9599.5n 0.4954 9600.0n 0.4922 10199.5n 0.4922 10200.0n 0.4870 10799.5n 0.4870 10800.0n 0.5015 11399.5n 0.5015 11400.0n 0.4961 11999.5n 0.4961 12000.0n 0.5060 12599.5n 0.5060 12600.0n 0.4916 13199.5n 0.4916 13200.0n 0.4965 13799.5n 0.4965 13800.0n 0.4903 14399.5n 0.4903 14400.0n 0.4956 14999.5n 0.4956 15000.0n 0.4880 15599.5n 0.4880 15600.0n 0.4995 16199.5n 0.4995 16200.0n 0.4930 16799.5n 0.4930 16800.0n 0.5045 17399.5n 0.5045 17400.0n 0.4954 17999.5n 0.4954 18000.0n 0.5052 18599.5n 0.5052 18600.0n 0.4674 19199.5n 0.4674 19200.0n 0.4810 19799.5n 0.4810 19800.0n 0.4610 20399.5n 0.4610 20400.0n 0.4893 20999.5n 0.4893 21000.0n 0.5235 21599.5n 0.5235 21600.0n 0.4632 22199.5n 0.4632 22200.0n 0.4660 22799.5n 0.4660 22800.0n 0.4904 23399.5n 0.4904 23400.0n 0.4888 23999.5n 0.4888 24000.0n 0.4602 24599.5n 0.4602 24600.0n 0.4668 25199.5n 0.4668 25200.0n 0.4980 25799.5n 0.4980 25800.0n 0.5168 26399.5n 0.5168 26400.0n 0.4997 26999.5n 0.4997 27000.0n 0.5041 27599.5n 0.5041 27600.0n 0.4987 28199.5n 0.4987 28200.0n 0.4794 28799.5n 0.4794 28800.0n 0.4908 29399.5n 0.4908 29400.0n 0.5243 29999.5n 0.5243 30000.0n 0.5261 30599.5n 0.5261 30600.0n 0.5333 31199.5n 0.5333 31200.0n 0.5150 31799.5n 0.5150 31800.0n 0.5175 32399.5n 0.5175 32400.0n 0.5169 32999.5n 0.5169 33000.0n 0.4740 33599.5n 0.4740 33600.0n 0.4819 34199.5n 0.4819 34200.0n 0.4681 34799.5n 0.4681 34800.0n 0.5294 35399.5n 0.5294 35400.0n 0.4817 35999.5n 0.4817)
Vyp_who_30_0 yp_who_30_0 0 PWL(0.0n 0.5031 599.5n 0.5031 600.0n 0.5023 1199.5n 0.5023 1200.0n 0.5052 1799.5n 0.5052 1800.0n 0.5048 2399.5n 0.5048 2400.0n 0.5043 2999.5n 0.5043 3000.0n 0.5034 3599.5n 0.5034 3600.0n 0.5048 4199.5n 0.5048 4200.0n 0.5031 4799.5n 0.5031 4800.0n 0.5040 5399.5n 0.5040 5400.0n 0.5040 5999.5n 0.5040 6000.0n 0.5054 6599.5n 0.5054 6600.0n 0.5040 7199.5n 0.5040 7200.0n 0.5027 7799.5n 0.5027 7800.0n 0.5027 8399.5n 0.5027 8400.0n 0.5038 8999.5n 0.5038 9000.0n 0.5040 9599.5n 0.5040 9600.0n 0.5039 10199.5n 0.5039 10200.0n 0.5033 10799.5n 0.5033 10800.0n 0.5056 11399.5n 0.5056 11400.0n 0.5040 11999.5n 0.5040 12000.0n 0.5036 12599.5n 0.5036 12600.0n 0.5039 13199.5n 0.5039 13200.0n 0.5029 13799.5n 0.5029 13800.0n 0.5025 14399.5n 0.5025 14400.0n 0.5038 14999.5n 0.5038 15000.0n 0.5041 15599.5n 0.5041 15600.0n 0.5036 16199.5n 0.5036 16200.0n 0.5025 16799.5n 0.5025 16800.0n 0.5040 17399.5n 0.5040 17400.0n 0.5029 17999.5n 0.5029 18000.0n 0.5057 18599.5n 0.5057 18600.0n 0.5010 19199.5n 0.5010 19200.0n 0.5041 19799.5n 0.5041 19800.0n 0.5021 20399.5n 0.5021 20400.0n 0.5044 20999.5n 0.5044 21000.0n 0.5056 21599.5n 0.5056 21600.0n 0.5016 22199.5n 0.5016 22200.0n 0.5006 22799.5n 0.5006 22800.0n 0.5041 23399.5n 0.5041 23400.0n 0.5027 23999.5n 0.5027 24000.0n 0.5029 24599.5n 0.5029 24600.0n 0.5006 25199.5n 0.5006 25200.0n 0.5047 25799.5n 0.5047 25800.0n 0.5046 26399.5n 0.5046 26400.0n 0.5039 26999.5n 0.5039 27000.0n 0.5049 27599.5n 0.5049 27600.0n 0.5039 28199.5n 0.5039 28200.0n 0.5017 28799.5n 0.5017 28800.0n 0.5042 29399.5n 0.5042 29400.0n 0.5056 29999.5n 0.5056 30000.0n 0.5051 30599.5n 0.5051 30600.0n 0.5039 31199.5n 0.5039 31200.0n 0.5033 31799.5n 0.5033 31800.0n 0.5049 32399.5n 0.5049 32400.0n 0.5045 32999.5n 0.5045 33000.0n 0.5036 33599.5n 0.5036 33600.0n 0.5042 34199.5n 0.5042 34200.0n 0.5012 34799.5n 0.5012 34800.0n 0.5036 35399.5n 0.5036 35400.0n 0.5042 35999.5n 0.5042)
Vyn_who_30_0 yn_who_30_0 0 PWL(0.0n 0.4969 599.5n 0.4969 600.0n 0.4977 1199.5n 0.4977 1200.0n 0.4948 1799.5n 0.4948 1800.0n 0.4952 2399.5n 0.4952 2400.0n 0.4957 2999.5n 0.4957 3000.0n 0.4966 3599.5n 0.4966 3600.0n 0.4952 4199.5n 0.4952 4200.0n 0.4969 4799.5n 0.4969 4800.0n 0.4960 5399.5n 0.4960 5400.0n 0.4960 5999.5n 0.4960 6000.0n 0.4946 6599.5n 0.4946 6600.0n 0.4960 7199.5n 0.4960 7200.0n 0.4973 7799.5n 0.4973 7800.0n 0.4973 8399.5n 0.4973 8400.0n 0.4962 8999.5n 0.4962 9000.0n 0.4960 9599.5n 0.4960 9600.0n 0.4961 10199.5n 0.4961 10200.0n 0.4967 10799.5n 0.4967 10800.0n 0.4944 11399.5n 0.4944 11400.0n 0.4960 11999.5n 0.4960 12000.0n 0.4964 12599.5n 0.4964 12600.0n 0.4961 13199.5n 0.4961 13200.0n 0.4971 13799.5n 0.4971 13800.0n 0.4975 14399.5n 0.4975 14400.0n 0.4962 14999.5n 0.4962 15000.0n 0.4959 15599.5n 0.4959 15600.0n 0.4964 16199.5n 0.4964 16200.0n 0.4975 16799.5n 0.4975 16800.0n 0.4960 17399.5n 0.4960 17400.0n 0.4971 17999.5n 0.4971 18000.0n 0.4943 18599.5n 0.4943 18600.0n 0.4990 19199.5n 0.4990 19200.0n 0.4959 19799.5n 0.4959 19800.0n 0.4979 20399.5n 0.4979 20400.0n 0.4956 20999.5n 0.4956 21000.0n 0.4944 21599.5n 0.4944 21600.0n 0.4984 22199.5n 0.4984 22200.0n 0.4994 22799.5n 0.4994 22800.0n 0.4959 23399.5n 0.4959 23400.0n 0.4973 23999.5n 0.4973 24000.0n 0.4971 24599.5n 0.4971 24600.0n 0.4994 25199.5n 0.4994 25200.0n 0.4953 25799.5n 0.4953 25800.0n 0.4954 26399.5n 0.4954 26400.0n 0.4961 26999.5n 0.4961 27000.0n 0.4951 27599.5n 0.4951 27600.0n 0.4961 28199.5n 0.4961 28200.0n 0.4983 28799.5n 0.4983 28800.0n 0.4958 29399.5n 0.4958 29400.0n 0.4944 29999.5n 0.4944 30000.0n 0.4949 30599.5n 0.4949 30600.0n 0.4961 31199.5n 0.4961 31200.0n 0.4967 31799.5n 0.4967 31800.0n 0.4951 32399.5n 0.4951 32400.0n 0.4955 32999.5n 0.4955 33000.0n 0.4964 33599.5n 0.4964 33600.0n 0.4958 34199.5n 0.4958 34200.0n 0.4988 34799.5n 0.4988 34800.0n 0.4964 35399.5n 0.4964 35400.0n 0.4958 35999.5n 0.4958)
Cwp_who_30_0 wp_who_30_0 0 400p
Cwn_who_30_0 wn_who_30_0 0 400p
Xu_who_30_0 xp_who_30_0 xn_who_30_0 yp_who_30_0 yn_who_30_0 wp_who_30_0 wn_who_30_0 vdd gbn gprod
Vxp_who_30_1 xp_who_30_1 0 PWL(0.0n 0.5020 599.5n 0.5020 600.0n 0.5163 1199.5n 0.5163 1200.0n 0.5011 1799.5n 0.5011 1800.0n 0.5126 2399.5n 0.5126 2400.0n 0.5141 2999.5n 0.5141 3000.0n 0.5075 3599.5n 0.5075 3600.0n 0.5002 4199.5n 0.5002 4200.0n 0.5005 4799.5n 0.5005 4800.0n 0.5044 5399.5n 0.5044 5400.0n 0.5047 5999.5n 0.5047 6000.0n 0.5025 6599.5n 0.5025 6600.0n 0.5023 7199.5n 0.5023 7200.0n 0.5152 7799.5n 0.5152 7800.0n 0.5161 8399.5n 0.5161 8400.0n 0.4964 8999.5n 0.4964 9000.0n 0.5046 9599.5n 0.5046 9600.0n 0.5078 10199.5n 0.5078 10200.0n 0.5130 10799.5n 0.5130 10800.0n 0.4985 11399.5n 0.4985 11400.0n 0.5039 11999.5n 0.5039 12000.0n 0.4940 12599.5n 0.4940 12600.0n 0.5084 13199.5n 0.5084 13200.0n 0.5035 13799.5n 0.5035 13800.0n 0.5097 14399.5n 0.5097 14400.0n 0.5044 14999.5n 0.5044 15000.0n 0.5120 15599.5n 0.5120 15600.0n 0.5005 16199.5n 0.5005 16200.0n 0.5070 16799.5n 0.5070 16800.0n 0.4955 17399.5n 0.4955 17400.0n 0.5046 17999.5n 0.5046 18000.0n 0.4948 18599.5n 0.4948 18600.0n 0.5326 19199.5n 0.5326 19200.0n 0.5190 19799.5n 0.5190 19800.0n 0.5390 20399.5n 0.5390 20400.0n 0.5107 20999.5n 0.5107 21000.0n 0.4765 21599.5n 0.4765 21600.0n 0.5368 22199.5n 0.5368 22200.0n 0.5340 22799.5n 0.5340 22800.0n 0.5096 23399.5n 0.5096 23400.0n 0.5112 23999.5n 0.5112 24000.0n 0.5398 24599.5n 0.5398 24600.0n 0.5332 25199.5n 0.5332 25200.0n 0.5020 25799.5n 0.5020 25800.0n 0.4832 26399.5n 0.4832 26400.0n 0.5003 26999.5n 0.5003 27000.0n 0.4959 27599.5n 0.4959 27600.0n 0.5013 28199.5n 0.5013 28200.0n 0.5206 28799.5n 0.5206 28800.0n 0.5092 29399.5n 0.5092 29400.0n 0.4757 29999.5n 0.4757 30000.0n 0.4739 30599.5n 0.4739 30600.0n 0.4667 31199.5n 0.4667 31200.0n 0.4850 31799.5n 0.4850 31800.0n 0.4825 32399.5n 0.4825 32400.0n 0.4831 32999.5n 0.4831 33000.0n 0.5260 33599.5n 0.5260 33600.0n 0.5181 34199.5n 0.5181 34200.0n 0.5319 34799.5n 0.5319 34800.0n 0.4706 35399.5n 0.4706 35400.0n 0.5183 35999.5n 0.5183)
Vxn_who_30_1 xn_who_30_1 0 PWL(0.0n 0.4980 599.5n 0.4980 600.0n 0.4837 1199.5n 0.4837 1200.0n 0.4989 1799.5n 0.4989 1800.0n 0.4874 2399.5n 0.4874 2400.0n 0.4859 2999.5n 0.4859 3000.0n 0.4925 3599.5n 0.4925 3600.0n 0.4998 4199.5n 0.4998 4200.0n 0.4995 4799.5n 0.4995 4800.0n 0.4956 5399.5n 0.4956 5400.0n 0.4953 5999.5n 0.4953 6000.0n 0.4975 6599.5n 0.4975 6600.0n 0.4977 7199.5n 0.4977 7200.0n 0.4848 7799.5n 0.4848 7800.0n 0.4839 8399.5n 0.4839 8400.0n 0.5036 8999.5n 0.5036 9000.0n 0.4954 9599.5n 0.4954 9600.0n 0.4922 10199.5n 0.4922 10200.0n 0.4870 10799.5n 0.4870 10800.0n 0.5015 11399.5n 0.5015 11400.0n 0.4961 11999.5n 0.4961 12000.0n 0.5060 12599.5n 0.5060 12600.0n 0.4916 13199.5n 0.4916 13200.0n 0.4965 13799.5n 0.4965 13800.0n 0.4903 14399.5n 0.4903 14400.0n 0.4956 14999.5n 0.4956 15000.0n 0.4880 15599.5n 0.4880 15600.0n 0.4995 16199.5n 0.4995 16200.0n 0.4930 16799.5n 0.4930 16800.0n 0.5045 17399.5n 0.5045 17400.0n 0.4954 17999.5n 0.4954 18000.0n 0.5052 18599.5n 0.5052 18600.0n 0.4674 19199.5n 0.4674 19200.0n 0.4810 19799.5n 0.4810 19800.0n 0.4610 20399.5n 0.4610 20400.0n 0.4893 20999.5n 0.4893 21000.0n 0.5235 21599.5n 0.5235 21600.0n 0.4632 22199.5n 0.4632 22200.0n 0.4660 22799.5n 0.4660 22800.0n 0.4904 23399.5n 0.4904 23400.0n 0.4888 23999.5n 0.4888 24000.0n 0.4602 24599.5n 0.4602 24600.0n 0.4668 25199.5n 0.4668 25200.0n 0.4980 25799.5n 0.4980 25800.0n 0.5168 26399.5n 0.5168 26400.0n 0.4997 26999.5n 0.4997 27000.0n 0.5041 27599.5n 0.5041 27600.0n 0.4987 28199.5n 0.4987 28200.0n 0.4794 28799.5n 0.4794 28800.0n 0.4908 29399.5n 0.4908 29400.0n 0.5243 29999.5n 0.5243 30000.0n 0.5261 30599.5n 0.5261 30600.0n 0.5333 31199.5n 0.5333 31200.0n 0.5150 31799.5n 0.5150 31800.0n 0.5175 32399.5n 0.5175 32400.0n 0.5169 32999.5n 0.5169 33000.0n 0.4740 33599.5n 0.4740 33600.0n 0.4819 34199.5n 0.4819 34200.0n 0.4681 34799.5n 0.4681 34800.0n 0.5294 35399.5n 0.5294 35400.0n 0.4817 35999.5n 0.4817)
Vyp_who_30_1 yp_who_30_1 0 PWL(0.0n 0.5071 599.5n 0.5071 600.0n 0.5053 1199.5n 0.5053 1200.0n 0.5052 1799.5n 0.5052 1800.0n 0.5027 2399.5n 0.5027 2400.0n 0.5034 2999.5n 0.5034 3000.0n 0.5055 3599.5n 0.5055 3600.0n 0.5056 4199.5n 0.5056 4200.0n 0.5071 4799.5n 0.5071 4800.0n 0.5056 5399.5n 0.5056 5400.0n 0.5056 5999.5n 0.5056 6000.0n 0.5048 6599.5n 0.5048 6600.0n 0.5060 7199.5n 0.5060 7200.0n 0.5048 7799.5n 0.5048 7800.0n 0.5046 8399.5n 0.5046 8400.0n 0.5066 8999.5n 0.5066 9000.0n 0.5056 9599.5n 0.5056 9600.0n 0.5051 10199.5n 0.5051 10200.0n 0.5046 10799.5n 0.5046 10800.0n 0.5056 11399.5n 0.5056 11400.0n 0.5058 11999.5n 0.5058 12000.0n 0.5068 12599.5n 0.5068 12600.0n 0.5050 13199.5n 0.5050 13200.0n 0.5071 13799.5n 0.5071 13800.0n 0.5059 14399.5n 0.5059 14400.0n 0.5058 14999.5n 0.5058 15000.0n 0.5043 15599.5n 0.5043 15600.0n 0.5067 16199.5n 0.5067 16200.0n 0.5068 16799.5n 0.5068 16800.0n 0.5066 17399.5n 0.5066 17400.0n 0.5069 17999.5n 0.5069 18000.0n 0.5061 18599.5n 0.5061 18600.0n 0.5034 19199.5n 0.5034 19200.0n 0.5010 19799.5n 0.5010 19800.0n 0.4989 20399.5n 0.4989 20400.0n 0.5022 20999.5n 0.5022 21000.0n 0.5086 21599.5n 0.5086 21600.0n 0.5007 22199.5n 0.5007 22200.0n 0.5023 22799.5n 0.5023 22800.0n 0.5021 23399.5n 0.5021 23400.0n 0.5077 23999.5n 0.5077 24000.0n 0.4979 24599.5n 0.4979 24600.0n 0.5035 25199.5n 0.5035 25200.0n 0.5041 25799.5n 0.5041 25800.0n 0.5075 26399.5n 0.5075 26400.0n 0.5041 26999.5n 0.5041 27000.0n 0.5056 27599.5n 0.5056 27600.0n 0.5039 28199.5n 0.5039 28200.0n 0.5059 28799.5n 0.5059 28800.0n 0.5023 29399.5n 0.5023 29400.0n 0.5086 29999.5n 0.5086 30000.0n 0.5084 30599.5n 0.5084 30600.0n 0.5085 31199.5n 0.5085 31200.0n 0.5088 31799.5n 0.5088 31800.0n 0.5078 32399.5n 0.5078 32400.0n 0.5074 32999.5n 0.5074 33000.0n 0.4996 33599.5n 0.4996 33600.0n 0.5010 34199.5n 0.5010 34200.0n 0.5044 34799.5n 0.5044 34800.0n 0.5084 35399.5n 0.5084 35400.0n 0.5012 35999.5n 0.5012)
Vyn_who_30_1 yn_who_30_1 0 PWL(0.0n 0.4929 599.5n 0.4929 600.0n 0.4947 1199.5n 0.4947 1200.0n 0.4948 1799.5n 0.4948 1800.0n 0.4973 2399.5n 0.4973 2400.0n 0.4966 2999.5n 0.4966 3000.0n 0.4945 3599.5n 0.4945 3600.0n 0.4944 4199.5n 0.4944 4200.0n 0.4929 4799.5n 0.4929 4800.0n 0.4944 5399.5n 0.4944 5400.0n 0.4944 5999.5n 0.4944 6000.0n 0.4952 6599.5n 0.4952 6600.0n 0.4940 7199.5n 0.4940 7200.0n 0.4952 7799.5n 0.4952 7800.0n 0.4954 8399.5n 0.4954 8400.0n 0.4934 8999.5n 0.4934 9000.0n 0.4944 9599.5n 0.4944 9600.0n 0.4949 10199.5n 0.4949 10200.0n 0.4954 10799.5n 0.4954 10800.0n 0.4944 11399.5n 0.4944 11400.0n 0.4942 11999.5n 0.4942 12000.0n 0.4932 12599.5n 0.4932 12600.0n 0.4950 13199.5n 0.4950 13200.0n 0.4929 13799.5n 0.4929 13800.0n 0.4941 14399.5n 0.4941 14400.0n 0.4942 14999.5n 0.4942 15000.0n 0.4957 15599.5n 0.4957 15600.0n 0.4933 16199.5n 0.4933 16200.0n 0.4932 16799.5n 0.4932 16800.0n 0.4934 17399.5n 0.4934 17400.0n 0.4931 17999.5n 0.4931 18000.0n 0.4939 18599.5n 0.4939 18600.0n 0.4966 19199.5n 0.4966 19200.0n 0.4990 19799.5n 0.4990 19800.0n 0.5011 20399.5n 0.5011 20400.0n 0.4978 20999.5n 0.4978 21000.0n 0.4914 21599.5n 0.4914 21600.0n 0.4993 22199.5n 0.4993 22200.0n 0.4977 22799.5n 0.4977 22800.0n 0.4979 23399.5n 0.4979 23400.0n 0.4923 23999.5n 0.4923 24000.0n 0.5021 24599.5n 0.5021 24600.0n 0.4965 25199.5n 0.4965 25200.0n 0.4959 25799.5n 0.4959 25800.0n 0.4925 26399.5n 0.4925 26400.0n 0.4959 26999.5n 0.4959 27000.0n 0.4944 27599.5n 0.4944 27600.0n 0.4961 28199.5n 0.4961 28200.0n 0.4941 28799.5n 0.4941 28800.0n 0.4977 29399.5n 0.4977 29400.0n 0.4914 29999.5n 0.4914 30000.0n 0.4916 30599.5n 0.4916 30600.0n 0.4915 31199.5n 0.4915 31200.0n 0.4912 31799.5n 0.4912 31800.0n 0.4922 32399.5n 0.4922 32400.0n 0.4926 32999.5n 0.4926 33000.0n 0.5004 33599.5n 0.5004 33600.0n 0.4990 34199.5n 0.4990 34200.0n 0.4956 34799.5n 0.4956 34800.0n 0.4916 35399.5n 0.4916 35400.0n 0.4988 35999.5n 0.4988)
Cwp_who_30_1 wp_who_30_1 0 400p
Cwn_who_30_1 wn_who_30_1 0 400p
Xu_who_30_1 xp_who_30_1 xn_who_30_1 yp_who_30_1 yn_who_30_1 wp_who_30_1 wn_who_30_1 vdd gbn gprod
Vxp_bh_30 xp_bh_30 0 PWL(0.0n 0.7100 599.5n 0.7100 600.0n 0.7100 1199.5n 0.7100 1200.0n 0.7100 1799.5n 0.7100 1800.0n 0.7100 2399.5n 0.7100 2400.0n 0.7100 2999.5n 0.7100 3000.0n 0.7100 3599.5n 0.7100 3600.0n 0.7100 4199.5n 0.7100 4200.0n 0.7100 4799.5n 0.7100 4800.0n 0.7100 5399.5n 0.7100 5400.0n 0.7100 5999.5n 0.7100 6000.0n 0.7100 6599.5n 0.7100 6600.0n 0.7100 7199.5n 0.7100 7200.0n 0.7100 7799.5n 0.7100 7800.0n 0.7100 8399.5n 0.7100 8400.0n 0.7100 8999.5n 0.7100 9000.0n 0.7100 9599.5n 0.7100 9600.0n 0.7100 10199.5n 0.7100 10200.0n 0.7100 10799.5n 0.7100 10800.0n 0.7100 11399.5n 0.7100 11400.0n 0.7100 11999.5n 0.7100 12000.0n 0.7100 12599.5n 0.7100 12600.0n 0.7100 13199.5n 0.7100 13200.0n 0.7100 13799.5n 0.7100 13800.0n 0.7100 14399.5n 0.7100 14400.0n 0.7100 14999.5n 0.7100 15000.0n 0.7100 15599.5n 0.7100 15600.0n 0.7100 16199.5n 0.7100 16200.0n 0.7100 16799.5n 0.7100 16800.0n 0.7100 17399.5n 0.7100 17400.0n 0.7100 17999.5n 0.7100 18000.0n 0.7100 18599.5n 0.7100 18600.0n 0.7100 19199.5n 0.7100 19200.0n 0.7100 19799.5n 0.7100 19800.0n 0.7100 20399.5n 0.7100 20400.0n 0.7100 20999.5n 0.7100 21000.0n 0.7100 21599.5n 0.7100 21600.0n 0.7100 22199.5n 0.7100 22200.0n 0.7100 22799.5n 0.7100 22800.0n 0.7100 23399.5n 0.7100 23400.0n 0.7100 23999.5n 0.7100 24000.0n 0.7100 24599.5n 0.7100 24600.0n 0.7100 25199.5n 0.7100 25200.0n 0.7100 25799.5n 0.7100 25800.0n 0.7100 26399.5n 0.7100 26400.0n 0.7100 26999.5n 0.7100 27000.0n 0.7100 27599.5n 0.7100 27600.0n 0.7100 28199.5n 0.7100 28200.0n 0.7100 28799.5n 0.7100 28800.0n 0.7100 29399.5n 0.7100 29400.0n 0.7100 29999.5n 0.7100 30000.0n 0.7100 30599.5n 0.7100 30600.0n 0.7100 31199.5n 0.7100 31200.0n 0.7100 31799.5n 0.7100 31800.0n 0.7100 32399.5n 0.7100 32400.0n 0.7100 32999.5n 0.7100 33000.0n 0.7100 33599.5n 0.7100 33600.0n 0.7100 34199.5n 0.7100 34200.0n 0.7100 34799.5n 0.7100 34800.0n 0.7100 35399.5n 0.7100 35400.0n 0.7100 35999.5n 0.7100)
Vxn_bh_30 xn_bh_30 0 PWL(0.0n 0.2900 599.5n 0.2900 600.0n 0.2900 1199.5n 0.2900 1200.0n 0.2900 1799.5n 0.2900 1800.0n 0.2900 2399.5n 0.2900 2400.0n 0.2900 2999.5n 0.2900 3000.0n 0.2900 3599.5n 0.2900 3600.0n 0.2900 4199.5n 0.2900 4200.0n 0.2900 4799.5n 0.2900 4800.0n 0.2900 5399.5n 0.2900 5400.0n 0.2900 5999.5n 0.2900 6000.0n 0.2900 6599.5n 0.2900 6600.0n 0.2900 7199.5n 0.2900 7200.0n 0.2900 7799.5n 0.2900 7800.0n 0.2900 8399.5n 0.2900 8400.0n 0.2900 8999.5n 0.2900 9000.0n 0.2900 9599.5n 0.2900 9600.0n 0.2900 10199.5n 0.2900 10200.0n 0.2900 10799.5n 0.2900 10800.0n 0.2900 11399.5n 0.2900 11400.0n 0.2900 11999.5n 0.2900 12000.0n 0.2900 12599.5n 0.2900 12600.0n 0.2900 13199.5n 0.2900 13200.0n 0.2900 13799.5n 0.2900 13800.0n 0.2900 14399.5n 0.2900 14400.0n 0.2900 14999.5n 0.2900 15000.0n 0.2900 15599.5n 0.2900 15600.0n 0.2900 16199.5n 0.2900 16200.0n 0.2900 16799.5n 0.2900 16800.0n 0.2900 17399.5n 0.2900 17400.0n 0.2900 17999.5n 0.2900 18000.0n 0.2900 18599.5n 0.2900 18600.0n 0.2900 19199.5n 0.2900 19200.0n 0.2900 19799.5n 0.2900 19800.0n 0.2900 20399.5n 0.2900 20400.0n 0.2900 20999.5n 0.2900 21000.0n 0.2900 21599.5n 0.2900 21600.0n 0.2900 22199.5n 0.2900 22200.0n 0.2900 22799.5n 0.2900 22800.0n 0.2900 23399.5n 0.2900 23400.0n 0.2900 23999.5n 0.2900 24000.0n 0.2900 24599.5n 0.2900 24600.0n 0.2900 25199.5n 0.2900 25200.0n 0.2900 25799.5n 0.2900 25800.0n 0.2900 26399.5n 0.2900 26400.0n 0.2900 26999.5n 0.2900 27000.0n 0.2900 27599.5n 0.2900 27600.0n 0.2900 28199.5n 0.2900 28200.0n 0.2900 28799.5n 0.2900 28800.0n 0.2900 29399.5n 0.2900 29400.0n 0.2900 29999.5n 0.2900 30000.0n 0.2900 30599.5n 0.2900 30600.0n 0.2900 31199.5n 0.2900 31200.0n 0.2900 31799.5n 0.2900 31800.0n 0.2900 32399.5n 0.2900 32400.0n 0.2900 32999.5n 0.2900 33000.0n 0.2900 33599.5n 0.2900 33600.0n 0.2900 34199.5n 0.2900 34200.0n 0.2900 34799.5n 0.2900 34800.0n 0.2900 35399.5n 0.2900 35400.0n 0.2900 35999.5n 0.2900)
Vyp_bh_30 yp_bh_30 0 PWL(0.0n 0.5020 599.5n 0.5020 600.0n 0.5163 1199.5n 0.5163 1200.0n 0.5011 1799.5n 0.5011 1800.0n 0.5126 2399.5n 0.5126 2400.0n 0.5141 2999.5n 0.5141 3000.0n 0.5075 3599.5n 0.5075 3600.0n 0.5002 4199.5n 0.5002 4200.0n 0.5005 4799.5n 0.5005 4800.0n 0.5044 5399.5n 0.5044 5400.0n 0.5047 5999.5n 0.5047 6000.0n 0.5025 6599.5n 0.5025 6600.0n 0.5023 7199.5n 0.5023 7200.0n 0.5152 7799.5n 0.5152 7800.0n 0.5161 8399.5n 0.5161 8400.0n 0.4964 8999.5n 0.4964 9000.0n 0.5046 9599.5n 0.5046 9600.0n 0.5078 10199.5n 0.5078 10200.0n 0.5130 10799.5n 0.5130 10800.0n 0.4985 11399.5n 0.4985 11400.0n 0.5039 11999.5n 0.5039 12000.0n 0.4940 12599.5n 0.4940 12600.0n 0.5084 13199.5n 0.5084 13200.0n 0.5035 13799.5n 0.5035 13800.0n 0.5097 14399.5n 0.5097 14400.0n 0.5044 14999.5n 0.5044 15000.0n 0.5120 15599.5n 0.5120 15600.0n 0.5005 16199.5n 0.5005 16200.0n 0.5070 16799.5n 0.5070 16800.0n 0.4955 17399.5n 0.4955 17400.0n 0.5046 17999.5n 0.5046 18000.0n 0.4948 18599.5n 0.4948 18600.0n 0.5326 19199.5n 0.5326 19200.0n 0.5190 19799.5n 0.5190 19800.0n 0.5390 20399.5n 0.5390 20400.0n 0.5107 20999.5n 0.5107 21000.0n 0.4765 21599.5n 0.4765 21600.0n 0.5368 22199.5n 0.5368 22200.0n 0.5340 22799.5n 0.5340 22800.0n 0.5096 23399.5n 0.5096 23400.0n 0.5112 23999.5n 0.5112 24000.0n 0.5398 24599.5n 0.5398 24600.0n 0.5332 25199.5n 0.5332 25200.0n 0.5020 25799.5n 0.5020 25800.0n 0.4832 26399.5n 0.4832 26400.0n 0.5003 26999.5n 0.5003 27000.0n 0.4959 27599.5n 0.4959 27600.0n 0.5013 28199.5n 0.5013 28200.0n 0.5206 28799.5n 0.5206 28800.0n 0.5092 29399.5n 0.5092 29400.0n 0.4757 29999.5n 0.4757 30000.0n 0.4739 30599.5n 0.4739 30600.0n 0.4667 31199.5n 0.4667 31200.0n 0.4850 31799.5n 0.4850 31800.0n 0.4825 32399.5n 0.4825 32400.0n 0.4831 32999.5n 0.4831 33000.0n 0.5260 33599.5n 0.5260 33600.0n 0.5181 34199.5n 0.5181 34200.0n 0.5319 34799.5n 0.5319 34800.0n 0.4706 35399.5n 0.4706 35400.0n 0.5183 35999.5n 0.5183)
Vyn_bh_30 yn_bh_30 0 PWL(0.0n 0.4980 599.5n 0.4980 600.0n 0.4837 1199.5n 0.4837 1200.0n 0.4989 1799.5n 0.4989 1800.0n 0.4874 2399.5n 0.4874 2400.0n 0.4859 2999.5n 0.4859 3000.0n 0.4925 3599.5n 0.4925 3600.0n 0.4998 4199.5n 0.4998 4200.0n 0.4995 4799.5n 0.4995 4800.0n 0.4956 5399.5n 0.4956 5400.0n 0.4953 5999.5n 0.4953 6000.0n 0.4975 6599.5n 0.4975 6600.0n 0.4977 7199.5n 0.4977 7200.0n 0.4848 7799.5n 0.4848 7800.0n 0.4839 8399.5n 0.4839 8400.0n 0.5036 8999.5n 0.5036 9000.0n 0.4954 9599.5n 0.4954 9600.0n 0.4922 10199.5n 0.4922 10200.0n 0.4870 10799.5n 0.4870 10800.0n 0.5015 11399.5n 0.5015 11400.0n 0.4961 11999.5n 0.4961 12000.0n 0.5060 12599.5n 0.5060 12600.0n 0.4916 13199.5n 0.4916 13200.0n 0.4965 13799.5n 0.4965 13800.0n 0.4903 14399.5n 0.4903 14400.0n 0.4956 14999.5n 0.4956 15000.0n 0.4880 15599.5n 0.4880 15600.0n 0.4995 16199.5n 0.4995 16200.0n 0.4930 16799.5n 0.4930 16800.0n 0.5045 17399.5n 0.5045 17400.0n 0.4954 17999.5n 0.4954 18000.0n 0.5052 18599.5n 0.5052 18600.0n 0.4674 19199.5n 0.4674 19200.0n 0.4810 19799.5n 0.4810 19800.0n 0.4610 20399.5n 0.4610 20400.0n 0.4893 20999.5n 0.4893 21000.0n 0.5235 21599.5n 0.5235 21600.0n 0.4632 22199.5n 0.4632 22200.0n 0.4660 22799.5n 0.4660 22800.0n 0.4904 23399.5n 0.4904 23400.0n 0.4888 23999.5n 0.4888 24000.0n 0.4602 24599.5n 0.4602 24600.0n 0.4668 25199.5n 0.4668 25200.0n 0.4980 25799.5n 0.4980 25800.0n 0.5168 26399.5n 0.5168 26400.0n 0.4997 26999.5n 0.4997 27000.0n 0.5041 27599.5n 0.5041 27600.0n 0.4987 28199.5n 0.4987 28200.0n 0.4794 28799.5n 0.4794 28800.0n 0.4908 29399.5n 0.4908 29400.0n 0.5243 29999.5n 0.5243 30000.0n 0.5261 30599.5n 0.5261 30600.0n 0.5333 31199.5n 0.5333 31200.0n 0.5150 31799.5n 0.5150 31800.0n 0.5175 32399.5n 0.5175 32400.0n 0.5169 32999.5n 0.5169 33000.0n 0.4740 33599.5n 0.4740 33600.0n 0.4819 34199.5n 0.4819 34200.0n 0.4681 34799.5n 0.4681 34800.0n 0.5294 35399.5n 0.5294 35400.0n 0.4817 35999.5n 0.4817)
Cwp_bh_30 wp_bh_30 0 400p
Cwn_bh_30 wn_bh_30 0 400p
Xu_bh_30 xp_bh_30 xn_bh_30 yp_bh_30 yn_bh_30 wp_bh_30 wn_bh_30 vdd gbn gprod
Vxp_wih_0_31 xp_wih_0_31 0 PWL(0.0n 0.4942 599.5n 0.4942 600.0n 0.5558 1199.5n 0.5558 1200.0n 0.4708 1799.5n 0.4708 1800.0n 0.5235 2399.5n 0.5235 2400.0n 0.5350 2999.5n 0.5350 3000.0n 0.5172 3599.5n 0.5172 3600.0n 0.4702 4199.5n 0.4702 4200.0n 0.4867 4799.5n 0.4867 4800.0n 0.4970 5399.5n 0.4970 5400.0n 0.4986 5999.5n 0.4986 6000.0n 0.4751 6599.5n 0.4751 6600.0n 0.4870 7199.5n 0.4870 7200.0n 0.5502 7799.5n 0.5502 7800.0n 0.5521 8399.5n 0.5521 8400.0n 0.4638 8999.5n 0.4638 9000.0n 0.4982 9599.5n 0.4982 9600.0n 0.5131 10199.5n 0.5131 10200.0n 0.5386 10799.5n 0.5386 10800.0n 0.4592 11399.5n 0.4592 11400.0n 0.4950 11999.5n 0.4950 12000.0n 0.4559 12599.5n 0.4559 12600.0n 0.5162 13199.5n 0.5162 13200.0n 0.5038 13799.5n 0.5038 13800.0n 0.5333 14399.5n 0.5333 14400.0n 0.4991 14999.5n 0.4991 15000.0n 0.5298 15599.5n 0.5298 15600.0n 0.4823 16199.5n 0.4823 16200.0n 0.5239 16799.5n 0.5239 16800.0n 0.4592 17399.5n 0.4592 17400.0n 0.5094 17999.5n 0.5094 18000.0n 0.4337 18599.5n 0.4337 18600.0n 0.5977 19199.5n 0.5977 19200.0n 0.5364 19799.5n 0.5364 19800.0n 0.6122 20399.5n 0.6122 20400.0n 0.4856 20999.5n 0.4856 21000.0n 0.3861 21599.5n 0.3861 21600.0n 0.6094 22199.5n 0.6094 22200.0n 0.6364 22799.5n 0.6364 22800.0n 0.4807 23399.5n 0.4807 23400.0n 0.5614 23999.5n 0.5614 24000.0n 0.5913 24599.5n 0.5913 24600.0n 0.6295 25199.5n 0.6295 25200.0n 0.4496 25799.5n 0.4496 25800.0n 0.3792 26399.5n 0.3792 26400.0n 0.4434 26999.5n 0.4434 27000.0n 0.4340 27599.5n 0.4340 27600.0n 0.4461 28199.5n 0.4461 28200.0n 0.5791 28799.5n 0.5791 28800.0n 0.4777 29399.5n 0.4777 29400.0n 0.3878 29999.5n 0.3878 30000.0n 0.3832 30599.5n 0.3832 30600.0n 0.4022 31199.5n 0.4022 31200.0n 0.4482 31799.5n 0.4482 31800.0n 0.3662 32399.5n 0.3662 32400.0n 0.3857 32999.5n 0.3857 33000.0n 0.5584 33599.5n 0.5584 33600.0n 0.5284 34199.5n 0.5284 34200.0n 0.6034 34799.5n 0.6034 34800.0n 0.3469 35399.5n 0.3469 35400.0n 0.5290 35999.5n 0.5290)
Vxn_wih_0_31 xn_wih_0_31 0 PWL(0.0n 0.5058 599.5n 0.5058 600.0n 0.4442 1199.5n 0.4442 1200.0n 0.5292 1799.5n 0.5292 1800.0n 0.4765 2399.5n 0.4765 2400.0n 0.4650 2999.5n 0.4650 3000.0n 0.4828 3599.5n 0.4828 3600.0n 0.5298 4199.5n 0.5298 4200.0n 0.5133 4799.5n 0.5133 4800.0n 0.5030 5399.5n 0.5030 5400.0n 0.5014 5999.5n 0.5014 6000.0n 0.5249 6599.5n 0.5249 6600.0n 0.5130 7199.5n 0.5130 7200.0n 0.4498 7799.5n 0.4498 7800.0n 0.4479 8399.5n 0.4479 8400.0n 0.5362 8999.5n 0.5362 9000.0n 0.5018 9599.5n 0.5018 9600.0n 0.4869 10199.5n 0.4869 10200.0n 0.4614 10799.5n 0.4614 10800.0n 0.5408 11399.5n 0.5408 11400.0n 0.5050 11999.5n 0.5050 12000.0n 0.5441 12599.5n 0.5441 12600.0n 0.4838 13199.5n 0.4838 13200.0n 0.4962 13799.5n 0.4962 13800.0n 0.4667 14399.5n 0.4667 14400.0n 0.5009 14999.5n 0.5009 15000.0n 0.4702 15599.5n 0.4702 15600.0n 0.5177 16199.5n 0.5177 16200.0n 0.4761 16799.5n 0.4761 16800.0n 0.5408 17399.5n 0.5408 17400.0n 0.4906 17999.5n 0.4906 18000.0n 0.5663 18599.5n 0.5663 18600.0n 0.4023 19199.5n 0.4023 19200.0n 0.4636 19799.5n 0.4636 19800.0n 0.3878 20399.5n 0.3878 20400.0n 0.5144 20999.5n 0.5144 21000.0n 0.6139 21599.5n 0.6139 21600.0n 0.3906 22199.5n 0.3906 22200.0n 0.3636 22799.5n 0.3636 22800.0n 0.5193 23399.5n 0.5193 23400.0n 0.4386 23999.5n 0.4386 24000.0n 0.4087 24599.5n 0.4087 24600.0n 0.3705 25199.5n 0.3705 25200.0n 0.5504 25799.5n 0.5504 25800.0n 0.6208 26399.5n 0.6208 26400.0n 0.5566 26999.5n 0.5566 27000.0n 0.5660 27599.5n 0.5660 27600.0n 0.5539 28199.5n 0.5539 28200.0n 0.4209 28799.5n 0.4209 28800.0n 0.5223 29399.5n 0.5223 29400.0n 0.6122 29999.5n 0.6122 30000.0n 0.6168 30599.5n 0.6168 30600.0n 0.5978 31199.5n 0.5978 31200.0n 0.5518 31799.5n 0.5518 31800.0n 0.6338 32399.5n 0.6338 32400.0n 0.6143 32999.5n 0.6143 33000.0n 0.4416 33599.5n 0.4416 33600.0n 0.4716 34199.5n 0.4716 34200.0n 0.3966 34799.5n 0.3966 34800.0n 0.6531 35399.5n 0.6531 35400.0n 0.4710 35999.5n 0.4710)
Vyp_wih_0_31 yp_wih_0_31 0 PWL(0.0n 0.6706 599.5n 0.6706 600.0n 0.6817 1199.5n 0.6817 1200.0n 0.6683 1799.5n 0.6683 1800.0n 0.6778 2399.5n 0.6778 2400.0n 0.6790 2999.5n 0.6790 3000.0n 0.6745 3599.5n 0.6745 3600.0n 0.6677 4199.5n 0.6677 4200.0n 0.6694 4799.5n 0.6694 4800.0n 0.6717 5399.5n 0.6717 5400.0n 0.6720 5999.5n 0.6720 6000.0n 0.6694 6599.5n 0.6694 6600.0n 0.6701 7199.5n 0.6701 7200.0n 0.6806 7799.5n 0.6806 7800.0n 0.6812 8399.5n 0.6812 8400.0n 0.6651 8999.5n 0.6651 9000.0n 0.6719 9599.5n 0.6719 9600.0n 0.6743 10199.5n 0.6743 10200.0n 0.6786 10799.5n 0.6786 10800.0n 0.6655 11399.5n 0.6655 11400.0n 0.6715 11999.5n 0.6715 12000.0n 0.6627 12599.5n 0.6627 12600.0n 0.6748 13199.5n 0.6748 13200.0n 0.6720 13799.5n 0.6720 13800.0n 0.6768 14399.5n 0.6768 14400.0n 0.6719 14999.5n 0.6719 15000.0n 0.6775 15599.5n 0.6775 15600.0n 0.6690 16199.5n 0.6690 16200.0n 0.6750 16799.5n 0.6750 16800.0n 0.6639 17399.5n 0.6639 17400.0n 0.6729 17999.5n 0.6729 18000.0n 0.6606 18599.5n 0.6606 18600.0n 0.6890 19199.5n 0.6890 19200.0n 0.6822 19799.5n 0.6822 19800.0n 0.6930 20399.5n 0.6930 20400.0n 0.6756 20999.5n 0.6756 21000.0n 0.6230 21599.5n 0.6230 21600.0n 0.6916 22199.5n 0.6916 22200.0n 0.6920 22799.5n 0.6920 22800.0n 0.6752 23399.5n 0.6752 23400.0n 0.6812 23999.5n 0.6812 24000.0n 0.6929 24599.5n 0.6929 24600.0n 0.6914 25199.5n 0.6914 25200.0n 0.6683 25799.5n 0.6683 25800.0n 0.6416 26399.5n 0.6416 26400.0n 0.6668 26999.5n 0.6668 27000.0n 0.6621 27599.5n 0.6621 27600.0n 0.6678 28199.5n 0.6678 28200.0n 0.6851 28799.5n 0.6851 28800.0n 0.6748 29399.5n 0.6748 29400.0n 0.6215 29999.5n 0.6215 30000.0n 0.6139 30599.5n 0.6139 30600.0n 0.5949 31199.5n 0.5949 31200.0n 0.6529 31799.5n 0.6529 31800.0n 0.6329 32399.5n 0.6329 32400.0n 0.6452 32999.5n 0.6452 33000.0n 0.6872 33599.5n 0.6872 33600.0n 0.6815 34199.5n 0.6815 34200.0n 0.6892 34799.5n 0.6892 34800.0n 0.5892 35399.5n 0.5892 35400.0n 0.6814 35999.5n 0.6814)
Vyn_wih_0_31 yn_wih_0_31 0 PWL(0.0n 0.3294 599.5n 0.3294 600.0n 0.3183 1199.5n 0.3183 1200.0n 0.3317 1799.5n 0.3317 1800.0n 0.3222 2399.5n 0.3222 2400.0n 0.3210 2999.5n 0.3210 3000.0n 0.3255 3599.5n 0.3255 3600.0n 0.3323 4199.5n 0.3323 4200.0n 0.3306 4799.5n 0.3306 4800.0n 0.3283 5399.5n 0.3283 5400.0n 0.3280 5999.5n 0.3280 6000.0n 0.3306 6599.5n 0.3306 6600.0n 0.3299 7199.5n 0.3299 7200.0n 0.3194 7799.5n 0.3194 7800.0n 0.3188 8399.5n 0.3188 8400.0n 0.3349 8999.5n 0.3349 9000.0n 0.3281 9599.5n 0.3281 9600.0n 0.3257 10199.5n 0.3257 10200.0n 0.3214 10799.5n 0.3214 10800.0n 0.3345 11399.5n 0.3345 11400.0n 0.3285 11999.5n 0.3285 12000.0n 0.3373 12599.5n 0.3373 12600.0n 0.3252 13199.5n 0.3252 13200.0n 0.3280 13799.5n 0.3280 13800.0n 0.3232 14399.5n 0.3232 14400.0n 0.3281 14999.5n 0.3281 15000.0n 0.3225 15599.5n 0.3225 15600.0n 0.3310 16199.5n 0.3310 16200.0n 0.3250 16799.5n 0.3250 16800.0n 0.3361 17399.5n 0.3361 17400.0n 0.3271 17999.5n 0.3271 18000.0n 0.3394 18599.5n 0.3394 18600.0n 0.3110 19199.5n 0.3110 19200.0n 0.3178 19799.5n 0.3178 19800.0n 0.3070 20399.5n 0.3070 20400.0n 0.3244 20999.5n 0.3244 21000.0n 0.3770 21599.5n 0.3770 21600.0n 0.3084 22199.5n 0.3084 22200.0n 0.3080 22799.5n 0.3080 22800.0n 0.3248 23399.5n 0.3248 23400.0n 0.3188 23999.5n 0.3188 24000.0n 0.3071 24599.5n 0.3071 24600.0n 0.3086 25199.5n 0.3086 25200.0n 0.3317 25799.5n 0.3317 25800.0n 0.3584 26399.5n 0.3584 26400.0n 0.3332 26999.5n 0.3332 27000.0n 0.3379 27599.5n 0.3379 27600.0n 0.3322 28199.5n 0.3322 28200.0n 0.3149 28799.5n 0.3149 28800.0n 0.3252 29399.5n 0.3252 29400.0n 0.3785 29999.5n 0.3785 30000.0n 0.3861 30599.5n 0.3861 30600.0n 0.4051 31199.5n 0.4051 31200.0n 0.3471 31799.5n 0.3471 31800.0n 0.3671 32399.5n 0.3671 32400.0n 0.3548 32999.5n 0.3548 33000.0n 0.3128 33599.5n 0.3128 33600.0n 0.3185 34199.5n 0.3185 34200.0n 0.3108 34799.5n 0.3108 34800.0n 0.4108 35399.5n 0.4108 35400.0n 0.3186 35999.5n 0.3186)
Cwp_wih_0_31 wp_wih_0_31 0 400p
Cwn_wih_0_31 wn_wih_0_31 0 400p
Xu_wih_0_31 xp_wih_0_31 xn_wih_0_31 yp_wih_0_31 yn_wih_0_31 wp_wih_0_31 wn_wih_0_31 vdd gbn gprod
Vxp_wih_1_31 xp_wih_1_31 0 PWL(0.0n 0.5370 599.5n 0.5370 600.0n 0.5167 1199.5n 0.5167 1200.0n 0.4793 1799.5n 0.4793 1800.0n 0.4441 2399.5n 0.4441 2400.0n 0.4555 2999.5n 0.4555 3000.0n 0.5055 3599.5n 0.5055 3600.0n 0.4939 4199.5n 0.4939 4200.0n 0.5385 4799.5n 0.5385 4800.0n 0.5024 5399.5n 0.5024 5400.0n 0.5015 5999.5n 0.5015 6000.0n 0.4700 6599.5n 0.4700 6600.0n 0.5120 7199.5n 0.5120 7200.0n 0.5006 7799.5n 0.5006 7800.0n 0.4950 8399.5n 0.4950 8400.0n 0.5309 8999.5n 0.5309 9000.0n 0.5023 9599.5n 0.5023 9600.0n 0.4893 10199.5n 0.4893 10200.0n 0.4837 10799.5n 0.4837 10800.0n 0.4823 11399.5n 0.4823 11400.0n 0.5074 11999.5n 0.5074 12000.0n 0.5364 12599.5n 0.5364 12600.0n 0.4868 13199.5n 0.4868 13200.0n 0.5380 13799.5n 0.5380 13800.0n 0.5220 14399.5n 0.5220 14400.0n 0.5095 14999.5n 0.5095 15000.0n 0.4705 15599.5n 0.4705 15600.0n 0.5289 16199.5n 0.5289 16200.0n 0.5368 16799.5n 0.5368 16800.0n 0.5287 17399.5n 0.5287 17400.0n 0.5342 17999.5n 0.5342 18000.0n 0.4253 18599.5n 0.4253 18600.0n 0.5119 19199.5n 0.5119 19200.0n 0.4104 19799.5n 0.4104 19800.0n 0.4314 20399.5n 0.4314 20400.0n 0.4005 20999.5n 0.4005 21000.0n 0.4696 21599.5n 0.4696 21600.0n 0.4531 22199.5n 0.4531 22200.0n 0.5039 22799.5n 0.5039 22800.0n 0.3608 23399.5n 0.3608 23400.0n 0.6273 23999.5n 0.6273 24000.0n 0.3928 24599.5n 0.3928 24600.0n 0.5253 25199.5n 0.5253 25200.0n 0.4107 25799.5n 0.4107 25800.0n 0.3947 26399.5n 0.3947 26400.0n 0.3716 26999.5n 0.3716 27000.0n 0.4111 27599.5n 0.4111 27600.0n 0.3715 28199.5n 0.3715 28200.0n 0.5939 28799.5n 0.5939 28800.0n 0.3849 29399.5n 0.3849 29400.0n 0.4835 29999.5n 0.4835 30000.0n 0.5119 30599.5n 0.5119 30600.0n 0.6226 31199.5n 0.6226 31200.0n 0.6064 31799.5n 0.6064 31800.0n 0.4115 32399.5n 0.4115 32400.0n 0.3900 32999.5n 0.3900 33000.0n 0.3958 33599.5n 0.3958 33600.0n 0.3747 34199.5n 0.3747 34200.0n 0.5423 34799.5n 0.5423 34800.0n 0.5509 35399.5n 0.5509 35400.0n 0.3990 35999.5n 0.3990)
Vxn_wih_1_31 xn_wih_1_31 0 PWL(0.0n 0.4630 599.5n 0.4630 600.0n 0.4833 1199.5n 0.4833 1200.0n 0.5207 1799.5n 0.5207 1800.0n 0.5559 2399.5n 0.5559 2400.0n 0.5445 2999.5n 0.5445 3000.0n 0.4945 3599.5n 0.4945 3600.0n 0.5061 4199.5n 0.5061 4200.0n 0.4615 4799.5n 0.4615 4800.0n 0.4976 5399.5n 0.4976 5400.0n 0.4985 5999.5n 0.4985 6000.0n 0.5300 6599.5n 0.5300 6600.0n 0.4880 7199.5n 0.4880 7200.0n 0.4994 7799.5n 0.4994 7800.0n 0.5050 8399.5n 0.5050 8400.0n 0.4691 8999.5n 0.4691 9000.0n 0.4977 9599.5n 0.4977 9600.0n 0.5107 10199.5n 0.5107 10200.0n 0.5163 10799.5n 0.5163 10800.0n 0.5177 11399.5n 0.5177 11400.0n 0.4926 11999.5n 0.4926 12000.0n 0.4636 12599.5n 0.4636 12600.0n 0.5132 13199.5n 0.5132 13200.0n 0.4620 13799.5n 0.4620 13800.0n 0.4780 14399.5n 0.4780 14400.0n 0.4905 14999.5n 0.4905 15000.0n 0.5295 15599.5n 0.5295 15600.0n 0.4711 16199.5n 0.4711 16200.0n 0.4632 16799.5n 0.4632 16800.0n 0.4713 17399.5n 0.4713 17400.0n 0.4658 17999.5n 0.4658 18000.0n 0.5747 18599.5n 0.5747 18600.0n 0.4881 19199.5n 0.4881 19200.0n 0.5896 19799.5n 0.5896 19800.0n 0.5686 20399.5n 0.5686 20400.0n 0.5995 20999.5n 0.5995 21000.0n 0.5304 21599.5n 0.5304 21600.0n 0.5469 22199.5n 0.5469 22200.0n 0.4961 22799.5n 0.4961 22800.0n 0.6392 23399.5n 0.6392 23400.0n 0.3727 23999.5n 0.3727 24000.0n 0.6072 24599.5n 0.6072 24600.0n 0.4747 25199.5n 0.4747 25200.0n 0.5893 25799.5n 0.5893 25800.0n 0.6053 26399.5n 0.6053 26400.0n 0.6284 26999.5n 0.6284 27000.0n 0.5889 27599.5n 0.5889 27600.0n 0.6285 28199.5n 0.6285 28200.0n 0.4061 28799.5n 0.4061 28800.0n 0.6151 29399.5n 0.6151 29400.0n 0.5165 29999.5n 0.5165 30000.0n 0.4881 30599.5n 0.4881 30600.0n 0.3774 31199.5n 0.3774 31200.0n 0.3936 31799.5n 0.3936 31800.0n 0.5885 32399.5n 0.5885 32400.0n 0.6100 32999.5n 0.6100 33000.0n 0.6042 33599.5n 0.6042 33600.0n 0.6253 34199.5n 0.6253 34200.0n 0.4577 34799.5n 0.4577 34800.0n 0.4491 35399.5n 0.4491 35400.0n 0.6010 35999.5n 0.6010)
Vyp_wih_1_31 yp_wih_1_31 0 PWL(0.0n 0.6706 599.5n 0.6706 600.0n 0.6817 1199.5n 0.6817 1200.0n 0.6683 1799.5n 0.6683 1800.0n 0.6778 2399.5n 0.6778 2400.0n 0.6790 2999.5n 0.6790 3000.0n 0.6745 3599.5n 0.6745 3600.0n 0.6677 4199.5n 0.6677 4200.0n 0.6694 4799.5n 0.6694 4800.0n 0.6717 5399.5n 0.6717 5400.0n 0.6720 5999.5n 0.6720 6000.0n 0.6694 6599.5n 0.6694 6600.0n 0.6701 7199.5n 0.6701 7200.0n 0.6806 7799.5n 0.6806 7800.0n 0.6812 8399.5n 0.6812 8400.0n 0.6651 8999.5n 0.6651 9000.0n 0.6719 9599.5n 0.6719 9600.0n 0.6743 10199.5n 0.6743 10200.0n 0.6786 10799.5n 0.6786 10800.0n 0.6655 11399.5n 0.6655 11400.0n 0.6715 11999.5n 0.6715 12000.0n 0.6627 12599.5n 0.6627 12600.0n 0.6748 13199.5n 0.6748 13200.0n 0.6720 13799.5n 0.6720 13800.0n 0.6768 14399.5n 0.6768 14400.0n 0.6719 14999.5n 0.6719 15000.0n 0.6775 15599.5n 0.6775 15600.0n 0.6690 16199.5n 0.6690 16200.0n 0.6750 16799.5n 0.6750 16800.0n 0.6639 17399.5n 0.6639 17400.0n 0.6729 17999.5n 0.6729 18000.0n 0.6606 18599.5n 0.6606 18600.0n 0.6890 19199.5n 0.6890 19200.0n 0.6822 19799.5n 0.6822 19800.0n 0.6930 20399.5n 0.6930 20400.0n 0.6756 20999.5n 0.6756 21000.0n 0.6230 21599.5n 0.6230 21600.0n 0.6916 22199.5n 0.6916 22200.0n 0.6920 22799.5n 0.6920 22800.0n 0.6752 23399.5n 0.6752 23400.0n 0.6812 23999.5n 0.6812 24000.0n 0.6929 24599.5n 0.6929 24600.0n 0.6914 25199.5n 0.6914 25200.0n 0.6683 25799.5n 0.6683 25800.0n 0.6416 26399.5n 0.6416 26400.0n 0.6668 26999.5n 0.6668 27000.0n 0.6621 27599.5n 0.6621 27600.0n 0.6678 28199.5n 0.6678 28200.0n 0.6851 28799.5n 0.6851 28800.0n 0.6748 29399.5n 0.6748 29400.0n 0.6215 29999.5n 0.6215 30000.0n 0.6139 30599.5n 0.6139 30600.0n 0.5949 31199.5n 0.5949 31200.0n 0.6529 31799.5n 0.6529 31800.0n 0.6329 32399.5n 0.6329 32400.0n 0.6452 32999.5n 0.6452 33000.0n 0.6872 33599.5n 0.6872 33600.0n 0.6815 34199.5n 0.6815 34200.0n 0.6892 34799.5n 0.6892 34800.0n 0.5892 35399.5n 0.5892 35400.0n 0.6814 35999.5n 0.6814)
Vyn_wih_1_31 yn_wih_1_31 0 PWL(0.0n 0.3294 599.5n 0.3294 600.0n 0.3183 1199.5n 0.3183 1200.0n 0.3317 1799.5n 0.3317 1800.0n 0.3222 2399.5n 0.3222 2400.0n 0.3210 2999.5n 0.3210 3000.0n 0.3255 3599.5n 0.3255 3600.0n 0.3323 4199.5n 0.3323 4200.0n 0.3306 4799.5n 0.3306 4800.0n 0.3283 5399.5n 0.3283 5400.0n 0.3280 5999.5n 0.3280 6000.0n 0.3306 6599.5n 0.3306 6600.0n 0.3299 7199.5n 0.3299 7200.0n 0.3194 7799.5n 0.3194 7800.0n 0.3188 8399.5n 0.3188 8400.0n 0.3349 8999.5n 0.3349 9000.0n 0.3281 9599.5n 0.3281 9600.0n 0.3257 10199.5n 0.3257 10200.0n 0.3214 10799.5n 0.3214 10800.0n 0.3345 11399.5n 0.3345 11400.0n 0.3285 11999.5n 0.3285 12000.0n 0.3373 12599.5n 0.3373 12600.0n 0.3252 13199.5n 0.3252 13200.0n 0.3280 13799.5n 0.3280 13800.0n 0.3232 14399.5n 0.3232 14400.0n 0.3281 14999.5n 0.3281 15000.0n 0.3225 15599.5n 0.3225 15600.0n 0.3310 16199.5n 0.3310 16200.0n 0.3250 16799.5n 0.3250 16800.0n 0.3361 17399.5n 0.3361 17400.0n 0.3271 17999.5n 0.3271 18000.0n 0.3394 18599.5n 0.3394 18600.0n 0.3110 19199.5n 0.3110 19200.0n 0.3178 19799.5n 0.3178 19800.0n 0.3070 20399.5n 0.3070 20400.0n 0.3244 20999.5n 0.3244 21000.0n 0.3770 21599.5n 0.3770 21600.0n 0.3084 22199.5n 0.3084 22200.0n 0.3080 22799.5n 0.3080 22800.0n 0.3248 23399.5n 0.3248 23400.0n 0.3188 23999.5n 0.3188 24000.0n 0.3071 24599.5n 0.3071 24600.0n 0.3086 25199.5n 0.3086 25200.0n 0.3317 25799.5n 0.3317 25800.0n 0.3584 26399.5n 0.3584 26400.0n 0.3332 26999.5n 0.3332 27000.0n 0.3379 27599.5n 0.3379 27600.0n 0.3322 28199.5n 0.3322 28200.0n 0.3149 28799.5n 0.3149 28800.0n 0.3252 29399.5n 0.3252 29400.0n 0.3785 29999.5n 0.3785 30000.0n 0.3861 30599.5n 0.3861 30600.0n 0.4051 31199.5n 0.4051 31200.0n 0.3471 31799.5n 0.3471 31800.0n 0.3671 32399.5n 0.3671 32400.0n 0.3548 32999.5n 0.3548 33000.0n 0.3128 33599.5n 0.3128 33600.0n 0.3185 34199.5n 0.3185 34200.0n 0.3108 34799.5n 0.3108 34800.0n 0.4108 35399.5n 0.4108 35400.0n 0.3186 35999.5n 0.3186)
Cwp_wih_1_31 wp_wih_1_31 0 400p
Cwn_wih_1_31 wn_wih_1_31 0 400p
Xu_wih_1_31 xp_wih_1_31 xn_wih_1_31 yp_wih_1_31 yn_wih_1_31 wp_wih_1_31 wn_wih_1_31 vdd gbn gprod
Vxp_who_31_0 xp_who_31_0 0 PWL(0.0n 0.6706 599.5n 0.6706 600.0n 0.6817 1199.5n 0.6817 1200.0n 0.6683 1799.5n 0.6683 1800.0n 0.6778 2399.5n 0.6778 2400.0n 0.6790 2999.5n 0.6790 3000.0n 0.6745 3599.5n 0.6745 3600.0n 0.6677 4199.5n 0.6677 4200.0n 0.6694 4799.5n 0.6694 4800.0n 0.6717 5399.5n 0.6717 5400.0n 0.6720 5999.5n 0.6720 6000.0n 0.6694 6599.5n 0.6694 6600.0n 0.6701 7199.5n 0.6701 7200.0n 0.6806 7799.5n 0.6806 7800.0n 0.6812 8399.5n 0.6812 8400.0n 0.6651 8999.5n 0.6651 9000.0n 0.6719 9599.5n 0.6719 9600.0n 0.6743 10199.5n 0.6743 10200.0n 0.6786 10799.5n 0.6786 10800.0n 0.6655 11399.5n 0.6655 11400.0n 0.6715 11999.5n 0.6715 12000.0n 0.6627 12599.5n 0.6627 12600.0n 0.6748 13199.5n 0.6748 13200.0n 0.6720 13799.5n 0.6720 13800.0n 0.6768 14399.5n 0.6768 14400.0n 0.6719 14999.5n 0.6719 15000.0n 0.6775 15599.5n 0.6775 15600.0n 0.6690 16199.5n 0.6690 16200.0n 0.6750 16799.5n 0.6750 16800.0n 0.6639 17399.5n 0.6639 17400.0n 0.6729 17999.5n 0.6729 18000.0n 0.6606 18599.5n 0.6606 18600.0n 0.6890 19199.5n 0.6890 19200.0n 0.6822 19799.5n 0.6822 19800.0n 0.6930 20399.5n 0.6930 20400.0n 0.6756 20999.5n 0.6756 21000.0n 0.6230 21599.5n 0.6230 21600.0n 0.6916 22199.5n 0.6916 22200.0n 0.6920 22799.5n 0.6920 22800.0n 0.6752 23399.5n 0.6752 23400.0n 0.6812 23999.5n 0.6812 24000.0n 0.6929 24599.5n 0.6929 24600.0n 0.6914 25199.5n 0.6914 25200.0n 0.6683 25799.5n 0.6683 25800.0n 0.6416 26399.5n 0.6416 26400.0n 0.6668 26999.5n 0.6668 27000.0n 0.6621 27599.5n 0.6621 27600.0n 0.6678 28199.5n 0.6678 28200.0n 0.6851 28799.5n 0.6851 28800.0n 0.6748 29399.5n 0.6748 29400.0n 0.6215 29999.5n 0.6215 30000.0n 0.6139 30599.5n 0.6139 30600.0n 0.5949 31199.5n 0.5949 31200.0n 0.6529 31799.5n 0.6529 31800.0n 0.6329 32399.5n 0.6329 32400.0n 0.6452 32999.5n 0.6452 33000.0n 0.6872 33599.5n 0.6872 33600.0n 0.6815 34199.5n 0.6815 34200.0n 0.6892 34799.5n 0.6892 34800.0n 0.5892 35399.5n 0.5892 35400.0n 0.6814 35999.5n 0.6814)
Vxn_who_31_0 xn_who_31_0 0 PWL(0.0n 0.3294 599.5n 0.3294 600.0n 0.3183 1199.5n 0.3183 1200.0n 0.3317 1799.5n 0.3317 1800.0n 0.3222 2399.5n 0.3222 2400.0n 0.3210 2999.5n 0.3210 3000.0n 0.3255 3599.5n 0.3255 3600.0n 0.3323 4199.5n 0.3323 4200.0n 0.3306 4799.5n 0.3306 4800.0n 0.3283 5399.5n 0.3283 5400.0n 0.3280 5999.5n 0.3280 6000.0n 0.3306 6599.5n 0.3306 6600.0n 0.3299 7199.5n 0.3299 7200.0n 0.3194 7799.5n 0.3194 7800.0n 0.3188 8399.5n 0.3188 8400.0n 0.3349 8999.5n 0.3349 9000.0n 0.3281 9599.5n 0.3281 9600.0n 0.3257 10199.5n 0.3257 10200.0n 0.3214 10799.5n 0.3214 10800.0n 0.3345 11399.5n 0.3345 11400.0n 0.3285 11999.5n 0.3285 12000.0n 0.3373 12599.5n 0.3373 12600.0n 0.3252 13199.5n 0.3252 13200.0n 0.3280 13799.5n 0.3280 13800.0n 0.3232 14399.5n 0.3232 14400.0n 0.3281 14999.5n 0.3281 15000.0n 0.3225 15599.5n 0.3225 15600.0n 0.3310 16199.5n 0.3310 16200.0n 0.3250 16799.5n 0.3250 16800.0n 0.3361 17399.5n 0.3361 17400.0n 0.3271 17999.5n 0.3271 18000.0n 0.3394 18599.5n 0.3394 18600.0n 0.3110 19199.5n 0.3110 19200.0n 0.3178 19799.5n 0.3178 19800.0n 0.3070 20399.5n 0.3070 20400.0n 0.3244 20999.5n 0.3244 21000.0n 0.3770 21599.5n 0.3770 21600.0n 0.3084 22199.5n 0.3084 22200.0n 0.3080 22799.5n 0.3080 22800.0n 0.3248 23399.5n 0.3248 23400.0n 0.3188 23999.5n 0.3188 24000.0n 0.3071 24599.5n 0.3071 24600.0n 0.3086 25199.5n 0.3086 25200.0n 0.3317 25799.5n 0.3317 25800.0n 0.3584 26399.5n 0.3584 26400.0n 0.3332 26999.5n 0.3332 27000.0n 0.3379 27599.5n 0.3379 27600.0n 0.3322 28199.5n 0.3322 28200.0n 0.3149 28799.5n 0.3149 28800.0n 0.3252 29399.5n 0.3252 29400.0n 0.3785 29999.5n 0.3785 30000.0n 0.3861 30599.5n 0.3861 30600.0n 0.4051 31199.5n 0.4051 31200.0n 0.3471 31799.5n 0.3471 31800.0n 0.3671 32399.5n 0.3671 32400.0n 0.3548 32999.5n 0.3548 33000.0n 0.3128 33599.5n 0.3128 33600.0n 0.3185 34199.5n 0.3185 34200.0n 0.3108 34799.5n 0.3108 34800.0n 0.4108 35399.5n 0.4108 35400.0n 0.3186 35999.5n 0.3186)
Vyp_who_31_0 yp_who_31_0 0 PWL(0.0n 0.5031 599.5n 0.5031 600.0n 0.5023 1199.5n 0.5023 1200.0n 0.5052 1799.5n 0.5052 1800.0n 0.5048 2399.5n 0.5048 2400.0n 0.5043 2999.5n 0.5043 3000.0n 0.5034 3599.5n 0.5034 3600.0n 0.5048 4199.5n 0.5048 4200.0n 0.5031 4799.5n 0.5031 4800.0n 0.5040 5399.5n 0.5040 5400.0n 0.5040 5999.5n 0.5040 6000.0n 0.5054 6599.5n 0.5054 6600.0n 0.5040 7199.5n 0.5040 7200.0n 0.5027 7799.5n 0.5027 7800.0n 0.5027 8399.5n 0.5027 8400.0n 0.5038 8999.5n 0.5038 9000.0n 0.5040 9599.5n 0.5040 9600.0n 0.5039 10199.5n 0.5039 10200.0n 0.5033 10799.5n 0.5033 10800.0n 0.5056 11399.5n 0.5056 11400.0n 0.5040 11999.5n 0.5040 12000.0n 0.5036 12599.5n 0.5036 12600.0n 0.5039 13199.5n 0.5039 13200.0n 0.5029 13799.5n 0.5029 13800.0n 0.5025 14399.5n 0.5025 14400.0n 0.5038 14999.5n 0.5038 15000.0n 0.5041 15599.5n 0.5041 15600.0n 0.5036 16199.5n 0.5036 16200.0n 0.5025 16799.5n 0.5025 16800.0n 0.5040 17399.5n 0.5040 17400.0n 0.5029 17999.5n 0.5029 18000.0n 0.5057 18599.5n 0.5057 18600.0n 0.5010 19199.5n 0.5010 19200.0n 0.5041 19799.5n 0.5041 19800.0n 0.5021 20399.5n 0.5021 20400.0n 0.5044 20999.5n 0.5044 21000.0n 0.5056 21599.5n 0.5056 21600.0n 0.5016 22199.5n 0.5016 22200.0n 0.5006 22799.5n 0.5006 22800.0n 0.5041 23399.5n 0.5041 23400.0n 0.5027 23999.5n 0.5027 24000.0n 0.5029 24599.5n 0.5029 24600.0n 0.5006 25199.5n 0.5006 25200.0n 0.5047 25799.5n 0.5047 25800.0n 0.5046 26399.5n 0.5046 26400.0n 0.5039 26999.5n 0.5039 27000.0n 0.5049 27599.5n 0.5049 27600.0n 0.5039 28199.5n 0.5039 28200.0n 0.5017 28799.5n 0.5017 28800.0n 0.5042 29399.5n 0.5042 29400.0n 0.5056 29999.5n 0.5056 30000.0n 0.5051 30599.5n 0.5051 30600.0n 0.5039 31199.5n 0.5039 31200.0n 0.5033 31799.5n 0.5033 31800.0n 0.5049 32399.5n 0.5049 32400.0n 0.5045 32999.5n 0.5045 33000.0n 0.5036 33599.5n 0.5036 33600.0n 0.5042 34199.5n 0.5042 34200.0n 0.5012 34799.5n 0.5012 34800.0n 0.5036 35399.5n 0.5036 35400.0n 0.5042 35999.5n 0.5042)
Vyn_who_31_0 yn_who_31_0 0 PWL(0.0n 0.4969 599.5n 0.4969 600.0n 0.4977 1199.5n 0.4977 1200.0n 0.4948 1799.5n 0.4948 1800.0n 0.4952 2399.5n 0.4952 2400.0n 0.4957 2999.5n 0.4957 3000.0n 0.4966 3599.5n 0.4966 3600.0n 0.4952 4199.5n 0.4952 4200.0n 0.4969 4799.5n 0.4969 4800.0n 0.4960 5399.5n 0.4960 5400.0n 0.4960 5999.5n 0.4960 6000.0n 0.4946 6599.5n 0.4946 6600.0n 0.4960 7199.5n 0.4960 7200.0n 0.4973 7799.5n 0.4973 7800.0n 0.4973 8399.5n 0.4973 8400.0n 0.4962 8999.5n 0.4962 9000.0n 0.4960 9599.5n 0.4960 9600.0n 0.4961 10199.5n 0.4961 10200.0n 0.4967 10799.5n 0.4967 10800.0n 0.4944 11399.5n 0.4944 11400.0n 0.4960 11999.5n 0.4960 12000.0n 0.4964 12599.5n 0.4964 12600.0n 0.4961 13199.5n 0.4961 13200.0n 0.4971 13799.5n 0.4971 13800.0n 0.4975 14399.5n 0.4975 14400.0n 0.4962 14999.5n 0.4962 15000.0n 0.4959 15599.5n 0.4959 15600.0n 0.4964 16199.5n 0.4964 16200.0n 0.4975 16799.5n 0.4975 16800.0n 0.4960 17399.5n 0.4960 17400.0n 0.4971 17999.5n 0.4971 18000.0n 0.4943 18599.5n 0.4943 18600.0n 0.4990 19199.5n 0.4990 19200.0n 0.4959 19799.5n 0.4959 19800.0n 0.4979 20399.5n 0.4979 20400.0n 0.4956 20999.5n 0.4956 21000.0n 0.4944 21599.5n 0.4944 21600.0n 0.4984 22199.5n 0.4984 22200.0n 0.4994 22799.5n 0.4994 22800.0n 0.4959 23399.5n 0.4959 23400.0n 0.4973 23999.5n 0.4973 24000.0n 0.4971 24599.5n 0.4971 24600.0n 0.4994 25199.5n 0.4994 25200.0n 0.4953 25799.5n 0.4953 25800.0n 0.4954 26399.5n 0.4954 26400.0n 0.4961 26999.5n 0.4961 27000.0n 0.4951 27599.5n 0.4951 27600.0n 0.4961 28199.5n 0.4961 28200.0n 0.4983 28799.5n 0.4983 28800.0n 0.4958 29399.5n 0.4958 29400.0n 0.4944 29999.5n 0.4944 30000.0n 0.4949 30599.5n 0.4949 30600.0n 0.4961 31199.5n 0.4961 31200.0n 0.4967 31799.5n 0.4967 31800.0n 0.4951 32399.5n 0.4951 32400.0n 0.4955 32999.5n 0.4955 33000.0n 0.4964 33599.5n 0.4964 33600.0n 0.4958 34199.5n 0.4958 34200.0n 0.4988 34799.5n 0.4988 34800.0n 0.4964 35399.5n 0.4964 35400.0n 0.4958 35999.5n 0.4958)
Cwp_who_31_0 wp_who_31_0 0 400p
Cwn_who_31_0 wn_who_31_0 0 400p
Xu_who_31_0 xp_who_31_0 xn_who_31_0 yp_who_31_0 yn_who_31_0 wp_who_31_0 wn_who_31_0 vdd gbn gprod
Vxp_who_31_1 xp_who_31_1 0 PWL(0.0n 0.6706 599.5n 0.6706 600.0n 0.6817 1199.5n 0.6817 1200.0n 0.6683 1799.5n 0.6683 1800.0n 0.6778 2399.5n 0.6778 2400.0n 0.6790 2999.5n 0.6790 3000.0n 0.6745 3599.5n 0.6745 3600.0n 0.6677 4199.5n 0.6677 4200.0n 0.6694 4799.5n 0.6694 4800.0n 0.6717 5399.5n 0.6717 5400.0n 0.6720 5999.5n 0.6720 6000.0n 0.6694 6599.5n 0.6694 6600.0n 0.6701 7199.5n 0.6701 7200.0n 0.6806 7799.5n 0.6806 7800.0n 0.6812 8399.5n 0.6812 8400.0n 0.6651 8999.5n 0.6651 9000.0n 0.6719 9599.5n 0.6719 9600.0n 0.6743 10199.5n 0.6743 10200.0n 0.6786 10799.5n 0.6786 10800.0n 0.6655 11399.5n 0.6655 11400.0n 0.6715 11999.5n 0.6715 12000.0n 0.6627 12599.5n 0.6627 12600.0n 0.6748 13199.5n 0.6748 13200.0n 0.6720 13799.5n 0.6720 13800.0n 0.6768 14399.5n 0.6768 14400.0n 0.6719 14999.5n 0.6719 15000.0n 0.6775 15599.5n 0.6775 15600.0n 0.6690 16199.5n 0.6690 16200.0n 0.6750 16799.5n 0.6750 16800.0n 0.6639 17399.5n 0.6639 17400.0n 0.6729 17999.5n 0.6729 18000.0n 0.6606 18599.5n 0.6606 18600.0n 0.6890 19199.5n 0.6890 19200.0n 0.6822 19799.5n 0.6822 19800.0n 0.6930 20399.5n 0.6930 20400.0n 0.6756 20999.5n 0.6756 21000.0n 0.6230 21599.5n 0.6230 21600.0n 0.6916 22199.5n 0.6916 22200.0n 0.6920 22799.5n 0.6920 22800.0n 0.6752 23399.5n 0.6752 23400.0n 0.6812 23999.5n 0.6812 24000.0n 0.6929 24599.5n 0.6929 24600.0n 0.6914 25199.5n 0.6914 25200.0n 0.6683 25799.5n 0.6683 25800.0n 0.6416 26399.5n 0.6416 26400.0n 0.6668 26999.5n 0.6668 27000.0n 0.6621 27599.5n 0.6621 27600.0n 0.6678 28199.5n 0.6678 28200.0n 0.6851 28799.5n 0.6851 28800.0n 0.6748 29399.5n 0.6748 29400.0n 0.6215 29999.5n 0.6215 30000.0n 0.6139 30599.5n 0.6139 30600.0n 0.5949 31199.5n 0.5949 31200.0n 0.6529 31799.5n 0.6529 31800.0n 0.6329 32399.5n 0.6329 32400.0n 0.6452 32999.5n 0.6452 33000.0n 0.6872 33599.5n 0.6872 33600.0n 0.6815 34199.5n 0.6815 34200.0n 0.6892 34799.5n 0.6892 34800.0n 0.5892 35399.5n 0.5892 35400.0n 0.6814 35999.5n 0.6814)
Vxn_who_31_1 xn_who_31_1 0 PWL(0.0n 0.3294 599.5n 0.3294 600.0n 0.3183 1199.5n 0.3183 1200.0n 0.3317 1799.5n 0.3317 1800.0n 0.3222 2399.5n 0.3222 2400.0n 0.3210 2999.5n 0.3210 3000.0n 0.3255 3599.5n 0.3255 3600.0n 0.3323 4199.5n 0.3323 4200.0n 0.3306 4799.5n 0.3306 4800.0n 0.3283 5399.5n 0.3283 5400.0n 0.3280 5999.5n 0.3280 6000.0n 0.3306 6599.5n 0.3306 6600.0n 0.3299 7199.5n 0.3299 7200.0n 0.3194 7799.5n 0.3194 7800.0n 0.3188 8399.5n 0.3188 8400.0n 0.3349 8999.5n 0.3349 9000.0n 0.3281 9599.5n 0.3281 9600.0n 0.3257 10199.5n 0.3257 10200.0n 0.3214 10799.5n 0.3214 10800.0n 0.3345 11399.5n 0.3345 11400.0n 0.3285 11999.5n 0.3285 12000.0n 0.3373 12599.5n 0.3373 12600.0n 0.3252 13199.5n 0.3252 13200.0n 0.3280 13799.5n 0.3280 13800.0n 0.3232 14399.5n 0.3232 14400.0n 0.3281 14999.5n 0.3281 15000.0n 0.3225 15599.5n 0.3225 15600.0n 0.3310 16199.5n 0.3310 16200.0n 0.3250 16799.5n 0.3250 16800.0n 0.3361 17399.5n 0.3361 17400.0n 0.3271 17999.5n 0.3271 18000.0n 0.3394 18599.5n 0.3394 18600.0n 0.3110 19199.5n 0.3110 19200.0n 0.3178 19799.5n 0.3178 19800.0n 0.3070 20399.5n 0.3070 20400.0n 0.3244 20999.5n 0.3244 21000.0n 0.3770 21599.5n 0.3770 21600.0n 0.3084 22199.5n 0.3084 22200.0n 0.3080 22799.5n 0.3080 22800.0n 0.3248 23399.5n 0.3248 23400.0n 0.3188 23999.5n 0.3188 24000.0n 0.3071 24599.5n 0.3071 24600.0n 0.3086 25199.5n 0.3086 25200.0n 0.3317 25799.5n 0.3317 25800.0n 0.3584 26399.5n 0.3584 26400.0n 0.3332 26999.5n 0.3332 27000.0n 0.3379 27599.5n 0.3379 27600.0n 0.3322 28199.5n 0.3322 28200.0n 0.3149 28799.5n 0.3149 28800.0n 0.3252 29399.5n 0.3252 29400.0n 0.3785 29999.5n 0.3785 30000.0n 0.3861 30599.5n 0.3861 30600.0n 0.4051 31199.5n 0.4051 31200.0n 0.3471 31799.5n 0.3471 31800.0n 0.3671 32399.5n 0.3671 32400.0n 0.3548 32999.5n 0.3548 33000.0n 0.3128 33599.5n 0.3128 33600.0n 0.3185 34199.5n 0.3185 34200.0n 0.3108 34799.5n 0.3108 34800.0n 0.4108 35399.5n 0.4108 35400.0n 0.3186 35999.5n 0.3186)
Vyp_who_31_1 yp_who_31_1 0 PWL(0.0n 0.5071 599.5n 0.5071 600.0n 0.5053 1199.5n 0.5053 1200.0n 0.5052 1799.5n 0.5052 1800.0n 0.5027 2399.5n 0.5027 2400.0n 0.5034 2999.5n 0.5034 3000.0n 0.5055 3599.5n 0.5055 3600.0n 0.5056 4199.5n 0.5056 4200.0n 0.5071 4799.5n 0.5071 4800.0n 0.5056 5399.5n 0.5056 5400.0n 0.5056 5999.5n 0.5056 6000.0n 0.5048 6599.5n 0.5048 6600.0n 0.5060 7199.5n 0.5060 7200.0n 0.5048 7799.5n 0.5048 7800.0n 0.5046 8399.5n 0.5046 8400.0n 0.5066 8999.5n 0.5066 9000.0n 0.5056 9599.5n 0.5056 9600.0n 0.5051 10199.5n 0.5051 10200.0n 0.5046 10799.5n 0.5046 10800.0n 0.5056 11399.5n 0.5056 11400.0n 0.5058 11999.5n 0.5058 12000.0n 0.5068 12599.5n 0.5068 12600.0n 0.5050 13199.5n 0.5050 13200.0n 0.5071 13799.5n 0.5071 13800.0n 0.5059 14399.5n 0.5059 14400.0n 0.5058 14999.5n 0.5058 15000.0n 0.5043 15599.5n 0.5043 15600.0n 0.5067 16199.5n 0.5067 16200.0n 0.5068 16799.5n 0.5068 16800.0n 0.5066 17399.5n 0.5066 17400.0n 0.5069 17999.5n 0.5069 18000.0n 0.5061 18599.5n 0.5061 18600.0n 0.5034 19199.5n 0.5034 19200.0n 0.5010 19799.5n 0.5010 19800.0n 0.4989 20399.5n 0.4989 20400.0n 0.5022 20999.5n 0.5022 21000.0n 0.5086 21599.5n 0.5086 21600.0n 0.5007 22199.5n 0.5007 22200.0n 0.5023 22799.5n 0.5023 22800.0n 0.5021 23399.5n 0.5021 23400.0n 0.5077 23999.5n 0.5077 24000.0n 0.4979 24599.5n 0.4979 24600.0n 0.5035 25199.5n 0.5035 25200.0n 0.5041 25799.5n 0.5041 25800.0n 0.5075 26399.5n 0.5075 26400.0n 0.5041 26999.5n 0.5041 27000.0n 0.5056 27599.5n 0.5056 27600.0n 0.5039 28199.5n 0.5039 28200.0n 0.5059 28799.5n 0.5059 28800.0n 0.5023 29399.5n 0.5023 29400.0n 0.5086 29999.5n 0.5086 30000.0n 0.5084 30599.5n 0.5084 30600.0n 0.5085 31199.5n 0.5085 31200.0n 0.5088 31799.5n 0.5088 31800.0n 0.5078 32399.5n 0.5078 32400.0n 0.5074 32999.5n 0.5074 33000.0n 0.4996 33599.5n 0.4996 33600.0n 0.5010 34199.5n 0.5010 34200.0n 0.5044 34799.5n 0.5044 34800.0n 0.5084 35399.5n 0.5084 35400.0n 0.5012 35999.5n 0.5012)
Vyn_who_31_1 yn_who_31_1 0 PWL(0.0n 0.4929 599.5n 0.4929 600.0n 0.4947 1199.5n 0.4947 1200.0n 0.4948 1799.5n 0.4948 1800.0n 0.4973 2399.5n 0.4973 2400.0n 0.4966 2999.5n 0.4966 3000.0n 0.4945 3599.5n 0.4945 3600.0n 0.4944 4199.5n 0.4944 4200.0n 0.4929 4799.5n 0.4929 4800.0n 0.4944 5399.5n 0.4944 5400.0n 0.4944 5999.5n 0.4944 6000.0n 0.4952 6599.5n 0.4952 6600.0n 0.4940 7199.5n 0.4940 7200.0n 0.4952 7799.5n 0.4952 7800.0n 0.4954 8399.5n 0.4954 8400.0n 0.4934 8999.5n 0.4934 9000.0n 0.4944 9599.5n 0.4944 9600.0n 0.4949 10199.5n 0.4949 10200.0n 0.4954 10799.5n 0.4954 10800.0n 0.4944 11399.5n 0.4944 11400.0n 0.4942 11999.5n 0.4942 12000.0n 0.4932 12599.5n 0.4932 12600.0n 0.4950 13199.5n 0.4950 13200.0n 0.4929 13799.5n 0.4929 13800.0n 0.4941 14399.5n 0.4941 14400.0n 0.4942 14999.5n 0.4942 15000.0n 0.4957 15599.5n 0.4957 15600.0n 0.4933 16199.5n 0.4933 16200.0n 0.4932 16799.5n 0.4932 16800.0n 0.4934 17399.5n 0.4934 17400.0n 0.4931 17999.5n 0.4931 18000.0n 0.4939 18599.5n 0.4939 18600.0n 0.4966 19199.5n 0.4966 19200.0n 0.4990 19799.5n 0.4990 19800.0n 0.5011 20399.5n 0.5011 20400.0n 0.4978 20999.5n 0.4978 21000.0n 0.4914 21599.5n 0.4914 21600.0n 0.4993 22199.5n 0.4993 22200.0n 0.4977 22799.5n 0.4977 22800.0n 0.4979 23399.5n 0.4979 23400.0n 0.4923 23999.5n 0.4923 24000.0n 0.5021 24599.5n 0.5021 24600.0n 0.4965 25199.5n 0.4965 25200.0n 0.4959 25799.5n 0.4959 25800.0n 0.4925 26399.5n 0.4925 26400.0n 0.4959 26999.5n 0.4959 27000.0n 0.4944 27599.5n 0.4944 27600.0n 0.4961 28199.5n 0.4961 28200.0n 0.4941 28799.5n 0.4941 28800.0n 0.4977 29399.5n 0.4977 29400.0n 0.4914 29999.5n 0.4914 30000.0n 0.4916 30599.5n 0.4916 30600.0n 0.4915 31199.5n 0.4915 31200.0n 0.4912 31799.5n 0.4912 31800.0n 0.4922 32399.5n 0.4922 32400.0n 0.4926 32999.5n 0.4926 33000.0n 0.5004 33599.5n 0.5004 33600.0n 0.4990 34199.5n 0.4990 34200.0n 0.4956 34799.5n 0.4956 34800.0n 0.4916 35399.5n 0.4916 35400.0n 0.4988 35999.5n 0.4988)
Cwp_who_31_1 wp_who_31_1 0 400p
Cwn_who_31_1 wn_who_31_1 0 400p
Xu_who_31_1 xp_who_31_1 xn_who_31_1 yp_who_31_1 yn_who_31_1 wp_who_31_1 wn_who_31_1 vdd gbn gprod
Vxp_bh_31 xp_bh_31 0 PWL(0.0n 0.7100 599.5n 0.7100 600.0n 0.7100 1199.5n 0.7100 1200.0n 0.7100 1799.5n 0.7100 1800.0n 0.7100 2399.5n 0.7100 2400.0n 0.7100 2999.5n 0.7100 3000.0n 0.7100 3599.5n 0.7100 3600.0n 0.7100 4199.5n 0.7100 4200.0n 0.7100 4799.5n 0.7100 4800.0n 0.7100 5399.5n 0.7100 5400.0n 0.7100 5999.5n 0.7100 6000.0n 0.7100 6599.5n 0.7100 6600.0n 0.7100 7199.5n 0.7100 7200.0n 0.7100 7799.5n 0.7100 7800.0n 0.7100 8399.5n 0.7100 8400.0n 0.7100 8999.5n 0.7100 9000.0n 0.7100 9599.5n 0.7100 9600.0n 0.7100 10199.5n 0.7100 10200.0n 0.7100 10799.5n 0.7100 10800.0n 0.7100 11399.5n 0.7100 11400.0n 0.7100 11999.5n 0.7100 12000.0n 0.7100 12599.5n 0.7100 12600.0n 0.7100 13199.5n 0.7100 13200.0n 0.7100 13799.5n 0.7100 13800.0n 0.7100 14399.5n 0.7100 14400.0n 0.7100 14999.5n 0.7100 15000.0n 0.7100 15599.5n 0.7100 15600.0n 0.7100 16199.5n 0.7100 16200.0n 0.7100 16799.5n 0.7100 16800.0n 0.7100 17399.5n 0.7100 17400.0n 0.7100 17999.5n 0.7100 18000.0n 0.7100 18599.5n 0.7100 18600.0n 0.7100 19199.5n 0.7100 19200.0n 0.7100 19799.5n 0.7100 19800.0n 0.7100 20399.5n 0.7100 20400.0n 0.7100 20999.5n 0.7100 21000.0n 0.7100 21599.5n 0.7100 21600.0n 0.7100 22199.5n 0.7100 22200.0n 0.7100 22799.5n 0.7100 22800.0n 0.7100 23399.5n 0.7100 23400.0n 0.7100 23999.5n 0.7100 24000.0n 0.7100 24599.5n 0.7100 24600.0n 0.7100 25199.5n 0.7100 25200.0n 0.7100 25799.5n 0.7100 25800.0n 0.7100 26399.5n 0.7100 26400.0n 0.7100 26999.5n 0.7100 27000.0n 0.7100 27599.5n 0.7100 27600.0n 0.7100 28199.5n 0.7100 28200.0n 0.7100 28799.5n 0.7100 28800.0n 0.7100 29399.5n 0.7100 29400.0n 0.7100 29999.5n 0.7100 30000.0n 0.7100 30599.5n 0.7100 30600.0n 0.7100 31199.5n 0.7100 31200.0n 0.7100 31799.5n 0.7100 31800.0n 0.7100 32399.5n 0.7100 32400.0n 0.7100 32999.5n 0.7100 33000.0n 0.7100 33599.5n 0.7100 33600.0n 0.7100 34199.5n 0.7100 34200.0n 0.7100 34799.5n 0.7100 34800.0n 0.7100 35399.5n 0.7100 35400.0n 0.7100 35999.5n 0.7100)
Vxn_bh_31 xn_bh_31 0 PWL(0.0n 0.2900 599.5n 0.2900 600.0n 0.2900 1199.5n 0.2900 1200.0n 0.2900 1799.5n 0.2900 1800.0n 0.2900 2399.5n 0.2900 2400.0n 0.2900 2999.5n 0.2900 3000.0n 0.2900 3599.5n 0.2900 3600.0n 0.2900 4199.5n 0.2900 4200.0n 0.2900 4799.5n 0.2900 4800.0n 0.2900 5399.5n 0.2900 5400.0n 0.2900 5999.5n 0.2900 6000.0n 0.2900 6599.5n 0.2900 6600.0n 0.2900 7199.5n 0.2900 7200.0n 0.2900 7799.5n 0.2900 7800.0n 0.2900 8399.5n 0.2900 8400.0n 0.2900 8999.5n 0.2900 9000.0n 0.2900 9599.5n 0.2900 9600.0n 0.2900 10199.5n 0.2900 10200.0n 0.2900 10799.5n 0.2900 10800.0n 0.2900 11399.5n 0.2900 11400.0n 0.2900 11999.5n 0.2900 12000.0n 0.2900 12599.5n 0.2900 12600.0n 0.2900 13199.5n 0.2900 13200.0n 0.2900 13799.5n 0.2900 13800.0n 0.2900 14399.5n 0.2900 14400.0n 0.2900 14999.5n 0.2900 15000.0n 0.2900 15599.5n 0.2900 15600.0n 0.2900 16199.5n 0.2900 16200.0n 0.2900 16799.5n 0.2900 16800.0n 0.2900 17399.5n 0.2900 17400.0n 0.2900 17999.5n 0.2900 18000.0n 0.2900 18599.5n 0.2900 18600.0n 0.2900 19199.5n 0.2900 19200.0n 0.2900 19799.5n 0.2900 19800.0n 0.2900 20399.5n 0.2900 20400.0n 0.2900 20999.5n 0.2900 21000.0n 0.2900 21599.5n 0.2900 21600.0n 0.2900 22199.5n 0.2900 22200.0n 0.2900 22799.5n 0.2900 22800.0n 0.2900 23399.5n 0.2900 23400.0n 0.2900 23999.5n 0.2900 24000.0n 0.2900 24599.5n 0.2900 24600.0n 0.2900 25199.5n 0.2900 25200.0n 0.2900 25799.5n 0.2900 25800.0n 0.2900 26399.5n 0.2900 26400.0n 0.2900 26999.5n 0.2900 27000.0n 0.2900 27599.5n 0.2900 27600.0n 0.2900 28199.5n 0.2900 28200.0n 0.2900 28799.5n 0.2900 28800.0n 0.2900 29399.5n 0.2900 29400.0n 0.2900 29999.5n 0.2900 30000.0n 0.2900 30599.5n 0.2900 30600.0n 0.2900 31199.5n 0.2900 31200.0n 0.2900 31799.5n 0.2900 31800.0n 0.2900 32399.5n 0.2900 32400.0n 0.2900 32999.5n 0.2900 33000.0n 0.2900 33599.5n 0.2900 33600.0n 0.2900 34199.5n 0.2900 34200.0n 0.2900 34799.5n 0.2900 34800.0n 0.2900 35399.5n 0.2900 35400.0n 0.2900 35999.5n 0.2900)
Vyp_bh_31 yp_bh_31 0 PWL(0.0n 0.6706 599.5n 0.6706 600.0n 0.6817 1199.5n 0.6817 1200.0n 0.6683 1799.5n 0.6683 1800.0n 0.6778 2399.5n 0.6778 2400.0n 0.6790 2999.5n 0.6790 3000.0n 0.6745 3599.5n 0.6745 3600.0n 0.6677 4199.5n 0.6677 4200.0n 0.6694 4799.5n 0.6694 4800.0n 0.6717 5399.5n 0.6717 5400.0n 0.6720 5999.5n 0.6720 6000.0n 0.6694 6599.5n 0.6694 6600.0n 0.6701 7199.5n 0.6701 7200.0n 0.6806 7799.5n 0.6806 7800.0n 0.6812 8399.5n 0.6812 8400.0n 0.6651 8999.5n 0.6651 9000.0n 0.6719 9599.5n 0.6719 9600.0n 0.6743 10199.5n 0.6743 10200.0n 0.6786 10799.5n 0.6786 10800.0n 0.6655 11399.5n 0.6655 11400.0n 0.6715 11999.5n 0.6715 12000.0n 0.6627 12599.5n 0.6627 12600.0n 0.6748 13199.5n 0.6748 13200.0n 0.6720 13799.5n 0.6720 13800.0n 0.6768 14399.5n 0.6768 14400.0n 0.6719 14999.5n 0.6719 15000.0n 0.6775 15599.5n 0.6775 15600.0n 0.6690 16199.5n 0.6690 16200.0n 0.6750 16799.5n 0.6750 16800.0n 0.6639 17399.5n 0.6639 17400.0n 0.6729 17999.5n 0.6729 18000.0n 0.6606 18599.5n 0.6606 18600.0n 0.6890 19199.5n 0.6890 19200.0n 0.6822 19799.5n 0.6822 19800.0n 0.6930 20399.5n 0.6930 20400.0n 0.6756 20999.5n 0.6756 21000.0n 0.6230 21599.5n 0.6230 21600.0n 0.6916 22199.5n 0.6916 22200.0n 0.6920 22799.5n 0.6920 22800.0n 0.6752 23399.5n 0.6752 23400.0n 0.6812 23999.5n 0.6812 24000.0n 0.6929 24599.5n 0.6929 24600.0n 0.6914 25199.5n 0.6914 25200.0n 0.6683 25799.5n 0.6683 25800.0n 0.6416 26399.5n 0.6416 26400.0n 0.6668 26999.5n 0.6668 27000.0n 0.6621 27599.5n 0.6621 27600.0n 0.6678 28199.5n 0.6678 28200.0n 0.6851 28799.5n 0.6851 28800.0n 0.6748 29399.5n 0.6748 29400.0n 0.6215 29999.5n 0.6215 30000.0n 0.6139 30599.5n 0.6139 30600.0n 0.5949 31199.5n 0.5949 31200.0n 0.6529 31799.5n 0.6529 31800.0n 0.6329 32399.5n 0.6329 32400.0n 0.6452 32999.5n 0.6452 33000.0n 0.6872 33599.5n 0.6872 33600.0n 0.6815 34199.5n 0.6815 34200.0n 0.6892 34799.5n 0.6892 34800.0n 0.5892 35399.5n 0.5892 35400.0n 0.6814 35999.5n 0.6814)
Vyn_bh_31 yn_bh_31 0 PWL(0.0n 0.3294 599.5n 0.3294 600.0n 0.3183 1199.5n 0.3183 1200.0n 0.3317 1799.5n 0.3317 1800.0n 0.3222 2399.5n 0.3222 2400.0n 0.3210 2999.5n 0.3210 3000.0n 0.3255 3599.5n 0.3255 3600.0n 0.3323 4199.5n 0.3323 4200.0n 0.3306 4799.5n 0.3306 4800.0n 0.3283 5399.5n 0.3283 5400.0n 0.3280 5999.5n 0.3280 6000.0n 0.3306 6599.5n 0.3306 6600.0n 0.3299 7199.5n 0.3299 7200.0n 0.3194 7799.5n 0.3194 7800.0n 0.3188 8399.5n 0.3188 8400.0n 0.3349 8999.5n 0.3349 9000.0n 0.3281 9599.5n 0.3281 9600.0n 0.3257 10199.5n 0.3257 10200.0n 0.3214 10799.5n 0.3214 10800.0n 0.3345 11399.5n 0.3345 11400.0n 0.3285 11999.5n 0.3285 12000.0n 0.3373 12599.5n 0.3373 12600.0n 0.3252 13199.5n 0.3252 13200.0n 0.3280 13799.5n 0.3280 13800.0n 0.3232 14399.5n 0.3232 14400.0n 0.3281 14999.5n 0.3281 15000.0n 0.3225 15599.5n 0.3225 15600.0n 0.3310 16199.5n 0.3310 16200.0n 0.3250 16799.5n 0.3250 16800.0n 0.3361 17399.5n 0.3361 17400.0n 0.3271 17999.5n 0.3271 18000.0n 0.3394 18599.5n 0.3394 18600.0n 0.3110 19199.5n 0.3110 19200.0n 0.3178 19799.5n 0.3178 19800.0n 0.3070 20399.5n 0.3070 20400.0n 0.3244 20999.5n 0.3244 21000.0n 0.3770 21599.5n 0.3770 21600.0n 0.3084 22199.5n 0.3084 22200.0n 0.3080 22799.5n 0.3080 22800.0n 0.3248 23399.5n 0.3248 23400.0n 0.3188 23999.5n 0.3188 24000.0n 0.3071 24599.5n 0.3071 24600.0n 0.3086 25199.5n 0.3086 25200.0n 0.3317 25799.5n 0.3317 25800.0n 0.3584 26399.5n 0.3584 26400.0n 0.3332 26999.5n 0.3332 27000.0n 0.3379 27599.5n 0.3379 27600.0n 0.3322 28199.5n 0.3322 28200.0n 0.3149 28799.5n 0.3149 28800.0n 0.3252 29399.5n 0.3252 29400.0n 0.3785 29999.5n 0.3785 30000.0n 0.3861 30599.5n 0.3861 30600.0n 0.4051 31199.5n 0.4051 31200.0n 0.3471 31799.5n 0.3471 31800.0n 0.3671 32399.5n 0.3671 32400.0n 0.3548 32999.5n 0.3548 33000.0n 0.3128 33599.5n 0.3128 33600.0n 0.3185 34199.5n 0.3185 34200.0n 0.3108 34799.5n 0.3108 34800.0n 0.4108 35399.5n 0.4108 35400.0n 0.3186 35999.5n 0.3186)
Cwp_bh_31 wp_bh_31 0 400p
Cwn_bh_31 wn_bh_31 0 400p
Xu_bh_31 xp_bh_31 xn_bh_31 yp_bh_31 yn_bh_31 wp_bh_31 wn_bh_31 vdd gbn gprod
Vxp_wih_0_32 xp_wih_0_32 0 PWL(0.0n 0.4942 599.5n 0.4942 600.0n 0.5558 1199.5n 0.5558 1200.0n 0.4708 1799.5n 0.4708 1800.0n 0.5235 2399.5n 0.5235 2400.0n 0.5350 2999.5n 0.5350 3000.0n 0.5172 3599.5n 0.5172 3600.0n 0.4702 4199.5n 0.4702 4200.0n 0.4867 4799.5n 0.4867 4800.0n 0.4970 5399.5n 0.4970 5400.0n 0.4986 5999.5n 0.4986 6000.0n 0.4751 6599.5n 0.4751 6600.0n 0.4870 7199.5n 0.4870 7200.0n 0.5502 7799.5n 0.5502 7800.0n 0.5521 8399.5n 0.5521 8400.0n 0.4638 8999.5n 0.4638 9000.0n 0.4982 9599.5n 0.4982 9600.0n 0.5131 10199.5n 0.5131 10200.0n 0.5386 10799.5n 0.5386 10800.0n 0.4592 11399.5n 0.4592 11400.0n 0.4950 11999.5n 0.4950 12000.0n 0.4559 12599.5n 0.4559 12600.0n 0.5162 13199.5n 0.5162 13200.0n 0.5038 13799.5n 0.5038 13800.0n 0.5333 14399.5n 0.5333 14400.0n 0.4991 14999.5n 0.4991 15000.0n 0.5298 15599.5n 0.5298 15600.0n 0.4823 16199.5n 0.4823 16200.0n 0.5239 16799.5n 0.5239 16800.0n 0.4592 17399.5n 0.4592 17400.0n 0.5094 17999.5n 0.5094 18000.0n 0.4337 18599.5n 0.4337 18600.0n 0.5977 19199.5n 0.5977 19200.0n 0.5364 19799.5n 0.5364 19800.0n 0.6122 20399.5n 0.6122 20400.0n 0.4856 20999.5n 0.4856 21000.0n 0.3861 21599.5n 0.3861 21600.0n 0.6094 22199.5n 0.6094 22200.0n 0.6364 22799.5n 0.6364 22800.0n 0.4807 23399.5n 0.4807 23400.0n 0.5614 23999.5n 0.5614 24000.0n 0.5913 24599.5n 0.5913 24600.0n 0.6295 25199.5n 0.6295 25200.0n 0.4496 25799.5n 0.4496 25800.0n 0.3792 26399.5n 0.3792 26400.0n 0.4434 26999.5n 0.4434 27000.0n 0.4340 27599.5n 0.4340 27600.0n 0.4461 28199.5n 0.4461 28200.0n 0.5791 28799.5n 0.5791 28800.0n 0.4777 29399.5n 0.4777 29400.0n 0.3878 29999.5n 0.3878 30000.0n 0.3832 30599.5n 0.3832 30600.0n 0.4022 31199.5n 0.4022 31200.0n 0.4482 31799.5n 0.4482 31800.0n 0.3662 32399.5n 0.3662 32400.0n 0.3857 32999.5n 0.3857 33000.0n 0.5584 33599.5n 0.5584 33600.0n 0.5284 34199.5n 0.5284 34200.0n 0.6034 34799.5n 0.6034 34800.0n 0.3469 35399.5n 0.3469 35400.0n 0.5290 35999.5n 0.5290)
Vxn_wih_0_32 xn_wih_0_32 0 PWL(0.0n 0.5058 599.5n 0.5058 600.0n 0.4442 1199.5n 0.4442 1200.0n 0.5292 1799.5n 0.5292 1800.0n 0.4765 2399.5n 0.4765 2400.0n 0.4650 2999.5n 0.4650 3000.0n 0.4828 3599.5n 0.4828 3600.0n 0.5298 4199.5n 0.5298 4200.0n 0.5133 4799.5n 0.5133 4800.0n 0.5030 5399.5n 0.5030 5400.0n 0.5014 5999.5n 0.5014 6000.0n 0.5249 6599.5n 0.5249 6600.0n 0.5130 7199.5n 0.5130 7200.0n 0.4498 7799.5n 0.4498 7800.0n 0.4479 8399.5n 0.4479 8400.0n 0.5362 8999.5n 0.5362 9000.0n 0.5018 9599.5n 0.5018 9600.0n 0.4869 10199.5n 0.4869 10200.0n 0.4614 10799.5n 0.4614 10800.0n 0.5408 11399.5n 0.5408 11400.0n 0.5050 11999.5n 0.5050 12000.0n 0.5441 12599.5n 0.5441 12600.0n 0.4838 13199.5n 0.4838 13200.0n 0.4962 13799.5n 0.4962 13800.0n 0.4667 14399.5n 0.4667 14400.0n 0.5009 14999.5n 0.5009 15000.0n 0.4702 15599.5n 0.4702 15600.0n 0.5177 16199.5n 0.5177 16200.0n 0.4761 16799.5n 0.4761 16800.0n 0.5408 17399.5n 0.5408 17400.0n 0.4906 17999.5n 0.4906 18000.0n 0.5663 18599.5n 0.5663 18600.0n 0.4023 19199.5n 0.4023 19200.0n 0.4636 19799.5n 0.4636 19800.0n 0.3878 20399.5n 0.3878 20400.0n 0.5144 20999.5n 0.5144 21000.0n 0.6139 21599.5n 0.6139 21600.0n 0.3906 22199.5n 0.3906 22200.0n 0.3636 22799.5n 0.3636 22800.0n 0.5193 23399.5n 0.5193 23400.0n 0.4386 23999.5n 0.4386 24000.0n 0.4087 24599.5n 0.4087 24600.0n 0.3705 25199.5n 0.3705 25200.0n 0.5504 25799.5n 0.5504 25800.0n 0.6208 26399.5n 0.6208 26400.0n 0.5566 26999.5n 0.5566 27000.0n 0.5660 27599.5n 0.5660 27600.0n 0.5539 28199.5n 0.5539 28200.0n 0.4209 28799.5n 0.4209 28800.0n 0.5223 29399.5n 0.5223 29400.0n 0.6122 29999.5n 0.6122 30000.0n 0.6168 30599.5n 0.6168 30600.0n 0.5978 31199.5n 0.5978 31200.0n 0.5518 31799.5n 0.5518 31800.0n 0.6338 32399.5n 0.6338 32400.0n 0.6143 32999.5n 0.6143 33000.0n 0.4416 33599.5n 0.4416 33600.0n 0.4716 34199.5n 0.4716 34200.0n 0.3966 34799.5n 0.3966 34800.0n 0.6531 35399.5n 0.6531 35400.0n 0.4710 35999.5n 0.4710)
Vyp_wih_0_32 yp_wih_0_32 0 PWL(0.0n 0.3406 599.5n 0.3406 600.0n 0.3338 1199.5n 0.3338 1200.0n 0.3398 1799.5n 0.3398 1800.0n 0.3335 2399.5n 0.3335 2400.0n 0.3335 2999.5n 0.3335 3000.0n 0.3375 3599.5n 0.3375 3600.0n 0.3406 4199.5n 0.3406 4200.0n 0.3412 4799.5n 0.3412 4800.0n 0.3389 5399.5n 0.3389 5400.0n 0.3387 5999.5n 0.3387 6000.0n 0.3389 6599.5n 0.3389 6600.0n 0.3400 7199.5n 0.3400 7200.0n 0.3340 7799.5n 0.3340 7800.0n 0.3336 8399.5n 0.3336 8400.0n 0.3430 8999.5n 0.3430 9000.0n 0.3388 9599.5n 0.3388 9600.0n 0.3372 10199.5n 0.3372 10200.0n 0.3347 10799.5n 0.3347 10800.0n 0.3411 11399.5n 0.3411 11400.0n 0.3392 11999.5n 0.3392 12000.0n 0.3444 12599.5n 0.3444 12600.0n 0.3368 13199.5n 0.3368 13200.0n 0.3399 13799.5n 0.3399 13800.0n 0.3367 14399.5n 0.3367 14400.0n 0.3390 14999.5n 0.3390 15000.0n 0.3349 15599.5n 0.3349 15600.0n 0.3411 16199.5n 0.3411 16200.0n 0.3381 16799.5n 0.3381 16800.0n 0.3434 17399.5n 0.3434 17400.0n 0.3392 17999.5n 0.3392 18000.0n 0.3394 18599.5n 0.3394 18600.0n 0.3280 19199.5n 0.3280 19200.0n 0.3291 19799.5n 0.3291 19800.0n 0.3231 20399.5n 0.3231 20400.0n 0.3319 20999.5n 0.3319 21000.0n 0.3577 21599.5n 0.3577 21600.0n 0.3250 22199.5n 0.3250 22200.0n 0.3268 22799.5n 0.3268 22800.0n 0.3319 23399.5n 0.3319 23400.0n 0.3382 23999.5n 0.3382 24000.0n 0.3219 24599.5n 0.3219 24600.0n 0.3273 25199.5n 0.3273 25200.0n 0.3351 25799.5n 0.3351 25800.0n 0.3434 26399.5n 0.3434 26400.0n 0.3350 26999.5n 0.3350 27000.0n 0.3378 27599.5n 0.3378 27600.0n 0.3346 28199.5n 0.3346 28200.0n 0.3336 28799.5n 0.3336 28800.0n 0.3321 29399.5n 0.3321 29400.0n 0.3599 29999.5n 0.3599 30000.0n 0.3651 30599.5n 0.3651 30600.0n 0.3906 31199.5n 0.3906 31200.0n 0.3604 31799.5n 0.3604 31800.0n 0.3448 32399.5n 0.3448 32400.0n 0.3430 32999.5n 0.3430 33000.0n 0.3261 33599.5n 0.3261 33600.0n 0.3290 34199.5n 0.3290 34200.0n 0.3285 34799.5n 0.3285 34800.0n 0.3745 35399.5n 0.3745 35400.0n 0.3292 35999.5n 0.3292)
Vyn_wih_0_32 yn_wih_0_32 0 PWL(0.0n 0.6594 599.5n 0.6594 600.0n 0.6662 1199.5n 0.6662 1200.0n 0.6602 1799.5n 0.6602 1800.0n 0.6665 2399.5n 0.6665 2400.0n 0.6665 2999.5n 0.6665 3000.0n 0.6625 3599.5n 0.6625 3600.0n 0.6594 4199.5n 0.6594 4200.0n 0.6588 4799.5n 0.6588 4800.0n 0.6611 5399.5n 0.6611 5400.0n 0.6613 5999.5n 0.6613 6000.0n 0.6611 6599.5n 0.6611 6600.0n 0.6600 7199.5n 0.6600 7200.0n 0.6660 7799.5n 0.6660 7800.0n 0.6664 8399.5n 0.6664 8400.0n 0.6570 8999.5n 0.6570 9000.0n 0.6612 9599.5n 0.6612 9600.0n 0.6628 10199.5n 0.6628 10200.0n 0.6653 10799.5n 0.6653 10800.0n 0.6589 11399.5n 0.6589 11400.0n 0.6608 11999.5n 0.6608 12000.0n 0.6556 12599.5n 0.6556 12600.0n 0.6632 13199.5n 0.6632 13200.0n 0.6601 13799.5n 0.6601 13800.0n 0.6633 14399.5n 0.6633 14400.0n 0.6610 14999.5n 0.6610 15000.0n 0.6651 15599.5n 0.6651 15600.0n 0.6589 16199.5n 0.6589 16200.0n 0.6619 16799.5n 0.6619 16800.0n 0.6566 17399.5n 0.6566 17400.0n 0.6608 17999.5n 0.6608 18000.0n 0.6606 18599.5n 0.6606 18600.0n 0.6720 19199.5n 0.6720 19200.0n 0.6709 19799.5n 0.6709 19800.0n 0.6769 20399.5n 0.6769 20400.0n 0.6681 20999.5n 0.6681 21000.0n 0.6423 21599.5n 0.6423 21600.0n 0.6750 22199.5n 0.6750 22200.0n 0.6732 22799.5n 0.6732 22800.0n 0.6681 23399.5n 0.6681 23400.0n 0.6618 23999.5n 0.6618 24000.0n 0.6781 24599.5n 0.6781 24600.0n 0.6727 25199.5n 0.6727 25200.0n 0.6649 25799.5n 0.6649 25800.0n 0.6566 26399.5n 0.6566 26400.0n 0.6650 26999.5n 0.6650 27000.0n 0.6622 27599.5n 0.6622 27600.0n 0.6654 28199.5n 0.6654 28200.0n 0.6664 28799.5n 0.6664 28800.0n 0.6679 29399.5n 0.6679 29400.0n 0.6401 29999.5n 0.6401 30000.0n 0.6349 30599.5n 0.6349 30600.0n 0.6094 31199.5n 0.6094 31200.0n 0.6396 31799.5n 0.6396 31800.0n 0.6552 32399.5n 0.6552 32400.0n 0.6570 32999.5n 0.6570 33000.0n 0.6739 33599.5n 0.6739 33600.0n 0.6710 34199.5n 0.6710 34200.0n 0.6715 34799.5n 0.6715 34800.0n 0.6255 35399.5n 0.6255 35400.0n 0.6708 35999.5n 0.6708)
Cwp_wih_0_32 wp_wih_0_32 0 400p
Cwn_wih_0_32 wn_wih_0_32 0 400p
Xu_wih_0_32 xp_wih_0_32 xn_wih_0_32 yp_wih_0_32 yn_wih_0_32 wp_wih_0_32 wn_wih_0_32 vdd gbn gprod
Vxp_wih_1_32 xp_wih_1_32 0 PWL(0.0n 0.5370 599.5n 0.5370 600.0n 0.5167 1199.5n 0.5167 1200.0n 0.4793 1799.5n 0.4793 1800.0n 0.4441 2399.5n 0.4441 2400.0n 0.4555 2999.5n 0.4555 3000.0n 0.5055 3599.5n 0.5055 3600.0n 0.4939 4199.5n 0.4939 4200.0n 0.5385 4799.5n 0.5385 4800.0n 0.5024 5399.5n 0.5024 5400.0n 0.5015 5999.5n 0.5015 6000.0n 0.4700 6599.5n 0.4700 6600.0n 0.5120 7199.5n 0.5120 7200.0n 0.5006 7799.5n 0.5006 7800.0n 0.4950 8399.5n 0.4950 8400.0n 0.5309 8999.5n 0.5309 9000.0n 0.5023 9599.5n 0.5023 9600.0n 0.4893 10199.5n 0.4893 10200.0n 0.4837 10799.5n 0.4837 10800.0n 0.4823 11399.5n 0.4823 11400.0n 0.5074 11999.5n 0.5074 12000.0n 0.5364 12599.5n 0.5364 12600.0n 0.4868 13199.5n 0.4868 13200.0n 0.5380 13799.5n 0.5380 13800.0n 0.5220 14399.5n 0.5220 14400.0n 0.5095 14999.5n 0.5095 15000.0n 0.4705 15599.5n 0.4705 15600.0n 0.5289 16199.5n 0.5289 16200.0n 0.5368 16799.5n 0.5368 16800.0n 0.5287 17399.5n 0.5287 17400.0n 0.5342 17999.5n 0.5342 18000.0n 0.4253 18599.5n 0.4253 18600.0n 0.5119 19199.5n 0.5119 19200.0n 0.4104 19799.5n 0.4104 19800.0n 0.4314 20399.5n 0.4314 20400.0n 0.4005 20999.5n 0.4005 21000.0n 0.4696 21599.5n 0.4696 21600.0n 0.4531 22199.5n 0.4531 22200.0n 0.5039 22799.5n 0.5039 22800.0n 0.3608 23399.5n 0.3608 23400.0n 0.6273 23999.5n 0.6273 24000.0n 0.3928 24599.5n 0.3928 24600.0n 0.5253 25199.5n 0.5253 25200.0n 0.4107 25799.5n 0.4107 25800.0n 0.3947 26399.5n 0.3947 26400.0n 0.3716 26999.5n 0.3716 27000.0n 0.4111 27599.5n 0.4111 27600.0n 0.3715 28199.5n 0.3715 28200.0n 0.5939 28799.5n 0.5939 28800.0n 0.3849 29399.5n 0.3849 29400.0n 0.4835 29999.5n 0.4835 30000.0n 0.5119 30599.5n 0.5119 30600.0n 0.6226 31199.5n 0.6226 31200.0n 0.6064 31799.5n 0.6064 31800.0n 0.4115 32399.5n 0.4115 32400.0n 0.3900 32999.5n 0.3900 33000.0n 0.3958 33599.5n 0.3958 33600.0n 0.3747 34199.5n 0.3747 34200.0n 0.5423 34799.5n 0.5423 34800.0n 0.5509 35399.5n 0.5509 35400.0n 0.3990 35999.5n 0.3990)
Vxn_wih_1_32 xn_wih_1_32 0 PWL(0.0n 0.4630 599.5n 0.4630 600.0n 0.4833 1199.5n 0.4833 1200.0n 0.5207 1799.5n 0.5207 1800.0n 0.5559 2399.5n 0.5559 2400.0n 0.5445 2999.5n 0.5445 3000.0n 0.4945 3599.5n 0.4945 3600.0n 0.5061 4199.5n 0.5061 4200.0n 0.4615 4799.5n 0.4615 4800.0n 0.4976 5399.5n 0.4976 5400.0n 0.4985 5999.5n 0.4985 6000.0n 0.5300 6599.5n 0.5300 6600.0n 0.4880 7199.5n 0.4880 7200.0n 0.4994 7799.5n 0.4994 7800.0n 0.5050 8399.5n 0.5050 8400.0n 0.4691 8999.5n 0.4691 9000.0n 0.4977 9599.5n 0.4977 9600.0n 0.5107 10199.5n 0.5107 10200.0n 0.5163 10799.5n 0.5163 10800.0n 0.5177 11399.5n 0.5177 11400.0n 0.4926 11999.5n 0.4926 12000.0n 0.4636 12599.5n 0.4636 12600.0n 0.5132 13199.5n 0.5132 13200.0n 0.4620 13799.5n 0.4620 13800.0n 0.4780 14399.5n 0.4780 14400.0n 0.4905 14999.5n 0.4905 15000.0n 0.5295 15599.5n 0.5295 15600.0n 0.4711 16199.5n 0.4711 16200.0n 0.4632 16799.5n 0.4632 16800.0n 0.4713 17399.5n 0.4713 17400.0n 0.4658 17999.5n 0.4658 18000.0n 0.5747 18599.5n 0.5747 18600.0n 0.4881 19199.5n 0.4881 19200.0n 0.5896 19799.5n 0.5896 19800.0n 0.5686 20399.5n 0.5686 20400.0n 0.5995 20999.5n 0.5995 21000.0n 0.5304 21599.5n 0.5304 21600.0n 0.5469 22199.5n 0.5469 22200.0n 0.4961 22799.5n 0.4961 22800.0n 0.6392 23399.5n 0.6392 23400.0n 0.3727 23999.5n 0.3727 24000.0n 0.6072 24599.5n 0.6072 24600.0n 0.4747 25199.5n 0.4747 25200.0n 0.5893 25799.5n 0.5893 25800.0n 0.6053 26399.5n 0.6053 26400.0n 0.6284 26999.5n 0.6284 27000.0n 0.5889 27599.5n 0.5889 27600.0n 0.6285 28199.5n 0.6285 28200.0n 0.4061 28799.5n 0.4061 28800.0n 0.6151 29399.5n 0.6151 29400.0n 0.5165 29999.5n 0.5165 30000.0n 0.4881 30599.5n 0.4881 30600.0n 0.3774 31199.5n 0.3774 31200.0n 0.3936 31799.5n 0.3936 31800.0n 0.5885 32399.5n 0.5885 32400.0n 0.6100 32999.5n 0.6100 33000.0n 0.6042 33599.5n 0.6042 33600.0n 0.6253 34199.5n 0.6253 34200.0n 0.4577 34799.5n 0.4577 34800.0n 0.4491 35399.5n 0.4491 35400.0n 0.6010 35999.5n 0.6010)
Vyp_wih_1_32 yp_wih_1_32 0 PWL(0.0n 0.3406 599.5n 0.3406 600.0n 0.3338 1199.5n 0.3338 1200.0n 0.3398 1799.5n 0.3398 1800.0n 0.3335 2399.5n 0.3335 2400.0n 0.3335 2999.5n 0.3335 3000.0n 0.3375 3599.5n 0.3375 3600.0n 0.3406 4199.5n 0.3406 4200.0n 0.3412 4799.5n 0.3412 4800.0n 0.3389 5399.5n 0.3389 5400.0n 0.3387 5999.5n 0.3387 6000.0n 0.3389 6599.5n 0.3389 6600.0n 0.3400 7199.5n 0.3400 7200.0n 0.3340 7799.5n 0.3340 7800.0n 0.3336 8399.5n 0.3336 8400.0n 0.3430 8999.5n 0.3430 9000.0n 0.3388 9599.5n 0.3388 9600.0n 0.3372 10199.5n 0.3372 10200.0n 0.3347 10799.5n 0.3347 10800.0n 0.3411 11399.5n 0.3411 11400.0n 0.3392 11999.5n 0.3392 12000.0n 0.3444 12599.5n 0.3444 12600.0n 0.3368 13199.5n 0.3368 13200.0n 0.3399 13799.5n 0.3399 13800.0n 0.3367 14399.5n 0.3367 14400.0n 0.3390 14999.5n 0.3390 15000.0n 0.3349 15599.5n 0.3349 15600.0n 0.3411 16199.5n 0.3411 16200.0n 0.3381 16799.5n 0.3381 16800.0n 0.3434 17399.5n 0.3434 17400.0n 0.3392 17999.5n 0.3392 18000.0n 0.3394 18599.5n 0.3394 18600.0n 0.3280 19199.5n 0.3280 19200.0n 0.3291 19799.5n 0.3291 19800.0n 0.3231 20399.5n 0.3231 20400.0n 0.3319 20999.5n 0.3319 21000.0n 0.3577 21599.5n 0.3577 21600.0n 0.3250 22199.5n 0.3250 22200.0n 0.3268 22799.5n 0.3268 22800.0n 0.3319 23399.5n 0.3319 23400.0n 0.3382 23999.5n 0.3382 24000.0n 0.3219 24599.5n 0.3219 24600.0n 0.3273 25199.5n 0.3273 25200.0n 0.3351 25799.5n 0.3351 25800.0n 0.3434 26399.5n 0.3434 26400.0n 0.3350 26999.5n 0.3350 27000.0n 0.3378 27599.5n 0.3378 27600.0n 0.3346 28199.5n 0.3346 28200.0n 0.3336 28799.5n 0.3336 28800.0n 0.3321 29399.5n 0.3321 29400.0n 0.3599 29999.5n 0.3599 30000.0n 0.3651 30599.5n 0.3651 30600.0n 0.3906 31199.5n 0.3906 31200.0n 0.3604 31799.5n 0.3604 31800.0n 0.3448 32399.5n 0.3448 32400.0n 0.3430 32999.5n 0.3430 33000.0n 0.3261 33599.5n 0.3261 33600.0n 0.3290 34199.5n 0.3290 34200.0n 0.3285 34799.5n 0.3285 34800.0n 0.3745 35399.5n 0.3745 35400.0n 0.3292 35999.5n 0.3292)
Vyn_wih_1_32 yn_wih_1_32 0 PWL(0.0n 0.6594 599.5n 0.6594 600.0n 0.6662 1199.5n 0.6662 1200.0n 0.6602 1799.5n 0.6602 1800.0n 0.6665 2399.5n 0.6665 2400.0n 0.6665 2999.5n 0.6665 3000.0n 0.6625 3599.5n 0.6625 3600.0n 0.6594 4199.5n 0.6594 4200.0n 0.6588 4799.5n 0.6588 4800.0n 0.6611 5399.5n 0.6611 5400.0n 0.6613 5999.5n 0.6613 6000.0n 0.6611 6599.5n 0.6611 6600.0n 0.6600 7199.5n 0.6600 7200.0n 0.6660 7799.5n 0.6660 7800.0n 0.6664 8399.5n 0.6664 8400.0n 0.6570 8999.5n 0.6570 9000.0n 0.6612 9599.5n 0.6612 9600.0n 0.6628 10199.5n 0.6628 10200.0n 0.6653 10799.5n 0.6653 10800.0n 0.6589 11399.5n 0.6589 11400.0n 0.6608 11999.5n 0.6608 12000.0n 0.6556 12599.5n 0.6556 12600.0n 0.6632 13199.5n 0.6632 13200.0n 0.6601 13799.5n 0.6601 13800.0n 0.6633 14399.5n 0.6633 14400.0n 0.6610 14999.5n 0.6610 15000.0n 0.6651 15599.5n 0.6651 15600.0n 0.6589 16199.5n 0.6589 16200.0n 0.6619 16799.5n 0.6619 16800.0n 0.6566 17399.5n 0.6566 17400.0n 0.6608 17999.5n 0.6608 18000.0n 0.6606 18599.5n 0.6606 18600.0n 0.6720 19199.5n 0.6720 19200.0n 0.6709 19799.5n 0.6709 19800.0n 0.6769 20399.5n 0.6769 20400.0n 0.6681 20999.5n 0.6681 21000.0n 0.6423 21599.5n 0.6423 21600.0n 0.6750 22199.5n 0.6750 22200.0n 0.6732 22799.5n 0.6732 22800.0n 0.6681 23399.5n 0.6681 23400.0n 0.6618 23999.5n 0.6618 24000.0n 0.6781 24599.5n 0.6781 24600.0n 0.6727 25199.5n 0.6727 25200.0n 0.6649 25799.5n 0.6649 25800.0n 0.6566 26399.5n 0.6566 26400.0n 0.6650 26999.5n 0.6650 27000.0n 0.6622 27599.5n 0.6622 27600.0n 0.6654 28199.5n 0.6654 28200.0n 0.6664 28799.5n 0.6664 28800.0n 0.6679 29399.5n 0.6679 29400.0n 0.6401 29999.5n 0.6401 30000.0n 0.6349 30599.5n 0.6349 30600.0n 0.6094 31199.5n 0.6094 31200.0n 0.6396 31799.5n 0.6396 31800.0n 0.6552 32399.5n 0.6552 32400.0n 0.6570 32999.5n 0.6570 33000.0n 0.6739 33599.5n 0.6739 33600.0n 0.6710 34199.5n 0.6710 34200.0n 0.6715 34799.5n 0.6715 34800.0n 0.6255 35399.5n 0.6255 35400.0n 0.6708 35999.5n 0.6708)
Cwp_wih_1_32 wp_wih_1_32 0 400p
Cwn_wih_1_32 wn_wih_1_32 0 400p
Xu_wih_1_32 xp_wih_1_32 xn_wih_1_32 yp_wih_1_32 yn_wih_1_32 wp_wih_1_32 wn_wih_1_32 vdd gbn gprod
Vxp_who_32_0 xp_who_32_0 0 PWL(0.0n 0.3406 599.5n 0.3406 600.0n 0.3338 1199.5n 0.3338 1200.0n 0.3398 1799.5n 0.3398 1800.0n 0.3335 2399.5n 0.3335 2400.0n 0.3335 2999.5n 0.3335 3000.0n 0.3375 3599.5n 0.3375 3600.0n 0.3406 4199.5n 0.3406 4200.0n 0.3412 4799.5n 0.3412 4800.0n 0.3389 5399.5n 0.3389 5400.0n 0.3387 5999.5n 0.3387 6000.0n 0.3389 6599.5n 0.3389 6600.0n 0.3400 7199.5n 0.3400 7200.0n 0.3340 7799.5n 0.3340 7800.0n 0.3336 8399.5n 0.3336 8400.0n 0.3430 8999.5n 0.3430 9000.0n 0.3388 9599.5n 0.3388 9600.0n 0.3372 10199.5n 0.3372 10200.0n 0.3347 10799.5n 0.3347 10800.0n 0.3411 11399.5n 0.3411 11400.0n 0.3392 11999.5n 0.3392 12000.0n 0.3444 12599.5n 0.3444 12600.0n 0.3368 13199.5n 0.3368 13200.0n 0.3399 13799.5n 0.3399 13800.0n 0.3367 14399.5n 0.3367 14400.0n 0.3390 14999.5n 0.3390 15000.0n 0.3349 15599.5n 0.3349 15600.0n 0.3411 16199.5n 0.3411 16200.0n 0.3381 16799.5n 0.3381 16800.0n 0.3434 17399.5n 0.3434 17400.0n 0.3392 17999.5n 0.3392 18000.0n 0.3394 18599.5n 0.3394 18600.0n 0.3280 19199.5n 0.3280 19200.0n 0.3291 19799.5n 0.3291 19800.0n 0.3231 20399.5n 0.3231 20400.0n 0.3319 20999.5n 0.3319 21000.0n 0.3577 21599.5n 0.3577 21600.0n 0.3250 22199.5n 0.3250 22200.0n 0.3268 22799.5n 0.3268 22800.0n 0.3319 23399.5n 0.3319 23400.0n 0.3382 23999.5n 0.3382 24000.0n 0.3219 24599.5n 0.3219 24600.0n 0.3273 25199.5n 0.3273 25200.0n 0.3351 25799.5n 0.3351 25800.0n 0.3434 26399.5n 0.3434 26400.0n 0.3350 26999.5n 0.3350 27000.0n 0.3378 27599.5n 0.3378 27600.0n 0.3346 28199.5n 0.3346 28200.0n 0.3336 28799.5n 0.3336 28800.0n 0.3321 29399.5n 0.3321 29400.0n 0.3599 29999.5n 0.3599 30000.0n 0.3651 30599.5n 0.3651 30600.0n 0.3906 31199.5n 0.3906 31200.0n 0.3604 31799.5n 0.3604 31800.0n 0.3448 32399.5n 0.3448 32400.0n 0.3430 32999.5n 0.3430 33000.0n 0.3261 33599.5n 0.3261 33600.0n 0.3290 34199.5n 0.3290 34200.0n 0.3285 34799.5n 0.3285 34800.0n 0.3745 35399.5n 0.3745 35400.0n 0.3292 35999.5n 0.3292)
Vxn_who_32_0 xn_who_32_0 0 PWL(0.0n 0.6594 599.5n 0.6594 600.0n 0.6662 1199.5n 0.6662 1200.0n 0.6602 1799.5n 0.6602 1800.0n 0.6665 2399.5n 0.6665 2400.0n 0.6665 2999.5n 0.6665 3000.0n 0.6625 3599.5n 0.6625 3600.0n 0.6594 4199.5n 0.6594 4200.0n 0.6588 4799.5n 0.6588 4800.0n 0.6611 5399.5n 0.6611 5400.0n 0.6613 5999.5n 0.6613 6000.0n 0.6611 6599.5n 0.6611 6600.0n 0.6600 7199.5n 0.6600 7200.0n 0.6660 7799.5n 0.6660 7800.0n 0.6664 8399.5n 0.6664 8400.0n 0.6570 8999.5n 0.6570 9000.0n 0.6612 9599.5n 0.6612 9600.0n 0.6628 10199.5n 0.6628 10200.0n 0.6653 10799.5n 0.6653 10800.0n 0.6589 11399.5n 0.6589 11400.0n 0.6608 11999.5n 0.6608 12000.0n 0.6556 12599.5n 0.6556 12600.0n 0.6632 13199.5n 0.6632 13200.0n 0.6601 13799.5n 0.6601 13800.0n 0.6633 14399.5n 0.6633 14400.0n 0.6610 14999.5n 0.6610 15000.0n 0.6651 15599.5n 0.6651 15600.0n 0.6589 16199.5n 0.6589 16200.0n 0.6619 16799.5n 0.6619 16800.0n 0.6566 17399.5n 0.6566 17400.0n 0.6608 17999.5n 0.6608 18000.0n 0.6606 18599.5n 0.6606 18600.0n 0.6720 19199.5n 0.6720 19200.0n 0.6709 19799.5n 0.6709 19800.0n 0.6769 20399.5n 0.6769 20400.0n 0.6681 20999.5n 0.6681 21000.0n 0.6423 21599.5n 0.6423 21600.0n 0.6750 22199.5n 0.6750 22200.0n 0.6732 22799.5n 0.6732 22800.0n 0.6681 23399.5n 0.6681 23400.0n 0.6618 23999.5n 0.6618 24000.0n 0.6781 24599.5n 0.6781 24600.0n 0.6727 25199.5n 0.6727 25200.0n 0.6649 25799.5n 0.6649 25800.0n 0.6566 26399.5n 0.6566 26400.0n 0.6650 26999.5n 0.6650 27000.0n 0.6622 27599.5n 0.6622 27600.0n 0.6654 28199.5n 0.6654 28200.0n 0.6664 28799.5n 0.6664 28800.0n 0.6679 29399.5n 0.6679 29400.0n 0.6401 29999.5n 0.6401 30000.0n 0.6349 30599.5n 0.6349 30600.0n 0.6094 31199.5n 0.6094 31200.0n 0.6396 31799.5n 0.6396 31800.0n 0.6552 32399.5n 0.6552 32400.0n 0.6570 32999.5n 0.6570 33000.0n 0.6739 33599.5n 0.6739 33600.0n 0.6710 34199.5n 0.6710 34200.0n 0.6715 34799.5n 0.6715 34800.0n 0.6255 35399.5n 0.6255 35400.0n 0.6708 35999.5n 0.6708)
Vyp_who_32_0 yp_who_32_0 0 PWL(0.0n 0.5031 599.5n 0.5031 600.0n 0.5023 1199.5n 0.5023 1200.0n 0.5052 1799.5n 0.5052 1800.0n 0.5048 2399.5n 0.5048 2400.0n 0.5043 2999.5n 0.5043 3000.0n 0.5034 3599.5n 0.5034 3600.0n 0.5048 4199.5n 0.5048 4200.0n 0.5031 4799.5n 0.5031 4800.0n 0.5040 5399.5n 0.5040 5400.0n 0.5040 5999.5n 0.5040 6000.0n 0.5054 6599.5n 0.5054 6600.0n 0.5040 7199.5n 0.5040 7200.0n 0.5027 7799.5n 0.5027 7800.0n 0.5027 8399.5n 0.5027 8400.0n 0.5038 8999.5n 0.5038 9000.0n 0.5040 9599.5n 0.5040 9600.0n 0.5039 10199.5n 0.5039 10200.0n 0.5033 10799.5n 0.5033 10800.0n 0.5056 11399.5n 0.5056 11400.0n 0.5040 11999.5n 0.5040 12000.0n 0.5036 12599.5n 0.5036 12600.0n 0.5039 13199.5n 0.5039 13200.0n 0.5029 13799.5n 0.5029 13800.0n 0.5025 14399.5n 0.5025 14400.0n 0.5038 14999.5n 0.5038 15000.0n 0.5041 15599.5n 0.5041 15600.0n 0.5036 16199.5n 0.5036 16200.0n 0.5025 16799.5n 0.5025 16800.0n 0.5040 17399.5n 0.5040 17400.0n 0.5029 17999.5n 0.5029 18000.0n 0.5057 18599.5n 0.5057 18600.0n 0.5010 19199.5n 0.5010 19200.0n 0.5041 19799.5n 0.5041 19800.0n 0.5021 20399.5n 0.5021 20400.0n 0.5044 20999.5n 0.5044 21000.0n 0.5056 21599.5n 0.5056 21600.0n 0.5016 22199.5n 0.5016 22200.0n 0.5006 22799.5n 0.5006 22800.0n 0.5041 23399.5n 0.5041 23400.0n 0.5027 23999.5n 0.5027 24000.0n 0.5029 24599.5n 0.5029 24600.0n 0.5006 25199.5n 0.5006 25200.0n 0.5047 25799.5n 0.5047 25800.0n 0.5046 26399.5n 0.5046 26400.0n 0.5039 26999.5n 0.5039 27000.0n 0.5049 27599.5n 0.5049 27600.0n 0.5039 28199.5n 0.5039 28200.0n 0.5017 28799.5n 0.5017 28800.0n 0.5042 29399.5n 0.5042 29400.0n 0.5056 29999.5n 0.5056 30000.0n 0.5051 30599.5n 0.5051 30600.0n 0.5039 31199.5n 0.5039 31200.0n 0.5033 31799.5n 0.5033 31800.0n 0.5049 32399.5n 0.5049 32400.0n 0.5045 32999.5n 0.5045 33000.0n 0.5036 33599.5n 0.5036 33600.0n 0.5042 34199.5n 0.5042 34200.0n 0.5012 34799.5n 0.5012 34800.0n 0.5036 35399.5n 0.5036 35400.0n 0.5042 35999.5n 0.5042)
Vyn_who_32_0 yn_who_32_0 0 PWL(0.0n 0.4969 599.5n 0.4969 600.0n 0.4977 1199.5n 0.4977 1200.0n 0.4948 1799.5n 0.4948 1800.0n 0.4952 2399.5n 0.4952 2400.0n 0.4957 2999.5n 0.4957 3000.0n 0.4966 3599.5n 0.4966 3600.0n 0.4952 4199.5n 0.4952 4200.0n 0.4969 4799.5n 0.4969 4800.0n 0.4960 5399.5n 0.4960 5400.0n 0.4960 5999.5n 0.4960 6000.0n 0.4946 6599.5n 0.4946 6600.0n 0.4960 7199.5n 0.4960 7200.0n 0.4973 7799.5n 0.4973 7800.0n 0.4973 8399.5n 0.4973 8400.0n 0.4962 8999.5n 0.4962 9000.0n 0.4960 9599.5n 0.4960 9600.0n 0.4961 10199.5n 0.4961 10200.0n 0.4967 10799.5n 0.4967 10800.0n 0.4944 11399.5n 0.4944 11400.0n 0.4960 11999.5n 0.4960 12000.0n 0.4964 12599.5n 0.4964 12600.0n 0.4961 13199.5n 0.4961 13200.0n 0.4971 13799.5n 0.4971 13800.0n 0.4975 14399.5n 0.4975 14400.0n 0.4962 14999.5n 0.4962 15000.0n 0.4959 15599.5n 0.4959 15600.0n 0.4964 16199.5n 0.4964 16200.0n 0.4975 16799.5n 0.4975 16800.0n 0.4960 17399.5n 0.4960 17400.0n 0.4971 17999.5n 0.4971 18000.0n 0.4943 18599.5n 0.4943 18600.0n 0.4990 19199.5n 0.4990 19200.0n 0.4959 19799.5n 0.4959 19800.0n 0.4979 20399.5n 0.4979 20400.0n 0.4956 20999.5n 0.4956 21000.0n 0.4944 21599.5n 0.4944 21600.0n 0.4984 22199.5n 0.4984 22200.0n 0.4994 22799.5n 0.4994 22800.0n 0.4959 23399.5n 0.4959 23400.0n 0.4973 23999.5n 0.4973 24000.0n 0.4971 24599.5n 0.4971 24600.0n 0.4994 25199.5n 0.4994 25200.0n 0.4953 25799.5n 0.4953 25800.0n 0.4954 26399.5n 0.4954 26400.0n 0.4961 26999.5n 0.4961 27000.0n 0.4951 27599.5n 0.4951 27600.0n 0.4961 28199.5n 0.4961 28200.0n 0.4983 28799.5n 0.4983 28800.0n 0.4958 29399.5n 0.4958 29400.0n 0.4944 29999.5n 0.4944 30000.0n 0.4949 30599.5n 0.4949 30600.0n 0.4961 31199.5n 0.4961 31200.0n 0.4967 31799.5n 0.4967 31800.0n 0.4951 32399.5n 0.4951 32400.0n 0.4955 32999.5n 0.4955 33000.0n 0.4964 33599.5n 0.4964 33600.0n 0.4958 34199.5n 0.4958 34200.0n 0.4988 34799.5n 0.4988 34800.0n 0.4964 35399.5n 0.4964 35400.0n 0.4958 35999.5n 0.4958)
Cwp_who_32_0 wp_who_32_0 0 400p
Cwn_who_32_0 wn_who_32_0 0 400p
Xu_who_32_0 xp_who_32_0 xn_who_32_0 yp_who_32_0 yn_who_32_0 wp_who_32_0 wn_who_32_0 vdd gbn gprod
Vxp_who_32_1 xp_who_32_1 0 PWL(0.0n 0.3406 599.5n 0.3406 600.0n 0.3338 1199.5n 0.3338 1200.0n 0.3398 1799.5n 0.3398 1800.0n 0.3335 2399.5n 0.3335 2400.0n 0.3335 2999.5n 0.3335 3000.0n 0.3375 3599.5n 0.3375 3600.0n 0.3406 4199.5n 0.3406 4200.0n 0.3412 4799.5n 0.3412 4800.0n 0.3389 5399.5n 0.3389 5400.0n 0.3387 5999.5n 0.3387 6000.0n 0.3389 6599.5n 0.3389 6600.0n 0.3400 7199.5n 0.3400 7200.0n 0.3340 7799.5n 0.3340 7800.0n 0.3336 8399.5n 0.3336 8400.0n 0.3430 8999.5n 0.3430 9000.0n 0.3388 9599.5n 0.3388 9600.0n 0.3372 10199.5n 0.3372 10200.0n 0.3347 10799.5n 0.3347 10800.0n 0.3411 11399.5n 0.3411 11400.0n 0.3392 11999.5n 0.3392 12000.0n 0.3444 12599.5n 0.3444 12600.0n 0.3368 13199.5n 0.3368 13200.0n 0.3399 13799.5n 0.3399 13800.0n 0.3367 14399.5n 0.3367 14400.0n 0.3390 14999.5n 0.3390 15000.0n 0.3349 15599.5n 0.3349 15600.0n 0.3411 16199.5n 0.3411 16200.0n 0.3381 16799.5n 0.3381 16800.0n 0.3434 17399.5n 0.3434 17400.0n 0.3392 17999.5n 0.3392 18000.0n 0.3394 18599.5n 0.3394 18600.0n 0.3280 19199.5n 0.3280 19200.0n 0.3291 19799.5n 0.3291 19800.0n 0.3231 20399.5n 0.3231 20400.0n 0.3319 20999.5n 0.3319 21000.0n 0.3577 21599.5n 0.3577 21600.0n 0.3250 22199.5n 0.3250 22200.0n 0.3268 22799.5n 0.3268 22800.0n 0.3319 23399.5n 0.3319 23400.0n 0.3382 23999.5n 0.3382 24000.0n 0.3219 24599.5n 0.3219 24600.0n 0.3273 25199.5n 0.3273 25200.0n 0.3351 25799.5n 0.3351 25800.0n 0.3434 26399.5n 0.3434 26400.0n 0.3350 26999.5n 0.3350 27000.0n 0.3378 27599.5n 0.3378 27600.0n 0.3346 28199.5n 0.3346 28200.0n 0.3336 28799.5n 0.3336 28800.0n 0.3321 29399.5n 0.3321 29400.0n 0.3599 29999.5n 0.3599 30000.0n 0.3651 30599.5n 0.3651 30600.0n 0.3906 31199.5n 0.3906 31200.0n 0.3604 31799.5n 0.3604 31800.0n 0.3448 32399.5n 0.3448 32400.0n 0.3430 32999.5n 0.3430 33000.0n 0.3261 33599.5n 0.3261 33600.0n 0.3290 34199.5n 0.3290 34200.0n 0.3285 34799.5n 0.3285 34800.0n 0.3745 35399.5n 0.3745 35400.0n 0.3292 35999.5n 0.3292)
Vxn_who_32_1 xn_who_32_1 0 PWL(0.0n 0.6594 599.5n 0.6594 600.0n 0.6662 1199.5n 0.6662 1200.0n 0.6602 1799.5n 0.6602 1800.0n 0.6665 2399.5n 0.6665 2400.0n 0.6665 2999.5n 0.6665 3000.0n 0.6625 3599.5n 0.6625 3600.0n 0.6594 4199.5n 0.6594 4200.0n 0.6588 4799.5n 0.6588 4800.0n 0.6611 5399.5n 0.6611 5400.0n 0.6613 5999.5n 0.6613 6000.0n 0.6611 6599.5n 0.6611 6600.0n 0.6600 7199.5n 0.6600 7200.0n 0.6660 7799.5n 0.6660 7800.0n 0.6664 8399.5n 0.6664 8400.0n 0.6570 8999.5n 0.6570 9000.0n 0.6612 9599.5n 0.6612 9600.0n 0.6628 10199.5n 0.6628 10200.0n 0.6653 10799.5n 0.6653 10800.0n 0.6589 11399.5n 0.6589 11400.0n 0.6608 11999.5n 0.6608 12000.0n 0.6556 12599.5n 0.6556 12600.0n 0.6632 13199.5n 0.6632 13200.0n 0.6601 13799.5n 0.6601 13800.0n 0.6633 14399.5n 0.6633 14400.0n 0.6610 14999.5n 0.6610 15000.0n 0.6651 15599.5n 0.6651 15600.0n 0.6589 16199.5n 0.6589 16200.0n 0.6619 16799.5n 0.6619 16800.0n 0.6566 17399.5n 0.6566 17400.0n 0.6608 17999.5n 0.6608 18000.0n 0.6606 18599.5n 0.6606 18600.0n 0.6720 19199.5n 0.6720 19200.0n 0.6709 19799.5n 0.6709 19800.0n 0.6769 20399.5n 0.6769 20400.0n 0.6681 20999.5n 0.6681 21000.0n 0.6423 21599.5n 0.6423 21600.0n 0.6750 22199.5n 0.6750 22200.0n 0.6732 22799.5n 0.6732 22800.0n 0.6681 23399.5n 0.6681 23400.0n 0.6618 23999.5n 0.6618 24000.0n 0.6781 24599.5n 0.6781 24600.0n 0.6727 25199.5n 0.6727 25200.0n 0.6649 25799.5n 0.6649 25800.0n 0.6566 26399.5n 0.6566 26400.0n 0.6650 26999.5n 0.6650 27000.0n 0.6622 27599.5n 0.6622 27600.0n 0.6654 28199.5n 0.6654 28200.0n 0.6664 28799.5n 0.6664 28800.0n 0.6679 29399.5n 0.6679 29400.0n 0.6401 29999.5n 0.6401 30000.0n 0.6349 30599.5n 0.6349 30600.0n 0.6094 31199.5n 0.6094 31200.0n 0.6396 31799.5n 0.6396 31800.0n 0.6552 32399.5n 0.6552 32400.0n 0.6570 32999.5n 0.6570 33000.0n 0.6739 33599.5n 0.6739 33600.0n 0.6710 34199.5n 0.6710 34200.0n 0.6715 34799.5n 0.6715 34800.0n 0.6255 35399.5n 0.6255 35400.0n 0.6708 35999.5n 0.6708)
Vyp_who_32_1 yp_who_32_1 0 PWL(0.0n 0.5071 599.5n 0.5071 600.0n 0.5053 1199.5n 0.5053 1200.0n 0.5052 1799.5n 0.5052 1800.0n 0.5027 2399.5n 0.5027 2400.0n 0.5034 2999.5n 0.5034 3000.0n 0.5055 3599.5n 0.5055 3600.0n 0.5056 4199.5n 0.5056 4200.0n 0.5071 4799.5n 0.5071 4800.0n 0.5056 5399.5n 0.5056 5400.0n 0.5056 5999.5n 0.5056 6000.0n 0.5048 6599.5n 0.5048 6600.0n 0.5060 7199.5n 0.5060 7200.0n 0.5048 7799.5n 0.5048 7800.0n 0.5046 8399.5n 0.5046 8400.0n 0.5066 8999.5n 0.5066 9000.0n 0.5056 9599.5n 0.5056 9600.0n 0.5051 10199.5n 0.5051 10200.0n 0.5046 10799.5n 0.5046 10800.0n 0.5056 11399.5n 0.5056 11400.0n 0.5058 11999.5n 0.5058 12000.0n 0.5068 12599.5n 0.5068 12600.0n 0.5050 13199.5n 0.5050 13200.0n 0.5071 13799.5n 0.5071 13800.0n 0.5059 14399.5n 0.5059 14400.0n 0.5058 14999.5n 0.5058 15000.0n 0.5043 15599.5n 0.5043 15600.0n 0.5067 16199.5n 0.5067 16200.0n 0.5068 16799.5n 0.5068 16800.0n 0.5066 17399.5n 0.5066 17400.0n 0.5069 17999.5n 0.5069 18000.0n 0.5061 18599.5n 0.5061 18600.0n 0.5034 19199.5n 0.5034 19200.0n 0.5010 19799.5n 0.5010 19800.0n 0.4989 20399.5n 0.4989 20400.0n 0.5022 20999.5n 0.5022 21000.0n 0.5086 21599.5n 0.5086 21600.0n 0.5007 22199.5n 0.5007 22200.0n 0.5023 22799.5n 0.5023 22800.0n 0.5021 23399.5n 0.5021 23400.0n 0.5077 23999.5n 0.5077 24000.0n 0.4979 24599.5n 0.4979 24600.0n 0.5035 25199.5n 0.5035 25200.0n 0.5041 25799.5n 0.5041 25800.0n 0.5075 26399.5n 0.5075 26400.0n 0.5041 26999.5n 0.5041 27000.0n 0.5056 27599.5n 0.5056 27600.0n 0.5039 28199.5n 0.5039 28200.0n 0.5059 28799.5n 0.5059 28800.0n 0.5023 29399.5n 0.5023 29400.0n 0.5086 29999.5n 0.5086 30000.0n 0.5084 30599.5n 0.5084 30600.0n 0.5085 31199.5n 0.5085 31200.0n 0.5088 31799.5n 0.5088 31800.0n 0.5078 32399.5n 0.5078 32400.0n 0.5074 32999.5n 0.5074 33000.0n 0.4996 33599.5n 0.4996 33600.0n 0.5010 34199.5n 0.5010 34200.0n 0.5044 34799.5n 0.5044 34800.0n 0.5084 35399.5n 0.5084 35400.0n 0.5012 35999.5n 0.5012)
Vyn_who_32_1 yn_who_32_1 0 PWL(0.0n 0.4929 599.5n 0.4929 600.0n 0.4947 1199.5n 0.4947 1200.0n 0.4948 1799.5n 0.4948 1800.0n 0.4973 2399.5n 0.4973 2400.0n 0.4966 2999.5n 0.4966 3000.0n 0.4945 3599.5n 0.4945 3600.0n 0.4944 4199.5n 0.4944 4200.0n 0.4929 4799.5n 0.4929 4800.0n 0.4944 5399.5n 0.4944 5400.0n 0.4944 5999.5n 0.4944 6000.0n 0.4952 6599.5n 0.4952 6600.0n 0.4940 7199.5n 0.4940 7200.0n 0.4952 7799.5n 0.4952 7800.0n 0.4954 8399.5n 0.4954 8400.0n 0.4934 8999.5n 0.4934 9000.0n 0.4944 9599.5n 0.4944 9600.0n 0.4949 10199.5n 0.4949 10200.0n 0.4954 10799.5n 0.4954 10800.0n 0.4944 11399.5n 0.4944 11400.0n 0.4942 11999.5n 0.4942 12000.0n 0.4932 12599.5n 0.4932 12600.0n 0.4950 13199.5n 0.4950 13200.0n 0.4929 13799.5n 0.4929 13800.0n 0.4941 14399.5n 0.4941 14400.0n 0.4942 14999.5n 0.4942 15000.0n 0.4957 15599.5n 0.4957 15600.0n 0.4933 16199.5n 0.4933 16200.0n 0.4932 16799.5n 0.4932 16800.0n 0.4934 17399.5n 0.4934 17400.0n 0.4931 17999.5n 0.4931 18000.0n 0.4939 18599.5n 0.4939 18600.0n 0.4966 19199.5n 0.4966 19200.0n 0.4990 19799.5n 0.4990 19800.0n 0.5011 20399.5n 0.5011 20400.0n 0.4978 20999.5n 0.4978 21000.0n 0.4914 21599.5n 0.4914 21600.0n 0.4993 22199.5n 0.4993 22200.0n 0.4977 22799.5n 0.4977 22800.0n 0.4979 23399.5n 0.4979 23400.0n 0.4923 23999.5n 0.4923 24000.0n 0.5021 24599.5n 0.5021 24600.0n 0.4965 25199.5n 0.4965 25200.0n 0.4959 25799.5n 0.4959 25800.0n 0.4925 26399.5n 0.4925 26400.0n 0.4959 26999.5n 0.4959 27000.0n 0.4944 27599.5n 0.4944 27600.0n 0.4961 28199.5n 0.4961 28200.0n 0.4941 28799.5n 0.4941 28800.0n 0.4977 29399.5n 0.4977 29400.0n 0.4914 29999.5n 0.4914 30000.0n 0.4916 30599.5n 0.4916 30600.0n 0.4915 31199.5n 0.4915 31200.0n 0.4912 31799.5n 0.4912 31800.0n 0.4922 32399.5n 0.4922 32400.0n 0.4926 32999.5n 0.4926 33000.0n 0.5004 33599.5n 0.5004 33600.0n 0.4990 34199.5n 0.4990 34200.0n 0.4956 34799.5n 0.4956 34800.0n 0.4916 35399.5n 0.4916 35400.0n 0.4988 35999.5n 0.4988)
Cwp_who_32_1 wp_who_32_1 0 400p
Cwn_who_32_1 wn_who_32_1 0 400p
Xu_who_32_1 xp_who_32_1 xn_who_32_1 yp_who_32_1 yn_who_32_1 wp_who_32_1 wn_who_32_1 vdd gbn gprod
Vxp_bh_32 xp_bh_32 0 PWL(0.0n 0.7100 599.5n 0.7100 600.0n 0.7100 1199.5n 0.7100 1200.0n 0.7100 1799.5n 0.7100 1800.0n 0.7100 2399.5n 0.7100 2400.0n 0.7100 2999.5n 0.7100 3000.0n 0.7100 3599.5n 0.7100 3600.0n 0.7100 4199.5n 0.7100 4200.0n 0.7100 4799.5n 0.7100 4800.0n 0.7100 5399.5n 0.7100 5400.0n 0.7100 5999.5n 0.7100 6000.0n 0.7100 6599.5n 0.7100 6600.0n 0.7100 7199.5n 0.7100 7200.0n 0.7100 7799.5n 0.7100 7800.0n 0.7100 8399.5n 0.7100 8400.0n 0.7100 8999.5n 0.7100 9000.0n 0.7100 9599.5n 0.7100 9600.0n 0.7100 10199.5n 0.7100 10200.0n 0.7100 10799.5n 0.7100 10800.0n 0.7100 11399.5n 0.7100 11400.0n 0.7100 11999.5n 0.7100 12000.0n 0.7100 12599.5n 0.7100 12600.0n 0.7100 13199.5n 0.7100 13200.0n 0.7100 13799.5n 0.7100 13800.0n 0.7100 14399.5n 0.7100 14400.0n 0.7100 14999.5n 0.7100 15000.0n 0.7100 15599.5n 0.7100 15600.0n 0.7100 16199.5n 0.7100 16200.0n 0.7100 16799.5n 0.7100 16800.0n 0.7100 17399.5n 0.7100 17400.0n 0.7100 17999.5n 0.7100 18000.0n 0.7100 18599.5n 0.7100 18600.0n 0.7100 19199.5n 0.7100 19200.0n 0.7100 19799.5n 0.7100 19800.0n 0.7100 20399.5n 0.7100 20400.0n 0.7100 20999.5n 0.7100 21000.0n 0.7100 21599.5n 0.7100 21600.0n 0.7100 22199.5n 0.7100 22200.0n 0.7100 22799.5n 0.7100 22800.0n 0.7100 23399.5n 0.7100 23400.0n 0.7100 23999.5n 0.7100 24000.0n 0.7100 24599.5n 0.7100 24600.0n 0.7100 25199.5n 0.7100 25200.0n 0.7100 25799.5n 0.7100 25800.0n 0.7100 26399.5n 0.7100 26400.0n 0.7100 26999.5n 0.7100 27000.0n 0.7100 27599.5n 0.7100 27600.0n 0.7100 28199.5n 0.7100 28200.0n 0.7100 28799.5n 0.7100 28800.0n 0.7100 29399.5n 0.7100 29400.0n 0.7100 29999.5n 0.7100 30000.0n 0.7100 30599.5n 0.7100 30600.0n 0.7100 31199.5n 0.7100 31200.0n 0.7100 31799.5n 0.7100 31800.0n 0.7100 32399.5n 0.7100 32400.0n 0.7100 32999.5n 0.7100 33000.0n 0.7100 33599.5n 0.7100 33600.0n 0.7100 34199.5n 0.7100 34200.0n 0.7100 34799.5n 0.7100 34800.0n 0.7100 35399.5n 0.7100 35400.0n 0.7100 35999.5n 0.7100)
Vxn_bh_32 xn_bh_32 0 PWL(0.0n 0.2900 599.5n 0.2900 600.0n 0.2900 1199.5n 0.2900 1200.0n 0.2900 1799.5n 0.2900 1800.0n 0.2900 2399.5n 0.2900 2400.0n 0.2900 2999.5n 0.2900 3000.0n 0.2900 3599.5n 0.2900 3600.0n 0.2900 4199.5n 0.2900 4200.0n 0.2900 4799.5n 0.2900 4800.0n 0.2900 5399.5n 0.2900 5400.0n 0.2900 5999.5n 0.2900 6000.0n 0.2900 6599.5n 0.2900 6600.0n 0.2900 7199.5n 0.2900 7200.0n 0.2900 7799.5n 0.2900 7800.0n 0.2900 8399.5n 0.2900 8400.0n 0.2900 8999.5n 0.2900 9000.0n 0.2900 9599.5n 0.2900 9600.0n 0.2900 10199.5n 0.2900 10200.0n 0.2900 10799.5n 0.2900 10800.0n 0.2900 11399.5n 0.2900 11400.0n 0.2900 11999.5n 0.2900 12000.0n 0.2900 12599.5n 0.2900 12600.0n 0.2900 13199.5n 0.2900 13200.0n 0.2900 13799.5n 0.2900 13800.0n 0.2900 14399.5n 0.2900 14400.0n 0.2900 14999.5n 0.2900 15000.0n 0.2900 15599.5n 0.2900 15600.0n 0.2900 16199.5n 0.2900 16200.0n 0.2900 16799.5n 0.2900 16800.0n 0.2900 17399.5n 0.2900 17400.0n 0.2900 17999.5n 0.2900 18000.0n 0.2900 18599.5n 0.2900 18600.0n 0.2900 19199.5n 0.2900 19200.0n 0.2900 19799.5n 0.2900 19800.0n 0.2900 20399.5n 0.2900 20400.0n 0.2900 20999.5n 0.2900 21000.0n 0.2900 21599.5n 0.2900 21600.0n 0.2900 22199.5n 0.2900 22200.0n 0.2900 22799.5n 0.2900 22800.0n 0.2900 23399.5n 0.2900 23400.0n 0.2900 23999.5n 0.2900 24000.0n 0.2900 24599.5n 0.2900 24600.0n 0.2900 25199.5n 0.2900 25200.0n 0.2900 25799.5n 0.2900 25800.0n 0.2900 26399.5n 0.2900 26400.0n 0.2900 26999.5n 0.2900 27000.0n 0.2900 27599.5n 0.2900 27600.0n 0.2900 28199.5n 0.2900 28200.0n 0.2900 28799.5n 0.2900 28800.0n 0.2900 29399.5n 0.2900 29400.0n 0.2900 29999.5n 0.2900 30000.0n 0.2900 30599.5n 0.2900 30600.0n 0.2900 31199.5n 0.2900 31200.0n 0.2900 31799.5n 0.2900 31800.0n 0.2900 32399.5n 0.2900 32400.0n 0.2900 32999.5n 0.2900 33000.0n 0.2900 33599.5n 0.2900 33600.0n 0.2900 34199.5n 0.2900 34200.0n 0.2900 34799.5n 0.2900 34800.0n 0.2900 35399.5n 0.2900 35400.0n 0.2900 35999.5n 0.2900)
Vyp_bh_32 yp_bh_32 0 PWL(0.0n 0.3406 599.5n 0.3406 600.0n 0.3338 1199.5n 0.3338 1200.0n 0.3398 1799.5n 0.3398 1800.0n 0.3335 2399.5n 0.3335 2400.0n 0.3335 2999.5n 0.3335 3000.0n 0.3375 3599.5n 0.3375 3600.0n 0.3406 4199.5n 0.3406 4200.0n 0.3412 4799.5n 0.3412 4800.0n 0.3389 5399.5n 0.3389 5400.0n 0.3387 5999.5n 0.3387 6000.0n 0.3389 6599.5n 0.3389 6600.0n 0.3400 7199.5n 0.3400 7200.0n 0.3340 7799.5n 0.3340 7800.0n 0.3336 8399.5n 0.3336 8400.0n 0.3430 8999.5n 0.3430 9000.0n 0.3388 9599.5n 0.3388 9600.0n 0.3372 10199.5n 0.3372 10200.0n 0.3347 10799.5n 0.3347 10800.0n 0.3411 11399.5n 0.3411 11400.0n 0.3392 11999.5n 0.3392 12000.0n 0.3444 12599.5n 0.3444 12600.0n 0.3368 13199.5n 0.3368 13200.0n 0.3399 13799.5n 0.3399 13800.0n 0.3367 14399.5n 0.3367 14400.0n 0.3390 14999.5n 0.3390 15000.0n 0.3349 15599.5n 0.3349 15600.0n 0.3411 16199.5n 0.3411 16200.0n 0.3381 16799.5n 0.3381 16800.0n 0.3434 17399.5n 0.3434 17400.0n 0.3392 17999.5n 0.3392 18000.0n 0.3394 18599.5n 0.3394 18600.0n 0.3280 19199.5n 0.3280 19200.0n 0.3291 19799.5n 0.3291 19800.0n 0.3231 20399.5n 0.3231 20400.0n 0.3319 20999.5n 0.3319 21000.0n 0.3577 21599.5n 0.3577 21600.0n 0.3250 22199.5n 0.3250 22200.0n 0.3268 22799.5n 0.3268 22800.0n 0.3319 23399.5n 0.3319 23400.0n 0.3382 23999.5n 0.3382 24000.0n 0.3219 24599.5n 0.3219 24600.0n 0.3273 25199.5n 0.3273 25200.0n 0.3351 25799.5n 0.3351 25800.0n 0.3434 26399.5n 0.3434 26400.0n 0.3350 26999.5n 0.3350 27000.0n 0.3378 27599.5n 0.3378 27600.0n 0.3346 28199.5n 0.3346 28200.0n 0.3336 28799.5n 0.3336 28800.0n 0.3321 29399.5n 0.3321 29400.0n 0.3599 29999.5n 0.3599 30000.0n 0.3651 30599.5n 0.3651 30600.0n 0.3906 31199.5n 0.3906 31200.0n 0.3604 31799.5n 0.3604 31800.0n 0.3448 32399.5n 0.3448 32400.0n 0.3430 32999.5n 0.3430 33000.0n 0.3261 33599.5n 0.3261 33600.0n 0.3290 34199.5n 0.3290 34200.0n 0.3285 34799.5n 0.3285 34800.0n 0.3745 35399.5n 0.3745 35400.0n 0.3292 35999.5n 0.3292)
Vyn_bh_32 yn_bh_32 0 PWL(0.0n 0.6594 599.5n 0.6594 600.0n 0.6662 1199.5n 0.6662 1200.0n 0.6602 1799.5n 0.6602 1800.0n 0.6665 2399.5n 0.6665 2400.0n 0.6665 2999.5n 0.6665 3000.0n 0.6625 3599.5n 0.6625 3600.0n 0.6594 4199.5n 0.6594 4200.0n 0.6588 4799.5n 0.6588 4800.0n 0.6611 5399.5n 0.6611 5400.0n 0.6613 5999.5n 0.6613 6000.0n 0.6611 6599.5n 0.6611 6600.0n 0.6600 7199.5n 0.6600 7200.0n 0.6660 7799.5n 0.6660 7800.0n 0.6664 8399.5n 0.6664 8400.0n 0.6570 8999.5n 0.6570 9000.0n 0.6612 9599.5n 0.6612 9600.0n 0.6628 10199.5n 0.6628 10200.0n 0.6653 10799.5n 0.6653 10800.0n 0.6589 11399.5n 0.6589 11400.0n 0.6608 11999.5n 0.6608 12000.0n 0.6556 12599.5n 0.6556 12600.0n 0.6632 13199.5n 0.6632 13200.0n 0.6601 13799.5n 0.6601 13800.0n 0.6633 14399.5n 0.6633 14400.0n 0.6610 14999.5n 0.6610 15000.0n 0.6651 15599.5n 0.6651 15600.0n 0.6589 16199.5n 0.6589 16200.0n 0.6619 16799.5n 0.6619 16800.0n 0.6566 17399.5n 0.6566 17400.0n 0.6608 17999.5n 0.6608 18000.0n 0.6606 18599.5n 0.6606 18600.0n 0.6720 19199.5n 0.6720 19200.0n 0.6709 19799.5n 0.6709 19800.0n 0.6769 20399.5n 0.6769 20400.0n 0.6681 20999.5n 0.6681 21000.0n 0.6423 21599.5n 0.6423 21600.0n 0.6750 22199.5n 0.6750 22200.0n 0.6732 22799.5n 0.6732 22800.0n 0.6681 23399.5n 0.6681 23400.0n 0.6618 23999.5n 0.6618 24000.0n 0.6781 24599.5n 0.6781 24600.0n 0.6727 25199.5n 0.6727 25200.0n 0.6649 25799.5n 0.6649 25800.0n 0.6566 26399.5n 0.6566 26400.0n 0.6650 26999.5n 0.6650 27000.0n 0.6622 27599.5n 0.6622 27600.0n 0.6654 28199.5n 0.6654 28200.0n 0.6664 28799.5n 0.6664 28800.0n 0.6679 29399.5n 0.6679 29400.0n 0.6401 29999.5n 0.6401 30000.0n 0.6349 30599.5n 0.6349 30600.0n 0.6094 31199.5n 0.6094 31200.0n 0.6396 31799.5n 0.6396 31800.0n 0.6552 32399.5n 0.6552 32400.0n 0.6570 32999.5n 0.6570 33000.0n 0.6739 33599.5n 0.6739 33600.0n 0.6710 34199.5n 0.6710 34200.0n 0.6715 34799.5n 0.6715 34800.0n 0.6255 35399.5n 0.6255 35400.0n 0.6708 35999.5n 0.6708)
Cwp_bh_32 wp_bh_32 0 400p
Cwn_bh_32 wn_bh_32 0 400p
Xu_bh_32 xp_bh_32 xn_bh_32 yp_bh_32 yn_bh_32 wp_bh_32 wn_bh_32 vdd gbn gprod
Vxp_wih_0_33 xp_wih_0_33 0 PWL(0.0n 0.4942 599.5n 0.4942 600.0n 0.5558 1199.5n 0.5558 1200.0n 0.4708 1799.5n 0.4708 1800.0n 0.5235 2399.5n 0.5235 2400.0n 0.5350 2999.5n 0.5350 3000.0n 0.5172 3599.5n 0.5172 3600.0n 0.4702 4199.5n 0.4702 4200.0n 0.4867 4799.5n 0.4867 4800.0n 0.4970 5399.5n 0.4970 5400.0n 0.4986 5999.5n 0.4986 6000.0n 0.4751 6599.5n 0.4751 6600.0n 0.4870 7199.5n 0.4870 7200.0n 0.5502 7799.5n 0.5502 7800.0n 0.5521 8399.5n 0.5521 8400.0n 0.4638 8999.5n 0.4638 9000.0n 0.4982 9599.5n 0.4982 9600.0n 0.5131 10199.5n 0.5131 10200.0n 0.5386 10799.5n 0.5386 10800.0n 0.4592 11399.5n 0.4592 11400.0n 0.4950 11999.5n 0.4950 12000.0n 0.4559 12599.5n 0.4559 12600.0n 0.5162 13199.5n 0.5162 13200.0n 0.5038 13799.5n 0.5038 13800.0n 0.5333 14399.5n 0.5333 14400.0n 0.4991 14999.5n 0.4991 15000.0n 0.5298 15599.5n 0.5298 15600.0n 0.4823 16199.5n 0.4823 16200.0n 0.5239 16799.5n 0.5239 16800.0n 0.4592 17399.5n 0.4592 17400.0n 0.5094 17999.5n 0.5094 18000.0n 0.4337 18599.5n 0.4337 18600.0n 0.5977 19199.5n 0.5977 19200.0n 0.5364 19799.5n 0.5364 19800.0n 0.6122 20399.5n 0.6122 20400.0n 0.4856 20999.5n 0.4856 21000.0n 0.3861 21599.5n 0.3861 21600.0n 0.6094 22199.5n 0.6094 22200.0n 0.6364 22799.5n 0.6364 22800.0n 0.4807 23399.5n 0.4807 23400.0n 0.5614 23999.5n 0.5614 24000.0n 0.5913 24599.5n 0.5913 24600.0n 0.6295 25199.5n 0.6295 25200.0n 0.4496 25799.5n 0.4496 25800.0n 0.3792 26399.5n 0.3792 26400.0n 0.4434 26999.5n 0.4434 27000.0n 0.4340 27599.5n 0.4340 27600.0n 0.4461 28199.5n 0.4461 28200.0n 0.5791 28799.5n 0.5791 28800.0n 0.4777 29399.5n 0.4777 29400.0n 0.3878 29999.5n 0.3878 30000.0n 0.3832 30599.5n 0.3832 30600.0n 0.4022 31199.5n 0.4022 31200.0n 0.4482 31799.5n 0.4482 31800.0n 0.3662 32399.5n 0.3662 32400.0n 0.3857 32999.5n 0.3857 33000.0n 0.5584 33599.5n 0.5584 33600.0n 0.5284 34199.5n 0.5284 34200.0n 0.6034 34799.5n 0.6034 34800.0n 0.3469 35399.5n 0.3469 35400.0n 0.5290 35999.5n 0.5290)
Vxn_wih_0_33 xn_wih_0_33 0 PWL(0.0n 0.5058 599.5n 0.5058 600.0n 0.4442 1199.5n 0.4442 1200.0n 0.5292 1799.5n 0.5292 1800.0n 0.4765 2399.5n 0.4765 2400.0n 0.4650 2999.5n 0.4650 3000.0n 0.4828 3599.5n 0.4828 3600.0n 0.5298 4199.5n 0.5298 4200.0n 0.5133 4799.5n 0.5133 4800.0n 0.5030 5399.5n 0.5030 5400.0n 0.5014 5999.5n 0.5014 6000.0n 0.5249 6599.5n 0.5249 6600.0n 0.5130 7199.5n 0.5130 7200.0n 0.4498 7799.5n 0.4498 7800.0n 0.4479 8399.5n 0.4479 8400.0n 0.5362 8999.5n 0.5362 9000.0n 0.5018 9599.5n 0.5018 9600.0n 0.4869 10199.5n 0.4869 10200.0n 0.4614 10799.5n 0.4614 10800.0n 0.5408 11399.5n 0.5408 11400.0n 0.5050 11999.5n 0.5050 12000.0n 0.5441 12599.5n 0.5441 12600.0n 0.4838 13199.5n 0.4838 13200.0n 0.4962 13799.5n 0.4962 13800.0n 0.4667 14399.5n 0.4667 14400.0n 0.5009 14999.5n 0.5009 15000.0n 0.4702 15599.5n 0.4702 15600.0n 0.5177 16199.5n 0.5177 16200.0n 0.4761 16799.5n 0.4761 16800.0n 0.5408 17399.5n 0.5408 17400.0n 0.4906 17999.5n 0.4906 18000.0n 0.5663 18599.5n 0.5663 18600.0n 0.4023 19199.5n 0.4023 19200.0n 0.4636 19799.5n 0.4636 19800.0n 0.3878 20399.5n 0.3878 20400.0n 0.5144 20999.5n 0.5144 21000.0n 0.6139 21599.5n 0.6139 21600.0n 0.3906 22199.5n 0.3906 22200.0n 0.3636 22799.5n 0.3636 22800.0n 0.5193 23399.5n 0.5193 23400.0n 0.4386 23999.5n 0.4386 24000.0n 0.4087 24599.5n 0.4087 24600.0n 0.3705 25199.5n 0.3705 25200.0n 0.5504 25799.5n 0.5504 25800.0n 0.6208 26399.5n 0.6208 26400.0n 0.5566 26999.5n 0.5566 27000.0n 0.5660 27599.5n 0.5660 27600.0n 0.5539 28199.5n 0.5539 28200.0n 0.4209 28799.5n 0.4209 28800.0n 0.5223 29399.5n 0.5223 29400.0n 0.6122 29999.5n 0.6122 30000.0n 0.6168 30599.5n 0.6168 30600.0n 0.5978 31199.5n 0.5978 31200.0n 0.5518 31799.5n 0.5518 31800.0n 0.6338 32399.5n 0.6338 32400.0n 0.6143 32999.5n 0.6143 33000.0n 0.4416 33599.5n 0.4416 33600.0n 0.4716 34199.5n 0.4716 34200.0n 0.3966 34799.5n 0.3966 34800.0n 0.6531 35399.5n 0.6531 35400.0n 0.4710 35999.5n 0.4710)
Vyp_wih_0_33 yp_wih_0_33 0 PWL(0.0n 0.3917 599.5n 0.3917 600.0n 0.3967 1199.5n 0.3967 1200.0n 0.3981 1799.5n 0.3981 1800.0n 0.4050 2399.5n 0.4050 2400.0n 0.4031 2999.5n 0.4031 3000.0n 0.3960 3599.5n 0.3960 3600.0n 0.3965 4199.5n 0.3965 4200.0n 0.3914 4799.5n 0.3914 4800.0n 0.3960 5399.5n 0.3960 5400.0n 0.3961 5999.5n 0.3961 6000.0n 0.3994 6599.5n 0.3994 6600.0n 0.3949 7199.5n 0.3949 7200.0n 0.3979 7799.5n 0.3979 7800.0n 0.3986 8399.5n 0.3986 8400.0n 0.3923 8999.5n 0.3923 9000.0n 0.3960 9599.5n 0.3960 9600.0n 0.3976 10199.5n 0.3976 10200.0n 0.3989 10799.5n 0.3989 10800.0n 0.3974 11399.5n 0.3974 11400.0n 0.3954 11999.5n 0.3954 12000.0n 0.3914 12599.5n 0.3914 12600.0n 0.3980 13199.5n 0.3980 13200.0n 0.3916 13799.5n 0.3916 13800.0n 0.3947 14399.5n 0.3947 14400.0n 0.3953 14999.5n 0.3953 15000.0n 0.4004 15599.5n 0.4004 15600.0n 0.3928 16199.5n 0.3928 16200.0n 0.3924 16799.5n 0.3924 16800.0n 0.3926 17399.5n 0.3926 17400.0n 0.3923 17999.5n 0.3923 18000.0n 0.4025 18599.5n 0.4025 18600.0n 0.4014 19199.5n 0.4014 19200.0n 0.4119 19799.5n 0.4119 19800.0n 0.4139 20399.5n 0.4139 20400.0n 0.4100 20999.5n 0.4100 21000.0n 0.3920 21599.5n 0.3920 21600.0n 0.4086 22199.5n 0.4086 22200.0n 0.4026 22799.5n 0.4026 22800.0n 0.4098 23399.5n 0.4098 23400.0n 0.3877 23999.5n 0.3877 24000.0n 0.4191 24599.5n 0.4191 24600.0n 0.4003 25199.5n 0.4003 25200.0n 0.4063 25799.5n 0.4063 25800.0n 0.4007 26399.5n 0.4007 26400.0n 0.4063 26999.5n 0.4063 27000.0n 0.4041 27599.5n 0.4041 27600.0n 0.4066 28199.5n 0.4066 28200.0n 0.3909 28799.5n 0.3909 28800.0n 0.4096 29399.5n 0.4096 29400.0n 0.3911 29999.5n 0.3911 30000.0n 0.3894 30599.5n 0.3894 30600.0n 0.3807 31199.5n 0.3807 31200.0n 0.3825 31799.5n 0.3825 31800.0n 0.3997 32399.5n 0.3997 32400.0n 0.4008 32999.5n 0.4008 33000.0n 0.4151 33599.5n 0.4151 33600.0n 0.4125 34199.5n 0.4125 34200.0n 0.3989 34799.5n 0.3989 34800.0n 0.3857 35399.5n 0.3857 35400.0n 0.4123 35999.5n 0.4123)
Vyn_wih_0_33 yn_wih_0_33 0 PWL(0.0n 0.6083 599.5n 0.6083 600.0n 0.6033 1199.5n 0.6033 1200.0n 0.6019 1799.5n 0.6019 1800.0n 0.5950 2399.5n 0.5950 2400.0n 0.5969 2999.5n 0.5969 3000.0n 0.6040 3599.5n 0.6040 3600.0n 0.6035 4199.5n 0.6035 4200.0n 0.6086 4799.5n 0.6086 4800.0n 0.6040 5399.5n 0.6040 5400.0n 0.6039 5999.5n 0.6039 6000.0n 0.6006 6599.5n 0.6006 6600.0n 0.6051 7199.5n 0.6051 7200.0n 0.6021 7799.5n 0.6021 7800.0n 0.6014 8399.5n 0.6014 8400.0n 0.6077 8999.5n 0.6077 9000.0n 0.6040 9599.5n 0.6040 9600.0n 0.6024 10199.5n 0.6024 10200.0n 0.6011 10799.5n 0.6011 10800.0n 0.6026 11399.5n 0.6026 11400.0n 0.6046 11999.5n 0.6046 12000.0n 0.6086 12599.5n 0.6086 12600.0n 0.6020 13199.5n 0.6020 13200.0n 0.6084 13799.5n 0.6084 13800.0n 0.6053 14399.5n 0.6053 14400.0n 0.6047 14999.5n 0.6047 15000.0n 0.5996 15599.5n 0.5996 15600.0n 0.6072 16199.5n 0.6072 16200.0n 0.6076 16799.5n 0.6076 16800.0n 0.6074 17399.5n 0.6074 17400.0n 0.6077 17999.5n 0.6077 18000.0n 0.5975 18599.5n 0.5975 18600.0n 0.5986 19199.5n 0.5986 19200.0n 0.5881 19799.5n 0.5881 19800.0n 0.5861 20399.5n 0.5861 20400.0n 0.5900 20999.5n 0.5900 21000.0n 0.6080 21599.5n 0.6080 21600.0n 0.5914 22199.5n 0.5914 22200.0n 0.5974 22799.5n 0.5974 22800.0n 0.5902 23399.5n 0.5902 23400.0n 0.6123 23999.5n 0.6123 24000.0n 0.5809 24599.5n 0.5809 24600.0n 0.5997 25199.5n 0.5997 25200.0n 0.5937 25799.5n 0.5937 25800.0n 0.5993 26399.5n 0.5993 26400.0n 0.5937 26999.5n 0.5937 27000.0n 0.5959 27599.5n 0.5959 27600.0n 0.5934 28199.5n 0.5934 28200.0n 0.6091 28799.5n 0.6091 28800.0n 0.5904 29399.5n 0.5904 29400.0n 0.6089 29999.5n 0.6089 30000.0n 0.6106 30599.5n 0.6106 30600.0n 0.6193 31199.5n 0.6193 31200.0n 0.6175 31799.5n 0.6175 31800.0n 0.6003 32399.5n 0.6003 32400.0n 0.5992 32999.5n 0.5992 33000.0n 0.5849 33599.5n 0.5849 33600.0n 0.5875 34199.5n 0.5875 34200.0n 0.6011 34799.5n 0.6011 34800.0n 0.6143 35399.5n 0.6143 35400.0n 0.5877 35999.5n 0.5877)
Cwp_wih_0_33 wp_wih_0_33 0 400p
Cwn_wih_0_33 wn_wih_0_33 0 400p
Xu_wih_0_33 xp_wih_0_33 xn_wih_0_33 yp_wih_0_33 yn_wih_0_33 wp_wih_0_33 wn_wih_0_33 vdd gbn gprod
Vxp_wih_1_33 xp_wih_1_33 0 PWL(0.0n 0.5370 599.5n 0.5370 600.0n 0.5167 1199.5n 0.5167 1200.0n 0.4793 1799.5n 0.4793 1800.0n 0.4441 2399.5n 0.4441 2400.0n 0.4555 2999.5n 0.4555 3000.0n 0.5055 3599.5n 0.5055 3600.0n 0.4939 4199.5n 0.4939 4200.0n 0.5385 4799.5n 0.5385 4800.0n 0.5024 5399.5n 0.5024 5400.0n 0.5015 5999.5n 0.5015 6000.0n 0.4700 6599.5n 0.4700 6600.0n 0.5120 7199.5n 0.5120 7200.0n 0.5006 7799.5n 0.5006 7800.0n 0.4950 8399.5n 0.4950 8400.0n 0.5309 8999.5n 0.5309 9000.0n 0.5023 9599.5n 0.5023 9600.0n 0.4893 10199.5n 0.4893 10200.0n 0.4837 10799.5n 0.4837 10800.0n 0.4823 11399.5n 0.4823 11400.0n 0.5074 11999.5n 0.5074 12000.0n 0.5364 12599.5n 0.5364 12600.0n 0.4868 13199.5n 0.4868 13200.0n 0.5380 13799.5n 0.5380 13800.0n 0.5220 14399.5n 0.5220 14400.0n 0.5095 14999.5n 0.5095 15000.0n 0.4705 15599.5n 0.4705 15600.0n 0.5289 16199.5n 0.5289 16200.0n 0.5368 16799.5n 0.5368 16800.0n 0.5287 17399.5n 0.5287 17400.0n 0.5342 17999.5n 0.5342 18000.0n 0.4253 18599.5n 0.4253 18600.0n 0.5119 19199.5n 0.5119 19200.0n 0.4104 19799.5n 0.4104 19800.0n 0.4314 20399.5n 0.4314 20400.0n 0.4005 20999.5n 0.4005 21000.0n 0.4696 21599.5n 0.4696 21600.0n 0.4531 22199.5n 0.4531 22200.0n 0.5039 22799.5n 0.5039 22800.0n 0.3608 23399.5n 0.3608 23400.0n 0.6273 23999.5n 0.6273 24000.0n 0.3928 24599.5n 0.3928 24600.0n 0.5253 25199.5n 0.5253 25200.0n 0.4107 25799.5n 0.4107 25800.0n 0.3947 26399.5n 0.3947 26400.0n 0.3716 26999.5n 0.3716 27000.0n 0.4111 27599.5n 0.4111 27600.0n 0.3715 28199.5n 0.3715 28200.0n 0.5939 28799.5n 0.5939 28800.0n 0.3849 29399.5n 0.3849 29400.0n 0.4835 29999.5n 0.4835 30000.0n 0.5119 30599.5n 0.5119 30600.0n 0.6226 31199.5n 0.6226 31200.0n 0.6064 31799.5n 0.6064 31800.0n 0.4115 32399.5n 0.4115 32400.0n 0.3900 32999.5n 0.3900 33000.0n 0.3958 33599.5n 0.3958 33600.0n 0.3747 34199.5n 0.3747 34200.0n 0.5423 34799.5n 0.5423 34800.0n 0.5509 35399.5n 0.5509 35400.0n 0.3990 35999.5n 0.3990)
Vxn_wih_1_33 xn_wih_1_33 0 PWL(0.0n 0.4630 599.5n 0.4630 600.0n 0.4833 1199.5n 0.4833 1200.0n 0.5207 1799.5n 0.5207 1800.0n 0.5559 2399.5n 0.5559 2400.0n 0.5445 2999.5n 0.5445 3000.0n 0.4945 3599.5n 0.4945 3600.0n 0.5061 4199.5n 0.5061 4200.0n 0.4615 4799.5n 0.4615 4800.0n 0.4976 5399.5n 0.4976 5400.0n 0.4985 5999.5n 0.4985 6000.0n 0.5300 6599.5n 0.5300 6600.0n 0.4880 7199.5n 0.4880 7200.0n 0.4994 7799.5n 0.4994 7800.0n 0.5050 8399.5n 0.5050 8400.0n 0.4691 8999.5n 0.4691 9000.0n 0.4977 9599.5n 0.4977 9600.0n 0.5107 10199.5n 0.5107 10200.0n 0.5163 10799.5n 0.5163 10800.0n 0.5177 11399.5n 0.5177 11400.0n 0.4926 11999.5n 0.4926 12000.0n 0.4636 12599.5n 0.4636 12600.0n 0.5132 13199.5n 0.5132 13200.0n 0.4620 13799.5n 0.4620 13800.0n 0.4780 14399.5n 0.4780 14400.0n 0.4905 14999.5n 0.4905 15000.0n 0.5295 15599.5n 0.5295 15600.0n 0.4711 16199.5n 0.4711 16200.0n 0.4632 16799.5n 0.4632 16800.0n 0.4713 17399.5n 0.4713 17400.0n 0.4658 17999.5n 0.4658 18000.0n 0.5747 18599.5n 0.5747 18600.0n 0.4881 19199.5n 0.4881 19200.0n 0.5896 19799.5n 0.5896 19800.0n 0.5686 20399.5n 0.5686 20400.0n 0.5995 20999.5n 0.5995 21000.0n 0.5304 21599.5n 0.5304 21600.0n 0.5469 22199.5n 0.5469 22200.0n 0.4961 22799.5n 0.4961 22800.0n 0.6392 23399.5n 0.6392 23400.0n 0.3727 23999.5n 0.3727 24000.0n 0.6072 24599.5n 0.6072 24600.0n 0.4747 25199.5n 0.4747 25200.0n 0.5893 25799.5n 0.5893 25800.0n 0.6053 26399.5n 0.6053 26400.0n 0.6284 26999.5n 0.6284 27000.0n 0.5889 27599.5n 0.5889 27600.0n 0.6285 28199.5n 0.6285 28200.0n 0.4061 28799.5n 0.4061 28800.0n 0.6151 29399.5n 0.6151 29400.0n 0.5165 29999.5n 0.5165 30000.0n 0.4881 30599.5n 0.4881 30600.0n 0.3774 31199.5n 0.3774 31200.0n 0.3936 31799.5n 0.3936 31800.0n 0.5885 32399.5n 0.5885 32400.0n 0.6100 32999.5n 0.6100 33000.0n 0.6042 33599.5n 0.6042 33600.0n 0.6253 34199.5n 0.6253 34200.0n 0.4577 34799.5n 0.4577 34800.0n 0.4491 35399.5n 0.4491 35400.0n 0.6010 35999.5n 0.6010)
Vyp_wih_1_33 yp_wih_1_33 0 PWL(0.0n 0.3917 599.5n 0.3917 600.0n 0.3967 1199.5n 0.3967 1200.0n 0.3981 1799.5n 0.3981 1800.0n 0.4050 2399.5n 0.4050 2400.0n 0.4031 2999.5n 0.4031 3000.0n 0.3960 3599.5n 0.3960 3600.0n 0.3965 4199.5n 0.3965 4200.0n 0.3914 4799.5n 0.3914 4800.0n 0.3960 5399.5n 0.3960 5400.0n 0.3961 5999.5n 0.3961 6000.0n 0.3994 6599.5n 0.3994 6600.0n 0.3949 7199.5n 0.3949 7200.0n 0.3979 7799.5n 0.3979 7800.0n 0.3986 8399.5n 0.3986 8400.0n 0.3923 8999.5n 0.3923 9000.0n 0.3960 9599.5n 0.3960 9600.0n 0.3976 10199.5n 0.3976 10200.0n 0.3989 10799.5n 0.3989 10800.0n 0.3974 11399.5n 0.3974 11400.0n 0.3954 11999.5n 0.3954 12000.0n 0.3914 12599.5n 0.3914 12600.0n 0.3980 13199.5n 0.3980 13200.0n 0.3916 13799.5n 0.3916 13800.0n 0.3947 14399.5n 0.3947 14400.0n 0.3953 14999.5n 0.3953 15000.0n 0.4004 15599.5n 0.4004 15600.0n 0.3928 16199.5n 0.3928 16200.0n 0.3924 16799.5n 0.3924 16800.0n 0.3926 17399.5n 0.3926 17400.0n 0.3923 17999.5n 0.3923 18000.0n 0.4025 18599.5n 0.4025 18600.0n 0.4014 19199.5n 0.4014 19200.0n 0.4119 19799.5n 0.4119 19800.0n 0.4139 20399.5n 0.4139 20400.0n 0.4100 20999.5n 0.4100 21000.0n 0.3920 21599.5n 0.3920 21600.0n 0.4086 22199.5n 0.4086 22200.0n 0.4026 22799.5n 0.4026 22800.0n 0.4098 23399.5n 0.4098 23400.0n 0.3877 23999.5n 0.3877 24000.0n 0.4191 24599.5n 0.4191 24600.0n 0.4003 25199.5n 0.4003 25200.0n 0.4063 25799.5n 0.4063 25800.0n 0.4007 26399.5n 0.4007 26400.0n 0.4063 26999.5n 0.4063 27000.0n 0.4041 27599.5n 0.4041 27600.0n 0.4066 28199.5n 0.4066 28200.0n 0.3909 28799.5n 0.3909 28800.0n 0.4096 29399.5n 0.4096 29400.0n 0.3911 29999.5n 0.3911 30000.0n 0.3894 30599.5n 0.3894 30600.0n 0.3807 31199.5n 0.3807 31200.0n 0.3825 31799.5n 0.3825 31800.0n 0.3997 32399.5n 0.3997 32400.0n 0.4008 32999.5n 0.4008 33000.0n 0.4151 33599.5n 0.4151 33600.0n 0.4125 34199.5n 0.4125 34200.0n 0.3989 34799.5n 0.3989 34800.0n 0.3857 35399.5n 0.3857 35400.0n 0.4123 35999.5n 0.4123)
Vyn_wih_1_33 yn_wih_1_33 0 PWL(0.0n 0.6083 599.5n 0.6083 600.0n 0.6033 1199.5n 0.6033 1200.0n 0.6019 1799.5n 0.6019 1800.0n 0.5950 2399.5n 0.5950 2400.0n 0.5969 2999.5n 0.5969 3000.0n 0.6040 3599.5n 0.6040 3600.0n 0.6035 4199.5n 0.6035 4200.0n 0.6086 4799.5n 0.6086 4800.0n 0.6040 5399.5n 0.6040 5400.0n 0.6039 5999.5n 0.6039 6000.0n 0.6006 6599.5n 0.6006 6600.0n 0.6051 7199.5n 0.6051 7200.0n 0.6021 7799.5n 0.6021 7800.0n 0.6014 8399.5n 0.6014 8400.0n 0.6077 8999.5n 0.6077 9000.0n 0.6040 9599.5n 0.6040 9600.0n 0.6024 10199.5n 0.6024 10200.0n 0.6011 10799.5n 0.6011 10800.0n 0.6026 11399.5n 0.6026 11400.0n 0.6046 11999.5n 0.6046 12000.0n 0.6086 12599.5n 0.6086 12600.0n 0.6020 13199.5n 0.6020 13200.0n 0.6084 13799.5n 0.6084 13800.0n 0.6053 14399.5n 0.6053 14400.0n 0.6047 14999.5n 0.6047 15000.0n 0.5996 15599.5n 0.5996 15600.0n 0.6072 16199.5n 0.6072 16200.0n 0.6076 16799.5n 0.6076 16800.0n 0.6074 17399.5n 0.6074 17400.0n 0.6077 17999.5n 0.6077 18000.0n 0.5975 18599.5n 0.5975 18600.0n 0.5986 19199.5n 0.5986 19200.0n 0.5881 19799.5n 0.5881 19800.0n 0.5861 20399.5n 0.5861 20400.0n 0.5900 20999.5n 0.5900 21000.0n 0.6080 21599.5n 0.6080 21600.0n 0.5914 22199.5n 0.5914 22200.0n 0.5974 22799.5n 0.5974 22800.0n 0.5902 23399.5n 0.5902 23400.0n 0.6123 23999.5n 0.6123 24000.0n 0.5809 24599.5n 0.5809 24600.0n 0.5997 25199.5n 0.5997 25200.0n 0.5937 25799.5n 0.5937 25800.0n 0.5993 26399.5n 0.5993 26400.0n 0.5937 26999.5n 0.5937 27000.0n 0.5959 27599.5n 0.5959 27600.0n 0.5934 28199.5n 0.5934 28200.0n 0.6091 28799.5n 0.6091 28800.0n 0.5904 29399.5n 0.5904 29400.0n 0.6089 29999.5n 0.6089 30000.0n 0.6106 30599.5n 0.6106 30600.0n 0.6193 31199.5n 0.6193 31200.0n 0.6175 31799.5n 0.6175 31800.0n 0.6003 32399.5n 0.6003 32400.0n 0.5992 32999.5n 0.5992 33000.0n 0.5849 33599.5n 0.5849 33600.0n 0.5875 34199.5n 0.5875 34200.0n 0.6011 34799.5n 0.6011 34800.0n 0.6143 35399.5n 0.6143 35400.0n 0.5877 35999.5n 0.5877)
Cwp_wih_1_33 wp_wih_1_33 0 400p
Cwn_wih_1_33 wn_wih_1_33 0 400p
Xu_wih_1_33 xp_wih_1_33 xn_wih_1_33 yp_wih_1_33 yn_wih_1_33 wp_wih_1_33 wn_wih_1_33 vdd gbn gprod
Vxp_who_33_0 xp_who_33_0 0 PWL(0.0n 0.3917 599.5n 0.3917 600.0n 0.3967 1199.5n 0.3967 1200.0n 0.3981 1799.5n 0.3981 1800.0n 0.4050 2399.5n 0.4050 2400.0n 0.4031 2999.5n 0.4031 3000.0n 0.3960 3599.5n 0.3960 3600.0n 0.3965 4199.5n 0.3965 4200.0n 0.3914 4799.5n 0.3914 4800.0n 0.3960 5399.5n 0.3960 5400.0n 0.3961 5999.5n 0.3961 6000.0n 0.3994 6599.5n 0.3994 6600.0n 0.3949 7199.5n 0.3949 7200.0n 0.3979 7799.5n 0.3979 7800.0n 0.3986 8399.5n 0.3986 8400.0n 0.3923 8999.5n 0.3923 9000.0n 0.3960 9599.5n 0.3960 9600.0n 0.3976 10199.5n 0.3976 10200.0n 0.3989 10799.5n 0.3989 10800.0n 0.3974 11399.5n 0.3974 11400.0n 0.3954 11999.5n 0.3954 12000.0n 0.3914 12599.5n 0.3914 12600.0n 0.3980 13199.5n 0.3980 13200.0n 0.3916 13799.5n 0.3916 13800.0n 0.3947 14399.5n 0.3947 14400.0n 0.3953 14999.5n 0.3953 15000.0n 0.4004 15599.5n 0.4004 15600.0n 0.3928 16199.5n 0.3928 16200.0n 0.3924 16799.5n 0.3924 16800.0n 0.3926 17399.5n 0.3926 17400.0n 0.3923 17999.5n 0.3923 18000.0n 0.4025 18599.5n 0.4025 18600.0n 0.4014 19199.5n 0.4014 19200.0n 0.4119 19799.5n 0.4119 19800.0n 0.4139 20399.5n 0.4139 20400.0n 0.4100 20999.5n 0.4100 21000.0n 0.3920 21599.5n 0.3920 21600.0n 0.4086 22199.5n 0.4086 22200.0n 0.4026 22799.5n 0.4026 22800.0n 0.4098 23399.5n 0.4098 23400.0n 0.3877 23999.5n 0.3877 24000.0n 0.4191 24599.5n 0.4191 24600.0n 0.4003 25199.5n 0.4003 25200.0n 0.4063 25799.5n 0.4063 25800.0n 0.4007 26399.5n 0.4007 26400.0n 0.4063 26999.5n 0.4063 27000.0n 0.4041 27599.5n 0.4041 27600.0n 0.4066 28199.5n 0.4066 28200.0n 0.3909 28799.5n 0.3909 28800.0n 0.4096 29399.5n 0.4096 29400.0n 0.3911 29999.5n 0.3911 30000.0n 0.3894 30599.5n 0.3894 30600.0n 0.3807 31199.5n 0.3807 31200.0n 0.3825 31799.5n 0.3825 31800.0n 0.3997 32399.5n 0.3997 32400.0n 0.4008 32999.5n 0.4008 33000.0n 0.4151 33599.5n 0.4151 33600.0n 0.4125 34199.5n 0.4125 34200.0n 0.3989 34799.5n 0.3989 34800.0n 0.3857 35399.5n 0.3857 35400.0n 0.4123 35999.5n 0.4123)
Vxn_who_33_0 xn_who_33_0 0 PWL(0.0n 0.6083 599.5n 0.6083 600.0n 0.6033 1199.5n 0.6033 1200.0n 0.6019 1799.5n 0.6019 1800.0n 0.5950 2399.5n 0.5950 2400.0n 0.5969 2999.5n 0.5969 3000.0n 0.6040 3599.5n 0.6040 3600.0n 0.6035 4199.5n 0.6035 4200.0n 0.6086 4799.5n 0.6086 4800.0n 0.6040 5399.5n 0.6040 5400.0n 0.6039 5999.5n 0.6039 6000.0n 0.6006 6599.5n 0.6006 6600.0n 0.6051 7199.5n 0.6051 7200.0n 0.6021 7799.5n 0.6021 7800.0n 0.6014 8399.5n 0.6014 8400.0n 0.6077 8999.5n 0.6077 9000.0n 0.6040 9599.5n 0.6040 9600.0n 0.6024 10199.5n 0.6024 10200.0n 0.6011 10799.5n 0.6011 10800.0n 0.6026 11399.5n 0.6026 11400.0n 0.6046 11999.5n 0.6046 12000.0n 0.6086 12599.5n 0.6086 12600.0n 0.6020 13199.5n 0.6020 13200.0n 0.6084 13799.5n 0.6084 13800.0n 0.6053 14399.5n 0.6053 14400.0n 0.6047 14999.5n 0.6047 15000.0n 0.5996 15599.5n 0.5996 15600.0n 0.6072 16199.5n 0.6072 16200.0n 0.6076 16799.5n 0.6076 16800.0n 0.6074 17399.5n 0.6074 17400.0n 0.6077 17999.5n 0.6077 18000.0n 0.5975 18599.5n 0.5975 18600.0n 0.5986 19199.5n 0.5986 19200.0n 0.5881 19799.5n 0.5881 19800.0n 0.5861 20399.5n 0.5861 20400.0n 0.5900 20999.5n 0.5900 21000.0n 0.6080 21599.5n 0.6080 21600.0n 0.5914 22199.5n 0.5914 22200.0n 0.5974 22799.5n 0.5974 22800.0n 0.5902 23399.5n 0.5902 23400.0n 0.6123 23999.5n 0.6123 24000.0n 0.5809 24599.5n 0.5809 24600.0n 0.5997 25199.5n 0.5997 25200.0n 0.5937 25799.5n 0.5937 25800.0n 0.5993 26399.5n 0.5993 26400.0n 0.5937 26999.5n 0.5937 27000.0n 0.5959 27599.5n 0.5959 27600.0n 0.5934 28199.5n 0.5934 28200.0n 0.6091 28799.5n 0.6091 28800.0n 0.5904 29399.5n 0.5904 29400.0n 0.6089 29999.5n 0.6089 30000.0n 0.6106 30599.5n 0.6106 30600.0n 0.6193 31199.5n 0.6193 31200.0n 0.6175 31799.5n 0.6175 31800.0n 0.6003 32399.5n 0.6003 32400.0n 0.5992 32999.5n 0.5992 33000.0n 0.5849 33599.5n 0.5849 33600.0n 0.5875 34199.5n 0.5875 34200.0n 0.6011 34799.5n 0.6011 34800.0n 0.6143 35399.5n 0.6143 35400.0n 0.5877 35999.5n 0.5877)
Vyp_who_33_0 yp_who_33_0 0 PWL(0.0n 0.5031 599.5n 0.5031 600.0n 0.5023 1199.5n 0.5023 1200.0n 0.5052 1799.5n 0.5052 1800.0n 0.5048 2399.5n 0.5048 2400.0n 0.5043 2999.5n 0.5043 3000.0n 0.5034 3599.5n 0.5034 3600.0n 0.5048 4199.5n 0.5048 4200.0n 0.5031 4799.5n 0.5031 4800.0n 0.5040 5399.5n 0.5040 5400.0n 0.5040 5999.5n 0.5040 6000.0n 0.5054 6599.5n 0.5054 6600.0n 0.5040 7199.5n 0.5040 7200.0n 0.5027 7799.5n 0.5027 7800.0n 0.5027 8399.5n 0.5027 8400.0n 0.5038 8999.5n 0.5038 9000.0n 0.5040 9599.5n 0.5040 9600.0n 0.5039 10199.5n 0.5039 10200.0n 0.5033 10799.5n 0.5033 10800.0n 0.5056 11399.5n 0.5056 11400.0n 0.5040 11999.5n 0.5040 12000.0n 0.5036 12599.5n 0.5036 12600.0n 0.5039 13199.5n 0.5039 13200.0n 0.5029 13799.5n 0.5029 13800.0n 0.5025 14399.5n 0.5025 14400.0n 0.5038 14999.5n 0.5038 15000.0n 0.5041 15599.5n 0.5041 15600.0n 0.5036 16199.5n 0.5036 16200.0n 0.5025 16799.5n 0.5025 16800.0n 0.5040 17399.5n 0.5040 17400.0n 0.5029 17999.5n 0.5029 18000.0n 0.5057 18599.5n 0.5057 18600.0n 0.5010 19199.5n 0.5010 19200.0n 0.5041 19799.5n 0.5041 19800.0n 0.5021 20399.5n 0.5021 20400.0n 0.5044 20999.5n 0.5044 21000.0n 0.5056 21599.5n 0.5056 21600.0n 0.5016 22199.5n 0.5016 22200.0n 0.5006 22799.5n 0.5006 22800.0n 0.5041 23399.5n 0.5041 23400.0n 0.5027 23999.5n 0.5027 24000.0n 0.5029 24599.5n 0.5029 24600.0n 0.5006 25199.5n 0.5006 25200.0n 0.5047 25799.5n 0.5047 25800.0n 0.5046 26399.5n 0.5046 26400.0n 0.5039 26999.5n 0.5039 27000.0n 0.5049 27599.5n 0.5049 27600.0n 0.5039 28199.5n 0.5039 28200.0n 0.5017 28799.5n 0.5017 28800.0n 0.5042 29399.5n 0.5042 29400.0n 0.5056 29999.5n 0.5056 30000.0n 0.5051 30599.5n 0.5051 30600.0n 0.5039 31199.5n 0.5039 31200.0n 0.5033 31799.5n 0.5033 31800.0n 0.5049 32399.5n 0.5049 32400.0n 0.5045 32999.5n 0.5045 33000.0n 0.5036 33599.5n 0.5036 33600.0n 0.5042 34199.5n 0.5042 34200.0n 0.5012 34799.5n 0.5012 34800.0n 0.5036 35399.5n 0.5036 35400.0n 0.5042 35999.5n 0.5042)
Vyn_who_33_0 yn_who_33_0 0 PWL(0.0n 0.4969 599.5n 0.4969 600.0n 0.4977 1199.5n 0.4977 1200.0n 0.4948 1799.5n 0.4948 1800.0n 0.4952 2399.5n 0.4952 2400.0n 0.4957 2999.5n 0.4957 3000.0n 0.4966 3599.5n 0.4966 3600.0n 0.4952 4199.5n 0.4952 4200.0n 0.4969 4799.5n 0.4969 4800.0n 0.4960 5399.5n 0.4960 5400.0n 0.4960 5999.5n 0.4960 6000.0n 0.4946 6599.5n 0.4946 6600.0n 0.4960 7199.5n 0.4960 7200.0n 0.4973 7799.5n 0.4973 7800.0n 0.4973 8399.5n 0.4973 8400.0n 0.4962 8999.5n 0.4962 9000.0n 0.4960 9599.5n 0.4960 9600.0n 0.4961 10199.5n 0.4961 10200.0n 0.4967 10799.5n 0.4967 10800.0n 0.4944 11399.5n 0.4944 11400.0n 0.4960 11999.5n 0.4960 12000.0n 0.4964 12599.5n 0.4964 12600.0n 0.4961 13199.5n 0.4961 13200.0n 0.4971 13799.5n 0.4971 13800.0n 0.4975 14399.5n 0.4975 14400.0n 0.4962 14999.5n 0.4962 15000.0n 0.4959 15599.5n 0.4959 15600.0n 0.4964 16199.5n 0.4964 16200.0n 0.4975 16799.5n 0.4975 16800.0n 0.4960 17399.5n 0.4960 17400.0n 0.4971 17999.5n 0.4971 18000.0n 0.4943 18599.5n 0.4943 18600.0n 0.4990 19199.5n 0.4990 19200.0n 0.4959 19799.5n 0.4959 19800.0n 0.4979 20399.5n 0.4979 20400.0n 0.4956 20999.5n 0.4956 21000.0n 0.4944 21599.5n 0.4944 21600.0n 0.4984 22199.5n 0.4984 22200.0n 0.4994 22799.5n 0.4994 22800.0n 0.4959 23399.5n 0.4959 23400.0n 0.4973 23999.5n 0.4973 24000.0n 0.4971 24599.5n 0.4971 24600.0n 0.4994 25199.5n 0.4994 25200.0n 0.4953 25799.5n 0.4953 25800.0n 0.4954 26399.5n 0.4954 26400.0n 0.4961 26999.5n 0.4961 27000.0n 0.4951 27599.5n 0.4951 27600.0n 0.4961 28199.5n 0.4961 28200.0n 0.4983 28799.5n 0.4983 28800.0n 0.4958 29399.5n 0.4958 29400.0n 0.4944 29999.5n 0.4944 30000.0n 0.4949 30599.5n 0.4949 30600.0n 0.4961 31199.5n 0.4961 31200.0n 0.4967 31799.5n 0.4967 31800.0n 0.4951 32399.5n 0.4951 32400.0n 0.4955 32999.5n 0.4955 33000.0n 0.4964 33599.5n 0.4964 33600.0n 0.4958 34199.5n 0.4958 34200.0n 0.4988 34799.5n 0.4988 34800.0n 0.4964 35399.5n 0.4964 35400.0n 0.4958 35999.5n 0.4958)
Cwp_who_33_0 wp_who_33_0 0 400p
Cwn_who_33_0 wn_who_33_0 0 400p
Xu_who_33_0 xp_who_33_0 xn_who_33_0 yp_who_33_0 yn_who_33_0 wp_who_33_0 wn_who_33_0 vdd gbn gprod
Vxp_who_33_1 xp_who_33_1 0 PWL(0.0n 0.3917 599.5n 0.3917 600.0n 0.3967 1199.5n 0.3967 1200.0n 0.3981 1799.5n 0.3981 1800.0n 0.4050 2399.5n 0.4050 2400.0n 0.4031 2999.5n 0.4031 3000.0n 0.3960 3599.5n 0.3960 3600.0n 0.3965 4199.5n 0.3965 4200.0n 0.3914 4799.5n 0.3914 4800.0n 0.3960 5399.5n 0.3960 5400.0n 0.3961 5999.5n 0.3961 6000.0n 0.3994 6599.5n 0.3994 6600.0n 0.3949 7199.5n 0.3949 7200.0n 0.3979 7799.5n 0.3979 7800.0n 0.3986 8399.5n 0.3986 8400.0n 0.3923 8999.5n 0.3923 9000.0n 0.3960 9599.5n 0.3960 9600.0n 0.3976 10199.5n 0.3976 10200.0n 0.3989 10799.5n 0.3989 10800.0n 0.3974 11399.5n 0.3974 11400.0n 0.3954 11999.5n 0.3954 12000.0n 0.3914 12599.5n 0.3914 12600.0n 0.3980 13199.5n 0.3980 13200.0n 0.3916 13799.5n 0.3916 13800.0n 0.3947 14399.5n 0.3947 14400.0n 0.3953 14999.5n 0.3953 15000.0n 0.4004 15599.5n 0.4004 15600.0n 0.3928 16199.5n 0.3928 16200.0n 0.3924 16799.5n 0.3924 16800.0n 0.3926 17399.5n 0.3926 17400.0n 0.3923 17999.5n 0.3923 18000.0n 0.4025 18599.5n 0.4025 18600.0n 0.4014 19199.5n 0.4014 19200.0n 0.4119 19799.5n 0.4119 19800.0n 0.4139 20399.5n 0.4139 20400.0n 0.4100 20999.5n 0.4100 21000.0n 0.3920 21599.5n 0.3920 21600.0n 0.4086 22199.5n 0.4086 22200.0n 0.4026 22799.5n 0.4026 22800.0n 0.4098 23399.5n 0.4098 23400.0n 0.3877 23999.5n 0.3877 24000.0n 0.4191 24599.5n 0.4191 24600.0n 0.4003 25199.5n 0.4003 25200.0n 0.4063 25799.5n 0.4063 25800.0n 0.4007 26399.5n 0.4007 26400.0n 0.4063 26999.5n 0.4063 27000.0n 0.4041 27599.5n 0.4041 27600.0n 0.4066 28199.5n 0.4066 28200.0n 0.3909 28799.5n 0.3909 28800.0n 0.4096 29399.5n 0.4096 29400.0n 0.3911 29999.5n 0.3911 30000.0n 0.3894 30599.5n 0.3894 30600.0n 0.3807 31199.5n 0.3807 31200.0n 0.3825 31799.5n 0.3825 31800.0n 0.3997 32399.5n 0.3997 32400.0n 0.4008 32999.5n 0.4008 33000.0n 0.4151 33599.5n 0.4151 33600.0n 0.4125 34199.5n 0.4125 34200.0n 0.3989 34799.5n 0.3989 34800.0n 0.3857 35399.5n 0.3857 35400.0n 0.4123 35999.5n 0.4123)
Vxn_who_33_1 xn_who_33_1 0 PWL(0.0n 0.6083 599.5n 0.6083 600.0n 0.6033 1199.5n 0.6033 1200.0n 0.6019 1799.5n 0.6019 1800.0n 0.5950 2399.5n 0.5950 2400.0n 0.5969 2999.5n 0.5969 3000.0n 0.6040 3599.5n 0.6040 3600.0n 0.6035 4199.5n 0.6035 4200.0n 0.6086 4799.5n 0.6086 4800.0n 0.6040 5399.5n 0.6040 5400.0n 0.6039 5999.5n 0.6039 6000.0n 0.6006 6599.5n 0.6006 6600.0n 0.6051 7199.5n 0.6051 7200.0n 0.6021 7799.5n 0.6021 7800.0n 0.6014 8399.5n 0.6014 8400.0n 0.6077 8999.5n 0.6077 9000.0n 0.6040 9599.5n 0.6040 9600.0n 0.6024 10199.5n 0.6024 10200.0n 0.6011 10799.5n 0.6011 10800.0n 0.6026 11399.5n 0.6026 11400.0n 0.6046 11999.5n 0.6046 12000.0n 0.6086 12599.5n 0.6086 12600.0n 0.6020 13199.5n 0.6020 13200.0n 0.6084 13799.5n 0.6084 13800.0n 0.6053 14399.5n 0.6053 14400.0n 0.6047 14999.5n 0.6047 15000.0n 0.5996 15599.5n 0.5996 15600.0n 0.6072 16199.5n 0.6072 16200.0n 0.6076 16799.5n 0.6076 16800.0n 0.6074 17399.5n 0.6074 17400.0n 0.6077 17999.5n 0.6077 18000.0n 0.5975 18599.5n 0.5975 18600.0n 0.5986 19199.5n 0.5986 19200.0n 0.5881 19799.5n 0.5881 19800.0n 0.5861 20399.5n 0.5861 20400.0n 0.5900 20999.5n 0.5900 21000.0n 0.6080 21599.5n 0.6080 21600.0n 0.5914 22199.5n 0.5914 22200.0n 0.5974 22799.5n 0.5974 22800.0n 0.5902 23399.5n 0.5902 23400.0n 0.6123 23999.5n 0.6123 24000.0n 0.5809 24599.5n 0.5809 24600.0n 0.5997 25199.5n 0.5997 25200.0n 0.5937 25799.5n 0.5937 25800.0n 0.5993 26399.5n 0.5993 26400.0n 0.5937 26999.5n 0.5937 27000.0n 0.5959 27599.5n 0.5959 27600.0n 0.5934 28199.5n 0.5934 28200.0n 0.6091 28799.5n 0.6091 28800.0n 0.5904 29399.5n 0.5904 29400.0n 0.6089 29999.5n 0.6089 30000.0n 0.6106 30599.5n 0.6106 30600.0n 0.6193 31199.5n 0.6193 31200.0n 0.6175 31799.5n 0.6175 31800.0n 0.6003 32399.5n 0.6003 32400.0n 0.5992 32999.5n 0.5992 33000.0n 0.5849 33599.5n 0.5849 33600.0n 0.5875 34199.5n 0.5875 34200.0n 0.6011 34799.5n 0.6011 34800.0n 0.6143 35399.5n 0.6143 35400.0n 0.5877 35999.5n 0.5877)
Vyp_who_33_1 yp_who_33_1 0 PWL(0.0n 0.5071 599.5n 0.5071 600.0n 0.5053 1199.5n 0.5053 1200.0n 0.5052 1799.5n 0.5052 1800.0n 0.5027 2399.5n 0.5027 2400.0n 0.5034 2999.5n 0.5034 3000.0n 0.5055 3599.5n 0.5055 3600.0n 0.5056 4199.5n 0.5056 4200.0n 0.5071 4799.5n 0.5071 4800.0n 0.5056 5399.5n 0.5056 5400.0n 0.5056 5999.5n 0.5056 6000.0n 0.5048 6599.5n 0.5048 6600.0n 0.5060 7199.5n 0.5060 7200.0n 0.5048 7799.5n 0.5048 7800.0n 0.5046 8399.5n 0.5046 8400.0n 0.5066 8999.5n 0.5066 9000.0n 0.5056 9599.5n 0.5056 9600.0n 0.5051 10199.5n 0.5051 10200.0n 0.5046 10799.5n 0.5046 10800.0n 0.5056 11399.5n 0.5056 11400.0n 0.5058 11999.5n 0.5058 12000.0n 0.5068 12599.5n 0.5068 12600.0n 0.5050 13199.5n 0.5050 13200.0n 0.5071 13799.5n 0.5071 13800.0n 0.5059 14399.5n 0.5059 14400.0n 0.5058 14999.5n 0.5058 15000.0n 0.5043 15599.5n 0.5043 15600.0n 0.5067 16199.5n 0.5067 16200.0n 0.5068 16799.5n 0.5068 16800.0n 0.5066 17399.5n 0.5066 17400.0n 0.5069 17999.5n 0.5069 18000.0n 0.5061 18599.5n 0.5061 18600.0n 0.5034 19199.5n 0.5034 19200.0n 0.5010 19799.5n 0.5010 19800.0n 0.4989 20399.5n 0.4989 20400.0n 0.5022 20999.5n 0.5022 21000.0n 0.5086 21599.5n 0.5086 21600.0n 0.5007 22199.5n 0.5007 22200.0n 0.5023 22799.5n 0.5023 22800.0n 0.5021 23399.5n 0.5021 23400.0n 0.5077 23999.5n 0.5077 24000.0n 0.4979 24599.5n 0.4979 24600.0n 0.5035 25199.5n 0.5035 25200.0n 0.5041 25799.5n 0.5041 25800.0n 0.5075 26399.5n 0.5075 26400.0n 0.5041 26999.5n 0.5041 27000.0n 0.5056 27599.5n 0.5056 27600.0n 0.5039 28199.5n 0.5039 28200.0n 0.5059 28799.5n 0.5059 28800.0n 0.5023 29399.5n 0.5023 29400.0n 0.5086 29999.5n 0.5086 30000.0n 0.5084 30599.5n 0.5084 30600.0n 0.5085 31199.5n 0.5085 31200.0n 0.5088 31799.5n 0.5088 31800.0n 0.5078 32399.5n 0.5078 32400.0n 0.5074 32999.5n 0.5074 33000.0n 0.4996 33599.5n 0.4996 33600.0n 0.5010 34199.5n 0.5010 34200.0n 0.5044 34799.5n 0.5044 34800.0n 0.5084 35399.5n 0.5084 35400.0n 0.5012 35999.5n 0.5012)
Vyn_who_33_1 yn_who_33_1 0 PWL(0.0n 0.4929 599.5n 0.4929 600.0n 0.4947 1199.5n 0.4947 1200.0n 0.4948 1799.5n 0.4948 1800.0n 0.4973 2399.5n 0.4973 2400.0n 0.4966 2999.5n 0.4966 3000.0n 0.4945 3599.5n 0.4945 3600.0n 0.4944 4199.5n 0.4944 4200.0n 0.4929 4799.5n 0.4929 4800.0n 0.4944 5399.5n 0.4944 5400.0n 0.4944 5999.5n 0.4944 6000.0n 0.4952 6599.5n 0.4952 6600.0n 0.4940 7199.5n 0.4940 7200.0n 0.4952 7799.5n 0.4952 7800.0n 0.4954 8399.5n 0.4954 8400.0n 0.4934 8999.5n 0.4934 9000.0n 0.4944 9599.5n 0.4944 9600.0n 0.4949 10199.5n 0.4949 10200.0n 0.4954 10799.5n 0.4954 10800.0n 0.4944 11399.5n 0.4944 11400.0n 0.4942 11999.5n 0.4942 12000.0n 0.4932 12599.5n 0.4932 12600.0n 0.4950 13199.5n 0.4950 13200.0n 0.4929 13799.5n 0.4929 13800.0n 0.4941 14399.5n 0.4941 14400.0n 0.4942 14999.5n 0.4942 15000.0n 0.4957 15599.5n 0.4957 15600.0n 0.4933 16199.5n 0.4933 16200.0n 0.4932 16799.5n 0.4932 16800.0n 0.4934 17399.5n 0.4934 17400.0n 0.4931 17999.5n 0.4931 18000.0n 0.4939 18599.5n 0.4939 18600.0n 0.4966 19199.5n 0.4966 19200.0n 0.4990 19799.5n 0.4990 19800.0n 0.5011 20399.5n 0.5011 20400.0n 0.4978 20999.5n 0.4978 21000.0n 0.4914 21599.5n 0.4914 21600.0n 0.4993 22199.5n 0.4993 22200.0n 0.4977 22799.5n 0.4977 22800.0n 0.4979 23399.5n 0.4979 23400.0n 0.4923 23999.5n 0.4923 24000.0n 0.5021 24599.5n 0.5021 24600.0n 0.4965 25199.5n 0.4965 25200.0n 0.4959 25799.5n 0.4959 25800.0n 0.4925 26399.5n 0.4925 26400.0n 0.4959 26999.5n 0.4959 27000.0n 0.4944 27599.5n 0.4944 27600.0n 0.4961 28199.5n 0.4961 28200.0n 0.4941 28799.5n 0.4941 28800.0n 0.4977 29399.5n 0.4977 29400.0n 0.4914 29999.5n 0.4914 30000.0n 0.4916 30599.5n 0.4916 30600.0n 0.4915 31199.5n 0.4915 31200.0n 0.4912 31799.5n 0.4912 31800.0n 0.4922 32399.5n 0.4922 32400.0n 0.4926 32999.5n 0.4926 33000.0n 0.5004 33599.5n 0.5004 33600.0n 0.4990 34199.5n 0.4990 34200.0n 0.4956 34799.5n 0.4956 34800.0n 0.4916 35399.5n 0.4916 35400.0n 0.4988 35999.5n 0.4988)
Cwp_who_33_1 wp_who_33_1 0 400p
Cwn_who_33_1 wn_who_33_1 0 400p
Xu_who_33_1 xp_who_33_1 xn_who_33_1 yp_who_33_1 yn_who_33_1 wp_who_33_1 wn_who_33_1 vdd gbn gprod
Vxp_bh_33 xp_bh_33 0 PWL(0.0n 0.7100 599.5n 0.7100 600.0n 0.7100 1199.5n 0.7100 1200.0n 0.7100 1799.5n 0.7100 1800.0n 0.7100 2399.5n 0.7100 2400.0n 0.7100 2999.5n 0.7100 3000.0n 0.7100 3599.5n 0.7100 3600.0n 0.7100 4199.5n 0.7100 4200.0n 0.7100 4799.5n 0.7100 4800.0n 0.7100 5399.5n 0.7100 5400.0n 0.7100 5999.5n 0.7100 6000.0n 0.7100 6599.5n 0.7100 6600.0n 0.7100 7199.5n 0.7100 7200.0n 0.7100 7799.5n 0.7100 7800.0n 0.7100 8399.5n 0.7100 8400.0n 0.7100 8999.5n 0.7100 9000.0n 0.7100 9599.5n 0.7100 9600.0n 0.7100 10199.5n 0.7100 10200.0n 0.7100 10799.5n 0.7100 10800.0n 0.7100 11399.5n 0.7100 11400.0n 0.7100 11999.5n 0.7100 12000.0n 0.7100 12599.5n 0.7100 12600.0n 0.7100 13199.5n 0.7100 13200.0n 0.7100 13799.5n 0.7100 13800.0n 0.7100 14399.5n 0.7100 14400.0n 0.7100 14999.5n 0.7100 15000.0n 0.7100 15599.5n 0.7100 15600.0n 0.7100 16199.5n 0.7100 16200.0n 0.7100 16799.5n 0.7100 16800.0n 0.7100 17399.5n 0.7100 17400.0n 0.7100 17999.5n 0.7100 18000.0n 0.7100 18599.5n 0.7100 18600.0n 0.7100 19199.5n 0.7100 19200.0n 0.7100 19799.5n 0.7100 19800.0n 0.7100 20399.5n 0.7100 20400.0n 0.7100 20999.5n 0.7100 21000.0n 0.7100 21599.5n 0.7100 21600.0n 0.7100 22199.5n 0.7100 22200.0n 0.7100 22799.5n 0.7100 22800.0n 0.7100 23399.5n 0.7100 23400.0n 0.7100 23999.5n 0.7100 24000.0n 0.7100 24599.5n 0.7100 24600.0n 0.7100 25199.5n 0.7100 25200.0n 0.7100 25799.5n 0.7100 25800.0n 0.7100 26399.5n 0.7100 26400.0n 0.7100 26999.5n 0.7100 27000.0n 0.7100 27599.5n 0.7100 27600.0n 0.7100 28199.5n 0.7100 28200.0n 0.7100 28799.5n 0.7100 28800.0n 0.7100 29399.5n 0.7100 29400.0n 0.7100 29999.5n 0.7100 30000.0n 0.7100 30599.5n 0.7100 30600.0n 0.7100 31199.5n 0.7100 31200.0n 0.7100 31799.5n 0.7100 31800.0n 0.7100 32399.5n 0.7100 32400.0n 0.7100 32999.5n 0.7100 33000.0n 0.7100 33599.5n 0.7100 33600.0n 0.7100 34199.5n 0.7100 34200.0n 0.7100 34799.5n 0.7100 34800.0n 0.7100 35399.5n 0.7100 35400.0n 0.7100 35999.5n 0.7100)
Vxn_bh_33 xn_bh_33 0 PWL(0.0n 0.2900 599.5n 0.2900 600.0n 0.2900 1199.5n 0.2900 1200.0n 0.2900 1799.5n 0.2900 1800.0n 0.2900 2399.5n 0.2900 2400.0n 0.2900 2999.5n 0.2900 3000.0n 0.2900 3599.5n 0.2900 3600.0n 0.2900 4199.5n 0.2900 4200.0n 0.2900 4799.5n 0.2900 4800.0n 0.2900 5399.5n 0.2900 5400.0n 0.2900 5999.5n 0.2900 6000.0n 0.2900 6599.5n 0.2900 6600.0n 0.2900 7199.5n 0.2900 7200.0n 0.2900 7799.5n 0.2900 7800.0n 0.2900 8399.5n 0.2900 8400.0n 0.2900 8999.5n 0.2900 9000.0n 0.2900 9599.5n 0.2900 9600.0n 0.2900 10199.5n 0.2900 10200.0n 0.2900 10799.5n 0.2900 10800.0n 0.2900 11399.5n 0.2900 11400.0n 0.2900 11999.5n 0.2900 12000.0n 0.2900 12599.5n 0.2900 12600.0n 0.2900 13199.5n 0.2900 13200.0n 0.2900 13799.5n 0.2900 13800.0n 0.2900 14399.5n 0.2900 14400.0n 0.2900 14999.5n 0.2900 15000.0n 0.2900 15599.5n 0.2900 15600.0n 0.2900 16199.5n 0.2900 16200.0n 0.2900 16799.5n 0.2900 16800.0n 0.2900 17399.5n 0.2900 17400.0n 0.2900 17999.5n 0.2900 18000.0n 0.2900 18599.5n 0.2900 18600.0n 0.2900 19199.5n 0.2900 19200.0n 0.2900 19799.5n 0.2900 19800.0n 0.2900 20399.5n 0.2900 20400.0n 0.2900 20999.5n 0.2900 21000.0n 0.2900 21599.5n 0.2900 21600.0n 0.2900 22199.5n 0.2900 22200.0n 0.2900 22799.5n 0.2900 22800.0n 0.2900 23399.5n 0.2900 23400.0n 0.2900 23999.5n 0.2900 24000.0n 0.2900 24599.5n 0.2900 24600.0n 0.2900 25199.5n 0.2900 25200.0n 0.2900 25799.5n 0.2900 25800.0n 0.2900 26399.5n 0.2900 26400.0n 0.2900 26999.5n 0.2900 27000.0n 0.2900 27599.5n 0.2900 27600.0n 0.2900 28199.5n 0.2900 28200.0n 0.2900 28799.5n 0.2900 28800.0n 0.2900 29399.5n 0.2900 29400.0n 0.2900 29999.5n 0.2900 30000.0n 0.2900 30599.5n 0.2900 30600.0n 0.2900 31199.5n 0.2900 31200.0n 0.2900 31799.5n 0.2900 31800.0n 0.2900 32399.5n 0.2900 32400.0n 0.2900 32999.5n 0.2900 33000.0n 0.2900 33599.5n 0.2900 33600.0n 0.2900 34199.5n 0.2900 34200.0n 0.2900 34799.5n 0.2900 34800.0n 0.2900 35399.5n 0.2900 35400.0n 0.2900 35999.5n 0.2900)
Vyp_bh_33 yp_bh_33 0 PWL(0.0n 0.3917 599.5n 0.3917 600.0n 0.3967 1199.5n 0.3967 1200.0n 0.3981 1799.5n 0.3981 1800.0n 0.4050 2399.5n 0.4050 2400.0n 0.4031 2999.5n 0.4031 3000.0n 0.3960 3599.5n 0.3960 3600.0n 0.3965 4199.5n 0.3965 4200.0n 0.3914 4799.5n 0.3914 4800.0n 0.3960 5399.5n 0.3960 5400.0n 0.3961 5999.5n 0.3961 6000.0n 0.3994 6599.5n 0.3994 6600.0n 0.3949 7199.5n 0.3949 7200.0n 0.3979 7799.5n 0.3979 7800.0n 0.3986 8399.5n 0.3986 8400.0n 0.3923 8999.5n 0.3923 9000.0n 0.3960 9599.5n 0.3960 9600.0n 0.3976 10199.5n 0.3976 10200.0n 0.3989 10799.5n 0.3989 10800.0n 0.3974 11399.5n 0.3974 11400.0n 0.3954 11999.5n 0.3954 12000.0n 0.3914 12599.5n 0.3914 12600.0n 0.3980 13199.5n 0.3980 13200.0n 0.3916 13799.5n 0.3916 13800.0n 0.3947 14399.5n 0.3947 14400.0n 0.3953 14999.5n 0.3953 15000.0n 0.4004 15599.5n 0.4004 15600.0n 0.3928 16199.5n 0.3928 16200.0n 0.3924 16799.5n 0.3924 16800.0n 0.3926 17399.5n 0.3926 17400.0n 0.3923 17999.5n 0.3923 18000.0n 0.4025 18599.5n 0.4025 18600.0n 0.4014 19199.5n 0.4014 19200.0n 0.4119 19799.5n 0.4119 19800.0n 0.4139 20399.5n 0.4139 20400.0n 0.4100 20999.5n 0.4100 21000.0n 0.3920 21599.5n 0.3920 21600.0n 0.4086 22199.5n 0.4086 22200.0n 0.4026 22799.5n 0.4026 22800.0n 0.4098 23399.5n 0.4098 23400.0n 0.3877 23999.5n 0.3877 24000.0n 0.4191 24599.5n 0.4191 24600.0n 0.4003 25199.5n 0.4003 25200.0n 0.4063 25799.5n 0.4063 25800.0n 0.4007 26399.5n 0.4007 26400.0n 0.4063 26999.5n 0.4063 27000.0n 0.4041 27599.5n 0.4041 27600.0n 0.4066 28199.5n 0.4066 28200.0n 0.3909 28799.5n 0.3909 28800.0n 0.4096 29399.5n 0.4096 29400.0n 0.3911 29999.5n 0.3911 30000.0n 0.3894 30599.5n 0.3894 30600.0n 0.3807 31199.5n 0.3807 31200.0n 0.3825 31799.5n 0.3825 31800.0n 0.3997 32399.5n 0.3997 32400.0n 0.4008 32999.5n 0.4008 33000.0n 0.4151 33599.5n 0.4151 33600.0n 0.4125 34199.5n 0.4125 34200.0n 0.3989 34799.5n 0.3989 34800.0n 0.3857 35399.5n 0.3857 35400.0n 0.4123 35999.5n 0.4123)
Vyn_bh_33 yn_bh_33 0 PWL(0.0n 0.6083 599.5n 0.6083 600.0n 0.6033 1199.5n 0.6033 1200.0n 0.6019 1799.5n 0.6019 1800.0n 0.5950 2399.5n 0.5950 2400.0n 0.5969 2999.5n 0.5969 3000.0n 0.6040 3599.5n 0.6040 3600.0n 0.6035 4199.5n 0.6035 4200.0n 0.6086 4799.5n 0.6086 4800.0n 0.6040 5399.5n 0.6040 5400.0n 0.6039 5999.5n 0.6039 6000.0n 0.6006 6599.5n 0.6006 6600.0n 0.6051 7199.5n 0.6051 7200.0n 0.6021 7799.5n 0.6021 7800.0n 0.6014 8399.5n 0.6014 8400.0n 0.6077 8999.5n 0.6077 9000.0n 0.6040 9599.5n 0.6040 9600.0n 0.6024 10199.5n 0.6024 10200.0n 0.6011 10799.5n 0.6011 10800.0n 0.6026 11399.5n 0.6026 11400.0n 0.6046 11999.5n 0.6046 12000.0n 0.6086 12599.5n 0.6086 12600.0n 0.6020 13199.5n 0.6020 13200.0n 0.6084 13799.5n 0.6084 13800.0n 0.6053 14399.5n 0.6053 14400.0n 0.6047 14999.5n 0.6047 15000.0n 0.5996 15599.5n 0.5996 15600.0n 0.6072 16199.5n 0.6072 16200.0n 0.6076 16799.5n 0.6076 16800.0n 0.6074 17399.5n 0.6074 17400.0n 0.6077 17999.5n 0.6077 18000.0n 0.5975 18599.5n 0.5975 18600.0n 0.5986 19199.5n 0.5986 19200.0n 0.5881 19799.5n 0.5881 19800.0n 0.5861 20399.5n 0.5861 20400.0n 0.5900 20999.5n 0.5900 21000.0n 0.6080 21599.5n 0.6080 21600.0n 0.5914 22199.5n 0.5914 22200.0n 0.5974 22799.5n 0.5974 22800.0n 0.5902 23399.5n 0.5902 23400.0n 0.6123 23999.5n 0.6123 24000.0n 0.5809 24599.5n 0.5809 24600.0n 0.5997 25199.5n 0.5997 25200.0n 0.5937 25799.5n 0.5937 25800.0n 0.5993 26399.5n 0.5993 26400.0n 0.5937 26999.5n 0.5937 27000.0n 0.5959 27599.5n 0.5959 27600.0n 0.5934 28199.5n 0.5934 28200.0n 0.6091 28799.5n 0.6091 28800.0n 0.5904 29399.5n 0.5904 29400.0n 0.6089 29999.5n 0.6089 30000.0n 0.6106 30599.5n 0.6106 30600.0n 0.6193 31199.5n 0.6193 31200.0n 0.6175 31799.5n 0.6175 31800.0n 0.6003 32399.5n 0.6003 32400.0n 0.5992 32999.5n 0.5992 33000.0n 0.5849 33599.5n 0.5849 33600.0n 0.5875 34199.5n 0.5875 34200.0n 0.6011 34799.5n 0.6011 34800.0n 0.6143 35399.5n 0.6143 35400.0n 0.5877 35999.5n 0.5877)
Cwp_bh_33 wp_bh_33 0 400p
Cwn_bh_33 wn_bh_33 0 400p
Xu_bh_33 xp_bh_33 xn_bh_33 yp_bh_33 yn_bh_33 wp_bh_33 wn_bh_33 vdd gbn gprod
Vxp_wih_0_34 xp_wih_0_34 0 PWL(0.0n 0.4942 599.5n 0.4942 600.0n 0.5558 1199.5n 0.5558 1200.0n 0.4708 1799.5n 0.4708 1800.0n 0.5235 2399.5n 0.5235 2400.0n 0.5350 2999.5n 0.5350 3000.0n 0.5172 3599.5n 0.5172 3600.0n 0.4702 4199.5n 0.4702 4200.0n 0.4867 4799.5n 0.4867 4800.0n 0.4970 5399.5n 0.4970 5400.0n 0.4986 5999.5n 0.4986 6000.0n 0.4751 6599.5n 0.4751 6600.0n 0.4870 7199.5n 0.4870 7200.0n 0.5502 7799.5n 0.5502 7800.0n 0.5521 8399.5n 0.5521 8400.0n 0.4638 8999.5n 0.4638 9000.0n 0.4982 9599.5n 0.4982 9600.0n 0.5131 10199.5n 0.5131 10200.0n 0.5386 10799.5n 0.5386 10800.0n 0.4592 11399.5n 0.4592 11400.0n 0.4950 11999.5n 0.4950 12000.0n 0.4559 12599.5n 0.4559 12600.0n 0.5162 13199.5n 0.5162 13200.0n 0.5038 13799.5n 0.5038 13800.0n 0.5333 14399.5n 0.5333 14400.0n 0.4991 14999.5n 0.4991 15000.0n 0.5298 15599.5n 0.5298 15600.0n 0.4823 16199.5n 0.4823 16200.0n 0.5239 16799.5n 0.5239 16800.0n 0.4592 17399.5n 0.4592 17400.0n 0.5094 17999.5n 0.5094 18000.0n 0.4337 18599.5n 0.4337 18600.0n 0.5977 19199.5n 0.5977 19200.0n 0.5364 19799.5n 0.5364 19800.0n 0.6122 20399.5n 0.6122 20400.0n 0.4856 20999.5n 0.4856 21000.0n 0.3861 21599.5n 0.3861 21600.0n 0.6094 22199.5n 0.6094 22200.0n 0.6364 22799.5n 0.6364 22800.0n 0.4807 23399.5n 0.4807 23400.0n 0.5614 23999.5n 0.5614 24000.0n 0.5913 24599.5n 0.5913 24600.0n 0.6295 25199.5n 0.6295 25200.0n 0.4496 25799.5n 0.4496 25800.0n 0.3792 26399.5n 0.3792 26400.0n 0.4434 26999.5n 0.4434 27000.0n 0.4340 27599.5n 0.4340 27600.0n 0.4461 28199.5n 0.4461 28200.0n 0.5791 28799.5n 0.5791 28800.0n 0.4777 29399.5n 0.4777 29400.0n 0.3878 29999.5n 0.3878 30000.0n 0.3832 30599.5n 0.3832 30600.0n 0.4022 31199.5n 0.4022 31200.0n 0.4482 31799.5n 0.4482 31800.0n 0.3662 32399.5n 0.3662 32400.0n 0.3857 32999.5n 0.3857 33000.0n 0.5584 33599.5n 0.5584 33600.0n 0.5284 34199.5n 0.5284 34200.0n 0.6034 34799.5n 0.6034 34800.0n 0.3469 35399.5n 0.3469 35400.0n 0.5290 35999.5n 0.5290)
Vxn_wih_0_34 xn_wih_0_34 0 PWL(0.0n 0.5058 599.5n 0.5058 600.0n 0.4442 1199.5n 0.4442 1200.0n 0.5292 1799.5n 0.5292 1800.0n 0.4765 2399.5n 0.4765 2400.0n 0.4650 2999.5n 0.4650 3000.0n 0.4828 3599.5n 0.4828 3600.0n 0.5298 4199.5n 0.5298 4200.0n 0.5133 4799.5n 0.5133 4800.0n 0.5030 5399.5n 0.5030 5400.0n 0.5014 5999.5n 0.5014 6000.0n 0.5249 6599.5n 0.5249 6600.0n 0.5130 7199.5n 0.5130 7200.0n 0.4498 7799.5n 0.4498 7800.0n 0.4479 8399.5n 0.4479 8400.0n 0.5362 8999.5n 0.5362 9000.0n 0.5018 9599.5n 0.5018 9600.0n 0.4869 10199.5n 0.4869 10200.0n 0.4614 10799.5n 0.4614 10800.0n 0.5408 11399.5n 0.5408 11400.0n 0.5050 11999.5n 0.5050 12000.0n 0.5441 12599.5n 0.5441 12600.0n 0.4838 13199.5n 0.4838 13200.0n 0.4962 13799.5n 0.4962 13800.0n 0.4667 14399.5n 0.4667 14400.0n 0.5009 14999.5n 0.5009 15000.0n 0.4702 15599.5n 0.4702 15600.0n 0.5177 16199.5n 0.5177 16200.0n 0.4761 16799.5n 0.4761 16800.0n 0.5408 17399.5n 0.5408 17400.0n 0.4906 17999.5n 0.4906 18000.0n 0.5663 18599.5n 0.5663 18600.0n 0.4023 19199.5n 0.4023 19200.0n 0.4636 19799.5n 0.4636 19800.0n 0.3878 20399.5n 0.3878 20400.0n 0.5144 20999.5n 0.5144 21000.0n 0.6139 21599.5n 0.6139 21600.0n 0.3906 22199.5n 0.3906 22200.0n 0.3636 22799.5n 0.3636 22800.0n 0.5193 23399.5n 0.5193 23400.0n 0.4386 23999.5n 0.4386 24000.0n 0.4087 24599.5n 0.4087 24600.0n 0.3705 25199.5n 0.3705 25200.0n 0.5504 25799.5n 0.5504 25800.0n 0.6208 26399.5n 0.6208 26400.0n 0.5566 26999.5n 0.5566 27000.0n 0.5660 27599.5n 0.5660 27600.0n 0.5539 28199.5n 0.5539 28200.0n 0.4209 28799.5n 0.4209 28800.0n 0.5223 29399.5n 0.5223 29400.0n 0.6122 29999.5n 0.6122 30000.0n 0.6168 30599.5n 0.6168 30600.0n 0.5978 31199.5n 0.5978 31200.0n 0.5518 31799.5n 0.5518 31800.0n 0.6338 32399.5n 0.6338 32400.0n 0.6143 32999.5n 0.6143 33000.0n 0.4416 33599.5n 0.4416 33600.0n 0.4716 34199.5n 0.4716 34200.0n 0.3966 34799.5n 0.3966 34800.0n 0.6531 35399.5n 0.6531 35400.0n 0.4710 35999.5n 0.4710)
Vyp_wih_0_34 yp_wih_0_34 0 PWL(0.0n 0.4317 599.5n 0.4317 600.0n 0.3791 1199.5n 0.3791 1200.0n 0.4502 1799.5n 0.4502 1800.0n 0.4148 2399.5n 0.4148 2400.0n 0.4045 2999.5n 0.4045 3000.0n 0.4171 3599.5n 0.4171 3600.0n 0.4504 4199.5n 0.4504 4200.0n 0.4369 4799.5n 0.4369 4800.0n 0.4306 5399.5n 0.4306 5400.0n 0.4296 5999.5n 0.4296 6000.0n 0.4470 6599.5n 0.4470 6600.0n 0.4372 7199.5n 0.4372 7200.0n 0.3870 7799.5n 0.3870 7800.0n 0.3847 8399.5n 0.3847 8400.0n 0.4556 8999.5n 0.4556 9000.0n 0.4298 9599.5n 0.4298 9600.0n 0.4202 10199.5n 0.4202 10200.0n 0.4002 10799.5n 0.4002 10800.0n 0.4610 11399.5n 0.4610 11400.0n 0.4319 11999.5n 0.4319 12000.0n 0.4638 12599.5n 0.4638 12600.0n 0.4181 13199.5n 0.4181 13200.0n 0.4254 13799.5n 0.4254 13800.0n 0.4042 14399.5n 0.4042 14400.0n 0.4291 14999.5n 0.4291 15000.0n 0.4083 15599.5n 0.4083 15600.0n 0.4402 16199.5n 0.4402 16200.0n 0.4114 16799.5n 0.4114 16800.0n 0.4603 17399.5n 0.4603 17400.0n 0.4217 17999.5n 0.4217 18000.0n 0.5016 18599.5n 0.5016 18600.0n 0.3466 19199.5n 0.3466 19200.0n 0.4075 19799.5n 0.4075 19800.0n 0.3449 20399.5n 0.3449 20400.0n 0.4449 20999.5n 0.4449 21000.0n 0.5359 21599.5n 0.5359 21600.0n 0.3451 22199.5n 0.3451 22200.0n 0.3420 22799.5n 0.3420 22800.0n 0.4487 23399.5n 0.4487 23400.0n 0.3662 23999.5n 0.3662 24000.0n 0.3495 24599.5n 0.3495 24600.0n 0.3422 25199.5n 0.3422 25200.0n 0.4776 25799.5n 0.4776 25800.0n 0.5432 26399.5n 0.5432 26400.0n 0.4875 26999.5n 0.4875 27000.0n 0.5025 27599.5n 0.5025 27600.0n 0.4834 28199.5n 0.4834 28200.0n 0.3487 28799.5n 0.3487 28800.0n 0.4509 29399.5n 0.4509 29400.0n 0.5348 29999.5n 0.5348 30000.0n 0.5361 30599.5n 0.5361 30600.0n 0.5232 31199.5n 0.5232 31200.0n 0.4694 31799.5n 0.4694 31800.0n 0.5463 32399.5n 0.5463 32400.0n 0.5408 32999.5n 0.5408 33000.0n 0.3823 33599.5n 0.3823 33600.0n 0.4151 34199.5n 0.4151 34200.0n 0.3450 34799.5n 0.3450 34800.0n 0.5438 35399.5n 0.5438 35400.0n 0.4145 35999.5n 0.4145)
Vyn_wih_0_34 yn_wih_0_34 0 PWL(0.0n 0.5683 599.5n 0.5683 600.0n 0.6209 1199.5n 0.6209 1200.0n 0.5498 1799.5n 0.5498 1800.0n 0.5852 2399.5n 0.5852 2400.0n 0.5955 2999.5n 0.5955 3000.0n 0.5829 3599.5n 0.5829 3600.0n 0.5496 4199.5n 0.5496 4200.0n 0.5631 4799.5n 0.5631 4800.0n 0.5694 5399.5n 0.5694 5400.0n 0.5704 5999.5n 0.5704 6000.0n 0.5530 6599.5n 0.5530 6600.0n 0.5628 7199.5n 0.5628 7200.0n 0.6130 7799.5n 0.6130 7800.0n 0.6153 8399.5n 0.6153 8400.0n 0.5444 8999.5n 0.5444 9000.0n 0.5702 9599.5n 0.5702 9600.0n 0.5798 10199.5n 0.5798 10200.0n 0.5998 10799.5n 0.5998 10800.0n 0.5390 11399.5n 0.5390 11400.0n 0.5681 11999.5n 0.5681 12000.0n 0.5362 12599.5n 0.5362 12600.0n 0.5819 13199.5n 0.5819 13200.0n 0.5746 13799.5n 0.5746 13800.0n 0.5958 14399.5n 0.5958 14400.0n 0.5709 14999.5n 0.5709 15000.0n 0.5917 15599.5n 0.5917 15600.0n 0.5598 16199.5n 0.5598 16200.0n 0.5886 16799.5n 0.5886 16800.0n 0.5397 17399.5n 0.5397 17400.0n 0.5783 17999.5n 0.5783 18000.0n 0.4984 18599.5n 0.4984 18600.0n 0.6534 19199.5n 0.6534 19200.0n 0.5925 19799.5n 0.5925 19800.0n 0.6551 20399.5n 0.6551 20400.0n 0.5551 20999.5n 0.5551 21000.0n 0.4641 21599.5n 0.4641 21600.0n 0.6549 22199.5n 0.6549 22200.0n 0.6580 22799.5n 0.6580 22800.0n 0.5513 23399.5n 0.5513 23400.0n 0.6338 23999.5n 0.6338 24000.0n 0.6505 24599.5n 0.6505 24600.0n 0.6578 25199.5n 0.6578 25200.0n 0.5224 25799.5n 0.5224 25800.0n 0.4568 26399.5n 0.4568 26400.0n 0.5125 26999.5n 0.5125 27000.0n 0.4975 27599.5n 0.4975 27600.0n 0.5166 28199.5n 0.5166 28200.0n 0.6513 28799.5n 0.6513 28800.0n 0.5491 29399.5n 0.5491 29400.0n 0.4652 29999.5n 0.4652 30000.0n 0.4639 30599.5n 0.4639 30600.0n 0.4768 31199.5n 0.4768 31200.0n 0.5306 31799.5n 0.5306 31800.0n 0.4537 32399.5n 0.4537 32400.0n 0.4592 32999.5n 0.4592 33000.0n 0.6177 33599.5n 0.6177 33600.0n 0.5849 34199.5n 0.5849 34200.0n 0.6550 34799.5n 0.6550 34800.0n 0.4562 35399.5n 0.4562 35400.0n 0.5855 35999.5n 0.5855)
Cwp_wih_0_34 wp_wih_0_34 0 400p
Cwn_wih_0_34 wn_wih_0_34 0 400p
Xu_wih_0_34 xp_wih_0_34 xn_wih_0_34 yp_wih_0_34 yn_wih_0_34 wp_wih_0_34 wn_wih_0_34 vdd gbn gprod
Vxp_wih_1_34 xp_wih_1_34 0 PWL(0.0n 0.5370 599.5n 0.5370 600.0n 0.5167 1199.5n 0.5167 1200.0n 0.4793 1799.5n 0.4793 1800.0n 0.4441 2399.5n 0.4441 2400.0n 0.4555 2999.5n 0.4555 3000.0n 0.5055 3599.5n 0.5055 3600.0n 0.4939 4199.5n 0.4939 4200.0n 0.5385 4799.5n 0.5385 4800.0n 0.5024 5399.5n 0.5024 5400.0n 0.5015 5999.5n 0.5015 6000.0n 0.4700 6599.5n 0.4700 6600.0n 0.5120 7199.5n 0.5120 7200.0n 0.5006 7799.5n 0.5006 7800.0n 0.4950 8399.5n 0.4950 8400.0n 0.5309 8999.5n 0.5309 9000.0n 0.5023 9599.5n 0.5023 9600.0n 0.4893 10199.5n 0.4893 10200.0n 0.4837 10799.5n 0.4837 10800.0n 0.4823 11399.5n 0.4823 11400.0n 0.5074 11999.5n 0.5074 12000.0n 0.5364 12599.5n 0.5364 12600.0n 0.4868 13199.5n 0.4868 13200.0n 0.5380 13799.5n 0.5380 13800.0n 0.5220 14399.5n 0.5220 14400.0n 0.5095 14999.5n 0.5095 15000.0n 0.4705 15599.5n 0.4705 15600.0n 0.5289 16199.5n 0.5289 16200.0n 0.5368 16799.5n 0.5368 16800.0n 0.5287 17399.5n 0.5287 17400.0n 0.5342 17999.5n 0.5342 18000.0n 0.4253 18599.5n 0.4253 18600.0n 0.5119 19199.5n 0.5119 19200.0n 0.4104 19799.5n 0.4104 19800.0n 0.4314 20399.5n 0.4314 20400.0n 0.4005 20999.5n 0.4005 21000.0n 0.4696 21599.5n 0.4696 21600.0n 0.4531 22199.5n 0.4531 22200.0n 0.5039 22799.5n 0.5039 22800.0n 0.3608 23399.5n 0.3608 23400.0n 0.6273 23999.5n 0.6273 24000.0n 0.3928 24599.5n 0.3928 24600.0n 0.5253 25199.5n 0.5253 25200.0n 0.4107 25799.5n 0.4107 25800.0n 0.3947 26399.5n 0.3947 26400.0n 0.3716 26999.5n 0.3716 27000.0n 0.4111 27599.5n 0.4111 27600.0n 0.3715 28199.5n 0.3715 28200.0n 0.5939 28799.5n 0.5939 28800.0n 0.3849 29399.5n 0.3849 29400.0n 0.4835 29999.5n 0.4835 30000.0n 0.5119 30599.5n 0.5119 30600.0n 0.6226 31199.5n 0.6226 31200.0n 0.6064 31799.5n 0.6064 31800.0n 0.4115 32399.5n 0.4115 32400.0n 0.3900 32999.5n 0.3900 33000.0n 0.3958 33599.5n 0.3958 33600.0n 0.3747 34199.5n 0.3747 34200.0n 0.5423 34799.5n 0.5423 34800.0n 0.5509 35399.5n 0.5509 35400.0n 0.3990 35999.5n 0.3990)
Vxn_wih_1_34 xn_wih_1_34 0 PWL(0.0n 0.4630 599.5n 0.4630 600.0n 0.4833 1199.5n 0.4833 1200.0n 0.5207 1799.5n 0.5207 1800.0n 0.5559 2399.5n 0.5559 2400.0n 0.5445 2999.5n 0.5445 3000.0n 0.4945 3599.5n 0.4945 3600.0n 0.5061 4199.5n 0.5061 4200.0n 0.4615 4799.5n 0.4615 4800.0n 0.4976 5399.5n 0.4976 5400.0n 0.4985 5999.5n 0.4985 6000.0n 0.5300 6599.5n 0.5300 6600.0n 0.4880 7199.5n 0.4880 7200.0n 0.4994 7799.5n 0.4994 7800.0n 0.5050 8399.5n 0.5050 8400.0n 0.4691 8999.5n 0.4691 9000.0n 0.4977 9599.5n 0.4977 9600.0n 0.5107 10199.5n 0.5107 10200.0n 0.5163 10799.5n 0.5163 10800.0n 0.5177 11399.5n 0.5177 11400.0n 0.4926 11999.5n 0.4926 12000.0n 0.4636 12599.5n 0.4636 12600.0n 0.5132 13199.5n 0.5132 13200.0n 0.4620 13799.5n 0.4620 13800.0n 0.4780 14399.5n 0.4780 14400.0n 0.4905 14999.5n 0.4905 15000.0n 0.5295 15599.5n 0.5295 15600.0n 0.4711 16199.5n 0.4711 16200.0n 0.4632 16799.5n 0.4632 16800.0n 0.4713 17399.5n 0.4713 17400.0n 0.4658 17999.5n 0.4658 18000.0n 0.5747 18599.5n 0.5747 18600.0n 0.4881 19199.5n 0.4881 19200.0n 0.5896 19799.5n 0.5896 19800.0n 0.5686 20399.5n 0.5686 20400.0n 0.5995 20999.5n 0.5995 21000.0n 0.5304 21599.5n 0.5304 21600.0n 0.5469 22199.5n 0.5469 22200.0n 0.4961 22799.5n 0.4961 22800.0n 0.6392 23399.5n 0.6392 23400.0n 0.3727 23999.5n 0.3727 24000.0n 0.6072 24599.5n 0.6072 24600.0n 0.4747 25199.5n 0.4747 25200.0n 0.5893 25799.5n 0.5893 25800.0n 0.6053 26399.5n 0.6053 26400.0n 0.6284 26999.5n 0.6284 27000.0n 0.5889 27599.5n 0.5889 27600.0n 0.6285 28199.5n 0.6285 28200.0n 0.4061 28799.5n 0.4061 28800.0n 0.6151 29399.5n 0.6151 29400.0n 0.5165 29999.5n 0.5165 30000.0n 0.4881 30599.5n 0.4881 30600.0n 0.3774 31199.5n 0.3774 31200.0n 0.3936 31799.5n 0.3936 31800.0n 0.5885 32399.5n 0.5885 32400.0n 0.6100 32999.5n 0.6100 33000.0n 0.6042 33599.5n 0.6042 33600.0n 0.6253 34199.5n 0.6253 34200.0n 0.4577 34799.5n 0.4577 34800.0n 0.4491 35399.5n 0.4491 35400.0n 0.6010 35999.5n 0.6010)
Vyp_wih_1_34 yp_wih_1_34 0 PWL(0.0n 0.4317 599.5n 0.4317 600.0n 0.3791 1199.5n 0.3791 1200.0n 0.4502 1799.5n 0.4502 1800.0n 0.4148 2399.5n 0.4148 2400.0n 0.4045 2999.5n 0.4045 3000.0n 0.4171 3599.5n 0.4171 3600.0n 0.4504 4199.5n 0.4504 4200.0n 0.4369 4799.5n 0.4369 4800.0n 0.4306 5399.5n 0.4306 5400.0n 0.4296 5999.5n 0.4296 6000.0n 0.4470 6599.5n 0.4470 6600.0n 0.4372 7199.5n 0.4372 7200.0n 0.3870 7799.5n 0.3870 7800.0n 0.3847 8399.5n 0.3847 8400.0n 0.4556 8999.5n 0.4556 9000.0n 0.4298 9599.5n 0.4298 9600.0n 0.4202 10199.5n 0.4202 10200.0n 0.4002 10799.5n 0.4002 10800.0n 0.4610 11399.5n 0.4610 11400.0n 0.4319 11999.5n 0.4319 12000.0n 0.4638 12599.5n 0.4638 12600.0n 0.4181 13199.5n 0.4181 13200.0n 0.4254 13799.5n 0.4254 13800.0n 0.4042 14399.5n 0.4042 14400.0n 0.4291 14999.5n 0.4291 15000.0n 0.4083 15599.5n 0.4083 15600.0n 0.4402 16199.5n 0.4402 16200.0n 0.4114 16799.5n 0.4114 16800.0n 0.4603 17399.5n 0.4603 17400.0n 0.4217 17999.5n 0.4217 18000.0n 0.5016 18599.5n 0.5016 18600.0n 0.3466 19199.5n 0.3466 19200.0n 0.4075 19799.5n 0.4075 19800.0n 0.3449 20399.5n 0.3449 20400.0n 0.4449 20999.5n 0.4449 21000.0n 0.5359 21599.5n 0.5359 21600.0n 0.3451 22199.5n 0.3451 22200.0n 0.3420 22799.5n 0.3420 22800.0n 0.4487 23399.5n 0.4487 23400.0n 0.3662 23999.5n 0.3662 24000.0n 0.3495 24599.5n 0.3495 24600.0n 0.3422 25199.5n 0.3422 25200.0n 0.4776 25799.5n 0.4776 25800.0n 0.5432 26399.5n 0.5432 26400.0n 0.4875 26999.5n 0.4875 27000.0n 0.5025 27599.5n 0.5025 27600.0n 0.4834 28199.5n 0.4834 28200.0n 0.3487 28799.5n 0.3487 28800.0n 0.4509 29399.5n 0.4509 29400.0n 0.5348 29999.5n 0.5348 30000.0n 0.5361 30599.5n 0.5361 30600.0n 0.5232 31199.5n 0.5232 31200.0n 0.4694 31799.5n 0.4694 31800.0n 0.5463 32399.5n 0.5463 32400.0n 0.5408 32999.5n 0.5408 33000.0n 0.3823 33599.5n 0.3823 33600.0n 0.4151 34199.5n 0.4151 34200.0n 0.3450 34799.5n 0.3450 34800.0n 0.5438 35399.5n 0.5438 35400.0n 0.4145 35999.5n 0.4145)
Vyn_wih_1_34 yn_wih_1_34 0 PWL(0.0n 0.5683 599.5n 0.5683 600.0n 0.6209 1199.5n 0.6209 1200.0n 0.5498 1799.5n 0.5498 1800.0n 0.5852 2399.5n 0.5852 2400.0n 0.5955 2999.5n 0.5955 3000.0n 0.5829 3599.5n 0.5829 3600.0n 0.5496 4199.5n 0.5496 4200.0n 0.5631 4799.5n 0.5631 4800.0n 0.5694 5399.5n 0.5694 5400.0n 0.5704 5999.5n 0.5704 6000.0n 0.5530 6599.5n 0.5530 6600.0n 0.5628 7199.5n 0.5628 7200.0n 0.6130 7799.5n 0.6130 7800.0n 0.6153 8399.5n 0.6153 8400.0n 0.5444 8999.5n 0.5444 9000.0n 0.5702 9599.5n 0.5702 9600.0n 0.5798 10199.5n 0.5798 10200.0n 0.5998 10799.5n 0.5998 10800.0n 0.5390 11399.5n 0.5390 11400.0n 0.5681 11999.5n 0.5681 12000.0n 0.5362 12599.5n 0.5362 12600.0n 0.5819 13199.5n 0.5819 13200.0n 0.5746 13799.5n 0.5746 13800.0n 0.5958 14399.5n 0.5958 14400.0n 0.5709 14999.5n 0.5709 15000.0n 0.5917 15599.5n 0.5917 15600.0n 0.5598 16199.5n 0.5598 16200.0n 0.5886 16799.5n 0.5886 16800.0n 0.5397 17399.5n 0.5397 17400.0n 0.5783 17999.5n 0.5783 18000.0n 0.4984 18599.5n 0.4984 18600.0n 0.6534 19199.5n 0.6534 19200.0n 0.5925 19799.5n 0.5925 19800.0n 0.6551 20399.5n 0.6551 20400.0n 0.5551 20999.5n 0.5551 21000.0n 0.4641 21599.5n 0.4641 21600.0n 0.6549 22199.5n 0.6549 22200.0n 0.6580 22799.5n 0.6580 22800.0n 0.5513 23399.5n 0.5513 23400.0n 0.6338 23999.5n 0.6338 24000.0n 0.6505 24599.5n 0.6505 24600.0n 0.6578 25199.5n 0.6578 25200.0n 0.5224 25799.5n 0.5224 25800.0n 0.4568 26399.5n 0.4568 26400.0n 0.5125 26999.5n 0.5125 27000.0n 0.4975 27599.5n 0.4975 27600.0n 0.5166 28199.5n 0.5166 28200.0n 0.6513 28799.5n 0.6513 28800.0n 0.5491 29399.5n 0.5491 29400.0n 0.4652 29999.5n 0.4652 30000.0n 0.4639 30599.5n 0.4639 30600.0n 0.4768 31199.5n 0.4768 31200.0n 0.5306 31799.5n 0.5306 31800.0n 0.4537 32399.5n 0.4537 32400.0n 0.4592 32999.5n 0.4592 33000.0n 0.6177 33599.5n 0.6177 33600.0n 0.5849 34199.5n 0.5849 34200.0n 0.6550 34799.5n 0.6550 34800.0n 0.4562 35399.5n 0.4562 35400.0n 0.5855 35999.5n 0.5855)
Cwp_wih_1_34 wp_wih_1_34 0 400p
Cwn_wih_1_34 wn_wih_1_34 0 400p
Xu_wih_1_34 xp_wih_1_34 xn_wih_1_34 yp_wih_1_34 yn_wih_1_34 wp_wih_1_34 wn_wih_1_34 vdd gbn gprod
Vxp_who_34_0 xp_who_34_0 0 PWL(0.0n 0.4317 599.5n 0.4317 600.0n 0.3791 1199.5n 0.3791 1200.0n 0.4502 1799.5n 0.4502 1800.0n 0.4148 2399.5n 0.4148 2400.0n 0.4045 2999.5n 0.4045 3000.0n 0.4171 3599.5n 0.4171 3600.0n 0.4504 4199.5n 0.4504 4200.0n 0.4369 4799.5n 0.4369 4800.0n 0.4306 5399.5n 0.4306 5400.0n 0.4296 5999.5n 0.4296 6000.0n 0.4470 6599.5n 0.4470 6600.0n 0.4372 7199.5n 0.4372 7200.0n 0.3870 7799.5n 0.3870 7800.0n 0.3847 8399.5n 0.3847 8400.0n 0.4556 8999.5n 0.4556 9000.0n 0.4298 9599.5n 0.4298 9600.0n 0.4202 10199.5n 0.4202 10200.0n 0.4002 10799.5n 0.4002 10800.0n 0.4610 11399.5n 0.4610 11400.0n 0.4319 11999.5n 0.4319 12000.0n 0.4638 12599.5n 0.4638 12600.0n 0.4181 13199.5n 0.4181 13200.0n 0.4254 13799.5n 0.4254 13800.0n 0.4042 14399.5n 0.4042 14400.0n 0.4291 14999.5n 0.4291 15000.0n 0.4083 15599.5n 0.4083 15600.0n 0.4402 16199.5n 0.4402 16200.0n 0.4114 16799.5n 0.4114 16800.0n 0.4603 17399.5n 0.4603 17400.0n 0.4217 17999.5n 0.4217 18000.0n 0.5016 18599.5n 0.5016 18600.0n 0.3466 19199.5n 0.3466 19200.0n 0.4075 19799.5n 0.4075 19800.0n 0.3449 20399.5n 0.3449 20400.0n 0.4449 20999.5n 0.4449 21000.0n 0.5359 21599.5n 0.5359 21600.0n 0.3451 22199.5n 0.3451 22200.0n 0.3420 22799.5n 0.3420 22800.0n 0.4487 23399.5n 0.4487 23400.0n 0.3662 23999.5n 0.3662 24000.0n 0.3495 24599.5n 0.3495 24600.0n 0.3422 25199.5n 0.3422 25200.0n 0.4776 25799.5n 0.4776 25800.0n 0.5432 26399.5n 0.5432 26400.0n 0.4875 26999.5n 0.4875 27000.0n 0.5025 27599.5n 0.5025 27600.0n 0.4834 28199.5n 0.4834 28200.0n 0.3487 28799.5n 0.3487 28800.0n 0.4509 29399.5n 0.4509 29400.0n 0.5348 29999.5n 0.5348 30000.0n 0.5361 30599.5n 0.5361 30600.0n 0.5232 31199.5n 0.5232 31200.0n 0.4694 31799.5n 0.4694 31800.0n 0.5463 32399.5n 0.5463 32400.0n 0.5408 32999.5n 0.5408 33000.0n 0.3823 33599.5n 0.3823 33600.0n 0.4151 34199.5n 0.4151 34200.0n 0.3450 34799.5n 0.3450 34800.0n 0.5438 35399.5n 0.5438 35400.0n 0.4145 35999.5n 0.4145)
Vxn_who_34_0 xn_who_34_0 0 PWL(0.0n 0.5683 599.5n 0.5683 600.0n 0.6209 1199.5n 0.6209 1200.0n 0.5498 1799.5n 0.5498 1800.0n 0.5852 2399.5n 0.5852 2400.0n 0.5955 2999.5n 0.5955 3000.0n 0.5829 3599.5n 0.5829 3600.0n 0.5496 4199.5n 0.5496 4200.0n 0.5631 4799.5n 0.5631 4800.0n 0.5694 5399.5n 0.5694 5400.0n 0.5704 5999.5n 0.5704 6000.0n 0.5530 6599.5n 0.5530 6600.0n 0.5628 7199.5n 0.5628 7200.0n 0.6130 7799.5n 0.6130 7800.0n 0.6153 8399.5n 0.6153 8400.0n 0.5444 8999.5n 0.5444 9000.0n 0.5702 9599.5n 0.5702 9600.0n 0.5798 10199.5n 0.5798 10200.0n 0.5998 10799.5n 0.5998 10800.0n 0.5390 11399.5n 0.5390 11400.0n 0.5681 11999.5n 0.5681 12000.0n 0.5362 12599.5n 0.5362 12600.0n 0.5819 13199.5n 0.5819 13200.0n 0.5746 13799.5n 0.5746 13800.0n 0.5958 14399.5n 0.5958 14400.0n 0.5709 14999.5n 0.5709 15000.0n 0.5917 15599.5n 0.5917 15600.0n 0.5598 16199.5n 0.5598 16200.0n 0.5886 16799.5n 0.5886 16800.0n 0.5397 17399.5n 0.5397 17400.0n 0.5783 17999.5n 0.5783 18000.0n 0.4984 18599.5n 0.4984 18600.0n 0.6534 19199.5n 0.6534 19200.0n 0.5925 19799.5n 0.5925 19800.0n 0.6551 20399.5n 0.6551 20400.0n 0.5551 20999.5n 0.5551 21000.0n 0.4641 21599.5n 0.4641 21600.0n 0.6549 22199.5n 0.6549 22200.0n 0.6580 22799.5n 0.6580 22800.0n 0.5513 23399.5n 0.5513 23400.0n 0.6338 23999.5n 0.6338 24000.0n 0.6505 24599.5n 0.6505 24600.0n 0.6578 25199.5n 0.6578 25200.0n 0.5224 25799.5n 0.5224 25800.0n 0.4568 26399.5n 0.4568 26400.0n 0.5125 26999.5n 0.5125 27000.0n 0.4975 27599.5n 0.4975 27600.0n 0.5166 28199.5n 0.5166 28200.0n 0.6513 28799.5n 0.6513 28800.0n 0.5491 29399.5n 0.5491 29400.0n 0.4652 29999.5n 0.4652 30000.0n 0.4639 30599.5n 0.4639 30600.0n 0.4768 31199.5n 0.4768 31200.0n 0.5306 31799.5n 0.5306 31800.0n 0.4537 32399.5n 0.4537 32400.0n 0.4592 32999.5n 0.4592 33000.0n 0.6177 33599.5n 0.6177 33600.0n 0.5849 34199.5n 0.5849 34200.0n 0.6550 34799.5n 0.6550 34800.0n 0.4562 35399.5n 0.4562 35400.0n 0.5855 35999.5n 0.5855)
Vyp_who_34_0 yp_who_34_0 0 PWL(0.0n 0.5031 599.5n 0.5031 600.0n 0.5023 1199.5n 0.5023 1200.0n 0.5052 1799.5n 0.5052 1800.0n 0.5048 2399.5n 0.5048 2400.0n 0.5043 2999.5n 0.5043 3000.0n 0.5034 3599.5n 0.5034 3600.0n 0.5048 4199.5n 0.5048 4200.0n 0.5031 4799.5n 0.5031 4800.0n 0.5040 5399.5n 0.5040 5400.0n 0.5040 5999.5n 0.5040 6000.0n 0.5054 6599.5n 0.5054 6600.0n 0.5040 7199.5n 0.5040 7200.0n 0.5027 7799.5n 0.5027 7800.0n 0.5027 8399.5n 0.5027 8400.0n 0.5038 8999.5n 0.5038 9000.0n 0.5040 9599.5n 0.5040 9600.0n 0.5039 10199.5n 0.5039 10200.0n 0.5033 10799.5n 0.5033 10800.0n 0.5056 11399.5n 0.5056 11400.0n 0.5040 11999.5n 0.5040 12000.0n 0.5036 12599.5n 0.5036 12600.0n 0.5039 13199.5n 0.5039 13200.0n 0.5029 13799.5n 0.5029 13800.0n 0.5025 14399.5n 0.5025 14400.0n 0.5038 14999.5n 0.5038 15000.0n 0.5041 15599.5n 0.5041 15600.0n 0.5036 16199.5n 0.5036 16200.0n 0.5025 16799.5n 0.5025 16800.0n 0.5040 17399.5n 0.5040 17400.0n 0.5029 17999.5n 0.5029 18000.0n 0.5057 18599.5n 0.5057 18600.0n 0.5010 19199.5n 0.5010 19200.0n 0.5041 19799.5n 0.5041 19800.0n 0.5021 20399.5n 0.5021 20400.0n 0.5044 20999.5n 0.5044 21000.0n 0.5056 21599.5n 0.5056 21600.0n 0.5016 22199.5n 0.5016 22200.0n 0.5006 22799.5n 0.5006 22800.0n 0.5041 23399.5n 0.5041 23400.0n 0.5027 23999.5n 0.5027 24000.0n 0.5029 24599.5n 0.5029 24600.0n 0.5006 25199.5n 0.5006 25200.0n 0.5047 25799.5n 0.5047 25800.0n 0.5046 26399.5n 0.5046 26400.0n 0.5039 26999.5n 0.5039 27000.0n 0.5049 27599.5n 0.5049 27600.0n 0.5039 28199.5n 0.5039 28200.0n 0.5017 28799.5n 0.5017 28800.0n 0.5042 29399.5n 0.5042 29400.0n 0.5056 29999.5n 0.5056 30000.0n 0.5051 30599.5n 0.5051 30600.0n 0.5039 31199.5n 0.5039 31200.0n 0.5033 31799.5n 0.5033 31800.0n 0.5049 32399.5n 0.5049 32400.0n 0.5045 32999.5n 0.5045 33000.0n 0.5036 33599.5n 0.5036 33600.0n 0.5042 34199.5n 0.5042 34200.0n 0.5012 34799.5n 0.5012 34800.0n 0.5036 35399.5n 0.5036 35400.0n 0.5042 35999.5n 0.5042)
Vyn_who_34_0 yn_who_34_0 0 PWL(0.0n 0.4969 599.5n 0.4969 600.0n 0.4977 1199.5n 0.4977 1200.0n 0.4948 1799.5n 0.4948 1800.0n 0.4952 2399.5n 0.4952 2400.0n 0.4957 2999.5n 0.4957 3000.0n 0.4966 3599.5n 0.4966 3600.0n 0.4952 4199.5n 0.4952 4200.0n 0.4969 4799.5n 0.4969 4800.0n 0.4960 5399.5n 0.4960 5400.0n 0.4960 5999.5n 0.4960 6000.0n 0.4946 6599.5n 0.4946 6600.0n 0.4960 7199.5n 0.4960 7200.0n 0.4973 7799.5n 0.4973 7800.0n 0.4973 8399.5n 0.4973 8400.0n 0.4962 8999.5n 0.4962 9000.0n 0.4960 9599.5n 0.4960 9600.0n 0.4961 10199.5n 0.4961 10200.0n 0.4967 10799.5n 0.4967 10800.0n 0.4944 11399.5n 0.4944 11400.0n 0.4960 11999.5n 0.4960 12000.0n 0.4964 12599.5n 0.4964 12600.0n 0.4961 13199.5n 0.4961 13200.0n 0.4971 13799.5n 0.4971 13800.0n 0.4975 14399.5n 0.4975 14400.0n 0.4962 14999.5n 0.4962 15000.0n 0.4959 15599.5n 0.4959 15600.0n 0.4964 16199.5n 0.4964 16200.0n 0.4975 16799.5n 0.4975 16800.0n 0.4960 17399.5n 0.4960 17400.0n 0.4971 17999.5n 0.4971 18000.0n 0.4943 18599.5n 0.4943 18600.0n 0.4990 19199.5n 0.4990 19200.0n 0.4959 19799.5n 0.4959 19800.0n 0.4979 20399.5n 0.4979 20400.0n 0.4956 20999.5n 0.4956 21000.0n 0.4944 21599.5n 0.4944 21600.0n 0.4984 22199.5n 0.4984 22200.0n 0.4994 22799.5n 0.4994 22800.0n 0.4959 23399.5n 0.4959 23400.0n 0.4973 23999.5n 0.4973 24000.0n 0.4971 24599.5n 0.4971 24600.0n 0.4994 25199.5n 0.4994 25200.0n 0.4953 25799.5n 0.4953 25800.0n 0.4954 26399.5n 0.4954 26400.0n 0.4961 26999.5n 0.4961 27000.0n 0.4951 27599.5n 0.4951 27600.0n 0.4961 28199.5n 0.4961 28200.0n 0.4983 28799.5n 0.4983 28800.0n 0.4958 29399.5n 0.4958 29400.0n 0.4944 29999.5n 0.4944 30000.0n 0.4949 30599.5n 0.4949 30600.0n 0.4961 31199.5n 0.4961 31200.0n 0.4967 31799.5n 0.4967 31800.0n 0.4951 32399.5n 0.4951 32400.0n 0.4955 32999.5n 0.4955 33000.0n 0.4964 33599.5n 0.4964 33600.0n 0.4958 34199.5n 0.4958 34200.0n 0.4988 34799.5n 0.4988 34800.0n 0.4964 35399.5n 0.4964 35400.0n 0.4958 35999.5n 0.4958)
Cwp_who_34_0 wp_who_34_0 0 400p
Cwn_who_34_0 wn_who_34_0 0 400p
Xu_who_34_0 xp_who_34_0 xn_who_34_0 yp_who_34_0 yn_who_34_0 wp_who_34_0 wn_who_34_0 vdd gbn gprod
Vxp_who_34_1 xp_who_34_1 0 PWL(0.0n 0.4317 599.5n 0.4317 600.0n 0.3791 1199.5n 0.3791 1200.0n 0.4502 1799.5n 0.4502 1800.0n 0.4148 2399.5n 0.4148 2400.0n 0.4045 2999.5n 0.4045 3000.0n 0.4171 3599.5n 0.4171 3600.0n 0.4504 4199.5n 0.4504 4200.0n 0.4369 4799.5n 0.4369 4800.0n 0.4306 5399.5n 0.4306 5400.0n 0.4296 5999.5n 0.4296 6000.0n 0.4470 6599.5n 0.4470 6600.0n 0.4372 7199.5n 0.4372 7200.0n 0.3870 7799.5n 0.3870 7800.0n 0.3847 8399.5n 0.3847 8400.0n 0.4556 8999.5n 0.4556 9000.0n 0.4298 9599.5n 0.4298 9600.0n 0.4202 10199.5n 0.4202 10200.0n 0.4002 10799.5n 0.4002 10800.0n 0.4610 11399.5n 0.4610 11400.0n 0.4319 11999.5n 0.4319 12000.0n 0.4638 12599.5n 0.4638 12600.0n 0.4181 13199.5n 0.4181 13200.0n 0.4254 13799.5n 0.4254 13800.0n 0.4042 14399.5n 0.4042 14400.0n 0.4291 14999.5n 0.4291 15000.0n 0.4083 15599.5n 0.4083 15600.0n 0.4402 16199.5n 0.4402 16200.0n 0.4114 16799.5n 0.4114 16800.0n 0.4603 17399.5n 0.4603 17400.0n 0.4217 17999.5n 0.4217 18000.0n 0.5016 18599.5n 0.5016 18600.0n 0.3466 19199.5n 0.3466 19200.0n 0.4075 19799.5n 0.4075 19800.0n 0.3449 20399.5n 0.3449 20400.0n 0.4449 20999.5n 0.4449 21000.0n 0.5359 21599.5n 0.5359 21600.0n 0.3451 22199.5n 0.3451 22200.0n 0.3420 22799.5n 0.3420 22800.0n 0.4487 23399.5n 0.4487 23400.0n 0.3662 23999.5n 0.3662 24000.0n 0.3495 24599.5n 0.3495 24600.0n 0.3422 25199.5n 0.3422 25200.0n 0.4776 25799.5n 0.4776 25800.0n 0.5432 26399.5n 0.5432 26400.0n 0.4875 26999.5n 0.4875 27000.0n 0.5025 27599.5n 0.5025 27600.0n 0.4834 28199.5n 0.4834 28200.0n 0.3487 28799.5n 0.3487 28800.0n 0.4509 29399.5n 0.4509 29400.0n 0.5348 29999.5n 0.5348 30000.0n 0.5361 30599.5n 0.5361 30600.0n 0.5232 31199.5n 0.5232 31200.0n 0.4694 31799.5n 0.4694 31800.0n 0.5463 32399.5n 0.5463 32400.0n 0.5408 32999.5n 0.5408 33000.0n 0.3823 33599.5n 0.3823 33600.0n 0.4151 34199.5n 0.4151 34200.0n 0.3450 34799.5n 0.3450 34800.0n 0.5438 35399.5n 0.5438 35400.0n 0.4145 35999.5n 0.4145)
Vxn_who_34_1 xn_who_34_1 0 PWL(0.0n 0.5683 599.5n 0.5683 600.0n 0.6209 1199.5n 0.6209 1200.0n 0.5498 1799.5n 0.5498 1800.0n 0.5852 2399.5n 0.5852 2400.0n 0.5955 2999.5n 0.5955 3000.0n 0.5829 3599.5n 0.5829 3600.0n 0.5496 4199.5n 0.5496 4200.0n 0.5631 4799.5n 0.5631 4800.0n 0.5694 5399.5n 0.5694 5400.0n 0.5704 5999.5n 0.5704 6000.0n 0.5530 6599.5n 0.5530 6600.0n 0.5628 7199.5n 0.5628 7200.0n 0.6130 7799.5n 0.6130 7800.0n 0.6153 8399.5n 0.6153 8400.0n 0.5444 8999.5n 0.5444 9000.0n 0.5702 9599.5n 0.5702 9600.0n 0.5798 10199.5n 0.5798 10200.0n 0.5998 10799.5n 0.5998 10800.0n 0.5390 11399.5n 0.5390 11400.0n 0.5681 11999.5n 0.5681 12000.0n 0.5362 12599.5n 0.5362 12600.0n 0.5819 13199.5n 0.5819 13200.0n 0.5746 13799.5n 0.5746 13800.0n 0.5958 14399.5n 0.5958 14400.0n 0.5709 14999.5n 0.5709 15000.0n 0.5917 15599.5n 0.5917 15600.0n 0.5598 16199.5n 0.5598 16200.0n 0.5886 16799.5n 0.5886 16800.0n 0.5397 17399.5n 0.5397 17400.0n 0.5783 17999.5n 0.5783 18000.0n 0.4984 18599.5n 0.4984 18600.0n 0.6534 19199.5n 0.6534 19200.0n 0.5925 19799.5n 0.5925 19800.0n 0.6551 20399.5n 0.6551 20400.0n 0.5551 20999.5n 0.5551 21000.0n 0.4641 21599.5n 0.4641 21600.0n 0.6549 22199.5n 0.6549 22200.0n 0.6580 22799.5n 0.6580 22800.0n 0.5513 23399.5n 0.5513 23400.0n 0.6338 23999.5n 0.6338 24000.0n 0.6505 24599.5n 0.6505 24600.0n 0.6578 25199.5n 0.6578 25200.0n 0.5224 25799.5n 0.5224 25800.0n 0.4568 26399.5n 0.4568 26400.0n 0.5125 26999.5n 0.5125 27000.0n 0.4975 27599.5n 0.4975 27600.0n 0.5166 28199.5n 0.5166 28200.0n 0.6513 28799.5n 0.6513 28800.0n 0.5491 29399.5n 0.5491 29400.0n 0.4652 29999.5n 0.4652 30000.0n 0.4639 30599.5n 0.4639 30600.0n 0.4768 31199.5n 0.4768 31200.0n 0.5306 31799.5n 0.5306 31800.0n 0.4537 32399.5n 0.4537 32400.0n 0.4592 32999.5n 0.4592 33000.0n 0.6177 33599.5n 0.6177 33600.0n 0.5849 34199.5n 0.5849 34200.0n 0.6550 34799.5n 0.6550 34800.0n 0.4562 35399.5n 0.4562 35400.0n 0.5855 35999.5n 0.5855)
Vyp_who_34_1 yp_who_34_1 0 PWL(0.0n 0.5071 599.5n 0.5071 600.0n 0.5053 1199.5n 0.5053 1200.0n 0.5052 1799.5n 0.5052 1800.0n 0.5027 2399.5n 0.5027 2400.0n 0.5034 2999.5n 0.5034 3000.0n 0.5055 3599.5n 0.5055 3600.0n 0.5056 4199.5n 0.5056 4200.0n 0.5071 4799.5n 0.5071 4800.0n 0.5056 5399.5n 0.5056 5400.0n 0.5056 5999.5n 0.5056 6000.0n 0.5048 6599.5n 0.5048 6600.0n 0.5060 7199.5n 0.5060 7200.0n 0.5048 7799.5n 0.5048 7800.0n 0.5046 8399.5n 0.5046 8400.0n 0.5066 8999.5n 0.5066 9000.0n 0.5056 9599.5n 0.5056 9600.0n 0.5051 10199.5n 0.5051 10200.0n 0.5046 10799.5n 0.5046 10800.0n 0.5056 11399.5n 0.5056 11400.0n 0.5058 11999.5n 0.5058 12000.0n 0.5068 12599.5n 0.5068 12600.0n 0.5050 13199.5n 0.5050 13200.0n 0.5071 13799.5n 0.5071 13800.0n 0.5059 14399.5n 0.5059 14400.0n 0.5058 14999.5n 0.5058 15000.0n 0.5043 15599.5n 0.5043 15600.0n 0.5067 16199.5n 0.5067 16200.0n 0.5068 16799.5n 0.5068 16800.0n 0.5066 17399.5n 0.5066 17400.0n 0.5069 17999.5n 0.5069 18000.0n 0.5061 18599.5n 0.5061 18600.0n 0.5034 19199.5n 0.5034 19200.0n 0.5010 19799.5n 0.5010 19800.0n 0.4989 20399.5n 0.4989 20400.0n 0.5022 20999.5n 0.5022 21000.0n 0.5086 21599.5n 0.5086 21600.0n 0.5007 22199.5n 0.5007 22200.0n 0.5023 22799.5n 0.5023 22800.0n 0.5021 23399.5n 0.5021 23400.0n 0.5077 23999.5n 0.5077 24000.0n 0.4979 24599.5n 0.4979 24600.0n 0.5035 25199.5n 0.5035 25200.0n 0.5041 25799.5n 0.5041 25800.0n 0.5075 26399.5n 0.5075 26400.0n 0.5041 26999.5n 0.5041 27000.0n 0.5056 27599.5n 0.5056 27600.0n 0.5039 28199.5n 0.5039 28200.0n 0.5059 28799.5n 0.5059 28800.0n 0.5023 29399.5n 0.5023 29400.0n 0.5086 29999.5n 0.5086 30000.0n 0.5084 30599.5n 0.5084 30600.0n 0.5085 31199.5n 0.5085 31200.0n 0.5088 31799.5n 0.5088 31800.0n 0.5078 32399.5n 0.5078 32400.0n 0.5074 32999.5n 0.5074 33000.0n 0.4996 33599.5n 0.4996 33600.0n 0.5010 34199.5n 0.5010 34200.0n 0.5044 34799.5n 0.5044 34800.0n 0.5084 35399.5n 0.5084 35400.0n 0.5012 35999.5n 0.5012)
Vyn_who_34_1 yn_who_34_1 0 PWL(0.0n 0.4929 599.5n 0.4929 600.0n 0.4947 1199.5n 0.4947 1200.0n 0.4948 1799.5n 0.4948 1800.0n 0.4973 2399.5n 0.4973 2400.0n 0.4966 2999.5n 0.4966 3000.0n 0.4945 3599.5n 0.4945 3600.0n 0.4944 4199.5n 0.4944 4200.0n 0.4929 4799.5n 0.4929 4800.0n 0.4944 5399.5n 0.4944 5400.0n 0.4944 5999.5n 0.4944 6000.0n 0.4952 6599.5n 0.4952 6600.0n 0.4940 7199.5n 0.4940 7200.0n 0.4952 7799.5n 0.4952 7800.0n 0.4954 8399.5n 0.4954 8400.0n 0.4934 8999.5n 0.4934 9000.0n 0.4944 9599.5n 0.4944 9600.0n 0.4949 10199.5n 0.4949 10200.0n 0.4954 10799.5n 0.4954 10800.0n 0.4944 11399.5n 0.4944 11400.0n 0.4942 11999.5n 0.4942 12000.0n 0.4932 12599.5n 0.4932 12600.0n 0.4950 13199.5n 0.4950 13200.0n 0.4929 13799.5n 0.4929 13800.0n 0.4941 14399.5n 0.4941 14400.0n 0.4942 14999.5n 0.4942 15000.0n 0.4957 15599.5n 0.4957 15600.0n 0.4933 16199.5n 0.4933 16200.0n 0.4932 16799.5n 0.4932 16800.0n 0.4934 17399.5n 0.4934 17400.0n 0.4931 17999.5n 0.4931 18000.0n 0.4939 18599.5n 0.4939 18600.0n 0.4966 19199.5n 0.4966 19200.0n 0.4990 19799.5n 0.4990 19800.0n 0.5011 20399.5n 0.5011 20400.0n 0.4978 20999.5n 0.4978 21000.0n 0.4914 21599.5n 0.4914 21600.0n 0.4993 22199.5n 0.4993 22200.0n 0.4977 22799.5n 0.4977 22800.0n 0.4979 23399.5n 0.4979 23400.0n 0.4923 23999.5n 0.4923 24000.0n 0.5021 24599.5n 0.5021 24600.0n 0.4965 25199.5n 0.4965 25200.0n 0.4959 25799.5n 0.4959 25800.0n 0.4925 26399.5n 0.4925 26400.0n 0.4959 26999.5n 0.4959 27000.0n 0.4944 27599.5n 0.4944 27600.0n 0.4961 28199.5n 0.4961 28200.0n 0.4941 28799.5n 0.4941 28800.0n 0.4977 29399.5n 0.4977 29400.0n 0.4914 29999.5n 0.4914 30000.0n 0.4916 30599.5n 0.4916 30600.0n 0.4915 31199.5n 0.4915 31200.0n 0.4912 31799.5n 0.4912 31800.0n 0.4922 32399.5n 0.4922 32400.0n 0.4926 32999.5n 0.4926 33000.0n 0.5004 33599.5n 0.5004 33600.0n 0.4990 34199.5n 0.4990 34200.0n 0.4956 34799.5n 0.4956 34800.0n 0.4916 35399.5n 0.4916 35400.0n 0.4988 35999.5n 0.4988)
Cwp_who_34_1 wp_who_34_1 0 400p
Cwn_who_34_1 wn_who_34_1 0 400p
Xu_who_34_1 xp_who_34_1 xn_who_34_1 yp_who_34_1 yn_who_34_1 wp_who_34_1 wn_who_34_1 vdd gbn gprod
Vxp_bh_34 xp_bh_34 0 PWL(0.0n 0.7100 599.5n 0.7100 600.0n 0.7100 1199.5n 0.7100 1200.0n 0.7100 1799.5n 0.7100 1800.0n 0.7100 2399.5n 0.7100 2400.0n 0.7100 2999.5n 0.7100 3000.0n 0.7100 3599.5n 0.7100 3600.0n 0.7100 4199.5n 0.7100 4200.0n 0.7100 4799.5n 0.7100 4800.0n 0.7100 5399.5n 0.7100 5400.0n 0.7100 5999.5n 0.7100 6000.0n 0.7100 6599.5n 0.7100 6600.0n 0.7100 7199.5n 0.7100 7200.0n 0.7100 7799.5n 0.7100 7800.0n 0.7100 8399.5n 0.7100 8400.0n 0.7100 8999.5n 0.7100 9000.0n 0.7100 9599.5n 0.7100 9600.0n 0.7100 10199.5n 0.7100 10200.0n 0.7100 10799.5n 0.7100 10800.0n 0.7100 11399.5n 0.7100 11400.0n 0.7100 11999.5n 0.7100 12000.0n 0.7100 12599.5n 0.7100 12600.0n 0.7100 13199.5n 0.7100 13200.0n 0.7100 13799.5n 0.7100 13800.0n 0.7100 14399.5n 0.7100 14400.0n 0.7100 14999.5n 0.7100 15000.0n 0.7100 15599.5n 0.7100 15600.0n 0.7100 16199.5n 0.7100 16200.0n 0.7100 16799.5n 0.7100 16800.0n 0.7100 17399.5n 0.7100 17400.0n 0.7100 17999.5n 0.7100 18000.0n 0.7100 18599.5n 0.7100 18600.0n 0.7100 19199.5n 0.7100 19200.0n 0.7100 19799.5n 0.7100 19800.0n 0.7100 20399.5n 0.7100 20400.0n 0.7100 20999.5n 0.7100 21000.0n 0.7100 21599.5n 0.7100 21600.0n 0.7100 22199.5n 0.7100 22200.0n 0.7100 22799.5n 0.7100 22800.0n 0.7100 23399.5n 0.7100 23400.0n 0.7100 23999.5n 0.7100 24000.0n 0.7100 24599.5n 0.7100 24600.0n 0.7100 25199.5n 0.7100 25200.0n 0.7100 25799.5n 0.7100 25800.0n 0.7100 26399.5n 0.7100 26400.0n 0.7100 26999.5n 0.7100 27000.0n 0.7100 27599.5n 0.7100 27600.0n 0.7100 28199.5n 0.7100 28200.0n 0.7100 28799.5n 0.7100 28800.0n 0.7100 29399.5n 0.7100 29400.0n 0.7100 29999.5n 0.7100 30000.0n 0.7100 30599.5n 0.7100 30600.0n 0.7100 31199.5n 0.7100 31200.0n 0.7100 31799.5n 0.7100 31800.0n 0.7100 32399.5n 0.7100 32400.0n 0.7100 32999.5n 0.7100 33000.0n 0.7100 33599.5n 0.7100 33600.0n 0.7100 34199.5n 0.7100 34200.0n 0.7100 34799.5n 0.7100 34800.0n 0.7100 35399.5n 0.7100 35400.0n 0.7100 35999.5n 0.7100)
Vxn_bh_34 xn_bh_34 0 PWL(0.0n 0.2900 599.5n 0.2900 600.0n 0.2900 1199.5n 0.2900 1200.0n 0.2900 1799.5n 0.2900 1800.0n 0.2900 2399.5n 0.2900 2400.0n 0.2900 2999.5n 0.2900 3000.0n 0.2900 3599.5n 0.2900 3600.0n 0.2900 4199.5n 0.2900 4200.0n 0.2900 4799.5n 0.2900 4800.0n 0.2900 5399.5n 0.2900 5400.0n 0.2900 5999.5n 0.2900 6000.0n 0.2900 6599.5n 0.2900 6600.0n 0.2900 7199.5n 0.2900 7200.0n 0.2900 7799.5n 0.2900 7800.0n 0.2900 8399.5n 0.2900 8400.0n 0.2900 8999.5n 0.2900 9000.0n 0.2900 9599.5n 0.2900 9600.0n 0.2900 10199.5n 0.2900 10200.0n 0.2900 10799.5n 0.2900 10800.0n 0.2900 11399.5n 0.2900 11400.0n 0.2900 11999.5n 0.2900 12000.0n 0.2900 12599.5n 0.2900 12600.0n 0.2900 13199.5n 0.2900 13200.0n 0.2900 13799.5n 0.2900 13800.0n 0.2900 14399.5n 0.2900 14400.0n 0.2900 14999.5n 0.2900 15000.0n 0.2900 15599.5n 0.2900 15600.0n 0.2900 16199.5n 0.2900 16200.0n 0.2900 16799.5n 0.2900 16800.0n 0.2900 17399.5n 0.2900 17400.0n 0.2900 17999.5n 0.2900 18000.0n 0.2900 18599.5n 0.2900 18600.0n 0.2900 19199.5n 0.2900 19200.0n 0.2900 19799.5n 0.2900 19800.0n 0.2900 20399.5n 0.2900 20400.0n 0.2900 20999.5n 0.2900 21000.0n 0.2900 21599.5n 0.2900 21600.0n 0.2900 22199.5n 0.2900 22200.0n 0.2900 22799.5n 0.2900 22800.0n 0.2900 23399.5n 0.2900 23400.0n 0.2900 23999.5n 0.2900 24000.0n 0.2900 24599.5n 0.2900 24600.0n 0.2900 25199.5n 0.2900 25200.0n 0.2900 25799.5n 0.2900 25800.0n 0.2900 26399.5n 0.2900 26400.0n 0.2900 26999.5n 0.2900 27000.0n 0.2900 27599.5n 0.2900 27600.0n 0.2900 28199.5n 0.2900 28200.0n 0.2900 28799.5n 0.2900 28800.0n 0.2900 29399.5n 0.2900 29400.0n 0.2900 29999.5n 0.2900 30000.0n 0.2900 30599.5n 0.2900 30600.0n 0.2900 31199.5n 0.2900 31200.0n 0.2900 31799.5n 0.2900 31800.0n 0.2900 32399.5n 0.2900 32400.0n 0.2900 32999.5n 0.2900 33000.0n 0.2900 33599.5n 0.2900 33600.0n 0.2900 34199.5n 0.2900 34200.0n 0.2900 34799.5n 0.2900 34800.0n 0.2900 35399.5n 0.2900 35400.0n 0.2900 35999.5n 0.2900)
Vyp_bh_34 yp_bh_34 0 PWL(0.0n 0.4317 599.5n 0.4317 600.0n 0.3791 1199.5n 0.3791 1200.0n 0.4502 1799.5n 0.4502 1800.0n 0.4148 2399.5n 0.4148 2400.0n 0.4045 2999.5n 0.4045 3000.0n 0.4171 3599.5n 0.4171 3600.0n 0.4504 4199.5n 0.4504 4200.0n 0.4369 4799.5n 0.4369 4800.0n 0.4306 5399.5n 0.4306 5400.0n 0.4296 5999.5n 0.4296 6000.0n 0.4470 6599.5n 0.4470 6600.0n 0.4372 7199.5n 0.4372 7200.0n 0.3870 7799.5n 0.3870 7800.0n 0.3847 8399.5n 0.3847 8400.0n 0.4556 8999.5n 0.4556 9000.0n 0.4298 9599.5n 0.4298 9600.0n 0.4202 10199.5n 0.4202 10200.0n 0.4002 10799.5n 0.4002 10800.0n 0.4610 11399.5n 0.4610 11400.0n 0.4319 11999.5n 0.4319 12000.0n 0.4638 12599.5n 0.4638 12600.0n 0.4181 13199.5n 0.4181 13200.0n 0.4254 13799.5n 0.4254 13800.0n 0.4042 14399.5n 0.4042 14400.0n 0.4291 14999.5n 0.4291 15000.0n 0.4083 15599.5n 0.4083 15600.0n 0.4402 16199.5n 0.4402 16200.0n 0.4114 16799.5n 0.4114 16800.0n 0.4603 17399.5n 0.4603 17400.0n 0.4217 17999.5n 0.4217 18000.0n 0.5016 18599.5n 0.5016 18600.0n 0.3466 19199.5n 0.3466 19200.0n 0.4075 19799.5n 0.4075 19800.0n 0.3449 20399.5n 0.3449 20400.0n 0.4449 20999.5n 0.4449 21000.0n 0.5359 21599.5n 0.5359 21600.0n 0.3451 22199.5n 0.3451 22200.0n 0.3420 22799.5n 0.3420 22800.0n 0.4487 23399.5n 0.4487 23400.0n 0.3662 23999.5n 0.3662 24000.0n 0.3495 24599.5n 0.3495 24600.0n 0.3422 25199.5n 0.3422 25200.0n 0.4776 25799.5n 0.4776 25800.0n 0.5432 26399.5n 0.5432 26400.0n 0.4875 26999.5n 0.4875 27000.0n 0.5025 27599.5n 0.5025 27600.0n 0.4834 28199.5n 0.4834 28200.0n 0.3487 28799.5n 0.3487 28800.0n 0.4509 29399.5n 0.4509 29400.0n 0.5348 29999.5n 0.5348 30000.0n 0.5361 30599.5n 0.5361 30600.0n 0.5232 31199.5n 0.5232 31200.0n 0.4694 31799.5n 0.4694 31800.0n 0.5463 32399.5n 0.5463 32400.0n 0.5408 32999.5n 0.5408 33000.0n 0.3823 33599.5n 0.3823 33600.0n 0.4151 34199.5n 0.4151 34200.0n 0.3450 34799.5n 0.3450 34800.0n 0.5438 35399.5n 0.5438 35400.0n 0.4145 35999.5n 0.4145)
Vyn_bh_34 yn_bh_34 0 PWL(0.0n 0.5683 599.5n 0.5683 600.0n 0.6209 1199.5n 0.6209 1200.0n 0.5498 1799.5n 0.5498 1800.0n 0.5852 2399.5n 0.5852 2400.0n 0.5955 2999.5n 0.5955 3000.0n 0.5829 3599.5n 0.5829 3600.0n 0.5496 4199.5n 0.5496 4200.0n 0.5631 4799.5n 0.5631 4800.0n 0.5694 5399.5n 0.5694 5400.0n 0.5704 5999.5n 0.5704 6000.0n 0.5530 6599.5n 0.5530 6600.0n 0.5628 7199.5n 0.5628 7200.0n 0.6130 7799.5n 0.6130 7800.0n 0.6153 8399.5n 0.6153 8400.0n 0.5444 8999.5n 0.5444 9000.0n 0.5702 9599.5n 0.5702 9600.0n 0.5798 10199.5n 0.5798 10200.0n 0.5998 10799.5n 0.5998 10800.0n 0.5390 11399.5n 0.5390 11400.0n 0.5681 11999.5n 0.5681 12000.0n 0.5362 12599.5n 0.5362 12600.0n 0.5819 13199.5n 0.5819 13200.0n 0.5746 13799.5n 0.5746 13800.0n 0.5958 14399.5n 0.5958 14400.0n 0.5709 14999.5n 0.5709 15000.0n 0.5917 15599.5n 0.5917 15600.0n 0.5598 16199.5n 0.5598 16200.0n 0.5886 16799.5n 0.5886 16800.0n 0.5397 17399.5n 0.5397 17400.0n 0.5783 17999.5n 0.5783 18000.0n 0.4984 18599.5n 0.4984 18600.0n 0.6534 19199.5n 0.6534 19200.0n 0.5925 19799.5n 0.5925 19800.0n 0.6551 20399.5n 0.6551 20400.0n 0.5551 20999.5n 0.5551 21000.0n 0.4641 21599.5n 0.4641 21600.0n 0.6549 22199.5n 0.6549 22200.0n 0.6580 22799.5n 0.6580 22800.0n 0.5513 23399.5n 0.5513 23400.0n 0.6338 23999.5n 0.6338 24000.0n 0.6505 24599.5n 0.6505 24600.0n 0.6578 25199.5n 0.6578 25200.0n 0.5224 25799.5n 0.5224 25800.0n 0.4568 26399.5n 0.4568 26400.0n 0.5125 26999.5n 0.5125 27000.0n 0.4975 27599.5n 0.4975 27600.0n 0.5166 28199.5n 0.5166 28200.0n 0.6513 28799.5n 0.6513 28800.0n 0.5491 29399.5n 0.5491 29400.0n 0.4652 29999.5n 0.4652 30000.0n 0.4639 30599.5n 0.4639 30600.0n 0.4768 31199.5n 0.4768 31200.0n 0.5306 31799.5n 0.5306 31800.0n 0.4537 32399.5n 0.4537 32400.0n 0.4592 32999.5n 0.4592 33000.0n 0.6177 33599.5n 0.6177 33600.0n 0.5849 34199.5n 0.5849 34200.0n 0.6550 34799.5n 0.6550 34800.0n 0.4562 35399.5n 0.4562 35400.0n 0.5855 35999.5n 0.5855)
Cwp_bh_34 wp_bh_34 0 400p
Cwn_bh_34 wn_bh_34 0 400p
Xu_bh_34 xp_bh_34 xn_bh_34 yp_bh_34 yn_bh_34 wp_bh_34 wn_bh_34 vdd gbn gprod
Vxp_wih_0_35 xp_wih_0_35 0 PWL(0.0n 0.4942 599.5n 0.4942 600.0n 0.5558 1199.5n 0.5558 1200.0n 0.4708 1799.5n 0.4708 1800.0n 0.5235 2399.5n 0.5235 2400.0n 0.5350 2999.5n 0.5350 3000.0n 0.5172 3599.5n 0.5172 3600.0n 0.4702 4199.5n 0.4702 4200.0n 0.4867 4799.5n 0.4867 4800.0n 0.4970 5399.5n 0.4970 5400.0n 0.4986 5999.5n 0.4986 6000.0n 0.4751 6599.5n 0.4751 6600.0n 0.4870 7199.5n 0.4870 7200.0n 0.5502 7799.5n 0.5502 7800.0n 0.5521 8399.5n 0.5521 8400.0n 0.4638 8999.5n 0.4638 9000.0n 0.4982 9599.5n 0.4982 9600.0n 0.5131 10199.5n 0.5131 10200.0n 0.5386 10799.5n 0.5386 10800.0n 0.4592 11399.5n 0.4592 11400.0n 0.4950 11999.5n 0.4950 12000.0n 0.4559 12599.5n 0.4559 12600.0n 0.5162 13199.5n 0.5162 13200.0n 0.5038 13799.5n 0.5038 13800.0n 0.5333 14399.5n 0.5333 14400.0n 0.4991 14999.5n 0.4991 15000.0n 0.5298 15599.5n 0.5298 15600.0n 0.4823 16199.5n 0.4823 16200.0n 0.5239 16799.5n 0.5239 16800.0n 0.4592 17399.5n 0.4592 17400.0n 0.5094 17999.5n 0.5094 18000.0n 0.4337 18599.5n 0.4337 18600.0n 0.5977 19199.5n 0.5977 19200.0n 0.5364 19799.5n 0.5364 19800.0n 0.6122 20399.5n 0.6122 20400.0n 0.4856 20999.5n 0.4856 21000.0n 0.3861 21599.5n 0.3861 21600.0n 0.6094 22199.5n 0.6094 22200.0n 0.6364 22799.5n 0.6364 22800.0n 0.4807 23399.5n 0.4807 23400.0n 0.5614 23999.5n 0.5614 24000.0n 0.5913 24599.5n 0.5913 24600.0n 0.6295 25199.5n 0.6295 25200.0n 0.4496 25799.5n 0.4496 25800.0n 0.3792 26399.5n 0.3792 26400.0n 0.4434 26999.5n 0.4434 27000.0n 0.4340 27599.5n 0.4340 27600.0n 0.4461 28199.5n 0.4461 28200.0n 0.5791 28799.5n 0.5791 28800.0n 0.4777 29399.5n 0.4777 29400.0n 0.3878 29999.5n 0.3878 30000.0n 0.3832 30599.5n 0.3832 30600.0n 0.4022 31199.5n 0.4022 31200.0n 0.4482 31799.5n 0.4482 31800.0n 0.3662 32399.5n 0.3662 32400.0n 0.3857 32999.5n 0.3857 33000.0n 0.5584 33599.5n 0.5584 33600.0n 0.5284 34199.5n 0.5284 34200.0n 0.6034 34799.5n 0.6034 34800.0n 0.3469 35399.5n 0.3469 35400.0n 0.5290 35999.5n 0.5290)
Vxn_wih_0_35 xn_wih_0_35 0 PWL(0.0n 0.5058 599.5n 0.5058 600.0n 0.4442 1199.5n 0.4442 1200.0n 0.5292 1799.5n 0.5292 1800.0n 0.4765 2399.5n 0.4765 2400.0n 0.4650 2999.5n 0.4650 3000.0n 0.4828 3599.5n 0.4828 3600.0n 0.5298 4199.5n 0.5298 4200.0n 0.5133 4799.5n 0.5133 4800.0n 0.5030 5399.5n 0.5030 5400.0n 0.5014 5999.5n 0.5014 6000.0n 0.5249 6599.5n 0.5249 6600.0n 0.5130 7199.5n 0.5130 7200.0n 0.4498 7799.5n 0.4498 7800.0n 0.4479 8399.5n 0.4479 8400.0n 0.5362 8999.5n 0.5362 9000.0n 0.5018 9599.5n 0.5018 9600.0n 0.4869 10199.5n 0.4869 10200.0n 0.4614 10799.5n 0.4614 10800.0n 0.5408 11399.5n 0.5408 11400.0n 0.5050 11999.5n 0.5050 12000.0n 0.5441 12599.5n 0.5441 12600.0n 0.4838 13199.5n 0.4838 13200.0n 0.4962 13799.5n 0.4962 13800.0n 0.4667 14399.5n 0.4667 14400.0n 0.5009 14999.5n 0.5009 15000.0n 0.4702 15599.5n 0.4702 15600.0n 0.5177 16199.5n 0.5177 16200.0n 0.4761 16799.5n 0.4761 16800.0n 0.5408 17399.5n 0.5408 17400.0n 0.4906 17999.5n 0.4906 18000.0n 0.5663 18599.5n 0.5663 18600.0n 0.4023 19199.5n 0.4023 19200.0n 0.4636 19799.5n 0.4636 19800.0n 0.3878 20399.5n 0.3878 20400.0n 0.5144 20999.5n 0.5144 21000.0n 0.6139 21599.5n 0.6139 21600.0n 0.3906 22199.5n 0.3906 22200.0n 0.3636 22799.5n 0.3636 22800.0n 0.5193 23399.5n 0.5193 23400.0n 0.4386 23999.5n 0.4386 24000.0n 0.4087 24599.5n 0.4087 24600.0n 0.3705 25199.5n 0.3705 25200.0n 0.5504 25799.5n 0.5504 25800.0n 0.6208 26399.5n 0.6208 26400.0n 0.5566 26999.5n 0.5566 27000.0n 0.5660 27599.5n 0.5660 27600.0n 0.5539 28199.5n 0.5539 28200.0n 0.4209 28799.5n 0.4209 28800.0n 0.5223 29399.5n 0.5223 29400.0n 0.6122 29999.5n 0.6122 30000.0n 0.6168 30599.5n 0.6168 30600.0n 0.5978 31199.5n 0.5978 31200.0n 0.5518 31799.5n 0.5518 31800.0n 0.6338 32399.5n 0.6338 32400.0n 0.6143 32999.5n 0.6143 33000.0n 0.4416 33599.5n 0.4416 33600.0n 0.4716 34199.5n 0.4716 34200.0n 0.3966 34799.5n 0.3966 34800.0n 0.6531 35399.5n 0.6531 35400.0n 0.4710 35999.5n 0.4710)
Vyp_wih_0_35 yp_wih_0_35 0 PWL(0.0n 0.5745 599.5n 0.5745 600.0n 0.5559 1199.5n 0.5559 1200.0n 0.5062 1799.5n 0.5062 1800.0n 0.4554 2399.5n 0.4554 2400.0n 0.4796 2999.5n 0.4796 3000.0n 0.5390 3599.5n 0.5390 3600.0n 0.5220 4199.5n 0.5220 4200.0n 0.5760 4799.5n 0.5760 4800.0n 0.5338 5399.5n 0.5338 5400.0n 0.5331 5999.5n 0.5331 6000.0n 0.4952 6599.5n 0.4952 6600.0n 0.5429 7199.5n 0.5429 7200.0n 0.5379 7799.5n 0.5379 7800.0n 0.5324 8399.5n 0.5324 8400.0n 0.5623 8999.5n 0.5623 9000.0n 0.5338 9599.5n 0.5338 9600.0n 0.5216 10199.5n 0.5216 10200.0n 0.5185 10799.5n 0.5185 10800.0n 0.5083 11399.5n 0.5083 11400.0n 0.5388 11999.5n 0.5388 12000.0n 0.5687 12599.5n 0.5687 12600.0n 0.5192 13199.5n 0.5192 13200.0n 0.5771 13799.5n 0.5771 13800.0n 0.5588 14399.5n 0.5588 14400.0n 0.5415 14999.5n 0.5415 15000.0n 0.5015 15599.5n 0.5015 15600.0n 0.5622 16199.5n 0.5622 16200.0n 0.5772 16799.5n 0.5772 16800.0n 0.5588 17399.5n 0.5588 17400.0n 0.5721 17999.5n 0.5721 18000.0n 0.4123 18599.5n 0.4123 18600.0n 0.5587 19199.5n 0.5587 19200.0n 0.4030 19799.5n 0.4030 19800.0n 0.4417 20399.5n 0.4417 20400.0n 0.3930 20999.5n 0.3930 21000.0n 0.4847 21599.5n 0.4847 21600.0n 0.4874 22199.5n 0.4874 22200.0n 0.5501 22799.5n 0.5501 22800.0n 0.3733 23399.5n 0.3733 23400.0n 0.6593 23999.5n 0.6593 24000.0n 0.4015 24599.5n 0.4015 24600.0n 0.5736 25199.5n 0.5736 25200.0n 0.3974 25799.5n 0.3974 25800.0n 0.3820 26399.5n 0.3820 26400.0n 0.3756 26999.5n 0.3756 27000.0n 0.3962 27599.5n 0.3962 27600.0n 0.3758 28199.5n 0.3758 28200.0n 0.6548 28799.5n 0.6548 28800.0n 0.3838 29399.5n 0.3838 29400.0n 0.5007 29999.5n 0.5007 30000.0n 0.5290 30599.5n 0.5290 30600.0n 0.6518 31199.5n 0.6518 31200.0n 0.6520 31799.5n 0.6520 31800.0n 0.3922 32399.5n 0.3922 32400.0n 0.3794 32999.5n 0.3794 33000.0n 0.3966 33599.5n 0.3966 33600.0n 0.3821 34199.5n 0.3821 34200.0n 0.5964 34799.5n 0.5964 34800.0n 0.5812 35399.5n 0.5812 35400.0n 0.3952 35999.5n 0.3952)
Vyn_wih_0_35 yn_wih_0_35 0 PWL(0.0n 0.4255 599.5n 0.4255 600.0n 0.4441 1199.5n 0.4441 1200.0n 0.4938 1799.5n 0.4938 1800.0n 0.5446 2399.5n 0.5446 2400.0n 0.5204 2999.5n 0.5204 3000.0n 0.4610 3599.5n 0.4610 3600.0n 0.4780 4199.5n 0.4780 4200.0n 0.4240 4799.5n 0.4240 4800.0n 0.4662 5399.5n 0.4662 5400.0n 0.4669 5999.5n 0.4669 6000.0n 0.5048 6599.5n 0.5048 6600.0n 0.4571 7199.5n 0.4571 7200.0n 0.4621 7799.5n 0.4621 7800.0n 0.4676 8399.5n 0.4676 8400.0n 0.4377 8999.5n 0.4377 9000.0n 0.4662 9599.5n 0.4662 9600.0n 0.4784 10199.5n 0.4784 10200.0n 0.4815 10799.5n 0.4815 10800.0n 0.4917 11399.5n 0.4917 11400.0n 0.4612 11999.5n 0.4612 12000.0n 0.4313 12599.5n 0.4313 12600.0n 0.4808 13199.5n 0.4808 13200.0n 0.4229 13799.5n 0.4229 13800.0n 0.4412 14399.5n 0.4412 14400.0n 0.4585 14999.5n 0.4585 15000.0n 0.4985 15599.5n 0.4985 15600.0n 0.4378 16199.5n 0.4378 16200.0n 0.4228 16799.5n 0.4228 16800.0n 0.4412 17399.5n 0.4412 17400.0n 0.4279 17999.5n 0.4279 18000.0n 0.5877 18599.5n 0.5877 18600.0n 0.4413 19199.5n 0.4413 19200.0n 0.5970 19799.5n 0.5970 19800.0n 0.5583 20399.5n 0.5583 20400.0n 0.6070 20999.5n 0.6070 21000.0n 0.5153 21599.5n 0.5153 21600.0n 0.5126 22199.5n 0.5126 22200.0n 0.4499 22799.5n 0.4499 22800.0n 0.6267 23399.5n 0.6267 23400.0n 0.3407 23999.5n 0.3407 24000.0n 0.5985 24599.5n 0.5985 24600.0n 0.4264 25199.5n 0.4264 25200.0n 0.6026 25799.5n 0.6026 25800.0n 0.6180 26399.5n 0.6180 26400.0n 0.6244 26999.5n 0.6244 27000.0n 0.6038 27599.5n 0.6038 27600.0n 0.6242 28199.5n 0.6242 28200.0n 0.3452 28799.5n 0.3452 28800.0n 0.6162 29399.5n 0.6162 29400.0n 0.4993 29999.5n 0.4993 30000.0n 0.4710 30599.5n 0.4710 30600.0n 0.3482 31199.5n 0.3482 31200.0n 0.3480 31799.5n 0.3480 31800.0n 0.6078 32399.5n 0.6078 32400.0n 0.6206 32999.5n 0.6206 33000.0n 0.6034 33599.5n 0.6034 33600.0n 0.6179 34199.5n 0.6179 34200.0n 0.4036 34799.5n 0.4036 34800.0n 0.4188 35399.5n 0.4188 35400.0n 0.6048 35999.5n 0.6048)
Cwp_wih_0_35 wp_wih_0_35 0 400p
Cwn_wih_0_35 wn_wih_0_35 0 400p
Xu_wih_0_35 xp_wih_0_35 xn_wih_0_35 yp_wih_0_35 yn_wih_0_35 wp_wih_0_35 wn_wih_0_35 vdd gbn gprod
Vxp_wih_1_35 xp_wih_1_35 0 PWL(0.0n 0.5370 599.5n 0.5370 600.0n 0.5167 1199.5n 0.5167 1200.0n 0.4793 1799.5n 0.4793 1800.0n 0.4441 2399.5n 0.4441 2400.0n 0.4555 2999.5n 0.4555 3000.0n 0.5055 3599.5n 0.5055 3600.0n 0.4939 4199.5n 0.4939 4200.0n 0.5385 4799.5n 0.5385 4800.0n 0.5024 5399.5n 0.5024 5400.0n 0.5015 5999.5n 0.5015 6000.0n 0.4700 6599.5n 0.4700 6600.0n 0.5120 7199.5n 0.5120 7200.0n 0.5006 7799.5n 0.5006 7800.0n 0.4950 8399.5n 0.4950 8400.0n 0.5309 8999.5n 0.5309 9000.0n 0.5023 9599.5n 0.5023 9600.0n 0.4893 10199.5n 0.4893 10200.0n 0.4837 10799.5n 0.4837 10800.0n 0.4823 11399.5n 0.4823 11400.0n 0.5074 11999.5n 0.5074 12000.0n 0.5364 12599.5n 0.5364 12600.0n 0.4868 13199.5n 0.4868 13200.0n 0.5380 13799.5n 0.5380 13800.0n 0.5220 14399.5n 0.5220 14400.0n 0.5095 14999.5n 0.5095 15000.0n 0.4705 15599.5n 0.4705 15600.0n 0.5289 16199.5n 0.5289 16200.0n 0.5368 16799.5n 0.5368 16800.0n 0.5287 17399.5n 0.5287 17400.0n 0.5342 17999.5n 0.5342 18000.0n 0.4253 18599.5n 0.4253 18600.0n 0.5119 19199.5n 0.5119 19200.0n 0.4104 19799.5n 0.4104 19800.0n 0.4314 20399.5n 0.4314 20400.0n 0.4005 20999.5n 0.4005 21000.0n 0.4696 21599.5n 0.4696 21600.0n 0.4531 22199.5n 0.4531 22200.0n 0.5039 22799.5n 0.5039 22800.0n 0.3608 23399.5n 0.3608 23400.0n 0.6273 23999.5n 0.6273 24000.0n 0.3928 24599.5n 0.3928 24600.0n 0.5253 25199.5n 0.5253 25200.0n 0.4107 25799.5n 0.4107 25800.0n 0.3947 26399.5n 0.3947 26400.0n 0.3716 26999.5n 0.3716 27000.0n 0.4111 27599.5n 0.4111 27600.0n 0.3715 28199.5n 0.3715 28200.0n 0.5939 28799.5n 0.5939 28800.0n 0.3849 29399.5n 0.3849 29400.0n 0.4835 29999.5n 0.4835 30000.0n 0.5119 30599.5n 0.5119 30600.0n 0.6226 31199.5n 0.6226 31200.0n 0.6064 31799.5n 0.6064 31800.0n 0.4115 32399.5n 0.4115 32400.0n 0.3900 32999.5n 0.3900 33000.0n 0.3958 33599.5n 0.3958 33600.0n 0.3747 34199.5n 0.3747 34200.0n 0.5423 34799.5n 0.5423 34800.0n 0.5509 35399.5n 0.5509 35400.0n 0.3990 35999.5n 0.3990)
Vxn_wih_1_35 xn_wih_1_35 0 PWL(0.0n 0.4630 599.5n 0.4630 600.0n 0.4833 1199.5n 0.4833 1200.0n 0.5207 1799.5n 0.5207 1800.0n 0.5559 2399.5n 0.5559 2400.0n 0.5445 2999.5n 0.5445 3000.0n 0.4945 3599.5n 0.4945 3600.0n 0.5061 4199.5n 0.5061 4200.0n 0.4615 4799.5n 0.4615 4800.0n 0.4976 5399.5n 0.4976 5400.0n 0.4985 5999.5n 0.4985 6000.0n 0.5300 6599.5n 0.5300 6600.0n 0.4880 7199.5n 0.4880 7200.0n 0.4994 7799.5n 0.4994 7800.0n 0.5050 8399.5n 0.5050 8400.0n 0.4691 8999.5n 0.4691 9000.0n 0.4977 9599.5n 0.4977 9600.0n 0.5107 10199.5n 0.5107 10200.0n 0.5163 10799.5n 0.5163 10800.0n 0.5177 11399.5n 0.5177 11400.0n 0.4926 11999.5n 0.4926 12000.0n 0.4636 12599.5n 0.4636 12600.0n 0.5132 13199.5n 0.5132 13200.0n 0.4620 13799.5n 0.4620 13800.0n 0.4780 14399.5n 0.4780 14400.0n 0.4905 14999.5n 0.4905 15000.0n 0.5295 15599.5n 0.5295 15600.0n 0.4711 16199.5n 0.4711 16200.0n 0.4632 16799.5n 0.4632 16800.0n 0.4713 17399.5n 0.4713 17400.0n 0.4658 17999.5n 0.4658 18000.0n 0.5747 18599.5n 0.5747 18600.0n 0.4881 19199.5n 0.4881 19200.0n 0.5896 19799.5n 0.5896 19800.0n 0.5686 20399.5n 0.5686 20400.0n 0.5995 20999.5n 0.5995 21000.0n 0.5304 21599.5n 0.5304 21600.0n 0.5469 22199.5n 0.5469 22200.0n 0.4961 22799.5n 0.4961 22800.0n 0.6392 23399.5n 0.6392 23400.0n 0.3727 23999.5n 0.3727 24000.0n 0.6072 24599.5n 0.6072 24600.0n 0.4747 25199.5n 0.4747 25200.0n 0.5893 25799.5n 0.5893 25800.0n 0.6053 26399.5n 0.6053 26400.0n 0.6284 26999.5n 0.6284 27000.0n 0.5889 27599.5n 0.5889 27600.0n 0.6285 28199.5n 0.6285 28200.0n 0.4061 28799.5n 0.4061 28800.0n 0.6151 29399.5n 0.6151 29400.0n 0.5165 29999.5n 0.5165 30000.0n 0.4881 30599.5n 0.4881 30600.0n 0.3774 31199.5n 0.3774 31200.0n 0.3936 31799.5n 0.3936 31800.0n 0.5885 32399.5n 0.5885 32400.0n 0.6100 32999.5n 0.6100 33000.0n 0.6042 33599.5n 0.6042 33600.0n 0.6253 34199.5n 0.6253 34200.0n 0.4577 34799.5n 0.4577 34800.0n 0.4491 35399.5n 0.4491 35400.0n 0.6010 35999.5n 0.6010)
Vyp_wih_1_35 yp_wih_1_35 0 PWL(0.0n 0.5745 599.5n 0.5745 600.0n 0.5559 1199.5n 0.5559 1200.0n 0.5062 1799.5n 0.5062 1800.0n 0.4554 2399.5n 0.4554 2400.0n 0.4796 2999.5n 0.4796 3000.0n 0.5390 3599.5n 0.5390 3600.0n 0.5220 4199.5n 0.5220 4200.0n 0.5760 4799.5n 0.5760 4800.0n 0.5338 5399.5n 0.5338 5400.0n 0.5331 5999.5n 0.5331 6000.0n 0.4952 6599.5n 0.4952 6600.0n 0.5429 7199.5n 0.5429 7200.0n 0.5379 7799.5n 0.5379 7800.0n 0.5324 8399.5n 0.5324 8400.0n 0.5623 8999.5n 0.5623 9000.0n 0.5338 9599.5n 0.5338 9600.0n 0.5216 10199.5n 0.5216 10200.0n 0.5185 10799.5n 0.5185 10800.0n 0.5083 11399.5n 0.5083 11400.0n 0.5388 11999.5n 0.5388 12000.0n 0.5687 12599.5n 0.5687 12600.0n 0.5192 13199.5n 0.5192 13200.0n 0.5771 13799.5n 0.5771 13800.0n 0.5588 14399.5n 0.5588 14400.0n 0.5415 14999.5n 0.5415 15000.0n 0.5015 15599.5n 0.5015 15600.0n 0.5622 16199.5n 0.5622 16200.0n 0.5772 16799.5n 0.5772 16800.0n 0.5588 17399.5n 0.5588 17400.0n 0.5721 17999.5n 0.5721 18000.0n 0.4123 18599.5n 0.4123 18600.0n 0.5587 19199.5n 0.5587 19200.0n 0.4030 19799.5n 0.4030 19800.0n 0.4417 20399.5n 0.4417 20400.0n 0.3930 20999.5n 0.3930 21000.0n 0.4847 21599.5n 0.4847 21600.0n 0.4874 22199.5n 0.4874 22200.0n 0.5501 22799.5n 0.5501 22800.0n 0.3733 23399.5n 0.3733 23400.0n 0.6593 23999.5n 0.6593 24000.0n 0.4015 24599.5n 0.4015 24600.0n 0.5736 25199.5n 0.5736 25200.0n 0.3974 25799.5n 0.3974 25800.0n 0.3820 26399.5n 0.3820 26400.0n 0.3756 26999.5n 0.3756 27000.0n 0.3962 27599.5n 0.3962 27600.0n 0.3758 28199.5n 0.3758 28200.0n 0.6548 28799.5n 0.6548 28800.0n 0.3838 29399.5n 0.3838 29400.0n 0.5007 29999.5n 0.5007 30000.0n 0.5290 30599.5n 0.5290 30600.0n 0.6518 31199.5n 0.6518 31200.0n 0.6520 31799.5n 0.6520 31800.0n 0.3922 32399.5n 0.3922 32400.0n 0.3794 32999.5n 0.3794 33000.0n 0.3966 33599.5n 0.3966 33600.0n 0.3821 34199.5n 0.3821 34200.0n 0.5964 34799.5n 0.5964 34800.0n 0.5812 35399.5n 0.5812 35400.0n 0.3952 35999.5n 0.3952)
Vyn_wih_1_35 yn_wih_1_35 0 PWL(0.0n 0.4255 599.5n 0.4255 600.0n 0.4441 1199.5n 0.4441 1200.0n 0.4938 1799.5n 0.4938 1800.0n 0.5446 2399.5n 0.5446 2400.0n 0.5204 2999.5n 0.5204 3000.0n 0.4610 3599.5n 0.4610 3600.0n 0.4780 4199.5n 0.4780 4200.0n 0.4240 4799.5n 0.4240 4800.0n 0.4662 5399.5n 0.4662 5400.0n 0.4669 5999.5n 0.4669 6000.0n 0.5048 6599.5n 0.5048 6600.0n 0.4571 7199.5n 0.4571 7200.0n 0.4621 7799.5n 0.4621 7800.0n 0.4676 8399.5n 0.4676 8400.0n 0.4377 8999.5n 0.4377 9000.0n 0.4662 9599.5n 0.4662 9600.0n 0.4784 10199.5n 0.4784 10200.0n 0.4815 10799.5n 0.4815 10800.0n 0.4917 11399.5n 0.4917 11400.0n 0.4612 11999.5n 0.4612 12000.0n 0.4313 12599.5n 0.4313 12600.0n 0.4808 13199.5n 0.4808 13200.0n 0.4229 13799.5n 0.4229 13800.0n 0.4412 14399.5n 0.4412 14400.0n 0.4585 14999.5n 0.4585 15000.0n 0.4985 15599.5n 0.4985 15600.0n 0.4378 16199.5n 0.4378 16200.0n 0.4228 16799.5n 0.4228 16800.0n 0.4412 17399.5n 0.4412 17400.0n 0.4279 17999.5n 0.4279 18000.0n 0.5877 18599.5n 0.5877 18600.0n 0.4413 19199.5n 0.4413 19200.0n 0.5970 19799.5n 0.5970 19800.0n 0.5583 20399.5n 0.5583 20400.0n 0.6070 20999.5n 0.6070 21000.0n 0.5153 21599.5n 0.5153 21600.0n 0.5126 22199.5n 0.5126 22200.0n 0.4499 22799.5n 0.4499 22800.0n 0.6267 23399.5n 0.6267 23400.0n 0.3407 23999.5n 0.3407 24000.0n 0.5985 24599.5n 0.5985 24600.0n 0.4264 25199.5n 0.4264 25200.0n 0.6026 25799.5n 0.6026 25800.0n 0.6180 26399.5n 0.6180 26400.0n 0.6244 26999.5n 0.6244 27000.0n 0.6038 27599.5n 0.6038 27600.0n 0.6242 28199.5n 0.6242 28200.0n 0.3452 28799.5n 0.3452 28800.0n 0.6162 29399.5n 0.6162 29400.0n 0.4993 29999.5n 0.4993 30000.0n 0.4710 30599.5n 0.4710 30600.0n 0.3482 31199.5n 0.3482 31200.0n 0.3480 31799.5n 0.3480 31800.0n 0.6078 32399.5n 0.6078 32400.0n 0.6206 32999.5n 0.6206 33000.0n 0.6034 33599.5n 0.6034 33600.0n 0.6179 34199.5n 0.6179 34200.0n 0.4036 34799.5n 0.4036 34800.0n 0.4188 35399.5n 0.4188 35400.0n 0.6048 35999.5n 0.6048)
Cwp_wih_1_35 wp_wih_1_35 0 400p
Cwn_wih_1_35 wn_wih_1_35 0 400p
Xu_wih_1_35 xp_wih_1_35 xn_wih_1_35 yp_wih_1_35 yn_wih_1_35 wp_wih_1_35 wn_wih_1_35 vdd gbn gprod
Vxp_who_35_0 xp_who_35_0 0 PWL(0.0n 0.5745 599.5n 0.5745 600.0n 0.5559 1199.5n 0.5559 1200.0n 0.5062 1799.5n 0.5062 1800.0n 0.4554 2399.5n 0.4554 2400.0n 0.4796 2999.5n 0.4796 3000.0n 0.5390 3599.5n 0.5390 3600.0n 0.5220 4199.5n 0.5220 4200.0n 0.5760 4799.5n 0.5760 4800.0n 0.5338 5399.5n 0.5338 5400.0n 0.5331 5999.5n 0.5331 6000.0n 0.4952 6599.5n 0.4952 6600.0n 0.5429 7199.5n 0.5429 7200.0n 0.5379 7799.5n 0.5379 7800.0n 0.5324 8399.5n 0.5324 8400.0n 0.5623 8999.5n 0.5623 9000.0n 0.5338 9599.5n 0.5338 9600.0n 0.5216 10199.5n 0.5216 10200.0n 0.5185 10799.5n 0.5185 10800.0n 0.5083 11399.5n 0.5083 11400.0n 0.5388 11999.5n 0.5388 12000.0n 0.5687 12599.5n 0.5687 12600.0n 0.5192 13199.5n 0.5192 13200.0n 0.5771 13799.5n 0.5771 13800.0n 0.5588 14399.5n 0.5588 14400.0n 0.5415 14999.5n 0.5415 15000.0n 0.5015 15599.5n 0.5015 15600.0n 0.5622 16199.5n 0.5622 16200.0n 0.5772 16799.5n 0.5772 16800.0n 0.5588 17399.5n 0.5588 17400.0n 0.5721 17999.5n 0.5721 18000.0n 0.4123 18599.5n 0.4123 18600.0n 0.5587 19199.5n 0.5587 19200.0n 0.4030 19799.5n 0.4030 19800.0n 0.4417 20399.5n 0.4417 20400.0n 0.3930 20999.5n 0.3930 21000.0n 0.4847 21599.5n 0.4847 21600.0n 0.4874 22199.5n 0.4874 22200.0n 0.5501 22799.5n 0.5501 22800.0n 0.3733 23399.5n 0.3733 23400.0n 0.6593 23999.5n 0.6593 24000.0n 0.4015 24599.5n 0.4015 24600.0n 0.5736 25199.5n 0.5736 25200.0n 0.3974 25799.5n 0.3974 25800.0n 0.3820 26399.5n 0.3820 26400.0n 0.3756 26999.5n 0.3756 27000.0n 0.3962 27599.5n 0.3962 27600.0n 0.3758 28199.5n 0.3758 28200.0n 0.6548 28799.5n 0.6548 28800.0n 0.3838 29399.5n 0.3838 29400.0n 0.5007 29999.5n 0.5007 30000.0n 0.5290 30599.5n 0.5290 30600.0n 0.6518 31199.5n 0.6518 31200.0n 0.6520 31799.5n 0.6520 31800.0n 0.3922 32399.5n 0.3922 32400.0n 0.3794 32999.5n 0.3794 33000.0n 0.3966 33599.5n 0.3966 33600.0n 0.3821 34199.5n 0.3821 34200.0n 0.5964 34799.5n 0.5964 34800.0n 0.5812 35399.5n 0.5812 35400.0n 0.3952 35999.5n 0.3952)
Vxn_who_35_0 xn_who_35_0 0 PWL(0.0n 0.4255 599.5n 0.4255 600.0n 0.4441 1199.5n 0.4441 1200.0n 0.4938 1799.5n 0.4938 1800.0n 0.5446 2399.5n 0.5446 2400.0n 0.5204 2999.5n 0.5204 3000.0n 0.4610 3599.5n 0.4610 3600.0n 0.4780 4199.5n 0.4780 4200.0n 0.4240 4799.5n 0.4240 4800.0n 0.4662 5399.5n 0.4662 5400.0n 0.4669 5999.5n 0.4669 6000.0n 0.5048 6599.5n 0.5048 6600.0n 0.4571 7199.5n 0.4571 7200.0n 0.4621 7799.5n 0.4621 7800.0n 0.4676 8399.5n 0.4676 8400.0n 0.4377 8999.5n 0.4377 9000.0n 0.4662 9599.5n 0.4662 9600.0n 0.4784 10199.5n 0.4784 10200.0n 0.4815 10799.5n 0.4815 10800.0n 0.4917 11399.5n 0.4917 11400.0n 0.4612 11999.5n 0.4612 12000.0n 0.4313 12599.5n 0.4313 12600.0n 0.4808 13199.5n 0.4808 13200.0n 0.4229 13799.5n 0.4229 13800.0n 0.4412 14399.5n 0.4412 14400.0n 0.4585 14999.5n 0.4585 15000.0n 0.4985 15599.5n 0.4985 15600.0n 0.4378 16199.5n 0.4378 16200.0n 0.4228 16799.5n 0.4228 16800.0n 0.4412 17399.5n 0.4412 17400.0n 0.4279 17999.5n 0.4279 18000.0n 0.5877 18599.5n 0.5877 18600.0n 0.4413 19199.5n 0.4413 19200.0n 0.5970 19799.5n 0.5970 19800.0n 0.5583 20399.5n 0.5583 20400.0n 0.6070 20999.5n 0.6070 21000.0n 0.5153 21599.5n 0.5153 21600.0n 0.5126 22199.5n 0.5126 22200.0n 0.4499 22799.5n 0.4499 22800.0n 0.6267 23399.5n 0.6267 23400.0n 0.3407 23999.5n 0.3407 24000.0n 0.5985 24599.5n 0.5985 24600.0n 0.4264 25199.5n 0.4264 25200.0n 0.6026 25799.5n 0.6026 25800.0n 0.6180 26399.5n 0.6180 26400.0n 0.6244 26999.5n 0.6244 27000.0n 0.6038 27599.5n 0.6038 27600.0n 0.6242 28199.5n 0.6242 28200.0n 0.3452 28799.5n 0.3452 28800.0n 0.6162 29399.5n 0.6162 29400.0n 0.4993 29999.5n 0.4993 30000.0n 0.4710 30599.5n 0.4710 30600.0n 0.3482 31199.5n 0.3482 31200.0n 0.3480 31799.5n 0.3480 31800.0n 0.6078 32399.5n 0.6078 32400.0n 0.6206 32999.5n 0.6206 33000.0n 0.6034 33599.5n 0.6034 33600.0n 0.6179 34199.5n 0.6179 34200.0n 0.4036 34799.5n 0.4036 34800.0n 0.4188 35399.5n 0.4188 35400.0n 0.6048 35999.5n 0.6048)
Vyp_who_35_0 yp_who_35_0 0 PWL(0.0n 0.5031 599.5n 0.5031 600.0n 0.5023 1199.5n 0.5023 1200.0n 0.5052 1799.5n 0.5052 1800.0n 0.5048 2399.5n 0.5048 2400.0n 0.5043 2999.5n 0.5043 3000.0n 0.5034 3599.5n 0.5034 3600.0n 0.5048 4199.5n 0.5048 4200.0n 0.5031 4799.5n 0.5031 4800.0n 0.5040 5399.5n 0.5040 5400.0n 0.5040 5999.5n 0.5040 6000.0n 0.5054 6599.5n 0.5054 6600.0n 0.5040 7199.5n 0.5040 7200.0n 0.5027 7799.5n 0.5027 7800.0n 0.5027 8399.5n 0.5027 8400.0n 0.5038 8999.5n 0.5038 9000.0n 0.5040 9599.5n 0.5040 9600.0n 0.5039 10199.5n 0.5039 10200.0n 0.5033 10799.5n 0.5033 10800.0n 0.5056 11399.5n 0.5056 11400.0n 0.5040 11999.5n 0.5040 12000.0n 0.5036 12599.5n 0.5036 12600.0n 0.5039 13199.5n 0.5039 13200.0n 0.5029 13799.5n 0.5029 13800.0n 0.5025 14399.5n 0.5025 14400.0n 0.5038 14999.5n 0.5038 15000.0n 0.5041 15599.5n 0.5041 15600.0n 0.5036 16199.5n 0.5036 16200.0n 0.5025 16799.5n 0.5025 16800.0n 0.5040 17399.5n 0.5040 17400.0n 0.5029 17999.5n 0.5029 18000.0n 0.5057 18599.5n 0.5057 18600.0n 0.5010 19199.5n 0.5010 19200.0n 0.5041 19799.5n 0.5041 19800.0n 0.5021 20399.5n 0.5021 20400.0n 0.5044 20999.5n 0.5044 21000.0n 0.5056 21599.5n 0.5056 21600.0n 0.5016 22199.5n 0.5016 22200.0n 0.5006 22799.5n 0.5006 22800.0n 0.5041 23399.5n 0.5041 23400.0n 0.5027 23999.5n 0.5027 24000.0n 0.5029 24599.5n 0.5029 24600.0n 0.5006 25199.5n 0.5006 25200.0n 0.5047 25799.5n 0.5047 25800.0n 0.5046 26399.5n 0.5046 26400.0n 0.5039 26999.5n 0.5039 27000.0n 0.5049 27599.5n 0.5049 27600.0n 0.5039 28199.5n 0.5039 28200.0n 0.5017 28799.5n 0.5017 28800.0n 0.5042 29399.5n 0.5042 29400.0n 0.5056 29999.5n 0.5056 30000.0n 0.5051 30599.5n 0.5051 30600.0n 0.5039 31199.5n 0.5039 31200.0n 0.5033 31799.5n 0.5033 31800.0n 0.5049 32399.5n 0.5049 32400.0n 0.5045 32999.5n 0.5045 33000.0n 0.5036 33599.5n 0.5036 33600.0n 0.5042 34199.5n 0.5042 34200.0n 0.5012 34799.5n 0.5012 34800.0n 0.5036 35399.5n 0.5036 35400.0n 0.5042 35999.5n 0.5042)
Vyn_who_35_0 yn_who_35_0 0 PWL(0.0n 0.4969 599.5n 0.4969 600.0n 0.4977 1199.5n 0.4977 1200.0n 0.4948 1799.5n 0.4948 1800.0n 0.4952 2399.5n 0.4952 2400.0n 0.4957 2999.5n 0.4957 3000.0n 0.4966 3599.5n 0.4966 3600.0n 0.4952 4199.5n 0.4952 4200.0n 0.4969 4799.5n 0.4969 4800.0n 0.4960 5399.5n 0.4960 5400.0n 0.4960 5999.5n 0.4960 6000.0n 0.4946 6599.5n 0.4946 6600.0n 0.4960 7199.5n 0.4960 7200.0n 0.4973 7799.5n 0.4973 7800.0n 0.4973 8399.5n 0.4973 8400.0n 0.4962 8999.5n 0.4962 9000.0n 0.4960 9599.5n 0.4960 9600.0n 0.4961 10199.5n 0.4961 10200.0n 0.4967 10799.5n 0.4967 10800.0n 0.4944 11399.5n 0.4944 11400.0n 0.4960 11999.5n 0.4960 12000.0n 0.4964 12599.5n 0.4964 12600.0n 0.4961 13199.5n 0.4961 13200.0n 0.4971 13799.5n 0.4971 13800.0n 0.4975 14399.5n 0.4975 14400.0n 0.4962 14999.5n 0.4962 15000.0n 0.4959 15599.5n 0.4959 15600.0n 0.4964 16199.5n 0.4964 16200.0n 0.4975 16799.5n 0.4975 16800.0n 0.4960 17399.5n 0.4960 17400.0n 0.4971 17999.5n 0.4971 18000.0n 0.4943 18599.5n 0.4943 18600.0n 0.4990 19199.5n 0.4990 19200.0n 0.4959 19799.5n 0.4959 19800.0n 0.4979 20399.5n 0.4979 20400.0n 0.4956 20999.5n 0.4956 21000.0n 0.4944 21599.5n 0.4944 21600.0n 0.4984 22199.5n 0.4984 22200.0n 0.4994 22799.5n 0.4994 22800.0n 0.4959 23399.5n 0.4959 23400.0n 0.4973 23999.5n 0.4973 24000.0n 0.4971 24599.5n 0.4971 24600.0n 0.4994 25199.5n 0.4994 25200.0n 0.4953 25799.5n 0.4953 25800.0n 0.4954 26399.5n 0.4954 26400.0n 0.4961 26999.5n 0.4961 27000.0n 0.4951 27599.5n 0.4951 27600.0n 0.4961 28199.5n 0.4961 28200.0n 0.4983 28799.5n 0.4983 28800.0n 0.4958 29399.5n 0.4958 29400.0n 0.4944 29999.5n 0.4944 30000.0n 0.4949 30599.5n 0.4949 30600.0n 0.4961 31199.5n 0.4961 31200.0n 0.4967 31799.5n 0.4967 31800.0n 0.4951 32399.5n 0.4951 32400.0n 0.4955 32999.5n 0.4955 33000.0n 0.4964 33599.5n 0.4964 33600.0n 0.4958 34199.5n 0.4958 34200.0n 0.4988 34799.5n 0.4988 34800.0n 0.4964 35399.5n 0.4964 35400.0n 0.4958 35999.5n 0.4958)
Cwp_who_35_0 wp_who_35_0 0 400p
Cwn_who_35_0 wn_who_35_0 0 400p
Xu_who_35_0 xp_who_35_0 xn_who_35_0 yp_who_35_0 yn_who_35_0 wp_who_35_0 wn_who_35_0 vdd gbn gprod
Vxp_who_35_1 xp_who_35_1 0 PWL(0.0n 0.5745 599.5n 0.5745 600.0n 0.5559 1199.5n 0.5559 1200.0n 0.5062 1799.5n 0.5062 1800.0n 0.4554 2399.5n 0.4554 2400.0n 0.4796 2999.5n 0.4796 3000.0n 0.5390 3599.5n 0.5390 3600.0n 0.5220 4199.5n 0.5220 4200.0n 0.5760 4799.5n 0.5760 4800.0n 0.5338 5399.5n 0.5338 5400.0n 0.5331 5999.5n 0.5331 6000.0n 0.4952 6599.5n 0.4952 6600.0n 0.5429 7199.5n 0.5429 7200.0n 0.5379 7799.5n 0.5379 7800.0n 0.5324 8399.5n 0.5324 8400.0n 0.5623 8999.5n 0.5623 9000.0n 0.5338 9599.5n 0.5338 9600.0n 0.5216 10199.5n 0.5216 10200.0n 0.5185 10799.5n 0.5185 10800.0n 0.5083 11399.5n 0.5083 11400.0n 0.5388 11999.5n 0.5388 12000.0n 0.5687 12599.5n 0.5687 12600.0n 0.5192 13199.5n 0.5192 13200.0n 0.5771 13799.5n 0.5771 13800.0n 0.5588 14399.5n 0.5588 14400.0n 0.5415 14999.5n 0.5415 15000.0n 0.5015 15599.5n 0.5015 15600.0n 0.5622 16199.5n 0.5622 16200.0n 0.5772 16799.5n 0.5772 16800.0n 0.5588 17399.5n 0.5588 17400.0n 0.5721 17999.5n 0.5721 18000.0n 0.4123 18599.5n 0.4123 18600.0n 0.5587 19199.5n 0.5587 19200.0n 0.4030 19799.5n 0.4030 19800.0n 0.4417 20399.5n 0.4417 20400.0n 0.3930 20999.5n 0.3930 21000.0n 0.4847 21599.5n 0.4847 21600.0n 0.4874 22199.5n 0.4874 22200.0n 0.5501 22799.5n 0.5501 22800.0n 0.3733 23399.5n 0.3733 23400.0n 0.6593 23999.5n 0.6593 24000.0n 0.4015 24599.5n 0.4015 24600.0n 0.5736 25199.5n 0.5736 25200.0n 0.3974 25799.5n 0.3974 25800.0n 0.3820 26399.5n 0.3820 26400.0n 0.3756 26999.5n 0.3756 27000.0n 0.3962 27599.5n 0.3962 27600.0n 0.3758 28199.5n 0.3758 28200.0n 0.6548 28799.5n 0.6548 28800.0n 0.3838 29399.5n 0.3838 29400.0n 0.5007 29999.5n 0.5007 30000.0n 0.5290 30599.5n 0.5290 30600.0n 0.6518 31199.5n 0.6518 31200.0n 0.6520 31799.5n 0.6520 31800.0n 0.3922 32399.5n 0.3922 32400.0n 0.3794 32999.5n 0.3794 33000.0n 0.3966 33599.5n 0.3966 33600.0n 0.3821 34199.5n 0.3821 34200.0n 0.5964 34799.5n 0.5964 34800.0n 0.5812 35399.5n 0.5812 35400.0n 0.3952 35999.5n 0.3952)
Vxn_who_35_1 xn_who_35_1 0 PWL(0.0n 0.4255 599.5n 0.4255 600.0n 0.4441 1199.5n 0.4441 1200.0n 0.4938 1799.5n 0.4938 1800.0n 0.5446 2399.5n 0.5446 2400.0n 0.5204 2999.5n 0.5204 3000.0n 0.4610 3599.5n 0.4610 3600.0n 0.4780 4199.5n 0.4780 4200.0n 0.4240 4799.5n 0.4240 4800.0n 0.4662 5399.5n 0.4662 5400.0n 0.4669 5999.5n 0.4669 6000.0n 0.5048 6599.5n 0.5048 6600.0n 0.4571 7199.5n 0.4571 7200.0n 0.4621 7799.5n 0.4621 7800.0n 0.4676 8399.5n 0.4676 8400.0n 0.4377 8999.5n 0.4377 9000.0n 0.4662 9599.5n 0.4662 9600.0n 0.4784 10199.5n 0.4784 10200.0n 0.4815 10799.5n 0.4815 10800.0n 0.4917 11399.5n 0.4917 11400.0n 0.4612 11999.5n 0.4612 12000.0n 0.4313 12599.5n 0.4313 12600.0n 0.4808 13199.5n 0.4808 13200.0n 0.4229 13799.5n 0.4229 13800.0n 0.4412 14399.5n 0.4412 14400.0n 0.4585 14999.5n 0.4585 15000.0n 0.4985 15599.5n 0.4985 15600.0n 0.4378 16199.5n 0.4378 16200.0n 0.4228 16799.5n 0.4228 16800.0n 0.4412 17399.5n 0.4412 17400.0n 0.4279 17999.5n 0.4279 18000.0n 0.5877 18599.5n 0.5877 18600.0n 0.4413 19199.5n 0.4413 19200.0n 0.5970 19799.5n 0.5970 19800.0n 0.5583 20399.5n 0.5583 20400.0n 0.6070 20999.5n 0.6070 21000.0n 0.5153 21599.5n 0.5153 21600.0n 0.5126 22199.5n 0.5126 22200.0n 0.4499 22799.5n 0.4499 22800.0n 0.6267 23399.5n 0.6267 23400.0n 0.3407 23999.5n 0.3407 24000.0n 0.5985 24599.5n 0.5985 24600.0n 0.4264 25199.5n 0.4264 25200.0n 0.6026 25799.5n 0.6026 25800.0n 0.6180 26399.5n 0.6180 26400.0n 0.6244 26999.5n 0.6244 27000.0n 0.6038 27599.5n 0.6038 27600.0n 0.6242 28199.5n 0.6242 28200.0n 0.3452 28799.5n 0.3452 28800.0n 0.6162 29399.5n 0.6162 29400.0n 0.4993 29999.5n 0.4993 30000.0n 0.4710 30599.5n 0.4710 30600.0n 0.3482 31199.5n 0.3482 31200.0n 0.3480 31799.5n 0.3480 31800.0n 0.6078 32399.5n 0.6078 32400.0n 0.6206 32999.5n 0.6206 33000.0n 0.6034 33599.5n 0.6034 33600.0n 0.6179 34199.5n 0.6179 34200.0n 0.4036 34799.5n 0.4036 34800.0n 0.4188 35399.5n 0.4188 35400.0n 0.6048 35999.5n 0.6048)
Vyp_who_35_1 yp_who_35_1 0 PWL(0.0n 0.5071 599.5n 0.5071 600.0n 0.5053 1199.5n 0.5053 1200.0n 0.5052 1799.5n 0.5052 1800.0n 0.5027 2399.5n 0.5027 2400.0n 0.5034 2999.5n 0.5034 3000.0n 0.5055 3599.5n 0.5055 3600.0n 0.5056 4199.5n 0.5056 4200.0n 0.5071 4799.5n 0.5071 4800.0n 0.5056 5399.5n 0.5056 5400.0n 0.5056 5999.5n 0.5056 6000.0n 0.5048 6599.5n 0.5048 6600.0n 0.5060 7199.5n 0.5060 7200.0n 0.5048 7799.5n 0.5048 7800.0n 0.5046 8399.5n 0.5046 8400.0n 0.5066 8999.5n 0.5066 9000.0n 0.5056 9599.5n 0.5056 9600.0n 0.5051 10199.5n 0.5051 10200.0n 0.5046 10799.5n 0.5046 10800.0n 0.5056 11399.5n 0.5056 11400.0n 0.5058 11999.5n 0.5058 12000.0n 0.5068 12599.5n 0.5068 12600.0n 0.5050 13199.5n 0.5050 13200.0n 0.5071 13799.5n 0.5071 13800.0n 0.5059 14399.5n 0.5059 14400.0n 0.5058 14999.5n 0.5058 15000.0n 0.5043 15599.5n 0.5043 15600.0n 0.5067 16199.5n 0.5067 16200.0n 0.5068 16799.5n 0.5068 16800.0n 0.5066 17399.5n 0.5066 17400.0n 0.5069 17999.5n 0.5069 18000.0n 0.5061 18599.5n 0.5061 18600.0n 0.5034 19199.5n 0.5034 19200.0n 0.5010 19799.5n 0.5010 19800.0n 0.4989 20399.5n 0.4989 20400.0n 0.5022 20999.5n 0.5022 21000.0n 0.5086 21599.5n 0.5086 21600.0n 0.5007 22199.5n 0.5007 22200.0n 0.5023 22799.5n 0.5023 22800.0n 0.5021 23399.5n 0.5021 23400.0n 0.5077 23999.5n 0.5077 24000.0n 0.4979 24599.5n 0.4979 24600.0n 0.5035 25199.5n 0.5035 25200.0n 0.5041 25799.5n 0.5041 25800.0n 0.5075 26399.5n 0.5075 26400.0n 0.5041 26999.5n 0.5041 27000.0n 0.5056 27599.5n 0.5056 27600.0n 0.5039 28199.5n 0.5039 28200.0n 0.5059 28799.5n 0.5059 28800.0n 0.5023 29399.5n 0.5023 29400.0n 0.5086 29999.5n 0.5086 30000.0n 0.5084 30599.5n 0.5084 30600.0n 0.5085 31199.5n 0.5085 31200.0n 0.5088 31799.5n 0.5088 31800.0n 0.5078 32399.5n 0.5078 32400.0n 0.5074 32999.5n 0.5074 33000.0n 0.4996 33599.5n 0.4996 33600.0n 0.5010 34199.5n 0.5010 34200.0n 0.5044 34799.5n 0.5044 34800.0n 0.5084 35399.5n 0.5084 35400.0n 0.5012 35999.5n 0.5012)
Vyn_who_35_1 yn_who_35_1 0 PWL(0.0n 0.4929 599.5n 0.4929 600.0n 0.4947 1199.5n 0.4947 1200.0n 0.4948 1799.5n 0.4948 1800.0n 0.4973 2399.5n 0.4973 2400.0n 0.4966 2999.5n 0.4966 3000.0n 0.4945 3599.5n 0.4945 3600.0n 0.4944 4199.5n 0.4944 4200.0n 0.4929 4799.5n 0.4929 4800.0n 0.4944 5399.5n 0.4944 5400.0n 0.4944 5999.5n 0.4944 6000.0n 0.4952 6599.5n 0.4952 6600.0n 0.4940 7199.5n 0.4940 7200.0n 0.4952 7799.5n 0.4952 7800.0n 0.4954 8399.5n 0.4954 8400.0n 0.4934 8999.5n 0.4934 9000.0n 0.4944 9599.5n 0.4944 9600.0n 0.4949 10199.5n 0.4949 10200.0n 0.4954 10799.5n 0.4954 10800.0n 0.4944 11399.5n 0.4944 11400.0n 0.4942 11999.5n 0.4942 12000.0n 0.4932 12599.5n 0.4932 12600.0n 0.4950 13199.5n 0.4950 13200.0n 0.4929 13799.5n 0.4929 13800.0n 0.4941 14399.5n 0.4941 14400.0n 0.4942 14999.5n 0.4942 15000.0n 0.4957 15599.5n 0.4957 15600.0n 0.4933 16199.5n 0.4933 16200.0n 0.4932 16799.5n 0.4932 16800.0n 0.4934 17399.5n 0.4934 17400.0n 0.4931 17999.5n 0.4931 18000.0n 0.4939 18599.5n 0.4939 18600.0n 0.4966 19199.5n 0.4966 19200.0n 0.4990 19799.5n 0.4990 19800.0n 0.5011 20399.5n 0.5011 20400.0n 0.4978 20999.5n 0.4978 21000.0n 0.4914 21599.5n 0.4914 21600.0n 0.4993 22199.5n 0.4993 22200.0n 0.4977 22799.5n 0.4977 22800.0n 0.4979 23399.5n 0.4979 23400.0n 0.4923 23999.5n 0.4923 24000.0n 0.5021 24599.5n 0.5021 24600.0n 0.4965 25199.5n 0.4965 25200.0n 0.4959 25799.5n 0.4959 25800.0n 0.4925 26399.5n 0.4925 26400.0n 0.4959 26999.5n 0.4959 27000.0n 0.4944 27599.5n 0.4944 27600.0n 0.4961 28199.5n 0.4961 28200.0n 0.4941 28799.5n 0.4941 28800.0n 0.4977 29399.5n 0.4977 29400.0n 0.4914 29999.5n 0.4914 30000.0n 0.4916 30599.5n 0.4916 30600.0n 0.4915 31199.5n 0.4915 31200.0n 0.4912 31799.5n 0.4912 31800.0n 0.4922 32399.5n 0.4922 32400.0n 0.4926 32999.5n 0.4926 33000.0n 0.5004 33599.5n 0.5004 33600.0n 0.4990 34199.5n 0.4990 34200.0n 0.4956 34799.5n 0.4956 34800.0n 0.4916 35399.5n 0.4916 35400.0n 0.4988 35999.5n 0.4988)
Cwp_who_35_1 wp_who_35_1 0 400p
Cwn_who_35_1 wn_who_35_1 0 400p
Xu_who_35_1 xp_who_35_1 xn_who_35_1 yp_who_35_1 yn_who_35_1 wp_who_35_1 wn_who_35_1 vdd gbn gprod
Vxp_bh_35 xp_bh_35 0 PWL(0.0n 0.7100 599.5n 0.7100 600.0n 0.7100 1199.5n 0.7100 1200.0n 0.7100 1799.5n 0.7100 1800.0n 0.7100 2399.5n 0.7100 2400.0n 0.7100 2999.5n 0.7100 3000.0n 0.7100 3599.5n 0.7100 3600.0n 0.7100 4199.5n 0.7100 4200.0n 0.7100 4799.5n 0.7100 4800.0n 0.7100 5399.5n 0.7100 5400.0n 0.7100 5999.5n 0.7100 6000.0n 0.7100 6599.5n 0.7100 6600.0n 0.7100 7199.5n 0.7100 7200.0n 0.7100 7799.5n 0.7100 7800.0n 0.7100 8399.5n 0.7100 8400.0n 0.7100 8999.5n 0.7100 9000.0n 0.7100 9599.5n 0.7100 9600.0n 0.7100 10199.5n 0.7100 10200.0n 0.7100 10799.5n 0.7100 10800.0n 0.7100 11399.5n 0.7100 11400.0n 0.7100 11999.5n 0.7100 12000.0n 0.7100 12599.5n 0.7100 12600.0n 0.7100 13199.5n 0.7100 13200.0n 0.7100 13799.5n 0.7100 13800.0n 0.7100 14399.5n 0.7100 14400.0n 0.7100 14999.5n 0.7100 15000.0n 0.7100 15599.5n 0.7100 15600.0n 0.7100 16199.5n 0.7100 16200.0n 0.7100 16799.5n 0.7100 16800.0n 0.7100 17399.5n 0.7100 17400.0n 0.7100 17999.5n 0.7100 18000.0n 0.7100 18599.5n 0.7100 18600.0n 0.7100 19199.5n 0.7100 19200.0n 0.7100 19799.5n 0.7100 19800.0n 0.7100 20399.5n 0.7100 20400.0n 0.7100 20999.5n 0.7100 21000.0n 0.7100 21599.5n 0.7100 21600.0n 0.7100 22199.5n 0.7100 22200.0n 0.7100 22799.5n 0.7100 22800.0n 0.7100 23399.5n 0.7100 23400.0n 0.7100 23999.5n 0.7100 24000.0n 0.7100 24599.5n 0.7100 24600.0n 0.7100 25199.5n 0.7100 25200.0n 0.7100 25799.5n 0.7100 25800.0n 0.7100 26399.5n 0.7100 26400.0n 0.7100 26999.5n 0.7100 27000.0n 0.7100 27599.5n 0.7100 27600.0n 0.7100 28199.5n 0.7100 28200.0n 0.7100 28799.5n 0.7100 28800.0n 0.7100 29399.5n 0.7100 29400.0n 0.7100 29999.5n 0.7100 30000.0n 0.7100 30599.5n 0.7100 30600.0n 0.7100 31199.5n 0.7100 31200.0n 0.7100 31799.5n 0.7100 31800.0n 0.7100 32399.5n 0.7100 32400.0n 0.7100 32999.5n 0.7100 33000.0n 0.7100 33599.5n 0.7100 33600.0n 0.7100 34199.5n 0.7100 34200.0n 0.7100 34799.5n 0.7100 34800.0n 0.7100 35399.5n 0.7100 35400.0n 0.7100 35999.5n 0.7100)
Vxn_bh_35 xn_bh_35 0 PWL(0.0n 0.2900 599.5n 0.2900 600.0n 0.2900 1199.5n 0.2900 1200.0n 0.2900 1799.5n 0.2900 1800.0n 0.2900 2399.5n 0.2900 2400.0n 0.2900 2999.5n 0.2900 3000.0n 0.2900 3599.5n 0.2900 3600.0n 0.2900 4199.5n 0.2900 4200.0n 0.2900 4799.5n 0.2900 4800.0n 0.2900 5399.5n 0.2900 5400.0n 0.2900 5999.5n 0.2900 6000.0n 0.2900 6599.5n 0.2900 6600.0n 0.2900 7199.5n 0.2900 7200.0n 0.2900 7799.5n 0.2900 7800.0n 0.2900 8399.5n 0.2900 8400.0n 0.2900 8999.5n 0.2900 9000.0n 0.2900 9599.5n 0.2900 9600.0n 0.2900 10199.5n 0.2900 10200.0n 0.2900 10799.5n 0.2900 10800.0n 0.2900 11399.5n 0.2900 11400.0n 0.2900 11999.5n 0.2900 12000.0n 0.2900 12599.5n 0.2900 12600.0n 0.2900 13199.5n 0.2900 13200.0n 0.2900 13799.5n 0.2900 13800.0n 0.2900 14399.5n 0.2900 14400.0n 0.2900 14999.5n 0.2900 15000.0n 0.2900 15599.5n 0.2900 15600.0n 0.2900 16199.5n 0.2900 16200.0n 0.2900 16799.5n 0.2900 16800.0n 0.2900 17399.5n 0.2900 17400.0n 0.2900 17999.5n 0.2900 18000.0n 0.2900 18599.5n 0.2900 18600.0n 0.2900 19199.5n 0.2900 19200.0n 0.2900 19799.5n 0.2900 19800.0n 0.2900 20399.5n 0.2900 20400.0n 0.2900 20999.5n 0.2900 21000.0n 0.2900 21599.5n 0.2900 21600.0n 0.2900 22199.5n 0.2900 22200.0n 0.2900 22799.5n 0.2900 22800.0n 0.2900 23399.5n 0.2900 23400.0n 0.2900 23999.5n 0.2900 24000.0n 0.2900 24599.5n 0.2900 24600.0n 0.2900 25199.5n 0.2900 25200.0n 0.2900 25799.5n 0.2900 25800.0n 0.2900 26399.5n 0.2900 26400.0n 0.2900 26999.5n 0.2900 27000.0n 0.2900 27599.5n 0.2900 27600.0n 0.2900 28199.5n 0.2900 28200.0n 0.2900 28799.5n 0.2900 28800.0n 0.2900 29399.5n 0.2900 29400.0n 0.2900 29999.5n 0.2900 30000.0n 0.2900 30599.5n 0.2900 30600.0n 0.2900 31199.5n 0.2900 31200.0n 0.2900 31799.5n 0.2900 31800.0n 0.2900 32399.5n 0.2900 32400.0n 0.2900 32999.5n 0.2900 33000.0n 0.2900 33599.5n 0.2900 33600.0n 0.2900 34199.5n 0.2900 34200.0n 0.2900 34799.5n 0.2900 34800.0n 0.2900 35399.5n 0.2900 35400.0n 0.2900 35999.5n 0.2900)
Vyp_bh_35 yp_bh_35 0 PWL(0.0n 0.5745 599.5n 0.5745 600.0n 0.5559 1199.5n 0.5559 1200.0n 0.5062 1799.5n 0.5062 1800.0n 0.4554 2399.5n 0.4554 2400.0n 0.4796 2999.5n 0.4796 3000.0n 0.5390 3599.5n 0.5390 3600.0n 0.5220 4199.5n 0.5220 4200.0n 0.5760 4799.5n 0.5760 4800.0n 0.5338 5399.5n 0.5338 5400.0n 0.5331 5999.5n 0.5331 6000.0n 0.4952 6599.5n 0.4952 6600.0n 0.5429 7199.5n 0.5429 7200.0n 0.5379 7799.5n 0.5379 7800.0n 0.5324 8399.5n 0.5324 8400.0n 0.5623 8999.5n 0.5623 9000.0n 0.5338 9599.5n 0.5338 9600.0n 0.5216 10199.5n 0.5216 10200.0n 0.5185 10799.5n 0.5185 10800.0n 0.5083 11399.5n 0.5083 11400.0n 0.5388 11999.5n 0.5388 12000.0n 0.5687 12599.5n 0.5687 12600.0n 0.5192 13199.5n 0.5192 13200.0n 0.5771 13799.5n 0.5771 13800.0n 0.5588 14399.5n 0.5588 14400.0n 0.5415 14999.5n 0.5415 15000.0n 0.5015 15599.5n 0.5015 15600.0n 0.5622 16199.5n 0.5622 16200.0n 0.5772 16799.5n 0.5772 16800.0n 0.5588 17399.5n 0.5588 17400.0n 0.5721 17999.5n 0.5721 18000.0n 0.4123 18599.5n 0.4123 18600.0n 0.5587 19199.5n 0.5587 19200.0n 0.4030 19799.5n 0.4030 19800.0n 0.4417 20399.5n 0.4417 20400.0n 0.3930 20999.5n 0.3930 21000.0n 0.4847 21599.5n 0.4847 21600.0n 0.4874 22199.5n 0.4874 22200.0n 0.5501 22799.5n 0.5501 22800.0n 0.3733 23399.5n 0.3733 23400.0n 0.6593 23999.5n 0.6593 24000.0n 0.4015 24599.5n 0.4015 24600.0n 0.5736 25199.5n 0.5736 25200.0n 0.3974 25799.5n 0.3974 25800.0n 0.3820 26399.5n 0.3820 26400.0n 0.3756 26999.5n 0.3756 27000.0n 0.3962 27599.5n 0.3962 27600.0n 0.3758 28199.5n 0.3758 28200.0n 0.6548 28799.5n 0.6548 28800.0n 0.3838 29399.5n 0.3838 29400.0n 0.5007 29999.5n 0.5007 30000.0n 0.5290 30599.5n 0.5290 30600.0n 0.6518 31199.5n 0.6518 31200.0n 0.6520 31799.5n 0.6520 31800.0n 0.3922 32399.5n 0.3922 32400.0n 0.3794 32999.5n 0.3794 33000.0n 0.3966 33599.5n 0.3966 33600.0n 0.3821 34199.5n 0.3821 34200.0n 0.5964 34799.5n 0.5964 34800.0n 0.5812 35399.5n 0.5812 35400.0n 0.3952 35999.5n 0.3952)
Vyn_bh_35 yn_bh_35 0 PWL(0.0n 0.4255 599.5n 0.4255 600.0n 0.4441 1199.5n 0.4441 1200.0n 0.4938 1799.5n 0.4938 1800.0n 0.5446 2399.5n 0.5446 2400.0n 0.5204 2999.5n 0.5204 3000.0n 0.4610 3599.5n 0.4610 3600.0n 0.4780 4199.5n 0.4780 4200.0n 0.4240 4799.5n 0.4240 4800.0n 0.4662 5399.5n 0.4662 5400.0n 0.4669 5999.5n 0.4669 6000.0n 0.5048 6599.5n 0.5048 6600.0n 0.4571 7199.5n 0.4571 7200.0n 0.4621 7799.5n 0.4621 7800.0n 0.4676 8399.5n 0.4676 8400.0n 0.4377 8999.5n 0.4377 9000.0n 0.4662 9599.5n 0.4662 9600.0n 0.4784 10199.5n 0.4784 10200.0n 0.4815 10799.5n 0.4815 10800.0n 0.4917 11399.5n 0.4917 11400.0n 0.4612 11999.5n 0.4612 12000.0n 0.4313 12599.5n 0.4313 12600.0n 0.4808 13199.5n 0.4808 13200.0n 0.4229 13799.5n 0.4229 13800.0n 0.4412 14399.5n 0.4412 14400.0n 0.4585 14999.5n 0.4585 15000.0n 0.4985 15599.5n 0.4985 15600.0n 0.4378 16199.5n 0.4378 16200.0n 0.4228 16799.5n 0.4228 16800.0n 0.4412 17399.5n 0.4412 17400.0n 0.4279 17999.5n 0.4279 18000.0n 0.5877 18599.5n 0.5877 18600.0n 0.4413 19199.5n 0.4413 19200.0n 0.5970 19799.5n 0.5970 19800.0n 0.5583 20399.5n 0.5583 20400.0n 0.6070 20999.5n 0.6070 21000.0n 0.5153 21599.5n 0.5153 21600.0n 0.5126 22199.5n 0.5126 22200.0n 0.4499 22799.5n 0.4499 22800.0n 0.6267 23399.5n 0.6267 23400.0n 0.3407 23999.5n 0.3407 24000.0n 0.5985 24599.5n 0.5985 24600.0n 0.4264 25199.5n 0.4264 25200.0n 0.6026 25799.5n 0.6026 25800.0n 0.6180 26399.5n 0.6180 26400.0n 0.6244 26999.5n 0.6244 27000.0n 0.6038 27599.5n 0.6038 27600.0n 0.6242 28199.5n 0.6242 28200.0n 0.3452 28799.5n 0.3452 28800.0n 0.6162 29399.5n 0.6162 29400.0n 0.4993 29999.5n 0.4993 30000.0n 0.4710 30599.5n 0.4710 30600.0n 0.3482 31199.5n 0.3482 31200.0n 0.3480 31799.5n 0.3480 31800.0n 0.6078 32399.5n 0.6078 32400.0n 0.6206 32999.5n 0.6206 33000.0n 0.6034 33599.5n 0.6034 33600.0n 0.6179 34199.5n 0.6179 34200.0n 0.4036 34799.5n 0.4036 34800.0n 0.4188 35399.5n 0.4188 35400.0n 0.6048 35999.5n 0.6048)
Cwp_bh_35 wp_bh_35 0 400p
Cwn_bh_35 wn_bh_35 0 400p
Xu_bh_35 xp_bh_35 xn_bh_35 yp_bh_35 yn_bh_35 wp_bh_35 wn_bh_35 vdd gbn gprod
Vxp_wih_0_36 xp_wih_0_36 0 PWL(0.0n 0.4942 599.5n 0.4942 600.0n 0.5558 1199.5n 0.5558 1200.0n 0.4708 1799.5n 0.4708 1800.0n 0.5235 2399.5n 0.5235 2400.0n 0.5350 2999.5n 0.5350 3000.0n 0.5172 3599.5n 0.5172 3600.0n 0.4702 4199.5n 0.4702 4200.0n 0.4867 4799.5n 0.4867 4800.0n 0.4970 5399.5n 0.4970 5400.0n 0.4986 5999.5n 0.4986 6000.0n 0.4751 6599.5n 0.4751 6600.0n 0.4870 7199.5n 0.4870 7200.0n 0.5502 7799.5n 0.5502 7800.0n 0.5521 8399.5n 0.5521 8400.0n 0.4638 8999.5n 0.4638 9000.0n 0.4982 9599.5n 0.4982 9600.0n 0.5131 10199.5n 0.5131 10200.0n 0.5386 10799.5n 0.5386 10800.0n 0.4592 11399.5n 0.4592 11400.0n 0.4950 11999.5n 0.4950 12000.0n 0.4559 12599.5n 0.4559 12600.0n 0.5162 13199.5n 0.5162 13200.0n 0.5038 13799.5n 0.5038 13800.0n 0.5333 14399.5n 0.5333 14400.0n 0.4991 14999.5n 0.4991 15000.0n 0.5298 15599.5n 0.5298 15600.0n 0.4823 16199.5n 0.4823 16200.0n 0.5239 16799.5n 0.5239 16800.0n 0.4592 17399.5n 0.4592 17400.0n 0.5094 17999.5n 0.5094 18000.0n 0.4337 18599.5n 0.4337 18600.0n 0.5977 19199.5n 0.5977 19200.0n 0.5364 19799.5n 0.5364 19800.0n 0.6122 20399.5n 0.6122 20400.0n 0.4856 20999.5n 0.4856 21000.0n 0.3861 21599.5n 0.3861 21600.0n 0.6094 22199.5n 0.6094 22200.0n 0.6364 22799.5n 0.6364 22800.0n 0.4807 23399.5n 0.4807 23400.0n 0.5614 23999.5n 0.5614 24000.0n 0.5913 24599.5n 0.5913 24600.0n 0.6295 25199.5n 0.6295 25200.0n 0.4496 25799.5n 0.4496 25800.0n 0.3792 26399.5n 0.3792 26400.0n 0.4434 26999.5n 0.4434 27000.0n 0.4340 27599.5n 0.4340 27600.0n 0.4461 28199.5n 0.4461 28200.0n 0.5791 28799.5n 0.5791 28800.0n 0.4777 29399.5n 0.4777 29400.0n 0.3878 29999.5n 0.3878 30000.0n 0.3832 30599.5n 0.3832 30600.0n 0.4022 31199.5n 0.4022 31200.0n 0.4482 31799.5n 0.4482 31800.0n 0.3662 32399.5n 0.3662 32400.0n 0.3857 32999.5n 0.3857 33000.0n 0.5584 33599.5n 0.5584 33600.0n 0.5284 34199.5n 0.5284 34200.0n 0.6034 34799.5n 0.6034 34800.0n 0.3469 35399.5n 0.3469 35400.0n 0.5290 35999.5n 0.5290)
Vxn_wih_0_36 xn_wih_0_36 0 PWL(0.0n 0.5058 599.5n 0.5058 600.0n 0.4442 1199.5n 0.4442 1200.0n 0.5292 1799.5n 0.5292 1800.0n 0.4765 2399.5n 0.4765 2400.0n 0.4650 2999.5n 0.4650 3000.0n 0.4828 3599.5n 0.4828 3600.0n 0.5298 4199.5n 0.5298 4200.0n 0.5133 4799.5n 0.5133 4800.0n 0.5030 5399.5n 0.5030 5400.0n 0.5014 5999.5n 0.5014 6000.0n 0.5249 6599.5n 0.5249 6600.0n 0.5130 7199.5n 0.5130 7200.0n 0.4498 7799.5n 0.4498 7800.0n 0.4479 8399.5n 0.4479 8400.0n 0.5362 8999.5n 0.5362 9000.0n 0.5018 9599.5n 0.5018 9600.0n 0.4869 10199.5n 0.4869 10200.0n 0.4614 10799.5n 0.4614 10800.0n 0.5408 11399.5n 0.5408 11400.0n 0.5050 11999.5n 0.5050 12000.0n 0.5441 12599.5n 0.5441 12600.0n 0.4838 13199.5n 0.4838 13200.0n 0.4962 13799.5n 0.4962 13800.0n 0.4667 14399.5n 0.4667 14400.0n 0.5009 14999.5n 0.5009 15000.0n 0.4702 15599.5n 0.4702 15600.0n 0.5177 16199.5n 0.5177 16200.0n 0.4761 16799.5n 0.4761 16800.0n 0.5408 17399.5n 0.5408 17400.0n 0.4906 17999.5n 0.4906 18000.0n 0.5663 18599.5n 0.5663 18600.0n 0.4023 19199.5n 0.4023 19200.0n 0.4636 19799.5n 0.4636 19800.0n 0.3878 20399.5n 0.3878 20400.0n 0.5144 20999.5n 0.5144 21000.0n 0.6139 21599.5n 0.6139 21600.0n 0.3906 22199.5n 0.3906 22200.0n 0.3636 22799.5n 0.3636 22800.0n 0.5193 23399.5n 0.5193 23400.0n 0.4386 23999.5n 0.4386 24000.0n 0.4087 24599.5n 0.4087 24600.0n 0.3705 25199.5n 0.3705 25200.0n 0.5504 25799.5n 0.5504 25800.0n 0.6208 26399.5n 0.6208 26400.0n 0.5566 26999.5n 0.5566 27000.0n 0.5660 27599.5n 0.5660 27600.0n 0.5539 28199.5n 0.5539 28200.0n 0.4209 28799.5n 0.4209 28800.0n 0.5223 29399.5n 0.5223 29400.0n 0.6122 29999.5n 0.6122 30000.0n 0.6168 30599.5n 0.6168 30600.0n 0.5978 31199.5n 0.5978 31200.0n 0.5518 31799.5n 0.5518 31800.0n 0.6338 32399.5n 0.6338 32400.0n 0.6143 32999.5n 0.6143 33000.0n 0.4416 33599.5n 0.4416 33600.0n 0.4716 34199.5n 0.4716 34200.0n 0.3966 34799.5n 0.3966 34800.0n 0.6531 35399.5n 0.6531 35400.0n 0.4710 35999.5n 0.4710)
Vyp_wih_0_36 yp_wih_0_36 0 PWL(0.0n 0.5753 599.5n 0.5753 600.0n 0.5686 1199.5n 0.5686 1200.0n 0.5291 1799.5n 0.5291 1800.0n 0.4994 2399.5n 0.4994 2400.0n 0.5163 2999.5n 0.5163 3000.0n 0.5539 3599.5n 0.5539 3600.0n 0.5394 4199.5n 0.5394 4200.0n 0.5758 4799.5n 0.5758 4800.0n 0.5490 5399.5n 0.5490 5400.0n 0.5487 5999.5n 0.5487 6000.0n 0.5222 6599.5n 0.5222 6600.0n 0.5542 7199.5n 0.5542 7200.0n 0.5562 7799.5n 0.5562 7800.0n 0.5529 8399.5n 0.5529 8400.0n 0.5652 8999.5n 0.5652 9000.0n 0.5492 9599.5n 0.5492 9600.0n 0.5423 10199.5n 0.5423 10200.0n 0.5422 10799.5n 0.5422 10800.0n 0.5292 11399.5n 0.5292 11400.0n 0.5521 11999.5n 0.5521 12000.0n 0.5687 12599.5n 0.5687 12600.0n 0.5409 13199.5n 0.5409 13200.0n 0.5775 13799.5n 0.5775 13800.0n 0.5679 14399.5n 0.5679 14400.0n 0.5542 14999.5n 0.5542 15000.0n 0.5303 15599.5n 0.5303 15600.0n 0.5664 16199.5n 0.5664 16200.0n 0.5790 16799.5n 0.5790 16800.0n 0.5624 17399.5n 0.5624 17400.0n 0.5746 17999.5n 0.5746 18000.0n 0.4539 18599.5n 0.4539 18600.0n 0.5775 19199.5n 0.5775 19200.0n 0.4584 19799.5n 0.4584 19800.0n 0.4980 20399.5n 0.4980 20400.0n 0.4465 20999.5n 0.4465 21000.0n 0.5027 21599.5n 0.5027 21600.0n 0.5318 22199.5n 0.5318 22200.0n 0.5730 22799.5n 0.5730 22800.0n 0.4323 23399.5n 0.4323 23400.0n 0.6540 23999.5n 0.6540 24000.0n 0.4656 24599.5n 0.4656 24600.0n 0.5879 25199.5n 0.5879 25200.0n 0.4460 25799.5n 0.4460 25800.0n 0.4246 26399.5n 0.4246 26400.0n 0.4286 26999.5n 0.4286 27000.0n 0.4419 27599.5n 0.4419 27600.0n 0.4293 28199.5n 0.4293 28200.0n 0.6514 28799.5n 0.6514 28800.0n 0.4388 29399.5n 0.4388 29400.0n 0.5136 29999.5n 0.5136 30000.0n 0.5328 30599.5n 0.5328 30600.0n 0.6304 31199.5n 0.6304 31200.0n 0.6383 31799.5n 0.6383 31800.0n 0.4327 32399.5n 0.4327 32400.0n 0.4227 32999.5n 0.4227 33000.0n 0.4561 33599.5n 0.4561 33600.0n 0.4417 34199.5n 0.4417 34200.0n 0.6026 34799.5n 0.6026 34800.0n 0.5683 35399.5n 0.5683 35400.0n 0.4514 35999.5n 0.4514)
Vyn_wih_0_36 yn_wih_0_36 0 PWL(0.0n 0.4247 599.5n 0.4247 600.0n 0.4314 1199.5n 0.4314 1200.0n 0.4709 1799.5n 0.4709 1800.0n 0.5006 2399.5n 0.5006 2400.0n 0.4837 2999.5n 0.4837 3000.0n 0.4461 3599.5n 0.4461 3600.0n 0.4606 4199.5n 0.4606 4200.0n 0.4242 4799.5n 0.4242 4800.0n 0.4510 5399.5n 0.4510 5400.0n 0.4513 5999.5n 0.4513 6000.0n 0.4778 6599.5n 0.4778 6600.0n 0.4458 7199.5n 0.4458 7200.0n 0.4438 7799.5n 0.4438 7800.0n 0.4471 8399.5n 0.4471 8400.0n 0.4348 8999.5n 0.4348 9000.0n 0.4508 9599.5n 0.4508 9600.0n 0.4577 10199.5n 0.4577 10200.0n 0.4578 10799.5n 0.4578 10800.0n 0.4708 11399.5n 0.4708 11400.0n 0.4479 11999.5n 0.4479 12000.0n 0.4313 12599.5n 0.4313 12600.0n 0.4591 13199.5n 0.4591 13200.0n 0.4225 13799.5n 0.4225 13800.0n 0.4321 14399.5n 0.4321 14400.0n 0.4458 14999.5n 0.4458 15000.0n 0.4697 15599.5n 0.4697 15600.0n 0.4336 16199.5n 0.4336 16200.0n 0.4210 16799.5n 0.4210 16800.0n 0.4376 17399.5n 0.4376 17400.0n 0.4254 17999.5n 0.4254 18000.0n 0.5461 18599.5n 0.5461 18600.0n 0.4225 19199.5n 0.4225 19200.0n 0.5416 19799.5n 0.5416 19800.0n 0.5020 20399.5n 0.5020 20400.0n 0.5535 20999.5n 0.5535 21000.0n 0.4973 21599.5n 0.4973 21600.0n 0.4682 22199.5n 0.4682 22200.0n 0.4270 22799.5n 0.4270 22800.0n 0.5677 23399.5n 0.5677 23400.0n 0.3460 23999.5n 0.3460 24000.0n 0.5344 24599.5n 0.5344 24600.0n 0.4121 25199.5n 0.4121 25200.0n 0.5540 25799.5n 0.5540 25800.0n 0.5754 26399.5n 0.5754 26400.0n 0.5714 26999.5n 0.5714 27000.0n 0.5581 27599.5n 0.5581 27600.0n 0.5707 28199.5n 0.5707 28200.0n 0.3486 28799.5n 0.3486 28800.0n 0.5612 29399.5n 0.5612 29400.0n 0.4864 29999.5n 0.4864 30000.0n 0.4672 30599.5n 0.4672 30600.0n 0.3696 31199.5n 0.3696 31200.0n 0.3617 31799.5n 0.3617 31800.0n 0.5673 32399.5n 0.5673 32400.0n 0.5773 32999.5n 0.5773 33000.0n 0.5439 33599.5n 0.5439 33600.0n 0.5583 34199.5n 0.5583 34200.0n 0.3974 34799.5n 0.3974 34800.0n 0.4317 35399.5n 0.4317 35400.0n 0.5486 35999.5n 0.5486)
Cwp_wih_0_36 wp_wih_0_36 0 400p
Cwn_wih_0_36 wn_wih_0_36 0 400p
Xu_wih_0_36 xp_wih_0_36 xn_wih_0_36 yp_wih_0_36 yn_wih_0_36 wp_wih_0_36 wn_wih_0_36 vdd gbn gprod
Vxp_wih_1_36 xp_wih_1_36 0 PWL(0.0n 0.5370 599.5n 0.5370 600.0n 0.5167 1199.5n 0.5167 1200.0n 0.4793 1799.5n 0.4793 1800.0n 0.4441 2399.5n 0.4441 2400.0n 0.4555 2999.5n 0.4555 3000.0n 0.5055 3599.5n 0.5055 3600.0n 0.4939 4199.5n 0.4939 4200.0n 0.5385 4799.5n 0.5385 4800.0n 0.5024 5399.5n 0.5024 5400.0n 0.5015 5999.5n 0.5015 6000.0n 0.4700 6599.5n 0.4700 6600.0n 0.5120 7199.5n 0.5120 7200.0n 0.5006 7799.5n 0.5006 7800.0n 0.4950 8399.5n 0.4950 8400.0n 0.5309 8999.5n 0.5309 9000.0n 0.5023 9599.5n 0.5023 9600.0n 0.4893 10199.5n 0.4893 10200.0n 0.4837 10799.5n 0.4837 10800.0n 0.4823 11399.5n 0.4823 11400.0n 0.5074 11999.5n 0.5074 12000.0n 0.5364 12599.5n 0.5364 12600.0n 0.4868 13199.5n 0.4868 13200.0n 0.5380 13799.5n 0.5380 13800.0n 0.5220 14399.5n 0.5220 14400.0n 0.5095 14999.5n 0.5095 15000.0n 0.4705 15599.5n 0.4705 15600.0n 0.5289 16199.5n 0.5289 16200.0n 0.5368 16799.5n 0.5368 16800.0n 0.5287 17399.5n 0.5287 17400.0n 0.5342 17999.5n 0.5342 18000.0n 0.4253 18599.5n 0.4253 18600.0n 0.5119 19199.5n 0.5119 19200.0n 0.4104 19799.5n 0.4104 19800.0n 0.4314 20399.5n 0.4314 20400.0n 0.4005 20999.5n 0.4005 21000.0n 0.4696 21599.5n 0.4696 21600.0n 0.4531 22199.5n 0.4531 22200.0n 0.5039 22799.5n 0.5039 22800.0n 0.3608 23399.5n 0.3608 23400.0n 0.6273 23999.5n 0.6273 24000.0n 0.3928 24599.5n 0.3928 24600.0n 0.5253 25199.5n 0.5253 25200.0n 0.4107 25799.5n 0.4107 25800.0n 0.3947 26399.5n 0.3947 26400.0n 0.3716 26999.5n 0.3716 27000.0n 0.4111 27599.5n 0.4111 27600.0n 0.3715 28199.5n 0.3715 28200.0n 0.5939 28799.5n 0.5939 28800.0n 0.3849 29399.5n 0.3849 29400.0n 0.4835 29999.5n 0.4835 30000.0n 0.5119 30599.5n 0.5119 30600.0n 0.6226 31199.5n 0.6226 31200.0n 0.6064 31799.5n 0.6064 31800.0n 0.4115 32399.5n 0.4115 32400.0n 0.3900 32999.5n 0.3900 33000.0n 0.3958 33599.5n 0.3958 33600.0n 0.3747 34199.5n 0.3747 34200.0n 0.5423 34799.5n 0.5423 34800.0n 0.5509 35399.5n 0.5509 35400.0n 0.3990 35999.5n 0.3990)
Vxn_wih_1_36 xn_wih_1_36 0 PWL(0.0n 0.4630 599.5n 0.4630 600.0n 0.4833 1199.5n 0.4833 1200.0n 0.5207 1799.5n 0.5207 1800.0n 0.5559 2399.5n 0.5559 2400.0n 0.5445 2999.5n 0.5445 3000.0n 0.4945 3599.5n 0.4945 3600.0n 0.5061 4199.5n 0.5061 4200.0n 0.4615 4799.5n 0.4615 4800.0n 0.4976 5399.5n 0.4976 5400.0n 0.4985 5999.5n 0.4985 6000.0n 0.5300 6599.5n 0.5300 6600.0n 0.4880 7199.5n 0.4880 7200.0n 0.4994 7799.5n 0.4994 7800.0n 0.5050 8399.5n 0.5050 8400.0n 0.4691 8999.5n 0.4691 9000.0n 0.4977 9599.5n 0.4977 9600.0n 0.5107 10199.5n 0.5107 10200.0n 0.5163 10799.5n 0.5163 10800.0n 0.5177 11399.5n 0.5177 11400.0n 0.4926 11999.5n 0.4926 12000.0n 0.4636 12599.5n 0.4636 12600.0n 0.5132 13199.5n 0.5132 13200.0n 0.4620 13799.5n 0.4620 13800.0n 0.4780 14399.5n 0.4780 14400.0n 0.4905 14999.5n 0.4905 15000.0n 0.5295 15599.5n 0.5295 15600.0n 0.4711 16199.5n 0.4711 16200.0n 0.4632 16799.5n 0.4632 16800.0n 0.4713 17399.5n 0.4713 17400.0n 0.4658 17999.5n 0.4658 18000.0n 0.5747 18599.5n 0.5747 18600.0n 0.4881 19199.5n 0.4881 19200.0n 0.5896 19799.5n 0.5896 19800.0n 0.5686 20399.5n 0.5686 20400.0n 0.5995 20999.5n 0.5995 21000.0n 0.5304 21599.5n 0.5304 21600.0n 0.5469 22199.5n 0.5469 22200.0n 0.4961 22799.5n 0.4961 22800.0n 0.6392 23399.5n 0.6392 23400.0n 0.3727 23999.5n 0.3727 24000.0n 0.6072 24599.5n 0.6072 24600.0n 0.4747 25199.5n 0.4747 25200.0n 0.5893 25799.5n 0.5893 25800.0n 0.6053 26399.5n 0.6053 26400.0n 0.6284 26999.5n 0.6284 27000.0n 0.5889 27599.5n 0.5889 27600.0n 0.6285 28199.5n 0.6285 28200.0n 0.4061 28799.5n 0.4061 28800.0n 0.6151 29399.5n 0.6151 29400.0n 0.5165 29999.5n 0.5165 30000.0n 0.4881 30599.5n 0.4881 30600.0n 0.3774 31199.5n 0.3774 31200.0n 0.3936 31799.5n 0.3936 31800.0n 0.5885 32399.5n 0.5885 32400.0n 0.6100 32999.5n 0.6100 33000.0n 0.6042 33599.5n 0.6042 33600.0n 0.6253 34199.5n 0.6253 34200.0n 0.4577 34799.5n 0.4577 34800.0n 0.4491 35399.5n 0.4491 35400.0n 0.6010 35999.5n 0.6010)
Vyp_wih_1_36 yp_wih_1_36 0 PWL(0.0n 0.5753 599.5n 0.5753 600.0n 0.5686 1199.5n 0.5686 1200.0n 0.5291 1799.5n 0.5291 1800.0n 0.4994 2399.5n 0.4994 2400.0n 0.5163 2999.5n 0.5163 3000.0n 0.5539 3599.5n 0.5539 3600.0n 0.5394 4199.5n 0.5394 4200.0n 0.5758 4799.5n 0.5758 4800.0n 0.5490 5399.5n 0.5490 5400.0n 0.5487 5999.5n 0.5487 6000.0n 0.5222 6599.5n 0.5222 6600.0n 0.5542 7199.5n 0.5542 7200.0n 0.5562 7799.5n 0.5562 7800.0n 0.5529 8399.5n 0.5529 8400.0n 0.5652 8999.5n 0.5652 9000.0n 0.5492 9599.5n 0.5492 9600.0n 0.5423 10199.5n 0.5423 10200.0n 0.5422 10799.5n 0.5422 10800.0n 0.5292 11399.5n 0.5292 11400.0n 0.5521 11999.5n 0.5521 12000.0n 0.5687 12599.5n 0.5687 12600.0n 0.5409 13199.5n 0.5409 13200.0n 0.5775 13799.5n 0.5775 13800.0n 0.5679 14399.5n 0.5679 14400.0n 0.5542 14999.5n 0.5542 15000.0n 0.5303 15599.5n 0.5303 15600.0n 0.5664 16199.5n 0.5664 16200.0n 0.5790 16799.5n 0.5790 16800.0n 0.5624 17399.5n 0.5624 17400.0n 0.5746 17999.5n 0.5746 18000.0n 0.4539 18599.5n 0.4539 18600.0n 0.5775 19199.5n 0.5775 19200.0n 0.4584 19799.5n 0.4584 19800.0n 0.4980 20399.5n 0.4980 20400.0n 0.4465 20999.5n 0.4465 21000.0n 0.5027 21599.5n 0.5027 21600.0n 0.5318 22199.5n 0.5318 22200.0n 0.5730 22799.5n 0.5730 22800.0n 0.4323 23399.5n 0.4323 23400.0n 0.6540 23999.5n 0.6540 24000.0n 0.4656 24599.5n 0.4656 24600.0n 0.5879 25199.5n 0.5879 25200.0n 0.4460 25799.5n 0.4460 25800.0n 0.4246 26399.5n 0.4246 26400.0n 0.4286 26999.5n 0.4286 27000.0n 0.4419 27599.5n 0.4419 27600.0n 0.4293 28199.5n 0.4293 28200.0n 0.6514 28799.5n 0.6514 28800.0n 0.4388 29399.5n 0.4388 29400.0n 0.5136 29999.5n 0.5136 30000.0n 0.5328 30599.5n 0.5328 30600.0n 0.6304 31199.5n 0.6304 31200.0n 0.6383 31799.5n 0.6383 31800.0n 0.4327 32399.5n 0.4327 32400.0n 0.4227 32999.5n 0.4227 33000.0n 0.4561 33599.5n 0.4561 33600.0n 0.4417 34199.5n 0.4417 34200.0n 0.6026 34799.5n 0.6026 34800.0n 0.5683 35399.5n 0.5683 35400.0n 0.4514 35999.5n 0.4514)
Vyn_wih_1_36 yn_wih_1_36 0 PWL(0.0n 0.4247 599.5n 0.4247 600.0n 0.4314 1199.5n 0.4314 1200.0n 0.4709 1799.5n 0.4709 1800.0n 0.5006 2399.5n 0.5006 2400.0n 0.4837 2999.5n 0.4837 3000.0n 0.4461 3599.5n 0.4461 3600.0n 0.4606 4199.5n 0.4606 4200.0n 0.4242 4799.5n 0.4242 4800.0n 0.4510 5399.5n 0.4510 5400.0n 0.4513 5999.5n 0.4513 6000.0n 0.4778 6599.5n 0.4778 6600.0n 0.4458 7199.5n 0.4458 7200.0n 0.4438 7799.5n 0.4438 7800.0n 0.4471 8399.5n 0.4471 8400.0n 0.4348 8999.5n 0.4348 9000.0n 0.4508 9599.5n 0.4508 9600.0n 0.4577 10199.5n 0.4577 10200.0n 0.4578 10799.5n 0.4578 10800.0n 0.4708 11399.5n 0.4708 11400.0n 0.4479 11999.5n 0.4479 12000.0n 0.4313 12599.5n 0.4313 12600.0n 0.4591 13199.5n 0.4591 13200.0n 0.4225 13799.5n 0.4225 13800.0n 0.4321 14399.5n 0.4321 14400.0n 0.4458 14999.5n 0.4458 15000.0n 0.4697 15599.5n 0.4697 15600.0n 0.4336 16199.5n 0.4336 16200.0n 0.4210 16799.5n 0.4210 16800.0n 0.4376 17399.5n 0.4376 17400.0n 0.4254 17999.5n 0.4254 18000.0n 0.5461 18599.5n 0.5461 18600.0n 0.4225 19199.5n 0.4225 19200.0n 0.5416 19799.5n 0.5416 19800.0n 0.5020 20399.5n 0.5020 20400.0n 0.5535 20999.5n 0.5535 21000.0n 0.4973 21599.5n 0.4973 21600.0n 0.4682 22199.5n 0.4682 22200.0n 0.4270 22799.5n 0.4270 22800.0n 0.5677 23399.5n 0.5677 23400.0n 0.3460 23999.5n 0.3460 24000.0n 0.5344 24599.5n 0.5344 24600.0n 0.4121 25199.5n 0.4121 25200.0n 0.5540 25799.5n 0.5540 25800.0n 0.5754 26399.5n 0.5754 26400.0n 0.5714 26999.5n 0.5714 27000.0n 0.5581 27599.5n 0.5581 27600.0n 0.5707 28199.5n 0.5707 28200.0n 0.3486 28799.5n 0.3486 28800.0n 0.5612 29399.5n 0.5612 29400.0n 0.4864 29999.5n 0.4864 30000.0n 0.4672 30599.5n 0.4672 30600.0n 0.3696 31199.5n 0.3696 31200.0n 0.3617 31799.5n 0.3617 31800.0n 0.5673 32399.5n 0.5673 32400.0n 0.5773 32999.5n 0.5773 33000.0n 0.5439 33599.5n 0.5439 33600.0n 0.5583 34199.5n 0.5583 34200.0n 0.3974 34799.5n 0.3974 34800.0n 0.4317 35399.5n 0.4317 35400.0n 0.5486 35999.5n 0.5486)
Cwp_wih_1_36 wp_wih_1_36 0 400p
Cwn_wih_1_36 wn_wih_1_36 0 400p
Xu_wih_1_36 xp_wih_1_36 xn_wih_1_36 yp_wih_1_36 yn_wih_1_36 wp_wih_1_36 wn_wih_1_36 vdd gbn gprod
Vxp_who_36_0 xp_who_36_0 0 PWL(0.0n 0.5753 599.5n 0.5753 600.0n 0.5686 1199.5n 0.5686 1200.0n 0.5291 1799.5n 0.5291 1800.0n 0.4994 2399.5n 0.4994 2400.0n 0.5163 2999.5n 0.5163 3000.0n 0.5539 3599.5n 0.5539 3600.0n 0.5394 4199.5n 0.5394 4200.0n 0.5758 4799.5n 0.5758 4800.0n 0.5490 5399.5n 0.5490 5400.0n 0.5487 5999.5n 0.5487 6000.0n 0.5222 6599.5n 0.5222 6600.0n 0.5542 7199.5n 0.5542 7200.0n 0.5562 7799.5n 0.5562 7800.0n 0.5529 8399.5n 0.5529 8400.0n 0.5652 8999.5n 0.5652 9000.0n 0.5492 9599.5n 0.5492 9600.0n 0.5423 10199.5n 0.5423 10200.0n 0.5422 10799.5n 0.5422 10800.0n 0.5292 11399.5n 0.5292 11400.0n 0.5521 11999.5n 0.5521 12000.0n 0.5687 12599.5n 0.5687 12600.0n 0.5409 13199.5n 0.5409 13200.0n 0.5775 13799.5n 0.5775 13800.0n 0.5679 14399.5n 0.5679 14400.0n 0.5542 14999.5n 0.5542 15000.0n 0.5303 15599.5n 0.5303 15600.0n 0.5664 16199.5n 0.5664 16200.0n 0.5790 16799.5n 0.5790 16800.0n 0.5624 17399.5n 0.5624 17400.0n 0.5746 17999.5n 0.5746 18000.0n 0.4539 18599.5n 0.4539 18600.0n 0.5775 19199.5n 0.5775 19200.0n 0.4584 19799.5n 0.4584 19800.0n 0.4980 20399.5n 0.4980 20400.0n 0.4465 20999.5n 0.4465 21000.0n 0.5027 21599.5n 0.5027 21600.0n 0.5318 22199.5n 0.5318 22200.0n 0.5730 22799.5n 0.5730 22800.0n 0.4323 23399.5n 0.4323 23400.0n 0.6540 23999.5n 0.6540 24000.0n 0.4656 24599.5n 0.4656 24600.0n 0.5879 25199.5n 0.5879 25200.0n 0.4460 25799.5n 0.4460 25800.0n 0.4246 26399.5n 0.4246 26400.0n 0.4286 26999.5n 0.4286 27000.0n 0.4419 27599.5n 0.4419 27600.0n 0.4293 28199.5n 0.4293 28200.0n 0.6514 28799.5n 0.6514 28800.0n 0.4388 29399.5n 0.4388 29400.0n 0.5136 29999.5n 0.5136 30000.0n 0.5328 30599.5n 0.5328 30600.0n 0.6304 31199.5n 0.6304 31200.0n 0.6383 31799.5n 0.6383 31800.0n 0.4327 32399.5n 0.4327 32400.0n 0.4227 32999.5n 0.4227 33000.0n 0.4561 33599.5n 0.4561 33600.0n 0.4417 34199.5n 0.4417 34200.0n 0.6026 34799.5n 0.6026 34800.0n 0.5683 35399.5n 0.5683 35400.0n 0.4514 35999.5n 0.4514)
Vxn_who_36_0 xn_who_36_0 0 PWL(0.0n 0.4247 599.5n 0.4247 600.0n 0.4314 1199.5n 0.4314 1200.0n 0.4709 1799.5n 0.4709 1800.0n 0.5006 2399.5n 0.5006 2400.0n 0.4837 2999.5n 0.4837 3000.0n 0.4461 3599.5n 0.4461 3600.0n 0.4606 4199.5n 0.4606 4200.0n 0.4242 4799.5n 0.4242 4800.0n 0.4510 5399.5n 0.4510 5400.0n 0.4513 5999.5n 0.4513 6000.0n 0.4778 6599.5n 0.4778 6600.0n 0.4458 7199.5n 0.4458 7200.0n 0.4438 7799.5n 0.4438 7800.0n 0.4471 8399.5n 0.4471 8400.0n 0.4348 8999.5n 0.4348 9000.0n 0.4508 9599.5n 0.4508 9600.0n 0.4577 10199.5n 0.4577 10200.0n 0.4578 10799.5n 0.4578 10800.0n 0.4708 11399.5n 0.4708 11400.0n 0.4479 11999.5n 0.4479 12000.0n 0.4313 12599.5n 0.4313 12600.0n 0.4591 13199.5n 0.4591 13200.0n 0.4225 13799.5n 0.4225 13800.0n 0.4321 14399.5n 0.4321 14400.0n 0.4458 14999.5n 0.4458 15000.0n 0.4697 15599.5n 0.4697 15600.0n 0.4336 16199.5n 0.4336 16200.0n 0.4210 16799.5n 0.4210 16800.0n 0.4376 17399.5n 0.4376 17400.0n 0.4254 17999.5n 0.4254 18000.0n 0.5461 18599.5n 0.5461 18600.0n 0.4225 19199.5n 0.4225 19200.0n 0.5416 19799.5n 0.5416 19800.0n 0.5020 20399.5n 0.5020 20400.0n 0.5535 20999.5n 0.5535 21000.0n 0.4973 21599.5n 0.4973 21600.0n 0.4682 22199.5n 0.4682 22200.0n 0.4270 22799.5n 0.4270 22800.0n 0.5677 23399.5n 0.5677 23400.0n 0.3460 23999.5n 0.3460 24000.0n 0.5344 24599.5n 0.5344 24600.0n 0.4121 25199.5n 0.4121 25200.0n 0.5540 25799.5n 0.5540 25800.0n 0.5754 26399.5n 0.5754 26400.0n 0.5714 26999.5n 0.5714 27000.0n 0.5581 27599.5n 0.5581 27600.0n 0.5707 28199.5n 0.5707 28200.0n 0.3486 28799.5n 0.3486 28800.0n 0.5612 29399.5n 0.5612 29400.0n 0.4864 29999.5n 0.4864 30000.0n 0.4672 30599.5n 0.4672 30600.0n 0.3696 31199.5n 0.3696 31200.0n 0.3617 31799.5n 0.3617 31800.0n 0.5673 32399.5n 0.5673 32400.0n 0.5773 32999.5n 0.5773 33000.0n 0.5439 33599.5n 0.5439 33600.0n 0.5583 34199.5n 0.5583 34200.0n 0.3974 34799.5n 0.3974 34800.0n 0.4317 35399.5n 0.4317 35400.0n 0.5486 35999.5n 0.5486)
Vyp_who_36_0 yp_who_36_0 0 PWL(0.0n 0.5031 599.5n 0.5031 600.0n 0.5023 1199.5n 0.5023 1200.0n 0.5052 1799.5n 0.5052 1800.0n 0.5048 2399.5n 0.5048 2400.0n 0.5043 2999.5n 0.5043 3000.0n 0.5034 3599.5n 0.5034 3600.0n 0.5048 4199.5n 0.5048 4200.0n 0.5031 4799.5n 0.5031 4800.0n 0.5040 5399.5n 0.5040 5400.0n 0.5040 5999.5n 0.5040 6000.0n 0.5054 6599.5n 0.5054 6600.0n 0.5040 7199.5n 0.5040 7200.0n 0.5027 7799.5n 0.5027 7800.0n 0.5027 8399.5n 0.5027 8400.0n 0.5038 8999.5n 0.5038 9000.0n 0.5040 9599.5n 0.5040 9600.0n 0.5039 10199.5n 0.5039 10200.0n 0.5033 10799.5n 0.5033 10800.0n 0.5056 11399.5n 0.5056 11400.0n 0.5040 11999.5n 0.5040 12000.0n 0.5036 12599.5n 0.5036 12600.0n 0.5039 13199.5n 0.5039 13200.0n 0.5029 13799.5n 0.5029 13800.0n 0.5025 14399.5n 0.5025 14400.0n 0.5038 14999.5n 0.5038 15000.0n 0.5041 15599.5n 0.5041 15600.0n 0.5036 16199.5n 0.5036 16200.0n 0.5025 16799.5n 0.5025 16800.0n 0.5040 17399.5n 0.5040 17400.0n 0.5029 17999.5n 0.5029 18000.0n 0.5057 18599.5n 0.5057 18600.0n 0.5010 19199.5n 0.5010 19200.0n 0.5041 19799.5n 0.5041 19800.0n 0.5021 20399.5n 0.5021 20400.0n 0.5044 20999.5n 0.5044 21000.0n 0.5056 21599.5n 0.5056 21600.0n 0.5016 22199.5n 0.5016 22200.0n 0.5006 22799.5n 0.5006 22800.0n 0.5041 23399.5n 0.5041 23400.0n 0.5027 23999.5n 0.5027 24000.0n 0.5029 24599.5n 0.5029 24600.0n 0.5006 25199.5n 0.5006 25200.0n 0.5047 25799.5n 0.5047 25800.0n 0.5046 26399.5n 0.5046 26400.0n 0.5039 26999.5n 0.5039 27000.0n 0.5049 27599.5n 0.5049 27600.0n 0.5039 28199.5n 0.5039 28200.0n 0.5017 28799.5n 0.5017 28800.0n 0.5042 29399.5n 0.5042 29400.0n 0.5056 29999.5n 0.5056 30000.0n 0.5051 30599.5n 0.5051 30600.0n 0.5039 31199.5n 0.5039 31200.0n 0.5033 31799.5n 0.5033 31800.0n 0.5049 32399.5n 0.5049 32400.0n 0.5045 32999.5n 0.5045 33000.0n 0.5036 33599.5n 0.5036 33600.0n 0.5042 34199.5n 0.5042 34200.0n 0.5012 34799.5n 0.5012 34800.0n 0.5036 35399.5n 0.5036 35400.0n 0.5042 35999.5n 0.5042)
Vyn_who_36_0 yn_who_36_0 0 PWL(0.0n 0.4969 599.5n 0.4969 600.0n 0.4977 1199.5n 0.4977 1200.0n 0.4948 1799.5n 0.4948 1800.0n 0.4952 2399.5n 0.4952 2400.0n 0.4957 2999.5n 0.4957 3000.0n 0.4966 3599.5n 0.4966 3600.0n 0.4952 4199.5n 0.4952 4200.0n 0.4969 4799.5n 0.4969 4800.0n 0.4960 5399.5n 0.4960 5400.0n 0.4960 5999.5n 0.4960 6000.0n 0.4946 6599.5n 0.4946 6600.0n 0.4960 7199.5n 0.4960 7200.0n 0.4973 7799.5n 0.4973 7800.0n 0.4973 8399.5n 0.4973 8400.0n 0.4962 8999.5n 0.4962 9000.0n 0.4960 9599.5n 0.4960 9600.0n 0.4961 10199.5n 0.4961 10200.0n 0.4967 10799.5n 0.4967 10800.0n 0.4944 11399.5n 0.4944 11400.0n 0.4960 11999.5n 0.4960 12000.0n 0.4964 12599.5n 0.4964 12600.0n 0.4961 13199.5n 0.4961 13200.0n 0.4971 13799.5n 0.4971 13800.0n 0.4975 14399.5n 0.4975 14400.0n 0.4962 14999.5n 0.4962 15000.0n 0.4959 15599.5n 0.4959 15600.0n 0.4964 16199.5n 0.4964 16200.0n 0.4975 16799.5n 0.4975 16800.0n 0.4960 17399.5n 0.4960 17400.0n 0.4971 17999.5n 0.4971 18000.0n 0.4943 18599.5n 0.4943 18600.0n 0.4990 19199.5n 0.4990 19200.0n 0.4959 19799.5n 0.4959 19800.0n 0.4979 20399.5n 0.4979 20400.0n 0.4956 20999.5n 0.4956 21000.0n 0.4944 21599.5n 0.4944 21600.0n 0.4984 22199.5n 0.4984 22200.0n 0.4994 22799.5n 0.4994 22800.0n 0.4959 23399.5n 0.4959 23400.0n 0.4973 23999.5n 0.4973 24000.0n 0.4971 24599.5n 0.4971 24600.0n 0.4994 25199.5n 0.4994 25200.0n 0.4953 25799.5n 0.4953 25800.0n 0.4954 26399.5n 0.4954 26400.0n 0.4961 26999.5n 0.4961 27000.0n 0.4951 27599.5n 0.4951 27600.0n 0.4961 28199.5n 0.4961 28200.0n 0.4983 28799.5n 0.4983 28800.0n 0.4958 29399.5n 0.4958 29400.0n 0.4944 29999.5n 0.4944 30000.0n 0.4949 30599.5n 0.4949 30600.0n 0.4961 31199.5n 0.4961 31200.0n 0.4967 31799.5n 0.4967 31800.0n 0.4951 32399.5n 0.4951 32400.0n 0.4955 32999.5n 0.4955 33000.0n 0.4964 33599.5n 0.4964 33600.0n 0.4958 34199.5n 0.4958 34200.0n 0.4988 34799.5n 0.4988 34800.0n 0.4964 35399.5n 0.4964 35400.0n 0.4958 35999.5n 0.4958)
Cwp_who_36_0 wp_who_36_0 0 400p
Cwn_who_36_0 wn_who_36_0 0 400p
Xu_who_36_0 xp_who_36_0 xn_who_36_0 yp_who_36_0 yn_who_36_0 wp_who_36_0 wn_who_36_0 vdd gbn gprod
Vxp_who_36_1 xp_who_36_1 0 PWL(0.0n 0.5753 599.5n 0.5753 600.0n 0.5686 1199.5n 0.5686 1200.0n 0.5291 1799.5n 0.5291 1800.0n 0.4994 2399.5n 0.4994 2400.0n 0.5163 2999.5n 0.5163 3000.0n 0.5539 3599.5n 0.5539 3600.0n 0.5394 4199.5n 0.5394 4200.0n 0.5758 4799.5n 0.5758 4800.0n 0.5490 5399.5n 0.5490 5400.0n 0.5487 5999.5n 0.5487 6000.0n 0.5222 6599.5n 0.5222 6600.0n 0.5542 7199.5n 0.5542 7200.0n 0.5562 7799.5n 0.5562 7800.0n 0.5529 8399.5n 0.5529 8400.0n 0.5652 8999.5n 0.5652 9000.0n 0.5492 9599.5n 0.5492 9600.0n 0.5423 10199.5n 0.5423 10200.0n 0.5422 10799.5n 0.5422 10800.0n 0.5292 11399.5n 0.5292 11400.0n 0.5521 11999.5n 0.5521 12000.0n 0.5687 12599.5n 0.5687 12600.0n 0.5409 13199.5n 0.5409 13200.0n 0.5775 13799.5n 0.5775 13800.0n 0.5679 14399.5n 0.5679 14400.0n 0.5542 14999.5n 0.5542 15000.0n 0.5303 15599.5n 0.5303 15600.0n 0.5664 16199.5n 0.5664 16200.0n 0.5790 16799.5n 0.5790 16800.0n 0.5624 17399.5n 0.5624 17400.0n 0.5746 17999.5n 0.5746 18000.0n 0.4539 18599.5n 0.4539 18600.0n 0.5775 19199.5n 0.5775 19200.0n 0.4584 19799.5n 0.4584 19800.0n 0.4980 20399.5n 0.4980 20400.0n 0.4465 20999.5n 0.4465 21000.0n 0.5027 21599.5n 0.5027 21600.0n 0.5318 22199.5n 0.5318 22200.0n 0.5730 22799.5n 0.5730 22800.0n 0.4323 23399.5n 0.4323 23400.0n 0.6540 23999.5n 0.6540 24000.0n 0.4656 24599.5n 0.4656 24600.0n 0.5879 25199.5n 0.5879 25200.0n 0.4460 25799.5n 0.4460 25800.0n 0.4246 26399.5n 0.4246 26400.0n 0.4286 26999.5n 0.4286 27000.0n 0.4419 27599.5n 0.4419 27600.0n 0.4293 28199.5n 0.4293 28200.0n 0.6514 28799.5n 0.6514 28800.0n 0.4388 29399.5n 0.4388 29400.0n 0.5136 29999.5n 0.5136 30000.0n 0.5328 30599.5n 0.5328 30600.0n 0.6304 31199.5n 0.6304 31200.0n 0.6383 31799.5n 0.6383 31800.0n 0.4327 32399.5n 0.4327 32400.0n 0.4227 32999.5n 0.4227 33000.0n 0.4561 33599.5n 0.4561 33600.0n 0.4417 34199.5n 0.4417 34200.0n 0.6026 34799.5n 0.6026 34800.0n 0.5683 35399.5n 0.5683 35400.0n 0.4514 35999.5n 0.4514)
Vxn_who_36_1 xn_who_36_1 0 PWL(0.0n 0.4247 599.5n 0.4247 600.0n 0.4314 1199.5n 0.4314 1200.0n 0.4709 1799.5n 0.4709 1800.0n 0.5006 2399.5n 0.5006 2400.0n 0.4837 2999.5n 0.4837 3000.0n 0.4461 3599.5n 0.4461 3600.0n 0.4606 4199.5n 0.4606 4200.0n 0.4242 4799.5n 0.4242 4800.0n 0.4510 5399.5n 0.4510 5400.0n 0.4513 5999.5n 0.4513 6000.0n 0.4778 6599.5n 0.4778 6600.0n 0.4458 7199.5n 0.4458 7200.0n 0.4438 7799.5n 0.4438 7800.0n 0.4471 8399.5n 0.4471 8400.0n 0.4348 8999.5n 0.4348 9000.0n 0.4508 9599.5n 0.4508 9600.0n 0.4577 10199.5n 0.4577 10200.0n 0.4578 10799.5n 0.4578 10800.0n 0.4708 11399.5n 0.4708 11400.0n 0.4479 11999.5n 0.4479 12000.0n 0.4313 12599.5n 0.4313 12600.0n 0.4591 13199.5n 0.4591 13200.0n 0.4225 13799.5n 0.4225 13800.0n 0.4321 14399.5n 0.4321 14400.0n 0.4458 14999.5n 0.4458 15000.0n 0.4697 15599.5n 0.4697 15600.0n 0.4336 16199.5n 0.4336 16200.0n 0.4210 16799.5n 0.4210 16800.0n 0.4376 17399.5n 0.4376 17400.0n 0.4254 17999.5n 0.4254 18000.0n 0.5461 18599.5n 0.5461 18600.0n 0.4225 19199.5n 0.4225 19200.0n 0.5416 19799.5n 0.5416 19800.0n 0.5020 20399.5n 0.5020 20400.0n 0.5535 20999.5n 0.5535 21000.0n 0.4973 21599.5n 0.4973 21600.0n 0.4682 22199.5n 0.4682 22200.0n 0.4270 22799.5n 0.4270 22800.0n 0.5677 23399.5n 0.5677 23400.0n 0.3460 23999.5n 0.3460 24000.0n 0.5344 24599.5n 0.5344 24600.0n 0.4121 25199.5n 0.4121 25200.0n 0.5540 25799.5n 0.5540 25800.0n 0.5754 26399.5n 0.5754 26400.0n 0.5714 26999.5n 0.5714 27000.0n 0.5581 27599.5n 0.5581 27600.0n 0.5707 28199.5n 0.5707 28200.0n 0.3486 28799.5n 0.3486 28800.0n 0.5612 29399.5n 0.5612 29400.0n 0.4864 29999.5n 0.4864 30000.0n 0.4672 30599.5n 0.4672 30600.0n 0.3696 31199.5n 0.3696 31200.0n 0.3617 31799.5n 0.3617 31800.0n 0.5673 32399.5n 0.5673 32400.0n 0.5773 32999.5n 0.5773 33000.0n 0.5439 33599.5n 0.5439 33600.0n 0.5583 34199.5n 0.5583 34200.0n 0.3974 34799.5n 0.3974 34800.0n 0.4317 35399.5n 0.4317 35400.0n 0.5486 35999.5n 0.5486)
Vyp_who_36_1 yp_who_36_1 0 PWL(0.0n 0.5071 599.5n 0.5071 600.0n 0.5053 1199.5n 0.5053 1200.0n 0.5052 1799.5n 0.5052 1800.0n 0.5027 2399.5n 0.5027 2400.0n 0.5034 2999.5n 0.5034 3000.0n 0.5055 3599.5n 0.5055 3600.0n 0.5056 4199.5n 0.5056 4200.0n 0.5071 4799.5n 0.5071 4800.0n 0.5056 5399.5n 0.5056 5400.0n 0.5056 5999.5n 0.5056 6000.0n 0.5048 6599.5n 0.5048 6600.0n 0.5060 7199.5n 0.5060 7200.0n 0.5048 7799.5n 0.5048 7800.0n 0.5046 8399.5n 0.5046 8400.0n 0.5066 8999.5n 0.5066 9000.0n 0.5056 9599.5n 0.5056 9600.0n 0.5051 10199.5n 0.5051 10200.0n 0.5046 10799.5n 0.5046 10800.0n 0.5056 11399.5n 0.5056 11400.0n 0.5058 11999.5n 0.5058 12000.0n 0.5068 12599.5n 0.5068 12600.0n 0.5050 13199.5n 0.5050 13200.0n 0.5071 13799.5n 0.5071 13800.0n 0.5059 14399.5n 0.5059 14400.0n 0.5058 14999.5n 0.5058 15000.0n 0.5043 15599.5n 0.5043 15600.0n 0.5067 16199.5n 0.5067 16200.0n 0.5068 16799.5n 0.5068 16800.0n 0.5066 17399.5n 0.5066 17400.0n 0.5069 17999.5n 0.5069 18000.0n 0.5061 18599.5n 0.5061 18600.0n 0.5034 19199.5n 0.5034 19200.0n 0.5010 19799.5n 0.5010 19800.0n 0.4989 20399.5n 0.4989 20400.0n 0.5022 20999.5n 0.5022 21000.0n 0.5086 21599.5n 0.5086 21600.0n 0.5007 22199.5n 0.5007 22200.0n 0.5023 22799.5n 0.5023 22800.0n 0.5021 23399.5n 0.5021 23400.0n 0.5077 23999.5n 0.5077 24000.0n 0.4979 24599.5n 0.4979 24600.0n 0.5035 25199.5n 0.5035 25200.0n 0.5041 25799.5n 0.5041 25800.0n 0.5075 26399.5n 0.5075 26400.0n 0.5041 26999.5n 0.5041 27000.0n 0.5056 27599.5n 0.5056 27600.0n 0.5039 28199.5n 0.5039 28200.0n 0.5059 28799.5n 0.5059 28800.0n 0.5023 29399.5n 0.5023 29400.0n 0.5086 29999.5n 0.5086 30000.0n 0.5084 30599.5n 0.5084 30600.0n 0.5085 31199.5n 0.5085 31200.0n 0.5088 31799.5n 0.5088 31800.0n 0.5078 32399.5n 0.5078 32400.0n 0.5074 32999.5n 0.5074 33000.0n 0.4996 33599.5n 0.4996 33600.0n 0.5010 34199.5n 0.5010 34200.0n 0.5044 34799.5n 0.5044 34800.0n 0.5084 35399.5n 0.5084 35400.0n 0.5012 35999.5n 0.5012)
Vyn_who_36_1 yn_who_36_1 0 PWL(0.0n 0.4929 599.5n 0.4929 600.0n 0.4947 1199.5n 0.4947 1200.0n 0.4948 1799.5n 0.4948 1800.0n 0.4973 2399.5n 0.4973 2400.0n 0.4966 2999.5n 0.4966 3000.0n 0.4945 3599.5n 0.4945 3600.0n 0.4944 4199.5n 0.4944 4200.0n 0.4929 4799.5n 0.4929 4800.0n 0.4944 5399.5n 0.4944 5400.0n 0.4944 5999.5n 0.4944 6000.0n 0.4952 6599.5n 0.4952 6600.0n 0.4940 7199.5n 0.4940 7200.0n 0.4952 7799.5n 0.4952 7800.0n 0.4954 8399.5n 0.4954 8400.0n 0.4934 8999.5n 0.4934 9000.0n 0.4944 9599.5n 0.4944 9600.0n 0.4949 10199.5n 0.4949 10200.0n 0.4954 10799.5n 0.4954 10800.0n 0.4944 11399.5n 0.4944 11400.0n 0.4942 11999.5n 0.4942 12000.0n 0.4932 12599.5n 0.4932 12600.0n 0.4950 13199.5n 0.4950 13200.0n 0.4929 13799.5n 0.4929 13800.0n 0.4941 14399.5n 0.4941 14400.0n 0.4942 14999.5n 0.4942 15000.0n 0.4957 15599.5n 0.4957 15600.0n 0.4933 16199.5n 0.4933 16200.0n 0.4932 16799.5n 0.4932 16800.0n 0.4934 17399.5n 0.4934 17400.0n 0.4931 17999.5n 0.4931 18000.0n 0.4939 18599.5n 0.4939 18600.0n 0.4966 19199.5n 0.4966 19200.0n 0.4990 19799.5n 0.4990 19800.0n 0.5011 20399.5n 0.5011 20400.0n 0.4978 20999.5n 0.4978 21000.0n 0.4914 21599.5n 0.4914 21600.0n 0.4993 22199.5n 0.4993 22200.0n 0.4977 22799.5n 0.4977 22800.0n 0.4979 23399.5n 0.4979 23400.0n 0.4923 23999.5n 0.4923 24000.0n 0.5021 24599.5n 0.5021 24600.0n 0.4965 25199.5n 0.4965 25200.0n 0.4959 25799.5n 0.4959 25800.0n 0.4925 26399.5n 0.4925 26400.0n 0.4959 26999.5n 0.4959 27000.0n 0.4944 27599.5n 0.4944 27600.0n 0.4961 28199.5n 0.4961 28200.0n 0.4941 28799.5n 0.4941 28800.0n 0.4977 29399.5n 0.4977 29400.0n 0.4914 29999.5n 0.4914 30000.0n 0.4916 30599.5n 0.4916 30600.0n 0.4915 31199.5n 0.4915 31200.0n 0.4912 31799.5n 0.4912 31800.0n 0.4922 32399.5n 0.4922 32400.0n 0.4926 32999.5n 0.4926 33000.0n 0.5004 33599.5n 0.5004 33600.0n 0.4990 34199.5n 0.4990 34200.0n 0.4956 34799.5n 0.4956 34800.0n 0.4916 35399.5n 0.4916 35400.0n 0.4988 35999.5n 0.4988)
Cwp_who_36_1 wp_who_36_1 0 400p
Cwn_who_36_1 wn_who_36_1 0 400p
Xu_who_36_1 xp_who_36_1 xn_who_36_1 yp_who_36_1 yn_who_36_1 wp_who_36_1 wn_who_36_1 vdd gbn gprod
Vxp_bh_36 xp_bh_36 0 PWL(0.0n 0.7100 599.5n 0.7100 600.0n 0.7100 1199.5n 0.7100 1200.0n 0.7100 1799.5n 0.7100 1800.0n 0.7100 2399.5n 0.7100 2400.0n 0.7100 2999.5n 0.7100 3000.0n 0.7100 3599.5n 0.7100 3600.0n 0.7100 4199.5n 0.7100 4200.0n 0.7100 4799.5n 0.7100 4800.0n 0.7100 5399.5n 0.7100 5400.0n 0.7100 5999.5n 0.7100 6000.0n 0.7100 6599.5n 0.7100 6600.0n 0.7100 7199.5n 0.7100 7200.0n 0.7100 7799.5n 0.7100 7800.0n 0.7100 8399.5n 0.7100 8400.0n 0.7100 8999.5n 0.7100 9000.0n 0.7100 9599.5n 0.7100 9600.0n 0.7100 10199.5n 0.7100 10200.0n 0.7100 10799.5n 0.7100 10800.0n 0.7100 11399.5n 0.7100 11400.0n 0.7100 11999.5n 0.7100 12000.0n 0.7100 12599.5n 0.7100 12600.0n 0.7100 13199.5n 0.7100 13200.0n 0.7100 13799.5n 0.7100 13800.0n 0.7100 14399.5n 0.7100 14400.0n 0.7100 14999.5n 0.7100 15000.0n 0.7100 15599.5n 0.7100 15600.0n 0.7100 16199.5n 0.7100 16200.0n 0.7100 16799.5n 0.7100 16800.0n 0.7100 17399.5n 0.7100 17400.0n 0.7100 17999.5n 0.7100 18000.0n 0.7100 18599.5n 0.7100 18600.0n 0.7100 19199.5n 0.7100 19200.0n 0.7100 19799.5n 0.7100 19800.0n 0.7100 20399.5n 0.7100 20400.0n 0.7100 20999.5n 0.7100 21000.0n 0.7100 21599.5n 0.7100 21600.0n 0.7100 22199.5n 0.7100 22200.0n 0.7100 22799.5n 0.7100 22800.0n 0.7100 23399.5n 0.7100 23400.0n 0.7100 23999.5n 0.7100 24000.0n 0.7100 24599.5n 0.7100 24600.0n 0.7100 25199.5n 0.7100 25200.0n 0.7100 25799.5n 0.7100 25800.0n 0.7100 26399.5n 0.7100 26400.0n 0.7100 26999.5n 0.7100 27000.0n 0.7100 27599.5n 0.7100 27600.0n 0.7100 28199.5n 0.7100 28200.0n 0.7100 28799.5n 0.7100 28800.0n 0.7100 29399.5n 0.7100 29400.0n 0.7100 29999.5n 0.7100 30000.0n 0.7100 30599.5n 0.7100 30600.0n 0.7100 31199.5n 0.7100 31200.0n 0.7100 31799.5n 0.7100 31800.0n 0.7100 32399.5n 0.7100 32400.0n 0.7100 32999.5n 0.7100 33000.0n 0.7100 33599.5n 0.7100 33600.0n 0.7100 34199.5n 0.7100 34200.0n 0.7100 34799.5n 0.7100 34800.0n 0.7100 35399.5n 0.7100 35400.0n 0.7100 35999.5n 0.7100)
Vxn_bh_36 xn_bh_36 0 PWL(0.0n 0.2900 599.5n 0.2900 600.0n 0.2900 1199.5n 0.2900 1200.0n 0.2900 1799.5n 0.2900 1800.0n 0.2900 2399.5n 0.2900 2400.0n 0.2900 2999.5n 0.2900 3000.0n 0.2900 3599.5n 0.2900 3600.0n 0.2900 4199.5n 0.2900 4200.0n 0.2900 4799.5n 0.2900 4800.0n 0.2900 5399.5n 0.2900 5400.0n 0.2900 5999.5n 0.2900 6000.0n 0.2900 6599.5n 0.2900 6600.0n 0.2900 7199.5n 0.2900 7200.0n 0.2900 7799.5n 0.2900 7800.0n 0.2900 8399.5n 0.2900 8400.0n 0.2900 8999.5n 0.2900 9000.0n 0.2900 9599.5n 0.2900 9600.0n 0.2900 10199.5n 0.2900 10200.0n 0.2900 10799.5n 0.2900 10800.0n 0.2900 11399.5n 0.2900 11400.0n 0.2900 11999.5n 0.2900 12000.0n 0.2900 12599.5n 0.2900 12600.0n 0.2900 13199.5n 0.2900 13200.0n 0.2900 13799.5n 0.2900 13800.0n 0.2900 14399.5n 0.2900 14400.0n 0.2900 14999.5n 0.2900 15000.0n 0.2900 15599.5n 0.2900 15600.0n 0.2900 16199.5n 0.2900 16200.0n 0.2900 16799.5n 0.2900 16800.0n 0.2900 17399.5n 0.2900 17400.0n 0.2900 17999.5n 0.2900 18000.0n 0.2900 18599.5n 0.2900 18600.0n 0.2900 19199.5n 0.2900 19200.0n 0.2900 19799.5n 0.2900 19800.0n 0.2900 20399.5n 0.2900 20400.0n 0.2900 20999.5n 0.2900 21000.0n 0.2900 21599.5n 0.2900 21600.0n 0.2900 22199.5n 0.2900 22200.0n 0.2900 22799.5n 0.2900 22800.0n 0.2900 23399.5n 0.2900 23400.0n 0.2900 23999.5n 0.2900 24000.0n 0.2900 24599.5n 0.2900 24600.0n 0.2900 25199.5n 0.2900 25200.0n 0.2900 25799.5n 0.2900 25800.0n 0.2900 26399.5n 0.2900 26400.0n 0.2900 26999.5n 0.2900 27000.0n 0.2900 27599.5n 0.2900 27600.0n 0.2900 28199.5n 0.2900 28200.0n 0.2900 28799.5n 0.2900 28800.0n 0.2900 29399.5n 0.2900 29400.0n 0.2900 29999.5n 0.2900 30000.0n 0.2900 30599.5n 0.2900 30600.0n 0.2900 31199.5n 0.2900 31200.0n 0.2900 31799.5n 0.2900 31800.0n 0.2900 32399.5n 0.2900 32400.0n 0.2900 32999.5n 0.2900 33000.0n 0.2900 33599.5n 0.2900 33600.0n 0.2900 34199.5n 0.2900 34200.0n 0.2900 34799.5n 0.2900 34800.0n 0.2900 35399.5n 0.2900 35400.0n 0.2900 35999.5n 0.2900)
Vyp_bh_36 yp_bh_36 0 PWL(0.0n 0.5753 599.5n 0.5753 600.0n 0.5686 1199.5n 0.5686 1200.0n 0.5291 1799.5n 0.5291 1800.0n 0.4994 2399.5n 0.4994 2400.0n 0.5163 2999.5n 0.5163 3000.0n 0.5539 3599.5n 0.5539 3600.0n 0.5394 4199.5n 0.5394 4200.0n 0.5758 4799.5n 0.5758 4800.0n 0.5490 5399.5n 0.5490 5400.0n 0.5487 5999.5n 0.5487 6000.0n 0.5222 6599.5n 0.5222 6600.0n 0.5542 7199.5n 0.5542 7200.0n 0.5562 7799.5n 0.5562 7800.0n 0.5529 8399.5n 0.5529 8400.0n 0.5652 8999.5n 0.5652 9000.0n 0.5492 9599.5n 0.5492 9600.0n 0.5423 10199.5n 0.5423 10200.0n 0.5422 10799.5n 0.5422 10800.0n 0.5292 11399.5n 0.5292 11400.0n 0.5521 11999.5n 0.5521 12000.0n 0.5687 12599.5n 0.5687 12600.0n 0.5409 13199.5n 0.5409 13200.0n 0.5775 13799.5n 0.5775 13800.0n 0.5679 14399.5n 0.5679 14400.0n 0.5542 14999.5n 0.5542 15000.0n 0.5303 15599.5n 0.5303 15600.0n 0.5664 16199.5n 0.5664 16200.0n 0.5790 16799.5n 0.5790 16800.0n 0.5624 17399.5n 0.5624 17400.0n 0.5746 17999.5n 0.5746 18000.0n 0.4539 18599.5n 0.4539 18600.0n 0.5775 19199.5n 0.5775 19200.0n 0.4584 19799.5n 0.4584 19800.0n 0.4980 20399.5n 0.4980 20400.0n 0.4465 20999.5n 0.4465 21000.0n 0.5027 21599.5n 0.5027 21600.0n 0.5318 22199.5n 0.5318 22200.0n 0.5730 22799.5n 0.5730 22800.0n 0.4323 23399.5n 0.4323 23400.0n 0.6540 23999.5n 0.6540 24000.0n 0.4656 24599.5n 0.4656 24600.0n 0.5879 25199.5n 0.5879 25200.0n 0.4460 25799.5n 0.4460 25800.0n 0.4246 26399.5n 0.4246 26400.0n 0.4286 26999.5n 0.4286 27000.0n 0.4419 27599.5n 0.4419 27600.0n 0.4293 28199.5n 0.4293 28200.0n 0.6514 28799.5n 0.6514 28800.0n 0.4388 29399.5n 0.4388 29400.0n 0.5136 29999.5n 0.5136 30000.0n 0.5328 30599.5n 0.5328 30600.0n 0.6304 31199.5n 0.6304 31200.0n 0.6383 31799.5n 0.6383 31800.0n 0.4327 32399.5n 0.4327 32400.0n 0.4227 32999.5n 0.4227 33000.0n 0.4561 33599.5n 0.4561 33600.0n 0.4417 34199.5n 0.4417 34200.0n 0.6026 34799.5n 0.6026 34800.0n 0.5683 35399.5n 0.5683 35400.0n 0.4514 35999.5n 0.4514)
Vyn_bh_36 yn_bh_36 0 PWL(0.0n 0.4247 599.5n 0.4247 600.0n 0.4314 1199.5n 0.4314 1200.0n 0.4709 1799.5n 0.4709 1800.0n 0.5006 2399.5n 0.5006 2400.0n 0.4837 2999.5n 0.4837 3000.0n 0.4461 3599.5n 0.4461 3600.0n 0.4606 4199.5n 0.4606 4200.0n 0.4242 4799.5n 0.4242 4800.0n 0.4510 5399.5n 0.4510 5400.0n 0.4513 5999.5n 0.4513 6000.0n 0.4778 6599.5n 0.4778 6600.0n 0.4458 7199.5n 0.4458 7200.0n 0.4438 7799.5n 0.4438 7800.0n 0.4471 8399.5n 0.4471 8400.0n 0.4348 8999.5n 0.4348 9000.0n 0.4508 9599.5n 0.4508 9600.0n 0.4577 10199.5n 0.4577 10200.0n 0.4578 10799.5n 0.4578 10800.0n 0.4708 11399.5n 0.4708 11400.0n 0.4479 11999.5n 0.4479 12000.0n 0.4313 12599.5n 0.4313 12600.0n 0.4591 13199.5n 0.4591 13200.0n 0.4225 13799.5n 0.4225 13800.0n 0.4321 14399.5n 0.4321 14400.0n 0.4458 14999.5n 0.4458 15000.0n 0.4697 15599.5n 0.4697 15600.0n 0.4336 16199.5n 0.4336 16200.0n 0.4210 16799.5n 0.4210 16800.0n 0.4376 17399.5n 0.4376 17400.0n 0.4254 17999.5n 0.4254 18000.0n 0.5461 18599.5n 0.5461 18600.0n 0.4225 19199.5n 0.4225 19200.0n 0.5416 19799.5n 0.5416 19800.0n 0.5020 20399.5n 0.5020 20400.0n 0.5535 20999.5n 0.5535 21000.0n 0.4973 21599.5n 0.4973 21600.0n 0.4682 22199.5n 0.4682 22200.0n 0.4270 22799.5n 0.4270 22800.0n 0.5677 23399.5n 0.5677 23400.0n 0.3460 23999.5n 0.3460 24000.0n 0.5344 24599.5n 0.5344 24600.0n 0.4121 25199.5n 0.4121 25200.0n 0.5540 25799.5n 0.5540 25800.0n 0.5754 26399.5n 0.5754 26400.0n 0.5714 26999.5n 0.5714 27000.0n 0.5581 27599.5n 0.5581 27600.0n 0.5707 28199.5n 0.5707 28200.0n 0.3486 28799.5n 0.3486 28800.0n 0.5612 29399.5n 0.5612 29400.0n 0.4864 29999.5n 0.4864 30000.0n 0.4672 30599.5n 0.4672 30600.0n 0.3696 31199.5n 0.3696 31200.0n 0.3617 31799.5n 0.3617 31800.0n 0.5673 32399.5n 0.5673 32400.0n 0.5773 32999.5n 0.5773 33000.0n 0.5439 33599.5n 0.5439 33600.0n 0.5583 34199.5n 0.5583 34200.0n 0.3974 34799.5n 0.3974 34800.0n 0.4317 35399.5n 0.4317 35400.0n 0.5486 35999.5n 0.5486)
Cwp_bh_36 wp_bh_36 0 400p
Cwn_bh_36 wn_bh_36 0 400p
Xu_bh_36 xp_bh_36 xn_bh_36 yp_bh_36 yn_bh_36 wp_bh_36 wn_bh_36 vdd gbn gprod
Vxp_wih_0_37 xp_wih_0_37 0 PWL(0.0n 0.4942 599.5n 0.4942 600.0n 0.5558 1199.5n 0.5558 1200.0n 0.4708 1799.5n 0.4708 1800.0n 0.5235 2399.5n 0.5235 2400.0n 0.5350 2999.5n 0.5350 3000.0n 0.5172 3599.5n 0.5172 3600.0n 0.4702 4199.5n 0.4702 4200.0n 0.4867 4799.5n 0.4867 4800.0n 0.4970 5399.5n 0.4970 5400.0n 0.4986 5999.5n 0.4986 6000.0n 0.4751 6599.5n 0.4751 6600.0n 0.4870 7199.5n 0.4870 7200.0n 0.5502 7799.5n 0.5502 7800.0n 0.5521 8399.5n 0.5521 8400.0n 0.4638 8999.5n 0.4638 9000.0n 0.4982 9599.5n 0.4982 9600.0n 0.5131 10199.5n 0.5131 10200.0n 0.5386 10799.5n 0.5386 10800.0n 0.4592 11399.5n 0.4592 11400.0n 0.4950 11999.5n 0.4950 12000.0n 0.4559 12599.5n 0.4559 12600.0n 0.5162 13199.5n 0.5162 13200.0n 0.5038 13799.5n 0.5038 13800.0n 0.5333 14399.5n 0.5333 14400.0n 0.4991 14999.5n 0.4991 15000.0n 0.5298 15599.5n 0.5298 15600.0n 0.4823 16199.5n 0.4823 16200.0n 0.5239 16799.5n 0.5239 16800.0n 0.4592 17399.5n 0.4592 17400.0n 0.5094 17999.5n 0.5094 18000.0n 0.4337 18599.5n 0.4337 18600.0n 0.5977 19199.5n 0.5977 19200.0n 0.5364 19799.5n 0.5364 19800.0n 0.6122 20399.5n 0.6122 20400.0n 0.4856 20999.5n 0.4856 21000.0n 0.3861 21599.5n 0.3861 21600.0n 0.6094 22199.5n 0.6094 22200.0n 0.6364 22799.5n 0.6364 22800.0n 0.4807 23399.5n 0.4807 23400.0n 0.5614 23999.5n 0.5614 24000.0n 0.5913 24599.5n 0.5913 24600.0n 0.6295 25199.5n 0.6295 25200.0n 0.4496 25799.5n 0.4496 25800.0n 0.3792 26399.5n 0.3792 26400.0n 0.4434 26999.5n 0.4434 27000.0n 0.4340 27599.5n 0.4340 27600.0n 0.4461 28199.5n 0.4461 28200.0n 0.5791 28799.5n 0.5791 28800.0n 0.4777 29399.5n 0.4777 29400.0n 0.3878 29999.5n 0.3878 30000.0n 0.3832 30599.5n 0.3832 30600.0n 0.4022 31199.5n 0.4022 31200.0n 0.4482 31799.5n 0.4482 31800.0n 0.3662 32399.5n 0.3662 32400.0n 0.3857 32999.5n 0.3857 33000.0n 0.5584 33599.5n 0.5584 33600.0n 0.5284 34199.5n 0.5284 34200.0n 0.6034 34799.5n 0.6034 34800.0n 0.3469 35399.5n 0.3469 35400.0n 0.5290 35999.5n 0.5290)
Vxn_wih_0_37 xn_wih_0_37 0 PWL(0.0n 0.5058 599.5n 0.5058 600.0n 0.4442 1199.5n 0.4442 1200.0n 0.5292 1799.5n 0.5292 1800.0n 0.4765 2399.5n 0.4765 2400.0n 0.4650 2999.5n 0.4650 3000.0n 0.4828 3599.5n 0.4828 3600.0n 0.5298 4199.5n 0.5298 4200.0n 0.5133 4799.5n 0.5133 4800.0n 0.5030 5399.5n 0.5030 5400.0n 0.5014 5999.5n 0.5014 6000.0n 0.5249 6599.5n 0.5249 6600.0n 0.5130 7199.5n 0.5130 7200.0n 0.4498 7799.5n 0.4498 7800.0n 0.4479 8399.5n 0.4479 8400.0n 0.5362 8999.5n 0.5362 9000.0n 0.5018 9599.5n 0.5018 9600.0n 0.4869 10199.5n 0.4869 10200.0n 0.4614 10799.5n 0.4614 10800.0n 0.5408 11399.5n 0.5408 11400.0n 0.5050 11999.5n 0.5050 12000.0n 0.5441 12599.5n 0.5441 12600.0n 0.4838 13199.5n 0.4838 13200.0n 0.4962 13799.5n 0.4962 13800.0n 0.4667 14399.5n 0.4667 14400.0n 0.5009 14999.5n 0.5009 15000.0n 0.4702 15599.5n 0.4702 15600.0n 0.5177 16199.5n 0.5177 16200.0n 0.4761 16799.5n 0.4761 16800.0n 0.5408 17399.5n 0.5408 17400.0n 0.4906 17999.5n 0.4906 18000.0n 0.5663 18599.5n 0.5663 18600.0n 0.4023 19199.5n 0.4023 19200.0n 0.4636 19799.5n 0.4636 19800.0n 0.3878 20399.5n 0.3878 20400.0n 0.5144 20999.5n 0.5144 21000.0n 0.6139 21599.5n 0.6139 21600.0n 0.3906 22199.5n 0.3906 22200.0n 0.3636 22799.5n 0.3636 22800.0n 0.5193 23399.5n 0.5193 23400.0n 0.4386 23999.5n 0.4386 24000.0n 0.4087 24599.5n 0.4087 24600.0n 0.3705 25199.5n 0.3705 25200.0n 0.5504 25799.5n 0.5504 25800.0n 0.6208 26399.5n 0.6208 26400.0n 0.5566 26999.5n 0.5566 27000.0n 0.5660 27599.5n 0.5660 27600.0n 0.5539 28199.5n 0.5539 28200.0n 0.4209 28799.5n 0.4209 28800.0n 0.5223 29399.5n 0.5223 29400.0n 0.6122 29999.5n 0.6122 30000.0n 0.6168 30599.5n 0.6168 30600.0n 0.5978 31199.5n 0.5978 31200.0n 0.5518 31799.5n 0.5518 31800.0n 0.6338 32399.5n 0.6338 32400.0n 0.6143 32999.5n 0.6143 33000.0n 0.4416 33599.5n 0.4416 33600.0n 0.4716 34199.5n 0.4716 34200.0n 0.3966 34799.5n 0.3966 34800.0n 0.6531 35399.5n 0.6531 35400.0n 0.4710 35999.5n 0.4710)
Vyp_wih_0_37 yp_wih_0_37 0 PWL(0.0n 0.5626 599.5n 0.5626 600.0n 0.5308 1199.5n 0.5308 1200.0n 0.5509 1799.5n 0.5509 1800.0n 0.5182 2399.5n 0.5182 2400.0n 0.5203 2999.5n 0.5203 3000.0n 0.5449 3599.5n 0.5449 3600.0n 0.5559 4199.5n 0.5559 4200.0n 0.5656 4799.5n 0.5656 4800.0n 0.5499 5399.5n 0.5499 5400.0n 0.5492 5999.5n 0.5492 6000.0n 0.5460 6599.5n 0.5460 6600.0n 0.5558 7199.5n 0.5558 7200.0n 0.5294 7799.5n 0.5294 7800.0n 0.5266 8399.5n 0.5266 8400.0n 0.5707 8999.5n 0.5707 9000.0n 0.5495 9599.5n 0.5495 9600.0n 0.5411 10199.5n 0.5411 10200.0n 0.5301 10799.5n 0.5301 10800.0n 0.5565 11399.5n 0.5565 11400.0n 0.5520 11999.5n 0.5520 12000.0n 0.5765 12599.5n 0.5765 12600.0n 0.5393 13199.5n 0.5393 13200.0n 0.5602 13799.5n 0.5602 13800.0n 0.5445 14399.5n 0.5445 14400.0n 0.5515 14999.5n 0.5515 15000.0n 0.5288 15599.5n 0.5288 15600.0n 0.5631 16199.5n 0.5631 16200.0n 0.5533 16799.5n 0.5533 16800.0n 0.5718 17399.5n 0.5718 17400.0n 0.5569 17999.5n 0.5569 18000.0n 0.5403 18599.5n 0.5403 18600.0n 0.5018 19199.5n 0.5018 19200.0n 0.4896 19799.5n 0.4896 19800.0n 0.4629 20399.5n 0.4629 20400.0n 0.5037 20999.5n 0.5037 21000.0n 0.5917 21599.5n 0.5917 21600.0n 0.4789 22199.5n 0.4789 22200.0n 0.4953 22799.5n 0.4953 22800.0n 0.5022 23399.5n 0.5022 23400.0n 0.5723 23999.5n 0.5723 24000.0n 0.4496 24599.5n 0.4496 24600.0n 0.5017 25199.5n 0.5017 25200.0n 0.5217 25799.5n 0.5217 25800.0n 0.5529 26399.5n 0.5529 26400.0n 0.5198 26999.5n 0.5198 27000.0n 0.5336 27599.5n 0.5336 27600.0n 0.5180 28199.5n 0.5180 28200.0n 0.5514 28799.5n 0.5514 28800.0n 0.5037 29399.5n 0.5037 29400.0n 0.5961 29999.5n 0.5961 30000.0n 0.6053 30599.5n 0.6053 30600.0n 0.6466 31199.5n 0.6466 31200.0n 0.6176 31799.5n 0.6176 31800.0n 0.5575 32399.5n 0.5575 32400.0n 0.5514 32999.5n 0.5514 33000.0n 0.4737 33599.5n 0.4737 33600.0n 0.4864 34199.5n 0.4864 34200.0n 0.5108 34799.5n 0.5108 34800.0n 0.6215 35399.5n 0.6215 35400.0n 0.4893 35999.5n 0.4893)
Vyn_wih_0_37 yn_wih_0_37 0 PWL(0.0n 0.4374 599.5n 0.4374 600.0n 0.4692 1199.5n 0.4692 1200.0n 0.4491 1799.5n 0.4491 1800.0n 0.4818 2399.5n 0.4818 2400.0n 0.4797 2999.5n 0.4797 3000.0n 0.4551 3599.5n 0.4551 3600.0n 0.4441 4199.5n 0.4441 4200.0n 0.4344 4799.5n 0.4344 4800.0n 0.4501 5399.5n 0.4501 5400.0n 0.4508 5999.5n 0.4508 6000.0n 0.4540 6599.5n 0.4540 6600.0n 0.4442 7199.5n 0.4442 7200.0n 0.4706 7799.5n 0.4706 7800.0n 0.4734 8399.5n 0.4734 8400.0n 0.4293 8999.5n 0.4293 9000.0n 0.4505 9599.5n 0.4505 9600.0n 0.4589 10199.5n 0.4589 10200.0n 0.4699 10799.5n 0.4699 10800.0n 0.4435 11399.5n 0.4435 11400.0n 0.4480 11999.5n 0.4480 12000.0n 0.4235 12599.5n 0.4235 12600.0n 0.4607 13199.5n 0.4607 13200.0n 0.4398 13799.5n 0.4398 13800.0n 0.4555 14399.5n 0.4555 14400.0n 0.4485 14999.5n 0.4485 15000.0n 0.4712 15599.5n 0.4712 15600.0n 0.4369 16199.5n 0.4369 16200.0n 0.4467 16799.5n 0.4467 16800.0n 0.4282 17399.5n 0.4282 17400.0n 0.4431 17999.5n 0.4431 18000.0n 0.4597 18599.5n 0.4597 18600.0n 0.4982 19199.5n 0.4982 19200.0n 0.5104 19799.5n 0.5104 19800.0n 0.5371 20399.5n 0.5371 20400.0n 0.4963 20999.5n 0.4963 21000.0n 0.4083 21599.5n 0.4083 21600.0n 0.5211 22199.5n 0.5211 22200.0n 0.5047 22799.5n 0.5047 22800.0n 0.4978 23399.5n 0.4978 23400.0n 0.4277 23999.5n 0.4277 24000.0n 0.5504 24599.5n 0.5504 24600.0n 0.4983 25199.5n 0.4983 25200.0n 0.4783 25799.5n 0.4783 25800.0n 0.4471 26399.5n 0.4471 26400.0n 0.4802 26999.5n 0.4802 27000.0n 0.4664 27599.5n 0.4664 27600.0n 0.4820 28199.5n 0.4820 28200.0n 0.4486 28799.5n 0.4486 28800.0n 0.4963 29399.5n 0.4963 29400.0n 0.4039 29999.5n 0.4039 30000.0n 0.3947 30599.5n 0.3947 30600.0n 0.3534 31199.5n 0.3534 31200.0n 0.3824 31799.5n 0.3824 31800.0n 0.4425 32399.5n 0.4425 32400.0n 0.4486 32999.5n 0.4486 33000.0n 0.5263 33599.5n 0.5263 33600.0n 0.5136 34199.5n 0.5136 34200.0n 0.4892 34799.5n 0.4892 34800.0n 0.3785 35399.5n 0.3785 35400.0n 0.5107 35999.5n 0.5107)
Cwp_wih_0_37 wp_wih_0_37 0 400p
Cwn_wih_0_37 wn_wih_0_37 0 400p
Xu_wih_0_37 xp_wih_0_37 xn_wih_0_37 yp_wih_0_37 yn_wih_0_37 wp_wih_0_37 wn_wih_0_37 vdd gbn gprod
Vxp_wih_1_37 xp_wih_1_37 0 PWL(0.0n 0.5370 599.5n 0.5370 600.0n 0.5167 1199.5n 0.5167 1200.0n 0.4793 1799.5n 0.4793 1800.0n 0.4441 2399.5n 0.4441 2400.0n 0.4555 2999.5n 0.4555 3000.0n 0.5055 3599.5n 0.5055 3600.0n 0.4939 4199.5n 0.4939 4200.0n 0.5385 4799.5n 0.5385 4800.0n 0.5024 5399.5n 0.5024 5400.0n 0.5015 5999.5n 0.5015 6000.0n 0.4700 6599.5n 0.4700 6600.0n 0.5120 7199.5n 0.5120 7200.0n 0.5006 7799.5n 0.5006 7800.0n 0.4950 8399.5n 0.4950 8400.0n 0.5309 8999.5n 0.5309 9000.0n 0.5023 9599.5n 0.5023 9600.0n 0.4893 10199.5n 0.4893 10200.0n 0.4837 10799.5n 0.4837 10800.0n 0.4823 11399.5n 0.4823 11400.0n 0.5074 11999.5n 0.5074 12000.0n 0.5364 12599.5n 0.5364 12600.0n 0.4868 13199.5n 0.4868 13200.0n 0.5380 13799.5n 0.5380 13800.0n 0.5220 14399.5n 0.5220 14400.0n 0.5095 14999.5n 0.5095 15000.0n 0.4705 15599.5n 0.4705 15600.0n 0.5289 16199.5n 0.5289 16200.0n 0.5368 16799.5n 0.5368 16800.0n 0.5287 17399.5n 0.5287 17400.0n 0.5342 17999.5n 0.5342 18000.0n 0.4253 18599.5n 0.4253 18600.0n 0.5119 19199.5n 0.5119 19200.0n 0.4104 19799.5n 0.4104 19800.0n 0.4314 20399.5n 0.4314 20400.0n 0.4005 20999.5n 0.4005 21000.0n 0.4696 21599.5n 0.4696 21600.0n 0.4531 22199.5n 0.4531 22200.0n 0.5039 22799.5n 0.5039 22800.0n 0.3608 23399.5n 0.3608 23400.0n 0.6273 23999.5n 0.6273 24000.0n 0.3928 24599.5n 0.3928 24600.0n 0.5253 25199.5n 0.5253 25200.0n 0.4107 25799.5n 0.4107 25800.0n 0.3947 26399.5n 0.3947 26400.0n 0.3716 26999.5n 0.3716 27000.0n 0.4111 27599.5n 0.4111 27600.0n 0.3715 28199.5n 0.3715 28200.0n 0.5939 28799.5n 0.5939 28800.0n 0.3849 29399.5n 0.3849 29400.0n 0.4835 29999.5n 0.4835 30000.0n 0.5119 30599.5n 0.5119 30600.0n 0.6226 31199.5n 0.6226 31200.0n 0.6064 31799.5n 0.6064 31800.0n 0.4115 32399.5n 0.4115 32400.0n 0.3900 32999.5n 0.3900 33000.0n 0.3958 33599.5n 0.3958 33600.0n 0.3747 34199.5n 0.3747 34200.0n 0.5423 34799.5n 0.5423 34800.0n 0.5509 35399.5n 0.5509 35400.0n 0.3990 35999.5n 0.3990)
Vxn_wih_1_37 xn_wih_1_37 0 PWL(0.0n 0.4630 599.5n 0.4630 600.0n 0.4833 1199.5n 0.4833 1200.0n 0.5207 1799.5n 0.5207 1800.0n 0.5559 2399.5n 0.5559 2400.0n 0.5445 2999.5n 0.5445 3000.0n 0.4945 3599.5n 0.4945 3600.0n 0.5061 4199.5n 0.5061 4200.0n 0.4615 4799.5n 0.4615 4800.0n 0.4976 5399.5n 0.4976 5400.0n 0.4985 5999.5n 0.4985 6000.0n 0.5300 6599.5n 0.5300 6600.0n 0.4880 7199.5n 0.4880 7200.0n 0.4994 7799.5n 0.4994 7800.0n 0.5050 8399.5n 0.5050 8400.0n 0.4691 8999.5n 0.4691 9000.0n 0.4977 9599.5n 0.4977 9600.0n 0.5107 10199.5n 0.5107 10200.0n 0.5163 10799.5n 0.5163 10800.0n 0.5177 11399.5n 0.5177 11400.0n 0.4926 11999.5n 0.4926 12000.0n 0.4636 12599.5n 0.4636 12600.0n 0.5132 13199.5n 0.5132 13200.0n 0.4620 13799.5n 0.4620 13800.0n 0.4780 14399.5n 0.4780 14400.0n 0.4905 14999.5n 0.4905 15000.0n 0.5295 15599.5n 0.5295 15600.0n 0.4711 16199.5n 0.4711 16200.0n 0.4632 16799.5n 0.4632 16800.0n 0.4713 17399.5n 0.4713 17400.0n 0.4658 17999.5n 0.4658 18000.0n 0.5747 18599.5n 0.5747 18600.0n 0.4881 19199.5n 0.4881 19200.0n 0.5896 19799.5n 0.5896 19800.0n 0.5686 20399.5n 0.5686 20400.0n 0.5995 20999.5n 0.5995 21000.0n 0.5304 21599.5n 0.5304 21600.0n 0.5469 22199.5n 0.5469 22200.0n 0.4961 22799.5n 0.4961 22800.0n 0.6392 23399.5n 0.6392 23400.0n 0.3727 23999.5n 0.3727 24000.0n 0.6072 24599.5n 0.6072 24600.0n 0.4747 25199.5n 0.4747 25200.0n 0.5893 25799.5n 0.5893 25800.0n 0.6053 26399.5n 0.6053 26400.0n 0.6284 26999.5n 0.6284 27000.0n 0.5889 27599.5n 0.5889 27600.0n 0.6285 28199.5n 0.6285 28200.0n 0.4061 28799.5n 0.4061 28800.0n 0.6151 29399.5n 0.6151 29400.0n 0.5165 29999.5n 0.5165 30000.0n 0.4881 30599.5n 0.4881 30600.0n 0.3774 31199.5n 0.3774 31200.0n 0.3936 31799.5n 0.3936 31800.0n 0.5885 32399.5n 0.5885 32400.0n 0.6100 32999.5n 0.6100 33000.0n 0.6042 33599.5n 0.6042 33600.0n 0.6253 34199.5n 0.6253 34200.0n 0.4577 34799.5n 0.4577 34800.0n 0.4491 35399.5n 0.4491 35400.0n 0.6010 35999.5n 0.6010)
Vyp_wih_1_37 yp_wih_1_37 0 PWL(0.0n 0.5626 599.5n 0.5626 600.0n 0.5308 1199.5n 0.5308 1200.0n 0.5509 1799.5n 0.5509 1800.0n 0.5182 2399.5n 0.5182 2400.0n 0.5203 2999.5n 0.5203 3000.0n 0.5449 3599.5n 0.5449 3600.0n 0.5559 4199.5n 0.5559 4200.0n 0.5656 4799.5n 0.5656 4800.0n 0.5499 5399.5n 0.5499 5400.0n 0.5492 5999.5n 0.5492 6000.0n 0.5460 6599.5n 0.5460 6600.0n 0.5558 7199.5n 0.5558 7200.0n 0.5294 7799.5n 0.5294 7800.0n 0.5266 8399.5n 0.5266 8400.0n 0.5707 8999.5n 0.5707 9000.0n 0.5495 9599.5n 0.5495 9600.0n 0.5411 10199.5n 0.5411 10200.0n 0.5301 10799.5n 0.5301 10800.0n 0.5565 11399.5n 0.5565 11400.0n 0.5520 11999.5n 0.5520 12000.0n 0.5765 12599.5n 0.5765 12600.0n 0.5393 13199.5n 0.5393 13200.0n 0.5602 13799.5n 0.5602 13800.0n 0.5445 14399.5n 0.5445 14400.0n 0.5515 14999.5n 0.5515 15000.0n 0.5288 15599.5n 0.5288 15600.0n 0.5631 16199.5n 0.5631 16200.0n 0.5533 16799.5n 0.5533 16800.0n 0.5718 17399.5n 0.5718 17400.0n 0.5569 17999.5n 0.5569 18000.0n 0.5403 18599.5n 0.5403 18600.0n 0.5018 19199.5n 0.5018 19200.0n 0.4896 19799.5n 0.4896 19800.0n 0.4629 20399.5n 0.4629 20400.0n 0.5037 20999.5n 0.5037 21000.0n 0.5917 21599.5n 0.5917 21600.0n 0.4789 22199.5n 0.4789 22200.0n 0.4953 22799.5n 0.4953 22800.0n 0.5022 23399.5n 0.5022 23400.0n 0.5723 23999.5n 0.5723 24000.0n 0.4496 24599.5n 0.4496 24600.0n 0.5017 25199.5n 0.5017 25200.0n 0.5217 25799.5n 0.5217 25800.0n 0.5529 26399.5n 0.5529 26400.0n 0.5198 26999.5n 0.5198 27000.0n 0.5336 27599.5n 0.5336 27600.0n 0.5180 28199.5n 0.5180 28200.0n 0.5514 28799.5n 0.5514 28800.0n 0.5037 29399.5n 0.5037 29400.0n 0.5961 29999.5n 0.5961 30000.0n 0.6053 30599.5n 0.6053 30600.0n 0.6466 31199.5n 0.6466 31200.0n 0.6176 31799.5n 0.6176 31800.0n 0.5575 32399.5n 0.5575 32400.0n 0.5514 32999.5n 0.5514 33000.0n 0.4737 33599.5n 0.4737 33600.0n 0.4864 34199.5n 0.4864 34200.0n 0.5108 34799.5n 0.5108 34800.0n 0.6215 35399.5n 0.6215 35400.0n 0.4893 35999.5n 0.4893)
Vyn_wih_1_37 yn_wih_1_37 0 PWL(0.0n 0.4374 599.5n 0.4374 600.0n 0.4692 1199.5n 0.4692 1200.0n 0.4491 1799.5n 0.4491 1800.0n 0.4818 2399.5n 0.4818 2400.0n 0.4797 2999.5n 0.4797 3000.0n 0.4551 3599.5n 0.4551 3600.0n 0.4441 4199.5n 0.4441 4200.0n 0.4344 4799.5n 0.4344 4800.0n 0.4501 5399.5n 0.4501 5400.0n 0.4508 5999.5n 0.4508 6000.0n 0.4540 6599.5n 0.4540 6600.0n 0.4442 7199.5n 0.4442 7200.0n 0.4706 7799.5n 0.4706 7800.0n 0.4734 8399.5n 0.4734 8400.0n 0.4293 8999.5n 0.4293 9000.0n 0.4505 9599.5n 0.4505 9600.0n 0.4589 10199.5n 0.4589 10200.0n 0.4699 10799.5n 0.4699 10800.0n 0.4435 11399.5n 0.4435 11400.0n 0.4480 11999.5n 0.4480 12000.0n 0.4235 12599.5n 0.4235 12600.0n 0.4607 13199.5n 0.4607 13200.0n 0.4398 13799.5n 0.4398 13800.0n 0.4555 14399.5n 0.4555 14400.0n 0.4485 14999.5n 0.4485 15000.0n 0.4712 15599.5n 0.4712 15600.0n 0.4369 16199.5n 0.4369 16200.0n 0.4467 16799.5n 0.4467 16800.0n 0.4282 17399.5n 0.4282 17400.0n 0.4431 17999.5n 0.4431 18000.0n 0.4597 18599.5n 0.4597 18600.0n 0.4982 19199.5n 0.4982 19200.0n 0.5104 19799.5n 0.5104 19800.0n 0.5371 20399.5n 0.5371 20400.0n 0.4963 20999.5n 0.4963 21000.0n 0.4083 21599.5n 0.4083 21600.0n 0.5211 22199.5n 0.5211 22200.0n 0.5047 22799.5n 0.5047 22800.0n 0.4978 23399.5n 0.4978 23400.0n 0.4277 23999.5n 0.4277 24000.0n 0.5504 24599.5n 0.5504 24600.0n 0.4983 25199.5n 0.4983 25200.0n 0.4783 25799.5n 0.4783 25800.0n 0.4471 26399.5n 0.4471 26400.0n 0.4802 26999.5n 0.4802 27000.0n 0.4664 27599.5n 0.4664 27600.0n 0.4820 28199.5n 0.4820 28200.0n 0.4486 28799.5n 0.4486 28800.0n 0.4963 29399.5n 0.4963 29400.0n 0.4039 29999.5n 0.4039 30000.0n 0.3947 30599.5n 0.3947 30600.0n 0.3534 31199.5n 0.3534 31200.0n 0.3824 31799.5n 0.3824 31800.0n 0.4425 32399.5n 0.4425 32400.0n 0.4486 32999.5n 0.4486 33000.0n 0.5263 33599.5n 0.5263 33600.0n 0.5136 34199.5n 0.5136 34200.0n 0.4892 34799.5n 0.4892 34800.0n 0.3785 35399.5n 0.3785 35400.0n 0.5107 35999.5n 0.5107)
Cwp_wih_1_37 wp_wih_1_37 0 400p
Cwn_wih_1_37 wn_wih_1_37 0 400p
Xu_wih_1_37 xp_wih_1_37 xn_wih_1_37 yp_wih_1_37 yn_wih_1_37 wp_wih_1_37 wn_wih_1_37 vdd gbn gprod
Vxp_who_37_0 xp_who_37_0 0 PWL(0.0n 0.5626 599.5n 0.5626 600.0n 0.5308 1199.5n 0.5308 1200.0n 0.5509 1799.5n 0.5509 1800.0n 0.5182 2399.5n 0.5182 2400.0n 0.5203 2999.5n 0.5203 3000.0n 0.5449 3599.5n 0.5449 3600.0n 0.5559 4199.5n 0.5559 4200.0n 0.5656 4799.5n 0.5656 4800.0n 0.5499 5399.5n 0.5499 5400.0n 0.5492 5999.5n 0.5492 6000.0n 0.5460 6599.5n 0.5460 6600.0n 0.5558 7199.5n 0.5558 7200.0n 0.5294 7799.5n 0.5294 7800.0n 0.5266 8399.5n 0.5266 8400.0n 0.5707 8999.5n 0.5707 9000.0n 0.5495 9599.5n 0.5495 9600.0n 0.5411 10199.5n 0.5411 10200.0n 0.5301 10799.5n 0.5301 10800.0n 0.5565 11399.5n 0.5565 11400.0n 0.5520 11999.5n 0.5520 12000.0n 0.5765 12599.5n 0.5765 12600.0n 0.5393 13199.5n 0.5393 13200.0n 0.5602 13799.5n 0.5602 13800.0n 0.5445 14399.5n 0.5445 14400.0n 0.5515 14999.5n 0.5515 15000.0n 0.5288 15599.5n 0.5288 15600.0n 0.5631 16199.5n 0.5631 16200.0n 0.5533 16799.5n 0.5533 16800.0n 0.5718 17399.5n 0.5718 17400.0n 0.5569 17999.5n 0.5569 18000.0n 0.5403 18599.5n 0.5403 18600.0n 0.5018 19199.5n 0.5018 19200.0n 0.4896 19799.5n 0.4896 19800.0n 0.4629 20399.5n 0.4629 20400.0n 0.5037 20999.5n 0.5037 21000.0n 0.5917 21599.5n 0.5917 21600.0n 0.4789 22199.5n 0.4789 22200.0n 0.4953 22799.5n 0.4953 22800.0n 0.5022 23399.5n 0.5022 23400.0n 0.5723 23999.5n 0.5723 24000.0n 0.4496 24599.5n 0.4496 24600.0n 0.5017 25199.5n 0.5017 25200.0n 0.5217 25799.5n 0.5217 25800.0n 0.5529 26399.5n 0.5529 26400.0n 0.5198 26999.5n 0.5198 27000.0n 0.5336 27599.5n 0.5336 27600.0n 0.5180 28199.5n 0.5180 28200.0n 0.5514 28799.5n 0.5514 28800.0n 0.5037 29399.5n 0.5037 29400.0n 0.5961 29999.5n 0.5961 30000.0n 0.6053 30599.5n 0.6053 30600.0n 0.6466 31199.5n 0.6466 31200.0n 0.6176 31799.5n 0.6176 31800.0n 0.5575 32399.5n 0.5575 32400.0n 0.5514 32999.5n 0.5514 33000.0n 0.4737 33599.5n 0.4737 33600.0n 0.4864 34199.5n 0.4864 34200.0n 0.5108 34799.5n 0.5108 34800.0n 0.6215 35399.5n 0.6215 35400.0n 0.4893 35999.5n 0.4893)
Vxn_who_37_0 xn_who_37_0 0 PWL(0.0n 0.4374 599.5n 0.4374 600.0n 0.4692 1199.5n 0.4692 1200.0n 0.4491 1799.5n 0.4491 1800.0n 0.4818 2399.5n 0.4818 2400.0n 0.4797 2999.5n 0.4797 3000.0n 0.4551 3599.5n 0.4551 3600.0n 0.4441 4199.5n 0.4441 4200.0n 0.4344 4799.5n 0.4344 4800.0n 0.4501 5399.5n 0.4501 5400.0n 0.4508 5999.5n 0.4508 6000.0n 0.4540 6599.5n 0.4540 6600.0n 0.4442 7199.5n 0.4442 7200.0n 0.4706 7799.5n 0.4706 7800.0n 0.4734 8399.5n 0.4734 8400.0n 0.4293 8999.5n 0.4293 9000.0n 0.4505 9599.5n 0.4505 9600.0n 0.4589 10199.5n 0.4589 10200.0n 0.4699 10799.5n 0.4699 10800.0n 0.4435 11399.5n 0.4435 11400.0n 0.4480 11999.5n 0.4480 12000.0n 0.4235 12599.5n 0.4235 12600.0n 0.4607 13199.5n 0.4607 13200.0n 0.4398 13799.5n 0.4398 13800.0n 0.4555 14399.5n 0.4555 14400.0n 0.4485 14999.5n 0.4485 15000.0n 0.4712 15599.5n 0.4712 15600.0n 0.4369 16199.5n 0.4369 16200.0n 0.4467 16799.5n 0.4467 16800.0n 0.4282 17399.5n 0.4282 17400.0n 0.4431 17999.5n 0.4431 18000.0n 0.4597 18599.5n 0.4597 18600.0n 0.4982 19199.5n 0.4982 19200.0n 0.5104 19799.5n 0.5104 19800.0n 0.5371 20399.5n 0.5371 20400.0n 0.4963 20999.5n 0.4963 21000.0n 0.4083 21599.5n 0.4083 21600.0n 0.5211 22199.5n 0.5211 22200.0n 0.5047 22799.5n 0.5047 22800.0n 0.4978 23399.5n 0.4978 23400.0n 0.4277 23999.5n 0.4277 24000.0n 0.5504 24599.5n 0.5504 24600.0n 0.4983 25199.5n 0.4983 25200.0n 0.4783 25799.5n 0.4783 25800.0n 0.4471 26399.5n 0.4471 26400.0n 0.4802 26999.5n 0.4802 27000.0n 0.4664 27599.5n 0.4664 27600.0n 0.4820 28199.5n 0.4820 28200.0n 0.4486 28799.5n 0.4486 28800.0n 0.4963 29399.5n 0.4963 29400.0n 0.4039 29999.5n 0.4039 30000.0n 0.3947 30599.5n 0.3947 30600.0n 0.3534 31199.5n 0.3534 31200.0n 0.3824 31799.5n 0.3824 31800.0n 0.4425 32399.5n 0.4425 32400.0n 0.4486 32999.5n 0.4486 33000.0n 0.5263 33599.5n 0.5263 33600.0n 0.5136 34199.5n 0.5136 34200.0n 0.4892 34799.5n 0.4892 34800.0n 0.3785 35399.5n 0.3785 35400.0n 0.5107 35999.5n 0.5107)
Vyp_who_37_0 yp_who_37_0 0 PWL(0.0n 0.5031 599.5n 0.5031 600.0n 0.5023 1199.5n 0.5023 1200.0n 0.5052 1799.5n 0.5052 1800.0n 0.5048 2399.5n 0.5048 2400.0n 0.5043 2999.5n 0.5043 3000.0n 0.5034 3599.5n 0.5034 3600.0n 0.5048 4199.5n 0.5048 4200.0n 0.5031 4799.5n 0.5031 4800.0n 0.5040 5399.5n 0.5040 5400.0n 0.5040 5999.5n 0.5040 6000.0n 0.5054 6599.5n 0.5054 6600.0n 0.5040 7199.5n 0.5040 7200.0n 0.5027 7799.5n 0.5027 7800.0n 0.5027 8399.5n 0.5027 8400.0n 0.5038 8999.5n 0.5038 9000.0n 0.5040 9599.5n 0.5040 9600.0n 0.5039 10199.5n 0.5039 10200.0n 0.5033 10799.5n 0.5033 10800.0n 0.5056 11399.5n 0.5056 11400.0n 0.5040 11999.5n 0.5040 12000.0n 0.5036 12599.5n 0.5036 12600.0n 0.5039 13199.5n 0.5039 13200.0n 0.5029 13799.5n 0.5029 13800.0n 0.5025 14399.5n 0.5025 14400.0n 0.5038 14999.5n 0.5038 15000.0n 0.5041 15599.5n 0.5041 15600.0n 0.5036 16199.5n 0.5036 16200.0n 0.5025 16799.5n 0.5025 16800.0n 0.5040 17399.5n 0.5040 17400.0n 0.5029 17999.5n 0.5029 18000.0n 0.5057 18599.5n 0.5057 18600.0n 0.5010 19199.5n 0.5010 19200.0n 0.5041 19799.5n 0.5041 19800.0n 0.5021 20399.5n 0.5021 20400.0n 0.5044 20999.5n 0.5044 21000.0n 0.5056 21599.5n 0.5056 21600.0n 0.5016 22199.5n 0.5016 22200.0n 0.5006 22799.5n 0.5006 22800.0n 0.5041 23399.5n 0.5041 23400.0n 0.5027 23999.5n 0.5027 24000.0n 0.5029 24599.5n 0.5029 24600.0n 0.5006 25199.5n 0.5006 25200.0n 0.5047 25799.5n 0.5047 25800.0n 0.5046 26399.5n 0.5046 26400.0n 0.5039 26999.5n 0.5039 27000.0n 0.5049 27599.5n 0.5049 27600.0n 0.5039 28199.5n 0.5039 28200.0n 0.5017 28799.5n 0.5017 28800.0n 0.5042 29399.5n 0.5042 29400.0n 0.5056 29999.5n 0.5056 30000.0n 0.5051 30599.5n 0.5051 30600.0n 0.5039 31199.5n 0.5039 31200.0n 0.5033 31799.5n 0.5033 31800.0n 0.5049 32399.5n 0.5049 32400.0n 0.5045 32999.5n 0.5045 33000.0n 0.5036 33599.5n 0.5036 33600.0n 0.5042 34199.5n 0.5042 34200.0n 0.5012 34799.5n 0.5012 34800.0n 0.5036 35399.5n 0.5036 35400.0n 0.5042 35999.5n 0.5042)
Vyn_who_37_0 yn_who_37_0 0 PWL(0.0n 0.4969 599.5n 0.4969 600.0n 0.4977 1199.5n 0.4977 1200.0n 0.4948 1799.5n 0.4948 1800.0n 0.4952 2399.5n 0.4952 2400.0n 0.4957 2999.5n 0.4957 3000.0n 0.4966 3599.5n 0.4966 3600.0n 0.4952 4199.5n 0.4952 4200.0n 0.4969 4799.5n 0.4969 4800.0n 0.4960 5399.5n 0.4960 5400.0n 0.4960 5999.5n 0.4960 6000.0n 0.4946 6599.5n 0.4946 6600.0n 0.4960 7199.5n 0.4960 7200.0n 0.4973 7799.5n 0.4973 7800.0n 0.4973 8399.5n 0.4973 8400.0n 0.4962 8999.5n 0.4962 9000.0n 0.4960 9599.5n 0.4960 9600.0n 0.4961 10199.5n 0.4961 10200.0n 0.4967 10799.5n 0.4967 10800.0n 0.4944 11399.5n 0.4944 11400.0n 0.4960 11999.5n 0.4960 12000.0n 0.4964 12599.5n 0.4964 12600.0n 0.4961 13199.5n 0.4961 13200.0n 0.4971 13799.5n 0.4971 13800.0n 0.4975 14399.5n 0.4975 14400.0n 0.4962 14999.5n 0.4962 15000.0n 0.4959 15599.5n 0.4959 15600.0n 0.4964 16199.5n 0.4964 16200.0n 0.4975 16799.5n 0.4975 16800.0n 0.4960 17399.5n 0.4960 17400.0n 0.4971 17999.5n 0.4971 18000.0n 0.4943 18599.5n 0.4943 18600.0n 0.4990 19199.5n 0.4990 19200.0n 0.4959 19799.5n 0.4959 19800.0n 0.4979 20399.5n 0.4979 20400.0n 0.4956 20999.5n 0.4956 21000.0n 0.4944 21599.5n 0.4944 21600.0n 0.4984 22199.5n 0.4984 22200.0n 0.4994 22799.5n 0.4994 22800.0n 0.4959 23399.5n 0.4959 23400.0n 0.4973 23999.5n 0.4973 24000.0n 0.4971 24599.5n 0.4971 24600.0n 0.4994 25199.5n 0.4994 25200.0n 0.4953 25799.5n 0.4953 25800.0n 0.4954 26399.5n 0.4954 26400.0n 0.4961 26999.5n 0.4961 27000.0n 0.4951 27599.5n 0.4951 27600.0n 0.4961 28199.5n 0.4961 28200.0n 0.4983 28799.5n 0.4983 28800.0n 0.4958 29399.5n 0.4958 29400.0n 0.4944 29999.5n 0.4944 30000.0n 0.4949 30599.5n 0.4949 30600.0n 0.4961 31199.5n 0.4961 31200.0n 0.4967 31799.5n 0.4967 31800.0n 0.4951 32399.5n 0.4951 32400.0n 0.4955 32999.5n 0.4955 33000.0n 0.4964 33599.5n 0.4964 33600.0n 0.4958 34199.5n 0.4958 34200.0n 0.4988 34799.5n 0.4988 34800.0n 0.4964 35399.5n 0.4964 35400.0n 0.4958 35999.5n 0.4958)
Cwp_who_37_0 wp_who_37_0 0 400p
Cwn_who_37_0 wn_who_37_0 0 400p
Xu_who_37_0 xp_who_37_0 xn_who_37_0 yp_who_37_0 yn_who_37_0 wp_who_37_0 wn_who_37_0 vdd gbn gprod
Vxp_who_37_1 xp_who_37_1 0 PWL(0.0n 0.5626 599.5n 0.5626 600.0n 0.5308 1199.5n 0.5308 1200.0n 0.5509 1799.5n 0.5509 1800.0n 0.5182 2399.5n 0.5182 2400.0n 0.5203 2999.5n 0.5203 3000.0n 0.5449 3599.5n 0.5449 3600.0n 0.5559 4199.5n 0.5559 4200.0n 0.5656 4799.5n 0.5656 4800.0n 0.5499 5399.5n 0.5499 5400.0n 0.5492 5999.5n 0.5492 6000.0n 0.5460 6599.5n 0.5460 6600.0n 0.5558 7199.5n 0.5558 7200.0n 0.5294 7799.5n 0.5294 7800.0n 0.5266 8399.5n 0.5266 8400.0n 0.5707 8999.5n 0.5707 9000.0n 0.5495 9599.5n 0.5495 9600.0n 0.5411 10199.5n 0.5411 10200.0n 0.5301 10799.5n 0.5301 10800.0n 0.5565 11399.5n 0.5565 11400.0n 0.5520 11999.5n 0.5520 12000.0n 0.5765 12599.5n 0.5765 12600.0n 0.5393 13199.5n 0.5393 13200.0n 0.5602 13799.5n 0.5602 13800.0n 0.5445 14399.5n 0.5445 14400.0n 0.5515 14999.5n 0.5515 15000.0n 0.5288 15599.5n 0.5288 15600.0n 0.5631 16199.5n 0.5631 16200.0n 0.5533 16799.5n 0.5533 16800.0n 0.5718 17399.5n 0.5718 17400.0n 0.5569 17999.5n 0.5569 18000.0n 0.5403 18599.5n 0.5403 18600.0n 0.5018 19199.5n 0.5018 19200.0n 0.4896 19799.5n 0.4896 19800.0n 0.4629 20399.5n 0.4629 20400.0n 0.5037 20999.5n 0.5037 21000.0n 0.5917 21599.5n 0.5917 21600.0n 0.4789 22199.5n 0.4789 22200.0n 0.4953 22799.5n 0.4953 22800.0n 0.5022 23399.5n 0.5022 23400.0n 0.5723 23999.5n 0.5723 24000.0n 0.4496 24599.5n 0.4496 24600.0n 0.5017 25199.5n 0.5017 25200.0n 0.5217 25799.5n 0.5217 25800.0n 0.5529 26399.5n 0.5529 26400.0n 0.5198 26999.5n 0.5198 27000.0n 0.5336 27599.5n 0.5336 27600.0n 0.5180 28199.5n 0.5180 28200.0n 0.5514 28799.5n 0.5514 28800.0n 0.5037 29399.5n 0.5037 29400.0n 0.5961 29999.5n 0.5961 30000.0n 0.6053 30599.5n 0.6053 30600.0n 0.6466 31199.5n 0.6466 31200.0n 0.6176 31799.5n 0.6176 31800.0n 0.5575 32399.5n 0.5575 32400.0n 0.5514 32999.5n 0.5514 33000.0n 0.4737 33599.5n 0.4737 33600.0n 0.4864 34199.5n 0.4864 34200.0n 0.5108 34799.5n 0.5108 34800.0n 0.6215 35399.5n 0.6215 35400.0n 0.4893 35999.5n 0.4893)
Vxn_who_37_1 xn_who_37_1 0 PWL(0.0n 0.4374 599.5n 0.4374 600.0n 0.4692 1199.5n 0.4692 1200.0n 0.4491 1799.5n 0.4491 1800.0n 0.4818 2399.5n 0.4818 2400.0n 0.4797 2999.5n 0.4797 3000.0n 0.4551 3599.5n 0.4551 3600.0n 0.4441 4199.5n 0.4441 4200.0n 0.4344 4799.5n 0.4344 4800.0n 0.4501 5399.5n 0.4501 5400.0n 0.4508 5999.5n 0.4508 6000.0n 0.4540 6599.5n 0.4540 6600.0n 0.4442 7199.5n 0.4442 7200.0n 0.4706 7799.5n 0.4706 7800.0n 0.4734 8399.5n 0.4734 8400.0n 0.4293 8999.5n 0.4293 9000.0n 0.4505 9599.5n 0.4505 9600.0n 0.4589 10199.5n 0.4589 10200.0n 0.4699 10799.5n 0.4699 10800.0n 0.4435 11399.5n 0.4435 11400.0n 0.4480 11999.5n 0.4480 12000.0n 0.4235 12599.5n 0.4235 12600.0n 0.4607 13199.5n 0.4607 13200.0n 0.4398 13799.5n 0.4398 13800.0n 0.4555 14399.5n 0.4555 14400.0n 0.4485 14999.5n 0.4485 15000.0n 0.4712 15599.5n 0.4712 15600.0n 0.4369 16199.5n 0.4369 16200.0n 0.4467 16799.5n 0.4467 16800.0n 0.4282 17399.5n 0.4282 17400.0n 0.4431 17999.5n 0.4431 18000.0n 0.4597 18599.5n 0.4597 18600.0n 0.4982 19199.5n 0.4982 19200.0n 0.5104 19799.5n 0.5104 19800.0n 0.5371 20399.5n 0.5371 20400.0n 0.4963 20999.5n 0.4963 21000.0n 0.4083 21599.5n 0.4083 21600.0n 0.5211 22199.5n 0.5211 22200.0n 0.5047 22799.5n 0.5047 22800.0n 0.4978 23399.5n 0.4978 23400.0n 0.4277 23999.5n 0.4277 24000.0n 0.5504 24599.5n 0.5504 24600.0n 0.4983 25199.5n 0.4983 25200.0n 0.4783 25799.5n 0.4783 25800.0n 0.4471 26399.5n 0.4471 26400.0n 0.4802 26999.5n 0.4802 27000.0n 0.4664 27599.5n 0.4664 27600.0n 0.4820 28199.5n 0.4820 28200.0n 0.4486 28799.5n 0.4486 28800.0n 0.4963 29399.5n 0.4963 29400.0n 0.4039 29999.5n 0.4039 30000.0n 0.3947 30599.5n 0.3947 30600.0n 0.3534 31199.5n 0.3534 31200.0n 0.3824 31799.5n 0.3824 31800.0n 0.4425 32399.5n 0.4425 32400.0n 0.4486 32999.5n 0.4486 33000.0n 0.5263 33599.5n 0.5263 33600.0n 0.5136 34199.5n 0.5136 34200.0n 0.4892 34799.5n 0.4892 34800.0n 0.3785 35399.5n 0.3785 35400.0n 0.5107 35999.5n 0.5107)
Vyp_who_37_1 yp_who_37_1 0 PWL(0.0n 0.5071 599.5n 0.5071 600.0n 0.5053 1199.5n 0.5053 1200.0n 0.5052 1799.5n 0.5052 1800.0n 0.5027 2399.5n 0.5027 2400.0n 0.5034 2999.5n 0.5034 3000.0n 0.5055 3599.5n 0.5055 3600.0n 0.5056 4199.5n 0.5056 4200.0n 0.5071 4799.5n 0.5071 4800.0n 0.5056 5399.5n 0.5056 5400.0n 0.5056 5999.5n 0.5056 6000.0n 0.5048 6599.5n 0.5048 6600.0n 0.5060 7199.5n 0.5060 7200.0n 0.5048 7799.5n 0.5048 7800.0n 0.5046 8399.5n 0.5046 8400.0n 0.5066 8999.5n 0.5066 9000.0n 0.5056 9599.5n 0.5056 9600.0n 0.5051 10199.5n 0.5051 10200.0n 0.5046 10799.5n 0.5046 10800.0n 0.5056 11399.5n 0.5056 11400.0n 0.5058 11999.5n 0.5058 12000.0n 0.5068 12599.5n 0.5068 12600.0n 0.5050 13199.5n 0.5050 13200.0n 0.5071 13799.5n 0.5071 13800.0n 0.5059 14399.5n 0.5059 14400.0n 0.5058 14999.5n 0.5058 15000.0n 0.5043 15599.5n 0.5043 15600.0n 0.5067 16199.5n 0.5067 16200.0n 0.5068 16799.5n 0.5068 16800.0n 0.5066 17399.5n 0.5066 17400.0n 0.5069 17999.5n 0.5069 18000.0n 0.5061 18599.5n 0.5061 18600.0n 0.5034 19199.5n 0.5034 19200.0n 0.5010 19799.5n 0.5010 19800.0n 0.4989 20399.5n 0.4989 20400.0n 0.5022 20999.5n 0.5022 21000.0n 0.5086 21599.5n 0.5086 21600.0n 0.5007 22199.5n 0.5007 22200.0n 0.5023 22799.5n 0.5023 22800.0n 0.5021 23399.5n 0.5021 23400.0n 0.5077 23999.5n 0.5077 24000.0n 0.4979 24599.5n 0.4979 24600.0n 0.5035 25199.5n 0.5035 25200.0n 0.5041 25799.5n 0.5041 25800.0n 0.5075 26399.5n 0.5075 26400.0n 0.5041 26999.5n 0.5041 27000.0n 0.5056 27599.5n 0.5056 27600.0n 0.5039 28199.5n 0.5039 28200.0n 0.5059 28799.5n 0.5059 28800.0n 0.5023 29399.5n 0.5023 29400.0n 0.5086 29999.5n 0.5086 30000.0n 0.5084 30599.5n 0.5084 30600.0n 0.5085 31199.5n 0.5085 31200.0n 0.5088 31799.5n 0.5088 31800.0n 0.5078 32399.5n 0.5078 32400.0n 0.5074 32999.5n 0.5074 33000.0n 0.4996 33599.5n 0.4996 33600.0n 0.5010 34199.5n 0.5010 34200.0n 0.5044 34799.5n 0.5044 34800.0n 0.5084 35399.5n 0.5084 35400.0n 0.5012 35999.5n 0.5012)
Vyn_who_37_1 yn_who_37_1 0 PWL(0.0n 0.4929 599.5n 0.4929 600.0n 0.4947 1199.5n 0.4947 1200.0n 0.4948 1799.5n 0.4948 1800.0n 0.4973 2399.5n 0.4973 2400.0n 0.4966 2999.5n 0.4966 3000.0n 0.4945 3599.5n 0.4945 3600.0n 0.4944 4199.5n 0.4944 4200.0n 0.4929 4799.5n 0.4929 4800.0n 0.4944 5399.5n 0.4944 5400.0n 0.4944 5999.5n 0.4944 6000.0n 0.4952 6599.5n 0.4952 6600.0n 0.4940 7199.5n 0.4940 7200.0n 0.4952 7799.5n 0.4952 7800.0n 0.4954 8399.5n 0.4954 8400.0n 0.4934 8999.5n 0.4934 9000.0n 0.4944 9599.5n 0.4944 9600.0n 0.4949 10199.5n 0.4949 10200.0n 0.4954 10799.5n 0.4954 10800.0n 0.4944 11399.5n 0.4944 11400.0n 0.4942 11999.5n 0.4942 12000.0n 0.4932 12599.5n 0.4932 12600.0n 0.4950 13199.5n 0.4950 13200.0n 0.4929 13799.5n 0.4929 13800.0n 0.4941 14399.5n 0.4941 14400.0n 0.4942 14999.5n 0.4942 15000.0n 0.4957 15599.5n 0.4957 15600.0n 0.4933 16199.5n 0.4933 16200.0n 0.4932 16799.5n 0.4932 16800.0n 0.4934 17399.5n 0.4934 17400.0n 0.4931 17999.5n 0.4931 18000.0n 0.4939 18599.5n 0.4939 18600.0n 0.4966 19199.5n 0.4966 19200.0n 0.4990 19799.5n 0.4990 19800.0n 0.5011 20399.5n 0.5011 20400.0n 0.4978 20999.5n 0.4978 21000.0n 0.4914 21599.5n 0.4914 21600.0n 0.4993 22199.5n 0.4993 22200.0n 0.4977 22799.5n 0.4977 22800.0n 0.4979 23399.5n 0.4979 23400.0n 0.4923 23999.5n 0.4923 24000.0n 0.5021 24599.5n 0.5021 24600.0n 0.4965 25199.5n 0.4965 25200.0n 0.4959 25799.5n 0.4959 25800.0n 0.4925 26399.5n 0.4925 26400.0n 0.4959 26999.5n 0.4959 27000.0n 0.4944 27599.5n 0.4944 27600.0n 0.4961 28199.5n 0.4961 28200.0n 0.4941 28799.5n 0.4941 28800.0n 0.4977 29399.5n 0.4977 29400.0n 0.4914 29999.5n 0.4914 30000.0n 0.4916 30599.5n 0.4916 30600.0n 0.4915 31199.5n 0.4915 31200.0n 0.4912 31799.5n 0.4912 31800.0n 0.4922 32399.5n 0.4922 32400.0n 0.4926 32999.5n 0.4926 33000.0n 0.5004 33599.5n 0.5004 33600.0n 0.4990 34199.5n 0.4990 34200.0n 0.4956 34799.5n 0.4956 34800.0n 0.4916 35399.5n 0.4916 35400.0n 0.4988 35999.5n 0.4988)
Cwp_who_37_1 wp_who_37_1 0 400p
Cwn_who_37_1 wn_who_37_1 0 400p
Xu_who_37_1 xp_who_37_1 xn_who_37_1 yp_who_37_1 yn_who_37_1 wp_who_37_1 wn_who_37_1 vdd gbn gprod
Vxp_bh_37 xp_bh_37 0 PWL(0.0n 0.7100 599.5n 0.7100 600.0n 0.7100 1199.5n 0.7100 1200.0n 0.7100 1799.5n 0.7100 1800.0n 0.7100 2399.5n 0.7100 2400.0n 0.7100 2999.5n 0.7100 3000.0n 0.7100 3599.5n 0.7100 3600.0n 0.7100 4199.5n 0.7100 4200.0n 0.7100 4799.5n 0.7100 4800.0n 0.7100 5399.5n 0.7100 5400.0n 0.7100 5999.5n 0.7100 6000.0n 0.7100 6599.5n 0.7100 6600.0n 0.7100 7199.5n 0.7100 7200.0n 0.7100 7799.5n 0.7100 7800.0n 0.7100 8399.5n 0.7100 8400.0n 0.7100 8999.5n 0.7100 9000.0n 0.7100 9599.5n 0.7100 9600.0n 0.7100 10199.5n 0.7100 10200.0n 0.7100 10799.5n 0.7100 10800.0n 0.7100 11399.5n 0.7100 11400.0n 0.7100 11999.5n 0.7100 12000.0n 0.7100 12599.5n 0.7100 12600.0n 0.7100 13199.5n 0.7100 13200.0n 0.7100 13799.5n 0.7100 13800.0n 0.7100 14399.5n 0.7100 14400.0n 0.7100 14999.5n 0.7100 15000.0n 0.7100 15599.5n 0.7100 15600.0n 0.7100 16199.5n 0.7100 16200.0n 0.7100 16799.5n 0.7100 16800.0n 0.7100 17399.5n 0.7100 17400.0n 0.7100 17999.5n 0.7100 18000.0n 0.7100 18599.5n 0.7100 18600.0n 0.7100 19199.5n 0.7100 19200.0n 0.7100 19799.5n 0.7100 19800.0n 0.7100 20399.5n 0.7100 20400.0n 0.7100 20999.5n 0.7100 21000.0n 0.7100 21599.5n 0.7100 21600.0n 0.7100 22199.5n 0.7100 22200.0n 0.7100 22799.5n 0.7100 22800.0n 0.7100 23399.5n 0.7100 23400.0n 0.7100 23999.5n 0.7100 24000.0n 0.7100 24599.5n 0.7100 24600.0n 0.7100 25199.5n 0.7100 25200.0n 0.7100 25799.5n 0.7100 25800.0n 0.7100 26399.5n 0.7100 26400.0n 0.7100 26999.5n 0.7100 27000.0n 0.7100 27599.5n 0.7100 27600.0n 0.7100 28199.5n 0.7100 28200.0n 0.7100 28799.5n 0.7100 28800.0n 0.7100 29399.5n 0.7100 29400.0n 0.7100 29999.5n 0.7100 30000.0n 0.7100 30599.5n 0.7100 30600.0n 0.7100 31199.5n 0.7100 31200.0n 0.7100 31799.5n 0.7100 31800.0n 0.7100 32399.5n 0.7100 32400.0n 0.7100 32999.5n 0.7100 33000.0n 0.7100 33599.5n 0.7100 33600.0n 0.7100 34199.5n 0.7100 34200.0n 0.7100 34799.5n 0.7100 34800.0n 0.7100 35399.5n 0.7100 35400.0n 0.7100 35999.5n 0.7100)
Vxn_bh_37 xn_bh_37 0 PWL(0.0n 0.2900 599.5n 0.2900 600.0n 0.2900 1199.5n 0.2900 1200.0n 0.2900 1799.5n 0.2900 1800.0n 0.2900 2399.5n 0.2900 2400.0n 0.2900 2999.5n 0.2900 3000.0n 0.2900 3599.5n 0.2900 3600.0n 0.2900 4199.5n 0.2900 4200.0n 0.2900 4799.5n 0.2900 4800.0n 0.2900 5399.5n 0.2900 5400.0n 0.2900 5999.5n 0.2900 6000.0n 0.2900 6599.5n 0.2900 6600.0n 0.2900 7199.5n 0.2900 7200.0n 0.2900 7799.5n 0.2900 7800.0n 0.2900 8399.5n 0.2900 8400.0n 0.2900 8999.5n 0.2900 9000.0n 0.2900 9599.5n 0.2900 9600.0n 0.2900 10199.5n 0.2900 10200.0n 0.2900 10799.5n 0.2900 10800.0n 0.2900 11399.5n 0.2900 11400.0n 0.2900 11999.5n 0.2900 12000.0n 0.2900 12599.5n 0.2900 12600.0n 0.2900 13199.5n 0.2900 13200.0n 0.2900 13799.5n 0.2900 13800.0n 0.2900 14399.5n 0.2900 14400.0n 0.2900 14999.5n 0.2900 15000.0n 0.2900 15599.5n 0.2900 15600.0n 0.2900 16199.5n 0.2900 16200.0n 0.2900 16799.5n 0.2900 16800.0n 0.2900 17399.5n 0.2900 17400.0n 0.2900 17999.5n 0.2900 18000.0n 0.2900 18599.5n 0.2900 18600.0n 0.2900 19199.5n 0.2900 19200.0n 0.2900 19799.5n 0.2900 19800.0n 0.2900 20399.5n 0.2900 20400.0n 0.2900 20999.5n 0.2900 21000.0n 0.2900 21599.5n 0.2900 21600.0n 0.2900 22199.5n 0.2900 22200.0n 0.2900 22799.5n 0.2900 22800.0n 0.2900 23399.5n 0.2900 23400.0n 0.2900 23999.5n 0.2900 24000.0n 0.2900 24599.5n 0.2900 24600.0n 0.2900 25199.5n 0.2900 25200.0n 0.2900 25799.5n 0.2900 25800.0n 0.2900 26399.5n 0.2900 26400.0n 0.2900 26999.5n 0.2900 27000.0n 0.2900 27599.5n 0.2900 27600.0n 0.2900 28199.5n 0.2900 28200.0n 0.2900 28799.5n 0.2900 28800.0n 0.2900 29399.5n 0.2900 29400.0n 0.2900 29999.5n 0.2900 30000.0n 0.2900 30599.5n 0.2900 30600.0n 0.2900 31199.5n 0.2900 31200.0n 0.2900 31799.5n 0.2900 31800.0n 0.2900 32399.5n 0.2900 32400.0n 0.2900 32999.5n 0.2900 33000.0n 0.2900 33599.5n 0.2900 33600.0n 0.2900 34199.5n 0.2900 34200.0n 0.2900 34799.5n 0.2900 34800.0n 0.2900 35399.5n 0.2900 35400.0n 0.2900 35999.5n 0.2900)
Vyp_bh_37 yp_bh_37 0 PWL(0.0n 0.5626 599.5n 0.5626 600.0n 0.5308 1199.5n 0.5308 1200.0n 0.5509 1799.5n 0.5509 1800.0n 0.5182 2399.5n 0.5182 2400.0n 0.5203 2999.5n 0.5203 3000.0n 0.5449 3599.5n 0.5449 3600.0n 0.5559 4199.5n 0.5559 4200.0n 0.5656 4799.5n 0.5656 4800.0n 0.5499 5399.5n 0.5499 5400.0n 0.5492 5999.5n 0.5492 6000.0n 0.5460 6599.5n 0.5460 6600.0n 0.5558 7199.5n 0.5558 7200.0n 0.5294 7799.5n 0.5294 7800.0n 0.5266 8399.5n 0.5266 8400.0n 0.5707 8999.5n 0.5707 9000.0n 0.5495 9599.5n 0.5495 9600.0n 0.5411 10199.5n 0.5411 10200.0n 0.5301 10799.5n 0.5301 10800.0n 0.5565 11399.5n 0.5565 11400.0n 0.5520 11999.5n 0.5520 12000.0n 0.5765 12599.5n 0.5765 12600.0n 0.5393 13199.5n 0.5393 13200.0n 0.5602 13799.5n 0.5602 13800.0n 0.5445 14399.5n 0.5445 14400.0n 0.5515 14999.5n 0.5515 15000.0n 0.5288 15599.5n 0.5288 15600.0n 0.5631 16199.5n 0.5631 16200.0n 0.5533 16799.5n 0.5533 16800.0n 0.5718 17399.5n 0.5718 17400.0n 0.5569 17999.5n 0.5569 18000.0n 0.5403 18599.5n 0.5403 18600.0n 0.5018 19199.5n 0.5018 19200.0n 0.4896 19799.5n 0.4896 19800.0n 0.4629 20399.5n 0.4629 20400.0n 0.5037 20999.5n 0.5037 21000.0n 0.5917 21599.5n 0.5917 21600.0n 0.4789 22199.5n 0.4789 22200.0n 0.4953 22799.5n 0.4953 22800.0n 0.5022 23399.5n 0.5022 23400.0n 0.5723 23999.5n 0.5723 24000.0n 0.4496 24599.5n 0.4496 24600.0n 0.5017 25199.5n 0.5017 25200.0n 0.5217 25799.5n 0.5217 25800.0n 0.5529 26399.5n 0.5529 26400.0n 0.5198 26999.5n 0.5198 27000.0n 0.5336 27599.5n 0.5336 27600.0n 0.5180 28199.5n 0.5180 28200.0n 0.5514 28799.5n 0.5514 28800.0n 0.5037 29399.5n 0.5037 29400.0n 0.5961 29999.5n 0.5961 30000.0n 0.6053 30599.5n 0.6053 30600.0n 0.6466 31199.5n 0.6466 31200.0n 0.6176 31799.5n 0.6176 31800.0n 0.5575 32399.5n 0.5575 32400.0n 0.5514 32999.5n 0.5514 33000.0n 0.4737 33599.5n 0.4737 33600.0n 0.4864 34199.5n 0.4864 34200.0n 0.5108 34799.5n 0.5108 34800.0n 0.6215 35399.5n 0.6215 35400.0n 0.4893 35999.5n 0.4893)
Vyn_bh_37 yn_bh_37 0 PWL(0.0n 0.4374 599.5n 0.4374 600.0n 0.4692 1199.5n 0.4692 1200.0n 0.4491 1799.5n 0.4491 1800.0n 0.4818 2399.5n 0.4818 2400.0n 0.4797 2999.5n 0.4797 3000.0n 0.4551 3599.5n 0.4551 3600.0n 0.4441 4199.5n 0.4441 4200.0n 0.4344 4799.5n 0.4344 4800.0n 0.4501 5399.5n 0.4501 5400.0n 0.4508 5999.5n 0.4508 6000.0n 0.4540 6599.5n 0.4540 6600.0n 0.4442 7199.5n 0.4442 7200.0n 0.4706 7799.5n 0.4706 7800.0n 0.4734 8399.5n 0.4734 8400.0n 0.4293 8999.5n 0.4293 9000.0n 0.4505 9599.5n 0.4505 9600.0n 0.4589 10199.5n 0.4589 10200.0n 0.4699 10799.5n 0.4699 10800.0n 0.4435 11399.5n 0.4435 11400.0n 0.4480 11999.5n 0.4480 12000.0n 0.4235 12599.5n 0.4235 12600.0n 0.4607 13199.5n 0.4607 13200.0n 0.4398 13799.5n 0.4398 13800.0n 0.4555 14399.5n 0.4555 14400.0n 0.4485 14999.5n 0.4485 15000.0n 0.4712 15599.5n 0.4712 15600.0n 0.4369 16199.5n 0.4369 16200.0n 0.4467 16799.5n 0.4467 16800.0n 0.4282 17399.5n 0.4282 17400.0n 0.4431 17999.5n 0.4431 18000.0n 0.4597 18599.5n 0.4597 18600.0n 0.4982 19199.5n 0.4982 19200.0n 0.5104 19799.5n 0.5104 19800.0n 0.5371 20399.5n 0.5371 20400.0n 0.4963 20999.5n 0.4963 21000.0n 0.4083 21599.5n 0.4083 21600.0n 0.5211 22199.5n 0.5211 22200.0n 0.5047 22799.5n 0.5047 22800.0n 0.4978 23399.5n 0.4978 23400.0n 0.4277 23999.5n 0.4277 24000.0n 0.5504 24599.5n 0.5504 24600.0n 0.4983 25199.5n 0.4983 25200.0n 0.4783 25799.5n 0.4783 25800.0n 0.4471 26399.5n 0.4471 26400.0n 0.4802 26999.5n 0.4802 27000.0n 0.4664 27599.5n 0.4664 27600.0n 0.4820 28199.5n 0.4820 28200.0n 0.4486 28799.5n 0.4486 28800.0n 0.4963 29399.5n 0.4963 29400.0n 0.4039 29999.5n 0.4039 30000.0n 0.3947 30599.5n 0.3947 30600.0n 0.3534 31199.5n 0.3534 31200.0n 0.3824 31799.5n 0.3824 31800.0n 0.4425 32399.5n 0.4425 32400.0n 0.4486 32999.5n 0.4486 33000.0n 0.5263 33599.5n 0.5263 33600.0n 0.5136 34199.5n 0.5136 34200.0n 0.4892 34799.5n 0.4892 34800.0n 0.3785 35399.5n 0.3785 35400.0n 0.5107 35999.5n 0.5107)
Cwp_bh_37 wp_bh_37 0 400p
Cwn_bh_37 wn_bh_37 0 400p
Xu_bh_37 xp_bh_37 xn_bh_37 yp_bh_37 yn_bh_37 wp_bh_37 wn_bh_37 vdd gbn gprod
Vxp_wih_0_38 xp_wih_0_38 0 PWL(0.0n 0.4942 599.5n 0.4942 600.0n 0.5558 1199.5n 0.5558 1200.0n 0.4708 1799.5n 0.4708 1800.0n 0.5235 2399.5n 0.5235 2400.0n 0.5350 2999.5n 0.5350 3000.0n 0.5172 3599.5n 0.5172 3600.0n 0.4702 4199.5n 0.4702 4200.0n 0.4867 4799.5n 0.4867 4800.0n 0.4970 5399.5n 0.4970 5400.0n 0.4986 5999.5n 0.4986 6000.0n 0.4751 6599.5n 0.4751 6600.0n 0.4870 7199.5n 0.4870 7200.0n 0.5502 7799.5n 0.5502 7800.0n 0.5521 8399.5n 0.5521 8400.0n 0.4638 8999.5n 0.4638 9000.0n 0.4982 9599.5n 0.4982 9600.0n 0.5131 10199.5n 0.5131 10200.0n 0.5386 10799.5n 0.5386 10800.0n 0.4592 11399.5n 0.4592 11400.0n 0.4950 11999.5n 0.4950 12000.0n 0.4559 12599.5n 0.4559 12600.0n 0.5162 13199.5n 0.5162 13200.0n 0.5038 13799.5n 0.5038 13800.0n 0.5333 14399.5n 0.5333 14400.0n 0.4991 14999.5n 0.4991 15000.0n 0.5298 15599.5n 0.5298 15600.0n 0.4823 16199.5n 0.4823 16200.0n 0.5239 16799.5n 0.5239 16800.0n 0.4592 17399.5n 0.4592 17400.0n 0.5094 17999.5n 0.5094 18000.0n 0.4337 18599.5n 0.4337 18600.0n 0.5977 19199.5n 0.5977 19200.0n 0.5364 19799.5n 0.5364 19800.0n 0.6122 20399.5n 0.6122 20400.0n 0.4856 20999.5n 0.4856 21000.0n 0.3861 21599.5n 0.3861 21600.0n 0.6094 22199.5n 0.6094 22200.0n 0.6364 22799.5n 0.6364 22800.0n 0.4807 23399.5n 0.4807 23400.0n 0.5614 23999.5n 0.5614 24000.0n 0.5913 24599.5n 0.5913 24600.0n 0.6295 25199.5n 0.6295 25200.0n 0.4496 25799.5n 0.4496 25800.0n 0.3792 26399.5n 0.3792 26400.0n 0.4434 26999.5n 0.4434 27000.0n 0.4340 27599.5n 0.4340 27600.0n 0.4461 28199.5n 0.4461 28200.0n 0.5791 28799.5n 0.5791 28800.0n 0.4777 29399.5n 0.4777 29400.0n 0.3878 29999.5n 0.3878 30000.0n 0.3832 30599.5n 0.3832 30600.0n 0.4022 31199.5n 0.4022 31200.0n 0.4482 31799.5n 0.4482 31800.0n 0.3662 32399.5n 0.3662 32400.0n 0.3857 32999.5n 0.3857 33000.0n 0.5584 33599.5n 0.5584 33600.0n 0.5284 34199.5n 0.5284 34200.0n 0.6034 34799.5n 0.6034 34800.0n 0.3469 35399.5n 0.3469 35400.0n 0.5290 35999.5n 0.5290)
Vxn_wih_0_38 xn_wih_0_38 0 PWL(0.0n 0.5058 599.5n 0.5058 600.0n 0.4442 1199.5n 0.4442 1200.0n 0.5292 1799.5n 0.5292 1800.0n 0.4765 2399.5n 0.4765 2400.0n 0.4650 2999.5n 0.4650 3000.0n 0.4828 3599.5n 0.4828 3600.0n 0.5298 4199.5n 0.5298 4200.0n 0.5133 4799.5n 0.5133 4800.0n 0.5030 5399.5n 0.5030 5400.0n 0.5014 5999.5n 0.5014 6000.0n 0.5249 6599.5n 0.5249 6600.0n 0.5130 7199.5n 0.5130 7200.0n 0.4498 7799.5n 0.4498 7800.0n 0.4479 8399.5n 0.4479 8400.0n 0.5362 8999.5n 0.5362 9000.0n 0.5018 9599.5n 0.5018 9600.0n 0.4869 10199.5n 0.4869 10200.0n 0.4614 10799.5n 0.4614 10800.0n 0.5408 11399.5n 0.5408 11400.0n 0.5050 11999.5n 0.5050 12000.0n 0.5441 12599.5n 0.5441 12600.0n 0.4838 13199.5n 0.4838 13200.0n 0.4962 13799.5n 0.4962 13800.0n 0.4667 14399.5n 0.4667 14400.0n 0.5009 14999.5n 0.5009 15000.0n 0.4702 15599.5n 0.4702 15600.0n 0.5177 16199.5n 0.5177 16200.0n 0.4761 16799.5n 0.4761 16800.0n 0.5408 17399.5n 0.5408 17400.0n 0.4906 17999.5n 0.4906 18000.0n 0.5663 18599.5n 0.5663 18600.0n 0.4023 19199.5n 0.4023 19200.0n 0.4636 19799.5n 0.4636 19800.0n 0.3878 20399.5n 0.3878 20400.0n 0.5144 20999.5n 0.5144 21000.0n 0.6139 21599.5n 0.6139 21600.0n 0.3906 22199.5n 0.3906 22200.0n 0.3636 22799.5n 0.3636 22800.0n 0.5193 23399.5n 0.5193 23400.0n 0.4386 23999.5n 0.4386 24000.0n 0.4087 24599.5n 0.4087 24600.0n 0.3705 25199.5n 0.3705 25200.0n 0.5504 25799.5n 0.5504 25800.0n 0.6208 26399.5n 0.6208 26400.0n 0.5566 26999.5n 0.5566 27000.0n 0.5660 27599.5n 0.5660 27600.0n 0.5539 28199.5n 0.5539 28200.0n 0.4209 28799.5n 0.4209 28800.0n 0.5223 29399.5n 0.5223 29400.0n 0.6122 29999.5n 0.6122 30000.0n 0.6168 30599.5n 0.6168 30600.0n 0.5978 31199.5n 0.5978 31200.0n 0.5518 31799.5n 0.5518 31800.0n 0.6338 32399.5n 0.6338 32400.0n 0.6143 32999.5n 0.6143 33000.0n 0.4416 33599.5n 0.4416 33600.0n 0.4716 34199.5n 0.4716 34200.0n 0.3966 34799.5n 0.3966 34800.0n 0.6531 35399.5n 0.6531 35400.0n 0.4710 35999.5n 0.4710)
Vyp_wih_0_38 yp_wih_0_38 0 PWL(0.0n 0.5584 599.5n 0.5584 600.0n 0.6399 1199.5n 0.6399 1200.0n 0.4683 1799.5n 0.4683 1800.0n 0.4957 2399.5n 0.4957 2400.0n 0.5342 2999.5n 0.5342 3000.0n 0.5577 3599.5n 0.5577 3600.0n 0.4809 4199.5n 0.4809 4200.0n 0.5503 4799.5n 0.5503 4800.0n 0.5274 5399.5n 0.5274 5400.0n 0.5288 5999.5n 0.5288 6000.0n 0.4654 6599.5n 0.4654 6600.0n 0.5224 7199.5n 0.5224 7200.0n 0.6134 7799.5n 0.6134 7800.0n 0.6134 8399.5n 0.6134 8400.0n 0.5050 8999.5n 0.5050 9000.0n 0.5290 9599.5n 0.5290 9600.0n 0.5375 10199.5n 0.5375 10200.0n 0.5732 10799.5n 0.5732 10800.0n 0.4498 11399.5n 0.4498 11400.0n 0.5291 11999.5n 0.5291 12000.0n 0.4956 12599.5n 0.4956 12600.0n 0.5396 13199.5n 0.5396 13200.0n 0.5724 13799.5n 0.5724 13800.0n 0.5979 14399.5n 0.5979 14400.0n 0.5366 14999.5n 0.5366 15000.0n 0.5440 15599.5n 0.5440 15600.0n 0.5326 16199.5n 0.5326 16200.0n 0.5987 16799.5n 0.5987 16800.0n 0.4934 17399.5n 0.4934 17400.0n 0.5752 17999.5n 0.5752 18000.0n 0.3416 18599.5n 0.3416 18600.0n 0.6615 19199.5n 0.6615 19200.0n 0.4676 19799.5n 0.4676 19800.0n 0.6136 20399.5n 0.6136 20400.0n 0.3898 20999.5n 0.3898 21000.0n 0.3448 21599.5n 0.3448 21600.0n 0.6471 22199.5n 0.6471 22200.0n 0.6664 22799.5n 0.6664 22800.0n 0.3666 23399.5n 0.3666 23400.0n 0.6739 23999.5n 0.6739 24000.0n 0.5629 24599.5n 0.5629 24600.0n 0.6689 25199.5n 0.6689 25200.0n 0.3474 25799.5n 0.3474 25800.0n 0.3243 26399.5n 0.3243 26400.0n 0.3377 26999.5n 0.3377 27000.0n 0.3382 27599.5n 0.3382 27600.0n 0.3391 28199.5n 0.3391 28200.0n 0.6758 28799.5n 0.6758 28800.0n 0.3715 29399.5n 0.3715 29400.0n 0.3499 29999.5n 0.3499 30000.0n 0.3630 30599.5n 0.3630 30600.0n 0.4971 31199.5n 0.4971 31200.0n 0.5664 31799.5n 0.5664 31800.0n 0.3247 32399.5n 0.3247 32400.0n 0.3247 32999.5n 0.3247 33000.0n 0.5088 33599.5n 0.5088 33600.0n 0.4348 34199.5n 0.4348 34200.0n 0.6685 34799.5n 0.6685 34800.0n 0.3878 35399.5n 0.3878 35400.0n 0.4478 35999.5n 0.4478)
Vyn_wih_0_38 yn_wih_0_38 0 PWL(0.0n 0.4416 599.5n 0.4416 600.0n 0.3601 1199.5n 0.3601 1200.0n 0.5317 1799.5n 0.5317 1800.0n 0.5043 2399.5n 0.5043 2400.0n 0.4658 2999.5n 0.4658 3000.0n 0.4423 3599.5n 0.4423 3600.0n 0.5191 4199.5n 0.5191 4200.0n 0.4497 4799.5n 0.4497 4800.0n 0.4726 5399.5n 0.4726 5400.0n 0.4712 5999.5n 0.4712 6000.0n 0.5346 6599.5n 0.5346 6600.0n 0.4776 7199.5n 0.4776 7200.0n 0.3866 7799.5n 0.3866 7800.0n 0.3866 8399.5n 0.3866 8400.0n 0.4950 8999.5n 0.4950 9000.0n 0.4710 9599.5n 0.4710 9600.0n 0.4625 10199.5n 0.4625 10200.0n 0.4268 10799.5n 0.4268 10800.0n 0.5502 11399.5n 0.5502 11400.0n 0.4709 11999.5n 0.4709 12000.0n 0.5044 12599.5n 0.5044 12600.0n 0.4604 13199.5n 0.4604 13200.0n 0.4276 13799.5n 0.4276 13800.0n 0.4021 14399.5n 0.4021 14400.0n 0.4634 14999.5n 0.4634 15000.0n 0.4560 15599.5n 0.4560 15600.0n 0.4674 16199.5n 0.4674 16200.0n 0.4013 16799.5n 0.4013 16800.0n 0.5066 17399.5n 0.5066 17400.0n 0.4248 17999.5n 0.4248 18000.0n 0.6584 18599.5n 0.6584 18600.0n 0.3385 19199.5n 0.3385 19200.0n 0.5324 19799.5n 0.5324 19800.0n 0.3864 20399.5n 0.3864 20400.0n 0.6102 20999.5n 0.6102 21000.0n 0.6552 21599.5n 0.6552 21600.0n 0.3529 22199.5n 0.3529 22200.0n 0.3336 22799.5n 0.3336 22800.0n 0.6334 23399.5n 0.6334 23400.0n 0.3261 23999.5n 0.3261 24000.0n 0.4371 24599.5n 0.4371 24600.0n 0.3311 25199.5n 0.3311 25200.0n 0.6526 25799.5n 0.6526 25800.0n 0.6757 26399.5n 0.6757 26400.0n 0.6623 26999.5n 0.6623 27000.0n 0.6618 27599.5n 0.6618 27600.0n 0.6609 28199.5n 0.6609 28200.0n 0.3242 28799.5n 0.3242 28800.0n 0.6285 29399.5n 0.6285 29400.0n 0.6501 29999.5n 0.6501 30000.0n 0.6370 30599.5n 0.6370 30600.0n 0.5029 31199.5n 0.5029 31200.0n 0.4336 31799.5n 0.4336 31800.0n 0.6753 32399.5n 0.6753 32400.0n 0.6753 32999.5n 0.6753 33000.0n 0.4912 33599.5n 0.4912 33600.0n 0.5652 34199.5n 0.5652 34200.0n 0.3315 34799.5n 0.3315 34800.0n 0.6122 35399.5n 0.6122 35400.0n 0.5522 35999.5n 0.5522)
Cwp_wih_0_38 wp_wih_0_38 0 400p
Cwn_wih_0_38 wn_wih_0_38 0 400p
Xu_wih_0_38 xp_wih_0_38 xn_wih_0_38 yp_wih_0_38 yn_wih_0_38 wp_wih_0_38 wn_wih_0_38 vdd gbn gprod
Vxp_wih_1_38 xp_wih_1_38 0 PWL(0.0n 0.5370 599.5n 0.5370 600.0n 0.5167 1199.5n 0.5167 1200.0n 0.4793 1799.5n 0.4793 1800.0n 0.4441 2399.5n 0.4441 2400.0n 0.4555 2999.5n 0.4555 3000.0n 0.5055 3599.5n 0.5055 3600.0n 0.4939 4199.5n 0.4939 4200.0n 0.5385 4799.5n 0.5385 4800.0n 0.5024 5399.5n 0.5024 5400.0n 0.5015 5999.5n 0.5015 6000.0n 0.4700 6599.5n 0.4700 6600.0n 0.5120 7199.5n 0.5120 7200.0n 0.5006 7799.5n 0.5006 7800.0n 0.4950 8399.5n 0.4950 8400.0n 0.5309 8999.5n 0.5309 9000.0n 0.5023 9599.5n 0.5023 9600.0n 0.4893 10199.5n 0.4893 10200.0n 0.4837 10799.5n 0.4837 10800.0n 0.4823 11399.5n 0.4823 11400.0n 0.5074 11999.5n 0.5074 12000.0n 0.5364 12599.5n 0.5364 12600.0n 0.4868 13199.5n 0.4868 13200.0n 0.5380 13799.5n 0.5380 13800.0n 0.5220 14399.5n 0.5220 14400.0n 0.5095 14999.5n 0.5095 15000.0n 0.4705 15599.5n 0.4705 15600.0n 0.5289 16199.5n 0.5289 16200.0n 0.5368 16799.5n 0.5368 16800.0n 0.5287 17399.5n 0.5287 17400.0n 0.5342 17999.5n 0.5342 18000.0n 0.4253 18599.5n 0.4253 18600.0n 0.5119 19199.5n 0.5119 19200.0n 0.4104 19799.5n 0.4104 19800.0n 0.4314 20399.5n 0.4314 20400.0n 0.4005 20999.5n 0.4005 21000.0n 0.4696 21599.5n 0.4696 21600.0n 0.4531 22199.5n 0.4531 22200.0n 0.5039 22799.5n 0.5039 22800.0n 0.3608 23399.5n 0.3608 23400.0n 0.6273 23999.5n 0.6273 24000.0n 0.3928 24599.5n 0.3928 24600.0n 0.5253 25199.5n 0.5253 25200.0n 0.4107 25799.5n 0.4107 25800.0n 0.3947 26399.5n 0.3947 26400.0n 0.3716 26999.5n 0.3716 27000.0n 0.4111 27599.5n 0.4111 27600.0n 0.3715 28199.5n 0.3715 28200.0n 0.5939 28799.5n 0.5939 28800.0n 0.3849 29399.5n 0.3849 29400.0n 0.4835 29999.5n 0.4835 30000.0n 0.5119 30599.5n 0.5119 30600.0n 0.6226 31199.5n 0.6226 31200.0n 0.6064 31799.5n 0.6064 31800.0n 0.4115 32399.5n 0.4115 32400.0n 0.3900 32999.5n 0.3900 33000.0n 0.3958 33599.5n 0.3958 33600.0n 0.3747 34199.5n 0.3747 34200.0n 0.5423 34799.5n 0.5423 34800.0n 0.5509 35399.5n 0.5509 35400.0n 0.3990 35999.5n 0.3990)
Vxn_wih_1_38 xn_wih_1_38 0 PWL(0.0n 0.4630 599.5n 0.4630 600.0n 0.4833 1199.5n 0.4833 1200.0n 0.5207 1799.5n 0.5207 1800.0n 0.5559 2399.5n 0.5559 2400.0n 0.5445 2999.5n 0.5445 3000.0n 0.4945 3599.5n 0.4945 3600.0n 0.5061 4199.5n 0.5061 4200.0n 0.4615 4799.5n 0.4615 4800.0n 0.4976 5399.5n 0.4976 5400.0n 0.4985 5999.5n 0.4985 6000.0n 0.5300 6599.5n 0.5300 6600.0n 0.4880 7199.5n 0.4880 7200.0n 0.4994 7799.5n 0.4994 7800.0n 0.5050 8399.5n 0.5050 8400.0n 0.4691 8999.5n 0.4691 9000.0n 0.4977 9599.5n 0.4977 9600.0n 0.5107 10199.5n 0.5107 10200.0n 0.5163 10799.5n 0.5163 10800.0n 0.5177 11399.5n 0.5177 11400.0n 0.4926 11999.5n 0.4926 12000.0n 0.4636 12599.5n 0.4636 12600.0n 0.5132 13199.5n 0.5132 13200.0n 0.4620 13799.5n 0.4620 13800.0n 0.4780 14399.5n 0.4780 14400.0n 0.4905 14999.5n 0.4905 15000.0n 0.5295 15599.5n 0.5295 15600.0n 0.4711 16199.5n 0.4711 16200.0n 0.4632 16799.5n 0.4632 16800.0n 0.4713 17399.5n 0.4713 17400.0n 0.4658 17999.5n 0.4658 18000.0n 0.5747 18599.5n 0.5747 18600.0n 0.4881 19199.5n 0.4881 19200.0n 0.5896 19799.5n 0.5896 19800.0n 0.5686 20399.5n 0.5686 20400.0n 0.5995 20999.5n 0.5995 21000.0n 0.5304 21599.5n 0.5304 21600.0n 0.5469 22199.5n 0.5469 22200.0n 0.4961 22799.5n 0.4961 22800.0n 0.6392 23399.5n 0.6392 23400.0n 0.3727 23999.5n 0.3727 24000.0n 0.6072 24599.5n 0.6072 24600.0n 0.4747 25199.5n 0.4747 25200.0n 0.5893 25799.5n 0.5893 25800.0n 0.6053 26399.5n 0.6053 26400.0n 0.6284 26999.5n 0.6284 27000.0n 0.5889 27599.5n 0.5889 27600.0n 0.6285 28199.5n 0.6285 28200.0n 0.4061 28799.5n 0.4061 28800.0n 0.6151 29399.5n 0.6151 29400.0n 0.5165 29999.5n 0.5165 30000.0n 0.4881 30599.5n 0.4881 30600.0n 0.3774 31199.5n 0.3774 31200.0n 0.3936 31799.5n 0.3936 31800.0n 0.5885 32399.5n 0.5885 32400.0n 0.6100 32999.5n 0.6100 33000.0n 0.6042 33599.5n 0.6042 33600.0n 0.6253 34199.5n 0.6253 34200.0n 0.4577 34799.5n 0.4577 34800.0n 0.4491 35399.5n 0.4491 35400.0n 0.6010 35999.5n 0.6010)
Vyp_wih_1_38 yp_wih_1_38 0 PWL(0.0n 0.5584 599.5n 0.5584 600.0n 0.6399 1199.5n 0.6399 1200.0n 0.4683 1799.5n 0.4683 1800.0n 0.4957 2399.5n 0.4957 2400.0n 0.5342 2999.5n 0.5342 3000.0n 0.5577 3599.5n 0.5577 3600.0n 0.4809 4199.5n 0.4809 4200.0n 0.5503 4799.5n 0.5503 4800.0n 0.5274 5399.5n 0.5274 5400.0n 0.5288 5999.5n 0.5288 6000.0n 0.4654 6599.5n 0.4654 6600.0n 0.5224 7199.5n 0.5224 7200.0n 0.6134 7799.5n 0.6134 7800.0n 0.6134 8399.5n 0.6134 8400.0n 0.5050 8999.5n 0.5050 9000.0n 0.5290 9599.5n 0.5290 9600.0n 0.5375 10199.5n 0.5375 10200.0n 0.5732 10799.5n 0.5732 10800.0n 0.4498 11399.5n 0.4498 11400.0n 0.5291 11999.5n 0.5291 12000.0n 0.4956 12599.5n 0.4956 12600.0n 0.5396 13199.5n 0.5396 13200.0n 0.5724 13799.5n 0.5724 13800.0n 0.5979 14399.5n 0.5979 14400.0n 0.5366 14999.5n 0.5366 15000.0n 0.5440 15599.5n 0.5440 15600.0n 0.5326 16199.5n 0.5326 16200.0n 0.5987 16799.5n 0.5987 16800.0n 0.4934 17399.5n 0.4934 17400.0n 0.5752 17999.5n 0.5752 18000.0n 0.3416 18599.5n 0.3416 18600.0n 0.6615 19199.5n 0.6615 19200.0n 0.4676 19799.5n 0.4676 19800.0n 0.6136 20399.5n 0.6136 20400.0n 0.3898 20999.5n 0.3898 21000.0n 0.3448 21599.5n 0.3448 21600.0n 0.6471 22199.5n 0.6471 22200.0n 0.6664 22799.5n 0.6664 22800.0n 0.3666 23399.5n 0.3666 23400.0n 0.6739 23999.5n 0.6739 24000.0n 0.5629 24599.5n 0.5629 24600.0n 0.6689 25199.5n 0.6689 25200.0n 0.3474 25799.5n 0.3474 25800.0n 0.3243 26399.5n 0.3243 26400.0n 0.3377 26999.5n 0.3377 27000.0n 0.3382 27599.5n 0.3382 27600.0n 0.3391 28199.5n 0.3391 28200.0n 0.6758 28799.5n 0.6758 28800.0n 0.3715 29399.5n 0.3715 29400.0n 0.3499 29999.5n 0.3499 30000.0n 0.3630 30599.5n 0.3630 30600.0n 0.4971 31199.5n 0.4971 31200.0n 0.5664 31799.5n 0.5664 31800.0n 0.3247 32399.5n 0.3247 32400.0n 0.3247 32999.5n 0.3247 33000.0n 0.5088 33599.5n 0.5088 33600.0n 0.4348 34199.5n 0.4348 34200.0n 0.6685 34799.5n 0.6685 34800.0n 0.3878 35399.5n 0.3878 35400.0n 0.4478 35999.5n 0.4478)
Vyn_wih_1_38 yn_wih_1_38 0 PWL(0.0n 0.4416 599.5n 0.4416 600.0n 0.3601 1199.5n 0.3601 1200.0n 0.5317 1799.5n 0.5317 1800.0n 0.5043 2399.5n 0.5043 2400.0n 0.4658 2999.5n 0.4658 3000.0n 0.4423 3599.5n 0.4423 3600.0n 0.5191 4199.5n 0.5191 4200.0n 0.4497 4799.5n 0.4497 4800.0n 0.4726 5399.5n 0.4726 5400.0n 0.4712 5999.5n 0.4712 6000.0n 0.5346 6599.5n 0.5346 6600.0n 0.4776 7199.5n 0.4776 7200.0n 0.3866 7799.5n 0.3866 7800.0n 0.3866 8399.5n 0.3866 8400.0n 0.4950 8999.5n 0.4950 9000.0n 0.4710 9599.5n 0.4710 9600.0n 0.4625 10199.5n 0.4625 10200.0n 0.4268 10799.5n 0.4268 10800.0n 0.5502 11399.5n 0.5502 11400.0n 0.4709 11999.5n 0.4709 12000.0n 0.5044 12599.5n 0.5044 12600.0n 0.4604 13199.5n 0.4604 13200.0n 0.4276 13799.5n 0.4276 13800.0n 0.4021 14399.5n 0.4021 14400.0n 0.4634 14999.5n 0.4634 15000.0n 0.4560 15599.5n 0.4560 15600.0n 0.4674 16199.5n 0.4674 16200.0n 0.4013 16799.5n 0.4013 16800.0n 0.5066 17399.5n 0.5066 17400.0n 0.4248 17999.5n 0.4248 18000.0n 0.6584 18599.5n 0.6584 18600.0n 0.3385 19199.5n 0.3385 19200.0n 0.5324 19799.5n 0.5324 19800.0n 0.3864 20399.5n 0.3864 20400.0n 0.6102 20999.5n 0.6102 21000.0n 0.6552 21599.5n 0.6552 21600.0n 0.3529 22199.5n 0.3529 22200.0n 0.3336 22799.5n 0.3336 22800.0n 0.6334 23399.5n 0.6334 23400.0n 0.3261 23999.5n 0.3261 24000.0n 0.4371 24599.5n 0.4371 24600.0n 0.3311 25199.5n 0.3311 25200.0n 0.6526 25799.5n 0.6526 25800.0n 0.6757 26399.5n 0.6757 26400.0n 0.6623 26999.5n 0.6623 27000.0n 0.6618 27599.5n 0.6618 27600.0n 0.6609 28199.5n 0.6609 28200.0n 0.3242 28799.5n 0.3242 28800.0n 0.6285 29399.5n 0.6285 29400.0n 0.6501 29999.5n 0.6501 30000.0n 0.6370 30599.5n 0.6370 30600.0n 0.5029 31199.5n 0.5029 31200.0n 0.4336 31799.5n 0.4336 31800.0n 0.6753 32399.5n 0.6753 32400.0n 0.6753 32999.5n 0.6753 33000.0n 0.4912 33599.5n 0.4912 33600.0n 0.5652 34199.5n 0.5652 34200.0n 0.3315 34799.5n 0.3315 34800.0n 0.6122 35399.5n 0.6122 35400.0n 0.5522 35999.5n 0.5522)
Cwp_wih_1_38 wp_wih_1_38 0 400p
Cwn_wih_1_38 wn_wih_1_38 0 400p
Xu_wih_1_38 xp_wih_1_38 xn_wih_1_38 yp_wih_1_38 yn_wih_1_38 wp_wih_1_38 wn_wih_1_38 vdd gbn gprod
Vxp_who_38_0 xp_who_38_0 0 PWL(0.0n 0.5584 599.5n 0.5584 600.0n 0.6399 1199.5n 0.6399 1200.0n 0.4683 1799.5n 0.4683 1800.0n 0.4957 2399.5n 0.4957 2400.0n 0.5342 2999.5n 0.5342 3000.0n 0.5577 3599.5n 0.5577 3600.0n 0.4809 4199.5n 0.4809 4200.0n 0.5503 4799.5n 0.5503 4800.0n 0.5274 5399.5n 0.5274 5400.0n 0.5288 5999.5n 0.5288 6000.0n 0.4654 6599.5n 0.4654 6600.0n 0.5224 7199.5n 0.5224 7200.0n 0.6134 7799.5n 0.6134 7800.0n 0.6134 8399.5n 0.6134 8400.0n 0.5050 8999.5n 0.5050 9000.0n 0.5290 9599.5n 0.5290 9600.0n 0.5375 10199.5n 0.5375 10200.0n 0.5732 10799.5n 0.5732 10800.0n 0.4498 11399.5n 0.4498 11400.0n 0.5291 11999.5n 0.5291 12000.0n 0.4956 12599.5n 0.4956 12600.0n 0.5396 13199.5n 0.5396 13200.0n 0.5724 13799.5n 0.5724 13800.0n 0.5979 14399.5n 0.5979 14400.0n 0.5366 14999.5n 0.5366 15000.0n 0.5440 15599.5n 0.5440 15600.0n 0.5326 16199.5n 0.5326 16200.0n 0.5987 16799.5n 0.5987 16800.0n 0.4934 17399.5n 0.4934 17400.0n 0.5752 17999.5n 0.5752 18000.0n 0.3416 18599.5n 0.3416 18600.0n 0.6615 19199.5n 0.6615 19200.0n 0.4676 19799.5n 0.4676 19800.0n 0.6136 20399.5n 0.6136 20400.0n 0.3898 20999.5n 0.3898 21000.0n 0.3448 21599.5n 0.3448 21600.0n 0.6471 22199.5n 0.6471 22200.0n 0.6664 22799.5n 0.6664 22800.0n 0.3666 23399.5n 0.3666 23400.0n 0.6739 23999.5n 0.6739 24000.0n 0.5629 24599.5n 0.5629 24600.0n 0.6689 25199.5n 0.6689 25200.0n 0.3474 25799.5n 0.3474 25800.0n 0.3243 26399.5n 0.3243 26400.0n 0.3377 26999.5n 0.3377 27000.0n 0.3382 27599.5n 0.3382 27600.0n 0.3391 28199.5n 0.3391 28200.0n 0.6758 28799.5n 0.6758 28800.0n 0.3715 29399.5n 0.3715 29400.0n 0.3499 29999.5n 0.3499 30000.0n 0.3630 30599.5n 0.3630 30600.0n 0.4971 31199.5n 0.4971 31200.0n 0.5664 31799.5n 0.5664 31800.0n 0.3247 32399.5n 0.3247 32400.0n 0.3247 32999.5n 0.3247 33000.0n 0.5088 33599.5n 0.5088 33600.0n 0.4348 34199.5n 0.4348 34200.0n 0.6685 34799.5n 0.6685 34800.0n 0.3878 35399.5n 0.3878 35400.0n 0.4478 35999.5n 0.4478)
Vxn_who_38_0 xn_who_38_0 0 PWL(0.0n 0.4416 599.5n 0.4416 600.0n 0.3601 1199.5n 0.3601 1200.0n 0.5317 1799.5n 0.5317 1800.0n 0.5043 2399.5n 0.5043 2400.0n 0.4658 2999.5n 0.4658 3000.0n 0.4423 3599.5n 0.4423 3600.0n 0.5191 4199.5n 0.5191 4200.0n 0.4497 4799.5n 0.4497 4800.0n 0.4726 5399.5n 0.4726 5400.0n 0.4712 5999.5n 0.4712 6000.0n 0.5346 6599.5n 0.5346 6600.0n 0.4776 7199.5n 0.4776 7200.0n 0.3866 7799.5n 0.3866 7800.0n 0.3866 8399.5n 0.3866 8400.0n 0.4950 8999.5n 0.4950 9000.0n 0.4710 9599.5n 0.4710 9600.0n 0.4625 10199.5n 0.4625 10200.0n 0.4268 10799.5n 0.4268 10800.0n 0.5502 11399.5n 0.5502 11400.0n 0.4709 11999.5n 0.4709 12000.0n 0.5044 12599.5n 0.5044 12600.0n 0.4604 13199.5n 0.4604 13200.0n 0.4276 13799.5n 0.4276 13800.0n 0.4021 14399.5n 0.4021 14400.0n 0.4634 14999.5n 0.4634 15000.0n 0.4560 15599.5n 0.4560 15600.0n 0.4674 16199.5n 0.4674 16200.0n 0.4013 16799.5n 0.4013 16800.0n 0.5066 17399.5n 0.5066 17400.0n 0.4248 17999.5n 0.4248 18000.0n 0.6584 18599.5n 0.6584 18600.0n 0.3385 19199.5n 0.3385 19200.0n 0.5324 19799.5n 0.5324 19800.0n 0.3864 20399.5n 0.3864 20400.0n 0.6102 20999.5n 0.6102 21000.0n 0.6552 21599.5n 0.6552 21600.0n 0.3529 22199.5n 0.3529 22200.0n 0.3336 22799.5n 0.3336 22800.0n 0.6334 23399.5n 0.6334 23400.0n 0.3261 23999.5n 0.3261 24000.0n 0.4371 24599.5n 0.4371 24600.0n 0.3311 25199.5n 0.3311 25200.0n 0.6526 25799.5n 0.6526 25800.0n 0.6757 26399.5n 0.6757 26400.0n 0.6623 26999.5n 0.6623 27000.0n 0.6618 27599.5n 0.6618 27600.0n 0.6609 28199.5n 0.6609 28200.0n 0.3242 28799.5n 0.3242 28800.0n 0.6285 29399.5n 0.6285 29400.0n 0.6501 29999.5n 0.6501 30000.0n 0.6370 30599.5n 0.6370 30600.0n 0.5029 31199.5n 0.5029 31200.0n 0.4336 31799.5n 0.4336 31800.0n 0.6753 32399.5n 0.6753 32400.0n 0.6753 32999.5n 0.6753 33000.0n 0.4912 33599.5n 0.4912 33600.0n 0.5652 34199.5n 0.5652 34200.0n 0.3315 34799.5n 0.3315 34800.0n 0.6122 35399.5n 0.6122 35400.0n 0.5522 35999.5n 0.5522)
Vyp_who_38_0 yp_who_38_0 0 PWL(0.0n 0.5031 599.5n 0.5031 600.0n 0.5023 1199.5n 0.5023 1200.0n 0.5052 1799.5n 0.5052 1800.0n 0.5048 2399.5n 0.5048 2400.0n 0.5043 2999.5n 0.5043 3000.0n 0.5034 3599.5n 0.5034 3600.0n 0.5048 4199.5n 0.5048 4200.0n 0.5031 4799.5n 0.5031 4800.0n 0.5040 5399.5n 0.5040 5400.0n 0.5040 5999.5n 0.5040 6000.0n 0.5054 6599.5n 0.5054 6600.0n 0.5040 7199.5n 0.5040 7200.0n 0.5027 7799.5n 0.5027 7800.0n 0.5027 8399.5n 0.5027 8400.0n 0.5038 8999.5n 0.5038 9000.0n 0.5040 9599.5n 0.5040 9600.0n 0.5039 10199.5n 0.5039 10200.0n 0.5033 10799.5n 0.5033 10800.0n 0.5056 11399.5n 0.5056 11400.0n 0.5040 11999.5n 0.5040 12000.0n 0.5036 12599.5n 0.5036 12600.0n 0.5039 13199.5n 0.5039 13200.0n 0.5029 13799.5n 0.5029 13800.0n 0.5025 14399.5n 0.5025 14400.0n 0.5038 14999.5n 0.5038 15000.0n 0.5041 15599.5n 0.5041 15600.0n 0.5036 16199.5n 0.5036 16200.0n 0.5025 16799.5n 0.5025 16800.0n 0.5040 17399.5n 0.5040 17400.0n 0.5029 17999.5n 0.5029 18000.0n 0.5057 18599.5n 0.5057 18600.0n 0.5010 19199.5n 0.5010 19200.0n 0.5041 19799.5n 0.5041 19800.0n 0.5021 20399.5n 0.5021 20400.0n 0.5044 20999.5n 0.5044 21000.0n 0.5056 21599.5n 0.5056 21600.0n 0.5016 22199.5n 0.5016 22200.0n 0.5006 22799.5n 0.5006 22800.0n 0.5041 23399.5n 0.5041 23400.0n 0.5027 23999.5n 0.5027 24000.0n 0.5029 24599.5n 0.5029 24600.0n 0.5006 25199.5n 0.5006 25200.0n 0.5047 25799.5n 0.5047 25800.0n 0.5046 26399.5n 0.5046 26400.0n 0.5039 26999.5n 0.5039 27000.0n 0.5049 27599.5n 0.5049 27600.0n 0.5039 28199.5n 0.5039 28200.0n 0.5017 28799.5n 0.5017 28800.0n 0.5042 29399.5n 0.5042 29400.0n 0.5056 29999.5n 0.5056 30000.0n 0.5051 30599.5n 0.5051 30600.0n 0.5039 31199.5n 0.5039 31200.0n 0.5033 31799.5n 0.5033 31800.0n 0.5049 32399.5n 0.5049 32400.0n 0.5045 32999.5n 0.5045 33000.0n 0.5036 33599.5n 0.5036 33600.0n 0.5042 34199.5n 0.5042 34200.0n 0.5012 34799.5n 0.5012 34800.0n 0.5036 35399.5n 0.5036 35400.0n 0.5042 35999.5n 0.5042)
Vyn_who_38_0 yn_who_38_0 0 PWL(0.0n 0.4969 599.5n 0.4969 600.0n 0.4977 1199.5n 0.4977 1200.0n 0.4948 1799.5n 0.4948 1800.0n 0.4952 2399.5n 0.4952 2400.0n 0.4957 2999.5n 0.4957 3000.0n 0.4966 3599.5n 0.4966 3600.0n 0.4952 4199.5n 0.4952 4200.0n 0.4969 4799.5n 0.4969 4800.0n 0.4960 5399.5n 0.4960 5400.0n 0.4960 5999.5n 0.4960 6000.0n 0.4946 6599.5n 0.4946 6600.0n 0.4960 7199.5n 0.4960 7200.0n 0.4973 7799.5n 0.4973 7800.0n 0.4973 8399.5n 0.4973 8400.0n 0.4962 8999.5n 0.4962 9000.0n 0.4960 9599.5n 0.4960 9600.0n 0.4961 10199.5n 0.4961 10200.0n 0.4967 10799.5n 0.4967 10800.0n 0.4944 11399.5n 0.4944 11400.0n 0.4960 11999.5n 0.4960 12000.0n 0.4964 12599.5n 0.4964 12600.0n 0.4961 13199.5n 0.4961 13200.0n 0.4971 13799.5n 0.4971 13800.0n 0.4975 14399.5n 0.4975 14400.0n 0.4962 14999.5n 0.4962 15000.0n 0.4959 15599.5n 0.4959 15600.0n 0.4964 16199.5n 0.4964 16200.0n 0.4975 16799.5n 0.4975 16800.0n 0.4960 17399.5n 0.4960 17400.0n 0.4971 17999.5n 0.4971 18000.0n 0.4943 18599.5n 0.4943 18600.0n 0.4990 19199.5n 0.4990 19200.0n 0.4959 19799.5n 0.4959 19800.0n 0.4979 20399.5n 0.4979 20400.0n 0.4956 20999.5n 0.4956 21000.0n 0.4944 21599.5n 0.4944 21600.0n 0.4984 22199.5n 0.4984 22200.0n 0.4994 22799.5n 0.4994 22800.0n 0.4959 23399.5n 0.4959 23400.0n 0.4973 23999.5n 0.4973 24000.0n 0.4971 24599.5n 0.4971 24600.0n 0.4994 25199.5n 0.4994 25200.0n 0.4953 25799.5n 0.4953 25800.0n 0.4954 26399.5n 0.4954 26400.0n 0.4961 26999.5n 0.4961 27000.0n 0.4951 27599.5n 0.4951 27600.0n 0.4961 28199.5n 0.4961 28200.0n 0.4983 28799.5n 0.4983 28800.0n 0.4958 29399.5n 0.4958 29400.0n 0.4944 29999.5n 0.4944 30000.0n 0.4949 30599.5n 0.4949 30600.0n 0.4961 31199.5n 0.4961 31200.0n 0.4967 31799.5n 0.4967 31800.0n 0.4951 32399.5n 0.4951 32400.0n 0.4955 32999.5n 0.4955 33000.0n 0.4964 33599.5n 0.4964 33600.0n 0.4958 34199.5n 0.4958 34200.0n 0.4988 34799.5n 0.4988 34800.0n 0.4964 35399.5n 0.4964 35400.0n 0.4958 35999.5n 0.4958)
Cwp_who_38_0 wp_who_38_0 0 400p
Cwn_who_38_0 wn_who_38_0 0 400p
Xu_who_38_0 xp_who_38_0 xn_who_38_0 yp_who_38_0 yn_who_38_0 wp_who_38_0 wn_who_38_0 vdd gbn gprod
Vxp_who_38_1 xp_who_38_1 0 PWL(0.0n 0.5584 599.5n 0.5584 600.0n 0.6399 1199.5n 0.6399 1200.0n 0.4683 1799.5n 0.4683 1800.0n 0.4957 2399.5n 0.4957 2400.0n 0.5342 2999.5n 0.5342 3000.0n 0.5577 3599.5n 0.5577 3600.0n 0.4809 4199.5n 0.4809 4200.0n 0.5503 4799.5n 0.5503 4800.0n 0.5274 5399.5n 0.5274 5400.0n 0.5288 5999.5n 0.5288 6000.0n 0.4654 6599.5n 0.4654 6600.0n 0.5224 7199.5n 0.5224 7200.0n 0.6134 7799.5n 0.6134 7800.0n 0.6134 8399.5n 0.6134 8400.0n 0.5050 8999.5n 0.5050 9000.0n 0.5290 9599.5n 0.5290 9600.0n 0.5375 10199.5n 0.5375 10200.0n 0.5732 10799.5n 0.5732 10800.0n 0.4498 11399.5n 0.4498 11400.0n 0.5291 11999.5n 0.5291 12000.0n 0.4956 12599.5n 0.4956 12600.0n 0.5396 13199.5n 0.5396 13200.0n 0.5724 13799.5n 0.5724 13800.0n 0.5979 14399.5n 0.5979 14400.0n 0.5366 14999.5n 0.5366 15000.0n 0.5440 15599.5n 0.5440 15600.0n 0.5326 16199.5n 0.5326 16200.0n 0.5987 16799.5n 0.5987 16800.0n 0.4934 17399.5n 0.4934 17400.0n 0.5752 17999.5n 0.5752 18000.0n 0.3416 18599.5n 0.3416 18600.0n 0.6615 19199.5n 0.6615 19200.0n 0.4676 19799.5n 0.4676 19800.0n 0.6136 20399.5n 0.6136 20400.0n 0.3898 20999.5n 0.3898 21000.0n 0.3448 21599.5n 0.3448 21600.0n 0.6471 22199.5n 0.6471 22200.0n 0.6664 22799.5n 0.6664 22800.0n 0.3666 23399.5n 0.3666 23400.0n 0.6739 23999.5n 0.6739 24000.0n 0.5629 24599.5n 0.5629 24600.0n 0.6689 25199.5n 0.6689 25200.0n 0.3474 25799.5n 0.3474 25800.0n 0.3243 26399.5n 0.3243 26400.0n 0.3377 26999.5n 0.3377 27000.0n 0.3382 27599.5n 0.3382 27600.0n 0.3391 28199.5n 0.3391 28200.0n 0.6758 28799.5n 0.6758 28800.0n 0.3715 29399.5n 0.3715 29400.0n 0.3499 29999.5n 0.3499 30000.0n 0.3630 30599.5n 0.3630 30600.0n 0.4971 31199.5n 0.4971 31200.0n 0.5664 31799.5n 0.5664 31800.0n 0.3247 32399.5n 0.3247 32400.0n 0.3247 32999.5n 0.3247 33000.0n 0.5088 33599.5n 0.5088 33600.0n 0.4348 34199.5n 0.4348 34200.0n 0.6685 34799.5n 0.6685 34800.0n 0.3878 35399.5n 0.3878 35400.0n 0.4478 35999.5n 0.4478)
Vxn_who_38_1 xn_who_38_1 0 PWL(0.0n 0.4416 599.5n 0.4416 600.0n 0.3601 1199.5n 0.3601 1200.0n 0.5317 1799.5n 0.5317 1800.0n 0.5043 2399.5n 0.5043 2400.0n 0.4658 2999.5n 0.4658 3000.0n 0.4423 3599.5n 0.4423 3600.0n 0.5191 4199.5n 0.5191 4200.0n 0.4497 4799.5n 0.4497 4800.0n 0.4726 5399.5n 0.4726 5400.0n 0.4712 5999.5n 0.4712 6000.0n 0.5346 6599.5n 0.5346 6600.0n 0.4776 7199.5n 0.4776 7200.0n 0.3866 7799.5n 0.3866 7800.0n 0.3866 8399.5n 0.3866 8400.0n 0.4950 8999.5n 0.4950 9000.0n 0.4710 9599.5n 0.4710 9600.0n 0.4625 10199.5n 0.4625 10200.0n 0.4268 10799.5n 0.4268 10800.0n 0.5502 11399.5n 0.5502 11400.0n 0.4709 11999.5n 0.4709 12000.0n 0.5044 12599.5n 0.5044 12600.0n 0.4604 13199.5n 0.4604 13200.0n 0.4276 13799.5n 0.4276 13800.0n 0.4021 14399.5n 0.4021 14400.0n 0.4634 14999.5n 0.4634 15000.0n 0.4560 15599.5n 0.4560 15600.0n 0.4674 16199.5n 0.4674 16200.0n 0.4013 16799.5n 0.4013 16800.0n 0.5066 17399.5n 0.5066 17400.0n 0.4248 17999.5n 0.4248 18000.0n 0.6584 18599.5n 0.6584 18600.0n 0.3385 19199.5n 0.3385 19200.0n 0.5324 19799.5n 0.5324 19800.0n 0.3864 20399.5n 0.3864 20400.0n 0.6102 20999.5n 0.6102 21000.0n 0.6552 21599.5n 0.6552 21600.0n 0.3529 22199.5n 0.3529 22200.0n 0.3336 22799.5n 0.3336 22800.0n 0.6334 23399.5n 0.6334 23400.0n 0.3261 23999.5n 0.3261 24000.0n 0.4371 24599.5n 0.4371 24600.0n 0.3311 25199.5n 0.3311 25200.0n 0.6526 25799.5n 0.6526 25800.0n 0.6757 26399.5n 0.6757 26400.0n 0.6623 26999.5n 0.6623 27000.0n 0.6618 27599.5n 0.6618 27600.0n 0.6609 28199.5n 0.6609 28200.0n 0.3242 28799.5n 0.3242 28800.0n 0.6285 29399.5n 0.6285 29400.0n 0.6501 29999.5n 0.6501 30000.0n 0.6370 30599.5n 0.6370 30600.0n 0.5029 31199.5n 0.5029 31200.0n 0.4336 31799.5n 0.4336 31800.0n 0.6753 32399.5n 0.6753 32400.0n 0.6753 32999.5n 0.6753 33000.0n 0.4912 33599.5n 0.4912 33600.0n 0.5652 34199.5n 0.5652 34200.0n 0.3315 34799.5n 0.3315 34800.0n 0.6122 35399.5n 0.6122 35400.0n 0.5522 35999.5n 0.5522)
Vyp_who_38_1 yp_who_38_1 0 PWL(0.0n 0.5071 599.5n 0.5071 600.0n 0.5053 1199.5n 0.5053 1200.0n 0.5052 1799.5n 0.5052 1800.0n 0.5027 2399.5n 0.5027 2400.0n 0.5034 2999.5n 0.5034 3000.0n 0.5055 3599.5n 0.5055 3600.0n 0.5056 4199.5n 0.5056 4200.0n 0.5071 4799.5n 0.5071 4800.0n 0.5056 5399.5n 0.5056 5400.0n 0.5056 5999.5n 0.5056 6000.0n 0.5048 6599.5n 0.5048 6600.0n 0.5060 7199.5n 0.5060 7200.0n 0.5048 7799.5n 0.5048 7800.0n 0.5046 8399.5n 0.5046 8400.0n 0.5066 8999.5n 0.5066 9000.0n 0.5056 9599.5n 0.5056 9600.0n 0.5051 10199.5n 0.5051 10200.0n 0.5046 10799.5n 0.5046 10800.0n 0.5056 11399.5n 0.5056 11400.0n 0.5058 11999.5n 0.5058 12000.0n 0.5068 12599.5n 0.5068 12600.0n 0.5050 13199.5n 0.5050 13200.0n 0.5071 13799.5n 0.5071 13800.0n 0.5059 14399.5n 0.5059 14400.0n 0.5058 14999.5n 0.5058 15000.0n 0.5043 15599.5n 0.5043 15600.0n 0.5067 16199.5n 0.5067 16200.0n 0.5068 16799.5n 0.5068 16800.0n 0.5066 17399.5n 0.5066 17400.0n 0.5069 17999.5n 0.5069 18000.0n 0.5061 18599.5n 0.5061 18600.0n 0.5034 19199.5n 0.5034 19200.0n 0.5010 19799.5n 0.5010 19800.0n 0.4989 20399.5n 0.4989 20400.0n 0.5022 20999.5n 0.5022 21000.0n 0.5086 21599.5n 0.5086 21600.0n 0.5007 22199.5n 0.5007 22200.0n 0.5023 22799.5n 0.5023 22800.0n 0.5021 23399.5n 0.5021 23400.0n 0.5077 23999.5n 0.5077 24000.0n 0.4979 24599.5n 0.4979 24600.0n 0.5035 25199.5n 0.5035 25200.0n 0.5041 25799.5n 0.5041 25800.0n 0.5075 26399.5n 0.5075 26400.0n 0.5041 26999.5n 0.5041 27000.0n 0.5056 27599.5n 0.5056 27600.0n 0.5039 28199.5n 0.5039 28200.0n 0.5059 28799.5n 0.5059 28800.0n 0.5023 29399.5n 0.5023 29400.0n 0.5086 29999.5n 0.5086 30000.0n 0.5084 30599.5n 0.5084 30600.0n 0.5085 31199.5n 0.5085 31200.0n 0.5088 31799.5n 0.5088 31800.0n 0.5078 32399.5n 0.5078 32400.0n 0.5074 32999.5n 0.5074 33000.0n 0.4996 33599.5n 0.4996 33600.0n 0.5010 34199.5n 0.5010 34200.0n 0.5044 34799.5n 0.5044 34800.0n 0.5084 35399.5n 0.5084 35400.0n 0.5012 35999.5n 0.5012)
Vyn_who_38_1 yn_who_38_1 0 PWL(0.0n 0.4929 599.5n 0.4929 600.0n 0.4947 1199.5n 0.4947 1200.0n 0.4948 1799.5n 0.4948 1800.0n 0.4973 2399.5n 0.4973 2400.0n 0.4966 2999.5n 0.4966 3000.0n 0.4945 3599.5n 0.4945 3600.0n 0.4944 4199.5n 0.4944 4200.0n 0.4929 4799.5n 0.4929 4800.0n 0.4944 5399.5n 0.4944 5400.0n 0.4944 5999.5n 0.4944 6000.0n 0.4952 6599.5n 0.4952 6600.0n 0.4940 7199.5n 0.4940 7200.0n 0.4952 7799.5n 0.4952 7800.0n 0.4954 8399.5n 0.4954 8400.0n 0.4934 8999.5n 0.4934 9000.0n 0.4944 9599.5n 0.4944 9600.0n 0.4949 10199.5n 0.4949 10200.0n 0.4954 10799.5n 0.4954 10800.0n 0.4944 11399.5n 0.4944 11400.0n 0.4942 11999.5n 0.4942 12000.0n 0.4932 12599.5n 0.4932 12600.0n 0.4950 13199.5n 0.4950 13200.0n 0.4929 13799.5n 0.4929 13800.0n 0.4941 14399.5n 0.4941 14400.0n 0.4942 14999.5n 0.4942 15000.0n 0.4957 15599.5n 0.4957 15600.0n 0.4933 16199.5n 0.4933 16200.0n 0.4932 16799.5n 0.4932 16800.0n 0.4934 17399.5n 0.4934 17400.0n 0.4931 17999.5n 0.4931 18000.0n 0.4939 18599.5n 0.4939 18600.0n 0.4966 19199.5n 0.4966 19200.0n 0.4990 19799.5n 0.4990 19800.0n 0.5011 20399.5n 0.5011 20400.0n 0.4978 20999.5n 0.4978 21000.0n 0.4914 21599.5n 0.4914 21600.0n 0.4993 22199.5n 0.4993 22200.0n 0.4977 22799.5n 0.4977 22800.0n 0.4979 23399.5n 0.4979 23400.0n 0.4923 23999.5n 0.4923 24000.0n 0.5021 24599.5n 0.5021 24600.0n 0.4965 25199.5n 0.4965 25200.0n 0.4959 25799.5n 0.4959 25800.0n 0.4925 26399.5n 0.4925 26400.0n 0.4959 26999.5n 0.4959 27000.0n 0.4944 27599.5n 0.4944 27600.0n 0.4961 28199.5n 0.4961 28200.0n 0.4941 28799.5n 0.4941 28800.0n 0.4977 29399.5n 0.4977 29400.0n 0.4914 29999.5n 0.4914 30000.0n 0.4916 30599.5n 0.4916 30600.0n 0.4915 31199.5n 0.4915 31200.0n 0.4912 31799.5n 0.4912 31800.0n 0.4922 32399.5n 0.4922 32400.0n 0.4926 32999.5n 0.4926 33000.0n 0.5004 33599.5n 0.5004 33600.0n 0.4990 34199.5n 0.4990 34200.0n 0.4956 34799.5n 0.4956 34800.0n 0.4916 35399.5n 0.4916 35400.0n 0.4988 35999.5n 0.4988)
Cwp_who_38_1 wp_who_38_1 0 400p
Cwn_who_38_1 wn_who_38_1 0 400p
Xu_who_38_1 xp_who_38_1 xn_who_38_1 yp_who_38_1 yn_who_38_1 wp_who_38_1 wn_who_38_1 vdd gbn gprod
Vxp_bh_38 xp_bh_38 0 PWL(0.0n 0.7100 599.5n 0.7100 600.0n 0.7100 1199.5n 0.7100 1200.0n 0.7100 1799.5n 0.7100 1800.0n 0.7100 2399.5n 0.7100 2400.0n 0.7100 2999.5n 0.7100 3000.0n 0.7100 3599.5n 0.7100 3600.0n 0.7100 4199.5n 0.7100 4200.0n 0.7100 4799.5n 0.7100 4800.0n 0.7100 5399.5n 0.7100 5400.0n 0.7100 5999.5n 0.7100 6000.0n 0.7100 6599.5n 0.7100 6600.0n 0.7100 7199.5n 0.7100 7200.0n 0.7100 7799.5n 0.7100 7800.0n 0.7100 8399.5n 0.7100 8400.0n 0.7100 8999.5n 0.7100 9000.0n 0.7100 9599.5n 0.7100 9600.0n 0.7100 10199.5n 0.7100 10200.0n 0.7100 10799.5n 0.7100 10800.0n 0.7100 11399.5n 0.7100 11400.0n 0.7100 11999.5n 0.7100 12000.0n 0.7100 12599.5n 0.7100 12600.0n 0.7100 13199.5n 0.7100 13200.0n 0.7100 13799.5n 0.7100 13800.0n 0.7100 14399.5n 0.7100 14400.0n 0.7100 14999.5n 0.7100 15000.0n 0.7100 15599.5n 0.7100 15600.0n 0.7100 16199.5n 0.7100 16200.0n 0.7100 16799.5n 0.7100 16800.0n 0.7100 17399.5n 0.7100 17400.0n 0.7100 17999.5n 0.7100 18000.0n 0.7100 18599.5n 0.7100 18600.0n 0.7100 19199.5n 0.7100 19200.0n 0.7100 19799.5n 0.7100 19800.0n 0.7100 20399.5n 0.7100 20400.0n 0.7100 20999.5n 0.7100 21000.0n 0.7100 21599.5n 0.7100 21600.0n 0.7100 22199.5n 0.7100 22200.0n 0.7100 22799.5n 0.7100 22800.0n 0.7100 23399.5n 0.7100 23400.0n 0.7100 23999.5n 0.7100 24000.0n 0.7100 24599.5n 0.7100 24600.0n 0.7100 25199.5n 0.7100 25200.0n 0.7100 25799.5n 0.7100 25800.0n 0.7100 26399.5n 0.7100 26400.0n 0.7100 26999.5n 0.7100 27000.0n 0.7100 27599.5n 0.7100 27600.0n 0.7100 28199.5n 0.7100 28200.0n 0.7100 28799.5n 0.7100 28800.0n 0.7100 29399.5n 0.7100 29400.0n 0.7100 29999.5n 0.7100 30000.0n 0.7100 30599.5n 0.7100 30600.0n 0.7100 31199.5n 0.7100 31200.0n 0.7100 31799.5n 0.7100 31800.0n 0.7100 32399.5n 0.7100 32400.0n 0.7100 32999.5n 0.7100 33000.0n 0.7100 33599.5n 0.7100 33600.0n 0.7100 34199.5n 0.7100 34200.0n 0.7100 34799.5n 0.7100 34800.0n 0.7100 35399.5n 0.7100 35400.0n 0.7100 35999.5n 0.7100)
Vxn_bh_38 xn_bh_38 0 PWL(0.0n 0.2900 599.5n 0.2900 600.0n 0.2900 1199.5n 0.2900 1200.0n 0.2900 1799.5n 0.2900 1800.0n 0.2900 2399.5n 0.2900 2400.0n 0.2900 2999.5n 0.2900 3000.0n 0.2900 3599.5n 0.2900 3600.0n 0.2900 4199.5n 0.2900 4200.0n 0.2900 4799.5n 0.2900 4800.0n 0.2900 5399.5n 0.2900 5400.0n 0.2900 5999.5n 0.2900 6000.0n 0.2900 6599.5n 0.2900 6600.0n 0.2900 7199.5n 0.2900 7200.0n 0.2900 7799.5n 0.2900 7800.0n 0.2900 8399.5n 0.2900 8400.0n 0.2900 8999.5n 0.2900 9000.0n 0.2900 9599.5n 0.2900 9600.0n 0.2900 10199.5n 0.2900 10200.0n 0.2900 10799.5n 0.2900 10800.0n 0.2900 11399.5n 0.2900 11400.0n 0.2900 11999.5n 0.2900 12000.0n 0.2900 12599.5n 0.2900 12600.0n 0.2900 13199.5n 0.2900 13200.0n 0.2900 13799.5n 0.2900 13800.0n 0.2900 14399.5n 0.2900 14400.0n 0.2900 14999.5n 0.2900 15000.0n 0.2900 15599.5n 0.2900 15600.0n 0.2900 16199.5n 0.2900 16200.0n 0.2900 16799.5n 0.2900 16800.0n 0.2900 17399.5n 0.2900 17400.0n 0.2900 17999.5n 0.2900 18000.0n 0.2900 18599.5n 0.2900 18600.0n 0.2900 19199.5n 0.2900 19200.0n 0.2900 19799.5n 0.2900 19800.0n 0.2900 20399.5n 0.2900 20400.0n 0.2900 20999.5n 0.2900 21000.0n 0.2900 21599.5n 0.2900 21600.0n 0.2900 22199.5n 0.2900 22200.0n 0.2900 22799.5n 0.2900 22800.0n 0.2900 23399.5n 0.2900 23400.0n 0.2900 23999.5n 0.2900 24000.0n 0.2900 24599.5n 0.2900 24600.0n 0.2900 25199.5n 0.2900 25200.0n 0.2900 25799.5n 0.2900 25800.0n 0.2900 26399.5n 0.2900 26400.0n 0.2900 26999.5n 0.2900 27000.0n 0.2900 27599.5n 0.2900 27600.0n 0.2900 28199.5n 0.2900 28200.0n 0.2900 28799.5n 0.2900 28800.0n 0.2900 29399.5n 0.2900 29400.0n 0.2900 29999.5n 0.2900 30000.0n 0.2900 30599.5n 0.2900 30600.0n 0.2900 31199.5n 0.2900 31200.0n 0.2900 31799.5n 0.2900 31800.0n 0.2900 32399.5n 0.2900 32400.0n 0.2900 32999.5n 0.2900 33000.0n 0.2900 33599.5n 0.2900 33600.0n 0.2900 34199.5n 0.2900 34200.0n 0.2900 34799.5n 0.2900 34800.0n 0.2900 35399.5n 0.2900 35400.0n 0.2900 35999.5n 0.2900)
Vyp_bh_38 yp_bh_38 0 PWL(0.0n 0.5584 599.5n 0.5584 600.0n 0.6399 1199.5n 0.6399 1200.0n 0.4683 1799.5n 0.4683 1800.0n 0.4957 2399.5n 0.4957 2400.0n 0.5342 2999.5n 0.5342 3000.0n 0.5577 3599.5n 0.5577 3600.0n 0.4809 4199.5n 0.4809 4200.0n 0.5503 4799.5n 0.5503 4800.0n 0.5274 5399.5n 0.5274 5400.0n 0.5288 5999.5n 0.5288 6000.0n 0.4654 6599.5n 0.4654 6600.0n 0.5224 7199.5n 0.5224 7200.0n 0.6134 7799.5n 0.6134 7800.0n 0.6134 8399.5n 0.6134 8400.0n 0.5050 8999.5n 0.5050 9000.0n 0.5290 9599.5n 0.5290 9600.0n 0.5375 10199.5n 0.5375 10200.0n 0.5732 10799.5n 0.5732 10800.0n 0.4498 11399.5n 0.4498 11400.0n 0.5291 11999.5n 0.5291 12000.0n 0.4956 12599.5n 0.4956 12600.0n 0.5396 13199.5n 0.5396 13200.0n 0.5724 13799.5n 0.5724 13800.0n 0.5979 14399.5n 0.5979 14400.0n 0.5366 14999.5n 0.5366 15000.0n 0.5440 15599.5n 0.5440 15600.0n 0.5326 16199.5n 0.5326 16200.0n 0.5987 16799.5n 0.5987 16800.0n 0.4934 17399.5n 0.4934 17400.0n 0.5752 17999.5n 0.5752 18000.0n 0.3416 18599.5n 0.3416 18600.0n 0.6615 19199.5n 0.6615 19200.0n 0.4676 19799.5n 0.4676 19800.0n 0.6136 20399.5n 0.6136 20400.0n 0.3898 20999.5n 0.3898 21000.0n 0.3448 21599.5n 0.3448 21600.0n 0.6471 22199.5n 0.6471 22200.0n 0.6664 22799.5n 0.6664 22800.0n 0.3666 23399.5n 0.3666 23400.0n 0.6739 23999.5n 0.6739 24000.0n 0.5629 24599.5n 0.5629 24600.0n 0.6689 25199.5n 0.6689 25200.0n 0.3474 25799.5n 0.3474 25800.0n 0.3243 26399.5n 0.3243 26400.0n 0.3377 26999.5n 0.3377 27000.0n 0.3382 27599.5n 0.3382 27600.0n 0.3391 28199.5n 0.3391 28200.0n 0.6758 28799.5n 0.6758 28800.0n 0.3715 29399.5n 0.3715 29400.0n 0.3499 29999.5n 0.3499 30000.0n 0.3630 30599.5n 0.3630 30600.0n 0.4971 31199.5n 0.4971 31200.0n 0.5664 31799.5n 0.5664 31800.0n 0.3247 32399.5n 0.3247 32400.0n 0.3247 32999.5n 0.3247 33000.0n 0.5088 33599.5n 0.5088 33600.0n 0.4348 34199.5n 0.4348 34200.0n 0.6685 34799.5n 0.6685 34800.0n 0.3878 35399.5n 0.3878 35400.0n 0.4478 35999.5n 0.4478)
Vyn_bh_38 yn_bh_38 0 PWL(0.0n 0.4416 599.5n 0.4416 600.0n 0.3601 1199.5n 0.3601 1200.0n 0.5317 1799.5n 0.5317 1800.0n 0.5043 2399.5n 0.5043 2400.0n 0.4658 2999.5n 0.4658 3000.0n 0.4423 3599.5n 0.4423 3600.0n 0.5191 4199.5n 0.5191 4200.0n 0.4497 4799.5n 0.4497 4800.0n 0.4726 5399.5n 0.4726 5400.0n 0.4712 5999.5n 0.4712 6000.0n 0.5346 6599.5n 0.5346 6600.0n 0.4776 7199.5n 0.4776 7200.0n 0.3866 7799.5n 0.3866 7800.0n 0.3866 8399.5n 0.3866 8400.0n 0.4950 8999.5n 0.4950 9000.0n 0.4710 9599.5n 0.4710 9600.0n 0.4625 10199.5n 0.4625 10200.0n 0.4268 10799.5n 0.4268 10800.0n 0.5502 11399.5n 0.5502 11400.0n 0.4709 11999.5n 0.4709 12000.0n 0.5044 12599.5n 0.5044 12600.0n 0.4604 13199.5n 0.4604 13200.0n 0.4276 13799.5n 0.4276 13800.0n 0.4021 14399.5n 0.4021 14400.0n 0.4634 14999.5n 0.4634 15000.0n 0.4560 15599.5n 0.4560 15600.0n 0.4674 16199.5n 0.4674 16200.0n 0.4013 16799.5n 0.4013 16800.0n 0.5066 17399.5n 0.5066 17400.0n 0.4248 17999.5n 0.4248 18000.0n 0.6584 18599.5n 0.6584 18600.0n 0.3385 19199.5n 0.3385 19200.0n 0.5324 19799.5n 0.5324 19800.0n 0.3864 20399.5n 0.3864 20400.0n 0.6102 20999.5n 0.6102 21000.0n 0.6552 21599.5n 0.6552 21600.0n 0.3529 22199.5n 0.3529 22200.0n 0.3336 22799.5n 0.3336 22800.0n 0.6334 23399.5n 0.6334 23400.0n 0.3261 23999.5n 0.3261 24000.0n 0.4371 24599.5n 0.4371 24600.0n 0.3311 25199.5n 0.3311 25200.0n 0.6526 25799.5n 0.6526 25800.0n 0.6757 26399.5n 0.6757 26400.0n 0.6623 26999.5n 0.6623 27000.0n 0.6618 27599.5n 0.6618 27600.0n 0.6609 28199.5n 0.6609 28200.0n 0.3242 28799.5n 0.3242 28800.0n 0.6285 29399.5n 0.6285 29400.0n 0.6501 29999.5n 0.6501 30000.0n 0.6370 30599.5n 0.6370 30600.0n 0.5029 31199.5n 0.5029 31200.0n 0.4336 31799.5n 0.4336 31800.0n 0.6753 32399.5n 0.6753 32400.0n 0.6753 32999.5n 0.6753 33000.0n 0.4912 33599.5n 0.4912 33600.0n 0.5652 34199.5n 0.5652 34200.0n 0.3315 34799.5n 0.3315 34800.0n 0.6122 35399.5n 0.6122 35400.0n 0.5522 35999.5n 0.5522)
Cwp_bh_38 wp_bh_38 0 400p
Cwn_bh_38 wn_bh_38 0 400p
Xu_bh_38 xp_bh_38 xn_bh_38 yp_bh_38 yn_bh_38 wp_bh_38 wn_bh_38 vdd gbn gprod
Vxp_wih_0_39 xp_wih_0_39 0 PWL(0.0n 0.4942 599.5n 0.4942 600.0n 0.5558 1199.5n 0.5558 1200.0n 0.4708 1799.5n 0.4708 1800.0n 0.5235 2399.5n 0.5235 2400.0n 0.5350 2999.5n 0.5350 3000.0n 0.5172 3599.5n 0.5172 3600.0n 0.4702 4199.5n 0.4702 4200.0n 0.4867 4799.5n 0.4867 4800.0n 0.4970 5399.5n 0.4970 5400.0n 0.4986 5999.5n 0.4986 6000.0n 0.4751 6599.5n 0.4751 6600.0n 0.4870 7199.5n 0.4870 7200.0n 0.5502 7799.5n 0.5502 7800.0n 0.5521 8399.5n 0.5521 8400.0n 0.4638 8999.5n 0.4638 9000.0n 0.4982 9599.5n 0.4982 9600.0n 0.5131 10199.5n 0.5131 10200.0n 0.5386 10799.5n 0.5386 10800.0n 0.4592 11399.5n 0.4592 11400.0n 0.4950 11999.5n 0.4950 12000.0n 0.4559 12599.5n 0.4559 12600.0n 0.5162 13199.5n 0.5162 13200.0n 0.5038 13799.5n 0.5038 13800.0n 0.5333 14399.5n 0.5333 14400.0n 0.4991 14999.5n 0.4991 15000.0n 0.5298 15599.5n 0.5298 15600.0n 0.4823 16199.5n 0.4823 16200.0n 0.5239 16799.5n 0.5239 16800.0n 0.4592 17399.5n 0.4592 17400.0n 0.5094 17999.5n 0.5094 18000.0n 0.4337 18599.5n 0.4337 18600.0n 0.5977 19199.5n 0.5977 19200.0n 0.5364 19799.5n 0.5364 19800.0n 0.6122 20399.5n 0.6122 20400.0n 0.4856 20999.5n 0.4856 21000.0n 0.3861 21599.5n 0.3861 21600.0n 0.6094 22199.5n 0.6094 22200.0n 0.6364 22799.5n 0.6364 22800.0n 0.4807 23399.5n 0.4807 23400.0n 0.5614 23999.5n 0.5614 24000.0n 0.5913 24599.5n 0.5913 24600.0n 0.6295 25199.5n 0.6295 25200.0n 0.4496 25799.5n 0.4496 25800.0n 0.3792 26399.5n 0.3792 26400.0n 0.4434 26999.5n 0.4434 27000.0n 0.4340 27599.5n 0.4340 27600.0n 0.4461 28199.5n 0.4461 28200.0n 0.5791 28799.5n 0.5791 28800.0n 0.4777 29399.5n 0.4777 29400.0n 0.3878 29999.5n 0.3878 30000.0n 0.3832 30599.5n 0.3832 30600.0n 0.4022 31199.5n 0.4022 31200.0n 0.4482 31799.5n 0.4482 31800.0n 0.3662 32399.5n 0.3662 32400.0n 0.3857 32999.5n 0.3857 33000.0n 0.5584 33599.5n 0.5584 33600.0n 0.5284 34199.5n 0.5284 34200.0n 0.6034 34799.5n 0.6034 34800.0n 0.3469 35399.5n 0.3469 35400.0n 0.5290 35999.5n 0.5290)
Vxn_wih_0_39 xn_wih_0_39 0 PWL(0.0n 0.5058 599.5n 0.5058 600.0n 0.4442 1199.5n 0.4442 1200.0n 0.5292 1799.5n 0.5292 1800.0n 0.4765 2399.5n 0.4765 2400.0n 0.4650 2999.5n 0.4650 3000.0n 0.4828 3599.5n 0.4828 3600.0n 0.5298 4199.5n 0.5298 4200.0n 0.5133 4799.5n 0.5133 4800.0n 0.5030 5399.5n 0.5030 5400.0n 0.5014 5999.5n 0.5014 6000.0n 0.5249 6599.5n 0.5249 6600.0n 0.5130 7199.5n 0.5130 7200.0n 0.4498 7799.5n 0.4498 7800.0n 0.4479 8399.5n 0.4479 8400.0n 0.5362 8999.5n 0.5362 9000.0n 0.5018 9599.5n 0.5018 9600.0n 0.4869 10199.5n 0.4869 10200.0n 0.4614 10799.5n 0.4614 10800.0n 0.5408 11399.5n 0.5408 11400.0n 0.5050 11999.5n 0.5050 12000.0n 0.5441 12599.5n 0.5441 12600.0n 0.4838 13199.5n 0.4838 13200.0n 0.4962 13799.5n 0.4962 13800.0n 0.4667 14399.5n 0.4667 14400.0n 0.5009 14999.5n 0.5009 15000.0n 0.4702 15599.5n 0.4702 15600.0n 0.5177 16199.5n 0.5177 16200.0n 0.4761 16799.5n 0.4761 16800.0n 0.5408 17399.5n 0.5408 17400.0n 0.4906 17999.5n 0.4906 18000.0n 0.5663 18599.5n 0.5663 18600.0n 0.4023 19199.5n 0.4023 19200.0n 0.4636 19799.5n 0.4636 19800.0n 0.3878 20399.5n 0.3878 20400.0n 0.5144 20999.5n 0.5144 21000.0n 0.6139 21599.5n 0.6139 21600.0n 0.3906 22199.5n 0.3906 22200.0n 0.3636 22799.5n 0.3636 22800.0n 0.5193 23399.5n 0.5193 23400.0n 0.4386 23999.5n 0.4386 24000.0n 0.4087 24599.5n 0.4087 24600.0n 0.3705 25199.5n 0.3705 25200.0n 0.5504 25799.5n 0.5504 25800.0n 0.6208 26399.5n 0.6208 26400.0n 0.5566 26999.5n 0.5566 27000.0n 0.5660 27599.5n 0.5660 27600.0n 0.5539 28199.5n 0.5539 28200.0n 0.4209 28799.5n 0.4209 28800.0n 0.5223 29399.5n 0.5223 29400.0n 0.6122 29999.5n 0.6122 30000.0n 0.6168 30599.5n 0.6168 30600.0n 0.5978 31199.5n 0.5978 31200.0n 0.5518 31799.5n 0.5518 31800.0n 0.6338 32399.5n 0.6338 32400.0n 0.6143 32999.5n 0.6143 33000.0n 0.4416 33599.5n 0.4416 33600.0n 0.4716 34199.5n 0.4716 34200.0n 0.3966 34799.5n 0.3966 34800.0n 0.6531 35399.5n 0.6531 35400.0n 0.4710 35999.5n 0.4710)
Vyp_wih_0_39 yp_wih_0_39 0 PWL(0.0n 0.4790 599.5n 0.4790 600.0n 0.3707 1199.5n 0.3707 1200.0n 0.4540 1799.5n 0.4540 1800.0n 0.3538 2399.5n 0.3538 2400.0n 0.3551 2999.5n 0.3551 3000.0n 0.4224 3599.5n 0.4224 3600.0n 0.4676 4199.5n 0.4676 4200.0n 0.4894 4799.5n 0.4894 4800.0n 0.4425 5399.5n 0.4425 5400.0n 0.4400 5999.5n 0.4400 6000.0n 0.4390 6599.5n 0.4390 6600.0n 0.4620 7199.5n 0.4620 7200.0n 0.3694 7799.5n 0.3694 7800.0n 0.3610 8399.5n 0.3610 8400.0n 0.5107 8999.5n 0.5107 9000.0n 0.4410 9599.5n 0.4410 9600.0n 0.4136 10199.5n 0.4136 10200.0n 0.3759 10799.5n 0.3759 10800.0n 0.4746 11399.5n 0.4746 11400.0n 0.4489 11999.5n 0.4489 12000.0n 0.5301 12599.5n 0.5301 12600.0n 0.4079 13199.5n 0.4079 13200.0n 0.4696 13799.5n 0.4696 13800.0n 0.4161 14399.5n 0.4161 14400.0n 0.4462 14999.5n 0.4462 15000.0n 0.3763 15599.5n 0.3763 15600.0n 0.4837 16199.5n 0.4837 16200.0n 0.4446 16799.5n 0.4446 16800.0n 0.5158 17399.5n 0.5158 17400.0n 0.4588 17999.5n 0.4588 18000.0n 0.4459 18599.5n 0.4459 18600.0n 0.3398 19199.5n 0.3398 19200.0n 0.3352 19799.5n 0.3352 19800.0n 0.3213 20399.5n 0.3213 20400.0n 0.3485 20999.5n 0.3485 21000.0n 0.5654 21599.5n 0.5654 21600.0n 0.3274 22199.5n 0.3274 22200.0n 0.3329 22799.5n 0.3329 22800.0n 0.3441 23399.5n 0.3441 23400.0n 0.4761 23999.5n 0.4761 24000.0n 0.3184 24599.5n 0.3184 24600.0n 0.3373 25199.5n 0.3373 25200.0n 0.3962 25799.5n 0.3962 25800.0n 0.4759 26399.5n 0.4759 26400.0n 0.3905 26999.5n 0.3905 27000.0n 0.4303 27599.5n 0.4303 27600.0n 0.3843 28199.5n 0.3843 28200.0n 0.4269 28799.5n 0.4269 28800.0n 0.3486 29399.5n 0.3486 29400.0n 0.5778 29999.5n 0.5778 30000.0n 0.6037 30599.5n 0.6037 30600.0n 0.6652 31199.5n 0.6652 31200.0n 0.6306 31799.5n 0.6306 31800.0n 0.4928 32399.5n 0.4928 32400.0n 0.4695 32999.5n 0.4695 33000.0n 0.3262 33599.5n 0.3262 33600.0n 0.3332 34199.5n 0.3332 34200.0n 0.3469 34799.5n 0.3469 34800.0n 0.6527 35399.5n 0.6527 35400.0n 0.3358 35999.5n 0.3358)
Vyn_wih_0_39 yn_wih_0_39 0 PWL(0.0n 0.5210 599.5n 0.5210 600.0n 0.6293 1199.5n 0.6293 1200.0n 0.5460 1799.5n 0.5460 1800.0n 0.6462 2399.5n 0.6462 2400.0n 0.6449 2999.5n 0.6449 3000.0n 0.5776 3599.5n 0.5776 3600.0n 0.5324 4199.5n 0.5324 4200.0n 0.5106 4799.5n 0.5106 4800.0n 0.5575 5399.5n 0.5575 5400.0n 0.5600 5999.5n 0.5600 6000.0n 0.5610 6599.5n 0.5610 6600.0n 0.5380 7199.5n 0.5380 7200.0n 0.6306 7799.5n 0.6306 7800.0n 0.6390 8399.5n 0.6390 8400.0n 0.4893 8999.5n 0.4893 9000.0n 0.5590 9599.5n 0.5590 9600.0n 0.5864 10199.5n 0.5864 10200.0n 0.6241 10799.5n 0.6241 10800.0n 0.5254 11399.5n 0.5254 11400.0n 0.5511 11999.5n 0.5511 12000.0n 0.4699 12599.5n 0.4699 12600.0n 0.5921 13199.5n 0.5921 13200.0n 0.5304 13799.5n 0.5304 13800.0n 0.5839 14399.5n 0.5839 14400.0n 0.5538 14999.5n 0.5538 15000.0n 0.6237 15599.5n 0.6237 15600.0n 0.5163 16199.5n 0.5163 16200.0n 0.5554 16799.5n 0.5554 16800.0n 0.4842 17399.5n 0.4842 17400.0n 0.5412 17999.5n 0.5412 18000.0n 0.5541 18599.5n 0.5541 18600.0n 0.6602 19199.5n 0.6602 19200.0n 0.6648 19799.5n 0.6648 19800.0n 0.6787 20399.5n 0.6787 20400.0n 0.6515 20999.5n 0.6515 21000.0n 0.4346 21599.5n 0.4346 21600.0n 0.6726 22199.5n 0.6726 22200.0n 0.6671 22799.5n 0.6671 22800.0n 0.6559 23399.5n 0.6559 23400.0n 0.5239 23999.5n 0.5239 24000.0n 0.6816 24599.5n 0.6816 24600.0n 0.6627 25199.5n 0.6627 25200.0n 0.6038 25799.5n 0.6038 25800.0n 0.5241 26399.5n 0.5241 26400.0n 0.6095 26999.5n 0.6095 27000.0n 0.5697 27599.5n 0.5697 27600.0n 0.6157 28199.5n 0.6157 28200.0n 0.5731 28799.5n 0.5731 28800.0n 0.6514 29399.5n 0.6514 29400.0n 0.4222 29999.5n 0.4222 30000.0n 0.3963 30599.5n 0.3963 30600.0n 0.3348 31199.5n 0.3348 31200.0n 0.3694 31799.5n 0.3694 31800.0n 0.5072 32399.5n 0.5072 32400.0n 0.5305 32999.5n 0.5305 33000.0n 0.6738 33599.5n 0.6738 33600.0n 0.6668 34199.5n 0.6668 34200.0n 0.6531 34799.5n 0.6531 34800.0n 0.3473 35399.5n 0.3473 35400.0n 0.6642 35999.5n 0.6642)
Cwp_wih_0_39 wp_wih_0_39 0 400p
Cwn_wih_0_39 wn_wih_0_39 0 400p
Xu_wih_0_39 xp_wih_0_39 xn_wih_0_39 yp_wih_0_39 yn_wih_0_39 wp_wih_0_39 wn_wih_0_39 vdd gbn gprod
Vxp_wih_1_39 xp_wih_1_39 0 PWL(0.0n 0.5370 599.5n 0.5370 600.0n 0.5167 1199.5n 0.5167 1200.0n 0.4793 1799.5n 0.4793 1800.0n 0.4441 2399.5n 0.4441 2400.0n 0.4555 2999.5n 0.4555 3000.0n 0.5055 3599.5n 0.5055 3600.0n 0.4939 4199.5n 0.4939 4200.0n 0.5385 4799.5n 0.5385 4800.0n 0.5024 5399.5n 0.5024 5400.0n 0.5015 5999.5n 0.5015 6000.0n 0.4700 6599.5n 0.4700 6600.0n 0.5120 7199.5n 0.5120 7200.0n 0.5006 7799.5n 0.5006 7800.0n 0.4950 8399.5n 0.4950 8400.0n 0.5309 8999.5n 0.5309 9000.0n 0.5023 9599.5n 0.5023 9600.0n 0.4893 10199.5n 0.4893 10200.0n 0.4837 10799.5n 0.4837 10800.0n 0.4823 11399.5n 0.4823 11400.0n 0.5074 11999.5n 0.5074 12000.0n 0.5364 12599.5n 0.5364 12600.0n 0.4868 13199.5n 0.4868 13200.0n 0.5380 13799.5n 0.5380 13800.0n 0.5220 14399.5n 0.5220 14400.0n 0.5095 14999.5n 0.5095 15000.0n 0.4705 15599.5n 0.4705 15600.0n 0.5289 16199.5n 0.5289 16200.0n 0.5368 16799.5n 0.5368 16800.0n 0.5287 17399.5n 0.5287 17400.0n 0.5342 17999.5n 0.5342 18000.0n 0.4253 18599.5n 0.4253 18600.0n 0.5119 19199.5n 0.5119 19200.0n 0.4104 19799.5n 0.4104 19800.0n 0.4314 20399.5n 0.4314 20400.0n 0.4005 20999.5n 0.4005 21000.0n 0.4696 21599.5n 0.4696 21600.0n 0.4531 22199.5n 0.4531 22200.0n 0.5039 22799.5n 0.5039 22800.0n 0.3608 23399.5n 0.3608 23400.0n 0.6273 23999.5n 0.6273 24000.0n 0.3928 24599.5n 0.3928 24600.0n 0.5253 25199.5n 0.5253 25200.0n 0.4107 25799.5n 0.4107 25800.0n 0.3947 26399.5n 0.3947 26400.0n 0.3716 26999.5n 0.3716 27000.0n 0.4111 27599.5n 0.4111 27600.0n 0.3715 28199.5n 0.3715 28200.0n 0.5939 28799.5n 0.5939 28800.0n 0.3849 29399.5n 0.3849 29400.0n 0.4835 29999.5n 0.4835 30000.0n 0.5119 30599.5n 0.5119 30600.0n 0.6226 31199.5n 0.6226 31200.0n 0.6064 31799.5n 0.6064 31800.0n 0.4115 32399.5n 0.4115 32400.0n 0.3900 32999.5n 0.3900 33000.0n 0.3958 33599.5n 0.3958 33600.0n 0.3747 34199.5n 0.3747 34200.0n 0.5423 34799.5n 0.5423 34800.0n 0.5509 35399.5n 0.5509 35400.0n 0.3990 35999.5n 0.3990)
Vxn_wih_1_39 xn_wih_1_39 0 PWL(0.0n 0.4630 599.5n 0.4630 600.0n 0.4833 1199.5n 0.4833 1200.0n 0.5207 1799.5n 0.5207 1800.0n 0.5559 2399.5n 0.5559 2400.0n 0.5445 2999.5n 0.5445 3000.0n 0.4945 3599.5n 0.4945 3600.0n 0.5061 4199.5n 0.5061 4200.0n 0.4615 4799.5n 0.4615 4800.0n 0.4976 5399.5n 0.4976 5400.0n 0.4985 5999.5n 0.4985 6000.0n 0.5300 6599.5n 0.5300 6600.0n 0.4880 7199.5n 0.4880 7200.0n 0.4994 7799.5n 0.4994 7800.0n 0.5050 8399.5n 0.5050 8400.0n 0.4691 8999.5n 0.4691 9000.0n 0.4977 9599.5n 0.4977 9600.0n 0.5107 10199.5n 0.5107 10200.0n 0.5163 10799.5n 0.5163 10800.0n 0.5177 11399.5n 0.5177 11400.0n 0.4926 11999.5n 0.4926 12000.0n 0.4636 12599.5n 0.4636 12600.0n 0.5132 13199.5n 0.5132 13200.0n 0.4620 13799.5n 0.4620 13800.0n 0.4780 14399.5n 0.4780 14400.0n 0.4905 14999.5n 0.4905 15000.0n 0.5295 15599.5n 0.5295 15600.0n 0.4711 16199.5n 0.4711 16200.0n 0.4632 16799.5n 0.4632 16800.0n 0.4713 17399.5n 0.4713 17400.0n 0.4658 17999.5n 0.4658 18000.0n 0.5747 18599.5n 0.5747 18600.0n 0.4881 19199.5n 0.4881 19200.0n 0.5896 19799.5n 0.5896 19800.0n 0.5686 20399.5n 0.5686 20400.0n 0.5995 20999.5n 0.5995 21000.0n 0.5304 21599.5n 0.5304 21600.0n 0.5469 22199.5n 0.5469 22200.0n 0.4961 22799.5n 0.4961 22800.0n 0.6392 23399.5n 0.6392 23400.0n 0.3727 23999.5n 0.3727 24000.0n 0.6072 24599.5n 0.6072 24600.0n 0.4747 25199.5n 0.4747 25200.0n 0.5893 25799.5n 0.5893 25800.0n 0.6053 26399.5n 0.6053 26400.0n 0.6284 26999.5n 0.6284 27000.0n 0.5889 27599.5n 0.5889 27600.0n 0.6285 28199.5n 0.6285 28200.0n 0.4061 28799.5n 0.4061 28800.0n 0.6151 29399.5n 0.6151 29400.0n 0.5165 29999.5n 0.5165 30000.0n 0.4881 30599.5n 0.4881 30600.0n 0.3774 31199.5n 0.3774 31200.0n 0.3936 31799.5n 0.3936 31800.0n 0.5885 32399.5n 0.5885 32400.0n 0.6100 32999.5n 0.6100 33000.0n 0.6042 33599.5n 0.6042 33600.0n 0.6253 34199.5n 0.6253 34200.0n 0.4577 34799.5n 0.4577 34800.0n 0.4491 35399.5n 0.4491 35400.0n 0.6010 35999.5n 0.6010)
Vyp_wih_1_39 yp_wih_1_39 0 PWL(0.0n 0.4790 599.5n 0.4790 600.0n 0.3707 1199.5n 0.3707 1200.0n 0.4540 1799.5n 0.4540 1800.0n 0.3538 2399.5n 0.3538 2400.0n 0.3551 2999.5n 0.3551 3000.0n 0.4224 3599.5n 0.4224 3600.0n 0.4676 4199.5n 0.4676 4200.0n 0.4894 4799.5n 0.4894 4800.0n 0.4425 5399.5n 0.4425 5400.0n 0.4400 5999.5n 0.4400 6000.0n 0.4390 6599.5n 0.4390 6600.0n 0.4620 7199.5n 0.4620 7200.0n 0.3694 7799.5n 0.3694 7800.0n 0.3610 8399.5n 0.3610 8400.0n 0.5107 8999.5n 0.5107 9000.0n 0.4410 9599.5n 0.4410 9600.0n 0.4136 10199.5n 0.4136 10200.0n 0.3759 10799.5n 0.3759 10800.0n 0.4746 11399.5n 0.4746 11400.0n 0.4489 11999.5n 0.4489 12000.0n 0.5301 12599.5n 0.5301 12600.0n 0.4079 13199.5n 0.4079 13200.0n 0.4696 13799.5n 0.4696 13800.0n 0.4161 14399.5n 0.4161 14400.0n 0.4462 14999.5n 0.4462 15000.0n 0.3763 15599.5n 0.3763 15600.0n 0.4837 16199.5n 0.4837 16200.0n 0.4446 16799.5n 0.4446 16800.0n 0.5158 17399.5n 0.5158 17400.0n 0.4588 17999.5n 0.4588 18000.0n 0.4459 18599.5n 0.4459 18600.0n 0.3398 19199.5n 0.3398 19200.0n 0.3352 19799.5n 0.3352 19800.0n 0.3213 20399.5n 0.3213 20400.0n 0.3485 20999.5n 0.3485 21000.0n 0.5654 21599.5n 0.5654 21600.0n 0.3274 22199.5n 0.3274 22200.0n 0.3329 22799.5n 0.3329 22800.0n 0.3441 23399.5n 0.3441 23400.0n 0.4761 23999.5n 0.4761 24000.0n 0.3184 24599.5n 0.3184 24600.0n 0.3373 25199.5n 0.3373 25200.0n 0.3962 25799.5n 0.3962 25800.0n 0.4759 26399.5n 0.4759 26400.0n 0.3905 26999.5n 0.3905 27000.0n 0.4303 27599.5n 0.4303 27600.0n 0.3843 28199.5n 0.3843 28200.0n 0.4269 28799.5n 0.4269 28800.0n 0.3486 29399.5n 0.3486 29400.0n 0.5778 29999.5n 0.5778 30000.0n 0.6037 30599.5n 0.6037 30600.0n 0.6652 31199.5n 0.6652 31200.0n 0.6306 31799.5n 0.6306 31800.0n 0.4928 32399.5n 0.4928 32400.0n 0.4695 32999.5n 0.4695 33000.0n 0.3262 33599.5n 0.3262 33600.0n 0.3332 34199.5n 0.3332 34200.0n 0.3469 34799.5n 0.3469 34800.0n 0.6527 35399.5n 0.6527 35400.0n 0.3358 35999.5n 0.3358)
Vyn_wih_1_39 yn_wih_1_39 0 PWL(0.0n 0.5210 599.5n 0.5210 600.0n 0.6293 1199.5n 0.6293 1200.0n 0.5460 1799.5n 0.5460 1800.0n 0.6462 2399.5n 0.6462 2400.0n 0.6449 2999.5n 0.6449 3000.0n 0.5776 3599.5n 0.5776 3600.0n 0.5324 4199.5n 0.5324 4200.0n 0.5106 4799.5n 0.5106 4800.0n 0.5575 5399.5n 0.5575 5400.0n 0.5600 5999.5n 0.5600 6000.0n 0.5610 6599.5n 0.5610 6600.0n 0.5380 7199.5n 0.5380 7200.0n 0.6306 7799.5n 0.6306 7800.0n 0.6390 8399.5n 0.6390 8400.0n 0.4893 8999.5n 0.4893 9000.0n 0.5590 9599.5n 0.5590 9600.0n 0.5864 10199.5n 0.5864 10200.0n 0.6241 10799.5n 0.6241 10800.0n 0.5254 11399.5n 0.5254 11400.0n 0.5511 11999.5n 0.5511 12000.0n 0.4699 12599.5n 0.4699 12600.0n 0.5921 13199.5n 0.5921 13200.0n 0.5304 13799.5n 0.5304 13800.0n 0.5839 14399.5n 0.5839 14400.0n 0.5538 14999.5n 0.5538 15000.0n 0.6237 15599.5n 0.6237 15600.0n 0.5163 16199.5n 0.5163 16200.0n 0.5554 16799.5n 0.5554 16800.0n 0.4842 17399.5n 0.4842 17400.0n 0.5412 17999.5n 0.5412 18000.0n 0.5541 18599.5n 0.5541 18600.0n 0.6602 19199.5n 0.6602 19200.0n 0.6648 19799.5n 0.6648 19800.0n 0.6787 20399.5n 0.6787 20400.0n 0.6515 20999.5n 0.6515 21000.0n 0.4346 21599.5n 0.4346 21600.0n 0.6726 22199.5n 0.6726 22200.0n 0.6671 22799.5n 0.6671 22800.0n 0.6559 23399.5n 0.6559 23400.0n 0.5239 23999.5n 0.5239 24000.0n 0.6816 24599.5n 0.6816 24600.0n 0.6627 25199.5n 0.6627 25200.0n 0.6038 25799.5n 0.6038 25800.0n 0.5241 26399.5n 0.5241 26400.0n 0.6095 26999.5n 0.6095 27000.0n 0.5697 27599.5n 0.5697 27600.0n 0.6157 28199.5n 0.6157 28200.0n 0.5731 28799.5n 0.5731 28800.0n 0.6514 29399.5n 0.6514 29400.0n 0.4222 29999.5n 0.4222 30000.0n 0.3963 30599.5n 0.3963 30600.0n 0.3348 31199.5n 0.3348 31200.0n 0.3694 31799.5n 0.3694 31800.0n 0.5072 32399.5n 0.5072 32400.0n 0.5305 32999.5n 0.5305 33000.0n 0.6738 33599.5n 0.6738 33600.0n 0.6668 34199.5n 0.6668 34200.0n 0.6531 34799.5n 0.6531 34800.0n 0.3473 35399.5n 0.3473 35400.0n 0.6642 35999.5n 0.6642)
Cwp_wih_1_39 wp_wih_1_39 0 400p
Cwn_wih_1_39 wn_wih_1_39 0 400p
Xu_wih_1_39 xp_wih_1_39 xn_wih_1_39 yp_wih_1_39 yn_wih_1_39 wp_wih_1_39 wn_wih_1_39 vdd gbn gprod
Vxp_who_39_0 xp_who_39_0 0 PWL(0.0n 0.4790 599.5n 0.4790 600.0n 0.3707 1199.5n 0.3707 1200.0n 0.4540 1799.5n 0.4540 1800.0n 0.3538 2399.5n 0.3538 2400.0n 0.3551 2999.5n 0.3551 3000.0n 0.4224 3599.5n 0.4224 3600.0n 0.4676 4199.5n 0.4676 4200.0n 0.4894 4799.5n 0.4894 4800.0n 0.4425 5399.5n 0.4425 5400.0n 0.4400 5999.5n 0.4400 6000.0n 0.4390 6599.5n 0.4390 6600.0n 0.4620 7199.5n 0.4620 7200.0n 0.3694 7799.5n 0.3694 7800.0n 0.3610 8399.5n 0.3610 8400.0n 0.5107 8999.5n 0.5107 9000.0n 0.4410 9599.5n 0.4410 9600.0n 0.4136 10199.5n 0.4136 10200.0n 0.3759 10799.5n 0.3759 10800.0n 0.4746 11399.5n 0.4746 11400.0n 0.4489 11999.5n 0.4489 12000.0n 0.5301 12599.5n 0.5301 12600.0n 0.4079 13199.5n 0.4079 13200.0n 0.4696 13799.5n 0.4696 13800.0n 0.4161 14399.5n 0.4161 14400.0n 0.4462 14999.5n 0.4462 15000.0n 0.3763 15599.5n 0.3763 15600.0n 0.4837 16199.5n 0.4837 16200.0n 0.4446 16799.5n 0.4446 16800.0n 0.5158 17399.5n 0.5158 17400.0n 0.4588 17999.5n 0.4588 18000.0n 0.4459 18599.5n 0.4459 18600.0n 0.3398 19199.5n 0.3398 19200.0n 0.3352 19799.5n 0.3352 19800.0n 0.3213 20399.5n 0.3213 20400.0n 0.3485 20999.5n 0.3485 21000.0n 0.5654 21599.5n 0.5654 21600.0n 0.3274 22199.5n 0.3274 22200.0n 0.3329 22799.5n 0.3329 22800.0n 0.3441 23399.5n 0.3441 23400.0n 0.4761 23999.5n 0.4761 24000.0n 0.3184 24599.5n 0.3184 24600.0n 0.3373 25199.5n 0.3373 25200.0n 0.3962 25799.5n 0.3962 25800.0n 0.4759 26399.5n 0.4759 26400.0n 0.3905 26999.5n 0.3905 27000.0n 0.4303 27599.5n 0.4303 27600.0n 0.3843 28199.5n 0.3843 28200.0n 0.4269 28799.5n 0.4269 28800.0n 0.3486 29399.5n 0.3486 29400.0n 0.5778 29999.5n 0.5778 30000.0n 0.6037 30599.5n 0.6037 30600.0n 0.6652 31199.5n 0.6652 31200.0n 0.6306 31799.5n 0.6306 31800.0n 0.4928 32399.5n 0.4928 32400.0n 0.4695 32999.5n 0.4695 33000.0n 0.3262 33599.5n 0.3262 33600.0n 0.3332 34199.5n 0.3332 34200.0n 0.3469 34799.5n 0.3469 34800.0n 0.6527 35399.5n 0.6527 35400.0n 0.3358 35999.5n 0.3358)
Vxn_who_39_0 xn_who_39_0 0 PWL(0.0n 0.5210 599.5n 0.5210 600.0n 0.6293 1199.5n 0.6293 1200.0n 0.5460 1799.5n 0.5460 1800.0n 0.6462 2399.5n 0.6462 2400.0n 0.6449 2999.5n 0.6449 3000.0n 0.5776 3599.5n 0.5776 3600.0n 0.5324 4199.5n 0.5324 4200.0n 0.5106 4799.5n 0.5106 4800.0n 0.5575 5399.5n 0.5575 5400.0n 0.5600 5999.5n 0.5600 6000.0n 0.5610 6599.5n 0.5610 6600.0n 0.5380 7199.5n 0.5380 7200.0n 0.6306 7799.5n 0.6306 7800.0n 0.6390 8399.5n 0.6390 8400.0n 0.4893 8999.5n 0.4893 9000.0n 0.5590 9599.5n 0.5590 9600.0n 0.5864 10199.5n 0.5864 10200.0n 0.6241 10799.5n 0.6241 10800.0n 0.5254 11399.5n 0.5254 11400.0n 0.5511 11999.5n 0.5511 12000.0n 0.4699 12599.5n 0.4699 12600.0n 0.5921 13199.5n 0.5921 13200.0n 0.5304 13799.5n 0.5304 13800.0n 0.5839 14399.5n 0.5839 14400.0n 0.5538 14999.5n 0.5538 15000.0n 0.6237 15599.5n 0.6237 15600.0n 0.5163 16199.5n 0.5163 16200.0n 0.5554 16799.5n 0.5554 16800.0n 0.4842 17399.5n 0.4842 17400.0n 0.5412 17999.5n 0.5412 18000.0n 0.5541 18599.5n 0.5541 18600.0n 0.6602 19199.5n 0.6602 19200.0n 0.6648 19799.5n 0.6648 19800.0n 0.6787 20399.5n 0.6787 20400.0n 0.6515 20999.5n 0.6515 21000.0n 0.4346 21599.5n 0.4346 21600.0n 0.6726 22199.5n 0.6726 22200.0n 0.6671 22799.5n 0.6671 22800.0n 0.6559 23399.5n 0.6559 23400.0n 0.5239 23999.5n 0.5239 24000.0n 0.6816 24599.5n 0.6816 24600.0n 0.6627 25199.5n 0.6627 25200.0n 0.6038 25799.5n 0.6038 25800.0n 0.5241 26399.5n 0.5241 26400.0n 0.6095 26999.5n 0.6095 27000.0n 0.5697 27599.5n 0.5697 27600.0n 0.6157 28199.5n 0.6157 28200.0n 0.5731 28799.5n 0.5731 28800.0n 0.6514 29399.5n 0.6514 29400.0n 0.4222 29999.5n 0.4222 30000.0n 0.3963 30599.5n 0.3963 30600.0n 0.3348 31199.5n 0.3348 31200.0n 0.3694 31799.5n 0.3694 31800.0n 0.5072 32399.5n 0.5072 32400.0n 0.5305 32999.5n 0.5305 33000.0n 0.6738 33599.5n 0.6738 33600.0n 0.6668 34199.5n 0.6668 34200.0n 0.6531 34799.5n 0.6531 34800.0n 0.3473 35399.5n 0.3473 35400.0n 0.6642 35999.5n 0.6642)
Vyp_who_39_0 yp_who_39_0 0 PWL(0.0n 0.5031 599.5n 0.5031 600.0n 0.5023 1199.5n 0.5023 1200.0n 0.5052 1799.5n 0.5052 1800.0n 0.5048 2399.5n 0.5048 2400.0n 0.5043 2999.5n 0.5043 3000.0n 0.5034 3599.5n 0.5034 3600.0n 0.5048 4199.5n 0.5048 4200.0n 0.5031 4799.5n 0.5031 4800.0n 0.5040 5399.5n 0.5040 5400.0n 0.5040 5999.5n 0.5040 6000.0n 0.5054 6599.5n 0.5054 6600.0n 0.5040 7199.5n 0.5040 7200.0n 0.5027 7799.5n 0.5027 7800.0n 0.5027 8399.5n 0.5027 8400.0n 0.5038 8999.5n 0.5038 9000.0n 0.5040 9599.5n 0.5040 9600.0n 0.5039 10199.5n 0.5039 10200.0n 0.5033 10799.5n 0.5033 10800.0n 0.5056 11399.5n 0.5056 11400.0n 0.5040 11999.5n 0.5040 12000.0n 0.5036 12599.5n 0.5036 12600.0n 0.5039 13199.5n 0.5039 13200.0n 0.5029 13799.5n 0.5029 13800.0n 0.5025 14399.5n 0.5025 14400.0n 0.5038 14999.5n 0.5038 15000.0n 0.5041 15599.5n 0.5041 15600.0n 0.5036 16199.5n 0.5036 16200.0n 0.5025 16799.5n 0.5025 16800.0n 0.5040 17399.5n 0.5040 17400.0n 0.5029 17999.5n 0.5029 18000.0n 0.5057 18599.5n 0.5057 18600.0n 0.5010 19199.5n 0.5010 19200.0n 0.5041 19799.5n 0.5041 19800.0n 0.5021 20399.5n 0.5021 20400.0n 0.5044 20999.5n 0.5044 21000.0n 0.5056 21599.5n 0.5056 21600.0n 0.5016 22199.5n 0.5016 22200.0n 0.5006 22799.5n 0.5006 22800.0n 0.5041 23399.5n 0.5041 23400.0n 0.5027 23999.5n 0.5027 24000.0n 0.5029 24599.5n 0.5029 24600.0n 0.5006 25199.5n 0.5006 25200.0n 0.5047 25799.5n 0.5047 25800.0n 0.5046 26399.5n 0.5046 26400.0n 0.5039 26999.5n 0.5039 27000.0n 0.5049 27599.5n 0.5049 27600.0n 0.5039 28199.5n 0.5039 28200.0n 0.5017 28799.5n 0.5017 28800.0n 0.5042 29399.5n 0.5042 29400.0n 0.5056 29999.5n 0.5056 30000.0n 0.5051 30599.5n 0.5051 30600.0n 0.5039 31199.5n 0.5039 31200.0n 0.5033 31799.5n 0.5033 31800.0n 0.5049 32399.5n 0.5049 32400.0n 0.5045 32999.5n 0.5045 33000.0n 0.5036 33599.5n 0.5036 33600.0n 0.5042 34199.5n 0.5042 34200.0n 0.5012 34799.5n 0.5012 34800.0n 0.5036 35399.5n 0.5036 35400.0n 0.5042 35999.5n 0.5042)
Vyn_who_39_0 yn_who_39_0 0 PWL(0.0n 0.4969 599.5n 0.4969 600.0n 0.4977 1199.5n 0.4977 1200.0n 0.4948 1799.5n 0.4948 1800.0n 0.4952 2399.5n 0.4952 2400.0n 0.4957 2999.5n 0.4957 3000.0n 0.4966 3599.5n 0.4966 3600.0n 0.4952 4199.5n 0.4952 4200.0n 0.4969 4799.5n 0.4969 4800.0n 0.4960 5399.5n 0.4960 5400.0n 0.4960 5999.5n 0.4960 6000.0n 0.4946 6599.5n 0.4946 6600.0n 0.4960 7199.5n 0.4960 7200.0n 0.4973 7799.5n 0.4973 7800.0n 0.4973 8399.5n 0.4973 8400.0n 0.4962 8999.5n 0.4962 9000.0n 0.4960 9599.5n 0.4960 9600.0n 0.4961 10199.5n 0.4961 10200.0n 0.4967 10799.5n 0.4967 10800.0n 0.4944 11399.5n 0.4944 11400.0n 0.4960 11999.5n 0.4960 12000.0n 0.4964 12599.5n 0.4964 12600.0n 0.4961 13199.5n 0.4961 13200.0n 0.4971 13799.5n 0.4971 13800.0n 0.4975 14399.5n 0.4975 14400.0n 0.4962 14999.5n 0.4962 15000.0n 0.4959 15599.5n 0.4959 15600.0n 0.4964 16199.5n 0.4964 16200.0n 0.4975 16799.5n 0.4975 16800.0n 0.4960 17399.5n 0.4960 17400.0n 0.4971 17999.5n 0.4971 18000.0n 0.4943 18599.5n 0.4943 18600.0n 0.4990 19199.5n 0.4990 19200.0n 0.4959 19799.5n 0.4959 19800.0n 0.4979 20399.5n 0.4979 20400.0n 0.4956 20999.5n 0.4956 21000.0n 0.4944 21599.5n 0.4944 21600.0n 0.4984 22199.5n 0.4984 22200.0n 0.4994 22799.5n 0.4994 22800.0n 0.4959 23399.5n 0.4959 23400.0n 0.4973 23999.5n 0.4973 24000.0n 0.4971 24599.5n 0.4971 24600.0n 0.4994 25199.5n 0.4994 25200.0n 0.4953 25799.5n 0.4953 25800.0n 0.4954 26399.5n 0.4954 26400.0n 0.4961 26999.5n 0.4961 27000.0n 0.4951 27599.5n 0.4951 27600.0n 0.4961 28199.5n 0.4961 28200.0n 0.4983 28799.5n 0.4983 28800.0n 0.4958 29399.5n 0.4958 29400.0n 0.4944 29999.5n 0.4944 30000.0n 0.4949 30599.5n 0.4949 30600.0n 0.4961 31199.5n 0.4961 31200.0n 0.4967 31799.5n 0.4967 31800.0n 0.4951 32399.5n 0.4951 32400.0n 0.4955 32999.5n 0.4955 33000.0n 0.4964 33599.5n 0.4964 33600.0n 0.4958 34199.5n 0.4958 34200.0n 0.4988 34799.5n 0.4988 34800.0n 0.4964 35399.5n 0.4964 35400.0n 0.4958 35999.5n 0.4958)
Cwp_who_39_0 wp_who_39_0 0 400p
Cwn_who_39_0 wn_who_39_0 0 400p
Xu_who_39_0 xp_who_39_0 xn_who_39_0 yp_who_39_0 yn_who_39_0 wp_who_39_0 wn_who_39_0 vdd gbn gprod
Vxp_who_39_1 xp_who_39_1 0 PWL(0.0n 0.4790 599.5n 0.4790 600.0n 0.3707 1199.5n 0.3707 1200.0n 0.4540 1799.5n 0.4540 1800.0n 0.3538 2399.5n 0.3538 2400.0n 0.3551 2999.5n 0.3551 3000.0n 0.4224 3599.5n 0.4224 3600.0n 0.4676 4199.5n 0.4676 4200.0n 0.4894 4799.5n 0.4894 4800.0n 0.4425 5399.5n 0.4425 5400.0n 0.4400 5999.5n 0.4400 6000.0n 0.4390 6599.5n 0.4390 6600.0n 0.4620 7199.5n 0.4620 7200.0n 0.3694 7799.5n 0.3694 7800.0n 0.3610 8399.5n 0.3610 8400.0n 0.5107 8999.5n 0.5107 9000.0n 0.4410 9599.5n 0.4410 9600.0n 0.4136 10199.5n 0.4136 10200.0n 0.3759 10799.5n 0.3759 10800.0n 0.4746 11399.5n 0.4746 11400.0n 0.4489 11999.5n 0.4489 12000.0n 0.5301 12599.5n 0.5301 12600.0n 0.4079 13199.5n 0.4079 13200.0n 0.4696 13799.5n 0.4696 13800.0n 0.4161 14399.5n 0.4161 14400.0n 0.4462 14999.5n 0.4462 15000.0n 0.3763 15599.5n 0.3763 15600.0n 0.4837 16199.5n 0.4837 16200.0n 0.4446 16799.5n 0.4446 16800.0n 0.5158 17399.5n 0.5158 17400.0n 0.4588 17999.5n 0.4588 18000.0n 0.4459 18599.5n 0.4459 18600.0n 0.3398 19199.5n 0.3398 19200.0n 0.3352 19799.5n 0.3352 19800.0n 0.3213 20399.5n 0.3213 20400.0n 0.3485 20999.5n 0.3485 21000.0n 0.5654 21599.5n 0.5654 21600.0n 0.3274 22199.5n 0.3274 22200.0n 0.3329 22799.5n 0.3329 22800.0n 0.3441 23399.5n 0.3441 23400.0n 0.4761 23999.5n 0.4761 24000.0n 0.3184 24599.5n 0.3184 24600.0n 0.3373 25199.5n 0.3373 25200.0n 0.3962 25799.5n 0.3962 25800.0n 0.4759 26399.5n 0.4759 26400.0n 0.3905 26999.5n 0.3905 27000.0n 0.4303 27599.5n 0.4303 27600.0n 0.3843 28199.5n 0.3843 28200.0n 0.4269 28799.5n 0.4269 28800.0n 0.3486 29399.5n 0.3486 29400.0n 0.5778 29999.5n 0.5778 30000.0n 0.6037 30599.5n 0.6037 30600.0n 0.6652 31199.5n 0.6652 31200.0n 0.6306 31799.5n 0.6306 31800.0n 0.4928 32399.5n 0.4928 32400.0n 0.4695 32999.5n 0.4695 33000.0n 0.3262 33599.5n 0.3262 33600.0n 0.3332 34199.5n 0.3332 34200.0n 0.3469 34799.5n 0.3469 34800.0n 0.6527 35399.5n 0.6527 35400.0n 0.3358 35999.5n 0.3358)
Vxn_who_39_1 xn_who_39_1 0 PWL(0.0n 0.5210 599.5n 0.5210 600.0n 0.6293 1199.5n 0.6293 1200.0n 0.5460 1799.5n 0.5460 1800.0n 0.6462 2399.5n 0.6462 2400.0n 0.6449 2999.5n 0.6449 3000.0n 0.5776 3599.5n 0.5776 3600.0n 0.5324 4199.5n 0.5324 4200.0n 0.5106 4799.5n 0.5106 4800.0n 0.5575 5399.5n 0.5575 5400.0n 0.5600 5999.5n 0.5600 6000.0n 0.5610 6599.5n 0.5610 6600.0n 0.5380 7199.5n 0.5380 7200.0n 0.6306 7799.5n 0.6306 7800.0n 0.6390 8399.5n 0.6390 8400.0n 0.4893 8999.5n 0.4893 9000.0n 0.5590 9599.5n 0.5590 9600.0n 0.5864 10199.5n 0.5864 10200.0n 0.6241 10799.5n 0.6241 10800.0n 0.5254 11399.5n 0.5254 11400.0n 0.5511 11999.5n 0.5511 12000.0n 0.4699 12599.5n 0.4699 12600.0n 0.5921 13199.5n 0.5921 13200.0n 0.5304 13799.5n 0.5304 13800.0n 0.5839 14399.5n 0.5839 14400.0n 0.5538 14999.5n 0.5538 15000.0n 0.6237 15599.5n 0.6237 15600.0n 0.5163 16199.5n 0.5163 16200.0n 0.5554 16799.5n 0.5554 16800.0n 0.4842 17399.5n 0.4842 17400.0n 0.5412 17999.5n 0.5412 18000.0n 0.5541 18599.5n 0.5541 18600.0n 0.6602 19199.5n 0.6602 19200.0n 0.6648 19799.5n 0.6648 19800.0n 0.6787 20399.5n 0.6787 20400.0n 0.6515 20999.5n 0.6515 21000.0n 0.4346 21599.5n 0.4346 21600.0n 0.6726 22199.5n 0.6726 22200.0n 0.6671 22799.5n 0.6671 22800.0n 0.6559 23399.5n 0.6559 23400.0n 0.5239 23999.5n 0.5239 24000.0n 0.6816 24599.5n 0.6816 24600.0n 0.6627 25199.5n 0.6627 25200.0n 0.6038 25799.5n 0.6038 25800.0n 0.5241 26399.5n 0.5241 26400.0n 0.6095 26999.5n 0.6095 27000.0n 0.5697 27599.5n 0.5697 27600.0n 0.6157 28199.5n 0.6157 28200.0n 0.5731 28799.5n 0.5731 28800.0n 0.6514 29399.5n 0.6514 29400.0n 0.4222 29999.5n 0.4222 30000.0n 0.3963 30599.5n 0.3963 30600.0n 0.3348 31199.5n 0.3348 31200.0n 0.3694 31799.5n 0.3694 31800.0n 0.5072 32399.5n 0.5072 32400.0n 0.5305 32999.5n 0.5305 33000.0n 0.6738 33599.5n 0.6738 33600.0n 0.6668 34199.5n 0.6668 34200.0n 0.6531 34799.5n 0.6531 34800.0n 0.3473 35399.5n 0.3473 35400.0n 0.6642 35999.5n 0.6642)
Vyp_who_39_1 yp_who_39_1 0 PWL(0.0n 0.5071 599.5n 0.5071 600.0n 0.5053 1199.5n 0.5053 1200.0n 0.5052 1799.5n 0.5052 1800.0n 0.5027 2399.5n 0.5027 2400.0n 0.5034 2999.5n 0.5034 3000.0n 0.5055 3599.5n 0.5055 3600.0n 0.5056 4199.5n 0.5056 4200.0n 0.5071 4799.5n 0.5071 4800.0n 0.5056 5399.5n 0.5056 5400.0n 0.5056 5999.5n 0.5056 6000.0n 0.5048 6599.5n 0.5048 6600.0n 0.5060 7199.5n 0.5060 7200.0n 0.5048 7799.5n 0.5048 7800.0n 0.5046 8399.5n 0.5046 8400.0n 0.5066 8999.5n 0.5066 9000.0n 0.5056 9599.5n 0.5056 9600.0n 0.5051 10199.5n 0.5051 10200.0n 0.5046 10799.5n 0.5046 10800.0n 0.5056 11399.5n 0.5056 11400.0n 0.5058 11999.5n 0.5058 12000.0n 0.5068 12599.5n 0.5068 12600.0n 0.5050 13199.5n 0.5050 13200.0n 0.5071 13799.5n 0.5071 13800.0n 0.5059 14399.5n 0.5059 14400.0n 0.5058 14999.5n 0.5058 15000.0n 0.5043 15599.5n 0.5043 15600.0n 0.5067 16199.5n 0.5067 16200.0n 0.5068 16799.5n 0.5068 16800.0n 0.5066 17399.5n 0.5066 17400.0n 0.5069 17999.5n 0.5069 18000.0n 0.5061 18599.5n 0.5061 18600.0n 0.5034 19199.5n 0.5034 19200.0n 0.5010 19799.5n 0.5010 19800.0n 0.4989 20399.5n 0.4989 20400.0n 0.5022 20999.5n 0.5022 21000.0n 0.5086 21599.5n 0.5086 21600.0n 0.5007 22199.5n 0.5007 22200.0n 0.5023 22799.5n 0.5023 22800.0n 0.5021 23399.5n 0.5021 23400.0n 0.5077 23999.5n 0.5077 24000.0n 0.4979 24599.5n 0.4979 24600.0n 0.5035 25199.5n 0.5035 25200.0n 0.5041 25799.5n 0.5041 25800.0n 0.5075 26399.5n 0.5075 26400.0n 0.5041 26999.5n 0.5041 27000.0n 0.5056 27599.5n 0.5056 27600.0n 0.5039 28199.5n 0.5039 28200.0n 0.5059 28799.5n 0.5059 28800.0n 0.5023 29399.5n 0.5023 29400.0n 0.5086 29999.5n 0.5086 30000.0n 0.5084 30599.5n 0.5084 30600.0n 0.5085 31199.5n 0.5085 31200.0n 0.5088 31799.5n 0.5088 31800.0n 0.5078 32399.5n 0.5078 32400.0n 0.5074 32999.5n 0.5074 33000.0n 0.4996 33599.5n 0.4996 33600.0n 0.5010 34199.5n 0.5010 34200.0n 0.5044 34799.5n 0.5044 34800.0n 0.5084 35399.5n 0.5084 35400.0n 0.5012 35999.5n 0.5012)
Vyn_who_39_1 yn_who_39_1 0 PWL(0.0n 0.4929 599.5n 0.4929 600.0n 0.4947 1199.5n 0.4947 1200.0n 0.4948 1799.5n 0.4948 1800.0n 0.4973 2399.5n 0.4973 2400.0n 0.4966 2999.5n 0.4966 3000.0n 0.4945 3599.5n 0.4945 3600.0n 0.4944 4199.5n 0.4944 4200.0n 0.4929 4799.5n 0.4929 4800.0n 0.4944 5399.5n 0.4944 5400.0n 0.4944 5999.5n 0.4944 6000.0n 0.4952 6599.5n 0.4952 6600.0n 0.4940 7199.5n 0.4940 7200.0n 0.4952 7799.5n 0.4952 7800.0n 0.4954 8399.5n 0.4954 8400.0n 0.4934 8999.5n 0.4934 9000.0n 0.4944 9599.5n 0.4944 9600.0n 0.4949 10199.5n 0.4949 10200.0n 0.4954 10799.5n 0.4954 10800.0n 0.4944 11399.5n 0.4944 11400.0n 0.4942 11999.5n 0.4942 12000.0n 0.4932 12599.5n 0.4932 12600.0n 0.4950 13199.5n 0.4950 13200.0n 0.4929 13799.5n 0.4929 13800.0n 0.4941 14399.5n 0.4941 14400.0n 0.4942 14999.5n 0.4942 15000.0n 0.4957 15599.5n 0.4957 15600.0n 0.4933 16199.5n 0.4933 16200.0n 0.4932 16799.5n 0.4932 16800.0n 0.4934 17399.5n 0.4934 17400.0n 0.4931 17999.5n 0.4931 18000.0n 0.4939 18599.5n 0.4939 18600.0n 0.4966 19199.5n 0.4966 19200.0n 0.4990 19799.5n 0.4990 19800.0n 0.5011 20399.5n 0.5011 20400.0n 0.4978 20999.5n 0.4978 21000.0n 0.4914 21599.5n 0.4914 21600.0n 0.4993 22199.5n 0.4993 22200.0n 0.4977 22799.5n 0.4977 22800.0n 0.4979 23399.5n 0.4979 23400.0n 0.4923 23999.5n 0.4923 24000.0n 0.5021 24599.5n 0.5021 24600.0n 0.4965 25199.5n 0.4965 25200.0n 0.4959 25799.5n 0.4959 25800.0n 0.4925 26399.5n 0.4925 26400.0n 0.4959 26999.5n 0.4959 27000.0n 0.4944 27599.5n 0.4944 27600.0n 0.4961 28199.5n 0.4961 28200.0n 0.4941 28799.5n 0.4941 28800.0n 0.4977 29399.5n 0.4977 29400.0n 0.4914 29999.5n 0.4914 30000.0n 0.4916 30599.5n 0.4916 30600.0n 0.4915 31199.5n 0.4915 31200.0n 0.4912 31799.5n 0.4912 31800.0n 0.4922 32399.5n 0.4922 32400.0n 0.4926 32999.5n 0.4926 33000.0n 0.5004 33599.5n 0.5004 33600.0n 0.4990 34199.5n 0.4990 34200.0n 0.4956 34799.5n 0.4956 34800.0n 0.4916 35399.5n 0.4916 35400.0n 0.4988 35999.5n 0.4988)
Cwp_who_39_1 wp_who_39_1 0 400p
Cwn_who_39_1 wn_who_39_1 0 400p
Xu_who_39_1 xp_who_39_1 xn_who_39_1 yp_who_39_1 yn_who_39_1 wp_who_39_1 wn_who_39_1 vdd gbn gprod
Vxp_bh_39 xp_bh_39 0 PWL(0.0n 0.7100 599.5n 0.7100 600.0n 0.7100 1199.5n 0.7100 1200.0n 0.7100 1799.5n 0.7100 1800.0n 0.7100 2399.5n 0.7100 2400.0n 0.7100 2999.5n 0.7100 3000.0n 0.7100 3599.5n 0.7100 3600.0n 0.7100 4199.5n 0.7100 4200.0n 0.7100 4799.5n 0.7100 4800.0n 0.7100 5399.5n 0.7100 5400.0n 0.7100 5999.5n 0.7100 6000.0n 0.7100 6599.5n 0.7100 6600.0n 0.7100 7199.5n 0.7100 7200.0n 0.7100 7799.5n 0.7100 7800.0n 0.7100 8399.5n 0.7100 8400.0n 0.7100 8999.5n 0.7100 9000.0n 0.7100 9599.5n 0.7100 9600.0n 0.7100 10199.5n 0.7100 10200.0n 0.7100 10799.5n 0.7100 10800.0n 0.7100 11399.5n 0.7100 11400.0n 0.7100 11999.5n 0.7100 12000.0n 0.7100 12599.5n 0.7100 12600.0n 0.7100 13199.5n 0.7100 13200.0n 0.7100 13799.5n 0.7100 13800.0n 0.7100 14399.5n 0.7100 14400.0n 0.7100 14999.5n 0.7100 15000.0n 0.7100 15599.5n 0.7100 15600.0n 0.7100 16199.5n 0.7100 16200.0n 0.7100 16799.5n 0.7100 16800.0n 0.7100 17399.5n 0.7100 17400.0n 0.7100 17999.5n 0.7100 18000.0n 0.7100 18599.5n 0.7100 18600.0n 0.7100 19199.5n 0.7100 19200.0n 0.7100 19799.5n 0.7100 19800.0n 0.7100 20399.5n 0.7100 20400.0n 0.7100 20999.5n 0.7100 21000.0n 0.7100 21599.5n 0.7100 21600.0n 0.7100 22199.5n 0.7100 22200.0n 0.7100 22799.5n 0.7100 22800.0n 0.7100 23399.5n 0.7100 23400.0n 0.7100 23999.5n 0.7100 24000.0n 0.7100 24599.5n 0.7100 24600.0n 0.7100 25199.5n 0.7100 25200.0n 0.7100 25799.5n 0.7100 25800.0n 0.7100 26399.5n 0.7100 26400.0n 0.7100 26999.5n 0.7100 27000.0n 0.7100 27599.5n 0.7100 27600.0n 0.7100 28199.5n 0.7100 28200.0n 0.7100 28799.5n 0.7100 28800.0n 0.7100 29399.5n 0.7100 29400.0n 0.7100 29999.5n 0.7100 30000.0n 0.7100 30599.5n 0.7100 30600.0n 0.7100 31199.5n 0.7100 31200.0n 0.7100 31799.5n 0.7100 31800.0n 0.7100 32399.5n 0.7100 32400.0n 0.7100 32999.5n 0.7100 33000.0n 0.7100 33599.5n 0.7100 33600.0n 0.7100 34199.5n 0.7100 34200.0n 0.7100 34799.5n 0.7100 34800.0n 0.7100 35399.5n 0.7100 35400.0n 0.7100 35999.5n 0.7100)
Vxn_bh_39 xn_bh_39 0 PWL(0.0n 0.2900 599.5n 0.2900 600.0n 0.2900 1199.5n 0.2900 1200.0n 0.2900 1799.5n 0.2900 1800.0n 0.2900 2399.5n 0.2900 2400.0n 0.2900 2999.5n 0.2900 3000.0n 0.2900 3599.5n 0.2900 3600.0n 0.2900 4199.5n 0.2900 4200.0n 0.2900 4799.5n 0.2900 4800.0n 0.2900 5399.5n 0.2900 5400.0n 0.2900 5999.5n 0.2900 6000.0n 0.2900 6599.5n 0.2900 6600.0n 0.2900 7199.5n 0.2900 7200.0n 0.2900 7799.5n 0.2900 7800.0n 0.2900 8399.5n 0.2900 8400.0n 0.2900 8999.5n 0.2900 9000.0n 0.2900 9599.5n 0.2900 9600.0n 0.2900 10199.5n 0.2900 10200.0n 0.2900 10799.5n 0.2900 10800.0n 0.2900 11399.5n 0.2900 11400.0n 0.2900 11999.5n 0.2900 12000.0n 0.2900 12599.5n 0.2900 12600.0n 0.2900 13199.5n 0.2900 13200.0n 0.2900 13799.5n 0.2900 13800.0n 0.2900 14399.5n 0.2900 14400.0n 0.2900 14999.5n 0.2900 15000.0n 0.2900 15599.5n 0.2900 15600.0n 0.2900 16199.5n 0.2900 16200.0n 0.2900 16799.5n 0.2900 16800.0n 0.2900 17399.5n 0.2900 17400.0n 0.2900 17999.5n 0.2900 18000.0n 0.2900 18599.5n 0.2900 18600.0n 0.2900 19199.5n 0.2900 19200.0n 0.2900 19799.5n 0.2900 19800.0n 0.2900 20399.5n 0.2900 20400.0n 0.2900 20999.5n 0.2900 21000.0n 0.2900 21599.5n 0.2900 21600.0n 0.2900 22199.5n 0.2900 22200.0n 0.2900 22799.5n 0.2900 22800.0n 0.2900 23399.5n 0.2900 23400.0n 0.2900 23999.5n 0.2900 24000.0n 0.2900 24599.5n 0.2900 24600.0n 0.2900 25199.5n 0.2900 25200.0n 0.2900 25799.5n 0.2900 25800.0n 0.2900 26399.5n 0.2900 26400.0n 0.2900 26999.5n 0.2900 27000.0n 0.2900 27599.5n 0.2900 27600.0n 0.2900 28199.5n 0.2900 28200.0n 0.2900 28799.5n 0.2900 28800.0n 0.2900 29399.5n 0.2900 29400.0n 0.2900 29999.5n 0.2900 30000.0n 0.2900 30599.5n 0.2900 30600.0n 0.2900 31199.5n 0.2900 31200.0n 0.2900 31799.5n 0.2900 31800.0n 0.2900 32399.5n 0.2900 32400.0n 0.2900 32999.5n 0.2900 33000.0n 0.2900 33599.5n 0.2900 33600.0n 0.2900 34199.5n 0.2900 34200.0n 0.2900 34799.5n 0.2900 34800.0n 0.2900 35399.5n 0.2900 35400.0n 0.2900 35999.5n 0.2900)
Vyp_bh_39 yp_bh_39 0 PWL(0.0n 0.4790 599.5n 0.4790 600.0n 0.3707 1199.5n 0.3707 1200.0n 0.4540 1799.5n 0.4540 1800.0n 0.3538 2399.5n 0.3538 2400.0n 0.3551 2999.5n 0.3551 3000.0n 0.4224 3599.5n 0.4224 3600.0n 0.4676 4199.5n 0.4676 4200.0n 0.4894 4799.5n 0.4894 4800.0n 0.4425 5399.5n 0.4425 5400.0n 0.4400 5999.5n 0.4400 6000.0n 0.4390 6599.5n 0.4390 6600.0n 0.4620 7199.5n 0.4620 7200.0n 0.3694 7799.5n 0.3694 7800.0n 0.3610 8399.5n 0.3610 8400.0n 0.5107 8999.5n 0.5107 9000.0n 0.4410 9599.5n 0.4410 9600.0n 0.4136 10199.5n 0.4136 10200.0n 0.3759 10799.5n 0.3759 10800.0n 0.4746 11399.5n 0.4746 11400.0n 0.4489 11999.5n 0.4489 12000.0n 0.5301 12599.5n 0.5301 12600.0n 0.4079 13199.5n 0.4079 13200.0n 0.4696 13799.5n 0.4696 13800.0n 0.4161 14399.5n 0.4161 14400.0n 0.4462 14999.5n 0.4462 15000.0n 0.3763 15599.5n 0.3763 15600.0n 0.4837 16199.5n 0.4837 16200.0n 0.4446 16799.5n 0.4446 16800.0n 0.5158 17399.5n 0.5158 17400.0n 0.4588 17999.5n 0.4588 18000.0n 0.4459 18599.5n 0.4459 18600.0n 0.3398 19199.5n 0.3398 19200.0n 0.3352 19799.5n 0.3352 19800.0n 0.3213 20399.5n 0.3213 20400.0n 0.3485 20999.5n 0.3485 21000.0n 0.5654 21599.5n 0.5654 21600.0n 0.3274 22199.5n 0.3274 22200.0n 0.3329 22799.5n 0.3329 22800.0n 0.3441 23399.5n 0.3441 23400.0n 0.4761 23999.5n 0.4761 24000.0n 0.3184 24599.5n 0.3184 24600.0n 0.3373 25199.5n 0.3373 25200.0n 0.3962 25799.5n 0.3962 25800.0n 0.4759 26399.5n 0.4759 26400.0n 0.3905 26999.5n 0.3905 27000.0n 0.4303 27599.5n 0.4303 27600.0n 0.3843 28199.5n 0.3843 28200.0n 0.4269 28799.5n 0.4269 28800.0n 0.3486 29399.5n 0.3486 29400.0n 0.5778 29999.5n 0.5778 30000.0n 0.6037 30599.5n 0.6037 30600.0n 0.6652 31199.5n 0.6652 31200.0n 0.6306 31799.5n 0.6306 31800.0n 0.4928 32399.5n 0.4928 32400.0n 0.4695 32999.5n 0.4695 33000.0n 0.3262 33599.5n 0.3262 33600.0n 0.3332 34199.5n 0.3332 34200.0n 0.3469 34799.5n 0.3469 34800.0n 0.6527 35399.5n 0.6527 35400.0n 0.3358 35999.5n 0.3358)
Vyn_bh_39 yn_bh_39 0 PWL(0.0n 0.5210 599.5n 0.5210 600.0n 0.6293 1199.5n 0.6293 1200.0n 0.5460 1799.5n 0.5460 1800.0n 0.6462 2399.5n 0.6462 2400.0n 0.6449 2999.5n 0.6449 3000.0n 0.5776 3599.5n 0.5776 3600.0n 0.5324 4199.5n 0.5324 4200.0n 0.5106 4799.5n 0.5106 4800.0n 0.5575 5399.5n 0.5575 5400.0n 0.5600 5999.5n 0.5600 6000.0n 0.5610 6599.5n 0.5610 6600.0n 0.5380 7199.5n 0.5380 7200.0n 0.6306 7799.5n 0.6306 7800.0n 0.6390 8399.5n 0.6390 8400.0n 0.4893 8999.5n 0.4893 9000.0n 0.5590 9599.5n 0.5590 9600.0n 0.5864 10199.5n 0.5864 10200.0n 0.6241 10799.5n 0.6241 10800.0n 0.5254 11399.5n 0.5254 11400.0n 0.5511 11999.5n 0.5511 12000.0n 0.4699 12599.5n 0.4699 12600.0n 0.5921 13199.5n 0.5921 13200.0n 0.5304 13799.5n 0.5304 13800.0n 0.5839 14399.5n 0.5839 14400.0n 0.5538 14999.5n 0.5538 15000.0n 0.6237 15599.5n 0.6237 15600.0n 0.5163 16199.5n 0.5163 16200.0n 0.5554 16799.5n 0.5554 16800.0n 0.4842 17399.5n 0.4842 17400.0n 0.5412 17999.5n 0.5412 18000.0n 0.5541 18599.5n 0.5541 18600.0n 0.6602 19199.5n 0.6602 19200.0n 0.6648 19799.5n 0.6648 19800.0n 0.6787 20399.5n 0.6787 20400.0n 0.6515 20999.5n 0.6515 21000.0n 0.4346 21599.5n 0.4346 21600.0n 0.6726 22199.5n 0.6726 22200.0n 0.6671 22799.5n 0.6671 22800.0n 0.6559 23399.5n 0.6559 23400.0n 0.5239 23999.5n 0.5239 24000.0n 0.6816 24599.5n 0.6816 24600.0n 0.6627 25199.5n 0.6627 25200.0n 0.6038 25799.5n 0.6038 25800.0n 0.5241 26399.5n 0.5241 26400.0n 0.6095 26999.5n 0.6095 27000.0n 0.5697 27599.5n 0.5697 27600.0n 0.6157 28199.5n 0.6157 28200.0n 0.5731 28799.5n 0.5731 28800.0n 0.6514 29399.5n 0.6514 29400.0n 0.4222 29999.5n 0.4222 30000.0n 0.3963 30599.5n 0.3963 30600.0n 0.3348 31199.5n 0.3348 31200.0n 0.3694 31799.5n 0.3694 31800.0n 0.5072 32399.5n 0.5072 32400.0n 0.5305 32999.5n 0.5305 33000.0n 0.6738 33599.5n 0.6738 33600.0n 0.6668 34199.5n 0.6668 34200.0n 0.6531 34799.5n 0.6531 34800.0n 0.3473 35399.5n 0.3473 35400.0n 0.6642 35999.5n 0.6642)
Cwp_bh_39 wp_bh_39 0 400p
Cwn_bh_39 wn_bh_39 0 400p
Xu_bh_39 xp_bh_39 xn_bh_39 yp_bh_39 yn_bh_39 wp_bh_39 wn_bh_39 vdd gbn gprod
Vxp_bo_0 xp_bo_0 0 PWL(0.0n 0.7100 599.5n 0.7100 600.0n 0.7100 1199.5n 0.7100 1200.0n 0.7100 1799.5n 0.7100 1800.0n 0.7100 2399.5n 0.7100 2400.0n 0.7100 2999.5n 0.7100 3000.0n 0.7100 3599.5n 0.7100 3600.0n 0.7100 4199.5n 0.7100 4200.0n 0.7100 4799.5n 0.7100 4800.0n 0.7100 5399.5n 0.7100 5400.0n 0.7100 5999.5n 0.7100 6000.0n 0.7100 6599.5n 0.7100 6600.0n 0.7100 7199.5n 0.7100 7200.0n 0.7100 7799.5n 0.7100 7800.0n 0.7100 8399.5n 0.7100 8400.0n 0.7100 8999.5n 0.7100 9000.0n 0.7100 9599.5n 0.7100 9600.0n 0.7100 10199.5n 0.7100 10200.0n 0.7100 10799.5n 0.7100 10800.0n 0.7100 11399.5n 0.7100 11400.0n 0.7100 11999.5n 0.7100 12000.0n 0.7100 12599.5n 0.7100 12600.0n 0.7100 13199.5n 0.7100 13200.0n 0.7100 13799.5n 0.7100 13800.0n 0.7100 14399.5n 0.7100 14400.0n 0.7100 14999.5n 0.7100 15000.0n 0.7100 15599.5n 0.7100 15600.0n 0.7100 16199.5n 0.7100 16200.0n 0.7100 16799.5n 0.7100 16800.0n 0.7100 17399.5n 0.7100 17400.0n 0.7100 17999.5n 0.7100 18000.0n 0.7100 18599.5n 0.7100 18600.0n 0.7100 19199.5n 0.7100 19200.0n 0.7100 19799.5n 0.7100 19800.0n 0.7100 20399.5n 0.7100 20400.0n 0.7100 20999.5n 0.7100 21000.0n 0.7100 21599.5n 0.7100 21600.0n 0.7100 22199.5n 0.7100 22200.0n 0.7100 22799.5n 0.7100 22800.0n 0.7100 23399.5n 0.7100 23400.0n 0.7100 23999.5n 0.7100 24000.0n 0.7100 24599.5n 0.7100 24600.0n 0.7100 25199.5n 0.7100 25200.0n 0.7100 25799.5n 0.7100 25800.0n 0.7100 26399.5n 0.7100 26400.0n 0.7100 26999.5n 0.7100 27000.0n 0.7100 27599.5n 0.7100 27600.0n 0.7100 28199.5n 0.7100 28200.0n 0.7100 28799.5n 0.7100 28800.0n 0.7100 29399.5n 0.7100 29400.0n 0.7100 29999.5n 0.7100 30000.0n 0.7100 30599.5n 0.7100 30600.0n 0.7100 31199.5n 0.7100 31200.0n 0.7100 31799.5n 0.7100 31800.0n 0.7100 32399.5n 0.7100 32400.0n 0.7100 32999.5n 0.7100 33000.0n 0.7100 33599.5n 0.7100 33600.0n 0.7100 34199.5n 0.7100 34200.0n 0.7100 34799.5n 0.7100 34800.0n 0.7100 35399.5n 0.7100 35400.0n 0.7100 35999.5n 0.7100)
Vxn_bo_0 xn_bo_0 0 PWL(0.0n 0.2900 599.5n 0.2900 600.0n 0.2900 1199.5n 0.2900 1200.0n 0.2900 1799.5n 0.2900 1800.0n 0.2900 2399.5n 0.2900 2400.0n 0.2900 2999.5n 0.2900 3000.0n 0.2900 3599.5n 0.2900 3600.0n 0.2900 4199.5n 0.2900 4200.0n 0.2900 4799.5n 0.2900 4800.0n 0.2900 5399.5n 0.2900 5400.0n 0.2900 5999.5n 0.2900 6000.0n 0.2900 6599.5n 0.2900 6600.0n 0.2900 7199.5n 0.2900 7200.0n 0.2900 7799.5n 0.2900 7800.0n 0.2900 8399.5n 0.2900 8400.0n 0.2900 8999.5n 0.2900 9000.0n 0.2900 9599.5n 0.2900 9600.0n 0.2900 10199.5n 0.2900 10200.0n 0.2900 10799.5n 0.2900 10800.0n 0.2900 11399.5n 0.2900 11400.0n 0.2900 11999.5n 0.2900 12000.0n 0.2900 12599.5n 0.2900 12600.0n 0.2900 13199.5n 0.2900 13200.0n 0.2900 13799.5n 0.2900 13800.0n 0.2900 14399.5n 0.2900 14400.0n 0.2900 14999.5n 0.2900 15000.0n 0.2900 15599.5n 0.2900 15600.0n 0.2900 16199.5n 0.2900 16200.0n 0.2900 16799.5n 0.2900 16800.0n 0.2900 17399.5n 0.2900 17400.0n 0.2900 17999.5n 0.2900 18000.0n 0.2900 18599.5n 0.2900 18600.0n 0.2900 19199.5n 0.2900 19200.0n 0.2900 19799.5n 0.2900 19800.0n 0.2900 20399.5n 0.2900 20400.0n 0.2900 20999.5n 0.2900 21000.0n 0.2900 21599.5n 0.2900 21600.0n 0.2900 22199.5n 0.2900 22200.0n 0.2900 22799.5n 0.2900 22800.0n 0.2900 23399.5n 0.2900 23400.0n 0.2900 23999.5n 0.2900 24000.0n 0.2900 24599.5n 0.2900 24600.0n 0.2900 25199.5n 0.2900 25200.0n 0.2900 25799.5n 0.2900 25800.0n 0.2900 26399.5n 0.2900 26400.0n 0.2900 26999.5n 0.2900 27000.0n 0.2900 27599.5n 0.2900 27600.0n 0.2900 28199.5n 0.2900 28200.0n 0.2900 28799.5n 0.2900 28800.0n 0.2900 29399.5n 0.2900 29400.0n 0.2900 29999.5n 0.2900 30000.0n 0.2900 30599.5n 0.2900 30600.0n 0.2900 31199.5n 0.2900 31200.0n 0.2900 31799.5n 0.2900 31800.0n 0.2900 32399.5n 0.2900 32400.0n 0.2900 32999.5n 0.2900 33000.0n 0.2900 33599.5n 0.2900 33600.0n 0.2900 34199.5n 0.2900 34200.0n 0.2900 34799.5n 0.2900 34800.0n 0.2900 35399.5n 0.2900 35400.0n 0.2900 35999.5n 0.2900)
Vyp_bo_0 yp_bo_0 0 PWL(0.0n 0.5031 599.5n 0.5031 600.0n 0.5023 1199.5n 0.5023 1200.0n 0.5052 1799.5n 0.5052 1800.0n 0.5048 2399.5n 0.5048 2400.0n 0.5043 2999.5n 0.5043 3000.0n 0.5034 3599.5n 0.5034 3600.0n 0.5048 4199.5n 0.5048 4200.0n 0.5031 4799.5n 0.5031 4800.0n 0.5040 5399.5n 0.5040 5400.0n 0.5040 5999.5n 0.5040 6000.0n 0.5054 6599.5n 0.5054 6600.0n 0.5040 7199.5n 0.5040 7200.0n 0.5027 7799.5n 0.5027 7800.0n 0.5027 8399.5n 0.5027 8400.0n 0.5038 8999.5n 0.5038 9000.0n 0.5040 9599.5n 0.5040 9600.0n 0.5039 10199.5n 0.5039 10200.0n 0.5033 10799.5n 0.5033 10800.0n 0.5056 11399.5n 0.5056 11400.0n 0.5040 11999.5n 0.5040 12000.0n 0.5036 12599.5n 0.5036 12600.0n 0.5039 13199.5n 0.5039 13200.0n 0.5029 13799.5n 0.5029 13800.0n 0.5025 14399.5n 0.5025 14400.0n 0.5038 14999.5n 0.5038 15000.0n 0.5041 15599.5n 0.5041 15600.0n 0.5036 16199.5n 0.5036 16200.0n 0.5025 16799.5n 0.5025 16800.0n 0.5040 17399.5n 0.5040 17400.0n 0.5029 17999.5n 0.5029 18000.0n 0.5057 18599.5n 0.5057 18600.0n 0.5010 19199.5n 0.5010 19200.0n 0.5041 19799.5n 0.5041 19800.0n 0.5021 20399.5n 0.5021 20400.0n 0.5044 20999.5n 0.5044 21000.0n 0.5056 21599.5n 0.5056 21600.0n 0.5016 22199.5n 0.5016 22200.0n 0.5006 22799.5n 0.5006 22800.0n 0.5041 23399.5n 0.5041 23400.0n 0.5027 23999.5n 0.5027 24000.0n 0.5029 24599.5n 0.5029 24600.0n 0.5006 25199.5n 0.5006 25200.0n 0.5047 25799.5n 0.5047 25800.0n 0.5046 26399.5n 0.5046 26400.0n 0.5039 26999.5n 0.5039 27000.0n 0.5049 27599.5n 0.5049 27600.0n 0.5039 28199.5n 0.5039 28200.0n 0.5017 28799.5n 0.5017 28800.0n 0.5042 29399.5n 0.5042 29400.0n 0.5056 29999.5n 0.5056 30000.0n 0.5051 30599.5n 0.5051 30600.0n 0.5039 31199.5n 0.5039 31200.0n 0.5033 31799.5n 0.5033 31800.0n 0.5049 32399.5n 0.5049 32400.0n 0.5045 32999.5n 0.5045 33000.0n 0.5036 33599.5n 0.5036 33600.0n 0.5042 34199.5n 0.5042 34200.0n 0.5012 34799.5n 0.5012 34800.0n 0.5036 35399.5n 0.5036 35400.0n 0.5042 35999.5n 0.5042)
Vyn_bo_0 yn_bo_0 0 PWL(0.0n 0.4969 599.5n 0.4969 600.0n 0.4977 1199.5n 0.4977 1200.0n 0.4948 1799.5n 0.4948 1800.0n 0.4952 2399.5n 0.4952 2400.0n 0.4957 2999.5n 0.4957 3000.0n 0.4966 3599.5n 0.4966 3600.0n 0.4952 4199.5n 0.4952 4200.0n 0.4969 4799.5n 0.4969 4800.0n 0.4960 5399.5n 0.4960 5400.0n 0.4960 5999.5n 0.4960 6000.0n 0.4946 6599.5n 0.4946 6600.0n 0.4960 7199.5n 0.4960 7200.0n 0.4973 7799.5n 0.4973 7800.0n 0.4973 8399.5n 0.4973 8400.0n 0.4962 8999.5n 0.4962 9000.0n 0.4960 9599.5n 0.4960 9600.0n 0.4961 10199.5n 0.4961 10200.0n 0.4967 10799.5n 0.4967 10800.0n 0.4944 11399.5n 0.4944 11400.0n 0.4960 11999.5n 0.4960 12000.0n 0.4964 12599.5n 0.4964 12600.0n 0.4961 13199.5n 0.4961 13200.0n 0.4971 13799.5n 0.4971 13800.0n 0.4975 14399.5n 0.4975 14400.0n 0.4962 14999.5n 0.4962 15000.0n 0.4959 15599.5n 0.4959 15600.0n 0.4964 16199.5n 0.4964 16200.0n 0.4975 16799.5n 0.4975 16800.0n 0.4960 17399.5n 0.4960 17400.0n 0.4971 17999.5n 0.4971 18000.0n 0.4943 18599.5n 0.4943 18600.0n 0.4990 19199.5n 0.4990 19200.0n 0.4959 19799.5n 0.4959 19800.0n 0.4979 20399.5n 0.4979 20400.0n 0.4956 20999.5n 0.4956 21000.0n 0.4944 21599.5n 0.4944 21600.0n 0.4984 22199.5n 0.4984 22200.0n 0.4994 22799.5n 0.4994 22800.0n 0.4959 23399.5n 0.4959 23400.0n 0.4973 23999.5n 0.4973 24000.0n 0.4971 24599.5n 0.4971 24600.0n 0.4994 25199.5n 0.4994 25200.0n 0.4953 25799.5n 0.4953 25800.0n 0.4954 26399.5n 0.4954 26400.0n 0.4961 26999.5n 0.4961 27000.0n 0.4951 27599.5n 0.4951 27600.0n 0.4961 28199.5n 0.4961 28200.0n 0.4983 28799.5n 0.4983 28800.0n 0.4958 29399.5n 0.4958 29400.0n 0.4944 29999.5n 0.4944 30000.0n 0.4949 30599.5n 0.4949 30600.0n 0.4961 31199.5n 0.4961 31200.0n 0.4967 31799.5n 0.4967 31800.0n 0.4951 32399.5n 0.4951 32400.0n 0.4955 32999.5n 0.4955 33000.0n 0.4964 33599.5n 0.4964 33600.0n 0.4958 34199.5n 0.4958 34200.0n 0.4988 34799.5n 0.4988 34800.0n 0.4964 35399.5n 0.4964 35400.0n 0.4958 35999.5n 0.4958)
Cwp_bo_0 wp_bo_0 0 400p
Cwn_bo_0 wn_bo_0 0 400p
Xu_bo_0 xp_bo_0 xn_bo_0 yp_bo_0 yn_bo_0 wp_bo_0 wn_bo_0 vdd gbn gprod
Vxp_bo_1 xp_bo_1 0 PWL(0.0n 0.7100 599.5n 0.7100 600.0n 0.7100 1199.5n 0.7100 1200.0n 0.7100 1799.5n 0.7100 1800.0n 0.7100 2399.5n 0.7100 2400.0n 0.7100 2999.5n 0.7100 3000.0n 0.7100 3599.5n 0.7100 3600.0n 0.7100 4199.5n 0.7100 4200.0n 0.7100 4799.5n 0.7100 4800.0n 0.7100 5399.5n 0.7100 5400.0n 0.7100 5999.5n 0.7100 6000.0n 0.7100 6599.5n 0.7100 6600.0n 0.7100 7199.5n 0.7100 7200.0n 0.7100 7799.5n 0.7100 7800.0n 0.7100 8399.5n 0.7100 8400.0n 0.7100 8999.5n 0.7100 9000.0n 0.7100 9599.5n 0.7100 9600.0n 0.7100 10199.5n 0.7100 10200.0n 0.7100 10799.5n 0.7100 10800.0n 0.7100 11399.5n 0.7100 11400.0n 0.7100 11999.5n 0.7100 12000.0n 0.7100 12599.5n 0.7100 12600.0n 0.7100 13199.5n 0.7100 13200.0n 0.7100 13799.5n 0.7100 13800.0n 0.7100 14399.5n 0.7100 14400.0n 0.7100 14999.5n 0.7100 15000.0n 0.7100 15599.5n 0.7100 15600.0n 0.7100 16199.5n 0.7100 16200.0n 0.7100 16799.5n 0.7100 16800.0n 0.7100 17399.5n 0.7100 17400.0n 0.7100 17999.5n 0.7100 18000.0n 0.7100 18599.5n 0.7100 18600.0n 0.7100 19199.5n 0.7100 19200.0n 0.7100 19799.5n 0.7100 19800.0n 0.7100 20399.5n 0.7100 20400.0n 0.7100 20999.5n 0.7100 21000.0n 0.7100 21599.5n 0.7100 21600.0n 0.7100 22199.5n 0.7100 22200.0n 0.7100 22799.5n 0.7100 22800.0n 0.7100 23399.5n 0.7100 23400.0n 0.7100 23999.5n 0.7100 24000.0n 0.7100 24599.5n 0.7100 24600.0n 0.7100 25199.5n 0.7100 25200.0n 0.7100 25799.5n 0.7100 25800.0n 0.7100 26399.5n 0.7100 26400.0n 0.7100 26999.5n 0.7100 27000.0n 0.7100 27599.5n 0.7100 27600.0n 0.7100 28199.5n 0.7100 28200.0n 0.7100 28799.5n 0.7100 28800.0n 0.7100 29399.5n 0.7100 29400.0n 0.7100 29999.5n 0.7100 30000.0n 0.7100 30599.5n 0.7100 30600.0n 0.7100 31199.5n 0.7100 31200.0n 0.7100 31799.5n 0.7100 31800.0n 0.7100 32399.5n 0.7100 32400.0n 0.7100 32999.5n 0.7100 33000.0n 0.7100 33599.5n 0.7100 33600.0n 0.7100 34199.5n 0.7100 34200.0n 0.7100 34799.5n 0.7100 34800.0n 0.7100 35399.5n 0.7100 35400.0n 0.7100 35999.5n 0.7100)
Vxn_bo_1 xn_bo_1 0 PWL(0.0n 0.2900 599.5n 0.2900 600.0n 0.2900 1199.5n 0.2900 1200.0n 0.2900 1799.5n 0.2900 1800.0n 0.2900 2399.5n 0.2900 2400.0n 0.2900 2999.5n 0.2900 3000.0n 0.2900 3599.5n 0.2900 3600.0n 0.2900 4199.5n 0.2900 4200.0n 0.2900 4799.5n 0.2900 4800.0n 0.2900 5399.5n 0.2900 5400.0n 0.2900 5999.5n 0.2900 6000.0n 0.2900 6599.5n 0.2900 6600.0n 0.2900 7199.5n 0.2900 7200.0n 0.2900 7799.5n 0.2900 7800.0n 0.2900 8399.5n 0.2900 8400.0n 0.2900 8999.5n 0.2900 9000.0n 0.2900 9599.5n 0.2900 9600.0n 0.2900 10199.5n 0.2900 10200.0n 0.2900 10799.5n 0.2900 10800.0n 0.2900 11399.5n 0.2900 11400.0n 0.2900 11999.5n 0.2900 12000.0n 0.2900 12599.5n 0.2900 12600.0n 0.2900 13199.5n 0.2900 13200.0n 0.2900 13799.5n 0.2900 13800.0n 0.2900 14399.5n 0.2900 14400.0n 0.2900 14999.5n 0.2900 15000.0n 0.2900 15599.5n 0.2900 15600.0n 0.2900 16199.5n 0.2900 16200.0n 0.2900 16799.5n 0.2900 16800.0n 0.2900 17399.5n 0.2900 17400.0n 0.2900 17999.5n 0.2900 18000.0n 0.2900 18599.5n 0.2900 18600.0n 0.2900 19199.5n 0.2900 19200.0n 0.2900 19799.5n 0.2900 19800.0n 0.2900 20399.5n 0.2900 20400.0n 0.2900 20999.5n 0.2900 21000.0n 0.2900 21599.5n 0.2900 21600.0n 0.2900 22199.5n 0.2900 22200.0n 0.2900 22799.5n 0.2900 22800.0n 0.2900 23399.5n 0.2900 23400.0n 0.2900 23999.5n 0.2900 24000.0n 0.2900 24599.5n 0.2900 24600.0n 0.2900 25199.5n 0.2900 25200.0n 0.2900 25799.5n 0.2900 25800.0n 0.2900 26399.5n 0.2900 26400.0n 0.2900 26999.5n 0.2900 27000.0n 0.2900 27599.5n 0.2900 27600.0n 0.2900 28199.5n 0.2900 28200.0n 0.2900 28799.5n 0.2900 28800.0n 0.2900 29399.5n 0.2900 29400.0n 0.2900 29999.5n 0.2900 30000.0n 0.2900 30599.5n 0.2900 30600.0n 0.2900 31199.5n 0.2900 31200.0n 0.2900 31799.5n 0.2900 31800.0n 0.2900 32399.5n 0.2900 32400.0n 0.2900 32999.5n 0.2900 33000.0n 0.2900 33599.5n 0.2900 33600.0n 0.2900 34199.5n 0.2900 34200.0n 0.2900 34799.5n 0.2900 34800.0n 0.2900 35399.5n 0.2900 35400.0n 0.2900 35999.5n 0.2900)
Vyp_bo_1 yp_bo_1 0 PWL(0.0n 0.5071 599.5n 0.5071 600.0n 0.5053 1199.5n 0.5053 1200.0n 0.5052 1799.5n 0.5052 1800.0n 0.5027 2399.5n 0.5027 2400.0n 0.5034 2999.5n 0.5034 3000.0n 0.5055 3599.5n 0.5055 3600.0n 0.5056 4199.5n 0.5056 4200.0n 0.5071 4799.5n 0.5071 4800.0n 0.5056 5399.5n 0.5056 5400.0n 0.5056 5999.5n 0.5056 6000.0n 0.5048 6599.5n 0.5048 6600.0n 0.5060 7199.5n 0.5060 7200.0n 0.5048 7799.5n 0.5048 7800.0n 0.5046 8399.5n 0.5046 8400.0n 0.5066 8999.5n 0.5066 9000.0n 0.5056 9599.5n 0.5056 9600.0n 0.5051 10199.5n 0.5051 10200.0n 0.5046 10799.5n 0.5046 10800.0n 0.5056 11399.5n 0.5056 11400.0n 0.5058 11999.5n 0.5058 12000.0n 0.5068 12599.5n 0.5068 12600.0n 0.5050 13199.5n 0.5050 13200.0n 0.5071 13799.5n 0.5071 13800.0n 0.5059 14399.5n 0.5059 14400.0n 0.5058 14999.5n 0.5058 15000.0n 0.5043 15599.5n 0.5043 15600.0n 0.5067 16199.5n 0.5067 16200.0n 0.5068 16799.5n 0.5068 16800.0n 0.5066 17399.5n 0.5066 17400.0n 0.5069 17999.5n 0.5069 18000.0n 0.5061 18599.5n 0.5061 18600.0n 0.5034 19199.5n 0.5034 19200.0n 0.5010 19799.5n 0.5010 19800.0n 0.4989 20399.5n 0.4989 20400.0n 0.5022 20999.5n 0.5022 21000.0n 0.5086 21599.5n 0.5086 21600.0n 0.5007 22199.5n 0.5007 22200.0n 0.5023 22799.5n 0.5023 22800.0n 0.5021 23399.5n 0.5021 23400.0n 0.5077 23999.5n 0.5077 24000.0n 0.4979 24599.5n 0.4979 24600.0n 0.5035 25199.5n 0.5035 25200.0n 0.5041 25799.5n 0.5041 25800.0n 0.5075 26399.5n 0.5075 26400.0n 0.5041 26999.5n 0.5041 27000.0n 0.5056 27599.5n 0.5056 27600.0n 0.5039 28199.5n 0.5039 28200.0n 0.5059 28799.5n 0.5059 28800.0n 0.5023 29399.5n 0.5023 29400.0n 0.5086 29999.5n 0.5086 30000.0n 0.5084 30599.5n 0.5084 30600.0n 0.5085 31199.5n 0.5085 31200.0n 0.5088 31799.5n 0.5088 31800.0n 0.5078 32399.5n 0.5078 32400.0n 0.5074 32999.5n 0.5074 33000.0n 0.4996 33599.5n 0.4996 33600.0n 0.5010 34199.5n 0.5010 34200.0n 0.5044 34799.5n 0.5044 34800.0n 0.5084 35399.5n 0.5084 35400.0n 0.5012 35999.5n 0.5012)
Vyn_bo_1 yn_bo_1 0 PWL(0.0n 0.4929 599.5n 0.4929 600.0n 0.4947 1199.5n 0.4947 1200.0n 0.4948 1799.5n 0.4948 1800.0n 0.4973 2399.5n 0.4973 2400.0n 0.4966 2999.5n 0.4966 3000.0n 0.4945 3599.5n 0.4945 3600.0n 0.4944 4199.5n 0.4944 4200.0n 0.4929 4799.5n 0.4929 4800.0n 0.4944 5399.5n 0.4944 5400.0n 0.4944 5999.5n 0.4944 6000.0n 0.4952 6599.5n 0.4952 6600.0n 0.4940 7199.5n 0.4940 7200.0n 0.4952 7799.5n 0.4952 7800.0n 0.4954 8399.5n 0.4954 8400.0n 0.4934 8999.5n 0.4934 9000.0n 0.4944 9599.5n 0.4944 9600.0n 0.4949 10199.5n 0.4949 10200.0n 0.4954 10799.5n 0.4954 10800.0n 0.4944 11399.5n 0.4944 11400.0n 0.4942 11999.5n 0.4942 12000.0n 0.4932 12599.5n 0.4932 12600.0n 0.4950 13199.5n 0.4950 13200.0n 0.4929 13799.5n 0.4929 13800.0n 0.4941 14399.5n 0.4941 14400.0n 0.4942 14999.5n 0.4942 15000.0n 0.4957 15599.5n 0.4957 15600.0n 0.4933 16199.5n 0.4933 16200.0n 0.4932 16799.5n 0.4932 16800.0n 0.4934 17399.5n 0.4934 17400.0n 0.4931 17999.5n 0.4931 18000.0n 0.4939 18599.5n 0.4939 18600.0n 0.4966 19199.5n 0.4966 19200.0n 0.4990 19799.5n 0.4990 19800.0n 0.5011 20399.5n 0.5011 20400.0n 0.4978 20999.5n 0.4978 21000.0n 0.4914 21599.5n 0.4914 21600.0n 0.4993 22199.5n 0.4993 22200.0n 0.4977 22799.5n 0.4977 22800.0n 0.4979 23399.5n 0.4979 23400.0n 0.4923 23999.5n 0.4923 24000.0n 0.5021 24599.5n 0.5021 24600.0n 0.4965 25199.5n 0.4965 25200.0n 0.4959 25799.5n 0.4959 25800.0n 0.4925 26399.5n 0.4925 26400.0n 0.4959 26999.5n 0.4959 27000.0n 0.4944 27599.5n 0.4944 27600.0n 0.4961 28199.5n 0.4961 28200.0n 0.4941 28799.5n 0.4941 28800.0n 0.4977 29399.5n 0.4977 29400.0n 0.4914 29999.5n 0.4914 30000.0n 0.4916 30599.5n 0.4916 30600.0n 0.4915 31199.5n 0.4915 31200.0n 0.4912 31799.5n 0.4912 31800.0n 0.4922 32399.5n 0.4922 32400.0n 0.4926 32999.5n 0.4926 33000.0n 0.5004 33599.5n 0.5004 33600.0n 0.4990 34199.5n 0.4990 34200.0n 0.4956 34799.5n 0.4956 34800.0n 0.4916 35399.5n 0.4916 35400.0n 0.4988 35999.5n 0.4988)
Cwp_bo_1 wp_bo_1 0 400p
Cwn_bo_1 wn_bo_1 0 400p
Xu_bo_1 xp_bo_1 xn_bo_1 yp_bo_1 yn_bo_1 wp_bo_1 wn_bo_1 vdd gbn gprod
.ic v(wp_wih_0_0)=0.5 v(wn_wih_0_0)=0.5
.ic v(wp_wih_1_0)=0.5 v(wn_wih_1_0)=0.5
.ic v(wp_who_0_0)=0.5 v(wn_who_0_0)=0.5
.ic v(wp_who_0_1)=0.5 v(wn_who_0_1)=0.5
.ic v(wp_bh_0)=0.5 v(wn_bh_0)=0.5
.ic v(wp_wih_0_1)=0.5 v(wn_wih_0_1)=0.5
.ic v(wp_wih_1_1)=0.5 v(wn_wih_1_1)=0.5
.ic v(wp_who_1_0)=0.5 v(wn_who_1_0)=0.5
.ic v(wp_who_1_1)=0.5 v(wn_who_1_1)=0.5
.ic v(wp_bh_1)=0.5 v(wn_bh_1)=0.5
.ic v(wp_wih_0_2)=0.5 v(wn_wih_0_2)=0.5
.ic v(wp_wih_1_2)=0.5 v(wn_wih_1_2)=0.5
.ic v(wp_who_2_0)=0.5 v(wn_who_2_0)=0.5
.ic v(wp_who_2_1)=0.5 v(wn_who_2_1)=0.5
.ic v(wp_bh_2)=0.5 v(wn_bh_2)=0.5
.ic v(wp_wih_0_3)=0.5 v(wn_wih_0_3)=0.5
.ic v(wp_wih_1_3)=0.5 v(wn_wih_1_3)=0.5
.ic v(wp_who_3_0)=0.5 v(wn_who_3_0)=0.5
.ic v(wp_who_3_1)=0.5 v(wn_who_3_1)=0.5
.ic v(wp_bh_3)=0.5 v(wn_bh_3)=0.5
.ic v(wp_wih_0_4)=0.5 v(wn_wih_0_4)=0.5
.ic v(wp_wih_1_4)=0.5 v(wn_wih_1_4)=0.5
.ic v(wp_who_4_0)=0.5 v(wn_who_4_0)=0.5
.ic v(wp_who_4_1)=0.5 v(wn_who_4_1)=0.5
.ic v(wp_bh_4)=0.5 v(wn_bh_4)=0.5
.ic v(wp_wih_0_5)=0.5 v(wn_wih_0_5)=0.5
.ic v(wp_wih_1_5)=0.5 v(wn_wih_1_5)=0.5
.ic v(wp_who_5_0)=0.5 v(wn_who_5_0)=0.5
.ic v(wp_who_5_1)=0.5 v(wn_who_5_1)=0.5
.ic v(wp_bh_5)=0.5 v(wn_bh_5)=0.5
.ic v(wp_wih_0_6)=0.5 v(wn_wih_0_6)=0.5
.ic v(wp_wih_1_6)=0.5 v(wn_wih_1_6)=0.5
.ic v(wp_who_6_0)=0.5 v(wn_who_6_0)=0.5
.ic v(wp_who_6_1)=0.5 v(wn_who_6_1)=0.5
.ic v(wp_bh_6)=0.5 v(wn_bh_6)=0.5
.ic v(wp_wih_0_7)=0.5 v(wn_wih_0_7)=0.5
.ic v(wp_wih_1_7)=0.5 v(wn_wih_1_7)=0.5
.ic v(wp_who_7_0)=0.5 v(wn_who_7_0)=0.5
.ic v(wp_who_7_1)=0.5 v(wn_who_7_1)=0.5
.ic v(wp_bh_7)=0.5 v(wn_bh_7)=0.5
.ic v(wp_wih_0_8)=0.5 v(wn_wih_0_8)=0.5
.ic v(wp_wih_1_8)=0.5 v(wn_wih_1_8)=0.5
.ic v(wp_who_8_0)=0.5 v(wn_who_8_0)=0.5
.ic v(wp_who_8_1)=0.5 v(wn_who_8_1)=0.5
.ic v(wp_bh_8)=0.5 v(wn_bh_8)=0.5
.ic v(wp_wih_0_9)=0.5 v(wn_wih_0_9)=0.5
.ic v(wp_wih_1_9)=0.5 v(wn_wih_1_9)=0.5
.ic v(wp_who_9_0)=0.5 v(wn_who_9_0)=0.5
.ic v(wp_who_9_1)=0.5 v(wn_who_9_1)=0.5
.ic v(wp_bh_9)=0.5 v(wn_bh_9)=0.5
.ic v(wp_wih_0_10)=0.5 v(wn_wih_0_10)=0.5
.ic v(wp_wih_1_10)=0.5 v(wn_wih_1_10)=0.5
.ic v(wp_who_10_0)=0.5 v(wn_who_10_0)=0.5
.ic v(wp_who_10_1)=0.5 v(wn_who_10_1)=0.5
.ic v(wp_bh_10)=0.5 v(wn_bh_10)=0.5
.ic v(wp_wih_0_11)=0.5 v(wn_wih_0_11)=0.5
.ic v(wp_wih_1_11)=0.5 v(wn_wih_1_11)=0.5
.ic v(wp_who_11_0)=0.5 v(wn_who_11_0)=0.5
.ic v(wp_who_11_1)=0.5 v(wn_who_11_1)=0.5
.ic v(wp_bh_11)=0.5 v(wn_bh_11)=0.5
.ic v(wp_wih_0_12)=0.5 v(wn_wih_0_12)=0.5
.ic v(wp_wih_1_12)=0.5 v(wn_wih_1_12)=0.5
.ic v(wp_who_12_0)=0.5 v(wn_who_12_0)=0.5
.ic v(wp_who_12_1)=0.5 v(wn_who_12_1)=0.5
.ic v(wp_bh_12)=0.5 v(wn_bh_12)=0.5
.ic v(wp_wih_0_13)=0.5 v(wn_wih_0_13)=0.5
.ic v(wp_wih_1_13)=0.5 v(wn_wih_1_13)=0.5
.ic v(wp_who_13_0)=0.5 v(wn_who_13_0)=0.5
.ic v(wp_who_13_1)=0.5 v(wn_who_13_1)=0.5
.ic v(wp_bh_13)=0.5 v(wn_bh_13)=0.5
.ic v(wp_wih_0_14)=0.5 v(wn_wih_0_14)=0.5
.ic v(wp_wih_1_14)=0.5 v(wn_wih_1_14)=0.5
.ic v(wp_who_14_0)=0.5 v(wn_who_14_0)=0.5
.ic v(wp_who_14_1)=0.5 v(wn_who_14_1)=0.5
.ic v(wp_bh_14)=0.5 v(wn_bh_14)=0.5
.ic v(wp_wih_0_15)=0.5 v(wn_wih_0_15)=0.5
.ic v(wp_wih_1_15)=0.5 v(wn_wih_1_15)=0.5
.ic v(wp_who_15_0)=0.5 v(wn_who_15_0)=0.5
.ic v(wp_who_15_1)=0.5 v(wn_who_15_1)=0.5
.ic v(wp_bh_15)=0.5 v(wn_bh_15)=0.5
.ic v(wp_wih_0_16)=0.5 v(wn_wih_0_16)=0.5
.ic v(wp_wih_1_16)=0.5 v(wn_wih_1_16)=0.5
.ic v(wp_who_16_0)=0.5 v(wn_who_16_0)=0.5
.ic v(wp_who_16_1)=0.5 v(wn_who_16_1)=0.5
.ic v(wp_bh_16)=0.5 v(wn_bh_16)=0.5
.ic v(wp_wih_0_17)=0.5 v(wn_wih_0_17)=0.5
.ic v(wp_wih_1_17)=0.5 v(wn_wih_1_17)=0.5
.ic v(wp_who_17_0)=0.5 v(wn_who_17_0)=0.5
.ic v(wp_who_17_1)=0.5 v(wn_who_17_1)=0.5
.ic v(wp_bh_17)=0.5 v(wn_bh_17)=0.5
.ic v(wp_wih_0_18)=0.5 v(wn_wih_0_18)=0.5
.ic v(wp_wih_1_18)=0.5 v(wn_wih_1_18)=0.5
.ic v(wp_who_18_0)=0.5 v(wn_who_18_0)=0.5
.ic v(wp_who_18_1)=0.5 v(wn_who_18_1)=0.5
.ic v(wp_bh_18)=0.5 v(wn_bh_18)=0.5
.ic v(wp_wih_0_19)=0.5 v(wn_wih_0_19)=0.5
.ic v(wp_wih_1_19)=0.5 v(wn_wih_1_19)=0.5
.ic v(wp_who_19_0)=0.5 v(wn_who_19_0)=0.5
.ic v(wp_who_19_1)=0.5 v(wn_who_19_1)=0.5
.ic v(wp_bh_19)=0.5 v(wn_bh_19)=0.5
.ic v(wp_wih_0_20)=0.5 v(wn_wih_0_20)=0.5
.ic v(wp_wih_1_20)=0.5 v(wn_wih_1_20)=0.5
.ic v(wp_who_20_0)=0.5 v(wn_who_20_0)=0.5
.ic v(wp_who_20_1)=0.5 v(wn_who_20_1)=0.5
.ic v(wp_bh_20)=0.5 v(wn_bh_20)=0.5
.ic v(wp_wih_0_21)=0.5 v(wn_wih_0_21)=0.5
.ic v(wp_wih_1_21)=0.5 v(wn_wih_1_21)=0.5
.ic v(wp_who_21_0)=0.5 v(wn_who_21_0)=0.5
.ic v(wp_who_21_1)=0.5 v(wn_who_21_1)=0.5
.ic v(wp_bh_21)=0.5 v(wn_bh_21)=0.5
.ic v(wp_wih_0_22)=0.5 v(wn_wih_0_22)=0.5
.ic v(wp_wih_1_22)=0.5 v(wn_wih_1_22)=0.5
.ic v(wp_who_22_0)=0.5 v(wn_who_22_0)=0.5
.ic v(wp_who_22_1)=0.5 v(wn_who_22_1)=0.5
.ic v(wp_bh_22)=0.5 v(wn_bh_22)=0.5
.ic v(wp_wih_0_23)=0.5 v(wn_wih_0_23)=0.5
.ic v(wp_wih_1_23)=0.5 v(wn_wih_1_23)=0.5
.ic v(wp_who_23_0)=0.5 v(wn_who_23_0)=0.5
.ic v(wp_who_23_1)=0.5 v(wn_who_23_1)=0.5
.ic v(wp_bh_23)=0.5 v(wn_bh_23)=0.5
.ic v(wp_wih_0_24)=0.5 v(wn_wih_0_24)=0.5
.ic v(wp_wih_1_24)=0.5 v(wn_wih_1_24)=0.5
.ic v(wp_who_24_0)=0.5 v(wn_who_24_0)=0.5
.ic v(wp_who_24_1)=0.5 v(wn_who_24_1)=0.5
.ic v(wp_bh_24)=0.5 v(wn_bh_24)=0.5
.ic v(wp_wih_0_25)=0.5 v(wn_wih_0_25)=0.5
.ic v(wp_wih_1_25)=0.5 v(wn_wih_1_25)=0.5
.ic v(wp_who_25_0)=0.5 v(wn_who_25_0)=0.5
.ic v(wp_who_25_1)=0.5 v(wn_who_25_1)=0.5
.ic v(wp_bh_25)=0.5 v(wn_bh_25)=0.5
.ic v(wp_wih_0_26)=0.5 v(wn_wih_0_26)=0.5
.ic v(wp_wih_1_26)=0.5 v(wn_wih_1_26)=0.5
.ic v(wp_who_26_0)=0.5 v(wn_who_26_0)=0.5
.ic v(wp_who_26_1)=0.5 v(wn_who_26_1)=0.5
.ic v(wp_bh_26)=0.5 v(wn_bh_26)=0.5
.ic v(wp_wih_0_27)=0.5 v(wn_wih_0_27)=0.5
.ic v(wp_wih_1_27)=0.5 v(wn_wih_1_27)=0.5
.ic v(wp_who_27_0)=0.5 v(wn_who_27_0)=0.5
.ic v(wp_who_27_1)=0.5 v(wn_who_27_1)=0.5
.ic v(wp_bh_27)=0.5 v(wn_bh_27)=0.5
.ic v(wp_wih_0_28)=0.5 v(wn_wih_0_28)=0.5
.ic v(wp_wih_1_28)=0.5 v(wn_wih_1_28)=0.5
.ic v(wp_who_28_0)=0.5 v(wn_who_28_0)=0.5
.ic v(wp_who_28_1)=0.5 v(wn_who_28_1)=0.5
.ic v(wp_bh_28)=0.5 v(wn_bh_28)=0.5
.ic v(wp_wih_0_29)=0.5 v(wn_wih_0_29)=0.5
.ic v(wp_wih_1_29)=0.5 v(wn_wih_1_29)=0.5
.ic v(wp_who_29_0)=0.5 v(wn_who_29_0)=0.5
.ic v(wp_who_29_1)=0.5 v(wn_who_29_1)=0.5
.ic v(wp_bh_29)=0.5 v(wn_bh_29)=0.5
.ic v(wp_wih_0_30)=0.5 v(wn_wih_0_30)=0.5
.ic v(wp_wih_1_30)=0.5 v(wn_wih_1_30)=0.5
.ic v(wp_who_30_0)=0.5 v(wn_who_30_0)=0.5
.ic v(wp_who_30_1)=0.5 v(wn_who_30_1)=0.5
.ic v(wp_bh_30)=0.5 v(wn_bh_30)=0.5
.ic v(wp_wih_0_31)=0.5 v(wn_wih_0_31)=0.5
.ic v(wp_wih_1_31)=0.5 v(wn_wih_1_31)=0.5
.ic v(wp_who_31_0)=0.5 v(wn_who_31_0)=0.5
.ic v(wp_who_31_1)=0.5 v(wn_who_31_1)=0.5
.ic v(wp_bh_31)=0.5 v(wn_bh_31)=0.5
.ic v(wp_wih_0_32)=0.5 v(wn_wih_0_32)=0.5
.ic v(wp_wih_1_32)=0.5 v(wn_wih_1_32)=0.5
.ic v(wp_who_32_0)=0.5 v(wn_who_32_0)=0.5
.ic v(wp_who_32_1)=0.5 v(wn_who_32_1)=0.5
.ic v(wp_bh_32)=0.5 v(wn_bh_32)=0.5
.ic v(wp_wih_0_33)=0.5 v(wn_wih_0_33)=0.5
.ic v(wp_wih_1_33)=0.5 v(wn_wih_1_33)=0.5
.ic v(wp_who_33_0)=0.5 v(wn_who_33_0)=0.5
.ic v(wp_who_33_1)=0.5 v(wn_who_33_1)=0.5
.ic v(wp_bh_33)=0.5 v(wn_bh_33)=0.5
.ic v(wp_wih_0_34)=0.5 v(wn_wih_0_34)=0.5
.ic v(wp_wih_1_34)=0.5 v(wn_wih_1_34)=0.5
.ic v(wp_who_34_0)=0.5 v(wn_who_34_0)=0.5
.ic v(wp_who_34_1)=0.5 v(wn_who_34_1)=0.5
.ic v(wp_bh_34)=0.5 v(wn_bh_34)=0.5
.ic v(wp_wih_0_35)=0.5 v(wn_wih_0_35)=0.5
.ic v(wp_wih_1_35)=0.5 v(wn_wih_1_35)=0.5
.ic v(wp_who_35_0)=0.5 v(wn_who_35_0)=0.5
.ic v(wp_who_35_1)=0.5 v(wn_who_35_1)=0.5
.ic v(wp_bh_35)=0.5 v(wn_bh_35)=0.5
.ic v(wp_wih_0_36)=0.5 v(wn_wih_0_36)=0.5
.ic v(wp_wih_1_36)=0.5 v(wn_wih_1_36)=0.5
.ic v(wp_who_36_0)=0.5 v(wn_who_36_0)=0.5
.ic v(wp_who_36_1)=0.5 v(wn_who_36_1)=0.5
.ic v(wp_bh_36)=0.5 v(wn_bh_36)=0.5
.ic v(wp_wih_0_37)=0.5 v(wn_wih_0_37)=0.5
.ic v(wp_wih_1_37)=0.5 v(wn_wih_1_37)=0.5
.ic v(wp_who_37_0)=0.5 v(wn_who_37_0)=0.5
.ic v(wp_who_37_1)=0.5 v(wn_who_37_1)=0.5
.ic v(wp_bh_37)=0.5 v(wn_bh_37)=0.5
.ic v(wp_wih_0_38)=0.5 v(wn_wih_0_38)=0.5
.ic v(wp_wih_1_38)=0.5 v(wn_wih_1_38)=0.5
.ic v(wp_who_38_0)=0.5 v(wn_who_38_0)=0.5
.ic v(wp_who_38_1)=0.5 v(wn_who_38_1)=0.5
.ic v(wp_bh_38)=0.5 v(wn_bh_38)=0.5
.ic v(wp_wih_0_39)=0.5 v(wn_wih_0_39)=0.5
.ic v(wp_wih_1_39)=0.5 v(wn_wih_1_39)=0.5
.ic v(wp_who_39_0)=0.5 v(wn_who_39_0)=0.5
.ic v(wp_who_39_1)=0.5 v(wn_who_39_1)=0.5
.ic v(wp_bh_39)=0.5 v(wn_bh_39)=0.5
.ic v(wp_bo_0)=0.5 v(wn_bo_0)=0.5
.ic v(wp_bo_1)=0.5 v(wn_bo_1)=0.5
.tran 1n 36000n uic
.control
run
wrdata pd2880135.dat v(wp_wih_0_0) v(wn_wih_0_0) v(wp_wih_1_0) v(wn_wih_1_0) v(wp_who_0_0) v(wn_who_0_0) v(wp_who_0_1) v(wn_who_0_1) v(wp_bh_0) v(wn_bh_0) v(wp_wih_0_1) v(wn_wih_0_1) v(wp_wih_1_1) v(wn_wih_1_1) v(wp_who_1_0) v(wn_who_1_0) v(wp_who_1_1) v(wn_who_1_1) v(wp_bh_1) v(wn_bh_1) v(wp_wih_0_2) v(wn_wih_0_2) v(wp_wih_1_2) v(wn_wih_1_2) v(wp_who_2_0) v(wn_who_2_0) v(wp_who_2_1) v(wn_who_2_1) v(wp_bh_2) v(wn_bh_2) v(wp_wih_0_3) v(wn_wih_0_3) v(wp_wih_1_3) v(wn_wih_1_3) v(wp_who_3_0) v(wn_who_3_0) v(wp_who_3_1) v(wn_who_3_1) v(wp_bh_3) v(wn_bh_3) v(wp_wih_0_4) v(wn_wih_0_4) v(wp_wih_1_4) v(wn_wih_1_4) v(wp_who_4_0) v(wn_who_4_0) v(wp_who_4_1) v(wn_who_4_1) v(wp_bh_4) v(wn_bh_4) v(wp_wih_0_5) v(wn_wih_0_5) v(wp_wih_1_5) v(wn_wih_1_5) v(wp_who_5_0) v(wn_who_5_0) v(wp_who_5_1) v(wn_who_5_1) v(wp_bh_5) v(wn_bh_5) v(wp_wih_0_6) v(wn_wih_0_6) v(wp_wih_1_6) v(wn_wih_1_6) v(wp_who_6_0) v(wn_who_6_0) v(wp_who_6_1) v(wn_who_6_1) v(wp_bh_6) v(wn_bh_6) v(wp_wih_0_7) v(wn_wih_0_7) v(wp_wih_1_7) v(wn_wih_1_7) v(wp_who_7_0) v(wn_who_7_0) v(wp_who_7_1) v(wn_who_7_1) v(wp_bh_7) v(wn_bh_7) v(wp_wih_0_8) v(wn_wih_0_8) v(wp_wih_1_8) v(wn_wih_1_8) v(wp_who_8_0) v(wn_who_8_0) v(wp_who_8_1) v(wn_who_8_1) v(wp_bh_8) v(wn_bh_8) v(wp_wih_0_9) v(wn_wih_0_9) v(wp_wih_1_9) v(wn_wih_1_9) v(wp_who_9_0) v(wn_who_9_0) v(wp_who_9_1) v(wn_who_9_1) v(wp_bh_9) v(wn_bh_9) v(wp_wih_0_10) v(wn_wih_0_10) v(wp_wih_1_10) v(wn_wih_1_10) v(wp_who_10_0) v(wn_who_10_0) v(wp_who_10_1) v(wn_who_10_1) v(wp_bh_10) v(wn_bh_10) v(wp_wih_0_11) v(wn_wih_0_11) v(wp_wih_1_11) v(wn_wih_1_11) v(wp_who_11_0) v(wn_who_11_0) v(wp_who_11_1) v(wn_who_11_1) v(wp_bh_11) v(wn_bh_11) v(wp_wih_0_12) v(wn_wih_0_12) v(wp_wih_1_12) v(wn_wih_1_12) v(wp_who_12_0) v(wn_who_12_0) v(wp_who_12_1) v(wn_who_12_1) v(wp_bh_12) v(wn_bh_12) v(wp_wih_0_13) v(wn_wih_0_13) v(wp_wih_1_13) v(wn_wih_1_13) v(wp_who_13_0) v(wn_who_13_0) v(wp_who_13_1) v(wn_who_13_1) v(wp_bh_13) v(wn_bh_13) v(wp_wih_0_14) v(wn_wih_0_14) v(wp_wih_1_14) v(wn_wih_1_14) v(wp_who_14_0) v(wn_who_14_0) v(wp_who_14_1) v(wn_who_14_1) v(wp_bh_14) v(wn_bh_14) v(wp_wih_0_15) v(wn_wih_0_15) v(wp_wih_1_15) v(wn_wih_1_15) v(wp_who_15_0) v(wn_who_15_0) v(wp_who_15_1) v(wn_who_15_1) v(wp_bh_15) v(wn_bh_15) v(wp_wih_0_16) v(wn_wih_0_16) v(wp_wih_1_16) v(wn_wih_1_16) v(wp_who_16_0) v(wn_who_16_0) v(wp_who_16_1) v(wn_who_16_1) v(wp_bh_16) v(wn_bh_16) v(wp_wih_0_17) v(wn_wih_0_17) v(wp_wih_1_17) v(wn_wih_1_17) v(wp_who_17_0) v(wn_who_17_0) v(wp_who_17_1) v(wn_who_17_1) v(wp_bh_17) v(wn_bh_17) v(wp_wih_0_18) v(wn_wih_0_18) v(wp_wih_1_18) v(wn_wih_1_18) v(wp_who_18_0) v(wn_who_18_0) v(wp_who_18_1) v(wn_who_18_1) v(wp_bh_18) v(wn_bh_18) v(wp_wih_0_19) v(wn_wih_0_19) v(wp_wih_1_19) v(wn_wih_1_19) v(wp_who_19_0) v(wn_who_19_0) v(wp_who_19_1) v(wn_who_19_1) v(wp_bh_19) v(wn_bh_19) v(wp_wih_0_20) v(wn_wih_0_20) v(wp_wih_1_20) v(wn_wih_1_20) v(wp_who_20_0) v(wn_who_20_0) v(wp_who_20_1) v(wn_who_20_1) v(wp_bh_20) v(wn_bh_20) v(wp_wih_0_21) v(wn_wih_0_21) v(wp_wih_1_21) v(wn_wih_1_21) v(wp_who_21_0) v(wn_who_21_0) v(wp_who_21_1) v(wn_who_21_1) v(wp_bh_21) v(wn_bh_21) v(wp_wih_0_22) v(wn_wih_0_22) v(wp_wih_1_22) v(wn_wih_1_22) v(wp_who_22_0) v(wn_who_22_0) v(wp_who_22_1) v(wn_who_22_1) v(wp_bh_22) v(wn_bh_22) v(wp_wih_0_23) v(wn_wih_0_23) v(wp_wih_1_23) v(wn_wih_1_23) v(wp_who_23_0) v(wn_who_23_0) v(wp_who_23_1) v(wn_who_23_1) v(wp_bh_23) v(wn_bh_23) v(wp_wih_0_24) v(wn_wih_0_24) v(wp_wih_1_24) v(wn_wih_1_24) v(wp_who_24_0) v(wn_who_24_0) v(wp_who_24_1) v(wn_who_24_1) v(wp_bh_24) v(wn_bh_24) v(wp_wih_0_25) v(wn_wih_0_25) v(wp_wih_1_25) v(wn_wih_1_25) v(wp_who_25_0) v(wn_who_25_0) v(wp_who_25_1) v(wn_who_25_1) v(wp_bh_25) v(wn_bh_25) v(wp_wih_0_26) v(wn_wih_0_26) v(wp_wih_1_26) v(wn_wih_1_26) v(wp_who_26_0) v(wn_who_26_0) v(wp_who_26_1) v(wn_who_26_1) v(wp_bh_26) v(wn_bh_26) v(wp_wih_0_27) v(wn_wih_0_27) v(wp_wih_1_27) v(wn_wih_1_27) v(wp_who_27_0) v(wn_who_27_0) v(wp_who_27_1) v(wn_who_27_1) v(wp_bh_27) v(wn_bh_27) v(wp_wih_0_28) v(wn_wih_0_28) v(wp_wih_1_28) v(wn_wih_1_28) v(wp_who_28_0) v(wn_who_28_0) v(wp_who_28_1) v(wn_who_28_1) v(wp_bh_28) v(wn_bh_28) v(wp_wih_0_29) v(wn_wih_0_29) v(wp_wih_1_29) v(wn_wih_1_29) v(wp_who_29_0) v(wn_who_29_0) v(wp_who_29_1) v(wn_who_29_1) v(wp_bh_29) v(wn_bh_29) v(wp_wih_0_30) v(wn_wih_0_30) v(wp_wih_1_30) v(wn_wih_1_30) v(wp_who_30_0) v(wn_who_30_0) v(wp_who_30_1) v(wn_who_30_1) v(wp_bh_30) v(wn_bh_30) v(wp_wih_0_31) v(wn_wih_0_31) v(wp_wih_1_31) v(wn_wih_1_31) v(wp_who_31_0) v(wn_who_31_0) v(wp_who_31_1) v(wn_who_31_1) v(wp_bh_31) v(wn_bh_31) v(wp_wih_0_32) v(wn_wih_0_32) v(wp_wih_1_32) v(wn_wih_1_32) v(wp_who_32_0) v(wn_who_32_0) v(wp_who_32_1) v(wn_who_32_1) v(wp_bh_32) v(wn_bh_32) v(wp_wih_0_33) v(wn_wih_0_33) v(wp_wih_1_33) v(wn_wih_1_33) v(wp_who_33_0) v(wn_who_33_0) v(wp_who_33_1) v(wn_who_33_1) v(wp_bh_33) v(wn_bh_33) v(wp_wih_0_34) v(wn_wih_0_34) v(wp_wih_1_34) v(wn_wih_1_34) v(wp_who_34_0) v(wn_who_34_0) v(wp_who_34_1) v(wn_who_34_1) v(wp_bh_34) v(wn_bh_34) v(wp_wih_0_35) v(wn_wih_0_35) v(wp_wih_1_35) v(wn_wih_1_35) v(wp_who_35_0) v(wn_who_35_0) v(wp_who_35_1) v(wn_who_35_1) v(wp_bh_35) v(wn_bh_35) v(wp_wih_0_36) v(wn_wih_0_36) v(wp_wih_1_36) v(wn_wih_1_36) v(wp_who_36_0) v(wn_who_36_0) v(wp_who_36_1) v(wn_who_36_1) v(wp_bh_36) v(wn_bh_36) v(wp_wih_0_37) v(wn_wih_0_37) v(wp_wih_1_37) v(wn_wih_1_37) v(wp_who_37_0) v(wn_who_37_0) v(wp_who_37_1) v(wn_who_37_1) v(wp_bh_37) v(wn_bh_37) v(wp_wih_0_38) v(wn_wih_0_38) v(wp_wih_1_38) v(wn_wih_1_38) v(wp_who_38_0) v(wn_who_38_0) v(wp_who_38_1) v(wn_who_38_1) v(wp_bh_38) v(wn_bh_38) v(wp_wih_0_39) v(wn_wih_0_39) v(wp_wih_1_39) v(wn_wih_1_39) v(wp_who_39_0) v(wn_who_39_0) v(wp_who_39_1) v(wn_who_39_1) v(wp_bh_39) v(wn_bh_39) v(wp_bo_0) v(wn_bo_0) v(wp_bo_1) v(wn_bo_1)
.endc
.end
