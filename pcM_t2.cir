multi-class continuous PC digits
.model NNR NMOS (LEVEL=1 VTO=0.2 KP=120u LAMBDA=0.02 GAMMA=0 PHI=0.7)
.model PNR PMOS (LEVEL=1 VTO=-0.2 KP=40u LAMBDA=0.02 GAMMA=0 PHI=0.7)
.subckt gsyn inp inn wp wn outp outn vdd vbn
Mtail nt vbn 0 0 NNR W=400u L=100u
M5 na wp nt 0 NNR W=200u L=100u
M6 nb wn nt 0 NNR W=200u L=100u
M1 outp inp na 0 NNR W=200u L=100u
M2 outn inn na 0 NNR W=200u L=100u
M3 outn inp nb 0 NNR W=200u L=100u
M4 outp inn nb 0 NNR W=200u L=100u
.ends
.subckt cmld p n vdd
Rcs1 p cmx 300k
Rcs2 n cmx 300k
MLp p cmx vdd vdd PNR W=1000u L=100u
MLn n cmx vdd vdd PNR W=1000u L=100u
.ends
.subckt dneuron up un ap an vdd vbn
M1 an up tn 0 NNR W=200u L=100u
M2 ap un tn 0 NNR W=200u L=100u
Mt tn vbn 0 0 NNR W=200u L=100u
Xcm ap an vdd cmld
.ends
.subckt esub xp xn mp mn ep en vdd vbn
Mt nt vbn 0 0 NNR W=400u L=100u
M1x ep xn nt 0 NNR W=200u L=100u
M2x en xp nt 0 NNR W=200u L=100u
M1m ep mp nt 0 NNR W=200u L=100u
M2m en mn nt 0 NNR W=200u L=100u
RLp vdd ep 50k
RLn vdd en 50k
.ends
.subckt gprod xp xn yp yn wp wn vdd vbn
Mtail nt vbn 0 0 NNR W=400u L=100u
Ctail nt 0 15f
M5 na yp nt 0 NNR W=200u L=100u
M6 nb yn nt 0 NNR W=200u L=100u
M1 iop xp na 0 NNR W=200u L=100u
M2 ion xn na 0 NNR W=200u L=100u
M3 ion xp nb 0 NNR W=200u L=100u
M4 iop xn nb 0 NNR W=200u L=100u
Mlp iop iop vdd vdd PNR W=200u L=100u
Mln ion ion vdd vdd PNR W=200u L=100u
Mpu_wp wp iop vdd vdd PNR W=200u L=100u
MpRn nrn ion vdd vdd PNR W=200u L=100u
MnRn nrn nrn 0 0 NNR W=200u L=100u
Mpd_wp wp nrn 0 0 NNR W=200u L=100u
Mpu_wn wn ion vdd vdd PNR W=200u L=100u
MpRp nrp iop vdd vdd PNR W=200u L=100u
MnRp nrp nrp 0 0 NNR W=200u L=100u
Mpd_wn wn nrp 0 0 NNR W=200u L=100u
.ends
Vdd vdd 0 1.0
Vbsyn vbsyn 0 0.45
Vbneu vbneu 0 0.35
Vgm gm 0 0.6
Vgblh gblh 0 0.85
Vgblo gblo 0 0.85
Vwcm wcm 0 0.5
Vxp0 a_xp0 0 PWL(0.0n 0.4393 249.9n 0.4393 250.0n 0.4393 499.9n 0.4393 500.0n 0.4393 749.9n 0.4393 750.0n 0.4393 999.9n 0.4393 1000.0n 0.4393 1249.9n 0.4393 1250.0n 0.4393 1499.9n 0.4393 1500.0n 0.4393 1749.9n 0.4393 1750.0n 0.4393 1999.9n 0.4393 2000.0n 0.4393 2249.9n 0.4393 2250.0n 0.4393 2499.9n 0.4393 2500.0n 0.4393 2749.9n 0.4393 2750.0n 0.5184 2999.9n 0.5184 3000.0n 0.4393 3249.9n 0.4393 3250.0n 0.4393 3499.9n 0.4393 3500.0n 0.4393 3749.9n 0.4393 3750.0n 0.4393 3999.9n 0.4393 4000.0n 0.4393 4249.9n 0.4393 4250.0n 0.4393 4499.9n 0.4393 4500.0n 0.4393 4749.9n 0.4393 4750.0n 0.4393 4999.9n 0.4393 5000.0n 0.4657 5249.9n 0.4657 5250.0n 0.4393 5499.9n 0.4393 5500.0n 0.4393 5749.9n 0.4393 5750.0n 0.4393 5999.9n 0.4393 6000.0n 0.4393 6249.9n 0.4393 6250.0n 0.4393 6499.9n 0.4393 6500.0n 0.4393 6749.9n 0.4393 6750.0n 0.4393 6999.9n 0.4393 7000.0n 0.4657 7249.9n 0.4657 7250.0n 0.4393 7499.9n 0.4393 7500.0n 0.4393 7749.9n 0.4393 7750.0n 0.4393 7999.9n 0.4393 8000.0n 0.4393 8249.9n 0.4393 8250.0n 0.4393 8499.9n 0.4393 8500.0n 0.4393 8749.9n 0.4393 8750.0n 0.4393 8999.9n 0.4393 9000.0n 0.4393 9249.9n 0.4393 9250.0n 0.4393 9499.9n 0.4393 9500.0n 0.4393 9749.9n 0.4393 9750.0n 0.4393 9999.9n 0.4393 10000.0n 0.4393 10249.9n 0.4393 10250.0n 0.5184 10499.9n 0.5184 10500.0n 0.4393 10749.9n 0.4393 10750.0n 0.4393 10999.9n 0.4393 11000.0n 0.4393 11249.9n 0.4393 11250.0n 0.4393 11499.9n 0.4393 11500.0n 0.4393 11749.9n 0.4393 11750.0n 0.4393 11999.9n 0.4393 12000.0n 0.4393 12249.9n 0.4393 12250.0n 0.4393 12499.9n 0.4393 12500.0n 0.4657 12749.9n 0.4657 12750.0n 0.4393 12999.9n 0.4393 13000.0n 0.4393 13249.9n 0.4393 13250.0n 0.4393 13499.9n 0.4393 13500.0n 0.4393 13749.9n 0.4393 13750.0n 0.4393 13999.9n 0.4393 14000.0n 0.4393 14249.9n 0.4393 14250.0n 0.4393 14499.9n 0.4393 14500.0n 0.4657 14749.9n 0.4657 14750.0n 0.4393 14999.9n 0.4393 15000.0n 0.4393 15249.9n 0.4393 15250.0n 0.4393 15499.9n 0.4393 15500.0n 0.4393 15749.9n 0.4393 15750.0n 0.4393 15999.9n 0.4393 16000.0n 0.4393 16249.9n 0.4393 16250.0n 0.4393 16499.9n 0.4393 16500.0n 0.4393 16749.9n 0.4393 16750.0n 0.4393 16999.9n 0.4393 17000.0n 0.4393 17249.9n 0.4393 17250.0n 0.4393 17499.9n 0.4393 17500.0n 0.4393 17749.9n 0.4393 17750.0n 0.5184 17999.9n 0.5184 18000.0n 0.4393 18249.9n 0.4393 18250.0n 0.4393 18499.9n 0.4393 18500.0n 0.4393 18749.9n 0.4393 18750.0n 0.4393 18999.9n 0.4393 19000.0n 0.4393 19249.9n 0.4393 19250.0n 0.4393 19499.9n 0.4393 19500.0n 0.4393 19749.9n 0.4393 19750.0n 0.4393 19999.9n 0.4393 20000.0n 0.4657 20249.9n 0.4657 20250.0n 0.4393 20499.9n 0.4393 20500.0n 0.4393 20749.9n 0.4393 20750.0n 0.4393 20999.9n 0.4393 21000.0n 0.4393 21249.9n 0.4393 21250.0n 0.4393 21499.9n 0.4393 21500.0n 0.4393 21749.9n 0.4393 21750.0n 0.4393 21999.9n 0.4393 22000.0n 0.4657 22249.9n 0.4657 22250.0n 0.4393 22499.9n 0.4393 22500.0n 0.4393 22749.9n 0.4393 22750.0n 0.4393 22999.9n 0.4393 23000.0n 0.4393 23249.9n 0.4393 23250.0n 0.4393 23499.9n 0.4393 23500.0n 0.4393 23749.9n 0.4393 23750.0n 0.4393 23999.9n 0.4393 24000.0n 0.4393 24249.9n 0.4393 24250.0n 0.4393 24499.9n 0.4393 24500.0n 0.4393 24749.9n 0.4393 24750.0n 0.4393 24999.9n 0.4393 25000.0n 0.4393 25249.9n 0.4393 25250.0n 0.5184 25499.9n 0.5184 25500.0n 0.4393 25749.9n 0.4393 25750.0n 0.4393 25999.9n 0.4393 26000.0n 0.4393 26249.9n 0.4393 26250.0n 0.4393 26499.9n 0.4393 26500.0n 0.4393 26749.9n 0.4393 26750.0n 0.4393 26999.9n 0.4393 27000.0n 0.4393 27249.9n 0.4393 27250.0n 0.4393 27499.9n 0.4393 27500.0n 0.4657 27749.9n 0.4657 27750.0n 0.4393 27999.9n 0.4393 28000.0n 0.4393 28249.9n 0.4393 28250.0n 0.4393 28499.9n 0.4393 28500.0n 0.4393 28749.9n 0.4393 28750.0n 0.4393 28999.9n 0.4393 29000.0n 0.4393 29249.9n 0.4393 29250.0n 0.4393 29499.9n 0.4393 29500.0n 0.4657 29749.9n 0.4657 29750.0n 0.4393 29999.9n 0.4393 30000.0n 0.4393 30249.9n 0.4393 30250.0n 0.4393 30499.9n 0.4393 30500.0n 0.4393 30749.9n 0.4393 30750.0n 0.4393 30999.9n 0.4393 31000.0n 0.4393 31249.9n 0.4393 31250.0n 0.4393 31499.9n 0.4393 31500.0n 0.4393 31749.9n 0.4393 31750.0n 0.4393 31999.9n 0.4393 32000.0n 0.4393 32249.9n 0.4393 32250.0n 0.4393 32499.9n 0.4393 32500.0n 0.4393 32749.9n 0.4393 32750.0n 0.5184 32999.9n 0.5184 33000.0n 0.4393 33249.9n 0.4393 33250.0n 0.4393 33499.9n 0.4393 33500.0n 0.4393 33749.9n 0.4393 33750.0n 0.4393 33999.9n 0.4393 34000.0n 0.4393 34249.9n 0.4393 34250.0n 0.4393 34499.9n 0.4393 34500.0n 0.4393 34749.9n 0.4393 34750.0n 0.4393 34999.9n 0.4393 35000.0n 0.4657 35249.9n 0.4657 35250.0n 0.4393 35499.9n 0.4393 35500.0n 0.4393 35749.9n 0.4393 35750.0n 0.4393 35999.9n 0.4393 36000.0n 0.4393 36249.9n 0.4393 36250.0n 0.4393 36499.9n 0.4393 36500.0n 0.4393 36749.9n 0.4393 36750.0n 0.4393 36999.9n 0.4393 37000.0n 0.4657 37249.9n 0.4657 37250.0n 0.4393 37499.9n 0.4393 37500.0n 0.4393 37749.9n 0.4393 37750.0n 0.4393 37999.9n 0.4393 38000.0n 0.4393 38249.9n 0.4393 38250.0n 0.4393 38499.9n 0.4393 38500.0n 0.4393 38749.9n 0.4393 38750.0n 0.4393 38999.9n 0.4393 39000.0n 0.4393 39249.9n 0.4393 39250.0n 0.4393 39499.9n 0.4393 39500.0n 0.4393 39749.9n 0.4393 39750.0n 0.4393 39999.9n 0.4393 40000.0n 0.4393 40249.9n 0.4393 40250.0n 0.5184 40499.9n 0.5184 40500.0n 0.4393 40749.9n 0.4393 40750.0n 0.4393 40999.9n 0.4393 41000.0n 0.4393 41249.9n 0.4393 41250.0n 0.4393 41499.9n 0.4393 41500.0n 0.4393 41749.9n 0.4393 41750.0n 0.4393 41999.9n 0.4393 42000.0n 0.4393 42249.9n 0.4393 42250.0n 0.4393 42499.9n 0.4393 42500.0n 0.4657 42749.9n 0.4657 42750.0n 0.4393 42999.9n 0.4393 43000.0n 0.4393 43249.9n 0.4393 43250.0n 0.4393 43499.9n 0.4393 43500.0n 0.4393 43749.9n 0.4393 43750.0n 0.4393 43999.9n 0.4393 44000.0n 0.4393 44249.9n 0.4393 44250.0n 0.4393 44499.9n 0.4393 44500.0n 0.4657 44749.9n 0.4657 44750.0n 0.4393 44999.9n 0.4393 45000.0n 0.4393 45249.9n 0.4393 45250.0n 0.4393 45499.9n 0.4393 45500.0n 0.4393 45749.9n 0.4393 45750.0n 0.4393 45999.9n 0.4393 46000.0n 0.4393 46249.9n 0.4393 46250.0n 0.4393 46499.9n 0.4393 46500.0n 0.4393 46749.9n 0.4393 46750.0n 0.4393 46999.9n 0.4393 47000.0n 0.4393 47249.9n 0.4393 47250.0n 0.4393 47499.9n 0.4393 47500.0n 0.4393 47749.9n 0.4393 47750.0n 0.5184 47999.9n 0.5184 48000.0n 0.4393 48249.9n 0.4393 48250.0n 0.4393 48499.9n 0.4393 48500.0n 0.4393 48749.9n 0.4393 48750.0n 0.4393 48999.9n 0.4393 49000.0n 0.4393 49249.9n 0.4393 49250.0n 0.4393 49499.9n 0.4393 49500.0n 0.4393 49749.9n 0.4393 49750.0n 0.4393 49999.9n 0.4393 50000.0n 0.4657 50249.9n 0.4657 50250.0n 0.4393 50499.9n 0.4393 50500.0n 0.4393 50749.9n 0.4393 50750.0n 0.4393 50999.9n 0.4393 51000.0n 0.4393 51249.9n 0.4393 51250.0n 0.4393 51499.9n 0.4393 51500.0n 0.4393 51749.9n 0.4393 51750.0n 0.4393 51999.9n 0.4393 52000.0n 0.4657 52249.9n 0.4657 52250.0n 0.4393 52499.9n 0.4393 52500.0n 0.4393 52749.9n 0.4393 52750.0n 0.4393 52999.9n 0.4393 53000.0n 0.4393 53249.9n 0.4393 53250.0n 0.4393 53499.9n 0.4393 53500.0n 0.4393 53749.9n 0.4393 53750.0n 0.4393 53999.9n 0.4393 54000.0n 0.4393 54249.9n 0.4393 54250.0n 0.4393 54499.9n 0.4393 54500.0n 0.4393 54749.9n 0.4393 54750.0n 0.4393 54999.9n 0.4393 55000.0n 0.4393 55249.9n 0.4393 55250.0n 0.5184 55499.9n 0.5184 55500.0n 0.4393 55749.9n 0.4393 55750.0n 0.4393 55999.9n 0.4393 56000.0n 0.4393 56249.9n 0.4393 56250.0n 0.4393 56499.9n 0.4393 56500.0n 0.4393 56749.9n 0.4393 56750.0n 0.4393 56999.9n 0.4393 57000.0n 0.4393 57249.9n 0.4393 57250.0n 0.4393 57499.9n 0.4393 57500.0n 0.4657 57749.9n 0.4657 57750.0n 0.4393 57999.9n 0.4393 58000.0n 0.4393 58249.9n 0.4393 58250.0n 0.4393 58499.9n 0.4393 58500.0n 0.4393 58749.9n 0.4393 58750.0n 0.4393 58999.9n 0.4393 59000.0n 0.4393 59249.9n 0.4393 59250.0n 0.4393 59499.9n 0.4393 59500.0n 0.4657 59749.9n 0.4657 59750.0n 0.4393 59999.9n 0.4393 60000.0n 0.4393 60249.9n 0.4393 60250.0n 0.4393 60499.9n 0.4393 60500.0n 0.4393 60749.9n 0.4393 60750.0n 0.4393 60999.9n 0.4393 61000.0n 0.4393 61249.9n 0.4393 61250.0n 0.4393 61499.9n 0.4393 61500.0n 0.4393 61749.9n 0.4393 61750.0n 0.4393 61999.9n 0.4393 62000.0n 0.4393 62249.9n 0.4393 62250.0n 0.4393 62499.9n 0.4393 62500.0n 0.4393 62749.9n 0.4393 62750.0n 0.5184 62999.9n 0.5184 63000.0n 0.4393 63249.9n 0.4393 63250.0n 0.4393 63499.9n 0.4393 63500.0n 0.4393 63749.9n 0.4393 63750.0n 0.4393 63999.9n 0.4393 64000.0n 0.4393 64249.9n 0.4393 64250.0n 0.4393 64499.9n 0.4393 64500.0n 0.4393 64749.9n 0.4393 64750.0n 0.4393 64999.9n 0.4393 65000.0n 0.4657 65249.9n 0.4657 65250.0n 0.4393 65499.9n 0.4393 65500.0n 0.4393 65749.9n 0.4393 65750.0n 0.4393 65999.9n 0.4393 66000.0n 0.4393 66249.9n 0.4393 66250.0n 0.4393 66499.9n 0.4393 66500.0n 0.4393 66749.9n 0.4393 66750.0n 0.4393 66999.9n 0.4393 67000.0n 0.4657 67249.9n 0.4657 67250.0n 0.4393 67499.9n 0.4393 67500.0n 0.4393 67749.9n 0.4393 67750.0n 0.4393 67999.9n 0.4393 68000.0n 0.4393 68249.9n 0.4393 68250.0n 0.4393 68499.9n 0.4393 68500.0n 0.4393 68749.9n 0.4393 68750.0n 0.4393 68999.9n 0.4393 69000.0n 0.4393 69249.9n 0.4393 69250.0n 0.4393 69499.9n 0.4393 69500.0n 0.4393 69749.9n 0.4393 69750.0n 0.4393 69999.9n 0.4393 70000.0n 0.4393 70249.9n 0.4393 70250.0n 0.5184 70499.9n 0.5184 70500.0n 0.4393 70749.9n 0.4393 70750.0n 0.4393 70999.9n 0.4393 71000.0n 0.4393 71249.9n 0.4393 71250.0n 0.4393 71499.9n 0.4393 71500.0n 0.4393 71749.9n 0.4393 71750.0n 0.4393 71999.9n 0.4393 72000.0n 0.4393 72249.9n 0.4393 72250.0n 0.4393 72499.9n 0.4393 72500.0n 0.4657 72749.9n 0.4657 72750.0n 0.4393 72999.9n 0.4393 73000.0n 0.4393 73249.9n 0.4393 73250.0n 0.4393 73499.9n 0.4393 73500.0n 0.4393 73749.9n 0.4393 73750.0n 0.4393 73999.9n 0.4393 74000.0n 0.4393 74249.9n 0.4393 74250.0n 0.4393 74499.9n 0.4393 74500.0n 0.4657 74749.9n 0.4657 74750.0n 0.4393 74999.9n 0.4393 75000.0n 0.4393 75249.9n 0.4393 75250.0n 0.4393 75499.9n 0.4393 75500.0n 0.4393 75749.9n 0.4393 75750.0n 0.4393 75999.9n 0.4393 76000.0n 0.4393 76249.9n 0.4393 76250.0n 0.4393 76499.9n 0.4393 76500.0n 0.4393 76749.9n 0.4393 76750.0n 0.4393 76999.9n 0.4393 77000.0n 0.4393 77249.9n 0.4393 77250.0n 0.4393 77499.9n 0.4393 77500.0n 0.4393 77749.9n 0.4393 77750.0n 0.5184 77999.9n 0.5184 78000.0n 0.4393 78249.9n 0.4393 78250.0n 0.4393 78499.9n 0.4393 78500.0n 0.4393 78749.9n 0.4393 78750.0n 0.4393 78999.9n 0.4393 79000.0n 0.4393 79249.9n 0.4393 79250.0n 0.4393 79499.9n 0.4393 79500.0n 0.4393 79749.9n 0.4393 79750.0n 0.4393 79999.9n 0.4393 80000.0n 0.4657 80249.9n 0.4657 80250.0n 0.4393 80499.9n 0.4393 80500.0n 0.4393 80749.9n 0.4393 80750.0n 0.4393 80999.9n 0.4393 81000.0n 0.4393 81249.9n 0.4393 81250.0n 0.4393 81499.9n 0.4393 81500.0n 0.4393 81749.9n 0.4393 81750.0n 0.4393 81999.9n 0.4393 82000.0n 0.4657 82249.9n 0.4657 82250.0n 0.4393 82499.9n 0.4393 82500.0n 0.4393 82749.9n 0.4393 82750.0n 0.4393 82999.9n 0.4393 83000.0n 0.4393 83249.9n 0.4393 83250.0n 0.4393 83499.9n 0.4393 83500.0n 0.4393 83749.9n 0.4393 83750.0n 0.4393 83999.9n 0.4393 84000.0n 0.4393 84249.9n 0.4393 84250.0n 0.4393 84499.9n 0.4393 84500.0n 0.4393 84749.9n 0.4393 84750.0n 0.4393 84999.9n 0.4393 85000.0n 0.4393 85249.9n 0.4393 85250.0n 0.5184 85499.9n 0.5184 85500.0n 0.4393 85749.9n 0.4393 85750.0n 0.4393 85999.9n 0.4393 86000.0n 0.4393 86249.9n 0.4393 86250.0n 0.4393 86499.9n 0.4393 86500.0n 0.4393 86749.9n 0.4393 86750.0n 0.4393 86999.9n 0.4393 87000.0n 0.4393 87249.9n 0.4393 87250.0n 0.4393 87499.9n 0.4393 87500.0n 0.4657 87749.9n 0.4657 87750.0n 0.4393 87999.9n 0.4393 88000.0n 0.4393 88249.9n 0.4393 88250.0n 0.4393 88499.9n 0.4393 88500.0n 0.4393 88749.9n 0.4393 88750.0n 0.4393 88999.9n 0.4393 89000.0n 0.4393 89249.9n 0.4393 89250.0n 0.4393 89499.9n 0.4393 89500.0n 0.4657 89749.9n 0.4657 89750.0n 0.4393 89999.9n 0.4393 90000.0n 0.4393 90249.9n 0.4393 90250.0n 0.4393 90499.9n 0.4393 90500.0n 0.4393 90749.9n 0.4393 90750.0n 0.4393 90999.9n 0.4393 91000.0n 0.4393 91249.9n 0.4393 91250.0n 0.4393 91499.9n 0.4393 91500.0n 0.4393 91749.9n 0.4393 91750.0n 0.4393 91999.9n 0.4393 92000.0n 0.4393 92249.9n 0.4393 92250.0n 0.4393 92499.9n 0.4393 92500.0n 0.4393 92749.9n 0.4393 92750.0n 0.5184 92999.9n 0.5184 93000.0n 0.4393 93249.9n 0.4393 93250.0n 0.4393 93499.9n 0.4393 93500.0n 0.4393 93749.9n 0.4393 93750.0n 0.4393 93999.9n 0.4393 94000.0n 0.4393 94249.9n 0.4393 94250.0n 0.4393 94499.9n 0.4393 94500.0n 0.4393 94749.9n 0.4393 94750.0n 0.4393 94999.9n 0.4393 95000.0n 0.4657 95249.9n 0.4657 95250.0n 0.4393 95499.9n 0.4393 95500.0n 0.4393 95749.9n 0.4393 95750.0n 0.4393 95999.9n 0.4393 96000.0n 0.4393 96249.9n 0.4393 96250.0n 0.4393 96499.9n 0.4393 96500.0n 0.4393 96749.9n 0.4393 96750.0n 0.4393 96999.9n 0.4393 97000.0n 0.4657 97249.9n 0.4657 97250.0n 0.4393 97499.9n 0.4393 97500.0n 0.4393 97749.9n 0.4393 97750.0n 0.4393 97999.9n 0.4393 98000.0n 0.4393 98249.9n 0.4393 98250.0n 0.4393 98499.9n 0.4393 98500.0n 0.4393 98749.9n 0.4393 98750.0n 0.4393 98999.9n 0.4393 99000.0n 0.4393 99249.9n 0.4393 99250.0n 0.4393 99499.9n 0.4393 99500.0n 0.4393 99749.9n 0.4393 99750.0n 0.4393 99999.9n 0.4393 100000.0n 0.4393 100249.9n 0.4393 100250.0n 0.5184 100499.9n 0.5184 100500.0n 0.4393 100749.9n 0.4393 100750.0n 0.4393 100999.9n 0.4393 101000.0n 0.4393 101249.9n 0.4393 101250.0n 0.4393 101499.9n 0.4393 101500.0n 0.4393 101749.9n 0.4393 101750.0n 0.4393 101999.9n 0.4393 102000.0n 0.4393 102249.9n 0.4393 102250.0n 0.4393 102499.9n 0.4393 102500.0n 0.4657 102749.9n 0.4657 102750.0n 0.4393 102999.9n 0.4393 103000.0n 0.4393 103249.9n 0.4393 103250.0n 0.4393 103499.9n 0.4393 103500.0n 0.4393 103749.9n 0.4393 103750.0n 0.4393 103999.9n 0.4393 104000.0n 0.4393 104249.9n 0.4393 104250.0n 0.4393 104499.9n 0.4393 104500.0n 0.4657 104749.9n 0.4657 104750.0n 0.4393 104999.9n 0.4393 105000.0n 0.4393 105249.9n 0.4393 105250.0n 0.4393 105499.9n 0.4393 105500.0n 0.4393 105749.9n 0.4393 105750.0n 0.4393 105999.9n 0.4393 106000.0n 0.4393 106249.9n 0.4393 106250.0n 0.4393 106499.9n 0.4393 106500.0n 0.4393 106749.9n 0.4393 106750.0n 0.4393 106999.9n 0.4393 107000.0n 0.4393 107249.9n 0.4393 107250.0n 0.4393 107499.9n 0.4393 107500.0n 0.4393 107749.9n 0.4393 107750.0n 0.5184 107999.9n 0.5184 108000.0n 0.4393 108249.9n 0.4393 108250.0n 0.4393 108499.9n 0.4393 108500.0n 0.4393 108749.9n 0.4393 108750.0n 0.4393 108999.9n 0.4393 109000.0n 0.4393 109249.9n 0.4393 109250.0n 0.4393 109499.9n 0.4393 109500.0n 0.4393 109749.9n 0.4393 109750.0n 0.4393 109999.9n 0.4393 110000.0n 0.4657 110249.9n 0.4657 110250.0n 0.4393 110499.9n 0.4393 110500.0n 0.4393 110749.9n 0.4393 110750.0n 0.4393 110999.9n 0.4393 111000.0n 0.4393 111249.9n 0.4393 111250.0n 0.4393 111499.9n 0.4393 111500.0n 0.4393 111749.9n 0.4393 111750.0n 0.4393 111999.9n 0.4393 112000.0n 0.4657 112249.9n 0.4657 112250.0n 0.4393 112499.9n 0.4393 112500.0n 0.4393 112749.9n 0.4393 112750.0n 0.4393 112999.9n 0.4393 113000.0n 0.4393 113249.9n 0.4393 113250.0n 0.4393 113499.9n 0.4393 113500.0n 0.4393 113749.9n 0.4393 113750.0n 0.4393 113999.9n 0.4393 114000.0n 0.4393 114249.9n 0.4393 114250.0n 0.4393 114499.9n 0.4393 114500.0n 0.4393 114749.9n 0.4393 114750.0n 0.4393 114999.9n 0.4393 115000.0n 0.4393 115249.9n 0.4393 115250.0n 0.5184 115499.9n 0.5184 115500.0n 0.4393 115749.9n 0.4393 115750.0n 0.4393 115999.9n 0.4393 116000.0n 0.4393 116249.9n 0.4393 116250.0n 0.4393 116499.9n 0.4393 116500.0n 0.4393 116749.9n 0.4393 116750.0n 0.4393 116999.9n 0.4393 117000.0n 0.4393 117249.9n 0.4393 117250.0n 0.4393 117499.9n 0.4393 117500.0n 0.4657 117749.9n 0.4657 117750.0n 0.4393 117999.9n 0.4393 118000.0n 0.4393 118249.9n 0.4393 118250.0n 0.4393 118499.9n 0.4393 118500.0n 0.4393 118749.9n 0.4393 118750.0n 0.4393 118999.9n 0.4393 119000.0n 0.4393 119249.9n 0.4393 119250.0n 0.4393 119499.9n 0.4393 119500.0n 0.4657 119749.9n 0.4657 119750.0n 0.4393 119999.9n 0.4393 120000.0n 0.4393 120249.9n 0.4393 120250.0n 0.4393 120499.9n 0.4393 120500.0n 0.4393 120749.9n 0.4393 120750.0n 0.4393 120999.9n 0.4393 121000.0n 0.4393 121249.9n 0.4393 121250.0n 0.4393 121499.9n 0.4393 121500.0n 0.4393 121749.9n 0.4393 121750.0n 0.4393 121999.9n 0.4393 122000.0n 0.4393 122249.9n 0.4393 122250.0n 0.4393 122499.9n 0.4393 122500.0n 0.4393 122749.9n 0.4393 122750.0n 0.5184 122999.9n 0.5184 123000.0n 0.4393 123249.9n 0.4393 123250.0n 0.4393 123499.9n 0.4393 123500.0n 0.4393 123749.9n 0.4393 123750.0n 0.4393 123999.9n 0.4393 124000.0n 0.4393 124249.9n 0.4393 124250.0n 0.4393 124499.9n 0.4393 124500.0n 0.4393 124749.9n 0.4393 124750.0n 0.4393 124999.9n 0.4393 125000.0n 0.4657 125249.9n 0.4657 125250.0n 0.4393 125499.9n 0.4393 125500.0n 0.4393 125749.9n 0.4393 125750.0n 0.4393 125999.9n 0.4393 126000.0n 0.4393 126249.9n 0.4393 126250.0n 0.4393 126499.9n 0.4393 126500.0n 0.4393 126749.9n 0.4393 126750.0n 0.4393 126999.9n 0.4393 127000.0n 0.4657 127249.9n 0.4657 127250.0n 0.4393 127499.9n 0.4393 127500.0n 0.4393 127749.9n 0.4393 127750.0n 0.4393 127999.9n 0.4393 128000.0n 0.4393 128249.9n 0.4393 128250.0n 0.4393 128499.9n 0.4393 128500.0n 0.4393 128749.9n 0.4393 128750.0n 0.4393 128999.9n 0.4393 129000.0n 0.4393 129249.9n 0.4393 129250.0n 0.4393 129499.9n 0.4393 129500.0n 0.4393 129749.9n 0.4393 129750.0n 0.4393 129999.9n 0.4393 130000.0n 0.4393 130249.9n 0.4393 130250.0n 0.5184 130499.9n 0.5184 130500.0n 0.4393 130749.9n 0.4393 130750.0n 0.4393 130999.9n 0.4393 131000.0n 0.4393 131249.9n 0.4393 131250.0n 0.4393 131499.9n 0.4393 131500.0n 0.4393 131749.9n 0.4393 131750.0n 0.4393 131999.9n 0.4393 132000.0n 0.4393 132249.9n 0.4393 132250.0n 0.4393 132499.9n 0.4393 132500.0n 0.4657 132749.9n 0.4657 132750.0n 0.4393 132999.9n 0.4393 133000.0n 0.4393 133249.9n 0.4393 133250.0n 0.4393 133499.9n 0.4393 133500.0n 0.4393 133749.9n 0.4393 133750.0n 0.4393 133999.9n 0.4393 134000.0n 0.4393 134249.9n 0.4393 134250.0n 0.4393 134499.9n 0.4393 134500.0n 0.4657 134749.9n 0.4657 134750.0n 0.4393 134999.9n 0.4393 135000.0n 0.4393 135249.9n 0.4393 135250.0n 0.4393 135499.9n 0.4393 135500.0n 0.4393 135749.9n 0.4393 135750.0n 0.4393 135999.9n 0.4393 136000.0n 0.4393 136249.9n 0.4393 136250.0n 0.4393 136499.9n 0.4393 136500.0n 0.4393 136749.9n 0.4393 136750.0n 0.4393 136999.9n 0.4393 137000.0n 0.4393 137249.9n 0.4393 137250.0n 0.4393 137499.9n 0.4393 137500.0n 0.4393 137749.9n 0.4393 137750.0n 0.5184 137999.9n 0.5184 138000.0n 0.4393 138249.9n 0.4393 138250.0n 0.4393 138499.9n 0.4393 138500.0n 0.4393 138749.9n 0.4393 138750.0n 0.4393 138999.9n 0.4393 139000.0n 0.4393 139249.9n 0.4393 139250.0n 0.4393 139499.9n 0.4393 139500.0n 0.4393 139749.9n 0.4393 139750.0n 0.4393 139999.9n 0.4393 140000.0n 0.4657 140249.9n 0.4657 140250.0n 0.4393 140499.9n 0.4393 140500.0n 0.4393 140749.9n 0.4393 140750.0n 0.4393 140999.9n 0.4393 141000.0n 0.4393 141249.9n 0.4393 141250.0n 0.4393 141499.9n 0.4393 141500.0n 0.4393 141749.9n 0.4393 141750.0n 0.4393 141999.9n 0.4393 142000.0n 0.4657 142249.9n 0.4657 142250.0n 0.4393 142499.9n 0.4393 142500.0n 0.4393 142749.9n 0.4393 142750.0n 0.4393 142999.9n 0.4393 143000.0n 0.4393 143249.9n 0.4393 143250.0n 0.4393 143499.9n 0.4393 143500.0n 0.4393 143749.9n 0.4393 143750.0n 0.4393 143999.9n 0.4393 144000.0n 0.4393 144249.9n 0.4393 144250.0n 0.4393 144499.9n 0.4393 144500.0n 0.4393 144749.9n 0.4393 144750.0n 0.4393 144999.9n 0.4393 145000.0n 0.4393 145249.9n 0.4393 145250.0n 0.5184 145499.9n 0.5184 145500.0n 0.4393 145749.9n 0.4393 145750.0n 0.4393 145999.9n 0.4393 146000.0n 0.4393 146249.9n 0.4393 146250.0n 0.4393 146499.9n 0.4393 146500.0n 0.4393 146749.9n 0.4393 146750.0n 0.4393 146999.9n 0.4393 147000.0n 0.4393 147249.9n 0.4393 147250.0n 0.4393 147499.9n 0.4393 147500.0n 0.4657 147749.9n 0.4657 147750.0n 0.4393 147999.9n 0.4393 148000.0n 0.4393 148249.9n 0.4393 148250.0n 0.4393 148499.9n 0.4393 148500.0n 0.4393 148749.9n 0.4393 148750.0n 0.4393 148999.9n 0.4393 149000.0n 0.4393 149249.9n 0.4393 149250.0n 0.4393 149499.9n 0.4393 149500.0n 0.4657 149749.9n 0.4657 149750.0n 0.4393 149999.9n 0.4393 150000.0n 0.4393 150249.9n 0.4393 150250.0n 0.4393 150499.9n 0.4393 150500.0n 0.4393 150749.9n 0.4393 150750.0n 0.4393 150999.9n 0.4393 151000.0n 0.4393 151249.9n 0.4393 151250.0n 0.4393 151499.9n 0.4393 151500.0n 0.4393 151749.9n 0.4393 151750.0n 0.4393 151999.9n 0.4393 152000.0n 0.4393 152249.9n 0.4393 152250.0n 0.4393 152499.9n 0.4393 152500.0n 0.4393 152749.9n 0.4393 152750.0n 0.5184 152999.9n 0.5184 153000.0n 0.4393 153249.9n 0.4393 153250.0n 0.4393 153499.9n 0.4393 153500.0n 0.4393 153749.9n 0.4393 153750.0n 0.4393 153999.9n 0.4393 154000.0n 0.4393 154249.9n 0.4393 154250.0n 0.4393 154499.9n 0.4393 154500.0n 0.4393 154749.9n 0.4393 154750.0n 0.4393 154999.9n 0.4393 155000.0n 0.4657 155249.9n 0.4657 155250.0n 0.4393 155499.9n 0.4393 155500.0n 0.4393 155749.9n 0.4393 155750.0n 0.4393 155999.9n 0.4393 156000.0n 0.4393 156249.9n 0.4393 156250.0n 0.4393 156499.9n 0.4393 156500.0n 0.4393 156749.9n 0.4393 156750.0n 0.4393 156999.9n 0.4393 157000.0n 0.4657 157249.9n 0.4657 157250.0n 0.4393 157499.9n 0.4393 157500.0n 0.4393 157749.9n 0.4393 157750.0n 0.4393 157999.9n 0.4393 158000.0n 0.4393 158249.9n 0.4393 158250.0n 0.4393 158499.9n 0.4393 158500.0n 0.4393 158749.9n 0.4393 158750.0n 0.4393 158999.9n 0.4393 159000.0n 0.4393 159249.9n 0.4393 159250.0n 0.4393 159499.9n 0.4393 159500.0n 0.4393 159749.9n 0.4393 159750.0n 0.4393 159999.9n 0.4393 160000.0n 0.4393 160249.9n 0.4393 160250.0n 0.5184 160499.9n 0.5184 160500.0n 0.4393 160749.9n 0.4393 160750.0n 0.4393 160999.9n 0.4393 161000.0n 0.4393 161249.9n 0.4393 161250.0n 0.4393 161499.9n 0.4393 161500.0n 0.4393 161749.9n 0.4393 161750.0n 0.4393 161999.9n 0.4393 162000.0n 0.4393 162249.9n 0.4393 162250.0n 0.4393 162499.9n 0.4393 162500.0n 0.4657 162749.9n 0.4657 162750.0n 0.4393 162999.9n 0.4393 163000.0n 0.4393 163249.9n 0.4393 163250.0n 0.4393 163499.9n 0.4393 163500.0n 0.4393 163749.9n 0.4393 163750.0n 0.4393 163999.9n 0.4393 164000.0n 0.4393 164249.9n 0.4393 164250.0n 0.4393 164499.9n 0.4393 164500.0n 0.4657 164749.9n 0.4657 164750.0n 0.4393 164999.9n 0.4393 165000.0n 0.4393 165249.9n 0.4393 165250.0n 0.4393 165499.9n 0.4393 165500.0n 0.4393 165749.9n 0.4393 165750.0n 0.4393 165999.9n 0.4393 166000.0n 0.4393 166249.9n 0.4393 166250.0n 0.4393 166499.9n 0.4393 166500.0n 0.4393 166749.9n 0.4393 166750.0n 0.4393 166999.9n 0.4393 167000.0n 0.4393 167249.9n 0.4393 167250.0n 0.4393 167499.9n 0.4393 167500.0n 0.4393 167749.9n 0.4393 167750.0n 0.5184 167999.9n 0.5184 168000.0n 0.4393 168249.9n 0.4393 168250.0n 0.4393 168499.9n 0.4393 168500.0n 0.4393 168749.9n 0.4393 168750.0n 0.4393 168999.9n 0.4393 169000.0n 0.4393 169249.9n 0.4393 169250.0n 0.4393 169499.9n 0.4393 169500.0n 0.4393 169749.9n 0.4393 169750.0n 0.4393 169999.9n 0.4393 170000.0n 0.4657 170249.9n 0.4657 170250.0n 0.4393 170499.9n 0.4393 170500.0n 0.4393 170749.9n 0.4393 170750.0n 0.4393 170999.9n 0.4393 171000.0n 0.4393 171249.9n 0.4393 171250.0n 0.4393 171499.9n 0.4393 171500.0n 0.4393 171749.9n 0.4393 171750.0n 0.4393 171999.9n 0.4393 172000.0n 0.4657 172249.9n 0.4657 172250.0n 0.4393 172499.9n 0.4393 172500.0n 0.4393 172749.9n 0.4393 172750.0n 0.4393 172999.9n 0.4393 173000.0n 0.4393 173249.9n 0.4393 173250.0n 0.4393 173499.9n 0.4393 173500.0n 0.4393 173749.9n 0.4393 173750.0n 0.4393 173999.9n 0.4393 174000.0n 0.4393 174249.9n 0.4393 174250.0n 0.4393 174499.9n 0.4393 174500.0n 0.4393 174749.9n 0.4393 174750.0n 0.4393 174999.9n 0.4393 175000.0n 0.4393 175249.9n 0.4393 175250.0n 0.5184 175499.9n 0.5184 175500.0n 0.4393 175749.9n 0.4393 175750.0n 0.4393 175999.9n 0.4393 176000.0n 0.4393 176249.9n 0.4393 176250.0n 0.4393 176499.9n 0.4393 176500.0n 0.4393 176749.9n 0.4393 176750.0n 0.4393 176999.9n 0.4393 177000.0n 0.4393 177249.9n 0.4393 177250.0n 0.4393 177499.9n 0.4393 177500.0n 0.4657 177749.9n 0.4657 177750.0n 0.4393 177999.9n 0.4393 178000.0n 0.4393 178249.9n 0.4393 178250.0n 0.4393 178499.9n 0.4393 178500.0n 0.4393 178749.9n 0.4393 178750.0n 0.4393 178999.9n 0.4393 179000.0n 0.4393 179249.9n 0.4393 179250.0n 0.4393 179499.9n 0.4393 179500.0n 0.4657 179749.9n 0.4657 179750.0n 0.4393 179999.9n 0.4393 180000.0n 0.4393 180249.9n 0.4393 180250.0n 0.4393 180499.9n 0.4393 180500.0n 0.4393 180749.9n 0.4393 180750.0n 0.4393 180999.9n 0.4393 181000.0n 0.4393 181249.9n 0.4393 181250.0n 0.4393 181499.9n 0.4393 181500.0n 0.4393 181749.9n 0.4393 181750.0n 0.4393 181999.9n 0.4393 182000.0n 0.4393 182249.9n 0.4393 182250.0n 0.4393 182499.9n 0.4393 182500.0n 0.4393 182749.9n 0.4393 182750.0n 0.5184 182999.9n 0.5184 183000.0n 0.4393 183249.9n 0.4393 183250.0n 0.4393 183499.9n 0.4393 183500.0n 0.4393 183749.9n 0.4393 183750.0n 0.4393 183999.9n 0.4393 184000.0n 0.4393 184249.9n 0.4393 184250.0n 0.4393 184499.9n 0.4393 184500.0n 0.4393 184749.9n 0.4393 184750.0n 0.4393 184999.9n 0.4393 185000.0n 0.4657 185249.9n 0.4657 185250.0n 0.4393 185499.9n 0.4393 185500.0n 0.4393 185749.9n 0.4393 185750.0n 0.4393 185999.9n 0.4393 186000.0n 0.4393 186249.9n 0.4393 186250.0n 0.4393 186499.9n 0.4393 186500.0n 0.4393 186749.9n 0.4393 186750.0n 0.4393 186999.9n 0.4393 187000.0n 0.4657 187249.9n 0.4657 187250.0n 0.4393 187499.9n 0.4393 187500.0n 0.4393 187749.9n 0.4393 187750.0n 0.4393 187999.9n 0.4393 188000.0n 0.4393 188249.9n 0.4393 188250.0n 0.4393 188499.9n 0.4393 188500.0n 0.4393 188749.9n 0.4393 188750.0n 0.4393 188999.9n 0.4393 189000.0n 0.4393 189249.9n 0.4393 189250.0n 0.4393 189499.9n 0.4393 189500.0n 0.4393 189749.9n 0.4393 189750.0n 0.4393 189999.9n 0.4393 190000.0n 0.4393 190249.9n 0.4393 190250.0n 0.5184 190499.9n 0.5184 190500.0n 0.4393 190749.9n 0.4393 190750.0n 0.4393 190999.9n 0.4393 191000.0n 0.4393 191249.9n 0.4393 191250.0n 0.4393 191499.9n 0.4393 191500.0n 0.4393 191749.9n 0.4393 191750.0n 0.4393 191999.9n 0.4393 192000.0n 0.4393 192249.9n 0.4393 192250.0n 0.4393 192499.9n 0.4393 192500.0n 0.4657 192749.9n 0.4657 192750.0n 0.4393 192999.9n 0.4393 193000.0n 0.4393 193249.9n 0.4393 193250.0n 0.4393 193499.9n 0.4393 193500.0n 0.4393 193749.9n 0.4393 193750.0n 0.4393 193999.9n 0.4393 194000.0n 0.4393 194249.9n 0.4393 194250.0n 0.4393 194499.9n 0.4393 194500.0n 0.4657 194749.9n 0.4657 194750.0n 0.4393 194999.9n 0.4393 195000.0n 0.4393 195249.9n 0.4393 195250.0n 0.4393 195499.9n 0.4393 195500.0n 0.4393 195749.9n 0.4393 195750.0n 0.4393 195999.9n 0.4393 196000.0n 0.4393 196249.9n 0.4393 196250.0n 0.4393 196499.9n 0.4393 196500.0n 0.4393 196749.9n 0.4393 196750.0n 0.4393 196999.9n 0.4393 197000.0n 0.4393 197249.9n 0.4393 197250.0n 0.4393 197499.9n 0.4393 197500.0n 0.4393 197749.9n 0.4393 197750.0n 0.5184 197999.9n 0.5184 198000.0n 0.4393 198249.9n 0.4393 198250.0n 0.4393 198499.9n 0.4393 198500.0n 0.4393 198749.9n 0.4393 198750.0n 0.4393 198999.9n 0.4393 199000.0n 0.4393 199249.9n 0.4393 199250.0n 0.4393 199499.9n 0.4393 199500.0n 0.4393 199749.9n 0.4393 199750.0n 0.4393 199999.9n 0.4393 200000.0n 0.4657 200249.9n 0.4657 200250.0n 0.4393 200499.9n 0.4393 200500.0n 0.4393 200749.9n 0.4393 200750.0n 0.4393 200999.9n 0.4393 201000.0n 0.4393 201249.9n 0.4393 201250.0n 0.4393 201499.9n 0.4393 201500.0n 0.4393 201749.9n 0.4393 201750.0n 0.4393 201999.9n 0.4393 202000.0n 0.4657 202249.9n 0.4657 202250.0n 0.4393 202499.9n 0.4393 202500.0n 0.4393 202749.9n 0.4393 202750.0n 0.4393 202999.9n 0.4393 203000.0n 0.4393 203249.9n 0.4393 203250.0n 0.4393 203499.9n 0.4393 203500.0n 0.4393 203749.9n 0.4393 203750.0n 0.4393 203999.9n 0.4393 204000.0n 0.4393 204249.9n 0.4393 204250.0n 0.4393 204499.9n 0.4393 204500.0n 0.4393 204749.9n 0.4393 204750.0n 0.4393 204999.9n 0.4393 205000.0n 0.4393 205249.9n 0.4393 205250.0n 0.5184 205499.9n 0.5184 205500.0n 0.4393 205749.9n 0.4393 205750.0n 0.4393 205999.9n 0.4393 206000.0n 0.4393 206249.9n 0.4393 206250.0n 0.4393 206499.9n 0.4393 206500.0n 0.4393 206749.9n 0.4393 206750.0n 0.4393 206999.9n 0.4393 207000.0n 0.4393 207249.9n 0.4393 207250.0n 0.4393 207499.9n 0.4393 207500.0n 0.4657 207749.9n 0.4657 207750.0n 0.4393 207999.9n 0.4393 208000.0n 0.4393 208249.9n 0.4393 208250.0n 0.4393 208499.9n 0.4393 208500.0n 0.4393 208749.9n 0.4393 208750.0n 0.4393 208999.9n 0.4393 209000.0n 0.4393 209249.9n 0.4393 209250.0n 0.4393 209499.9n 0.4393 209500.0n 0.4657 209749.9n 0.4657 209750.0n 0.4393 209999.9n 0.4393 210000.0n 0.4393 210249.9n 0.4393 210250.0n 0.4393 210499.9n 0.4393 210500.0n 0.4393 210749.9n 0.4393 210750.0n 0.4393 210999.9n 0.4393 211000.0n 0.4393 211249.9n 0.4393 211250.0n 0.4393 211499.9n 0.4393 211500.0n 0.4393 211749.9n 0.4393 211750.0n 0.4393 211999.9n 0.4393 212000.0n 0.4393 212249.9n 0.4393 212250.0n 0.4393 212499.9n 0.4393 212500.0n 0.4393 212749.9n 0.4393 212750.0n 0.5184 212999.9n 0.5184 213000.0n 0.4393 213249.9n 0.4393 213250.0n 0.4393 213499.9n 0.4393 213500.0n 0.4393 213749.9n 0.4393 213750.0n 0.4393 213999.9n 0.4393 214000.0n 0.4393 214249.9n 0.4393 214250.0n 0.4393 214499.9n 0.4393 214500.0n 0.4393 214749.9n 0.4393 214750.0n 0.4393 214999.9n 0.4393 215000.0n 0.4657 215249.9n 0.4657 215250.0n 0.4393 215499.9n 0.4393 215500.0n 0.4393 215749.9n 0.4393 215750.0n 0.4393 215999.9n 0.4393 216000.0n 0.4393 216249.9n 0.4393 216250.0n 0.4393 216499.9n 0.4393 216500.0n 0.4393 216749.9n 0.4393 216750.0n 0.4393 216999.9n 0.4393 217000.0n 0.4657 217249.9n 0.4657 217250.0n 0.4393 217499.9n 0.4393 217500.0n 0.4393 217749.9n 0.4393 217750.0n 0.4393 217999.9n 0.4393 218000.0n 0.4393 218249.9n 0.4393 218250.0n 0.4393 218499.9n 0.4393 218500.0n 0.4393 218749.9n 0.4393 218750.0n 0.4393 218999.9n 0.4393 219000.0n 0.4393 219249.9n 0.4393 219250.0n 0.4393 219499.9n 0.4393 219500.0n 0.4393 219749.9n 0.4393 219750.0n 0.4393 219999.9n 0.4393 220000.0n 0.4393 220249.9n 0.4393 220250.0n 0.5184 220499.9n 0.5184 220500.0n 0.4393 220749.9n 0.4393 220750.0n 0.4393 220999.9n 0.4393 221000.0n 0.4393 221249.9n 0.4393 221250.0n 0.4393 221499.9n 0.4393 221500.0n 0.4393 221749.9n 0.4393 221750.0n 0.4393 221999.9n 0.4393 222000.0n 0.4393 222249.9n 0.4393 222250.0n 0.4393 222499.9n 0.4393 222500.0n 0.4657 222749.9n 0.4657 222750.0n 0.4393 222999.9n 0.4393 223000.0n 0.4393 223249.9n 0.4393 223250.0n 0.4393 223499.9n 0.4393 223500.0n 0.4393 223749.9n 0.4393 223750.0n 0.4393 223999.9n 0.4393 224000.0n 0.4393 224249.9n 0.4393 224250.0n 0.4393 224499.9n 0.4393 224500.0n 0.4657 224749.9n 0.4657 224750.0n 0.4393 224999.9n 0.4393 225000.0n 0.4393 225249.9n 0.4393 225250.0n 0.4393 225499.9n 0.4393 225500.0n 0.4393 225749.9n 0.4393 225750.0n 0.4393 225999.9n 0.4393 226000.0n 0.4393 226249.9n 0.4393 226250.0n 0.4393 226499.9n 0.4393 226500.0n 0.4393 226749.9n 0.4393 226750.0n 0.4393 226999.9n 0.4393 227000.0n 0.4393 227249.9n 0.4393 227250.0n 0.4393 227499.9n 0.4393 227500.0n 0.4393 227749.9n 0.4393 227750.0n 0.5184 227999.9n 0.5184 228000.0n 0.4393 228249.9n 0.4393 228250.0n 0.4393 228499.9n 0.4393 228500.0n 0.4393 228749.9n 0.4393 228750.0n 0.4393 228999.9n 0.4393 229000.0n 0.4393 229249.9n 0.4393 229250.0n 0.4393 229499.9n 0.4393 229500.0n 0.4393 229749.9n 0.4393 229750.0n 0.4393 229999.9n 0.4393 230000.0n 0.4657 230249.9n 0.4657 230250.0n 0.4393 230499.9n 0.4393 230500.0n 0.4393 230749.9n 0.4393 230750.0n 0.4393 230999.9n 0.4393 231000.0n 0.4393 231249.9n 0.4393 231250.0n 0.4393 231499.9n 0.4393 231500.0n 0.4393 231749.9n 0.4393 231750.0n 0.4393 231999.9n 0.4393 232000.0n 0.4657 232249.9n 0.4657 232250.0n 0.4393 232499.9n 0.4393 232500.0n 0.4393 232749.9n 0.4393 232750.0n 0.4393 232999.9n 0.4393 233000.0n 0.4393 233249.9n 0.4393 233250.0n 0.4393 233499.9n 0.4393 233500.0n 0.4393 233749.9n 0.4393 233750.0n 0.4393 233999.9n 0.4393 234000.0n 0.4393 234249.9n 0.4393 234250.0n 0.4393 234499.9n 0.4393 234500.0n 0.4393 234749.9n 0.4393 234750.0n 0.4393 234999.9n 0.4393 235000.0n 0.4393 235249.9n 0.4393 235250.0n 0.5184 235499.9n 0.5184 235500.0n 0.4393 235749.9n 0.4393 235750.0n 0.4393 235999.9n 0.4393 236000.0n 0.4393 236249.9n 0.4393 236250.0n 0.4393 236499.9n 0.4393 236500.0n 0.4393 236749.9n 0.4393 236750.0n 0.4393 236999.9n 0.4393 237000.0n 0.4393 237249.9n 0.4393 237250.0n 0.4393 237499.9n 0.4393 237500.0n 0.4657 237749.9n 0.4657 237750.0n 0.4393 237999.9n 0.4393 238000.0n 0.4393 238249.9n 0.4393 238250.0n 0.4393 238499.9n 0.4393 238500.0n 0.4393 238749.9n 0.4393 238750.0n 0.4393 238999.9n 0.4393 239000.0n 0.4393 239249.9n 0.4393 239250.0n 0.4393 239499.9n 0.4393 239500.0n 0.4657 239749.9n 0.4657 239750.0n 0.4393 239999.9n 0.4393 240000.0n 0.4393 240249.9n 0.4393 240250.0n 0.4393 240499.9n 0.4393 240500.0n 0.4393 240749.9n 0.4393 240750.0n 0.4393 240999.9n 0.4393 241000.0n 0.4393 241249.9n 0.4393 241250.0n 0.4393 241499.9n 0.4393 241500.0n 0.4393 241749.9n 0.4393 241750.0n 0.4393 241999.9n 0.4393 242000.0n 0.4393 242249.9n 0.4393 242250.0n 0.4393 242499.9n 0.4393 242500.0n 0.4393 242749.9n 0.4393 242750.0n 0.5184 242999.9n 0.5184 243000.0n 0.4393 243249.9n 0.4393 243250.0n 0.4393 243499.9n 0.4393 243500.0n 0.4393 243749.9n 0.4393 243750.0n 0.4393 243999.9n 0.4393 244000.0n 0.4393 244249.9n 0.4393 244250.0n 0.4393 244499.9n 0.4393 244500.0n 0.4393 244749.9n 0.4393 244750.0n 0.4393 244999.9n 0.4393 245000.0n 0.4657 245249.9n 0.4657 245250.0n 0.4393 245499.9n 0.4393 245500.0n 0.4393 245749.9n 0.4393 245750.0n 0.4393 245999.9n 0.4393 246000.0n 0.4393 246249.9n 0.4393 246250.0n 0.4393 246499.9n 0.4393 246500.0n 0.4393 246749.9n 0.4393 246750.0n 0.4393 246999.9n 0.4393 247000.0n 0.4657 247249.9n 0.4657 247250.0n 0.4393 247499.9n 0.4393 247500.0n 0.4393 247749.9n 0.4393 247750.0n 0.4393 247999.9n 0.4393 248000.0n 0.4393 248249.9n 0.4393 248250.0n 0.4393 248499.9n 0.4393 248500.0n 0.4393 248749.9n 0.4393 248750.0n 0.4393 248999.9n 0.4393 249000.0n 0.4393 249249.9n 0.4393 249250.0n 0.4393 249499.9n 0.4393 249500.0n 0.4393 249749.9n 0.4393 249750.0n 0.4393 249999.9n 0.4393 250000.0n 0.4393 250249.9n 0.4393 250250.0n 0.5184 250499.9n 0.5184 250500.0n 0.4393 250749.9n 0.4393 250750.0n 0.4393 250999.9n 0.4393 251000.0n 0.4393 251249.9n 0.4393 251250.0n 0.4393 251499.9n 0.4393 251500.0n 0.4393 251749.9n 0.4393 251750.0n 0.4393 251999.9n 0.4393 252000.0n 0.4393 252249.9n 0.4393 252250.0n 0.4393 252499.9n 0.4393 252500.0n 0.4657 252749.9n 0.4657 252750.0n 0.4393 252999.9n 0.4393 253000.0n 0.4393 253249.9n 0.4393 253250.0n 0.4393 253499.9n 0.4393 253500.0n 0.4393 253749.9n 0.4393 253750.0n 0.4393 253999.9n 0.4393 254000.0n 0.4393 254249.9n 0.4393 254250.0n 0.4393 254499.9n 0.4393 254500.0n 0.4657 254749.9n 0.4657 254750.0n 0.4393 254999.9n 0.4393 255000.0n 0.4393 255249.9n 0.4393 255250.0n 0.4393 255499.9n 0.4393 255500.0n 0.4393 255749.9n 0.4393 255750.0n 0.4393 255999.9n 0.4393 256000.0n 0.4393 256249.9n 0.4393 256250.0n 0.4393 256499.9n 0.4393 256500.0n 0.4393 256749.9n 0.4393 256750.0n 0.4393 256999.9n 0.4393 257000.0n 0.4393 257249.9n 0.4393 257250.0n 0.4393 257499.9n 0.4393 257500.0n 0.4393 257749.9n 0.4393 257750.0n 0.5184 257999.9n 0.5184 258000.0n 0.4393 258249.9n 0.4393 258250.0n 0.4393 258499.9n 0.4393 258500.0n 0.4393 258749.9n 0.4393 258750.0n 0.4393 258999.9n 0.4393 259000.0n 0.4393 259249.9n 0.4393 259250.0n 0.4393 259499.9n 0.4393 259500.0n 0.4393 259749.9n 0.4393 259750.0n 0.4393 259999.9n 0.4393 260000.0n 0.4657 260249.9n 0.4657 260250.0n 0.4393 260499.9n 0.4393 260500.0n 0.4393 260749.9n 0.4393 260750.0n 0.4393 260999.9n 0.4393 261000.0n 0.4393 261249.9n 0.4393 261250.0n 0.4393 261499.9n 0.4393 261500.0n 0.4393 261749.9n 0.4393 261750.0n 0.4393 261999.9n 0.4393 262000.0n 0.4657 262249.9n 0.4657 262250.0n 0.4393 262499.9n 0.4393 262500.0n 0.4393 262749.9n 0.4393 262750.0n 0.4393 262999.9n 0.4393 263000.0n 0.4393 263249.9n 0.4393 263250.0n 0.4393 263499.9n 0.4393 263500.0n 0.4393 263749.9n 0.4393 263750.0n 0.4393 263999.9n 0.4393 264000.0n 0.4393 264249.9n 0.4393 264250.0n 0.4393 264499.9n 0.4393 264500.0n 0.4393 264749.9n 0.4393 264750.0n 0.4393 264999.9n 0.4393 265000.0n 0.4393 265249.9n 0.4393 265250.0n 0.5184 265499.9n 0.5184 265500.0n 0.4393 265749.9n 0.4393 265750.0n 0.4393 265999.9n 0.4393 266000.0n 0.4393 266249.9n 0.4393 266250.0n 0.4393 266499.9n 0.4393 266500.0n 0.4393 266749.9n 0.4393 266750.0n 0.4393 266999.9n 0.4393 267000.0n 0.4393 267249.9n 0.4393 267250.0n 0.4393 267499.9n 0.4393 267500.0n 0.4657 267749.9n 0.4657 267750.0n 0.4393 267999.9n 0.4393 268000.0n 0.4393 268249.9n 0.4393 268250.0n 0.4393 268499.9n 0.4393 268500.0n 0.4393 268749.9n 0.4393 268750.0n 0.4393 268999.9n 0.4393 269000.0n 0.4393 269249.9n 0.4393 269250.0n 0.4393 269499.9n 0.4393 269500.0n 0.4657 269749.9n 0.4657 269750.0n 0.4393 269999.9n 0.4393 270000.0n 0.4393 270249.9n 0.4393 270250.0n 0.4393 270499.9n 0.4393 270500.0n 0.4393 270749.9n 0.4393 270750.0n 0.4393 270999.9n 0.4393 271000.0n 0.4393 271249.9n 0.4393 271250.0n 0.4393 271499.9n 0.4393 271500.0n 0.4393 271749.9n 0.4393 271750.0n 0.4393 271999.9n 0.4393 272000.0n 0.4393 272249.9n 0.4393 272250.0n 0.4393 272499.9n 0.4393 272500.0n 0.4393 272749.9n 0.4393 272750.0n 0.5184 272999.9n 0.5184 273000.0n 0.4393 273249.9n 0.4393 273250.0n 0.4393 273499.9n 0.4393 273500.0n 0.4393 273749.9n 0.4393 273750.0n 0.4393 273999.9n 0.4393 274000.0n 0.4393 274249.9n 0.4393 274250.0n 0.4393 274499.9n 0.4393 274500.0n 0.4393 274749.9n 0.4393 274750.0n 0.4393 274999.9n 0.4393 275000.0n 0.4657 275249.9n 0.4657 275250.0n 0.4393 275499.9n 0.4393 275500.0n 0.4393 275749.9n 0.4393 275750.0n 0.4393 275999.9n 0.4393 276000.0n 0.4393 276249.9n 0.4393 276250.0n 0.4393 276499.9n 0.4393 276500.0n 0.4393 276749.9n 0.4393 276750.0n 0.4393 276999.9n 0.4393 277000.0n 0.4657 277249.9n 0.4657 277250.0n 0.4393 277499.9n 0.4393 277500.0n 0.4393 277749.9n 0.4393 277750.0n 0.4393 277999.9n 0.4393 278000.0n 0.4393 278249.9n 0.4393 278250.0n 0.4393 278499.9n 0.4393 278500.0n 0.4393 278749.9n 0.4393 278750.0n 0.4393 278999.9n 0.4393 279000.0n 0.4393 279249.9n 0.4393 279250.0n 0.4393 279499.9n 0.4393 279500.0n 0.4393 279749.9n 0.4393 279750.0n 0.4393 279999.9n 0.4393 280000.0n 0.4393 280249.9n 0.4393 280250.0n 0.5184 280499.9n 0.5184 280500.0n 0.4393 280749.9n 0.4393 280750.0n 0.4393 280999.9n 0.4393 281000.0n 0.4393 281249.9n 0.4393 281250.0n 0.4393 281499.9n 0.4393 281500.0n 0.4393 281749.9n 0.4393 281750.0n 0.4393 281999.9n 0.4393 282000.0n 0.4393 282249.9n 0.4393 282250.0n 0.4393 282499.9n 0.4393 282500.0n 0.4657 282749.9n 0.4657 282750.0n 0.4393 282999.9n 0.4393 283000.0n 0.4393 283249.9n 0.4393 283250.0n 0.4393 283499.9n 0.4393 283500.0n 0.4393 283749.9n 0.4393 283750.0n 0.4393 283999.9n 0.4393 284000.0n 0.4393 284249.9n 0.4393 284250.0n 0.4393 284499.9n 0.4393 284500.0n 0.4657 284749.9n 0.4657 284750.0n 0.4393 284999.9n 0.4393 285000.0n 0.4393 285249.9n 0.4393 285250.0n 0.4393 285499.9n 0.4393 285500.0n 0.4393 285749.9n 0.4393 285750.0n 0.4393 285999.9n 0.4393 286000.0n 0.4393 286249.9n 0.4393 286250.0n 0.4393 286499.9n 0.4393 286500.0n 0.4393 286749.9n 0.4393 286750.0n 0.4393 286999.9n 0.4393 287000.0n 0.4393 287249.9n 0.4393 287250.0n 0.4393 287499.9n 0.4393 287500.0n 0.4393 287749.9n 0.4393 287750.0n 0.5184 287999.9n 0.5184 288000.0n 0.4393 288249.9n 0.4393 288250.0n 0.4393 288499.9n 0.4393 288500.0n 0.4393 288749.9n 0.4393 288750.0n 0.4393 288999.9n 0.4393 289000.0n 0.4393 289249.9n 0.4393 289250.0n 0.4393 289499.9n 0.4393 289500.0n 0.4393 289749.9n 0.4393 289750.0n 0.4393 289999.9n 0.4393 290000.0n 0.4657 290249.9n 0.4657 290250.0n 0.4393 290499.9n 0.4393 290500.0n 0.4393 290749.9n 0.4393 290750.0n 0.4393 290999.9n 0.4393 291000.0n 0.4393 291249.9n 0.4393 291250.0n 0.4393 291499.9n 0.4393 291500.0n 0.4393 291749.9n 0.4393 291750.0n 0.4393 291999.9n 0.4393 292000.0n 0.4657 292249.9n 0.4657 292250.0n 0.4393 292499.9n 0.4393 292500.0n 0.4393 292749.9n 0.4393 292750.0n 0.4393 292999.9n 0.4393 293000.0n 0.4393 293249.9n 0.4393 293250.0n 0.4393 293499.9n 0.4393 293500.0n 0.4393 293749.9n 0.4393 293750.0n 0.4393 293999.9n 0.4393 294000.0n 0.4393 294249.9n 0.4393 294250.0n 0.4393 294499.9n 0.4393 294500.0n 0.4393 294749.9n 0.4393 294750.0n 0.4393 294999.9n 0.4393 295000.0n 0.4393 295249.9n 0.4393 295250.0n 0.5184 295499.9n 0.5184 295500.0n 0.4393 295749.9n 0.4393 295750.0n 0.4393 295999.9n 0.4393 296000.0n 0.4393 296249.9n 0.4393 296250.0n 0.4393 296499.9n 0.4393 296500.0n 0.4393 296749.9n 0.4393 296750.0n 0.4393 296999.9n 0.4393 297000.0n 0.4393 297249.9n 0.4393 297250.0n 0.4393 297499.9n 0.4393 297500.0n 0.4657 297749.9n 0.4657 297750.0n 0.4393 297999.9n 0.4393 298000.0n 0.4393 298249.9n 0.4393 298250.0n 0.4393 298499.9n 0.4393 298500.0n 0.4393 298749.9n 0.4393 298750.0n 0.4393 298999.9n 0.4393 299000.0n 0.4393 299249.9n 0.4393 299250.0n 0.4393 299499.9n 0.4393 299500.0n 0.4657 299749.9n 0.4657 299750.0n 0.4393)
Vxn0 a_xn0 0 PWL(0.0n 0.5607 249.9n 0.5607 250.0n 0.5607 499.9n 0.5607 500.0n 0.5607 749.9n 0.5607 750.0n 0.5607 999.9n 0.5607 1000.0n 0.5607 1249.9n 0.5607 1250.0n 0.5607 1499.9n 0.5607 1500.0n 0.5607 1749.9n 0.5607 1750.0n 0.5607 1999.9n 0.5607 2000.0n 0.5607 2249.9n 0.5607 2250.0n 0.5607 2499.9n 0.5607 2500.0n 0.5607 2749.9n 0.5607 2750.0n 0.4816 2999.9n 0.4816 3000.0n 0.5607 3249.9n 0.5607 3250.0n 0.5607 3499.9n 0.5607 3500.0n 0.5607 3749.9n 0.5607 3750.0n 0.5607 3999.9n 0.5607 4000.0n 0.5607 4249.9n 0.5607 4250.0n 0.5607 4499.9n 0.5607 4500.0n 0.5607 4749.9n 0.5607 4750.0n 0.5607 4999.9n 0.5607 5000.0n 0.5343 5249.9n 0.5343 5250.0n 0.5607 5499.9n 0.5607 5500.0n 0.5607 5749.9n 0.5607 5750.0n 0.5607 5999.9n 0.5607 6000.0n 0.5607 6249.9n 0.5607 6250.0n 0.5607 6499.9n 0.5607 6500.0n 0.5607 6749.9n 0.5607 6750.0n 0.5607 6999.9n 0.5607 7000.0n 0.5343 7249.9n 0.5343 7250.0n 0.5607 7499.9n 0.5607 7500.0n 0.5607 7749.9n 0.5607 7750.0n 0.5607 7999.9n 0.5607 8000.0n 0.5607 8249.9n 0.5607 8250.0n 0.5607 8499.9n 0.5607 8500.0n 0.5607 8749.9n 0.5607 8750.0n 0.5607 8999.9n 0.5607 9000.0n 0.5607 9249.9n 0.5607 9250.0n 0.5607 9499.9n 0.5607 9500.0n 0.5607 9749.9n 0.5607 9750.0n 0.5607 9999.9n 0.5607 10000.0n 0.5607 10249.9n 0.5607 10250.0n 0.4816 10499.9n 0.4816 10500.0n 0.5607 10749.9n 0.5607 10750.0n 0.5607 10999.9n 0.5607 11000.0n 0.5607 11249.9n 0.5607 11250.0n 0.5607 11499.9n 0.5607 11500.0n 0.5607 11749.9n 0.5607 11750.0n 0.5607 11999.9n 0.5607 12000.0n 0.5607 12249.9n 0.5607 12250.0n 0.5607 12499.9n 0.5607 12500.0n 0.5343 12749.9n 0.5343 12750.0n 0.5607 12999.9n 0.5607 13000.0n 0.5607 13249.9n 0.5607 13250.0n 0.5607 13499.9n 0.5607 13500.0n 0.5607 13749.9n 0.5607 13750.0n 0.5607 13999.9n 0.5607 14000.0n 0.5607 14249.9n 0.5607 14250.0n 0.5607 14499.9n 0.5607 14500.0n 0.5343 14749.9n 0.5343 14750.0n 0.5607 14999.9n 0.5607 15000.0n 0.5607 15249.9n 0.5607 15250.0n 0.5607 15499.9n 0.5607 15500.0n 0.5607 15749.9n 0.5607 15750.0n 0.5607 15999.9n 0.5607 16000.0n 0.5607 16249.9n 0.5607 16250.0n 0.5607 16499.9n 0.5607 16500.0n 0.5607 16749.9n 0.5607 16750.0n 0.5607 16999.9n 0.5607 17000.0n 0.5607 17249.9n 0.5607 17250.0n 0.5607 17499.9n 0.5607 17500.0n 0.5607 17749.9n 0.5607 17750.0n 0.4816 17999.9n 0.4816 18000.0n 0.5607 18249.9n 0.5607 18250.0n 0.5607 18499.9n 0.5607 18500.0n 0.5607 18749.9n 0.5607 18750.0n 0.5607 18999.9n 0.5607 19000.0n 0.5607 19249.9n 0.5607 19250.0n 0.5607 19499.9n 0.5607 19500.0n 0.5607 19749.9n 0.5607 19750.0n 0.5607 19999.9n 0.5607 20000.0n 0.5343 20249.9n 0.5343 20250.0n 0.5607 20499.9n 0.5607 20500.0n 0.5607 20749.9n 0.5607 20750.0n 0.5607 20999.9n 0.5607 21000.0n 0.5607 21249.9n 0.5607 21250.0n 0.5607 21499.9n 0.5607 21500.0n 0.5607 21749.9n 0.5607 21750.0n 0.5607 21999.9n 0.5607 22000.0n 0.5343 22249.9n 0.5343 22250.0n 0.5607 22499.9n 0.5607 22500.0n 0.5607 22749.9n 0.5607 22750.0n 0.5607 22999.9n 0.5607 23000.0n 0.5607 23249.9n 0.5607 23250.0n 0.5607 23499.9n 0.5607 23500.0n 0.5607 23749.9n 0.5607 23750.0n 0.5607 23999.9n 0.5607 24000.0n 0.5607 24249.9n 0.5607 24250.0n 0.5607 24499.9n 0.5607 24500.0n 0.5607 24749.9n 0.5607 24750.0n 0.5607 24999.9n 0.5607 25000.0n 0.5607 25249.9n 0.5607 25250.0n 0.4816 25499.9n 0.4816 25500.0n 0.5607 25749.9n 0.5607 25750.0n 0.5607 25999.9n 0.5607 26000.0n 0.5607 26249.9n 0.5607 26250.0n 0.5607 26499.9n 0.5607 26500.0n 0.5607 26749.9n 0.5607 26750.0n 0.5607 26999.9n 0.5607 27000.0n 0.5607 27249.9n 0.5607 27250.0n 0.5607 27499.9n 0.5607 27500.0n 0.5343 27749.9n 0.5343 27750.0n 0.5607 27999.9n 0.5607 28000.0n 0.5607 28249.9n 0.5607 28250.0n 0.5607 28499.9n 0.5607 28500.0n 0.5607 28749.9n 0.5607 28750.0n 0.5607 28999.9n 0.5607 29000.0n 0.5607 29249.9n 0.5607 29250.0n 0.5607 29499.9n 0.5607 29500.0n 0.5343 29749.9n 0.5343 29750.0n 0.5607 29999.9n 0.5607 30000.0n 0.5607 30249.9n 0.5607 30250.0n 0.5607 30499.9n 0.5607 30500.0n 0.5607 30749.9n 0.5607 30750.0n 0.5607 30999.9n 0.5607 31000.0n 0.5607 31249.9n 0.5607 31250.0n 0.5607 31499.9n 0.5607 31500.0n 0.5607 31749.9n 0.5607 31750.0n 0.5607 31999.9n 0.5607 32000.0n 0.5607 32249.9n 0.5607 32250.0n 0.5607 32499.9n 0.5607 32500.0n 0.5607 32749.9n 0.5607 32750.0n 0.4816 32999.9n 0.4816 33000.0n 0.5607 33249.9n 0.5607 33250.0n 0.5607 33499.9n 0.5607 33500.0n 0.5607 33749.9n 0.5607 33750.0n 0.5607 33999.9n 0.5607 34000.0n 0.5607 34249.9n 0.5607 34250.0n 0.5607 34499.9n 0.5607 34500.0n 0.5607 34749.9n 0.5607 34750.0n 0.5607 34999.9n 0.5607 35000.0n 0.5343 35249.9n 0.5343 35250.0n 0.5607 35499.9n 0.5607 35500.0n 0.5607 35749.9n 0.5607 35750.0n 0.5607 35999.9n 0.5607 36000.0n 0.5607 36249.9n 0.5607 36250.0n 0.5607 36499.9n 0.5607 36500.0n 0.5607 36749.9n 0.5607 36750.0n 0.5607 36999.9n 0.5607 37000.0n 0.5343 37249.9n 0.5343 37250.0n 0.5607 37499.9n 0.5607 37500.0n 0.5607 37749.9n 0.5607 37750.0n 0.5607 37999.9n 0.5607 38000.0n 0.5607 38249.9n 0.5607 38250.0n 0.5607 38499.9n 0.5607 38500.0n 0.5607 38749.9n 0.5607 38750.0n 0.5607 38999.9n 0.5607 39000.0n 0.5607 39249.9n 0.5607 39250.0n 0.5607 39499.9n 0.5607 39500.0n 0.5607 39749.9n 0.5607 39750.0n 0.5607 39999.9n 0.5607 40000.0n 0.5607 40249.9n 0.5607 40250.0n 0.4816 40499.9n 0.4816 40500.0n 0.5607 40749.9n 0.5607 40750.0n 0.5607 40999.9n 0.5607 41000.0n 0.5607 41249.9n 0.5607 41250.0n 0.5607 41499.9n 0.5607 41500.0n 0.5607 41749.9n 0.5607 41750.0n 0.5607 41999.9n 0.5607 42000.0n 0.5607 42249.9n 0.5607 42250.0n 0.5607 42499.9n 0.5607 42500.0n 0.5343 42749.9n 0.5343 42750.0n 0.5607 42999.9n 0.5607 43000.0n 0.5607 43249.9n 0.5607 43250.0n 0.5607 43499.9n 0.5607 43500.0n 0.5607 43749.9n 0.5607 43750.0n 0.5607 43999.9n 0.5607 44000.0n 0.5607 44249.9n 0.5607 44250.0n 0.5607 44499.9n 0.5607 44500.0n 0.5343 44749.9n 0.5343 44750.0n 0.5607 44999.9n 0.5607 45000.0n 0.5607 45249.9n 0.5607 45250.0n 0.5607 45499.9n 0.5607 45500.0n 0.5607 45749.9n 0.5607 45750.0n 0.5607 45999.9n 0.5607 46000.0n 0.5607 46249.9n 0.5607 46250.0n 0.5607 46499.9n 0.5607 46500.0n 0.5607 46749.9n 0.5607 46750.0n 0.5607 46999.9n 0.5607 47000.0n 0.5607 47249.9n 0.5607 47250.0n 0.5607 47499.9n 0.5607 47500.0n 0.5607 47749.9n 0.5607 47750.0n 0.4816 47999.9n 0.4816 48000.0n 0.5607 48249.9n 0.5607 48250.0n 0.5607 48499.9n 0.5607 48500.0n 0.5607 48749.9n 0.5607 48750.0n 0.5607 48999.9n 0.5607 49000.0n 0.5607 49249.9n 0.5607 49250.0n 0.5607 49499.9n 0.5607 49500.0n 0.5607 49749.9n 0.5607 49750.0n 0.5607 49999.9n 0.5607 50000.0n 0.5343 50249.9n 0.5343 50250.0n 0.5607 50499.9n 0.5607 50500.0n 0.5607 50749.9n 0.5607 50750.0n 0.5607 50999.9n 0.5607 51000.0n 0.5607 51249.9n 0.5607 51250.0n 0.5607 51499.9n 0.5607 51500.0n 0.5607 51749.9n 0.5607 51750.0n 0.5607 51999.9n 0.5607 52000.0n 0.5343 52249.9n 0.5343 52250.0n 0.5607 52499.9n 0.5607 52500.0n 0.5607 52749.9n 0.5607 52750.0n 0.5607 52999.9n 0.5607 53000.0n 0.5607 53249.9n 0.5607 53250.0n 0.5607 53499.9n 0.5607 53500.0n 0.5607 53749.9n 0.5607 53750.0n 0.5607 53999.9n 0.5607 54000.0n 0.5607 54249.9n 0.5607 54250.0n 0.5607 54499.9n 0.5607 54500.0n 0.5607 54749.9n 0.5607 54750.0n 0.5607 54999.9n 0.5607 55000.0n 0.5607 55249.9n 0.5607 55250.0n 0.4816 55499.9n 0.4816 55500.0n 0.5607 55749.9n 0.5607 55750.0n 0.5607 55999.9n 0.5607 56000.0n 0.5607 56249.9n 0.5607 56250.0n 0.5607 56499.9n 0.5607 56500.0n 0.5607 56749.9n 0.5607 56750.0n 0.5607 56999.9n 0.5607 57000.0n 0.5607 57249.9n 0.5607 57250.0n 0.5607 57499.9n 0.5607 57500.0n 0.5343 57749.9n 0.5343 57750.0n 0.5607 57999.9n 0.5607 58000.0n 0.5607 58249.9n 0.5607 58250.0n 0.5607 58499.9n 0.5607 58500.0n 0.5607 58749.9n 0.5607 58750.0n 0.5607 58999.9n 0.5607 59000.0n 0.5607 59249.9n 0.5607 59250.0n 0.5607 59499.9n 0.5607 59500.0n 0.5343 59749.9n 0.5343 59750.0n 0.5607 59999.9n 0.5607 60000.0n 0.5607 60249.9n 0.5607 60250.0n 0.5607 60499.9n 0.5607 60500.0n 0.5607 60749.9n 0.5607 60750.0n 0.5607 60999.9n 0.5607 61000.0n 0.5607 61249.9n 0.5607 61250.0n 0.5607 61499.9n 0.5607 61500.0n 0.5607 61749.9n 0.5607 61750.0n 0.5607 61999.9n 0.5607 62000.0n 0.5607 62249.9n 0.5607 62250.0n 0.5607 62499.9n 0.5607 62500.0n 0.5607 62749.9n 0.5607 62750.0n 0.4816 62999.9n 0.4816 63000.0n 0.5607 63249.9n 0.5607 63250.0n 0.5607 63499.9n 0.5607 63500.0n 0.5607 63749.9n 0.5607 63750.0n 0.5607 63999.9n 0.5607 64000.0n 0.5607 64249.9n 0.5607 64250.0n 0.5607 64499.9n 0.5607 64500.0n 0.5607 64749.9n 0.5607 64750.0n 0.5607 64999.9n 0.5607 65000.0n 0.5343 65249.9n 0.5343 65250.0n 0.5607 65499.9n 0.5607 65500.0n 0.5607 65749.9n 0.5607 65750.0n 0.5607 65999.9n 0.5607 66000.0n 0.5607 66249.9n 0.5607 66250.0n 0.5607 66499.9n 0.5607 66500.0n 0.5607 66749.9n 0.5607 66750.0n 0.5607 66999.9n 0.5607 67000.0n 0.5343 67249.9n 0.5343 67250.0n 0.5607 67499.9n 0.5607 67500.0n 0.5607 67749.9n 0.5607 67750.0n 0.5607 67999.9n 0.5607 68000.0n 0.5607 68249.9n 0.5607 68250.0n 0.5607 68499.9n 0.5607 68500.0n 0.5607 68749.9n 0.5607 68750.0n 0.5607 68999.9n 0.5607 69000.0n 0.5607 69249.9n 0.5607 69250.0n 0.5607 69499.9n 0.5607 69500.0n 0.5607 69749.9n 0.5607 69750.0n 0.5607 69999.9n 0.5607 70000.0n 0.5607 70249.9n 0.5607 70250.0n 0.4816 70499.9n 0.4816 70500.0n 0.5607 70749.9n 0.5607 70750.0n 0.5607 70999.9n 0.5607 71000.0n 0.5607 71249.9n 0.5607 71250.0n 0.5607 71499.9n 0.5607 71500.0n 0.5607 71749.9n 0.5607 71750.0n 0.5607 71999.9n 0.5607 72000.0n 0.5607 72249.9n 0.5607 72250.0n 0.5607 72499.9n 0.5607 72500.0n 0.5343 72749.9n 0.5343 72750.0n 0.5607 72999.9n 0.5607 73000.0n 0.5607 73249.9n 0.5607 73250.0n 0.5607 73499.9n 0.5607 73500.0n 0.5607 73749.9n 0.5607 73750.0n 0.5607 73999.9n 0.5607 74000.0n 0.5607 74249.9n 0.5607 74250.0n 0.5607 74499.9n 0.5607 74500.0n 0.5343 74749.9n 0.5343 74750.0n 0.5607 74999.9n 0.5607 75000.0n 0.5607 75249.9n 0.5607 75250.0n 0.5607 75499.9n 0.5607 75500.0n 0.5607 75749.9n 0.5607 75750.0n 0.5607 75999.9n 0.5607 76000.0n 0.5607 76249.9n 0.5607 76250.0n 0.5607 76499.9n 0.5607 76500.0n 0.5607 76749.9n 0.5607 76750.0n 0.5607 76999.9n 0.5607 77000.0n 0.5607 77249.9n 0.5607 77250.0n 0.5607 77499.9n 0.5607 77500.0n 0.5607 77749.9n 0.5607 77750.0n 0.4816 77999.9n 0.4816 78000.0n 0.5607 78249.9n 0.5607 78250.0n 0.5607 78499.9n 0.5607 78500.0n 0.5607 78749.9n 0.5607 78750.0n 0.5607 78999.9n 0.5607 79000.0n 0.5607 79249.9n 0.5607 79250.0n 0.5607 79499.9n 0.5607 79500.0n 0.5607 79749.9n 0.5607 79750.0n 0.5607 79999.9n 0.5607 80000.0n 0.5343 80249.9n 0.5343 80250.0n 0.5607 80499.9n 0.5607 80500.0n 0.5607 80749.9n 0.5607 80750.0n 0.5607 80999.9n 0.5607 81000.0n 0.5607 81249.9n 0.5607 81250.0n 0.5607 81499.9n 0.5607 81500.0n 0.5607 81749.9n 0.5607 81750.0n 0.5607 81999.9n 0.5607 82000.0n 0.5343 82249.9n 0.5343 82250.0n 0.5607 82499.9n 0.5607 82500.0n 0.5607 82749.9n 0.5607 82750.0n 0.5607 82999.9n 0.5607 83000.0n 0.5607 83249.9n 0.5607 83250.0n 0.5607 83499.9n 0.5607 83500.0n 0.5607 83749.9n 0.5607 83750.0n 0.5607 83999.9n 0.5607 84000.0n 0.5607 84249.9n 0.5607 84250.0n 0.5607 84499.9n 0.5607 84500.0n 0.5607 84749.9n 0.5607 84750.0n 0.5607 84999.9n 0.5607 85000.0n 0.5607 85249.9n 0.5607 85250.0n 0.4816 85499.9n 0.4816 85500.0n 0.5607 85749.9n 0.5607 85750.0n 0.5607 85999.9n 0.5607 86000.0n 0.5607 86249.9n 0.5607 86250.0n 0.5607 86499.9n 0.5607 86500.0n 0.5607 86749.9n 0.5607 86750.0n 0.5607 86999.9n 0.5607 87000.0n 0.5607 87249.9n 0.5607 87250.0n 0.5607 87499.9n 0.5607 87500.0n 0.5343 87749.9n 0.5343 87750.0n 0.5607 87999.9n 0.5607 88000.0n 0.5607 88249.9n 0.5607 88250.0n 0.5607 88499.9n 0.5607 88500.0n 0.5607 88749.9n 0.5607 88750.0n 0.5607 88999.9n 0.5607 89000.0n 0.5607 89249.9n 0.5607 89250.0n 0.5607 89499.9n 0.5607 89500.0n 0.5343 89749.9n 0.5343 89750.0n 0.5607 89999.9n 0.5607 90000.0n 0.5607 90249.9n 0.5607 90250.0n 0.5607 90499.9n 0.5607 90500.0n 0.5607 90749.9n 0.5607 90750.0n 0.5607 90999.9n 0.5607 91000.0n 0.5607 91249.9n 0.5607 91250.0n 0.5607 91499.9n 0.5607 91500.0n 0.5607 91749.9n 0.5607 91750.0n 0.5607 91999.9n 0.5607 92000.0n 0.5607 92249.9n 0.5607 92250.0n 0.5607 92499.9n 0.5607 92500.0n 0.5607 92749.9n 0.5607 92750.0n 0.4816 92999.9n 0.4816 93000.0n 0.5607 93249.9n 0.5607 93250.0n 0.5607 93499.9n 0.5607 93500.0n 0.5607 93749.9n 0.5607 93750.0n 0.5607 93999.9n 0.5607 94000.0n 0.5607 94249.9n 0.5607 94250.0n 0.5607 94499.9n 0.5607 94500.0n 0.5607 94749.9n 0.5607 94750.0n 0.5607 94999.9n 0.5607 95000.0n 0.5343 95249.9n 0.5343 95250.0n 0.5607 95499.9n 0.5607 95500.0n 0.5607 95749.9n 0.5607 95750.0n 0.5607 95999.9n 0.5607 96000.0n 0.5607 96249.9n 0.5607 96250.0n 0.5607 96499.9n 0.5607 96500.0n 0.5607 96749.9n 0.5607 96750.0n 0.5607 96999.9n 0.5607 97000.0n 0.5343 97249.9n 0.5343 97250.0n 0.5607 97499.9n 0.5607 97500.0n 0.5607 97749.9n 0.5607 97750.0n 0.5607 97999.9n 0.5607 98000.0n 0.5607 98249.9n 0.5607 98250.0n 0.5607 98499.9n 0.5607 98500.0n 0.5607 98749.9n 0.5607 98750.0n 0.5607 98999.9n 0.5607 99000.0n 0.5607 99249.9n 0.5607 99250.0n 0.5607 99499.9n 0.5607 99500.0n 0.5607 99749.9n 0.5607 99750.0n 0.5607 99999.9n 0.5607 100000.0n 0.5607 100249.9n 0.5607 100250.0n 0.4816 100499.9n 0.4816 100500.0n 0.5607 100749.9n 0.5607 100750.0n 0.5607 100999.9n 0.5607 101000.0n 0.5607 101249.9n 0.5607 101250.0n 0.5607 101499.9n 0.5607 101500.0n 0.5607 101749.9n 0.5607 101750.0n 0.5607 101999.9n 0.5607 102000.0n 0.5607 102249.9n 0.5607 102250.0n 0.5607 102499.9n 0.5607 102500.0n 0.5343 102749.9n 0.5343 102750.0n 0.5607 102999.9n 0.5607 103000.0n 0.5607 103249.9n 0.5607 103250.0n 0.5607 103499.9n 0.5607 103500.0n 0.5607 103749.9n 0.5607 103750.0n 0.5607 103999.9n 0.5607 104000.0n 0.5607 104249.9n 0.5607 104250.0n 0.5607 104499.9n 0.5607 104500.0n 0.5343 104749.9n 0.5343 104750.0n 0.5607 104999.9n 0.5607 105000.0n 0.5607 105249.9n 0.5607 105250.0n 0.5607 105499.9n 0.5607 105500.0n 0.5607 105749.9n 0.5607 105750.0n 0.5607 105999.9n 0.5607 106000.0n 0.5607 106249.9n 0.5607 106250.0n 0.5607 106499.9n 0.5607 106500.0n 0.5607 106749.9n 0.5607 106750.0n 0.5607 106999.9n 0.5607 107000.0n 0.5607 107249.9n 0.5607 107250.0n 0.5607 107499.9n 0.5607 107500.0n 0.5607 107749.9n 0.5607 107750.0n 0.4816 107999.9n 0.4816 108000.0n 0.5607 108249.9n 0.5607 108250.0n 0.5607 108499.9n 0.5607 108500.0n 0.5607 108749.9n 0.5607 108750.0n 0.5607 108999.9n 0.5607 109000.0n 0.5607 109249.9n 0.5607 109250.0n 0.5607 109499.9n 0.5607 109500.0n 0.5607 109749.9n 0.5607 109750.0n 0.5607 109999.9n 0.5607 110000.0n 0.5343 110249.9n 0.5343 110250.0n 0.5607 110499.9n 0.5607 110500.0n 0.5607 110749.9n 0.5607 110750.0n 0.5607 110999.9n 0.5607 111000.0n 0.5607 111249.9n 0.5607 111250.0n 0.5607 111499.9n 0.5607 111500.0n 0.5607 111749.9n 0.5607 111750.0n 0.5607 111999.9n 0.5607 112000.0n 0.5343 112249.9n 0.5343 112250.0n 0.5607 112499.9n 0.5607 112500.0n 0.5607 112749.9n 0.5607 112750.0n 0.5607 112999.9n 0.5607 113000.0n 0.5607 113249.9n 0.5607 113250.0n 0.5607 113499.9n 0.5607 113500.0n 0.5607 113749.9n 0.5607 113750.0n 0.5607 113999.9n 0.5607 114000.0n 0.5607 114249.9n 0.5607 114250.0n 0.5607 114499.9n 0.5607 114500.0n 0.5607 114749.9n 0.5607 114750.0n 0.5607 114999.9n 0.5607 115000.0n 0.5607 115249.9n 0.5607 115250.0n 0.4816 115499.9n 0.4816 115500.0n 0.5607 115749.9n 0.5607 115750.0n 0.5607 115999.9n 0.5607 116000.0n 0.5607 116249.9n 0.5607 116250.0n 0.5607 116499.9n 0.5607 116500.0n 0.5607 116749.9n 0.5607 116750.0n 0.5607 116999.9n 0.5607 117000.0n 0.5607 117249.9n 0.5607 117250.0n 0.5607 117499.9n 0.5607 117500.0n 0.5343 117749.9n 0.5343 117750.0n 0.5607 117999.9n 0.5607 118000.0n 0.5607 118249.9n 0.5607 118250.0n 0.5607 118499.9n 0.5607 118500.0n 0.5607 118749.9n 0.5607 118750.0n 0.5607 118999.9n 0.5607 119000.0n 0.5607 119249.9n 0.5607 119250.0n 0.5607 119499.9n 0.5607 119500.0n 0.5343 119749.9n 0.5343 119750.0n 0.5607 119999.9n 0.5607 120000.0n 0.5607 120249.9n 0.5607 120250.0n 0.5607 120499.9n 0.5607 120500.0n 0.5607 120749.9n 0.5607 120750.0n 0.5607 120999.9n 0.5607 121000.0n 0.5607 121249.9n 0.5607 121250.0n 0.5607 121499.9n 0.5607 121500.0n 0.5607 121749.9n 0.5607 121750.0n 0.5607 121999.9n 0.5607 122000.0n 0.5607 122249.9n 0.5607 122250.0n 0.5607 122499.9n 0.5607 122500.0n 0.5607 122749.9n 0.5607 122750.0n 0.4816 122999.9n 0.4816 123000.0n 0.5607 123249.9n 0.5607 123250.0n 0.5607 123499.9n 0.5607 123500.0n 0.5607 123749.9n 0.5607 123750.0n 0.5607 123999.9n 0.5607 124000.0n 0.5607 124249.9n 0.5607 124250.0n 0.5607 124499.9n 0.5607 124500.0n 0.5607 124749.9n 0.5607 124750.0n 0.5607 124999.9n 0.5607 125000.0n 0.5343 125249.9n 0.5343 125250.0n 0.5607 125499.9n 0.5607 125500.0n 0.5607 125749.9n 0.5607 125750.0n 0.5607 125999.9n 0.5607 126000.0n 0.5607 126249.9n 0.5607 126250.0n 0.5607 126499.9n 0.5607 126500.0n 0.5607 126749.9n 0.5607 126750.0n 0.5607 126999.9n 0.5607 127000.0n 0.5343 127249.9n 0.5343 127250.0n 0.5607 127499.9n 0.5607 127500.0n 0.5607 127749.9n 0.5607 127750.0n 0.5607 127999.9n 0.5607 128000.0n 0.5607 128249.9n 0.5607 128250.0n 0.5607 128499.9n 0.5607 128500.0n 0.5607 128749.9n 0.5607 128750.0n 0.5607 128999.9n 0.5607 129000.0n 0.5607 129249.9n 0.5607 129250.0n 0.5607 129499.9n 0.5607 129500.0n 0.5607 129749.9n 0.5607 129750.0n 0.5607 129999.9n 0.5607 130000.0n 0.5607 130249.9n 0.5607 130250.0n 0.4816 130499.9n 0.4816 130500.0n 0.5607 130749.9n 0.5607 130750.0n 0.5607 130999.9n 0.5607 131000.0n 0.5607 131249.9n 0.5607 131250.0n 0.5607 131499.9n 0.5607 131500.0n 0.5607 131749.9n 0.5607 131750.0n 0.5607 131999.9n 0.5607 132000.0n 0.5607 132249.9n 0.5607 132250.0n 0.5607 132499.9n 0.5607 132500.0n 0.5343 132749.9n 0.5343 132750.0n 0.5607 132999.9n 0.5607 133000.0n 0.5607 133249.9n 0.5607 133250.0n 0.5607 133499.9n 0.5607 133500.0n 0.5607 133749.9n 0.5607 133750.0n 0.5607 133999.9n 0.5607 134000.0n 0.5607 134249.9n 0.5607 134250.0n 0.5607 134499.9n 0.5607 134500.0n 0.5343 134749.9n 0.5343 134750.0n 0.5607 134999.9n 0.5607 135000.0n 0.5607 135249.9n 0.5607 135250.0n 0.5607 135499.9n 0.5607 135500.0n 0.5607 135749.9n 0.5607 135750.0n 0.5607 135999.9n 0.5607 136000.0n 0.5607 136249.9n 0.5607 136250.0n 0.5607 136499.9n 0.5607 136500.0n 0.5607 136749.9n 0.5607 136750.0n 0.5607 136999.9n 0.5607 137000.0n 0.5607 137249.9n 0.5607 137250.0n 0.5607 137499.9n 0.5607 137500.0n 0.5607 137749.9n 0.5607 137750.0n 0.4816 137999.9n 0.4816 138000.0n 0.5607 138249.9n 0.5607 138250.0n 0.5607 138499.9n 0.5607 138500.0n 0.5607 138749.9n 0.5607 138750.0n 0.5607 138999.9n 0.5607 139000.0n 0.5607 139249.9n 0.5607 139250.0n 0.5607 139499.9n 0.5607 139500.0n 0.5607 139749.9n 0.5607 139750.0n 0.5607 139999.9n 0.5607 140000.0n 0.5343 140249.9n 0.5343 140250.0n 0.5607 140499.9n 0.5607 140500.0n 0.5607 140749.9n 0.5607 140750.0n 0.5607 140999.9n 0.5607 141000.0n 0.5607 141249.9n 0.5607 141250.0n 0.5607 141499.9n 0.5607 141500.0n 0.5607 141749.9n 0.5607 141750.0n 0.5607 141999.9n 0.5607 142000.0n 0.5343 142249.9n 0.5343 142250.0n 0.5607 142499.9n 0.5607 142500.0n 0.5607 142749.9n 0.5607 142750.0n 0.5607 142999.9n 0.5607 143000.0n 0.5607 143249.9n 0.5607 143250.0n 0.5607 143499.9n 0.5607 143500.0n 0.5607 143749.9n 0.5607 143750.0n 0.5607 143999.9n 0.5607 144000.0n 0.5607 144249.9n 0.5607 144250.0n 0.5607 144499.9n 0.5607 144500.0n 0.5607 144749.9n 0.5607 144750.0n 0.5607 144999.9n 0.5607 145000.0n 0.5607 145249.9n 0.5607 145250.0n 0.4816 145499.9n 0.4816 145500.0n 0.5607 145749.9n 0.5607 145750.0n 0.5607 145999.9n 0.5607 146000.0n 0.5607 146249.9n 0.5607 146250.0n 0.5607 146499.9n 0.5607 146500.0n 0.5607 146749.9n 0.5607 146750.0n 0.5607 146999.9n 0.5607 147000.0n 0.5607 147249.9n 0.5607 147250.0n 0.5607 147499.9n 0.5607 147500.0n 0.5343 147749.9n 0.5343 147750.0n 0.5607 147999.9n 0.5607 148000.0n 0.5607 148249.9n 0.5607 148250.0n 0.5607 148499.9n 0.5607 148500.0n 0.5607 148749.9n 0.5607 148750.0n 0.5607 148999.9n 0.5607 149000.0n 0.5607 149249.9n 0.5607 149250.0n 0.5607 149499.9n 0.5607 149500.0n 0.5343 149749.9n 0.5343 149750.0n 0.5607 149999.9n 0.5607 150000.0n 0.5607 150249.9n 0.5607 150250.0n 0.5607 150499.9n 0.5607 150500.0n 0.5607 150749.9n 0.5607 150750.0n 0.5607 150999.9n 0.5607 151000.0n 0.5607 151249.9n 0.5607 151250.0n 0.5607 151499.9n 0.5607 151500.0n 0.5607 151749.9n 0.5607 151750.0n 0.5607 151999.9n 0.5607 152000.0n 0.5607 152249.9n 0.5607 152250.0n 0.5607 152499.9n 0.5607 152500.0n 0.5607 152749.9n 0.5607 152750.0n 0.4816 152999.9n 0.4816 153000.0n 0.5607 153249.9n 0.5607 153250.0n 0.5607 153499.9n 0.5607 153500.0n 0.5607 153749.9n 0.5607 153750.0n 0.5607 153999.9n 0.5607 154000.0n 0.5607 154249.9n 0.5607 154250.0n 0.5607 154499.9n 0.5607 154500.0n 0.5607 154749.9n 0.5607 154750.0n 0.5607 154999.9n 0.5607 155000.0n 0.5343 155249.9n 0.5343 155250.0n 0.5607 155499.9n 0.5607 155500.0n 0.5607 155749.9n 0.5607 155750.0n 0.5607 155999.9n 0.5607 156000.0n 0.5607 156249.9n 0.5607 156250.0n 0.5607 156499.9n 0.5607 156500.0n 0.5607 156749.9n 0.5607 156750.0n 0.5607 156999.9n 0.5607 157000.0n 0.5343 157249.9n 0.5343 157250.0n 0.5607 157499.9n 0.5607 157500.0n 0.5607 157749.9n 0.5607 157750.0n 0.5607 157999.9n 0.5607 158000.0n 0.5607 158249.9n 0.5607 158250.0n 0.5607 158499.9n 0.5607 158500.0n 0.5607 158749.9n 0.5607 158750.0n 0.5607 158999.9n 0.5607 159000.0n 0.5607 159249.9n 0.5607 159250.0n 0.5607 159499.9n 0.5607 159500.0n 0.5607 159749.9n 0.5607 159750.0n 0.5607 159999.9n 0.5607 160000.0n 0.5607 160249.9n 0.5607 160250.0n 0.4816 160499.9n 0.4816 160500.0n 0.5607 160749.9n 0.5607 160750.0n 0.5607 160999.9n 0.5607 161000.0n 0.5607 161249.9n 0.5607 161250.0n 0.5607 161499.9n 0.5607 161500.0n 0.5607 161749.9n 0.5607 161750.0n 0.5607 161999.9n 0.5607 162000.0n 0.5607 162249.9n 0.5607 162250.0n 0.5607 162499.9n 0.5607 162500.0n 0.5343 162749.9n 0.5343 162750.0n 0.5607 162999.9n 0.5607 163000.0n 0.5607 163249.9n 0.5607 163250.0n 0.5607 163499.9n 0.5607 163500.0n 0.5607 163749.9n 0.5607 163750.0n 0.5607 163999.9n 0.5607 164000.0n 0.5607 164249.9n 0.5607 164250.0n 0.5607 164499.9n 0.5607 164500.0n 0.5343 164749.9n 0.5343 164750.0n 0.5607 164999.9n 0.5607 165000.0n 0.5607 165249.9n 0.5607 165250.0n 0.5607 165499.9n 0.5607 165500.0n 0.5607 165749.9n 0.5607 165750.0n 0.5607 165999.9n 0.5607 166000.0n 0.5607 166249.9n 0.5607 166250.0n 0.5607 166499.9n 0.5607 166500.0n 0.5607 166749.9n 0.5607 166750.0n 0.5607 166999.9n 0.5607 167000.0n 0.5607 167249.9n 0.5607 167250.0n 0.5607 167499.9n 0.5607 167500.0n 0.5607 167749.9n 0.5607 167750.0n 0.4816 167999.9n 0.4816 168000.0n 0.5607 168249.9n 0.5607 168250.0n 0.5607 168499.9n 0.5607 168500.0n 0.5607 168749.9n 0.5607 168750.0n 0.5607 168999.9n 0.5607 169000.0n 0.5607 169249.9n 0.5607 169250.0n 0.5607 169499.9n 0.5607 169500.0n 0.5607 169749.9n 0.5607 169750.0n 0.5607 169999.9n 0.5607 170000.0n 0.5343 170249.9n 0.5343 170250.0n 0.5607 170499.9n 0.5607 170500.0n 0.5607 170749.9n 0.5607 170750.0n 0.5607 170999.9n 0.5607 171000.0n 0.5607 171249.9n 0.5607 171250.0n 0.5607 171499.9n 0.5607 171500.0n 0.5607 171749.9n 0.5607 171750.0n 0.5607 171999.9n 0.5607 172000.0n 0.5343 172249.9n 0.5343 172250.0n 0.5607 172499.9n 0.5607 172500.0n 0.5607 172749.9n 0.5607 172750.0n 0.5607 172999.9n 0.5607 173000.0n 0.5607 173249.9n 0.5607 173250.0n 0.5607 173499.9n 0.5607 173500.0n 0.5607 173749.9n 0.5607 173750.0n 0.5607 173999.9n 0.5607 174000.0n 0.5607 174249.9n 0.5607 174250.0n 0.5607 174499.9n 0.5607 174500.0n 0.5607 174749.9n 0.5607 174750.0n 0.5607 174999.9n 0.5607 175000.0n 0.5607 175249.9n 0.5607 175250.0n 0.4816 175499.9n 0.4816 175500.0n 0.5607 175749.9n 0.5607 175750.0n 0.5607 175999.9n 0.5607 176000.0n 0.5607 176249.9n 0.5607 176250.0n 0.5607 176499.9n 0.5607 176500.0n 0.5607 176749.9n 0.5607 176750.0n 0.5607 176999.9n 0.5607 177000.0n 0.5607 177249.9n 0.5607 177250.0n 0.5607 177499.9n 0.5607 177500.0n 0.5343 177749.9n 0.5343 177750.0n 0.5607 177999.9n 0.5607 178000.0n 0.5607 178249.9n 0.5607 178250.0n 0.5607 178499.9n 0.5607 178500.0n 0.5607 178749.9n 0.5607 178750.0n 0.5607 178999.9n 0.5607 179000.0n 0.5607 179249.9n 0.5607 179250.0n 0.5607 179499.9n 0.5607 179500.0n 0.5343 179749.9n 0.5343 179750.0n 0.5607 179999.9n 0.5607 180000.0n 0.5607 180249.9n 0.5607 180250.0n 0.5607 180499.9n 0.5607 180500.0n 0.5607 180749.9n 0.5607 180750.0n 0.5607 180999.9n 0.5607 181000.0n 0.5607 181249.9n 0.5607 181250.0n 0.5607 181499.9n 0.5607 181500.0n 0.5607 181749.9n 0.5607 181750.0n 0.5607 181999.9n 0.5607 182000.0n 0.5607 182249.9n 0.5607 182250.0n 0.5607 182499.9n 0.5607 182500.0n 0.5607 182749.9n 0.5607 182750.0n 0.4816 182999.9n 0.4816 183000.0n 0.5607 183249.9n 0.5607 183250.0n 0.5607 183499.9n 0.5607 183500.0n 0.5607 183749.9n 0.5607 183750.0n 0.5607 183999.9n 0.5607 184000.0n 0.5607 184249.9n 0.5607 184250.0n 0.5607 184499.9n 0.5607 184500.0n 0.5607 184749.9n 0.5607 184750.0n 0.5607 184999.9n 0.5607 185000.0n 0.5343 185249.9n 0.5343 185250.0n 0.5607 185499.9n 0.5607 185500.0n 0.5607 185749.9n 0.5607 185750.0n 0.5607 185999.9n 0.5607 186000.0n 0.5607 186249.9n 0.5607 186250.0n 0.5607 186499.9n 0.5607 186500.0n 0.5607 186749.9n 0.5607 186750.0n 0.5607 186999.9n 0.5607 187000.0n 0.5343 187249.9n 0.5343 187250.0n 0.5607 187499.9n 0.5607 187500.0n 0.5607 187749.9n 0.5607 187750.0n 0.5607 187999.9n 0.5607 188000.0n 0.5607 188249.9n 0.5607 188250.0n 0.5607 188499.9n 0.5607 188500.0n 0.5607 188749.9n 0.5607 188750.0n 0.5607 188999.9n 0.5607 189000.0n 0.5607 189249.9n 0.5607 189250.0n 0.5607 189499.9n 0.5607 189500.0n 0.5607 189749.9n 0.5607 189750.0n 0.5607 189999.9n 0.5607 190000.0n 0.5607 190249.9n 0.5607 190250.0n 0.4816 190499.9n 0.4816 190500.0n 0.5607 190749.9n 0.5607 190750.0n 0.5607 190999.9n 0.5607 191000.0n 0.5607 191249.9n 0.5607 191250.0n 0.5607 191499.9n 0.5607 191500.0n 0.5607 191749.9n 0.5607 191750.0n 0.5607 191999.9n 0.5607 192000.0n 0.5607 192249.9n 0.5607 192250.0n 0.5607 192499.9n 0.5607 192500.0n 0.5343 192749.9n 0.5343 192750.0n 0.5607 192999.9n 0.5607 193000.0n 0.5607 193249.9n 0.5607 193250.0n 0.5607 193499.9n 0.5607 193500.0n 0.5607 193749.9n 0.5607 193750.0n 0.5607 193999.9n 0.5607 194000.0n 0.5607 194249.9n 0.5607 194250.0n 0.5607 194499.9n 0.5607 194500.0n 0.5343 194749.9n 0.5343 194750.0n 0.5607 194999.9n 0.5607 195000.0n 0.5607 195249.9n 0.5607 195250.0n 0.5607 195499.9n 0.5607 195500.0n 0.5607 195749.9n 0.5607 195750.0n 0.5607 195999.9n 0.5607 196000.0n 0.5607 196249.9n 0.5607 196250.0n 0.5607 196499.9n 0.5607 196500.0n 0.5607 196749.9n 0.5607 196750.0n 0.5607 196999.9n 0.5607 197000.0n 0.5607 197249.9n 0.5607 197250.0n 0.5607 197499.9n 0.5607 197500.0n 0.5607 197749.9n 0.5607 197750.0n 0.4816 197999.9n 0.4816 198000.0n 0.5607 198249.9n 0.5607 198250.0n 0.5607 198499.9n 0.5607 198500.0n 0.5607 198749.9n 0.5607 198750.0n 0.5607 198999.9n 0.5607 199000.0n 0.5607 199249.9n 0.5607 199250.0n 0.5607 199499.9n 0.5607 199500.0n 0.5607 199749.9n 0.5607 199750.0n 0.5607 199999.9n 0.5607 200000.0n 0.5343 200249.9n 0.5343 200250.0n 0.5607 200499.9n 0.5607 200500.0n 0.5607 200749.9n 0.5607 200750.0n 0.5607 200999.9n 0.5607 201000.0n 0.5607 201249.9n 0.5607 201250.0n 0.5607 201499.9n 0.5607 201500.0n 0.5607 201749.9n 0.5607 201750.0n 0.5607 201999.9n 0.5607 202000.0n 0.5343 202249.9n 0.5343 202250.0n 0.5607 202499.9n 0.5607 202500.0n 0.5607 202749.9n 0.5607 202750.0n 0.5607 202999.9n 0.5607 203000.0n 0.5607 203249.9n 0.5607 203250.0n 0.5607 203499.9n 0.5607 203500.0n 0.5607 203749.9n 0.5607 203750.0n 0.5607 203999.9n 0.5607 204000.0n 0.5607 204249.9n 0.5607 204250.0n 0.5607 204499.9n 0.5607 204500.0n 0.5607 204749.9n 0.5607 204750.0n 0.5607 204999.9n 0.5607 205000.0n 0.5607 205249.9n 0.5607 205250.0n 0.4816 205499.9n 0.4816 205500.0n 0.5607 205749.9n 0.5607 205750.0n 0.5607 205999.9n 0.5607 206000.0n 0.5607 206249.9n 0.5607 206250.0n 0.5607 206499.9n 0.5607 206500.0n 0.5607 206749.9n 0.5607 206750.0n 0.5607 206999.9n 0.5607 207000.0n 0.5607 207249.9n 0.5607 207250.0n 0.5607 207499.9n 0.5607 207500.0n 0.5343 207749.9n 0.5343 207750.0n 0.5607 207999.9n 0.5607 208000.0n 0.5607 208249.9n 0.5607 208250.0n 0.5607 208499.9n 0.5607 208500.0n 0.5607 208749.9n 0.5607 208750.0n 0.5607 208999.9n 0.5607 209000.0n 0.5607 209249.9n 0.5607 209250.0n 0.5607 209499.9n 0.5607 209500.0n 0.5343 209749.9n 0.5343 209750.0n 0.5607 209999.9n 0.5607 210000.0n 0.5607 210249.9n 0.5607 210250.0n 0.5607 210499.9n 0.5607 210500.0n 0.5607 210749.9n 0.5607 210750.0n 0.5607 210999.9n 0.5607 211000.0n 0.5607 211249.9n 0.5607 211250.0n 0.5607 211499.9n 0.5607 211500.0n 0.5607 211749.9n 0.5607 211750.0n 0.5607 211999.9n 0.5607 212000.0n 0.5607 212249.9n 0.5607 212250.0n 0.5607 212499.9n 0.5607 212500.0n 0.5607 212749.9n 0.5607 212750.0n 0.4816 212999.9n 0.4816 213000.0n 0.5607 213249.9n 0.5607 213250.0n 0.5607 213499.9n 0.5607 213500.0n 0.5607 213749.9n 0.5607 213750.0n 0.5607 213999.9n 0.5607 214000.0n 0.5607 214249.9n 0.5607 214250.0n 0.5607 214499.9n 0.5607 214500.0n 0.5607 214749.9n 0.5607 214750.0n 0.5607 214999.9n 0.5607 215000.0n 0.5343 215249.9n 0.5343 215250.0n 0.5607 215499.9n 0.5607 215500.0n 0.5607 215749.9n 0.5607 215750.0n 0.5607 215999.9n 0.5607 216000.0n 0.5607 216249.9n 0.5607 216250.0n 0.5607 216499.9n 0.5607 216500.0n 0.5607 216749.9n 0.5607 216750.0n 0.5607 216999.9n 0.5607 217000.0n 0.5343 217249.9n 0.5343 217250.0n 0.5607 217499.9n 0.5607 217500.0n 0.5607 217749.9n 0.5607 217750.0n 0.5607 217999.9n 0.5607 218000.0n 0.5607 218249.9n 0.5607 218250.0n 0.5607 218499.9n 0.5607 218500.0n 0.5607 218749.9n 0.5607 218750.0n 0.5607 218999.9n 0.5607 219000.0n 0.5607 219249.9n 0.5607 219250.0n 0.5607 219499.9n 0.5607 219500.0n 0.5607 219749.9n 0.5607 219750.0n 0.5607 219999.9n 0.5607 220000.0n 0.5607 220249.9n 0.5607 220250.0n 0.4816 220499.9n 0.4816 220500.0n 0.5607 220749.9n 0.5607 220750.0n 0.5607 220999.9n 0.5607 221000.0n 0.5607 221249.9n 0.5607 221250.0n 0.5607 221499.9n 0.5607 221500.0n 0.5607 221749.9n 0.5607 221750.0n 0.5607 221999.9n 0.5607 222000.0n 0.5607 222249.9n 0.5607 222250.0n 0.5607 222499.9n 0.5607 222500.0n 0.5343 222749.9n 0.5343 222750.0n 0.5607 222999.9n 0.5607 223000.0n 0.5607 223249.9n 0.5607 223250.0n 0.5607 223499.9n 0.5607 223500.0n 0.5607 223749.9n 0.5607 223750.0n 0.5607 223999.9n 0.5607 224000.0n 0.5607 224249.9n 0.5607 224250.0n 0.5607 224499.9n 0.5607 224500.0n 0.5343 224749.9n 0.5343 224750.0n 0.5607 224999.9n 0.5607 225000.0n 0.5607 225249.9n 0.5607 225250.0n 0.5607 225499.9n 0.5607 225500.0n 0.5607 225749.9n 0.5607 225750.0n 0.5607 225999.9n 0.5607 226000.0n 0.5607 226249.9n 0.5607 226250.0n 0.5607 226499.9n 0.5607 226500.0n 0.5607 226749.9n 0.5607 226750.0n 0.5607 226999.9n 0.5607 227000.0n 0.5607 227249.9n 0.5607 227250.0n 0.5607 227499.9n 0.5607 227500.0n 0.5607 227749.9n 0.5607 227750.0n 0.4816 227999.9n 0.4816 228000.0n 0.5607 228249.9n 0.5607 228250.0n 0.5607 228499.9n 0.5607 228500.0n 0.5607 228749.9n 0.5607 228750.0n 0.5607 228999.9n 0.5607 229000.0n 0.5607 229249.9n 0.5607 229250.0n 0.5607 229499.9n 0.5607 229500.0n 0.5607 229749.9n 0.5607 229750.0n 0.5607 229999.9n 0.5607 230000.0n 0.5343 230249.9n 0.5343 230250.0n 0.5607 230499.9n 0.5607 230500.0n 0.5607 230749.9n 0.5607 230750.0n 0.5607 230999.9n 0.5607 231000.0n 0.5607 231249.9n 0.5607 231250.0n 0.5607 231499.9n 0.5607 231500.0n 0.5607 231749.9n 0.5607 231750.0n 0.5607 231999.9n 0.5607 232000.0n 0.5343 232249.9n 0.5343 232250.0n 0.5607 232499.9n 0.5607 232500.0n 0.5607 232749.9n 0.5607 232750.0n 0.5607 232999.9n 0.5607 233000.0n 0.5607 233249.9n 0.5607 233250.0n 0.5607 233499.9n 0.5607 233500.0n 0.5607 233749.9n 0.5607 233750.0n 0.5607 233999.9n 0.5607 234000.0n 0.5607 234249.9n 0.5607 234250.0n 0.5607 234499.9n 0.5607 234500.0n 0.5607 234749.9n 0.5607 234750.0n 0.5607 234999.9n 0.5607 235000.0n 0.5607 235249.9n 0.5607 235250.0n 0.4816 235499.9n 0.4816 235500.0n 0.5607 235749.9n 0.5607 235750.0n 0.5607 235999.9n 0.5607 236000.0n 0.5607 236249.9n 0.5607 236250.0n 0.5607 236499.9n 0.5607 236500.0n 0.5607 236749.9n 0.5607 236750.0n 0.5607 236999.9n 0.5607 237000.0n 0.5607 237249.9n 0.5607 237250.0n 0.5607 237499.9n 0.5607 237500.0n 0.5343 237749.9n 0.5343 237750.0n 0.5607 237999.9n 0.5607 238000.0n 0.5607 238249.9n 0.5607 238250.0n 0.5607 238499.9n 0.5607 238500.0n 0.5607 238749.9n 0.5607 238750.0n 0.5607 238999.9n 0.5607 239000.0n 0.5607 239249.9n 0.5607 239250.0n 0.5607 239499.9n 0.5607 239500.0n 0.5343 239749.9n 0.5343 239750.0n 0.5607 239999.9n 0.5607 240000.0n 0.5607 240249.9n 0.5607 240250.0n 0.5607 240499.9n 0.5607 240500.0n 0.5607 240749.9n 0.5607 240750.0n 0.5607 240999.9n 0.5607 241000.0n 0.5607 241249.9n 0.5607 241250.0n 0.5607 241499.9n 0.5607 241500.0n 0.5607 241749.9n 0.5607 241750.0n 0.5607 241999.9n 0.5607 242000.0n 0.5607 242249.9n 0.5607 242250.0n 0.5607 242499.9n 0.5607 242500.0n 0.5607 242749.9n 0.5607 242750.0n 0.4816 242999.9n 0.4816 243000.0n 0.5607 243249.9n 0.5607 243250.0n 0.5607 243499.9n 0.5607 243500.0n 0.5607 243749.9n 0.5607 243750.0n 0.5607 243999.9n 0.5607 244000.0n 0.5607 244249.9n 0.5607 244250.0n 0.5607 244499.9n 0.5607 244500.0n 0.5607 244749.9n 0.5607 244750.0n 0.5607 244999.9n 0.5607 245000.0n 0.5343 245249.9n 0.5343 245250.0n 0.5607 245499.9n 0.5607 245500.0n 0.5607 245749.9n 0.5607 245750.0n 0.5607 245999.9n 0.5607 246000.0n 0.5607 246249.9n 0.5607 246250.0n 0.5607 246499.9n 0.5607 246500.0n 0.5607 246749.9n 0.5607 246750.0n 0.5607 246999.9n 0.5607 247000.0n 0.5343 247249.9n 0.5343 247250.0n 0.5607 247499.9n 0.5607 247500.0n 0.5607 247749.9n 0.5607 247750.0n 0.5607 247999.9n 0.5607 248000.0n 0.5607 248249.9n 0.5607 248250.0n 0.5607 248499.9n 0.5607 248500.0n 0.5607 248749.9n 0.5607 248750.0n 0.5607 248999.9n 0.5607 249000.0n 0.5607 249249.9n 0.5607 249250.0n 0.5607 249499.9n 0.5607 249500.0n 0.5607 249749.9n 0.5607 249750.0n 0.5607 249999.9n 0.5607 250000.0n 0.5607 250249.9n 0.5607 250250.0n 0.4816 250499.9n 0.4816 250500.0n 0.5607 250749.9n 0.5607 250750.0n 0.5607 250999.9n 0.5607 251000.0n 0.5607 251249.9n 0.5607 251250.0n 0.5607 251499.9n 0.5607 251500.0n 0.5607 251749.9n 0.5607 251750.0n 0.5607 251999.9n 0.5607 252000.0n 0.5607 252249.9n 0.5607 252250.0n 0.5607 252499.9n 0.5607 252500.0n 0.5343 252749.9n 0.5343 252750.0n 0.5607 252999.9n 0.5607 253000.0n 0.5607 253249.9n 0.5607 253250.0n 0.5607 253499.9n 0.5607 253500.0n 0.5607 253749.9n 0.5607 253750.0n 0.5607 253999.9n 0.5607 254000.0n 0.5607 254249.9n 0.5607 254250.0n 0.5607 254499.9n 0.5607 254500.0n 0.5343 254749.9n 0.5343 254750.0n 0.5607 254999.9n 0.5607 255000.0n 0.5607 255249.9n 0.5607 255250.0n 0.5607 255499.9n 0.5607 255500.0n 0.5607 255749.9n 0.5607 255750.0n 0.5607 255999.9n 0.5607 256000.0n 0.5607 256249.9n 0.5607 256250.0n 0.5607 256499.9n 0.5607 256500.0n 0.5607 256749.9n 0.5607 256750.0n 0.5607 256999.9n 0.5607 257000.0n 0.5607 257249.9n 0.5607 257250.0n 0.5607 257499.9n 0.5607 257500.0n 0.5607 257749.9n 0.5607 257750.0n 0.4816 257999.9n 0.4816 258000.0n 0.5607 258249.9n 0.5607 258250.0n 0.5607 258499.9n 0.5607 258500.0n 0.5607 258749.9n 0.5607 258750.0n 0.5607 258999.9n 0.5607 259000.0n 0.5607 259249.9n 0.5607 259250.0n 0.5607 259499.9n 0.5607 259500.0n 0.5607 259749.9n 0.5607 259750.0n 0.5607 259999.9n 0.5607 260000.0n 0.5343 260249.9n 0.5343 260250.0n 0.5607 260499.9n 0.5607 260500.0n 0.5607 260749.9n 0.5607 260750.0n 0.5607 260999.9n 0.5607 261000.0n 0.5607 261249.9n 0.5607 261250.0n 0.5607 261499.9n 0.5607 261500.0n 0.5607 261749.9n 0.5607 261750.0n 0.5607 261999.9n 0.5607 262000.0n 0.5343 262249.9n 0.5343 262250.0n 0.5607 262499.9n 0.5607 262500.0n 0.5607 262749.9n 0.5607 262750.0n 0.5607 262999.9n 0.5607 263000.0n 0.5607 263249.9n 0.5607 263250.0n 0.5607 263499.9n 0.5607 263500.0n 0.5607 263749.9n 0.5607 263750.0n 0.5607 263999.9n 0.5607 264000.0n 0.5607 264249.9n 0.5607 264250.0n 0.5607 264499.9n 0.5607 264500.0n 0.5607 264749.9n 0.5607 264750.0n 0.5607 264999.9n 0.5607 265000.0n 0.5607 265249.9n 0.5607 265250.0n 0.4816 265499.9n 0.4816 265500.0n 0.5607 265749.9n 0.5607 265750.0n 0.5607 265999.9n 0.5607 266000.0n 0.5607 266249.9n 0.5607 266250.0n 0.5607 266499.9n 0.5607 266500.0n 0.5607 266749.9n 0.5607 266750.0n 0.5607 266999.9n 0.5607 267000.0n 0.5607 267249.9n 0.5607 267250.0n 0.5607 267499.9n 0.5607 267500.0n 0.5343 267749.9n 0.5343 267750.0n 0.5607 267999.9n 0.5607 268000.0n 0.5607 268249.9n 0.5607 268250.0n 0.5607 268499.9n 0.5607 268500.0n 0.5607 268749.9n 0.5607 268750.0n 0.5607 268999.9n 0.5607 269000.0n 0.5607 269249.9n 0.5607 269250.0n 0.5607 269499.9n 0.5607 269500.0n 0.5343 269749.9n 0.5343 269750.0n 0.5607 269999.9n 0.5607 270000.0n 0.5607 270249.9n 0.5607 270250.0n 0.5607 270499.9n 0.5607 270500.0n 0.5607 270749.9n 0.5607 270750.0n 0.5607 270999.9n 0.5607 271000.0n 0.5607 271249.9n 0.5607 271250.0n 0.5607 271499.9n 0.5607 271500.0n 0.5607 271749.9n 0.5607 271750.0n 0.5607 271999.9n 0.5607 272000.0n 0.5607 272249.9n 0.5607 272250.0n 0.5607 272499.9n 0.5607 272500.0n 0.5607 272749.9n 0.5607 272750.0n 0.4816 272999.9n 0.4816 273000.0n 0.5607 273249.9n 0.5607 273250.0n 0.5607 273499.9n 0.5607 273500.0n 0.5607 273749.9n 0.5607 273750.0n 0.5607 273999.9n 0.5607 274000.0n 0.5607 274249.9n 0.5607 274250.0n 0.5607 274499.9n 0.5607 274500.0n 0.5607 274749.9n 0.5607 274750.0n 0.5607 274999.9n 0.5607 275000.0n 0.5343 275249.9n 0.5343 275250.0n 0.5607 275499.9n 0.5607 275500.0n 0.5607 275749.9n 0.5607 275750.0n 0.5607 275999.9n 0.5607 276000.0n 0.5607 276249.9n 0.5607 276250.0n 0.5607 276499.9n 0.5607 276500.0n 0.5607 276749.9n 0.5607 276750.0n 0.5607 276999.9n 0.5607 277000.0n 0.5343 277249.9n 0.5343 277250.0n 0.5607 277499.9n 0.5607 277500.0n 0.5607 277749.9n 0.5607 277750.0n 0.5607 277999.9n 0.5607 278000.0n 0.5607 278249.9n 0.5607 278250.0n 0.5607 278499.9n 0.5607 278500.0n 0.5607 278749.9n 0.5607 278750.0n 0.5607 278999.9n 0.5607 279000.0n 0.5607 279249.9n 0.5607 279250.0n 0.5607 279499.9n 0.5607 279500.0n 0.5607 279749.9n 0.5607 279750.0n 0.5607 279999.9n 0.5607 280000.0n 0.5607 280249.9n 0.5607 280250.0n 0.4816 280499.9n 0.4816 280500.0n 0.5607 280749.9n 0.5607 280750.0n 0.5607 280999.9n 0.5607 281000.0n 0.5607 281249.9n 0.5607 281250.0n 0.5607 281499.9n 0.5607 281500.0n 0.5607 281749.9n 0.5607 281750.0n 0.5607 281999.9n 0.5607 282000.0n 0.5607 282249.9n 0.5607 282250.0n 0.5607 282499.9n 0.5607 282500.0n 0.5343 282749.9n 0.5343 282750.0n 0.5607 282999.9n 0.5607 283000.0n 0.5607 283249.9n 0.5607 283250.0n 0.5607 283499.9n 0.5607 283500.0n 0.5607 283749.9n 0.5607 283750.0n 0.5607 283999.9n 0.5607 284000.0n 0.5607 284249.9n 0.5607 284250.0n 0.5607 284499.9n 0.5607 284500.0n 0.5343 284749.9n 0.5343 284750.0n 0.5607 284999.9n 0.5607 285000.0n 0.5607 285249.9n 0.5607 285250.0n 0.5607 285499.9n 0.5607 285500.0n 0.5607 285749.9n 0.5607 285750.0n 0.5607 285999.9n 0.5607 286000.0n 0.5607 286249.9n 0.5607 286250.0n 0.5607 286499.9n 0.5607 286500.0n 0.5607 286749.9n 0.5607 286750.0n 0.5607 286999.9n 0.5607 287000.0n 0.5607 287249.9n 0.5607 287250.0n 0.5607 287499.9n 0.5607 287500.0n 0.5607 287749.9n 0.5607 287750.0n 0.4816 287999.9n 0.4816 288000.0n 0.5607 288249.9n 0.5607 288250.0n 0.5607 288499.9n 0.5607 288500.0n 0.5607 288749.9n 0.5607 288750.0n 0.5607 288999.9n 0.5607 289000.0n 0.5607 289249.9n 0.5607 289250.0n 0.5607 289499.9n 0.5607 289500.0n 0.5607 289749.9n 0.5607 289750.0n 0.5607 289999.9n 0.5607 290000.0n 0.5343 290249.9n 0.5343 290250.0n 0.5607 290499.9n 0.5607 290500.0n 0.5607 290749.9n 0.5607 290750.0n 0.5607 290999.9n 0.5607 291000.0n 0.5607 291249.9n 0.5607 291250.0n 0.5607 291499.9n 0.5607 291500.0n 0.5607 291749.9n 0.5607 291750.0n 0.5607 291999.9n 0.5607 292000.0n 0.5343 292249.9n 0.5343 292250.0n 0.5607 292499.9n 0.5607 292500.0n 0.5607 292749.9n 0.5607 292750.0n 0.5607 292999.9n 0.5607 293000.0n 0.5607 293249.9n 0.5607 293250.0n 0.5607 293499.9n 0.5607 293500.0n 0.5607 293749.9n 0.5607 293750.0n 0.5607 293999.9n 0.5607 294000.0n 0.5607 294249.9n 0.5607 294250.0n 0.5607 294499.9n 0.5607 294500.0n 0.5607 294749.9n 0.5607 294750.0n 0.5607 294999.9n 0.5607 295000.0n 0.5607 295249.9n 0.5607 295250.0n 0.4816 295499.9n 0.4816 295500.0n 0.5607 295749.9n 0.5607 295750.0n 0.5607 295999.9n 0.5607 296000.0n 0.5607 296249.9n 0.5607 296250.0n 0.5607 296499.9n 0.5607 296500.0n 0.5607 296749.9n 0.5607 296750.0n 0.5607 296999.9n 0.5607 297000.0n 0.5607 297249.9n 0.5607 297250.0n 0.5607 297499.9n 0.5607 297500.0n 0.5343 297749.9n 0.5343 297750.0n 0.5607 297999.9n 0.5607 298000.0n 0.5607 298249.9n 0.5607 298250.0n 0.5607 298499.9n 0.5607 298500.0n 0.5607 298749.9n 0.5607 298750.0n 0.5607 298999.9n 0.5607 299000.0n 0.5607 299249.9n 0.5607 299250.0n 0.5607 299499.9n 0.5607 299500.0n 0.5343 299749.9n 0.5343 299750.0n 0.5607)
Vxp1 a_xp1 0 PWL(0.0n 0.2133 249.9n 0.2133 250.0n 0.5372 499.9n 0.5372 500.0n 0.4886 749.9n 0.4886 750.0n 0.4724 999.9n 0.4724 1000.0n 0.5210 1249.9n 0.5210 1250.0n 0.2052 1499.9n 0.2052 1500.0n 0.4400 1749.9n 0.4400 1750.0n 0.2618 1999.9n 0.2618 2000.0n 0.4562 2249.9n 0.4562 2250.0n 0.6020 2499.9n 0.6020 2500.0n 0.5453 2749.9n 0.5453 2750.0n 0.5291 2999.9n 0.5291 3000.0n 0.2052 3249.9n 0.2052 3250.0n 0.4886 3499.9n 0.4886 3500.0n 0.4562 3749.9n 0.4562 3750.0n 0.5129 3999.9n 0.5129 4000.0n 0.2000 4249.9n 0.2000 4250.0n 0.5048 4499.9n 0.5048 4500.0n 0.5129 4749.9n 0.5129 4750.0n 0.4724 4999.9n 0.4724 5000.0n 0.5048 5249.9n 0.5048 5250.0n 0.2000 5499.9n 0.2000 5500.0n 0.4967 5749.9n 0.4967 5750.0n 0.4481 5999.9n 0.4481 6000.0n 0.2942 6249.9n 0.2942 6250.0n 0.5291 6499.9n 0.5291 6500.0n 0.3752 6749.9n 0.3752 6750.0n 0.5129 6999.9n 0.5129 7000.0n 0.6020 7249.9n 0.6020 7250.0n 0.5129 7499.9n 0.5129 7500.0n 0.2133 7749.9n 0.2133 7750.0n 0.5372 7999.9n 0.5372 8000.0n 0.4886 8249.9n 0.4886 8250.0n 0.4724 8499.9n 0.4724 8500.0n 0.5210 8749.9n 0.5210 8750.0n 0.2052 8999.9n 0.2052 9000.0n 0.4400 9249.9n 0.4400 9250.0n 0.2618 9499.9n 0.2618 9500.0n 0.4562 9749.9n 0.4562 9750.0n 0.6020 9999.9n 0.6020 10000.0n 0.5453 10249.9n 0.5453 10250.0n 0.5291 10499.9n 0.5291 10500.0n 0.2052 10749.9n 0.2052 10750.0n 0.4886 10999.9n 0.4886 11000.0n 0.4562 11249.9n 0.4562 11250.0n 0.5129 11499.9n 0.5129 11500.0n 0.2000 11749.9n 0.2000 11750.0n 0.5048 11999.9n 0.5048 12000.0n 0.5129 12249.9n 0.5129 12250.0n 0.4724 12499.9n 0.4724 12500.0n 0.5048 12749.9n 0.5048 12750.0n 0.2000 12999.9n 0.2000 13000.0n 0.4967 13249.9n 0.4967 13250.0n 0.4481 13499.9n 0.4481 13500.0n 0.2942 13749.9n 0.2942 13750.0n 0.5291 13999.9n 0.5291 14000.0n 0.3752 14249.9n 0.3752 14250.0n 0.5129 14499.9n 0.5129 14500.0n 0.6020 14749.9n 0.6020 14750.0n 0.5129 14999.9n 0.5129 15000.0n 0.2133 15249.9n 0.2133 15250.0n 0.5372 15499.9n 0.5372 15500.0n 0.4886 15749.9n 0.4886 15750.0n 0.4724 15999.9n 0.4724 16000.0n 0.5210 16249.9n 0.5210 16250.0n 0.2052 16499.9n 0.2052 16500.0n 0.4400 16749.9n 0.4400 16750.0n 0.2618 16999.9n 0.2618 17000.0n 0.4562 17249.9n 0.4562 17250.0n 0.6020 17499.9n 0.6020 17500.0n 0.5453 17749.9n 0.5453 17750.0n 0.5291 17999.9n 0.5291 18000.0n 0.2052 18249.9n 0.2052 18250.0n 0.4886 18499.9n 0.4886 18500.0n 0.4562 18749.9n 0.4562 18750.0n 0.5129 18999.9n 0.5129 19000.0n 0.2000 19249.9n 0.2000 19250.0n 0.5048 19499.9n 0.5048 19500.0n 0.5129 19749.9n 0.5129 19750.0n 0.4724 19999.9n 0.4724 20000.0n 0.5048 20249.9n 0.5048 20250.0n 0.2000 20499.9n 0.2000 20500.0n 0.4967 20749.9n 0.4967 20750.0n 0.4481 20999.9n 0.4481 21000.0n 0.2942 21249.9n 0.2942 21250.0n 0.5291 21499.9n 0.5291 21500.0n 0.3752 21749.9n 0.3752 21750.0n 0.5129 21999.9n 0.5129 22000.0n 0.6020 22249.9n 0.6020 22250.0n 0.5129 22499.9n 0.5129 22500.0n 0.2133 22749.9n 0.2133 22750.0n 0.5372 22999.9n 0.5372 23000.0n 0.4886 23249.9n 0.4886 23250.0n 0.4724 23499.9n 0.4724 23500.0n 0.5210 23749.9n 0.5210 23750.0n 0.2052 23999.9n 0.2052 24000.0n 0.4400 24249.9n 0.4400 24250.0n 0.2618 24499.9n 0.2618 24500.0n 0.4562 24749.9n 0.4562 24750.0n 0.6020 24999.9n 0.6020 25000.0n 0.5453 25249.9n 0.5453 25250.0n 0.5291 25499.9n 0.5291 25500.0n 0.2052 25749.9n 0.2052 25750.0n 0.4886 25999.9n 0.4886 26000.0n 0.4562 26249.9n 0.4562 26250.0n 0.5129 26499.9n 0.5129 26500.0n 0.2000 26749.9n 0.2000 26750.0n 0.5048 26999.9n 0.5048 27000.0n 0.5129 27249.9n 0.5129 27250.0n 0.4724 27499.9n 0.4724 27500.0n 0.5048 27749.9n 0.5048 27750.0n 0.2000 27999.9n 0.2000 28000.0n 0.4967 28249.9n 0.4967 28250.0n 0.4481 28499.9n 0.4481 28500.0n 0.2942 28749.9n 0.2942 28750.0n 0.5291 28999.9n 0.5291 29000.0n 0.3752 29249.9n 0.3752 29250.0n 0.5129 29499.9n 0.5129 29500.0n 0.6020 29749.9n 0.6020 29750.0n 0.5129 29999.9n 0.5129 30000.0n 0.2133 30249.9n 0.2133 30250.0n 0.5372 30499.9n 0.5372 30500.0n 0.4886 30749.9n 0.4886 30750.0n 0.4724 30999.9n 0.4724 31000.0n 0.5210 31249.9n 0.5210 31250.0n 0.2052 31499.9n 0.2052 31500.0n 0.4400 31749.9n 0.4400 31750.0n 0.2618 31999.9n 0.2618 32000.0n 0.4562 32249.9n 0.4562 32250.0n 0.6020 32499.9n 0.6020 32500.0n 0.5453 32749.9n 0.5453 32750.0n 0.5291 32999.9n 0.5291 33000.0n 0.2052 33249.9n 0.2052 33250.0n 0.4886 33499.9n 0.4886 33500.0n 0.4562 33749.9n 0.4562 33750.0n 0.5129 33999.9n 0.5129 34000.0n 0.2000 34249.9n 0.2000 34250.0n 0.5048 34499.9n 0.5048 34500.0n 0.5129 34749.9n 0.5129 34750.0n 0.4724 34999.9n 0.4724 35000.0n 0.5048 35249.9n 0.5048 35250.0n 0.2000 35499.9n 0.2000 35500.0n 0.4967 35749.9n 0.4967 35750.0n 0.4481 35999.9n 0.4481 36000.0n 0.2942 36249.9n 0.2942 36250.0n 0.5291 36499.9n 0.5291 36500.0n 0.3752 36749.9n 0.3752 36750.0n 0.5129 36999.9n 0.5129 37000.0n 0.6020 37249.9n 0.6020 37250.0n 0.5129 37499.9n 0.5129 37500.0n 0.2133 37749.9n 0.2133 37750.0n 0.5372 37999.9n 0.5372 38000.0n 0.4886 38249.9n 0.4886 38250.0n 0.4724 38499.9n 0.4724 38500.0n 0.5210 38749.9n 0.5210 38750.0n 0.2052 38999.9n 0.2052 39000.0n 0.4400 39249.9n 0.4400 39250.0n 0.2618 39499.9n 0.2618 39500.0n 0.4562 39749.9n 0.4562 39750.0n 0.6020 39999.9n 0.6020 40000.0n 0.5453 40249.9n 0.5453 40250.0n 0.5291 40499.9n 0.5291 40500.0n 0.2052 40749.9n 0.2052 40750.0n 0.4886 40999.9n 0.4886 41000.0n 0.4562 41249.9n 0.4562 41250.0n 0.5129 41499.9n 0.5129 41500.0n 0.2000 41749.9n 0.2000 41750.0n 0.5048 41999.9n 0.5048 42000.0n 0.5129 42249.9n 0.5129 42250.0n 0.4724 42499.9n 0.4724 42500.0n 0.5048 42749.9n 0.5048 42750.0n 0.2000 42999.9n 0.2000 43000.0n 0.4967 43249.9n 0.4967 43250.0n 0.4481 43499.9n 0.4481 43500.0n 0.2942 43749.9n 0.2942 43750.0n 0.5291 43999.9n 0.5291 44000.0n 0.3752 44249.9n 0.3752 44250.0n 0.5129 44499.9n 0.5129 44500.0n 0.6020 44749.9n 0.6020 44750.0n 0.5129 44999.9n 0.5129 45000.0n 0.2133 45249.9n 0.2133 45250.0n 0.5372 45499.9n 0.5372 45500.0n 0.4886 45749.9n 0.4886 45750.0n 0.4724 45999.9n 0.4724 46000.0n 0.5210 46249.9n 0.5210 46250.0n 0.2052 46499.9n 0.2052 46500.0n 0.4400 46749.9n 0.4400 46750.0n 0.2618 46999.9n 0.2618 47000.0n 0.4562 47249.9n 0.4562 47250.0n 0.6020 47499.9n 0.6020 47500.0n 0.5453 47749.9n 0.5453 47750.0n 0.5291 47999.9n 0.5291 48000.0n 0.2052 48249.9n 0.2052 48250.0n 0.4886 48499.9n 0.4886 48500.0n 0.4562 48749.9n 0.4562 48750.0n 0.5129 48999.9n 0.5129 49000.0n 0.2000 49249.9n 0.2000 49250.0n 0.5048 49499.9n 0.5048 49500.0n 0.5129 49749.9n 0.5129 49750.0n 0.4724 49999.9n 0.4724 50000.0n 0.5048 50249.9n 0.5048 50250.0n 0.2000 50499.9n 0.2000 50500.0n 0.4967 50749.9n 0.4967 50750.0n 0.4481 50999.9n 0.4481 51000.0n 0.2942 51249.9n 0.2942 51250.0n 0.5291 51499.9n 0.5291 51500.0n 0.3752 51749.9n 0.3752 51750.0n 0.5129 51999.9n 0.5129 52000.0n 0.6020 52249.9n 0.6020 52250.0n 0.5129 52499.9n 0.5129 52500.0n 0.2133 52749.9n 0.2133 52750.0n 0.5372 52999.9n 0.5372 53000.0n 0.4886 53249.9n 0.4886 53250.0n 0.4724 53499.9n 0.4724 53500.0n 0.5210 53749.9n 0.5210 53750.0n 0.2052 53999.9n 0.2052 54000.0n 0.4400 54249.9n 0.4400 54250.0n 0.2618 54499.9n 0.2618 54500.0n 0.4562 54749.9n 0.4562 54750.0n 0.6020 54999.9n 0.6020 55000.0n 0.5453 55249.9n 0.5453 55250.0n 0.5291 55499.9n 0.5291 55500.0n 0.2052 55749.9n 0.2052 55750.0n 0.4886 55999.9n 0.4886 56000.0n 0.4562 56249.9n 0.4562 56250.0n 0.5129 56499.9n 0.5129 56500.0n 0.2000 56749.9n 0.2000 56750.0n 0.5048 56999.9n 0.5048 57000.0n 0.5129 57249.9n 0.5129 57250.0n 0.4724 57499.9n 0.4724 57500.0n 0.5048 57749.9n 0.5048 57750.0n 0.2000 57999.9n 0.2000 58000.0n 0.4967 58249.9n 0.4967 58250.0n 0.4481 58499.9n 0.4481 58500.0n 0.2942 58749.9n 0.2942 58750.0n 0.5291 58999.9n 0.5291 59000.0n 0.3752 59249.9n 0.3752 59250.0n 0.5129 59499.9n 0.5129 59500.0n 0.6020 59749.9n 0.6020 59750.0n 0.5129 59999.9n 0.5129 60000.0n 0.2133 60249.9n 0.2133 60250.0n 0.5372 60499.9n 0.5372 60500.0n 0.4886 60749.9n 0.4886 60750.0n 0.4724 60999.9n 0.4724 61000.0n 0.5210 61249.9n 0.5210 61250.0n 0.2052 61499.9n 0.2052 61500.0n 0.4400 61749.9n 0.4400 61750.0n 0.2618 61999.9n 0.2618 62000.0n 0.4562 62249.9n 0.4562 62250.0n 0.6020 62499.9n 0.6020 62500.0n 0.5453 62749.9n 0.5453 62750.0n 0.5291 62999.9n 0.5291 63000.0n 0.2052 63249.9n 0.2052 63250.0n 0.4886 63499.9n 0.4886 63500.0n 0.4562 63749.9n 0.4562 63750.0n 0.5129 63999.9n 0.5129 64000.0n 0.2000 64249.9n 0.2000 64250.0n 0.5048 64499.9n 0.5048 64500.0n 0.5129 64749.9n 0.5129 64750.0n 0.4724 64999.9n 0.4724 65000.0n 0.5048 65249.9n 0.5048 65250.0n 0.2000 65499.9n 0.2000 65500.0n 0.4967 65749.9n 0.4967 65750.0n 0.4481 65999.9n 0.4481 66000.0n 0.2942 66249.9n 0.2942 66250.0n 0.5291 66499.9n 0.5291 66500.0n 0.3752 66749.9n 0.3752 66750.0n 0.5129 66999.9n 0.5129 67000.0n 0.6020 67249.9n 0.6020 67250.0n 0.5129 67499.9n 0.5129 67500.0n 0.2133 67749.9n 0.2133 67750.0n 0.5372 67999.9n 0.5372 68000.0n 0.4886 68249.9n 0.4886 68250.0n 0.4724 68499.9n 0.4724 68500.0n 0.5210 68749.9n 0.5210 68750.0n 0.2052 68999.9n 0.2052 69000.0n 0.4400 69249.9n 0.4400 69250.0n 0.2618 69499.9n 0.2618 69500.0n 0.4562 69749.9n 0.4562 69750.0n 0.6020 69999.9n 0.6020 70000.0n 0.5453 70249.9n 0.5453 70250.0n 0.5291 70499.9n 0.5291 70500.0n 0.2052 70749.9n 0.2052 70750.0n 0.4886 70999.9n 0.4886 71000.0n 0.4562 71249.9n 0.4562 71250.0n 0.5129 71499.9n 0.5129 71500.0n 0.2000 71749.9n 0.2000 71750.0n 0.5048 71999.9n 0.5048 72000.0n 0.5129 72249.9n 0.5129 72250.0n 0.4724 72499.9n 0.4724 72500.0n 0.5048 72749.9n 0.5048 72750.0n 0.2000 72999.9n 0.2000 73000.0n 0.4967 73249.9n 0.4967 73250.0n 0.4481 73499.9n 0.4481 73500.0n 0.2942 73749.9n 0.2942 73750.0n 0.5291 73999.9n 0.5291 74000.0n 0.3752 74249.9n 0.3752 74250.0n 0.5129 74499.9n 0.5129 74500.0n 0.6020 74749.9n 0.6020 74750.0n 0.5129 74999.9n 0.5129 75000.0n 0.2133 75249.9n 0.2133 75250.0n 0.5372 75499.9n 0.5372 75500.0n 0.4886 75749.9n 0.4886 75750.0n 0.4724 75999.9n 0.4724 76000.0n 0.5210 76249.9n 0.5210 76250.0n 0.2052 76499.9n 0.2052 76500.0n 0.4400 76749.9n 0.4400 76750.0n 0.2618 76999.9n 0.2618 77000.0n 0.4562 77249.9n 0.4562 77250.0n 0.6020 77499.9n 0.6020 77500.0n 0.5453 77749.9n 0.5453 77750.0n 0.5291 77999.9n 0.5291 78000.0n 0.2052 78249.9n 0.2052 78250.0n 0.4886 78499.9n 0.4886 78500.0n 0.4562 78749.9n 0.4562 78750.0n 0.5129 78999.9n 0.5129 79000.0n 0.2000 79249.9n 0.2000 79250.0n 0.5048 79499.9n 0.5048 79500.0n 0.5129 79749.9n 0.5129 79750.0n 0.4724 79999.9n 0.4724 80000.0n 0.5048 80249.9n 0.5048 80250.0n 0.2000 80499.9n 0.2000 80500.0n 0.4967 80749.9n 0.4967 80750.0n 0.4481 80999.9n 0.4481 81000.0n 0.2942 81249.9n 0.2942 81250.0n 0.5291 81499.9n 0.5291 81500.0n 0.3752 81749.9n 0.3752 81750.0n 0.5129 81999.9n 0.5129 82000.0n 0.6020 82249.9n 0.6020 82250.0n 0.5129 82499.9n 0.5129 82500.0n 0.2133 82749.9n 0.2133 82750.0n 0.5372 82999.9n 0.5372 83000.0n 0.4886 83249.9n 0.4886 83250.0n 0.4724 83499.9n 0.4724 83500.0n 0.5210 83749.9n 0.5210 83750.0n 0.2052 83999.9n 0.2052 84000.0n 0.4400 84249.9n 0.4400 84250.0n 0.2618 84499.9n 0.2618 84500.0n 0.4562 84749.9n 0.4562 84750.0n 0.6020 84999.9n 0.6020 85000.0n 0.5453 85249.9n 0.5453 85250.0n 0.5291 85499.9n 0.5291 85500.0n 0.2052 85749.9n 0.2052 85750.0n 0.4886 85999.9n 0.4886 86000.0n 0.4562 86249.9n 0.4562 86250.0n 0.5129 86499.9n 0.5129 86500.0n 0.2000 86749.9n 0.2000 86750.0n 0.5048 86999.9n 0.5048 87000.0n 0.5129 87249.9n 0.5129 87250.0n 0.4724 87499.9n 0.4724 87500.0n 0.5048 87749.9n 0.5048 87750.0n 0.2000 87999.9n 0.2000 88000.0n 0.4967 88249.9n 0.4967 88250.0n 0.4481 88499.9n 0.4481 88500.0n 0.2942 88749.9n 0.2942 88750.0n 0.5291 88999.9n 0.5291 89000.0n 0.3752 89249.9n 0.3752 89250.0n 0.5129 89499.9n 0.5129 89500.0n 0.6020 89749.9n 0.6020 89750.0n 0.5129 89999.9n 0.5129 90000.0n 0.2133 90249.9n 0.2133 90250.0n 0.5372 90499.9n 0.5372 90500.0n 0.4886 90749.9n 0.4886 90750.0n 0.4724 90999.9n 0.4724 91000.0n 0.5210 91249.9n 0.5210 91250.0n 0.2052 91499.9n 0.2052 91500.0n 0.4400 91749.9n 0.4400 91750.0n 0.2618 91999.9n 0.2618 92000.0n 0.4562 92249.9n 0.4562 92250.0n 0.6020 92499.9n 0.6020 92500.0n 0.5453 92749.9n 0.5453 92750.0n 0.5291 92999.9n 0.5291 93000.0n 0.2052 93249.9n 0.2052 93250.0n 0.4886 93499.9n 0.4886 93500.0n 0.4562 93749.9n 0.4562 93750.0n 0.5129 93999.9n 0.5129 94000.0n 0.2000 94249.9n 0.2000 94250.0n 0.5048 94499.9n 0.5048 94500.0n 0.5129 94749.9n 0.5129 94750.0n 0.4724 94999.9n 0.4724 95000.0n 0.5048 95249.9n 0.5048 95250.0n 0.2000 95499.9n 0.2000 95500.0n 0.4967 95749.9n 0.4967 95750.0n 0.4481 95999.9n 0.4481 96000.0n 0.2942 96249.9n 0.2942 96250.0n 0.5291 96499.9n 0.5291 96500.0n 0.3752 96749.9n 0.3752 96750.0n 0.5129 96999.9n 0.5129 97000.0n 0.6020 97249.9n 0.6020 97250.0n 0.5129 97499.9n 0.5129 97500.0n 0.2133 97749.9n 0.2133 97750.0n 0.5372 97999.9n 0.5372 98000.0n 0.4886 98249.9n 0.4886 98250.0n 0.4724 98499.9n 0.4724 98500.0n 0.5210 98749.9n 0.5210 98750.0n 0.2052 98999.9n 0.2052 99000.0n 0.4400 99249.9n 0.4400 99250.0n 0.2618 99499.9n 0.2618 99500.0n 0.4562 99749.9n 0.4562 99750.0n 0.6020 99999.9n 0.6020 100000.0n 0.5453 100249.9n 0.5453 100250.0n 0.5291 100499.9n 0.5291 100500.0n 0.2052 100749.9n 0.2052 100750.0n 0.4886 100999.9n 0.4886 101000.0n 0.4562 101249.9n 0.4562 101250.0n 0.5129 101499.9n 0.5129 101500.0n 0.2000 101749.9n 0.2000 101750.0n 0.5048 101999.9n 0.5048 102000.0n 0.5129 102249.9n 0.5129 102250.0n 0.4724 102499.9n 0.4724 102500.0n 0.5048 102749.9n 0.5048 102750.0n 0.2000 102999.9n 0.2000 103000.0n 0.4967 103249.9n 0.4967 103250.0n 0.4481 103499.9n 0.4481 103500.0n 0.2942 103749.9n 0.2942 103750.0n 0.5291 103999.9n 0.5291 104000.0n 0.3752 104249.9n 0.3752 104250.0n 0.5129 104499.9n 0.5129 104500.0n 0.6020 104749.9n 0.6020 104750.0n 0.5129 104999.9n 0.5129 105000.0n 0.2133 105249.9n 0.2133 105250.0n 0.5372 105499.9n 0.5372 105500.0n 0.4886 105749.9n 0.4886 105750.0n 0.4724 105999.9n 0.4724 106000.0n 0.5210 106249.9n 0.5210 106250.0n 0.2052 106499.9n 0.2052 106500.0n 0.4400 106749.9n 0.4400 106750.0n 0.2618 106999.9n 0.2618 107000.0n 0.4562 107249.9n 0.4562 107250.0n 0.6020 107499.9n 0.6020 107500.0n 0.5453 107749.9n 0.5453 107750.0n 0.5291 107999.9n 0.5291 108000.0n 0.2052 108249.9n 0.2052 108250.0n 0.4886 108499.9n 0.4886 108500.0n 0.4562 108749.9n 0.4562 108750.0n 0.5129 108999.9n 0.5129 109000.0n 0.2000 109249.9n 0.2000 109250.0n 0.5048 109499.9n 0.5048 109500.0n 0.5129 109749.9n 0.5129 109750.0n 0.4724 109999.9n 0.4724 110000.0n 0.5048 110249.9n 0.5048 110250.0n 0.2000 110499.9n 0.2000 110500.0n 0.4967 110749.9n 0.4967 110750.0n 0.4481 110999.9n 0.4481 111000.0n 0.2942 111249.9n 0.2942 111250.0n 0.5291 111499.9n 0.5291 111500.0n 0.3752 111749.9n 0.3752 111750.0n 0.5129 111999.9n 0.5129 112000.0n 0.6020 112249.9n 0.6020 112250.0n 0.5129 112499.9n 0.5129 112500.0n 0.2133 112749.9n 0.2133 112750.0n 0.5372 112999.9n 0.5372 113000.0n 0.4886 113249.9n 0.4886 113250.0n 0.4724 113499.9n 0.4724 113500.0n 0.5210 113749.9n 0.5210 113750.0n 0.2052 113999.9n 0.2052 114000.0n 0.4400 114249.9n 0.4400 114250.0n 0.2618 114499.9n 0.2618 114500.0n 0.4562 114749.9n 0.4562 114750.0n 0.6020 114999.9n 0.6020 115000.0n 0.5453 115249.9n 0.5453 115250.0n 0.5291 115499.9n 0.5291 115500.0n 0.2052 115749.9n 0.2052 115750.0n 0.4886 115999.9n 0.4886 116000.0n 0.4562 116249.9n 0.4562 116250.0n 0.5129 116499.9n 0.5129 116500.0n 0.2000 116749.9n 0.2000 116750.0n 0.5048 116999.9n 0.5048 117000.0n 0.5129 117249.9n 0.5129 117250.0n 0.4724 117499.9n 0.4724 117500.0n 0.5048 117749.9n 0.5048 117750.0n 0.2000 117999.9n 0.2000 118000.0n 0.4967 118249.9n 0.4967 118250.0n 0.4481 118499.9n 0.4481 118500.0n 0.2942 118749.9n 0.2942 118750.0n 0.5291 118999.9n 0.5291 119000.0n 0.3752 119249.9n 0.3752 119250.0n 0.5129 119499.9n 0.5129 119500.0n 0.6020 119749.9n 0.6020 119750.0n 0.5129 119999.9n 0.5129 120000.0n 0.2133 120249.9n 0.2133 120250.0n 0.5372 120499.9n 0.5372 120500.0n 0.4886 120749.9n 0.4886 120750.0n 0.4724 120999.9n 0.4724 121000.0n 0.5210 121249.9n 0.5210 121250.0n 0.2052 121499.9n 0.2052 121500.0n 0.4400 121749.9n 0.4400 121750.0n 0.2618 121999.9n 0.2618 122000.0n 0.4562 122249.9n 0.4562 122250.0n 0.6020 122499.9n 0.6020 122500.0n 0.5453 122749.9n 0.5453 122750.0n 0.5291 122999.9n 0.5291 123000.0n 0.2052 123249.9n 0.2052 123250.0n 0.4886 123499.9n 0.4886 123500.0n 0.4562 123749.9n 0.4562 123750.0n 0.5129 123999.9n 0.5129 124000.0n 0.2000 124249.9n 0.2000 124250.0n 0.5048 124499.9n 0.5048 124500.0n 0.5129 124749.9n 0.5129 124750.0n 0.4724 124999.9n 0.4724 125000.0n 0.5048 125249.9n 0.5048 125250.0n 0.2000 125499.9n 0.2000 125500.0n 0.4967 125749.9n 0.4967 125750.0n 0.4481 125999.9n 0.4481 126000.0n 0.2942 126249.9n 0.2942 126250.0n 0.5291 126499.9n 0.5291 126500.0n 0.3752 126749.9n 0.3752 126750.0n 0.5129 126999.9n 0.5129 127000.0n 0.6020 127249.9n 0.6020 127250.0n 0.5129 127499.9n 0.5129 127500.0n 0.2133 127749.9n 0.2133 127750.0n 0.5372 127999.9n 0.5372 128000.0n 0.4886 128249.9n 0.4886 128250.0n 0.4724 128499.9n 0.4724 128500.0n 0.5210 128749.9n 0.5210 128750.0n 0.2052 128999.9n 0.2052 129000.0n 0.4400 129249.9n 0.4400 129250.0n 0.2618 129499.9n 0.2618 129500.0n 0.4562 129749.9n 0.4562 129750.0n 0.6020 129999.9n 0.6020 130000.0n 0.5453 130249.9n 0.5453 130250.0n 0.5291 130499.9n 0.5291 130500.0n 0.2052 130749.9n 0.2052 130750.0n 0.4886 130999.9n 0.4886 131000.0n 0.4562 131249.9n 0.4562 131250.0n 0.5129 131499.9n 0.5129 131500.0n 0.2000 131749.9n 0.2000 131750.0n 0.5048 131999.9n 0.5048 132000.0n 0.5129 132249.9n 0.5129 132250.0n 0.4724 132499.9n 0.4724 132500.0n 0.5048 132749.9n 0.5048 132750.0n 0.2000 132999.9n 0.2000 133000.0n 0.4967 133249.9n 0.4967 133250.0n 0.4481 133499.9n 0.4481 133500.0n 0.2942 133749.9n 0.2942 133750.0n 0.5291 133999.9n 0.5291 134000.0n 0.3752 134249.9n 0.3752 134250.0n 0.5129 134499.9n 0.5129 134500.0n 0.6020 134749.9n 0.6020 134750.0n 0.5129 134999.9n 0.5129 135000.0n 0.2133 135249.9n 0.2133 135250.0n 0.5372 135499.9n 0.5372 135500.0n 0.4886 135749.9n 0.4886 135750.0n 0.4724 135999.9n 0.4724 136000.0n 0.5210 136249.9n 0.5210 136250.0n 0.2052 136499.9n 0.2052 136500.0n 0.4400 136749.9n 0.4400 136750.0n 0.2618 136999.9n 0.2618 137000.0n 0.4562 137249.9n 0.4562 137250.0n 0.6020 137499.9n 0.6020 137500.0n 0.5453 137749.9n 0.5453 137750.0n 0.5291 137999.9n 0.5291 138000.0n 0.2052 138249.9n 0.2052 138250.0n 0.4886 138499.9n 0.4886 138500.0n 0.4562 138749.9n 0.4562 138750.0n 0.5129 138999.9n 0.5129 139000.0n 0.2000 139249.9n 0.2000 139250.0n 0.5048 139499.9n 0.5048 139500.0n 0.5129 139749.9n 0.5129 139750.0n 0.4724 139999.9n 0.4724 140000.0n 0.5048 140249.9n 0.5048 140250.0n 0.2000 140499.9n 0.2000 140500.0n 0.4967 140749.9n 0.4967 140750.0n 0.4481 140999.9n 0.4481 141000.0n 0.2942 141249.9n 0.2942 141250.0n 0.5291 141499.9n 0.5291 141500.0n 0.3752 141749.9n 0.3752 141750.0n 0.5129 141999.9n 0.5129 142000.0n 0.6020 142249.9n 0.6020 142250.0n 0.5129 142499.9n 0.5129 142500.0n 0.2133 142749.9n 0.2133 142750.0n 0.5372 142999.9n 0.5372 143000.0n 0.4886 143249.9n 0.4886 143250.0n 0.4724 143499.9n 0.4724 143500.0n 0.5210 143749.9n 0.5210 143750.0n 0.2052 143999.9n 0.2052 144000.0n 0.4400 144249.9n 0.4400 144250.0n 0.2618 144499.9n 0.2618 144500.0n 0.4562 144749.9n 0.4562 144750.0n 0.6020 144999.9n 0.6020 145000.0n 0.5453 145249.9n 0.5453 145250.0n 0.5291 145499.9n 0.5291 145500.0n 0.2052 145749.9n 0.2052 145750.0n 0.4886 145999.9n 0.4886 146000.0n 0.4562 146249.9n 0.4562 146250.0n 0.5129 146499.9n 0.5129 146500.0n 0.2000 146749.9n 0.2000 146750.0n 0.5048 146999.9n 0.5048 147000.0n 0.5129 147249.9n 0.5129 147250.0n 0.4724 147499.9n 0.4724 147500.0n 0.5048 147749.9n 0.5048 147750.0n 0.2000 147999.9n 0.2000 148000.0n 0.4967 148249.9n 0.4967 148250.0n 0.4481 148499.9n 0.4481 148500.0n 0.2942 148749.9n 0.2942 148750.0n 0.5291 148999.9n 0.5291 149000.0n 0.3752 149249.9n 0.3752 149250.0n 0.5129 149499.9n 0.5129 149500.0n 0.6020 149749.9n 0.6020 149750.0n 0.5129 149999.9n 0.5129 150000.0n 0.2133 150249.9n 0.2133 150250.0n 0.5372 150499.9n 0.5372 150500.0n 0.4886 150749.9n 0.4886 150750.0n 0.4724 150999.9n 0.4724 151000.0n 0.5210 151249.9n 0.5210 151250.0n 0.2052 151499.9n 0.2052 151500.0n 0.4400 151749.9n 0.4400 151750.0n 0.2618 151999.9n 0.2618 152000.0n 0.4562 152249.9n 0.4562 152250.0n 0.6020 152499.9n 0.6020 152500.0n 0.5453 152749.9n 0.5453 152750.0n 0.5291 152999.9n 0.5291 153000.0n 0.2052 153249.9n 0.2052 153250.0n 0.4886 153499.9n 0.4886 153500.0n 0.4562 153749.9n 0.4562 153750.0n 0.5129 153999.9n 0.5129 154000.0n 0.2000 154249.9n 0.2000 154250.0n 0.5048 154499.9n 0.5048 154500.0n 0.5129 154749.9n 0.5129 154750.0n 0.4724 154999.9n 0.4724 155000.0n 0.5048 155249.9n 0.5048 155250.0n 0.2000 155499.9n 0.2000 155500.0n 0.4967 155749.9n 0.4967 155750.0n 0.4481 155999.9n 0.4481 156000.0n 0.2942 156249.9n 0.2942 156250.0n 0.5291 156499.9n 0.5291 156500.0n 0.3752 156749.9n 0.3752 156750.0n 0.5129 156999.9n 0.5129 157000.0n 0.6020 157249.9n 0.6020 157250.0n 0.5129 157499.9n 0.5129 157500.0n 0.2133 157749.9n 0.2133 157750.0n 0.5372 157999.9n 0.5372 158000.0n 0.4886 158249.9n 0.4886 158250.0n 0.4724 158499.9n 0.4724 158500.0n 0.5210 158749.9n 0.5210 158750.0n 0.2052 158999.9n 0.2052 159000.0n 0.4400 159249.9n 0.4400 159250.0n 0.2618 159499.9n 0.2618 159500.0n 0.4562 159749.9n 0.4562 159750.0n 0.6020 159999.9n 0.6020 160000.0n 0.5453 160249.9n 0.5453 160250.0n 0.5291 160499.9n 0.5291 160500.0n 0.2052 160749.9n 0.2052 160750.0n 0.4886 160999.9n 0.4886 161000.0n 0.4562 161249.9n 0.4562 161250.0n 0.5129 161499.9n 0.5129 161500.0n 0.2000 161749.9n 0.2000 161750.0n 0.5048 161999.9n 0.5048 162000.0n 0.5129 162249.9n 0.5129 162250.0n 0.4724 162499.9n 0.4724 162500.0n 0.5048 162749.9n 0.5048 162750.0n 0.2000 162999.9n 0.2000 163000.0n 0.4967 163249.9n 0.4967 163250.0n 0.4481 163499.9n 0.4481 163500.0n 0.2942 163749.9n 0.2942 163750.0n 0.5291 163999.9n 0.5291 164000.0n 0.3752 164249.9n 0.3752 164250.0n 0.5129 164499.9n 0.5129 164500.0n 0.6020 164749.9n 0.6020 164750.0n 0.5129 164999.9n 0.5129 165000.0n 0.2133 165249.9n 0.2133 165250.0n 0.5372 165499.9n 0.5372 165500.0n 0.4886 165749.9n 0.4886 165750.0n 0.4724 165999.9n 0.4724 166000.0n 0.5210 166249.9n 0.5210 166250.0n 0.2052 166499.9n 0.2052 166500.0n 0.4400 166749.9n 0.4400 166750.0n 0.2618 166999.9n 0.2618 167000.0n 0.4562 167249.9n 0.4562 167250.0n 0.6020 167499.9n 0.6020 167500.0n 0.5453 167749.9n 0.5453 167750.0n 0.5291 167999.9n 0.5291 168000.0n 0.2052 168249.9n 0.2052 168250.0n 0.4886 168499.9n 0.4886 168500.0n 0.4562 168749.9n 0.4562 168750.0n 0.5129 168999.9n 0.5129 169000.0n 0.2000 169249.9n 0.2000 169250.0n 0.5048 169499.9n 0.5048 169500.0n 0.5129 169749.9n 0.5129 169750.0n 0.4724 169999.9n 0.4724 170000.0n 0.5048 170249.9n 0.5048 170250.0n 0.2000 170499.9n 0.2000 170500.0n 0.4967 170749.9n 0.4967 170750.0n 0.4481 170999.9n 0.4481 171000.0n 0.2942 171249.9n 0.2942 171250.0n 0.5291 171499.9n 0.5291 171500.0n 0.3752 171749.9n 0.3752 171750.0n 0.5129 171999.9n 0.5129 172000.0n 0.6020 172249.9n 0.6020 172250.0n 0.5129 172499.9n 0.5129 172500.0n 0.2133 172749.9n 0.2133 172750.0n 0.5372 172999.9n 0.5372 173000.0n 0.4886 173249.9n 0.4886 173250.0n 0.4724 173499.9n 0.4724 173500.0n 0.5210 173749.9n 0.5210 173750.0n 0.2052 173999.9n 0.2052 174000.0n 0.4400 174249.9n 0.4400 174250.0n 0.2618 174499.9n 0.2618 174500.0n 0.4562 174749.9n 0.4562 174750.0n 0.6020 174999.9n 0.6020 175000.0n 0.5453 175249.9n 0.5453 175250.0n 0.5291 175499.9n 0.5291 175500.0n 0.2052 175749.9n 0.2052 175750.0n 0.4886 175999.9n 0.4886 176000.0n 0.4562 176249.9n 0.4562 176250.0n 0.5129 176499.9n 0.5129 176500.0n 0.2000 176749.9n 0.2000 176750.0n 0.5048 176999.9n 0.5048 177000.0n 0.5129 177249.9n 0.5129 177250.0n 0.4724 177499.9n 0.4724 177500.0n 0.5048 177749.9n 0.5048 177750.0n 0.2000 177999.9n 0.2000 178000.0n 0.4967 178249.9n 0.4967 178250.0n 0.4481 178499.9n 0.4481 178500.0n 0.2942 178749.9n 0.2942 178750.0n 0.5291 178999.9n 0.5291 179000.0n 0.3752 179249.9n 0.3752 179250.0n 0.5129 179499.9n 0.5129 179500.0n 0.6020 179749.9n 0.6020 179750.0n 0.5129 179999.9n 0.5129 180000.0n 0.2133 180249.9n 0.2133 180250.0n 0.5372 180499.9n 0.5372 180500.0n 0.4886 180749.9n 0.4886 180750.0n 0.4724 180999.9n 0.4724 181000.0n 0.5210 181249.9n 0.5210 181250.0n 0.2052 181499.9n 0.2052 181500.0n 0.4400 181749.9n 0.4400 181750.0n 0.2618 181999.9n 0.2618 182000.0n 0.4562 182249.9n 0.4562 182250.0n 0.6020 182499.9n 0.6020 182500.0n 0.5453 182749.9n 0.5453 182750.0n 0.5291 182999.9n 0.5291 183000.0n 0.2052 183249.9n 0.2052 183250.0n 0.4886 183499.9n 0.4886 183500.0n 0.4562 183749.9n 0.4562 183750.0n 0.5129 183999.9n 0.5129 184000.0n 0.2000 184249.9n 0.2000 184250.0n 0.5048 184499.9n 0.5048 184500.0n 0.5129 184749.9n 0.5129 184750.0n 0.4724 184999.9n 0.4724 185000.0n 0.5048 185249.9n 0.5048 185250.0n 0.2000 185499.9n 0.2000 185500.0n 0.4967 185749.9n 0.4967 185750.0n 0.4481 185999.9n 0.4481 186000.0n 0.2942 186249.9n 0.2942 186250.0n 0.5291 186499.9n 0.5291 186500.0n 0.3752 186749.9n 0.3752 186750.0n 0.5129 186999.9n 0.5129 187000.0n 0.6020 187249.9n 0.6020 187250.0n 0.5129 187499.9n 0.5129 187500.0n 0.2133 187749.9n 0.2133 187750.0n 0.5372 187999.9n 0.5372 188000.0n 0.4886 188249.9n 0.4886 188250.0n 0.4724 188499.9n 0.4724 188500.0n 0.5210 188749.9n 0.5210 188750.0n 0.2052 188999.9n 0.2052 189000.0n 0.4400 189249.9n 0.4400 189250.0n 0.2618 189499.9n 0.2618 189500.0n 0.4562 189749.9n 0.4562 189750.0n 0.6020 189999.9n 0.6020 190000.0n 0.5453 190249.9n 0.5453 190250.0n 0.5291 190499.9n 0.5291 190500.0n 0.2052 190749.9n 0.2052 190750.0n 0.4886 190999.9n 0.4886 191000.0n 0.4562 191249.9n 0.4562 191250.0n 0.5129 191499.9n 0.5129 191500.0n 0.2000 191749.9n 0.2000 191750.0n 0.5048 191999.9n 0.5048 192000.0n 0.5129 192249.9n 0.5129 192250.0n 0.4724 192499.9n 0.4724 192500.0n 0.5048 192749.9n 0.5048 192750.0n 0.2000 192999.9n 0.2000 193000.0n 0.4967 193249.9n 0.4967 193250.0n 0.4481 193499.9n 0.4481 193500.0n 0.2942 193749.9n 0.2942 193750.0n 0.5291 193999.9n 0.5291 194000.0n 0.3752 194249.9n 0.3752 194250.0n 0.5129 194499.9n 0.5129 194500.0n 0.6020 194749.9n 0.6020 194750.0n 0.5129 194999.9n 0.5129 195000.0n 0.2133 195249.9n 0.2133 195250.0n 0.5372 195499.9n 0.5372 195500.0n 0.4886 195749.9n 0.4886 195750.0n 0.4724 195999.9n 0.4724 196000.0n 0.5210 196249.9n 0.5210 196250.0n 0.2052 196499.9n 0.2052 196500.0n 0.4400 196749.9n 0.4400 196750.0n 0.2618 196999.9n 0.2618 197000.0n 0.4562 197249.9n 0.4562 197250.0n 0.6020 197499.9n 0.6020 197500.0n 0.5453 197749.9n 0.5453 197750.0n 0.5291 197999.9n 0.5291 198000.0n 0.2052 198249.9n 0.2052 198250.0n 0.4886 198499.9n 0.4886 198500.0n 0.4562 198749.9n 0.4562 198750.0n 0.5129 198999.9n 0.5129 199000.0n 0.2000 199249.9n 0.2000 199250.0n 0.5048 199499.9n 0.5048 199500.0n 0.5129 199749.9n 0.5129 199750.0n 0.4724 199999.9n 0.4724 200000.0n 0.5048 200249.9n 0.5048 200250.0n 0.2000 200499.9n 0.2000 200500.0n 0.4967 200749.9n 0.4967 200750.0n 0.4481 200999.9n 0.4481 201000.0n 0.2942 201249.9n 0.2942 201250.0n 0.5291 201499.9n 0.5291 201500.0n 0.3752 201749.9n 0.3752 201750.0n 0.5129 201999.9n 0.5129 202000.0n 0.6020 202249.9n 0.6020 202250.0n 0.5129 202499.9n 0.5129 202500.0n 0.2133 202749.9n 0.2133 202750.0n 0.5372 202999.9n 0.5372 203000.0n 0.4886 203249.9n 0.4886 203250.0n 0.4724 203499.9n 0.4724 203500.0n 0.5210 203749.9n 0.5210 203750.0n 0.2052 203999.9n 0.2052 204000.0n 0.4400 204249.9n 0.4400 204250.0n 0.2618 204499.9n 0.2618 204500.0n 0.4562 204749.9n 0.4562 204750.0n 0.6020 204999.9n 0.6020 205000.0n 0.5453 205249.9n 0.5453 205250.0n 0.5291 205499.9n 0.5291 205500.0n 0.2052 205749.9n 0.2052 205750.0n 0.4886 205999.9n 0.4886 206000.0n 0.4562 206249.9n 0.4562 206250.0n 0.5129 206499.9n 0.5129 206500.0n 0.2000 206749.9n 0.2000 206750.0n 0.5048 206999.9n 0.5048 207000.0n 0.5129 207249.9n 0.5129 207250.0n 0.4724 207499.9n 0.4724 207500.0n 0.5048 207749.9n 0.5048 207750.0n 0.2000 207999.9n 0.2000 208000.0n 0.4967 208249.9n 0.4967 208250.0n 0.4481 208499.9n 0.4481 208500.0n 0.2942 208749.9n 0.2942 208750.0n 0.5291 208999.9n 0.5291 209000.0n 0.3752 209249.9n 0.3752 209250.0n 0.5129 209499.9n 0.5129 209500.0n 0.6020 209749.9n 0.6020 209750.0n 0.5129 209999.9n 0.5129 210000.0n 0.2133 210249.9n 0.2133 210250.0n 0.5372 210499.9n 0.5372 210500.0n 0.4886 210749.9n 0.4886 210750.0n 0.4724 210999.9n 0.4724 211000.0n 0.5210 211249.9n 0.5210 211250.0n 0.2052 211499.9n 0.2052 211500.0n 0.4400 211749.9n 0.4400 211750.0n 0.2618 211999.9n 0.2618 212000.0n 0.4562 212249.9n 0.4562 212250.0n 0.6020 212499.9n 0.6020 212500.0n 0.5453 212749.9n 0.5453 212750.0n 0.5291 212999.9n 0.5291 213000.0n 0.2052 213249.9n 0.2052 213250.0n 0.4886 213499.9n 0.4886 213500.0n 0.4562 213749.9n 0.4562 213750.0n 0.5129 213999.9n 0.5129 214000.0n 0.2000 214249.9n 0.2000 214250.0n 0.5048 214499.9n 0.5048 214500.0n 0.5129 214749.9n 0.5129 214750.0n 0.4724 214999.9n 0.4724 215000.0n 0.5048 215249.9n 0.5048 215250.0n 0.2000 215499.9n 0.2000 215500.0n 0.4967 215749.9n 0.4967 215750.0n 0.4481 215999.9n 0.4481 216000.0n 0.2942 216249.9n 0.2942 216250.0n 0.5291 216499.9n 0.5291 216500.0n 0.3752 216749.9n 0.3752 216750.0n 0.5129 216999.9n 0.5129 217000.0n 0.6020 217249.9n 0.6020 217250.0n 0.5129 217499.9n 0.5129 217500.0n 0.2133 217749.9n 0.2133 217750.0n 0.5372 217999.9n 0.5372 218000.0n 0.4886 218249.9n 0.4886 218250.0n 0.4724 218499.9n 0.4724 218500.0n 0.5210 218749.9n 0.5210 218750.0n 0.2052 218999.9n 0.2052 219000.0n 0.4400 219249.9n 0.4400 219250.0n 0.2618 219499.9n 0.2618 219500.0n 0.4562 219749.9n 0.4562 219750.0n 0.6020 219999.9n 0.6020 220000.0n 0.5453 220249.9n 0.5453 220250.0n 0.5291 220499.9n 0.5291 220500.0n 0.2052 220749.9n 0.2052 220750.0n 0.4886 220999.9n 0.4886 221000.0n 0.4562 221249.9n 0.4562 221250.0n 0.5129 221499.9n 0.5129 221500.0n 0.2000 221749.9n 0.2000 221750.0n 0.5048 221999.9n 0.5048 222000.0n 0.5129 222249.9n 0.5129 222250.0n 0.4724 222499.9n 0.4724 222500.0n 0.5048 222749.9n 0.5048 222750.0n 0.2000 222999.9n 0.2000 223000.0n 0.4967 223249.9n 0.4967 223250.0n 0.4481 223499.9n 0.4481 223500.0n 0.2942 223749.9n 0.2942 223750.0n 0.5291 223999.9n 0.5291 224000.0n 0.3752 224249.9n 0.3752 224250.0n 0.5129 224499.9n 0.5129 224500.0n 0.6020 224749.9n 0.6020 224750.0n 0.5129 224999.9n 0.5129 225000.0n 0.2133 225249.9n 0.2133 225250.0n 0.5372 225499.9n 0.5372 225500.0n 0.4886 225749.9n 0.4886 225750.0n 0.4724 225999.9n 0.4724 226000.0n 0.5210 226249.9n 0.5210 226250.0n 0.2052 226499.9n 0.2052 226500.0n 0.4400 226749.9n 0.4400 226750.0n 0.2618 226999.9n 0.2618 227000.0n 0.4562 227249.9n 0.4562 227250.0n 0.6020 227499.9n 0.6020 227500.0n 0.5453 227749.9n 0.5453 227750.0n 0.5291 227999.9n 0.5291 228000.0n 0.2052 228249.9n 0.2052 228250.0n 0.4886 228499.9n 0.4886 228500.0n 0.4562 228749.9n 0.4562 228750.0n 0.5129 228999.9n 0.5129 229000.0n 0.2000 229249.9n 0.2000 229250.0n 0.5048 229499.9n 0.5048 229500.0n 0.5129 229749.9n 0.5129 229750.0n 0.4724 229999.9n 0.4724 230000.0n 0.5048 230249.9n 0.5048 230250.0n 0.2000 230499.9n 0.2000 230500.0n 0.4967 230749.9n 0.4967 230750.0n 0.4481 230999.9n 0.4481 231000.0n 0.2942 231249.9n 0.2942 231250.0n 0.5291 231499.9n 0.5291 231500.0n 0.3752 231749.9n 0.3752 231750.0n 0.5129 231999.9n 0.5129 232000.0n 0.6020 232249.9n 0.6020 232250.0n 0.5129 232499.9n 0.5129 232500.0n 0.2133 232749.9n 0.2133 232750.0n 0.5372 232999.9n 0.5372 233000.0n 0.4886 233249.9n 0.4886 233250.0n 0.4724 233499.9n 0.4724 233500.0n 0.5210 233749.9n 0.5210 233750.0n 0.2052 233999.9n 0.2052 234000.0n 0.4400 234249.9n 0.4400 234250.0n 0.2618 234499.9n 0.2618 234500.0n 0.4562 234749.9n 0.4562 234750.0n 0.6020 234999.9n 0.6020 235000.0n 0.5453 235249.9n 0.5453 235250.0n 0.5291 235499.9n 0.5291 235500.0n 0.2052 235749.9n 0.2052 235750.0n 0.4886 235999.9n 0.4886 236000.0n 0.4562 236249.9n 0.4562 236250.0n 0.5129 236499.9n 0.5129 236500.0n 0.2000 236749.9n 0.2000 236750.0n 0.5048 236999.9n 0.5048 237000.0n 0.5129 237249.9n 0.5129 237250.0n 0.4724 237499.9n 0.4724 237500.0n 0.5048 237749.9n 0.5048 237750.0n 0.2000 237999.9n 0.2000 238000.0n 0.4967 238249.9n 0.4967 238250.0n 0.4481 238499.9n 0.4481 238500.0n 0.2942 238749.9n 0.2942 238750.0n 0.5291 238999.9n 0.5291 239000.0n 0.3752 239249.9n 0.3752 239250.0n 0.5129 239499.9n 0.5129 239500.0n 0.6020 239749.9n 0.6020 239750.0n 0.5129 239999.9n 0.5129 240000.0n 0.2133 240249.9n 0.2133 240250.0n 0.5372 240499.9n 0.5372 240500.0n 0.4886 240749.9n 0.4886 240750.0n 0.4724 240999.9n 0.4724 241000.0n 0.5210 241249.9n 0.5210 241250.0n 0.2052 241499.9n 0.2052 241500.0n 0.4400 241749.9n 0.4400 241750.0n 0.2618 241999.9n 0.2618 242000.0n 0.4562 242249.9n 0.4562 242250.0n 0.6020 242499.9n 0.6020 242500.0n 0.5453 242749.9n 0.5453 242750.0n 0.5291 242999.9n 0.5291 243000.0n 0.2052 243249.9n 0.2052 243250.0n 0.4886 243499.9n 0.4886 243500.0n 0.4562 243749.9n 0.4562 243750.0n 0.5129 243999.9n 0.5129 244000.0n 0.2000 244249.9n 0.2000 244250.0n 0.5048 244499.9n 0.5048 244500.0n 0.5129 244749.9n 0.5129 244750.0n 0.4724 244999.9n 0.4724 245000.0n 0.5048 245249.9n 0.5048 245250.0n 0.2000 245499.9n 0.2000 245500.0n 0.4967 245749.9n 0.4967 245750.0n 0.4481 245999.9n 0.4481 246000.0n 0.2942 246249.9n 0.2942 246250.0n 0.5291 246499.9n 0.5291 246500.0n 0.3752 246749.9n 0.3752 246750.0n 0.5129 246999.9n 0.5129 247000.0n 0.6020 247249.9n 0.6020 247250.0n 0.5129 247499.9n 0.5129 247500.0n 0.2133 247749.9n 0.2133 247750.0n 0.5372 247999.9n 0.5372 248000.0n 0.4886 248249.9n 0.4886 248250.0n 0.4724 248499.9n 0.4724 248500.0n 0.5210 248749.9n 0.5210 248750.0n 0.2052 248999.9n 0.2052 249000.0n 0.4400 249249.9n 0.4400 249250.0n 0.2618 249499.9n 0.2618 249500.0n 0.4562 249749.9n 0.4562 249750.0n 0.6020 249999.9n 0.6020 250000.0n 0.5453 250249.9n 0.5453 250250.0n 0.5291 250499.9n 0.5291 250500.0n 0.2052 250749.9n 0.2052 250750.0n 0.4886 250999.9n 0.4886 251000.0n 0.4562 251249.9n 0.4562 251250.0n 0.5129 251499.9n 0.5129 251500.0n 0.2000 251749.9n 0.2000 251750.0n 0.5048 251999.9n 0.5048 252000.0n 0.5129 252249.9n 0.5129 252250.0n 0.4724 252499.9n 0.4724 252500.0n 0.5048 252749.9n 0.5048 252750.0n 0.2000 252999.9n 0.2000 253000.0n 0.4967 253249.9n 0.4967 253250.0n 0.4481 253499.9n 0.4481 253500.0n 0.2942 253749.9n 0.2942 253750.0n 0.5291 253999.9n 0.5291 254000.0n 0.3752 254249.9n 0.3752 254250.0n 0.5129 254499.9n 0.5129 254500.0n 0.6020 254749.9n 0.6020 254750.0n 0.5129 254999.9n 0.5129 255000.0n 0.2133 255249.9n 0.2133 255250.0n 0.5372 255499.9n 0.5372 255500.0n 0.4886 255749.9n 0.4886 255750.0n 0.4724 255999.9n 0.4724 256000.0n 0.5210 256249.9n 0.5210 256250.0n 0.2052 256499.9n 0.2052 256500.0n 0.4400 256749.9n 0.4400 256750.0n 0.2618 256999.9n 0.2618 257000.0n 0.4562 257249.9n 0.4562 257250.0n 0.6020 257499.9n 0.6020 257500.0n 0.5453 257749.9n 0.5453 257750.0n 0.5291 257999.9n 0.5291 258000.0n 0.2052 258249.9n 0.2052 258250.0n 0.4886 258499.9n 0.4886 258500.0n 0.4562 258749.9n 0.4562 258750.0n 0.5129 258999.9n 0.5129 259000.0n 0.2000 259249.9n 0.2000 259250.0n 0.5048 259499.9n 0.5048 259500.0n 0.5129 259749.9n 0.5129 259750.0n 0.4724 259999.9n 0.4724 260000.0n 0.5048 260249.9n 0.5048 260250.0n 0.2000 260499.9n 0.2000 260500.0n 0.4967 260749.9n 0.4967 260750.0n 0.4481 260999.9n 0.4481 261000.0n 0.2942 261249.9n 0.2942 261250.0n 0.5291 261499.9n 0.5291 261500.0n 0.3752 261749.9n 0.3752 261750.0n 0.5129 261999.9n 0.5129 262000.0n 0.6020 262249.9n 0.6020 262250.0n 0.5129 262499.9n 0.5129 262500.0n 0.2133 262749.9n 0.2133 262750.0n 0.5372 262999.9n 0.5372 263000.0n 0.4886 263249.9n 0.4886 263250.0n 0.4724 263499.9n 0.4724 263500.0n 0.5210 263749.9n 0.5210 263750.0n 0.2052 263999.9n 0.2052 264000.0n 0.4400 264249.9n 0.4400 264250.0n 0.2618 264499.9n 0.2618 264500.0n 0.4562 264749.9n 0.4562 264750.0n 0.6020 264999.9n 0.6020 265000.0n 0.5453 265249.9n 0.5453 265250.0n 0.5291 265499.9n 0.5291 265500.0n 0.2052 265749.9n 0.2052 265750.0n 0.4886 265999.9n 0.4886 266000.0n 0.4562 266249.9n 0.4562 266250.0n 0.5129 266499.9n 0.5129 266500.0n 0.2000 266749.9n 0.2000 266750.0n 0.5048 266999.9n 0.5048 267000.0n 0.5129 267249.9n 0.5129 267250.0n 0.4724 267499.9n 0.4724 267500.0n 0.5048 267749.9n 0.5048 267750.0n 0.2000 267999.9n 0.2000 268000.0n 0.4967 268249.9n 0.4967 268250.0n 0.4481 268499.9n 0.4481 268500.0n 0.2942 268749.9n 0.2942 268750.0n 0.5291 268999.9n 0.5291 269000.0n 0.3752 269249.9n 0.3752 269250.0n 0.5129 269499.9n 0.5129 269500.0n 0.6020 269749.9n 0.6020 269750.0n 0.5129 269999.9n 0.5129 270000.0n 0.2133 270249.9n 0.2133 270250.0n 0.5372 270499.9n 0.5372 270500.0n 0.4886 270749.9n 0.4886 270750.0n 0.4724 270999.9n 0.4724 271000.0n 0.5210 271249.9n 0.5210 271250.0n 0.2052 271499.9n 0.2052 271500.0n 0.4400 271749.9n 0.4400 271750.0n 0.2618 271999.9n 0.2618 272000.0n 0.4562 272249.9n 0.4562 272250.0n 0.6020 272499.9n 0.6020 272500.0n 0.5453 272749.9n 0.5453 272750.0n 0.5291 272999.9n 0.5291 273000.0n 0.2052 273249.9n 0.2052 273250.0n 0.4886 273499.9n 0.4886 273500.0n 0.4562 273749.9n 0.4562 273750.0n 0.5129 273999.9n 0.5129 274000.0n 0.2000 274249.9n 0.2000 274250.0n 0.5048 274499.9n 0.5048 274500.0n 0.5129 274749.9n 0.5129 274750.0n 0.4724 274999.9n 0.4724 275000.0n 0.5048 275249.9n 0.5048 275250.0n 0.2000 275499.9n 0.2000 275500.0n 0.4967 275749.9n 0.4967 275750.0n 0.4481 275999.9n 0.4481 276000.0n 0.2942 276249.9n 0.2942 276250.0n 0.5291 276499.9n 0.5291 276500.0n 0.3752 276749.9n 0.3752 276750.0n 0.5129 276999.9n 0.5129 277000.0n 0.6020 277249.9n 0.6020 277250.0n 0.5129 277499.9n 0.5129 277500.0n 0.2133 277749.9n 0.2133 277750.0n 0.5372 277999.9n 0.5372 278000.0n 0.4886 278249.9n 0.4886 278250.0n 0.4724 278499.9n 0.4724 278500.0n 0.5210 278749.9n 0.5210 278750.0n 0.2052 278999.9n 0.2052 279000.0n 0.4400 279249.9n 0.4400 279250.0n 0.2618 279499.9n 0.2618 279500.0n 0.4562 279749.9n 0.4562 279750.0n 0.6020 279999.9n 0.6020 280000.0n 0.5453 280249.9n 0.5453 280250.0n 0.5291 280499.9n 0.5291 280500.0n 0.2052 280749.9n 0.2052 280750.0n 0.4886 280999.9n 0.4886 281000.0n 0.4562 281249.9n 0.4562 281250.0n 0.5129 281499.9n 0.5129 281500.0n 0.2000 281749.9n 0.2000 281750.0n 0.5048 281999.9n 0.5048 282000.0n 0.5129 282249.9n 0.5129 282250.0n 0.4724 282499.9n 0.4724 282500.0n 0.5048 282749.9n 0.5048 282750.0n 0.2000 282999.9n 0.2000 283000.0n 0.4967 283249.9n 0.4967 283250.0n 0.4481 283499.9n 0.4481 283500.0n 0.2942 283749.9n 0.2942 283750.0n 0.5291 283999.9n 0.5291 284000.0n 0.3752 284249.9n 0.3752 284250.0n 0.5129 284499.9n 0.5129 284500.0n 0.6020 284749.9n 0.6020 284750.0n 0.5129 284999.9n 0.5129 285000.0n 0.2133 285249.9n 0.2133 285250.0n 0.5372 285499.9n 0.5372 285500.0n 0.4886 285749.9n 0.4886 285750.0n 0.4724 285999.9n 0.4724 286000.0n 0.5210 286249.9n 0.5210 286250.0n 0.2052 286499.9n 0.2052 286500.0n 0.4400 286749.9n 0.4400 286750.0n 0.2618 286999.9n 0.2618 287000.0n 0.4562 287249.9n 0.4562 287250.0n 0.6020 287499.9n 0.6020 287500.0n 0.5453 287749.9n 0.5453 287750.0n 0.5291 287999.9n 0.5291 288000.0n 0.2052 288249.9n 0.2052 288250.0n 0.4886 288499.9n 0.4886 288500.0n 0.4562 288749.9n 0.4562 288750.0n 0.5129 288999.9n 0.5129 289000.0n 0.2000 289249.9n 0.2000 289250.0n 0.5048 289499.9n 0.5048 289500.0n 0.5129 289749.9n 0.5129 289750.0n 0.4724 289999.9n 0.4724 290000.0n 0.5048 290249.9n 0.5048 290250.0n 0.2000 290499.9n 0.2000 290500.0n 0.4967 290749.9n 0.4967 290750.0n 0.4481 290999.9n 0.4481 291000.0n 0.2942 291249.9n 0.2942 291250.0n 0.5291 291499.9n 0.5291 291500.0n 0.3752 291749.9n 0.3752 291750.0n 0.5129 291999.9n 0.5129 292000.0n 0.6020 292249.9n 0.6020 292250.0n 0.5129 292499.9n 0.5129 292500.0n 0.2133 292749.9n 0.2133 292750.0n 0.5372 292999.9n 0.5372 293000.0n 0.4886 293249.9n 0.4886 293250.0n 0.4724 293499.9n 0.4724 293500.0n 0.5210 293749.9n 0.5210 293750.0n 0.2052 293999.9n 0.2052 294000.0n 0.4400 294249.9n 0.4400 294250.0n 0.2618 294499.9n 0.2618 294500.0n 0.4562 294749.9n 0.4562 294750.0n 0.6020 294999.9n 0.6020 295000.0n 0.5453 295249.9n 0.5453 295250.0n 0.5291 295499.9n 0.5291 295500.0n 0.2052 295749.9n 0.2052 295750.0n 0.4886 295999.9n 0.4886 296000.0n 0.4562 296249.9n 0.4562 296250.0n 0.5129 296499.9n 0.5129 296500.0n 0.2000 296749.9n 0.2000 296750.0n 0.5048 296999.9n 0.5048 297000.0n 0.5129 297249.9n 0.5129 297250.0n 0.4724 297499.9n 0.4724 297500.0n 0.5048 297749.9n 0.5048 297750.0n 0.2000 297999.9n 0.2000 298000.0n 0.4967 298249.9n 0.4967 298250.0n 0.4481 298499.9n 0.4481 298500.0n 0.2942 298749.9n 0.2942 298750.0n 0.5291 298999.9n 0.5291 299000.0n 0.3752 299249.9n 0.3752 299250.0n 0.5129 299499.9n 0.5129 299500.0n 0.6020 299749.9n 0.6020 299750.0n 0.5129)
Vxn1 a_xn1 0 PWL(0.0n 0.7867 249.9n 0.7867 250.0n 0.4628 499.9n 0.4628 500.0n 0.5114 749.9n 0.5114 750.0n 0.5276 999.9n 0.5276 1000.0n 0.4790 1249.9n 0.4790 1250.0n 0.7948 1499.9n 0.7948 1500.0n 0.5600 1749.9n 0.5600 1750.0n 0.7382 1999.9n 0.7382 2000.0n 0.5438 2249.9n 0.5438 2250.0n 0.3980 2499.9n 0.3980 2500.0n 0.4547 2749.9n 0.4547 2750.0n 0.4709 2999.9n 0.4709 3000.0n 0.7948 3249.9n 0.7948 3250.0n 0.5114 3499.9n 0.5114 3500.0n 0.5438 3749.9n 0.5438 3750.0n 0.4871 3999.9n 0.4871 4000.0n 0.8000 4249.9n 0.8000 4250.0n 0.4952 4499.9n 0.4952 4500.0n 0.4871 4749.9n 0.4871 4750.0n 0.5276 4999.9n 0.5276 5000.0n 0.4952 5249.9n 0.4952 5250.0n 0.8000 5499.9n 0.8000 5500.0n 0.5033 5749.9n 0.5033 5750.0n 0.5519 5999.9n 0.5519 6000.0n 0.7058 6249.9n 0.7058 6250.0n 0.4709 6499.9n 0.4709 6500.0n 0.6248 6749.9n 0.6248 6750.0n 0.4871 6999.9n 0.4871 7000.0n 0.3980 7249.9n 0.3980 7250.0n 0.4871 7499.9n 0.4871 7500.0n 0.7867 7749.9n 0.7867 7750.0n 0.4628 7999.9n 0.4628 8000.0n 0.5114 8249.9n 0.5114 8250.0n 0.5276 8499.9n 0.5276 8500.0n 0.4790 8749.9n 0.4790 8750.0n 0.7948 8999.9n 0.7948 9000.0n 0.5600 9249.9n 0.5600 9250.0n 0.7382 9499.9n 0.7382 9500.0n 0.5438 9749.9n 0.5438 9750.0n 0.3980 9999.9n 0.3980 10000.0n 0.4547 10249.9n 0.4547 10250.0n 0.4709 10499.9n 0.4709 10500.0n 0.7948 10749.9n 0.7948 10750.0n 0.5114 10999.9n 0.5114 11000.0n 0.5438 11249.9n 0.5438 11250.0n 0.4871 11499.9n 0.4871 11500.0n 0.8000 11749.9n 0.8000 11750.0n 0.4952 11999.9n 0.4952 12000.0n 0.4871 12249.9n 0.4871 12250.0n 0.5276 12499.9n 0.5276 12500.0n 0.4952 12749.9n 0.4952 12750.0n 0.8000 12999.9n 0.8000 13000.0n 0.5033 13249.9n 0.5033 13250.0n 0.5519 13499.9n 0.5519 13500.0n 0.7058 13749.9n 0.7058 13750.0n 0.4709 13999.9n 0.4709 14000.0n 0.6248 14249.9n 0.6248 14250.0n 0.4871 14499.9n 0.4871 14500.0n 0.3980 14749.9n 0.3980 14750.0n 0.4871 14999.9n 0.4871 15000.0n 0.7867 15249.9n 0.7867 15250.0n 0.4628 15499.9n 0.4628 15500.0n 0.5114 15749.9n 0.5114 15750.0n 0.5276 15999.9n 0.5276 16000.0n 0.4790 16249.9n 0.4790 16250.0n 0.7948 16499.9n 0.7948 16500.0n 0.5600 16749.9n 0.5600 16750.0n 0.7382 16999.9n 0.7382 17000.0n 0.5438 17249.9n 0.5438 17250.0n 0.3980 17499.9n 0.3980 17500.0n 0.4547 17749.9n 0.4547 17750.0n 0.4709 17999.9n 0.4709 18000.0n 0.7948 18249.9n 0.7948 18250.0n 0.5114 18499.9n 0.5114 18500.0n 0.5438 18749.9n 0.5438 18750.0n 0.4871 18999.9n 0.4871 19000.0n 0.8000 19249.9n 0.8000 19250.0n 0.4952 19499.9n 0.4952 19500.0n 0.4871 19749.9n 0.4871 19750.0n 0.5276 19999.9n 0.5276 20000.0n 0.4952 20249.9n 0.4952 20250.0n 0.8000 20499.9n 0.8000 20500.0n 0.5033 20749.9n 0.5033 20750.0n 0.5519 20999.9n 0.5519 21000.0n 0.7058 21249.9n 0.7058 21250.0n 0.4709 21499.9n 0.4709 21500.0n 0.6248 21749.9n 0.6248 21750.0n 0.4871 21999.9n 0.4871 22000.0n 0.3980 22249.9n 0.3980 22250.0n 0.4871 22499.9n 0.4871 22500.0n 0.7867 22749.9n 0.7867 22750.0n 0.4628 22999.9n 0.4628 23000.0n 0.5114 23249.9n 0.5114 23250.0n 0.5276 23499.9n 0.5276 23500.0n 0.4790 23749.9n 0.4790 23750.0n 0.7948 23999.9n 0.7948 24000.0n 0.5600 24249.9n 0.5600 24250.0n 0.7382 24499.9n 0.7382 24500.0n 0.5438 24749.9n 0.5438 24750.0n 0.3980 24999.9n 0.3980 25000.0n 0.4547 25249.9n 0.4547 25250.0n 0.4709 25499.9n 0.4709 25500.0n 0.7948 25749.9n 0.7948 25750.0n 0.5114 25999.9n 0.5114 26000.0n 0.5438 26249.9n 0.5438 26250.0n 0.4871 26499.9n 0.4871 26500.0n 0.8000 26749.9n 0.8000 26750.0n 0.4952 26999.9n 0.4952 27000.0n 0.4871 27249.9n 0.4871 27250.0n 0.5276 27499.9n 0.5276 27500.0n 0.4952 27749.9n 0.4952 27750.0n 0.8000 27999.9n 0.8000 28000.0n 0.5033 28249.9n 0.5033 28250.0n 0.5519 28499.9n 0.5519 28500.0n 0.7058 28749.9n 0.7058 28750.0n 0.4709 28999.9n 0.4709 29000.0n 0.6248 29249.9n 0.6248 29250.0n 0.4871 29499.9n 0.4871 29500.0n 0.3980 29749.9n 0.3980 29750.0n 0.4871 29999.9n 0.4871 30000.0n 0.7867 30249.9n 0.7867 30250.0n 0.4628 30499.9n 0.4628 30500.0n 0.5114 30749.9n 0.5114 30750.0n 0.5276 30999.9n 0.5276 31000.0n 0.4790 31249.9n 0.4790 31250.0n 0.7948 31499.9n 0.7948 31500.0n 0.5600 31749.9n 0.5600 31750.0n 0.7382 31999.9n 0.7382 32000.0n 0.5438 32249.9n 0.5438 32250.0n 0.3980 32499.9n 0.3980 32500.0n 0.4547 32749.9n 0.4547 32750.0n 0.4709 32999.9n 0.4709 33000.0n 0.7948 33249.9n 0.7948 33250.0n 0.5114 33499.9n 0.5114 33500.0n 0.5438 33749.9n 0.5438 33750.0n 0.4871 33999.9n 0.4871 34000.0n 0.8000 34249.9n 0.8000 34250.0n 0.4952 34499.9n 0.4952 34500.0n 0.4871 34749.9n 0.4871 34750.0n 0.5276 34999.9n 0.5276 35000.0n 0.4952 35249.9n 0.4952 35250.0n 0.8000 35499.9n 0.8000 35500.0n 0.5033 35749.9n 0.5033 35750.0n 0.5519 35999.9n 0.5519 36000.0n 0.7058 36249.9n 0.7058 36250.0n 0.4709 36499.9n 0.4709 36500.0n 0.6248 36749.9n 0.6248 36750.0n 0.4871 36999.9n 0.4871 37000.0n 0.3980 37249.9n 0.3980 37250.0n 0.4871 37499.9n 0.4871 37500.0n 0.7867 37749.9n 0.7867 37750.0n 0.4628 37999.9n 0.4628 38000.0n 0.5114 38249.9n 0.5114 38250.0n 0.5276 38499.9n 0.5276 38500.0n 0.4790 38749.9n 0.4790 38750.0n 0.7948 38999.9n 0.7948 39000.0n 0.5600 39249.9n 0.5600 39250.0n 0.7382 39499.9n 0.7382 39500.0n 0.5438 39749.9n 0.5438 39750.0n 0.3980 39999.9n 0.3980 40000.0n 0.4547 40249.9n 0.4547 40250.0n 0.4709 40499.9n 0.4709 40500.0n 0.7948 40749.9n 0.7948 40750.0n 0.5114 40999.9n 0.5114 41000.0n 0.5438 41249.9n 0.5438 41250.0n 0.4871 41499.9n 0.4871 41500.0n 0.8000 41749.9n 0.8000 41750.0n 0.4952 41999.9n 0.4952 42000.0n 0.4871 42249.9n 0.4871 42250.0n 0.5276 42499.9n 0.5276 42500.0n 0.4952 42749.9n 0.4952 42750.0n 0.8000 42999.9n 0.8000 43000.0n 0.5033 43249.9n 0.5033 43250.0n 0.5519 43499.9n 0.5519 43500.0n 0.7058 43749.9n 0.7058 43750.0n 0.4709 43999.9n 0.4709 44000.0n 0.6248 44249.9n 0.6248 44250.0n 0.4871 44499.9n 0.4871 44500.0n 0.3980 44749.9n 0.3980 44750.0n 0.4871 44999.9n 0.4871 45000.0n 0.7867 45249.9n 0.7867 45250.0n 0.4628 45499.9n 0.4628 45500.0n 0.5114 45749.9n 0.5114 45750.0n 0.5276 45999.9n 0.5276 46000.0n 0.4790 46249.9n 0.4790 46250.0n 0.7948 46499.9n 0.7948 46500.0n 0.5600 46749.9n 0.5600 46750.0n 0.7382 46999.9n 0.7382 47000.0n 0.5438 47249.9n 0.5438 47250.0n 0.3980 47499.9n 0.3980 47500.0n 0.4547 47749.9n 0.4547 47750.0n 0.4709 47999.9n 0.4709 48000.0n 0.7948 48249.9n 0.7948 48250.0n 0.5114 48499.9n 0.5114 48500.0n 0.5438 48749.9n 0.5438 48750.0n 0.4871 48999.9n 0.4871 49000.0n 0.8000 49249.9n 0.8000 49250.0n 0.4952 49499.9n 0.4952 49500.0n 0.4871 49749.9n 0.4871 49750.0n 0.5276 49999.9n 0.5276 50000.0n 0.4952 50249.9n 0.4952 50250.0n 0.8000 50499.9n 0.8000 50500.0n 0.5033 50749.9n 0.5033 50750.0n 0.5519 50999.9n 0.5519 51000.0n 0.7058 51249.9n 0.7058 51250.0n 0.4709 51499.9n 0.4709 51500.0n 0.6248 51749.9n 0.6248 51750.0n 0.4871 51999.9n 0.4871 52000.0n 0.3980 52249.9n 0.3980 52250.0n 0.4871 52499.9n 0.4871 52500.0n 0.7867 52749.9n 0.7867 52750.0n 0.4628 52999.9n 0.4628 53000.0n 0.5114 53249.9n 0.5114 53250.0n 0.5276 53499.9n 0.5276 53500.0n 0.4790 53749.9n 0.4790 53750.0n 0.7948 53999.9n 0.7948 54000.0n 0.5600 54249.9n 0.5600 54250.0n 0.7382 54499.9n 0.7382 54500.0n 0.5438 54749.9n 0.5438 54750.0n 0.3980 54999.9n 0.3980 55000.0n 0.4547 55249.9n 0.4547 55250.0n 0.4709 55499.9n 0.4709 55500.0n 0.7948 55749.9n 0.7948 55750.0n 0.5114 55999.9n 0.5114 56000.0n 0.5438 56249.9n 0.5438 56250.0n 0.4871 56499.9n 0.4871 56500.0n 0.8000 56749.9n 0.8000 56750.0n 0.4952 56999.9n 0.4952 57000.0n 0.4871 57249.9n 0.4871 57250.0n 0.5276 57499.9n 0.5276 57500.0n 0.4952 57749.9n 0.4952 57750.0n 0.8000 57999.9n 0.8000 58000.0n 0.5033 58249.9n 0.5033 58250.0n 0.5519 58499.9n 0.5519 58500.0n 0.7058 58749.9n 0.7058 58750.0n 0.4709 58999.9n 0.4709 59000.0n 0.6248 59249.9n 0.6248 59250.0n 0.4871 59499.9n 0.4871 59500.0n 0.3980 59749.9n 0.3980 59750.0n 0.4871 59999.9n 0.4871 60000.0n 0.7867 60249.9n 0.7867 60250.0n 0.4628 60499.9n 0.4628 60500.0n 0.5114 60749.9n 0.5114 60750.0n 0.5276 60999.9n 0.5276 61000.0n 0.4790 61249.9n 0.4790 61250.0n 0.7948 61499.9n 0.7948 61500.0n 0.5600 61749.9n 0.5600 61750.0n 0.7382 61999.9n 0.7382 62000.0n 0.5438 62249.9n 0.5438 62250.0n 0.3980 62499.9n 0.3980 62500.0n 0.4547 62749.9n 0.4547 62750.0n 0.4709 62999.9n 0.4709 63000.0n 0.7948 63249.9n 0.7948 63250.0n 0.5114 63499.9n 0.5114 63500.0n 0.5438 63749.9n 0.5438 63750.0n 0.4871 63999.9n 0.4871 64000.0n 0.8000 64249.9n 0.8000 64250.0n 0.4952 64499.9n 0.4952 64500.0n 0.4871 64749.9n 0.4871 64750.0n 0.5276 64999.9n 0.5276 65000.0n 0.4952 65249.9n 0.4952 65250.0n 0.8000 65499.9n 0.8000 65500.0n 0.5033 65749.9n 0.5033 65750.0n 0.5519 65999.9n 0.5519 66000.0n 0.7058 66249.9n 0.7058 66250.0n 0.4709 66499.9n 0.4709 66500.0n 0.6248 66749.9n 0.6248 66750.0n 0.4871 66999.9n 0.4871 67000.0n 0.3980 67249.9n 0.3980 67250.0n 0.4871 67499.9n 0.4871 67500.0n 0.7867 67749.9n 0.7867 67750.0n 0.4628 67999.9n 0.4628 68000.0n 0.5114 68249.9n 0.5114 68250.0n 0.5276 68499.9n 0.5276 68500.0n 0.4790 68749.9n 0.4790 68750.0n 0.7948 68999.9n 0.7948 69000.0n 0.5600 69249.9n 0.5600 69250.0n 0.7382 69499.9n 0.7382 69500.0n 0.5438 69749.9n 0.5438 69750.0n 0.3980 69999.9n 0.3980 70000.0n 0.4547 70249.9n 0.4547 70250.0n 0.4709 70499.9n 0.4709 70500.0n 0.7948 70749.9n 0.7948 70750.0n 0.5114 70999.9n 0.5114 71000.0n 0.5438 71249.9n 0.5438 71250.0n 0.4871 71499.9n 0.4871 71500.0n 0.8000 71749.9n 0.8000 71750.0n 0.4952 71999.9n 0.4952 72000.0n 0.4871 72249.9n 0.4871 72250.0n 0.5276 72499.9n 0.5276 72500.0n 0.4952 72749.9n 0.4952 72750.0n 0.8000 72999.9n 0.8000 73000.0n 0.5033 73249.9n 0.5033 73250.0n 0.5519 73499.9n 0.5519 73500.0n 0.7058 73749.9n 0.7058 73750.0n 0.4709 73999.9n 0.4709 74000.0n 0.6248 74249.9n 0.6248 74250.0n 0.4871 74499.9n 0.4871 74500.0n 0.3980 74749.9n 0.3980 74750.0n 0.4871 74999.9n 0.4871 75000.0n 0.7867 75249.9n 0.7867 75250.0n 0.4628 75499.9n 0.4628 75500.0n 0.5114 75749.9n 0.5114 75750.0n 0.5276 75999.9n 0.5276 76000.0n 0.4790 76249.9n 0.4790 76250.0n 0.7948 76499.9n 0.7948 76500.0n 0.5600 76749.9n 0.5600 76750.0n 0.7382 76999.9n 0.7382 77000.0n 0.5438 77249.9n 0.5438 77250.0n 0.3980 77499.9n 0.3980 77500.0n 0.4547 77749.9n 0.4547 77750.0n 0.4709 77999.9n 0.4709 78000.0n 0.7948 78249.9n 0.7948 78250.0n 0.5114 78499.9n 0.5114 78500.0n 0.5438 78749.9n 0.5438 78750.0n 0.4871 78999.9n 0.4871 79000.0n 0.8000 79249.9n 0.8000 79250.0n 0.4952 79499.9n 0.4952 79500.0n 0.4871 79749.9n 0.4871 79750.0n 0.5276 79999.9n 0.5276 80000.0n 0.4952 80249.9n 0.4952 80250.0n 0.8000 80499.9n 0.8000 80500.0n 0.5033 80749.9n 0.5033 80750.0n 0.5519 80999.9n 0.5519 81000.0n 0.7058 81249.9n 0.7058 81250.0n 0.4709 81499.9n 0.4709 81500.0n 0.6248 81749.9n 0.6248 81750.0n 0.4871 81999.9n 0.4871 82000.0n 0.3980 82249.9n 0.3980 82250.0n 0.4871 82499.9n 0.4871 82500.0n 0.7867 82749.9n 0.7867 82750.0n 0.4628 82999.9n 0.4628 83000.0n 0.5114 83249.9n 0.5114 83250.0n 0.5276 83499.9n 0.5276 83500.0n 0.4790 83749.9n 0.4790 83750.0n 0.7948 83999.9n 0.7948 84000.0n 0.5600 84249.9n 0.5600 84250.0n 0.7382 84499.9n 0.7382 84500.0n 0.5438 84749.9n 0.5438 84750.0n 0.3980 84999.9n 0.3980 85000.0n 0.4547 85249.9n 0.4547 85250.0n 0.4709 85499.9n 0.4709 85500.0n 0.7948 85749.9n 0.7948 85750.0n 0.5114 85999.9n 0.5114 86000.0n 0.5438 86249.9n 0.5438 86250.0n 0.4871 86499.9n 0.4871 86500.0n 0.8000 86749.9n 0.8000 86750.0n 0.4952 86999.9n 0.4952 87000.0n 0.4871 87249.9n 0.4871 87250.0n 0.5276 87499.9n 0.5276 87500.0n 0.4952 87749.9n 0.4952 87750.0n 0.8000 87999.9n 0.8000 88000.0n 0.5033 88249.9n 0.5033 88250.0n 0.5519 88499.9n 0.5519 88500.0n 0.7058 88749.9n 0.7058 88750.0n 0.4709 88999.9n 0.4709 89000.0n 0.6248 89249.9n 0.6248 89250.0n 0.4871 89499.9n 0.4871 89500.0n 0.3980 89749.9n 0.3980 89750.0n 0.4871 89999.9n 0.4871 90000.0n 0.7867 90249.9n 0.7867 90250.0n 0.4628 90499.9n 0.4628 90500.0n 0.5114 90749.9n 0.5114 90750.0n 0.5276 90999.9n 0.5276 91000.0n 0.4790 91249.9n 0.4790 91250.0n 0.7948 91499.9n 0.7948 91500.0n 0.5600 91749.9n 0.5600 91750.0n 0.7382 91999.9n 0.7382 92000.0n 0.5438 92249.9n 0.5438 92250.0n 0.3980 92499.9n 0.3980 92500.0n 0.4547 92749.9n 0.4547 92750.0n 0.4709 92999.9n 0.4709 93000.0n 0.7948 93249.9n 0.7948 93250.0n 0.5114 93499.9n 0.5114 93500.0n 0.5438 93749.9n 0.5438 93750.0n 0.4871 93999.9n 0.4871 94000.0n 0.8000 94249.9n 0.8000 94250.0n 0.4952 94499.9n 0.4952 94500.0n 0.4871 94749.9n 0.4871 94750.0n 0.5276 94999.9n 0.5276 95000.0n 0.4952 95249.9n 0.4952 95250.0n 0.8000 95499.9n 0.8000 95500.0n 0.5033 95749.9n 0.5033 95750.0n 0.5519 95999.9n 0.5519 96000.0n 0.7058 96249.9n 0.7058 96250.0n 0.4709 96499.9n 0.4709 96500.0n 0.6248 96749.9n 0.6248 96750.0n 0.4871 96999.9n 0.4871 97000.0n 0.3980 97249.9n 0.3980 97250.0n 0.4871 97499.9n 0.4871 97500.0n 0.7867 97749.9n 0.7867 97750.0n 0.4628 97999.9n 0.4628 98000.0n 0.5114 98249.9n 0.5114 98250.0n 0.5276 98499.9n 0.5276 98500.0n 0.4790 98749.9n 0.4790 98750.0n 0.7948 98999.9n 0.7948 99000.0n 0.5600 99249.9n 0.5600 99250.0n 0.7382 99499.9n 0.7382 99500.0n 0.5438 99749.9n 0.5438 99750.0n 0.3980 99999.9n 0.3980 100000.0n 0.4547 100249.9n 0.4547 100250.0n 0.4709 100499.9n 0.4709 100500.0n 0.7948 100749.9n 0.7948 100750.0n 0.5114 100999.9n 0.5114 101000.0n 0.5438 101249.9n 0.5438 101250.0n 0.4871 101499.9n 0.4871 101500.0n 0.8000 101749.9n 0.8000 101750.0n 0.4952 101999.9n 0.4952 102000.0n 0.4871 102249.9n 0.4871 102250.0n 0.5276 102499.9n 0.5276 102500.0n 0.4952 102749.9n 0.4952 102750.0n 0.8000 102999.9n 0.8000 103000.0n 0.5033 103249.9n 0.5033 103250.0n 0.5519 103499.9n 0.5519 103500.0n 0.7058 103749.9n 0.7058 103750.0n 0.4709 103999.9n 0.4709 104000.0n 0.6248 104249.9n 0.6248 104250.0n 0.4871 104499.9n 0.4871 104500.0n 0.3980 104749.9n 0.3980 104750.0n 0.4871 104999.9n 0.4871 105000.0n 0.7867 105249.9n 0.7867 105250.0n 0.4628 105499.9n 0.4628 105500.0n 0.5114 105749.9n 0.5114 105750.0n 0.5276 105999.9n 0.5276 106000.0n 0.4790 106249.9n 0.4790 106250.0n 0.7948 106499.9n 0.7948 106500.0n 0.5600 106749.9n 0.5600 106750.0n 0.7382 106999.9n 0.7382 107000.0n 0.5438 107249.9n 0.5438 107250.0n 0.3980 107499.9n 0.3980 107500.0n 0.4547 107749.9n 0.4547 107750.0n 0.4709 107999.9n 0.4709 108000.0n 0.7948 108249.9n 0.7948 108250.0n 0.5114 108499.9n 0.5114 108500.0n 0.5438 108749.9n 0.5438 108750.0n 0.4871 108999.9n 0.4871 109000.0n 0.8000 109249.9n 0.8000 109250.0n 0.4952 109499.9n 0.4952 109500.0n 0.4871 109749.9n 0.4871 109750.0n 0.5276 109999.9n 0.5276 110000.0n 0.4952 110249.9n 0.4952 110250.0n 0.8000 110499.9n 0.8000 110500.0n 0.5033 110749.9n 0.5033 110750.0n 0.5519 110999.9n 0.5519 111000.0n 0.7058 111249.9n 0.7058 111250.0n 0.4709 111499.9n 0.4709 111500.0n 0.6248 111749.9n 0.6248 111750.0n 0.4871 111999.9n 0.4871 112000.0n 0.3980 112249.9n 0.3980 112250.0n 0.4871 112499.9n 0.4871 112500.0n 0.7867 112749.9n 0.7867 112750.0n 0.4628 112999.9n 0.4628 113000.0n 0.5114 113249.9n 0.5114 113250.0n 0.5276 113499.9n 0.5276 113500.0n 0.4790 113749.9n 0.4790 113750.0n 0.7948 113999.9n 0.7948 114000.0n 0.5600 114249.9n 0.5600 114250.0n 0.7382 114499.9n 0.7382 114500.0n 0.5438 114749.9n 0.5438 114750.0n 0.3980 114999.9n 0.3980 115000.0n 0.4547 115249.9n 0.4547 115250.0n 0.4709 115499.9n 0.4709 115500.0n 0.7948 115749.9n 0.7948 115750.0n 0.5114 115999.9n 0.5114 116000.0n 0.5438 116249.9n 0.5438 116250.0n 0.4871 116499.9n 0.4871 116500.0n 0.8000 116749.9n 0.8000 116750.0n 0.4952 116999.9n 0.4952 117000.0n 0.4871 117249.9n 0.4871 117250.0n 0.5276 117499.9n 0.5276 117500.0n 0.4952 117749.9n 0.4952 117750.0n 0.8000 117999.9n 0.8000 118000.0n 0.5033 118249.9n 0.5033 118250.0n 0.5519 118499.9n 0.5519 118500.0n 0.7058 118749.9n 0.7058 118750.0n 0.4709 118999.9n 0.4709 119000.0n 0.6248 119249.9n 0.6248 119250.0n 0.4871 119499.9n 0.4871 119500.0n 0.3980 119749.9n 0.3980 119750.0n 0.4871 119999.9n 0.4871 120000.0n 0.7867 120249.9n 0.7867 120250.0n 0.4628 120499.9n 0.4628 120500.0n 0.5114 120749.9n 0.5114 120750.0n 0.5276 120999.9n 0.5276 121000.0n 0.4790 121249.9n 0.4790 121250.0n 0.7948 121499.9n 0.7948 121500.0n 0.5600 121749.9n 0.5600 121750.0n 0.7382 121999.9n 0.7382 122000.0n 0.5438 122249.9n 0.5438 122250.0n 0.3980 122499.9n 0.3980 122500.0n 0.4547 122749.9n 0.4547 122750.0n 0.4709 122999.9n 0.4709 123000.0n 0.7948 123249.9n 0.7948 123250.0n 0.5114 123499.9n 0.5114 123500.0n 0.5438 123749.9n 0.5438 123750.0n 0.4871 123999.9n 0.4871 124000.0n 0.8000 124249.9n 0.8000 124250.0n 0.4952 124499.9n 0.4952 124500.0n 0.4871 124749.9n 0.4871 124750.0n 0.5276 124999.9n 0.5276 125000.0n 0.4952 125249.9n 0.4952 125250.0n 0.8000 125499.9n 0.8000 125500.0n 0.5033 125749.9n 0.5033 125750.0n 0.5519 125999.9n 0.5519 126000.0n 0.7058 126249.9n 0.7058 126250.0n 0.4709 126499.9n 0.4709 126500.0n 0.6248 126749.9n 0.6248 126750.0n 0.4871 126999.9n 0.4871 127000.0n 0.3980 127249.9n 0.3980 127250.0n 0.4871 127499.9n 0.4871 127500.0n 0.7867 127749.9n 0.7867 127750.0n 0.4628 127999.9n 0.4628 128000.0n 0.5114 128249.9n 0.5114 128250.0n 0.5276 128499.9n 0.5276 128500.0n 0.4790 128749.9n 0.4790 128750.0n 0.7948 128999.9n 0.7948 129000.0n 0.5600 129249.9n 0.5600 129250.0n 0.7382 129499.9n 0.7382 129500.0n 0.5438 129749.9n 0.5438 129750.0n 0.3980 129999.9n 0.3980 130000.0n 0.4547 130249.9n 0.4547 130250.0n 0.4709 130499.9n 0.4709 130500.0n 0.7948 130749.9n 0.7948 130750.0n 0.5114 130999.9n 0.5114 131000.0n 0.5438 131249.9n 0.5438 131250.0n 0.4871 131499.9n 0.4871 131500.0n 0.8000 131749.9n 0.8000 131750.0n 0.4952 131999.9n 0.4952 132000.0n 0.4871 132249.9n 0.4871 132250.0n 0.5276 132499.9n 0.5276 132500.0n 0.4952 132749.9n 0.4952 132750.0n 0.8000 132999.9n 0.8000 133000.0n 0.5033 133249.9n 0.5033 133250.0n 0.5519 133499.9n 0.5519 133500.0n 0.7058 133749.9n 0.7058 133750.0n 0.4709 133999.9n 0.4709 134000.0n 0.6248 134249.9n 0.6248 134250.0n 0.4871 134499.9n 0.4871 134500.0n 0.3980 134749.9n 0.3980 134750.0n 0.4871 134999.9n 0.4871 135000.0n 0.7867 135249.9n 0.7867 135250.0n 0.4628 135499.9n 0.4628 135500.0n 0.5114 135749.9n 0.5114 135750.0n 0.5276 135999.9n 0.5276 136000.0n 0.4790 136249.9n 0.4790 136250.0n 0.7948 136499.9n 0.7948 136500.0n 0.5600 136749.9n 0.5600 136750.0n 0.7382 136999.9n 0.7382 137000.0n 0.5438 137249.9n 0.5438 137250.0n 0.3980 137499.9n 0.3980 137500.0n 0.4547 137749.9n 0.4547 137750.0n 0.4709 137999.9n 0.4709 138000.0n 0.7948 138249.9n 0.7948 138250.0n 0.5114 138499.9n 0.5114 138500.0n 0.5438 138749.9n 0.5438 138750.0n 0.4871 138999.9n 0.4871 139000.0n 0.8000 139249.9n 0.8000 139250.0n 0.4952 139499.9n 0.4952 139500.0n 0.4871 139749.9n 0.4871 139750.0n 0.5276 139999.9n 0.5276 140000.0n 0.4952 140249.9n 0.4952 140250.0n 0.8000 140499.9n 0.8000 140500.0n 0.5033 140749.9n 0.5033 140750.0n 0.5519 140999.9n 0.5519 141000.0n 0.7058 141249.9n 0.7058 141250.0n 0.4709 141499.9n 0.4709 141500.0n 0.6248 141749.9n 0.6248 141750.0n 0.4871 141999.9n 0.4871 142000.0n 0.3980 142249.9n 0.3980 142250.0n 0.4871 142499.9n 0.4871 142500.0n 0.7867 142749.9n 0.7867 142750.0n 0.4628 142999.9n 0.4628 143000.0n 0.5114 143249.9n 0.5114 143250.0n 0.5276 143499.9n 0.5276 143500.0n 0.4790 143749.9n 0.4790 143750.0n 0.7948 143999.9n 0.7948 144000.0n 0.5600 144249.9n 0.5600 144250.0n 0.7382 144499.9n 0.7382 144500.0n 0.5438 144749.9n 0.5438 144750.0n 0.3980 144999.9n 0.3980 145000.0n 0.4547 145249.9n 0.4547 145250.0n 0.4709 145499.9n 0.4709 145500.0n 0.7948 145749.9n 0.7948 145750.0n 0.5114 145999.9n 0.5114 146000.0n 0.5438 146249.9n 0.5438 146250.0n 0.4871 146499.9n 0.4871 146500.0n 0.8000 146749.9n 0.8000 146750.0n 0.4952 146999.9n 0.4952 147000.0n 0.4871 147249.9n 0.4871 147250.0n 0.5276 147499.9n 0.5276 147500.0n 0.4952 147749.9n 0.4952 147750.0n 0.8000 147999.9n 0.8000 148000.0n 0.5033 148249.9n 0.5033 148250.0n 0.5519 148499.9n 0.5519 148500.0n 0.7058 148749.9n 0.7058 148750.0n 0.4709 148999.9n 0.4709 149000.0n 0.6248 149249.9n 0.6248 149250.0n 0.4871 149499.9n 0.4871 149500.0n 0.3980 149749.9n 0.3980 149750.0n 0.4871 149999.9n 0.4871 150000.0n 0.7867 150249.9n 0.7867 150250.0n 0.4628 150499.9n 0.4628 150500.0n 0.5114 150749.9n 0.5114 150750.0n 0.5276 150999.9n 0.5276 151000.0n 0.4790 151249.9n 0.4790 151250.0n 0.7948 151499.9n 0.7948 151500.0n 0.5600 151749.9n 0.5600 151750.0n 0.7382 151999.9n 0.7382 152000.0n 0.5438 152249.9n 0.5438 152250.0n 0.3980 152499.9n 0.3980 152500.0n 0.4547 152749.9n 0.4547 152750.0n 0.4709 152999.9n 0.4709 153000.0n 0.7948 153249.9n 0.7948 153250.0n 0.5114 153499.9n 0.5114 153500.0n 0.5438 153749.9n 0.5438 153750.0n 0.4871 153999.9n 0.4871 154000.0n 0.8000 154249.9n 0.8000 154250.0n 0.4952 154499.9n 0.4952 154500.0n 0.4871 154749.9n 0.4871 154750.0n 0.5276 154999.9n 0.5276 155000.0n 0.4952 155249.9n 0.4952 155250.0n 0.8000 155499.9n 0.8000 155500.0n 0.5033 155749.9n 0.5033 155750.0n 0.5519 155999.9n 0.5519 156000.0n 0.7058 156249.9n 0.7058 156250.0n 0.4709 156499.9n 0.4709 156500.0n 0.6248 156749.9n 0.6248 156750.0n 0.4871 156999.9n 0.4871 157000.0n 0.3980 157249.9n 0.3980 157250.0n 0.4871 157499.9n 0.4871 157500.0n 0.7867 157749.9n 0.7867 157750.0n 0.4628 157999.9n 0.4628 158000.0n 0.5114 158249.9n 0.5114 158250.0n 0.5276 158499.9n 0.5276 158500.0n 0.4790 158749.9n 0.4790 158750.0n 0.7948 158999.9n 0.7948 159000.0n 0.5600 159249.9n 0.5600 159250.0n 0.7382 159499.9n 0.7382 159500.0n 0.5438 159749.9n 0.5438 159750.0n 0.3980 159999.9n 0.3980 160000.0n 0.4547 160249.9n 0.4547 160250.0n 0.4709 160499.9n 0.4709 160500.0n 0.7948 160749.9n 0.7948 160750.0n 0.5114 160999.9n 0.5114 161000.0n 0.5438 161249.9n 0.5438 161250.0n 0.4871 161499.9n 0.4871 161500.0n 0.8000 161749.9n 0.8000 161750.0n 0.4952 161999.9n 0.4952 162000.0n 0.4871 162249.9n 0.4871 162250.0n 0.5276 162499.9n 0.5276 162500.0n 0.4952 162749.9n 0.4952 162750.0n 0.8000 162999.9n 0.8000 163000.0n 0.5033 163249.9n 0.5033 163250.0n 0.5519 163499.9n 0.5519 163500.0n 0.7058 163749.9n 0.7058 163750.0n 0.4709 163999.9n 0.4709 164000.0n 0.6248 164249.9n 0.6248 164250.0n 0.4871 164499.9n 0.4871 164500.0n 0.3980 164749.9n 0.3980 164750.0n 0.4871 164999.9n 0.4871 165000.0n 0.7867 165249.9n 0.7867 165250.0n 0.4628 165499.9n 0.4628 165500.0n 0.5114 165749.9n 0.5114 165750.0n 0.5276 165999.9n 0.5276 166000.0n 0.4790 166249.9n 0.4790 166250.0n 0.7948 166499.9n 0.7948 166500.0n 0.5600 166749.9n 0.5600 166750.0n 0.7382 166999.9n 0.7382 167000.0n 0.5438 167249.9n 0.5438 167250.0n 0.3980 167499.9n 0.3980 167500.0n 0.4547 167749.9n 0.4547 167750.0n 0.4709 167999.9n 0.4709 168000.0n 0.7948 168249.9n 0.7948 168250.0n 0.5114 168499.9n 0.5114 168500.0n 0.5438 168749.9n 0.5438 168750.0n 0.4871 168999.9n 0.4871 169000.0n 0.8000 169249.9n 0.8000 169250.0n 0.4952 169499.9n 0.4952 169500.0n 0.4871 169749.9n 0.4871 169750.0n 0.5276 169999.9n 0.5276 170000.0n 0.4952 170249.9n 0.4952 170250.0n 0.8000 170499.9n 0.8000 170500.0n 0.5033 170749.9n 0.5033 170750.0n 0.5519 170999.9n 0.5519 171000.0n 0.7058 171249.9n 0.7058 171250.0n 0.4709 171499.9n 0.4709 171500.0n 0.6248 171749.9n 0.6248 171750.0n 0.4871 171999.9n 0.4871 172000.0n 0.3980 172249.9n 0.3980 172250.0n 0.4871 172499.9n 0.4871 172500.0n 0.7867 172749.9n 0.7867 172750.0n 0.4628 172999.9n 0.4628 173000.0n 0.5114 173249.9n 0.5114 173250.0n 0.5276 173499.9n 0.5276 173500.0n 0.4790 173749.9n 0.4790 173750.0n 0.7948 173999.9n 0.7948 174000.0n 0.5600 174249.9n 0.5600 174250.0n 0.7382 174499.9n 0.7382 174500.0n 0.5438 174749.9n 0.5438 174750.0n 0.3980 174999.9n 0.3980 175000.0n 0.4547 175249.9n 0.4547 175250.0n 0.4709 175499.9n 0.4709 175500.0n 0.7948 175749.9n 0.7948 175750.0n 0.5114 175999.9n 0.5114 176000.0n 0.5438 176249.9n 0.5438 176250.0n 0.4871 176499.9n 0.4871 176500.0n 0.8000 176749.9n 0.8000 176750.0n 0.4952 176999.9n 0.4952 177000.0n 0.4871 177249.9n 0.4871 177250.0n 0.5276 177499.9n 0.5276 177500.0n 0.4952 177749.9n 0.4952 177750.0n 0.8000 177999.9n 0.8000 178000.0n 0.5033 178249.9n 0.5033 178250.0n 0.5519 178499.9n 0.5519 178500.0n 0.7058 178749.9n 0.7058 178750.0n 0.4709 178999.9n 0.4709 179000.0n 0.6248 179249.9n 0.6248 179250.0n 0.4871 179499.9n 0.4871 179500.0n 0.3980 179749.9n 0.3980 179750.0n 0.4871 179999.9n 0.4871 180000.0n 0.7867 180249.9n 0.7867 180250.0n 0.4628 180499.9n 0.4628 180500.0n 0.5114 180749.9n 0.5114 180750.0n 0.5276 180999.9n 0.5276 181000.0n 0.4790 181249.9n 0.4790 181250.0n 0.7948 181499.9n 0.7948 181500.0n 0.5600 181749.9n 0.5600 181750.0n 0.7382 181999.9n 0.7382 182000.0n 0.5438 182249.9n 0.5438 182250.0n 0.3980 182499.9n 0.3980 182500.0n 0.4547 182749.9n 0.4547 182750.0n 0.4709 182999.9n 0.4709 183000.0n 0.7948 183249.9n 0.7948 183250.0n 0.5114 183499.9n 0.5114 183500.0n 0.5438 183749.9n 0.5438 183750.0n 0.4871 183999.9n 0.4871 184000.0n 0.8000 184249.9n 0.8000 184250.0n 0.4952 184499.9n 0.4952 184500.0n 0.4871 184749.9n 0.4871 184750.0n 0.5276 184999.9n 0.5276 185000.0n 0.4952 185249.9n 0.4952 185250.0n 0.8000 185499.9n 0.8000 185500.0n 0.5033 185749.9n 0.5033 185750.0n 0.5519 185999.9n 0.5519 186000.0n 0.7058 186249.9n 0.7058 186250.0n 0.4709 186499.9n 0.4709 186500.0n 0.6248 186749.9n 0.6248 186750.0n 0.4871 186999.9n 0.4871 187000.0n 0.3980 187249.9n 0.3980 187250.0n 0.4871 187499.9n 0.4871 187500.0n 0.7867 187749.9n 0.7867 187750.0n 0.4628 187999.9n 0.4628 188000.0n 0.5114 188249.9n 0.5114 188250.0n 0.5276 188499.9n 0.5276 188500.0n 0.4790 188749.9n 0.4790 188750.0n 0.7948 188999.9n 0.7948 189000.0n 0.5600 189249.9n 0.5600 189250.0n 0.7382 189499.9n 0.7382 189500.0n 0.5438 189749.9n 0.5438 189750.0n 0.3980 189999.9n 0.3980 190000.0n 0.4547 190249.9n 0.4547 190250.0n 0.4709 190499.9n 0.4709 190500.0n 0.7948 190749.9n 0.7948 190750.0n 0.5114 190999.9n 0.5114 191000.0n 0.5438 191249.9n 0.5438 191250.0n 0.4871 191499.9n 0.4871 191500.0n 0.8000 191749.9n 0.8000 191750.0n 0.4952 191999.9n 0.4952 192000.0n 0.4871 192249.9n 0.4871 192250.0n 0.5276 192499.9n 0.5276 192500.0n 0.4952 192749.9n 0.4952 192750.0n 0.8000 192999.9n 0.8000 193000.0n 0.5033 193249.9n 0.5033 193250.0n 0.5519 193499.9n 0.5519 193500.0n 0.7058 193749.9n 0.7058 193750.0n 0.4709 193999.9n 0.4709 194000.0n 0.6248 194249.9n 0.6248 194250.0n 0.4871 194499.9n 0.4871 194500.0n 0.3980 194749.9n 0.3980 194750.0n 0.4871 194999.9n 0.4871 195000.0n 0.7867 195249.9n 0.7867 195250.0n 0.4628 195499.9n 0.4628 195500.0n 0.5114 195749.9n 0.5114 195750.0n 0.5276 195999.9n 0.5276 196000.0n 0.4790 196249.9n 0.4790 196250.0n 0.7948 196499.9n 0.7948 196500.0n 0.5600 196749.9n 0.5600 196750.0n 0.7382 196999.9n 0.7382 197000.0n 0.5438 197249.9n 0.5438 197250.0n 0.3980 197499.9n 0.3980 197500.0n 0.4547 197749.9n 0.4547 197750.0n 0.4709 197999.9n 0.4709 198000.0n 0.7948 198249.9n 0.7948 198250.0n 0.5114 198499.9n 0.5114 198500.0n 0.5438 198749.9n 0.5438 198750.0n 0.4871 198999.9n 0.4871 199000.0n 0.8000 199249.9n 0.8000 199250.0n 0.4952 199499.9n 0.4952 199500.0n 0.4871 199749.9n 0.4871 199750.0n 0.5276 199999.9n 0.5276 200000.0n 0.4952 200249.9n 0.4952 200250.0n 0.8000 200499.9n 0.8000 200500.0n 0.5033 200749.9n 0.5033 200750.0n 0.5519 200999.9n 0.5519 201000.0n 0.7058 201249.9n 0.7058 201250.0n 0.4709 201499.9n 0.4709 201500.0n 0.6248 201749.9n 0.6248 201750.0n 0.4871 201999.9n 0.4871 202000.0n 0.3980 202249.9n 0.3980 202250.0n 0.4871 202499.9n 0.4871 202500.0n 0.7867 202749.9n 0.7867 202750.0n 0.4628 202999.9n 0.4628 203000.0n 0.5114 203249.9n 0.5114 203250.0n 0.5276 203499.9n 0.5276 203500.0n 0.4790 203749.9n 0.4790 203750.0n 0.7948 203999.9n 0.7948 204000.0n 0.5600 204249.9n 0.5600 204250.0n 0.7382 204499.9n 0.7382 204500.0n 0.5438 204749.9n 0.5438 204750.0n 0.3980 204999.9n 0.3980 205000.0n 0.4547 205249.9n 0.4547 205250.0n 0.4709 205499.9n 0.4709 205500.0n 0.7948 205749.9n 0.7948 205750.0n 0.5114 205999.9n 0.5114 206000.0n 0.5438 206249.9n 0.5438 206250.0n 0.4871 206499.9n 0.4871 206500.0n 0.8000 206749.9n 0.8000 206750.0n 0.4952 206999.9n 0.4952 207000.0n 0.4871 207249.9n 0.4871 207250.0n 0.5276 207499.9n 0.5276 207500.0n 0.4952 207749.9n 0.4952 207750.0n 0.8000 207999.9n 0.8000 208000.0n 0.5033 208249.9n 0.5033 208250.0n 0.5519 208499.9n 0.5519 208500.0n 0.7058 208749.9n 0.7058 208750.0n 0.4709 208999.9n 0.4709 209000.0n 0.6248 209249.9n 0.6248 209250.0n 0.4871 209499.9n 0.4871 209500.0n 0.3980 209749.9n 0.3980 209750.0n 0.4871 209999.9n 0.4871 210000.0n 0.7867 210249.9n 0.7867 210250.0n 0.4628 210499.9n 0.4628 210500.0n 0.5114 210749.9n 0.5114 210750.0n 0.5276 210999.9n 0.5276 211000.0n 0.4790 211249.9n 0.4790 211250.0n 0.7948 211499.9n 0.7948 211500.0n 0.5600 211749.9n 0.5600 211750.0n 0.7382 211999.9n 0.7382 212000.0n 0.5438 212249.9n 0.5438 212250.0n 0.3980 212499.9n 0.3980 212500.0n 0.4547 212749.9n 0.4547 212750.0n 0.4709 212999.9n 0.4709 213000.0n 0.7948 213249.9n 0.7948 213250.0n 0.5114 213499.9n 0.5114 213500.0n 0.5438 213749.9n 0.5438 213750.0n 0.4871 213999.9n 0.4871 214000.0n 0.8000 214249.9n 0.8000 214250.0n 0.4952 214499.9n 0.4952 214500.0n 0.4871 214749.9n 0.4871 214750.0n 0.5276 214999.9n 0.5276 215000.0n 0.4952 215249.9n 0.4952 215250.0n 0.8000 215499.9n 0.8000 215500.0n 0.5033 215749.9n 0.5033 215750.0n 0.5519 215999.9n 0.5519 216000.0n 0.7058 216249.9n 0.7058 216250.0n 0.4709 216499.9n 0.4709 216500.0n 0.6248 216749.9n 0.6248 216750.0n 0.4871 216999.9n 0.4871 217000.0n 0.3980 217249.9n 0.3980 217250.0n 0.4871 217499.9n 0.4871 217500.0n 0.7867 217749.9n 0.7867 217750.0n 0.4628 217999.9n 0.4628 218000.0n 0.5114 218249.9n 0.5114 218250.0n 0.5276 218499.9n 0.5276 218500.0n 0.4790 218749.9n 0.4790 218750.0n 0.7948 218999.9n 0.7948 219000.0n 0.5600 219249.9n 0.5600 219250.0n 0.7382 219499.9n 0.7382 219500.0n 0.5438 219749.9n 0.5438 219750.0n 0.3980 219999.9n 0.3980 220000.0n 0.4547 220249.9n 0.4547 220250.0n 0.4709 220499.9n 0.4709 220500.0n 0.7948 220749.9n 0.7948 220750.0n 0.5114 220999.9n 0.5114 221000.0n 0.5438 221249.9n 0.5438 221250.0n 0.4871 221499.9n 0.4871 221500.0n 0.8000 221749.9n 0.8000 221750.0n 0.4952 221999.9n 0.4952 222000.0n 0.4871 222249.9n 0.4871 222250.0n 0.5276 222499.9n 0.5276 222500.0n 0.4952 222749.9n 0.4952 222750.0n 0.8000 222999.9n 0.8000 223000.0n 0.5033 223249.9n 0.5033 223250.0n 0.5519 223499.9n 0.5519 223500.0n 0.7058 223749.9n 0.7058 223750.0n 0.4709 223999.9n 0.4709 224000.0n 0.6248 224249.9n 0.6248 224250.0n 0.4871 224499.9n 0.4871 224500.0n 0.3980 224749.9n 0.3980 224750.0n 0.4871 224999.9n 0.4871 225000.0n 0.7867 225249.9n 0.7867 225250.0n 0.4628 225499.9n 0.4628 225500.0n 0.5114 225749.9n 0.5114 225750.0n 0.5276 225999.9n 0.5276 226000.0n 0.4790 226249.9n 0.4790 226250.0n 0.7948 226499.9n 0.7948 226500.0n 0.5600 226749.9n 0.5600 226750.0n 0.7382 226999.9n 0.7382 227000.0n 0.5438 227249.9n 0.5438 227250.0n 0.3980 227499.9n 0.3980 227500.0n 0.4547 227749.9n 0.4547 227750.0n 0.4709 227999.9n 0.4709 228000.0n 0.7948 228249.9n 0.7948 228250.0n 0.5114 228499.9n 0.5114 228500.0n 0.5438 228749.9n 0.5438 228750.0n 0.4871 228999.9n 0.4871 229000.0n 0.8000 229249.9n 0.8000 229250.0n 0.4952 229499.9n 0.4952 229500.0n 0.4871 229749.9n 0.4871 229750.0n 0.5276 229999.9n 0.5276 230000.0n 0.4952 230249.9n 0.4952 230250.0n 0.8000 230499.9n 0.8000 230500.0n 0.5033 230749.9n 0.5033 230750.0n 0.5519 230999.9n 0.5519 231000.0n 0.7058 231249.9n 0.7058 231250.0n 0.4709 231499.9n 0.4709 231500.0n 0.6248 231749.9n 0.6248 231750.0n 0.4871 231999.9n 0.4871 232000.0n 0.3980 232249.9n 0.3980 232250.0n 0.4871 232499.9n 0.4871 232500.0n 0.7867 232749.9n 0.7867 232750.0n 0.4628 232999.9n 0.4628 233000.0n 0.5114 233249.9n 0.5114 233250.0n 0.5276 233499.9n 0.5276 233500.0n 0.4790 233749.9n 0.4790 233750.0n 0.7948 233999.9n 0.7948 234000.0n 0.5600 234249.9n 0.5600 234250.0n 0.7382 234499.9n 0.7382 234500.0n 0.5438 234749.9n 0.5438 234750.0n 0.3980 234999.9n 0.3980 235000.0n 0.4547 235249.9n 0.4547 235250.0n 0.4709 235499.9n 0.4709 235500.0n 0.7948 235749.9n 0.7948 235750.0n 0.5114 235999.9n 0.5114 236000.0n 0.5438 236249.9n 0.5438 236250.0n 0.4871 236499.9n 0.4871 236500.0n 0.8000 236749.9n 0.8000 236750.0n 0.4952 236999.9n 0.4952 237000.0n 0.4871 237249.9n 0.4871 237250.0n 0.5276 237499.9n 0.5276 237500.0n 0.4952 237749.9n 0.4952 237750.0n 0.8000 237999.9n 0.8000 238000.0n 0.5033 238249.9n 0.5033 238250.0n 0.5519 238499.9n 0.5519 238500.0n 0.7058 238749.9n 0.7058 238750.0n 0.4709 238999.9n 0.4709 239000.0n 0.6248 239249.9n 0.6248 239250.0n 0.4871 239499.9n 0.4871 239500.0n 0.3980 239749.9n 0.3980 239750.0n 0.4871 239999.9n 0.4871 240000.0n 0.7867 240249.9n 0.7867 240250.0n 0.4628 240499.9n 0.4628 240500.0n 0.5114 240749.9n 0.5114 240750.0n 0.5276 240999.9n 0.5276 241000.0n 0.4790 241249.9n 0.4790 241250.0n 0.7948 241499.9n 0.7948 241500.0n 0.5600 241749.9n 0.5600 241750.0n 0.7382 241999.9n 0.7382 242000.0n 0.5438 242249.9n 0.5438 242250.0n 0.3980 242499.9n 0.3980 242500.0n 0.4547 242749.9n 0.4547 242750.0n 0.4709 242999.9n 0.4709 243000.0n 0.7948 243249.9n 0.7948 243250.0n 0.5114 243499.9n 0.5114 243500.0n 0.5438 243749.9n 0.5438 243750.0n 0.4871 243999.9n 0.4871 244000.0n 0.8000 244249.9n 0.8000 244250.0n 0.4952 244499.9n 0.4952 244500.0n 0.4871 244749.9n 0.4871 244750.0n 0.5276 244999.9n 0.5276 245000.0n 0.4952 245249.9n 0.4952 245250.0n 0.8000 245499.9n 0.8000 245500.0n 0.5033 245749.9n 0.5033 245750.0n 0.5519 245999.9n 0.5519 246000.0n 0.7058 246249.9n 0.7058 246250.0n 0.4709 246499.9n 0.4709 246500.0n 0.6248 246749.9n 0.6248 246750.0n 0.4871 246999.9n 0.4871 247000.0n 0.3980 247249.9n 0.3980 247250.0n 0.4871 247499.9n 0.4871 247500.0n 0.7867 247749.9n 0.7867 247750.0n 0.4628 247999.9n 0.4628 248000.0n 0.5114 248249.9n 0.5114 248250.0n 0.5276 248499.9n 0.5276 248500.0n 0.4790 248749.9n 0.4790 248750.0n 0.7948 248999.9n 0.7948 249000.0n 0.5600 249249.9n 0.5600 249250.0n 0.7382 249499.9n 0.7382 249500.0n 0.5438 249749.9n 0.5438 249750.0n 0.3980 249999.9n 0.3980 250000.0n 0.4547 250249.9n 0.4547 250250.0n 0.4709 250499.9n 0.4709 250500.0n 0.7948 250749.9n 0.7948 250750.0n 0.5114 250999.9n 0.5114 251000.0n 0.5438 251249.9n 0.5438 251250.0n 0.4871 251499.9n 0.4871 251500.0n 0.8000 251749.9n 0.8000 251750.0n 0.4952 251999.9n 0.4952 252000.0n 0.4871 252249.9n 0.4871 252250.0n 0.5276 252499.9n 0.5276 252500.0n 0.4952 252749.9n 0.4952 252750.0n 0.8000 252999.9n 0.8000 253000.0n 0.5033 253249.9n 0.5033 253250.0n 0.5519 253499.9n 0.5519 253500.0n 0.7058 253749.9n 0.7058 253750.0n 0.4709 253999.9n 0.4709 254000.0n 0.6248 254249.9n 0.6248 254250.0n 0.4871 254499.9n 0.4871 254500.0n 0.3980 254749.9n 0.3980 254750.0n 0.4871 254999.9n 0.4871 255000.0n 0.7867 255249.9n 0.7867 255250.0n 0.4628 255499.9n 0.4628 255500.0n 0.5114 255749.9n 0.5114 255750.0n 0.5276 255999.9n 0.5276 256000.0n 0.4790 256249.9n 0.4790 256250.0n 0.7948 256499.9n 0.7948 256500.0n 0.5600 256749.9n 0.5600 256750.0n 0.7382 256999.9n 0.7382 257000.0n 0.5438 257249.9n 0.5438 257250.0n 0.3980 257499.9n 0.3980 257500.0n 0.4547 257749.9n 0.4547 257750.0n 0.4709 257999.9n 0.4709 258000.0n 0.7948 258249.9n 0.7948 258250.0n 0.5114 258499.9n 0.5114 258500.0n 0.5438 258749.9n 0.5438 258750.0n 0.4871 258999.9n 0.4871 259000.0n 0.8000 259249.9n 0.8000 259250.0n 0.4952 259499.9n 0.4952 259500.0n 0.4871 259749.9n 0.4871 259750.0n 0.5276 259999.9n 0.5276 260000.0n 0.4952 260249.9n 0.4952 260250.0n 0.8000 260499.9n 0.8000 260500.0n 0.5033 260749.9n 0.5033 260750.0n 0.5519 260999.9n 0.5519 261000.0n 0.7058 261249.9n 0.7058 261250.0n 0.4709 261499.9n 0.4709 261500.0n 0.6248 261749.9n 0.6248 261750.0n 0.4871 261999.9n 0.4871 262000.0n 0.3980 262249.9n 0.3980 262250.0n 0.4871 262499.9n 0.4871 262500.0n 0.7867 262749.9n 0.7867 262750.0n 0.4628 262999.9n 0.4628 263000.0n 0.5114 263249.9n 0.5114 263250.0n 0.5276 263499.9n 0.5276 263500.0n 0.4790 263749.9n 0.4790 263750.0n 0.7948 263999.9n 0.7948 264000.0n 0.5600 264249.9n 0.5600 264250.0n 0.7382 264499.9n 0.7382 264500.0n 0.5438 264749.9n 0.5438 264750.0n 0.3980 264999.9n 0.3980 265000.0n 0.4547 265249.9n 0.4547 265250.0n 0.4709 265499.9n 0.4709 265500.0n 0.7948 265749.9n 0.7948 265750.0n 0.5114 265999.9n 0.5114 266000.0n 0.5438 266249.9n 0.5438 266250.0n 0.4871 266499.9n 0.4871 266500.0n 0.8000 266749.9n 0.8000 266750.0n 0.4952 266999.9n 0.4952 267000.0n 0.4871 267249.9n 0.4871 267250.0n 0.5276 267499.9n 0.5276 267500.0n 0.4952 267749.9n 0.4952 267750.0n 0.8000 267999.9n 0.8000 268000.0n 0.5033 268249.9n 0.5033 268250.0n 0.5519 268499.9n 0.5519 268500.0n 0.7058 268749.9n 0.7058 268750.0n 0.4709 268999.9n 0.4709 269000.0n 0.6248 269249.9n 0.6248 269250.0n 0.4871 269499.9n 0.4871 269500.0n 0.3980 269749.9n 0.3980 269750.0n 0.4871 269999.9n 0.4871 270000.0n 0.7867 270249.9n 0.7867 270250.0n 0.4628 270499.9n 0.4628 270500.0n 0.5114 270749.9n 0.5114 270750.0n 0.5276 270999.9n 0.5276 271000.0n 0.4790 271249.9n 0.4790 271250.0n 0.7948 271499.9n 0.7948 271500.0n 0.5600 271749.9n 0.5600 271750.0n 0.7382 271999.9n 0.7382 272000.0n 0.5438 272249.9n 0.5438 272250.0n 0.3980 272499.9n 0.3980 272500.0n 0.4547 272749.9n 0.4547 272750.0n 0.4709 272999.9n 0.4709 273000.0n 0.7948 273249.9n 0.7948 273250.0n 0.5114 273499.9n 0.5114 273500.0n 0.5438 273749.9n 0.5438 273750.0n 0.4871 273999.9n 0.4871 274000.0n 0.8000 274249.9n 0.8000 274250.0n 0.4952 274499.9n 0.4952 274500.0n 0.4871 274749.9n 0.4871 274750.0n 0.5276 274999.9n 0.5276 275000.0n 0.4952 275249.9n 0.4952 275250.0n 0.8000 275499.9n 0.8000 275500.0n 0.5033 275749.9n 0.5033 275750.0n 0.5519 275999.9n 0.5519 276000.0n 0.7058 276249.9n 0.7058 276250.0n 0.4709 276499.9n 0.4709 276500.0n 0.6248 276749.9n 0.6248 276750.0n 0.4871 276999.9n 0.4871 277000.0n 0.3980 277249.9n 0.3980 277250.0n 0.4871 277499.9n 0.4871 277500.0n 0.7867 277749.9n 0.7867 277750.0n 0.4628 277999.9n 0.4628 278000.0n 0.5114 278249.9n 0.5114 278250.0n 0.5276 278499.9n 0.5276 278500.0n 0.4790 278749.9n 0.4790 278750.0n 0.7948 278999.9n 0.7948 279000.0n 0.5600 279249.9n 0.5600 279250.0n 0.7382 279499.9n 0.7382 279500.0n 0.5438 279749.9n 0.5438 279750.0n 0.3980 279999.9n 0.3980 280000.0n 0.4547 280249.9n 0.4547 280250.0n 0.4709 280499.9n 0.4709 280500.0n 0.7948 280749.9n 0.7948 280750.0n 0.5114 280999.9n 0.5114 281000.0n 0.5438 281249.9n 0.5438 281250.0n 0.4871 281499.9n 0.4871 281500.0n 0.8000 281749.9n 0.8000 281750.0n 0.4952 281999.9n 0.4952 282000.0n 0.4871 282249.9n 0.4871 282250.0n 0.5276 282499.9n 0.5276 282500.0n 0.4952 282749.9n 0.4952 282750.0n 0.8000 282999.9n 0.8000 283000.0n 0.5033 283249.9n 0.5033 283250.0n 0.5519 283499.9n 0.5519 283500.0n 0.7058 283749.9n 0.7058 283750.0n 0.4709 283999.9n 0.4709 284000.0n 0.6248 284249.9n 0.6248 284250.0n 0.4871 284499.9n 0.4871 284500.0n 0.3980 284749.9n 0.3980 284750.0n 0.4871 284999.9n 0.4871 285000.0n 0.7867 285249.9n 0.7867 285250.0n 0.4628 285499.9n 0.4628 285500.0n 0.5114 285749.9n 0.5114 285750.0n 0.5276 285999.9n 0.5276 286000.0n 0.4790 286249.9n 0.4790 286250.0n 0.7948 286499.9n 0.7948 286500.0n 0.5600 286749.9n 0.5600 286750.0n 0.7382 286999.9n 0.7382 287000.0n 0.5438 287249.9n 0.5438 287250.0n 0.3980 287499.9n 0.3980 287500.0n 0.4547 287749.9n 0.4547 287750.0n 0.4709 287999.9n 0.4709 288000.0n 0.7948 288249.9n 0.7948 288250.0n 0.5114 288499.9n 0.5114 288500.0n 0.5438 288749.9n 0.5438 288750.0n 0.4871 288999.9n 0.4871 289000.0n 0.8000 289249.9n 0.8000 289250.0n 0.4952 289499.9n 0.4952 289500.0n 0.4871 289749.9n 0.4871 289750.0n 0.5276 289999.9n 0.5276 290000.0n 0.4952 290249.9n 0.4952 290250.0n 0.8000 290499.9n 0.8000 290500.0n 0.5033 290749.9n 0.5033 290750.0n 0.5519 290999.9n 0.5519 291000.0n 0.7058 291249.9n 0.7058 291250.0n 0.4709 291499.9n 0.4709 291500.0n 0.6248 291749.9n 0.6248 291750.0n 0.4871 291999.9n 0.4871 292000.0n 0.3980 292249.9n 0.3980 292250.0n 0.4871 292499.9n 0.4871 292500.0n 0.7867 292749.9n 0.7867 292750.0n 0.4628 292999.9n 0.4628 293000.0n 0.5114 293249.9n 0.5114 293250.0n 0.5276 293499.9n 0.5276 293500.0n 0.4790 293749.9n 0.4790 293750.0n 0.7948 293999.9n 0.7948 294000.0n 0.5600 294249.9n 0.5600 294250.0n 0.7382 294499.9n 0.7382 294500.0n 0.5438 294749.9n 0.5438 294750.0n 0.3980 294999.9n 0.3980 295000.0n 0.4547 295249.9n 0.4547 295250.0n 0.4709 295499.9n 0.4709 295500.0n 0.7948 295749.9n 0.7948 295750.0n 0.5114 295999.9n 0.5114 296000.0n 0.5438 296249.9n 0.5438 296250.0n 0.4871 296499.9n 0.4871 296500.0n 0.8000 296749.9n 0.8000 296750.0n 0.4952 296999.9n 0.4952 297000.0n 0.4871 297249.9n 0.4871 297250.0n 0.5276 297499.9n 0.5276 297500.0n 0.4952 297749.9n 0.4952 297750.0n 0.8000 297999.9n 0.8000 298000.0n 0.5033 298249.9n 0.5033 298250.0n 0.5519 298499.9n 0.5519 298500.0n 0.7058 298749.9n 0.7058 298750.0n 0.4709 298999.9n 0.4709 299000.0n 0.6248 299249.9n 0.6248 299250.0n 0.4871 299499.9n 0.4871 299500.0n 0.3980 299749.9n 0.3980 299750.0n 0.4871)
Vxp2 a_xp2 0 PWL(0.0n 0.6036 249.9n 0.6036 250.0n 0.4994 499.9n 0.4994 500.0n 0.6175 749.9n 0.6175 750.0n 0.5133 999.9n 0.5133 1000.0n 0.5411 1249.9n 0.5411 1250.0n 0.6105 1499.9n 0.6105 1500.0n 0.5064 1749.9n 0.5064 1750.0n 0.6452 1999.9n 0.6452 2000.0n 0.5689 2249.9n 0.5689 2250.0n 0.2494 2499.9n 0.2494 2500.0n 0.4647 2749.9n 0.4647 2750.0n 0.4925 2999.9n 0.4925 3000.0n 0.6175 3249.9n 0.6175 3250.0n 0.3536 3499.9n 0.3536 3500.0n 0.4508 3749.9n 0.4508 3750.0n 0.5619 3999.9n 0.5619 4000.0n 0.5897 4249.9n 0.5897 4250.0n 0.4091 4499.9n 0.4091 4500.0n 0.4091 4749.9n 0.4091 4750.0n 0.4994 4999.9n 0.4994 5000.0n 0.4508 5249.9n 0.4508 5250.0n 0.6591 5499.9n 0.6591 5500.0n 0.4994 5749.9n 0.4994 5750.0n 0.4508 5999.9n 0.4508 6000.0n 0.6730 6249.9n 0.6730 6250.0n 0.6036 6499.9n 0.6036 6500.0n 0.6244 6749.9n 0.6244 6750.0n 0.5550 6999.9n 0.5550 7000.0n 0.5480 7249.9n 0.5480 7250.0n 0.5689 7499.9n 0.5689 7500.0n 0.6036 7749.9n 0.6036 7750.0n 0.4994 7999.9n 0.4994 8000.0n 0.6175 8249.9n 0.6175 8250.0n 0.5133 8499.9n 0.5133 8500.0n 0.5411 8749.9n 0.5411 8750.0n 0.6105 8999.9n 0.6105 9000.0n 0.5064 9249.9n 0.5064 9250.0n 0.6452 9499.9n 0.6452 9500.0n 0.5689 9749.9n 0.5689 9750.0n 0.2494 9999.9n 0.2494 10000.0n 0.4647 10249.9n 0.4647 10250.0n 0.4925 10499.9n 0.4925 10500.0n 0.6175 10749.9n 0.6175 10750.0n 0.3536 10999.9n 0.3536 11000.0n 0.4508 11249.9n 0.4508 11250.0n 0.5619 11499.9n 0.5619 11500.0n 0.5897 11749.9n 0.5897 11750.0n 0.4091 11999.9n 0.4091 12000.0n 0.4091 12249.9n 0.4091 12250.0n 0.4994 12499.9n 0.4994 12500.0n 0.4508 12749.9n 0.4508 12750.0n 0.6591 12999.9n 0.6591 13000.0n 0.4994 13249.9n 0.4994 13250.0n 0.4508 13499.9n 0.4508 13500.0n 0.6730 13749.9n 0.6730 13750.0n 0.6036 13999.9n 0.6036 14000.0n 0.6244 14249.9n 0.6244 14250.0n 0.5550 14499.9n 0.5550 14500.0n 0.5480 14749.9n 0.5480 14750.0n 0.5689 14999.9n 0.5689 15000.0n 0.6036 15249.9n 0.6036 15250.0n 0.4994 15499.9n 0.4994 15500.0n 0.6175 15749.9n 0.6175 15750.0n 0.5133 15999.9n 0.5133 16000.0n 0.5411 16249.9n 0.5411 16250.0n 0.6105 16499.9n 0.6105 16500.0n 0.5064 16749.9n 0.5064 16750.0n 0.6452 16999.9n 0.6452 17000.0n 0.5689 17249.9n 0.5689 17250.0n 0.2494 17499.9n 0.2494 17500.0n 0.4647 17749.9n 0.4647 17750.0n 0.4925 17999.9n 0.4925 18000.0n 0.6175 18249.9n 0.6175 18250.0n 0.3536 18499.9n 0.3536 18500.0n 0.4508 18749.9n 0.4508 18750.0n 0.5619 18999.9n 0.5619 19000.0n 0.5897 19249.9n 0.5897 19250.0n 0.4091 19499.9n 0.4091 19500.0n 0.4091 19749.9n 0.4091 19750.0n 0.4994 19999.9n 0.4994 20000.0n 0.4508 20249.9n 0.4508 20250.0n 0.6591 20499.9n 0.6591 20500.0n 0.4994 20749.9n 0.4994 20750.0n 0.4508 20999.9n 0.4508 21000.0n 0.6730 21249.9n 0.6730 21250.0n 0.6036 21499.9n 0.6036 21500.0n 0.6244 21749.9n 0.6244 21750.0n 0.5550 21999.9n 0.5550 22000.0n 0.5480 22249.9n 0.5480 22250.0n 0.5689 22499.9n 0.5689 22500.0n 0.6036 22749.9n 0.6036 22750.0n 0.4994 22999.9n 0.4994 23000.0n 0.6175 23249.9n 0.6175 23250.0n 0.5133 23499.9n 0.5133 23500.0n 0.5411 23749.9n 0.5411 23750.0n 0.6105 23999.9n 0.6105 24000.0n 0.5064 24249.9n 0.5064 24250.0n 0.6452 24499.9n 0.6452 24500.0n 0.5689 24749.9n 0.5689 24750.0n 0.2494 24999.9n 0.2494 25000.0n 0.4647 25249.9n 0.4647 25250.0n 0.4925 25499.9n 0.4925 25500.0n 0.6175 25749.9n 0.6175 25750.0n 0.3536 25999.9n 0.3536 26000.0n 0.4508 26249.9n 0.4508 26250.0n 0.5619 26499.9n 0.5619 26500.0n 0.5897 26749.9n 0.5897 26750.0n 0.4091 26999.9n 0.4091 27000.0n 0.4091 27249.9n 0.4091 27250.0n 0.4994 27499.9n 0.4994 27500.0n 0.4508 27749.9n 0.4508 27750.0n 0.6591 27999.9n 0.6591 28000.0n 0.4994 28249.9n 0.4994 28250.0n 0.4508 28499.9n 0.4508 28500.0n 0.6730 28749.9n 0.6730 28750.0n 0.6036 28999.9n 0.6036 29000.0n 0.6244 29249.9n 0.6244 29250.0n 0.5550 29499.9n 0.5550 29500.0n 0.5480 29749.9n 0.5480 29750.0n 0.5689 29999.9n 0.5689 30000.0n 0.6036 30249.9n 0.6036 30250.0n 0.4994 30499.9n 0.4994 30500.0n 0.6175 30749.9n 0.6175 30750.0n 0.5133 30999.9n 0.5133 31000.0n 0.5411 31249.9n 0.5411 31250.0n 0.6105 31499.9n 0.6105 31500.0n 0.5064 31749.9n 0.5064 31750.0n 0.6452 31999.9n 0.6452 32000.0n 0.5689 32249.9n 0.5689 32250.0n 0.2494 32499.9n 0.2494 32500.0n 0.4647 32749.9n 0.4647 32750.0n 0.4925 32999.9n 0.4925 33000.0n 0.6175 33249.9n 0.6175 33250.0n 0.3536 33499.9n 0.3536 33500.0n 0.4508 33749.9n 0.4508 33750.0n 0.5619 33999.9n 0.5619 34000.0n 0.5897 34249.9n 0.5897 34250.0n 0.4091 34499.9n 0.4091 34500.0n 0.4091 34749.9n 0.4091 34750.0n 0.4994 34999.9n 0.4994 35000.0n 0.4508 35249.9n 0.4508 35250.0n 0.6591 35499.9n 0.6591 35500.0n 0.4994 35749.9n 0.4994 35750.0n 0.4508 35999.9n 0.4508 36000.0n 0.6730 36249.9n 0.6730 36250.0n 0.6036 36499.9n 0.6036 36500.0n 0.6244 36749.9n 0.6244 36750.0n 0.5550 36999.9n 0.5550 37000.0n 0.5480 37249.9n 0.5480 37250.0n 0.5689 37499.9n 0.5689 37500.0n 0.6036 37749.9n 0.6036 37750.0n 0.4994 37999.9n 0.4994 38000.0n 0.6175 38249.9n 0.6175 38250.0n 0.5133 38499.9n 0.5133 38500.0n 0.5411 38749.9n 0.5411 38750.0n 0.6105 38999.9n 0.6105 39000.0n 0.5064 39249.9n 0.5064 39250.0n 0.6452 39499.9n 0.6452 39500.0n 0.5689 39749.9n 0.5689 39750.0n 0.2494 39999.9n 0.2494 40000.0n 0.4647 40249.9n 0.4647 40250.0n 0.4925 40499.9n 0.4925 40500.0n 0.6175 40749.9n 0.6175 40750.0n 0.3536 40999.9n 0.3536 41000.0n 0.4508 41249.9n 0.4508 41250.0n 0.5619 41499.9n 0.5619 41500.0n 0.5897 41749.9n 0.5897 41750.0n 0.4091 41999.9n 0.4091 42000.0n 0.4091 42249.9n 0.4091 42250.0n 0.4994 42499.9n 0.4994 42500.0n 0.4508 42749.9n 0.4508 42750.0n 0.6591 42999.9n 0.6591 43000.0n 0.4994 43249.9n 0.4994 43250.0n 0.4508 43499.9n 0.4508 43500.0n 0.6730 43749.9n 0.6730 43750.0n 0.6036 43999.9n 0.6036 44000.0n 0.6244 44249.9n 0.6244 44250.0n 0.5550 44499.9n 0.5550 44500.0n 0.5480 44749.9n 0.5480 44750.0n 0.5689 44999.9n 0.5689 45000.0n 0.6036 45249.9n 0.6036 45250.0n 0.4994 45499.9n 0.4994 45500.0n 0.6175 45749.9n 0.6175 45750.0n 0.5133 45999.9n 0.5133 46000.0n 0.5411 46249.9n 0.5411 46250.0n 0.6105 46499.9n 0.6105 46500.0n 0.5064 46749.9n 0.5064 46750.0n 0.6452 46999.9n 0.6452 47000.0n 0.5689 47249.9n 0.5689 47250.0n 0.2494 47499.9n 0.2494 47500.0n 0.4647 47749.9n 0.4647 47750.0n 0.4925 47999.9n 0.4925 48000.0n 0.6175 48249.9n 0.6175 48250.0n 0.3536 48499.9n 0.3536 48500.0n 0.4508 48749.9n 0.4508 48750.0n 0.5619 48999.9n 0.5619 49000.0n 0.5897 49249.9n 0.5897 49250.0n 0.4091 49499.9n 0.4091 49500.0n 0.4091 49749.9n 0.4091 49750.0n 0.4994 49999.9n 0.4994 50000.0n 0.4508 50249.9n 0.4508 50250.0n 0.6591 50499.9n 0.6591 50500.0n 0.4994 50749.9n 0.4994 50750.0n 0.4508 50999.9n 0.4508 51000.0n 0.6730 51249.9n 0.6730 51250.0n 0.6036 51499.9n 0.6036 51500.0n 0.6244 51749.9n 0.6244 51750.0n 0.5550 51999.9n 0.5550 52000.0n 0.5480 52249.9n 0.5480 52250.0n 0.5689 52499.9n 0.5689 52500.0n 0.6036 52749.9n 0.6036 52750.0n 0.4994 52999.9n 0.4994 53000.0n 0.6175 53249.9n 0.6175 53250.0n 0.5133 53499.9n 0.5133 53500.0n 0.5411 53749.9n 0.5411 53750.0n 0.6105 53999.9n 0.6105 54000.0n 0.5064 54249.9n 0.5064 54250.0n 0.6452 54499.9n 0.6452 54500.0n 0.5689 54749.9n 0.5689 54750.0n 0.2494 54999.9n 0.2494 55000.0n 0.4647 55249.9n 0.4647 55250.0n 0.4925 55499.9n 0.4925 55500.0n 0.6175 55749.9n 0.6175 55750.0n 0.3536 55999.9n 0.3536 56000.0n 0.4508 56249.9n 0.4508 56250.0n 0.5619 56499.9n 0.5619 56500.0n 0.5897 56749.9n 0.5897 56750.0n 0.4091 56999.9n 0.4091 57000.0n 0.4091 57249.9n 0.4091 57250.0n 0.4994 57499.9n 0.4994 57500.0n 0.4508 57749.9n 0.4508 57750.0n 0.6591 57999.9n 0.6591 58000.0n 0.4994 58249.9n 0.4994 58250.0n 0.4508 58499.9n 0.4508 58500.0n 0.6730 58749.9n 0.6730 58750.0n 0.6036 58999.9n 0.6036 59000.0n 0.6244 59249.9n 0.6244 59250.0n 0.5550 59499.9n 0.5550 59500.0n 0.5480 59749.9n 0.5480 59750.0n 0.5689 59999.9n 0.5689 60000.0n 0.6036 60249.9n 0.6036 60250.0n 0.4994 60499.9n 0.4994 60500.0n 0.6175 60749.9n 0.6175 60750.0n 0.5133 60999.9n 0.5133 61000.0n 0.5411 61249.9n 0.5411 61250.0n 0.6105 61499.9n 0.6105 61500.0n 0.5064 61749.9n 0.5064 61750.0n 0.6452 61999.9n 0.6452 62000.0n 0.5689 62249.9n 0.5689 62250.0n 0.2494 62499.9n 0.2494 62500.0n 0.4647 62749.9n 0.4647 62750.0n 0.4925 62999.9n 0.4925 63000.0n 0.6175 63249.9n 0.6175 63250.0n 0.3536 63499.9n 0.3536 63500.0n 0.4508 63749.9n 0.4508 63750.0n 0.5619 63999.9n 0.5619 64000.0n 0.5897 64249.9n 0.5897 64250.0n 0.4091 64499.9n 0.4091 64500.0n 0.4091 64749.9n 0.4091 64750.0n 0.4994 64999.9n 0.4994 65000.0n 0.4508 65249.9n 0.4508 65250.0n 0.6591 65499.9n 0.6591 65500.0n 0.4994 65749.9n 0.4994 65750.0n 0.4508 65999.9n 0.4508 66000.0n 0.6730 66249.9n 0.6730 66250.0n 0.6036 66499.9n 0.6036 66500.0n 0.6244 66749.9n 0.6244 66750.0n 0.5550 66999.9n 0.5550 67000.0n 0.5480 67249.9n 0.5480 67250.0n 0.5689 67499.9n 0.5689 67500.0n 0.6036 67749.9n 0.6036 67750.0n 0.4994 67999.9n 0.4994 68000.0n 0.6175 68249.9n 0.6175 68250.0n 0.5133 68499.9n 0.5133 68500.0n 0.5411 68749.9n 0.5411 68750.0n 0.6105 68999.9n 0.6105 69000.0n 0.5064 69249.9n 0.5064 69250.0n 0.6452 69499.9n 0.6452 69500.0n 0.5689 69749.9n 0.5689 69750.0n 0.2494 69999.9n 0.2494 70000.0n 0.4647 70249.9n 0.4647 70250.0n 0.4925 70499.9n 0.4925 70500.0n 0.6175 70749.9n 0.6175 70750.0n 0.3536 70999.9n 0.3536 71000.0n 0.4508 71249.9n 0.4508 71250.0n 0.5619 71499.9n 0.5619 71500.0n 0.5897 71749.9n 0.5897 71750.0n 0.4091 71999.9n 0.4091 72000.0n 0.4091 72249.9n 0.4091 72250.0n 0.4994 72499.9n 0.4994 72500.0n 0.4508 72749.9n 0.4508 72750.0n 0.6591 72999.9n 0.6591 73000.0n 0.4994 73249.9n 0.4994 73250.0n 0.4508 73499.9n 0.4508 73500.0n 0.6730 73749.9n 0.6730 73750.0n 0.6036 73999.9n 0.6036 74000.0n 0.6244 74249.9n 0.6244 74250.0n 0.5550 74499.9n 0.5550 74500.0n 0.5480 74749.9n 0.5480 74750.0n 0.5689 74999.9n 0.5689 75000.0n 0.6036 75249.9n 0.6036 75250.0n 0.4994 75499.9n 0.4994 75500.0n 0.6175 75749.9n 0.6175 75750.0n 0.5133 75999.9n 0.5133 76000.0n 0.5411 76249.9n 0.5411 76250.0n 0.6105 76499.9n 0.6105 76500.0n 0.5064 76749.9n 0.5064 76750.0n 0.6452 76999.9n 0.6452 77000.0n 0.5689 77249.9n 0.5689 77250.0n 0.2494 77499.9n 0.2494 77500.0n 0.4647 77749.9n 0.4647 77750.0n 0.4925 77999.9n 0.4925 78000.0n 0.6175 78249.9n 0.6175 78250.0n 0.3536 78499.9n 0.3536 78500.0n 0.4508 78749.9n 0.4508 78750.0n 0.5619 78999.9n 0.5619 79000.0n 0.5897 79249.9n 0.5897 79250.0n 0.4091 79499.9n 0.4091 79500.0n 0.4091 79749.9n 0.4091 79750.0n 0.4994 79999.9n 0.4994 80000.0n 0.4508 80249.9n 0.4508 80250.0n 0.6591 80499.9n 0.6591 80500.0n 0.4994 80749.9n 0.4994 80750.0n 0.4508 80999.9n 0.4508 81000.0n 0.6730 81249.9n 0.6730 81250.0n 0.6036 81499.9n 0.6036 81500.0n 0.6244 81749.9n 0.6244 81750.0n 0.5550 81999.9n 0.5550 82000.0n 0.5480 82249.9n 0.5480 82250.0n 0.5689 82499.9n 0.5689 82500.0n 0.6036 82749.9n 0.6036 82750.0n 0.4994 82999.9n 0.4994 83000.0n 0.6175 83249.9n 0.6175 83250.0n 0.5133 83499.9n 0.5133 83500.0n 0.5411 83749.9n 0.5411 83750.0n 0.6105 83999.9n 0.6105 84000.0n 0.5064 84249.9n 0.5064 84250.0n 0.6452 84499.9n 0.6452 84500.0n 0.5689 84749.9n 0.5689 84750.0n 0.2494 84999.9n 0.2494 85000.0n 0.4647 85249.9n 0.4647 85250.0n 0.4925 85499.9n 0.4925 85500.0n 0.6175 85749.9n 0.6175 85750.0n 0.3536 85999.9n 0.3536 86000.0n 0.4508 86249.9n 0.4508 86250.0n 0.5619 86499.9n 0.5619 86500.0n 0.5897 86749.9n 0.5897 86750.0n 0.4091 86999.9n 0.4091 87000.0n 0.4091 87249.9n 0.4091 87250.0n 0.4994 87499.9n 0.4994 87500.0n 0.4508 87749.9n 0.4508 87750.0n 0.6591 87999.9n 0.6591 88000.0n 0.4994 88249.9n 0.4994 88250.0n 0.4508 88499.9n 0.4508 88500.0n 0.6730 88749.9n 0.6730 88750.0n 0.6036 88999.9n 0.6036 89000.0n 0.6244 89249.9n 0.6244 89250.0n 0.5550 89499.9n 0.5550 89500.0n 0.5480 89749.9n 0.5480 89750.0n 0.5689 89999.9n 0.5689 90000.0n 0.6036 90249.9n 0.6036 90250.0n 0.4994 90499.9n 0.4994 90500.0n 0.6175 90749.9n 0.6175 90750.0n 0.5133 90999.9n 0.5133 91000.0n 0.5411 91249.9n 0.5411 91250.0n 0.6105 91499.9n 0.6105 91500.0n 0.5064 91749.9n 0.5064 91750.0n 0.6452 91999.9n 0.6452 92000.0n 0.5689 92249.9n 0.5689 92250.0n 0.2494 92499.9n 0.2494 92500.0n 0.4647 92749.9n 0.4647 92750.0n 0.4925 92999.9n 0.4925 93000.0n 0.6175 93249.9n 0.6175 93250.0n 0.3536 93499.9n 0.3536 93500.0n 0.4508 93749.9n 0.4508 93750.0n 0.5619 93999.9n 0.5619 94000.0n 0.5897 94249.9n 0.5897 94250.0n 0.4091 94499.9n 0.4091 94500.0n 0.4091 94749.9n 0.4091 94750.0n 0.4994 94999.9n 0.4994 95000.0n 0.4508 95249.9n 0.4508 95250.0n 0.6591 95499.9n 0.6591 95500.0n 0.4994 95749.9n 0.4994 95750.0n 0.4508 95999.9n 0.4508 96000.0n 0.6730 96249.9n 0.6730 96250.0n 0.6036 96499.9n 0.6036 96500.0n 0.6244 96749.9n 0.6244 96750.0n 0.5550 96999.9n 0.5550 97000.0n 0.5480 97249.9n 0.5480 97250.0n 0.5689 97499.9n 0.5689 97500.0n 0.6036 97749.9n 0.6036 97750.0n 0.4994 97999.9n 0.4994 98000.0n 0.6175 98249.9n 0.6175 98250.0n 0.5133 98499.9n 0.5133 98500.0n 0.5411 98749.9n 0.5411 98750.0n 0.6105 98999.9n 0.6105 99000.0n 0.5064 99249.9n 0.5064 99250.0n 0.6452 99499.9n 0.6452 99500.0n 0.5689 99749.9n 0.5689 99750.0n 0.2494 99999.9n 0.2494 100000.0n 0.4647 100249.9n 0.4647 100250.0n 0.4925 100499.9n 0.4925 100500.0n 0.6175 100749.9n 0.6175 100750.0n 0.3536 100999.9n 0.3536 101000.0n 0.4508 101249.9n 0.4508 101250.0n 0.5619 101499.9n 0.5619 101500.0n 0.5897 101749.9n 0.5897 101750.0n 0.4091 101999.9n 0.4091 102000.0n 0.4091 102249.9n 0.4091 102250.0n 0.4994 102499.9n 0.4994 102500.0n 0.4508 102749.9n 0.4508 102750.0n 0.6591 102999.9n 0.6591 103000.0n 0.4994 103249.9n 0.4994 103250.0n 0.4508 103499.9n 0.4508 103500.0n 0.6730 103749.9n 0.6730 103750.0n 0.6036 103999.9n 0.6036 104000.0n 0.6244 104249.9n 0.6244 104250.0n 0.5550 104499.9n 0.5550 104500.0n 0.5480 104749.9n 0.5480 104750.0n 0.5689 104999.9n 0.5689 105000.0n 0.6036 105249.9n 0.6036 105250.0n 0.4994 105499.9n 0.4994 105500.0n 0.6175 105749.9n 0.6175 105750.0n 0.5133 105999.9n 0.5133 106000.0n 0.5411 106249.9n 0.5411 106250.0n 0.6105 106499.9n 0.6105 106500.0n 0.5064 106749.9n 0.5064 106750.0n 0.6452 106999.9n 0.6452 107000.0n 0.5689 107249.9n 0.5689 107250.0n 0.2494 107499.9n 0.2494 107500.0n 0.4647 107749.9n 0.4647 107750.0n 0.4925 107999.9n 0.4925 108000.0n 0.6175 108249.9n 0.6175 108250.0n 0.3536 108499.9n 0.3536 108500.0n 0.4508 108749.9n 0.4508 108750.0n 0.5619 108999.9n 0.5619 109000.0n 0.5897 109249.9n 0.5897 109250.0n 0.4091 109499.9n 0.4091 109500.0n 0.4091 109749.9n 0.4091 109750.0n 0.4994 109999.9n 0.4994 110000.0n 0.4508 110249.9n 0.4508 110250.0n 0.6591 110499.9n 0.6591 110500.0n 0.4994 110749.9n 0.4994 110750.0n 0.4508 110999.9n 0.4508 111000.0n 0.6730 111249.9n 0.6730 111250.0n 0.6036 111499.9n 0.6036 111500.0n 0.6244 111749.9n 0.6244 111750.0n 0.5550 111999.9n 0.5550 112000.0n 0.5480 112249.9n 0.5480 112250.0n 0.5689 112499.9n 0.5689 112500.0n 0.6036 112749.9n 0.6036 112750.0n 0.4994 112999.9n 0.4994 113000.0n 0.6175 113249.9n 0.6175 113250.0n 0.5133 113499.9n 0.5133 113500.0n 0.5411 113749.9n 0.5411 113750.0n 0.6105 113999.9n 0.6105 114000.0n 0.5064 114249.9n 0.5064 114250.0n 0.6452 114499.9n 0.6452 114500.0n 0.5689 114749.9n 0.5689 114750.0n 0.2494 114999.9n 0.2494 115000.0n 0.4647 115249.9n 0.4647 115250.0n 0.4925 115499.9n 0.4925 115500.0n 0.6175 115749.9n 0.6175 115750.0n 0.3536 115999.9n 0.3536 116000.0n 0.4508 116249.9n 0.4508 116250.0n 0.5619 116499.9n 0.5619 116500.0n 0.5897 116749.9n 0.5897 116750.0n 0.4091 116999.9n 0.4091 117000.0n 0.4091 117249.9n 0.4091 117250.0n 0.4994 117499.9n 0.4994 117500.0n 0.4508 117749.9n 0.4508 117750.0n 0.6591 117999.9n 0.6591 118000.0n 0.4994 118249.9n 0.4994 118250.0n 0.4508 118499.9n 0.4508 118500.0n 0.6730 118749.9n 0.6730 118750.0n 0.6036 118999.9n 0.6036 119000.0n 0.6244 119249.9n 0.6244 119250.0n 0.5550 119499.9n 0.5550 119500.0n 0.5480 119749.9n 0.5480 119750.0n 0.5689 119999.9n 0.5689 120000.0n 0.6036 120249.9n 0.6036 120250.0n 0.4994 120499.9n 0.4994 120500.0n 0.6175 120749.9n 0.6175 120750.0n 0.5133 120999.9n 0.5133 121000.0n 0.5411 121249.9n 0.5411 121250.0n 0.6105 121499.9n 0.6105 121500.0n 0.5064 121749.9n 0.5064 121750.0n 0.6452 121999.9n 0.6452 122000.0n 0.5689 122249.9n 0.5689 122250.0n 0.2494 122499.9n 0.2494 122500.0n 0.4647 122749.9n 0.4647 122750.0n 0.4925 122999.9n 0.4925 123000.0n 0.6175 123249.9n 0.6175 123250.0n 0.3536 123499.9n 0.3536 123500.0n 0.4508 123749.9n 0.4508 123750.0n 0.5619 123999.9n 0.5619 124000.0n 0.5897 124249.9n 0.5897 124250.0n 0.4091 124499.9n 0.4091 124500.0n 0.4091 124749.9n 0.4091 124750.0n 0.4994 124999.9n 0.4994 125000.0n 0.4508 125249.9n 0.4508 125250.0n 0.6591 125499.9n 0.6591 125500.0n 0.4994 125749.9n 0.4994 125750.0n 0.4508 125999.9n 0.4508 126000.0n 0.6730 126249.9n 0.6730 126250.0n 0.6036 126499.9n 0.6036 126500.0n 0.6244 126749.9n 0.6244 126750.0n 0.5550 126999.9n 0.5550 127000.0n 0.5480 127249.9n 0.5480 127250.0n 0.5689 127499.9n 0.5689 127500.0n 0.6036 127749.9n 0.6036 127750.0n 0.4994 127999.9n 0.4994 128000.0n 0.6175 128249.9n 0.6175 128250.0n 0.5133 128499.9n 0.5133 128500.0n 0.5411 128749.9n 0.5411 128750.0n 0.6105 128999.9n 0.6105 129000.0n 0.5064 129249.9n 0.5064 129250.0n 0.6452 129499.9n 0.6452 129500.0n 0.5689 129749.9n 0.5689 129750.0n 0.2494 129999.9n 0.2494 130000.0n 0.4647 130249.9n 0.4647 130250.0n 0.4925 130499.9n 0.4925 130500.0n 0.6175 130749.9n 0.6175 130750.0n 0.3536 130999.9n 0.3536 131000.0n 0.4508 131249.9n 0.4508 131250.0n 0.5619 131499.9n 0.5619 131500.0n 0.5897 131749.9n 0.5897 131750.0n 0.4091 131999.9n 0.4091 132000.0n 0.4091 132249.9n 0.4091 132250.0n 0.4994 132499.9n 0.4994 132500.0n 0.4508 132749.9n 0.4508 132750.0n 0.6591 132999.9n 0.6591 133000.0n 0.4994 133249.9n 0.4994 133250.0n 0.4508 133499.9n 0.4508 133500.0n 0.6730 133749.9n 0.6730 133750.0n 0.6036 133999.9n 0.6036 134000.0n 0.6244 134249.9n 0.6244 134250.0n 0.5550 134499.9n 0.5550 134500.0n 0.5480 134749.9n 0.5480 134750.0n 0.5689 134999.9n 0.5689 135000.0n 0.6036 135249.9n 0.6036 135250.0n 0.4994 135499.9n 0.4994 135500.0n 0.6175 135749.9n 0.6175 135750.0n 0.5133 135999.9n 0.5133 136000.0n 0.5411 136249.9n 0.5411 136250.0n 0.6105 136499.9n 0.6105 136500.0n 0.5064 136749.9n 0.5064 136750.0n 0.6452 136999.9n 0.6452 137000.0n 0.5689 137249.9n 0.5689 137250.0n 0.2494 137499.9n 0.2494 137500.0n 0.4647 137749.9n 0.4647 137750.0n 0.4925 137999.9n 0.4925 138000.0n 0.6175 138249.9n 0.6175 138250.0n 0.3536 138499.9n 0.3536 138500.0n 0.4508 138749.9n 0.4508 138750.0n 0.5619 138999.9n 0.5619 139000.0n 0.5897 139249.9n 0.5897 139250.0n 0.4091 139499.9n 0.4091 139500.0n 0.4091 139749.9n 0.4091 139750.0n 0.4994 139999.9n 0.4994 140000.0n 0.4508 140249.9n 0.4508 140250.0n 0.6591 140499.9n 0.6591 140500.0n 0.4994 140749.9n 0.4994 140750.0n 0.4508 140999.9n 0.4508 141000.0n 0.6730 141249.9n 0.6730 141250.0n 0.6036 141499.9n 0.6036 141500.0n 0.6244 141749.9n 0.6244 141750.0n 0.5550 141999.9n 0.5550 142000.0n 0.5480 142249.9n 0.5480 142250.0n 0.5689 142499.9n 0.5689 142500.0n 0.6036 142749.9n 0.6036 142750.0n 0.4994 142999.9n 0.4994 143000.0n 0.6175 143249.9n 0.6175 143250.0n 0.5133 143499.9n 0.5133 143500.0n 0.5411 143749.9n 0.5411 143750.0n 0.6105 143999.9n 0.6105 144000.0n 0.5064 144249.9n 0.5064 144250.0n 0.6452 144499.9n 0.6452 144500.0n 0.5689 144749.9n 0.5689 144750.0n 0.2494 144999.9n 0.2494 145000.0n 0.4647 145249.9n 0.4647 145250.0n 0.4925 145499.9n 0.4925 145500.0n 0.6175 145749.9n 0.6175 145750.0n 0.3536 145999.9n 0.3536 146000.0n 0.4508 146249.9n 0.4508 146250.0n 0.5619 146499.9n 0.5619 146500.0n 0.5897 146749.9n 0.5897 146750.0n 0.4091 146999.9n 0.4091 147000.0n 0.4091 147249.9n 0.4091 147250.0n 0.4994 147499.9n 0.4994 147500.0n 0.4508 147749.9n 0.4508 147750.0n 0.6591 147999.9n 0.6591 148000.0n 0.4994 148249.9n 0.4994 148250.0n 0.4508 148499.9n 0.4508 148500.0n 0.6730 148749.9n 0.6730 148750.0n 0.6036 148999.9n 0.6036 149000.0n 0.6244 149249.9n 0.6244 149250.0n 0.5550 149499.9n 0.5550 149500.0n 0.5480 149749.9n 0.5480 149750.0n 0.5689 149999.9n 0.5689 150000.0n 0.6036 150249.9n 0.6036 150250.0n 0.4994 150499.9n 0.4994 150500.0n 0.6175 150749.9n 0.6175 150750.0n 0.5133 150999.9n 0.5133 151000.0n 0.5411 151249.9n 0.5411 151250.0n 0.6105 151499.9n 0.6105 151500.0n 0.5064 151749.9n 0.5064 151750.0n 0.6452 151999.9n 0.6452 152000.0n 0.5689 152249.9n 0.5689 152250.0n 0.2494 152499.9n 0.2494 152500.0n 0.4647 152749.9n 0.4647 152750.0n 0.4925 152999.9n 0.4925 153000.0n 0.6175 153249.9n 0.6175 153250.0n 0.3536 153499.9n 0.3536 153500.0n 0.4508 153749.9n 0.4508 153750.0n 0.5619 153999.9n 0.5619 154000.0n 0.5897 154249.9n 0.5897 154250.0n 0.4091 154499.9n 0.4091 154500.0n 0.4091 154749.9n 0.4091 154750.0n 0.4994 154999.9n 0.4994 155000.0n 0.4508 155249.9n 0.4508 155250.0n 0.6591 155499.9n 0.6591 155500.0n 0.4994 155749.9n 0.4994 155750.0n 0.4508 155999.9n 0.4508 156000.0n 0.6730 156249.9n 0.6730 156250.0n 0.6036 156499.9n 0.6036 156500.0n 0.6244 156749.9n 0.6244 156750.0n 0.5550 156999.9n 0.5550 157000.0n 0.5480 157249.9n 0.5480 157250.0n 0.5689 157499.9n 0.5689 157500.0n 0.6036 157749.9n 0.6036 157750.0n 0.4994 157999.9n 0.4994 158000.0n 0.6175 158249.9n 0.6175 158250.0n 0.5133 158499.9n 0.5133 158500.0n 0.5411 158749.9n 0.5411 158750.0n 0.6105 158999.9n 0.6105 159000.0n 0.5064 159249.9n 0.5064 159250.0n 0.6452 159499.9n 0.6452 159500.0n 0.5689 159749.9n 0.5689 159750.0n 0.2494 159999.9n 0.2494 160000.0n 0.4647 160249.9n 0.4647 160250.0n 0.4925 160499.9n 0.4925 160500.0n 0.6175 160749.9n 0.6175 160750.0n 0.3536 160999.9n 0.3536 161000.0n 0.4508 161249.9n 0.4508 161250.0n 0.5619 161499.9n 0.5619 161500.0n 0.5897 161749.9n 0.5897 161750.0n 0.4091 161999.9n 0.4091 162000.0n 0.4091 162249.9n 0.4091 162250.0n 0.4994 162499.9n 0.4994 162500.0n 0.4508 162749.9n 0.4508 162750.0n 0.6591 162999.9n 0.6591 163000.0n 0.4994 163249.9n 0.4994 163250.0n 0.4508 163499.9n 0.4508 163500.0n 0.6730 163749.9n 0.6730 163750.0n 0.6036 163999.9n 0.6036 164000.0n 0.6244 164249.9n 0.6244 164250.0n 0.5550 164499.9n 0.5550 164500.0n 0.5480 164749.9n 0.5480 164750.0n 0.5689 164999.9n 0.5689 165000.0n 0.6036 165249.9n 0.6036 165250.0n 0.4994 165499.9n 0.4994 165500.0n 0.6175 165749.9n 0.6175 165750.0n 0.5133 165999.9n 0.5133 166000.0n 0.5411 166249.9n 0.5411 166250.0n 0.6105 166499.9n 0.6105 166500.0n 0.5064 166749.9n 0.5064 166750.0n 0.6452 166999.9n 0.6452 167000.0n 0.5689 167249.9n 0.5689 167250.0n 0.2494 167499.9n 0.2494 167500.0n 0.4647 167749.9n 0.4647 167750.0n 0.4925 167999.9n 0.4925 168000.0n 0.6175 168249.9n 0.6175 168250.0n 0.3536 168499.9n 0.3536 168500.0n 0.4508 168749.9n 0.4508 168750.0n 0.5619 168999.9n 0.5619 169000.0n 0.5897 169249.9n 0.5897 169250.0n 0.4091 169499.9n 0.4091 169500.0n 0.4091 169749.9n 0.4091 169750.0n 0.4994 169999.9n 0.4994 170000.0n 0.4508 170249.9n 0.4508 170250.0n 0.6591 170499.9n 0.6591 170500.0n 0.4994 170749.9n 0.4994 170750.0n 0.4508 170999.9n 0.4508 171000.0n 0.6730 171249.9n 0.6730 171250.0n 0.6036 171499.9n 0.6036 171500.0n 0.6244 171749.9n 0.6244 171750.0n 0.5550 171999.9n 0.5550 172000.0n 0.5480 172249.9n 0.5480 172250.0n 0.5689 172499.9n 0.5689 172500.0n 0.6036 172749.9n 0.6036 172750.0n 0.4994 172999.9n 0.4994 173000.0n 0.6175 173249.9n 0.6175 173250.0n 0.5133 173499.9n 0.5133 173500.0n 0.5411 173749.9n 0.5411 173750.0n 0.6105 173999.9n 0.6105 174000.0n 0.5064 174249.9n 0.5064 174250.0n 0.6452 174499.9n 0.6452 174500.0n 0.5689 174749.9n 0.5689 174750.0n 0.2494 174999.9n 0.2494 175000.0n 0.4647 175249.9n 0.4647 175250.0n 0.4925 175499.9n 0.4925 175500.0n 0.6175 175749.9n 0.6175 175750.0n 0.3536 175999.9n 0.3536 176000.0n 0.4508 176249.9n 0.4508 176250.0n 0.5619 176499.9n 0.5619 176500.0n 0.5897 176749.9n 0.5897 176750.0n 0.4091 176999.9n 0.4091 177000.0n 0.4091 177249.9n 0.4091 177250.0n 0.4994 177499.9n 0.4994 177500.0n 0.4508 177749.9n 0.4508 177750.0n 0.6591 177999.9n 0.6591 178000.0n 0.4994 178249.9n 0.4994 178250.0n 0.4508 178499.9n 0.4508 178500.0n 0.6730 178749.9n 0.6730 178750.0n 0.6036 178999.9n 0.6036 179000.0n 0.6244 179249.9n 0.6244 179250.0n 0.5550 179499.9n 0.5550 179500.0n 0.5480 179749.9n 0.5480 179750.0n 0.5689 179999.9n 0.5689 180000.0n 0.6036 180249.9n 0.6036 180250.0n 0.4994 180499.9n 0.4994 180500.0n 0.6175 180749.9n 0.6175 180750.0n 0.5133 180999.9n 0.5133 181000.0n 0.5411 181249.9n 0.5411 181250.0n 0.6105 181499.9n 0.6105 181500.0n 0.5064 181749.9n 0.5064 181750.0n 0.6452 181999.9n 0.6452 182000.0n 0.5689 182249.9n 0.5689 182250.0n 0.2494 182499.9n 0.2494 182500.0n 0.4647 182749.9n 0.4647 182750.0n 0.4925 182999.9n 0.4925 183000.0n 0.6175 183249.9n 0.6175 183250.0n 0.3536 183499.9n 0.3536 183500.0n 0.4508 183749.9n 0.4508 183750.0n 0.5619 183999.9n 0.5619 184000.0n 0.5897 184249.9n 0.5897 184250.0n 0.4091 184499.9n 0.4091 184500.0n 0.4091 184749.9n 0.4091 184750.0n 0.4994 184999.9n 0.4994 185000.0n 0.4508 185249.9n 0.4508 185250.0n 0.6591 185499.9n 0.6591 185500.0n 0.4994 185749.9n 0.4994 185750.0n 0.4508 185999.9n 0.4508 186000.0n 0.6730 186249.9n 0.6730 186250.0n 0.6036 186499.9n 0.6036 186500.0n 0.6244 186749.9n 0.6244 186750.0n 0.5550 186999.9n 0.5550 187000.0n 0.5480 187249.9n 0.5480 187250.0n 0.5689 187499.9n 0.5689 187500.0n 0.6036 187749.9n 0.6036 187750.0n 0.4994 187999.9n 0.4994 188000.0n 0.6175 188249.9n 0.6175 188250.0n 0.5133 188499.9n 0.5133 188500.0n 0.5411 188749.9n 0.5411 188750.0n 0.6105 188999.9n 0.6105 189000.0n 0.5064 189249.9n 0.5064 189250.0n 0.6452 189499.9n 0.6452 189500.0n 0.5689 189749.9n 0.5689 189750.0n 0.2494 189999.9n 0.2494 190000.0n 0.4647 190249.9n 0.4647 190250.0n 0.4925 190499.9n 0.4925 190500.0n 0.6175 190749.9n 0.6175 190750.0n 0.3536 190999.9n 0.3536 191000.0n 0.4508 191249.9n 0.4508 191250.0n 0.5619 191499.9n 0.5619 191500.0n 0.5897 191749.9n 0.5897 191750.0n 0.4091 191999.9n 0.4091 192000.0n 0.4091 192249.9n 0.4091 192250.0n 0.4994 192499.9n 0.4994 192500.0n 0.4508 192749.9n 0.4508 192750.0n 0.6591 192999.9n 0.6591 193000.0n 0.4994 193249.9n 0.4994 193250.0n 0.4508 193499.9n 0.4508 193500.0n 0.6730 193749.9n 0.6730 193750.0n 0.6036 193999.9n 0.6036 194000.0n 0.6244 194249.9n 0.6244 194250.0n 0.5550 194499.9n 0.5550 194500.0n 0.5480 194749.9n 0.5480 194750.0n 0.5689 194999.9n 0.5689 195000.0n 0.6036 195249.9n 0.6036 195250.0n 0.4994 195499.9n 0.4994 195500.0n 0.6175 195749.9n 0.6175 195750.0n 0.5133 195999.9n 0.5133 196000.0n 0.5411 196249.9n 0.5411 196250.0n 0.6105 196499.9n 0.6105 196500.0n 0.5064 196749.9n 0.5064 196750.0n 0.6452 196999.9n 0.6452 197000.0n 0.5689 197249.9n 0.5689 197250.0n 0.2494 197499.9n 0.2494 197500.0n 0.4647 197749.9n 0.4647 197750.0n 0.4925 197999.9n 0.4925 198000.0n 0.6175 198249.9n 0.6175 198250.0n 0.3536 198499.9n 0.3536 198500.0n 0.4508 198749.9n 0.4508 198750.0n 0.5619 198999.9n 0.5619 199000.0n 0.5897 199249.9n 0.5897 199250.0n 0.4091 199499.9n 0.4091 199500.0n 0.4091 199749.9n 0.4091 199750.0n 0.4994 199999.9n 0.4994 200000.0n 0.4508 200249.9n 0.4508 200250.0n 0.6591 200499.9n 0.6591 200500.0n 0.4994 200749.9n 0.4994 200750.0n 0.4508 200999.9n 0.4508 201000.0n 0.6730 201249.9n 0.6730 201250.0n 0.6036 201499.9n 0.6036 201500.0n 0.6244 201749.9n 0.6244 201750.0n 0.5550 201999.9n 0.5550 202000.0n 0.5480 202249.9n 0.5480 202250.0n 0.5689 202499.9n 0.5689 202500.0n 0.6036 202749.9n 0.6036 202750.0n 0.4994 202999.9n 0.4994 203000.0n 0.6175 203249.9n 0.6175 203250.0n 0.5133 203499.9n 0.5133 203500.0n 0.5411 203749.9n 0.5411 203750.0n 0.6105 203999.9n 0.6105 204000.0n 0.5064 204249.9n 0.5064 204250.0n 0.6452 204499.9n 0.6452 204500.0n 0.5689 204749.9n 0.5689 204750.0n 0.2494 204999.9n 0.2494 205000.0n 0.4647 205249.9n 0.4647 205250.0n 0.4925 205499.9n 0.4925 205500.0n 0.6175 205749.9n 0.6175 205750.0n 0.3536 205999.9n 0.3536 206000.0n 0.4508 206249.9n 0.4508 206250.0n 0.5619 206499.9n 0.5619 206500.0n 0.5897 206749.9n 0.5897 206750.0n 0.4091 206999.9n 0.4091 207000.0n 0.4091 207249.9n 0.4091 207250.0n 0.4994 207499.9n 0.4994 207500.0n 0.4508 207749.9n 0.4508 207750.0n 0.6591 207999.9n 0.6591 208000.0n 0.4994 208249.9n 0.4994 208250.0n 0.4508 208499.9n 0.4508 208500.0n 0.6730 208749.9n 0.6730 208750.0n 0.6036 208999.9n 0.6036 209000.0n 0.6244 209249.9n 0.6244 209250.0n 0.5550 209499.9n 0.5550 209500.0n 0.5480 209749.9n 0.5480 209750.0n 0.5689 209999.9n 0.5689 210000.0n 0.6036 210249.9n 0.6036 210250.0n 0.4994 210499.9n 0.4994 210500.0n 0.6175 210749.9n 0.6175 210750.0n 0.5133 210999.9n 0.5133 211000.0n 0.5411 211249.9n 0.5411 211250.0n 0.6105 211499.9n 0.6105 211500.0n 0.5064 211749.9n 0.5064 211750.0n 0.6452 211999.9n 0.6452 212000.0n 0.5689 212249.9n 0.5689 212250.0n 0.2494 212499.9n 0.2494 212500.0n 0.4647 212749.9n 0.4647 212750.0n 0.4925 212999.9n 0.4925 213000.0n 0.6175 213249.9n 0.6175 213250.0n 0.3536 213499.9n 0.3536 213500.0n 0.4508 213749.9n 0.4508 213750.0n 0.5619 213999.9n 0.5619 214000.0n 0.5897 214249.9n 0.5897 214250.0n 0.4091 214499.9n 0.4091 214500.0n 0.4091 214749.9n 0.4091 214750.0n 0.4994 214999.9n 0.4994 215000.0n 0.4508 215249.9n 0.4508 215250.0n 0.6591 215499.9n 0.6591 215500.0n 0.4994 215749.9n 0.4994 215750.0n 0.4508 215999.9n 0.4508 216000.0n 0.6730 216249.9n 0.6730 216250.0n 0.6036 216499.9n 0.6036 216500.0n 0.6244 216749.9n 0.6244 216750.0n 0.5550 216999.9n 0.5550 217000.0n 0.5480 217249.9n 0.5480 217250.0n 0.5689 217499.9n 0.5689 217500.0n 0.6036 217749.9n 0.6036 217750.0n 0.4994 217999.9n 0.4994 218000.0n 0.6175 218249.9n 0.6175 218250.0n 0.5133 218499.9n 0.5133 218500.0n 0.5411 218749.9n 0.5411 218750.0n 0.6105 218999.9n 0.6105 219000.0n 0.5064 219249.9n 0.5064 219250.0n 0.6452 219499.9n 0.6452 219500.0n 0.5689 219749.9n 0.5689 219750.0n 0.2494 219999.9n 0.2494 220000.0n 0.4647 220249.9n 0.4647 220250.0n 0.4925 220499.9n 0.4925 220500.0n 0.6175 220749.9n 0.6175 220750.0n 0.3536 220999.9n 0.3536 221000.0n 0.4508 221249.9n 0.4508 221250.0n 0.5619 221499.9n 0.5619 221500.0n 0.5897 221749.9n 0.5897 221750.0n 0.4091 221999.9n 0.4091 222000.0n 0.4091 222249.9n 0.4091 222250.0n 0.4994 222499.9n 0.4994 222500.0n 0.4508 222749.9n 0.4508 222750.0n 0.6591 222999.9n 0.6591 223000.0n 0.4994 223249.9n 0.4994 223250.0n 0.4508 223499.9n 0.4508 223500.0n 0.6730 223749.9n 0.6730 223750.0n 0.6036 223999.9n 0.6036 224000.0n 0.6244 224249.9n 0.6244 224250.0n 0.5550 224499.9n 0.5550 224500.0n 0.5480 224749.9n 0.5480 224750.0n 0.5689 224999.9n 0.5689 225000.0n 0.6036 225249.9n 0.6036 225250.0n 0.4994 225499.9n 0.4994 225500.0n 0.6175 225749.9n 0.6175 225750.0n 0.5133 225999.9n 0.5133 226000.0n 0.5411 226249.9n 0.5411 226250.0n 0.6105 226499.9n 0.6105 226500.0n 0.5064 226749.9n 0.5064 226750.0n 0.6452 226999.9n 0.6452 227000.0n 0.5689 227249.9n 0.5689 227250.0n 0.2494 227499.9n 0.2494 227500.0n 0.4647 227749.9n 0.4647 227750.0n 0.4925 227999.9n 0.4925 228000.0n 0.6175 228249.9n 0.6175 228250.0n 0.3536 228499.9n 0.3536 228500.0n 0.4508 228749.9n 0.4508 228750.0n 0.5619 228999.9n 0.5619 229000.0n 0.5897 229249.9n 0.5897 229250.0n 0.4091 229499.9n 0.4091 229500.0n 0.4091 229749.9n 0.4091 229750.0n 0.4994 229999.9n 0.4994 230000.0n 0.4508 230249.9n 0.4508 230250.0n 0.6591 230499.9n 0.6591 230500.0n 0.4994 230749.9n 0.4994 230750.0n 0.4508 230999.9n 0.4508 231000.0n 0.6730 231249.9n 0.6730 231250.0n 0.6036 231499.9n 0.6036 231500.0n 0.6244 231749.9n 0.6244 231750.0n 0.5550 231999.9n 0.5550 232000.0n 0.5480 232249.9n 0.5480 232250.0n 0.5689 232499.9n 0.5689 232500.0n 0.6036 232749.9n 0.6036 232750.0n 0.4994 232999.9n 0.4994 233000.0n 0.6175 233249.9n 0.6175 233250.0n 0.5133 233499.9n 0.5133 233500.0n 0.5411 233749.9n 0.5411 233750.0n 0.6105 233999.9n 0.6105 234000.0n 0.5064 234249.9n 0.5064 234250.0n 0.6452 234499.9n 0.6452 234500.0n 0.5689 234749.9n 0.5689 234750.0n 0.2494 234999.9n 0.2494 235000.0n 0.4647 235249.9n 0.4647 235250.0n 0.4925 235499.9n 0.4925 235500.0n 0.6175 235749.9n 0.6175 235750.0n 0.3536 235999.9n 0.3536 236000.0n 0.4508 236249.9n 0.4508 236250.0n 0.5619 236499.9n 0.5619 236500.0n 0.5897 236749.9n 0.5897 236750.0n 0.4091 236999.9n 0.4091 237000.0n 0.4091 237249.9n 0.4091 237250.0n 0.4994 237499.9n 0.4994 237500.0n 0.4508 237749.9n 0.4508 237750.0n 0.6591 237999.9n 0.6591 238000.0n 0.4994 238249.9n 0.4994 238250.0n 0.4508 238499.9n 0.4508 238500.0n 0.6730 238749.9n 0.6730 238750.0n 0.6036 238999.9n 0.6036 239000.0n 0.6244 239249.9n 0.6244 239250.0n 0.5550 239499.9n 0.5550 239500.0n 0.5480 239749.9n 0.5480 239750.0n 0.5689 239999.9n 0.5689 240000.0n 0.6036 240249.9n 0.6036 240250.0n 0.4994 240499.9n 0.4994 240500.0n 0.6175 240749.9n 0.6175 240750.0n 0.5133 240999.9n 0.5133 241000.0n 0.5411 241249.9n 0.5411 241250.0n 0.6105 241499.9n 0.6105 241500.0n 0.5064 241749.9n 0.5064 241750.0n 0.6452 241999.9n 0.6452 242000.0n 0.5689 242249.9n 0.5689 242250.0n 0.2494 242499.9n 0.2494 242500.0n 0.4647 242749.9n 0.4647 242750.0n 0.4925 242999.9n 0.4925 243000.0n 0.6175 243249.9n 0.6175 243250.0n 0.3536 243499.9n 0.3536 243500.0n 0.4508 243749.9n 0.4508 243750.0n 0.5619 243999.9n 0.5619 244000.0n 0.5897 244249.9n 0.5897 244250.0n 0.4091 244499.9n 0.4091 244500.0n 0.4091 244749.9n 0.4091 244750.0n 0.4994 244999.9n 0.4994 245000.0n 0.4508 245249.9n 0.4508 245250.0n 0.6591 245499.9n 0.6591 245500.0n 0.4994 245749.9n 0.4994 245750.0n 0.4508 245999.9n 0.4508 246000.0n 0.6730 246249.9n 0.6730 246250.0n 0.6036 246499.9n 0.6036 246500.0n 0.6244 246749.9n 0.6244 246750.0n 0.5550 246999.9n 0.5550 247000.0n 0.5480 247249.9n 0.5480 247250.0n 0.5689 247499.9n 0.5689 247500.0n 0.6036 247749.9n 0.6036 247750.0n 0.4994 247999.9n 0.4994 248000.0n 0.6175 248249.9n 0.6175 248250.0n 0.5133 248499.9n 0.5133 248500.0n 0.5411 248749.9n 0.5411 248750.0n 0.6105 248999.9n 0.6105 249000.0n 0.5064 249249.9n 0.5064 249250.0n 0.6452 249499.9n 0.6452 249500.0n 0.5689 249749.9n 0.5689 249750.0n 0.2494 249999.9n 0.2494 250000.0n 0.4647 250249.9n 0.4647 250250.0n 0.4925 250499.9n 0.4925 250500.0n 0.6175 250749.9n 0.6175 250750.0n 0.3536 250999.9n 0.3536 251000.0n 0.4508 251249.9n 0.4508 251250.0n 0.5619 251499.9n 0.5619 251500.0n 0.5897 251749.9n 0.5897 251750.0n 0.4091 251999.9n 0.4091 252000.0n 0.4091 252249.9n 0.4091 252250.0n 0.4994 252499.9n 0.4994 252500.0n 0.4508 252749.9n 0.4508 252750.0n 0.6591 252999.9n 0.6591 253000.0n 0.4994 253249.9n 0.4994 253250.0n 0.4508 253499.9n 0.4508 253500.0n 0.6730 253749.9n 0.6730 253750.0n 0.6036 253999.9n 0.6036 254000.0n 0.6244 254249.9n 0.6244 254250.0n 0.5550 254499.9n 0.5550 254500.0n 0.5480 254749.9n 0.5480 254750.0n 0.5689 254999.9n 0.5689 255000.0n 0.6036 255249.9n 0.6036 255250.0n 0.4994 255499.9n 0.4994 255500.0n 0.6175 255749.9n 0.6175 255750.0n 0.5133 255999.9n 0.5133 256000.0n 0.5411 256249.9n 0.5411 256250.0n 0.6105 256499.9n 0.6105 256500.0n 0.5064 256749.9n 0.5064 256750.0n 0.6452 256999.9n 0.6452 257000.0n 0.5689 257249.9n 0.5689 257250.0n 0.2494 257499.9n 0.2494 257500.0n 0.4647 257749.9n 0.4647 257750.0n 0.4925 257999.9n 0.4925 258000.0n 0.6175 258249.9n 0.6175 258250.0n 0.3536 258499.9n 0.3536 258500.0n 0.4508 258749.9n 0.4508 258750.0n 0.5619 258999.9n 0.5619 259000.0n 0.5897 259249.9n 0.5897 259250.0n 0.4091 259499.9n 0.4091 259500.0n 0.4091 259749.9n 0.4091 259750.0n 0.4994 259999.9n 0.4994 260000.0n 0.4508 260249.9n 0.4508 260250.0n 0.6591 260499.9n 0.6591 260500.0n 0.4994 260749.9n 0.4994 260750.0n 0.4508 260999.9n 0.4508 261000.0n 0.6730 261249.9n 0.6730 261250.0n 0.6036 261499.9n 0.6036 261500.0n 0.6244 261749.9n 0.6244 261750.0n 0.5550 261999.9n 0.5550 262000.0n 0.5480 262249.9n 0.5480 262250.0n 0.5689 262499.9n 0.5689 262500.0n 0.6036 262749.9n 0.6036 262750.0n 0.4994 262999.9n 0.4994 263000.0n 0.6175 263249.9n 0.6175 263250.0n 0.5133 263499.9n 0.5133 263500.0n 0.5411 263749.9n 0.5411 263750.0n 0.6105 263999.9n 0.6105 264000.0n 0.5064 264249.9n 0.5064 264250.0n 0.6452 264499.9n 0.6452 264500.0n 0.5689 264749.9n 0.5689 264750.0n 0.2494 264999.9n 0.2494 265000.0n 0.4647 265249.9n 0.4647 265250.0n 0.4925 265499.9n 0.4925 265500.0n 0.6175 265749.9n 0.6175 265750.0n 0.3536 265999.9n 0.3536 266000.0n 0.4508 266249.9n 0.4508 266250.0n 0.5619 266499.9n 0.5619 266500.0n 0.5897 266749.9n 0.5897 266750.0n 0.4091 266999.9n 0.4091 267000.0n 0.4091 267249.9n 0.4091 267250.0n 0.4994 267499.9n 0.4994 267500.0n 0.4508 267749.9n 0.4508 267750.0n 0.6591 267999.9n 0.6591 268000.0n 0.4994 268249.9n 0.4994 268250.0n 0.4508 268499.9n 0.4508 268500.0n 0.6730 268749.9n 0.6730 268750.0n 0.6036 268999.9n 0.6036 269000.0n 0.6244 269249.9n 0.6244 269250.0n 0.5550 269499.9n 0.5550 269500.0n 0.5480 269749.9n 0.5480 269750.0n 0.5689 269999.9n 0.5689 270000.0n 0.6036 270249.9n 0.6036 270250.0n 0.4994 270499.9n 0.4994 270500.0n 0.6175 270749.9n 0.6175 270750.0n 0.5133 270999.9n 0.5133 271000.0n 0.5411 271249.9n 0.5411 271250.0n 0.6105 271499.9n 0.6105 271500.0n 0.5064 271749.9n 0.5064 271750.0n 0.6452 271999.9n 0.6452 272000.0n 0.5689 272249.9n 0.5689 272250.0n 0.2494 272499.9n 0.2494 272500.0n 0.4647 272749.9n 0.4647 272750.0n 0.4925 272999.9n 0.4925 273000.0n 0.6175 273249.9n 0.6175 273250.0n 0.3536 273499.9n 0.3536 273500.0n 0.4508 273749.9n 0.4508 273750.0n 0.5619 273999.9n 0.5619 274000.0n 0.5897 274249.9n 0.5897 274250.0n 0.4091 274499.9n 0.4091 274500.0n 0.4091 274749.9n 0.4091 274750.0n 0.4994 274999.9n 0.4994 275000.0n 0.4508 275249.9n 0.4508 275250.0n 0.6591 275499.9n 0.6591 275500.0n 0.4994 275749.9n 0.4994 275750.0n 0.4508 275999.9n 0.4508 276000.0n 0.6730 276249.9n 0.6730 276250.0n 0.6036 276499.9n 0.6036 276500.0n 0.6244 276749.9n 0.6244 276750.0n 0.5550 276999.9n 0.5550 277000.0n 0.5480 277249.9n 0.5480 277250.0n 0.5689 277499.9n 0.5689 277500.0n 0.6036 277749.9n 0.6036 277750.0n 0.4994 277999.9n 0.4994 278000.0n 0.6175 278249.9n 0.6175 278250.0n 0.5133 278499.9n 0.5133 278500.0n 0.5411 278749.9n 0.5411 278750.0n 0.6105 278999.9n 0.6105 279000.0n 0.5064 279249.9n 0.5064 279250.0n 0.6452 279499.9n 0.6452 279500.0n 0.5689 279749.9n 0.5689 279750.0n 0.2494 279999.9n 0.2494 280000.0n 0.4647 280249.9n 0.4647 280250.0n 0.4925 280499.9n 0.4925 280500.0n 0.6175 280749.9n 0.6175 280750.0n 0.3536 280999.9n 0.3536 281000.0n 0.4508 281249.9n 0.4508 281250.0n 0.5619 281499.9n 0.5619 281500.0n 0.5897 281749.9n 0.5897 281750.0n 0.4091 281999.9n 0.4091 282000.0n 0.4091 282249.9n 0.4091 282250.0n 0.4994 282499.9n 0.4994 282500.0n 0.4508 282749.9n 0.4508 282750.0n 0.6591 282999.9n 0.6591 283000.0n 0.4994 283249.9n 0.4994 283250.0n 0.4508 283499.9n 0.4508 283500.0n 0.6730 283749.9n 0.6730 283750.0n 0.6036 283999.9n 0.6036 284000.0n 0.6244 284249.9n 0.6244 284250.0n 0.5550 284499.9n 0.5550 284500.0n 0.5480 284749.9n 0.5480 284750.0n 0.5689 284999.9n 0.5689 285000.0n 0.6036 285249.9n 0.6036 285250.0n 0.4994 285499.9n 0.4994 285500.0n 0.6175 285749.9n 0.6175 285750.0n 0.5133 285999.9n 0.5133 286000.0n 0.5411 286249.9n 0.5411 286250.0n 0.6105 286499.9n 0.6105 286500.0n 0.5064 286749.9n 0.5064 286750.0n 0.6452 286999.9n 0.6452 287000.0n 0.5689 287249.9n 0.5689 287250.0n 0.2494 287499.9n 0.2494 287500.0n 0.4647 287749.9n 0.4647 287750.0n 0.4925 287999.9n 0.4925 288000.0n 0.6175 288249.9n 0.6175 288250.0n 0.3536 288499.9n 0.3536 288500.0n 0.4508 288749.9n 0.4508 288750.0n 0.5619 288999.9n 0.5619 289000.0n 0.5897 289249.9n 0.5897 289250.0n 0.4091 289499.9n 0.4091 289500.0n 0.4091 289749.9n 0.4091 289750.0n 0.4994 289999.9n 0.4994 290000.0n 0.4508 290249.9n 0.4508 290250.0n 0.6591 290499.9n 0.6591 290500.0n 0.4994 290749.9n 0.4994 290750.0n 0.4508 290999.9n 0.4508 291000.0n 0.6730 291249.9n 0.6730 291250.0n 0.6036 291499.9n 0.6036 291500.0n 0.6244 291749.9n 0.6244 291750.0n 0.5550 291999.9n 0.5550 292000.0n 0.5480 292249.9n 0.5480 292250.0n 0.5689 292499.9n 0.5689 292500.0n 0.6036 292749.9n 0.6036 292750.0n 0.4994 292999.9n 0.4994 293000.0n 0.6175 293249.9n 0.6175 293250.0n 0.5133 293499.9n 0.5133 293500.0n 0.5411 293749.9n 0.5411 293750.0n 0.6105 293999.9n 0.6105 294000.0n 0.5064 294249.9n 0.5064 294250.0n 0.6452 294499.9n 0.6452 294500.0n 0.5689 294749.9n 0.5689 294750.0n 0.2494 294999.9n 0.2494 295000.0n 0.4647 295249.9n 0.4647 295250.0n 0.4925 295499.9n 0.4925 295500.0n 0.6175 295749.9n 0.6175 295750.0n 0.3536 295999.9n 0.3536 296000.0n 0.4508 296249.9n 0.4508 296250.0n 0.5619 296499.9n 0.5619 296500.0n 0.5897 296749.9n 0.5897 296750.0n 0.4091 296999.9n 0.4091 297000.0n 0.4091 297249.9n 0.4091 297250.0n 0.4994 297499.9n 0.4994 297500.0n 0.4508 297749.9n 0.4508 297750.0n 0.6591 297999.9n 0.6591 298000.0n 0.4994 298249.9n 0.4994 298250.0n 0.4508 298499.9n 0.4508 298500.0n 0.6730 298749.9n 0.6730 298750.0n 0.6036 298999.9n 0.6036 299000.0n 0.6244 299249.9n 0.6244 299250.0n 0.5550 299499.9n 0.5550 299500.0n 0.5480 299749.9n 0.5480 299750.0n 0.5689)
Vxn2 a_xn2 0 PWL(0.0n 0.3964 249.9n 0.3964 250.0n 0.5006 499.9n 0.5006 500.0n 0.3825 749.9n 0.3825 750.0n 0.4867 999.9n 0.4867 1000.0n 0.4589 1249.9n 0.4589 1250.0n 0.3895 1499.9n 0.3895 1500.0n 0.4936 1749.9n 0.4936 1750.0n 0.3548 1999.9n 0.3548 2000.0n 0.4311 2249.9n 0.4311 2250.0n 0.7506 2499.9n 0.7506 2500.0n 0.5353 2749.9n 0.5353 2750.0n 0.5075 2999.9n 0.5075 3000.0n 0.3825 3249.9n 0.3825 3250.0n 0.6464 3499.9n 0.6464 3500.0n 0.5492 3749.9n 0.5492 3750.0n 0.4381 3999.9n 0.4381 4000.0n 0.4103 4249.9n 0.4103 4250.0n 0.5909 4499.9n 0.5909 4500.0n 0.5909 4749.9n 0.5909 4750.0n 0.5006 4999.9n 0.5006 5000.0n 0.5492 5249.9n 0.5492 5250.0n 0.3409 5499.9n 0.3409 5500.0n 0.5006 5749.9n 0.5006 5750.0n 0.5492 5999.9n 0.5492 6000.0n 0.3270 6249.9n 0.3270 6250.0n 0.3964 6499.9n 0.3964 6500.0n 0.3756 6749.9n 0.3756 6750.0n 0.4450 6999.9n 0.4450 7000.0n 0.4520 7249.9n 0.4520 7250.0n 0.4311 7499.9n 0.4311 7500.0n 0.3964 7749.9n 0.3964 7750.0n 0.5006 7999.9n 0.5006 8000.0n 0.3825 8249.9n 0.3825 8250.0n 0.4867 8499.9n 0.4867 8500.0n 0.4589 8749.9n 0.4589 8750.0n 0.3895 8999.9n 0.3895 9000.0n 0.4936 9249.9n 0.4936 9250.0n 0.3548 9499.9n 0.3548 9500.0n 0.4311 9749.9n 0.4311 9750.0n 0.7506 9999.9n 0.7506 10000.0n 0.5353 10249.9n 0.5353 10250.0n 0.5075 10499.9n 0.5075 10500.0n 0.3825 10749.9n 0.3825 10750.0n 0.6464 10999.9n 0.6464 11000.0n 0.5492 11249.9n 0.5492 11250.0n 0.4381 11499.9n 0.4381 11500.0n 0.4103 11749.9n 0.4103 11750.0n 0.5909 11999.9n 0.5909 12000.0n 0.5909 12249.9n 0.5909 12250.0n 0.5006 12499.9n 0.5006 12500.0n 0.5492 12749.9n 0.5492 12750.0n 0.3409 12999.9n 0.3409 13000.0n 0.5006 13249.9n 0.5006 13250.0n 0.5492 13499.9n 0.5492 13500.0n 0.3270 13749.9n 0.3270 13750.0n 0.3964 13999.9n 0.3964 14000.0n 0.3756 14249.9n 0.3756 14250.0n 0.4450 14499.9n 0.4450 14500.0n 0.4520 14749.9n 0.4520 14750.0n 0.4311 14999.9n 0.4311 15000.0n 0.3964 15249.9n 0.3964 15250.0n 0.5006 15499.9n 0.5006 15500.0n 0.3825 15749.9n 0.3825 15750.0n 0.4867 15999.9n 0.4867 16000.0n 0.4589 16249.9n 0.4589 16250.0n 0.3895 16499.9n 0.3895 16500.0n 0.4936 16749.9n 0.4936 16750.0n 0.3548 16999.9n 0.3548 17000.0n 0.4311 17249.9n 0.4311 17250.0n 0.7506 17499.9n 0.7506 17500.0n 0.5353 17749.9n 0.5353 17750.0n 0.5075 17999.9n 0.5075 18000.0n 0.3825 18249.9n 0.3825 18250.0n 0.6464 18499.9n 0.6464 18500.0n 0.5492 18749.9n 0.5492 18750.0n 0.4381 18999.9n 0.4381 19000.0n 0.4103 19249.9n 0.4103 19250.0n 0.5909 19499.9n 0.5909 19500.0n 0.5909 19749.9n 0.5909 19750.0n 0.5006 19999.9n 0.5006 20000.0n 0.5492 20249.9n 0.5492 20250.0n 0.3409 20499.9n 0.3409 20500.0n 0.5006 20749.9n 0.5006 20750.0n 0.5492 20999.9n 0.5492 21000.0n 0.3270 21249.9n 0.3270 21250.0n 0.3964 21499.9n 0.3964 21500.0n 0.3756 21749.9n 0.3756 21750.0n 0.4450 21999.9n 0.4450 22000.0n 0.4520 22249.9n 0.4520 22250.0n 0.4311 22499.9n 0.4311 22500.0n 0.3964 22749.9n 0.3964 22750.0n 0.5006 22999.9n 0.5006 23000.0n 0.3825 23249.9n 0.3825 23250.0n 0.4867 23499.9n 0.4867 23500.0n 0.4589 23749.9n 0.4589 23750.0n 0.3895 23999.9n 0.3895 24000.0n 0.4936 24249.9n 0.4936 24250.0n 0.3548 24499.9n 0.3548 24500.0n 0.4311 24749.9n 0.4311 24750.0n 0.7506 24999.9n 0.7506 25000.0n 0.5353 25249.9n 0.5353 25250.0n 0.5075 25499.9n 0.5075 25500.0n 0.3825 25749.9n 0.3825 25750.0n 0.6464 25999.9n 0.6464 26000.0n 0.5492 26249.9n 0.5492 26250.0n 0.4381 26499.9n 0.4381 26500.0n 0.4103 26749.9n 0.4103 26750.0n 0.5909 26999.9n 0.5909 27000.0n 0.5909 27249.9n 0.5909 27250.0n 0.5006 27499.9n 0.5006 27500.0n 0.5492 27749.9n 0.5492 27750.0n 0.3409 27999.9n 0.3409 28000.0n 0.5006 28249.9n 0.5006 28250.0n 0.5492 28499.9n 0.5492 28500.0n 0.3270 28749.9n 0.3270 28750.0n 0.3964 28999.9n 0.3964 29000.0n 0.3756 29249.9n 0.3756 29250.0n 0.4450 29499.9n 0.4450 29500.0n 0.4520 29749.9n 0.4520 29750.0n 0.4311 29999.9n 0.4311 30000.0n 0.3964 30249.9n 0.3964 30250.0n 0.5006 30499.9n 0.5006 30500.0n 0.3825 30749.9n 0.3825 30750.0n 0.4867 30999.9n 0.4867 31000.0n 0.4589 31249.9n 0.4589 31250.0n 0.3895 31499.9n 0.3895 31500.0n 0.4936 31749.9n 0.4936 31750.0n 0.3548 31999.9n 0.3548 32000.0n 0.4311 32249.9n 0.4311 32250.0n 0.7506 32499.9n 0.7506 32500.0n 0.5353 32749.9n 0.5353 32750.0n 0.5075 32999.9n 0.5075 33000.0n 0.3825 33249.9n 0.3825 33250.0n 0.6464 33499.9n 0.6464 33500.0n 0.5492 33749.9n 0.5492 33750.0n 0.4381 33999.9n 0.4381 34000.0n 0.4103 34249.9n 0.4103 34250.0n 0.5909 34499.9n 0.5909 34500.0n 0.5909 34749.9n 0.5909 34750.0n 0.5006 34999.9n 0.5006 35000.0n 0.5492 35249.9n 0.5492 35250.0n 0.3409 35499.9n 0.3409 35500.0n 0.5006 35749.9n 0.5006 35750.0n 0.5492 35999.9n 0.5492 36000.0n 0.3270 36249.9n 0.3270 36250.0n 0.3964 36499.9n 0.3964 36500.0n 0.3756 36749.9n 0.3756 36750.0n 0.4450 36999.9n 0.4450 37000.0n 0.4520 37249.9n 0.4520 37250.0n 0.4311 37499.9n 0.4311 37500.0n 0.3964 37749.9n 0.3964 37750.0n 0.5006 37999.9n 0.5006 38000.0n 0.3825 38249.9n 0.3825 38250.0n 0.4867 38499.9n 0.4867 38500.0n 0.4589 38749.9n 0.4589 38750.0n 0.3895 38999.9n 0.3895 39000.0n 0.4936 39249.9n 0.4936 39250.0n 0.3548 39499.9n 0.3548 39500.0n 0.4311 39749.9n 0.4311 39750.0n 0.7506 39999.9n 0.7506 40000.0n 0.5353 40249.9n 0.5353 40250.0n 0.5075 40499.9n 0.5075 40500.0n 0.3825 40749.9n 0.3825 40750.0n 0.6464 40999.9n 0.6464 41000.0n 0.5492 41249.9n 0.5492 41250.0n 0.4381 41499.9n 0.4381 41500.0n 0.4103 41749.9n 0.4103 41750.0n 0.5909 41999.9n 0.5909 42000.0n 0.5909 42249.9n 0.5909 42250.0n 0.5006 42499.9n 0.5006 42500.0n 0.5492 42749.9n 0.5492 42750.0n 0.3409 42999.9n 0.3409 43000.0n 0.5006 43249.9n 0.5006 43250.0n 0.5492 43499.9n 0.5492 43500.0n 0.3270 43749.9n 0.3270 43750.0n 0.3964 43999.9n 0.3964 44000.0n 0.3756 44249.9n 0.3756 44250.0n 0.4450 44499.9n 0.4450 44500.0n 0.4520 44749.9n 0.4520 44750.0n 0.4311 44999.9n 0.4311 45000.0n 0.3964 45249.9n 0.3964 45250.0n 0.5006 45499.9n 0.5006 45500.0n 0.3825 45749.9n 0.3825 45750.0n 0.4867 45999.9n 0.4867 46000.0n 0.4589 46249.9n 0.4589 46250.0n 0.3895 46499.9n 0.3895 46500.0n 0.4936 46749.9n 0.4936 46750.0n 0.3548 46999.9n 0.3548 47000.0n 0.4311 47249.9n 0.4311 47250.0n 0.7506 47499.9n 0.7506 47500.0n 0.5353 47749.9n 0.5353 47750.0n 0.5075 47999.9n 0.5075 48000.0n 0.3825 48249.9n 0.3825 48250.0n 0.6464 48499.9n 0.6464 48500.0n 0.5492 48749.9n 0.5492 48750.0n 0.4381 48999.9n 0.4381 49000.0n 0.4103 49249.9n 0.4103 49250.0n 0.5909 49499.9n 0.5909 49500.0n 0.5909 49749.9n 0.5909 49750.0n 0.5006 49999.9n 0.5006 50000.0n 0.5492 50249.9n 0.5492 50250.0n 0.3409 50499.9n 0.3409 50500.0n 0.5006 50749.9n 0.5006 50750.0n 0.5492 50999.9n 0.5492 51000.0n 0.3270 51249.9n 0.3270 51250.0n 0.3964 51499.9n 0.3964 51500.0n 0.3756 51749.9n 0.3756 51750.0n 0.4450 51999.9n 0.4450 52000.0n 0.4520 52249.9n 0.4520 52250.0n 0.4311 52499.9n 0.4311 52500.0n 0.3964 52749.9n 0.3964 52750.0n 0.5006 52999.9n 0.5006 53000.0n 0.3825 53249.9n 0.3825 53250.0n 0.4867 53499.9n 0.4867 53500.0n 0.4589 53749.9n 0.4589 53750.0n 0.3895 53999.9n 0.3895 54000.0n 0.4936 54249.9n 0.4936 54250.0n 0.3548 54499.9n 0.3548 54500.0n 0.4311 54749.9n 0.4311 54750.0n 0.7506 54999.9n 0.7506 55000.0n 0.5353 55249.9n 0.5353 55250.0n 0.5075 55499.9n 0.5075 55500.0n 0.3825 55749.9n 0.3825 55750.0n 0.6464 55999.9n 0.6464 56000.0n 0.5492 56249.9n 0.5492 56250.0n 0.4381 56499.9n 0.4381 56500.0n 0.4103 56749.9n 0.4103 56750.0n 0.5909 56999.9n 0.5909 57000.0n 0.5909 57249.9n 0.5909 57250.0n 0.5006 57499.9n 0.5006 57500.0n 0.5492 57749.9n 0.5492 57750.0n 0.3409 57999.9n 0.3409 58000.0n 0.5006 58249.9n 0.5006 58250.0n 0.5492 58499.9n 0.5492 58500.0n 0.3270 58749.9n 0.3270 58750.0n 0.3964 58999.9n 0.3964 59000.0n 0.3756 59249.9n 0.3756 59250.0n 0.4450 59499.9n 0.4450 59500.0n 0.4520 59749.9n 0.4520 59750.0n 0.4311 59999.9n 0.4311 60000.0n 0.3964 60249.9n 0.3964 60250.0n 0.5006 60499.9n 0.5006 60500.0n 0.3825 60749.9n 0.3825 60750.0n 0.4867 60999.9n 0.4867 61000.0n 0.4589 61249.9n 0.4589 61250.0n 0.3895 61499.9n 0.3895 61500.0n 0.4936 61749.9n 0.4936 61750.0n 0.3548 61999.9n 0.3548 62000.0n 0.4311 62249.9n 0.4311 62250.0n 0.7506 62499.9n 0.7506 62500.0n 0.5353 62749.9n 0.5353 62750.0n 0.5075 62999.9n 0.5075 63000.0n 0.3825 63249.9n 0.3825 63250.0n 0.6464 63499.9n 0.6464 63500.0n 0.5492 63749.9n 0.5492 63750.0n 0.4381 63999.9n 0.4381 64000.0n 0.4103 64249.9n 0.4103 64250.0n 0.5909 64499.9n 0.5909 64500.0n 0.5909 64749.9n 0.5909 64750.0n 0.5006 64999.9n 0.5006 65000.0n 0.5492 65249.9n 0.5492 65250.0n 0.3409 65499.9n 0.3409 65500.0n 0.5006 65749.9n 0.5006 65750.0n 0.5492 65999.9n 0.5492 66000.0n 0.3270 66249.9n 0.3270 66250.0n 0.3964 66499.9n 0.3964 66500.0n 0.3756 66749.9n 0.3756 66750.0n 0.4450 66999.9n 0.4450 67000.0n 0.4520 67249.9n 0.4520 67250.0n 0.4311 67499.9n 0.4311 67500.0n 0.3964 67749.9n 0.3964 67750.0n 0.5006 67999.9n 0.5006 68000.0n 0.3825 68249.9n 0.3825 68250.0n 0.4867 68499.9n 0.4867 68500.0n 0.4589 68749.9n 0.4589 68750.0n 0.3895 68999.9n 0.3895 69000.0n 0.4936 69249.9n 0.4936 69250.0n 0.3548 69499.9n 0.3548 69500.0n 0.4311 69749.9n 0.4311 69750.0n 0.7506 69999.9n 0.7506 70000.0n 0.5353 70249.9n 0.5353 70250.0n 0.5075 70499.9n 0.5075 70500.0n 0.3825 70749.9n 0.3825 70750.0n 0.6464 70999.9n 0.6464 71000.0n 0.5492 71249.9n 0.5492 71250.0n 0.4381 71499.9n 0.4381 71500.0n 0.4103 71749.9n 0.4103 71750.0n 0.5909 71999.9n 0.5909 72000.0n 0.5909 72249.9n 0.5909 72250.0n 0.5006 72499.9n 0.5006 72500.0n 0.5492 72749.9n 0.5492 72750.0n 0.3409 72999.9n 0.3409 73000.0n 0.5006 73249.9n 0.5006 73250.0n 0.5492 73499.9n 0.5492 73500.0n 0.3270 73749.9n 0.3270 73750.0n 0.3964 73999.9n 0.3964 74000.0n 0.3756 74249.9n 0.3756 74250.0n 0.4450 74499.9n 0.4450 74500.0n 0.4520 74749.9n 0.4520 74750.0n 0.4311 74999.9n 0.4311 75000.0n 0.3964 75249.9n 0.3964 75250.0n 0.5006 75499.9n 0.5006 75500.0n 0.3825 75749.9n 0.3825 75750.0n 0.4867 75999.9n 0.4867 76000.0n 0.4589 76249.9n 0.4589 76250.0n 0.3895 76499.9n 0.3895 76500.0n 0.4936 76749.9n 0.4936 76750.0n 0.3548 76999.9n 0.3548 77000.0n 0.4311 77249.9n 0.4311 77250.0n 0.7506 77499.9n 0.7506 77500.0n 0.5353 77749.9n 0.5353 77750.0n 0.5075 77999.9n 0.5075 78000.0n 0.3825 78249.9n 0.3825 78250.0n 0.6464 78499.9n 0.6464 78500.0n 0.5492 78749.9n 0.5492 78750.0n 0.4381 78999.9n 0.4381 79000.0n 0.4103 79249.9n 0.4103 79250.0n 0.5909 79499.9n 0.5909 79500.0n 0.5909 79749.9n 0.5909 79750.0n 0.5006 79999.9n 0.5006 80000.0n 0.5492 80249.9n 0.5492 80250.0n 0.3409 80499.9n 0.3409 80500.0n 0.5006 80749.9n 0.5006 80750.0n 0.5492 80999.9n 0.5492 81000.0n 0.3270 81249.9n 0.3270 81250.0n 0.3964 81499.9n 0.3964 81500.0n 0.3756 81749.9n 0.3756 81750.0n 0.4450 81999.9n 0.4450 82000.0n 0.4520 82249.9n 0.4520 82250.0n 0.4311 82499.9n 0.4311 82500.0n 0.3964 82749.9n 0.3964 82750.0n 0.5006 82999.9n 0.5006 83000.0n 0.3825 83249.9n 0.3825 83250.0n 0.4867 83499.9n 0.4867 83500.0n 0.4589 83749.9n 0.4589 83750.0n 0.3895 83999.9n 0.3895 84000.0n 0.4936 84249.9n 0.4936 84250.0n 0.3548 84499.9n 0.3548 84500.0n 0.4311 84749.9n 0.4311 84750.0n 0.7506 84999.9n 0.7506 85000.0n 0.5353 85249.9n 0.5353 85250.0n 0.5075 85499.9n 0.5075 85500.0n 0.3825 85749.9n 0.3825 85750.0n 0.6464 85999.9n 0.6464 86000.0n 0.5492 86249.9n 0.5492 86250.0n 0.4381 86499.9n 0.4381 86500.0n 0.4103 86749.9n 0.4103 86750.0n 0.5909 86999.9n 0.5909 87000.0n 0.5909 87249.9n 0.5909 87250.0n 0.5006 87499.9n 0.5006 87500.0n 0.5492 87749.9n 0.5492 87750.0n 0.3409 87999.9n 0.3409 88000.0n 0.5006 88249.9n 0.5006 88250.0n 0.5492 88499.9n 0.5492 88500.0n 0.3270 88749.9n 0.3270 88750.0n 0.3964 88999.9n 0.3964 89000.0n 0.3756 89249.9n 0.3756 89250.0n 0.4450 89499.9n 0.4450 89500.0n 0.4520 89749.9n 0.4520 89750.0n 0.4311 89999.9n 0.4311 90000.0n 0.3964 90249.9n 0.3964 90250.0n 0.5006 90499.9n 0.5006 90500.0n 0.3825 90749.9n 0.3825 90750.0n 0.4867 90999.9n 0.4867 91000.0n 0.4589 91249.9n 0.4589 91250.0n 0.3895 91499.9n 0.3895 91500.0n 0.4936 91749.9n 0.4936 91750.0n 0.3548 91999.9n 0.3548 92000.0n 0.4311 92249.9n 0.4311 92250.0n 0.7506 92499.9n 0.7506 92500.0n 0.5353 92749.9n 0.5353 92750.0n 0.5075 92999.9n 0.5075 93000.0n 0.3825 93249.9n 0.3825 93250.0n 0.6464 93499.9n 0.6464 93500.0n 0.5492 93749.9n 0.5492 93750.0n 0.4381 93999.9n 0.4381 94000.0n 0.4103 94249.9n 0.4103 94250.0n 0.5909 94499.9n 0.5909 94500.0n 0.5909 94749.9n 0.5909 94750.0n 0.5006 94999.9n 0.5006 95000.0n 0.5492 95249.9n 0.5492 95250.0n 0.3409 95499.9n 0.3409 95500.0n 0.5006 95749.9n 0.5006 95750.0n 0.5492 95999.9n 0.5492 96000.0n 0.3270 96249.9n 0.3270 96250.0n 0.3964 96499.9n 0.3964 96500.0n 0.3756 96749.9n 0.3756 96750.0n 0.4450 96999.9n 0.4450 97000.0n 0.4520 97249.9n 0.4520 97250.0n 0.4311 97499.9n 0.4311 97500.0n 0.3964 97749.9n 0.3964 97750.0n 0.5006 97999.9n 0.5006 98000.0n 0.3825 98249.9n 0.3825 98250.0n 0.4867 98499.9n 0.4867 98500.0n 0.4589 98749.9n 0.4589 98750.0n 0.3895 98999.9n 0.3895 99000.0n 0.4936 99249.9n 0.4936 99250.0n 0.3548 99499.9n 0.3548 99500.0n 0.4311 99749.9n 0.4311 99750.0n 0.7506 99999.9n 0.7506 100000.0n 0.5353 100249.9n 0.5353 100250.0n 0.5075 100499.9n 0.5075 100500.0n 0.3825 100749.9n 0.3825 100750.0n 0.6464 100999.9n 0.6464 101000.0n 0.5492 101249.9n 0.5492 101250.0n 0.4381 101499.9n 0.4381 101500.0n 0.4103 101749.9n 0.4103 101750.0n 0.5909 101999.9n 0.5909 102000.0n 0.5909 102249.9n 0.5909 102250.0n 0.5006 102499.9n 0.5006 102500.0n 0.5492 102749.9n 0.5492 102750.0n 0.3409 102999.9n 0.3409 103000.0n 0.5006 103249.9n 0.5006 103250.0n 0.5492 103499.9n 0.5492 103500.0n 0.3270 103749.9n 0.3270 103750.0n 0.3964 103999.9n 0.3964 104000.0n 0.3756 104249.9n 0.3756 104250.0n 0.4450 104499.9n 0.4450 104500.0n 0.4520 104749.9n 0.4520 104750.0n 0.4311 104999.9n 0.4311 105000.0n 0.3964 105249.9n 0.3964 105250.0n 0.5006 105499.9n 0.5006 105500.0n 0.3825 105749.9n 0.3825 105750.0n 0.4867 105999.9n 0.4867 106000.0n 0.4589 106249.9n 0.4589 106250.0n 0.3895 106499.9n 0.3895 106500.0n 0.4936 106749.9n 0.4936 106750.0n 0.3548 106999.9n 0.3548 107000.0n 0.4311 107249.9n 0.4311 107250.0n 0.7506 107499.9n 0.7506 107500.0n 0.5353 107749.9n 0.5353 107750.0n 0.5075 107999.9n 0.5075 108000.0n 0.3825 108249.9n 0.3825 108250.0n 0.6464 108499.9n 0.6464 108500.0n 0.5492 108749.9n 0.5492 108750.0n 0.4381 108999.9n 0.4381 109000.0n 0.4103 109249.9n 0.4103 109250.0n 0.5909 109499.9n 0.5909 109500.0n 0.5909 109749.9n 0.5909 109750.0n 0.5006 109999.9n 0.5006 110000.0n 0.5492 110249.9n 0.5492 110250.0n 0.3409 110499.9n 0.3409 110500.0n 0.5006 110749.9n 0.5006 110750.0n 0.5492 110999.9n 0.5492 111000.0n 0.3270 111249.9n 0.3270 111250.0n 0.3964 111499.9n 0.3964 111500.0n 0.3756 111749.9n 0.3756 111750.0n 0.4450 111999.9n 0.4450 112000.0n 0.4520 112249.9n 0.4520 112250.0n 0.4311 112499.9n 0.4311 112500.0n 0.3964 112749.9n 0.3964 112750.0n 0.5006 112999.9n 0.5006 113000.0n 0.3825 113249.9n 0.3825 113250.0n 0.4867 113499.9n 0.4867 113500.0n 0.4589 113749.9n 0.4589 113750.0n 0.3895 113999.9n 0.3895 114000.0n 0.4936 114249.9n 0.4936 114250.0n 0.3548 114499.9n 0.3548 114500.0n 0.4311 114749.9n 0.4311 114750.0n 0.7506 114999.9n 0.7506 115000.0n 0.5353 115249.9n 0.5353 115250.0n 0.5075 115499.9n 0.5075 115500.0n 0.3825 115749.9n 0.3825 115750.0n 0.6464 115999.9n 0.6464 116000.0n 0.5492 116249.9n 0.5492 116250.0n 0.4381 116499.9n 0.4381 116500.0n 0.4103 116749.9n 0.4103 116750.0n 0.5909 116999.9n 0.5909 117000.0n 0.5909 117249.9n 0.5909 117250.0n 0.5006 117499.9n 0.5006 117500.0n 0.5492 117749.9n 0.5492 117750.0n 0.3409 117999.9n 0.3409 118000.0n 0.5006 118249.9n 0.5006 118250.0n 0.5492 118499.9n 0.5492 118500.0n 0.3270 118749.9n 0.3270 118750.0n 0.3964 118999.9n 0.3964 119000.0n 0.3756 119249.9n 0.3756 119250.0n 0.4450 119499.9n 0.4450 119500.0n 0.4520 119749.9n 0.4520 119750.0n 0.4311 119999.9n 0.4311 120000.0n 0.3964 120249.9n 0.3964 120250.0n 0.5006 120499.9n 0.5006 120500.0n 0.3825 120749.9n 0.3825 120750.0n 0.4867 120999.9n 0.4867 121000.0n 0.4589 121249.9n 0.4589 121250.0n 0.3895 121499.9n 0.3895 121500.0n 0.4936 121749.9n 0.4936 121750.0n 0.3548 121999.9n 0.3548 122000.0n 0.4311 122249.9n 0.4311 122250.0n 0.7506 122499.9n 0.7506 122500.0n 0.5353 122749.9n 0.5353 122750.0n 0.5075 122999.9n 0.5075 123000.0n 0.3825 123249.9n 0.3825 123250.0n 0.6464 123499.9n 0.6464 123500.0n 0.5492 123749.9n 0.5492 123750.0n 0.4381 123999.9n 0.4381 124000.0n 0.4103 124249.9n 0.4103 124250.0n 0.5909 124499.9n 0.5909 124500.0n 0.5909 124749.9n 0.5909 124750.0n 0.5006 124999.9n 0.5006 125000.0n 0.5492 125249.9n 0.5492 125250.0n 0.3409 125499.9n 0.3409 125500.0n 0.5006 125749.9n 0.5006 125750.0n 0.5492 125999.9n 0.5492 126000.0n 0.3270 126249.9n 0.3270 126250.0n 0.3964 126499.9n 0.3964 126500.0n 0.3756 126749.9n 0.3756 126750.0n 0.4450 126999.9n 0.4450 127000.0n 0.4520 127249.9n 0.4520 127250.0n 0.4311 127499.9n 0.4311 127500.0n 0.3964 127749.9n 0.3964 127750.0n 0.5006 127999.9n 0.5006 128000.0n 0.3825 128249.9n 0.3825 128250.0n 0.4867 128499.9n 0.4867 128500.0n 0.4589 128749.9n 0.4589 128750.0n 0.3895 128999.9n 0.3895 129000.0n 0.4936 129249.9n 0.4936 129250.0n 0.3548 129499.9n 0.3548 129500.0n 0.4311 129749.9n 0.4311 129750.0n 0.7506 129999.9n 0.7506 130000.0n 0.5353 130249.9n 0.5353 130250.0n 0.5075 130499.9n 0.5075 130500.0n 0.3825 130749.9n 0.3825 130750.0n 0.6464 130999.9n 0.6464 131000.0n 0.5492 131249.9n 0.5492 131250.0n 0.4381 131499.9n 0.4381 131500.0n 0.4103 131749.9n 0.4103 131750.0n 0.5909 131999.9n 0.5909 132000.0n 0.5909 132249.9n 0.5909 132250.0n 0.5006 132499.9n 0.5006 132500.0n 0.5492 132749.9n 0.5492 132750.0n 0.3409 132999.9n 0.3409 133000.0n 0.5006 133249.9n 0.5006 133250.0n 0.5492 133499.9n 0.5492 133500.0n 0.3270 133749.9n 0.3270 133750.0n 0.3964 133999.9n 0.3964 134000.0n 0.3756 134249.9n 0.3756 134250.0n 0.4450 134499.9n 0.4450 134500.0n 0.4520 134749.9n 0.4520 134750.0n 0.4311 134999.9n 0.4311 135000.0n 0.3964 135249.9n 0.3964 135250.0n 0.5006 135499.9n 0.5006 135500.0n 0.3825 135749.9n 0.3825 135750.0n 0.4867 135999.9n 0.4867 136000.0n 0.4589 136249.9n 0.4589 136250.0n 0.3895 136499.9n 0.3895 136500.0n 0.4936 136749.9n 0.4936 136750.0n 0.3548 136999.9n 0.3548 137000.0n 0.4311 137249.9n 0.4311 137250.0n 0.7506 137499.9n 0.7506 137500.0n 0.5353 137749.9n 0.5353 137750.0n 0.5075 137999.9n 0.5075 138000.0n 0.3825 138249.9n 0.3825 138250.0n 0.6464 138499.9n 0.6464 138500.0n 0.5492 138749.9n 0.5492 138750.0n 0.4381 138999.9n 0.4381 139000.0n 0.4103 139249.9n 0.4103 139250.0n 0.5909 139499.9n 0.5909 139500.0n 0.5909 139749.9n 0.5909 139750.0n 0.5006 139999.9n 0.5006 140000.0n 0.5492 140249.9n 0.5492 140250.0n 0.3409 140499.9n 0.3409 140500.0n 0.5006 140749.9n 0.5006 140750.0n 0.5492 140999.9n 0.5492 141000.0n 0.3270 141249.9n 0.3270 141250.0n 0.3964 141499.9n 0.3964 141500.0n 0.3756 141749.9n 0.3756 141750.0n 0.4450 141999.9n 0.4450 142000.0n 0.4520 142249.9n 0.4520 142250.0n 0.4311 142499.9n 0.4311 142500.0n 0.3964 142749.9n 0.3964 142750.0n 0.5006 142999.9n 0.5006 143000.0n 0.3825 143249.9n 0.3825 143250.0n 0.4867 143499.9n 0.4867 143500.0n 0.4589 143749.9n 0.4589 143750.0n 0.3895 143999.9n 0.3895 144000.0n 0.4936 144249.9n 0.4936 144250.0n 0.3548 144499.9n 0.3548 144500.0n 0.4311 144749.9n 0.4311 144750.0n 0.7506 144999.9n 0.7506 145000.0n 0.5353 145249.9n 0.5353 145250.0n 0.5075 145499.9n 0.5075 145500.0n 0.3825 145749.9n 0.3825 145750.0n 0.6464 145999.9n 0.6464 146000.0n 0.5492 146249.9n 0.5492 146250.0n 0.4381 146499.9n 0.4381 146500.0n 0.4103 146749.9n 0.4103 146750.0n 0.5909 146999.9n 0.5909 147000.0n 0.5909 147249.9n 0.5909 147250.0n 0.5006 147499.9n 0.5006 147500.0n 0.5492 147749.9n 0.5492 147750.0n 0.3409 147999.9n 0.3409 148000.0n 0.5006 148249.9n 0.5006 148250.0n 0.5492 148499.9n 0.5492 148500.0n 0.3270 148749.9n 0.3270 148750.0n 0.3964 148999.9n 0.3964 149000.0n 0.3756 149249.9n 0.3756 149250.0n 0.4450 149499.9n 0.4450 149500.0n 0.4520 149749.9n 0.4520 149750.0n 0.4311 149999.9n 0.4311 150000.0n 0.3964 150249.9n 0.3964 150250.0n 0.5006 150499.9n 0.5006 150500.0n 0.3825 150749.9n 0.3825 150750.0n 0.4867 150999.9n 0.4867 151000.0n 0.4589 151249.9n 0.4589 151250.0n 0.3895 151499.9n 0.3895 151500.0n 0.4936 151749.9n 0.4936 151750.0n 0.3548 151999.9n 0.3548 152000.0n 0.4311 152249.9n 0.4311 152250.0n 0.7506 152499.9n 0.7506 152500.0n 0.5353 152749.9n 0.5353 152750.0n 0.5075 152999.9n 0.5075 153000.0n 0.3825 153249.9n 0.3825 153250.0n 0.6464 153499.9n 0.6464 153500.0n 0.5492 153749.9n 0.5492 153750.0n 0.4381 153999.9n 0.4381 154000.0n 0.4103 154249.9n 0.4103 154250.0n 0.5909 154499.9n 0.5909 154500.0n 0.5909 154749.9n 0.5909 154750.0n 0.5006 154999.9n 0.5006 155000.0n 0.5492 155249.9n 0.5492 155250.0n 0.3409 155499.9n 0.3409 155500.0n 0.5006 155749.9n 0.5006 155750.0n 0.5492 155999.9n 0.5492 156000.0n 0.3270 156249.9n 0.3270 156250.0n 0.3964 156499.9n 0.3964 156500.0n 0.3756 156749.9n 0.3756 156750.0n 0.4450 156999.9n 0.4450 157000.0n 0.4520 157249.9n 0.4520 157250.0n 0.4311 157499.9n 0.4311 157500.0n 0.3964 157749.9n 0.3964 157750.0n 0.5006 157999.9n 0.5006 158000.0n 0.3825 158249.9n 0.3825 158250.0n 0.4867 158499.9n 0.4867 158500.0n 0.4589 158749.9n 0.4589 158750.0n 0.3895 158999.9n 0.3895 159000.0n 0.4936 159249.9n 0.4936 159250.0n 0.3548 159499.9n 0.3548 159500.0n 0.4311 159749.9n 0.4311 159750.0n 0.7506 159999.9n 0.7506 160000.0n 0.5353 160249.9n 0.5353 160250.0n 0.5075 160499.9n 0.5075 160500.0n 0.3825 160749.9n 0.3825 160750.0n 0.6464 160999.9n 0.6464 161000.0n 0.5492 161249.9n 0.5492 161250.0n 0.4381 161499.9n 0.4381 161500.0n 0.4103 161749.9n 0.4103 161750.0n 0.5909 161999.9n 0.5909 162000.0n 0.5909 162249.9n 0.5909 162250.0n 0.5006 162499.9n 0.5006 162500.0n 0.5492 162749.9n 0.5492 162750.0n 0.3409 162999.9n 0.3409 163000.0n 0.5006 163249.9n 0.5006 163250.0n 0.5492 163499.9n 0.5492 163500.0n 0.3270 163749.9n 0.3270 163750.0n 0.3964 163999.9n 0.3964 164000.0n 0.3756 164249.9n 0.3756 164250.0n 0.4450 164499.9n 0.4450 164500.0n 0.4520 164749.9n 0.4520 164750.0n 0.4311 164999.9n 0.4311 165000.0n 0.3964 165249.9n 0.3964 165250.0n 0.5006 165499.9n 0.5006 165500.0n 0.3825 165749.9n 0.3825 165750.0n 0.4867 165999.9n 0.4867 166000.0n 0.4589 166249.9n 0.4589 166250.0n 0.3895 166499.9n 0.3895 166500.0n 0.4936 166749.9n 0.4936 166750.0n 0.3548 166999.9n 0.3548 167000.0n 0.4311 167249.9n 0.4311 167250.0n 0.7506 167499.9n 0.7506 167500.0n 0.5353 167749.9n 0.5353 167750.0n 0.5075 167999.9n 0.5075 168000.0n 0.3825 168249.9n 0.3825 168250.0n 0.6464 168499.9n 0.6464 168500.0n 0.5492 168749.9n 0.5492 168750.0n 0.4381 168999.9n 0.4381 169000.0n 0.4103 169249.9n 0.4103 169250.0n 0.5909 169499.9n 0.5909 169500.0n 0.5909 169749.9n 0.5909 169750.0n 0.5006 169999.9n 0.5006 170000.0n 0.5492 170249.9n 0.5492 170250.0n 0.3409 170499.9n 0.3409 170500.0n 0.5006 170749.9n 0.5006 170750.0n 0.5492 170999.9n 0.5492 171000.0n 0.3270 171249.9n 0.3270 171250.0n 0.3964 171499.9n 0.3964 171500.0n 0.3756 171749.9n 0.3756 171750.0n 0.4450 171999.9n 0.4450 172000.0n 0.4520 172249.9n 0.4520 172250.0n 0.4311 172499.9n 0.4311 172500.0n 0.3964 172749.9n 0.3964 172750.0n 0.5006 172999.9n 0.5006 173000.0n 0.3825 173249.9n 0.3825 173250.0n 0.4867 173499.9n 0.4867 173500.0n 0.4589 173749.9n 0.4589 173750.0n 0.3895 173999.9n 0.3895 174000.0n 0.4936 174249.9n 0.4936 174250.0n 0.3548 174499.9n 0.3548 174500.0n 0.4311 174749.9n 0.4311 174750.0n 0.7506 174999.9n 0.7506 175000.0n 0.5353 175249.9n 0.5353 175250.0n 0.5075 175499.9n 0.5075 175500.0n 0.3825 175749.9n 0.3825 175750.0n 0.6464 175999.9n 0.6464 176000.0n 0.5492 176249.9n 0.5492 176250.0n 0.4381 176499.9n 0.4381 176500.0n 0.4103 176749.9n 0.4103 176750.0n 0.5909 176999.9n 0.5909 177000.0n 0.5909 177249.9n 0.5909 177250.0n 0.5006 177499.9n 0.5006 177500.0n 0.5492 177749.9n 0.5492 177750.0n 0.3409 177999.9n 0.3409 178000.0n 0.5006 178249.9n 0.5006 178250.0n 0.5492 178499.9n 0.5492 178500.0n 0.3270 178749.9n 0.3270 178750.0n 0.3964 178999.9n 0.3964 179000.0n 0.3756 179249.9n 0.3756 179250.0n 0.4450 179499.9n 0.4450 179500.0n 0.4520 179749.9n 0.4520 179750.0n 0.4311 179999.9n 0.4311 180000.0n 0.3964 180249.9n 0.3964 180250.0n 0.5006 180499.9n 0.5006 180500.0n 0.3825 180749.9n 0.3825 180750.0n 0.4867 180999.9n 0.4867 181000.0n 0.4589 181249.9n 0.4589 181250.0n 0.3895 181499.9n 0.3895 181500.0n 0.4936 181749.9n 0.4936 181750.0n 0.3548 181999.9n 0.3548 182000.0n 0.4311 182249.9n 0.4311 182250.0n 0.7506 182499.9n 0.7506 182500.0n 0.5353 182749.9n 0.5353 182750.0n 0.5075 182999.9n 0.5075 183000.0n 0.3825 183249.9n 0.3825 183250.0n 0.6464 183499.9n 0.6464 183500.0n 0.5492 183749.9n 0.5492 183750.0n 0.4381 183999.9n 0.4381 184000.0n 0.4103 184249.9n 0.4103 184250.0n 0.5909 184499.9n 0.5909 184500.0n 0.5909 184749.9n 0.5909 184750.0n 0.5006 184999.9n 0.5006 185000.0n 0.5492 185249.9n 0.5492 185250.0n 0.3409 185499.9n 0.3409 185500.0n 0.5006 185749.9n 0.5006 185750.0n 0.5492 185999.9n 0.5492 186000.0n 0.3270 186249.9n 0.3270 186250.0n 0.3964 186499.9n 0.3964 186500.0n 0.3756 186749.9n 0.3756 186750.0n 0.4450 186999.9n 0.4450 187000.0n 0.4520 187249.9n 0.4520 187250.0n 0.4311 187499.9n 0.4311 187500.0n 0.3964 187749.9n 0.3964 187750.0n 0.5006 187999.9n 0.5006 188000.0n 0.3825 188249.9n 0.3825 188250.0n 0.4867 188499.9n 0.4867 188500.0n 0.4589 188749.9n 0.4589 188750.0n 0.3895 188999.9n 0.3895 189000.0n 0.4936 189249.9n 0.4936 189250.0n 0.3548 189499.9n 0.3548 189500.0n 0.4311 189749.9n 0.4311 189750.0n 0.7506 189999.9n 0.7506 190000.0n 0.5353 190249.9n 0.5353 190250.0n 0.5075 190499.9n 0.5075 190500.0n 0.3825 190749.9n 0.3825 190750.0n 0.6464 190999.9n 0.6464 191000.0n 0.5492 191249.9n 0.5492 191250.0n 0.4381 191499.9n 0.4381 191500.0n 0.4103 191749.9n 0.4103 191750.0n 0.5909 191999.9n 0.5909 192000.0n 0.5909 192249.9n 0.5909 192250.0n 0.5006 192499.9n 0.5006 192500.0n 0.5492 192749.9n 0.5492 192750.0n 0.3409 192999.9n 0.3409 193000.0n 0.5006 193249.9n 0.5006 193250.0n 0.5492 193499.9n 0.5492 193500.0n 0.3270 193749.9n 0.3270 193750.0n 0.3964 193999.9n 0.3964 194000.0n 0.3756 194249.9n 0.3756 194250.0n 0.4450 194499.9n 0.4450 194500.0n 0.4520 194749.9n 0.4520 194750.0n 0.4311 194999.9n 0.4311 195000.0n 0.3964 195249.9n 0.3964 195250.0n 0.5006 195499.9n 0.5006 195500.0n 0.3825 195749.9n 0.3825 195750.0n 0.4867 195999.9n 0.4867 196000.0n 0.4589 196249.9n 0.4589 196250.0n 0.3895 196499.9n 0.3895 196500.0n 0.4936 196749.9n 0.4936 196750.0n 0.3548 196999.9n 0.3548 197000.0n 0.4311 197249.9n 0.4311 197250.0n 0.7506 197499.9n 0.7506 197500.0n 0.5353 197749.9n 0.5353 197750.0n 0.5075 197999.9n 0.5075 198000.0n 0.3825 198249.9n 0.3825 198250.0n 0.6464 198499.9n 0.6464 198500.0n 0.5492 198749.9n 0.5492 198750.0n 0.4381 198999.9n 0.4381 199000.0n 0.4103 199249.9n 0.4103 199250.0n 0.5909 199499.9n 0.5909 199500.0n 0.5909 199749.9n 0.5909 199750.0n 0.5006 199999.9n 0.5006 200000.0n 0.5492 200249.9n 0.5492 200250.0n 0.3409 200499.9n 0.3409 200500.0n 0.5006 200749.9n 0.5006 200750.0n 0.5492 200999.9n 0.5492 201000.0n 0.3270 201249.9n 0.3270 201250.0n 0.3964 201499.9n 0.3964 201500.0n 0.3756 201749.9n 0.3756 201750.0n 0.4450 201999.9n 0.4450 202000.0n 0.4520 202249.9n 0.4520 202250.0n 0.4311 202499.9n 0.4311 202500.0n 0.3964 202749.9n 0.3964 202750.0n 0.5006 202999.9n 0.5006 203000.0n 0.3825 203249.9n 0.3825 203250.0n 0.4867 203499.9n 0.4867 203500.0n 0.4589 203749.9n 0.4589 203750.0n 0.3895 203999.9n 0.3895 204000.0n 0.4936 204249.9n 0.4936 204250.0n 0.3548 204499.9n 0.3548 204500.0n 0.4311 204749.9n 0.4311 204750.0n 0.7506 204999.9n 0.7506 205000.0n 0.5353 205249.9n 0.5353 205250.0n 0.5075 205499.9n 0.5075 205500.0n 0.3825 205749.9n 0.3825 205750.0n 0.6464 205999.9n 0.6464 206000.0n 0.5492 206249.9n 0.5492 206250.0n 0.4381 206499.9n 0.4381 206500.0n 0.4103 206749.9n 0.4103 206750.0n 0.5909 206999.9n 0.5909 207000.0n 0.5909 207249.9n 0.5909 207250.0n 0.5006 207499.9n 0.5006 207500.0n 0.5492 207749.9n 0.5492 207750.0n 0.3409 207999.9n 0.3409 208000.0n 0.5006 208249.9n 0.5006 208250.0n 0.5492 208499.9n 0.5492 208500.0n 0.3270 208749.9n 0.3270 208750.0n 0.3964 208999.9n 0.3964 209000.0n 0.3756 209249.9n 0.3756 209250.0n 0.4450 209499.9n 0.4450 209500.0n 0.4520 209749.9n 0.4520 209750.0n 0.4311 209999.9n 0.4311 210000.0n 0.3964 210249.9n 0.3964 210250.0n 0.5006 210499.9n 0.5006 210500.0n 0.3825 210749.9n 0.3825 210750.0n 0.4867 210999.9n 0.4867 211000.0n 0.4589 211249.9n 0.4589 211250.0n 0.3895 211499.9n 0.3895 211500.0n 0.4936 211749.9n 0.4936 211750.0n 0.3548 211999.9n 0.3548 212000.0n 0.4311 212249.9n 0.4311 212250.0n 0.7506 212499.9n 0.7506 212500.0n 0.5353 212749.9n 0.5353 212750.0n 0.5075 212999.9n 0.5075 213000.0n 0.3825 213249.9n 0.3825 213250.0n 0.6464 213499.9n 0.6464 213500.0n 0.5492 213749.9n 0.5492 213750.0n 0.4381 213999.9n 0.4381 214000.0n 0.4103 214249.9n 0.4103 214250.0n 0.5909 214499.9n 0.5909 214500.0n 0.5909 214749.9n 0.5909 214750.0n 0.5006 214999.9n 0.5006 215000.0n 0.5492 215249.9n 0.5492 215250.0n 0.3409 215499.9n 0.3409 215500.0n 0.5006 215749.9n 0.5006 215750.0n 0.5492 215999.9n 0.5492 216000.0n 0.3270 216249.9n 0.3270 216250.0n 0.3964 216499.9n 0.3964 216500.0n 0.3756 216749.9n 0.3756 216750.0n 0.4450 216999.9n 0.4450 217000.0n 0.4520 217249.9n 0.4520 217250.0n 0.4311 217499.9n 0.4311 217500.0n 0.3964 217749.9n 0.3964 217750.0n 0.5006 217999.9n 0.5006 218000.0n 0.3825 218249.9n 0.3825 218250.0n 0.4867 218499.9n 0.4867 218500.0n 0.4589 218749.9n 0.4589 218750.0n 0.3895 218999.9n 0.3895 219000.0n 0.4936 219249.9n 0.4936 219250.0n 0.3548 219499.9n 0.3548 219500.0n 0.4311 219749.9n 0.4311 219750.0n 0.7506 219999.9n 0.7506 220000.0n 0.5353 220249.9n 0.5353 220250.0n 0.5075 220499.9n 0.5075 220500.0n 0.3825 220749.9n 0.3825 220750.0n 0.6464 220999.9n 0.6464 221000.0n 0.5492 221249.9n 0.5492 221250.0n 0.4381 221499.9n 0.4381 221500.0n 0.4103 221749.9n 0.4103 221750.0n 0.5909 221999.9n 0.5909 222000.0n 0.5909 222249.9n 0.5909 222250.0n 0.5006 222499.9n 0.5006 222500.0n 0.5492 222749.9n 0.5492 222750.0n 0.3409 222999.9n 0.3409 223000.0n 0.5006 223249.9n 0.5006 223250.0n 0.5492 223499.9n 0.5492 223500.0n 0.3270 223749.9n 0.3270 223750.0n 0.3964 223999.9n 0.3964 224000.0n 0.3756 224249.9n 0.3756 224250.0n 0.4450 224499.9n 0.4450 224500.0n 0.4520 224749.9n 0.4520 224750.0n 0.4311 224999.9n 0.4311 225000.0n 0.3964 225249.9n 0.3964 225250.0n 0.5006 225499.9n 0.5006 225500.0n 0.3825 225749.9n 0.3825 225750.0n 0.4867 225999.9n 0.4867 226000.0n 0.4589 226249.9n 0.4589 226250.0n 0.3895 226499.9n 0.3895 226500.0n 0.4936 226749.9n 0.4936 226750.0n 0.3548 226999.9n 0.3548 227000.0n 0.4311 227249.9n 0.4311 227250.0n 0.7506 227499.9n 0.7506 227500.0n 0.5353 227749.9n 0.5353 227750.0n 0.5075 227999.9n 0.5075 228000.0n 0.3825 228249.9n 0.3825 228250.0n 0.6464 228499.9n 0.6464 228500.0n 0.5492 228749.9n 0.5492 228750.0n 0.4381 228999.9n 0.4381 229000.0n 0.4103 229249.9n 0.4103 229250.0n 0.5909 229499.9n 0.5909 229500.0n 0.5909 229749.9n 0.5909 229750.0n 0.5006 229999.9n 0.5006 230000.0n 0.5492 230249.9n 0.5492 230250.0n 0.3409 230499.9n 0.3409 230500.0n 0.5006 230749.9n 0.5006 230750.0n 0.5492 230999.9n 0.5492 231000.0n 0.3270 231249.9n 0.3270 231250.0n 0.3964 231499.9n 0.3964 231500.0n 0.3756 231749.9n 0.3756 231750.0n 0.4450 231999.9n 0.4450 232000.0n 0.4520 232249.9n 0.4520 232250.0n 0.4311 232499.9n 0.4311 232500.0n 0.3964 232749.9n 0.3964 232750.0n 0.5006 232999.9n 0.5006 233000.0n 0.3825 233249.9n 0.3825 233250.0n 0.4867 233499.9n 0.4867 233500.0n 0.4589 233749.9n 0.4589 233750.0n 0.3895 233999.9n 0.3895 234000.0n 0.4936 234249.9n 0.4936 234250.0n 0.3548 234499.9n 0.3548 234500.0n 0.4311 234749.9n 0.4311 234750.0n 0.7506 234999.9n 0.7506 235000.0n 0.5353 235249.9n 0.5353 235250.0n 0.5075 235499.9n 0.5075 235500.0n 0.3825 235749.9n 0.3825 235750.0n 0.6464 235999.9n 0.6464 236000.0n 0.5492 236249.9n 0.5492 236250.0n 0.4381 236499.9n 0.4381 236500.0n 0.4103 236749.9n 0.4103 236750.0n 0.5909 236999.9n 0.5909 237000.0n 0.5909 237249.9n 0.5909 237250.0n 0.5006 237499.9n 0.5006 237500.0n 0.5492 237749.9n 0.5492 237750.0n 0.3409 237999.9n 0.3409 238000.0n 0.5006 238249.9n 0.5006 238250.0n 0.5492 238499.9n 0.5492 238500.0n 0.3270 238749.9n 0.3270 238750.0n 0.3964 238999.9n 0.3964 239000.0n 0.3756 239249.9n 0.3756 239250.0n 0.4450 239499.9n 0.4450 239500.0n 0.4520 239749.9n 0.4520 239750.0n 0.4311 239999.9n 0.4311 240000.0n 0.3964 240249.9n 0.3964 240250.0n 0.5006 240499.9n 0.5006 240500.0n 0.3825 240749.9n 0.3825 240750.0n 0.4867 240999.9n 0.4867 241000.0n 0.4589 241249.9n 0.4589 241250.0n 0.3895 241499.9n 0.3895 241500.0n 0.4936 241749.9n 0.4936 241750.0n 0.3548 241999.9n 0.3548 242000.0n 0.4311 242249.9n 0.4311 242250.0n 0.7506 242499.9n 0.7506 242500.0n 0.5353 242749.9n 0.5353 242750.0n 0.5075 242999.9n 0.5075 243000.0n 0.3825 243249.9n 0.3825 243250.0n 0.6464 243499.9n 0.6464 243500.0n 0.5492 243749.9n 0.5492 243750.0n 0.4381 243999.9n 0.4381 244000.0n 0.4103 244249.9n 0.4103 244250.0n 0.5909 244499.9n 0.5909 244500.0n 0.5909 244749.9n 0.5909 244750.0n 0.5006 244999.9n 0.5006 245000.0n 0.5492 245249.9n 0.5492 245250.0n 0.3409 245499.9n 0.3409 245500.0n 0.5006 245749.9n 0.5006 245750.0n 0.5492 245999.9n 0.5492 246000.0n 0.3270 246249.9n 0.3270 246250.0n 0.3964 246499.9n 0.3964 246500.0n 0.3756 246749.9n 0.3756 246750.0n 0.4450 246999.9n 0.4450 247000.0n 0.4520 247249.9n 0.4520 247250.0n 0.4311 247499.9n 0.4311 247500.0n 0.3964 247749.9n 0.3964 247750.0n 0.5006 247999.9n 0.5006 248000.0n 0.3825 248249.9n 0.3825 248250.0n 0.4867 248499.9n 0.4867 248500.0n 0.4589 248749.9n 0.4589 248750.0n 0.3895 248999.9n 0.3895 249000.0n 0.4936 249249.9n 0.4936 249250.0n 0.3548 249499.9n 0.3548 249500.0n 0.4311 249749.9n 0.4311 249750.0n 0.7506 249999.9n 0.7506 250000.0n 0.5353 250249.9n 0.5353 250250.0n 0.5075 250499.9n 0.5075 250500.0n 0.3825 250749.9n 0.3825 250750.0n 0.6464 250999.9n 0.6464 251000.0n 0.5492 251249.9n 0.5492 251250.0n 0.4381 251499.9n 0.4381 251500.0n 0.4103 251749.9n 0.4103 251750.0n 0.5909 251999.9n 0.5909 252000.0n 0.5909 252249.9n 0.5909 252250.0n 0.5006 252499.9n 0.5006 252500.0n 0.5492 252749.9n 0.5492 252750.0n 0.3409 252999.9n 0.3409 253000.0n 0.5006 253249.9n 0.5006 253250.0n 0.5492 253499.9n 0.5492 253500.0n 0.3270 253749.9n 0.3270 253750.0n 0.3964 253999.9n 0.3964 254000.0n 0.3756 254249.9n 0.3756 254250.0n 0.4450 254499.9n 0.4450 254500.0n 0.4520 254749.9n 0.4520 254750.0n 0.4311 254999.9n 0.4311 255000.0n 0.3964 255249.9n 0.3964 255250.0n 0.5006 255499.9n 0.5006 255500.0n 0.3825 255749.9n 0.3825 255750.0n 0.4867 255999.9n 0.4867 256000.0n 0.4589 256249.9n 0.4589 256250.0n 0.3895 256499.9n 0.3895 256500.0n 0.4936 256749.9n 0.4936 256750.0n 0.3548 256999.9n 0.3548 257000.0n 0.4311 257249.9n 0.4311 257250.0n 0.7506 257499.9n 0.7506 257500.0n 0.5353 257749.9n 0.5353 257750.0n 0.5075 257999.9n 0.5075 258000.0n 0.3825 258249.9n 0.3825 258250.0n 0.6464 258499.9n 0.6464 258500.0n 0.5492 258749.9n 0.5492 258750.0n 0.4381 258999.9n 0.4381 259000.0n 0.4103 259249.9n 0.4103 259250.0n 0.5909 259499.9n 0.5909 259500.0n 0.5909 259749.9n 0.5909 259750.0n 0.5006 259999.9n 0.5006 260000.0n 0.5492 260249.9n 0.5492 260250.0n 0.3409 260499.9n 0.3409 260500.0n 0.5006 260749.9n 0.5006 260750.0n 0.5492 260999.9n 0.5492 261000.0n 0.3270 261249.9n 0.3270 261250.0n 0.3964 261499.9n 0.3964 261500.0n 0.3756 261749.9n 0.3756 261750.0n 0.4450 261999.9n 0.4450 262000.0n 0.4520 262249.9n 0.4520 262250.0n 0.4311 262499.9n 0.4311 262500.0n 0.3964 262749.9n 0.3964 262750.0n 0.5006 262999.9n 0.5006 263000.0n 0.3825 263249.9n 0.3825 263250.0n 0.4867 263499.9n 0.4867 263500.0n 0.4589 263749.9n 0.4589 263750.0n 0.3895 263999.9n 0.3895 264000.0n 0.4936 264249.9n 0.4936 264250.0n 0.3548 264499.9n 0.3548 264500.0n 0.4311 264749.9n 0.4311 264750.0n 0.7506 264999.9n 0.7506 265000.0n 0.5353 265249.9n 0.5353 265250.0n 0.5075 265499.9n 0.5075 265500.0n 0.3825 265749.9n 0.3825 265750.0n 0.6464 265999.9n 0.6464 266000.0n 0.5492 266249.9n 0.5492 266250.0n 0.4381 266499.9n 0.4381 266500.0n 0.4103 266749.9n 0.4103 266750.0n 0.5909 266999.9n 0.5909 267000.0n 0.5909 267249.9n 0.5909 267250.0n 0.5006 267499.9n 0.5006 267500.0n 0.5492 267749.9n 0.5492 267750.0n 0.3409 267999.9n 0.3409 268000.0n 0.5006 268249.9n 0.5006 268250.0n 0.5492 268499.9n 0.5492 268500.0n 0.3270 268749.9n 0.3270 268750.0n 0.3964 268999.9n 0.3964 269000.0n 0.3756 269249.9n 0.3756 269250.0n 0.4450 269499.9n 0.4450 269500.0n 0.4520 269749.9n 0.4520 269750.0n 0.4311 269999.9n 0.4311 270000.0n 0.3964 270249.9n 0.3964 270250.0n 0.5006 270499.9n 0.5006 270500.0n 0.3825 270749.9n 0.3825 270750.0n 0.4867 270999.9n 0.4867 271000.0n 0.4589 271249.9n 0.4589 271250.0n 0.3895 271499.9n 0.3895 271500.0n 0.4936 271749.9n 0.4936 271750.0n 0.3548 271999.9n 0.3548 272000.0n 0.4311 272249.9n 0.4311 272250.0n 0.7506 272499.9n 0.7506 272500.0n 0.5353 272749.9n 0.5353 272750.0n 0.5075 272999.9n 0.5075 273000.0n 0.3825 273249.9n 0.3825 273250.0n 0.6464 273499.9n 0.6464 273500.0n 0.5492 273749.9n 0.5492 273750.0n 0.4381 273999.9n 0.4381 274000.0n 0.4103 274249.9n 0.4103 274250.0n 0.5909 274499.9n 0.5909 274500.0n 0.5909 274749.9n 0.5909 274750.0n 0.5006 274999.9n 0.5006 275000.0n 0.5492 275249.9n 0.5492 275250.0n 0.3409 275499.9n 0.3409 275500.0n 0.5006 275749.9n 0.5006 275750.0n 0.5492 275999.9n 0.5492 276000.0n 0.3270 276249.9n 0.3270 276250.0n 0.3964 276499.9n 0.3964 276500.0n 0.3756 276749.9n 0.3756 276750.0n 0.4450 276999.9n 0.4450 277000.0n 0.4520 277249.9n 0.4520 277250.0n 0.4311 277499.9n 0.4311 277500.0n 0.3964 277749.9n 0.3964 277750.0n 0.5006 277999.9n 0.5006 278000.0n 0.3825 278249.9n 0.3825 278250.0n 0.4867 278499.9n 0.4867 278500.0n 0.4589 278749.9n 0.4589 278750.0n 0.3895 278999.9n 0.3895 279000.0n 0.4936 279249.9n 0.4936 279250.0n 0.3548 279499.9n 0.3548 279500.0n 0.4311 279749.9n 0.4311 279750.0n 0.7506 279999.9n 0.7506 280000.0n 0.5353 280249.9n 0.5353 280250.0n 0.5075 280499.9n 0.5075 280500.0n 0.3825 280749.9n 0.3825 280750.0n 0.6464 280999.9n 0.6464 281000.0n 0.5492 281249.9n 0.5492 281250.0n 0.4381 281499.9n 0.4381 281500.0n 0.4103 281749.9n 0.4103 281750.0n 0.5909 281999.9n 0.5909 282000.0n 0.5909 282249.9n 0.5909 282250.0n 0.5006 282499.9n 0.5006 282500.0n 0.5492 282749.9n 0.5492 282750.0n 0.3409 282999.9n 0.3409 283000.0n 0.5006 283249.9n 0.5006 283250.0n 0.5492 283499.9n 0.5492 283500.0n 0.3270 283749.9n 0.3270 283750.0n 0.3964 283999.9n 0.3964 284000.0n 0.3756 284249.9n 0.3756 284250.0n 0.4450 284499.9n 0.4450 284500.0n 0.4520 284749.9n 0.4520 284750.0n 0.4311 284999.9n 0.4311 285000.0n 0.3964 285249.9n 0.3964 285250.0n 0.5006 285499.9n 0.5006 285500.0n 0.3825 285749.9n 0.3825 285750.0n 0.4867 285999.9n 0.4867 286000.0n 0.4589 286249.9n 0.4589 286250.0n 0.3895 286499.9n 0.3895 286500.0n 0.4936 286749.9n 0.4936 286750.0n 0.3548 286999.9n 0.3548 287000.0n 0.4311 287249.9n 0.4311 287250.0n 0.7506 287499.9n 0.7506 287500.0n 0.5353 287749.9n 0.5353 287750.0n 0.5075 287999.9n 0.5075 288000.0n 0.3825 288249.9n 0.3825 288250.0n 0.6464 288499.9n 0.6464 288500.0n 0.5492 288749.9n 0.5492 288750.0n 0.4381 288999.9n 0.4381 289000.0n 0.4103 289249.9n 0.4103 289250.0n 0.5909 289499.9n 0.5909 289500.0n 0.5909 289749.9n 0.5909 289750.0n 0.5006 289999.9n 0.5006 290000.0n 0.5492 290249.9n 0.5492 290250.0n 0.3409 290499.9n 0.3409 290500.0n 0.5006 290749.9n 0.5006 290750.0n 0.5492 290999.9n 0.5492 291000.0n 0.3270 291249.9n 0.3270 291250.0n 0.3964 291499.9n 0.3964 291500.0n 0.3756 291749.9n 0.3756 291750.0n 0.4450 291999.9n 0.4450 292000.0n 0.4520 292249.9n 0.4520 292250.0n 0.4311 292499.9n 0.4311 292500.0n 0.3964 292749.9n 0.3964 292750.0n 0.5006 292999.9n 0.5006 293000.0n 0.3825 293249.9n 0.3825 293250.0n 0.4867 293499.9n 0.4867 293500.0n 0.4589 293749.9n 0.4589 293750.0n 0.3895 293999.9n 0.3895 294000.0n 0.4936 294249.9n 0.4936 294250.0n 0.3548 294499.9n 0.3548 294500.0n 0.4311 294749.9n 0.4311 294750.0n 0.7506 294999.9n 0.7506 295000.0n 0.5353 295249.9n 0.5353 295250.0n 0.5075 295499.9n 0.5075 295500.0n 0.3825 295749.9n 0.3825 295750.0n 0.6464 295999.9n 0.6464 296000.0n 0.5492 296249.9n 0.5492 296250.0n 0.4381 296499.9n 0.4381 296500.0n 0.4103 296749.9n 0.4103 296750.0n 0.5909 296999.9n 0.5909 297000.0n 0.5909 297249.9n 0.5909 297250.0n 0.5006 297499.9n 0.5006 297500.0n 0.5492 297749.9n 0.5492 297750.0n 0.3409 297999.9n 0.3409 298000.0n 0.5006 298249.9n 0.5006 298250.0n 0.5492 298499.9n 0.5492 298500.0n 0.3270 298749.9n 0.3270 298750.0n 0.3964 298999.9n 0.3964 299000.0n 0.3756 299249.9n 0.3756 299250.0n 0.4450 299499.9n 0.4450 299500.0n 0.4520 299749.9n 0.4520 299750.0n 0.4311)
Vxp3 a_xp3 0 PWL(0.0n 0.5881 249.9n 0.5881 250.0n 0.4537 499.9n 0.4537 500.0n 0.6016 749.9n 0.6016 750.0n 0.4537 999.9n 0.4537 1000.0n 0.4537 1249.9n 0.4537 1250.0n 0.4537 1499.9n 0.4537 1500.0n 0.4806 1749.9n 0.4806 1750.0n 0.5881 1999.9n 0.5881 2000.0n 0.4537 2249.9n 0.4537 2250.0n 0.4537 2499.9n 0.4537 2500.0n 0.4537 2749.9n 0.4537 2750.0n 0.4537 2999.9n 0.4537 3000.0n 0.6688 3249.9n 0.6688 3250.0n 0.4537 3499.9n 0.4537 3500.0n 0.4537 3749.9n 0.4537 3750.0n 0.4537 3999.9n 0.4537 4000.0n 0.4671 4249.9n 0.4671 4250.0n 0.4806 4499.9n 0.4806 4500.0n 0.4537 4749.9n 0.4537 4750.0n 0.4537 4999.9n 0.4537 5000.0n 0.4537 5249.9n 0.4537 5250.0n 0.5074 5499.9n 0.5074 5500.0n 0.4537 5749.9n 0.4537 5750.0n 0.4537 5999.9n 0.4537 6000.0n 0.6016 6249.9n 0.6016 6250.0n 0.4940 6499.9n 0.4940 6500.0n 0.4537 6749.9n 0.4537 6750.0n 0.4806 6999.9n 0.4806 7000.0n 0.4671 7249.9n 0.4671 7250.0n 0.4806 7499.9n 0.4806 7500.0n 0.5881 7749.9n 0.5881 7750.0n 0.4537 7999.9n 0.4537 8000.0n 0.6016 8249.9n 0.6016 8250.0n 0.4537 8499.9n 0.4537 8500.0n 0.4537 8749.9n 0.4537 8750.0n 0.4537 8999.9n 0.4537 9000.0n 0.4806 9249.9n 0.4806 9250.0n 0.5881 9499.9n 0.5881 9500.0n 0.4537 9749.9n 0.4537 9750.0n 0.4537 9999.9n 0.4537 10000.0n 0.4537 10249.9n 0.4537 10250.0n 0.4537 10499.9n 0.4537 10500.0n 0.6688 10749.9n 0.6688 10750.0n 0.4537 10999.9n 0.4537 11000.0n 0.4537 11249.9n 0.4537 11250.0n 0.4537 11499.9n 0.4537 11500.0n 0.4671 11749.9n 0.4671 11750.0n 0.4806 11999.9n 0.4806 12000.0n 0.4537 12249.9n 0.4537 12250.0n 0.4537 12499.9n 0.4537 12500.0n 0.4537 12749.9n 0.4537 12750.0n 0.5074 12999.9n 0.5074 13000.0n 0.4537 13249.9n 0.4537 13250.0n 0.4537 13499.9n 0.4537 13500.0n 0.6016 13749.9n 0.6016 13750.0n 0.4940 13999.9n 0.4940 14000.0n 0.4537 14249.9n 0.4537 14250.0n 0.4806 14499.9n 0.4806 14500.0n 0.4671 14749.9n 0.4671 14750.0n 0.4806 14999.9n 0.4806 15000.0n 0.5881 15249.9n 0.5881 15250.0n 0.4537 15499.9n 0.4537 15500.0n 0.6016 15749.9n 0.6016 15750.0n 0.4537 15999.9n 0.4537 16000.0n 0.4537 16249.9n 0.4537 16250.0n 0.4537 16499.9n 0.4537 16500.0n 0.4806 16749.9n 0.4806 16750.0n 0.5881 16999.9n 0.5881 17000.0n 0.4537 17249.9n 0.4537 17250.0n 0.4537 17499.9n 0.4537 17500.0n 0.4537 17749.9n 0.4537 17750.0n 0.4537 17999.9n 0.4537 18000.0n 0.6688 18249.9n 0.6688 18250.0n 0.4537 18499.9n 0.4537 18500.0n 0.4537 18749.9n 0.4537 18750.0n 0.4537 18999.9n 0.4537 19000.0n 0.4671 19249.9n 0.4671 19250.0n 0.4806 19499.9n 0.4806 19500.0n 0.4537 19749.9n 0.4537 19750.0n 0.4537 19999.9n 0.4537 20000.0n 0.4537 20249.9n 0.4537 20250.0n 0.5074 20499.9n 0.5074 20500.0n 0.4537 20749.9n 0.4537 20750.0n 0.4537 20999.9n 0.4537 21000.0n 0.6016 21249.9n 0.6016 21250.0n 0.4940 21499.9n 0.4940 21500.0n 0.4537 21749.9n 0.4537 21750.0n 0.4806 21999.9n 0.4806 22000.0n 0.4671 22249.9n 0.4671 22250.0n 0.4806 22499.9n 0.4806 22500.0n 0.5881 22749.9n 0.5881 22750.0n 0.4537 22999.9n 0.4537 23000.0n 0.6016 23249.9n 0.6016 23250.0n 0.4537 23499.9n 0.4537 23500.0n 0.4537 23749.9n 0.4537 23750.0n 0.4537 23999.9n 0.4537 24000.0n 0.4806 24249.9n 0.4806 24250.0n 0.5881 24499.9n 0.5881 24500.0n 0.4537 24749.9n 0.4537 24750.0n 0.4537 24999.9n 0.4537 25000.0n 0.4537 25249.9n 0.4537 25250.0n 0.4537 25499.9n 0.4537 25500.0n 0.6688 25749.9n 0.6688 25750.0n 0.4537 25999.9n 0.4537 26000.0n 0.4537 26249.9n 0.4537 26250.0n 0.4537 26499.9n 0.4537 26500.0n 0.4671 26749.9n 0.4671 26750.0n 0.4806 26999.9n 0.4806 27000.0n 0.4537 27249.9n 0.4537 27250.0n 0.4537 27499.9n 0.4537 27500.0n 0.4537 27749.9n 0.4537 27750.0n 0.5074 27999.9n 0.5074 28000.0n 0.4537 28249.9n 0.4537 28250.0n 0.4537 28499.9n 0.4537 28500.0n 0.6016 28749.9n 0.6016 28750.0n 0.4940 28999.9n 0.4940 29000.0n 0.4537 29249.9n 0.4537 29250.0n 0.4806 29499.9n 0.4806 29500.0n 0.4671 29749.9n 0.4671 29750.0n 0.4806 29999.9n 0.4806 30000.0n 0.5881 30249.9n 0.5881 30250.0n 0.4537 30499.9n 0.4537 30500.0n 0.6016 30749.9n 0.6016 30750.0n 0.4537 30999.9n 0.4537 31000.0n 0.4537 31249.9n 0.4537 31250.0n 0.4537 31499.9n 0.4537 31500.0n 0.4806 31749.9n 0.4806 31750.0n 0.5881 31999.9n 0.5881 32000.0n 0.4537 32249.9n 0.4537 32250.0n 0.4537 32499.9n 0.4537 32500.0n 0.4537 32749.9n 0.4537 32750.0n 0.4537 32999.9n 0.4537 33000.0n 0.6688 33249.9n 0.6688 33250.0n 0.4537 33499.9n 0.4537 33500.0n 0.4537 33749.9n 0.4537 33750.0n 0.4537 33999.9n 0.4537 34000.0n 0.4671 34249.9n 0.4671 34250.0n 0.4806 34499.9n 0.4806 34500.0n 0.4537 34749.9n 0.4537 34750.0n 0.4537 34999.9n 0.4537 35000.0n 0.4537 35249.9n 0.4537 35250.0n 0.5074 35499.9n 0.5074 35500.0n 0.4537 35749.9n 0.4537 35750.0n 0.4537 35999.9n 0.4537 36000.0n 0.6016 36249.9n 0.6016 36250.0n 0.4940 36499.9n 0.4940 36500.0n 0.4537 36749.9n 0.4537 36750.0n 0.4806 36999.9n 0.4806 37000.0n 0.4671 37249.9n 0.4671 37250.0n 0.4806 37499.9n 0.4806 37500.0n 0.5881 37749.9n 0.5881 37750.0n 0.4537 37999.9n 0.4537 38000.0n 0.6016 38249.9n 0.6016 38250.0n 0.4537 38499.9n 0.4537 38500.0n 0.4537 38749.9n 0.4537 38750.0n 0.4537 38999.9n 0.4537 39000.0n 0.4806 39249.9n 0.4806 39250.0n 0.5881 39499.9n 0.5881 39500.0n 0.4537 39749.9n 0.4537 39750.0n 0.4537 39999.9n 0.4537 40000.0n 0.4537 40249.9n 0.4537 40250.0n 0.4537 40499.9n 0.4537 40500.0n 0.6688 40749.9n 0.6688 40750.0n 0.4537 40999.9n 0.4537 41000.0n 0.4537 41249.9n 0.4537 41250.0n 0.4537 41499.9n 0.4537 41500.0n 0.4671 41749.9n 0.4671 41750.0n 0.4806 41999.9n 0.4806 42000.0n 0.4537 42249.9n 0.4537 42250.0n 0.4537 42499.9n 0.4537 42500.0n 0.4537 42749.9n 0.4537 42750.0n 0.5074 42999.9n 0.5074 43000.0n 0.4537 43249.9n 0.4537 43250.0n 0.4537 43499.9n 0.4537 43500.0n 0.6016 43749.9n 0.6016 43750.0n 0.4940 43999.9n 0.4940 44000.0n 0.4537 44249.9n 0.4537 44250.0n 0.4806 44499.9n 0.4806 44500.0n 0.4671 44749.9n 0.4671 44750.0n 0.4806 44999.9n 0.4806 45000.0n 0.5881 45249.9n 0.5881 45250.0n 0.4537 45499.9n 0.4537 45500.0n 0.6016 45749.9n 0.6016 45750.0n 0.4537 45999.9n 0.4537 46000.0n 0.4537 46249.9n 0.4537 46250.0n 0.4537 46499.9n 0.4537 46500.0n 0.4806 46749.9n 0.4806 46750.0n 0.5881 46999.9n 0.5881 47000.0n 0.4537 47249.9n 0.4537 47250.0n 0.4537 47499.9n 0.4537 47500.0n 0.4537 47749.9n 0.4537 47750.0n 0.4537 47999.9n 0.4537 48000.0n 0.6688 48249.9n 0.6688 48250.0n 0.4537 48499.9n 0.4537 48500.0n 0.4537 48749.9n 0.4537 48750.0n 0.4537 48999.9n 0.4537 49000.0n 0.4671 49249.9n 0.4671 49250.0n 0.4806 49499.9n 0.4806 49500.0n 0.4537 49749.9n 0.4537 49750.0n 0.4537 49999.9n 0.4537 50000.0n 0.4537 50249.9n 0.4537 50250.0n 0.5074 50499.9n 0.5074 50500.0n 0.4537 50749.9n 0.4537 50750.0n 0.4537 50999.9n 0.4537 51000.0n 0.6016 51249.9n 0.6016 51250.0n 0.4940 51499.9n 0.4940 51500.0n 0.4537 51749.9n 0.4537 51750.0n 0.4806 51999.9n 0.4806 52000.0n 0.4671 52249.9n 0.4671 52250.0n 0.4806 52499.9n 0.4806 52500.0n 0.5881 52749.9n 0.5881 52750.0n 0.4537 52999.9n 0.4537 53000.0n 0.6016 53249.9n 0.6016 53250.0n 0.4537 53499.9n 0.4537 53500.0n 0.4537 53749.9n 0.4537 53750.0n 0.4537 53999.9n 0.4537 54000.0n 0.4806 54249.9n 0.4806 54250.0n 0.5881 54499.9n 0.5881 54500.0n 0.4537 54749.9n 0.4537 54750.0n 0.4537 54999.9n 0.4537 55000.0n 0.4537 55249.9n 0.4537 55250.0n 0.4537 55499.9n 0.4537 55500.0n 0.6688 55749.9n 0.6688 55750.0n 0.4537 55999.9n 0.4537 56000.0n 0.4537 56249.9n 0.4537 56250.0n 0.4537 56499.9n 0.4537 56500.0n 0.4671 56749.9n 0.4671 56750.0n 0.4806 56999.9n 0.4806 57000.0n 0.4537 57249.9n 0.4537 57250.0n 0.4537 57499.9n 0.4537 57500.0n 0.4537 57749.9n 0.4537 57750.0n 0.5074 57999.9n 0.5074 58000.0n 0.4537 58249.9n 0.4537 58250.0n 0.4537 58499.9n 0.4537 58500.0n 0.6016 58749.9n 0.6016 58750.0n 0.4940 58999.9n 0.4940 59000.0n 0.4537 59249.9n 0.4537 59250.0n 0.4806 59499.9n 0.4806 59500.0n 0.4671 59749.9n 0.4671 59750.0n 0.4806 59999.9n 0.4806 60000.0n 0.5881 60249.9n 0.5881 60250.0n 0.4537 60499.9n 0.4537 60500.0n 0.6016 60749.9n 0.6016 60750.0n 0.4537 60999.9n 0.4537 61000.0n 0.4537 61249.9n 0.4537 61250.0n 0.4537 61499.9n 0.4537 61500.0n 0.4806 61749.9n 0.4806 61750.0n 0.5881 61999.9n 0.5881 62000.0n 0.4537 62249.9n 0.4537 62250.0n 0.4537 62499.9n 0.4537 62500.0n 0.4537 62749.9n 0.4537 62750.0n 0.4537 62999.9n 0.4537 63000.0n 0.6688 63249.9n 0.6688 63250.0n 0.4537 63499.9n 0.4537 63500.0n 0.4537 63749.9n 0.4537 63750.0n 0.4537 63999.9n 0.4537 64000.0n 0.4671 64249.9n 0.4671 64250.0n 0.4806 64499.9n 0.4806 64500.0n 0.4537 64749.9n 0.4537 64750.0n 0.4537 64999.9n 0.4537 65000.0n 0.4537 65249.9n 0.4537 65250.0n 0.5074 65499.9n 0.5074 65500.0n 0.4537 65749.9n 0.4537 65750.0n 0.4537 65999.9n 0.4537 66000.0n 0.6016 66249.9n 0.6016 66250.0n 0.4940 66499.9n 0.4940 66500.0n 0.4537 66749.9n 0.4537 66750.0n 0.4806 66999.9n 0.4806 67000.0n 0.4671 67249.9n 0.4671 67250.0n 0.4806 67499.9n 0.4806 67500.0n 0.5881 67749.9n 0.5881 67750.0n 0.4537 67999.9n 0.4537 68000.0n 0.6016 68249.9n 0.6016 68250.0n 0.4537 68499.9n 0.4537 68500.0n 0.4537 68749.9n 0.4537 68750.0n 0.4537 68999.9n 0.4537 69000.0n 0.4806 69249.9n 0.4806 69250.0n 0.5881 69499.9n 0.5881 69500.0n 0.4537 69749.9n 0.4537 69750.0n 0.4537 69999.9n 0.4537 70000.0n 0.4537 70249.9n 0.4537 70250.0n 0.4537 70499.9n 0.4537 70500.0n 0.6688 70749.9n 0.6688 70750.0n 0.4537 70999.9n 0.4537 71000.0n 0.4537 71249.9n 0.4537 71250.0n 0.4537 71499.9n 0.4537 71500.0n 0.4671 71749.9n 0.4671 71750.0n 0.4806 71999.9n 0.4806 72000.0n 0.4537 72249.9n 0.4537 72250.0n 0.4537 72499.9n 0.4537 72500.0n 0.4537 72749.9n 0.4537 72750.0n 0.5074 72999.9n 0.5074 73000.0n 0.4537 73249.9n 0.4537 73250.0n 0.4537 73499.9n 0.4537 73500.0n 0.6016 73749.9n 0.6016 73750.0n 0.4940 73999.9n 0.4940 74000.0n 0.4537 74249.9n 0.4537 74250.0n 0.4806 74499.9n 0.4806 74500.0n 0.4671 74749.9n 0.4671 74750.0n 0.4806 74999.9n 0.4806 75000.0n 0.5881 75249.9n 0.5881 75250.0n 0.4537 75499.9n 0.4537 75500.0n 0.6016 75749.9n 0.6016 75750.0n 0.4537 75999.9n 0.4537 76000.0n 0.4537 76249.9n 0.4537 76250.0n 0.4537 76499.9n 0.4537 76500.0n 0.4806 76749.9n 0.4806 76750.0n 0.5881 76999.9n 0.5881 77000.0n 0.4537 77249.9n 0.4537 77250.0n 0.4537 77499.9n 0.4537 77500.0n 0.4537 77749.9n 0.4537 77750.0n 0.4537 77999.9n 0.4537 78000.0n 0.6688 78249.9n 0.6688 78250.0n 0.4537 78499.9n 0.4537 78500.0n 0.4537 78749.9n 0.4537 78750.0n 0.4537 78999.9n 0.4537 79000.0n 0.4671 79249.9n 0.4671 79250.0n 0.4806 79499.9n 0.4806 79500.0n 0.4537 79749.9n 0.4537 79750.0n 0.4537 79999.9n 0.4537 80000.0n 0.4537 80249.9n 0.4537 80250.0n 0.5074 80499.9n 0.5074 80500.0n 0.4537 80749.9n 0.4537 80750.0n 0.4537 80999.9n 0.4537 81000.0n 0.6016 81249.9n 0.6016 81250.0n 0.4940 81499.9n 0.4940 81500.0n 0.4537 81749.9n 0.4537 81750.0n 0.4806 81999.9n 0.4806 82000.0n 0.4671 82249.9n 0.4671 82250.0n 0.4806 82499.9n 0.4806 82500.0n 0.5881 82749.9n 0.5881 82750.0n 0.4537 82999.9n 0.4537 83000.0n 0.6016 83249.9n 0.6016 83250.0n 0.4537 83499.9n 0.4537 83500.0n 0.4537 83749.9n 0.4537 83750.0n 0.4537 83999.9n 0.4537 84000.0n 0.4806 84249.9n 0.4806 84250.0n 0.5881 84499.9n 0.5881 84500.0n 0.4537 84749.9n 0.4537 84750.0n 0.4537 84999.9n 0.4537 85000.0n 0.4537 85249.9n 0.4537 85250.0n 0.4537 85499.9n 0.4537 85500.0n 0.6688 85749.9n 0.6688 85750.0n 0.4537 85999.9n 0.4537 86000.0n 0.4537 86249.9n 0.4537 86250.0n 0.4537 86499.9n 0.4537 86500.0n 0.4671 86749.9n 0.4671 86750.0n 0.4806 86999.9n 0.4806 87000.0n 0.4537 87249.9n 0.4537 87250.0n 0.4537 87499.9n 0.4537 87500.0n 0.4537 87749.9n 0.4537 87750.0n 0.5074 87999.9n 0.5074 88000.0n 0.4537 88249.9n 0.4537 88250.0n 0.4537 88499.9n 0.4537 88500.0n 0.6016 88749.9n 0.6016 88750.0n 0.4940 88999.9n 0.4940 89000.0n 0.4537 89249.9n 0.4537 89250.0n 0.4806 89499.9n 0.4806 89500.0n 0.4671 89749.9n 0.4671 89750.0n 0.4806 89999.9n 0.4806 90000.0n 0.5881 90249.9n 0.5881 90250.0n 0.4537 90499.9n 0.4537 90500.0n 0.6016 90749.9n 0.6016 90750.0n 0.4537 90999.9n 0.4537 91000.0n 0.4537 91249.9n 0.4537 91250.0n 0.4537 91499.9n 0.4537 91500.0n 0.4806 91749.9n 0.4806 91750.0n 0.5881 91999.9n 0.5881 92000.0n 0.4537 92249.9n 0.4537 92250.0n 0.4537 92499.9n 0.4537 92500.0n 0.4537 92749.9n 0.4537 92750.0n 0.4537 92999.9n 0.4537 93000.0n 0.6688 93249.9n 0.6688 93250.0n 0.4537 93499.9n 0.4537 93500.0n 0.4537 93749.9n 0.4537 93750.0n 0.4537 93999.9n 0.4537 94000.0n 0.4671 94249.9n 0.4671 94250.0n 0.4806 94499.9n 0.4806 94500.0n 0.4537 94749.9n 0.4537 94750.0n 0.4537 94999.9n 0.4537 95000.0n 0.4537 95249.9n 0.4537 95250.0n 0.5074 95499.9n 0.5074 95500.0n 0.4537 95749.9n 0.4537 95750.0n 0.4537 95999.9n 0.4537 96000.0n 0.6016 96249.9n 0.6016 96250.0n 0.4940 96499.9n 0.4940 96500.0n 0.4537 96749.9n 0.4537 96750.0n 0.4806 96999.9n 0.4806 97000.0n 0.4671 97249.9n 0.4671 97250.0n 0.4806 97499.9n 0.4806 97500.0n 0.5881 97749.9n 0.5881 97750.0n 0.4537 97999.9n 0.4537 98000.0n 0.6016 98249.9n 0.6016 98250.0n 0.4537 98499.9n 0.4537 98500.0n 0.4537 98749.9n 0.4537 98750.0n 0.4537 98999.9n 0.4537 99000.0n 0.4806 99249.9n 0.4806 99250.0n 0.5881 99499.9n 0.5881 99500.0n 0.4537 99749.9n 0.4537 99750.0n 0.4537 99999.9n 0.4537 100000.0n 0.4537 100249.9n 0.4537 100250.0n 0.4537 100499.9n 0.4537 100500.0n 0.6688 100749.9n 0.6688 100750.0n 0.4537 100999.9n 0.4537 101000.0n 0.4537 101249.9n 0.4537 101250.0n 0.4537 101499.9n 0.4537 101500.0n 0.4671 101749.9n 0.4671 101750.0n 0.4806 101999.9n 0.4806 102000.0n 0.4537 102249.9n 0.4537 102250.0n 0.4537 102499.9n 0.4537 102500.0n 0.4537 102749.9n 0.4537 102750.0n 0.5074 102999.9n 0.5074 103000.0n 0.4537 103249.9n 0.4537 103250.0n 0.4537 103499.9n 0.4537 103500.0n 0.6016 103749.9n 0.6016 103750.0n 0.4940 103999.9n 0.4940 104000.0n 0.4537 104249.9n 0.4537 104250.0n 0.4806 104499.9n 0.4806 104500.0n 0.4671 104749.9n 0.4671 104750.0n 0.4806 104999.9n 0.4806 105000.0n 0.5881 105249.9n 0.5881 105250.0n 0.4537 105499.9n 0.4537 105500.0n 0.6016 105749.9n 0.6016 105750.0n 0.4537 105999.9n 0.4537 106000.0n 0.4537 106249.9n 0.4537 106250.0n 0.4537 106499.9n 0.4537 106500.0n 0.4806 106749.9n 0.4806 106750.0n 0.5881 106999.9n 0.5881 107000.0n 0.4537 107249.9n 0.4537 107250.0n 0.4537 107499.9n 0.4537 107500.0n 0.4537 107749.9n 0.4537 107750.0n 0.4537 107999.9n 0.4537 108000.0n 0.6688 108249.9n 0.6688 108250.0n 0.4537 108499.9n 0.4537 108500.0n 0.4537 108749.9n 0.4537 108750.0n 0.4537 108999.9n 0.4537 109000.0n 0.4671 109249.9n 0.4671 109250.0n 0.4806 109499.9n 0.4806 109500.0n 0.4537 109749.9n 0.4537 109750.0n 0.4537 109999.9n 0.4537 110000.0n 0.4537 110249.9n 0.4537 110250.0n 0.5074 110499.9n 0.5074 110500.0n 0.4537 110749.9n 0.4537 110750.0n 0.4537 110999.9n 0.4537 111000.0n 0.6016 111249.9n 0.6016 111250.0n 0.4940 111499.9n 0.4940 111500.0n 0.4537 111749.9n 0.4537 111750.0n 0.4806 111999.9n 0.4806 112000.0n 0.4671 112249.9n 0.4671 112250.0n 0.4806 112499.9n 0.4806 112500.0n 0.5881 112749.9n 0.5881 112750.0n 0.4537 112999.9n 0.4537 113000.0n 0.6016 113249.9n 0.6016 113250.0n 0.4537 113499.9n 0.4537 113500.0n 0.4537 113749.9n 0.4537 113750.0n 0.4537 113999.9n 0.4537 114000.0n 0.4806 114249.9n 0.4806 114250.0n 0.5881 114499.9n 0.5881 114500.0n 0.4537 114749.9n 0.4537 114750.0n 0.4537 114999.9n 0.4537 115000.0n 0.4537 115249.9n 0.4537 115250.0n 0.4537 115499.9n 0.4537 115500.0n 0.6688 115749.9n 0.6688 115750.0n 0.4537 115999.9n 0.4537 116000.0n 0.4537 116249.9n 0.4537 116250.0n 0.4537 116499.9n 0.4537 116500.0n 0.4671 116749.9n 0.4671 116750.0n 0.4806 116999.9n 0.4806 117000.0n 0.4537 117249.9n 0.4537 117250.0n 0.4537 117499.9n 0.4537 117500.0n 0.4537 117749.9n 0.4537 117750.0n 0.5074 117999.9n 0.5074 118000.0n 0.4537 118249.9n 0.4537 118250.0n 0.4537 118499.9n 0.4537 118500.0n 0.6016 118749.9n 0.6016 118750.0n 0.4940 118999.9n 0.4940 119000.0n 0.4537 119249.9n 0.4537 119250.0n 0.4806 119499.9n 0.4806 119500.0n 0.4671 119749.9n 0.4671 119750.0n 0.4806 119999.9n 0.4806 120000.0n 0.5881 120249.9n 0.5881 120250.0n 0.4537 120499.9n 0.4537 120500.0n 0.6016 120749.9n 0.6016 120750.0n 0.4537 120999.9n 0.4537 121000.0n 0.4537 121249.9n 0.4537 121250.0n 0.4537 121499.9n 0.4537 121500.0n 0.4806 121749.9n 0.4806 121750.0n 0.5881 121999.9n 0.5881 122000.0n 0.4537 122249.9n 0.4537 122250.0n 0.4537 122499.9n 0.4537 122500.0n 0.4537 122749.9n 0.4537 122750.0n 0.4537 122999.9n 0.4537 123000.0n 0.6688 123249.9n 0.6688 123250.0n 0.4537 123499.9n 0.4537 123500.0n 0.4537 123749.9n 0.4537 123750.0n 0.4537 123999.9n 0.4537 124000.0n 0.4671 124249.9n 0.4671 124250.0n 0.4806 124499.9n 0.4806 124500.0n 0.4537 124749.9n 0.4537 124750.0n 0.4537 124999.9n 0.4537 125000.0n 0.4537 125249.9n 0.4537 125250.0n 0.5074 125499.9n 0.5074 125500.0n 0.4537 125749.9n 0.4537 125750.0n 0.4537 125999.9n 0.4537 126000.0n 0.6016 126249.9n 0.6016 126250.0n 0.4940 126499.9n 0.4940 126500.0n 0.4537 126749.9n 0.4537 126750.0n 0.4806 126999.9n 0.4806 127000.0n 0.4671 127249.9n 0.4671 127250.0n 0.4806 127499.9n 0.4806 127500.0n 0.5881 127749.9n 0.5881 127750.0n 0.4537 127999.9n 0.4537 128000.0n 0.6016 128249.9n 0.6016 128250.0n 0.4537 128499.9n 0.4537 128500.0n 0.4537 128749.9n 0.4537 128750.0n 0.4537 128999.9n 0.4537 129000.0n 0.4806 129249.9n 0.4806 129250.0n 0.5881 129499.9n 0.5881 129500.0n 0.4537 129749.9n 0.4537 129750.0n 0.4537 129999.9n 0.4537 130000.0n 0.4537 130249.9n 0.4537 130250.0n 0.4537 130499.9n 0.4537 130500.0n 0.6688 130749.9n 0.6688 130750.0n 0.4537 130999.9n 0.4537 131000.0n 0.4537 131249.9n 0.4537 131250.0n 0.4537 131499.9n 0.4537 131500.0n 0.4671 131749.9n 0.4671 131750.0n 0.4806 131999.9n 0.4806 132000.0n 0.4537 132249.9n 0.4537 132250.0n 0.4537 132499.9n 0.4537 132500.0n 0.4537 132749.9n 0.4537 132750.0n 0.5074 132999.9n 0.5074 133000.0n 0.4537 133249.9n 0.4537 133250.0n 0.4537 133499.9n 0.4537 133500.0n 0.6016 133749.9n 0.6016 133750.0n 0.4940 133999.9n 0.4940 134000.0n 0.4537 134249.9n 0.4537 134250.0n 0.4806 134499.9n 0.4806 134500.0n 0.4671 134749.9n 0.4671 134750.0n 0.4806 134999.9n 0.4806 135000.0n 0.5881 135249.9n 0.5881 135250.0n 0.4537 135499.9n 0.4537 135500.0n 0.6016 135749.9n 0.6016 135750.0n 0.4537 135999.9n 0.4537 136000.0n 0.4537 136249.9n 0.4537 136250.0n 0.4537 136499.9n 0.4537 136500.0n 0.4806 136749.9n 0.4806 136750.0n 0.5881 136999.9n 0.5881 137000.0n 0.4537 137249.9n 0.4537 137250.0n 0.4537 137499.9n 0.4537 137500.0n 0.4537 137749.9n 0.4537 137750.0n 0.4537 137999.9n 0.4537 138000.0n 0.6688 138249.9n 0.6688 138250.0n 0.4537 138499.9n 0.4537 138500.0n 0.4537 138749.9n 0.4537 138750.0n 0.4537 138999.9n 0.4537 139000.0n 0.4671 139249.9n 0.4671 139250.0n 0.4806 139499.9n 0.4806 139500.0n 0.4537 139749.9n 0.4537 139750.0n 0.4537 139999.9n 0.4537 140000.0n 0.4537 140249.9n 0.4537 140250.0n 0.5074 140499.9n 0.5074 140500.0n 0.4537 140749.9n 0.4537 140750.0n 0.4537 140999.9n 0.4537 141000.0n 0.6016 141249.9n 0.6016 141250.0n 0.4940 141499.9n 0.4940 141500.0n 0.4537 141749.9n 0.4537 141750.0n 0.4806 141999.9n 0.4806 142000.0n 0.4671 142249.9n 0.4671 142250.0n 0.4806 142499.9n 0.4806 142500.0n 0.5881 142749.9n 0.5881 142750.0n 0.4537 142999.9n 0.4537 143000.0n 0.6016 143249.9n 0.6016 143250.0n 0.4537 143499.9n 0.4537 143500.0n 0.4537 143749.9n 0.4537 143750.0n 0.4537 143999.9n 0.4537 144000.0n 0.4806 144249.9n 0.4806 144250.0n 0.5881 144499.9n 0.5881 144500.0n 0.4537 144749.9n 0.4537 144750.0n 0.4537 144999.9n 0.4537 145000.0n 0.4537 145249.9n 0.4537 145250.0n 0.4537 145499.9n 0.4537 145500.0n 0.6688 145749.9n 0.6688 145750.0n 0.4537 145999.9n 0.4537 146000.0n 0.4537 146249.9n 0.4537 146250.0n 0.4537 146499.9n 0.4537 146500.0n 0.4671 146749.9n 0.4671 146750.0n 0.4806 146999.9n 0.4806 147000.0n 0.4537 147249.9n 0.4537 147250.0n 0.4537 147499.9n 0.4537 147500.0n 0.4537 147749.9n 0.4537 147750.0n 0.5074 147999.9n 0.5074 148000.0n 0.4537 148249.9n 0.4537 148250.0n 0.4537 148499.9n 0.4537 148500.0n 0.6016 148749.9n 0.6016 148750.0n 0.4940 148999.9n 0.4940 149000.0n 0.4537 149249.9n 0.4537 149250.0n 0.4806 149499.9n 0.4806 149500.0n 0.4671 149749.9n 0.4671 149750.0n 0.4806 149999.9n 0.4806 150000.0n 0.5881 150249.9n 0.5881 150250.0n 0.4537 150499.9n 0.4537 150500.0n 0.6016 150749.9n 0.6016 150750.0n 0.4537 150999.9n 0.4537 151000.0n 0.4537 151249.9n 0.4537 151250.0n 0.4537 151499.9n 0.4537 151500.0n 0.4806 151749.9n 0.4806 151750.0n 0.5881 151999.9n 0.5881 152000.0n 0.4537 152249.9n 0.4537 152250.0n 0.4537 152499.9n 0.4537 152500.0n 0.4537 152749.9n 0.4537 152750.0n 0.4537 152999.9n 0.4537 153000.0n 0.6688 153249.9n 0.6688 153250.0n 0.4537 153499.9n 0.4537 153500.0n 0.4537 153749.9n 0.4537 153750.0n 0.4537 153999.9n 0.4537 154000.0n 0.4671 154249.9n 0.4671 154250.0n 0.4806 154499.9n 0.4806 154500.0n 0.4537 154749.9n 0.4537 154750.0n 0.4537 154999.9n 0.4537 155000.0n 0.4537 155249.9n 0.4537 155250.0n 0.5074 155499.9n 0.5074 155500.0n 0.4537 155749.9n 0.4537 155750.0n 0.4537 155999.9n 0.4537 156000.0n 0.6016 156249.9n 0.6016 156250.0n 0.4940 156499.9n 0.4940 156500.0n 0.4537 156749.9n 0.4537 156750.0n 0.4806 156999.9n 0.4806 157000.0n 0.4671 157249.9n 0.4671 157250.0n 0.4806 157499.9n 0.4806 157500.0n 0.5881 157749.9n 0.5881 157750.0n 0.4537 157999.9n 0.4537 158000.0n 0.6016 158249.9n 0.6016 158250.0n 0.4537 158499.9n 0.4537 158500.0n 0.4537 158749.9n 0.4537 158750.0n 0.4537 158999.9n 0.4537 159000.0n 0.4806 159249.9n 0.4806 159250.0n 0.5881 159499.9n 0.5881 159500.0n 0.4537 159749.9n 0.4537 159750.0n 0.4537 159999.9n 0.4537 160000.0n 0.4537 160249.9n 0.4537 160250.0n 0.4537 160499.9n 0.4537 160500.0n 0.6688 160749.9n 0.6688 160750.0n 0.4537 160999.9n 0.4537 161000.0n 0.4537 161249.9n 0.4537 161250.0n 0.4537 161499.9n 0.4537 161500.0n 0.4671 161749.9n 0.4671 161750.0n 0.4806 161999.9n 0.4806 162000.0n 0.4537 162249.9n 0.4537 162250.0n 0.4537 162499.9n 0.4537 162500.0n 0.4537 162749.9n 0.4537 162750.0n 0.5074 162999.9n 0.5074 163000.0n 0.4537 163249.9n 0.4537 163250.0n 0.4537 163499.9n 0.4537 163500.0n 0.6016 163749.9n 0.6016 163750.0n 0.4940 163999.9n 0.4940 164000.0n 0.4537 164249.9n 0.4537 164250.0n 0.4806 164499.9n 0.4806 164500.0n 0.4671 164749.9n 0.4671 164750.0n 0.4806 164999.9n 0.4806 165000.0n 0.5881 165249.9n 0.5881 165250.0n 0.4537 165499.9n 0.4537 165500.0n 0.6016 165749.9n 0.6016 165750.0n 0.4537 165999.9n 0.4537 166000.0n 0.4537 166249.9n 0.4537 166250.0n 0.4537 166499.9n 0.4537 166500.0n 0.4806 166749.9n 0.4806 166750.0n 0.5881 166999.9n 0.5881 167000.0n 0.4537 167249.9n 0.4537 167250.0n 0.4537 167499.9n 0.4537 167500.0n 0.4537 167749.9n 0.4537 167750.0n 0.4537 167999.9n 0.4537 168000.0n 0.6688 168249.9n 0.6688 168250.0n 0.4537 168499.9n 0.4537 168500.0n 0.4537 168749.9n 0.4537 168750.0n 0.4537 168999.9n 0.4537 169000.0n 0.4671 169249.9n 0.4671 169250.0n 0.4806 169499.9n 0.4806 169500.0n 0.4537 169749.9n 0.4537 169750.0n 0.4537 169999.9n 0.4537 170000.0n 0.4537 170249.9n 0.4537 170250.0n 0.5074 170499.9n 0.5074 170500.0n 0.4537 170749.9n 0.4537 170750.0n 0.4537 170999.9n 0.4537 171000.0n 0.6016 171249.9n 0.6016 171250.0n 0.4940 171499.9n 0.4940 171500.0n 0.4537 171749.9n 0.4537 171750.0n 0.4806 171999.9n 0.4806 172000.0n 0.4671 172249.9n 0.4671 172250.0n 0.4806 172499.9n 0.4806 172500.0n 0.5881 172749.9n 0.5881 172750.0n 0.4537 172999.9n 0.4537 173000.0n 0.6016 173249.9n 0.6016 173250.0n 0.4537 173499.9n 0.4537 173500.0n 0.4537 173749.9n 0.4537 173750.0n 0.4537 173999.9n 0.4537 174000.0n 0.4806 174249.9n 0.4806 174250.0n 0.5881 174499.9n 0.5881 174500.0n 0.4537 174749.9n 0.4537 174750.0n 0.4537 174999.9n 0.4537 175000.0n 0.4537 175249.9n 0.4537 175250.0n 0.4537 175499.9n 0.4537 175500.0n 0.6688 175749.9n 0.6688 175750.0n 0.4537 175999.9n 0.4537 176000.0n 0.4537 176249.9n 0.4537 176250.0n 0.4537 176499.9n 0.4537 176500.0n 0.4671 176749.9n 0.4671 176750.0n 0.4806 176999.9n 0.4806 177000.0n 0.4537 177249.9n 0.4537 177250.0n 0.4537 177499.9n 0.4537 177500.0n 0.4537 177749.9n 0.4537 177750.0n 0.5074 177999.9n 0.5074 178000.0n 0.4537 178249.9n 0.4537 178250.0n 0.4537 178499.9n 0.4537 178500.0n 0.6016 178749.9n 0.6016 178750.0n 0.4940 178999.9n 0.4940 179000.0n 0.4537 179249.9n 0.4537 179250.0n 0.4806 179499.9n 0.4806 179500.0n 0.4671 179749.9n 0.4671 179750.0n 0.4806 179999.9n 0.4806 180000.0n 0.5881 180249.9n 0.5881 180250.0n 0.4537 180499.9n 0.4537 180500.0n 0.6016 180749.9n 0.6016 180750.0n 0.4537 180999.9n 0.4537 181000.0n 0.4537 181249.9n 0.4537 181250.0n 0.4537 181499.9n 0.4537 181500.0n 0.4806 181749.9n 0.4806 181750.0n 0.5881 181999.9n 0.5881 182000.0n 0.4537 182249.9n 0.4537 182250.0n 0.4537 182499.9n 0.4537 182500.0n 0.4537 182749.9n 0.4537 182750.0n 0.4537 182999.9n 0.4537 183000.0n 0.6688 183249.9n 0.6688 183250.0n 0.4537 183499.9n 0.4537 183500.0n 0.4537 183749.9n 0.4537 183750.0n 0.4537 183999.9n 0.4537 184000.0n 0.4671 184249.9n 0.4671 184250.0n 0.4806 184499.9n 0.4806 184500.0n 0.4537 184749.9n 0.4537 184750.0n 0.4537 184999.9n 0.4537 185000.0n 0.4537 185249.9n 0.4537 185250.0n 0.5074 185499.9n 0.5074 185500.0n 0.4537 185749.9n 0.4537 185750.0n 0.4537 185999.9n 0.4537 186000.0n 0.6016 186249.9n 0.6016 186250.0n 0.4940 186499.9n 0.4940 186500.0n 0.4537 186749.9n 0.4537 186750.0n 0.4806 186999.9n 0.4806 187000.0n 0.4671 187249.9n 0.4671 187250.0n 0.4806 187499.9n 0.4806 187500.0n 0.5881 187749.9n 0.5881 187750.0n 0.4537 187999.9n 0.4537 188000.0n 0.6016 188249.9n 0.6016 188250.0n 0.4537 188499.9n 0.4537 188500.0n 0.4537 188749.9n 0.4537 188750.0n 0.4537 188999.9n 0.4537 189000.0n 0.4806 189249.9n 0.4806 189250.0n 0.5881 189499.9n 0.5881 189500.0n 0.4537 189749.9n 0.4537 189750.0n 0.4537 189999.9n 0.4537 190000.0n 0.4537 190249.9n 0.4537 190250.0n 0.4537 190499.9n 0.4537 190500.0n 0.6688 190749.9n 0.6688 190750.0n 0.4537 190999.9n 0.4537 191000.0n 0.4537 191249.9n 0.4537 191250.0n 0.4537 191499.9n 0.4537 191500.0n 0.4671 191749.9n 0.4671 191750.0n 0.4806 191999.9n 0.4806 192000.0n 0.4537 192249.9n 0.4537 192250.0n 0.4537 192499.9n 0.4537 192500.0n 0.4537 192749.9n 0.4537 192750.0n 0.5074 192999.9n 0.5074 193000.0n 0.4537 193249.9n 0.4537 193250.0n 0.4537 193499.9n 0.4537 193500.0n 0.6016 193749.9n 0.6016 193750.0n 0.4940 193999.9n 0.4940 194000.0n 0.4537 194249.9n 0.4537 194250.0n 0.4806 194499.9n 0.4806 194500.0n 0.4671 194749.9n 0.4671 194750.0n 0.4806 194999.9n 0.4806 195000.0n 0.5881 195249.9n 0.5881 195250.0n 0.4537 195499.9n 0.4537 195500.0n 0.6016 195749.9n 0.6016 195750.0n 0.4537 195999.9n 0.4537 196000.0n 0.4537 196249.9n 0.4537 196250.0n 0.4537 196499.9n 0.4537 196500.0n 0.4806 196749.9n 0.4806 196750.0n 0.5881 196999.9n 0.5881 197000.0n 0.4537 197249.9n 0.4537 197250.0n 0.4537 197499.9n 0.4537 197500.0n 0.4537 197749.9n 0.4537 197750.0n 0.4537 197999.9n 0.4537 198000.0n 0.6688 198249.9n 0.6688 198250.0n 0.4537 198499.9n 0.4537 198500.0n 0.4537 198749.9n 0.4537 198750.0n 0.4537 198999.9n 0.4537 199000.0n 0.4671 199249.9n 0.4671 199250.0n 0.4806 199499.9n 0.4806 199500.0n 0.4537 199749.9n 0.4537 199750.0n 0.4537 199999.9n 0.4537 200000.0n 0.4537 200249.9n 0.4537 200250.0n 0.5074 200499.9n 0.5074 200500.0n 0.4537 200749.9n 0.4537 200750.0n 0.4537 200999.9n 0.4537 201000.0n 0.6016 201249.9n 0.6016 201250.0n 0.4940 201499.9n 0.4940 201500.0n 0.4537 201749.9n 0.4537 201750.0n 0.4806 201999.9n 0.4806 202000.0n 0.4671 202249.9n 0.4671 202250.0n 0.4806 202499.9n 0.4806 202500.0n 0.5881 202749.9n 0.5881 202750.0n 0.4537 202999.9n 0.4537 203000.0n 0.6016 203249.9n 0.6016 203250.0n 0.4537 203499.9n 0.4537 203500.0n 0.4537 203749.9n 0.4537 203750.0n 0.4537 203999.9n 0.4537 204000.0n 0.4806 204249.9n 0.4806 204250.0n 0.5881 204499.9n 0.5881 204500.0n 0.4537 204749.9n 0.4537 204750.0n 0.4537 204999.9n 0.4537 205000.0n 0.4537 205249.9n 0.4537 205250.0n 0.4537 205499.9n 0.4537 205500.0n 0.6688 205749.9n 0.6688 205750.0n 0.4537 205999.9n 0.4537 206000.0n 0.4537 206249.9n 0.4537 206250.0n 0.4537 206499.9n 0.4537 206500.0n 0.4671 206749.9n 0.4671 206750.0n 0.4806 206999.9n 0.4806 207000.0n 0.4537 207249.9n 0.4537 207250.0n 0.4537 207499.9n 0.4537 207500.0n 0.4537 207749.9n 0.4537 207750.0n 0.5074 207999.9n 0.5074 208000.0n 0.4537 208249.9n 0.4537 208250.0n 0.4537 208499.9n 0.4537 208500.0n 0.6016 208749.9n 0.6016 208750.0n 0.4940 208999.9n 0.4940 209000.0n 0.4537 209249.9n 0.4537 209250.0n 0.4806 209499.9n 0.4806 209500.0n 0.4671 209749.9n 0.4671 209750.0n 0.4806 209999.9n 0.4806 210000.0n 0.5881 210249.9n 0.5881 210250.0n 0.4537 210499.9n 0.4537 210500.0n 0.6016 210749.9n 0.6016 210750.0n 0.4537 210999.9n 0.4537 211000.0n 0.4537 211249.9n 0.4537 211250.0n 0.4537 211499.9n 0.4537 211500.0n 0.4806 211749.9n 0.4806 211750.0n 0.5881 211999.9n 0.5881 212000.0n 0.4537 212249.9n 0.4537 212250.0n 0.4537 212499.9n 0.4537 212500.0n 0.4537 212749.9n 0.4537 212750.0n 0.4537 212999.9n 0.4537 213000.0n 0.6688 213249.9n 0.6688 213250.0n 0.4537 213499.9n 0.4537 213500.0n 0.4537 213749.9n 0.4537 213750.0n 0.4537 213999.9n 0.4537 214000.0n 0.4671 214249.9n 0.4671 214250.0n 0.4806 214499.9n 0.4806 214500.0n 0.4537 214749.9n 0.4537 214750.0n 0.4537 214999.9n 0.4537 215000.0n 0.4537 215249.9n 0.4537 215250.0n 0.5074 215499.9n 0.5074 215500.0n 0.4537 215749.9n 0.4537 215750.0n 0.4537 215999.9n 0.4537 216000.0n 0.6016 216249.9n 0.6016 216250.0n 0.4940 216499.9n 0.4940 216500.0n 0.4537 216749.9n 0.4537 216750.0n 0.4806 216999.9n 0.4806 217000.0n 0.4671 217249.9n 0.4671 217250.0n 0.4806 217499.9n 0.4806 217500.0n 0.5881 217749.9n 0.5881 217750.0n 0.4537 217999.9n 0.4537 218000.0n 0.6016 218249.9n 0.6016 218250.0n 0.4537 218499.9n 0.4537 218500.0n 0.4537 218749.9n 0.4537 218750.0n 0.4537 218999.9n 0.4537 219000.0n 0.4806 219249.9n 0.4806 219250.0n 0.5881 219499.9n 0.5881 219500.0n 0.4537 219749.9n 0.4537 219750.0n 0.4537 219999.9n 0.4537 220000.0n 0.4537 220249.9n 0.4537 220250.0n 0.4537 220499.9n 0.4537 220500.0n 0.6688 220749.9n 0.6688 220750.0n 0.4537 220999.9n 0.4537 221000.0n 0.4537 221249.9n 0.4537 221250.0n 0.4537 221499.9n 0.4537 221500.0n 0.4671 221749.9n 0.4671 221750.0n 0.4806 221999.9n 0.4806 222000.0n 0.4537 222249.9n 0.4537 222250.0n 0.4537 222499.9n 0.4537 222500.0n 0.4537 222749.9n 0.4537 222750.0n 0.5074 222999.9n 0.5074 223000.0n 0.4537 223249.9n 0.4537 223250.0n 0.4537 223499.9n 0.4537 223500.0n 0.6016 223749.9n 0.6016 223750.0n 0.4940 223999.9n 0.4940 224000.0n 0.4537 224249.9n 0.4537 224250.0n 0.4806 224499.9n 0.4806 224500.0n 0.4671 224749.9n 0.4671 224750.0n 0.4806 224999.9n 0.4806 225000.0n 0.5881 225249.9n 0.5881 225250.0n 0.4537 225499.9n 0.4537 225500.0n 0.6016 225749.9n 0.6016 225750.0n 0.4537 225999.9n 0.4537 226000.0n 0.4537 226249.9n 0.4537 226250.0n 0.4537 226499.9n 0.4537 226500.0n 0.4806 226749.9n 0.4806 226750.0n 0.5881 226999.9n 0.5881 227000.0n 0.4537 227249.9n 0.4537 227250.0n 0.4537 227499.9n 0.4537 227500.0n 0.4537 227749.9n 0.4537 227750.0n 0.4537 227999.9n 0.4537 228000.0n 0.6688 228249.9n 0.6688 228250.0n 0.4537 228499.9n 0.4537 228500.0n 0.4537 228749.9n 0.4537 228750.0n 0.4537 228999.9n 0.4537 229000.0n 0.4671 229249.9n 0.4671 229250.0n 0.4806 229499.9n 0.4806 229500.0n 0.4537 229749.9n 0.4537 229750.0n 0.4537 229999.9n 0.4537 230000.0n 0.4537 230249.9n 0.4537 230250.0n 0.5074 230499.9n 0.5074 230500.0n 0.4537 230749.9n 0.4537 230750.0n 0.4537 230999.9n 0.4537 231000.0n 0.6016 231249.9n 0.6016 231250.0n 0.4940 231499.9n 0.4940 231500.0n 0.4537 231749.9n 0.4537 231750.0n 0.4806 231999.9n 0.4806 232000.0n 0.4671 232249.9n 0.4671 232250.0n 0.4806 232499.9n 0.4806 232500.0n 0.5881 232749.9n 0.5881 232750.0n 0.4537 232999.9n 0.4537 233000.0n 0.6016 233249.9n 0.6016 233250.0n 0.4537 233499.9n 0.4537 233500.0n 0.4537 233749.9n 0.4537 233750.0n 0.4537 233999.9n 0.4537 234000.0n 0.4806 234249.9n 0.4806 234250.0n 0.5881 234499.9n 0.5881 234500.0n 0.4537 234749.9n 0.4537 234750.0n 0.4537 234999.9n 0.4537 235000.0n 0.4537 235249.9n 0.4537 235250.0n 0.4537 235499.9n 0.4537 235500.0n 0.6688 235749.9n 0.6688 235750.0n 0.4537 235999.9n 0.4537 236000.0n 0.4537 236249.9n 0.4537 236250.0n 0.4537 236499.9n 0.4537 236500.0n 0.4671 236749.9n 0.4671 236750.0n 0.4806 236999.9n 0.4806 237000.0n 0.4537 237249.9n 0.4537 237250.0n 0.4537 237499.9n 0.4537 237500.0n 0.4537 237749.9n 0.4537 237750.0n 0.5074 237999.9n 0.5074 238000.0n 0.4537 238249.9n 0.4537 238250.0n 0.4537 238499.9n 0.4537 238500.0n 0.6016 238749.9n 0.6016 238750.0n 0.4940 238999.9n 0.4940 239000.0n 0.4537 239249.9n 0.4537 239250.0n 0.4806 239499.9n 0.4806 239500.0n 0.4671 239749.9n 0.4671 239750.0n 0.4806 239999.9n 0.4806 240000.0n 0.5881 240249.9n 0.5881 240250.0n 0.4537 240499.9n 0.4537 240500.0n 0.6016 240749.9n 0.6016 240750.0n 0.4537 240999.9n 0.4537 241000.0n 0.4537 241249.9n 0.4537 241250.0n 0.4537 241499.9n 0.4537 241500.0n 0.4806 241749.9n 0.4806 241750.0n 0.5881 241999.9n 0.5881 242000.0n 0.4537 242249.9n 0.4537 242250.0n 0.4537 242499.9n 0.4537 242500.0n 0.4537 242749.9n 0.4537 242750.0n 0.4537 242999.9n 0.4537 243000.0n 0.6688 243249.9n 0.6688 243250.0n 0.4537 243499.9n 0.4537 243500.0n 0.4537 243749.9n 0.4537 243750.0n 0.4537 243999.9n 0.4537 244000.0n 0.4671 244249.9n 0.4671 244250.0n 0.4806 244499.9n 0.4806 244500.0n 0.4537 244749.9n 0.4537 244750.0n 0.4537 244999.9n 0.4537 245000.0n 0.4537 245249.9n 0.4537 245250.0n 0.5074 245499.9n 0.5074 245500.0n 0.4537 245749.9n 0.4537 245750.0n 0.4537 245999.9n 0.4537 246000.0n 0.6016 246249.9n 0.6016 246250.0n 0.4940 246499.9n 0.4940 246500.0n 0.4537 246749.9n 0.4537 246750.0n 0.4806 246999.9n 0.4806 247000.0n 0.4671 247249.9n 0.4671 247250.0n 0.4806 247499.9n 0.4806 247500.0n 0.5881 247749.9n 0.5881 247750.0n 0.4537 247999.9n 0.4537 248000.0n 0.6016 248249.9n 0.6016 248250.0n 0.4537 248499.9n 0.4537 248500.0n 0.4537 248749.9n 0.4537 248750.0n 0.4537 248999.9n 0.4537 249000.0n 0.4806 249249.9n 0.4806 249250.0n 0.5881 249499.9n 0.5881 249500.0n 0.4537 249749.9n 0.4537 249750.0n 0.4537 249999.9n 0.4537 250000.0n 0.4537 250249.9n 0.4537 250250.0n 0.4537 250499.9n 0.4537 250500.0n 0.6688 250749.9n 0.6688 250750.0n 0.4537 250999.9n 0.4537 251000.0n 0.4537 251249.9n 0.4537 251250.0n 0.4537 251499.9n 0.4537 251500.0n 0.4671 251749.9n 0.4671 251750.0n 0.4806 251999.9n 0.4806 252000.0n 0.4537 252249.9n 0.4537 252250.0n 0.4537 252499.9n 0.4537 252500.0n 0.4537 252749.9n 0.4537 252750.0n 0.5074 252999.9n 0.5074 253000.0n 0.4537 253249.9n 0.4537 253250.0n 0.4537 253499.9n 0.4537 253500.0n 0.6016 253749.9n 0.6016 253750.0n 0.4940 253999.9n 0.4940 254000.0n 0.4537 254249.9n 0.4537 254250.0n 0.4806 254499.9n 0.4806 254500.0n 0.4671 254749.9n 0.4671 254750.0n 0.4806 254999.9n 0.4806 255000.0n 0.5881 255249.9n 0.5881 255250.0n 0.4537 255499.9n 0.4537 255500.0n 0.6016 255749.9n 0.6016 255750.0n 0.4537 255999.9n 0.4537 256000.0n 0.4537 256249.9n 0.4537 256250.0n 0.4537 256499.9n 0.4537 256500.0n 0.4806 256749.9n 0.4806 256750.0n 0.5881 256999.9n 0.5881 257000.0n 0.4537 257249.9n 0.4537 257250.0n 0.4537 257499.9n 0.4537 257500.0n 0.4537 257749.9n 0.4537 257750.0n 0.4537 257999.9n 0.4537 258000.0n 0.6688 258249.9n 0.6688 258250.0n 0.4537 258499.9n 0.4537 258500.0n 0.4537 258749.9n 0.4537 258750.0n 0.4537 258999.9n 0.4537 259000.0n 0.4671 259249.9n 0.4671 259250.0n 0.4806 259499.9n 0.4806 259500.0n 0.4537 259749.9n 0.4537 259750.0n 0.4537 259999.9n 0.4537 260000.0n 0.4537 260249.9n 0.4537 260250.0n 0.5074 260499.9n 0.5074 260500.0n 0.4537 260749.9n 0.4537 260750.0n 0.4537 260999.9n 0.4537 261000.0n 0.6016 261249.9n 0.6016 261250.0n 0.4940 261499.9n 0.4940 261500.0n 0.4537 261749.9n 0.4537 261750.0n 0.4806 261999.9n 0.4806 262000.0n 0.4671 262249.9n 0.4671 262250.0n 0.4806 262499.9n 0.4806 262500.0n 0.5881 262749.9n 0.5881 262750.0n 0.4537 262999.9n 0.4537 263000.0n 0.6016 263249.9n 0.6016 263250.0n 0.4537 263499.9n 0.4537 263500.0n 0.4537 263749.9n 0.4537 263750.0n 0.4537 263999.9n 0.4537 264000.0n 0.4806 264249.9n 0.4806 264250.0n 0.5881 264499.9n 0.5881 264500.0n 0.4537 264749.9n 0.4537 264750.0n 0.4537 264999.9n 0.4537 265000.0n 0.4537 265249.9n 0.4537 265250.0n 0.4537 265499.9n 0.4537 265500.0n 0.6688 265749.9n 0.6688 265750.0n 0.4537 265999.9n 0.4537 266000.0n 0.4537 266249.9n 0.4537 266250.0n 0.4537 266499.9n 0.4537 266500.0n 0.4671 266749.9n 0.4671 266750.0n 0.4806 266999.9n 0.4806 267000.0n 0.4537 267249.9n 0.4537 267250.0n 0.4537 267499.9n 0.4537 267500.0n 0.4537 267749.9n 0.4537 267750.0n 0.5074 267999.9n 0.5074 268000.0n 0.4537 268249.9n 0.4537 268250.0n 0.4537 268499.9n 0.4537 268500.0n 0.6016 268749.9n 0.6016 268750.0n 0.4940 268999.9n 0.4940 269000.0n 0.4537 269249.9n 0.4537 269250.0n 0.4806 269499.9n 0.4806 269500.0n 0.4671 269749.9n 0.4671 269750.0n 0.4806 269999.9n 0.4806 270000.0n 0.5881 270249.9n 0.5881 270250.0n 0.4537 270499.9n 0.4537 270500.0n 0.6016 270749.9n 0.6016 270750.0n 0.4537 270999.9n 0.4537 271000.0n 0.4537 271249.9n 0.4537 271250.0n 0.4537 271499.9n 0.4537 271500.0n 0.4806 271749.9n 0.4806 271750.0n 0.5881 271999.9n 0.5881 272000.0n 0.4537 272249.9n 0.4537 272250.0n 0.4537 272499.9n 0.4537 272500.0n 0.4537 272749.9n 0.4537 272750.0n 0.4537 272999.9n 0.4537 273000.0n 0.6688 273249.9n 0.6688 273250.0n 0.4537 273499.9n 0.4537 273500.0n 0.4537 273749.9n 0.4537 273750.0n 0.4537 273999.9n 0.4537 274000.0n 0.4671 274249.9n 0.4671 274250.0n 0.4806 274499.9n 0.4806 274500.0n 0.4537 274749.9n 0.4537 274750.0n 0.4537 274999.9n 0.4537 275000.0n 0.4537 275249.9n 0.4537 275250.0n 0.5074 275499.9n 0.5074 275500.0n 0.4537 275749.9n 0.4537 275750.0n 0.4537 275999.9n 0.4537 276000.0n 0.6016 276249.9n 0.6016 276250.0n 0.4940 276499.9n 0.4940 276500.0n 0.4537 276749.9n 0.4537 276750.0n 0.4806 276999.9n 0.4806 277000.0n 0.4671 277249.9n 0.4671 277250.0n 0.4806 277499.9n 0.4806 277500.0n 0.5881 277749.9n 0.5881 277750.0n 0.4537 277999.9n 0.4537 278000.0n 0.6016 278249.9n 0.6016 278250.0n 0.4537 278499.9n 0.4537 278500.0n 0.4537 278749.9n 0.4537 278750.0n 0.4537 278999.9n 0.4537 279000.0n 0.4806 279249.9n 0.4806 279250.0n 0.5881 279499.9n 0.5881 279500.0n 0.4537 279749.9n 0.4537 279750.0n 0.4537 279999.9n 0.4537 280000.0n 0.4537 280249.9n 0.4537 280250.0n 0.4537 280499.9n 0.4537 280500.0n 0.6688 280749.9n 0.6688 280750.0n 0.4537 280999.9n 0.4537 281000.0n 0.4537 281249.9n 0.4537 281250.0n 0.4537 281499.9n 0.4537 281500.0n 0.4671 281749.9n 0.4671 281750.0n 0.4806 281999.9n 0.4806 282000.0n 0.4537 282249.9n 0.4537 282250.0n 0.4537 282499.9n 0.4537 282500.0n 0.4537 282749.9n 0.4537 282750.0n 0.5074 282999.9n 0.5074 283000.0n 0.4537 283249.9n 0.4537 283250.0n 0.4537 283499.9n 0.4537 283500.0n 0.6016 283749.9n 0.6016 283750.0n 0.4940 283999.9n 0.4940 284000.0n 0.4537 284249.9n 0.4537 284250.0n 0.4806 284499.9n 0.4806 284500.0n 0.4671 284749.9n 0.4671 284750.0n 0.4806 284999.9n 0.4806 285000.0n 0.5881 285249.9n 0.5881 285250.0n 0.4537 285499.9n 0.4537 285500.0n 0.6016 285749.9n 0.6016 285750.0n 0.4537 285999.9n 0.4537 286000.0n 0.4537 286249.9n 0.4537 286250.0n 0.4537 286499.9n 0.4537 286500.0n 0.4806 286749.9n 0.4806 286750.0n 0.5881 286999.9n 0.5881 287000.0n 0.4537 287249.9n 0.4537 287250.0n 0.4537 287499.9n 0.4537 287500.0n 0.4537 287749.9n 0.4537 287750.0n 0.4537 287999.9n 0.4537 288000.0n 0.6688 288249.9n 0.6688 288250.0n 0.4537 288499.9n 0.4537 288500.0n 0.4537 288749.9n 0.4537 288750.0n 0.4537 288999.9n 0.4537 289000.0n 0.4671 289249.9n 0.4671 289250.0n 0.4806 289499.9n 0.4806 289500.0n 0.4537 289749.9n 0.4537 289750.0n 0.4537 289999.9n 0.4537 290000.0n 0.4537 290249.9n 0.4537 290250.0n 0.5074 290499.9n 0.5074 290500.0n 0.4537 290749.9n 0.4537 290750.0n 0.4537 290999.9n 0.4537 291000.0n 0.6016 291249.9n 0.6016 291250.0n 0.4940 291499.9n 0.4940 291500.0n 0.4537 291749.9n 0.4537 291750.0n 0.4806 291999.9n 0.4806 292000.0n 0.4671 292249.9n 0.4671 292250.0n 0.4806 292499.9n 0.4806 292500.0n 0.5881 292749.9n 0.5881 292750.0n 0.4537 292999.9n 0.4537 293000.0n 0.6016 293249.9n 0.6016 293250.0n 0.4537 293499.9n 0.4537 293500.0n 0.4537 293749.9n 0.4537 293750.0n 0.4537 293999.9n 0.4537 294000.0n 0.4806 294249.9n 0.4806 294250.0n 0.5881 294499.9n 0.5881 294500.0n 0.4537 294749.9n 0.4537 294750.0n 0.4537 294999.9n 0.4537 295000.0n 0.4537 295249.9n 0.4537 295250.0n 0.4537 295499.9n 0.4537 295500.0n 0.6688 295749.9n 0.6688 295750.0n 0.4537 295999.9n 0.4537 296000.0n 0.4537 296249.9n 0.4537 296250.0n 0.4537 296499.9n 0.4537 296500.0n 0.4671 296749.9n 0.4671 296750.0n 0.4806 296999.9n 0.4806 297000.0n 0.4537 297249.9n 0.4537 297250.0n 0.4537 297499.9n 0.4537 297500.0n 0.4537 297749.9n 0.4537 297750.0n 0.5074 297999.9n 0.5074 298000.0n 0.4537 298249.9n 0.4537 298250.0n 0.4537 298499.9n 0.4537 298500.0n 0.6016 298749.9n 0.6016 298750.0n 0.4940 298999.9n 0.4940 299000.0n 0.4537 299249.9n 0.4537 299250.0n 0.4806 299499.9n 0.4806 299500.0n 0.4671 299749.9n 0.4671 299750.0n 0.4806)
Vxn3 a_xn3 0 PWL(0.0n 0.4119 249.9n 0.4119 250.0n 0.5463 499.9n 0.5463 500.0n 0.3984 749.9n 0.3984 750.0n 0.5463 999.9n 0.5463 1000.0n 0.5463 1249.9n 0.5463 1250.0n 0.5463 1499.9n 0.5463 1500.0n 0.5194 1749.9n 0.5194 1750.0n 0.4119 1999.9n 0.4119 2000.0n 0.5463 2249.9n 0.5463 2250.0n 0.5463 2499.9n 0.5463 2500.0n 0.5463 2749.9n 0.5463 2750.0n 0.5463 2999.9n 0.5463 3000.0n 0.3312 3249.9n 0.3312 3250.0n 0.5463 3499.9n 0.5463 3500.0n 0.5463 3749.9n 0.5463 3750.0n 0.5463 3999.9n 0.5463 4000.0n 0.5329 4249.9n 0.5329 4250.0n 0.5194 4499.9n 0.5194 4500.0n 0.5463 4749.9n 0.5463 4750.0n 0.5463 4999.9n 0.5463 5000.0n 0.5463 5249.9n 0.5463 5250.0n 0.4926 5499.9n 0.4926 5500.0n 0.5463 5749.9n 0.5463 5750.0n 0.5463 5999.9n 0.5463 6000.0n 0.3984 6249.9n 0.3984 6250.0n 0.5060 6499.9n 0.5060 6500.0n 0.5463 6749.9n 0.5463 6750.0n 0.5194 6999.9n 0.5194 7000.0n 0.5329 7249.9n 0.5329 7250.0n 0.5194 7499.9n 0.5194 7500.0n 0.4119 7749.9n 0.4119 7750.0n 0.5463 7999.9n 0.5463 8000.0n 0.3984 8249.9n 0.3984 8250.0n 0.5463 8499.9n 0.5463 8500.0n 0.5463 8749.9n 0.5463 8750.0n 0.5463 8999.9n 0.5463 9000.0n 0.5194 9249.9n 0.5194 9250.0n 0.4119 9499.9n 0.4119 9500.0n 0.5463 9749.9n 0.5463 9750.0n 0.5463 9999.9n 0.5463 10000.0n 0.5463 10249.9n 0.5463 10250.0n 0.5463 10499.9n 0.5463 10500.0n 0.3312 10749.9n 0.3312 10750.0n 0.5463 10999.9n 0.5463 11000.0n 0.5463 11249.9n 0.5463 11250.0n 0.5463 11499.9n 0.5463 11500.0n 0.5329 11749.9n 0.5329 11750.0n 0.5194 11999.9n 0.5194 12000.0n 0.5463 12249.9n 0.5463 12250.0n 0.5463 12499.9n 0.5463 12500.0n 0.5463 12749.9n 0.5463 12750.0n 0.4926 12999.9n 0.4926 13000.0n 0.5463 13249.9n 0.5463 13250.0n 0.5463 13499.9n 0.5463 13500.0n 0.3984 13749.9n 0.3984 13750.0n 0.5060 13999.9n 0.5060 14000.0n 0.5463 14249.9n 0.5463 14250.0n 0.5194 14499.9n 0.5194 14500.0n 0.5329 14749.9n 0.5329 14750.0n 0.5194 14999.9n 0.5194 15000.0n 0.4119 15249.9n 0.4119 15250.0n 0.5463 15499.9n 0.5463 15500.0n 0.3984 15749.9n 0.3984 15750.0n 0.5463 15999.9n 0.5463 16000.0n 0.5463 16249.9n 0.5463 16250.0n 0.5463 16499.9n 0.5463 16500.0n 0.5194 16749.9n 0.5194 16750.0n 0.4119 16999.9n 0.4119 17000.0n 0.5463 17249.9n 0.5463 17250.0n 0.5463 17499.9n 0.5463 17500.0n 0.5463 17749.9n 0.5463 17750.0n 0.5463 17999.9n 0.5463 18000.0n 0.3312 18249.9n 0.3312 18250.0n 0.5463 18499.9n 0.5463 18500.0n 0.5463 18749.9n 0.5463 18750.0n 0.5463 18999.9n 0.5463 19000.0n 0.5329 19249.9n 0.5329 19250.0n 0.5194 19499.9n 0.5194 19500.0n 0.5463 19749.9n 0.5463 19750.0n 0.5463 19999.9n 0.5463 20000.0n 0.5463 20249.9n 0.5463 20250.0n 0.4926 20499.9n 0.4926 20500.0n 0.5463 20749.9n 0.5463 20750.0n 0.5463 20999.9n 0.5463 21000.0n 0.3984 21249.9n 0.3984 21250.0n 0.5060 21499.9n 0.5060 21500.0n 0.5463 21749.9n 0.5463 21750.0n 0.5194 21999.9n 0.5194 22000.0n 0.5329 22249.9n 0.5329 22250.0n 0.5194 22499.9n 0.5194 22500.0n 0.4119 22749.9n 0.4119 22750.0n 0.5463 22999.9n 0.5463 23000.0n 0.3984 23249.9n 0.3984 23250.0n 0.5463 23499.9n 0.5463 23500.0n 0.5463 23749.9n 0.5463 23750.0n 0.5463 23999.9n 0.5463 24000.0n 0.5194 24249.9n 0.5194 24250.0n 0.4119 24499.9n 0.4119 24500.0n 0.5463 24749.9n 0.5463 24750.0n 0.5463 24999.9n 0.5463 25000.0n 0.5463 25249.9n 0.5463 25250.0n 0.5463 25499.9n 0.5463 25500.0n 0.3312 25749.9n 0.3312 25750.0n 0.5463 25999.9n 0.5463 26000.0n 0.5463 26249.9n 0.5463 26250.0n 0.5463 26499.9n 0.5463 26500.0n 0.5329 26749.9n 0.5329 26750.0n 0.5194 26999.9n 0.5194 27000.0n 0.5463 27249.9n 0.5463 27250.0n 0.5463 27499.9n 0.5463 27500.0n 0.5463 27749.9n 0.5463 27750.0n 0.4926 27999.9n 0.4926 28000.0n 0.5463 28249.9n 0.5463 28250.0n 0.5463 28499.9n 0.5463 28500.0n 0.3984 28749.9n 0.3984 28750.0n 0.5060 28999.9n 0.5060 29000.0n 0.5463 29249.9n 0.5463 29250.0n 0.5194 29499.9n 0.5194 29500.0n 0.5329 29749.9n 0.5329 29750.0n 0.5194 29999.9n 0.5194 30000.0n 0.4119 30249.9n 0.4119 30250.0n 0.5463 30499.9n 0.5463 30500.0n 0.3984 30749.9n 0.3984 30750.0n 0.5463 30999.9n 0.5463 31000.0n 0.5463 31249.9n 0.5463 31250.0n 0.5463 31499.9n 0.5463 31500.0n 0.5194 31749.9n 0.5194 31750.0n 0.4119 31999.9n 0.4119 32000.0n 0.5463 32249.9n 0.5463 32250.0n 0.5463 32499.9n 0.5463 32500.0n 0.5463 32749.9n 0.5463 32750.0n 0.5463 32999.9n 0.5463 33000.0n 0.3312 33249.9n 0.3312 33250.0n 0.5463 33499.9n 0.5463 33500.0n 0.5463 33749.9n 0.5463 33750.0n 0.5463 33999.9n 0.5463 34000.0n 0.5329 34249.9n 0.5329 34250.0n 0.5194 34499.9n 0.5194 34500.0n 0.5463 34749.9n 0.5463 34750.0n 0.5463 34999.9n 0.5463 35000.0n 0.5463 35249.9n 0.5463 35250.0n 0.4926 35499.9n 0.4926 35500.0n 0.5463 35749.9n 0.5463 35750.0n 0.5463 35999.9n 0.5463 36000.0n 0.3984 36249.9n 0.3984 36250.0n 0.5060 36499.9n 0.5060 36500.0n 0.5463 36749.9n 0.5463 36750.0n 0.5194 36999.9n 0.5194 37000.0n 0.5329 37249.9n 0.5329 37250.0n 0.5194 37499.9n 0.5194 37500.0n 0.4119 37749.9n 0.4119 37750.0n 0.5463 37999.9n 0.5463 38000.0n 0.3984 38249.9n 0.3984 38250.0n 0.5463 38499.9n 0.5463 38500.0n 0.5463 38749.9n 0.5463 38750.0n 0.5463 38999.9n 0.5463 39000.0n 0.5194 39249.9n 0.5194 39250.0n 0.4119 39499.9n 0.4119 39500.0n 0.5463 39749.9n 0.5463 39750.0n 0.5463 39999.9n 0.5463 40000.0n 0.5463 40249.9n 0.5463 40250.0n 0.5463 40499.9n 0.5463 40500.0n 0.3312 40749.9n 0.3312 40750.0n 0.5463 40999.9n 0.5463 41000.0n 0.5463 41249.9n 0.5463 41250.0n 0.5463 41499.9n 0.5463 41500.0n 0.5329 41749.9n 0.5329 41750.0n 0.5194 41999.9n 0.5194 42000.0n 0.5463 42249.9n 0.5463 42250.0n 0.5463 42499.9n 0.5463 42500.0n 0.5463 42749.9n 0.5463 42750.0n 0.4926 42999.9n 0.4926 43000.0n 0.5463 43249.9n 0.5463 43250.0n 0.5463 43499.9n 0.5463 43500.0n 0.3984 43749.9n 0.3984 43750.0n 0.5060 43999.9n 0.5060 44000.0n 0.5463 44249.9n 0.5463 44250.0n 0.5194 44499.9n 0.5194 44500.0n 0.5329 44749.9n 0.5329 44750.0n 0.5194 44999.9n 0.5194 45000.0n 0.4119 45249.9n 0.4119 45250.0n 0.5463 45499.9n 0.5463 45500.0n 0.3984 45749.9n 0.3984 45750.0n 0.5463 45999.9n 0.5463 46000.0n 0.5463 46249.9n 0.5463 46250.0n 0.5463 46499.9n 0.5463 46500.0n 0.5194 46749.9n 0.5194 46750.0n 0.4119 46999.9n 0.4119 47000.0n 0.5463 47249.9n 0.5463 47250.0n 0.5463 47499.9n 0.5463 47500.0n 0.5463 47749.9n 0.5463 47750.0n 0.5463 47999.9n 0.5463 48000.0n 0.3312 48249.9n 0.3312 48250.0n 0.5463 48499.9n 0.5463 48500.0n 0.5463 48749.9n 0.5463 48750.0n 0.5463 48999.9n 0.5463 49000.0n 0.5329 49249.9n 0.5329 49250.0n 0.5194 49499.9n 0.5194 49500.0n 0.5463 49749.9n 0.5463 49750.0n 0.5463 49999.9n 0.5463 50000.0n 0.5463 50249.9n 0.5463 50250.0n 0.4926 50499.9n 0.4926 50500.0n 0.5463 50749.9n 0.5463 50750.0n 0.5463 50999.9n 0.5463 51000.0n 0.3984 51249.9n 0.3984 51250.0n 0.5060 51499.9n 0.5060 51500.0n 0.5463 51749.9n 0.5463 51750.0n 0.5194 51999.9n 0.5194 52000.0n 0.5329 52249.9n 0.5329 52250.0n 0.5194 52499.9n 0.5194 52500.0n 0.4119 52749.9n 0.4119 52750.0n 0.5463 52999.9n 0.5463 53000.0n 0.3984 53249.9n 0.3984 53250.0n 0.5463 53499.9n 0.5463 53500.0n 0.5463 53749.9n 0.5463 53750.0n 0.5463 53999.9n 0.5463 54000.0n 0.5194 54249.9n 0.5194 54250.0n 0.4119 54499.9n 0.4119 54500.0n 0.5463 54749.9n 0.5463 54750.0n 0.5463 54999.9n 0.5463 55000.0n 0.5463 55249.9n 0.5463 55250.0n 0.5463 55499.9n 0.5463 55500.0n 0.3312 55749.9n 0.3312 55750.0n 0.5463 55999.9n 0.5463 56000.0n 0.5463 56249.9n 0.5463 56250.0n 0.5463 56499.9n 0.5463 56500.0n 0.5329 56749.9n 0.5329 56750.0n 0.5194 56999.9n 0.5194 57000.0n 0.5463 57249.9n 0.5463 57250.0n 0.5463 57499.9n 0.5463 57500.0n 0.5463 57749.9n 0.5463 57750.0n 0.4926 57999.9n 0.4926 58000.0n 0.5463 58249.9n 0.5463 58250.0n 0.5463 58499.9n 0.5463 58500.0n 0.3984 58749.9n 0.3984 58750.0n 0.5060 58999.9n 0.5060 59000.0n 0.5463 59249.9n 0.5463 59250.0n 0.5194 59499.9n 0.5194 59500.0n 0.5329 59749.9n 0.5329 59750.0n 0.5194 59999.9n 0.5194 60000.0n 0.4119 60249.9n 0.4119 60250.0n 0.5463 60499.9n 0.5463 60500.0n 0.3984 60749.9n 0.3984 60750.0n 0.5463 60999.9n 0.5463 61000.0n 0.5463 61249.9n 0.5463 61250.0n 0.5463 61499.9n 0.5463 61500.0n 0.5194 61749.9n 0.5194 61750.0n 0.4119 61999.9n 0.4119 62000.0n 0.5463 62249.9n 0.5463 62250.0n 0.5463 62499.9n 0.5463 62500.0n 0.5463 62749.9n 0.5463 62750.0n 0.5463 62999.9n 0.5463 63000.0n 0.3312 63249.9n 0.3312 63250.0n 0.5463 63499.9n 0.5463 63500.0n 0.5463 63749.9n 0.5463 63750.0n 0.5463 63999.9n 0.5463 64000.0n 0.5329 64249.9n 0.5329 64250.0n 0.5194 64499.9n 0.5194 64500.0n 0.5463 64749.9n 0.5463 64750.0n 0.5463 64999.9n 0.5463 65000.0n 0.5463 65249.9n 0.5463 65250.0n 0.4926 65499.9n 0.4926 65500.0n 0.5463 65749.9n 0.5463 65750.0n 0.5463 65999.9n 0.5463 66000.0n 0.3984 66249.9n 0.3984 66250.0n 0.5060 66499.9n 0.5060 66500.0n 0.5463 66749.9n 0.5463 66750.0n 0.5194 66999.9n 0.5194 67000.0n 0.5329 67249.9n 0.5329 67250.0n 0.5194 67499.9n 0.5194 67500.0n 0.4119 67749.9n 0.4119 67750.0n 0.5463 67999.9n 0.5463 68000.0n 0.3984 68249.9n 0.3984 68250.0n 0.5463 68499.9n 0.5463 68500.0n 0.5463 68749.9n 0.5463 68750.0n 0.5463 68999.9n 0.5463 69000.0n 0.5194 69249.9n 0.5194 69250.0n 0.4119 69499.9n 0.4119 69500.0n 0.5463 69749.9n 0.5463 69750.0n 0.5463 69999.9n 0.5463 70000.0n 0.5463 70249.9n 0.5463 70250.0n 0.5463 70499.9n 0.5463 70500.0n 0.3312 70749.9n 0.3312 70750.0n 0.5463 70999.9n 0.5463 71000.0n 0.5463 71249.9n 0.5463 71250.0n 0.5463 71499.9n 0.5463 71500.0n 0.5329 71749.9n 0.5329 71750.0n 0.5194 71999.9n 0.5194 72000.0n 0.5463 72249.9n 0.5463 72250.0n 0.5463 72499.9n 0.5463 72500.0n 0.5463 72749.9n 0.5463 72750.0n 0.4926 72999.9n 0.4926 73000.0n 0.5463 73249.9n 0.5463 73250.0n 0.5463 73499.9n 0.5463 73500.0n 0.3984 73749.9n 0.3984 73750.0n 0.5060 73999.9n 0.5060 74000.0n 0.5463 74249.9n 0.5463 74250.0n 0.5194 74499.9n 0.5194 74500.0n 0.5329 74749.9n 0.5329 74750.0n 0.5194 74999.9n 0.5194 75000.0n 0.4119 75249.9n 0.4119 75250.0n 0.5463 75499.9n 0.5463 75500.0n 0.3984 75749.9n 0.3984 75750.0n 0.5463 75999.9n 0.5463 76000.0n 0.5463 76249.9n 0.5463 76250.0n 0.5463 76499.9n 0.5463 76500.0n 0.5194 76749.9n 0.5194 76750.0n 0.4119 76999.9n 0.4119 77000.0n 0.5463 77249.9n 0.5463 77250.0n 0.5463 77499.9n 0.5463 77500.0n 0.5463 77749.9n 0.5463 77750.0n 0.5463 77999.9n 0.5463 78000.0n 0.3312 78249.9n 0.3312 78250.0n 0.5463 78499.9n 0.5463 78500.0n 0.5463 78749.9n 0.5463 78750.0n 0.5463 78999.9n 0.5463 79000.0n 0.5329 79249.9n 0.5329 79250.0n 0.5194 79499.9n 0.5194 79500.0n 0.5463 79749.9n 0.5463 79750.0n 0.5463 79999.9n 0.5463 80000.0n 0.5463 80249.9n 0.5463 80250.0n 0.4926 80499.9n 0.4926 80500.0n 0.5463 80749.9n 0.5463 80750.0n 0.5463 80999.9n 0.5463 81000.0n 0.3984 81249.9n 0.3984 81250.0n 0.5060 81499.9n 0.5060 81500.0n 0.5463 81749.9n 0.5463 81750.0n 0.5194 81999.9n 0.5194 82000.0n 0.5329 82249.9n 0.5329 82250.0n 0.5194 82499.9n 0.5194 82500.0n 0.4119 82749.9n 0.4119 82750.0n 0.5463 82999.9n 0.5463 83000.0n 0.3984 83249.9n 0.3984 83250.0n 0.5463 83499.9n 0.5463 83500.0n 0.5463 83749.9n 0.5463 83750.0n 0.5463 83999.9n 0.5463 84000.0n 0.5194 84249.9n 0.5194 84250.0n 0.4119 84499.9n 0.4119 84500.0n 0.5463 84749.9n 0.5463 84750.0n 0.5463 84999.9n 0.5463 85000.0n 0.5463 85249.9n 0.5463 85250.0n 0.5463 85499.9n 0.5463 85500.0n 0.3312 85749.9n 0.3312 85750.0n 0.5463 85999.9n 0.5463 86000.0n 0.5463 86249.9n 0.5463 86250.0n 0.5463 86499.9n 0.5463 86500.0n 0.5329 86749.9n 0.5329 86750.0n 0.5194 86999.9n 0.5194 87000.0n 0.5463 87249.9n 0.5463 87250.0n 0.5463 87499.9n 0.5463 87500.0n 0.5463 87749.9n 0.5463 87750.0n 0.4926 87999.9n 0.4926 88000.0n 0.5463 88249.9n 0.5463 88250.0n 0.5463 88499.9n 0.5463 88500.0n 0.3984 88749.9n 0.3984 88750.0n 0.5060 88999.9n 0.5060 89000.0n 0.5463 89249.9n 0.5463 89250.0n 0.5194 89499.9n 0.5194 89500.0n 0.5329 89749.9n 0.5329 89750.0n 0.5194 89999.9n 0.5194 90000.0n 0.4119 90249.9n 0.4119 90250.0n 0.5463 90499.9n 0.5463 90500.0n 0.3984 90749.9n 0.3984 90750.0n 0.5463 90999.9n 0.5463 91000.0n 0.5463 91249.9n 0.5463 91250.0n 0.5463 91499.9n 0.5463 91500.0n 0.5194 91749.9n 0.5194 91750.0n 0.4119 91999.9n 0.4119 92000.0n 0.5463 92249.9n 0.5463 92250.0n 0.5463 92499.9n 0.5463 92500.0n 0.5463 92749.9n 0.5463 92750.0n 0.5463 92999.9n 0.5463 93000.0n 0.3312 93249.9n 0.3312 93250.0n 0.5463 93499.9n 0.5463 93500.0n 0.5463 93749.9n 0.5463 93750.0n 0.5463 93999.9n 0.5463 94000.0n 0.5329 94249.9n 0.5329 94250.0n 0.5194 94499.9n 0.5194 94500.0n 0.5463 94749.9n 0.5463 94750.0n 0.5463 94999.9n 0.5463 95000.0n 0.5463 95249.9n 0.5463 95250.0n 0.4926 95499.9n 0.4926 95500.0n 0.5463 95749.9n 0.5463 95750.0n 0.5463 95999.9n 0.5463 96000.0n 0.3984 96249.9n 0.3984 96250.0n 0.5060 96499.9n 0.5060 96500.0n 0.5463 96749.9n 0.5463 96750.0n 0.5194 96999.9n 0.5194 97000.0n 0.5329 97249.9n 0.5329 97250.0n 0.5194 97499.9n 0.5194 97500.0n 0.4119 97749.9n 0.4119 97750.0n 0.5463 97999.9n 0.5463 98000.0n 0.3984 98249.9n 0.3984 98250.0n 0.5463 98499.9n 0.5463 98500.0n 0.5463 98749.9n 0.5463 98750.0n 0.5463 98999.9n 0.5463 99000.0n 0.5194 99249.9n 0.5194 99250.0n 0.4119 99499.9n 0.4119 99500.0n 0.5463 99749.9n 0.5463 99750.0n 0.5463 99999.9n 0.5463 100000.0n 0.5463 100249.9n 0.5463 100250.0n 0.5463 100499.9n 0.5463 100500.0n 0.3312 100749.9n 0.3312 100750.0n 0.5463 100999.9n 0.5463 101000.0n 0.5463 101249.9n 0.5463 101250.0n 0.5463 101499.9n 0.5463 101500.0n 0.5329 101749.9n 0.5329 101750.0n 0.5194 101999.9n 0.5194 102000.0n 0.5463 102249.9n 0.5463 102250.0n 0.5463 102499.9n 0.5463 102500.0n 0.5463 102749.9n 0.5463 102750.0n 0.4926 102999.9n 0.4926 103000.0n 0.5463 103249.9n 0.5463 103250.0n 0.5463 103499.9n 0.5463 103500.0n 0.3984 103749.9n 0.3984 103750.0n 0.5060 103999.9n 0.5060 104000.0n 0.5463 104249.9n 0.5463 104250.0n 0.5194 104499.9n 0.5194 104500.0n 0.5329 104749.9n 0.5329 104750.0n 0.5194 104999.9n 0.5194 105000.0n 0.4119 105249.9n 0.4119 105250.0n 0.5463 105499.9n 0.5463 105500.0n 0.3984 105749.9n 0.3984 105750.0n 0.5463 105999.9n 0.5463 106000.0n 0.5463 106249.9n 0.5463 106250.0n 0.5463 106499.9n 0.5463 106500.0n 0.5194 106749.9n 0.5194 106750.0n 0.4119 106999.9n 0.4119 107000.0n 0.5463 107249.9n 0.5463 107250.0n 0.5463 107499.9n 0.5463 107500.0n 0.5463 107749.9n 0.5463 107750.0n 0.5463 107999.9n 0.5463 108000.0n 0.3312 108249.9n 0.3312 108250.0n 0.5463 108499.9n 0.5463 108500.0n 0.5463 108749.9n 0.5463 108750.0n 0.5463 108999.9n 0.5463 109000.0n 0.5329 109249.9n 0.5329 109250.0n 0.5194 109499.9n 0.5194 109500.0n 0.5463 109749.9n 0.5463 109750.0n 0.5463 109999.9n 0.5463 110000.0n 0.5463 110249.9n 0.5463 110250.0n 0.4926 110499.9n 0.4926 110500.0n 0.5463 110749.9n 0.5463 110750.0n 0.5463 110999.9n 0.5463 111000.0n 0.3984 111249.9n 0.3984 111250.0n 0.5060 111499.9n 0.5060 111500.0n 0.5463 111749.9n 0.5463 111750.0n 0.5194 111999.9n 0.5194 112000.0n 0.5329 112249.9n 0.5329 112250.0n 0.5194 112499.9n 0.5194 112500.0n 0.4119 112749.9n 0.4119 112750.0n 0.5463 112999.9n 0.5463 113000.0n 0.3984 113249.9n 0.3984 113250.0n 0.5463 113499.9n 0.5463 113500.0n 0.5463 113749.9n 0.5463 113750.0n 0.5463 113999.9n 0.5463 114000.0n 0.5194 114249.9n 0.5194 114250.0n 0.4119 114499.9n 0.4119 114500.0n 0.5463 114749.9n 0.5463 114750.0n 0.5463 114999.9n 0.5463 115000.0n 0.5463 115249.9n 0.5463 115250.0n 0.5463 115499.9n 0.5463 115500.0n 0.3312 115749.9n 0.3312 115750.0n 0.5463 115999.9n 0.5463 116000.0n 0.5463 116249.9n 0.5463 116250.0n 0.5463 116499.9n 0.5463 116500.0n 0.5329 116749.9n 0.5329 116750.0n 0.5194 116999.9n 0.5194 117000.0n 0.5463 117249.9n 0.5463 117250.0n 0.5463 117499.9n 0.5463 117500.0n 0.5463 117749.9n 0.5463 117750.0n 0.4926 117999.9n 0.4926 118000.0n 0.5463 118249.9n 0.5463 118250.0n 0.5463 118499.9n 0.5463 118500.0n 0.3984 118749.9n 0.3984 118750.0n 0.5060 118999.9n 0.5060 119000.0n 0.5463 119249.9n 0.5463 119250.0n 0.5194 119499.9n 0.5194 119500.0n 0.5329 119749.9n 0.5329 119750.0n 0.5194 119999.9n 0.5194 120000.0n 0.4119 120249.9n 0.4119 120250.0n 0.5463 120499.9n 0.5463 120500.0n 0.3984 120749.9n 0.3984 120750.0n 0.5463 120999.9n 0.5463 121000.0n 0.5463 121249.9n 0.5463 121250.0n 0.5463 121499.9n 0.5463 121500.0n 0.5194 121749.9n 0.5194 121750.0n 0.4119 121999.9n 0.4119 122000.0n 0.5463 122249.9n 0.5463 122250.0n 0.5463 122499.9n 0.5463 122500.0n 0.5463 122749.9n 0.5463 122750.0n 0.5463 122999.9n 0.5463 123000.0n 0.3312 123249.9n 0.3312 123250.0n 0.5463 123499.9n 0.5463 123500.0n 0.5463 123749.9n 0.5463 123750.0n 0.5463 123999.9n 0.5463 124000.0n 0.5329 124249.9n 0.5329 124250.0n 0.5194 124499.9n 0.5194 124500.0n 0.5463 124749.9n 0.5463 124750.0n 0.5463 124999.9n 0.5463 125000.0n 0.5463 125249.9n 0.5463 125250.0n 0.4926 125499.9n 0.4926 125500.0n 0.5463 125749.9n 0.5463 125750.0n 0.5463 125999.9n 0.5463 126000.0n 0.3984 126249.9n 0.3984 126250.0n 0.5060 126499.9n 0.5060 126500.0n 0.5463 126749.9n 0.5463 126750.0n 0.5194 126999.9n 0.5194 127000.0n 0.5329 127249.9n 0.5329 127250.0n 0.5194 127499.9n 0.5194 127500.0n 0.4119 127749.9n 0.4119 127750.0n 0.5463 127999.9n 0.5463 128000.0n 0.3984 128249.9n 0.3984 128250.0n 0.5463 128499.9n 0.5463 128500.0n 0.5463 128749.9n 0.5463 128750.0n 0.5463 128999.9n 0.5463 129000.0n 0.5194 129249.9n 0.5194 129250.0n 0.4119 129499.9n 0.4119 129500.0n 0.5463 129749.9n 0.5463 129750.0n 0.5463 129999.9n 0.5463 130000.0n 0.5463 130249.9n 0.5463 130250.0n 0.5463 130499.9n 0.5463 130500.0n 0.3312 130749.9n 0.3312 130750.0n 0.5463 130999.9n 0.5463 131000.0n 0.5463 131249.9n 0.5463 131250.0n 0.5463 131499.9n 0.5463 131500.0n 0.5329 131749.9n 0.5329 131750.0n 0.5194 131999.9n 0.5194 132000.0n 0.5463 132249.9n 0.5463 132250.0n 0.5463 132499.9n 0.5463 132500.0n 0.5463 132749.9n 0.5463 132750.0n 0.4926 132999.9n 0.4926 133000.0n 0.5463 133249.9n 0.5463 133250.0n 0.5463 133499.9n 0.5463 133500.0n 0.3984 133749.9n 0.3984 133750.0n 0.5060 133999.9n 0.5060 134000.0n 0.5463 134249.9n 0.5463 134250.0n 0.5194 134499.9n 0.5194 134500.0n 0.5329 134749.9n 0.5329 134750.0n 0.5194 134999.9n 0.5194 135000.0n 0.4119 135249.9n 0.4119 135250.0n 0.5463 135499.9n 0.5463 135500.0n 0.3984 135749.9n 0.3984 135750.0n 0.5463 135999.9n 0.5463 136000.0n 0.5463 136249.9n 0.5463 136250.0n 0.5463 136499.9n 0.5463 136500.0n 0.5194 136749.9n 0.5194 136750.0n 0.4119 136999.9n 0.4119 137000.0n 0.5463 137249.9n 0.5463 137250.0n 0.5463 137499.9n 0.5463 137500.0n 0.5463 137749.9n 0.5463 137750.0n 0.5463 137999.9n 0.5463 138000.0n 0.3312 138249.9n 0.3312 138250.0n 0.5463 138499.9n 0.5463 138500.0n 0.5463 138749.9n 0.5463 138750.0n 0.5463 138999.9n 0.5463 139000.0n 0.5329 139249.9n 0.5329 139250.0n 0.5194 139499.9n 0.5194 139500.0n 0.5463 139749.9n 0.5463 139750.0n 0.5463 139999.9n 0.5463 140000.0n 0.5463 140249.9n 0.5463 140250.0n 0.4926 140499.9n 0.4926 140500.0n 0.5463 140749.9n 0.5463 140750.0n 0.5463 140999.9n 0.5463 141000.0n 0.3984 141249.9n 0.3984 141250.0n 0.5060 141499.9n 0.5060 141500.0n 0.5463 141749.9n 0.5463 141750.0n 0.5194 141999.9n 0.5194 142000.0n 0.5329 142249.9n 0.5329 142250.0n 0.5194 142499.9n 0.5194 142500.0n 0.4119 142749.9n 0.4119 142750.0n 0.5463 142999.9n 0.5463 143000.0n 0.3984 143249.9n 0.3984 143250.0n 0.5463 143499.9n 0.5463 143500.0n 0.5463 143749.9n 0.5463 143750.0n 0.5463 143999.9n 0.5463 144000.0n 0.5194 144249.9n 0.5194 144250.0n 0.4119 144499.9n 0.4119 144500.0n 0.5463 144749.9n 0.5463 144750.0n 0.5463 144999.9n 0.5463 145000.0n 0.5463 145249.9n 0.5463 145250.0n 0.5463 145499.9n 0.5463 145500.0n 0.3312 145749.9n 0.3312 145750.0n 0.5463 145999.9n 0.5463 146000.0n 0.5463 146249.9n 0.5463 146250.0n 0.5463 146499.9n 0.5463 146500.0n 0.5329 146749.9n 0.5329 146750.0n 0.5194 146999.9n 0.5194 147000.0n 0.5463 147249.9n 0.5463 147250.0n 0.5463 147499.9n 0.5463 147500.0n 0.5463 147749.9n 0.5463 147750.0n 0.4926 147999.9n 0.4926 148000.0n 0.5463 148249.9n 0.5463 148250.0n 0.5463 148499.9n 0.5463 148500.0n 0.3984 148749.9n 0.3984 148750.0n 0.5060 148999.9n 0.5060 149000.0n 0.5463 149249.9n 0.5463 149250.0n 0.5194 149499.9n 0.5194 149500.0n 0.5329 149749.9n 0.5329 149750.0n 0.5194 149999.9n 0.5194 150000.0n 0.4119 150249.9n 0.4119 150250.0n 0.5463 150499.9n 0.5463 150500.0n 0.3984 150749.9n 0.3984 150750.0n 0.5463 150999.9n 0.5463 151000.0n 0.5463 151249.9n 0.5463 151250.0n 0.5463 151499.9n 0.5463 151500.0n 0.5194 151749.9n 0.5194 151750.0n 0.4119 151999.9n 0.4119 152000.0n 0.5463 152249.9n 0.5463 152250.0n 0.5463 152499.9n 0.5463 152500.0n 0.5463 152749.9n 0.5463 152750.0n 0.5463 152999.9n 0.5463 153000.0n 0.3312 153249.9n 0.3312 153250.0n 0.5463 153499.9n 0.5463 153500.0n 0.5463 153749.9n 0.5463 153750.0n 0.5463 153999.9n 0.5463 154000.0n 0.5329 154249.9n 0.5329 154250.0n 0.5194 154499.9n 0.5194 154500.0n 0.5463 154749.9n 0.5463 154750.0n 0.5463 154999.9n 0.5463 155000.0n 0.5463 155249.9n 0.5463 155250.0n 0.4926 155499.9n 0.4926 155500.0n 0.5463 155749.9n 0.5463 155750.0n 0.5463 155999.9n 0.5463 156000.0n 0.3984 156249.9n 0.3984 156250.0n 0.5060 156499.9n 0.5060 156500.0n 0.5463 156749.9n 0.5463 156750.0n 0.5194 156999.9n 0.5194 157000.0n 0.5329 157249.9n 0.5329 157250.0n 0.5194 157499.9n 0.5194 157500.0n 0.4119 157749.9n 0.4119 157750.0n 0.5463 157999.9n 0.5463 158000.0n 0.3984 158249.9n 0.3984 158250.0n 0.5463 158499.9n 0.5463 158500.0n 0.5463 158749.9n 0.5463 158750.0n 0.5463 158999.9n 0.5463 159000.0n 0.5194 159249.9n 0.5194 159250.0n 0.4119 159499.9n 0.4119 159500.0n 0.5463 159749.9n 0.5463 159750.0n 0.5463 159999.9n 0.5463 160000.0n 0.5463 160249.9n 0.5463 160250.0n 0.5463 160499.9n 0.5463 160500.0n 0.3312 160749.9n 0.3312 160750.0n 0.5463 160999.9n 0.5463 161000.0n 0.5463 161249.9n 0.5463 161250.0n 0.5463 161499.9n 0.5463 161500.0n 0.5329 161749.9n 0.5329 161750.0n 0.5194 161999.9n 0.5194 162000.0n 0.5463 162249.9n 0.5463 162250.0n 0.5463 162499.9n 0.5463 162500.0n 0.5463 162749.9n 0.5463 162750.0n 0.4926 162999.9n 0.4926 163000.0n 0.5463 163249.9n 0.5463 163250.0n 0.5463 163499.9n 0.5463 163500.0n 0.3984 163749.9n 0.3984 163750.0n 0.5060 163999.9n 0.5060 164000.0n 0.5463 164249.9n 0.5463 164250.0n 0.5194 164499.9n 0.5194 164500.0n 0.5329 164749.9n 0.5329 164750.0n 0.5194 164999.9n 0.5194 165000.0n 0.4119 165249.9n 0.4119 165250.0n 0.5463 165499.9n 0.5463 165500.0n 0.3984 165749.9n 0.3984 165750.0n 0.5463 165999.9n 0.5463 166000.0n 0.5463 166249.9n 0.5463 166250.0n 0.5463 166499.9n 0.5463 166500.0n 0.5194 166749.9n 0.5194 166750.0n 0.4119 166999.9n 0.4119 167000.0n 0.5463 167249.9n 0.5463 167250.0n 0.5463 167499.9n 0.5463 167500.0n 0.5463 167749.9n 0.5463 167750.0n 0.5463 167999.9n 0.5463 168000.0n 0.3312 168249.9n 0.3312 168250.0n 0.5463 168499.9n 0.5463 168500.0n 0.5463 168749.9n 0.5463 168750.0n 0.5463 168999.9n 0.5463 169000.0n 0.5329 169249.9n 0.5329 169250.0n 0.5194 169499.9n 0.5194 169500.0n 0.5463 169749.9n 0.5463 169750.0n 0.5463 169999.9n 0.5463 170000.0n 0.5463 170249.9n 0.5463 170250.0n 0.4926 170499.9n 0.4926 170500.0n 0.5463 170749.9n 0.5463 170750.0n 0.5463 170999.9n 0.5463 171000.0n 0.3984 171249.9n 0.3984 171250.0n 0.5060 171499.9n 0.5060 171500.0n 0.5463 171749.9n 0.5463 171750.0n 0.5194 171999.9n 0.5194 172000.0n 0.5329 172249.9n 0.5329 172250.0n 0.5194 172499.9n 0.5194 172500.0n 0.4119 172749.9n 0.4119 172750.0n 0.5463 172999.9n 0.5463 173000.0n 0.3984 173249.9n 0.3984 173250.0n 0.5463 173499.9n 0.5463 173500.0n 0.5463 173749.9n 0.5463 173750.0n 0.5463 173999.9n 0.5463 174000.0n 0.5194 174249.9n 0.5194 174250.0n 0.4119 174499.9n 0.4119 174500.0n 0.5463 174749.9n 0.5463 174750.0n 0.5463 174999.9n 0.5463 175000.0n 0.5463 175249.9n 0.5463 175250.0n 0.5463 175499.9n 0.5463 175500.0n 0.3312 175749.9n 0.3312 175750.0n 0.5463 175999.9n 0.5463 176000.0n 0.5463 176249.9n 0.5463 176250.0n 0.5463 176499.9n 0.5463 176500.0n 0.5329 176749.9n 0.5329 176750.0n 0.5194 176999.9n 0.5194 177000.0n 0.5463 177249.9n 0.5463 177250.0n 0.5463 177499.9n 0.5463 177500.0n 0.5463 177749.9n 0.5463 177750.0n 0.4926 177999.9n 0.4926 178000.0n 0.5463 178249.9n 0.5463 178250.0n 0.5463 178499.9n 0.5463 178500.0n 0.3984 178749.9n 0.3984 178750.0n 0.5060 178999.9n 0.5060 179000.0n 0.5463 179249.9n 0.5463 179250.0n 0.5194 179499.9n 0.5194 179500.0n 0.5329 179749.9n 0.5329 179750.0n 0.5194 179999.9n 0.5194 180000.0n 0.4119 180249.9n 0.4119 180250.0n 0.5463 180499.9n 0.5463 180500.0n 0.3984 180749.9n 0.3984 180750.0n 0.5463 180999.9n 0.5463 181000.0n 0.5463 181249.9n 0.5463 181250.0n 0.5463 181499.9n 0.5463 181500.0n 0.5194 181749.9n 0.5194 181750.0n 0.4119 181999.9n 0.4119 182000.0n 0.5463 182249.9n 0.5463 182250.0n 0.5463 182499.9n 0.5463 182500.0n 0.5463 182749.9n 0.5463 182750.0n 0.5463 182999.9n 0.5463 183000.0n 0.3312 183249.9n 0.3312 183250.0n 0.5463 183499.9n 0.5463 183500.0n 0.5463 183749.9n 0.5463 183750.0n 0.5463 183999.9n 0.5463 184000.0n 0.5329 184249.9n 0.5329 184250.0n 0.5194 184499.9n 0.5194 184500.0n 0.5463 184749.9n 0.5463 184750.0n 0.5463 184999.9n 0.5463 185000.0n 0.5463 185249.9n 0.5463 185250.0n 0.4926 185499.9n 0.4926 185500.0n 0.5463 185749.9n 0.5463 185750.0n 0.5463 185999.9n 0.5463 186000.0n 0.3984 186249.9n 0.3984 186250.0n 0.5060 186499.9n 0.5060 186500.0n 0.5463 186749.9n 0.5463 186750.0n 0.5194 186999.9n 0.5194 187000.0n 0.5329 187249.9n 0.5329 187250.0n 0.5194 187499.9n 0.5194 187500.0n 0.4119 187749.9n 0.4119 187750.0n 0.5463 187999.9n 0.5463 188000.0n 0.3984 188249.9n 0.3984 188250.0n 0.5463 188499.9n 0.5463 188500.0n 0.5463 188749.9n 0.5463 188750.0n 0.5463 188999.9n 0.5463 189000.0n 0.5194 189249.9n 0.5194 189250.0n 0.4119 189499.9n 0.4119 189500.0n 0.5463 189749.9n 0.5463 189750.0n 0.5463 189999.9n 0.5463 190000.0n 0.5463 190249.9n 0.5463 190250.0n 0.5463 190499.9n 0.5463 190500.0n 0.3312 190749.9n 0.3312 190750.0n 0.5463 190999.9n 0.5463 191000.0n 0.5463 191249.9n 0.5463 191250.0n 0.5463 191499.9n 0.5463 191500.0n 0.5329 191749.9n 0.5329 191750.0n 0.5194 191999.9n 0.5194 192000.0n 0.5463 192249.9n 0.5463 192250.0n 0.5463 192499.9n 0.5463 192500.0n 0.5463 192749.9n 0.5463 192750.0n 0.4926 192999.9n 0.4926 193000.0n 0.5463 193249.9n 0.5463 193250.0n 0.5463 193499.9n 0.5463 193500.0n 0.3984 193749.9n 0.3984 193750.0n 0.5060 193999.9n 0.5060 194000.0n 0.5463 194249.9n 0.5463 194250.0n 0.5194 194499.9n 0.5194 194500.0n 0.5329 194749.9n 0.5329 194750.0n 0.5194 194999.9n 0.5194 195000.0n 0.4119 195249.9n 0.4119 195250.0n 0.5463 195499.9n 0.5463 195500.0n 0.3984 195749.9n 0.3984 195750.0n 0.5463 195999.9n 0.5463 196000.0n 0.5463 196249.9n 0.5463 196250.0n 0.5463 196499.9n 0.5463 196500.0n 0.5194 196749.9n 0.5194 196750.0n 0.4119 196999.9n 0.4119 197000.0n 0.5463 197249.9n 0.5463 197250.0n 0.5463 197499.9n 0.5463 197500.0n 0.5463 197749.9n 0.5463 197750.0n 0.5463 197999.9n 0.5463 198000.0n 0.3312 198249.9n 0.3312 198250.0n 0.5463 198499.9n 0.5463 198500.0n 0.5463 198749.9n 0.5463 198750.0n 0.5463 198999.9n 0.5463 199000.0n 0.5329 199249.9n 0.5329 199250.0n 0.5194 199499.9n 0.5194 199500.0n 0.5463 199749.9n 0.5463 199750.0n 0.5463 199999.9n 0.5463 200000.0n 0.5463 200249.9n 0.5463 200250.0n 0.4926 200499.9n 0.4926 200500.0n 0.5463 200749.9n 0.5463 200750.0n 0.5463 200999.9n 0.5463 201000.0n 0.3984 201249.9n 0.3984 201250.0n 0.5060 201499.9n 0.5060 201500.0n 0.5463 201749.9n 0.5463 201750.0n 0.5194 201999.9n 0.5194 202000.0n 0.5329 202249.9n 0.5329 202250.0n 0.5194 202499.9n 0.5194 202500.0n 0.4119 202749.9n 0.4119 202750.0n 0.5463 202999.9n 0.5463 203000.0n 0.3984 203249.9n 0.3984 203250.0n 0.5463 203499.9n 0.5463 203500.0n 0.5463 203749.9n 0.5463 203750.0n 0.5463 203999.9n 0.5463 204000.0n 0.5194 204249.9n 0.5194 204250.0n 0.4119 204499.9n 0.4119 204500.0n 0.5463 204749.9n 0.5463 204750.0n 0.5463 204999.9n 0.5463 205000.0n 0.5463 205249.9n 0.5463 205250.0n 0.5463 205499.9n 0.5463 205500.0n 0.3312 205749.9n 0.3312 205750.0n 0.5463 205999.9n 0.5463 206000.0n 0.5463 206249.9n 0.5463 206250.0n 0.5463 206499.9n 0.5463 206500.0n 0.5329 206749.9n 0.5329 206750.0n 0.5194 206999.9n 0.5194 207000.0n 0.5463 207249.9n 0.5463 207250.0n 0.5463 207499.9n 0.5463 207500.0n 0.5463 207749.9n 0.5463 207750.0n 0.4926 207999.9n 0.4926 208000.0n 0.5463 208249.9n 0.5463 208250.0n 0.5463 208499.9n 0.5463 208500.0n 0.3984 208749.9n 0.3984 208750.0n 0.5060 208999.9n 0.5060 209000.0n 0.5463 209249.9n 0.5463 209250.0n 0.5194 209499.9n 0.5194 209500.0n 0.5329 209749.9n 0.5329 209750.0n 0.5194 209999.9n 0.5194 210000.0n 0.4119 210249.9n 0.4119 210250.0n 0.5463 210499.9n 0.5463 210500.0n 0.3984 210749.9n 0.3984 210750.0n 0.5463 210999.9n 0.5463 211000.0n 0.5463 211249.9n 0.5463 211250.0n 0.5463 211499.9n 0.5463 211500.0n 0.5194 211749.9n 0.5194 211750.0n 0.4119 211999.9n 0.4119 212000.0n 0.5463 212249.9n 0.5463 212250.0n 0.5463 212499.9n 0.5463 212500.0n 0.5463 212749.9n 0.5463 212750.0n 0.5463 212999.9n 0.5463 213000.0n 0.3312 213249.9n 0.3312 213250.0n 0.5463 213499.9n 0.5463 213500.0n 0.5463 213749.9n 0.5463 213750.0n 0.5463 213999.9n 0.5463 214000.0n 0.5329 214249.9n 0.5329 214250.0n 0.5194 214499.9n 0.5194 214500.0n 0.5463 214749.9n 0.5463 214750.0n 0.5463 214999.9n 0.5463 215000.0n 0.5463 215249.9n 0.5463 215250.0n 0.4926 215499.9n 0.4926 215500.0n 0.5463 215749.9n 0.5463 215750.0n 0.5463 215999.9n 0.5463 216000.0n 0.3984 216249.9n 0.3984 216250.0n 0.5060 216499.9n 0.5060 216500.0n 0.5463 216749.9n 0.5463 216750.0n 0.5194 216999.9n 0.5194 217000.0n 0.5329 217249.9n 0.5329 217250.0n 0.5194 217499.9n 0.5194 217500.0n 0.4119 217749.9n 0.4119 217750.0n 0.5463 217999.9n 0.5463 218000.0n 0.3984 218249.9n 0.3984 218250.0n 0.5463 218499.9n 0.5463 218500.0n 0.5463 218749.9n 0.5463 218750.0n 0.5463 218999.9n 0.5463 219000.0n 0.5194 219249.9n 0.5194 219250.0n 0.4119 219499.9n 0.4119 219500.0n 0.5463 219749.9n 0.5463 219750.0n 0.5463 219999.9n 0.5463 220000.0n 0.5463 220249.9n 0.5463 220250.0n 0.5463 220499.9n 0.5463 220500.0n 0.3312 220749.9n 0.3312 220750.0n 0.5463 220999.9n 0.5463 221000.0n 0.5463 221249.9n 0.5463 221250.0n 0.5463 221499.9n 0.5463 221500.0n 0.5329 221749.9n 0.5329 221750.0n 0.5194 221999.9n 0.5194 222000.0n 0.5463 222249.9n 0.5463 222250.0n 0.5463 222499.9n 0.5463 222500.0n 0.5463 222749.9n 0.5463 222750.0n 0.4926 222999.9n 0.4926 223000.0n 0.5463 223249.9n 0.5463 223250.0n 0.5463 223499.9n 0.5463 223500.0n 0.3984 223749.9n 0.3984 223750.0n 0.5060 223999.9n 0.5060 224000.0n 0.5463 224249.9n 0.5463 224250.0n 0.5194 224499.9n 0.5194 224500.0n 0.5329 224749.9n 0.5329 224750.0n 0.5194 224999.9n 0.5194 225000.0n 0.4119 225249.9n 0.4119 225250.0n 0.5463 225499.9n 0.5463 225500.0n 0.3984 225749.9n 0.3984 225750.0n 0.5463 225999.9n 0.5463 226000.0n 0.5463 226249.9n 0.5463 226250.0n 0.5463 226499.9n 0.5463 226500.0n 0.5194 226749.9n 0.5194 226750.0n 0.4119 226999.9n 0.4119 227000.0n 0.5463 227249.9n 0.5463 227250.0n 0.5463 227499.9n 0.5463 227500.0n 0.5463 227749.9n 0.5463 227750.0n 0.5463 227999.9n 0.5463 228000.0n 0.3312 228249.9n 0.3312 228250.0n 0.5463 228499.9n 0.5463 228500.0n 0.5463 228749.9n 0.5463 228750.0n 0.5463 228999.9n 0.5463 229000.0n 0.5329 229249.9n 0.5329 229250.0n 0.5194 229499.9n 0.5194 229500.0n 0.5463 229749.9n 0.5463 229750.0n 0.5463 229999.9n 0.5463 230000.0n 0.5463 230249.9n 0.5463 230250.0n 0.4926 230499.9n 0.4926 230500.0n 0.5463 230749.9n 0.5463 230750.0n 0.5463 230999.9n 0.5463 231000.0n 0.3984 231249.9n 0.3984 231250.0n 0.5060 231499.9n 0.5060 231500.0n 0.5463 231749.9n 0.5463 231750.0n 0.5194 231999.9n 0.5194 232000.0n 0.5329 232249.9n 0.5329 232250.0n 0.5194 232499.9n 0.5194 232500.0n 0.4119 232749.9n 0.4119 232750.0n 0.5463 232999.9n 0.5463 233000.0n 0.3984 233249.9n 0.3984 233250.0n 0.5463 233499.9n 0.5463 233500.0n 0.5463 233749.9n 0.5463 233750.0n 0.5463 233999.9n 0.5463 234000.0n 0.5194 234249.9n 0.5194 234250.0n 0.4119 234499.9n 0.4119 234500.0n 0.5463 234749.9n 0.5463 234750.0n 0.5463 234999.9n 0.5463 235000.0n 0.5463 235249.9n 0.5463 235250.0n 0.5463 235499.9n 0.5463 235500.0n 0.3312 235749.9n 0.3312 235750.0n 0.5463 235999.9n 0.5463 236000.0n 0.5463 236249.9n 0.5463 236250.0n 0.5463 236499.9n 0.5463 236500.0n 0.5329 236749.9n 0.5329 236750.0n 0.5194 236999.9n 0.5194 237000.0n 0.5463 237249.9n 0.5463 237250.0n 0.5463 237499.9n 0.5463 237500.0n 0.5463 237749.9n 0.5463 237750.0n 0.4926 237999.9n 0.4926 238000.0n 0.5463 238249.9n 0.5463 238250.0n 0.5463 238499.9n 0.5463 238500.0n 0.3984 238749.9n 0.3984 238750.0n 0.5060 238999.9n 0.5060 239000.0n 0.5463 239249.9n 0.5463 239250.0n 0.5194 239499.9n 0.5194 239500.0n 0.5329 239749.9n 0.5329 239750.0n 0.5194 239999.9n 0.5194 240000.0n 0.4119 240249.9n 0.4119 240250.0n 0.5463 240499.9n 0.5463 240500.0n 0.3984 240749.9n 0.3984 240750.0n 0.5463 240999.9n 0.5463 241000.0n 0.5463 241249.9n 0.5463 241250.0n 0.5463 241499.9n 0.5463 241500.0n 0.5194 241749.9n 0.5194 241750.0n 0.4119 241999.9n 0.4119 242000.0n 0.5463 242249.9n 0.5463 242250.0n 0.5463 242499.9n 0.5463 242500.0n 0.5463 242749.9n 0.5463 242750.0n 0.5463 242999.9n 0.5463 243000.0n 0.3312 243249.9n 0.3312 243250.0n 0.5463 243499.9n 0.5463 243500.0n 0.5463 243749.9n 0.5463 243750.0n 0.5463 243999.9n 0.5463 244000.0n 0.5329 244249.9n 0.5329 244250.0n 0.5194 244499.9n 0.5194 244500.0n 0.5463 244749.9n 0.5463 244750.0n 0.5463 244999.9n 0.5463 245000.0n 0.5463 245249.9n 0.5463 245250.0n 0.4926 245499.9n 0.4926 245500.0n 0.5463 245749.9n 0.5463 245750.0n 0.5463 245999.9n 0.5463 246000.0n 0.3984 246249.9n 0.3984 246250.0n 0.5060 246499.9n 0.5060 246500.0n 0.5463 246749.9n 0.5463 246750.0n 0.5194 246999.9n 0.5194 247000.0n 0.5329 247249.9n 0.5329 247250.0n 0.5194 247499.9n 0.5194 247500.0n 0.4119 247749.9n 0.4119 247750.0n 0.5463 247999.9n 0.5463 248000.0n 0.3984 248249.9n 0.3984 248250.0n 0.5463 248499.9n 0.5463 248500.0n 0.5463 248749.9n 0.5463 248750.0n 0.5463 248999.9n 0.5463 249000.0n 0.5194 249249.9n 0.5194 249250.0n 0.4119 249499.9n 0.4119 249500.0n 0.5463 249749.9n 0.5463 249750.0n 0.5463 249999.9n 0.5463 250000.0n 0.5463 250249.9n 0.5463 250250.0n 0.5463 250499.9n 0.5463 250500.0n 0.3312 250749.9n 0.3312 250750.0n 0.5463 250999.9n 0.5463 251000.0n 0.5463 251249.9n 0.5463 251250.0n 0.5463 251499.9n 0.5463 251500.0n 0.5329 251749.9n 0.5329 251750.0n 0.5194 251999.9n 0.5194 252000.0n 0.5463 252249.9n 0.5463 252250.0n 0.5463 252499.9n 0.5463 252500.0n 0.5463 252749.9n 0.5463 252750.0n 0.4926 252999.9n 0.4926 253000.0n 0.5463 253249.9n 0.5463 253250.0n 0.5463 253499.9n 0.5463 253500.0n 0.3984 253749.9n 0.3984 253750.0n 0.5060 253999.9n 0.5060 254000.0n 0.5463 254249.9n 0.5463 254250.0n 0.5194 254499.9n 0.5194 254500.0n 0.5329 254749.9n 0.5329 254750.0n 0.5194 254999.9n 0.5194 255000.0n 0.4119 255249.9n 0.4119 255250.0n 0.5463 255499.9n 0.5463 255500.0n 0.3984 255749.9n 0.3984 255750.0n 0.5463 255999.9n 0.5463 256000.0n 0.5463 256249.9n 0.5463 256250.0n 0.5463 256499.9n 0.5463 256500.0n 0.5194 256749.9n 0.5194 256750.0n 0.4119 256999.9n 0.4119 257000.0n 0.5463 257249.9n 0.5463 257250.0n 0.5463 257499.9n 0.5463 257500.0n 0.5463 257749.9n 0.5463 257750.0n 0.5463 257999.9n 0.5463 258000.0n 0.3312 258249.9n 0.3312 258250.0n 0.5463 258499.9n 0.5463 258500.0n 0.5463 258749.9n 0.5463 258750.0n 0.5463 258999.9n 0.5463 259000.0n 0.5329 259249.9n 0.5329 259250.0n 0.5194 259499.9n 0.5194 259500.0n 0.5463 259749.9n 0.5463 259750.0n 0.5463 259999.9n 0.5463 260000.0n 0.5463 260249.9n 0.5463 260250.0n 0.4926 260499.9n 0.4926 260500.0n 0.5463 260749.9n 0.5463 260750.0n 0.5463 260999.9n 0.5463 261000.0n 0.3984 261249.9n 0.3984 261250.0n 0.5060 261499.9n 0.5060 261500.0n 0.5463 261749.9n 0.5463 261750.0n 0.5194 261999.9n 0.5194 262000.0n 0.5329 262249.9n 0.5329 262250.0n 0.5194 262499.9n 0.5194 262500.0n 0.4119 262749.9n 0.4119 262750.0n 0.5463 262999.9n 0.5463 263000.0n 0.3984 263249.9n 0.3984 263250.0n 0.5463 263499.9n 0.5463 263500.0n 0.5463 263749.9n 0.5463 263750.0n 0.5463 263999.9n 0.5463 264000.0n 0.5194 264249.9n 0.5194 264250.0n 0.4119 264499.9n 0.4119 264500.0n 0.5463 264749.9n 0.5463 264750.0n 0.5463 264999.9n 0.5463 265000.0n 0.5463 265249.9n 0.5463 265250.0n 0.5463 265499.9n 0.5463 265500.0n 0.3312 265749.9n 0.3312 265750.0n 0.5463 265999.9n 0.5463 266000.0n 0.5463 266249.9n 0.5463 266250.0n 0.5463 266499.9n 0.5463 266500.0n 0.5329 266749.9n 0.5329 266750.0n 0.5194 266999.9n 0.5194 267000.0n 0.5463 267249.9n 0.5463 267250.0n 0.5463 267499.9n 0.5463 267500.0n 0.5463 267749.9n 0.5463 267750.0n 0.4926 267999.9n 0.4926 268000.0n 0.5463 268249.9n 0.5463 268250.0n 0.5463 268499.9n 0.5463 268500.0n 0.3984 268749.9n 0.3984 268750.0n 0.5060 268999.9n 0.5060 269000.0n 0.5463 269249.9n 0.5463 269250.0n 0.5194 269499.9n 0.5194 269500.0n 0.5329 269749.9n 0.5329 269750.0n 0.5194 269999.9n 0.5194 270000.0n 0.4119 270249.9n 0.4119 270250.0n 0.5463 270499.9n 0.5463 270500.0n 0.3984 270749.9n 0.3984 270750.0n 0.5463 270999.9n 0.5463 271000.0n 0.5463 271249.9n 0.5463 271250.0n 0.5463 271499.9n 0.5463 271500.0n 0.5194 271749.9n 0.5194 271750.0n 0.4119 271999.9n 0.4119 272000.0n 0.5463 272249.9n 0.5463 272250.0n 0.5463 272499.9n 0.5463 272500.0n 0.5463 272749.9n 0.5463 272750.0n 0.5463 272999.9n 0.5463 273000.0n 0.3312 273249.9n 0.3312 273250.0n 0.5463 273499.9n 0.5463 273500.0n 0.5463 273749.9n 0.5463 273750.0n 0.5463 273999.9n 0.5463 274000.0n 0.5329 274249.9n 0.5329 274250.0n 0.5194 274499.9n 0.5194 274500.0n 0.5463 274749.9n 0.5463 274750.0n 0.5463 274999.9n 0.5463 275000.0n 0.5463 275249.9n 0.5463 275250.0n 0.4926 275499.9n 0.4926 275500.0n 0.5463 275749.9n 0.5463 275750.0n 0.5463 275999.9n 0.5463 276000.0n 0.3984 276249.9n 0.3984 276250.0n 0.5060 276499.9n 0.5060 276500.0n 0.5463 276749.9n 0.5463 276750.0n 0.5194 276999.9n 0.5194 277000.0n 0.5329 277249.9n 0.5329 277250.0n 0.5194 277499.9n 0.5194 277500.0n 0.4119 277749.9n 0.4119 277750.0n 0.5463 277999.9n 0.5463 278000.0n 0.3984 278249.9n 0.3984 278250.0n 0.5463 278499.9n 0.5463 278500.0n 0.5463 278749.9n 0.5463 278750.0n 0.5463 278999.9n 0.5463 279000.0n 0.5194 279249.9n 0.5194 279250.0n 0.4119 279499.9n 0.4119 279500.0n 0.5463 279749.9n 0.5463 279750.0n 0.5463 279999.9n 0.5463 280000.0n 0.5463 280249.9n 0.5463 280250.0n 0.5463 280499.9n 0.5463 280500.0n 0.3312 280749.9n 0.3312 280750.0n 0.5463 280999.9n 0.5463 281000.0n 0.5463 281249.9n 0.5463 281250.0n 0.5463 281499.9n 0.5463 281500.0n 0.5329 281749.9n 0.5329 281750.0n 0.5194 281999.9n 0.5194 282000.0n 0.5463 282249.9n 0.5463 282250.0n 0.5463 282499.9n 0.5463 282500.0n 0.5463 282749.9n 0.5463 282750.0n 0.4926 282999.9n 0.4926 283000.0n 0.5463 283249.9n 0.5463 283250.0n 0.5463 283499.9n 0.5463 283500.0n 0.3984 283749.9n 0.3984 283750.0n 0.5060 283999.9n 0.5060 284000.0n 0.5463 284249.9n 0.5463 284250.0n 0.5194 284499.9n 0.5194 284500.0n 0.5329 284749.9n 0.5329 284750.0n 0.5194 284999.9n 0.5194 285000.0n 0.4119 285249.9n 0.4119 285250.0n 0.5463 285499.9n 0.5463 285500.0n 0.3984 285749.9n 0.3984 285750.0n 0.5463 285999.9n 0.5463 286000.0n 0.5463 286249.9n 0.5463 286250.0n 0.5463 286499.9n 0.5463 286500.0n 0.5194 286749.9n 0.5194 286750.0n 0.4119 286999.9n 0.4119 287000.0n 0.5463 287249.9n 0.5463 287250.0n 0.5463 287499.9n 0.5463 287500.0n 0.5463 287749.9n 0.5463 287750.0n 0.5463 287999.9n 0.5463 288000.0n 0.3312 288249.9n 0.3312 288250.0n 0.5463 288499.9n 0.5463 288500.0n 0.5463 288749.9n 0.5463 288750.0n 0.5463 288999.9n 0.5463 289000.0n 0.5329 289249.9n 0.5329 289250.0n 0.5194 289499.9n 0.5194 289500.0n 0.5463 289749.9n 0.5463 289750.0n 0.5463 289999.9n 0.5463 290000.0n 0.5463 290249.9n 0.5463 290250.0n 0.4926 290499.9n 0.4926 290500.0n 0.5463 290749.9n 0.5463 290750.0n 0.5463 290999.9n 0.5463 291000.0n 0.3984 291249.9n 0.3984 291250.0n 0.5060 291499.9n 0.5060 291500.0n 0.5463 291749.9n 0.5463 291750.0n 0.5194 291999.9n 0.5194 292000.0n 0.5329 292249.9n 0.5329 292250.0n 0.5194 292499.9n 0.5194 292500.0n 0.4119 292749.9n 0.4119 292750.0n 0.5463 292999.9n 0.5463 293000.0n 0.3984 293249.9n 0.3984 293250.0n 0.5463 293499.9n 0.5463 293500.0n 0.5463 293749.9n 0.5463 293750.0n 0.5463 293999.9n 0.5463 294000.0n 0.5194 294249.9n 0.5194 294250.0n 0.4119 294499.9n 0.4119 294500.0n 0.5463 294749.9n 0.5463 294750.0n 0.5463 294999.9n 0.5463 295000.0n 0.5463 295249.9n 0.5463 295250.0n 0.5463 295499.9n 0.5463 295500.0n 0.3312 295749.9n 0.3312 295750.0n 0.5463 295999.9n 0.5463 296000.0n 0.5463 296249.9n 0.5463 296250.0n 0.5463 296499.9n 0.5463 296500.0n 0.5329 296749.9n 0.5329 296750.0n 0.5194 296999.9n 0.5194 297000.0n 0.5463 297249.9n 0.5463 297250.0n 0.5463 297499.9n 0.5463 297500.0n 0.5463 297749.9n 0.5463 297750.0n 0.4926 297999.9n 0.4926 298000.0n 0.5463 298249.9n 0.5463 298250.0n 0.5463 298499.9n 0.5463 298500.0n 0.3984 298749.9n 0.3984 298750.0n 0.5060 298999.9n 0.5060 299000.0n 0.5463 299249.9n 0.5463 299250.0n 0.5194 299499.9n 0.5194 299500.0n 0.5329 299749.9n 0.5329 299750.0n 0.5194)
Vxp4 a_xp4 0 PWL(0.0n 0.5338 249.9n 0.5338 250.0n 0.5689 499.9n 0.5689 500.0n 0.4461 749.9n 0.4461 750.0n 0.4636 999.9n 0.4636 1000.0n 0.5338 1249.9n 0.5338 1250.0n 0.4110 1499.9n 0.4110 1500.0n 0.5162 1749.9n 0.5162 1750.0n 0.4987 1999.9n 0.4987 2000.0n 0.4110 2249.9n 0.4110 2250.0n 0.6566 2499.9n 0.6566 2500.0n 0.4110 2749.9n 0.4110 2750.0n 0.6390 2999.9n 0.6390 3000.0n 0.4987 3249.9n 0.4987 3250.0n 0.4110 3499.9n 0.4110 3500.0n 0.4110 3749.9n 0.4110 3750.0n 0.4110 3999.9n 0.4110 4000.0n 0.4110 4249.9n 0.4110 4250.0n 0.4636 4499.9n 0.4636 4500.0n 0.4636 4749.9n 0.4636 4750.0n 0.4110 4999.9n 0.4110 5000.0n 0.6215 5249.9n 0.6215 5250.0n 0.5689 5499.9n 0.5689 5500.0n 0.4811 5749.9n 0.4811 5750.0n 0.4110 5999.9n 0.4110 6000.0n 0.5689 6249.9n 0.5689 6250.0n 0.6039 6499.9n 0.6039 6500.0n 0.7969 6749.9n 0.7969 6750.0n 0.5513 6999.9n 0.5513 7000.0n 0.6566 7249.9n 0.6566 7250.0n 0.5162 7499.9n 0.5162 7500.0n 0.5338 7749.9n 0.5338 7750.0n 0.5689 7999.9n 0.5689 8000.0n 0.4461 8249.9n 0.4461 8250.0n 0.4636 8499.9n 0.4636 8500.0n 0.5338 8749.9n 0.5338 8750.0n 0.4110 8999.9n 0.4110 9000.0n 0.5162 9249.9n 0.5162 9250.0n 0.4987 9499.9n 0.4987 9500.0n 0.4110 9749.9n 0.4110 9750.0n 0.6566 9999.9n 0.6566 10000.0n 0.4110 10249.9n 0.4110 10250.0n 0.6390 10499.9n 0.6390 10500.0n 0.4987 10749.9n 0.4987 10750.0n 0.4110 10999.9n 0.4110 11000.0n 0.4110 11249.9n 0.4110 11250.0n 0.4110 11499.9n 0.4110 11500.0n 0.4110 11749.9n 0.4110 11750.0n 0.4636 11999.9n 0.4636 12000.0n 0.4636 12249.9n 0.4636 12250.0n 0.4110 12499.9n 0.4110 12500.0n 0.6215 12749.9n 0.6215 12750.0n 0.5689 12999.9n 0.5689 13000.0n 0.4811 13249.9n 0.4811 13250.0n 0.4110 13499.9n 0.4110 13500.0n 0.5689 13749.9n 0.5689 13750.0n 0.6039 13999.9n 0.6039 14000.0n 0.7969 14249.9n 0.7969 14250.0n 0.5513 14499.9n 0.5513 14500.0n 0.6566 14749.9n 0.6566 14750.0n 0.5162 14999.9n 0.5162 15000.0n 0.5338 15249.9n 0.5338 15250.0n 0.5689 15499.9n 0.5689 15500.0n 0.4461 15749.9n 0.4461 15750.0n 0.4636 15999.9n 0.4636 16000.0n 0.5338 16249.9n 0.5338 16250.0n 0.4110 16499.9n 0.4110 16500.0n 0.5162 16749.9n 0.5162 16750.0n 0.4987 16999.9n 0.4987 17000.0n 0.4110 17249.9n 0.4110 17250.0n 0.6566 17499.9n 0.6566 17500.0n 0.4110 17749.9n 0.4110 17750.0n 0.6390 17999.9n 0.6390 18000.0n 0.4987 18249.9n 0.4987 18250.0n 0.4110 18499.9n 0.4110 18500.0n 0.4110 18749.9n 0.4110 18750.0n 0.4110 18999.9n 0.4110 19000.0n 0.4110 19249.9n 0.4110 19250.0n 0.4636 19499.9n 0.4636 19500.0n 0.4636 19749.9n 0.4636 19750.0n 0.4110 19999.9n 0.4110 20000.0n 0.6215 20249.9n 0.6215 20250.0n 0.5689 20499.9n 0.5689 20500.0n 0.4811 20749.9n 0.4811 20750.0n 0.4110 20999.9n 0.4110 21000.0n 0.5689 21249.9n 0.5689 21250.0n 0.6039 21499.9n 0.6039 21500.0n 0.7969 21749.9n 0.7969 21750.0n 0.5513 21999.9n 0.5513 22000.0n 0.6566 22249.9n 0.6566 22250.0n 0.5162 22499.9n 0.5162 22500.0n 0.5338 22749.9n 0.5338 22750.0n 0.5689 22999.9n 0.5689 23000.0n 0.4461 23249.9n 0.4461 23250.0n 0.4636 23499.9n 0.4636 23500.0n 0.5338 23749.9n 0.5338 23750.0n 0.4110 23999.9n 0.4110 24000.0n 0.5162 24249.9n 0.5162 24250.0n 0.4987 24499.9n 0.4987 24500.0n 0.4110 24749.9n 0.4110 24750.0n 0.6566 24999.9n 0.6566 25000.0n 0.4110 25249.9n 0.4110 25250.0n 0.6390 25499.9n 0.6390 25500.0n 0.4987 25749.9n 0.4987 25750.0n 0.4110 25999.9n 0.4110 26000.0n 0.4110 26249.9n 0.4110 26250.0n 0.4110 26499.9n 0.4110 26500.0n 0.4110 26749.9n 0.4110 26750.0n 0.4636 26999.9n 0.4636 27000.0n 0.4636 27249.9n 0.4636 27250.0n 0.4110 27499.9n 0.4110 27500.0n 0.6215 27749.9n 0.6215 27750.0n 0.5689 27999.9n 0.5689 28000.0n 0.4811 28249.9n 0.4811 28250.0n 0.4110 28499.9n 0.4110 28500.0n 0.5689 28749.9n 0.5689 28750.0n 0.6039 28999.9n 0.6039 29000.0n 0.7969 29249.9n 0.7969 29250.0n 0.5513 29499.9n 0.5513 29500.0n 0.6566 29749.9n 0.6566 29750.0n 0.5162 29999.9n 0.5162 30000.0n 0.5338 30249.9n 0.5338 30250.0n 0.5689 30499.9n 0.5689 30500.0n 0.4461 30749.9n 0.4461 30750.0n 0.4636 30999.9n 0.4636 31000.0n 0.5338 31249.9n 0.5338 31250.0n 0.4110 31499.9n 0.4110 31500.0n 0.5162 31749.9n 0.5162 31750.0n 0.4987 31999.9n 0.4987 32000.0n 0.4110 32249.9n 0.4110 32250.0n 0.6566 32499.9n 0.6566 32500.0n 0.4110 32749.9n 0.4110 32750.0n 0.6390 32999.9n 0.6390 33000.0n 0.4987 33249.9n 0.4987 33250.0n 0.4110 33499.9n 0.4110 33500.0n 0.4110 33749.9n 0.4110 33750.0n 0.4110 33999.9n 0.4110 34000.0n 0.4110 34249.9n 0.4110 34250.0n 0.4636 34499.9n 0.4636 34500.0n 0.4636 34749.9n 0.4636 34750.0n 0.4110 34999.9n 0.4110 35000.0n 0.6215 35249.9n 0.6215 35250.0n 0.5689 35499.9n 0.5689 35500.0n 0.4811 35749.9n 0.4811 35750.0n 0.4110 35999.9n 0.4110 36000.0n 0.5689 36249.9n 0.5689 36250.0n 0.6039 36499.9n 0.6039 36500.0n 0.7969 36749.9n 0.7969 36750.0n 0.5513 36999.9n 0.5513 37000.0n 0.6566 37249.9n 0.6566 37250.0n 0.5162 37499.9n 0.5162 37500.0n 0.5338 37749.9n 0.5338 37750.0n 0.5689 37999.9n 0.5689 38000.0n 0.4461 38249.9n 0.4461 38250.0n 0.4636 38499.9n 0.4636 38500.0n 0.5338 38749.9n 0.5338 38750.0n 0.4110 38999.9n 0.4110 39000.0n 0.5162 39249.9n 0.5162 39250.0n 0.4987 39499.9n 0.4987 39500.0n 0.4110 39749.9n 0.4110 39750.0n 0.6566 39999.9n 0.6566 40000.0n 0.4110 40249.9n 0.4110 40250.0n 0.6390 40499.9n 0.6390 40500.0n 0.4987 40749.9n 0.4987 40750.0n 0.4110 40999.9n 0.4110 41000.0n 0.4110 41249.9n 0.4110 41250.0n 0.4110 41499.9n 0.4110 41500.0n 0.4110 41749.9n 0.4110 41750.0n 0.4636 41999.9n 0.4636 42000.0n 0.4636 42249.9n 0.4636 42250.0n 0.4110 42499.9n 0.4110 42500.0n 0.6215 42749.9n 0.6215 42750.0n 0.5689 42999.9n 0.5689 43000.0n 0.4811 43249.9n 0.4811 43250.0n 0.4110 43499.9n 0.4110 43500.0n 0.5689 43749.9n 0.5689 43750.0n 0.6039 43999.9n 0.6039 44000.0n 0.7969 44249.9n 0.7969 44250.0n 0.5513 44499.9n 0.5513 44500.0n 0.6566 44749.9n 0.6566 44750.0n 0.5162 44999.9n 0.5162 45000.0n 0.5338 45249.9n 0.5338 45250.0n 0.5689 45499.9n 0.5689 45500.0n 0.4461 45749.9n 0.4461 45750.0n 0.4636 45999.9n 0.4636 46000.0n 0.5338 46249.9n 0.5338 46250.0n 0.4110 46499.9n 0.4110 46500.0n 0.5162 46749.9n 0.5162 46750.0n 0.4987 46999.9n 0.4987 47000.0n 0.4110 47249.9n 0.4110 47250.0n 0.6566 47499.9n 0.6566 47500.0n 0.4110 47749.9n 0.4110 47750.0n 0.6390 47999.9n 0.6390 48000.0n 0.4987 48249.9n 0.4987 48250.0n 0.4110 48499.9n 0.4110 48500.0n 0.4110 48749.9n 0.4110 48750.0n 0.4110 48999.9n 0.4110 49000.0n 0.4110 49249.9n 0.4110 49250.0n 0.4636 49499.9n 0.4636 49500.0n 0.4636 49749.9n 0.4636 49750.0n 0.4110 49999.9n 0.4110 50000.0n 0.6215 50249.9n 0.6215 50250.0n 0.5689 50499.9n 0.5689 50500.0n 0.4811 50749.9n 0.4811 50750.0n 0.4110 50999.9n 0.4110 51000.0n 0.5689 51249.9n 0.5689 51250.0n 0.6039 51499.9n 0.6039 51500.0n 0.7969 51749.9n 0.7969 51750.0n 0.5513 51999.9n 0.5513 52000.0n 0.6566 52249.9n 0.6566 52250.0n 0.5162 52499.9n 0.5162 52500.0n 0.5338 52749.9n 0.5338 52750.0n 0.5689 52999.9n 0.5689 53000.0n 0.4461 53249.9n 0.4461 53250.0n 0.4636 53499.9n 0.4636 53500.0n 0.5338 53749.9n 0.5338 53750.0n 0.4110 53999.9n 0.4110 54000.0n 0.5162 54249.9n 0.5162 54250.0n 0.4987 54499.9n 0.4987 54500.0n 0.4110 54749.9n 0.4110 54750.0n 0.6566 54999.9n 0.6566 55000.0n 0.4110 55249.9n 0.4110 55250.0n 0.6390 55499.9n 0.6390 55500.0n 0.4987 55749.9n 0.4987 55750.0n 0.4110 55999.9n 0.4110 56000.0n 0.4110 56249.9n 0.4110 56250.0n 0.4110 56499.9n 0.4110 56500.0n 0.4110 56749.9n 0.4110 56750.0n 0.4636 56999.9n 0.4636 57000.0n 0.4636 57249.9n 0.4636 57250.0n 0.4110 57499.9n 0.4110 57500.0n 0.6215 57749.9n 0.6215 57750.0n 0.5689 57999.9n 0.5689 58000.0n 0.4811 58249.9n 0.4811 58250.0n 0.4110 58499.9n 0.4110 58500.0n 0.5689 58749.9n 0.5689 58750.0n 0.6039 58999.9n 0.6039 59000.0n 0.7969 59249.9n 0.7969 59250.0n 0.5513 59499.9n 0.5513 59500.0n 0.6566 59749.9n 0.6566 59750.0n 0.5162 59999.9n 0.5162 60000.0n 0.5338 60249.9n 0.5338 60250.0n 0.5689 60499.9n 0.5689 60500.0n 0.4461 60749.9n 0.4461 60750.0n 0.4636 60999.9n 0.4636 61000.0n 0.5338 61249.9n 0.5338 61250.0n 0.4110 61499.9n 0.4110 61500.0n 0.5162 61749.9n 0.5162 61750.0n 0.4987 61999.9n 0.4987 62000.0n 0.4110 62249.9n 0.4110 62250.0n 0.6566 62499.9n 0.6566 62500.0n 0.4110 62749.9n 0.4110 62750.0n 0.6390 62999.9n 0.6390 63000.0n 0.4987 63249.9n 0.4987 63250.0n 0.4110 63499.9n 0.4110 63500.0n 0.4110 63749.9n 0.4110 63750.0n 0.4110 63999.9n 0.4110 64000.0n 0.4110 64249.9n 0.4110 64250.0n 0.4636 64499.9n 0.4636 64500.0n 0.4636 64749.9n 0.4636 64750.0n 0.4110 64999.9n 0.4110 65000.0n 0.6215 65249.9n 0.6215 65250.0n 0.5689 65499.9n 0.5689 65500.0n 0.4811 65749.9n 0.4811 65750.0n 0.4110 65999.9n 0.4110 66000.0n 0.5689 66249.9n 0.5689 66250.0n 0.6039 66499.9n 0.6039 66500.0n 0.7969 66749.9n 0.7969 66750.0n 0.5513 66999.9n 0.5513 67000.0n 0.6566 67249.9n 0.6566 67250.0n 0.5162 67499.9n 0.5162 67500.0n 0.5338 67749.9n 0.5338 67750.0n 0.5689 67999.9n 0.5689 68000.0n 0.4461 68249.9n 0.4461 68250.0n 0.4636 68499.9n 0.4636 68500.0n 0.5338 68749.9n 0.5338 68750.0n 0.4110 68999.9n 0.4110 69000.0n 0.5162 69249.9n 0.5162 69250.0n 0.4987 69499.9n 0.4987 69500.0n 0.4110 69749.9n 0.4110 69750.0n 0.6566 69999.9n 0.6566 70000.0n 0.4110 70249.9n 0.4110 70250.0n 0.6390 70499.9n 0.6390 70500.0n 0.4987 70749.9n 0.4987 70750.0n 0.4110 70999.9n 0.4110 71000.0n 0.4110 71249.9n 0.4110 71250.0n 0.4110 71499.9n 0.4110 71500.0n 0.4110 71749.9n 0.4110 71750.0n 0.4636 71999.9n 0.4636 72000.0n 0.4636 72249.9n 0.4636 72250.0n 0.4110 72499.9n 0.4110 72500.0n 0.6215 72749.9n 0.6215 72750.0n 0.5689 72999.9n 0.5689 73000.0n 0.4811 73249.9n 0.4811 73250.0n 0.4110 73499.9n 0.4110 73500.0n 0.5689 73749.9n 0.5689 73750.0n 0.6039 73999.9n 0.6039 74000.0n 0.7969 74249.9n 0.7969 74250.0n 0.5513 74499.9n 0.5513 74500.0n 0.6566 74749.9n 0.6566 74750.0n 0.5162 74999.9n 0.5162 75000.0n 0.5338 75249.9n 0.5338 75250.0n 0.5689 75499.9n 0.5689 75500.0n 0.4461 75749.9n 0.4461 75750.0n 0.4636 75999.9n 0.4636 76000.0n 0.5338 76249.9n 0.5338 76250.0n 0.4110 76499.9n 0.4110 76500.0n 0.5162 76749.9n 0.5162 76750.0n 0.4987 76999.9n 0.4987 77000.0n 0.4110 77249.9n 0.4110 77250.0n 0.6566 77499.9n 0.6566 77500.0n 0.4110 77749.9n 0.4110 77750.0n 0.6390 77999.9n 0.6390 78000.0n 0.4987 78249.9n 0.4987 78250.0n 0.4110 78499.9n 0.4110 78500.0n 0.4110 78749.9n 0.4110 78750.0n 0.4110 78999.9n 0.4110 79000.0n 0.4110 79249.9n 0.4110 79250.0n 0.4636 79499.9n 0.4636 79500.0n 0.4636 79749.9n 0.4636 79750.0n 0.4110 79999.9n 0.4110 80000.0n 0.6215 80249.9n 0.6215 80250.0n 0.5689 80499.9n 0.5689 80500.0n 0.4811 80749.9n 0.4811 80750.0n 0.4110 80999.9n 0.4110 81000.0n 0.5689 81249.9n 0.5689 81250.0n 0.6039 81499.9n 0.6039 81500.0n 0.7969 81749.9n 0.7969 81750.0n 0.5513 81999.9n 0.5513 82000.0n 0.6566 82249.9n 0.6566 82250.0n 0.5162 82499.9n 0.5162 82500.0n 0.5338 82749.9n 0.5338 82750.0n 0.5689 82999.9n 0.5689 83000.0n 0.4461 83249.9n 0.4461 83250.0n 0.4636 83499.9n 0.4636 83500.0n 0.5338 83749.9n 0.5338 83750.0n 0.4110 83999.9n 0.4110 84000.0n 0.5162 84249.9n 0.5162 84250.0n 0.4987 84499.9n 0.4987 84500.0n 0.4110 84749.9n 0.4110 84750.0n 0.6566 84999.9n 0.6566 85000.0n 0.4110 85249.9n 0.4110 85250.0n 0.6390 85499.9n 0.6390 85500.0n 0.4987 85749.9n 0.4987 85750.0n 0.4110 85999.9n 0.4110 86000.0n 0.4110 86249.9n 0.4110 86250.0n 0.4110 86499.9n 0.4110 86500.0n 0.4110 86749.9n 0.4110 86750.0n 0.4636 86999.9n 0.4636 87000.0n 0.4636 87249.9n 0.4636 87250.0n 0.4110 87499.9n 0.4110 87500.0n 0.6215 87749.9n 0.6215 87750.0n 0.5689 87999.9n 0.5689 88000.0n 0.4811 88249.9n 0.4811 88250.0n 0.4110 88499.9n 0.4110 88500.0n 0.5689 88749.9n 0.5689 88750.0n 0.6039 88999.9n 0.6039 89000.0n 0.7969 89249.9n 0.7969 89250.0n 0.5513 89499.9n 0.5513 89500.0n 0.6566 89749.9n 0.6566 89750.0n 0.5162 89999.9n 0.5162 90000.0n 0.5338 90249.9n 0.5338 90250.0n 0.5689 90499.9n 0.5689 90500.0n 0.4461 90749.9n 0.4461 90750.0n 0.4636 90999.9n 0.4636 91000.0n 0.5338 91249.9n 0.5338 91250.0n 0.4110 91499.9n 0.4110 91500.0n 0.5162 91749.9n 0.5162 91750.0n 0.4987 91999.9n 0.4987 92000.0n 0.4110 92249.9n 0.4110 92250.0n 0.6566 92499.9n 0.6566 92500.0n 0.4110 92749.9n 0.4110 92750.0n 0.6390 92999.9n 0.6390 93000.0n 0.4987 93249.9n 0.4987 93250.0n 0.4110 93499.9n 0.4110 93500.0n 0.4110 93749.9n 0.4110 93750.0n 0.4110 93999.9n 0.4110 94000.0n 0.4110 94249.9n 0.4110 94250.0n 0.4636 94499.9n 0.4636 94500.0n 0.4636 94749.9n 0.4636 94750.0n 0.4110 94999.9n 0.4110 95000.0n 0.6215 95249.9n 0.6215 95250.0n 0.5689 95499.9n 0.5689 95500.0n 0.4811 95749.9n 0.4811 95750.0n 0.4110 95999.9n 0.4110 96000.0n 0.5689 96249.9n 0.5689 96250.0n 0.6039 96499.9n 0.6039 96500.0n 0.7969 96749.9n 0.7969 96750.0n 0.5513 96999.9n 0.5513 97000.0n 0.6566 97249.9n 0.6566 97250.0n 0.5162 97499.9n 0.5162 97500.0n 0.5338 97749.9n 0.5338 97750.0n 0.5689 97999.9n 0.5689 98000.0n 0.4461 98249.9n 0.4461 98250.0n 0.4636 98499.9n 0.4636 98500.0n 0.5338 98749.9n 0.5338 98750.0n 0.4110 98999.9n 0.4110 99000.0n 0.5162 99249.9n 0.5162 99250.0n 0.4987 99499.9n 0.4987 99500.0n 0.4110 99749.9n 0.4110 99750.0n 0.6566 99999.9n 0.6566 100000.0n 0.4110 100249.9n 0.4110 100250.0n 0.6390 100499.9n 0.6390 100500.0n 0.4987 100749.9n 0.4987 100750.0n 0.4110 100999.9n 0.4110 101000.0n 0.4110 101249.9n 0.4110 101250.0n 0.4110 101499.9n 0.4110 101500.0n 0.4110 101749.9n 0.4110 101750.0n 0.4636 101999.9n 0.4636 102000.0n 0.4636 102249.9n 0.4636 102250.0n 0.4110 102499.9n 0.4110 102500.0n 0.6215 102749.9n 0.6215 102750.0n 0.5689 102999.9n 0.5689 103000.0n 0.4811 103249.9n 0.4811 103250.0n 0.4110 103499.9n 0.4110 103500.0n 0.5689 103749.9n 0.5689 103750.0n 0.6039 103999.9n 0.6039 104000.0n 0.7969 104249.9n 0.7969 104250.0n 0.5513 104499.9n 0.5513 104500.0n 0.6566 104749.9n 0.6566 104750.0n 0.5162 104999.9n 0.5162 105000.0n 0.5338 105249.9n 0.5338 105250.0n 0.5689 105499.9n 0.5689 105500.0n 0.4461 105749.9n 0.4461 105750.0n 0.4636 105999.9n 0.4636 106000.0n 0.5338 106249.9n 0.5338 106250.0n 0.4110 106499.9n 0.4110 106500.0n 0.5162 106749.9n 0.5162 106750.0n 0.4987 106999.9n 0.4987 107000.0n 0.4110 107249.9n 0.4110 107250.0n 0.6566 107499.9n 0.6566 107500.0n 0.4110 107749.9n 0.4110 107750.0n 0.6390 107999.9n 0.6390 108000.0n 0.4987 108249.9n 0.4987 108250.0n 0.4110 108499.9n 0.4110 108500.0n 0.4110 108749.9n 0.4110 108750.0n 0.4110 108999.9n 0.4110 109000.0n 0.4110 109249.9n 0.4110 109250.0n 0.4636 109499.9n 0.4636 109500.0n 0.4636 109749.9n 0.4636 109750.0n 0.4110 109999.9n 0.4110 110000.0n 0.6215 110249.9n 0.6215 110250.0n 0.5689 110499.9n 0.5689 110500.0n 0.4811 110749.9n 0.4811 110750.0n 0.4110 110999.9n 0.4110 111000.0n 0.5689 111249.9n 0.5689 111250.0n 0.6039 111499.9n 0.6039 111500.0n 0.7969 111749.9n 0.7969 111750.0n 0.5513 111999.9n 0.5513 112000.0n 0.6566 112249.9n 0.6566 112250.0n 0.5162 112499.9n 0.5162 112500.0n 0.5338 112749.9n 0.5338 112750.0n 0.5689 112999.9n 0.5689 113000.0n 0.4461 113249.9n 0.4461 113250.0n 0.4636 113499.9n 0.4636 113500.0n 0.5338 113749.9n 0.5338 113750.0n 0.4110 113999.9n 0.4110 114000.0n 0.5162 114249.9n 0.5162 114250.0n 0.4987 114499.9n 0.4987 114500.0n 0.4110 114749.9n 0.4110 114750.0n 0.6566 114999.9n 0.6566 115000.0n 0.4110 115249.9n 0.4110 115250.0n 0.6390 115499.9n 0.6390 115500.0n 0.4987 115749.9n 0.4987 115750.0n 0.4110 115999.9n 0.4110 116000.0n 0.4110 116249.9n 0.4110 116250.0n 0.4110 116499.9n 0.4110 116500.0n 0.4110 116749.9n 0.4110 116750.0n 0.4636 116999.9n 0.4636 117000.0n 0.4636 117249.9n 0.4636 117250.0n 0.4110 117499.9n 0.4110 117500.0n 0.6215 117749.9n 0.6215 117750.0n 0.5689 117999.9n 0.5689 118000.0n 0.4811 118249.9n 0.4811 118250.0n 0.4110 118499.9n 0.4110 118500.0n 0.5689 118749.9n 0.5689 118750.0n 0.6039 118999.9n 0.6039 119000.0n 0.7969 119249.9n 0.7969 119250.0n 0.5513 119499.9n 0.5513 119500.0n 0.6566 119749.9n 0.6566 119750.0n 0.5162 119999.9n 0.5162 120000.0n 0.5338 120249.9n 0.5338 120250.0n 0.5689 120499.9n 0.5689 120500.0n 0.4461 120749.9n 0.4461 120750.0n 0.4636 120999.9n 0.4636 121000.0n 0.5338 121249.9n 0.5338 121250.0n 0.4110 121499.9n 0.4110 121500.0n 0.5162 121749.9n 0.5162 121750.0n 0.4987 121999.9n 0.4987 122000.0n 0.4110 122249.9n 0.4110 122250.0n 0.6566 122499.9n 0.6566 122500.0n 0.4110 122749.9n 0.4110 122750.0n 0.6390 122999.9n 0.6390 123000.0n 0.4987 123249.9n 0.4987 123250.0n 0.4110 123499.9n 0.4110 123500.0n 0.4110 123749.9n 0.4110 123750.0n 0.4110 123999.9n 0.4110 124000.0n 0.4110 124249.9n 0.4110 124250.0n 0.4636 124499.9n 0.4636 124500.0n 0.4636 124749.9n 0.4636 124750.0n 0.4110 124999.9n 0.4110 125000.0n 0.6215 125249.9n 0.6215 125250.0n 0.5689 125499.9n 0.5689 125500.0n 0.4811 125749.9n 0.4811 125750.0n 0.4110 125999.9n 0.4110 126000.0n 0.5689 126249.9n 0.5689 126250.0n 0.6039 126499.9n 0.6039 126500.0n 0.7969 126749.9n 0.7969 126750.0n 0.5513 126999.9n 0.5513 127000.0n 0.6566 127249.9n 0.6566 127250.0n 0.5162 127499.9n 0.5162 127500.0n 0.5338 127749.9n 0.5338 127750.0n 0.5689 127999.9n 0.5689 128000.0n 0.4461 128249.9n 0.4461 128250.0n 0.4636 128499.9n 0.4636 128500.0n 0.5338 128749.9n 0.5338 128750.0n 0.4110 128999.9n 0.4110 129000.0n 0.5162 129249.9n 0.5162 129250.0n 0.4987 129499.9n 0.4987 129500.0n 0.4110 129749.9n 0.4110 129750.0n 0.6566 129999.9n 0.6566 130000.0n 0.4110 130249.9n 0.4110 130250.0n 0.6390 130499.9n 0.6390 130500.0n 0.4987 130749.9n 0.4987 130750.0n 0.4110 130999.9n 0.4110 131000.0n 0.4110 131249.9n 0.4110 131250.0n 0.4110 131499.9n 0.4110 131500.0n 0.4110 131749.9n 0.4110 131750.0n 0.4636 131999.9n 0.4636 132000.0n 0.4636 132249.9n 0.4636 132250.0n 0.4110 132499.9n 0.4110 132500.0n 0.6215 132749.9n 0.6215 132750.0n 0.5689 132999.9n 0.5689 133000.0n 0.4811 133249.9n 0.4811 133250.0n 0.4110 133499.9n 0.4110 133500.0n 0.5689 133749.9n 0.5689 133750.0n 0.6039 133999.9n 0.6039 134000.0n 0.7969 134249.9n 0.7969 134250.0n 0.5513 134499.9n 0.5513 134500.0n 0.6566 134749.9n 0.6566 134750.0n 0.5162 134999.9n 0.5162 135000.0n 0.5338 135249.9n 0.5338 135250.0n 0.5689 135499.9n 0.5689 135500.0n 0.4461 135749.9n 0.4461 135750.0n 0.4636 135999.9n 0.4636 136000.0n 0.5338 136249.9n 0.5338 136250.0n 0.4110 136499.9n 0.4110 136500.0n 0.5162 136749.9n 0.5162 136750.0n 0.4987 136999.9n 0.4987 137000.0n 0.4110 137249.9n 0.4110 137250.0n 0.6566 137499.9n 0.6566 137500.0n 0.4110 137749.9n 0.4110 137750.0n 0.6390 137999.9n 0.6390 138000.0n 0.4987 138249.9n 0.4987 138250.0n 0.4110 138499.9n 0.4110 138500.0n 0.4110 138749.9n 0.4110 138750.0n 0.4110 138999.9n 0.4110 139000.0n 0.4110 139249.9n 0.4110 139250.0n 0.4636 139499.9n 0.4636 139500.0n 0.4636 139749.9n 0.4636 139750.0n 0.4110 139999.9n 0.4110 140000.0n 0.6215 140249.9n 0.6215 140250.0n 0.5689 140499.9n 0.5689 140500.0n 0.4811 140749.9n 0.4811 140750.0n 0.4110 140999.9n 0.4110 141000.0n 0.5689 141249.9n 0.5689 141250.0n 0.6039 141499.9n 0.6039 141500.0n 0.7969 141749.9n 0.7969 141750.0n 0.5513 141999.9n 0.5513 142000.0n 0.6566 142249.9n 0.6566 142250.0n 0.5162 142499.9n 0.5162 142500.0n 0.5338 142749.9n 0.5338 142750.0n 0.5689 142999.9n 0.5689 143000.0n 0.4461 143249.9n 0.4461 143250.0n 0.4636 143499.9n 0.4636 143500.0n 0.5338 143749.9n 0.5338 143750.0n 0.4110 143999.9n 0.4110 144000.0n 0.5162 144249.9n 0.5162 144250.0n 0.4987 144499.9n 0.4987 144500.0n 0.4110 144749.9n 0.4110 144750.0n 0.6566 144999.9n 0.6566 145000.0n 0.4110 145249.9n 0.4110 145250.0n 0.6390 145499.9n 0.6390 145500.0n 0.4987 145749.9n 0.4987 145750.0n 0.4110 145999.9n 0.4110 146000.0n 0.4110 146249.9n 0.4110 146250.0n 0.4110 146499.9n 0.4110 146500.0n 0.4110 146749.9n 0.4110 146750.0n 0.4636 146999.9n 0.4636 147000.0n 0.4636 147249.9n 0.4636 147250.0n 0.4110 147499.9n 0.4110 147500.0n 0.6215 147749.9n 0.6215 147750.0n 0.5689 147999.9n 0.5689 148000.0n 0.4811 148249.9n 0.4811 148250.0n 0.4110 148499.9n 0.4110 148500.0n 0.5689 148749.9n 0.5689 148750.0n 0.6039 148999.9n 0.6039 149000.0n 0.7969 149249.9n 0.7969 149250.0n 0.5513 149499.9n 0.5513 149500.0n 0.6566 149749.9n 0.6566 149750.0n 0.5162 149999.9n 0.5162 150000.0n 0.5338 150249.9n 0.5338 150250.0n 0.5689 150499.9n 0.5689 150500.0n 0.4461 150749.9n 0.4461 150750.0n 0.4636 150999.9n 0.4636 151000.0n 0.5338 151249.9n 0.5338 151250.0n 0.4110 151499.9n 0.4110 151500.0n 0.5162 151749.9n 0.5162 151750.0n 0.4987 151999.9n 0.4987 152000.0n 0.4110 152249.9n 0.4110 152250.0n 0.6566 152499.9n 0.6566 152500.0n 0.4110 152749.9n 0.4110 152750.0n 0.6390 152999.9n 0.6390 153000.0n 0.4987 153249.9n 0.4987 153250.0n 0.4110 153499.9n 0.4110 153500.0n 0.4110 153749.9n 0.4110 153750.0n 0.4110 153999.9n 0.4110 154000.0n 0.4110 154249.9n 0.4110 154250.0n 0.4636 154499.9n 0.4636 154500.0n 0.4636 154749.9n 0.4636 154750.0n 0.4110 154999.9n 0.4110 155000.0n 0.6215 155249.9n 0.6215 155250.0n 0.5689 155499.9n 0.5689 155500.0n 0.4811 155749.9n 0.4811 155750.0n 0.4110 155999.9n 0.4110 156000.0n 0.5689 156249.9n 0.5689 156250.0n 0.6039 156499.9n 0.6039 156500.0n 0.7969 156749.9n 0.7969 156750.0n 0.5513 156999.9n 0.5513 157000.0n 0.6566 157249.9n 0.6566 157250.0n 0.5162 157499.9n 0.5162 157500.0n 0.5338 157749.9n 0.5338 157750.0n 0.5689 157999.9n 0.5689 158000.0n 0.4461 158249.9n 0.4461 158250.0n 0.4636 158499.9n 0.4636 158500.0n 0.5338 158749.9n 0.5338 158750.0n 0.4110 158999.9n 0.4110 159000.0n 0.5162 159249.9n 0.5162 159250.0n 0.4987 159499.9n 0.4987 159500.0n 0.4110 159749.9n 0.4110 159750.0n 0.6566 159999.9n 0.6566 160000.0n 0.4110 160249.9n 0.4110 160250.0n 0.6390 160499.9n 0.6390 160500.0n 0.4987 160749.9n 0.4987 160750.0n 0.4110 160999.9n 0.4110 161000.0n 0.4110 161249.9n 0.4110 161250.0n 0.4110 161499.9n 0.4110 161500.0n 0.4110 161749.9n 0.4110 161750.0n 0.4636 161999.9n 0.4636 162000.0n 0.4636 162249.9n 0.4636 162250.0n 0.4110 162499.9n 0.4110 162500.0n 0.6215 162749.9n 0.6215 162750.0n 0.5689 162999.9n 0.5689 163000.0n 0.4811 163249.9n 0.4811 163250.0n 0.4110 163499.9n 0.4110 163500.0n 0.5689 163749.9n 0.5689 163750.0n 0.6039 163999.9n 0.6039 164000.0n 0.7969 164249.9n 0.7969 164250.0n 0.5513 164499.9n 0.5513 164500.0n 0.6566 164749.9n 0.6566 164750.0n 0.5162 164999.9n 0.5162 165000.0n 0.5338 165249.9n 0.5338 165250.0n 0.5689 165499.9n 0.5689 165500.0n 0.4461 165749.9n 0.4461 165750.0n 0.4636 165999.9n 0.4636 166000.0n 0.5338 166249.9n 0.5338 166250.0n 0.4110 166499.9n 0.4110 166500.0n 0.5162 166749.9n 0.5162 166750.0n 0.4987 166999.9n 0.4987 167000.0n 0.4110 167249.9n 0.4110 167250.0n 0.6566 167499.9n 0.6566 167500.0n 0.4110 167749.9n 0.4110 167750.0n 0.6390 167999.9n 0.6390 168000.0n 0.4987 168249.9n 0.4987 168250.0n 0.4110 168499.9n 0.4110 168500.0n 0.4110 168749.9n 0.4110 168750.0n 0.4110 168999.9n 0.4110 169000.0n 0.4110 169249.9n 0.4110 169250.0n 0.4636 169499.9n 0.4636 169500.0n 0.4636 169749.9n 0.4636 169750.0n 0.4110 169999.9n 0.4110 170000.0n 0.6215 170249.9n 0.6215 170250.0n 0.5689 170499.9n 0.5689 170500.0n 0.4811 170749.9n 0.4811 170750.0n 0.4110 170999.9n 0.4110 171000.0n 0.5689 171249.9n 0.5689 171250.0n 0.6039 171499.9n 0.6039 171500.0n 0.7969 171749.9n 0.7969 171750.0n 0.5513 171999.9n 0.5513 172000.0n 0.6566 172249.9n 0.6566 172250.0n 0.5162 172499.9n 0.5162 172500.0n 0.5338 172749.9n 0.5338 172750.0n 0.5689 172999.9n 0.5689 173000.0n 0.4461 173249.9n 0.4461 173250.0n 0.4636 173499.9n 0.4636 173500.0n 0.5338 173749.9n 0.5338 173750.0n 0.4110 173999.9n 0.4110 174000.0n 0.5162 174249.9n 0.5162 174250.0n 0.4987 174499.9n 0.4987 174500.0n 0.4110 174749.9n 0.4110 174750.0n 0.6566 174999.9n 0.6566 175000.0n 0.4110 175249.9n 0.4110 175250.0n 0.6390 175499.9n 0.6390 175500.0n 0.4987 175749.9n 0.4987 175750.0n 0.4110 175999.9n 0.4110 176000.0n 0.4110 176249.9n 0.4110 176250.0n 0.4110 176499.9n 0.4110 176500.0n 0.4110 176749.9n 0.4110 176750.0n 0.4636 176999.9n 0.4636 177000.0n 0.4636 177249.9n 0.4636 177250.0n 0.4110 177499.9n 0.4110 177500.0n 0.6215 177749.9n 0.6215 177750.0n 0.5689 177999.9n 0.5689 178000.0n 0.4811 178249.9n 0.4811 178250.0n 0.4110 178499.9n 0.4110 178500.0n 0.5689 178749.9n 0.5689 178750.0n 0.6039 178999.9n 0.6039 179000.0n 0.7969 179249.9n 0.7969 179250.0n 0.5513 179499.9n 0.5513 179500.0n 0.6566 179749.9n 0.6566 179750.0n 0.5162 179999.9n 0.5162 180000.0n 0.5338 180249.9n 0.5338 180250.0n 0.5689 180499.9n 0.5689 180500.0n 0.4461 180749.9n 0.4461 180750.0n 0.4636 180999.9n 0.4636 181000.0n 0.5338 181249.9n 0.5338 181250.0n 0.4110 181499.9n 0.4110 181500.0n 0.5162 181749.9n 0.5162 181750.0n 0.4987 181999.9n 0.4987 182000.0n 0.4110 182249.9n 0.4110 182250.0n 0.6566 182499.9n 0.6566 182500.0n 0.4110 182749.9n 0.4110 182750.0n 0.6390 182999.9n 0.6390 183000.0n 0.4987 183249.9n 0.4987 183250.0n 0.4110 183499.9n 0.4110 183500.0n 0.4110 183749.9n 0.4110 183750.0n 0.4110 183999.9n 0.4110 184000.0n 0.4110 184249.9n 0.4110 184250.0n 0.4636 184499.9n 0.4636 184500.0n 0.4636 184749.9n 0.4636 184750.0n 0.4110 184999.9n 0.4110 185000.0n 0.6215 185249.9n 0.6215 185250.0n 0.5689 185499.9n 0.5689 185500.0n 0.4811 185749.9n 0.4811 185750.0n 0.4110 185999.9n 0.4110 186000.0n 0.5689 186249.9n 0.5689 186250.0n 0.6039 186499.9n 0.6039 186500.0n 0.7969 186749.9n 0.7969 186750.0n 0.5513 186999.9n 0.5513 187000.0n 0.6566 187249.9n 0.6566 187250.0n 0.5162 187499.9n 0.5162 187500.0n 0.5338 187749.9n 0.5338 187750.0n 0.5689 187999.9n 0.5689 188000.0n 0.4461 188249.9n 0.4461 188250.0n 0.4636 188499.9n 0.4636 188500.0n 0.5338 188749.9n 0.5338 188750.0n 0.4110 188999.9n 0.4110 189000.0n 0.5162 189249.9n 0.5162 189250.0n 0.4987 189499.9n 0.4987 189500.0n 0.4110 189749.9n 0.4110 189750.0n 0.6566 189999.9n 0.6566 190000.0n 0.4110 190249.9n 0.4110 190250.0n 0.6390 190499.9n 0.6390 190500.0n 0.4987 190749.9n 0.4987 190750.0n 0.4110 190999.9n 0.4110 191000.0n 0.4110 191249.9n 0.4110 191250.0n 0.4110 191499.9n 0.4110 191500.0n 0.4110 191749.9n 0.4110 191750.0n 0.4636 191999.9n 0.4636 192000.0n 0.4636 192249.9n 0.4636 192250.0n 0.4110 192499.9n 0.4110 192500.0n 0.6215 192749.9n 0.6215 192750.0n 0.5689 192999.9n 0.5689 193000.0n 0.4811 193249.9n 0.4811 193250.0n 0.4110 193499.9n 0.4110 193500.0n 0.5689 193749.9n 0.5689 193750.0n 0.6039 193999.9n 0.6039 194000.0n 0.7969 194249.9n 0.7969 194250.0n 0.5513 194499.9n 0.5513 194500.0n 0.6566 194749.9n 0.6566 194750.0n 0.5162 194999.9n 0.5162 195000.0n 0.5338 195249.9n 0.5338 195250.0n 0.5689 195499.9n 0.5689 195500.0n 0.4461 195749.9n 0.4461 195750.0n 0.4636 195999.9n 0.4636 196000.0n 0.5338 196249.9n 0.5338 196250.0n 0.4110 196499.9n 0.4110 196500.0n 0.5162 196749.9n 0.5162 196750.0n 0.4987 196999.9n 0.4987 197000.0n 0.4110 197249.9n 0.4110 197250.0n 0.6566 197499.9n 0.6566 197500.0n 0.4110 197749.9n 0.4110 197750.0n 0.6390 197999.9n 0.6390 198000.0n 0.4987 198249.9n 0.4987 198250.0n 0.4110 198499.9n 0.4110 198500.0n 0.4110 198749.9n 0.4110 198750.0n 0.4110 198999.9n 0.4110 199000.0n 0.4110 199249.9n 0.4110 199250.0n 0.4636 199499.9n 0.4636 199500.0n 0.4636 199749.9n 0.4636 199750.0n 0.4110 199999.9n 0.4110 200000.0n 0.6215 200249.9n 0.6215 200250.0n 0.5689 200499.9n 0.5689 200500.0n 0.4811 200749.9n 0.4811 200750.0n 0.4110 200999.9n 0.4110 201000.0n 0.5689 201249.9n 0.5689 201250.0n 0.6039 201499.9n 0.6039 201500.0n 0.7969 201749.9n 0.7969 201750.0n 0.5513 201999.9n 0.5513 202000.0n 0.6566 202249.9n 0.6566 202250.0n 0.5162 202499.9n 0.5162 202500.0n 0.5338 202749.9n 0.5338 202750.0n 0.5689 202999.9n 0.5689 203000.0n 0.4461 203249.9n 0.4461 203250.0n 0.4636 203499.9n 0.4636 203500.0n 0.5338 203749.9n 0.5338 203750.0n 0.4110 203999.9n 0.4110 204000.0n 0.5162 204249.9n 0.5162 204250.0n 0.4987 204499.9n 0.4987 204500.0n 0.4110 204749.9n 0.4110 204750.0n 0.6566 204999.9n 0.6566 205000.0n 0.4110 205249.9n 0.4110 205250.0n 0.6390 205499.9n 0.6390 205500.0n 0.4987 205749.9n 0.4987 205750.0n 0.4110 205999.9n 0.4110 206000.0n 0.4110 206249.9n 0.4110 206250.0n 0.4110 206499.9n 0.4110 206500.0n 0.4110 206749.9n 0.4110 206750.0n 0.4636 206999.9n 0.4636 207000.0n 0.4636 207249.9n 0.4636 207250.0n 0.4110 207499.9n 0.4110 207500.0n 0.6215 207749.9n 0.6215 207750.0n 0.5689 207999.9n 0.5689 208000.0n 0.4811 208249.9n 0.4811 208250.0n 0.4110 208499.9n 0.4110 208500.0n 0.5689 208749.9n 0.5689 208750.0n 0.6039 208999.9n 0.6039 209000.0n 0.7969 209249.9n 0.7969 209250.0n 0.5513 209499.9n 0.5513 209500.0n 0.6566 209749.9n 0.6566 209750.0n 0.5162 209999.9n 0.5162 210000.0n 0.5338 210249.9n 0.5338 210250.0n 0.5689 210499.9n 0.5689 210500.0n 0.4461 210749.9n 0.4461 210750.0n 0.4636 210999.9n 0.4636 211000.0n 0.5338 211249.9n 0.5338 211250.0n 0.4110 211499.9n 0.4110 211500.0n 0.5162 211749.9n 0.5162 211750.0n 0.4987 211999.9n 0.4987 212000.0n 0.4110 212249.9n 0.4110 212250.0n 0.6566 212499.9n 0.6566 212500.0n 0.4110 212749.9n 0.4110 212750.0n 0.6390 212999.9n 0.6390 213000.0n 0.4987 213249.9n 0.4987 213250.0n 0.4110 213499.9n 0.4110 213500.0n 0.4110 213749.9n 0.4110 213750.0n 0.4110 213999.9n 0.4110 214000.0n 0.4110 214249.9n 0.4110 214250.0n 0.4636 214499.9n 0.4636 214500.0n 0.4636 214749.9n 0.4636 214750.0n 0.4110 214999.9n 0.4110 215000.0n 0.6215 215249.9n 0.6215 215250.0n 0.5689 215499.9n 0.5689 215500.0n 0.4811 215749.9n 0.4811 215750.0n 0.4110 215999.9n 0.4110 216000.0n 0.5689 216249.9n 0.5689 216250.0n 0.6039 216499.9n 0.6039 216500.0n 0.7969 216749.9n 0.7969 216750.0n 0.5513 216999.9n 0.5513 217000.0n 0.6566 217249.9n 0.6566 217250.0n 0.5162 217499.9n 0.5162 217500.0n 0.5338 217749.9n 0.5338 217750.0n 0.5689 217999.9n 0.5689 218000.0n 0.4461 218249.9n 0.4461 218250.0n 0.4636 218499.9n 0.4636 218500.0n 0.5338 218749.9n 0.5338 218750.0n 0.4110 218999.9n 0.4110 219000.0n 0.5162 219249.9n 0.5162 219250.0n 0.4987 219499.9n 0.4987 219500.0n 0.4110 219749.9n 0.4110 219750.0n 0.6566 219999.9n 0.6566 220000.0n 0.4110 220249.9n 0.4110 220250.0n 0.6390 220499.9n 0.6390 220500.0n 0.4987 220749.9n 0.4987 220750.0n 0.4110 220999.9n 0.4110 221000.0n 0.4110 221249.9n 0.4110 221250.0n 0.4110 221499.9n 0.4110 221500.0n 0.4110 221749.9n 0.4110 221750.0n 0.4636 221999.9n 0.4636 222000.0n 0.4636 222249.9n 0.4636 222250.0n 0.4110 222499.9n 0.4110 222500.0n 0.6215 222749.9n 0.6215 222750.0n 0.5689 222999.9n 0.5689 223000.0n 0.4811 223249.9n 0.4811 223250.0n 0.4110 223499.9n 0.4110 223500.0n 0.5689 223749.9n 0.5689 223750.0n 0.6039 223999.9n 0.6039 224000.0n 0.7969 224249.9n 0.7969 224250.0n 0.5513 224499.9n 0.5513 224500.0n 0.6566 224749.9n 0.6566 224750.0n 0.5162 224999.9n 0.5162 225000.0n 0.5338 225249.9n 0.5338 225250.0n 0.5689 225499.9n 0.5689 225500.0n 0.4461 225749.9n 0.4461 225750.0n 0.4636 225999.9n 0.4636 226000.0n 0.5338 226249.9n 0.5338 226250.0n 0.4110 226499.9n 0.4110 226500.0n 0.5162 226749.9n 0.5162 226750.0n 0.4987 226999.9n 0.4987 227000.0n 0.4110 227249.9n 0.4110 227250.0n 0.6566 227499.9n 0.6566 227500.0n 0.4110 227749.9n 0.4110 227750.0n 0.6390 227999.9n 0.6390 228000.0n 0.4987 228249.9n 0.4987 228250.0n 0.4110 228499.9n 0.4110 228500.0n 0.4110 228749.9n 0.4110 228750.0n 0.4110 228999.9n 0.4110 229000.0n 0.4110 229249.9n 0.4110 229250.0n 0.4636 229499.9n 0.4636 229500.0n 0.4636 229749.9n 0.4636 229750.0n 0.4110 229999.9n 0.4110 230000.0n 0.6215 230249.9n 0.6215 230250.0n 0.5689 230499.9n 0.5689 230500.0n 0.4811 230749.9n 0.4811 230750.0n 0.4110 230999.9n 0.4110 231000.0n 0.5689 231249.9n 0.5689 231250.0n 0.6039 231499.9n 0.6039 231500.0n 0.7969 231749.9n 0.7969 231750.0n 0.5513 231999.9n 0.5513 232000.0n 0.6566 232249.9n 0.6566 232250.0n 0.5162 232499.9n 0.5162 232500.0n 0.5338 232749.9n 0.5338 232750.0n 0.5689 232999.9n 0.5689 233000.0n 0.4461 233249.9n 0.4461 233250.0n 0.4636 233499.9n 0.4636 233500.0n 0.5338 233749.9n 0.5338 233750.0n 0.4110 233999.9n 0.4110 234000.0n 0.5162 234249.9n 0.5162 234250.0n 0.4987 234499.9n 0.4987 234500.0n 0.4110 234749.9n 0.4110 234750.0n 0.6566 234999.9n 0.6566 235000.0n 0.4110 235249.9n 0.4110 235250.0n 0.6390 235499.9n 0.6390 235500.0n 0.4987 235749.9n 0.4987 235750.0n 0.4110 235999.9n 0.4110 236000.0n 0.4110 236249.9n 0.4110 236250.0n 0.4110 236499.9n 0.4110 236500.0n 0.4110 236749.9n 0.4110 236750.0n 0.4636 236999.9n 0.4636 237000.0n 0.4636 237249.9n 0.4636 237250.0n 0.4110 237499.9n 0.4110 237500.0n 0.6215 237749.9n 0.6215 237750.0n 0.5689 237999.9n 0.5689 238000.0n 0.4811 238249.9n 0.4811 238250.0n 0.4110 238499.9n 0.4110 238500.0n 0.5689 238749.9n 0.5689 238750.0n 0.6039 238999.9n 0.6039 239000.0n 0.7969 239249.9n 0.7969 239250.0n 0.5513 239499.9n 0.5513 239500.0n 0.6566 239749.9n 0.6566 239750.0n 0.5162 239999.9n 0.5162 240000.0n 0.5338 240249.9n 0.5338 240250.0n 0.5689 240499.9n 0.5689 240500.0n 0.4461 240749.9n 0.4461 240750.0n 0.4636 240999.9n 0.4636 241000.0n 0.5338 241249.9n 0.5338 241250.0n 0.4110 241499.9n 0.4110 241500.0n 0.5162 241749.9n 0.5162 241750.0n 0.4987 241999.9n 0.4987 242000.0n 0.4110 242249.9n 0.4110 242250.0n 0.6566 242499.9n 0.6566 242500.0n 0.4110 242749.9n 0.4110 242750.0n 0.6390 242999.9n 0.6390 243000.0n 0.4987 243249.9n 0.4987 243250.0n 0.4110 243499.9n 0.4110 243500.0n 0.4110 243749.9n 0.4110 243750.0n 0.4110 243999.9n 0.4110 244000.0n 0.4110 244249.9n 0.4110 244250.0n 0.4636 244499.9n 0.4636 244500.0n 0.4636 244749.9n 0.4636 244750.0n 0.4110 244999.9n 0.4110 245000.0n 0.6215 245249.9n 0.6215 245250.0n 0.5689 245499.9n 0.5689 245500.0n 0.4811 245749.9n 0.4811 245750.0n 0.4110 245999.9n 0.4110 246000.0n 0.5689 246249.9n 0.5689 246250.0n 0.6039 246499.9n 0.6039 246500.0n 0.7969 246749.9n 0.7969 246750.0n 0.5513 246999.9n 0.5513 247000.0n 0.6566 247249.9n 0.6566 247250.0n 0.5162 247499.9n 0.5162 247500.0n 0.5338 247749.9n 0.5338 247750.0n 0.5689 247999.9n 0.5689 248000.0n 0.4461 248249.9n 0.4461 248250.0n 0.4636 248499.9n 0.4636 248500.0n 0.5338 248749.9n 0.5338 248750.0n 0.4110 248999.9n 0.4110 249000.0n 0.5162 249249.9n 0.5162 249250.0n 0.4987 249499.9n 0.4987 249500.0n 0.4110 249749.9n 0.4110 249750.0n 0.6566 249999.9n 0.6566 250000.0n 0.4110 250249.9n 0.4110 250250.0n 0.6390 250499.9n 0.6390 250500.0n 0.4987 250749.9n 0.4987 250750.0n 0.4110 250999.9n 0.4110 251000.0n 0.4110 251249.9n 0.4110 251250.0n 0.4110 251499.9n 0.4110 251500.0n 0.4110 251749.9n 0.4110 251750.0n 0.4636 251999.9n 0.4636 252000.0n 0.4636 252249.9n 0.4636 252250.0n 0.4110 252499.9n 0.4110 252500.0n 0.6215 252749.9n 0.6215 252750.0n 0.5689 252999.9n 0.5689 253000.0n 0.4811 253249.9n 0.4811 253250.0n 0.4110 253499.9n 0.4110 253500.0n 0.5689 253749.9n 0.5689 253750.0n 0.6039 253999.9n 0.6039 254000.0n 0.7969 254249.9n 0.7969 254250.0n 0.5513 254499.9n 0.5513 254500.0n 0.6566 254749.9n 0.6566 254750.0n 0.5162 254999.9n 0.5162 255000.0n 0.5338 255249.9n 0.5338 255250.0n 0.5689 255499.9n 0.5689 255500.0n 0.4461 255749.9n 0.4461 255750.0n 0.4636 255999.9n 0.4636 256000.0n 0.5338 256249.9n 0.5338 256250.0n 0.4110 256499.9n 0.4110 256500.0n 0.5162 256749.9n 0.5162 256750.0n 0.4987 256999.9n 0.4987 257000.0n 0.4110 257249.9n 0.4110 257250.0n 0.6566 257499.9n 0.6566 257500.0n 0.4110 257749.9n 0.4110 257750.0n 0.6390 257999.9n 0.6390 258000.0n 0.4987 258249.9n 0.4987 258250.0n 0.4110 258499.9n 0.4110 258500.0n 0.4110 258749.9n 0.4110 258750.0n 0.4110 258999.9n 0.4110 259000.0n 0.4110 259249.9n 0.4110 259250.0n 0.4636 259499.9n 0.4636 259500.0n 0.4636 259749.9n 0.4636 259750.0n 0.4110 259999.9n 0.4110 260000.0n 0.6215 260249.9n 0.6215 260250.0n 0.5689 260499.9n 0.5689 260500.0n 0.4811 260749.9n 0.4811 260750.0n 0.4110 260999.9n 0.4110 261000.0n 0.5689 261249.9n 0.5689 261250.0n 0.6039 261499.9n 0.6039 261500.0n 0.7969 261749.9n 0.7969 261750.0n 0.5513 261999.9n 0.5513 262000.0n 0.6566 262249.9n 0.6566 262250.0n 0.5162 262499.9n 0.5162 262500.0n 0.5338 262749.9n 0.5338 262750.0n 0.5689 262999.9n 0.5689 263000.0n 0.4461 263249.9n 0.4461 263250.0n 0.4636 263499.9n 0.4636 263500.0n 0.5338 263749.9n 0.5338 263750.0n 0.4110 263999.9n 0.4110 264000.0n 0.5162 264249.9n 0.5162 264250.0n 0.4987 264499.9n 0.4987 264500.0n 0.4110 264749.9n 0.4110 264750.0n 0.6566 264999.9n 0.6566 265000.0n 0.4110 265249.9n 0.4110 265250.0n 0.6390 265499.9n 0.6390 265500.0n 0.4987 265749.9n 0.4987 265750.0n 0.4110 265999.9n 0.4110 266000.0n 0.4110 266249.9n 0.4110 266250.0n 0.4110 266499.9n 0.4110 266500.0n 0.4110 266749.9n 0.4110 266750.0n 0.4636 266999.9n 0.4636 267000.0n 0.4636 267249.9n 0.4636 267250.0n 0.4110 267499.9n 0.4110 267500.0n 0.6215 267749.9n 0.6215 267750.0n 0.5689 267999.9n 0.5689 268000.0n 0.4811 268249.9n 0.4811 268250.0n 0.4110 268499.9n 0.4110 268500.0n 0.5689 268749.9n 0.5689 268750.0n 0.6039 268999.9n 0.6039 269000.0n 0.7969 269249.9n 0.7969 269250.0n 0.5513 269499.9n 0.5513 269500.0n 0.6566 269749.9n 0.6566 269750.0n 0.5162 269999.9n 0.5162 270000.0n 0.5338 270249.9n 0.5338 270250.0n 0.5689 270499.9n 0.5689 270500.0n 0.4461 270749.9n 0.4461 270750.0n 0.4636 270999.9n 0.4636 271000.0n 0.5338 271249.9n 0.5338 271250.0n 0.4110 271499.9n 0.4110 271500.0n 0.5162 271749.9n 0.5162 271750.0n 0.4987 271999.9n 0.4987 272000.0n 0.4110 272249.9n 0.4110 272250.0n 0.6566 272499.9n 0.6566 272500.0n 0.4110 272749.9n 0.4110 272750.0n 0.6390 272999.9n 0.6390 273000.0n 0.4987 273249.9n 0.4987 273250.0n 0.4110 273499.9n 0.4110 273500.0n 0.4110 273749.9n 0.4110 273750.0n 0.4110 273999.9n 0.4110 274000.0n 0.4110 274249.9n 0.4110 274250.0n 0.4636 274499.9n 0.4636 274500.0n 0.4636 274749.9n 0.4636 274750.0n 0.4110 274999.9n 0.4110 275000.0n 0.6215 275249.9n 0.6215 275250.0n 0.5689 275499.9n 0.5689 275500.0n 0.4811 275749.9n 0.4811 275750.0n 0.4110 275999.9n 0.4110 276000.0n 0.5689 276249.9n 0.5689 276250.0n 0.6039 276499.9n 0.6039 276500.0n 0.7969 276749.9n 0.7969 276750.0n 0.5513 276999.9n 0.5513 277000.0n 0.6566 277249.9n 0.6566 277250.0n 0.5162 277499.9n 0.5162 277500.0n 0.5338 277749.9n 0.5338 277750.0n 0.5689 277999.9n 0.5689 278000.0n 0.4461 278249.9n 0.4461 278250.0n 0.4636 278499.9n 0.4636 278500.0n 0.5338 278749.9n 0.5338 278750.0n 0.4110 278999.9n 0.4110 279000.0n 0.5162 279249.9n 0.5162 279250.0n 0.4987 279499.9n 0.4987 279500.0n 0.4110 279749.9n 0.4110 279750.0n 0.6566 279999.9n 0.6566 280000.0n 0.4110 280249.9n 0.4110 280250.0n 0.6390 280499.9n 0.6390 280500.0n 0.4987 280749.9n 0.4987 280750.0n 0.4110 280999.9n 0.4110 281000.0n 0.4110 281249.9n 0.4110 281250.0n 0.4110 281499.9n 0.4110 281500.0n 0.4110 281749.9n 0.4110 281750.0n 0.4636 281999.9n 0.4636 282000.0n 0.4636 282249.9n 0.4636 282250.0n 0.4110 282499.9n 0.4110 282500.0n 0.6215 282749.9n 0.6215 282750.0n 0.5689 282999.9n 0.5689 283000.0n 0.4811 283249.9n 0.4811 283250.0n 0.4110 283499.9n 0.4110 283500.0n 0.5689 283749.9n 0.5689 283750.0n 0.6039 283999.9n 0.6039 284000.0n 0.7969 284249.9n 0.7969 284250.0n 0.5513 284499.9n 0.5513 284500.0n 0.6566 284749.9n 0.6566 284750.0n 0.5162 284999.9n 0.5162 285000.0n 0.5338 285249.9n 0.5338 285250.0n 0.5689 285499.9n 0.5689 285500.0n 0.4461 285749.9n 0.4461 285750.0n 0.4636 285999.9n 0.4636 286000.0n 0.5338 286249.9n 0.5338 286250.0n 0.4110 286499.9n 0.4110 286500.0n 0.5162 286749.9n 0.5162 286750.0n 0.4987 286999.9n 0.4987 287000.0n 0.4110 287249.9n 0.4110 287250.0n 0.6566 287499.9n 0.6566 287500.0n 0.4110 287749.9n 0.4110 287750.0n 0.6390 287999.9n 0.6390 288000.0n 0.4987 288249.9n 0.4987 288250.0n 0.4110 288499.9n 0.4110 288500.0n 0.4110 288749.9n 0.4110 288750.0n 0.4110 288999.9n 0.4110 289000.0n 0.4110 289249.9n 0.4110 289250.0n 0.4636 289499.9n 0.4636 289500.0n 0.4636 289749.9n 0.4636 289750.0n 0.4110 289999.9n 0.4110 290000.0n 0.6215 290249.9n 0.6215 290250.0n 0.5689 290499.9n 0.5689 290500.0n 0.4811 290749.9n 0.4811 290750.0n 0.4110 290999.9n 0.4110 291000.0n 0.5689 291249.9n 0.5689 291250.0n 0.6039 291499.9n 0.6039 291500.0n 0.7969 291749.9n 0.7969 291750.0n 0.5513 291999.9n 0.5513 292000.0n 0.6566 292249.9n 0.6566 292250.0n 0.5162 292499.9n 0.5162 292500.0n 0.5338 292749.9n 0.5338 292750.0n 0.5689 292999.9n 0.5689 293000.0n 0.4461 293249.9n 0.4461 293250.0n 0.4636 293499.9n 0.4636 293500.0n 0.5338 293749.9n 0.5338 293750.0n 0.4110 293999.9n 0.4110 294000.0n 0.5162 294249.9n 0.5162 294250.0n 0.4987 294499.9n 0.4987 294500.0n 0.4110 294749.9n 0.4110 294750.0n 0.6566 294999.9n 0.6566 295000.0n 0.4110 295249.9n 0.4110 295250.0n 0.6390 295499.9n 0.6390 295500.0n 0.4987 295749.9n 0.4987 295750.0n 0.4110 295999.9n 0.4110 296000.0n 0.4110 296249.9n 0.4110 296250.0n 0.4110 296499.9n 0.4110 296500.0n 0.4110 296749.9n 0.4110 296750.0n 0.4636 296999.9n 0.4636 297000.0n 0.4636 297249.9n 0.4636 297250.0n 0.4110 297499.9n 0.4110 297500.0n 0.6215 297749.9n 0.6215 297750.0n 0.5689 297999.9n 0.5689 298000.0n 0.4811 298249.9n 0.4811 298250.0n 0.4110 298499.9n 0.4110 298500.0n 0.5689 298749.9n 0.5689 298750.0n 0.6039 298999.9n 0.6039 299000.0n 0.7969 299249.9n 0.7969 299250.0n 0.5513 299499.9n 0.5513 299500.0n 0.6566 299749.9n 0.6566 299750.0n 0.5162)
Vxn4 a_xn4 0 PWL(0.0n 0.4662 249.9n 0.4662 250.0n 0.4311 499.9n 0.4311 500.0n 0.5539 749.9n 0.5539 750.0n 0.5364 999.9n 0.5364 1000.0n 0.4662 1249.9n 0.4662 1250.0n 0.5890 1499.9n 0.5890 1500.0n 0.4838 1749.9n 0.4838 1750.0n 0.5013 1999.9n 0.5013 2000.0n 0.5890 2249.9n 0.5890 2250.0n 0.3434 2499.9n 0.3434 2500.0n 0.5890 2749.9n 0.5890 2750.0n 0.3610 2999.9n 0.3610 3000.0n 0.5013 3249.9n 0.5013 3250.0n 0.5890 3499.9n 0.5890 3500.0n 0.5890 3749.9n 0.5890 3750.0n 0.5890 3999.9n 0.5890 4000.0n 0.5890 4249.9n 0.5890 4250.0n 0.5364 4499.9n 0.5364 4500.0n 0.5364 4749.9n 0.5364 4750.0n 0.5890 4999.9n 0.5890 5000.0n 0.3785 5249.9n 0.3785 5250.0n 0.4311 5499.9n 0.4311 5500.0n 0.5189 5749.9n 0.5189 5750.0n 0.5890 5999.9n 0.5890 6000.0n 0.4311 6249.9n 0.4311 6250.0n 0.3961 6499.9n 0.3961 6500.0n 0.2031 6749.9n 0.2031 6750.0n 0.4487 6999.9n 0.4487 7000.0n 0.3434 7249.9n 0.3434 7250.0n 0.4838 7499.9n 0.4838 7500.0n 0.4662 7749.9n 0.4662 7750.0n 0.4311 7999.9n 0.4311 8000.0n 0.5539 8249.9n 0.5539 8250.0n 0.5364 8499.9n 0.5364 8500.0n 0.4662 8749.9n 0.4662 8750.0n 0.5890 8999.9n 0.5890 9000.0n 0.4838 9249.9n 0.4838 9250.0n 0.5013 9499.9n 0.5013 9500.0n 0.5890 9749.9n 0.5890 9750.0n 0.3434 9999.9n 0.3434 10000.0n 0.5890 10249.9n 0.5890 10250.0n 0.3610 10499.9n 0.3610 10500.0n 0.5013 10749.9n 0.5013 10750.0n 0.5890 10999.9n 0.5890 11000.0n 0.5890 11249.9n 0.5890 11250.0n 0.5890 11499.9n 0.5890 11500.0n 0.5890 11749.9n 0.5890 11750.0n 0.5364 11999.9n 0.5364 12000.0n 0.5364 12249.9n 0.5364 12250.0n 0.5890 12499.9n 0.5890 12500.0n 0.3785 12749.9n 0.3785 12750.0n 0.4311 12999.9n 0.4311 13000.0n 0.5189 13249.9n 0.5189 13250.0n 0.5890 13499.9n 0.5890 13500.0n 0.4311 13749.9n 0.4311 13750.0n 0.3961 13999.9n 0.3961 14000.0n 0.2031 14249.9n 0.2031 14250.0n 0.4487 14499.9n 0.4487 14500.0n 0.3434 14749.9n 0.3434 14750.0n 0.4838 14999.9n 0.4838 15000.0n 0.4662 15249.9n 0.4662 15250.0n 0.4311 15499.9n 0.4311 15500.0n 0.5539 15749.9n 0.5539 15750.0n 0.5364 15999.9n 0.5364 16000.0n 0.4662 16249.9n 0.4662 16250.0n 0.5890 16499.9n 0.5890 16500.0n 0.4838 16749.9n 0.4838 16750.0n 0.5013 16999.9n 0.5013 17000.0n 0.5890 17249.9n 0.5890 17250.0n 0.3434 17499.9n 0.3434 17500.0n 0.5890 17749.9n 0.5890 17750.0n 0.3610 17999.9n 0.3610 18000.0n 0.5013 18249.9n 0.5013 18250.0n 0.5890 18499.9n 0.5890 18500.0n 0.5890 18749.9n 0.5890 18750.0n 0.5890 18999.9n 0.5890 19000.0n 0.5890 19249.9n 0.5890 19250.0n 0.5364 19499.9n 0.5364 19500.0n 0.5364 19749.9n 0.5364 19750.0n 0.5890 19999.9n 0.5890 20000.0n 0.3785 20249.9n 0.3785 20250.0n 0.4311 20499.9n 0.4311 20500.0n 0.5189 20749.9n 0.5189 20750.0n 0.5890 20999.9n 0.5890 21000.0n 0.4311 21249.9n 0.4311 21250.0n 0.3961 21499.9n 0.3961 21500.0n 0.2031 21749.9n 0.2031 21750.0n 0.4487 21999.9n 0.4487 22000.0n 0.3434 22249.9n 0.3434 22250.0n 0.4838 22499.9n 0.4838 22500.0n 0.4662 22749.9n 0.4662 22750.0n 0.4311 22999.9n 0.4311 23000.0n 0.5539 23249.9n 0.5539 23250.0n 0.5364 23499.9n 0.5364 23500.0n 0.4662 23749.9n 0.4662 23750.0n 0.5890 23999.9n 0.5890 24000.0n 0.4838 24249.9n 0.4838 24250.0n 0.5013 24499.9n 0.5013 24500.0n 0.5890 24749.9n 0.5890 24750.0n 0.3434 24999.9n 0.3434 25000.0n 0.5890 25249.9n 0.5890 25250.0n 0.3610 25499.9n 0.3610 25500.0n 0.5013 25749.9n 0.5013 25750.0n 0.5890 25999.9n 0.5890 26000.0n 0.5890 26249.9n 0.5890 26250.0n 0.5890 26499.9n 0.5890 26500.0n 0.5890 26749.9n 0.5890 26750.0n 0.5364 26999.9n 0.5364 27000.0n 0.5364 27249.9n 0.5364 27250.0n 0.5890 27499.9n 0.5890 27500.0n 0.3785 27749.9n 0.3785 27750.0n 0.4311 27999.9n 0.4311 28000.0n 0.5189 28249.9n 0.5189 28250.0n 0.5890 28499.9n 0.5890 28500.0n 0.4311 28749.9n 0.4311 28750.0n 0.3961 28999.9n 0.3961 29000.0n 0.2031 29249.9n 0.2031 29250.0n 0.4487 29499.9n 0.4487 29500.0n 0.3434 29749.9n 0.3434 29750.0n 0.4838 29999.9n 0.4838 30000.0n 0.4662 30249.9n 0.4662 30250.0n 0.4311 30499.9n 0.4311 30500.0n 0.5539 30749.9n 0.5539 30750.0n 0.5364 30999.9n 0.5364 31000.0n 0.4662 31249.9n 0.4662 31250.0n 0.5890 31499.9n 0.5890 31500.0n 0.4838 31749.9n 0.4838 31750.0n 0.5013 31999.9n 0.5013 32000.0n 0.5890 32249.9n 0.5890 32250.0n 0.3434 32499.9n 0.3434 32500.0n 0.5890 32749.9n 0.5890 32750.0n 0.3610 32999.9n 0.3610 33000.0n 0.5013 33249.9n 0.5013 33250.0n 0.5890 33499.9n 0.5890 33500.0n 0.5890 33749.9n 0.5890 33750.0n 0.5890 33999.9n 0.5890 34000.0n 0.5890 34249.9n 0.5890 34250.0n 0.5364 34499.9n 0.5364 34500.0n 0.5364 34749.9n 0.5364 34750.0n 0.5890 34999.9n 0.5890 35000.0n 0.3785 35249.9n 0.3785 35250.0n 0.4311 35499.9n 0.4311 35500.0n 0.5189 35749.9n 0.5189 35750.0n 0.5890 35999.9n 0.5890 36000.0n 0.4311 36249.9n 0.4311 36250.0n 0.3961 36499.9n 0.3961 36500.0n 0.2031 36749.9n 0.2031 36750.0n 0.4487 36999.9n 0.4487 37000.0n 0.3434 37249.9n 0.3434 37250.0n 0.4838 37499.9n 0.4838 37500.0n 0.4662 37749.9n 0.4662 37750.0n 0.4311 37999.9n 0.4311 38000.0n 0.5539 38249.9n 0.5539 38250.0n 0.5364 38499.9n 0.5364 38500.0n 0.4662 38749.9n 0.4662 38750.0n 0.5890 38999.9n 0.5890 39000.0n 0.4838 39249.9n 0.4838 39250.0n 0.5013 39499.9n 0.5013 39500.0n 0.5890 39749.9n 0.5890 39750.0n 0.3434 39999.9n 0.3434 40000.0n 0.5890 40249.9n 0.5890 40250.0n 0.3610 40499.9n 0.3610 40500.0n 0.5013 40749.9n 0.5013 40750.0n 0.5890 40999.9n 0.5890 41000.0n 0.5890 41249.9n 0.5890 41250.0n 0.5890 41499.9n 0.5890 41500.0n 0.5890 41749.9n 0.5890 41750.0n 0.5364 41999.9n 0.5364 42000.0n 0.5364 42249.9n 0.5364 42250.0n 0.5890 42499.9n 0.5890 42500.0n 0.3785 42749.9n 0.3785 42750.0n 0.4311 42999.9n 0.4311 43000.0n 0.5189 43249.9n 0.5189 43250.0n 0.5890 43499.9n 0.5890 43500.0n 0.4311 43749.9n 0.4311 43750.0n 0.3961 43999.9n 0.3961 44000.0n 0.2031 44249.9n 0.2031 44250.0n 0.4487 44499.9n 0.4487 44500.0n 0.3434 44749.9n 0.3434 44750.0n 0.4838 44999.9n 0.4838 45000.0n 0.4662 45249.9n 0.4662 45250.0n 0.4311 45499.9n 0.4311 45500.0n 0.5539 45749.9n 0.5539 45750.0n 0.5364 45999.9n 0.5364 46000.0n 0.4662 46249.9n 0.4662 46250.0n 0.5890 46499.9n 0.5890 46500.0n 0.4838 46749.9n 0.4838 46750.0n 0.5013 46999.9n 0.5013 47000.0n 0.5890 47249.9n 0.5890 47250.0n 0.3434 47499.9n 0.3434 47500.0n 0.5890 47749.9n 0.5890 47750.0n 0.3610 47999.9n 0.3610 48000.0n 0.5013 48249.9n 0.5013 48250.0n 0.5890 48499.9n 0.5890 48500.0n 0.5890 48749.9n 0.5890 48750.0n 0.5890 48999.9n 0.5890 49000.0n 0.5890 49249.9n 0.5890 49250.0n 0.5364 49499.9n 0.5364 49500.0n 0.5364 49749.9n 0.5364 49750.0n 0.5890 49999.9n 0.5890 50000.0n 0.3785 50249.9n 0.3785 50250.0n 0.4311 50499.9n 0.4311 50500.0n 0.5189 50749.9n 0.5189 50750.0n 0.5890 50999.9n 0.5890 51000.0n 0.4311 51249.9n 0.4311 51250.0n 0.3961 51499.9n 0.3961 51500.0n 0.2031 51749.9n 0.2031 51750.0n 0.4487 51999.9n 0.4487 52000.0n 0.3434 52249.9n 0.3434 52250.0n 0.4838 52499.9n 0.4838 52500.0n 0.4662 52749.9n 0.4662 52750.0n 0.4311 52999.9n 0.4311 53000.0n 0.5539 53249.9n 0.5539 53250.0n 0.5364 53499.9n 0.5364 53500.0n 0.4662 53749.9n 0.4662 53750.0n 0.5890 53999.9n 0.5890 54000.0n 0.4838 54249.9n 0.4838 54250.0n 0.5013 54499.9n 0.5013 54500.0n 0.5890 54749.9n 0.5890 54750.0n 0.3434 54999.9n 0.3434 55000.0n 0.5890 55249.9n 0.5890 55250.0n 0.3610 55499.9n 0.3610 55500.0n 0.5013 55749.9n 0.5013 55750.0n 0.5890 55999.9n 0.5890 56000.0n 0.5890 56249.9n 0.5890 56250.0n 0.5890 56499.9n 0.5890 56500.0n 0.5890 56749.9n 0.5890 56750.0n 0.5364 56999.9n 0.5364 57000.0n 0.5364 57249.9n 0.5364 57250.0n 0.5890 57499.9n 0.5890 57500.0n 0.3785 57749.9n 0.3785 57750.0n 0.4311 57999.9n 0.4311 58000.0n 0.5189 58249.9n 0.5189 58250.0n 0.5890 58499.9n 0.5890 58500.0n 0.4311 58749.9n 0.4311 58750.0n 0.3961 58999.9n 0.3961 59000.0n 0.2031 59249.9n 0.2031 59250.0n 0.4487 59499.9n 0.4487 59500.0n 0.3434 59749.9n 0.3434 59750.0n 0.4838 59999.9n 0.4838 60000.0n 0.4662 60249.9n 0.4662 60250.0n 0.4311 60499.9n 0.4311 60500.0n 0.5539 60749.9n 0.5539 60750.0n 0.5364 60999.9n 0.5364 61000.0n 0.4662 61249.9n 0.4662 61250.0n 0.5890 61499.9n 0.5890 61500.0n 0.4838 61749.9n 0.4838 61750.0n 0.5013 61999.9n 0.5013 62000.0n 0.5890 62249.9n 0.5890 62250.0n 0.3434 62499.9n 0.3434 62500.0n 0.5890 62749.9n 0.5890 62750.0n 0.3610 62999.9n 0.3610 63000.0n 0.5013 63249.9n 0.5013 63250.0n 0.5890 63499.9n 0.5890 63500.0n 0.5890 63749.9n 0.5890 63750.0n 0.5890 63999.9n 0.5890 64000.0n 0.5890 64249.9n 0.5890 64250.0n 0.5364 64499.9n 0.5364 64500.0n 0.5364 64749.9n 0.5364 64750.0n 0.5890 64999.9n 0.5890 65000.0n 0.3785 65249.9n 0.3785 65250.0n 0.4311 65499.9n 0.4311 65500.0n 0.5189 65749.9n 0.5189 65750.0n 0.5890 65999.9n 0.5890 66000.0n 0.4311 66249.9n 0.4311 66250.0n 0.3961 66499.9n 0.3961 66500.0n 0.2031 66749.9n 0.2031 66750.0n 0.4487 66999.9n 0.4487 67000.0n 0.3434 67249.9n 0.3434 67250.0n 0.4838 67499.9n 0.4838 67500.0n 0.4662 67749.9n 0.4662 67750.0n 0.4311 67999.9n 0.4311 68000.0n 0.5539 68249.9n 0.5539 68250.0n 0.5364 68499.9n 0.5364 68500.0n 0.4662 68749.9n 0.4662 68750.0n 0.5890 68999.9n 0.5890 69000.0n 0.4838 69249.9n 0.4838 69250.0n 0.5013 69499.9n 0.5013 69500.0n 0.5890 69749.9n 0.5890 69750.0n 0.3434 69999.9n 0.3434 70000.0n 0.5890 70249.9n 0.5890 70250.0n 0.3610 70499.9n 0.3610 70500.0n 0.5013 70749.9n 0.5013 70750.0n 0.5890 70999.9n 0.5890 71000.0n 0.5890 71249.9n 0.5890 71250.0n 0.5890 71499.9n 0.5890 71500.0n 0.5890 71749.9n 0.5890 71750.0n 0.5364 71999.9n 0.5364 72000.0n 0.5364 72249.9n 0.5364 72250.0n 0.5890 72499.9n 0.5890 72500.0n 0.3785 72749.9n 0.3785 72750.0n 0.4311 72999.9n 0.4311 73000.0n 0.5189 73249.9n 0.5189 73250.0n 0.5890 73499.9n 0.5890 73500.0n 0.4311 73749.9n 0.4311 73750.0n 0.3961 73999.9n 0.3961 74000.0n 0.2031 74249.9n 0.2031 74250.0n 0.4487 74499.9n 0.4487 74500.0n 0.3434 74749.9n 0.3434 74750.0n 0.4838 74999.9n 0.4838 75000.0n 0.4662 75249.9n 0.4662 75250.0n 0.4311 75499.9n 0.4311 75500.0n 0.5539 75749.9n 0.5539 75750.0n 0.5364 75999.9n 0.5364 76000.0n 0.4662 76249.9n 0.4662 76250.0n 0.5890 76499.9n 0.5890 76500.0n 0.4838 76749.9n 0.4838 76750.0n 0.5013 76999.9n 0.5013 77000.0n 0.5890 77249.9n 0.5890 77250.0n 0.3434 77499.9n 0.3434 77500.0n 0.5890 77749.9n 0.5890 77750.0n 0.3610 77999.9n 0.3610 78000.0n 0.5013 78249.9n 0.5013 78250.0n 0.5890 78499.9n 0.5890 78500.0n 0.5890 78749.9n 0.5890 78750.0n 0.5890 78999.9n 0.5890 79000.0n 0.5890 79249.9n 0.5890 79250.0n 0.5364 79499.9n 0.5364 79500.0n 0.5364 79749.9n 0.5364 79750.0n 0.5890 79999.9n 0.5890 80000.0n 0.3785 80249.9n 0.3785 80250.0n 0.4311 80499.9n 0.4311 80500.0n 0.5189 80749.9n 0.5189 80750.0n 0.5890 80999.9n 0.5890 81000.0n 0.4311 81249.9n 0.4311 81250.0n 0.3961 81499.9n 0.3961 81500.0n 0.2031 81749.9n 0.2031 81750.0n 0.4487 81999.9n 0.4487 82000.0n 0.3434 82249.9n 0.3434 82250.0n 0.4838 82499.9n 0.4838 82500.0n 0.4662 82749.9n 0.4662 82750.0n 0.4311 82999.9n 0.4311 83000.0n 0.5539 83249.9n 0.5539 83250.0n 0.5364 83499.9n 0.5364 83500.0n 0.4662 83749.9n 0.4662 83750.0n 0.5890 83999.9n 0.5890 84000.0n 0.4838 84249.9n 0.4838 84250.0n 0.5013 84499.9n 0.5013 84500.0n 0.5890 84749.9n 0.5890 84750.0n 0.3434 84999.9n 0.3434 85000.0n 0.5890 85249.9n 0.5890 85250.0n 0.3610 85499.9n 0.3610 85500.0n 0.5013 85749.9n 0.5013 85750.0n 0.5890 85999.9n 0.5890 86000.0n 0.5890 86249.9n 0.5890 86250.0n 0.5890 86499.9n 0.5890 86500.0n 0.5890 86749.9n 0.5890 86750.0n 0.5364 86999.9n 0.5364 87000.0n 0.5364 87249.9n 0.5364 87250.0n 0.5890 87499.9n 0.5890 87500.0n 0.3785 87749.9n 0.3785 87750.0n 0.4311 87999.9n 0.4311 88000.0n 0.5189 88249.9n 0.5189 88250.0n 0.5890 88499.9n 0.5890 88500.0n 0.4311 88749.9n 0.4311 88750.0n 0.3961 88999.9n 0.3961 89000.0n 0.2031 89249.9n 0.2031 89250.0n 0.4487 89499.9n 0.4487 89500.0n 0.3434 89749.9n 0.3434 89750.0n 0.4838 89999.9n 0.4838 90000.0n 0.4662 90249.9n 0.4662 90250.0n 0.4311 90499.9n 0.4311 90500.0n 0.5539 90749.9n 0.5539 90750.0n 0.5364 90999.9n 0.5364 91000.0n 0.4662 91249.9n 0.4662 91250.0n 0.5890 91499.9n 0.5890 91500.0n 0.4838 91749.9n 0.4838 91750.0n 0.5013 91999.9n 0.5013 92000.0n 0.5890 92249.9n 0.5890 92250.0n 0.3434 92499.9n 0.3434 92500.0n 0.5890 92749.9n 0.5890 92750.0n 0.3610 92999.9n 0.3610 93000.0n 0.5013 93249.9n 0.5013 93250.0n 0.5890 93499.9n 0.5890 93500.0n 0.5890 93749.9n 0.5890 93750.0n 0.5890 93999.9n 0.5890 94000.0n 0.5890 94249.9n 0.5890 94250.0n 0.5364 94499.9n 0.5364 94500.0n 0.5364 94749.9n 0.5364 94750.0n 0.5890 94999.9n 0.5890 95000.0n 0.3785 95249.9n 0.3785 95250.0n 0.4311 95499.9n 0.4311 95500.0n 0.5189 95749.9n 0.5189 95750.0n 0.5890 95999.9n 0.5890 96000.0n 0.4311 96249.9n 0.4311 96250.0n 0.3961 96499.9n 0.3961 96500.0n 0.2031 96749.9n 0.2031 96750.0n 0.4487 96999.9n 0.4487 97000.0n 0.3434 97249.9n 0.3434 97250.0n 0.4838 97499.9n 0.4838 97500.0n 0.4662 97749.9n 0.4662 97750.0n 0.4311 97999.9n 0.4311 98000.0n 0.5539 98249.9n 0.5539 98250.0n 0.5364 98499.9n 0.5364 98500.0n 0.4662 98749.9n 0.4662 98750.0n 0.5890 98999.9n 0.5890 99000.0n 0.4838 99249.9n 0.4838 99250.0n 0.5013 99499.9n 0.5013 99500.0n 0.5890 99749.9n 0.5890 99750.0n 0.3434 99999.9n 0.3434 100000.0n 0.5890 100249.9n 0.5890 100250.0n 0.3610 100499.9n 0.3610 100500.0n 0.5013 100749.9n 0.5013 100750.0n 0.5890 100999.9n 0.5890 101000.0n 0.5890 101249.9n 0.5890 101250.0n 0.5890 101499.9n 0.5890 101500.0n 0.5890 101749.9n 0.5890 101750.0n 0.5364 101999.9n 0.5364 102000.0n 0.5364 102249.9n 0.5364 102250.0n 0.5890 102499.9n 0.5890 102500.0n 0.3785 102749.9n 0.3785 102750.0n 0.4311 102999.9n 0.4311 103000.0n 0.5189 103249.9n 0.5189 103250.0n 0.5890 103499.9n 0.5890 103500.0n 0.4311 103749.9n 0.4311 103750.0n 0.3961 103999.9n 0.3961 104000.0n 0.2031 104249.9n 0.2031 104250.0n 0.4487 104499.9n 0.4487 104500.0n 0.3434 104749.9n 0.3434 104750.0n 0.4838 104999.9n 0.4838 105000.0n 0.4662 105249.9n 0.4662 105250.0n 0.4311 105499.9n 0.4311 105500.0n 0.5539 105749.9n 0.5539 105750.0n 0.5364 105999.9n 0.5364 106000.0n 0.4662 106249.9n 0.4662 106250.0n 0.5890 106499.9n 0.5890 106500.0n 0.4838 106749.9n 0.4838 106750.0n 0.5013 106999.9n 0.5013 107000.0n 0.5890 107249.9n 0.5890 107250.0n 0.3434 107499.9n 0.3434 107500.0n 0.5890 107749.9n 0.5890 107750.0n 0.3610 107999.9n 0.3610 108000.0n 0.5013 108249.9n 0.5013 108250.0n 0.5890 108499.9n 0.5890 108500.0n 0.5890 108749.9n 0.5890 108750.0n 0.5890 108999.9n 0.5890 109000.0n 0.5890 109249.9n 0.5890 109250.0n 0.5364 109499.9n 0.5364 109500.0n 0.5364 109749.9n 0.5364 109750.0n 0.5890 109999.9n 0.5890 110000.0n 0.3785 110249.9n 0.3785 110250.0n 0.4311 110499.9n 0.4311 110500.0n 0.5189 110749.9n 0.5189 110750.0n 0.5890 110999.9n 0.5890 111000.0n 0.4311 111249.9n 0.4311 111250.0n 0.3961 111499.9n 0.3961 111500.0n 0.2031 111749.9n 0.2031 111750.0n 0.4487 111999.9n 0.4487 112000.0n 0.3434 112249.9n 0.3434 112250.0n 0.4838 112499.9n 0.4838 112500.0n 0.4662 112749.9n 0.4662 112750.0n 0.4311 112999.9n 0.4311 113000.0n 0.5539 113249.9n 0.5539 113250.0n 0.5364 113499.9n 0.5364 113500.0n 0.4662 113749.9n 0.4662 113750.0n 0.5890 113999.9n 0.5890 114000.0n 0.4838 114249.9n 0.4838 114250.0n 0.5013 114499.9n 0.5013 114500.0n 0.5890 114749.9n 0.5890 114750.0n 0.3434 114999.9n 0.3434 115000.0n 0.5890 115249.9n 0.5890 115250.0n 0.3610 115499.9n 0.3610 115500.0n 0.5013 115749.9n 0.5013 115750.0n 0.5890 115999.9n 0.5890 116000.0n 0.5890 116249.9n 0.5890 116250.0n 0.5890 116499.9n 0.5890 116500.0n 0.5890 116749.9n 0.5890 116750.0n 0.5364 116999.9n 0.5364 117000.0n 0.5364 117249.9n 0.5364 117250.0n 0.5890 117499.9n 0.5890 117500.0n 0.3785 117749.9n 0.3785 117750.0n 0.4311 117999.9n 0.4311 118000.0n 0.5189 118249.9n 0.5189 118250.0n 0.5890 118499.9n 0.5890 118500.0n 0.4311 118749.9n 0.4311 118750.0n 0.3961 118999.9n 0.3961 119000.0n 0.2031 119249.9n 0.2031 119250.0n 0.4487 119499.9n 0.4487 119500.0n 0.3434 119749.9n 0.3434 119750.0n 0.4838 119999.9n 0.4838 120000.0n 0.4662 120249.9n 0.4662 120250.0n 0.4311 120499.9n 0.4311 120500.0n 0.5539 120749.9n 0.5539 120750.0n 0.5364 120999.9n 0.5364 121000.0n 0.4662 121249.9n 0.4662 121250.0n 0.5890 121499.9n 0.5890 121500.0n 0.4838 121749.9n 0.4838 121750.0n 0.5013 121999.9n 0.5013 122000.0n 0.5890 122249.9n 0.5890 122250.0n 0.3434 122499.9n 0.3434 122500.0n 0.5890 122749.9n 0.5890 122750.0n 0.3610 122999.9n 0.3610 123000.0n 0.5013 123249.9n 0.5013 123250.0n 0.5890 123499.9n 0.5890 123500.0n 0.5890 123749.9n 0.5890 123750.0n 0.5890 123999.9n 0.5890 124000.0n 0.5890 124249.9n 0.5890 124250.0n 0.5364 124499.9n 0.5364 124500.0n 0.5364 124749.9n 0.5364 124750.0n 0.5890 124999.9n 0.5890 125000.0n 0.3785 125249.9n 0.3785 125250.0n 0.4311 125499.9n 0.4311 125500.0n 0.5189 125749.9n 0.5189 125750.0n 0.5890 125999.9n 0.5890 126000.0n 0.4311 126249.9n 0.4311 126250.0n 0.3961 126499.9n 0.3961 126500.0n 0.2031 126749.9n 0.2031 126750.0n 0.4487 126999.9n 0.4487 127000.0n 0.3434 127249.9n 0.3434 127250.0n 0.4838 127499.9n 0.4838 127500.0n 0.4662 127749.9n 0.4662 127750.0n 0.4311 127999.9n 0.4311 128000.0n 0.5539 128249.9n 0.5539 128250.0n 0.5364 128499.9n 0.5364 128500.0n 0.4662 128749.9n 0.4662 128750.0n 0.5890 128999.9n 0.5890 129000.0n 0.4838 129249.9n 0.4838 129250.0n 0.5013 129499.9n 0.5013 129500.0n 0.5890 129749.9n 0.5890 129750.0n 0.3434 129999.9n 0.3434 130000.0n 0.5890 130249.9n 0.5890 130250.0n 0.3610 130499.9n 0.3610 130500.0n 0.5013 130749.9n 0.5013 130750.0n 0.5890 130999.9n 0.5890 131000.0n 0.5890 131249.9n 0.5890 131250.0n 0.5890 131499.9n 0.5890 131500.0n 0.5890 131749.9n 0.5890 131750.0n 0.5364 131999.9n 0.5364 132000.0n 0.5364 132249.9n 0.5364 132250.0n 0.5890 132499.9n 0.5890 132500.0n 0.3785 132749.9n 0.3785 132750.0n 0.4311 132999.9n 0.4311 133000.0n 0.5189 133249.9n 0.5189 133250.0n 0.5890 133499.9n 0.5890 133500.0n 0.4311 133749.9n 0.4311 133750.0n 0.3961 133999.9n 0.3961 134000.0n 0.2031 134249.9n 0.2031 134250.0n 0.4487 134499.9n 0.4487 134500.0n 0.3434 134749.9n 0.3434 134750.0n 0.4838 134999.9n 0.4838 135000.0n 0.4662 135249.9n 0.4662 135250.0n 0.4311 135499.9n 0.4311 135500.0n 0.5539 135749.9n 0.5539 135750.0n 0.5364 135999.9n 0.5364 136000.0n 0.4662 136249.9n 0.4662 136250.0n 0.5890 136499.9n 0.5890 136500.0n 0.4838 136749.9n 0.4838 136750.0n 0.5013 136999.9n 0.5013 137000.0n 0.5890 137249.9n 0.5890 137250.0n 0.3434 137499.9n 0.3434 137500.0n 0.5890 137749.9n 0.5890 137750.0n 0.3610 137999.9n 0.3610 138000.0n 0.5013 138249.9n 0.5013 138250.0n 0.5890 138499.9n 0.5890 138500.0n 0.5890 138749.9n 0.5890 138750.0n 0.5890 138999.9n 0.5890 139000.0n 0.5890 139249.9n 0.5890 139250.0n 0.5364 139499.9n 0.5364 139500.0n 0.5364 139749.9n 0.5364 139750.0n 0.5890 139999.9n 0.5890 140000.0n 0.3785 140249.9n 0.3785 140250.0n 0.4311 140499.9n 0.4311 140500.0n 0.5189 140749.9n 0.5189 140750.0n 0.5890 140999.9n 0.5890 141000.0n 0.4311 141249.9n 0.4311 141250.0n 0.3961 141499.9n 0.3961 141500.0n 0.2031 141749.9n 0.2031 141750.0n 0.4487 141999.9n 0.4487 142000.0n 0.3434 142249.9n 0.3434 142250.0n 0.4838 142499.9n 0.4838 142500.0n 0.4662 142749.9n 0.4662 142750.0n 0.4311 142999.9n 0.4311 143000.0n 0.5539 143249.9n 0.5539 143250.0n 0.5364 143499.9n 0.5364 143500.0n 0.4662 143749.9n 0.4662 143750.0n 0.5890 143999.9n 0.5890 144000.0n 0.4838 144249.9n 0.4838 144250.0n 0.5013 144499.9n 0.5013 144500.0n 0.5890 144749.9n 0.5890 144750.0n 0.3434 144999.9n 0.3434 145000.0n 0.5890 145249.9n 0.5890 145250.0n 0.3610 145499.9n 0.3610 145500.0n 0.5013 145749.9n 0.5013 145750.0n 0.5890 145999.9n 0.5890 146000.0n 0.5890 146249.9n 0.5890 146250.0n 0.5890 146499.9n 0.5890 146500.0n 0.5890 146749.9n 0.5890 146750.0n 0.5364 146999.9n 0.5364 147000.0n 0.5364 147249.9n 0.5364 147250.0n 0.5890 147499.9n 0.5890 147500.0n 0.3785 147749.9n 0.3785 147750.0n 0.4311 147999.9n 0.4311 148000.0n 0.5189 148249.9n 0.5189 148250.0n 0.5890 148499.9n 0.5890 148500.0n 0.4311 148749.9n 0.4311 148750.0n 0.3961 148999.9n 0.3961 149000.0n 0.2031 149249.9n 0.2031 149250.0n 0.4487 149499.9n 0.4487 149500.0n 0.3434 149749.9n 0.3434 149750.0n 0.4838 149999.9n 0.4838 150000.0n 0.4662 150249.9n 0.4662 150250.0n 0.4311 150499.9n 0.4311 150500.0n 0.5539 150749.9n 0.5539 150750.0n 0.5364 150999.9n 0.5364 151000.0n 0.4662 151249.9n 0.4662 151250.0n 0.5890 151499.9n 0.5890 151500.0n 0.4838 151749.9n 0.4838 151750.0n 0.5013 151999.9n 0.5013 152000.0n 0.5890 152249.9n 0.5890 152250.0n 0.3434 152499.9n 0.3434 152500.0n 0.5890 152749.9n 0.5890 152750.0n 0.3610 152999.9n 0.3610 153000.0n 0.5013 153249.9n 0.5013 153250.0n 0.5890 153499.9n 0.5890 153500.0n 0.5890 153749.9n 0.5890 153750.0n 0.5890 153999.9n 0.5890 154000.0n 0.5890 154249.9n 0.5890 154250.0n 0.5364 154499.9n 0.5364 154500.0n 0.5364 154749.9n 0.5364 154750.0n 0.5890 154999.9n 0.5890 155000.0n 0.3785 155249.9n 0.3785 155250.0n 0.4311 155499.9n 0.4311 155500.0n 0.5189 155749.9n 0.5189 155750.0n 0.5890 155999.9n 0.5890 156000.0n 0.4311 156249.9n 0.4311 156250.0n 0.3961 156499.9n 0.3961 156500.0n 0.2031 156749.9n 0.2031 156750.0n 0.4487 156999.9n 0.4487 157000.0n 0.3434 157249.9n 0.3434 157250.0n 0.4838 157499.9n 0.4838 157500.0n 0.4662 157749.9n 0.4662 157750.0n 0.4311 157999.9n 0.4311 158000.0n 0.5539 158249.9n 0.5539 158250.0n 0.5364 158499.9n 0.5364 158500.0n 0.4662 158749.9n 0.4662 158750.0n 0.5890 158999.9n 0.5890 159000.0n 0.4838 159249.9n 0.4838 159250.0n 0.5013 159499.9n 0.5013 159500.0n 0.5890 159749.9n 0.5890 159750.0n 0.3434 159999.9n 0.3434 160000.0n 0.5890 160249.9n 0.5890 160250.0n 0.3610 160499.9n 0.3610 160500.0n 0.5013 160749.9n 0.5013 160750.0n 0.5890 160999.9n 0.5890 161000.0n 0.5890 161249.9n 0.5890 161250.0n 0.5890 161499.9n 0.5890 161500.0n 0.5890 161749.9n 0.5890 161750.0n 0.5364 161999.9n 0.5364 162000.0n 0.5364 162249.9n 0.5364 162250.0n 0.5890 162499.9n 0.5890 162500.0n 0.3785 162749.9n 0.3785 162750.0n 0.4311 162999.9n 0.4311 163000.0n 0.5189 163249.9n 0.5189 163250.0n 0.5890 163499.9n 0.5890 163500.0n 0.4311 163749.9n 0.4311 163750.0n 0.3961 163999.9n 0.3961 164000.0n 0.2031 164249.9n 0.2031 164250.0n 0.4487 164499.9n 0.4487 164500.0n 0.3434 164749.9n 0.3434 164750.0n 0.4838 164999.9n 0.4838 165000.0n 0.4662 165249.9n 0.4662 165250.0n 0.4311 165499.9n 0.4311 165500.0n 0.5539 165749.9n 0.5539 165750.0n 0.5364 165999.9n 0.5364 166000.0n 0.4662 166249.9n 0.4662 166250.0n 0.5890 166499.9n 0.5890 166500.0n 0.4838 166749.9n 0.4838 166750.0n 0.5013 166999.9n 0.5013 167000.0n 0.5890 167249.9n 0.5890 167250.0n 0.3434 167499.9n 0.3434 167500.0n 0.5890 167749.9n 0.5890 167750.0n 0.3610 167999.9n 0.3610 168000.0n 0.5013 168249.9n 0.5013 168250.0n 0.5890 168499.9n 0.5890 168500.0n 0.5890 168749.9n 0.5890 168750.0n 0.5890 168999.9n 0.5890 169000.0n 0.5890 169249.9n 0.5890 169250.0n 0.5364 169499.9n 0.5364 169500.0n 0.5364 169749.9n 0.5364 169750.0n 0.5890 169999.9n 0.5890 170000.0n 0.3785 170249.9n 0.3785 170250.0n 0.4311 170499.9n 0.4311 170500.0n 0.5189 170749.9n 0.5189 170750.0n 0.5890 170999.9n 0.5890 171000.0n 0.4311 171249.9n 0.4311 171250.0n 0.3961 171499.9n 0.3961 171500.0n 0.2031 171749.9n 0.2031 171750.0n 0.4487 171999.9n 0.4487 172000.0n 0.3434 172249.9n 0.3434 172250.0n 0.4838 172499.9n 0.4838 172500.0n 0.4662 172749.9n 0.4662 172750.0n 0.4311 172999.9n 0.4311 173000.0n 0.5539 173249.9n 0.5539 173250.0n 0.5364 173499.9n 0.5364 173500.0n 0.4662 173749.9n 0.4662 173750.0n 0.5890 173999.9n 0.5890 174000.0n 0.4838 174249.9n 0.4838 174250.0n 0.5013 174499.9n 0.5013 174500.0n 0.5890 174749.9n 0.5890 174750.0n 0.3434 174999.9n 0.3434 175000.0n 0.5890 175249.9n 0.5890 175250.0n 0.3610 175499.9n 0.3610 175500.0n 0.5013 175749.9n 0.5013 175750.0n 0.5890 175999.9n 0.5890 176000.0n 0.5890 176249.9n 0.5890 176250.0n 0.5890 176499.9n 0.5890 176500.0n 0.5890 176749.9n 0.5890 176750.0n 0.5364 176999.9n 0.5364 177000.0n 0.5364 177249.9n 0.5364 177250.0n 0.5890 177499.9n 0.5890 177500.0n 0.3785 177749.9n 0.3785 177750.0n 0.4311 177999.9n 0.4311 178000.0n 0.5189 178249.9n 0.5189 178250.0n 0.5890 178499.9n 0.5890 178500.0n 0.4311 178749.9n 0.4311 178750.0n 0.3961 178999.9n 0.3961 179000.0n 0.2031 179249.9n 0.2031 179250.0n 0.4487 179499.9n 0.4487 179500.0n 0.3434 179749.9n 0.3434 179750.0n 0.4838 179999.9n 0.4838 180000.0n 0.4662 180249.9n 0.4662 180250.0n 0.4311 180499.9n 0.4311 180500.0n 0.5539 180749.9n 0.5539 180750.0n 0.5364 180999.9n 0.5364 181000.0n 0.4662 181249.9n 0.4662 181250.0n 0.5890 181499.9n 0.5890 181500.0n 0.4838 181749.9n 0.4838 181750.0n 0.5013 181999.9n 0.5013 182000.0n 0.5890 182249.9n 0.5890 182250.0n 0.3434 182499.9n 0.3434 182500.0n 0.5890 182749.9n 0.5890 182750.0n 0.3610 182999.9n 0.3610 183000.0n 0.5013 183249.9n 0.5013 183250.0n 0.5890 183499.9n 0.5890 183500.0n 0.5890 183749.9n 0.5890 183750.0n 0.5890 183999.9n 0.5890 184000.0n 0.5890 184249.9n 0.5890 184250.0n 0.5364 184499.9n 0.5364 184500.0n 0.5364 184749.9n 0.5364 184750.0n 0.5890 184999.9n 0.5890 185000.0n 0.3785 185249.9n 0.3785 185250.0n 0.4311 185499.9n 0.4311 185500.0n 0.5189 185749.9n 0.5189 185750.0n 0.5890 185999.9n 0.5890 186000.0n 0.4311 186249.9n 0.4311 186250.0n 0.3961 186499.9n 0.3961 186500.0n 0.2031 186749.9n 0.2031 186750.0n 0.4487 186999.9n 0.4487 187000.0n 0.3434 187249.9n 0.3434 187250.0n 0.4838 187499.9n 0.4838 187500.0n 0.4662 187749.9n 0.4662 187750.0n 0.4311 187999.9n 0.4311 188000.0n 0.5539 188249.9n 0.5539 188250.0n 0.5364 188499.9n 0.5364 188500.0n 0.4662 188749.9n 0.4662 188750.0n 0.5890 188999.9n 0.5890 189000.0n 0.4838 189249.9n 0.4838 189250.0n 0.5013 189499.9n 0.5013 189500.0n 0.5890 189749.9n 0.5890 189750.0n 0.3434 189999.9n 0.3434 190000.0n 0.5890 190249.9n 0.5890 190250.0n 0.3610 190499.9n 0.3610 190500.0n 0.5013 190749.9n 0.5013 190750.0n 0.5890 190999.9n 0.5890 191000.0n 0.5890 191249.9n 0.5890 191250.0n 0.5890 191499.9n 0.5890 191500.0n 0.5890 191749.9n 0.5890 191750.0n 0.5364 191999.9n 0.5364 192000.0n 0.5364 192249.9n 0.5364 192250.0n 0.5890 192499.9n 0.5890 192500.0n 0.3785 192749.9n 0.3785 192750.0n 0.4311 192999.9n 0.4311 193000.0n 0.5189 193249.9n 0.5189 193250.0n 0.5890 193499.9n 0.5890 193500.0n 0.4311 193749.9n 0.4311 193750.0n 0.3961 193999.9n 0.3961 194000.0n 0.2031 194249.9n 0.2031 194250.0n 0.4487 194499.9n 0.4487 194500.0n 0.3434 194749.9n 0.3434 194750.0n 0.4838 194999.9n 0.4838 195000.0n 0.4662 195249.9n 0.4662 195250.0n 0.4311 195499.9n 0.4311 195500.0n 0.5539 195749.9n 0.5539 195750.0n 0.5364 195999.9n 0.5364 196000.0n 0.4662 196249.9n 0.4662 196250.0n 0.5890 196499.9n 0.5890 196500.0n 0.4838 196749.9n 0.4838 196750.0n 0.5013 196999.9n 0.5013 197000.0n 0.5890 197249.9n 0.5890 197250.0n 0.3434 197499.9n 0.3434 197500.0n 0.5890 197749.9n 0.5890 197750.0n 0.3610 197999.9n 0.3610 198000.0n 0.5013 198249.9n 0.5013 198250.0n 0.5890 198499.9n 0.5890 198500.0n 0.5890 198749.9n 0.5890 198750.0n 0.5890 198999.9n 0.5890 199000.0n 0.5890 199249.9n 0.5890 199250.0n 0.5364 199499.9n 0.5364 199500.0n 0.5364 199749.9n 0.5364 199750.0n 0.5890 199999.9n 0.5890 200000.0n 0.3785 200249.9n 0.3785 200250.0n 0.4311 200499.9n 0.4311 200500.0n 0.5189 200749.9n 0.5189 200750.0n 0.5890 200999.9n 0.5890 201000.0n 0.4311 201249.9n 0.4311 201250.0n 0.3961 201499.9n 0.3961 201500.0n 0.2031 201749.9n 0.2031 201750.0n 0.4487 201999.9n 0.4487 202000.0n 0.3434 202249.9n 0.3434 202250.0n 0.4838 202499.9n 0.4838 202500.0n 0.4662 202749.9n 0.4662 202750.0n 0.4311 202999.9n 0.4311 203000.0n 0.5539 203249.9n 0.5539 203250.0n 0.5364 203499.9n 0.5364 203500.0n 0.4662 203749.9n 0.4662 203750.0n 0.5890 203999.9n 0.5890 204000.0n 0.4838 204249.9n 0.4838 204250.0n 0.5013 204499.9n 0.5013 204500.0n 0.5890 204749.9n 0.5890 204750.0n 0.3434 204999.9n 0.3434 205000.0n 0.5890 205249.9n 0.5890 205250.0n 0.3610 205499.9n 0.3610 205500.0n 0.5013 205749.9n 0.5013 205750.0n 0.5890 205999.9n 0.5890 206000.0n 0.5890 206249.9n 0.5890 206250.0n 0.5890 206499.9n 0.5890 206500.0n 0.5890 206749.9n 0.5890 206750.0n 0.5364 206999.9n 0.5364 207000.0n 0.5364 207249.9n 0.5364 207250.0n 0.5890 207499.9n 0.5890 207500.0n 0.3785 207749.9n 0.3785 207750.0n 0.4311 207999.9n 0.4311 208000.0n 0.5189 208249.9n 0.5189 208250.0n 0.5890 208499.9n 0.5890 208500.0n 0.4311 208749.9n 0.4311 208750.0n 0.3961 208999.9n 0.3961 209000.0n 0.2031 209249.9n 0.2031 209250.0n 0.4487 209499.9n 0.4487 209500.0n 0.3434 209749.9n 0.3434 209750.0n 0.4838 209999.9n 0.4838 210000.0n 0.4662 210249.9n 0.4662 210250.0n 0.4311 210499.9n 0.4311 210500.0n 0.5539 210749.9n 0.5539 210750.0n 0.5364 210999.9n 0.5364 211000.0n 0.4662 211249.9n 0.4662 211250.0n 0.5890 211499.9n 0.5890 211500.0n 0.4838 211749.9n 0.4838 211750.0n 0.5013 211999.9n 0.5013 212000.0n 0.5890 212249.9n 0.5890 212250.0n 0.3434 212499.9n 0.3434 212500.0n 0.5890 212749.9n 0.5890 212750.0n 0.3610 212999.9n 0.3610 213000.0n 0.5013 213249.9n 0.5013 213250.0n 0.5890 213499.9n 0.5890 213500.0n 0.5890 213749.9n 0.5890 213750.0n 0.5890 213999.9n 0.5890 214000.0n 0.5890 214249.9n 0.5890 214250.0n 0.5364 214499.9n 0.5364 214500.0n 0.5364 214749.9n 0.5364 214750.0n 0.5890 214999.9n 0.5890 215000.0n 0.3785 215249.9n 0.3785 215250.0n 0.4311 215499.9n 0.4311 215500.0n 0.5189 215749.9n 0.5189 215750.0n 0.5890 215999.9n 0.5890 216000.0n 0.4311 216249.9n 0.4311 216250.0n 0.3961 216499.9n 0.3961 216500.0n 0.2031 216749.9n 0.2031 216750.0n 0.4487 216999.9n 0.4487 217000.0n 0.3434 217249.9n 0.3434 217250.0n 0.4838 217499.9n 0.4838 217500.0n 0.4662 217749.9n 0.4662 217750.0n 0.4311 217999.9n 0.4311 218000.0n 0.5539 218249.9n 0.5539 218250.0n 0.5364 218499.9n 0.5364 218500.0n 0.4662 218749.9n 0.4662 218750.0n 0.5890 218999.9n 0.5890 219000.0n 0.4838 219249.9n 0.4838 219250.0n 0.5013 219499.9n 0.5013 219500.0n 0.5890 219749.9n 0.5890 219750.0n 0.3434 219999.9n 0.3434 220000.0n 0.5890 220249.9n 0.5890 220250.0n 0.3610 220499.9n 0.3610 220500.0n 0.5013 220749.9n 0.5013 220750.0n 0.5890 220999.9n 0.5890 221000.0n 0.5890 221249.9n 0.5890 221250.0n 0.5890 221499.9n 0.5890 221500.0n 0.5890 221749.9n 0.5890 221750.0n 0.5364 221999.9n 0.5364 222000.0n 0.5364 222249.9n 0.5364 222250.0n 0.5890 222499.9n 0.5890 222500.0n 0.3785 222749.9n 0.3785 222750.0n 0.4311 222999.9n 0.4311 223000.0n 0.5189 223249.9n 0.5189 223250.0n 0.5890 223499.9n 0.5890 223500.0n 0.4311 223749.9n 0.4311 223750.0n 0.3961 223999.9n 0.3961 224000.0n 0.2031 224249.9n 0.2031 224250.0n 0.4487 224499.9n 0.4487 224500.0n 0.3434 224749.9n 0.3434 224750.0n 0.4838 224999.9n 0.4838 225000.0n 0.4662 225249.9n 0.4662 225250.0n 0.4311 225499.9n 0.4311 225500.0n 0.5539 225749.9n 0.5539 225750.0n 0.5364 225999.9n 0.5364 226000.0n 0.4662 226249.9n 0.4662 226250.0n 0.5890 226499.9n 0.5890 226500.0n 0.4838 226749.9n 0.4838 226750.0n 0.5013 226999.9n 0.5013 227000.0n 0.5890 227249.9n 0.5890 227250.0n 0.3434 227499.9n 0.3434 227500.0n 0.5890 227749.9n 0.5890 227750.0n 0.3610 227999.9n 0.3610 228000.0n 0.5013 228249.9n 0.5013 228250.0n 0.5890 228499.9n 0.5890 228500.0n 0.5890 228749.9n 0.5890 228750.0n 0.5890 228999.9n 0.5890 229000.0n 0.5890 229249.9n 0.5890 229250.0n 0.5364 229499.9n 0.5364 229500.0n 0.5364 229749.9n 0.5364 229750.0n 0.5890 229999.9n 0.5890 230000.0n 0.3785 230249.9n 0.3785 230250.0n 0.4311 230499.9n 0.4311 230500.0n 0.5189 230749.9n 0.5189 230750.0n 0.5890 230999.9n 0.5890 231000.0n 0.4311 231249.9n 0.4311 231250.0n 0.3961 231499.9n 0.3961 231500.0n 0.2031 231749.9n 0.2031 231750.0n 0.4487 231999.9n 0.4487 232000.0n 0.3434 232249.9n 0.3434 232250.0n 0.4838 232499.9n 0.4838 232500.0n 0.4662 232749.9n 0.4662 232750.0n 0.4311 232999.9n 0.4311 233000.0n 0.5539 233249.9n 0.5539 233250.0n 0.5364 233499.9n 0.5364 233500.0n 0.4662 233749.9n 0.4662 233750.0n 0.5890 233999.9n 0.5890 234000.0n 0.4838 234249.9n 0.4838 234250.0n 0.5013 234499.9n 0.5013 234500.0n 0.5890 234749.9n 0.5890 234750.0n 0.3434 234999.9n 0.3434 235000.0n 0.5890 235249.9n 0.5890 235250.0n 0.3610 235499.9n 0.3610 235500.0n 0.5013 235749.9n 0.5013 235750.0n 0.5890 235999.9n 0.5890 236000.0n 0.5890 236249.9n 0.5890 236250.0n 0.5890 236499.9n 0.5890 236500.0n 0.5890 236749.9n 0.5890 236750.0n 0.5364 236999.9n 0.5364 237000.0n 0.5364 237249.9n 0.5364 237250.0n 0.5890 237499.9n 0.5890 237500.0n 0.3785 237749.9n 0.3785 237750.0n 0.4311 237999.9n 0.4311 238000.0n 0.5189 238249.9n 0.5189 238250.0n 0.5890 238499.9n 0.5890 238500.0n 0.4311 238749.9n 0.4311 238750.0n 0.3961 238999.9n 0.3961 239000.0n 0.2031 239249.9n 0.2031 239250.0n 0.4487 239499.9n 0.4487 239500.0n 0.3434 239749.9n 0.3434 239750.0n 0.4838 239999.9n 0.4838 240000.0n 0.4662 240249.9n 0.4662 240250.0n 0.4311 240499.9n 0.4311 240500.0n 0.5539 240749.9n 0.5539 240750.0n 0.5364 240999.9n 0.5364 241000.0n 0.4662 241249.9n 0.4662 241250.0n 0.5890 241499.9n 0.5890 241500.0n 0.4838 241749.9n 0.4838 241750.0n 0.5013 241999.9n 0.5013 242000.0n 0.5890 242249.9n 0.5890 242250.0n 0.3434 242499.9n 0.3434 242500.0n 0.5890 242749.9n 0.5890 242750.0n 0.3610 242999.9n 0.3610 243000.0n 0.5013 243249.9n 0.5013 243250.0n 0.5890 243499.9n 0.5890 243500.0n 0.5890 243749.9n 0.5890 243750.0n 0.5890 243999.9n 0.5890 244000.0n 0.5890 244249.9n 0.5890 244250.0n 0.5364 244499.9n 0.5364 244500.0n 0.5364 244749.9n 0.5364 244750.0n 0.5890 244999.9n 0.5890 245000.0n 0.3785 245249.9n 0.3785 245250.0n 0.4311 245499.9n 0.4311 245500.0n 0.5189 245749.9n 0.5189 245750.0n 0.5890 245999.9n 0.5890 246000.0n 0.4311 246249.9n 0.4311 246250.0n 0.3961 246499.9n 0.3961 246500.0n 0.2031 246749.9n 0.2031 246750.0n 0.4487 246999.9n 0.4487 247000.0n 0.3434 247249.9n 0.3434 247250.0n 0.4838 247499.9n 0.4838 247500.0n 0.4662 247749.9n 0.4662 247750.0n 0.4311 247999.9n 0.4311 248000.0n 0.5539 248249.9n 0.5539 248250.0n 0.5364 248499.9n 0.5364 248500.0n 0.4662 248749.9n 0.4662 248750.0n 0.5890 248999.9n 0.5890 249000.0n 0.4838 249249.9n 0.4838 249250.0n 0.5013 249499.9n 0.5013 249500.0n 0.5890 249749.9n 0.5890 249750.0n 0.3434 249999.9n 0.3434 250000.0n 0.5890 250249.9n 0.5890 250250.0n 0.3610 250499.9n 0.3610 250500.0n 0.5013 250749.9n 0.5013 250750.0n 0.5890 250999.9n 0.5890 251000.0n 0.5890 251249.9n 0.5890 251250.0n 0.5890 251499.9n 0.5890 251500.0n 0.5890 251749.9n 0.5890 251750.0n 0.5364 251999.9n 0.5364 252000.0n 0.5364 252249.9n 0.5364 252250.0n 0.5890 252499.9n 0.5890 252500.0n 0.3785 252749.9n 0.3785 252750.0n 0.4311 252999.9n 0.4311 253000.0n 0.5189 253249.9n 0.5189 253250.0n 0.5890 253499.9n 0.5890 253500.0n 0.4311 253749.9n 0.4311 253750.0n 0.3961 253999.9n 0.3961 254000.0n 0.2031 254249.9n 0.2031 254250.0n 0.4487 254499.9n 0.4487 254500.0n 0.3434 254749.9n 0.3434 254750.0n 0.4838 254999.9n 0.4838 255000.0n 0.4662 255249.9n 0.4662 255250.0n 0.4311 255499.9n 0.4311 255500.0n 0.5539 255749.9n 0.5539 255750.0n 0.5364 255999.9n 0.5364 256000.0n 0.4662 256249.9n 0.4662 256250.0n 0.5890 256499.9n 0.5890 256500.0n 0.4838 256749.9n 0.4838 256750.0n 0.5013 256999.9n 0.5013 257000.0n 0.5890 257249.9n 0.5890 257250.0n 0.3434 257499.9n 0.3434 257500.0n 0.5890 257749.9n 0.5890 257750.0n 0.3610 257999.9n 0.3610 258000.0n 0.5013 258249.9n 0.5013 258250.0n 0.5890 258499.9n 0.5890 258500.0n 0.5890 258749.9n 0.5890 258750.0n 0.5890 258999.9n 0.5890 259000.0n 0.5890 259249.9n 0.5890 259250.0n 0.5364 259499.9n 0.5364 259500.0n 0.5364 259749.9n 0.5364 259750.0n 0.5890 259999.9n 0.5890 260000.0n 0.3785 260249.9n 0.3785 260250.0n 0.4311 260499.9n 0.4311 260500.0n 0.5189 260749.9n 0.5189 260750.0n 0.5890 260999.9n 0.5890 261000.0n 0.4311 261249.9n 0.4311 261250.0n 0.3961 261499.9n 0.3961 261500.0n 0.2031 261749.9n 0.2031 261750.0n 0.4487 261999.9n 0.4487 262000.0n 0.3434 262249.9n 0.3434 262250.0n 0.4838 262499.9n 0.4838 262500.0n 0.4662 262749.9n 0.4662 262750.0n 0.4311 262999.9n 0.4311 263000.0n 0.5539 263249.9n 0.5539 263250.0n 0.5364 263499.9n 0.5364 263500.0n 0.4662 263749.9n 0.4662 263750.0n 0.5890 263999.9n 0.5890 264000.0n 0.4838 264249.9n 0.4838 264250.0n 0.5013 264499.9n 0.5013 264500.0n 0.5890 264749.9n 0.5890 264750.0n 0.3434 264999.9n 0.3434 265000.0n 0.5890 265249.9n 0.5890 265250.0n 0.3610 265499.9n 0.3610 265500.0n 0.5013 265749.9n 0.5013 265750.0n 0.5890 265999.9n 0.5890 266000.0n 0.5890 266249.9n 0.5890 266250.0n 0.5890 266499.9n 0.5890 266500.0n 0.5890 266749.9n 0.5890 266750.0n 0.5364 266999.9n 0.5364 267000.0n 0.5364 267249.9n 0.5364 267250.0n 0.5890 267499.9n 0.5890 267500.0n 0.3785 267749.9n 0.3785 267750.0n 0.4311 267999.9n 0.4311 268000.0n 0.5189 268249.9n 0.5189 268250.0n 0.5890 268499.9n 0.5890 268500.0n 0.4311 268749.9n 0.4311 268750.0n 0.3961 268999.9n 0.3961 269000.0n 0.2031 269249.9n 0.2031 269250.0n 0.4487 269499.9n 0.4487 269500.0n 0.3434 269749.9n 0.3434 269750.0n 0.4838 269999.9n 0.4838 270000.0n 0.4662 270249.9n 0.4662 270250.0n 0.4311 270499.9n 0.4311 270500.0n 0.5539 270749.9n 0.5539 270750.0n 0.5364 270999.9n 0.5364 271000.0n 0.4662 271249.9n 0.4662 271250.0n 0.5890 271499.9n 0.5890 271500.0n 0.4838 271749.9n 0.4838 271750.0n 0.5013 271999.9n 0.5013 272000.0n 0.5890 272249.9n 0.5890 272250.0n 0.3434 272499.9n 0.3434 272500.0n 0.5890 272749.9n 0.5890 272750.0n 0.3610 272999.9n 0.3610 273000.0n 0.5013 273249.9n 0.5013 273250.0n 0.5890 273499.9n 0.5890 273500.0n 0.5890 273749.9n 0.5890 273750.0n 0.5890 273999.9n 0.5890 274000.0n 0.5890 274249.9n 0.5890 274250.0n 0.5364 274499.9n 0.5364 274500.0n 0.5364 274749.9n 0.5364 274750.0n 0.5890 274999.9n 0.5890 275000.0n 0.3785 275249.9n 0.3785 275250.0n 0.4311 275499.9n 0.4311 275500.0n 0.5189 275749.9n 0.5189 275750.0n 0.5890 275999.9n 0.5890 276000.0n 0.4311 276249.9n 0.4311 276250.0n 0.3961 276499.9n 0.3961 276500.0n 0.2031 276749.9n 0.2031 276750.0n 0.4487 276999.9n 0.4487 277000.0n 0.3434 277249.9n 0.3434 277250.0n 0.4838 277499.9n 0.4838 277500.0n 0.4662 277749.9n 0.4662 277750.0n 0.4311 277999.9n 0.4311 278000.0n 0.5539 278249.9n 0.5539 278250.0n 0.5364 278499.9n 0.5364 278500.0n 0.4662 278749.9n 0.4662 278750.0n 0.5890 278999.9n 0.5890 279000.0n 0.4838 279249.9n 0.4838 279250.0n 0.5013 279499.9n 0.5013 279500.0n 0.5890 279749.9n 0.5890 279750.0n 0.3434 279999.9n 0.3434 280000.0n 0.5890 280249.9n 0.5890 280250.0n 0.3610 280499.9n 0.3610 280500.0n 0.5013 280749.9n 0.5013 280750.0n 0.5890 280999.9n 0.5890 281000.0n 0.5890 281249.9n 0.5890 281250.0n 0.5890 281499.9n 0.5890 281500.0n 0.5890 281749.9n 0.5890 281750.0n 0.5364 281999.9n 0.5364 282000.0n 0.5364 282249.9n 0.5364 282250.0n 0.5890 282499.9n 0.5890 282500.0n 0.3785 282749.9n 0.3785 282750.0n 0.4311 282999.9n 0.4311 283000.0n 0.5189 283249.9n 0.5189 283250.0n 0.5890 283499.9n 0.5890 283500.0n 0.4311 283749.9n 0.4311 283750.0n 0.3961 283999.9n 0.3961 284000.0n 0.2031 284249.9n 0.2031 284250.0n 0.4487 284499.9n 0.4487 284500.0n 0.3434 284749.9n 0.3434 284750.0n 0.4838 284999.9n 0.4838 285000.0n 0.4662 285249.9n 0.4662 285250.0n 0.4311 285499.9n 0.4311 285500.0n 0.5539 285749.9n 0.5539 285750.0n 0.5364 285999.9n 0.5364 286000.0n 0.4662 286249.9n 0.4662 286250.0n 0.5890 286499.9n 0.5890 286500.0n 0.4838 286749.9n 0.4838 286750.0n 0.5013 286999.9n 0.5013 287000.0n 0.5890 287249.9n 0.5890 287250.0n 0.3434 287499.9n 0.3434 287500.0n 0.5890 287749.9n 0.5890 287750.0n 0.3610 287999.9n 0.3610 288000.0n 0.5013 288249.9n 0.5013 288250.0n 0.5890 288499.9n 0.5890 288500.0n 0.5890 288749.9n 0.5890 288750.0n 0.5890 288999.9n 0.5890 289000.0n 0.5890 289249.9n 0.5890 289250.0n 0.5364 289499.9n 0.5364 289500.0n 0.5364 289749.9n 0.5364 289750.0n 0.5890 289999.9n 0.5890 290000.0n 0.3785 290249.9n 0.3785 290250.0n 0.4311 290499.9n 0.4311 290500.0n 0.5189 290749.9n 0.5189 290750.0n 0.5890 290999.9n 0.5890 291000.0n 0.4311 291249.9n 0.4311 291250.0n 0.3961 291499.9n 0.3961 291500.0n 0.2031 291749.9n 0.2031 291750.0n 0.4487 291999.9n 0.4487 292000.0n 0.3434 292249.9n 0.3434 292250.0n 0.4838 292499.9n 0.4838 292500.0n 0.4662 292749.9n 0.4662 292750.0n 0.4311 292999.9n 0.4311 293000.0n 0.5539 293249.9n 0.5539 293250.0n 0.5364 293499.9n 0.5364 293500.0n 0.4662 293749.9n 0.4662 293750.0n 0.5890 293999.9n 0.5890 294000.0n 0.4838 294249.9n 0.4838 294250.0n 0.5013 294499.9n 0.5013 294500.0n 0.5890 294749.9n 0.5890 294750.0n 0.3434 294999.9n 0.3434 295000.0n 0.5890 295249.9n 0.5890 295250.0n 0.3610 295499.9n 0.3610 295500.0n 0.5013 295749.9n 0.5013 295750.0n 0.5890 295999.9n 0.5890 296000.0n 0.5890 296249.9n 0.5890 296250.0n 0.5890 296499.9n 0.5890 296500.0n 0.5890 296749.9n 0.5890 296750.0n 0.5364 296999.9n 0.5364 297000.0n 0.5364 297249.9n 0.5364 297250.0n 0.5890 297499.9n 0.5890 297500.0n 0.3785 297749.9n 0.3785 297750.0n 0.4311 297999.9n 0.4311 298000.0n 0.5189 298249.9n 0.5189 298250.0n 0.5890 298499.9n 0.5890 298500.0n 0.4311 298749.9n 0.4311 298750.0n 0.3961 298999.9n 0.3961 299000.0n 0.2031 299249.9n 0.2031 299250.0n 0.4487 299499.9n 0.4487 299500.0n 0.3434 299749.9n 0.3434 299750.0n 0.4838)
Vxp5 a_xp5 0 PWL(0.0n 0.5410 249.9n 0.5410 250.0n 0.4284 499.9n 0.4284 500.0n 0.5941 749.9n 0.5941 750.0n 0.4151 999.9n 0.4151 1000.0n 0.5742 1249.9n 0.5742 1250.0n 0.5079 1499.9n 0.5079 1500.0n 0.4217 1749.9n 0.4217 1750.0n 0.6537 1999.9n 0.6537 2000.0n 0.5278 2249.9n 0.5278 2250.0n 0.6537 2499.9n 0.6537 2500.0n 0.6206 2749.9n 0.6206 2750.0n 0.4549 2999.9n 0.4549 3000.0n 0.6206 3249.9n 0.6206 3250.0n 0.5675 3499.9n 0.5675 3500.0n 0.5212 3749.9n 0.5212 3750.0n 0.6670 3999.9n 0.6670 4000.0n 0.3356 4249.9n 0.3356 4250.0n 0.5079 4499.9n 0.5079 4500.0n 0.4416 4749.9n 0.4416 4750.0n 0.6537 4999.9n 0.6537 5000.0n 0.4549 5249.9n 0.4549 5250.0n 0.6471 5499.9n 0.6471 5500.0n 0.5675 5749.9n 0.5675 5750.0n 0.6073 5999.9n 0.6073 6000.0n 0.6073 6249.9n 0.6073 6250.0n 0.6206 6499.9n 0.6206 6500.0n 0.6272 6749.9n 0.6272 6750.0n 0.4880 6999.9n 0.4880 7000.0n 0.4217 7249.9n 0.4217 7250.0n 0.4549 7499.9n 0.4549 7500.0n 0.5410 7749.9n 0.5410 7750.0n 0.4284 7999.9n 0.4284 8000.0n 0.5941 8249.9n 0.5941 8250.0n 0.4151 8499.9n 0.4151 8500.0n 0.5742 8749.9n 0.5742 8750.0n 0.5079 8999.9n 0.5079 9000.0n 0.4217 9249.9n 0.4217 9250.0n 0.6537 9499.9n 0.6537 9500.0n 0.5278 9749.9n 0.5278 9750.0n 0.6537 9999.9n 0.6537 10000.0n 0.6206 10249.9n 0.6206 10250.0n 0.4549 10499.9n 0.4549 10500.0n 0.6206 10749.9n 0.6206 10750.0n 0.5675 10999.9n 0.5675 11000.0n 0.5212 11249.9n 0.5212 11250.0n 0.6670 11499.9n 0.6670 11500.0n 0.3356 11749.9n 0.3356 11750.0n 0.5079 11999.9n 0.5079 12000.0n 0.4416 12249.9n 0.4416 12250.0n 0.6537 12499.9n 0.6537 12500.0n 0.4549 12749.9n 0.4549 12750.0n 0.6471 12999.9n 0.6471 13000.0n 0.5675 13249.9n 0.5675 13250.0n 0.6073 13499.9n 0.6073 13500.0n 0.6073 13749.9n 0.6073 13750.0n 0.6206 13999.9n 0.6206 14000.0n 0.6272 14249.9n 0.6272 14250.0n 0.4880 14499.9n 0.4880 14500.0n 0.4217 14749.9n 0.4217 14750.0n 0.4549 14999.9n 0.4549 15000.0n 0.5410 15249.9n 0.5410 15250.0n 0.4284 15499.9n 0.4284 15500.0n 0.5941 15749.9n 0.5941 15750.0n 0.4151 15999.9n 0.4151 16000.0n 0.5742 16249.9n 0.5742 16250.0n 0.5079 16499.9n 0.5079 16500.0n 0.4217 16749.9n 0.4217 16750.0n 0.6537 16999.9n 0.6537 17000.0n 0.5278 17249.9n 0.5278 17250.0n 0.6537 17499.9n 0.6537 17500.0n 0.6206 17749.9n 0.6206 17750.0n 0.4549 17999.9n 0.4549 18000.0n 0.6206 18249.9n 0.6206 18250.0n 0.5675 18499.9n 0.5675 18500.0n 0.5212 18749.9n 0.5212 18750.0n 0.6670 18999.9n 0.6670 19000.0n 0.3356 19249.9n 0.3356 19250.0n 0.5079 19499.9n 0.5079 19500.0n 0.4416 19749.9n 0.4416 19750.0n 0.6537 19999.9n 0.6537 20000.0n 0.4549 20249.9n 0.4549 20250.0n 0.6471 20499.9n 0.6471 20500.0n 0.5675 20749.9n 0.5675 20750.0n 0.6073 20999.9n 0.6073 21000.0n 0.6073 21249.9n 0.6073 21250.0n 0.6206 21499.9n 0.6206 21500.0n 0.6272 21749.9n 0.6272 21750.0n 0.4880 21999.9n 0.4880 22000.0n 0.4217 22249.9n 0.4217 22250.0n 0.4549 22499.9n 0.4549 22500.0n 0.5410 22749.9n 0.5410 22750.0n 0.4284 22999.9n 0.4284 23000.0n 0.5941 23249.9n 0.5941 23250.0n 0.4151 23499.9n 0.4151 23500.0n 0.5742 23749.9n 0.5742 23750.0n 0.5079 23999.9n 0.5079 24000.0n 0.4217 24249.9n 0.4217 24250.0n 0.6537 24499.9n 0.6537 24500.0n 0.5278 24749.9n 0.5278 24750.0n 0.6537 24999.9n 0.6537 25000.0n 0.6206 25249.9n 0.6206 25250.0n 0.4549 25499.9n 0.4549 25500.0n 0.6206 25749.9n 0.6206 25750.0n 0.5675 25999.9n 0.5675 26000.0n 0.5212 26249.9n 0.5212 26250.0n 0.6670 26499.9n 0.6670 26500.0n 0.3356 26749.9n 0.3356 26750.0n 0.5079 26999.9n 0.5079 27000.0n 0.4416 27249.9n 0.4416 27250.0n 0.6537 27499.9n 0.6537 27500.0n 0.4549 27749.9n 0.4549 27750.0n 0.6471 27999.9n 0.6471 28000.0n 0.5675 28249.9n 0.5675 28250.0n 0.6073 28499.9n 0.6073 28500.0n 0.6073 28749.9n 0.6073 28750.0n 0.6206 28999.9n 0.6206 29000.0n 0.6272 29249.9n 0.6272 29250.0n 0.4880 29499.9n 0.4880 29500.0n 0.4217 29749.9n 0.4217 29750.0n 0.4549 29999.9n 0.4549 30000.0n 0.5410 30249.9n 0.5410 30250.0n 0.4284 30499.9n 0.4284 30500.0n 0.5941 30749.9n 0.5941 30750.0n 0.4151 30999.9n 0.4151 31000.0n 0.5742 31249.9n 0.5742 31250.0n 0.5079 31499.9n 0.5079 31500.0n 0.4217 31749.9n 0.4217 31750.0n 0.6537 31999.9n 0.6537 32000.0n 0.5278 32249.9n 0.5278 32250.0n 0.6537 32499.9n 0.6537 32500.0n 0.6206 32749.9n 0.6206 32750.0n 0.4549 32999.9n 0.4549 33000.0n 0.6206 33249.9n 0.6206 33250.0n 0.5675 33499.9n 0.5675 33500.0n 0.5212 33749.9n 0.5212 33750.0n 0.6670 33999.9n 0.6670 34000.0n 0.3356 34249.9n 0.3356 34250.0n 0.5079 34499.9n 0.5079 34500.0n 0.4416 34749.9n 0.4416 34750.0n 0.6537 34999.9n 0.6537 35000.0n 0.4549 35249.9n 0.4549 35250.0n 0.6471 35499.9n 0.6471 35500.0n 0.5675 35749.9n 0.5675 35750.0n 0.6073 35999.9n 0.6073 36000.0n 0.6073 36249.9n 0.6073 36250.0n 0.6206 36499.9n 0.6206 36500.0n 0.6272 36749.9n 0.6272 36750.0n 0.4880 36999.9n 0.4880 37000.0n 0.4217 37249.9n 0.4217 37250.0n 0.4549 37499.9n 0.4549 37500.0n 0.5410 37749.9n 0.5410 37750.0n 0.4284 37999.9n 0.4284 38000.0n 0.5941 38249.9n 0.5941 38250.0n 0.4151 38499.9n 0.4151 38500.0n 0.5742 38749.9n 0.5742 38750.0n 0.5079 38999.9n 0.5079 39000.0n 0.4217 39249.9n 0.4217 39250.0n 0.6537 39499.9n 0.6537 39500.0n 0.5278 39749.9n 0.5278 39750.0n 0.6537 39999.9n 0.6537 40000.0n 0.6206 40249.9n 0.6206 40250.0n 0.4549 40499.9n 0.4549 40500.0n 0.6206 40749.9n 0.6206 40750.0n 0.5675 40999.9n 0.5675 41000.0n 0.5212 41249.9n 0.5212 41250.0n 0.6670 41499.9n 0.6670 41500.0n 0.3356 41749.9n 0.3356 41750.0n 0.5079 41999.9n 0.5079 42000.0n 0.4416 42249.9n 0.4416 42250.0n 0.6537 42499.9n 0.6537 42500.0n 0.4549 42749.9n 0.4549 42750.0n 0.6471 42999.9n 0.6471 43000.0n 0.5675 43249.9n 0.5675 43250.0n 0.6073 43499.9n 0.6073 43500.0n 0.6073 43749.9n 0.6073 43750.0n 0.6206 43999.9n 0.6206 44000.0n 0.6272 44249.9n 0.6272 44250.0n 0.4880 44499.9n 0.4880 44500.0n 0.4217 44749.9n 0.4217 44750.0n 0.4549 44999.9n 0.4549 45000.0n 0.5410 45249.9n 0.5410 45250.0n 0.4284 45499.9n 0.4284 45500.0n 0.5941 45749.9n 0.5941 45750.0n 0.4151 45999.9n 0.4151 46000.0n 0.5742 46249.9n 0.5742 46250.0n 0.5079 46499.9n 0.5079 46500.0n 0.4217 46749.9n 0.4217 46750.0n 0.6537 46999.9n 0.6537 47000.0n 0.5278 47249.9n 0.5278 47250.0n 0.6537 47499.9n 0.6537 47500.0n 0.6206 47749.9n 0.6206 47750.0n 0.4549 47999.9n 0.4549 48000.0n 0.6206 48249.9n 0.6206 48250.0n 0.5675 48499.9n 0.5675 48500.0n 0.5212 48749.9n 0.5212 48750.0n 0.6670 48999.9n 0.6670 49000.0n 0.3356 49249.9n 0.3356 49250.0n 0.5079 49499.9n 0.5079 49500.0n 0.4416 49749.9n 0.4416 49750.0n 0.6537 49999.9n 0.6537 50000.0n 0.4549 50249.9n 0.4549 50250.0n 0.6471 50499.9n 0.6471 50500.0n 0.5675 50749.9n 0.5675 50750.0n 0.6073 50999.9n 0.6073 51000.0n 0.6073 51249.9n 0.6073 51250.0n 0.6206 51499.9n 0.6206 51500.0n 0.6272 51749.9n 0.6272 51750.0n 0.4880 51999.9n 0.4880 52000.0n 0.4217 52249.9n 0.4217 52250.0n 0.4549 52499.9n 0.4549 52500.0n 0.5410 52749.9n 0.5410 52750.0n 0.4284 52999.9n 0.4284 53000.0n 0.5941 53249.9n 0.5941 53250.0n 0.4151 53499.9n 0.4151 53500.0n 0.5742 53749.9n 0.5742 53750.0n 0.5079 53999.9n 0.5079 54000.0n 0.4217 54249.9n 0.4217 54250.0n 0.6537 54499.9n 0.6537 54500.0n 0.5278 54749.9n 0.5278 54750.0n 0.6537 54999.9n 0.6537 55000.0n 0.6206 55249.9n 0.6206 55250.0n 0.4549 55499.9n 0.4549 55500.0n 0.6206 55749.9n 0.6206 55750.0n 0.5675 55999.9n 0.5675 56000.0n 0.5212 56249.9n 0.5212 56250.0n 0.6670 56499.9n 0.6670 56500.0n 0.3356 56749.9n 0.3356 56750.0n 0.5079 56999.9n 0.5079 57000.0n 0.4416 57249.9n 0.4416 57250.0n 0.6537 57499.9n 0.6537 57500.0n 0.4549 57749.9n 0.4549 57750.0n 0.6471 57999.9n 0.6471 58000.0n 0.5675 58249.9n 0.5675 58250.0n 0.6073 58499.9n 0.6073 58500.0n 0.6073 58749.9n 0.6073 58750.0n 0.6206 58999.9n 0.6206 59000.0n 0.6272 59249.9n 0.6272 59250.0n 0.4880 59499.9n 0.4880 59500.0n 0.4217 59749.9n 0.4217 59750.0n 0.4549 59999.9n 0.4549 60000.0n 0.5410 60249.9n 0.5410 60250.0n 0.4284 60499.9n 0.4284 60500.0n 0.5941 60749.9n 0.5941 60750.0n 0.4151 60999.9n 0.4151 61000.0n 0.5742 61249.9n 0.5742 61250.0n 0.5079 61499.9n 0.5079 61500.0n 0.4217 61749.9n 0.4217 61750.0n 0.6537 61999.9n 0.6537 62000.0n 0.5278 62249.9n 0.5278 62250.0n 0.6537 62499.9n 0.6537 62500.0n 0.6206 62749.9n 0.6206 62750.0n 0.4549 62999.9n 0.4549 63000.0n 0.6206 63249.9n 0.6206 63250.0n 0.5675 63499.9n 0.5675 63500.0n 0.5212 63749.9n 0.5212 63750.0n 0.6670 63999.9n 0.6670 64000.0n 0.3356 64249.9n 0.3356 64250.0n 0.5079 64499.9n 0.5079 64500.0n 0.4416 64749.9n 0.4416 64750.0n 0.6537 64999.9n 0.6537 65000.0n 0.4549 65249.9n 0.4549 65250.0n 0.6471 65499.9n 0.6471 65500.0n 0.5675 65749.9n 0.5675 65750.0n 0.6073 65999.9n 0.6073 66000.0n 0.6073 66249.9n 0.6073 66250.0n 0.6206 66499.9n 0.6206 66500.0n 0.6272 66749.9n 0.6272 66750.0n 0.4880 66999.9n 0.4880 67000.0n 0.4217 67249.9n 0.4217 67250.0n 0.4549 67499.9n 0.4549 67500.0n 0.5410 67749.9n 0.5410 67750.0n 0.4284 67999.9n 0.4284 68000.0n 0.5941 68249.9n 0.5941 68250.0n 0.4151 68499.9n 0.4151 68500.0n 0.5742 68749.9n 0.5742 68750.0n 0.5079 68999.9n 0.5079 69000.0n 0.4217 69249.9n 0.4217 69250.0n 0.6537 69499.9n 0.6537 69500.0n 0.5278 69749.9n 0.5278 69750.0n 0.6537 69999.9n 0.6537 70000.0n 0.6206 70249.9n 0.6206 70250.0n 0.4549 70499.9n 0.4549 70500.0n 0.6206 70749.9n 0.6206 70750.0n 0.5675 70999.9n 0.5675 71000.0n 0.5212 71249.9n 0.5212 71250.0n 0.6670 71499.9n 0.6670 71500.0n 0.3356 71749.9n 0.3356 71750.0n 0.5079 71999.9n 0.5079 72000.0n 0.4416 72249.9n 0.4416 72250.0n 0.6537 72499.9n 0.6537 72500.0n 0.4549 72749.9n 0.4549 72750.0n 0.6471 72999.9n 0.6471 73000.0n 0.5675 73249.9n 0.5675 73250.0n 0.6073 73499.9n 0.6073 73500.0n 0.6073 73749.9n 0.6073 73750.0n 0.6206 73999.9n 0.6206 74000.0n 0.6272 74249.9n 0.6272 74250.0n 0.4880 74499.9n 0.4880 74500.0n 0.4217 74749.9n 0.4217 74750.0n 0.4549 74999.9n 0.4549 75000.0n 0.5410 75249.9n 0.5410 75250.0n 0.4284 75499.9n 0.4284 75500.0n 0.5941 75749.9n 0.5941 75750.0n 0.4151 75999.9n 0.4151 76000.0n 0.5742 76249.9n 0.5742 76250.0n 0.5079 76499.9n 0.5079 76500.0n 0.4217 76749.9n 0.4217 76750.0n 0.6537 76999.9n 0.6537 77000.0n 0.5278 77249.9n 0.5278 77250.0n 0.6537 77499.9n 0.6537 77500.0n 0.6206 77749.9n 0.6206 77750.0n 0.4549 77999.9n 0.4549 78000.0n 0.6206 78249.9n 0.6206 78250.0n 0.5675 78499.9n 0.5675 78500.0n 0.5212 78749.9n 0.5212 78750.0n 0.6670 78999.9n 0.6670 79000.0n 0.3356 79249.9n 0.3356 79250.0n 0.5079 79499.9n 0.5079 79500.0n 0.4416 79749.9n 0.4416 79750.0n 0.6537 79999.9n 0.6537 80000.0n 0.4549 80249.9n 0.4549 80250.0n 0.6471 80499.9n 0.6471 80500.0n 0.5675 80749.9n 0.5675 80750.0n 0.6073 80999.9n 0.6073 81000.0n 0.6073 81249.9n 0.6073 81250.0n 0.6206 81499.9n 0.6206 81500.0n 0.6272 81749.9n 0.6272 81750.0n 0.4880 81999.9n 0.4880 82000.0n 0.4217 82249.9n 0.4217 82250.0n 0.4549 82499.9n 0.4549 82500.0n 0.5410 82749.9n 0.5410 82750.0n 0.4284 82999.9n 0.4284 83000.0n 0.5941 83249.9n 0.5941 83250.0n 0.4151 83499.9n 0.4151 83500.0n 0.5742 83749.9n 0.5742 83750.0n 0.5079 83999.9n 0.5079 84000.0n 0.4217 84249.9n 0.4217 84250.0n 0.6537 84499.9n 0.6537 84500.0n 0.5278 84749.9n 0.5278 84750.0n 0.6537 84999.9n 0.6537 85000.0n 0.6206 85249.9n 0.6206 85250.0n 0.4549 85499.9n 0.4549 85500.0n 0.6206 85749.9n 0.6206 85750.0n 0.5675 85999.9n 0.5675 86000.0n 0.5212 86249.9n 0.5212 86250.0n 0.6670 86499.9n 0.6670 86500.0n 0.3356 86749.9n 0.3356 86750.0n 0.5079 86999.9n 0.5079 87000.0n 0.4416 87249.9n 0.4416 87250.0n 0.6537 87499.9n 0.6537 87500.0n 0.4549 87749.9n 0.4549 87750.0n 0.6471 87999.9n 0.6471 88000.0n 0.5675 88249.9n 0.5675 88250.0n 0.6073 88499.9n 0.6073 88500.0n 0.6073 88749.9n 0.6073 88750.0n 0.6206 88999.9n 0.6206 89000.0n 0.6272 89249.9n 0.6272 89250.0n 0.4880 89499.9n 0.4880 89500.0n 0.4217 89749.9n 0.4217 89750.0n 0.4549 89999.9n 0.4549 90000.0n 0.5410 90249.9n 0.5410 90250.0n 0.4284 90499.9n 0.4284 90500.0n 0.5941 90749.9n 0.5941 90750.0n 0.4151 90999.9n 0.4151 91000.0n 0.5742 91249.9n 0.5742 91250.0n 0.5079 91499.9n 0.5079 91500.0n 0.4217 91749.9n 0.4217 91750.0n 0.6537 91999.9n 0.6537 92000.0n 0.5278 92249.9n 0.5278 92250.0n 0.6537 92499.9n 0.6537 92500.0n 0.6206 92749.9n 0.6206 92750.0n 0.4549 92999.9n 0.4549 93000.0n 0.6206 93249.9n 0.6206 93250.0n 0.5675 93499.9n 0.5675 93500.0n 0.5212 93749.9n 0.5212 93750.0n 0.6670 93999.9n 0.6670 94000.0n 0.3356 94249.9n 0.3356 94250.0n 0.5079 94499.9n 0.5079 94500.0n 0.4416 94749.9n 0.4416 94750.0n 0.6537 94999.9n 0.6537 95000.0n 0.4549 95249.9n 0.4549 95250.0n 0.6471 95499.9n 0.6471 95500.0n 0.5675 95749.9n 0.5675 95750.0n 0.6073 95999.9n 0.6073 96000.0n 0.6073 96249.9n 0.6073 96250.0n 0.6206 96499.9n 0.6206 96500.0n 0.6272 96749.9n 0.6272 96750.0n 0.4880 96999.9n 0.4880 97000.0n 0.4217 97249.9n 0.4217 97250.0n 0.4549 97499.9n 0.4549 97500.0n 0.5410 97749.9n 0.5410 97750.0n 0.4284 97999.9n 0.4284 98000.0n 0.5941 98249.9n 0.5941 98250.0n 0.4151 98499.9n 0.4151 98500.0n 0.5742 98749.9n 0.5742 98750.0n 0.5079 98999.9n 0.5079 99000.0n 0.4217 99249.9n 0.4217 99250.0n 0.6537 99499.9n 0.6537 99500.0n 0.5278 99749.9n 0.5278 99750.0n 0.6537 99999.9n 0.6537 100000.0n 0.6206 100249.9n 0.6206 100250.0n 0.4549 100499.9n 0.4549 100500.0n 0.6206 100749.9n 0.6206 100750.0n 0.5675 100999.9n 0.5675 101000.0n 0.5212 101249.9n 0.5212 101250.0n 0.6670 101499.9n 0.6670 101500.0n 0.3356 101749.9n 0.3356 101750.0n 0.5079 101999.9n 0.5079 102000.0n 0.4416 102249.9n 0.4416 102250.0n 0.6537 102499.9n 0.6537 102500.0n 0.4549 102749.9n 0.4549 102750.0n 0.6471 102999.9n 0.6471 103000.0n 0.5675 103249.9n 0.5675 103250.0n 0.6073 103499.9n 0.6073 103500.0n 0.6073 103749.9n 0.6073 103750.0n 0.6206 103999.9n 0.6206 104000.0n 0.6272 104249.9n 0.6272 104250.0n 0.4880 104499.9n 0.4880 104500.0n 0.4217 104749.9n 0.4217 104750.0n 0.4549 104999.9n 0.4549 105000.0n 0.5410 105249.9n 0.5410 105250.0n 0.4284 105499.9n 0.4284 105500.0n 0.5941 105749.9n 0.5941 105750.0n 0.4151 105999.9n 0.4151 106000.0n 0.5742 106249.9n 0.5742 106250.0n 0.5079 106499.9n 0.5079 106500.0n 0.4217 106749.9n 0.4217 106750.0n 0.6537 106999.9n 0.6537 107000.0n 0.5278 107249.9n 0.5278 107250.0n 0.6537 107499.9n 0.6537 107500.0n 0.6206 107749.9n 0.6206 107750.0n 0.4549 107999.9n 0.4549 108000.0n 0.6206 108249.9n 0.6206 108250.0n 0.5675 108499.9n 0.5675 108500.0n 0.5212 108749.9n 0.5212 108750.0n 0.6670 108999.9n 0.6670 109000.0n 0.3356 109249.9n 0.3356 109250.0n 0.5079 109499.9n 0.5079 109500.0n 0.4416 109749.9n 0.4416 109750.0n 0.6537 109999.9n 0.6537 110000.0n 0.4549 110249.9n 0.4549 110250.0n 0.6471 110499.9n 0.6471 110500.0n 0.5675 110749.9n 0.5675 110750.0n 0.6073 110999.9n 0.6073 111000.0n 0.6073 111249.9n 0.6073 111250.0n 0.6206 111499.9n 0.6206 111500.0n 0.6272 111749.9n 0.6272 111750.0n 0.4880 111999.9n 0.4880 112000.0n 0.4217 112249.9n 0.4217 112250.0n 0.4549 112499.9n 0.4549 112500.0n 0.5410 112749.9n 0.5410 112750.0n 0.4284 112999.9n 0.4284 113000.0n 0.5941 113249.9n 0.5941 113250.0n 0.4151 113499.9n 0.4151 113500.0n 0.5742 113749.9n 0.5742 113750.0n 0.5079 113999.9n 0.5079 114000.0n 0.4217 114249.9n 0.4217 114250.0n 0.6537 114499.9n 0.6537 114500.0n 0.5278 114749.9n 0.5278 114750.0n 0.6537 114999.9n 0.6537 115000.0n 0.6206 115249.9n 0.6206 115250.0n 0.4549 115499.9n 0.4549 115500.0n 0.6206 115749.9n 0.6206 115750.0n 0.5675 115999.9n 0.5675 116000.0n 0.5212 116249.9n 0.5212 116250.0n 0.6670 116499.9n 0.6670 116500.0n 0.3356 116749.9n 0.3356 116750.0n 0.5079 116999.9n 0.5079 117000.0n 0.4416 117249.9n 0.4416 117250.0n 0.6537 117499.9n 0.6537 117500.0n 0.4549 117749.9n 0.4549 117750.0n 0.6471 117999.9n 0.6471 118000.0n 0.5675 118249.9n 0.5675 118250.0n 0.6073 118499.9n 0.6073 118500.0n 0.6073 118749.9n 0.6073 118750.0n 0.6206 118999.9n 0.6206 119000.0n 0.6272 119249.9n 0.6272 119250.0n 0.4880 119499.9n 0.4880 119500.0n 0.4217 119749.9n 0.4217 119750.0n 0.4549 119999.9n 0.4549 120000.0n 0.5410 120249.9n 0.5410 120250.0n 0.4284 120499.9n 0.4284 120500.0n 0.5941 120749.9n 0.5941 120750.0n 0.4151 120999.9n 0.4151 121000.0n 0.5742 121249.9n 0.5742 121250.0n 0.5079 121499.9n 0.5079 121500.0n 0.4217 121749.9n 0.4217 121750.0n 0.6537 121999.9n 0.6537 122000.0n 0.5278 122249.9n 0.5278 122250.0n 0.6537 122499.9n 0.6537 122500.0n 0.6206 122749.9n 0.6206 122750.0n 0.4549 122999.9n 0.4549 123000.0n 0.6206 123249.9n 0.6206 123250.0n 0.5675 123499.9n 0.5675 123500.0n 0.5212 123749.9n 0.5212 123750.0n 0.6670 123999.9n 0.6670 124000.0n 0.3356 124249.9n 0.3356 124250.0n 0.5079 124499.9n 0.5079 124500.0n 0.4416 124749.9n 0.4416 124750.0n 0.6537 124999.9n 0.6537 125000.0n 0.4549 125249.9n 0.4549 125250.0n 0.6471 125499.9n 0.6471 125500.0n 0.5675 125749.9n 0.5675 125750.0n 0.6073 125999.9n 0.6073 126000.0n 0.6073 126249.9n 0.6073 126250.0n 0.6206 126499.9n 0.6206 126500.0n 0.6272 126749.9n 0.6272 126750.0n 0.4880 126999.9n 0.4880 127000.0n 0.4217 127249.9n 0.4217 127250.0n 0.4549 127499.9n 0.4549 127500.0n 0.5410 127749.9n 0.5410 127750.0n 0.4284 127999.9n 0.4284 128000.0n 0.5941 128249.9n 0.5941 128250.0n 0.4151 128499.9n 0.4151 128500.0n 0.5742 128749.9n 0.5742 128750.0n 0.5079 128999.9n 0.5079 129000.0n 0.4217 129249.9n 0.4217 129250.0n 0.6537 129499.9n 0.6537 129500.0n 0.5278 129749.9n 0.5278 129750.0n 0.6537 129999.9n 0.6537 130000.0n 0.6206 130249.9n 0.6206 130250.0n 0.4549 130499.9n 0.4549 130500.0n 0.6206 130749.9n 0.6206 130750.0n 0.5675 130999.9n 0.5675 131000.0n 0.5212 131249.9n 0.5212 131250.0n 0.6670 131499.9n 0.6670 131500.0n 0.3356 131749.9n 0.3356 131750.0n 0.5079 131999.9n 0.5079 132000.0n 0.4416 132249.9n 0.4416 132250.0n 0.6537 132499.9n 0.6537 132500.0n 0.4549 132749.9n 0.4549 132750.0n 0.6471 132999.9n 0.6471 133000.0n 0.5675 133249.9n 0.5675 133250.0n 0.6073 133499.9n 0.6073 133500.0n 0.6073 133749.9n 0.6073 133750.0n 0.6206 133999.9n 0.6206 134000.0n 0.6272 134249.9n 0.6272 134250.0n 0.4880 134499.9n 0.4880 134500.0n 0.4217 134749.9n 0.4217 134750.0n 0.4549 134999.9n 0.4549 135000.0n 0.5410 135249.9n 0.5410 135250.0n 0.4284 135499.9n 0.4284 135500.0n 0.5941 135749.9n 0.5941 135750.0n 0.4151 135999.9n 0.4151 136000.0n 0.5742 136249.9n 0.5742 136250.0n 0.5079 136499.9n 0.5079 136500.0n 0.4217 136749.9n 0.4217 136750.0n 0.6537 136999.9n 0.6537 137000.0n 0.5278 137249.9n 0.5278 137250.0n 0.6537 137499.9n 0.6537 137500.0n 0.6206 137749.9n 0.6206 137750.0n 0.4549 137999.9n 0.4549 138000.0n 0.6206 138249.9n 0.6206 138250.0n 0.5675 138499.9n 0.5675 138500.0n 0.5212 138749.9n 0.5212 138750.0n 0.6670 138999.9n 0.6670 139000.0n 0.3356 139249.9n 0.3356 139250.0n 0.5079 139499.9n 0.5079 139500.0n 0.4416 139749.9n 0.4416 139750.0n 0.6537 139999.9n 0.6537 140000.0n 0.4549 140249.9n 0.4549 140250.0n 0.6471 140499.9n 0.6471 140500.0n 0.5675 140749.9n 0.5675 140750.0n 0.6073 140999.9n 0.6073 141000.0n 0.6073 141249.9n 0.6073 141250.0n 0.6206 141499.9n 0.6206 141500.0n 0.6272 141749.9n 0.6272 141750.0n 0.4880 141999.9n 0.4880 142000.0n 0.4217 142249.9n 0.4217 142250.0n 0.4549 142499.9n 0.4549 142500.0n 0.5410 142749.9n 0.5410 142750.0n 0.4284 142999.9n 0.4284 143000.0n 0.5941 143249.9n 0.5941 143250.0n 0.4151 143499.9n 0.4151 143500.0n 0.5742 143749.9n 0.5742 143750.0n 0.5079 143999.9n 0.5079 144000.0n 0.4217 144249.9n 0.4217 144250.0n 0.6537 144499.9n 0.6537 144500.0n 0.5278 144749.9n 0.5278 144750.0n 0.6537 144999.9n 0.6537 145000.0n 0.6206 145249.9n 0.6206 145250.0n 0.4549 145499.9n 0.4549 145500.0n 0.6206 145749.9n 0.6206 145750.0n 0.5675 145999.9n 0.5675 146000.0n 0.5212 146249.9n 0.5212 146250.0n 0.6670 146499.9n 0.6670 146500.0n 0.3356 146749.9n 0.3356 146750.0n 0.5079 146999.9n 0.5079 147000.0n 0.4416 147249.9n 0.4416 147250.0n 0.6537 147499.9n 0.6537 147500.0n 0.4549 147749.9n 0.4549 147750.0n 0.6471 147999.9n 0.6471 148000.0n 0.5675 148249.9n 0.5675 148250.0n 0.6073 148499.9n 0.6073 148500.0n 0.6073 148749.9n 0.6073 148750.0n 0.6206 148999.9n 0.6206 149000.0n 0.6272 149249.9n 0.6272 149250.0n 0.4880 149499.9n 0.4880 149500.0n 0.4217 149749.9n 0.4217 149750.0n 0.4549 149999.9n 0.4549 150000.0n 0.5410 150249.9n 0.5410 150250.0n 0.4284 150499.9n 0.4284 150500.0n 0.5941 150749.9n 0.5941 150750.0n 0.4151 150999.9n 0.4151 151000.0n 0.5742 151249.9n 0.5742 151250.0n 0.5079 151499.9n 0.5079 151500.0n 0.4217 151749.9n 0.4217 151750.0n 0.6537 151999.9n 0.6537 152000.0n 0.5278 152249.9n 0.5278 152250.0n 0.6537 152499.9n 0.6537 152500.0n 0.6206 152749.9n 0.6206 152750.0n 0.4549 152999.9n 0.4549 153000.0n 0.6206 153249.9n 0.6206 153250.0n 0.5675 153499.9n 0.5675 153500.0n 0.5212 153749.9n 0.5212 153750.0n 0.6670 153999.9n 0.6670 154000.0n 0.3356 154249.9n 0.3356 154250.0n 0.5079 154499.9n 0.5079 154500.0n 0.4416 154749.9n 0.4416 154750.0n 0.6537 154999.9n 0.6537 155000.0n 0.4549 155249.9n 0.4549 155250.0n 0.6471 155499.9n 0.6471 155500.0n 0.5675 155749.9n 0.5675 155750.0n 0.6073 155999.9n 0.6073 156000.0n 0.6073 156249.9n 0.6073 156250.0n 0.6206 156499.9n 0.6206 156500.0n 0.6272 156749.9n 0.6272 156750.0n 0.4880 156999.9n 0.4880 157000.0n 0.4217 157249.9n 0.4217 157250.0n 0.4549 157499.9n 0.4549 157500.0n 0.5410 157749.9n 0.5410 157750.0n 0.4284 157999.9n 0.4284 158000.0n 0.5941 158249.9n 0.5941 158250.0n 0.4151 158499.9n 0.4151 158500.0n 0.5742 158749.9n 0.5742 158750.0n 0.5079 158999.9n 0.5079 159000.0n 0.4217 159249.9n 0.4217 159250.0n 0.6537 159499.9n 0.6537 159500.0n 0.5278 159749.9n 0.5278 159750.0n 0.6537 159999.9n 0.6537 160000.0n 0.6206 160249.9n 0.6206 160250.0n 0.4549 160499.9n 0.4549 160500.0n 0.6206 160749.9n 0.6206 160750.0n 0.5675 160999.9n 0.5675 161000.0n 0.5212 161249.9n 0.5212 161250.0n 0.6670 161499.9n 0.6670 161500.0n 0.3356 161749.9n 0.3356 161750.0n 0.5079 161999.9n 0.5079 162000.0n 0.4416 162249.9n 0.4416 162250.0n 0.6537 162499.9n 0.6537 162500.0n 0.4549 162749.9n 0.4549 162750.0n 0.6471 162999.9n 0.6471 163000.0n 0.5675 163249.9n 0.5675 163250.0n 0.6073 163499.9n 0.6073 163500.0n 0.6073 163749.9n 0.6073 163750.0n 0.6206 163999.9n 0.6206 164000.0n 0.6272 164249.9n 0.6272 164250.0n 0.4880 164499.9n 0.4880 164500.0n 0.4217 164749.9n 0.4217 164750.0n 0.4549 164999.9n 0.4549 165000.0n 0.5410 165249.9n 0.5410 165250.0n 0.4284 165499.9n 0.4284 165500.0n 0.5941 165749.9n 0.5941 165750.0n 0.4151 165999.9n 0.4151 166000.0n 0.5742 166249.9n 0.5742 166250.0n 0.5079 166499.9n 0.5079 166500.0n 0.4217 166749.9n 0.4217 166750.0n 0.6537 166999.9n 0.6537 167000.0n 0.5278 167249.9n 0.5278 167250.0n 0.6537 167499.9n 0.6537 167500.0n 0.6206 167749.9n 0.6206 167750.0n 0.4549 167999.9n 0.4549 168000.0n 0.6206 168249.9n 0.6206 168250.0n 0.5675 168499.9n 0.5675 168500.0n 0.5212 168749.9n 0.5212 168750.0n 0.6670 168999.9n 0.6670 169000.0n 0.3356 169249.9n 0.3356 169250.0n 0.5079 169499.9n 0.5079 169500.0n 0.4416 169749.9n 0.4416 169750.0n 0.6537 169999.9n 0.6537 170000.0n 0.4549 170249.9n 0.4549 170250.0n 0.6471 170499.9n 0.6471 170500.0n 0.5675 170749.9n 0.5675 170750.0n 0.6073 170999.9n 0.6073 171000.0n 0.6073 171249.9n 0.6073 171250.0n 0.6206 171499.9n 0.6206 171500.0n 0.6272 171749.9n 0.6272 171750.0n 0.4880 171999.9n 0.4880 172000.0n 0.4217 172249.9n 0.4217 172250.0n 0.4549 172499.9n 0.4549 172500.0n 0.5410 172749.9n 0.5410 172750.0n 0.4284 172999.9n 0.4284 173000.0n 0.5941 173249.9n 0.5941 173250.0n 0.4151 173499.9n 0.4151 173500.0n 0.5742 173749.9n 0.5742 173750.0n 0.5079 173999.9n 0.5079 174000.0n 0.4217 174249.9n 0.4217 174250.0n 0.6537 174499.9n 0.6537 174500.0n 0.5278 174749.9n 0.5278 174750.0n 0.6537 174999.9n 0.6537 175000.0n 0.6206 175249.9n 0.6206 175250.0n 0.4549 175499.9n 0.4549 175500.0n 0.6206 175749.9n 0.6206 175750.0n 0.5675 175999.9n 0.5675 176000.0n 0.5212 176249.9n 0.5212 176250.0n 0.6670 176499.9n 0.6670 176500.0n 0.3356 176749.9n 0.3356 176750.0n 0.5079 176999.9n 0.5079 177000.0n 0.4416 177249.9n 0.4416 177250.0n 0.6537 177499.9n 0.6537 177500.0n 0.4549 177749.9n 0.4549 177750.0n 0.6471 177999.9n 0.6471 178000.0n 0.5675 178249.9n 0.5675 178250.0n 0.6073 178499.9n 0.6073 178500.0n 0.6073 178749.9n 0.6073 178750.0n 0.6206 178999.9n 0.6206 179000.0n 0.6272 179249.9n 0.6272 179250.0n 0.4880 179499.9n 0.4880 179500.0n 0.4217 179749.9n 0.4217 179750.0n 0.4549 179999.9n 0.4549 180000.0n 0.5410 180249.9n 0.5410 180250.0n 0.4284 180499.9n 0.4284 180500.0n 0.5941 180749.9n 0.5941 180750.0n 0.4151 180999.9n 0.4151 181000.0n 0.5742 181249.9n 0.5742 181250.0n 0.5079 181499.9n 0.5079 181500.0n 0.4217 181749.9n 0.4217 181750.0n 0.6537 181999.9n 0.6537 182000.0n 0.5278 182249.9n 0.5278 182250.0n 0.6537 182499.9n 0.6537 182500.0n 0.6206 182749.9n 0.6206 182750.0n 0.4549 182999.9n 0.4549 183000.0n 0.6206 183249.9n 0.6206 183250.0n 0.5675 183499.9n 0.5675 183500.0n 0.5212 183749.9n 0.5212 183750.0n 0.6670 183999.9n 0.6670 184000.0n 0.3356 184249.9n 0.3356 184250.0n 0.5079 184499.9n 0.5079 184500.0n 0.4416 184749.9n 0.4416 184750.0n 0.6537 184999.9n 0.6537 185000.0n 0.4549 185249.9n 0.4549 185250.0n 0.6471 185499.9n 0.6471 185500.0n 0.5675 185749.9n 0.5675 185750.0n 0.6073 185999.9n 0.6073 186000.0n 0.6073 186249.9n 0.6073 186250.0n 0.6206 186499.9n 0.6206 186500.0n 0.6272 186749.9n 0.6272 186750.0n 0.4880 186999.9n 0.4880 187000.0n 0.4217 187249.9n 0.4217 187250.0n 0.4549 187499.9n 0.4549 187500.0n 0.5410 187749.9n 0.5410 187750.0n 0.4284 187999.9n 0.4284 188000.0n 0.5941 188249.9n 0.5941 188250.0n 0.4151 188499.9n 0.4151 188500.0n 0.5742 188749.9n 0.5742 188750.0n 0.5079 188999.9n 0.5079 189000.0n 0.4217 189249.9n 0.4217 189250.0n 0.6537 189499.9n 0.6537 189500.0n 0.5278 189749.9n 0.5278 189750.0n 0.6537 189999.9n 0.6537 190000.0n 0.6206 190249.9n 0.6206 190250.0n 0.4549 190499.9n 0.4549 190500.0n 0.6206 190749.9n 0.6206 190750.0n 0.5675 190999.9n 0.5675 191000.0n 0.5212 191249.9n 0.5212 191250.0n 0.6670 191499.9n 0.6670 191500.0n 0.3356 191749.9n 0.3356 191750.0n 0.5079 191999.9n 0.5079 192000.0n 0.4416 192249.9n 0.4416 192250.0n 0.6537 192499.9n 0.6537 192500.0n 0.4549 192749.9n 0.4549 192750.0n 0.6471 192999.9n 0.6471 193000.0n 0.5675 193249.9n 0.5675 193250.0n 0.6073 193499.9n 0.6073 193500.0n 0.6073 193749.9n 0.6073 193750.0n 0.6206 193999.9n 0.6206 194000.0n 0.6272 194249.9n 0.6272 194250.0n 0.4880 194499.9n 0.4880 194500.0n 0.4217 194749.9n 0.4217 194750.0n 0.4549 194999.9n 0.4549 195000.0n 0.5410 195249.9n 0.5410 195250.0n 0.4284 195499.9n 0.4284 195500.0n 0.5941 195749.9n 0.5941 195750.0n 0.4151 195999.9n 0.4151 196000.0n 0.5742 196249.9n 0.5742 196250.0n 0.5079 196499.9n 0.5079 196500.0n 0.4217 196749.9n 0.4217 196750.0n 0.6537 196999.9n 0.6537 197000.0n 0.5278 197249.9n 0.5278 197250.0n 0.6537 197499.9n 0.6537 197500.0n 0.6206 197749.9n 0.6206 197750.0n 0.4549 197999.9n 0.4549 198000.0n 0.6206 198249.9n 0.6206 198250.0n 0.5675 198499.9n 0.5675 198500.0n 0.5212 198749.9n 0.5212 198750.0n 0.6670 198999.9n 0.6670 199000.0n 0.3356 199249.9n 0.3356 199250.0n 0.5079 199499.9n 0.5079 199500.0n 0.4416 199749.9n 0.4416 199750.0n 0.6537 199999.9n 0.6537 200000.0n 0.4549 200249.9n 0.4549 200250.0n 0.6471 200499.9n 0.6471 200500.0n 0.5675 200749.9n 0.5675 200750.0n 0.6073 200999.9n 0.6073 201000.0n 0.6073 201249.9n 0.6073 201250.0n 0.6206 201499.9n 0.6206 201500.0n 0.6272 201749.9n 0.6272 201750.0n 0.4880 201999.9n 0.4880 202000.0n 0.4217 202249.9n 0.4217 202250.0n 0.4549 202499.9n 0.4549 202500.0n 0.5410 202749.9n 0.5410 202750.0n 0.4284 202999.9n 0.4284 203000.0n 0.5941 203249.9n 0.5941 203250.0n 0.4151 203499.9n 0.4151 203500.0n 0.5742 203749.9n 0.5742 203750.0n 0.5079 203999.9n 0.5079 204000.0n 0.4217 204249.9n 0.4217 204250.0n 0.6537 204499.9n 0.6537 204500.0n 0.5278 204749.9n 0.5278 204750.0n 0.6537 204999.9n 0.6537 205000.0n 0.6206 205249.9n 0.6206 205250.0n 0.4549 205499.9n 0.4549 205500.0n 0.6206 205749.9n 0.6206 205750.0n 0.5675 205999.9n 0.5675 206000.0n 0.5212 206249.9n 0.5212 206250.0n 0.6670 206499.9n 0.6670 206500.0n 0.3356 206749.9n 0.3356 206750.0n 0.5079 206999.9n 0.5079 207000.0n 0.4416 207249.9n 0.4416 207250.0n 0.6537 207499.9n 0.6537 207500.0n 0.4549 207749.9n 0.4549 207750.0n 0.6471 207999.9n 0.6471 208000.0n 0.5675 208249.9n 0.5675 208250.0n 0.6073 208499.9n 0.6073 208500.0n 0.6073 208749.9n 0.6073 208750.0n 0.6206 208999.9n 0.6206 209000.0n 0.6272 209249.9n 0.6272 209250.0n 0.4880 209499.9n 0.4880 209500.0n 0.4217 209749.9n 0.4217 209750.0n 0.4549 209999.9n 0.4549 210000.0n 0.5410 210249.9n 0.5410 210250.0n 0.4284 210499.9n 0.4284 210500.0n 0.5941 210749.9n 0.5941 210750.0n 0.4151 210999.9n 0.4151 211000.0n 0.5742 211249.9n 0.5742 211250.0n 0.5079 211499.9n 0.5079 211500.0n 0.4217 211749.9n 0.4217 211750.0n 0.6537 211999.9n 0.6537 212000.0n 0.5278 212249.9n 0.5278 212250.0n 0.6537 212499.9n 0.6537 212500.0n 0.6206 212749.9n 0.6206 212750.0n 0.4549 212999.9n 0.4549 213000.0n 0.6206 213249.9n 0.6206 213250.0n 0.5675 213499.9n 0.5675 213500.0n 0.5212 213749.9n 0.5212 213750.0n 0.6670 213999.9n 0.6670 214000.0n 0.3356 214249.9n 0.3356 214250.0n 0.5079 214499.9n 0.5079 214500.0n 0.4416 214749.9n 0.4416 214750.0n 0.6537 214999.9n 0.6537 215000.0n 0.4549 215249.9n 0.4549 215250.0n 0.6471 215499.9n 0.6471 215500.0n 0.5675 215749.9n 0.5675 215750.0n 0.6073 215999.9n 0.6073 216000.0n 0.6073 216249.9n 0.6073 216250.0n 0.6206 216499.9n 0.6206 216500.0n 0.6272 216749.9n 0.6272 216750.0n 0.4880 216999.9n 0.4880 217000.0n 0.4217 217249.9n 0.4217 217250.0n 0.4549 217499.9n 0.4549 217500.0n 0.5410 217749.9n 0.5410 217750.0n 0.4284 217999.9n 0.4284 218000.0n 0.5941 218249.9n 0.5941 218250.0n 0.4151 218499.9n 0.4151 218500.0n 0.5742 218749.9n 0.5742 218750.0n 0.5079 218999.9n 0.5079 219000.0n 0.4217 219249.9n 0.4217 219250.0n 0.6537 219499.9n 0.6537 219500.0n 0.5278 219749.9n 0.5278 219750.0n 0.6537 219999.9n 0.6537 220000.0n 0.6206 220249.9n 0.6206 220250.0n 0.4549 220499.9n 0.4549 220500.0n 0.6206 220749.9n 0.6206 220750.0n 0.5675 220999.9n 0.5675 221000.0n 0.5212 221249.9n 0.5212 221250.0n 0.6670 221499.9n 0.6670 221500.0n 0.3356 221749.9n 0.3356 221750.0n 0.5079 221999.9n 0.5079 222000.0n 0.4416 222249.9n 0.4416 222250.0n 0.6537 222499.9n 0.6537 222500.0n 0.4549 222749.9n 0.4549 222750.0n 0.6471 222999.9n 0.6471 223000.0n 0.5675 223249.9n 0.5675 223250.0n 0.6073 223499.9n 0.6073 223500.0n 0.6073 223749.9n 0.6073 223750.0n 0.6206 223999.9n 0.6206 224000.0n 0.6272 224249.9n 0.6272 224250.0n 0.4880 224499.9n 0.4880 224500.0n 0.4217 224749.9n 0.4217 224750.0n 0.4549 224999.9n 0.4549 225000.0n 0.5410 225249.9n 0.5410 225250.0n 0.4284 225499.9n 0.4284 225500.0n 0.5941 225749.9n 0.5941 225750.0n 0.4151 225999.9n 0.4151 226000.0n 0.5742 226249.9n 0.5742 226250.0n 0.5079 226499.9n 0.5079 226500.0n 0.4217 226749.9n 0.4217 226750.0n 0.6537 226999.9n 0.6537 227000.0n 0.5278 227249.9n 0.5278 227250.0n 0.6537 227499.9n 0.6537 227500.0n 0.6206 227749.9n 0.6206 227750.0n 0.4549 227999.9n 0.4549 228000.0n 0.6206 228249.9n 0.6206 228250.0n 0.5675 228499.9n 0.5675 228500.0n 0.5212 228749.9n 0.5212 228750.0n 0.6670 228999.9n 0.6670 229000.0n 0.3356 229249.9n 0.3356 229250.0n 0.5079 229499.9n 0.5079 229500.0n 0.4416 229749.9n 0.4416 229750.0n 0.6537 229999.9n 0.6537 230000.0n 0.4549 230249.9n 0.4549 230250.0n 0.6471 230499.9n 0.6471 230500.0n 0.5675 230749.9n 0.5675 230750.0n 0.6073 230999.9n 0.6073 231000.0n 0.6073 231249.9n 0.6073 231250.0n 0.6206 231499.9n 0.6206 231500.0n 0.6272 231749.9n 0.6272 231750.0n 0.4880 231999.9n 0.4880 232000.0n 0.4217 232249.9n 0.4217 232250.0n 0.4549 232499.9n 0.4549 232500.0n 0.5410 232749.9n 0.5410 232750.0n 0.4284 232999.9n 0.4284 233000.0n 0.5941 233249.9n 0.5941 233250.0n 0.4151 233499.9n 0.4151 233500.0n 0.5742 233749.9n 0.5742 233750.0n 0.5079 233999.9n 0.5079 234000.0n 0.4217 234249.9n 0.4217 234250.0n 0.6537 234499.9n 0.6537 234500.0n 0.5278 234749.9n 0.5278 234750.0n 0.6537 234999.9n 0.6537 235000.0n 0.6206 235249.9n 0.6206 235250.0n 0.4549 235499.9n 0.4549 235500.0n 0.6206 235749.9n 0.6206 235750.0n 0.5675 235999.9n 0.5675 236000.0n 0.5212 236249.9n 0.5212 236250.0n 0.6670 236499.9n 0.6670 236500.0n 0.3356 236749.9n 0.3356 236750.0n 0.5079 236999.9n 0.5079 237000.0n 0.4416 237249.9n 0.4416 237250.0n 0.6537 237499.9n 0.6537 237500.0n 0.4549 237749.9n 0.4549 237750.0n 0.6471 237999.9n 0.6471 238000.0n 0.5675 238249.9n 0.5675 238250.0n 0.6073 238499.9n 0.6073 238500.0n 0.6073 238749.9n 0.6073 238750.0n 0.6206 238999.9n 0.6206 239000.0n 0.6272 239249.9n 0.6272 239250.0n 0.4880 239499.9n 0.4880 239500.0n 0.4217 239749.9n 0.4217 239750.0n 0.4549 239999.9n 0.4549 240000.0n 0.5410 240249.9n 0.5410 240250.0n 0.4284 240499.9n 0.4284 240500.0n 0.5941 240749.9n 0.5941 240750.0n 0.4151 240999.9n 0.4151 241000.0n 0.5742 241249.9n 0.5742 241250.0n 0.5079 241499.9n 0.5079 241500.0n 0.4217 241749.9n 0.4217 241750.0n 0.6537 241999.9n 0.6537 242000.0n 0.5278 242249.9n 0.5278 242250.0n 0.6537 242499.9n 0.6537 242500.0n 0.6206 242749.9n 0.6206 242750.0n 0.4549 242999.9n 0.4549 243000.0n 0.6206 243249.9n 0.6206 243250.0n 0.5675 243499.9n 0.5675 243500.0n 0.5212 243749.9n 0.5212 243750.0n 0.6670 243999.9n 0.6670 244000.0n 0.3356 244249.9n 0.3356 244250.0n 0.5079 244499.9n 0.5079 244500.0n 0.4416 244749.9n 0.4416 244750.0n 0.6537 244999.9n 0.6537 245000.0n 0.4549 245249.9n 0.4549 245250.0n 0.6471 245499.9n 0.6471 245500.0n 0.5675 245749.9n 0.5675 245750.0n 0.6073 245999.9n 0.6073 246000.0n 0.6073 246249.9n 0.6073 246250.0n 0.6206 246499.9n 0.6206 246500.0n 0.6272 246749.9n 0.6272 246750.0n 0.4880 246999.9n 0.4880 247000.0n 0.4217 247249.9n 0.4217 247250.0n 0.4549 247499.9n 0.4549 247500.0n 0.5410 247749.9n 0.5410 247750.0n 0.4284 247999.9n 0.4284 248000.0n 0.5941 248249.9n 0.5941 248250.0n 0.4151 248499.9n 0.4151 248500.0n 0.5742 248749.9n 0.5742 248750.0n 0.5079 248999.9n 0.5079 249000.0n 0.4217 249249.9n 0.4217 249250.0n 0.6537 249499.9n 0.6537 249500.0n 0.5278 249749.9n 0.5278 249750.0n 0.6537 249999.9n 0.6537 250000.0n 0.6206 250249.9n 0.6206 250250.0n 0.4549 250499.9n 0.4549 250500.0n 0.6206 250749.9n 0.6206 250750.0n 0.5675 250999.9n 0.5675 251000.0n 0.5212 251249.9n 0.5212 251250.0n 0.6670 251499.9n 0.6670 251500.0n 0.3356 251749.9n 0.3356 251750.0n 0.5079 251999.9n 0.5079 252000.0n 0.4416 252249.9n 0.4416 252250.0n 0.6537 252499.9n 0.6537 252500.0n 0.4549 252749.9n 0.4549 252750.0n 0.6471 252999.9n 0.6471 253000.0n 0.5675 253249.9n 0.5675 253250.0n 0.6073 253499.9n 0.6073 253500.0n 0.6073 253749.9n 0.6073 253750.0n 0.6206 253999.9n 0.6206 254000.0n 0.6272 254249.9n 0.6272 254250.0n 0.4880 254499.9n 0.4880 254500.0n 0.4217 254749.9n 0.4217 254750.0n 0.4549 254999.9n 0.4549 255000.0n 0.5410 255249.9n 0.5410 255250.0n 0.4284 255499.9n 0.4284 255500.0n 0.5941 255749.9n 0.5941 255750.0n 0.4151 255999.9n 0.4151 256000.0n 0.5742 256249.9n 0.5742 256250.0n 0.5079 256499.9n 0.5079 256500.0n 0.4217 256749.9n 0.4217 256750.0n 0.6537 256999.9n 0.6537 257000.0n 0.5278 257249.9n 0.5278 257250.0n 0.6537 257499.9n 0.6537 257500.0n 0.6206 257749.9n 0.6206 257750.0n 0.4549 257999.9n 0.4549 258000.0n 0.6206 258249.9n 0.6206 258250.0n 0.5675 258499.9n 0.5675 258500.0n 0.5212 258749.9n 0.5212 258750.0n 0.6670 258999.9n 0.6670 259000.0n 0.3356 259249.9n 0.3356 259250.0n 0.5079 259499.9n 0.5079 259500.0n 0.4416 259749.9n 0.4416 259750.0n 0.6537 259999.9n 0.6537 260000.0n 0.4549 260249.9n 0.4549 260250.0n 0.6471 260499.9n 0.6471 260500.0n 0.5675 260749.9n 0.5675 260750.0n 0.6073 260999.9n 0.6073 261000.0n 0.6073 261249.9n 0.6073 261250.0n 0.6206 261499.9n 0.6206 261500.0n 0.6272 261749.9n 0.6272 261750.0n 0.4880 261999.9n 0.4880 262000.0n 0.4217 262249.9n 0.4217 262250.0n 0.4549 262499.9n 0.4549 262500.0n 0.5410 262749.9n 0.5410 262750.0n 0.4284 262999.9n 0.4284 263000.0n 0.5941 263249.9n 0.5941 263250.0n 0.4151 263499.9n 0.4151 263500.0n 0.5742 263749.9n 0.5742 263750.0n 0.5079 263999.9n 0.5079 264000.0n 0.4217 264249.9n 0.4217 264250.0n 0.6537 264499.9n 0.6537 264500.0n 0.5278 264749.9n 0.5278 264750.0n 0.6537 264999.9n 0.6537 265000.0n 0.6206 265249.9n 0.6206 265250.0n 0.4549 265499.9n 0.4549 265500.0n 0.6206 265749.9n 0.6206 265750.0n 0.5675 265999.9n 0.5675 266000.0n 0.5212 266249.9n 0.5212 266250.0n 0.6670 266499.9n 0.6670 266500.0n 0.3356 266749.9n 0.3356 266750.0n 0.5079 266999.9n 0.5079 267000.0n 0.4416 267249.9n 0.4416 267250.0n 0.6537 267499.9n 0.6537 267500.0n 0.4549 267749.9n 0.4549 267750.0n 0.6471 267999.9n 0.6471 268000.0n 0.5675 268249.9n 0.5675 268250.0n 0.6073 268499.9n 0.6073 268500.0n 0.6073 268749.9n 0.6073 268750.0n 0.6206 268999.9n 0.6206 269000.0n 0.6272 269249.9n 0.6272 269250.0n 0.4880 269499.9n 0.4880 269500.0n 0.4217 269749.9n 0.4217 269750.0n 0.4549 269999.9n 0.4549 270000.0n 0.5410 270249.9n 0.5410 270250.0n 0.4284 270499.9n 0.4284 270500.0n 0.5941 270749.9n 0.5941 270750.0n 0.4151 270999.9n 0.4151 271000.0n 0.5742 271249.9n 0.5742 271250.0n 0.5079 271499.9n 0.5079 271500.0n 0.4217 271749.9n 0.4217 271750.0n 0.6537 271999.9n 0.6537 272000.0n 0.5278 272249.9n 0.5278 272250.0n 0.6537 272499.9n 0.6537 272500.0n 0.6206 272749.9n 0.6206 272750.0n 0.4549 272999.9n 0.4549 273000.0n 0.6206 273249.9n 0.6206 273250.0n 0.5675 273499.9n 0.5675 273500.0n 0.5212 273749.9n 0.5212 273750.0n 0.6670 273999.9n 0.6670 274000.0n 0.3356 274249.9n 0.3356 274250.0n 0.5079 274499.9n 0.5079 274500.0n 0.4416 274749.9n 0.4416 274750.0n 0.6537 274999.9n 0.6537 275000.0n 0.4549 275249.9n 0.4549 275250.0n 0.6471 275499.9n 0.6471 275500.0n 0.5675 275749.9n 0.5675 275750.0n 0.6073 275999.9n 0.6073 276000.0n 0.6073 276249.9n 0.6073 276250.0n 0.6206 276499.9n 0.6206 276500.0n 0.6272 276749.9n 0.6272 276750.0n 0.4880 276999.9n 0.4880 277000.0n 0.4217 277249.9n 0.4217 277250.0n 0.4549 277499.9n 0.4549 277500.0n 0.5410 277749.9n 0.5410 277750.0n 0.4284 277999.9n 0.4284 278000.0n 0.5941 278249.9n 0.5941 278250.0n 0.4151 278499.9n 0.4151 278500.0n 0.5742 278749.9n 0.5742 278750.0n 0.5079 278999.9n 0.5079 279000.0n 0.4217 279249.9n 0.4217 279250.0n 0.6537 279499.9n 0.6537 279500.0n 0.5278 279749.9n 0.5278 279750.0n 0.6537 279999.9n 0.6537 280000.0n 0.6206 280249.9n 0.6206 280250.0n 0.4549 280499.9n 0.4549 280500.0n 0.6206 280749.9n 0.6206 280750.0n 0.5675 280999.9n 0.5675 281000.0n 0.5212 281249.9n 0.5212 281250.0n 0.6670 281499.9n 0.6670 281500.0n 0.3356 281749.9n 0.3356 281750.0n 0.5079 281999.9n 0.5079 282000.0n 0.4416 282249.9n 0.4416 282250.0n 0.6537 282499.9n 0.6537 282500.0n 0.4549 282749.9n 0.4549 282750.0n 0.6471 282999.9n 0.6471 283000.0n 0.5675 283249.9n 0.5675 283250.0n 0.6073 283499.9n 0.6073 283500.0n 0.6073 283749.9n 0.6073 283750.0n 0.6206 283999.9n 0.6206 284000.0n 0.6272 284249.9n 0.6272 284250.0n 0.4880 284499.9n 0.4880 284500.0n 0.4217 284749.9n 0.4217 284750.0n 0.4549 284999.9n 0.4549 285000.0n 0.5410 285249.9n 0.5410 285250.0n 0.4284 285499.9n 0.4284 285500.0n 0.5941 285749.9n 0.5941 285750.0n 0.4151 285999.9n 0.4151 286000.0n 0.5742 286249.9n 0.5742 286250.0n 0.5079 286499.9n 0.5079 286500.0n 0.4217 286749.9n 0.4217 286750.0n 0.6537 286999.9n 0.6537 287000.0n 0.5278 287249.9n 0.5278 287250.0n 0.6537 287499.9n 0.6537 287500.0n 0.6206 287749.9n 0.6206 287750.0n 0.4549 287999.9n 0.4549 288000.0n 0.6206 288249.9n 0.6206 288250.0n 0.5675 288499.9n 0.5675 288500.0n 0.5212 288749.9n 0.5212 288750.0n 0.6670 288999.9n 0.6670 289000.0n 0.3356 289249.9n 0.3356 289250.0n 0.5079 289499.9n 0.5079 289500.0n 0.4416 289749.9n 0.4416 289750.0n 0.6537 289999.9n 0.6537 290000.0n 0.4549 290249.9n 0.4549 290250.0n 0.6471 290499.9n 0.6471 290500.0n 0.5675 290749.9n 0.5675 290750.0n 0.6073 290999.9n 0.6073 291000.0n 0.6073 291249.9n 0.6073 291250.0n 0.6206 291499.9n 0.6206 291500.0n 0.6272 291749.9n 0.6272 291750.0n 0.4880 291999.9n 0.4880 292000.0n 0.4217 292249.9n 0.4217 292250.0n 0.4549 292499.9n 0.4549 292500.0n 0.5410 292749.9n 0.5410 292750.0n 0.4284 292999.9n 0.4284 293000.0n 0.5941 293249.9n 0.5941 293250.0n 0.4151 293499.9n 0.4151 293500.0n 0.5742 293749.9n 0.5742 293750.0n 0.5079 293999.9n 0.5079 294000.0n 0.4217 294249.9n 0.4217 294250.0n 0.6537 294499.9n 0.6537 294500.0n 0.5278 294749.9n 0.5278 294750.0n 0.6537 294999.9n 0.6537 295000.0n 0.6206 295249.9n 0.6206 295250.0n 0.4549 295499.9n 0.4549 295500.0n 0.6206 295749.9n 0.6206 295750.0n 0.5675 295999.9n 0.5675 296000.0n 0.5212 296249.9n 0.5212 296250.0n 0.6670 296499.9n 0.6670 296500.0n 0.3356 296749.9n 0.3356 296750.0n 0.5079 296999.9n 0.5079 297000.0n 0.4416 297249.9n 0.4416 297250.0n 0.6537 297499.9n 0.6537 297500.0n 0.4549 297749.9n 0.4549 297750.0n 0.6471 297999.9n 0.6471 298000.0n 0.5675 298249.9n 0.5675 298250.0n 0.6073 298499.9n 0.6073 298500.0n 0.6073 298749.9n 0.6073 298750.0n 0.6206 298999.9n 0.6206 299000.0n 0.6272 299249.9n 0.6272 299250.0n 0.4880 299499.9n 0.4880 299500.0n 0.4217 299749.9n 0.4217 299750.0n 0.4549)
Vxn5 a_xn5 0 PWL(0.0n 0.4590 249.9n 0.4590 250.0n 0.5716 499.9n 0.5716 500.0n 0.4059 749.9n 0.4059 750.0n 0.5849 999.9n 0.5849 1000.0n 0.4258 1249.9n 0.4258 1250.0n 0.4921 1499.9n 0.4921 1500.0n 0.5783 1749.9n 0.5783 1750.0n 0.3463 1999.9n 0.3463 2000.0n 0.4722 2249.9n 0.4722 2250.0n 0.3463 2499.9n 0.3463 2500.0n 0.3794 2749.9n 0.3794 2750.0n 0.5451 2999.9n 0.5451 3000.0n 0.3794 3249.9n 0.3794 3250.0n 0.4325 3499.9n 0.4325 3500.0n 0.4788 3749.9n 0.4788 3750.0n 0.3330 3999.9n 0.3330 4000.0n 0.6644 4249.9n 0.6644 4250.0n 0.4921 4499.9n 0.4921 4500.0n 0.5584 4749.9n 0.5584 4750.0n 0.3463 4999.9n 0.3463 5000.0n 0.5451 5249.9n 0.5451 5250.0n 0.3529 5499.9n 0.3529 5500.0n 0.4325 5749.9n 0.4325 5750.0n 0.3927 5999.9n 0.3927 6000.0n 0.3927 6249.9n 0.3927 6250.0n 0.3794 6499.9n 0.3794 6500.0n 0.3728 6749.9n 0.3728 6750.0n 0.5120 6999.9n 0.5120 7000.0n 0.5783 7249.9n 0.5783 7250.0n 0.5451 7499.9n 0.5451 7500.0n 0.4590 7749.9n 0.4590 7750.0n 0.5716 7999.9n 0.5716 8000.0n 0.4059 8249.9n 0.4059 8250.0n 0.5849 8499.9n 0.5849 8500.0n 0.4258 8749.9n 0.4258 8750.0n 0.4921 8999.9n 0.4921 9000.0n 0.5783 9249.9n 0.5783 9250.0n 0.3463 9499.9n 0.3463 9500.0n 0.4722 9749.9n 0.4722 9750.0n 0.3463 9999.9n 0.3463 10000.0n 0.3794 10249.9n 0.3794 10250.0n 0.5451 10499.9n 0.5451 10500.0n 0.3794 10749.9n 0.3794 10750.0n 0.4325 10999.9n 0.4325 11000.0n 0.4788 11249.9n 0.4788 11250.0n 0.3330 11499.9n 0.3330 11500.0n 0.6644 11749.9n 0.6644 11750.0n 0.4921 11999.9n 0.4921 12000.0n 0.5584 12249.9n 0.5584 12250.0n 0.3463 12499.9n 0.3463 12500.0n 0.5451 12749.9n 0.5451 12750.0n 0.3529 12999.9n 0.3529 13000.0n 0.4325 13249.9n 0.4325 13250.0n 0.3927 13499.9n 0.3927 13500.0n 0.3927 13749.9n 0.3927 13750.0n 0.3794 13999.9n 0.3794 14000.0n 0.3728 14249.9n 0.3728 14250.0n 0.5120 14499.9n 0.5120 14500.0n 0.5783 14749.9n 0.5783 14750.0n 0.5451 14999.9n 0.5451 15000.0n 0.4590 15249.9n 0.4590 15250.0n 0.5716 15499.9n 0.5716 15500.0n 0.4059 15749.9n 0.4059 15750.0n 0.5849 15999.9n 0.5849 16000.0n 0.4258 16249.9n 0.4258 16250.0n 0.4921 16499.9n 0.4921 16500.0n 0.5783 16749.9n 0.5783 16750.0n 0.3463 16999.9n 0.3463 17000.0n 0.4722 17249.9n 0.4722 17250.0n 0.3463 17499.9n 0.3463 17500.0n 0.3794 17749.9n 0.3794 17750.0n 0.5451 17999.9n 0.5451 18000.0n 0.3794 18249.9n 0.3794 18250.0n 0.4325 18499.9n 0.4325 18500.0n 0.4788 18749.9n 0.4788 18750.0n 0.3330 18999.9n 0.3330 19000.0n 0.6644 19249.9n 0.6644 19250.0n 0.4921 19499.9n 0.4921 19500.0n 0.5584 19749.9n 0.5584 19750.0n 0.3463 19999.9n 0.3463 20000.0n 0.5451 20249.9n 0.5451 20250.0n 0.3529 20499.9n 0.3529 20500.0n 0.4325 20749.9n 0.4325 20750.0n 0.3927 20999.9n 0.3927 21000.0n 0.3927 21249.9n 0.3927 21250.0n 0.3794 21499.9n 0.3794 21500.0n 0.3728 21749.9n 0.3728 21750.0n 0.5120 21999.9n 0.5120 22000.0n 0.5783 22249.9n 0.5783 22250.0n 0.5451 22499.9n 0.5451 22500.0n 0.4590 22749.9n 0.4590 22750.0n 0.5716 22999.9n 0.5716 23000.0n 0.4059 23249.9n 0.4059 23250.0n 0.5849 23499.9n 0.5849 23500.0n 0.4258 23749.9n 0.4258 23750.0n 0.4921 23999.9n 0.4921 24000.0n 0.5783 24249.9n 0.5783 24250.0n 0.3463 24499.9n 0.3463 24500.0n 0.4722 24749.9n 0.4722 24750.0n 0.3463 24999.9n 0.3463 25000.0n 0.3794 25249.9n 0.3794 25250.0n 0.5451 25499.9n 0.5451 25500.0n 0.3794 25749.9n 0.3794 25750.0n 0.4325 25999.9n 0.4325 26000.0n 0.4788 26249.9n 0.4788 26250.0n 0.3330 26499.9n 0.3330 26500.0n 0.6644 26749.9n 0.6644 26750.0n 0.4921 26999.9n 0.4921 27000.0n 0.5584 27249.9n 0.5584 27250.0n 0.3463 27499.9n 0.3463 27500.0n 0.5451 27749.9n 0.5451 27750.0n 0.3529 27999.9n 0.3529 28000.0n 0.4325 28249.9n 0.4325 28250.0n 0.3927 28499.9n 0.3927 28500.0n 0.3927 28749.9n 0.3927 28750.0n 0.3794 28999.9n 0.3794 29000.0n 0.3728 29249.9n 0.3728 29250.0n 0.5120 29499.9n 0.5120 29500.0n 0.5783 29749.9n 0.5783 29750.0n 0.5451 29999.9n 0.5451 30000.0n 0.4590 30249.9n 0.4590 30250.0n 0.5716 30499.9n 0.5716 30500.0n 0.4059 30749.9n 0.4059 30750.0n 0.5849 30999.9n 0.5849 31000.0n 0.4258 31249.9n 0.4258 31250.0n 0.4921 31499.9n 0.4921 31500.0n 0.5783 31749.9n 0.5783 31750.0n 0.3463 31999.9n 0.3463 32000.0n 0.4722 32249.9n 0.4722 32250.0n 0.3463 32499.9n 0.3463 32500.0n 0.3794 32749.9n 0.3794 32750.0n 0.5451 32999.9n 0.5451 33000.0n 0.3794 33249.9n 0.3794 33250.0n 0.4325 33499.9n 0.4325 33500.0n 0.4788 33749.9n 0.4788 33750.0n 0.3330 33999.9n 0.3330 34000.0n 0.6644 34249.9n 0.6644 34250.0n 0.4921 34499.9n 0.4921 34500.0n 0.5584 34749.9n 0.5584 34750.0n 0.3463 34999.9n 0.3463 35000.0n 0.5451 35249.9n 0.5451 35250.0n 0.3529 35499.9n 0.3529 35500.0n 0.4325 35749.9n 0.4325 35750.0n 0.3927 35999.9n 0.3927 36000.0n 0.3927 36249.9n 0.3927 36250.0n 0.3794 36499.9n 0.3794 36500.0n 0.3728 36749.9n 0.3728 36750.0n 0.5120 36999.9n 0.5120 37000.0n 0.5783 37249.9n 0.5783 37250.0n 0.5451 37499.9n 0.5451 37500.0n 0.4590 37749.9n 0.4590 37750.0n 0.5716 37999.9n 0.5716 38000.0n 0.4059 38249.9n 0.4059 38250.0n 0.5849 38499.9n 0.5849 38500.0n 0.4258 38749.9n 0.4258 38750.0n 0.4921 38999.9n 0.4921 39000.0n 0.5783 39249.9n 0.5783 39250.0n 0.3463 39499.9n 0.3463 39500.0n 0.4722 39749.9n 0.4722 39750.0n 0.3463 39999.9n 0.3463 40000.0n 0.3794 40249.9n 0.3794 40250.0n 0.5451 40499.9n 0.5451 40500.0n 0.3794 40749.9n 0.3794 40750.0n 0.4325 40999.9n 0.4325 41000.0n 0.4788 41249.9n 0.4788 41250.0n 0.3330 41499.9n 0.3330 41500.0n 0.6644 41749.9n 0.6644 41750.0n 0.4921 41999.9n 0.4921 42000.0n 0.5584 42249.9n 0.5584 42250.0n 0.3463 42499.9n 0.3463 42500.0n 0.5451 42749.9n 0.5451 42750.0n 0.3529 42999.9n 0.3529 43000.0n 0.4325 43249.9n 0.4325 43250.0n 0.3927 43499.9n 0.3927 43500.0n 0.3927 43749.9n 0.3927 43750.0n 0.3794 43999.9n 0.3794 44000.0n 0.3728 44249.9n 0.3728 44250.0n 0.5120 44499.9n 0.5120 44500.0n 0.5783 44749.9n 0.5783 44750.0n 0.5451 44999.9n 0.5451 45000.0n 0.4590 45249.9n 0.4590 45250.0n 0.5716 45499.9n 0.5716 45500.0n 0.4059 45749.9n 0.4059 45750.0n 0.5849 45999.9n 0.5849 46000.0n 0.4258 46249.9n 0.4258 46250.0n 0.4921 46499.9n 0.4921 46500.0n 0.5783 46749.9n 0.5783 46750.0n 0.3463 46999.9n 0.3463 47000.0n 0.4722 47249.9n 0.4722 47250.0n 0.3463 47499.9n 0.3463 47500.0n 0.3794 47749.9n 0.3794 47750.0n 0.5451 47999.9n 0.5451 48000.0n 0.3794 48249.9n 0.3794 48250.0n 0.4325 48499.9n 0.4325 48500.0n 0.4788 48749.9n 0.4788 48750.0n 0.3330 48999.9n 0.3330 49000.0n 0.6644 49249.9n 0.6644 49250.0n 0.4921 49499.9n 0.4921 49500.0n 0.5584 49749.9n 0.5584 49750.0n 0.3463 49999.9n 0.3463 50000.0n 0.5451 50249.9n 0.5451 50250.0n 0.3529 50499.9n 0.3529 50500.0n 0.4325 50749.9n 0.4325 50750.0n 0.3927 50999.9n 0.3927 51000.0n 0.3927 51249.9n 0.3927 51250.0n 0.3794 51499.9n 0.3794 51500.0n 0.3728 51749.9n 0.3728 51750.0n 0.5120 51999.9n 0.5120 52000.0n 0.5783 52249.9n 0.5783 52250.0n 0.5451 52499.9n 0.5451 52500.0n 0.4590 52749.9n 0.4590 52750.0n 0.5716 52999.9n 0.5716 53000.0n 0.4059 53249.9n 0.4059 53250.0n 0.5849 53499.9n 0.5849 53500.0n 0.4258 53749.9n 0.4258 53750.0n 0.4921 53999.9n 0.4921 54000.0n 0.5783 54249.9n 0.5783 54250.0n 0.3463 54499.9n 0.3463 54500.0n 0.4722 54749.9n 0.4722 54750.0n 0.3463 54999.9n 0.3463 55000.0n 0.3794 55249.9n 0.3794 55250.0n 0.5451 55499.9n 0.5451 55500.0n 0.3794 55749.9n 0.3794 55750.0n 0.4325 55999.9n 0.4325 56000.0n 0.4788 56249.9n 0.4788 56250.0n 0.3330 56499.9n 0.3330 56500.0n 0.6644 56749.9n 0.6644 56750.0n 0.4921 56999.9n 0.4921 57000.0n 0.5584 57249.9n 0.5584 57250.0n 0.3463 57499.9n 0.3463 57500.0n 0.5451 57749.9n 0.5451 57750.0n 0.3529 57999.9n 0.3529 58000.0n 0.4325 58249.9n 0.4325 58250.0n 0.3927 58499.9n 0.3927 58500.0n 0.3927 58749.9n 0.3927 58750.0n 0.3794 58999.9n 0.3794 59000.0n 0.3728 59249.9n 0.3728 59250.0n 0.5120 59499.9n 0.5120 59500.0n 0.5783 59749.9n 0.5783 59750.0n 0.5451 59999.9n 0.5451 60000.0n 0.4590 60249.9n 0.4590 60250.0n 0.5716 60499.9n 0.5716 60500.0n 0.4059 60749.9n 0.4059 60750.0n 0.5849 60999.9n 0.5849 61000.0n 0.4258 61249.9n 0.4258 61250.0n 0.4921 61499.9n 0.4921 61500.0n 0.5783 61749.9n 0.5783 61750.0n 0.3463 61999.9n 0.3463 62000.0n 0.4722 62249.9n 0.4722 62250.0n 0.3463 62499.9n 0.3463 62500.0n 0.3794 62749.9n 0.3794 62750.0n 0.5451 62999.9n 0.5451 63000.0n 0.3794 63249.9n 0.3794 63250.0n 0.4325 63499.9n 0.4325 63500.0n 0.4788 63749.9n 0.4788 63750.0n 0.3330 63999.9n 0.3330 64000.0n 0.6644 64249.9n 0.6644 64250.0n 0.4921 64499.9n 0.4921 64500.0n 0.5584 64749.9n 0.5584 64750.0n 0.3463 64999.9n 0.3463 65000.0n 0.5451 65249.9n 0.5451 65250.0n 0.3529 65499.9n 0.3529 65500.0n 0.4325 65749.9n 0.4325 65750.0n 0.3927 65999.9n 0.3927 66000.0n 0.3927 66249.9n 0.3927 66250.0n 0.3794 66499.9n 0.3794 66500.0n 0.3728 66749.9n 0.3728 66750.0n 0.5120 66999.9n 0.5120 67000.0n 0.5783 67249.9n 0.5783 67250.0n 0.5451 67499.9n 0.5451 67500.0n 0.4590 67749.9n 0.4590 67750.0n 0.5716 67999.9n 0.5716 68000.0n 0.4059 68249.9n 0.4059 68250.0n 0.5849 68499.9n 0.5849 68500.0n 0.4258 68749.9n 0.4258 68750.0n 0.4921 68999.9n 0.4921 69000.0n 0.5783 69249.9n 0.5783 69250.0n 0.3463 69499.9n 0.3463 69500.0n 0.4722 69749.9n 0.4722 69750.0n 0.3463 69999.9n 0.3463 70000.0n 0.3794 70249.9n 0.3794 70250.0n 0.5451 70499.9n 0.5451 70500.0n 0.3794 70749.9n 0.3794 70750.0n 0.4325 70999.9n 0.4325 71000.0n 0.4788 71249.9n 0.4788 71250.0n 0.3330 71499.9n 0.3330 71500.0n 0.6644 71749.9n 0.6644 71750.0n 0.4921 71999.9n 0.4921 72000.0n 0.5584 72249.9n 0.5584 72250.0n 0.3463 72499.9n 0.3463 72500.0n 0.5451 72749.9n 0.5451 72750.0n 0.3529 72999.9n 0.3529 73000.0n 0.4325 73249.9n 0.4325 73250.0n 0.3927 73499.9n 0.3927 73500.0n 0.3927 73749.9n 0.3927 73750.0n 0.3794 73999.9n 0.3794 74000.0n 0.3728 74249.9n 0.3728 74250.0n 0.5120 74499.9n 0.5120 74500.0n 0.5783 74749.9n 0.5783 74750.0n 0.5451 74999.9n 0.5451 75000.0n 0.4590 75249.9n 0.4590 75250.0n 0.5716 75499.9n 0.5716 75500.0n 0.4059 75749.9n 0.4059 75750.0n 0.5849 75999.9n 0.5849 76000.0n 0.4258 76249.9n 0.4258 76250.0n 0.4921 76499.9n 0.4921 76500.0n 0.5783 76749.9n 0.5783 76750.0n 0.3463 76999.9n 0.3463 77000.0n 0.4722 77249.9n 0.4722 77250.0n 0.3463 77499.9n 0.3463 77500.0n 0.3794 77749.9n 0.3794 77750.0n 0.5451 77999.9n 0.5451 78000.0n 0.3794 78249.9n 0.3794 78250.0n 0.4325 78499.9n 0.4325 78500.0n 0.4788 78749.9n 0.4788 78750.0n 0.3330 78999.9n 0.3330 79000.0n 0.6644 79249.9n 0.6644 79250.0n 0.4921 79499.9n 0.4921 79500.0n 0.5584 79749.9n 0.5584 79750.0n 0.3463 79999.9n 0.3463 80000.0n 0.5451 80249.9n 0.5451 80250.0n 0.3529 80499.9n 0.3529 80500.0n 0.4325 80749.9n 0.4325 80750.0n 0.3927 80999.9n 0.3927 81000.0n 0.3927 81249.9n 0.3927 81250.0n 0.3794 81499.9n 0.3794 81500.0n 0.3728 81749.9n 0.3728 81750.0n 0.5120 81999.9n 0.5120 82000.0n 0.5783 82249.9n 0.5783 82250.0n 0.5451 82499.9n 0.5451 82500.0n 0.4590 82749.9n 0.4590 82750.0n 0.5716 82999.9n 0.5716 83000.0n 0.4059 83249.9n 0.4059 83250.0n 0.5849 83499.9n 0.5849 83500.0n 0.4258 83749.9n 0.4258 83750.0n 0.4921 83999.9n 0.4921 84000.0n 0.5783 84249.9n 0.5783 84250.0n 0.3463 84499.9n 0.3463 84500.0n 0.4722 84749.9n 0.4722 84750.0n 0.3463 84999.9n 0.3463 85000.0n 0.3794 85249.9n 0.3794 85250.0n 0.5451 85499.9n 0.5451 85500.0n 0.3794 85749.9n 0.3794 85750.0n 0.4325 85999.9n 0.4325 86000.0n 0.4788 86249.9n 0.4788 86250.0n 0.3330 86499.9n 0.3330 86500.0n 0.6644 86749.9n 0.6644 86750.0n 0.4921 86999.9n 0.4921 87000.0n 0.5584 87249.9n 0.5584 87250.0n 0.3463 87499.9n 0.3463 87500.0n 0.5451 87749.9n 0.5451 87750.0n 0.3529 87999.9n 0.3529 88000.0n 0.4325 88249.9n 0.4325 88250.0n 0.3927 88499.9n 0.3927 88500.0n 0.3927 88749.9n 0.3927 88750.0n 0.3794 88999.9n 0.3794 89000.0n 0.3728 89249.9n 0.3728 89250.0n 0.5120 89499.9n 0.5120 89500.0n 0.5783 89749.9n 0.5783 89750.0n 0.5451 89999.9n 0.5451 90000.0n 0.4590 90249.9n 0.4590 90250.0n 0.5716 90499.9n 0.5716 90500.0n 0.4059 90749.9n 0.4059 90750.0n 0.5849 90999.9n 0.5849 91000.0n 0.4258 91249.9n 0.4258 91250.0n 0.4921 91499.9n 0.4921 91500.0n 0.5783 91749.9n 0.5783 91750.0n 0.3463 91999.9n 0.3463 92000.0n 0.4722 92249.9n 0.4722 92250.0n 0.3463 92499.9n 0.3463 92500.0n 0.3794 92749.9n 0.3794 92750.0n 0.5451 92999.9n 0.5451 93000.0n 0.3794 93249.9n 0.3794 93250.0n 0.4325 93499.9n 0.4325 93500.0n 0.4788 93749.9n 0.4788 93750.0n 0.3330 93999.9n 0.3330 94000.0n 0.6644 94249.9n 0.6644 94250.0n 0.4921 94499.9n 0.4921 94500.0n 0.5584 94749.9n 0.5584 94750.0n 0.3463 94999.9n 0.3463 95000.0n 0.5451 95249.9n 0.5451 95250.0n 0.3529 95499.9n 0.3529 95500.0n 0.4325 95749.9n 0.4325 95750.0n 0.3927 95999.9n 0.3927 96000.0n 0.3927 96249.9n 0.3927 96250.0n 0.3794 96499.9n 0.3794 96500.0n 0.3728 96749.9n 0.3728 96750.0n 0.5120 96999.9n 0.5120 97000.0n 0.5783 97249.9n 0.5783 97250.0n 0.5451 97499.9n 0.5451 97500.0n 0.4590 97749.9n 0.4590 97750.0n 0.5716 97999.9n 0.5716 98000.0n 0.4059 98249.9n 0.4059 98250.0n 0.5849 98499.9n 0.5849 98500.0n 0.4258 98749.9n 0.4258 98750.0n 0.4921 98999.9n 0.4921 99000.0n 0.5783 99249.9n 0.5783 99250.0n 0.3463 99499.9n 0.3463 99500.0n 0.4722 99749.9n 0.4722 99750.0n 0.3463 99999.9n 0.3463 100000.0n 0.3794 100249.9n 0.3794 100250.0n 0.5451 100499.9n 0.5451 100500.0n 0.3794 100749.9n 0.3794 100750.0n 0.4325 100999.9n 0.4325 101000.0n 0.4788 101249.9n 0.4788 101250.0n 0.3330 101499.9n 0.3330 101500.0n 0.6644 101749.9n 0.6644 101750.0n 0.4921 101999.9n 0.4921 102000.0n 0.5584 102249.9n 0.5584 102250.0n 0.3463 102499.9n 0.3463 102500.0n 0.5451 102749.9n 0.5451 102750.0n 0.3529 102999.9n 0.3529 103000.0n 0.4325 103249.9n 0.4325 103250.0n 0.3927 103499.9n 0.3927 103500.0n 0.3927 103749.9n 0.3927 103750.0n 0.3794 103999.9n 0.3794 104000.0n 0.3728 104249.9n 0.3728 104250.0n 0.5120 104499.9n 0.5120 104500.0n 0.5783 104749.9n 0.5783 104750.0n 0.5451 104999.9n 0.5451 105000.0n 0.4590 105249.9n 0.4590 105250.0n 0.5716 105499.9n 0.5716 105500.0n 0.4059 105749.9n 0.4059 105750.0n 0.5849 105999.9n 0.5849 106000.0n 0.4258 106249.9n 0.4258 106250.0n 0.4921 106499.9n 0.4921 106500.0n 0.5783 106749.9n 0.5783 106750.0n 0.3463 106999.9n 0.3463 107000.0n 0.4722 107249.9n 0.4722 107250.0n 0.3463 107499.9n 0.3463 107500.0n 0.3794 107749.9n 0.3794 107750.0n 0.5451 107999.9n 0.5451 108000.0n 0.3794 108249.9n 0.3794 108250.0n 0.4325 108499.9n 0.4325 108500.0n 0.4788 108749.9n 0.4788 108750.0n 0.3330 108999.9n 0.3330 109000.0n 0.6644 109249.9n 0.6644 109250.0n 0.4921 109499.9n 0.4921 109500.0n 0.5584 109749.9n 0.5584 109750.0n 0.3463 109999.9n 0.3463 110000.0n 0.5451 110249.9n 0.5451 110250.0n 0.3529 110499.9n 0.3529 110500.0n 0.4325 110749.9n 0.4325 110750.0n 0.3927 110999.9n 0.3927 111000.0n 0.3927 111249.9n 0.3927 111250.0n 0.3794 111499.9n 0.3794 111500.0n 0.3728 111749.9n 0.3728 111750.0n 0.5120 111999.9n 0.5120 112000.0n 0.5783 112249.9n 0.5783 112250.0n 0.5451 112499.9n 0.5451 112500.0n 0.4590 112749.9n 0.4590 112750.0n 0.5716 112999.9n 0.5716 113000.0n 0.4059 113249.9n 0.4059 113250.0n 0.5849 113499.9n 0.5849 113500.0n 0.4258 113749.9n 0.4258 113750.0n 0.4921 113999.9n 0.4921 114000.0n 0.5783 114249.9n 0.5783 114250.0n 0.3463 114499.9n 0.3463 114500.0n 0.4722 114749.9n 0.4722 114750.0n 0.3463 114999.9n 0.3463 115000.0n 0.3794 115249.9n 0.3794 115250.0n 0.5451 115499.9n 0.5451 115500.0n 0.3794 115749.9n 0.3794 115750.0n 0.4325 115999.9n 0.4325 116000.0n 0.4788 116249.9n 0.4788 116250.0n 0.3330 116499.9n 0.3330 116500.0n 0.6644 116749.9n 0.6644 116750.0n 0.4921 116999.9n 0.4921 117000.0n 0.5584 117249.9n 0.5584 117250.0n 0.3463 117499.9n 0.3463 117500.0n 0.5451 117749.9n 0.5451 117750.0n 0.3529 117999.9n 0.3529 118000.0n 0.4325 118249.9n 0.4325 118250.0n 0.3927 118499.9n 0.3927 118500.0n 0.3927 118749.9n 0.3927 118750.0n 0.3794 118999.9n 0.3794 119000.0n 0.3728 119249.9n 0.3728 119250.0n 0.5120 119499.9n 0.5120 119500.0n 0.5783 119749.9n 0.5783 119750.0n 0.5451 119999.9n 0.5451 120000.0n 0.4590 120249.9n 0.4590 120250.0n 0.5716 120499.9n 0.5716 120500.0n 0.4059 120749.9n 0.4059 120750.0n 0.5849 120999.9n 0.5849 121000.0n 0.4258 121249.9n 0.4258 121250.0n 0.4921 121499.9n 0.4921 121500.0n 0.5783 121749.9n 0.5783 121750.0n 0.3463 121999.9n 0.3463 122000.0n 0.4722 122249.9n 0.4722 122250.0n 0.3463 122499.9n 0.3463 122500.0n 0.3794 122749.9n 0.3794 122750.0n 0.5451 122999.9n 0.5451 123000.0n 0.3794 123249.9n 0.3794 123250.0n 0.4325 123499.9n 0.4325 123500.0n 0.4788 123749.9n 0.4788 123750.0n 0.3330 123999.9n 0.3330 124000.0n 0.6644 124249.9n 0.6644 124250.0n 0.4921 124499.9n 0.4921 124500.0n 0.5584 124749.9n 0.5584 124750.0n 0.3463 124999.9n 0.3463 125000.0n 0.5451 125249.9n 0.5451 125250.0n 0.3529 125499.9n 0.3529 125500.0n 0.4325 125749.9n 0.4325 125750.0n 0.3927 125999.9n 0.3927 126000.0n 0.3927 126249.9n 0.3927 126250.0n 0.3794 126499.9n 0.3794 126500.0n 0.3728 126749.9n 0.3728 126750.0n 0.5120 126999.9n 0.5120 127000.0n 0.5783 127249.9n 0.5783 127250.0n 0.5451 127499.9n 0.5451 127500.0n 0.4590 127749.9n 0.4590 127750.0n 0.5716 127999.9n 0.5716 128000.0n 0.4059 128249.9n 0.4059 128250.0n 0.5849 128499.9n 0.5849 128500.0n 0.4258 128749.9n 0.4258 128750.0n 0.4921 128999.9n 0.4921 129000.0n 0.5783 129249.9n 0.5783 129250.0n 0.3463 129499.9n 0.3463 129500.0n 0.4722 129749.9n 0.4722 129750.0n 0.3463 129999.9n 0.3463 130000.0n 0.3794 130249.9n 0.3794 130250.0n 0.5451 130499.9n 0.5451 130500.0n 0.3794 130749.9n 0.3794 130750.0n 0.4325 130999.9n 0.4325 131000.0n 0.4788 131249.9n 0.4788 131250.0n 0.3330 131499.9n 0.3330 131500.0n 0.6644 131749.9n 0.6644 131750.0n 0.4921 131999.9n 0.4921 132000.0n 0.5584 132249.9n 0.5584 132250.0n 0.3463 132499.9n 0.3463 132500.0n 0.5451 132749.9n 0.5451 132750.0n 0.3529 132999.9n 0.3529 133000.0n 0.4325 133249.9n 0.4325 133250.0n 0.3927 133499.9n 0.3927 133500.0n 0.3927 133749.9n 0.3927 133750.0n 0.3794 133999.9n 0.3794 134000.0n 0.3728 134249.9n 0.3728 134250.0n 0.5120 134499.9n 0.5120 134500.0n 0.5783 134749.9n 0.5783 134750.0n 0.5451 134999.9n 0.5451 135000.0n 0.4590 135249.9n 0.4590 135250.0n 0.5716 135499.9n 0.5716 135500.0n 0.4059 135749.9n 0.4059 135750.0n 0.5849 135999.9n 0.5849 136000.0n 0.4258 136249.9n 0.4258 136250.0n 0.4921 136499.9n 0.4921 136500.0n 0.5783 136749.9n 0.5783 136750.0n 0.3463 136999.9n 0.3463 137000.0n 0.4722 137249.9n 0.4722 137250.0n 0.3463 137499.9n 0.3463 137500.0n 0.3794 137749.9n 0.3794 137750.0n 0.5451 137999.9n 0.5451 138000.0n 0.3794 138249.9n 0.3794 138250.0n 0.4325 138499.9n 0.4325 138500.0n 0.4788 138749.9n 0.4788 138750.0n 0.3330 138999.9n 0.3330 139000.0n 0.6644 139249.9n 0.6644 139250.0n 0.4921 139499.9n 0.4921 139500.0n 0.5584 139749.9n 0.5584 139750.0n 0.3463 139999.9n 0.3463 140000.0n 0.5451 140249.9n 0.5451 140250.0n 0.3529 140499.9n 0.3529 140500.0n 0.4325 140749.9n 0.4325 140750.0n 0.3927 140999.9n 0.3927 141000.0n 0.3927 141249.9n 0.3927 141250.0n 0.3794 141499.9n 0.3794 141500.0n 0.3728 141749.9n 0.3728 141750.0n 0.5120 141999.9n 0.5120 142000.0n 0.5783 142249.9n 0.5783 142250.0n 0.5451 142499.9n 0.5451 142500.0n 0.4590 142749.9n 0.4590 142750.0n 0.5716 142999.9n 0.5716 143000.0n 0.4059 143249.9n 0.4059 143250.0n 0.5849 143499.9n 0.5849 143500.0n 0.4258 143749.9n 0.4258 143750.0n 0.4921 143999.9n 0.4921 144000.0n 0.5783 144249.9n 0.5783 144250.0n 0.3463 144499.9n 0.3463 144500.0n 0.4722 144749.9n 0.4722 144750.0n 0.3463 144999.9n 0.3463 145000.0n 0.3794 145249.9n 0.3794 145250.0n 0.5451 145499.9n 0.5451 145500.0n 0.3794 145749.9n 0.3794 145750.0n 0.4325 145999.9n 0.4325 146000.0n 0.4788 146249.9n 0.4788 146250.0n 0.3330 146499.9n 0.3330 146500.0n 0.6644 146749.9n 0.6644 146750.0n 0.4921 146999.9n 0.4921 147000.0n 0.5584 147249.9n 0.5584 147250.0n 0.3463 147499.9n 0.3463 147500.0n 0.5451 147749.9n 0.5451 147750.0n 0.3529 147999.9n 0.3529 148000.0n 0.4325 148249.9n 0.4325 148250.0n 0.3927 148499.9n 0.3927 148500.0n 0.3927 148749.9n 0.3927 148750.0n 0.3794 148999.9n 0.3794 149000.0n 0.3728 149249.9n 0.3728 149250.0n 0.5120 149499.9n 0.5120 149500.0n 0.5783 149749.9n 0.5783 149750.0n 0.5451 149999.9n 0.5451 150000.0n 0.4590 150249.9n 0.4590 150250.0n 0.5716 150499.9n 0.5716 150500.0n 0.4059 150749.9n 0.4059 150750.0n 0.5849 150999.9n 0.5849 151000.0n 0.4258 151249.9n 0.4258 151250.0n 0.4921 151499.9n 0.4921 151500.0n 0.5783 151749.9n 0.5783 151750.0n 0.3463 151999.9n 0.3463 152000.0n 0.4722 152249.9n 0.4722 152250.0n 0.3463 152499.9n 0.3463 152500.0n 0.3794 152749.9n 0.3794 152750.0n 0.5451 152999.9n 0.5451 153000.0n 0.3794 153249.9n 0.3794 153250.0n 0.4325 153499.9n 0.4325 153500.0n 0.4788 153749.9n 0.4788 153750.0n 0.3330 153999.9n 0.3330 154000.0n 0.6644 154249.9n 0.6644 154250.0n 0.4921 154499.9n 0.4921 154500.0n 0.5584 154749.9n 0.5584 154750.0n 0.3463 154999.9n 0.3463 155000.0n 0.5451 155249.9n 0.5451 155250.0n 0.3529 155499.9n 0.3529 155500.0n 0.4325 155749.9n 0.4325 155750.0n 0.3927 155999.9n 0.3927 156000.0n 0.3927 156249.9n 0.3927 156250.0n 0.3794 156499.9n 0.3794 156500.0n 0.3728 156749.9n 0.3728 156750.0n 0.5120 156999.9n 0.5120 157000.0n 0.5783 157249.9n 0.5783 157250.0n 0.5451 157499.9n 0.5451 157500.0n 0.4590 157749.9n 0.4590 157750.0n 0.5716 157999.9n 0.5716 158000.0n 0.4059 158249.9n 0.4059 158250.0n 0.5849 158499.9n 0.5849 158500.0n 0.4258 158749.9n 0.4258 158750.0n 0.4921 158999.9n 0.4921 159000.0n 0.5783 159249.9n 0.5783 159250.0n 0.3463 159499.9n 0.3463 159500.0n 0.4722 159749.9n 0.4722 159750.0n 0.3463 159999.9n 0.3463 160000.0n 0.3794 160249.9n 0.3794 160250.0n 0.5451 160499.9n 0.5451 160500.0n 0.3794 160749.9n 0.3794 160750.0n 0.4325 160999.9n 0.4325 161000.0n 0.4788 161249.9n 0.4788 161250.0n 0.3330 161499.9n 0.3330 161500.0n 0.6644 161749.9n 0.6644 161750.0n 0.4921 161999.9n 0.4921 162000.0n 0.5584 162249.9n 0.5584 162250.0n 0.3463 162499.9n 0.3463 162500.0n 0.5451 162749.9n 0.5451 162750.0n 0.3529 162999.9n 0.3529 163000.0n 0.4325 163249.9n 0.4325 163250.0n 0.3927 163499.9n 0.3927 163500.0n 0.3927 163749.9n 0.3927 163750.0n 0.3794 163999.9n 0.3794 164000.0n 0.3728 164249.9n 0.3728 164250.0n 0.5120 164499.9n 0.5120 164500.0n 0.5783 164749.9n 0.5783 164750.0n 0.5451 164999.9n 0.5451 165000.0n 0.4590 165249.9n 0.4590 165250.0n 0.5716 165499.9n 0.5716 165500.0n 0.4059 165749.9n 0.4059 165750.0n 0.5849 165999.9n 0.5849 166000.0n 0.4258 166249.9n 0.4258 166250.0n 0.4921 166499.9n 0.4921 166500.0n 0.5783 166749.9n 0.5783 166750.0n 0.3463 166999.9n 0.3463 167000.0n 0.4722 167249.9n 0.4722 167250.0n 0.3463 167499.9n 0.3463 167500.0n 0.3794 167749.9n 0.3794 167750.0n 0.5451 167999.9n 0.5451 168000.0n 0.3794 168249.9n 0.3794 168250.0n 0.4325 168499.9n 0.4325 168500.0n 0.4788 168749.9n 0.4788 168750.0n 0.3330 168999.9n 0.3330 169000.0n 0.6644 169249.9n 0.6644 169250.0n 0.4921 169499.9n 0.4921 169500.0n 0.5584 169749.9n 0.5584 169750.0n 0.3463 169999.9n 0.3463 170000.0n 0.5451 170249.9n 0.5451 170250.0n 0.3529 170499.9n 0.3529 170500.0n 0.4325 170749.9n 0.4325 170750.0n 0.3927 170999.9n 0.3927 171000.0n 0.3927 171249.9n 0.3927 171250.0n 0.3794 171499.9n 0.3794 171500.0n 0.3728 171749.9n 0.3728 171750.0n 0.5120 171999.9n 0.5120 172000.0n 0.5783 172249.9n 0.5783 172250.0n 0.5451 172499.9n 0.5451 172500.0n 0.4590 172749.9n 0.4590 172750.0n 0.5716 172999.9n 0.5716 173000.0n 0.4059 173249.9n 0.4059 173250.0n 0.5849 173499.9n 0.5849 173500.0n 0.4258 173749.9n 0.4258 173750.0n 0.4921 173999.9n 0.4921 174000.0n 0.5783 174249.9n 0.5783 174250.0n 0.3463 174499.9n 0.3463 174500.0n 0.4722 174749.9n 0.4722 174750.0n 0.3463 174999.9n 0.3463 175000.0n 0.3794 175249.9n 0.3794 175250.0n 0.5451 175499.9n 0.5451 175500.0n 0.3794 175749.9n 0.3794 175750.0n 0.4325 175999.9n 0.4325 176000.0n 0.4788 176249.9n 0.4788 176250.0n 0.3330 176499.9n 0.3330 176500.0n 0.6644 176749.9n 0.6644 176750.0n 0.4921 176999.9n 0.4921 177000.0n 0.5584 177249.9n 0.5584 177250.0n 0.3463 177499.9n 0.3463 177500.0n 0.5451 177749.9n 0.5451 177750.0n 0.3529 177999.9n 0.3529 178000.0n 0.4325 178249.9n 0.4325 178250.0n 0.3927 178499.9n 0.3927 178500.0n 0.3927 178749.9n 0.3927 178750.0n 0.3794 178999.9n 0.3794 179000.0n 0.3728 179249.9n 0.3728 179250.0n 0.5120 179499.9n 0.5120 179500.0n 0.5783 179749.9n 0.5783 179750.0n 0.5451 179999.9n 0.5451 180000.0n 0.4590 180249.9n 0.4590 180250.0n 0.5716 180499.9n 0.5716 180500.0n 0.4059 180749.9n 0.4059 180750.0n 0.5849 180999.9n 0.5849 181000.0n 0.4258 181249.9n 0.4258 181250.0n 0.4921 181499.9n 0.4921 181500.0n 0.5783 181749.9n 0.5783 181750.0n 0.3463 181999.9n 0.3463 182000.0n 0.4722 182249.9n 0.4722 182250.0n 0.3463 182499.9n 0.3463 182500.0n 0.3794 182749.9n 0.3794 182750.0n 0.5451 182999.9n 0.5451 183000.0n 0.3794 183249.9n 0.3794 183250.0n 0.4325 183499.9n 0.4325 183500.0n 0.4788 183749.9n 0.4788 183750.0n 0.3330 183999.9n 0.3330 184000.0n 0.6644 184249.9n 0.6644 184250.0n 0.4921 184499.9n 0.4921 184500.0n 0.5584 184749.9n 0.5584 184750.0n 0.3463 184999.9n 0.3463 185000.0n 0.5451 185249.9n 0.5451 185250.0n 0.3529 185499.9n 0.3529 185500.0n 0.4325 185749.9n 0.4325 185750.0n 0.3927 185999.9n 0.3927 186000.0n 0.3927 186249.9n 0.3927 186250.0n 0.3794 186499.9n 0.3794 186500.0n 0.3728 186749.9n 0.3728 186750.0n 0.5120 186999.9n 0.5120 187000.0n 0.5783 187249.9n 0.5783 187250.0n 0.5451 187499.9n 0.5451 187500.0n 0.4590 187749.9n 0.4590 187750.0n 0.5716 187999.9n 0.5716 188000.0n 0.4059 188249.9n 0.4059 188250.0n 0.5849 188499.9n 0.5849 188500.0n 0.4258 188749.9n 0.4258 188750.0n 0.4921 188999.9n 0.4921 189000.0n 0.5783 189249.9n 0.5783 189250.0n 0.3463 189499.9n 0.3463 189500.0n 0.4722 189749.9n 0.4722 189750.0n 0.3463 189999.9n 0.3463 190000.0n 0.3794 190249.9n 0.3794 190250.0n 0.5451 190499.9n 0.5451 190500.0n 0.3794 190749.9n 0.3794 190750.0n 0.4325 190999.9n 0.4325 191000.0n 0.4788 191249.9n 0.4788 191250.0n 0.3330 191499.9n 0.3330 191500.0n 0.6644 191749.9n 0.6644 191750.0n 0.4921 191999.9n 0.4921 192000.0n 0.5584 192249.9n 0.5584 192250.0n 0.3463 192499.9n 0.3463 192500.0n 0.5451 192749.9n 0.5451 192750.0n 0.3529 192999.9n 0.3529 193000.0n 0.4325 193249.9n 0.4325 193250.0n 0.3927 193499.9n 0.3927 193500.0n 0.3927 193749.9n 0.3927 193750.0n 0.3794 193999.9n 0.3794 194000.0n 0.3728 194249.9n 0.3728 194250.0n 0.5120 194499.9n 0.5120 194500.0n 0.5783 194749.9n 0.5783 194750.0n 0.5451 194999.9n 0.5451 195000.0n 0.4590 195249.9n 0.4590 195250.0n 0.5716 195499.9n 0.5716 195500.0n 0.4059 195749.9n 0.4059 195750.0n 0.5849 195999.9n 0.5849 196000.0n 0.4258 196249.9n 0.4258 196250.0n 0.4921 196499.9n 0.4921 196500.0n 0.5783 196749.9n 0.5783 196750.0n 0.3463 196999.9n 0.3463 197000.0n 0.4722 197249.9n 0.4722 197250.0n 0.3463 197499.9n 0.3463 197500.0n 0.3794 197749.9n 0.3794 197750.0n 0.5451 197999.9n 0.5451 198000.0n 0.3794 198249.9n 0.3794 198250.0n 0.4325 198499.9n 0.4325 198500.0n 0.4788 198749.9n 0.4788 198750.0n 0.3330 198999.9n 0.3330 199000.0n 0.6644 199249.9n 0.6644 199250.0n 0.4921 199499.9n 0.4921 199500.0n 0.5584 199749.9n 0.5584 199750.0n 0.3463 199999.9n 0.3463 200000.0n 0.5451 200249.9n 0.5451 200250.0n 0.3529 200499.9n 0.3529 200500.0n 0.4325 200749.9n 0.4325 200750.0n 0.3927 200999.9n 0.3927 201000.0n 0.3927 201249.9n 0.3927 201250.0n 0.3794 201499.9n 0.3794 201500.0n 0.3728 201749.9n 0.3728 201750.0n 0.5120 201999.9n 0.5120 202000.0n 0.5783 202249.9n 0.5783 202250.0n 0.5451 202499.9n 0.5451 202500.0n 0.4590 202749.9n 0.4590 202750.0n 0.5716 202999.9n 0.5716 203000.0n 0.4059 203249.9n 0.4059 203250.0n 0.5849 203499.9n 0.5849 203500.0n 0.4258 203749.9n 0.4258 203750.0n 0.4921 203999.9n 0.4921 204000.0n 0.5783 204249.9n 0.5783 204250.0n 0.3463 204499.9n 0.3463 204500.0n 0.4722 204749.9n 0.4722 204750.0n 0.3463 204999.9n 0.3463 205000.0n 0.3794 205249.9n 0.3794 205250.0n 0.5451 205499.9n 0.5451 205500.0n 0.3794 205749.9n 0.3794 205750.0n 0.4325 205999.9n 0.4325 206000.0n 0.4788 206249.9n 0.4788 206250.0n 0.3330 206499.9n 0.3330 206500.0n 0.6644 206749.9n 0.6644 206750.0n 0.4921 206999.9n 0.4921 207000.0n 0.5584 207249.9n 0.5584 207250.0n 0.3463 207499.9n 0.3463 207500.0n 0.5451 207749.9n 0.5451 207750.0n 0.3529 207999.9n 0.3529 208000.0n 0.4325 208249.9n 0.4325 208250.0n 0.3927 208499.9n 0.3927 208500.0n 0.3927 208749.9n 0.3927 208750.0n 0.3794 208999.9n 0.3794 209000.0n 0.3728 209249.9n 0.3728 209250.0n 0.5120 209499.9n 0.5120 209500.0n 0.5783 209749.9n 0.5783 209750.0n 0.5451 209999.9n 0.5451 210000.0n 0.4590 210249.9n 0.4590 210250.0n 0.5716 210499.9n 0.5716 210500.0n 0.4059 210749.9n 0.4059 210750.0n 0.5849 210999.9n 0.5849 211000.0n 0.4258 211249.9n 0.4258 211250.0n 0.4921 211499.9n 0.4921 211500.0n 0.5783 211749.9n 0.5783 211750.0n 0.3463 211999.9n 0.3463 212000.0n 0.4722 212249.9n 0.4722 212250.0n 0.3463 212499.9n 0.3463 212500.0n 0.3794 212749.9n 0.3794 212750.0n 0.5451 212999.9n 0.5451 213000.0n 0.3794 213249.9n 0.3794 213250.0n 0.4325 213499.9n 0.4325 213500.0n 0.4788 213749.9n 0.4788 213750.0n 0.3330 213999.9n 0.3330 214000.0n 0.6644 214249.9n 0.6644 214250.0n 0.4921 214499.9n 0.4921 214500.0n 0.5584 214749.9n 0.5584 214750.0n 0.3463 214999.9n 0.3463 215000.0n 0.5451 215249.9n 0.5451 215250.0n 0.3529 215499.9n 0.3529 215500.0n 0.4325 215749.9n 0.4325 215750.0n 0.3927 215999.9n 0.3927 216000.0n 0.3927 216249.9n 0.3927 216250.0n 0.3794 216499.9n 0.3794 216500.0n 0.3728 216749.9n 0.3728 216750.0n 0.5120 216999.9n 0.5120 217000.0n 0.5783 217249.9n 0.5783 217250.0n 0.5451 217499.9n 0.5451 217500.0n 0.4590 217749.9n 0.4590 217750.0n 0.5716 217999.9n 0.5716 218000.0n 0.4059 218249.9n 0.4059 218250.0n 0.5849 218499.9n 0.5849 218500.0n 0.4258 218749.9n 0.4258 218750.0n 0.4921 218999.9n 0.4921 219000.0n 0.5783 219249.9n 0.5783 219250.0n 0.3463 219499.9n 0.3463 219500.0n 0.4722 219749.9n 0.4722 219750.0n 0.3463 219999.9n 0.3463 220000.0n 0.3794 220249.9n 0.3794 220250.0n 0.5451 220499.9n 0.5451 220500.0n 0.3794 220749.9n 0.3794 220750.0n 0.4325 220999.9n 0.4325 221000.0n 0.4788 221249.9n 0.4788 221250.0n 0.3330 221499.9n 0.3330 221500.0n 0.6644 221749.9n 0.6644 221750.0n 0.4921 221999.9n 0.4921 222000.0n 0.5584 222249.9n 0.5584 222250.0n 0.3463 222499.9n 0.3463 222500.0n 0.5451 222749.9n 0.5451 222750.0n 0.3529 222999.9n 0.3529 223000.0n 0.4325 223249.9n 0.4325 223250.0n 0.3927 223499.9n 0.3927 223500.0n 0.3927 223749.9n 0.3927 223750.0n 0.3794 223999.9n 0.3794 224000.0n 0.3728 224249.9n 0.3728 224250.0n 0.5120 224499.9n 0.5120 224500.0n 0.5783 224749.9n 0.5783 224750.0n 0.5451 224999.9n 0.5451 225000.0n 0.4590 225249.9n 0.4590 225250.0n 0.5716 225499.9n 0.5716 225500.0n 0.4059 225749.9n 0.4059 225750.0n 0.5849 225999.9n 0.5849 226000.0n 0.4258 226249.9n 0.4258 226250.0n 0.4921 226499.9n 0.4921 226500.0n 0.5783 226749.9n 0.5783 226750.0n 0.3463 226999.9n 0.3463 227000.0n 0.4722 227249.9n 0.4722 227250.0n 0.3463 227499.9n 0.3463 227500.0n 0.3794 227749.9n 0.3794 227750.0n 0.5451 227999.9n 0.5451 228000.0n 0.3794 228249.9n 0.3794 228250.0n 0.4325 228499.9n 0.4325 228500.0n 0.4788 228749.9n 0.4788 228750.0n 0.3330 228999.9n 0.3330 229000.0n 0.6644 229249.9n 0.6644 229250.0n 0.4921 229499.9n 0.4921 229500.0n 0.5584 229749.9n 0.5584 229750.0n 0.3463 229999.9n 0.3463 230000.0n 0.5451 230249.9n 0.5451 230250.0n 0.3529 230499.9n 0.3529 230500.0n 0.4325 230749.9n 0.4325 230750.0n 0.3927 230999.9n 0.3927 231000.0n 0.3927 231249.9n 0.3927 231250.0n 0.3794 231499.9n 0.3794 231500.0n 0.3728 231749.9n 0.3728 231750.0n 0.5120 231999.9n 0.5120 232000.0n 0.5783 232249.9n 0.5783 232250.0n 0.5451 232499.9n 0.5451 232500.0n 0.4590 232749.9n 0.4590 232750.0n 0.5716 232999.9n 0.5716 233000.0n 0.4059 233249.9n 0.4059 233250.0n 0.5849 233499.9n 0.5849 233500.0n 0.4258 233749.9n 0.4258 233750.0n 0.4921 233999.9n 0.4921 234000.0n 0.5783 234249.9n 0.5783 234250.0n 0.3463 234499.9n 0.3463 234500.0n 0.4722 234749.9n 0.4722 234750.0n 0.3463 234999.9n 0.3463 235000.0n 0.3794 235249.9n 0.3794 235250.0n 0.5451 235499.9n 0.5451 235500.0n 0.3794 235749.9n 0.3794 235750.0n 0.4325 235999.9n 0.4325 236000.0n 0.4788 236249.9n 0.4788 236250.0n 0.3330 236499.9n 0.3330 236500.0n 0.6644 236749.9n 0.6644 236750.0n 0.4921 236999.9n 0.4921 237000.0n 0.5584 237249.9n 0.5584 237250.0n 0.3463 237499.9n 0.3463 237500.0n 0.5451 237749.9n 0.5451 237750.0n 0.3529 237999.9n 0.3529 238000.0n 0.4325 238249.9n 0.4325 238250.0n 0.3927 238499.9n 0.3927 238500.0n 0.3927 238749.9n 0.3927 238750.0n 0.3794 238999.9n 0.3794 239000.0n 0.3728 239249.9n 0.3728 239250.0n 0.5120 239499.9n 0.5120 239500.0n 0.5783 239749.9n 0.5783 239750.0n 0.5451 239999.9n 0.5451 240000.0n 0.4590 240249.9n 0.4590 240250.0n 0.5716 240499.9n 0.5716 240500.0n 0.4059 240749.9n 0.4059 240750.0n 0.5849 240999.9n 0.5849 241000.0n 0.4258 241249.9n 0.4258 241250.0n 0.4921 241499.9n 0.4921 241500.0n 0.5783 241749.9n 0.5783 241750.0n 0.3463 241999.9n 0.3463 242000.0n 0.4722 242249.9n 0.4722 242250.0n 0.3463 242499.9n 0.3463 242500.0n 0.3794 242749.9n 0.3794 242750.0n 0.5451 242999.9n 0.5451 243000.0n 0.3794 243249.9n 0.3794 243250.0n 0.4325 243499.9n 0.4325 243500.0n 0.4788 243749.9n 0.4788 243750.0n 0.3330 243999.9n 0.3330 244000.0n 0.6644 244249.9n 0.6644 244250.0n 0.4921 244499.9n 0.4921 244500.0n 0.5584 244749.9n 0.5584 244750.0n 0.3463 244999.9n 0.3463 245000.0n 0.5451 245249.9n 0.5451 245250.0n 0.3529 245499.9n 0.3529 245500.0n 0.4325 245749.9n 0.4325 245750.0n 0.3927 245999.9n 0.3927 246000.0n 0.3927 246249.9n 0.3927 246250.0n 0.3794 246499.9n 0.3794 246500.0n 0.3728 246749.9n 0.3728 246750.0n 0.5120 246999.9n 0.5120 247000.0n 0.5783 247249.9n 0.5783 247250.0n 0.5451 247499.9n 0.5451 247500.0n 0.4590 247749.9n 0.4590 247750.0n 0.5716 247999.9n 0.5716 248000.0n 0.4059 248249.9n 0.4059 248250.0n 0.5849 248499.9n 0.5849 248500.0n 0.4258 248749.9n 0.4258 248750.0n 0.4921 248999.9n 0.4921 249000.0n 0.5783 249249.9n 0.5783 249250.0n 0.3463 249499.9n 0.3463 249500.0n 0.4722 249749.9n 0.4722 249750.0n 0.3463 249999.9n 0.3463 250000.0n 0.3794 250249.9n 0.3794 250250.0n 0.5451 250499.9n 0.5451 250500.0n 0.3794 250749.9n 0.3794 250750.0n 0.4325 250999.9n 0.4325 251000.0n 0.4788 251249.9n 0.4788 251250.0n 0.3330 251499.9n 0.3330 251500.0n 0.6644 251749.9n 0.6644 251750.0n 0.4921 251999.9n 0.4921 252000.0n 0.5584 252249.9n 0.5584 252250.0n 0.3463 252499.9n 0.3463 252500.0n 0.5451 252749.9n 0.5451 252750.0n 0.3529 252999.9n 0.3529 253000.0n 0.4325 253249.9n 0.4325 253250.0n 0.3927 253499.9n 0.3927 253500.0n 0.3927 253749.9n 0.3927 253750.0n 0.3794 253999.9n 0.3794 254000.0n 0.3728 254249.9n 0.3728 254250.0n 0.5120 254499.9n 0.5120 254500.0n 0.5783 254749.9n 0.5783 254750.0n 0.5451 254999.9n 0.5451 255000.0n 0.4590 255249.9n 0.4590 255250.0n 0.5716 255499.9n 0.5716 255500.0n 0.4059 255749.9n 0.4059 255750.0n 0.5849 255999.9n 0.5849 256000.0n 0.4258 256249.9n 0.4258 256250.0n 0.4921 256499.9n 0.4921 256500.0n 0.5783 256749.9n 0.5783 256750.0n 0.3463 256999.9n 0.3463 257000.0n 0.4722 257249.9n 0.4722 257250.0n 0.3463 257499.9n 0.3463 257500.0n 0.3794 257749.9n 0.3794 257750.0n 0.5451 257999.9n 0.5451 258000.0n 0.3794 258249.9n 0.3794 258250.0n 0.4325 258499.9n 0.4325 258500.0n 0.4788 258749.9n 0.4788 258750.0n 0.3330 258999.9n 0.3330 259000.0n 0.6644 259249.9n 0.6644 259250.0n 0.4921 259499.9n 0.4921 259500.0n 0.5584 259749.9n 0.5584 259750.0n 0.3463 259999.9n 0.3463 260000.0n 0.5451 260249.9n 0.5451 260250.0n 0.3529 260499.9n 0.3529 260500.0n 0.4325 260749.9n 0.4325 260750.0n 0.3927 260999.9n 0.3927 261000.0n 0.3927 261249.9n 0.3927 261250.0n 0.3794 261499.9n 0.3794 261500.0n 0.3728 261749.9n 0.3728 261750.0n 0.5120 261999.9n 0.5120 262000.0n 0.5783 262249.9n 0.5783 262250.0n 0.5451 262499.9n 0.5451 262500.0n 0.4590 262749.9n 0.4590 262750.0n 0.5716 262999.9n 0.5716 263000.0n 0.4059 263249.9n 0.4059 263250.0n 0.5849 263499.9n 0.5849 263500.0n 0.4258 263749.9n 0.4258 263750.0n 0.4921 263999.9n 0.4921 264000.0n 0.5783 264249.9n 0.5783 264250.0n 0.3463 264499.9n 0.3463 264500.0n 0.4722 264749.9n 0.4722 264750.0n 0.3463 264999.9n 0.3463 265000.0n 0.3794 265249.9n 0.3794 265250.0n 0.5451 265499.9n 0.5451 265500.0n 0.3794 265749.9n 0.3794 265750.0n 0.4325 265999.9n 0.4325 266000.0n 0.4788 266249.9n 0.4788 266250.0n 0.3330 266499.9n 0.3330 266500.0n 0.6644 266749.9n 0.6644 266750.0n 0.4921 266999.9n 0.4921 267000.0n 0.5584 267249.9n 0.5584 267250.0n 0.3463 267499.9n 0.3463 267500.0n 0.5451 267749.9n 0.5451 267750.0n 0.3529 267999.9n 0.3529 268000.0n 0.4325 268249.9n 0.4325 268250.0n 0.3927 268499.9n 0.3927 268500.0n 0.3927 268749.9n 0.3927 268750.0n 0.3794 268999.9n 0.3794 269000.0n 0.3728 269249.9n 0.3728 269250.0n 0.5120 269499.9n 0.5120 269500.0n 0.5783 269749.9n 0.5783 269750.0n 0.5451 269999.9n 0.5451 270000.0n 0.4590 270249.9n 0.4590 270250.0n 0.5716 270499.9n 0.5716 270500.0n 0.4059 270749.9n 0.4059 270750.0n 0.5849 270999.9n 0.5849 271000.0n 0.4258 271249.9n 0.4258 271250.0n 0.4921 271499.9n 0.4921 271500.0n 0.5783 271749.9n 0.5783 271750.0n 0.3463 271999.9n 0.3463 272000.0n 0.4722 272249.9n 0.4722 272250.0n 0.3463 272499.9n 0.3463 272500.0n 0.3794 272749.9n 0.3794 272750.0n 0.5451 272999.9n 0.5451 273000.0n 0.3794 273249.9n 0.3794 273250.0n 0.4325 273499.9n 0.4325 273500.0n 0.4788 273749.9n 0.4788 273750.0n 0.3330 273999.9n 0.3330 274000.0n 0.6644 274249.9n 0.6644 274250.0n 0.4921 274499.9n 0.4921 274500.0n 0.5584 274749.9n 0.5584 274750.0n 0.3463 274999.9n 0.3463 275000.0n 0.5451 275249.9n 0.5451 275250.0n 0.3529 275499.9n 0.3529 275500.0n 0.4325 275749.9n 0.4325 275750.0n 0.3927 275999.9n 0.3927 276000.0n 0.3927 276249.9n 0.3927 276250.0n 0.3794 276499.9n 0.3794 276500.0n 0.3728 276749.9n 0.3728 276750.0n 0.5120 276999.9n 0.5120 277000.0n 0.5783 277249.9n 0.5783 277250.0n 0.5451 277499.9n 0.5451 277500.0n 0.4590 277749.9n 0.4590 277750.0n 0.5716 277999.9n 0.5716 278000.0n 0.4059 278249.9n 0.4059 278250.0n 0.5849 278499.9n 0.5849 278500.0n 0.4258 278749.9n 0.4258 278750.0n 0.4921 278999.9n 0.4921 279000.0n 0.5783 279249.9n 0.5783 279250.0n 0.3463 279499.9n 0.3463 279500.0n 0.4722 279749.9n 0.4722 279750.0n 0.3463 279999.9n 0.3463 280000.0n 0.3794 280249.9n 0.3794 280250.0n 0.5451 280499.9n 0.5451 280500.0n 0.3794 280749.9n 0.3794 280750.0n 0.4325 280999.9n 0.4325 281000.0n 0.4788 281249.9n 0.4788 281250.0n 0.3330 281499.9n 0.3330 281500.0n 0.6644 281749.9n 0.6644 281750.0n 0.4921 281999.9n 0.4921 282000.0n 0.5584 282249.9n 0.5584 282250.0n 0.3463 282499.9n 0.3463 282500.0n 0.5451 282749.9n 0.5451 282750.0n 0.3529 282999.9n 0.3529 283000.0n 0.4325 283249.9n 0.4325 283250.0n 0.3927 283499.9n 0.3927 283500.0n 0.3927 283749.9n 0.3927 283750.0n 0.3794 283999.9n 0.3794 284000.0n 0.3728 284249.9n 0.3728 284250.0n 0.5120 284499.9n 0.5120 284500.0n 0.5783 284749.9n 0.5783 284750.0n 0.5451 284999.9n 0.5451 285000.0n 0.4590 285249.9n 0.4590 285250.0n 0.5716 285499.9n 0.5716 285500.0n 0.4059 285749.9n 0.4059 285750.0n 0.5849 285999.9n 0.5849 286000.0n 0.4258 286249.9n 0.4258 286250.0n 0.4921 286499.9n 0.4921 286500.0n 0.5783 286749.9n 0.5783 286750.0n 0.3463 286999.9n 0.3463 287000.0n 0.4722 287249.9n 0.4722 287250.0n 0.3463 287499.9n 0.3463 287500.0n 0.3794 287749.9n 0.3794 287750.0n 0.5451 287999.9n 0.5451 288000.0n 0.3794 288249.9n 0.3794 288250.0n 0.4325 288499.9n 0.4325 288500.0n 0.4788 288749.9n 0.4788 288750.0n 0.3330 288999.9n 0.3330 289000.0n 0.6644 289249.9n 0.6644 289250.0n 0.4921 289499.9n 0.4921 289500.0n 0.5584 289749.9n 0.5584 289750.0n 0.3463 289999.9n 0.3463 290000.0n 0.5451 290249.9n 0.5451 290250.0n 0.3529 290499.9n 0.3529 290500.0n 0.4325 290749.9n 0.4325 290750.0n 0.3927 290999.9n 0.3927 291000.0n 0.3927 291249.9n 0.3927 291250.0n 0.3794 291499.9n 0.3794 291500.0n 0.3728 291749.9n 0.3728 291750.0n 0.5120 291999.9n 0.5120 292000.0n 0.5783 292249.9n 0.5783 292250.0n 0.5451 292499.9n 0.5451 292500.0n 0.4590 292749.9n 0.4590 292750.0n 0.5716 292999.9n 0.5716 293000.0n 0.4059 293249.9n 0.4059 293250.0n 0.5849 293499.9n 0.5849 293500.0n 0.4258 293749.9n 0.4258 293750.0n 0.4921 293999.9n 0.4921 294000.0n 0.5783 294249.9n 0.5783 294250.0n 0.3463 294499.9n 0.3463 294500.0n 0.4722 294749.9n 0.4722 294750.0n 0.3463 294999.9n 0.3463 295000.0n 0.3794 295249.9n 0.3794 295250.0n 0.5451 295499.9n 0.5451 295500.0n 0.3794 295749.9n 0.3794 295750.0n 0.4325 295999.9n 0.4325 296000.0n 0.4788 296249.9n 0.4788 296250.0n 0.3330 296499.9n 0.3330 296500.0n 0.6644 296749.9n 0.6644 296750.0n 0.4921 296999.9n 0.4921 297000.0n 0.5584 297249.9n 0.5584 297250.0n 0.3463 297499.9n 0.3463 297500.0n 0.5451 297749.9n 0.5451 297750.0n 0.3529 297999.9n 0.3529 298000.0n 0.4325 298249.9n 0.4325 298250.0n 0.3927 298499.9n 0.3927 298500.0n 0.3927 298749.9n 0.3927 298750.0n 0.3794 298999.9n 0.3794 299000.0n 0.3728 299249.9n 0.3728 299250.0n 0.5120 299499.9n 0.5120 299500.0n 0.5783 299749.9n 0.5783 299750.0n 0.5451)
Vxp6 a_xp6 0 PWL(0.0n 0.5580 249.9n 0.5580 250.0n 0.4193 499.9n 0.4193 500.0n 0.4736 749.9n 0.4736 750.0n 0.4434 999.9n 0.4434 1000.0n 0.3831 1249.9n 0.3831 1250.0n 0.6244 1499.9n 0.6244 1500.0n 0.4012 1749.9n 0.4012 1750.0n 0.6907 1999.9n 0.6907 2000.0n 0.6002 2249.9n 0.6002 2250.0n 0.3469 2499.9n 0.3469 2500.0n 0.4253 2749.9n 0.4253 2750.0n 0.4193 2999.9n 0.4193 3000.0n 0.6907 3249.9n 0.6907 3250.0n 0.4012 3499.9n 0.4012 3500.0n 0.5399 3749.9n 0.5399 3750.0n 0.5942 3999.9n 0.5942 4000.0n 0.6726 4249.9n 0.6726 4250.0n 0.4253 4499.9n 0.4253 4500.0n 0.4313 4749.9n 0.4313 4750.0n 0.5278 4999.9n 0.5278 5000.0n 0.4434 5249.9n 0.4434 5250.0n 0.6847 5499.9n 0.6847 5500.0n 0.4072 5749.9n 0.4072 5750.0n 0.5701 5999.9n 0.5701 6000.0n 0.6907 6249.9n 0.6907 6250.0n 0.5098 6499.9n 0.5098 6500.0n 0.5339 6749.9n 0.5339 6750.0n 0.4133 6999.9n 0.4133 7000.0n 0.4313 7249.9n 0.4313 7250.0n 0.4313 7499.9n 0.4313 7500.0n 0.5580 7749.9n 0.5580 7750.0n 0.4193 7999.9n 0.4193 8000.0n 0.4736 8249.9n 0.4736 8250.0n 0.4434 8499.9n 0.4434 8500.0n 0.3831 8749.9n 0.3831 8750.0n 0.6244 8999.9n 0.6244 9000.0n 0.4012 9249.9n 0.4012 9250.0n 0.6907 9499.9n 0.6907 9500.0n 0.6002 9749.9n 0.6002 9750.0n 0.3469 9999.9n 0.3469 10000.0n 0.4253 10249.9n 0.4253 10250.0n 0.4193 10499.9n 0.4193 10500.0n 0.6907 10749.9n 0.6907 10750.0n 0.4012 10999.9n 0.4012 11000.0n 0.5399 11249.9n 0.5399 11250.0n 0.5942 11499.9n 0.5942 11500.0n 0.6726 11749.9n 0.6726 11750.0n 0.4253 11999.9n 0.4253 12000.0n 0.4313 12249.9n 0.4313 12250.0n 0.5278 12499.9n 0.5278 12500.0n 0.4434 12749.9n 0.4434 12750.0n 0.6847 12999.9n 0.6847 13000.0n 0.4072 13249.9n 0.4072 13250.0n 0.5701 13499.9n 0.5701 13500.0n 0.6907 13749.9n 0.6907 13750.0n 0.5098 13999.9n 0.5098 14000.0n 0.5339 14249.9n 0.5339 14250.0n 0.4133 14499.9n 0.4133 14500.0n 0.4313 14749.9n 0.4313 14750.0n 0.4313 14999.9n 0.4313 15000.0n 0.5580 15249.9n 0.5580 15250.0n 0.4193 15499.9n 0.4193 15500.0n 0.4736 15749.9n 0.4736 15750.0n 0.4434 15999.9n 0.4434 16000.0n 0.3831 16249.9n 0.3831 16250.0n 0.6244 16499.9n 0.6244 16500.0n 0.4012 16749.9n 0.4012 16750.0n 0.6907 16999.9n 0.6907 17000.0n 0.6002 17249.9n 0.6002 17250.0n 0.3469 17499.9n 0.3469 17500.0n 0.4253 17749.9n 0.4253 17750.0n 0.4193 17999.9n 0.4193 18000.0n 0.6907 18249.9n 0.6907 18250.0n 0.4012 18499.9n 0.4012 18500.0n 0.5399 18749.9n 0.5399 18750.0n 0.5942 18999.9n 0.5942 19000.0n 0.6726 19249.9n 0.6726 19250.0n 0.4253 19499.9n 0.4253 19500.0n 0.4313 19749.9n 0.4313 19750.0n 0.5278 19999.9n 0.5278 20000.0n 0.4434 20249.9n 0.4434 20250.0n 0.6847 20499.9n 0.6847 20500.0n 0.4072 20749.9n 0.4072 20750.0n 0.5701 20999.9n 0.5701 21000.0n 0.6907 21249.9n 0.6907 21250.0n 0.5098 21499.9n 0.5098 21500.0n 0.5339 21749.9n 0.5339 21750.0n 0.4133 21999.9n 0.4133 22000.0n 0.4313 22249.9n 0.4313 22250.0n 0.4313 22499.9n 0.4313 22500.0n 0.5580 22749.9n 0.5580 22750.0n 0.4193 22999.9n 0.4193 23000.0n 0.4736 23249.9n 0.4736 23250.0n 0.4434 23499.9n 0.4434 23500.0n 0.3831 23749.9n 0.3831 23750.0n 0.6244 23999.9n 0.6244 24000.0n 0.4012 24249.9n 0.4012 24250.0n 0.6907 24499.9n 0.6907 24500.0n 0.6002 24749.9n 0.6002 24750.0n 0.3469 24999.9n 0.3469 25000.0n 0.4253 25249.9n 0.4253 25250.0n 0.4193 25499.9n 0.4193 25500.0n 0.6907 25749.9n 0.6907 25750.0n 0.4012 25999.9n 0.4012 26000.0n 0.5399 26249.9n 0.5399 26250.0n 0.5942 26499.9n 0.5942 26500.0n 0.6726 26749.9n 0.6726 26750.0n 0.4253 26999.9n 0.4253 27000.0n 0.4313 27249.9n 0.4313 27250.0n 0.5278 27499.9n 0.5278 27500.0n 0.4434 27749.9n 0.4434 27750.0n 0.6847 27999.9n 0.6847 28000.0n 0.4072 28249.9n 0.4072 28250.0n 0.5701 28499.9n 0.5701 28500.0n 0.6907 28749.9n 0.6907 28750.0n 0.5098 28999.9n 0.5098 29000.0n 0.5339 29249.9n 0.5339 29250.0n 0.4133 29499.9n 0.4133 29500.0n 0.4313 29749.9n 0.4313 29750.0n 0.4313 29999.9n 0.4313 30000.0n 0.5580 30249.9n 0.5580 30250.0n 0.4193 30499.9n 0.4193 30500.0n 0.4736 30749.9n 0.4736 30750.0n 0.4434 30999.9n 0.4434 31000.0n 0.3831 31249.9n 0.3831 31250.0n 0.6244 31499.9n 0.6244 31500.0n 0.4012 31749.9n 0.4012 31750.0n 0.6907 31999.9n 0.6907 32000.0n 0.6002 32249.9n 0.6002 32250.0n 0.3469 32499.9n 0.3469 32500.0n 0.4253 32749.9n 0.4253 32750.0n 0.4193 32999.9n 0.4193 33000.0n 0.6907 33249.9n 0.6907 33250.0n 0.4012 33499.9n 0.4012 33500.0n 0.5399 33749.9n 0.5399 33750.0n 0.5942 33999.9n 0.5942 34000.0n 0.6726 34249.9n 0.6726 34250.0n 0.4253 34499.9n 0.4253 34500.0n 0.4313 34749.9n 0.4313 34750.0n 0.5278 34999.9n 0.5278 35000.0n 0.4434 35249.9n 0.4434 35250.0n 0.6847 35499.9n 0.6847 35500.0n 0.4072 35749.9n 0.4072 35750.0n 0.5701 35999.9n 0.5701 36000.0n 0.6907 36249.9n 0.6907 36250.0n 0.5098 36499.9n 0.5098 36500.0n 0.5339 36749.9n 0.5339 36750.0n 0.4133 36999.9n 0.4133 37000.0n 0.4313 37249.9n 0.4313 37250.0n 0.4313 37499.9n 0.4313 37500.0n 0.5580 37749.9n 0.5580 37750.0n 0.4193 37999.9n 0.4193 38000.0n 0.4736 38249.9n 0.4736 38250.0n 0.4434 38499.9n 0.4434 38500.0n 0.3831 38749.9n 0.3831 38750.0n 0.6244 38999.9n 0.6244 39000.0n 0.4012 39249.9n 0.4012 39250.0n 0.6907 39499.9n 0.6907 39500.0n 0.6002 39749.9n 0.6002 39750.0n 0.3469 39999.9n 0.3469 40000.0n 0.4253 40249.9n 0.4253 40250.0n 0.4193 40499.9n 0.4193 40500.0n 0.6907 40749.9n 0.6907 40750.0n 0.4012 40999.9n 0.4012 41000.0n 0.5399 41249.9n 0.5399 41250.0n 0.5942 41499.9n 0.5942 41500.0n 0.6726 41749.9n 0.6726 41750.0n 0.4253 41999.9n 0.4253 42000.0n 0.4313 42249.9n 0.4313 42250.0n 0.5278 42499.9n 0.5278 42500.0n 0.4434 42749.9n 0.4434 42750.0n 0.6847 42999.9n 0.6847 43000.0n 0.4072 43249.9n 0.4072 43250.0n 0.5701 43499.9n 0.5701 43500.0n 0.6907 43749.9n 0.6907 43750.0n 0.5098 43999.9n 0.5098 44000.0n 0.5339 44249.9n 0.5339 44250.0n 0.4133 44499.9n 0.4133 44500.0n 0.4313 44749.9n 0.4313 44750.0n 0.4313 44999.9n 0.4313 45000.0n 0.5580 45249.9n 0.5580 45250.0n 0.4193 45499.9n 0.4193 45500.0n 0.4736 45749.9n 0.4736 45750.0n 0.4434 45999.9n 0.4434 46000.0n 0.3831 46249.9n 0.3831 46250.0n 0.6244 46499.9n 0.6244 46500.0n 0.4012 46749.9n 0.4012 46750.0n 0.6907 46999.9n 0.6907 47000.0n 0.6002 47249.9n 0.6002 47250.0n 0.3469 47499.9n 0.3469 47500.0n 0.4253 47749.9n 0.4253 47750.0n 0.4193 47999.9n 0.4193 48000.0n 0.6907 48249.9n 0.6907 48250.0n 0.4012 48499.9n 0.4012 48500.0n 0.5399 48749.9n 0.5399 48750.0n 0.5942 48999.9n 0.5942 49000.0n 0.6726 49249.9n 0.6726 49250.0n 0.4253 49499.9n 0.4253 49500.0n 0.4313 49749.9n 0.4313 49750.0n 0.5278 49999.9n 0.5278 50000.0n 0.4434 50249.9n 0.4434 50250.0n 0.6847 50499.9n 0.6847 50500.0n 0.4072 50749.9n 0.4072 50750.0n 0.5701 50999.9n 0.5701 51000.0n 0.6907 51249.9n 0.6907 51250.0n 0.5098 51499.9n 0.5098 51500.0n 0.5339 51749.9n 0.5339 51750.0n 0.4133 51999.9n 0.4133 52000.0n 0.4313 52249.9n 0.4313 52250.0n 0.4313 52499.9n 0.4313 52500.0n 0.5580 52749.9n 0.5580 52750.0n 0.4193 52999.9n 0.4193 53000.0n 0.4736 53249.9n 0.4736 53250.0n 0.4434 53499.9n 0.4434 53500.0n 0.3831 53749.9n 0.3831 53750.0n 0.6244 53999.9n 0.6244 54000.0n 0.4012 54249.9n 0.4012 54250.0n 0.6907 54499.9n 0.6907 54500.0n 0.6002 54749.9n 0.6002 54750.0n 0.3469 54999.9n 0.3469 55000.0n 0.4253 55249.9n 0.4253 55250.0n 0.4193 55499.9n 0.4193 55500.0n 0.6907 55749.9n 0.6907 55750.0n 0.4012 55999.9n 0.4012 56000.0n 0.5399 56249.9n 0.5399 56250.0n 0.5942 56499.9n 0.5942 56500.0n 0.6726 56749.9n 0.6726 56750.0n 0.4253 56999.9n 0.4253 57000.0n 0.4313 57249.9n 0.4313 57250.0n 0.5278 57499.9n 0.5278 57500.0n 0.4434 57749.9n 0.4434 57750.0n 0.6847 57999.9n 0.6847 58000.0n 0.4072 58249.9n 0.4072 58250.0n 0.5701 58499.9n 0.5701 58500.0n 0.6907 58749.9n 0.6907 58750.0n 0.5098 58999.9n 0.5098 59000.0n 0.5339 59249.9n 0.5339 59250.0n 0.4133 59499.9n 0.4133 59500.0n 0.4313 59749.9n 0.4313 59750.0n 0.4313 59999.9n 0.4313 60000.0n 0.5580 60249.9n 0.5580 60250.0n 0.4193 60499.9n 0.4193 60500.0n 0.4736 60749.9n 0.4736 60750.0n 0.4434 60999.9n 0.4434 61000.0n 0.3831 61249.9n 0.3831 61250.0n 0.6244 61499.9n 0.6244 61500.0n 0.4012 61749.9n 0.4012 61750.0n 0.6907 61999.9n 0.6907 62000.0n 0.6002 62249.9n 0.6002 62250.0n 0.3469 62499.9n 0.3469 62500.0n 0.4253 62749.9n 0.4253 62750.0n 0.4193 62999.9n 0.4193 63000.0n 0.6907 63249.9n 0.6907 63250.0n 0.4012 63499.9n 0.4012 63500.0n 0.5399 63749.9n 0.5399 63750.0n 0.5942 63999.9n 0.5942 64000.0n 0.6726 64249.9n 0.6726 64250.0n 0.4253 64499.9n 0.4253 64500.0n 0.4313 64749.9n 0.4313 64750.0n 0.5278 64999.9n 0.5278 65000.0n 0.4434 65249.9n 0.4434 65250.0n 0.6847 65499.9n 0.6847 65500.0n 0.4072 65749.9n 0.4072 65750.0n 0.5701 65999.9n 0.5701 66000.0n 0.6907 66249.9n 0.6907 66250.0n 0.5098 66499.9n 0.5098 66500.0n 0.5339 66749.9n 0.5339 66750.0n 0.4133 66999.9n 0.4133 67000.0n 0.4313 67249.9n 0.4313 67250.0n 0.4313 67499.9n 0.4313 67500.0n 0.5580 67749.9n 0.5580 67750.0n 0.4193 67999.9n 0.4193 68000.0n 0.4736 68249.9n 0.4736 68250.0n 0.4434 68499.9n 0.4434 68500.0n 0.3831 68749.9n 0.3831 68750.0n 0.6244 68999.9n 0.6244 69000.0n 0.4012 69249.9n 0.4012 69250.0n 0.6907 69499.9n 0.6907 69500.0n 0.6002 69749.9n 0.6002 69750.0n 0.3469 69999.9n 0.3469 70000.0n 0.4253 70249.9n 0.4253 70250.0n 0.4193 70499.9n 0.4193 70500.0n 0.6907 70749.9n 0.6907 70750.0n 0.4012 70999.9n 0.4012 71000.0n 0.5399 71249.9n 0.5399 71250.0n 0.5942 71499.9n 0.5942 71500.0n 0.6726 71749.9n 0.6726 71750.0n 0.4253 71999.9n 0.4253 72000.0n 0.4313 72249.9n 0.4313 72250.0n 0.5278 72499.9n 0.5278 72500.0n 0.4434 72749.9n 0.4434 72750.0n 0.6847 72999.9n 0.6847 73000.0n 0.4072 73249.9n 0.4072 73250.0n 0.5701 73499.9n 0.5701 73500.0n 0.6907 73749.9n 0.6907 73750.0n 0.5098 73999.9n 0.5098 74000.0n 0.5339 74249.9n 0.5339 74250.0n 0.4133 74499.9n 0.4133 74500.0n 0.4313 74749.9n 0.4313 74750.0n 0.4313 74999.9n 0.4313 75000.0n 0.5580 75249.9n 0.5580 75250.0n 0.4193 75499.9n 0.4193 75500.0n 0.4736 75749.9n 0.4736 75750.0n 0.4434 75999.9n 0.4434 76000.0n 0.3831 76249.9n 0.3831 76250.0n 0.6244 76499.9n 0.6244 76500.0n 0.4012 76749.9n 0.4012 76750.0n 0.6907 76999.9n 0.6907 77000.0n 0.6002 77249.9n 0.6002 77250.0n 0.3469 77499.9n 0.3469 77500.0n 0.4253 77749.9n 0.4253 77750.0n 0.4193 77999.9n 0.4193 78000.0n 0.6907 78249.9n 0.6907 78250.0n 0.4012 78499.9n 0.4012 78500.0n 0.5399 78749.9n 0.5399 78750.0n 0.5942 78999.9n 0.5942 79000.0n 0.6726 79249.9n 0.6726 79250.0n 0.4253 79499.9n 0.4253 79500.0n 0.4313 79749.9n 0.4313 79750.0n 0.5278 79999.9n 0.5278 80000.0n 0.4434 80249.9n 0.4434 80250.0n 0.6847 80499.9n 0.6847 80500.0n 0.4072 80749.9n 0.4072 80750.0n 0.5701 80999.9n 0.5701 81000.0n 0.6907 81249.9n 0.6907 81250.0n 0.5098 81499.9n 0.5098 81500.0n 0.5339 81749.9n 0.5339 81750.0n 0.4133 81999.9n 0.4133 82000.0n 0.4313 82249.9n 0.4313 82250.0n 0.4313 82499.9n 0.4313 82500.0n 0.5580 82749.9n 0.5580 82750.0n 0.4193 82999.9n 0.4193 83000.0n 0.4736 83249.9n 0.4736 83250.0n 0.4434 83499.9n 0.4434 83500.0n 0.3831 83749.9n 0.3831 83750.0n 0.6244 83999.9n 0.6244 84000.0n 0.4012 84249.9n 0.4012 84250.0n 0.6907 84499.9n 0.6907 84500.0n 0.6002 84749.9n 0.6002 84750.0n 0.3469 84999.9n 0.3469 85000.0n 0.4253 85249.9n 0.4253 85250.0n 0.4193 85499.9n 0.4193 85500.0n 0.6907 85749.9n 0.6907 85750.0n 0.4012 85999.9n 0.4012 86000.0n 0.5399 86249.9n 0.5399 86250.0n 0.5942 86499.9n 0.5942 86500.0n 0.6726 86749.9n 0.6726 86750.0n 0.4253 86999.9n 0.4253 87000.0n 0.4313 87249.9n 0.4313 87250.0n 0.5278 87499.9n 0.5278 87500.0n 0.4434 87749.9n 0.4434 87750.0n 0.6847 87999.9n 0.6847 88000.0n 0.4072 88249.9n 0.4072 88250.0n 0.5701 88499.9n 0.5701 88500.0n 0.6907 88749.9n 0.6907 88750.0n 0.5098 88999.9n 0.5098 89000.0n 0.5339 89249.9n 0.5339 89250.0n 0.4133 89499.9n 0.4133 89500.0n 0.4313 89749.9n 0.4313 89750.0n 0.4313 89999.9n 0.4313 90000.0n 0.5580 90249.9n 0.5580 90250.0n 0.4193 90499.9n 0.4193 90500.0n 0.4736 90749.9n 0.4736 90750.0n 0.4434 90999.9n 0.4434 91000.0n 0.3831 91249.9n 0.3831 91250.0n 0.6244 91499.9n 0.6244 91500.0n 0.4012 91749.9n 0.4012 91750.0n 0.6907 91999.9n 0.6907 92000.0n 0.6002 92249.9n 0.6002 92250.0n 0.3469 92499.9n 0.3469 92500.0n 0.4253 92749.9n 0.4253 92750.0n 0.4193 92999.9n 0.4193 93000.0n 0.6907 93249.9n 0.6907 93250.0n 0.4012 93499.9n 0.4012 93500.0n 0.5399 93749.9n 0.5399 93750.0n 0.5942 93999.9n 0.5942 94000.0n 0.6726 94249.9n 0.6726 94250.0n 0.4253 94499.9n 0.4253 94500.0n 0.4313 94749.9n 0.4313 94750.0n 0.5278 94999.9n 0.5278 95000.0n 0.4434 95249.9n 0.4434 95250.0n 0.6847 95499.9n 0.6847 95500.0n 0.4072 95749.9n 0.4072 95750.0n 0.5701 95999.9n 0.5701 96000.0n 0.6907 96249.9n 0.6907 96250.0n 0.5098 96499.9n 0.5098 96500.0n 0.5339 96749.9n 0.5339 96750.0n 0.4133 96999.9n 0.4133 97000.0n 0.4313 97249.9n 0.4313 97250.0n 0.4313 97499.9n 0.4313 97500.0n 0.5580 97749.9n 0.5580 97750.0n 0.4193 97999.9n 0.4193 98000.0n 0.4736 98249.9n 0.4736 98250.0n 0.4434 98499.9n 0.4434 98500.0n 0.3831 98749.9n 0.3831 98750.0n 0.6244 98999.9n 0.6244 99000.0n 0.4012 99249.9n 0.4012 99250.0n 0.6907 99499.9n 0.6907 99500.0n 0.6002 99749.9n 0.6002 99750.0n 0.3469 99999.9n 0.3469 100000.0n 0.4253 100249.9n 0.4253 100250.0n 0.4193 100499.9n 0.4193 100500.0n 0.6907 100749.9n 0.6907 100750.0n 0.4012 100999.9n 0.4012 101000.0n 0.5399 101249.9n 0.5399 101250.0n 0.5942 101499.9n 0.5942 101500.0n 0.6726 101749.9n 0.6726 101750.0n 0.4253 101999.9n 0.4253 102000.0n 0.4313 102249.9n 0.4313 102250.0n 0.5278 102499.9n 0.5278 102500.0n 0.4434 102749.9n 0.4434 102750.0n 0.6847 102999.9n 0.6847 103000.0n 0.4072 103249.9n 0.4072 103250.0n 0.5701 103499.9n 0.5701 103500.0n 0.6907 103749.9n 0.6907 103750.0n 0.5098 103999.9n 0.5098 104000.0n 0.5339 104249.9n 0.5339 104250.0n 0.4133 104499.9n 0.4133 104500.0n 0.4313 104749.9n 0.4313 104750.0n 0.4313 104999.9n 0.4313 105000.0n 0.5580 105249.9n 0.5580 105250.0n 0.4193 105499.9n 0.4193 105500.0n 0.4736 105749.9n 0.4736 105750.0n 0.4434 105999.9n 0.4434 106000.0n 0.3831 106249.9n 0.3831 106250.0n 0.6244 106499.9n 0.6244 106500.0n 0.4012 106749.9n 0.4012 106750.0n 0.6907 106999.9n 0.6907 107000.0n 0.6002 107249.9n 0.6002 107250.0n 0.3469 107499.9n 0.3469 107500.0n 0.4253 107749.9n 0.4253 107750.0n 0.4193 107999.9n 0.4193 108000.0n 0.6907 108249.9n 0.6907 108250.0n 0.4012 108499.9n 0.4012 108500.0n 0.5399 108749.9n 0.5399 108750.0n 0.5942 108999.9n 0.5942 109000.0n 0.6726 109249.9n 0.6726 109250.0n 0.4253 109499.9n 0.4253 109500.0n 0.4313 109749.9n 0.4313 109750.0n 0.5278 109999.9n 0.5278 110000.0n 0.4434 110249.9n 0.4434 110250.0n 0.6847 110499.9n 0.6847 110500.0n 0.4072 110749.9n 0.4072 110750.0n 0.5701 110999.9n 0.5701 111000.0n 0.6907 111249.9n 0.6907 111250.0n 0.5098 111499.9n 0.5098 111500.0n 0.5339 111749.9n 0.5339 111750.0n 0.4133 111999.9n 0.4133 112000.0n 0.4313 112249.9n 0.4313 112250.0n 0.4313 112499.9n 0.4313 112500.0n 0.5580 112749.9n 0.5580 112750.0n 0.4193 112999.9n 0.4193 113000.0n 0.4736 113249.9n 0.4736 113250.0n 0.4434 113499.9n 0.4434 113500.0n 0.3831 113749.9n 0.3831 113750.0n 0.6244 113999.9n 0.6244 114000.0n 0.4012 114249.9n 0.4012 114250.0n 0.6907 114499.9n 0.6907 114500.0n 0.6002 114749.9n 0.6002 114750.0n 0.3469 114999.9n 0.3469 115000.0n 0.4253 115249.9n 0.4253 115250.0n 0.4193 115499.9n 0.4193 115500.0n 0.6907 115749.9n 0.6907 115750.0n 0.4012 115999.9n 0.4012 116000.0n 0.5399 116249.9n 0.5399 116250.0n 0.5942 116499.9n 0.5942 116500.0n 0.6726 116749.9n 0.6726 116750.0n 0.4253 116999.9n 0.4253 117000.0n 0.4313 117249.9n 0.4313 117250.0n 0.5278 117499.9n 0.5278 117500.0n 0.4434 117749.9n 0.4434 117750.0n 0.6847 117999.9n 0.6847 118000.0n 0.4072 118249.9n 0.4072 118250.0n 0.5701 118499.9n 0.5701 118500.0n 0.6907 118749.9n 0.6907 118750.0n 0.5098 118999.9n 0.5098 119000.0n 0.5339 119249.9n 0.5339 119250.0n 0.4133 119499.9n 0.4133 119500.0n 0.4313 119749.9n 0.4313 119750.0n 0.4313 119999.9n 0.4313 120000.0n 0.5580 120249.9n 0.5580 120250.0n 0.4193 120499.9n 0.4193 120500.0n 0.4736 120749.9n 0.4736 120750.0n 0.4434 120999.9n 0.4434 121000.0n 0.3831 121249.9n 0.3831 121250.0n 0.6244 121499.9n 0.6244 121500.0n 0.4012 121749.9n 0.4012 121750.0n 0.6907 121999.9n 0.6907 122000.0n 0.6002 122249.9n 0.6002 122250.0n 0.3469 122499.9n 0.3469 122500.0n 0.4253 122749.9n 0.4253 122750.0n 0.4193 122999.9n 0.4193 123000.0n 0.6907 123249.9n 0.6907 123250.0n 0.4012 123499.9n 0.4012 123500.0n 0.5399 123749.9n 0.5399 123750.0n 0.5942 123999.9n 0.5942 124000.0n 0.6726 124249.9n 0.6726 124250.0n 0.4253 124499.9n 0.4253 124500.0n 0.4313 124749.9n 0.4313 124750.0n 0.5278 124999.9n 0.5278 125000.0n 0.4434 125249.9n 0.4434 125250.0n 0.6847 125499.9n 0.6847 125500.0n 0.4072 125749.9n 0.4072 125750.0n 0.5701 125999.9n 0.5701 126000.0n 0.6907 126249.9n 0.6907 126250.0n 0.5098 126499.9n 0.5098 126500.0n 0.5339 126749.9n 0.5339 126750.0n 0.4133 126999.9n 0.4133 127000.0n 0.4313 127249.9n 0.4313 127250.0n 0.4313 127499.9n 0.4313 127500.0n 0.5580 127749.9n 0.5580 127750.0n 0.4193 127999.9n 0.4193 128000.0n 0.4736 128249.9n 0.4736 128250.0n 0.4434 128499.9n 0.4434 128500.0n 0.3831 128749.9n 0.3831 128750.0n 0.6244 128999.9n 0.6244 129000.0n 0.4012 129249.9n 0.4012 129250.0n 0.6907 129499.9n 0.6907 129500.0n 0.6002 129749.9n 0.6002 129750.0n 0.3469 129999.9n 0.3469 130000.0n 0.4253 130249.9n 0.4253 130250.0n 0.4193 130499.9n 0.4193 130500.0n 0.6907 130749.9n 0.6907 130750.0n 0.4012 130999.9n 0.4012 131000.0n 0.5399 131249.9n 0.5399 131250.0n 0.5942 131499.9n 0.5942 131500.0n 0.6726 131749.9n 0.6726 131750.0n 0.4253 131999.9n 0.4253 132000.0n 0.4313 132249.9n 0.4313 132250.0n 0.5278 132499.9n 0.5278 132500.0n 0.4434 132749.9n 0.4434 132750.0n 0.6847 132999.9n 0.6847 133000.0n 0.4072 133249.9n 0.4072 133250.0n 0.5701 133499.9n 0.5701 133500.0n 0.6907 133749.9n 0.6907 133750.0n 0.5098 133999.9n 0.5098 134000.0n 0.5339 134249.9n 0.5339 134250.0n 0.4133 134499.9n 0.4133 134500.0n 0.4313 134749.9n 0.4313 134750.0n 0.4313 134999.9n 0.4313 135000.0n 0.5580 135249.9n 0.5580 135250.0n 0.4193 135499.9n 0.4193 135500.0n 0.4736 135749.9n 0.4736 135750.0n 0.4434 135999.9n 0.4434 136000.0n 0.3831 136249.9n 0.3831 136250.0n 0.6244 136499.9n 0.6244 136500.0n 0.4012 136749.9n 0.4012 136750.0n 0.6907 136999.9n 0.6907 137000.0n 0.6002 137249.9n 0.6002 137250.0n 0.3469 137499.9n 0.3469 137500.0n 0.4253 137749.9n 0.4253 137750.0n 0.4193 137999.9n 0.4193 138000.0n 0.6907 138249.9n 0.6907 138250.0n 0.4012 138499.9n 0.4012 138500.0n 0.5399 138749.9n 0.5399 138750.0n 0.5942 138999.9n 0.5942 139000.0n 0.6726 139249.9n 0.6726 139250.0n 0.4253 139499.9n 0.4253 139500.0n 0.4313 139749.9n 0.4313 139750.0n 0.5278 139999.9n 0.5278 140000.0n 0.4434 140249.9n 0.4434 140250.0n 0.6847 140499.9n 0.6847 140500.0n 0.4072 140749.9n 0.4072 140750.0n 0.5701 140999.9n 0.5701 141000.0n 0.6907 141249.9n 0.6907 141250.0n 0.5098 141499.9n 0.5098 141500.0n 0.5339 141749.9n 0.5339 141750.0n 0.4133 141999.9n 0.4133 142000.0n 0.4313 142249.9n 0.4313 142250.0n 0.4313 142499.9n 0.4313 142500.0n 0.5580 142749.9n 0.5580 142750.0n 0.4193 142999.9n 0.4193 143000.0n 0.4736 143249.9n 0.4736 143250.0n 0.4434 143499.9n 0.4434 143500.0n 0.3831 143749.9n 0.3831 143750.0n 0.6244 143999.9n 0.6244 144000.0n 0.4012 144249.9n 0.4012 144250.0n 0.6907 144499.9n 0.6907 144500.0n 0.6002 144749.9n 0.6002 144750.0n 0.3469 144999.9n 0.3469 145000.0n 0.4253 145249.9n 0.4253 145250.0n 0.4193 145499.9n 0.4193 145500.0n 0.6907 145749.9n 0.6907 145750.0n 0.4012 145999.9n 0.4012 146000.0n 0.5399 146249.9n 0.5399 146250.0n 0.5942 146499.9n 0.5942 146500.0n 0.6726 146749.9n 0.6726 146750.0n 0.4253 146999.9n 0.4253 147000.0n 0.4313 147249.9n 0.4313 147250.0n 0.5278 147499.9n 0.5278 147500.0n 0.4434 147749.9n 0.4434 147750.0n 0.6847 147999.9n 0.6847 148000.0n 0.4072 148249.9n 0.4072 148250.0n 0.5701 148499.9n 0.5701 148500.0n 0.6907 148749.9n 0.6907 148750.0n 0.5098 148999.9n 0.5098 149000.0n 0.5339 149249.9n 0.5339 149250.0n 0.4133 149499.9n 0.4133 149500.0n 0.4313 149749.9n 0.4313 149750.0n 0.4313 149999.9n 0.4313 150000.0n 0.5580 150249.9n 0.5580 150250.0n 0.4193 150499.9n 0.4193 150500.0n 0.4736 150749.9n 0.4736 150750.0n 0.4434 150999.9n 0.4434 151000.0n 0.3831 151249.9n 0.3831 151250.0n 0.6244 151499.9n 0.6244 151500.0n 0.4012 151749.9n 0.4012 151750.0n 0.6907 151999.9n 0.6907 152000.0n 0.6002 152249.9n 0.6002 152250.0n 0.3469 152499.9n 0.3469 152500.0n 0.4253 152749.9n 0.4253 152750.0n 0.4193 152999.9n 0.4193 153000.0n 0.6907 153249.9n 0.6907 153250.0n 0.4012 153499.9n 0.4012 153500.0n 0.5399 153749.9n 0.5399 153750.0n 0.5942 153999.9n 0.5942 154000.0n 0.6726 154249.9n 0.6726 154250.0n 0.4253 154499.9n 0.4253 154500.0n 0.4313 154749.9n 0.4313 154750.0n 0.5278 154999.9n 0.5278 155000.0n 0.4434 155249.9n 0.4434 155250.0n 0.6847 155499.9n 0.6847 155500.0n 0.4072 155749.9n 0.4072 155750.0n 0.5701 155999.9n 0.5701 156000.0n 0.6907 156249.9n 0.6907 156250.0n 0.5098 156499.9n 0.5098 156500.0n 0.5339 156749.9n 0.5339 156750.0n 0.4133 156999.9n 0.4133 157000.0n 0.4313 157249.9n 0.4313 157250.0n 0.4313 157499.9n 0.4313 157500.0n 0.5580 157749.9n 0.5580 157750.0n 0.4193 157999.9n 0.4193 158000.0n 0.4736 158249.9n 0.4736 158250.0n 0.4434 158499.9n 0.4434 158500.0n 0.3831 158749.9n 0.3831 158750.0n 0.6244 158999.9n 0.6244 159000.0n 0.4012 159249.9n 0.4012 159250.0n 0.6907 159499.9n 0.6907 159500.0n 0.6002 159749.9n 0.6002 159750.0n 0.3469 159999.9n 0.3469 160000.0n 0.4253 160249.9n 0.4253 160250.0n 0.4193 160499.9n 0.4193 160500.0n 0.6907 160749.9n 0.6907 160750.0n 0.4012 160999.9n 0.4012 161000.0n 0.5399 161249.9n 0.5399 161250.0n 0.5942 161499.9n 0.5942 161500.0n 0.6726 161749.9n 0.6726 161750.0n 0.4253 161999.9n 0.4253 162000.0n 0.4313 162249.9n 0.4313 162250.0n 0.5278 162499.9n 0.5278 162500.0n 0.4434 162749.9n 0.4434 162750.0n 0.6847 162999.9n 0.6847 163000.0n 0.4072 163249.9n 0.4072 163250.0n 0.5701 163499.9n 0.5701 163500.0n 0.6907 163749.9n 0.6907 163750.0n 0.5098 163999.9n 0.5098 164000.0n 0.5339 164249.9n 0.5339 164250.0n 0.4133 164499.9n 0.4133 164500.0n 0.4313 164749.9n 0.4313 164750.0n 0.4313 164999.9n 0.4313 165000.0n 0.5580 165249.9n 0.5580 165250.0n 0.4193 165499.9n 0.4193 165500.0n 0.4736 165749.9n 0.4736 165750.0n 0.4434 165999.9n 0.4434 166000.0n 0.3831 166249.9n 0.3831 166250.0n 0.6244 166499.9n 0.6244 166500.0n 0.4012 166749.9n 0.4012 166750.0n 0.6907 166999.9n 0.6907 167000.0n 0.6002 167249.9n 0.6002 167250.0n 0.3469 167499.9n 0.3469 167500.0n 0.4253 167749.9n 0.4253 167750.0n 0.4193 167999.9n 0.4193 168000.0n 0.6907 168249.9n 0.6907 168250.0n 0.4012 168499.9n 0.4012 168500.0n 0.5399 168749.9n 0.5399 168750.0n 0.5942 168999.9n 0.5942 169000.0n 0.6726 169249.9n 0.6726 169250.0n 0.4253 169499.9n 0.4253 169500.0n 0.4313 169749.9n 0.4313 169750.0n 0.5278 169999.9n 0.5278 170000.0n 0.4434 170249.9n 0.4434 170250.0n 0.6847 170499.9n 0.6847 170500.0n 0.4072 170749.9n 0.4072 170750.0n 0.5701 170999.9n 0.5701 171000.0n 0.6907 171249.9n 0.6907 171250.0n 0.5098 171499.9n 0.5098 171500.0n 0.5339 171749.9n 0.5339 171750.0n 0.4133 171999.9n 0.4133 172000.0n 0.4313 172249.9n 0.4313 172250.0n 0.4313 172499.9n 0.4313 172500.0n 0.5580 172749.9n 0.5580 172750.0n 0.4193 172999.9n 0.4193 173000.0n 0.4736 173249.9n 0.4736 173250.0n 0.4434 173499.9n 0.4434 173500.0n 0.3831 173749.9n 0.3831 173750.0n 0.6244 173999.9n 0.6244 174000.0n 0.4012 174249.9n 0.4012 174250.0n 0.6907 174499.9n 0.6907 174500.0n 0.6002 174749.9n 0.6002 174750.0n 0.3469 174999.9n 0.3469 175000.0n 0.4253 175249.9n 0.4253 175250.0n 0.4193 175499.9n 0.4193 175500.0n 0.6907 175749.9n 0.6907 175750.0n 0.4012 175999.9n 0.4012 176000.0n 0.5399 176249.9n 0.5399 176250.0n 0.5942 176499.9n 0.5942 176500.0n 0.6726 176749.9n 0.6726 176750.0n 0.4253 176999.9n 0.4253 177000.0n 0.4313 177249.9n 0.4313 177250.0n 0.5278 177499.9n 0.5278 177500.0n 0.4434 177749.9n 0.4434 177750.0n 0.6847 177999.9n 0.6847 178000.0n 0.4072 178249.9n 0.4072 178250.0n 0.5701 178499.9n 0.5701 178500.0n 0.6907 178749.9n 0.6907 178750.0n 0.5098 178999.9n 0.5098 179000.0n 0.5339 179249.9n 0.5339 179250.0n 0.4133 179499.9n 0.4133 179500.0n 0.4313 179749.9n 0.4313 179750.0n 0.4313 179999.9n 0.4313 180000.0n 0.5580 180249.9n 0.5580 180250.0n 0.4193 180499.9n 0.4193 180500.0n 0.4736 180749.9n 0.4736 180750.0n 0.4434 180999.9n 0.4434 181000.0n 0.3831 181249.9n 0.3831 181250.0n 0.6244 181499.9n 0.6244 181500.0n 0.4012 181749.9n 0.4012 181750.0n 0.6907 181999.9n 0.6907 182000.0n 0.6002 182249.9n 0.6002 182250.0n 0.3469 182499.9n 0.3469 182500.0n 0.4253 182749.9n 0.4253 182750.0n 0.4193 182999.9n 0.4193 183000.0n 0.6907 183249.9n 0.6907 183250.0n 0.4012 183499.9n 0.4012 183500.0n 0.5399 183749.9n 0.5399 183750.0n 0.5942 183999.9n 0.5942 184000.0n 0.6726 184249.9n 0.6726 184250.0n 0.4253 184499.9n 0.4253 184500.0n 0.4313 184749.9n 0.4313 184750.0n 0.5278 184999.9n 0.5278 185000.0n 0.4434 185249.9n 0.4434 185250.0n 0.6847 185499.9n 0.6847 185500.0n 0.4072 185749.9n 0.4072 185750.0n 0.5701 185999.9n 0.5701 186000.0n 0.6907 186249.9n 0.6907 186250.0n 0.5098 186499.9n 0.5098 186500.0n 0.5339 186749.9n 0.5339 186750.0n 0.4133 186999.9n 0.4133 187000.0n 0.4313 187249.9n 0.4313 187250.0n 0.4313 187499.9n 0.4313 187500.0n 0.5580 187749.9n 0.5580 187750.0n 0.4193 187999.9n 0.4193 188000.0n 0.4736 188249.9n 0.4736 188250.0n 0.4434 188499.9n 0.4434 188500.0n 0.3831 188749.9n 0.3831 188750.0n 0.6244 188999.9n 0.6244 189000.0n 0.4012 189249.9n 0.4012 189250.0n 0.6907 189499.9n 0.6907 189500.0n 0.6002 189749.9n 0.6002 189750.0n 0.3469 189999.9n 0.3469 190000.0n 0.4253 190249.9n 0.4253 190250.0n 0.4193 190499.9n 0.4193 190500.0n 0.6907 190749.9n 0.6907 190750.0n 0.4012 190999.9n 0.4012 191000.0n 0.5399 191249.9n 0.5399 191250.0n 0.5942 191499.9n 0.5942 191500.0n 0.6726 191749.9n 0.6726 191750.0n 0.4253 191999.9n 0.4253 192000.0n 0.4313 192249.9n 0.4313 192250.0n 0.5278 192499.9n 0.5278 192500.0n 0.4434 192749.9n 0.4434 192750.0n 0.6847 192999.9n 0.6847 193000.0n 0.4072 193249.9n 0.4072 193250.0n 0.5701 193499.9n 0.5701 193500.0n 0.6907 193749.9n 0.6907 193750.0n 0.5098 193999.9n 0.5098 194000.0n 0.5339 194249.9n 0.5339 194250.0n 0.4133 194499.9n 0.4133 194500.0n 0.4313 194749.9n 0.4313 194750.0n 0.4313 194999.9n 0.4313 195000.0n 0.5580 195249.9n 0.5580 195250.0n 0.4193 195499.9n 0.4193 195500.0n 0.4736 195749.9n 0.4736 195750.0n 0.4434 195999.9n 0.4434 196000.0n 0.3831 196249.9n 0.3831 196250.0n 0.6244 196499.9n 0.6244 196500.0n 0.4012 196749.9n 0.4012 196750.0n 0.6907 196999.9n 0.6907 197000.0n 0.6002 197249.9n 0.6002 197250.0n 0.3469 197499.9n 0.3469 197500.0n 0.4253 197749.9n 0.4253 197750.0n 0.4193 197999.9n 0.4193 198000.0n 0.6907 198249.9n 0.6907 198250.0n 0.4012 198499.9n 0.4012 198500.0n 0.5399 198749.9n 0.5399 198750.0n 0.5942 198999.9n 0.5942 199000.0n 0.6726 199249.9n 0.6726 199250.0n 0.4253 199499.9n 0.4253 199500.0n 0.4313 199749.9n 0.4313 199750.0n 0.5278 199999.9n 0.5278 200000.0n 0.4434 200249.9n 0.4434 200250.0n 0.6847 200499.9n 0.6847 200500.0n 0.4072 200749.9n 0.4072 200750.0n 0.5701 200999.9n 0.5701 201000.0n 0.6907 201249.9n 0.6907 201250.0n 0.5098 201499.9n 0.5098 201500.0n 0.5339 201749.9n 0.5339 201750.0n 0.4133 201999.9n 0.4133 202000.0n 0.4313 202249.9n 0.4313 202250.0n 0.4313 202499.9n 0.4313 202500.0n 0.5580 202749.9n 0.5580 202750.0n 0.4193 202999.9n 0.4193 203000.0n 0.4736 203249.9n 0.4736 203250.0n 0.4434 203499.9n 0.4434 203500.0n 0.3831 203749.9n 0.3831 203750.0n 0.6244 203999.9n 0.6244 204000.0n 0.4012 204249.9n 0.4012 204250.0n 0.6907 204499.9n 0.6907 204500.0n 0.6002 204749.9n 0.6002 204750.0n 0.3469 204999.9n 0.3469 205000.0n 0.4253 205249.9n 0.4253 205250.0n 0.4193 205499.9n 0.4193 205500.0n 0.6907 205749.9n 0.6907 205750.0n 0.4012 205999.9n 0.4012 206000.0n 0.5399 206249.9n 0.5399 206250.0n 0.5942 206499.9n 0.5942 206500.0n 0.6726 206749.9n 0.6726 206750.0n 0.4253 206999.9n 0.4253 207000.0n 0.4313 207249.9n 0.4313 207250.0n 0.5278 207499.9n 0.5278 207500.0n 0.4434 207749.9n 0.4434 207750.0n 0.6847 207999.9n 0.6847 208000.0n 0.4072 208249.9n 0.4072 208250.0n 0.5701 208499.9n 0.5701 208500.0n 0.6907 208749.9n 0.6907 208750.0n 0.5098 208999.9n 0.5098 209000.0n 0.5339 209249.9n 0.5339 209250.0n 0.4133 209499.9n 0.4133 209500.0n 0.4313 209749.9n 0.4313 209750.0n 0.4313 209999.9n 0.4313 210000.0n 0.5580 210249.9n 0.5580 210250.0n 0.4193 210499.9n 0.4193 210500.0n 0.4736 210749.9n 0.4736 210750.0n 0.4434 210999.9n 0.4434 211000.0n 0.3831 211249.9n 0.3831 211250.0n 0.6244 211499.9n 0.6244 211500.0n 0.4012 211749.9n 0.4012 211750.0n 0.6907 211999.9n 0.6907 212000.0n 0.6002 212249.9n 0.6002 212250.0n 0.3469 212499.9n 0.3469 212500.0n 0.4253 212749.9n 0.4253 212750.0n 0.4193 212999.9n 0.4193 213000.0n 0.6907 213249.9n 0.6907 213250.0n 0.4012 213499.9n 0.4012 213500.0n 0.5399 213749.9n 0.5399 213750.0n 0.5942 213999.9n 0.5942 214000.0n 0.6726 214249.9n 0.6726 214250.0n 0.4253 214499.9n 0.4253 214500.0n 0.4313 214749.9n 0.4313 214750.0n 0.5278 214999.9n 0.5278 215000.0n 0.4434 215249.9n 0.4434 215250.0n 0.6847 215499.9n 0.6847 215500.0n 0.4072 215749.9n 0.4072 215750.0n 0.5701 215999.9n 0.5701 216000.0n 0.6907 216249.9n 0.6907 216250.0n 0.5098 216499.9n 0.5098 216500.0n 0.5339 216749.9n 0.5339 216750.0n 0.4133 216999.9n 0.4133 217000.0n 0.4313 217249.9n 0.4313 217250.0n 0.4313 217499.9n 0.4313 217500.0n 0.5580 217749.9n 0.5580 217750.0n 0.4193 217999.9n 0.4193 218000.0n 0.4736 218249.9n 0.4736 218250.0n 0.4434 218499.9n 0.4434 218500.0n 0.3831 218749.9n 0.3831 218750.0n 0.6244 218999.9n 0.6244 219000.0n 0.4012 219249.9n 0.4012 219250.0n 0.6907 219499.9n 0.6907 219500.0n 0.6002 219749.9n 0.6002 219750.0n 0.3469 219999.9n 0.3469 220000.0n 0.4253 220249.9n 0.4253 220250.0n 0.4193 220499.9n 0.4193 220500.0n 0.6907 220749.9n 0.6907 220750.0n 0.4012 220999.9n 0.4012 221000.0n 0.5399 221249.9n 0.5399 221250.0n 0.5942 221499.9n 0.5942 221500.0n 0.6726 221749.9n 0.6726 221750.0n 0.4253 221999.9n 0.4253 222000.0n 0.4313 222249.9n 0.4313 222250.0n 0.5278 222499.9n 0.5278 222500.0n 0.4434 222749.9n 0.4434 222750.0n 0.6847 222999.9n 0.6847 223000.0n 0.4072 223249.9n 0.4072 223250.0n 0.5701 223499.9n 0.5701 223500.0n 0.6907 223749.9n 0.6907 223750.0n 0.5098 223999.9n 0.5098 224000.0n 0.5339 224249.9n 0.5339 224250.0n 0.4133 224499.9n 0.4133 224500.0n 0.4313 224749.9n 0.4313 224750.0n 0.4313 224999.9n 0.4313 225000.0n 0.5580 225249.9n 0.5580 225250.0n 0.4193 225499.9n 0.4193 225500.0n 0.4736 225749.9n 0.4736 225750.0n 0.4434 225999.9n 0.4434 226000.0n 0.3831 226249.9n 0.3831 226250.0n 0.6244 226499.9n 0.6244 226500.0n 0.4012 226749.9n 0.4012 226750.0n 0.6907 226999.9n 0.6907 227000.0n 0.6002 227249.9n 0.6002 227250.0n 0.3469 227499.9n 0.3469 227500.0n 0.4253 227749.9n 0.4253 227750.0n 0.4193 227999.9n 0.4193 228000.0n 0.6907 228249.9n 0.6907 228250.0n 0.4012 228499.9n 0.4012 228500.0n 0.5399 228749.9n 0.5399 228750.0n 0.5942 228999.9n 0.5942 229000.0n 0.6726 229249.9n 0.6726 229250.0n 0.4253 229499.9n 0.4253 229500.0n 0.4313 229749.9n 0.4313 229750.0n 0.5278 229999.9n 0.5278 230000.0n 0.4434 230249.9n 0.4434 230250.0n 0.6847 230499.9n 0.6847 230500.0n 0.4072 230749.9n 0.4072 230750.0n 0.5701 230999.9n 0.5701 231000.0n 0.6907 231249.9n 0.6907 231250.0n 0.5098 231499.9n 0.5098 231500.0n 0.5339 231749.9n 0.5339 231750.0n 0.4133 231999.9n 0.4133 232000.0n 0.4313 232249.9n 0.4313 232250.0n 0.4313 232499.9n 0.4313 232500.0n 0.5580 232749.9n 0.5580 232750.0n 0.4193 232999.9n 0.4193 233000.0n 0.4736 233249.9n 0.4736 233250.0n 0.4434 233499.9n 0.4434 233500.0n 0.3831 233749.9n 0.3831 233750.0n 0.6244 233999.9n 0.6244 234000.0n 0.4012 234249.9n 0.4012 234250.0n 0.6907 234499.9n 0.6907 234500.0n 0.6002 234749.9n 0.6002 234750.0n 0.3469 234999.9n 0.3469 235000.0n 0.4253 235249.9n 0.4253 235250.0n 0.4193 235499.9n 0.4193 235500.0n 0.6907 235749.9n 0.6907 235750.0n 0.4012 235999.9n 0.4012 236000.0n 0.5399 236249.9n 0.5399 236250.0n 0.5942 236499.9n 0.5942 236500.0n 0.6726 236749.9n 0.6726 236750.0n 0.4253 236999.9n 0.4253 237000.0n 0.4313 237249.9n 0.4313 237250.0n 0.5278 237499.9n 0.5278 237500.0n 0.4434 237749.9n 0.4434 237750.0n 0.6847 237999.9n 0.6847 238000.0n 0.4072 238249.9n 0.4072 238250.0n 0.5701 238499.9n 0.5701 238500.0n 0.6907 238749.9n 0.6907 238750.0n 0.5098 238999.9n 0.5098 239000.0n 0.5339 239249.9n 0.5339 239250.0n 0.4133 239499.9n 0.4133 239500.0n 0.4313 239749.9n 0.4313 239750.0n 0.4313 239999.9n 0.4313 240000.0n 0.5580 240249.9n 0.5580 240250.0n 0.4193 240499.9n 0.4193 240500.0n 0.4736 240749.9n 0.4736 240750.0n 0.4434 240999.9n 0.4434 241000.0n 0.3831 241249.9n 0.3831 241250.0n 0.6244 241499.9n 0.6244 241500.0n 0.4012 241749.9n 0.4012 241750.0n 0.6907 241999.9n 0.6907 242000.0n 0.6002 242249.9n 0.6002 242250.0n 0.3469 242499.9n 0.3469 242500.0n 0.4253 242749.9n 0.4253 242750.0n 0.4193 242999.9n 0.4193 243000.0n 0.6907 243249.9n 0.6907 243250.0n 0.4012 243499.9n 0.4012 243500.0n 0.5399 243749.9n 0.5399 243750.0n 0.5942 243999.9n 0.5942 244000.0n 0.6726 244249.9n 0.6726 244250.0n 0.4253 244499.9n 0.4253 244500.0n 0.4313 244749.9n 0.4313 244750.0n 0.5278 244999.9n 0.5278 245000.0n 0.4434 245249.9n 0.4434 245250.0n 0.6847 245499.9n 0.6847 245500.0n 0.4072 245749.9n 0.4072 245750.0n 0.5701 245999.9n 0.5701 246000.0n 0.6907 246249.9n 0.6907 246250.0n 0.5098 246499.9n 0.5098 246500.0n 0.5339 246749.9n 0.5339 246750.0n 0.4133 246999.9n 0.4133 247000.0n 0.4313 247249.9n 0.4313 247250.0n 0.4313 247499.9n 0.4313 247500.0n 0.5580 247749.9n 0.5580 247750.0n 0.4193 247999.9n 0.4193 248000.0n 0.4736 248249.9n 0.4736 248250.0n 0.4434 248499.9n 0.4434 248500.0n 0.3831 248749.9n 0.3831 248750.0n 0.6244 248999.9n 0.6244 249000.0n 0.4012 249249.9n 0.4012 249250.0n 0.6907 249499.9n 0.6907 249500.0n 0.6002 249749.9n 0.6002 249750.0n 0.3469 249999.9n 0.3469 250000.0n 0.4253 250249.9n 0.4253 250250.0n 0.4193 250499.9n 0.4193 250500.0n 0.6907 250749.9n 0.6907 250750.0n 0.4012 250999.9n 0.4012 251000.0n 0.5399 251249.9n 0.5399 251250.0n 0.5942 251499.9n 0.5942 251500.0n 0.6726 251749.9n 0.6726 251750.0n 0.4253 251999.9n 0.4253 252000.0n 0.4313 252249.9n 0.4313 252250.0n 0.5278 252499.9n 0.5278 252500.0n 0.4434 252749.9n 0.4434 252750.0n 0.6847 252999.9n 0.6847 253000.0n 0.4072 253249.9n 0.4072 253250.0n 0.5701 253499.9n 0.5701 253500.0n 0.6907 253749.9n 0.6907 253750.0n 0.5098 253999.9n 0.5098 254000.0n 0.5339 254249.9n 0.5339 254250.0n 0.4133 254499.9n 0.4133 254500.0n 0.4313 254749.9n 0.4313 254750.0n 0.4313 254999.9n 0.4313 255000.0n 0.5580 255249.9n 0.5580 255250.0n 0.4193 255499.9n 0.4193 255500.0n 0.4736 255749.9n 0.4736 255750.0n 0.4434 255999.9n 0.4434 256000.0n 0.3831 256249.9n 0.3831 256250.0n 0.6244 256499.9n 0.6244 256500.0n 0.4012 256749.9n 0.4012 256750.0n 0.6907 256999.9n 0.6907 257000.0n 0.6002 257249.9n 0.6002 257250.0n 0.3469 257499.9n 0.3469 257500.0n 0.4253 257749.9n 0.4253 257750.0n 0.4193 257999.9n 0.4193 258000.0n 0.6907 258249.9n 0.6907 258250.0n 0.4012 258499.9n 0.4012 258500.0n 0.5399 258749.9n 0.5399 258750.0n 0.5942 258999.9n 0.5942 259000.0n 0.6726 259249.9n 0.6726 259250.0n 0.4253 259499.9n 0.4253 259500.0n 0.4313 259749.9n 0.4313 259750.0n 0.5278 259999.9n 0.5278 260000.0n 0.4434 260249.9n 0.4434 260250.0n 0.6847 260499.9n 0.6847 260500.0n 0.4072 260749.9n 0.4072 260750.0n 0.5701 260999.9n 0.5701 261000.0n 0.6907 261249.9n 0.6907 261250.0n 0.5098 261499.9n 0.5098 261500.0n 0.5339 261749.9n 0.5339 261750.0n 0.4133 261999.9n 0.4133 262000.0n 0.4313 262249.9n 0.4313 262250.0n 0.4313 262499.9n 0.4313 262500.0n 0.5580 262749.9n 0.5580 262750.0n 0.4193 262999.9n 0.4193 263000.0n 0.4736 263249.9n 0.4736 263250.0n 0.4434 263499.9n 0.4434 263500.0n 0.3831 263749.9n 0.3831 263750.0n 0.6244 263999.9n 0.6244 264000.0n 0.4012 264249.9n 0.4012 264250.0n 0.6907 264499.9n 0.6907 264500.0n 0.6002 264749.9n 0.6002 264750.0n 0.3469 264999.9n 0.3469 265000.0n 0.4253 265249.9n 0.4253 265250.0n 0.4193 265499.9n 0.4193 265500.0n 0.6907 265749.9n 0.6907 265750.0n 0.4012 265999.9n 0.4012 266000.0n 0.5399 266249.9n 0.5399 266250.0n 0.5942 266499.9n 0.5942 266500.0n 0.6726 266749.9n 0.6726 266750.0n 0.4253 266999.9n 0.4253 267000.0n 0.4313 267249.9n 0.4313 267250.0n 0.5278 267499.9n 0.5278 267500.0n 0.4434 267749.9n 0.4434 267750.0n 0.6847 267999.9n 0.6847 268000.0n 0.4072 268249.9n 0.4072 268250.0n 0.5701 268499.9n 0.5701 268500.0n 0.6907 268749.9n 0.6907 268750.0n 0.5098 268999.9n 0.5098 269000.0n 0.5339 269249.9n 0.5339 269250.0n 0.4133 269499.9n 0.4133 269500.0n 0.4313 269749.9n 0.4313 269750.0n 0.4313 269999.9n 0.4313 270000.0n 0.5580 270249.9n 0.5580 270250.0n 0.4193 270499.9n 0.4193 270500.0n 0.4736 270749.9n 0.4736 270750.0n 0.4434 270999.9n 0.4434 271000.0n 0.3831 271249.9n 0.3831 271250.0n 0.6244 271499.9n 0.6244 271500.0n 0.4012 271749.9n 0.4012 271750.0n 0.6907 271999.9n 0.6907 272000.0n 0.6002 272249.9n 0.6002 272250.0n 0.3469 272499.9n 0.3469 272500.0n 0.4253 272749.9n 0.4253 272750.0n 0.4193 272999.9n 0.4193 273000.0n 0.6907 273249.9n 0.6907 273250.0n 0.4012 273499.9n 0.4012 273500.0n 0.5399 273749.9n 0.5399 273750.0n 0.5942 273999.9n 0.5942 274000.0n 0.6726 274249.9n 0.6726 274250.0n 0.4253 274499.9n 0.4253 274500.0n 0.4313 274749.9n 0.4313 274750.0n 0.5278 274999.9n 0.5278 275000.0n 0.4434 275249.9n 0.4434 275250.0n 0.6847 275499.9n 0.6847 275500.0n 0.4072 275749.9n 0.4072 275750.0n 0.5701 275999.9n 0.5701 276000.0n 0.6907 276249.9n 0.6907 276250.0n 0.5098 276499.9n 0.5098 276500.0n 0.5339 276749.9n 0.5339 276750.0n 0.4133 276999.9n 0.4133 277000.0n 0.4313 277249.9n 0.4313 277250.0n 0.4313 277499.9n 0.4313 277500.0n 0.5580 277749.9n 0.5580 277750.0n 0.4193 277999.9n 0.4193 278000.0n 0.4736 278249.9n 0.4736 278250.0n 0.4434 278499.9n 0.4434 278500.0n 0.3831 278749.9n 0.3831 278750.0n 0.6244 278999.9n 0.6244 279000.0n 0.4012 279249.9n 0.4012 279250.0n 0.6907 279499.9n 0.6907 279500.0n 0.6002 279749.9n 0.6002 279750.0n 0.3469 279999.9n 0.3469 280000.0n 0.4253 280249.9n 0.4253 280250.0n 0.4193 280499.9n 0.4193 280500.0n 0.6907 280749.9n 0.6907 280750.0n 0.4012 280999.9n 0.4012 281000.0n 0.5399 281249.9n 0.5399 281250.0n 0.5942 281499.9n 0.5942 281500.0n 0.6726 281749.9n 0.6726 281750.0n 0.4253 281999.9n 0.4253 282000.0n 0.4313 282249.9n 0.4313 282250.0n 0.5278 282499.9n 0.5278 282500.0n 0.4434 282749.9n 0.4434 282750.0n 0.6847 282999.9n 0.6847 283000.0n 0.4072 283249.9n 0.4072 283250.0n 0.5701 283499.9n 0.5701 283500.0n 0.6907 283749.9n 0.6907 283750.0n 0.5098 283999.9n 0.5098 284000.0n 0.5339 284249.9n 0.5339 284250.0n 0.4133 284499.9n 0.4133 284500.0n 0.4313 284749.9n 0.4313 284750.0n 0.4313 284999.9n 0.4313 285000.0n 0.5580 285249.9n 0.5580 285250.0n 0.4193 285499.9n 0.4193 285500.0n 0.4736 285749.9n 0.4736 285750.0n 0.4434 285999.9n 0.4434 286000.0n 0.3831 286249.9n 0.3831 286250.0n 0.6244 286499.9n 0.6244 286500.0n 0.4012 286749.9n 0.4012 286750.0n 0.6907 286999.9n 0.6907 287000.0n 0.6002 287249.9n 0.6002 287250.0n 0.3469 287499.9n 0.3469 287500.0n 0.4253 287749.9n 0.4253 287750.0n 0.4193 287999.9n 0.4193 288000.0n 0.6907 288249.9n 0.6907 288250.0n 0.4012 288499.9n 0.4012 288500.0n 0.5399 288749.9n 0.5399 288750.0n 0.5942 288999.9n 0.5942 289000.0n 0.6726 289249.9n 0.6726 289250.0n 0.4253 289499.9n 0.4253 289500.0n 0.4313 289749.9n 0.4313 289750.0n 0.5278 289999.9n 0.5278 290000.0n 0.4434 290249.9n 0.4434 290250.0n 0.6847 290499.9n 0.6847 290500.0n 0.4072 290749.9n 0.4072 290750.0n 0.5701 290999.9n 0.5701 291000.0n 0.6907 291249.9n 0.6907 291250.0n 0.5098 291499.9n 0.5098 291500.0n 0.5339 291749.9n 0.5339 291750.0n 0.4133 291999.9n 0.4133 292000.0n 0.4313 292249.9n 0.4313 292250.0n 0.4313 292499.9n 0.4313 292500.0n 0.5580 292749.9n 0.5580 292750.0n 0.4193 292999.9n 0.4193 293000.0n 0.4736 293249.9n 0.4736 293250.0n 0.4434 293499.9n 0.4434 293500.0n 0.3831 293749.9n 0.3831 293750.0n 0.6244 293999.9n 0.6244 294000.0n 0.4012 294249.9n 0.4012 294250.0n 0.6907 294499.9n 0.6907 294500.0n 0.6002 294749.9n 0.6002 294750.0n 0.3469 294999.9n 0.3469 295000.0n 0.4253 295249.9n 0.4253 295250.0n 0.4193 295499.9n 0.4193 295500.0n 0.6907 295749.9n 0.6907 295750.0n 0.4012 295999.9n 0.4012 296000.0n 0.5399 296249.9n 0.5399 296250.0n 0.5942 296499.9n 0.5942 296500.0n 0.6726 296749.9n 0.6726 296750.0n 0.4253 296999.9n 0.4253 297000.0n 0.4313 297249.9n 0.4313 297250.0n 0.5278 297499.9n 0.5278 297500.0n 0.4434 297749.9n 0.4434 297750.0n 0.6847 297999.9n 0.6847 298000.0n 0.4072 298249.9n 0.4072 298250.0n 0.5701 298499.9n 0.5701 298500.0n 0.6907 298749.9n 0.6907 298750.0n 0.5098 298999.9n 0.5098 299000.0n 0.5339 299249.9n 0.5339 299250.0n 0.4133 299499.9n 0.4133 299500.0n 0.4313 299749.9n 0.4313 299750.0n 0.4313)
Vxn6 a_xn6 0 PWL(0.0n 0.4420 249.9n 0.4420 250.0n 0.5807 499.9n 0.5807 500.0n 0.5264 749.9n 0.5264 750.0n 0.5566 999.9n 0.5566 1000.0n 0.6169 1249.9n 0.6169 1250.0n 0.3756 1499.9n 0.3756 1500.0n 0.5988 1749.9n 0.5988 1750.0n 0.3093 1999.9n 0.3093 2000.0n 0.3998 2249.9n 0.3998 2250.0n 0.6531 2499.9n 0.6531 2500.0n 0.5747 2749.9n 0.5747 2750.0n 0.5807 2999.9n 0.5807 3000.0n 0.3093 3249.9n 0.3093 3250.0n 0.5988 3499.9n 0.5988 3500.0n 0.4601 3749.9n 0.4601 3750.0n 0.4058 3999.9n 0.4058 4000.0n 0.3274 4249.9n 0.3274 4250.0n 0.5747 4499.9n 0.5747 4500.0n 0.5687 4749.9n 0.5687 4750.0n 0.4722 4999.9n 0.4722 5000.0n 0.5566 5249.9n 0.5566 5250.0n 0.3153 5499.9n 0.3153 5500.0n 0.5928 5749.9n 0.5928 5750.0n 0.4299 5999.9n 0.4299 6000.0n 0.3093 6249.9n 0.3093 6250.0n 0.4902 6499.9n 0.4902 6500.0n 0.4661 6749.9n 0.4661 6750.0n 0.5867 6999.9n 0.5867 7000.0n 0.5687 7249.9n 0.5687 7250.0n 0.5687 7499.9n 0.5687 7500.0n 0.4420 7749.9n 0.4420 7750.0n 0.5807 7999.9n 0.5807 8000.0n 0.5264 8249.9n 0.5264 8250.0n 0.5566 8499.9n 0.5566 8500.0n 0.6169 8749.9n 0.6169 8750.0n 0.3756 8999.9n 0.3756 9000.0n 0.5988 9249.9n 0.5988 9250.0n 0.3093 9499.9n 0.3093 9500.0n 0.3998 9749.9n 0.3998 9750.0n 0.6531 9999.9n 0.6531 10000.0n 0.5747 10249.9n 0.5747 10250.0n 0.5807 10499.9n 0.5807 10500.0n 0.3093 10749.9n 0.3093 10750.0n 0.5988 10999.9n 0.5988 11000.0n 0.4601 11249.9n 0.4601 11250.0n 0.4058 11499.9n 0.4058 11500.0n 0.3274 11749.9n 0.3274 11750.0n 0.5747 11999.9n 0.5747 12000.0n 0.5687 12249.9n 0.5687 12250.0n 0.4722 12499.9n 0.4722 12500.0n 0.5566 12749.9n 0.5566 12750.0n 0.3153 12999.9n 0.3153 13000.0n 0.5928 13249.9n 0.5928 13250.0n 0.4299 13499.9n 0.4299 13500.0n 0.3093 13749.9n 0.3093 13750.0n 0.4902 13999.9n 0.4902 14000.0n 0.4661 14249.9n 0.4661 14250.0n 0.5867 14499.9n 0.5867 14500.0n 0.5687 14749.9n 0.5687 14750.0n 0.5687 14999.9n 0.5687 15000.0n 0.4420 15249.9n 0.4420 15250.0n 0.5807 15499.9n 0.5807 15500.0n 0.5264 15749.9n 0.5264 15750.0n 0.5566 15999.9n 0.5566 16000.0n 0.6169 16249.9n 0.6169 16250.0n 0.3756 16499.9n 0.3756 16500.0n 0.5988 16749.9n 0.5988 16750.0n 0.3093 16999.9n 0.3093 17000.0n 0.3998 17249.9n 0.3998 17250.0n 0.6531 17499.9n 0.6531 17500.0n 0.5747 17749.9n 0.5747 17750.0n 0.5807 17999.9n 0.5807 18000.0n 0.3093 18249.9n 0.3093 18250.0n 0.5988 18499.9n 0.5988 18500.0n 0.4601 18749.9n 0.4601 18750.0n 0.4058 18999.9n 0.4058 19000.0n 0.3274 19249.9n 0.3274 19250.0n 0.5747 19499.9n 0.5747 19500.0n 0.5687 19749.9n 0.5687 19750.0n 0.4722 19999.9n 0.4722 20000.0n 0.5566 20249.9n 0.5566 20250.0n 0.3153 20499.9n 0.3153 20500.0n 0.5928 20749.9n 0.5928 20750.0n 0.4299 20999.9n 0.4299 21000.0n 0.3093 21249.9n 0.3093 21250.0n 0.4902 21499.9n 0.4902 21500.0n 0.4661 21749.9n 0.4661 21750.0n 0.5867 21999.9n 0.5867 22000.0n 0.5687 22249.9n 0.5687 22250.0n 0.5687 22499.9n 0.5687 22500.0n 0.4420 22749.9n 0.4420 22750.0n 0.5807 22999.9n 0.5807 23000.0n 0.5264 23249.9n 0.5264 23250.0n 0.5566 23499.9n 0.5566 23500.0n 0.6169 23749.9n 0.6169 23750.0n 0.3756 23999.9n 0.3756 24000.0n 0.5988 24249.9n 0.5988 24250.0n 0.3093 24499.9n 0.3093 24500.0n 0.3998 24749.9n 0.3998 24750.0n 0.6531 24999.9n 0.6531 25000.0n 0.5747 25249.9n 0.5747 25250.0n 0.5807 25499.9n 0.5807 25500.0n 0.3093 25749.9n 0.3093 25750.0n 0.5988 25999.9n 0.5988 26000.0n 0.4601 26249.9n 0.4601 26250.0n 0.4058 26499.9n 0.4058 26500.0n 0.3274 26749.9n 0.3274 26750.0n 0.5747 26999.9n 0.5747 27000.0n 0.5687 27249.9n 0.5687 27250.0n 0.4722 27499.9n 0.4722 27500.0n 0.5566 27749.9n 0.5566 27750.0n 0.3153 27999.9n 0.3153 28000.0n 0.5928 28249.9n 0.5928 28250.0n 0.4299 28499.9n 0.4299 28500.0n 0.3093 28749.9n 0.3093 28750.0n 0.4902 28999.9n 0.4902 29000.0n 0.4661 29249.9n 0.4661 29250.0n 0.5867 29499.9n 0.5867 29500.0n 0.5687 29749.9n 0.5687 29750.0n 0.5687 29999.9n 0.5687 30000.0n 0.4420 30249.9n 0.4420 30250.0n 0.5807 30499.9n 0.5807 30500.0n 0.5264 30749.9n 0.5264 30750.0n 0.5566 30999.9n 0.5566 31000.0n 0.6169 31249.9n 0.6169 31250.0n 0.3756 31499.9n 0.3756 31500.0n 0.5988 31749.9n 0.5988 31750.0n 0.3093 31999.9n 0.3093 32000.0n 0.3998 32249.9n 0.3998 32250.0n 0.6531 32499.9n 0.6531 32500.0n 0.5747 32749.9n 0.5747 32750.0n 0.5807 32999.9n 0.5807 33000.0n 0.3093 33249.9n 0.3093 33250.0n 0.5988 33499.9n 0.5988 33500.0n 0.4601 33749.9n 0.4601 33750.0n 0.4058 33999.9n 0.4058 34000.0n 0.3274 34249.9n 0.3274 34250.0n 0.5747 34499.9n 0.5747 34500.0n 0.5687 34749.9n 0.5687 34750.0n 0.4722 34999.9n 0.4722 35000.0n 0.5566 35249.9n 0.5566 35250.0n 0.3153 35499.9n 0.3153 35500.0n 0.5928 35749.9n 0.5928 35750.0n 0.4299 35999.9n 0.4299 36000.0n 0.3093 36249.9n 0.3093 36250.0n 0.4902 36499.9n 0.4902 36500.0n 0.4661 36749.9n 0.4661 36750.0n 0.5867 36999.9n 0.5867 37000.0n 0.5687 37249.9n 0.5687 37250.0n 0.5687 37499.9n 0.5687 37500.0n 0.4420 37749.9n 0.4420 37750.0n 0.5807 37999.9n 0.5807 38000.0n 0.5264 38249.9n 0.5264 38250.0n 0.5566 38499.9n 0.5566 38500.0n 0.6169 38749.9n 0.6169 38750.0n 0.3756 38999.9n 0.3756 39000.0n 0.5988 39249.9n 0.5988 39250.0n 0.3093 39499.9n 0.3093 39500.0n 0.3998 39749.9n 0.3998 39750.0n 0.6531 39999.9n 0.6531 40000.0n 0.5747 40249.9n 0.5747 40250.0n 0.5807 40499.9n 0.5807 40500.0n 0.3093 40749.9n 0.3093 40750.0n 0.5988 40999.9n 0.5988 41000.0n 0.4601 41249.9n 0.4601 41250.0n 0.4058 41499.9n 0.4058 41500.0n 0.3274 41749.9n 0.3274 41750.0n 0.5747 41999.9n 0.5747 42000.0n 0.5687 42249.9n 0.5687 42250.0n 0.4722 42499.9n 0.4722 42500.0n 0.5566 42749.9n 0.5566 42750.0n 0.3153 42999.9n 0.3153 43000.0n 0.5928 43249.9n 0.5928 43250.0n 0.4299 43499.9n 0.4299 43500.0n 0.3093 43749.9n 0.3093 43750.0n 0.4902 43999.9n 0.4902 44000.0n 0.4661 44249.9n 0.4661 44250.0n 0.5867 44499.9n 0.5867 44500.0n 0.5687 44749.9n 0.5687 44750.0n 0.5687 44999.9n 0.5687 45000.0n 0.4420 45249.9n 0.4420 45250.0n 0.5807 45499.9n 0.5807 45500.0n 0.5264 45749.9n 0.5264 45750.0n 0.5566 45999.9n 0.5566 46000.0n 0.6169 46249.9n 0.6169 46250.0n 0.3756 46499.9n 0.3756 46500.0n 0.5988 46749.9n 0.5988 46750.0n 0.3093 46999.9n 0.3093 47000.0n 0.3998 47249.9n 0.3998 47250.0n 0.6531 47499.9n 0.6531 47500.0n 0.5747 47749.9n 0.5747 47750.0n 0.5807 47999.9n 0.5807 48000.0n 0.3093 48249.9n 0.3093 48250.0n 0.5988 48499.9n 0.5988 48500.0n 0.4601 48749.9n 0.4601 48750.0n 0.4058 48999.9n 0.4058 49000.0n 0.3274 49249.9n 0.3274 49250.0n 0.5747 49499.9n 0.5747 49500.0n 0.5687 49749.9n 0.5687 49750.0n 0.4722 49999.9n 0.4722 50000.0n 0.5566 50249.9n 0.5566 50250.0n 0.3153 50499.9n 0.3153 50500.0n 0.5928 50749.9n 0.5928 50750.0n 0.4299 50999.9n 0.4299 51000.0n 0.3093 51249.9n 0.3093 51250.0n 0.4902 51499.9n 0.4902 51500.0n 0.4661 51749.9n 0.4661 51750.0n 0.5867 51999.9n 0.5867 52000.0n 0.5687 52249.9n 0.5687 52250.0n 0.5687 52499.9n 0.5687 52500.0n 0.4420 52749.9n 0.4420 52750.0n 0.5807 52999.9n 0.5807 53000.0n 0.5264 53249.9n 0.5264 53250.0n 0.5566 53499.9n 0.5566 53500.0n 0.6169 53749.9n 0.6169 53750.0n 0.3756 53999.9n 0.3756 54000.0n 0.5988 54249.9n 0.5988 54250.0n 0.3093 54499.9n 0.3093 54500.0n 0.3998 54749.9n 0.3998 54750.0n 0.6531 54999.9n 0.6531 55000.0n 0.5747 55249.9n 0.5747 55250.0n 0.5807 55499.9n 0.5807 55500.0n 0.3093 55749.9n 0.3093 55750.0n 0.5988 55999.9n 0.5988 56000.0n 0.4601 56249.9n 0.4601 56250.0n 0.4058 56499.9n 0.4058 56500.0n 0.3274 56749.9n 0.3274 56750.0n 0.5747 56999.9n 0.5747 57000.0n 0.5687 57249.9n 0.5687 57250.0n 0.4722 57499.9n 0.4722 57500.0n 0.5566 57749.9n 0.5566 57750.0n 0.3153 57999.9n 0.3153 58000.0n 0.5928 58249.9n 0.5928 58250.0n 0.4299 58499.9n 0.4299 58500.0n 0.3093 58749.9n 0.3093 58750.0n 0.4902 58999.9n 0.4902 59000.0n 0.4661 59249.9n 0.4661 59250.0n 0.5867 59499.9n 0.5867 59500.0n 0.5687 59749.9n 0.5687 59750.0n 0.5687 59999.9n 0.5687 60000.0n 0.4420 60249.9n 0.4420 60250.0n 0.5807 60499.9n 0.5807 60500.0n 0.5264 60749.9n 0.5264 60750.0n 0.5566 60999.9n 0.5566 61000.0n 0.6169 61249.9n 0.6169 61250.0n 0.3756 61499.9n 0.3756 61500.0n 0.5988 61749.9n 0.5988 61750.0n 0.3093 61999.9n 0.3093 62000.0n 0.3998 62249.9n 0.3998 62250.0n 0.6531 62499.9n 0.6531 62500.0n 0.5747 62749.9n 0.5747 62750.0n 0.5807 62999.9n 0.5807 63000.0n 0.3093 63249.9n 0.3093 63250.0n 0.5988 63499.9n 0.5988 63500.0n 0.4601 63749.9n 0.4601 63750.0n 0.4058 63999.9n 0.4058 64000.0n 0.3274 64249.9n 0.3274 64250.0n 0.5747 64499.9n 0.5747 64500.0n 0.5687 64749.9n 0.5687 64750.0n 0.4722 64999.9n 0.4722 65000.0n 0.5566 65249.9n 0.5566 65250.0n 0.3153 65499.9n 0.3153 65500.0n 0.5928 65749.9n 0.5928 65750.0n 0.4299 65999.9n 0.4299 66000.0n 0.3093 66249.9n 0.3093 66250.0n 0.4902 66499.9n 0.4902 66500.0n 0.4661 66749.9n 0.4661 66750.0n 0.5867 66999.9n 0.5867 67000.0n 0.5687 67249.9n 0.5687 67250.0n 0.5687 67499.9n 0.5687 67500.0n 0.4420 67749.9n 0.4420 67750.0n 0.5807 67999.9n 0.5807 68000.0n 0.5264 68249.9n 0.5264 68250.0n 0.5566 68499.9n 0.5566 68500.0n 0.6169 68749.9n 0.6169 68750.0n 0.3756 68999.9n 0.3756 69000.0n 0.5988 69249.9n 0.5988 69250.0n 0.3093 69499.9n 0.3093 69500.0n 0.3998 69749.9n 0.3998 69750.0n 0.6531 69999.9n 0.6531 70000.0n 0.5747 70249.9n 0.5747 70250.0n 0.5807 70499.9n 0.5807 70500.0n 0.3093 70749.9n 0.3093 70750.0n 0.5988 70999.9n 0.5988 71000.0n 0.4601 71249.9n 0.4601 71250.0n 0.4058 71499.9n 0.4058 71500.0n 0.3274 71749.9n 0.3274 71750.0n 0.5747 71999.9n 0.5747 72000.0n 0.5687 72249.9n 0.5687 72250.0n 0.4722 72499.9n 0.4722 72500.0n 0.5566 72749.9n 0.5566 72750.0n 0.3153 72999.9n 0.3153 73000.0n 0.5928 73249.9n 0.5928 73250.0n 0.4299 73499.9n 0.4299 73500.0n 0.3093 73749.9n 0.3093 73750.0n 0.4902 73999.9n 0.4902 74000.0n 0.4661 74249.9n 0.4661 74250.0n 0.5867 74499.9n 0.5867 74500.0n 0.5687 74749.9n 0.5687 74750.0n 0.5687 74999.9n 0.5687 75000.0n 0.4420 75249.9n 0.4420 75250.0n 0.5807 75499.9n 0.5807 75500.0n 0.5264 75749.9n 0.5264 75750.0n 0.5566 75999.9n 0.5566 76000.0n 0.6169 76249.9n 0.6169 76250.0n 0.3756 76499.9n 0.3756 76500.0n 0.5988 76749.9n 0.5988 76750.0n 0.3093 76999.9n 0.3093 77000.0n 0.3998 77249.9n 0.3998 77250.0n 0.6531 77499.9n 0.6531 77500.0n 0.5747 77749.9n 0.5747 77750.0n 0.5807 77999.9n 0.5807 78000.0n 0.3093 78249.9n 0.3093 78250.0n 0.5988 78499.9n 0.5988 78500.0n 0.4601 78749.9n 0.4601 78750.0n 0.4058 78999.9n 0.4058 79000.0n 0.3274 79249.9n 0.3274 79250.0n 0.5747 79499.9n 0.5747 79500.0n 0.5687 79749.9n 0.5687 79750.0n 0.4722 79999.9n 0.4722 80000.0n 0.5566 80249.9n 0.5566 80250.0n 0.3153 80499.9n 0.3153 80500.0n 0.5928 80749.9n 0.5928 80750.0n 0.4299 80999.9n 0.4299 81000.0n 0.3093 81249.9n 0.3093 81250.0n 0.4902 81499.9n 0.4902 81500.0n 0.4661 81749.9n 0.4661 81750.0n 0.5867 81999.9n 0.5867 82000.0n 0.5687 82249.9n 0.5687 82250.0n 0.5687 82499.9n 0.5687 82500.0n 0.4420 82749.9n 0.4420 82750.0n 0.5807 82999.9n 0.5807 83000.0n 0.5264 83249.9n 0.5264 83250.0n 0.5566 83499.9n 0.5566 83500.0n 0.6169 83749.9n 0.6169 83750.0n 0.3756 83999.9n 0.3756 84000.0n 0.5988 84249.9n 0.5988 84250.0n 0.3093 84499.9n 0.3093 84500.0n 0.3998 84749.9n 0.3998 84750.0n 0.6531 84999.9n 0.6531 85000.0n 0.5747 85249.9n 0.5747 85250.0n 0.5807 85499.9n 0.5807 85500.0n 0.3093 85749.9n 0.3093 85750.0n 0.5988 85999.9n 0.5988 86000.0n 0.4601 86249.9n 0.4601 86250.0n 0.4058 86499.9n 0.4058 86500.0n 0.3274 86749.9n 0.3274 86750.0n 0.5747 86999.9n 0.5747 87000.0n 0.5687 87249.9n 0.5687 87250.0n 0.4722 87499.9n 0.4722 87500.0n 0.5566 87749.9n 0.5566 87750.0n 0.3153 87999.9n 0.3153 88000.0n 0.5928 88249.9n 0.5928 88250.0n 0.4299 88499.9n 0.4299 88500.0n 0.3093 88749.9n 0.3093 88750.0n 0.4902 88999.9n 0.4902 89000.0n 0.4661 89249.9n 0.4661 89250.0n 0.5867 89499.9n 0.5867 89500.0n 0.5687 89749.9n 0.5687 89750.0n 0.5687 89999.9n 0.5687 90000.0n 0.4420 90249.9n 0.4420 90250.0n 0.5807 90499.9n 0.5807 90500.0n 0.5264 90749.9n 0.5264 90750.0n 0.5566 90999.9n 0.5566 91000.0n 0.6169 91249.9n 0.6169 91250.0n 0.3756 91499.9n 0.3756 91500.0n 0.5988 91749.9n 0.5988 91750.0n 0.3093 91999.9n 0.3093 92000.0n 0.3998 92249.9n 0.3998 92250.0n 0.6531 92499.9n 0.6531 92500.0n 0.5747 92749.9n 0.5747 92750.0n 0.5807 92999.9n 0.5807 93000.0n 0.3093 93249.9n 0.3093 93250.0n 0.5988 93499.9n 0.5988 93500.0n 0.4601 93749.9n 0.4601 93750.0n 0.4058 93999.9n 0.4058 94000.0n 0.3274 94249.9n 0.3274 94250.0n 0.5747 94499.9n 0.5747 94500.0n 0.5687 94749.9n 0.5687 94750.0n 0.4722 94999.9n 0.4722 95000.0n 0.5566 95249.9n 0.5566 95250.0n 0.3153 95499.9n 0.3153 95500.0n 0.5928 95749.9n 0.5928 95750.0n 0.4299 95999.9n 0.4299 96000.0n 0.3093 96249.9n 0.3093 96250.0n 0.4902 96499.9n 0.4902 96500.0n 0.4661 96749.9n 0.4661 96750.0n 0.5867 96999.9n 0.5867 97000.0n 0.5687 97249.9n 0.5687 97250.0n 0.5687 97499.9n 0.5687 97500.0n 0.4420 97749.9n 0.4420 97750.0n 0.5807 97999.9n 0.5807 98000.0n 0.5264 98249.9n 0.5264 98250.0n 0.5566 98499.9n 0.5566 98500.0n 0.6169 98749.9n 0.6169 98750.0n 0.3756 98999.9n 0.3756 99000.0n 0.5988 99249.9n 0.5988 99250.0n 0.3093 99499.9n 0.3093 99500.0n 0.3998 99749.9n 0.3998 99750.0n 0.6531 99999.9n 0.6531 100000.0n 0.5747 100249.9n 0.5747 100250.0n 0.5807 100499.9n 0.5807 100500.0n 0.3093 100749.9n 0.3093 100750.0n 0.5988 100999.9n 0.5988 101000.0n 0.4601 101249.9n 0.4601 101250.0n 0.4058 101499.9n 0.4058 101500.0n 0.3274 101749.9n 0.3274 101750.0n 0.5747 101999.9n 0.5747 102000.0n 0.5687 102249.9n 0.5687 102250.0n 0.4722 102499.9n 0.4722 102500.0n 0.5566 102749.9n 0.5566 102750.0n 0.3153 102999.9n 0.3153 103000.0n 0.5928 103249.9n 0.5928 103250.0n 0.4299 103499.9n 0.4299 103500.0n 0.3093 103749.9n 0.3093 103750.0n 0.4902 103999.9n 0.4902 104000.0n 0.4661 104249.9n 0.4661 104250.0n 0.5867 104499.9n 0.5867 104500.0n 0.5687 104749.9n 0.5687 104750.0n 0.5687 104999.9n 0.5687 105000.0n 0.4420 105249.9n 0.4420 105250.0n 0.5807 105499.9n 0.5807 105500.0n 0.5264 105749.9n 0.5264 105750.0n 0.5566 105999.9n 0.5566 106000.0n 0.6169 106249.9n 0.6169 106250.0n 0.3756 106499.9n 0.3756 106500.0n 0.5988 106749.9n 0.5988 106750.0n 0.3093 106999.9n 0.3093 107000.0n 0.3998 107249.9n 0.3998 107250.0n 0.6531 107499.9n 0.6531 107500.0n 0.5747 107749.9n 0.5747 107750.0n 0.5807 107999.9n 0.5807 108000.0n 0.3093 108249.9n 0.3093 108250.0n 0.5988 108499.9n 0.5988 108500.0n 0.4601 108749.9n 0.4601 108750.0n 0.4058 108999.9n 0.4058 109000.0n 0.3274 109249.9n 0.3274 109250.0n 0.5747 109499.9n 0.5747 109500.0n 0.5687 109749.9n 0.5687 109750.0n 0.4722 109999.9n 0.4722 110000.0n 0.5566 110249.9n 0.5566 110250.0n 0.3153 110499.9n 0.3153 110500.0n 0.5928 110749.9n 0.5928 110750.0n 0.4299 110999.9n 0.4299 111000.0n 0.3093 111249.9n 0.3093 111250.0n 0.4902 111499.9n 0.4902 111500.0n 0.4661 111749.9n 0.4661 111750.0n 0.5867 111999.9n 0.5867 112000.0n 0.5687 112249.9n 0.5687 112250.0n 0.5687 112499.9n 0.5687 112500.0n 0.4420 112749.9n 0.4420 112750.0n 0.5807 112999.9n 0.5807 113000.0n 0.5264 113249.9n 0.5264 113250.0n 0.5566 113499.9n 0.5566 113500.0n 0.6169 113749.9n 0.6169 113750.0n 0.3756 113999.9n 0.3756 114000.0n 0.5988 114249.9n 0.5988 114250.0n 0.3093 114499.9n 0.3093 114500.0n 0.3998 114749.9n 0.3998 114750.0n 0.6531 114999.9n 0.6531 115000.0n 0.5747 115249.9n 0.5747 115250.0n 0.5807 115499.9n 0.5807 115500.0n 0.3093 115749.9n 0.3093 115750.0n 0.5988 115999.9n 0.5988 116000.0n 0.4601 116249.9n 0.4601 116250.0n 0.4058 116499.9n 0.4058 116500.0n 0.3274 116749.9n 0.3274 116750.0n 0.5747 116999.9n 0.5747 117000.0n 0.5687 117249.9n 0.5687 117250.0n 0.4722 117499.9n 0.4722 117500.0n 0.5566 117749.9n 0.5566 117750.0n 0.3153 117999.9n 0.3153 118000.0n 0.5928 118249.9n 0.5928 118250.0n 0.4299 118499.9n 0.4299 118500.0n 0.3093 118749.9n 0.3093 118750.0n 0.4902 118999.9n 0.4902 119000.0n 0.4661 119249.9n 0.4661 119250.0n 0.5867 119499.9n 0.5867 119500.0n 0.5687 119749.9n 0.5687 119750.0n 0.5687 119999.9n 0.5687 120000.0n 0.4420 120249.9n 0.4420 120250.0n 0.5807 120499.9n 0.5807 120500.0n 0.5264 120749.9n 0.5264 120750.0n 0.5566 120999.9n 0.5566 121000.0n 0.6169 121249.9n 0.6169 121250.0n 0.3756 121499.9n 0.3756 121500.0n 0.5988 121749.9n 0.5988 121750.0n 0.3093 121999.9n 0.3093 122000.0n 0.3998 122249.9n 0.3998 122250.0n 0.6531 122499.9n 0.6531 122500.0n 0.5747 122749.9n 0.5747 122750.0n 0.5807 122999.9n 0.5807 123000.0n 0.3093 123249.9n 0.3093 123250.0n 0.5988 123499.9n 0.5988 123500.0n 0.4601 123749.9n 0.4601 123750.0n 0.4058 123999.9n 0.4058 124000.0n 0.3274 124249.9n 0.3274 124250.0n 0.5747 124499.9n 0.5747 124500.0n 0.5687 124749.9n 0.5687 124750.0n 0.4722 124999.9n 0.4722 125000.0n 0.5566 125249.9n 0.5566 125250.0n 0.3153 125499.9n 0.3153 125500.0n 0.5928 125749.9n 0.5928 125750.0n 0.4299 125999.9n 0.4299 126000.0n 0.3093 126249.9n 0.3093 126250.0n 0.4902 126499.9n 0.4902 126500.0n 0.4661 126749.9n 0.4661 126750.0n 0.5867 126999.9n 0.5867 127000.0n 0.5687 127249.9n 0.5687 127250.0n 0.5687 127499.9n 0.5687 127500.0n 0.4420 127749.9n 0.4420 127750.0n 0.5807 127999.9n 0.5807 128000.0n 0.5264 128249.9n 0.5264 128250.0n 0.5566 128499.9n 0.5566 128500.0n 0.6169 128749.9n 0.6169 128750.0n 0.3756 128999.9n 0.3756 129000.0n 0.5988 129249.9n 0.5988 129250.0n 0.3093 129499.9n 0.3093 129500.0n 0.3998 129749.9n 0.3998 129750.0n 0.6531 129999.9n 0.6531 130000.0n 0.5747 130249.9n 0.5747 130250.0n 0.5807 130499.9n 0.5807 130500.0n 0.3093 130749.9n 0.3093 130750.0n 0.5988 130999.9n 0.5988 131000.0n 0.4601 131249.9n 0.4601 131250.0n 0.4058 131499.9n 0.4058 131500.0n 0.3274 131749.9n 0.3274 131750.0n 0.5747 131999.9n 0.5747 132000.0n 0.5687 132249.9n 0.5687 132250.0n 0.4722 132499.9n 0.4722 132500.0n 0.5566 132749.9n 0.5566 132750.0n 0.3153 132999.9n 0.3153 133000.0n 0.5928 133249.9n 0.5928 133250.0n 0.4299 133499.9n 0.4299 133500.0n 0.3093 133749.9n 0.3093 133750.0n 0.4902 133999.9n 0.4902 134000.0n 0.4661 134249.9n 0.4661 134250.0n 0.5867 134499.9n 0.5867 134500.0n 0.5687 134749.9n 0.5687 134750.0n 0.5687 134999.9n 0.5687 135000.0n 0.4420 135249.9n 0.4420 135250.0n 0.5807 135499.9n 0.5807 135500.0n 0.5264 135749.9n 0.5264 135750.0n 0.5566 135999.9n 0.5566 136000.0n 0.6169 136249.9n 0.6169 136250.0n 0.3756 136499.9n 0.3756 136500.0n 0.5988 136749.9n 0.5988 136750.0n 0.3093 136999.9n 0.3093 137000.0n 0.3998 137249.9n 0.3998 137250.0n 0.6531 137499.9n 0.6531 137500.0n 0.5747 137749.9n 0.5747 137750.0n 0.5807 137999.9n 0.5807 138000.0n 0.3093 138249.9n 0.3093 138250.0n 0.5988 138499.9n 0.5988 138500.0n 0.4601 138749.9n 0.4601 138750.0n 0.4058 138999.9n 0.4058 139000.0n 0.3274 139249.9n 0.3274 139250.0n 0.5747 139499.9n 0.5747 139500.0n 0.5687 139749.9n 0.5687 139750.0n 0.4722 139999.9n 0.4722 140000.0n 0.5566 140249.9n 0.5566 140250.0n 0.3153 140499.9n 0.3153 140500.0n 0.5928 140749.9n 0.5928 140750.0n 0.4299 140999.9n 0.4299 141000.0n 0.3093 141249.9n 0.3093 141250.0n 0.4902 141499.9n 0.4902 141500.0n 0.4661 141749.9n 0.4661 141750.0n 0.5867 141999.9n 0.5867 142000.0n 0.5687 142249.9n 0.5687 142250.0n 0.5687 142499.9n 0.5687 142500.0n 0.4420 142749.9n 0.4420 142750.0n 0.5807 142999.9n 0.5807 143000.0n 0.5264 143249.9n 0.5264 143250.0n 0.5566 143499.9n 0.5566 143500.0n 0.6169 143749.9n 0.6169 143750.0n 0.3756 143999.9n 0.3756 144000.0n 0.5988 144249.9n 0.5988 144250.0n 0.3093 144499.9n 0.3093 144500.0n 0.3998 144749.9n 0.3998 144750.0n 0.6531 144999.9n 0.6531 145000.0n 0.5747 145249.9n 0.5747 145250.0n 0.5807 145499.9n 0.5807 145500.0n 0.3093 145749.9n 0.3093 145750.0n 0.5988 145999.9n 0.5988 146000.0n 0.4601 146249.9n 0.4601 146250.0n 0.4058 146499.9n 0.4058 146500.0n 0.3274 146749.9n 0.3274 146750.0n 0.5747 146999.9n 0.5747 147000.0n 0.5687 147249.9n 0.5687 147250.0n 0.4722 147499.9n 0.4722 147500.0n 0.5566 147749.9n 0.5566 147750.0n 0.3153 147999.9n 0.3153 148000.0n 0.5928 148249.9n 0.5928 148250.0n 0.4299 148499.9n 0.4299 148500.0n 0.3093 148749.9n 0.3093 148750.0n 0.4902 148999.9n 0.4902 149000.0n 0.4661 149249.9n 0.4661 149250.0n 0.5867 149499.9n 0.5867 149500.0n 0.5687 149749.9n 0.5687 149750.0n 0.5687 149999.9n 0.5687 150000.0n 0.4420 150249.9n 0.4420 150250.0n 0.5807 150499.9n 0.5807 150500.0n 0.5264 150749.9n 0.5264 150750.0n 0.5566 150999.9n 0.5566 151000.0n 0.6169 151249.9n 0.6169 151250.0n 0.3756 151499.9n 0.3756 151500.0n 0.5988 151749.9n 0.5988 151750.0n 0.3093 151999.9n 0.3093 152000.0n 0.3998 152249.9n 0.3998 152250.0n 0.6531 152499.9n 0.6531 152500.0n 0.5747 152749.9n 0.5747 152750.0n 0.5807 152999.9n 0.5807 153000.0n 0.3093 153249.9n 0.3093 153250.0n 0.5988 153499.9n 0.5988 153500.0n 0.4601 153749.9n 0.4601 153750.0n 0.4058 153999.9n 0.4058 154000.0n 0.3274 154249.9n 0.3274 154250.0n 0.5747 154499.9n 0.5747 154500.0n 0.5687 154749.9n 0.5687 154750.0n 0.4722 154999.9n 0.4722 155000.0n 0.5566 155249.9n 0.5566 155250.0n 0.3153 155499.9n 0.3153 155500.0n 0.5928 155749.9n 0.5928 155750.0n 0.4299 155999.9n 0.4299 156000.0n 0.3093 156249.9n 0.3093 156250.0n 0.4902 156499.9n 0.4902 156500.0n 0.4661 156749.9n 0.4661 156750.0n 0.5867 156999.9n 0.5867 157000.0n 0.5687 157249.9n 0.5687 157250.0n 0.5687 157499.9n 0.5687 157500.0n 0.4420 157749.9n 0.4420 157750.0n 0.5807 157999.9n 0.5807 158000.0n 0.5264 158249.9n 0.5264 158250.0n 0.5566 158499.9n 0.5566 158500.0n 0.6169 158749.9n 0.6169 158750.0n 0.3756 158999.9n 0.3756 159000.0n 0.5988 159249.9n 0.5988 159250.0n 0.3093 159499.9n 0.3093 159500.0n 0.3998 159749.9n 0.3998 159750.0n 0.6531 159999.9n 0.6531 160000.0n 0.5747 160249.9n 0.5747 160250.0n 0.5807 160499.9n 0.5807 160500.0n 0.3093 160749.9n 0.3093 160750.0n 0.5988 160999.9n 0.5988 161000.0n 0.4601 161249.9n 0.4601 161250.0n 0.4058 161499.9n 0.4058 161500.0n 0.3274 161749.9n 0.3274 161750.0n 0.5747 161999.9n 0.5747 162000.0n 0.5687 162249.9n 0.5687 162250.0n 0.4722 162499.9n 0.4722 162500.0n 0.5566 162749.9n 0.5566 162750.0n 0.3153 162999.9n 0.3153 163000.0n 0.5928 163249.9n 0.5928 163250.0n 0.4299 163499.9n 0.4299 163500.0n 0.3093 163749.9n 0.3093 163750.0n 0.4902 163999.9n 0.4902 164000.0n 0.4661 164249.9n 0.4661 164250.0n 0.5867 164499.9n 0.5867 164500.0n 0.5687 164749.9n 0.5687 164750.0n 0.5687 164999.9n 0.5687 165000.0n 0.4420 165249.9n 0.4420 165250.0n 0.5807 165499.9n 0.5807 165500.0n 0.5264 165749.9n 0.5264 165750.0n 0.5566 165999.9n 0.5566 166000.0n 0.6169 166249.9n 0.6169 166250.0n 0.3756 166499.9n 0.3756 166500.0n 0.5988 166749.9n 0.5988 166750.0n 0.3093 166999.9n 0.3093 167000.0n 0.3998 167249.9n 0.3998 167250.0n 0.6531 167499.9n 0.6531 167500.0n 0.5747 167749.9n 0.5747 167750.0n 0.5807 167999.9n 0.5807 168000.0n 0.3093 168249.9n 0.3093 168250.0n 0.5988 168499.9n 0.5988 168500.0n 0.4601 168749.9n 0.4601 168750.0n 0.4058 168999.9n 0.4058 169000.0n 0.3274 169249.9n 0.3274 169250.0n 0.5747 169499.9n 0.5747 169500.0n 0.5687 169749.9n 0.5687 169750.0n 0.4722 169999.9n 0.4722 170000.0n 0.5566 170249.9n 0.5566 170250.0n 0.3153 170499.9n 0.3153 170500.0n 0.5928 170749.9n 0.5928 170750.0n 0.4299 170999.9n 0.4299 171000.0n 0.3093 171249.9n 0.3093 171250.0n 0.4902 171499.9n 0.4902 171500.0n 0.4661 171749.9n 0.4661 171750.0n 0.5867 171999.9n 0.5867 172000.0n 0.5687 172249.9n 0.5687 172250.0n 0.5687 172499.9n 0.5687 172500.0n 0.4420 172749.9n 0.4420 172750.0n 0.5807 172999.9n 0.5807 173000.0n 0.5264 173249.9n 0.5264 173250.0n 0.5566 173499.9n 0.5566 173500.0n 0.6169 173749.9n 0.6169 173750.0n 0.3756 173999.9n 0.3756 174000.0n 0.5988 174249.9n 0.5988 174250.0n 0.3093 174499.9n 0.3093 174500.0n 0.3998 174749.9n 0.3998 174750.0n 0.6531 174999.9n 0.6531 175000.0n 0.5747 175249.9n 0.5747 175250.0n 0.5807 175499.9n 0.5807 175500.0n 0.3093 175749.9n 0.3093 175750.0n 0.5988 175999.9n 0.5988 176000.0n 0.4601 176249.9n 0.4601 176250.0n 0.4058 176499.9n 0.4058 176500.0n 0.3274 176749.9n 0.3274 176750.0n 0.5747 176999.9n 0.5747 177000.0n 0.5687 177249.9n 0.5687 177250.0n 0.4722 177499.9n 0.4722 177500.0n 0.5566 177749.9n 0.5566 177750.0n 0.3153 177999.9n 0.3153 178000.0n 0.5928 178249.9n 0.5928 178250.0n 0.4299 178499.9n 0.4299 178500.0n 0.3093 178749.9n 0.3093 178750.0n 0.4902 178999.9n 0.4902 179000.0n 0.4661 179249.9n 0.4661 179250.0n 0.5867 179499.9n 0.5867 179500.0n 0.5687 179749.9n 0.5687 179750.0n 0.5687 179999.9n 0.5687 180000.0n 0.4420 180249.9n 0.4420 180250.0n 0.5807 180499.9n 0.5807 180500.0n 0.5264 180749.9n 0.5264 180750.0n 0.5566 180999.9n 0.5566 181000.0n 0.6169 181249.9n 0.6169 181250.0n 0.3756 181499.9n 0.3756 181500.0n 0.5988 181749.9n 0.5988 181750.0n 0.3093 181999.9n 0.3093 182000.0n 0.3998 182249.9n 0.3998 182250.0n 0.6531 182499.9n 0.6531 182500.0n 0.5747 182749.9n 0.5747 182750.0n 0.5807 182999.9n 0.5807 183000.0n 0.3093 183249.9n 0.3093 183250.0n 0.5988 183499.9n 0.5988 183500.0n 0.4601 183749.9n 0.4601 183750.0n 0.4058 183999.9n 0.4058 184000.0n 0.3274 184249.9n 0.3274 184250.0n 0.5747 184499.9n 0.5747 184500.0n 0.5687 184749.9n 0.5687 184750.0n 0.4722 184999.9n 0.4722 185000.0n 0.5566 185249.9n 0.5566 185250.0n 0.3153 185499.9n 0.3153 185500.0n 0.5928 185749.9n 0.5928 185750.0n 0.4299 185999.9n 0.4299 186000.0n 0.3093 186249.9n 0.3093 186250.0n 0.4902 186499.9n 0.4902 186500.0n 0.4661 186749.9n 0.4661 186750.0n 0.5867 186999.9n 0.5867 187000.0n 0.5687 187249.9n 0.5687 187250.0n 0.5687 187499.9n 0.5687 187500.0n 0.4420 187749.9n 0.4420 187750.0n 0.5807 187999.9n 0.5807 188000.0n 0.5264 188249.9n 0.5264 188250.0n 0.5566 188499.9n 0.5566 188500.0n 0.6169 188749.9n 0.6169 188750.0n 0.3756 188999.9n 0.3756 189000.0n 0.5988 189249.9n 0.5988 189250.0n 0.3093 189499.9n 0.3093 189500.0n 0.3998 189749.9n 0.3998 189750.0n 0.6531 189999.9n 0.6531 190000.0n 0.5747 190249.9n 0.5747 190250.0n 0.5807 190499.9n 0.5807 190500.0n 0.3093 190749.9n 0.3093 190750.0n 0.5988 190999.9n 0.5988 191000.0n 0.4601 191249.9n 0.4601 191250.0n 0.4058 191499.9n 0.4058 191500.0n 0.3274 191749.9n 0.3274 191750.0n 0.5747 191999.9n 0.5747 192000.0n 0.5687 192249.9n 0.5687 192250.0n 0.4722 192499.9n 0.4722 192500.0n 0.5566 192749.9n 0.5566 192750.0n 0.3153 192999.9n 0.3153 193000.0n 0.5928 193249.9n 0.5928 193250.0n 0.4299 193499.9n 0.4299 193500.0n 0.3093 193749.9n 0.3093 193750.0n 0.4902 193999.9n 0.4902 194000.0n 0.4661 194249.9n 0.4661 194250.0n 0.5867 194499.9n 0.5867 194500.0n 0.5687 194749.9n 0.5687 194750.0n 0.5687 194999.9n 0.5687 195000.0n 0.4420 195249.9n 0.4420 195250.0n 0.5807 195499.9n 0.5807 195500.0n 0.5264 195749.9n 0.5264 195750.0n 0.5566 195999.9n 0.5566 196000.0n 0.6169 196249.9n 0.6169 196250.0n 0.3756 196499.9n 0.3756 196500.0n 0.5988 196749.9n 0.5988 196750.0n 0.3093 196999.9n 0.3093 197000.0n 0.3998 197249.9n 0.3998 197250.0n 0.6531 197499.9n 0.6531 197500.0n 0.5747 197749.9n 0.5747 197750.0n 0.5807 197999.9n 0.5807 198000.0n 0.3093 198249.9n 0.3093 198250.0n 0.5988 198499.9n 0.5988 198500.0n 0.4601 198749.9n 0.4601 198750.0n 0.4058 198999.9n 0.4058 199000.0n 0.3274 199249.9n 0.3274 199250.0n 0.5747 199499.9n 0.5747 199500.0n 0.5687 199749.9n 0.5687 199750.0n 0.4722 199999.9n 0.4722 200000.0n 0.5566 200249.9n 0.5566 200250.0n 0.3153 200499.9n 0.3153 200500.0n 0.5928 200749.9n 0.5928 200750.0n 0.4299 200999.9n 0.4299 201000.0n 0.3093 201249.9n 0.3093 201250.0n 0.4902 201499.9n 0.4902 201500.0n 0.4661 201749.9n 0.4661 201750.0n 0.5867 201999.9n 0.5867 202000.0n 0.5687 202249.9n 0.5687 202250.0n 0.5687 202499.9n 0.5687 202500.0n 0.4420 202749.9n 0.4420 202750.0n 0.5807 202999.9n 0.5807 203000.0n 0.5264 203249.9n 0.5264 203250.0n 0.5566 203499.9n 0.5566 203500.0n 0.6169 203749.9n 0.6169 203750.0n 0.3756 203999.9n 0.3756 204000.0n 0.5988 204249.9n 0.5988 204250.0n 0.3093 204499.9n 0.3093 204500.0n 0.3998 204749.9n 0.3998 204750.0n 0.6531 204999.9n 0.6531 205000.0n 0.5747 205249.9n 0.5747 205250.0n 0.5807 205499.9n 0.5807 205500.0n 0.3093 205749.9n 0.3093 205750.0n 0.5988 205999.9n 0.5988 206000.0n 0.4601 206249.9n 0.4601 206250.0n 0.4058 206499.9n 0.4058 206500.0n 0.3274 206749.9n 0.3274 206750.0n 0.5747 206999.9n 0.5747 207000.0n 0.5687 207249.9n 0.5687 207250.0n 0.4722 207499.9n 0.4722 207500.0n 0.5566 207749.9n 0.5566 207750.0n 0.3153 207999.9n 0.3153 208000.0n 0.5928 208249.9n 0.5928 208250.0n 0.4299 208499.9n 0.4299 208500.0n 0.3093 208749.9n 0.3093 208750.0n 0.4902 208999.9n 0.4902 209000.0n 0.4661 209249.9n 0.4661 209250.0n 0.5867 209499.9n 0.5867 209500.0n 0.5687 209749.9n 0.5687 209750.0n 0.5687 209999.9n 0.5687 210000.0n 0.4420 210249.9n 0.4420 210250.0n 0.5807 210499.9n 0.5807 210500.0n 0.5264 210749.9n 0.5264 210750.0n 0.5566 210999.9n 0.5566 211000.0n 0.6169 211249.9n 0.6169 211250.0n 0.3756 211499.9n 0.3756 211500.0n 0.5988 211749.9n 0.5988 211750.0n 0.3093 211999.9n 0.3093 212000.0n 0.3998 212249.9n 0.3998 212250.0n 0.6531 212499.9n 0.6531 212500.0n 0.5747 212749.9n 0.5747 212750.0n 0.5807 212999.9n 0.5807 213000.0n 0.3093 213249.9n 0.3093 213250.0n 0.5988 213499.9n 0.5988 213500.0n 0.4601 213749.9n 0.4601 213750.0n 0.4058 213999.9n 0.4058 214000.0n 0.3274 214249.9n 0.3274 214250.0n 0.5747 214499.9n 0.5747 214500.0n 0.5687 214749.9n 0.5687 214750.0n 0.4722 214999.9n 0.4722 215000.0n 0.5566 215249.9n 0.5566 215250.0n 0.3153 215499.9n 0.3153 215500.0n 0.5928 215749.9n 0.5928 215750.0n 0.4299 215999.9n 0.4299 216000.0n 0.3093 216249.9n 0.3093 216250.0n 0.4902 216499.9n 0.4902 216500.0n 0.4661 216749.9n 0.4661 216750.0n 0.5867 216999.9n 0.5867 217000.0n 0.5687 217249.9n 0.5687 217250.0n 0.5687 217499.9n 0.5687 217500.0n 0.4420 217749.9n 0.4420 217750.0n 0.5807 217999.9n 0.5807 218000.0n 0.5264 218249.9n 0.5264 218250.0n 0.5566 218499.9n 0.5566 218500.0n 0.6169 218749.9n 0.6169 218750.0n 0.3756 218999.9n 0.3756 219000.0n 0.5988 219249.9n 0.5988 219250.0n 0.3093 219499.9n 0.3093 219500.0n 0.3998 219749.9n 0.3998 219750.0n 0.6531 219999.9n 0.6531 220000.0n 0.5747 220249.9n 0.5747 220250.0n 0.5807 220499.9n 0.5807 220500.0n 0.3093 220749.9n 0.3093 220750.0n 0.5988 220999.9n 0.5988 221000.0n 0.4601 221249.9n 0.4601 221250.0n 0.4058 221499.9n 0.4058 221500.0n 0.3274 221749.9n 0.3274 221750.0n 0.5747 221999.9n 0.5747 222000.0n 0.5687 222249.9n 0.5687 222250.0n 0.4722 222499.9n 0.4722 222500.0n 0.5566 222749.9n 0.5566 222750.0n 0.3153 222999.9n 0.3153 223000.0n 0.5928 223249.9n 0.5928 223250.0n 0.4299 223499.9n 0.4299 223500.0n 0.3093 223749.9n 0.3093 223750.0n 0.4902 223999.9n 0.4902 224000.0n 0.4661 224249.9n 0.4661 224250.0n 0.5867 224499.9n 0.5867 224500.0n 0.5687 224749.9n 0.5687 224750.0n 0.5687 224999.9n 0.5687 225000.0n 0.4420 225249.9n 0.4420 225250.0n 0.5807 225499.9n 0.5807 225500.0n 0.5264 225749.9n 0.5264 225750.0n 0.5566 225999.9n 0.5566 226000.0n 0.6169 226249.9n 0.6169 226250.0n 0.3756 226499.9n 0.3756 226500.0n 0.5988 226749.9n 0.5988 226750.0n 0.3093 226999.9n 0.3093 227000.0n 0.3998 227249.9n 0.3998 227250.0n 0.6531 227499.9n 0.6531 227500.0n 0.5747 227749.9n 0.5747 227750.0n 0.5807 227999.9n 0.5807 228000.0n 0.3093 228249.9n 0.3093 228250.0n 0.5988 228499.9n 0.5988 228500.0n 0.4601 228749.9n 0.4601 228750.0n 0.4058 228999.9n 0.4058 229000.0n 0.3274 229249.9n 0.3274 229250.0n 0.5747 229499.9n 0.5747 229500.0n 0.5687 229749.9n 0.5687 229750.0n 0.4722 229999.9n 0.4722 230000.0n 0.5566 230249.9n 0.5566 230250.0n 0.3153 230499.9n 0.3153 230500.0n 0.5928 230749.9n 0.5928 230750.0n 0.4299 230999.9n 0.4299 231000.0n 0.3093 231249.9n 0.3093 231250.0n 0.4902 231499.9n 0.4902 231500.0n 0.4661 231749.9n 0.4661 231750.0n 0.5867 231999.9n 0.5867 232000.0n 0.5687 232249.9n 0.5687 232250.0n 0.5687 232499.9n 0.5687 232500.0n 0.4420 232749.9n 0.4420 232750.0n 0.5807 232999.9n 0.5807 233000.0n 0.5264 233249.9n 0.5264 233250.0n 0.5566 233499.9n 0.5566 233500.0n 0.6169 233749.9n 0.6169 233750.0n 0.3756 233999.9n 0.3756 234000.0n 0.5988 234249.9n 0.5988 234250.0n 0.3093 234499.9n 0.3093 234500.0n 0.3998 234749.9n 0.3998 234750.0n 0.6531 234999.9n 0.6531 235000.0n 0.5747 235249.9n 0.5747 235250.0n 0.5807 235499.9n 0.5807 235500.0n 0.3093 235749.9n 0.3093 235750.0n 0.5988 235999.9n 0.5988 236000.0n 0.4601 236249.9n 0.4601 236250.0n 0.4058 236499.9n 0.4058 236500.0n 0.3274 236749.9n 0.3274 236750.0n 0.5747 236999.9n 0.5747 237000.0n 0.5687 237249.9n 0.5687 237250.0n 0.4722 237499.9n 0.4722 237500.0n 0.5566 237749.9n 0.5566 237750.0n 0.3153 237999.9n 0.3153 238000.0n 0.5928 238249.9n 0.5928 238250.0n 0.4299 238499.9n 0.4299 238500.0n 0.3093 238749.9n 0.3093 238750.0n 0.4902 238999.9n 0.4902 239000.0n 0.4661 239249.9n 0.4661 239250.0n 0.5867 239499.9n 0.5867 239500.0n 0.5687 239749.9n 0.5687 239750.0n 0.5687 239999.9n 0.5687 240000.0n 0.4420 240249.9n 0.4420 240250.0n 0.5807 240499.9n 0.5807 240500.0n 0.5264 240749.9n 0.5264 240750.0n 0.5566 240999.9n 0.5566 241000.0n 0.6169 241249.9n 0.6169 241250.0n 0.3756 241499.9n 0.3756 241500.0n 0.5988 241749.9n 0.5988 241750.0n 0.3093 241999.9n 0.3093 242000.0n 0.3998 242249.9n 0.3998 242250.0n 0.6531 242499.9n 0.6531 242500.0n 0.5747 242749.9n 0.5747 242750.0n 0.5807 242999.9n 0.5807 243000.0n 0.3093 243249.9n 0.3093 243250.0n 0.5988 243499.9n 0.5988 243500.0n 0.4601 243749.9n 0.4601 243750.0n 0.4058 243999.9n 0.4058 244000.0n 0.3274 244249.9n 0.3274 244250.0n 0.5747 244499.9n 0.5747 244500.0n 0.5687 244749.9n 0.5687 244750.0n 0.4722 244999.9n 0.4722 245000.0n 0.5566 245249.9n 0.5566 245250.0n 0.3153 245499.9n 0.3153 245500.0n 0.5928 245749.9n 0.5928 245750.0n 0.4299 245999.9n 0.4299 246000.0n 0.3093 246249.9n 0.3093 246250.0n 0.4902 246499.9n 0.4902 246500.0n 0.4661 246749.9n 0.4661 246750.0n 0.5867 246999.9n 0.5867 247000.0n 0.5687 247249.9n 0.5687 247250.0n 0.5687 247499.9n 0.5687 247500.0n 0.4420 247749.9n 0.4420 247750.0n 0.5807 247999.9n 0.5807 248000.0n 0.5264 248249.9n 0.5264 248250.0n 0.5566 248499.9n 0.5566 248500.0n 0.6169 248749.9n 0.6169 248750.0n 0.3756 248999.9n 0.3756 249000.0n 0.5988 249249.9n 0.5988 249250.0n 0.3093 249499.9n 0.3093 249500.0n 0.3998 249749.9n 0.3998 249750.0n 0.6531 249999.9n 0.6531 250000.0n 0.5747 250249.9n 0.5747 250250.0n 0.5807 250499.9n 0.5807 250500.0n 0.3093 250749.9n 0.3093 250750.0n 0.5988 250999.9n 0.5988 251000.0n 0.4601 251249.9n 0.4601 251250.0n 0.4058 251499.9n 0.4058 251500.0n 0.3274 251749.9n 0.3274 251750.0n 0.5747 251999.9n 0.5747 252000.0n 0.5687 252249.9n 0.5687 252250.0n 0.4722 252499.9n 0.4722 252500.0n 0.5566 252749.9n 0.5566 252750.0n 0.3153 252999.9n 0.3153 253000.0n 0.5928 253249.9n 0.5928 253250.0n 0.4299 253499.9n 0.4299 253500.0n 0.3093 253749.9n 0.3093 253750.0n 0.4902 253999.9n 0.4902 254000.0n 0.4661 254249.9n 0.4661 254250.0n 0.5867 254499.9n 0.5867 254500.0n 0.5687 254749.9n 0.5687 254750.0n 0.5687 254999.9n 0.5687 255000.0n 0.4420 255249.9n 0.4420 255250.0n 0.5807 255499.9n 0.5807 255500.0n 0.5264 255749.9n 0.5264 255750.0n 0.5566 255999.9n 0.5566 256000.0n 0.6169 256249.9n 0.6169 256250.0n 0.3756 256499.9n 0.3756 256500.0n 0.5988 256749.9n 0.5988 256750.0n 0.3093 256999.9n 0.3093 257000.0n 0.3998 257249.9n 0.3998 257250.0n 0.6531 257499.9n 0.6531 257500.0n 0.5747 257749.9n 0.5747 257750.0n 0.5807 257999.9n 0.5807 258000.0n 0.3093 258249.9n 0.3093 258250.0n 0.5988 258499.9n 0.5988 258500.0n 0.4601 258749.9n 0.4601 258750.0n 0.4058 258999.9n 0.4058 259000.0n 0.3274 259249.9n 0.3274 259250.0n 0.5747 259499.9n 0.5747 259500.0n 0.5687 259749.9n 0.5687 259750.0n 0.4722 259999.9n 0.4722 260000.0n 0.5566 260249.9n 0.5566 260250.0n 0.3153 260499.9n 0.3153 260500.0n 0.5928 260749.9n 0.5928 260750.0n 0.4299 260999.9n 0.4299 261000.0n 0.3093 261249.9n 0.3093 261250.0n 0.4902 261499.9n 0.4902 261500.0n 0.4661 261749.9n 0.4661 261750.0n 0.5867 261999.9n 0.5867 262000.0n 0.5687 262249.9n 0.5687 262250.0n 0.5687 262499.9n 0.5687 262500.0n 0.4420 262749.9n 0.4420 262750.0n 0.5807 262999.9n 0.5807 263000.0n 0.5264 263249.9n 0.5264 263250.0n 0.5566 263499.9n 0.5566 263500.0n 0.6169 263749.9n 0.6169 263750.0n 0.3756 263999.9n 0.3756 264000.0n 0.5988 264249.9n 0.5988 264250.0n 0.3093 264499.9n 0.3093 264500.0n 0.3998 264749.9n 0.3998 264750.0n 0.6531 264999.9n 0.6531 265000.0n 0.5747 265249.9n 0.5747 265250.0n 0.5807 265499.9n 0.5807 265500.0n 0.3093 265749.9n 0.3093 265750.0n 0.5988 265999.9n 0.5988 266000.0n 0.4601 266249.9n 0.4601 266250.0n 0.4058 266499.9n 0.4058 266500.0n 0.3274 266749.9n 0.3274 266750.0n 0.5747 266999.9n 0.5747 267000.0n 0.5687 267249.9n 0.5687 267250.0n 0.4722 267499.9n 0.4722 267500.0n 0.5566 267749.9n 0.5566 267750.0n 0.3153 267999.9n 0.3153 268000.0n 0.5928 268249.9n 0.5928 268250.0n 0.4299 268499.9n 0.4299 268500.0n 0.3093 268749.9n 0.3093 268750.0n 0.4902 268999.9n 0.4902 269000.0n 0.4661 269249.9n 0.4661 269250.0n 0.5867 269499.9n 0.5867 269500.0n 0.5687 269749.9n 0.5687 269750.0n 0.5687 269999.9n 0.5687 270000.0n 0.4420 270249.9n 0.4420 270250.0n 0.5807 270499.9n 0.5807 270500.0n 0.5264 270749.9n 0.5264 270750.0n 0.5566 270999.9n 0.5566 271000.0n 0.6169 271249.9n 0.6169 271250.0n 0.3756 271499.9n 0.3756 271500.0n 0.5988 271749.9n 0.5988 271750.0n 0.3093 271999.9n 0.3093 272000.0n 0.3998 272249.9n 0.3998 272250.0n 0.6531 272499.9n 0.6531 272500.0n 0.5747 272749.9n 0.5747 272750.0n 0.5807 272999.9n 0.5807 273000.0n 0.3093 273249.9n 0.3093 273250.0n 0.5988 273499.9n 0.5988 273500.0n 0.4601 273749.9n 0.4601 273750.0n 0.4058 273999.9n 0.4058 274000.0n 0.3274 274249.9n 0.3274 274250.0n 0.5747 274499.9n 0.5747 274500.0n 0.5687 274749.9n 0.5687 274750.0n 0.4722 274999.9n 0.4722 275000.0n 0.5566 275249.9n 0.5566 275250.0n 0.3153 275499.9n 0.3153 275500.0n 0.5928 275749.9n 0.5928 275750.0n 0.4299 275999.9n 0.4299 276000.0n 0.3093 276249.9n 0.3093 276250.0n 0.4902 276499.9n 0.4902 276500.0n 0.4661 276749.9n 0.4661 276750.0n 0.5867 276999.9n 0.5867 277000.0n 0.5687 277249.9n 0.5687 277250.0n 0.5687 277499.9n 0.5687 277500.0n 0.4420 277749.9n 0.4420 277750.0n 0.5807 277999.9n 0.5807 278000.0n 0.5264 278249.9n 0.5264 278250.0n 0.5566 278499.9n 0.5566 278500.0n 0.6169 278749.9n 0.6169 278750.0n 0.3756 278999.9n 0.3756 279000.0n 0.5988 279249.9n 0.5988 279250.0n 0.3093 279499.9n 0.3093 279500.0n 0.3998 279749.9n 0.3998 279750.0n 0.6531 279999.9n 0.6531 280000.0n 0.5747 280249.9n 0.5747 280250.0n 0.5807 280499.9n 0.5807 280500.0n 0.3093 280749.9n 0.3093 280750.0n 0.5988 280999.9n 0.5988 281000.0n 0.4601 281249.9n 0.4601 281250.0n 0.4058 281499.9n 0.4058 281500.0n 0.3274 281749.9n 0.3274 281750.0n 0.5747 281999.9n 0.5747 282000.0n 0.5687 282249.9n 0.5687 282250.0n 0.4722 282499.9n 0.4722 282500.0n 0.5566 282749.9n 0.5566 282750.0n 0.3153 282999.9n 0.3153 283000.0n 0.5928 283249.9n 0.5928 283250.0n 0.4299 283499.9n 0.4299 283500.0n 0.3093 283749.9n 0.3093 283750.0n 0.4902 283999.9n 0.4902 284000.0n 0.4661 284249.9n 0.4661 284250.0n 0.5867 284499.9n 0.5867 284500.0n 0.5687 284749.9n 0.5687 284750.0n 0.5687 284999.9n 0.5687 285000.0n 0.4420 285249.9n 0.4420 285250.0n 0.5807 285499.9n 0.5807 285500.0n 0.5264 285749.9n 0.5264 285750.0n 0.5566 285999.9n 0.5566 286000.0n 0.6169 286249.9n 0.6169 286250.0n 0.3756 286499.9n 0.3756 286500.0n 0.5988 286749.9n 0.5988 286750.0n 0.3093 286999.9n 0.3093 287000.0n 0.3998 287249.9n 0.3998 287250.0n 0.6531 287499.9n 0.6531 287500.0n 0.5747 287749.9n 0.5747 287750.0n 0.5807 287999.9n 0.5807 288000.0n 0.3093 288249.9n 0.3093 288250.0n 0.5988 288499.9n 0.5988 288500.0n 0.4601 288749.9n 0.4601 288750.0n 0.4058 288999.9n 0.4058 289000.0n 0.3274 289249.9n 0.3274 289250.0n 0.5747 289499.9n 0.5747 289500.0n 0.5687 289749.9n 0.5687 289750.0n 0.4722 289999.9n 0.4722 290000.0n 0.5566 290249.9n 0.5566 290250.0n 0.3153 290499.9n 0.3153 290500.0n 0.5928 290749.9n 0.5928 290750.0n 0.4299 290999.9n 0.4299 291000.0n 0.3093 291249.9n 0.3093 291250.0n 0.4902 291499.9n 0.4902 291500.0n 0.4661 291749.9n 0.4661 291750.0n 0.5867 291999.9n 0.5867 292000.0n 0.5687 292249.9n 0.5687 292250.0n 0.5687 292499.9n 0.5687 292500.0n 0.4420 292749.9n 0.4420 292750.0n 0.5807 292999.9n 0.5807 293000.0n 0.5264 293249.9n 0.5264 293250.0n 0.5566 293499.9n 0.5566 293500.0n 0.6169 293749.9n 0.6169 293750.0n 0.3756 293999.9n 0.3756 294000.0n 0.5988 294249.9n 0.5988 294250.0n 0.3093 294499.9n 0.3093 294500.0n 0.3998 294749.9n 0.3998 294750.0n 0.6531 294999.9n 0.6531 295000.0n 0.5747 295249.9n 0.5747 295250.0n 0.5807 295499.9n 0.5807 295500.0n 0.3093 295749.9n 0.3093 295750.0n 0.5988 295999.9n 0.5988 296000.0n 0.4601 296249.9n 0.4601 296250.0n 0.4058 296499.9n 0.4058 296500.0n 0.3274 296749.9n 0.3274 296750.0n 0.5747 296999.9n 0.5747 297000.0n 0.5687 297249.9n 0.5687 297250.0n 0.4722 297499.9n 0.4722 297500.0n 0.5566 297749.9n 0.5566 297750.0n 0.3153 297999.9n 0.3153 298000.0n 0.5928 298249.9n 0.5928 298250.0n 0.4299 298499.9n 0.4299 298500.0n 0.3093 298749.9n 0.3093 298750.0n 0.4902 298999.9n 0.4902 299000.0n 0.4661 299249.9n 0.4661 299250.0n 0.5867 299499.9n 0.5867 299500.0n 0.5687 299749.9n 0.5687 299750.0n 0.5687)
Vxp7 a_xp7 0 PWL(0.0n 0.5602 249.9n 0.5602 250.0n 0.5759 499.9n 0.5759 500.0n 0.7170 749.9n 0.7170 750.0n 0.6073 999.9n 0.6073 1000.0n 0.5602 1249.9n 0.5602 1250.0n 0.4348 1499.9n 0.4348 1500.0n 0.6543 1749.9n 0.6543 1750.0n 0.4505 1999.9n 0.4505 2000.0n 0.4348 2249.9n 0.4348 2250.0n 0.4348 2499.9n 0.4348 2500.0n 0.4975 2749.9n 0.4975 2750.0n 0.6543 2999.9n 0.6543 3000.0n 0.5602 3249.9n 0.5602 3250.0n 0.4348 3499.9n 0.4348 3500.0n 0.4348 3749.9n 0.4348 3750.0n 0.4348 3999.9n 0.4348 4000.0n 0.4348 4249.9n 0.4348 4250.0n 0.5602 4499.9n 0.5602 4500.0n 0.5132 4749.9n 0.5132 4750.0n 0.4348 4999.9n 0.4348 5000.0n 0.5759 5249.9n 0.5759 5250.0n 0.4348 5499.9n 0.4348 5500.0n 0.6229 5749.9n 0.6229 5750.0n 0.4348 5999.9n 0.4348 6000.0n 0.5602 6249.9n 0.5602 6250.0n 0.6386 6499.9n 0.6386 6500.0n 0.4348 6749.9n 0.4348 6750.0n 0.6229 6999.9n 0.6229 7000.0n 0.6857 7249.9n 0.6857 7250.0n 0.6857 7499.9n 0.6857 7500.0n 0.5602 7749.9n 0.5602 7750.0n 0.5759 7999.9n 0.5759 8000.0n 0.7170 8249.9n 0.7170 8250.0n 0.6073 8499.9n 0.6073 8500.0n 0.5602 8749.9n 0.5602 8750.0n 0.4348 8999.9n 0.4348 9000.0n 0.6543 9249.9n 0.6543 9250.0n 0.4505 9499.9n 0.4505 9500.0n 0.4348 9749.9n 0.4348 9750.0n 0.4348 9999.9n 0.4348 10000.0n 0.4975 10249.9n 0.4975 10250.0n 0.6543 10499.9n 0.6543 10500.0n 0.5602 10749.9n 0.5602 10750.0n 0.4348 10999.9n 0.4348 11000.0n 0.4348 11249.9n 0.4348 11250.0n 0.4348 11499.9n 0.4348 11500.0n 0.4348 11749.9n 0.4348 11750.0n 0.5602 11999.9n 0.5602 12000.0n 0.5132 12249.9n 0.5132 12250.0n 0.4348 12499.9n 0.4348 12500.0n 0.5759 12749.9n 0.5759 12750.0n 0.4348 12999.9n 0.4348 13000.0n 0.6229 13249.9n 0.6229 13250.0n 0.4348 13499.9n 0.4348 13500.0n 0.5602 13749.9n 0.5602 13750.0n 0.6386 13999.9n 0.6386 14000.0n 0.4348 14249.9n 0.4348 14250.0n 0.6229 14499.9n 0.6229 14500.0n 0.6857 14749.9n 0.6857 14750.0n 0.6857 14999.9n 0.6857 15000.0n 0.5602 15249.9n 0.5602 15250.0n 0.5759 15499.9n 0.5759 15500.0n 0.7170 15749.9n 0.7170 15750.0n 0.6073 15999.9n 0.6073 16000.0n 0.5602 16249.9n 0.5602 16250.0n 0.4348 16499.9n 0.4348 16500.0n 0.6543 16749.9n 0.6543 16750.0n 0.4505 16999.9n 0.4505 17000.0n 0.4348 17249.9n 0.4348 17250.0n 0.4348 17499.9n 0.4348 17500.0n 0.4975 17749.9n 0.4975 17750.0n 0.6543 17999.9n 0.6543 18000.0n 0.5602 18249.9n 0.5602 18250.0n 0.4348 18499.9n 0.4348 18500.0n 0.4348 18749.9n 0.4348 18750.0n 0.4348 18999.9n 0.4348 19000.0n 0.4348 19249.9n 0.4348 19250.0n 0.5602 19499.9n 0.5602 19500.0n 0.5132 19749.9n 0.5132 19750.0n 0.4348 19999.9n 0.4348 20000.0n 0.5759 20249.9n 0.5759 20250.0n 0.4348 20499.9n 0.4348 20500.0n 0.6229 20749.9n 0.6229 20750.0n 0.4348 20999.9n 0.4348 21000.0n 0.5602 21249.9n 0.5602 21250.0n 0.6386 21499.9n 0.6386 21500.0n 0.4348 21749.9n 0.4348 21750.0n 0.6229 21999.9n 0.6229 22000.0n 0.6857 22249.9n 0.6857 22250.0n 0.6857 22499.9n 0.6857 22500.0n 0.5602 22749.9n 0.5602 22750.0n 0.5759 22999.9n 0.5759 23000.0n 0.7170 23249.9n 0.7170 23250.0n 0.6073 23499.9n 0.6073 23500.0n 0.5602 23749.9n 0.5602 23750.0n 0.4348 23999.9n 0.4348 24000.0n 0.6543 24249.9n 0.6543 24250.0n 0.4505 24499.9n 0.4505 24500.0n 0.4348 24749.9n 0.4348 24750.0n 0.4348 24999.9n 0.4348 25000.0n 0.4975 25249.9n 0.4975 25250.0n 0.6543 25499.9n 0.6543 25500.0n 0.5602 25749.9n 0.5602 25750.0n 0.4348 25999.9n 0.4348 26000.0n 0.4348 26249.9n 0.4348 26250.0n 0.4348 26499.9n 0.4348 26500.0n 0.4348 26749.9n 0.4348 26750.0n 0.5602 26999.9n 0.5602 27000.0n 0.5132 27249.9n 0.5132 27250.0n 0.4348 27499.9n 0.4348 27500.0n 0.5759 27749.9n 0.5759 27750.0n 0.4348 27999.9n 0.4348 28000.0n 0.6229 28249.9n 0.6229 28250.0n 0.4348 28499.9n 0.4348 28500.0n 0.5602 28749.9n 0.5602 28750.0n 0.6386 28999.9n 0.6386 29000.0n 0.4348 29249.9n 0.4348 29250.0n 0.6229 29499.9n 0.6229 29500.0n 0.6857 29749.9n 0.6857 29750.0n 0.6857 29999.9n 0.6857 30000.0n 0.5602 30249.9n 0.5602 30250.0n 0.5759 30499.9n 0.5759 30500.0n 0.7170 30749.9n 0.7170 30750.0n 0.6073 30999.9n 0.6073 31000.0n 0.5602 31249.9n 0.5602 31250.0n 0.4348 31499.9n 0.4348 31500.0n 0.6543 31749.9n 0.6543 31750.0n 0.4505 31999.9n 0.4505 32000.0n 0.4348 32249.9n 0.4348 32250.0n 0.4348 32499.9n 0.4348 32500.0n 0.4975 32749.9n 0.4975 32750.0n 0.6543 32999.9n 0.6543 33000.0n 0.5602 33249.9n 0.5602 33250.0n 0.4348 33499.9n 0.4348 33500.0n 0.4348 33749.9n 0.4348 33750.0n 0.4348 33999.9n 0.4348 34000.0n 0.4348 34249.9n 0.4348 34250.0n 0.5602 34499.9n 0.5602 34500.0n 0.5132 34749.9n 0.5132 34750.0n 0.4348 34999.9n 0.4348 35000.0n 0.5759 35249.9n 0.5759 35250.0n 0.4348 35499.9n 0.4348 35500.0n 0.6229 35749.9n 0.6229 35750.0n 0.4348 35999.9n 0.4348 36000.0n 0.5602 36249.9n 0.5602 36250.0n 0.6386 36499.9n 0.6386 36500.0n 0.4348 36749.9n 0.4348 36750.0n 0.6229 36999.9n 0.6229 37000.0n 0.6857 37249.9n 0.6857 37250.0n 0.6857 37499.9n 0.6857 37500.0n 0.5602 37749.9n 0.5602 37750.0n 0.5759 37999.9n 0.5759 38000.0n 0.7170 38249.9n 0.7170 38250.0n 0.6073 38499.9n 0.6073 38500.0n 0.5602 38749.9n 0.5602 38750.0n 0.4348 38999.9n 0.4348 39000.0n 0.6543 39249.9n 0.6543 39250.0n 0.4505 39499.9n 0.4505 39500.0n 0.4348 39749.9n 0.4348 39750.0n 0.4348 39999.9n 0.4348 40000.0n 0.4975 40249.9n 0.4975 40250.0n 0.6543 40499.9n 0.6543 40500.0n 0.5602 40749.9n 0.5602 40750.0n 0.4348 40999.9n 0.4348 41000.0n 0.4348 41249.9n 0.4348 41250.0n 0.4348 41499.9n 0.4348 41500.0n 0.4348 41749.9n 0.4348 41750.0n 0.5602 41999.9n 0.5602 42000.0n 0.5132 42249.9n 0.5132 42250.0n 0.4348 42499.9n 0.4348 42500.0n 0.5759 42749.9n 0.5759 42750.0n 0.4348 42999.9n 0.4348 43000.0n 0.6229 43249.9n 0.6229 43250.0n 0.4348 43499.9n 0.4348 43500.0n 0.5602 43749.9n 0.5602 43750.0n 0.6386 43999.9n 0.6386 44000.0n 0.4348 44249.9n 0.4348 44250.0n 0.6229 44499.9n 0.6229 44500.0n 0.6857 44749.9n 0.6857 44750.0n 0.6857 44999.9n 0.6857 45000.0n 0.5602 45249.9n 0.5602 45250.0n 0.5759 45499.9n 0.5759 45500.0n 0.7170 45749.9n 0.7170 45750.0n 0.6073 45999.9n 0.6073 46000.0n 0.5602 46249.9n 0.5602 46250.0n 0.4348 46499.9n 0.4348 46500.0n 0.6543 46749.9n 0.6543 46750.0n 0.4505 46999.9n 0.4505 47000.0n 0.4348 47249.9n 0.4348 47250.0n 0.4348 47499.9n 0.4348 47500.0n 0.4975 47749.9n 0.4975 47750.0n 0.6543 47999.9n 0.6543 48000.0n 0.5602 48249.9n 0.5602 48250.0n 0.4348 48499.9n 0.4348 48500.0n 0.4348 48749.9n 0.4348 48750.0n 0.4348 48999.9n 0.4348 49000.0n 0.4348 49249.9n 0.4348 49250.0n 0.5602 49499.9n 0.5602 49500.0n 0.5132 49749.9n 0.5132 49750.0n 0.4348 49999.9n 0.4348 50000.0n 0.5759 50249.9n 0.5759 50250.0n 0.4348 50499.9n 0.4348 50500.0n 0.6229 50749.9n 0.6229 50750.0n 0.4348 50999.9n 0.4348 51000.0n 0.5602 51249.9n 0.5602 51250.0n 0.6386 51499.9n 0.6386 51500.0n 0.4348 51749.9n 0.4348 51750.0n 0.6229 51999.9n 0.6229 52000.0n 0.6857 52249.9n 0.6857 52250.0n 0.6857 52499.9n 0.6857 52500.0n 0.5602 52749.9n 0.5602 52750.0n 0.5759 52999.9n 0.5759 53000.0n 0.7170 53249.9n 0.7170 53250.0n 0.6073 53499.9n 0.6073 53500.0n 0.5602 53749.9n 0.5602 53750.0n 0.4348 53999.9n 0.4348 54000.0n 0.6543 54249.9n 0.6543 54250.0n 0.4505 54499.9n 0.4505 54500.0n 0.4348 54749.9n 0.4348 54750.0n 0.4348 54999.9n 0.4348 55000.0n 0.4975 55249.9n 0.4975 55250.0n 0.6543 55499.9n 0.6543 55500.0n 0.5602 55749.9n 0.5602 55750.0n 0.4348 55999.9n 0.4348 56000.0n 0.4348 56249.9n 0.4348 56250.0n 0.4348 56499.9n 0.4348 56500.0n 0.4348 56749.9n 0.4348 56750.0n 0.5602 56999.9n 0.5602 57000.0n 0.5132 57249.9n 0.5132 57250.0n 0.4348 57499.9n 0.4348 57500.0n 0.5759 57749.9n 0.5759 57750.0n 0.4348 57999.9n 0.4348 58000.0n 0.6229 58249.9n 0.6229 58250.0n 0.4348 58499.9n 0.4348 58500.0n 0.5602 58749.9n 0.5602 58750.0n 0.6386 58999.9n 0.6386 59000.0n 0.4348 59249.9n 0.4348 59250.0n 0.6229 59499.9n 0.6229 59500.0n 0.6857 59749.9n 0.6857 59750.0n 0.6857 59999.9n 0.6857 60000.0n 0.5602 60249.9n 0.5602 60250.0n 0.5759 60499.9n 0.5759 60500.0n 0.7170 60749.9n 0.7170 60750.0n 0.6073 60999.9n 0.6073 61000.0n 0.5602 61249.9n 0.5602 61250.0n 0.4348 61499.9n 0.4348 61500.0n 0.6543 61749.9n 0.6543 61750.0n 0.4505 61999.9n 0.4505 62000.0n 0.4348 62249.9n 0.4348 62250.0n 0.4348 62499.9n 0.4348 62500.0n 0.4975 62749.9n 0.4975 62750.0n 0.6543 62999.9n 0.6543 63000.0n 0.5602 63249.9n 0.5602 63250.0n 0.4348 63499.9n 0.4348 63500.0n 0.4348 63749.9n 0.4348 63750.0n 0.4348 63999.9n 0.4348 64000.0n 0.4348 64249.9n 0.4348 64250.0n 0.5602 64499.9n 0.5602 64500.0n 0.5132 64749.9n 0.5132 64750.0n 0.4348 64999.9n 0.4348 65000.0n 0.5759 65249.9n 0.5759 65250.0n 0.4348 65499.9n 0.4348 65500.0n 0.6229 65749.9n 0.6229 65750.0n 0.4348 65999.9n 0.4348 66000.0n 0.5602 66249.9n 0.5602 66250.0n 0.6386 66499.9n 0.6386 66500.0n 0.4348 66749.9n 0.4348 66750.0n 0.6229 66999.9n 0.6229 67000.0n 0.6857 67249.9n 0.6857 67250.0n 0.6857 67499.9n 0.6857 67500.0n 0.5602 67749.9n 0.5602 67750.0n 0.5759 67999.9n 0.5759 68000.0n 0.7170 68249.9n 0.7170 68250.0n 0.6073 68499.9n 0.6073 68500.0n 0.5602 68749.9n 0.5602 68750.0n 0.4348 68999.9n 0.4348 69000.0n 0.6543 69249.9n 0.6543 69250.0n 0.4505 69499.9n 0.4505 69500.0n 0.4348 69749.9n 0.4348 69750.0n 0.4348 69999.9n 0.4348 70000.0n 0.4975 70249.9n 0.4975 70250.0n 0.6543 70499.9n 0.6543 70500.0n 0.5602 70749.9n 0.5602 70750.0n 0.4348 70999.9n 0.4348 71000.0n 0.4348 71249.9n 0.4348 71250.0n 0.4348 71499.9n 0.4348 71500.0n 0.4348 71749.9n 0.4348 71750.0n 0.5602 71999.9n 0.5602 72000.0n 0.5132 72249.9n 0.5132 72250.0n 0.4348 72499.9n 0.4348 72500.0n 0.5759 72749.9n 0.5759 72750.0n 0.4348 72999.9n 0.4348 73000.0n 0.6229 73249.9n 0.6229 73250.0n 0.4348 73499.9n 0.4348 73500.0n 0.5602 73749.9n 0.5602 73750.0n 0.6386 73999.9n 0.6386 74000.0n 0.4348 74249.9n 0.4348 74250.0n 0.6229 74499.9n 0.6229 74500.0n 0.6857 74749.9n 0.6857 74750.0n 0.6857 74999.9n 0.6857 75000.0n 0.5602 75249.9n 0.5602 75250.0n 0.5759 75499.9n 0.5759 75500.0n 0.7170 75749.9n 0.7170 75750.0n 0.6073 75999.9n 0.6073 76000.0n 0.5602 76249.9n 0.5602 76250.0n 0.4348 76499.9n 0.4348 76500.0n 0.6543 76749.9n 0.6543 76750.0n 0.4505 76999.9n 0.4505 77000.0n 0.4348 77249.9n 0.4348 77250.0n 0.4348 77499.9n 0.4348 77500.0n 0.4975 77749.9n 0.4975 77750.0n 0.6543 77999.9n 0.6543 78000.0n 0.5602 78249.9n 0.5602 78250.0n 0.4348 78499.9n 0.4348 78500.0n 0.4348 78749.9n 0.4348 78750.0n 0.4348 78999.9n 0.4348 79000.0n 0.4348 79249.9n 0.4348 79250.0n 0.5602 79499.9n 0.5602 79500.0n 0.5132 79749.9n 0.5132 79750.0n 0.4348 79999.9n 0.4348 80000.0n 0.5759 80249.9n 0.5759 80250.0n 0.4348 80499.9n 0.4348 80500.0n 0.6229 80749.9n 0.6229 80750.0n 0.4348 80999.9n 0.4348 81000.0n 0.5602 81249.9n 0.5602 81250.0n 0.6386 81499.9n 0.6386 81500.0n 0.4348 81749.9n 0.4348 81750.0n 0.6229 81999.9n 0.6229 82000.0n 0.6857 82249.9n 0.6857 82250.0n 0.6857 82499.9n 0.6857 82500.0n 0.5602 82749.9n 0.5602 82750.0n 0.5759 82999.9n 0.5759 83000.0n 0.7170 83249.9n 0.7170 83250.0n 0.6073 83499.9n 0.6073 83500.0n 0.5602 83749.9n 0.5602 83750.0n 0.4348 83999.9n 0.4348 84000.0n 0.6543 84249.9n 0.6543 84250.0n 0.4505 84499.9n 0.4505 84500.0n 0.4348 84749.9n 0.4348 84750.0n 0.4348 84999.9n 0.4348 85000.0n 0.4975 85249.9n 0.4975 85250.0n 0.6543 85499.9n 0.6543 85500.0n 0.5602 85749.9n 0.5602 85750.0n 0.4348 85999.9n 0.4348 86000.0n 0.4348 86249.9n 0.4348 86250.0n 0.4348 86499.9n 0.4348 86500.0n 0.4348 86749.9n 0.4348 86750.0n 0.5602 86999.9n 0.5602 87000.0n 0.5132 87249.9n 0.5132 87250.0n 0.4348 87499.9n 0.4348 87500.0n 0.5759 87749.9n 0.5759 87750.0n 0.4348 87999.9n 0.4348 88000.0n 0.6229 88249.9n 0.6229 88250.0n 0.4348 88499.9n 0.4348 88500.0n 0.5602 88749.9n 0.5602 88750.0n 0.6386 88999.9n 0.6386 89000.0n 0.4348 89249.9n 0.4348 89250.0n 0.6229 89499.9n 0.6229 89500.0n 0.6857 89749.9n 0.6857 89750.0n 0.6857 89999.9n 0.6857 90000.0n 0.5602 90249.9n 0.5602 90250.0n 0.5759 90499.9n 0.5759 90500.0n 0.7170 90749.9n 0.7170 90750.0n 0.6073 90999.9n 0.6073 91000.0n 0.5602 91249.9n 0.5602 91250.0n 0.4348 91499.9n 0.4348 91500.0n 0.6543 91749.9n 0.6543 91750.0n 0.4505 91999.9n 0.4505 92000.0n 0.4348 92249.9n 0.4348 92250.0n 0.4348 92499.9n 0.4348 92500.0n 0.4975 92749.9n 0.4975 92750.0n 0.6543 92999.9n 0.6543 93000.0n 0.5602 93249.9n 0.5602 93250.0n 0.4348 93499.9n 0.4348 93500.0n 0.4348 93749.9n 0.4348 93750.0n 0.4348 93999.9n 0.4348 94000.0n 0.4348 94249.9n 0.4348 94250.0n 0.5602 94499.9n 0.5602 94500.0n 0.5132 94749.9n 0.5132 94750.0n 0.4348 94999.9n 0.4348 95000.0n 0.5759 95249.9n 0.5759 95250.0n 0.4348 95499.9n 0.4348 95500.0n 0.6229 95749.9n 0.6229 95750.0n 0.4348 95999.9n 0.4348 96000.0n 0.5602 96249.9n 0.5602 96250.0n 0.6386 96499.9n 0.6386 96500.0n 0.4348 96749.9n 0.4348 96750.0n 0.6229 96999.9n 0.6229 97000.0n 0.6857 97249.9n 0.6857 97250.0n 0.6857 97499.9n 0.6857 97500.0n 0.5602 97749.9n 0.5602 97750.0n 0.5759 97999.9n 0.5759 98000.0n 0.7170 98249.9n 0.7170 98250.0n 0.6073 98499.9n 0.6073 98500.0n 0.5602 98749.9n 0.5602 98750.0n 0.4348 98999.9n 0.4348 99000.0n 0.6543 99249.9n 0.6543 99250.0n 0.4505 99499.9n 0.4505 99500.0n 0.4348 99749.9n 0.4348 99750.0n 0.4348 99999.9n 0.4348 100000.0n 0.4975 100249.9n 0.4975 100250.0n 0.6543 100499.9n 0.6543 100500.0n 0.5602 100749.9n 0.5602 100750.0n 0.4348 100999.9n 0.4348 101000.0n 0.4348 101249.9n 0.4348 101250.0n 0.4348 101499.9n 0.4348 101500.0n 0.4348 101749.9n 0.4348 101750.0n 0.5602 101999.9n 0.5602 102000.0n 0.5132 102249.9n 0.5132 102250.0n 0.4348 102499.9n 0.4348 102500.0n 0.5759 102749.9n 0.5759 102750.0n 0.4348 102999.9n 0.4348 103000.0n 0.6229 103249.9n 0.6229 103250.0n 0.4348 103499.9n 0.4348 103500.0n 0.5602 103749.9n 0.5602 103750.0n 0.6386 103999.9n 0.6386 104000.0n 0.4348 104249.9n 0.4348 104250.0n 0.6229 104499.9n 0.6229 104500.0n 0.6857 104749.9n 0.6857 104750.0n 0.6857 104999.9n 0.6857 105000.0n 0.5602 105249.9n 0.5602 105250.0n 0.5759 105499.9n 0.5759 105500.0n 0.7170 105749.9n 0.7170 105750.0n 0.6073 105999.9n 0.6073 106000.0n 0.5602 106249.9n 0.5602 106250.0n 0.4348 106499.9n 0.4348 106500.0n 0.6543 106749.9n 0.6543 106750.0n 0.4505 106999.9n 0.4505 107000.0n 0.4348 107249.9n 0.4348 107250.0n 0.4348 107499.9n 0.4348 107500.0n 0.4975 107749.9n 0.4975 107750.0n 0.6543 107999.9n 0.6543 108000.0n 0.5602 108249.9n 0.5602 108250.0n 0.4348 108499.9n 0.4348 108500.0n 0.4348 108749.9n 0.4348 108750.0n 0.4348 108999.9n 0.4348 109000.0n 0.4348 109249.9n 0.4348 109250.0n 0.5602 109499.9n 0.5602 109500.0n 0.5132 109749.9n 0.5132 109750.0n 0.4348 109999.9n 0.4348 110000.0n 0.5759 110249.9n 0.5759 110250.0n 0.4348 110499.9n 0.4348 110500.0n 0.6229 110749.9n 0.6229 110750.0n 0.4348 110999.9n 0.4348 111000.0n 0.5602 111249.9n 0.5602 111250.0n 0.6386 111499.9n 0.6386 111500.0n 0.4348 111749.9n 0.4348 111750.0n 0.6229 111999.9n 0.6229 112000.0n 0.6857 112249.9n 0.6857 112250.0n 0.6857 112499.9n 0.6857 112500.0n 0.5602 112749.9n 0.5602 112750.0n 0.5759 112999.9n 0.5759 113000.0n 0.7170 113249.9n 0.7170 113250.0n 0.6073 113499.9n 0.6073 113500.0n 0.5602 113749.9n 0.5602 113750.0n 0.4348 113999.9n 0.4348 114000.0n 0.6543 114249.9n 0.6543 114250.0n 0.4505 114499.9n 0.4505 114500.0n 0.4348 114749.9n 0.4348 114750.0n 0.4348 114999.9n 0.4348 115000.0n 0.4975 115249.9n 0.4975 115250.0n 0.6543 115499.9n 0.6543 115500.0n 0.5602 115749.9n 0.5602 115750.0n 0.4348 115999.9n 0.4348 116000.0n 0.4348 116249.9n 0.4348 116250.0n 0.4348 116499.9n 0.4348 116500.0n 0.4348 116749.9n 0.4348 116750.0n 0.5602 116999.9n 0.5602 117000.0n 0.5132 117249.9n 0.5132 117250.0n 0.4348 117499.9n 0.4348 117500.0n 0.5759 117749.9n 0.5759 117750.0n 0.4348 117999.9n 0.4348 118000.0n 0.6229 118249.9n 0.6229 118250.0n 0.4348 118499.9n 0.4348 118500.0n 0.5602 118749.9n 0.5602 118750.0n 0.6386 118999.9n 0.6386 119000.0n 0.4348 119249.9n 0.4348 119250.0n 0.6229 119499.9n 0.6229 119500.0n 0.6857 119749.9n 0.6857 119750.0n 0.6857 119999.9n 0.6857 120000.0n 0.5602 120249.9n 0.5602 120250.0n 0.5759 120499.9n 0.5759 120500.0n 0.7170 120749.9n 0.7170 120750.0n 0.6073 120999.9n 0.6073 121000.0n 0.5602 121249.9n 0.5602 121250.0n 0.4348 121499.9n 0.4348 121500.0n 0.6543 121749.9n 0.6543 121750.0n 0.4505 121999.9n 0.4505 122000.0n 0.4348 122249.9n 0.4348 122250.0n 0.4348 122499.9n 0.4348 122500.0n 0.4975 122749.9n 0.4975 122750.0n 0.6543 122999.9n 0.6543 123000.0n 0.5602 123249.9n 0.5602 123250.0n 0.4348 123499.9n 0.4348 123500.0n 0.4348 123749.9n 0.4348 123750.0n 0.4348 123999.9n 0.4348 124000.0n 0.4348 124249.9n 0.4348 124250.0n 0.5602 124499.9n 0.5602 124500.0n 0.5132 124749.9n 0.5132 124750.0n 0.4348 124999.9n 0.4348 125000.0n 0.5759 125249.9n 0.5759 125250.0n 0.4348 125499.9n 0.4348 125500.0n 0.6229 125749.9n 0.6229 125750.0n 0.4348 125999.9n 0.4348 126000.0n 0.5602 126249.9n 0.5602 126250.0n 0.6386 126499.9n 0.6386 126500.0n 0.4348 126749.9n 0.4348 126750.0n 0.6229 126999.9n 0.6229 127000.0n 0.6857 127249.9n 0.6857 127250.0n 0.6857 127499.9n 0.6857 127500.0n 0.5602 127749.9n 0.5602 127750.0n 0.5759 127999.9n 0.5759 128000.0n 0.7170 128249.9n 0.7170 128250.0n 0.6073 128499.9n 0.6073 128500.0n 0.5602 128749.9n 0.5602 128750.0n 0.4348 128999.9n 0.4348 129000.0n 0.6543 129249.9n 0.6543 129250.0n 0.4505 129499.9n 0.4505 129500.0n 0.4348 129749.9n 0.4348 129750.0n 0.4348 129999.9n 0.4348 130000.0n 0.4975 130249.9n 0.4975 130250.0n 0.6543 130499.9n 0.6543 130500.0n 0.5602 130749.9n 0.5602 130750.0n 0.4348 130999.9n 0.4348 131000.0n 0.4348 131249.9n 0.4348 131250.0n 0.4348 131499.9n 0.4348 131500.0n 0.4348 131749.9n 0.4348 131750.0n 0.5602 131999.9n 0.5602 132000.0n 0.5132 132249.9n 0.5132 132250.0n 0.4348 132499.9n 0.4348 132500.0n 0.5759 132749.9n 0.5759 132750.0n 0.4348 132999.9n 0.4348 133000.0n 0.6229 133249.9n 0.6229 133250.0n 0.4348 133499.9n 0.4348 133500.0n 0.5602 133749.9n 0.5602 133750.0n 0.6386 133999.9n 0.6386 134000.0n 0.4348 134249.9n 0.4348 134250.0n 0.6229 134499.9n 0.6229 134500.0n 0.6857 134749.9n 0.6857 134750.0n 0.6857 134999.9n 0.6857 135000.0n 0.5602 135249.9n 0.5602 135250.0n 0.5759 135499.9n 0.5759 135500.0n 0.7170 135749.9n 0.7170 135750.0n 0.6073 135999.9n 0.6073 136000.0n 0.5602 136249.9n 0.5602 136250.0n 0.4348 136499.9n 0.4348 136500.0n 0.6543 136749.9n 0.6543 136750.0n 0.4505 136999.9n 0.4505 137000.0n 0.4348 137249.9n 0.4348 137250.0n 0.4348 137499.9n 0.4348 137500.0n 0.4975 137749.9n 0.4975 137750.0n 0.6543 137999.9n 0.6543 138000.0n 0.5602 138249.9n 0.5602 138250.0n 0.4348 138499.9n 0.4348 138500.0n 0.4348 138749.9n 0.4348 138750.0n 0.4348 138999.9n 0.4348 139000.0n 0.4348 139249.9n 0.4348 139250.0n 0.5602 139499.9n 0.5602 139500.0n 0.5132 139749.9n 0.5132 139750.0n 0.4348 139999.9n 0.4348 140000.0n 0.5759 140249.9n 0.5759 140250.0n 0.4348 140499.9n 0.4348 140500.0n 0.6229 140749.9n 0.6229 140750.0n 0.4348 140999.9n 0.4348 141000.0n 0.5602 141249.9n 0.5602 141250.0n 0.6386 141499.9n 0.6386 141500.0n 0.4348 141749.9n 0.4348 141750.0n 0.6229 141999.9n 0.6229 142000.0n 0.6857 142249.9n 0.6857 142250.0n 0.6857 142499.9n 0.6857 142500.0n 0.5602 142749.9n 0.5602 142750.0n 0.5759 142999.9n 0.5759 143000.0n 0.7170 143249.9n 0.7170 143250.0n 0.6073 143499.9n 0.6073 143500.0n 0.5602 143749.9n 0.5602 143750.0n 0.4348 143999.9n 0.4348 144000.0n 0.6543 144249.9n 0.6543 144250.0n 0.4505 144499.9n 0.4505 144500.0n 0.4348 144749.9n 0.4348 144750.0n 0.4348 144999.9n 0.4348 145000.0n 0.4975 145249.9n 0.4975 145250.0n 0.6543 145499.9n 0.6543 145500.0n 0.5602 145749.9n 0.5602 145750.0n 0.4348 145999.9n 0.4348 146000.0n 0.4348 146249.9n 0.4348 146250.0n 0.4348 146499.9n 0.4348 146500.0n 0.4348 146749.9n 0.4348 146750.0n 0.5602 146999.9n 0.5602 147000.0n 0.5132 147249.9n 0.5132 147250.0n 0.4348 147499.9n 0.4348 147500.0n 0.5759 147749.9n 0.5759 147750.0n 0.4348 147999.9n 0.4348 148000.0n 0.6229 148249.9n 0.6229 148250.0n 0.4348 148499.9n 0.4348 148500.0n 0.5602 148749.9n 0.5602 148750.0n 0.6386 148999.9n 0.6386 149000.0n 0.4348 149249.9n 0.4348 149250.0n 0.6229 149499.9n 0.6229 149500.0n 0.6857 149749.9n 0.6857 149750.0n 0.6857 149999.9n 0.6857 150000.0n 0.5602 150249.9n 0.5602 150250.0n 0.5759 150499.9n 0.5759 150500.0n 0.7170 150749.9n 0.7170 150750.0n 0.6073 150999.9n 0.6073 151000.0n 0.5602 151249.9n 0.5602 151250.0n 0.4348 151499.9n 0.4348 151500.0n 0.6543 151749.9n 0.6543 151750.0n 0.4505 151999.9n 0.4505 152000.0n 0.4348 152249.9n 0.4348 152250.0n 0.4348 152499.9n 0.4348 152500.0n 0.4975 152749.9n 0.4975 152750.0n 0.6543 152999.9n 0.6543 153000.0n 0.5602 153249.9n 0.5602 153250.0n 0.4348 153499.9n 0.4348 153500.0n 0.4348 153749.9n 0.4348 153750.0n 0.4348 153999.9n 0.4348 154000.0n 0.4348 154249.9n 0.4348 154250.0n 0.5602 154499.9n 0.5602 154500.0n 0.5132 154749.9n 0.5132 154750.0n 0.4348 154999.9n 0.4348 155000.0n 0.5759 155249.9n 0.5759 155250.0n 0.4348 155499.9n 0.4348 155500.0n 0.6229 155749.9n 0.6229 155750.0n 0.4348 155999.9n 0.4348 156000.0n 0.5602 156249.9n 0.5602 156250.0n 0.6386 156499.9n 0.6386 156500.0n 0.4348 156749.9n 0.4348 156750.0n 0.6229 156999.9n 0.6229 157000.0n 0.6857 157249.9n 0.6857 157250.0n 0.6857 157499.9n 0.6857 157500.0n 0.5602 157749.9n 0.5602 157750.0n 0.5759 157999.9n 0.5759 158000.0n 0.7170 158249.9n 0.7170 158250.0n 0.6073 158499.9n 0.6073 158500.0n 0.5602 158749.9n 0.5602 158750.0n 0.4348 158999.9n 0.4348 159000.0n 0.6543 159249.9n 0.6543 159250.0n 0.4505 159499.9n 0.4505 159500.0n 0.4348 159749.9n 0.4348 159750.0n 0.4348 159999.9n 0.4348 160000.0n 0.4975 160249.9n 0.4975 160250.0n 0.6543 160499.9n 0.6543 160500.0n 0.5602 160749.9n 0.5602 160750.0n 0.4348 160999.9n 0.4348 161000.0n 0.4348 161249.9n 0.4348 161250.0n 0.4348 161499.9n 0.4348 161500.0n 0.4348 161749.9n 0.4348 161750.0n 0.5602 161999.9n 0.5602 162000.0n 0.5132 162249.9n 0.5132 162250.0n 0.4348 162499.9n 0.4348 162500.0n 0.5759 162749.9n 0.5759 162750.0n 0.4348 162999.9n 0.4348 163000.0n 0.6229 163249.9n 0.6229 163250.0n 0.4348 163499.9n 0.4348 163500.0n 0.5602 163749.9n 0.5602 163750.0n 0.6386 163999.9n 0.6386 164000.0n 0.4348 164249.9n 0.4348 164250.0n 0.6229 164499.9n 0.6229 164500.0n 0.6857 164749.9n 0.6857 164750.0n 0.6857 164999.9n 0.6857 165000.0n 0.5602 165249.9n 0.5602 165250.0n 0.5759 165499.9n 0.5759 165500.0n 0.7170 165749.9n 0.7170 165750.0n 0.6073 165999.9n 0.6073 166000.0n 0.5602 166249.9n 0.5602 166250.0n 0.4348 166499.9n 0.4348 166500.0n 0.6543 166749.9n 0.6543 166750.0n 0.4505 166999.9n 0.4505 167000.0n 0.4348 167249.9n 0.4348 167250.0n 0.4348 167499.9n 0.4348 167500.0n 0.4975 167749.9n 0.4975 167750.0n 0.6543 167999.9n 0.6543 168000.0n 0.5602 168249.9n 0.5602 168250.0n 0.4348 168499.9n 0.4348 168500.0n 0.4348 168749.9n 0.4348 168750.0n 0.4348 168999.9n 0.4348 169000.0n 0.4348 169249.9n 0.4348 169250.0n 0.5602 169499.9n 0.5602 169500.0n 0.5132 169749.9n 0.5132 169750.0n 0.4348 169999.9n 0.4348 170000.0n 0.5759 170249.9n 0.5759 170250.0n 0.4348 170499.9n 0.4348 170500.0n 0.6229 170749.9n 0.6229 170750.0n 0.4348 170999.9n 0.4348 171000.0n 0.5602 171249.9n 0.5602 171250.0n 0.6386 171499.9n 0.6386 171500.0n 0.4348 171749.9n 0.4348 171750.0n 0.6229 171999.9n 0.6229 172000.0n 0.6857 172249.9n 0.6857 172250.0n 0.6857 172499.9n 0.6857 172500.0n 0.5602 172749.9n 0.5602 172750.0n 0.5759 172999.9n 0.5759 173000.0n 0.7170 173249.9n 0.7170 173250.0n 0.6073 173499.9n 0.6073 173500.0n 0.5602 173749.9n 0.5602 173750.0n 0.4348 173999.9n 0.4348 174000.0n 0.6543 174249.9n 0.6543 174250.0n 0.4505 174499.9n 0.4505 174500.0n 0.4348 174749.9n 0.4348 174750.0n 0.4348 174999.9n 0.4348 175000.0n 0.4975 175249.9n 0.4975 175250.0n 0.6543 175499.9n 0.6543 175500.0n 0.5602 175749.9n 0.5602 175750.0n 0.4348 175999.9n 0.4348 176000.0n 0.4348 176249.9n 0.4348 176250.0n 0.4348 176499.9n 0.4348 176500.0n 0.4348 176749.9n 0.4348 176750.0n 0.5602 176999.9n 0.5602 177000.0n 0.5132 177249.9n 0.5132 177250.0n 0.4348 177499.9n 0.4348 177500.0n 0.5759 177749.9n 0.5759 177750.0n 0.4348 177999.9n 0.4348 178000.0n 0.6229 178249.9n 0.6229 178250.0n 0.4348 178499.9n 0.4348 178500.0n 0.5602 178749.9n 0.5602 178750.0n 0.6386 178999.9n 0.6386 179000.0n 0.4348 179249.9n 0.4348 179250.0n 0.6229 179499.9n 0.6229 179500.0n 0.6857 179749.9n 0.6857 179750.0n 0.6857 179999.9n 0.6857 180000.0n 0.5602 180249.9n 0.5602 180250.0n 0.5759 180499.9n 0.5759 180500.0n 0.7170 180749.9n 0.7170 180750.0n 0.6073 180999.9n 0.6073 181000.0n 0.5602 181249.9n 0.5602 181250.0n 0.4348 181499.9n 0.4348 181500.0n 0.6543 181749.9n 0.6543 181750.0n 0.4505 181999.9n 0.4505 182000.0n 0.4348 182249.9n 0.4348 182250.0n 0.4348 182499.9n 0.4348 182500.0n 0.4975 182749.9n 0.4975 182750.0n 0.6543 182999.9n 0.6543 183000.0n 0.5602 183249.9n 0.5602 183250.0n 0.4348 183499.9n 0.4348 183500.0n 0.4348 183749.9n 0.4348 183750.0n 0.4348 183999.9n 0.4348 184000.0n 0.4348 184249.9n 0.4348 184250.0n 0.5602 184499.9n 0.5602 184500.0n 0.5132 184749.9n 0.5132 184750.0n 0.4348 184999.9n 0.4348 185000.0n 0.5759 185249.9n 0.5759 185250.0n 0.4348 185499.9n 0.4348 185500.0n 0.6229 185749.9n 0.6229 185750.0n 0.4348 185999.9n 0.4348 186000.0n 0.5602 186249.9n 0.5602 186250.0n 0.6386 186499.9n 0.6386 186500.0n 0.4348 186749.9n 0.4348 186750.0n 0.6229 186999.9n 0.6229 187000.0n 0.6857 187249.9n 0.6857 187250.0n 0.6857 187499.9n 0.6857 187500.0n 0.5602 187749.9n 0.5602 187750.0n 0.5759 187999.9n 0.5759 188000.0n 0.7170 188249.9n 0.7170 188250.0n 0.6073 188499.9n 0.6073 188500.0n 0.5602 188749.9n 0.5602 188750.0n 0.4348 188999.9n 0.4348 189000.0n 0.6543 189249.9n 0.6543 189250.0n 0.4505 189499.9n 0.4505 189500.0n 0.4348 189749.9n 0.4348 189750.0n 0.4348 189999.9n 0.4348 190000.0n 0.4975 190249.9n 0.4975 190250.0n 0.6543 190499.9n 0.6543 190500.0n 0.5602 190749.9n 0.5602 190750.0n 0.4348 190999.9n 0.4348 191000.0n 0.4348 191249.9n 0.4348 191250.0n 0.4348 191499.9n 0.4348 191500.0n 0.4348 191749.9n 0.4348 191750.0n 0.5602 191999.9n 0.5602 192000.0n 0.5132 192249.9n 0.5132 192250.0n 0.4348 192499.9n 0.4348 192500.0n 0.5759 192749.9n 0.5759 192750.0n 0.4348 192999.9n 0.4348 193000.0n 0.6229 193249.9n 0.6229 193250.0n 0.4348 193499.9n 0.4348 193500.0n 0.5602 193749.9n 0.5602 193750.0n 0.6386 193999.9n 0.6386 194000.0n 0.4348 194249.9n 0.4348 194250.0n 0.6229 194499.9n 0.6229 194500.0n 0.6857 194749.9n 0.6857 194750.0n 0.6857 194999.9n 0.6857 195000.0n 0.5602 195249.9n 0.5602 195250.0n 0.5759 195499.9n 0.5759 195500.0n 0.7170 195749.9n 0.7170 195750.0n 0.6073 195999.9n 0.6073 196000.0n 0.5602 196249.9n 0.5602 196250.0n 0.4348 196499.9n 0.4348 196500.0n 0.6543 196749.9n 0.6543 196750.0n 0.4505 196999.9n 0.4505 197000.0n 0.4348 197249.9n 0.4348 197250.0n 0.4348 197499.9n 0.4348 197500.0n 0.4975 197749.9n 0.4975 197750.0n 0.6543 197999.9n 0.6543 198000.0n 0.5602 198249.9n 0.5602 198250.0n 0.4348 198499.9n 0.4348 198500.0n 0.4348 198749.9n 0.4348 198750.0n 0.4348 198999.9n 0.4348 199000.0n 0.4348 199249.9n 0.4348 199250.0n 0.5602 199499.9n 0.5602 199500.0n 0.5132 199749.9n 0.5132 199750.0n 0.4348 199999.9n 0.4348 200000.0n 0.5759 200249.9n 0.5759 200250.0n 0.4348 200499.9n 0.4348 200500.0n 0.6229 200749.9n 0.6229 200750.0n 0.4348 200999.9n 0.4348 201000.0n 0.5602 201249.9n 0.5602 201250.0n 0.6386 201499.9n 0.6386 201500.0n 0.4348 201749.9n 0.4348 201750.0n 0.6229 201999.9n 0.6229 202000.0n 0.6857 202249.9n 0.6857 202250.0n 0.6857 202499.9n 0.6857 202500.0n 0.5602 202749.9n 0.5602 202750.0n 0.5759 202999.9n 0.5759 203000.0n 0.7170 203249.9n 0.7170 203250.0n 0.6073 203499.9n 0.6073 203500.0n 0.5602 203749.9n 0.5602 203750.0n 0.4348 203999.9n 0.4348 204000.0n 0.6543 204249.9n 0.6543 204250.0n 0.4505 204499.9n 0.4505 204500.0n 0.4348 204749.9n 0.4348 204750.0n 0.4348 204999.9n 0.4348 205000.0n 0.4975 205249.9n 0.4975 205250.0n 0.6543 205499.9n 0.6543 205500.0n 0.5602 205749.9n 0.5602 205750.0n 0.4348 205999.9n 0.4348 206000.0n 0.4348 206249.9n 0.4348 206250.0n 0.4348 206499.9n 0.4348 206500.0n 0.4348 206749.9n 0.4348 206750.0n 0.5602 206999.9n 0.5602 207000.0n 0.5132 207249.9n 0.5132 207250.0n 0.4348 207499.9n 0.4348 207500.0n 0.5759 207749.9n 0.5759 207750.0n 0.4348 207999.9n 0.4348 208000.0n 0.6229 208249.9n 0.6229 208250.0n 0.4348 208499.9n 0.4348 208500.0n 0.5602 208749.9n 0.5602 208750.0n 0.6386 208999.9n 0.6386 209000.0n 0.4348 209249.9n 0.4348 209250.0n 0.6229 209499.9n 0.6229 209500.0n 0.6857 209749.9n 0.6857 209750.0n 0.6857 209999.9n 0.6857 210000.0n 0.5602 210249.9n 0.5602 210250.0n 0.5759 210499.9n 0.5759 210500.0n 0.7170 210749.9n 0.7170 210750.0n 0.6073 210999.9n 0.6073 211000.0n 0.5602 211249.9n 0.5602 211250.0n 0.4348 211499.9n 0.4348 211500.0n 0.6543 211749.9n 0.6543 211750.0n 0.4505 211999.9n 0.4505 212000.0n 0.4348 212249.9n 0.4348 212250.0n 0.4348 212499.9n 0.4348 212500.0n 0.4975 212749.9n 0.4975 212750.0n 0.6543 212999.9n 0.6543 213000.0n 0.5602 213249.9n 0.5602 213250.0n 0.4348 213499.9n 0.4348 213500.0n 0.4348 213749.9n 0.4348 213750.0n 0.4348 213999.9n 0.4348 214000.0n 0.4348 214249.9n 0.4348 214250.0n 0.5602 214499.9n 0.5602 214500.0n 0.5132 214749.9n 0.5132 214750.0n 0.4348 214999.9n 0.4348 215000.0n 0.5759 215249.9n 0.5759 215250.0n 0.4348 215499.9n 0.4348 215500.0n 0.6229 215749.9n 0.6229 215750.0n 0.4348 215999.9n 0.4348 216000.0n 0.5602 216249.9n 0.5602 216250.0n 0.6386 216499.9n 0.6386 216500.0n 0.4348 216749.9n 0.4348 216750.0n 0.6229 216999.9n 0.6229 217000.0n 0.6857 217249.9n 0.6857 217250.0n 0.6857 217499.9n 0.6857 217500.0n 0.5602 217749.9n 0.5602 217750.0n 0.5759 217999.9n 0.5759 218000.0n 0.7170 218249.9n 0.7170 218250.0n 0.6073 218499.9n 0.6073 218500.0n 0.5602 218749.9n 0.5602 218750.0n 0.4348 218999.9n 0.4348 219000.0n 0.6543 219249.9n 0.6543 219250.0n 0.4505 219499.9n 0.4505 219500.0n 0.4348 219749.9n 0.4348 219750.0n 0.4348 219999.9n 0.4348 220000.0n 0.4975 220249.9n 0.4975 220250.0n 0.6543 220499.9n 0.6543 220500.0n 0.5602 220749.9n 0.5602 220750.0n 0.4348 220999.9n 0.4348 221000.0n 0.4348 221249.9n 0.4348 221250.0n 0.4348 221499.9n 0.4348 221500.0n 0.4348 221749.9n 0.4348 221750.0n 0.5602 221999.9n 0.5602 222000.0n 0.5132 222249.9n 0.5132 222250.0n 0.4348 222499.9n 0.4348 222500.0n 0.5759 222749.9n 0.5759 222750.0n 0.4348 222999.9n 0.4348 223000.0n 0.6229 223249.9n 0.6229 223250.0n 0.4348 223499.9n 0.4348 223500.0n 0.5602 223749.9n 0.5602 223750.0n 0.6386 223999.9n 0.6386 224000.0n 0.4348 224249.9n 0.4348 224250.0n 0.6229 224499.9n 0.6229 224500.0n 0.6857 224749.9n 0.6857 224750.0n 0.6857 224999.9n 0.6857 225000.0n 0.5602 225249.9n 0.5602 225250.0n 0.5759 225499.9n 0.5759 225500.0n 0.7170 225749.9n 0.7170 225750.0n 0.6073 225999.9n 0.6073 226000.0n 0.5602 226249.9n 0.5602 226250.0n 0.4348 226499.9n 0.4348 226500.0n 0.6543 226749.9n 0.6543 226750.0n 0.4505 226999.9n 0.4505 227000.0n 0.4348 227249.9n 0.4348 227250.0n 0.4348 227499.9n 0.4348 227500.0n 0.4975 227749.9n 0.4975 227750.0n 0.6543 227999.9n 0.6543 228000.0n 0.5602 228249.9n 0.5602 228250.0n 0.4348 228499.9n 0.4348 228500.0n 0.4348 228749.9n 0.4348 228750.0n 0.4348 228999.9n 0.4348 229000.0n 0.4348 229249.9n 0.4348 229250.0n 0.5602 229499.9n 0.5602 229500.0n 0.5132 229749.9n 0.5132 229750.0n 0.4348 229999.9n 0.4348 230000.0n 0.5759 230249.9n 0.5759 230250.0n 0.4348 230499.9n 0.4348 230500.0n 0.6229 230749.9n 0.6229 230750.0n 0.4348 230999.9n 0.4348 231000.0n 0.5602 231249.9n 0.5602 231250.0n 0.6386 231499.9n 0.6386 231500.0n 0.4348 231749.9n 0.4348 231750.0n 0.6229 231999.9n 0.6229 232000.0n 0.6857 232249.9n 0.6857 232250.0n 0.6857 232499.9n 0.6857 232500.0n 0.5602 232749.9n 0.5602 232750.0n 0.5759 232999.9n 0.5759 233000.0n 0.7170 233249.9n 0.7170 233250.0n 0.6073 233499.9n 0.6073 233500.0n 0.5602 233749.9n 0.5602 233750.0n 0.4348 233999.9n 0.4348 234000.0n 0.6543 234249.9n 0.6543 234250.0n 0.4505 234499.9n 0.4505 234500.0n 0.4348 234749.9n 0.4348 234750.0n 0.4348 234999.9n 0.4348 235000.0n 0.4975 235249.9n 0.4975 235250.0n 0.6543 235499.9n 0.6543 235500.0n 0.5602 235749.9n 0.5602 235750.0n 0.4348 235999.9n 0.4348 236000.0n 0.4348 236249.9n 0.4348 236250.0n 0.4348 236499.9n 0.4348 236500.0n 0.4348 236749.9n 0.4348 236750.0n 0.5602 236999.9n 0.5602 237000.0n 0.5132 237249.9n 0.5132 237250.0n 0.4348 237499.9n 0.4348 237500.0n 0.5759 237749.9n 0.5759 237750.0n 0.4348 237999.9n 0.4348 238000.0n 0.6229 238249.9n 0.6229 238250.0n 0.4348 238499.9n 0.4348 238500.0n 0.5602 238749.9n 0.5602 238750.0n 0.6386 238999.9n 0.6386 239000.0n 0.4348 239249.9n 0.4348 239250.0n 0.6229 239499.9n 0.6229 239500.0n 0.6857 239749.9n 0.6857 239750.0n 0.6857 239999.9n 0.6857 240000.0n 0.5602 240249.9n 0.5602 240250.0n 0.5759 240499.9n 0.5759 240500.0n 0.7170 240749.9n 0.7170 240750.0n 0.6073 240999.9n 0.6073 241000.0n 0.5602 241249.9n 0.5602 241250.0n 0.4348 241499.9n 0.4348 241500.0n 0.6543 241749.9n 0.6543 241750.0n 0.4505 241999.9n 0.4505 242000.0n 0.4348 242249.9n 0.4348 242250.0n 0.4348 242499.9n 0.4348 242500.0n 0.4975 242749.9n 0.4975 242750.0n 0.6543 242999.9n 0.6543 243000.0n 0.5602 243249.9n 0.5602 243250.0n 0.4348 243499.9n 0.4348 243500.0n 0.4348 243749.9n 0.4348 243750.0n 0.4348 243999.9n 0.4348 244000.0n 0.4348 244249.9n 0.4348 244250.0n 0.5602 244499.9n 0.5602 244500.0n 0.5132 244749.9n 0.5132 244750.0n 0.4348 244999.9n 0.4348 245000.0n 0.5759 245249.9n 0.5759 245250.0n 0.4348 245499.9n 0.4348 245500.0n 0.6229 245749.9n 0.6229 245750.0n 0.4348 245999.9n 0.4348 246000.0n 0.5602 246249.9n 0.5602 246250.0n 0.6386 246499.9n 0.6386 246500.0n 0.4348 246749.9n 0.4348 246750.0n 0.6229 246999.9n 0.6229 247000.0n 0.6857 247249.9n 0.6857 247250.0n 0.6857 247499.9n 0.6857 247500.0n 0.5602 247749.9n 0.5602 247750.0n 0.5759 247999.9n 0.5759 248000.0n 0.7170 248249.9n 0.7170 248250.0n 0.6073 248499.9n 0.6073 248500.0n 0.5602 248749.9n 0.5602 248750.0n 0.4348 248999.9n 0.4348 249000.0n 0.6543 249249.9n 0.6543 249250.0n 0.4505 249499.9n 0.4505 249500.0n 0.4348 249749.9n 0.4348 249750.0n 0.4348 249999.9n 0.4348 250000.0n 0.4975 250249.9n 0.4975 250250.0n 0.6543 250499.9n 0.6543 250500.0n 0.5602 250749.9n 0.5602 250750.0n 0.4348 250999.9n 0.4348 251000.0n 0.4348 251249.9n 0.4348 251250.0n 0.4348 251499.9n 0.4348 251500.0n 0.4348 251749.9n 0.4348 251750.0n 0.5602 251999.9n 0.5602 252000.0n 0.5132 252249.9n 0.5132 252250.0n 0.4348 252499.9n 0.4348 252500.0n 0.5759 252749.9n 0.5759 252750.0n 0.4348 252999.9n 0.4348 253000.0n 0.6229 253249.9n 0.6229 253250.0n 0.4348 253499.9n 0.4348 253500.0n 0.5602 253749.9n 0.5602 253750.0n 0.6386 253999.9n 0.6386 254000.0n 0.4348 254249.9n 0.4348 254250.0n 0.6229 254499.9n 0.6229 254500.0n 0.6857 254749.9n 0.6857 254750.0n 0.6857 254999.9n 0.6857 255000.0n 0.5602 255249.9n 0.5602 255250.0n 0.5759 255499.9n 0.5759 255500.0n 0.7170 255749.9n 0.7170 255750.0n 0.6073 255999.9n 0.6073 256000.0n 0.5602 256249.9n 0.5602 256250.0n 0.4348 256499.9n 0.4348 256500.0n 0.6543 256749.9n 0.6543 256750.0n 0.4505 256999.9n 0.4505 257000.0n 0.4348 257249.9n 0.4348 257250.0n 0.4348 257499.9n 0.4348 257500.0n 0.4975 257749.9n 0.4975 257750.0n 0.6543 257999.9n 0.6543 258000.0n 0.5602 258249.9n 0.5602 258250.0n 0.4348 258499.9n 0.4348 258500.0n 0.4348 258749.9n 0.4348 258750.0n 0.4348 258999.9n 0.4348 259000.0n 0.4348 259249.9n 0.4348 259250.0n 0.5602 259499.9n 0.5602 259500.0n 0.5132 259749.9n 0.5132 259750.0n 0.4348 259999.9n 0.4348 260000.0n 0.5759 260249.9n 0.5759 260250.0n 0.4348 260499.9n 0.4348 260500.0n 0.6229 260749.9n 0.6229 260750.0n 0.4348 260999.9n 0.4348 261000.0n 0.5602 261249.9n 0.5602 261250.0n 0.6386 261499.9n 0.6386 261500.0n 0.4348 261749.9n 0.4348 261750.0n 0.6229 261999.9n 0.6229 262000.0n 0.6857 262249.9n 0.6857 262250.0n 0.6857 262499.9n 0.6857 262500.0n 0.5602 262749.9n 0.5602 262750.0n 0.5759 262999.9n 0.5759 263000.0n 0.7170 263249.9n 0.7170 263250.0n 0.6073 263499.9n 0.6073 263500.0n 0.5602 263749.9n 0.5602 263750.0n 0.4348 263999.9n 0.4348 264000.0n 0.6543 264249.9n 0.6543 264250.0n 0.4505 264499.9n 0.4505 264500.0n 0.4348 264749.9n 0.4348 264750.0n 0.4348 264999.9n 0.4348 265000.0n 0.4975 265249.9n 0.4975 265250.0n 0.6543 265499.9n 0.6543 265500.0n 0.5602 265749.9n 0.5602 265750.0n 0.4348 265999.9n 0.4348 266000.0n 0.4348 266249.9n 0.4348 266250.0n 0.4348 266499.9n 0.4348 266500.0n 0.4348 266749.9n 0.4348 266750.0n 0.5602 266999.9n 0.5602 267000.0n 0.5132 267249.9n 0.5132 267250.0n 0.4348 267499.9n 0.4348 267500.0n 0.5759 267749.9n 0.5759 267750.0n 0.4348 267999.9n 0.4348 268000.0n 0.6229 268249.9n 0.6229 268250.0n 0.4348 268499.9n 0.4348 268500.0n 0.5602 268749.9n 0.5602 268750.0n 0.6386 268999.9n 0.6386 269000.0n 0.4348 269249.9n 0.4348 269250.0n 0.6229 269499.9n 0.6229 269500.0n 0.6857 269749.9n 0.6857 269750.0n 0.6857 269999.9n 0.6857 270000.0n 0.5602 270249.9n 0.5602 270250.0n 0.5759 270499.9n 0.5759 270500.0n 0.7170 270749.9n 0.7170 270750.0n 0.6073 270999.9n 0.6073 271000.0n 0.5602 271249.9n 0.5602 271250.0n 0.4348 271499.9n 0.4348 271500.0n 0.6543 271749.9n 0.6543 271750.0n 0.4505 271999.9n 0.4505 272000.0n 0.4348 272249.9n 0.4348 272250.0n 0.4348 272499.9n 0.4348 272500.0n 0.4975 272749.9n 0.4975 272750.0n 0.6543 272999.9n 0.6543 273000.0n 0.5602 273249.9n 0.5602 273250.0n 0.4348 273499.9n 0.4348 273500.0n 0.4348 273749.9n 0.4348 273750.0n 0.4348 273999.9n 0.4348 274000.0n 0.4348 274249.9n 0.4348 274250.0n 0.5602 274499.9n 0.5602 274500.0n 0.5132 274749.9n 0.5132 274750.0n 0.4348 274999.9n 0.4348 275000.0n 0.5759 275249.9n 0.5759 275250.0n 0.4348 275499.9n 0.4348 275500.0n 0.6229 275749.9n 0.6229 275750.0n 0.4348 275999.9n 0.4348 276000.0n 0.5602 276249.9n 0.5602 276250.0n 0.6386 276499.9n 0.6386 276500.0n 0.4348 276749.9n 0.4348 276750.0n 0.6229 276999.9n 0.6229 277000.0n 0.6857 277249.9n 0.6857 277250.0n 0.6857 277499.9n 0.6857 277500.0n 0.5602 277749.9n 0.5602 277750.0n 0.5759 277999.9n 0.5759 278000.0n 0.7170 278249.9n 0.7170 278250.0n 0.6073 278499.9n 0.6073 278500.0n 0.5602 278749.9n 0.5602 278750.0n 0.4348 278999.9n 0.4348 279000.0n 0.6543 279249.9n 0.6543 279250.0n 0.4505 279499.9n 0.4505 279500.0n 0.4348 279749.9n 0.4348 279750.0n 0.4348 279999.9n 0.4348 280000.0n 0.4975 280249.9n 0.4975 280250.0n 0.6543 280499.9n 0.6543 280500.0n 0.5602 280749.9n 0.5602 280750.0n 0.4348 280999.9n 0.4348 281000.0n 0.4348 281249.9n 0.4348 281250.0n 0.4348 281499.9n 0.4348 281500.0n 0.4348 281749.9n 0.4348 281750.0n 0.5602 281999.9n 0.5602 282000.0n 0.5132 282249.9n 0.5132 282250.0n 0.4348 282499.9n 0.4348 282500.0n 0.5759 282749.9n 0.5759 282750.0n 0.4348 282999.9n 0.4348 283000.0n 0.6229 283249.9n 0.6229 283250.0n 0.4348 283499.9n 0.4348 283500.0n 0.5602 283749.9n 0.5602 283750.0n 0.6386 283999.9n 0.6386 284000.0n 0.4348 284249.9n 0.4348 284250.0n 0.6229 284499.9n 0.6229 284500.0n 0.6857 284749.9n 0.6857 284750.0n 0.6857 284999.9n 0.6857 285000.0n 0.5602 285249.9n 0.5602 285250.0n 0.5759 285499.9n 0.5759 285500.0n 0.7170 285749.9n 0.7170 285750.0n 0.6073 285999.9n 0.6073 286000.0n 0.5602 286249.9n 0.5602 286250.0n 0.4348 286499.9n 0.4348 286500.0n 0.6543 286749.9n 0.6543 286750.0n 0.4505 286999.9n 0.4505 287000.0n 0.4348 287249.9n 0.4348 287250.0n 0.4348 287499.9n 0.4348 287500.0n 0.4975 287749.9n 0.4975 287750.0n 0.6543 287999.9n 0.6543 288000.0n 0.5602 288249.9n 0.5602 288250.0n 0.4348 288499.9n 0.4348 288500.0n 0.4348 288749.9n 0.4348 288750.0n 0.4348 288999.9n 0.4348 289000.0n 0.4348 289249.9n 0.4348 289250.0n 0.5602 289499.9n 0.5602 289500.0n 0.5132 289749.9n 0.5132 289750.0n 0.4348 289999.9n 0.4348 290000.0n 0.5759 290249.9n 0.5759 290250.0n 0.4348 290499.9n 0.4348 290500.0n 0.6229 290749.9n 0.6229 290750.0n 0.4348 290999.9n 0.4348 291000.0n 0.5602 291249.9n 0.5602 291250.0n 0.6386 291499.9n 0.6386 291500.0n 0.4348 291749.9n 0.4348 291750.0n 0.6229 291999.9n 0.6229 292000.0n 0.6857 292249.9n 0.6857 292250.0n 0.6857 292499.9n 0.6857 292500.0n 0.5602 292749.9n 0.5602 292750.0n 0.5759 292999.9n 0.5759 293000.0n 0.7170 293249.9n 0.7170 293250.0n 0.6073 293499.9n 0.6073 293500.0n 0.5602 293749.9n 0.5602 293750.0n 0.4348 293999.9n 0.4348 294000.0n 0.6543 294249.9n 0.6543 294250.0n 0.4505 294499.9n 0.4505 294500.0n 0.4348 294749.9n 0.4348 294750.0n 0.4348 294999.9n 0.4348 295000.0n 0.4975 295249.9n 0.4975 295250.0n 0.6543 295499.9n 0.6543 295500.0n 0.5602 295749.9n 0.5602 295750.0n 0.4348 295999.9n 0.4348 296000.0n 0.4348 296249.9n 0.4348 296250.0n 0.4348 296499.9n 0.4348 296500.0n 0.4348 296749.9n 0.4348 296750.0n 0.5602 296999.9n 0.5602 297000.0n 0.5132 297249.9n 0.5132 297250.0n 0.4348 297499.9n 0.4348 297500.0n 0.5759 297749.9n 0.5759 297750.0n 0.4348 297999.9n 0.4348 298000.0n 0.6229 298249.9n 0.6229 298250.0n 0.4348 298499.9n 0.4348 298500.0n 0.5602 298749.9n 0.5602 298750.0n 0.6386 298999.9n 0.6386 299000.0n 0.4348 299249.9n 0.4348 299250.0n 0.6229 299499.9n 0.6229 299500.0n 0.6857 299749.9n 0.6857 299750.0n 0.6857)
Vxn7 a_xn7 0 PWL(0.0n 0.4398 249.9n 0.4398 250.0n 0.4241 499.9n 0.4241 500.0n 0.2830 749.9n 0.2830 750.0n 0.3927 999.9n 0.3927 1000.0n 0.4398 1249.9n 0.4398 1250.0n 0.5652 1499.9n 0.5652 1500.0n 0.3457 1749.9n 0.3457 1750.0n 0.5495 1999.9n 0.5495 2000.0n 0.5652 2249.9n 0.5652 2250.0n 0.5652 2499.9n 0.5652 2500.0n 0.5025 2749.9n 0.5025 2750.0n 0.3457 2999.9n 0.3457 3000.0n 0.4398 3249.9n 0.4398 3250.0n 0.5652 3499.9n 0.5652 3500.0n 0.5652 3749.9n 0.5652 3750.0n 0.5652 3999.9n 0.5652 4000.0n 0.5652 4249.9n 0.5652 4250.0n 0.4398 4499.9n 0.4398 4500.0n 0.4868 4749.9n 0.4868 4750.0n 0.5652 4999.9n 0.5652 5000.0n 0.4241 5249.9n 0.4241 5250.0n 0.5652 5499.9n 0.5652 5500.0n 0.3771 5749.9n 0.3771 5750.0n 0.5652 5999.9n 0.5652 6000.0n 0.4398 6249.9n 0.4398 6250.0n 0.3614 6499.9n 0.3614 6500.0n 0.5652 6749.9n 0.5652 6750.0n 0.3771 6999.9n 0.3771 7000.0n 0.3143 7249.9n 0.3143 7250.0n 0.3143 7499.9n 0.3143 7500.0n 0.4398 7749.9n 0.4398 7750.0n 0.4241 7999.9n 0.4241 8000.0n 0.2830 8249.9n 0.2830 8250.0n 0.3927 8499.9n 0.3927 8500.0n 0.4398 8749.9n 0.4398 8750.0n 0.5652 8999.9n 0.5652 9000.0n 0.3457 9249.9n 0.3457 9250.0n 0.5495 9499.9n 0.5495 9500.0n 0.5652 9749.9n 0.5652 9750.0n 0.5652 9999.9n 0.5652 10000.0n 0.5025 10249.9n 0.5025 10250.0n 0.3457 10499.9n 0.3457 10500.0n 0.4398 10749.9n 0.4398 10750.0n 0.5652 10999.9n 0.5652 11000.0n 0.5652 11249.9n 0.5652 11250.0n 0.5652 11499.9n 0.5652 11500.0n 0.5652 11749.9n 0.5652 11750.0n 0.4398 11999.9n 0.4398 12000.0n 0.4868 12249.9n 0.4868 12250.0n 0.5652 12499.9n 0.5652 12500.0n 0.4241 12749.9n 0.4241 12750.0n 0.5652 12999.9n 0.5652 13000.0n 0.3771 13249.9n 0.3771 13250.0n 0.5652 13499.9n 0.5652 13500.0n 0.4398 13749.9n 0.4398 13750.0n 0.3614 13999.9n 0.3614 14000.0n 0.5652 14249.9n 0.5652 14250.0n 0.3771 14499.9n 0.3771 14500.0n 0.3143 14749.9n 0.3143 14750.0n 0.3143 14999.9n 0.3143 15000.0n 0.4398 15249.9n 0.4398 15250.0n 0.4241 15499.9n 0.4241 15500.0n 0.2830 15749.9n 0.2830 15750.0n 0.3927 15999.9n 0.3927 16000.0n 0.4398 16249.9n 0.4398 16250.0n 0.5652 16499.9n 0.5652 16500.0n 0.3457 16749.9n 0.3457 16750.0n 0.5495 16999.9n 0.5495 17000.0n 0.5652 17249.9n 0.5652 17250.0n 0.5652 17499.9n 0.5652 17500.0n 0.5025 17749.9n 0.5025 17750.0n 0.3457 17999.9n 0.3457 18000.0n 0.4398 18249.9n 0.4398 18250.0n 0.5652 18499.9n 0.5652 18500.0n 0.5652 18749.9n 0.5652 18750.0n 0.5652 18999.9n 0.5652 19000.0n 0.5652 19249.9n 0.5652 19250.0n 0.4398 19499.9n 0.4398 19500.0n 0.4868 19749.9n 0.4868 19750.0n 0.5652 19999.9n 0.5652 20000.0n 0.4241 20249.9n 0.4241 20250.0n 0.5652 20499.9n 0.5652 20500.0n 0.3771 20749.9n 0.3771 20750.0n 0.5652 20999.9n 0.5652 21000.0n 0.4398 21249.9n 0.4398 21250.0n 0.3614 21499.9n 0.3614 21500.0n 0.5652 21749.9n 0.5652 21750.0n 0.3771 21999.9n 0.3771 22000.0n 0.3143 22249.9n 0.3143 22250.0n 0.3143 22499.9n 0.3143 22500.0n 0.4398 22749.9n 0.4398 22750.0n 0.4241 22999.9n 0.4241 23000.0n 0.2830 23249.9n 0.2830 23250.0n 0.3927 23499.9n 0.3927 23500.0n 0.4398 23749.9n 0.4398 23750.0n 0.5652 23999.9n 0.5652 24000.0n 0.3457 24249.9n 0.3457 24250.0n 0.5495 24499.9n 0.5495 24500.0n 0.5652 24749.9n 0.5652 24750.0n 0.5652 24999.9n 0.5652 25000.0n 0.5025 25249.9n 0.5025 25250.0n 0.3457 25499.9n 0.3457 25500.0n 0.4398 25749.9n 0.4398 25750.0n 0.5652 25999.9n 0.5652 26000.0n 0.5652 26249.9n 0.5652 26250.0n 0.5652 26499.9n 0.5652 26500.0n 0.5652 26749.9n 0.5652 26750.0n 0.4398 26999.9n 0.4398 27000.0n 0.4868 27249.9n 0.4868 27250.0n 0.5652 27499.9n 0.5652 27500.0n 0.4241 27749.9n 0.4241 27750.0n 0.5652 27999.9n 0.5652 28000.0n 0.3771 28249.9n 0.3771 28250.0n 0.5652 28499.9n 0.5652 28500.0n 0.4398 28749.9n 0.4398 28750.0n 0.3614 28999.9n 0.3614 29000.0n 0.5652 29249.9n 0.5652 29250.0n 0.3771 29499.9n 0.3771 29500.0n 0.3143 29749.9n 0.3143 29750.0n 0.3143 29999.9n 0.3143 30000.0n 0.4398 30249.9n 0.4398 30250.0n 0.4241 30499.9n 0.4241 30500.0n 0.2830 30749.9n 0.2830 30750.0n 0.3927 30999.9n 0.3927 31000.0n 0.4398 31249.9n 0.4398 31250.0n 0.5652 31499.9n 0.5652 31500.0n 0.3457 31749.9n 0.3457 31750.0n 0.5495 31999.9n 0.5495 32000.0n 0.5652 32249.9n 0.5652 32250.0n 0.5652 32499.9n 0.5652 32500.0n 0.5025 32749.9n 0.5025 32750.0n 0.3457 32999.9n 0.3457 33000.0n 0.4398 33249.9n 0.4398 33250.0n 0.5652 33499.9n 0.5652 33500.0n 0.5652 33749.9n 0.5652 33750.0n 0.5652 33999.9n 0.5652 34000.0n 0.5652 34249.9n 0.5652 34250.0n 0.4398 34499.9n 0.4398 34500.0n 0.4868 34749.9n 0.4868 34750.0n 0.5652 34999.9n 0.5652 35000.0n 0.4241 35249.9n 0.4241 35250.0n 0.5652 35499.9n 0.5652 35500.0n 0.3771 35749.9n 0.3771 35750.0n 0.5652 35999.9n 0.5652 36000.0n 0.4398 36249.9n 0.4398 36250.0n 0.3614 36499.9n 0.3614 36500.0n 0.5652 36749.9n 0.5652 36750.0n 0.3771 36999.9n 0.3771 37000.0n 0.3143 37249.9n 0.3143 37250.0n 0.3143 37499.9n 0.3143 37500.0n 0.4398 37749.9n 0.4398 37750.0n 0.4241 37999.9n 0.4241 38000.0n 0.2830 38249.9n 0.2830 38250.0n 0.3927 38499.9n 0.3927 38500.0n 0.4398 38749.9n 0.4398 38750.0n 0.5652 38999.9n 0.5652 39000.0n 0.3457 39249.9n 0.3457 39250.0n 0.5495 39499.9n 0.5495 39500.0n 0.5652 39749.9n 0.5652 39750.0n 0.5652 39999.9n 0.5652 40000.0n 0.5025 40249.9n 0.5025 40250.0n 0.3457 40499.9n 0.3457 40500.0n 0.4398 40749.9n 0.4398 40750.0n 0.5652 40999.9n 0.5652 41000.0n 0.5652 41249.9n 0.5652 41250.0n 0.5652 41499.9n 0.5652 41500.0n 0.5652 41749.9n 0.5652 41750.0n 0.4398 41999.9n 0.4398 42000.0n 0.4868 42249.9n 0.4868 42250.0n 0.5652 42499.9n 0.5652 42500.0n 0.4241 42749.9n 0.4241 42750.0n 0.5652 42999.9n 0.5652 43000.0n 0.3771 43249.9n 0.3771 43250.0n 0.5652 43499.9n 0.5652 43500.0n 0.4398 43749.9n 0.4398 43750.0n 0.3614 43999.9n 0.3614 44000.0n 0.5652 44249.9n 0.5652 44250.0n 0.3771 44499.9n 0.3771 44500.0n 0.3143 44749.9n 0.3143 44750.0n 0.3143 44999.9n 0.3143 45000.0n 0.4398 45249.9n 0.4398 45250.0n 0.4241 45499.9n 0.4241 45500.0n 0.2830 45749.9n 0.2830 45750.0n 0.3927 45999.9n 0.3927 46000.0n 0.4398 46249.9n 0.4398 46250.0n 0.5652 46499.9n 0.5652 46500.0n 0.3457 46749.9n 0.3457 46750.0n 0.5495 46999.9n 0.5495 47000.0n 0.5652 47249.9n 0.5652 47250.0n 0.5652 47499.9n 0.5652 47500.0n 0.5025 47749.9n 0.5025 47750.0n 0.3457 47999.9n 0.3457 48000.0n 0.4398 48249.9n 0.4398 48250.0n 0.5652 48499.9n 0.5652 48500.0n 0.5652 48749.9n 0.5652 48750.0n 0.5652 48999.9n 0.5652 49000.0n 0.5652 49249.9n 0.5652 49250.0n 0.4398 49499.9n 0.4398 49500.0n 0.4868 49749.9n 0.4868 49750.0n 0.5652 49999.9n 0.5652 50000.0n 0.4241 50249.9n 0.4241 50250.0n 0.5652 50499.9n 0.5652 50500.0n 0.3771 50749.9n 0.3771 50750.0n 0.5652 50999.9n 0.5652 51000.0n 0.4398 51249.9n 0.4398 51250.0n 0.3614 51499.9n 0.3614 51500.0n 0.5652 51749.9n 0.5652 51750.0n 0.3771 51999.9n 0.3771 52000.0n 0.3143 52249.9n 0.3143 52250.0n 0.3143 52499.9n 0.3143 52500.0n 0.4398 52749.9n 0.4398 52750.0n 0.4241 52999.9n 0.4241 53000.0n 0.2830 53249.9n 0.2830 53250.0n 0.3927 53499.9n 0.3927 53500.0n 0.4398 53749.9n 0.4398 53750.0n 0.5652 53999.9n 0.5652 54000.0n 0.3457 54249.9n 0.3457 54250.0n 0.5495 54499.9n 0.5495 54500.0n 0.5652 54749.9n 0.5652 54750.0n 0.5652 54999.9n 0.5652 55000.0n 0.5025 55249.9n 0.5025 55250.0n 0.3457 55499.9n 0.3457 55500.0n 0.4398 55749.9n 0.4398 55750.0n 0.5652 55999.9n 0.5652 56000.0n 0.5652 56249.9n 0.5652 56250.0n 0.5652 56499.9n 0.5652 56500.0n 0.5652 56749.9n 0.5652 56750.0n 0.4398 56999.9n 0.4398 57000.0n 0.4868 57249.9n 0.4868 57250.0n 0.5652 57499.9n 0.5652 57500.0n 0.4241 57749.9n 0.4241 57750.0n 0.5652 57999.9n 0.5652 58000.0n 0.3771 58249.9n 0.3771 58250.0n 0.5652 58499.9n 0.5652 58500.0n 0.4398 58749.9n 0.4398 58750.0n 0.3614 58999.9n 0.3614 59000.0n 0.5652 59249.9n 0.5652 59250.0n 0.3771 59499.9n 0.3771 59500.0n 0.3143 59749.9n 0.3143 59750.0n 0.3143 59999.9n 0.3143 60000.0n 0.4398 60249.9n 0.4398 60250.0n 0.4241 60499.9n 0.4241 60500.0n 0.2830 60749.9n 0.2830 60750.0n 0.3927 60999.9n 0.3927 61000.0n 0.4398 61249.9n 0.4398 61250.0n 0.5652 61499.9n 0.5652 61500.0n 0.3457 61749.9n 0.3457 61750.0n 0.5495 61999.9n 0.5495 62000.0n 0.5652 62249.9n 0.5652 62250.0n 0.5652 62499.9n 0.5652 62500.0n 0.5025 62749.9n 0.5025 62750.0n 0.3457 62999.9n 0.3457 63000.0n 0.4398 63249.9n 0.4398 63250.0n 0.5652 63499.9n 0.5652 63500.0n 0.5652 63749.9n 0.5652 63750.0n 0.5652 63999.9n 0.5652 64000.0n 0.5652 64249.9n 0.5652 64250.0n 0.4398 64499.9n 0.4398 64500.0n 0.4868 64749.9n 0.4868 64750.0n 0.5652 64999.9n 0.5652 65000.0n 0.4241 65249.9n 0.4241 65250.0n 0.5652 65499.9n 0.5652 65500.0n 0.3771 65749.9n 0.3771 65750.0n 0.5652 65999.9n 0.5652 66000.0n 0.4398 66249.9n 0.4398 66250.0n 0.3614 66499.9n 0.3614 66500.0n 0.5652 66749.9n 0.5652 66750.0n 0.3771 66999.9n 0.3771 67000.0n 0.3143 67249.9n 0.3143 67250.0n 0.3143 67499.9n 0.3143 67500.0n 0.4398 67749.9n 0.4398 67750.0n 0.4241 67999.9n 0.4241 68000.0n 0.2830 68249.9n 0.2830 68250.0n 0.3927 68499.9n 0.3927 68500.0n 0.4398 68749.9n 0.4398 68750.0n 0.5652 68999.9n 0.5652 69000.0n 0.3457 69249.9n 0.3457 69250.0n 0.5495 69499.9n 0.5495 69500.0n 0.5652 69749.9n 0.5652 69750.0n 0.5652 69999.9n 0.5652 70000.0n 0.5025 70249.9n 0.5025 70250.0n 0.3457 70499.9n 0.3457 70500.0n 0.4398 70749.9n 0.4398 70750.0n 0.5652 70999.9n 0.5652 71000.0n 0.5652 71249.9n 0.5652 71250.0n 0.5652 71499.9n 0.5652 71500.0n 0.5652 71749.9n 0.5652 71750.0n 0.4398 71999.9n 0.4398 72000.0n 0.4868 72249.9n 0.4868 72250.0n 0.5652 72499.9n 0.5652 72500.0n 0.4241 72749.9n 0.4241 72750.0n 0.5652 72999.9n 0.5652 73000.0n 0.3771 73249.9n 0.3771 73250.0n 0.5652 73499.9n 0.5652 73500.0n 0.4398 73749.9n 0.4398 73750.0n 0.3614 73999.9n 0.3614 74000.0n 0.5652 74249.9n 0.5652 74250.0n 0.3771 74499.9n 0.3771 74500.0n 0.3143 74749.9n 0.3143 74750.0n 0.3143 74999.9n 0.3143 75000.0n 0.4398 75249.9n 0.4398 75250.0n 0.4241 75499.9n 0.4241 75500.0n 0.2830 75749.9n 0.2830 75750.0n 0.3927 75999.9n 0.3927 76000.0n 0.4398 76249.9n 0.4398 76250.0n 0.5652 76499.9n 0.5652 76500.0n 0.3457 76749.9n 0.3457 76750.0n 0.5495 76999.9n 0.5495 77000.0n 0.5652 77249.9n 0.5652 77250.0n 0.5652 77499.9n 0.5652 77500.0n 0.5025 77749.9n 0.5025 77750.0n 0.3457 77999.9n 0.3457 78000.0n 0.4398 78249.9n 0.4398 78250.0n 0.5652 78499.9n 0.5652 78500.0n 0.5652 78749.9n 0.5652 78750.0n 0.5652 78999.9n 0.5652 79000.0n 0.5652 79249.9n 0.5652 79250.0n 0.4398 79499.9n 0.4398 79500.0n 0.4868 79749.9n 0.4868 79750.0n 0.5652 79999.9n 0.5652 80000.0n 0.4241 80249.9n 0.4241 80250.0n 0.5652 80499.9n 0.5652 80500.0n 0.3771 80749.9n 0.3771 80750.0n 0.5652 80999.9n 0.5652 81000.0n 0.4398 81249.9n 0.4398 81250.0n 0.3614 81499.9n 0.3614 81500.0n 0.5652 81749.9n 0.5652 81750.0n 0.3771 81999.9n 0.3771 82000.0n 0.3143 82249.9n 0.3143 82250.0n 0.3143 82499.9n 0.3143 82500.0n 0.4398 82749.9n 0.4398 82750.0n 0.4241 82999.9n 0.4241 83000.0n 0.2830 83249.9n 0.2830 83250.0n 0.3927 83499.9n 0.3927 83500.0n 0.4398 83749.9n 0.4398 83750.0n 0.5652 83999.9n 0.5652 84000.0n 0.3457 84249.9n 0.3457 84250.0n 0.5495 84499.9n 0.5495 84500.0n 0.5652 84749.9n 0.5652 84750.0n 0.5652 84999.9n 0.5652 85000.0n 0.5025 85249.9n 0.5025 85250.0n 0.3457 85499.9n 0.3457 85500.0n 0.4398 85749.9n 0.4398 85750.0n 0.5652 85999.9n 0.5652 86000.0n 0.5652 86249.9n 0.5652 86250.0n 0.5652 86499.9n 0.5652 86500.0n 0.5652 86749.9n 0.5652 86750.0n 0.4398 86999.9n 0.4398 87000.0n 0.4868 87249.9n 0.4868 87250.0n 0.5652 87499.9n 0.5652 87500.0n 0.4241 87749.9n 0.4241 87750.0n 0.5652 87999.9n 0.5652 88000.0n 0.3771 88249.9n 0.3771 88250.0n 0.5652 88499.9n 0.5652 88500.0n 0.4398 88749.9n 0.4398 88750.0n 0.3614 88999.9n 0.3614 89000.0n 0.5652 89249.9n 0.5652 89250.0n 0.3771 89499.9n 0.3771 89500.0n 0.3143 89749.9n 0.3143 89750.0n 0.3143 89999.9n 0.3143 90000.0n 0.4398 90249.9n 0.4398 90250.0n 0.4241 90499.9n 0.4241 90500.0n 0.2830 90749.9n 0.2830 90750.0n 0.3927 90999.9n 0.3927 91000.0n 0.4398 91249.9n 0.4398 91250.0n 0.5652 91499.9n 0.5652 91500.0n 0.3457 91749.9n 0.3457 91750.0n 0.5495 91999.9n 0.5495 92000.0n 0.5652 92249.9n 0.5652 92250.0n 0.5652 92499.9n 0.5652 92500.0n 0.5025 92749.9n 0.5025 92750.0n 0.3457 92999.9n 0.3457 93000.0n 0.4398 93249.9n 0.4398 93250.0n 0.5652 93499.9n 0.5652 93500.0n 0.5652 93749.9n 0.5652 93750.0n 0.5652 93999.9n 0.5652 94000.0n 0.5652 94249.9n 0.5652 94250.0n 0.4398 94499.9n 0.4398 94500.0n 0.4868 94749.9n 0.4868 94750.0n 0.5652 94999.9n 0.5652 95000.0n 0.4241 95249.9n 0.4241 95250.0n 0.5652 95499.9n 0.5652 95500.0n 0.3771 95749.9n 0.3771 95750.0n 0.5652 95999.9n 0.5652 96000.0n 0.4398 96249.9n 0.4398 96250.0n 0.3614 96499.9n 0.3614 96500.0n 0.5652 96749.9n 0.5652 96750.0n 0.3771 96999.9n 0.3771 97000.0n 0.3143 97249.9n 0.3143 97250.0n 0.3143 97499.9n 0.3143 97500.0n 0.4398 97749.9n 0.4398 97750.0n 0.4241 97999.9n 0.4241 98000.0n 0.2830 98249.9n 0.2830 98250.0n 0.3927 98499.9n 0.3927 98500.0n 0.4398 98749.9n 0.4398 98750.0n 0.5652 98999.9n 0.5652 99000.0n 0.3457 99249.9n 0.3457 99250.0n 0.5495 99499.9n 0.5495 99500.0n 0.5652 99749.9n 0.5652 99750.0n 0.5652 99999.9n 0.5652 100000.0n 0.5025 100249.9n 0.5025 100250.0n 0.3457 100499.9n 0.3457 100500.0n 0.4398 100749.9n 0.4398 100750.0n 0.5652 100999.9n 0.5652 101000.0n 0.5652 101249.9n 0.5652 101250.0n 0.5652 101499.9n 0.5652 101500.0n 0.5652 101749.9n 0.5652 101750.0n 0.4398 101999.9n 0.4398 102000.0n 0.4868 102249.9n 0.4868 102250.0n 0.5652 102499.9n 0.5652 102500.0n 0.4241 102749.9n 0.4241 102750.0n 0.5652 102999.9n 0.5652 103000.0n 0.3771 103249.9n 0.3771 103250.0n 0.5652 103499.9n 0.5652 103500.0n 0.4398 103749.9n 0.4398 103750.0n 0.3614 103999.9n 0.3614 104000.0n 0.5652 104249.9n 0.5652 104250.0n 0.3771 104499.9n 0.3771 104500.0n 0.3143 104749.9n 0.3143 104750.0n 0.3143 104999.9n 0.3143 105000.0n 0.4398 105249.9n 0.4398 105250.0n 0.4241 105499.9n 0.4241 105500.0n 0.2830 105749.9n 0.2830 105750.0n 0.3927 105999.9n 0.3927 106000.0n 0.4398 106249.9n 0.4398 106250.0n 0.5652 106499.9n 0.5652 106500.0n 0.3457 106749.9n 0.3457 106750.0n 0.5495 106999.9n 0.5495 107000.0n 0.5652 107249.9n 0.5652 107250.0n 0.5652 107499.9n 0.5652 107500.0n 0.5025 107749.9n 0.5025 107750.0n 0.3457 107999.9n 0.3457 108000.0n 0.4398 108249.9n 0.4398 108250.0n 0.5652 108499.9n 0.5652 108500.0n 0.5652 108749.9n 0.5652 108750.0n 0.5652 108999.9n 0.5652 109000.0n 0.5652 109249.9n 0.5652 109250.0n 0.4398 109499.9n 0.4398 109500.0n 0.4868 109749.9n 0.4868 109750.0n 0.5652 109999.9n 0.5652 110000.0n 0.4241 110249.9n 0.4241 110250.0n 0.5652 110499.9n 0.5652 110500.0n 0.3771 110749.9n 0.3771 110750.0n 0.5652 110999.9n 0.5652 111000.0n 0.4398 111249.9n 0.4398 111250.0n 0.3614 111499.9n 0.3614 111500.0n 0.5652 111749.9n 0.5652 111750.0n 0.3771 111999.9n 0.3771 112000.0n 0.3143 112249.9n 0.3143 112250.0n 0.3143 112499.9n 0.3143 112500.0n 0.4398 112749.9n 0.4398 112750.0n 0.4241 112999.9n 0.4241 113000.0n 0.2830 113249.9n 0.2830 113250.0n 0.3927 113499.9n 0.3927 113500.0n 0.4398 113749.9n 0.4398 113750.0n 0.5652 113999.9n 0.5652 114000.0n 0.3457 114249.9n 0.3457 114250.0n 0.5495 114499.9n 0.5495 114500.0n 0.5652 114749.9n 0.5652 114750.0n 0.5652 114999.9n 0.5652 115000.0n 0.5025 115249.9n 0.5025 115250.0n 0.3457 115499.9n 0.3457 115500.0n 0.4398 115749.9n 0.4398 115750.0n 0.5652 115999.9n 0.5652 116000.0n 0.5652 116249.9n 0.5652 116250.0n 0.5652 116499.9n 0.5652 116500.0n 0.5652 116749.9n 0.5652 116750.0n 0.4398 116999.9n 0.4398 117000.0n 0.4868 117249.9n 0.4868 117250.0n 0.5652 117499.9n 0.5652 117500.0n 0.4241 117749.9n 0.4241 117750.0n 0.5652 117999.9n 0.5652 118000.0n 0.3771 118249.9n 0.3771 118250.0n 0.5652 118499.9n 0.5652 118500.0n 0.4398 118749.9n 0.4398 118750.0n 0.3614 118999.9n 0.3614 119000.0n 0.5652 119249.9n 0.5652 119250.0n 0.3771 119499.9n 0.3771 119500.0n 0.3143 119749.9n 0.3143 119750.0n 0.3143 119999.9n 0.3143 120000.0n 0.4398 120249.9n 0.4398 120250.0n 0.4241 120499.9n 0.4241 120500.0n 0.2830 120749.9n 0.2830 120750.0n 0.3927 120999.9n 0.3927 121000.0n 0.4398 121249.9n 0.4398 121250.0n 0.5652 121499.9n 0.5652 121500.0n 0.3457 121749.9n 0.3457 121750.0n 0.5495 121999.9n 0.5495 122000.0n 0.5652 122249.9n 0.5652 122250.0n 0.5652 122499.9n 0.5652 122500.0n 0.5025 122749.9n 0.5025 122750.0n 0.3457 122999.9n 0.3457 123000.0n 0.4398 123249.9n 0.4398 123250.0n 0.5652 123499.9n 0.5652 123500.0n 0.5652 123749.9n 0.5652 123750.0n 0.5652 123999.9n 0.5652 124000.0n 0.5652 124249.9n 0.5652 124250.0n 0.4398 124499.9n 0.4398 124500.0n 0.4868 124749.9n 0.4868 124750.0n 0.5652 124999.9n 0.5652 125000.0n 0.4241 125249.9n 0.4241 125250.0n 0.5652 125499.9n 0.5652 125500.0n 0.3771 125749.9n 0.3771 125750.0n 0.5652 125999.9n 0.5652 126000.0n 0.4398 126249.9n 0.4398 126250.0n 0.3614 126499.9n 0.3614 126500.0n 0.5652 126749.9n 0.5652 126750.0n 0.3771 126999.9n 0.3771 127000.0n 0.3143 127249.9n 0.3143 127250.0n 0.3143 127499.9n 0.3143 127500.0n 0.4398 127749.9n 0.4398 127750.0n 0.4241 127999.9n 0.4241 128000.0n 0.2830 128249.9n 0.2830 128250.0n 0.3927 128499.9n 0.3927 128500.0n 0.4398 128749.9n 0.4398 128750.0n 0.5652 128999.9n 0.5652 129000.0n 0.3457 129249.9n 0.3457 129250.0n 0.5495 129499.9n 0.5495 129500.0n 0.5652 129749.9n 0.5652 129750.0n 0.5652 129999.9n 0.5652 130000.0n 0.5025 130249.9n 0.5025 130250.0n 0.3457 130499.9n 0.3457 130500.0n 0.4398 130749.9n 0.4398 130750.0n 0.5652 130999.9n 0.5652 131000.0n 0.5652 131249.9n 0.5652 131250.0n 0.5652 131499.9n 0.5652 131500.0n 0.5652 131749.9n 0.5652 131750.0n 0.4398 131999.9n 0.4398 132000.0n 0.4868 132249.9n 0.4868 132250.0n 0.5652 132499.9n 0.5652 132500.0n 0.4241 132749.9n 0.4241 132750.0n 0.5652 132999.9n 0.5652 133000.0n 0.3771 133249.9n 0.3771 133250.0n 0.5652 133499.9n 0.5652 133500.0n 0.4398 133749.9n 0.4398 133750.0n 0.3614 133999.9n 0.3614 134000.0n 0.5652 134249.9n 0.5652 134250.0n 0.3771 134499.9n 0.3771 134500.0n 0.3143 134749.9n 0.3143 134750.0n 0.3143 134999.9n 0.3143 135000.0n 0.4398 135249.9n 0.4398 135250.0n 0.4241 135499.9n 0.4241 135500.0n 0.2830 135749.9n 0.2830 135750.0n 0.3927 135999.9n 0.3927 136000.0n 0.4398 136249.9n 0.4398 136250.0n 0.5652 136499.9n 0.5652 136500.0n 0.3457 136749.9n 0.3457 136750.0n 0.5495 136999.9n 0.5495 137000.0n 0.5652 137249.9n 0.5652 137250.0n 0.5652 137499.9n 0.5652 137500.0n 0.5025 137749.9n 0.5025 137750.0n 0.3457 137999.9n 0.3457 138000.0n 0.4398 138249.9n 0.4398 138250.0n 0.5652 138499.9n 0.5652 138500.0n 0.5652 138749.9n 0.5652 138750.0n 0.5652 138999.9n 0.5652 139000.0n 0.5652 139249.9n 0.5652 139250.0n 0.4398 139499.9n 0.4398 139500.0n 0.4868 139749.9n 0.4868 139750.0n 0.5652 139999.9n 0.5652 140000.0n 0.4241 140249.9n 0.4241 140250.0n 0.5652 140499.9n 0.5652 140500.0n 0.3771 140749.9n 0.3771 140750.0n 0.5652 140999.9n 0.5652 141000.0n 0.4398 141249.9n 0.4398 141250.0n 0.3614 141499.9n 0.3614 141500.0n 0.5652 141749.9n 0.5652 141750.0n 0.3771 141999.9n 0.3771 142000.0n 0.3143 142249.9n 0.3143 142250.0n 0.3143 142499.9n 0.3143 142500.0n 0.4398 142749.9n 0.4398 142750.0n 0.4241 142999.9n 0.4241 143000.0n 0.2830 143249.9n 0.2830 143250.0n 0.3927 143499.9n 0.3927 143500.0n 0.4398 143749.9n 0.4398 143750.0n 0.5652 143999.9n 0.5652 144000.0n 0.3457 144249.9n 0.3457 144250.0n 0.5495 144499.9n 0.5495 144500.0n 0.5652 144749.9n 0.5652 144750.0n 0.5652 144999.9n 0.5652 145000.0n 0.5025 145249.9n 0.5025 145250.0n 0.3457 145499.9n 0.3457 145500.0n 0.4398 145749.9n 0.4398 145750.0n 0.5652 145999.9n 0.5652 146000.0n 0.5652 146249.9n 0.5652 146250.0n 0.5652 146499.9n 0.5652 146500.0n 0.5652 146749.9n 0.5652 146750.0n 0.4398 146999.9n 0.4398 147000.0n 0.4868 147249.9n 0.4868 147250.0n 0.5652 147499.9n 0.5652 147500.0n 0.4241 147749.9n 0.4241 147750.0n 0.5652 147999.9n 0.5652 148000.0n 0.3771 148249.9n 0.3771 148250.0n 0.5652 148499.9n 0.5652 148500.0n 0.4398 148749.9n 0.4398 148750.0n 0.3614 148999.9n 0.3614 149000.0n 0.5652 149249.9n 0.5652 149250.0n 0.3771 149499.9n 0.3771 149500.0n 0.3143 149749.9n 0.3143 149750.0n 0.3143 149999.9n 0.3143 150000.0n 0.4398 150249.9n 0.4398 150250.0n 0.4241 150499.9n 0.4241 150500.0n 0.2830 150749.9n 0.2830 150750.0n 0.3927 150999.9n 0.3927 151000.0n 0.4398 151249.9n 0.4398 151250.0n 0.5652 151499.9n 0.5652 151500.0n 0.3457 151749.9n 0.3457 151750.0n 0.5495 151999.9n 0.5495 152000.0n 0.5652 152249.9n 0.5652 152250.0n 0.5652 152499.9n 0.5652 152500.0n 0.5025 152749.9n 0.5025 152750.0n 0.3457 152999.9n 0.3457 153000.0n 0.4398 153249.9n 0.4398 153250.0n 0.5652 153499.9n 0.5652 153500.0n 0.5652 153749.9n 0.5652 153750.0n 0.5652 153999.9n 0.5652 154000.0n 0.5652 154249.9n 0.5652 154250.0n 0.4398 154499.9n 0.4398 154500.0n 0.4868 154749.9n 0.4868 154750.0n 0.5652 154999.9n 0.5652 155000.0n 0.4241 155249.9n 0.4241 155250.0n 0.5652 155499.9n 0.5652 155500.0n 0.3771 155749.9n 0.3771 155750.0n 0.5652 155999.9n 0.5652 156000.0n 0.4398 156249.9n 0.4398 156250.0n 0.3614 156499.9n 0.3614 156500.0n 0.5652 156749.9n 0.5652 156750.0n 0.3771 156999.9n 0.3771 157000.0n 0.3143 157249.9n 0.3143 157250.0n 0.3143 157499.9n 0.3143 157500.0n 0.4398 157749.9n 0.4398 157750.0n 0.4241 157999.9n 0.4241 158000.0n 0.2830 158249.9n 0.2830 158250.0n 0.3927 158499.9n 0.3927 158500.0n 0.4398 158749.9n 0.4398 158750.0n 0.5652 158999.9n 0.5652 159000.0n 0.3457 159249.9n 0.3457 159250.0n 0.5495 159499.9n 0.5495 159500.0n 0.5652 159749.9n 0.5652 159750.0n 0.5652 159999.9n 0.5652 160000.0n 0.5025 160249.9n 0.5025 160250.0n 0.3457 160499.9n 0.3457 160500.0n 0.4398 160749.9n 0.4398 160750.0n 0.5652 160999.9n 0.5652 161000.0n 0.5652 161249.9n 0.5652 161250.0n 0.5652 161499.9n 0.5652 161500.0n 0.5652 161749.9n 0.5652 161750.0n 0.4398 161999.9n 0.4398 162000.0n 0.4868 162249.9n 0.4868 162250.0n 0.5652 162499.9n 0.5652 162500.0n 0.4241 162749.9n 0.4241 162750.0n 0.5652 162999.9n 0.5652 163000.0n 0.3771 163249.9n 0.3771 163250.0n 0.5652 163499.9n 0.5652 163500.0n 0.4398 163749.9n 0.4398 163750.0n 0.3614 163999.9n 0.3614 164000.0n 0.5652 164249.9n 0.5652 164250.0n 0.3771 164499.9n 0.3771 164500.0n 0.3143 164749.9n 0.3143 164750.0n 0.3143 164999.9n 0.3143 165000.0n 0.4398 165249.9n 0.4398 165250.0n 0.4241 165499.9n 0.4241 165500.0n 0.2830 165749.9n 0.2830 165750.0n 0.3927 165999.9n 0.3927 166000.0n 0.4398 166249.9n 0.4398 166250.0n 0.5652 166499.9n 0.5652 166500.0n 0.3457 166749.9n 0.3457 166750.0n 0.5495 166999.9n 0.5495 167000.0n 0.5652 167249.9n 0.5652 167250.0n 0.5652 167499.9n 0.5652 167500.0n 0.5025 167749.9n 0.5025 167750.0n 0.3457 167999.9n 0.3457 168000.0n 0.4398 168249.9n 0.4398 168250.0n 0.5652 168499.9n 0.5652 168500.0n 0.5652 168749.9n 0.5652 168750.0n 0.5652 168999.9n 0.5652 169000.0n 0.5652 169249.9n 0.5652 169250.0n 0.4398 169499.9n 0.4398 169500.0n 0.4868 169749.9n 0.4868 169750.0n 0.5652 169999.9n 0.5652 170000.0n 0.4241 170249.9n 0.4241 170250.0n 0.5652 170499.9n 0.5652 170500.0n 0.3771 170749.9n 0.3771 170750.0n 0.5652 170999.9n 0.5652 171000.0n 0.4398 171249.9n 0.4398 171250.0n 0.3614 171499.9n 0.3614 171500.0n 0.5652 171749.9n 0.5652 171750.0n 0.3771 171999.9n 0.3771 172000.0n 0.3143 172249.9n 0.3143 172250.0n 0.3143 172499.9n 0.3143 172500.0n 0.4398 172749.9n 0.4398 172750.0n 0.4241 172999.9n 0.4241 173000.0n 0.2830 173249.9n 0.2830 173250.0n 0.3927 173499.9n 0.3927 173500.0n 0.4398 173749.9n 0.4398 173750.0n 0.5652 173999.9n 0.5652 174000.0n 0.3457 174249.9n 0.3457 174250.0n 0.5495 174499.9n 0.5495 174500.0n 0.5652 174749.9n 0.5652 174750.0n 0.5652 174999.9n 0.5652 175000.0n 0.5025 175249.9n 0.5025 175250.0n 0.3457 175499.9n 0.3457 175500.0n 0.4398 175749.9n 0.4398 175750.0n 0.5652 175999.9n 0.5652 176000.0n 0.5652 176249.9n 0.5652 176250.0n 0.5652 176499.9n 0.5652 176500.0n 0.5652 176749.9n 0.5652 176750.0n 0.4398 176999.9n 0.4398 177000.0n 0.4868 177249.9n 0.4868 177250.0n 0.5652 177499.9n 0.5652 177500.0n 0.4241 177749.9n 0.4241 177750.0n 0.5652 177999.9n 0.5652 178000.0n 0.3771 178249.9n 0.3771 178250.0n 0.5652 178499.9n 0.5652 178500.0n 0.4398 178749.9n 0.4398 178750.0n 0.3614 178999.9n 0.3614 179000.0n 0.5652 179249.9n 0.5652 179250.0n 0.3771 179499.9n 0.3771 179500.0n 0.3143 179749.9n 0.3143 179750.0n 0.3143 179999.9n 0.3143 180000.0n 0.4398 180249.9n 0.4398 180250.0n 0.4241 180499.9n 0.4241 180500.0n 0.2830 180749.9n 0.2830 180750.0n 0.3927 180999.9n 0.3927 181000.0n 0.4398 181249.9n 0.4398 181250.0n 0.5652 181499.9n 0.5652 181500.0n 0.3457 181749.9n 0.3457 181750.0n 0.5495 181999.9n 0.5495 182000.0n 0.5652 182249.9n 0.5652 182250.0n 0.5652 182499.9n 0.5652 182500.0n 0.5025 182749.9n 0.5025 182750.0n 0.3457 182999.9n 0.3457 183000.0n 0.4398 183249.9n 0.4398 183250.0n 0.5652 183499.9n 0.5652 183500.0n 0.5652 183749.9n 0.5652 183750.0n 0.5652 183999.9n 0.5652 184000.0n 0.5652 184249.9n 0.5652 184250.0n 0.4398 184499.9n 0.4398 184500.0n 0.4868 184749.9n 0.4868 184750.0n 0.5652 184999.9n 0.5652 185000.0n 0.4241 185249.9n 0.4241 185250.0n 0.5652 185499.9n 0.5652 185500.0n 0.3771 185749.9n 0.3771 185750.0n 0.5652 185999.9n 0.5652 186000.0n 0.4398 186249.9n 0.4398 186250.0n 0.3614 186499.9n 0.3614 186500.0n 0.5652 186749.9n 0.5652 186750.0n 0.3771 186999.9n 0.3771 187000.0n 0.3143 187249.9n 0.3143 187250.0n 0.3143 187499.9n 0.3143 187500.0n 0.4398 187749.9n 0.4398 187750.0n 0.4241 187999.9n 0.4241 188000.0n 0.2830 188249.9n 0.2830 188250.0n 0.3927 188499.9n 0.3927 188500.0n 0.4398 188749.9n 0.4398 188750.0n 0.5652 188999.9n 0.5652 189000.0n 0.3457 189249.9n 0.3457 189250.0n 0.5495 189499.9n 0.5495 189500.0n 0.5652 189749.9n 0.5652 189750.0n 0.5652 189999.9n 0.5652 190000.0n 0.5025 190249.9n 0.5025 190250.0n 0.3457 190499.9n 0.3457 190500.0n 0.4398 190749.9n 0.4398 190750.0n 0.5652 190999.9n 0.5652 191000.0n 0.5652 191249.9n 0.5652 191250.0n 0.5652 191499.9n 0.5652 191500.0n 0.5652 191749.9n 0.5652 191750.0n 0.4398 191999.9n 0.4398 192000.0n 0.4868 192249.9n 0.4868 192250.0n 0.5652 192499.9n 0.5652 192500.0n 0.4241 192749.9n 0.4241 192750.0n 0.5652 192999.9n 0.5652 193000.0n 0.3771 193249.9n 0.3771 193250.0n 0.5652 193499.9n 0.5652 193500.0n 0.4398 193749.9n 0.4398 193750.0n 0.3614 193999.9n 0.3614 194000.0n 0.5652 194249.9n 0.5652 194250.0n 0.3771 194499.9n 0.3771 194500.0n 0.3143 194749.9n 0.3143 194750.0n 0.3143 194999.9n 0.3143 195000.0n 0.4398 195249.9n 0.4398 195250.0n 0.4241 195499.9n 0.4241 195500.0n 0.2830 195749.9n 0.2830 195750.0n 0.3927 195999.9n 0.3927 196000.0n 0.4398 196249.9n 0.4398 196250.0n 0.5652 196499.9n 0.5652 196500.0n 0.3457 196749.9n 0.3457 196750.0n 0.5495 196999.9n 0.5495 197000.0n 0.5652 197249.9n 0.5652 197250.0n 0.5652 197499.9n 0.5652 197500.0n 0.5025 197749.9n 0.5025 197750.0n 0.3457 197999.9n 0.3457 198000.0n 0.4398 198249.9n 0.4398 198250.0n 0.5652 198499.9n 0.5652 198500.0n 0.5652 198749.9n 0.5652 198750.0n 0.5652 198999.9n 0.5652 199000.0n 0.5652 199249.9n 0.5652 199250.0n 0.4398 199499.9n 0.4398 199500.0n 0.4868 199749.9n 0.4868 199750.0n 0.5652 199999.9n 0.5652 200000.0n 0.4241 200249.9n 0.4241 200250.0n 0.5652 200499.9n 0.5652 200500.0n 0.3771 200749.9n 0.3771 200750.0n 0.5652 200999.9n 0.5652 201000.0n 0.4398 201249.9n 0.4398 201250.0n 0.3614 201499.9n 0.3614 201500.0n 0.5652 201749.9n 0.5652 201750.0n 0.3771 201999.9n 0.3771 202000.0n 0.3143 202249.9n 0.3143 202250.0n 0.3143 202499.9n 0.3143 202500.0n 0.4398 202749.9n 0.4398 202750.0n 0.4241 202999.9n 0.4241 203000.0n 0.2830 203249.9n 0.2830 203250.0n 0.3927 203499.9n 0.3927 203500.0n 0.4398 203749.9n 0.4398 203750.0n 0.5652 203999.9n 0.5652 204000.0n 0.3457 204249.9n 0.3457 204250.0n 0.5495 204499.9n 0.5495 204500.0n 0.5652 204749.9n 0.5652 204750.0n 0.5652 204999.9n 0.5652 205000.0n 0.5025 205249.9n 0.5025 205250.0n 0.3457 205499.9n 0.3457 205500.0n 0.4398 205749.9n 0.4398 205750.0n 0.5652 205999.9n 0.5652 206000.0n 0.5652 206249.9n 0.5652 206250.0n 0.5652 206499.9n 0.5652 206500.0n 0.5652 206749.9n 0.5652 206750.0n 0.4398 206999.9n 0.4398 207000.0n 0.4868 207249.9n 0.4868 207250.0n 0.5652 207499.9n 0.5652 207500.0n 0.4241 207749.9n 0.4241 207750.0n 0.5652 207999.9n 0.5652 208000.0n 0.3771 208249.9n 0.3771 208250.0n 0.5652 208499.9n 0.5652 208500.0n 0.4398 208749.9n 0.4398 208750.0n 0.3614 208999.9n 0.3614 209000.0n 0.5652 209249.9n 0.5652 209250.0n 0.3771 209499.9n 0.3771 209500.0n 0.3143 209749.9n 0.3143 209750.0n 0.3143 209999.9n 0.3143 210000.0n 0.4398 210249.9n 0.4398 210250.0n 0.4241 210499.9n 0.4241 210500.0n 0.2830 210749.9n 0.2830 210750.0n 0.3927 210999.9n 0.3927 211000.0n 0.4398 211249.9n 0.4398 211250.0n 0.5652 211499.9n 0.5652 211500.0n 0.3457 211749.9n 0.3457 211750.0n 0.5495 211999.9n 0.5495 212000.0n 0.5652 212249.9n 0.5652 212250.0n 0.5652 212499.9n 0.5652 212500.0n 0.5025 212749.9n 0.5025 212750.0n 0.3457 212999.9n 0.3457 213000.0n 0.4398 213249.9n 0.4398 213250.0n 0.5652 213499.9n 0.5652 213500.0n 0.5652 213749.9n 0.5652 213750.0n 0.5652 213999.9n 0.5652 214000.0n 0.5652 214249.9n 0.5652 214250.0n 0.4398 214499.9n 0.4398 214500.0n 0.4868 214749.9n 0.4868 214750.0n 0.5652 214999.9n 0.5652 215000.0n 0.4241 215249.9n 0.4241 215250.0n 0.5652 215499.9n 0.5652 215500.0n 0.3771 215749.9n 0.3771 215750.0n 0.5652 215999.9n 0.5652 216000.0n 0.4398 216249.9n 0.4398 216250.0n 0.3614 216499.9n 0.3614 216500.0n 0.5652 216749.9n 0.5652 216750.0n 0.3771 216999.9n 0.3771 217000.0n 0.3143 217249.9n 0.3143 217250.0n 0.3143 217499.9n 0.3143 217500.0n 0.4398 217749.9n 0.4398 217750.0n 0.4241 217999.9n 0.4241 218000.0n 0.2830 218249.9n 0.2830 218250.0n 0.3927 218499.9n 0.3927 218500.0n 0.4398 218749.9n 0.4398 218750.0n 0.5652 218999.9n 0.5652 219000.0n 0.3457 219249.9n 0.3457 219250.0n 0.5495 219499.9n 0.5495 219500.0n 0.5652 219749.9n 0.5652 219750.0n 0.5652 219999.9n 0.5652 220000.0n 0.5025 220249.9n 0.5025 220250.0n 0.3457 220499.9n 0.3457 220500.0n 0.4398 220749.9n 0.4398 220750.0n 0.5652 220999.9n 0.5652 221000.0n 0.5652 221249.9n 0.5652 221250.0n 0.5652 221499.9n 0.5652 221500.0n 0.5652 221749.9n 0.5652 221750.0n 0.4398 221999.9n 0.4398 222000.0n 0.4868 222249.9n 0.4868 222250.0n 0.5652 222499.9n 0.5652 222500.0n 0.4241 222749.9n 0.4241 222750.0n 0.5652 222999.9n 0.5652 223000.0n 0.3771 223249.9n 0.3771 223250.0n 0.5652 223499.9n 0.5652 223500.0n 0.4398 223749.9n 0.4398 223750.0n 0.3614 223999.9n 0.3614 224000.0n 0.5652 224249.9n 0.5652 224250.0n 0.3771 224499.9n 0.3771 224500.0n 0.3143 224749.9n 0.3143 224750.0n 0.3143 224999.9n 0.3143 225000.0n 0.4398 225249.9n 0.4398 225250.0n 0.4241 225499.9n 0.4241 225500.0n 0.2830 225749.9n 0.2830 225750.0n 0.3927 225999.9n 0.3927 226000.0n 0.4398 226249.9n 0.4398 226250.0n 0.5652 226499.9n 0.5652 226500.0n 0.3457 226749.9n 0.3457 226750.0n 0.5495 226999.9n 0.5495 227000.0n 0.5652 227249.9n 0.5652 227250.0n 0.5652 227499.9n 0.5652 227500.0n 0.5025 227749.9n 0.5025 227750.0n 0.3457 227999.9n 0.3457 228000.0n 0.4398 228249.9n 0.4398 228250.0n 0.5652 228499.9n 0.5652 228500.0n 0.5652 228749.9n 0.5652 228750.0n 0.5652 228999.9n 0.5652 229000.0n 0.5652 229249.9n 0.5652 229250.0n 0.4398 229499.9n 0.4398 229500.0n 0.4868 229749.9n 0.4868 229750.0n 0.5652 229999.9n 0.5652 230000.0n 0.4241 230249.9n 0.4241 230250.0n 0.5652 230499.9n 0.5652 230500.0n 0.3771 230749.9n 0.3771 230750.0n 0.5652 230999.9n 0.5652 231000.0n 0.4398 231249.9n 0.4398 231250.0n 0.3614 231499.9n 0.3614 231500.0n 0.5652 231749.9n 0.5652 231750.0n 0.3771 231999.9n 0.3771 232000.0n 0.3143 232249.9n 0.3143 232250.0n 0.3143 232499.9n 0.3143 232500.0n 0.4398 232749.9n 0.4398 232750.0n 0.4241 232999.9n 0.4241 233000.0n 0.2830 233249.9n 0.2830 233250.0n 0.3927 233499.9n 0.3927 233500.0n 0.4398 233749.9n 0.4398 233750.0n 0.5652 233999.9n 0.5652 234000.0n 0.3457 234249.9n 0.3457 234250.0n 0.5495 234499.9n 0.5495 234500.0n 0.5652 234749.9n 0.5652 234750.0n 0.5652 234999.9n 0.5652 235000.0n 0.5025 235249.9n 0.5025 235250.0n 0.3457 235499.9n 0.3457 235500.0n 0.4398 235749.9n 0.4398 235750.0n 0.5652 235999.9n 0.5652 236000.0n 0.5652 236249.9n 0.5652 236250.0n 0.5652 236499.9n 0.5652 236500.0n 0.5652 236749.9n 0.5652 236750.0n 0.4398 236999.9n 0.4398 237000.0n 0.4868 237249.9n 0.4868 237250.0n 0.5652 237499.9n 0.5652 237500.0n 0.4241 237749.9n 0.4241 237750.0n 0.5652 237999.9n 0.5652 238000.0n 0.3771 238249.9n 0.3771 238250.0n 0.5652 238499.9n 0.5652 238500.0n 0.4398 238749.9n 0.4398 238750.0n 0.3614 238999.9n 0.3614 239000.0n 0.5652 239249.9n 0.5652 239250.0n 0.3771 239499.9n 0.3771 239500.0n 0.3143 239749.9n 0.3143 239750.0n 0.3143 239999.9n 0.3143 240000.0n 0.4398 240249.9n 0.4398 240250.0n 0.4241 240499.9n 0.4241 240500.0n 0.2830 240749.9n 0.2830 240750.0n 0.3927 240999.9n 0.3927 241000.0n 0.4398 241249.9n 0.4398 241250.0n 0.5652 241499.9n 0.5652 241500.0n 0.3457 241749.9n 0.3457 241750.0n 0.5495 241999.9n 0.5495 242000.0n 0.5652 242249.9n 0.5652 242250.0n 0.5652 242499.9n 0.5652 242500.0n 0.5025 242749.9n 0.5025 242750.0n 0.3457 242999.9n 0.3457 243000.0n 0.4398 243249.9n 0.4398 243250.0n 0.5652 243499.9n 0.5652 243500.0n 0.5652 243749.9n 0.5652 243750.0n 0.5652 243999.9n 0.5652 244000.0n 0.5652 244249.9n 0.5652 244250.0n 0.4398 244499.9n 0.4398 244500.0n 0.4868 244749.9n 0.4868 244750.0n 0.5652 244999.9n 0.5652 245000.0n 0.4241 245249.9n 0.4241 245250.0n 0.5652 245499.9n 0.5652 245500.0n 0.3771 245749.9n 0.3771 245750.0n 0.5652 245999.9n 0.5652 246000.0n 0.4398 246249.9n 0.4398 246250.0n 0.3614 246499.9n 0.3614 246500.0n 0.5652 246749.9n 0.5652 246750.0n 0.3771 246999.9n 0.3771 247000.0n 0.3143 247249.9n 0.3143 247250.0n 0.3143 247499.9n 0.3143 247500.0n 0.4398 247749.9n 0.4398 247750.0n 0.4241 247999.9n 0.4241 248000.0n 0.2830 248249.9n 0.2830 248250.0n 0.3927 248499.9n 0.3927 248500.0n 0.4398 248749.9n 0.4398 248750.0n 0.5652 248999.9n 0.5652 249000.0n 0.3457 249249.9n 0.3457 249250.0n 0.5495 249499.9n 0.5495 249500.0n 0.5652 249749.9n 0.5652 249750.0n 0.5652 249999.9n 0.5652 250000.0n 0.5025 250249.9n 0.5025 250250.0n 0.3457 250499.9n 0.3457 250500.0n 0.4398 250749.9n 0.4398 250750.0n 0.5652 250999.9n 0.5652 251000.0n 0.5652 251249.9n 0.5652 251250.0n 0.5652 251499.9n 0.5652 251500.0n 0.5652 251749.9n 0.5652 251750.0n 0.4398 251999.9n 0.4398 252000.0n 0.4868 252249.9n 0.4868 252250.0n 0.5652 252499.9n 0.5652 252500.0n 0.4241 252749.9n 0.4241 252750.0n 0.5652 252999.9n 0.5652 253000.0n 0.3771 253249.9n 0.3771 253250.0n 0.5652 253499.9n 0.5652 253500.0n 0.4398 253749.9n 0.4398 253750.0n 0.3614 253999.9n 0.3614 254000.0n 0.5652 254249.9n 0.5652 254250.0n 0.3771 254499.9n 0.3771 254500.0n 0.3143 254749.9n 0.3143 254750.0n 0.3143 254999.9n 0.3143 255000.0n 0.4398 255249.9n 0.4398 255250.0n 0.4241 255499.9n 0.4241 255500.0n 0.2830 255749.9n 0.2830 255750.0n 0.3927 255999.9n 0.3927 256000.0n 0.4398 256249.9n 0.4398 256250.0n 0.5652 256499.9n 0.5652 256500.0n 0.3457 256749.9n 0.3457 256750.0n 0.5495 256999.9n 0.5495 257000.0n 0.5652 257249.9n 0.5652 257250.0n 0.5652 257499.9n 0.5652 257500.0n 0.5025 257749.9n 0.5025 257750.0n 0.3457 257999.9n 0.3457 258000.0n 0.4398 258249.9n 0.4398 258250.0n 0.5652 258499.9n 0.5652 258500.0n 0.5652 258749.9n 0.5652 258750.0n 0.5652 258999.9n 0.5652 259000.0n 0.5652 259249.9n 0.5652 259250.0n 0.4398 259499.9n 0.4398 259500.0n 0.4868 259749.9n 0.4868 259750.0n 0.5652 259999.9n 0.5652 260000.0n 0.4241 260249.9n 0.4241 260250.0n 0.5652 260499.9n 0.5652 260500.0n 0.3771 260749.9n 0.3771 260750.0n 0.5652 260999.9n 0.5652 261000.0n 0.4398 261249.9n 0.4398 261250.0n 0.3614 261499.9n 0.3614 261500.0n 0.5652 261749.9n 0.5652 261750.0n 0.3771 261999.9n 0.3771 262000.0n 0.3143 262249.9n 0.3143 262250.0n 0.3143 262499.9n 0.3143 262500.0n 0.4398 262749.9n 0.4398 262750.0n 0.4241 262999.9n 0.4241 263000.0n 0.2830 263249.9n 0.2830 263250.0n 0.3927 263499.9n 0.3927 263500.0n 0.4398 263749.9n 0.4398 263750.0n 0.5652 263999.9n 0.5652 264000.0n 0.3457 264249.9n 0.3457 264250.0n 0.5495 264499.9n 0.5495 264500.0n 0.5652 264749.9n 0.5652 264750.0n 0.5652 264999.9n 0.5652 265000.0n 0.5025 265249.9n 0.5025 265250.0n 0.3457 265499.9n 0.3457 265500.0n 0.4398 265749.9n 0.4398 265750.0n 0.5652 265999.9n 0.5652 266000.0n 0.5652 266249.9n 0.5652 266250.0n 0.5652 266499.9n 0.5652 266500.0n 0.5652 266749.9n 0.5652 266750.0n 0.4398 266999.9n 0.4398 267000.0n 0.4868 267249.9n 0.4868 267250.0n 0.5652 267499.9n 0.5652 267500.0n 0.4241 267749.9n 0.4241 267750.0n 0.5652 267999.9n 0.5652 268000.0n 0.3771 268249.9n 0.3771 268250.0n 0.5652 268499.9n 0.5652 268500.0n 0.4398 268749.9n 0.4398 268750.0n 0.3614 268999.9n 0.3614 269000.0n 0.5652 269249.9n 0.5652 269250.0n 0.3771 269499.9n 0.3771 269500.0n 0.3143 269749.9n 0.3143 269750.0n 0.3143 269999.9n 0.3143 270000.0n 0.4398 270249.9n 0.4398 270250.0n 0.4241 270499.9n 0.4241 270500.0n 0.2830 270749.9n 0.2830 270750.0n 0.3927 270999.9n 0.3927 271000.0n 0.4398 271249.9n 0.4398 271250.0n 0.5652 271499.9n 0.5652 271500.0n 0.3457 271749.9n 0.3457 271750.0n 0.5495 271999.9n 0.5495 272000.0n 0.5652 272249.9n 0.5652 272250.0n 0.5652 272499.9n 0.5652 272500.0n 0.5025 272749.9n 0.5025 272750.0n 0.3457 272999.9n 0.3457 273000.0n 0.4398 273249.9n 0.4398 273250.0n 0.5652 273499.9n 0.5652 273500.0n 0.5652 273749.9n 0.5652 273750.0n 0.5652 273999.9n 0.5652 274000.0n 0.5652 274249.9n 0.5652 274250.0n 0.4398 274499.9n 0.4398 274500.0n 0.4868 274749.9n 0.4868 274750.0n 0.5652 274999.9n 0.5652 275000.0n 0.4241 275249.9n 0.4241 275250.0n 0.5652 275499.9n 0.5652 275500.0n 0.3771 275749.9n 0.3771 275750.0n 0.5652 275999.9n 0.5652 276000.0n 0.4398 276249.9n 0.4398 276250.0n 0.3614 276499.9n 0.3614 276500.0n 0.5652 276749.9n 0.5652 276750.0n 0.3771 276999.9n 0.3771 277000.0n 0.3143 277249.9n 0.3143 277250.0n 0.3143 277499.9n 0.3143 277500.0n 0.4398 277749.9n 0.4398 277750.0n 0.4241 277999.9n 0.4241 278000.0n 0.2830 278249.9n 0.2830 278250.0n 0.3927 278499.9n 0.3927 278500.0n 0.4398 278749.9n 0.4398 278750.0n 0.5652 278999.9n 0.5652 279000.0n 0.3457 279249.9n 0.3457 279250.0n 0.5495 279499.9n 0.5495 279500.0n 0.5652 279749.9n 0.5652 279750.0n 0.5652 279999.9n 0.5652 280000.0n 0.5025 280249.9n 0.5025 280250.0n 0.3457 280499.9n 0.3457 280500.0n 0.4398 280749.9n 0.4398 280750.0n 0.5652 280999.9n 0.5652 281000.0n 0.5652 281249.9n 0.5652 281250.0n 0.5652 281499.9n 0.5652 281500.0n 0.5652 281749.9n 0.5652 281750.0n 0.4398 281999.9n 0.4398 282000.0n 0.4868 282249.9n 0.4868 282250.0n 0.5652 282499.9n 0.5652 282500.0n 0.4241 282749.9n 0.4241 282750.0n 0.5652 282999.9n 0.5652 283000.0n 0.3771 283249.9n 0.3771 283250.0n 0.5652 283499.9n 0.5652 283500.0n 0.4398 283749.9n 0.4398 283750.0n 0.3614 283999.9n 0.3614 284000.0n 0.5652 284249.9n 0.5652 284250.0n 0.3771 284499.9n 0.3771 284500.0n 0.3143 284749.9n 0.3143 284750.0n 0.3143 284999.9n 0.3143 285000.0n 0.4398 285249.9n 0.4398 285250.0n 0.4241 285499.9n 0.4241 285500.0n 0.2830 285749.9n 0.2830 285750.0n 0.3927 285999.9n 0.3927 286000.0n 0.4398 286249.9n 0.4398 286250.0n 0.5652 286499.9n 0.5652 286500.0n 0.3457 286749.9n 0.3457 286750.0n 0.5495 286999.9n 0.5495 287000.0n 0.5652 287249.9n 0.5652 287250.0n 0.5652 287499.9n 0.5652 287500.0n 0.5025 287749.9n 0.5025 287750.0n 0.3457 287999.9n 0.3457 288000.0n 0.4398 288249.9n 0.4398 288250.0n 0.5652 288499.9n 0.5652 288500.0n 0.5652 288749.9n 0.5652 288750.0n 0.5652 288999.9n 0.5652 289000.0n 0.5652 289249.9n 0.5652 289250.0n 0.4398 289499.9n 0.4398 289500.0n 0.4868 289749.9n 0.4868 289750.0n 0.5652 289999.9n 0.5652 290000.0n 0.4241 290249.9n 0.4241 290250.0n 0.5652 290499.9n 0.5652 290500.0n 0.3771 290749.9n 0.3771 290750.0n 0.5652 290999.9n 0.5652 291000.0n 0.4398 291249.9n 0.4398 291250.0n 0.3614 291499.9n 0.3614 291500.0n 0.5652 291749.9n 0.5652 291750.0n 0.3771 291999.9n 0.3771 292000.0n 0.3143 292249.9n 0.3143 292250.0n 0.3143 292499.9n 0.3143 292500.0n 0.4398 292749.9n 0.4398 292750.0n 0.4241 292999.9n 0.4241 293000.0n 0.2830 293249.9n 0.2830 293250.0n 0.3927 293499.9n 0.3927 293500.0n 0.4398 293749.9n 0.4398 293750.0n 0.5652 293999.9n 0.5652 294000.0n 0.3457 294249.9n 0.3457 294250.0n 0.5495 294499.9n 0.5495 294500.0n 0.5652 294749.9n 0.5652 294750.0n 0.5652 294999.9n 0.5652 295000.0n 0.5025 295249.9n 0.5025 295250.0n 0.3457 295499.9n 0.3457 295500.0n 0.4398 295749.9n 0.4398 295750.0n 0.5652 295999.9n 0.5652 296000.0n 0.5652 296249.9n 0.5652 296250.0n 0.5652 296499.9n 0.5652 296500.0n 0.5652 296749.9n 0.5652 296750.0n 0.4398 296999.9n 0.4398 297000.0n 0.4868 297249.9n 0.4868 297250.0n 0.5652 297499.9n 0.5652 297500.0n 0.4241 297749.9n 0.4241 297750.0n 0.5652 297999.9n 0.5652 298000.0n 0.3771 298249.9n 0.3771 298250.0n 0.5652 298499.9n 0.5652 298500.0n 0.4398 298749.9n 0.4398 298750.0n 0.3614 298999.9n 0.3614 299000.0n 0.5652 299249.9n 0.5652 299250.0n 0.3771 299499.9n 0.3771 299500.0n 0.3143 299749.9n 0.3143 299750.0n 0.3143)
Vxp8 a_xp8 0 PWL(0.0n 0.4339 249.9n 0.4339 250.0n 0.5348 499.9n 0.5348 500.0n 0.6189 749.9n 0.6189 750.0n 0.6189 999.9n 0.6189 1000.0n 0.6189 1249.9n 0.6189 1250.0n 0.5516 1499.9n 0.5516 1500.0n 0.5516 1749.9n 0.5516 1750.0n 0.4507 1999.9n 0.4507 2000.0n 0.5011 2249.9n 0.5011 2250.0n 0.4339 2499.9n 0.4339 2500.0n 0.5011 2749.9n 0.5011 2750.0n 0.6189 2999.9n 0.6189 3000.0n 0.5011 3249.9n 0.5011 3250.0n 0.4339 3499.9n 0.4339 3500.0n 0.4339 3749.9n 0.4339 3750.0n 0.4339 3999.9n 0.4339 4000.0n 0.5180 4249.9n 0.5180 4250.0n 0.5852 4499.9n 0.5852 4500.0n 0.4675 4749.9n 0.4675 4750.0n 0.4507 4999.9n 0.4507 5000.0n 0.5180 5249.9n 0.5180 5250.0n 0.4339 5499.9n 0.4339 5500.0n 0.5348 5749.9n 0.5348 5750.0n 0.4339 5999.9n 0.4339 6000.0n 0.4339 6249.9n 0.4339 6250.0n 0.5684 6499.9n 0.5684 6500.0n 0.4339 6749.9n 0.4339 6750.0n 0.6189 6999.9n 0.6189 7000.0n 0.6525 7249.9n 0.6525 7250.0n 0.7198 7499.9n 0.7198 7500.0n 0.4339 7749.9n 0.4339 7750.0n 0.5348 7999.9n 0.5348 8000.0n 0.6189 8249.9n 0.6189 8250.0n 0.6189 8499.9n 0.6189 8500.0n 0.6189 8749.9n 0.6189 8750.0n 0.5516 8999.9n 0.5516 9000.0n 0.5516 9249.9n 0.5516 9250.0n 0.4507 9499.9n 0.4507 9500.0n 0.5011 9749.9n 0.5011 9750.0n 0.4339 9999.9n 0.4339 10000.0n 0.5011 10249.9n 0.5011 10250.0n 0.6189 10499.9n 0.6189 10500.0n 0.5011 10749.9n 0.5011 10750.0n 0.4339 10999.9n 0.4339 11000.0n 0.4339 11249.9n 0.4339 11250.0n 0.4339 11499.9n 0.4339 11500.0n 0.5180 11749.9n 0.5180 11750.0n 0.5852 11999.9n 0.5852 12000.0n 0.4675 12249.9n 0.4675 12250.0n 0.4507 12499.9n 0.4507 12500.0n 0.5180 12749.9n 0.5180 12750.0n 0.4339 12999.9n 0.4339 13000.0n 0.5348 13249.9n 0.5348 13250.0n 0.4339 13499.9n 0.4339 13500.0n 0.4339 13749.9n 0.4339 13750.0n 0.5684 13999.9n 0.5684 14000.0n 0.4339 14249.9n 0.4339 14250.0n 0.6189 14499.9n 0.6189 14500.0n 0.6525 14749.9n 0.6525 14750.0n 0.7198 14999.9n 0.7198 15000.0n 0.4339 15249.9n 0.4339 15250.0n 0.5348 15499.9n 0.5348 15500.0n 0.6189 15749.9n 0.6189 15750.0n 0.6189 15999.9n 0.6189 16000.0n 0.6189 16249.9n 0.6189 16250.0n 0.5516 16499.9n 0.5516 16500.0n 0.5516 16749.9n 0.5516 16750.0n 0.4507 16999.9n 0.4507 17000.0n 0.5011 17249.9n 0.5011 17250.0n 0.4339 17499.9n 0.4339 17500.0n 0.5011 17749.9n 0.5011 17750.0n 0.6189 17999.9n 0.6189 18000.0n 0.5011 18249.9n 0.5011 18250.0n 0.4339 18499.9n 0.4339 18500.0n 0.4339 18749.9n 0.4339 18750.0n 0.4339 18999.9n 0.4339 19000.0n 0.5180 19249.9n 0.5180 19250.0n 0.5852 19499.9n 0.5852 19500.0n 0.4675 19749.9n 0.4675 19750.0n 0.4507 19999.9n 0.4507 20000.0n 0.5180 20249.9n 0.5180 20250.0n 0.4339 20499.9n 0.4339 20500.0n 0.5348 20749.9n 0.5348 20750.0n 0.4339 20999.9n 0.4339 21000.0n 0.4339 21249.9n 0.4339 21250.0n 0.5684 21499.9n 0.5684 21500.0n 0.4339 21749.9n 0.4339 21750.0n 0.6189 21999.9n 0.6189 22000.0n 0.6525 22249.9n 0.6525 22250.0n 0.7198 22499.9n 0.7198 22500.0n 0.4339 22749.9n 0.4339 22750.0n 0.5348 22999.9n 0.5348 23000.0n 0.6189 23249.9n 0.6189 23250.0n 0.6189 23499.9n 0.6189 23500.0n 0.6189 23749.9n 0.6189 23750.0n 0.5516 23999.9n 0.5516 24000.0n 0.5516 24249.9n 0.5516 24250.0n 0.4507 24499.9n 0.4507 24500.0n 0.5011 24749.9n 0.5011 24750.0n 0.4339 24999.9n 0.4339 25000.0n 0.5011 25249.9n 0.5011 25250.0n 0.6189 25499.9n 0.6189 25500.0n 0.5011 25749.9n 0.5011 25750.0n 0.4339 25999.9n 0.4339 26000.0n 0.4339 26249.9n 0.4339 26250.0n 0.4339 26499.9n 0.4339 26500.0n 0.5180 26749.9n 0.5180 26750.0n 0.5852 26999.9n 0.5852 27000.0n 0.4675 27249.9n 0.4675 27250.0n 0.4507 27499.9n 0.4507 27500.0n 0.5180 27749.9n 0.5180 27750.0n 0.4339 27999.9n 0.4339 28000.0n 0.5348 28249.9n 0.5348 28250.0n 0.4339 28499.9n 0.4339 28500.0n 0.4339 28749.9n 0.4339 28750.0n 0.5684 28999.9n 0.5684 29000.0n 0.4339 29249.9n 0.4339 29250.0n 0.6189 29499.9n 0.6189 29500.0n 0.6525 29749.9n 0.6525 29750.0n 0.7198 29999.9n 0.7198 30000.0n 0.4339 30249.9n 0.4339 30250.0n 0.5348 30499.9n 0.5348 30500.0n 0.6189 30749.9n 0.6189 30750.0n 0.6189 30999.9n 0.6189 31000.0n 0.6189 31249.9n 0.6189 31250.0n 0.5516 31499.9n 0.5516 31500.0n 0.5516 31749.9n 0.5516 31750.0n 0.4507 31999.9n 0.4507 32000.0n 0.5011 32249.9n 0.5011 32250.0n 0.4339 32499.9n 0.4339 32500.0n 0.5011 32749.9n 0.5011 32750.0n 0.6189 32999.9n 0.6189 33000.0n 0.5011 33249.9n 0.5011 33250.0n 0.4339 33499.9n 0.4339 33500.0n 0.4339 33749.9n 0.4339 33750.0n 0.4339 33999.9n 0.4339 34000.0n 0.5180 34249.9n 0.5180 34250.0n 0.5852 34499.9n 0.5852 34500.0n 0.4675 34749.9n 0.4675 34750.0n 0.4507 34999.9n 0.4507 35000.0n 0.5180 35249.9n 0.5180 35250.0n 0.4339 35499.9n 0.4339 35500.0n 0.5348 35749.9n 0.5348 35750.0n 0.4339 35999.9n 0.4339 36000.0n 0.4339 36249.9n 0.4339 36250.0n 0.5684 36499.9n 0.5684 36500.0n 0.4339 36749.9n 0.4339 36750.0n 0.6189 36999.9n 0.6189 37000.0n 0.6525 37249.9n 0.6525 37250.0n 0.7198 37499.9n 0.7198 37500.0n 0.4339 37749.9n 0.4339 37750.0n 0.5348 37999.9n 0.5348 38000.0n 0.6189 38249.9n 0.6189 38250.0n 0.6189 38499.9n 0.6189 38500.0n 0.6189 38749.9n 0.6189 38750.0n 0.5516 38999.9n 0.5516 39000.0n 0.5516 39249.9n 0.5516 39250.0n 0.4507 39499.9n 0.4507 39500.0n 0.5011 39749.9n 0.5011 39750.0n 0.4339 39999.9n 0.4339 40000.0n 0.5011 40249.9n 0.5011 40250.0n 0.6189 40499.9n 0.6189 40500.0n 0.5011 40749.9n 0.5011 40750.0n 0.4339 40999.9n 0.4339 41000.0n 0.4339 41249.9n 0.4339 41250.0n 0.4339 41499.9n 0.4339 41500.0n 0.5180 41749.9n 0.5180 41750.0n 0.5852 41999.9n 0.5852 42000.0n 0.4675 42249.9n 0.4675 42250.0n 0.4507 42499.9n 0.4507 42500.0n 0.5180 42749.9n 0.5180 42750.0n 0.4339 42999.9n 0.4339 43000.0n 0.5348 43249.9n 0.5348 43250.0n 0.4339 43499.9n 0.4339 43500.0n 0.4339 43749.9n 0.4339 43750.0n 0.5684 43999.9n 0.5684 44000.0n 0.4339 44249.9n 0.4339 44250.0n 0.6189 44499.9n 0.6189 44500.0n 0.6525 44749.9n 0.6525 44750.0n 0.7198 44999.9n 0.7198 45000.0n 0.4339 45249.9n 0.4339 45250.0n 0.5348 45499.9n 0.5348 45500.0n 0.6189 45749.9n 0.6189 45750.0n 0.6189 45999.9n 0.6189 46000.0n 0.6189 46249.9n 0.6189 46250.0n 0.5516 46499.9n 0.5516 46500.0n 0.5516 46749.9n 0.5516 46750.0n 0.4507 46999.9n 0.4507 47000.0n 0.5011 47249.9n 0.5011 47250.0n 0.4339 47499.9n 0.4339 47500.0n 0.5011 47749.9n 0.5011 47750.0n 0.6189 47999.9n 0.6189 48000.0n 0.5011 48249.9n 0.5011 48250.0n 0.4339 48499.9n 0.4339 48500.0n 0.4339 48749.9n 0.4339 48750.0n 0.4339 48999.9n 0.4339 49000.0n 0.5180 49249.9n 0.5180 49250.0n 0.5852 49499.9n 0.5852 49500.0n 0.4675 49749.9n 0.4675 49750.0n 0.4507 49999.9n 0.4507 50000.0n 0.5180 50249.9n 0.5180 50250.0n 0.4339 50499.9n 0.4339 50500.0n 0.5348 50749.9n 0.5348 50750.0n 0.4339 50999.9n 0.4339 51000.0n 0.4339 51249.9n 0.4339 51250.0n 0.5684 51499.9n 0.5684 51500.0n 0.4339 51749.9n 0.4339 51750.0n 0.6189 51999.9n 0.6189 52000.0n 0.6525 52249.9n 0.6525 52250.0n 0.7198 52499.9n 0.7198 52500.0n 0.4339 52749.9n 0.4339 52750.0n 0.5348 52999.9n 0.5348 53000.0n 0.6189 53249.9n 0.6189 53250.0n 0.6189 53499.9n 0.6189 53500.0n 0.6189 53749.9n 0.6189 53750.0n 0.5516 53999.9n 0.5516 54000.0n 0.5516 54249.9n 0.5516 54250.0n 0.4507 54499.9n 0.4507 54500.0n 0.5011 54749.9n 0.5011 54750.0n 0.4339 54999.9n 0.4339 55000.0n 0.5011 55249.9n 0.5011 55250.0n 0.6189 55499.9n 0.6189 55500.0n 0.5011 55749.9n 0.5011 55750.0n 0.4339 55999.9n 0.4339 56000.0n 0.4339 56249.9n 0.4339 56250.0n 0.4339 56499.9n 0.4339 56500.0n 0.5180 56749.9n 0.5180 56750.0n 0.5852 56999.9n 0.5852 57000.0n 0.4675 57249.9n 0.4675 57250.0n 0.4507 57499.9n 0.4507 57500.0n 0.5180 57749.9n 0.5180 57750.0n 0.4339 57999.9n 0.4339 58000.0n 0.5348 58249.9n 0.5348 58250.0n 0.4339 58499.9n 0.4339 58500.0n 0.4339 58749.9n 0.4339 58750.0n 0.5684 58999.9n 0.5684 59000.0n 0.4339 59249.9n 0.4339 59250.0n 0.6189 59499.9n 0.6189 59500.0n 0.6525 59749.9n 0.6525 59750.0n 0.7198 59999.9n 0.7198 60000.0n 0.4339 60249.9n 0.4339 60250.0n 0.5348 60499.9n 0.5348 60500.0n 0.6189 60749.9n 0.6189 60750.0n 0.6189 60999.9n 0.6189 61000.0n 0.6189 61249.9n 0.6189 61250.0n 0.5516 61499.9n 0.5516 61500.0n 0.5516 61749.9n 0.5516 61750.0n 0.4507 61999.9n 0.4507 62000.0n 0.5011 62249.9n 0.5011 62250.0n 0.4339 62499.9n 0.4339 62500.0n 0.5011 62749.9n 0.5011 62750.0n 0.6189 62999.9n 0.6189 63000.0n 0.5011 63249.9n 0.5011 63250.0n 0.4339 63499.9n 0.4339 63500.0n 0.4339 63749.9n 0.4339 63750.0n 0.4339 63999.9n 0.4339 64000.0n 0.5180 64249.9n 0.5180 64250.0n 0.5852 64499.9n 0.5852 64500.0n 0.4675 64749.9n 0.4675 64750.0n 0.4507 64999.9n 0.4507 65000.0n 0.5180 65249.9n 0.5180 65250.0n 0.4339 65499.9n 0.4339 65500.0n 0.5348 65749.9n 0.5348 65750.0n 0.4339 65999.9n 0.4339 66000.0n 0.4339 66249.9n 0.4339 66250.0n 0.5684 66499.9n 0.5684 66500.0n 0.4339 66749.9n 0.4339 66750.0n 0.6189 66999.9n 0.6189 67000.0n 0.6525 67249.9n 0.6525 67250.0n 0.7198 67499.9n 0.7198 67500.0n 0.4339 67749.9n 0.4339 67750.0n 0.5348 67999.9n 0.5348 68000.0n 0.6189 68249.9n 0.6189 68250.0n 0.6189 68499.9n 0.6189 68500.0n 0.6189 68749.9n 0.6189 68750.0n 0.5516 68999.9n 0.5516 69000.0n 0.5516 69249.9n 0.5516 69250.0n 0.4507 69499.9n 0.4507 69500.0n 0.5011 69749.9n 0.5011 69750.0n 0.4339 69999.9n 0.4339 70000.0n 0.5011 70249.9n 0.5011 70250.0n 0.6189 70499.9n 0.6189 70500.0n 0.5011 70749.9n 0.5011 70750.0n 0.4339 70999.9n 0.4339 71000.0n 0.4339 71249.9n 0.4339 71250.0n 0.4339 71499.9n 0.4339 71500.0n 0.5180 71749.9n 0.5180 71750.0n 0.5852 71999.9n 0.5852 72000.0n 0.4675 72249.9n 0.4675 72250.0n 0.4507 72499.9n 0.4507 72500.0n 0.5180 72749.9n 0.5180 72750.0n 0.4339 72999.9n 0.4339 73000.0n 0.5348 73249.9n 0.5348 73250.0n 0.4339 73499.9n 0.4339 73500.0n 0.4339 73749.9n 0.4339 73750.0n 0.5684 73999.9n 0.5684 74000.0n 0.4339 74249.9n 0.4339 74250.0n 0.6189 74499.9n 0.6189 74500.0n 0.6525 74749.9n 0.6525 74750.0n 0.7198 74999.9n 0.7198 75000.0n 0.4339 75249.9n 0.4339 75250.0n 0.5348 75499.9n 0.5348 75500.0n 0.6189 75749.9n 0.6189 75750.0n 0.6189 75999.9n 0.6189 76000.0n 0.6189 76249.9n 0.6189 76250.0n 0.5516 76499.9n 0.5516 76500.0n 0.5516 76749.9n 0.5516 76750.0n 0.4507 76999.9n 0.4507 77000.0n 0.5011 77249.9n 0.5011 77250.0n 0.4339 77499.9n 0.4339 77500.0n 0.5011 77749.9n 0.5011 77750.0n 0.6189 77999.9n 0.6189 78000.0n 0.5011 78249.9n 0.5011 78250.0n 0.4339 78499.9n 0.4339 78500.0n 0.4339 78749.9n 0.4339 78750.0n 0.4339 78999.9n 0.4339 79000.0n 0.5180 79249.9n 0.5180 79250.0n 0.5852 79499.9n 0.5852 79500.0n 0.4675 79749.9n 0.4675 79750.0n 0.4507 79999.9n 0.4507 80000.0n 0.5180 80249.9n 0.5180 80250.0n 0.4339 80499.9n 0.4339 80500.0n 0.5348 80749.9n 0.5348 80750.0n 0.4339 80999.9n 0.4339 81000.0n 0.4339 81249.9n 0.4339 81250.0n 0.5684 81499.9n 0.5684 81500.0n 0.4339 81749.9n 0.4339 81750.0n 0.6189 81999.9n 0.6189 82000.0n 0.6525 82249.9n 0.6525 82250.0n 0.7198 82499.9n 0.7198 82500.0n 0.4339 82749.9n 0.4339 82750.0n 0.5348 82999.9n 0.5348 83000.0n 0.6189 83249.9n 0.6189 83250.0n 0.6189 83499.9n 0.6189 83500.0n 0.6189 83749.9n 0.6189 83750.0n 0.5516 83999.9n 0.5516 84000.0n 0.5516 84249.9n 0.5516 84250.0n 0.4507 84499.9n 0.4507 84500.0n 0.5011 84749.9n 0.5011 84750.0n 0.4339 84999.9n 0.4339 85000.0n 0.5011 85249.9n 0.5011 85250.0n 0.6189 85499.9n 0.6189 85500.0n 0.5011 85749.9n 0.5011 85750.0n 0.4339 85999.9n 0.4339 86000.0n 0.4339 86249.9n 0.4339 86250.0n 0.4339 86499.9n 0.4339 86500.0n 0.5180 86749.9n 0.5180 86750.0n 0.5852 86999.9n 0.5852 87000.0n 0.4675 87249.9n 0.4675 87250.0n 0.4507 87499.9n 0.4507 87500.0n 0.5180 87749.9n 0.5180 87750.0n 0.4339 87999.9n 0.4339 88000.0n 0.5348 88249.9n 0.5348 88250.0n 0.4339 88499.9n 0.4339 88500.0n 0.4339 88749.9n 0.4339 88750.0n 0.5684 88999.9n 0.5684 89000.0n 0.4339 89249.9n 0.4339 89250.0n 0.6189 89499.9n 0.6189 89500.0n 0.6525 89749.9n 0.6525 89750.0n 0.7198 89999.9n 0.7198 90000.0n 0.4339 90249.9n 0.4339 90250.0n 0.5348 90499.9n 0.5348 90500.0n 0.6189 90749.9n 0.6189 90750.0n 0.6189 90999.9n 0.6189 91000.0n 0.6189 91249.9n 0.6189 91250.0n 0.5516 91499.9n 0.5516 91500.0n 0.5516 91749.9n 0.5516 91750.0n 0.4507 91999.9n 0.4507 92000.0n 0.5011 92249.9n 0.5011 92250.0n 0.4339 92499.9n 0.4339 92500.0n 0.5011 92749.9n 0.5011 92750.0n 0.6189 92999.9n 0.6189 93000.0n 0.5011 93249.9n 0.5011 93250.0n 0.4339 93499.9n 0.4339 93500.0n 0.4339 93749.9n 0.4339 93750.0n 0.4339 93999.9n 0.4339 94000.0n 0.5180 94249.9n 0.5180 94250.0n 0.5852 94499.9n 0.5852 94500.0n 0.4675 94749.9n 0.4675 94750.0n 0.4507 94999.9n 0.4507 95000.0n 0.5180 95249.9n 0.5180 95250.0n 0.4339 95499.9n 0.4339 95500.0n 0.5348 95749.9n 0.5348 95750.0n 0.4339 95999.9n 0.4339 96000.0n 0.4339 96249.9n 0.4339 96250.0n 0.5684 96499.9n 0.5684 96500.0n 0.4339 96749.9n 0.4339 96750.0n 0.6189 96999.9n 0.6189 97000.0n 0.6525 97249.9n 0.6525 97250.0n 0.7198 97499.9n 0.7198 97500.0n 0.4339 97749.9n 0.4339 97750.0n 0.5348 97999.9n 0.5348 98000.0n 0.6189 98249.9n 0.6189 98250.0n 0.6189 98499.9n 0.6189 98500.0n 0.6189 98749.9n 0.6189 98750.0n 0.5516 98999.9n 0.5516 99000.0n 0.5516 99249.9n 0.5516 99250.0n 0.4507 99499.9n 0.4507 99500.0n 0.5011 99749.9n 0.5011 99750.0n 0.4339 99999.9n 0.4339 100000.0n 0.5011 100249.9n 0.5011 100250.0n 0.6189 100499.9n 0.6189 100500.0n 0.5011 100749.9n 0.5011 100750.0n 0.4339 100999.9n 0.4339 101000.0n 0.4339 101249.9n 0.4339 101250.0n 0.4339 101499.9n 0.4339 101500.0n 0.5180 101749.9n 0.5180 101750.0n 0.5852 101999.9n 0.5852 102000.0n 0.4675 102249.9n 0.4675 102250.0n 0.4507 102499.9n 0.4507 102500.0n 0.5180 102749.9n 0.5180 102750.0n 0.4339 102999.9n 0.4339 103000.0n 0.5348 103249.9n 0.5348 103250.0n 0.4339 103499.9n 0.4339 103500.0n 0.4339 103749.9n 0.4339 103750.0n 0.5684 103999.9n 0.5684 104000.0n 0.4339 104249.9n 0.4339 104250.0n 0.6189 104499.9n 0.6189 104500.0n 0.6525 104749.9n 0.6525 104750.0n 0.7198 104999.9n 0.7198 105000.0n 0.4339 105249.9n 0.4339 105250.0n 0.5348 105499.9n 0.5348 105500.0n 0.6189 105749.9n 0.6189 105750.0n 0.6189 105999.9n 0.6189 106000.0n 0.6189 106249.9n 0.6189 106250.0n 0.5516 106499.9n 0.5516 106500.0n 0.5516 106749.9n 0.5516 106750.0n 0.4507 106999.9n 0.4507 107000.0n 0.5011 107249.9n 0.5011 107250.0n 0.4339 107499.9n 0.4339 107500.0n 0.5011 107749.9n 0.5011 107750.0n 0.6189 107999.9n 0.6189 108000.0n 0.5011 108249.9n 0.5011 108250.0n 0.4339 108499.9n 0.4339 108500.0n 0.4339 108749.9n 0.4339 108750.0n 0.4339 108999.9n 0.4339 109000.0n 0.5180 109249.9n 0.5180 109250.0n 0.5852 109499.9n 0.5852 109500.0n 0.4675 109749.9n 0.4675 109750.0n 0.4507 109999.9n 0.4507 110000.0n 0.5180 110249.9n 0.5180 110250.0n 0.4339 110499.9n 0.4339 110500.0n 0.5348 110749.9n 0.5348 110750.0n 0.4339 110999.9n 0.4339 111000.0n 0.4339 111249.9n 0.4339 111250.0n 0.5684 111499.9n 0.5684 111500.0n 0.4339 111749.9n 0.4339 111750.0n 0.6189 111999.9n 0.6189 112000.0n 0.6525 112249.9n 0.6525 112250.0n 0.7198 112499.9n 0.7198 112500.0n 0.4339 112749.9n 0.4339 112750.0n 0.5348 112999.9n 0.5348 113000.0n 0.6189 113249.9n 0.6189 113250.0n 0.6189 113499.9n 0.6189 113500.0n 0.6189 113749.9n 0.6189 113750.0n 0.5516 113999.9n 0.5516 114000.0n 0.5516 114249.9n 0.5516 114250.0n 0.4507 114499.9n 0.4507 114500.0n 0.5011 114749.9n 0.5011 114750.0n 0.4339 114999.9n 0.4339 115000.0n 0.5011 115249.9n 0.5011 115250.0n 0.6189 115499.9n 0.6189 115500.0n 0.5011 115749.9n 0.5011 115750.0n 0.4339 115999.9n 0.4339 116000.0n 0.4339 116249.9n 0.4339 116250.0n 0.4339 116499.9n 0.4339 116500.0n 0.5180 116749.9n 0.5180 116750.0n 0.5852 116999.9n 0.5852 117000.0n 0.4675 117249.9n 0.4675 117250.0n 0.4507 117499.9n 0.4507 117500.0n 0.5180 117749.9n 0.5180 117750.0n 0.4339 117999.9n 0.4339 118000.0n 0.5348 118249.9n 0.5348 118250.0n 0.4339 118499.9n 0.4339 118500.0n 0.4339 118749.9n 0.4339 118750.0n 0.5684 118999.9n 0.5684 119000.0n 0.4339 119249.9n 0.4339 119250.0n 0.6189 119499.9n 0.6189 119500.0n 0.6525 119749.9n 0.6525 119750.0n 0.7198 119999.9n 0.7198 120000.0n 0.4339 120249.9n 0.4339 120250.0n 0.5348 120499.9n 0.5348 120500.0n 0.6189 120749.9n 0.6189 120750.0n 0.6189 120999.9n 0.6189 121000.0n 0.6189 121249.9n 0.6189 121250.0n 0.5516 121499.9n 0.5516 121500.0n 0.5516 121749.9n 0.5516 121750.0n 0.4507 121999.9n 0.4507 122000.0n 0.5011 122249.9n 0.5011 122250.0n 0.4339 122499.9n 0.4339 122500.0n 0.5011 122749.9n 0.5011 122750.0n 0.6189 122999.9n 0.6189 123000.0n 0.5011 123249.9n 0.5011 123250.0n 0.4339 123499.9n 0.4339 123500.0n 0.4339 123749.9n 0.4339 123750.0n 0.4339 123999.9n 0.4339 124000.0n 0.5180 124249.9n 0.5180 124250.0n 0.5852 124499.9n 0.5852 124500.0n 0.4675 124749.9n 0.4675 124750.0n 0.4507 124999.9n 0.4507 125000.0n 0.5180 125249.9n 0.5180 125250.0n 0.4339 125499.9n 0.4339 125500.0n 0.5348 125749.9n 0.5348 125750.0n 0.4339 125999.9n 0.4339 126000.0n 0.4339 126249.9n 0.4339 126250.0n 0.5684 126499.9n 0.5684 126500.0n 0.4339 126749.9n 0.4339 126750.0n 0.6189 126999.9n 0.6189 127000.0n 0.6525 127249.9n 0.6525 127250.0n 0.7198 127499.9n 0.7198 127500.0n 0.4339 127749.9n 0.4339 127750.0n 0.5348 127999.9n 0.5348 128000.0n 0.6189 128249.9n 0.6189 128250.0n 0.6189 128499.9n 0.6189 128500.0n 0.6189 128749.9n 0.6189 128750.0n 0.5516 128999.9n 0.5516 129000.0n 0.5516 129249.9n 0.5516 129250.0n 0.4507 129499.9n 0.4507 129500.0n 0.5011 129749.9n 0.5011 129750.0n 0.4339 129999.9n 0.4339 130000.0n 0.5011 130249.9n 0.5011 130250.0n 0.6189 130499.9n 0.6189 130500.0n 0.5011 130749.9n 0.5011 130750.0n 0.4339 130999.9n 0.4339 131000.0n 0.4339 131249.9n 0.4339 131250.0n 0.4339 131499.9n 0.4339 131500.0n 0.5180 131749.9n 0.5180 131750.0n 0.5852 131999.9n 0.5852 132000.0n 0.4675 132249.9n 0.4675 132250.0n 0.4507 132499.9n 0.4507 132500.0n 0.5180 132749.9n 0.5180 132750.0n 0.4339 132999.9n 0.4339 133000.0n 0.5348 133249.9n 0.5348 133250.0n 0.4339 133499.9n 0.4339 133500.0n 0.4339 133749.9n 0.4339 133750.0n 0.5684 133999.9n 0.5684 134000.0n 0.4339 134249.9n 0.4339 134250.0n 0.6189 134499.9n 0.6189 134500.0n 0.6525 134749.9n 0.6525 134750.0n 0.7198 134999.9n 0.7198 135000.0n 0.4339 135249.9n 0.4339 135250.0n 0.5348 135499.9n 0.5348 135500.0n 0.6189 135749.9n 0.6189 135750.0n 0.6189 135999.9n 0.6189 136000.0n 0.6189 136249.9n 0.6189 136250.0n 0.5516 136499.9n 0.5516 136500.0n 0.5516 136749.9n 0.5516 136750.0n 0.4507 136999.9n 0.4507 137000.0n 0.5011 137249.9n 0.5011 137250.0n 0.4339 137499.9n 0.4339 137500.0n 0.5011 137749.9n 0.5011 137750.0n 0.6189 137999.9n 0.6189 138000.0n 0.5011 138249.9n 0.5011 138250.0n 0.4339 138499.9n 0.4339 138500.0n 0.4339 138749.9n 0.4339 138750.0n 0.4339 138999.9n 0.4339 139000.0n 0.5180 139249.9n 0.5180 139250.0n 0.5852 139499.9n 0.5852 139500.0n 0.4675 139749.9n 0.4675 139750.0n 0.4507 139999.9n 0.4507 140000.0n 0.5180 140249.9n 0.5180 140250.0n 0.4339 140499.9n 0.4339 140500.0n 0.5348 140749.9n 0.5348 140750.0n 0.4339 140999.9n 0.4339 141000.0n 0.4339 141249.9n 0.4339 141250.0n 0.5684 141499.9n 0.5684 141500.0n 0.4339 141749.9n 0.4339 141750.0n 0.6189 141999.9n 0.6189 142000.0n 0.6525 142249.9n 0.6525 142250.0n 0.7198 142499.9n 0.7198 142500.0n 0.4339 142749.9n 0.4339 142750.0n 0.5348 142999.9n 0.5348 143000.0n 0.6189 143249.9n 0.6189 143250.0n 0.6189 143499.9n 0.6189 143500.0n 0.6189 143749.9n 0.6189 143750.0n 0.5516 143999.9n 0.5516 144000.0n 0.5516 144249.9n 0.5516 144250.0n 0.4507 144499.9n 0.4507 144500.0n 0.5011 144749.9n 0.5011 144750.0n 0.4339 144999.9n 0.4339 145000.0n 0.5011 145249.9n 0.5011 145250.0n 0.6189 145499.9n 0.6189 145500.0n 0.5011 145749.9n 0.5011 145750.0n 0.4339 145999.9n 0.4339 146000.0n 0.4339 146249.9n 0.4339 146250.0n 0.4339 146499.9n 0.4339 146500.0n 0.5180 146749.9n 0.5180 146750.0n 0.5852 146999.9n 0.5852 147000.0n 0.4675 147249.9n 0.4675 147250.0n 0.4507 147499.9n 0.4507 147500.0n 0.5180 147749.9n 0.5180 147750.0n 0.4339 147999.9n 0.4339 148000.0n 0.5348 148249.9n 0.5348 148250.0n 0.4339 148499.9n 0.4339 148500.0n 0.4339 148749.9n 0.4339 148750.0n 0.5684 148999.9n 0.5684 149000.0n 0.4339 149249.9n 0.4339 149250.0n 0.6189 149499.9n 0.6189 149500.0n 0.6525 149749.9n 0.6525 149750.0n 0.7198 149999.9n 0.7198 150000.0n 0.4339 150249.9n 0.4339 150250.0n 0.5348 150499.9n 0.5348 150500.0n 0.6189 150749.9n 0.6189 150750.0n 0.6189 150999.9n 0.6189 151000.0n 0.6189 151249.9n 0.6189 151250.0n 0.5516 151499.9n 0.5516 151500.0n 0.5516 151749.9n 0.5516 151750.0n 0.4507 151999.9n 0.4507 152000.0n 0.5011 152249.9n 0.5011 152250.0n 0.4339 152499.9n 0.4339 152500.0n 0.5011 152749.9n 0.5011 152750.0n 0.6189 152999.9n 0.6189 153000.0n 0.5011 153249.9n 0.5011 153250.0n 0.4339 153499.9n 0.4339 153500.0n 0.4339 153749.9n 0.4339 153750.0n 0.4339 153999.9n 0.4339 154000.0n 0.5180 154249.9n 0.5180 154250.0n 0.5852 154499.9n 0.5852 154500.0n 0.4675 154749.9n 0.4675 154750.0n 0.4507 154999.9n 0.4507 155000.0n 0.5180 155249.9n 0.5180 155250.0n 0.4339 155499.9n 0.4339 155500.0n 0.5348 155749.9n 0.5348 155750.0n 0.4339 155999.9n 0.4339 156000.0n 0.4339 156249.9n 0.4339 156250.0n 0.5684 156499.9n 0.5684 156500.0n 0.4339 156749.9n 0.4339 156750.0n 0.6189 156999.9n 0.6189 157000.0n 0.6525 157249.9n 0.6525 157250.0n 0.7198 157499.9n 0.7198 157500.0n 0.4339 157749.9n 0.4339 157750.0n 0.5348 157999.9n 0.5348 158000.0n 0.6189 158249.9n 0.6189 158250.0n 0.6189 158499.9n 0.6189 158500.0n 0.6189 158749.9n 0.6189 158750.0n 0.5516 158999.9n 0.5516 159000.0n 0.5516 159249.9n 0.5516 159250.0n 0.4507 159499.9n 0.4507 159500.0n 0.5011 159749.9n 0.5011 159750.0n 0.4339 159999.9n 0.4339 160000.0n 0.5011 160249.9n 0.5011 160250.0n 0.6189 160499.9n 0.6189 160500.0n 0.5011 160749.9n 0.5011 160750.0n 0.4339 160999.9n 0.4339 161000.0n 0.4339 161249.9n 0.4339 161250.0n 0.4339 161499.9n 0.4339 161500.0n 0.5180 161749.9n 0.5180 161750.0n 0.5852 161999.9n 0.5852 162000.0n 0.4675 162249.9n 0.4675 162250.0n 0.4507 162499.9n 0.4507 162500.0n 0.5180 162749.9n 0.5180 162750.0n 0.4339 162999.9n 0.4339 163000.0n 0.5348 163249.9n 0.5348 163250.0n 0.4339 163499.9n 0.4339 163500.0n 0.4339 163749.9n 0.4339 163750.0n 0.5684 163999.9n 0.5684 164000.0n 0.4339 164249.9n 0.4339 164250.0n 0.6189 164499.9n 0.6189 164500.0n 0.6525 164749.9n 0.6525 164750.0n 0.7198 164999.9n 0.7198 165000.0n 0.4339 165249.9n 0.4339 165250.0n 0.5348 165499.9n 0.5348 165500.0n 0.6189 165749.9n 0.6189 165750.0n 0.6189 165999.9n 0.6189 166000.0n 0.6189 166249.9n 0.6189 166250.0n 0.5516 166499.9n 0.5516 166500.0n 0.5516 166749.9n 0.5516 166750.0n 0.4507 166999.9n 0.4507 167000.0n 0.5011 167249.9n 0.5011 167250.0n 0.4339 167499.9n 0.4339 167500.0n 0.5011 167749.9n 0.5011 167750.0n 0.6189 167999.9n 0.6189 168000.0n 0.5011 168249.9n 0.5011 168250.0n 0.4339 168499.9n 0.4339 168500.0n 0.4339 168749.9n 0.4339 168750.0n 0.4339 168999.9n 0.4339 169000.0n 0.5180 169249.9n 0.5180 169250.0n 0.5852 169499.9n 0.5852 169500.0n 0.4675 169749.9n 0.4675 169750.0n 0.4507 169999.9n 0.4507 170000.0n 0.5180 170249.9n 0.5180 170250.0n 0.4339 170499.9n 0.4339 170500.0n 0.5348 170749.9n 0.5348 170750.0n 0.4339 170999.9n 0.4339 171000.0n 0.4339 171249.9n 0.4339 171250.0n 0.5684 171499.9n 0.5684 171500.0n 0.4339 171749.9n 0.4339 171750.0n 0.6189 171999.9n 0.6189 172000.0n 0.6525 172249.9n 0.6525 172250.0n 0.7198 172499.9n 0.7198 172500.0n 0.4339 172749.9n 0.4339 172750.0n 0.5348 172999.9n 0.5348 173000.0n 0.6189 173249.9n 0.6189 173250.0n 0.6189 173499.9n 0.6189 173500.0n 0.6189 173749.9n 0.6189 173750.0n 0.5516 173999.9n 0.5516 174000.0n 0.5516 174249.9n 0.5516 174250.0n 0.4507 174499.9n 0.4507 174500.0n 0.5011 174749.9n 0.5011 174750.0n 0.4339 174999.9n 0.4339 175000.0n 0.5011 175249.9n 0.5011 175250.0n 0.6189 175499.9n 0.6189 175500.0n 0.5011 175749.9n 0.5011 175750.0n 0.4339 175999.9n 0.4339 176000.0n 0.4339 176249.9n 0.4339 176250.0n 0.4339 176499.9n 0.4339 176500.0n 0.5180 176749.9n 0.5180 176750.0n 0.5852 176999.9n 0.5852 177000.0n 0.4675 177249.9n 0.4675 177250.0n 0.4507 177499.9n 0.4507 177500.0n 0.5180 177749.9n 0.5180 177750.0n 0.4339 177999.9n 0.4339 178000.0n 0.5348 178249.9n 0.5348 178250.0n 0.4339 178499.9n 0.4339 178500.0n 0.4339 178749.9n 0.4339 178750.0n 0.5684 178999.9n 0.5684 179000.0n 0.4339 179249.9n 0.4339 179250.0n 0.6189 179499.9n 0.6189 179500.0n 0.6525 179749.9n 0.6525 179750.0n 0.7198 179999.9n 0.7198 180000.0n 0.4339 180249.9n 0.4339 180250.0n 0.5348 180499.9n 0.5348 180500.0n 0.6189 180749.9n 0.6189 180750.0n 0.6189 180999.9n 0.6189 181000.0n 0.6189 181249.9n 0.6189 181250.0n 0.5516 181499.9n 0.5516 181500.0n 0.5516 181749.9n 0.5516 181750.0n 0.4507 181999.9n 0.4507 182000.0n 0.5011 182249.9n 0.5011 182250.0n 0.4339 182499.9n 0.4339 182500.0n 0.5011 182749.9n 0.5011 182750.0n 0.6189 182999.9n 0.6189 183000.0n 0.5011 183249.9n 0.5011 183250.0n 0.4339 183499.9n 0.4339 183500.0n 0.4339 183749.9n 0.4339 183750.0n 0.4339 183999.9n 0.4339 184000.0n 0.5180 184249.9n 0.5180 184250.0n 0.5852 184499.9n 0.5852 184500.0n 0.4675 184749.9n 0.4675 184750.0n 0.4507 184999.9n 0.4507 185000.0n 0.5180 185249.9n 0.5180 185250.0n 0.4339 185499.9n 0.4339 185500.0n 0.5348 185749.9n 0.5348 185750.0n 0.4339 185999.9n 0.4339 186000.0n 0.4339 186249.9n 0.4339 186250.0n 0.5684 186499.9n 0.5684 186500.0n 0.4339 186749.9n 0.4339 186750.0n 0.6189 186999.9n 0.6189 187000.0n 0.6525 187249.9n 0.6525 187250.0n 0.7198 187499.9n 0.7198 187500.0n 0.4339 187749.9n 0.4339 187750.0n 0.5348 187999.9n 0.5348 188000.0n 0.6189 188249.9n 0.6189 188250.0n 0.6189 188499.9n 0.6189 188500.0n 0.6189 188749.9n 0.6189 188750.0n 0.5516 188999.9n 0.5516 189000.0n 0.5516 189249.9n 0.5516 189250.0n 0.4507 189499.9n 0.4507 189500.0n 0.5011 189749.9n 0.5011 189750.0n 0.4339 189999.9n 0.4339 190000.0n 0.5011 190249.9n 0.5011 190250.0n 0.6189 190499.9n 0.6189 190500.0n 0.5011 190749.9n 0.5011 190750.0n 0.4339 190999.9n 0.4339 191000.0n 0.4339 191249.9n 0.4339 191250.0n 0.4339 191499.9n 0.4339 191500.0n 0.5180 191749.9n 0.5180 191750.0n 0.5852 191999.9n 0.5852 192000.0n 0.4675 192249.9n 0.4675 192250.0n 0.4507 192499.9n 0.4507 192500.0n 0.5180 192749.9n 0.5180 192750.0n 0.4339 192999.9n 0.4339 193000.0n 0.5348 193249.9n 0.5348 193250.0n 0.4339 193499.9n 0.4339 193500.0n 0.4339 193749.9n 0.4339 193750.0n 0.5684 193999.9n 0.5684 194000.0n 0.4339 194249.9n 0.4339 194250.0n 0.6189 194499.9n 0.6189 194500.0n 0.6525 194749.9n 0.6525 194750.0n 0.7198 194999.9n 0.7198 195000.0n 0.4339 195249.9n 0.4339 195250.0n 0.5348 195499.9n 0.5348 195500.0n 0.6189 195749.9n 0.6189 195750.0n 0.6189 195999.9n 0.6189 196000.0n 0.6189 196249.9n 0.6189 196250.0n 0.5516 196499.9n 0.5516 196500.0n 0.5516 196749.9n 0.5516 196750.0n 0.4507 196999.9n 0.4507 197000.0n 0.5011 197249.9n 0.5011 197250.0n 0.4339 197499.9n 0.4339 197500.0n 0.5011 197749.9n 0.5011 197750.0n 0.6189 197999.9n 0.6189 198000.0n 0.5011 198249.9n 0.5011 198250.0n 0.4339 198499.9n 0.4339 198500.0n 0.4339 198749.9n 0.4339 198750.0n 0.4339 198999.9n 0.4339 199000.0n 0.5180 199249.9n 0.5180 199250.0n 0.5852 199499.9n 0.5852 199500.0n 0.4675 199749.9n 0.4675 199750.0n 0.4507 199999.9n 0.4507 200000.0n 0.5180 200249.9n 0.5180 200250.0n 0.4339 200499.9n 0.4339 200500.0n 0.5348 200749.9n 0.5348 200750.0n 0.4339 200999.9n 0.4339 201000.0n 0.4339 201249.9n 0.4339 201250.0n 0.5684 201499.9n 0.5684 201500.0n 0.4339 201749.9n 0.4339 201750.0n 0.6189 201999.9n 0.6189 202000.0n 0.6525 202249.9n 0.6525 202250.0n 0.7198 202499.9n 0.7198 202500.0n 0.4339 202749.9n 0.4339 202750.0n 0.5348 202999.9n 0.5348 203000.0n 0.6189 203249.9n 0.6189 203250.0n 0.6189 203499.9n 0.6189 203500.0n 0.6189 203749.9n 0.6189 203750.0n 0.5516 203999.9n 0.5516 204000.0n 0.5516 204249.9n 0.5516 204250.0n 0.4507 204499.9n 0.4507 204500.0n 0.5011 204749.9n 0.5011 204750.0n 0.4339 204999.9n 0.4339 205000.0n 0.5011 205249.9n 0.5011 205250.0n 0.6189 205499.9n 0.6189 205500.0n 0.5011 205749.9n 0.5011 205750.0n 0.4339 205999.9n 0.4339 206000.0n 0.4339 206249.9n 0.4339 206250.0n 0.4339 206499.9n 0.4339 206500.0n 0.5180 206749.9n 0.5180 206750.0n 0.5852 206999.9n 0.5852 207000.0n 0.4675 207249.9n 0.4675 207250.0n 0.4507 207499.9n 0.4507 207500.0n 0.5180 207749.9n 0.5180 207750.0n 0.4339 207999.9n 0.4339 208000.0n 0.5348 208249.9n 0.5348 208250.0n 0.4339 208499.9n 0.4339 208500.0n 0.4339 208749.9n 0.4339 208750.0n 0.5684 208999.9n 0.5684 209000.0n 0.4339 209249.9n 0.4339 209250.0n 0.6189 209499.9n 0.6189 209500.0n 0.6525 209749.9n 0.6525 209750.0n 0.7198 209999.9n 0.7198 210000.0n 0.4339 210249.9n 0.4339 210250.0n 0.5348 210499.9n 0.5348 210500.0n 0.6189 210749.9n 0.6189 210750.0n 0.6189 210999.9n 0.6189 211000.0n 0.6189 211249.9n 0.6189 211250.0n 0.5516 211499.9n 0.5516 211500.0n 0.5516 211749.9n 0.5516 211750.0n 0.4507 211999.9n 0.4507 212000.0n 0.5011 212249.9n 0.5011 212250.0n 0.4339 212499.9n 0.4339 212500.0n 0.5011 212749.9n 0.5011 212750.0n 0.6189 212999.9n 0.6189 213000.0n 0.5011 213249.9n 0.5011 213250.0n 0.4339 213499.9n 0.4339 213500.0n 0.4339 213749.9n 0.4339 213750.0n 0.4339 213999.9n 0.4339 214000.0n 0.5180 214249.9n 0.5180 214250.0n 0.5852 214499.9n 0.5852 214500.0n 0.4675 214749.9n 0.4675 214750.0n 0.4507 214999.9n 0.4507 215000.0n 0.5180 215249.9n 0.5180 215250.0n 0.4339 215499.9n 0.4339 215500.0n 0.5348 215749.9n 0.5348 215750.0n 0.4339 215999.9n 0.4339 216000.0n 0.4339 216249.9n 0.4339 216250.0n 0.5684 216499.9n 0.5684 216500.0n 0.4339 216749.9n 0.4339 216750.0n 0.6189 216999.9n 0.6189 217000.0n 0.6525 217249.9n 0.6525 217250.0n 0.7198 217499.9n 0.7198 217500.0n 0.4339 217749.9n 0.4339 217750.0n 0.5348 217999.9n 0.5348 218000.0n 0.6189 218249.9n 0.6189 218250.0n 0.6189 218499.9n 0.6189 218500.0n 0.6189 218749.9n 0.6189 218750.0n 0.5516 218999.9n 0.5516 219000.0n 0.5516 219249.9n 0.5516 219250.0n 0.4507 219499.9n 0.4507 219500.0n 0.5011 219749.9n 0.5011 219750.0n 0.4339 219999.9n 0.4339 220000.0n 0.5011 220249.9n 0.5011 220250.0n 0.6189 220499.9n 0.6189 220500.0n 0.5011 220749.9n 0.5011 220750.0n 0.4339 220999.9n 0.4339 221000.0n 0.4339 221249.9n 0.4339 221250.0n 0.4339 221499.9n 0.4339 221500.0n 0.5180 221749.9n 0.5180 221750.0n 0.5852 221999.9n 0.5852 222000.0n 0.4675 222249.9n 0.4675 222250.0n 0.4507 222499.9n 0.4507 222500.0n 0.5180 222749.9n 0.5180 222750.0n 0.4339 222999.9n 0.4339 223000.0n 0.5348 223249.9n 0.5348 223250.0n 0.4339 223499.9n 0.4339 223500.0n 0.4339 223749.9n 0.4339 223750.0n 0.5684 223999.9n 0.5684 224000.0n 0.4339 224249.9n 0.4339 224250.0n 0.6189 224499.9n 0.6189 224500.0n 0.6525 224749.9n 0.6525 224750.0n 0.7198 224999.9n 0.7198 225000.0n 0.4339 225249.9n 0.4339 225250.0n 0.5348 225499.9n 0.5348 225500.0n 0.6189 225749.9n 0.6189 225750.0n 0.6189 225999.9n 0.6189 226000.0n 0.6189 226249.9n 0.6189 226250.0n 0.5516 226499.9n 0.5516 226500.0n 0.5516 226749.9n 0.5516 226750.0n 0.4507 226999.9n 0.4507 227000.0n 0.5011 227249.9n 0.5011 227250.0n 0.4339 227499.9n 0.4339 227500.0n 0.5011 227749.9n 0.5011 227750.0n 0.6189 227999.9n 0.6189 228000.0n 0.5011 228249.9n 0.5011 228250.0n 0.4339 228499.9n 0.4339 228500.0n 0.4339 228749.9n 0.4339 228750.0n 0.4339 228999.9n 0.4339 229000.0n 0.5180 229249.9n 0.5180 229250.0n 0.5852 229499.9n 0.5852 229500.0n 0.4675 229749.9n 0.4675 229750.0n 0.4507 229999.9n 0.4507 230000.0n 0.5180 230249.9n 0.5180 230250.0n 0.4339 230499.9n 0.4339 230500.0n 0.5348 230749.9n 0.5348 230750.0n 0.4339 230999.9n 0.4339 231000.0n 0.4339 231249.9n 0.4339 231250.0n 0.5684 231499.9n 0.5684 231500.0n 0.4339 231749.9n 0.4339 231750.0n 0.6189 231999.9n 0.6189 232000.0n 0.6525 232249.9n 0.6525 232250.0n 0.7198 232499.9n 0.7198 232500.0n 0.4339 232749.9n 0.4339 232750.0n 0.5348 232999.9n 0.5348 233000.0n 0.6189 233249.9n 0.6189 233250.0n 0.6189 233499.9n 0.6189 233500.0n 0.6189 233749.9n 0.6189 233750.0n 0.5516 233999.9n 0.5516 234000.0n 0.5516 234249.9n 0.5516 234250.0n 0.4507 234499.9n 0.4507 234500.0n 0.5011 234749.9n 0.5011 234750.0n 0.4339 234999.9n 0.4339 235000.0n 0.5011 235249.9n 0.5011 235250.0n 0.6189 235499.9n 0.6189 235500.0n 0.5011 235749.9n 0.5011 235750.0n 0.4339 235999.9n 0.4339 236000.0n 0.4339 236249.9n 0.4339 236250.0n 0.4339 236499.9n 0.4339 236500.0n 0.5180 236749.9n 0.5180 236750.0n 0.5852 236999.9n 0.5852 237000.0n 0.4675 237249.9n 0.4675 237250.0n 0.4507 237499.9n 0.4507 237500.0n 0.5180 237749.9n 0.5180 237750.0n 0.4339 237999.9n 0.4339 238000.0n 0.5348 238249.9n 0.5348 238250.0n 0.4339 238499.9n 0.4339 238500.0n 0.4339 238749.9n 0.4339 238750.0n 0.5684 238999.9n 0.5684 239000.0n 0.4339 239249.9n 0.4339 239250.0n 0.6189 239499.9n 0.6189 239500.0n 0.6525 239749.9n 0.6525 239750.0n 0.7198 239999.9n 0.7198 240000.0n 0.4339 240249.9n 0.4339 240250.0n 0.5348 240499.9n 0.5348 240500.0n 0.6189 240749.9n 0.6189 240750.0n 0.6189 240999.9n 0.6189 241000.0n 0.6189 241249.9n 0.6189 241250.0n 0.5516 241499.9n 0.5516 241500.0n 0.5516 241749.9n 0.5516 241750.0n 0.4507 241999.9n 0.4507 242000.0n 0.5011 242249.9n 0.5011 242250.0n 0.4339 242499.9n 0.4339 242500.0n 0.5011 242749.9n 0.5011 242750.0n 0.6189 242999.9n 0.6189 243000.0n 0.5011 243249.9n 0.5011 243250.0n 0.4339 243499.9n 0.4339 243500.0n 0.4339 243749.9n 0.4339 243750.0n 0.4339 243999.9n 0.4339 244000.0n 0.5180 244249.9n 0.5180 244250.0n 0.5852 244499.9n 0.5852 244500.0n 0.4675 244749.9n 0.4675 244750.0n 0.4507 244999.9n 0.4507 245000.0n 0.5180 245249.9n 0.5180 245250.0n 0.4339 245499.9n 0.4339 245500.0n 0.5348 245749.9n 0.5348 245750.0n 0.4339 245999.9n 0.4339 246000.0n 0.4339 246249.9n 0.4339 246250.0n 0.5684 246499.9n 0.5684 246500.0n 0.4339 246749.9n 0.4339 246750.0n 0.6189 246999.9n 0.6189 247000.0n 0.6525 247249.9n 0.6525 247250.0n 0.7198 247499.9n 0.7198 247500.0n 0.4339 247749.9n 0.4339 247750.0n 0.5348 247999.9n 0.5348 248000.0n 0.6189 248249.9n 0.6189 248250.0n 0.6189 248499.9n 0.6189 248500.0n 0.6189 248749.9n 0.6189 248750.0n 0.5516 248999.9n 0.5516 249000.0n 0.5516 249249.9n 0.5516 249250.0n 0.4507 249499.9n 0.4507 249500.0n 0.5011 249749.9n 0.5011 249750.0n 0.4339 249999.9n 0.4339 250000.0n 0.5011 250249.9n 0.5011 250250.0n 0.6189 250499.9n 0.6189 250500.0n 0.5011 250749.9n 0.5011 250750.0n 0.4339 250999.9n 0.4339 251000.0n 0.4339 251249.9n 0.4339 251250.0n 0.4339 251499.9n 0.4339 251500.0n 0.5180 251749.9n 0.5180 251750.0n 0.5852 251999.9n 0.5852 252000.0n 0.4675 252249.9n 0.4675 252250.0n 0.4507 252499.9n 0.4507 252500.0n 0.5180 252749.9n 0.5180 252750.0n 0.4339 252999.9n 0.4339 253000.0n 0.5348 253249.9n 0.5348 253250.0n 0.4339 253499.9n 0.4339 253500.0n 0.4339 253749.9n 0.4339 253750.0n 0.5684 253999.9n 0.5684 254000.0n 0.4339 254249.9n 0.4339 254250.0n 0.6189 254499.9n 0.6189 254500.0n 0.6525 254749.9n 0.6525 254750.0n 0.7198 254999.9n 0.7198 255000.0n 0.4339 255249.9n 0.4339 255250.0n 0.5348 255499.9n 0.5348 255500.0n 0.6189 255749.9n 0.6189 255750.0n 0.6189 255999.9n 0.6189 256000.0n 0.6189 256249.9n 0.6189 256250.0n 0.5516 256499.9n 0.5516 256500.0n 0.5516 256749.9n 0.5516 256750.0n 0.4507 256999.9n 0.4507 257000.0n 0.5011 257249.9n 0.5011 257250.0n 0.4339 257499.9n 0.4339 257500.0n 0.5011 257749.9n 0.5011 257750.0n 0.6189 257999.9n 0.6189 258000.0n 0.5011 258249.9n 0.5011 258250.0n 0.4339 258499.9n 0.4339 258500.0n 0.4339 258749.9n 0.4339 258750.0n 0.4339 258999.9n 0.4339 259000.0n 0.5180 259249.9n 0.5180 259250.0n 0.5852 259499.9n 0.5852 259500.0n 0.4675 259749.9n 0.4675 259750.0n 0.4507 259999.9n 0.4507 260000.0n 0.5180 260249.9n 0.5180 260250.0n 0.4339 260499.9n 0.4339 260500.0n 0.5348 260749.9n 0.5348 260750.0n 0.4339 260999.9n 0.4339 261000.0n 0.4339 261249.9n 0.4339 261250.0n 0.5684 261499.9n 0.5684 261500.0n 0.4339 261749.9n 0.4339 261750.0n 0.6189 261999.9n 0.6189 262000.0n 0.6525 262249.9n 0.6525 262250.0n 0.7198 262499.9n 0.7198 262500.0n 0.4339 262749.9n 0.4339 262750.0n 0.5348 262999.9n 0.5348 263000.0n 0.6189 263249.9n 0.6189 263250.0n 0.6189 263499.9n 0.6189 263500.0n 0.6189 263749.9n 0.6189 263750.0n 0.5516 263999.9n 0.5516 264000.0n 0.5516 264249.9n 0.5516 264250.0n 0.4507 264499.9n 0.4507 264500.0n 0.5011 264749.9n 0.5011 264750.0n 0.4339 264999.9n 0.4339 265000.0n 0.5011 265249.9n 0.5011 265250.0n 0.6189 265499.9n 0.6189 265500.0n 0.5011 265749.9n 0.5011 265750.0n 0.4339 265999.9n 0.4339 266000.0n 0.4339 266249.9n 0.4339 266250.0n 0.4339 266499.9n 0.4339 266500.0n 0.5180 266749.9n 0.5180 266750.0n 0.5852 266999.9n 0.5852 267000.0n 0.4675 267249.9n 0.4675 267250.0n 0.4507 267499.9n 0.4507 267500.0n 0.5180 267749.9n 0.5180 267750.0n 0.4339 267999.9n 0.4339 268000.0n 0.5348 268249.9n 0.5348 268250.0n 0.4339 268499.9n 0.4339 268500.0n 0.4339 268749.9n 0.4339 268750.0n 0.5684 268999.9n 0.5684 269000.0n 0.4339 269249.9n 0.4339 269250.0n 0.6189 269499.9n 0.6189 269500.0n 0.6525 269749.9n 0.6525 269750.0n 0.7198 269999.9n 0.7198 270000.0n 0.4339 270249.9n 0.4339 270250.0n 0.5348 270499.9n 0.5348 270500.0n 0.6189 270749.9n 0.6189 270750.0n 0.6189 270999.9n 0.6189 271000.0n 0.6189 271249.9n 0.6189 271250.0n 0.5516 271499.9n 0.5516 271500.0n 0.5516 271749.9n 0.5516 271750.0n 0.4507 271999.9n 0.4507 272000.0n 0.5011 272249.9n 0.5011 272250.0n 0.4339 272499.9n 0.4339 272500.0n 0.5011 272749.9n 0.5011 272750.0n 0.6189 272999.9n 0.6189 273000.0n 0.5011 273249.9n 0.5011 273250.0n 0.4339 273499.9n 0.4339 273500.0n 0.4339 273749.9n 0.4339 273750.0n 0.4339 273999.9n 0.4339 274000.0n 0.5180 274249.9n 0.5180 274250.0n 0.5852 274499.9n 0.5852 274500.0n 0.4675 274749.9n 0.4675 274750.0n 0.4507 274999.9n 0.4507 275000.0n 0.5180 275249.9n 0.5180 275250.0n 0.4339 275499.9n 0.4339 275500.0n 0.5348 275749.9n 0.5348 275750.0n 0.4339 275999.9n 0.4339 276000.0n 0.4339 276249.9n 0.4339 276250.0n 0.5684 276499.9n 0.5684 276500.0n 0.4339 276749.9n 0.4339 276750.0n 0.6189 276999.9n 0.6189 277000.0n 0.6525 277249.9n 0.6525 277250.0n 0.7198 277499.9n 0.7198 277500.0n 0.4339 277749.9n 0.4339 277750.0n 0.5348 277999.9n 0.5348 278000.0n 0.6189 278249.9n 0.6189 278250.0n 0.6189 278499.9n 0.6189 278500.0n 0.6189 278749.9n 0.6189 278750.0n 0.5516 278999.9n 0.5516 279000.0n 0.5516 279249.9n 0.5516 279250.0n 0.4507 279499.9n 0.4507 279500.0n 0.5011 279749.9n 0.5011 279750.0n 0.4339 279999.9n 0.4339 280000.0n 0.5011 280249.9n 0.5011 280250.0n 0.6189 280499.9n 0.6189 280500.0n 0.5011 280749.9n 0.5011 280750.0n 0.4339 280999.9n 0.4339 281000.0n 0.4339 281249.9n 0.4339 281250.0n 0.4339 281499.9n 0.4339 281500.0n 0.5180 281749.9n 0.5180 281750.0n 0.5852 281999.9n 0.5852 282000.0n 0.4675 282249.9n 0.4675 282250.0n 0.4507 282499.9n 0.4507 282500.0n 0.5180 282749.9n 0.5180 282750.0n 0.4339 282999.9n 0.4339 283000.0n 0.5348 283249.9n 0.5348 283250.0n 0.4339 283499.9n 0.4339 283500.0n 0.4339 283749.9n 0.4339 283750.0n 0.5684 283999.9n 0.5684 284000.0n 0.4339 284249.9n 0.4339 284250.0n 0.6189 284499.9n 0.6189 284500.0n 0.6525 284749.9n 0.6525 284750.0n 0.7198 284999.9n 0.7198 285000.0n 0.4339 285249.9n 0.4339 285250.0n 0.5348 285499.9n 0.5348 285500.0n 0.6189 285749.9n 0.6189 285750.0n 0.6189 285999.9n 0.6189 286000.0n 0.6189 286249.9n 0.6189 286250.0n 0.5516 286499.9n 0.5516 286500.0n 0.5516 286749.9n 0.5516 286750.0n 0.4507 286999.9n 0.4507 287000.0n 0.5011 287249.9n 0.5011 287250.0n 0.4339 287499.9n 0.4339 287500.0n 0.5011 287749.9n 0.5011 287750.0n 0.6189 287999.9n 0.6189 288000.0n 0.5011 288249.9n 0.5011 288250.0n 0.4339 288499.9n 0.4339 288500.0n 0.4339 288749.9n 0.4339 288750.0n 0.4339 288999.9n 0.4339 289000.0n 0.5180 289249.9n 0.5180 289250.0n 0.5852 289499.9n 0.5852 289500.0n 0.4675 289749.9n 0.4675 289750.0n 0.4507 289999.9n 0.4507 290000.0n 0.5180 290249.9n 0.5180 290250.0n 0.4339 290499.9n 0.4339 290500.0n 0.5348 290749.9n 0.5348 290750.0n 0.4339 290999.9n 0.4339 291000.0n 0.4339 291249.9n 0.4339 291250.0n 0.5684 291499.9n 0.5684 291500.0n 0.4339 291749.9n 0.4339 291750.0n 0.6189 291999.9n 0.6189 292000.0n 0.6525 292249.9n 0.6525 292250.0n 0.7198 292499.9n 0.7198 292500.0n 0.4339 292749.9n 0.4339 292750.0n 0.5348 292999.9n 0.5348 293000.0n 0.6189 293249.9n 0.6189 293250.0n 0.6189 293499.9n 0.6189 293500.0n 0.6189 293749.9n 0.6189 293750.0n 0.5516 293999.9n 0.5516 294000.0n 0.5516 294249.9n 0.5516 294250.0n 0.4507 294499.9n 0.4507 294500.0n 0.5011 294749.9n 0.5011 294750.0n 0.4339 294999.9n 0.4339 295000.0n 0.5011 295249.9n 0.5011 295250.0n 0.6189 295499.9n 0.6189 295500.0n 0.5011 295749.9n 0.5011 295750.0n 0.4339 295999.9n 0.4339 296000.0n 0.4339 296249.9n 0.4339 296250.0n 0.4339 296499.9n 0.4339 296500.0n 0.5180 296749.9n 0.5180 296750.0n 0.5852 296999.9n 0.5852 297000.0n 0.4675 297249.9n 0.4675 297250.0n 0.4507 297499.9n 0.4507 297500.0n 0.5180 297749.9n 0.5180 297750.0n 0.4339 297999.9n 0.4339 298000.0n 0.5348 298249.9n 0.5348 298250.0n 0.4339 298499.9n 0.4339 298500.0n 0.4339 298749.9n 0.4339 298750.0n 0.5684 298999.9n 0.5684 299000.0n 0.4339 299249.9n 0.4339 299250.0n 0.6189 299499.9n 0.6189 299500.0n 0.6525 299749.9n 0.6525 299750.0n 0.7198)
Vxn8 a_xn8 0 PWL(0.0n 0.5661 249.9n 0.5661 250.0n 0.4652 499.9n 0.4652 500.0n 0.3811 749.9n 0.3811 750.0n 0.3811 999.9n 0.3811 1000.0n 0.3811 1249.9n 0.3811 1250.0n 0.4484 1499.9n 0.4484 1500.0n 0.4484 1749.9n 0.4484 1750.0n 0.5493 1999.9n 0.5493 2000.0n 0.4989 2249.9n 0.4989 2250.0n 0.5661 2499.9n 0.5661 2500.0n 0.4989 2749.9n 0.4989 2750.0n 0.3811 2999.9n 0.3811 3000.0n 0.4989 3249.9n 0.4989 3250.0n 0.5661 3499.9n 0.5661 3500.0n 0.5661 3749.9n 0.5661 3750.0n 0.5661 3999.9n 0.5661 4000.0n 0.4820 4249.9n 0.4820 4250.0n 0.4148 4499.9n 0.4148 4500.0n 0.5325 4749.9n 0.5325 4750.0n 0.5493 4999.9n 0.5493 5000.0n 0.4820 5249.9n 0.4820 5250.0n 0.5661 5499.9n 0.5661 5500.0n 0.4652 5749.9n 0.4652 5750.0n 0.5661 5999.9n 0.5661 6000.0n 0.5661 6249.9n 0.5661 6250.0n 0.4316 6499.9n 0.4316 6500.0n 0.5661 6749.9n 0.5661 6750.0n 0.3811 6999.9n 0.3811 7000.0n 0.3475 7249.9n 0.3475 7250.0n 0.2802 7499.9n 0.2802 7500.0n 0.5661 7749.9n 0.5661 7750.0n 0.4652 7999.9n 0.4652 8000.0n 0.3811 8249.9n 0.3811 8250.0n 0.3811 8499.9n 0.3811 8500.0n 0.3811 8749.9n 0.3811 8750.0n 0.4484 8999.9n 0.4484 9000.0n 0.4484 9249.9n 0.4484 9250.0n 0.5493 9499.9n 0.5493 9500.0n 0.4989 9749.9n 0.4989 9750.0n 0.5661 9999.9n 0.5661 10000.0n 0.4989 10249.9n 0.4989 10250.0n 0.3811 10499.9n 0.3811 10500.0n 0.4989 10749.9n 0.4989 10750.0n 0.5661 10999.9n 0.5661 11000.0n 0.5661 11249.9n 0.5661 11250.0n 0.5661 11499.9n 0.5661 11500.0n 0.4820 11749.9n 0.4820 11750.0n 0.4148 11999.9n 0.4148 12000.0n 0.5325 12249.9n 0.5325 12250.0n 0.5493 12499.9n 0.5493 12500.0n 0.4820 12749.9n 0.4820 12750.0n 0.5661 12999.9n 0.5661 13000.0n 0.4652 13249.9n 0.4652 13250.0n 0.5661 13499.9n 0.5661 13500.0n 0.5661 13749.9n 0.5661 13750.0n 0.4316 13999.9n 0.4316 14000.0n 0.5661 14249.9n 0.5661 14250.0n 0.3811 14499.9n 0.3811 14500.0n 0.3475 14749.9n 0.3475 14750.0n 0.2802 14999.9n 0.2802 15000.0n 0.5661 15249.9n 0.5661 15250.0n 0.4652 15499.9n 0.4652 15500.0n 0.3811 15749.9n 0.3811 15750.0n 0.3811 15999.9n 0.3811 16000.0n 0.3811 16249.9n 0.3811 16250.0n 0.4484 16499.9n 0.4484 16500.0n 0.4484 16749.9n 0.4484 16750.0n 0.5493 16999.9n 0.5493 17000.0n 0.4989 17249.9n 0.4989 17250.0n 0.5661 17499.9n 0.5661 17500.0n 0.4989 17749.9n 0.4989 17750.0n 0.3811 17999.9n 0.3811 18000.0n 0.4989 18249.9n 0.4989 18250.0n 0.5661 18499.9n 0.5661 18500.0n 0.5661 18749.9n 0.5661 18750.0n 0.5661 18999.9n 0.5661 19000.0n 0.4820 19249.9n 0.4820 19250.0n 0.4148 19499.9n 0.4148 19500.0n 0.5325 19749.9n 0.5325 19750.0n 0.5493 19999.9n 0.5493 20000.0n 0.4820 20249.9n 0.4820 20250.0n 0.5661 20499.9n 0.5661 20500.0n 0.4652 20749.9n 0.4652 20750.0n 0.5661 20999.9n 0.5661 21000.0n 0.5661 21249.9n 0.5661 21250.0n 0.4316 21499.9n 0.4316 21500.0n 0.5661 21749.9n 0.5661 21750.0n 0.3811 21999.9n 0.3811 22000.0n 0.3475 22249.9n 0.3475 22250.0n 0.2802 22499.9n 0.2802 22500.0n 0.5661 22749.9n 0.5661 22750.0n 0.4652 22999.9n 0.4652 23000.0n 0.3811 23249.9n 0.3811 23250.0n 0.3811 23499.9n 0.3811 23500.0n 0.3811 23749.9n 0.3811 23750.0n 0.4484 23999.9n 0.4484 24000.0n 0.4484 24249.9n 0.4484 24250.0n 0.5493 24499.9n 0.5493 24500.0n 0.4989 24749.9n 0.4989 24750.0n 0.5661 24999.9n 0.5661 25000.0n 0.4989 25249.9n 0.4989 25250.0n 0.3811 25499.9n 0.3811 25500.0n 0.4989 25749.9n 0.4989 25750.0n 0.5661 25999.9n 0.5661 26000.0n 0.5661 26249.9n 0.5661 26250.0n 0.5661 26499.9n 0.5661 26500.0n 0.4820 26749.9n 0.4820 26750.0n 0.4148 26999.9n 0.4148 27000.0n 0.5325 27249.9n 0.5325 27250.0n 0.5493 27499.9n 0.5493 27500.0n 0.4820 27749.9n 0.4820 27750.0n 0.5661 27999.9n 0.5661 28000.0n 0.4652 28249.9n 0.4652 28250.0n 0.5661 28499.9n 0.5661 28500.0n 0.5661 28749.9n 0.5661 28750.0n 0.4316 28999.9n 0.4316 29000.0n 0.5661 29249.9n 0.5661 29250.0n 0.3811 29499.9n 0.3811 29500.0n 0.3475 29749.9n 0.3475 29750.0n 0.2802 29999.9n 0.2802 30000.0n 0.5661 30249.9n 0.5661 30250.0n 0.4652 30499.9n 0.4652 30500.0n 0.3811 30749.9n 0.3811 30750.0n 0.3811 30999.9n 0.3811 31000.0n 0.3811 31249.9n 0.3811 31250.0n 0.4484 31499.9n 0.4484 31500.0n 0.4484 31749.9n 0.4484 31750.0n 0.5493 31999.9n 0.5493 32000.0n 0.4989 32249.9n 0.4989 32250.0n 0.5661 32499.9n 0.5661 32500.0n 0.4989 32749.9n 0.4989 32750.0n 0.3811 32999.9n 0.3811 33000.0n 0.4989 33249.9n 0.4989 33250.0n 0.5661 33499.9n 0.5661 33500.0n 0.5661 33749.9n 0.5661 33750.0n 0.5661 33999.9n 0.5661 34000.0n 0.4820 34249.9n 0.4820 34250.0n 0.4148 34499.9n 0.4148 34500.0n 0.5325 34749.9n 0.5325 34750.0n 0.5493 34999.9n 0.5493 35000.0n 0.4820 35249.9n 0.4820 35250.0n 0.5661 35499.9n 0.5661 35500.0n 0.4652 35749.9n 0.4652 35750.0n 0.5661 35999.9n 0.5661 36000.0n 0.5661 36249.9n 0.5661 36250.0n 0.4316 36499.9n 0.4316 36500.0n 0.5661 36749.9n 0.5661 36750.0n 0.3811 36999.9n 0.3811 37000.0n 0.3475 37249.9n 0.3475 37250.0n 0.2802 37499.9n 0.2802 37500.0n 0.5661 37749.9n 0.5661 37750.0n 0.4652 37999.9n 0.4652 38000.0n 0.3811 38249.9n 0.3811 38250.0n 0.3811 38499.9n 0.3811 38500.0n 0.3811 38749.9n 0.3811 38750.0n 0.4484 38999.9n 0.4484 39000.0n 0.4484 39249.9n 0.4484 39250.0n 0.5493 39499.9n 0.5493 39500.0n 0.4989 39749.9n 0.4989 39750.0n 0.5661 39999.9n 0.5661 40000.0n 0.4989 40249.9n 0.4989 40250.0n 0.3811 40499.9n 0.3811 40500.0n 0.4989 40749.9n 0.4989 40750.0n 0.5661 40999.9n 0.5661 41000.0n 0.5661 41249.9n 0.5661 41250.0n 0.5661 41499.9n 0.5661 41500.0n 0.4820 41749.9n 0.4820 41750.0n 0.4148 41999.9n 0.4148 42000.0n 0.5325 42249.9n 0.5325 42250.0n 0.5493 42499.9n 0.5493 42500.0n 0.4820 42749.9n 0.4820 42750.0n 0.5661 42999.9n 0.5661 43000.0n 0.4652 43249.9n 0.4652 43250.0n 0.5661 43499.9n 0.5661 43500.0n 0.5661 43749.9n 0.5661 43750.0n 0.4316 43999.9n 0.4316 44000.0n 0.5661 44249.9n 0.5661 44250.0n 0.3811 44499.9n 0.3811 44500.0n 0.3475 44749.9n 0.3475 44750.0n 0.2802 44999.9n 0.2802 45000.0n 0.5661 45249.9n 0.5661 45250.0n 0.4652 45499.9n 0.4652 45500.0n 0.3811 45749.9n 0.3811 45750.0n 0.3811 45999.9n 0.3811 46000.0n 0.3811 46249.9n 0.3811 46250.0n 0.4484 46499.9n 0.4484 46500.0n 0.4484 46749.9n 0.4484 46750.0n 0.5493 46999.9n 0.5493 47000.0n 0.4989 47249.9n 0.4989 47250.0n 0.5661 47499.9n 0.5661 47500.0n 0.4989 47749.9n 0.4989 47750.0n 0.3811 47999.9n 0.3811 48000.0n 0.4989 48249.9n 0.4989 48250.0n 0.5661 48499.9n 0.5661 48500.0n 0.5661 48749.9n 0.5661 48750.0n 0.5661 48999.9n 0.5661 49000.0n 0.4820 49249.9n 0.4820 49250.0n 0.4148 49499.9n 0.4148 49500.0n 0.5325 49749.9n 0.5325 49750.0n 0.5493 49999.9n 0.5493 50000.0n 0.4820 50249.9n 0.4820 50250.0n 0.5661 50499.9n 0.5661 50500.0n 0.4652 50749.9n 0.4652 50750.0n 0.5661 50999.9n 0.5661 51000.0n 0.5661 51249.9n 0.5661 51250.0n 0.4316 51499.9n 0.4316 51500.0n 0.5661 51749.9n 0.5661 51750.0n 0.3811 51999.9n 0.3811 52000.0n 0.3475 52249.9n 0.3475 52250.0n 0.2802 52499.9n 0.2802 52500.0n 0.5661 52749.9n 0.5661 52750.0n 0.4652 52999.9n 0.4652 53000.0n 0.3811 53249.9n 0.3811 53250.0n 0.3811 53499.9n 0.3811 53500.0n 0.3811 53749.9n 0.3811 53750.0n 0.4484 53999.9n 0.4484 54000.0n 0.4484 54249.9n 0.4484 54250.0n 0.5493 54499.9n 0.5493 54500.0n 0.4989 54749.9n 0.4989 54750.0n 0.5661 54999.9n 0.5661 55000.0n 0.4989 55249.9n 0.4989 55250.0n 0.3811 55499.9n 0.3811 55500.0n 0.4989 55749.9n 0.4989 55750.0n 0.5661 55999.9n 0.5661 56000.0n 0.5661 56249.9n 0.5661 56250.0n 0.5661 56499.9n 0.5661 56500.0n 0.4820 56749.9n 0.4820 56750.0n 0.4148 56999.9n 0.4148 57000.0n 0.5325 57249.9n 0.5325 57250.0n 0.5493 57499.9n 0.5493 57500.0n 0.4820 57749.9n 0.4820 57750.0n 0.5661 57999.9n 0.5661 58000.0n 0.4652 58249.9n 0.4652 58250.0n 0.5661 58499.9n 0.5661 58500.0n 0.5661 58749.9n 0.5661 58750.0n 0.4316 58999.9n 0.4316 59000.0n 0.5661 59249.9n 0.5661 59250.0n 0.3811 59499.9n 0.3811 59500.0n 0.3475 59749.9n 0.3475 59750.0n 0.2802 59999.9n 0.2802 60000.0n 0.5661 60249.9n 0.5661 60250.0n 0.4652 60499.9n 0.4652 60500.0n 0.3811 60749.9n 0.3811 60750.0n 0.3811 60999.9n 0.3811 61000.0n 0.3811 61249.9n 0.3811 61250.0n 0.4484 61499.9n 0.4484 61500.0n 0.4484 61749.9n 0.4484 61750.0n 0.5493 61999.9n 0.5493 62000.0n 0.4989 62249.9n 0.4989 62250.0n 0.5661 62499.9n 0.5661 62500.0n 0.4989 62749.9n 0.4989 62750.0n 0.3811 62999.9n 0.3811 63000.0n 0.4989 63249.9n 0.4989 63250.0n 0.5661 63499.9n 0.5661 63500.0n 0.5661 63749.9n 0.5661 63750.0n 0.5661 63999.9n 0.5661 64000.0n 0.4820 64249.9n 0.4820 64250.0n 0.4148 64499.9n 0.4148 64500.0n 0.5325 64749.9n 0.5325 64750.0n 0.5493 64999.9n 0.5493 65000.0n 0.4820 65249.9n 0.4820 65250.0n 0.5661 65499.9n 0.5661 65500.0n 0.4652 65749.9n 0.4652 65750.0n 0.5661 65999.9n 0.5661 66000.0n 0.5661 66249.9n 0.5661 66250.0n 0.4316 66499.9n 0.4316 66500.0n 0.5661 66749.9n 0.5661 66750.0n 0.3811 66999.9n 0.3811 67000.0n 0.3475 67249.9n 0.3475 67250.0n 0.2802 67499.9n 0.2802 67500.0n 0.5661 67749.9n 0.5661 67750.0n 0.4652 67999.9n 0.4652 68000.0n 0.3811 68249.9n 0.3811 68250.0n 0.3811 68499.9n 0.3811 68500.0n 0.3811 68749.9n 0.3811 68750.0n 0.4484 68999.9n 0.4484 69000.0n 0.4484 69249.9n 0.4484 69250.0n 0.5493 69499.9n 0.5493 69500.0n 0.4989 69749.9n 0.4989 69750.0n 0.5661 69999.9n 0.5661 70000.0n 0.4989 70249.9n 0.4989 70250.0n 0.3811 70499.9n 0.3811 70500.0n 0.4989 70749.9n 0.4989 70750.0n 0.5661 70999.9n 0.5661 71000.0n 0.5661 71249.9n 0.5661 71250.0n 0.5661 71499.9n 0.5661 71500.0n 0.4820 71749.9n 0.4820 71750.0n 0.4148 71999.9n 0.4148 72000.0n 0.5325 72249.9n 0.5325 72250.0n 0.5493 72499.9n 0.5493 72500.0n 0.4820 72749.9n 0.4820 72750.0n 0.5661 72999.9n 0.5661 73000.0n 0.4652 73249.9n 0.4652 73250.0n 0.5661 73499.9n 0.5661 73500.0n 0.5661 73749.9n 0.5661 73750.0n 0.4316 73999.9n 0.4316 74000.0n 0.5661 74249.9n 0.5661 74250.0n 0.3811 74499.9n 0.3811 74500.0n 0.3475 74749.9n 0.3475 74750.0n 0.2802 74999.9n 0.2802 75000.0n 0.5661 75249.9n 0.5661 75250.0n 0.4652 75499.9n 0.4652 75500.0n 0.3811 75749.9n 0.3811 75750.0n 0.3811 75999.9n 0.3811 76000.0n 0.3811 76249.9n 0.3811 76250.0n 0.4484 76499.9n 0.4484 76500.0n 0.4484 76749.9n 0.4484 76750.0n 0.5493 76999.9n 0.5493 77000.0n 0.4989 77249.9n 0.4989 77250.0n 0.5661 77499.9n 0.5661 77500.0n 0.4989 77749.9n 0.4989 77750.0n 0.3811 77999.9n 0.3811 78000.0n 0.4989 78249.9n 0.4989 78250.0n 0.5661 78499.9n 0.5661 78500.0n 0.5661 78749.9n 0.5661 78750.0n 0.5661 78999.9n 0.5661 79000.0n 0.4820 79249.9n 0.4820 79250.0n 0.4148 79499.9n 0.4148 79500.0n 0.5325 79749.9n 0.5325 79750.0n 0.5493 79999.9n 0.5493 80000.0n 0.4820 80249.9n 0.4820 80250.0n 0.5661 80499.9n 0.5661 80500.0n 0.4652 80749.9n 0.4652 80750.0n 0.5661 80999.9n 0.5661 81000.0n 0.5661 81249.9n 0.5661 81250.0n 0.4316 81499.9n 0.4316 81500.0n 0.5661 81749.9n 0.5661 81750.0n 0.3811 81999.9n 0.3811 82000.0n 0.3475 82249.9n 0.3475 82250.0n 0.2802 82499.9n 0.2802 82500.0n 0.5661 82749.9n 0.5661 82750.0n 0.4652 82999.9n 0.4652 83000.0n 0.3811 83249.9n 0.3811 83250.0n 0.3811 83499.9n 0.3811 83500.0n 0.3811 83749.9n 0.3811 83750.0n 0.4484 83999.9n 0.4484 84000.0n 0.4484 84249.9n 0.4484 84250.0n 0.5493 84499.9n 0.5493 84500.0n 0.4989 84749.9n 0.4989 84750.0n 0.5661 84999.9n 0.5661 85000.0n 0.4989 85249.9n 0.4989 85250.0n 0.3811 85499.9n 0.3811 85500.0n 0.4989 85749.9n 0.4989 85750.0n 0.5661 85999.9n 0.5661 86000.0n 0.5661 86249.9n 0.5661 86250.0n 0.5661 86499.9n 0.5661 86500.0n 0.4820 86749.9n 0.4820 86750.0n 0.4148 86999.9n 0.4148 87000.0n 0.5325 87249.9n 0.5325 87250.0n 0.5493 87499.9n 0.5493 87500.0n 0.4820 87749.9n 0.4820 87750.0n 0.5661 87999.9n 0.5661 88000.0n 0.4652 88249.9n 0.4652 88250.0n 0.5661 88499.9n 0.5661 88500.0n 0.5661 88749.9n 0.5661 88750.0n 0.4316 88999.9n 0.4316 89000.0n 0.5661 89249.9n 0.5661 89250.0n 0.3811 89499.9n 0.3811 89500.0n 0.3475 89749.9n 0.3475 89750.0n 0.2802 89999.9n 0.2802 90000.0n 0.5661 90249.9n 0.5661 90250.0n 0.4652 90499.9n 0.4652 90500.0n 0.3811 90749.9n 0.3811 90750.0n 0.3811 90999.9n 0.3811 91000.0n 0.3811 91249.9n 0.3811 91250.0n 0.4484 91499.9n 0.4484 91500.0n 0.4484 91749.9n 0.4484 91750.0n 0.5493 91999.9n 0.5493 92000.0n 0.4989 92249.9n 0.4989 92250.0n 0.5661 92499.9n 0.5661 92500.0n 0.4989 92749.9n 0.4989 92750.0n 0.3811 92999.9n 0.3811 93000.0n 0.4989 93249.9n 0.4989 93250.0n 0.5661 93499.9n 0.5661 93500.0n 0.5661 93749.9n 0.5661 93750.0n 0.5661 93999.9n 0.5661 94000.0n 0.4820 94249.9n 0.4820 94250.0n 0.4148 94499.9n 0.4148 94500.0n 0.5325 94749.9n 0.5325 94750.0n 0.5493 94999.9n 0.5493 95000.0n 0.4820 95249.9n 0.4820 95250.0n 0.5661 95499.9n 0.5661 95500.0n 0.4652 95749.9n 0.4652 95750.0n 0.5661 95999.9n 0.5661 96000.0n 0.5661 96249.9n 0.5661 96250.0n 0.4316 96499.9n 0.4316 96500.0n 0.5661 96749.9n 0.5661 96750.0n 0.3811 96999.9n 0.3811 97000.0n 0.3475 97249.9n 0.3475 97250.0n 0.2802 97499.9n 0.2802 97500.0n 0.5661 97749.9n 0.5661 97750.0n 0.4652 97999.9n 0.4652 98000.0n 0.3811 98249.9n 0.3811 98250.0n 0.3811 98499.9n 0.3811 98500.0n 0.3811 98749.9n 0.3811 98750.0n 0.4484 98999.9n 0.4484 99000.0n 0.4484 99249.9n 0.4484 99250.0n 0.5493 99499.9n 0.5493 99500.0n 0.4989 99749.9n 0.4989 99750.0n 0.5661 99999.9n 0.5661 100000.0n 0.4989 100249.9n 0.4989 100250.0n 0.3811 100499.9n 0.3811 100500.0n 0.4989 100749.9n 0.4989 100750.0n 0.5661 100999.9n 0.5661 101000.0n 0.5661 101249.9n 0.5661 101250.0n 0.5661 101499.9n 0.5661 101500.0n 0.4820 101749.9n 0.4820 101750.0n 0.4148 101999.9n 0.4148 102000.0n 0.5325 102249.9n 0.5325 102250.0n 0.5493 102499.9n 0.5493 102500.0n 0.4820 102749.9n 0.4820 102750.0n 0.5661 102999.9n 0.5661 103000.0n 0.4652 103249.9n 0.4652 103250.0n 0.5661 103499.9n 0.5661 103500.0n 0.5661 103749.9n 0.5661 103750.0n 0.4316 103999.9n 0.4316 104000.0n 0.5661 104249.9n 0.5661 104250.0n 0.3811 104499.9n 0.3811 104500.0n 0.3475 104749.9n 0.3475 104750.0n 0.2802 104999.9n 0.2802 105000.0n 0.5661 105249.9n 0.5661 105250.0n 0.4652 105499.9n 0.4652 105500.0n 0.3811 105749.9n 0.3811 105750.0n 0.3811 105999.9n 0.3811 106000.0n 0.3811 106249.9n 0.3811 106250.0n 0.4484 106499.9n 0.4484 106500.0n 0.4484 106749.9n 0.4484 106750.0n 0.5493 106999.9n 0.5493 107000.0n 0.4989 107249.9n 0.4989 107250.0n 0.5661 107499.9n 0.5661 107500.0n 0.4989 107749.9n 0.4989 107750.0n 0.3811 107999.9n 0.3811 108000.0n 0.4989 108249.9n 0.4989 108250.0n 0.5661 108499.9n 0.5661 108500.0n 0.5661 108749.9n 0.5661 108750.0n 0.5661 108999.9n 0.5661 109000.0n 0.4820 109249.9n 0.4820 109250.0n 0.4148 109499.9n 0.4148 109500.0n 0.5325 109749.9n 0.5325 109750.0n 0.5493 109999.9n 0.5493 110000.0n 0.4820 110249.9n 0.4820 110250.0n 0.5661 110499.9n 0.5661 110500.0n 0.4652 110749.9n 0.4652 110750.0n 0.5661 110999.9n 0.5661 111000.0n 0.5661 111249.9n 0.5661 111250.0n 0.4316 111499.9n 0.4316 111500.0n 0.5661 111749.9n 0.5661 111750.0n 0.3811 111999.9n 0.3811 112000.0n 0.3475 112249.9n 0.3475 112250.0n 0.2802 112499.9n 0.2802 112500.0n 0.5661 112749.9n 0.5661 112750.0n 0.4652 112999.9n 0.4652 113000.0n 0.3811 113249.9n 0.3811 113250.0n 0.3811 113499.9n 0.3811 113500.0n 0.3811 113749.9n 0.3811 113750.0n 0.4484 113999.9n 0.4484 114000.0n 0.4484 114249.9n 0.4484 114250.0n 0.5493 114499.9n 0.5493 114500.0n 0.4989 114749.9n 0.4989 114750.0n 0.5661 114999.9n 0.5661 115000.0n 0.4989 115249.9n 0.4989 115250.0n 0.3811 115499.9n 0.3811 115500.0n 0.4989 115749.9n 0.4989 115750.0n 0.5661 115999.9n 0.5661 116000.0n 0.5661 116249.9n 0.5661 116250.0n 0.5661 116499.9n 0.5661 116500.0n 0.4820 116749.9n 0.4820 116750.0n 0.4148 116999.9n 0.4148 117000.0n 0.5325 117249.9n 0.5325 117250.0n 0.5493 117499.9n 0.5493 117500.0n 0.4820 117749.9n 0.4820 117750.0n 0.5661 117999.9n 0.5661 118000.0n 0.4652 118249.9n 0.4652 118250.0n 0.5661 118499.9n 0.5661 118500.0n 0.5661 118749.9n 0.5661 118750.0n 0.4316 118999.9n 0.4316 119000.0n 0.5661 119249.9n 0.5661 119250.0n 0.3811 119499.9n 0.3811 119500.0n 0.3475 119749.9n 0.3475 119750.0n 0.2802 119999.9n 0.2802 120000.0n 0.5661 120249.9n 0.5661 120250.0n 0.4652 120499.9n 0.4652 120500.0n 0.3811 120749.9n 0.3811 120750.0n 0.3811 120999.9n 0.3811 121000.0n 0.3811 121249.9n 0.3811 121250.0n 0.4484 121499.9n 0.4484 121500.0n 0.4484 121749.9n 0.4484 121750.0n 0.5493 121999.9n 0.5493 122000.0n 0.4989 122249.9n 0.4989 122250.0n 0.5661 122499.9n 0.5661 122500.0n 0.4989 122749.9n 0.4989 122750.0n 0.3811 122999.9n 0.3811 123000.0n 0.4989 123249.9n 0.4989 123250.0n 0.5661 123499.9n 0.5661 123500.0n 0.5661 123749.9n 0.5661 123750.0n 0.5661 123999.9n 0.5661 124000.0n 0.4820 124249.9n 0.4820 124250.0n 0.4148 124499.9n 0.4148 124500.0n 0.5325 124749.9n 0.5325 124750.0n 0.5493 124999.9n 0.5493 125000.0n 0.4820 125249.9n 0.4820 125250.0n 0.5661 125499.9n 0.5661 125500.0n 0.4652 125749.9n 0.4652 125750.0n 0.5661 125999.9n 0.5661 126000.0n 0.5661 126249.9n 0.5661 126250.0n 0.4316 126499.9n 0.4316 126500.0n 0.5661 126749.9n 0.5661 126750.0n 0.3811 126999.9n 0.3811 127000.0n 0.3475 127249.9n 0.3475 127250.0n 0.2802 127499.9n 0.2802 127500.0n 0.5661 127749.9n 0.5661 127750.0n 0.4652 127999.9n 0.4652 128000.0n 0.3811 128249.9n 0.3811 128250.0n 0.3811 128499.9n 0.3811 128500.0n 0.3811 128749.9n 0.3811 128750.0n 0.4484 128999.9n 0.4484 129000.0n 0.4484 129249.9n 0.4484 129250.0n 0.5493 129499.9n 0.5493 129500.0n 0.4989 129749.9n 0.4989 129750.0n 0.5661 129999.9n 0.5661 130000.0n 0.4989 130249.9n 0.4989 130250.0n 0.3811 130499.9n 0.3811 130500.0n 0.4989 130749.9n 0.4989 130750.0n 0.5661 130999.9n 0.5661 131000.0n 0.5661 131249.9n 0.5661 131250.0n 0.5661 131499.9n 0.5661 131500.0n 0.4820 131749.9n 0.4820 131750.0n 0.4148 131999.9n 0.4148 132000.0n 0.5325 132249.9n 0.5325 132250.0n 0.5493 132499.9n 0.5493 132500.0n 0.4820 132749.9n 0.4820 132750.0n 0.5661 132999.9n 0.5661 133000.0n 0.4652 133249.9n 0.4652 133250.0n 0.5661 133499.9n 0.5661 133500.0n 0.5661 133749.9n 0.5661 133750.0n 0.4316 133999.9n 0.4316 134000.0n 0.5661 134249.9n 0.5661 134250.0n 0.3811 134499.9n 0.3811 134500.0n 0.3475 134749.9n 0.3475 134750.0n 0.2802 134999.9n 0.2802 135000.0n 0.5661 135249.9n 0.5661 135250.0n 0.4652 135499.9n 0.4652 135500.0n 0.3811 135749.9n 0.3811 135750.0n 0.3811 135999.9n 0.3811 136000.0n 0.3811 136249.9n 0.3811 136250.0n 0.4484 136499.9n 0.4484 136500.0n 0.4484 136749.9n 0.4484 136750.0n 0.5493 136999.9n 0.5493 137000.0n 0.4989 137249.9n 0.4989 137250.0n 0.5661 137499.9n 0.5661 137500.0n 0.4989 137749.9n 0.4989 137750.0n 0.3811 137999.9n 0.3811 138000.0n 0.4989 138249.9n 0.4989 138250.0n 0.5661 138499.9n 0.5661 138500.0n 0.5661 138749.9n 0.5661 138750.0n 0.5661 138999.9n 0.5661 139000.0n 0.4820 139249.9n 0.4820 139250.0n 0.4148 139499.9n 0.4148 139500.0n 0.5325 139749.9n 0.5325 139750.0n 0.5493 139999.9n 0.5493 140000.0n 0.4820 140249.9n 0.4820 140250.0n 0.5661 140499.9n 0.5661 140500.0n 0.4652 140749.9n 0.4652 140750.0n 0.5661 140999.9n 0.5661 141000.0n 0.5661 141249.9n 0.5661 141250.0n 0.4316 141499.9n 0.4316 141500.0n 0.5661 141749.9n 0.5661 141750.0n 0.3811 141999.9n 0.3811 142000.0n 0.3475 142249.9n 0.3475 142250.0n 0.2802 142499.9n 0.2802 142500.0n 0.5661 142749.9n 0.5661 142750.0n 0.4652 142999.9n 0.4652 143000.0n 0.3811 143249.9n 0.3811 143250.0n 0.3811 143499.9n 0.3811 143500.0n 0.3811 143749.9n 0.3811 143750.0n 0.4484 143999.9n 0.4484 144000.0n 0.4484 144249.9n 0.4484 144250.0n 0.5493 144499.9n 0.5493 144500.0n 0.4989 144749.9n 0.4989 144750.0n 0.5661 144999.9n 0.5661 145000.0n 0.4989 145249.9n 0.4989 145250.0n 0.3811 145499.9n 0.3811 145500.0n 0.4989 145749.9n 0.4989 145750.0n 0.5661 145999.9n 0.5661 146000.0n 0.5661 146249.9n 0.5661 146250.0n 0.5661 146499.9n 0.5661 146500.0n 0.4820 146749.9n 0.4820 146750.0n 0.4148 146999.9n 0.4148 147000.0n 0.5325 147249.9n 0.5325 147250.0n 0.5493 147499.9n 0.5493 147500.0n 0.4820 147749.9n 0.4820 147750.0n 0.5661 147999.9n 0.5661 148000.0n 0.4652 148249.9n 0.4652 148250.0n 0.5661 148499.9n 0.5661 148500.0n 0.5661 148749.9n 0.5661 148750.0n 0.4316 148999.9n 0.4316 149000.0n 0.5661 149249.9n 0.5661 149250.0n 0.3811 149499.9n 0.3811 149500.0n 0.3475 149749.9n 0.3475 149750.0n 0.2802 149999.9n 0.2802 150000.0n 0.5661 150249.9n 0.5661 150250.0n 0.4652 150499.9n 0.4652 150500.0n 0.3811 150749.9n 0.3811 150750.0n 0.3811 150999.9n 0.3811 151000.0n 0.3811 151249.9n 0.3811 151250.0n 0.4484 151499.9n 0.4484 151500.0n 0.4484 151749.9n 0.4484 151750.0n 0.5493 151999.9n 0.5493 152000.0n 0.4989 152249.9n 0.4989 152250.0n 0.5661 152499.9n 0.5661 152500.0n 0.4989 152749.9n 0.4989 152750.0n 0.3811 152999.9n 0.3811 153000.0n 0.4989 153249.9n 0.4989 153250.0n 0.5661 153499.9n 0.5661 153500.0n 0.5661 153749.9n 0.5661 153750.0n 0.5661 153999.9n 0.5661 154000.0n 0.4820 154249.9n 0.4820 154250.0n 0.4148 154499.9n 0.4148 154500.0n 0.5325 154749.9n 0.5325 154750.0n 0.5493 154999.9n 0.5493 155000.0n 0.4820 155249.9n 0.4820 155250.0n 0.5661 155499.9n 0.5661 155500.0n 0.4652 155749.9n 0.4652 155750.0n 0.5661 155999.9n 0.5661 156000.0n 0.5661 156249.9n 0.5661 156250.0n 0.4316 156499.9n 0.4316 156500.0n 0.5661 156749.9n 0.5661 156750.0n 0.3811 156999.9n 0.3811 157000.0n 0.3475 157249.9n 0.3475 157250.0n 0.2802 157499.9n 0.2802 157500.0n 0.5661 157749.9n 0.5661 157750.0n 0.4652 157999.9n 0.4652 158000.0n 0.3811 158249.9n 0.3811 158250.0n 0.3811 158499.9n 0.3811 158500.0n 0.3811 158749.9n 0.3811 158750.0n 0.4484 158999.9n 0.4484 159000.0n 0.4484 159249.9n 0.4484 159250.0n 0.5493 159499.9n 0.5493 159500.0n 0.4989 159749.9n 0.4989 159750.0n 0.5661 159999.9n 0.5661 160000.0n 0.4989 160249.9n 0.4989 160250.0n 0.3811 160499.9n 0.3811 160500.0n 0.4989 160749.9n 0.4989 160750.0n 0.5661 160999.9n 0.5661 161000.0n 0.5661 161249.9n 0.5661 161250.0n 0.5661 161499.9n 0.5661 161500.0n 0.4820 161749.9n 0.4820 161750.0n 0.4148 161999.9n 0.4148 162000.0n 0.5325 162249.9n 0.5325 162250.0n 0.5493 162499.9n 0.5493 162500.0n 0.4820 162749.9n 0.4820 162750.0n 0.5661 162999.9n 0.5661 163000.0n 0.4652 163249.9n 0.4652 163250.0n 0.5661 163499.9n 0.5661 163500.0n 0.5661 163749.9n 0.5661 163750.0n 0.4316 163999.9n 0.4316 164000.0n 0.5661 164249.9n 0.5661 164250.0n 0.3811 164499.9n 0.3811 164500.0n 0.3475 164749.9n 0.3475 164750.0n 0.2802 164999.9n 0.2802 165000.0n 0.5661 165249.9n 0.5661 165250.0n 0.4652 165499.9n 0.4652 165500.0n 0.3811 165749.9n 0.3811 165750.0n 0.3811 165999.9n 0.3811 166000.0n 0.3811 166249.9n 0.3811 166250.0n 0.4484 166499.9n 0.4484 166500.0n 0.4484 166749.9n 0.4484 166750.0n 0.5493 166999.9n 0.5493 167000.0n 0.4989 167249.9n 0.4989 167250.0n 0.5661 167499.9n 0.5661 167500.0n 0.4989 167749.9n 0.4989 167750.0n 0.3811 167999.9n 0.3811 168000.0n 0.4989 168249.9n 0.4989 168250.0n 0.5661 168499.9n 0.5661 168500.0n 0.5661 168749.9n 0.5661 168750.0n 0.5661 168999.9n 0.5661 169000.0n 0.4820 169249.9n 0.4820 169250.0n 0.4148 169499.9n 0.4148 169500.0n 0.5325 169749.9n 0.5325 169750.0n 0.5493 169999.9n 0.5493 170000.0n 0.4820 170249.9n 0.4820 170250.0n 0.5661 170499.9n 0.5661 170500.0n 0.4652 170749.9n 0.4652 170750.0n 0.5661 170999.9n 0.5661 171000.0n 0.5661 171249.9n 0.5661 171250.0n 0.4316 171499.9n 0.4316 171500.0n 0.5661 171749.9n 0.5661 171750.0n 0.3811 171999.9n 0.3811 172000.0n 0.3475 172249.9n 0.3475 172250.0n 0.2802 172499.9n 0.2802 172500.0n 0.5661 172749.9n 0.5661 172750.0n 0.4652 172999.9n 0.4652 173000.0n 0.3811 173249.9n 0.3811 173250.0n 0.3811 173499.9n 0.3811 173500.0n 0.3811 173749.9n 0.3811 173750.0n 0.4484 173999.9n 0.4484 174000.0n 0.4484 174249.9n 0.4484 174250.0n 0.5493 174499.9n 0.5493 174500.0n 0.4989 174749.9n 0.4989 174750.0n 0.5661 174999.9n 0.5661 175000.0n 0.4989 175249.9n 0.4989 175250.0n 0.3811 175499.9n 0.3811 175500.0n 0.4989 175749.9n 0.4989 175750.0n 0.5661 175999.9n 0.5661 176000.0n 0.5661 176249.9n 0.5661 176250.0n 0.5661 176499.9n 0.5661 176500.0n 0.4820 176749.9n 0.4820 176750.0n 0.4148 176999.9n 0.4148 177000.0n 0.5325 177249.9n 0.5325 177250.0n 0.5493 177499.9n 0.5493 177500.0n 0.4820 177749.9n 0.4820 177750.0n 0.5661 177999.9n 0.5661 178000.0n 0.4652 178249.9n 0.4652 178250.0n 0.5661 178499.9n 0.5661 178500.0n 0.5661 178749.9n 0.5661 178750.0n 0.4316 178999.9n 0.4316 179000.0n 0.5661 179249.9n 0.5661 179250.0n 0.3811 179499.9n 0.3811 179500.0n 0.3475 179749.9n 0.3475 179750.0n 0.2802 179999.9n 0.2802 180000.0n 0.5661 180249.9n 0.5661 180250.0n 0.4652 180499.9n 0.4652 180500.0n 0.3811 180749.9n 0.3811 180750.0n 0.3811 180999.9n 0.3811 181000.0n 0.3811 181249.9n 0.3811 181250.0n 0.4484 181499.9n 0.4484 181500.0n 0.4484 181749.9n 0.4484 181750.0n 0.5493 181999.9n 0.5493 182000.0n 0.4989 182249.9n 0.4989 182250.0n 0.5661 182499.9n 0.5661 182500.0n 0.4989 182749.9n 0.4989 182750.0n 0.3811 182999.9n 0.3811 183000.0n 0.4989 183249.9n 0.4989 183250.0n 0.5661 183499.9n 0.5661 183500.0n 0.5661 183749.9n 0.5661 183750.0n 0.5661 183999.9n 0.5661 184000.0n 0.4820 184249.9n 0.4820 184250.0n 0.4148 184499.9n 0.4148 184500.0n 0.5325 184749.9n 0.5325 184750.0n 0.5493 184999.9n 0.5493 185000.0n 0.4820 185249.9n 0.4820 185250.0n 0.5661 185499.9n 0.5661 185500.0n 0.4652 185749.9n 0.4652 185750.0n 0.5661 185999.9n 0.5661 186000.0n 0.5661 186249.9n 0.5661 186250.0n 0.4316 186499.9n 0.4316 186500.0n 0.5661 186749.9n 0.5661 186750.0n 0.3811 186999.9n 0.3811 187000.0n 0.3475 187249.9n 0.3475 187250.0n 0.2802 187499.9n 0.2802 187500.0n 0.5661 187749.9n 0.5661 187750.0n 0.4652 187999.9n 0.4652 188000.0n 0.3811 188249.9n 0.3811 188250.0n 0.3811 188499.9n 0.3811 188500.0n 0.3811 188749.9n 0.3811 188750.0n 0.4484 188999.9n 0.4484 189000.0n 0.4484 189249.9n 0.4484 189250.0n 0.5493 189499.9n 0.5493 189500.0n 0.4989 189749.9n 0.4989 189750.0n 0.5661 189999.9n 0.5661 190000.0n 0.4989 190249.9n 0.4989 190250.0n 0.3811 190499.9n 0.3811 190500.0n 0.4989 190749.9n 0.4989 190750.0n 0.5661 190999.9n 0.5661 191000.0n 0.5661 191249.9n 0.5661 191250.0n 0.5661 191499.9n 0.5661 191500.0n 0.4820 191749.9n 0.4820 191750.0n 0.4148 191999.9n 0.4148 192000.0n 0.5325 192249.9n 0.5325 192250.0n 0.5493 192499.9n 0.5493 192500.0n 0.4820 192749.9n 0.4820 192750.0n 0.5661 192999.9n 0.5661 193000.0n 0.4652 193249.9n 0.4652 193250.0n 0.5661 193499.9n 0.5661 193500.0n 0.5661 193749.9n 0.5661 193750.0n 0.4316 193999.9n 0.4316 194000.0n 0.5661 194249.9n 0.5661 194250.0n 0.3811 194499.9n 0.3811 194500.0n 0.3475 194749.9n 0.3475 194750.0n 0.2802 194999.9n 0.2802 195000.0n 0.5661 195249.9n 0.5661 195250.0n 0.4652 195499.9n 0.4652 195500.0n 0.3811 195749.9n 0.3811 195750.0n 0.3811 195999.9n 0.3811 196000.0n 0.3811 196249.9n 0.3811 196250.0n 0.4484 196499.9n 0.4484 196500.0n 0.4484 196749.9n 0.4484 196750.0n 0.5493 196999.9n 0.5493 197000.0n 0.4989 197249.9n 0.4989 197250.0n 0.5661 197499.9n 0.5661 197500.0n 0.4989 197749.9n 0.4989 197750.0n 0.3811 197999.9n 0.3811 198000.0n 0.4989 198249.9n 0.4989 198250.0n 0.5661 198499.9n 0.5661 198500.0n 0.5661 198749.9n 0.5661 198750.0n 0.5661 198999.9n 0.5661 199000.0n 0.4820 199249.9n 0.4820 199250.0n 0.4148 199499.9n 0.4148 199500.0n 0.5325 199749.9n 0.5325 199750.0n 0.5493 199999.9n 0.5493 200000.0n 0.4820 200249.9n 0.4820 200250.0n 0.5661 200499.9n 0.5661 200500.0n 0.4652 200749.9n 0.4652 200750.0n 0.5661 200999.9n 0.5661 201000.0n 0.5661 201249.9n 0.5661 201250.0n 0.4316 201499.9n 0.4316 201500.0n 0.5661 201749.9n 0.5661 201750.0n 0.3811 201999.9n 0.3811 202000.0n 0.3475 202249.9n 0.3475 202250.0n 0.2802 202499.9n 0.2802 202500.0n 0.5661 202749.9n 0.5661 202750.0n 0.4652 202999.9n 0.4652 203000.0n 0.3811 203249.9n 0.3811 203250.0n 0.3811 203499.9n 0.3811 203500.0n 0.3811 203749.9n 0.3811 203750.0n 0.4484 203999.9n 0.4484 204000.0n 0.4484 204249.9n 0.4484 204250.0n 0.5493 204499.9n 0.5493 204500.0n 0.4989 204749.9n 0.4989 204750.0n 0.5661 204999.9n 0.5661 205000.0n 0.4989 205249.9n 0.4989 205250.0n 0.3811 205499.9n 0.3811 205500.0n 0.4989 205749.9n 0.4989 205750.0n 0.5661 205999.9n 0.5661 206000.0n 0.5661 206249.9n 0.5661 206250.0n 0.5661 206499.9n 0.5661 206500.0n 0.4820 206749.9n 0.4820 206750.0n 0.4148 206999.9n 0.4148 207000.0n 0.5325 207249.9n 0.5325 207250.0n 0.5493 207499.9n 0.5493 207500.0n 0.4820 207749.9n 0.4820 207750.0n 0.5661 207999.9n 0.5661 208000.0n 0.4652 208249.9n 0.4652 208250.0n 0.5661 208499.9n 0.5661 208500.0n 0.5661 208749.9n 0.5661 208750.0n 0.4316 208999.9n 0.4316 209000.0n 0.5661 209249.9n 0.5661 209250.0n 0.3811 209499.9n 0.3811 209500.0n 0.3475 209749.9n 0.3475 209750.0n 0.2802 209999.9n 0.2802 210000.0n 0.5661 210249.9n 0.5661 210250.0n 0.4652 210499.9n 0.4652 210500.0n 0.3811 210749.9n 0.3811 210750.0n 0.3811 210999.9n 0.3811 211000.0n 0.3811 211249.9n 0.3811 211250.0n 0.4484 211499.9n 0.4484 211500.0n 0.4484 211749.9n 0.4484 211750.0n 0.5493 211999.9n 0.5493 212000.0n 0.4989 212249.9n 0.4989 212250.0n 0.5661 212499.9n 0.5661 212500.0n 0.4989 212749.9n 0.4989 212750.0n 0.3811 212999.9n 0.3811 213000.0n 0.4989 213249.9n 0.4989 213250.0n 0.5661 213499.9n 0.5661 213500.0n 0.5661 213749.9n 0.5661 213750.0n 0.5661 213999.9n 0.5661 214000.0n 0.4820 214249.9n 0.4820 214250.0n 0.4148 214499.9n 0.4148 214500.0n 0.5325 214749.9n 0.5325 214750.0n 0.5493 214999.9n 0.5493 215000.0n 0.4820 215249.9n 0.4820 215250.0n 0.5661 215499.9n 0.5661 215500.0n 0.4652 215749.9n 0.4652 215750.0n 0.5661 215999.9n 0.5661 216000.0n 0.5661 216249.9n 0.5661 216250.0n 0.4316 216499.9n 0.4316 216500.0n 0.5661 216749.9n 0.5661 216750.0n 0.3811 216999.9n 0.3811 217000.0n 0.3475 217249.9n 0.3475 217250.0n 0.2802 217499.9n 0.2802 217500.0n 0.5661 217749.9n 0.5661 217750.0n 0.4652 217999.9n 0.4652 218000.0n 0.3811 218249.9n 0.3811 218250.0n 0.3811 218499.9n 0.3811 218500.0n 0.3811 218749.9n 0.3811 218750.0n 0.4484 218999.9n 0.4484 219000.0n 0.4484 219249.9n 0.4484 219250.0n 0.5493 219499.9n 0.5493 219500.0n 0.4989 219749.9n 0.4989 219750.0n 0.5661 219999.9n 0.5661 220000.0n 0.4989 220249.9n 0.4989 220250.0n 0.3811 220499.9n 0.3811 220500.0n 0.4989 220749.9n 0.4989 220750.0n 0.5661 220999.9n 0.5661 221000.0n 0.5661 221249.9n 0.5661 221250.0n 0.5661 221499.9n 0.5661 221500.0n 0.4820 221749.9n 0.4820 221750.0n 0.4148 221999.9n 0.4148 222000.0n 0.5325 222249.9n 0.5325 222250.0n 0.5493 222499.9n 0.5493 222500.0n 0.4820 222749.9n 0.4820 222750.0n 0.5661 222999.9n 0.5661 223000.0n 0.4652 223249.9n 0.4652 223250.0n 0.5661 223499.9n 0.5661 223500.0n 0.5661 223749.9n 0.5661 223750.0n 0.4316 223999.9n 0.4316 224000.0n 0.5661 224249.9n 0.5661 224250.0n 0.3811 224499.9n 0.3811 224500.0n 0.3475 224749.9n 0.3475 224750.0n 0.2802 224999.9n 0.2802 225000.0n 0.5661 225249.9n 0.5661 225250.0n 0.4652 225499.9n 0.4652 225500.0n 0.3811 225749.9n 0.3811 225750.0n 0.3811 225999.9n 0.3811 226000.0n 0.3811 226249.9n 0.3811 226250.0n 0.4484 226499.9n 0.4484 226500.0n 0.4484 226749.9n 0.4484 226750.0n 0.5493 226999.9n 0.5493 227000.0n 0.4989 227249.9n 0.4989 227250.0n 0.5661 227499.9n 0.5661 227500.0n 0.4989 227749.9n 0.4989 227750.0n 0.3811 227999.9n 0.3811 228000.0n 0.4989 228249.9n 0.4989 228250.0n 0.5661 228499.9n 0.5661 228500.0n 0.5661 228749.9n 0.5661 228750.0n 0.5661 228999.9n 0.5661 229000.0n 0.4820 229249.9n 0.4820 229250.0n 0.4148 229499.9n 0.4148 229500.0n 0.5325 229749.9n 0.5325 229750.0n 0.5493 229999.9n 0.5493 230000.0n 0.4820 230249.9n 0.4820 230250.0n 0.5661 230499.9n 0.5661 230500.0n 0.4652 230749.9n 0.4652 230750.0n 0.5661 230999.9n 0.5661 231000.0n 0.5661 231249.9n 0.5661 231250.0n 0.4316 231499.9n 0.4316 231500.0n 0.5661 231749.9n 0.5661 231750.0n 0.3811 231999.9n 0.3811 232000.0n 0.3475 232249.9n 0.3475 232250.0n 0.2802 232499.9n 0.2802 232500.0n 0.5661 232749.9n 0.5661 232750.0n 0.4652 232999.9n 0.4652 233000.0n 0.3811 233249.9n 0.3811 233250.0n 0.3811 233499.9n 0.3811 233500.0n 0.3811 233749.9n 0.3811 233750.0n 0.4484 233999.9n 0.4484 234000.0n 0.4484 234249.9n 0.4484 234250.0n 0.5493 234499.9n 0.5493 234500.0n 0.4989 234749.9n 0.4989 234750.0n 0.5661 234999.9n 0.5661 235000.0n 0.4989 235249.9n 0.4989 235250.0n 0.3811 235499.9n 0.3811 235500.0n 0.4989 235749.9n 0.4989 235750.0n 0.5661 235999.9n 0.5661 236000.0n 0.5661 236249.9n 0.5661 236250.0n 0.5661 236499.9n 0.5661 236500.0n 0.4820 236749.9n 0.4820 236750.0n 0.4148 236999.9n 0.4148 237000.0n 0.5325 237249.9n 0.5325 237250.0n 0.5493 237499.9n 0.5493 237500.0n 0.4820 237749.9n 0.4820 237750.0n 0.5661 237999.9n 0.5661 238000.0n 0.4652 238249.9n 0.4652 238250.0n 0.5661 238499.9n 0.5661 238500.0n 0.5661 238749.9n 0.5661 238750.0n 0.4316 238999.9n 0.4316 239000.0n 0.5661 239249.9n 0.5661 239250.0n 0.3811 239499.9n 0.3811 239500.0n 0.3475 239749.9n 0.3475 239750.0n 0.2802 239999.9n 0.2802 240000.0n 0.5661 240249.9n 0.5661 240250.0n 0.4652 240499.9n 0.4652 240500.0n 0.3811 240749.9n 0.3811 240750.0n 0.3811 240999.9n 0.3811 241000.0n 0.3811 241249.9n 0.3811 241250.0n 0.4484 241499.9n 0.4484 241500.0n 0.4484 241749.9n 0.4484 241750.0n 0.5493 241999.9n 0.5493 242000.0n 0.4989 242249.9n 0.4989 242250.0n 0.5661 242499.9n 0.5661 242500.0n 0.4989 242749.9n 0.4989 242750.0n 0.3811 242999.9n 0.3811 243000.0n 0.4989 243249.9n 0.4989 243250.0n 0.5661 243499.9n 0.5661 243500.0n 0.5661 243749.9n 0.5661 243750.0n 0.5661 243999.9n 0.5661 244000.0n 0.4820 244249.9n 0.4820 244250.0n 0.4148 244499.9n 0.4148 244500.0n 0.5325 244749.9n 0.5325 244750.0n 0.5493 244999.9n 0.5493 245000.0n 0.4820 245249.9n 0.4820 245250.0n 0.5661 245499.9n 0.5661 245500.0n 0.4652 245749.9n 0.4652 245750.0n 0.5661 245999.9n 0.5661 246000.0n 0.5661 246249.9n 0.5661 246250.0n 0.4316 246499.9n 0.4316 246500.0n 0.5661 246749.9n 0.5661 246750.0n 0.3811 246999.9n 0.3811 247000.0n 0.3475 247249.9n 0.3475 247250.0n 0.2802 247499.9n 0.2802 247500.0n 0.5661 247749.9n 0.5661 247750.0n 0.4652 247999.9n 0.4652 248000.0n 0.3811 248249.9n 0.3811 248250.0n 0.3811 248499.9n 0.3811 248500.0n 0.3811 248749.9n 0.3811 248750.0n 0.4484 248999.9n 0.4484 249000.0n 0.4484 249249.9n 0.4484 249250.0n 0.5493 249499.9n 0.5493 249500.0n 0.4989 249749.9n 0.4989 249750.0n 0.5661 249999.9n 0.5661 250000.0n 0.4989 250249.9n 0.4989 250250.0n 0.3811 250499.9n 0.3811 250500.0n 0.4989 250749.9n 0.4989 250750.0n 0.5661 250999.9n 0.5661 251000.0n 0.5661 251249.9n 0.5661 251250.0n 0.5661 251499.9n 0.5661 251500.0n 0.4820 251749.9n 0.4820 251750.0n 0.4148 251999.9n 0.4148 252000.0n 0.5325 252249.9n 0.5325 252250.0n 0.5493 252499.9n 0.5493 252500.0n 0.4820 252749.9n 0.4820 252750.0n 0.5661 252999.9n 0.5661 253000.0n 0.4652 253249.9n 0.4652 253250.0n 0.5661 253499.9n 0.5661 253500.0n 0.5661 253749.9n 0.5661 253750.0n 0.4316 253999.9n 0.4316 254000.0n 0.5661 254249.9n 0.5661 254250.0n 0.3811 254499.9n 0.3811 254500.0n 0.3475 254749.9n 0.3475 254750.0n 0.2802 254999.9n 0.2802 255000.0n 0.5661 255249.9n 0.5661 255250.0n 0.4652 255499.9n 0.4652 255500.0n 0.3811 255749.9n 0.3811 255750.0n 0.3811 255999.9n 0.3811 256000.0n 0.3811 256249.9n 0.3811 256250.0n 0.4484 256499.9n 0.4484 256500.0n 0.4484 256749.9n 0.4484 256750.0n 0.5493 256999.9n 0.5493 257000.0n 0.4989 257249.9n 0.4989 257250.0n 0.5661 257499.9n 0.5661 257500.0n 0.4989 257749.9n 0.4989 257750.0n 0.3811 257999.9n 0.3811 258000.0n 0.4989 258249.9n 0.4989 258250.0n 0.5661 258499.9n 0.5661 258500.0n 0.5661 258749.9n 0.5661 258750.0n 0.5661 258999.9n 0.5661 259000.0n 0.4820 259249.9n 0.4820 259250.0n 0.4148 259499.9n 0.4148 259500.0n 0.5325 259749.9n 0.5325 259750.0n 0.5493 259999.9n 0.5493 260000.0n 0.4820 260249.9n 0.4820 260250.0n 0.5661 260499.9n 0.5661 260500.0n 0.4652 260749.9n 0.4652 260750.0n 0.5661 260999.9n 0.5661 261000.0n 0.5661 261249.9n 0.5661 261250.0n 0.4316 261499.9n 0.4316 261500.0n 0.5661 261749.9n 0.5661 261750.0n 0.3811 261999.9n 0.3811 262000.0n 0.3475 262249.9n 0.3475 262250.0n 0.2802 262499.9n 0.2802 262500.0n 0.5661 262749.9n 0.5661 262750.0n 0.4652 262999.9n 0.4652 263000.0n 0.3811 263249.9n 0.3811 263250.0n 0.3811 263499.9n 0.3811 263500.0n 0.3811 263749.9n 0.3811 263750.0n 0.4484 263999.9n 0.4484 264000.0n 0.4484 264249.9n 0.4484 264250.0n 0.5493 264499.9n 0.5493 264500.0n 0.4989 264749.9n 0.4989 264750.0n 0.5661 264999.9n 0.5661 265000.0n 0.4989 265249.9n 0.4989 265250.0n 0.3811 265499.9n 0.3811 265500.0n 0.4989 265749.9n 0.4989 265750.0n 0.5661 265999.9n 0.5661 266000.0n 0.5661 266249.9n 0.5661 266250.0n 0.5661 266499.9n 0.5661 266500.0n 0.4820 266749.9n 0.4820 266750.0n 0.4148 266999.9n 0.4148 267000.0n 0.5325 267249.9n 0.5325 267250.0n 0.5493 267499.9n 0.5493 267500.0n 0.4820 267749.9n 0.4820 267750.0n 0.5661 267999.9n 0.5661 268000.0n 0.4652 268249.9n 0.4652 268250.0n 0.5661 268499.9n 0.5661 268500.0n 0.5661 268749.9n 0.5661 268750.0n 0.4316 268999.9n 0.4316 269000.0n 0.5661 269249.9n 0.5661 269250.0n 0.3811 269499.9n 0.3811 269500.0n 0.3475 269749.9n 0.3475 269750.0n 0.2802 269999.9n 0.2802 270000.0n 0.5661 270249.9n 0.5661 270250.0n 0.4652 270499.9n 0.4652 270500.0n 0.3811 270749.9n 0.3811 270750.0n 0.3811 270999.9n 0.3811 271000.0n 0.3811 271249.9n 0.3811 271250.0n 0.4484 271499.9n 0.4484 271500.0n 0.4484 271749.9n 0.4484 271750.0n 0.5493 271999.9n 0.5493 272000.0n 0.4989 272249.9n 0.4989 272250.0n 0.5661 272499.9n 0.5661 272500.0n 0.4989 272749.9n 0.4989 272750.0n 0.3811 272999.9n 0.3811 273000.0n 0.4989 273249.9n 0.4989 273250.0n 0.5661 273499.9n 0.5661 273500.0n 0.5661 273749.9n 0.5661 273750.0n 0.5661 273999.9n 0.5661 274000.0n 0.4820 274249.9n 0.4820 274250.0n 0.4148 274499.9n 0.4148 274500.0n 0.5325 274749.9n 0.5325 274750.0n 0.5493 274999.9n 0.5493 275000.0n 0.4820 275249.9n 0.4820 275250.0n 0.5661 275499.9n 0.5661 275500.0n 0.4652 275749.9n 0.4652 275750.0n 0.5661 275999.9n 0.5661 276000.0n 0.5661 276249.9n 0.5661 276250.0n 0.4316 276499.9n 0.4316 276500.0n 0.5661 276749.9n 0.5661 276750.0n 0.3811 276999.9n 0.3811 277000.0n 0.3475 277249.9n 0.3475 277250.0n 0.2802 277499.9n 0.2802 277500.0n 0.5661 277749.9n 0.5661 277750.0n 0.4652 277999.9n 0.4652 278000.0n 0.3811 278249.9n 0.3811 278250.0n 0.3811 278499.9n 0.3811 278500.0n 0.3811 278749.9n 0.3811 278750.0n 0.4484 278999.9n 0.4484 279000.0n 0.4484 279249.9n 0.4484 279250.0n 0.5493 279499.9n 0.5493 279500.0n 0.4989 279749.9n 0.4989 279750.0n 0.5661 279999.9n 0.5661 280000.0n 0.4989 280249.9n 0.4989 280250.0n 0.3811 280499.9n 0.3811 280500.0n 0.4989 280749.9n 0.4989 280750.0n 0.5661 280999.9n 0.5661 281000.0n 0.5661 281249.9n 0.5661 281250.0n 0.5661 281499.9n 0.5661 281500.0n 0.4820 281749.9n 0.4820 281750.0n 0.4148 281999.9n 0.4148 282000.0n 0.5325 282249.9n 0.5325 282250.0n 0.5493 282499.9n 0.5493 282500.0n 0.4820 282749.9n 0.4820 282750.0n 0.5661 282999.9n 0.5661 283000.0n 0.4652 283249.9n 0.4652 283250.0n 0.5661 283499.9n 0.5661 283500.0n 0.5661 283749.9n 0.5661 283750.0n 0.4316 283999.9n 0.4316 284000.0n 0.5661 284249.9n 0.5661 284250.0n 0.3811 284499.9n 0.3811 284500.0n 0.3475 284749.9n 0.3475 284750.0n 0.2802 284999.9n 0.2802 285000.0n 0.5661 285249.9n 0.5661 285250.0n 0.4652 285499.9n 0.4652 285500.0n 0.3811 285749.9n 0.3811 285750.0n 0.3811 285999.9n 0.3811 286000.0n 0.3811 286249.9n 0.3811 286250.0n 0.4484 286499.9n 0.4484 286500.0n 0.4484 286749.9n 0.4484 286750.0n 0.5493 286999.9n 0.5493 287000.0n 0.4989 287249.9n 0.4989 287250.0n 0.5661 287499.9n 0.5661 287500.0n 0.4989 287749.9n 0.4989 287750.0n 0.3811 287999.9n 0.3811 288000.0n 0.4989 288249.9n 0.4989 288250.0n 0.5661 288499.9n 0.5661 288500.0n 0.5661 288749.9n 0.5661 288750.0n 0.5661 288999.9n 0.5661 289000.0n 0.4820 289249.9n 0.4820 289250.0n 0.4148 289499.9n 0.4148 289500.0n 0.5325 289749.9n 0.5325 289750.0n 0.5493 289999.9n 0.5493 290000.0n 0.4820 290249.9n 0.4820 290250.0n 0.5661 290499.9n 0.5661 290500.0n 0.4652 290749.9n 0.4652 290750.0n 0.5661 290999.9n 0.5661 291000.0n 0.5661 291249.9n 0.5661 291250.0n 0.4316 291499.9n 0.4316 291500.0n 0.5661 291749.9n 0.5661 291750.0n 0.3811 291999.9n 0.3811 292000.0n 0.3475 292249.9n 0.3475 292250.0n 0.2802 292499.9n 0.2802 292500.0n 0.5661 292749.9n 0.5661 292750.0n 0.4652 292999.9n 0.4652 293000.0n 0.3811 293249.9n 0.3811 293250.0n 0.3811 293499.9n 0.3811 293500.0n 0.3811 293749.9n 0.3811 293750.0n 0.4484 293999.9n 0.4484 294000.0n 0.4484 294249.9n 0.4484 294250.0n 0.5493 294499.9n 0.5493 294500.0n 0.4989 294749.9n 0.4989 294750.0n 0.5661 294999.9n 0.5661 295000.0n 0.4989 295249.9n 0.4989 295250.0n 0.3811 295499.9n 0.3811 295500.0n 0.4989 295749.9n 0.4989 295750.0n 0.5661 295999.9n 0.5661 296000.0n 0.5661 296249.9n 0.5661 296250.0n 0.5661 296499.9n 0.5661 296500.0n 0.4820 296749.9n 0.4820 296750.0n 0.4148 296999.9n 0.4148 297000.0n 0.5325 297249.9n 0.5325 297250.0n 0.5493 297499.9n 0.5493 297500.0n 0.4820 297749.9n 0.4820 297750.0n 0.5661 297999.9n 0.5661 298000.0n 0.4652 298249.9n 0.4652 298250.0n 0.5661 298499.9n 0.5661 298500.0n 0.5661 298749.9n 0.5661 298750.0n 0.4316 298999.9n 0.4316 299000.0n 0.5661 299249.9n 0.5661 299250.0n 0.3811 299499.9n 0.3811 299500.0n 0.3475 299749.9n 0.3475 299750.0n 0.2802)
Vxp9 a_xp9 0 PWL(0.0n 0.3356 249.9n 0.3356 250.0n 0.4582 499.9n 0.4582 500.0n 0.4742 749.9n 0.4742 750.0n 0.4475 999.9n 0.4475 1000.0n 0.5115 1249.9n 0.5115 1250.0n 0.5541 1499.9n 0.5541 1500.0n 0.4422 1749.9n 0.4422 1750.0n 0.4475 1999.9n 0.4475 2000.0n 0.6660 2249.9n 0.6660 2250.0n 0.4635 2499.9n 0.4635 2500.0n 0.5861 2749.9n 0.5861 2750.0n 0.4742 2999.9n 0.4742 3000.0n 0.4369 3249.9n 0.4369 3250.0n 0.5807 3499.9n 0.5807 3500.0n 0.5381 3749.9n 0.5381 3750.0n 0.6180 3999.9n 0.6180 4000.0n 0.6020 4249.9n 0.6020 4250.0n 0.4848 4499.9n 0.4848 4500.0n 0.5008 4749.9n 0.5008 4750.0n 0.6660 4999.9n 0.6660 5000.0n 0.5115 5249.9n 0.5115 5250.0n 0.4315 5499.9n 0.4315 5500.0n 0.4635 5749.9n 0.4635 5750.0n 0.5061 5999.9n 0.5061 6000.0n 0.3356 6249.9n 0.3356 6250.0n 0.5541 6499.9n 0.5541 6500.0n 0.4209 6749.9n 0.4209 6750.0n 0.4902 6999.9n 0.4902 7000.0n 0.4742 7249.9n 0.4742 7250.0n 0.4848 7499.9n 0.4848 7500.0n 0.3356 7749.9n 0.3356 7750.0n 0.4582 7999.9n 0.4582 8000.0n 0.4742 8249.9n 0.4742 8250.0n 0.4475 8499.9n 0.4475 8500.0n 0.5115 8749.9n 0.5115 8750.0n 0.5541 8999.9n 0.5541 9000.0n 0.4422 9249.9n 0.4422 9250.0n 0.4475 9499.9n 0.4475 9500.0n 0.6660 9749.9n 0.6660 9750.0n 0.4635 9999.9n 0.4635 10000.0n 0.5861 10249.9n 0.5861 10250.0n 0.4742 10499.9n 0.4742 10500.0n 0.4369 10749.9n 0.4369 10750.0n 0.5807 10999.9n 0.5807 11000.0n 0.5381 11249.9n 0.5381 11250.0n 0.6180 11499.9n 0.6180 11500.0n 0.6020 11749.9n 0.6020 11750.0n 0.4848 11999.9n 0.4848 12000.0n 0.5008 12249.9n 0.5008 12250.0n 0.6660 12499.9n 0.6660 12500.0n 0.5115 12749.9n 0.5115 12750.0n 0.4315 12999.9n 0.4315 13000.0n 0.4635 13249.9n 0.4635 13250.0n 0.5061 13499.9n 0.5061 13500.0n 0.3356 13749.9n 0.3356 13750.0n 0.5541 13999.9n 0.5541 14000.0n 0.4209 14249.9n 0.4209 14250.0n 0.4902 14499.9n 0.4902 14500.0n 0.4742 14749.9n 0.4742 14750.0n 0.4848 14999.9n 0.4848 15000.0n 0.3356 15249.9n 0.3356 15250.0n 0.4582 15499.9n 0.4582 15500.0n 0.4742 15749.9n 0.4742 15750.0n 0.4475 15999.9n 0.4475 16000.0n 0.5115 16249.9n 0.5115 16250.0n 0.5541 16499.9n 0.5541 16500.0n 0.4422 16749.9n 0.4422 16750.0n 0.4475 16999.9n 0.4475 17000.0n 0.6660 17249.9n 0.6660 17250.0n 0.4635 17499.9n 0.4635 17500.0n 0.5861 17749.9n 0.5861 17750.0n 0.4742 17999.9n 0.4742 18000.0n 0.4369 18249.9n 0.4369 18250.0n 0.5807 18499.9n 0.5807 18500.0n 0.5381 18749.9n 0.5381 18750.0n 0.6180 18999.9n 0.6180 19000.0n 0.6020 19249.9n 0.6020 19250.0n 0.4848 19499.9n 0.4848 19500.0n 0.5008 19749.9n 0.5008 19750.0n 0.6660 19999.9n 0.6660 20000.0n 0.5115 20249.9n 0.5115 20250.0n 0.4315 20499.9n 0.4315 20500.0n 0.4635 20749.9n 0.4635 20750.0n 0.5061 20999.9n 0.5061 21000.0n 0.3356 21249.9n 0.3356 21250.0n 0.5541 21499.9n 0.5541 21500.0n 0.4209 21749.9n 0.4209 21750.0n 0.4902 21999.9n 0.4902 22000.0n 0.4742 22249.9n 0.4742 22250.0n 0.4848 22499.9n 0.4848 22500.0n 0.3356 22749.9n 0.3356 22750.0n 0.4582 22999.9n 0.4582 23000.0n 0.4742 23249.9n 0.4742 23250.0n 0.4475 23499.9n 0.4475 23500.0n 0.5115 23749.9n 0.5115 23750.0n 0.5541 23999.9n 0.5541 24000.0n 0.4422 24249.9n 0.4422 24250.0n 0.4475 24499.9n 0.4475 24500.0n 0.6660 24749.9n 0.6660 24750.0n 0.4635 24999.9n 0.4635 25000.0n 0.5861 25249.9n 0.5861 25250.0n 0.4742 25499.9n 0.4742 25500.0n 0.4369 25749.9n 0.4369 25750.0n 0.5807 25999.9n 0.5807 26000.0n 0.5381 26249.9n 0.5381 26250.0n 0.6180 26499.9n 0.6180 26500.0n 0.6020 26749.9n 0.6020 26750.0n 0.4848 26999.9n 0.4848 27000.0n 0.5008 27249.9n 0.5008 27250.0n 0.6660 27499.9n 0.6660 27500.0n 0.5115 27749.9n 0.5115 27750.0n 0.4315 27999.9n 0.4315 28000.0n 0.4635 28249.9n 0.4635 28250.0n 0.5061 28499.9n 0.5061 28500.0n 0.3356 28749.9n 0.3356 28750.0n 0.5541 28999.9n 0.5541 29000.0n 0.4209 29249.9n 0.4209 29250.0n 0.4902 29499.9n 0.4902 29500.0n 0.4742 29749.9n 0.4742 29750.0n 0.4848 29999.9n 0.4848 30000.0n 0.3356 30249.9n 0.3356 30250.0n 0.4582 30499.9n 0.4582 30500.0n 0.4742 30749.9n 0.4742 30750.0n 0.4475 30999.9n 0.4475 31000.0n 0.5115 31249.9n 0.5115 31250.0n 0.5541 31499.9n 0.5541 31500.0n 0.4422 31749.9n 0.4422 31750.0n 0.4475 31999.9n 0.4475 32000.0n 0.6660 32249.9n 0.6660 32250.0n 0.4635 32499.9n 0.4635 32500.0n 0.5861 32749.9n 0.5861 32750.0n 0.4742 32999.9n 0.4742 33000.0n 0.4369 33249.9n 0.4369 33250.0n 0.5807 33499.9n 0.5807 33500.0n 0.5381 33749.9n 0.5381 33750.0n 0.6180 33999.9n 0.6180 34000.0n 0.6020 34249.9n 0.6020 34250.0n 0.4848 34499.9n 0.4848 34500.0n 0.5008 34749.9n 0.5008 34750.0n 0.6660 34999.9n 0.6660 35000.0n 0.5115 35249.9n 0.5115 35250.0n 0.4315 35499.9n 0.4315 35500.0n 0.4635 35749.9n 0.4635 35750.0n 0.5061 35999.9n 0.5061 36000.0n 0.3356 36249.9n 0.3356 36250.0n 0.5541 36499.9n 0.5541 36500.0n 0.4209 36749.9n 0.4209 36750.0n 0.4902 36999.9n 0.4902 37000.0n 0.4742 37249.9n 0.4742 37250.0n 0.4848 37499.9n 0.4848 37500.0n 0.3356 37749.9n 0.3356 37750.0n 0.4582 37999.9n 0.4582 38000.0n 0.4742 38249.9n 0.4742 38250.0n 0.4475 38499.9n 0.4475 38500.0n 0.5115 38749.9n 0.5115 38750.0n 0.5541 38999.9n 0.5541 39000.0n 0.4422 39249.9n 0.4422 39250.0n 0.4475 39499.9n 0.4475 39500.0n 0.6660 39749.9n 0.6660 39750.0n 0.4635 39999.9n 0.4635 40000.0n 0.5861 40249.9n 0.5861 40250.0n 0.4742 40499.9n 0.4742 40500.0n 0.4369 40749.9n 0.4369 40750.0n 0.5807 40999.9n 0.5807 41000.0n 0.5381 41249.9n 0.5381 41250.0n 0.6180 41499.9n 0.6180 41500.0n 0.6020 41749.9n 0.6020 41750.0n 0.4848 41999.9n 0.4848 42000.0n 0.5008 42249.9n 0.5008 42250.0n 0.6660 42499.9n 0.6660 42500.0n 0.5115 42749.9n 0.5115 42750.0n 0.4315 42999.9n 0.4315 43000.0n 0.4635 43249.9n 0.4635 43250.0n 0.5061 43499.9n 0.5061 43500.0n 0.3356 43749.9n 0.3356 43750.0n 0.5541 43999.9n 0.5541 44000.0n 0.4209 44249.9n 0.4209 44250.0n 0.4902 44499.9n 0.4902 44500.0n 0.4742 44749.9n 0.4742 44750.0n 0.4848 44999.9n 0.4848 45000.0n 0.3356 45249.9n 0.3356 45250.0n 0.4582 45499.9n 0.4582 45500.0n 0.4742 45749.9n 0.4742 45750.0n 0.4475 45999.9n 0.4475 46000.0n 0.5115 46249.9n 0.5115 46250.0n 0.5541 46499.9n 0.5541 46500.0n 0.4422 46749.9n 0.4422 46750.0n 0.4475 46999.9n 0.4475 47000.0n 0.6660 47249.9n 0.6660 47250.0n 0.4635 47499.9n 0.4635 47500.0n 0.5861 47749.9n 0.5861 47750.0n 0.4742 47999.9n 0.4742 48000.0n 0.4369 48249.9n 0.4369 48250.0n 0.5807 48499.9n 0.5807 48500.0n 0.5381 48749.9n 0.5381 48750.0n 0.6180 48999.9n 0.6180 49000.0n 0.6020 49249.9n 0.6020 49250.0n 0.4848 49499.9n 0.4848 49500.0n 0.5008 49749.9n 0.5008 49750.0n 0.6660 49999.9n 0.6660 50000.0n 0.5115 50249.9n 0.5115 50250.0n 0.4315 50499.9n 0.4315 50500.0n 0.4635 50749.9n 0.4635 50750.0n 0.5061 50999.9n 0.5061 51000.0n 0.3356 51249.9n 0.3356 51250.0n 0.5541 51499.9n 0.5541 51500.0n 0.4209 51749.9n 0.4209 51750.0n 0.4902 51999.9n 0.4902 52000.0n 0.4742 52249.9n 0.4742 52250.0n 0.4848 52499.9n 0.4848 52500.0n 0.3356 52749.9n 0.3356 52750.0n 0.4582 52999.9n 0.4582 53000.0n 0.4742 53249.9n 0.4742 53250.0n 0.4475 53499.9n 0.4475 53500.0n 0.5115 53749.9n 0.5115 53750.0n 0.5541 53999.9n 0.5541 54000.0n 0.4422 54249.9n 0.4422 54250.0n 0.4475 54499.9n 0.4475 54500.0n 0.6660 54749.9n 0.6660 54750.0n 0.4635 54999.9n 0.4635 55000.0n 0.5861 55249.9n 0.5861 55250.0n 0.4742 55499.9n 0.4742 55500.0n 0.4369 55749.9n 0.4369 55750.0n 0.5807 55999.9n 0.5807 56000.0n 0.5381 56249.9n 0.5381 56250.0n 0.6180 56499.9n 0.6180 56500.0n 0.6020 56749.9n 0.6020 56750.0n 0.4848 56999.9n 0.4848 57000.0n 0.5008 57249.9n 0.5008 57250.0n 0.6660 57499.9n 0.6660 57500.0n 0.5115 57749.9n 0.5115 57750.0n 0.4315 57999.9n 0.4315 58000.0n 0.4635 58249.9n 0.4635 58250.0n 0.5061 58499.9n 0.5061 58500.0n 0.3356 58749.9n 0.3356 58750.0n 0.5541 58999.9n 0.5541 59000.0n 0.4209 59249.9n 0.4209 59250.0n 0.4902 59499.9n 0.4902 59500.0n 0.4742 59749.9n 0.4742 59750.0n 0.4848 59999.9n 0.4848 60000.0n 0.3356 60249.9n 0.3356 60250.0n 0.4582 60499.9n 0.4582 60500.0n 0.4742 60749.9n 0.4742 60750.0n 0.4475 60999.9n 0.4475 61000.0n 0.5115 61249.9n 0.5115 61250.0n 0.5541 61499.9n 0.5541 61500.0n 0.4422 61749.9n 0.4422 61750.0n 0.4475 61999.9n 0.4475 62000.0n 0.6660 62249.9n 0.6660 62250.0n 0.4635 62499.9n 0.4635 62500.0n 0.5861 62749.9n 0.5861 62750.0n 0.4742 62999.9n 0.4742 63000.0n 0.4369 63249.9n 0.4369 63250.0n 0.5807 63499.9n 0.5807 63500.0n 0.5381 63749.9n 0.5381 63750.0n 0.6180 63999.9n 0.6180 64000.0n 0.6020 64249.9n 0.6020 64250.0n 0.4848 64499.9n 0.4848 64500.0n 0.5008 64749.9n 0.5008 64750.0n 0.6660 64999.9n 0.6660 65000.0n 0.5115 65249.9n 0.5115 65250.0n 0.4315 65499.9n 0.4315 65500.0n 0.4635 65749.9n 0.4635 65750.0n 0.5061 65999.9n 0.5061 66000.0n 0.3356 66249.9n 0.3356 66250.0n 0.5541 66499.9n 0.5541 66500.0n 0.4209 66749.9n 0.4209 66750.0n 0.4902 66999.9n 0.4902 67000.0n 0.4742 67249.9n 0.4742 67250.0n 0.4848 67499.9n 0.4848 67500.0n 0.3356 67749.9n 0.3356 67750.0n 0.4582 67999.9n 0.4582 68000.0n 0.4742 68249.9n 0.4742 68250.0n 0.4475 68499.9n 0.4475 68500.0n 0.5115 68749.9n 0.5115 68750.0n 0.5541 68999.9n 0.5541 69000.0n 0.4422 69249.9n 0.4422 69250.0n 0.4475 69499.9n 0.4475 69500.0n 0.6660 69749.9n 0.6660 69750.0n 0.4635 69999.9n 0.4635 70000.0n 0.5861 70249.9n 0.5861 70250.0n 0.4742 70499.9n 0.4742 70500.0n 0.4369 70749.9n 0.4369 70750.0n 0.5807 70999.9n 0.5807 71000.0n 0.5381 71249.9n 0.5381 71250.0n 0.6180 71499.9n 0.6180 71500.0n 0.6020 71749.9n 0.6020 71750.0n 0.4848 71999.9n 0.4848 72000.0n 0.5008 72249.9n 0.5008 72250.0n 0.6660 72499.9n 0.6660 72500.0n 0.5115 72749.9n 0.5115 72750.0n 0.4315 72999.9n 0.4315 73000.0n 0.4635 73249.9n 0.4635 73250.0n 0.5061 73499.9n 0.5061 73500.0n 0.3356 73749.9n 0.3356 73750.0n 0.5541 73999.9n 0.5541 74000.0n 0.4209 74249.9n 0.4209 74250.0n 0.4902 74499.9n 0.4902 74500.0n 0.4742 74749.9n 0.4742 74750.0n 0.4848 74999.9n 0.4848 75000.0n 0.3356 75249.9n 0.3356 75250.0n 0.4582 75499.9n 0.4582 75500.0n 0.4742 75749.9n 0.4742 75750.0n 0.4475 75999.9n 0.4475 76000.0n 0.5115 76249.9n 0.5115 76250.0n 0.5541 76499.9n 0.5541 76500.0n 0.4422 76749.9n 0.4422 76750.0n 0.4475 76999.9n 0.4475 77000.0n 0.6660 77249.9n 0.6660 77250.0n 0.4635 77499.9n 0.4635 77500.0n 0.5861 77749.9n 0.5861 77750.0n 0.4742 77999.9n 0.4742 78000.0n 0.4369 78249.9n 0.4369 78250.0n 0.5807 78499.9n 0.5807 78500.0n 0.5381 78749.9n 0.5381 78750.0n 0.6180 78999.9n 0.6180 79000.0n 0.6020 79249.9n 0.6020 79250.0n 0.4848 79499.9n 0.4848 79500.0n 0.5008 79749.9n 0.5008 79750.0n 0.6660 79999.9n 0.6660 80000.0n 0.5115 80249.9n 0.5115 80250.0n 0.4315 80499.9n 0.4315 80500.0n 0.4635 80749.9n 0.4635 80750.0n 0.5061 80999.9n 0.5061 81000.0n 0.3356 81249.9n 0.3356 81250.0n 0.5541 81499.9n 0.5541 81500.0n 0.4209 81749.9n 0.4209 81750.0n 0.4902 81999.9n 0.4902 82000.0n 0.4742 82249.9n 0.4742 82250.0n 0.4848 82499.9n 0.4848 82500.0n 0.3356 82749.9n 0.3356 82750.0n 0.4582 82999.9n 0.4582 83000.0n 0.4742 83249.9n 0.4742 83250.0n 0.4475 83499.9n 0.4475 83500.0n 0.5115 83749.9n 0.5115 83750.0n 0.5541 83999.9n 0.5541 84000.0n 0.4422 84249.9n 0.4422 84250.0n 0.4475 84499.9n 0.4475 84500.0n 0.6660 84749.9n 0.6660 84750.0n 0.4635 84999.9n 0.4635 85000.0n 0.5861 85249.9n 0.5861 85250.0n 0.4742 85499.9n 0.4742 85500.0n 0.4369 85749.9n 0.4369 85750.0n 0.5807 85999.9n 0.5807 86000.0n 0.5381 86249.9n 0.5381 86250.0n 0.6180 86499.9n 0.6180 86500.0n 0.6020 86749.9n 0.6020 86750.0n 0.4848 86999.9n 0.4848 87000.0n 0.5008 87249.9n 0.5008 87250.0n 0.6660 87499.9n 0.6660 87500.0n 0.5115 87749.9n 0.5115 87750.0n 0.4315 87999.9n 0.4315 88000.0n 0.4635 88249.9n 0.4635 88250.0n 0.5061 88499.9n 0.5061 88500.0n 0.3356 88749.9n 0.3356 88750.0n 0.5541 88999.9n 0.5541 89000.0n 0.4209 89249.9n 0.4209 89250.0n 0.4902 89499.9n 0.4902 89500.0n 0.4742 89749.9n 0.4742 89750.0n 0.4848 89999.9n 0.4848 90000.0n 0.3356 90249.9n 0.3356 90250.0n 0.4582 90499.9n 0.4582 90500.0n 0.4742 90749.9n 0.4742 90750.0n 0.4475 90999.9n 0.4475 91000.0n 0.5115 91249.9n 0.5115 91250.0n 0.5541 91499.9n 0.5541 91500.0n 0.4422 91749.9n 0.4422 91750.0n 0.4475 91999.9n 0.4475 92000.0n 0.6660 92249.9n 0.6660 92250.0n 0.4635 92499.9n 0.4635 92500.0n 0.5861 92749.9n 0.5861 92750.0n 0.4742 92999.9n 0.4742 93000.0n 0.4369 93249.9n 0.4369 93250.0n 0.5807 93499.9n 0.5807 93500.0n 0.5381 93749.9n 0.5381 93750.0n 0.6180 93999.9n 0.6180 94000.0n 0.6020 94249.9n 0.6020 94250.0n 0.4848 94499.9n 0.4848 94500.0n 0.5008 94749.9n 0.5008 94750.0n 0.6660 94999.9n 0.6660 95000.0n 0.5115 95249.9n 0.5115 95250.0n 0.4315 95499.9n 0.4315 95500.0n 0.4635 95749.9n 0.4635 95750.0n 0.5061 95999.9n 0.5061 96000.0n 0.3356 96249.9n 0.3356 96250.0n 0.5541 96499.9n 0.5541 96500.0n 0.4209 96749.9n 0.4209 96750.0n 0.4902 96999.9n 0.4902 97000.0n 0.4742 97249.9n 0.4742 97250.0n 0.4848 97499.9n 0.4848 97500.0n 0.3356 97749.9n 0.3356 97750.0n 0.4582 97999.9n 0.4582 98000.0n 0.4742 98249.9n 0.4742 98250.0n 0.4475 98499.9n 0.4475 98500.0n 0.5115 98749.9n 0.5115 98750.0n 0.5541 98999.9n 0.5541 99000.0n 0.4422 99249.9n 0.4422 99250.0n 0.4475 99499.9n 0.4475 99500.0n 0.6660 99749.9n 0.6660 99750.0n 0.4635 99999.9n 0.4635 100000.0n 0.5861 100249.9n 0.5861 100250.0n 0.4742 100499.9n 0.4742 100500.0n 0.4369 100749.9n 0.4369 100750.0n 0.5807 100999.9n 0.5807 101000.0n 0.5381 101249.9n 0.5381 101250.0n 0.6180 101499.9n 0.6180 101500.0n 0.6020 101749.9n 0.6020 101750.0n 0.4848 101999.9n 0.4848 102000.0n 0.5008 102249.9n 0.5008 102250.0n 0.6660 102499.9n 0.6660 102500.0n 0.5115 102749.9n 0.5115 102750.0n 0.4315 102999.9n 0.4315 103000.0n 0.4635 103249.9n 0.4635 103250.0n 0.5061 103499.9n 0.5061 103500.0n 0.3356 103749.9n 0.3356 103750.0n 0.5541 103999.9n 0.5541 104000.0n 0.4209 104249.9n 0.4209 104250.0n 0.4902 104499.9n 0.4902 104500.0n 0.4742 104749.9n 0.4742 104750.0n 0.4848 104999.9n 0.4848 105000.0n 0.3356 105249.9n 0.3356 105250.0n 0.4582 105499.9n 0.4582 105500.0n 0.4742 105749.9n 0.4742 105750.0n 0.4475 105999.9n 0.4475 106000.0n 0.5115 106249.9n 0.5115 106250.0n 0.5541 106499.9n 0.5541 106500.0n 0.4422 106749.9n 0.4422 106750.0n 0.4475 106999.9n 0.4475 107000.0n 0.6660 107249.9n 0.6660 107250.0n 0.4635 107499.9n 0.4635 107500.0n 0.5861 107749.9n 0.5861 107750.0n 0.4742 107999.9n 0.4742 108000.0n 0.4369 108249.9n 0.4369 108250.0n 0.5807 108499.9n 0.5807 108500.0n 0.5381 108749.9n 0.5381 108750.0n 0.6180 108999.9n 0.6180 109000.0n 0.6020 109249.9n 0.6020 109250.0n 0.4848 109499.9n 0.4848 109500.0n 0.5008 109749.9n 0.5008 109750.0n 0.6660 109999.9n 0.6660 110000.0n 0.5115 110249.9n 0.5115 110250.0n 0.4315 110499.9n 0.4315 110500.0n 0.4635 110749.9n 0.4635 110750.0n 0.5061 110999.9n 0.5061 111000.0n 0.3356 111249.9n 0.3356 111250.0n 0.5541 111499.9n 0.5541 111500.0n 0.4209 111749.9n 0.4209 111750.0n 0.4902 111999.9n 0.4902 112000.0n 0.4742 112249.9n 0.4742 112250.0n 0.4848 112499.9n 0.4848 112500.0n 0.3356 112749.9n 0.3356 112750.0n 0.4582 112999.9n 0.4582 113000.0n 0.4742 113249.9n 0.4742 113250.0n 0.4475 113499.9n 0.4475 113500.0n 0.5115 113749.9n 0.5115 113750.0n 0.5541 113999.9n 0.5541 114000.0n 0.4422 114249.9n 0.4422 114250.0n 0.4475 114499.9n 0.4475 114500.0n 0.6660 114749.9n 0.6660 114750.0n 0.4635 114999.9n 0.4635 115000.0n 0.5861 115249.9n 0.5861 115250.0n 0.4742 115499.9n 0.4742 115500.0n 0.4369 115749.9n 0.4369 115750.0n 0.5807 115999.9n 0.5807 116000.0n 0.5381 116249.9n 0.5381 116250.0n 0.6180 116499.9n 0.6180 116500.0n 0.6020 116749.9n 0.6020 116750.0n 0.4848 116999.9n 0.4848 117000.0n 0.5008 117249.9n 0.5008 117250.0n 0.6660 117499.9n 0.6660 117500.0n 0.5115 117749.9n 0.5115 117750.0n 0.4315 117999.9n 0.4315 118000.0n 0.4635 118249.9n 0.4635 118250.0n 0.5061 118499.9n 0.5061 118500.0n 0.3356 118749.9n 0.3356 118750.0n 0.5541 118999.9n 0.5541 119000.0n 0.4209 119249.9n 0.4209 119250.0n 0.4902 119499.9n 0.4902 119500.0n 0.4742 119749.9n 0.4742 119750.0n 0.4848 119999.9n 0.4848 120000.0n 0.3356 120249.9n 0.3356 120250.0n 0.4582 120499.9n 0.4582 120500.0n 0.4742 120749.9n 0.4742 120750.0n 0.4475 120999.9n 0.4475 121000.0n 0.5115 121249.9n 0.5115 121250.0n 0.5541 121499.9n 0.5541 121500.0n 0.4422 121749.9n 0.4422 121750.0n 0.4475 121999.9n 0.4475 122000.0n 0.6660 122249.9n 0.6660 122250.0n 0.4635 122499.9n 0.4635 122500.0n 0.5861 122749.9n 0.5861 122750.0n 0.4742 122999.9n 0.4742 123000.0n 0.4369 123249.9n 0.4369 123250.0n 0.5807 123499.9n 0.5807 123500.0n 0.5381 123749.9n 0.5381 123750.0n 0.6180 123999.9n 0.6180 124000.0n 0.6020 124249.9n 0.6020 124250.0n 0.4848 124499.9n 0.4848 124500.0n 0.5008 124749.9n 0.5008 124750.0n 0.6660 124999.9n 0.6660 125000.0n 0.5115 125249.9n 0.5115 125250.0n 0.4315 125499.9n 0.4315 125500.0n 0.4635 125749.9n 0.4635 125750.0n 0.5061 125999.9n 0.5061 126000.0n 0.3356 126249.9n 0.3356 126250.0n 0.5541 126499.9n 0.5541 126500.0n 0.4209 126749.9n 0.4209 126750.0n 0.4902 126999.9n 0.4902 127000.0n 0.4742 127249.9n 0.4742 127250.0n 0.4848 127499.9n 0.4848 127500.0n 0.3356 127749.9n 0.3356 127750.0n 0.4582 127999.9n 0.4582 128000.0n 0.4742 128249.9n 0.4742 128250.0n 0.4475 128499.9n 0.4475 128500.0n 0.5115 128749.9n 0.5115 128750.0n 0.5541 128999.9n 0.5541 129000.0n 0.4422 129249.9n 0.4422 129250.0n 0.4475 129499.9n 0.4475 129500.0n 0.6660 129749.9n 0.6660 129750.0n 0.4635 129999.9n 0.4635 130000.0n 0.5861 130249.9n 0.5861 130250.0n 0.4742 130499.9n 0.4742 130500.0n 0.4369 130749.9n 0.4369 130750.0n 0.5807 130999.9n 0.5807 131000.0n 0.5381 131249.9n 0.5381 131250.0n 0.6180 131499.9n 0.6180 131500.0n 0.6020 131749.9n 0.6020 131750.0n 0.4848 131999.9n 0.4848 132000.0n 0.5008 132249.9n 0.5008 132250.0n 0.6660 132499.9n 0.6660 132500.0n 0.5115 132749.9n 0.5115 132750.0n 0.4315 132999.9n 0.4315 133000.0n 0.4635 133249.9n 0.4635 133250.0n 0.5061 133499.9n 0.5061 133500.0n 0.3356 133749.9n 0.3356 133750.0n 0.5541 133999.9n 0.5541 134000.0n 0.4209 134249.9n 0.4209 134250.0n 0.4902 134499.9n 0.4902 134500.0n 0.4742 134749.9n 0.4742 134750.0n 0.4848 134999.9n 0.4848 135000.0n 0.3356 135249.9n 0.3356 135250.0n 0.4582 135499.9n 0.4582 135500.0n 0.4742 135749.9n 0.4742 135750.0n 0.4475 135999.9n 0.4475 136000.0n 0.5115 136249.9n 0.5115 136250.0n 0.5541 136499.9n 0.5541 136500.0n 0.4422 136749.9n 0.4422 136750.0n 0.4475 136999.9n 0.4475 137000.0n 0.6660 137249.9n 0.6660 137250.0n 0.4635 137499.9n 0.4635 137500.0n 0.5861 137749.9n 0.5861 137750.0n 0.4742 137999.9n 0.4742 138000.0n 0.4369 138249.9n 0.4369 138250.0n 0.5807 138499.9n 0.5807 138500.0n 0.5381 138749.9n 0.5381 138750.0n 0.6180 138999.9n 0.6180 139000.0n 0.6020 139249.9n 0.6020 139250.0n 0.4848 139499.9n 0.4848 139500.0n 0.5008 139749.9n 0.5008 139750.0n 0.6660 139999.9n 0.6660 140000.0n 0.5115 140249.9n 0.5115 140250.0n 0.4315 140499.9n 0.4315 140500.0n 0.4635 140749.9n 0.4635 140750.0n 0.5061 140999.9n 0.5061 141000.0n 0.3356 141249.9n 0.3356 141250.0n 0.5541 141499.9n 0.5541 141500.0n 0.4209 141749.9n 0.4209 141750.0n 0.4902 141999.9n 0.4902 142000.0n 0.4742 142249.9n 0.4742 142250.0n 0.4848 142499.9n 0.4848 142500.0n 0.3356 142749.9n 0.3356 142750.0n 0.4582 142999.9n 0.4582 143000.0n 0.4742 143249.9n 0.4742 143250.0n 0.4475 143499.9n 0.4475 143500.0n 0.5115 143749.9n 0.5115 143750.0n 0.5541 143999.9n 0.5541 144000.0n 0.4422 144249.9n 0.4422 144250.0n 0.4475 144499.9n 0.4475 144500.0n 0.6660 144749.9n 0.6660 144750.0n 0.4635 144999.9n 0.4635 145000.0n 0.5861 145249.9n 0.5861 145250.0n 0.4742 145499.9n 0.4742 145500.0n 0.4369 145749.9n 0.4369 145750.0n 0.5807 145999.9n 0.5807 146000.0n 0.5381 146249.9n 0.5381 146250.0n 0.6180 146499.9n 0.6180 146500.0n 0.6020 146749.9n 0.6020 146750.0n 0.4848 146999.9n 0.4848 147000.0n 0.5008 147249.9n 0.5008 147250.0n 0.6660 147499.9n 0.6660 147500.0n 0.5115 147749.9n 0.5115 147750.0n 0.4315 147999.9n 0.4315 148000.0n 0.4635 148249.9n 0.4635 148250.0n 0.5061 148499.9n 0.5061 148500.0n 0.3356 148749.9n 0.3356 148750.0n 0.5541 148999.9n 0.5541 149000.0n 0.4209 149249.9n 0.4209 149250.0n 0.4902 149499.9n 0.4902 149500.0n 0.4742 149749.9n 0.4742 149750.0n 0.4848 149999.9n 0.4848 150000.0n 0.3356 150249.9n 0.3356 150250.0n 0.4582 150499.9n 0.4582 150500.0n 0.4742 150749.9n 0.4742 150750.0n 0.4475 150999.9n 0.4475 151000.0n 0.5115 151249.9n 0.5115 151250.0n 0.5541 151499.9n 0.5541 151500.0n 0.4422 151749.9n 0.4422 151750.0n 0.4475 151999.9n 0.4475 152000.0n 0.6660 152249.9n 0.6660 152250.0n 0.4635 152499.9n 0.4635 152500.0n 0.5861 152749.9n 0.5861 152750.0n 0.4742 152999.9n 0.4742 153000.0n 0.4369 153249.9n 0.4369 153250.0n 0.5807 153499.9n 0.5807 153500.0n 0.5381 153749.9n 0.5381 153750.0n 0.6180 153999.9n 0.6180 154000.0n 0.6020 154249.9n 0.6020 154250.0n 0.4848 154499.9n 0.4848 154500.0n 0.5008 154749.9n 0.5008 154750.0n 0.6660 154999.9n 0.6660 155000.0n 0.5115 155249.9n 0.5115 155250.0n 0.4315 155499.9n 0.4315 155500.0n 0.4635 155749.9n 0.4635 155750.0n 0.5061 155999.9n 0.5061 156000.0n 0.3356 156249.9n 0.3356 156250.0n 0.5541 156499.9n 0.5541 156500.0n 0.4209 156749.9n 0.4209 156750.0n 0.4902 156999.9n 0.4902 157000.0n 0.4742 157249.9n 0.4742 157250.0n 0.4848 157499.9n 0.4848 157500.0n 0.3356 157749.9n 0.3356 157750.0n 0.4582 157999.9n 0.4582 158000.0n 0.4742 158249.9n 0.4742 158250.0n 0.4475 158499.9n 0.4475 158500.0n 0.5115 158749.9n 0.5115 158750.0n 0.5541 158999.9n 0.5541 159000.0n 0.4422 159249.9n 0.4422 159250.0n 0.4475 159499.9n 0.4475 159500.0n 0.6660 159749.9n 0.6660 159750.0n 0.4635 159999.9n 0.4635 160000.0n 0.5861 160249.9n 0.5861 160250.0n 0.4742 160499.9n 0.4742 160500.0n 0.4369 160749.9n 0.4369 160750.0n 0.5807 160999.9n 0.5807 161000.0n 0.5381 161249.9n 0.5381 161250.0n 0.6180 161499.9n 0.6180 161500.0n 0.6020 161749.9n 0.6020 161750.0n 0.4848 161999.9n 0.4848 162000.0n 0.5008 162249.9n 0.5008 162250.0n 0.6660 162499.9n 0.6660 162500.0n 0.5115 162749.9n 0.5115 162750.0n 0.4315 162999.9n 0.4315 163000.0n 0.4635 163249.9n 0.4635 163250.0n 0.5061 163499.9n 0.5061 163500.0n 0.3356 163749.9n 0.3356 163750.0n 0.5541 163999.9n 0.5541 164000.0n 0.4209 164249.9n 0.4209 164250.0n 0.4902 164499.9n 0.4902 164500.0n 0.4742 164749.9n 0.4742 164750.0n 0.4848 164999.9n 0.4848 165000.0n 0.3356 165249.9n 0.3356 165250.0n 0.4582 165499.9n 0.4582 165500.0n 0.4742 165749.9n 0.4742 165750.0n 0.4475 165999.9n 0.4475 166000.0n 0.5115 166249.9n 0.5115 166250.0n 0.5541 166499.9n 0.5541 166500.0n 0.4422 166749.9n 0.4422 166750.0n 0.4475 166999.9n 0.4475 167000.0n 0.6660 167249.9n 0.6660 167250.0n 0.4635 167499.9n 0.4635 167500.0n 0.5861 167749.9n 0.5861 167750.0n 0.4742 167999.9n 0.4742 168000.0n 0.4369 168249.9n 0.4369 168250.0n 0.5807 168499.9n 0.5807 168500.0n 0.5381 168749.9n 0.5381 168750.0n 0.6180 168999.9n 0.6180 169000.0n 0.6020 169249.9n 0.6020 169250.0n 0.4848 169499.9n 0.4848 169500.0n 0.5008 169749.9n 0.5008 169750.0n 0.6660 169999.9n 0.6660 170000.0n 0.5115 170249.9n 0.5115 170250.0n 0.4315 170499.9n 0.4315 170500.0n 0.4635 170749.9n 0.4635 170750.0n 0.5061 170999.9n 0.5061 171000.0n 0.3356 171249.9n 0.3356 171250.0n 0.5541 171499.9n 0.5541 171500.0n 0.4209 171749.9n 0.4209 171750.0n 0.4902 171999.9n 0.4902 172000.0n 0.4742 172249.9n 0.4742 172250.0n 0.4848 172499.9n 0.4848 172500.0n 0.3356 172749.9n 0.3356 172750.0n 0.4582 172999.9n 0.4582 173000.0n 0.4742 173249.9n 0.4742 173250.0n 0.4475 173499.9n 0.4475 173500.0n 0.5115 173749.9n 0.5115 173750.0n 0.5541 173999.9n 0.5541 174000.0n 0.4422 174249.9n 0.4422 174250.0n 0.4475 174499.9n 0.4475 174500.0n 0.6660 174749.9n 0.6660 174750.0n 0.4635 174999.9n 0.4635 175000.0n 0.5861 175249.9n 0.5861 175250.0n 0.4742 175499.9n 0.4742 175500.0n 0.4369 175749.9n 0.4369 175750.0n 0.5807 175999.9n 0.5807 176000.0n 0.5381 176249.9n 0.5381 176250.0n 0.6180 176499.9n 0.6180 176500.0n 0.6020 176749.9n 0.6020 176750.0n 0.4848 176999.9n 0.4848 177000.0n 0.5008 177249.9n 0.5008 177250.0n 0.6660 177499.9n 0.6660 177500.0n 0.5115 177749.9n 0.5115 177750.0n 0.4315 177999.9n 0.4315 178000.0n 0.4635 178249.9n 0.4635 178250.0n 0.5061 178499.9n 0.5061 178500.0n 0.3356 178749.9n 0.3356 178750.0n 0.5541 178999.9n 0.5541 179000.0n 0.4209 179249.9n 0.4209 179250.0n 0.4902 179499.9n 0.4902 179500.0n 0.4742 179749.9n 0.4742 179750.0n 0.4848 179999.9n 0.4848 180000.0n 0.3356 180249.9n 0.3356 180250.0n 0.4582 180499.9n 0.4582 180500.0n 0.4742 180749.9n 0.4742 180750.0n 0.4475 180999.9n 0.4475 181000.0n 0.5115 181249.9n 0.5115 181250.0n 0.5541 181499.9n 0.5541 181500.0n 0.4422 181749.9n 0.4422 181750.0n 0.4475 181999.9n 0.4475 182000.0n 0.6660 182249.9n 0.6660 182250.0n 0.4635 182499.9n 0.4635 182500.0n 0.5861 182749.9n 0.5861 182750.0n 0.4742 182999.9n 0.4742 183000.0n 0.4369 183249.9n 0.4369 183250.0n 0.5807 183499.9n 0.5807 183500.0n 0.5381 183749.9n 0.5381 183750.0n 0.6180 183999.9n 0.6180 184000.0n 0.6020 184249.9n 0.6020 184250.0n 0.4848 184499.9n 0.4848 184500.0n 0.5008 184749.9n 0.5008 184750.0n 0.6660 184999.9n 0.6660 185000.0n 0.5115 185249.9n 0.5115 185250.0n 0.4315 185499.9n 0.4315 185500.0n 0.4635 185749.9n 0.4635 185750.0n 0.5061 185999.9n 0.5061 186000.0n 0.3356 186249.9n 0.3356 186250.0n 0.5541 186499.9n 0.5541 186500.0n 0.4209 186749.9n 0.4209 186750.0n 0.4902 186999.9n 0.4902 187000.0n 0.4742 187249.9n 0.4742 187250.0n 0.4848 187499.9n 0.4848 187500.0n 0.3356 187749.9n 0.3356 187750.0n 0.4582 187999.9n 0.4582 188000.0n 0.4742 188249.9n 0.4742 188250.0n 0.4475 188499.9n 0.4475 188500.0n 0.5115 188749.9n 0.5115 188750.0n 0.5541 188999.9n 0.5541 189000.0n 0.4422 189249.9n 0.4422 189250.0n 0.4475 189499.9n 0.4475 189500.0n 0.6660 189749.9n 0.6660 189750.0n 0.4635 189999.9n 0.4635 190000.0n 0.5861 190249.9n 0.5861 190250.0n 0.4742 190499.9n 0.4742 190500.0n 0.4369 190749.9n 0.4369 190750.0n 0.5807 190999.9n 0.5807 191000.0n 0.5381 191249.9n 0.5381 191250.0n 0.6180 191499.9n 0.6180 191500.0n 0.6020 191749.9n 0.6020 191750.0n 0.4848 191999.9n 0.4848 192000.0n 0.5008 192249.9n 0.5008 192250.0n 0.6660 192499.9n 0.6660 192500.0n 0.5115 192749.9n 0.5115 192750.0n 0.4315 192999.9n 0.4315 193000.0n 0.4635 193249.9n 0.4635 193250.0n 0.5061 193499.9n 0.5061 193500.0n 0.3356 193749.9n 0.3356 193750.0n 0.5541 193999.9n 0.5541 194000.0n 0.4209 194249.9n 0.4209 194250.0n 0.4902 194499.9n 0.4902 194500.0n 0.4742 194749.9n 0.4742 194750.0n 0.4848 194999.9n 0.4848 195000.0n 0.3356 195249.9n 0.3356 195250.0n 0.4582 195499.9n 0.4582 195500.0n 0.4742 195749.9n 0.4742 195750.0n 0.4475 195999.9n 0.4475 196000.0n 0.5115 196249.9n 0.5115 196250.0n 0.5541 196499.9n 0.5541 196500.0n 0.4422 196749.9n 0.4422 196750.0n 0.4475 196999.9n 0.4475 197000.0n 0.6660 197249.9n 0.6660 197250.0n 0.4635 197499.9n 0.4635 197500.0n 0.5861 197749.9n 0.5861 197750.0n 0.4742 197999.9n 0.4742 198000.0n 0.4369 198249.9n 0.4369 198250.0n 0.5807 198499.9n 0.5807 198500.0n 0.5381 198749.9n 0.5381 198750.0n 0.6180 198999.9n 0.6180 199000.0n 0.6020 199249.9n 0.6020 199250.0n 0.4848 199499.9n 0.4848 199500.0n 0.5008 199749.9n 0.5008 199750.0n 0.6660 199999.9n 0.6660 200000.0n 0.5115 200249.9n 0.5115 200250.0n 0.4315 200499.9n 0.4315 200500.0n 0.4635 200749.9n 0.4635 200750.0n 0.5061 200999.9n 0.5061 201000.0n 0.3356 201249.9n 0.3356 201250.0n 0.5541 201499.9n 0.5541 201500.0n 0.4209 201749.9n 0.4209 201750.0n 0.4902 201999.9n 0.4902 202000.0n 0.4742 202249.9n 0.4742 202250.0n 0.4848 202499.9n 0.4848 202500.0n 0.3356 202749.9n 0.3356 202750.0n 0.4582 202999.9n 0.4582 203000.0n 0.4742 203249.9n 0.4742 203250.0n 0.4475 203499.9n 0.4475 203500.0n 0.5115 203749.9n 0.5115 203750.0n 0.5541 203999.9n 0.5541 204000.0n 0.4422 204249.9n 0.4422 204250.0n 0.4475 204499.9n 0.4475 204500.0n 0.6660 204749.9n 0.6660 204750.0n 0.4635 204999.9n 0.4635 205000.0n 0.5861 205249.9n 0.5861 205250.0n 0.4742 205499.9n 0.4742 205500.0n 0.4369 205749.9n 0.4369 205750.0n 0.5807 205999.9n 0.5807 206000.0n 0.5381 206249.9n 0.5381 206250.0n 0.6180 206499.9n 0.6180 206500.0n 0.6020 206749.9n 0.6020 206750.0n 0.4848 206999.9n 0.4848 207000.0n 0.5008 207249.9n 0.5008 207250.0n 0.6660 207499.9n 0.6660 207500.0n 0.5115 207749.9n 0.5115 207750.0n 0.4315 207999.9n 0.4315 208000.0n 0.4635 208249.9n 0.4635 208250.0n 0.5061 208499.9n 0.5061 208500.0n 0.3356 208749.9n 0.3356 208750.0n 0.5541 208999.9n 0.5541 209000.0n 0.4209 209249.9n 0.4209 209250.0n 0.4902 209499.9n 0.4902 209500.0n 0.4742 209749.9n 0.4742 209750.0n 0.4848 209999.9n 0.4848 210000.0n 0.3356 210249.9n 0.3356 210250.0n 0.4582 210499.9n 0.4582 210500.0n 0.4742 210749.9n 0.4742 210750.0n 0.4475 210999.9n 0.4475 211000.0n 0.5115 211249.9n 0.5115 211250.0n 0.5541 211499.9n 0.5541 211500.0n 0.4422 211749.9n 0.4422 211750.0n 0.4475 211999.9n 0.4475 212000.0n 0.6660 212249.9n 0.6660 212250.0n 0.4635 212499.9n 0.4635 212500.0n 0.5861 212749.9n 0.5861 212750.0n 0.4742 212999.9n 0.4742 213000.0n 0.4369 213249.9n 0.4369 213250.0n 0.5807 213499.9n 0.5807 213500.0n 0.5381 213749.9n 0.5381 213750.0n 0.6180 213999.9n 0.6180 214000.0n 0.6020 214249.9n 0.6020 214250.0n 0.4848 214499.9n 0.4848 214500.0n 0.5008 214749.9n 0.5008 214750.0n 0.6660 214999.9n 0.6660 215000.0n 0.5115 215249.9n 0.5115 215250.0n 0.4315 215499.9n 0.4315 215500.0n 0.4635 215749.9n 0.4635 215750.0n 0.5061 215999.9n 0.5061 216000.0n 0.3356 216249.9n 0.3356 216250.0n 0.5541 216499.9n 0.5541 216500.0n 0.4209 216749.9n 0.4209 216750.0n 0.4902 216999.9n 0.4902 217000.0n 0.4742 217249.9n 0.4742 217250.0n 0.4848 217499.9n 0.4848 217500.0n 0.3356 217749.9n 0.3356 217750.0n 0.4582 217999.9n 0.4582 218000.0n 0.4742 218249.9n 0.4742 218250.0n 0.4475 218499.9n 0.4475 218500.0n 0.5115 218749.9n 0.5115 218750.0n 0.5541 218999.9n 0.5541 219000.0n 0.4422 219249.9n 0.4422 219250.0n 0.4475 219499.9n 0.4475 219500.0n 0.6660 219749.9n 0.6660 219750.0n 0.4635 219999.9n 0.4635 220000.0n 0.5861 220249.9n 0.5861 220250.0n 0.4742 220499.9n 0.4742 220500.0n 0.4369 220749.9n 0.4369 220750.0n 0.5807 220999.9n 0.5807 221000.0n 0.5381 221249.9n 0.5381 221250.0n 0.6180 221499.9n 0.6180 221500.0n 0.6020 221749.9n 0.6020 221750.0n 0.4848 221999.9n 0.4848 222000.0n 0.5008 222249.9n 0.5008 222250.0n 0.6660 222499.9n 0.6660 222500.0n 0.5115 222749.9n 0.5115 222750.0n 0.4315 222999.9n 0.4315 223000.0n 0.4635 223249.9n 0.4635 223250.0n 0.5061 223499.9n 0.5061 223500.0n 0.3356 223749.9n 0.3356 223750.0n 0.5541 223999.9n 0.5541 224000.0n 0.4209 224249.9n 0.4209 224250.0n 0.4902 224499.9n 0.4902 224500.0n 0.4742 224749.9n 0.4742 224750.0n 0.4848 224999.9n 0.4848 225000.0n 0.3356 225249.9n 0.3356 225250.0n 0.4582 225499.9n 0.4582 225500.0n 0.4742 225749.9n 0.4742 225750.0n 0.4475 225999.9n 0.4475 226000.0n 0.5115 226249.9n 0.5115 226250.0n 0.5541 226499.9n 0.5541 226500.0n 0.4422 226749.9n 0.4422 226750.0n 0.4475 226999.9n 0.4475 227000.0n 0.6660 227249.9n 0.6660 227250.0n 0.4635 227499.9n 0.4635 227500.0n 0.5861 227749.9n 0.5861 227750.0n 0.4742 227999.9n 0.4742 228000.0n 0.4369 228249.9n 0.4369 228250.0n 0.5807 228499.9n 0.5807 228500.0n 0.5381 228749.9n 0.5381 228750.0n 0.6180 228999.9n 0.6180 229000.0n 0.6020 229249.9n 0.6020 229250.0n 0.4848 229499.9n 0.4848 229500.0n 0.5008 229749.9n 0.5008 229750.0n 0.6660 229999.9n 0.6660 230000.0n 0.5115 230249.9n 0.5115 230250.0n 0.4315 230499.9n 0.4315 230500.0n 0.4635 230749.9n 0.4635 230750.0n 0.5061 230999.9n 0.5061 231000.0n 0.3356 231249.9n 0.3356 231250.0n 0.5541 231499.9n 0.5541 231500.0n 0.4209 231749.9n 0.4209 231750.0n 0.4902 231999.9n 0.4902 232000.0n 0.4742 232249.9n 0.4742 232250.0n 0.4848 232499.9n 0.4848 232500.0n 0.3356 232749.9n 0.3356 232750.0n 0.4582 232999.9n 0.4582 233000.0n 0.4742 233249.9n 0.4742 233250.0n 0.4475 233499.9n 0.4475 233500.0n 0.5115 233749.9n 0.5115 233750.0n 0.5541 233999.9n 0.5541 234000.0n 0.4422 234249.9n 0.4422 234250.0n 0.4475 234499.9n 0.4475 234500.0n 0.6660 234749.9n 0.6660 234750.0n 0.4635 234999.9n 0.4635 235000.0n 0.5861 235249.9n 0.5861 235250.0n 0.4742 235499.9n 0.4742 235500.0n 0.4369 235749.9n 0.4369 235750.0n 0.5807 235999.9n 0.5807 236000.0n 0.5381 236249.9n 0.5381 236250.0n 0.6180 236499.9n 0.6180 236500.0n 0.6020 236749.9n 0.6020 236750.0n 0.4848 236999.9n 0.4848 237000.0n 0.5008 237249.9n 0.5008 237250.0n 0.6660 237499.9n 0.6660 237500.0n 0.5115 237749.9n 0.5115 237750.0n 0.4315 237999.9n 0.4315 238000.0n 0.4635 238249.9n 0.4635 238250.0n 0.5061 238499.9n 0.5061 238500.0n 0.3356 238749.9n 0.3356 238750.0n 0.5541 238999.9n 0.5541 239000.0n 0.4209 239249.9n 0.4209 239250.0n 0.4902 239499.9n 0.4902 239500.0n 0.4742 239749.9n 0.4742 239750.0n 0.4848 239999.9n 0.4848 240000.0n 0.3356 240249.9n 0.3356 240250.0n 0.4582 240499.9n 0.4582 240500.0n 0.4742 240749.9n 0.4742 240750.0n 0.4475 240999.9n 0.4475 241000.0n 0.5115 241249.9n 0.5115 241250.0n 0.5541 241499.9n 0.5541 241500.0n 0.4422 241749.9n 0.4422 241750.0n 0.4475 241999.9n 0.4475 242000.0n 0.6660 242249.9n 0.6660 242250.0n 0.4635 242499.9n 0.4635 242500.0n 0.5861 242749.9n 0.5861 242750.0n 0.4742 242999.9n 0.4742 243000.0n 0.4369 243249.9n 0.4369 243250.0n 0.5807 243499.9n 0.5807 243500.0n 0.5381 243749.9n 0.5381 243750.0n 0.6180 243999.9n 0.6180 244000.0n 0.6020 244249.9n 0.6020 244250.0n 0.4848 244499.9n 0.4848 244500.0n 0.5008 244749.9n 0.5008 244750.0n 0.6660 244999.9n 0.6660 245000.0n 0.5115 245249.9n 0.5115 245250.0n 0.4315 245499.9n 0.4315 245500.0n 0.4635 245749.9n 0.4635 245750.0n 0.5061 245999.9n 0.5061 246000.0n 0.3356 246249.9n 0.3356 246250.0n 0.5541 246499.9n 0.5541 246500.0n 0.4209 246749.9n 0.4209 246750.0n 0.4902 246999.9n 0.4902 247000.0n 0.4742 247249.9n 0.4742 247250.0n 0.4848 247499.9n 0.4848 247500.0n 0.3356 247749.9n 0.3356 247750.0n 0.4582 247999.9n 0.4582 248000.0n 0.4742 248249.9n 0.4742 248250.0n 0.4475 248499.9n 0.4475 248500.0n 0.5115 248749.9n 0.5115 248750.0n 0.5541 248999.9n 0.5541 249000.0n 0.4422 249249.9n 0.4422 249250.0n 0.4475 249499.9n 0.4475 249500.0n 0.6660 249749.9n 0.6660 249750.0n 0.4635 249999.9n 0.4635 250000.0n 0.5861 250249.9n 0.5861 250250.0n 0.4742 250499.9n 0.4742 250500.0n 0.4369 250749.9n 0.4369 250750.0n 0.5807 250999.9n 0.5807 251000.0n 0.5381 251249.9n 0.5381 251250.0n 0.6180 251499.9n 0.6180 251500.0n 0.6020 251749.9n 0.6020 251750.0n 0.4848 251999.9n 0.4848 252000.0n 0.5008 252249.9n 0.5008 252250.0n 0.6660 252499.9n 0.6660 252500.0n 0.5115 252749.9n 0.5115 252750.0n 0.4315 252999.9n 0.4315 253000.0n 0.4635 253249.9n 0.4635 253250.0n 0.5061 253499.9n 0.5061 253500.0n 0.3356 253749.9n 0.3356 253750.0n 0.5541 253999.9n 0.5541 254000.0n 0.4209 254249.9n 0.4209 254250.0n 0.4902 254499.9n 0.4902 254500.0n 0.4742 254749.9n 0.4742 254750.0n 0.4848 254999.9n 0.4848 255000.0n 0.3356 255249.9n 0.3356 255250.0n 0.4582 255499.9n 0.4582 255500.0n 0.4742 255749.9n 0.4742 255750.0n 0.4475 255999.9n 0.4475 256000.0n 0.5115 256249.9n 0.5115 256250.0n 0.5541 256499.9n 0.5541 256500.0n 0.4422 256749.9n 0.4422 256750.0n 0.4475 256999.9n 0.4475 257000.0n 0.6660 257249.9n 0.6660 257250.0n 0.4635 257499.9n 0.4635 257500.0n 0.5861 257749.9n 0.5861 257750.0n 0.4742 257999.9n 0.4742 258000.0n 0.4369 258249.9n 0.4369 258250.0n 0.5807 258499.9n 0.5807 258500.0n 0.5381 258749.9n 0.5381 258750.0n 0.6180 258999.9n 0.6180 259000.0n 0.6020 259249.9n 0.6020 259250.0n 0.4848 259499.9n 0.4848 259500.0n 0.5008 259749.9n 0.5008 259750.0n 0.6660 259999.9n 0.6660 260000.0n 0.5115 260249.9n 0.5115 260250.0n 0.4315 260499.9n 0.4315 260500.0n 0.4635 260749.9n 0.4635 260750.0n 0.5061 260999.9n 0.5061 261000.0n 0.3356 261249.9n 0.3356 261250.0n 0.5541 261499.9n 0.5541 261500.0n 0.4209 261749.9n 0.4209 261750.0n 0.4902 261999.9n 0.4902 262000.0n 0.4742 262249.9n 0.4742 262250.0n 0.4848 262499.9n 0.4848 262500.0n 0.3356 262749.9n 0.3356 262750.0n 0.4582 262999.9n 0.4582 263000.0n 0.4742 263249.9n 0.4742 263250.0n 0.4475 263499.9n 0.4475 263500.0n 0.5115 263749.9n 0.5115 263750.0n 0.5541 263999.9n 0.5541 264000.0n 0.4422 264249.9n 0.4422 264250.0n 0.4475 264499.9n 0.4475 264500.0n 0.6660 264749.9n 0.6660 264750.0n 0.4635 264999.9n 0.4635 265000.0n 0.5861 265249.9n 0.5861 265250.0n 0.4742 265499.9n 0.4742 265500.0n 0.4369 265749.9n 0.4369 265750.0n 0.5807 265999.9n 0.5807 266000.0n 0.5381 266249.9n 0.5381 266250.0n 0.6180 266499.9n 0.6180 266500.0n 0.6020 266749.9n 0.6020 266750.0n 0.4848 266999.9n 0.4848 267000.0n 0.5008 267249.9n 0.5008 267250.0n 0.6660 267499.9n 0.6660 267500.0n 0.5115 267749.9n 0.5115 267750.0n 0.4315 267999.9n 0.4315 268000.0n 0.4635 268249.9n 0.4635 268250.0n 0.5061 268499.9n 0.5061 268500.0n 0.3356 268749.9n 0.3356 268750.0n 0.5541 268999.9n 0.5541 269000.0n 0.4209 269249.9n 0.4209 269250.0n 0.4902 269499.9n 0.4902 269500.0n 0.4742 269749.9n 0.4742 269750.0n 0.4848 269999.9n 0.4848 270000.0n 0.3356 270249.9n 0.3356 270250.0n 0.4582 270499.9n 0.4582 270500.0n 0.4742 270749.9n 0.4742 270750.0n 0.4475 270999.9n 0.4475 271000.0n 0.5115 271249.9n 0.5115 271250.0n 0.5541 271499.9n 0.5541 271500.0n 0.4422 271749.9n 0.4422 271750.0n 0.4475 271999.9n 0.4475 272000.0n 0.6660 272249.9n 0.6660 272250.0n 0.4635 272499.9n 0.4635 272500.0n 0.5861 272749.9n 0.5861 272750.0n 0.4742 272999.9n 0.4742 273000.0n 0.4369 273249.9n 0.4369 273250.0n 0.5807 273499.9n 0.5807 273500.0n 0.5381 273749.9n 0.5381 273750.0n 0.6180 273999.9n 0.6180 274000.0n 0.6020 274249.9n 0.6020 274250.0n 0.4848 274499.9n 0.4848 274500.0n 0.5008 274749.9n 0.5008 274750.0n 0.6660 274999.9n 0.6660 275000.0n 0.5115 275249.9n 0.5115 275250.0n 0.4315 275499.9n 0.4315 275500.0n 0.4635 275749.9n 0.4635 275750.0n 0.5061 275999.9n 0.5061 276000.0n 0.3356 276249.9n 0.3356 276250.0n 0.5541 276499.9n 0.5541 276500.0n 0.4209 276749.9n 0.4209 276750.0n 0.4902 276999.9n 0.4902 277000.0n 0.4742 277249.9n 0.4742 277250.0n 0.4848 277499.9n 0.4848 277500.0n 0.3356 277749.9n 0.3356 277750.0n 0.4582 277999.9n 0.4582 278000.0n 0.4742 278249.9n 0.4742 278250.0n 0.4475 278499.9n 0.4475 278500.0n 0.5115 278749.9n 0.5115 278750.0n 0.5541 278999.9n 0.5541 279000.0n 0.4422 279249.9n 0.4422 279250.0n 0.4475 279499.9n 0.4475 279500.0n 0.6660 279749.9n 0.6660 279750.0n 0.4635 279999.9n 0.4635 280000.0n 0.5861 280249.9n 0.5861 280250.0n 0.4742 280499.9n 0.4742 280500.0n 0.4369 280749.9n 0.4369 280750.0n 0.5807 280999.9n 0.5807 281000.0n 0.5381 281249.9n 0.5381 281250.0n 0.6180 281499.9n 0.6180 281500.0n 0.6020 281749.9n 0.6020 281750.0n 0.4848 281999.9n 0.4848 282000.0n 0.5008 282249.9n 0.5008 282250.0n 0.6660 282499.9n 0.6660 282500.0n 0.5115 282749.9n 0.5115 282750.0n 0.4315 282999.9n 0.4315 283000.0n 0.4635 283249.9n 0.4635 283250.0n 0.5061 283499.9n 0.5061 283500.0n 0.3356 283749.9n 0.3356 283750.0n 0.5541 283999.9n 0.5541 284000.0n 0.4209 284249.9n 0.4209 284250.0n 0.4902 284499.9n 0.4902 284500.0n 0.4742 284749.9n 0.4742 284750.0n 0.4848 284999.9n 0.4848 285000.0n 0.3356 285249.9n 0.3356 285250.0n 0.4582 285499.9n 0.4582 285500.0n 0.4742 285749.9n 0.4742 285750.0n 0.4475 285999.9n 0.4475 286000.0n 0.5115 286249.9n 0.5115 286250.0n 0.5541 286499.9n 0.5541 286500.0n 0.4422 286749.9n 0.4422 286750.0n 0.4475 286999.9n 0.4475 287000.0n 0.6660 287249.9n 0.6660 287250.0n 0.4635 287499.9n 0.4635 287500.0n 0.5861 287749.9n 0.5861 287750.0n 0.4742 287999.9n 0.4742 288000.0n 0.4369 288249.9n 0.4369 288250.0n 0.5807 288499.9n 0.5807 288500.0n 0.5381 288749.9n 0.5381 288750.0n 0.6180 288999.9n 0.6180 289000.0n 0.6020 289249.9n 0.6020 289250.0n 0.4848 289499.9n 0.4848 289500.0n 0.5008 289749.9n 0.5008 289750.0n 0.6660 289999.9n 0.6660 290000.0n 0.5115 290249.9n 0.5115 290250.0n 0.4315 290499.9n 0.4315 290500.0n 0.4635 290749.9n 0.4635 290750.0n 0.5061 290999.9n 0.5061 291000.0n 0.3356 291249.9n 0.3356 291250.0n 0.5541 291499.9n 0.5541 291500.0n 0.4209 291749.9n 0.4209 291750.0n 0.4902 291999.9n 0.4902 292000.0n 0.4742 292249.9n 0.4742 292250.0n 0.4848 292499.9n 0.4848 292500.0n 0.3356 292749.9n 0.3356 292750.0n 0.4582 292999.9n 0.4582 293000.0n 0.4742 293249.9n 0.4742 293250.0n 0.4475 293499.9n 0.4475 293500.0n 0.5115 293749.9n 0.5115 293750.0n 0.5541 293999.9n 0.5541 294000.0n 0.4422 294249.9n 0.4422 294250.0n 0.4475 294499.9n 0.4475 294500.0n 0.6660 294749.9n 0.6660 294750.0n 0.4635 294999.9n 0.4635 295000.0n 0.5861 295249.9n 0.5861 295250.0n 0.4742 295499.9n 0.4742 295500.0n 0.4369 295749.9n 0.4369 295750.0n 0.5807 295999.9n 0.5807 296000.0n 0.5381 296249.9n 0.5381 296250.0n 0.6180 296499.9n 0.6180 296500.0n 0.6020 296749.9n 0.6020 296750.0n 0.4848 296999.9n 0.4848 297000.0n 0.5008 297249.9n 0.5008 297250.0n 0.6660 297499.9n 0.6660 297500.0n 0.5115 297749.9n 0.5115 297750.0n 0.4315 297999.9n 0.4315 298000.0n 0.4635 298249.9n 0.4635 298250.0n 0.5061 298499.9n 0.5061 298500.0n 0.3356 298749.9n 0.3356 298750.0n 0.5541 298999.9n 0.5541 299000.0n 0.4209 299249.9n 0.4209 299250.0n 0.4902 299499.9n 0.4902 299500.0n 0.4742 299749.9n 0.4742 299750.0n 0.4848)
Vxn9 a_xn9 0 PWL(0.0n 0.6644 249.9n 0.6644 250.0n 0.5418 499.9n 0.5418 500.0n 0.5258 749.9n 0.5258 750.0n 0.5525 999.9n 0.5525 1000.0n 0.4885 1249.9n 0.4885 1250.0n 0.4459 1499.9n 0.4459 1500.0n 0.5578 1749.9n 0.5578 1750.0n 0.5525 1999.9n 0.5525 2000.0n 0.3340 2249.9n 0.3340 2250.0n 0.5365 2499.9n 0.5365 2500.0n 0.4139 2749.9n 0.4139 2750.0n 0.5258 2999.9n 0.5258 3000.0n 0.5631 3249.9n 0.5631 3250.0n 0.4193 3499.9n 0.4193 3500.0n 0.4619 3749.9n 0.4619 3750.0n 0.3820 3999.9n 0.3820 4000.0n 0.3980 4249.9n 0.3980 4250.0n 0.5152 4499.9n 0.5152 4500.0n 0.4992 4749.9n 0.4992 4750.0n 0.3340 4999.9n 0.3340 5000.0n 0.4885 5249.9n 0.4885 5250.0n 0.5685 5499.9n 0.5685 5500.0n 0.5365 5749.9n 0.5365 5750.0n 0.4939 5999.9n 0.4939 6000.0n 0.6644 6249.9n 0.6644 6250.0n 0.4459 6499.9n 0.4459 6500.0n 0.5791 6749.9n 0.5791 6750.0n 0.5098 6999.9n 0.5098 7000.0n 0.5258 7249.9n 0.5258 7250.0n 0.5152 7499.9n 0.5152 7500.0n 0.6644 7749.9n 0.6644 7750.0n 0.5418 7999.9n 0.5418 8000.0n 0.5258 8249.9n 0.5258 8250.0n 0.5525 8499.9n 0.5525 8500.0n 0.4885 8749.9n 0.4885 8750.0n 0.4459 8999.9n 0.4459 9000.0n 0.5578 9249.9n 0.5578 9250.0n 0.5525 9499.9n 0.5525 9500.0n 0.3340 9749.9n 0.3340 9750.0n 0.5365 9999.9n 0.5365 10000.0n 0.4139 10249.9n 0.4139 10250.0n 0.5258 10499.9n 0.5258 10500.0n 0.5631 10749.9n 0.5631 10750.0n 0.4193 10999.9n 0.4193 11000.0n 0.4619 11249.9n 0.4619 11250.0n 0.3820 11499.9n 0.3820 11500.0n 0.3980 11749.9n 0.3980 11750.0n 0.5152 11999.9n 0.5152 12000.0n 0.4992 12249.9n 0.4992 12250.0n 0.3340 12499.9n 0.3340 12500.0n 0.4885 12749.9n 0.4885 12750.0n 0.5685 12999.9n 0.5685 13000.0n 0.5365 13249.9n 0.5365 13250.0n 0.4939 13499.9n 0.4939 13500.0n 0.6644 13749.9n 0.6644 13750.0n 0.4459 13999.9n 0.4459 14000.0n 0.5791 14249.9n 0.5791 14250.0n 0.5098 14499.9n 0.5098 14500.0n 0.5258 14749.9n 0.5258 14750.0n 0.5152 14999.9n 0.5152 15000.0n 0.6644 15249.9n 0.6644 15250.0n 0.5418 15499.9n 0.5418 15500.0n 0.5258 15749.9n 0.5258 15750.0n 0.5525 15999.9n 0.5525 16000.0n 0.4885 16249.9n 0.4885 16250.0n 0.4459 16499.9n 0.4459 16500.0n 0.5578 16749.9n 0.5578 16750.0n 0.5525 16999.9n 0.5525 17000.0n 0.3340 17249.9n 0.3340 17250.0n 0.5365 17499.9n 0.5365 17500.0n 0.4139 17749.9n 0.4139 17750.0n 0.5258 17999.9n 0.5258 18000.0n 0.5631 18249.9n 0.5631 18250.0n 0.4193 18499.9n 0.4193 18500.0n 0.4619 18749.9n 0.4619 18750.0n 0.3820 18999.9n 0.3820 19000.0n 0.3980 19249.9n 0.3980 19250.0n 0.5152 19499.9n 0.5152 19500.0n 0.4992 19749.9n 0.4992 19750.0n 0.3340 19999.9n 0.3340 20000.0n 0.4885 20249.9n 0.4885 20250.0n 0.5685 20499.9n 0.5685 20500.0n 0.5365 20749.9n 0.5365 20750.0n 0.4939 20999.9n 0.4939 21000.0n 0.6644 21249.9n 0.6644 21250.0n 0.4459 21499.9n 0.4459 21500.0n 0.5791 21749.9n 0.5791 21750.0n 0.5098 21999.9n 0.5098 22000.0n 0.5258 22249.9n 0.5258 22250.0n 0.5152 22499.9n 0.5152 22500.0n 0.6644 22749.9n 0.6644 22750.0n 0.5418 22999.9n 0.5418 23000.0n 0.5258 23249.9n 0.5258 23250.0n 0.5525 23499.9n 0.5525 23500.0n 0.4885 23749.9n 0.4885 23750.0n 0.4459 23999.9n 0.4459 24000.0n 0.5578 24249.9n 0.5578 24250.0n 0.5525 24499.9n 0.5525 24500.0n 0.3340 24749.9n 0.3340 24750.0n 0.5365 24999.9n 0.5365 25000.0n 0.4139 25249.9n 0.4139 25250.0n 0.5258 25499.9n 0.5258 25500.0n 0.5631 25749.9n 0.5631 25750.0n 0.4193 25999.9n 0.4193 26000.0n 0.4619 26249.9n 0.4619 26250.0n 0.3820 26499.9n 0.3820 26500.0n 0.3980 26749.9n 0.3980 26750.0n 0.5152 26999.9n 0.5152 27000.0n 0.4992 27249.9n 0.4992 27250.0n 0.3340 27499.9n 0.3340 27500.0n 0.4885 27749.9n 0.4885 27750.0n 0.5685 27999.9n 0.5685 28000.0n 0.5365 28249.9n 0.5365 28250.0n 0.4939 28499.9n 0.4939 28500.0n 0.6644 28749.9n 0.6644 28750.0n 0.4459 28999.9n 0.4459 29000.0n 0.5791 29249.9n 0.5791 29250.0n 0.5098 29499.9n 0.5098 29500.0n 0.5258 29749.9n 0.5258 29750.0n 0.5152 29999.9n 0.5152 30000.0n 0.6644 30249.9n 0.6644 30250.0n 0.5418 30499.9n 0.5418 30500.0n 0.5258 30749.9n 0.5258 30750.0n 0.5525 30999.9n 0.5525 31000.0n 0.4885 31249.9n 0.4885 31250.0n 0.4459 31499.9n 0.4459 31500.0n 0.5578 31749.9n 0.5578 31750.0n 0.5525 31999.9n 0.5525 32000.0n 0.3340 32249.9n 0.3340 32250.0n 0.5365 32499.9n 0.5365 32500.0n 0.4139 32749.9n 0.4139 32750.0n 0.5258 32999.9n 0.5258 33000.0n 0.5631 33249.9n 0.5631 33250.0n 0.4193 33499.9n 0.4193 33500.0n 0.4619 33749.9n 0.4619 33750.0n 0.3820 33999.9n 0.3820 34000.0n 0.3980 34249.9n 0.3980 34250.0n 0.5152 34499.9n 0.5152 34500.0n 0.4992 34749.9n 0.4992 34750.0n 0.3340 34999.9n 0.3340 35000.0n 0.4885 35249.9n 0.4885 35250.0n 0.5685 35499.9n 0.5685 35500.0n 0.5365 35749.9n 0.5365 35750.0n 0.4939 35999.9n 0.4939 36000.0n 0.6644 36249.9n 0.6644 36250.0n 0.4459 36499.9n 0.4459 36500.0n 0.5791 36749.9n 0.5791 36750.0n 0.5098 36999.9n 0.5098 37000.0n 0.5258 37249.9n 0.5258 37250.0n 0.5152 37499.9n 0.5152 37500.0n 0.6644 37749.9n 0.6644 37750.0n 0.5418 37999.9n 0.5418 38000.0n 0.5258 38249.9n 0.5258 38250.0n 0.5525 38499.9n 0.5525 38500.0n 0.4885 38749.9n 0.4885 38750.0n 0.4459 38999.9n 0.4459 39000.0n 0.5578 39249.9n 0.5578 39250.0n 0.5525 39499.9n 0.5525 39500.0n 0.3340 39749.9n 0.3340 39750.0n 0.5365 39999.9n 0.5365 40000.0n 0.4139 40249.9n 0.4139 40250.0n 0.5258 40499.9n 0.5258 40500.0n 0.5631 40749.9n 0.5631 40750.0n 0.4193 40999.9n 0.4193 41000.0n 0.4619 41249.9n 0.4619 41250.0n 0.3820 41499.9n 0.3820 41500.0n 0.3980 41749.9n 0.3980 41750.0n 0.5152 41999.9n 0.5152 42000.0n 0.4992 42249.9n 0.4992 42250.0n 0.3340 42499.9n 0.3340 42500.0n 0.4885 42749.9n 0.4885 42750.0n 0.5685 42999.9n 0.5685 43000.0n 0.5365 43249.9n 0.5365 43250.0n 0.4939 43499.9n 0.4939 43500.0n 0.6644 43749.9n 0.6644 43750.0n 0.4459 43999.9n 0.4459 44000.0n 0.5791 44249.9n 0.5791 44250.0n 0.5098 44499.9n 0.5098 44500.0n 0.5258 44749.9n 0.5258 44750.0n 0.5152 44999.9n 0.5152 45000.0n 0.6644 45249.9n 0.6644 45250.0n 0.5418 45499.9n 0.5418 45500.0n 0.5258 45749.9n 0.5258 45750.0n 0.5525 45999.9n 0.5525 46000.0n 0.4885 46249.9n 0.4885 46250.0n 0.4459 46499.9n 0.4459 46500.0n 0.5578 46749.9n 0.5578 46750.0n 0.5525 46999.9n 0.5525 47000.0n 0.3340 47249.9n 0.3340 47250.0n 0.5365 47499.9n 0.5365 47500.0n 0.4139 47749.9n 0.4139 47750.0n 0.5258 47999.9n 0.5258 48000.0n 0.5631 48249.9n 0.5631 48250.0n 0.4193 48499.9n 0.4193 48500.0n 0.4619 48749.9n 0.4619 48750.0n 0.3820 48999.9n 0.3820 49000.0n 0.3980 49249.9n 0.3980 49250.0n 0.5152 49499.9n 0.5152 49500.0n 0.4992 49749.9n 0.4992 49750.0n 0.3340 49999.9n 0.3340 50000.0n 0.4885 50249.9n 0.4885 50250.0n 0.5685 50499.9n 0.5685 50500.0n 0.5365 50749.9n 0.5365 50750.0n 0.4939 50999.9n 0.4939 51000.0n 0.6644 51249.9n 0.6644 51250.0n 0.4459 51499.9n 0.4459 51500.0n 0.5791 51749.9n 0.5791 51750.0n 0.5098 51999.9n 0.5098 52000.0n 0.5258 52249.9n 0.5258 52250.0n 0.5152 52499.9n 0.5152 52500.0n 0.6644 52749.9n 0.6644 52750.0n 0.5418 52999.9n 0.5418 53000.0n 0.5258 53249.9n 0.5258 53250.0n 0.5525 53499.9n 0.5525 53500.0n 0.4885 53749.9n 0.4885 53750.0n 0.4459 53999.9n 0.4459 54000.0n 0.5578 54249.9n 0.5578 54250.0n 0.5525 54499.9n 0.5525 54500.0n 0.3340 54749.9n 0.3340 54750.0n 0.5365 54999.9n 0.5365 55000.0n 0.4139 55249.9n 0.4139 55250.0n 0.5258 55499.9n 0.5258 55500.0n 0.5631 55749.9n 0.5631 55750.0n 0.4193 55999.9n 0.4193 56000.0n 0.4619 56249.9n 0.4619 56250.0n 0.3820 56499.9n 0.3820 56500.0n 0.3980 56749.9n 0.3980 56750.0n 0.5152 56999.9n 0.5152 57000.0n 0.4992 57249.9n 0.4992 57250.0n 0.3340 57499.9n 0.3340 57500.0n 0.4885 57749.9n 0.4885 57750.0n 0.5685 57999.9n 0.5685 58000.0n 0.5365 58249.9n 0.5365 58250.0n 0.4939 58499.9n 0.4939 58500.0n 0.6644 58749.9n 0.6644 58750.0n 0.4459 58999.9n 0.4459 59000.0n 0.5791 59249.9n 0.5791 59250.0n 0.5098 59499.9n 0.5098 59500.0n 0.5258 59749.9n 0.5258 59750.0n 0.5152 59999.9n 0.5152 60000.0n 0.6644 60249.9n 0.6644 60250.0n 0.5418 60499.9n 0.5418 60500.0n 0.5258 60749.9n 0.5258 60750.0n 0.5525 60999.9n 0.5525 61000.0n 0.4885 61249.9n 0.4885 61250.0n 0.4459 61499.9n 0.4459 61500.0n 0.5578 61749.9n 0.5578 61750.0n 0.5525 61999.9n 0.5525 62000.0n 0.3340 62249.9n 0.3340 62250.0n 0.5365 62499.9n 0.5365 62500.0n 0.4139 62749.9n 0.4139 62750.0n 0.5258 62999.9n 0.5258 63000.0n 0.5631 63249.9n 0.5631 63250.0n 0.4193 63499.9n 0.4193 63500.0n 0.4619 63749.9n 0.4619 63750.0n 0.3820 63999.9n 0.3820 64000.0n 0.3980 64249.9n 0.3980 64250.0n 0.5152 64499.9n 0.5152 64500.0n 0.4992 64749.9n 0.4992 64750.0n 0.3340 64999.9n 0.3340 65000.0n 0.4885 65249.9n 0.4885 65250.0n 0.5685 65499.9n 0.5685 65500.0n 0.5365 65749.9n 0.5365 65750.0n 0.4939 65999.9n 0.4939 66000.0n 0.6644 66249.9n 0.6644 66250.0n 0.4459 66499.9n 0.4459 66500.0n 0.5791 66749.9n 0.5791 66750.0n 0.5098 66999.9n 0.5098 67000.0n 0.5258 67249.9n 0.5258 67250.0n 0.5152 67499.9n 0.5152 67500.0n 0.6644 67749.9n 0.6644 67750.0n 0.5418 67999.9n 0.5418 68000.0n 0.5258 68249.9n 0.5258 68250.0n 0.5525 68499.9n 0.5525 68500.0n 0.4885 68749.9n 0.4885 68750.0n 0.4459 68999.9n 0.4459 69000.0n 0.5578 69249.9n 0.5578 69250.0n 0.5525 69499.9n 0.5525 69500.0n 0.3340 69749.9n 0.3340 69750.0n 0.5365 69999.9n 0.5365 70000.0n 0.4139 70249.9n 0.4139 70250.0n 0.5258 70499.9n 0.5258 70500.0n 0.5631 70749.9n 0.5631 70750.0n 0.4193 70999.9n 0.4193 71000.0n 0.4619 71249.9n 0.4619 71250.0n 0.3820 71499.9n 0.3820 71500.0n 0.3980 71749.9n 0.3980 71750.0n 0.5152 71999.9n 0.5152 72000.0n 0.4992 72249.9n 0.4992 72250.0n 0.3340 72499.9n 0.3340 72500.0n 0.4885 72749.9n 0.4885 72750.0n 0.5685 72999.9n 0.5685 73000.0n 0.5365 73249.9n 0.5365 73250.0n 0.4939 73499.9n 0.4939 73500.0n 0.6644 73749.9n 0.6644 73750.0n 0.4459 73999.9n 0.4459 74000.0n 0.5791 74249.9n 0.5791 74250.0n 0.5098 74499.9n 0.5098 74500.0n 0.5258 74749.9n 0.5258 74750.0n 0.5152 74999.9n 0.5152 75000.0n 0.6644 75249.9n 0.6644 75250.0n 0.5418 75499.9n 0.5418 75500.0n 0.5258 75749.9n 0.5258 75750.0n 0.5525 75999.9n 0.5525 76000.0n 0.4885 76249.9n 0.4885 76250.0n 0.4459 76499.9n 0.4459 76500.0n 0.5578 76749.9n 0.5578 76750.0n 0.5525 76999.9n 0.5525 77000.0n 0.3340 77249.9n 0.3340 77250.0n 0.5365 77499.9n 0.5365 77500.0n 0.4139 77749.9n 0.4139 77750.0n 0.5258 77999.9n 0.5258 78000.0n 0.5631 78249.9n 0.5631 78250.0n 0.4193 78499.9n 0.4193 78500.0n 0.4619 78749.9n 0.4619 78750.0n 0.3820 78999.9n 0.3820 79000.0n 0.3980 79249.9n 0.3980 79250.0n 0.5152 79499.9n 0.5152 79500.0n 0.4992 79749.9n 0.4992 79750.0n 0.3340 79999.9n 0.3340 80000.0n 0.4885 80249.9n 0.4885 80250.0n 0.5685 80499.9n 0.5685 80500.0n 0.5365 80749.9n 0.5365 80750.0n 0.4939 80999.9n 0.4939 81000.0n 0.6644 81249.9n 0.6644 81250.0n 0.4459 81499.9n 0.4459 81500.0n 0.5791 81749.9n 0.5791 81750.0n 0.5098 81999.9n 0.5098 82000.0n 0.5258 82249.9n 0.5258 82250.0n 0.5152 82499.9n 0.5152 82500.0n 0.6644 82749.9n 0.6644 82750.0n 0.5418 82999.9n 0.5418 83000.0n 0.5258 83249.9n 0.5258 83250.0n 0.5525 83499.9n 0.5525 83500.0n 0.4885 83749.9n 0.4885 83750.0n 0.4459 83999.9n 0.4459 84000.0n 0.5578 84249.9n 0.5578 84250.0n 0.5525 84499.9n 0.5525 84500.0n 0.3340 84749.9n 0.3340 84750.0n 0.5365 84999.9n 0.5365 85000.0n 0.4139 85249.9n 0.4139 85250.0n 0.5258 85499.9n 0.5258 85500.0n 0.5631 85749.9n 0.5631 85750.0n 0.4193 85999.9n 0.4193 86000.0n 0.4619 86249.9n 0.4619 86250.0n 0.3820 86499.9n 0.3820 86500.0n 0.3980 86749.9n 0.3980 86750.0n 0.5152 86999.9n 0.5152 87000.0n 0.4992 87249.9n 0.4992 87250.0n 0.3340 87499.9n 0.3340 87500.0n 0.4885 87749.9n 0.4885 87750.0n 0.5685 87999.9n 0.5685 88000.0n 0.5365 88249.9n 0.5365 88250.0n 0.4939 88499.9n 0.4939 88500.0n 0.6644 88749.9n 0.6644 88750.0n 0.4459 88999.9n 0.4459 89000.0n 0.5791 89249.9n 0.5791 89250.0n 0.5098 89499.9n 0.5098 89500.0n 0.5258 89749.9n 0.5258 89750.0n 0.5152 89999.9n 0.5152 90000.0n 0.6644 90249.9n 0.6644 90250.0n 0.5418 90499.9n 0.5418 90500.0n 0.5258 90749.9n 0.5258 90750.0n 0.5525 90999.9n 0.5525 91000.0n 0.4885 91249.9n 0.4885 91250.0n 0.4459 91499.9n 0.4459 91500.0n 0.5578 91749.9n 0.5578 91750.0n 0.5525 91999.9n 0.5525 92000.0n 0.3340 92249.9n 0.3340 92250.0n 0.5365 92499.9n 0.5365 92500.0n 0.4139 92749.9n 0.4139 92750.0n 0.5258 92999.9n 0.5258 93000.0n 0.5631 93249.9n 0.5631 93250.0n 0.4193 93499.9n 0.4193 93500.0n 0.4619 93749.9n 0.4619 93750.0n 0.3820 93999.9n 0.3820 94000.0n 0.3980 94249.9n 0.3980 94250.0n 0.5152 94499.9n 0.5152 94500.0n 0.4992 94749.9n 0.4992 94750.0n 0.3340 94999.9n 0.3340 95000.0n 0.4885 95249.9n 0.4885 95250.0n 0.5685 95499.9n 0.5685 95500.0n 0.5365 95749.9n 0.5365 95750.0n 0.4939 95999.9n 0.4939 96000.0n 0.6644 96249.9n 0.6644 96250.0n 0.4459 96499.9n 0.4459 96500.0n 0.5791 96749.9n 0.5791 96750.0n 0.5098 96999.9n 0.5098 97000.0n 0.5258 97249.9n 0.5258 97250.0n 0.5152 97499.9n 0.5152 97500.0n 0.6644 97749.9n 0.6644 97750.0n 0.5418 97999.9n 0.5418 98000.0n 0.5258 98249.9n 0.5258 98250.0n 0.5525 98499.9n 0.5525 98500.0n 0.4885 98749.9n 0.4885 98750.0n 0.4459 98999.9n 0.4459 99000.0n 0.5578 99249.9n 0.5578 99250.0n 0.5525 99499.9n 0.5525 99500.0n 0.3340 99749.9n 0.3340 99750.0n 0.5365 99999.9n 0.5365 100000.0n 0.4139 100249.9n 0.4139 100250.0n 0.5258 100499.9n 0.5258 100500.0n 0.5631 100749.9n 0.5631 100750.0n 0.4193 100999.9n 0.4193 101000.0n 0.4619 101249.9n 0.4619 101250.0n 0.3820 101499.9n 0.3820 101500.0n 0.3980 101749.9n 0.3980 101750.0n 0.5152 101999.9n 0.5152 102000.0n 0.4992 102249.9n 0.4992 102250.0n 0.3340 102499.9n 0.3340 102500.0n 0.4885 102749.9n 0.4885 102750.0n 0.5685 102999.9n 0.5685 103000.0n 0.5365 103249.9n 0.5365 103250.0n 0.4939 103499.9n 0.4939 103500.0n 0.6644 103749.9n 0.6644 103750.0n 0.4459 103999.9n 0.4459 104000.0n 0.5791 104249.9n 0.5791 104250.0n 0.5098 104499.9n 0.5098 104500.0n 0.5258 104749.9n 0.5258 104750.0n 0.5152 104999.9n 0.5152 105000.0n 0.6644 105249.9n 0.6644 105250.0n 0.5418 105499.9n 0.5418 105500.0n 0.5258 105749.9n 0.5258 105750.0n 0.5525 105999.9n 0.5525 106000.0n 0.4885 106249.9n 0.4885 106250.0n 0.4459 106499.9n 0.4459 106500.0n 0.5578 106749.9n 0.5578 106750.0n 0.5525 106999.9n 0.5525 107000.0n 0.3340 107249.9n 0.3340 107250.0n 0.5365 107499.9n 0.5365 107500.0n 0.4139 107749.9n 0.4139 107750.0n 0.5258 107999.9n 0.5258 108000.0n 0.5631 108249.9n 0.5631 108250.0n 0.4193 108499.9n 0.4193 108500.0n 0.4619 108749.9n 0.4619 108750.0n 0.3820 108999.9n 0.3820 109000.0n 0.3980 109249.9n 0.3980 109250.0n 0.5152 109499.9n 0.5152 109500.0n 0.4992 109749.9n 0.4992 109750.0n 0.3340 109999.9n 0.3340 110000.0n 0.4885 110249.9n 0.4885 110250.0n 0.5685 110499.9n 0.5685 110500.0n 0.5365 110749.9n 0.5365 110750.0n 0.4939 110999.9n 0.4939 111000.0n 0.6644 111249.9n 0.6644 111250.0n 0.4459 111499.9n 0.4459 111500.0n 0.5791 111749.9n 0.5791 111750.0n 0.5098 111999.9n 0.5098 112000.0n 0.5258 112249.9n 0.5258 112250.0n 0.5152 112499.9n 0.5152 112500.0n 0.6644 112749.9n 0.6644 112750.0n 0.5418 112999.9n 0.5418 113000.0n 0.5258 113249.9n 0.5258 113250.0n 0.5525 113499.9n 0.5525 113500.0n 0.4885 113749.9n 0.4885 113750.0n 0.4459 113999.9n 0.4459 114000.0n 0.5578 114249.9n 0.5578 114250.0n 0.5525 114499.9n 0.5525 114500.0n 0.3340 114749.9n 0.3340 114750.0n 0.5365 114999.9n 0.5365 115000.0n 0.4139 115249.9n 0.4139 115250.0n 0.5258 115499.9n 0.5258 115500.0n 0.5631 115749.9n 0.5631 115750.0n 0.4193 115999.9n 0.4193 116000.0n 0.4619 116249.9n 0.4619 116250.0n 0.3820 116499.9n 0.3820 116500.0n 0.3980 116749.9n 0.3980 116750.0n 0.5152 116999.9n 0.5152 117000.0n 0.4992 117249.9n 0.4992 117250.0n 0.3340 117499.9n 0.3340 117500.0n 0.4885 117749.9n 0.4885 117750.0n 0.5685 117999.9n 0.5685 118000.0n 0.5365 118249.9n 0.5365 118250.0n 0.4939 118499.9n 0.4939 118500.0n 0.6644 118749.9n 0.6644 118750.0n 0.4459 118999.9n 0.4459 119000.0n 0.5791 119249.9n 0.5791 119250.0n 0.5098 119499.9n 0.5098 119500.0n 0.5258 119749.9n 0.5258 119750.0n 0.5152 119999.9n 0.5152 120000.0n 0.6644 120249.9n 0.6644 120250.0n 0.5418 120499.9n 0.5418 120500.0n 0.5258 120749.9n 0.5258 120750.0n 0.5525 120999.9n 0.5525 121000.0n 0.4885 121249.9n 0.4885 121250.0n 0.4459 121499.9n 0.4459 121500.0n 0.5578 121749.9n 0.5578 121750.0n 0.5525 121999.9n 0.5525 122000.0n 0.3340 122249.9n 0.3340 122250.0n 0.5365 122499.9n 0.5365 122500.0n 0.4139 122749.9n 0.4139 122750.0n 0.5258 122999.9n 0.5258 123000.0n 0.5631 123249.9n 0.5631 123250.0n 0.4193 123499.9n 0.4193 123500.0n 0.4619 123749.9n 0.4619 123750.0n 0.3820 123999.9n 0.3820 124000.0n 0.3980 124249.9n 0.3980 124250.0n 0.5152 124499.9n 0.5152 124500.0n 0.4992 124749.9n 0.4992 124750.0n 0.3340 124999.9n 0.3340 125000.0n 0.4885 125249.9n 0.4885 125250.0n 0.5685 125499.9n 0.5685 125500.0n 0.5365 125749.9n 0.5365 125750.0n 0.4939 125999.9n 0.4939 126000.0n 0.6644 126249.9n 0.6644 126250.0n 0.4459 126499.9n 0.4459 126500.0n 0.5791 126749.9n 0.5791 126750.0n 0.5098 126999.9n 0.5098 127000.0n 0.5258 127249.9n 0.5258 127250.0n 0.5152 127499.9n 0.5152 127500.0n 0.6644 127749.9n 0.6644 127750.0n 0.5418 127999.9n 0.5418 128000.0n 0.5258 128249.9n 0.5258 128250.0n 0.5525 128499.9n 0.5525 128500.0n 0.4885 128749.9n 0.4885 128750.0n 0.4459 128999.9n 0.4459 129000.0n 0.5578 129249.9n 0.5578 129250.0n 0.5525 129499.9n 0.5525 129500.0n 0.3340 129749.9n 0.3340 129750.0n 0.5365 129999.9n 0.5365 130000.0n 0.4139 130249.9n 0.4139 130250.0n 0.5258 130499.9n 0.5258 130500.0n 0.5631 130749.9n 0.5631 130750.0n 0.4193 130999.9n 0.4193 131000.0n 0.4619 131249.9n 0.4619 131250.0n 0.3820 131499.9n 0.3820 131500.0n 0.3980 131749.9n 0.3980 131750.0n 0.5152 131999.9n 0.5152 132000.0n 0.4992 132249.9n 0.4992 132250.0n 0.3340 132499.9n 0.3340 132500.0n 0.4885 132749.9n 0.4885 132750.0n 0.5685 132999.9n 0.5685 133000.0n 0.5365 133249.9n 0.5365 133250.0n 0.4939 133499.9n 0.4939 133500.0n 0.6644 133749.9n 0.6644 133750.0n 0.4459 133999.9n 0.4459 134000.0n 0.5791 134249.9n 0.5791 134250.0n 0.5098 134499.9n 0.5098 134500.0n 0.5258 134749.9n 0.5258 134750.0n 0.5152 134999.9n 0.5152 135000.0n 0.6644 135249.9n 0.6644 135250.0n 0.5418 135499.9n 0.5418 135500.0n 0.5258 135749.9n 0.5258 135750.0n 0.5525 135999.9n 0.5525 136000.0n 0.4885 136249.9n 0.4885 136250.0n 0.4459 136499.9n 0.4459 136500.0n 0.5578 136749.9n 0.5578 136750.0n 0.5525 136999.9n 0.5525 137000.0n 0.3340 137249.9n 0.3340 137250.0n 0.5365 137499.9n 0.5365 137500.0n 0.4139 137749.9n 0.4139 137750.0n 0.5258 137999.9n 0.5258 138000.0n 0.5631 138249.9n 0.5631 138250.0n 0.4193 138499.9n 0.4193 138500.0n 0.4619 138749.9n 0.4619 138750.0n 0.3820 138999.9n 0.3820 139000.0n 0.3980 139249.9n 0.3980 139250.0n 0.5152 139499.9n 0.5152 139500.0n 0.4992 139749.9n 0.4992 139750.0n 0.3340 139999.9n 0.3340 140000.0n 0.4885 140249.9n 0.4885 140250.0n 0.5685 140499.9n 0.5685 140500.0n 0.5365 140749.9n 0.5365 140750.0n 0.4939 140999.9n 0.4939 141000.0n 0.6644 141249.9n 0.6644 141250.0n 0.4459 141499.9n 0.4459 141500.0n 0.5791 141749.9n 0.5791 141750.0n 0.5098 141999.9n 0.5098 142000.0n 0.5258 142249.9n 0.5258 142250.0n 0.5152 142499.9n 0.5152 142500.0n 0.6644 142749.9n 0.6644 142750.0n 0.5418 142999.9n 0.5418 143000.0n 0.5258 143249.9n 0.5258 143250.0n 0.5525 143499.9n 0.5525 143500.0n 0.4885 143749.9n 0.4885 143750.0n 0.4459 143999.9n 0.4459 144000.0n 0.5578 144249.9n 0.5578 144250.0n 0.5525 144499.9n 0.5525 144500.0n 0.3340 144749.9n 0.3340 144750.0n 0.5365 144999.9n 0.5365 145000.0n 0.4139 145249.9n 0.4139 145250.0n 0.5258 145499.9n 0.5258 145500.0n 0.5631 145749.9n 0.5631 145750.0n 0.4193 145999.9n 0.4193 146000.0n 0.4619 146249.9n 0.4619 146250.0n 0.3820 146499.9n 0.3820 146500.0n 0.3980 146749.9n 0.3980 146750.0n 0.5152 146999.9n 0.5152 147000.0n 0.4992 147249.9n 0.4992 147250.0n 0.3340 147499.9n 0.3340 147500.0n 0.4885 147749.9n 0.4885 147750.0n 0.5685 147999.9n 0.5685 148000.0n 0.5365 148249.9n 0.5365 148250.0n 0.4939 148499.9n 0.4939 148500.0n 0.6644 148749.9n 0.6644 148750.0n 0.4459 148999.9n 0.4459 149000.0n 0.5791 149249.9n 0.5791 149250.0n 0.5098 149499.9n 0.5098 149500.0n 0.5258 149749.9n 0.5258 149750.0n 0.5152 149999.9n 0.5152 150000.0n 0.6644 150249.9n 0.6644 150250.0n 0.5418 150499.9n 0.5418 150500.0n 0.5258 150749.9n 0.5258 150750.0n 0.5525 150999.9n 0.5525 151000.0n 0.4885 151249.9n 0.4885 151250.0n 0.4459 151499.9n 0.4459 151500.0n 0.5578 151749.9n 0.5578 151750.0n 0.5525 151999.9n 0.5525 152000.0n 0.3340 152249.9n 0.3340 152250.0n 0.5365 152499.9n 0.5365 152500.0n 0.4139 152749.9n 0.4139 152750.0n 0.5258 152999.9n 0.5258 153000.0n 0.5631 153249.9n 0.5631 153250.0n 0.4193 153499.9n 0.4193 153500.0n 0.4619 153749.9n 0.4619 153750.0n 0.3820 153999.9n 0.3820 154000.0n 0.3980 154249.9n 0.3980 154250.0n 0.5152 154499.9n 0.5152 154500.0n 0.4992 154749.9n 0.4992 154750.0n 0.3340 154999.9n 0.3340 155000.0n 0.4885 155249.9n 0.4885 155250.0n 0.5685 155499.9n 0.5685 155500.0n 0.5365 155749.9n 0.5365 155750.0n 0.4939 155999.9n 0.4939 156000.0n 0.6644 156249.9n 0.6644 156250.0n 0.4459 156499.9n 0.4459 156500.0n 0.5791 156749.9n 0.5791 156750.0n 0.5098 156999.9n 0.5098 157000.0n 0.5258 157249.9n 0.5258 157250.0n 0.5152 157499.9n 0.5152 157500.0n 0.6644 157749.9n 0.6644 157750.0n 0.5418 157999.9n 0.5418 158000.0n 0.5258 158249.9n 0.5258 158250.0n 0.5525 158499.9n 0.5525 158500.0n 0.4885 158749.9n 0.4885 158750.0n 0.4459 158999.9n 0.4459 159000.0n 0.5578 159249.9n 0.5578 159250.0n 0.5525 159499.9n 0.5525 159500.0n 0.3340 159749.9n 0.3340 159750.0n 0.5365 159999.9n 0.5365 160000.0n 0.4139 160249.9n 0.4139 160250.0n 0.5258 160499.9n 0.5258 160500.0n 0.5631 160749.9n 0.5631 160750.0n 0.4193 160999.9n 0.4193 161000.0n 0.4619 161249.9n 0.4619 161250.0n 0.3820 161499.9n 0.3820 161500.0n 0.3980 161749.9n 0.3980 161750.0n 0.5152 161999.9n 0.5152 162000.0n 0.4992 162249.9n 0.4992 162250.0n 0.3340 162499.9n 0.3340 162500.0n 0.4885 162749.9n 0.4885 162750.0n 0.5685 162999.9n 0.5685 163000.0n 0.5365 163249.9n 0.5365 163250.0n 0.4939 163499.9n 0.4939 163500.0n 0.6644 163749.9n 0.6644 163750.0n 0.4459 163999.9n 0.4459 164000.0n 0.5791 164249.9n 0.5791 164250.0n 0.5098 164499.9n 0.5098 164500.0n 0.5258 164749.9n 0.5258 164750.0n 0.5152 164999.9n 0.5152 165000.0n 0.6644 165249.9n 0.6644 165250.0n 0.5418 165499.9n 0.5418 165500.0n 0.5258 165749.9n 0.5258 165750.0n 0.5525 165999.9n 0.5525 166000.0n 0.4885 166249.9n 0.4885 166250.0n 0.4459 166499.9n 0.4459 166500.0n 0.5578 166749.9n 0.5578 166750.0n 0.5525 166999.9n 0.5525 167000.0n 0.3340 167249.9n 0.3340 167250.0n 0.5365 167499.9n 0.5365 167500.0n 0.4139 167749.9n 0.4139 167750.0n 0.5258 167999.9n 0.5258 168000.0n 0.5631 168249.9n 0.5631 168250.0n 0.4193 168499.9n 0.4193 168500.0n 0.4619 168749.9n 0.4619 168750.0n 0.3820 168999.9n 0.3820 169000.0n 0.3980 169249.9n 0.3980 169250.0n 0.5152 169499.9n 0.5152 169500.0n 0.4992 169749.9n 0.4992 169750.0n 0.3340 169999.9n 0.3340 170000.0n 0.4885 170249.9n 0.4885 170250.0n 0.5685 170499.9n 0.5685 170500.0n 0.5365 170749.9n 0.5365 170750.0n 0.4939 170999.9n 0.4939 171000.0n 0.6644 171249.9n 0.6644 171250.0n 0.4459 171499.9n 0.4459 171500.0n 0.5791 171749.9n 0.5791 171750.0n 0.5098 171999.9n 0.5098 172000.0n 0.5258 172249.9n 0.5258 172250.0n 0.5152 172499.9n 0.5152 172500.0n 0.6644 172749.9n 0.6644 172750.0n 0.5418 172999.9n 0.5418 173000.0n 0.5258 173249.9n 0.5258 173250.0n 0.5525 173499.9n 0.5525 173500.0n 0.4885 173749.9n 0.4885 173750.0n 0.4459 173999.9n 0.4459 174000.0n 0.5578 174249.9n 0.5578 174250.0n 0.5525 174499.9n 0.5525 174500.0n 0.3340 174749.9n 0.3340 174750.0n 0.5365 174999.9n 0.5365 175000.0n 0.4139 175249.9n 0.4139 175250.0n 0.5258 175499.9n 0.5258 175500.0n 0.5631 175749.9n 0.5631 175750.0n 0.4193 175999.9n 0.4193 176000.0n 0.4619 176249.9n 0.4619 176250.0n 0.3820 176499.9n 0.3820 176500.0n 0.3980 176749.9n 0.3980 176750.0n 0.5152 176999.9n 0.5152 177000.0n 0.4992 177249.9n 0.4992 177250.0n 0.3340 177499.9n 0.3340 177500.0n 0.4885 177749.9n 0.4885 177750.0n 0.5685 177999.9n 0.5685 178000.0n 0.5365 178249.9n 0.5365 178250.0n 0.4939 178499.9n 0.4939 178500.0n 0.6644 178749.9n 0.6644 178750.0n 0.4459 178999.9n 0.4459 179000.0n 0.5791 179249.9n 0.5791 179250.0n 0.5098 179499.9n 0.5098 179500.0n 0.5258 179749.9n 0.5258 179750.0n 0.5152 179999.9n 0.5152 180000.0n 0.6644 180249.9n 0.6644 180250.0n 0.5418 180499.9n 0.5418 180500.0n 0.5258 180749.9n 0.5258 180750.0n 0.5525 180999.9n 0.5525 181000.0n 0.4885 181249.9n 0.4885 181250.0n 0.4459 181499.9n 0.4459 181500.0n 0.5578 181749.9n 0.5578 181750.0n 0.5525 181999.9n 0.5525 182000.0n 0.3340 182249.9n 0.3340 182250.0n 0.5365 182499.9n 0.5365 182500.0n 0.4139 182749.9n 0.4139 182750.0n 0.5258 182999.9n 0.5258 183000.0n 0.5631 183249.9n 0.5631 183250.0n 0.4193 183499.9n 0.4193 183500.0n 0.4619 183749.9n 0.4619 183750.0n 0.3820 183999.9n 0.3820 184000.0n 0.3980 184249.9n 0.3980 184250.0n 0.5152 184499.9n 0.5152 184500.0n 0.4992 184749.9n 0.4992 184750.0n 0.3340 184999.9n 0.3340 185000.0n 0.4885 185249.9n 0.4885 185250.0n 0.5685 185499.9n 0.5685 185500.0n 0.5365 185749.9n 0.5365 185750.0n 0.4939 185999.9n 0.4939 186000.0n 0.6644 186249.9n 0.6644 186250.0n 0.4459 186499.9n 0.4459 186500.0n 0.5791 186749.9n 0.5791 186750.0n 0.5098 186999.9n 0.5098 187000.0n 0.5258 187249.9n 0.5258 187250.0n 0.5152 187499.9n 0.5152 187500.0n 0.6644 187749.9n 0.6644 187750.0n 0.5418 187999.9n 0.5418 188000.0n 0.5258 188249.9n 0.5258 188250.0n 0.5525 188499.9n 0.5525 188500.0n 0.4885 188749.9n 0.4885 188750.0n 0.4459 188999.9n 0.4459 189000.0n 0.5578 189249.9n 0.5578 189250.0n 0.5525 189499.9n 0.5525 189500.0n 0.3340 189749.9n 0.3340 189750.0n 0.5365 189999.9n 0.5365 190000.0n 0.4139 190249.9n 0.4139 190250.0n 0.5258 190499.9n 0.5258 190500.0n 0.5631 190749.9n 0.5631 190750.0n 0.4193 190999.9n 0.4193 191000.0n 0.4619 191249.9n 0.4619 191250.0n 0.3820 191499.9n 0.3820 191500.0n 0.3980 191749.9n 0.3980 191750.0n 0.5152 191999.9n 0.5152 192000.0n 0.4992 192249.9n 0.4992 192250.0n 0.3340 192499.9n 0.3340 192500.0n 0.4885 192749.9n 0.4885 192750.0n 0.5685 192999.9n 0.5685 193000.0n 0.5365 193249.9n 0.5365 193250.0n 0.4939 193499.9n 0.4939 193500.0n 0.6644 193749.9n 0.6644 193750.0n 0.4459 193999.9n 0.4459 194000.0n 0.5791 194249.9n 0.5791 194250.0n 0.5098 194499.9n 0.5098 194500.0n 0.5258 194749.9n 0.5258 194750.0n 0.5152 194999.9n 0.5152 195000.0n 0.6644 195249.9n 0.6644 195250.0n 0.5418 195499.9n 0.5418 195500.0n 0.5258 195749.9n 0.5258 195750.0n 0.5525 195999.9n 0.5525 196000.0n 0.4885 196249.9n 0.4885 196250.0n 0.4459 196499.9n 0.4459 196500.0n 0.5578 196749.9n 0.5578 196750.0n 0.5525 196999.9n 0.5525 197000.0n 0.3340 197249.9n 0.3340 197250.0n 0.5365 197499.9n 0.5365 197500.0n 0.4139 197749.9n 0.4139 197750.0n 0.5258 197999.9n 0.5258 198000.0n 0.5631 198249.9n 0.5631 198250.0n 0.4193 198499.9n 0.4193 198500.0n 0.4619 198749.9n 0.4619 198750.0n 0.3820 198999.9n 0.3820 199000.0n 0.3980 199249.9n 0.3980 199250.0n 0.5152 199499.9n 0.5152 199500.0n 0.4992 199749.9n 0.4992 199750.0n 0.3340 199999.9n 0.3340 200000.0n 0.4885 200249.9n 0.4885 200250.0n 0.5685 200499.9n 0.5685 200500.0n 0.5365 200749.9n 0.5365 200750.0n 0.4939 200999.9n 0.4939 201000.0n 0.6644 201249.9n 0.6644 201250.0n 0.4459 201499.9n 0.4459 201500.0n 0.5791 201749.9n 0.5791 201750.0n 0.5098 201999.9n 0.5098 202000.0n 0.5258 202249.9n 0.5258 202250.0n 0.5152 202499.9n 0.5152 202500.0n 0.6644 202749.9n 0.6644 202750.0n 0.5418 202999.9n 0.5418 203000.0n 0.5258 203249.9n 0.5258 203250.0n 0.5525 203499.9n 0.5525 203500.0n 0.4885 203749.9n 0.4885 203750.0n 0.4459 203999.9n 0.4459 204000.0n 0.5578 204249.9n 0.5578 204250.0n 0.5525 204499.9n 0.5525 204500.0n 0.3340 204749.9n 0.3340 204750.0n 0.5365 204999.9n 0.5365 205000.0n 0.4139 205249.9n 0.4139 205250.0n 0.5258 205499.9n 0.5258 205500.0n 0.5631 205749.9n 0.5631 205750.0n 0.4193 205999.9n 0.4193 206000.0n 0.4619 206249.9n 0.4619 206250.0n 0.3820 206499.9n 0.3820 206500.0n 0.3980 206749.9n 0.3980 206750.0n 0.5152 206999.9n 0.5152 207000.0n 0.4992 207249.9n 0.4992 207250.0n 0.3340 207499.9n 0.3340 207500.0n 0.4885 207749.9n 0.4885 207750.0n 0.5685 207999.9n 0.5685 208000.0n 0.5365 208249.9n 0.5365 208250.0n 0.4939 208499.9n 0.4939 208500.0n 0.6644 208749.9n 0.6644 208750.0n 0.4459 208999.9n 0.4459 209000.0n 0.5791 209249.9n 0.5791 209250.0n 0.5098 209499.9n 0.5098 209500.0n 0.5258 209749.9n 0.5258 209750.0n 0.5152 209999.9n 0.5152 210000.0n 0.6644 210249.9n 0.6644 210250.0n 0.5418 210499.9n 0.5418 210500.0n 0.5258 210749.9n 0.5258 210750.0n 0.5525 210999.9n 0.5525 211000.0n 0.4885 211249.9n 0.4885 211250.0n 0.4459 211499.9n 0.4459 211500.0n 0.5578 211749.9n 0.5578 211750.0n 0.5525 211999.9n 0.5525 212000.0n 0.3340 212249.9n 0.3340 212250.0n 0.5365 212499.9n 0.5365 212500.0n 0.4139 212749.9n 0.4139 212750.0n 0.5258 212999.9n 0.5258 213000.0n 0.5631 213249.9n 0.5631 213250.0n 0.4193 213499.9n 0.4193 213500.0n 0.4619 213749.9n 0.4619 213750.0n 0.3820 213999.9n 0.3820 214000.0n 0.3980 214249.9n 0.3980 214250.0n 0.5152 214499.9n 0.5152 214500.0n 0.4992 214749.9n 0.4992 214750.0n 0.3340 214999.9n 0.3340 215000.0n 0.4885 215249.9n 0.4885 215250.0n 0.5685 215499.9n 0.5685 215500.0n 0.5365 215749.9n 0.5365 215750.0n 0.4939 215999.9n 0.4939 216000.0n 0.6644 216249.9n 0.6644 216250.0n 0.4459 216499.9n 0.4459 216500.0n 0.5791 216749.9n 0.5791 216750.0n 0.5098 216999.9n 0.5098 217000.0n 0.5258 217249.9n 0.5258 217250.0n 0.5152 217499.9n 0.5152 217500.0n 0.6644 217749.9n 0.6644 217750.0n 0.5418 217999.9n 0.5418 218000.0n 0.5258 218249.9n 0.5258 218250.0n 0.5525 218499.9n 0.5525 218500.0n 0.4885 218749.9n 0.4885 218750.0n 0.4459 218999.9n 0.4459 219000.0n 0.5578 219249.9n 0.5578 219250.0n 0.5525 219499.9n 0.5525 219500.0n 0.3340 219749.9n 0.3340 219750.0n 0.5365 219999.9n 0.5365 220000.0n 0.4139 220249.9n 0.4139 220250.0n 0.5258 220499.9n 0.5258 220500.0n 0.5631 220749.9n 0.5631 220750.0n 0.4193 220999.9n 0.4193 221000.0n 0.4619 221249.9n 0.4619 221250.0n 0.3820 221499.9n 0.3820 221500.0n 0.3980 221749.9n 0.3980 221750.0n 0.5152 221999.9n 0.5152 222000.0n 0.4992 222249.9n 0.4992 222250.0n 0.3340 222499.9n 0.3340 222500.0n 0.4885 222749.9n 0.4885 222750.0n 0.5685 222999.9n 0.5685 223000.0n 0.5365 223249.9n 0.5365 223250.0n 0.4939 223499.9n 0.4939 223500.0n 0.6644 223749.9n 0.6644 223750.0n 0.4459 223999.9n 0.4459 224000.0n 0.5791 224249.9n 0.5791 224250.0n 0.5098 224499.9n 0.5098 224500.0n 0.5258 224749.9n 0.5258 224750.0n 0.5152 224999.9n 0.5152 225000.0n 0.6644 225249.9n 0.6644 225250.0n 0.5418 225499.9n 0.5418 225500.0n 0.5258 225749.9n 0.5258 225750.0n 0.5525 225999.9n 0.5525 226000.0n 0.4885 226249.9n 0.4885 226250.0n 0.4459 226499.9n 0.4459 226500.0n 0.5578 226749.9n 0.5578 226750.0n 0.5525 226999.9n 0.5525 227000.0n 0.3340 227249.9n 0.3340 227250.0n 0.5365 227499.9n 0.5365 227500.0n 0.4139 227749.9n 0.4139 227750.0n 0.5258 227999.9n 0.5258 228000.0n 0.5631 228249.9n 0.5631 228250.0n 0.4193 228499.9n 0.4193 228500.0n 0.4619 228749.9n 0.4619 228750.0n 0.3820 228999.9n 0.3820 229000.0n 0.3980 229249.9n 0.3980 229250.0n 0.5152 229499.9n 0.5152 229500.0n 0.4992 229749.9n 0.4992 229750.0n 0.3340 229999.9n 0.3340 230000.0n 0.4885 230249.9n 0.4885 230250.0n 0.5685 230499.9n 0.5685 230500.0n 0.5365 230749.9n 0.5365 230750.0n 0.4939 230999.9n 0.4939 231000.0n 0.6644 231249.9n 0.6644 231250.0n 0.4459 231499.9n 0.4459 231500.0n 0.5791 231749.9n 0.5791 231750.0n 0.5098 231999.9n 0.5098 232000.0n 0.5258 232249.9n 0.5258 232250.0n 0.5152 232499.9n 0.5152 232500.0n 0.6644 232749.9n 0.6644 232750.0n 0.5418 232999.9n 0.5418 233000.0n 0.5258 233249.9n 0.5258 233250.0n 0.5525 233499.9n 0.5525 233500.0n 0.4885 233749.9n 0.4885 233750.0n 0.4459 233999.9n 0.4459 234000.0n 0.5578 234249.9n 0.5578 234250.0n 0.5525 234499.9n 0.5525 234500.0n 0.3340 234749.9n 0.3340 234750.0n 0.5365 234999.9n 0.5365 235000.0n 0.4139 235249.9n 0.4139 235250.0n 0.5258 235499.9n 0.5258 235500.0n 0.5631 235749.9n 0.5631 235750.0n 0.4193 235999.9n 0.4193 236000.0n 0.4619 236249.9n 0.4619 236250.0n 0.3820 236499.9n 0.3820 236500.0n 0.3980 236749.9n 0.3980 236750.0n 0.5152 236999.9n 0.5152 237000.0n 0.4992 237249.9n 0.4992 237250.0n 0.3340 237499.9n 0.3340 237500.0n 0.4885 237749.9n 0.4885 237750.0n 0.5685 237999.9n 0.5685 238000.0n 0.5365 238249.9n 0.5365 238250.0n 0.4939 238499.9n 0.4939 238500.0n 0.6644 238749.9n 0.6644 238750.0n 0.4459 238999.9n 0.4459 239000.0n 0.5791 239249.9n 0.5791 239250.0n 0.5098 239499.9n 0.5098 239500.0n 0.5258 239749.9n 0.5258 239750.0n 0.5152 239999.9n 0.5152 240000.0n 0.6644 240249.9n 0.6644 240250.0n 0.5418 240499.9n 0.5418 240500.0n 0.5258 240749.9n 0.5258 240750.0n 0.5525 240999.9n 0.5525 241000.0n 0.4885 241249.9n 0.4885 241250.0n 0.4459 241499.9n 0.4459 241500.0n 0.5578 241749.9n 0.5578 241750.0n 0.5525 241999.9n 0.5525 242000.0n 0.3340 242249.9n 0.3340 242250.0n 0.5365 242499.9n 0.5365 242500.0n 0.4139 242749.9n 0.4139 242750.0n 0.5258 242999.9n 0.5258 243000.0n 0.5631 243249.9n 0.5631 243250.0n 0.4193 243499.9n 0.4193 243500.0n 0.4619 243749.9n 0.4619 243750.0n 0.3820 243999.9n 0.3820 244000.0n 0.3980 244249.9n 0.3980 244250.0n 0.5152 244499.9n 0.5152 244500.0n 0.4992 244749.9n 0.4992 244750.0n 0.3340 244999.9n 0.3340 245000.0n 0.4885 245249.9n 0.4885 245250.0n 0.5685 245499.9n 0.5685 245500.0n 0.5365 245749.9n 0.5365 245750.0n 0.4939 245999.9n 0.4939 246000.0n 0.6644 246249.9n 0.6644 246250.0n 0.4459 246499.9n 0.4459 246500.0n 0.5791 246749.9n 0.5791 246750.0n 0.5098 246999.9n 0.5098 247000.0n 0.5258 247249.9n 0.5258 247250.0n 0.5152 247499.9n 0.5152 247500.0n 0.6644 247749.9n 0.6644 247750.0n 0.5418 247999.9n 0.5418 248000.0n 0.5258 248249.9n 0.5258 248250.0n 0.5525 248499.9n 0.5525 248500.0n 0.4885 248749.9n 0.4885 248750.0n 0.4459 248999.9n 0.4459 249000.0n 0.5578 249249.9n 0.5578 249250.0n 0.5525 249499.9n 0.5525 249500.0n 0.3340 249749.9n 0.3340 249750.0n 0.5365 249999.9n 0.5365 250000.0n 0.4139 250249.9n 0.4139 250250.0n 0.5258 250499.9n 0.5258 250500.0n 0.5631 250749.9n 0.5631 250750.0n 0.4193 250999.9n 0.4193 251000.0n 0.4619 251249.9n 0.4619 251250.0n 0.3820 251499.9n 0.3820 251500.0n 0.3980 251749.9n 0.3980 251750.0n 0.5152 251999.9n 0.5152 252000.0n 0.4992 252249.9n 0.4992 252250.0n 0.3340 252499.9n 0.3340 252500.0n 0.4885 252749.9n 0.4885 252750.0n 0.5685 252999.9n 0.5685 253000.0n 0.5365 253249.9n 0.5365 253250.0n 0.4939 253499.9n 0.4939 253500.0n 0.6644 253749.9n 0.6644 253750.0n 0.4459 253999.9n 0.4459 254000.0n 0.5791 254249.9n 0.5791 254250.0n 0.5098 254499.9n 0.5098 254500.0n 0.5258 254749.9n 0.5258 254750.0n 0.5152 254999.9n 0.5152 255000.0n 0.6644 255249.9n 0.6644 255250.0n 0.5418 255499.9n 0.5418 255500.0n 0.5258 255749.9n 0.5258 255750.0n 0.5525 255999.9n 0.5525 256000.0n 0.4885 256249.9n 0.4885 256250.0n 0.4459 256499.9n 0.4459 256500.0n 0.5578 256749.9n 0.5578 256750.0n 0.5525 256999.9n 0.5525 257000.0n 0.3340 257249.9n 0.3340 257250.0n 0.5365 257499.9n 0.5365 257500.0n 0.4139 257749.9n 0.4139 257750.0n 0.5258 257999.9n 0.5258 258000.0n 0.5631 258249.9n 0.5631 258250.0n 0.4193 258499.9n 0.4193 258500.0n 0.4619 258749.9n 0.4619 258750.0n 0.3820 258999.9n 0.3820 259000.0n 0.3980 259249.9n 0.3980 259250.0n 0.5152 259499.9n 0.5152 259500.0n 0.4992 259749.9n 0.4992 259750.0n 0.3340 259999.9n 0.3340 260000.0n 0.4885 260249.9n 0.4885 260250.0n 0.5685 260499.9n 0.5685 260500.0n 0.5365 260749.9n 0.5365 260750.0n 0.4939 260999.9n 0.4939 261000.0n 0.6644 261249.9n 0.6644 261250.0n 0.4459 261499.9n 0.4459 261500.0n 0.5791 261749.9n 0.5791 261750.0n 0.5098 261999.9n 0.5098 262000.0n 0.5258 262249.9n 0.5258 262250.0n 0.5152 262499.9n 0.5152 262500.0n 0.6644 262749.9n 0.6644 262750.0n 0.5418 262999.9n 0.5418 263000.0n 0.5258 263249.9n 0.5258 263250.0n 0.5525 263499.9n 0.5525 263500.0n 0.4885 263749.9n 0.4885 263750.0n 0.4459 263999.9n 0.4459 264000.0n 0.5578 264249.9n 0.5578 264250.0n 0.5525 264499.9n 0.5525 264500.0n 0.3340 264749.9n 0.3340 264750.0n 0.5365 264999.9n 0.5365 265000.0n 0.4139 265249.9n 0.4139 265250.0n 0.5258 265499.9n 0.5258 265500.0n 0.5631 265749.9n 0.5631 265750.0n 0.4193 265999.9n 0.4193 266000.0n 0.4619 266249.9n 0.4619 266250.0n 0.3820 266499.9n 0.3820 266500.0n 0.3980 266749.9n 0.3980 266750.0n 0.5152 266999.9n 0.5152 267000.0n 0.4992 267249.9n 0.4992 267250.0n 0.3340 267499.9n 0.3340 267500.0n 0.4885 267749.9n 0.4885 267750.0n 0.5685 267999.9n 0.5685 268000.0n 0.5365 268249.9n 0.5365 268250.0n 0.4939 268499.9n 0.4939 268500.0n 0.6644 268749.9n 0.6644 268750.0n 0.4459 268999.9n 0.4459 269000.0n 0.5791 269249.9n 0.5791 269250.0n 0.5098 269499.9n 0.5098 269500.0n 0.5258 269749.9n 0.5258 269750.0n 0.5152 269999.9n 0.5152 270000.0n 0.6644 270249.9n 0.6644 270250.0n 0.5418 270499.9n 0.5418 270500.0n 0.5258 270749.9n 0.5258 270750.0n 0.5525 270999.9n 0.5525 271000.0n 0.4885 271249.9n 0.4885 271250.0n 0.4459 271499.9n 0.4459 271500.0n 0.5578 271749.9n 0.5578 271750.0n 0.5525 271999.9n 0.5525 272000.0n 0.3340 272249.9n 0.3340 272250.0n 0.5365 272499.9n 0.5365 272500.0n 0.4139 272749.9n 0.4139 272750.0n 0.5258 272999.9n 0.5258 273000.0n 0.5631 273249.9n 0.5631 273250.0n 0.4193 273499.9n 0.4193 273500.0n 0.4619 273749.9n 0.4619 273750.0n 0.3820 273999.9n 0.3820 274000.0n 0.3980 274249.9n 0.3980 274250.0n 0.5152 274499.9n 0.5152 274500.0n 0.4992 274749.9n 0.4992 274750.0n 0.3340 274999.9n 0.3340 275000.0n 0.4885 275249.9n 0.4885 275250.0n 0.5685 275499.9n 0.5685 275500.0n 0.5365 275749.9n 0.5365 275750.0n 0.4939 275999.9n 0.4939 276000.0n 0.6644 276249.9n 0.6644 276250.0n 0.4459 276499.9n 0.4459 276500.0n 0.5791 276749.9n 0.5791 276750.0n 0.5098 276999.9n 0.5098 277000.0n 0.5258 277249.9n 0.5258 277250.0n 0.5152 277499.9n 0.5152 277500.0n 0.6644 277749.9n 0.6644 277750.0n 0.5418 277999.9n 0.5418 278000.0n 0.5258 278249.9n 0.5258 278250.0n 0.5525 278499.9n 0.5525 278500.0n 0.4885 278749.9n 0.4885 278750.0n 0.4459 278999.9n 0.4459 279000.0n 0.5578 279249.9n 0.5578 279250.0n 0.5525 279499.9n 0.5525 279500.0n 0.3340 279749.9n 0.3340 279750.0n 0.5365 279999.9n 0.5365 280000.0n 0.4139 280249.9n 0.4139 280250.0n 0.5258 280499.9n 0.5258 280500.0n 0.5631 280749.9n 0.5631 280750.0n 0.4193 280999.9n 0.4193 281000.0n 0.4619 281249.9n 0.4619 281250.0n 0.3820 281499.9n 0.3820 281500.0n 0.3980 281749.9n 0.3980 281750.0n 0.5152 281999.9n 0.5152 282000.0n 0.4992 282249.9n 0.4992 282250.0n 0.3340 282499.9n 0.3340 282500.0n 0.4885 282749.9n 0.4885 282750.0n 0.5685 282999.9n 0.5685 283000.0n 0.5365 283249.9n 0.5365 283250.0n 0.4939 283499.9n 0.4939 283500.0n 0.6644 283749.9n 0.6644 283750.0n 0.4459 283999.9n 0.4459 284000.0n 0.5791 284249.9n 0.5791 284250.0n 0.5098 284499.9n 0.5098 284500.0n 0.5258 284749.9n 0.5258 284750.0n 0.5152 284999.9n 0.5152 285000.0n 0.6644 285249.9n 0.6644 285250.0n 0.5418 285499.9n 0.5418 285500.0n 0.5258 285749.9n 0.5258 285750.0n 0.5525 285999.9n 0.5525 286000.0n 0.4885 286249.9n 0.4885 286250.0n 0.4459 286499.9n 0.4459 286500.0n 0.5578 286749.9n 0.5578 286750.0n 0.5525 286999.9n 0.5525 287000.0n 0.3340 287249.9n 0.3340 287250.0n 0.5365 287499.9n 0.5365 287500.0n 0.4139 287749.9n 0.4139 287750.0n 0.5258 287999.9n 0.5258 288000.0n 0.5631 288249.9n 0.5631 288250.0n 0.4193 288499.9n 0.4193 288500.0n 0.4619 288749.9n 0.4619 288750.0n 0.3820 288999.9n 0.3820 289000.0n 0.3980 289249.9n 0.3980 289250.0n 0.5152 289499.9n 0.5152 289500.0n 0.4992 289749.9n 0.4992 289750.0n 0.3340 289999.9n 0.3340 290000.0n 0.4885 290249.9n 0.4885 290250.0n 0.5685 290499.9n 0.5685 290500.0n 0.5365 290749.9n 0.5365 290750.0n 0.4939 290999.9n 0.4939 291000.0n 0.6644 291249.9n 0.6644 291250.0n 0.4459 291499.9n 0.4459 291500.0n 0.5791 291749.9n 0.5791 291750.0n 0.5098 291999.9n 0.5098 292000.0n 0.5258 292249.9n 0.5258 292250.0n 0.5152 292499.9n 0.5152 292500.0n 0.6644 292749.9n 0.6644 292750.0n 0.5418 292999.9n 0.5418 293000.0n 0.5258 293249.9n 0.5258 293250.0n 0.5525 293499.9n 0.5525 293500.0n 0.4885 293749.9n 0.4885 293750.0n 0.4459 293999.9n 0.4459 294000.0n 0.5578 294249.9n 0.5578 294250.0n 0.5525 294499.9n 0.5525 294500.0n 0.3340 294749.9n 0.3340 294750.0n 0.5365 294999.9n 0.5365 295000.0n 0.4139 295249.9n 0.4139 295250.0n 0.5258 295499.9n 0.5258 295500.0n 0.5631 295749.9n 0.5631 295750.0n 0.4193 295999.9n 0.4193 296000.0n 0.4619 296249.9n 0.4619 296250.0n 0.3820 296499.9n 0.3820 296500.0n 0.3980 296749.9n 0.3980 296750.0n 0.5152 296999.9n 0.5152 297000.0n 0.4992 297249.9n 0.4992 297250.0n 0.3340 297499.9n 0.3340 297500.0n 0.4885 297749.9n 0.4885 297750.0n 0.5685 297999.9n 0.5685 298000.0n 0.5365 298249.9n 0.5365 298250.0n 0.4939 298499.9n 0.4939 298500.0n 0.6644 298749.9n 0.6644 298750.0n 0.4459 298999.9n 0.4459 299000.0n 0.5791 299249.9n 0.5791 299250.0n 0.5098 299499.9n 0.5098 299500.0n 0.5258 299749.9n 0.5258 299750.0n 0.5152)
Vxp10 a_xp10 0 PWL(0.0n 0.5076 249.9n 0.5076 250.0n 0.3191 499.9n 0.3191 500.0n 0.3989 749.9n 0.3989 750.0n 0.3409 999.9n 0.3409 1000.0n 0.2974 1249.9n 0.2974 1250.0n 0.6453 1499.9n 0.6453 1500.0n 0.3699 1749.9n 0.3699 1750.0n 0.7105 1999.9n 0.7105 2000.0n 0.4206 2249.9n 0.4206 2250.0n 0.4206 2499.9n 0.4206 2500.0n 0.3046 2749.9n 0.3046 2750.0n 0.3409 2999.9n 0.3409 3000.0n 0.7105 3249.9n 0.7105 3250.0n 0.5366 3499.9n 0.5366 3500.0n 0.4858 3749.9n 0.4858 3750.0n 0.5728 3999.9n 0.5728 4000.0n 0.6380 4249.9n 0.6380 4250.0n 0.3699 4499.9n 0.3699 4500.0n 0.2829 4749.9n 0.2829 4750.0n 0.5221 4999.9n 0.5221 5000.0n 0.3844 5249.9n 0.3844 5250.0n 0.5511 5499.9n 0.5511 5500.0n 0.3699 5749.9n 0.3699 5750.0n 0.5221 5999.9n 0.5221 6000.0n 0.6598 6249.9n 0.6598 6250.0n 0.5583 6499.9n 0.5583 6500.0n 0.4931 6749.9n 0.4931 6750.0n 0.3771 6999.9n 0.3771 7000.0n 0.3916 7249.9n 0.3916 7250.0n 0.3844 7499.9n 0.3844 7500.0n 0.5076 7749.9n 0.5076 7750.0n 0.3191 7999.9n 0.3191 8000.0n 0.3989 8249.9n 0.3989 8250.0n 0.3409 8499.9n 0.3409 8500.0n 0.2974 8749.9n 0.2974 8750.0n 0.6453 8999.9n 0.6453 9000.0n 0.3699 9249.9n 0.3699 9250.0n 0.7105 9499.9n 0.7105 9500.0n 0.4206 9749.9n 0.4206 9750.0n 0.4206 9999.9n 0.4206 10000.0n 0.3046 10249.9n 0.3046 10250.0n 0.3409 10499.9n 0.3409 10500.0n 0.7105 10749.9n 0.7105 10750.0n 0.5366 10999.9n 0.5366 11000.0n 0.4858 11249.9n 0.4858 11250.0n 0.5728 11499.9n 0.5728 11500.0n 0.6380 11749.9n 0.6380 11750.0n 0.3699 11999.9n 0.3699 12000.0n 0.2829 12249.9n 0.2829 12250.0n 0.5221 12499.9n 0.5221 12500.0n 0.3844 12749.9n 0.3844 12750.0n 0.5511 12999.9n 0.5511 13000.0n 0.3699 13249.9n 0.3699 13250.0n 0.5221 13499.9n 0.5221 13500.0n 0.6598 13749.9n 0.6598 13750.0n 0.5583 13999.9n 0.5583 14000.0n 0.4931 14249.9n 0.4931 14250.0n 0.3771 14499.9n 0.3771 14500.0n 0.3916 14749.9n 0.3916 14750.0n 0.3844 14999.9n 0.3844 15000.0n 0.5076 15249.9n 0.5076 15250.0n 0.3191 15499.9n 0.3191 15500.0n 0.3989 15749.9n 0.3989 15750.0n 0.3409 15999.9n 0.3409 16000.0n 0.2974 16249.9n 0.2974 16250.0n 0.6453 16499.9n 0.6453 16500.0n 0.3699 16749.9n 0.3699 16750.0n 0.7105 16999.9n 0.7105 17000.0n 0.4206 17249.9n 0.4206 17250.0n 0.4206 17499.9n 0.4206 17500.0n 0.3046 17749.9n 0.3046 17750.0n 0.3409 17999.9n 0.3409 18000.0n 0.7105 18249.9n 0.7105 18250.0n 0.5366 18499.9n 0.5366 18500.0n 0.4858 18749.9n 0.4858 18750.0n 0.5728 18999.9n 0.5728 19000.0n 0.6380 19249.9n 0.6380 19250.0n 0.3699 19499.9n 0.3699 19500.0n 0.2829 19749.9n 0.2829 19750.0n 0.5221 19999.9n 0.5221 20000.0n 0.3844 20249.9n 0.3844 20250.0n 0.5511 20499.9n 0.5511 20500.0n 0.3699 20749.9n 0.3699 20750.0n 0.5221 20999.9n 0.5221 21000.0n 0.6598 21249.9n 0.6598 21250.0n 0.5583 21499.9n 0.5583 21500.0n 0.4931 21749.9n 0.4931 21750.0n 0.3771 21999.9n 0.3771 22000.0n 0.3916 22249.9n 0.3916 22250.0n 0.3844 22499.9n 0.3844 22500.0n 0.5076 22749.9n 0.5076 22750.0n 0.3191 22999.9n 0.3191 23000.0n 0.3989 23249.9n 0.3989 23250.0n 0.3409 23499.9n 0.3409 23500.0n 0.2974 23749.9n 0.2974 23750.0n 0.6453 23999.9n 0.6453 24000.0n 0.3699 24249.9n 0.3699 24250.0n 0.7105 24499.9n 0.7105 24500.0n 0.4206 24749.9n 0.4206 24750.0n 0.4206 24999.9n 0.4206 25000.0n 0.3046 25249.9n 0.3046 25250.0n 0.3409 25499.9n 0.3409 25500.0n 0.7105 25749.9n 0.7105 25750.0n 0.5366 25999.9n 0.5366 26000.0n 0.4858 26249.9n 0.4858 26250.0n 0.5728 26499.9n 0.5728 26500.0n 0.6380 26749.9n 0.6380 26750.0n 0.3699 26999.9n 0.3699 27000.0n 0.2829 27249.9n 0.2829 27250.0n 0.5221 27499.9n 0.5221 27500.0n 0.3844 27749.9n 0.3844 27750.0n 0.5511 27999.9n 0.5511 28000.0n 0.3699 28249.9n 0.3699 28250.0n 0.5221 28499.9n 0.5221 28500.0n 0.6598 28749.9n 0.6598 28750.0n 0.5583 28999.9n 0.5583 29000.0n 0.4931 29249.9n 0.4931 29250.0n 0.3771 29499.9n 0.3771 29500.0n 0.3916 29749.9n 0.3916 29750.0n 0.3844 29999.9n 0.3844 30000.0n 0.5076 30249.9n 0.5076 30250.0n 0.3191 30499.9n 0.3191 30500.0n 0.3989 30749.9n 0.3989 30750.0n 0.3409 30999.9n 0.3409 31000.0n 0.2974 31249.9n 0.2974 31250.0n 0.6453 31499.9n 0.6453 31500.0n 0.3699 31749.9n 0.3699 31750.0n 0.7105 31999.9n 0.7105 32000.0n 0.4206 32249.9n 0.4206 32250.0n 0.4206 32499.9n 0.4206 32500.0n 0.3046 32749.9n 0.3046 32750.0n 0.3409 32999.9n 0.3409 33000.0n 0.7105 33249.9n 0.7105 33250.0n 0.5366 33499.9n 0.5366 33500.0n 0.4858 33749.9n 0.4858 33750.0n 0.5728 33999.9n 0.5728 34000.0n 0.6380 34249.9n 0.6380 34250.0n 0.3699 34499.9n 0.3699 34500.0n 0.2829 34749.9n 0.2829 34750.0n 0.5221 34999.9n 0.5221 35000.0n 0.3844 35249.9n 0.3844 35250.0n 0.5511 35499.9n 0.5511 35500.0n 0.3699 35749.9n 0.3699 35750.0n 0.5221 35999.9n 0.5221 36000.0n 0.6598 36249.9n 0.6598 36250.0n 0.5583 36499.9n 0.5583 36500.0n 0.4931 36749.9n 0.4931 36750.0n 0.3771 36999.9n 0.3771 37000.0n 0.3916 37249.9n 0.3916 37250.0n 0.3844 37499.9n 0.3844 37500.0n 0.5076 37749.9n 0.5076 37750.0n 0.3191 37999.9n 0.3191 38000.0n 0.3989 38249.9n 0.3989 38250.0n 0.3409 38499.9n 0.3409 38500.0n 0.2974 38749.9n 0.2974 38750.0n 0.6453 38999.9n 0.6453 39000.0n 0.3699 39249.9n 0.3699 39250.0n 0.7105 39499.9n 0.7105 39500.0n 0.4206 39749.9n 0.4206 39750.0n 0.4206 39999.9n 0.4206 40000.0n 0.3046 40249.9n 0.3046 40250.0n 0.3409 40499.9n 0.3409 40500.0n 0.7105 40749.9n 0.7105 40750.0n 0.5366 40999.9n 0.5366 41000.0n 0.4858 41249.9n 0.4858 41250.0n 0.5728 41499.9n 0.5728 41500.0n 0.6380 41749.9n 0.6380 41750.0n 0.3699 41999.9n 0.3699 42000.0n 0.2829 42249.9n 0.2829 42250.0n 0.5221 42499.9n 0.5221 42500.0n 0.3844 42749.9n 0.3844 42750.0n 0.5511 42999.9n 0.5511 43000.0n 0.3699 43249.9n 0.3699 43250.0n 0.5221 43499.9n 0.5221 43500.0n 0.6598 43749.9n 0.6598 43750.0n 0.5583 43999.9n 0.5583 44000.0n 0.4931 44249.9n 0.4931 44250.0n 0.3771 44499.9n 0.3771 44500.0n 0.3916 44749.9n 0.3916 44750.0n 0.3844 44999.9n 0.3844 45000.0n 0.5076 45249.9n 0.5076 45250.0n 0.3191 45499.9n 0.3191 45500.0n 0.3989 45749.9n 0.3989 45750.0n 0.3409 45999.9n 0.3409 46000.0n 0.2974 46249.9n 0.2974 46250.0n 0.6453 46499.9n 0.6453 46500.0n 0.3699 46749.9n 0.3699 46750.0n 0.7105 46999.9n 0.7105 47000.0n 0.4206 47249.9n 0.4206 47250.0n 0.4206 47499.9n 0.4206 47500.0n 0.3046 47749.9n 0.3046 47750.0n 0.3409 47999.9n 0.3409 48000.0n 0.7105 48249.9n 0.7105 48250.0n 0.5366 48499.9n 0.5366 48500.0n 0.4858 48749.9n 0.4858 48750.0n 0.5728 48999.9n 0.5728 49000.0n 0.6380 49249.9n 0.6380 49250.0n 0.3699 49499.9n 0.3699 49500.0n 0.2829 49749.9n 0.2829 49750.0n 0.5221 49999.9n 0.5221 50000.0n 0.3844 50249.9n 0.3844 50250.0n 0.5511 50499.9n 0.5511 50500.0n 0.3699 50749.9n 0.3699 50750.0n 0.5221 50999.9n 0.5221 51000.0n 0.6598 51249.9n 0.6598 51250.0n 0.5583 51499.9n 0.5583 51500.0n 0.4931 51749.9n 0.4931 51750.0n 0.3771 51999.9n 0.3771 52000.0n 0.3916 52249.9n 0.3916 52250.0n 0.3844 52499.9n 0.3844 52500.0n 0.5076 52749.9n 0.5076 52750.0n 0.3191 52999.9n 0.3191 53000.0n 0.3989 53249.9n 0.3989 53250.0n 0.3409 53499.9n 0.3409 53500.0n 0.2974 53749.9n 0.2974 53750.0n 0.6453 53999.9n 0.6453 54000.0n 0.3699 54249.9n 0.3699 54250.0n 0.7105 54499.9n 0.7105 54500.0n 0.4206 54749.9n 0.4206 54750.0n 0.4206 54999.9n 0.4206 55000.0n 0.3046 55249.9n 0.3046 55250.0n 0.3409 55499.9n 0.3409 55500.0n 0.7105 55749.9n 0.7105 55750.0n 0.5366 55999.9n 0.5366 56000.0n 0.4858 56249.9n 0.4858 56250.0n 0.5728 56499.9n 0.5728 56500.0n 0.6380 56749.9n 0.6380 56750.0n 0.3699 56999.9n 0.3699 57000.0n 0.2829 57249.9n 0.2829 57250.0n 0.5221 57499.9n 0.5221 57500.0n 0.3844 57749.9n 0.3844 57750.0n 0.5511 57999.9n 0.5511 58000.0n 0.3699 58249.9n 0.3699 58250.0n 0.5221 58499.9n 0.5221 58500.0n 0.6598 58749.9n 0.6598 58750.0n 0.5583 58999.9n 0.5583 59000.0n 0.4931 59249.9n 0.4931 59250.0n 0.3771 59499.9n 0.3771 59500.0n 0.3916 59749.9n 0.3916 59750.0n 0.3844 59999.9n 0.3844 60000.0n 0.5076 60249.9n 0.5076 60250.0n 0.3191 60499.9n 0.3191 60500.0n 0.3989 60749.9n 0.3989 60750.0n 0.3409 60999.9n 0.3409 61000.0n 0.2974 61249.9n 0.2974 61250.0n 0.6453 61499.9n 0.6453 61500.0n 0.3699 61749.9n 0.3699 61750.0n 0.7105 61999.9n 0.7105 62000.0n 0.4206 62249.9n 0.4206 62250.0n 0.4206 62499.9n 0.4206 62500.0n 0.3046 62749.9n 0.3046 62750.0n 0.3409 62999.9n 0.3409 63000.0n 0.7105 63249.9n 0.7105 63250.0n 0.5366 63499.9n 0.5366 63500.0n 0.4858 63749.9n 0.4858 63750.0n 0.5728 63999.9n 0.5728 64000.0n 0.6380 64249.9n 0.6380 64250.0n 0.3699 64499.9n 0.3699 64500.0n 0.2829 64749.9n 0.2829 64750.0n 0.5221 64999.9n 0.5221 65000.0n 0.3844 65249.9n 0.3844 65250.0n 0.5511 65499.9n 0.5511 65500.0n 0.3699 65749.9n 0.3699 65750.0n 0.5221 65999.9n 0.5221 66000.0n 0.6598 66249.9n 0.6598 66250.0n 0.5583 66499.9n 0.5583 66500.0n 0.4931 66749.9n 0.4931 66750.0n 0.3771 66999.9n 0.3771 67000.0n 0.3916 67249.9n 0.3916 67250.0n 0.3844 67499.9n 0.3844 67500.0n 0.5076 67749.9n 0.5076 67750.0n 0.3191 67999.9n 0.3191 68000.0n 0.3989 68249.9n 0.3989 68250.0n 0.3409 68499.9n 0.3409 68500.0n 0.2974 68749.9n 0.2974 68750.0n 0.6453 68999.9n 0.6453 69000.0n 0.3699 69249.9n 0.3699 69250.0n 0.7105 69499.9n 0.7105 69500.0n 0.4206 69749.9n 0.4206 69750.0n 0.4206 69999.9n 0.4206 70000.0n 0.3046 70249.9n 0.3046 70250.0n 0.3409 70499.9n 0.3409 70500.0n 0.7105 70749.9n 0.7105 70750.0n 0.5366 70999.9n 0.5366 71000.0n 0.4858 71249.9n 0.4858 71250.0n 0.5728 71499.9n 0.5728 71500.0n 0.6380 71749.9n 0.6380 71750.0n 0.3699 71999.9n 0.3699 72000.0n 0.2829 72249.9n 0.2829 72250.0n 0.5221 72499.9n 0.5221 72500.0n 0.3844 72749.9n 0.3844 72750.0n 0.5511 72999.9n 0.5511 73000.0n 0.3699 73249.9n 0.3699 73250.0n 0.5221 73499.9n 0.5221 73500.0n 0.6598 73749.9n 0.6598 73750.0n 0.5583 73999.9n 0.5583 74000.0n 0.4931 74249.9n 0.4931 74250.0n 0.3771 74499.9n 0.3771 74500.0n 0.3916 74749.9n 0.3916 74750.0n 0.3844 74999.9n 0.3844 75000.0n 0.5076 75249.9n 0.5076 75250.0n 0.3191 75499.9n 0.3191 75500.0n 0.3989 75749.9n 0.3989 75750.0n 0.3409 75999.9n 0.3409 76000.0n 0.2974 76249.9n 0.2974 76250.0n 0.6453 76499.9n 0.6453 76500.0n 0.3699 76749.9n 0.3699 76750.0n 0.7105 76999.9n 0.7105 77000.0n 0.4206 77249.9n 0.4206 77250.0n 0.4206 77499.9n 0.4206 77500.0n 0.3046 77749.9n 0.3046 77750.0n 0.3409 77999.9n 0.3409 78000.0n 0.7105 78249.9n 0.7105 78250.0n 0.5366 78499.9n 0.5366 78500.0n 0.4858 78749.9n 0.4858 78750.0n 0.5728 78999.9n 0.5728 79000.0n 0.6380 79249.9n 0.6380 79250.0n 0.3699 79499.9n 0.3699 79500.0n 0.2829 79749.9n 0.2829 79750.0n 0.5221 79999.9n 0.5221 80000.0n 0.3844 80249.9n 0.3844 80250.0n 0.5511 80499.9n 0.5511 80500.0n 0.3699 80749.9n 0.3699 80750.0n 0.5221 80999.9n 0.5221 81000.0n 0.6598 81249.9n 0.6598 81250.0n 0.5583 81499.9n 0.5583 81500.0n 0.4931 81749.9n 0.4931 81750.0n 0.3771 81999.9n 0.3771 82000.0n 0.3916 82249.9n 0.3916 82250.0n 0.3844 82499.9n 0.3844 82500.0n 0.5076 82749.9n 0.5076 82750.0n 0.3191 82999.9n 0.3191 83000.0n 0.3989 83249.9n 0.3989 83250.0n 0.3409 83499.9n 0.3409 83500.0n 0.2974 83749.9n 0.2974 83750.0n 0.6453 83999.9n 0.6453 84000.0n 0.3699 84249.9n 0.3699 84250.0n 0.7105 84499.9n 0.7105 84500.0n 0.4206 84749.9n 0.4206 84750.0n 0.4206 84999.9n 0.4206 85000.0n 0.3046 85249.9n 0.3046 85250.0n 0.3409 85499.9n 0.3409 85500.0n 0.7105 85749.9n 0.7105 85750.0n 0.5366 85999.9n 0.5366 86000.0n 0.4858 86249.9n 0.4858 86250.0n 0.5728 86499.9n 0.5728 86500.0n 0.6380 86749.9n 0.6380 86750.0n 0.3699 86999.9n 0.3699 87000.0n 0.2829 87249.9n 0.2829 87250.0n 0.5221 87499.9n 0.5221 87500.0n 0.3844 87749.9n 0.3844 87750.0n 0.5511 87999.9n 0.5511 88000.0n 0.3699 88249.9n 0.3699 88250.0n 0.5221 88499.9n 0.5221 88500.0n 0.6598 88749.9n 0.6598 88750.0n 0.5583 88999.9n 0.5583 89000.0n 0.4931 89249.9n 0.4931 89250.0n 0.3771 89499.9n 0.3771 89500.0n 0.3916 89749.9n 0.3916 89750.0n 0.3844 89999.9n 0.3844 90000.0n 0.5076 90249.9n 0.5076 90250.0n 0.3191 90499.9n 0.3191 90500.0n 0.3989 90749.9n 0.3989 90750.0n 0.3409 90999.9n 0.3409 91000.0n 0.2974 91249.9n 0.2974 91250.0n 0.6453 91499.9n 0.6453 91500.0n 0.3699 91749.9n 0.3699 91750.0n 0.7105 91999.9n 0.7105 92000.0n 0.4206 92249.9n 0.4206 92250.0n 0.4206 92499.9n 0.4206 92500.0n 0.3046 92749.9n 0.3046 92750.0n 0.3409 92999.9n 0.3409 93000.0n 0.7105 93249.9n 0.7105 93250.0n 0.5366 93499.9n 0.5366 93500.0n 0.4858 93749.9n 0.4858 93750.0n 0.5728 93999.9n 0.5728 94000.0n 0.6380 94249.9n 0.6380 94250.0n 0.3699 94499.9n 0.3699 94500.0n 0.2829 94749.9n 0.2829 94750.0n 0.5221 94999.9n 0.5221 95000.0n 0.3844 95249.9n 0.3844 95250.0n 0.5511 95499.9n 0.5511 95500.0n 0.3699 95749.9n 0.3699 95750.0n 0.5221 95999.9n 0.5221 96000.0n 0.6598 96249.9n 0.6598 96250.0n 0.5583 96499.9n 0.5583 96500.0n 0.4931 96749.9n 0.4931 96750.0n 0.3771 96999.9n 0.3771 97000.0n 0.3916 97249.9n 0.3916 97250.0n 0.3844 97499.9n 0.3844 97500.0n 0.5076 97749.9n 0.5076 97750.0n 0.3191 97999.9n 0.3191 98000.0n 0.3989 98249.9n 0.3989 98250.0n 0.3409 98499.9n 0.3409 98500.0n 0.2974 98749.9n 0.2974 98750.0n 0.6453 98999.9n 0.6453 99000.0n 0.3699 99249.9n 0.3699 99250.0n 0.7105 99499.9n 0.7105 99500.0n 0.4206 99749.9n 0.4206 99750.0n 0.4206 99999.9n 0.4206 100000.0n 0.3046 100249.9n 0.3046 100250.0n 0.3409 100499.9n 0.3409 100500.0n 0.7105 100749.9n 0.7105 100750.0n 0.5366 100999.9n 0.5366 101000.0n 0.4858 101249.9n 0.4858 101250.0n 0.5728 101499.9n 0.5728 101500.0n 0.6380 101749.9n 0.6380 101750.0n 0.3699 101999.9n 0.3699 102000.0n 0.2829 102249.9n 0.2829 102250.0n 0.5221 102499.9n 0.5221 102500.0n 0.3844 102749.9n 0.3844 102750.0n 0.5511 102999.9n 0.5511 103000.0n 0.3699 103249.9n 0.3699 103250.0n 0.5221 103499.9n 0.5221 103500.0n 0.6598 103749.9n 0.6598 103750.0n 0.5583 103999.9n 0.5583 104000.0n 0.4931 104249.9n 0.4931 104250.0n 0.3771 104499.9n 0.3771 104500.0n 0.3916 104749.9n 0.3916 104750.0n 0.3844 104999.9n 0.3844 105000.0n 0.5076 105249.9n 0.5076 105250.0n 0.3191 105499.9n 0.3191 105500.0n 0.3989 105749.9n 0.3989 105750.0n 0.3409 105999.9n 0.3409 106000.0n 0.2974 106249.9n 0.2974 106250.0n 0.6453 106499.9n 0.6453 106500.0n 0.3699 106749.9n 0.3699 106750.0n 0.7105 106999.9n 0.7105 107000.0n 0.4206 107249.9n 0.4206 107250.0n 0.4206 107499.9n 0.4206 107500.0n 0.3046 107749.9n 0.3046 107750.0n 0.3409 107999.9n 0.3409 108000.0n 0.7105 108249.9n 0.7105 108250.0n 0.5366 108499.9n 0.5366 108500.0n 0.4858 108749.9n 0.4858 108750.0n 0.5728 108999.9n 0.5728 109000.0n 0.6380 109249.9n 0.6380 109250.0n 0.3699 109499.9n 0.3699 109500.0n 0.2829 109749.9n 0.2829 109750.0n 0.5221 109999.9n 0.5221 110000.0n 0.3844 110249.9n 0.3844 110250.0n 0.5511 110499.9n 0.5511 110500.0n 0.3699 110749.9n 0.3699 110750.0n 0.5221 110999.9n 0.5221 111000.0n 0.6598 111249.9n 0.6598 111250.0n 0.5583 111499.9n 0.5583 111500.0n 0.4931 111749.9n 0.4931 111750.0n 0.3771 111999.9n 0.3771 112000.0n 0.3916 112249.9n 0.3916 112250.0n 0.3844 112499.9n 0.3844 112500.0n 0.5076 112749.9n 0.5076 112750.0n 0.3191 112999.9n 0.3191 113000.0n 0.3989 113249.9n 0.3989 113250.0n 0.3409 113499.9n 0.3409 113500.0n 0.2974 113749.9n 0.2974 113750.0n 0.6453 113999.9n 0.6453 114000.0n 0.3699 114249.9n 0.3699 114250.0n 0.7105 114499.9n 0.7105 114500.0n 0.4206 114749.9n 0.4206 114750.0n 0.4206 114999.9n 0.4206 115000.0n 0.3046 115249.9n 0.3046 115250.0n 0.3409 115499.9n 0.3409 115500.0n 0.7105 115749.9n 0.7105 115750.0n 0.5366 115999.9n 0.5366 116000.0n 0.4858 116249.9n 0.4858 116250.0n 0.5728 116499.9n 0.5728 116500.0n 0.6380 116749.9n 0.6380 116750.0n 0.3699 116999.9n 0.3699 117000.0n 0.2829 117249.9n 0.2829 117250.0n 0.5221 117499.9n 0.5221 117500.0n 0.3844 117749.9n 0.3844 117750.0n 0.5511 117999.9n 0.5511 118000.0n 0.3699 118249.9n 0.3699 118250.0n 0.5221 118499.9n 0.5221 118500.0n 0.6598 118749.9n 0.6598 118750.0n 0.5583 118999.9n 0.5583 119000.0n 0.4931 119249.9n 0.4931 119250.0n 0.3771 119499.9n 0.3771 119500.0n 0.3916 119749.9n 0.3916 119750.0n 0.3844 119999.9n 0.3844 120000.0n 0.5076 120249.9n 0.5076 120250.0n 0.3191 120499.9n 0.3191 120500.0n 0.3989 120749.9n 0.3989 120750.0n 0.3409 120999.9n 0.3409 121000.0n 0.2974 121249.9n 0.2974 121250.0n 0.6453 121499.9n 0.6453 121500.0n 0.3699 121749.9n 0.3699 121750.0n 0.7105 121999.9n 0.7105 122000.0n 0.4206 122249.9n 0.4206 122250.0n 0.4206 122499.9n 0.4206 122500.0n 0.3046 122749.9n 0.3046 122750.0n 0.3409 122999.9n 0.3409 123000.0n 0.7105 123249.9n 0.7105 123250.0n 0.5366 123499.9n 0.5366 123500.0n 0.4858 123749.9n 0.4858 123750.0n 0.5728 123999.9n 0.5728 124000.0n 0.6380 124249.9n 0.6380 124250.0n 0.3699 124499.9n 0.3699 124500.0n 0.2829 124749.9n 0.2829 124750.0n 0.5221 124999.9n 0.5221 125000.0n 0.3844 125249.9n 0.3844 125250.0n 0.5511 125499.9n 0.5511 125500.0n 0.3699 125749.9n 0.3699 125750.0n 0.5221 125999.9n 0.5221 126000.0n 0.6598 126249.9n 0.6598 126250.0n 0.5583 126499.9n 0.5583 126500.0n 0.4931 126749.9n 0.4931 126750.0n 0.3771 126999.9n 0.3771 127000.0n 0.3916 127249.9n 0.3916 127250.0n 0.3844 127499.9n 0.3844 127500.0n 0.5076 127749.9n 0.5076 127750.0n 0.3191 127999.9n 0.3191 128000.0n 0.3989 128249.9n 0.3989 128250.0n 0.3409 128499.9n 0.3409 128500.0n 0.2974 128749.9n 0.2974 128750.0n 0.6453 128999.9n 0.6453 129000.0n 0.3699 129249.9n 0.3699 129250.0n 0.7105 129499.9n 0.7105 129500.0n 0.4206 129749.9n 0.4206 129750.0n 0.4206 129999.9n 0.4206 130000.0n 0.3046 130249.9n 0.3046 130250.0n 0.3409 130499.9n 0.3409 130500.0n 0.7105 130749.9n 0.7105 130750.0n 0.5366 130999.9n 0.5366 131000.0n 0.4858 131249.9n 0.4858 131250.0n 0.5728 131499.9n 0.5728 131500.0n 0.6380 131749.9n 0.6380 131750.0n 0.3699 131999.9n 0.3699 132000.0n 0.2829 132249.9n 0.2829 132250.0n 0.5221 132499.9n 0.5221 132500.0n 0.3844 132749.9n 0.3844 132750.0n 0.5511 132999.9n 0.5511 133000.0n 0.3699 133249.9n 0.3699 133250.0n 0.5221 133499.9n 0.5221 133500.0n 0.6598 133749.9n 0.6598 133750.0n 0.5583 133999.9n 0.5583 134000.0n 0.4931 134249.9n 0.4931 134250.0n 0.3771 134499.9n 0.3771 134500.0n 0.3916 134749.9n 0.3916 134750.0n 0.3844 134999.9n 0.3844 135000.0n 0.5076 135249.9n 0.5076 135250.0n 0.3191 135499.9n 0.3191 135500.0n 0.3989 135749.9n 0.3989 135750.0n 0.3409 135999.9n 0.3409 136000.0n 0.2974 136249.9n 0.2974 136250.0n 0.6453 136499.9n 0.6453 136500.0n 0.3699 136749.9n 0.3699 136750.0n 0.7105 136999.9n 0.7105 137000.0n 0.4206 137249.9n 0.4206 137250.0n 0.4206 137499.9n 0.4206 137500.0n 0.3046 137749.9n 0.3046 137750.0n 0.3409 137999.9n 0.3409 138000.0n 0.7105 138249.9n 0.7105 138250.0n 0.5366 138499.9n 0.5366 138500.0n 0.4858 138749.9n 0.4858 138750.0n 0.5728 138999.9n 0.5728 139000.0n 0.6380 139249.9n 0.6380 139250.0n 0.3699 139499.9n 0.3699 139500.0n 0.2829 139749.9n 0.2829 139750.0n 0.5221 139999.9n 0.5221 140000.0n 0.3844 140249.9n 0.3844 140250.0n 0.5511 140499.9n 0.5511 140500.0n 0.3699 140749.9n 0.3699 140750.0n 0.5221 140999.9n 0.5221 141000.0n 0.6598 141249.9n 0.6598 141250.0n 0.5583 141499.9n 0.5583 141500.0n 0.4931 141749.9n 0.4931 141750.0n 0.3771 141999.9n 0.3771 142000.0n 0.3916 142249.9n 0.3916 142250.0n 0.3844 142499.9n 0.3844 142500.0n 0.5076 142749.9n 0.5076 142750.0n 0.3191 142999.9n 0.3191 143000.0n 0.3989 143249.9n 0.3989 143250.0n 0.3409 143499.9n 0.3409 143500.0n 0.2974 143749.9n 0.2974 143750.0n 0.6453 143999.9n 0.6453 144000.0n 0.3699 144249.9n 0.3699 144250.0n 0.7105 144499.9n 0.7105 144500.0n 0.4206 144749.9n 0.4206 144750.0n 0.4206 144999.9n 0.4206 145000.0n 0.3046 145249.9n 0.3046 145250.0n 0.3409 145499.9n 0.3409 145500.0n 0.7105 145749.9n 0.7105 145750.0n 0.5366 145999.9n 0.5366 146000.0n 0.4858 146249.9n 0.4858 146250.0n 0.5728 146499.9n 0.5728 146500.0n 0.6380 146749.9n 0.6380 146750.0n 0.3699 146999.9n 0.3699 147000.0n 0.2829 147249.9n 0.2829 147250.0n 0.5221 147499.9n 0.5221 147500.0n 0.3844 147749.9n 0.3844 147750.0n 0.5511 147999.9n 0.5511 148000.0n 0.3699 148249.9n 0.3699 148250.0n 0.5221 148499.9n 0.5221 148500.0n 0.6598 148749.9n 0.6598 148750.0n 0.5583 148999.9n 0.5583 149000.0n 0.4931 149249.9n 0.4931 149250.0n 0.3771 149499.9n 0.3771 149500.0n 0.3916 149749.9n 0.3916 149750.0n 0.3844 149999.9n 0.3844 150000.0n 0.5076 150249.9n 0.5076 150250.0n 0.3191 150499.9n 0.3191 150500.0n 0.3989 150749.9n 0.3989 150750.0n 0.3409 150999.9n 0.3409 151000.0n 0.2974 151249.9n 0.2974 151250.0n 0.6453 151499.9n 0.6453 151500.0n 0.3699 151749.9n 0.3699 151750.0n 0.7105 151999.9n 0.7105 152000.0n 0.4206 152249.9n 0.4206 152250.0n 0.4206 152499.9n 0.4206 152500.0n 0.3046 152749.9n 0.3046 152750.0n 0.3409 152999.9n 0.3409 153000.0n 0.7105 153249.9n 0.7105 153250.0n 0.5366 153499.9n 0.5366 153500.0n 0.4858 153749.9n 0.4858 153750.0n 0.5728 153999.9n 0.5728 154000.0n 0.6380 154249.9n 0.6380 154250.0n 0.3699 154499.9n 0.3699 154500.0n 0.2829 154749.9n 0.2829 154750.0n 0.5221 154999.9n 0.5221 155000.0n 0.3844 155249.9n 0.3844 155250.0n 0.5511 155499.9n 0.5511 155500.0n 0.3699 155749.9n 0.3699 155750.0n 0.5221 155999.9n 0.5221 156000.0n 0.6598 156249.9n 0.6598 156250.0n 0.5583 156499.9n 0.5583 156500.0n 0.4931 156749.9n 0.4931 156750.0n 0.3771 156999.9n 0.3771 157000.0n 0.3916 157249.9n 0.3916 157250.0n 0.3844 157499.9n 0.3844 157500.0n 0.5076 157749.9n 0.5076 157750.0n 0.3191 157999.9n 0.3191 158000.0n 0.3989 158249.9n 0.3989 158250.0n 0.3409 158499.9n 0.3409 158500.0n 0.2974 158749.9n 0.2974 158750.0n 0.6453 158999.9n 0.6453 159000.0n 0.3699 159249.9n 0.3699 159250.0n 0.7105 159499.9n 0.7105 159500.0n 0.4206 159749.9n 0.4206 159750.0n 0.4206 159999.9n 0.4206 160000.0n 0.3046 160249.9n 0.3046 160250.0n 0.3409 160499.9n 0.3409 160500.0n 0.7105 160749.9n 0.7105 160750.0n 0.5366 160999.9n 0.5366 161000.0n 0.4858 161249.9n 0.4858 161250.0n 0.5728 161499.9n 0.5728 161500.0n 0.6380 161749.9n 0.6380 161750.0n 0.3699 161999.9n 0.3699 162000.0n 0.2829 162249.9n 0.2829 162250.0n 0.5221 162499.9n 0.5221 162500.0n 0.3844 162749.9n 0.3844 162750.0n 0.5511 162999.9n 0.5511 163000.0n 0.3699 163249.9n 0.3699 163250.0n 0.5221 163499.9n 0.5221 163500.0n 0.6598 163749.9n 0.6598 163750.0n 0.5583 163999.9n 0.5583 164000.0n 0.4931 164249.9n 0.4931 164250.0n 0.3771 164499.9n 0.3771 164500.0n 0.3916 164749.9n 0.3916 164750.0n 0.3844 164999.9n 0.3844 165000.0n 0.5076 165249.9n 0.5076 165250.0n 0.3191 165499.9n 0.3191 165500.0n 0.3989 165749.9n 0.3989 165750.0n 0.3409 165999.9n 0.3409 166000.0n 0.2974 166249.9n 0.2974 166250.0n 0.6453 166499.9n 0.6453 166500.0n 0.3699 166749.9n 0.3699 166750.0n 0.7105 166999.9n 0.7105 167000.0n 0.4206 167249.9n 0.4206 167250.0n 0.4206 167499.9n 0.4206 167500.0n 0.3046 167749.9n 0.3046 167750.0n 0.3409 167999.9n 0.3409 168000.0n 0.7105 168249.9n 0.7105 168250.0n 0.5366 168499.9n 0.5366 168500.0n 0.4858 168749.9n 0.4858 168750.0n 0.5728 168999.9n 0.5728 169000.0n 0.6380 169249.9n 0.6380 169250.0n 0.3699 169499.9n 0.3699 169500.0n 0.2829 169749.9n 0.2829 169750.0n 0.5221 169999.9n 0.5221 170000.0n 0.3844 170249.9n 0.3844 170250.0n 0.5511 170499.9n 0.5511 170500.0n 0.3699 170749.9n 0.3699 170750.0n 0.5221 170999.9n 0.5221 171000.0n 0.6598 171249.9n 0.6598 171250.0n 0.5583 171499.9n 0.5583 171500.0n 0.4931 171749.9n 0.4931 171750.0n 0.3771 171999.9n 0.3771 172000.0n 0.3916 172249.9n 0.3916 172250.0n 0.3844 172499.9n 0.3844 172500.0n 0.5076 172749.9n 0.5076 172750.0n 0.3191 172999.9n 0.3191 173000.0n 0.3989 173249.9n 0.3989 173250.0n 0.3409 173499.9n 0.3409 173500.0n 0.2974 173749.9n 0.2974 173750.0n 0.6453 173999.9n 0.6453 174000.0n 0.3699 174249.9n 0.3699 174250.0n 0.7105 174499.9n 0.7105 174500.0n 0.4206 174749.9n 0.4206 174750.0n 0.4206 174999.9n 0.4206 175000.0n 0.3046 175249.9n 0.3046 175250.0n 0.3409 175499.9n 0.3409 175500.0n 0.7105 175749.9n 0.7105 175750.0n 0.5366 175999.9n 0.5366 176000.0n 0.4858 176249.9n 0.4858 176250.0n 0.5728 176499.9n 0.5728 176500.0n 0.6380 176749.9n 0.6380 176750.0n 0.3699 176999.9n 0.3699 177000.0n 0.2829 177249.9n 0.2829 177250.0n 0.5221 177499.9n 0.5221 177500.0n 0.3844 177749.9n 0.3844 177750.0n 0.5511 177999.9n 0.5511 178000.0n 0.3699 178249.9n 0.3699 178250.0n 0.5221 178499.9n 0.5221 178500.0n 0.6598 178749.9n 0.6598 178750.0n 0.5583 178999.9n 0.5583 179000.0n 0.4931 179249.9n 0.4931 179250.0n 0.3771 179499.9n 0.3771 179500.0n 0.3916 179749.9n 0.3916 179750.0n 0.3844 179999.9n 0.3844 180000.0n 0.5076 180249.9n 0.5076 180250.0n 0.3191 180499.9n 0.3191 180500.0n 0.3989 180749.9n 0.3989 180750.0n 0.3409 180999.9n 0.3409 181000.0n 0.2974 181249.9n 0.2974 181250.0n 0.6453 181499.9n 0.6453 181500.0n 0.3699 181749.9n 0.3699 181750.0n 0.7105 181999.9n 0.7105 182000.0n 0.4206 182249.9n 0.4206 182250.0n 0.4206 182499.9n 0.4206 182500.0n 0.3046 182749.9n 0.3046 182750.0n 0.3409 182999.9n 0.3409 183000.0n 0.7105 183249.9n 0.7105 183250.0n 0.5366 183499.9n 0.5366 183500.0n 0.4858 183749.9n 0.4858 183750.0n 0.5728 183999.9n 0.5728 184000.0n 0.6380 184249.9n 0.6380 184250.0n 0.3699 184499.9n 0.3699 184500.0n 0.2829 184749.9n 0.2829 184750.0n 0.5221 184999.9n 0.5221 185000.0n 0.3844 185249.9n 0.3844 185250.0n 0.5511 185499.9n 0.5511 185500.0n 0.3699 185749.9n 0.3699 185750.0n 0.5221 185999.9n 0.5221 186000.0n 0.6598 186249.9n 0.6598 186250.0n 0.5583 186499.9n 0.5583 186500.0n 0.4931 186749.9n 0.4931 186750.0n 0.3771 186999.9n 0.3771 187000.0n 0.3916 187249.9n 0.3916 187250.0n 0.3844 187499.9n 0.3844 187500.0n 0.5076 187749.9n 0.5076 187750.0n 0.3191 187999.9n 0.3191 188000.0n 0.3989 188249.9n 0.3989 188250.0n 0.3409 188499.9n 0.3409 188500.0n 0.2974 188749.9n 0.2974 188750.0n 0.6453 188999.9n 0.6453 189000.0n 0.3699 189249.9n 0.3699 189250.0n 0.7105 189499.9n 0.7105 189500.0n 0.4206 189749.9n 0.4206 189750.0n 0.4206 189999.9n 0.4206 190000.0n 0.3046 190249.9n 0.3046 190250.0n 0.3409 190499.9n 0.3409 190500.0n 0.7105 190749.9n 0.7105 190750.0n 0.5366 190999.9n 0.5366 191000.0n 0.4858 191249.9n 0.4858 191250.0n 0.5728 191499.9n 0.5728 191500.0n 0.6380 191749.9n 0.6380 191750.0n 0.3699 191999.9n 0.3699 192000.0n 0.2829 192249.9n 0.2829 192250.0n 0.5221 192499.9n 0.5221 192500.0n 0.3844 192749.9n 0.3844 192750.0n 0.5511 192999.9n 0.5511 193000.0n 0.3699 193249.9n 0.3699 193250.0n 0.5221 193499.9n 0.5221 193500.0n 0.6598 193749.9n 0.6598 193750.0n 0.5583 193999.9n 0.5583 194000.0n 0.4931 194249.9n 0.4931 194250.0n 0.3771 194499.9n 0.3771 194500.0n 0.3916 194749.9n 0.3916 194750.0n 0.3844 194999.9n 0.3844 195000.0n 0.5076 195249.9n 0.5076 195250.0n 0.3191 195499.9n 0.3191 195500.0n 0.3989 195749.9n 0.3989 195750.0n 0.3409 195999.9n 0.3409 196000.0n 0.2974 196249.9n 0.2974 196250.0n 0.6453 196499.9n 0.6453 196500.0n 0.3699 196749.9n 0.3699 196750.0n 0.7105 196999.9n 0.7105 197000.0n 0.4206 197249.9n 0.4206 197250.0n 0.4206 197499.9n 0.4206 197500.0n 0.3046 197749.9n 0.3046 197750.0n 0.3409 197999.9n 0.3409 198000.0n 0.7105 198249.9n 0.7105 198250.0n 0.5366 198499.9n 0.5366 198500.0n 0.4858 198749.9n 0.4858 198750.0n 0.5728 198999.9n 0.5728 199000.0n 0.6380 199249.9n 0.6380 199250.0n 0.3699 199499.9n 0.3699 199500.0n 0.2829 199749.9n 0.2829 199750.0n 0.5221 199999.9n 0.5221 200000.0n 0.3844 200249.9n 0.3844 200250.0n 0.5511 200499.9n 0.5511 200500.0n 0.3699 200749.9n 0.3699 200750.0n 0.5221 200999.9n 0.5221 201000.0n 0.6598 201249.9n 0.6598 201250.0n 0.5583 201499.9n 0.5583 201500.0n 0.4931 201749.9n 0.4931 201750.0n 0.3771 201999.9n 0.3771 202000.0n 0.3916 202249.9n 0.3916 202250.0n 0.3844 202499.9n 0.3844 202500.0n 0.5076 202749.9n 0.5076 202750.0n 0.3191 202999.9n 0.3191 203000.0n 0.3989 203249.9n 0.3989 203250.0n 0.3409 203499.9n 0.3409 203500.0n 0.2974 203749.9n 0.2974 203750.0n 0.6453 203999.9n 0.6453 204000.0n 0.3699 204249.9n 0.3699 204250.0n 0.7105 204499.9n 0.7105 204500.0n 0.4206 204749.9n 0.4206 204750.0n 0.4206 204999.9n 0.4206 205000.0n 0.3046 205249.9n 0.3046 205250.0n 0.3409 205499.9n 0.3409 205500.0n 0.7105 205749.9n 0.7105 205750.0n 0.5366 205999.9n 0.5366 206000.0n 0.4858 206249.9n 0.4858 206250.0n 0.5728 206499.9n 0.5728 206500.0n 0.6380 206749.9n 0.6380 206750.0n 0.3699 206999.9n 0.3699 207000.0n 0.2829 207249.9n 0.2829 207250.0n 0.5221 207499.9n 0.5221 207500.0n 0.3844 207749.9n 0.3844 207750.0n 0.5511 207999.9n 0.5511 208000.0n 0.3699 208249.9n 0.3699 208250.0n 0.5221 208499.9n 0.5221 208500.0n 0.6598 208749.9n 0.6598 208750.0n 0.5583 208999.9n 0.5583 209000.0n 0.4931 209249.9n 0.4931 209250.0n 0.3771 209499.9n 0.3771 209500.0n 0.3916 209749.9n 0.3916 209750.0n 0.3844 209999.9n 0.3844 210000.0n 0.5076 210249.9n 0.5076 210250.0n 0.3191 210499.9n 0.3191 210500.0n 0.3989 210749.9n 0.3989 210750.0n 0.3409 210999.9n 0.3409 211000.0n 0.2974 211249.9n 0.2974 211250.0n 0.6453 211499.9n 0.6453 211500.0n 0.3699 211749.9n 0.3699 211750.0n 0.7105 211999.9n 0.7105 212000.0n 0.4206 212249.9n 0.4206 212250.0n 0.4206 212499.9n 0.4206 212500.0n 0.3046 212749.9n 0.3046 212750.0n 0.3409 212999.9n 0.3409 213000.0n 0.7105 213249.9n 0.7105 213250.0n 0.5366 213499.9n 0.5366 213500.0n 0.4858 213749.9n 0.4858 213750.0n 0.5728 213999.9n 0.5728 214000.0n 0.6380 214249.9n 0.6380 214250.0n 0.3699 214499.9n 0.3699 214500.0n 0.2829 214749.9n 0.2829 214750.0n 0.5221 214999.9n 0.5221 215000.0n 0.3844 215249.9n 0.3844 215250.0n 0.5511 215499.9n 0.5511 215500.0n 0.3699 215749.9n 0.3699 215750.0n 0.5221 215999.9n 0.5221 216000.0n 0.6598 216249.9n 0.6598 216250.0n 0.5583 216499.9n 0.5583 216500.0n 0.4931 216749.9n 0.4931 216750.0n 0.3771 216999.9n 0.3771 217000.0n 0.3916 217249.9n 0.3916 217250.0n 0.3844 217499.9n 0.3844 217500.0n 0.5076 217749.9n 0.5076 217750.0n 0.3191 217999.9n 0.3191 218000.0n 0.3989 218249.9n 0.3989 218250.0n 0.3409 218499.9n 0.3409 218500.0n 0.2974 218749.9n 0.2974 218750.0n 0.6453 218999.9n 0.6453 219000.0n 0.3699 219249.9n 0.3699 219250.0n 0.7105 219499.9n 0.7105 219500.0n 0.4206 219749.9n 0.4206 219750.0n 0.4206 219999.9n 0.4206 220000.0n 0.3046 220249.9n 0.3046 220250.0n 0.3409 220499.9n 0.3409 220500.0n 0.7105 220749.9n 0.7105 220750.0n 0.5366 220999.9n 0.5366 221000.0n 0.4858 221249.9n 0.4858 221250.0n 0.5728 221499.9n 0.5728 221500.0n 0.6380 221749.9n 0.6380 221750.0n 0.3699 221999.9n 0.3699 222000.0n 0.2829 222249.9n 0.2829 222250.0n 0.5221 222499.9n 0.5221 222500.0n 0.3844 222749.9n 0.3844 222750.0n 0.5511 222999.9n 0.5511 223000.0n 0.3699 223249.9n 0.3699 223250.0n 0.5221 223499.9n 0.5221 223500.0n 0.6598 223749.9n 0.6598 223750.0n 0.5583 223999.9n 0.5583 224000.0n 0.4931 224249.9n 0.4931 224250.0n 0.3771 224499.9n 0.3771 224500.0n 0.3916 224749.9n 0.3916 224750.0n 0.3844 224999.9n 0.3844 225000.0n 0.5076 225249.9n 0.5076 225250.0n 0.3191 225499.9n 0.3191 225500.0n 0.3989 225749.9n 0.3989 225750.0n 0.3409 225999.9n 0.3409 226000.0n 0.2974 226249.9n 0.2974 226250.0n 0.6453 226499.9n 0.6453 226500.0n 0.3699 226749.9n 0.3699 226750.0n 0.7105 226999.9n 0.7105 227000.0n 0.4206 227249.9n 0.4206 227250.0n 0.4206 227499.9n 0.4206 227500.0n 0.3046 227749.9n 0.3046 227750.0n 0.3409 227999.9n 0.3409 228000.0n 0.7105 228249.9n 0.7105 228250.0n 0.5366 228499.9n 0.5366 228500.0n 0.4858 228749.9n 0.4858 228750.0n 0.5728 228999.9n 0.5728 229000.0n 0.6380 229249.9n 0.6380 229250.0n 0.3699 229499.9n 0.3699 229500.0n 0.2829 229749.9n 0.2829 229750.0n 0.5221 229999.9n 0.5221 230000.0n 0.3844 230249.9n 0.3844 230250.0n 0.5511 230499.9n 0.5511 230500.0n 0.3699 230749.9n 0.3699 230750.0n 0.5221 230999.9n 0.5221 231000.0n 0.6598 231249.9n 0.6598 231250.0n 0.5583 231499.9n 0.5583 231500.0n 0.4931 231749.9n 0.4931 231750.0n 0.3771 231999.9n 0.3771 232000.0n 0.3916 232249.9n 0.3916 232250.0n 0.3844 232499.9n 0.3844 232500.0n 0.5076 232749.9n 0.5076 232750.0n 0.3191 232999.9n 0.3191 233000.0n 0.3989 233249.9n 0.3989 233250.0n 0.3409 233499.9n 0.3409 233500.0n 0.2974 233749.9n 0.2974 233750.0n 0.6453 233999.9n 0.6453 234000.0n 0.3699 234249.9n 0.3699 234250.0n 0.7105 234499.9n 0.7105 234500.0n 0.4206 234749.9n 0.4206 234750.0n 0.4206 234999.9n 0.4206 235000.0n 0.3046 235249.9n 0.3046 235250.0n 0.3409 235499.9n 0.3409 235500.0n 0.7105 235749.9n 0.7105 235750.0n 0.5366 235999.9n 0.5366 236000.0n 0.4858 236249.9n 0.4858 236250.0n 0.5728 236499.9n 0.5728 236500.0n 0.6380 236749.9n 0.6380 236750.0n 0.3699 236999.9n 0.3699 237000.0n 0.2829 237249.9n 0.2829 237250.0n 0.5221 237499.9n 0.5221 237500.0n 0.3844 237749.9n 0.3844 237750.0n 0.5511 237999.9n 0.5511 238000.0n 0.3699 238249.9n 0.3699 238250.0n 0.5221 238499.9n 0.5221 238500.0n 0.6598 238749.9n 0.6598 238750.0n 0.5583 238999.9n 0.5583 239000.0n 0.4931 239249.9n 0.4931 239250.0n 0.3771 239499.9n 0.3771 239500.0n 0.3916 239749.9n 0.3916 239750.0n 0.3844 239999.9n 0.3844 240000.0n 0.5076 240249.9n 0.5076 240250.0n 0.3191 240499.9n 0.3191 240500.0n 0.3989 240749.9n 0.3989 240750.0n 0.3409 240999.9n 0.3409 241000.0n 0.2974 241249.9n 0.2974 241250.0n 0.6453 241499.9n 0.6453 241500.0n 0.3699 241749.9n 0.3699 241750.0n 0.7105 241999.9n 0.7105 242000.0n 0.4206 242249.9n 0.4206 242250.0n 0.4206 242499.9n 0.4206 242500.0n 0.3046 242749.9n 0.3046 242750.0n 0.3409 242999.9n 0.3409 243000.0n 0.7105 243249.9n 0.7105 243250.0n 0.5366 243499.9n 0.5366 243500.0n 0.4858 243749.9n 0.4858 243750.0n 0.5728 243999.9n 0.5728 244000.0n 0.6380 244249.9n 0.6380 244250.0n 0.3699 244499.9n 0.3699 244500.0n 0.2829 244749.9n 0.2829 244750.0n 0.5221 244999.9n 0.5221 245000.0n 0.3844 245249.9n 0.3844 245250.0n 0.5511 245499.9n 0.5511 245500.0n 0.3699 245749.9n 0.3699 245750.0n 0.5221 245999.9n 0.5221 246000.0n 0.6598 246249.9n 0.6598 246250.0n 0.5583 246499.9n 0.5583 246500.0n 0.4931 246749.9n 0.4931 246750.0n 0.3771 246999.9n 0.3771 247000.0n 0.3916 247249.9n 0.3916 247250.0n 0.3844 247499.9n 0.3844 247500.0n 0.5076 247749.9n 0.5076 247750.0n 0.3191 247999.9n 0.3191 248000.0n 0.3989 248249.9n 0.3989 248250.0n 0.3409 248499.9n 0.3409 248500.0n 0.2974 248749.9n 0.2974 248750.0n 0.6453 248999.9n 0.6453 249000.0n 0.3699 249249.9n 0.3699 249250.0n 0.7105 249499.9n 0.7105 249500.0n 0.4206 249749.9n 0.4206 249750.0n 0.4206 249999.9n 0.4206 250000.0n 0.3046 250249.9n 0.3046 250250.0n 0.3409 250499.9n 0.3409 250500.0n 0.7105 250749.9n 0.7105 250750.0n 0.5366 250999.9n 0.5366 251000.0n 0.4858 251249.9n 0.4858 251250.0n 0.5728 251499.9n 0.5728 251500.0n 0.6380 251749.9n 0.6380 251750.0n 0.3699 251999.9n 0.3699 252000.0n 0.2829 252249.9n 0.2829 252250.0n 0.5221 252499.9n 0.5221 252500.0n 0.3844 252749.9n 0.3844 252750.0n 0.5511 252999.9n 0.5511 253000.0n 0.3699 253249.9n 0.3699 253250.0n 0.5221 253499.9n 0.5221 253500.0n 0.6598 253749.9n 0.6598 253750.0n 0.5583 253999.9n 0.5583 254000.0n 0.4931 254249.9n 0.4931 254250.0n 0.3771 254499.9n 0.3771 254500.0n 0.3916 254749.9n 0.3916 254750.0n 0.3844 254999.9n 0.3844 255000.0n 0.5076 255249.9n 0.5076 255250.0n 0.3191 255499.9n 0.3191 255500.0n 0.3989 255749.9n 0.3989 255750.0n 0.3409 255999.9n 0.3409 256000.0n 0.2974 256249.9n 0.2974 256250.0n 0.6453 256499.9n 0.6453 256500.0n 0.3699 256749.9n 0.3699 256750.0n 0.7105 256999.9n 0.7105 257000.0n 0.4206 257249.9n 0.4206 257250.0n 0.4206 257499.9n 0.4206 257500.0n 0.3046 257749.9n 0.3046 257750.0n 0.3409 257999.9n 0.3409 258000.0n 0.7105 258249.9n 0.7105 258250.0n 0.5366 258499.9n 0.5366 258500.0n 0.4858 258749.9n 0.4858 258750.0n 0.5728 258999.9n 0.5728 259000.0n 0.6380 259249.9n 0.6380 259250.0n 0.3699 259499.9n 0.3699 259500.0n 0.2829 259749.9n 0.2829 259750.0n 0.5221 259999.9n 0.5221 260000.0n 0.3844 260249.9n 0.3844 260250.0n 0.5511 260499.9n 0.5511 260500.0n 0.3699 260749.9n 0.3699 260750.0n 0.5221 260999.9n 0.5221 261000.0n 0.6598 261249.9n 0.6598 261250.0n 0.5583 261499.9n 0.5583 261500.0n 0.4931 261749.9n 0.4931 261750.0n 0.3771 261999.9n 0.3771 262000.0n 0.3916 262249.9n 0.3916 262250.0n 0.3844 262499.9n 0.3844 262500.0n 0.5076 262749.9n 0.5076 262750.0n 0.3191 262999.9n 0.3191 263000.0n 0.3989 263249.9n 0.3989 263250.0n 0.3409 263499.9n 0.3409 263500.0n 0.2974 263749.9n 0.2974 263750.0n 0.6453 263999.9n 0.6453 264000.0n 0.3699 264249.9n 0.3699 264250.0n 0.7105 264499.9n 0.7105 264500.0n 0.4206 264749.9n 0.4206 264750.0n 0.4206 264999.9n 0.4206 265000.0n 0.3046 265249.9n 0.3046 265250.0n 0.3409 265499.9n 0.3409 265500.0n 0.7105 265749.9n 0.7105 265750.0n 0.5366 265999.9n 0.5366 266000.0n 0.4858 266249.9n 0.4858 266250.0n 0.5728 266499.9n 0.5728 266500.0n 0.6380 266749.9n 0.6380 266750.0n 0.3699 266999.9n 0.3699 267000.0n 0.2829 267249.9n 0.2829 267250.0n 0.5221 267499.9n 0.5221 267500.0n 0.3844 267749.9n 0.3844 267750.0n 0.5511 267999.9n 0.5511 268000.0n 0.3699 268249.9n 0.3699 268250.0n 0.5221 268499.9n 0.5221 268500.0n 0.6598 268749.9n 0.6598 268750.0n 0.5583 268999.9n 0.5583 269000.0n 0.4931 269249.9n 0.4931 269250.0n 0.3771 269499.9n 0.3771 269500.0n 0.3916 269749.9n 0.3916 269750.0n 0.3844 269999.9n 0.3844 270000.0n 0.5076 270249.9n 0.5076 270250.0n 0.3191 270499.9n 0.3191 270500.0n 0.3989 270749.9n 0.3989 270750.0n 0.3409 270999.9n 0.3409 271000.0n 0.2974 271249.9n 0.2974 271250.0n 0.6453 271499.9n 0.6453 271500.0n 0.3699 271749.9n 0.3699 271750.0n 0.7105 271999.9n 0.7105 272000.0n 0.4206 272249.9n 0.4206 272250.0n 0.4206 272499.9n 0.4206 272500.0n 0.3046 272749.9n 0.3046 272750.0n 0.3409 272999.9n 0.3409 273000.0n 0.7105 273249.9n 0.7105 273250.0n 0.5366 273499.9n 0.5366 273500.0n 0.4858 273749.9n 0.4858 273750.0n 0.5728 273999.9n 0.5728 274000.0n 0.6380 274249.9n 0.6380 274250.0n 0.3699 274499.9n 0.3699 274500.0n 0.2829 274749.9n 0.2829 274750.0n 0.5221 274999.9n 0.5221 275000.0n 0.3844 275249.9n 0.3844 275250.0n 0.5511 275499.9n 0.5511 275500.0n 0.3699 275749.9n 0.3699 275750.0n 0.5221 275999.9n 0.5221 276000.0n 0.6598 276249.9n 0.6598 276250.0n 0.5583 276499.9n 0.5583 276500.0n 0.4931 276749.9n 0.4931 276750.0n 0.3771 276999.9n 0.3771 277000.0n 0.3916 277249.9n 0.3916 277250.0n 0.3844 277499.9n 0.3844 277500.0n 0.5076 277749.9n 0.5076 277750.0n 0.3191 277999.9n 0.3191 278000.0n 0.3989 278249.9n 0.3989 278250.0n 0.3409 278499.9n 0.3409 278500.0n 0.2974 278749.9n 0.2974 278750.0n 0.6453 278999.9n 0.6453 279000.0n 0.3699 279249.9n 0.3699 279250.0n 0.7105 279499.9n 0.7105 279500.0n 0.4206 279749.9n 0.4206 279750.0n 0.4206 279999.9n 0.4206 280000.0n 0.3046 280249.9n 0.3046 280250.0n 0.3409 280499.9n 0.3409 280500.0n 0.7105 280749.9n 0.7105 280750.0n 0.5366 280999.9n 0.5366 281000.0n 0.4858 281249.9n 0.4858 281250.0n 0.5728 281499.9n 0.5728 281500.0n 0.6380 281749.9n 0.6380 281750.0n 0.3699 281999.9n 0.3699 282000.0n 0.2829 282249.9n 0.2829 282250.0n 0.5221 282499.9n 0.5221 282500.0n 0.3844 282749.9n 0.3844 282750.0n 0.5511 282999.9n 0.5511 283000.0n 0.3699 283249.9n 0.3699 283250.0n 0.5221 283499.9n 0.5221 283500.0n 0.6598 283749.9n 0.6598 283750.0n 0.5583 283999.9n 0.5583 284000.0n 0.4931 284249.9n 0.4931 284250.0n 0.3771 284499.9n 0.3771 284500.0n 0.3916 284749.9n 0.3916 284750.0n 0.3844 284999.9n 0.3844 285000.0n 0.5076 285249.9n 0.5076 285250.0n 0.3191 285499.9n 0.3191 285500.0n 0.3989 285749.9n 0.3989 285750.0n 0.3409 285999.9n 0.3409 286000.0n 0.2974 286249.9n 0.2974 286250.0n 0.6453 286499.9n 0.6453 286500.0n 0.3699 286749.9n 0.3699 286750.0n 0.7105 286999.9n 0.7105 287000.0n 0.4206 287249.9n 0.4206 287250.0n 0.4206 287499.9n 0.4206 287500.0n 0.3046 287749.9n 0.3046 287750.0n 0.3409 287999.9n 0.3409 288000.0n 0.7105 288249.9n 0.7105 288250.0n 0.5366 288499.9n 0.5366 288500.0n 0.4858 288749.9n 0.4858 288750.0n 0.5728 288999.9n 0.5728 289000.0n 0.6380 289249.9n 0.6380 289250.0n 0.3699 289499.9n 0.3699 289500.0n 0.2829 289749.9n 0.2829 289750.0n 0.5221 289999.9n 0.5221 290000.0n 0.3844 290249.9n 0.3844 290250.0n 0.5511 290499.9n 0.5511 290500.0n 0.3699 290749.9n 0.3699 290750.0n 0.5221 290999.9n 0.5221 291000.0n 0.6598 291249.9n 0.6598 291250.0n 0.5583 291499.9n 0.5583 291500.0n 0.4931 291749.9n 0.4931 291750.0n 0.3771 291999.9n 0.3771 292000.0n 0.3916 292249.9n 0.3916 292250.0n 0.3844 292499.9n 0.3844 292500.0n 0.5076 292749.9n 0.5076 292750.0n 0.3191 292999.9n 0.3191 293000.0n 0.3989 293249.9n 0.3989 293250.0n 0.3409 293499.9n 0.3409 293500.0n 0.2974 293749.9n 0.2974 293750.0n 0.6453 293999.9n 0.6453 294000.0n 0.3699 294249.9n 0.3699 294250.0n 0.7105 294499.9n 0.7105 294500.0n 0.4206 294749.9n 0.4206 294750.0n 0.4206 294999.9n 0.4206 295000.0n 0.3046 295249.9n 0.3046 295250.0n 0.3409 295499.9n 0.3409 295500.0n 0.7105 295749.9n 0.7105 295750.0n 0.5366 295999.9n 0.5366 296000.0n 0.4858 296249.9n 0.4858 296250.0n 0.5728 296499.9n 0.5728 296500.0n 0.6380 296749.9n 0.6380 296750.0n 0.3699 296999.9n 0.3699 297000.0n 0.2829 297249.9n 0.2829 297250.0n 0.5221 297499.9n 0.5221 297500.0n 0.3844 297749.9n 0.3844 297750.0n 0.5511 297999.9n 0.5511 298000.0n 0.3699 298249.9n 0.3699 298250.0n 0.5221 298499.9n 0.5221 298500.0n 0.6598 298749.9n 0.6598 298750.0n 0.5583 298999.9n 0.5583 299000.0n 0.4931 299249.9n 0.4931 299250.0n 0.3771 299499.9n 0.3771 299500.0n 0.3916 299749.9n 0.3916 299750.0n 0.3844)
Vxn10 a_xn10 0 PWL(0.0n 0.4924 249.9n 0.4924 250.0n 0.6809 499.9n 0.6809 500.0n 0.6011 749.9n 0.6011 750.0n 0.6591 999.9n 0.6591 1000.0n 0.7026 1249.9n 0.7026 1250.0n 0.3547 1499.9n 0.3547 1500.0n 0.6301 1749.9n 0.6301 1750.0n 0.2895 1999.9n 0.2895 2000.0n 0.5794 2249.9n 0.5794 2250.0n 0.5794 2499.9n 0.5794 2500.0n 0.6954 2749.9n 0.6954 2750.0n 0.6591 2999.9n 0.6591 3000.0n 0.2895 3249.9n 0.2895 3250.0n 0.4634 3499.9n 0.4634 3500.0n 0.5142 3749.9n 0.5142 3750.0n 0.4272 3999.9n 0.4272 4000.0n 0.3620 4249.9n 0.3620 4250.0n 0.6301 4499.9n 0.6301 4500.0n 0.7171 4749.9n 0.7171 4750.0n 0.4779 4999.9n 0.4779 5000.0n 0.6156 5249.9n 0.6156 5250.0n 0.4489 5499.9n 0.4489 5500.0n 0.6301 5749.9n 0.6301 5750.0n 0.4779 5999.9n 0.4779 6000.0n 0.3402 6249.9n 0.3402 6250.0n 0.4417 6499.9n 0.4417 6500.0n 0.5069 6749.9n 0.5069 6750.0n 0.6229 6999.9n 0.6229 7000.0n 0.6084 7249.9n 0.6084 7250.0n 0.6156 7499.9n 0.6156 7500.0n 0.4924 7749.9n 0.4924 7750.0n 0.6809 7999.9n 0.6809 8000.0n 0.6011 8249.9n 0.6011 8250.0n 0.6591 8499.9n 0.6591 8500.0n 0.7026 8749.9n 0.7026 8750.0n 0.3547 8999.9n 0.3547 9000.0n 0.6301 9249.9n 0.6301 9250.0n 0.2895 9499.9n 0.2895 9500.0n 0.5794 9749.9n 0.5794 9750.0n 0.5794 9999.9n 0.5794 10000.0n 0.6954 10249.9n 0.6954 10250.0n 0.6591 10499.9n 0.6591 10500.0n 0.2895 10749.9n 0.2895 10750.0n 0.4634 10999.9n 0.4634 11000.0n 0.5142 11249.9n 0.5142 11250.0n 0.4272 11499.9n 0.4272 11500.0n 0.3620 11749.9n 0.3620 11750.0n 0.6301 11999.9n 0.6301 12000.0n 0.7171 12249.9n 0.7171 12250.0n 0.4779 12499.9n 0.4779 12500.0n 0.6156 12749.9n 0.6156 12750.0n 0.4489 12999.9n 0.4489 13000.0n 0.6301 13249.9n 0.6301 13250.0n 0.4779 13499.9n 0.4779 13500.0n 0.3402 13749.9n 0.3402 13750.0n 0.4417 13999.9n 0.4417 14000.0n 0.5069 14249.9n 0.5069 14250.0n 0.6229 14499.9n 0.6229 14500.0n 0.6084 14749.9n 0.6084 14750.0n 0.6156 14999.9n 0.6156 15000.0n 0.4924 15249.9n 0.4924 15250.0n 0.6809 15499.9n 0.6809 15500.0n 0.6011 15749.9n 0.6011 15750.0n 0.6591 15999.9n 0.6591 16000.0n 0.7026 16249.9n 0.7026 16250.0n 0.3547 16499.9n 0.3547 16500.0n 0.6301 16749.9n 0.6301 16750.0n 0.2895 16999.9n 0.2895 17000.0n 0.5794 17249.9n 0.5794 17250.0n 0.5794 17499.9n 0.5794 17500.0n 0.6954 17749.9n 0.6954 17750.0n 0.6591 17999.9n 0.6591 18000.0n 0.2895 18249.9n 0.2895 18250.0n 0.4634 18499.9n 0.4634 18500.0n 0.5142 18749.9n 0.5142 18750.0n 0.4272 18999.9n 0.4272 19000.0n 0.3620 19249.9n 0.3620 19250.0n 0.6301 19499.9n 0.6301 19500.0n 0.7171 19749.9n 0.7171 19750.0n 0.4779 19999.9n 0.4779 20000.0n 0.6156 20249.9n 0.6156 20250.0n 0.4489 20499.9n 0.4489 20500.0n 0.6301 20749.9n 0.6301 20750.0n 0.4779 20999.9n 0.4779 21000.0n 0.3402 21249.9n 0.3402 21250.0n 0.4417 21499.9n 0.4417 21500.0n 0.5069 21749.9n 0.5069 21750.0n 0.6229 21999.9n 0.6229 22000.0n 0.6084 22249.9n 0.6084 22250.0n 0.6156 22499.9n 0.6156 22500.0n 0.4924 22749.9n 0.4924 22750.0n 0.6809 22999.9n 0.6809 23000.0n 0.6011 23249.9n 0.6011 23250.0n 0.6591 23499.9n 0.6591 23500.0n 0.7026 23749.9n 0.7026 23750.0n 0.3547 23999.9n 0.3547 24000.0n 0.6301 24249.9n 0.6301 24250.0n 0.2895 24499.9n 0.2895 24500.0n 0.5794 24749.9n 0.5794 24750.0n 0.5794 24999.9n 0.5794 25000.0n 0.6954 25249.9n 0.6954 25250.0n 0.6591 25499.9n 0.6591 25500.0n 0.2895 25749.9n 0.2895 25750.0n 0.4634 25999.9n 0.4634 26000.0n 0.5142 26249.9n 0.5142 26250.0n 0.4272 26499.9n 0.4272 26500.0n 0.3620 26749.9n 0.3620 26750.0n 0.6301 26999.9n 0.6301 27000.0n 0.7171 27249.9n 0.7171 27250.0n 0.4779 27499.9n 0.4779 27500.0n 0.6156 27749.9n 0.6156 27750.0n 0.4489 27999.9n 0.4489 28000.0n 0.6301 28249.9n 0.6301 28250.0n 0.4779 28499.9n 0.4779 28500.0n 0.3402 28749.9n 0.3402 28750.0n 0.4417 28999.9n 0.4417 29000.0n 0.5069 29249.9n 0.5069 29250.0n 0.6229 29499.9n 0.6229 29500.0n 0.6084 29749.9n 0.6084 29750.0n 0.6156 29999.9n 0.6156 30000.0n 0.4924 30249.9n 0.4924 30250.0n 0.6809 30499.9n 0.6809 30500.0n 0.6011 30749.9n 0.6011 30750.0n 0.6591 30999.9n 0.6591 31000.0n 0.7026 31249.9n 0.7026 31250.0n 0.3547 31499.9n 0.3547 31500.0n 0.6301 31749.9n 0.6301 31750.0n 0.2895 31999.9n 0.2895 32000.0n 0.5794 32249.9n 0.5794 32250.0n 0.5794 32499.9n 0.5794 32500.0n 0.6954 32749.9n 0.6954 32750.0n 0.6591 32999.9n 0.6591 33000.0n 0.2895 33249.9n 0.2895 33250.0n 0.4634 33499.9n 0.4634 33500.0n 0.5142 33749.9n 0.5142 33750.0n 0.4272 33999.9n 0.4272 34000.0n 0.3620 34249.9n 0.3620 34250.0n 0.6301 34499.9n 0.6301 34500.0n 0.7171 34749.9n 0.7171 34750.0n 0.4779 34999.9n 0.4779 35000.0n 0.6156 35249.9n 0.6156 35250.0n 0.4489 35499.9n 0.4489 35500.0n 0.6301 35749.9n 0.6301 35750.0n 0.4779 35999.9n 0.4779 36000.0n 0.3402 36249.9n 0.3402 36250.0n 0.4417 36499.9n 0.4417 36500.0n 0.5069 36749.9n 0.5069 36750.0n 0.6229 36999.9n 0.6229 37000.0n 0.6084 37249.9n 0.6084 37250.0n 0.6156 37499.9n 0.6156 37500.0n 0.4924 37749.9n 0.4924 37750.0n 0.6809 37999.9n 0.6809 38000.0n 0.6011 38249.9n 0.6011 38250.0n 0.6591 38499.9n 0.6591 38500.0n 0.7026 38749.9n 0.7026 38750.0n 0.3547 38999.9n 0.3547 39000.0n 0.6301 39249.9n 0.6301 39250.0n 0.2895 39499.9n 0.2895 39500.0n 0.5794 39749.9n 0.5794 39750.0n 0.5794 39999.9n 0.5794 40000.0n 0.6954 40249.9n 0.6954 40250.0n 0.6591 40499.9n 0.6591 40500.0n 0.2895 40749.9n 0.2895 40750.0n 0.4634 40999.9n 0.4634 41000.0n 0.5142 41249.9n 0.5142 41250.0n 0.4272 41499.9n 0.4272 41500.0n 0.3620 41749.9n 0.3620 41750.0n 0.6301 41999.9n 0.6301 42000.0n 0.7171 42249.9n 0.7171 42250.0n 0.4779 42499.9n 0.4779 42500.0n 0.6156 42749.9n 0.6156 42750.0n 0.4489 42999.9n 0.4489 43000.0n 0.6301 43249.9n 0.6301 43250.0n 0.4779 43499.9n 0.4779 43500.0n 0.3402 43749.9n 0.3402 43750.0n 0.4417 43999.9n 0.4417 44000.0n 0.5069 44249.9n 0.5069 44250.0n 0.6229 44499.9n 0.6229 44500.0n 0.6084 44749.9n 0.6084 44750.0n 0.6156 44999.9n 0.6156 45000.0n 0.4924 45249.9n 0.4924 45250.0n 0.6809 45499.9n 0.6809 45500.0n 0.6011 45749.9n 0.6011 45750.0n 0.6591 45999.9n 0.6591 46000.0n 0.7026 46249.9n 0.7026 46250.0n 0.3547 46499.9n 0.3547 46500.0n 0.6301 46749.9n 0.6301 46750.0n 0.2895 46999.9n 0.2895 47000.0n 0.5794 47249.9n 0.5794 47250.0n 0.5794 47499.9n 0.5794 47500.0n 0.6954 47749.9n 0.6954 47750.0n 0.6591 47999.9n 0.6591 48000.0n 0.2895 48249.9n 0.2895 48250.0n 0.4634 48499.9n 0.4634 48500.0n 0.5142 48749.9n 0.5142 48750.0n 0.4272 48999.9n 0.4272 49000.0n 0.3620 49249.9n 0.3620 49250.0n 0.6301 49499.9n 0.6301 49500.0n 0.7171 49749.9n 0.7171 49750.0n 0.4779 49999.9n 0.4779 50000.0n 0.6156 50249.9n 0.6156 50250.0n 0.4489 50499.9n 0.4489 50500.0n 0.6301 50749.9n 0.6301 50750.0n 0.4779 50999.9n 0.4779 51000.0n 0.3402 51249.9n 0.3402 51250.0n 0.4417 51499.9n 0.4417 51500.0n 0.5069 51749.9n 0.5069 51750.0n 0.6229 51999.9n 0.6229 52000.0n 0.6084 52249.9n 0.6084 52250.0n 0.6156 52499.9n 0.6156 52500.0n 0.4924 52749.9n 0.4924 52750.0n 0.6809 52999.9n 0.6809 53000.0n 0.6011 53249.9n 0.6011 53250.0n 0.6591 53499.9n 0.6591 53500.0n 0.7026 53749.9n 0.7026 53750.0n 0.3547 53999.9n 0.3547 54000.0n 0.6301 54249.9n 0.6301 54250.0n 0.2895 54499.9n 0.2895 54500.0n 0.5794 54749.9n 0.5794 54750.0n 0.5794 54999.9n 0.5794 55000.0n 0.6954 55249.9n 0.6954 55250.0n 0.6591 55499.9n 0.6591 55500.0n 0.2895 55749.9n 0.2895 55750.0n 0.4634 55999.9n 0.4634 56000.0n 0.5142 56249.9n 0.5142 56250.0n 0.4272 56499.9n 0.4272 56500.0n 0.3620 56749.9n 0.3620 56750.0n 0.6301 56999.9n 0.6301 57000.0n 0.7171 57249.9n 0.7171 57250.0n 0.4779 57499.9n 0.4779 57500.0n 0.6156 57749.9n 0.6156 57750.0n 0.4489 57999.9n 0.4489 58000.0n 0.6301 58249.9n 0.6301 58250.0n 0.4779 58499.9n 0.4779 58500.0n 0.3402 58749.9n 0.3402 58750.0n 0.4417 58999.9n 0.4417 59000.0n 0.5069 59249.9n 0.5069 59250.0n 0.6229 59499.9n 0.6229 59500.0n 0.6084 59749.9n 0.6084 59750.0n 0.6156 59999.9n 0.6156 60000.0n 0.4924 60249.9n 0.4924 60250.0n 0.6809 60499.9n 0.6809 60500.0n 0.6011 60749.9n 0.6011 60750.0n 0.6591 60999.9n 0.6591 61000.0n 0.7026 61249.9n 0.7026 61250.0n 0.3547 61499.9n 0.3547 61500.0n 0.6301 61749.9n 0.6301 61750.0n 0.2895 61999.9n 0.2895 62000.0n 0.5794 62249.9n 0.5794 62250.0n 0.5794 62499.9n 0.5794 62500.0n 0.6954 62749.9n 0.6954 62750.0n 0.6591 62999.9n 0.6591 63000.0n 0.2895 63249.9n 0.2895 63250.0n 0.4634 63499.9n 0.4634 63500.0n 0.5142 63749.9n 0.5142 63750.0n 0.4272 63999.9n 0.4272 64000.0n 0.3620 64249.9n 0.3620 64250.0n 0.6301 64499.9n 0.6301 64500.0n 0.7171 64749.9n 0.7171 64750.0n 0.4779 64999.9n 0.4779 65000.0n 0.6156 65249.9n 0.6156 65250.0n 0.4489 65499.9n 0.4489 65500.0n 0.6301 65749.9n 0.6301 65750.0n 0.4779 65999.9n 0.4779 66000.0n 0.3402 66249.9n 0.3402 66250.0n 0.4417 66499.9n 0.4417 66500.0n 0.5069 66749.9n 0.5069 66750.0n 0.6229 66999.9n 0.6229 67000.0n 0.6084 67249.9n 0.6084 67250.0n 0.6156 67499.9n 0.6156 67500.0n 0.4924 67749.9n 0.4924 67750.0n 0.6809 67999.9n 0.6809 68000.0n 0.6011 68249.9n 0.6011 68250.0n 0.6591 68499.9n 0.6591 68500.0n 0.7026 68749.9n 0.7026 68750.0n 0.3547 68999.9n 0.3547 69000.0n 0.6301 69249.9n 0.6301 69250.0n 0.2895 69499.9n 0.2895 69500.0n 0.5794 69749.9n 0.5794 69750.0n 0.5794 69999.9n 0.5794 70000.0n 0.6954 70249.9n 0.6954 70250.0n 0.6591 70499.9n 0.6591 70500.0n 0.2895 70749.9n 0.2895 70750.0n 0.4634 70999.9n 0.4634 71000.0n 0.5142 71249.9n 0.5142 71250.0n 0.4272 71499.9n 0.4272 71500.0n 0.3620 71749.9n 0.3620 71750.0n 0.6301 71999.9n 0.6301 72000.0n 0.7171 72249.9n 0.7171 72250.0n 0.4779 72499.9n 0.4779 72500.0n 0.6156 72749.9n 0.6156 72750.0n 0.4489 72999.9n 0.4489 73000.0n 0.6301 73249.9n 0.6301 73250.0n 0.4779 73499.9n 0.4779 73500.0n 0.3402 73749.9n 0.3402 73750.0n 0.4417 73999.9n 0.4417 74000.0n 0.5069 74249.9n 0.5069 74250.0n 0.6229 74499.9n 0.6229 74500.0n 0.6084 74749.9n 0.6084 74750.0n 0.6156 74999.9n 0.6156 75000.0n 0.4924 75249.9n 0.4924 75250.0n 0.6809 75499.9n 0.6809 75500.0n 0.6011 75749.9n 0.6011 75750.0n 0.6591 75999.9n 0.6591 76000.0n 0.7026 76249.9n 0.7026 76250.0n 0.3547 76499.9n 0.3547 76500.0n 0.6301 76749.9n 0.6301 76750.0n 0.2895 76999.9n 0.2895 77000.0n 0.5794 77249.9n 0.5794 77250.0n 0.5794 77499.9n 0.5794 77500.0n 0.6954 77749.9n 0.6954 77750.0n 0.6591 77999.9n 0.6591 78000.0n 0.2895 78249.9n 0.2895 78250.0n 0.4634 78499.9n 0.4634 78500.0n 0.5142 78749.9n 0.5142 78750.0n 0.4272 78999.9n 0.4272 79000.0n 0.3620 79249.9n 0.3620 79250.0n 0.6301 79499.9n 0.6301 79500.0n 0.7171 79749.9n 0.7171 79750.0n 0.4779 79999.9n 0.4779 80000.0n 0.6156 80249.9n 0.6156 80250.0n 0.4489 80499.9n 0.4489 80500.0n 0.6301 80749.9n 0.6301 80750.0n 0.4779 80999.9n 0.4779 81000.0n 0.3402 81249.9n 0.3402 81250.0n 0.4417 81499.9n 0.4417 81500.0n 0.5069 81749.9n 0.5069 81750.0n 0.6229 81999.9n 0.6229 82000.0n 0.6084 82249.9n 0.6084 82250.0n 0.6156 82499.9n 0.6156 82500.0n 0.4924 82749.9n 0.4924 82750.0n 0.6809 82999.9n 0.6809 83000.0n 0.6011 83249.9n 0.6011 83250.0n 0.6591 83499.9n 0.6591 83500.0n 0.7026 83749.9n 0.7026 83750.0n 0.3547 83999.9n 0.3547 84000.0n 0.6301 84249.9n 0.6301 84250.0n 0.2895 84499.9n 0.2895 84500.0n 0.5794 84749.9n 0.5794 84750.0n 0.5794 84999.9n 0.5794 85000.0n 0.6954 85249.9n 0.6954 85250.0n 0.6591 85499.9n 0.6591 85500.0n 0.2895 85749.9n 0.2895 85750.0n 0.4634 85999.9n 0.4634 86000.0n 0.5142 86249.9n 0.5142 86250.0n 0.4272 86499.9n 0.4272 86500.0n 0.3620 86749.9n 0.3620 86750.0n 0.6301 86999.9n 0.6301 87000.0n 0.7171 87249.9n 0.7171 87250.0n 0.4779 87499.9n 0.4779 87500.0n 0.6156 87749.9n 0.6156 87750.0n 0.4489 87999.9n 0.4489 88000.0n 0.6301 88249.9n 0.6301 88250.0n 0.4779 88499.9n 0.4779 88500.0n 0.3402 88749.9n 0.3402 88750.0n 0.4417 88999.9n 0.4417 89000.0n 0.5069 89249.9n 0.5069 89250.0n 0.6229 89499.9n 0.6229 89500.0n 0.6084 89749.9n 0.6084 89750.0n 0.6156 89999.9n 0.6156 90000.0n 0.4924 90249.9n 0.4924 90250.0n 0.6809 90499.9n 0.6809 90500.0n 0.6011 90749.9n 0.6011 90750.0n 0.6591 90999.9n 0.6591 91000.0n 0.7026 91249.9n 0.7026 91250.0n 0.3547 91499.9n 0.3547 91500.0n 0.6301 91749.9n 0.6301 91750.0n 0.2895 91999.9n 0.2895 92000.0n 0.5794 92249.9n 0.5794 92250.0n 0.5794 92499.9n 0.5794 92500.0n 0.6954 92749.9n 0.6954 92750.0n 0.6591 92999.9n 0.6591 93000.0n 0.2895 93249.9n 0.2895 93250.0n 0.4634 93499.9n 0.4634 93500.0n 0.5142 93749.9n 0.5142 93750.0n 0.4272 93999.9n 0.4272 94000.0n 0.3620 94249.9n 0.3620 94250.0n 0.6301 94499.9n 0.6301 94500.0n 0.7171 94749.9n 0.7171 94750.0n 0.4779 94999.9n 0.4779 95000.0n 0.6156 95249.9n 0.6156 95250.0n 0.4489 95499.9n 0.4489 95500.0n 0.6301 95749.9n 0.6301 95750.0n 0.4779 95999.9n 0.4779 96000.0n 0.3402 96249.9n 0.3402 96250.0n 0.4417 96499.9n 0.4417 96500.0n 0.5069 96749.9n 0.5069 96750.0n 0.6229 96999.9n 0.6229 97000.0n 0.6084 97249.9n 0.6084 97250.0n 0.6156 97499.9n 0.6156 97500.0n 0.4924 97749.9n 0.4924 97750.0n 0.6809 97999.9n 0.6809 98000.0n 0.6011 98249.9n 0.6011 98250.0n 0.6591 98499.9n 0.6591 98500.0n 0.7026 98749.9n 0.7026 98750.0n 0.3547 98999.9n 0.3547 99000.0n 0.6301 99249.9n 0.6301 99250.0n 0.2895 99499.9n 0.2895 99500.0n 0.5794 99749.9n 0.5794 99750.0n 0.5794 99999.9n 0.5794 100000.0n 0.6954 100249.9n 0.6954 100250.0n 0.6591 100499.9n 0.6591 100500.0n 0.2895 100749.9n 0.2895 100750.0n 0.4634 100999.9n 0.4634 101000.0n 0.5142 101249.9n 0.5142 101250.0n 0.4272 101499.9n 0.4272 101500.0n 0.3620 101749.9n 0.3620 101750.0n 0.6301 101999.9n 0.6301 102000.0n 0.7171 102249.9n 0.7171 102250.0n 0.4779 102499.9n 0.4779 102500.0n 0.6156 102749.9n 0.6156 102750.0n 0.4489 102999.9n 0.4489 103000.0n 0.6301 103249.9n 0.6301 103250.0n 0.4779 103499.9n 0.4779 103500.0n 0.3402 103749.9n 0.3402 103750.0n 0.4417 103999.9n 0.4417 104000.0n 0.5069 104249.9n 0.5069 104250.0n 0.6229 104499.9n 0.6229 104500.0n 0.6084 104749.9n 0.6084 104750.0n 0.6156 104999.9n 0.6156 105000.0n 0.4924 105249.9n 0.4924 105250.0n 0.6809 105499.9n 0.6809 105500.0n 0.6011 105749.9n 0.6011 105750.0n 0.6591 105999.9n 0.6591 106000.0n 0.7026 106249.9n 0.7026 106250.0n 0.3547 106499.9n 0.3547 106500.0n 0.6301 106749.9n 0.6301 106750.0n 0.2895 106999.9n 0.2895 107000.0n 0.5794 107249.9n 0.5794 107250.0n 0.5794 107499.9n 0.5794 107500.0n 0.6954 107749.9n 0.6954 107750.0n 0.6591 107999.9n 0.6591 108000.0n 0.2895 108249.9n 0.2895 108250.0n 0.4634 108499.9n 0.4634 108500.0n 0.5142 108749.9n 0.5142 108750.0n 0.4272 108999.9n 0.4272 109000.0n 0.3620 109249.9n 0.3620 109250.0n 0.6301 109499.9n 0.6301 109500.0n 0.7171 109749.9n 0.7171 109750.0n 0.4779 109999.9n 0.4779 110000.0n 0.6156 110249.9n 0.6156 110250.0n 0.4489 110499.9n 0.4489 110500.0n 0.6301 110749.9n 0.6301 110750.0n 0.4779 110999.9n 0.4779 111000.0n 0.3402 111249.9n 0.3402 111250.0n 0.4417 111499.9n 0.4417 111500.0n 0.5069 111749.9n 0.5069 111750.0n 0.6229 111999.9n 0.6229 112000.0n 0.6084 112249.9n 0.6084 112250.0n 0.6156 112499.9n 0.6156 112500.0n 0.4924 112749.9n 0.4924 112750.0n 0.6809 112999.9n 0.6809 113000.0n 0.6011 113249.9n 0.6011 113250.0n 0.6591 113499.9n 0.6591 113500.0n 0.7026 113749.9n 0.7026 113750.0n 0.3547 113999.9n 0.3547 114000.0n 0.6301 114249.9n 0.6301 114250.0n 0.2895 114499.9n 0.2895 114500.0n 0.5794 114749.9n 0.5794 114750.0n 0.5794 114999.9n 0.5794 115000.0n 0.6954 115249.9n 0.6954 115250.0n 0.6591 115499.9n 0.6591 115500.0n 0.2895 115749.9n 0.2895 115750.0n 0.4634 115999.9n 0.4634 116000.0n 0.5142 116249.9n 0.5142 116250.0n 0.4272 116499.9n 0.4272 116500.0n 0.3620 116749.9n 0.3620 116750.0n 0.6301 116999.9n 0.6301 117000.0n 0.7171 117249.9n 0.7171 117250.0n 0.4779 117499.9n 0.4779 117500.0n 0.6156 117749.9n 0.6156 117750.0n 0.4489 117999.9n 0.4489 118000.0n 0.6301 118249.9n 0.6301 118250.0n 0.4779 118499.9n 0.4779 118500.0n 0.3402 118749.9n 0.3402 118750.0n 0.4417 118999.9n 0.4417 119000.0n 0.5069 119249.9n 0.5069 119250.0n 0.6229 119499.9n 0.6229 119500.0n 0.6084 119749.9n 0.6084 119750.0n 0.6156 119999.9n 0.6156 120000.0n 0.4924 120249.9n 0.4924 120250.0n 0.6809 120499.9n 0.6809 120500.0n 0.6011 120749.9n 0.6011 120750.0n 0.6591 120999.9n 0.6591 121000.0n 0.7026 121249.9n 0.7026 121250.0n 0.3547 121499.9n 0.3547 121500.0n 0.6301 121749.9n 0.6301 121750.0n 0.2895 121999.9n 0.2895 122000.0n 0.5794 122249.9n 0.5794 122250.0n 0.5794 122499.9n 0.5794 122500.0n 0.6954 122749.9n 0.6954 122750.0n 0.6591 122999.9n 0.6591 123000.0n 0.2895 123249.9n 0.2895 123250.0n 0.4634 123499.9n 0.4634 123500.0n 0.5142 123749.9n 0.5142 123750.0n 0.4272 123999.9n 0.4272 124000.0n 0.3620 124249.9n 0.3620 124250.0n 0.6301 124499.9n 0.6301 124500.0n 0.7171 124749.9n 0.7171 124750.0n 0.4779 124999.9n 0.4779 125000.0n 0.6156 125249.9n 0.6156 125250.0n 0.4489 125499.9n 0.4489 125500.0n 0.6301 125749.9n 0.6301 125750.0n 0.4779 125999.9n 0.4779 126000.0n 0.3402 126249.9n 0.3402 126250.0n 0.4417 126499.9n 0.4417 126500.0n 0.5069 126749.9n 0.5069 126750.0n 0.6229 126999.9n 0.6229 127000.0n 0.6084 127249.9n 0.6084 127250.0n 0.6156 127499.9n 0.6156 127500.0n 0.4924 127749.9n 0.4924 127750.0n 0.6809 127999.9n 0.6809 128000.0n 0.6011 128249.9n 0.6011 128250.0n 0.6591 128499.9n 0.6591 128500.0n 0.7026 128749.9n 0.7026 128750.0n 0.3547 128999.9n 0.3547 129000.0n 0.6301 129249.9n 0.6301 129250.0n 0.2895 129499.9n 0.2895 129500.0n 0.5794 129749.9n 0.5794 129750.0n 0.5794 129999.9n 0.5794 130000.0n 0.6954 130249.9n 0.6954 130250.0n 0.6591 130499.9n 0.6591 130500.0n 0.2895 130749.9n 0.2895 130750.0n 0.4634 130999.9n 0.4634 131000.0n 0.5142 131249.9n 0.5142 131250.0n 0.4272 131499.9n 0.4272 131500.0n 0.3620 131749.9n 0.3620 131750.0n 0.6301 131999.9n 0.6301 132000.0n 0.7171 132249.9n 0.7171 132250.0n 0.4779 132499.9n 0.4779 132500.0n 0.6156 132749.9n 0.6156 132750.0n 0.4489 132999.9n 0.4489 133000.0n 0.6301 133249.9n 0.6301 133250.0n 0.4779 133499.9n 0.4779 133500.0n 0.3402 133749.9n 0.3402 133750.0n 0.4417 133999.9n 0.4417 134000.0n 0.5069 134249.9n 0.5069 134250.0n 0.6229 134499.9n 0.6229 134500.0n 0.6084 134749.9n 0.6084 134750.0n 0.6156 134999.9n 0.6156 135000.0n 0.4924 135249.9n 0.4924 135250.0n 0.6809 135499.9n 0.6809 135500.0n 0.6011 135749.9n 0.6011 135750.0n 0.6591 135999.9n 0.6591 136000.0n 0.7026 136249.9n 0.7026 136250.0n 0.3547 136499.9n 0.3547 136500.0n 0.6301 136749.9n 0.6301 136750.0n 0.2895 136999.9n 0.2895 137000.0n 0.5794 137249.9n 0.5794 137250.0n 0.5794 137499.9n 0.5794 137500.0n 0.6954 137749.9n 0.6954 137750.0n 0.6591 137999.9n 0.6591 138000.0n 0.2895 138249.9n 0.2895 138250.0n 0.4634 138499.9n 0.4634 138500.0n 0.5142 138749.9n 0.5142 138750.0n 0.4272 138999.9n 0.4272 139000.0n 0.3620 139249.9n 0.3620 139250.0n 0.6301 139499.9n 0.6301 139500.0n 0.7171 139749.9n 0.7171 139750.0n 0.4779 139999.9n 0.4779 140000.0n 0.6156 140249.9n 0.6156 140250.0n 0.4489 140499.9n 0.4489 140500.0n 0.6301 140749.9n 0.6301 140750.0n 0.4779 140999.9n 0.4779 141000.0n 0.3402 141249.9n 0.3402 141250.0n 0.4417 141499.9n 0.4417 141500.0n 0.5069 141749.9n 0.5069 141750.0n 0.6229 141999.9n 0.6229 142000.0n 0.6084 142249.9n 0.6084 142250.0n 0.6156 142499.9n 0.6156 142500.0n 0.4924 142749.9n 0.4924 142750.0n 0.6809 142999.9n 0.6809 143000.0n 0.6011 143249.9n 0.6011 143250.0n 0.6591 143499.9n 0.6591 143500.0n 0.7026 143749.9n 0.7026 143750.0n 0.3547 143999.9n 0.3547 144000.0n 0.6301 144249.9n 0.6301 144250.0n 0.2895 144499.9n 0.2895 144500.0n 0.5794 144749.9n 0.5794 144750.0n 0.5794 144999.9n 0.5794 145000.0n 0.6954 145249.9n 0.6954 145250.0n 0.6591 145499.9n 0.6591 145500.0n 0.2895 145749.9n 0.2895 145750.0n 0.4634 145999.9n 0.4634 146000.0n 0.5142 146249.9n 0.5142 146250.0n 0.4272 146499.9n 0.4272 146500.0n 0.3620 146749.9n 0.3620 146750.0n 0.6301 146999.9n 0.6301 147000.0n 0.7171 147249.9n 0.7171 147250.0n 0.4779 147499.9n 0.4779 147500.0n 0.6156 147749.9n 0.6156 147750.0n 0.4489 147999.9n 0.4489 148000.0n 0.6301 148249.9n 0.6301 148250.0n 0.4779 148499.9n 0.4779 148500.0n 0.3402 148749.9n 0.3402 148750.0n 0.4417 148999.9n 0.4417 149000.0n 0.5069 149249.9n 0.5069 149250.0n 0.6229 149499.9n 0.6229 149500.0n 0.6084 149749.9n 0.6084 149750.0n 0.6156 149999.9n 0.6156 150000.0n 0.4924 150249.9n 0.4924 150250.0n 0.6809 150499.9n 0.6809 150500.0n 0.6011 150749.9n 0.6011 150750.0n 0.6591 150999.9n 0.6591 151000.0n 0.7026 151249.9n 0.7026 151250.0n 0.3547 151499.9n 0.3547 151500.0n 0.6301 151749.9n 0.6301 151750.0n 0.2895 151999.9n 0.2895 152000.0n 0.5794 152249.9n 0.5794 152250.0n 0.5794 152499.9n 0.5794 152500.0n 0.6954 152749.9n 0.6954 152750.0n 0.6591 152999.9n 0.6591 153000.0n 0.2895 153249.9n 0.2895 153250.0n 0.4634 153499.9n 0.4634 153500.0n 0.5142 153749.9n 0.5142 153750.0n 0.4272 153999.9n 0.4272 154000.0n 0.3620 154249.9n 0.3620 154250.0n 0.6301 154499.9n 0.6301 154500.0n 0.7171 154749.9n 0.7171 154750.0n 0.4779 154999.9n 0.4779 155000.0n 0.6156 155249.9n 0.6156 155250.0n 0.4489 155499.9n 0.4489 155500.0n 0.6301 155749.9n 0.6301 155750.0n 0.4779 155999.9n 0.4779 156000.0n 0.3402 156249.9n 0.3402 156250.0n 0.4417 156499.9n 0.4417 156500.0n 0.5069 156749.9n 0.5069 156750.0n 0.6229 156999.9n 0.6229 157000.0n 0.6084 157249.9n 0.6084 157250.0n 0.6156 157499.9n 0.6156 157500.0n 0.4924 157749.9n 0.4924 157750.0n 0.6809 157999.9n 0.6809 158000.0n 0.6011 158249.9n 0.6011 158250.0n 0.6591 158499.9n 0.6591 158500.0n 0.7026 158749.9n 0.7026 158750.0n 0.3547 158999.9n 0.3547 159000.0n 0.6301 159249.9n 0.6301 159250.0n 0.2895 159499.9n 0.2895 159500.0n 0.5794 159749.9n 0.5794 159750.0n 0.5794 159999.9n 0.5794 160000.0n 0.6954 160249.9n 0.6954 160250.0n 0.6591 160499.9n 0.6591 160500.0n 0.2895 160749.9n 0.2895 160750.0n 0.4634 160999.9n 0.4634 161000.0n 0.5142 161249.9n 0.5142 161250.0n 0.4272 161499.9n 0.4272 161500.0n 0.3620 161749.9n 0.3620 161750.0n 0.6301 161999.9n 0.6301 162000.0n 0.7171 162249.9n 0.7171 162250.0n 0.4779 162499.9n 0.4779 162500.0n 0.6156 162749.9n 0.6156 162750.0n 0.4489 162999.9n 0.4489 163000.0n 0.6301 163249.9n 0.6301 163250.0n 0.4779 163499.9n 0.4779 163500.0n 0.3402 163749.9n 0.3402 163750.0n 0.4417 163999.9n 0.4417 164000.0n 0.5069 164249.9n 0.5069 164250.0n 0.6229 164499.9n 0.6229 164500.0n 0.6084 164749.9n 0.6084 164750.0n 0.6156 164999.9n 0.6156 165000.0n 0.4924 165249.9n 0.4924 165250.0n 0.6809 165499.9n 0.6809 165500.0n 0.6011 165749.9n 0.6011 165750.0n 0.6591 165999.9n 0.6591 166000.0n 0.7026 166249.9n 0.7026 166250.0n 0.3547 166499.9n 0.3547 166500.0n 0.6301 166749.9n 0.6301 166750.0n 0.2895 166999.9n 0.2895 167000.0n 0.5794 167249.9n 0.5794 167250.0n 0.5794 167499.9n 0.5794 167500.0n 0.6954 167749.9n 0.6954 167750.0n 0.6591 167999.9n 0.6591 168000.0n 0.2895 168249.9n 0.2895 168250.0n 0.4634 168499.9n 0.4634 168500.0n 0.5142 168749.9n 0.5142 168750.0n 0.4272 168999.9n 0.4272 169000.0n 0.3620 169249.9n 0.3620 169250.0n 0.6301 169499.9n 0.6301 169500.0n 0.7171 169749.9n 0.7171 169750.0n 0.4779 169999.9n 0.4779 170000.0n 0.6156 170249.9n 0.6156 170250.0n 0.4489 170499.9n 0.4489 170500.0n 0.6301 170749.9n 0.6301 170750.0n 0.4779 170999.9n 0.4779 171000.0n 0.3402 171249.9n 0.3402 171250.0n 0.4417 171499.9n 0.4417 171500.0n 0.5069 171749.9n 0.5069 171750.0n 0.6229 171999.9n 0.6229 172000.0n 0.6084 172249.9n 0.6084 172250.0n 0.6156 172499.9n 0.6156 172500.0n 0.4924 172749.9n 0.4924 172750.0n 0.6809 172999.9n 0.6809 173000.0n 0.6011 173249.9n 0.6011 173250.0n 0.6591 173499.9n 0.6591 173500.0n 0.7026 173749.9n 0.7026 173750.0n 0.3547 173999.9n 0.3547 174000.0n 0.6301 174249.9n 0.6301 174250.0n 0.2895 174499.9n 0.2895 174500.0n 0.5794 174749.9n 0.5794 174750.0n 0.5794 174999.9n 0.5794 175000.0n 0.6954 175249.9n 0.6954 175250.0n 0.6591 175499.9n 0.6591 175500.0n 0.2895 175749.9n 0.2895 175750.0n 0.4634 175999.9n 0.4634 176000.0n 0.5142 176249.9n 0.5142 176250.0n 0.4272 176499.9n 0.4272 176500.0n 0.3620 176749.9n 0.3620 176750.0n 0.6301 176999.9n 0.6301 177000.0n 0.7171 177249.9n 0.7171 177250.0n 0.4779 177499.9n 0.4779 177500.0n 0.6156 177749.9n 0.6156 177750.0n 0.4489 177999.9n 0.4489 178000.0n 0.6301 178249.9n 0.6301 178250.0n 0.4779 178499.9n 0.4779 178500.0n 0.3402 178749.9n 0.3402 178750.0n 0.4417 178999.9n 0.4417 179000.0n 0.5069 179249.9n 0.5069 179250.0n 0.6229 179499.9n 0.6229 179500.0n 0.6084 179749.9n 0.6084 179750.0n 0.6156 179999.9n 0.6156 180000.0n 0.4924 180249.9n 0.4924 180250.0n 0.6809 180499.9n 0.6809 180500.0n 0.6011 180749.9n 0.6011 180750.0n 0.6591 180999.9n 0.6591 181000.0n 0.7026 181249.9n 0.7026 181250.0n 0.3547 181499.9n 0.3547 181500.0n 0.6301 181749.9n 0.6301 181750.0n 0.2895 181999.9n 0.2895 182000.0n 0.5794 182249.9n 0.5794 182250.0n 0.5794 182499.9n 0.5794 182500.0n 0.6954 182749.9n 0.6954 182750.0n 0.6591 182999.9n 0.6591 183000.0n 0.2895 183249.9n 0.2895 183250.0n 0.4634 183499.9n 0.4634 183500.0n 0.5142 183749.9n 0.5142 183750.0n 0.4272 183999.9n 0.4272 184000.0n 0.3620 184249.9n 0.3620 184250.0n 0.6301 184499.9n 0.6301 184500.0n 0.7171 184749.9n 0.7171 184750.0n 0.4779 184999.9n 0.4779 185000.0n 0.6156 185249.9n 0.6156 185250.0n 0.4489 185499.9n 0.4489 185500.0n 0.6301 185749.9n 0.6301 185750.0n 0.4779 185999.9n 0.4779 186000.0n 0.3402 186249.9n 0.3402 186250.0n 0.4417 186499.9n 0.4417 186500.0n 0.5069 186749.9n 0.5069 186750.0n 0.6229 186999.9n 0.6229 187000.0n 0.6084 187249.9n 0.6084 187250.0n 0.6156 187499.9n 0.6156 187500.0n 0.4924 187749.9n 0.4924 187750.0n 0.6809 187999.9n 0.6809 188000.0n 0.6011 188249.9n 0.6011 188250.0n 0.6591 188499.9n 0.6591 188500.0n 0.7026 188749.9n 0.7026 188750.0n 0.3547 188999.9n 0.3547 189000.0n 0.6301 189249.9n 0.6301 189250.0n 0.2895 189499.9n 0.2895 189500.0n 0.5794 189749.9n 0.5794 189750.0n 0.5794 189999.9n 0.5794 190000.0n 0.6954 190249.9n 0.6954 190250.0n 0.6591 190499.9n 0.6591 190500.0n 0.2895 190749.9n 0.2895 190750.0n 0.4634 190999.9n 0.4634 191000.0n 0.5142 191249.9n 0.5142 191250.0n 0.4272 191499.9n 0.4272 191500.0n 0.3620 191749.9n 0.3620 191750.0n 0.6301 191999.9n 0.6301 192000.0n 0.7171 192249.9n 0.7171 192250.0n 0.4779 192499.9n 0.4779 192500.0n 0.6156 192749.9n 0.6156 192750.0n 0.4489 192999.9n 0.4489 193000.0n 0.6301 193249.9n 0.6301 193250.0n 0.4779 193499.9n 0.4779 193500.0n 0.3402 193749.9n 0.3402 193750.0n 0.4417 193999.9n 0.4417 194000.0n 0.5069 194249.9n 0.5069 194250.0n 0.6229 194499.9n 0.6229 194500.0n 0.6084 194749.9n 0.6084 194750.0n 0.6156 194999.9n 0.6156 195000.0n 0.4924 195249.9n 0.4924 195250.0n 0.6809 195499.9n 0.6809 195500.0n 0.6011 195749.9n 0.6011 195750.0n 0.6591 195999.9n 0.6591 196000.0n 0.7026 196249.9n 0.7026 196250.0n 0.3547 196499.9n 0.3547 196500.0n 0.6301 196749.9n 0.6301 196750.0n 0.2895 196999.9n 0.2895 197000.0n 0.5794 197249.9n 0.5794 197250.0n 0.5794 197499.9n 0.5794 197500.0n 0.6954 197749.9n 0.6954 197750.0n 0.6591 197999.9n 0.6591 198000.0n 0.2895 198249.9n 0.2895 198250.0n 0.4634 198499.9n 0.4634 198500.0n 0.5142 198749.9n 0.5142 198750.0n 0.4272 198999.9n 0.4272 199000.0n 0.3620 199249.9n 0.3620 199250.0n 0.6301 199499.9n 0.6301 199500.0n 0.7171 199749.9n 0.7171 199750.0n 0.4779 199999.9n 0.4779 200000.0n 0.6156 200249.9n 0.6156 200250.0n 0.4489 200499.9n 0.4489 200500.0n 0.6301 200749.9n 0.6301 200750.0n 0.4779 200999.9n 0.4779 201000.0n 0.3402 201249.9n 0.3402 201250.0n 0.4417 201499.9n 0.4417 201500.0n 0.5069 201749.9n 0.5069 201750.0n 0.6229 201999.9n 0.6229 202000.0n 0.6084 202249.9n 0.6084 202250.0n 0.6156 202499.9n 0.6156 202500.0n 0.4924 202749.9n 0.4924 202750.0n 0.6809 202999.9n 0.6809 203000.0n 0.6011 203249.9n 0.6011 203250.0n 0.6591 203499.9n 0.6591 203500.0n 0.7026 203749.9n 0.7026 203750.0n 0.3547 203999.9n 0.3547 204000.0n 0.6301 204249.9n 0.6301 204250.0n 0.2895 204499.9n 0.2895 204500.0n 0.5794 204749.9n 0.5794 204750.0n 0.5794 204999.9n 0.5794 205000.0n 0.6954 205249.9n 0.6954 205250.0n 0.6591 205499.9n 0.6591 205500.0n 0.2895 205749.9n 0.2895 205750.0n 0.4634 205999.9n 0.4634 206000.0n 0.5142 206249.9n 0.5142 206250.0n 0.4272 206499.9n 0.4272 206500.0n 0.3620 206749.9n 0.3620 206750.0n 0.6301 206999.9n 0.6301 207000.0n 0.7171 207249.9n 0.7171 207250.0n 0.4779 207499.9n 0.4779 207500.0n 0.6156 207749.9n 0.6156 207750.0n 0.4489 207999.9n 0.4489 208000.0n 0.6301 208249.9n 0.6301 208250.0n 0.4779 208499.9n 0.4779 208500.0n 0.3402 208749.9n 0.3402 208750.0n 0.4417 208999.9n 0.4417 209000.0n 0.5069 209249.9n 0.5069 209250.0n 0.6229 209499.9n 0.6229 209500.0n 0.6084 209749.9n 0.6084 209750.0n 0.6156 209999.9n 0.6156 210000.0n 0.4924 210249.9n 0.4924 210250.0n 0.6809 210499.9n 0.6809 210500.0n 0.6011 210749.9n 0.6011 210750.0n 0.6591 210999.9n 0.6591 211000.0n 0.7026 211249.9n 0.7026 211250.0n 0.3547 211499.9n 0.3547 211500.0n 0.6301 211749.9n 0.6301 211750.0n 0.2895 211999.9n 0.2895 212000.0n 0.5794 212249.9n 0.5794 212250.0n 0.5794 212499.9n 0.5794 212500.0n 0.6954 212749.9n 0.6954 212750.0n 0.6591 212999.9n 0.6591 213000.0n 0.2895 213249.9n 0.2895 213250.0n 0.4634 213499.9n 0.4634 213500.0n 0.5142 213749.9n 0.5142 213750.0n 0.4272 213999.9n 0.4272 214000.0n 0.3620 214249.9n 0.3620 214250.0n 0.6301 214499.9n 0.6301 214500.0n 0.7171 214749.9n 0.7171 214750.0n 0.4779 214999.9n 0.4779 215000.0n 0.6156 215249.9n 0.6156 215250.0n 0.4489 215499.9n 0.4489 215500.0n 0.6301 215749.9n 0.6301 215750.0n 0.4779 215999.9n 0.4779 216000.0n 0.3402 216249.9n 0.3402 216250.0n 0.4417 216499.9n 0.4417 216500.0n 0.5069 216749.9n 0.5069 216750.0n 0.6229 216999.9n 0.6229 217000.0n 0.6084 217249.9n 0.6084 217250.0n 0.6156 217499.9n 0.6156 217500.0n 0.4924 217749.9n 0.4924 217750.0n 0.6809 217999.9n 0.6809 218000.0n 0.6011 218249.9n 0.6011 218250.0n 0.6591 218499.9n 0.6591 218500.0n 0.7026 218749.9n 0.7026 218750.0n 0.3547 218999.9n 0.3547 219000.0n 0.6301 219249.9n 0.6301 219250.0n 0.2895 219499.9n 0.2895 219500.0n 0.5794 219749.9n 0.5794 219750.0n 0.5794 219999.9n 0.5794 220000.0n 0.6954 220249.9n 0.6954 220250.0n 0.6591 220499.9n 0.6591 220500.0n 0.2895 220749.9n 0.2895 220750.0n 0.4634 220999.9n 0.4634 221000.0n 0.5142 221249.9n 0.5142 221250.0n 0.4272 221499.9n 0.4272 221500.0n 0.3620 221749.9n 0.3620 221750.0n 0.6301 221999.9n 0.6301 222000.0n 0.7171 222249.9n 0.7171 222250.0n 0.4779 222499.9n 0.4779 222500.0n 0.6156 222749.9n 0.6156 222750.0n 0.4489 222999.9n 0.4489 223000.0n 0.6301 223249.9n 0.6301 223250.0n 0.4779 223499.9n 0.4779 223500.0n 0.3402 223749.9n 0.3402 223750.0n 0.4417 223999.9n 0.4417 224000.0n 0.5069 224249.9n 0.5069 224250.0n 0.6229 224499.9n 0.6229 224500.0n 0.6084 224749.9n 0.6084 224750.0n 0.6156 224999.9n 0.6156 225000.0n 0.4924 225249.9n 0.4924 225250.0n 0.6809 225499.9n 0.6809 225500.0n 0.6011 225749.9n 0.6011 225750.0n 0.6591 225999.9n 0.6591 226000.0n 0.7026 226249.9n 0.7026 226250.0n 0.3547 226499.9n 0.3547 226500.0n 0.6301 226749.9n 0.6301 226750.0n 0.2895 226999.9n 0.2895 227000.0n 0.5794 227249.9n 0.5794 227250.0n 0.5794 227499.9n 0.5794 227500.0n 0.6954 227749.9n 0.6954 227750.0n 0.6591 227999.9n 0.6591 228000.0n 0.2895 228249.9n 0.2895 228250.0n 0.4634 228499.9n 0.4634 228500.0n 0.5142 228749.9n 0.5142 228750.0n 0.4272 228999.9n 0.4272 229000.0n 0.3620 229249.9n 0.3620 229250.0n 0.6301 229499.9n 0.6301 229500.0n 0.7171 229749.9n 0.7171 229750.0n 0.4779 229999.9n 0.4779 230000.0n 0.6156 230249.9n 0.6156 230250.0n 0.4489 230499.9n 0.4489 230500.0n 0.6301 230749.9n 0.6301 230750.0n 0.4779 230999.9n 0.4779 231000.0n 0.3402 231249.9n 0.3402 231250.0n 0.4417 231499.9n 0.4417 231500.0n 0.5069 231749.9n 0.5069 231750.0n 0.6229 231999.9n 0.6229 232000.0n 0.6084 232249.9n 0.6084 232250.0n 0.6156 232499.9n 0.6156 232500.0n 0.4924 232749.9n 0.4924 232750.0n 0.6809 232999.9n 0.6809 233000.0n 0.6011 233249.9n 0.6011 233250.0n 0.6591 233499.9n 0.6591 233500.0n 0.7026 233749.9n 0.7026 233750.0n 0.3547 233999.9n 0.3547 234000.0n 0.6301 234249.9n 0.6301 234250.0n 0.2895 234499.9n 0.2895 234500.0n 0.5794 234749.9n 0.5794 234750.0n 0.5794 234999.9n 0.5794 235000.0n 0.6954 235249.9n 0.6954 235250.0n 0.6591 235499.9n 0.6591 235500.0n 0.2895 235749.9n 0.2895 235750.0n 0.4634 235999.9n 0.4634 236000.0n 0.5142 236249.9n 0.5142 236250.0n 0.4272 236499.9n 0.4272 236500.0n 0.3620 236749.9n 0.3620 236750.0n 0.6301 236999.9n 0.6301 237000.0n 0.7171 237249.9n 0.7171 237250.0n 0.4779 237499.9n 0.4779 237500.0n 0.6156 237749.9n 0.6156 237750.0n 0.4489 237999.9n 0.4489 238000.0n 0.6301 238249.9n 0.6301 238250.0n 0.4779 238499.9n 0.4779 238500.0n 0.3402 238749.9n 0.3402 238750.0n 0.4417 238999.9n 0.4417 239000.0n 0.5069 239249.9n 0.5069 239250.0n 0.6229 239499.9n 0.6229 239500.0n 0.6084 239749.9n 0.6084 239750.0n 0.6156 239999.9n 0.6156 240000.0n 0.4924 240249.9n 0.4924 240250.0n 0.6809 240499.9n 0.6809 240500.0n 0.6011 240749.9n 0.6011 240750.0n 0.6591 240999.9n 0.6591 241000.0n 0.7026 241249.9n 0.7026 241250.0n 0.3547 241499.9n 0.3547 241500.0n 0.6301 241749.9n 0.6301 241750.0n 0.2895 241999.9n 0.2895 242000.0n 0.5794 242249.9n 0.5794 242250.0n 0.5794 242499.9n 0.5794 242500.0n 0.6954 242749.9n 0.6954 242750.0n 0.6591 242999.9n 0.6591 243000.0n 0.2895 243249.9n 0.2895 243250.0n 0.4634 243499.9n 0.4634 243500.0n 0.5142 243749.9n 0.5142 243750.0n 0.4272 243999.9n 0.4272 244000.0n 0.3620 244249.9n 0.3620 244250.0n 0.6301 244499.9n 0.6301 244500.0n 0.7171 244749.9n 0.7171 244750.0n 0.4779 244999.9n 0.4779 245000.0n 0.6156 245249.9n 0.6156 245250.0n 0.4489 245499.9n 0.4489 245500.0n 0.6301 245749.9n 0.6301 245750.0n 0.4779 245999.9n 0.4779 246000.0n 0.3402 246249.9n 0.3402 246250.0n 0.4417 246499.9n 0.4417 246500.0n 0.5069 246749.9n 0.5069 246750.0n 0.6229 246999.9n 0.6229 247000.0n 0.6084 247249.9n 0.6084 247250.0n 0.6156 247499.9n 0.6156 247500.0n 0.4924 247749.9n 0.4924 247750.0n 0.6809 247999.9n 0.6809 248000.0n 0.6011 248249.9n 0.6011 248250.0n 0.6591 248499.9n 0.6591 248500.0n 0.7026 248749.9n 0.7026 248750.0n 0.3547 248999.9n 0.3547 249000.0n 0.6301 249249.9n 0.6301 249250.0n 0.2895 249499.9n 0.2895 249500.0n 0.5794 249749.9n 0.5794 249750.0n 0.5794 249999.9n 0.5794 250000.0n 0.6954 250249.9n 0.6954 250250.0n 0.6591 250499.9n 0.6591 250500.0n 0.2895 250749.9n 0.2895 250750.0n 0.4634 250999.9n 0.4634 251000.0n 0.5142 251249.9n 0.5142 251250.0n 0.4272 251499.9n 0.4272 251500.0n 0.3620 251749.9n 0.3620 251750.0n 0.6301 251999.9n 0.6301 252000.0n 0.7171 252249.9n 0.7171 252250.0n 0.4779 252499.9n 0.4779 252500.0n 0.6156 252749.9n 0.6156 252750.0n 0.4489 252999.9n 0.4489 253000.0n 0.6301 253249.9n 0.6301 253250.0n 0.4779 253499.9n 0.4779 253500.0n 0.3402 253749.9n 0.3402 253750.0n 0.4417 253999.9n 0.4417 254000.0n 0.5069 254249.9n 0.5069 254250.0n 0.6229 254499.9n 0.6229 254500.0n 0.6084 254749.9n 0.6084 254750.0n 0.6156 254999.9n 0.6156 255000.0n 0.4924 255249.9n 0.4924 255250.0n 0.6809 255499.9n 0.6809 255500.0n 0.6011 255749.9n 0.6011 255750.0n 0.6591 255999.9n 0.6591 256000.0n 0.7026 256249.9n 0.7026 256250.0n 0.3547 256499.9n 0.3547 256500.0n 0.6301 256749.9n 0.6301 256750.0n 0.2895 256999.9n 0.2895 257000.0n 0.5794 257249.9n 0.5794 257250.0n 0.5794 257499.9n 0.5794 257500.0n 0.6954 257749.9n 0.6954 257750.0n 0.6591 257999.9n 0.6591 258000.0n 0.2895 258249.9n 0.2895 258250.0n 0.4634 258499.9n 0.4634 258500.0n 0.5142 258749.9n 0.5142 258750.0n 0.4272 258999.9n 0.4272 259000.0n 0.3620 259249.9n 0.3620 259250.0n 0.6301 259499.9n 0.6301 259500.0n 0.7171 259749.9n 0.7171 259750.0n 0.4779 259999.9n 0.4779 260000.0n 0.6156 260249.9n 0.6156 260250.0n 0.4489 260499.9n 0.4489 260500.0n 0.6301 260749.9n 0.6301 260750.0n 0.4779 260999.9n 0.4779 261000.0n 0.3402 261249.9n 0.3402 261250.0n 0.4417 261499.9n 0.4417 261500.0n 0.5069 261749.9n 0.5069 261750.0n 0.6229 261999.9n 0.6229 262000.0n 0.6084 262249.9n 0.6084 262250.0n 0.6156 262499.9n 0.6156 262500.0n 0.4924 262749.9n 0.4924 262750.0n 0.6809 262999.9n 0.6809 263000.0n 0.6011 263249.9n 0.6011 263250.0n 0.6591 263499.9n 0.6591 263500.0n 0.7026 263749.9n 0.7026 263750.0n 0.3547 263999.9n 0.3547 264000.0n 0.6301 264249.9n 0.6301 264250.0n 0.2895 264499.9n 0.2895 264500.0n 0.5794 264749.9n 0.5794 264750.0n 0.5794 264999.9n 0.5794 265000.0n 0.6954 265249.9n 0.6954 265250.0n 0.6591 265499.9n 0.6591 265500.0n 0.2895 265749.9n 0.2895 265750.0n 0.4634 265999.9n 0.4634 266000.0n 0.5142 266249.9n 0.5142 266250.0n 0.4272 266499.9n 0.4272 266500.0n 0.3620 266749.9n 0.3620 266750.0n 0.6301 266999.9n 0.6301 267000.0n 0.7171 267249.9n 0.7171 267250.0n 0.4779 267499.9n 0.4779 267500.0n 0.6156 267749.9n 0.6156 267750.0n 0.4489 267999.9n 0.4489 268000.0n 0.6301 268249.9n 0.6301 268250.0n 0.4779 268499.9n 0.4779 268500.0n 0.3402 268749.9n 0.3402 268750.0n 0.4417 268999.9n 0.4417 269000.0n 0.5069 269249.9n 0.5069 269250.0n 0.6229 269499.9n 0.6229 269500.0n 0.6084 269749.9n 0.6084 269750.0n 0.6156 269999.9n 0.6156 270000.0n 0.4924 270249.9n 0.4924 270250.0n 0.6809 270499.9n 0.6809 270500.0n 0.6011 270749.9n 0.6011 270750.0n 0.6591 270999.9n 0.6591 271000.0n 0.7026 271249.9n 0.7026 271250.0n 0.3547 271499.9n 0.3547 271500.0n 0.6301 271749.9n 0.6301 271750.0n 0.2895 271999.9n 0.2895 272000.0n 0.5794 272249.9n 0.5794 272250.0n 0.5794 272499.9n 0.5794 272500.0n 0.6954 272749.9n 0.6954 272750.0n 0.6591 272999.9n 0.6591 273000.0n 0.2895 273249.9n 0.2895 273250.0n 0.4634 273499.9n 0.4634 273500.0n 0.5142 273749.9n 0.5142 273750.0n 0.4272 273999.9n 0.4272 274000.0n 0.3620 274249.9n 0.3620 274250.0n 0.6301 274499.9n 0.6301 274500.0n 0.7171 274749.9n 0.7171 274750.0n 0.4779 274999.9n 0.4779 275000.0n 0.6156 275249.9n 0.6156 275250.0n 0.4489 275499.9n 0.4489 275500.0n 0.6301 275749.9n 0.6301 275750.0n 0.4779 275999.9n 0.4779 276000.0n 0.3402 276249.9n 0.3402 276250.0n 0.4417 276499.9n 0.4417 276500.0n 0.5069 276749.9n 0.5069 276750.0n 0.6229 276999.9n 0.6229 277000.0n 0.6084 277249.9n 0.6084 277250.0n 0.6156 277499.9n 0.6156 277500.0n 0.4924 277749.9n 0.4924 277750.0n 0.6809 277999.9n 0.6809 278000.0n 0.6011 278249.9n 0.6011 278250.0n 0.6591 278499.9n 0.6591 278500.0n 0.7026 278749.9n 0.7026 278750.0n 0.3547 278999.9n 0.3547 279000.0n 0.6301 279249.9n 0.6301 279250.0n 0.2895 279499.9n 0.2895 279500.0n 0.5794 279749.9n 0.5794 279750.0n 0.5794 279999.9n 0.5794 280000.0n 0.6954 280249.9n 0.6954 280250.0n 0.6591 280499.9n 0.6591 280500.0n 0.2895 280749.9n 0.2895 280750.0n 0.4634 280999.9n 0.4634 281000.0n 0.5142 281249.9n 0.5142 281250.0n 0.4272 281499.9n 0.4272 281500.0n 0.3620 281749.9n 0.3620 281750.0n 0.6301 281999.9n 0.6301 282000.0n 0.7171 282249.9n 0.7171 282250.0n 0.4779 282499.9n 0.4779 282500.0n 0.6156 282749.9n 0.6156 282750.0n 0.4489 282999.9n 0.4489 283000.0n 0.6301 283249.9n 0.6301 283250.0n 0.4779 283499.9n 0.4779 283500.0n 0.3402 283749.9n 0.3402 283750.0n 0.4417 283999.9n 0.4417 284000.0n 0.5069 284249.9n 0.5069 284250.0n 0.6229 284499.9n 0.6229 284500.0n 0.6084 284749.9n 0.6084 284750.0n 0.6156 284999.9n 0.6156 285000.0n 0.4924 285249.9n 0.4924 285250.0n 0.6809 285499.9n 0.6809 285500.0n 0.6011 285749.9n 0.6011 285750.0n 0.6591 285999.9n 0.6591 286000.0n 0.7026 286249.9n 0.7026 286250.0n 0.3547 286499.9n 0.3547 286500.0n 0.6301 286749.9n 0.6301 286750.0n 0.2895 286999.9n 0.2895 287000.0n 0.5794 287249.9n 0.5794 287250.0n 0.5794 287499.9n 0.5794 287500.0n 0.6954 287749.9n 0.6954 287750.0n 0.6591 287999.9n 0.6591 288000.0n 0.2895 288249.9n 0.2895 288250.0n 0.4634 288499.9n 0.4634 288500.0n 0.5142 288749.9n 0.5142 288750.0n 0.4272 288999.9n 0.4272 289000.0n 0.3620 289249.9n 0.3620 289250.0n 0.6301 289499.9n 0.6301 289500.0n 0.7171 289749.9n 0.7171 289750.0n 0.4779 289999.9n 0.4779 290000.0n 0.6156 290249.9n 0.6156 290250.0n 0.4489 290499.9n 0.4489 290500.0n 0.6301 290749.9n 0.6301 290750.0n 0.4779 290999.9n 0.4779 291000.0n 0.3402 291249.9n 0.3402 291250.0n 0.4417 291499.9n 0.4417 291500.0n 0.5069 291749.9n 0.5069 291750.0n 0.6229 291999.9n 0.6229 292000.0n 0.6084 292249.9n 0.6084 292250.0n 0.6156 292499.9n 0.6156 292500.0n 0.4924 292749.9n 0.4924 292750.0n 0.6809 292999.9n 0.6809 293000.0n 0.6011 293249.9n 0.6011 293250.0n 0.6591 293499.9n 0.6591 293500.0n 0.7026 293749.9n 0.7026 293750.0n 0.3547 293999.9n 0.3547 294000.0n 0.6301 294249.9n 0.6301 294250.0n 0.2895 294499.9n 0.2895 294500.0n 0.5794 294749.9n 0.5794 294750.0n 0.5794 294999.9n 0.5794 295000.0n 0.6954 295249.9n 0.6954 295250.0n 0.6591 295499.9n 0.6591 295500.0n 0.2895 295749.9n 0.2895 295750.0n 0.4634 295999.9n 0.4634 296000.0n 0.5142 296249.9n 0.5142 296250.0n 0.4272 296499.9n 0.4272 296500.0n 0.3620 296749.9n 0.3620 296750.0n 0.6301 296999.9n 0.6301 297000.0n 0.7171 297249.9n 0.7171 297250.0n 0.4779 297499.9n 0.4779 297500.0n 0.6156 297749.9n 0.6156 297750.0n 0.4489 297999.9n 0.4489 298000.0n 0.6301 298249.9n 0.6301 298250.0n 0.4779 298499.9n 0.4779 298500.0n 0.3402 298749.9n 0.3402 298750.0n 0.4417 298999.9n 0.4417 299000.0n 0.5069 299249.9n 0.5069 299250.0n 0.6229 299499.9n 0.6229 299500.0n 0.6084 299749.9n 0.6084 299750.0n 0.6156)
Vxp11 a_xp11 0 PWL(0.0n 0.5089 249.9n 0.5089 250.0n 0.6111 499.9n 0.6111 500.0n 0.5673 749.9n 0.5673 750.0n 0.5819 999.9n 0.5819 1000.0n 0.6257 1249.9n 0.6257 1250.0n 0.4066 1499.9n 0.4066 1500.0n 0.5819 1749.9n 0.5819 1750.0n 0.4066 1999.9n 0.4066 2000.0n 0.4066 2249.9n 0.4066 2250.0n 0.4066 2499.9n 0.4066 2500.0n 0.6987 2749.9n 0.6987 2750.0n 0.6257 2999.9n 0.6257 3000.0n 0.4504 3249.9n 0.4504 3250.0n 0.4066 3499.9n 0.4066 3500.0n 0.4066 3749.9n 0.4066 3750.0n 0.4066 3999.9n 0.4066 4000.0n 0.4066 4249.9n 0.4066 4250.0n 0.5819 4499.9n 0.5819 4500.0n 0.7572 4749.9n 0.7572 4750.0n 0.4066 4999.9n 0.4066 5000.0n 0.6695 5249.9n 0.6695 5250.0n 0.4066 5499.9n 0.4066 5500.0n 0.6549 5749.9n 0.6549 5750.0n 0.4066 5999.9n 0.4066 6000.0n 0.5235 6249.9n 0.5235 6250.0n 0.4651 6499.9n 0.4651 6500.0n 0.4066 6749.9n 0.4066 6750.0n 0.5673 6999.9n 0.5673 7000.0n 0.7279 7249.9n 0.7279 7250.0n 0.7718 7499.9n 0.7718 7500.0n 0.5089 7749.9n 0.5089 7750.0n 0.6111 7999.9n 0.6111 8000.0n 0.5673 8249.9n 0.5673 8250.0n 0.5819 8499.9n 0.5819 8500.0n 0.6257 8749.9n 0.6257 8750.0n 0.4066 8999.9n 0.4066 9000.0n 0.5819 9249.9n 0.5819 9250.0n 0.4066 9499.9n 0.4066 9500.0n 0.4066 9749.9n 0.4066 9750.0n 0.4066 9999.9n 0.4066 10000.0n 0.6987 10249.9n 0.6987 10250.0n 0.6257 10499.9n 0.6257 10500.0n 0.4504 10749.9n 0.4504 10750.0n 0.4066 10999.9n 0.4066 11000.0n 0.4066 11249.9n 0.4066 11250.0n 0.4066 11499.9n 0.4066 11500.0n 0.4066 11749.9n 0.4066 11750.0n 0.5819 11999.9n 0.5819 12000.0n 0.7572 12249.9n 0.7572 12250.0n 0.4066 12499.9n 0.4066 12500.0n 0.6695 12749.9n 0.6695 12750.0n 0.4066 12999.9n 0.4066 13000.0n 0.6549 13249.9n 0.6549 13250.0n 0.4066 13499.9n 0.4066 13500.0n 0.5235 13749.9n 0.5235 13750.0n 0.4651 13999.9n 0.4651 14000.0n 0.4066 14249.9n 0.4066 14250.0n 0.5673 14499.9n 0.5673 14500.0n 0.7279 14749.9n 0.7279 14750.0n 0.7718 14999.9n 0.7718 15000.0n 0.5089 15249.9n 0.5089 15250.0n 0.6111 15499.9n 0.6111 15500.0n 0.5673 15749.9n 0.5673 15750.0n 0.5819 15999.9n 0.5819 16000.0n 0.6257 16249.9n 0.6257 16250.0n 0.4066 16499.9n 0.4066 16500.0n 0.5819 16749.9n 0.5819 16750.0n 0.4066 16999.9n 0.4066 17000.0n 0.4066 17249.9n 0.4066 17250.0n 0.4066 17499.9n 0.4066 17500.0n 0.6987 17749.9n 0.6987 17750.0n 0.6257 17999.9n 0.6257 18000.0n 0.4504 18249.9n 0.4504 18250.0n 0.4066 18499.9n 0.4066 18500.0n 0.4066 18749.9n 0.4066 18750.0n 0.4066 18999.9n 0.4066 19000.0n 0.4066 19249.9n 0.4066 19250.0n 0.5819 19499.9n 0.5819 19500.0n 0.7572 19749.9n 0.7572 19750.0n 0.4066 19999.9n 0.4066 20000.0n 0.6695 20249.9n 0.6695 20250.0n 0.4066 20499.9n 0.4066 20500.0n 0.6549 20749.9n 0.6549 20750.0n 0.4066 20999.9n 0.4066 21000.0n 0.5235 21249.9n 0.5235 21250.0n 0.4651 21499.9n 0.4651 21500.0n 0.4066 21749.9n 0.4066 21750.0n 0.5673 21999.9n 0.5673 22000.0n 0.7279 22249.9n 0.7279 22250.0n 0.7718 22499.9n 0.7718 22500.0n 0.5089 22749.9n 0.5089 22750.0n 0.6111 22999.9n 0.6111 23000.0n 0.5673 23249.9n 0.5673 23250.0n 0.5819 23499.9n 0.5819 23500.0n 0.6257 23749.9n 0.6257 23750.0n 0.4066 23999.9n 0.4066 24000.0n 0.5819 24249.9n 0.5819 24250.0n 0.4066 24499.9n 0.4066 24500.0n 0.4066 24749.9n 0.4066 24750.0n 0.4066 24999.9n 0.4066 25000.0n 0.6987 25249.9n 0.6987 25250.0n 0.6257 25499.9n 0.6257 25500.0n 0.4504 25749.9n 0.4504 25750.0n 0.4066 25999.9n 0.4066 26000.0n 0.4066 26249.9n 0.4066 26250.0n 0.4066 26499.9n 0.4066 26500.0n 0.4066 26749.9n 0.4066 26750.0n 0.5819 26999.9n 0.5819 27000.0n 0.7572 27249.9n 0.7572 27250.0n 0.4066 27499.9n 0.4066 27500.0n 0.6695 27749.9n 0.6695 27750.0n 0.4066 27999.9n 0.4066 28000.0n 0.6549 28249.9n 0.6549 28250.0n 0.4066 28499.9n 0.4066 28500.0n 0.5235 28749.9n 0.5235 28750.0n 0.4651 28999.9n 0.4651 29000.0n 0.4066 29249.9n 0.4066 29250.0n 0.5673 29499.9n 0.5673 29500.0n 0.7279 29749.9n 0.7279 29750.0n 0.7718 29999.9n 0.7718 30000.0n 0.5089 30249.9n 0.5089 30250.0n 0.6111 30499.9n 0.6111 30500.0n 0.5673 30749.9n 0.5673 30750.0n 0.5819 30999.9n 0.5819 31000.0n 0.6257 31249.9n 0.6257 31250.0n 0.4066 31499.9n 0.4066 31500.0n 0.5819 31749.9n 0.5819 31750.0n 0.4066 31999.9n 0.4066 32000.0n 0.4066 32249.9n 0.4066 32250.0n 0.4066 32499.9n 0.4066 32500.0n 0.6987 32749.9n 0.6987 32750.0n 0.6257 32999.9n 0.6257 33000.0n 0.4504 33249.9n 0.4504 33250.0n 0.4066 33499.9n 0.4066 33500.0n 0.4066 33749.9n 0.4066 33750.0n 0.4066 33999.9n 0.4066 34000.0n 0.4066 34249.9n 0.4066 34250.0n 0.5819 34499.9n 0.5819 34500.0n 0.7572 34749.9n 0.7572 34750.0n 0.4066 34999.9n 0.4066 35000.0n 0.6695 35249.9n 0.6695 35250.0n 0.4066 35499.9n 0.4066 35500.0n 0.6549 35749.9n 0.6549 35750.0n 0.4066 35999.9n 0.4066 36000.0n 0.5235 36249.9n 0.5235 36250.0n 0.4651 36499.9n 0.4651 36500.0n 0.4066 36749.9n 0.4066 36750.0n 0.5673 36999.9n 0.5673 37000.0n 0.7279 37249.9n 0.7279 37250.0n 0.7718 37499.9n 0.7718 37500.0n 0.5089 37749.9n 0.5089 37750.0n 0.6111 37999.9n 0.6111 38000.0n 0.5673 38249.9n 0.5673 38250.0n 0.5819 38499.9n 0.5819 38500.0n 0.6257 38749.9n 0.6257 38750.0n 0.4066 38999.9n 0.4066 39000.0n 0.5819 39249.9n 0.5819 39250.0n 0.4066 39499.9n 0.4066 39500.0n 0.4066 39749.9n 0.4066 39750.0n 0.4066 39999.9n 0.4066 40000.0n 0.6987 40249.9n 0.6987 40250.0n 0.6257 40499.9n 0.6257 40500.0n 0.4504 40749.9n 0.4504 40750.0n 0.4066 40999.9n 0.4066 41000.0n 0.4066 41249.9n 0.4066 41250.0n 0.4066 41499.9n 0.4066 41500.0n 0.4066 41749.9n 0.4066 41750.0n 0.5819 41999.9n 0.5819 42000.0n 0.7572 42249.9n 0.7572 42250.0n 0.4066 42499.9n 0.4066 42500.0n 0.6695 42749.9n 0.6695 42750.0n 0.4066 42999.9n 0.4066 43000.0n 0.6549 43249.9n 0.6549 43250.0n 0.4066 43499.9n 0.4066 43500.0n 0.5235 43749.9n 0.5235 43750.0n 0.4651 43999.9n 0.4651 44000.0n 0.4066 44249.9n 0.4066 44250.0n 0.5673 44499.9n 0.5673 44500.0n 0.7279 44749.9n 0.7279 44750.0n 0.7718 44999.9n 0.7718 45000.0n 0.5089 45249.9n 0.5089 45250.0n 0.6111 45499.9n 0.6111 45500.0n 0.5673 45749.9n 0.5673 45750.0n 0.5819 45999.9n 0.5819 46000.0n 0.6257 46249.9n 0.6257 46250.0n 0.4066 46499.9n 0.4066 46500.0n 0.5819 46749.9n 0.5819 46750.0n 0.4066 46999.9n 0.4066 47000.0n 0.4066 47249.9n 0.4066 47250.0n 0.4066 47499.9n 0.4066 47500.0n 0.6987 47749.9n 0.6987 47750.0n 0.6257 47999.9n 0.6257 48000.0n 0.4504 48249.9n 0.4504 48250.0n 0.4066 48499.9n 0.4066 48500.0n 0.4066 48749.9n 0.4066 48750.0n 0.4066 48999.9n 0.4066 49000.0n 0.4066 49249.9n 0.4066 49250.0n 0.5819 49499.9n 0.5819 49500.0n 0.7572 49749.9n 0.7572 49750.0n 0.4066 49999.9n 0.4066 50000.0n 0.6695 50249.9n 0.6695 50250.0n 0.4066 50499.9n 0.4066 50500.0n 0.6549 50749.9n 0.6549 50750.0n 0.4066 50999.9n 0.4066 51000.0n 0.5235 51249.9n 0.5235 51250.0n 0.4651 51499.9n 0.4651 51500.0n 0.4066 51749.9n 0.4066 51750.0n 0.5673 51999.9n 0.5673 52000.0n 0.7279 52249.9n 0.7279 52250.0n 0.7718 52499.9n 0.7718 52500.0n 0.5089 52749.9n 0.5089 52750.0n 0.6111 52999.9n 0.6111 53000.0n 0.5673 53249.9n 0.5673 53250.0n 0.5819 53499.9n 0.5819 53500.0n 0.6257 53749.9n 0.6257 53750.0n 0.4066 53999.9n 0.4066 54000.0n 0.5819 54249.9n 0.5819 54250.0n 0.4066 54499.9n 0.4066 54500.0n 0.4066 54749.9n 0.4066 54750.0n 0.4066 54999.9n 0.4066 55000.0n 0.6987 55249.9n 0.6987 55250.0n 0.6257 55499.9n 0.6257 55500.0n 0.4504 55749.9n 0.4504 55750.0n 0.4066 55999.9n 0.4066 56000.0n 0.4066 56249.9n 0.4066 56250.0n 0.4066 56499.9n 0.4066 56500.0n 0.4066 56749.9n 0.4066 56750.0n 0.5819 56999.9n 0.5819 57000.0n 0.7572 57249.9n 0.7572 57250.0n 0.4066 57499.9n 0.4066 57500.0n 0.6695 57749.9n 0.6695 57750.0n 0.4066 57999.9n 0.4066 58000.0n 0.6549 58249.9n 0.6549 58250.0n 0.4066 58499.9n 0.4066 58500.0n 0.5235 58749.9n 0.5235 58750.0n 0.4651 58999.9n 0.4651 59000.0n 0.4066 59249.9n 0.4066 59250.0n 0.5673 59499.9n 0.5673 59500.0n 0.7279 59749.9n 0.7279 59750.0n 0.7718 59999.9n 0.7718 60000.0n 0.5089 60249.9n 0.5089 60250.0n 0.6111 60499.9n 0.6111 60500.0n 0.5673 60749.9n 0.5673 60750.0n 0.5819 60999.9n 0.5819 61000.0n 0.6257 61249.9n 0.6257 61250.0n 0.4066 61499.9n 0.4066 61500.0n 0.5819 61749.9n 0.5819 61750.0n 0.4066 61999.9n 0.4066 62000.0n 0.4066 62249.9n 0.4066 62250.0n 0.4066 62499.9n 0.4066 62500.0n 0.6987 62749.9n 0.6987 62750.0n 0.6257 62999.9n 0.6257 63000.0n 0.4504 63249.9n 0.4504 63250.0n 0.4066 63499.9n 0.4066 63500.0n 0.4066 63749.9n 0.4066 63750.0n 0.4066 63999.9n 0.4066 64000.0n 0.4066 64249.9n 0.4066 64250.0n 0.5819 64499.9n 0.5819 64500.0n 0.7572 64749.9n 0.7572 64750.0n 0.4066 64999.9n 0.4066 65000.0n 0.6695 65249.9n 0.6695 65250.0n 0.4066 65499.9n 0.4066 65500.0n 0.6549 65749.9n 0.6549 65750.0n 0.4066 65999.9n 0.4066 66000.0n 0.5235 66249.9n 0.5235 66250.0n 0.4651 66499.9n 0.4651 66500.0n 0.4066 66749.9n 0.4066 66750.0n 0.5673 66999.9n 0.5673 67000.0n 0.7279 67249.9n 0.7279 67250.0n 0.7718 67499.9n 0.7718 67500.0n 0.5089 67749.9n 0.5089 67750.0n 0.6111 67999.9n 0.6111 68000.0n 0.5673 68249.9n 0.5673 68250.0n 0.5819 68499.9n 0.5819 68500.0n 0.6257 68749.9n 0.6257 68750.0n 0.4066 68999.9n 0.4066 69000.0n 0.5819 69249.9n 0.5819 69250.0n 0.4066 69499.9n 0.4066 69500.0n 0.4066 69749.9n 0.4066 69750.0n 0.4066 69999.9n 0.4066 70000.0n 0.6987 70249.9n 0.6987 70250.0n 0.6257 70499.9n 0.6257 70500.0n 0.4504 70749.9n 0.4504 70750.0n 0.4066 70999.9n 0.4066 71000.0n 0.4066 71249.9n 0.4066 71250.0n 0.4066 71499.9n 0.4066 71500.0n 0.4066 71749.9n 0.4066 71750.0n 0.5819 71999.9n 0.5819 72000.0n 0.7572 72249.9n 0.7572 72250.0n 0.4066 72499.9n 0.4066 72500.0n 0.6695 72749.9n 0.6695 72750.0n 0.4066 72999.9n 0.4066 73000.0n 0.6549 73249.9n 0.6549 73250.0n 0.4066 73499.9n 0.4066 73500.0n 0.5235 73749.9n 0.5235 73750.0n 0.4651 73999.9n 0.4651 74000.0n 0.4066 74249.9n 0.4066 74250.0n 0.5673 74499.9n 0.5673 74500.0n 0.7279 74749.9n 0.7279 74750.0n 0.7718 74999.9n 0.7718 75000.0n 0.5089 75249.9n 0.5089 75250.0n 0.6111 75499.9n 0.6111 75500.0n 0.5673 75749.9n 0.5673 75750.0n 0.5819 75999.9n 0.5819 76000.0n 0.6257 76249.9n 0.6257 76250.0n 0.4066 76499.9n 0.4066 76500.0n 0.5819 76749.9n 0.5819 76750.0n 0.4066 76999.9n 0.4066 77000.0n 0.4066 77249.9n 0.4066 77250.0n 0.4066 77499.9n 0.4066 77500.0n 0.6987 77749.9n 0.6987 77750.0n 0.6257 77999.9n 0.6257 78000.0n 0.4504 78249.9n 0.4504 78250.0n 0.4066 78499.9n 0.4066 78500.0n 0.4066 78749.9n 0.4066 78750.0n 0.4066 78999.9n 0.4066 79000.0n 0.4066 79249.9n 0.4066 79250.0n 0.5819 79499.9n 0.5819 79500.0n 0.7572 79749.9n 0.7572 79750.0n 0.4066 79999.9n 0.4066 80000.0n 0.6695 80249.9n 0.6695 80250.0n 0.4066 80499.9n 0.4066 80500.0n 0.6549 80749.9n 0.6549 80750.0n 0.4066 80999.9n 0.4066 81000.0n 0.5235 81249.9n 0.5235 81250.0n 0.4651 81499.9n 0.4651 81500.0n 0.4066 81749.9n 0.4066 81750.0n 0.5673 81999.9n 0.5673 82000.0n 0.7279 82249.9n 0.7279 82250.0n 0.7718 82499.9n 0.7718 82500.0n 0.5089 82749.9n 0.5089 82750.0n 0.6111 82999.9n 0.6111 83000.0n 0.5673 83249.9n 0.5673 83250.0n 0.5819 83499.9n 0.5819 83500.0n 0.6257 83749.9n 0.6257 83750.0n 0.4066 83999.9n 0.4066 84000.0n 0.5819 84249.9n 0.5819 84250.0n 0.4066 84499.9n 0.4066 84500.0n 0.4066 84749.9n 0.4066 84750.0n 0.4066 84999.9n 0.4066 85000.0n 0.6987 85249.9n 0.6987 85250.0n 0.6257 85499.9n 0.6257 85500.0n 0.4504 85749.9n 0.4504 85750.0n 0.4066 85999.9n 0.4066 86000.0n 0.4066 86249.9n 0.4066 86250.0n 0.4066 86499.9n 0.4066 86500.0n 0.4066 86749.9n 0.4066 86750.0n 0.5819 86999.9n 0.5819 87000.0n 0.7572 87249.9n 0.7572 87250.0n 0.4066 87499.9n 0.4066 87500.0n 0.6695 87749.9n 0.6695 87750.0n 0.4066 87999.9n 0.4066 88000.0n 0.6549 88249.9n 0.6549 88250.0n 0.4066 88499.9n 0.4066 88500.0n 0.5235 88749.9n 0.5235 88750.0n 0.4651 88999.9n 0.4651 89000.0n 0.4066 89249.9n 0.4066 89250.0n 0.5673 89499.9n 0.5673 89500.0n 0.7279 89749.9n 0.7279 89750.0n 0.7718 89999.9n 0.7718 90000.0n 0.5089 90249.9n 0.5089 90250.0n 0.6111 90499.9n 0.6111 90500.0n 0.5673 90749.9n 0.5673 90750.0n 0.5819 90999.9n 0.5819 91000.0n 0.6257 91249.9n 0.6257 91250.0n 0.4066 91499.9n 0.4066 91500.0n 0.5819 91749.9n 0.5819 91750.0n 0.4066 91999.9n 0.4066 92000.0n 0.4066 92249.9n 0.4066 92250.0n 0.4066 92499.9n 0.4066 92500.0n 0.6987 92749.9n 0.6987 92750.0n 0.6257 92999.9n 0.6257 93000.0n 0.4504 93249.9n 0.4504 93250.0n 0.4066 93499.9n 0.4066 93500.0n 0.4066 93749.9n 0.4066 93750.0n 0.4066 93999.9n 0.4066 94000.0n 0.4066 94249.9n 0.4066 94250.0n 0.5819 94499.9n 0.5819 94500.0n 0.7572 94749.9n 0.7572 94750.0n 0.4066 94999.9n 0.4066 95000.0n 0.6695 95249.9n 0.6695 95250.0n 0.4066 95499.9n 0.4066 95500.0n 0.6549 95749.9n 0.6549 95750.0n 0.4066 95999.9n 0.4066 96000.0n 0.5235 96249.9n 0.5235 96250.0n 0.4651 96499.9n 0.4651 96500.0n 0.4066 96749.9n 0.4066 96750.0n 0.5673 96999.9n 0.5673 97000.0n 0.7279 97249.9n 0.7279 97250.0n 0.7718 97499.9n 0.7718 97500.0n 0.5089 97749.9n 0.5089 97750.0n 0.6111 97999.9n 0.6111 98000.0n 0.5673 98249.9n 0.5673 98250.0n 0.5819 98499.9n 0.5819 98500.0n 0.6257 98749.9n 0.6257 98750.0n 0.4066 98999.9n 0.4066 99000.0n 0.5819 99249.9n 0.5819 99250.0n 0.4066 99499.9n 0.4066 99500.0n 0.4066 99749.9n 0.4066 99750.0n 0.4066 99999.9n 0.4066 100000.0n 0.6987 100249.9n 0.6987 100250.0n 0.6257 100499.9n 0.6257 100500.0n 0.4504 100749.9n 0.4504 100750.0n 0.4066 100999.9n 0.4066 101000.0n 0.4066 101249.9n 0.4066 101250.0n 0.4066 101499.9n 0.4066 101500.0n 0.4066 101749.9n 0.4066 101750.0n 0.5819 101999.9n 0.5819 102000.0n 0.7572 102249.9n 0.7572 102250.0n 0.4066 102499.9n 0.4066 102500.0n 0.6695 102749.9n 0.6695 102750.0n 0.4066 102999.9n 0.4066 103000.0n 0.6549 103249.9n 0.6549 103250.0n 0.4066 103499.9n 0.4066 103500.0n 0.5235 103749.9n 0.5235 103750.0n 0.4651 103999.9n 0.4651 104000.0n 0.4066 104249.9n 0.4066 104250.0n 0.5673 104499.9n 0.5673 104500.0n 0.7279 104749.9n 0.7279 104750.0n 0.7718 104999.9n 0.7718 105000.0n 0.5089 105249.9n 0.5089 105250.0n 0.6111 105499.9n 0.6111 105500.0n 0.5673 105749.9n 0.5673 105750.0n 0.5819 105999.9n 0.5819 106000.0n 0.6257 106249.9n 0.6257 106250.0n 0.4066 106499.9n 0.4066 106500.0n 0.5819 106749.9n 0.5819 106750.0n 0.4066 106999.9n 0.4066 107000.0n 0.4066 107249.9n 0.4066 107250.0n 0.4066 107499.9n 0.4066 107500.0n 0.6987 107749.9n 0.6987 107750.0n 0.6257 107999.9n 0.6257 108000.0n 0.4504 108249.9n 0.4504 108250.0n 0.4066 108499.9n 0.4066 108500.0n 0.4066 108749.9n 0.4066 108750.0n 0.4066 108999.9n 0.4066 109000.0n 0.4066 109249.9n 0.4066 109250.0n 0.5819 109499.9n 0.5819 109500.0n 0.7572 109749.9n 0.7572 109750.0n 0.4066 109999.9n 0.4066 110000.0n 0.6695 110249.9n 0.6695 110250.0n 0.4066 110499.9n 0.4066 110500.0n 0.6549 110749.9n 0.6549 110750.0n 0.4066 110999.9n 0.4066 111000.0n 0.5235 111249.9n 0.5235 111250.0n 0.4651 111499.9n 0.4651 111500.0n 0.4066 111749.9n 0.4066 111750.0n 0.5673 111999.9n 0.5673 112000.0n 0.7279 112249.9n 0.7279 112250.0n 0.7718 112499.9n 0.7718 112500.0n 0.5089 112749.9n 0.5089 112750.0n 0.6111 112999.9n 0.6111 113000.0n 0.5673 113249.9n 0.5673 113250.0n 0.5819 113499.9n 0.5819 113500.0n 0.6257 113749.9n 0.6257 113750.0n 0.4066 113999.9n 0.4066 114000.0n 0.5819 114249.9n 0.5819 114250.0n 0.4066 114499.9n 0.4066 114500.0n 0.4066 114749.9n 0.4066 114750.0n 0.4066 114999.9n 0.4066 115000.0n 0.6987 115249.9n 0.6987 115250.0n 0.6257 115499.9n 0.6257 115500.0n 0.4504 115749.9n 0.4504 115750.0n 0.4066 115999.9n 0.4066 116000.0n 0.4066 116249.9n 0.4066 116250.0n 0.4066 116499.9n 0.4066 116500.0n 0.4066 116749.9n 0.4066 116750.0n 0.5819 116999.9n 0.5819 117000.0n 0.7572 117249.9n 0.7572 117250.0n 0.4066 117499.9n 0.4066 117500.0n 0.6695 117749.9n 0.6695 117750.0n 0.4066 117999.9n 0.4066 118000.0n 0.6549 118249.9n 0.6549 118250.0n 0.4066 118499.9n 0.4066 118500.0n 0.5235 118749.9n 0.5235 118750.0n 0.4651 118999.9n 0.4651 119000.0n 0.4066 119249.9n 0.4066 119250.0n 0.5673 119499.9n 0.5673 119500.0n 0.7279 119749.9n 0.7279 119750.0n 0.7718 119999.9n 0.7718 120000.0n 0.5089 120249.9n 0.5089 120250.0n 0.6111 120499.9n 0.6111 120500.0n 0.5673 120749.9n 0.5673 120750.0n 0.5819 120999.9n 0.5819 121000.0n 0.6257 121249.9n 0.6257 121250.0n 0.4066 121499.9n 0.4066 121500.0n 0.5819 121749.9n 0.5819 121750.0n 0.4066 121999.9n 0.4066 122000.0n 0.4066 122249.9n 0.4066 122250.0n 0.4066 122499.9n 0.4066 122500.0n 0.6987 122749.9n 0.6987 122750.0n 0.6257 122999.9n 0.6257 123000.0n 0.4504 123249.9n 0.4504 123250.0n 0.4066 123499.9n 0.4066 123500.0n 0.4066 123749.9n 0.4066 123750.0n 0.4066 123999.9n 0.4066 124000.0n 0.4066 124249.9n 0.4066 124250.0n 0.5819 124499.9n 0.5819 124500.0n 0.7572 124749.9n 0.7572 124750.0n 0.4066 124999.9n 0.4066 125000.0n 0.6695 125249.9n 0.6695 125250.0n 0.4066 125499.9n 0.4066 125500.0n 0.6549 125749.9n 0.6549 125750.0n 0.4066 125999.9n 0.4066 126000.0n 0.5235 126249.9n 0.5235 126250.0n 0.4651 126499.9n 0.4651 126500.0n 0.4066 126749.9n 0.4066 126750.0n 0.5673 126999.9n 0.5673 127000.0n 0.7279 127249.9n 0.7279 127250.0n 0.7718 127499.9n 0.7718 127500.0n 0.5089 127749.9n 0.5089 127750.0n 0.6111 127999.9n 0.6111 128000.0n 0.5673 128249.9n 0.5673 128250.0n 0.5819 128499.9n 0.5819 128500.0n 0.6257 128749.9n 0.6257 128750.0n 0.4066 128999.9n 0.4066 129000.0n 0.5819 129249.9n 0.5819 129250.0n 0.4066 129499.9n 0.4066 129500.0n 0.4066 129749.9n 0.4066 129750.0n 0.4066 129999.9n 0.4066 130000.0n 0.6987 130249.9n 0.6987 130250.0n 0.6257 130499.9n 0.6257 130500.0n 0.4504 130749.9n 0.4504 130750.0n 0.4066 130999.9n 0.4066 131000.0n 0.4066 131249.9n 0.4066 131250.0n 0.4066 131499.9n 0.4066 131500.0n 0.4066 131749.9n 0.4066 131750.0n 0.5819 131999.9n 0.5819 132000.0n 0.7572 132249.9n 0.7572 132250.0n 0.4066 132499.9n 0.4066 132500.0n 0.6695 132749.9n 0.6695 132750.0n 0.4066 132999.9n 0.4066 133000.0n 0.6549 133249.9n 0.6549 133250.0n 0.4066 133499.9n 0.4066 133500.0n 0.5235 133749.9n 0.5235 133750.0n 0.4651 133999.9n 0.4651 134000.0n 0.4066 134249.9n 0.4066 134250.0n 0.5673 134499.9n 0.5673 134500.0n 0.7279 134749.9n 0.7279 134750.0n 0.7718 134999.9n 0.7718 135000.0n 0.5089 135249.9n 0.5089 135250.0n 0.6111 135499.9n 0.6111 135500.0n 0.5673 135749.9n 0.5673 135750.0n 0.5819 135999.9n 0.5819 136000.0n 0.6257 136249.9n 0.6257 136250.0n 0.4066 136499.9n 0.4066 136500.0n 0.5819 136749.9n 0.5819 136750.0n 0.4066 136999.9n 0.4066 137000.0n 0.4066 137249.9n 0.4066 137250.0n 0.4066 137499.9n 0.4066 137500.0n 0.6987 137749.9n 0.6987 137750.0n 0.6257 137999.9n 0.6257 138000.0n 0.4504 138249.9n 0.4504 138250.0n 0.4066 138499.9n 0.4066 138500.0n 0.4066 138749.9n 0.4066 138750.0n 0.4066 138999.9n 0.4066 139000.0n 0.4066 139249.9n 0.4066 139250.0n 0.5819 139499.9n 0.5819 139500.0n 0.7572 139749.9n 0.7572 139750.0n 0.4066 139999.9n 0.4066 140000.0n 0.6695 140249.9n 0.6695 140250.0n 0.4066 140499.9n 0.4066 140500.0n 0.6549 140749.9n 0.6549 140750.0n 0.4066 140999.9n 0.4066 141000.0n 0.5235 141249.9n 0.5235 141250.0n 0.4651 141499.9n 0.4651 141500.0n 0.4066 141749.9n 0.4066 141750.0n 0.5673 141999.9n 0.5673 142000.0n 0.7279 142249.9n 0.7279 142250.0n 0.7718 142499.9n 0.7718 142500.0n 0.5089 142749.9n 0.5089 142750.0n 0.6111 142999.9n 0.6111 143000.0n 0.5673 143249.9n 0.5673 143250.0n 0.5819 143499.9n 0.5819 143500.0n 0.6257 143749.9n 0.6257 143750.0n 0.4066 143999.9n 0.4066 144000.0n 0.5819 144249.9n 0.5819 144250.0n 0.4066 144499.9n 0.4066 144500.0n 0.4066 144749.9n 0.4066 144750.0n 0.4066 144999.9n 0.4066 145000.0n 0.6987 145249.9n 0.6987 145250.0n 0.6257 145499.9n 0.6257 145500.0n 0.4504 145749.9n 0.4504 145750.0n 0.4066 145999.9n 0.4066 146000.0n 0.4066 146249.9n 0.4066 146250.0n 0.4066 146499.9n 0.4066 146500.0n 0.4066 146749.9n 0.4066 146750.0n 0.5819 146999.9n 0.5819 147000.0n 0.7572 147249.9n 0.7572 147250.0n 0.4066 147499.9n 0.4066 147500.0n 0.6695 147749.9n 0.6695 147750.0n 0.4066 147999.9n 0.4066 148000.0n 0.6549 148249.9n 0.6549 148250.0n 0.4066 148499.9n 0.4066 148500.0n 0.5235 148749.9n 0.5235 148750.0n 0.4651 148999.9n 0.4651 149000.0n 0.4066 149249.9n 0.4066 149250.0n 0.5673 149499.9n 0.5673 149500.0n 0.7279 149749.9n 0.7279 149750.0n 0.7718 149999.9n 0.7718 150000.0n 0.5089 150249.9n 0.5089 150250.0n 0.6111 150499.9n 0.6111 150500.0n 0.5673 150749.9n 0.5673 150750.0n 0.5819 150999.9n 0.5819 151000.0n 0.6257 151249.9n 0.6257 151250.0n 0.4066 151499.9n 0.4066 151500.0n 0.5819 151749.9n 0.5819 151750.0n 0.4066 151999.9n 0.4066 152000.0n 0.4066 152249.9n 0.4066 152250.0n 0.4066 152499.9n 0.4066 152500.0n 0.6987 152749.9n 0.6987 152750.0n 0.6257 152999.9n 0.6257 153000.0n 0.4504 153249.9n 0.4504 153250.0n 0.4066 153499.9n 0.4066 153500.0n 0.4066 153749.9n 0.4066 153750.0n 0.4066 153999.9n 0.4066 154000.0n 0.4066 154249.9n 0.4066 154250.0n 0.5819 154499.9n 0.5819 154500.0n 0.7572 154749.9n 0.7572 154750.0n 0.4066 154999.9n 0.4066 155000.0n 0.6695 155249.9n 0.6695 155250.0n 0.4066 155499.9n 0.4066 155500.0n 0.6549 155749.9n 0.6549 155750.0n 0.4066 155999.9n 0.4066 156000.0n 0.5235 156249.9n 0.5235 156250.0n 0.4651 156499.9n 0.4651 156500.0n 0.4066 156749.9n 0.4066 156750.0n 0.5673 156999.9n 0.5673 157000.0n 0.7279 157249.9n 0.7279 157250.0n 0.7718 157499.9n 0.7718 157500.0n 0.5089 157749.9n 0.5089 157750.0n 0.6111 157999.9n 0.6111 158000.0n 0.5673 158249.9n 0.5673 158250.0n 0.5819 158499.9n 0.5819 158500.0n 0.6257 158749.9n 0.6257 158750.0n 0.4066 158999.9n 0.4066 159000.0n 0.5819 159249.9n 0.5819 159250.0n 0.4066 159499.9n 0.4066 159500.0n 0.4066 159749.9n 0.4066 159750.0n 0.4066 159999.9n 0.4066 160000.0n 0.6987 160249.9n 0.6987 160250.0n 0.6257 160499.9n 0.6257 160500.0n 0.4504 160749.9n 0.4504 160750.0n 0.4066 160999.9n 0.4066 161000.0n 0.4066 161249.9n 0.4066 161250.0n 0.4066 161499.9n 0.4066 161500.0n 0.4066 161749.9n 0.4066 161750.0n 0.5819 161999.9n 0.5819 162000.0n 0.7572 162249.9n 0.7572 162250.0n 0.4066 162499.9n 0.4066 162500.0n 0.6695 162749.9n 0.6695 162750.0n 0.4066 162999.9n 0.4066 163000.0n 0.6549 163249.9n 0.6549 163250.0n 0.4066 163499.9n 0.4066 163500.0n 0.5235 163749.9n 0.5235 163750.0n 0.4651 163999.9n 0.4651 164000.0n 0.4066 164249.9n 0.4066 164250.0n 0.5673 164499.9n 0.5673 164500.0n 0.7279 164749.9n 0.7279 164750.0n 0.7718 164999.9n 0.7718 165000.0n 0.5089 165249.9n 0.5089 165250.0n 0.6111 165499.9n 0.6111 165500.0n 0.5673 165749.9n 0.5673 165750.0n 0.5819 165999.9n 0.5819 166000.0n 0.6257 166249.9n 0.6257 166250.0n 0.4066 166499.9n 0.4066 166500.0n 0.5819 166749.9n 0.5819 166750.0n 0.4066 166999.9n 0.4066 167000.0n 0.4066 167249.9n 0.4066 167250.0n 0.4066 167499.9n 0.4066 167500.0n 0.6987 167749.9n 0.6987 167750.0n 0.6257 167999.9n 0.6257 168000.0n 0.4504 168249.9n 0.4504 168250.0n 0.4066 168499.9n 0.4066 168500.0n 0.4066 168749.9n 0.4066 168750.0n 0.4066 168999.9n 0.4066 169000.0n 0.4066 169249.9n 0.4066 169250.0n 0.5819 169499.9n 0.5819 169500.0n 0.7572 169749.9n 0.7572 169750.0n 0.4066 169999.9n 0.4066 170000.0n 0.6695 170249.9n 0.6695 170250.0n 0.4066 170499.9n 0.4066 170500.0n 0.6549 170749.9n 0.6549 170750.0n 0.4066 170999.9n 0.4066 171000.0n 0.5235 171249.9n 0.5235 171250.0n 0.4651 171499.9n 0.4651 171500.0n 0.4066 171749.9n 0.4066 171750.0n 0.5673 171999.9n 0.5673 172000.0n 0.7279 172249.9n 0.7279 172250.0n 0.7718 172499.9n 0.7718 172500.0n 0.5089 172749.9n 0.5089 172750.0n 0.6111 172999.9n 0.6111 173000.0n 0.5673 173249.9n 0.5673 173250.0n 0.5819 173499.9n 0.5819 173500.0n 0.6257 173749.9n 0.6257 173750.0n 0.4066 173999.9n 0.4066 174000.0n 0.5819 174249.9n 0.5819 174250.0n 0.4066 174499.9n 0.4066 174500.0n 0.4066 174749.9n 0.4066 174750.0n 0.4066 174999.9n 0.4066 175000.0n 0.6987 175249.9n 0.6987 175250.0n 0.6257 175499.9n 0.6257 175500.0n 0.4504 175749.9n 0.4504 175750.0n 0.4066 175999.9n 0.4066 176000.0n 0.4066 176249.9n 0.4066 176250.0n 0.4066 176499.9n 0.4066 176500.0n 0.4066 176749.9n 0.4066 176750.0n 0.5819 176999.9n 0.5819 177000.0n 0.7572 177249.9n 0.7572 177250.0n 0.4066 177499.9n 0.4066 177500.0n 0.6695 177749.9n 0.6695 177750.0n 0.4066 177999.9n 0.4066 178000.0n 0.6549 178249.9n 0.6549 178250.0n 0.4066 178499.9n 0.4066 178500.0n 0.5235 178749.9n 0.5235 178750.0n 0.4651 178999.9n 0.4651 179000.0n 0.4066 179249.9n 0.4066 179250.0n 0.5673 179499.9n 0.5673 179500.0n 0.7279 179749.9n 0.7279 179750.0n 0.7718 179999.9n 0.7718 180000.0n 0.5089 180249.9n 0.5089 180250.0n 0.6111 180499.9n 0.6111 180500.0n 0.5673 180749.9n 0.5673 180750.0n 0.5819 180999.9n 0.5819 181000.0n 0.6257 181249.9n 0.6257 181250.0n 0.4066 181499.9n 0.4066 181500.0n 0.5819 181749.9n 0.5819 181750.0n 0.4066 181999.9n 0.4066 182000.0n 0.4066 182249.9n 0.4066 182250.0n 0.4066 182499.9n 0.4066 182500.0n 0.6987 182749.9n 0.6987 182750.0n 0.6257 182999.9n 0.6257 183000.0n 0.4504 183249.9n 0.4504 183250.0n 0.4066 183499.9n 0.4066 183500.0n 0.4066 183749.9n 0.4066 183750.0n 0.4066 183999.9n 0.4066 184000.0n 0.4066 184249.9n 0.4066 184250.0n 0.5819 184499.9n 0.5819 184500.0n 0.7572 184749.9n 0.7572 184750.0n 0.4066 184999.9n 0.4066 185000.0n 0.6695 185249.9n 0.6695 185250.0n 0.4066 185499.9n 0.4066 185500.0n 0.6549 185749.9n 0.6549 185750.0n 0.4066 185999.9n 0.4066 186000.0n 0.5235 186249.9n 0.5235 186250.0n 0.4651 186499.9n 0.4651 186500.0n 0.4066 186749.9n 0.4066 186750.0n 0.5673 186999.9n 0.5673 187000.0n 0.7279 187249.9n 0.7279 187250.0n 0.7718 187499.9n 0.7718 187500.0n 0.5089 187749.9n 0.5089 187750.0n 0.6111 187999.9n 0.6111 188000.0n 0.5673 188249.9n 0.5673 188250.0n 0.5819 188499.9n 0.5819 188500.0n 0.6257 188749.9n 0.6257 188750.0n 0.4066 188999.9n 0.4066 189000.0n 0.5819 189249.9n 0.5819 189250.0n 0.4066 189499.9n 0.4066 189500.0n 0.4066 189749.9n 0.4066 189750.0n 0.4066 189999.9n 0.4066 190000.0n 0.6987 190249.9n 0.6987 190250.0n 0.6257 190499.9n 0.6257 190500.0n 0.4504 190749.9n 0.4504 190750.0n 0.4066 190999.9n 0.4066 191000.0n 0.4066 191249.9n 0.4066 191250.0n 0.4066 191499.9n 0.4066 191500.0n 0.4066 191749.9n 0.4066 191750.0n 0.5819 191999.9n 0.5819 192000.0n 0.7572 192249.9n 0.7572 192250.0n 0.4066 192499.9n 0.4066 192500.0n 0.6695 192749.9n 0.6695 192750.0n 0.4066 192999.9n 0.4066 193000.0n 0.6549 193249.9n 0.6549 193250.0n 0.4066 193499.9n 0.4066 193500.0n 0.5235 193749.9n 0.5235 193750.0n 0.4651 193999.9n 0.4651 194000.0n 0.4066 194249.9n 0.4066 194250.0n 0.5673 194499.9n 0.5673 194500.0n 0.7279 194749.9n 0.7279 194750.0n 0.7718 194999.9n 0.7718 195000.0n 0.5089 195249.9n 0.5089 195250.0n 0.6111 195499.9n 0.6111 195500.0n 0.5673 195749.9n 0.5673 195750.0n 0.5819 195999.9n 0.5819 196000.0n 0.6257 196249.9n 0.6257 196250.0n 0.4066 196499.9n 0.4066 196500.0n 0.5819 196749.9n 0.5819 196750.0n 0.4066 196999.9n 0.4066 197000.0n 0.4066 197249.9n 0.4066 197250.0n 0.4066 197499.9n 0.4066 197500.0n 0.6987 197749.9n 0.6987 197750.0n 0.6257 197999.9n 0.6257 198000.0n 0.4504 198249.9n 0.4504 198250.0n 0.4066 198499.9n 0.4066 198500.0n 0.4066 198749.9n 0.4066 198750.0n 0.4066 198999.9n 0.4066 199000.0n 0.4066 199249.9n 0.4066 199250.0n 0.5819 199499.9n 0.5819 199500.0n 0.7572 199749.9n 0.7572 199750.0n 0.4066 199999.9n 0.4066 200000.0n 0.6695 200249.9n 0.6695 200250.0n 0.4066 200499.9n 0.4066 200500.0n 0.6549 200749.9n 0.6549 200750.0n 0.4066 200999.9n 0.4066 201000.0n 0.5235 201249.9n 0.5235 201250.0n 0.4651 201499.9n 0.4651 201500.0n 0.4066 201749.9n 0.4066 201750.0n 0.5673 201999.9n 0.5673 202000.0n 0.7279 202249.9n 0.7279 202250.0n 0.7718 202499.9n 0.7718 202500.0n 0.5089 202749.9n 0.5089 202750.0n 0.6111 202999.9n 0.6111 203000.0n 0.5673 203249.9n 0.5673 203250.0n 0.5819 203499.9n 0.5819 203500.0n 0.6257 203749.9n 0.6257 203750.0n 0.4066 203999.9n 0.4066 204000.0n 0.5819 204249.9n 0.5819 204250.0n 0.4066 204499.9n 0.4066 204500.0n 0.4066 204749.9n 0.4066 204750.0n 0.4066 204999.9n 0.4066 205000.0n 0.6987 205249.9n 0.6987 205250.0n 0.6257 205499.9n 0.6257 205500.0n 0.4504 205749.9n 0.4504 205750.0n 0.4066 205999.9n 0.4066 206000.0n 0.4066 206249.9n 0.4066 206250.0n 0.4066 206499.9n 0.4066 206500.0n 0.4066 206749.9n 0.4066 206750.0n 0.5819 206999.9n 0.5819 207000.0n 0.7572 207249.9n 0.7572 207250.0n 0.4066 207499.9n 0.4066 207500.0n 0.6695 207749.9n 0.6695 207750.0n 0.4066 207999.9n 0.4066 208000.0n 0.6549 208249.9n 0.6549 208250.0n 0.4066 208499.9n 0.4066 208500.0n 0.5235 208749.9n 0.5235 208750.0n 0.4651 208999.9n 0.4651 209000.0n 0.4066 209249.9n 0.4066 209250.0n 0.5673 209499.9n 0.5673 209500.0n 0.7279 209749.9n 0.7279 209750.0n 0.7718 209999.9n 0.7718 210000.0n 0.5089 210249.9n 0.5089 210250.0n 0.6111 210499.9n 0.6111 210500.0n 0.5673 210749.9n 0.5673 210750.0n 0.5819 210999.9n 0.5819 211000.0n 0.6257 211249.9n 0.6257 211250.0n 0.4066 211499.9n 0.4066 211500.0n 0.5819 211749.9n 0.5819 211750.0n 0.4066 211999.9n 0.4066 212000.0n 0.4066 212249.9n 0.4066 212250.0n 0.4066 212499.9n 0.4066 212500.0n 0.6987 212749.9n 0.6987 212750.0n 0.6257 212999.9n 0.6257 213000.0n 0.4504 213249.9n 0.4504 213250.0n 0.4066 213499.9n 0.4066 213500.0n 0.4066 213749.9n 0.4066 213750.0n 0.4066 213999.9n 0.4066 214000.0n 0.4066 214249.9n 0.4066 214250.0n 0.5819 214499.9n 0.5819 214500.0n 0.7572 214749.9n 0.7572 214750.0n 0.4066 214999.9n 0.4066 215000.0n 0.6695 215249.9n 0.6695 215250.0n 0.4066 215499.9n 0.4066 215500.0n 0.6549 215749.9n 0.6549 215750.0n 0.4066 215999.9n 0.4066 216000.0n 0.5235 216249.9n 0.5235 216250.0n 0.4651 216499.9n 0.4651 216500.0n 0.4066 216749.9n 0.4066 216750.0n 0.5673 216999.9n 0.5673 217000.0n 0.7279 217249.9n 0.7279 217250.0n 0.7718 217499.9n 0.7718 217500.0n 0.5089 217749.9n 0.5089 217750.0n 0.6111 217999.9n 0.6111 218000.0n 0.5673 218249.9n 0.5673 218250.0n 0.5819 218499.9n 0.5819 218500.0n 0.6257 218749.9n 0.6257 218750.0n 0.4066 218999.9n 0.4066 219000.0n 0.5819 219249.9n 0.5819 219250.0n 0.4066 219499.9n 0.4066 219500.0n 0.4066 219749.9n 0.4066 219750.0n 0.4066 219999.9n 0.4066 220000.0n 0.6987 220249.9n 0.6987 220250.0n 0.6257 220499.9n 0.6257 220500.0n 0.4504 220749.9n 0.4504 220750.0n 0.4066 220999.9n 0.4066 221000.0n 0.4066 221249.9n 0.4066 221250.0n 0.4066 221499.9n 0.4066 221500.0n 0.4066 221749.9n 0.4066 221750.0n 0.5819 221999.9n 0.5819 222000.0n 0.7572 222249.9n 0.7572 222250.0n 0.4066 222499.9n 0.4066 222500.0n 0.6695 222749.9n 0.6695 222750.0n 0.4066 222999.9n 0.4066 223000.0n 0.6549 223249.9n 0.6549 223250.0n 0.4066 223499.9n 0.4066 223500.0n 0.5235 223749.9n 0.5235 223750.0n 0.4651 223999.9n 0.4651 224000.0n 0.4066 224249.9n 0.4066 224250.0n 0.5673 224499.9n 0.5673 224500.0n 0.7279 224749.9n 0.7279 224750.0n 0.7718 224999.9n 0.7718 225000.0n 0.5089 225249.9n 0.5089 225250.0n 0.6111 225499.9n 0.6111 225500.0n 0.5673 225749.9n 0.5673 225750.0n 0.5819 225999.9n 0.5819 226000.0n 0.6257 226249.9n 0.6257 226250.0n 0.4066 226499.9n 0.4066 226500.0n 0.5819 226749.9n 0.5819 226750.0n 0.4066 226999.9n 0.4066 227000.0n 0.4066 227249.9n 0.4066 227250.0n 0.4066 227499.9n 0.4066 227500.0n 0.6987 227749.9n 0.6987 227750.0n 0.6257 227999.9n 0.6257 228000.0n 0.4504 228249.9n 0.4504 228250.0n 0.4066 228499.9n 0.4066 228500.0n 0.4066 228749.9n 0.4066 228750.0n 0.4066 228999.9n 0.4066 229000.0n 0.4066 229249.9n 0.4066 229250.0n 0.5819 229499.9n 0.5819 229500.0n 0.7572 229749.9n 0.7572 229750.0n 0.4066 229999.9n 0.4066 230000.0n 0.6695 230249.9n 0.6695 230250.0n 0.4066 230499.9n 0.4066 230500.0n 0.6549 230749.9n 0.6549 230750.0n 0.4066 230999.9n 0.4066 231000.0n 0.5235 231249.9n 0.5235 231250.0n 0.4651 231499.9n 0.4651 231500.0n 0.4066 231749.9n 0.4066 231750.0n 0.5673 231999.9n 0.5673 232000.0n 0.7279 232249.9n 0.7279 232250.0n 0.7718 232499.9n 0.7718 232500.0n 0.5089 232749.9n 0.5089 232750.0n 0.6111 232999.9n 0.6111 233000.0n 0.5673 233249.9n 0.5673 233250.0n 0.5819 233499.9n 0.5819 233500.0n 0.6257 233749.9n 0.6257 233750.0n 0.4066 233999.9n 0.4066 234000.0n 0.5819 234249.9n 0.5819 234250.0n 0.4066 234499.9n 0.4066 234500.0n 0.4066 234749.9n 0.4066 234750.0n 0.4066 234999.9n 0.4066 235000.0n 0.6987 235249.9n 0.6987 235250.0n 0.6257 235499.9n 0.6257 235500.0n 0.4504 235749.9n 0.4504 235750.0n 0.4066 235999.9n 0.4066 236000.0n 0.4066 236249.9n 0.4066 236250.0n 0.4066 236499.9n 0.4066 236500.0n 0.4066 236749.9n 0.4066 236750.0n 0.5819 236999.9n 0.5819 237000.0n 0.7572 237249.9n 0.7572 237250.0n 0.4066 237499.9n 0.4066 237500.0n 0.6695 237749.9n 0.6695 237750.0n 0.4066 237999.9n 0.4066 238000.0n 0.6549 238249.9n 0.6549 238250.0n 0.4066 238499.9n 0.4066 238500.0n 0.5235 238749.9n 0.5235 238750.0n 0.4651 238999.9n 0.4651 239000.0n 0.4066 239249.9n 0.4066 239250.0n 0.5673 239499.9n 0.5673 239500.0n 0.7279 239749.9n 0.7279 239750.0n 0.7718 239999.9n 0.7718 240000.0n 0.5089 240249.9n 0.5089 240250.0n 0.6111 240499.9n 0.6111 240500.0n 0.5673 240749.9n 0.5673 240750.0n 0.5819 240999.9n 0.5819 241000.0n 0.6257 241249.9n 0.6257 241250.0n 0.4066 241499.9n 0.4066 241500.0n 0.5819 241749.9n 0.5819 241750.0n 0.4066 241999.9n 0.4066 242000.0n 0.4066 242249.9n 0.4066 242250.0n 0.4066 242499.9n 0.4066 242500.0n 0.6987 242749.9n 0.6987 242750.0n 0.6257 242999.9n 0.6257 243000.0n 0.4504 243249.9n 0.4504 243250.0n 0.4066 243499.9n 0.4066 243500.0n 0.4066 243749.9n 0.4066 243750.0n 0.4066 243999.9n 0.4066 244000.0n 0.4066 244249.9n 0.4066 244250.0n 0.5819 244499.9n 0.5819 244500.0n 0.7572 244749.9n 0.7572 244750.0n 0.4066 244999.9n 0.4066 245000.0n 0.6695 245249.9n 0.6695 245250.0n 0.4066 245499.9n 0.4066 245500.0n 0.6549 245749.9n 0.6549 245750.0n 0.4066 245999.9n 0.4066 246000.0n 0.5235 246249.9n 0.5235 246250.0n 0.4651 246499.9n 0.4651 246500.0n 0.4066 246749.9n 0.4066 246750.0n 0.5673 246999.9n 0.5673 247000.0n 0.7279 247249.9n 0.7279 247250.0n 0.7718 247499.9n 0.7718 247500.0n 0.5089 247749.9n 0.5089 247750.0n 0.6111 247999.9n 0.6111 248000.0n 0.5673 248249.9n 0.5673 248250.0n 0.5819 248499.9n 0.5819 248500.0n 0.6257 248749.9n 0.6257 248750.0n 0.4066 248999.9n 0.4066 249000.0n 0.5819 249249.9n 0.5819 249250.0n 0.4066 249499.9n 0.4066 249500.0n 0.4066 249749.9n 0.4066 249750.0n 0.4066 249999.9n 0.4066 250000.0n 0.6987 250249.9n 0.6987 250250.0n 0.6257 250499.9n 0.6257 250500.0n 0.4504 250749.9n 0.4504 250750.0n 0.4066 250999.9n 0.4066 251000.0n 0.4066 251249.9n 0.4066 251250.0n 0.4066 251499.9n 0.4066 251500.0n 0.4066 251749.9n 0.4066 251750.0n 0.5819 251999.9n 0.5819 252000.0n 0.7572 252249.9n 0.7572 252250.0n 0.4066 252499.9n 0.4066 252500.0n 0.6695 252749.9n 0.6695 252750.0n 0.4066 252999.9n 0.4066 253000.0n 0.6549 253249.9n 0.6549 253250.0n 0.4066 253499.9n 0.4066 253500.0n 0.5235 253749.9n 0.5235 253750.0n 0.4651 253999.9n 0.4651 254000.0n 0.4066 254249.9n 0.4066 254250.0n 0.5673 254499.9n 0.5673 254500.0n 0.7279 254749.9n 0.7279 254750.0n 0.7718 254999.9n 0.7718 255000.0n 0.5089 255249.9n 0.5089 255250.0n 0.6111 255499.9n 0.6111 255500.0n 0.5673 255749.9n 0.5673 255750.0n 0.5819 255999.9n 0.5819 256000.0n 0.6257 256249.9n 0.6257 256250.0n 0.4066 256499.9n 0.4066 256500.0n 0.5819 256749.9n 0.5819 256750.0n 0.4066 256999.9n 0.4066 257000.0n 0.4066 257249.9n 0.4066 257250.0n 0.4066 257499.9n 0.4066 257500.0n 0.6987 257749.9n 0.6987 257750.0n 0.6257 257999.9n 0.6257 258000.0n 0.4504 258249.9n 0.4504 258250.0n 0.4066 258499.9n 0.4066 258500.0n 0.4066 258749.9n 0.4066 258750.0n 0.4066 258999.9n 0.4066 259000.0n 0.4066 259249.9n 0.4066 259250.0n 0.5819 259499.9n 0.5819 259500.0n 0.7572 259749.9n 0.7572 259750.0n 0.4066 259999.9n 0.4066 260000.0n 0.6695 260249.9n 0.6695 260250.0n 0.4066 260499.9n 0.4066 260500.0n 0.6549 260749.9n 0.6549 260750.0n 0.4066 260999.9n 0.4066 261000.0n 0.5235 261249.9n 0.5235 261250.0n 0.4651 261499.9n 0.4651 261500.0n 0.4066 261749.9n 0.4066 261750.0n 0.5673 261999.9n 0.5673 262000.0n 0.7279 262249.9n 0.7279 262250.0n 0.7718 262499.9n 0.7718 262500.0n 0.5089 262749.9n 0.5089 262750.0n 0.6111 262999.9n 0.6111 263000.0n 0.5673 263249.9n 0.5673 263250.0n 0.5819 263499.9n 0.5819 263500.0n 0.6257 263749.9n 0.6257 263750.0n 0.4066 263999.9n 0.4066 264000.0n 0.5819 264249.9n 0.5819 264250.0n 0.4066 264499.9n 0.4066 264500.0n 0.4066 264749.9n 0.4066 264750.0n 0.4066 264999.9n 0.4066 265000.0n 0.6987 265249.9n 0.6987 265250.0n 0.6257 265499.9n 0.6257 265500.0n 0.4504 265749.9n 0.4504 265750.0n 0.4066 265999.9n 0.4066 266000.0n 0.4066 266249.9n 0.4066 266250.0n 0.4066 266499.9n 0.4066 266500.0n 0.4066 266749.9n 0.4066 266750.0n 0.5819 266999.9n 0.5819 267000.0n 0.7572 267249.9n 0.7572 267250.0n 0.4066 267499.9n 0.4066 267500.0n 0.6695 267749.9n 0.6695 267750.0n 0.4066 267999.9n 0.4066 268000.0n 0.6549 268249.9n 0.6549 268250.0n 0.4066 268499.9n 0.4066 268500.0n 0.5235 268749.9n 0.5235 268750.0n 0.4651 268999.9n 0.4651 269000.0n 0.4066 269249.9n 0.4066 269250.0n 0.5673 269499.9n 0.5673 269500.0n 0.7279 269749.9n 0.7279 269750.0n 0.7718 269999.9n 0.7718 270000.0n 0.5089 270249.9n 0.5089 270250.0n 0.6111 270499.9n 0.6111 270500.0n 0.5673 270749.9n 0.5673 270750.0n 0.5819 270999.9n 0.5819 271000.0n 0.6257 271249.9n 0.6257 271250.0n 0.4066 271499.9n 0.4066 271500.0n 0.5819 271749.9n 0.5819 271750.0n 0.4066 271999.9n 0.4066 272000.0n 0.4066 272249.9n 0.4066 272250.0n 0.4066 272499.9n 0.4066 272500.0n 0.6987 272749.9n 0.6987 272750.0n 0.6257 272999.9n 0.6257 273000.0n 0.4504 273249.9n 0.4504 273250.0n 0.4066 273499.9n 0.4066 273500.0n 0.4066 273749.9n 0.4066 273750.0n 0.4066 273999.9n 0.4066 274000.0n 0.4066 274249.9n 0.4066 274250.0n 0.5819 274499.9n 0.5819 274500.0n 0.7572 274749.9n 0.7572 274750.0n 0.4066 274999.9n 0.4066 275000.0n 0.6695 275249.9n 0.6695 275250.0n 0.4066 275499.9n 0.4066 275500.0n 0.6549 275749.9n 0.6549 275750.0n 0.4066 275999.9n 0.4066 276000.0n 0.5235 276249.9n 0.5235 276250.0n 0.4651 276499.9n 0.4651 276500.0n 0.4066 276749.9n 0.4066 276750.0n 0.5673 276999.9n 0.5673 277000.0n 0.7279 277249.9n 0.7279 277250.0n 0.7718 277499.9n 0.7718 277500.0n 0.5089 277749.9n 0.5089 277750.0n 0.6111 277999.9n 0.6111 278000.0n 0.5673 278249.9n 0.5673 278250.0n 0.5819 278499.9n 0.5819 278500.0n 0.6257 278749.9n 0.6257 278750.0n 0.4066 278999.9n 0.4066 279000.0n 0.5819 279249.9n 0.5819 279250.0n 0.4066 279499.9n 0.4066 279500.0n 0.4066 279749.9n 0.4066 279750.0n 0.4066 279999.9n 0.4066 280000.0n 0.6987 280249.9n 0.6987 280250.0n 0.6257 280499.9n 0.6257 280500.0n 0.4504 280749.9n 0.4504 280750.0n 0.4066 280999.9n 0.4066 281000.0n 0.4066 281249.9n 0.4066 281250.0n 0.4066 281499.9n 0.4066 281500.0n 0.4066 281749.9n 0.4066 281750.0n 0.5819 281999.9n 0.5819 282000.0n 0.7572 282249.9n 0.7572 282250.0n 0.4066 282499.9n 0.4066 282500.0n 0.6695 282749.9n 0.6695 282750.0n 0.4066 282999.9n 0.4066 283000.0n 0.6549 283249.9n 0.6549 283250.0n 0.4066 283499.9n 0.4066 283500.0n 0.5235 283749.9n 0.5235 283750.0n 0.4651 283999.9n 0.4651 284000.0n 0.4066 284249.9n 0.4066 284250.0n 0.5673 284499.9n 0.5673 284500.0n 0.7279 284749.9n 0.7279 284750.0n 0.7718 284999.9n 0.7718 285000.0n 0.5089 285249.9n 0.5089 285250.0n 0.6111 285499.9n 0.6111 285500.0n 0.5673 285749.9n 0.5673 285750.0n 0.5819 285999.9n 0.5819 286000.0n 0.6257 286249.9n 0.6257 286250.0n 0.4066 286499.9n 0.4066 286500.0n 0.5819 286749.9n 0.5819 286750.0n 0.4066 286999.9n 0.4066 287000.0n 0.4066 287249.9n 0.4066 287250.0n 0.4066 287499.9n 0.4066 287500.0n 0.6987 287749.9n 0.6987 287750.0n 0.6257 287999.9n 0.6257 288000.0n 0.4504 288249.9n 0.4504 288250.0n 0.4066 288499.9n 0.4066 288500.0n 0.4066 288749.9n 0.4066 288750.0n 0.4066 288999.9n 0.4066 289000.0n 0.4066 289249.9n 0.4066 289250.0n 0.5819 289499.9n 0.5819 289500.0n 0.7572 289749.9n 0.7572 289750.0n 0.4066 289999.9n 0.4066 290000.0n 0.6695 290249.9n 0.6695 290250.0n 0.4066 290499.9n 0.4066 290500.0n 0.6549 290749.9n 0.6549 290750.0n 0.4066 290999.9n 0.4066 291000.0n 0.5235 291249.9n 0.5235 291250.0n 0.4651 291499.9n 0.4651 291500.0n 0.4066 291749.9n 0.4066 291750.0n 0.5673 291999.9n 0.5673 292000.0n 0.7279 292249.9n 0.7279 292250.0n 0.7718 292499.9n 0.7718 292500.0n 0.5089 292749.9n 0.5089 292750.0n 0.6111 292999.9n 0.6111 293000.0n 0.5673 293249.9n 0.5673 293250.0n 0.5819 293499.9n 0.5819 293500.0n 0.6257 293749.9n 0.6257 293750.0n 0.4066 293999.9n 0.4066 294000.0n 0.5819 294249.9n 0.5819 294250.0n 0.4066 294499.9n 0.4066 294500.0n 0.4066 294749.9n 0.4066 294750.0n 0.4066 294999.9n 0.4066 295000.0n 0.6987 295249.9n 0.6987 295250.0n 0.6257 295499.9n 0.6257 295500.0n 0.4504 295749.9n 0.4504 295750.0n 0.4066 295999.9n 0.4066 296000.0n 0.4066 296249.9n 0.4066 296250.0n 0.4066 296499.9n 0.4066 296500.0n 0.4066 296749.9n 0.4066 296750.0n 0.5819 296999.9n 0.5819 297000.0n 0.7572 297249.9n 0.7572 297250.0n 0.4066 297499.9n 0.4066 297500.0n 0.6695 297749.9n 0.6695 297750.0n 0.4066 297999.9n 0.4066 298000.0n 0.6549 298249.9n 0.6549 298250.0n 0.4066 298499.9n 0.4066 298500.0n 0.5235 298749.9n 0.5235 298750.0n 0.4651 298999.9n 0.4651 299000.0n 0.4066 299249.9n 0.4066 299250.0n 0.5673 299499.9n 0.5673 299500.0n 0.7279 299749.9n 0.7279 299750.0n 0.7718)
Vxn11 a_xn11 0 PWL(0.0n 0.4911 249.9n 0.4911 250.0n 0.3889 499.9n 0.3889 500.0n 0.4327 749.9n 0.4327 750.0n 0.4181 999.9n 0.4181 1000.0n 0.3743 1249.9n 0.3743 1250.0n 0.5934 1499.9n 0.5934 1500.0n 0.4181 1749.9n 0.4181 1750.0n 0.5934 1999.9n 0.5934 2000.0n 0.5934 2249.9n 0.5934 2250.0n 0.5934 2499.9n 0.5934 2500.0n 0.3013 2749.9n 0.3013 2750.0n 0.3743 2999.9n 0.3743 3000.0n 0.5496 3249.9n 0.5496 3250.0n 0.5934 3499.9n 0.5934 3500.0n 0.5934 3749.9n 0.5934 3750.0n 0.5934 3999.9n 0.5934 4000.0n 0.5934 4249.9n 0.5934 4250.0n 0.4181 4499.9n 0.4181 4500.0n 0.2428 4749.9n 0.2428 4750.0n 0.5934 4999.9n 0.5934 5000.0n 0.3305 5249.9n 0.3305 5250.0n 0.5934 5499.9n 0.5934 5500.0n 0.3451 5749.9n 0.3451 5750.0n 0.5934 5999.9n 0.5934 6000.0n 0.4765 6249.9n 0.4765 6250.0n 0.5349 6499.9n 0.5349 6500.0n 0.5934 6749.9n 0.5934 6750.0n 0.4327 6999.9n 0.4327 7000.0n 0.2721 7249.9n 0.2721 7250.0n 0.2282 7499.9n 0.2282 7500.0n 0.4911 7749.9n 0.4911 7750.0n 0.3889 7999.9n 0.3889 8000.0n 0.4327 8249.9n 0.4327 8250.0n 0.4181 8499.9n 0.4181 8500.0n 0.3743 8749.9n 0.3743 8750.0n 0.5934 8999.9n 0.5934 9000.0n 0.4181 9249.9n 0.4181 9250.0n 0.5934 9499.9n 0.5934 9500.0n 0.5934 9749.9n 0.5934 9750.0n 0.5934 9999.9n 0.5934 10000.0n 0.3013 10249.9n 0.3013 10250.0n 0.3743 10499.9n 0.3743 10500.0n 0.5496 10749.9n 0.5496 10750.0n 0.5934 10999.9n 0.5934 11000.0n 0.5934 11249.9n 0.5934 11250.0n 0.5934 11499.9n 0.5934 11500.0n 0.5934 11749.9n 0.5934 11750.0n 0.4181 11999.9n 0.4181 12000.0n 0.2428 12249.9n 0.2428 12250.0n 0.5934 12499.9n 0.5934 12500.0n 0.3305 12749.9n 0.3305 12750.0n 0.5934 12999.9n 0.5934 13000.0n 0.3451 13249.9n 0.3451 13250.0n 0.5934 13499.9n 0.5934 13500.0n 0.4765 13749.9n 0.4765 13750.0n 0.5349 13999.9n 0.5349 14000.0n 0.5934 14249.9n 0.5934 14250.0n 0.4327 14499.9n 0.4327 14500.0n 0.2721 14749.9n 0.2721 14750.0n 0.2282 14999.9n 0.2282 15000.0n 0.4911 15249.9n 0.4911 15250.0n 0.3889 15499.9n 0.3889 15500.0n 0.4327 15749.9n 0.4327 15750.0n 0.4181 15999.9n 0.4181 16000.0n 0.3743 16249.9n 0.3743 16250.0n 0.5934 16499.9n 0.5934 16500.0n 0.4181 16749.9n 0.4181 16750.0n 0.5934 16999.9n 0.5934 17000.0n 0.5934 17249.9n 0.5934 17250.0n 0.5934 17499.9n 0.5934 17500.0n 0.3013 17749.9n 0.3013 17750.0n 0.3743 17999.9n 0.3743 18000.0n 0.5496 18249.9n 0.5496 18250.0n 0.5934 18499.9n 0.5934 18500.0n 0.5934 18749.9n 0.5934 18750.0n 0.5934 18999.9n 0.5934 19000.0n 0.5934 19249.9n 0.5934 19250.0n 0.4181 19499.9n 0.4181 19500.0n 0.2428 19749.9n 0.2428 19750.0n 0.5934 19999.9n 0.5934 20000.0n 0.3305 20249.9n 0.3305 20250.0n 0.5934 20499.9n 0.5934 20500.0n 0.3451 20749.9n 0.3451 20750.0n 0.5934 20999.9n 0.5934 21000.0n 0.4765 21249.9n 0.4765 21250.0n 0.5349 21499.9n 0.5349 21500.0n 0.5934 21749.9n 0.5934 21750.0n 0.4327 21999.9n 0.4327 22000.0n 0.2721 22249.9n 0.2721 22250.0n 0.2282 22499.9n 0.2282 22500.0n 0.4911 22749.9n 0.4911 22750.0n 0.3889 22999.9n 0.3889 23000.0n 0.4327 23249.9n 0.4327 23250.0n 0.4181 23499.9n 0.4181 23500.0n 0.3743 23749.9n 0.3743 23750.0n 0.5934 23999.9n 0.5934 24000.0n 0.4181 24249.9n 0.4181 24250.0n 0.5934 24499.9n 0.5934 24500.0n 0.5934 24749.9n 0.5934 24750.0n 0.5934 24999.9n 0.5934 25000.0n 0.3013 25249.9n 0.3013 25250.0n 0.3743 25499.9n 0.3743 25500.0n 0.5496 25749.9n 0.5496 25750.0n 0.5934 25999.9n 0.5934 26000.0n 0.5934 26249.9n 0.5934 26250.0n 0.5934 26499.9n 0.5934 26500.0n 0.5934 26749.9n 0.5934 26750.0n 0.4181 26999.9n 0.4181 27000.0n 0.2428 27249.9n 0.2428 27250.0n 0.5934 27499.9n 0.5934 27500.0n 0.3305 27749.9n 0.3305 27750.0n 0.5934 27999.9n 0.5934 28000.0n 0.3451 28249.9n 0.3451 28250.0n 0.5934 28499.9n 0.5934 28500.0n 0.4765 28749.9n 0.4765 28750.0n 0.5349 28999.9n 0.5349 29000.0n 0.5934 29249.9n 0.5934 29250.0n 0.4327 29499.9n 0.4327 29500.0n 0.2721 29749.9n 0.2721 29750.0n 0.2282 29999.9n 0.2282 30000.0n 0.4911 30249.9n 0.4911 30250.0n 0.3889 30499.9n 0.3889 30500.0n 0.4327 30749.9n 0.4327 30750.0n 0.4181 30999.9n 0.4181 31000.0n 0.3743 31249.9n 0.3743 31250.0n 0.5934 31499.9n 0.5934 31500.0n 0.4181 31749.9n 0.4181 31750.0n 0.5934 31999.9n 0.5934 32000.0n 0.5934 32249.9n 0.5934 32250.0n 0.5934 32499.9n 0.5934 32500.0n 0.3013 32749.9n 0.3013 32750.0n 0.3743 32999.9n 0.3743 33000.0n 0.5496 33249.9n 0.5496 33250.0n 0.5934 33499.9n 0.5934 33500.0n 0.5934 33749.9n 0.5934 33750.0n 0.5934 33999.9n 0.5934 34000.0n 0.5934 34249.9n 0.5934 34250.0n 0.4181 34499.9n 0.4181 34500.0n 0.2428 34749.9n 0.2428 34750.0n 0.5934 34999.9n 0.5934 35000.0n 0.3305 35249.9n 0.3305 35250.0n 0.5934 35499.9n 0.5934 35500.0n 0.3451 35749.9n 0.3451 35750.0n 0.5934 35999.9n 0.5934 36000.0n 0.4765 36249.9n 0.4765 36250.0n 0.5349 36499.9n 0.5349 36500.0n 0.5934 36749.9n 0.5934 36750.0n 0.4327 36999.9n 0.4327 37000.0n 0.2721 37249.9n 0.2721 37250.0n 0.2282 37499.9n 0.2282 37500.0n 0.4911 37749.9n 0.4911 37750.0n 0.3889 37999.9n 0.3889 38000.0n 0.4327 38249.9n 0.4327 38250.0n 0.4181 38499.9n 0.4181 38500.0n 0.3743 38749.9n 0.3743 38750.0n 0.5934 38999.9n 0.5934 39000.0n 0.4181 39249.9n 0.4181 39250.0n 0.5934 39499.9n 0.5934 39500.0n 0.5934 39749.9n 0.5934 39750.0n 0.5934 39999.9n 0.5934 40000.0n 0.3013 40249.9n 0.3013 40250.0n 0.3743 40499.9n 0.3743 40500.0n 0.5496 40749.9n 0.5496 40750.0n 0.5934 40999.9n 0.5934 41000.0n 0.5934 41249.9n 0.5934 41250.0n 0.5934 41499.9n 0.5934 41500.0n 0.5934 41749.9n 0.5934 41750.0n 0.4181 41999.9n 0.4181 42000.0n 0.2428 42249.9n 0.2428 42250.0n 0.5934 42499.9n 0.5934 42500.0n 0.3305 42749.9n 0.3305 42750.0n 0.5934 42999.9n 0.5934 43000.0n 0.3451 43249.9n 0.3451 43250.0n 0.5934 43499.9n 0.5934 43500.0n 0.4765 43749.9n 0.4765 43750.0n 0.5349 43999.9n 0.5349 44000.0n 0.5934 44249.9n 0.5934 44250.0n 0.4327 44499.9n 0.4327 44500.0n 0.2721 44749.9n 0.2721 44750.0n 0.2282 44999.9n 0.2282 45000.0n 0.4911 45249.9n 0.4911 45250.0n 0.3889 45499.9n 0.3889 45500.0n 0.4327 45749.9n 0.4327 45750.0n 0.4181 45999.9n 0.4181 46000.0n 0.3743 46249.9n 0.3743 46250.0n 0.5934 46499.9n 0.5934 46500.0n 0.4181 46749.9n 0.4181 46750.0n 0.5934 46999.9n 0.5934 47000.0n 0.5934 47249.9n 0.5934 47250.0n 0.5934 47499.9n 0.5934 47500.0n 0.3013 47749.9n 0.3013 47750.0n 0.3743 47999.9n 0.3743 48000.0n 0.5496 48249.9n 0.5496 48250.0n 0.5934 48499.9n 0.5934 48500.0n 0.5934 48749.9n 0.5934 48750.0n 0.5934 48999.9n 0.5934 49000.0n 0.5934 49249.9n 0.5934 49250.0n 0.4181 49499.9n 0.4181 49500.0n 0.2428 49749.9n 0.2428 49750.0n 0.5934 49999.9n 0.5934 50000.0n 0.3305 50249.9n 0.3305 50250.0n 0.5934 50499.9n 0.5934 50500.0n 0.3451 50749.9n 0.3451 50750.0n 0.5934 50999.9n 0.5934 51000.0n 0.4765 51249.9n 0.4765 51250.0n 0.5349 51499.9n 0.5349 51500.0n 0.5934 51749.9n 0.5934 51750.0n 0.4327 51999.9n 0.4327 52000.0n 0.2721 52249.9n 0.2721 52250.0n 0.2282 52499.9n 0.2282 52500.0n 0.4911 52749.9n 0.4911 52750.0n 0.3889 52999.9n 0.3889 53000.0n 0.4327 53249.9n 0.4327 53250.0n 0.4181 53499.9n 0.4181 53500.0n 0.3743 53749.9n 0.3743 53750.0n 0.5934 53999.9n 0.5934 54000.0n 0.4181 54249.9n 0.4181 54250.0n 0.5934 54499.9n 0.5934 54500.0n 0.5934 54749.9n 0.5934 54750.0n 0.5934 54999.9n 0.5934 55000.0n 0.3013 55249.9n 0.3013 55250.0n 0.3743 55499.9n 0.3743 55500.0n 0.5496 55749.9n 0.5496 55750.0n 0.5934 55999.9n 0.5934 56000.0n 0.5934 56249.9n 0.5934 56250.0n 0.5934 56499.9n 0.5934 56500.0n 0.5934 56749.9n 0.5934 56750.0n 0.4181 56999.9n 0.4181 57000.0n 0.2428 57249.9n 0.2428 57250.0n 0.5934 57499.9n 0.5934 57500.0n 0.3305 57749.9n 0.3305 57750.0n 0.5934 57999.9n 0.5934 58000.0n 0.3451 58249.9n 0.3451 58250.0n 0.5934 58499.9n 0.5934 58500.0n 0.4765 58749.9n 0.4765 58750.0n 0.5349 58999.9n 0.5349 59000.0n 0.5934 59249.9n 0.5934 59250.0n 0.4327 59499.9n 0.4327 59500.0n 0.2721 59749.9n 0.2721 59750.0n 0.2282 59999.9n 0.2282 60000.0n 0.4911 60249.9n 0.4911 60250.0n 0.3889 60499.9n 0.3889 60500.0n 0.4327 60749.9n 0.4327 60750.0n 0.4181 60999.9n 0.4181 61000.0n 0.3743 61249.9n 0.3743 61250.0n 0.5934 61499.9n 0.5934 61500.0n 0.4181 61749.9n 0.4181 61750.0n 0.5934 61999.9n 0.5934 62000.0n 0.5934 62249.9n 0.5934 62250.0n 0.5934 62499.9n 0.5934 62500.0n 0.3013 62749.9n 0.3013 62750.0n 0.3743 62999.9n 0.3743 63000.0n 0.5496 63249.9n 0.5496 63250.0n 0.5934 63499.9n 0.5934 63500.0n 0.5934 63749.9n 0.5934 63750.0n 0.5934 63999.9n 0.5934 64000.0n 0.5934 64249.9n 0.5934 64250.0n 0.4181 64499.9n 0.4181 64500.0n 0.2428 64749.9n 0.2428 64750.0n 0.5934 64999.9n 0.5934 65000.0n 0.3305 65249.9n 0.3305 65250.0n 0.5934 65499.9n 0.5934 65500.0n 0.3451 65749.9n 0.3451 65750.0n 0.5934 65999.9n 0.5934 66000.0n 0.4765 66249.9n 0.4765 66250.0n 0.5349 66499.9n 0.5349 66500.0n 0.5934 66749.9n 0.5934 66750.0n 0.4327 66999.9n 0.4327 67000.0n 0.2721 67249.9n 0.2721 67250.0n 0.2282 67499.9n 0.2282 67500.0n 0.4911 67749.9n 0.4911 67750.0n 0.3889 67999.9n 0.3889 68000.0n 0.4327 68249.9n 0.4327 68250.0n 0.4181 68499.9n 0.4181 68500.0n 0.3743 68749.9n 0.3743 68750.0n 0.5934 68999.9n 0.5934 69000.0n 0.4181 69249.9n 0.4181 69250.0n 0.5934 69499.9n 0.5934 69500.0n 0.5934 69749.9n 0.5934 69750.0n 0.5934 69999.9n 0.5934 70000.0n 0.3013 70249.9n 0.3013 70250.0n 0.3743 70499.9n 0.3743 70500.0n 0.5496 70749.9n 0.5496 70750.0n 0.5934 70999.9n 0.5934 71000.0n 0.5934 71249.9n 0.5934 71250.0n 0.5934 71499.9n 0.5934 71500.0n 0.5934 71749.9n 0.5934 71750.0n 0.4181 71999.9n 0.4181 72000.0n 0.2428 72249.9n 0.2428 72250.0n 0.5934 72499.9n 0.5934 72500.0n 0.3305 72749.9n 0.3305 72750.0n 0.5934 72999.9n 0.5934 73000.0n 0.3451 73249.9n 0.3451 73250.0n 0.5934 73499.9n 0.5934 73500.0n 0.4765 73749.9n 0.4765 73750.0n 0.5349 73999.9n 0.5349 74000.0n 0.5934 74249.9n 0.5934 74250.0n 0.4327 74499.9n 0.4327 74500.0n 0.2721 74749.9n 0.2721 74750.0n 0.2282 74999.9n 0.2282 75000.0n 0.4911 75249.9n 0.4911 75250.0n 0.3889 75499.9n 0.3889 75500.0n 0.4327 75749.9n 0.4327 75750.0n 0.4181 75999.9n 0.4181 76000.0n 0.3743 76249.9n 0.3743 76250.0n 0.5934 76499.9n 0.5934 76500.0n 0.4181 76749.9n 0.4181 76750.0n 0.5934 76999.9n 0.5934 77000.0n 0.5934 77249.9n 0.5934 77250.0n 0.5934 77499.9n 0.5934 77500.0n 0.3013 77749.9n 0.3013 77750.0n 0.3743 77999.9n 0.3743 78000.0n 0.5496 78249.9n 0.5496 78250.0n 0.5934 78499.9n 0.5934 78500.0n 0.5934 78749.9n 0.5934 78750.0n 0.5934 78999.9n 0.5934 79000.0n 0.5934 79249.9n 0.5934 79250.0n 0.4181 79499.9n 0.4181 79500.0n 0.2428 79749.9n 0.2428 79750.0n 0.5934 79999.9n 0.5934 80000.0n 0.3305 80249.9n 0.3305 80250.0n 0.5934 80499.9n 0.5934 80500.0n 0.3451 80749.9n 0.3451 80750.0n 0.5934 80999.9n 0.5934 81000.0n 0.4765 81249.9n 0.4765 81250.0n 0.5349 81499.9n 0.5349 81500.0n 0.5934 81749.9n 0.5934 81750.0n 0.4327 81999.9n 0.4327 82000.0n 0.2721 82249.9n 0.2721 82250.0n 0.2282 82499.9n 0.2282 82500.0n 0.4911 82749.9n 0.4911 82750.0n 0.3889 82999.9n 0.3889 83000.0n 0.4327 83249.9n 0.4327 83250.0n 0.4181 83499.9n 0.4181 83500.0n 0.3743 83749.9n 0.3743 83750.0n 0.5934 83999.9n 0.5934 84000.0n 0.4181 84249.9n 0.4181 84250.0n 0.5934 84499.9n 0.5934 84500.0n 0.5934 84749.9n 0.5934 84750.0n 0.5934 84999.9n 0.5934 85000.0n 0.3013 85249.9n 0.3013 85250.0n 0.3743 85499.9n 0.3743 85500.0n 0.5496 85749.9n 0.5496 85750.0n 0.5934 85999.9n 0.5934 86000.0n 0.5934 86249.9n 0.5934 86250.0n 0.5934 86499.9n 0.5934 86500.0n 0.5934 86749.9n 0.5934 86750.0n 0.4181 86999.9n 0.4181 87000.0n 0.2428 87249.9n 0.2428 87250.0n 0.5934 87499.9n 0.5934 87500.0n 0.3305 87749.9n 0.3305 87750.0n 0.5934 87999.9n 0.5934 88000.0n 0.3451 88249.9n 0.3451 88250.0n 0.5934 88499.9n 0.5934 88500.0n 0.4765 88749.9n 0.4765 88750.0n 0.5349 88999.9n 0.5349 89000.0n 0.5934 89249.9n 0.5934 89250.0n 0.4327 89499.9n 0.4327 89500.0n 0.2721 89749.9n 0.2721 89750.0n 0.2282 89999.9n 0.2282 90000.0n 0.4911 90249.9n 0.4911 90250.0n 0.3889 90499.9n 0.3889 90500.0n 0.4327 90749.9n 0.4327 90750.0n 0.4181 90999.9n 0.4181 91000.0n 0.3743 91249.9n 0.3743 91250.0n 0.5934 91499.9n 0.5934 91500.0n 0.4181 91749.9n 0.4181 91750.0n 0.5934 91999.9n 0.5934 92000.0n 0.5934 92249.9n 0.5934 92250.0n 0.5934 92499.9n 0.5934 92500.0n 0.3013 92749.9n 0.3013 92750.0n 0.3743 92999.9n 0.3743 93000.0n 0.5496 93249.9n 0.5496 93250.0n 0.5934 93499.9n 0.5934 93500.0n 0.5934 93749.9n 0.5934 93750.0n 0.5934 93999.9n 0.5934 94000.0n 0.5934 94249.9n 0.5934 94250.0n 0.4181 94499.9n 0.4181 94500.0n 0.2428 94749.9n 0.2428 94750.0n 0.5934 94999.9n 0.5934 95000.0n 0.3305 95249.9n 0.3305 95250.0n 0.5934 95499.9n 0.5934 95500.0n 0.3451 95749.9n 0.3451 95750.0n 0.5934 95999.9n 0.5934 96000.0n 0.4765 96249.9n 0.4765 96250.0n 0.5349 96499.9n 0.5349 96500.0n 0.5934 96749.9n 0.5934 96750.0n 0.4327 96999.9n 0.4327 97000.0n 0.2721 97249.9n 0.2721 97250.0n 0.2282 97499.9n 0.2282 97500.0n 0.4911 97749.9n 0.4911 97750.0n 0.3889 97999.9n 0.3889 98000.0n 0.4327 98249.9n 0.4327 98250.0n 0.4181 98499.9n 0.4181 98500.0n 0.3743 98749.9n 0.3743 98750.0n 0.5934 98999.9n 0.5934 99000.0n 0.4181 99249.9n 0.4181 99250.0n 0.5934 99499.9n 0.5934 99500.0n 0.5934 99749.9n 0.5934 99750.0n 0.5934 99999.9n 0.5934 100000.0n 0.3013 100249.9n 0.3013 100250.0n 0.3743 100499.9n 0.3743 100500.0n 0.5496 100749.9n 0.5496 100750.0n 0.5934 100999.9n 0.5934 101000.0n 0.5934 101249.9n 0.5934 101250.0n 0.5934 101499.9n 0.5934 101500.0n 0.5934 101749.9n 0.5934 101750.0n 0.4181 101999.9n 0.4181 102000.0n 0.2428 102249.9n 0.2428 102250.0n 0.5934 102499.9n 0.5934 102500.0n 0.3305 102749.9n 0.3305 102750.0n 0.5934 102999.9n 0.5934 103000.0n 0.3451 103249.9n 0.3451 103250.0n 0.5934 103499.9n 0.5934 103500.0n 0.4765 103749.9n 0.4765 103750.0n 0.5349 103999.9n 0.5349 104000.0n 0.5934 104249.9n 0.5934 104250.0n 0.4327 104499.9n 0.4327 104500.0n 0.2721 104749.9n 0.2721 104750.0n 0.2282 104999.9n 0.2282 105000.0n 0.4911 105249.9n 0.4911 105250.0n 0.3889 105499.9n 0.3889 105500.0n 0.4327 105749.9n 0.4327 105750.0n 0.4181 105999.9n 0.4181 106000.0n 0.3743 106249.9n 0.3743 106250.0n 0.5934 106499.9n 0.5934 106500.0n 0.4181 106749.9n 0.4181 106750.0n 0.5934 106999.9n 0.5934 107000.0n 0.5934 107249.9n 0.5934 107250.0n 0.5934 107499.9n 0.5934 107500.0n 0.3013 107749.9n 0.3013 107750.0n 0.3743 107999.9n 0.3743 108000.0n 0.5496 108249.9n 0.5496 108250.0n 0.5934 108499.9n 0.5934 108500.0n 0.5934 108749.9n 0.5934 108750.0n 0.5934 108999.9n 0.5934 109000.0n 0.5934 109249.9n 0.5934 109250.0n 0.4181 109499.9n 0.4181 109500.0n 0.2428 109749.9n 0.2428 109750.0n 0.5934 109999.9n 0.5934 110000.0n 0.3305 110249.9n 0.3305 110250.0n 0.5934 110499.9n 0.5934 110500.0n 0.3451 110749.9n 0.3451 110750.0n 0.5934 110999.9n 0.5934 111000.0n 0.4765 111249.9n 0.4765 111250.0n 0.5349 111499.9n 0.5349 111500.0n 0.5934 111749.9n 0.5934 111750.0n 0.4327 111999.9n 0.4327 112000.0n 0.2721 112249.9n 0.2721 112250.0n 0.2282 112499.9n 0.2282 112500.0n 0.4911 112749.9n 0.4911 112750.0n 0.3889 112999.9n 0.3889 113000.0n 0.4327 113249.9n 0.4327 113250.0n 0.4181 113499.9n 0.4181 113500.0n 0.3743 113749.9n 0.3743 113750.0n 0.5934 113999.9n 0.5934 114000.0n 0.4181 114249.9n 0.4181 114250.0n 0.5934 114499.9n 0.5934 114500.0n 0.5934 114749.9n 0.5934 114750.0n 0.5934 114999.9n 0.5934 115000.0n 0.3013 115249.9n 0.3013 115250.0n 0.3743 115499.9n 0.3743 115500.0n 0.5496 115749.9n 0.5496 115750.0n 0.5934 115999.9n 0.5934 116000.0n 0.5934 116249.9n 0.5934 116250.0n 0.5934 116499.9n 0.5934 116500.0n 0.5934 116749.9n 0.5934 116750.0n 0.4181 116999.9n 0.4181 117000.0n 0.2428 117249.9n 0.2428 117250.0n 0.5934 117499.9n 0.5934 117500.0n 0.3305 117749.9n 0.3305 117750.0n 0.5934 117999.9n 0.5934 118000.0n 0.3451 118249.9n 0.3451 118250.0n 0.5934 118499.9n 0.5934 118500.0n 0.4765 118749.9n 0.4765 118750.0n 0.5349 118999.9n 0.5349 119000.0n 0.5934 119249.9n 0.5934 119250.0n 0.4327 119499.9n 0.4327 119500.0n 0.2721 119749.9n 0.2721 119750.0n 0.2282 119999.9n 0.2282 120000.0n 0.4911 120249.9n 0.4911 120250.0n 0.3889 120499.9n 0.3889 120500.0n 0.4327 120749.9n 0.4327 120750.0n 0.4181 120999.9n 0.4181 121000.0n 0.3743 121249.9n 0.3743 121250.0n 0.5934 121499.9n 0.5934 121500.0n 0.4181 121749.9n 0.4181 121750.0n 0.5934 121999.9n 0.5934 122000.0n 0.5934 122249.9n 0.5934 122250.0n 0.5934 122499.9n 0.5934 122500.0n 0.3013 122749.9n 0.3013 122750.0n 0.3743 122999.9n 0.3743 123000.0n 0.5496 123249.9n 0.5496 123250.0n 0.5934 123499.9n 0.5934 123500.0n 0.5934 123749.9n 0.5934 123750.0n 0.5934 123999.9n 0.5934 124000.0n 0.5934 124249.9n 0.5934 124250.0n 0.4181 124499.9n 0.4181 124500.0n 0.2428 124749.9n 0.2428 124750.0n 0.5934 124999.9n 0.5934 125000.0n 0.3305 125249.9n 0.3305 125250.0n 0.5934 125499.9n 0.5934 125500.0n 0.3451 125749.9n 0.3451 125750.0n 0.5934 125999.9n 0.5934 126000.0n 0.4765 126249.9n 0.4765 126250.0n 0.5349 126499.9n 0.5349 126500.0n 0.5934 126749.9n 0.5934 126750.0n 0.4327 126999.9n 0.4327 127000.0n 0.2721 127249.9n 0.2721 127250.0n 0.2282 127499.9n 0.2282 127500.0n 0.4911 127749.9n 0.4911 127750.0n 0.3889 127999.9n 0.3889 128000.0n 0.4327 128249.9n 0.4327 128250.0n 0.4181 128499.9n 0.4181 128500.0n 0.3743 128749.9n 0.3743 128750.0n 0.5934 128999.9n 0.5934 129000.0n 0.4181 129249.9n 0.4181 129250.0n 0.5934 129499.9n 0.5934 129500.0n 0.5934 129749.9n 0.5934 129750.0n 0.5934 129999.9n 0.5934 130000.0n 0.3013 130249.9n 0.3013 130250.0n 0.3743 130499.9n 0.3743 130500.0n 0.5496 130749.9n 0.5496 130750.0n 0.5934 130999.9n 0.5934 131000.0n 0.5934 131249.9n 0.5934 131250.0n 0.5934 131499.9n 0.5934 131500.0n 0.5934 131749.9n 0.5934 131750.0n 0.4181 131999.9n 0.4181 132000.0n 0.2428 132249.9n 0.2428 132250.0n 0.5934 132499.9n 0.5934 132500.0n 0.3305 132749.9n 0.3305 132750.0n 0.5934 132999.9n 0.5934 133000.0n 0.3451 133249.9n 0.3451 133250.0n 0.5934 133499.9n 0.5934 133500.0n 0.4765 133749.9n 0.4765 133750.0n 0.5349 133999.9n 0.5349 134000.0n 0.5934 134249.9n 0.5934 134250.0n 0.4327 134499.9n 0.4327 134500.0n 0.2721 134749.9n 0.2721 134750.0n 0.2282 134999.9n 0.2282 135000.0n 0.4911 135249.9n 0.4911 135250.0n 0.3889 135499.9n 0.3889 135500.0n 0.4327 135749.9n 0.4327 135750.0n 0.4181 135999.9n 0.4181 136000.0n 0.3743 136249.9n 0.3743 136250.0n 0.5934 136499.9n 0.5934 136500.0n 0.4181 136749.9n 0.4181 136750.0n 0.5934 136999.9n 0.5934 137000.0n 0.5934 137249.9n 0.5934 137250.0n 0.5934 137499.9n 0.5934 137500.0n 0.3013 137749.9n 0.3013 137750.0n 0.3743 137999.9n 0.3743 138000.0n 0.5496 138249.9n 0.5496 138250.0n 0.5934 138499.9n 0.5934 138500.0n 0.5934 138749.9n 0.5934 138750.0n 0.5934 138999.9n 0.5934 139000.0n 0.5934 139249.9n 0.5934 139250.0n 0.4181 139499.9n 0.4181 139500.0n 0.2428 139749.9n 0.2428 139750.0n 0.5934 139999.9n 0.5934 140000.0n 0.3305 140249.9n 0.3305 140250.0n 0.5934 140499.9n 0.5934 140500.0n 0.3451 140749.9n 0.3451 140750.0n 0.5934 140999.9n 0.5934 141000.0n 0.4765 141249.9n 0.4765 141250.0n 0.5349 141499.9n 0.5349 141500.0n 0.5934 141749.9n 0.5934 141750.0n 0.4327 141999.9n 0.4327 142000.0n 0.2721 142249.9n 0.2721 142250.0n 0.2282 142499.9n 0.2282 142500.0n 0.4911 142749.9n 0.4911 142750.0n 0.3889 142999.9n 0.3889 143000.0n 0.4327 143249.9n 0.4327 143250.0n 0.4181 143499.9n 0.4181 143500.0n 0.3743 143749.9n 0.3743 143750.0n 0.5934 143999.9n 0.5934 144000.0n 0.4181 144249.9n 0.4181 144250.0n 0.5934 144499.9n 0.5934 144500.0n 0.5934 144749.9n 0.5934 144750.0n 0.5934 144999.9n 0.5934 145000.0n 0.3013 145249.9n 0.3013 145250.0n 0.3743 145499.9n 0.3743 145500.0n 0.5496 145749.9n 0.5496 145750.0n 0.5934 145999.9n 0.5934 146000.0n 0.5934 146249.9n 0.5934 146250.0n 0.5934 146499.9n 0.5934 146500.0n 0.5934 146749.9n 0.5934 146750.0n 0.4181 146999.9n 0.4181 147000.0n 0.2428 147249.9n 0.2428 147250.0n 0.5934 147499.9n 0.5934 147500.0n 0.3305 147749.9n 0.3305 147750.0n 0.5934 147999.9n 0.5934 148000.0n 0.3451 148249.9n 0.3451 148250.0n 0.5934 148499.9n 0.5934 148500.0n 0.4765 148749.9n 0.4765 148750.0n 0.5349 148999.9n 0.5349 149000.0n 0.5934 149249.9n 0.5934 149250.0n 0.4327 149499.9n 0.4327 149500.0n 0.2721 149749.9n 0.2721 149750.0n 0.2282 149999.9n 0.2282 150000.0n 0.4911 150249.9n 0.4911 150250.0n 0.3889 150499.9n 0.3889 150500.0n 0.4327 150749.9n 0.4327 150750.0n 0.4181 150999.9n 0.4181 151000.0n 0.3743 151249.9n 0.3743 151250.0n 0.5934 151499.9n 0.5934 151500.0n 0.4181 151749.9n 0.4181 151750.0n 0.5934 151999.9n 0.5934 152000.0n 0.5934 152249.9n 0.5934 152250.0n 0.5934 152499.9n 0.5934 152500.0n 0.3013 152749.9n 0.3013 152750.0n 0.3743 152999.9n 0.3743 153000.0n 0.5496 153249.9n 0.5496 153250.0n 0.5934 153499.9n 0.5934 153500.0n 0.5934 153749.9n 0.5934 153750.0n 0.5934 153999.9n 0.5934 154000.0n 0.5934 154249.9n 0.5934 154250.0n 0.4181 154499.9n 0.4181 154500.0n 0.2428 154749.9n 0.2428 154750.0n 0.5934 154999.9n 0.5934 155000.0n 0.3305 155249.9n 0.3305 155250.0n 0.5934 155499.9n 0.5934 155500.0n 0.3451 155749.9n 0.3451 155750.0n 0.5934 155999.9n 0.5934 156000.0n 0.4765 156249.9n 0.4765 156250.0n 0.5349 156499.9n 0.5349 156500.0n 0.5934 156749.9n 0.5934 156750.0n 0.4327 156999.9n 0.4327 157000.0n 0.2721 157249.9n 0.2721 157250.0n 0.2282 157499.9n 0.2282 157500.0n 0.4911 157749.9n 0.4911 157750.0n 0.3889 157999.9n 0.3889 158000.0n 0.4327 158249.9n 0.4327 158250.0n 0.4181 158499.9n 0.4181 158500.0n 0.3743 158749.9n 0.3743 158750.0n 0.5934 158999.9n 0.5934 159000.0n 0.4181 159249.9n 0.4181 159250.0n 0.5934 159499.9n 0.5934 159500.0n 0.5934 159749.9n 0.5934 159750.0n 0.5934 159999.9n 0.5934 160000.0n 0.3013 160249.9n 0.3013 160250.0n 0.3743 160499.9n 0.3743 160500.0n 0.5496 160749.9n 0.5496 160750.0n 0.5934 160999.9n 0.5934 161000.0n 0.5934 161249.9n 0.5934 161250.0n 0.5934 161499.9n 0.5934 161500.0n 0.5934 161749.9n 0.5934 161750.0n 0.4181 161999.9n 0.4181 162000.0n 0.2428 162249.9n 0.2428 162250.0n 0.5934 162499.9n 0.5934 162500.0n 0.3305 162749.9n 0.3305 162750.0n 0.5934 162999.9n 0.5934 163000.0n 0.3451 163249.9n 0.3451 163250.0n 0.5934 163499.9n 0.5934 163500.0n 0.4765 163749.9n 0.4765 163750.0n 0.5349 163999.9n 0.5349 164000.0n 0.5934 164249.9n 0.5934 164250.0n 0.4327 164499.9n 0.4327 164500.0n 0.2721 164749.9n 0.2721 164750.0n 0.2282 164999.9n 0.2282 165000.0n 0.4911 165249.9n 0.4911 165250.0n 0.3889 165499.9n 0.3889 165500.0n 0.4327 165749.9n 0.4327 165750.0n 0.4181 165999.9n 0.4181 166000.0n 0.3743 166249.9n 0.3743 166250.0n 0.5934 166499.9n 0.5934 166500.0n 0.4181 166749.9n 0.4181 166750.0n 0.5934 166999.9n 0.5934 167000.0n 0.5934 167249.9n 0.5934 167250.0n 0.5934 167499.9n 0.5934 167500.0n 0.3013 167749.9n 0.3013 167750.0n 0.3743 167999.9n 0.3743 168000.0n 0.5496 168249.9n 0.5496 168250.0n 0.5934 168499.9n 0.5934 168500.0n 0.5934 168749.9n 0.5934 168750.0n 0.5934 168999.9n 0.5934 169000.0n 0.5934 169249.9n 0.5934 169250.0n 0.4181 169499.9n 0.4181 169500.0n 0.2428 169749.9n 0.2428 169750.0n 0.5934 169999.9n 0.5934 170000.0n 0.3305 170249.9n 0.3305 170250.0n 0.5934 170499.9n 0.5934 170500.0n 0.3451 170749.9n 0.3451 170750.0n 0.5934 170999.9n 0.5934 171000.0n 0.4765 171249.9n 0.4765 171250.0n 0.5349 171499.9n 0.5349 171500.0n 0.5934 171749.9n 0.5934 171750.0n 0.4327 171999.9n 0.4327 172000.0n 0.2721 172249.9n 0.2721 172250.0n 0.2282 172499.9n 0.2282 172500.0n 0.4911 172749.9n 0.4911 172750.0n 0.3889 172999.9n 0.3889 173000.0n 0.4327 173249.9n 0.4327 173250.0n 0.4181 173499.9n 0.4181 173500.0n 0.3743 173749.9n 0.3743 173750.0n 0.5934 173999.9n 0.5934 174000.0n 0.4181 174249.9n 0.4181 174250.0n 0.5934 174499.9n 0.5934 174500.0n 0.5934 174749.9n 0.5934 174750.0n 0.5934 174999.9n 0.5934 175000.0n 0.3013 175249.9n 0.3013 175250.0n 0.3743 175499.9n 0.3743 175500.0n 0.5496 175749.9n 0.5496 175750.0n 0.5934 175999.9n 0.5934 176000.0n 0.5934 176249.9n 0.5934 176250.0n 0.5934 176499.9n 0.5934 176500.0n 0.5934 176749.9n 0.5934 176750.0n 0.4181 176999.9n 0.4181 177000.0n 0.2428 177249.9n 0.2428 177250.0n 0.5934 177499.9n 0.5934 177500.0n 0.3305 177749.9n 0.3305 177750.0n 0.5934 177999.9n 0.5934 178000.0n 0.3451 178249.9n 0.3451 178250.0n 0.5934 178499.9n 0.5934 178500.0n 0.4765 178749.9n 0.4765 178750.0n 0.5349 178999.9n 0.5349 179000.0n 0.5934 179249.9n 0.5934 179250.0n 0.4327 179499.9n 0.4327 179500.0n 0.2721 179749.9n 0.2721 179750.0n 0.2282 179999.9n 0.2282 180000.0n 0.4911 180249.9n 0.4911 180250.0n 0.3889 180499.9n 0.3889 180500.0n 0.4327 180749.9n 0.4327 180750.0n 0.4181 180999.9n 0.4181 181000.0n 0.3743 181249.9n 0.3743 181250.0n 0.5934 181499.9n 0.5934 181500.0n 0.4181 181749.9n 0.4181 181750.0n 0.5934 181999.9n 0.5934 182000.0n 0.5934 182249.9n 0.5934 182250.0n 0.5934 182499.9n 0.5934 182500.0n 0.3013 182749.9n 0.3013 182750.0n 0.3743 182999.9n 0.3743 183000.0n 0.5496 183249.9n 0.5496 183250.0n 0.5934 183499.9n 0.5934 183500.0n 0.5934 183749.9n 0.5934 183750.0n 0.5934 183999.9n 0.5934 184000.0n 0.5934 184249.9n 0.5934 184250.0n 0.4181 184499.9n 0.4181 184500.0n 0.2428 184749.9n 0.2428 184750.0n 0.5934 184999.9n 0.5934 185000.0n 0.3305 185249.9n 0.3305 185250.0n 0.5934 185499.9n 0.5934 185500.0n 0.3451 185749.9n 0.3451 185750.0n 0.5934 185999.9n 0.5934 186000.0n 0.4765 186249.9n 0.4765 186250.0n 0.5349 186499.9n 0.5349 186500.0n 0.5934 186749.9n 0.5934 186750.0n 0.4327 186999.9n 0.4327 187000.0n 0.2721 187249.9n 0.2721 187250.0n 0.2282 187499.9n 0.2282 187500.0n 0.4911 187749.9n 0.4911 187750.0n 0.3889 187999.9n 0.3889 188000.0n 0.4327 188249.9n 0.4327 188250.0n 0.4181 188499.9n 0.4181 188500.0n 0.3743 188749.9n 0.3743 188750.0n 0.5934 188999.9n 0.5934 189000.0n 0.4181 189249.9n 0.4181 189250.0n 0.5934 189499.9n 0.5934 189500.0n 0.5934 189749.9n 0.5934 189750.0n 0.5934 189999.9n 0.5934 190000.0n 0.3013 190249.9n 0.3013 190250.0n 0.3743 190499.9n 0.3743 190500.0n 0.5496 190749.9n 0.5496 190750.0n 0.5934 190999.9n 0.5934 191000.0n 0.5934 191249.9n 0.5934 191250.0n 0.5934 191499.9n 0.5934 191500.0n 0.5934 191749.9n 0.5934 191750.0n 0.4181 191999.9n 0.4181 192000.0n 0.2428 192249.9n 0.2428 192250.0n 0.5934 192499.9n 0.5934 192500.0n 0.3305 192749.9n 0.3305 192750.0n 0.5934 192999.9n 0.5934 193000.0n 0.3451 193249.9n 0.3451 193250.0n 0.5934 193499.9n 0.5934 193500.0n 0.4765 193749.9n 0.4765 193750.0n 0.5349 193999.9n 0.5349 194000.0n 0.5934 194249.9n 0.5934 194250.0n 0.4327 194499.9n 0.4327 194500.0n 0.2721 194749.9n 0.2721 194750.0n 0.2282 194999.9n 0.2282 195000.0n 0.4911 195249.9n 0.4911 195250.0n 0.3889 195499.9n 0.3889 195500.0n 0.4327 195749.9n 0.4327 195750.0n 0.4181 195999.9n 0.4181 196000.0n 0.3743 196249.9n 0.3743 196250.0n 0.5934 196499.9n 0.5934 196500.0n 0.4181 196749.9n 0.4181 196750.0n 0.5934 196999.9n 0.5934 197000.0n 0.5934 197249.9n 0.5934 197250.0n 0.5934 197499.9n 0.5934 197500.0n 0.3013 197749.9n 0.3013 197750.0n 0.3743 197999.9n 0.3743 198000.0n 0.5496 198249.9n 0.5496 198250.0n 0.5934 198499.9n 0.5934 198500.0n 0.5934 198749.9n 0.5934 198750.0n 0.5934 198999.9n 0.5934 199000.0n 0.5934 199249.9n 0.5934 199250.0n 0.4181 199499.9n 0.4181 199500.0n 0.2428 199749.9n 0.2428 199750.0n 0.5934 199999.9n 0.5934 200000.0n 0.3305 200249.9n 0.3305 200250.0n 0.5934 200499.9n 0.5934 200500.0n 0.3451 200749.9n 0.3451 200750.0n 0.5934 200999.9n 0.5934 201000.0n 0.4765 201249.9n 0.4765 201250.0n 0.5349 201499.9n 0.5349 201500.0n 0.5934 201749.9n 0.5934 201750.0n 0.4327 201999.9n 0.4327 202000.0n 0.2721 202249.9n 0.2721 202250.0n 0.2282 202499.9n 0.2282 202500.0n 0.4911 202749.9n 0.4911 202750.0n 0.3889 202999.9n 0.3889 203000.0n 0.4327 203249.9n 0.4327 203250.0n 0.4181 203499.9n 0.4181 203500.0n 0.3743 203749.9n 0.3743 203750.0n 0.5934 203999.9n 0.5934 204000.0n 0.4181 204249.9n 0.4181 204250.0n 0.5934 204499.9n 0.5934 204500.0n 0.5934 204749.9n 0.5934 204750.0n 0.5934 204999.9n 0.5934 205000.0n 0.3013 205249.9n 0.3013 205250.0n 0.3743 205499.9n 0.3743 205500.0n 0.5496 205749.9n 0.5496 205750.0n 0.5934 205999.9n 0.5934 206000.0n 0.5934 206249.9n 0.5934 206250.0n 0.5934 206499.9n 0.5934 206500.0n 0.5934 206749.9n 0.5934 206750.0n 0.4181 206999.9n 0.4181 207000.0n 0.2428 207249.9n 0.2428 207250.0n 0.5934 207499.9n 0.5934 207500.0n 0.3305 207749.9n 0.3305 207750.0n 0.5934 207999.9n 0.5934 208000.0n 0.3451 208249.9n 0.3451 208250.0n 0.5934 208499.9n 0.5934 208500.0n 0.4765 208749.9n 0.4765 208750.0n 0.5349 208999.9n 0.5349 209000.0n 0.5934 209249.9n 0.5934 209250.0n 0.4327 209499.9n 0.4327 209500.0n 0.2721 209749.9n 0.2721 209750.0n 0.2282 209999.9n 0.2282 210000.0n 0.4911 210249.9n 0.4911 210250.0n 0.3889 210499.9n 0.3889 210500.0n 0.4327 210749.9n 0.4327 210750.0n 0.4181 210999.9n 0.4181 211000.0n 0.3743 211249.9n 0.3743 211250.0n 0.5934 211499.9n 0.5934 211500.0n 0.4181 211749.9n 0.4181 211750.0n 0.5934 211999.9n 0.5934 212000.0n 0.5934 212249.9n 0.5934 212250.0n 0.5934 212499.9n 0.5934 212500.0n 0.3013 212749.9n 0.3013 212750.0n 0.3743 212999.9n 0.3743 213000.0n 0.5496 213249.9n 0.5496 213250.0n 0.5934 213499.9n 0.5934 213500.0n 0.5934 213749.9n 0.5934 213750.0n 0.5934 213999.9n 0.5934 214000.0n 0.5934 214249.9n 0.5934 214250.0n 0.4181 214499.9n 0.4181 214500.0n 0.2428 214749.9n 0.2428 214750.0n 0.5934 214999.9n 0.5934 215000.0n 0.3305 215249.9n 0.3305 215250.0n 0.5934 215499.9n 0.5934 215500.0n 0.3451 215749.9n 0.3451 215750.0n 0.5934 215999.9n 0.5934 216000.0n 0.4765 216249.9n 0.4765 216250.0n 0.5349 216499.9n 0.5349 216500.0n 0.5934 216749.9n 0.5934 216750.0n 0.4327 216999.9n 0.4327 217000.0n 0.2721 217249.9n 0.2721 217250.0n 0.2282 217499.9n 0.2282 217500.0n 0.4911 217749.9n 0.4911 217750.0n 0.3889 217999.9n 0.3889 218000.0n 0.4327 218249.9n 0.4327 218250.0n 0.4181 218499.9n 0.4181 218500.0n 0.3743 218749.9n 0.3743 218750.0n 0.5934 218999.9n 0.5934 219000.0n 0.4181 219249.9n 0.4181 219250.0n 0.5934 219499.9n 0.5934 219500.0n 0.5934 219749.9n 0.5934 219750.0n 0.5934 219999.9n 0.5934 220000.0n 0.3013 220249.9n 0.3013 220250.0n 0.3743 220499.9n 0.3743 220500.0n 0.5496 220749.9n 0.5496 220750.0n 0.5934 220999.9n 0.5934 221000.0n 0.5934 221249.9n 0.5934 221250.0n 0.5934 221499.9n 0.5934 221500.0n 0.5934 221749.9n 0.5934 221750.0n 0.4181 221999.9n 0.4181 222000.0n 0.2428 222249.9n 0.2428 222250.0n 0.5934 222499.9n 0.5934 222500.0n 0.3305 222749.9n 0.3305 222750.0n 0.5934 222999.9n 0.5934 223000.0n 0.3451 223249.9n 0.3451 223250.0n 0.5934 223499.9n 0.5934 223500.0n 0.4765 223749.9n 0.4765 223750.0n 0.5349 223999.9n 0.5349 224000.0n 0.5934 224249.9n 0.5934 224250.0n 0.4327 224499.9n 0.4327 224500.0n 0.2721 224749.9n 0.2721 224750.0n 0.2282 224999.9n 0.2282 225000.0n 0.4911 225249.9n 0.4911 225250.0n 0.3889 225499.9n 0.3889 225500.0n 0.4327 225749.9n 0.4327 225750.0n 0.4181 225999.9n 0.4181 226000.0n 0.3743 226249.9n 0.3743 226250.0n 0.5934 226499.9n 0.5934 226500.0n 0.4181 226749.9n 0.4181 226750.0n 0.5934 226999.9n 0.5934 227000.0n 0.5934 227249.9n 0.5934 227250.0n 0.5934 227499.9n 0.5934 227500.0n 0.3013 227749.9n 0.3013 227750.0n 0.3743 227999.9n 0.3743 228000.0n 0.5496 228249.9n 0.5496 228250.0n 0.5934 228499.9n 0.5934 228500.0n 0.5934 228749.9n 0.5934 228750.0n 0.5934 228999.9n 0.5934 229000.0n 0.5934 229249.9n 0.5934 229250.0n 0.4181 229499.9n 0.4181 229500.0n 0.2428 229749.9n 0.2428 229750.0n 0.5934 229999.9n 0.5934 230000.0n 0.3305 230249.9n 0.3305 230250.0n 0.5934 230499.9n 0.5934 230500.0n 0.3451 230749.9n 0.3451 230750.0n 0.5934 230999.9n 0.5934 231000.0n 0.4765 231249.9n 0.4765 231250.0n 0.5349 231499.9n 0.5349 231500.0n 0.5934 231749.9n 0.5934 231750.0n 0.4327 231999.9n 0.4327 232000.0n 0.2721 232249.9n 0.2721 232250.0n 0.2282 232499.9n 0.2282 232500.0n 0.4911 232749.9n 0.4911 232750.0n 0.3889 232999.9n 0.3889 233000.0n 0.4327 233249.9n 0.4327 233250.0n 0.4181 233499.9n 0.4181 233500.0n 0.3743 233749.9n 0.3743 233750.0n 0.5934 233999.9n 0.5934 234000.0n 0.4181 234249.9n 0.4181 234250.0n 0.5934 234499.9n 0.5934 234500.0n 0.5934 234749.9n 0.5934 234750.0n 0.5934 234999.9n 0.5934 235000.0n 0.3013 235249.9n 0.3013 235250.0n 0.3743 235499.9n 0.3743 235500.0n 0.5496 235749.9n 0.5496 235750.0n 0.5934 235999.9n 0.5934 236000.0n 0.5934 236249.9n 0.5934 236250.0n 0.5934 236499.9n 0.5934 236500.0n 0.5934 236749.9n 0.5934 236750.0n 0.4181 236999.9n 0.4181 237000.0n 0.2428 237249.9n 0.2428 237250.0n 0.5934 237499.9n 0.5934 237500.0n 0.3305 237749.9n 0.3305 237750.0n 0.5934 237999.9n 0.5934 238000.0n 0.3451 238249.9n 0.3451 238250.0n 0.5934 238499.9n 0.5934 238500.0n 0.4765 238749.9n 0.4765 238750.0n 0.5349 238999.9n 0.5349 239000.0n 0.5934 239249.9n 0.5934 239250.0n 0.4327 239499.9n 0.4327 239500.0n 0.2721 239749.9n 0.2721 239750.0n 0.2282 239999.9n 0.2282 240000.0n 0.4911 240249.9n 0.4911 240250.0n 0.3889 240499.9n 0.3889 240500.0n 0.4327 240749.9n 0.4327 240750.0n 0.4181 240999.9n 0.4181 241000.0n 0.3743 241249.9n 0.3743 241250.0n 0.5934 241499.9n 0.5934 241500.0n 0.4181 241749.9n 0.4181 241750.0n 0.5934 241999.9n 0.5934 242000.0n 0.5934 242249.9n 0.5934 242250.0n 0.5934 242499.9n 0.5934 242500.0n 0.3013 242749.9n 0.3013 242750.0n 0.3743 242999.9n 0.3743 243000.0n 0.5496 243249.9n 0.5496 243250.0n 0.5934 243499.9n 0.5934 243500.0n 0.5934 243749.9n 0.5934 243750.0n 0.5934 243999.9n 0.5934 244000.0n 0.5934 244249.9n 0.5934 244250.0n 0.4181 244499.9n 0.4181 244500.0n 0.2428 244749.9n 0.2428 244750.0n 0.5934 244999.9n 0.5934 245000.0n 0.3305 245249.9n 0.3305 245250.0n 0.5934 245499.9n 0.5934 245500.0n 0.3451 245749.9n 0.3451 245750.0n 0.5934 245999.9n 0.5934 246000.0n 0.4765 246249.9n 0.4765 246250.0n 0.5349 246499.9n 0.5349 246500.0n 0.5934 246749.9n 0.5934 246750.0n 0.4327 246999.9n 0.4327 247000.0n 0.2721 247249.9n 0.2721 247250.0n 0.2282 247499.9n 0.2282 247500.0n 0.4911 247749.9n 0.4911 247750.0n 0.3889 247999.9n 0.3889 248000.0n 0.4327 248249.9n 0.4327 248250.0n 0.4181 248499.9n 0.4181 248500.0n 0.3743 248749.9n 0.3743 248750.0n 0.5934 248999.9n 0.5934 249000.0n 0.4181 249249.9n 0.4181 249250.0n 0.5934 249499.9n 0.5934 249500.0n 0.5934 249749.9n 0.5934 249750.0n 0.5934 249999.9n 0.5934 250000.0n 0.3013 250249.9n 0.3013 250250.0n 0.3743 250499.9n 0.3743 250500.0n 0.5496 250749.9n 0.5496 250750.0n 0.5934 250999.9n 0.5934 251000.0n 0.5934 251249.9n 0.5934 251250.0n 0.5934 251499.9n 0.5934 251500.0n 0.5934 251749.9n 0.5934 251750.0n 0.4181 251999.9n 0.4181 252000.0n 0.2428 252249.9n 0.2428 252250.0n 0.5934 252499.9n 0.5934 252500.0n 0.3305 252749.9n 0.3305 252750.0n 0.5934 252999.9n 0.5934 253000.0n 0.3451 253249.9n 0.3451 253250.0n 0.5934 253499.9n 0.5934 253500.0n 0.4765 253749.9n 0.4765 253750.0n 0.5349 253999.9n 0.5349 254000.0n 0.5934 254249.9n 0.5934 254250.0n 0.4327 254499.9n 0.4327 254500.0n 0.2721 254749.9n 0.2721 254750.0n 0.2282 254999.9n 0.2282 255000.0n 0.4911 255249.9n 0.4911 255250.0n 0.3889 255499.9n 0.3889 255500.0n 0.4327 255749.9n 0.4327 255750.0n 0.4181 255999.9n 0.4181 256000.0n 0.3743 256249.9n 0.3743 256250.0n 0.5934 256499.9n 0.5934 256500.0n 0.4181 256749.9n 0.4181 256750.0n 0.5934 256999.9n 0.5934 257000.0n 0.5934 257249.9n 0.5934 257250.0n 0.5934 257499.9n 0.5934 257500.0n 0.3013 257749.9n 0.3013 257750.0n 0.3743 257999.9n 0.3743 258000.0n 0.5496 258249.9n 0.5496 258250.0n 0.5934 258499.9n 0.5934 258500.0n 0.5934 258749.9n 0.5934 258750.0n 0.5934 258999.9n 0.5934 259000.0n 0.5934 259249.9n 0.5934 259250.0n 0.4181 259499.9n 0.4181 259500.0n 0.2428 259749.9n 0.2428 259750.0n 0.5934 259999.9n 0.5934 260000.0n 0.3305 260249.9n 0.3305 260250.0n 0.5934 260499.9n 0.5934 260500.0n 0.3451 260749.9n 0.3451 260750.0n 0.5934 260999.9n 0.5934 261000.0n 0.4765 261249.9n 0.4765 261250.0n 0.5349 261499.9n 0.5349 261500.0n 0.5934 261749.9n 0.5934 261750.0n 0.4327 261999.9n 0.4327 262000.0n 0.2721 262249.9n 0.2721 262250.0n 0.2282 262499.9n 0.2282 262500.0n 0.4911 262749.9n 0.4911 262750.0n 0.3889 262999.9n 0.3889 263000.0n 0.4327 263249.9n 0.4327 263250.0n 0.4181 263499.9n 0.4181 263500.0n 0.3743 263749.9n 0.3743 263750.0n 0.5934 263999.9n 0.5934 264000.0n 0.4181 264249.9n 0.4181 264250.0n 0.5934 264499.9n 0.5934 264500.0n 0.5934 264749.9n 0.5934 264750.0n 0.5934 264999.9n 0.5934 265000.0n 0.3013 265249.9n 0.3013 265250.0n 0.3743 265499.9n 0.3743 265500.0n 0.5496 265749.9n 0.5496 265750.0n 0.5934 265999.9n 0.5934 266000.0n 0.5934 266249.9n 0.5934 266250.0n 0.5934 266499.9n 0.5934 266500.0n 0.5934 266749.9n 0.5934 266750.0n 0.4181 266999.9n 0.4181 267000.0n 0.2428 267249.9n 0.2428 267250.0n 0.5934 267499.9n 0.5934 267500.0n 0.3305 267749.9n 0.3305 267750.0n 0.5934 267999.9n 0.5934 268000.0n 0.3451 268249.9n 0.3451 268250.0n 0.5934 268499.9n 0.5934 268500.0n 0.4765 268749.9n 0.4765 268750.0n 0.5349 268999.9n 0.5349 269000.0n 0.5934 269249.9n 0.5934 269250.0n 0.4327 269499.9n 0.4327 269500.0n 0.2721 269749.9n 0.2721 269750.0n 0.2282 269999.9n 0.2282 270000.0n 0.4911 270249.9n 0.4911 270250.0n 0.3889 270499.9n 0.3889 270500.0n 0.4327 270749.9n 0.4327 270750.0n 0.4181 270999.9n 0.4181 271000.0n 0.3743 271249.9n 0.3743 271250.0n 0.5934 271499.9n 0.5934 271500.0n 0.4181 271749.9n 0.4181 271750.0n 0.5934 271999.9n 0.5934 272000.0n 0.5934 272249.9n 0.5934 272250.0n 0.5934 272499.9n 0.5934 272500.0n 0.3013 272749.9n 0.3013 272750.0n 0.3743 272999.9n 0.3743 273000.0n 0.5496 273249.9n 0.5496 273250.0n 0.5934 273499.9n 0.5934 273500.0n 0.5934 273749.9n 0.5934 273750.0n 0.5934 273999.9n 0.5934 274000.0n 0.5934 274249.9n 0.5934 274250.0n 0.4181 274499.9n 0.4181 274500.0n 0.2428 274749.9n 0.2428 274750.0n 0.5934 274999.9n 0.5934 275000.0n 0.3305 275249.9n 0.3305 275250.0n 0.5934 275499.9n 0.5934 275500.0n 0.3451 275749.9n 0.3451 275750.0n 0.5934 275999.9n 0.5934 276000.0n 0.4765 276249.9n 0.4765 276250.0n 0.5349 276499.9n 0.5349 276500.0n 0.5934 276749.9n 0.5934 276750.0n 0.4327 276999.9n 0.4327 277000.0n 0.2721 277249.9n 0.2721 277250.0n 0.2282 277499.9n 0.2282 277500.0n 0.4911 277749.9n 0.4911 277750.0n 0.3889 277999.9n 0.3889 278000.0n 0.4327 278249.9n 0.4327 278250.0n 0.4181 278499.9n 0.4181 278500.0n 0.3743 278749.9n 0.3743 278750.0n 0.5934 278999.9n 0.5934 279000.0n 0.4181 279249.9n 0.4181 279250.0n 0.5934 279499.9n 0.5934 279500.0n 0.5934 279749.9n 0.5934 279750.0n 0.5934 279999.9n 0.5934 280000.0n 0.3013 280249.9n 0.3013 280250.0n 0.3743 280499.9n 0.3743 280500.0n 0.5496 280749.9n 0.5496 280750.0n 0.5934 280999.9n 0.5934 281000.0n 0.5934 281249.9n 0.5934 281250.0n 0.5934 281499.9n 0.5934 281500.0n 0.5934 281749.9n 0.5934 281750.0n 0.4181 281999.9n 0.4181 282000.0n 0.2428 282249.9n 0.2428 282250.0n 0.5934 282499.9n 0.5934 282500.0n 0.3305 282749.9n 0.3305 282750.0n 0.5934 282999.9n 0.5934 283000.0n 0.3451 283249.9n 0.3451 283250.0n 0.5934 283499.9n 0.5934 283500.0n 0.4765 283749.9n 0.4765 283750.0n 0.5349 283999.9n 0.5349 284000.0n 0.5934 284249.9n 0.5934 284250.0n 0.4327 284499.9n 0.4327 284500.0n 0.2721 284749.9n 0.2721 284750.0n 0.2282 284999.9n 0.2282 285000.0n 0.4911 285249.9n 0.4911 285250.0n 0.3889 285499.9n 0.3889 285500.0n 0.4327 285749.9n 0.4327 285750.0n 0.4181 285999.9n 0.4181 286000.0n 0.3743 286249.9n 0.3743 286250.0n 0.5934 286499.9n 0.5934 286500.0n 0.4181 286749.9n 0.4181 286750.0n 0.5934 286999.9n 0.5934 287000.0n 0.5934 287249.9n 0.5934 287250.0n 0.5934 287499.9n 0.5934 287500.0n 0.3013 287749.9n 0.3013 287750.0n 0.3743 287999.9n 0.3743 288000.0n 0.5496 288249.9n 0.5496 288250.0n 0.5934 288499.9n 0.5934 288500.0n 0.5934 288749.9n 0.5934 288750.0n 0.5934 288999.9n 0.5934 289000.0n 0.5934 289249.9n 0.5934 289250.0n 0.4181 289499.9n 0.4181 289500.0n 0.2428 289749.9n 0.2428 289750.0n 0.5934 289999.9n 0.5934 290000.0n 0.3305 290249.9n 0.3305 290250.0n 0.5934 290499.9n 0.5934 290500.0n 0.3451 290749.9n 0.3451 290750.0n 0.5934 290999.9n 0.5934 291000.0n 0.4765 291249.9n 0.4765 291250.0n 0.5349 291499.9n 0.5349 291500.0n 0.5934 291749.9n 0.5934 291750.0n 0.4327 291999.9n 0.4327 292000.0n 0.2721 292249.9n 0.2721 292250.0n 0.2282 292499.9n 0.2282 292500.0n 0.4911 292749.9n 0.4911 292750.0n 0.3889 292999.9n 0.3889 293000.0n 0.4327 293249.9n 0.4327 293250.0n 0.4181 293499.9n 0.4181 293500.0n 0.3743 293749.9n 0.3743 293750.0n 0.5934 293999.9n 0.5934 294000.0n 0.4181 294249.9n 0.4181 294250.0n 0.5934 294499.9n 0.5934 294500.0n 0.5934 294749.9n 0.5934 294750.0n 0.5934 294999.9n 0.5934 295000.0n 0.3013 295249.9n 0.3013 295250.0n 0.3743 295499.9n 0.3743 295500.0n 0.5496 295749.9n 0.5496 295750.0n 0.5934 295999.9n 0.5934 296000.0n 0.5934 296249.9n 0.5934 296250.0n 0.5934 296499.9n 0.5934 296500.0n 0.5934 296749.9n 0.5934 296750.0n 0.4181 296999.9n 0.4181 297000.0n 0.2428 297249.9n 0.2428 297250.0n 0.5934 297499.9n 0.5934 297500.0n 0.3305 297749.9n 0.3305 297750.0n 0.5934 297999.9n 0.5934 298000.0n 0.3451 298249.9n 0.3451 298250.0n 0.5934 298499.9n 0.5934 298500.0n 0.4765 298749.9n 0.4765 298750.0n 0.5349 298999.9n 0.5349 299000.0n 0.5934 299249.9n 0.5934 299250.0n 0.4327 299499.9n 0.4327 299500.0n 0.2721 299749.9n 0.2721 299750.0n 0.2282)
Vxp12 a_xp12 0 PWL(0.0n 0.4570 249.9n 0.4570 250.0n 0.4570 499.9n 0.4570 500.0n 0.5438 749.9n 0.5438 750.0n 0.4570 999.9n 0.4570 1000.0n 0.4570 1249.9n 0.4570 1250.0n 0.4570 1499.9n 0.4570 1500.0n 0.4570 1749.9n 0.4570 1750.0n 0.4570 1999.9n 0.4570 2000.0n 0.5871 2249.9n 0.5871 2250.0n 0.4570 2499.9n 0.4570 2500.0n 0.5004 2749.9n 0.5004 2750.0n 0.5871 2999.9n 0.5871 3000.0n 0.4570 3249.9n 0.4570 3250.0n 0.4570 3499.9n 0.4570 3500.0n 0.4570 3749.9n 0.4570 3750.0n 0.4570 3999.9n 0.4570 4000.0n 0.4570 4249.9n 0.4570 4250.0n 0.4570 4499.9n 0.4570 4500.0n 0.4570 4749.9n 0.4570 4750.0n 0.4570 4999.9n 0.4570 5000.0n 0.4570 5249.9n 0.4570 5250.0n 0.4570 5499.9n 0.4570 5500.0n 0.4570 5749.9n 0.4570 5750.0n 0.4570 5999.9n 0.4570 6000.0n 0.4570 6249.9n 0.4570 6250.0n 0.4570 6499.9n 0.4570 6500.0n 0.4570 6749.9n 0.4570 6750.0n 0.5004 6999.9n 0.5004 7000.0n 0.5871 7249.9n 0.5871 7250.0n 0.4570 7499.9n 0.4570 7500.0n 0.4570 7749.9n 0.4570 7750.0n 0.4570 7999.9n 0.4570 8000.0n 0.5438 8249.9n 0.5438 8250.0n 0.4570 8499.9n 0.4570 8500.0n 0.4570 8749.9n 0.4570 8750.0n 0.4570 8999.9n 0.4570 9000.0n 0.4570 9249.9n 0.4570 9250.0n 0.4570 9499.9n 0.4570 9500.0n 0.5871 9749.9n 0.5871 9750.0n 0.4570 9999.9n 0.4570 10000.0n 0.5004 10249.9n 0.5004 10250.0n 0.5871 10499.9n 0.5871 10500.0n 0.4570 10749.9n 0.4570 10750.0n 0.4570 10999.9n 0.4570 11000.0n 0.4570 11249.9n 0.4570 11250.0n 0.4570 11499.9n 0.4570 11500.0n 0.4570 11749.9n 0.4570 11750.0n 0.4570 11999.9n 0.4570 12000.0n 0.4570 12249.9n 0.4570 12250.0n 0.4570 12499.9n 0.4570 12500.0n 0.4570 12749.9n 0.4570 12750.0n 0.4570 12999.9n 0.4570 13000.0n 0.4570 13249.9n 0.4570 13250.0n 0.4570 13499.9n 0.4570 13500.0n 0.4570 13749.9n 0.4570 13750.0n 0.4570 13999.9n 0.4570 14000.0n 0.4570 14249.9n 0.4570 14250.0n 0.5004 14499.9n 0.5004 14500.0n 0.5871 14749.9n 0.5871 14750.0n 0.4570 14999.9n 0.4570 15000.0n 0.4570 15249.9n 0.4570 15250.0n 0.4570 15499.9n 0.4570 15500.0n 0.5438 15749.9n 0.5438 15750.0n 0.4570 15999.9n 0.4570 16000.0n 0.4570 16249.9n 0.4570 16250.0n 0.4570 16499.9n 0.4570 16500.0n 0.4570 16749.9n 0.4570 16750.0n 0.4570 16999.9n 0.4570 17000.0n 0.5871 17249.9n 0.5871 17250.0n 0.4570 17499.9n 0.4570 17500.0n 0.5004 17749.9n 0.5004 17750.0n 0.5871 17999.9n 0.5871 18000.0n 0.4570 18249.9n 0.4570 18250.0n 0.4570 18499.9n 0.4570 18500.0n 0.4570 18749.9n 0.4570 18750.0n 0.4570 18999.9n 0.4570 19000.0n 0.4570 19249.9n 0.4570 19250.0n 0.4570 19499.9n 0.4570 19500.0n 0.4570 19749.9n 0.4570 19750.0n 0.4570 19999.9n 0.4570 20000.0n 0.4570 20249.9n 0.4570 20250.0n 0.4570 20499.9n 0.4570 20500.0n 0.4570 20749.9n 0.4570 20750.0n 0.4570 20999.9n 0.4570 21000.0n 0.4570 21249.9n 0.4570 21250.0n 0.4570 21499.9n 0.4570 21500.0n 0.4570 21749.9n 0.4570 21750.0n 0.5004 21999.9n 0.5004 22000.0n 0.5871 22249.9n 0.5871 22250.0n 0.4570 22499.9n 0.4570 22500.0n 0.4570 22749.9n 0.4570 22750.0n 0.4570 22999.9n 0.4570 23000.0n 0.5438 23249.9n 0.5438 23250.0n 0.4570 23499.9n 0.4570 23500.0n 0.4570 23749.9n 0.4570 23750.0n 0.4570 23999.9n 0.4570 24000.0n 0.4570 24249.9n 0.4570 24250.0n 0.4570 24499.9n 0.4570 24500.0n 0.5871 24749.9n 0.5871 24750.0n 0.4570 24999.9n 0.4570 25000.0n 0.5004 25249.9n 0.5004 25250.0n 0.5871 25499.9n 0.5871 25500.0n 0.4570 25749.9n 0.4570 25750.0n 0.4570 25999.9n 0.4570 26000.0n 0.4570 26249.9n 0.4570 26250.0n 0.4570 26499.9n 0.4570 26500.0n 0.4570 26749.9n 0.4570 26750.0n 0.4570 26999.9n 0.4570 27000.0n 0.4570 27249.9n 0.4570 27250.0n 0.4570 27499.9n 0.4570 27500.0n 0.4570 27749.9n 0.4570 27750.0n 0.4570 27999.9n 0.4570 28000.0n 0.4570 28249.9n 0.4570 28250.0n 0.4570 28499.9n 0.4570 28500.0n 0.4570 28749.9n 0.4570 28750.0n 0.4570 28999.9n 0.4570 29000.0n 0.4570 29249.9n 0.4570 29250.0n 0.5004 29499.9n 0.5004 29500.0n 0.5871 29749.9n 0.5871 29750.0n 0.4570 29999.9n 0.4570 30000.0n 0.4570 30249.9n 0.4570 30250.0n 0.4570 30499.9n 0.4570 30500.0n 0.5438 30749.9n 0.5438 30750.0n 0.4570 30999.9n 0.4570 31000.0n 0.4570 31249.9n 0.4570 31250.0n 0.4570 31499.9n 0.4570 31500.0n 0.4570 31749.9n 0.4570 31750.0n 0.4570 31999.9n 0.4570 32000.0n 0.5871 32249.9n 0.5871 32250.0n 0.4570 32499.9n 0.4570 32500.0n 0.5004 32749.9n 0.5004 32750.0n 0.5871 32999.9n 0.5871 33000.0n 0.4570 33249.9n 0.4570 33250.0n 0.4570 33499.9n 0.4570 33500.0n 0.4570 33749.9n 0.4570 33750.0n 0.4570 33999.9n 0.4570 34000.0n 0.4570 34249.9n 0.4570 34250.0n 0.4570 34499.9n 0.4570 34500.0n 0.4570 34749.9n 0.4570 34750.0n 0.4570 34999.9n 0.4570 35000.0n 0.4570 35249.9n 0.4570 35250.0n 0.4570 35499.9n 0.4570 35500.0n 0.4570 35749.9n 0.4570 35750.0n 0.4570 35999.9n 0.4570 36000.0n 0.4570 36249.9n 0.4570 36250.0n 0.4570 36499.9n 0.4570 36500.0n 0.4570 36749.9n 0.4570 36750.0n 0.5004 36999.9n 0.5004 37000.0n 0.5871 37249.9n 0.5871 37250.0n 0.4570 37499.9n 0.4570 37500.0n 0.4570 37749.9n 0.4570 37750.0n 0.4570 37999.9n 0.4570 38000.0n 0.5438 38249.9n 0.5438 38250.0n 0.4570 38499.9n 0.4570 38500.0n 0.4570 38749.9n 0.4570 38750.0n 0.4570 38999.9n 0.4570 39000.0n 0.4570 39249.9n 0.4570 39250.0n 0.4570 39499.9n 0.4570 39500.0n 0.5871 39749.9n 0.5871 39750.0n 0.4570 39999.9n 0.4570 40000.0n 0.5004 40249.9n 0.5004 40250.0n 0.5871 40499.9n 0.5871 40500.0n 0.4570 40749.9n 0.4570 40750.0n 0.4570 40999.9n 0.4570 41000.0n 0.4570 41249.9n 0.4570 41250.0n 0.4570 41499.9n 0.4570 41500.0n 0.4570 41749.9n 0.4570 41750.0n 0.4570 41999.9n 0.4570 42000.0n 0.4570 42249.9n 0.4570 42250.0n 0.4570 42499.9n 0.4570 42500.0n 0.4570 42749.9n 0.4570 42750.0n 0.4570 42999.9n 0.4570 43000.0n 0.4570 43249.9n 0.4570 43250.0n 0.4570 43499.9n 0.4570 43500.0n 0.4570 43749.9n 0.4570 43750.0n 0.4570 43999.9n 0.4570 44000.0n 0.4570 44249.9n 0.4570 44250.0n 0.5004 44499.9n 0.5004 44500.0n 0.5871 44749.9n 0.5871 44750.0n 0.4570 44999.9n 0.4570 45000.0n 0.4570 45249.9n 0.4570 45250.0n 0.4570 45499.9n 0.4570 45500.0n 0.5438 45749.9n 0.5438 45750.0n 0.4570 45999.9n 0.4570 46000.0n 0.4570 46249.9n 0.4570 46250.0n 0.4570 46499.9n 0.4570 46500.0n 0.4570 46749.9n 0.4570 46750.0n 0.4570 46999.9n 0.4570 47000.0n 0.5871 47249.9n 0.5871 47250.0n 0.4570 47499.9n 0.4570 47500.0n 0.5004 47749.9n 0.5004 47750.0n 0.5871 47999.9n 0.5871 48000.0n 0.4570 48249.9n 0.4570 48250.0n 0.4570 48499.9n 0.4570 48500.0n 0.4570 48749.9n 0.4570 48750.0n 0.4570 48999.9n 0.4570 49000.0n 0.4570 49249.9n 0.4570 49250.0n 0.4570 49499.9n 0.4570 49500.0n 0.4570 49749.9n 0.4570 49750.0n 0.4570 49999.9n 0.4570 50000.0n 0.4570 50249.9n 0.4570 50250.0n 0.4570 50499.9n 0.4570 50500.0n 0.4570 50749.9n 0.4570 50750.0n 0.4570 50999.9n 0.4570 51000.0n 0.4570 51249.9n 0.4570 51250.0n 0.4570 51499.9n 0.4570 51500.0n 0.4570 51749.9n 0.4570 51750.0n 0.5004 51999.9n 0.5004 52000.0n 0.5871 52249.9n 0.5871 52250.0n 0.4570 52499.9n 0.4570 52500.0n 0.4570 52749.9n 0.4570 52750.0n 0.4570 52999.9n 0.4570 53000.0n 0.5438 53249.9n 0.5438 53250.0n 0.4570 53499.9n 0.4570 53500.0n 0.4570 53749.9n 0.4570 53750.0n 0.4570 53999.9n 0.4570 54000.0n 0.4570 54249.9n 0.4570 54250.0n 0.4570 54499.9n 0.4570 54500.0n 0.5871 54749.9n 0.5871 54750.0n 0.4570 54999.9n 0.4570 55000.0n 0.5004 55249.9n 0.5004 55250.0n 0.5871 55499.9n 0.5871 55500.0n 0.4570 55749.9n 0.4570 55750.0n 0.4570 55999.9n 0.4570 56000.0n 0.4570 56249.9n 0.4570 56250.0n 0.4570 56499.9n 0.4570 56500.0n 0.4570 56749.9n 0.4570 56750.0n 0.4570 56999.9n 0.4570 57000.0n 0.4570 57249.9n 0.4570 57250.0n 0.4570 57499.9n 0.4570 57500.0n 0.4570 57749.9n 0.4570 57750.0n 0.4570 57999.9n 0.4570 58000.0n 0.4570 58249.9n 0.4570 58250.0n 0.4570 58499.9n 0.4570 58500.0n 0.4570 58749.9n 0.4570 58750.0n 0.4570 58999.9n 0.4570 59000.0n 0.4570 59249.9n 0.4570 59250.0n 0.5004 59499.9n 0.5004 59500.0n 0.5871 59749.9n 0.5871 59750.0n 0.4570 59999.9n 0.4570 60000.0n 0.4570 60249.9n 0.4570 60250.0n 0.4570 60499.9n 0.4570 60500.0n 0.5438 60749.9n 0.5438 60750.0n 0.4570 60999.9n 0.4570 61000.0n 0.4570 61249.9n 0.4570 61250.0n 0.4570 61499.9n 0.4570 61500.0n 0.4570 61749.9n 0.4570 61750.0n 0.4570 61999.9n 0.4570 62000.0n 0.5871 62249.9n 0.5871 62250.0n 0.4570 62499.9n 0.4570 62500.0n 0.5004 62749.9n 0.5004 62750.0n 0.5871 62999.9n 0.5871 63000.0n 0.4570 63249.9n 0.4570 63250.0n 0.4570 63499.9n 0.4570 63500.0n 0.4570 63749.9n 0.4570 63750.0n 0.4570 63999.9n 0.4570 64000.0n 0.4570 64249.9n 0.4570 64250.0n 0.4570 64499.9n 0.4570 64500.0n 0.4570 64749.9n 0.4570 64750.0n 0.4570 64999.9n 0.4570 65000.0n 0.4570 65249.9n 0.4570 65250.0n 0.4570 65499.9n 0.4570 65500.0n 0.4570 65749.9n 0.4570 65750.0n 0.4570 65999.9n 0.4570 66000.0n 0.4570 66249.9n 0.4570 66250.0n 0.4570 66499.9n 0.4570 66500.0n 0.4570 66749.9n 0.4570 66750.0n 0.5004 66999.9n 0.5004 67000.0n 0.5871 67249.9n 0.5871 67250.0n 0.4570 67499.9n 0.4570 67500.0n 0.4570 67749.9n 0.4570 67750.0n 0.4570 67999.9n 0.4570 68000.0n 0.5438 68249.9n 0.5438 68250.0n 0.4570 68499.9n 0.4570 68500.0n 0.4570 68749.9n 0.4570 68750.0n 0.4570 68999.9n 0.4570 69000.0n 0.4570 69249.9n 0.4570 69250.0n 0.4570 69499.9n 0.4570 69500.0n 0.5871 69749.9n 0.5871 69750.0n 0.4570 69999.9n 0.4570 70000.0n 0.5004 70249.9n 0.5004 70250.0n 0.5871 70499.9n 0.5871 70500.0n 0.4570 70749.9n 0.4570 70750.0n 0.4570 70999.9n 0.4570 71000.0n 0.4570 71249.9n 0.4570 71250.0n 0.4570 71499.9n 0.4570 71500.0n 0.4570 71749.9n 0.4570 71750.0n 0.4570 71999.9n 0.4570 72000.0n 0.4570 72249.9n 0.4570 72250.0n 0.4570 72499.9n 0.4570 72500.0n 0.4570 72749.9n 0.4570 72750.0n 0.4570 72999.9n 0.4570 73000.0n 0.4570 73249.9n 0.4570 73250.0n 0.4570 73499.9n 0.4570 73500.0n 0.4570 73749.9n 0.4570 73750.0n 0.4570 73999.9n 0.4570 74000.0n 0.4570 74249.9n 0.4570 74250.0n 0.5004 74499.9n 0.5004 74500.0n 0.5871 74749.9n 0.5871 74750.0n 0.4570 74999.9n 0.4570 75000.0n 0.4570 75249.9n 0.4570 75250.0n 0.4570 75499.9n 0.4570 75500.0n 0.5438 75749.9n 0.5438 75750.0n 0.4570 75999.9n 0.4570 76000.0n 0.4570 76249.9n 0.4570 76250.0n 0.4570 76499.9n 0.4570 76500.0n 0.4570 76749.9n 0.4570 76750.0n 0.4570 76999.9n 0.4570 77000.0n 0.5871 77249.9n 0.5871 77250.0n 0.4570 77499.9n 0.4570 77500.0n 0.5004 77749.9n 0.5004 77750.0n 0.5871 77999.9n 0.5871 78000.0n 0.4570 78249.9n 0.4570 78250.0n 0.4570 78499.9n 0.4570 78500.0n 0.4570 78749.9n 0.4570 78750.0n 0.4570 78999.9n 0.4570 79000.0n 0.4570 79249.9n 0.4570 79250.0n 0.4570 79499.9n 0.4570 79500.0n 0.4570 79749.9n 0.4570 79750.0n 0.4570 79999.9n 0.4570 80000.0n 0.4570 80249.9n 0.4570 80250.0n 0.4570 80499.9n 0.4570 80500.0n 0.4570 80749.9n 0.4570 80750.0n 0.4570 80999.9n 0.4570 81000.0n 0.4570 81249.9n 0.4570 81250.0n 0.4570 81499.9n 0.4570 81500.0n 0.4570 81749.9n 0.4570 81750.0n 0.5004 81999.9n 0.5004 82000.0n 0.5871 82249.9n 0.5871 82250.0n 0.4570 82499.9n 0.4570 82500.0n 0.4570 82749.9n 0.4570 82750.0n 0.4570 82999.9n 0.4570 83000.0n 0.5438 83249.9n 0.5438 83250.0n 0.4570 83499.9n 0.4570 83500.0n 0.4570 83749.9n 0.4570 83750.0n 0.4570 83999.9n 0.4570 84000.0n 0.4570 84249.9n 0.4570 84250.0n 0.4570 84499.9n 0.4570 84500.0n 0.5871 84749.9n 0.5871 84750.0n 0.4570 84999.9n 0.4570 85000.0n 0.5004 85249.9n 0.5004 85250.0n 0.5871 85499.9n 0.5871 85500.0n 0.4570 85749.9n 0.4570 85750.0n 0.4570 85999.9n 0.4570 86000.0n 0.4570 86249.9n 0.4570 86250.0n 0.4570 86499.9n 0.4570 86500.0n 0.4570 86749.9n 0.4570 86750.0n 0.4570 86999.9n 0.4570 87000.0n 0.4570 87249.9n 0.4570 87250.0n 0.4570 87499.9n 0.4570 87500.0n 0.4570 87749.9n 0.4570 87750.0n 0.4570 87999.9n 0.4570 88000.0n 0.4570 88249.9n 0.4570 88250.0n 0.4570 88499.9n 0.4570 88500.0n 0.4570 88749.9n 0.4570 88750.0n 0.4570 88999.9n 0.4570 89000.0n 0.4570 89249.9n 0.4570 89250.0n 0.5004 89499.9n 0.5004 89500.0n 0.5871 89749.9n 0.5871 89750.0n 0.4570 89999.9n 0.4570 90000.0n 0.4570 90249.9n 0.4570 90250.0n 0.4570 90499.9n 0.4570 90500.0n 0.5438 90749.9n 0.5438 90750.0n 0.4570 90999.9n 0.4570 91000.0n 0.4570 91249.9n 0.4570 91250.0n 0.4570 91499.9n 0.4570 91500.0n 0.4570 91749.9n 0.4570 91750.0n 0.4570 91999.9n 0.4570 92000.0n 0.5871 92249.9n 0.5871 92250.0n 0.4570 92499.9n 0.4570 92500.0n 0.5004 92749.9n 0.5004 92750.0n 0.5871 92999.9n 0.5871 93000.0n 0.4570 93249.9n 0.4570 93250.0n 0.4570 93499.9n 0.4570 93500.0n 0.4570 93749.9n 0.4570 93750.0n 0.4570 93999.9n 0.4570 94000.0n 0.4570 94249.9n 0.4570 94250.0n 0.4570 94499.9n 0.4570 94500.0n 0.4570 94749.9n 0.4570 94750.0n 0.4570 94999.9n 0.4570 95000.0n 0.4570 95249.9n 0.4570 95250.0n 0.4570 95499.9n 0.4570 95500.0n 0.4570 95749.9n 0.4570 95750.0n 0.4570 95999.9n 0.4570 96000.0n 0.4570 96249.9n 0.4570 96250.0n 0.4570 96499.9n 0.4570 96500.0n 0.4570 96749.9n 0.4570 96750.0n 0.5004 96999.9n 0.5004 97000.0n 0.5871 97249.9n 0.5871 97250.0n 0.4570 97499.9n 0.4570 97500.0n 0.4570 97749.9n 0.4570 97750.0n 0.4570 97999.9n 0.4570 98000.0n 0.5438 98249.9n 0.5438 98250.0n 0.4570 98499.9n 0.4570 98500.0n 0.4570 98749.9n 0.4570 98750.0n 0.4570 98999.9n 0.4570 99000.0n 0.4570 99249.9n 0.4570 99250.0n 0.4570 99499.9n 0.4570 99500.0n 0.5871 99749.9n 0.5871 99750.0n 0.4570 99999.9n 0.4570 100000.0n 0.5004 100249.9n 0.5004 100250.0n 0.5871 100499.9n 0.5871 100500.0n 0.4570 100749.9n 0.4570 100750.0n 0.4570 100999.9n 0.4570 101000.0n 0.4570 101249.9n 0.4570 101250.0n 0.4570 101499.9n 0.4570 101500.0n 0.4570 101749.9n 0.4570 101750.0n 0.4570 101999.9n 0.4570 102000.0n 0.4570 102249.9n 0.4570 102250.0n 0.4570 102499.9n 0.4570 102500.0n 0.4570 102749.9n 0.4570 102750.0n 0.4570 102999.9n 0.4570 103000.0n 0.4570 103249.9n 0.4570 103250.0n 0.4570 103499.9n 0.4570 103500.0n 0.4570 103749.9n 0.4570 103750.0n 0.4570 103999.9n 0.4570 104000.0n 0.4570 104249.9n 0.4570 104250.0n 0.5004 104499.9n 0.5004 104500.0n 0.5871 104749.9n 0.5871 104750.0n 0.4570 104999.9n 0.4570 105000.0n 0.4570 105249.9n 0.4570 105250.0n 0.4570 105499.9n 0.4570 105500.0n 0.5438 105749.9n 0.5438 105750.0n 0.4570 105999.9n 0.4570 106000.0n 0.4570 106249.9n 0.4570 106250.0n 0.4570 106499.9n 0.4570 106500.0n 0.4570 106749.9n 0.4570 106750.0n 0.4570 106999.9n 0.4570 107000.0n 0.5871 107249.9n 0.5871 107250.0n 0.4570 107499.9n 0.4570 107500.0n 0.5004 107749.9n 0.5004 107750.0n 0.5871 107999.9n 0.5871 108000.0n 0.4570 108249.9n 0.4570 108250.0n 0.4570 108499.9n 0.4570 108500.0n 0.4570 108749.9n 0.4570 108750.0n 0.4570 108999.9n 0.4570 109000.0n 0.4570 109249.9n 0.4570 109250.0n 0.4570 109499.9n 0.4570 109500.0n 0.4570 109749.9n 0.4570 109750.0n 0.4570 109999.9n 0.4570 110000.0n 0.4570 110249.9n 0.4570 110250.0n 0.4570 110499.9n 0.4570 110500.0n 0.4570 110749.9n 0.4570 110750.0n 0.4570 110999.9n 0.4570 111000.0n 0.4570 111249.9n 0.4570 111250.0n 0.4570 111499.9n 0.4570 111500.0n 0.4570 111749.9n 0.4570 111750.0n 0.5004 111999.9n 0.5004 112000.0n 0.5871 112249.9n 0.5871 112250.0n 0.4570 112499.9n 0.4570 112500.0n 0.4570 112749.9n 0.4570 112750.0n 0.4570 112999.9n 0.4570 113000.0n 0.5438 113249.9n 0.5438 113250.0n 0.4570 113499.9n 0.4570 113500.0n 0.4570 113749.9n 0.4570 113750.0n 0.4570 113999.9n 0.4570 114000.0n 0.4570 114249.9n 0.4570 114250.0n 0.4570 114499.9n 0.4570 114500.0n 0.5871 114749.9n 0.5871 114750.0n 0.4570 114999.9n 0.4570 115000.0n 0.5004 115249.9n 0.5004 115250.0n 0.5871 115499.9n 0.5871 115500.0n 0.4570 115749.9n 0.4570 115750.0n 0.4570 115999.9n 0.4570 116000.0n 0.4570 116249.9n 0.4570 116250.0n 0.4570 116499.9n 0.4570 116500.0n 0.4570 116749.9n 0.4570 116750.0n 0.4570 116999.9n 0.4570 117000.0n 0.4570 117249.9n 0.4570 117250.0n 0.4570 117499.9n 0.4570 117500.0n 0.4570 117749.9n 0.4570 117750.0n 0.4570 117999.9n 0.4570 118000.0n 0.4570 118249.9n 0.4570 118250.0n 0.4570 118499.9n 0.4570 118500.0n 0.4570 118749.9n 0.4570 118750.0n 0.4570 118999.9n 0.4570 119000.0n 0.4570 119249.9n 0.4570 119250.0n 0.5004 119499.9n 0.5004 119500.0n 0.5871 119749.9n 0.5871 119750.0n 0.4570 119999.9n 0.4570 120000.0n 0.4570 120249.9n 0.4570 120250.0n 0.4570 120499.9n 0.4570 120500.0n 0.5438 120749.9n 0.5438 120750.0n 0.4570 120999.9n 0.4570 121000.0n 0.4570 121249.9n 0.4570 121250.0n 0.4570 121499.9n 0.4570 121500.0n 0.4570 121749.9n 0.4570 121750.0n 0.4570 121999.9n 0.4570 122000.0n 0.5871 122249.9n 0.5871 122250.0n 0.4570 122499.9n 0.4570 122500.0n 0.5004 122749.9n 0.5004 122750.0n 0.5871 122999.9n 0.5871 123000.0n 0.4570 123249.9n 0.4570 123250.0n 0.4570 123499.9n 0.4570 123500.0n 0.4570 123749.9n 0.4570 123750.0n 0.4570 123999.9n 0.4570 124000.0n 0.4570 124249.9n 0.4570 124250.0n 0.4570 124499.9n 0.4570 124500.0n 0.4570 124749.9n 0.4570 124750.0n 0.4570 124999.9n 0.4570 125000.0n 0.4570 125249.9n 0.4570 125250.0n 0.4570 125499.9n 0.4570 125500.0n 0.4570 125749.9n 0.4570 125750.0n 0.4570 125999.9n 0.4570 126000.0n 0.4570 126249.9n 0.4570 126250.0n 0.4570 126499.9n 0.4570 126500.0n 0.4570 126749.9n 0.4570 126750.0n 0.5004 126999.9n 0.5004 127000.0n 0.5871 127249.9n 0.5871 127250.0n 0.4570 127499.9n 0.4570 127500.0n 0.4570 127749.9n 0.4570 127750.0n 0.4570 127999.9n 0.4570 128000.0n 0.5438 128249.9n 0.5438 128250.0n 0.4570 128499.9n 0.4570 128500.0n 0.4570 128749.9n 0.4570 128750.0n 0.4570 128999.9n 0.4570 129000.0n 0.4570 129249.9n 0.4570 129250.0n 0.4570 129499.9n 0.4570 129500.0n 0.5871 129749.9n 0.5871 129750.0n 0.4570 129999.9n 0.4570 130000.0n 0.5004 130249.9n 0.5004 130250.0n 0.5871 130499.9n 0.5871 130500.0n 0.4570 130749.9n 0.4570 130750.0n 0.4570 130999.9n 0.4570 131000.0n 0.4570 131249.9n 0.4570 131250.0n 0.4570 131499.9n 0.4570 131500.0n 0.4570 131749.9n 0.4570 131750.0n 0.4570 131999.9n 0.4570 132000.0n 0.4570 132249.9n 0.4570 132250.0n 0.4570 132499.9n 0.4570 132500.0n 0.4570 132749.9n 0.4570 132750.0n 0.4570 132999.9n 0.4570 133000.0n 0.4570 133249.9n 0.4570 133250.0n 0.4570 133499.9n 0.4570 133500.0n 0.4570 133749.9n 0.4570 133750.0n 0.4570 133999.9n 0.4570 134000.0n 0.4570 134249.9n 0.4570 134250.0n 0.5004 134499.9n 0.5004 134500.0n 0.5871 134749.9n 0.5871 134750.0n 0.4570 134999.9n 0.4570 135000.0n 0.4570 135249.9n 0.4570 135250.0n 0.4570 135499.9n 0.4570 135500.0n 0.5438 135749.9n 0.5438 135750.0n 0.4570 135999.9n 0.4570 136000.0n 0.4570 136249.9n 0.4570 136250.0n 0.4570 136499.9n 0.4570 136500.0n 0.4570 136749.9n 0.4570 136750.0n 0.4570 136999.9n 0.4570 137000.0n 0.5871 137249.9n 0.5871 137250.0n 0.4570 137499.9n 0.4570 137500.0n 0.5004 137749.9n 0.5004 137750.0n 0.5871 137999.9n 0.5871 138000.0n 0.4570 138249.9n 0.4570 138250.0n 0.4570 138499.9n 0.4570 138500.0n 0.4570 138749.9n 0.4570 138750.0n 0.4570 138999.9n 0.4570 139000.0n 0.4570 139249.9n 0.4570 139250.0n 0.4570 139499.9n 0.4570 139500.0n 0.4570 139749.9n 0.4570 139750.0n 0.4570 139999.9n 0.4570 140000.0n 0.4570 140249.9n 0.4570 140250.0n 0.4570 140499.9n 0.4570 140500.0n 0.4570 140749.9n 0.4570 140750.0n 0.4570 140999.9n 0.4570 141000.0n 0.4570 141249.9n 0.4570 141250.0n 0.4570 141499.9n 0.4570 141500.0n 0.4570 141749.9n 0.4570 141750.0n 0.5004 141999.9n 0.5004 142000.0n 0.5871 142249.9n 0.5871 142250.0n 0.4570 142499.9n 0.4570 142500.0n 0.4570 142749.9n 0.4570 142750.0n 0.4570 142999.9n 0.4570 143000.0n 0.5438 143249.9n 0.5438 143250.0n 0.4570 143499.9n 0.4570 143500.0n 0.4570 143749.9n 0.4570 143750.0n 0.4570 143999.9n 0.4570 144000.0n 0.4570 144249.9n 0.4570 144250.0n 0.4570 144499.9n 0.4570 144500.0n 0.5871 144749.9n 0.5871 144750.0n 0.4570 144999.9n 0.4570 145000.0n 0.5004 145249.9n 0.5004 145250.0n 0.5871 145499.9n 0.5871 145500.0n 0.4570 145749.9n 0.4570 145750.0n 0.4570 145999.9n 0.4570 146000.0n 0.4570 146249.9n 0.4570 146250.0n 0.4570 146499.9n 0.4570 146500.0n 0.4570 146749.9n 0.4570 146750.0n 0.4570 146999.9n 0.4570 147000.0n 0.4570 147249.9n 0.4570 147250.0n 0.4570 147499.9n 0.4570 147500.0n 0.4570 147749.9n 0.4570 147750.0n 0.4570 147999.9n 0.4570 148000.0n 0.4570 148249.9n 0.4570 148250.0n 0.4570 148499.9n 0.4570 148500.0n 0.4570 148749.9n 0.4570 148750.0n 0.4570 148999.9n 0.4570 149000.0n 0.4570 149249.9n 0.4570 149250.0n 0.5004 149499.9n 0.5004 149500.0n 0.5871 149749.9n 0.5871 149750.0n 0.4570 149999.9n 0.4570 150000.0n 0.4570 150249.9n 0.4570 150250.0n 0.4570 150499.9n 0.4570 150500.0n 0.5438 150749.9n 0.5438 150750.0n 0.4570 150999.9n 0.4570 151000.0n 0.4570 151249.9n 0.4570 151250.0n 0.4570 151499.9n 0.4570 151500.0n 0.4570 151749.9n 0.4570 151750.0n 0.4570 151999.9n 0.4570 152000.0n 0.5871 152249.9n 0.5871 152250.0n 0.4570 152499.9n 0.4570 152500.0n 0.5004 152749.9n 0.5004 152750.0n 0.5871 152999.9n 0.5871 153000.0n 0.4570 153249.9n 0.4570 153250.0n 0.4570 153499.9n 0.4570 153500.0n 0.4570 153749.9n 0.4570 153750.0n 0.4570 153999.9n 0.4570 154000.0n 0.4570 154249.9n 0.4570 154250.0n 0.4570 154499.9n 0.4570 154500.0n 0.4570 154749.9n 0.4570 154750.0n 0.4570 154999.9n 0.4570 155000.0n 0.4570 155249.9n 0.4570 155250.0n 0.4570 155499.9n 0.4570 155500.0n 0.4570 155749.9n 0.4570 155750.0n 0.4570 155999.9n 0.4570 156000.0n 0.4570 156249.9n 0.4570 156250.0n 0.4570 156499.9n 0.4570 156500.0n 0.4570 156749.9n 0.4570 156750.0n 0.5004 156999.9n 0.5004 157000.0n 0.5871 157249.9n 0.5871 157250.0n 0.4570 157499.9n 0.4570 157500.0n 0.4570 157749.9n 0.4570 157750.0n 0.4570 157999.9n 0.4570 158000.0n 0.5438 158249.9n 0.5438 158250.0n 0.4570 158499.9n 0.4570 158500.0n 0.4570 158749.9n 0.4570 158750.0n 0.4570 158999.9n 0.4570 159000.0n 0.4570 159249.9n 0.4570 159250.0n 0.4570 159499.9n 0.4570 159500.0n 0.5871 159749.9n 0.5871 159750.0n 0.4570 159999.9n 0.4570 160000.0n 0.5004 160249.9n 0.5004 160250.0n 0.5871 160499.9n 0.5871 160500.0n 0.4570 160749.9n 0.4570 160750.0n 0.4570 160999.9n 0.4570 161000.0n 0.4570 161249.9n 0.4570 161250.0n 0.4570 161499.9n 0.4570 161500.0n 0.4570 161749.9n 0.4570 161750.0n 0.4570 161999.9n 0.4570 162000.0n 0.4570 162249.9n 0.4570 162250.0n 0.4570 162499.9n 0.4570 162500.0n 0.4570 162749.9n 0.4570 162750.0n 0.4570 162999.9n 0.4570 163000.0n 0.4570 163249.9n 0.4570 163250.0n 0.4570 163499.9n 0.4570 163500.0n 0.4570 163749.9n 0.4570 163750.0n 0.4570 163999.9n 0.4570 164000.0n 0.4570 164249.9n 0.4570 164250.0n 0.5004 164499.9n 0.5004 164500.0n 0.5871 164749.9n 0.5871 164750.0n 0.4570 164999.9n 0.4570 165000.0n 0.4570 165249.9n 0.4570 165250.0n 0.4570 165499.9n 0.4570 165500.0n 0.5438 165749.9n 0.5438 165750.0n 0.4570 165999.9n 0.4570 166000.0n 0.4570 166249.9n 0.4570 166250.0n 0.4570 166499.9n 0.4570 166500.0n 0.4570 166749.9n 0.4570 166750.0n 0.4570 166999.9n 0.4570 167000.0n 0.5871 167249.9n 0.5871 167250.0n 0.4570 167499.9n 0.4570 167500.0n 0.5004 167749.9n 0.5004 167750.0n 0.5871 167999.9n 0.5871 168000.0n 0.4570 168249.9n 0.4570 168250.0n 0.4570 168499.9n 0.4570 168500.0n 0.4570 168749.9n 0.4570 168750.0n 0.4570 168999.9n 0.4570 169000.0n 0.4570 169249.9n 0.4570 169250.0n 0.4570 169499.9n 0.4570 169500.0n 0.4570 169749.9n 0.4570 169750.0n 0.4570 169999.9n 0.4570 170000.0n 0.4570 170249.9n 0.4570 170250.0n 0.4570 170499.9n 0.4570 170500.0n 0.4570 170749.9n 0.4570 170750.0n 0.4570 170999.9n 0.4570 171000.0n 0.4570 171249.9n 0.4570 171250.0n 0.4570 171499.9n 0.4570 171500.0n 0.4570 171749.9n 0.4570 171750.0n 0.5004 171999.9n 0.5004 172000.0n 0.5871 172249.9n 0.5871 172250.0n 0.4570 172499.9n 0.4570 172500.0n 0.4570 172749.9n 0.4570 172750.0n 0.4570 172999.9n 0.4570 173000.0n 0.5438 173249.9n 0.5438 173250.0n 0.4570 173499.9n 0.4570 173500.0n 0.4570 173749.9n 0.4570 173750.0n 0.4570 173999.9n 0.4570 174000.0n 0.4570 174249.9n 0.4570 174250.0n 0.4570 174499.9n 0.4570 174500.0n 0.5871 174749.9n 0.5871 174750.0n 0.4570 174999.9n 0.4570 175000.0n 0.5004 175249.9n 0.5004 175250.0n 0.5871 175499.9n 0.5871 175500.0n 0.4570 175749.9n 0.4570 175750.0n 0.4570 175999.9n 0.4570 176000.0n 0.4570 176249.9n 0.4570 176250.0n 0.4570 176499.9n 0.4570 176500.0n 0.4570 176749.9n 0.4570 176750.0n 0.4570 176999.9n 0.4570 177000.0n 0.4570 177249.9n 0.4570 177250.0n 0.4570 177499.9n 0.4570 177500.0n 0.4570 177749.9n 0.4570 177750.0n 0.4570 177999.9n 0.4570 178000.0n 0.4570 178249.9n 0.4570 178250.0n 0.4570 178499.9n 0.4570 178500.0n 0.4570 178749.9n 0.4570 178750.0n 0.4570 178999.9n 0.4570 179000.0n 0.4570 179249.9n 0.4570 179250.0n 0.5004 179499.9n 0.5004 179500.0n 0.5871 179749.9n 0.5871 179750.0n 0.4570 179999.9n 0.4570 180000.0n 0.4570 180249.9n 0.4570 180250.0n 0.4570 180499.9n 0.4570 180500.0n 0.5438 180749.9n 0.5438 180750.0n 0.4570 180999.9n 0.4570 181000.0n 0.4570 181249.9n 0.4570 181250.0n 0.4570 181499.9n 0.4570 181500.0n 0.4570 181749.9n 0.4570 181750.0n 0.4570 181999.9n 0.4570 182000.0n 0.5871 182249.9n 0.5871 182250.0n 0.4570 182499.9n 0.4570 182500.0n 0.5004 182749.9n 0.5004 182750.0n 0.5871 182999.9n 0.5871 183000.0n 0.4570 183249.9n 0.4570 183250.0n 0.4570 183499.9n 0.4570 183500.0n 0.4570 183749.9n 0.4570 183750.0n 0.4570 183999.9n 0.4570 184000.0n 0.4570 184249.9n 0.4570 184250.0n 0.4570 184499.9n 0.4570 184500.0n 0.4570 184749.9n 0.4570 184750.0n 0.4570 184999.9n 0.4570 185000.0n 0.4570 185249.9n 0.4570 185250.0n 0.4570 185499.9n 0.4570 185500.0n 0.4570 185749.9n 0.4570 185750.0n 0.4570 185999.9n 0.4570 186000.0n 0.4570 186249.9n 0.4570 186250.0n 0.4570 186499.9n 0.4570 186500.0n 0.4570 186749.9n 0.4570 186750.0n 0.5004 186999.9n 0.5004 187000.0n 0.5871 187249.9n 0.5871 187250.0n 0.4570 187499.9n 0.4570 187500.0n 0.4570 187749.9n 0.4570 187750.0n 0.4570 187999.9n 0.4570 188000.0n 0.5438 188249.9n 0.5438 188250.0n 0.4570 188499.9n 0.4570 188500.0n 0.4570 188749.9n 0.4570 188750.0n 0.4570 188999.9n 0.4570 189000.0n 0.4570 189249.9n 0.4570 189250.0n 0.4570 189499.9n 0.4570 189500.0n 0.5871 189749.9n 0.5871 189750.0n 0.4570 189999.9n 0.4570 190000.0n 0.5004 190249.9n 0.5004 190250.0n 0.5871 190499.9n 0.5871 190500.0n 0.4570 190749.9n 0.4570 190750.0n 0.4570 190999.9n 0.4570 191000.0n 0.4570 191249.9n 0.4570 191250.0n 0.4570 191499.9n 0.4570 191500.0n 0.4570 191749.9n 0.4570 191750.0n 0.4570 191999.9n 0.4570 192000.0n 0.4570 192249.9n 0.4570 192250.0n 0.4570 192499.9n 0.4570 192500.0n 0.4570 192749.9n 0.4570 192750.0n 0.4570 192999.9n 0.4570 193000.0n 0.4570 193249.9n 0.4570 193250.0n 0.4570 193499.9n 0.4570 193500.0n 0.4570 193749.9n 0.4570 193750.0n 0.4570 193999.9n 0.4570 194000.0n 0.4570 194249.9n 0.4570 194250.0n 0.5004 194499.9n 0.5004 194500.0n 0.5871 194749.9n 0.5871 194750.0n 0.4570 194999.9n 0.4570 195000.0n 0.4570 195249.9n 0.4570 195250.0n 0.4570 195499.9n 0.4570 195500.0n 0.5438 195749.9n 0.5438 195750.0n 0.4570 195999.9n 0.4570 196000.0n 0.4570 196249.9n 0.4570 196250.0n 0.4570 196499.9n 0.4570 196500.0n 0.4570 196749.9n 0.4570 196750.0n 0.4570 196999.9n 0.4570 197000.0n 0.5871 197249.9n 0.5871 197250.0n 0.4570 197499.9n 0.4570 197500.0n 0.5004 197749.9n 0.5004 197750.0n 0.5871 197999.9n 0.5871 198000.0n 0.4570 198249.9n 0.4570 198250.0n 0.4570 198499.9n 0.4570 198500.0n 0.4570 198749.9n 0.4570 198750.0n 0.4570 198999.9n 0.4570 199000.0n 0.4570 199249.9n 0.4570 199250.0n 0.4570 199499.9n 0.4570 199500.0n 0.4570 199749.9n 0.4570 199750.0n 0.4570 199999.9n 0.4570 200000.0n 0.4570 200249.9n 0.4570 200250.0n 0.4570 200499.9n 0.4570 200500.0n 0.4570 200749.9n 0.4570 200750.0n 0.4570 200999.9n 0.4570 201000.0n 0.4570 201249.9n 0.4570 201250.0n 0.4570 201499.9n 0.4570 201500.0n 0.4570 201749.9n 0.4570 201750.0n 0.5004 201999.9n 0.5004 202000.0n 0.5871 202249.9n 0.5871 202250.0n 0.4570 202499.9n 0.4570 202500.0n 0.4570 202749.9n 0.4570 202750.0n 0.4570 202999.9n 0.4570 203000.0n 0.5438 203249.9n 0.5438 203250.0n 0.4570 203499.9n 0.4570 203500.0n 0.4570 203749.9n 0.4570 203750.0n 0.4570 203999.9n 0.4570 204000.0n 0.4570 204249.9n 0.4570 204250.0n 0.4570 204499.9n 0.4570 204500.0n 0.5871 204749.9n 0.5871 204750.0n 0.4570 204999.9n 0.4570 205000.0n 0.5004 205249.9n 0.5004 205250.0n 0.5871 205499.9n 0.5871 205500.0n 0.4570 205749.9n 0.4570 205750.0n 0.4570 205999.9n 0.4570 206000.0n 0.4570 206249.9n 0.4570 206250.0n 0.4570 206499.9n 0.4570 206500.0n 0.4570 206749.9n 0.4570 206750.0n 0.4570 206999.9n 0.4570 207000.0n 0.4570 207249.9n 0.4570 207250.0n 0.4570 207499.9n 0.4570 207500.0n 0.4570 207749.9n 0.4570 207750.0n 0.4570 207999.9n 0.4570 208000.0n 0.4570 208249.9n 0.4570 208250.0n 0.4570 208499.9n 0.4570 208500.0n 0.4570 208749.9n 0.4570 208750.0n 0.4570 208999.9n 0.4570 209000.0n 0.4570 209249.9n 0.4570 209250.0n 0.5004 209499.9n 0.5004 209500.0n 0.5871 209749.9n 0.5871 209750.0n 0.4570 209999.9n 0.4570 210000.0n 0.4570 210249.9n 0.4570 210250.0n 0.4570 210499.9n 0.4570 210500.0n 0.5438 210749.9n 0.5438 210750.0n 0.4570 210999.9n 0.4570 211000.0n 0.4570 211249.9n 0.4570 211250.0n 0.4570 211499.9n 0.4570 211500.0n 0.4570 211749.9n 0.4570 211750.0n 0.4570 211999.9n 0.4570 212000.0n 0.5871 212249.9n 0.5871 212250.0n 0.4570 212499.9n 0.4570 212500.0n 0.5004 212749.9n 0.5004 212750.0n 0.5871 212999.9n 0.5871 213000.0n 0.4570 213249.9n 0.4570 213250.0n 0.4570 213499.9n 0.4570 213500.0n 0.4570 213749.9n 0.4570 213750.0n 0.4570 213999.9n 0.4570 214000.0n 0.4570 214249.9n 0.4570 214250.0n 0.4570 214499.9n 0.4570 214500.0n 0.4570 214749.9n 0.4570 214750.0n 0.4570 214999.9n 0.4570 215000.0n 0.4570 215249.9n 0.4570 215250.0n 0.4570 215499.9n 0.4570 215500.0n 0.4570 215749.9n 0.4570 215750.0n 0.4570 215999.9n 0.4570 216000.0n 0.4570 216249.9n 0.4570 216250.0n 0.4570 216499.9n 0.4570 216500.0n 0.4570 216749.9n 0.4570 216750.0n 0.5004 216999.9n 0.5004 217000.0n 0.5871 217249.9n 0.5871 217250.0n 0.4570 217499.9n 0.4570 217500.0n 0.4570 217749.9n 0.4570 217750.0n 0.4570 217999.9n 0.4570 218000.0n 0.5438 218249.9n 0.5438 218250.0n 0.4570 218499.9n 0.4570 218500.0n 0.4570 218749.9n 0.4570 218750.0n 0.4570 218999.9n 0.4570 219000.0n 0.4570 219249.9n 0.4570 219250.0n 0.4570 219499.9n 0.4570 219500.0n 0.5871 219749.9n 0.5871 219750.0n 0.4570 219999.9n 0.4570 220000.0n 0.5004 220249.9n 0.5004 220250.0n 0.5871 220499.9n 0.5871 220500.0n 0.4570 220749.9n 0.4570 220750.0n 0.4570 220999.9n 0.4570 221000.0n 0.4570 221249.9n 0.4570 221250.0n 0.4570 221499.9n 0.4570 221500.0n 0.4570 221749.9n 0.4570 221750.0n 0.4570 221999.9n 0.4570 222000.0n 0.4570 222249.9n 0.4570 222250.0n 0.4570 222499.9n 0.4570 222500.0n 0.4570 222749.9n 0.4570 222750.0n 0.4570 222999.9n 0.4570 223000.0n 0.4570 223249.9n 0.4570 223250.0n 0.4570 223499.9n 0.4570 223500.0n 0.4570 223749.9n 0.4570 223750.0n 0.4570 223999.9n 0.4570 224000.0n 0.4570 224249.9n 0.4570 224250.0n 0.5004 224499.9n 0.5004 224500.0n 0.5871 224749.9n 0.5871 224750.0n 0.4570 224999.9n 0.4570 225000.0n 0.4570 225249.9n 0.4570 225250.0n 0.4570 225499.9n 0.4570 225500.0n 0.5438 225749.9n 0.5438 225750.0n 0.4570 225999.9n 0.4570 226000.0n 0.4570 226249.9n 0.4570 226250.0n 0.4570 226499.9n 0.4570 226500.0n 0.4570 226749.9n 0.4570 226750.0n 0.4570 226999.9n 0.4570 227000.0n 0.5871 227249.9n 0.5871 227250.0n 0.4570 227499.9n 0.4570 227500.0n 0.5004 227749.9n 0.5004 227750.0n 0.5871 227999.9n 0.5871 228000.0n 0.4570 228249.9n 0.4570 228250.0n 0.4570 228499.9n 0.4570 228500.0n 0.4570 228749.9n 0.4570 228750.0n 0.4570 228999.9n 0.4570 229000.0n 0.4570 229249.9n 0.4570 229250.0n 0.4570 229499.9n 0.4570 229500.0n 0.4570 229749.9n 0.4570 229750.0n 0.4570 229999.9n 0.4570 230000.0n 0.4570 230249.9n 0.4570 230250.0n 0.4570 230499.9n 0.4570 230500.0n 0.4570 230749.9n 0.4570 230750.0n 0.4570 230999.9n 0.4570 231000.0n 0.4570 231249.9n 0.4570 231250.0n 0.4570 231499.9n 0.4570 231500.0n 0.4570 231749.9n 0.4570 231750.0n 0.5004 231999.9n 0.5004 232000.0n 0.5871 232249.9n 0.5871 232250.0n 0.4570 232499.9n 0.4570 232500.0n 0.4570 232749.9n 0.4570 232750.0n 0.4570 232999.9n 0.4570 233000.0n 0.5438 233249.9n 0.5438 233250.0n 0.4570 233499.9n 0.4570 233500.0n 0.4570 233749.9n 0.4570 233750.0n 0.4570 233999.9n 0.4570 234000.0n 0.4570 234249.9n 0.4570 234250.0n 0.4570 234499.9n 0.4570 234500.0n 0.5871 234749.9n 0.5871 234750.0n 0.4570 234999.9n 0.4570 235000.0n 0.5004 235249.9n 0.5004 235250.0n 0.5871 235499.9n 0.5871 235500.0n 0.4570 235749.9n 0.4570 235750.0n 0.4570 235999.9n 0.4570 236000.0n 0.4570 236249.9n 0.4570 236250.0n 0.4570 236499.9n 0.4570 236500.0n 0.4570 236749.9n 0.4570 236750.0n 0.4570 236999.9n 0.4570 237000.0n 0.4570 237249.9n 0.4570 237250.0n 0.4570 237499.9n 0.4570 237500.0n 0.4570 237749.9n 0.4570 237750.0n 0.4570 237999.9n 0.4570 238000.0n 0.4570 238249.9n 0.4570 238250.0n 0.4570 238499.9n 0.4570 238500.0n 0.4570 238749.9n 0.4570 238750.0n 0.4570 238999.9n 0.4570 239000.0n 0.4570 239249.9n 0.4570 239250.0n 0.5004 239499.9n 0.5004 239500.0n 0.5871 239749.9n 0.5871 239750.0n 0.4570 239999.9n 0.4570 240000.0n 0.4570 240249.9n 0.4570 240250.0n 0.4570 240499.9n 0.4570 240500.0n 0.5438 240749.9n 0.5438 240750.0n 0.4570 240999.9n 0.4570 241000.0n 0.4570 241249.9n 0.4570 241250.0n 0.4570 241499.9n 0.4570 241500.0n 0.4570 241749.9n 0.4570 241750.0n 0.4570 241999.9n 0.4570 242000.0n 0.5871 242249.9n 0.5871 242250.0n 0.4570 242499.9n 0.4570 242500.0n 0.5004 242749.9n 0.5004 242750.0n 0.5871 242999.9n 0.5871 243000.0n 0.4570 243249.9n 0.4570 243250.0n 0.4570 243499.9n 0.4570 243500.0n 0.4570 243749.9n 0.4570 243750.0n 0.4570 243999.9n 0.4570 244000.0n 0.4570 244249.9n 0.4570 244250.0n 0.4570 244499.9n 0.4570 244500.0n 0.4570 244749.9n 0.4570 244750.0n 0.4570 244999.9n 0.4570 245000.0n 0.4570 245249.9n 0.4570 245250.0n 0.4570 245499.9n 0.4570 245500.0n 0.4570 245749.9n 0.4570 245750.0n 0.4570 245999.9n 0.4570 246000.0n 0.4570 246249.9n 0.4570 246250.0n 0.4570 246499.9n 0.4570 246500.0n 0.4570 246749.9n 0.4570 246750.0n 0.5004 246999.9n 0.5004 247000.0n 0.5871 247249.9n 0.5871 247250.0n 0.4570 247499.9n 0.4570 247500.0n 0.4570 247749.9n 0.4570 247750.0n 0.4570 247999.9n 0.4570 248000.0n 0.5438 248249.9n 0.5438 248250.0n 0.4570 248499.9n 0.4570 248500.0n 0.4570 248749.9n 0.4570 248750.0n 0.4570 248999.9n 0.4570 249000.0n 0.4570 249249.9n 0.4570 249250.0n 0.4570 249499.9n 0.4570 249500.0n 0.5871 249749.9n 0.5871 249750.0n 0.4570 249999.9n 0.4570 250000.0n 0.5004 250249.9n 0.5004 250250.0n 0.5871 250499.9n 0.5871 250500.0n 0.4570 250749.9n 0.4570 250750.0n 0.4570 250999.9n 0.4570 251000.0n 0.4570 251249.9n 0.4570 251250.0n 0.4570 251499.9n 0.4570 251500.0n 0.4570 251749.9n 0.4570 251750.0n 0.4570 251999.9n 0.4570 252000.0n 0.4570 252249.9n 0.4570 252250.0n 0.4570 252499.9n 0.4570 252500.0n 0.4570 252749.9n 0.4570 252750.0n 0.4570 252999.9n 0.4570 253000.0n 0.4570 253249.9n 0.4570 253250.0n 0.4570 253499.9n 0.4570 253500.0n 0.4570 253749.9n 0.4570 253750.0n 0.4570 253999.9n 0.4570 254000.0n 0.4570 254249.9n 0.4570 254250.0n 0.5004 254499.9n 0.5004 254500.0n 0.5871 254749.9n 0.5871 254750.0n 0.4570 254999.9n 0.4570 255000.0n 0.4570 255249.9n 0.4570 255250.0n 0.4570 255499.9n 0.4570 255500.0n 0.5438 255749.9n 0.5438 255750.0n 0.4570 255999.9n 0.4570 256000.0n 0.4570 256249.9n 0.4570 256250.0n 0.4570 256499.9n 0.4570 256500.0n 0.4570 256749.9n 0.4570 256750.0n 0.4570 256999.9n 0.4570 257000.0n 0.5871 257249.9n 0.5871 257250.0n 0.4570 257499.9n 0.4570 257500.0n 0.5004 257749.9n 0.5004 257750.0n 0.5871 257999.9n 0.5871 258000.0n 0.4570 258249.9n 0.4570 258250.0n 0.4570 258499.9n 0.4570 258500.0n 0.4570 258749.9n 0.4570 258750.0n 0.4570 258999.9n 0.4570 259000.0n 0.4570 259249.9n 0.4570 259250.0n 0.4570 259499.9n 0.4570 259500.0n 0.4570 259749.9n 0.4570 259750.0n 0.4570 259999.9n 0.4570 260000.0n 0.4570 260249.9n 0.4570 260250.0n 0.4570 260499.9n 0.4570 260500.0n 0.4570 260749.9n 0.4570 260750.0n 0.4570 260999.9n 0.4570 261000.0n 0.4570 261249.9n 0.4570 261250.0n 0.4570 261499.9n 0.4570 261500.0n 0.4570 261749.9n 0.4570 261750.0n 0.5004 261999.9n 0.5004 262000.0n 0.5871 262249.9n 0.5871 262250.0n 0.4570 262499.9n 0.4570 262500.0n 0.4570 262749.9n 0.4570 262750.0n 0.4570 262999.9n 0.4570 263000.0n 0.5438 263249.9n 0.5438 263250.0n 0.4570 263499.9n 0.4570 263500.0n 0.4570 263749.9n 0.4570 263750.0n 0.4570 263999.9n 0.4570 264000.0n 0.4570 264249.9n 0.4570 264250.0n 0.4570 264499.9n 0.4570 264500.0n 0.5871 264749.9n 0.5871 264750.0n 0.4570 264999.9n 0.4570 265000.0n 0.5004 265249.9n 0.5004 265250.0n 0.5871 265499.9n 0.5871 265500.0n 0.4570 265749.9n 0.4570 265750.0n 0.4570 265999.9n 0.4570 266000.0n 0.4570 266249.9n 0.4570 266250.0n 0.4570 266499.9n 0.4570 266500.0n 0.4570 266749.9n 0.4570 266750.0n 0.4570 266999.9n 0.4570 267000.0n 0.4570 267249.9n 0.4570 267250.0n 0.4570 267499.9n 0.4570 267500.0n 0.4570 267749.9n 0.4570 267750.0n 0.4570 267999.9n 0.4570 268000.0n 0.4570 268249.9n 0.4570 268250.0n 0.4570 268499.9n 0.4570 268500.0n 0.4570 268749.9n 0.4570 268750.0n 0.4570 268999.9n 0.4570 269000.0n 0.4570 269249.9n 0.4570 269250.0n 0.5004 269499.9n 0.5004 269500.0n 0.5871 269749.9n 0.5871 269750.0n 0.4570 269999.9n 0.4570 270000.0n 0.4570 270249.9n 0.4570 270250.0n 0.4570 270499.9n 0.4570 270500.0n 0.5438 270749.9n 0.5438 270750.0n 0.4570 270999.9n 0.4570 271000.0n 0.4570 271249.9n 0.4570 271250.0n 0.4570 271499.9n 0.4570 271500.0n 0.4570 271749.9n 0.4570 271750.0n 0.4570 271999.9n 0.4570 272000.0n 0.5871 272249.9n 0.5871 272250.0n 0.4570 272499.9n 0.4570 272500.0n 0.5004 272749.9n 0.5004 272750.0n 0.5871 272999.9n 0.5871 273000.0n 0.4570 273249.9n 0.4570 273250.0n 0.4570 273499.9n 0.4570 273500.0n 0.4570 273749.9n 0.4570 273750.0n 0.4570 273999.9n 0.4570 274000.0n 0.4570 274249.9n 0.4570 274250.0n 0.4570 274499.9n 0.4570 274500.0n 0.4570 274749.9n 0.4570 274750.0n 0.4570 274999.9n 0.4570 275000.0n 0.4570 275249.9n 0.4570 275250.0n 0.4570 275499.9n 0.4570 275500.0n 0.4570 275749.9n 0.4570 275750.0n 0.4570 275999.9n 0.4570 276000.0n 0.4570 276249.9n 0.4570 276250.0n 0.4570 276499.9n 0.4570 276500.0n 0.4570 276749.9n 0.4570 276750.0n 0.5004 276999.9n 0.5004 277000.0n 0.5871 277249.9n 0.5871 277250.0n 0.4570 277499.9n 0.4570 277500.0n 0.4570 277749.9n 0.4570 277750.0n 0.4570 277999.9n 0.4570 278000.0n 0.5438 278249.9n 0.5438 278250.0n 0.4570 278499.9n 0.4570 278500.0n 0.4570 278749.9n 0.4570 278750.0n 0.4570 278999.9n 0.4570 279000.0n 0.4570 279249.9n 0.4570 279250.0n 0.4570 279499.9n 0.4570 279500.0n 0.5871 279749.9n 0.5871 279750.0n 0.4570 279999.9n 0.4570 280000.0n 0.5004 280249.9n 0.5004 280250.0n 0.5871 280499.9n 0.5871 280500.0n 0.4570 280749.9n 0.4570 280750.0n 0.4570 280999.9n 0.4570 281000.0n 0.4570 281249.9n 0.4570 281250.0n 0.4570 281499.9n 0.4570 281500.0n 0.4570 281749.9n 0.4570 281750.0n 0.4570 281999.9n 0.4570 282000.0n 0.4570 282249.9n 0.4570 282250.0n 0.4570 282499.9n 0.4570 282500.0n 0.4570 282749.9n 0.4570 282750.0n 0.4570 282999.9n 0.4570 283000.0n 0.4570 283249.9n 0.4570 283250.0n 0.4570 283499.9n 0.4570 283500.0n 0.4570 283749.9n 0.4570 283750.0n 0.4570 283999.9n 0.4570 284000.0n 0.4570 284249.9n 0.4570 284250.0n 0.5004 284499.9n 0.5004 284500.0n 0.5871 284749.9n 0.5871 284750.0n 0.4570 284999.9n 0.4570 285000.0n 0.4570 285249.9n 0.4570 285250.0n 0.4570 285499.9n 0.4570 285500.0n 0.5438 285749.9n 0.5438 285750.0n 0.4570 285999.9n 0.4570 286000.0n 0.4570 286249.9n 0.4570 286250.0n 0.4570 286499.9n 0.4570 286500.0n 0.4570 286749.9n 0.4570 286750.0n 0.4570 286999.9n 0.4570 287000.0n 0.5871 287249.9n 0.5871 287250.0n 0.4570 287499.9n 0.4570 287500.0n 0.5004 287749.9n 0.5004 287750.0n 0.5871 287999.9n 0.5871 288000.0n 0.4570 288249.9n 0.4570 288250.0n 0.4570 288499.9n 0.4570 288500.0n 0.4570 288749.9n 0.4570 288750.0n 0.4570 288999.9n 0.4570 289000.0n 0.4570 289249.9n 0.4570 289250.0n 0.4570 289499.9n 0.4570 289500.0n 0.4570 289749.9n 0.4570 289750.0n 0.4570 289999.9n 0.4570 290000.0n 0.4570 290249.9n 0.4570 290250.0n 0.4570 290499.9n 0.4570 290500.0n 0.4570 290749.9n 0.4570 290750.0n 0.4570 290999.9n 0.4570 291000.0n 0.4570 291249.9n 0.4570 291250.0n 0.4570 291499.9n 0.4570 291500.0n 0.4570 291749.9n 0.4570 291750.0n 0.5004 291999.9n 0.5004 292000.0n 0.5871 292249.9n 0.5871 292250.0n 0.4570 292499.9n 0.4570 292500.0n 0.4570 292749.9n 0.4570 292750.0n 0.4570 292999.9n 0.4570 293000.0n 0.5438 293249.9n 0.5438 293250.0n 0.4570 293499.9n 0.4570 293500.0n 0.4570 293749.9n 0.4570 293750.0n 0.4570 293999.9n 0.4570 294000.0n 0.4570 294249.9n 0.4570 294250.0n 0.4570 294499.9n 0.4570 294500.0n 0.5871 294749.9n 0.5871 294750.0n 0.4570 294999.9n 0.4570 295000.0n 0.5004 295249.9n 0.5004 295250.0n 0.5871 295499.9n 0.5871 295500.0n 0.4570 295749.9n 0.4570 295750.0n 0.4570 295999.9n 0.4570 296000.0n 0.4570 296249.9n 0.4570 296250.0n 0.4570 296499.9n 0.4570 296500.0n 0.4570 296749.9n 0.4570 296750.0n 0.4570 296999.9n 0.4570 297000.0n 0.4570 297249.9n 0.4570 297250.0n 0.4570 297499.9n 0.4570 297500.0n 0.4570 297749.9n 0.4570 297750.0n 0.4570 297999.9n 0.4570 298000.0n 0.4570 298249.9n 0.4570 298250.0n 0.4570 298499.9n 0.4570 298500.0n 0.4570 298749.9n 0.4570 298750.0n 0.4570 298999.9n 0.4570 299000.0n 0.4570 299249.9n 0.4570 299250.0n 0.5004 299499.9n 0.5004 299500.0n 0.5871 299749.9n 0.5871 299750.0n 0.4570)
Vxn12 a_xn12 0 PWL(0.0n 0.5430 249.9n 0.5430 250.0n 0.5430 499.9n 0.5430 500.0n 0.4562 749.9n 0.4562 750.0n 0.5430 999.9n 0.5430 1000.0n 0.5430 1249.9n 0.5430 1250.0n 0.5430 1499.9n 0.5430 1500.0n 0.5430 1749.9n 0.5430 1750.0n 0.5430 1999.9n 0.5430 2000.0n 0.4129 2249.9n 0.4129 2250.0n 0.5430 2499.9n 0.5430 2500.0n 0.4996 2749.9n 0.4996 2750.0n 0.4129 2999.9n 0.4129 3000.0n 0.5430 3249.9n 0.5430 3250.0n 0.5430 3499.9n 0.5430 3500.0n 0.5430 3749.9n 0.5430 3750.0n 0.5430 3999.9n 0.5430 4000.0n 0.5430 4249.9n 0.5430 4250.0n 0.5430 4499.9n 0.5430 4500.0n 0.5430 4749.9n 0.5430 4750.0n 0.5430 4999.9n 0.5430 5000.0n 0.5430 5249.9n 0.5430 5250.0n 0.5430 5499.9n 0.5430 5500.0n 0.5430 5749.9n 0.5430 5750.0n 0.5430 5999.9n 0.5430 6000.0n 0.5430 6249.9n 0.5430 6250.0n 0.5430 6499.9n 0.5430 6500.0n 0.5430 6749.9n 0.5430 6750.0n 0.4996 6999.9n 0.4996 7000.0n 0.4129 7249.9n 0.4129 7250.0n 0.5430 7499.9n 0.5430 7500.0n 0.5430 7749.9n 0.5430 7750.0n 0.5430 7999.9n 0.5430 8000.0n 0.4562 8249.9n 0.4562 8250.0n 0.5430 8499.9n 0.5430 8500.0n 0.5430 8749.9n 0.5430 8750.0n 0.5430 8999.9n 0.5430 9000.0n 0.5430 9249.9n 0.5430 9250.0n 0.5430 9499.9n 0.5430 9500.0n 0.4129 9749.9n 0.4129 9750.0n 0.5430 9999.9n 0.5430 10000.0n 0.4996 10249.9n 0.4996 10250.0n 0.4129 10499.9n 0.4129 10500.0n 0.5430 10749.9n 0.5430 10750.0n 0.5430 10999.9n 0.5430 11000.0n 0.5430 11249.9n 0.5430 11250.0n 0.5430 11499.9n 0.5430 11500.0n 0.5430 11749.9n 0.5430 11750.0n 0.5430 11999.9n 0.5430 12000.0n 0.5430 12249.9n 0.5430 12250.0n 0.5430 12499.9n 0.5430 12500.0n 0.5430 12749.9n 0.5430 12750.0n 0.5430 12999.9n 0.5430 13000.0n 0.5430 13249.9n 0.5430 13250.0n 0.5430 13499.9n 0.5430 13500.0n 0.5430 13749.9n 0.5430 13750.0n 0.5430 13999.9n 0.5430 14000.0n 0.5430 14249.9n 0.5430 14250.0n 0.4996 14499.9n 0.4996 14500.0n 0.4129 14749.9n 0.4129 14750.0n 0.5430 14999.9n 0.5430 15000.0n 0.5430 15249.9n 0.5430 15250.0n 0.5430 15499.9n 0.5430 15500.0n 0.4562 15749.9n 0.4562 15750.0n 0.5430 15999.9n 0.5430 16000.0n 0.5430 16249.9n 0.5430 16250.0n 0.5430 16499.9n 0.5430 16500.0n 0.5430 16749.9n 0.5430 16750.0n 0.5430 16999.9n 0.5430 17000.0n 0.4129 17249.9n 0.4129 17250.0n 0.5430 17499.9n 0.5430 17500.0n 0.4996 17749.9n 0.4996 17750.0n 0.4129 17999.9n 0.4129 18000.0n 0.5430 18249.9n 0.5430 18250.0n 0.5430 18499.9n 0.5430 18500.0n 0.5430 18749.9n 0.5430 18750.0n 0.5430 18999.9n 0.5430 19000.0n 0.5430 19249.9n 0.5430 19250.0n 0.5430 19499.9n 0.5430 19500.0n 0.5430 19749.9n 0.5430 19750.0n 0.5430 19999.9n 0.5430 20000.0n 0.5430 20249.9n 0.5430 20250.0n 0.5430 20499.9n 0.5430 20500.0n 0.5430 20749.9n 0.5430 20750.0n 0.5430 20999.9n 0.5430 21000.0n 0.5430 21249.9n 0.5430 21250.0n 0.5430 21499.9n 0.5430 21500.0n 0.5430 21749.9n 0.5430 21750.0n 0.4996 21999.9n 0.4996 22000.0n 0.4129 22249.9n 0.4129 22250.0n 0.5430 22499.9n 0.5430 22500.0n 0.5430 22749.9n 0.5430 22750.0n 0.5430 22999.9n 0.5430 23000.0n 0.4562 23249.9n 0.4562 23250.0n 0.5430 23499.9n 0.5430 23500.0n 0.5430 23749.9n 0.5430 23750.0n 0.5430 23999.9n 0.5430 24000.0n 0.5430 24249.9n 0.5430 24250.0n 0.5430 24499.9n 0.5430 24500.0n 0.4129 24749.9n 0.4129 24750.0n 0.5430 24999.9n 0.5430 25000.0n 0.4996 25249.9n 0.4996 25250.0n 0.4129 25499.9n 0.4129 25500.0n 0.5430 25749.9n 0.5430 25750.0n 0.5430 25999.9n 0.5430 26000.0n 0.5430 26249.9n 0.5430 26250.0n 0.5430 26499.9n 0.5430 26500.0n 0.5430 26749.9n 0.5430 26750.0n 0.5430 26999.9n 0.5430 27000.0n 0.5430 27249.9n 0.5430 27250.0n 0.5430 27499.9n 0.5430 27500.0n 0.5430 27749.9n 0.5430 27750.0n 0.5430 27999.9n 0.5430 28000.0n 0.5430 28249.9n 0.5430 28250.0n 0.5430 28499.9n 0.5430 28500.0n 0.5430 28749.9n 0.5430 28750.0n 0.5430 28999.9n 0.5430 29000.0n 0.5430 29249.9n 0.5430 29250.0n 0.4996 29499.9n 0.4996 29500.0n 0.4129 29749.9n 0.4129 29750.0n 0.5430 29999.9n 0.5430 30000.0n 0.5430 30249.9n 0.5430 30250.0n 0.5430 30499.9n 0.5430 30500.0n 0.4562 30749.9n 0.4562 30750.0n 0.5430 30999.9n 0.5430 31000.0n 0.5430 31249.9n 0.5430 31250.0n 0.5430 31499.9n 0.5430 31500.0n 0.5430 31749.9n 0.5430 31750.0n 0.5430 31999.9n 0.5430 32000.0n 0.4129 32249.9n 0.4129 32250.0n 0.5430 32499.9n 0.5430 32500.0n 0.4996 32749.9n 0.4996 32750.0n 0.4129 32999.9n 0.4129 33000.0n 0.5430 33249.9n 0.5430 33250.0n 0.5430 33499.9n 0.5430 33500.0n 0.5430 33749.9n 0.5430 33750.0n 0.5430 33999.9n 0.5430 34000.0n 0.5430 34249.9n 0.5430 34250.0n 0.5430 34499.9n 0.5430 34500.0n 0.5430 34749.9n 0.5430 34750.0n 0.5430 34999.9n 0.5430 35000.0n 0.5430 35249.9n 0.5430 35250.0n 0.5430 35499.9n 0.5430 35500.0n 0.5430 35749.9n 0.5430 35750.0n 0.5430 35999.9n 0.5430 36000.0n 0.5430 36249.9n 0.5430 36250.0n 0.5430 36499.9n 0.5430 36500.0n 0.5430 36749.9n 0.5430 36750.0n 0.4996 36999.9n 0.4996 37000.0n 0.4129 37249.9n 0.4129 37250.0n 0.5430 37499.9n 0.5430 37500.0n 0.5430 37749.9n 0.5430 37750.0n 0.5430 37999.9n 0.5430 38000.0n 0.4562 38249.9n 0.4562 38250.0n 0.5430 38499.9n 0.5430 38500.0n 0.5430 38749.9n 0.5430 38750.0n 0.5430 38999.9n 0.5430 39000.0n 0.5430 39249.9n 0.5430 39250.0n 0.5430 39499.9n 0.5430 39500.0n 0.4129 39749.9n 0.4129 39750.0n 0.5430 39999.9n 0.5430 40000.0n 0.4996 40249.9n 0.4996 40250.0n 0.4129 40499.9n 0.4129 40500.0n 0.5430 40749.9n 0.5430 40750.0n 0.5430 40999.9n 0.5430 41000.0n 0.5430 41249.9n 0.5430 41250.0n 0.5430 41499.9n 0.5430 41500.0n 0.5430 41749.9n 0.5430 41750.0n 0.5430 41999.9n 0.5430 42000.0n 0.5430 42249.9n 0.5430 42250.0n 0.5430 42499.9n 0.5430 42500.0n 0.5430 42749.9n 0.5430 42750.0n 0.5430 42999.9n 0.5430 43000.0n 0.5430 43249.9n 0.5430 43250.0n 0.5430 43499.9n 0.5430 43500.0n 0.5430 43749.9n 0.5430 43750.0n 0.5430 43999.9n 0.5430 44000.0n 0.5430 44249.9n 0.5430 44250.0n 0.4996 44499.9n 0.4996 44500.0n 0.4129 44749.9n 0.4129 44750.0n 0.5430 44999.9n 0.5430 45000.0n 0.5430 45249.9n 0.5430 45250.0n 0.5430 45499.9n 0.5430 45500.0n 0.4562 45749.9n 0.4562 45750.0n 0.5430 45999.9n 0.5430 46000.0n 0.5430 46249.9n 0.5430 46250.0n 0.5430 46499.9n 0.5430 46500.0n 0.5430 46749.9n 0.5430 46750.0n 0.5430 46999.9n 0.5430 47000.0n 0.4129 47249.9n 0.4129 47250.0n 0.5430 47499.9n 0.5430 47500.0n 0.4996 47749.9n 0.4996 47750.0n 0.4129 47999.9n 0.4129 48000.0n 0.5430 48249.9n 0.5430 48250.0n 0.5430 48499.9n 0.5430 48500.0n 0.5430 48749.9n 0.5430 48750.0n 0.5430 48999.9n 0.5430 49000.0n 0.5430 49249.9n 0.5430 49250.0n 0.5430 49499.9n 0.5430 49500.0n 0.5430 49749.9n 0.5430 49750.0n 0.5430 49999.9n 0.5430 50000.0n 0.5430 50249.9n 0.5430 50250.0n 0.5430 50499.9n 0.5430 50500.0n 0.5430 50749.9n 0.5430 50750.0n 0.5430 50999.9n 0.5430 51000.0n 0.5430 51249.9n 0.5430 51250.0n 0.5430 51499.9n 0.5430 51500.0n 0.5430 51749.9n 0.5430 51750.0n 0.4996 51999.9n 0.4996 52000.0n 0.4129 52249.9n 0.4129 52250.0n 0.5430 52499.9n 0.5430 52500.0n 0.5430 52749.9n 0.5430 52750.0n 0.5430 52999.9n 0.5430 53000.0n 0.4562 53249.9n 0.4562 53250.0n 0.5430 53499.9n 0.5430 53500.0n 0.5430 53749.9n 0.5430 53750.0n 0.5430 53999.9n 0.5430 54000.0n 0.5430 54249.9n 0.5430 54250.0n 0.5430 54499.9n 0.5430 54500.0n 0.4129 54749.9n 0.4129 54750.0n 0.5430 54999.9n 0.5430 55000.0n 0.4996 55249.9n 0.4996 55250.0n 0.4129 55499.9n 0.4129 55500.0n 0.5430 55749.9n 0.5430 55750.0n 0.5430 55999.9n 0.5430 56000.0n 0.5430 56249.9n 0.5430 56250.0n 0.5430 56499.9n 0.5430 56500.0n 0.5430 56749.9n 0.5430 56750.0n 0.5430 56999.9n 0.5430 57000.0n 0.5430 57249.9n 0.5430 57250.0n 0.5430 57499.9n 0.5430 57500.0n 0.5430 57749.9n 0.5430 57750.0n 0.5430 57999.9n 0.5430 58000.0n 0.5430 58249.9n 0.5430 58250.0n 0.5430 58499.9n 0.5430 58500.0n 0.5430 58749.9n 0.5430 58750.0n 0.5430 58999.9n 0.5430 59000.0n 0.5430 59249.9n 0.5430 59250.0n 0.4996 59499.9n 0.4996 59500.0n 0.4129 59749.9n 0.4129 59750.0n 0.5430 59999.9n 0.5430 60000.0n 0.5430 60249.9n 0.5430 60250.0n 0.5430 60499.9n 0.5430 60500.0n 0.4562 60749.9n 0.4562 60750.0n 0.5430 60999.9n 0.5430 61000.0n 0.5430 61249.9n 0.5430 61250.0n 0.5430 61499.9n 0.5430 61500.0n 0.5430 61749.9n 0.5430 61750.0n 0.5430 61999.9n 0.5430 62000.0n 0.4129 62249.9n 0.4129 62250.0n 0.5430 62499.9n 0.5430 62500.0n 0.4996 62749.9n 0.4996 62750.0n 0.4129 62999.9n 0.4129 63000.0n 0.5430 63249.9n 0.5430 63250.0n 0.5430 63499.9n 0.5430 63500.0n 0.5430 63749.9n 0.5430 63750.0n 0.5430 63999.9n 0.5430 64000.0n 0.5430 64249.9n 0.5430 64250.0n 0.5430 64499.9n 0.5430 64500.0n 0.5430 64749.9n 0.5430 64750.0n 0.5430 64999.9n 0.5430 65000.0n 0.5430 65249.9n 0.5430 65250.0n 0.5430 65499.9n 0.5430 65500.0n 0.5430 65749.9n 0.5430 65750.0n 0.5430 65999.9n 0.5430 66000.0n 0.5430 66249.9n 0.5430 66250.0n 0.5430 66499.9n 0.5430 66500.0n 0.5430 66749.9n 0.5430 66750.0n 0.4996 66999.9n 0.4996 67000.0n 0.4129 67249.9n 0.4129 67250.0n 0.5430 67499.9n 0.5430 67500.0n 0.5430 67749.9n 0.5430 67750.0n 0.5430 67999.9n 0.5430 68000.0n 0.4562 68249.9n 0.4562 68250.0n 0.5430 68499.9n 0.5430 68500.0n 0.5430 68749.9n 0.5430 68750.0n 0.5430 68999.9n 0.5430 69000.0n 0.5430 69249.9n 0.5430 69250.0n 0.5430 69499.9n 0.5430 69500.0n 0.4129 69749.9n 0.4129 69750.0n 0.5430 69999.9n 0.5430 70000.0n 0.4996 70249.9n 0.4996 70250.0n 0.4129 70499.9n 0.4129 70500.0n 0.5430 70749.9n 0.5430 70750.0n 0.5430 70999.9n 0.5430 71000.0n 0.5430 71249.9n 0.5430 71250.0n 0.5430 71499.9n 0.5430 71500.0n 0.5430 71749.9n 0.5430 71750.0n 0.5430 71999.9n 0.5430 72000.0n 0.5430 72249.9n 0.5430 72250.0n 0.5430 72499.9n 0.5430 72500.0n 0.5430 72749.9n 0.5430 72750.0n 0.5430 72999.9n 0.5430 73000.0n 0.5430 73249.9n 0.5430 73250.0n 0.5430 73499.9n 0.5430 73500.0n 0.5430 73749.9n 0.5430 73750.0n 0.5430 73999.9n 0.5430 74000.0n 0.5430 74249.9n 0.5430 74250.0n 0.4996 74499.9n 0.4996 74500.0n 0.4129 74749.9n 0.4129 74750.0n 0.5430 74999.9n 0.5430 75000.0n 0.5430 75249.9n 0.5430 75250.0n 0.5430 75499.9n 0.5430 75500.0n 0.4562 75749.9n 0.4562 75750.0n 0.5430 75999.9n 0.5430 76000.0n 0.5430 76249.9n 0.5430 76250.0n 0.5430 76499.9n 0.5430 76500.0n 0.5430 76749.9n 0.5430 76750.0n 0.5430 76999.9n 0.5430 77000.0n 0.4129 77249.9n 0.4129 77250.0n 0.5430 77499.9n 0.5430 77500.0n 0.4996 77749.9n 0.4996 77750.0n 0.4129 77999.9n 0.4129 78000.0n 0.5430 78249.9n 0.5430 78250.0n 0.5430 78499.9n 0.5430 78500.0n 0.5430 78749.9n 0.5430 78750.0n 0.5430 78999.9n 0.5430 79000.0n 0.5430 79249.9n 0.5430 79250.0n 0.5430 79499.9n 0.5430 79500.0n 0.5430 79749.9n 0.5430 79750.0n 0.5430 79999.9n 0.5430 80000.0n 0.5430 80249.9n 0.5430 80250.0n 0.5430 80499.9n 0.5430 80500.0n 0.5430 80749.9n 0.5430 80750.0n 0.5430 80999.9n 0.5430 81000.0n 0.5430 81249.9n 0.5430 81250.0n 0.5430 81499.9n 0.5430 81500.0n 0.5430 81749.9n 0.5430 81750.0n 0.4996 81999.9n 0.4996 82000.0n 0.4129 82249.9n 0.4129 82250.0n 0.5430 82499.9n 0.5430 82500.0n 0.5430 82749.9n 0.5430 82750.0n 0.5430 82999.9n 0.5430 83000.0n 0.4562 83249.9n 0.4562 83250.0n 0.5430 83499.9n 0.5430 83500.0n 0.5430 83749.9n 0.5430 83750.0n 0.5430 83999.9n 0.5430 84000.0n 0.5430 84249.9n 0.5430 84250.0n 0.5430 84499.9n 0.5430 84500.0n 0.4129 84749.9n 0.4129 84750.0n 0.5430 84999.9n 0.5430 85000.0n 0.4996 85249.9n 0.4996 85250.0n 0.4129 85499.9n 0.4129 85500.0n 0.5430 85749.9n 0.5430 85750.0n 0.5430 85999.9n 0.5430 86000.0n 0.5430 86249.9n 0.5430 86250.0n 0.5430 86499.9n 0.5430 86500.0n 0.5430 86749.9n 0.5430 86750.0n 0.5430 86999.9n 0.5430 87000.0n 0.5430 87249.9n 0.5430 87250.0n 0.5430 87499.9n 0.5430 87500.0n 0.5430 87749.9n 0.5430 87750.0n 0.5430 87999.9n 0.5430 88000.0n 0.5430 88249.9n 0.5430 88250.0n 0.5430 88499.9n 0.5430 88500.0n 0.5430 88749.9n 0.5430 88750.0n 0.5430 88999.9n 0.5430 89000.0n 0.5430 89249.9n 0.5430 89250.0n 0.4996 89499.9n 0.4996 89500.0n 0.4129 89749.9n 0.4129 89750.0n 0.5430 89999.9n 0.5430 90000.0n 0.5430 90249.9n 0.5430 90250.0n 0.5430 90499.9n 0.5430 90500.0n 0.4562 90749.9n 0.4562 90750.0n 0.5430 90999.9n 0.5430 91000.0n 0.5430 91249.9n 0.5430 91250.0n 0.5430 91499.9n 0.5430 91500.0n 0.5430 91749.9n 0.5430 91750.0n 0.5430 91999.9n 0.5430 92000.0n 0.4129 92249.9n 0.4129 92250.0n 0.5430 92499.9n 0.5430 92500.0n 0.4996 92749.9n 0.4996 92750.0n 0.4129 92999.9n 0.4129 93000.0n 0.5430 93249.9n 0.5430 93250.0n 0.5430 93499.9n 0.5430 93500.0n 0.5430 93749.9n 0.5430 93750.0n 0.5430 93999.9n 0.5430 94000.0n 0.5430 94249.9n 0.5430 94250.0n 0.5430 94499.9n 0.5430 94500.0n 0.5430 94749.9n 0.5430 94750.0n 0.5430 94999.9n 0.5430 95000.0n 0.5430 95249.9n 0.5430 95250.0n 0.5430 95499.9n 0.5430 95500.0n 0.5430 95749.9n 0.5430 95750.0n 0.5430 95999.9n 0.5430 96000.0n 0.5430 96249.9n 0.5430 96250.0n 0.5430 96499.9n 0.5430 96500.0n 0.5430 96749.9n 0.5430 96750.0n 0.4996 96999.9n 0.4996 97000.0n 0.4129 97249.9n 0.4129 97250.0n 0.5430 97499.9n 0.5430 97500.0n 0.5430 97749.9n 0.5430 97750.0n 0.5430 97999.9n 0.5430 98000.0n 0.4562 98249.9n 0.4562 98250.0n 0.5430 98499.9n 0.5430 98500.0n 0.5430 98749.9n 0.5430 98750.0n 0.5430 98999.9n 0.5430 99000.0n 0.5430 99249.9n 0.5430 99250.0n 0.5430 99499.9n 0.5430 99500.0n 0.4129 99749.9n 0.4129 99750.0n 0.5430 99999.9n 0.5430 100000.0n 0.4996 100249.9n 0.4996 100250.0n 0.4129 100499.9n 0.4129 100500.0n 0.5430 100749.9n 0.5430 100750.0n 0.5430 100999.9n 0.5430 101000.0n 0.5430 101249.9n 0.5430 101250.0n 0.5430 101499.9n 0.5430 101500.0n 0.5430 101749.9n 0.5430 101750.0n 0.5430 101999.9n 0.5430 102000.0n 0.5430 102249.9n 0.5430 102250.0n 0.5430 102499.9n 0.5430 102500.0n 0.5430 102749.9n 0.5430 102750.0n 0.5430 102999.9n 0.5430 103000.0n 0.5430 103249.9n 0.5430 103250.0n 0.5430 103499.9n 0.5430 103500.0n 0.5430 103749.9n 0.5430 103750.0n 0.5430 103999.9n 0.5430 104000.0n 0.5430 104249.9n 0.5430 104250.0n 0.4996 104499.9n 0.4996 104500.0n 0.4129 104749.9n 0.4129 104750.0n 0.5430 104999.9n 0.5430 105000.0n 0.5430 105249.9n 0.5430 105250.0n 0.5430 105499.9n 0.5430 105500.0n 0.4562 105749.9n 0.4562 105750.0n 0.5430 105999.9n 0.5430 106000.0n 0.5430 106249.9n 0.5430 106250.0n 0.5430 106499.9n 0.5430 106500.0n 0.5430 106749.9n 0.5430 106750.0n 0.5430 106999.9n 0.5430 107000.0n 0.4129 107249.9n 0.4129 107250.0n 0.5430 107499.9n 0.5430 107500.0n 0.4996 107749.9n 0.4996 107750.0n 0.4129 107999.9n 0.4129 108000.0n 0.5430 108249.9n 0.5430 108250.0n 0.5430 108499.9n 0.5430 108500.0n 0.5430 108749.9n 0.5430 108750.0n 0.5430 108999.9n 0.5430 109000.0n 0.5430 109249.9n 0.5430 109250.0n 0.5430 109499.9n 0.5430 109500.0n 0.5430 109749.9n 0.5430 109750.0n 0.5430 109999.9n 0.5430 110000.0n 0.5430 110249.9n 0.5430 110250.0n 0.5430 110499.9n 0.5430 110500.0n 0.5430 110749.9n 0.5430 110750.0n 0.5430 110999.9n 0.5430 111000.0n 0.5430 111249.9n 0.5430 111250.0n 0.5430 111499.9n 0.5430 111500.0n 0.5430 111749.9n 0.5430 111750.0n 0.4996 111999.9n 0.4996 112000.0n 0.4129 112249.9n 0.4129 112250.0n 0.5430 112499.9n 0.5430 112500.0n 0.5430 112749.9n 0.5430 112750.0n 0.5430 112999.9n 0.5430 113000.0n 0.4562 113249.9n 0.4562 113250.0n 0.5430 113499.9n 0.5430 113500.0n 0.5430 113749.9n 0.5430 113750.0n 0.5430 113999.9n 0.5430 114000.0n 0.5430 114249.9n 0.5430 114250.0n 0.5430 114499.9n 0.5430 114500.0n 0.4129 114749.9n 0.4129 114750.0n 0.5430 114999.9n 0.5430 115000.0n 0.4996 115249.9n 0.4996 115250.0n 0.4129 115499.9n 0.4129 115500.0n 0.5430 115749.9n 0.5430 115750.0n 0.5430 115999.9n 0.5430 116000.0n 0.5430 116249.9n 0.5430 116250.0n 0.5430 116499.9n 0.5430 116500.0n 0.5430 116749.9n 0.5430 116750.0n 0.5430 116999.9n 0.5430 117000.0n 0.5430 117249.9n 0.5430 117250.0n 0.5430 117499.9n 0.5430 117500.0n 0.5430 117749.9n 0.5430 117750.0n 0.5430 117999.9n 0.5430 118000.0n 0.5430 118249.9n 0.5430 118250.0n 0.5430 118499.9n 0.5430 118500.0n 0.5430 118749.9n 0.5430 118750.0n 0.5430 118999.9n 0.5430 119000.0n 0.5430 119249.9n 0.5430 119250.0n 0.4996 119499.9n 0.4996 119500.0n 0.4129 119749.9n 0.4129 119750.0n 0.5430 119999.9n 0.5430 120000.0n 0.5430 120249.9n 0.5430 120250.0n 0.5430 120499.9n 0.5430 120500.0n 0.4562 120749.9n 0.4562 120750.0n 0.5430 120999.9n 0.5430 121000.0n 0.5430 121249.9n 0.5430 121250.0n 0.5430 121499.9n 0.5430 121500.0n 0.5430 121749.9n 0.5430 121750.0n 0.5430 121999.9n 0.5430 122000.0n 0.4129 122249.9n 0.4129 122250.0n 0.5430 122499.9n 0.5430 122500.0n 0.4996 122749.9n 0.4996 122750.0n 0.4129 122999.9n 0.4129 123000.0n 0.5430 123249.9n 0.5430 123250.0n 0.5430 123499.9n 0.5430 123500.0n 0.5430 123749.9n 0.5430 123750.0n 0.5430 123999.9n 0.5430 124000.0n 0.5430 124249.9n 0.5430 124250.0n 0.5430 124499.9n 0.5430 124500.0n 0.5430 124749.9n 0.5430 124750.0n 0.5430 124999.9n 0.5430 125000.0n 0.5430 125249.9n 0.5430 125250.0n 0.5430 125499.9n 0.5430 125500.0n 0.5430 125749.9n 0.5430 125750.0n 0.5430 125999.9n 0.5430 126000.0n 0.5430 126249.9n 0.5430 126250.0n 0.5430 126499.9n 0.5430 126500.0n 0.5430 126749.9n 0.5430 126750.0n 0.4996 126999.9n 0.4996 127000.0n 0.4129 127249.9n 0.4129 127250.0n 0.5430 127499.9n 0.5430 127500.0n 0.5430 127749.9n 0.5430 127750.0n 0.5430 127999.9n 0.5430 128000.0n 0.4562 128249.9n 0.4562 128250.0n 0.5430 128499.9n 0.5430 128500.0n 0.5430 128749.9n 0.5430 128750.0n 0.5430 128999.9n 0.5430 129000.0n 0.5430 129249.9n 0.5430 129250.0n 0.5430 129499.9n 0.5430 129500.0n 0.4129 129749.9n 0.4129 129750.0n 0.5430 129999.9n 0.5430 130000.0n 0.4996 130249.9n 0.4996 130250.0n 0.4129 130499.9n 0.4129 130500.0n 0.5430 130749.9n 0.5430 130750.0n 0.5430 130999.9n 0.5430 131000.0n 0.5430 131249.9n 0.5430 131250.0n 0.5430 131499.9n 0.5430 131500.0n 0.5430 131749.9n 0.5430 131750.0n 0.5430 131999.9n 0.5430 132000.0n 0.5430 132249.9n 0.5430 132250.0n 0.5430 132499.9n 0.5430 132500.0n 0.5430 132749.9n 0.5430 132750.0n 0.5430 132999.9n 0.5430 133000.0n 0.5430 133249.9n 0.5430 133250.0n 0.5430 133499.9n 0.5430 133500.0n 0.5430 133749.9n 0.5430 133750.0n 0.5430 133999.9n 0.5430 134000.0n 0.5430 134249.9n 0.5430 134250.0n 0.4996 134499.9n 0.4996 134500.0n 0.4129 134749.9n 0.4129 134750.0n 0.5430 134999.9n 0.5430 135000.0n 0.5430 135249.9n 0.5430 135250.0n 0.5430 135499.9n 0.5430 135500.0n 0.4562 135749.9n 0.4562 135750.0n 0.5430 135999.9n 0.5430 136000.0n 0.5430 136249.9n 0.5430 136250.0n 0.5430 136499.9n 0.5430 136500.0n 0.5430 136749.9n 0.5430 136750.0n 0.5430 136999.9n 0.5430 137000.0n 0.4129 137249.9n 0.4129 137250.0n 0.5430 137499.9n 0.5430 137500.0n 0.4996 137749.9n 0.4996 137750.0n 0.4129 137999.9n 0.4129 138000.0n 0.5430 138249.9n 0.5430 138250.0n 0.5430 138499.9n 0.5430 138500.0n 0.5430 138749.9n 0.5430 138750.0n 0.5430 138999.9n 0.5430 139000.0n 0.5430 139249.9n 0.5430 139250.0n 0.5430 139499.9n 0.5430 139500.0n 0.5430 139749.9n 0.5430 139750.0n 0.5430 139999.9n 0.5430 140000.0n 0.5430 140249.9n 0.5430 140250.0n 0.5430 140499.9n 0.5430 140500.0n 0.5430 140749.9n 0.5430 140750.0n 0.5430 140999.9n 0.5430 141000.0n 0.5430 141249.9n 0.5430 141250.0n 0.5430 141499.9n 0.5430 141500.0n 0.5430 141749.9n 0.5430 141750.0n 0.4996 141999.9n 0.4996 142000.0n 0.4129 142249.9n 0.4129 142250.0n 0.5430 142499.9n 0.5430 142500.0n 0.5430 142749.9n 0.5430 142750.0n 0.5430 142999.9n 0.5430 143000.0n 0.4562 143249.9n 0.4562 143250.0n 0.5430 143499.9n 0.5430 143500.0n 0.5430 143749.9n 0.5430 143750.0n 0.5430 143999.9n 0.5430 144000.0n 0.5430 144249.9n 0.5430 144250.0n 0.5430 144499.9n 0.5430 144500.0n 0.4129 144749.9n 0.4129 144750.0n 0.5430 144999.9n 0.5430 145000.0n 0.4996 145249.9n 0.4996 145250.0n 0.4129 145499.9n 0.4129 145500.0n 0.5430 145749.9n 0.5430 145750.0n 0.5430 145999.9n 0.5430 146000.0n 0.5430 146249.9n 0.5430 146250.0n 0.5430 146499.9n 0.5430 146500.0n 0.5430 146749.9n 0.5430 146750.0n 0.5430 146999.9n 0.5430 147000.0n 0.5430 147249.9n 0.5430 147250.0n 0.5430 147499.9n 0.5430 147500.0n 0.5430 147749.9n 0.5430 147750.0n 0.5430 147999.9n 0.5430 148000.0n 0.5430 148249.9n 0.5430 148250.0n 0.5430 148499.9n 0.5430 148500.0n 0.5430 148749.9n 0.5430 148750.0n 0.5430 148999.9n 0.5430 149000.0n 0.5430 149249.9n 0.5430 149250.0n 0.4996 149499.9n 0.4996 149500.0n 0.4129 149749.9n 0.4129 149750.0n 0.5430 149999.9n 0.5430 150000.0n 0.5430 150249.9n 0.5430 150250.0n 0.5430 150499.9n 0.5430 150500.0n 0.4562 150749.9n 0.4562 150750.0n 0.5430 150999.9n 0.5430 151000.0n 0.5430 151249.9n 0.5430 151250.0n 0.5430 151499.9n 0.5430 151500.0n 0.5430 151749.9n 0.5430 151750.0n 0.5430 151999.9n 0.5430 152000.0n 0.4129 152249.9n 0.4129 152250.0n 0.5430 152499.9n 0.5430 152500.0n 0.4996 152749.9n 0.4996 152750.0n 0.4129 152999.9n 0.4129 153000.0n 0.5430 153249.9n 0.5430 153250.0n 0.5430 153499.9n 0.5430 153500.0n 0.5430 153749.9n 0.5430 153750.0n 0.5430 153999.9n 0.5430 154000.0n 0.5430 154249.9n 0.5430 154250.0n 0.5430 154499.9n 0.5430 154500.0n 0.5430 154749.9n 0.5430 154750.0n 0.5430 154999.9n 0.5430 155000.0n 0.5430 155249.9n 0.5430 155250.0n 0.5430 155499.9n 0.5430 155500.0n 0.5430 155749.9n 0.5430 155750.0n 0.5430 155999.9n 0.5430 156000.0n 0.5430 156249.9n 0.5430 156250.0n 0.5430 156499.9n 0.5430 156500.0n 0.5430 156749.9n 0.5430 156750.0n 0.4996 156999.9n 0.4996 157000.0n 0.4129 157249.9n 0.4129 157250.0n 0.5430 157499.9n 0.5430 157500.0n 0.5430 157749.9n 0.5430 157750.0n 0.5430 157999.9n 0.5430 158000.0n 0.4562 158249.9n 0.4562 158250.0n 0.5430 158499.9n 0.5430 158500.0n 0.5430 158749.9n 0.5430 158750.0n 0.5430 158999.9n 0.5430 159000.0n 0.5430 159249.9n 0.5430 159250.0n 0.5430 159499.9n 0.5430 159500.0n 0.4129 159749.9n 0.4129 159750.0n 0.5430 159999.9n 0.5430 160000.0n 0.4996 160249.9n 0.4996 160250.0n 0.4129 160499.9n 0.4129 160500.0n 0.5430 160749.9n 0.5430 160750.0n 0.5430 160999.9n 0.5430 161000.0n 0.5430 161249.9n 0.5430 161250.0n 0.5430 161499.9n 0.5430 161500.0n 0.5430 161749.9n 0.5430 161750.0n 0.5430 161999.9n 0.5430 162000.0n 0.5430 162249.9n 0.5430 162250.0n 0.5430 162499.9n 0.5430 162500.0n 0.5430 162749.9n 0.5430 162750.0n 0.5430 162999.9n 0.5430 163000.0n 0.5430 163249.9n 0.5430 163250.0n 0.5430 163499.9n 0.5430 163500.0n 0.5430 163749.9n 0.5430 163750.0n 0.5430 163999.9n 0.5430 164000.0n 0.5430 164249.9n 0.5430 164250.0n 0.4996 164499.9n 0.4996 164500.0n 0.4129 164749.9n 0.4129 164750.0n 0.5430 164999.9n 0.5430 165000.0n 0.5430 165249.9n 0.5430 165250.0n 0.5430 165499.9n 0.5430 165500.0n 0.4562 165749.9n 0.4562 165750.0n 0.5430 165999.9n 0.5430 166000.0n 0.5430 166249.9n 0.5430 166250.0n 0.5430 166499.9n 0.5430 166500.0n 0.5430 166749.9n 0.5430 166750.0n 0.5430 166999.9n 0.5430 167000.0n 0.4129 167249.9n 0.4129 167250.0n 0.5430 167499.9n 0.5430 167500.0n 0.4996 167749.9n 0.4996 167750.0n 0.4129 167999.9n 0.4129 168000.0n 0.5430 168249.9n 0.5430 168250.0n 0.5430 168499.9n 0.5430 168500.0n 0.5430 168749.9n 0.5430 168750.0n 0.5430 168999.9n 0.5430 169000.0n 0.5430 169249.9n 0.5430 169250.0n 0.5430 169499.9n 0.5430 169500.0n 0.5430 169749.9n 0.5430 169750.0n 0.5430 169999.9n 0.5430 170000.0n 0.5430 170249.9n 0.5430 170250.0n 0.5430 170499.9n 0.5430 170500.0n 0.5430 170749.9n 0.5430 170750.0n 0.5430 170999.9n 0.5430 171000.0n 0.5430 171249.9n 0.5430 171250.0n 0.5430 171499.9n 0.5430 171500.0n 0.5430 171749.9n 0.5430 171750.0n 0.4996 171999.9n 0.4996 172000.0n 0.4129 172249.9n 0.4129 172250.0n 0.5430 172499.9n 0.5430 172500.0n 0.5430 172749.9n 0.5430 172750.0n 0.5430 172999.9n 0.5430 173000.0n 0.4562 173249.9n 0.4562 173250.0n 0.5430 173499.9n 0.5430 173500.0n 0.5430 173749.9n 0.5430 173750.0n 0.5430 173999.9n 0.5430 174000.0n 0.5430 174249.9n 0.5430 174250.0n 0.5430 174499.9n 0.5430 174500.0n 0.4129 174749.9n 0.4129 174750.0n 0.5430 174999.9n 0.5430 175000.0n 0.4996 175249.9n 0.4996 175250.0n 0.4129 175499.9n 0.4129 175500.0n 0.5430 175749.9n 0.5430 175750.0n 0.5430 175999.9n 0.5430 176000.0n 0.5430 176249.9n 0.5430 176250.0n 0.5430 176499.9n 0.5430 176500.0n 0.5430 176749.9n 0.5430 176750.0n 0.5430 176999.9n 0.5430 177000.0n 0.5430 177249.9n 0.5430 177250.0n 0.5430 177499.9n 0.5430 177500.0n 0.5430 177749.9n 0.5430 177750.0n 0.5430 177999.9n 0.5430 178000.0n 0.5430 178249.9n 0.5430 178250.0n 0.5430 178499.9n 0.5430 178500.0n 0.5430 178749.9n 0.5430 178750.0n 0.5430 178999.9n 0.5430 179000.0n 0.5430 179249.9n 0.5430 179250.0n 0.4996 179499.9n 0.4996 179500.0n 0.4129 179749.9n 0.4129 179750.0n 0.5430 179999.9n 0.5430 180000.0n 0.5430 180249.9n 0.5430 180250.0n 0.5430 180499.9n 0.5430 180500.0n 0.4562 180749.9n 0.4562 180750.0n 0.5430 180999.9n 0.5430 181000.0n 0.5430 181249.9n 0.5430 181250.0n 0.5430 181499.9n 0.5430 181500.0n 0.5430 181749.9n 0.5430 181750.0n 0.5430 181999.9n 0.5430 182000.0n 0.4129 182249.9n 0.4129 182250.0n 0.5430 182499.9n 0.5430 182500.0n 0.4996 182749.9n 0.4996 182750.0n 0.4129 182999.9n 0.4129 183000.0n 0.5430 183249.9n 0.5430 183250.0n 0.5430 183499.9n 0.5430 183500.0n 0.5430 183749.9n 0.5430 183750.0n 0.5430 183999.9n 0.5430 184000.0n 0.5430 184249.9n 0.5430 184250.0n 0.5430 184499.9n 0.5430 184500.0n 0.5430 184749.9n 0.5430 184750.0n 0.5430 184999.9n 0.5430 185000.0n 0.5430 185249.9n 0.5430 185250.0n 0.5430 185499.9n 0.5430 185500.0n 0.5430 185749.9n 0.5430 185750.0n 0.5430 185999.9n 0.5430 186000.0n 0.5430 186249.9n 0.5430 186250.0n 0.5430 186499.9n 0.5430 186500.0n 0.5430 186749.9n 0.5430 186750.0n 0.4996 186999.9n 0.4996 187000.0n 0.4129 187249.9n 0.4129 187250.0n 0.5430 187499.9n 0.5430 187500.0n 0.5430 187749.9n 0.5430 187750.0n 0.5430 187999.9n 0.5430 188000.0n 0.4562 188249.9n 0.4562 188250.0n 0.5430 188499.9n 0.5430 188500.0n 0.5430 188749.9n 0.5430 188750.0n 0.5430 188999.9n 0.5430 189000.0n 0.5430 189249.9n 0.5430 189250.0n 0.5430 189499.9n 0.5430 189500.0n 0.4129 189749.9n 0.4129 189750.0n 0.5430 189999.9n 0.5430 190000.0n 0.4996 190249.9n 0.4996 190250.0n 0.4129 190499.9n 0.4129 190500.0n 0.5430 190749.9n 0.5430 190750.0n 0.5430 190999.9n 0.5430 191000.0n 0.5430 191249.9n 0.5430 191250.0n 0.5430 191499.9n 0.5430 191500.0n 0.5430 191749.9n 0.5430 191750.0n 0.5430 191999.9n 0.5430 192000.0n 0.5430 192249.9n 0.5430 192250.0n 0.5430 192499.9n 0.5430 192500.0n 0.5430 192749.9n 0.5430 192750.0n 0.5430 192999.9n 0.5430 193000.0n 0.5430 193249.9n 0.5430 193250.0n 0.5430 193499.9n 0.5430 193500.0n 0.5430 193749.9n 0.5430 193750.0n 0.5430 193999.9n 0.5430 194000.0n 0.5430 194249.9n 0.5430 194250.0n 0.4996 194499.9n 0.4996 194500.0n 0.4129 194749.9n 0.4129 194750.0n 0.5430 194999.9n 0.5430 195000.0n 0.5430 195249.9n 0.5430 195250.0n 0.5430 195499.9n 0.5430 195500.0n 0.4562 195749.9n 0.4562 195750.0n 0.5430 195999.9n 0.5430 196000.0n 0.5430 196249.9n 0.5430 196250.0n 0.5430 196499.9n 0.5430 196500.0n 0.5430 196749.9n 0.5430 196750.0n 0.5430 196999.9n 0.5430 197000.0n 0.4129 197249.9n 0.4129 197250.0n 0.5430 197499.9n 0.5430 197500.0n 0.4996 197749.9n 0.4996 197750.0n 0.4129 197999.9n 0.4129 198000.0n 0.5430 198249.9n 0.5430 198250.0n 0.5430 198499.9n 0.5430 198500.0n 0.5430 198749.9n 0.5430 198750.0n 0.5430 198999.9n 0.5430 199000.0n 0.5430 199249.9n 0.5430 199250.0n 0.5430 199499.9n 0.5430 199500.0n 0.5430 199749.9n 0.5430 199750.0n 0.5430 199999.9n 0.5430 200000.0n 0.5430 200249.9n 0.5430 200250.0n 0.5430 200499.9n 0.5430 200500.0n 0.5430 200749.9n 0.5430 200750.0n 0.5430 200999.9n 0.5430 201000.0n 0.5430 201249.9n 0.5430 201250.0n 0.5430 201499.9n 0.5430 201500.0n 0.5430 201749.9n 0.5430 201750.0n 0.4996 201999.9n 0.4996 202000.0n 0.4129 202249.9n 0.4129 202250.0n 0.5430 202499.9n 0.5430 202500.0n 0.5430 202749.9n 0.5430 202750.0n 0.5430 202999.9n 0.5430 203000.0n 0.4562 203249.9n 0.4562 203250.0n 0.5430 203499.9n 0.5430 203500.0n 0.5430 203749.9n 0.5430 203750.0n 0.5430 203999.9n 0.5430 204000.0n 0.5430 204249.9n 0.5430 204250.0n 0.5430 204499.9n 0.5430 204500.0n 0.4129 204749.9n 0.4129 204750.0n 0.5430 204999.9n 0.5430 205000.0n 0.4996 205249.9n 0.4996 205250.0n 0.4129 205499.9n 0.4129 205500.0n 0.5430 205749.9n 0.5430 205750.0n 0.5430 205999.9n 0.5430 206000.0n 0.5430 206249.9n 0.5430 206250.0n 0.5430 206499.9n 0.5430 206500.0n 0.5430 206749.9n 0.5430 206750.0n 0.5430 206999.9n 0.5430 207000.0n 0.5430 207249.9n 0.5430 207250.0n 0.5430 207499.9n 0.5430 207500.0n 0.5430 207749.9n 0.5430 207750.0n 0.5430 207999.9n 0.5430 208000.0n 0.5430 208249.9n 0.5430 208250.0n 0.5430 208499.9n 0.5430 208500.0n 0.5430 208749.9n 0.5430 208750.0n 0.5430 208999.9n 0.5430 209000.0n 0.5430 209249.9n 0.5430 209250.0n 0.4996 209499.9n 0.4996 209500.0n 0.4129 209749.9n 0.4129 209750.0n 0.5430 209999.9n 0.5430 210000.0n 0.5430 210249.9n 0.5430 210250.0n 0.5430 210499.9n 0.5430 210500.0n 0.4562 210749.9n 0.4562 210750.0n 0.5430 210999.9n 0.5430 211000.0n 0.5430 211249.9n 0.5430 211250.0n 0.5430 211499.9n 0.5430 211500.0n 0.5430 211749.9n 0.5430 211750.0n 0.5430 211999.9n 0.5430 212000.0n 0.4129 212249.9n 0.4129 212250.0n 0.5430 212499.9n 0.5430 212500.0n 0.4996 212749.9n 0.4996 212750.0n 0.4129 212999.9n 0.4129 213000.0n 0.5430 213249.9n 0.5430 213250.0n 0.5430 213499.9n 0.5430 213500.0n 0.5430 213749.9n 0.5430 213750.0n 0.5430 213999.9n 0.5430 214000.0n 0.5430 214249.9n 0.5430 214250.0n 0.5430 214499.9n 0.5430 214500.0n 0.5430 214749.9n 0.5430 214750.0n 0.5430 214999.9n 0.5430 215000.0n 0.5430 215249.9n 0.5430 215250.0n 0.5430 215499.9n 0.5430 215500.0n 0.5430 215749.9n 0.5430 215750.0n 0.5430 215999.9n 0.5430 216000.0n 0.5430 216249.9n 0.5430 216250.0n 0.5430 216499.9n 0.5430 216500.0n 0.5430 216749.9n 0.5430 216750.0n 0.4996 216999.9n 0.4996 217000.0n 0.4129 217249.9n 0.4129 217250.0n 0.5430 217499.9n 0.5430 217500.0n 0.5430 217749.9n 0.5430 217750.0n 0.5430 217999.9n 0.5430 218000.0n 0.4562 218249.9n 0.4562 218250.0n 0.5430 218499.9n 0.5430 218500.0n 0.5430 218749.9n 0.5430 218750.0n 0.5430 218999.9n 0.5430 219000.0n 0.5430 219249.9n 0.5430 219250.0n 0.5430 219499.9n 0.5430 219500.0n 0.4129 219749.9n 0.4129 219750.0n 0.5430 219999.9n 0.5430 220000.0n 0.4996 220249.9n 0.4996 220250.0n 0.4129 220499.9n 0.4129 220500.0n 0.5430 220749.9n 0.5430 220750.0n 0.5430 220999.9n 0.5430 221000.0n 0.5430 221249.9n 0.5430 221250.0n 0.5430 221499.9n 0.5430 221500.0n 0.5430 221749.9n 0.5430 221750.0n 0.5430 221999.9n 0.5430 222000.0n 0.5430 222249.9n 0.5430 222250.0n 0.5430 222499.9n 0.5430 222500.0n 0.5430 222749.9n 0.5430 222750.0n 0.5430 222999.9n 0.5430 223000.0n 0.5430 223249.9n 0.5430 223250.0n 0.5430 223499.9n 0.5430 223500.0n 0.5430 223749.9n 0.5430 223750.0n 0.5430 223999.9n 0.5430 224000.0n 0.5430 224249.9n 0.5430 224250.0n 0.4996 224499.9n 0.4996 224500.0n 0.4129 224749.9n 0.4129 224750.0n 0.5430 224999.9n 0.5430 225000.0n 0.5430 225249.9n 0.5430 225250.0n 0.5430 225499.9n 0.5430 225500.0n 0.4562 225749.9n 0.4562 225750.0n 0.5430 225999.9n 0.5430 226000.0n 0.5430 226249.9n 0.5430 226250.0n 0.5430 226499.9n 0.5430 226500.0n 0.5430 226749.9n 0.5430 226750.0n 0.5430 226999.9n 0.5430 227000.0n 0.4129 227249.9n 0.4129 227250.0n 0.5430 227499.9n 0.5430 227500.0n 0.4996 227749.9n 0.4996 227750.0n 0.4129 227999.9n 0.4129 228000.0n 0.5430 228249.9n 0.5430 228250.0n 0.5430 228499.9n 0.5430 228500.0n 0.5430 228749.9n 0.5430 228750.0n 0.5430 228999.9n 0.5430 229000.0n 0.5430 229249.9n 0.5430 229250.0n 0.5430 229499.9n 0.5430 229500.0n 0.5430 229749.9n 0.5430 229750.0n 0.5430 229999.9n 0.5430 230000.0n 0.5430 230249.9n 0.5430 230250.0n 0.5430 230499.9n 0.5430 230500.0n 0.5430 230749.9n 0.5430 230750.0n 0.5430 230999.9n 0.5430 231000.0n 0.5430 231249.9n 0.5430 231250.0n 0.5430 231499.9n 0.5430 231500.0n 0.5430 231749.9n 0.5430 231750.0n 0.4996 231999.9n 0.4996 232000.0n 0.4129 232249.9n 0.4129 232250.0n 0.5430 232499.9n 0.5430 232500.0n 0.5430 232749.9n 0.5430 232750.0n 0.5430 232999.9n 0.5430 233000.0n 0.4562 233249.9n 0.4562 233250.0n 0.5430 233499.9n 0.5430 233500.0n 0.5430 233749.9n 0.5430 233750.0n 0.5430 233999.9n 0.5430 234000.0n 0.5430 234249.9n 0.5430 234250.0n 0.5430 234499.9n 0.5430 234500.0n 0.4129 234749.9n 0.4129 234750.0n 0.5430 234999.9n 0.5430 235000.0n 0.4996 235249.9n 0.4996 235250.0n 0.4129 235499.9n 0.4129 235500.0n 0.5430 235749.9n 0.5430 235750.0n 0.5430 235999.9n 0.5430 236000.0n 0.5430 236249.9n 0.5430 236250.0n 0.5430 236499.9n 0.5430 236500.0n 0.5430 236749.9n 0.5430 236750.0n 0.5430 236999.9n 0.5430 237000.0n 0.5430 237249.9n 0.5430 237250.0n 0.5430 237499.9n 0.5430 237500.0n 0.5430 237749.9n 0.5430 237750.0n 0.5430 237999.9n 0.5430 238000.0n 0.5430 238249.9n 0.5430 238250.0n 0.5430 238499.9n 0.5430 238500.0n 0.5430 238749.9n 0.5430 238750.0n 0.5430 238999.9n 0.5430 239000.0n 0.5430 239249.9n 0.5430 239250.0n 0.4996 239499.9n 0.4996 239500.0n 0.4129 239749.9n 0.4129 239750.0n 0.5430 239999.9n 0.5430 240000.0n 0.5430 240249.9n 0.5430 240250.0n 0.5430 240499.9n 0.5430 240500.0n 0.4562 240749.9n 0.4562 240750.0n 0.5430 240999.9n 0.5430 241000.0n 0.5430 241249.9n 0.5430 241250.0n 0.5430 241499.9n 0.5430 241500.0n 0.5430 241749.9n 0.5430 241750.0n 0.5430 241999.9n 0.5430 242000.0n 0.4129 242249.9n 0.4129 242250.0n 0.5430 242499.9n 0.5430 242500.0n 0.4996 242749.9n 0.4996 242750.0n 0.4129 242999.9n 0.4129 243000.0n 0.5430 243249.9n 0.5430 243250.0n 0.5430 243499.9n 0.5430 243500.0n 0.5430 243749.9n 0.5430 243750.0n 0.5430 243999.9n 0.5430 244000.0n 0.5430 244249.9n 0.5430 244250.0n 0.5430 244499.9n 0.5430 244500.0n 0.5430 244749.9n 0.5430 244750.0n 0.5430 244999.9n 0.5430 245000.0n 0.5430 245249.9n 0.5430 245250.0n 0.5430 245499.9n 0.5430 245500.0n 0.5430 245749.9n 0.5430 245750.0n 0.5430 245999.9n 0.5430 246000.0n 0.5430 246249.9n 0.5430 246250.0n 0.5430 246499.9n 0.5430 246500.0n 0.5430 246749.9n 0.5430 246750.0n 0.4996 246999.9n 0.4996 247000.0n 0.4129 247249.9n 0.4129 247250.0n 0.5430 247499.9n 0.5430 247500.0n 0.5430 247749.9n 0.5430 247750.0n 0.5430 247999.9n 0.5430 248000.0n 0.4562 248249.9n 0.4562 248250.0n 0.5430 248499.9n 0.5430 248500.0n 0.5430 248749.9n 0.5430 248750.0n 0.5430 248999.9n 0.5430 249000.0n 0.5430 249249.9n 0.5430 249250.0n 0.5430 249499.9n 0.5430 249500.0n 0.4129 249749.9n 0.4129 249750.0n 0.5430 249999.9n 0.5430 250000.0n 0.4996 250249.9n 0.4996 250250.0n 0.4129 250499.9n 0.4129 250500.0n 0.5430 250749.9n 0.5430 250750.0n 0.5430 250999.9n 0.5430 251000.0n 0.5430 251249.9n 0.5430 251250.0n 0.5430 251499.9n 0.5430 251500.0n 0.5430 251749.9n 0.5430 251750.0n 0.5430 251999.9n 0.5430 252000.0n 0.5430 252249.9n 0.5430 252250.0n 0.5430 252499.9n 0.5430 252500.0n 0.5430 252749.9n 0.5430 252750.0n 0.5430 252999.9n 0.5430 253000.0n 0.5430 253249.9n 0.5430 253250.0n 0.5430 253499.9n 0.5430 253500.0n 0.5430 253749.9n 0.5430 253750.0n 0.5430 253999.9n 0.5430 254000.0n 0.5430 254249.9n 0.5430 254250.0n 0.4996 254499.9n 0.4996 254500.0n 0.4129 254749.9n 0.4129 254750.0n 0.5430 254999.9n 0.5430 255000.0n 0.5430 255249.9n 0.5430 255250.0n 0.5430 255499.9n 0.5430 255500.0n 0.4562 255749.9n 0.4562 255750.0n 0.5430 255999.9n 0.5430 256000.0n 0.5430 256249.9n 0.5430 256250.0n 0.5430 256499.9n 0.5430 256500.0n 0.5430 256749.9n 0.5430 256750.0n 0.5430 256999.9n 0.5430 257000.0n 0.4129 257249.9n 0.4129 257250.0n 0.5430 257499.9n 0.5430 257500.0n 0.4996 257749.9n 0.4996 257750.0n 0.4129 257999.9n 0.4129 258000.0n 0.5430 258249.9n 0.5430 258250.0n 0.5430 258499.9n 0.5430 258500.0n 0.5430 258749.9n 0.5430 258750.0n 0.5430 258999.9n 0.5430 259000.0n 0.5430 259249.9n 0.5430 259250.0n 0.5430 259499.9n 0.5430 259500.0n 0.5430 259749.9n 0.5430 259750.0n 0.5430 259999.9n 0.5430 260000.0n 0.5430 260249.9n 0.5430 260250.0n 0.5430 260499.9n 0.5430 260500.0n 0.5430 260749.9n 0.5430 260750.0n 0.5430 260999.9n 0.5430 261000.0n 0.5430 261249.9n 0.5430 261250.0n 0.5430 261499.9n 0.5430 261500.0n 0.5430 261749.9n 0.5430 261750.0n 0.4996 261999.9n 0.4996 262000.0n 0.4129 262249.9n 0.4129 262250.0n 0.5430 262499.9n 0.5430 262500.0n 0.5430 262749.9n 0.5430 262750.0n 0.5430 262999.9n 0.5430 263000.0n 0.4562 263249.9n 0.4562 263250.0n 0.5430 263499.9n 0.5430 263500.0n 0.5430 263749.9n 0.5430 263750.0n 0.5430 263999.9n 0.5430 264000.0n 0.5430 264249.9n 0.5430 264250.0n 0.5430 264499.9n 0.5430 264500.0n 0.4129 264749.9n 0.4129 264750.0n 0.5430 264999.9n 0.5430 265000.0n 0.4996 265249.9n 0.4996 265250.0n 0.4129 265499.9n 0.4129 265500.0n 0.5430 265749.9n 0.5430 265750.0n 0.5430 265999.9n 0.5430 266000.0n 0.5430 266249.9n 0.5430 266250.0n 0.5430 266499.9n 0.5430 266500.0n 0.5430 266749.9n 0.5430 266750.0n 0.5430 266999.9n 0.5430 267000.0n 0.5430 267249.9n 0.5430 267250.0n 0.5430 267499.9n 0.5430 267500.0n 0.5430 267749.9n 0.5430 267750.0n 0.5430 267999.9n 0.5430 268000.0n 0.5430 268249.9n 0.5430 268250.0n 0.5430 268499.9n 0.5430 268500.0n 0.5430 268749.9n 0.5430 268750.0n 0.5430 268999.9n 0.5430 269000.0n 0.5430 269249.9n 0.5430 269250.0n 0.4996 269499.9n 0.4996 269500.0n 0.4129 269749.9n 0.4129 269750.0n 0.5430 269999.9n 0.5430 270000.0n 0.5430 270249.9n 0.5430 270250.0n 0.5430 270499.9n 0.5430 270500.0n 0.4562 270749.9n 0.4562 270750.0n 0.5430 270999.9n 0.5430 271000.0n 0.5430 271249.9n 0.5430 271250.0n 0.5430 271499.9n 0.5430 271500.0n 0.5430 271749.9n 0.5430 271750.0n 0.5430 271999.9n 0.5430 272000.0n 0.4129 272249.9n 0.4129 272250.0n 0.5430 272499.9n 0.5430 272500.0n 0.4996 272749.9n 0.4996 272750.0n 0.4129 272999.9n 0.4129 273000.0n 0.5430 273249.9n 0.5430 273250.0n 0.5430 273499.9n 0.5430 273500.0n 0.5430 273749.9n 0.5430 273750.0n 0.5430 273999.9n 0.5430 274000.0n 0.5430 274249.9n 0.5430 274250.0n 0.5430 274499.9n 0.5430 274500.0n 0.5430 274749.9n 0.5430 274750.0n 0.5430 274999.9n 0.5430 275000.0n 0.5430 275249.9n 0.5430 275250.0n 0.5430 275499.9n 0.5430 275500.0n 0.5430 275749.9n 0.5430 275750.0n 0.5430 275999.9n 0.5430 276000.0n 0.5430 276249.9n 0.5430 276250.0n 0.5430 276499.9n 0.5430 276500.0n 0.5430 276749.9n 0.5430 276750.0n 0.4996 276999.9n 0.4996 277000.0n 0.4129 277249.9n 0.4129 277250.0n 0.5430 277499.9n 0.5430 277500.0n 0.5430 277749.9n 0.5430 277750.0n 0.5430 277999.9n 0.5430 278000.0n 0.4562 278249.9n 0.4562 278250.0n 0.5430 278499.9n 0.5430 278500.0n 0.5430 278749.9n 0.5430 278750.0n 0.5430 278999.9n 0.5430 279000.0n 0.5430 279249.9n 0.5430 279250.0n 0.5430 279499.9n 0.5430 279500.0n 0.4129 279749.9n 0.4129 279750.0n 0.5430 279999.9n 0.5430 280000.0n 0.4996 280249.9n 0.4996 280250.0n 0.4129 280499.9n 0.4129 280500.0n 0.5430 280749.9n 0.5430 280750.0n 0.5430 280999.9n 0.5430 281000.0n 0.5430 281249.9n 0.5430 281250.0n 0.5430 281499.9n 0.5430 281500.0n 0.5430 281749.9n 0.5430 281750.0n 0.5430 281999.9n 0.5430 282000.0n 0.5430 282249.9n 0.5430 282250.0n 0.5430 282499.9n 0.5430 282500.0n 0.5430 282749.9n 0.5430 282750.0n 0.5430 282999.9n 0.5430 283000.0n 0.5430 283249.9n 0.5430 283250.0n 0.5430 283499.9n 0.5430 283500.0n 0.5430 283749.9n 0.5430 283750.0n 0.5430 283999.9n 0.5430 284000.0n 0.5430 284249.9n 0.5430 284250.0n 0.4996 284499.9n 0.4996 284500.0n 0.4129 284749.9n 0.4129 284750.0n 0.5430 284999.9n 0.5430 285000.0n 0.5430 285249.9n 0.5430 285250.0n 0.5430 285499.9n 0.5430 285500.0n 0.4562 285749.9n 0.4562 285750.0n 0.5430 285999.9n 0.5430 286000.0n 0.5430 286249.9n 0.5430 286250.0n 0.5430 286499.9n 0.5430 286500.0n 0.5430 286749.9n 0.5430 286750.0n 0.5430 286999.9n 0.5430 287000.0n 0.4129 287249.9n 0.4129 287250.0n 0.5430 287499.9n 0.5430 287500.0n 0.4996 287749.9n 0.4996 287750.0n 0.4129 287999.9n 0.4129 288000.0n 0.5430 288249.9n 0.5430 288250.0n 0.5430 288499.9n 0.5430 288500.0n 0.5430 288749.9n 0.5430 288750.0n 0.5430 288999.9n 0.5430 289000.0n 0.5430 289249.9n 0.5430 289250.0n 0.5430 289499.9n 0.5430 289500.0n 0.5430 289749.9n 0.5430 289750.0n 0.5430 289999.9n 0.5430 290000.0n 0.5430 290249.9n 0.5430 290250.0n 0.5430 290499.9n 0.5430 290500.0n 0.5430 290749.9n 0.5430 290750.0n 0.5430 290999.9n 0.5430 291000.0n 0.5430 291249.9n 0.5430 291250.0n 0.5430 291499.9n 0.5430 291500.0n 0.5430 291749.9n 0.5430 291750.0n 0.4996 291999.9n 0.4996 292000.0n 0.4129 292249.9n 0.4129 292250.0n 0.5430 292499.9n 0.5430 292500.0n 0.5430 292749.9n 0.5430 292750.0n 0.5430 292999.9n 0.5430 293000.0n 0.4562 293249.9n 0.4562 293250.0n 0.5430 293499.9n 0.5430 293500.0n 0.5430 293749.9n 0.5430 293750.0n 0.5430 293999.9n 0.5430 294000.0n 0.5430 294249.9n 0.5430 294250.0n 0.5430 294499.9n 0.5430 294500.0n 0.4129 294749.9n 0.4129 294750.0n 0.5430 294999.9n 0.5430 295000.0n 0.4996 295249.9n 0.4996 295250.0n 0.4129 295499.9n 0.4129 295500.0n 0.5430 295749.9n 0.5430 295750.0n 0.5430 295999.9n 0.5430 296000.0n 0.5430 296249.9n 0.5430 296250.0n 0.5430 296499.9n 0.5430 296500.0n 0.5430 296749.9n 0.5430 296750.0n 0.5430 296999.9n 0.5430 297000.0n 0.5430 297249.9n 0.5430 297250.0n 0.5430 297499.9n 0.5430 297500.0n 0.5430 297749.9n 0.5430 297750.0n 0.5430 297999.9n 0.5430 298000.0n 0.5430 298249.9n 0.5430 298250.0n 0.5430 298499.9n 0.5430 298500.0n 0.5430 298749.9n 0.5430 298750.0n 0.5430 298999.9n 0.5430 299000.0n 0.5430 299249.9n 0.5430 299250.0n 0.4996 299499.9n 0.4996 299500.0n 0.4129 299749.9n 0.4129 299750.0n 0.5430)
Vxp13 a_xp13 0 PWL(0.0n 0.2339 249.9n 0.2339 250.0n 0.5330 499.9n 0.5330 500.0n 0.5330 749.9n 0.5330 750.0n 0.5484 999.9n 0.5484 1000.0n 0.5484 1249.9n 0.5484 1250.0n 0.2339 1499.9n 0.2339 1500.0n 0.4563 1749.9n 0.4563 1750.0n 0.2339 1999.9n 0.2339 2000.0n 0.6251 2249.9n 0.6251 2250.0n 0.6251 2499.9n 0.6251 2500.0n 0.5791 2749.9n 0.5791 2750.0n 0.5714 2999.9n 0.5714 3000.0n 0.2416 3249.9n 0.2416 3250.0n 0.5330 3499.9n 0.5330 3500.0n 0.4563 3749.9n 0.4563 3750.0n 0.6097 3999.9n 0.6097 4000.0n 0.2416 4249.9n 0.2416 4250.0n 0.5637 4499.9n 0.5637 4500.0n 0.4793 4749.9n 0.4793 4750.0n 0.5024 4999.9n 0.5024 5000.0n 0.5560 5249.9n 0.5560 5250.0n 0.3106 5499.9n 0.3106 5500.0n 0.5637 5749.9n 0.5637 5750.0n 0.4180 5999.9n 0.4180 6000.0n 0.2569 6249.9n 0.2569 6250.0n 0.6021 6499.9n 0.6021 6500.0n 0.3413 6749.9n 0.3413 6750.0n 0.5484 6999.9n 0.5484 7000.0n 0.6251 7249.9n 0.6251 7250.0n 0.5867 7499.9n 0.5867 7500.0n 0.2339 7749.9n 0.2339 7750.0n 0.5330 7999.9n 0.5330 8000.0n 0.5330 8249.9n 0.5330 8250.0n 0.5484 8499.9n 0.5484 8500.0n 0.5484 8749.9n 0.5484 8750.0n 0.2339 8999.9n 0.2339 9000.0n 0.4563 9249.9n 0.4563 9250.0n 0.2339 9499.9n 0.2339 9500.0n 0.6251 9749.9n 0.6251 9750.0n 0.6251 9999.9n 0.6251 10000.0n 0.5791 10249.9n 0.5791 10250.0n 0.5714 10499.9n 0.5714 10500.0n 0.2416 10749.9n 0.2416 10750.0n 0.5330 10999.9n 0.5330 11000.0n 0.4563 11249.9n 0.4563 11250.0n 0.6097 11499.9n 0.6097 11500.0n 0.2416 11749.9n 0.2416 11750.0n 0.5637 11999.9n 0.5637 12000.0n 0.4793 12249.9n 0.4793 12250.0n 0.5024 12499.9n 0.5024 12500.0n 0.5560 12749.9n 0.5560 12750.0n 0.3106 12999.9n 0.3106 13000.0n 0.5637 13249.9n 0.5637 13250.0n 0.4180 13499.9n 0.4180 13500.0n 0.2569 13749.9n 0.2569 13750.0n 0.6021 13999.9n 0.6021 14000.0n 0.3413 14249.9n 0.3413 14250.0n 0.5484 14499.9n 0.5484 14500.0n 0.6251 14749.9n 0.6251 14750.0n 0.5867 14999.9n 0.5867 15000.0n 0.2339 15249.9n 0.2339 15250.0n 0.5330 15499.9n 0.5330 15500.0n 0.5330 15749.9n 0.5330 15750.0n 0.5484 15999.9n 0.5484 16000.0n 0.5484 16249.9n 0.5484 16250.0n 0.2339 16499.9n 0.2339 16500.0n 0.4563 16749.9n 0.4563 16750.0n 0.2339 16999.9n 0.2339 17000.0n 0.6251 17249.9n 0.6251 17250.0n 0.6251 17499.9n 0.6251 17500.0n 0.5791 17749.9n 0.5791 17750.0n 0.5714 17999.9n 0.5714 18000.0n 0.2416 18249.9n 0.2416 18250.0n 0.5330 18499.9n 0.5330 18500.0n 0.4563 18749.9n 0.4563 18750.0n 0.6097 18999.9n 0.6097 19000.0n 0.2416 19249.9n 0.2416 19250.0n 0.5637 19499.9n 0.5637 19500.0n 0.4793 19749.9n 0.4793 19750.0n 0.5024 19999.9n 0.5024 20000.0n 0.5560 20249.9n 0.5560 20250.0n 0.3106 20499.9n 0.3106 20500.0n 0.5637 20749.9n 0.5637 20750.0n 0.4180 20999.9n 0.4180 21000.0n 0.2569 21249.9n 0.2569 21250.0n 0.6021 21499.9n 0.6021 21500.0n 0.3413 21749.9n 0.3413 21750.0n 0.5484 21999.9n 0.5484 22000.0n 0.6251 22249.9n 0.6251 22250.0n 0.5867 22499.9n 0.5867 22500.0n 0.2339 22749.9n 0.2339 22750.0n 0.5330 22999.9n 0.5330 23000.0n 0.5330 23249.9n 0.5330 23250.0n 0.5484 23499.9n 0.5484 23500.0n 0.5484 23749.9n 0.5484 23750.0n 0.2339 23999.9n 0.2339 24000.0n 0.4563 24249.9n 0.4563 24250.0n 0.2339 24499.9n 0.2339 24500.0n 0.6251 24749.9n 0.6251 24750.0n 0.6251 24999.9n 0.6251 25000.0n 0.5791 25249.9n 0.5791 25250.0n 0.5714 25499.9n 0.5714 25500.0n 0.2416 25749.9n 0.2416 25750.0n 0.5330 25999.9n 0.5330 26000.0n 0.4563 26249.9n 0.4563 26250.0n 0.6097 26499.9n 0.6097 26500.0n 0.2416 26749.9n 0.2416 26750.0n 0.5637 26999.9n 0.5637 27000.0n 0.4793 27249.9n 0.4793 27250.0n 0.5024 27499.9n 0.5024 27500.0n 0.5560 27749.9n 0.5560 27750.0n 0.3106 27999.9n 0.3106 28000.0n 0.5637 28249.9n 0.5637 28250.0n 0.4180 28499.9n 0.4180 28500.0n 0.2569 28749.9n 0.2569 28750.0n 0.6021 28999.9n 0.6021 29000.0n 0.3413 29249.9n 0.3413 29250.0n 0.5484 29499.9n 0.5484 29500.0n 0.6251 29749.9n 0.6251 29750.0n 0.5867 29999.9n 0.5867 30000.0n 0.2339 30249.9n 0.2339 30250.0n 0.5330 30499.9n 0.5330 30500.0n 0.5330 30749.9n 0.5330 30750.0n 0.5484 30999.9n 0.5484 31000.0n 0.5484 31249.9n 0.5484 31250.0n 0.2339 31499.9n 0.2339 31500.0n 0.4563 31749.9n 0.4563 31750.0n 0.2339 31999.9n 0.2339 32000.0n 0.6251 32249.9n 0.6251 32250.0n 0.6251 32499.9n 0.6251 32500.0n 0.5791 32749.9n 0.5791 32750.0n 0.5714 32999.9n 0.5714 33000.0n 0.2416 33249.9n 0.2416 33250.0n 0.5330 33499.9n 0.5330 33500.0n 0.4563 33749.9n 0.4563 33750.0n 0.6097 33999.9n 0.6097 34000.0n 0.2416 34249.9n 0.2416 34250.0n 0.5637 34499.9n 0.5637 34500.0n 0.4793 34749.9n 0.4793 34750.0n 0.5024 34999.9n 0.5024 35000.0n 0.5560 35249.9n 0.5560 35250.0n 0.3106 35499.9n 0.3106 35500.0n 0.5637 35749.9n 0.5637 35750.0n 0.4180 35999.9n 0.4180 36000.0n 0.2569 36249.9n 0.2569 36250.0n 0.6021 36499.9n 0.6021 36500.0n 0.3413 36749.9n 0.3413 36750.0n 0.5484 36999.9n 0.5484 37000.0n 0.6251 37249.9n 0.6251 37250.0n 0.5867 37499.9n 0.5867 37500.0n 0.2339 37749.9n 0.2339 37750.0n 0.5330 37999.9n 0.5330 38000.0n 0.5330 38249.9n 0.5330 38250.0n 0.5484 38499.9n 0.5484 38500.0n 0.5484 38749.9n 0.5484 38750.0n 0.2339 38999.9n 0.2339 39000.0n 0.4563 39249.9n 0.4563 39250.0n 0.2339 39499.9n 0.2339 39500.0n 0.6251 39749.9n 0.6251 39750.0n 0.6251 39999.9n 0.6251 40000.0n 0.5791 40249.9n 0.5791 40250.0n 0.5714 40499.9n 0.5714 40500.0n 0.2416 40749.9n 0.2416 40750.0n 0.5330 40999.9n 0.5330 41000.0n 0.4563 41249.9n 0.4563 41250.0n 0.6097 41499.9n 0.6097 41500.0n 0.2416 41749.9n 0.2416 41750.0n 0.5637 41999.9n 0.5637 42000.0n 0.4793 42249.9n 0.4793 42250.0n 0.5024 42499.9n 0.5024 42500.0n 0.5560 42749.9n 0.5560 42750.0n 0.3106 42999.9n 0.3106 43000.0n 0.5637 43249.9n 0.5637 43250.0n 0.4180 43499.9n 0.4180 43500.0n 0.2569 43749.9n 0.2569 43750.0n 0.6021 43999.9n 0.6021 44000.0n 0.3413 44249.9n 0.3413 44250.0n 0.5484 44499.9n 0.5484 44500.0n 0.6251 44749.9n 0.6251 44750.0n 0.5867 44999.9n 0.5867 45000.0n 0.2339 45249.9n 0.2339 45250.0n 0.5330 45499.9n 0.5330 45500.0n 0.5330 45749.9n 0.5330 45750.0n 0.5484 45999.9n 0.5484 46000.0n 0.5484 46249.9n 0.5484 46250.0n 0.2339 46499.9n 0.2339 46500.0n 0.4563 46749.9n 0.4563 46750.0n 0.2339 46999.9n 0.2339 47000.0n 0.6251 47249.9n 0.6251 47250.0n 0.6251 47499.9n 0.6251 47500.0n 0.5791 47749.9n 0.5791 47750.0n 0.5714 47999.9n 0.5714 48000.0n 0.2416 48249.9n 0.2416 48250.0n 0.5330 48499.9n 0.5330 48500.0n 0.4563 48749.9n 0.4563 48750.0n 0.6097 48999.9n 0.6097 49000.0n 0.2416 49249.9n 0.2416 49250.0n 0.5637 49499.9n 0.5637 49500.0n 0.4793 49749.9n 0.4793 49750.0n 0.5024 49999.9n 0.5024 50000.0n 0.5560 50249.9n 0.5560 50250.0n 0.3106 50499.9n 0.3106 50500.0n 0.5637 50749.9n 0.5637 50750.0n 0.4180 50999.9n 0.4180 51000.0n 0.2569 51249.9n 0.2569 51250.0n 0.6021 51499.9n 0.6021 51500.0n 0.3413 51749.9n 0.3413 51750.0n 0.5484 51999.9n 0.5484 52000.0n 0.6251 52249.9n 0.6251 52250.0n 0.5867 52499.9n 0.5867 52500.0n 0.2339 52749.9n 0.2339 52750.0n 0.5330 52999.9n 0.5330 53000.0n 0.5330 53249.9n 0.5330 53250.0n 0.5484 53499.9n 0.5484 53500.0n 0.5484 53749.9n 0.5484 53750.0n 0.2339 53999.9n 0.2339 54000.0n 0.4563 54249.9n 0.4563 54250.0n 0.2339 54499.9n 0.2339 54500.0n 0.6251 54749.9n 0.6251 54750.0n 0.6251 54999.9n 0.6251 55000.0n 0.5791 55249.9n 0.5791 55250.0n 0.5714 55499.9n 0.5714 55500.0n 0.2416 55749.9n 0.2416 55750.0n 0.5330 55999.9n 0.5330 56000.0n 0.4563 56249.9n 0.4563 56250.0n 0.6097 56499.9n 0.6097 56500.0n 0.2416 56749.9n 0.2416 56750.0n 0.5637 56999.9n 0.5637 57000.0n 0.4793 57249.9n 0.4793 57250.0n 0.5024 57499.9n 0.5024 57500.0n 0.5560 57749.9n 0.5560 57750.0n 0.3106 57999.9n 0.3106 58000.0n 0.5637 58249.9n 0.5637 58250.0n 0.4180 58499.9n 0.4180 58500.0n 0.2569 58749.9n 0.2569 58750.0n 0.6021 58999.9n 0.6021 59000.0n 0.3413 59249.9n 0.3413 59250.0n 0.5484 59499.9n 0.5484 59500.0n 0.6251 59749.9n 0.6251 59750.0n 0.5867 59999.9n 0.5867 60000.0n 0.2339 60249.9n 0.2339 60250.0n 0.5330 60499.9n 0.5330 60500.0n 0.5330 60749.9n 0.5330 60750.0n 0.5484 60999.9n 0.5484 61000.0n 0.5484 61249.9n 0.5484 61250.0n 0.2339 61499.9n 0.2339 61500.0n 0.4563 61749.9n 0.4563 61750.0n 0.2339 61999.9n 0.2339 62000.0n 0.6251 62249.9n 0.6251 62250.0n 0.6251 62499.9n 0.6251 62500.0n 0.5791 62749.9n 0.5791 62750.0n 0.5714 62999.9n 0.5714 63000.0n 0.2416 63249.9n 0.2416 63250.0n 0.5330 63499.9n 0.5330 63500.0n 0.4563 63749.9n 0.4563 63750.0n 0.6097 63999.9n 0.6097 64000.0n 0.2416 64249.9n 0.2416 64250.0n 0.5637 64499.9n 0.5637 64500.0n 0.4793 64749.9n 0.4793 64750.0n 0.5024 64999.9n 0.5024 65000.0n 0.5560 65249.9n 0.5560 65250.0n 0.3106 65499.9n 0.3106 65500.0n 0.5637 65749.9n 0.5637 65750.0n 0.4180 65999.9n 0.4180 66000.0n 0.2569 66249.9n 0.2569 66250.0n 0.6021 66499.9n 0.6021 66500.0n 0.3413 66749.9n 0.3413 66750.0n 0.5484 66999.9n 0.5484 67000.0n 0.6251 67249.9n 0.6251 67250.0n 0.5867 67499.9n 0.5867 67500.0n 0.2339 67749.9n 0.2339 67750.0n 0.5330 67999.9n 0.5330 68000.0n 0.5330 68249.9n 0.5330 68250.0n 0.5484 68499.9n 0.5484 68500.0n 0.5484 68749.9n 0.5484 68750.0n 0.2339 68999.9n 0.2339 69000.0n 0.4563 69249.9n 0.4563 69250.0n 0.2339 69499.9n 0.2339 69500.0n 0.6251 69749.9n 0.6251 69750.0n 0.6251 69999.9n 0.6251 70000.0n 0.5791 70249.9n 0.5791 70250.0n 0.5714 70499.9n 0.5714 70500.0n 0.2416 70749.9n 0.2416 70750.0n 0.5330 70999.9n 0.5330 71000.0n 0.4563 71249.9n 0.4563 71250.0n 0.6097 71499.9n 0.6097 71500.0n 0.2416 71749.9n 0.2416 71750.0n 0.5637 71999.9n 0.5637 72000.0n 0.4793 72249.9n 0.4793 72250.0n 0.5024 72499.9n 0.5024 72500.0n 0.5560 72749.9n 0.5560 72750.0n 0.3106 72999.9n 0.3106 73000.0n 0.5637 73249.9n 0.5637 73250.0n 0.4180 73499.9n 0.4180 73500.0n 0.2569 73749.9n 0.2569 73750.0n 0.6021 73999.9n 0.6021 74000.0n 0.3413 74249.9n 0.3413 74250.0n 0.5484 74499.9n 0.5484 74500.0n 0.6251 74749.9n 0.6251 74750.0n 0.5867 74999.9n 0.5867 75000.0n 0.2339 75249.9n 0.2339 75250.0n 0.5330 75499.9n 0.5330 75500.0n 0.5330 75749.9n 0.5330 75750.0n 0.5484 75999.9n 0.5484 76000.0n 0.5484 76249.9n 0.5484 76250.0n 0.2339 76499.9n 0.2339 76500.0n 0.4563 76749.9n 0.4563 76750.0n 0.2339 76999.9n 0.2339 77000.0n 0.6251 77249.9n 0.6251 77250.0n 0.6251 77499.9n 0.6251 77500.0n 0.5791 77749.9n 0.5791 77750.0n 0.5714 77999.9n 0.5714 78000.0n 0.2416 78249.9n 0.2416 78250.0n 0.5330 78499.9n 0.5330 78500.0n 0.4563 78749.9n 0.4563 78750.0n 0.6097 78999.9n 0.6097 79000.0n 0.2416 79249.9n 0.2416 79250.0n 0.5637 79499.9n 0.5637 79500.0n 0.4793 79749.9n 0.4793 79750.0n 0.5024 79999.9n 0.5024 80000.0n 0.5560 80249.9n 0.5560 80250.0n 0.3106 80499.9n 0.3106 80500.0n 0.5637 80749.9n 0.5637 80750.0n 0.4180 80999.9n 0.4180 81000.0n 0.2569 81249.9n 0.2569 81250.0n 0.6021 81499.9n 0.6021 81500.0n 0.3413 81749.9n 0.3413 81750.0n 0.5484 81999.9n 0.5484 82000.0n 0.6251 82249.9n 0.6251 82250.0n 0.5867 82499.9n 0.5867 82500.0n 0.2339 82749.9n 0.2339 82750.0n 0.5330 82999.9n 0.5330 83000.0n 0.5330 83249.9n 0.5330 83250.0n 0.5484 83499.9n 0.5484 83500.0n 0.5484 83749.9n 0.5484 83750.0n 0.2339 83999.9n 0.2339 84000.0n 0.4563 84249.9n 0.4563 84250.0n 0.2339 84499.9n 0.2339 84500.0n 0.6251 84749.9n 0.6251 84750.0n 0.6251 84999.9n 0.6251 85000.0n 0.5791 85249.9n 0.5791 85250.0n 0.5714 85499.9n 0.5714 85500.0n 0.2416 85749.9n 0.2416 85750.0n 0.5330 85999.9n 0.5330 86000.0n 0.4563 86249.9n 0.4563 86250.0n 0.6097 86499.9n 0.6097 86500.0n 0.2416 86749.9n 0.2416 86750.0n 0.5637 86999.9n 0.5637 87000.0n 0.4793 87249.9n 0.4793 87250.0n 0.5024 87499.9n 0.5024 87500.0n 0.5560 87749.9n 0.5560 87750.0n 0.3106 87999.9n 0.3106 88000.0n 0.5637 88249.9n 0.5637 88250.0n 0.4180 88499.9n 0.4180 88500.0n 0.2569 88749.9n 0.2569 88750.0n 0.6021 88999.9n 0.6021 89000.0n 0.3413 89249.9n 0.3413 89250.0n 0.5484 89499.9n 0.5484 89500.0n 0.6251 89749.9n 0.6251 89750.0n 0.5867 89999.9n 0.5867 90000.0n 0.2339 90249.9n 0.2339 90250.0n 0.5330 90499.9n 0.5330 90500.0n 0.5330 90749.9n 0.5330 90750.0n 0.5484 90999.9n 0.5484 91000.0n 0.5484 91249.9n 0.5484 91250.0n 0.2339 91499.9n 0.2339 91500.0n 0.4563 91749.9n 0.4563 91750.0n 0.2339 91999.9n 0.2339 92000.0n 0.6251 92249.9n 0.6251 92250.0n 0.6251 92499.9n 0.6251 92500.0n 0.5791 92749.9n 0.5791 92750.0n 0.5714 92999.9n 0.5714 93000.0n 0.2416 93249.9n 0.2416 93250.0n 0.5330 93499.9n 0.5330 93500.0n 0.4563 93749.9n 0.4563 93750.0n 0.6097 93999.9n 0.6097 94000.0n 0.2416 94249.9n 0.2416 94250.0n 0.5637 94499.9n 0.5637 94500.0n 0.4793 94749.9n 0.4793 94750.0n 0.5024 94999.9n 0.5024 95000.0n 0.5560 95249.9n 0.5560 95250.0n 0.3106 95499.9n 0.3106 95500.0n 0.5637 95749.9n 0.5637 95750.0n 0.4180 95999.9n 0.4180 96000.0n 0.2569 96249.9n 0.2569 96250.0n 0.6021 96499.9n 0.6021 96500.0n 0.3413 96749.9n 0.3413 96750.0n 0.5484 96999.9n 0.5484 97000.0n 0.6251 97249.9n 0.6251 97250.0n 0.5867 97499.9n 0.5867 97500.0n 0.2339 97749.9n 0.2339 97750.0n 0.5330 97999.9n 0.5330 98000.0n 0.5330 98249.9n 0.5330 98250.0n 0.5484 98499.9n 0.5484 98500.0n 0.5484 98749.9n 0.5484 98750.0n 0.2339 98999.9n 0.2339 99000.0n 0.4563 99249.9n 0.4563 99250.0n 0.2339 99499.9n 0.2339 99500.0n 0.6251 99749.9n 0.6251 99750.0n 0.6251 99999.9n 0.6251 100000.0n 0.5791 100249.9n 0.5791 100250.0n 0.5714 100499.9n 0.5714 100500.0n 0.2416 100749.9n 0.2416 100750.0n 0.5330 100999.9n 0.5330 101000.0n 0.4563 101249.9n 0.4563 101250.0n 0.6097 101499.9n 0.6097 101500.0n 0.2416 101749.9n 0.2416 101750.0n 0.5637 101999.9n 0.5637 102000.0n 0.4793 102249.9n 0.4793 102250.0n 0.5024 102499.9n 0.5024 102500.0n 0.5560 102749.9n 0.5560 102750.0n 0.3106 102999.9n 0.3106 103000.0n 0.5637 103249.9n 0.5637 103250.0n 0.4180 103499.9n 0.4180 103500.0n 0.2569 103749.9n 0.2569 103750.0n 0.6021 103999.9n 0.6021 104000.0n 0.3413 104249.9n 0.3413 104250.0n 0.5484 104499.9n 0.5484 104500.0n 0.6251 104749.9n 0.6251 104750.0n 0.5867 104999.9n 0.5867 105000.0n 0.2339 105249.9n 0.2339 105250.0n 0.5330 105499.9n 0.5330 105500.0n 0.5330 105749.9n 0.5330 105750.0n 0.5484 105999.9n 0.5484 106000.0n 0.5484 106249.9n 0.5484 106250.0n 0.2339 106499.9n 0.2339 106500.0n 0.4563 106749.9n 0.4563 106750.0n 0.2339 106999.9n 0.2339 107000.0n 0.6251 107249.9n 0.6251 107250.0n 0.6251 107499.9n 0.6251 107500.0n 0.5791 107749.9n 0.5791 107750.0n 0.5714 107999.9n 0.5714 108000.0n 0.2416 108249.9n 0.2416 108250.0n 0.5330 108499.9n 0.5330 108500.0n 0.4563 108749.9n 0.4563 108750.0n 0.6097 108999.9n 0.6097 109000.0n 0.2416 109249.9n 0.2416 109250.0n 0.5637 109499.9n 0.5637 109500.0n 0.4793 109749.9n 0.4793 109750.0n 0.5024 109999.9n 0.5024 110000.0n 0.5560 110249.9n 0.5560 110250.0n 0.3106 110499.9n 0.3106 110500.0n 0.5637 110749.9n 0.5637 110750.0n 0.4180 110999.9n 0.4180 111000.0n 0.2569 111249.9n 0.2569 111250.0n 0.6021 111499.9n 0.6021 111500.0n 0.3413 111749.9n 0.3413 111750.0n 0.5484 111999.9n 0.5484 112000.0n 0.6251 112249.9n 0.6251 112250.0n 0.5867 112499.9n 0.5867 112500.0n 0.2339 112749.9n 0.2339 112750.0n 0.5330 112999.9n 0.5330 113000.0n 0.5330 113249.9n 0.5330 113250.0n 0.5484 113499.9n 0.5484 113500.0n 0.5484 113749.9n 0.5484 113750.0n 0.2339 113999.9n 0.2339 114000.0n 0.4563 114249.9n 0.4563 114250.0n 0.2339 114499.9n 0.2339 114500.0n 0.6251 114749.9n 0.6251 114750.0n 0.6251 114999.9n 0.6251 115000.0n 0.5791 115249.9n 0.5791 115250.0n 0.5714 115499.9n 0.5714 115500.0n 0.2416 115749.9n 0.2416 115750.0n 0.5330 115999.9n 0.5330 116000.0n 0.4563 116249.9n 0.4563 116250.0n 0.6097 116499.9n 0.6097 116500.0n 0.2416 116749.9n 0.2416 116750.0n 0.5637 116999.9n 0.5637 117000.0n 0.4793 117249.9n 0.4793 117250.0n 0.5024 117499.9n 0.5024 117500.0n 0.5560 117749.9n 0.5560 117750.0n 0.3106 117999.9n 0.3106 118000.0n 0.5637 118249.9n 0.5637 118250.0n 0.4180 118499.9n 0.4180 118500.0n 0.2569 118749.9n 0.2569 118750.0n 0.6021 118999.9n 0.6021 119000.0n 0.3413 119249.9n 0.3413 119250.0n 0.5484 119499.9n 0.5484 119500.0n 0.6251 119749.9n 0.6251 119750.0n 0.5867 119999.9n 0.5867 120000.0n 0.2339 120249.9n 0.2339 120250.0n 0.5330 120499.9n 0.5330 120500.0n 0.5330 120749.9n 0.5330 120750.0n 0.5484 120999.9n 0.5484 121000.0n 0.5484 121249.9n 0.5484 121250.0n 0.2339 121499.9n 0.2339 121500.0n 0.4563 121749.9n 0.4563 121750.0n 0.2339 121999.9n 0.2339 122000.0n 0.6251 122249.9n 0.6251 122250.0n 0.6251 122499.9n 0.6251 122500.0n 0.5791 122749.9n 0.5791 122750.0n 0.5714 122999.9n 0.5714 123000.0n 0.2416 123249.9n 0.2416 123250.0n 0.5330 123499.9n 0.5330 123500.0n 0.4563 123749.9n 0.4563 123750.0n 0.6097 123999.9n 0.6097 124000.0n 0.2416 124249.9n 0.2416 124250.0n 0.5637 124499.9n 0.5637 124500.0n 0.4793 124749.9n 0.4793 124750.0n 0.5024 124999.9n 0.5024 125000.0n 0.5560 125249.9n 0.5560 125250.0n 0.3106 125499.9n 0.3106 125500.0n 0.5637 125749.9n 0.5637 125750.0n 0.4180 125999.9n 0.4180 126000.0n 0.2569 126249.9n 0.2569 126250.0n 0.6021 126499.9n 0.6021 126500.0n 0.3413 126749.9n 0.3413 126750.0n 0.5484 126999.9n 0.5484 127000.0n 0.6251 127249.9n 0.6251 127250.0n 0.5867 127499.9n 0.5867 127500.0n 0.2339 127749.9n 0.2339 127750.0n 0.5330 127999.9n 0.5330 128000.0n 0.5330 128249.9n 0.5330 128250.0n 0.5484 128499.9n 0.5484 128500.0n 0.5484 128749.9n 0.5484 128750.0n 0.2339 128999.9n 0.2339 129000.0n 0.4563 129249.9n 0.4563 129250.0n 0.2339 129499.9n 0.2339 129500.0n 0.6251 129749.9n 0.6251 129750.0n 0.6251 129999.9n 0.6251 130000.0n 0.5791 130249.9n 0.5791 130250.0n 0.5714 130499.9n 0.5714 130500.0n 0.2416 130749.9n 0.2416 130750.0n 0.5330 130999.9n 0.5330 131000.0n 0.4563 131249.9n 0.4563 131250.0n 0.6097 131499.9n 0.6097 131500.0n 0.2416 131749.9n 0.2416 131750.0n 0.5637 131999.9n 0.5637 132000.0n 0.4793 132249.9n 0.4793 132250.0n 0.5024 132499.9n 0.5024 132500.0n 0.5560 132749.9n 0.5560 132750.0n 0.3106 132999.9n 0.3106 133000.0n 0.5637 133249.9n 0.5637 133250.0n 0.4180 133499.9n 0.4180 133500.0n 0.2569 133749.9n 0.2569 133750.0n 0.6021 133999.9n 0.6021 134000.0n 0.3413 134249.9n 0.3413 134250.0n 0.5484 134499.9n 0.5484 134500.0n 0.6251 134749.9n 0.6251 134750.0n 0.5867 134999.9n 0.5867 135000.0n 0.2339 135249.9n 0.2339 135250.0n 0.5330 135499.9n 0.5330 135500.0n 0.5330 135749.9n 0.5330 135750.0n 0.5484 135999.9n 0.5484 136000.0n 0.5484 136249.9n 0.5484 136250.0n 0.2339 136499.9n 0.2339 136500.0n 0.4563 136749.9n 0.4563 136750.0n 0.2339 136999.9n 0.2339 137000.0n 0.6251 137249.9n 0.6251 137250.0n 0.6251 137499.9n 0.6251 137500.0n 0.5791 137749.9n 0.5791 137750.0n 0.5714 137999.9n 0.5714 138000.0n 0.2416 138249.9n 0.2416 138250.0n 0.5330 138499.9n 0.5330 138500.0n 0.4563 138749.9n 0.4563 138750.0n 0.6097 138999.9n 0.6097 139000.0n 0.2416 139249.9n 0.2416 139250.0n 0.5637 139499.9n 0.5637 139500.0n 0.4793 139749.9n 0.4793 139750.0n 0.5024 139999.9n 0.5024 140000.0n 0.5560 140249.9n 0.5560 140250.0n 0.3106 140499.9n 0.3106 140500.0n 0.5637 140749.9n 0.5637 140750.0n 0.4180 140999.9n 0.4180 141000.0n 0.2569 141249.9n 0.2569 141250.0n 0.6021 141499.9n 0.6021 141500.0n 0.3413 141749.9n 0.3413 141750.0n 0.5484 141999.9n 0.5484 142000.0n 0.6251 142249.9n 0.6251 142250.0n 0.5867 142499.9n 0.5867 142500.0n 0.2339 142749.9n 0.2339 142750.0n 0.5330 142999.9n 0.5330 143000.0n 0.5330 143249.9n 0.5330 143250.0n 0.5484 143499.9n 0.5484 143500.0n 0.5484 143749.9n 0.5484 143750.0n 0.2339 143999.9n 0.2339 144000.0n 0.4563 144249.9n 0.4563 144250.0n 0.2339 144499.9n 0.2339 144500.0n 0.6251 144749.9n 0.6251 144750.0n 0.6251 144999.9n 0.6251 145000.0n 0.5791 145249.9n 0.5791 145250.0n 0.5714 145499.9n 0.5714 145500.0n 0.2416 145749.9n 0.2416 145750.0n 0.5330 145999.9n 0.5330 146000.0n 0.4563 146249.9n 0.4563 146250.0n 0.6097 146499.9n 0.6097 146500.0n 0.2416 146749.9n 0.2416 146750.0n 0.5637 146999.9n 0.5637 147000.0n 0.4793 147249.9n 0.4793 147250.0n 0.5024 147499.9n 0.5024 147500.0n 0.5560 147749.9n 0.5560 147750.0n 0.3106 147999.9n 0.3106 148000.0n 0.5637 148249.9n 0.5637 148250.0n 0.4180 148499.9n 0.4180 148500.0n 0.2569 148749.9n 0.2569 148750.0n 0.6021 148999.9n 0.6021 149000.0n 0.3413 149249.9n 0.3413 149250.0n 0.5484 149499.9n 0.5484 149500.0n 0.6251 149749.9n 0.6251 149750.0n 0.5867 149999.9n 0.5867 150000.0n 0.2339 150249.9n 0.2339 150250.0n 0.5330 150499.9n 0.5330 150500.0n 0.5330 150749.9n 0.5330 150750.0n 0.5484 150999.9n 0.5484 151000.0n 0.5484 151249.9n 0.5484 151250.0n 0.2339 151499.9n 0.2339 151500.0n 0.4563 151749.9n 0.4563 151750.0n 0.2339 151999.9n 0.2339 152000.0n 0.6251 152249.9n 0.6251 152250.0n 0.6251 152499.9n 0.6251 152500.0n 0.5791 152749.9n 0.5791 152750.0n 0.5714 152999.9n 0.5714 153000.0n 0.2416 153249.9n 0.2416 153250.0n 0.5330 153499.9n 0.5330 153500.0n 0.4563 153749.9n 0.4563 153750.0n 0.6097 153999.9n 0.6097 154000.0n 0.2416 154249.9n 0.2416 154250.0n 0.5637 154499.9n 0.5637 154500.0n 0.4793 154749.9n 0.4793 154750.0n 0.5024 154999.9n 0.5024 155000.0n 0.5560 155249.9n 0.5560 155250.0n 0.3106 155499.9n 0.3106 155500.0n 0.5637 155749.9n 0.5637 155750.0n 0.4180 155999.9n 0.4180 156000.0n 0.2569 156249.9n 0.2569 156250.0n 0.6021 156499.9n 0.6021 156500.0n 0.3413 156749.9n 0.3413 156750.0n 0.5484 156999.9n 0.5484 157000.0n 0.6251 157249.9n 0.6251 157250.0n 0.5867 157499.9n 0.5867 157500.0n 0.2339 157749.9n 0.2339 157750.0n 0.5330 157999.9n 0.5330 158000.0n 0.5330 158249.9n 0.5330 158250.0n 0.5484 158499.9n 0.5484 158500.0n 0.5484 158749.9n 0.5484 158750.0n 0.2339 158999.9n 0.2339 159000.0n 0.4563 159249.9n 0.4563 159250.0n 0.2339 159499.9n 0.2339 159500.0n 0.6251 159749.9n 0.6251 159750.0n 0.6251 159999.9n 0.6251 160000.0n 0.5791 160249.9n 0.5791 160250.0n 0.5714 160499.9n 0.5714 160500.0n 0.2416 160749.9n 0.2416 160750.0n 0.5330 160999.9n 0.5330 161000.0n 0.4563 161249.9n 0.4563 161250.0n 0.6097 161499.9n 0.6097 161500.0n 0.2416 161749.9n 0.2416 161750.0n 0.5637 161999.9n 0.5637 162000.0n 0.4793 162249.9n 0.4793 162250.0n 0.5024 162499.9n 0.5024 162500.0n 0.5560 162749.9n 0.5560 162750.0n 0.3106 162999.9n 0.3106 163000.0n 0.5637 163249.9n 0.5637 163250.0n 0.4180 163499.9n 0.4180 163500.0n 0.2569 163749.9n 0.2569 163750.0n 0.6021 163999.9n 0.6021 164000.0n 0.3413 164249.9n 0.3413 164250.0n 0.5484 164499.9n 0.5484 164500.0n 0.6251 164749.9n 0.6251 164750.0n 0.5867 164999.9n 0.5867 165000.0n 0.2339 165249.9n 0.2339 165250.0n 0.5330 165499.9n 0.5330 165500.0n 0.5330 165749.9n 0.5330 165750.0n 0.5484 165999.9n 0.5484 166000.0n 0.5484 166249.9n 0.5484 166250.0n 0.2339 166499.9n 0.2339 166500.0n 0.4563 166749.9n 0.4563 166750.0n 0.2339 166999.9n 0.2339 167000.0n 0.6251 167249.9n 0.6251 167250.0n 0.6251 167499.9n 0.6251 167500.0n 0.5791 167749.9n 0.5791 167750.0n 0.5714 167999.9n 0.5714 168000.0n 0.2416 168249.9n 0.2416 168250.0n 0.5330 168499.9n 0.5330 168500.0n 0.4563 168749.9n 0.4563 168750.0n 0.6097 168999.9n 0.6097 169000.0n 0.2416 169249.9n 0.2416 169250.0n 0.5637 169499.9n 0.5637 169500.0n 0.4793 169749.9n 0.4793 169750.0n 0.5024 169999.9n 0.5024 170000.0n 0.5560 170249.9n 0.5560 170250.0n 0.3106 170499.9n 0.3106 170500.0n 0.5637 170749.9n 0.5637 170750.0n 0.4180 170999.9n 0.4180 171000.0n 0.2569 171249.9n 0.2569 171250.0n 0.6021 171499.9n 0.6021 171500.0n 0.3413 171749.9n 0.3413 171750.0n 0.5484 171999.9n 0.5484 172000.0n 0.6251 172249.9n 0.6251 172250.0n 0.5867 172499.9n 0.5867 172500.0n 0.2339 172749.9n 0.2339 172750.0n 0.5330 172999.9n 0.5330 173000.0n 0.5330 173249.9n 0.5330 173250.0n 0.5484 173499.9n 0.5484 173500.0n 0.5484 173749.9n 0.5484 173750.0n 0.2339 173999.9n 0.2339 174000.0n 0.4563 174249.9n 0.4563 174250.0n 0.2339 174499.9n 0.2339 174500.0n 0.6251 174749.9n 0.6251 174750.0n 0.6251 174999.9n 0.6251 175000.0n 0.5791 175249.9n 0.5791 175250.0n 0.5714 175499.9n 0.5714 175500.0n 0.2416 175749.9n 0.2416 175750.0n 0.5330 175999.9n 0.5330 176000.0n 0.4563 176249.9n 0.4563 176250.0n 0.6097 176499.9n 0.6097 176500.0n 0.2416 176749.9n 0.2416 176750.0n 0.5637 176999.9n 0.5637 177000.0n 0.4793 177249.9n 0.4793 177250.0n 0.5024 177499.9n 0.5024 177500.0n 0.5560 177749.9n 0.5560 177750.0n 0.3106 177999.9n 0.3106 178000.0n 0.5637 178249.9n 0.5637 178250.0n 0.4180 178499.9n 0.4180 178500.0n 0.2569 178749.9n 0.2569 178750.0n 0.6021 178999.9n 0.6021 179000.0n 0.3413 179249.9n 0.3413 179250.0n 0.5484 179499.9n 0.5484 179500.0n 0.6251 179749.9n 0.6251 179750.0n 0.5867 179999.9n 0.5867 180000.0n 0.2339 180249.9n 0.2339 180250.0n 0.5330 180499.9n 0.5330 180500.0n 0.5330 180749.9n 0.5330 180750.0n 0.5484 180999.9n 0.5484 181000.0n 0.5484 181249.9n 0.5484 181250.0n 0.2339 181499.9n 0.2339 181500.0n 0.4563 181749.9n 0.4563 181750.0n 0.2339 181999.9n 0.2339 182000.0n 0.6251 182249.9n 0.6251 182250.0n 0.6251 182499.9n 0.6251 182500.0n 0.5791 182749.9n 0.5791 182750.0n 0.5714 182999.9n 0.5714 183000.0n 0.2416 183249.9n 0.2416 183250.0n 0.5330 183499.9n 0.5330 183500.0n 0.4563 183749.9n 0.4563 183750.0n 0.6097 183999.9n 0.6097 184000.0n 0.2416 184249.9n 0.2416 184250.0n 0.5637 184499.9n 0.5637 184500.0n 0.4793 184749.9n 0.4793 184750.0n 0.5024 184999.9n 0.5024 185000.0n 0.5560 185249.9n 0.5560 185250.0n 0.3106 185499.9n 0.3106 185500.0n 0.5637 185749.9n 0.5637 185750.0n 0.4180 185999.9n 0.4180 186000.0n 0.2569 186249.9n 0.2569 186250.0n 0.6021 186499.9n 0.6021 186500.0n 0.3413 186749.9n 0.3413 186750.0n 0.5484 186999.9n 0.5484 187000.0n 0.6251 187249.9n 0.6251 187250.0n 0.5867 187499.9n 0.5867 187500.0n 0.2339 187749.9n 0.2339 187750.0n 0.5330 187999.9n 0.5330 188000.0n 0.5330 188249.9n 0.5330 188250.0n 0.5484 188499.9n 0.5484 188500.0n 0.5484 188749.9n 0.5484 188750.0n 0.2339 188999.9n 0.2339 189000.0n 0.4563 189249.9n 0.4563 189250.0n 0.2339 189499.9n 0.2339 189500.0n 0.6251 189749.9n 0.6251 189750.0n 0.6251 189999.9n 0.6251 190000.0n 0.5791 190249.9n 0.5791 190250.0n 0.5714 190499.9n 0.5714 190500.0n 0.2416 190749.9n 0.2416 190750.0n 0.5330 190999.9n 0.5330 191000.0n 0.4563 191249.9n 0.4563 191250.0n 0.6097 191499.9n 0.6097 191500.0n 0.2416 191749.9n 0.2416 191750.0n 0.5637 191999.9n 0.5637 192000.0n 0.4793 192249.9n 0.4793 192250.0n 0.5024 192499.9n 0.5024 192500.0n 0.5560 192749.9n 0.5560 192750.0n 0.3106 192999.9n 0.3106 193000.0n 0.5637 193249.9n 0.5637 193250.0n 0.4180 193499.9n 0.4180 193500.0n 0.2569 193749.9n 0.2569 193750.0n 0.6021 193999.9n 0.6021 194000.0n 0.3413 194249.9n 0.3413 194250.0n 0.5484 194499.9n 0.5484 194500.0n 0.6251 194749.9n 0.6251 194750.0n 0.5867 194999.9n 0.5867 195000.0n 0.2339 195249.9n 0.2339 195250.0n 0.5330 195499.9n 0.5330 195500.0n 0.5330 195749.9n 0.5330 195750.0n 0.5484 195999.9n 0.5484 196000.0n 0.5484 196249.9n 0.5484 196250.0n 0.2339 196499.9n 0.2339 196500.0n 0.4563 196749.9n 0.4563 196750.0n 0.2339 196999.9n 0.2339 197000.0n 0.6251 197249.9n 0.6251 197250.0n 0.6251 197499.9n 0.6251 197500.0n 0.5791 197749.9n 0.5791 197750.0n 0.5714 197999.9n 0.5714 198000.0n 0.2416 198249.9n 0.2416 198250.0n 0.5330 198499.9n 0.5330 198500.0n 0.4563 198749.9n 0.4563 198750.0n 0.6097 198999.9n 0.6097 199000.0n 0.2416 199249.9n 0.2416 199250.0n 0.5637 199499.9n 0.5637 199500.0n 0.4793 199749.9n 0.4793 199750.0n 0.5024 199999.9n 0.5024 200000.0n 0.5560 200249.9n 0.5560 200250.0n 0.3106 200499.9n 0.3106 200500.0n 0.5637 200749.9n 0.5637 200750.0n 0.4180 200999.9n 0.4180 201000.0n 0.2569 201249.9n 0.2569 201250.0n 0.6021 201499.9n 0.6021 201500.0n 0.3413 201749.9n 0.3413 201750.0n 0.5484 201999.9n 0.5484 202000.0n 0.6251 202249.9n 0.6251 202250.0n 0.5867 202499.9n 0.5867 202500.0n 0.2339 202749.9n 0.2339 202750.0n 0.5330 202999.9n 0.5330 203000.0n 0.5330 203249.9n 0.5330 203250.0n 0.5484 203499.9n 0.5484 203500.0n 0.5484 203749.9n 0.5484 203750.0n 0.2339 203999.9n 0.2339 204000.0n 0.4563 204249.9n 0.4563 204250.0n 0.2339 204499.9n 0.2339 204500.0n 0.6251 204749.9n 0.6251 204750.0n 0.6251 204999.9n 0.6251 205000.0n 0.5791 205249.9n 0.5791 205250.0n 0.5714 205499.9n 0.5714 205500.0n 0.2416 205749.9n 0.2416 205750.0n 0.5330 205999.9n 0.5330 206000.0n 0.4563 206249.9n 0.4563 206250.0n 0.6097 206499.9n 0.6097 206500.0n 0.2416 206749.9n 0.2416 206750.0n 0.5637 206999.9n 0.5637 207000.0n 0.4793 207249.9n 0.4793 207250.0n 0.5024 207499.9n 0.5024 207500.0n 0.5560 207749.9n 0.5560 207750.0n 0.3106 207999.9n 0.3106 208000.0n 0.5637 208249.9n 0.5637 208250.0n 0.4180 208499.9n 0.4180 208500.0n 0.2569 208749.9n 0.2569 208750.0n 0.6021 208999.9n 0.6021 209000.0n 0.3413 209249.9n 0.3413 209250.0n 0.5484 209499.9n 0.5484 209500.0n 0.6251 209749.9n 0.6251 209750.0n 0.5867 209999.9n 0.5867 210000.0n 0.2339 210249.9n 0.2339 210250.0n 0.5330 210499.9n 0.5330 210500.0n 0.5330 210749.9n 0.5330 210750.0n 0.5484 210999.9n 0.5484 211000.0n 0.5484 211249.9n 0.5484 211250.0n 0.2339 211499.9n 0.2339 211500.0n 0.4563 211749.9n 0.4563 211750.0n 0.2339 211999.9n 0.2339 212000.0n 0.6251 212249.9n 0.6251 212250.0n 0.6251 212499.9n 0.6251 212500.0n 0.5791 212749.9n 0.5791 212750.0n 0.5714 212999.9n 0.5714 213000.0n 0.2416 213249.9n 0.2416 213250.0n 0.5330 213499.9n 0.5330 213500.0n 0.4563 213749.9n 0.4563 213750.0n 0.6097 213999.9n 0.6097 214000.0n 0.2416 214249.9n 0.2416 214250.0n 0.5637 214499.9n 0.5637 214500.0n 0.4793 214749.9n 0.4793 214750.0n 0.5024 214999.9n 0.5024 215000.0n 0.5560 215249.9n 0.5560 215250.0n 0.3106 215499.9n 0.3106 215500.0n 0.5637 215749.9n 0.5637 215750.0n 0.4180 215999.9n 0.4180 216000.0n 0.2569 216249.9n 0.2569 216250.0n 0.6021 216499.9n 0.6021 216500.0n 0.3413 216749.9n 0.3413 216750.0n 0.5484 216999.9n 0.5484 217000.0n 0.6251 217249.9n 0.6251 217250.0n 0.5867 217499.9n 0.5867 217500.0n 0.2339 217749.9n 0.2339 217750.0n 0.5330 217999.9n 0.5330 218000.0n 0.5330 218249.9n 0.5330 218250.0n 0.5484 218499.9n 0.5484 218500.0n 0.5484 218749.9n 0.5484 218750.0n 0.2339 218999.9n 0.2339 219000.0n 0.4563 219249.9n 0.4563 219250.0n 0.2339 219499.9n 0.2339 219500.0n 0.6251 219749.9n 0.6251 219750.0n 0.6251 219999.9n 0.6251 220000.0n 0.5791 220249.9n 0.5791 220250.0n 0.5714 220499.9n 0.5714 220500.0n 0.2416 220749.9n 0.2416 220750.0n 0.5330 220999.9n 0.5330 221000.0n 0.4563 221249.9n 0.4563 221250.0n 0.6097 221499.9n 0.6097 221500.0n 0.2416 221749.9n 0.2416 221750.0n 0.5637 221999.9n 0.5637 222000.0n 0.4793 222249.9n 0.4793 222250.0n 0.5024 222499.9n 0.5024 222500.0n 0.5560 222749.9n 0.5560 222750.0n 0.3106 222999.9n 0.3106 223000.0n 0.5637 223249.9n 0.5637 223250.0n 0.4180 223499.9n 0.4180 223500.0n 0.2569 223749.9n 0.2569 223750.0n 0.6021 223999.9n 0.6021 224000.0n 0.3413 224249.9n 0.3413 224250.0n 0.5484 224499.9n 0.5484 224500.0n 0.6251 224749.9n 0.6251 224750.0n 0.5867 224999.9n 0.5867 225000.0n 0.2339 225249.9n 0.2339 225250.0n 0.5330 225499.9n 0.5330 225500.0n 0.5330 225749.9n 0.5330 225750.0n 0.5484 225999.9n 0.5484 226000.0n 0.5484 226249.9n 0.5484 226250.0n 0.2339 226499.9n 0.2339 226500.0n 0.4563 226749.9n 0.4563 226750.0n 0.2339 226999.9n 0.2339 227000.0n 0.6251 227249.9n 0.6251 227250.0n 0.6251 227499.9n 0.6251 227500.0n 0.5791 227749.9n 0.5791 227750.0n 0.5714 227999.9n 0.5714 228000.0n 0.2416 228249.9n 0.2416 228250.0n 0.5330 228499.9n 0.5330 228500.0n 0.4563 228749.9n 0.4563 228750.0n 0.6097 228999.9n 0.6097 229000.0n 0.2416 229249.9n 0.2416 229250.0n 0.5637 229499.9n 0.5637 229500.0n 0.4793 229749.9n 0.4793 229750.0n 0.5024 229999.9n 0.5024 230000.0n 0.5560 230249.9n 0.5560 230250.0n 0.3106 230499.9n 0.3106 230500.0n 0.5637 230749.9n 0.5637 230750.0n 0.4180 230999.9n 0.4180 231000.0n 0.2569 231249.9n 0.2569 231250.0n 0.6021 231499.9n 0.6021 231500.0n 0.3413 231749.9n 0.3413 231750.0n 0.5484 231999.9n 0.5484 232000.0n 0.6251 232249.9n 0.6251 232250.0n 0.5867 232499.9n 0.5867 232500.0n 0.2339 232749.9n 0.2339 232750.0n 0.5330 232999.9n 0.5330 233000.0n 0.5330 233249.9n 0.5330 233250.0n 0.5484 233499.9n 0.5484 233500.0n 0.5484 233749.9n 0.5484 233750.0n 0.2339 233999.9n 0.2339 234000.0n 0.4563 234249.9n 0.4563 234250.0n 0.2339 234499.9n 0.2339 234500.0n 0.6251 234749.9n 0.6251 234750.0n 0.6251 234999.9n 0.6251 235000.0n 0.5791 235249.9n 0.5791 235250.0n 0.5714 235499.9n 0.5714 235500.0n 0.2416 235749.9n 0.2416 235750.0n 0.5330 235999.9n 0.5330 236000.0n 0.4563 236249.9n 0.4563 236250.0n 0.6097 236499.9n 0.6097 236500.0n 0.2416 236749.9n 0.2416 236750.0n 0.5637 236999.9n 0.5637 237000.0n 0.4793 237249.9n 0.4793 237250.0n 0.5024 237499.9n 0.5024 237500.0n 0.5560 237749.9n 0.5560 237750.0n 0.3106 237999.9n 0.3106 238000.0n 0.5637 238249.9n 0.5637 238250.0n 0.4180 238499.9n 0.4180 238500.0n 0.2569 238749.9n 0.2569 238750.0n 0.6021 238999.9n 0.6021 239000.0n 0.3413 239249.9n 0.3413 239250.0n 0.5484 239499.9n 0.5484 239500.0n 0.6251 239749.9n 0.6251 239750.0n 0.5867 239999.9n 0.5867 240000.0n 0.2339 240249.9n 0.2339 240250.0n 0.5330 240499.9n 0.5330 240500.0n 0.5330 240749.9n 0.5330 240750.0n 0.5484 240999.9n 0.5484 241000.0n 0.5484 241249.9n 0.5484 241250.0n 0.2339 241499.9n 0.2339 241500.0n 0.4563 241749.9n 0.4563 241750.0n 0.2339 241999.9n 0.2339 242000.0n 0.6251 242249.9n 0.6251 242250.0n 0.6251 242499.9n 0.6251 242500.0n 0.5791 242749.9n 0.5791 242750.0n 0.5714 242999.9n 0.5714 243000.0n 0.2416 243249.9n 0.2416 243250.0n 0.5330 243499.9n 0.5330 243500.0n 0.4563 243749.9n 0.4563 243750.0n 0.6097 243999.9n 0.6097 244000.0n 0.2416 244249.9n 0.2416 244250.0n 0.5637 244499.9n 0.5637 244500.0n 0.4793 244749.9n 0.4793 244750.0n 0.5024 244999.9n 0.5024 245000.0n 0.5560 245249.9n 0.5560 245250.0n 0.3106 245499.9n 0.3106 245500.0n 0.5637 245749.9n 0.5637 245750.0n 0.4180 245999.9n 0.4180 246000.0n 0.2569 246249.9n 0.2569 246250.0n 0.6021 246499.9n 0.6021 246500.0n 0.3413 246749.9n 0.3413 246750.0n 0.5484 246999.9n 0.5484 247000.0n 0.6251 247249.9n 0.6251 247250.0n 0.5867 247499.9n 0.5867 247500.0n 0.2339 247749.9n 0.2339 247750.0n 0.5330 247999.9n 0.5330 248000.0n 0.5330 248249.9n 0.5330 248250.0n 0.5484 248499.9n 0.5484 248500.0n 0.5484 248749.9n 0.5484 248750.0n 0.2339 248999.9n 0.2339 249000.0n 0.4563 249249.9n 0.4563 249250.0n 0.2339 249499.9n 0.2339 249500.0n 0.6251 249749.9n 0.6251 249750.0n 0.6251 249999.9n 0.6251 250000.0n 0.5791 250249.9n 0.5791 250250.0n 0.5714 250499.9n 0.5714 250500.0n 0.2416 250749.9n 0.2416 250750.0n 0.5330 250999.9n 0.5330 251000.0n 0.4563 251249.9n 0.4563 251250.0n 0.6097 251499.9n 0.6097 251500.0n 0.2416 251749.9n 0.2416 251750.0n 0.5637 251999.9n 0.5637 252000.0n 0.4793 252249.9n 0.4793 252250.0n 0.5024 252499.9n 0.5024 252500.0n 0.5560 252749.9n 0.5560 252750.0n 0.3106 252999.9n 0.3106 253000.0n 0.5637 253249.9n 0.5637 253250.0n 0.4180 253499.9n 0.4180 253500.0n 0.2569 253749.9n 0.2569 253750.0n 0.6021 253999.9n 0.6021 254000.0n 0.3413 254249.9n 0.3413 254250.0n 0.5484 254499.9n 0.5484 254500.0n 0.6251 254749.9n 0.6251 254750.0n 0.5867 254999.9n 0.5867 255000.0n 0.2339 255249.9n 0.2339 255250.0n 0.5330 255499.9n 0.5330 255500.0n 0.5330 255749.9n 0.5330 255750.0n 0.5484 255999.9n 0.5484 256000.0n 0.5484 256249.9n 0.5484 256250.0n 0.2339 256499.9n 0.2339 256500.0n 0.4563 256749.9n 0.4563 256750.0n 0.2339 256999.9n 0.2339 257000.0n 0.6251 257249.9n 0.6251 257250.0n 0.6251 257499.9n 0.6251 257500.0n 0.5791 257749.9n 0.5791 257750.0n 0.5714 257999.9n 0.5714 258000.0n 0.2416 258249.9n 0.2416 258250.0n 0.5330 258499.9n 0.5330 258500.0n 0.4563 258749.9n 0.4563 258750.0n 0.6097 258999.9n 0.6097 259000.0n 0.2416 259249.9n 0.2416 259250.0n 0.5637 259499.9n 0.5637 259500.0n 0.4793 259749.9n 0.4793 259750.0n 0.5024 259999.9n 0.5024 260000.0n 0.5560 260249.9n 0.5560 260250.0n 0.3106 260499.9n 0.3106 260500.0n 0.5637 260749.9n 0.5637 260750.0n 0.4180 260999.9n 0.4180 261000.0n 0.2569 261249.9n 0.2569 261250.0n 0.6021 261499.9n 0.6021 261500.0n 0.3413 261749.9n 0.3413 261750.0n 0.5484 261999.9n 0.5484 262000.0n 0.6251 262249.9n 0.6251 262250.0n 0.5867 262499.9n 0.5867 262500.0n 0.2339 262749.9n 0.2339 262750.0n 0.5330 262999.9n 0.5330 263000.0n 0.5330 263249.9n 0.5330 263250.0n 0.5484 263499.9n 0.5484 263500.0n 0.5484 263749.9n 0.5484 263750.0n 0.2339 263999.9n 0.2339 264000.0n 0.4563 264249.9n 0.4563 264250.0n 0.2339 264499.9n 0.2339 264500.0n 0.6251 264749.9n 0.6251 264750.0n 0.6251 264999.9n 0.6251 265000.0n 0.5791 265249.9n 0.5791 265250.0n 0.5714 265499.9n 0.5714 265500.0n 0.2416 265749.9n 0.2416 265750.0n 0.5330 265999.9n 0.5330 266000.0n 0.4563 266249.9n 0.4563 266250.0n 0.6097 266499.9n 0.6097 266500.0n 0.2416 266749.9n 0.2416 266750.0n 0.5637 266999.9n 0.5637 267000.0n 0.4793 267249.9n 0.4793 267250.0n 0.5024 267499.9n 0.5024 267500.0n 0.5560 267749.9n 0.5560 267750.0n 0.3106 267999.9n 0.3106 268000.0n 0.5637 268249.9n 0.5637 268250.0n 0.4180 268499.9n 0.4180 268500.0n 0.2569 268749.9n 0.2569 268750.0n 0.6021 268999.9n 0.6021 269000.0n 0.3413 269249.9n 0.3413 269250.0n 0.5484 269499.9n 0.5484 269500.0n 0.6251 269749.9n 0.6251 269750.0n 0.5867 269999.9n 0.5867 270000.0n 0.2339 270249.9n 0.2339 270250.0n 0.5330 270499.9n 0.5330 270500.0n 0.5330 270749.9n 0.5330 270750.0n 0.5484 270999.9n 0.5484 271000.0n 0.5484 271249.9n 0.5484 271250.0n 0.2339 271499.9n 0.2339 271500.0n 0.4563 271749.9n 0.4563 271750.0n 0.2339 271999.9n 0.2339 272000.0n 0.6251 272249.9n 0.6251 272250.0n 0.6251 272499.9n 0.6251 272500.0n 0.5791 272749.9n 0.5791 272750.0n 0.5714 272999.9n 0.5714 273000.0n 0.2416 273249.9n 0.2416 273250.0n 0.5330 273499.9n 0.5330 273500.0n 0.4563 273749.9n 0.4563 273750.0n 0.6097 273999.9n 0.6097 274000.0n 0.2416 274249.9n 0.2416 274250.0n 0.5637 274499.9n 0.5637 274500.0n 0.4793 274749.9n 0.4793 274750.0n 0.5024 274999.9n 0.5024 275000.0n 0.5560 275249.9n 0.5560 275250.0n 0.3106 275499.9n 0.3106 275500.0n 0.5637 275749.9n 0.5637 275750.0n 0.4180 275999.9n 0.4180 276000.0n 0.2569 276249.9n 0.2569 276250.0n 0.6021 276499.9n 0.6021 276500.0n 0.3413 276749.9n 0.3413 276750.0n 0.5484 276999.9n 0.5484 277000.0n 0.6251 277249.9n 0.6251 277250.0n 0.5867 277499.9n 0.5867 277500.0n 0.2339 277749.9n 0.2339 277750.0n 0.5330 277999.9n 0.5330 278000.0n 0.5330 278249.9n 0.5330 278250.0n 0.5484 278499.9n 0.5484 278500.0n 0.5484 278749.9n 0.5484 278750.0n 0.2339 278999.9n 0.2339 279000.0n 0.4563 279249.9n 0.4563 279250.0n 0.2339 279499.9n 0.2339 279500.0n 0.6251 279749.9n 0.6251 279750.0n 0.6251 279999.9n 0.6251 280000.0n 0.5791 280249.9n 0.5791 280250.0n 0.5714 280499.9n 0.5714 280500.0n 0.2416 280749.9n 0.2416 280750.0n 0.5330 280999.9n 0.5330 281000.0n 0.4563 281249.9n 0.4563 281250.0n 0.6097 281499.9n 0.6097 281500.0n 0.2416 281749.9n 0.2416 281750.0n 0.5637 281999.9n 0.5637 282000.0n 0.4793 282249.9n 0.4793 282250.0n 0.5024 282499.9n 0.5024 282500.0n 0.5560 282749.9n 0.5560 282750.0n 0.3106 282999.9n 0.3106 283000.0n 0.5637 283249.9n 0.5637 283250.0n 0.4180 283499.9n 0.4180 283500.0n 0.2569 283749.9n 0.2569 283750.0n 0.6021 283999.9n 0.6021 284000.0n 0.3413 284249.9n 0.3413 284250.0n 0.5484 284499.9n 0.5484 284500.0n 0.6251 284749.9n 0.6251 284750.0n 0.5867 284999.9n 0.5867 285000.0n 0.2339 285249.9n 0.2339 285250.0n 0.5330 285499.9n 0.5330 285500.0n 0.5330 285749.9n 0.5330 285750.0n 0.5484 285999.9n 0.5484 286000.0n 0.5484 286249.9n 0.5484 286250.0n 0.2339 286499.9n 0.2339 286500.0n 0.4563 286749.9n 0.4563 286750.0n 0.2339 286999.9n 0.2339 287000.0n 0.6251 287249.9n 0.6251 287250.0n 0.6251 287499.9n 0.6251 287500.0n 0.5791 287749.9n 0.5791 287750.0n 0.5714 287999.9n 0.5714 288000.0n 0.2416 288249.9n 0.2416 288250.0n 0.5330 288499.9n 0.5330 288500.0n 0.4563 288749.9n 0.4563 288750.0n 0.6097 288999.9n 0.6097 289000.0n 0.2416 289249.9n 0.2416 289250.0n 0.5637 289499.9n 0.5637 289500.0n 0.4793 289749.9n 0.4793 289750.0n 0.5024 289999.9n 0.5024 290000.0n 0.5560 290249.9n 0.5560 290250.0n 0.3106 290499.9n 0.3106 290500.0n 0.5637 290749.9n 0.5637 290750.0n 0.4180 290999.9n 0.4180 291000.0n 0.2569 291249.9n 0.2569 291250.0n 0.6021 291499.9n 0.6021 291500.0n 0.3413 291749.9n 0.3413 291750.0n 0.5484 291999.9n 0.5484 292000.0n 0.6251 292249.9n 0.6251 292250.0n 0.5867 292499.9n 0.5867 292500.0n 0.2339 292749.9n 0.2339 292750.0n 0.5330 292999.9n 0.5330 293000.0n 0.5330 293249.9n 0.5330 293250.0n 0.5484 293499.9n 0.5484 293500.0n 0.5484 293749.9n 0.5484 293750.0n 0.2339 293999.9n 0.2339 294000.0n 0.4563 294249.9n 0.4563 294250.0n 0.2339 294499.9n 0.2339 294500.0n 0.6251 294749.9n 0.6251 294750.0n 0.6251 294999.9n 0.6251 295000.0n 0.5791 295249.9n 0.5791 295250.0n 0.5714 295499.9n 0.5714 295500.0n 0.2416 295749.9n 0.2416 295750.0n 0.5330 295999.9n 0.5330 296000.0n 0.4563 296249.9n 0.4563 296250.0n 0.6097 296499.9n 0.6097 296500.0n 0.2416 296749.9n 0.2416 296750.0n 0.5637 296999.9n 0.5637 297000.0n 0.4793 297249.9n 0.4793 297250.0n 0.5024 297499.9n 0.5024 297500.0n 0.5560 297749.9n 0.5560 297750.0n 0.3106 297999.9n 0.3106 298000.0n 0.5637 298249.9n 0.5637 298250.0n 0.4180 298499.9n 0.4180 298500.0n 0.2569 298749.9n 0.2569 298750.0n 0.6021 298999.9n 0.6021 299000.0n 0.3413 299249.9n 0.3413 299250.0n 0.5484 299499.9n 0.5484 299500.0n 0.6251 299749.9n 0.6251 299750.0n 0.5867)
Vxn13 a_xn13 0 PWL(0.0n 0.7661 249.9n 0.7661 250.0n 0.4670 499.9n 0.4670 500.0n 0.4670 749.9n 0.4670 750.0n 0.4516 999.9n 0.4516 1000.0n 0.4516 1249.9n 0.4516 1250.0n 0.7661 1499.9n 0.7661 1500.0n 0.5437 1749.9n 0.5437 1750.0n 0.7661 1999.9n 0.7661 2000.0n 0.3749 2249.9n 0.3749 2250.0n 0.3749 2499.9n 0.3749 2500.0n 0.4209 2749.9n 0.4209 2750.0n 0.4286 2999.9n 0.4286 3000.0n 0.7584 3249.9n 0.7584 3250.0n 0.4670 3499.9n 0.4670 3500.0n 0.5437 3749.9n 0.5437 3750.0n 0.3903 3999.9n 0.3903 4000.0n 0.7584 4249.9n 0.7584 4250.0n 0.4363 4499.9n 0.4363 4500.0n 0.5207 4749.9n 0.5207 4750.0n 0.4976 4999.9n 0.4976 5000.0n 0.4440 5249.9n 0.4440 5250.0n 0.6894 5499.9n 0.6894 5500.0n 0.4363 5749.9n 0.4363 5750.0n 0.5820 5999.9n 0.5820 6000.0n 0.7431 6249.9n 0.7431 6250.0n 0.3979 6499.9n 0.3979 6500.0n 0.6587 6749.9n 0.6587 6750.0n 0.4516 6999.9n 0.4516 7000.0n 0.3749 7249.9n 0.3749 7250.0n 0.4133 7499.9n 0.4133 7500.0n 0.7661 7749.9n 0.7661 7750.0n 0.4670 7999.9n 0.4670 8000.0n 0.4670 8249.9n 0.4670 8250.0n 0.4516 8499.9n 0.4516 8500.0n 0.4516 8749.9n 0.4516 8750.0n 0.7661 8999.9n 0.7661 9000.0n 0.5437 9249.9n 0.5437 9250.0n 0.7661 9499.9n 0.7661 9500.0n 0.3749 9749.9n 0.3749 9750.0n 0.3749 9999.9n 0.3749 10000.0n 0.4209 10249.9n 0.4209 10250.0n 0.4286 10499.9n 0.4286 10500.0n 0.7584 10749.9n 0.7584 10750.0n 0.4670 10999.9n 0.4670 11000.0n 0.5437 11249.9n 0.5437 11250.0n 0.3903 11499.9n 0.3903 11500.0n 0.7584 11749.9n 0.7584 11750.0n 0.4363 11999.9n 0.4363 12000.0n 0.5207 12249.9n 0.5207 12250.0n 0.4976 12499.9n 0.4976 12500.0n 0.4440 12749.9n 0.4440 12750.0n 0.6894 12999.9n 0.6894 13000.0n 0.4363 13249.9n 0.4363 13250.0n 0.5820 13499.9n 0.5820 13500.0n 0.7431 13749.9n 0.7431 13750.0n 0.3979 13999.9n 0.3979 14000.0n 0.6587 14249.9n 0.6587 14250.0n 0.4516 14499.9n 0.4516 14500.0n 0.3749 14749.9n 0.3749 14750.0n 0.4133 14999.9n 0.4133 15000.0n 0.7661 15249.9n 0.7661 15250.0n 0.4670 15499.9n 0.4670 15500.0n 0.4670 15749.9n 0.4670 15750.0n 0.4516 15999.9n 0.4516 16000.0n 0.4516 16249.9n 0.4516 16250.0n 0.7661 16499.9n 0.7661 16500.0n 0.5437 16749.9n 0.5437 16750.0n 0.7661 16999.9n 0.7661 17000.0n 0.3749 17249.9n 0.3749 17250.0n 0.3749 17499.9n 0.3749 17500.0n 0.4209 17749.9n 0.4209 17750.0n 0.4286 17999.9n 0.4286 18000.0n 0.7584 18249.9n 0.7584 18250.0n 0.4670 18499.9n 0.4670 18500.0n 0.5437 18749.9n 0.5437 18750.0n 0.3903 18999.9n 0.3903 19000.0n 0.7584 19249.9n 0.7584 19250.0n 0.4363 19499.9n 0.4363 19500.0n 0.5207 19749.9n 0.5207 19750.0n 0.4976 19999.9n 0.4976 20000.0n 0.4440 20249.9n 0.4440 20250.0n 0.6894 20499.9n 0.6894 20500.0n 0.4363 20749.9n 0.4363 20750.0n 0.5820 20999.9n 0.5820 21000.0n 0.7431 21249.9n 0.7431 21250.0n 0.3979 21499.9n 0.3979 21500.0n 0.6587 21749.9n 0.6587 21750.0n 0.4516 21999.9n 0.4516 22000.0n 0.3749 22249.9n 0.3749 22250.0n 0.4133 22499.9n 0.4133 22500.0n 0.7661 22749.9n 0.7661 22750.0n 0.4670 22999.9n 0.4670 23000.0n 0.4670 23249.9n 0.4670 23250.0n 0.4516 23499.9n 0.4516 23500.0n 0.4516 23749.9n 0.4516 23750.0n 0.7661 23999.9n 0.7661 24000.0n 0.5437 24249.9n 0.5437 24250.0n 0.7661 24499.9n 0.7661 24500.0n 0.3749 24749.9n 0.3749 24750.0n 0.3749 24999.9n 0.3749 25000.0n 0.4209 25249.9n 0.4209 25250.0n 0.4286 25499.9n 0.4286 25500.0n 0.7584 25749.9n 0.7584 25750.0n 0.4670 25999.9n 0.4670 26000.0n 0.5437 26249.9n 0.5437 26250.0n 0.3903 26499.9n 0.3903 26500.0n 0.7584 26749.9n 0.7584 26750.0n 0.4363 26999.9n 0.4363 27000.0n 0.5207 27249.9n 0.5207 27250.0n 0.4976 27499.9n 0.4976 27500.0n 0.4440 27749.9n 0.4440 27750.0n 0.6894 27999.9n 0.6894 28000.0n 0.4363 28249.9n 0.4363 28250.0n 0.5820 28499.9n 0.5820 28500.0n 0.7431 28749.9n 0.7431 28750.0n 0.3979 28999.9n 0.3979 29000.0n 0.6587 29249.9n 0.6587 29250.0n 0.4516 29499.9n 0.4516 29500.0n 0.3749 29749.9n 0.3749 29750.0n 0.4133 29999.9n 0.4133 30000.0n 0.7661 30249.9n 0.7661 30250.0n 0.4670 30499.9n 0.4670 30500.0n 0.4670 30749.9n 0.4670 30750.0n 0.4516 30999.9n 0.4516 31000.0n 0.4516 31249.9n 0.4516 31250.0n 0.7661 31499.9n 0.7661 31500.0n 0.5437 31749.9n 0.5437 31750.0n 0.7661 31999.9n 0.7661 32000.0n 0.3749 32249.9n 0.3749 32250.0n 0.3749 32499.9n 0.3749 32500.0n 0.4209 32749.9n 0.4209 32750.0n 0.4286 32999.9n 0.4286 33000.0n 0.7584 33249.9n 0.7584 33250.0n 0.4670 33499.9n 0.4670 33500.0n 0.5437 33749.9n 0.5437 33750.0n 0.3903 33999.9n 0.3903 34000.0n 0.7584 34249.9n 0.7584 34250.0n 0.4363 34499.9n 0.4363 34500.0n 0.5207 34749.9n 0.5207 34750.0n 0.4976 34999.9n 0.4976 35000.0n 0.4440 35249.9n 0.4440 35250.0n 0.6894 35499.9n 0.6894 35500.0n 0.4363 35749.9n 0.4363 35750.0n 0.5820 35999.9n 0.5820 36000.0n 0.7431 36249.9n 0.7431 36250.0n 0.3979 36499.9n 0.3979 36500.0n 0.6587 36749.9n 0.6587 36750.0n 0.4516 36999.9n 0.4516 37000.0n 0.3749 37249.9n 0.3749 37250.0n 0.4133 37499.9n 0.4133 37500.0n 0.7661 37749.9n 0.7661 37750.0n 0.4670 37999.9n 0.4670 38000.0n 0.4670 38249.9n 0.4670 38250.0n 0.4516 38499.9n 0.4516 38500.0n 0.4516 38749.9n 0.4516 38750.0n 0.7661 38999.9n 0.7661 39000.0n 0.5437 39249.9n 0.5437 39250.0n 0.7661 39499.9n 0.7661 39500.0n 0.3749 39749.9n 0.3749 39750.0n 0.3749 39999.9n 0.3749 40000.0n 0.4209 40249.9n 0.4209 40250.0n 0.4286 40499.9n 0.4286 40500.0n 0.7584 40749.9n 0.7584 40750.0n 0.4670 40999.9n 0.4670 41000.0n 0.5437 41249.9n 0.5437 41250.0n 0.3903 41499.9n 0.3903 41500.0n 0.7584 41749.9n 0.7584 41750.0n 0.4363 41999.9n 0.4363 42000.0n 0.5207 42249.9n 0.5207 42250.0n 0.4976 42499.9n 0.4976 42500.0n 0.4440 42749.9n 0.4440 42750.0n 0.6894 42999.9n 0.6894 43000.0n 0.4363 43249.9n 0.4363 43250.0n 0.5820 43499.9n 0.5820 43500.0n 0.7431 43749.9n 0.7431 43750.0n 0.3979 43999.9n 0.3979 44000.0n 0.6587 44249.9n 0.6587 44250.0n 0.4516 44499.9n 0.4516 44500.0n 0.3749 44749.9n 0.3749 44750.0n 0.4133 44999.9n 0.4133 45000.0n 0.7661 45249.9n 0.7661 45250.0n 0.4670 45499.9n 0.4670 45500.0n 0.4670 45749.9n 0.4670 45750.0n 0.4516 45999.9n 0.4516 46000.0n 0.4516 46249.9n 0.4516 46250.0n 0.7661 46499.9n 0.7661 46500.0n 0.5437 46749.9n 0.5437 46750.0n 0.7661 46999.9n 0.7661 47000.0n 0.3749 47249.9n 0.3749 47250.0n 0.3749 47499.9n 0.3749 47500.0n 0.4209 47749.9n 0.4209 47750.0n 0.4286 47999.9n 0.4286 48000.0n 0.7584 48249.9n 0.7584 48250.0n 0.4670 48499.9n 0.4670 48500.0n 0.5437 48749.9n 0.5437 48750.0n 0.3903 48999.9n 0.3903 49000.0n 0.7584 49249.9n 0.7584 49250.0n 0.4363 49499.9n 0.4363 49500.0n 0.5207 49749.9n 0.5207 49750.0n 0.4976 49999.9n 0.4976 50000.0n 0.4440 50249.9n 0.4440 50250.0n 0.6894 50499.9n 0.6894 50500.0n 0.4363 50749.9n 0.4363 50750.0n 0.5820 50999.9n 0.5820 51000.0n 0.7431 51249.9n 0.7431 51250.0n 0.3979 51499.9n 0.3979 51500.0n 0.6587 51749.9n 0.6587 51750.0n 0.4516 51999.9n 0.4516 52000.0n 0.3749 52249.9n 0.3749 52250.0n 0.4133 52499.9n 0.4133 52500.0n 0.7661 52749.9n 0.7661 52750.0n 0.4670 52999.9n 0.4670 53000.0n 0.4670 53249.9n 0.4670 53250.0n 0.4516 53499.9n 0.4516 53500.0n 0.4516 53749.9n 0.4516 53750.0n 0.7661 53999.9n 0.7661 54000.0n 0.5437 54249.9n 0.5437 54250.0n 0.7661 54499.9n 0.7661 54500.0n 0.3749 54749.9n 0.3749 54750.0n 0.3749 54999.9n 0.3749 55000.0n 0.4209 55249.9n 0.4209 55250.0n 0.4286 55499.9n 0.4286 55500.0n 0.7584 55749.9n 0.7584 55750.0n 0.4670 55999.9n 0.4670 56000.0n 0.5437 56249.9n 0.5437 56250.0n 0.3903 56499.9n 0.3903 56500.0n 0.7584 56749.9n 0.7584 56750.0n 0.4363 56999.9n 0.4363 57000.0n 0.5207 57249.9n 0.5207 57250.0n 0.4976 57499.9n 0.4976 57500.0n 0.4440 57749.9n 0.4440 57750.0n 0.6894 57999.9n 0.6894 58000.0n 0.4363 58249.9n 0.4363 58250.0n 0.5820 58499.9n 0.5820 58500.0n 0.7431 58749.9n 0.7431 58750.0n 0.3979 58999.9n 0.3979 59000.0n 0.6587 59249.9n 0.6587 59250.0n 0.4516 59499.9n 0.4516 59500.0n 0.3749 59749.9n 0.3749 59750.0n 0.4133 59999.9n 0.4133 60000.0n 0.7661 60249.9n 0.7661 60250.0n 0.4670 60499.9n 0.4670 60500.0n 0.4670 60749.9n 0.4670 60750.0n 0.4516 60999.9n 0.4516 61000.0n 0.4516 61249.9n 0.4516 61250.0n 0.7661 61499.9n 0.7661 61500.0n 0.5437 61749.9n 0.5437 61750.0n 0.7661 61999.9n 0.7661 62000.0n 0.3749 62249.9n 0.3749 62250.0n 0.3749 62499.9n 0.3749 62500.0n 0.4209 62749.9n 0.4209 62750.0n 0.4286 62999.9n 0.4286 63000.0n 0.7584 63249.9n 0.7584 63250.0n 0.4670 63499.9n 0.4670 63500.0n 0.5437 63749.9n 0.5437 63750.0n 0.3903 63999.9n 0.3903 64000.0n 0.7584 64249.9n 0.7584 64250.0n 0.4363 64499.9n 0.4363 64500.0n 0.5207 64749.9n 0.5207 64750.0n 0.4976 64999.9n 0.4976 65000.0n 0.4440 65249.9n 0.4440 65250.0n 0.6894 65499.9n 0.6894 65500.0n 0.4363 65749.9n 0.4363 65750.0n 0.5820 65999.9n 0.5820 66000.0n 0.7431 66249.9n 0.7431 66250.0n 0.3979 66499.9n 0.3979 66500.0n 0.6587 66749.9n 0.6587 66750.0n 0.4516 66999.9n 0.4516 67000.0n 0.3749 67249.9n 0.3749 67250.0n 0.4133 67499.9n 0.4133 67500.0n 0.7661 67749.9n 0.7661 67750.0n 0.4670 67999.9n 0.4670 68000.0n 0.4670 68249.9n 0.4670 68250.0n 0.4516 68499.9n 0.4516 68500.0n 0.4516 68749.9n 0.4516 68750.0n 0.7661 68999.9n 0.7661 69000.0n 0.5437 69249.9n 0.5437 69250.0n 0.7661 69499.9n 0.7661 69500.0n 0.3749 69749.9n 0.3749 69750.0n 0.3749 69999.9n 0.3749 70000.0n 0.4209 70249.9n 0.4209 70250.0n 0.4286 70499.9n 0.4286 70500.0n 0.7584 70749.9n 0.7584 70750.0n 0.4670 70999.9n 0.4670 71000.0n 0.5437 71249.9n 0.5437 71250.0n 0.3903 71499.9n 0.3903 71500.0n 0.7584 71749.9n 0.7584 71750.0n 0.4363 71999.9n 0.4363 72000.0n 0.5207 72249.9n 0.5207 72250.0n 0.4976 72499.9n 0.4976 72500.0n 0.4440 72749.9n 0.4440 72750.0n 0.6894 72999.9n 0.6894 73000.0n 0.4363 73249.9n 0.4363 73250.0n 0.5820 73499.9n 0.5820 73500.0n 0.7431 73749.9n 0.7431 73750.0n 0.3979 73999.9n 0.3979 74000.0n 0.6587 74249.9n 0.6587 74250.0n 0.4516 74499.9n 0.4516 74500.0n 0.3749 74749.9n 0.3749 74750.0n 0.4133 74999.9n 0.4133 75000.0n 0.7661 75249.9n 0.7661 75250.0n 0.4670 75499.9n 0.4670 75500.0n 0.4670 75749.9n 0.4670 75750.0n 0.4516 75999.9n 0.4516 76000.0n 0.4516 76249.9n 0.4516 76250.0n 0.7661 76499.9n 0.7661 76500.0n 0.5437 76749.9n 0.5437 76750.0n 0.7661 76999.9n 0.7661 77000.0n 0.3749 77249.9n 0.3749 77250.0n 0.3749 77499.9n 0.3749 77500.0n 0.4209 77749.9n 0.4209 77750.0n 0.4286 77999.9n 0.4286 78000.0n 0.7584 78249.9n 0.7584 78250.0n 0.4670 78499.9n 0.4670 78500.0n 0.5437 78749.9n 0.5437 78750.0n 0.3903 78999.9n 0.3903 79000.0n 0.7584 79249.9n 0.7584 79250.0n 0.4363 79499.9n 0.4363 79500.0n 0.5207 79749.9n 0.5207 79750.0n 0.4976 79999.9n 0.4976 80000.0n 0.4440 80249.9n 0.4440 80250.0n 0.6894 80499.9n 0.6894 80500.0n 0.4363 80749.9n 0.4363 80750.0n 0.5820 80999.9n 0.5820 81000.0n 0.7431 81249.9n 0.7431 81250.0n 0.3979 81499.9n 0.3979 81500.0n 0.6587 81749.9n 0.6587 81750.0n 0.4516 81999.9n 0.4516 82000.0n 0.3749 82249.9n 0.3749 82250.0n 0.4133 82499.9n 0.4133 82500.0n 0.7661 82749.9n 0.7661 82750.0n 0.4670 82999.9n 0.4670 83000.0n 0.4670 83249.9n 0.4670 83250.0n 0.4516 83499.9n 0.4516 83500.0n 0.4516 83749.9n 0.4516 83750.0n 0.7661 83999.9n 0.7661 84000.0n 0.5437 84249.9n 0.5437 84250.0n 0.7661 84499.9n 0.7661 84500.0n 0.3749 84749.9n 0.3749 84750.0n 0.3749 84999.9n 0.3749 85000.0n 0.4209 85249.9n 0.4209 85250.0n 0.4286 85499.9n 0.4286 85500.0n 0.7584 85749.9n 0.7584 85750.0n 0.4670 85999.9n 0.4670 86000.0n 0.5437 86249.9n 0.5437 86250.0n 0.3903 86499.9n 0.3903 86500.0n 0.7584 86749.9n 0.7584 86750.0n 0.4363 86999.9n 0.4363 87000.0n 0.5207 87249.9n 0.5207 87250.0n 0.4976 87499.9n 0.4976 87500.0n 0.4440 87749.9n 0.4440 87750.0n 0.6894 87999.9n 0.6894 88000.0n 0.4363 88249.9n 0.4363 88250.0n 0.5820 88499.9n 0.5820 88500.0n 0.7431 88749.9n 0.7431 88750.0n 0.3979 88999.9n 0.3979 89000.0n 0.6587 89249.9n 0.6587 89250.0n 0.4516 89499.9n 0.4516 89500.0n 0.3749 89749.9n 0.3749 89750.0n 0.4133 89999.9n 0.4133 90000.0n 0.7661 90249.9n 0.7661 90250.0n 0.4670 90499.9n 0.4670 90500.0n 0.4670 90749.9n 0.4670 90750.0n 0.4516 90999.9n 0.4516 91000.0n 0.4516 91249.9n 0.4516 91250.0n 0.7661 91499.9n 0.7661 91500.0n 0.5437 91749.9n 0.5437 91750.0n 0.7661 91999.9n 0.7661 92000.0n 0.3749 92249.9n 0.3749 92250.0n 0.3749 92499.9n 0.3749 92500.0n 0.4209 92749.9n 0.4209 92750.0n 0.4286 92999.9n 0.4286 93000.0n 0.7584 93249.9n 0.7584 93250.0n 0.4670 93499.9n 0.4670 93500.0n 0.5437 93749.9n 0.5437 93750.0n 0.3903 93999.9n 0.3903 94000.0n 0.7584 94249.9n 0.7584 94250.0n 0.4363 94499.9n 0.4363 94500.0n 0.5207 94749.9n 0.5207 94750.0n 0.4976 94999.9n 0.4976 95000.0n 0.4440 95249.9n 0.4440 95250.0n 0.6894 95499.9n 0.6894 95500.0n 0.4363 95749.9n 0.4363 95750.0n 0.5820 95999.9n 0.5820 96000.0n 0.7431 96249.9n 0.7431 96250.0n 0.3979 96499.9n 0.3979 96500.0n 0.6587 96749.9n 0.6587 96750.0n 0.4516 96999.9n 0.4516 97000.0n 0.3749 97249.9n 0.3749 97250.0n 0.4133 97499.9n 0.4133 97500.0n 0.7661 97749.9n 0.7661 97750.0n 0.4670 97999.9n 0.4670 98000.0n 0.4670 98249.9n 0.4670 98250.0n 0.4516 98499.9n 0.4516 98500.0n 0.4516 98749.9n 0.4516 98750.0n 0.7661 98999.9n 0.7661 99000.0n 0.5437 99249.9n 0.5437 99250.0n 0.7661 99499.9n 0.7661 99500.0n 0.3749 99749.9n 0.3749 99750.0n 0.3749 99999.9n 0.3749 100000.0n 0.4209 100249.9n 0.4209 100250.0n 0.4286 100499.9n 0.4286 100500.0n 0.7584 100749.9n 0.7584 100750.0n 0.4670 100999.9n 0.4670 101000.0n 0.5437 101249.9n 0.5437 101250.0n 0.3903 101499.9n 0.3903 101500.0n 0.7584 101749.9n 0.7584 101750.0n 0.4363 101999.9n 0.4363 102000.0n 0.5207 102249.9n 0.5207 102250.0n 0.4976 102499.9n 0.4976 102500.0n 0.4440 102749.9n 0.4440 102750.0n 0.6894 102999.9n 0.6894 103000.0n 0.4363 103249.9n 0.4363 103250.0n 0.5820 103499.9n 0.5820 103500.0n 0.7431 103749.9n 0.7431 103750.0n 0.3979 103999.9n 0.3979 104000.0n 0.6587 104249.9n 0.6587 104250.0n 0.4516 104499.9n 0.4516 104500.0n 0.3749 104749.9n 0.3749 104750.0n 0.4133 104999.9n 0.4133 105000.0n 0.7661 105249.9n 0.7661 105250.0n 0.4670 105499.9n 0.4670 105500.0n 0.4670 105749.9n 0.4670 105750.0n 0.4516 105999.9n 0.4516 106000.0n 0.4516 106249.9n 0.4516 106250.0n 0.7661 106499.9n 0.7661 106500.0n 0.5437 106749.9n 0.5437 106750.0n 0.7661 106999.9n 0.7661 107000.0n 0.3749 107249.9n 0.3749 107250.0n 0.3749 107499.9n 0.3749 107500.0n 0.4209 107749.9n 0.4209 107750.0n 0.4286 107999.9n 0.4286 108000.0n 0.7584 108249.9n 0.7584 108250.0n 0.4670 108499.9n 0.4670 108500.0n 0.5437 108749.9n 0.5437 108750.0n 0.3903 108999.9n 0.3903 109000.0n 0.7584 109249.9n 0.7584 109250.0n 0.4363 109499.9n 0.4363 109500.0n 0.5207 109749.9n 0.5207 109750.0n 0.4976 109999.9n 0.4976 110000.0n 0.4440 110249.9n 0.4440 110250.0n 0.6894 110499.9n 0.6894 110500.0n 0.4363 110749.9n 0.4363 110750.0n 0.5820 110999.9n 0.5820 111000.0n 0.7431 111249.9n 0.7431 111250.0n 0.3979 111499.9n 0.3979 111500.0n 0.6587 111749.9n 0.6587 111750.0n 0.4516 111999.9n 0.4516 112000.0n 0.3749 112249.9n 0.3749 112250.0n 0.4133 112499.9n 0.4133 112500.0n 0.7661 112749.9n 0.7661 112750.0n 0.4670 112999.9n 0.4670 113000.0n 0.4670 113249.9n 0.4670 113250.0n 0.4516 113499.9n 0.4516 113500.0n 0.4516 113749.9n 0.4516 113750.0n 0.7661 113999.9n 0.7661 114000.0n 0.5437 114249.9n 0.5437 114250.0n 0.7661 114499.9n 0.7661 114500.0n 0.3749 114749.9n 0.3749 114750.0n 0.3749 114999.9n 0.3749 115000.0n 0.4209 115249.9n 0.4209 115250.0n 0.4286 115499.9n 0.4286 115500.0n 0.7584 115749.9n 0.7584 115750.0n 0.4670 115999.9n 0.4670 116000.0n 0.5437 116249.9n 0.5437 116250.0n 0.3903 116499.9n 0.3903 116500.0n 0.7584 116749.9n 0.7584 116750.0n 0.4363 116999.9n 0.4363 117000.0n 0.5207 117249.9n 0.5207 117250.0n 0.4976 117499.9n 0.4976 117500.0n 0.4440 117749.9n 0.4440 117750.0n 0.6894 117999.9n 0.6894 118000.0n 0.4363 118249.9n 0.4363 118250.0n 0.5820 118499.9n 0.5820 118500.0n 0.7431 118749.9n 0.7431 118750.0n 0.3979 118999.9n 0.3979 119000.0n 0.6587 119249.9n 0.6587 119250.0n 0.4516 119499.9n 0.4516 119500.0n 0.3749 119749.9n 0.3749 119750.0n 0.4133 119999.9n 0.4133 120000.0n 0.7661 120249.9n 0.7661 120250.0n 0.4670 120499.9n 0.4670 120500.0n 0.4670 120749.9n 0.4670 120750.0n 0.4516 120999.9n 0.4516 121000.0n 0.4516 121249.9n 0.4516 121250.0n 0.7661 121499.9n 0.7661 121500.0n 0.5437 121749.9n 0.5437 121750.0n 0.7661 121999.9n 0.7661 122000.0n 0.3749 122249.9n 0.3749 122250.0n 0.3749 122499.9n 0.3749 122500.0n 0.4209 122749.9n 0.4209 122750.0n 0.4286 122999.9n 0.4286 123000.0n 0.7584 123249.9n 0.7584 123250.0n 0.4670 123499.9n 0.4670 123500.0n 0.5437 123749.9n 0.5437 123750.0n 0.3903 123999.9n 0.3903 124000.0n 0.7584 124249.9n 0.7584 124250.0n 0.4363 124499.9n 0.4363 124500.0n 0.5207 124749.9n 0.5207 124750.0n 0.4976 124999.9n 0.4976 125000.0n 0.4440 125249.9n 0.4440 125250.0n 0.6894 125499.9n 0.6894 125500.0n 0.4363 125749.9n 0.4363 125750.0n 0.5820 125999.9n 0.5820 126000.0n 0.7431 126249.9n 0.7431 126250.0n 0.3979 126499.9n 0.3979 126500.0n 0.6587 126749.9n 0.6587 126750.0n 0.4516 126999.9n 0.4516 127000.0n 0.3749 127249.9n 0.3749 127250.0n 0.4133 127499.9n 0.4133 127500.0n 0.7661 127749.9n 0.7661 127750.0n 0.4670 127999.9n 0.4670 128000.0n 0.4670 128249.9n 0.4670 128250.0n 0.4516 128499.9n 0.4516 128500.0n 0.4516 128749.9n 0.4516 128750.0n 0.7661 128999.9n 0.7661 129000.0n 0.5437 129249.9n 0.5437 129250.0n 0.7661 129499.9n 0.7661 129500.0n 0.3749 129749.9n 0.3749 129750.0n 0.3749 129999.9n 0.3749 130000.0n 0.4209 130249.9n 0.4209 130250.0n 0.4286 130499.9n 0.4286 130500.0n 0.7584 130749.9n 0.7584 130750.0n 0.4670 130999.9n 0.4670 131000.0n 0.5437 131249.9n 0.5437 131250.0n 0.3903 131499.9n 0.3903 131500.0n 0.7584 131749.9n 0.7584 131750.0n 0.4363 131999.9n 0.4363 132000.0n 0.5207 132249.9n 0.5207 132250.0n 0.4976 132499.9n 0.4976 132500.0n 0.4440 132749.9n 0.4440 132750.0n 0.6894 132999.9n 0.6894 133000.0n 0.4363 133249.9n 0.4363 133250.0n 0.5820 133499.9n 0.5820 133500.0n 0.7431 133749.9n 0.7431 133750.0n 0.3979 133999.9n 0.3979 134000.0n 0.6587 134249.9n 0.6587 134250.0n 0.4516 134499.9n 0.4516 134500.0n 0.3749 134749.9n 0.3749 134750.0n 0.4133 134999.9n 0.4133 135000.0n 0.7661 135249.9n 0.7661 135250.0n 0.4670 135499.9n 0.4670 135500.0n 0.4670 135749.9n 0.4670 135750.0n 0.4516 135999.9n 0.4516 136000.0n 0.4516 136249.9n 0.4516 136250.0n 0.7661 136499.9n 0.7661 136500.0n 0.5437 136749.9n 0.5437 136750.0n 0.7661 136999.9n 0.7661 137000.0n 0.3749 137249.9n 0.3749 137250.0n 0.3749 137499.9n 0.3749 137500.0n 0.4209 137749.9n 0.4209 137750.0n 0.4286 137999.9n 0.4286 138000.0n 0.7584 138249.9n 0.7584 138250.0n 0.4670 138499.9n 0.4670 138500.0n 0.5437 138749.9n 0.5437 138750.0n 0.3903 138999.9n 0.3903 139000.0n 0.7584 139249.9n 0.7584 139250.0n 0.4363 139499.9n 0.4363 139500.0n 0.5207 139749.9n 0.5207 139750.0n 0.4976 139999.9n 0.4976 140000.0n 0.4440 140249.9n 0.4440 140250.0n 0.6894 140499.9n 0.6894 140500.0n 0.4363 140749.9n 0.4363 140750.0n 0.5820 140999.9n 0.5820 141000.0n 0.7431 141249.9n 0.7431 141250.0n 0.3979 141499.9n 0.3979 141500.0n 0.6587 141749.9n 0.6587 141750.0n 0.4516 141999.9n 0.4516 142000.0n 0.3749 142249.9n 0.3749 142250.0n 0.4133 142499.9n 0.4133 142500.0n 0.7661 142749.9n 0.7661 142750.0n 0.4670 142999.9n 0.4670 143000.0n 0.4670 143249.9n 0.4670 143250.0n 0.4516 143499.9n 0.4516 143500.0n 0.4516 143749.9n 0.4516 143750.0n 0.7661 143999.9n 0.7661 144000.0n 0.5437 144249.9n 0.5437 144250.0n 0.7661 144499.9n 0.7661 144500.0n 0.3749 144749.9n 0.3749 144750.0n 0.3749 144999.9n 0.3749 145000.0n 0.4209 145249.9n 0.4209 145250.0n 0.4286 145499.9n 0.4286 145500.0n 0.7584 145749.9n 0.7584 145750.0n 0.4670 145999.9n 0.4670 146000.0n 0.5437 146249.9n 0.5437 146250.0n 0.3903 146499.9n 0.3903 146500.0n 0.7584 146749.9n 0.7584 146750.0n 0.4363 146999.9n 0.4363 147000.0n 0.5207 147249.9n 0.5207 147250.0n 0.4976 147499.9n 0.4976 147500.0n 0.4440 147749.9n 0.4440 147750.0n 0.6894 147999.9n 0.6894 148000.0n 0.4363 148249.9n 0.4363 148250.0n 0.5820 148499.9n 0.5820 148500.0n 0.7431 148749.9n 0.7431 148750.0n 0.3979 148999.9n 0.3979 149000.0n 0.6587 149249.9n 0.6587 149250.0n 0.4516 149499.9n 0.4516 149500.0n 0.3749 149749.9n 0.3749 149750.0n 0.4133 149999.9n 0.4133 150000.0n 0.7661 150249.9n 0.7661 150250.0n 0.4670 150499.9n 0.4670 150500.0n 0.4670 150749.9n 0.4670 150750.0n 0.4516 150999.9n 0.4516 151000.0n 0.4516 151249.9n 0.4516 151250.0n 0.7661 151499.9n 0.7661 151500.0n 0.5437 151749.9n 0.5437 151750.0n 0.7661 151999.9n 0.7661 152000.0n 0.3749 152249.9n 0.3749 152250.0n 0.3749 152499.9n 0.3749 152500.0n 0.4209 152749.9n 0.4209 152750.0n 0.4286 152999.9n 0.4286 153000.0n 0.7584 153249.9n 0.7584 153250.0n 0.4670 153499.9n 0.4670 153500.0n 0.5437 153749.9n 0.5437 153750.0n 0.3903 153999.9n 0.3903 154000.0n 0.7584 154249.9n 0.7584 154250.0n 0.4363 154499.9n 0.4363 154500.0n 0.5207 154749.9n 0.5207 154750.0n 0.4976 154999.9n 0.4976 155000.0n 0.4440 155249.9n 0.4440 155250.0n 0.6894 155499.9n 0.6894 155500.0n 0.4363 155749.9n 0.4363 155750.0n 0.5820 155999.9n 0.5820 156000.0n 0.7431 156249.9n 0.7431 156250.0n 0.3979 156499.9n 0.3979 156500.0n 0.6587 156749.9n 0.6587 156750.0n 0.4516 156999.9n 0.4516 157000.0n 0.3749 157249.9n 0.3749 157250.0n 0.4133 157499.9n 0.4133 157500.0n 0.7661 157749.9n 0.7661 157750.0n 0.4670 157999.9n 0.4670 158000.0n 0.4670 158249.9n 0.4670 158250.0n 0.4516 158499.9n 0.4516 158500.0n 0.4516 158749.9n 0.4516 158750.0n 0.7661 158999.9n 0.7661 159000.0n 0.5437 159249.9n 0.5437 159250.0n 0.7661 159499.9n 0.7661 159500.0n 0.3749 159749.9n 0.3749 159750.0n 0.3749 159999.9n 0.3749 160000.0n 0.4209 160249.9n 0.4209 160250.0n 0.4286 160499.9n 0.4286 160500.0n 0.7584 160749.9n 0.7584 160750.0n 0.4670 160999.9n 0.4670 161000.0n 0.5437 161249.9n 0.5437 161250.0n 0.3903 161499.9n 0.3903 161500.0n 0.7584 161749.9n 0.7584 161750.0n 0.4363 161999.9n 0.4363 162000.0n 0.5207 162249.9n 0.5207 162250.0n 0.4976 162499.9n 0.4976 162500.0n 0.4440 162749.9n 0.4440 162750.0n 0.6894 162999.9n 0.6894 163000.0n 0.4363 163249.9n 0.4363 163250.0n 0.5820 163499.9n 0.5820 163500.0n 0.7431 163749.9n 0.7431 163750.0n 0.3979 163999.9n 0.3979 164000.0n 0.6587 164249.9n 0.6587 164250.0n 0.4516 164499.9n 0.4516 164500.0n 0.3749 164749.9n 0.3749 164750.0n 0.4133 164999.9n 0.4133 165000.0n 0.7661 165249.9n 0.7661 165250.0n 0.4670 165499.9n 0.4670 165500.0n 0.4670 165749.9n 0.4670 165750.0n 0.4516 165999.9n 0.4516 166000.0n 0.4516 166249.9n 0.4516 166250.0n 0.7661 166499.9n 0.7661 166500.0n 0.5437 166749.9n 0.5437 166750.0n 0.7661 166999.9n 0.7661 167000.0n 0.3749 167249.9n 0.3749 167250.0n 0.3749 167499.9n 0.3749 167500.0n 0.4209 167749.9n 0.4209 167750.0n 0.4286 167999.9n 0.4286 168000.0n 0.7584 168249.9n 0.7584 168250.0n 0.4670 168499.9n 0.4670 168500.0n 0.5437 168749.9n 0.5437 168750.0n 0.3903 168999.9n 0.3903 169000.0n 0.7584 169249.9n 0.7584 169250.0n 0.4363 169499.9n 0.4363 169500.0n 0.5207 169749.9n 0.5207 169750.0n 0.4976 169999.9n 0.4976 170000.0n 0.4440 170249.9n 0.4440 170250.0n 0.6894 170499.9n 0.6894 170500.0n 0.4363 170749.9n 0.4363 170750.0n 0.5820 170999.9n 0.5820 171000.0n 0.7431 171249.9n 0.7431 171250.0n 0.3979 171499.9n 0.3979 171500.0n 0.6587 171749.9n 0.6587 171750.0n 0.4516 171999.9n 0.4516 172000.0n 0.3749 172249.9n 0.3749 172250.0n 0.4133 172499.9n 0.4133 172500.0n 0.7661 172749.9n 0.7661 172750.0n 0.4670 172999.9n 0.4670 173000.0n 0.4670 173249.9n 0.4670 173250.0n 0.4516 173499.9n 0.4516 173500.0n 0.4516 173749.9n 0.4516 173750.0n 0.7661 173999.9n 0.7661 174000.0n 0.5437 174249.9n 0.5437 174250.0n 0.7661 174499.9n 0.7661 174500.0n 0.3749 174749.9n 0.3749 174750.0n 0.3749 174999.9n 0.3749 175000.0n 0.4209 175249.9n 0.4209 175250.0n 0.4286 175499.9n 0.4286 175500.0n 0.7584 175749.9n 0.7584 175750.0n 0.4670 175999.9n 0.4670 176000.0n 0.5437 176249.9n 0.5437 176250.0n 0.3903 176499.9n 0.3903 176500.0n 0.7584 176749.9n 0.7584 176750.0n 0.4363 176999.9n 0.4363 177000.0n 0.5207 177249.9n 0.5207 177250.0n 0.4976 177499.9n 0.4976 177500.0n 0.4440 177749.9n 0.4440 177750.0n 0.6894 177999.9n 0.6894 178000.0n 0.4363 178249.9n 0.4363 178250.0n 0.5820 178499.9n 0.5820 178500.0n 0.7431 178749.9n 0.7431 178750.0n 0.3979 178999.9n 0.3979 179000.0n 0.6587 179249.9n 0.6587 179250.0n 0.4516 179499.9n 0.4516 179500.0n 0.3749 179749.9n 0.3749 179750.0n 0.4133 179999.9n 0.4133 180000.0n 0.7661 180249.9n 0.7661 180250.0n 0.4670 180499.9n 0.4670 180500.0n 0.4670 180749.9n 0.4670 180750.0n 0.4516 180999.9n 0.4516 181000.0n 0.4516 181249.9n 0.4516 181250.0n 0.7661 181499.9n 0.7661 181500.0n 0.5437 181749.9n 0.5437 181750.0n 0.7661 181999.9n 0.7661 182000.0n 0.3749 182249.9n 0.3749 182250.0n 0.3749 182499.9n 0.3749 182500.0n 0.4209 182749.9n 0.4209 182750.0n 0.4286 182999.9n 0.4286 183000.0n 0.7584 183249.9n 0.7584 183250.0n 0.4670 183499.9n 0.4670 183500.0n 0.5437 183749.9n 0.5437 183750.0n 0.3903 183999.9n 0.3903 184000.0n 0.7584 184249.9n 0.7584 184250.0n 0.4363 184499.9n 0.4363 184500.0n 0.5207 184749.9n 0.5207 184750.0n 0.4976 184999.9n 0.4976 185000.0n 0.4440 185249.9n 0.4440 185250.0n 0.6894 185499.9n 0.6894 185500.0n 0.4363 185749.9n 0.4363 185750.0n 0.5820 185999.9n 0.5820 186000.0n 0.7431 186249.9n 0.7431 186250.0n 0.3979 186499.9n 0.3979 186500.0n 0.6587 186749.9n 0.6587 186750.0n 0.4516 186999.9n 0.4516 187000.0n 0.3749 187249.9n 0.3749 187250.0n 0.4133 187499.9n 0.4133 187500.0n 0.7661 187749.9n 0.7661 187750.0n 0.4670 187999.9n 0.4670 188000.0n 0.4670 188249.9n 0.4670 188250.0n 0.4516 188499.9n 0.4516 188500.0n 0.4516 188749.9n 0.4516 188750.0n 0.7661 188999.9n 0.7661 189000.0n 0.5437 189249.9n 0.5437 189250.0n 0.7661 189499.9n 0.7661 189500.0n 0.3749 189749.9n 0.3749 189750.0n 0.3749 189999.9n 0.3749 190000.0n 0.4209 190249.9n 0.4209 190250.0n 0.4286 190499.9n 0.4286 190500.0n 0.7584 190749.9n 0.7584 190750.0n 0.4670 190999.9n 0.4670 191000.0n 0.5437 191249.9n 0.5437 191250.0n 0.3903 191499.9n 0.3903 191500.0n 0.7584 191749.9n 0.7584 191750.0n 0.4363 191999.9n 0.4363 192000.0n 0.5207 192249.9n 0.5207 192250.0n 0.4976 192499.9n 0.4976 192500.0n 0.4440 192749.9n 0.4440 192750.0n 0.6894 192999.9n 0.6894 193000.0n 0.4363 193249.9n 0.4363 193250.0n 0.5820 193499.9n 0.5820 193500.0n 0.7431 193749.9n 0.7431 193750.0n 0.3979 193999.9n 0.3979 194000.0n 0.6587 194249.9n 0.6587 194250.0n 0.4516 194499.9n 0.4516 194500.0n 0.3749 194749.9n 0.3749 194750.0n 0.4133 194999.9n 0.4133 195000.0n 0.7661 195249.9n 0.7661 195250.0n 0.4670 195499.9n 0.4670 195500.0n 0.4670 195749.9n 0.4670 195750.0n 0.4516 195999.9n 0.4516 196000.0n 0.4516 196249.9n 0.4516 196250.0n 0.7661 196499.9n 0.7661 196500.0n 0.5437 196749.9n 0.5437 196750.0n 0.7661 196999.9n 0.7661 197000.0n 0.3749 197249.9n 0.3749 197250.0n 0.3749 197499.9n 0.3749 197500.0n 0.4209 197749.9n 0.4209 197750.0n 0.4286 197999.9n 0.4286 198000.0n 0.7584 198249.9n 0.7584 198250.0n 0.4670 198499.9n 0.4670 198500.0n 0.5437 198749.9n 0.5437 198750.0n 0.3903 198999.9n 0.3903 199000.0n 0.7584 199249.9n 0.7584 199250.0n 0.4363 199499.9n 0.4363 199500.0n 0.5207 199749.9n 0.5207 199750.0n 0.4976 199999.9n 0.4976 200000.0n 0.4440 200249.9n 0.4440 200250.0n 0.6894 200499.9n 0.6894 200500.0n 0.4363 200749.9n 0.4363 200750.0n 0.5820 200999.9n 0.5820 201000.0n 0.7431 201249.9n 0.7431 201250.0n 0.3979 201499.9n 0.3979 201500.0n 0.6587 201749.9n 0.6587 201750.0n 0.4516 201999.9n 0.4516 202000.0n 0.3749 202249.9n 0.3749 202250.0n 0.4133 202499.9n 0.4133 202500.0n 0.7661 202749.9n 0.7661 202750.0n 0.4670 202999.9n 0.4670 203000.0n 0.4670 203249.9n 0.4670 203250.0n 0.4516 203499.9n 0.4516 203500.0n 0.4516 203749.9n 0.4516 203750.0n 0.7661 203999.9n 0.7661 204000.0n 0.5437 204249.9n 0.5437 204250.0n 0.7661 204499.9n 0.7661 204500.0n 0.3749 204749.9n 0.3749 204750.0n 0.3749 204999.9n 0.3749 205000.0n 0.4209 205249.9n 0.4209 205250.0n 0.4286 205499.9n 0.4286 205500.0n 0.7584 205749.9n 0.7584 205750.0n 0.4670 205999.9n 0.4670 206000.0n 0.5437 206249.9n 0.5437 206250.0n 0.3903 206499.9n 0.3903 206500.0n 0.7584 206749.9n 0.7584 206750.0n 0.4363 206999.9n 0.4363 207000.0n 0.5207 207249.9n 0.5207 207250.0n 0.4976 207499.9n 0.4976 207500.0n 0.4440 207749.9n 0.4440 207750.0n 0.6894 207999.9n 0.6894 208000.0n 0.4363 208249.9n 0.4363 208250.0n 0.5820 208499.9n 0.5820 208500.0n 0.7431 208749.9n 0.7431 208750.0n 0.3979 208999.9n 0.3979 209000.0n 0.6587 209249.9n 0.6587 209250.0n 0.4516 209499.9n 0.4516 209500.0n 0.3749 209749.9n 0.3749 209750.0n 0.4133 209999.9n 0.4133 210000.0n 0.7661 210249.9n 0.7661 210250.0n 0.4670 210499.9n 0.4670 210500.0n 0.4670 210749.9n 0.4670 210750.0n 0.4516 210999.9n 0.4516 211000.0n 0.4516 211249.9n 0.4516 211250.0n 0.7661 211499.9n 0.7661 211500.0n 0.5437 211749.9n 0.5437 211750.0n 0.7661 211999.9n 0.7661 212000.0n 0.3749 212249.9n 0.3749 212250.0n 0.3749 212499.9n 0.3749 212500.0n 0.4209 212749.9n 0.4209 212750.0n 0.4286 212999.9n 0.4286 213000.0n 0.7584 213249.9n 0.7584 213250.0n 0.4670 213499.9n 0.4670 213500.0n 0.5437 213749.9n 0.5437 213750.0n 0.3903 213999.9n 0.3903 214000.0n 0.7584 214249.9n 0.7584 214250.0n 0.4363 214499.9n 0.4363 214500.0n 0.5207 214749.9n 0.5207 214750.0n 0.4976 214999.9n 0.4976 215000.0n 0.4440 215249.9n 0.4440 215250.0n 0.6894 215499.9n 0.6894 215500.0n 0.4363 215749.9n 0.4363 215750.0n 0.5820 215999.9n 0.5820 216000.0n 0.7431 216249.9n 0.7431 216250.0n 0.3979 216499.9n 0.3979 216500.0n 0.6587 216749.9n 0.6587 216750.0n 0.4516 216999.9n 0.4516 217000.0n 0.3749 217249.9n 0.3749 217250.0n 0.4133 217499.9n 0.4133 217500.0n 0.7661 217749.9n 0.7661 217750.0n 0.4670 217999.9n 0.4670 218000.0n 0.4670 218249.9n 0.4670 218250.0n 0.4516 218499.9n 0.4516 218500.0n 0.4516 218749.9n 0.4516 218750.0n 0.7661 218999.9n 0.7661 219000.0n 0.5437 219249.9n 0.5437 219250.0n 0.7661 219499.9n 0.7661 219500.0n 0.3749 219749.9n 0.3749 219750.0n 0.3749 219999.9n 0.3749 220000.0n 0.4209 220249.9n 0.4209 220250.0n 0.4286 220499.9n 0.4286 220500.0n 0.7584 220749.9n 0.7584 220750.0n 0.4670 220999.9n 0.4670 221000.0n 0.5437 221249.9n 0.5437 221250.0n 0.3903 221499.9n 0.3903 221500.0n 0.7584 221749.9n 0.7584 221750.0n 0.4363 221999.9n 0.4363 222000.0n 0.5207 222249.9n 0.5207 222250.0n 0.4976 222499.9n 0.4976 222500.0n 0.4440 222749.9n 0.4440 222750.0n 0.6894 222999.9n 0.6894 223000.0n 0.4363 223249.9n 0.4363 223250.0n 0.5820 223499.9n 0.5820 223500.0n 0.7431 223749.9n 0.7431 223750.0n 0.3979 223999.9n 0.3979 224000.0n 0.6587 224249.9n 0.6587 224250.0n 0.4516 224499.9n 0.4516 224500.0n 0.3749 224749.9n 0.3749 224750.0n 0.4133 224999.9n 0.4133 225000.0n 0.7661 225249.9n 0.7661 225250.0n 0.4670 225499.9n 0.4670 225500.0n 0.4670 225749.9n 0.4670 225750.0n 0.4516 225999.9n 0.4516 226000.0n 0.4516 226249.9n 0.4516 226250.0n 0.7661 226499.9n 0.7661 226500.0n 0.5437 226749.9n 0.5437 226750.0n 0.7661 226999.9n 0.7661 227000.0n 0.3749 227249.9n 0.3749 227250.0n 0.3749 227499.9n 0.3749 227500.0n 0.4209 227749.9n 0.4209 227750.0n 0.4286 227999.9n 0.4286 228000.0n 0.7584 228249.9n 0.7584 228250.0n 0.4670 228499.9n 0.4670 228500.0n 0.5437 228749.9n 0.5437 228750.0n 0.3903 228999.9n 0.3903 229000.0n 0.7584 229249.9n 0.7584 229250.0n 0.4363 229499.9n 0.4363 229500.0n 0.5207 229749.9n 0.5207 229750.0n 0.4976 229999.9n 0.4976 230000.0n 0.4440 230249.9n 0.4440 230250.0n 0.6894 230499.9n 0.6894 230500.0n 0.4363 230749.9n 0.4363 230750.0n 0.5820 230999.9n 0.5820 231000.0n 0.7431 231249.9n 0.7431 231250.0n 0.3979 231499.9n 0.3979 231500.0n 0.6587 231749.9n 0.6587 231750.0n 0.4516 231999.9n 0.4516 232000.0n 0.3749 232249.9n 0.3749 232250.0n 0.4133 232499.9n 0.4133 232500.0n 0.7661 232749.9n 0.7661 232750.0n 0.4670 232999.9n 0.4670 233000.0n 0.4670 233249.9n 0.4670 233250.0n 0.4516 233499.9n 0.4516 233500.0n 0.4516 233749.9n 0.4516 233750.0n 0.7661 233999.9n 0.7661 234000.0n 0.5437 234249.9n 0.5437 234250.0n 0.7661 234499.9n 0.7661 234500.0n 0.3749 234749.9n 0.3749 234750.0n 0.3749 234999.9n 0.3749 235000.0n 0.4209 235249.9n 0.4209 235250.0n 0.4286 235499.9n 0.4286 235500.0n 0.7584 235749.9n 0.7584 235750.0n 0.4670 235999.9n 0.4670 236000.0n 0.5437 236249.9n 0.5437 236250.0n 0.3903 236499.9n 0.3903 236500.0n 0.7584 236749.9n 0.7584 236750.0n 0.4363 236999.9n 0.4363 237000.0n 0.5207 237249.9n 0.5207 237250.0n 0.4976 237499.9n 0.4976 237500.0n 0.4440 237749.9n 0.4440 237750.0n 0.6894 237999.9n 0.6894 238000.0n 0.4363 238249.9n 0.4363 238250.0n 0.5820 238499.9n 0.5820 238500.0n 0.7431 238749.9n 0.7431 238750.0n 0.3979 238999.9n 0.3979 239000.0n 0.6587 239249.9n 0.6587 239250.0n 0.4516 239499.9n 0.4516 239500.0n 0.3749 239749.9n 0.3749 239750.0n 0.4133 239999.9n 0.4133 240000.0n 0.7661 240249.9n 0.7661 240250.0n 0.4670 240499.9n 0.4670 240500.0n 0.4670 240749.9n 0.4670 240750.0n 0.4516 240999.9n 0.4516 241000.0n 0.4516 241249.9n 0.4516 241250.0n 0.7661 241499.9n 0.7661 241500.0n 0.5437 241749.9n 0.5437 241750.0n 0.7661 241999.9n 0.7661 242000.0n 0.3749 242249.9n 0.3749 242250.0n 0.3749 242499.9n 0.3749 242500.0n 0.4209 242749.9n 0.4209 242750.0n 0.4286 242999.9n 0.4286 243000.0n 0.7584 243249.9n 0.7584 243250.0n 0.4670 243499.9n 0.4670 243500.0n 0.5437 243749.9n 0.5437 243750.0n 0.3903 243999.9n 0.3903 244000.0n 0.7584 244249.9n 0.7584 244250.0n 0.4363 244499.9n 0.4363 244500.0n 0.5207 244749.9n 0.5207 244750.0n 0.4976 244999.9n 0.4976 245000.0n 0.4440 245249.9n 0.4440 245250.0n 0.6894 245499.9n 0.6894 245500.0n 0.4363 245749.9n 0.4363 245750.0n 0.5820 245999.9n 0.5820 246000.0n 0.7431 246249.9n 0.7431 246250.0n 0.3979 246499.9n 0.3979 246500.0n 0.6587 246749.9n 0.6587 246750.0n 0.4516 246999.9n 0.4516 247000.0n 0.3749 247249.9n 0.3749 247250.0n 0.4133 247499.9n 0.4133 247500.0n 0.7661 247749.9n 0.7661 247750.0n 0.4670 247999.9n 0.4670 248000.0n 0.4670 248249.9n 0.4670 248250.0n 0.4516 248499.9n 0.4516 248500.0n 0.4516 248749.9n 0.4516 248750.0n 0.7661 248999.9n 0.7661 249000.0n 0.5437 249249.9n 0.5437 249250.0n 0.7661 249499.9n 0.7661 249500.0n 0.3749 249749.9n 0.3749 249750.0n 0.3749 249999.9n 0.3749 250000.0n 0.4209 250249.9n 0.4209 250250.0n 0.4286 250499.9n 0.4286 250500.0n 0.7584 250749.9n 0.7584 250750.0n 0.4670 250999.9n 0.4670 251000.0n 0.5437 251249.9n 0.5437 251250.0n 0.3903 251499.9n 0.3903 251500.0n 0.7584 251749.9n 0.7584 251750.0n 0.4363 251999.9n 0.4363 252000.0n 0.5207 252249.9n 0.5207 252250.0n 0.4976 252499.9n 0.4976 252500.0n 0.4440 252749.9n 0.4440 252750.0n 0.6894 252999.9n 0.6894 253000.0n 0.4363 253249.9n 0.4363 253250.0n 0.5820 253499.9n 0.5820 253500.0n 0.7431 253749.9n 0.7431 253750.0n 0.3979 253999.9n 0.3979 254000.0n 0.6587 254249.9n 0.6587 254250.0n 0.4516 254499.9n 0.4516 254500.0n 0.3749 254749.9n 0.3749 254750.0n 0.4133 254999.9n 0.4133 255000.0n 0.7661 255249.9n 0.7661 255250.0n 0.4670 255499.9n 0.4670 255500.0n 0.4670 255749.9n 0.4670 255750.0n 0.4516 255999.9n 0.4516 256000.0n 0.4516 256249.9n 0.4516 256250.0n 0.7661 256499.9n 0.7661 256500.0n 0.5437 256749.9n 0.5437 256750.0n 0.7661 256999.9n 0.7661 257000.0n 0.3749 257249.9n 0.3749 257250.0n 0.3749 257499.9n 0.3749 257500.0n 0.4209 257749.9n 0.4209 257750.0n 0.4286 257999.9n 0.4286 258000.0n 0.7584 258249.9n 0.7584 258250.0n 0.4670 258499.9n 0.4670 258500.0n 0.5437 258749.9n 0.5437 258750.0n 0.3903 258999.9n 0.3903 259000.0n 0.7584 259249.9n 0.7584 259250.0n 0.4363 259499.9n 0.4363 259500.0n 0.5207 259749.9n 0.5207 259750.0n 0.4976 259999.9n 0.4976 260000.0n 0.4440 260249.9n 0.4440 260250.0n 0.6894 260499.9n 0.6894 260500.0n 0.4363 260749.9n 0.4363 260750.0n 0.5820 260999.9n 0.5820 261000.0n 0.7431 261249.9n 0.7431 261250.0n 0.3979 261499.9n 0.3979 261500.0n 0.6587 261749.9n 0.6587 261750.0n 0.4516 261999.9n 0.4516 262000.0n 0.3749 262249.9n 0.3749 262250.0n 0.4133 262499.9n 0.4133 262500.0n 0.7661 262749.9n 0.7661 262750.0n 0.4670 262999.9n 0.4670 263000.0n 0.4670 263249.9n 0.4670 263250.0n 0.4516 263499.9n 0.4516 263500.0n 0.4516 263749.9n 0.4516 263750.0n 0.7661 263999.9n 0.7661 264000.0n 0.5437 264249.9n 0.5437 264250.0n 0.7661 264499.9n 0.7661 264500.0n 0.3749 264749.9n 0.3749 264750.0n 0.3749 264999.9n 0.3749 265000.0n 0.4209 265249.9n 0.4209 265250.0n 0.4286 265499.9n 0.4286 265500.0n 0.7584 265749.9n 0.7584 265750.0n 0.4670 265999.9n 0.4670 266000.0n 0.5437 266249.9n 0.5437 266250.0n 0.3903 266499.9n 0.3903 266500.0n 0.7584 266749.9n 0.7584 266750.0n 0.4363 266999.9n 0.4363 267000.0n 0.5207 267249.9n 0.5207 267250.0n 0.4976 267499.9n 0.4976 267500.0n 0.4440 267749.9n 0.4440 267750.0n 0.6894 267999.9n 0.6894 268000.0n 0.4363 268249.9n 0.4363 268250.0n 0.5820 268499.9n 0.5820 268500.0n 0.7431 268749.9n 0.7431 268750.0n 0.3979 268999.9n 0.3979 269000.0n 0.6587 269249.9n 0.6587 269250.0n 0.4516 269499.9n 0.4516 269500.0n 0.3749 269749.9n 0.3749 269750.0n 0.4133 269999.9n 0.4133 270000.0n 0.7661 270249.9n 0.7661 270250.0n 0.4670 270499.9n 0.4670 270500.0n 0.4670 270749.9n 0.4670 270750.0n 0.4516 270999.9n 0.4516 271000.0n 0.4516 271249.9n 0.4516 271250.0n 0.7661 271499.9n 0.7661 271500.0n 0.5437 271749.9n 0.5437 271750.0n 0.7661 271999.9n 0.7661 272000.0n 0.3749 272249.9n 0.3749 272250.0n 0.3749 272499.9n 0.3749 272500.0n 0.4209 272749.9n 0.4209 272750.0n 0.4286 272999.9n 0.4286 273000.0n 0.7584 273249.9n 0.7584 273250.0n 0.4670 273499.9n 0.4670 273500.0n 0.5437 273749.9n 0.5437 273750.0n 0.3903 273999.9n 0.3903 274000.0n 0.7584 274249.9n 0.7584 274250.0n 0.4363 274499.9n 0.4363 274500.0n 0.5207 274749.9n 0.5207 274750.0n 0.4976 274999.9n 0.4976 275000.0n 0.4440 275249.9n 0.4440 275250.0n 0.6894 275499.9n 0.6894 275500.0n 0.4363 275749.9n 0.4363 275750.0n 0.5820 275999.9n 0.5820 276000.0n 0.7431 276249.9n 0.7431 276250.0n 0.3979 276499.9n 0.3979 276500.0n 0.6587 276749.9n 0.6587 276750.0n 0.4516 276999.9n 0.4516 277000.0n 0.3749 277249.9n 0.3749 277250.0n 0.4133 277499.9n 0.4133 277500.0n 0.7661 277749.9n 0.7661 277750.0n 0.4670 277999.9n 0.4670 278000.0n 0.4670 278249.9n 0.4670 278250.0n 0.4516 278499.9n 0.4516 278500.0n 0.4516 278749.9n 0.4516 278750.0n 0.7661 278999.9n 0.7661 279000.0n 0.5437 279249.9n 0.5437 279250.0n 0.7661 279499.9n 0.7661 279500.0n 0.3749 279749.9n 0.3749 279750.0n 0.3749 279999.9n 0.3749 280000.0n 0.4209 280249.9n 0.4209 280250.0n 0.4286 280499.9n 0.4286 280500.0n 0.7584 280749.9n 0.7584 280750.0n 0.4670 280999.9n 0.4670 281000.0n 0.5437 281249.9n 0.5437 281250.0n 0.3903 281499.9n 0.3903 281500.0n 0.7584 281749.9n 0.7584 281750.0n 0.4363 281999.9n 0.4363 282000.0n 0.5207 282249.9n 0.5207 282250.0n 0.4976 282499.9n 0.4976 282500.0n 0.4440 282749.9n 0.4440 282750.0n 0.6894 282999.9n 0.6894 283000.0n 0.4363 283249.9n 0.4363 283250.0n 0.5820 283499.9n 0.5820 283500.0n 0.7431 283749.9n 0.7431 283750.0n 0.3979 283999.9n 0.3979 284000.0n 0.6587 284249.9n 0.6587 284250.0n 0.4516 284499.9n 0.4516 284500.0n 0.3749 284749.9n 0.3749 284750.0n 0.4133 284999.9n 0.4133 285000.0n 0.7661 285249.9n 0.7661 285250.0n 0.4670 285499.9n 0.4670 285500.0n 0.4670 285749.9n 0.4670 285750.0n 0.4516 285999.9n 0.4516 286000.0n 0.4516 286249.9n 0.4516 286250.0n 0.7661 286499.9n 0.7661 286500.0n 0.5437 286749.9n 0.5437 286750.0n 0.7661 286999.9n 0.7661 287000.0n 0.3749 287249.9n 0.3749 287250.0n 0.3749 287499.9n 0.3749 287500.0n 0.4209 287749.9n 0.4209 287750.0n 0.4286 287999.9n 0.4286 288000.0n 0.7584 288249.9n 0.7584 288250.0n 0.4670 288499.9n 0.4670 288500.0n 0.5437 288749.9n 0.5437 288750.0n 0.3903 288999.9n 0.3903 289000.0n 0.7584 289249.9n 0.7584 289250.0n 0.4363 289499.9n 0.4363 289500.0n 0.5207 289749.9n 0.5207 289750.0n 0.4976 289999.9n 0.4976 290000.0n 0.4440 290249.9n 0.4440 290250.0n 0.6894 290499.9n 0.6894 290500.0n 0.4363 290749.9n 0.4363 290750.0n 0.5820 290999.9n 0.5820 291000.0n 0.7431 291249.9n 0.7431 291250.0n 0.3979 291499.9n 0.3979 291500.0n 0.6587 291749.9n 0.6587 291750.0n 0.4516 291999.9n 0.4516 292000.0n 0.3749 292249.9n 0.3749 292250.0n 0.4133 292499.9n 0.4133 292500.0n 0.7661 292749.9n 0.7661 292750.0n 0.4670 292999.9n 0.4670 293000.0n 0.4670 293249.9n 0.4670 293250.0n 0.4516 293499.9n 0.4516 293500.0n 0.4516 293749.9n 0.4516 293750.0n 0.7661 293999.9n 0.7661 294000.0n 0.5437 294249.9n 0.5437 294250.0n 0.7661 294499.9n 0.7661 294500.0n 0.3749 294749.9n 0.3749 294750.0n 0.3749 294999.9n 0.3749 295000.0n 0.4209 295249.9n 0.4209 295250.0n 0.4286 295499.9n 0.4286 295500.0n 0.7584 295749.9n 0.7584 295750.0n 0.4670 295999.9n 0.4670 296000.0n 0.5437 296249.9n 0.5437 296250.0n 0.3903 296499.9n 0.3903 296500.0n 0.7584 296749.9n 0.7584 296750.0n 0.4363 296999.9n 0.4363 297000.0n 0.5207 297249.9n 0.5207 297250.0n 0.4976 297499.9n 0.4976 297500.0n 0.4440 297749.9n 0.4440 297750.0n 0.6894 297999.9n 0.6894 298000.0n 0.4363 298249.9n 0.4363 298250.0n 0.5820 298499.9n 0.5820 298500.0n 0.7431 298749.9n 0.7431 298750.0n 0.3979 298999.9n 0.3979 299000.0n 0.6587 299249.9n 0.6587 299250.0n 0.4516 299499.9n 0.4516 299500.0n 0.3749 299749.9n 0.3749 299750.0n 0.4133)
Vxp14 a_xp14 0 PWL(0.0n 0.5357 249.9n 0.5357 250.0n 0.5289 499.9n 0.5289 500.0n 0.4813 749.9n 0.4813 750.0n 0.5085 999.9n 0.5085 1000.0n 0.5289 1249.9n 0.5289 1250.0n 0.6037 1499.9n 0.6037 1500.0n 0.5561 1749.9n 0.5561 1750.0n 0.5765 1999.9n 0.5765 2000.0n 0.4065 2249.9n 0.4065 2250.0n 0.6514 2499.9n 0.6514 2500.0n 0.6173 2749.9n 0.6173 2750.0n 0.5017 2999.9n 0.5017 3000.0n 0.6037 3249.9n 0.6037 3250.0n 0.6514 3499.9n 0.6514 3500.0n 0.4813 3749.9n 0.4813 3750.0n 0.6718 3999.9n 0.6718 4000.0n 0.5697 4249.9n 0.5697 4250.0n 0.5357 4499.9n 0.5357 4500.0n 0.5629 4749.9n 0.5629 4750.0n 0.5629 4999.9n 0.5629 5000.0n 0.5629 5249.9n 0.5629 5250.0n 0.5901 5499.9n 0.5901 5500.0n 0.5765 5749.9n 0.5765 5750.0n 0.3997 5999.9n 0.3997 6000.0n 0.6446 6249.9n 0.6446 6250.0n 0.5357 6499.9n 0.5357 6500.0n 0.5221 6749.9n 0.5221 6750.0n 0.5493 6999.9n 0.5493 7000.0n 0.6377 7249.9n 0.6377 7250.0n 0.6309 7499.9n 0.6309 7500.0n 0.5357 7749.9n 0.5357 7750.0n 0.5289 7999.9n 0.5289 8000.0n 0.4813 8249.9n 0.4813 8250.0n 0.5085 8499.9n 0.5085 8500.0n 0.5289 8749.9n 0.5289 8750.0n 0.6037 8999.9n 0.6037 9000.0n 0.5561 9249.9n 0.5561 9250.0n 0.5765 9499.9n 0.5765 9500.0n 0.4065 9749.9n 0.4065 9750.0n 0.6514 9999.9n 0.6514 10000.0n 0.6173 10249.9n 0.6173 10250.0n 0.5017 10499.9n 0.5017 10500.0n 0.6037 10749.9n 0.6037 10750.0n 0.6514 10999.9n 0.6514 11000.0n 0.4813 11249.9n 0.4813 11250.0n 0.6718 11499.9n 0.6718 11500.0n 0.5697 11749.9n 0.5697 11750.0n 0.5357 11999.9n 0.5357 12000.0n 0.5629 12249.9n 0.5629 12250.0n 0.5629 12499.9n 0.5629 12500.0n 0.5629 12749.9n 0.5629 12750.0n 0.5901 12999.9n 0.5901 13000.0n 0.5765 13249.9n 0.5765 13250.0n 0.3997 13499.9n 0.3997 13500.0n 0.6446 13749.9n 0.6446 13750.0n 0.5357 13999.9n 0.5357 14000.0n 0.5221 14249.9n 0.5221 14250.0n 0.5493 14499.9n 0.5493 14500.0n 0.6377 14749.9n 0.6377 14750.0n 0.6309 14999.9n 0.6309 15000.0n 0.5357 15249.9n 0.5357 15250.0n 0.5289 15499.9n 0.5289 15500.0n 0.4813 15749.9n 0.4813 15750.0n 0.5085 15999.9n 0.5085 16000.0n 0.5289 16249.9n 0.5289 16250.0n 0.6037 16499.9n 0.6037 16500.0n 0.5561 16749.9n 0.5561 16750.0n 0.5765 16999.9n 0.5765 17000.0n 0.4065 17249.9n 0.4065 17250.0n 0.6514 17499.9n 0.6514 17500.0n 0.6173 17749.9n 0.6173 17750.0n 0.5017 17999.9n 0.5017 18000.0n 0.6037 18249.9n 0.6037 18250.0n 0.6514 18499.9n 0.6514 18500.0n 0.4813 18749.9n 0.4813 18750.0n 0.6718 18999.9n 0.6718 19000.0n 0.5697 19249.9n 0.5697 19250.0n 0.5357 19499.9n 0.5357 19500.0n 0.5629 19749.9n 0.5629 19750.0n 0.5629 19999.9n 0.5629 20000.0n 0.5629 20249.9n 0.5629 20250.0n 0.5901 20499.9n 0.5901 20500.0n 0.5765 20749.9n 0.5765 20750.0n 0.3997 20999.9n 0.3997 21000.0n 0.6446 21249.9n 0.6446 21250.0n 0.5357 21499.9n 0.5357 21500.0n 0.5221 21749.9n 0.5221 21750.0n 0.5493 21999.9n 0.5493 22000.0n 0.6377 22249.9n 0.6377 22250.0n 0.6309 22499.9n 0.6309 22500.0n 0.5357 22749.9n 0.5357 22750.0n 0.5289 22999.9n 0.5289 23000.0n 0.4813 23249.9n 0.4813 23250.0n 0.5085 23499.9n 0.5085 23500.0n 0.5289 23749.9n 0.5289 23750.0n 0.6037 23999.9n 0.6037 24000.0n 0.5561 24249.9n 0.5561 24250.0n 0.5765 24499.9n 0.5765 24500.0n 0.4065 24749.9n 0.4065 24750.0n 0.6514 24999.9n 0.6514 25000.0n 0.6173 25249.9n 0.6173 25250.0n 0.5017 25499.9n 0.5017 25500.0n 0.6037 25749.9n 0.6037 25750.0n 0.6514 25999.9n 0.6514 26000.0n 0.4813 26249.9n 0.4813 26250.0n 0.6718 26499.9n 0.6718 26500.0n 0.5697 26749.9n 0.5697 26750.0n 0.5357 26999.9n 0.5357 27000.0n 0.5629 27249.9n 0.5629 27250.0n 0.5629 27499.9n 0.5629 27500.0n 0.5629 27749.9n 0.5629 27750.0n 0.5901 27999.9n 0.5901 28000.0n 0.5765 28249.9n 0.5765 28250.0n 0.3997 28499.9n 0.3997 28500.0n 0.6446 28749.9n 0.6446 28750.0n 0.5357 28999.9n 0.5357 29000.0n 0.5221 29249.9n 0.5221 29250.0n 0.5493 29499.9n 0.5493 29500.0n 0.6377 29749.9n 0.6377 29750.0n 0.6309 29999.9n 0.6309 30000.0n 0.5357 30249.9n 0.5357 30250.0n 0.5289 30499.9n 0.5289 30500.0n 0.4813 30749.9n 0.4813 30750.0n 0.5085 30999.9n 0.5085 31000.0n 0.5289 31249.9n 0.5289 31250.0n 0.6037 31499.9n 0.6037 31500.0n 0.5561 31749.9n 0.5561 31750.0n 0.5765 31999.9n 0.5765 32000.0n 0.4065 32249.9n 0.4065 32250.0n 0.6514 32499.9n 0.6514 32500.0n 0.6173 32749.9n 0.6173 32750.0n 0.5017 32999.9n 0.5017 33000.0n 0.6037 33249.9n 0.6037 33250.0n 0.6514 33499.9n 0.6514 33500.0n 0.4813 33749.9n 0.4813 33750.0n 0.6718 33999.9n 0.6718 34000.0n 0.5697 34249.9n 0.5697 34250.0n 0.5357 34499.9n 0.5357 34500.0n 0.5629 34749.9n 0.5629 34750.0n 0.5629 34999.9n 0.5629 35000.0n 0.5629 35249.9n 0.5629 35250.0n 0.5901 35499.9n 0.5901 35500.0n 0.5765 35749.9n 0.5765 35750.0n 0.3997 35999.9n 0.3997 36000.0n 0.6446 36249.9n 0.6446 36250.0n 0.5357 36499.9n 0.5357 36500.0n 0.5221 36749.9n 0.5221 36750.0n 0.5493 36999.9n 0.5493 37000.0n 0.6377 37249.9n 0.6377 37250.0n 0.6309 37499.9n 0.6309 37500.0n 0.5357 37749.9n 0.5357 37750.0n 0.5289 37999.9n 0.5289 38000.0n 0.4813 38249.9n 0.4813 38250.0n 0.5085 38499.9n 0.5085 38500.0n 0.5289 38749.9n 0.5289 38750.0n 0.6037 38999.9n 0.6037 39000.0n 0.5561 39249.9n 0.5561 39250.0n 0.5765 39499.9n 0.5765 39500.0n 0.4065 39749.9n 0.4065 39750.0n 0.6514 39999.9n 0.6514 40000.0n 0.6173 40249.9n 0.6173 40250.0n 0.5017 40499.9n 0.5017 40500.0n 0.6037 40749.9n 0.6037 40750.0n 0.6514 40999.9n 0.6514 41000.0n 0.4813 41249.9n 0.4813 41250.0n 0.6718 41499.9n 0.6718 41500.0n 0.5697 41749.9n 0.5697 41750.0n 0.5357 41999.9n 0.5357 42000.0n 0.5629 42249.9n 0.5629 42250.0n 0.5629 42499.9n 0.5629 42500.0n 0.5629 42749.9n 0.5629 42750.0n 0.5901 42999.9n 0.5901 43000.0n 0.5765 43249.9n 0.5765 43250.0n 0.3997 43499.9n 0.3997 43500.0n 0.6446 43749.9n 0.6446 43750.0n 0.5357 43999.9n 0.5357 44000.0n 0.5221 44249.9n 0.5221 44250.0n 0.5493 44499.9n 0.5493 44500.0n 0.6377 44749.9n 0.6377 44750.0n 0.6309 44999.9n 0.6309 45000.0n 0.5357 45249.9n 0.5357 45250.0n 0.5289 45499.9n 0.5289 45500.0n 0.4813 45749.9n 0.4813 45750.0n 0.5085 45999.9n 0.5085 46000.0n 0.5289 46249.9n 0.5289 46250.0n 0.6037 46499.9n 0.6037 46500.0n 0.5561 46749.9n 0.5561 46750.0n 0.5765 46999.9n 0.5765 47000.0n 0.4065 47249.9n 0.4065 47250.0n 0.6514 47499.9n 0.6514 47500.0n 0.6173 47749.9n 0.6173 47750.0n 0.5017 47999.9n 0.5017 48000.0n 0.6037 48249.9n 0.6037 48250.0n 0.6514 48499.9n 0.6514 48500.0n 0.4813 48749.9n 0.4813 48750.0n 0.6718 48999.9n 0.6718 49000.0n 0.5697 49249.9n 0.5697 49250.0n 0.5357 49499.9n 0.5357 49500.0n 0.5629 49749.9n 0.5629 49750.0n 0.5629 49999.9n 0.5629 50000.0n 0.5629 50249.9n 0.5629 50250.0n 0.5901 50499.9n 0.5901 50500.0n 0.5765 50749.9n 0.5765 50750.0n 0.3997 50999.9n 0.3997 51000.0n 0.6446 51249.9n 0.6446 51250.0n 0.5357 51499.9n 0.5357 51500.0n 0.5221 51749.9n 0.5221 51750.0n 0.5493 51999.9n 0.5493 52000.0n 0.6377 52249.9n 0.6377 52250.0n 0.6309 52499.9n 0.6309 52500.0n 0.5357 52749.9n 0.5357 52750.0n 0.5289 52999.9n 0.5289 53000.0n 0.4813 53249.9n 0.4813 53250.0n 0.5085 53499.9n 0.5085 53500.0n 0.5289 53749.9n 0.5289 53750.0n 0.6037 53999.9n 0.6037 54000.0n 0.5561 54249.9n 0.5561 54250.0n 0.5765 54499.9n 0.5765 54500.0n 0.4065 54749.9n 0.4065 54750.0n 0.6514 54999.9n 0.6514 55000.0n 0.6173 55249.9n 0.6173 55250.0n 0.5017 55499.9n 0.5017 55500.0n 0.6037 55749.9n 0.6037 55750.0n 0.6514 55999.9n 0.6514 56000.0n 0.4813 56249.9n 0.4813 56250.0n 0.6718 56499.9n 0.6718 56500.0n 0.5697 56749.9n 0.5697 56750.0n 0.5357 56999.9n 0.5357 57000.0n 0.5629 57249.9n 0.5629 57250.0n 0.5629 57499.9n 0.5629 57500.0n 0.5629 57749.9n 0.5629 57750.0n 0.5901 57999.9n 0.5901 58000.0n 0.5765 58249.9n 0.5765 58250.0n 0.3997 58499.9n 0.3997 58500.0n 0.6446 58749.9n 0.6446 58750.0n 0.5357 58999.9n 0.5357 59000.0n 0.5221 59249.9n 0.5221 59250.0n 0.5493 59499.9n 0.5493 59500.0n 0.6377 59749.9n 0.6377 59750.0n 0.6309 59999.9n 0.6309 60000.0n 0.5357 60249.9n 0.5357 60250.0n 0.5289 60499.9n 0.5289 60500.0n 0.4813 60749.9n 0.4813 60750.0n 0.5085 60999.9n 0.5085 61000.0n 0.5289 61249.9n 0.5289 61250.0n 0.6037 61499.9n 0.6037 61500.0n 0.5561 61749.9n 0.5561 61750.0n 0.5765 61999.9n 0.5765 62000.0n 0.4065 62249.9n 0.4065 62250.0n 0.6514 62499.9n 0.6514 62500.0n 0.6173 62749.9n 0.6173 62750.0n 0.5017 62999.9n 0.5017 63000.0n 0.6037 63249.9n 0.6037 63250.0n 0.6514 63499.9n 0.6514 63500.0n 0.4813 63749.9n 0.4813 63750.0n 0.6718 63999.9n 0.6718 64000.0n 0.5697 64249.9n 0.5697 64250.0n 0.5357 64499.9n 0.5357 64500.0n 0.5629 64749.9n 0.5629 64750.0n 0.5629 64999.9n 0.5629 65000.0n 0.5629 65249.9n 0.5629 65250.0n 0.5901 65499.9n 0.5901 65500.0n 0.5765 65749.9n 0.5765 65750.0n 0.3997 65999.9n 0.3997 66000.0n 0.6446 66249.9n 0.6446 66250.0n 0.5357 66499.9n 0.5357 66500.0n 0.5221 66749.9n 0.5221 66750.0n 0.5493 66999.9n 0.5493 67000.0n 0.6377 67249.9n 0.6377 67250.0n 0.6309 67499.9n 0.6309 67500.0n 0.5357 67749.9n 0.5357 67750.0n 0.5289 67999.9n 0.5289 68000.0n 0.4813 68249.9n 0.4813 68250.0n 0.5085 68499.9n 0.5085 68500.0n 0.5289 68749.9n 0.5289 68750.0n 0.6037 68999.9n 0.6037 69000.0n 0.5561 69249.9n 0.5561 69250.0n 0.5765 69499.9n 0.5765 69500.0n 0.4065 69749.9n 0.4065 69750.0n 0.6514 69999.9n 0.6514 70000.0n 0.6173 70249.9n 0.6173 70250.0n 0.5017 70499.9n 0.5017 70500.0n 0.6037 70749.9n 0.6037 70750.0n 0.6514 70999.9n 0.6514 71000.0n 0.4813 71249.9n 0.4813 71250.0n 0.6718 71499.9n 0.6718 71500.0n 0.5697 71749.9n 0.5697 71750.0n 0.5357 71999.9n 0.5357 72000.0n 0.5629 72249.9n 0.5629 72250.0n 0.5629 72499.9n 0.5629 72500.0n 0.5629 72749.9n 0.5629 72750.0n 0.5901 72999.9n 0.5901 73000.0n 0.5765 73249.9n 0.5765 73250.0n 0.3997 73499.9n 0.3997 73500.0n 0.6446 73749.9n 0.6446 73750.0n 0.5357 73999.9n 0.5357 74000.0n 0.5221 74249.9n 0.5221 74250.0n 0.5493 74499.9n 0.5493 74500.0n 0.6377 74749.9n 0.6377 74750.0n 0.6309 74999.9n 0.6309 75000.0n 0.5357 75249.9n 0.5357 75250.0n 0.5289 75499.9n 0.5289 75500.0n 0.4813 75749.9n 0.4813 75750.0n 0.5085 75999.9n 0.5085 76000.0n 0.5289 76249.9n 0.5289 76250.0n 0.6037 76499.9n 0.6037 76500.0n 0.5561 76749.9n 0.5561 76750.0n 0.5765 76999.9n 0.5765 77000.0n 0.4065 77249.9n 0.4065 77250.0n 0.6514 77499.9n 0.6514 77500.0n 0.6173 77749.9n 0.6173 77750.0n 0.5017 77999.9n 0.5017 78000.0n 0.6037 78249.9n 0.6037 78250.0n 0.6514 78499.9n 0.6514 78500.0n 0.4813 78749.9n 0.4813 78750.0n 0.6718 78999.9n 0.6718 79000.0n 0.5697 79249.9n 0.5697 79250.0n 0.5357 79499.9n 0.5357 79500.0n 0.5629 79749.9n 0.5629 79750.0n 0.5629 79999.9n 0.5629 80000.0n 0.5629 80249.9n 0.5629 80250.0n 0.5901 80499.9n 0.5901 80500.0n 0.5765 80749.9n 0.5765 80750.0n 0.3997 80999.9n 0.3997 81000.0n 0.6446 81249.9n 0.6446 81250.0n 0.5357 81499.9n 0.5357 81500.0n 0.5221 81749.9n 0.5221 81750.0n 0.5493 81999.9n 0.5493 82000.0n 0.6377 82249.9n 0.6377 82250.0n 0.6309 82499.9n 0.6309 82500.0n 0.5357 82749.9n 0.5357 82750.0n 0.5289 82999.9n 0.5289 83000.0n 0.4813 83249.9n 0.4813 83250.0n 0.5085 83499.9n 0.5085 83500.0n 0.5289 83749.9n 0.5289 83750.0n 0.6037 83999.9n 0.6037 84000.0n 0.5561 84249.9n 0.5561 84250.0n 0.5765 84499.9n 0.5765 84500.0n 0.4065 84749.9n 0.4065 84750.0n 0.6514 84999.9n 0.6514 85000.0n 0.6173 85249.9n 0.6173 85250.0n 0.5017 85499.9n 0.5017 85500.0n 0.6037 85749.9n 0.6037 85750.0n 0.6514 85999.9n 0.6514 86000.0n 0.4813 86249.9n 0.4813 86250.0n 0.6718 86499.9n 0.6718 86500.0n 0.5697 86749.9n 0.5697 86750.0n 0.5357 86999.9n 0.5357 87000.0n 0.5629 87249.9n 0.5629 87250.0n 0.5629 87499.9n 0.5629 87500.0n 0.5629 87749.9n 0.5629 87750.0n 0.5901 87999.9n 0.5901 88000.0n 0.5765 88249.9n 0.5765 88250.0n 0.3997 88499.9n 0.3997 88500.0n 0.6446 88749.9n 0.6446 88750.0n 0.5357 88999.9n 0.5357 89000.0n 0.5221 89249.9n 0.5221 89250.0n 0.5493 89499.9n 0.5493 89500.0n 0.6377 89749.9n 0.6377 89750.0n 0.6309 89999.9n 0.6309 90000.0n 0.5357 90249.9n 0.5357 90250.0n 0.5289 90499.9n 0.5289 90500.0n 0.4813 90749.9n 0.4813 90750.0n 0.5085 90999.9n 0.5085 91000.0n 0.5289 91249.9n 0.5289 91250.0n 0.6037 91499.9n 0.6037 91500.0n 0.5561 91749.9n 0.5561 91750.0n 0.5765 91999.9n 0.5765 92000.0n 0.4065 92249.9n 0.4065 92250.0n 0.6514 92499.9n 0.6514 92500.0n 0.6173 92749.9n 0.6173 92750.0n 0.5017 92999.9n 0.5017 93000.0n 0.6037 93249.9n 0.6037 93250.0n 0.6514 93499.9n 0.6514 93500.0n 0.4813 93749.9n 0.4813 93750.0n 0.6718 93999.9n 0.6718 94000.0n 0.5697 94249.9n 0.5697 94250.0n 0.5357 94499.9n 0.5357 94500.0n 0.5629 94749.9n 0.5629 94750.0n 0.5629 94999.9n 0.5629 95000.0n 0.5629 95249.9n 0.5629 95250.0n 0.5901 95499.9n 0.5901 95500.0n 0.5765 95749.9n 0.5765 95750.0n 0.3997 95999.9n 0.3997 96000.0n 0.6446 96249.9n 0.6446 96250.0n 0.5357 96499.9n 0.5357 96500.0n 0.5221 96749.9n 0.5221 96750.0n 0.5493 96999.9n 0.5493 97000.0n 0.6377 97249.9n 0.6377 97250.0n 0.6309 97499.9n 0.6309 97500.0n 0.5357 97749.9n 0.5357 97750.0n 0.5289 97999.9n 0.5289 98000.0n 0.4813 98249.9n 0.4813 98250.0n 0.5085 98499.9n 0.5085 98500.0n 0.5289 98749.9n 0.5289 98750.0n 0.6037 98999.9n 0.6037 99000.0n 0.5561 99249.9n 0.5561 99250.0n 0.5765 99499.9n 0.5765 99500.0n 0.4065 99749.9n 0.4065 99750.0n 0.6514 99999.9n 0.6514 100000.0n 0.6173 100249.9n 0.6173 100250.0n 0.5017 100499.9n 0.5017 100500.0n 0.6037 100749.9n 0.6037 100750.0n 0.6514 100999.9n 0.6514 101000.0n 0.4813 101249.9n 0.4813 101250.0n 0.6718 101499.9n 0.6718 101500.0n 0.5697 101749.9n 0.5697 101750.0n 0.5357 101999.9n 0.5357 102000.0n 0.5629 102249.9n 0.5629 102250.0n 0.5629 102499.9n 0.5629 102500.0n 0.5629 102749.9n 0.5629 102750.0n 0.5901 102999.9n 0.5901 103000.0n 0.5765 103249.9n 0.5765 103250.0n 0.3997 103499.9n 0.3997 103500.0n 0.6446 103749.9n 0.6446 103750.0n 0.5357 103999.9n 0.5357 104000.0n 0.5221 104249.9n 0.5221 104250.0n 0.5493 104499.9n 0.5493 104500.0n 0.6377 104749.9n 0.6377 104750.0n 0.6309 104999.9n 0.6309 105000.0n 0.5357 105249.9n 0.5357 105250.0n 0.5289 105499.9n 0.5289 105500.0n 0.4813 105749.9n 0.4813 105750.0n 0.5085 105999.9n 0.5085 106000.0n 0.5289 106249.9n 0.5289 106250.0n 0.6037 106499.9n 0.6037 106500.0n 0.5561 106749.9n 0.5561 106750.0n 0.5765 106999.9n 0.5765 107000.0n 0.4065 107249.9n 0.4065 107250.0n 0.6514 107499.9n 0.6514 107500.0n 0.6173 107749.9n 0.6173 107750.0n 0.5017 107999.9n 0.5017 108000.0n 0.6037 108249.9n 0.6037 108250.0n 0.6514 108499.9n 0.6514 108500.0n 0.4813 108749.9n 0.4813 108750.0n 0.6718 108999.9n 0.6718 109000.0n 0.5697 109249.9n 0.5697 109250.0n 0.5357 109499.9n 0.5357 109500.0n 0.5629 109749.9n 0.5629 109750.0n 0.5629 109999.9n 0.5629 110000.0n 0.5629 110249.9n 0.5629 110250.0n 0.5901 110499.9n 0.5901 110500.0n 0.5765 110749.9n 0.5765 110750.0n 0.3997 110999.9n 0.3997 111000.0n 0.6446 111249.9n 0.6446 111250.0n 0.5357 111499.9n 0.5357 111500.0n 0.5221 111749.9n 0.5221 111750.0n 0.5493 111999.9n 0.5493 112000.0n 0.6377 112249.9n 0.6377 112250.0n 0.6309 112499.9n 0.6309 112500.0n 0.5357 112749.9n 0.5357 112750.0n 0.5289 112999.9n 0.5289 113000.0n 0.4813 113249.9n 0.4813 113250.0n 0.5085 113499.9n 0.5085 113500.0n 0.5289 113749.9n 0.5289 113750.0n 0.6037 113999.9n 0.6037 114000.0n 0.5561 114249.9n 0.5561 114250.0n 0.5765 114499.9n 0.5765 114500.0n 0.4065 114749.9n 0.4065 114750.0n 0.6514 114999.9n 0.6514 115000.0n 0.6173 115249.9n 0.6173 115250.0n 0.5017 115499.9n 0.5017 115500.0n 0.6037 115749.9n 0.6037 115750.0n 0.6514 115999.9n 0.6514 116000.0n 0.4813 116249.9n 0.4813 116250.0n 0.6718 116499.9n 0.6718 116500.0n 0.5697 116749.9n 0.5697 116750.0n 0.5357 116999.9n 0.5357 117000.0n 0.5629 117249.9n 0.5629 117250.0n 0.5629 117499.9n 0.5629 117500.0n 0.5629 117749.9n 0.5629 117750.0n 0.5901 117999.9n 0.5901 118000.0n 0.5765 118249.9n 0.5765 118250.0n 0.3997 118499.9n 0.3997 118500.0n 0.6446 118749.9n 0.6446 118750.0n 0.5357 118999.9n 0.5357 119000.0n 0.5221 119249.9n 0.5221 119250.0n 0.5493 119499.9n 0.5493 119500.0n 0.6377 119749.9n 0.6377 119750.0n 0.6309 119999.9n 0.6309 120000.0n 0.5357 120249.9n 0.5357 120250.0n 0.5289 120499.9n 0.5289 120500.0n 0.4813 120749.9n 0.4813 120750.0n 0.5085 120999.9n 0.5085 121000.0n 0.5289 121249.9n 0.5289 121250.0n 0.6037 121499.9n 0.6037 121500.0n 0.5561 121749.9n 0.5561 121750.0n 0.5765 121999.9n 0.5765 122000.0n 0.4065 122249.9n 0.4065 122250.0n 0.6514 122499.9n 0.6514 122500.0n 0.6173 122749.9n 0.6173 122750.0n 0.5017 122999.9n 0.5017 123000.0n 0.6037 123249.9n 0.6037 123250.0n 0.6514 123499.9n 0.6514 123500.0n 0.4813 123749.9n 0.4813 123750.0n 0.6718 123999.9n 0.6718 124000.0n 0.5697 124249.9n 0.5697 124250.0n 0.5357 124499.9n 0.5357 124500.0n 0.5629 124749.9n 0.5629 124750.0n 0.5629 124999.9n 0.5629 125000.0n 0.5629 125249.9n 0.5629 125250.0n 0.5901 125499.9n 0.5901 125500.0n 0.5765 125749.9n 0.5765 125750.0n 0.3997 125999.9n 0.3997 126000.0n 0.6446 126249.9n 0.6446 126250.0n 0.5357 126499.9n 0.5357 126500.0n 0.5221 126749.9n 0.5221 126750.0n 0.5493 126999.9n 0.5493 127000.0n 0.6377 127249.9n 0.6377 127250.0n 0.6309 127499.9n 0.6309 127500.0n 0.5357 127749.9n 0.5357 127750.0n 0.5289 127999.9n 0.5289 128000.0n 0.4813 128249.9n 0.4813 128250.0n 0.5085 128499.9n 0.5085 128500.0n 0.5289 128749.9n 0.5289 128750.0n 0.6037 128999.9n 0.6037 129000.0n 0.5561 129249.9n 0.5561 129250.0n 0.5765 129499.9n 0.5765 129500.0n 0.4065 129749.9n 0.4065 129750.0n 0.6514 129999.9n 0.6514 130000.0n 0.6173 130249.9n 0.6173 130250.0n 0.5017 130499.9n 0.5017 130500.0n 0.6037 130749.9n 0.6037 130750.0n 0.6514 130999.9n 0.6514 131000.0n 0.4813 131249.9n 0.4813 131250.0n 0.6718 131499.9n 0.6718 131500.0n 0.5697 131749.9n 0.5697 131750.0n 0.5357 131999.9n 0.5357 132000.0n 0.5629 132249.9n 0.5629 132250.0n 0.5629 132499.9n 0.5629 132500.0n 0.5629 132749.9n 0.5629 132750.0n 0.5901 132999.9n 0.5901 133000.0n 0.5765 133249.9n 0.5765 133250.0n 0.3997 133499.9n 0.3997 133500.0n 0.6446 133749.9n 0.6446 133750.0n 0.5357 133999.9n 0.5357 134000.0n 0.5221 134249.9n 0.5221 134250.0n 0.5493 134499.9n 0.5493 134500.0n 0.6377 134749.9n 0.6377 134750.0n 0.6309 134999.9n 0.6309 135000.0n 0.5357 135249.9n 0.5357 135250.0n 0.5289 135499.9n 0.5289 135500.0n 0.4813 135749.9n 0.4813 135750.0n 0.5085 135999.9n 0.5085 136000.0n 0.5289 136249.9n 0.5289 136250.0n 0.6037 136499.9n 0.6037 136500.0n 0.5561 136749.9n 0.5561 136750.0n 0.5765 136999.9n 0.5765 137000.0n 0.4065 137249.9n 0.4065 137250.0n 0.6514 137499.9n 0.6514 137500.0n 0.6173 137749.9n 0.6173 137750.0n 0.5017 137999.9n 0.5017 138000.0n 0.6037 138249.9n 0.6037 138250.0n 0.6514 138499.9n 0.6514 138500.0n 0.4813 138749.9n 0.4813 138750.0n 0.6718 138999.9n 0.6718 139000.0n 0.5697 139249.9n 0.5697 139250.0n 0.5357 139499.9n 0.5357 139500.0n 0.5629 139749.9n 0.5629 139750.0n 0.5629 139999.9n 0.5629 140000.0n 0.5629 140249.9n 0.5629 140250.0n 0.5901 140499.9n 0.5901 140500.0n 0.5765 140749.9n 0.5765 140750.0n 0.3997 140999.9n 0.3997 141000.0n 0.6446 141249.9n 0.6446 141250.0n 0.5357 141499.9n 0.5357 141500.0n 0.5221 141749.9n 0.5221 141750.0n 0.5493 141999.9n 0.5493 142000.0n 0.6377 142249.9n 0.6377 142250.0n 0.6309 142499.9n 0.6309 142500.0n 0.5357 142749.9n 0.5357 142750.0n 0.5289 142999.9n 0.5289 143000.0n 0.4813 143249.9n 0.4813 143250.0n 0.5085 143499.9n 0.5085 143500.0n 0.5289 143749.9n 0.5289 143750.0n 0.6037 143999.9n 0.6037 144000.0n 0.5561 144249.9n 0.5561 144250.0n 0.5765 144499.9n 0.5765 144500.0n 0.4065 144749.9n 0.4065 144750.0n 0.6514 144999.9n 0.6514 145000.0n 0.6173 145249.9n 0.6173 145250.0n 0.5017 145499.9n 0.5017 145500.0n 0.6037 145749.9n 0.6037 145750.0n 0.6514 145999.9n 0.6514 146000.0n 0.4813 146249.9n 0.4813 146250.0n 0.6718 146499.9n 0.6718 146500.0n 0.5697 146749.9n 0.5697 146750.0n 0.5357 146999.9n 0.5357 147000.0n 0.5629 147249.9n 0.5629 147250.0n 0.5629 147499.9n 0.5629 147500.0n 0.5629 147749.9n 0.5629 147750.0n 0.5901 147999.9n 0.5901 148000.0n 0.5765 148249.9n 0.5765 148250.0n 0.3997 148499.9n 0.3997 148500.0n 0.6446 148749.9n 0.6446 148750.0n 0.5357 148999.9n 0.5357 149000.0n 0.5221 149249.9n 0.5221 149250.0n 0.5493 149499.9n 0.5493 149500.0n 0.6377 149749.9n 0.6377 149750.0n 0.6309 149999.9n 0.6309 150000.0n 0.5357 150249.9n 0.5357 150250.0n 0.5289 150499.9n 0.5289 150500.0n 0.4813 150749.9n 0.4813 150750.0n 0.5085 150999.9n 0.5085 151000.0n 0.5289 151249.9n 0.5289 151250.0n 0.6037 151499.9n 0.6037 151500.0n 0.5561 151749.9n 0.5561 151750.0n 0.5765 151999.9n 0.5765 152000.0n 0.4065 152249.9n 0.4065 152250.0n 0.6514 152499.9n 0.6514 152500.0n 0.6173 152749.9n 0.6173 152750.0n 0.5017 152999.9n 0.5017 153000.0n 0.6037 153249.9n 0.6037 153250.0n 0.6514 153499.9n 0.6514 153500.0n 0.4813 153749.9n 0.4813 153750.0n 0.6718 153999.9n 0.6718 154000.0n 0.5697 154249.9n 0.5697 154250.0n 0.5357 154499.9n 0.5357 154500.0n 0.5629 154749.9n 0.5629 154750.0n 0.5629 154999.9n 0.5629 155000.0n 0.5629 155249.9n 0.5629 155250.0n 0.5901 155499.9n 0.5901 155500.0n 0.5765 155749.9n 0.5765 155750.0n 0.3997 155999.9n 0.3997 156000.0n 0.6446 156249.9n 0.6446 156250.0n 0.5357 156499.9n 0.5357 156500.0n 0.5221 156749.9n 0.5221 156750.0n 0.5493 156999.9n 0.5493 157000.0n 0.6377 157249.9n 0.6377 157250.0n 0.6309 157499.9n 0.6309 157500.0n 0.5357 157749.9n 0.5357 157750.0n 0.5289 157999.9n 0.5289 158000.0n 0.4813 158249.9n 0.4813 158250.0n 0.5085 158499.9n 0.5085 158500.0n 0.5289 158749.9n 0.5289 158750.0n 0.6037 158999.9n 0.6037 159000.0n 0.5561 159249.9n 0.5561 159250.0n 0.5765 159499.9n 0.5765 159500.0n 0.4065 159749.9n 0.4065 159750.0n 0.6514 159999.9n 0.6514 160000.0n 0.6173 160249.9n 0.6173 160250.0n 0.5017 160499.9n 0.5017 160500.0n 0.6037 160749.9n 0.6037 160750.0n 0.6514 160999.9n 0.6514 161000.0n 0.4813 161249.9n 0.4813 161250.0n 0.6718 161499.9n 0.6718 161500.0n 0.5697 161749.9n 0.5697 161750.0n 0.5357 161999.9n 0.5357 162000.0n 0.5629 162249.9n 0.5629 162250.0n 0.5629 162499.9n 0.5629 162500.0n 0.5629 162749.9n 0.5629 162750.0n 0.5901 162999.9n 0.5901 163000.0n 0.5765 163249.9n 0.5765 163250.0n 0.3997 163499.9n 0.3997 163500.0n 0.6446 163749.9n 0.6446 163750.0n 0.5357 163999.9n 0.5357 164000.0n 0.5221 164249.9n 0.5221 164250.0n 0.5493 164499.9n 0.5493 164500.0n 0.6377 164749.9n 0.6377 164750.0n 0.6309 164999.9n 0.6309 165000.0n 0.5357 165249.9n 0.5357 165250.0n 0.5289 165499.9n 0.5289 165500.0n 0.4813 165749.9n 0.4813 165750.0n 0.5085 165999.9n 0.5085 166000.0n 0.5289 166249.9n 0.5289 166250.0n 0.6037 166499.9n 0.6037 166500.0n 0.5561 166749.9n 0.5561 166750.0n 0.5765 166999.9n 0.5765 167000.0n 0.4065 167249.9n 0.4065 167250.0n 0.6514 167499.9n 0.6514 167500.0n 0.6173 167749.9n 0.6173 167750.0n 0.5017 167999.9n 0.5017 168000.0n 0.6037 168249.9n 0.6037 168250.0n 0.6514 168499.9n 0.6514 168500.0n 0.4813 168749.9n 0.4813 168750.0n 0.6718 168999.9n 0.6718 169000.0n 0.5697 169249.9n 0.5697 169250.0n 0.5357 169499.9n 0.5357 169500.0n 0.5629 169749.9n 0.5629 169750.0n 0.5629 169999.9n 0.5629 170000.0n 0.5629 170249.9n 0.5629 170250.0n 0.5901 170499.9n 0.5901 170500.0n 0.5765 170749.9n 0.5765 170750.0n 0.3997 170999.9n 0.3997 171000.0n 0.6446 171249.9n 0.6446 171250.0n 0.5357 171499.9n 0.5357 171500.0n 0.5221 171749.9n 0.5221 171750.0n 0.5493 171999.9n 0.5493 172000.0n 0.6377 172249.9n 0.6377 172250.0n 0.6309 172499.9n 0.6309 172500.0n 0.5357 172749.9n 0.5357 172750.0n 0.5289 172999.9n 0.5289 173000.0n 0.4813 173249.9n 0.4813 173250.0n 0.5085 173499.9n 0.5085 173500.0n 0.5289 173749.9n 0.5289 173750.0n 0.6037 173999.9n 0.6037 174000.0n 0.5561 174249.9n 0.5561 174250.0n 0.5765 174499.9n 0.5765 174500.0n 0.4065 174749.9n 0.4065 174750.0n 0.6514 174999.9n 0.6514 175000.0n 0.6173 175249.9n 0.6173 175250.0n 0.5017 175499.9n 0.5017 175500.0n 0.6037 175749.9n 0.6037 175750.0n 0.6514 175999.9n 0.6514 176000.0n 0.4813 176249.9n 0.4813 176250.0n 0.6718 176499.9n 0.6718 176500.0n 0.5697 176749.9n 0.5697 176750.0n 0.5357 176999.9n 0.5357 177000.0n 0.5629 177249.9n 0.5629 177250.0n 0.5629 177499.9n 0.5629 177500.0n 0.5629 177749.9n 0.5629 177750.0n 0.5901 177999.9n 0.5901 178000.0n 0.5765 178249.9n 0.5765 178250.0n 0.3997 178499.9n 0.3997 178500.0n 0.6446 178749.9n 0.6446 178750.0n 0.5357 178999.9n 0.5357 179000.0n 0.5221 179249.9n 0.5221 179250.0n 0.5493 179499.9n 0.5493 179500.0n 0.6377 179749.9n 0.6377 179750.0n 0.6309 179999.9n 0.6309 180000.0n 0.5357 180249.9n 0.5357 180250.0n 0.5289 180499.9n 0.5289 180500.0n 0.4813 180749.9n 0.4813 180750.0n 0.5085 180999.9n 0.5085 181000.0n 0.5289 181249.9n 0.5289 181250.0n 0.6037 181499.9n 0.6037 181500.0n 0.5561 181749.9n 0.5561 181750.0n 0.5765 181999.9n 0.5765 182000.0n 0.4065 182249.9n 0.4065 182250.0n 0.6514 182499.9n 0.6514 182500.0n 0.6173 182749.9n 0.6173 182750.0n 0.5017 182999.9n 0.5017 183000.0n 0.6037 183249.9n 0.6037 183250.0n 0.6514 183499.9n 0.6514 183500.0n 0.4813 183749.9n 0.4813 183750.0n 0.6718 183999.9n 0.6718 184000.0n 0.5697 184249.9n 0.5697 184250.0n 0.5357 184499.9n 0.5357 184500.0n 0.5629 184749.9n 0.5629 184750.0n 0.5629 184999.9n 0.5629 185000.0n 0.5629 185249.9n 0.5629 185250.0n 0.5901 185499.9n 0.5901 185500.0n 0.5765 185749.9n 0.5765 185750.0n 0.3997 185999.9n 0.3997 186000.0n 0.6446 186249.9n 0.6446 186250.0n 0.5357 186499.9n 0.5357 186500.0n 0.5221 186749.9n 0.5221 186750.0n 0.5493 186999.9n 0.5493 187000.0n 0.6377 187249.9n 0.6377 187250.0n 0.6309 187499.9n 0.6309 187500.0n 0.5357 187749.9n 0.5357 187750.0n 0.5289 187999.9n 0.5289 188000.0n 0.4813 188249.9n 0.4813 188250.0n 0.5085 188499.9n 0.5085 188500.0n 0.5289 188749.9n 0.5289 188750.0n 0.6037 188999.9n 0.6037 189000.0n 0.5561 189249.9n 0.5561 189250.0n 0.5765 189499.9n 0.5765 189500.0n 0.4065 189749.9n 0.4065 189750.0n 0.6514 189999.9n 0.6514 190000.0n 0.6173 190249.9n 0.6173 190250.0n 0.5017 190499.9n 0.5017 190500.0n 0.6037 190749.9n 0.6037 190750.0n 0.6514 190999.9n 0.6514 191000.0n 0.4813 191249.9n 0.4813 191250.0n 0.6718 191499.9n 0.6718 191500.0n 0.5697 191749.9n 0.5697 191750.0n 0.5357 191999.9n 0.5357 192000.0n 0.5629 192249.9n 0.5629 192250.0n 0.5629 192499.9n 0.5629 192500.0n 0.5629 192749.9n 0.5629 192750.0n 0.5901 192999.9n 0.5901 193000.0n 0.5765 193249.9n 0.5765 193250.0n 0.3997 193499.9n 0.3997 193500.0n 0.6446 193749.9n 0.6446 193750.0n 0.5357 193999.9n 0.5357 194000.0n 0.5221 194249.9n 0.5221 194250.0n 0.5493 194499.9n 0.5493 194500.0n 0.6377 194749.9n 0.6377 194750.0n 0.6309 194999.9n 0.6309 195000.0n 0.5357 195249.9n 0.5357 195250.0n 0.5289 195499.9n 0.5289 195500.0n 0.4813 195749.9n 0.4813 195750.0n 0.5085 195999.9n 0.5085 196000.0n 0.5289 196249.9n 0.5289 196250.0n 0.6037 196499.9n 0.6037 196500.0n 0.5561 196749.9n 0.5561 196750.0n 0.5765 196999.9n 0.5765 197000.0n 0.4065 197249.9n 0.4065 197250.0n 0.6514 197499.9n 0.6514 197500.0n 0.6173 197749.9n 0.6173 197750.0n 0.5017 197999.9n 0.5017 198000.0n 0.6037 198249.9n 0.6037 198250.0n 0.6514 198499.9n 0.6514 198500.0n 0.4813 198749.9n 0.4813 198750.0n 0.6718 198999.9n 0.6718 199000.0n 0.5697 199249.9n 0.5697 199250.0n 0.5357 199499.9n 0.5357 199500.0n 0.5629 199749.9n 0.5629 199750.0n 0.5629 199999.9n 0.5629 200000.0n 0.5629 200249.9n 0.5629 200250.0n 0.5901 200499.9n 0.5901 200500.0n 0.5765 200749.9n 0.5765 200750.0n 0.3997 200999.9n 0.3997 201000.0n 0.6446 201249.9n 0.6446 201250.0n 0.5357 201499.9n 0.5357 201500.0n 0.5221 201749.9n 0.5221 201750.0n 0.5493 201999.9n 0.5493 202000.0n 0.6377 202249.9n 0.6377 202250.0n 0.6309 202499.9n 0.6309 202500.0n 0.5357 202749.9n 0.5357 202750.0n 0.5289 202999.9n 0.5289 203000.0n 0.4813 203249.9n 0.4813 203250.0n 0.5085 203499.9n 0.5085 203500.0n 0.5289 203749.9n 0.5289 203750.0n 0.6037 203999.9n 0.6037 204000.0n 0.5561 204249.9n 0.5561 204250.0n 0.5765 204499.9n 0.5765 204500.0n 0.4065 204749.9n 0.4065 204750.0n 0.6514 204999.9n 0.6514 205000.0n 0.6173 205249.9n 0.6173 205250.0n 0.5017 205499.9n 0.5017 205500.0n 0.6037 205749.9n 0.6037 205750.0n 0.6514 205999.9n 0.6514 206000.0n 0.4813 206249.9n 0.4813 206250.0n 0.6718 206499.9n 0.6718 206500.0n 0.5697 206749.9n 0.5697 206750.0n 0.5357 206999.9n 0.5357 207000.0n 0.5629 207249.9n 0.5629 207250.0n 0.5629 207499.9n 0.5629 207500.0n 0.5629 207749.9n 0.5629 207750.0n 0.5901 207999.9n 0.5901 208000.0n 0.5765 208249.9n 0.5765 208250.0n 0.3997 208499.9n 0.3997 208500.0n 0.6446 208749.9n 0.6446 208750.0n 0.5357 208999.9n 0.5357 209000.0n 0.5221 209249.9n 0.5221 209250.0n 0.5493 209499.9n 0.5493 209500.0n 0.6377 209749.9n 0.6377 209750.0n 0.6309 209999.9n 0.6309 210000.0n 0.5357 210249.9n 0.5357 210250.0n 0.5289 210499.9n 0.5289 210500.0n 0.4813 210749.9n 0.4813 210750.0n 0.5085 210999.9n 0.5085 211000.0n 0.5289 211249.9n 0.5289 211250.0n 0.6037 211499.9n 0.6037 211500.0n 0.5561 211749.9n 0.5561 211750.0n 0.5765 211999.9n 0.5765 212000.0n 0.4065 212249.9n 0.4065 212250.0n 0.6514 212499.9n 0.6514 212500.0n 0.6173 212749.9n 0.6173 212750.0n 0.5017 212999.9n 0.5017 213000.0n 0.6037 213249.9n 0.6037 213250.0n 0.6514 213499.9n 0.6514 213500.0n 0.4813 213749.9n 0.4813 213750.0n 0.6718 213999.9n 0.6718 214000.0n 0.5697 214249.9n 0.5697 214250.0n 0.5357 214499.9n 0.5357 214500.0n 0.5629 214749.9n 0.5629 214750.0n 0.5629 214999.9n 0.5629 215000.0n 0.5629 215249.9n 0.5629 215250.0n 0.5901 215499.9n 0.5901 215500.0n 0.5765 215749.9n 0.5765 215750.0n 0.3997 215999.9n 0.3997 216000.0n 0.6446 216249.9n 0.6446 216250.0n 0.5357 216499.9n 0.5357 216500.0n 0.5221 216749.9n 0.5221 216750.0n 0.5493 216999.9n 0.5493 217000.0n 0.6377 217249.9n 0.6377 217250.0n 0.6309 217499.9n 0.6309 217500.0n 0.5357 217749.9n 0.5357 217750.0n 0.5289 217999.9n 0.5289 218000.0n 0.4813 218249.9n 0.4813 218250.0n 0.5085 218499.9n 0.5085 218500.0n 0.5289 218749.9n 0.5289 218750.0n 0.6037 218999.9n 0.6037 219000.0n 0.5561 219249.9n 0.5561 219250.0n 0.5765 219499.9n 0.5765 219500.0n 0.4065 219749.9n 0.4065 219750.0n 0.6514 219999.9n 0.6514 220000.0n 0.6173 220249.9n 0.6173 220250.0n 0.5017 220499.9n 0.5017 220500.0n 0.6037 220749.9n 0.6037 220750.0n 0.6514 220999.9n 0.6514 221000.0n 0.4813 221249.9n 0.4813 221250.0n 0.6718 221499.9n 0.6718 221500.0n 0.5697 221749.9n 0.5697 221750.0n 0.5357 221999.9n 0.5357 222000.0n 0.5629 222249.9n 0.5629 222250.0n 0.5629 222499.9n 0.5629 222500.0n 0.5629 222749.9n 0.5629 222750.0n 0.5901 222999.9n 0.5901 223000.0n 0.5765 223249.9n 0.5765 223250.0n 0.3997 223499.9n 0.3997 223500.0n 0.6446 223749.9n 0.6446 223750.0n 0.5357 223999.9n 0.5357 224000.0n 0.5221 224249.9n 0.5221 224250.0n 0.5493 224499.9n 0.5493 224500.0n 0.6377 224749.9n 0.6377 224750.0n 0.6309 224999.9n 0.6309 225000.0n 0.5357 225249.9n 0.5357 225250.0n 0.5289 225499.9n 0.5289 225500.0n 0.4813 225749.9n 0.4813 225750.0n 0.5085 225999.9n 0.5085 226000.0n 0.5289 226249.9n 0.5289 226250.0n 0.6037 226499.9n 0.6037 226500.0n 0.5561 226749.9n 0.5561 226750.0n 0.5765 226999.9n 0.5765 227000.0n 0.4065 227249.9n 0.4065 227250.0n 0.6514 227499.9n 0.6514 227500.0n 0.6173 227749.9n 0.6173 227750.0n 0.5017 227999.9n 0.5017 228000.0n 0.6037 228249.9n 0.6037 228250.0n 0.6514 228499.9n 0.6514 228500.0n 0.4813 228749.9n 0.4813 228750.0n 0.6718 228999.9n 0.6718 229000.0n 0.5697 229249.9n 0.5697 229250.0n 0.5357 229499.9n 0.5357 229500.0n 0.5629 229749.9n 0.5629 229750.0n 0.5629 229999.9n 0.5629 230000.0n 0.5629 230249.9n 0.5629 230250.0n 0.5901 230499.9n 0.5901 230500.0n 0.5765 230749.9n 0.5765 230750.0n 0.3997 230999.9n 0.3997 231000.0n 0.6446 231249.9n 0.6446 231250.0n 0.5357 231499.9n 0.5357 231500.0n 0.5221 231749.9n 0.5221 231750.0n 0.5493 231999.9n 0.5493 232000.0n 0.6377 232249.9n 0.6377 232250.0n 0.6309 232499.9n 0.6309 232500.0n 0.5357 232749.9n 0.5357 232750.0n 0.5289 232999.9n 0.5289 233000.0n 0.4813 233249.9n 0.4813 233250.0n 0.5085 233499.9n 0.5085 233500.0n 0.5289 233749.9n 0.5289 233750.0n 0.6037 233999.9n 0.6037 234000.0n 0.5561 234249.9n 0.5561 234250.0n 0.5765 234499.9n 0.5765 234500.0n 0.4065 234749.9n 0.4065 234750.0n 0.6514 234999.9n 0.6514 235000.0n 0.6173 235249.9n 0.6173 235250.0n 0.5017 235499.9n 0.5017 235500.0n 0.6037 235749.9n 0.6037 235750.0n 0.6514 235999.9n 0.6514 236000.0n 0.4813 236249.9n 0.4813 236250.0n 0.6718 236499.9n 0.6718 236500.0n 0.5697 236749.9n 0.5697 236750.0n 0.5357 236999.9n 0.5357 237000.0n 0.5629 237249.9n 0.5629 237250.0n 0.5629 237499.9n 0.5629 237500.0n 0.5629 237749.9n 0.5629 237750.0n 0.5901 237999.9n 0.5901 238000.0n 0.5765 238249.9n 0.5765 238250.0n 0.3997 238499.9n 0.3997 238500.0n 0.6446 238749.9n 0.6446 238750.0n 0.5357 238999.9n 0.5357 239000.0n 0.5221 239249.9n 0.5221 239250.0n 0.5493 239499.9n 0.5493 239500.0n 0.6377 239749.9n 0.6377 239750.0n 0.6309 239999.9n 0.6309 240000.0n 0.5357 240249.9n 0.5357 240250.0n 0.5289 240499.9n 0.5289 240500.0n 0.4813 240749.9n 0.4813 240750.0n 0.5085 240999.9n 0.5085 241000.0n 0.5289 241249.9n 0.5289 241250.0n 0.6037 241499.9n 0.6037 241500.0n 0.5561 241749.9n 0.5561 241750.0n 0.5765 241999.9n 0.5765 242000.0n 0.4065 242249.9n 0.4065 242250.0n 0.6514 242499.9n 0.6514 242500.0n 0.6173 242749.9n 0.6173 242750.0n 0.5017 242999.9n 0.5017 243000.0n 0.6037 243249.9n 0.6037 243250.0n 0.6514 243499.9n 0.6514 243500.0n 0.4813 243749.9n 0.4813 243750.0n 0.6718 243999.9n 0.6718 244000.0n 0.5697 244249.9n 0.5697 244250.0n 0.5357 244499.9n 0.5357 244500.0n 0.5629 244749.9n 0.5629 244750.0n 0.5629 244999.9n 0.5629 245000.0n 0.5629 245249.9n 0.5629 245250.0n 0.5901 245499.9n 0.5901 245500.0n 0.5765 245749.9n 0.5765 245750.0n 0.3997 245999.9n 0.3997 246000.0n 0.6446 246249.9n 0.6446 246250.0n 0.5357 246499.9n 0.5357 246500.0n 0.5221 246749.9n 0.5221 246750.0n 0.5493 246999.9n 0.5493 247000.0n 0.6377 247249.9n 0.6377 247250.0n 0.6309 247499.9n 0.6309 247500.0n 0.5357 247749.9n 0.5357 247750.0n 0.5289 247999.9n 0.5289 248000.0n 0.4813 248249.9n 0.4813 248250.0n 0.5085 248499.9n 0.5085 248500.0n 0.5289 248749.9n 0.5289 248750.0n 0.6037 248999.9n 0.6037 249000.0n 0.5561 249249.9n 0.5561 249250.0n 0.5765 249499.9n 0.5765 249500.0n 0.4065 249749.9n 0.4065 249750.0n 0.6514 249999.9n 0.6514 250000.0n 0.6173 250249.9n 0.6173 250250.0n 0.5017 250499.9n 0.5017 250500.0n 0.6037 250749.9n 0.6037 250750.0n 0.6514 250999.9n 0.6514 251000.0n 0.4813 251249.9n 0.4813 251250.0n 0.6718 251499.9n 0.6718 251500.0n 0.5697 251749.9n 0.5697 251750.0n 0.5357 251999.9n 0.5357 252000.0n 0.5629 252249.9n 0.5629 252250.0n 0.5629 252499.9n 0.5629 252500.0n 0.5629 252749.9n 0.5629 252750.0n 0.5901 252999.9n 0.5901 253000.0n 0.5765 253249.9n 0.5765 253250.0n 0.3997 253499.9n 0.3997 253500.0n 0.6446 253749.9n 0.6446 253750.0n 0.5357 253999.9n 0.5357 254000.0n 0.5221 254249.9n 0.5221 254250.0n 0.5493 254499.9n 0.5493 254500.0n 0.6377 254749.9n 0.6377 254750.0n 0.6309 254999.9n 0.6309 255000.0n 0.5357 255249.9n 0.5357 255250.0n 0.5289 255499.9n 0.5289 255500.0n 0.4813 255749.9n 0.4813 255750.0n 0.5085 255999.9n 0.5085 256000.0n 0.5289 256249.9n 0.5289 256250.0n 0.6037 256499.9n 0.6037 256500.0n 0.5561 256749.9n 0.5561 256750.0n 0.5765 256999.9n 0.5765 257000.0n 0.4065 257249.9n 0.4065 257250.0n 0.6514 257499.9n 0.6514 257500.0n 0.6173 257749.9n 0.6173 257750.0n 0.5017 257999.9n 0.5017 258000.0n 0.6037 258249.9n 0.6037 258250.0n 0.6514 258499.9n 0.6514 258500.0n 0.4813 258749.9n 0.4813 258750.0n 0.6718 258999.9n 0.6718 259000.0n 0.5697 259249.9n 0.5697 259250.0n 0.5357 259499.9n 0.5357 259500.0n 0.5629 259749.9n 0.5629 259750.0n 0.5629 259999.9n 0.5629 260000.0n 0.5629 260249.9n 0.5629 260250.0n 0.5901 260499.9n 0.5901 260500.0n 0.5765 260749.9n 0.5765 260750.0n 0.3997 260999.9n 0.3997 261000.0n 0.6446 261249.9n 0.6446 261250.0n 0.5357 261499.9n 0.5357 261500.0n 0.5221 261749.9n 0.5221 261750.0n 0.5493 261999.9n 0.5493 262000.0n 0.6377 262249.9n 0.6377 262250.0n 0.6309 262499.9n 0.6309 262500.0n 0.5357 262749.9n 0.5357 262750.0n 0.5289 262999.9n 0.5289 263000.0n 0.4813 263249.9n 0.4813 263250.0n 0.5085 263499.9n 0.5085 263500.0n 0.5289 263749.9n 0.5289 263750.0n 0.6037 263999.9n 0.6037 264000.0n 0.5561 264249.9n 0.5561 264250.0n 0.5765 264499.9n 0.5765 264500.0n 0.4065 264749.9n 0.4065 264750.0n 0.6514 264999.9n 0.6514 265000.0n 0.6173 265249.9n 0.6173 265250.0n 0.5017 265499.9n 0.5017 265500.0n 0.6037 265749.9n 0.6037 265750.0n 0.6514 265999.9n 0.6514 266000.0n 0.4813 266249.9n 0.4813 266250.0n 0.6718 266499.9n 0.6718 266500.0n 0.5697 266749.9n 0.5697 266750.0n 0.5357 266999.9n 0.5357 267000.0n 0.5629 267249.9n 0.5629 267250.0n 0.5629 267499.9n 0.5629 267500.0n 0.5629 267749.9n 0.5629 267750.0n 0.5901 267999.9n 0.5901 268000.0n 0.5765 268249.9n 0.5765 268250.0n 0.3997 268499.9n 0.3997 268500.0n 0.6446 268749.9n 0.6446 268750.0n 0.5357 268999.9n 0.5357 269000.0n 0.5221 269249.9n 0.5221 269250.0n 0.5493 269499.9n 0.5493 269500.0n 0.6377 269749.9n 0.6377 269750.0n 0.6309 269999.9n 0.6309 270000.0n 0.5357 270249.9n 0.5357 270250.0n 0.5289 270499.9n 0.5289 270500.0n 0.4813 270749.9n 0.4813 270750.0n 0.5085 270999.9n 0.5085 271000.0n 0.5289 271249.9n 0.5289 271250.0n 0.6037 271499.9n 0.6037 271500.0n 0.5561 271749.9n 0.5561 271750.0n 0.5765 271999.9n 0.5765 272000.0n 0.4065 272249.9n 0.4065 272250.0n 0.6514 272499.9n 0.6514 272500.0n 0.6173 272749.9n 0.6173 272750.0n 0.5017 272999.9n 0.5017 273000.0n 0.6037 273249.9n 0.6037 273250.0n 0.6514 273499.9n 0.6514 273500.0n 0.4813 273749.9n 0.4813 273750.0n 0.6718 273999.9n 0.6718 274000.0n 0.5697 274249.9n 0.5697 274250.0n 0.5357 274499.9n 0.5357 274500.0n 0.5629 274749.9n 0.5629 274750.0n 0.5629 274999.9n 0.5629 275000.0n 0.5629 275249.9n 0.5629 275250.0n 0.5901 275499.9n 0.5901 275500.0n 0.5765 275749.9n 0.5765 275750.0n 0.3997 275999.9n 0.3997 276000.0n 0.6446 276249.9n 0.6446 276250.0n 0.5357 276499.9n 0.5357 276500.0n 0.5221 276749.9n 0.5221 276750.0n 0.5493 276999.9n 0.5493 277000.0n 0.6377 277249.9n 0.6377 277250.0n 0.6309 277499.9n 0.6309 277500.0n 0.5357 277749.9n 0.5357 277750.0n 0.5289 277999.9n 0.5289 278000.0n 0.4813 278249.9n 0.4813 278250.0n 0.5085 278499.9n 0.5085 278500.0n 0.5289 278749.9n 0.5289 278750.0n 0.6037 278999.9n 0.6037 279000.0n 0.5561 279249.9n 0.5561 279250.0n 0.5765 279499.9n 0.5765 279500.0n 0.4065 279749.9n 0.4065 279750.0n 0.6514 279999.9n 0.6514 280000.0n 0.6173 280249.9n 0.6173 280250.0n 0.5017 280499.9n 0.5017 280500.0n 0.6037 280749.9n 0.6037 280750.0n 0.6514 280999.9n 0.6514 281000.0n 0.4813 281249.9n 0.4813 281250.0n 0.6718 281499.9n 0.6718 281500.0n 0.5697 281749.9n 0.5697 281750.0n 0.5357 281999.9n 0.5357 282000.0n 0.5629 282249.9n 0.5629 282250.0n 0.5629 282499.9n 0.5629 282500.0n 0.5629 282749.9n 0.5629 282750.0n 0.5901 282999.9n 0.5901 283000.0n 0.5765 283249.9n 0.5765 283250.0n 0.3997 283499.9n 0.3997 283500.0n 0.6446 283749.9n 0.6446 283750.0n 0.5357 283999.9n 0.5357 284000.0n 0.5221 284249.9n 0.5221 284250.0n 0.5493 284499.9n 0.5493 284500.0n 0.6377 284749.9n 0.6377 284750.0n 0.6309 284999.9n 0.6309 285000.0n 0.5357 285249.9n 0.5357 285250.0n 0.5289 285499.9n 0.5289 285500.0n 0.4813 285749.9n 0.4813 285750.0n 0.5085 285999.9n 0.5085 286000.0n 0.5289 286249.9n 0.5289 286250.0n 0.6037 286499.9n 0.6037 286500.0n 0.5561 286749.9n 0.5561 286750.0n 0.5765 286999.9n 0.5765 287000.0n 0.4065 287249.9n 0.4065 287250.0n 0.6514 287499.9n 0.6514 287500.0n 0.6173 287749.9n 0.6173 287750.0n 0.5017 287999.9n 0.5017 288000.0n 0.6037 288249.9n 0.6037 288250.0n 0.6514 288499.9n 0.6514 288500.0n 0.4813 288749.9n 0.4813 288750.0n 0.6718 288999.9n 0.6718 289000.0n 0.5697 289249.9n 0.5697 289250.0n 0.5357 289499.9n 0.5357 289500.0n 0.5629 289749.9n 0.5629 289750.0n 0.5629 289999.9n 0.5629 290000.0n 0.5629 290249.9n 0.5629 290250.0n 0.5901 290499.9n 0.5901 290500.0n 0.5765 290749.9n 0.5765 290750.0n 0.3997 290999.9n 0.3997 291000.0n 0.6446 291249.9n 0.6446 291250.0n 0.5357 291499.9n 0.5357 291500.0n 0.5221 291749.9n 0.5221 291750.0n 0.5493 291999.9n 0.5493 292000.0n 0.6377 292249.9n 0.6377 292250.0n 0.6309 292499.9n 0.6309 292500.0n 0.5357 292749.9n 0.5357 292750.0n 0.5289 292999.9n 0.5289 293000.0n 0.4813 293249.9n 0.4813 293250.0n 0.5085 293499.9n 0.5085 293500.0n 0.5289 293749.9n 0.5289 293750.0n 0.6037 293999.9n 0.6037 294000.0n 0.5561 294249.9n 0.5561 294250.0n 0.5765 294499.9n 0.5765 294500.0n 0.4065 294749.9n 0.4065 294750.0n 0.6514 294999.9n 0.6514 295000.0n 0.6173 295249.9n 0.6173 295250.0n 0.5017 295499.9n 0.5017 295500.0n 0.6037 295749.9n 0.6037 295750.0n 0.6514 295999.9n 0.6514 296000.0n 0.4813 296249.9n 0.4813 296250.0n 0.6718 296499.9n 0.6718 296500.0n 0.5697 296749.9n 0.5697 296750.0n 0.5357 296999.9n 0.5357 297000.0n 0.5629 297249.9n 0.5629 297250.0n 0.5629 297499.9n 0.5629 297500.0n 0.5629 297749.9n 0.5629 297750.0n 0.5901 297999.9n 0.5901 298000.0n 0.5765 298249.9n 0.5765 298250.0n 0.3997 298499.9n 0.3997 298500.0n 0.6446 298749.9n 0.6446 298750.0n 0.5357 298999.9n 0.5357 299000.0n 0.5221 299249.9n 0.5221 299250.0n 0.5493 299499.9n 0.5493 299500.0n 0.6377 299749.9n 0.6377 299750.0n 0.6309)
Vxn14 a_xn14 0 PWL(0.0n 0.4643 249.9n 0.4643 250.0n 0.4711 499.9n 0.4711 500.0n 0.5187 749.9n 0.5187 750.0n 0.4915 999.9n 0.4915 1000.0n 0.4711 1249.9n 0.4711 1250.0n 0.3963 1499.9n 0.3963 1500.0n 0.4439 1749.9n 0.4439 1750.0n 0.4235 1999.9n 0.4235 2000.0n 0.5935 2249.9n 0.5935 2250.0n 0.3486 2499.9n 0.3486 2500.0n 0.3827 2749.9n 0.3827 2750.0n 0.4983 2999.9n 0.4983 3000.0n 0.3963 3249.9n 0.3963 3250.0n 0.3486 3499.9n 0.3486 3500.0n 0.5187 3749.9n 0.5187 3750.0n 0.3282 3999.9n 0.3282 4000.0n 0.4303 4249.9n 0.4303 4250.0n 0.4643 4499.9n 0.4643 4500.0n 0.4371 4749.9n 0.4371 4750.0n 0.4371 4999.9n 0.4371 5000.0n 0.4371 5249.9n 0.4371 5250.0n 0.4099 5499.9n 0.4099 5500.0n 0.4235 5749.9n 0.4235 5750.0n 0.6003 5999.9n 0.6003 6000.0n 0.3554 6249.9n 0.3554 6250.0n 0.4643 6499.9n 0.4643 6500.0n 0.4779 6749.9n 0.4779 6750.0n 0.4507 6999.9n 0.4507 7000.0n 0.3623 7249.9n 0.3623 7250.0n 0.3691 7499.9n 0.3691 7500.0n 0.4643 7749.9n 0.4643 7750.0n 0.4711 7999.9n 0.4711 8000.0n 0.5187 8249.9n 0.5187 8250.0n 0.4915 8499.9n 0.4915 8500.0n 0.4711 8749.9n 0.4711 8750.0n 0.3963 8999.9n 0.3963 9000.0n 0.4439 9249.9n 0.4439 9250.0n 0.4235 9499.9n 0.4235 9500.0n 0.5935 9749.9n 0.5935 9750.0n 0.3486 9999.9n 0.3486 10000.0n 0.3827 10249.9n 0.3827 10250.0n 0.4983 10499.9n 0.4983 10500.0n 0.3963 10749.9n 0.3963 10750.0n 0.3486 10999.9n 0.3486 11000.0n 0.5187 11249.9n 0.5187 11250.0n 0.3282 11499.9n 0.3282 11500.0n 0.4303 11749.9n 0.4303 11750.0n 0.4643 11999.9n 0.4643 12000.0n 0.4371 12249.9n 0.4371 12250.0n 0.4371 12499.9n 0.4371 12500.0n 0.4371 12749.9n 0.4371 12750.0n 0.4099 12999.9n 0.4099 13000.0n 0.4235 13249.9n 0.4235 13250.0n 0.6003 13499.9n 0.6003 13500.0n 0.3554 13749.9n 0.3554 13750.0n 0.4643 13999.9n 0.4643 14000.0n 0.4779 14249.9n 0.4779 14250.0n 0.4507 14499.9n 0.4507 14500.0n 0.3623 14749.9n 0.3623 14750.0n 0.3691 14999.9n 0.3691 15000.0n 0.4643 15249.9n 0.4643 15250.0n 0.4711 15499.9n 0.4711 15500.0n 0.5187 15749.9n 0.5187 15750.0n 0.4915 15999.9n 0.4915 16000.0n 0.4711 16249.9n 0.4711 16250.0n 0.3963 16499.9n 0.3963 16500.0n 0.4439 16749.9n 0.4439 16750.0n 0.4235 16999.9n 0.4235 17000.0n 0.5935 17249.9n 0.5935 17250.0n 0.3486 17499.9n 0.3486 17500.0n 0.3827 17749.9n 0.3827 17750.0n 0.4983 17999.9n 0.4983 18000.0n 0.3963 18249.9n 0.3963 18250.0n 0.3486 18499.9n 0.3486 18500.0n 0.5187 18749.9n 0.5187 18750.0n 0.3282 18999.9n 0.3282 19000.0n 0.4303 19249.9n 0.4303 19250.0n 0.4643 19499.9n 0.4643 19500.0n 0.4371 19749.9n 0.4371 19750.0n 0.4371 19999.9n 0.4371 20000.0n 0.4371 20249.9n 0.4371 20250.0n 0.4099 20499.9n 0.4099 20500.0n 0.4235 20749.9n 0.4235 20750.0n 0.6003 20999.9n 0.6003 21000.0n 0.3554 21249.9n 0.3554 21250.0n 0.4643 21499.9n 0.4643 21500.0n 0.4779 21749.9n 0.4779 21750.0n 0.4507 21999.9n 0.4507 22000.0n 0.3623 22249.9n 0.3623 22250.0n 0.3691 22499.9n 0.3691 22500.0n 0.4643 22749.9n 0.4643 22750.0n 0.4711 22999.9n 0.4711 23000.0n 0.5187 23249.9n 0.5187 23250.0n 0.4915 23499.9n 0.4915 23500.0n 0.4711 23749.9n 0.4711 23750.0n 0.3963 23999.9n 0.3963 24000.0n 0.4439 24249.9n 0.4439 24250.0n 0.4235 24499.9n 0.4235 24500.0n 0.5935 24749.9n 0.5935 24750.0n 0.3486 24999.9n 0.3486 25000.0n 0.3827 25249.9n 0.3827 25250.0n 0.4983 25499.9n 0.4983 25500.0n 0.3963 25749.9n 0.3963 25750.0n 0.3486 25999.9n 0.3486 26000.0n 0.5187 26249.9n 0.5187 26250.0n 0.3282 26499.9n 0.3282 26500.0n 0.4303 26749.9n 0.4303 26750.0n 0.4643 26999.9n 0.4643 27000.0n 0.4371 27249.9n 0.4371 27250.0n 0.4371 27499.9n 0.4371 27500.0n 0.4371 27749.9n 0.4371 27750.0n 0.4099 27999.9n 0.4099 28000.0n 0.4235 28249.9n 0.4235 28250.0n 0.6003 28499.9n 0.6003 28500.0n 0.3554 28749.9n 0.3554 28750.0n 0.4643 28999.9n 0.4643 29000.0n 0.4779 29249.9n 0.4779 29250.0n 0.4507 29499.9n 0.4507 29500.0n 0.3623 29749.9n 0.3623 29750.0n 0.3691 29999.9n 0.3691 30000.0n 0.4643 30249.9n 0.4643 30250.0n 0.4711 30499.9n 0.4711 30500.0n 0.5187 30749.9n 0.5187 30750.0n 0.4915 30999.9n 0.4915 31000.0n 0.4711 31249.9n 0.4711 31250.0n 0.3963 31499.9n 0.3963 31500.0n 0.4439 31749.9n 0.4439 31750.0n 0.4235 31999.9n 0.4235 32000.0n 0.5935 32249.9n 0.5935 32250.0n 0.3486 32499.9n 0.3486 32500.0n 0.3827 32749.9n 0.3827 32750.0n 0.4983 32999.9n 0.4983 33000.0n 0.3963 33249.9n 0.3963 33250.0n 0.3486 33499.9n 0.3486 33500.0n 0.5187 33749.9n 0.5187 33750.0n 0.3282 33999.9n 0.3282 34000.0n 0.4303 34249.9n 0.4303 34250.0n 0.4643 34499.9n 0.4643 34500.0n 0.4371 34749.9n 0.4371 34750.0n 0.4371 34999.9n 0.4371 35000.0n 0.4371 35249.9n 0.4371 35250.0n 0.4099 35499.9n 0.4099 35500.0n 0.4235 35749.9n 0.4235 35750.0n 0.6003 35999.9n 0.6003 36000.0n 0.3554 36249.9n 0.3554 36250.0n 0.4643 36499.9n 0.4643 36500.0n 0.4779 36749.9n 0.4779 36750.0n 0.4507 36999.9n 0.4507 37000.0n 0.3623 37249.9n 0.3623 37250.0n 0.3691 37499.9n 0.3691 37500.0n 0.4643 37749.9n 0.4643 37750.0n 0.4711 37999.9n 0.4711 38000.0n 0.5187 38249.9n 0.5187 38250.0n 0.4915 38499.9n 0.4915 38500.0n 0.4711 38749.9n 0.4711 38750.0n 0.3963 38999.9n 0.3963 39000.0n 0.4439 39249.9n 0.4439 39250.0n 0.4235 39499.9n 0.4235 39500.0n 0.5935 39749.9n 0.5935 39750.0n 0.3486 39999.9n 0.3486 40000.0n 0.3827 40249.9n 0.3827 40250.0n 0.4983 40499.9n 0.4983 40500.0n 0.3963 40749.9n 0.3963 40750.0n 0.3486 40999.9n 0.3486 41000.0n 0.5187 41249.9n 0.5187 41250.0n 0.3282 41499.9n 0.3282 41500.0n 0.4303 41749.9n 0.4303 41750.0n 0.4643 41999.9n 0.4643 42000.0n 0.4371 42249.9n 0.4371 42250.0n 0.4371 42499.9n 0.4371 42500.0n 0.4371 42749.9n 0.4371 42750.0n 0.4099 42999.9n 0.4099 43000.0n 0.4235 43249.9n 0.4235 43250.0n 0.6003 43499.9n 0.6003 43500.0n 0.3554 43749.9n 0.3554 43750.0n 0.4643 43999.9n 0.4643 44000.0n 0.4779 44249.9n 0.4779 44250.0n 0.4507 44499.9n 0.4507 44500.0n 0.3623 44749.9n 0.3623 44750.0n 0.3691 44999.9n 0.3691 45000.0n 0.4643 45249.9n 0.4643 45250.0n 0.4711 45499.9n 0.4711 45500.0n 0.5187 45749.9n 0.5187 45750.0n 0.4915 45999.9n 0.4915 46000.0n 0.4711 46249.9n 0.4711 46250.0n 0.3963 46499.9n 0.3963 46500.0n 0.4439 46749.9n 0.4439 46750.0n 0.4235 46999.9n 0.4235 47000.0n 0.5935 47249.9n 0.5935 47250.0n 0.3486 47499.9n 0.3486 47500.0n 0.3827 47749.9n 0.3827 47750.0n 0.4983 47999.9n 0.4983 48000.0n 0.3963 48249.9n 0.3963 48250.0n 0.3486 48499.9n 0.3486 48500.0n 0.5187 48749.9n 0.5187 48750.0n 0.3282 48999.9n 0.3282 49000.0n 0.4303 49249.9n 0.4303 49250.0n 0.4643 49499.9n 0.4643 49500.0n 0.4371 49749.9n 0.4371 49750.0n 0.4371 49999.9n 0.4371 50000.0n 0.4371 50249.9n 0.4371 50250.0n 0.4099 50499.9n 0.4099 50500.0n 0.4235 50749.9n 0.4235 50750.0n 0.6003 50999.9n 0.6003 51000.0n 0.3554 51249.9n 0.3554 51250.0n 0.4643 51499.9n 0.4643 51500.0n 0.4779 51749.9n 0.4779 51750.0n 0.4507 51999.9n 0.4507 52000.0n 0.3623 52249.9n 0.3623 52250.0n 0.3691 52499.9n 0.3691 52500.0n 0.4643 52749.9n 0.4643 52750.0n 0.4711 52999.9n 0.4711 53000.0n 0.5187 53249.9n 0.5187 53250.0n 0.4915 53499.9n 0.4915 53500.0n 0.4711 53749.9n 0.4711 53750.0n 0.3963 53999.9n 0.3963 54000.0n 0.4439 54249.9n 0.4439 54250.0n 0.4235 54499.9n 0.4235 54500.0n 0.5935 54749.9n 0.5935 54750.0n 0.3486 54999.9n 0.3486 55000.0n 0.3827 55249.9n 0.3827 55250.0n 0.4983 55499.9n 0.4983 55500.0n 0.3963 55749.9n 0.3963 55750.0n 0.3486 55999.9n 0.3486 56000.0n 0.5187 56249.9n 0.5187 56250.0n 0.3282 56499.9n 0.3282 56500.0n 0.4303 56749.9n 0.4303 56750.0n 0.4643 56999.9n 0.4643 57000.0n 0.4371 57249.9n 0.4371 57250.0n 0.4371 57499.9n 0.4371 57500.0n 0.4371 57749.9n 0.4371 57750.0n 0.4099 57999.9n 0.4099 58000.0n 0.4235 58249.9n 0.4235 58250.0n 0.6003 58499.9n 0.6003 58500.0n 0.3554 58749.9n 0.3554 58750.0n 0.4643 58999.9n 0.4643 59000.0n 0.4779 59249.9n 0.4779 59250.0n 0.4507 59499.9n 0.4507 59500.0n 0.3623 59749.9n 0.3623 59750.0n 0.3691 59999.9n 0.3691 60000.0n 0.4643 60249.9n 0.4643 60250.0n 0.4711 60499.9n 0.4711 60500.0n 0.5187 60749.9n 0.5187 60750.0n 0.4915 60999.9n 0.4915 61000.0n 0.4711 61249.9n 0.4711 61250.0n 0.3963 61499.9n 0.3963 61500.0n 0.4439 61749.9n 0.4439 61750.0n 0.4235 61999.9n 0.4235 62000.0n 0.5935 62249.9n 0.5935 62250.0n 0.3486 62499.9n 0.3486 62500.0n 0.3827 62749.9n 0.3827 62750.0n 0.4983 62999.9n 0.4983 63000.0n 0.3963 63249.9n 0.3963 63250.0n 0.3486 63499.9n 0.3486 63500.0n 0.5187 63749.9n 0.5187 63750.0n 0.3282 63999.9n 0.3282 64000.0n 0.4303 64249.9n 0.4303 64250.0n 0.4643 64499.9n 0.4643 64500.0n 0.4371 64749.9n 0.4371 64750.0n 0.4371 64999.9n 0.4371 65000.0n 0.4371 65249.9n 0.4371 65250.0n 0.4099 65499.9n 0.4099 65500.0n 0.4235 65749.9n 0.4235 65750.0n 0.6003 65999.9n 0.6003 66000.0n 0.3554 66249.9n 0.3554 66250.0n 0.4643 66499.9n 0.4643 66500.0n 0.4779 66749.9n 0.4779 66750.0n 0.4507 66999.9n 0.4507 67000.0n 0.3623 67249.9n 0.3623 67250.0n 0.3691 67499.9n 0.3691 67500.0n 0.4643 67749.9n 0.4643 67750.0n 0.4711 67999.9n 0.4711 68000.0n 0.5187 68249.9n 0.5187 68250.0n 0.4915 68499.9n 0.4915 68500.0n 0.4711 68749.9n 0.4711 68750.0n 0.3963 68999.9n 0.3963 69000.0n 0.4439 69249.9n 0.4439 69250.0n 0.4235 69499.9n 0.4235 69500.0n 0.5935 69749.9n 0.5935 69750.0n 0.3486 69999.9n 0.3486 70000.0n 0.3827 70249.9n 0.3827 70250.0n 0.4983 70499.9n 0.4983 70500.0n 0.3963 70749.9n 0.3963 70750.0n 0.3486 70999.9n 0.3486 71000.0n 0.5187 71249.9n 0.5187 71250.0n 0.3282 71499.9n 0.3282 71500.0n 0.4303 71749.9n 0.4303 71750.0n 0.4643 71999.9n 0.4643 72000.0n 0.4371 72249.9n 0.4371 72250.0n 0.4371 72499.9n 0.4371 72500.0n 0.4371 72749.9n 0.4371 72750.0n 0.4099 72999.9n 0.4099 73000.0n 0.4235 73249.9n 0.4235 73250.0n 0.6003 73499.9n 0.6003 73500.0n 0.3554 73749.9n 0.3554 73750.0n 0.4643 73999.9n 0.4643 74000.0n 0.4779 74249.9n 0.4779 74250.0n 0.4507 74499.9n 0.4507 74500.0n 0.3623 74749.9n 0.3623 74750.0n 0.3691 74999.9n 0.3691 75000.0n 0.4643 75249.9n 0.4643 75250.0n 0.4711 75499.9n 0.4711 75500.0n 0.5187 75749.9n 0.5187 75750.0n 0.4915 75999.9n 0.4915 76000.0n 0.4711 76249.9n 0.4711 76250.0n 0.3963 76499.9n 0.3963 76500.0n 0.4439 76749.9n 0.4439 76750.0n 0.4235 76999.9n 0.4235 77000.0n 0.5935 77249.9n 0.5935 77250.0n 0.3486 77499.9n 0.3486 77500.0n 0.3827 77749.9n 0.3827 77750.0n 0.4983 77999.9n 0.4983 78000.0n 0.3963 78249.9n 0.3963 78250.0n 0.3486 78499.9n 0.3486 78500.0n 0.5187 78749.9n 0.5187 78750.0n 0.3282 78999.9n 0.3282 79000.0n 0.4303 79249.9n 0.4303 79250.0n 0.4643 79499.9n 0.4643 79500.0n 0.4371 79749.9n 0.4371 79750.0n 0.4371 79999.9n 0.4371 80000.0n 0.4371 80249.9n 0.4371 80250.0n 0.4099 80499.9n 0.4099 80500.0n 0.4235 80749.9n 0.4235 80750.0n 0.6003 80999.9n 0.6003 81000.0n 0.3554 81249.9n 0.3554 81250.0n 0.4643 81499.9n 0.4643 81500.0n 0.4779 81749.9n 0.4779 81750.0n 0.4507 81999.9n 0.4507 82000.0n 0.3623 82249.9n 0.3623 82250.0n 0.3691 82499.9n 0.3691 82500.0n 0.4643 82749.9n 0.4643 82750.0n 0.4711 82999.9n 0.4711 83000.0n 0.5187 83249.9n 0.5187 83250.0n 0.4915 83499.9n 0.4915 83500.0n 0.4711 83749.9n 0.4711 83750.0n 0.3963 83999.9n 0.3963 84000.0n 0.4439 84249.9n 0.4439 84250.0n 0.4235 84499.9n 0.4235 84500.0n 0.5935 84749.9n 0.5935 84750.0n 0.3486 84999.9n 0.3486 85000.0n 0.3827 85249.9n 0.3827 85250.0n 0.4983 85499.9n 0.4983 85500.0n 0.3963 85749.9n 0.3963 85750.0n 0.3486 85999.9n 0.3486 86000.0n 0.5187 86249.9n 0.5187 86250.0n 0.3282 86499.9n 0.3282 86500.0n 0.4303 86749.9n 0.4303 86750.0n 0.4643 86999.9n 0.4643 87000.0n 0.4371 87249.9n 0.4371 87250.0n 0.4371 87499.9n 0.4371 87500.0n 0.4371 87749.9n 0.4371 87750.0n 0.4099 87999.9n 0.4099 88000.0n 0.4235 88249.9n 0.4235 88250.0n 0.6003 88499.9n 0.6003 88500.0n 0.3554 88749.9n 0.3554 88750.0n 0.4643 88999.9n 0.4643 89000.0n 0.4779 89249.9n 0.4779 89250.0n 0.4507 89499.9n 0.4507 89500.0n 0.3623 89749.9n 0.3623 89750.0n 0.3691 89999.9n 0.3691 90000.0n 0.4643 90249.9n 0.4643 90250.0n 0.4711 90499.9n 0.4711 90500.0n 0.5187 90749.9n 0.5187 90750.0n 0.4915 90999.9n 0.4915 91000.0n 0.4711 91249.9n 0.4711 91250.0n 0.3963 91499.9n 0.3963 91500.0n 0.4439 91749.9n 0.4439 91750.0n 0.4235 91999.9n 0.4235 92000.0n 0.5935 92249.9n 0.5935 92250.0n 0.3486 92499.9n 0.3486 92500.0n 0.3827 92749.9n 0.3827 92750.0n 0.4983 92999.9n 0.4983 93000.0n 0.3963 93249.9n 0.3963 93250.0n 0.3486 93499.9n 0.3486 93500.0n 0.5187 93749.9n 0.5187 93750.0n 0.3282 93999.9n 0.3282 94000.0n 0.4303 94249.9n 0.4303 94250.0n 0.4643 94499.9n 0.4643 94500.0n 0.4371 94749.9n 0.4371 94750.0n 0.4371 94999.9n 0.4371 95000.0n 0.4371 95249.9n 0.4371 95250.0n 0.4099 95499.9n 0.4099 95500.0n 0.4235 95749.9n 0.4235 95750.0n 0.6003 95999.9n 0.6003 96000.0n 0.3554 96249.9n 0.3554 96250.0n 0.4643 96499.9n 0.4643 96500.0n 0.4779 96749.9n 0.4779 96750.0n 0.4507 96999.9n 0.4507 97000.0n 0.3623 97249.9n 0.3623 97250.0n 0.3691 97499.9n 0.3691 97500.0n 0.4643 97749.9n 0.4643 97750.0n 0.4711 97999.9n 0.4711 98000.0n 0.5187 98249.9n 0.5187 98250.0n 0.4915 98499.9n 0.4915 98500.0n 0.4711 98749.9n 0.4711 98750.0n 0.3963 98999.9n 0.3963 99000.0n 0.4439 99249.9n 0.4439 99250.0n 0.4235 99499.9n 0.4235 99500.0n 0.5935 99749.9n 0.5935 99750.0n 0.3486 99999.9n 0.3486 100000.0n 0.3827 100249.9n 0.3827 100250.0n 0.4983 100499.9n 0.4983 100500.0n 0.3963 100749.9n 0.3963 100750.0n 0.3486 100999.9n 0.3486 101000.0n 0.5187 101249.9n 0.5187 101250.0n 0.3282 101499.9n 0.3282 101500.0n 0.4303 101749.9n 0.4303 101750.0n 0.4643 101999.9n 0.4643 102000.0n 0.4371 102249.9n 0.4371 102250.0n 0.4371 102499.9n 0.4371 102500.0n 0.4371 102749.9n 0.4371 102750.0n 0.4099 102999.9n 0.4099 103000.0n 0.4235 103249.9n 0.4235 103250.0n 0.6003 103499.9n 0.6003 103500.0n 0.3554 103749.9n 0.3554 103750.0n 0.4643 103999.9n 0.4643 104000.0n 0.4779 104249.9n 0.4779 104250.0n 0.4507 104499.9n 0.4507 104500.0n 0.3623 104749.9n 0.3623 104750.0n 0.3691 104999.9n 0.3691 105000.0n 0.4643 105249.9n 0.4643 105250.0n 0.4711 105499.9n 0.4711 105500.0n 0.5187 105749.9n 0.5187 105750.0n 0.4915 105999.9n 0.4915 106000.0n 0.4711 106249.9n 0.4711 106250.0n 0.3963 106499.9n 0.3963 106500.0n 0.4439 106749.9n 0.4439 106750.0n 0.4235 106999.9n 0.4235 107000.0n 0.5935 107249.9n 0.5935 107250.0n 0.3486 107499.9n 0.3486 107500.0n 0.3827 107749.9n 0.3827 107750.0n 0.4983 107999.9n 0.4983 108000.0n 0.3963 108249.9n 0.3963 108250.0n 0.3486 108499.9n 0.3486 108500.0n 0.5187 108749.9n 0.5187 108750.0n 0.3282 108999.9n 0.3282 109000.0n 0.4303 109249.9n 0.4303 109250.0n 0.4643 109499.9n 0.4643 109500.0n 0.4371 109749.9n 0.4371 109750.0n 0.4371 109999.9n 0.4371 110000.0n 0.4371 110249.9n 0.4371 110250.0n 0.4099 110499.9n 0.4099 110500.0n 0.4235 110749.9n 0.4235 110750.0n 0.6003 110999.9n 0.6003 111000.0n 0.3554 111249.9n 0.3554 111250.0n 0.4643 111499.9n 0.4643 111500.0n 0.4779 111749.9n 0.4779 111750.0n 0.4507 111999.9n 0.4507 112000.0n 0.3623 112249.9n 0.3623 112250.0n 0.3691 112499.9n 0.3691 112500.0n 0.4643 112749.9n 0.4643 112750.0n 0.4711 112999.9n 0.4711 113000.0n 0.5187 113249.9n 0.5187 113250.0n 0.4915 113499.9n 0.4915 113500.0n 0.4711 113749.9n 0.4711 113750.0n 0.3963 113999.9n 0.3963 114000.0n 0.4439 114249.9n 0.4439 114250.0n 0.4235 114499.9n 0.4235 114500.0n 0.5935 114749.9n 0.5935 114750.0n 0.3486 114999.9n 0.3486 115000.0n 0.3827 115249.9n 0.3827 115250.0n 0.4983 115499.9n 0.4983 115500.0n 0.3963 115749.9n 0.3963 115750.0n 0.3486 115999.9n 0.3486 116000.0n 0.5187 116249.9n 0.5187 116250.0n 0.3282 116499.9n 0.3282 116500.0n 0.4303 116749.9n 0.4303 116750.0n 0.4643 116999.9n 0.4643 117000.0n 0.4371 117249.9n 0.4371 117250.0n 0.4371 117499.9n 0.4371 117500.0n 0.4371 117749.9n 0.4371 117750.0n 0.4099 117999.9n 0.4099 118000.0n 0.4235 118249.9n 0.4235 118250.0n 0.6003 118499.9n 0.6003 118500.0n 0.3554 118749.9n 0.3554 118750.0n 0.4643 118999.9n 0.4643 119000.0n 0.4779 119249.9n 0.4779 119250.0n 0.4507 119499.9n 0.4507 119500.0n 0.3623 119749.9n 0.3623 119750.0n 0.3691 119999.9n 0.3691 120000.0n 0.4643 120249.9n 0.4643 120250.0n 0.4711 120499.9n 0.4711 120500.0n 0.5187 120749.9n 0.5187 120750.0n 0.4915 120999.9n 0.4915 121000.0n 0.4711 121249.9n 0.4711 121250.0n 0.3963 121499.9n 0.3963 121500.0n 0.4439 121749.9n 0.4439 121750.0n 0.4235 121999.9n 0.4235 122000.0n 0.5935 122249.9n 0.5935 122250.0n 0.3486 122499.9n 0.3486 122500.0n 0.3827 122749.9n 0.3827 122750.0n 0.4983 122999.9n 0.4983 123000.0n 0.3963 123249.9n 0.3963 123250.0n 0.3486 123499.9n 0.3486 123500.0n 0.5187 123749.9n 0.5187 123750.0n 0.3282 123999.9n 0.3282 124000.0n 0.4303 124249.9n 0.4303 124250.0n 0.4643 124499.9n 0.4643 124500.0n 0.4371 124749.9n 0.4371 124750.0n 0.4371 124999.9n 0.4371 125000.0n 0.4371 125249.9n 0.4371 125250.0n 0.4099 125499.9n 0.4099 125500.0n 0.4235 125749.9n 0.4235 125750.0n 0.6003 125999.9n 0.6003 126000.0n 0.3554 126249.9n 0.3554 126250.0n 0.4643 126499.9n 0.4643 126500.0n 0.4779 126749.9n 0.4779 126750.0n 0.4507 126999.9n 0.4507 127000.0n 0.3623 127249.9n 0.3623 127250.0n 0.3691 127499.9n 0.3691 127500.0n 0.4643 127749.9n 0.4643 127750.0n 0.4711 127999.9n 0.4711 128000.0n 0.5187 128249.9n 0.5187 128250.0n 0.4915 128499.9n 0.4915 128500.0n 0.4711 128749.9n 0.4711 128750.0n 0.3963 128999.9n 0.3963 129000.0n 0.4439 129249.9n 0.4439 129250.0n 0.4235 129499.9n 0.4235 129500.0n 0.5935 129749.9n 0.5935 129750.0n 0.3486 129999.9n 0.3486 130000.0n 0.3827 130249.9n 0.3827 130250.0n 0.4983 130499.9n 0.4983 130500.0n 0.3963 130749.9n 0.3963 130750.0n 0.3486 130999.9n 0.3486 131000.0n 0.5187 131249.9n 0.5187 131250.0n 0.3282 131499.9n 0.3282 131500.0n 0.4303 131749.9n 0.4303 131750.0n 0.4643 131999.9n 0.4643 132000.0n 0.4371 132249.9n 0.4371 132250.0n 0.4371 132499.9n 0.4371 132500.0n 0.4371 132749.9n 0.4371 132750.0n 0.4099 132999.9n 0.4099 133000.0n 0.4235 133249.9n 0.4235 133250.0n 0.6003 133499.9n 0.6003 133500.0n 0.3554 133749.9n 0.3554 133750.0n 0.4643 133999.9n 0.4643 134000.0n 0.4779 134249.9n 0.4779 134250.0n 0.4507 134499.9n 0.4507 134500.0n 0.3623 134749.9n 0.3623 134750.0n 0.3691 134999.9n 0.3691 135000.0n 0.4643 135249.9n 0.4643 135250.0n 0.4711 135499.9n 0.4711 135500.0n 0.5187 135749.9n 0.5187 135750.0n 0.4915 135999.9n 0.4915 136000.0n 0.4711 136249.9n 0.4711 136250.0n 0.3963 136499.9n 0.3963 136500.0n 0.4439 136749.9n 0.4439 136750.0n 0.4235 136999.9n 0.4235 137000.0n 0.5935 137249.9n 0.5935 137250.0n 0.3486 137499.9n 0.3486 137500.0n 0.3827 137749.9n 0.3827 137750.0n 0.4983 137999.9n 0.4983 138000.0n 0.3963 138249.9n 0.3963 138250.0n 0.3486 138499.9n 0.3486 138500.0n 0.5187 138749.9n 0.5187 138750.0n 0.3282 138999.9n 0.3282 139000.0n 0.4303 139249.9n 0.4303 139250.0n 0.4643 139499.9n 0.4643 139500.0n 0.4371 139749.9n 0.4371 139750.0n 0.4371 139999.9n 0.4371 140000.0n 0.4371 140249.9n 0.4371 140250.0n 0.4099 140499.9n 0.4099 140500.0n 0.4235 140749.9n 0.4235 140750.0n 0.6003 140999.9n 0.6003 141000.0n 0.3554 141249.9n 0.3554 141250.0n 0.4643 141499.9n 0.4643 141500.0n 0.4779 141749.9n 0.4779 141750.0n 0.4507 141999.9n 0.4507 142000.0n 0.3623 142249.9n 0.3623 142250.0n 0.3691 142499.9n 0.3691 142500.0n 0.4643 142749.9n 0.4643 142750.0n 0.4711 142999.9n 0.4711 143000.0n 0.5187 143249.9n 0.5187 143250.0n 0.4915 143499.9n 0.4915 143500.0n 0.4711 143749.9n 0.4711 143750.0n 0.3963 143999.9n 0.3963 144000.0n 0.4439 144249.9n 0.4439 144250.0n 0.4235 144499.9n 0.4235 144500.0n 0.5935 144749.9n 0.5935 144750.0n 0.3486 144999.9n 0.3486 145000.0n 0.3827 145249.9n 0.3827 145250.0n 0.4983 145499.9n 0.4983 145500.0n 0.3963 145749.9n 0.3963 145750.0n 0.3486 145999.9n 0.3486 146000.0n 0.5187 146249.9n 0.5187 146250.0n 0.3282 146499.9n 0.3282 146500.0n 0.4303 146749.9n 0.4303 146750.0n 0.4643 146999.9n 0.4643 147000.0n 0.4371 147249.9n 0.4371 147250.0n 0.4371 147499.9n 0.4371 147500.0n 0.4371 147749.9n 0.4371 147750.0n 0.4099 147999.9n 0.4099 148000.0n 0.4235 148249.9n 0.4235 148250.0n 0.6003 148499.9n 0.6003 148500.0n 0.3554 148749.9n 0.3554 148750.0n 0.4643 148999.9n 0.4643 149000.0n 0.4779 149249.9n 0.4779 149250.0n 0.4507 149499.9n 0.4507 149500.0n 0.3623 149749.9n 0.3623 149750.0n 0.3691 149999.9n 0.3691 150000.0n 0.4643 150249.9n 0.4643 150250.0n 0.4711 150499.9n 0.4711 150500.0n 0.5187 150749.9n 0.5187 150750.0n 0.4915 150999.9n 0.4915 151000.0n 0.4711 151249.9n 0.4711 151250.0n 0.3963 151499.9n 0.3963 151500.0n 0.4439 151749.9n 0.4439 151750.0n 0.4235 151999.9n 0.4235 152000.0n 0.5935 152249.9n 0.5935 152250.0n 0.3486 152499.9n 0.3486 152500.0n 0.3827 152749.9n 0.3827 152750.0n 0.4983 152999.9n 0.4983 153000.0n 0.3963 153249.9n 0.3963 153250.0n 0.3486 153499.9n 0.3486 153500.0n 0.5187 153749.9n 0.5187 153750.0n 0.3282 153999.9n 0.3282 154000.0n 0.4303 154249.9n 0.4303 154250.0n 0.4643 154499.9n 0.4643 154500.0n 0.4371 154749.9n 0.4371 154750.0n 0.4371 154999.9n 0.4371 155000.0n 0.4371 155249.9n 0.4371 155250.0n 0.4099 155499.9n 0.4099 155500.0n 0.4235 155749.9n 0.4235 155750.0n 0.6003 155999.9n 0.6003 156000.0n 0.3554 156249.9n 0.3554 156250.0n 0.4643 156499.9n 0.4643 156500.0n 0.4779 156749.9n 0.4779 156750.0n 0.4507 156999.9n 0.4507 157000.0n 0.3623 157249.9n 0.3623 157250.0n 0.3691 157499.9n 0.3691 157500.0n 0.4643 157749.9n 0.4643 157750.0n 0.4711 157999.9n 0.4711 158000.0n 0.5187 158249.9n 0.5187 158250.0n 0.4915 158499.9n 0.4915 158500.0n 0.4711 158749.9n 0.4711 158750.0n 0.3963 158999.9n 0.3963 159000.0n 0.4439 159249.9n 0.4439 159250.0n 0.4235 159499.9n 0.4235 159500.0n 0.5935 159749.9n 0.5935 159750.0n 0.3486 159999.9n 0.3486 160000.0n 0.3827 160249.9n 0.3827 160250.0n 0.4983 160499.9n 0.4983 160500.0n 0.3963 160749.9n 0.3963 160750.0n 0.3486 160999.9n 0.3486 161000.0n 0.5187 161249.9n 0.5187 161250.0n 0.3282 161499.9n 0.3282 161500.0n 0.4303 161749.9n 0.4303 161750.0n 0.4643 161999.9n 0.4643 162000.0n 0.4371 162249.9n 0.4371 162250.0n 0.4371 162499.9n 0.4371 162500.0n 0.4371 162749.9n 0.4371 162750.0n 0.4099 162999.9n 0.4099 163000.0n 0.4235 163249.9n 0.4235 163250.0n 0.6003 163499.9n 0.6003 163500.0n 0.3554 163749.9n 0.3554 163750.0n 0.4643 163999.9n 0.4643 164000.0n 0.4779 164249.9n 0.4779 164250.0n 0.4507 164499.9n 0.4507 164500.0n 0.3623 164749.9n 0.3623 164750.0n 0.3691 164999.9n 0.3691 165000.0n 0.4643 165249.9n 0.4643 165250.0n 0.4711 165499.9n 0.4711 165500.0n 0.5187 165749.9n 0.5187 165750.0n 0.4915 165999.9n 0.4915 166000.0n 0.4711 166249.9n 0.4711 166250.0n 0.3963 166499.9n 0.3963 166500.0n 0.4439 166749.9n 0.4439 166750.0n 0.4235 166999.9n 0.4235 167000.0n 0.5935 167249.9n 0.5935 167250.0n 0.3486 167499.9n 0.3486 167500.0n 0.3827 167749.9n 0.3827 167750.0n 0.4983 167999.9n 0.4983 168000.0n 0.3963 168249.9n 0.3963 168250.0n 0.3486 168499.9n 0.3486 168500.0n 0.5187 168749.9n 0.5187 168750.0n 0.3282 168999.9n 0.3282 169000.0n 0.4303 169249.9n 0.4303 169250.0n 0.4643 169499.9n 0.4643 169500.0n 0.4371 169749.9n 0.4371 169750.0n 0.4371 169999.9n 0.4371 170000.0n 0.4371 170249.9n 0.4371 170250.0n 0.4099 170499.9n 0.4099 170500.0n 0.4235 170749.9n 0.4235 170750.0n 0.6003 170999.9n 0.6003 171000.0n 0.3554 171249.9n 0.3554 171250.0n 0.4643 171499.9n 0.4643 171500.0n 0.4779 171749.9n 0.4779 171750.0n 0.4507 171999.9n 0.4507 172000.0n 0.3623 172249.9n 0.3623 172250.0n 0.3691 172499.9n 0.3691 172500.0n 0.4643 172749.9n 0.4643 172750.0n 0.4711 172999.9n 0.4711 173000.0n 0.5187 173249.9n 0.5187 173250.0n 0.4915 173499.9n 0.4915 173500.0n 0.4711 173749.9n 0.4711 173750.0n 0.3963 173999.9n 0.3963 174000.0n 0.4439 174249.9n 0.4439 174250.0n 0.4235 174499.9n 0.4235 174500.0n 0.5935 174749.9n 0.5935 174750.0n 0.3486 174999.9n 0.3486 175000.0n 0.3827 175249.9n 0.3827 175250.0n 0.4983 175499.9n 0.4983 175500.0n 0.3963 175749.9n 0.3963 175750.0n 0.3486 175999.9n 0.3486 176000.0n 0.5187 176249.9n 0.5187 176250.0n 0.3282 176499.9n 0.3282 176500.0n 0.4303 176749.9n 0.4303 176750.0n 0.4643 176999.9n 0.4643 177000.0n 0.4371 177249.9n 0.4371 177250.0n 0.4371 177499.9n 0.4371 177500.0n 0.4371 177749.9n 0.4371 177750.0n 0.4099 177999.9n 0.4099 178000.0n 0.4235 178249.9n 0.4235 178250.0n 0.6003 178499.9n 0.6003 178500.0n 0.3554 178749.9n 0.3554 178750.0n 0.4643 178999.9n 0.4643 179000.0n 0.4779 179249.9n 0.4779 179250.0n 0.4507 179499.9n 0.4507 179500.0n 0.3623 179749.9n 0.3623 179750.0n 0.3691 179999.9n 0.3691 180000.0n 0.4643 180249.9n 0.4643 180250.0n 0.4711 180499.9n 0.4711 180500.0n 0.5187 180749.9n 0.5187 180750.0n 0.4915 180999.9n 0.4915 181000.0n 0.4711 181249.9n 0.4711 181250.0n 0.3963 181499.9n 0.3963 181500.0n 0.4439 181749.9n 0.4439 181750.0n 0.4235 181999.9n 0.4235 182000.0n 0.5935 182249.9n 0.5935 182250.0n 0.3486 182499.9n 0.3486 182500.0n 0.3827 182749.9n 0.3827 182750.0n 0.4983 182999.9n 0.4983 183000.0n 0.3963 183249.9n 0.3963 183250.0n 0.3486 183499.9n 0.3486 183500.0n 0.5187 183749.9n 0.5187 183750.0n 0.3282 183999.9n 0.3282 184000.0n 0.4303 184249.9n 0.4303 184250.0n 0.4643 184499.9n 0.4643 184500.0n 0.4371 184749.9n 0.4371 184750.0n 0.4371 184999.9n 0.4371 185000.0n 0.4371 185249.9n 0.4371 185250.0n 0.4099 185499.9n 0.4099 185500.0n 0.4235 185749.9n 0.4235 185750.0n 0.6003 185999.9n 0.6003 186000.0n 0.3554 186249.9n 0.3554 186250.0n 0.4643 186499.9n 0.4643 186500.0n 0.4779 186749.9n 0.4779 186750.0n 0.4507 186999.9n 0.4507 187000.0n 0.3623 187249.9n 0.3623 187250.0n 0.3691 187499.9n 0.3691 187500.0n 0.4643 187749.9n 0.4643 187750.0n 0.4711 187999.9n 0.4711 188000.0n 0.5187 188249.9n 0.5187 188250.0n 0.4915 188499.9n 0.4915 188500.0n 0.4711 188749.9n 0.4711 188750.0n 0.3963 188999.9n 0.3963 189000.0n 0.4439 189249.9n 0.4439 189250.0n 0.4235 189499.9n 0.4235 189500.0n 0.5935 189749.9n 0.5935 189750.0n 0.3486 189999.9n 0.3486 190000.0n 0.3827 190249.9n 0.3827 190250.0n 0.4983 190499.9n 0.4983 190500.0n 0.3963 190749.9n 0.3963 190750.0n 0.3486 190999.9n 0.3486 191000.0n 0.5187 191249.9n 0.5187 191250.0n 0.3282 191499.9n 0.3282 191500.0n 0.4303 191749.9n 0.4303 191750.0n 0.4643 191999.9n 0.4643 192000.0n 0.4371 192249.9n 0.4371 192250.0n 0.4371 192499.9n 0.4371 192500.0n 0.4371 192749.9n 0.4371 192750.0n 0.4099 192999.9n 0.4099 193000.0n 0.4235 193249.9n 0.4235 193250.0n 0.6003 193499.9n 0.6003 193500.0n 0.3554 193749.9n 0.3554 193750.0n 0.4643 193999.9n 0.4643 194000.0n 0.4779 194249.9n 0.4779 194250.0n 0.4507 194499.9n 0.4507 194500.0n 0.3623 194749.9n 0.3623 194750.0n 0.3691 194999.9n 0.3691 195000.0n 0.4643 195249.9n 0.4643 195250.0n 0.4711 195499.9n 0.4711 195500.0n 0.5187 195749.9n 0.5187 195750.0n 0.4915 195999.9n 0.4915 196000.0n 0.4711 196249.9n 0.4711 196250.0n 0.3963 196499.9n 0.3963 196500.0n 0.4439 196749.9n 0.4439 196750.0n 0.4235 196999.9n 0.4235 197000.0n 0.5935 197249.9n 0.5935 197250.0n 0.3486 197499.9n 0.3486 197500.0n 0.3827 197749.9n 0.3827 197750.0n 0.4983 197999.9n 0.4983 198000.0n 0.3963 198249.9n 0.3963 198250.0n 0.3486 198499.9n 0.3486 198500.0n 0.5187 198749.9n 0.5187 198750.0n 0.3282 198999.9n 0.3282 199000.0n 0.4303 199249.9n 0.4303 199250.0n 0.4643 199499.9n 0.4643 199500.0n 0.4371 199749.9n 0.4371 199750.0n 0.4371 199999.9n 0.4371 200000.0n 0.4371 200249.9n 0.4371 200250.0n 0.4099 200499.9n 0.4099 200500.0n 0.4235 200749.9n 0.4235 200750.0n 0.6003 200999.9n 0.6003 201000.0n 0.3554 201249.9n 0.3554 201250.0n 0.4643 201499.9n 0.4643 201500.0n 0.4779 201749.9n 0.4779 201750.0n 0.4507 201999.9n 0.4507 202000.0n 0.3623 202249.9n 0.3623 202250.0n 0.3691 202499.9n 0.3691 202500.0n 0.4643 202749.9n 0.4643 202750.0n 0.4711 202999.9n 0.4711 203000.0n 0.5187 203249.9n 0.5187 203250.0n 0.4915 203499.9n 0.4915 203500.0n 0.4711 203749.9n 0.4711 203750.0n 0.3963 203999.9n 0.3963 204000.0n 0.4439 204249.9n 0.4439 204250.0n 0.4235 204499.9n 0.4235 204500.0n 0.5935 204749.9n 0.5935 204750.0n 0.3486 204999.9n 0.3486 205000.0n 0.3827 205249.9n 0.3827 205250.0n 0.4983 205499.9n 0.4983 205500.0n 0.3963 205749.9n 0.3963 205750.0n 0.3486 205999.9n 0.3486 206000.0n 0.5187 206249.9n 0.5187 206250.0n 0.3282 206499.9n 0.3282 206500.0n 0.4303 206749.9n 0.4303 206750.0n 0.4643 206999.9n 0.4643 207000.0n 0.4371 207249.9n 0.4371 207250.0n 0.4371 207499.9n 0.4371 207500.0n 0.4371 207749.9n 0.4371 207750.0n 0.4099 207999.9n 0.4099 208000.0n 0.4235 208249.9n 0.4235 208250.0n 0.6003 208499.9n 0.6003 208500.0n 0.3554 208749.9n 0.3554 208750.0n 0.4643 208999.9n 0.4643 209000.0n 0.4779 209249.9n 0.4779 209250.0n 0.4507 209499.9n 0.4507 209500.0n 0.3623 209749.9n 0.3623 209750.0n 0.3691 209999.9n 0.3691 210000.0n 0.4643 210249.9n 0.4643 210250.0n 0.4711 210499.9n 0.4711 210500.0n 0.5187 210749.9n 0.5187 210750.0n 0.4915 210999.9n 0.4915 211000.0n 0.4711 211249.9n 0.4711 211250.0n 0.3963 211499.9n 0.3963 211500.0n 0.4439 211749.9n 0.4439 211750.0n 0.4235 211999.9n 0.4235 212000.0n 0.5935 212249.9n 0.5935 212250.0n 0.3486 212499.9n 0.3486 212500.0n 0.3827 212749.9n 0.3827 212750.0n 0.4983 212999.9n 0.4983 213000.0n 0.3963 213249.9n 0.3963 213250.0n 0.3486 213499.9n 0.3486 213500.0n 0.5187 213749.9n 0.5187 213750.0n 0.3282 213999.9n 0.3282 214000.0n 0.4303 214249.9n 0.4303 214250.0n 0.4643 214499.9n 0.4643 214500.0n 0.4371 214749.9n 0.4371 214750.0n 0.4371 214999.9n 0.4371 215000.0n 0.4371 215249.9n 0.4371 215250.0n 0.4099 215499.9n 0.4099 215500.0n 0.4235 215749.9n 0.4235 215750.0n 0.6003 215999.9n 0.6003 216000.0n 0.3554 216249.9n 0.3554 216250.0n 0.4643 216499.9n 0.4643 216500.0n 0.4779 216749.9n 0.4779 216750.0n 0.4507 216999.9n 0.4507 217000.0n 0.3623 217249.9n 0.3623 217250.0n 0.3691 217499.9n 0.3691 217500.0n 0.4643 217749.9n 0.4643 217750.0n 0.4711 217999.9n 0.4711 218000.0n 0.5187 218249.9n 0.5187 218250.0n 0.4915 218499.9n 0.4915 218500.0n 0.4711 218749.9n 0.4711 218750.0n 0.3963 218999.9n 0.3963 219000.0n 0.4439 219249.9n 0.4439 219250.0n 0.4235 219499.9n 0.4235 219500.0n 0.5935 219749.9n 0.5935 219750.0n 0.3486 219999.9n 0.3486 220000.0n 0.3827 220249.9n 0.3827 220250.0n 0.4983 220499.9n 0.4983 220500.0n 0.3963 220749.9n 0.3963 220750.0n 0.3486 220999.9n 0.3486 221000.0n 0.5187 221249.9n 0.5187 221250.0n 0.3282 221499.9n 0.3282 221500.0n 0.4303 221749.9n 0.4303 221750.0n 0.4643 221999.9n 0.4643 222000.0n 0.4371 222249.9n 0.4371 222250.0n 0.4371 222499.9n 0.4371 222500.0n 0.4371 222749.9n 0.4371 222750.0n 0.4099 222999.9n 0.4099 223000.0n 0.4235 223249.9n 0.4235 223250.0n 0.6003 223499.9n 0.6003 223500.0n 0.3554 223749.9n 0.3554 223750.0n 0.4643 223999.9n 0.4643 224000.0n 0.4779 224249.9n 0.4779 224250.0n 0.4507 224499.9n 0.4507 224500.0n 0.3623 224749.9n 0.3623 224750.0n 0.3691 224999.9n 0.3691 225000.0n 0.4643 225249.9n 0.4643 225250.0n 0.4711 225499.9n 0.4711 225500.0n 0.5187 225749.9n 0.5187 225750.0n 0.4915 225999.9n 0.4915 226000.0n 0.4711 226249.9n 0.4711 226250.0n 0.3963 226499.9n 0.3963 226500.0n 0.4439 226749.9n 0.4439 226750.0n 0.4235 226999.9n 0.4235 227000.0n 0.5935 227249.9n 0.5935 227250.0n 0.3486 227499.9n 0.3486 227500.0n 0.3827 227749.9n 0.3827 227750.0n 0.4983 227999.9n 0.4983 228000.0n 0.3963 228249.9n 0.3963 228250.0n 0.3486 228499.9n 0.3486 228500.0n 0.5187 228749.9n 0.5187 228750.0n 0.3282 228999.9n 0.3282 229000.0n 0.4303 229249.9n 0.4303 229250.0n 0.4643 229499.9n 0.4643 229500.0n 0.4371 229749.9n 0.4371 229750.0n 0.4371 229999.9n 0.4371 230000.0n 0.4371 230249.9n 0.4371 230250.0n 0.4099 230499.9n 0.4099 230500.0n 0.4235 230749.9n 0.4235 230750.0n 0.6003 230999.9n 0.6003 231000.0n 0.3554 231249.9n 0.3554 231250.0n 0.4643 231499.9n 0.4643 231500.0n 0.4779 231749.9n 0.4779 231750.0n 0.4507 231999.9n 0.4507 232000.0n 0.3623 232249.9n 0.3623 232250.0n 0.3691 232499.9n 0.3691 232500.0n 0.4643 232749.9n 0.4643 232750.0n 0.4711 232999.9n 0.4711 233000.0n 0.5187 233249.9n 0.5187 233250.0n 0.4915 233499.9n 0.4915 233500.0n 0.4711 233749.9n 0.4711 233750.0n 0.3963 233999.9n 0.3963 234000.0n 0.4439 234249.9n 0.4439 234250.0n 0.4235 234499.9n 0.4235 234500.0n 0.5935 234749.9n 0.5935 234750.0n 0.3486 234999.9n 0.3486 235000.0n 0.3827 235249.9n 0.3827 235250.0n 0.4983 235499.9n 0.4983 235500.0n 0.3963 235749.9n 0.3963 235750.0n 0.3486 235999.9n 0.3486 236000.0n 0.5187 236249.9n 0.5187 236250.0n 0.3282 236499.9n 0.3282 236500.0n 0.4303 236749.9n 0.4303 236750.0n 0.4643 236999.9n 0.4643 237000.0n 0.4371 237249.9n 0.4371 237250.0n 0.4371 237499.9n 0.4371 237500.0n 0.4371 237749.9n 0.4371 237750.0n 0.4099 237999.9n 0.4099 238000.0n 0.4235 238249.9n 0.4235 238250.0n 0.6003 238499.9n 0.6003 238500.0n 0.3554 238749.9n 0.3554 238750.0n 0.4643 238999.9n 0.4643 239000.0n 0.4779 239249.9n 0.4779 239250.0n 0.4507 239499.9n 0.4507 239500.0n 0.3623 239749.9n 0.3623 239750.0n 0.3691 239999.9n 0.3691 240000.0n 0.4643 240249.9n 0.4643 240250.0n 0.4711 240499.9n 0.4711 240500.0n 0.5187 240749.9n 0.5187 240750.0n 0.4915 240999.9n 0.4915 241000.0n 0.4711 241249.9n 0.4711 241250.0n 0.3963 241499.9n 0.3963 241500.0n 0.4439 241749.9n 0.4439 241750.0n 0.4235 241999.9n 0.4235 242000.0n 0.5935 242249.9n 0.5935 242250.0n 0.3486 242499.9n 0.3486 242500.0n 0.3827 242749.9n 0.3827 242750.0n 0.4983 242999.9n 0.4983 243000.0n 0.3963 243249.9n 0.3963 243250.0n 0.3486 243499.9n 0.3486 243500.0n 0.5187 243749.9n 0.5187 243750.0n 0.3282 243999.9n 0.3282 244000.0n 0.4303 244249.9n 0.4303 244250.0n 0.4643 244499.9n 0.4643 244500.0n 0.4371 244749.9n 0.4371 244750.0n 0.4371 244999.9n 0.4371 245000.0n 0.4371 245249.9n 0.4371 245250.0n 0.4099 245499.9n 0.4099 245500.0n 0.4235 245749.9n 0.4235 245750.0n 0.6003 245999.9n 0.6003 246000.0n 0.3554 246249.9n 0.3554 246250.0n 0.4643 246499.9n 0.4643 246500.0n 0.4779 246749.9n 0.4779 246750.0n 0.4507 246999.9n 0.4507 247000.0n 0.3623 247249.9n 0.3623 247250.0n 0.3691 247499.9n 0.3691 247500.0n 0.4643 247749.9n 0.4643 247750.0n 0.4711 247999.9n 0.4711 248000.0n 0.5187 248249.9n 0.5187 248250.0n 0.4915 248499.9n 0.4915 248500.0n 0.4711 248749.9n 0.4711 248750.0n 0.3963 248999.9n 0.3963 249000.0n 0.4439 249249.9n 0.4439 249250.0n 0.4235 249499.9n 0.4235 249500.0n 0.5935 249749.9n 0.5935 249750.0n 0.3486 249999.9n 0.3486 250000.0n 0.3827 250249.9n 0.3827 250250.0n 0.4983 250499.9n 0.4983 250500.0n 0.3963 250749.9n 0.3963 250750.0n 0.3486 250999.9n 0.3486 251000.0n 0.5187 251249.9n 0.5187 251250.0n 0.3282 251499.9n 0.3282 251500.0n 0.4303 251749.9n 0.4303 251750.0n 0.4643 251999.9n 0.4643 252000.0n 0.4371 252249.9n 0.4371 252250.0n 0.4371 252499.9n 0.4371 252500.0n 0.4371 252749.9n 0.4371 252750.0n 0.4099 252999.9n 0.4099 253000.0n 0.4235 253249.9n 0.4235 253250.0n 0.6003 253499.9n 0.6003 253500.0n 0.3554 253749.9n 0.3554 253750.0n 0.4643 253999.9n 0.4643 254000.0n 0.4779 254249.9n 0.4779 254250.0n 0.4507 254499.9n 0.4507 254500.0n 0.3623 254749.9n 0.3623 254750.0n 0.3691 254999.9n 0.3691 255000.0n 0.4643 255249.9n 0.4643 255250.0n 0.4711 255499.9n 0.4711 255500.0n 0.5187 255749.9n 0.5187 255750.0n 0.4915 255999.9n 0.4915 256000.0n 0.4711 256249.9n 0.4711 256250.0n 0.3963 256499.9n 0.3963 256500.0n 0.4439 256749.9n 0.4439 256750.0n 0.4235 256999.9n 0.4235 257000.0n 0.5935 257249.9n 0.5935 257250.0n 0.3486 257499.9n 0.3486 257500.0n 0.3827 257749.9n 0.3827 257750.0n 0.4983 257999.9n 0.4983 258000.0n 0.3963 258249.9n 0.3963 258250.0n 0.3486 258499.9n 0.3486 258500.0n 0.5187 258749.9n 0.5187 258750.0n 0.3282 258999.9n 0.3282 259000.0n 0.4303 259249.9n 0.4303 259250.0n 0.4643 259499.9n 0.4643 259500.0n 0.4371 259749.9n 0.4371 259750.0n 0.4371 259999.9n 0.4371 260000.0n 0.4371 260249.9n 0.4371 260250.0n 0.4099 260499.9n 0.4099 260500.0n 0.4235 260749.9n 0.4235 260750.0n 0.6003 260999.9n 0.6003 261000.0n 0.3554 261249.9n 0.3554 261250.0n 0.4643 261499.9n 0.4643 261500.0n 0.4779 261749.9n 0.4779 261750.0n 0.4507 261999.9n 0.4507 262000.0n 0.3623 262249.9n 0.3623 262250.0n 0.3691 262499.9n 0.3691 262500.0n 0.4643 262749.9n 0.4643 262750.0n 0.4711 262999.9n 0.4711 263000.0n 0.5187 263249.9n 0.5187 263250.0n 0.4915 263499.9n 0.4915 263500.0n 0.4711 263749.9n 0.4711 263750.0n 0.3963 263999.9n 0.3963 264000.0n 0.4439 264249.9n 0.4439 264250.0n 0.4235 264499.9n 0.4235 264500.0n 0.5935 264749.9n 0.5935 264750.0n 0.3486 264999.9n 0.3486 265000.0n 0.3827 265249.9n 0.3827 265250.0n 0.4983 265499.9n 0.4983 265500.0n 0.3963 265749.9n 0.3963 265750.0n 0.3486 265999.9n 0.3486 266000.0n 0.5187 266249.9n 0.5187 266250.0n 0.3282 266499.9n 0.3282 266500.0n 0.4303 266749.9n 0.4303 266750.0n 0.4643 266999.9n 0.4643 267000.0n 0.4371 267249.9n 0.4371 267250.0n 0.4371 267499.9n 0.4371 267500.0n 0.4371 267749.9n 0.4371 267750.0n 0.4099 267999.9n 0.4099 268000.0n 0.4235 268249.9n 0.4235 268250.0n 0.6003 268499.9n 0.6003 268500.0n 0.3554 268749.9n 0.3554 268750.0n 0.4643 268999.9n 0.4643 269000.0n 0.4779 269249.9n 0.4779 269250.0n 0.4507 269499.9n 0.4507 269500.0n 0.3623 269749.9n 0.3623 269750.0n 0.3691 269999.9n 0.3691 270000.0n 0.4643 270249.9n 0.4643 270250.0n 0.4711 270499.9n 0.4711 270500.0n 0.5187 270749.9n 0.5187 270750.0n 0.4915 270999.9n 0.4915 271000.0n 0.4711 271249.9n 0.4711 271250.0n 0.3963 271499.9n 0.3963 271500.0n 0.4439 271749.9n 0.4439 271750.0n 0.4235 271999.9n 0.4235 272000.0n 0.5935 272249.9n 0.5935 272250.0n 0.3486 272499.9n 0.3486 272500.0n 0.3827 272749.9n 0.3827 272750.0n 0.4983 272999.9n 0.4983 273000.0n 0.3963 273249.9n 0.3963 273250.0n 0.3486 273499.9n 0.3486 273500.0n 0.5187 273749.9n 0.5187 273750.0n 0.3282 273999.9n 0.3282 274000.0n 0.4303 274249.9n 0.4303 274250.0n 0.4643 274499.9n 0.4643 274500.0n 0.4371 274749.9n 0.4371 274750.0n 0.4371 274999.9n 0.4371 275000.0n 0.4371 275249.9n 0.4371 275250.0n 0.4099 275499.9n 0.4099 275500.0n 0.4235 275749.9n 0.4235 275750.0n 0.6003 275999.9n 0.6003 276000.0n 0.3554 276249.9n 0.3554 276250.0n 0.4643 276499.9n 0.4643 276500.0n 0.4779 276749.9n 0.4779 276750.0n 0.4507 276999.9n 0.4507 277000.0n 0.3623 277249.9n 0.3623 277250.0n 0.3691 277499.9n 0.3691 277500.0n 0.4643 277749.9n 0.4643 277750.0n 0.4711 277999.9n 0.4711 278000.0n 0.5187 278249.9n 0.5187 278250.0n 0.4915 278499.9n 0.4915 278500.0n 0.4711 278749.9n 0.4711 278750.0n 0.3963 278999.9n 0.3963 279000.0n 0.4439 279249.9n 0.4439 279250.0n 0.4235 279499.9n 0.4235 279500.0n 0.5935 279749.9n 0.5935 279750.0n 0.3486 279999.9n 0.3486 280000.0n 0.3827 280249.9n 0.3827 280250.0n 0.4983 280499.9n 0.4983 280500.0n 0.3963 280749.9n 0.3963 280750.0n 0.3486 280999.9n 0.3486 281000.0n 0.5187 281249.9n 0.5187 281250.0n 0.3282 281499.9n 0.3282 281500.0n 0.4303 281749.9n 0.4303 281750.0n 0.4643 281999.9n 0.4643 282000.0n 0.4371 282249.9n 0.4371 282250.0n 0.4371 282499.9n 0.4371 282500.0n 0.4371 282749.9n 0.4371 282750.0n 0.4099 282999.9n 0.4099 283000.0n 0.4235 283249.9n 0.4235 283250.0n 0.6003 283499.9n 0.6003 283500.0n 0.3554 283749.9n 0.3554 283750.0n 0.4643 283999.9n 0.4643 284000.0n 0.4779 284249.9n 0.4779 284250.0n 0.4507 284499.9n 0.4507 284500.0n 0.3623 284749.9n 0.3623 284750.0n 0.3691 284999.9n 0.3691 285000.0n 0.4643 285249.9n 0.4643 285250.0n 0.4711 285499.9n 0.4711 285500.0n 0.5187 285749.9n 0.5187 285750.0n 0.4915 285999.9n 0.4915 286000.0n 0.4711 286249.9n 0.4711 286250.0n 0.3963 286499.9n 0.3963 286500.0n 0.4439 286749.9n 0.4439 286750.0n 0.4235 286999.9n 0.4235 287000.0n 0.5935 287249.9n 0.5935 287250.0n 0.3486 287499.9n 0.3486 287500.0n 0.3827 287749.9n 0.3827 287750.0n 0.4983 287999.9n 0.4983 288000.0n 0.3963 288249.9n 0.3963 288250.0n 0.3486 288499.9n 0.3486 288500.0n 0.5187 288749.9n 0.5187 288750.0n 0.3282 288999.9n 0.3282 289000.0n 0.4303 289249.9n 0.4303 289250.0n 0.4643 289499.9n 0.4643 289500.0n 0.4371 289749.9n 0.4371 289750.0n 0.4371 289999.9n 0.4371 290000.0n 0.4371 290249.9n 0.4371 290250.0n 0.4099 290499.9n 0.4099 290500.0n 0.4235 290749.9n 0.4235 290750.0n 0.6003 290999.9n 0.6003 291000.0n 0.3554 291249.9n 0.3554 291250.0n 0.4643 291499.9n 0.4643 291500.0n 0.4779 291749.9n 0.4779 291750.0n 0.4507 291999.9n 0.4507 292000.0n 0.3623 292249.9n 0.3623 292250.0n 0.3691 292499.9n 0.3691 292500.0n 0.4643 292749.9n 0.4643 292750.0n 0.4711 292999.9n 0.4711 293000.0n 0.5187 293249.9n 0.5187 293250.0n 0.4915 293499.9n 0.4915 293500.0n 0.4711 293749.9n 0.4711 293750.0n 0.3963 293999.9n 0.3963 294000.0n 0.4439 294249.9n 0.4439 294250.0n 0.4235 294499.9n 0.4235 294500.0n 0.5935 294749.9n 0.5935 294750.0n 0.3486 294999.9n 0.3486 295000.0n 0.3827 295249.9n 0.3827 295250.0n 0.4983 295499.9n 0.4983 295500.0n 0.3963 295749.9n 0.3963 295750.0n 0.3486 295999.9n 0.3486 296000.0n 0.5187 296249.9n 0.5187 296250.0n 0.3282 296499.9n 0.3282 296500.0n 0.4303 296749.9n 0.4303 296750.0n 0.4643 296999.9n 0.4643 297000.0n 0.4371 297249.9n 0.4371 297250.0n 0.4371 297499.9n 0.4371 297500.0n 0.4371 297749.9n 0.4371 297750.0n 0.4099 297999.9n 0.4099 298000.0n 0.4235 298249.9n 0.4235 298250.0n 0.6003 298499.9n 0.6003 298500.0n 0.3554 298749.9n 0.3554 298750.0n 0.4643 298999.9n 0.4643 299000.0n 0.4779 299249.9n 0.4779 299250.0n 0.4507 299499.9n 0.4507 299500.0n 0.3623 299749.9n 0.3623 299750.0n 0.3691)
Vxp15 a_xp15 0 PWL(0.0n 0.5170 249.9n 0.5170 250.0n 0.4546 499.9n 0.4546 500.0n 0.4339 749.9n 0.4339 750.0n 0.4443 999.9n 0.4443 1000.0n 0.4858 1249.9n 0.4858 1250.0n 0.4339 1499.9n 0.4339 1500.0n 0.4650 1749.9n 0.4650 1750.0n 0.4339 1999.9n 0.4339 2000.0n 0.4339 2249.9n 0.4339 2250.0n 0.7560 2499.9n 0.7560 2500.0n 0.4962 2749.9n 0.4962 2750.0n 0.4546 2999.9n 0.4546 3000.0n 0.4339 3249.9n 0.4339 3250.0n 0.8000 3499.9n 0.8000 3500.0n 0.4339 3749.9n 0.4339 3750.0n 0.4962 3999.9n 0.4962 4000.0n 0.4754 4249.9n 0.4754 4250.0n 0.4650 4499.9n 0.4650 4500.0n 0.5794 4749.9n 0.5794 4750.0n 0.4339 4999.9n 0.4339 5000.0n 0.4754 5249.9n 0.4754 5250.0n 0.4546 5499.9n 0.4546 5500.0n 0.4443 5749.9n 0.4443 5750.0n 0.4339 5999.9n 0.4339 6000.0n 0.5586 6249.9n 0.5586 6250.0n 0.4339 6499.9n 0.4339 6500.0n 0.4339 6749.9n 0.4339 6750.0n 0.4443 6999.9n 0.4443 7000.0n 0.5274 7249.9n 0.5274 7250.0n 0.5898 7499.9n 0.5898 7500.0n 0.5170 7749.9n 0.5170 7750.0n 0.4546 7999.9n 0.4546 8000.0n 0.4339 8249.9n 0.4339 8250.0n 0.4443 8499.9n 0.4443 8500.0n 0.4858 8749.9n 0.4858 8750.0n 0.4339 8999.9n 0.4339 9000.0n 0.4650 9249.9n 0.4650 9250.0n 0.4339 9499.9n 0.4339 9500.0n 0.4339 9749.9n 0.4339 9750.0n 0.7560 9999.9n 0.7560 10000.0n 0.4962 10249.9n 0.4962 10250.0n 0.4546 10499.9n 0.4546 10500.0n 0.4339 10749.9n 0.4339 10750.0n 0.8000 10999.9n 0.8000 11000.0n 0.4339 11249.9n 0.4339 11250.0n 0.4962 11499.9n 0.4962 11500.0n 0.4754 11749.9n 0.4754 11750.0n 0.4650 11999.9n 0.4650 12000.0n 0.5794 12249.9n 0.5794 12250.0n 0.4339 12499.9n 0.4339 12500.0n 0.4754 12749.9n 0.4754 12750.0n 0.4546 12999.9n 0.4546 13000.0n 0.4443 13249.9n 0.4443 13250.0n 0.4339 13499.9n 0.4339 13500.0n 0.5586 13749.9n 0.5586 13750.0n 0.4339 13999.9n 0.4339 14000.0n 0.4339 14249.9n 0.4339 14250.0n 0.4443 14499.9n 0.4443 14500.0n 0.5274 14749.9n 0.5274 14750.0n 0.5898 14999.9n 0.5898 15000.0n 0.5170 15249.9n 0.5170 15250.0n 0.4546 15499.9n 0.4546 15500.0n 0.4339 15749.9n 0.4339 15750.0n 0.4443 15999.9n 0.4443 16000.0n 0.4858 16249.9n 0.4858 16250.0n 0.4339 16499.9n 0.4339 16500.0n 0.4650 16749.9n 0.4650 16750.0n 0.4339 16999.9n 0.4339 17000.0n 0.4339 17249.9n 0.4339 17250.0n 0.7560 17499.9n 0.7560 17500.0n 0.4962 17749.9n 0.4962 17750.0n 0.4546 17999.9n 0.4546 18000.0n 0.4339 18249.9n 0.4339 18250.0n 0.8000 18499.9n 0.8000 18500.0n 0.4339 18749.9n 0.4339 18750.0n 0.4962 18999.9n 0.4962 19000.0n 0.4754 19249.9n 0.4754 19250.0n 0.4650 19499.9n 0.4650 19500.0n 0.5794 19749.9n 0.5794 19750.0n 0.4339 19999.9n 0.4339 20000.0n 0.4754 20249.9n 0.4754 20250.0n 0.4546 20499.9n 0.4546 20500.0n 0.4443 20749.9n 0.4443 20750.0n 0.4339 20999.9n 0.4339 21000.0n 0.5586 21249.9n 0.5586 21250.0n 0.4339 21499.9n 0.4339 21500.0n 0.4339 21749.9n 0.4339 21750.0n 0.4443 21999.9n 0.4443 22000.0n 0.5274 22249.9n 0.5274 22250.0n 0.5898 22499.9n 0.5898 22500.0n 0.5170 22749.9n 0.5170 22750.0n 0.4546 22999.9n 0.4546 23000.0n 0.4339 23249.9n 0.4339 23250.0n 0.4443 23499.9n 0.4443 23500.0n 0.4858 23749.9n 0.4858 23750.0n 0.4339 23999.9n 0.4339 24000.0n 0.4650 24249.9n 0.4650 24250.0n 0.4339 24499.9n 0.4339 24500.0n 0.4339 24749.9n 0.4339 24750.0n 0.7560 24999.9n 0.7560 25000.0n 0.4962 25249.9n 0.4962 25250.0n 0.4546 25499.9n 0.4546 25500.0n 0.4339 25749.9n 0.4339 25750.0n 0.8000 25999.9n 0.8000 26000.0n 0.4339 26249.9n 0.4339 26250.0n 0.4962 26499.9n 0.4962 26500.0n 0.4754 26749.9n 0.4754 26750.0n 0.4650 26999.9n 0.4650 27000.0n 0.5794 27249.9n 0.5794 27250.0n 0.4339 27499.9n 0.4339 27500.0n 0.4754 27749.9n 0.4754 27750.0n 0.4546 27999.9n 0.4546 28000.0n 0.4443 28249.9n 0.4443 28250.0n 0.4339 28499.9n 0.4339 28500.0n 0.5586 28749.9n 0.5586 28750.0n 0.4339 28999.9n 0.4339 29000.0n 0.4339 29249.9n 0.4339 29250.0n 0.4443 29499.9n 0.4443 29500.0n 0.5274 29749.9n 0.5274 29750.0n 0.5898 29999.9n 0.5898 30000.0n 0.5170 30249.9n 0.5170 30250.0n 0.4546 30499.9n 0.4546 30500.0n 0.4339 30749.9n 0.4339 30750.0n 0.4443 30999.9n 0.4443 31000.0n 0.4858 31249.9n 0.4858 31250.0n 0.4339 31499.9n 0.4339 31500.0n 0.4650 31749.9n 0.4650 31750.0n 0.4339 31999.9n 0.4339 32000.0n 0.4339 32249.9n 0.4339 32250.0n 0.7560 32499.9n 0.7560 32500.0n 0.4962 32749.9n 0.4962 32750.0n 0.4546 32999.9n 0.4546 33000.0n 0.4339 33249.9n 0.4339 33250.0n 0.8000 33499.9n 0.8000 33500.0n 0.4339 33749.9n 0.4339 33750.0n 0.4962 33999.9n 0.4962 34000.0n 0.4754 34249.9n 0.4754 34250.0n 0.4650 34499.9n 0.4650 34500.0n 0.5794 34749.9n 0.5794 34750.0n 0.4339 34999.9n 0.4339 35000.0n 0.4754 35249.9n 0.4754 35250.0n 0.4546 35499.9n 0.4546 35500.0n 0.4443 35749.9n 0.4443 35750.0n 0.4339 35999.9n 0.4339 36000.0n 0.5586 36249.9n 0.5586 36250.0n 0.4339 36499.9n 0.4339 36500.0n 0.4339 36749.9n 0.4339 36750.0n 0.4443 36999.9n 0.4443 37000.0n 0.5274 37249.9n 0.5274 37250.0n 0.5898 37499.9n 0.5898 37500.0n 0.5170 37749.9n 0.5170 37750.0n 0.4546 37999.9n 0.4546 38000.0n 0.4339 38249.9n 0.4339 38250.0n 0.4443 38499.9n 0.4443 38500.0n 0.4858 38749.9n 0.4858 38750.0n 0.4339 38999.9n 0.4339 39000.0n 0.4650 39249.9n 0.4650 39250.0n 0.4339 39499.9n 0.4339 39500.0n 0.4339 39749.9n 0.4339 39750.0n 0.7560 39999.9n 0.7560 40000.0n 0.4962 40249.9n 0.4962 40250.0n 0.4546 40499.9n 0.4546 40500.0n 0.4339 40749.9n 0.4339 40750.0n 0.8000 40999.9n 0.8000 41000.0n 0.4339 41249.9n 0.4339 41250.0n 0.4962 41499.9n 0.4962 41500.0n 0.4754 41749.9n 0.4754 41750.0n 0.4650 41999.9n 0.4650 42000.0n 0.5794 42249.9n 0.5794 42250.0n 0.4339 42499.9n 0.4339 42500.0n 0.4754 42749.9n 0.4754 42750.0n 0.4546 42999.9n 0.4546 43000.0n 0.4443 43249.9n 0.4443 43250.0n 0.4339 43499.9n 0.4339 43500.0n 0.5586 43749.9n 0.5586 43750.0n 0.4339 43999.9n 0.4339 44000.0n 0.4339 44249.9n 0.4339 44250.0n 0.4443 44499.9n 0.4443 44500.0n 0.5274 44749.9n 0.5274 44750.0n 0.5898 44999.9n 0.5898 45000.0n 0.5170 45249.9n 0.5170 45250.0n 0.4546 45499.9n 0.4546 45500.0n 0.4339 45749.9n 0.4339 45750.0n 0.4443 45999.9n 0.4443 46000.0n 0.4858 46249.9n 0.4858 46250.0n 0.4339 46499.9n 0.4339 46500.0n 0.4650 46749.9n 0.4650 46750.0n 0.4339 46999.9n 0.4339 47000.0n 0.4339 47249.9n 0.4339 47250.0n 0.7560 47499.9n 0.7560 47500.0n 0.4962 47749.9n 0.4962 47750.0n 0.4546 47999.9n 0.4546 48000.0n 0.4339 48249.9n 0.4339 48250.0n 0.8000 48499.9n 0.8000 48500.0n 0.4339 48749.9n 0.4339 48750.0n 0.4962 48999.9n 0.4962 49000.0n 0.4754 49249.9n 0.4754 49250.0n 0.4650 49499.9n 0.4650 49500.0n 0.5794 49749.9n 0.5794 49750.0n 0.4339 49999.9n 0.4339 50000.0n 0.4754 50249.9n 0.4754 50250.0n 0.4546 50499.9n 0.4546 50500.0n 0.4443 50749.9n 0.4443 50750.0n 0.4339 50999.9n 0.4339 51000.0n 0.5586 51249.9n 0.5586 51250.0n 0.4339 51499.9n 0.4339 51500.0n 0.4339 51749.9n 0.4339 51750.0n 0.4443 51999.9n 0.4443 52000.0n 0.5274 52249.9n 0.5274 52250.0n 0.5898 52499.9n 0.5898 52500.0n 0.5170 52749.9n 0.5170 52750.0n 0.4546 52999.9n 0.4546 53000.0n 0.4339 53249.9n 0.4339 53250.0n 0.4443 53499.9n 0.4443 53500.0n 0.4858 53749.9n 0.4858 53750.0n 0.4339 53999.9n 0.4339 54000.0n 0.4650 54249.9n 0.4650 54250.0n 0.4339 54499.9n 0.4339 54500.0n 0.4339 54749.9n 0.4339 54750.0n 0.7560 54999.9n 0.7560 55000.0n 0.4962 55249.9n 0.4962 55250.0n 0.4546 55499.9n 0.4546 55500.0n 0.4339 55749.9n 0.4339 55750.0n 0.8000 55999.9n 0.8000 56000.0n 0.4339 56249.9n 0.4339 56250.0n 0.4962 56499.9n 0.4962 56500.0n 0.4754 56749.9n 0.4754 56750.0n 0.4650 56999.9n 0.4650 57000.0n 0.5794 57249.9n 0.5794 57250.0n 0.4339 57499.9n 0.4339 57500.0n 0.4754 57749.9n 0.4754 57750.0n 0.4546 57999.9n 0.4546 58000.0n 0.4443 58249.9n 0.4443 58250.0n 0.4339 58499.9n 0.4339 58500.0n 0.5586 58749.9n 0.5586 58750.0n 0.4339 58999.9n 0.4339 59000.0n 0.4339 59249.9n 0.4339 59250.0n 0.4443 59499.9n 0.4443 59500.0n 0.5274 59749.9n 0.5274 59750.0n 0.5898 59999.9n 0.5898 60000.0n 0.5170 60249.9n 0.5170 60250.0n 0.4546 60499.9n 0.4546 60500.0n 0.4339 60749.9n 0.4339 60750.0n 0.4443 60999.9n 0.4443 61000.0n 0.4858 61249.9n 0.4858 61250.0n 0.4339 61499.9n 0.4339 61500.0n 0.4650 61749.9n 0.4650 61750.0n 0.4339 61999.9n 0.4339 62000.0n 0.4339 62249.9n 0.4339 62250.0n 0.7560 62499.9n 0.7560 62500.0n 0.4962 62749.9n 0.4962 62750.0n 0.4546 62999.9n 0.4546 63000.0n 0.4339 63249.9n 0.4339 63250.0n 0.8000 63499.9n 0.8000 63500.0n 0.4339 63749.9n 0.4339 63750.0n 0.4962 63999.9n 0.4962 64000.0n 0.4754 64249.9n 0.4754 64250.0n 0.4650 64499.9n 0.4650 64500.0n 0.5794 64749.9n 0.5794 64750.0n 0.4339 64999.9n 0.4339 65000.0n 0.4754 65249.9n 0.4754 65250.0n 0.4546 65499.9n 0.4546 65500.0n 0.4443 65749.9n 0.4443 65750.0n 0.4339 65999.9n 0.4339 66000.0n 0.5586 66249.9n 0.5586 66250.0n 0.4339 66499.9n 0.4339 66500.0n 0.4339 66749.9n 0.4339 66750.0n 0.4443 66999.9n 0.4443 67000.0n 0.5274 67249.9n 0.5274 67250.0n 0.5898 67499.9n 0.5898 67500.0n 0.5170 67749.9n 0.5170 67750.0n 0.4546 67999.9n 0.4546 68000.0n 0.4339 68249.9n 0.4339 68250.0n 0.4443 68499.9n 0.4443 68500.0n 0.4858 68749.9n 0.4858 68750.0n 0.4339 68999.9n 0.4339 69000.0n 0.4650 69249.9n 0.4650 69250.0n 0.4339 69499.9n 0.4339 69500.0n 0.4339 69749.9n 0.4339 69750.0n 0.7560 69999.9n 0.7560 70000.0n 0.4962 70249.9n 0.4962 70250.0n 0.4546 70499.9n 0.4546 70500.0n 0.4339 70749.9n 0.4339 70750.0n 0.8000 70999.9n 0.8000 71000.0n 0.4339 71249.9n 0.4339 71250.0n 0.4962 71499.9n 0.4962 71500.0n 0.4754 71749.9n 0.4754 71750.0n 0.4650 71999.9n 0.4650 72000.0n 0.5794 72249.9n 0.5794 72250.0n 0.4339 72499.9n 0.4339 72500.0n 0.4754 72749.9n 0.4754 72750.0n 0.4546 72999.9n 0.4546 73000.0n 0.4443 73249.9n 0.4443 73250.0n 0.4339 73499.9n 0.4339 73500.0n 0.5586 73749.9n 0.5586 73750.0n 0.4339 73999.9n 0.4339 74000.0n 0.4339 74249.9n 0.4339 74250.0n 0.4443 74499.9n 0.4443 74500.0n 0.5274 74749.9n 0.5274 74750.0n 0.5898 74999.9n 0.5898 75000.0n 0.5170 75249.9n 0.5170 75250.0n 0.4546 75499.9n 0.4546 75500.0n 0.4339 75749.9n 0.4339 75750.0n 0.4443 75999.9n 0.4443 76000.0n 0.4858 76249.9n 0.4858 76250.0n 0.4339 76499.9n 0.4339 76500.0n 0.4650 76749.9n 0.4650 76750.0n 0.4339 76999.9n 0.4339 77000.0n 0.4339 77249.9n 0.4339 77250.0n 0.7560 77499.9n 0.7560 77500.0n 0.4962 77749.9n 0.4962 77750.0n 0.4546 77999.9n 0.4546 78000.0n 0.4339 78249.9n 0.4339 78250.0n 0.8000 78499.9n 0.8000 78500.0n 0.4339 78749.9n 0.4339 78750.0n 0.4962 78999.9n 0.4962 79000.0n 0.4754 79249.9n 0.4754 79250.0n 0.4650 79499.9n 0.4650 79500.0n 0.5794 79749.9n 0.5794 79750.0n 0.4339 79999.9n 0.4339 80000.0n 0.4754 80249.9n 0.4754 80250.0n 0.4546 80499.9n 0.4546 80500.0n 0.4443 80749.9n 0.4443 80750.0n 0.4339 80999.9n 0.4339 81000.0n 0.5586 81249.9n 0.5586 81250.0n 0.4339 81499.9n 0.4339 81500.0n 0.4339 81749.9n 0.4339 81750.0n 0.4443 81999.9n 0.4443 82000.0n 0.5274 82249.9n 0.5274 82250.0n 0.5898 82499.9n 0.5898 82500.0n 0.5170 82749.9n 0.5170 82750.0n 0.4546 82999.9n 0.4546 83000.0n 0.4339 83249.9n 0.4339 83250.0n 0.4443 83499.9n 0.4443 83500.0n 0.4858 83749.9n 0.4858 83750.0n 0.4339 83999.9n 0.4339 84000.0n 0.4650 84249.9n 0.4650 84250.0n 0.4339 84499.9n 0.4339 84500.0n 0.4339 84749.9n 0.4339 84750.0n 0.7560 84999.9n 0.7560 85000.0n 0.4962 85249.9n 0.4962 85250.0n 0.4546 85499.9n 0.4546 85500.0n 0.4339 85749.9n 0.4339 85750.0n 0.8000 85999.9n 0.8000 86000.0n 0.4339 86249.9n 0.4339 86250.0n 0.4962 86499.9n 0.4962 86500.0n 0.4754 86749.9n 0.4754 86750.0n 0.4650 86999.9n 0.4650 87000.0n 0.5794 87249.9n 0.5794 87250.0n 0.4339 87499.9n 0.4339 87500.0n 0.4754 87749.9n 0.4754 87750.0n 0.4546 87999.9n 0.4546 88000.0n 0.4443 88249.9n 0.4443 88250.0n 0.4339 88499.9n 0.4339 88500.0n 0.5586 88749.9n 0.5586 88750.0n 0.4339 88999.9n 0.4339 89000.0n 0.4339 89249.9n 0.4339 89250.0n 0.4443 89499.9n 0.4443 89500.0n 0.5274 89749.9n 0.5274 89750.0n 0.5898 89999.9n 0.5898 90000.0n 0.5170 90249.9n 0.5170 90250.0n 0.4546 90499.9n 0.4546 90500.0n 0.4339 90749.9n 0.4339 90750.0n 0.4443 90999.9n 0.4443 91000.0n 0.4858 91249.9n 0.4858 91250.0n 0.4339 91499.9n 0.4339 91500.0n 0.4650 91749.9n 0.4650 91750.0n 0.4339 91999.9n 0.4339 92000.0n 0.4339 92249.9n 0.4339 92250.0n 0.7560 92499.9n 0.7560 92500.0n 0.4962 92749.9n 0.4962 92750.0n 0.4546 92999.9n 0.4546 93000.0n 0.4339 93249.9n 0.4339 93250.0n 0.8000 93499.9n 0.8000 93500.0n 0.4339 93749.9n 0.4339 93750.0n 0.4962 93999.9n 0.4962 94000.0n 0.4754 94249.9n 0.4754 94250.0n 0.4650 94499.9n 0.4650 94500.0n 0.5794 94749.9n 0.5794 94750.0n 0.4339 94999.9n 0.4339 95000.0n 0.4754 95249.9n 0.4754 95250.0n 0.4546 95499.9n 0.4546 95500.0n 0.4443 95749.9n 0.4443 95750.0n 0.4339 95999.9n 0.4339 96000.0n 0.5586 96249.9n 0.5586 96250.0n 0.4339 96499.9n 0.4339 96500.0n 0.4339 96749.9n 0.4339 96750.0n 0.4443 96999.9n 0.4443 97000.0n 0.5274 97249.9n 0.5274 97250.0n 0.5898 97499.9n 0.5898 97500.0n 0.5170 97749.9n 0.5170 97750.0n 0.4546 97999.9n 0.4546 98000.0n 0.4339 98249.9n 0.4339 98250.0n 0.4443 98499.9n 0.4443 98500.0n 0.4858 98749.9n 0.4858 98750.0n 0.4339 98999.9n 0.4339 99000.0n 0.4650 99249.9n 0.4650 99250.0n 0.4339 99499.9n 0.4339 99500.0n 0.4339 99749.9n 0.4339 99750.0n 0.7560 99999.9n 0.7560 100000.0n 0.4962 100249.9n 0.4962 100250.0n 0.4546 100499.9n 0.4546 100500.0n 0.4339 100749.9n 0.4339 100750.0n 0.8000 100999.9n 0.8000 101000.0n 0.4339 101249.9n 0.4339 101250.0n 0.4962 101499.9n 0.4962 101500.0n 0.4754 101749.9n 0.4754 101750.0n 0.4650 101999.9n 0.4650 102000.0n 0.5794 102249.9n 0.5794 102250.0n 0.4339 102499.9n 0.4339 102500.0n 0.4754 102749.9n 0.4754 102750.0n 0.4546 102999.9n 0.4546 103000.0n 0.4443 103249.9n 0.4443 103250.0n 0.4339 103499.9n 0.4339 103500.0n 0.5586 103749.9n 0.5586 103750.0n 0.4339 103999.9n 0.4339 104000.0n 0.4339 104249.9n 0.4339 104250.0n 0.4443 104499.9n 0.4443 104500.0n 0.5274 104749.9n 0.5274 104750.0n 0.5898 104999.9n 0.5898 105000.0n 0.5170 105249.9n 0.5170 105250.0n 0.4546 105499.9n 0.4546 105500.0n 0.4339 105749.9n 0.4339 105750.0n 0.4443 105999.9n 0.4443 106000.0n 0.4858 106249.9n 0.4858 106250.0n 0.4339 106499.9n 0.4339 106500.0n 0.4650 106749.9n 0.4650 106750.0n 0.4339 106999.9n 0.4339 107000.0n 0.4339 107249.9n 0.4339 107250.0n 0.7560 107499.9n 0.7560 107500.0n 0.4962 107749.9n 0.4962 107750.0n 0.4546 107999.9n 0.4546 108000.0n 0.4339 108249.9n 0.4339 108250.0n 0.8000 108499.9n 0.8000 108500.0n 0.4339 108749.9n 0.4339 108750.0n 0.4962 108999.9n 0.4962 109000.0n 0.4754 109249.9n 0.4754 109250.0n 0.4650 109499.9n 0.4650 109500.0n 0.5794 109749.9n 0.5794 109750.0n 0.4339 109999.9n 0.4339 110000.0n 0.4754 110249.9n 0.4754 110250.0n 0.4546 110499.9n 0.4546 110500.0n 0.4443 110749.9n 0.4443 110750.0n 0.4339 110999.9n 0.4339 111000.0n 0.5586 111249.9n 0.5586 111250.0n 0.4339 111499.9n 0.4339 111500.0n 0.4339 111749.9n 0.4339 111750.0n 0.4443 111999.9n 0.4443 112000.0n 0.5274 112249.9n 0.5274 112250.0n 0.5898 112499.9n 0.5898 112500.0n 0.5170 112749.9n 0.5170 112750.0n 0.4546 112999.9n 0.4546 113000.0n 0.4339 113249.9n 0.4339 113250.0n 0.4443 113499.9n 0.4443 113500.0n 0.4858 113749.9n 0.4858 113750.0n 0.4339 113999.9n 0.4339 114000.0n 0.4650 114249.9n 0.4650 114250.0n 0.4339 114499.9n 0.4339 114500.0n 0.4339 114749.9n 0.4339 114750.0n 0.7560 114999.9n 0.7560 115000.0n 0.4962 115249.9n 0.4962 115250.0n 0.4546 115499.9n 0.4546 115500.0n 0.4339 115749.9n 0.4339 115750.0n 0.8000 115999.9n 0.8000 116000.0n 0.4339 116249.9n 0.4339 116250.0n 0.4962 116499.9n 0.4962 116500.0n 0.4754 116749.9n 0.4754 116750.0n 0.4650 116999.9n 0.4650 117000.0n 0.5794 117249.9n 0.5794 117250.0n 0.4339 117499.9n 0.4339 117500.0n 0.4754 117749.9n 0.4754 117750.0n 0.4546 117999.9n 0.4546 118000.0n 0.4443 118249.9n 0.4443 118250.0n 0.4339 118499.9n 0.4339 118500.0n 0.5586 118749.9n 0.5586 118750.0n 0.4339 118999.9n 0.4339 119000.0n 0.4339 119249.9n 0.4339 119250.0n 0.4443 119499.9n 0.4443 119500.0n 0.5274 119749.9n 0.5274 119750.0n 0.5898 119999.9n 0.5898 120000.0n 0.5170 120249.9n 0.5170 120250.0n 0.4546 120499.9n 0.4546 120500.0n 0.4339 120749.9n 0.4339 120750.0n 0.4443 120999.9n 0.4443 121000.0n 0.4858 121249.9n 0.4858 121250.0n 0.4339 121499.9n 0.4339 121500.0n 0.4650 121749.9n 0.4650 121750.0n 0.4339 121999.9n 0.4339 122000.0n 0.4339 122249.9n 0.4339 122250.0n 0.7560 122499.9n 0.7560 122500.0n 0.4962 122749.9n 0.4962 122750.0n 0.4546 122999.9n 0.4546 123000.0n 0.4339 123249.9n 0.4339 123250.0n 0.8000 123499.9n 0.8000 123500.0n 0.4339 123749.9n 0.4339 123750.0n 0.4962 123999.9n 0.4962 124000.0n 0.4754 124249.9n 0.4754 124250.0n 0.4650 124499.9n 0.4650 124500.0n 0.5794 124749.9n 0.5794 124750.0n 0.4339 124999.9n 0.4339 125000.0n 0.4754 125249.9n 0.4754 125250.0n 0.4546 125499.9n 0.4546 125500.0n 0.4443 125749.9n 0.4443 125750.0n 0.4339 125999.9n 0.4339 126000.0n 0.5586 126249.9n 0.5586 126250.0n 0.4339 126499.9n 0.4339 126500.0n 0.4339 126749.9n 0.4339 126750.0n 0.4443 126999.9n 0.4443 127000.0n 0.5274 127249.9n 0.5274 127250.0n 0.5898 127499.9n 0.5898 127500.0n 0.5170 127749.9n 0.5170 127750.0n 0.4546 127999.9n 0.4546 128000.0n 0.4339 128249.9n 0.4339 128250.0n 0.4443 128499.9n 0.4443 128500.0n 0.4858 128749.9n 0.4858 128750.0n 0.4339 128999.9n 0.4339 129000.0n 0.4650 129249.9n 0.4650 129250.0n 0.4339 129499.9n 0.4339 129500.0n 0.4339 129749.9n 0.4339 129750.0n 0.7560 129999.9n 0.7560 130000.0n 0.4962 130249.9n 0.4962 130250.0n 0.4546 130499.9n 0.4546 130500.0n 0.4339 130749.9n 0.4339 130750.0n 0.8000 130999.9n 0.8000 131000.0n 0.4339 131249.9n 0.4339 131250.0n 0.4962 131499.9n 0.4962 131500.0n 0.4754 131749.9n 0.4754 131750.0n 0.4650 131999.9n 0.4650 132000.0n 0.5794 132249.9n 0.5794 132250.0n 0.4339 132499.9n 0.4339 132500.0n 0.4754 132749.9n 0.4754 132750.0n 0.4546 132999.9n 0.4546 133000.0n 0.4443 133249.9n 0.4443 133250.0n 0.4339 133499.9n 0.4339 133500.0n 0.5586 133749.9n 0.5586 133750.0n 0.4339 133999.9n 0.4339 134000.0n 0.4339 134249.9n 0.4339 134250.0n 0.4443 134499.9n 0.4443 134500.0n 0.5274 134749.9n 0.5274 134750.0n 0.5898 134999.9n 0.5898 135000.0n 0.5170 135249.9n 0.5170 135250.0n 0.4546 135499.9n 0.4546 135500.0n 0.4339 135749.9n 0.4339 135750.0n 0.4443 135999.9n 0.4443 136000.0n 0.4858 136249.9n 0.4858 136250.0n 0.4339 136499.9n 0.4339 136500.0n 0.4650 136749.9n 0.4650 136750.0n 0.4339 136999.9n 0.4339 137000.0n 0.4339 137249.9n 0.4339 137250.0n 0.7560 137499.9n 0.7560 137500.0n 0.4962 137749.9n 0.4962 137750.0n 0.4546 137999.9n 0.4546 138000.0n 0.4339 138249.9n 0.4339 138250.0n 0.8000 138499.9n 0.8000 138500.0n 0.4339 138749.9n 0.4339 138750.0n 0.4962 138999.9n 0.4962 139000.0n 0.4754 139249.9n 0.4754 139250.0n 0.4650 139499.9n 0.4650 139500.0n 0.5794 139749.9n 0.5794 139750.0n 0.4339 139999.9n 0.4339 140000.0n 0.4754 140249.9n 0.4754 140250.0n 0.4546 140499.9n 0.4546 140500.0n 0.4443 140749.9n 0.4443 140750.0n 0.4339 140999.9n 0.4339 141000.0n 0.5586 141249.9n 0.5586 141250.0n 0.4339 141499.9n 0.4339 141500.0n 0.4339 141749.9n 0.4339 141750.0n 0.4443 141999.9n 0.4443 142000.0n 0.5274 142249.9n 0.5274 142250.0n 0.5898 142499.9n 0.5898 142500.0n 0.5170 142749.9n 0.5170 142750.0n 0.4546 142999.9n 0.4546 143000.0n 0.4339 143249.9n 0.4339 143250.0n 0.4443 143499.9n 0.4443 143500.0n 0.4858 143749.9n 0.4858 143750.0n 0.4339 143999.9n 0.4339 144000.0n 0.4650 144249.9n 0.4650 144250.0n 0.4339 144499.9n 0.4339 144500.0n 0.4339 144749.9n 0.4339 144750.0n 0.7560 144999.9n 0.7560 145000.0n 0.4962 145249.9n 0.4962 145250.0n 0.4546 145499.9n 0.4546 145500.0n 0.4339 145749.9n 0.4339 145750.0n 0.8000 145999.9n 0.8000 146000.0n 0.4339 146249.9n 0.4339 146250.0n 0.4962 146499.9n 0.4962 146500.0n 0.4754 146749.9n 0.4754 146750.0n 0.4650 146999.9n 0.4650 147000.0n 0.5794 147249.9n 0.5794 147250.0n 0.4339 147499.9n 0.4339 147500.0n 0.4754 147749.9n 0.4754 147750.0n 0.4546 147999.9n 0.4546 148000.0n 0.4443 148249.9n 0.4443 148250.0n 0.4339 148499.9n 0.4339 148500.0n 0.5586 148749.9n 0.5586 148750.0n 0.4339 148999.9n 0.4339 149000.0n 0.4339 149249.9n 0.4339 149250.0n 0.4443 149499.9n 0.4443 149500.0n 0.5274 149749.9n 0.5274 149750.0n 0.5898 149999.9n 0.5898 150000.0n 0.5170 150249.9n 0.5170 150250.0n 0.4546 150499.9n 0.4546 150500.0n 0.4339 150749.9n 0.4339 150750.0n 0.4443 150999.9n 0.4443 151000.0n 0.4858 151249.9n 0.4858 151250.0n 0.4339 151499.9n 0.4339 151500.0n 0.4650 151749.9n 0.4650 151750.0n 0.4339 151999.9n 0.4339 152000.0n 0.4339 152249.9n 0.4339 152250.0n 0.7560 152499.9n 0.7560 152500.0n 0.4962 152749.9n 0.4962 152750.0n 0.4546 152999.9n 0.4546 153000.0n 0.4339 153249.9n 0.4339 153250.0n 0.8000 153499.9n 0.8000 153500.0n 0.4339 153749.9n 0.4339 153750.0n 0.4962 153999.9n 0.4962 154000.0n 0.4754 154249.9n 0.4754 154250.0n 0.4650 154499.9n 0.4650 154500.0n 0.5794 154749.9n 0.5794 154750.0n 0.4339 154999.9n 0.4339 155000.0n 0.4754 155249.9n 0.4754 155250.0n 0.4546 155499.9n 0.4546 155500.0n 0.4443 155749.9n 0.4443 155750.0n 0.4339 155999.9n 0.4339 156000.0n 0.5586 156249.9n 0.5586 156250.0n 0.4339 156499.9n 0.4339 156500.0n 0.4339 156749.9n 0.4339 156750.0n 0.4443 156999.9n 0.4443 157000.0n 0.5274 157249.9n 0.5274 157250.0n 0.5898 157499.9n 0.5898 157500.0n 0.5170 157749.9n 0.5170 157750.0n 0.4546 157999.9n 0.4546 158000.0n 0.4339 158249.9n 0.4339 158250.0n 0.4443 158499.9n 0.4443 158500.0n 0.4858 158749.9n 0.4858 158750.0n 0.4339 158999.9n 0.4339 159000.0n 0.4650 159249.9n 0.4650 159250.0n 0.4339 159499.9n 0.4339 159500.0n 0.4339 159749.9n 0.4339 159750.0n 0.7560 159999.9n 0.7560 160000.0n 0.4962 160249.9n 0.4962 160250.0n 0.4546 160499.9n 0.4546 160500.0n 0.4339 160749.9n 0.4339 160750.0n 0.8000 160999.9n 0.8000 161000.0n 0.4339 161249.9n 0.4339 161250.0n 0.4962 161499.9n 0.4962 161500.0n 0.4754 161749.9n 0.4754 161750.0n 0.4650 161999.9n 0.4650 162000.0n 0.5794 162249.9n 0.5794 162250.0n 0.4339 162499.9n 0.4339 162500.0n 0.4754 162749.9n 0.4754 162750.0n 0.4546 162999.9n 0.4546 163000.0n 0.4443 163249.9n 0.4443 163250.0n 0.4339 163499.9n 0.4339 163500.0n 0.5586 163749.9n 0.5586 163750.0n 0.4339 163999.9n 0.4339 164000.0n 0.4339 164249.9n 0.4339 164250.0n 0.4443 164499.9n 0.4443 164500.0n 0.5274 164749.9n 0.5274 164750.0n 0.5898 164999.9n 0.5898 165000.0n 0.5170 165249.9n 0.5170 165250.0n 0.4546 165499.9n 0.4546 165500.0n 0.4339 165749.9n 0.4339 165750.0n 0.4443 165999.9n 0.4443 166000.0n 0.4858 166249.9n 0.4858 166250.0n 0.4339 166499.9n 0.4339 166500.0n 0.4650 166749.9n 0.4650 166750.0n 0.4339 166999.9n 0.4339 167000.0n 0.4339 167249.9n 0.4339 167250.0n 0.7560 167499.9n 0.7560 167500.0n 0.4962 167749.9n 0.4962 167750.0n 0.4546 167999.9n 0.4546 168000.0n 0.4339 168249.9n 0.4339 168250.0n 0.8000 168499.9n 0.8000 168500.0n 0.4339 168749.9n 0.4339 168750.0n 0.4962 168999.9n 0.4962 169000.0n 0.4754 169249.9n 0.4754 169250.0n 0.4650 169499.9n 0.4650 169500.0n 0.5794 169749.9n 0.5794 169750.0n 0.4339 169999.9n 0.4339 170000.0n 0.4754 170249.9n 0.4754 170250.0n 0.4546 170499.9n 0.4546 170500.0n 0.4443 170749.9n 0.4443 170750.0n 0.4339 170999.9n 0.4339 171000.0n 0.5586 171249.9n 0.5586 171250.0n 0.4339 171499.9n 0.4339 171500.0n 0.4339 171749.9n 0.4339 171750.0n 0.4443 171999.9n 0.4443 172000.0n 0.5274 172249.9n 0.5274 172250.0n 0.5898 172499.9n 0.5898 172500.0n 0.5170 172749.9n 0.5170 172750.0n 0.4546 172999.9n 0.4546 173000.0n 0.4339 173249.9n 0.4339 173250.0n 0.4443 173499.9n 0.4443 173500.0n 0.4858 173749.9n 0.4858 173750.0n 0.4339 173999.9n 0.4339 174000.0n 0.4650 174249.9n 0.4650 174250.0n 0.4339 174499.9n 0.4339 174500.0n 0.4339 174749.9n 0.4339 174750.0n 0.7560 174999.9n 0.7560 175000.0n 0.4962 175249.9n 0.4962 175250.0n 0.4546 175499.9n 0.4546 175500.0n 0.4339 175749.9n 0.4339 175750.0n 0.8000 175999.9n 0.8000 176000.0n 0.4339 176249.9n 0.4339 176250.0n 0.4962 176499.9n 0.4962 176500.0n 0.4754 176749.9n 0.4754 176750.0n 0.4650 176999.9n 0.4650 177000.0n 0.5794 177249.9n 0.5794 177250.0n 0.4339 177499.9n 0.4339 177500.0n 0.4754 177749.9n 0.4754 177750.0n 0.4546 177999.9n 0.4546 178000.0n 0.4443 178249.9n 0.4443 178250.0n 0.4339 178499.9n 0.4339 178500.0n 0.5586 178749.9n 0.5586 178750.0n 0.4339 178999.9n 0.4339 179000.0n 0.4339 179249.9n 0.4339 179250.0n 0.4443 179499.9n 0.4443 179500.0n 0.5274 179749.9n 0.5274 179750.0n 0.5898 179999.9n 0.5898 180000.0n 0.5170 180249.9n 0.5170 180250.0n 0.4546 180499.9n 0.4546 180500.0n 0.4339 180749.9n 0.4339 180750.0n 0.4443 180999.9n 0.4443 181000.0n 0.4858 181249.9n 0.4858 181250.0n 0.4339 181499.9n 0.4339 181500.0n 0.4650 181749.9n 0.4650 181750.0n 0.4339 181999.9n 0.4339 182000.0n 0.4339 182249.9n 0.4339 182250.0n 0.7560 182499.9n 0.7560 182500.0n 0.4962 182749.9n 0.4962 182750.0n 0.4546 182999.9n 0.4546 183000.0n 0.4339 183249.9n 0.4339 183250.0n 0.8000 183499.9n 0.8000 183500.0n 0.4339 183749.9n 0.4339 183750.0n 0.4962 183999.9n 0.4962 184000.0n 0.4754 184249.9n 0.4754 184250.0n 0.4650 184499.9n 0.4650 184500.0n 0.5794 184749.9n 0.5794 184750.0n 0.4339 184999.9n 0.4339 185000.0n 0.4754 185249.9n 0.4754 185250.0n 0.4546 185499.9n 0.4546 185500.0n 0.4443 185749.9n 0.4443 185750.0n 0.4339 185999.9n 0.4339 186000.0n 0.5586 186249.9n 0.5586 186250.0n 0.4339 186499.9n 0.4339 186500.0n 0.4339 186749.9n 0.4339 186750.0n 0.4443 186999.9n 0.4443 187000.0n 0.5274 187249.9n 0.5274 187250.0n 0.5898 187499.9n 0.5898 187500.0n 0.5170 187749.9n 0.5170 187750.0n 0.4546 187999.9n 0.4546 188000.0n 0.4339 188249.9n 0.4339 188250.0n 0.4443 188499.9n 0.4443 188500.0n 0.4858 188749.9n 0.4858 188750.0n 0.4339 188999.9n 0.4339 189000.0n 0.4650 189249.9n 0.4650 189250.0n 0.4339 189499.9n 0.4339 189500.0n 0.4339 189749.9n 0.4339 189750.0n 0.7560 189999.9n 0.7560 190000.0n 0.4962 190249.9n 0.4962 190250.0n 0.4546 190499.9n 0.4546 190500.0n 0.4339 190749.9n 0.4339 190750.0n 0.8000 190999.9n 0.8000 191000.0n 0.4339 191249.9n 0.4339 191250.0n 0.4962 191499.9n 0.4962 191500.0n 0.4754 191749.9n 0.4754 191750.0n 0.4650 191999.9n 0.4650 192000.0n 0.5794 192249.9n 0.5794 192250.0n 0.4339 192499.9n 0.4339 192500.0n 0.4754 192749.9n 0.4754 192750.0n 0.4546 192999.9n 0.4546 193000.0n 0.4443 193249.9n 0.4443 193250.0n 0.4339 193499.9n 0.4339 193500.0n 0.5586 193749.9n 0.5586 193750.0n 0.4339 193999.9n 0.4339 194000.0n 0.4339 194249.9n 0.4339 194250.0n 0.4443 194499.9n 0.4443 194500.0n 0.5274 194749.9n 0.5274 194750.0n 0.5898 194999.9n 0.5898 195000.0n 0.5170 195249.9n 0.5170 195250.0n 0.4546 195499.9n 0.4546 195500.0n 0.4339 195749.9n 0.4339 195750.0n 0.4443 195999.9n 0.4443 196000.0n 0.4858 196249.9n 0.4858 196250.0n 0.4339 196499.9n 0.4339 196500.0n 0.4650 196749.9n 0.4650 196750.0n 0.4339 196999.9n 0.4339 197000.0n 0.4339 197249.9n 0.4339 197250.0n 0.7560 197499.9n 0.7560 197500.0n 0.4962 197749.9n 0.4962 197750.0n 0.4546 197999.9n 0.4546 198000.0n 0.4339 198249.9n 0.4339 198250.0n 0.8000 198499.9n 0.8000 198500.0n 0.4339 198749.9n 0.4339 198750.0n 0.4962 198999.9n 0.4962 199000.0n 0.4754 199249.9n 0.4754 199250.0n 0.4650 199499.9n 0.4650 199500.0n 0.5794 199749.9n 0.5794 199750.0n 0.4339 199999.9n 0.4339 200000.0n 0.4754 200249.9n 0.4754 200250.0n 0.4546 200499.9n 0.4546 200500.0n 0.4443 200749.9n 0.4443 200750.0n 0.4339 200999.9n 0.4339 201000.0n 0.5586 201249.9n 0.5586 201250.0n 0.4339 201499.9n 0.4339 201500.0n 0.4339 201749.9n 0.4339 201750.0n 0.4443 201999.9n 0.4443 202000.0n 0.5274 202249.9n 0.5274 202250.0n 0.5898 202499.9n 0.5898 202500.0n 0.5170 202749.9n 0.5170 202750.0n 0.4546 202999.9n 0.4546 203000.0n 0.4339 203249.9n 0.4339 203250.0n 0.4443 203499.9n 0.4443 203500.0n 0.4858 203749.9n 0.4858 203750.0n 0.4339 203999.9n 0.4339 204000.0n 0.4650 204249.9n 0.4650 204250.0n 0.4339 204499.9n 0.4339 204500.0n 0.4339 204749.9n 0.4339 204750.0n 0.7560 204999.9n 0.7560 205000.0n 0.4962 205249.9n 0.4962 205250.0n 0.4546 205499.9n 0.4546 205500.0n 0.4339 205749.9n 0.4339 205750.0n 0.8000 205999.9n 0.8000 206000.0n 0.4339 206249.9n 0.4339 206250.0n 0.4962 206499.9n 0.4962 206500.0n 0.4754 206749.9n 0.4754 206750.0n 0.4650 206999.9n 0.4650 207000.0n 0.5794 207249.9n 0.5794 207250.0n 0.4339 207499.9n 0.4339 207500.0n 0.4754 207749.9n 0.4754 207750.0n 0.4546 207999.9n 0.4546 208000.0n 0.4443 208249.9n 0.4443 208250.0n 0.4339 208499.9n 0.4339 208500.0n 0.5586 208749.9n 0.5586 208750.0n 0.4339 208999.9n 0.4339 209000.0n 0.4339 209249.9n 0.4339 209250.0n 0.4443 209499.9n 0.4443 209500.0n 0.5274 209749.9n 0.5274 209750.0n 0.5898 209999.9n 0.5898 210000.0n 0.5170 210249.9n 0.5170 210250.0n 0.4546 210499.9n 0.4546 210500.0n 0.4339 210749.9n 0.4339 210750.0n 0.4443 210999.9n 0.4443 211000.0n 0.4858 211249.9n 0.4858 211250.0n 0.4339 211499.9n 0.4339 211500.0n 0.4650 211749.9n 0.4650 211750.0n 0.4339 211999.9n 0.4339 212000.0n 0.4339 212249.9n 0.4339 212250.0n 0.7560 212499.9n 0.7560 212500.0n 0.4962 212749.9n 0.4962 212750.0n 0.4546 212999.9n 0.4546 213000.0n 0.4339 213249.9n 0.4339 213250.0n 0.8000 213499.9n 0.8000 213500.0n 0.4339 213749.9n 0.4339 213750.0n 0.4962 213999.9n 0.4962 214000.0n 0.4754 214249.9n 0.4754 214250.0n 0.4650 214499.9n 0.4650 214500.0n 0.5794 214749.9n 0.5794 214750.0n 0.4339 214999.9n 0.4339 215000.0n 0.4754 215249.9n 0.4754 215250.0n 0.4546 215499.9n 0.4546 215500.0n 0.4443 215749.9n 0.4443 215750.0n 0.4339 215999.9n 0.4339 216000.0n 0.5586 216249.9n 0.5586 216250.0n 0.4339 216499.9n 0.4339 216500.0n 0.4339 216749.9n 0.4339 216750.0n 0.4443 216999.9n 0.4443 217000.0n 0.5274 217249.9n 0.5274 217250.0n 0.5898 217499.9n 0.5898 217500.0n 0.5170 217749.9n 0.5170 217750.0n 0.4546 217999.9n 0.4546 218000.0n 0.4339 218249.9n 0.4339 218250.0n 0.4443 218499.9n 0.4443 218500.0n 0.4858 218749.9n 0.4858 218750.0n 0.4339 218999.9n 0.4339 219000.0n 0.4650 219249.9n 0.4650 219250.0n 0.4339 219499.9n 0.4339 219500.0n 0.4339 219749.9n 0.4339 219750.0n 0.7560 219999.9n 0.7560 220000.0n 0.4962 220249.9n 0.4962 220250.0n 0.4546 220499.9n 0.4546 220500.0n 0.4339 220749.9n 0.4339 220750.0n 0.8000 220999.9n 0.8000 221000.0n 0.4339 221249.9n 0.4339 221250.0n 0.4962 221499.9n 0.4962 221500.0n 0.4754 221749.9n 0.4754 221750.0n 0.4650 221999.9n 0.4650 222000.0n 0.5794 222249.9n 0.5794 222250.0n 0.4339 222499.9n 0.4339 222500.0n 0.4754 222749.9n 0.4754 222750.0n 0.4546 222999.9n 0.4546 223000.0n 0.4443 223249.9n 0.4443 223250.0n 0.4339 223499.9n 0.4339 223500.0n 0.5586 223749.9n 0.5586 223750.0n 0.4339 223999.9n 0.4339 224000.0n 0.4339 224249.9n 0.4339 224250.0n 0.4443 224499.9n 0.4443 224500.0n 0.5274 224749.9n 0.5274 224750.0n 0.5898 224999.9n 0.5898 225000.0n 0.5170 225249.9n 0.5170 225250.0n 0.4546 225499.9n 0.4546 225500.0n 0.4339 225749.9n 0.4339 225750.0n 0.4443 225999.9n 0.4443 226000.0n 0.4858 226249.9n 0.4858 226250.0n 0.4339 226499.9n 0.4339 226500.0n 0.4650 226749.9n 0.4650 226750.0n 0.4339 226999.9n 0.4339 227000.0n 0.4339 227249.9n 0.4339 227250.0n 0.7560 227499.9n 0.7560 227500.0n 0.4962 227749.9n 0.4962 227750.0n 0.4546 227999.9n 0.4546 228000.0n 0.4339 228249.9n 0.4339 228250.0n 0.8000 228499.9n 0.8000 228500.0n 0.4339 228749.9n 0.4339 228750.0n 0.4962 228999.9n 0.4962 229000.0n 0.4754 229249.9n 0.4754 229250.0n 0.4650 229499.9n 0.4650 229500.0n 0.5794 229749.9n 0.5794 229750.0n 0.4339 229999.9n 0.4339 230000.0n 0.4754 230249.9n 0.4754 230250.0n 0.4546 230499.9n 0.4546 230500.0n 0.4443 230749.9n 0.4443 230750.0n 0.4339 230999.9n 0.4339 231000.0n 0.5586 231249.9n 0.5586 231250.0n 0.4339 231499.9n 0.4339 231500.0n 0.4339 231749.9n 0.4339 231750.0n 0.4443 231999.9n 0.4443 232000.0n 0.5274 232249.9n 0.5274 232250.0n 0.5898 232499.9n 0.5898 232500.0n 0.5170 232749.9n 0.5170 232750.0n 0.4546 232999.9n 0.4546 233000.0n 0.4339 233249.9n 0.4339 233250.0n 0.4443 233499.9n 0.4443 233500.0n 0.4858 233749.9n 0.4858 233750.0n 0.4339 233999.9n 0.4339 234000.0n 0.4650 234249.9n 0.4650 234250.0n 0.4339 234499.9n 0.4339 234500.0n 0.4339 234749.9n 0.4339 234750.0n 0.7560 234999.9n 0.7560 235000.0n 0.4962 235249.9n 0.4962 235250.0n 0.4546 235499.9n 0.4546 235500.0n 0.4339 235749.9n 0.4339 235750.0n 0.8000 235999.9n 0.8000 236000.0n 0.4339 236249.9n 0.4339 236250.0n 0.4962 236499.9n 0.4962 236500.0n 0.4754 236749.9n 0.4754 236750.0n 0.4650 236999.9n 0.4650 237000.0n 0.5794 237249.9n 0.5794 237250.0n 0.4339 237499.9n 0.4339 237500.0n 0.4754 237749.9n 0.4754 237750.0n 0.4546 237999.9n 0.4546 238000.0n 0.4443 238249.9n 0.4443 238250.0n 0.4339 238499.9n 0.4339 238500.0n 0.5586 238749.9n 0.5586 238750.0n 0.4339 238999.9n 0.4339 239000.0n 0.4339 239249.9n 0.4339 239250.0n 0.4443 239499.9n 0.4443 239500.0n 0.5274 239749.9n 0.5274 239750.0n 0.5898 239999.9n 0.5898 240000.0n 0.5170 240249.9n 0.5170 240250.0n 0.4546 240499.9n 0.4546 240500.0n 0.4339 240749.9n 0.4339 240750.0n 0.4443 240999.9n 0.4443 241000.0n 0.4858 241249.9n 0.4858 241250.0n 0.4339 241499.9n 0.4339 241500.0n 0.4650 241749.9n 0.4650 241750.0n 0.4339 241999.9n 0.4339 242000.0n 0.4339 242249.9n 0.4339 242250.0n 0.7560 242499.9n 0.7560 242500.0n 0.4962 242749.9n 0.4962 242750.0n 0.4546 242999.9n 0.4546 243000.0n 0.4339 243249.9n 0.4339 243250.0n 0.8000 243499.9n 0.8000 243500.0n 0.4339 243749.9n 0.4339 243750.0n 0.4962 243999.9n 0.4962 244000.0n 0.4754 244249.9n 0.4754 244250.0n 0.4650 244499.9n 0.4650 244500.0n 0.5794 244749.9n 0.5794 244750.0n 0.4339 244999.9n 0.4339 245000.0n 0.4754 245249.9n 0.4754 245250.0n 0.4546 245499.9n 0.4546 245500.0n 0.4443 245749.9n 0.4443 245750.0n 0.4339 245999.9n 0.4339 246000.0n 0.5586 246249.9n 0.5586 246250.0n 0.4339 246499.9n 0.4339 246500.0n 0.4339 246749.9n 0.4339 246750.0n 0.4443 246999.9n 0.4443 247000.0n 0.5274 247249.9n 0.5274 247250.0n 0.5898 247499.9n 0.5898 247500.0n 0.5170 247749.9n 0.5170 247750.0n 0.4546 247999.9n 0.4546 248000.0n 0.4339 248249.9n 0.4339 248250.0n 0.4443 248499.9n 0.4443 248500.0n 0.4858 248749.9n 0.4858 248750.0n 0.4339 248999.9n 0.4339 249000.0n 0.4650 249249.9n 0.4650 249250.0n 0.4339 249499.9n 0.4339 249500.0n 0.4339 249749.9n 0.4339 249750.0n 0.7560 249999.9n 0.7560 250000.0n 0.4962 250249.9n 0.4962 250250.0n 0.4546 250499.9n 0.4546 250500.0n 0.4339 250749.9n 0.4339 250750.0n 0.8000 250999.9n 0.8000 251000.0n 0.4339 251249.9n 0.4339 251250.0n 0.4962 251499.9n 0.4962 251500.0n 0.4754 251749.9n 0.4754 251750.0n 0.4650 251999.9n 0.4650 252000.0n 0.5794 252249.9n 0.5794 252250.0n 0.4339 252499.9n 0.4339 252500.0n 0.4754 252749.9n 0.4754 252750.0n 0.4546 252999.9n 0.4546 253000.0n 0.4443 253249.9n 0.4443 253250.0n 0.4339 253499.9n 0.4339 253500.0n 0.5586 253749.9n 0.5586 253750.0n 0.4339 253999.9n 0.4339 254000.0n 0.4339 254249.9n 0.4339 254250.0n 0.4443 254499.9n 0.4443 254500.0n 0.5274 254749.9n 0.5274 254750.0n 0.5898 254999.9n 0.5898 255000.0n 0.5170 255249.9n 0.5170 255250.0n 0.4546 255499.9n 0.4546 255500.0n 0.4339 255749.9n 0.4339 255750.0n 0.4443 255999.9n 0.4443 256000.0n 0.4858 256249.9n 0.4858 256250.0n 0.4339 256499.9n 0.4339 256500.0n 0.4650 256749.9n 0.4650 256750.0n 0.4339 256999.9n 0.4339 257000.0n 0.4339 257249.9n 0.4339 257250.0n 0.7560 257499.9n 0.7560 257500.0n 0.4962 257749.9n 0.4962 257750.0n 0.4546 257999.9n 0.4546 258000.0n 0.4339 258249.9n 0.4339 258250.0n 0.8000 258499.9n 0.8000 258500.0n 0.4339 258749.9n 0.4339 258750.0n 0.4962 258999.9n 0.4962 259000.0n 0.4754 259249.9n 0.4754 259250.0n 0.4650 259499.9n 0.4650 259500.0n 0.5794 259749.9n 0.5794 259750.0n 0.4339 259999.9n 0.4339 260000.0n 0.4754 260249.9n 0.4754 260250.0n 0.4546 260499.9n 0.4546 260500.0n 0.4443 260749.9n 0.4443 260750.0n 0.4339 260999.9n 0.4339 261000.0n 0.5586 261249.9n 0.5586 261250.0n 0.4339 261499.9n 0.4339 261500.0n 0.4339 261749.9n 0.4339 261750.0n 0.4443 261999.9n 0.4443 262000.0n 0.5274 262249.9n 0.5274 262250.0n 0.5898 262499.9n 0.5898 262500.0n 0.5170 262749.9n 0.5170 262750.0n 0.4546 262999.9n 0.4546 263000.0n 0.4339 263249.9n 0.4339 263250.0n 0.4443 263499.9n 0.4443 263500.0n 0.4858 263749.9n 0.4858 263750.0n 0.4339 263999.9n 0.4339 264000.0n 0.4650 264249.9n 0.4650 264250.0n 0.4339 264499.9n 0.4339 264500.0n 0.4339 264749.9n 0.4339 264750.0n 0.7560 264999.9n 0.7560 265000.0n 0.4962 265249.9n 0.4962 265250.0n 0.4546 265499.9n 0.4546 265500.0n 0.4339 265749.9n 0.4339 265750.0n 0.8000 265999.9n 0.8000 266000.0n 0.4339 266249.9n 0.4339 266250.0n 0.4962 266499.9n 0.4962 266500.0n 0.4754 266749.9n 0.4754 266750.0n 0.4650 266999.9n 0.4650 267000.0n 0.5794 267249.9n 0.5794 267250.0n 0.4339 267499.9n 0.4339 267500.0n 0.4754 267749.9n 0.4754 267750.0n 0.4546 267999.9n 0.4546 268000.0n 0.4443 268249.9n 0.4443 268250.0n 0.4339 268499.9n 0.4339 268500.0n 0.5586 268749.9n 0.5586 268750.0n 0.4339 268999.9n 0.4339 269000.0n 0.4339 269249.9n 0.4339 269250.0n 0.4443 269499.9n 0.4443 269500.0n 0.5274 269749.9n 0.5274 269750.0n 0.5898 269999.9n 0.5898 270000.0n 0.5170 270249.9n 0.5170 270250.0n 0.4546 270499.9n 0.4546 270500.0n 0.4339 270749.9n 0.4339 270750.0n 0.4443 270999.9n 0.4443 271000.0n 0.4858 271249.9n 0.4858 271250.0n 0.4339 271499.9n 0.4339 271500.0n 0.4650 271749.9n 0.4650 271750.0n 0.4339 271999.9n 0.4339 272000.0n 0.4339 272249.9n 0.4339 272250.0n 0.7560 272499.9n 0.7560 272500.0n 0.4962 272749.9n 0.4962 272750.0n 0.4546 272999.9n 0.4546 273000.0n 0.4339 273249.9n 0.4339 273250.0n 0.8000 273499.9n 0.8000 273500.0n 0.4339 273749.9n 0.4339 273750.0n 0.4962 273999.9n 0.4962 274000.0n 0.4754 274249.9n 0.4754 274250.0n 0.4650 274499.9n 0.4650 274500.0n 0.5794 274749.9n 0.5794 274750.0n 0.4339 274999.9n 0.4339 275000.0n 0.4754 275249.9n 0.4754 275250.0n 0.4546 275499.9n 0.4546 275500.0n 0.4443 275749.9n 0.4443 275750.0n 0.4339 275999.9n 0.4339 276000.0n 0.5586 276249.9n 0.5586 276250.0n 0.4339 276499.9n 0.4339 276500.0n 0.4339 276749.9n 0.4339 276750.0n 0.4443 276999.9n 0.4443 277000.0n 0.5274 277249.9n 0.5274 277250.0n 0.5898 277499.9n 0.5898 277500.0n 0.5170 277749.9n 0.5170 277750.0n 0.4546 277999.9n 0.4546 278000.0n 0.4339 278249.9n 0.4339 278250.0n 0.4443 278499.9n 0.4443 278500.0n 0.4858 278749.9n 0.4858 278750.0n 0.4339 278999.9n 0.4339 279000.0n 0.4650 279249.9n 0.4650 279250.0n 0.4339 279499.9n 0.4339 279500.0n 0.4339 279749.9n 0.4339 279750.0n 0.7560 279999.9n 0.7560 280000.0n 0.4962 280249.9n 0.4962 280250.0n 0.4546 280499.9n 0.4546 280500.0n 0.4339 280749.9n 0.4339 280750.0n 0.8000 280999.9n 0.8000 281000.0n 0.4339 281249.9n 0.4339 281250.0n 0.4962 281499.9n 0.4962 281500.0n 0.4754 281749.9n 0.4754 281750.0n 0.4650 281999.9n 0.4650 282000.0n 0.5794 282249.9n 0.5794 282250.0n 0.4339 282499.9n 0.4339 282500.0n 0.4754 282749.9n 0.4754 282750.0n 0.4546 282999.9n 0.4546 283000.0n 0.4443 283249.9n 0.4443 283250.0n 0.4339 283499.9n 0.4339 283500.0n 0.5586 283749.9n 0.5586 283750.0n 0.4339 283999.9n 0.4339 284000.0n 0.4339 284249.9n 0.4339 284250.0n 0.4443 284499.9n 0.4443 284500.0n 0.5274 284749.9n 0.5274 284750.0n 0.5898 284999.9n 0.5898 285000.0n 0.5170 285249.9n 0.5170 285250.0n 0.4546 285499.9n 0.4546 285500.0n 0.4339 285749.9n 0.4339 285750.0n 0.4443 285999.9n 0.4443 286000.0n 0.4858 286249.9n 0.4858 286250.0n 0.4339 286499.9n 0.4339 286500.0n 0.4650 286749.9n 0.4650 286750.0n 0.4339 286999.9n 0.4339 287000.0n 0.4339 287249.9n 0.4339 287250.0n 0.7560 287499.9n 0.7560 287500.0n 0.4962 287749.9n 0.4962 287750.0n 0.4546 287999.9n 0.4546 288000.0n 0.4339 288249.9n 0.4339 288250.0n 0.8000 288499.9n 0.8000 288500.0n 0.4339 288749.9n 0.4339 288750.0n 0.4962 288999.9n 0.4962 289000.0n 0.4754 289249.9n 0.4754 289250.0n 0.4650 289499.9n 0.4650 289500.0n 0.5794 289749.9n 0.5794 289750.0n 0.4339 289999.9n 0.4339 290000.0n 0.4754 290249.9n 0.4754 290250.0n 0.4546 290499.9n 0.4546 290500.0n 0.4443 290749.9n 0.4443 290750.0n 0.4339 290999.9n 0.4339 291000.0n 0.5586 291249.9n 0.5586 291250.0n 0.4339 291499.9n 0.4339 291500.0n 0.4339 291749.9n 0.4339 291750.0n 0.4443 291999.9n 0.4443 292000.0n 0.5274 292249.9n 0.5274 292250.0n 0.5898 292499.9n 0.5898 292500.0n 0.5170 292749.9n 0.5170 292750.0n 0.4546 292999.9n 0.4546 293000.0n 0.4339 293249.9n 0.4339 293250.0n 0.4443 293499.9n 0.4443 293500.0n 0.4858 293749.9n 0.4858 293750.0n 0.4339 293999.9n 0.4339 294000.0n 0.4650 294249.9n 0.4650 294250.0n 0.4339 294499.9n 0.4339 294500.0n 0.4339 294749.9n 0.4339 294750.0n 0.7560 294999.9n 0.7560 295000.0n 0.4962 295249.9n 0.4962 295250.0n 0.4546 295499.9n 0.4546 295500.0n 0.4339 295749.9n 0.4339 295750.0n 0.8000 295999.9n 0.8000 296000.0n 0.4339 296249.9n 0.4339 296250.0n 0.4962 296499.9n 0.4962 296500.0n 0.4754 296749.9n 0.4754 296750.0n 0.4650 296999.9n 0.4650 297000.0n 0.5794 297249.9n 0.5794 297250.0n 0.4339 297499.9n 0.4339 297500.0n 0.4754 297749.9n 0.4754 297750.0n 0.4546 297999.9n 0.4546 298000.0n 0.4443 298249.9n 0.4443 298250.0n 0.4339 298499.9n 0.4339 298500.0n 0.5586 298749.9n 0.5586 298750.0n 0.4339 298999.9n 0.4339 299000.0n 0.4339 299249.9n 0.4339 299250.0n 0.4443 299499.9n 0.4443 299500.0n 0.5274 299749.9n 0.5274 299750.0n 0.5898)
Vxn15 a_xn15 0 PWL(0.0n 0.4830 249.9n 0.4830 250.0n 0.5454 499.9n 0.5454 500.0n 0.5661 749.9n 0.5661 750.0n 0.5557 999.9n 0.5557 1000.0n 0.5142 1249.9n 0.5142 1250.0n 0.5661 1499.9n 0.5661 1500.0n 0.5350 1749.9n 0.5350 1750.0n 0.5661 1999.9n 0.5661 2000.0n 0.5661 2249.9n 0.5661 2250.0n 0.2440 2499.9n 0.2440 2500.0n 0.5038 2749.9n 0.5038 2750.0n 0.5454 2999.9n 0.5454 3000.0n 0.5661 3249.9n 0.5661 3250.0n 0.2000 3499.9n 0.2000 3500.0n 0.5661 3749.9n 0.5661 3750.0n 0.5038 3999.9n 0.5038 4000.0n 0.5246 4249.9n 0.5246 4250.0n 0.5350 4499.9n 0.5350 4500.0n 0.4206 4749.9n 0.4206 4750.0n 0.5661 4999.9n 0.5661 5000.0n 0.5246 5249.9n 0.5246 5250.0n 0.5454 5499.9n 0.5454 5500.0n 0.5557 5749.9n 0.5557 5750.0n 0.5661 5999.9n 0.5661 6000.0n 0.4414 6249.9n 0.4414 6250.0n 0.5661 6499.9n 0.5661 6500.0n 0.5661 6749.9n 0.5661 6750.0n 0.5557 6999.9n 0.5557 7000.0n 0.4726 7249.9n 0.4726 7250.0n 0.4102 7499.9n 0.4102 7500.0n 0.4830 7749.9n 0.4830 7750.0n 0.5454 7999.9n 0.5454 8000.0n 0.5661 8249.9n 0.5661 8250.0n 0.5557 8499.9n 0.5557 8500.0n 0.5142 8749.9n 0.5142 8750.0n 0.5661 8999.9n 0.5661 9000.0n 0.5350 9249.9n 0.5350 9250.0n 0.5661 9499.9n 0.5661 9500.0n 0.5661 9749.9n 0.5661 9750.0n 0.2440 9999.9n 0.2440 10000.0n 0.5038 10249.9n 0.5038 10250.0n 0.5454 10499.9n 0.5454 10500.0n 0.5661 10749.9n 0.5661 10750.0n 0.2000 10999.9n 0.2000 11000.0n 0.5661 11249.9n 0.5661 11250.0n 0.5038 11499.9n 0.5038 11500.0n 0.5246 11749.9n 0.5246 11750.0n 0.5350 11999.9n 0.5350 12000.0n 0.4206 12249.9n 0.4206 12250.0n 0.5661 12499.9n 0.5661 12500.0n 0.5246 12749.9n 0.5246 12750.0n 0.5454 12999.9n 0.5454 13000.0n 0.5557 13249.9n 0.5557 13250.0n 0.5661 13499.9n 0.5661 13500.0n 0.4414 13749.9n 0.4414 13750.0n 0.5661 13999.9n 0.5661 14000.0n 0.5661 14249.9n 0.5661 14250.0n 0.5557 14499.9n 0.5557 14500.0n 0.4726 14749.9n 0.4726 14750.0n 0.4102 14999.9n 0.4102 15000.0n 0.4830 15249.9n 0.4830 15250.0n 0.5454 15499.9n 0.5454 15500.0n 0.5661 15749.9n 0.5661 15750.0n 0.5557 15999.9n 0.5557 16000.0n 0.5142 16249.9n 0.5142 16250.0n 0.5661 16499.9n 0.5661 16500.0n 0.5350 16749.9n 0.5350 16750.0n 0.5661 16999.9n 0.5661 17000.0n 0.5661 17249.9n 0.5661 17250.0n 0.2440 17499.9n 0.2440 17500.0n 0.5038 17749.9n 0.5038 17750.0n 0.5454 17999.9n 0.5454 18000.0n 0.5661 18249.9n 0.5661 18250.0n 0.2000 18499.9n 0.2000 18500.0n 0.5661 18749.9n 0.5661 18750.0n 0.5038 18999.9n 0.5038 19000.0n 0.5246 19249.9n 0.5246 19250.0n 0.5350 19499.9n 0.5350 19500.0n 0.4206 19749.9n 0.4206 19750.0n 0.5661 19999.9n 0.5661 20000.0n 0.5246 20249.9n 0.5246 20250.0n 0.5454 20499.9n 0.5454 20500.0n 0.5557 20749.9n 0.5557 20750.0n 0.5661 20999.9n 0.5661 21000.0n 0.4414 21249.9n 0.4414 21250.0n 0.5661 21499.9n 0.5661 21500.0n 0.5661 21749.9n 0.5661 21750.0n 0.5557 21999.9n 0.5557 22000.0n 0.4726 22249.9n 0.4726 22250.0n 0.4102 22499.9n 0.4102 22500.0n 0.4830 22749.9n 0.4830 22750.0n 0.5454 22999.9n 0.5454 23000.0n 0.5661 23249.9n 0.5661 23250.0n 0.5557 23499.9n 0.5557 23500.0n 0.5142 23749.9n 0.5142 23750.0n 0.5661 23999.9n 0.5661 24000.0n 0.5350 24249.9n 0.5350 24250.0n 0.5661 24499.9n 0.5661 24500.0n 0.5661 24749.9n 0.5661 24750.0n 0.2440 24999.9n 0.2440 25000.0n 0.5038 25249.9n 0.5038 25250.0n 0.5454 25499.9n 0.5454 25500.0n 0.5661 25749.9n 0.5661 25750.0n 0.2000 25999.9n 0.2000 26000.0n 0.5661 26249.9n 0.5661 26250.0n 0.5038 26499.9n 0.5038 26500.0n 0.5246 26749.9n 0.5246 26750.0n 0.5350 26999.9n 0.5350 27000.0n 0.4206 27249.9n 0.4206 27250.0n 0.5661 27499.9n 0.5661 27500.0n 0.5246 27749.9n 0.5246 27750.0n 0.5454 27999.9n 0.5454 28000.0n 0.5557 28249.9n 0.5557 28250.0n 0.5661 28499.9n 0.5661 28500.0n 0.4414 28749.9n 0.4414 28750.0n 0.5661 28999.9n 0.5661 29000.0n 0.5661 29249.9n 0.5661 29250.0n 0.5557 29499.9n 0.5557 29500.0n 0.4726 29749.9n 0.4726 29750.0n 0.4102 29999.9n 0.4102 30000.0n 0.4830 30249.9n 0.4830 30250.0n 0.5454 30499.9n 0.5454 30500.0n 0.5661 30749.9n 0.5661 30750.0n 0.5557 30999.9n 0.5557 31000.0n 0.5142 31249.9n 0.5142 31250.0n 0.5661 31499.9n 0.5661 31500.0n 0.5350 31749.9n 0.5350 31750.0n 0.5661 31999.9n 0.5661 32000.0n 0.5661 32249.9n 0.5661 32250.0n 0.2440 32499.9n 0.2440 32500.0n 0.5038 32749.9n 0.5038 32750.0n 0.5454 32999.9n 0.5454 33000.0n 0.5661 33249.9n 0.5661 33250.0n 0.2000 33499.9n 0.2000 33500.0n 0.5661 33749.9n 0.5661 33750.0n 0.5038 33999.9n 0.5038 34000.0n 0.5246 34249.9n 0.5246 34250.0n 0.5350 34499.9n 0.5350 34500.0n 0.4206 34749.9n 0.4206 34750.0n 0.5661 34999.9n 0.5661 35000.0n 0.5246 35249.9n 0.5246 35250.0n 0.5454 35499.9n 0.5454 35500.0n 0.5557 35749.9n 0.5557 35750.0n 0.5661 35999.9n 0.5661 36000.0n 0.4414 36249.9n 0.4414 36250.0n 0.5661 36499.9n 0.5661 36500.0n 0.5661 36749.9n 0.5661 36750.0n 0.5557 36999.9n 0.5557 37000.0n 0.4726 37249.9n 0.4726 37250.0n 0.4102 37499.9n 0.4102 37500.0n 0.4830 37749.9n 0.4830 37750.0n 0.5454 37999.9n 0.5454 38000.0n 0.5661 38249.9n 0.5661 38250.0n 0.5557 38499.9n 0.5557 38500.0n 0.5142 38749.9n 0.5142 38750.0n 0.5661 38999.9n 0.5661 39000.0n 0.5350 39249.9n 0.5350 39250.0n 0.5661 39499.9n 0.5661 39500.0n 0.5661 39749.9n 0.5661 39750.0n 0.2440 39999.9n 0.2440 40000.0n 0.5038 40249.9n 0.5038 40250.0n 0.5454 40499.9n 0.5454 40500.0n 0.5661 40749.9n 0.5661 40750.0n 0.2000 40999.9n 0.2000 41000.0n 0.5661 41249.9n 0.5661 41250.0n 0.5038 41499.9n 0.5038 41500.0n 0.5246 41749.9n 0.5246 41750.0n 0.5350 41999.9n 0.5350 42000.0n 0.4206 42249.9n 0.4206 42250.0n 0.5661 42499.9n 0.5661 42500.0n 0.5246 42749.9n 0.5246 42750.0n 0.5454 42999.9n 0.5454 43000.0n 0.5557 43249.9n 0.5557 43250.0n 0.5661 43499.9n 0.5661 43500.0n 0.4414 43749.9n 0.4414 43750.0n 0.5661 43999.9n 0.5661 44000.0n 0.5661 44249.9n 0.5661 44250.0n 0.5557 44499.9n 0.5557 44500.0n 0.4726 44749.9n 0.4726 44750.0n 0.4102 44999.9n 0.4102 45000.0n 0.4830 45249.9n 0.4830 45250.0n 0.5454 45499.9n 0.5454 45500.0n 0.5661 45749.9n 0.5661 45750.0n 0.5557 45999.9n 0.5557 46000.0n 0.5142 46249.9n 0.5142 46250.0n 0.5661 46499.9n 0.5661 46500.0n 0.5350 46749.9n 0.5350 46750.0n 0.5661 46999.9n 0.5661 47000.0n 0.5661 47249.9n 0.5661 47250.0n 0.2440 47499.9n 0.2440 47500.0n 0.5038 47749.9n 0.5038 47750.0n 0.5454 47999.9n 0.5454 48000.0n 0.5661 48249.9n 0.5661 48250.0n 0.2000 48499.9n 0.2000 48500.0n 0.5661 48749.9n 0.5661 48750.0n 0.5038 48999.9n 0.5038 49000.0n 0.5246 49249.9n 0.5246 49250.0n 0.5350 49499.9n 0.5350 49500.0n 0.4206 49749.9n 0.4206 49750.0n 0.5661 49999.9n 0.5661 50000.0n 0.5246 50249.9n 0.5246 50250.0n 0.5454 50499.9n 0.5454 50500.0n 0.5557 50749.9n 0.5557 50750.0n 0.5661 50999.9n 0.5661 51000.0n 0.4414 51249.9n 0.4414 51250.0n 0.5661 51499.9n 0.5661 51500.0n 0.5661 51749.9n 0.5661 51750.0n 0.5557 51999.9n 0.5557 52000.0n 0.4726 52249.9n 0.4726 52250.0n 0.4102 52499.9n 0.4102 52500.0n 0.4830 52749.9n 0.4830 52750.0n 0.5454 52999.9n 0.5454 53000.0n 0.5661 53249.9n 0.5661 53250.0n 0.5557 53499.9n 0.5557 53500.0n 0.5142 53749.9n 0.5142 53750.0n 0.5661 53999.9n 0.5661 54000.0n 0.5350 54249.9n 0.5350 54250.0n 0.5661 54499.9n 0.5661 54500.0n 0.5661 54749.9n 0.5661 54750.0n 0.2440 54999.9n 0.2440 55000.0n 0.5038 55249.9n 0.5038 55250.0n 0.5454 55499.9n 0.5454 55500.0n 0.5661 55749.9n 0.5661 55750.0n 0.2000 55999.9n 0.2000 56000.0n 0.5661 56249.9n 0.5661 56250.0n 0.5038 56499.9n 0.5038 56500.0n 0.5246 56749.9n 0.5246 56750.0n 0.5350 56999.9n 0.5350 57000.0n 0.4206 57249.9n 0.4206 57250.0n 0.5661 57499.9n 0.5661 57500.0n 0.5246 57749.9n 0.5246 57750.0n 0.5454 57999.9n 0.5454 58000.0n 0.5557 58249.9n 0.5557 58250.0n 0.5661 58499.9n 0.5661 58500.0n 0.4414 58749.9n 0.4414 58750.0n 0.5661 58999.9n 0.5661 59000.0n 0.5661 59249.9n 0.5661 59250.0n 0.5557 59499.9n 0.5557 59500.0n 0.4726 59749.9n 0.4726 59750.0n 0.4102 59999.9n 0.4102 60000.0n 0.4830 60249.9n 0.4830 60250.0n 0.5454 60499.9n 0.5454 60500.0n 0.5661 60749.9n 0.5661 60750.0n 0.5557 60999.9n 0.5557 61000.0n 0.5142 61249.9n 0.5142 61250.0n 0.5661 61499.9n 0.5661 61500.0n 0.5350 61749.9n 0.5350 61750.0n 0.5661 61999.9n 0.5661 62000.0n 0.5661 62249.9n 0.5661 62250.0n 0.2440 62499.9n 0.2440 62500.0n 0.5038 62749.9n 0.5038 62750.0n 0.5454 62999.9n 0.5454 63000.0n 0.5661 63249.9n 0.5661 63250.0n 0.2000 63499.9n 0.2000 63500.0n 0.5661 63749.9n 0.5661 63750.0n 0.5038 63999.9n 0.5038 64000.0n 0.5246 64249.9n 0.5246 64250.0n 0.5350 64499.9n 0.5350 64500.0n 0.4206 64749.9n 0.4206 64750.0n 0.5661 64999.9n 0.5661 65000.0n 0.5246 65249.9n 0.5246 65250.0n 0.5454 65499.9n 0.5454 65500.0n 0.5557 65749.9n 0.5557 65750.0n 0.5661 65999.9n 0.5661 66000.0n 0.4414 66249.9n 0.4414 66250.0n 0.5661 66499.9n 0.5661 66500.0n 0.5661 66749.9n 0.5661 66750.0n 0.5557 66999.9n 0.5557 67000.0n 0.4726 67249.9n 0.4726 67250.0n 0.4102 67499.9n 0.4102 67500.0n 0.4830 67749.9n 0.4830 67750.0n 0.5454 67999.9n 0.5454 68000.0n 0.5661 68249.9n 0.5661 68250.0n 0.5557 68499.9n 0.5557 68500.0n 0.5142 68749.9n 0.5142 68750.0n 0.5661 68999.9n 0.5661 69000.0n 0.5350 69249.9n 0.5350 69250.0n 0.5661 69499.9n 0.5661 69500.0n 0.5661 69749.9n 0.5661 69750.0n 0.2440 69999.9n 0.2440 70000.0n 0.5038 70249.9n 0.5038 70250.0n 0.5454 70499.9n 0.5454 70500.0n 0.5661 70749.9n 0.5661 70750.0n 0.2000 70999.9n 0.2000 71000.0n 0.5661 71249.9n 0.5661 71250.0n 0.5038 71499.9n 0.5038 71500.0n 0.5246 71749.9n 0.5246 71750.0n 0.5350 71999.9n 0.5350 72000.0n 0.4206 72249.9n 0.4206 72250.0n 0.5661 72499.9n 0.5661 72500.0n 0.5246 72749.9n 0.5246 72750.0n 0.5454 72999.9n 0.5454 73000.0n 0.5557 73249.9n 0.5557 73250.0n 0.5661 73499.9n 0.5661 73500.0n 0.4414 73749.9n 0.4414 73750.0n 0.5661 73999.9n 0.5661 74000.0n 0.5661 74249.9n 0.5661 74250.0n 0.5557 74499.9n 0.5557 74500.0n 0.4726 74749.9n 0.4726 74750.0n 0.4102 74999.9n 0.4102 75000.0n 0.4830 75249.9n 0.4830 75250.0n 0.5454 75499.9n 0.5454 75500.0n 0.5661 75749.9n 0.5661 75750.0n 0.5557 75999.9n 0.5557 76000.0n 0.5142 76249.9n 0.5142 76250.0n 0.5661 76499.9n 0.5661 76500.0n 0.5350 76749.9n 0.5350 76750.0n 0.5661 76999.9n 0.5661 77000.0n 0.5661 77249.9n 0.5661 77250.0n 0.2440 77499.9n 0.2440 77500.0n 0.5038 77749.9n 0.5038 77750.0n 0.5454 77999.9n 0.5454 78000.0n 0.5661 78249.9n 0.5661 78250.0n 0.2000 78499.9n 0.2000 78500.0n 0.5661 78749.9n 0.5661 78750.0n 0.5038 78999.9n 0.5038 79000.0n 0.5246 79249.9n 0.5246 79250.0n 0.5350 79499.9n 0.5350 79500.0n 0.4206 79749.9n 0.4206 79750.0n 0.5661 79999.9n 0.5661 80000.0n 0.5246 80249.9n 0.5246 80250.0n 0.5454 80499.9n 0.5454 80500.0n 0.5557 80749.9n 0.5557 80750.0n 0.5661 80999.9n 0.5661 81000.0n 0.4414 81249.9n 0.4414 81250.0n 0.5661 81499.9n 0.5661 81500.0n 0.5661 81749.9n 0.5661 81750.0n 0.5557 81999.9n 0.5557 82000.0n 0.4726 82249.9n 0.4726 82250.0n 0.4102 82499.9n 0.4102 82500.0n 0.4830 82749.9n 0.4830 82750.0n 0.5454 82999.9n 0.5454 83000.0n 0.5661 83249.9n 0.5661 83250.0n 0.5557 83499.9n 0.5557 83500.0n 0.5142 83749.9n 0.5142 83750.0n 0.5661 83999.9n 0.5661 84000.0n 0.5350 84249.9n 0.5350 84250.0n 0.5661 84499.9n 0.5661 84500.0n 0.5661 84749.9n 0.5661 84750.0n 0.2440 84999.9n 0.2440 85000.0n 0.5038 85249.9n 0.5038 85250.0n 0.5454 85499.9n 0.5454 85500.0n 0.5661 85749.9n 0.5661 85750.0n 0.2000 85999.9n 0.2000 86000.0n 0.5661 86249.9n 0.5661 86250.0n 0.5038 86499.9n 0.5038 86500.0n 0.5246 86749.9n 0.5246 86750.0n 0.5350 86999.9n 0.5350 87000.0n 0.4206 87249.9n 0.4206 87250.0n 0.5661 87499.9n 0.5661 87500.0n 0.5246 87749.9n 0.5246 87750.0n 0.5454 87999.9n 0.5454 88000.0n 0.5557 88249.9n 0.5557 88250.0n 0.5661 88499.9n 0.5661 88500.0n 0.4414 88749.9n 0.4414 88750.0n 0.5661 88999.9n 0.5661 89000.0n 0.5661 89249.9n 0.5661 89250.0n 0.5557 89499.9n 0.5557 89500.0n 0.4726 89749.9n 0.4726 89750.0n 0.4102 89999.9n 0.4102 90000.0n 0.4830 90249.9n 0.4830 90250.0n 0.5454 90499.9n 0.5454 90500.0n 0.5661 90749.9n 0.5661 90750.0n 0.5557 90999.9n 0.5557 91000.0n 0.5142 91249.9n 0.5142 91250.0n 0.5661 91499.9n 0.5661 91500.0n 0.5350 91749.9n 0.5350 91750.0n 0.5661 91999.9n 0.5661 92000.0n 0.5661 92249.9n 0.5661 92250.0n 0.2440 92499.9n 0.2440 92500.0n 0.5038 92749.9n 0.5038 92750.0n 0.5454 92999.9n 0.5454 93000.0n 0.5661 93249.9n 0.5661 93250.0n 0.2000 93499.9n 0.2000 93500.0n 0.5661 93749.9n 0.5661 93750.0n 0.5038 93999.9n 0.5038 94000.0n 0.5246 94249.9n 0.5246 94250.0n 0.5350 94499.9n 0.5350 94500.0n 0.4206 94749.9n 0.4206 94750.0n 0.5661 94999.9n 0.5661 95000.0n 0.5246 95249.9n 0.5246 95250.0n 0.5454 95499.9n 0.5454 95500.0n 0.5557 95749.9n 0.5557 95750.0n 0.5661 95999.9n 0.5661 96000.0n 0.4414 96249.9n 0.4414 96250.0n 0.5661 96499.9n 0.5661 96500.0n 0.5661 96749.9n 0.5661 96750.0n 0.5557 96999.9n 0.5557 97000.0n 0.4726 97249.9n 0.4726 97250.0n 0.4102 97499.9n 0.4102 97500.0n 0.4830 97749.9n 0.4830 97750.0n 0.5454 97999.9n 0.5454 98000.0n 0.5661 98249.9n 0.5661 98250.0n 0.5557 98499.9n 0.5557 98500.0n 0.5142 98749.9n 0.5142 98750.0n 0.5661 98999.9n 0.5661 99000.0n 0.5350 99249.9n 0.5350 99250.0n 0.5661 99499.9n 0.5661 99500.0n 0.5661 99749.9n 0.5661 99750.0n 0.2440 99999.9n 0.2440 100000.0n 0.5038 100249.9n 0.5038 100250.0n 0.5454 100499.9n 0.5454 100500.0n 0.5661 100749.9n 0.5661 100750.0n 0.2000 100999.9n 0.2000 101000.0n 0.5661 101249.9n 0.5661 101250.0n 0.5038 101499.9n 0.5038 101500.0n 0.5246 101749.9n 0.5246 101750.0n 0.5350 101999.9n 0.5350 102000.0n 0.4206 102249.9n 0.4206 102250.0n 0.5661 102499.9n 0.5661 102500.0n 0.5246 102749.9n 0.5246 102750.0n 0.5454 102999.9n 0.5454 103000.0n 0.5557 103249.9n 0.5557 103250.0n 0.5661 103499.9n 0.5661 103500.0n 0.4414 103749.9n 0.4414 103750.0n 0.5661 103999.9n 0.5661 104000.0n 0.5661 104249.9n 0.5661 104250.0n 0.5557 104499.9n 0.5557 104500.0n 0.4726 104749.9n 0.4726 104750.0n 0.4102 104999.9n 0.4102 105000.0n 0.4830 105249.9n 0.4830 105250.0n 0.5454 105499.9n 0.5454 105500.0n 0.5661 105749.9n 0.5661 105750.0n 0.5557 105999.9n 0.5557 106000.0n 0.5142 106249.9n 0.5142 106250.0n 0.5661 106499.9n 0.5661 106500.0n 0.5350 106749.9n 0.5350 106750.0n 0.5661 106999.9n 0.5661 107000.0n 0.5661 107249.9n 0.5661 107250.0n 0.2440 107499.9n 0.2440 107500.0n 0.5038 107749.9n 0.5038 107750.0n 0.5454 107999.9n 0.5454 108000.0n 0.5661 108249.9n 0.5661 108250.0n 0.2000 108499.9n 0.2000 108500.0n 0.5661 108749.9n 0.5661 108750.0n 0.5038 108999.9n 0.5038 109000.0n 0.5246 109249.9n 0.5246 109250.0n 0.5350 109499.9n 0.5350 109500.0n 0.4206 109749.9n 0.4206 109750.0n 0.5661 109999.9n 0.5661 110000.0n 0.5246 110249.9n 0.5246 110250.0n 0.5454 110499.9n 0.5454 110500.0n 0.5557 110749.9n 0.5557 110750.0n 0.5661 110999.9n 0.5661 111000.0n 0.4414 111249.9n 0.4414 111250.0n 0.5661 111499.9n 0.5661 111500.0n 0.5661 111749.9n 0.5661 111750.0n 0.5557 111999.9n 0.5557 112000.0n 0.4726 112249.9n 0.4726 112250.0n 0.4102 112499.9n 0.4102 112500.0n 0.4830 112749.9n 0.4830 112750.0n 0.5454 112999.9n 0.5454 113000.0n 0.5661 113249.9n 0.5661 113250.0n 0.5557 113499.9n 0.5557 113500.0n 0.5142 113749.9n 0.5142 113750.0n 0.5661 113999.9n 0.5661 114000.0n 0.5350 114249.9n 0.5350 114250.0n 0.5661 114499.9n 0.5661 114500.0n 0.5661 114749.9n 0.5661 114750.0n 0.2440 114999.9n 0.2440 115000.0n 0.5038 115249.9n 0.5038 115250.0n 0.5454 115499.9n 0.5454 115500.0n 0.5661 115749.9n 0.5661 115750.0n 0.2000 115999.9n 0.2000 116000.0n 0.5661 116249.9n 0.5661 116250.0n 0.5038 116499.9n 0.5038 116500.0n 0.5246 116749.9n 0.5246 116750.0n 0.5350 116999.9n 0.5350 117000.0n 0.4206 117249.9n 0.4206 117250.0n 0.5661 117499.9n 0.5661 117500.0n 0.5246 117749.9n 0.5246 117750.0n 0.5454 117999.9n 0.5454 118000.0n 0.5557 118249.9n 0.5557 118250.0n 0.5661 118499.9n 0.5661 118500.0n 0.4414 118749.9n 0.4414 118750.0n 0.5661 118999.9n 0.5661 119000.0n 0.5661 119249.9n 0.5661 119250.0n 0.5557 119499.9n 0.5557 119500.0n 0.4726 119749.9n 0.4726 119750.0n 0.4102 119999.9n 0.4102 120000.0n 0.4830 120249.9n 0.4830 120250.0n 0.5454 120499.9n 0.5454 120500.0n 0.5661 120749.9n 0.5661 120750.0n 0.5557 120999.9n 0.5557 121000.0n 0.5142 121249.9n 0.5142 121250.0n 0.5661 121499.9n 0.5661 121500.0n 0.5350 121749.9n 0.5350 121750.0n 0.5661 121999.9n 0.5661 122000.0n 0.5661 122249.9n 0.5661 122250.0n 0.2440 122499.9n 0.2440 122500.0n 0.5038 122749.9n 0.5038 122750.0n 0.5454 122999.9n 0.5454 123000.0n 0.5661 123249.9n 0.5661 123250.0n 0.2000 123499.9n 0.2000 123500.0n 0.5661 123749.9n 0.5661 123750.0n 0.5038 123999.9n 0.5038 124000.0n 0.5246 124249.9n 0.5246 124250.0n 0.5350 124499.9n 0.5350 124500.0n 0.4206 124749.9n 0.4206 124750.0n 0.5661 124999.9n 0.5661 125000.0n 0.5246 125249.9n 0.5246 125250.0n 0.5454 125499.9n 0.5454 125500.0n 0.5557 125749.9n 0.5557 125750.0n 0.5661 125999.9n 0.5661 126000.0n 0.4414 126249.9n 0.4414 126250.0n 0.5661 126499.9n 0.5661 126500.0n 0.5661 126749.9n 0.5661 126750.0n 0.5557 126999.9n 0.5557 127000.0n 0.4726 127249.9n 0.4726 127250.0n 0.4102 127499.9n 0.4102 127500.0n 0.4830 127749.9n 0.4830 127750.0n 0.5454 127999.9n 0.5454 128000.0n 0.5661 128249.9n 0.5661 128250.0n 0.5557 128499.9n 0.5557 128500.0n 0.5142 128749.9n 0.5142 128750.0n 0.5661 128999.9n 0.5661 129000.0n 0.5350 129249.9n 0.5350 129250.0n 0.5661 129499.9n 0.5661 129500.0n 0.5661 129749.9n 0.5661 129750.0n 0.2440 129999.9n 0.2440 130000.0n 0.5038 130249.9n 0.5038 130250.0n 0.5454 130499.9n 0.5454 130500.0n 0.5661 130749.9n 0.5661 130750.0n 0.2000 130999.9n 0.2000 131000.0n 0.5661 131249.9n 0.5661 131250.0n 0.5038 131499.9n 0.5038 131500.0n 0.5246 131749.9n 0.5246 131750.0n 0.5350 131999.9n 0.5350 132000.0n 0.4206 132249.9n 0.4206 132250.0n 0.5661 132499.9n 0.5661 132500.0n 0.5246 132749.9n 0.5246 132750.0n 0.5454 132999.9n 0.5454 133000.0n 0.5557 133249.9n 0.5557 133250.0n 0.5661 133499.9n 0.5661 133500.0n 0.4414 133749.9n 0.4414 133750.0n 0.5661 133999.9n 0.5661 134000.0n 0.5661 134249.9n 0.5661 134250.0n 0.5557 134499.9n 0.5557 134500.0n 0.4726 134749.9n 0.4726 134750.0n 0.4102 134999.9n 0.4102 135000.0n 0.4830 135249.9n 0.4830 135250.0n 0.5454 135499.9n 0.5454 135500.0n 0.5661 135749.9n 0.5661 135750.0n 0.5557 135999.9n 0.5557 136000.0n 0.5142 136249.9n 0.5142 136250.0n 0.5661 136499.9n 0.5661 136500.0n 0.5350 136749.9n 0.5350 136750.0n 0.5661 136999.9n 0.5661 137000.0n 0.5661 137249.9n 0.5661 137250.0n 0.2440 137499.9n 0.2440 137500.0n 0.5038 137749.9n 0.5038 137750.0n 0.5454 137999.9n 0.5454 138000.0n 0.5661 138249.9n 0.5661 138250.0n 0.2000 138499.9n 0.2000 138500.0n 0.5661 138749.9n 0.5661 138750.0n 0.5038 138999.9n 0.5038 139000.0n 0.5246 139249.9n 0.5246 139250.0n 0.5350 139499.9n 0.5350 139500.0n 0.4206 139749.9n 0.4206 139750.0n 0.5661 139999.9n 0.5661 140000.0n 0.5246 140249.9n 0.5246 140250.0n 0.5454 140499.9n 0.5454 140500.0n 0.5557 140749.9n 0.5557 140750.0n 0.5661 140999.9n 0.5661 141000.0n 0.4414 141249.9n 0.4414 141250.0n 0.5661 141499.9n 0.5661 141500.0n 0.5661 141749.9n 0.5661 141750.0n 0.5557 141999.9n 0.5557 142000.0n 0.4726 142249.9n 0.4726 142250.0n 0.4102 142499.9n 0.4102 142500.0n 0.4830 142749.9n 0.4830 142750.0n 0.5454 142999.9n 0.5454 143000.0n 0.5661 143249.9n 0.5661 143250.0n 0.5557 143499.9n 0.5557 143500.0n 0.5142 143749.9n 0.5142 143750.0n 0.5661 143999.9n 0.5661 144000.0n 0.5350 144249.9n 0.5350 144250.0n 0.5661 144499.9n 0.5661 144500.0n 0.5661 144749.9n 0.5661 144750.0n 0.2440 144999.9n 0.2440 145000.0n 0.5038 145249.9n 0.5038 145250.0n 0.5454 145499.9n 0.5454 145500.0n 0.5661 145749.9n 0.5661 145750.0n 0.2000 145999.9n 0.2000 146000.0n 0.5661 146249.9n 0.5661 146250.0n 0.5038 146499.9n 0.5038 146500.0n 0.5246 146749.9n 0.5246 146750.0n 0.5350 146999.9n 0.5350 147000.0n 0.4206 147249.9n 0.4206 147250.0n 0.5661 147499.9n 0.5661 147500.0n 0.5246 147749.9n 0.5246 147750.0n 0.5454 147999.9n 0.5454 148000.0n 0.5557 148249.9n 0.5557 148250.0n 0.5661 148499.9n 0.5661 148500.0n 0.4414 148749.9n 0.4414 148750.0n 0.5661 148999.9n 0.5661 149000.0n 0.5661 149249.9n 0.5661 149250.0n 0.5557 149499.9n 0.5557 149500.0n 0.4726 149749.9n 0.4726 149750.0n 0.4102 149999.9n 0.4102 150000.0n 0.4830 150249.9n 0.4830 150250.0n 0.5454 150499.9n 0.5454 150500.0n 0.5661 150749.9n 0.5661 150750.0n 0.5557 150999.9n 0.5557 151000.0n 0.5142 151249.9n 0.5142 151250.0n 0.5661 151499.9n 0.5661 151500.0n 0.5350 151749.9n 0.5350 151750.0n 0.5661 151999.9n 0.5661 152000.0n 0.5661 152249.9n 0.5661 152250.0n 0.2440 152499.9n 0.2440 152500.0n 0.5038 152749.9n 0.5038 152750.0n 0.5454 152999.9n 0.5454 153000.0n 0.5661 153249.9n 0.5661 153250.0n 0.2000 153499.9n 0.2000 153500.0n 0.5661 153749.9n 0.5661 153750.0n 0.5038 153999.9n 0.5038 154000.0n 0.5246 154249.9n 0.5246 154250.0n 0.5350 154499.9n 0.5350 154500.0n 0.4206 154749.9n 0.4206 154750.0n 0.5661 154999.9n 0.5661 155000.0n 0.5246 155249.9n 0.5246 155250.0n 0.5454 155499.9n 0.5454 155500.0n 0.5557 155749.9n 0.5557 155750.0n 0.5661 155999.9n 0.5661 156000.0n 0.4414 156249.9n 0.4414 156250.0n 0.5661 156499.9n 0.5661 156500.0n 0.5661 156749.9n 0.5661 156750.0n 0.5557 156999.9n 0.5557 157000.0n 0.4726 157249.9n 0.4726 157250.0n 0.4102 157499.9n 0.4102 157500.0n 0.4830 157749.9n 0.4830 157750.0n 0.5454 157999.9n 0.5454 158000.0n 0.5661 158249.9n 0.5661 158250.0n 0.5557 158499.9n 0.5557 158500.0n 0.5142 158749.9n 0.5142 158750.0n 0.5661 158999.9n 0.5661 159000.0n 0.5350 159249.9n 0.5350 159250.0n 0.5661 159499.9n 0.5661 159500.0n 0.5661 159749.9n 0.5661 159750.0n 0.2440 159999.9n 0.2440 160000.0n 0.5038 160249.9n 0.5038 160250.0n 0.5454 160499.9n 0.5454 160500.0n 0.5661 160749.9n 0.5661 160750.0n 0.2000 160999.9n 0.2000 161000.0n 0.5661 161249.9n 0.5661 161250.0n 0.5038 161499.9n 0.5038 161500.0n 0.5246 161749.9n 0.5246 161750.0n 0.5350 161999.9n 0.5350 162000.0n 0.4206 162249.9n 0.4206 162250.0n 0.5661 162499.9n 0.5661 162500.0n 0.5246 162749.9n 0.5246 162750.0n 0.5454 162999.9n 0.5454 163000.0n 0.5557 163249.9n 0.5557 163250.0n 0.5661 163499.9n 0.5661 163500.0n 0.4414 163749.9n 0.4414 163750.0n 0.5661 163999.9n 0.5661 164000.0n 0.5661 164249.9n 0.5661 164250.0n 0.5557 164499.9n 0.5557 164500.0n 0.4726 164749.9n 0.4726 164750.0n 0.4102 164999.9n 0.4102 165000.0n 0.4830 165249.9n 0.4830 165250.0n 0.5454 165499.9n 0.5454 165500.0n 0.5661 165749.9n 0.5661 165750.0n 0.5557 165999.9n 0.5557 166000.0n 0.5142 166249.9n 0.5142 166250.0n 0.5661 166499.9n 0.5661 166500.0n 0.5350 166749.9n 0.5350 166750.0n 0.5661 166999.9n 0.5661 167000.0n 0.5661 167249.9n 0.5661 167250.0n 0.2440 167499.9n 0.2440 167500.0n 0.5038 167749.9n 0.5038 167750.0n 0.5454 167999.9n 0.5454 168000.0n 0.5661 168249.9n 0.5661 168250.0n 0.2000 168499.9n 0.2000 168500.0n 0.5661 168749.9n 0.5661 168750.0n 0.5038 168999.9n 0.5038 169000.0n 0.5246 169249.9n 0.5246 169250.0n 0.5350 169499.9n 0.5350 169500.0n 0.4206 169749.9n 0.4206 169750.0n 0.5661 169999.9n 0.5661 170000.0n 0.5246 170249.9n 0.5246 170250.0n 0.5454 170499.9n 0.5454 170500.0n 0.5557 170749.9n 0.5557 170750.0n 0.5661 170999.9n 0.5661 171000.0n 0.4414 171249.9n 0.4414 171250.0n 0.5661 171499.9n 0.5661 171500.0n 0.5661 171749.9n 0.5661 171750.0n 0.5557 171999.9n 0.5557 172000.0n 0.4726 172249.9n 0.4726 172250.0n 0.4102 172499.9n 0.4102 172500.0n 0.4830 172749.9n 0.4830 172750.0n 0.5454 172999.9n 0.5454 173000.0n 0.5661 173249.9n 0.5661 173250.0n 0.5557 173499.9n 0.5557 173500.0n 0.5142 173749.9n 0.5142 173750.0n 0.5661 173999.9n 0.5661 174000.0n 0.5350 174249.9n 0.5350 174250.0n 0.5661 174499.9n 0.5661 174500.0n 0.5661 174749.9n 0.5661 174750.0n 0.2440 174999.9n 0.2440 175000.0n 0.5038 175249.9n 0.5038 175250.0n 0.5454 175499.9n 0.5454 175500.0n 0.5661 175749.9n 0.5661 175750.0n 0.2000 175999.9n 0.2000 176000.0n 0.5661 176249.9n 0.5661 176250.0n 0.5038 176499.9n 0.5038 176500.0n 0.5246 176749.9n 0.5246 176750.0n 0.5350 176999.9n 0.5350 177000.0n 0.4206 177249.9n 0.4206 177250.0n 0.5661 177499.9n 0.5661 177500.0n 0.5246 177749.9n 0.5246 177750.0n 0.5454 177999.9n 0.5454 178000.0n 0.5557 178249.9n 0.5557 178250.0n 0.5661 178499.9n 0.5661 178500.0n 0.4414 178749.9n 0.4414 178750.0n 0.5661 178999.9n 0.5661 179000.0n 0.5661 179249.9n 0.5661 179250.0n 0.5557 179499.9n 0.5557 179500.0n 0.4726 179749.9n 0.4726 179750.0n 0.4102 179999.9n 0.4102 180000.0n 0.4830 180249.9n 0.4830 180250.0n 0.5454 180499.9n 0.5454 180500.0n 0.5661 180749.9n 0.5661 180750.0n 0.5557 180999.9n 0.5557 181000.0n 0.5142 181249.9n 0.5142 181250.0n 0.5661 181499.9n 0.5661 181500.0n 0.5350 181749.9n 0.5350 181750.0n 0.5661 181999.9n 0.5661 182000.0n 0.5661 182249.9n 0.5661 182250.0n 0.2440 182499.9n 0.2440 182500.0n 0.5038 182749.9n 0.5038 182750.0n 0.5454 182999.9n 0.5454 183000.0n 0.5661 183249.9n 0.5661 183250.0n 0.2000 183499.9n 0.2000 183500.0n 0.5661 183749.9n 0.5661 183750.0n 0.5038 183999.9n 0.5038 184000.0n 0.5246 184249.9n 0.5246 184250.0n 0.5350 184499.9n 0.5350 184500.0n 0.4206 184749.9n 0.4206 184750.0n 0.5661 184999.9n 0.5661 185000.0n 0.5246 185249.9n 0.5246 185250.0n 0.5454 185499.9n 0.5454 185500.0n 0.5557 185749.9n 0.5557 185750.0n 0.5661 185999.9n 0.5661 186000.0n 0.4414 186249.9n 0.4414 186250.0n 0.5661 186499.9n 0.5661 186500.0n 0.5661 186749.9n 0.5661 186750.0n 0.5557 186999.9n 0.5557 187000.0n 0.4726 187249.9n 0.4726 187250.0n 0.4102 187499.9n 0.4102 187500.0n 0.4830 187749.9n 0.4830 187750.0n 0.5454 187999.9n 0.5454 188000.0n 0.5661 188249.9n 0.5661 188250.0n 0.5557 188499.9n 0.5557 188500.0n 0.5142 188749.9n 0.5142 188750.0n 0.5661 188999.9n 0.5661 189000.0n 0.5350 189249.9n 0.5350 189250.0n 0.5661 189499.9n 0.5661 189500.0n 0.5661 189749.9n 0.5661 189750.0n 0.2440 189999.9n 0.2440 190000.0n 0.5038 190249.9n 0.5038 190250.0n 0.5454 190499.9n 0.5454 190500.0n 0.5661 190749.9n 0.5661 190750.0n 0.2000 190999.9n 0.2000 191000.0n 0.5661 191249.9n 0.5661 191250.0n 0.5038 191499.9n 0.5038 191500.0n 0.5246 191749.9n 0.5246 191750.0n 0.5350 191999.9n 0.5350 192000.0n 0.4206 192249.9n 0.4206 192250.0n 0.5661 192499.9n 0.5661 192500.0n 0.5246 192749.9n 0.5246 192750.0n 0.5454 192999.9n 0.5454 193000.0n 0.5557 193249.9n 0.5557 193250.0n 0.5661 193499.9n 0.5661 193500.0n 0.4414 193749.9n 0.4414 193750.0n 0.5661 193999.9n 0.5661 194000.0n 0.5661 194249.9n 0.5661 194250.0n 0.5557 194499.9n 0.5557 194500.0n 0.4726 194749.9n 0.4726 194750.0n 0.4102 194999.9n 0.4102 195000.0n 0.4830 195249.9n 0.4830 195250.0n 0.5454 195499.9n 0.5454 195500.0n 0.5661 195749.9n 0.5661 195750.0n 0.5557 195999.9n 0.5557 196000.0n 0.5142 196249.9n 0.5142 196250.0n 0.5661 196499.9n 0.5661 196500.0n 0.5350 196749.9n 0.5350 196750.0n 0.5661 196999.9n 0.5661 197000.0n 0.5661 197249.9n 0.5661 197250.0n 0.2440 197499.9n 0.2440 197500.0n 0.5038 197749.9n 0.5038 197750.0n 0.5454 197999.9n 0.5454 198000.0n 0.5661 198249.9n 0.5661 198250.0n 0.2000 198499.9n 0.2000 198500.0n 0.5661 198749.9n 0.5661 198750.0n 0.5038 198999.9n 0.5038 199000.0n 0.5246 199249.9n 0.5246 199250.0n 0.5350 199499.9n 0.5350 199500.0n 0.4206 199749.9n 0.4206 199750.0n 0.5661 199999.9n 0.5661 200000.0n 0.5246 200249.9n 0.5246 200250.0n 0.5454 200499.9n 0.5454 200500.0n 0.5557 200749.9n 0.5557 200750.0n 0.5661 200999.9n 0.5661 201000.0n 0.4414 201249.9n 0.4414 201250.0n 0.5661 201499.9n 0.5661 201500.0n 0.5661 201749.9n 0.5661 201750.0n 0.5557 201999.9n 0.5557 202000.0n 0.4726 202249.9n 0.4726 202250.0n 0.4102 202499.9n 0.4102 202500.0n 0.4830 202749.9n 0.4830 202750.0n 0.5454 202999.9n 0.5454 203000.0n 0.5661 203249.9n 0.5661 203250.0n 0.5557 203499.9n 0.5557 203500.0n 0.5142 203749.9n 0.5142 203750.0n 0.5661 203999.9n 0.5661 204000.0n 0.5350 204249.9n 0.5350 204250.0n 0.5661 204499.9n 0.5661 204500.0n 0.5661 204749.9n 0.5661 204750.0n 0.2440 204999.9n 0.2440 205000.0n 0.5038 205249.9n 0.5038 205250.0n 0.5454 205499.9n 0.5454 205500.0n 0.5661 205749.9n 0.5661 205750.0n 0.2000 205999.9n 0.2000 206000.0n 0.5661 206249.9n 0.5661 206250.0n 0.5038 206499.9n 0.5038 206500.0n 0.5246 206749.9n 0.5246 206750.0n 0.5350 206999.9n 0.5350 207000.0n 0.4206 207249.9n 0.4206 207250.0n 0.5661 207499.9n 0.5661 207500.0n 0.5246 207749.9n 0.5246 207750.0n 0.5454 207999.9n 0.5454 208000.0n 0.5557 208249.9n 0.5557 208250.0n 0.5661 208499.9n 0.5661 208500.0n 0.4414 208749.9n 0.4414 208750.0n 0.5661 208999.9n 0.5661 209000.0n 0.5661 209249.9n 0.5661 209250.0n 0.5557 209499.9n 0.5557 209500.0n 0.4726 209749.9n 0.4726 209750.0n 0.4102 209999.9n 0.4102 210000.0n 0.4830 210249.9n 0.4830 210250.0n 0.5454 210499.9n 0.5454 210500.0n 0.5661 210749.9n 0.5661 210750.0n 0.5557 210999.9n 0.5557 211000.0n 0.5142 211249.9n 0.5142 211250.0n 0.5661 211499.9n 0.5661 211500.0n 0.5350 211749.9n 0.5350 211750.0n 0.5661 211999.9n 0.5661 212000.0n 0.5661 212249.9n 0.5661 212250.0n 0.2440 212499.9n 0.2440 212500.0n 0.5038 212749.9n 0.5038 212750.0n 0.5454 212999.9n 0.5454 213000.0n 0.5661 213249.9n 0.5661 213250.0n 0.2000 213499.9n 0.2000 213500.0n 0.5661 213749.9n 0.5661 213750.0n 0.5038 213999.9n 0.5038 214000.0n 0.5246 214249.9n 0.5246 214250.0n 0.5350 214499.9n 0.5350 214500.0n 0.4206 214749.9n 0.4206 214750.0n 0.5661 214999.9n 0.5661 215000.0n 0.5246 215249.9n 0.5246 215250.0n 0.5454 215499.9n 0.5454 215500.0n 0.5557 215749.9n 0.5557 215750.0n 0.5661 215999.9n 0.5661 216000.0n 0.4414 216249.9n 0.4414 216250.0n 0.5661 216499.9n 0.5661 216500.0n 0.5661 216749.9n 0.5661 216750.0n 0.5557 216999.9n 0.5557 217000.0n 0.4726 217249.9n 0.4726 217250.0n 0.4102 217499.9n 0.4102 217500.0n 0.4830 217749.9n 0.4830 217750.0n 0.5454 217999.9n 0.5454 218000.0n 0.5661 218249.9n 0.5661 218250.0n 0.5557 218499.9n 0.5557 218500.0n 0.5142 218749.9n 0.5142 218750.0n 0.5661 218999.9n 0.5661 219000.0n 0.5350 219249.9n 0.5350 219250.0n 0.5661 219499.9n 0.5661 219500.0n 0.5661 219749.9n 0.5661 219750.0n 0.2440 219999.9n 0.2440 220000.0n 0.5038 220249.9n 0.5038 220250.0n 0.5454 220499.9n 0.5454 220500.0n 0.5661 220749.9n 0.5661 220750.0n 0.2000 220999.9n 0.2000 221000.0n 0.5661 221249.9n 0.5661 221250.0n 0.5038 221499.9n 0.5038 221500.0n 0.5246 221749.9n 0.5246 221750.0n 0.5350 221999.9n 0.5350 222000.0n 0.4206 222249.9n 0.4206 222250.0n 0.5661 222499.9n 0.5661 222500.0n 0.5246 222749.9n 0.5246 222750.0n 0.5454 222999.9n 0.5454 223000.0n 0.5557 223249.9n 0.5557 223250.0n 0.5661 223499.9n 0.5661 223500.0n 0.4414 223749.9n 0.4414 223750.0n 0.5661 223999.9n 0.5661 224000.0n 0.5661 224249.9n 0.5661 224250.0n 0.5557 224499.9n 0.5557 224500.0n 0.4726 224749.9n 0.4726 224750.0n 0.4102 224999.9n 0.4102 225000.0n 0.4830 225249.9n 0.4830 225250.0n 0.5454 225499.9n 0.5454 225500.0n 0.5661 225749.9n 0.5661 225750.0n 0.5557 225999.9n 0.5557 226000.0n 0.5142 226249.9n 0.5142 226250.0n 0.5661 226499.9n 0.5661 226500.0n 0.5350 226749.9n 0.5350 226750.0n 0.5661 226999.9n 0.5661 227000.0n 0.5661 227249.9n 0.5661 227250.0n 0.2440 227499.9n 0.2440 227500.0n 0.5038 227749.9n 0.5038 227750.0n 0.5454 227999.9n 0.5454 228000.0n 0.5661 228249.9n 0.5661 228250.0n 0.2000 228499.9n 0.2000 228500.0n 0.5661 228749.9n 0.5661 228750.0n 0.5038 228999.9n 0.5038 229000.0n 0.5246 229249.9n 0.5246 229250.0n 0.5350 229499.9n 0.5350 229500.0n 0.4206 229749.9n 0.4206 229750.0n 0.5661 229999.9n 0.5661 230000.0n 0.5246 230249.9n 0.5246 230250.0n 0.5454 230499.9n 0.5454 230500.0n 0.5557 230749.9n 0.5557 230750.0n 0.5661 230999.9n 0.5661 231000.0n 0.4414 231249.9n 0.4414 231250.0n 0.5661 231499.9n 0.5661 231500.0n 0.5661 231749.9n 0.5661 231750.0n 0.5557 231999.9n 0.5557 232000.0n 0.4726 232249.9n 0.4726 232250.0n 0.4102 232499.9n 0.4102 232500.0n 0.4830 232749.9n 0.4830 232750.0n 0.5454 232999.9n 0.5454 233000.0n 0.5661 233249.9n 0.5661 233250.0n 0.5557 233499.9n 0.5557 233500.0n 0.5142 233749.9n 0.5142 233750.0n 0.5661 233999.9n 0.5661 234000.0n 0.5350 234249.9n 0.5350 234250.0n 0.5661 234499.9n 0.5661 234500.0n 0.5661 234749.9n 0.5661 234750.0n 0.2440 234999.9n 0.2440 235000.0n 0.5038 235249.9n 0.5038 235250.0n 0.5454 235499.9n 0.5454 235500.0n 0.5661 235749.9n 0.5661 235750.0n 0.2000 235999.9n 0.2000 236000.0n 0.5661 236249.9n 0.5661 236250.0n 0.5038 236499.9n 0.5038 236500.0n 0.5246 236749.9n 0.5246 236750.0n 0.5350 236999.9n 0.5350 237000.0n 0.4206 237249.9n 0.4206 237250.0n 0.5661 237499.9n 0.5661 237500.0n 0.5246 237749.9n 0.5246 237750.0n 0.5454 237999.9n 0.5454 238000.0n 0.5557 238249.9n 0.5557 238250.0n 0.5661 238499.9n 0.5661 238500.0n 0.4414 238749.9n 0.4414 238750.0n 0.5661 238999.9n 0.5661 239000.0n 0.5661 239249.9n 0.5661 239250.0n 0.5557 239499.9n 0.5557 239500.0n 0.4726 239749.9n 0.4726 239750.0n 0.4102 239999.9n 0.4102 240000.0n 0.4830 240249.9n 0.4830 240250.0n 0.5454 240499.9n 0.5454 240500.0n 0.5661 240749.9n 0.5661 240750.0n 0.5557 240999.9n 0.5557 241000.0n 0.5142 241249.9n 0.5142 241250.0n 0.5661 241499.9n 0.5661 241500.0n 0.5350 241749.9n 0.5350 241750.0n 0.5661 241999.9n 0.5661 242000.0n 0.5661 242249.9n 0.5661 242250.0n 0.2440 242499.9n 0.2440 242500.0n 0.5038 242749.9n 0.5038 242750.0n 0.5454 242999.9n 0.5454 243000.0n 0.5661 243249.9n 0.5661 243250.0n 0.2000 243499.9n 0.2000 243500.0n 0.5661 243749.9n 0.5661 243750.0n 0.5038 243999.9n 0.5038 244000.0n 0.5246 244249.9n 0.5246 244250.0n 0.5350 244499.9n 0.5350 244500.0n 0.4206 244749.9n 0.4206 244750.0n 0.5661 244999.9n 0.5661 245000.0n 0.5246 245249.9n 0.5246 245250.0n 0.5454 245499.9n 0.5454 245500.0n 0.5557 245749.9n 0.5557 245750.0n 0.5661 245999.9n 0.5661 246000.0n 0.4414 246249.9n 0.4414 246250.0n 0.5661 246499.9n 0.5661 246500.0n 0.5661 246749.9n 0.5661 246750.0n 0.5557 246999.9n 0.5557 247000.0n 0.4726 247249.9n 0.4726 247250.0n 0.4102 247499.9n 0.4102 247500.0n 0.4830 247749.9n 0.4830 247750.0n 0.5454 247999.9n 0.5454 248000.0n 0.5661 248249.9n 0.5661 248250.0n 0.5557 248499.9n 0.5557 248500.0n 0.5142 248749.9n 0.5142 248750.0n 0.5661 248999.9n 0.5661 249000.0n 0.5350 249249.9n 0.5350 249250.0n 0.5661 249499.9n 0.5661 249500.0n 0.5661 249749.9n 0.5661 249750.0n 0.2440 249999.9n 0.2440 250000.0n 0.5038 250249.9n 0.5038 250250.0n 0.5454 250499.9n 0.5454 250500.0n 0.5661 250749.9n 0.5661 250750.0n 0.2000 250999.9n 0.2000 251000.0n 0.5661 251249.9n 0.5661 251250.0n 0.5038 251499.9n 0.5038 251500.0n 0.5246 251749.9n 0.5246 251750.0n 0.5350 251999.9n 0.5350 252000.0n 0.4206 252249.9n 0.4206 252250.0n 0.5661 252499.9n 0.5661 252500.0n 0.5246 252749.9n 0.5246 252750.0n 0.5454 252999.9n 0.5454 253000.0n 0.5557 253249.9n 0.5557 253250.0n 0.5661 253499.9n 0.5661 253500.0n 0.4414 253749.9n 0.4414 253750.0n 0.5661 253999.9n 0.5661 254000.0n 0.5661 254249.9n 0.5661 254250.0n 0.5557 254499.9n 0.5557 254500.0n 0.4726 254749.9n 0.4726 254750.0n 0.4102 254999.9n 0.4102 255000.0n 0.4830 255249.9n 0.4830 255250.0n 0.5454 255499.9n 0.5454 255500.0n 0.5661 255749.9n 0.5661 255750.0n 0.5557 255999.9n 0.5557 256000.0n 0.5142 256249.9n 0.5142 256250.0n 0.5661 256499.9n 0.5661 256500.0n 0.5350 256749.9n 0.5350 256750.0n 0.5661 256999.9n 0.5661 257000.0n 0.5661 257249.9n 0.5661 257250.0n 0.2440 257499.9n 0.2440 257500.0n 0.5038 257749.9n 0.5038 257750.0n 0.5454 257999.9n 0.5454 258000.0n 0.5661 258249.9n 0.5661 258250.0n 0.2000 258499.9n 0.2000 258500.0n 0.5661 258749.9n 0.5661 258750.0n 0.5038 258999.9n 0.5038 259000.0n 0.5246 259249.9n 0.5246 259250.0n 0.5350 259499.9n 0.5350 259500.0n 0.4206 259749.9n 0.4206 259750.0n 0.5661 259999.9n 0.5661 260000.0n 0.5246 260249.9n 0.5246 260250.0n 0.5454 260499.9n 0.5454 260500.0n 0.5557 260749.9n 0.5557 260750.0n 0.5661 260999.9n 0.5661 261000.0n 0.4414 261249.9n 0.4414 261250.0n 0.5661 261499.9n 0.5661 261500.0n 0.5661 261749.9n 0.5661 261750.0n 0.5557 261999.9n 0.5557 262000.0n 0.4726 262249.9n 0.4726 262250.0n 0.4102 262499.9n 0.4102 262500.0n 0.4830 262749.9n 0.4830 262750.0n 0.5454 262999.9n 0.5454 263000.0n 0.5661 263249.9n 0.5661 263250.0n 0.5557 263499.9n 0.5557 263500.0n 0.5142 263749.9n 0.5142 263750.0n 0.5661 263999.9n 0.5661 264000.0n 0.5350 264249.9n 0.5350 264250.0n 0.5661 264499.9n 0.5661 264500.0n 0.5661 264749.9n 0.5661 264750.0n 0.2440 264999.9n 0.2440 265000.0n 0.5038 265249.9n 0.5038 265250.0n 0.5454 265499.9n 0.5454 265500.0n 0.5661 265749.9n 0.5661 265750.0n 0.2000 265999.9n 0.2000 266000.0n 0.5661 266249.9n 0.5661 266250.0n 0.5038 266499.9n 0.5038 266500.0n 0.5246 266749.9n 0.5246 266750.0n 0.5350 266999.9n 0.5350 267000.0n 0.4206 267249.9n 0.4206 267250.0n 0.5661 267499.9n 0.5661 267500.0n 0.5246 267749.9n 0.5246 267750.0n 0.5454 267999.9n 0.5454 268000.0n 0.5557 268249.9n 0.5557 268250.0n 0.5661 268499.9n 0.5661 268500.0n 0.4414 268749.9n 0.4414 268750.0n 0.5661 268999.9n 0.5661 269000.0n 0.5661 269249.9n 0.5661 269250.0n 0.5557 269499.9n 0.5557 269500.0n 0.4726 269749.9n 0.4726 269750.0n 0.4102 269999.9n 0.4102 270000.0n 0.4830 270249.9n 0.4830 270250.0n 0.5454 270499.9n 0.5454 270500.0n 0.5661 270749.9n 0.5661 270750.0n 0.5557 270999.9n 0.5557 271000.0n 0.5142 271249.9n 0.5142 271250.0n 0.5661 271499.9n 0.5661 271500.0n 0.5350 271749.9n 0.5350 271750.0n 0.5661 271999.9n 0.5661 272000.0n 0.5661 272249.9n 0.5661 272250.0n 0.2440 272499.9n 0.2440 272500.0n 0.5038 272749.9n 0.5038 272750.0n 0.5454 272999.9n 0.5454 273000.0n 0.5661 273249.9n 0.5661 273250.0n 0.2000 273499.9n 0.2000 273500.0n 0.5661 273749.9n 0.5661 273750.0n 0.5038 273999.9n 0.5038 274000.0n 0.5246 274249.9n 0.5246 274250.0n 0.5350 274499.9n 0.5350 274500.0n 0.4206 274749.9n 0.4206 274750.0n 0.5661 274999.9n 0.5661 275000.0n 0.5246 275249.9n 0.5246 275250.0n 0.5454 275499.9n 0.5454 275500.0n 0.5557 275749.9n 0.5557 275750.0n 0.5661 275999.9n 0.5661 276000.0n 0.4414 276249.9n 0.4414 276250.0n 0.5661 276499.9n 0.5661 276500.0n 0.5661 276749.9n 0.5661 276750.0n 0.5557 276999.9n 0.5557 277000.0n 0.4726 277249.9n 0.4726 277250.0n 0.4102 277499.9n 0.4102 277500.0n 0.4830 277749.9n 0.4830 277750.0n 0.5454 277999.9n 0.5454 278000.0n 0.5661 278249.9n 0.5661 278250.0n 0.5557 278499.9n 0.5557 278500.0n 0.5142 278749.9n 0.5142 278750.0n 0.5661 278999.9n 0.5661 279000.0n 0.5350 279249.9n 0.5350 279250.0n 0.5661 279499.9n 0.5661 279500.0n 0.5661 279749.9n 0.5661 279750.0n 0.2440 279999.9n 0.2440 280000.0n 0.5038 280249.9n 0.5038 280250.0n 0.5454 280499.9n 0.5454 280500.0n 0.5661 280749.9n 0.5661 280750.0n 0.2000 280999.9n 0.2000 281000.0n 0.5661 281249.9n 0.5661 281250.0n 0.5038 281499.9n 0.5038 281500.0n 0.5246 281749.9n 0.5246 281750.0n 0.5350 281999.9n 0.5350 282000.0n 0.4206 282249.9n 0.4206 282250.0n 0.5661 282499.9n 0.5661 282500.0n 0.5246 282749.9n 0.5246 282750.0n 0.5454 282999.9n 0.5454 283000.0n 0.5557 283249.9n 0.5557 283250.0n 0.5661 283499.9n 0.5661 283500.0n 0.4414 283749.9n 0.4414 283750.0n 0.5661 283999.9n 0.5661 284000.0n 0.5661 284249.9n 0.5661 284250.0n 0.5557 284499.9n 0.5557 284500.0n 0.4726 284749.9n 0.4726 284750.0n 0.4102 284999.9n 0.4102 285000.0n 0.4830 285249.9n 0.4830 285250.0n 0.5454 285499.9n 0.5454 285500.0n 0.5661 285749.9n 0.5661 285750.0n 0.5557 285999.9n 0.5557 286000.0n 0.5142 286249.9n 0.5142 286250.0n 0.5661 286499.9n 0.5661 286500.0n 0.5350 286749.9n 0.5350 286750.0n 0.5661 286999.9n 0.5661 287000.0n 0.5661 287249.9n 0.5661 287250.0n 0.2440 287499.9n 0.2440 287500.0n 0.5038 287749.9n 0.5038 287750.0n 0.5454 287999.9n 0.5454 288000.0n 0.5661 288249.9n 0.5661 288250.0n 0.2000 288499.9n 0.2000 288500.0n 0.5661 288749.9n 0.5661 288750.0n 0.5038 288999.9n 0.5038 289000.0n 0.5246 289249.9n 0.5246 289250.0n 0.5350 289499.9n 0.5350 289500.0n 0.4206 289749.9n 0.4206 289750.0n 0.5661 289999.9n 0.5661 290000.0n 0.5246 290249.9n 0.5246 290250.0n 0.5454 290499.9n 0.5454 290500.0n 0.5557 290749.9n 0.5557 290750.0n 0.5661 290999.9n 0.5661 291000.0n 0.4414 291249.9n 0.4414 291250.0n 0.5661 291499.9n 0.5661 291500.0n 0.5661 291749.9n 0.5661 291750.0n 0.5557 291999.9n 0.5557 292000.0n 0.4726 292249.9n 0.4726 292250.0n 0.4102 292499.9n 0.4102 292500.0n 0.4830 292749.9n 0.4830 292750.0n 0.5454 292999.9n 0.5454 293000.0n 0.5661 293249.9n 0.5661 293250.0n 0.5557 293499.9n 0.5557 293500.0n 0.5142 293749.9n 0.5142 293750.0n 0.5661 293999.9n 0.5661 294000.0n 0.5350 294249.9n 0.5350 294250.0n 0.5661 294499.9n 0.5661 294500.0n 0.5661 294749.9n 0.5661 294750.0n 0.2440 294999.9n 0.2440 295000.0n 0.5038 295249.9n 0.5038 295250.0n 0.5454 295499.9n 0.5454 295500.0n 0.5661 295749.9n 0.5661 295750.0n 0.2000 295999.9n 0.2000 296000.0n 0.5661 296249.9n 0.5661 296250.0n 0.5038 296499.9n 0.5038 296500.0n 0.5246 296749.9n 0.5246 296750.0n 0.5350 296999.9n 0.5350 297000.0n 0.4206 297249.9n 0.4206 297250.0n 0.5661 297499.9n 0.5661 297500.0n 0.5246 297749.9n 0.5246 297750.0n 0.5454 297999.9n 0.5454 298000.0n 0.5557 298249.9n 0.5557 298250.0n 0.5661 298499.9n 0.5661 298500.0n 0.4414 298749.9n 0.4414 298750.0n 0.5661 298999.9n 0.5661 299000.0n 0.5661 299249.9n 0.5661 299250.0n 0.5557 299499.9n 0.5557 299500.0n 0.4726 299749.9n 0.4726 299750.0n 0.4102)
Vtp0 xop0 0 PWL(0.0n 0.3000 249.9n 0.3000 250.0n 0.7000 499.9n 0.7000 500.0n 0.7000 749.9n 0.7000 750.0n 0.7000 999.9n 0.7000 1000.0n 0.7000 1249.9n 0.7000 1250.0n 0.3000 1499.9n 0.3000 1500.0n 0.7000 1749.9n 0.7000 1750.0n 0.3000 1999.9n 0.3000 2000.0n 0.3000 2249.9n 0.3000 2250.0n 0.3000 2499.9n 0.3000 2500.0n 0.7000 2749.9n 0.7000 2750.0n 0.7000 2999.9n 0.7000 3000.0n 0.3000 3249.9n 0.3000 3250.0n 0.3000 3499.9n 0.3000 3500.0n 0.3000 3749.9n 0.3000 3750.0n 0.3000 3999.9n 0.3000 4000.0n 0.3000 4249.9n 0.3000 4250.0n 0.7000 4499.9n 0.7000 4500.0n 0.7000 4749.9n 0.7000 4750.0n 0.3000 4999.9n 0.3000 5000.0n 0.7000 5249.9n 0.7000 5250.0n 0.3000 5499.9n 0.3000 5500.0n 0.7000 5749.9n 0.7000 5750.0n 0.3000 5999.9n 0.3000 6000.0n 0.3000 6249.9n 0.3000 6250.0n 0.7000 6499.9n 0.7000 6500.0n 0.3000 6749.9n 0.3000 6750.0n 0.7000 6999.9n 0.7000 7000.0n 0.7000 7249.9n 0.7000 7250.0n 0.7000 7499.9n 0.7000 7500.0n 0.3000 7749.9n 0.3000 7750.0n 0.7000 7999.9n 0.7000 8000.0n 0.7000 8249.9n 0.7000 8250.0n 0.7000 8499.9n 0.7000 8500.0n 0.7000 8749.9n 0.7000 8750.0n 0.3000 8999.9n 0.3000 9000.0n 0.7000 9249.9n 0.7000 9250.0n 0.3000 9499.9n 0.3000 9500.0n 0.3000 9749.9n 0.3000 9750.0n 0.3000 9999.9n 0.3000 10000.0n 0.7000 10249.9n 0.7000 10250.0n 0.7000 10499.9n 0.7000 10500.0n 0.3000 10749.9n 0.3000 10750.0n 0.3000 10999.9n 0.3000 11000.0n 0.3000 11249.9n 0.3000 11250.0n 0.3000 11499.9n 0.3000 11500.0n 0.3000 11749.9n 0.3000 11750.0n 0.7000 11999.9n 0.7000 12000.0n 0.7000 12249.9n 0.7000 12250.0n 0.3000 12499.9n 0.3000 12500.0n 0.7000 12749.9n 0.7000 12750.0n 0.3000 12999.9n 0.3000 13000.0n 0.7000 13249.9n 0.7000 13250.0n 0.3000 13499.9n 0.3000 13500.0n 0.3000 13749.9n 0.3000 13750.0n 0.7000 13999.9n 0.7000 14000.0n 0.3000 14249.9n 0.3000 14250.0n 0.7000 14499.9n 0.7000 14500.0n 0.7000 14749.9n 0.7000 14750.0n 0.7000 14999.9n 0.7000 15000.0n 0.3000 15249.9n 0.3000 15250.0n 0.7000 15499.9n 0.7000 15500.0n 0.7000 15749.9n 0.7000 15750.0n 0.7000 15999.9n 0.7000 16000.0n 0.7000 16249.9n 0.7000 16250.0n 0.3000 16499.9n 0.3000 16500.0n 0.7000 16749.9n 0.7000 16750.0n 0.3000 16999.9n 0.3000 17000.0n 0.3000 17249.9n 0.3000 17250.0n 0.3000 17499.9n 0.3000 17500.0n 0.7000 17749.9n 0.7000 17750.0n 0.7000 17999.9n 0.7000 18000.0n 0.3000 18249.9n 0.3000 18250.0n 0.3000 18499.9n 0.3000 18500.0n 0.3000 18749.9n 0.3000 18750.0n 0.3000 18999.9n 0.3000 19000.0n 0.3000 19249.9n 0.3000 19250.0n 0.7000 19499.9n 0.7000 19500.0n 0.7000 19749.9n 0.7000 19750.0n 0.3000 19999.9n 0.3000 20000.0n 0.7000 20249.9n 0.7000 20250.0n 0.3000 20499.9n 0.3000 20500.0n 0.7000 20749.9n 0.7000 20750.0n 0.3000 20999.9n 0.3000 21000.0n 0.3000 21249.9n 0.3000 21250.0n 0.7000 21499.9n 0.7000 21500.0n 0.3000 21749.9n 0.3000 21750.0n 0.7000 21999.9n 0.7000 22000.0n 0.7000 22249.9n 0.7000 22250.0n 0.7000 22499.9n 0.7000 22500.0n 0.3000 22749.9n 0.3000 22750.0n 0.7000 22999.9n 0.7000 23000.0n 0.7000 23249.9n 0.7000 23250.0n 0.7000 23499.9n 0.7000 23500.0n 0.7000 23749.9n 0.7000 23750.0n 0.3000 23999.9n 0.3000 24000.0n 0.7000 24249.9n 0.7000 24250.0n 0.3000 24499.9n 0.3000 24500.0n 0.3000 24749.9n 0.3000 24750.0n 0.3000 24999.9n 0.3000 25000.0n 0.7000 25249.9n 0.7000 25250.0n 0.7000 25499.9n 0.7000 25500.0n 0.3000 25749.9n 0.3000 25750.0n 0.3000 25999.9n 0.3000 26000.0n 0.3000 26249.9n 0.3000 26250.0n 0.3000 26499.9n 0.3000 26500.0n 0.3000 26749.9n 0.3000 26750.0n 0.7000 26999.9n 0.7000 27000.0n 0.7000 27249.9n 0.7000 27250.0n 0.3000 27499.9n 0.3000 27500.0n 0.7000 27749.9n 0.7000 27750.0n 0.3000 27999.9n 0.3000 28000.0n 0.7000 28249.9n 0.7000 28250.0n 0.3000 28499.9n 0.3000 28500.0n 0.3000 28749.9n 0.3000 28750.0n 0.7000 28999.9n 0.7000 29000.0n 0.3000 29249.9n 0.3000 29250.0n 0.7000 29499.9n 0.7000 29500.0n 0.7000 29749.9n 0.7000 29750.0n 0.7000 29999.9n 0.7000 30000.0n 0.3000 30249.9n 0.3000 30250.0n 0.7000 30499.9n 0.7000 30500.0n 0.7000 30749.9n 0.7000 30750.0n 0.7000 30999.9n 0.7000 31000.0n 0.7000 31249.9n 0.7000 31250.0n 0.3000 31499.9n 0.3000 31500.0n 0.7000 31749.9n 0.7000 31750.0n 0.3000 31999.9n 0.3000 32000.0n 0.3000 32249.9n 0.3000 32250.0n 0.3000 32499.9n 0.3000 32500.0n 0.7000 32749.9n 0.7000 32750.0n 0.7000 32999.9n 0.7000 33000.0n 0.3000 33249.9n 0.3000 33250.0n 0.3000 33499.9n 0.3000 33500.0n 0.3000 33749.9n 0.3000 33750.0n 0.3000 33999.9n 0.3000 34000.0n 0.3000 34249.9n 0.3000 34250.0n 0.7000 34499.9n 0.7000 34500.0n 0.7000 34749.9n 0.7000 34750.0n 0.3000 34999.9n 0.3000 35000.0n 0.7000 35249.9n 0.7000 35250.0n 0.3000 35499.9n 0.3000 35500.0n 0.7000 35749.9n 0.7000 35750.0n 0.3000 35999.9n 0.3000 36000.0n 0.3000 36249.9n 0.3000 36250.0n 0.7000 36499.9n 0.7000 36500.0n 0.3000 36749.9n 0.3000 36750.0n 0.7000 36999.9n 0.7000 37000.0n 0.7000 37249.9n 0.7000 37250.0n 0.7000 37499.9n 0.7000 37500.0n 0.3000 37749.9n 0.3000 37750.0n 0.7000 37999.9n 0.7000 38000.0n 0.7000 38249.9n 0.7000 38250.0n 0.7000 38499.9n 0.7000 38500.0n 0.7000 38749.9n 0.7000 38750.0n 0.3000 38999.9n 0.3000 39000.0n 0.7000 39249.9n 0.7000 39250.0n 0.3000 39499.9n 0.3000 39500.0n 0.3000 39749.9n 0.3000 39750.0n 0.3000 39999.9n 0.3000 40000.0n 0.7000 40249.9n 0.7000 40250.0n 0.7000 40499.9n 0.7000 40500.0n 0.3000 40749.9n 0.3000 40750.0n 0.3000 40999.9n 0.3000 41000.0n 0.3000 41249.9n 0.3000 41250.0n 0.3000 41499.9n 0.3000 41500.0n 0.3000 41749.9n 0.3000 41750.0n 0.7000 41999.9n 0.7000 42000.0n 0.7000 42249.9n 0.7000 42250.0n 0.3000 42499.9n 0.3000 42500.0n 0.7000 42749.9n 0.7000 42750.0n 0.3000 42999.9n 0.3000 43000.0n 0.7000 43249.9n 0.7000 43250.0n 0.3000 43499.9n 0.3000 43500.0n 0.3000 43749.9n 0.3000 43750.0n 0.7000 43999.9n 0.7000 44000.0n 0.3000 44249.9n 0.3000 44250.0n 0.7000 44499.9n 0.7000 44500.0n 0.7000 44749.9n 0.7000 44750.0n 0.7000 44999.9n 0.7000 45000.0n 0.3000 45249.9n 0.3000 45250.0n 0.7000 45499.9n 0.7000 45500.0n 0.7000 45749.9n 0.7000 45750.0n 0.7000 45999.9n 0.7000 46000.0n 0.7000 46249.9n 0.7000 46250.0n 0.3000 46499.9n 0.3000 46500.0n 0.7000 46749.9n 0.7000 46750.0n 0.3000 46999.9n 0.3000 47000.0n 0.3000 47249.9n 0.3000 47250.0n 0.3000 47499.9n 0.3000 47500.0n 0.7000 47749.9n 0.7000 47750.0n 0.7000 47999.9n 0.7000 48000.0n 0.3000 48249.9n 0.3000 48250.0n 0.3000 48499.9n 0.3000 48500.0n 0.3000 48749.9n 0.3000 48750.0n 0.3000 48999.9n 0.3000 49000.0n 0.3000 49249.9n 0.3000 49250.0n 0.7000 49499.9n 0.7000 49500.0n 0.7000 49749.9n 0.7000 49750.0n 0.3000 49999.9n 0.3000 50000.0n 0.7000 50249.9n 0.7000 50250.0n 0.3000 50499.9n 0.3000 50500.0n 0.7000 50749.9n 0.7000 50750.0n 0.3000 50999.9n 0.3000 51000.0n 0.3000 51249.9n 0.3000 51250.0n 0.7000 51499.9n 0.7000 51500.0n 0.3000 51749.9n 0.3000 51750.0n 0.7000 51999.9n 0.7000 52000.0n 0.7000 52249.9n 0.7000 52250.0n 0.7000 52499.9n 0.7000 52500.0n 0.3000 52749.9n 0.3000 52750.0n 0.7000 52999.9n 0.7000 53000.0n 0.7000 53249.9n 0.7000 53250.0n 0.7000 53499.9n 0.7000 53500.0n 0.7000 53749.9n 0.7000 53750.0n 0.3000 53999.9n 0.3000 54000.0n 0.7000 54249.9n 0.7000 54250.0n 0.3000 54499.9n 0.3000 54500.0n 0.3000 54749.9n 0.3000 54750.0n 0.3000 54999.9n 0.3000 55000.0n 0.7000 55249.9n 0.7000 55250.0n 0.7000 55499.9n 0.7000 55500.0n 0.3000 55749.9n 0.3000 55750.0n 0.3000 55999.9n 0.3000 56000.0n 0.3000 56249.9n 0.3000 56250.0n 0.3000 56499.9n 0.3000 56500.0n 0.3000 56749.9n 0.3000 56750.0n 0.7000 56999.9n 0.7000 57000.0n 0.7000 57249.9n 0.7000 57250.0n 0.3000 57499.9n 0.3000 57500.0n 0.7000 57749.9n 0.7000 57750.0n 0.3000 57999.9n 0.3000 58000.0n 0.7000 58249.9n 0.7000 58250.0n 0.3000 58499.9n 0.3000 58500.0n 0.3000 58749.9n 0.3000 58750.0n 0.7000 58999.9n 0.7000 59000.0n 0.3000 59249.9n 0.3000 59250.0n 0.7000 59499.9n 0.7000 59500.0n 0.7000 59749.9n 0.7000 59750.0n 0.7000 59999.9n 0.7000 60000.0n 0.3000 60249.9n 0.3000 60250.0n 0.7000 60499.9n 0.7000 60500.0n 0.7000 60749.9n 0.7000 60750.0n 0.7000 60999.9n 0.7000 61000.0n 0.7000 61249.9n 0.7000 61250.0n 0.3000 61499.9n 0.3000 61500.0n 0.7000 61749.9n 0.7000 61750.0n 0.3000 61999.9n 0.3000 62000.0n 0.3000 62249.9n 0.3000 62250.0n 0.3000 62499.9n 0.3000 62500.0n 0.7000 62749.9n 0.7000 62750.0n 0.7000 62999.9n 0.7000 63000.0n 0.3000 63249.9n 0.3000 63250.0n 0.3000 63499.9n 0.3000 63500.0n 0.3000 63749.9n 0.3000 63750.0n 0.3000 63999.9n 0.3000 64000.0n 0.3000 64249.9n 0.3000 64250.0n 0.7000 64499.9n 0.7000 64500.0n 0.7000 64749.9n 0.7000 64750.0n 0.3000 64999.9n 0.3000 65000.0n 0.7000 65249.9n 0.7000 65250.0n 0.3000 65499.9n 0.3000 65500.0n 0.7000 65749.9n 0.7000 65750.0n 0.3000 65999.9n 0.3000 66000.0n 0.3000 66249.9n 0.3000 66250.0n 0.7000 66499.9n 0.7000 66500.0n 0.3000 66749.9n 0.3000 66750.0n 0.7000 66999.9n 0.7000 67000.0n 0.7000 67249.9n 0.7000 67250.0n 0.7000 67499.9n 0.7000 67500.0n 0.3000 67749.9n 0.3000 67750.0n 0.7000 67999.9n 0.7000 68000.0n 0.7000 68249.9n 0.7000 68250.0n 0.7000 68499.9n 0.7000 68500.0n 0.7000 68749.9n 0.7000 68750.0n 0.3000 68999.9n 0.3000 69000.0n 0.7000 69249.9n 0.7000 69250.0n 0.3000 69499.9n 0.3000 69500.0n 0.3000 69749.9n 0.3000 69750.0n 0.3000 69999.9n 0.3000 70000.0n 0.7000 70249.9n 0.7000 70250.0n 0.7000 70499.9n 0.7000 70500.0n 0.3000 70749.9n 0.3000 70750.0n 0.3000 70999.9n 0.3000 71000.0n 0.3000 71249.9n 0.3000 71250.0n 0.3000 71499.9n 0.3000 71500.0n 0.3000 71749.9n 0.3000 71750.0n 0.7000 71999.9n 0.7000 72000.0n 0.7000 72249.9n 0.7000 72250.0n 0.3000 72499.9n 0.3000 72500.0n 0.7000 72749.9n 0.7000 72750.0n 0.3000 72999.9n 0.3000 73000.0n 0.7000 73249.9n 0.7000 73250.0n 0.3000 73499.9n 0.3000 73500.0n 0.3000 73749.9n 0.3000 73750.0n 0.7000 73999.9n 0.7000 74000.0n 0.3000 74249.9n 0.3000 74250.0n 0.7000 74499.9n 0.7000 74500.0n 0.7000 74749.9n 0.7000 74750.0n 0.7000 74999.9n 0.7000 75000.0n 0.3000 75249.9n 0.3000 75250.0n 0.7000 75499.9n 0.7000 75500.0n 0.7000 75749.9n 0.7000 75750.0n 0.7000 75999.9n 0.7000 76000.0n 0.7000 76249.9n 0.7000 76250.0n 0.3000 76499.9n 0.3000 76500.0n 0.7000 76749.9n 0.7000 76750.0n 0.3000 76999.9n 0.3000 77000.0n 0.3000 77249.9n 0.3000 77250.0n 0.3000 77499.9n 0.3000 77500.0n 0.7000 77749.9n 0.7000 77750.0n 0.7000 77999.9n 0.7000 78000.0n 0.3000 78249.9n 0.3000 78250.0n 0.3000 78499.9n 0.3000 78500.0n 0.3000 78749.9n 0.3000 78750.0n 0.3000 78999.9n 0.3000 79000.0n 0.3000 79249.9n 0.3000 79250.0n 0.7000 79499.9n 0.7000 79500.0n 0.7000 79749.9n 0.7000 79750.0n 0.3000 79999.9n 0.3000 80000.0n 0.7000 80249.9n 0.7000 80250.0n 0.3000 80499.9n 0.3000 80500.0n 0.7000 80749.9n 0.7000 80750.0n 0.3000 80999.9n 0.3000 81000.0n 0.3000 81249.9n 0.3000 81250.0n 0.7000 81499.9n 0.7000 81500.0n 0.3000 81749.9n 0.3000 81750.0n 0.7000 81999.9n 0.7000 82000.0n 0.7000 82249.9n 0.7000 82250.0n 0.7000 82499.9n 0.7000 82500.0n 0.3000 82749.9n 0.3000 82750.0n 0.7000 82999.9n 0.7000 83000.0n 0.7000 83249.9n 0.7000 83250.0n 0.7000 83499.9n 0.7000 83500.0n 0.7000 83749.9n 0.7000 83750.0n 0.3000 83999.9n 0.3000 84000.0n 0.7000 84249.9n 0.7000 84250.0n 0.3000 84499.9n 0.3000 84500.0n 0.3000 84749.9n 0.3000 84750.0n 0.3000 84999.9n 0.3000 85000.0n 0.7000 85249.9n 0.7000 85250.0n 0.7000 85499.9n 0.7000 85500.0n 0.3000 85749.9n 0.3000 85750.0n 0.3000 85999.9n 0.3000 86000.0n 0.3000 86249.9n 0.3000 86250.0n 0.3000 86499.9n 0.3000 86500.0n 0.3000 86749.9n 0.3000 86750.0n 0.7000 86999.9n 0.7000 87000.0n 0.7000 87249.9n 0.7000 87250.0n 0.3000 87499.9n 0.3000 87500.0n 0.7000 87749.9n 0.7000 87750.0n 0.3000 87999.9n 0.3000 88000.0n 0.7000 88249.9n 0.7000 88250.0n 0.3000 88499.9n 0.3000 88500.0n 0.3000 88749.9n 0.3000 88750.0n 0.7000 88999.9n 0.7000 89000.0n 0.3000 89249.9n 0.3000 89250.0n 0.7000 89499.9n 0.7000 89500.0n 0.7000 89749.9n 0.7000 89750.0n 0.7000 89999.9n 0.7000 90000.0n 0.3000 90249.9n 0.3000 90250.0n 0.7000 90499.9n 0.7000 90500.0n 0.7000 90749.9n 0.7000 90750.0n 0.7000 90999.9n 0.7000 91000.0n 0.7000 91249.9n 0.7000 91250.0n 0.3000 91499.9n 0.3000 91500.0n 0.7000 91749.9n 0.7000 91750.0n 0.3000 91999.9n 0.3000 92000.0n 0.3000 92249.9n 0.3000 92250.0n 0.3000 92499.9n 0.3000 92500.0n 0.7000 92749.9n 0.7000 92750.0n 0.7000 92999.9n 0.7000 93000.0n 0.3000 93249.9n 0.3000 93250.0n 0.3000 93499.9n 0.3000 93500.0n 0.3000 93749.9n 0.3000 93750.0n 0.3000 93999.9n 0.3000 94000.0n 0.3000 94249.9n 0.3000 94250.0n 0.7000 94499.9n 0.7000 94500.0n 0.7000 94749.9n 0.7000 94750.0n 0.3000 94999.9n 0.3000 95000.0n 0.7000 95249.9n 0.7000 95250.0n 0.3000 95499.9n 0.3000 95500.0n 0.7000 95749.9n 0.7000 95750.0n 0.3000 95999.9n 0.3000 96000.0n 0.3000 96249.9n 0.3000 96250.0n 0.7000 96499.9n 0.7000 96500.0n 0.3000 96749.9n 0.3000 96750.0n 0.7000 96999.9n 0.7000 97000.0n 0.7000 97249.9n 0.7000 97250.0n 0.7000 97499.9n 0.7000 97500.0n 0.3000 97749.9n 0.3000 97750.0n 0.7000 97999.9n 0.7000 98000.0n 0.7000 98249.9n 0.7000 98250.0n 0.7000 98499.9n 0.7000 98500.0n 0.7000 98749.9n 0.7000 98750.0n 0.3000 98999.9n 0.3000 99000.0n 0.7000 99249.9n 0.7000 99250.0n 0.3000 99499.9n 0.3000 99500.0n 0.3000 99749.9n 0.3000 99750.0n 0.3000 99999.9n 0.3000 100000.0n 0.7000 100249.9n 0.7000 100250.0n 0.7000 100499.9n 0.7000 100500.0n 0.3000 100749.9n 0.3000 100750.0n 0.3000 100999.9n 0.3000 101000.0n 0.3000 101249.9n 0.3000 101250.0n 0.3000 101499.9n 0.3000 101500.0n 0.3000 101749.9n 0.3000 101750.0n 0.7000 101999.9n 0.7000 102000.0n 0.7000 102249.9n 0.7000 102250.0n 0.3000 102499.9n 0.3000 102500.0n 0.7000 102749.9n 0.7000 102750.0n 0.3000 102999.9n 0.3000 103000.0n 0.7000 103249.9n 0.7000 103250.0n 0.3000 103499.9n 0.3000 103500.0n 0.3000 103749.9n 0.3000 103750.0n 0.7000 103999.9n 0.7000 104000.0n 0.3000 104249.9n 0.3000 104250.0n 0.7000 104499.9n 0.7000 104500.0n 0.7000 104749.9n 0.7000 104750.0n 0.7000 104999.9n 0.7000 105000.0n 0.3000 105249.9n 0.3000 105250.0n 0.7000 105499.9n 0.7000 105500.0n 0.7000 105749.9n 0.7000 105750.0n 0.7000 105999.9n 0.7000 106000.0n 0.7000 106249.9n 0.7000 106250.0n 0.3000 106499.9n 0.3000 106500.0n 0.7000 106749.9n 0.7000 106750.0n 0.3000 106999.9n 0.3000 107000.0n 0.3000 107249.9n 0.3000 107250.0n 0.3000 107499.9n 0.3000 107500.0n 0.7000 107749.9n 0.7000 107750.0n 0.7000 107999.9n 0.7000 108000.0n 0.3000 108249.9n 0.3000 108250.0n 0.3000 108499.9n 0.3000 108500.0n 0.3000 108749.9n 0.3000 108750.0n 0.3000 108999.9n 0.3000 109000.0n 0.3000 109249.9n 0.3000 109250.0n 0.7000 109499.9n 0.7000 109500.0n 0.7000 109749.9n 0.7000 109750.0n 0.3000 109999.9n 0.3000 110000.0n 0.7000 110249.9n 0.7000 110250.0n 0.3000 110499.9n 0.3000 110500.0n 0.7000 110749.9n 0.7000 110750.0n 0.3000 110999.9n 0.3000 111000.0n 0.3000 111249.9n 0.3000 111250.0n 0.7000 111499.9n 0.7000 111500.0n 0.3000 111749.9n 0.3000 111750.0n 0.7000 111999.9n 0.7000 112000.0n 0.7000 112249.9n 0.7000 112250.0n 0.7000 112499.9n 0.7000 112500.0n 0.3000 112749.9n 0.3000 112750.0n 0.7000 112999.9n 0.7000 113000.0n 0.7000 113249.9n 0.7000 113250.0n 0.7000 113499.9n 0.7000 113500.0n 0.7000 113749.9n 0.7000 113750.0n 0.3000 113999.9n 0.3000 114000.0n 0.7000 114249.9n 0.7000 114250.0n 0.3000 114499.9n 0.3000 114500.0n 0.3000 114749.9n 0.3000 114750.0n 0.3000 114999.9n 0.3000 115000.0n 0.7000 115249.9n 0.7000 115250.0n 0.7000 115499.9n 0.7000 115500.0n 0.3000 115749.9n 0.3000 115750.0n 0.3000 115999.9n 0.3000 116000.0n 0.3000 116249.9n 0.3000 116250.0n 0.3000 116499.9n 0.3000 116500.0n 0.3000 116749.9n 0.3000 116750.0n 0.7000 116999.9n 0.7000 117000.0n 0.7000 117249.9n 0.7000 117250.0n 0.3000 117499.9n 0.3000 117500.0n 0.7000 117749.9n 0.7000 117750.0n 0.3000 117999.9n 0.3000 118000.0n 0.7000 118249.9n 0.7000 118250.0n 0.3000 118499.9n 0.3000 118500.0n 0.3000 118749.9n 0.3000 118750.0n 0.7000 118999.9n 0.7000 119000.0n 0.3000 119249.9n 0.3000 119250.0n 0.7000 119499.9n 0.7000 119500.0n 0.7000 119749.9n 0.7000 119750.0n 0.7000 119999.9n 0.7000 120000.0n 0.3000 120249.9n 0.3000 120250.0n 0.7000 120499.9n 0.7000 120500.0n 0.7000 120749.9n 0.7000 120750.0n 0.7000 120999.9n 0.7000 121000.0n 0.7000 121249.9n 0.7000 121250.0n 0.3000 121499.9n 0.3000 121500.0n 0.7000 121749.9n 0.7000 121750.0n 0.3000 121999.9n 0.3000 122000.0n 0.3000 122249.9n 0.3000 122250.0n 0.3000 122499.9n 0.3000 122500.0n 0.7000 122749.9n 0.7000 122750.0n 0.7000 122999.9n 0.7000 123000.0n 0.3000 123249.9n 0.3000 123250.0n 0.3000 123499.9n 0.3000 123500.0n 0.3000 123749.9n 0.3000 123750.0n 0.3000 123999.9n 0.3000 124000.0n 0.3000 124249.9n 0.3000 124250.0n 0.7000 124499.9n 0.7000 124500.0n 0.7000 124749.9n 0.7000 124750.0n 0.3000 124999.9n 0.3000 125000.0n 0.7000 125249.9n 0.7000 125250.0n 0.3000 125499.9n 0.3000 125500.0n 0.7000 125749.9n 0.7000 125750.0n 0.3000 125999.9n 0.3000 126000.0n 0.3000 126249.9n 0.3000 126250.0n 0.7000 126499.9n 0.7000 126500.0n 0.3000 126749.9n 0.3000 126750.0n 0.7000 126999.9n 0.7000 127000.0n 0.7000 127249.9n 0.7000 127250.0n 0.7000 127499.9n 0.7000 127500.0n 0.3000 127749.9n 0.3000 127750.0n 0.7000 127999.9n 0.7000 128000.0n 0.7000 128249.9n 0.7000 128250.0n 0.7000 128499.9n 0.7000 128500.0n 0.7000 128749.9n 0.7000 128750.0n 0.3000 128999.9n 0.3000 129000.0n 0.7000 129249.9n 0.7000 129250.0n 0.3000 129499.9n 0.3000 129500.0n 0.3000 129749.9n 0.3000 129750.0n 0.3000 129999.9n 0.3000 130000.0n 0.7000 130249.9n 0.7000 130250.0n 0.7000 130499.9n 0.7000 130500.0n 0.3000 130749.9n 0.3000 130750.0n 0.3000 130999.9n 0.3000 131000.0n 0.3000 131249.9n 0.3000 131250.0n 0.3000 131499.9n 0.3000 131500.0n 0.3000 131749.9n 0.3000 131750.0n 0.7000 131999.9n 0.7000 132000.0n 0.7000 132249.9n 0.7000 132250.0n 0.3000 132499.9n 0.3000 132500.0n 0.7000 132749.9n 0.7000 132750.0n 0.3000 132999.9n 0.3000 133000.0n 0.7000 133249.9n 0.7000 133250.0n 0.3000 133499.9n 0.3000 133500.0n 0.3000 133749.9n 0.3000 133750.0n 0.7000 133999.9n 0.7000 134000.0n 0.3000 134249.9n 0.3000 134250.0n 0.7000 134499.9n 0.7000 134500.0n 0.7000 134749.9n 0.7000 134750.0n 0.7000 134999.9n 0.7000 135000.0n 0.3000 135249.9n 0.3000 135250.0n 0.7000 135499.9n 0.7000 135500.0n 0.7000 135749.9n 0.7000 135750.0n 0.7000 135999.9n 0.7000 136000.0n 0.7000 136249.9n 0.7000 136250.0n 0.3000 136499.9n 0.3000 136500.0n 0.7000 136749.9n 0.7000 136750.0n 0.3000 136999.9n 0.3000 137000.0n 0.3000 137249.9n 0.3000 137250.0n 0.3000 137499.9n 0.3000 137500.0n 0.7000 137749.9n 0.7000 137750.0n 0.7000 137999.9n 0.7000 138000.0n 0.3000 138249.9n 0.3000 138250.0n 0.3000 138499.9n 0.3000 138500.0n 0.3000 138749.9n 0.3000 138750.0n 0.3000 138999.9n 0.3000 139000.0n 0.3000 139249.9n 0.3000 139250.0n 0.7000 139499.9n 0.7000 139500.0n 0.7000 139749.9n 0.7000 139750.0n 0.3000 139999.9n 0.3000 140000.0n 0.7000 140249.9n 0.7000 140250.0n 0.3000 140499.9n 0.3000 140500.0n 0.7000 140749.9n 0.7000 140750.0n 0.3000 140999.9n 0.3000 141000.0n 0.3000 141249.9n 0.3000 141250.0n 0.7000 141499.9n 0.7000 141500.0n 0.3000 141749.9n 0.3000 141750.0n 0.7000 141999.9n 0.7000 142000.0n 0.7000 142249.9n 0.7000 142250.0n 0.7000 142499.9n 0.7000 142500.0n 0.3000 142749.9n 0.3000 142750.0n 0.7000 142999.9n 0.7000 143000.0n 0.7000 143249.9n 0.7000 143250.0n 0.7000 143499.9n 0.7000 143500.0n 0.7000 143749.9n 0.7000 143750.0n 0.3000 143999.9n 0.3000 144000.0n 0.7000 144249.9n 0.7000 144250.0n 0.3000 144499.9n 0.3000 144500.0n 0.3000 144749.9n 0.3000 144750.0n 0.3000 144999.9n 0.3000 145000.0n 0.7000 145249.9n 0.7000 145250.0n 0.7000 145499.9n 0.7000 145500.0n 0.3000 145749.9n 0.3000 145750.0n 0.3000 145999.9n 0.3000 146000.0n 0.3000 146249.9n 0.3000 146250.0n 0.3000 146499.9n 0.3000 146500.0n 0.3000 146749.9n 0.3000 146750.0n 0.7000 146999.9n 0.7000 147000.0n 0.7000 147249.9n 0.7000 147250.0n 0.3000 147499.9n 0.3000 147500.0n 0.7000 147749.9n 0.7000 147750.0n 0.3000 147999.9n 0.3000 148000.0n 0.7000 148249.9n 0.7000 148250.0n 0.3000 148499.9n 0.3000 148500.0n 0.3000 148749.9n 0.3000 148750.0n 0.7000 148999.9n 0.7000 149000.0n 0.3000 149249.9n 0.3000 149250.0n 0.7000 149499.9n 0.7000 149500.0n 0.7000 149749.9n 0.7000 149750.0n 0.7000 149999.9n 0.7000 150000.0n 0.3000 150249.9n 0.3000 150250.0n 0.7000 150499.9n 0.7000 150500.0n 0.7000 150749.9n 0.7000 150750.0n 0.7000 150999.9n 0.7000 151000.0n 0.7000 151249.9n 0.7000 151250.0n 0.3000 151499.9n 0.3000 151500.0n 0.7000 151749.9n 0.7000 151750.0n 0.3000 151999.9n 0.3000 152000.0n 0.3000 152249.9n 0.3000 152250.0n 0.3000 152499.9n 0.3000 152500.0n 0.7000 152749.9n 0.7000 152750.0n 0.7000 152999.9n 0.7000 153000.0n 0.3000 153249.9n 0.3000 153250.0n 0.3000 153499.9n 0.3000 153500.0n 0.3000 153749.9n 0.3000 153750.0n 0.3000 153999.9n 0.3000 154000.0n 0.3000 154249.9n 0.3000 154250.0n 0.7000 154499.9n 0.7000 154500.0n 0.7000 154749.9n 0.7000 154750.0n 0.3000 154999.9n 0.3000 155000.0n 0.7000 155249.9n 0.7000 155250.0n 0.3000 155499.9n 0.3000 155500.0n 0.7000 155749.9n 0.7000 155750.0n 0.3000 155999.9n 0.3000 156000.0n 0.3000 156249.9n 0.3000 156250.0n 0.7000 156499.9n 0.7000 156500.0n 0.3000 156749.9n 0.3000 156750.0n 0.7000 156999.9n 0.7000 157000.0n 0.7000 157249.9n 0.7000 157250.0n 0.7000 157499.9n 0.7000 157500.0n 0.3000 157749.9n 0.3000 157750.0n 0.7000 157999.9n 0.7000 158000.0n 0.7000 158249.9n 0.7000 158250.0n 0.7000 158499.9n 0.7000 158500.0n 0.7000 158749.9n 0.7000 158750.0n 0.3000 158999.9n 0.3000 159000.0n 0.7000 159249.9n 0.7000 159250.0n 0.3000 159499.9n 0.3000 159500.0n 0.3000 159749.9n 0.3000 159750.0n 0.3000 159999.9n 0.3000 160000.0n 0.7000 160249.9n 0.7000 160250.0n 0.7000 160499.9n 0.7000 160500.0n 0.3000 160749.9n 0.3000 160750.0n 0.3000 160999.9n 0.3000 161000.0n 0.3000 161249.9n 0.3000 161250.0n 0.3000 161499.9n 0.3000 161500.0n 0.3000 161749.9n 0.3000 161750.0n 0.7000 161999.9n 0.7000 162000.0n 0.7000 162249.9n 0.7000 162250.0n 0.3000 162499.9n 0.3000 162500.0n 0.7000 162749.9n 0.7000 162750.0n 0.3000 162999.9n 0.3000 163000.0n 0.7000 163249.9n 0.7000 163250.0n 0.3000 163499.9n 0.3000 163500.0n 0.3000 163749.9n 0.3000 163750.0n 0.7000 163999.9n 0.7000 164000.0n 0.3000 164249.9n 0.3000 164250.0n 0.7000 164499.9n 0.7000 164500.0n 0.7000 164749.9n 0.7000 164750.0n 0.7000 164999.9n 0.7000 165000.0n 0.3000 165249.9n 0.3000 165250.0n 0.7000 165499.9n 0.7000 165500.0n 0.7000 165749.9n 0.7000 165750.0n 0.7000 165999.9n 0.7000 166000.0n 0.7000 166249.9n 0.7000 166250.0n 0.3000 166499.9n 0.3000 166500.0n 0.7000 166749.9n 0.7000 166750.0n 0.3000 166999.9n 0.3000 167000.0n 0.3000 167249.9n 0.3000 167250.0n 0.3000 167499.9n 0.3000 167500.0n 0.7000 167749.9n 0.7000 167750.0n 0.7000 167999.9n 0.7000 168000.0n 0.3000 168249.9n 0.3000 168250.0n 0.3000 168499.9n 0.3000 168500.0n 0.3000 168749.9n 0.3000 168750.0n 0.3000 168999.9n 0.3000 169000.0n 0.3000 169249.9n 0.3000 169250.0n 0.7000 169499.9n 0.7000 169500.0n 0.7000 169749.9n 0.7000 169750.0n 0.3000 169999.9n 0.3000 170000.0n 0.7000 170249.9n 0.7000 170250.0n 0.3000 170499.9n 0.3000 170500.0n 0.7000 170749.9n 0.7000 170750.0n 0.3000 170999.9n 0.3000 171000.0n 0.3000 171249.9n 0.3000 171250.0n 0.7000 171499.9n 0.7000 171500.0n 0.3000 171749.9n 0.3000 171750.0n 0.7000 171999.9n 0.7000 172000.0n 0.7000 172249.9n 0.7000 172250.0n 0.7000 172499.9n 0.7000 172500.0n 0.3000 172749.9n 0.3000 172750.0n 0.7000 172999.9n 0.7000 173000.0n 0.7000 173249.9n 0.7000 173250.0n 0.7000 173499.9n 0.7000 173500.0n 0.7000 173749.9n 0.7000 173750.0n 0.3000 173999.9n 0.3000 174000.0n 0.7000 174249.9n 0.7000 174250.0n 0.3000 174499.9n 0.3000 174500.0n 0.3000 174749.9n 0.3000 174750.0n 0.3000 174999.9n 0.3000 175000.0n 0.7000 175249.9n 0.7000 175250.0n 0.7000 175499.9n 0.7000 175500.0n 0.3000 175749.9n 0.3000 175750.0n 0.3000 175999.9n 0.3000 176000.0n 0.3000 176249.9n 0.3000 176250.0n 0.3000 176499.9n 0.3000 176500.0n 0.3000 176749.9n 0.3000 176750.0n 0.7000 176999.9n 0.7000 177000.0n 0.7000 177249.9n 0.7000 177250.0n 0.3000 177499.9n 0.3000 177500.0n 0.7000 177749.9n 0.7000 177750.0n 0.3000 177999.9n 0.3000 178000.0n 0.7000 178249.9n 0.7000 178250.0n 0.3000 178499.9n 0.3000 178500.0n 0.3000 178749.9n 0.3000 178750.0n 0.7000 178999.9n 0.7000 179000.0n 0.3000 179249.9n 0.3000 179250.0n 0.7000 179499.9n 0.7000 179500.0n 0.7000 179749.9n 0.7000 179750.0n 0.7000 179999.9n 0.7000 180000.0n 0.3000 180249.9n 0.3000 180250.0n 0.7000 180499.9n 0.7000 180500.0n 0.7000 180749.9n 0.7000 180750.0n 0.7000 180999.9n 0.7000 181000.0n 0.7000 181249.9n 0.7000 181250.0n 0.3000 181499.9n 0.3000 181500.0n 0.7000 181749.9n 0.7000 181750.0n 0.3000 181999.9n 0.3000 182000.0n 0.3000 182249.9n 0.3000 182250.0n 0.3000 182499.9n 0.3000 182500.0n 0.7000 182749.9n 0.7000 182750.0n 0.7000 182999.9n 0.7000 183000.0n 0.3000 183249.9n 0.3000 183250.0n 0.3000 183499.9n 0.3000 183500.0n 0.3000 183749.9n 0.3000 183750.0n 0.3000 183999.9n 0.3000 184000.0n 0.3000 184249.9n 0.3000 184250.0n 0.7000 184499.9n 0.7000 184500.0n 0.7000 184749.9n 0.7000 184750.0n 0.3000 184999.9n 0.3000 185000.0n 0.7000 185249.9n 0.7000 185250.0n 0.3000 185499.9n 0.3000 185500.0n 0.7000 185749.9n 0.7000 185750.0n 0.3000 185999.9n 0.3000 186000.0n 0.3000 186249.9n 0.3000 186250.0n 0.7000 186499.9n 0.7000 186500.0n 0.3000 186749.9n 0.3000 186750.0n 0.7000 186999.9n 0.7000 187000.0n 0.7000 187249.9n 0.7000 187250.0n 0.7000 187499.9n 0.7000 187500.0n 0.3000 187749.9n 0.3000 187750.0n 0.7000 187999.9n 0.7000 188000.0n 0.7000 188249.9n 0.7000 188250.0n 0.7000 188499.9n 0.7000 188500.0n 0.7000 188749.9n 0.7000 188750.0n 0.3000 188999.9n 0.3000 189000.0n 0.7000 189249.9n 0.7000 189250.0n 0.3000 189499.9n 0.3000 189500.0n 0.3000 189749.9n 0.3000 189750.0n 0.3000 189999.9n 0.3000 190000.0n 0.7000 190249.9n 0.7000 190250.0n 0.7000 190499.9n 0.7000 190500.0n 0.3000 190749.9n 0.3000 190750.0n 0.3000 190999.9n 0.3000 191000.0n 0.3000 191249.9n 0.3000 191250.0n 0.3000 191499.9n 0.3000 191500.0n 0.3000 191749.9n 0.3000 191750.0n 0.7000 191999.9n 0.7000 192000.0n 0.7000 192249.9n 0.7000 192250.0n 0.3000 192499.9n 0.3000 192500.0n 0.7000 192749.9n 0.7000 192750.0n 0.3000 192999.9n 0.3000 193000.0n 0.7000 193249.9n 0.7000 193250.0n 0.3000 193499.9n 0.3000 193500.0n 0.3000 193749.9n 0.3000 193750.0n 0.7000 193999.9n 0.7000 194000.0n 0.3000 194249.9n 0.3000 194250.0n 0.7000 194499.9n 0.7000 194500.0n 0.7000 194749.9n 0.7000 194750.0n 0.7000 194999.9n 0.7000 195000.0n 0.3000 195249.9n 0.3000 195250.0n 0.7000 195499.9n 0.7000 195500.0n 0.7000 195749.9n 0.7000 195750.0n 0.7000 195999.9n 0.7000 196000.0n 0.7000 196249.9n 0.7000 196250.0n 0.3000 196499.9n 0.3000 196500.0n 0.7000 196749.9n 0.7000 196750.0n 0.3000 196999.9n 0.3000 197000.0n 0.3000 197249.9n 0.3000 197250.0n 0.3000 197499.9n 0.3000 197500.0n 0.7000 197749.9n 0.7000 197750.0n 0.7000 197999.9n 0.7000 198000.0n 0.3000 198249.9n 0.3000 198250.0n 0.3000 198499.9n 0.3000 198500.0n 0.3000 198749.9n 0.3000 198750.0n 0.3000 198999.9n 0.3000 199000.0n 0.3000 199249.9n 0.3000 199250.0n 0.7000 199499.9n 0.7000 199500.0n 0.7000 199749.9n 0.7000 199750.0n 0.3000 199999.9n 0.3000 200000.0n 0.7000 200249.9n 0.7000 200250.0n 0.3000 200499.9n 0.3000 200500.0n 0.7000 200749.9n 0.7000 200750.0n 0.3000 200999.9n 0.3000 201000.0n 0.3000 201249.9n 0.3000 201250.0n 0.7000 201499.9n 0.7000 201500.0n 0.3000 201749.9n 0.3000 201750.0n 0.7000 201999.9n 0.7000 202000.0n 0.7000 202249.9n 0.7000 202250.0n 0.7000 202499.9n 0.7000 202500.0n 0.3000 202749.9n 0.3000 202750.0n 0.7000 202999.9n 0.7000 203000.0n 0.7000 203249.9n 0.7000 203250.0n 0.7000 203499.9n 0.7000 203500.0n 0.7000 203749.9n 0.7000 203750.0n 0.3000 203999.9n 0.3000 204000.0n 0.7000 204249.9n 0.7000 204250.0n 0.3000 204499.9n 0.3000 204500.0n 0.3000 204749.9n 0.3000 204750.0n 0.3000 204999.9n 0.3000 205000.0n 0.7000 205249.9n 0.7000 205250.0n 0.7000 205499.9n 0.7000 205500.0n 0.3000 205749.9n 0.3000 205750.0n 0.3000 205999.9n 0.3000 206000.0n 0.3000 206249.9n 0.3000 206250.0n 0.3000 206499.9n 0.3000 206500.0n 0.3000 206749.9n 0.3000 206750.0n 0.7000 206999.9n 0.7000 207000.0n 0.7000 207249.9n 0.7000 207250.0n 0.3000 207499.9n 0.3000 207500.0n 0.7000 207749.9n 0.7000 207750.0n 0.3000 207999.9n 0.3000 208000.0n 0.7000 208249.9n 0.7000 208250.0n 0.3000 208499.9n 0.3000 208500.0n 0.3000 208749.9n 0.3000 208750.0n 0.7000 208999.9n 0.7000 209000.0n 0.3000 209249.9n 0.3000 209250.0n 0.7000 209499.9n 0.7000 209500.0n 0.7000 209749.9n 0.7000 209750.0n 0.7000 209999.9n 0.7000 210000.0n 0.3000 210249.9n 0.3000 210250.0n 0.7000 210499.9n 0.7000 210500.0n 0.7000 210749.9n 0.7000 210750.0n 0.7000 210999.9n 0.7000 211000.0n 0.7000 211249.9n 0.7000 211250.0n 0.3000 211499.9n 0.3000 211500.0n 0.7000 211749.9n 0.7000 211750.0n 0.3000 211999.9n 0.3000 212000.0n 0.3000 212249.9n 0.3000 212250.0n 0.3000 212499.9n 0.3000 212500.0n 0.7000 212749.9n 0.7000 212750.0n 0.7000 212999.9n 0.7000 213000.0n 0.3000 213249.9n 0.3000 213250.0n 0.3000 213499.9n 0.3000 213500.0n 0.3000 213749.9n 0.3000 213750.0n 0.3000 213999.9n 0.3000 214000.0n 0.3000 214249.9n 0.3000 214250.0n 0.7000 214499.9n 0.7000 214500.0n 0.7000 214749.9n 0.7000 214750.0n 0.3000 214999.9n 0.3000 215000.0n 0.7000 215249.9n 0.7000 215250.0n 0.3000 215499.9n 0.3000 215500.0n 0.7000 215749.9n 0.7000 215750.0n 0.3000 215999.9n 0.3000 216000.0n 0.3000 216249.9n 0.3000 216250.0n 0.7000 216499.9n 0.7000 216500.0n 0.3000 216749.9n 0.3000 216750.0n 0.7000 216999.9n 0.7000 217000.0n 0.7000 217249.9n 0.7000 217250.0n 0.7000 217499.9n 0.7000 217500.0n 0.3000 217749.9n 0.3000 217750.0n 0.7000 217999.9n 0.7000 218000.0n 0.7000 218249.9n 0.7000 218250.0n 0.7000 218499.9n 0.7000 218500.0n 0.7000 218749.9n 0.7000 218750.0n 0.3000 218999.9n 0.3000 219000.0n 0.7000 219249.9n 0.7000 219250.0n 0.3000 219499.9n 0.3000 219500.0n 0.3000 219749.9n 0.3000 219750.0n 0.3000 219999.9n 0.3000 220000.0n 0.7000 220249.9n 0.7000 220250.0n 0.7000 220499.9n 0.7000 220500.0n 0.3000 220749.9n 0.3000 220750.0n 0.3000 220999.9n 0.3000 221000.0n 0.3000 221249.9n 0.3000 221250.0n 0.3000 221499.9n 0.3000 221500.0n 0.3000 221749.9n 0.3000 221750.0n 0.7000 221999.9n 0.7000 222000.0n 0.7000 222249.9n 0.7000 222250.0n 0.3000 222499.9n 0.3000 222500.0n 0.7000 222749.9n 0.7000 222750.0n 0.3000 222999.9n 0.3000 223000.0n 0.7000 223249.9n 0.7000 223250.0n 0.3000 223499.9n 0.3000 223500.0n 0.3000 223749.9n 0.3000 223750.0n 0.7000 223999.9n 0.7000 224000.0n 0.3000 224249.9n 0.3000 224250.0n 0.7000 224499.9n 0.7000 224500.0n 0.7000 224749.9n 0.7000 224750.0n 0.7000 224999.9n 0.7000 225000.0n 0.3000 225249.9n 0.3000 225250.0n 0.7000 225499.9n 0.7000 225500.0n 0.7000 225749.9n 0.7000 225750.0n 0.7000 225999.9n 0.7000 226000.0n 0.7000 226249.9n 0.7000 226250.0n 0.3000 226499.9n 0.3000 226500.0n 0.7000 226749.9n 0.7000 226750.0n 0.3000 226999.9n 0.3000 227000.0n 0.3000 227249.9n 0.3000 227250.0n 0.3000 227499.9n 0.3000 227500.0n 0.7000 227749.9n 0.7000 227750.0n 0.7000 227999.9n 0.7000 228000.0n 0.3000 228249.9n 0.3000 228250.0n 0.3000 228499.9n 0.3000 228500.0n 0.3000 228749.9n 0.3000 228750.0n 0.3000 228999.9n 0.3000 229000.0n 0.3000 229249.9n 0.3000 229250.0n 0.7000 229499.9n 0.7000 229500.0n 0.7000 229749.9n 0.7000 229750.0n 0.3000 229999.9n 0.3000 230000.0n 0.7000 230249.9n 0.7000 230250.0n 0.3000 230499.9n 0.3000 230500.0n 0.7000 230749.9n 0.7000 230750.0n 0.3000 230999.9n 0.3000 231000.0n 0.3000 231249.9n 0.3000 231250.0n 0.7000 231499.9n 0.7000 231500.0n 0.3000 231749.9n 0.3000 231750.0n 0.7000 231999.9n 0.7000 232000.0n 0.7000 232249.9n 0.7000 232250.0n 0.7000 232499.9n 0.7000 232500.0n 0.3000 232749.9n 0.3000 232750.0n 0.7000 232999.9n 0.7000 233000.0n 0.7000 233249.9n 0.7000 233250.0n 0.7000 233499.9n 0.7000 233500.0n 0.7000 233749.9n 0.7000 233750.0n 0.3000 233999.9n 0.3000 234000.0n 0.7000 234249.9n 0.7000 234250.0n 0.3000 234499.9n 0.3000 234500.0n 0.3000 234749.9n 0.3000 234750.0n 0.3000 234999.9n 0.3000 235000.0n 0.7000 235249.9n 0.7000 235250.0n 0.7000 235499.9n 0.7000 235500.0n 0.3000 235749.9n 0.3000 235750.0n 0.3000 235999.9n 0.3000 236000.0n 0.3000 236249.9n 0.3000 236250.0n 0.3000 236499.9n 0.3000 236500.0n 0.3000 236749.9n 0.3000 236750.0n 0.7000 236999.9n 0.7000 237000.0n 0.7000 237249.9n 0.7000 237250.0n 0.3000 237499.9n 0.3000 237500.0n 0.7000 237749.9n 0.7000 237750.0n 0.3000 237999.9n 0.3000 238000.0n 0.7000 238249.9n 0.7000 238250.0n 0.3000 238499.9n 0.3000 238500.0n 0.3000 238749.9n 0.3000 238750.0n 0.7000 238999.9n 0.7000 239000.0n 0.3000 239249.9n 0.3000 239250.0n 0.7000 239499.9n 0.7000 239500.0n 0.7000 239749.9n 0.7000 239750.0n 0.7000 239999.9n 0.7000 240000.0n 0.3000 240249.9n 0.3000 240250.0n 0.7000 240499.9n 0.7000 240500.0n 0.7000 240749.9n 0.7000 240750.0n 0.7000 240999.9n 0.7000 241000.0n 0.7000 241249.9n 0.7000 241250.0n 0.3000 241499.9n 0.3000 241500.0n 0.7000 241749.9n 0.7000 241750.0n 0.3000 241999.9n 0.3000 242000.0n 0.3000 242249.9n 0.3000 242250.0n 0.3000 242499.9n 0.3000 242500.0n 0.7000 242749.9n 0.7000 242750.0n 0.7000 242999.9n 0.7000 243000.0n 0.3000 243249.9n 0.3000 243250.0n 0.3000 243499.9n 0.3000 243500.0n 0.3000 243749.9n 0.3000 243750.0n 0.3000 243999.9n 0.3000 244000.0n 0.3000 244249.9n 0.3000 244250.0n 0.7000 244499.9n 0.7000 244500.0n 0.7000 244749.9n 0.7000 244750.0n 0.3000 244999.9n 0.3000 245000.0n 0.7000 245249.9n 0.7000 245250.0n 0.3000 245499.9n 0.3000 245500.0n 0.7000 245749.9n 0.7000 245750.0n 0.3000 245999.9n 0.3000 246000.0n 0.3000 246249.9n 0.3000 246250.0n 0.7000 246499.9n 0.7000 246500.0n 0.3000 246749.9n 0.3000 246750.0n 0.7000 246999.9n 0.7000 247000.0n 0.7000 247249.9n 0.7000 247250.0n 0.7000 247499.9n 0.7000 247500.0n 0.3000 247749.9n 0.3000 247750.0n 0.7000 247999.9n 0.7000 248000.0n 0.7000 248249.9n 0.7000 248250.0n 0.7000 248499.9n 0.7000 248500.0n 0.7000 248749.9n 0.7000 248750.0n 0.3000 248999.9n 0.3000 249000.0n 0.7000 249249.9n 0.7000 249250.0n 0.3000 249499.9n 0.3000 249500.0n 0.3000 249749.9n 0.3000 249750.0n 0.3000 249999.9n 0.3000 250000.0n 0.7000 250249.9n 0.7000 250250.0n 0.7000 250499.9n 0.7000 250500.0n 0.3000 250749.9n 0.3000 250750.0n 0.3000 250999.9n 0.3000 251000.0n 0.3000 251249.9n 0.3000 251250.0n 0.3000 251499.9n 0.3000 251500.0n 0.3000 251749.9n 0.3000 251750.0n 0.7000 251999.9n 0.7000 252000.0n 0.7000 252249.9n 0.7000 252250.0n 0.3000 252499.9n 0.3000 252500.0n 0.7000 252749.9n 0.7000 252750.0n 0.3000 252999.9n 0.3000 253000.0n 0.7000 253249.9n 0.7000 253250.0n 0.3000 253499.9n 0.3000 253500.0n 0.3000 253749.9n 0.3000 253750.0n 0.7000 253999.9n 0.7000 254000.0n 0.3000 254249.9n 0.3000 254250.0n 0.7000 254499.9n 0.7000 254500.0n 0.7000 254749.9n 0.7000 254750.0n 0.7000 254999.9n 0.7000 255000.0n 0.3000 255249.9n 0.3000 255250.0n 0.7000 255499.9n 0.7000 255500.0n 0.7000 255749.9n 0.7000 255750.0n 0.7000 255999.9n 0.7000 256000.0n 0.7000 256249.9n 0.7000 256250.0n 0.3000 256499.9n 0.3000 256500.0n 0.7000 256749.9n 0.7000 256750.0n 0.3000 256999.9n 0.3000 257000.0n 0.3000 257249.9n 0.3000 257250.0n 0.3000 257499.9n 0.3000 257500.0n 0.7000 257749.9n 0.7000 257750.0n 0.7000 257999.9n 0.7000 258000.0n 0.3000 258249.9n 0.3000 258250.0n 0.3000 258499.9n 0.3000 258500.0n 0.3000 258749.9n 0.3000 258750.0n 0.3000 258999.9n 0.3000 259000.0n 0.3000 259249.9n 0.3000 259250.0n 0.7000 259499.9n 0.7000 259500.0n 0.7000 259749.9n 0.7000 259750.0n 0.3000 259999.9n 0.3000 260000.0n 0.7000 260249.9n 0.7000 260250.0n 0.3000 260499.9n 0.3000 260500.0n 0.7000 260749.9n 0.7000 260750.0n 0.3000 260999.9n 0.3000 261000.0n 0.3000 261249.9n 0.3000 261250.0n 0.7000 261499.9n 0.7000 261500.0n 0.3000 261749.9n 0.3000 261750.0n 0.7000 261999.9n 0.7000 262000.0n 0.7000 262249.9n 0.7000 262250.0n 0.7000 262499.9n 0.7000 262500.0n 0.3000 262749.9n 0.3000 262750.0n 0.7000 262999.9n 0.7000 263000.0n 0.7000 263249.9n 0.7000 263250.0n 0.7000 263499.9n 0.7000 263500.0n 0.7000 263749.9n 0.7000 263750.0n 0.3000 263999.9n 0.3000 264000.0n 0.7000 264249.9n 0.7000 264250.0n 0.3000 264499.9n 0.3000 264500.0n 0.3000 264749.9n 0.3000 264750.0n 0.3000 264999.9n 0.3000 265000.0n 0.7000 265249.9n 0.7000 265250.0n 0.7000 265499.9n 0.7000 265500.0n 0.3000 265749.9n 0.3000 265750.0n 0.3000 265999.9n 0.3000 266000.0n 0.3000 266249.9n 0.3000 266250.0n 0.3000 266499.9n 0.3000 266500.0n 0.3000 266749.9n 0.3000 266750.0n 0.7000 266999.9n 0.7000 267000.0n 0.7000 267249.9n 0.7000 267250.0n 0.3000 267499.9n 0.3000 267500.0n 0.7000 267749.9n 0.7000 267750.0n 0.3000 267999.9n 0.3000 268000.0n 0.7000 268249.9n 0.7000 268250.0n 0.3000 268499.9n 0.3000 268500.0n 0.3000 268749.9n 0.3000 268750.0n 0.7000 268999.9n 0.7000 269000.0n 0.3000 269249.9n 0.3000 269250.0n 0.7000 269499.9n 0.7000 269500.0n 0.7000 269749.9n 0.7000 269750.0n 0.7000 269999.9n 0.7000 270000.0n 0.3000 270249.9n 0.3000 270250.0n 0.7000 270499.9n 0.7000 270500.0n 0.7000 270749.9n 0.7000 270750.0n 0.7000 270999.9n 0.7000 271000.0n 0.7000 271249.9n 0.7000 271250.0n 0.3000 271499.9n 0.3000 271500.0n 0.7000 271749.9n 0.7000 271750.0n 0.3000 271999.9n 0.3000 272000.0n 0.3000 272249.9n 0.3000 272250.0n 0.3000 272499.9n 0.3000 272500.0n 0.7000 272749.9n 0.7000 272750.0n 0.7000 272999.9n 0.7000 273000.0n 0.3000 273249.9n 0.3000 273250.0n 0.3000 273499.9n 0.3000 273500.0n 0.3000 273749.9n 0.3000 273750.0n 0.3000 273999.9n 0.3000 274000.0n 0.3000 274249.9n 0.3000 274250.0n 0.7000 274499.9n 0.7000 274500.0n 0.7000 274749.9n 0.7000 274750.0n 0.3000 274999.9n 0.3000 275000.0n 0.7000 275249.9n 0.7000 275250.0n 0.3000 275499.9n 0.3000 275500.0n 0.7000 275749.9n 0.7000 275750.0n 0.3000 275999.9n 0.3000 276000.0n 0.3000 276249.9n 0.3000 276250.0n 0.7000 276499.9n 0.7000 276500.0n 0.3000 276749.9n 0.3000 276750.0n 0.7000 276999.9n 0.7000 277000.0n 0.7000 277249.9n 0.7000 277250.0n 0.7000 277499.9n 0.7000 277500.0n 0.3000 277749.9n 0.3000 277750.0n 0.7000 277999.9n 0.7000 278000.0n 0.7000 278249.9n 0.7000 278250.0n 0.7000 278499.9n 0.7000 278500.0n 0.7000 278749.9n 0.7000 278750.0n 0.3000 278999.9n 0.3000 279000.0n 0.7000 279249.9n 0.7000 279250.0n 0.3000 279499.9n 0.3000 279500.0n 0.3000 279749.9n 0.3000 279750.0n 0.3000 279999.9n 0.3000 280000.0n 0.7000 280249.9n 0.7000 280250.0n 0.7000 280499.9n 0.7000 280500.0n 0.3000 280749.9n 0.3000 280750.0n 0.3000 280999.9n 0.3000 281000.0n 0.3000 281249.9n 0.3000 281250.0n 0.3000 281499.9n 0.3000 281500.0n 0.3000 281749.9n 0.3000 281750.0n 0.7000 281999.9n 0.7000 282000.0n 0.7000 282249.9n 0.7000 282250.0n 0.3000 282499.9n 0.3000 282500.0n 0.7000 282749.9n 0.7000 282750.0n 0.3000 282999.9n 0.3000 283000.0n 0.7000 283249.9n 0.7000 283250.0n 0.3000 283499.9n 0.3000 283500.0n 0.3000 283749.9n 0.3000 283750.0n 0.7000 283999.9n 0.7000 284000.0n 0.3000 284249.9n 0.3000 284250.0n 0.7000 284499.9n 0.7000 284500.0n 0.7000 284749.9n 0.7000 284750.0n 0.7000 284999.9n 0.7000 285000.0n 0.3000 285249.9n 0.3000 285250.0n 0.7000 285499.9n 0.7000 285500.0n 0.7000 285749.9n 0.7000 285750.0n 0.7000 285999.9n 0.7000 286000.0n 0.7000 286249.9n 0.7000 286250.0n 0.3000 286499.9n 0.3000 286500.0n 0.7000 286749.9n 0.7000 286750.0n 0.3000 286999.9n 0.3000 287000.0n 0.3000 287249.9n 0.3000 287250.0n 0.3000 287499.9n 0.3000 287500.0n 0.7000 287749.9n 0.7000 287750.0n 0.7000 287999.9n 0.7000 288000.0n 0.3000 288249.9n 0.3000 288250.0n 0.3000 288499.9n 0.3000 288500.0n 0.3000 288749.9n 0.3000 288750.0n 0.3000 288999.9n 0.3000 289000.0n 0.3000 289249.9n 0.3000 289250.0n 0.7000 289499.9n 0.7000 289500.0n 0.7000 289749.9n 0.7000 289750.0n 0.3000 289999.9n 0.3000 290000.0n 0.7000 290249.9n 0.7000 290250.0n 0.3000 290499.9n 0.3000 290500.0n 0.7000 290749.9n 0.7000 290750.0n 0.3000 290999.9n 0.3000 291000.0n 0.3000 291249.9n 0.3000 291250.0n 0.7000 291499.9n 0.7000 291500.0n 0.3000 291749.9n 0.3000 291750.0n 0.7000 291999.9n 0.7000 292000.0n 0.7000 292249.9n 0.7000 292250.0n 0.7000 292499.9n 0.7000 292500.0n 0.3000 292749.9n 0.3000 292750.0n 0.7000 292999.9n 0.7000 293000.0n 0.7000 293249.9n 0.7000 293250.0n 0.7000 293499.9n 0.7000 293500.0n 0.7000 293749.9n 0.7000 293750.0n 0.3000 293999.9n 0.3000 294000.0n 0.7000 294249.9n 0.7000 294250.0n 0.3000 294499.9n 0.3000 294500.0n 0.3000 294749.9n 0.3000 294750.0n 0.3000 294999.9n 0.3000 295000.0n 0.7000 295249.9n 0.7000 295250.0n 0.7000 295499.9n 0.7000 295500.0n 0.3000 295749.9n 0.3000 295750.0n 0.3000 295999.9n 0.3000 296000.0n 0.3000 296249.9n 0.3000 296250.0n 0.3000 296499.9n 0.3000 296500.0n 0.3000 296749.9n 0.3000 296750.0n 0.7000 296999.9n 0.7000 297000.0n 0.7000 297249.9n 0.7000 297250.0n 0.3000 297499.9n 0.3000 297500.0n 0.7000 297749.9n 0.7000 297750.0n 0.3000 297999.9n 0.3000 298000.0n 0.7000 298249.9n 0.7000 298250.0n 0.3000 298499.9n 0.3000 298500.0n 0.3000 298749.9n 0.3000 298750.0n 0.7000 298999.9n 0.7000 299000.0n 0.3000 299249.9n 0.3000 299250.0n 0.7000 299499.9n 0.7000 299500.0n 0.7000 299749.9n 0.7000 299750.0n 0.7000)
Vtn0 xon0 0 PWL(0.0n 0.7000 249.9n 0.7000 250.0n 0.3000 499.9n 0.3000 500.0n 0.3000 749.9n 0.3000 750.0n 0.3000 999.9n 0.3000 1000.0n 0.3000 1249.9n 0.3000 1250.0n 0.7000 1499.9n 0.7000 1500.0n 0.3000 1749.9n 0.3000 1750.0n 0.7000 1999.9n 0.7000 2000.0n 0.7000 2249.9n 0.7000 2250.0n 0.7000 2499.9n 0.7000 2500.0n 0.3000 2749.9n 0.3000 2750.0n 0.3000 2999.9n 0.3000 3000.0n 0.7000 3249.9n 0.7000 3250.0n 0.7000 3499.9n 0.7000 3500.0n 0.7000 3749.9n 0.7000 3750.0n 0.7000 3999.9n 0.7000 4000.0n 0.7000 4249.9n 0.7000 4250.0n 0.3000 4499.9n 0.3000 4500.0n 0.3000 4749.9n 0.3000 4750.0n 0.7000 4999.9n 0.7000 5000.0n 0.3000 5249.9n 0.3000 5250.0n 0.7000 5499.9n 0.7000 5500.0n 0.3000 5749.9n 0.3000 5750.0n 0.7000 5999.9n 0.7000 6000.0n 0.7000 6249.9n 0.7000 6250.0n 0.3000 6499.9n 0.3000 6500.0n 0.7000 6749.9n 0.7000 6750.0n 0.3000 6999.9n 0.3000 7000.0n 0.3000 7249.9n 0.3000 7250.0n 0.3000 7499.9n 0.3000 7500.0n 0.7000 7749.9n 0.7000 7750.0n 0.3000 7999.9n 0.3000 8000.0n 0.3000 8249.9n 0.3000 8250.0n 0.3000 8499.9n 0.3000 8500.0n 0.3000 8749.9n 0.3000 8750.0n 0.7000 8999.9n 0.7000 9000.0n 0.3000 9249.9n 0.3000 9250.0n 0.7000 9499.9n 0.7000 9500.0n 0.7000 9749.9n 0.7000 9750.0n 0.7000 9999.9n 0.7000 10000.0n 0.3000 10249.9n 0.3000 10250.0n 0.3000 10499.9n 0.3000 10500.0n 0.7000 10749.9n 0.7000 10750.0n 0.7000 10999.9n 0.7000 11000.0n 0.7000 11249.9n 0.7000 11250.0n 0.7000 11499.9n 0.7000 11500.0n 0.7000 11749.9n 0.7000 11750.0n 0.3000 11999.9n 0.3000 12000.0n 0.3000 12249.9n 0.3000 12250.0n 0.7000 12499.9n 0.7000 12500.0n 0.3000 12749.9n 0.3000 12750.0n 0.7000 12999.9n 0.7000 13000.0n 0.3000 13249.9n 0.3000 13250.0n 0.7000 13499.9n 0.7000 13500.0n 0.7000 13749.9n 0.7000 13750.0n 0.3000 13999.9n 0.3000 14000.0n 0.7000 14249.9n 0.7000 14250.0n 0.3000 14499.9n 0.3000 14500.0n 0.3000 14749.9n 0.3000 14750.0n 0.3000 14999.9n 0.3000 15000.0n 0.7000 15249.9n 0.7000 15250.0n 0.3000 15499.9n 0.3000 15500.0n 0.3000 15749.9n 0.3000 15750.0n 0.3000 15999.9n 0.3000 16000.0n 0.3000 16249.9n 0.3000 16250.0n 0.7000 16499.9n 0.7000 16500.0n 0.3000 16749.9n 0.3000 16750.0n 0.7000 16999.9n 0.7000 17000.0n 0.7000 17249.9n 0.7000 17250.0n 0.7000 17499.9n 0.7000 17500.0n 0.3000 17749.9n 0.3000 17750.0n 0.3000 17999.9n 0.3000 18000.0n 0.7000 18249.9n 0.7000 18250.0n 0.7000 18499.9n 0.7000 18500.0n 0.7000 18749.9n 0.7000 18750.0n 0.7000 18999.9n 0.7000 19000.0n 0.7000 19249.9n 0.7000 19250.0n 0.3000 19499.9n 0.3000 19500.0n 0.3000 19749.9n 0.3000 19750.0n 0.7000 19999.9n 0.7000 20000.0n 0.3000 20249.9n 0.3000 20250.0n 0.7000 20499.9n 0.7000 20500.0n 0.3000 20749.9n 0.3000 20750.0n 0.7000 20999.9n 0.7000 21000.0n 0.7000 21249.9n 0.7000 21250.0n 0.3000 21499.9n 0.3000 21500.0n 0.7000 21749.9n 0.7000 21750.0n 0.3000 21999.9n 0.3000 22000.0n 0.3000 22249.9n 0.3000 22250.0n 0.3000 22499.9n 0.3000 22500.0n 0.7000 22749.9n 0.7000 22750.0n 0.3000 22999.9n 0.3000 23000.0n 0.3000 23249.9n 0.3000 23250.0n 0.3000 23499.9n 0.3000 23500.0n 0.3000 23749.9n 0.3000 23750.0n 0.7000 23999.9n 0.7000 24000.0n 0.3000 24249.9n 0.3000 24250.0n 0.7000 24499.9n 0.7000 24500.0n 0.7000 24749.9n 0.7000 24750.0n 0.7000 24999.9n 0.7000 25000.0n 0.3000 25249.9n 0.3000 25250.0n 0.3000 25499.9n 0.3000 25500.0n 0.7000 25749.9n 0.7000 25750.0n 0.7000 25999.9n 0.7000 26000.0n 0.7000 26249.9n 0.7000 26250.0n 0.7000 26499.9n 0.7000 26500.0n 0.7000 26749.9n 0.7000 26750.0n 0.3000 26999.9n 0.3000 27000.0n 0.3000 27249.9n 0.3000 27250.0n 0.7000 27499.9n 0.7000 27500.0n 0.3000 27749.9n 0.3000 27750.0n 0.7000 27999.9n 0.7000 28000.0n 0.3000 28249.9n 0.3000 28250.0n 0.7000 28499.9n 0.7000 28500.0n 0.7000 28749.9n 0.7000 28750.0n 0.3000 28999.9n 0.3000 29000.0n 0.7000 29249.9n 0.7000 29250.0n 0.3000 29499.9n 0.3000 29500.0n 0.3000 29749.9n 0.3000 29750.0n 0.3000 29999.9n 0.3000 30000.0n 0.7000 30249.9n 0.7000 30250.0n 0.3000 30499.9n 0.3000 30500.0n 0.3000 30749.9n 0.3000 30750.0n 0.3000 30999.9n 0.3000 31000.0n 0.3000 31249.9n 0.3000 31250.0n 0.7000 31499.9n 0.7000 31500.0n 0.3000 31749.9n 0.3000 31750.0n 0.7000 31999.9n 0.7000 32000.0n 0.7000 32249.9n 0.7000 32250.0n 0.7000 32499.9n 0.7000 32500.0n 0.3000 32749.9n 0.3000 32750.0n 0.3000 32999.9n 0.3000 33000.0n 0.7000 33249.9n 0.7000 33250.0n 0.7000 33499.9n 0.7000 33500.0n 0.7000 33749.9n 0.7000 33750.0n 0.7000 33999.9n 0.7000 34000.0n 0.7000 34249.9n 0.7000 34250.0n 0.3000 34499.9n 0.3000 34500.0n 0.3000 34749.9n 0.3000 34750.0n 0.7000 34999.9n 0.7000 35000.0n 0.3000 35249.9n 0.3000 35250.0n 0.7000 35499.9n 0.7000 35500.0n 0.3000 35749.9n 0.3000 35750.0n 0.7000 35999.9n 0.7000 36000.0n 0.7000 36249.9n 0.7000 36250.0n 0.3000 36499.9n 0.3000 36500.0n 0.7000 36749.9n 0.7000 36750.0n 0.3000 36999.9n 0.3000 37000.0n 0.3000 37249.9n 0.3000 37250.0n 0.3000 37499.9n 0.3000 37500.0n 0.7000 37749.9n 0.7000 37750.0n 0.3000 37999.9n 0.3000 38000.0n 0.3000 38249.9n 0.3000 38250.0n 0.3000 38499.9n 0.3000 38500.0n 0.3000 38749.9n 0.3000 38750.0n 0.7000 38999.9n 0.7000 39000.0n 0.3000 39249.9n 0.3000 39250.0n 0.7000 39499.9n 0.7000 39500.0n 0.7000 39749.9n 0.7000 39750.0n 0.7000 39999.9n 0.7000 40000.0n 0.3000 40249.9n 0.3000 40250.0n 0.3000 40499.9n 0.3000 40500.0n 0.7000 40749.9n 0.7000 40750.0n 0.7000 40999.9n 0.7000 41000.0n 0.7000 41249.9n 0.7000 41250.0n 0.7000 41499.9n 0.7000 41500.0n 0.7000 41749.9n 0.7000 41750.0n 0.3000 41999.9n 0.3000 42000.0n 0.3000 42249.9n 0.3000 42250.0n 0.7000 42499.9n 0.7000 42500.0n 0.3000 42749.9n 0.3000 42750.0n 0.7000 42999.9n 0.7000 43000.0n 0.3000 43249.9n 0.3000 43250.0n 0.7000 43499.9n 0.7000 43500.0n 0.7000 43749.9n 0.7000 43750.0n 0.3000 43999.9n 0.3000 44000.0n 0.7000 44249.9n 0.7000 44250.0n 0.3000 44499.9n 0.3000 44500.0n 0.3000 44749.9n 0.3000 44750.0n 0.3000 44999.9n 0.3000 45000.0n 0.7000 45249.9n 0.7000 45250.0n 0.3000 45499.9n 0.3000 45500.0n 0.3000 45749.9n 0.3000 45750.0n 0.3000 45999.9n 0.3000 46000.0n 0.3000 46249.9n 0.3000 46250.0n 0.7000 46499.9n 0.7000 46500.0n 0.3000 46749.9n 0.3000 46750.0n 0.7000 46999.9n 0.7000 47000.0n 0.7000 47249.9n 0.7000 47250.0n 0.7000 47499.9n 0.7000 47500.0n 0.3000 47749.9n 0.3000 47750.0n 0.3000 47999.9n 0.3000 48000.0n 0.7000 48249.9n 0.7000 48250.0n 0.7000 48499.9n 0.7000 48500.0n 0.7000 48749.9n 0.7000 48750.0n 0.7000 48999.9n 0.7000 49000.0n 0.7000 49249.9n 0.7000 49250.0n 0.3000 49499.9n 0.3000 49500.0n 0.3000 49749.9n 0.3000 49750.0n 0.7000 49999.9n 0.7000 50000.0n 0.3000 50249.9n 0.3000 50250.0n 0.7000 50499.9n 0.7000 50500.0n 0.3000 50749.9n 0.3000 50750.0n 0.7000 50999.9n 0.7000 51000.0n 0.7000 51249.9n 0.7000 51250.0n 0.3000 51499.9n 0.3000 51500.0n 0.7000 51749.9n 0.7000 51750.0n 0.3000 51999.9n 0.3000 52000.0n 0.3000 52249.9n 0.3000 52250.0n 0.3000 52499.9n 0.3000 52500.0n 0.7000 52749.9n 0.7000 52750.0n 0.3000 52999.9n 0.3000 53000.0n 0.3000 53249.9n 0.3000 53250.0n 0.3000 53499.9n 0.3000 53500.0n 0.3000 53749.9n 0.3000 53750.0n 0.7000 53999.9n 0.7000 54000.0n 0.3000 54249.9n 0.3000 54250.0n 0.7000 54499.9n 0.7000 54500.0n 0.7000 54749.9n 0.7000 54750.0n 0.7000 54999.9n 0.7000 55000.0n 0.3000 55249.9n 0.3000 55250.0n 0.3000 55499.9n 0.3000 55500.0n 0.7000 55749.9n 0.7000 55750.0n 0.7000 55999.9n 0.7000 56000.0n 0.7000 56249.9n 0.7000 56250.0n 0.7000 56499.9n 0.7000 56500.0n 0.7000 56749.9n 0.7000 56750.0n 0.3000 56999.9n 0.3000 57000.0n 0.3000 57249.9n 0.3000 57250.0n 0.7000 57499.9n 0.7000 57500.0n 0.3000 57749.9n 0.3000 57750.0n 0.7000 57999.9n 0.7000 58000.0n 0.3000 58249.9n 0.3000 58250.0n 0.7000 58499.9n 0.7000 58500.0n 0.7000 58749.9n 0.7000 58750.0n 0.3000 58999.9n 0.3000 59000.0n 0.7000 59249.9n 0.7000 59250.0n 0.3000 59499.9n 0.3000 59500.0n 0.3000 59749.9n 0.3000 59750.0n 0.3000 59999.9n 0.3000 60000.0n 0.7000 60249.9n 0.7000 60250.0n 0.3000 60499.9n 0.3000 60500.0n 0.3000 60749.9n 0.3000 60750.0n 0.3000 60999.9n 0.3000 61000.0n 0.3000 61249.9n 0.3000 61250.0n 0.7000 61499.9n 0.7000 61500.0n 0.3000 61749.9n 0.3000 61750.0n 0.7000 61999.9n 0.7000 62000.0n 0.7000 62249.9n 0.7000 62250.0n 0.7000 62499.9n 0.7000 62500.0n 0.3000 62749.9n 0.3000 62750.0n 0.3000 62999.9n 0.3000 63000.0n 0.7000 63249.9n 0.7000 63250.0n 0.7000 63499.9n 0.7000 63500.0n 0.7000 63749.9n 0.7000 63750.0n 0.7000 63999.9n 0.7000 64000.0n 0.7000 64249.9n 0.7000 64250.0n 0.3000 64499.9n 0.3000 64500.0n 0.3000 64749.9n 0.3000 64750.0n 0.7000 64999.9n 0.7000 65000.0n 0.3000 65249.9n 0.3000 65250.0n 0.7000 65499.9n 0.7000 65500.0n 0.3000 65749.9n 0.3000 65750.0n 0.7000 65999.9n 0.7000 66000.0n 0.7000 66249.9n 0.7000 66250.0n 0.3000 66499.9n 0.3000 66500.0n 0.7000 66749.9n 0.7000 66750.0n 0.3000 66999.9n 0.3000 67000.0n 0.3000 67249.9n 0.3000 67250.0n 0.3000 67499.9n 0.3000 67500.0n 0.7000 67749.9n 0.7000 67750.0n 0.3000 67999.9n 0.3000 68000.0n 0.3000 68249.9n 0.3000 68250.0n 0.3000 68499.9n 0.3000 68500.0n 0.3000 68749.9n 0.3000 68750.0n 0.7000 68999.9n 0.7000 69000.0n 0.3000 69249.9n 0.3000 69250.0n 0.7000 69499.9n 0.7000 69500.0n 0.7000 69749.9n 0.7000 69750.0n 0.7000 69999.9n 0.7000 70000.0n 0.3000 70249.9n 0.3000 70250.0n 0.3000 70499.9n 0.3000 70500.0n 0.7000 70749.9n 0.7000 70750.0n 0.7000 70999.9n 0.7000 71000.0n 0.7000 71249.9n 0.7000 71250.0n 0.7000 71499.9n 0.7000 71500.0n 0.7000 71749.9n 0.7000 71750.0n 0.3000 71999.9n 0.3000 72000.0n 0.3000 72249.9n 0.3000 72250.0n 0.7000 72499.9n 0.7000 72500.0n 0.3000 72749.9n 0.3000 72750.0n 0.7000 72999.9n 0.7000 73000.0n 0.3000 73249.9n 0.3000 73250.0n 0.7000 73499.9n 0.7000 73500.0n 0.7000 73749.9n 0.7000 73750.0n 0.3000 73999.9n 0.3000 74000.0n 0.7000 74249.9n 0.7000 74250.0n 0.3000 74499.9n 0.3000 74500.0n 0.3000 74749.9n 0.3000 74750.0n 0.3000 74999.9n 0.3000 75000.0n 0.7000 75249.9n 0.7000 75250.0n 0.3000 75499.9n 0.3000 75500.0n 0.3000 75749.9n 0.3000 75750.0n 0.3000 75999.9n 0.3000 76000.0n 0.3000 76249.9n 0.3000 76250.0n 0.7000 76499.9n 0.7000 76500.0n 0.3000 76749.9n 0.3000 76750.0n 0.7000 76999.9n 0.7000 77000.0n 0.7000 77249.9n 0.7000 77250.0n 0.7000 77499.9n 0.7000 77500.0n 0.3000 77749.9n 0.3000 77750.0n 0.3000 77999.9n 0.3000 78000.0n 0.7000 78249.9n 0.7000 78250.0n 0.7000 78499.9n 0.7000 78500.0n 0.7000 78749.9n 0.7000 78750.0n 0.7000 78999.9n 0.7000 79000.0n 0.7000 79249.9n 0.7000 79250.0n 0.3000 79499.9n 0.3000 79500.0n 0.3000 79749.9n 0.3000 79750.0n 0.7000 79999.9n 0.7000 80000.0n 0.3000 80249.9n 0.3000 80250.0n 0.7000 80499.9n 0.7000 80500.0n 0.3000 80749.9n 0.3000 80750.0n 0.7000 80999.9n 0.7000 81000.0n 0.7000 81249.9n 0.7000 81250.0n 0.3000 81499.9n 0.3000 81500.0n 0.7000 81749.9n 0.7000 81750.0n 0.3000 81999.9n 0.3000 82000.0n 0.3000 82249.9n 0.3000 82250.0n 0.3000 82499.9n 0.3000 82500.0n 0.7000 82749.9n 0.7000 82750.0n 0.3000 82999.9n 0.3000 83000.0n 0.3000 83249.9n 0.3000 83250.0n 0.3000 83499.9n 0.3000 83500.0n 0.3000 83749.9n 0.3000 83750.0n 0.7000 83999.9n 0.7000 84000.0n 0.3000 84249.9n 0.3000 84250.0n 0.7000 84499.9n 0.7000 84500.0n 0.7000 84749.9n 0.7000 84750.0n 0.7000 84999.9n 0.7000 85000.0n 0.3000 85249.9n 0.3000 85250.0n 0.3000 85499.9n 0.3000 85500.0n 0.7000 85749.9n 0.7000 85750.0n 0.7000 85999.9n 0.7000 86000.0n 0.7000 86249.9n 0.7000 86250.0n 0.7000 86499.9n 0.7000 86500.0n 0.7000 86749.9n 0.7000 86750.0n 0.3000 86999.9n 0.3000 87000.0n 0.3000 87249.9n 0.3000 87250.0n 0.7000 87499.9n 0.7000 87500.0n 0.3000 87749.9n 0.3000 87750.0n 0.7000 87999.9n 0.7000 88000.0n 0.3000 88249.9n 0.3000 88250.0n 0.7000 88499.9n 0.7000 88500.0n 0.7000 88749.9n 0.7000 88750.0n 0.3000 88999.9n 0.3000 89000.0n 0.7000 89249.9n 0.7000 89250.0n 0.3000 89499.9n 0.3000 89500.0n 0.3000 89749.9n 0.3000 89750.0n 0.3000 89999.9n 0.3000 90000.0n 0.7000 90249.9n 0.7000 90250.0n 0.3000 90499.9n 0.3000 90500.0n 0.3000 90749.9n 0.3000 90750.0n 0.3000 90999.9n 0.3000 91000.0n 0.3000 91249.9n 0.3000 91250.0n 0.7000 91499.9n 0.7000 91500.0n 0.3000 91749.9n 0.3000 91750.0n 0.7000 91999.9n 0.7000 92000.0n 0.7000 92249.9n 0.7000 92250.0n 0.7000 92499.9n 0.7000 92500.0n 0.3000 92749.9n 0.3000 92750.0n 0.3000 92999.9n 0.3000 93000.0n 0.7000 93249.9n 0.7000 93250.0n 0.7000 93499.9n 0.7000 93500.0n 0.7000 93749.9n 0.7000 93750.0n 0.7000 93999.9n 0.7000 94000.0n 0.7000 94249.9n 0.7000 94250.0n 0.3000 94499.9n 0.3000 94500.0n 0.3000 94749.9n 0.3000 94750.0n 0.7000 94999.9n 0.7000 95000.0n 0.3000 95249.9n 0.3000 95250.0n 0.7000 95499.9n 0.7000 95500.0n 0.3000 95749.9n 0.3000 95750.0n 0.7000 95999.9n 0.7000 96000.0n 0.7000 96249.9n 0.7000 96250.0n 0.3000 96499.9n 0.3000 96500.0n 0.7000 96749.9n 0.7000 96750.0n 0.3000 96999.9n 0.3000 97000.0n 0.3000 97249.9n 0.3000 97250.0n 0.3000 97499.9n 0.3000 97500.0n 0.7000 97749.9n 0.7000 97750.0n 0.3000 97999.9n 0.3000 98000.0n 0.3000 98249.9n 0.3000 98250.0n 0.3000 98499.9n 0.3000 98500.0n 0.3000 98749.9n 0.3000 98750.0n 0.7000 98999.9n 0.7000 99000.0n 0.3000 99249.9n 0.3000 99250.0n 0.7000 99499.9n 0.7000 99500.0n 0.7000 99749.9n 0.7000 99750.0n 0.7000 99999.9n 0.7000 100000.0n 0.3000 100249.9n 0.3000 100250.0n 0.3000 100499.9n 0.3000 100500.0n 0.7000 100749.9n 0.7000 100750.0n 0.7000 100999.9n 0.7000 101000.0n 0.7000 101249.9n 0.7000 101250.0n 0.7000 101499.9n 0.7000 101500.0n 0.7000 101749.9n 0.7000 101750.0n 0.3000 101999.9n 0.3000 102000.0n 0.3000 102249.9n 0.3000 102250.0n 0.7000 102499.9n 0.7000 102500.0n 0.3000 102749.9n 0.3000 102750.0n 0.7000 102999.9n 0.7000 103000.0n 0.3000 103249.9n 0.3000 103250.0n 0.7000 103499.9n 0.7000 103500.0n 0.7000 103749.9n 0.7000 103750.0n 0.3000 103999.9n 0.3000 104000.0n 0.7000 104249.9n 0.7000 104250.0n 0.3000 104499.9n 0.3000 104500.0n 0.3000 104749.9n 0.3000 104750.0n 0.3000 104999.9n 0.3000 105000.0n 0.7000 105249.9n 0.7000 105250.0n 0.3000 105499.9n 0.3000 105500.0n 0.3000 105749.9n 0.3000 105750.0n 0.3000 105999.9n 0.3000 106000.0n 0.3000 106249.9n 0.3000 106250.0n 0.7000 106499.9n 0.7000 106500.0n 0.3000 106749.9n 0.3000 106750.0n 0.7000 106999.9n 0.7000 107000.0n 0.7000 107249.9n 0.7000 107250.0n 0.7000 107499.9n 0.7000 107500.0n 0.3000 107749.9n 0.3000 107750.0n 0.3000 107999.9n 0.3000 108000.0n 0.7000 108249.9n 0.7000 108250.0n 0.7000 108499.9n 0.7000 108500.0n 0.7000 108749.9n 0.7000 108750.0n 0.7000 108999.9n 0.7000 109000.0n 0.7000 109249.9n 0.7000 109250.0n 0.3000 109499.9n 0.3000 109500.0n 0.3000 109749.9n 0.3000 109750.0n 0.7000 109999.9n 0.7000 110000.0n 0.3000 110249.9n 0.3000 110250.0n 0.7000 110499.9n 0.7000 110500.0n 0.3000 110749.9n 0.3000 110750.0n 0.7000 110999.9n 0.7000 111000.0n 0.7000 111249.9n 0.7000 111250.0n 0.3000 111499.9n 0.3000 111500.0n 0.7000 111749.9n 0.7000 111750.0n 0.3000 111999.9n 0.3000 112000.0n 0.3000 112249.9n 0.3000 112250.0n 0.3000 112499.9n 0.3000 112500.0n 0.7000 112749.9n 0.7000 112750.0n 0.3000 112999.9n 0.3000 113000.0n 0.3000 113249.9n 0.3000 113250.0n 0.3000 113499.9n 0.3000 113500.0n 0.3000 113749.9n 0.3000 113750.0n 0.7000 113999.9n 0.7000 114000.0n 0.3000 114249.9n 0.3000 114250.0n 0.7000 114499.9n 0.7000 114500.0n 0.7000 114749.9n 0.7000 114750.0n 0.7000 114999.9n 0.7000 115000.0n 0.3000 115249.9n 0.3000 115250.0n 0.3000 115499.9n 0.3000 115500.0n 0.7000 115749.9n 0.7000 115750.0n 0.7000 115999.9n 0.7000 116000.0n 0.7000 116249.9n 0.7000 116250.0n 0.7000 116499.9n 0.7000 116500.0n 0.7000 116749.9n 0.7000 116750.0n 0.3000 116999.9n 0.3000 117000.0n 0.3000 117249.9n 0.3000 117250.0n 0.7000 117499.9n 0.7000 117500.0n 0.3000 117749.9n 0.3000 117750.0n 0.7000 117999.9n 0.7000 118000.0n 0.3000 118249.9n 0.3000 118250.0n 0.7000 118499.9n 0.7000 118500.0n 0.7000 118749.9n 0.7000 118750.0n 0.3000 118999.9n 0.3000 119000.0n 0.7000 119249.9n 0.7000 119250.0n 0.3000 119499.9n 0.3000 119500.0n 0.3000 119749.9n 0.3000 119750.0n 0.3000 119999.9n 0.3000 120000.0n 0.7000 120249.9n 0.7000 120250.0n 0.3000 120499.9n 0.3000 120500.0n 0.3000 120749.9n 0.3000 120750.0n 0.3000 120999.9n 0.3000 121000.0n 0.3000 121249.9n 0.3000 121250.0n 0.7000 121499.9n 0.7000 121500.0n 0.3000 121749.9n 0.3000 121750.0n 0.7000 121999.9n 0.7000 122000.0n 0.7000 122249.9n 0.7000 122250.0n 0.7000 122499.9n 0.7000 122500.0n 0.3000 122749.9n 0.3000 122750.0n 0.3000 122999.9n 0.3000 123000.0n 0.7000 123249.9n 0.7000 123250.0n 0.7000 123499.9n 0.7000 123500.0n 0.7000 123749.9n 0.7000 123750.0n 0.7000 123999.9n 0.7000 124000.0n 0.7000 124249.9n 0.7000 124250.0n 0.3000 124499.9n 0.3000 124500.0n 0.3000 124749.9n 0.3000 124750.0n 0.7000 124999.9n 0.7000 125000.0n 0.3000 125249.9n 0.3000 125250.0n 0.7000 125499.9n 0.7000 125500.0n 0.3000 125749.9n 0.3000 125750.0n 0.7000 125999.9n 0.7000 126000.0n 0.7000 126249.9n 0.7000 126250.0n 0.3000 126499.9n 0.3000 126500.0n 0.7000 126749.9n 0.7000 126750.0n 0.3000 126999.9n 0.3000 127000.0n 0.3000 127249.9n 0.3000 127250.0n 0.3000 127499.9n 0.3000 127500.0n 0.7000 127749.9n 0.7000 127750.0n 0.3000 127999.9n 0.3000 128000.0n 0.3000 128249.9n 0.3000 128250.0n 0.3000 128499.9n 0.3000 128500.0n 0.3000 128749.9n 0.3000 128750.0n 0.7000 128999.9n 0.7000 129000.0n 0.3000 129249.9n 0.3000 129250.0n 0.7000 129499.9n 0.7000 129500.0n 0.7000 129749.9n 0.7000 129750.0n 0.7000 129999.9n 0.7000 130000.0n 0.3000 130249.9n 0.3000 130250.0n 0.3000 130499.9n 0.3000 130500.0n 0.7000 130749.9n 0.7000 130750.0n 0.7000 130999.9n 0.7000 131000.0n 0.7000 131249.9n 0.7000 131250.0n 0.7000 131499.9n 0.7000 131500.0n 0.7000 131749.9n 0.7000 131750.0n 0.3000 131999.9n 0.3000 132000.0n 0.3000 132249.9n 0.3000 132250.0n 0.7000 132499.9n 0.7000 132500.0n 0.3000 132749.9n 0.3000 132750.0n 0.7000 132999.9n 0.7000 133000.0n 0.3000 133249.9n 0.3000 133250.0n 0.7000 133499.9n 0.7000 133500.0n 0.7000 133749.9n 0.7000 133750.0n 0.3000 133999.9n 0.3000 134000.0n 0.7000 134249.9n 0.7000 134250.0n 0.3000 134499.9n 0.3000 134500.0n 0.3000 134749.9n 0.3000 134750.0n 0.3000 134999.9n 0.3000 135000.0n 0.7000 135249.9n 0.7000 135250.0n 0.3000 135499.9n 0.3000 135500.0n 0.3000 135749.9n 0.3000 135750.0n 0.3000 135999.9n 0.3000 136000.0n 0.3000 136249.9n 0.3000 136250.0n 0.7000 136499.9n 0.7000 136500.0n 0.3000 136749.9n 0.3000 136750.0n 0.7000 136999.9n 0.7000 137000.0n 0.7000 137249.9n 0.7000 137250.0n 0.7000 137499.9n 0.7000 137500.0n 0.3000 137749.9n 0.3000 137750.0n 0.3000 137999.9n 0.3000 138000.0n 0.7000 138249.9n 0.7000 138250.0n 0.7000 138499.9n 0.7000 138500.0n 0.7000 138749.9n 0.7000 138750.0n 0.7000 138999.9n 0.7000 139000.0n 0.7000 139249.9n 0.7000 139250.0n 0.3000 139499.9n 0.3000 139500.0n 0.3000 139749.9n 0.3000 139750.0n 0.7000 139999.9n 0.7000 140000.0n 0.3000 140249.9n 0.3000 140250.0n 0.7000 140499.9n 0.7000 140500.0n 0.3000 140749.9n 0.3000 140750.0n 0.7000 140999.9n 0.7000 141000.0n 0.7000 141249.9n 0.7000 141250.0n 0.3000 141499.9n 0.3000 141500.0n 0.7000 141749.9n 0.7000 141750.0n 0.3000 141999.9n 0.3000 142000.0n 0.3000 142249.9n 0.3000 142250.0n 0.3000 142499.9n 0.3000 142500.0n 0.7000 142749.9n 0.7000 142750.0n 0.3000 142999.9n 0.3000 143000.0n 0.3000 143249.9n 0.3000 143250.0n 0.3000 143499.9n 0.3000 143500.0n 0.3000 143749.9n 0.3000 143750.0n 0.7000 143999.9n 0.7000 144000.0n 0.3000 144249.9n 0.3000 144250.0n 0.7000 144499.9n 0.7000 144500.0n 0.7000 144749.9n 0.7000 144750.0n 0.7000 144999.9n 0.7000 145000.0n 0.3000 145249.9n 0.3000 145250.0n 0.3000 145499.9n 0.3000 145500.0n 0.7000 145749.9n 0.7000 145750.0n 0.7000 145999.9n 0.7000 146000.0n 0.7000 146249.9n 0.7000 146250.0n 0.7000 146499.9n 0.7000 146500.0n 0.7000 146749.9n 0.7000 146750.0n 0.3000 146999.9n 0.3000 147000.0n 0.3000 147249.9n 0.3000 147250.0n 0.7000 147499.9n 0.7000 147500.0n 0.3000 147749.9n 0.3000 147750.0n 0.7000 147999.9n 0.7000 148000.0n 0.3000 148249.9n 0.3000 148250.0n 0.7000 148499.9n 0.7000 148500.0n 0.7000 148749.9n 0.7000 148750.0n 0.3000 148999.9n 0.3000 149000.0n 0.7000 149249.9n 0.7000 149250.0n 0.3000 149499.9n 0.3000 149500.0n 0.3000 149749.9n 0.3000 149750.0n 0.3000 149999.9n 0.3000 150000.0n 0.7000 150249.9n 0.7000 150250.0n 0.3000 150499.9n 0.3000 150500.0n 0.3000 150749.9n 0.3000 150750.0n 0.3000 150999.9n 0.3000 151000.0n 0.3000 151249.9n 0.3000 151250.0n 0.7000 151499.9n 0.7000 151500.0n 0.3000 151749.9n 0.3000 151750.0n 0.7000 151999.9n 0.7000 152000.0n 0.7000 152249.9n 0.7000 152250.0n 0.7000 152499.9n 0.7000 152500.0n 0.3000 152749.9n 0.3000 152750.0n 0.3000 152999.9n 0.3000 153000.0n 0.7000 153249.9n 0.7000 153250.0n 0.7000 153499.9n 0.7000 153500.0n 0.7000 153749.9n 0.7000 153750.0n 0.7000 153999.9n 0.7000 154000.0n 0.7000 154249.9n 0.7000 154250.0n 0.3000 154499.9n 0.3000 154500.0n 0.3000 154749.9n 0.3000 154750.0n 0.7000 154999.9n 0.7000 155000.0n 0.3000 155249.9n 0.3000 155250.0n 0.7000 155499.9n 0.7000 155500.0n 0.3000 155749.9n 0.3000 155750.0n 0.7000 155999.9n 0.7000 156000.0n 0.7000 156249.9n 0.7000 156250.0n 0.3000 156499.9n 0.3000 156500.0n 0.7000 156749.9n 0.7000 156750.0n 0.3000 156999.9n 0.3000 157000.0n 0.3000 157249.9n 0.3000 157250.0n 0.3000 157499.9n 0.3000 157500.0n 0.7000 157749.9n 0.7000 157750.0n 0.3000 157999.9n 0.3000 158000.0n 0.3000 158249.9n 0.3000 158250.0n 0.3000 158499.9n 0.3000 158500.0n 0.3000 158749.9n 0.3000 158750.0n 0.7000 158999.9n 0.7000 159000.0n 0.3000 159249.9n 0.3000 159250.0n 0.7000 159499.9n 0.7000 159500.0n 0.7000 159749.9n 0.7000 159750.0n 0.7000 159999.9n 0.7000 160000.0n 0.3000 160249.9n 0.3000 160250.0n 0.3000 160499.9n 0.3000 160500.0n 0.7000 160749.9n 0.7000 160750.0n 0.7000 160999.9n 0.7000 161000.0n 0.7000 161249.9n 0.7000 161250.0n 0.7000 161499.9n 0.7000 161500.0n 0.7000 161749.9n 0.7000 161750.0n 0.3000 161999.9n 0.3000 162000.0n 0.3000 162249.9n 0.3000 162250.0n 0.7000 162499.9n 0.7000 162500.0n 0.3000 162749.9n 0.3000 162750.0n 0.7000 162999.9n 0.7000 163000.0n 0.3000 163249.9n 0.3000 163250.0n 0.7000 163499.9n 0.7000 163500.0n 0.7000 163749.9n 0.7000 163750.0n 0.3000 163999.9n 0.3000 164000.0n 0.7000 164249.9n 0.7000 164250.0n 0.3000 164499.9n 0.3000 164500.0n 0.3000 164749.9n 0.3000 164750.0n 0.3000 164999.9n 0.3000 165000.0n 0.7000 165249.9n 0.7000 165250.0n 0.3000 165499.9n 0.3000 165500.0n 0.3000 165749.9n 0.3000 165750.0n 0.3000 165999.9n 0.3000 166000.0n 0.3000 166249.9n 0.3000 166250.0n 0.7000 166499.9n 0.7000 166500.0n 0.3000 166749.9n 0.3000 166750.0n 0.7000 166999.9n 0.7000 167000.0n 0.7000 167249.9n 0.7000 167250.0n 0.7000 167499.9n 0.7000 167500.0n 0.3000 167749.9n 0.3000 167750.0n 0.3000 167999.9n 0.3000 168000.0n 0.7000 168249.9n 0.7000 168250.0n 0.7000 168499.9n 0.7000 168500.0n 0.7000 168749.9n 0.7000 168750.0n 0.7000 168999.9n 0.7000 169000.0n 0.7000 169249.9n 0.7000 169250.0n 0.3000 169499.9n 0.3000 169500.0n 0.3000 169749.9n 0.3000 169750.0n 0.7000 169999.9n 0.7000 170000.0n 0.3000 170249.9n 0.3000 170250.0n 0.7000 170499.9n 0.7000 170500.0n 0.3000 170749.9n 0.3000 170750.0n 0.7000 170999.9n 0.7000 171000.0n 0.7000 171249.9n 0.7000 171250.0n 0.3000 171499.9n 0.3000 171500.0n 0.7000 171749.9n 0.7000 171750.0n 0.3000 171999.9n 0.3000 172000.0n 0.3000 172249.9n 0.3000 172250.0n 0.3000 172499.9n 0.3000 172500.0n 0.7000 172749.9n 0.7000 172750.0n 0.3000 172999.9n 0.3000 173000.0n 0.3000 173249.9n 0.3000 173250.0n 0.3000 173499.9n 0.3000 173500.0n 0.3000 173749.9n 0.3000 173750.0n 0.7000 173999.9n 0.7000 174000.0n 0.3000 174249.9n 0.3000 174250.0n 0.7000 174499.9n 0.7000 174500.0n 0.7000 174749.9n 0.7000 174750.0n 0.7000 174999.9n 0.7000 175000.0n 0.3000 175249.9n 0.3000 175250.0n 0.3000 175499.9n 0.3000 175500.0n 0.7000 175749.9n 0.7000 175750.0n 0.7000 175999.9n 0.7000 176000.0n 0.7000 176249.9n 0.7000 176250.0n 0.7000 176499.9n 0.7000 176500.0n 0.7000 176749.9n 0.7000 176750.0n 0.3000 176999.9n 0.3000 177000.0n 0.3000 177249.9n 0.3000 177250.0n 0.7000 177499.9n 0.7000 177500.0n 0.3000 177749.9n 0.3000 177750.0n 0.7000 177999.9n 0.7000 178000.0n 0.3000 178249.9n 0.3000 178250.0n 0.7000 178499.9n 0.7000 178500.0n 0.7000 178749.9n 0.7000 178750.0n 0.3000 178999.9n 0.3000 179000.0n 0.7000 179249.9n 0.7000 179250.0n 0.3000 179499.9n 0.3000 179500.0n 0.3000 179749.9n 0.3000 179750.0n 0.3000 179999.9n 0.3000 180000.0n 0.7000 180249.9n 0.7000 180250.0n 0.3000 180499.9n 0.3000 180500.0n 0.3000 180749.9n 0.3000 180750.0n 0.3000 180999.9n 0.3000 181000.0n 0.3000 181249.9n 0.3000 181250.0n 0.7000 181499.9n 0.7000 181500.0n 0.3000 181749.9n 0.3000 181750.0n 0.7000 181999.9n 0.7000 182000.0n 0.7000 182249.9n 0.7000 182250.0n 0.7000 182499.9n 0.7000 182500.0n 0.3000 182749.9n 0.3000 182750.0n 0.3000 182999.9n 0.3000 183000.0n 0.7000 183249.9n 0.7000 183250.0n 0.7000 183499.9n 0.7000 183500.0n 0.7000 183749.9n 0.7000 183750.0n 0.7000 183999.9n 0.7000 184000.0n 0.7000 184249.9n 0.7000 184250.0n 0.3000 184499.9n 0.3000 184500.0n 0.3000 184749.9n 0.3000 184750.0n 0.7000 184999.9n 0.7000 185000.0n 0.3000 185249.9n 0.3000 185250.0n 0.7000 185499.9n 0.7000 185500.0n 0.3000 185749.9n 0.3000 185750.0n 0.7000 185999.9n 0.7000 186000.0n 0.7000 186249.9n 0.7000 186250.0n 0.3000 186499.9n 0.3000 186500.0n 0.7000 186749.9n 0.7000 186750.0n 0.3000 186999.9n 0.3000 187000.0n 0.3000 187249.9n 0.3000 187250.0n 0.3000 187499.9n 0.3000 187500.0n 0.7000 187749.9n 0.7000 187750.0n 0.3000 187999.9n 0.3000 188000.0n 0.3000 188249.9n 0.3000 188250.0n 0.3000 188499.9n 0.3000 188500.0n 0.3000 188749.9n 0.3000 188750.0n 0.7000 188999.9n 0.7000 189000.0n 0.3000 189249.9n 0.3000 189250.0n 0.7000 189499.9n 0.7000 189500.0n 0.7000 189749.9n 0.7000 189750.0n 0.7000 189999.9n 0.7000 190000.0n 0.3000 190249.9n 0.3000 190250.0n 0.3000 190499.9n 0.3000 190500.0n 0.7000 190749.9n 0.7000 190750.0n 0.7000 190999.9n 0.7000 191000.0n 0.7000 191249.9n 0.7000 191250.0n 0.7000 191499.9n 0.7000 191500.0n 0.7000 191749.9n 0.7000 191750.0n 0.3000 191999.9n 0.3000 192000.0n 0.3000 192249.9n 0.3000 192250.0n 0.7000 192499.9n 0.7000 192500.0n 0.3000 192749.9n 0.3000 192750.0n 0.7000 192999.9n 0.7000 193000.0n 0.3000 193249.9n 0.3000 193250.0n 0.7000 193499.9n 0.7000 193500.0n 0.7000 193749.9n 0.7000 193750.0n 0.3000 193999.9n 0.3000 194000.0n 0.7000 194249.9n 0.7000 194250.0n 0.3000 194499.9n 0.3000 194500.0n 0.3000 194749.9n 0.3000 194750.0n 0.3000 194999.9n 0.3000 195000.0n 0.7000 195249.9n 0.7000 195250.0n 0.3000 195499.9n 0.3000 195500.0n 0.3000 195749.9n 0.3000 195750.0n 0.3000 195999.9n 0.3000 196000.0n 0.3000 196249.9n 0.3000 196250.0n 0.7000 196499.9n 0.7000 196500.0n 0.3000 196749.9n 0.3000 196750.0n 0.7000 196999.9n 0.7000 197000.0n 0.7000 197249.9n 0.7000 197250.0n 0.7000 197499.9n 0.7000 197500.0n 0.3000 197749.9n 0.3000 197750.0n 0.3000 197999.9n 0.3000 198000.0n 0.7000 198249.9n 0.7000 198250.0n 0.7000 198499.9n 0.7000 198500.0n 0.7000 198749.9n 0.7000 198750.0n 0.7000 198999.9n 0.7000 199000.0n 0.7000 199249.9n 0.7000 199250.0n 0.3000 199499.9n 0.3000 199500.0n 0.3000 199749.9n 0.3000 199750.0n 0.7000 199999.9n 0.7000 200000.0n 0.3000 200249.9n 0.3000 200250.0n 0.7000 200499.9n 0.7000 200500.0n 0.3000 200749.9n 0.3000 200750.0n 0.7000 200999.9n 0.7000 201000.0n 0.7000 201249.9n 0.7000 201250.0n 0.3000 201499.9n 0.3000 201500.0n 0.7000 201749.9n 0.7000 201750.0n 0.3000 201999.9n 0.3000 202000.0n 0.3000 202249.9n 0.3000 202250.0n 0.3000 202499.9n 0.3000 202500.0n 0.7000 202749.9n 0.7000 202750.0n 0.3000 202999.9n 0.3000 203000.0n 0.3000 203249.9n 0.3000 203250.0n 0.3000 203499.9n 0.3000 203500.0n 0.3000 203749.9n 0.3000 203750.0n 0.7000 203999.9n 0.7000 204000.0n 0.3000 204249.9n 0.3000 204250.0n 0.7000 204499.9n 0.7000 204500.0n 0.7000 204749.9n 0.7000 204750.0n 0.7000 204999.9n 0.7000 205000.0n 0.3000 205249.9n 0.3000 205250.0n 0.3000 205499.9n 0.3000 205500.0n 0.7000 205749.9n 0.7000 205750.0n 0.7000 205999.9n 0.7000 206000.0n 0.7000 206249.9n 0.7000 206250.0n 0.7000 206499.9n 0.7000 206500.0n 0.7000 206749.9n 0.7000 206750.0n 0.3000 206999.9n 0.3000 207000.0n 0.3000 207249.9n 0.3000 207250.0n 0.7000 207499.9n 0.7000 207500.0n 0.3000 207749.9n 0.3000 207750.0n 0.7000 207999.9n 0.7000 208000.0n 0.3000 208249.9n 0.3000 208250.0n 0.7000 208499.9n 0.7000 208500.0n 0.7000 208749.9n 0.7000 208750.0n 0.3000 208999.9n 0.3000 209000.0n 0.7000 209249.9n 0.7000 209250.0n 0.3000 209499.9n 0.3000 209500.0n 0.3000 209749.9n 0.3000 209750.0n 0.3000 209999.9n 0.3000 210000.0n 0.7000 210249.9n 0.7000 210250.0n 0.3000 210499.9n 0.3000 210500.0n 0.3000 210749.9n 0.3000 210750.0n 0.3000 210999.9n 0.3000 211000.0n 0.3000 211249.9n 0.3000 211250.0n 0.7000 211499.9n 0.7000 211500.0n 0.3000 211749.9n 0.3000 211750.0n 0.7000 211999.9n 0.7000 212000.0n 0.7000 212249.9n 0.7000 212250.0n 0.7000 212499.9n 0.7000 212500.0n 0.3000 212749.9n 0.3000 212750.0n 0.3000 212999.9n 0.3000 213000.0n 0.7000 213249.9n 0.7000 213250.0n 0.7000 213499.9n 0.7000 213500.0n 0.7000 213749.9n 0.7000 213750.0n 0.7000 213999.9n 0.7000 214000.0n 0.7000 214249.9n 0.7000 214250.0n 0.3000 214499.9n 0.3000 214500.0n 0.3000 214749.9n 0.3000 214750.0n 0.7000 214999.9n 0.7000 215000.0n 0.3000 215249.9n 0.3000 215250.0n 0.7000 215499.9n 0.7000 215500.0n 0.3000 215749.9n 0.3000 215750.0n 0.7000 215999.9n 0.7000 216000.0n 0.7000 216249.9n 0.7000 216250.0n 0.3000 216499.9n 0.3000 216500.0n 0.7000 216749.9n 0.7000 216750.0n 0.3000 216999.9n 0.3000 217000.0n 0.3000 217249.9n 0.3000 217250.0n 0.3000 217499.9n 0.3000 217500.0n 0.7000 217749.9n 0.7000 217750.0n 0.3000 217999.9n 0.3000 218000.0n 0.3000 218249.9n 0.3000 218250.0n 0.3000 218499.9n 0.3000 218500.0n 0.3000 218749.9n 0.3000 218750.0n 0.7000 218999.9n 0.7000 219000.0n 0.3000 219249.9n 0.3000 219250.0n 0.7000 219499.9n 0.7000 219500.0n 0.7000 219749.9n 0.7000 219750.0n 0.7000 219999.9n 0.7000 220000.0n 0.3000 220249.9n 0.3000 220250.0n 0.3000 220499.9n 0.3000 220500.0n 0.7000 220749.9n 0.7000 220750.0n 0.7000 220999.9n 0.7000 221000.0n 0.7000 221249.9n 0.7000 221250.0n 0.7000 221499.9n 0.7000 221500.0n 0.7000 221749.9n 0.7000 221750.0n 0.3000 221999.9n 0.3000 222000.0n 0.3000 222249.9n 0.3000 222250.0n 0.7000 222499.9n 0.7000 222500.0n 0.3000 222749.9n 0.3000 222750.0n 0.7000 222999.9n 0.7000 223000.0n 0.3000 223249.9n 0.3000 223250.0n 0.7000 223499.9n 0.7000 223500.0n 0.7000 223749.9n 0.7000 223750.0n 0.3000 223999.9n 0.3000 224000.0n 0.7000 224249.9n 0.7000 224250.0n 0.3000 224499.9n 0.3000 224500.0n 0.3000 224749.9n 0.3000 224750.0n 0.3000 224999.9n 0.3000 225000.0n 0.7000 225249.9n 0.7000 225250.0n 0.3000 225499.9n 0.3000 225500.0n 0.3000 225749.9n 0.3000 225750.0n 0.3000 225999.9n 0.3000 226000.0n 0.3000 226249.9n 0.3000 226250.0n 0.7000 226499.9n 0.7000 226500.0n 0.3000 226749.9n 0.3000 226750.0n 0.7000 226999.9n 0.7000 227000.0n 0.7000 227249.9n 0.7000 227250.0n 0.7000 227499.9n 0.7000 227500.0n 0.3000 227749.9n 0.3000 227750.0n 0.3000 227999.9n 0.3000 228000.0n 0.7000 228249.9n 0.7000 228250.0n 0.7000 228499.9n 0.7000 228500.0n 0.7000 228749.9n 0.7000 228750.0n 0.7000 228999.9n 0.7000 229000.0n 0.7000 229249.9n 0.7000 229250.0n 0.3000 229499.9n 0.3000 229500.0n 0.3000 229749.9n 0.3000 229750.0n 0.7000 229999.9n 0.7000 230000.0n 0.3000 230249.9n 0.3000 230250.0n 0.7000 230499.9n 0.7000 230500.0n 0.3000 230749.9n 0.3000 230750.0n 0.7000 230999.9n 0.7000 231000.0n 0.7000 231249.9n 0.7000 231250.0n 0.3000 231499.9n 0.3000 231500.0n 0.7000 231749.9n 0.7000 231750.0n 0.3000 231999.9n 0.3000 232000.0n 0.3000 232249.9n 0.3000 232250.0n 0.3000 232499.9n 0.3000 232500.0n 0.7000 232749.9n 0.7000 232750.0n 0.3000 232999.9n 0.3000 233000.0n 0.3000 233249.9n 0.3000 233250.0n 0.3000 233499.9n 0.3000 233500.0n 0.3000 233749.9n 0.3000 233750.0n 0.7000 233999.9n 0.7000 234000.0n 0.3000 234249.9n 0.3000 234250.0n 0.7000 234499.9n 0.7000 234500.0n 0.7000 234749.9n 0.7000 234750.0n 0.7000 234999.9n 0.7000 235000.0n 0.3000 235249.9n 0.3000 235250.0n 0.3000 235499.9n 0.3000 235500.0n 0.7000 235749.9n 0.7000 235750.0n 0.7000 235999.9n 0.7000 236000.0n 0.7000 236249.9n 0.7000 236250.0n 0.7000 236499.9n 0.7000 236500.0n 0.7000 236749.9n 0.7000 236750.0n 0.3000 236999.9n 0.3000 237000.0n 0.3000 237249.9n 0.3000 237250.0n 0.7000 237499.9n 0.7000 237500.0n 0.3000 237749.9n 0.3000 237750.0n 0.7000 237999.9n 0.7000 238000.0n 0.3000 238249.9n 0.3000 238250.0n 0.7000 238499.9n 0.7000 238500.0n 0.7000 238749.9n 0.7000 238750.0n 0.3000 238999.9n 0.3000 239000.0n 0.7000 239249.9n 0.7000 239250.0n 0.3000 239499.9n 0.3000 239500.0n 0.3000 239749.9n 0.3000 239750.0n 0.3000 239999.9n 0.3000 240000.0n 0.7000 240249.9n 0.7000 240250.0n 0.3000 240499.9n 0.3000 240500.0n 0.3000 240749.9n 0.3000 240750.0n 0.3000 240999.9n 0.3000 241000.0n 0.3000 241249.9n 0.3000 241250.0n 0.7000 241499.9n 0.7000 241500.0n 0.3000 241749.9n 0.3000 241750.0n 0.7000 241999.9n 0.7000 242000.0n 0.7000 242249.9n 0.7000 242250.0n 0.7000 242499.9n 0.7000 242500.0n 0.3000 242749.9n 0.3000 242750.0n 0.3000 242999.9n 0.3000 243000.0n 0.7000 243249.9n 0.7000 243250.0n 0.7000 243499.9n 0.7000 243500.0n 0.7000 243749.9n 0.7000 243750.0n 0.7000 243999.9n 0.7000 244000.0n 0.7000 244249.9n 0.7000 244250.0n 0.3000 244499.9n 0.3000 244500.0n 0.3000 244749.9n 0.3000 244750.0n 0.7000 244999.9n 0.7000 245000.0n 0.3000 245249.9n 0.3000 245250.0n 0.7000 245499.9n 0.7000 245500.0n 0.3000 245749.9n 0.3000 245750.0n 0.7000 245999.9n 0.7000 246000.0n 0.7000 246249.9n 0.7000 246250.0n 0.3000 246499.9n 0.3000 246500.0n 0.7000 246749.9n 0.7000 246750.0n 0.3000 246999.9n 0.3000 247000.0n 0.3000 247249.9n 0.3000 247250.0n 0.3000 247499.9n 0.3000 247500.0n 0.7000 247749.9n 0.7000 247750.0n 0.3000 247999.9n 0.3000 248000.0n 0.3000 248249.9n 0.3000 248250.0n 0.3000 248499.9n 0.3000 248500.0n 0.3000 248749.9n 0.3000 248750.0n 0.7000 248999.9n 0.7000 249000.0n 0.3000 249249.9n 0.3000 249250.0n 0.7000 249499.9n 0.7000 249500.0n 0.7000 249749.9n 0.7000 249750.0n 0.7000 249999.9n 0.7000 250000.0n 0.3000 250249.9n 0.3000 250250.0n 0.3000 250499.9n 0.3000 250500.0n 0.7000 250749.9n 0.7000 250750.0n 0.7000 250999.9n 0.7000 251000.0n 0.7000 251249.9n 0.7000 251250.0n 0.7000 251499.9n 0.7000 251500.0n 0.7000 251749.9n 0.7000 251750.0n 0.3000 251999.9n 0.3000 252000.0n 0.3000 252249.9n 0.3000 252250.0n 0.7000 252499.9n 0.7000 252500.0n 0.3000 252749.9n 0.3000 252750.0n 0.7000 252999.9n 0.7000 253000.0n 0.3000 253249.9n 0.3000 253250.0n 0.7000 253499.9n 0.7000 253500.0n 0.7000 253749.9n 0.7000 253750.0n 0.3000 253999.9n 0.3000 254000.0n 0.7000 254249.9n 0.7000 254250.0n 0.3000 254499.9n 0.3000 254500.0n 0.3000 254749.9n 0.3000 254750.0n 0.3000 254999.9n 0.3000 255000.0n 0.7000 255249.9n 0.7000 255250.0n 0.3000 255499.9n 0.3000 255500.0n 0.3000 255749.9n 0.3000 255750.0n 0.3000 255999.9n 0.3000 256000.0n 0.3000 256249.9n 0.3000 256250.0n 0.7000 256499.9n 0.7000 256500.0n 0.3000 256749.9n 0.3000 256750.0n 0.7000 256999.9n 0.7000 257000.0n 0.7000 257249.9n 0.7000 257250.0n 0.7000 257499.9n 0.7000 257500.0n 0.3000 257749.9n 0.3000 257750.0n 0.3000 257999.9n 0.3000 258000.0n 0.7000 258249.9n 0.7000 258250.0n 0.7000 258499.9n 0.7000 258500.0n 0.7000 258749.9n 0.7000 258750.0n 0.7000 258999.9n 0.7000 259000.0n 0.7000 259249.9n 0.7000 259250.0n 0.3000 259499.9n 0.3000 259500.0n 0.3000 259749.9n 0.3000 259750.0n 0.7000 259999.9n 0.7000 260000.0n 0.3000 260249.9n 0.3000 260250.0n 0.7000 260499.9n 0.7000 260500.0n 0.3000 260749.9n 0.3000 260750.0n 0.7000 260999.9n 0.7000 261000.0n 0.7000 261249.9n 0.7000 261250.0n 0.3000 261499.9n 0.3000 261500.0n 0.7000 261749.9n 0.7000 261750.0n 0.3000 261999.9n 0.3000 262000.0n 0.3000 262249.9n 0.3000 262250.0n 0.3000 262499.9n 0.3000 262500.0n 0.7000 262749.9n 0.7000 262750.0n 0.3000 262999.9n 0.3000 263000.0n 0.3000 263249.9n 0.3000 263250.0n 0.3000 263499.9n 0.3000 263500.0n 0.3000 263749.9n 0.3000 263750.0n 0.7000 263999.9n 0.7000 264000.0n 0.3000 264249.9n 0.3000 264250.0n 0.7000 264499.9n 0.7000 264500.0n 0.7000 264749.9n 0.7000 264750.0n 0.7000 264999.9n 0.7000 265000.0n 0.3000 265249.9n 0.3000 265250.0n 0.3000 265499.9n 0.3000 265500.0n 0.7000 265749.9n 0.7000 265750.0n 0.7000 265999.9n 0.7000 266000.0n 0.7000 266249.9n 0.7000 266250.0n 0.7000 266499.9n 0.7000 266500.0n 0.7000 266749.9n 0.7000 266750.0n 0.3000 266999.9n 0.3000 267000.0n 0.3000 267249.9n 0.3000 267250.0n 0.7000 267499.9n 0.7000 267500.0n 0.3000 267749.9n 0.3000 267750.0n 0.7000 267999.9n 0.7000 268000.0n 0.3000 268249.9n 0.3000 268250.0n 0.7000 268499.9n 0.7000 268500.0n 0.7000 268749.9n 0.7000 268750.0n 0.3000 268999.9n 0.3000 269000.0n 0.7000 269249.9n 0.7000 269250.0n 0.3000 269499.9n 0.3000 269500.0n 0.3000 269749.9n 0.3000 269750.0n 0.3000 269999.9n 0.3000 270000.0n 0.7000 270249.9n 0.7000 270250.0n 0.3000 270499.9n 0.3000 270500.0n 0.3000 270749.9n 0.3000 270750.0n 0.3000 270999.9n 0.3000 271000.0n 0.3000 271249.9n 0.3000 271250.0n 0.7000 271499.9n 0.7000 271500.0n 0.3000 271749.9n 0.3000 271750.0n 0.7000 271999.9n 0.7000 272000.0n 0.7000 272249.9n 0.7000 272250.0n 0.7000 272499.9n 0.7000 272500.0n 0.3000 272749.9n 0.3000 272750.0n 0.3000 272999.9n 0.3000 273000.0n 0.7000 273249.9n 0.7000 273250.0n 0.7000 273499.9n 0.7000 273500.0n 0.7000 273749.9n 0.7000 273750.0n 0.7000 273999.9n 0.7000 274000.0n 0.7000 274249.9n 0.7000 274250.0n 0.3000 274499.9n 0.3000 274500.0n 0.3000 274749.9n 0.3000 274750.0n 0.7000 274999.9n 0.7000 275000.0n 0.3000 275249.9n 0.3000 275250.0n 0.7000 275499.9n 0.7000 275500.0n 0.3000 275749.9n 0.3000 275750.0n 0.7000 275999.9n 0.7000 276000.0n 0.7000 276249.9n 0.7000 276250.0n 0.3000 276499.9n 0.3000 276500.0n 0.7000 276749.9n 0.7000 276750.0n 0.3000 276999.9n 0.3000 277000.0n 0.3000 277249.9n 0.3000 277250.0n 0.3000 277499.9n 0.3000 277500.0n 0.7000 277749.9n 0.7000 277750.0n 0.3000 277999.9n 0.3000 278000.0n 0.3000 278249.9n 0.3000 278250.0n 0.3000 278499.9n 0.3000 278500.0n 0.3000 278749.9n 0.3000 278750.0n 0.7000 278999.9n 0.7000 279000.0n 0.3000 279249.9n 0.3000 279250.0n 0.7000 279499.9n 0.7000 279500.0n 0.7000 279749.9n 0.7000 279750.0n 0.7000 279999.9n 0.7000 280000.0n 0.3000 280249.9n 0.3000 280250.0n 0.3000 280499.9n 0.3000 280500.0n 0.7000 280749.9n 0.7000 280750.0n 0.7000 280999.9n 0.7000 281000.0n 0.7000 281249.9n 0.7000 281250.0n 0.7000 281499.9n 0.7000 281500.0n 0.7000 281749.9n 0.7000 281750.0n 0.3000 281999.9n 0.3000 282000.0n 0.3000 282249.9n 0.3000 282250.0n 0.7000 282499.9n 0.7000 282500.0n 0.3000 282749.9n 0.3000 282750.0n 0.7000 282999.9n 0.7000 283000.0n 0.3000 283249.9n 0.3000 283250.0n 0.7000 283499.9n 0.7000 283500.0n 0.7000 283749.9n 0.7000 283750.0n 0.3000 283999.9n 0.3000 284000.0n 0.7000 284249.9n 0.7000 284250.0n 0.3000 284499.9n 0.3000 284500.0n 0.3000 284749.9n 0.3000 284750.0n 0.3000 284999.9n 0.3000 285000.0n 0.7000 285249.9n 0.7000 285250.0n 0.3000 285499.9n 0.3000 285500.0n 0.3000 285749.9n 0.3000 285750.0n 0.3000 285999.9n 0.3000 286000.0n 0.3000 286249.9n 0.3000 286250.0n 0.7000 286499.9n 0.7000 286500.0n 0.3000 286749.9n 0.3000 286750.0n 0.7000 286999.9n 0.7000 287000.0n 0.7000 287249.9n 0.7000 287250.0n 0.7000 287499.9n 0.7000 287500.0n 0.3000 287749.9n 0.3000 287750.0n 0.3000 287999.9n 0.3000 288000.0n 0.7000 288249.9n 0.7000 288250.0n 0.7000 288499.9n 0.7000 288500.0n 0.7000 288749.9n 0.7000 288750.0n 0.7000 288999.9n 0.7000 289000.0n 0.7000 289249.9n 0.7000 289250.0n 0.3000 289499.9n 0.3000 289500.0n 0.3000 289749.9n 0.3000 289750.0n 0.7000 289999.9n 0.7000 290000.0n 0.3000 290249.9n 0.3000 290250.0n 0.7000 290499.9n 0.7000 290500.0n 0.3000 290749.9n 0.3000 290750.0n 0.7000 290999.9n 0.7000 291000.0n 0.7000 291249.9n 0.7000 291250.0n 0.3000 291499.9n 0.3000 291500.0n 0.7000 291749.9n 0.7000 291750.0n 0.3000 291999.9n 0.3000 292000.0n 0.3000 292249.9n 0.3000 292250.0n 0.3000 292499.9n 0.3000 292500.0n 0.7000 292749.9n 0.7000 292750.0n 0.3000 292999.9n 0.3000 293000.0n 0.3000 293249.9n 0.3000 293250.0n 0.3000 293499.9n 0.3000 293500.0n 0.3000 293749.9n 0.3000 293750.0n 0.7000 293999.9n 0.7000 294000.0n 0.3000 294249.9n 0.3000 294250.0n 0.7000 294499.9n 0.7000 294500.0n 0.7000 294749.9n 0.7000 294750.0n 0.7000 294999.9n 0.7000 295000.0n 0.3000 295249.9n 0.3000 295250.0n 0.3000 295499.9n 0.3000 295500.0n 0.7000 295749.9n 0.7000 295750.0n 0.7000 295999.9n 0.7000 296000.0n 0.7000 296249.9n 0.7000 296250.0n 0.7000 296499.9n 0.7000 296500.0n 0.7000 296749.9n 0.7000 296750.0n 0.3000 296999.9n 0.3000 297000.0n 0.3000 297249.9n 0.3000 297250.0n 0.7000 297499.9n 0.7000 297500.0n 0.3000 297749.9n 0.3000 297750.0n 0.7000 297999.9n 0.7000 298000.0n 0.3000 298249.9n 0.3000 298250.0n 0.7000 298499.9n 0.7000 298500.0n 0.7000 298749.9n 0.7000 298750.0n 0.3000 298999.9n 0.3000 299000.0n 0.7000 299249.9n 0.7000 299250.0n 0.3000 299499.9n 0.3000 299500.0n 0.3000 299749.9n 0.3000 299750.0n 0.3000)
Vtp1 xop1 0 PWL(0.0n 0.7000 249.9n 0.7000 250.0n 0.3000 499.9n 0.3000 500.0n 0.3000 749.9n 0.3000 750.0n 0.3000 999.9n 0.3000 1000.0n 0.3000 1249.9n 0.3000 1250.0n 0.7000 1499.9n 0.7000 1500.0n 0.3000 1749.9n 0.3000 1750.0n 0.7000 1999.9n 0.7000 2000.0n 0.7000 2249.9n 0.7000 2250.0n 0.7000 2499.9n 0.7000 2500.0n 0.3000 2749.9n 0.3000 2750.0n 0.3000 2999.9n 0.3000 3000.0n 0.7000 3249.9n 0.7000 3250.0n 0.7000 3499.9n 0.7000 3500.0n 0.7000 3749.9n 0.7000 3750.0n 0.7000 3999.9n 0.7000 4000.0n 0.7000 4249.9n 0.7000 4250.0n 0.3000 4499.9n 0.3000 4500.0n 0.3000 4749.9n 0.3000 4750.0n 0.7000 4999.9n 0.7000 5000.0n 0.3000 5249.9n 0.3000 5250.0n 0.7000 5499.9n 0.7000 5500.0n 0.3000 5749.9n 0.3000 5750.0n 0.7000 5999.9n 0.7000 6000.0n 0.7000 6249.9n 0.7000 6250.0n 0.3000 6499.9n 0.3000 6500.0n 0.7000 6749.9n 0.7000 6750.0n 0.3000 6999.9n 0.3000 7000.0n 0.3000 7249.9n 0.3000 7250.0n 0.3000 7499.9n 0.3000 7500.0n 0.7000 7749.9n 0.7000 7750.0n 0.3000 7999.9n 0.3000 8000.0n 0.3000 8249.9n 0.3000 8250.0n 0.3000 8499.9n 0.3000 8500.0n 0.3000 8749.9n 0.3000 8750.0n 0.7000 8999.9n 0.7000 9000.0n 0.3000 9249.9n 0.3000 9250.0n 0.7000 9499.9n 0.7000 9500.0n 0.7000 9749.9n 0.7000 9750.0n 0.7000 9999.9n 0.7000 10000.0n 0.3000 10249.9n 0.3000 10250.0n 0.3000 10499.9n 0.3000 10500.0n 0.7000 10749.9n 0.7000 10750.0n 0.7000 10999.9n 0.7000 11000.0n 0.7000 11249.9n 0.7000 11250.0n 0.7000 11499.9n 0.7000 11500.0n 0.7000 11749.9n 0.7000 11750.0n 0.3000 11999.9n 0.3000 12000.0n 0.3000 12249.9n 0.3000 12250.0n 0.7000 12499.9n 0.7000 12500.0n 0.3000 12749.9n 0.3000 12750.0n 0.7000 12999.9n 0.7000 13000.0n 0.3000 13249.9n 0.3000 13250.0n 0.7000 13499.9n 0.7000 13500.0n 0.7000 13749.9n 0.7000 13750.0n 0.3000 13999.9n 0.3000 14000.0n 0.7000 14249.9n 0.7000 14250.0n 0.3000 14499.9n 0.3000 14500.0n 0.3000 14749.9n 0.3000 14750.0n 0.3000 14999.9n 0.3000 15000.0n 0.7000 15249.9n 0.7000 15250.0n 0.3000 15499.9n 0.3000 15500.0n 0.3000 15749.9n 0.3000 15750.0n 0.3000 15999.9n 0.3000 16000.0n 0.3000 16249.9n 0.3000 16250.0n 0.7000 16499.9n 0.7000 16500.0n 0.3000 16749.9n 0.3000 16750.0n 0.7000 16999.9n 0.7000 17000.0n 0.7000 17249.9n 0.7000 17250.0n 0.7000 17499.9n 0.7000 17500.0n 0.3000 17749.9n 0.3000 17750.0n 0.3000 17999.9n 0.3000 18000.0n 0.7000 18249.9n 0.7000 18250.0n 0.7000 18499.9n 0.7000 18500.0n 0.7000 18749.9n 0.7000 18750.0n 0.7000 18999.9n 0.7000 19000.0n 0.7000 19249.9n 0.7000 19250.0n 0.3000 19499.9n 0.3000 19500.0n 0.3000 19749.9n 0.3000 19750.0n 0.7000 19999.9n 0.7000 20000.0n 0.3000 20249.9n 0.3000 20250.0n 0.7000 20499.9n 0.7000 20500.0n 0.3000 20749.9n 0.3000 20750.0n 0.7000 20999.9n 0.7000 21000.0n 0.7000 21249.9n 0.7000 21250.0n 0.3000 21499.9n 0.3000 21500.0n 0.7000 21749.9n 0.7000 21750.0n 0.3000 21999.9n 0.3000 22000.0n 0.3000 22249.9n 0.3000 22250.0n 0.3000 22499.9n 0.3000 22500.0n 0.7000 22749.9n 0.7000 22750.0n 0.3000 22999.9n 0.3000 23000.0n 0.3000 23249.9n 0.3000 23250.0n 0.3000 23499.9n 0.3000 23500.0n 0.3000 23749.9n 0.3000 23750.0n 0.7000 23999.9n 0.7000 24000.0n 0.3000 24249.9n 0.3000 24250.0n 0.7000 24499.9n 0.7000 24500.0n 0.7000 24749.9n 0.7000 24750.0n 0.7000 24999.9n 0.7000 25000.0n 0.3000 25249.9n 0.3000 25250.0n 0.3000 25499.9n 0.3000 25500.0n 0.7000 25749.9n 0.7000 25750.0n 0.7000 25999.9n 0.7000 26000.0n 0.7000 26249.9n 0.7000 26250.0n 0.7000 26499.9n 0.7000 26500.0n 0.7000 26749.9n 0.7000 26750.0n 0.3000 26999.9n 0.3000 27000.0n 0.3000 27249.9n 0.3000 27250.0n 0.7000 27499.9n 0.7000 27500.0n 0.3000 27749.9n 0.3000 27750.0n 0.7000 27999.9n 0.7000 28000.0n 0.3000 28249.9n 0.3000 28250.0n 0.7000 28499.9n 0.7000 28500.0n 0.7000 28749.9n 0.7000 28750.0n 0.3000 28999.9n 0.3000 29000.0n 0.7000 29249.9n 0.7000 29250.0n 0.3000 29499.9n 0.3000 29500.0n 0.3000 29749.9n 0.3000 29750.0n 0.3000 29999.9n 0.3000 30000.0n 0.7000 30249.9n 0.7000 30250.0n 0.3000 30499.9n 0.3000 30500.0n 0.3000 30749.9n 0.3000 30750.0n 0.3000 30999.9n 0.3000 31000.0n 0.3000 31249.9n 0.3000 31250.0n 0.7000 31499.9n 0.7000 31500.0n 0.3000 31749.9n 0.3000 31750.0n 0.7000 31999.9n 0.7000 32000.0n 0.7000 32249.9n 0.7000 32250.0n 0.7000 32499.9n 0.7000 32500.0n 0.3000 32749.9n 0.3000 32750.0n 0.3000 32999.9n 0.3000 33000.0n 0.7000 33249.9n 0.7000 33250.0n 0.7000 33499.9n 0.7000 33500.0n 0.7000 33749.9n 0.7000 33750.0n 0.7000 33999.9n 0.7000 34000.0n 0.7000 34249.9n 0.7000 34250.0n 0.3000 34499.9n 0.3000 34500.0n 0.3000 34749.9n 0.3000 34750.0n 0.7000 34999.9n 0.7000 35000.0n 0.3000 35249.9n 0.3000 35250.0n 0.7000 35499.9n 0.7000 35500.0n 0.3000 35749.9n 0.3000 35750.0n 0.7000 35999.9n 0.7000 36000.0n 0.7000 36249.9n 0.7000 36250.0n 0.3000 36499.9n 0.3000 36500.0n 0.7000 36749.9n 0.7000 36750.0n 0.3000 36999.9n 0.3000 37000.0n 0.3000 37249.9n 0.3000 37250.0n 0.3000 37499.9n 0.3000 37500.0n 0.7000 37749.9n 0.7000 37750.0n 0.3000 37999.9n 0.3000 38000.0n 0.3000 38249.9n 0.3000 38250.0n 0.3000 38499.9n 0.3000 38500.0n 0.3000 38749.9n 0.3000 38750.0n 0.7000 38999.9n 0.7000 39000.0n 0.3000 39249.9n 0.3000 39250.0n 0.7000 39499.9n 0.7000 39500.0n 0.7000 39749.9n 0.7000 39750.0n 0.7000 39999.9n 0.7000 40000.0n 0.3000 40249.9n 0.3000 40250.0n 0.3000 40499.9n 0.3000 40500.0n 0.7000 40749.9n 0.7000 40750.0n 0.7000 40999.9n 0.7000 41000.0n 0.7000 41249.9n 0.7000 41250.0n 0.7000 41499.9n 0.7000 41500.0n 0.7000 41749.9n 0.7000 41750.0n 0.3000 41999.9n 0.3000 42000.0n 0.3000 42249.9n 0.3000 42250.0n 0.7000 42499.9n 0.7000 42500.0n 0.3000 42749.9n 0.3000 42750.0n 0.7000 42999.9n 0.7000 43000.0n 0.3000 43249.9n 0.3000 43250.0n 0.7000 43499.9n 0.7000 43500.0n 0.7000 43749.9n 0.7000 43750.0n 0.3000 43999.9n 0.3000 44000.0n 0.7000 44249.9n 0.7000 44250.0n 0.3000 44499.9n 0.3000 44500.0n 0.3000 44749.9n 0.3000 44750.0n 0.3000 44999.9n 0.3000 45000.0n 0.7000 45249.9n 0.7000 45250.0n 0.3000 45499.9n 0.3000 45500.0n 0.3000 45749.9n 0.3000 45750.0n 0.3000 45999.9n 0.3000 46000.0n 0.3000 46249.9n 0.3000 46250.0n 0.7000 46499.9n 0.7000 46500.0n 0.3000 46749.9n 0.3000 46750.0n 0.7000 46999.9n 0.7000 47000.0n 0.7000 47249.9n 0.7000 47250.0n 0.7000 47499.9n 0.7000 47500.0n 0.3000 47749.9n 0.3000 47750.0n 0.3000 47999.9n 0.3000 48000.0n 0.7000 48249.9n 0.7000 48250.0n 0.7000 48499.9n 0.7000 48500.0n 0.7000 48749.9n 0.7000 48750.0n 0.7000 48999.9n 0.7000 49000.0n 0.7000 49249.9n 0.7000 49250.0n 0.3000 49499.9n 0.3000 49500.0n 0.3000 49749.9n 0.3000 49750.0n 0.7000 49999.9n 0.7000 50000.0n 0.3000 50249.9n 0.3000 50250.0n 0.7000 50499.9n 0.7000 50500.0n 0.3000 50749.9n 0.3000 50750.0n 0.7000 50999.9n 0.7000 51000.0n 0.7000 51249.9n 0.7000 51250.0n 0.3000 51499.9n 0.3000 51500.0n 0.7000 51749.9n 0.7000 51750.0n 0.3000 51999.9n 0.3000 52000.0n 0.3000 52249.9n 0.3000 52250.0n 0.3000 52499.9n 0.3000 52500.0n 0.7000 52749.9n 0.7000 52750.0n 0.3000 52999.9n 0.3000 53000.0n 0.3000 53249.9n 0.3000 53250.0n 0.3000 53499.9n 0.3000 53500.0n 0.3000 53749.9n 0.3000 53750.0n 0.7000 53999.9n 0.7000 54000.0n 0.3000 54249.9n 0.3000 54250.0n 0.7000 54499.9n 0.7000 54500.0n 0.7000 54749.9n 0.7000 54750.0n 0.7000 54999.9n 0.7000 55000.0n 0.3000 55249.9n 0.3000 55250.0n 0.3000 55499.9n 0.3000 55500.0n 0.7000 55749.9n 0.7000 55750.0n 0.7000 55999.9n 0.7000 56000.0n 0.7000 56249.9n 0.7000 56250.0n 0.7000 56499.9n 0.7000 56500.0n 0.7000 56749.9n 0.7000 56750.0n 0.3000 56999.9n 0.3000 57000.0n 0.3000 57249.9n 0.3000 57250.0n 0.7000 57499.9n 0.7000 57500.0n 0.3000 57749.9n 0.3000 57750.0n 0.7000 57999.9n 0.7000 58000.0n 0.3000 58249.9n 0.3000 58250.0n 0.7000 58499.9n 0.7000 58500.0n 0.7000 58749.9n 0.7000 58750.0n 0.3000 58999.9n 0.3000 59000.0n 0.7000 59249.9n 0.7000 59250.0n 0.3000 59499.9n 0.3000 59500.0n 0.3000 59749.9n 0.3000 59750.0n 0.3000 59999.9n 0.3000 60000.0n 0.7000 60249.9n 0.7000 60250.0n 0.3000 60499.9n 0.3000 60500.0n 0.3000 60749.9n 0.3000 60750.0n 0.3000 60999.9n 0.3000 61000.0n 0.3000 61249.9n 0.3000 61250.0n 0.7000 61499.9n 0.7000 61500.0n 0.3000 61749.9n 0.3000 61750.0n 0.7000 61999.9n 0.7000 62000.0n 0.7000 62249.9n 0.7000 62250.0n 0.7000 62499.9n 0.7000 62500.0n 0.3000 62749.9n 0.3000 62750.0n 0.3000 62999.9n 0.3000 63000.0n 0.7000 63249.9n 0.7000 63250.0n 0.7000 63499.9n 0.7000 63500.0n 0.7000 63749.9n 0.7000 63750.0n 0.7000 63999.9n 0.7000 64000.0n 0.7000 64249.9n 0.7000 64250.0n 0.3000 64499.9n 0.3000 64500.0n 0.3000 64749.9n 0.3000 64750.0n 0.7000 64999.9n 0.7000 65000.0n 0.3000 65249.9n 0.3000 65250.0n 0.7000 65499.9n 0.7000 65500.0n 0.3000 65749.9n 0.3000 65750.0n 0.7000 65999.9n 0.7000 66000.0n 0.7000 66249.9n 0.7000 66250.0n 0.3000 66499.9n 0.3000 66500.0n 0.7000 66749.9n 0.7000 66750.0n 0.3000 66999.9n 0.3000 67000.0n 0.3000 67249.9n 0.3000 67250.0n 0.3000 67499.9n 0.3000 67500.0n 0.7000 67749.9n 0.7000 67750.0n 0.3000 67999.9n 0.3000 68000.0n 0.3000 68249.9n 0.3000 68250.0n 0.3000 68499.9n 0.3000 68500.0n 0.3000 68749.9n 0.3000 68750.0n 0.7000 68999.9n 0.7000 69000.0n 0.3000 69249.9n 0.3000 69250.0n 0.7000 69499.9n 0.7000 69500.0n 0.7000 69749.9n 0.7000 69750.0n 0.7000 69999.9n 0.7000 70000.0n 0.3000 70249.9n 0.3000 70250.0n 0.3000 70499.9n 0.3000 70500.0n 0.7000 70749.9n 0.7000 70750.0n 0.7000 70999.9n 0.7000 71000.0n 0.7000 71249.9n 0.7000 71250.0n 0.7000 71499.9n 0.7000 71500.0n 0.7000 71749.9n 0.7000 71750.0n 0.3000 71999.9n 0.3000 72000.0n 0.3000 72249.9n 0.3000 72250.0n 0.7000 72499.9n 0.7000 72500.0n 0.3000 72749.9n 0.3000 72750.0n 0.7000 72999.9n 0.7000 73000.0n 0.3000 73249.9n 0.3000 73250.0n 0.7000 73499.9n 0.7000 73500.0n 0.7000 73749.9n 0.7000 73750.0n 0.3000 73999.9n 0.3000 74000.0n 0.7000 74249.9n 0.7000 74250.0n 0.3000 74499.9n 0.3000 74500.0n 0.3000 74749.9n 0.3000 74750.0n 0.3000 74999.9n 0.3000 75000.0n 0.7000 75249.9n 0.7000 75250.0n 0.3000 75499.9n 0.3000 75500.0n 0.3000 75749.9n 0.3000 75750.0n 0.3000 75999.9n 0.3000 76000.0n 0.3000 76249.9n 0.3000 76250.0n 0.7000 76499.9n 0.7000 76500.0n 0.3000 76749.9n 0.3000 76750.0n 0.7000 76999.9n 0.7000 77000.0n 0.7000 77249.9n 0.7000 77250.0n 0.7000 77499.9n 0.7000 77500.0n 0.3000 77749.9n 0.3000 77750.0n 0.3000 77999.9n 0.3000 78000.0n 0.7000 78249.9n 0.7000 78250.0n 0.7000 78499.9n 0.7000 78500.0n 0.7000 78749.9n 0.7000 78750.0n 0.7000 78999.9n 0.7000 79000.0n 0.7000 79249.9n 0.7000 79250.0n 0.3000 79499.9n 0.3000 79500.0n 0.3000 79749.9n 0.3000 79750.0n 0.7000 79999.9n 0.7000 80000.0n 0.3000 80249.9n 0.3000 80250.0n 0.7000 80499.9n 0.7000 80500.0n 0.3000 80749.9n 0.3000 80750.0n 0.7000 80999.9n 0.7000 81000.0n 0.7000 81249.9n 0.7000 81250.0n 0.3000 81499.9n 0.3000 81500.0n 0.7000 81749.9n 0.7000 81750.0n 0.3000 81999.9n 0.3000 82000.0n 0.3000 82249.9n 0.3000 82250.0n 0.3000 82499.9n 0.3000 82500.0n 0.7000 82749.9n 0.7000 82750.0n 0.3000 82999.9n 0.3000 83000.0n 0.3000 83249.9n 0.3000 83250.0n 0.3000 83499.9n 0.3000 83500.0n 0.3000 83749.9n 0.3000 83750.0n 0.7000 83999.9n 0.7000 84000.0n 0.3000 84249.9n 0.3000 84250.0n 0.7000 84499.9n 0.7000 84500.0n 0.7000 84749.9n 0.7000 84750.0n 0.7000 84999.9n 0.7000 85000.0n 0.3000 85249.9n 0.3000 85250.0n 0.3000 85499.9n 0.3000 85500.0n 0.7000 85749.9n 0.7000 85750.0n 0.7000 85999.9n 0.7000 86000.0n 0.7000 86249.9n 0.7000 86250.0n 0.7000 86499.9n 0.7000 86500.0n 0.7000 86749.9n 0.7000 86750.0n 0.3000 86999.9n 0.3000 87000.0n 0.3000 87249.9n 0.3000 87250.0n 0.7000 87499.9n 0.7000 87500.0n 0.3000 87749.9n 0.3000 87750.0n 0.7000 87999.9n 0.7000 88000.0n 0.3000 88249.9n 0.3000 88250.0n 0.7000 88499.9n 0.7000 88500.0n 0.7000 88749.9n 0.7000 88750.0n 0.3000 88999.9n 0.3000 89000.0n 0.7000 89249.9n 0.7000 89250.0n 0.3000 89499.9n 0.3000 89500.0n 0.3000 89749.9n 0.3000 89750.0n 0.3000 89999.9n 0.3000 90000.0n 0.7000 90249.9n 0.7000 90250.0n 0.3000 90499.9n 0.3000 90500.0n 0.3000 90749.9n 0.3000 90750.0n 0.3000 90999.9n 0.3000 91000.0n 0.3000 91249.9n 0.3000 91250.0n 0.7000 91499.9n 0.7000 91500.0n 0.3000 91749.9n 0.3000 91750.0n 0.7000 91999.9n 0.7000 92000.0n 0.7000 92249.9n 0.7000 92250.0n 0.7000 92499.9n 0.7000 92500.0n 0.3000 92749.9n 0.3000 92750.0n 0.3000 92999.9n 0.3000 93000.0n 0.7000 93249.9n 0.7000 93250.0n 0.7000 93499.9n 0.7000 93500.0n 0.7000 93749.9n 0.7000 93750.0n 0.7000 93999.9n 0.7000 94000.0n 0.7000 94249.9n 0.7000 94250.0n 0.3000 94499.9n 0.3000 94500.0n 0.3000 94749.9n 0.3000 94750.0n 0.7000 94999.9n 0.7000 95000.0n 0.3000 95249.9n 0.3000 95250.0n 0.7000 95499.9n 0.7000 95500.0n 0.3000 95749.9n 0.3000 95750.0n 0.7000 95999.9n 0.7000 96000.0n 0.7000 96249.9n 0.7000 96250.0n 0.3000 96499.9n 0.3000 96500.0n 0.7000 96749.9n 0.7000 96750.0n 0.3000 96999.9n 0.3000 97000.0n 0.3000 97249.9n 0.3000 97250.0n 0.3000 97499.9n 0.3000 97500.0n 0.7000 97749.9n 0.7000 97750.0n 0.3000 97999.9n 0.3000 98000.0n 0.3000 98249.9n 0.3000 98250.0n 0.3000 98499.9n 0.3000 98500.0n 0.3000 98749.9n 0.3000 98750.0n 0.7000 98999.9n 0.7000 99000.0n 0.3000 99249.9n 0.3000 99250.0n 0.7000 99499.9n 0.7000 99500.0n 0.7000 99749.9n 0.7000 99750.0n 0.7000 99999.9n 0.7000 100000.0n 0.3000 100249.9n 0.3000 100250.0n 0.3000 100499.9n 0.3000 100500.0n 0.7000 100749.9n 0.7000 100750.0n 0.7000 100999.9n 0.7000 101000.0n 0.7000 101249.9n 0.7000 101250.0n 0.7000 101499.9n 0.7000 101500.0n 0.7000 101749.9n 0.7000 101750.0n 0.3000 101999.9n 0.3000 102000.0n 0.3000 102249.9n 0.3000 102250.0n 0.7000 102499.9n 0.7000 102500.0n 0.3000 102749.9n 0.3000 102750.0n 0.7000 102999.9n 0.7000 103000.0n 0.3000 103249.9n 0.3000 103250.0n 0.7000 103499.9n 0.7000 103500.0n 0.7000 103749.9n 0.7000 103750.0n 0.3000 103999.9n 0.3000 104000.0n 0.7000 104249.9n 0.7000 104250.0n 0.3000 104499.9n 0.3000 104500.0n 0.3000 104749.9n 0.3000 104750.0n 0.3000 104999.9n 0.3000 105000.0n 0.7000 105249.9n 0.7000 105250.0n 0.3000 105499.9n 0.3000 105500.0n 0.3000 105749.9n 0.3000 105750.0n 0.3000 105999.9n 0.3000 106000.0n 0.3000 106249.9n 0.3000 106250.0n 0.7000 106499.9n 0.7000 106500.0n 0.3000 106749.9n 0.3000 106750.0n 0.7000 106999.9n 0.7000 107000.0n 0.7000 107249.9n 0.7000 107250.0n 0.7000 107499.9n 0.7000 107500.0n 0.3000 107749.9n 0.3000 107750.0n 0.3000 107999.9n 0.3000 108000.0n 0.7000 108249.9n 0.7000 108250.0n 0.7000 108499.9n 0.7000 108500.0n 0.7000 108749.9n 0.7000 108750.0n 0.7000 108999.9n 0.7000 109000.0n 0.7000 109249.9n 0.7000 109250.0n 0.3000 109499.9n 0.3000 109500.0n 0.3000 109749.9n 0.3000 109750.0n 0.7000 109999.9n 0.7000 110000.0n 0.3000 110249.9n 0.3000 110250.0n 0.7000 110499.9n 0.7000 110500.0n 0.3000 110749.9n 0.3000 110750.0n 0.7000 110999.9n 0.7000 111000.0n 0.7000 111249.9n 0.7000 111250.0n 0.3000 111499.9n 0.3000 111500.0n 0.7000 111749.9n 0.7000 111750.0n 0.3000 111999.9n 0.3000 112000.0n 0.3000 112249.9n 0.3000 112250.0n 0.3000 112499.9n 0.3000 112500.0n 0.7000 112749.9n 0.7000 112750.0n 0.3000 112999.9n 0.3000 113000.0n 0.3000 113249.9n 0.3000 113250.0n 0.3000 113499.9n 0.3000 113500.0n 0.3000 113749.9n 0.3000 113750.0n 0.7000 113999.9n 0.7000 114000.0n 0.3000 114249.9n 0.3000 114250.0n 0.7000 114499.9n 0.7000 114500.0n 0.7000 114749.9n 0.7000 114750.0n 0.7000 114999.9n 0.7000 115000.0n 0.3000 115249.9n 0.3000 115250.0n 0.3000 115499.9n 0.3000 115500.0n 0.7000 115749.9n 0.7000 115750.0n 0.7000 115999.9n 0.7000 116000.0n 0.7000 116249.9n 0.7000 116250.0n 0.7000 116499.9n 0.7000 116500.0n 0.7000 116749.9n 0.7000 116750.0n 0.3000 116999.9n 0.3000 117000.0n 0.3000 117249.9n 0.3000 117250.0n 0.7000 117499.9n 0.7000 117500.0n 0.3000 117749.9n 0.3000 117750.0n 0.7000 117999.9n 0.7000 118000.0n 0.3000 118249.9n 0.3000 118250.0n 0.7000 118499.9n 0.7000 118500.0n 0.7000 118749.9n 0.7000 118750.0n 0.3000 118999.9n 0.3000 119000.0n 0.7000 119249.9n 0.7000 119250.0n 0.3000 119499.9n 0.3000 119500.0n 0.3000 119749.9n 0.3000 119750.0n 0.3000 119999.9n 0.3000 120000.0n 0.7000 120249.9n 0.7000 120250.0n 0.3000 120499.9n 0.3000 120500.0n 0.3000 120749.9n 0.3000 120750.0n 0.3000 120999.9n 0.3000 121000.0n 0.3000 121249.9n 0.3000 121250.0n 0.7000 121499.9n 0.7000 121500.0n 0.3000 121749.9n 0.3000 121750.0n 0.7000 121999.9n 0.7000 122000.0n 0.7000 122249.9n 0.7000 122250.0n 0.7000 122499.9n 0.7000 122500.0n 0.3000 122749.9n 0.3000 122750.0n 0.3000 122999.9n 0.3000 123000.0n 0.7000 123249.9n 0.7000 123250.0n 0.7000 123499.9n 0.7000 123500.0n 0.7000 123749.9n 0.7000 123750.0n 0.7000 123999.9n 0.7000 124000.0n 0.7000 124249.9n 0.7000 124250.0n 0.3000 124499.9n 0.3000 124500.0n 0.3000 124749.9n 0.3000 124750.0n 0.7000 124999.9n 0.7000 125000.0n 0.3000 125249.9n 0.3000 125250.0n 0.7000 125499.9n 0.7000 125500.0n 0.3000 125749.9n 0.3000 125750.0n 0.7000 125999.9n 0.7000 126000.0n 0.7000 126249.9n 0.7000 126250.0n 0.3000 126499.9n 0.3000 126500.0n 0.7000 126749.9n 0.7000 126750.0n 0.3000 126999.9n 0.3000 127000.0n 0.3000 127249.9n 0.3000 127250.0n 0.3000 127499.9n 0.3000 127500.0n 0.7000 127749.9n 0.7000 127750.0n 0.3000 127999.9n 0.3000 128000.0n 0.3000 128249.9n 0.3000 128250.0n 0.3000 128499.9n 0.3000 128500.0n 0.3000 128749.9n 0.3000 128750.0n 0.7000 128999.9n 0.7000 129000.0n 0.3000 129249.9n 0.3000 129250.0n 0.7000 129499.9n 0.7000 129500.0n 0.7000 129749.9n 0.7000 129750.0n 0.7000 129999.9n 0.7000 130000.0n 0.3000 130249.9n 0.3000 130250.0n 0.3000 130499.9n 0.3000 130500.0n 0.7000 130749.9n 0.7000 130750.0n 0.7000 130999.9n 0.7000 131000.0n 0.7000 131249.9n 0.7000 131250.0n 0.7000 131499.9n 0.7000 131500.0n 0.7000 131749.9n 0.7000 131750.0n 0.3000 131999.9n 0.3000 132000.0n 0.3000 132249.9n 0.3000 132250.0n 0.7000 132499.9n 0.7000 132500.0n 0.3000 132749.9n 0.3000 132750.0n 0.7000 132999.9n 0.7000 133000.0n 0.3000 133249.9n 0.3000 133250.0n 0.7000 133499.9n 0.7000 133500.0n 0.7000 133749.9n 0.7000 133750.0n 0.3000 133999.9n 0.3000 134000.0n 0.7000 134249.9n 0.7000 134250.0n 0.3000 134499.9n 0.3000 134500.0n 0.3000 134749.9n 0.3000 134750.0n 0.3000 134999.9n 0.3000 135000.0n 0.7000 135249.9n 0.7000 135250.0n 0.3000 135499.9n 0.3000 135500.0n 0.3000 135749.9n 0.3000 135750.0n 0.3000 135999.9n 0.3000 136000.0n 0.3000 136249.9n 0.3000 136250.0n 0.7000 136499.9n 0.7000 136500.0n 0.3000 136749.9n 0.3000 136750.0n 0.7000 136999.9n 0.7000 137000.0n 0.7000 137249.9n 0.7000 137250.0n 0.7000 137499.9n 0.7000 137500.0n 0.3000 137749.9n 0.3000 137750.0n 0.3000 137999.9n 0.3000 138000.0n 0.7000 138249.9n 0.7000 138250.0n 0.7000 138499.9n 0.7000 138500.0n 0.7000 138749.9n 0.7000 138750.0n 0.7000 138999.9n 0.7000 139000.0n 0.7000 139249.9n 0.7000 139250.0n 0.3000 139499.9n 0.3000 139500.0n 0.3000 139749.9n 0.3000 139750.0n 0.7000 139999.9n 0.7000 140000.0n 0.3000 140249.9n 0.3000 140250.0n 0.7000 140499.9n 0.7000 140500.0n 0.3000 140749.9n 0.3000 140750.0n 0.7000 140999.9n 0.7000 141000.0n 0.7000 141249.9n 0.7000 141250.0n 0.3000 141499.9n 0.3000 141500.0n 0.7000 141749.9n 0.7000 141750.0n 0.3000 141999.9n 0.3000 142000.0n 0.3000 142249.9n 0.3000 142250.0n 0.3000 142499.9n 0.3000 142500.0n 0.7000 142749.9n 0.7000 142750.0n 0.3000 142999.9n 0.3000 143000.0n 0.3000 143249.9n 0.3000 143250.0n 0.3000 143499.9n 0.3000 143500.0n 0.3000 143749.9n 0.3000 143750.0n 0.7000 143999.9n 0.7000 144000.0n 0.3000 144249.9n 0.3000 144250.0n 0.7000 144499.9n 0.7000 144500.0n 0.7000 144749.9n 0.7000 144750.0n 0.7000 144999.9n 0.7000 145000.0n 0.3000 145249.9n 0.3000 145250.0n 0.3000 145499.9n 0.3000 145500.0n 0.7000 145749.9n 0.7000 145750.0n 0.7000 145999.9n 0.7000 146000.0n 0.7000 146249.9n 0.7000 146250.0n 0.7000 146499.9n 0.7000 146500.0n 0.7000 146749.9n 0.7000 146750.0n 0.3000 146999.9n 0.3000 147000.0n 0.3000 147249.9n 0.3000 147250.0n 0.7000 147499.9n 0.7000 147500.0n 0.3000 147749.9n 0.3000 147750.0n 0.7000 147999.9n 0.7000 148000.0n 0.3000 148249.9n 0.3000 148250.0n 0.7000 148499.9n 0.7000 148500.0n 0.7000 148749.9n 0.7000 148750.0n 0.3000 148999.9n 0.3000 149000.0n 0.7000 149249.9n 0.7000 149250.0n 0.3000 149499.9n 0.3000 149500.0n 0.3000 149749.9n 0.3000 149750.0n 0.3000 149999.9n 0.3000 150000.0n 0.7000 150249.9n 0.7000 150250.0n 0.3000 150499.9n 0.3000 150500.0n 0.3000 150749.9n 0.3000 150750.0n 0.3000 150999.9n 0.3000 151000.0n 0.3000 151249.9n 0.3000 151250.0n 0.7000 151499.9n 0.7000 151500.0n 0.3000 151749.9n 0.3000 151750.0n 0.7000 151999.9n 0.7000 152000.0n 0.7000 152249.9n 0.7000 152250.0n 0.7000 152499.9n 0.7000 152500.0n 0.3000 152749.9n 0.3000 152750.0n 0.3000 152999.9n 0.3000 153000.0n 0.7000 153249.9n 0.7000 153250.0n 0.7000 153499.9n 0.7000 153500.0n 0.7000 153749.9n 0.7000 153750.0n 0.7000 153999.9n 0.7000 154000.0n 0.7000 154249.9n 0.7000 154250.0n 0.3000 154499.9n 0.3000 154500.0n 0.3000 154749.9n 0.3000 154750.0n 0.7000 154999.9n 0.7000 155000.0n 0.3000 155249.9n 0.3000 155250.0n 0.7000 155499.9n 0.7000 155500.0n 0.3000 155749.9n 0.3000 155750.0n 0.7000 155999.9n 0.7000 156000.0n 0.7000 156249.9n 0.7000 156250.0n 0.3000 156499.9n 0.3000 156500.0n 0.7000 156749.9n 0.7000 156750.0n 0.3000 156999.9n 0.3000 157000.0n 0.3000 157249.9n 0.3000 157250.0n 0.3000 157499.9n 0.3000 157500.0n 0.7000 157749.9n 0.7000 157750.0n 0.3000 157999.9n 0.3000 158000.0n 0.3000 158249.9n 0.3000 158250.0n 0.3000 158499.9n 0.3000 158500.0n 0.3000 158749.9n 0.3000 158750.0n 0.7000 158999.9n 0.7000 159000.0n 0.3000 159249.9n 0.3000 159250.0n 0.7000 159499.9n 0.7000 159500.0n 0.7000 159749.9n 0.7000 159750.0n 0.7000 159999.9n 0.7000 160000.0n 0.3000 160249.9n 0.3000 160250.0n 0.3000 160499.9n 0.3000 160500.0n 0.7000 160749.9n 0.7000 160750.0n 0.7000 160999.9n 0.7000 161000.0n 0.7000 161249.9n 0.7000 161250.0n 0.7000 161499.9n 0.7000 161500.0n 0.7000 161749.9n 0.7000 161750.0n 0.3000 161999.9n 0.3000 162000.0n 0.3000 162249.9n 0.3000 162250.0n 0.7000 162499.9n 0.7000 162500.0n 0.3000 162749.9n 0.3000 162750.0n 0.7000 162999.9n 0.7000 163000.0n 0.3000 163249.9n 0.3000 163250.0n 0.7000 163499.9n 0.7000 163500.0n 0.7000 163749.9n 0.7000 163750.0n 0.3000 163999.9n 0.3000 164000.0n 0.7000 164249.9n 0.7000 164250.0n 0.3000 164499.9n 0.3000 164500.0n 0.3000 164749.9n 0.3000 164750.0n 0.3000 164999.9n 0.3000 165000.0n 0.7000 165249.9n 0.7000 165250.0n 0.3000 165499.9n 0.3000 165500.0n 0.3000 165749.9n 0.3000 165750.0n 0.3000 165999.9n 0.3000 166000.0n 0.3000 166249.9n 0.3000 166250.0n 0.7000 166499.9n 0.7000 166500.0n 0.3000 166749.9n 0.3000 166750.0n 0.7000 166999.9n 0.7000 167000.0n 0.7000 167249.9n 0.7000 167250.0n 0.7000 167499.9n 0.7000 167500.0n 0.3000 167749.9n 0.3000 167750.0n 0.3000 167999.9n 0.3000 168000.0n 0.7000 168249.9n 0.7000 168250.0n 0.7000 168499.9n 0.7000 168500.0n 0.7000 168749.9n 0.7000 168750.0n 0.7000 168999.9n 0.7000 169000.0n 0.7000 169249.9n 0.7000 169250.0n 0.3000 169499.9n 0.3000 169500.0n 0.3000 169749.9n 0.3000 169750.0n 0.7000 169999.9n 0.7000 170000.0n 0.3000 170249.9n 0.3000 170250.0n 0.7000 170499.9n 0.7000 170500.0n 0.3000 170749.9n 0.3000 170750.0n 0.7000 170999.9n 0.7000 171000.0n 0.7000 171249.9n 0.7000 171250.0n 0.3000 171499.9n 0.3000 171500.0n 0.7000 171749.9n 0.7000 171750.0n 0.3000 171999.9n 0.3000 172000.0n 0.3000 172249.9n 0.3000 172250.0n 0.3000 172499.9n 0.3000 172500.0n 0.7000 172749.9n 0.7000 172750.0n 0.3000 172999.9n 0.3000 173000.0n 0.3000 173249.9n 0.3000 173250.0n 0.3000 173499.9n 0.3000 173500.0n 0.3000 173749.9n 0.3000 173750.0n 0.7000 173999.9n 0.7000 174000.0n 0.3000 174249.9n 0.3000 174250.0n 0.7000 174499.9n 0.7000 174500.0n 0.7000 174749.9n 0.7000 174750.0n 0.7000 174999.9n 0.7000 175000.0n 0.3000 175249.9n 0.3000 175250.0n 0.3000 175499.9n 0.3000 175500.0n 0.7000 175749.9n 0.7000 175750.0n 0.7000 175999.9n 0.7000 176000.0n 0.7000 176249.9n 0.7000 176250.0n 0.7000 176499.9n 0.7000 176500.0n 0.7000 176749.9n 0.7000 176750.0n 0.3000 176999.9n 0.3000 177000.0n 0.3000 177249.9n 0.3000 177250.0n 0.7000 177499.9n 0.7000 177500.0n 0.3000 177749.9n 0.3000 177750.0n 0.7000 177999.9n 0.7000 178000.0n 0.3000 178249.9n 0.3000 178250.0n 0.7000 178499.9n 0.7000 178500.0n 0.7000 178749.9n 0.7000 178750.0n 0.3000 178999.9n 0.3000 179000.0n 0.7000 179249.9n 0.7000 179250.0n 0.3000 179499.9n 0.3000 179500.0n 0.3000 179749.9n 0.3000 179750.0n 0.3000 179999.9n 0.3000 180000.0n 0.7000 180249.9n 0.7000 180250.0n 0.3000 180499.9n 0.3000 180500.0n 0.3000 180749.9n 0.3000 180750.0n 0.3000 180999.9n 0.3000 181000.0n 0.3000 181249.9n 0.3000 181250.0n 0.7000 181499.9n 0.7000 181500.0n 0.3000 181749.9n 0.3000 181750.0n 0.7000 181999.9n 0.7000 182000.0n 0.7000 182249.9n 0.7000 182250.0n 0.7000 182499.9n 0.7000 182500.0n 0.3000 182749.9n 0.3000 182750.0n 0.3000 182999.9n 0.3000 183000.0n 0.7000 183249.9n 0.7000 183250.0n 0.7000 183499.9n 0.7000 183500.0n 0.7000 183749.9n 0.7000 183750.0n 0.7000 183999.9n 0.7000 184000.0n 0.7000 184249.9n 0.7000 184250.0n 0.3000 184499.9n 0.3000 184500.0n 0.3000 184749.9n 0.3000 184750.0n 0.7000 184999.9n 0.7000 185000.0n 0.3000 185249.9n 0.3000 185250.0n 0.7000 185499.9n 0.7000 185500.0n 0.3000 185749.9n 0.3000 185750.0n 0.7000 185999.9n 0.7000 186000.0n 0.7000 186249.9n 0.7000 186250.0n 0.3000 186499.9n 0.3000 186500.0n 0.7000 186749.9n 0.7000 186750.0n 0.3000 186999.9n 0.3000 187000.0n 0.3000 187249.9n 0.3000 187250.0n 0.3000 187499.9n 0.3000 187500.0n 0.7000 187749.9n 0.7000 187750.0n 0.3000 187999.9n 0.3000 188000.0n 0.3000 188249.9n 0.3000 188250.0n 0.3000 188499.9n 0.3000 188500.0n 0.3000 188749.9n 0.3000 188750.0n 0.7000 188999.9n 0.7000 189000.0n 0.3000 189249.9n 0.3000 189250.0n 0.7000 189499.9n 0.7000 189500.0n 0.7000 189749.9n 0.7000 189750.0n 0.7000 189999.9n 0.7000 190000.0n 0.3000 190249.9n 0.3000 190250.0n 0.3000 190499.9n 0.3000 190500.0n 0.7000 190749.9n 0.7000 190750.0n 0.7000 190999.9n 0.7000 191000.0n 0.7000 191249.9n 0.7000 191250.0n 0.7000 191499.9n 0.7000 191500.0n 0.7000 191749.9n 0.7000 191750.0n 0.3000 191999.9n 0.3000 192000.0n 0.3000 192249.9n 0.3000 192250.0n 0.7000 192499.9n 0.7000 192500.0n 0.3000 192749.9n 0.3000 192750.0n 0.7000 192999.9n 0.7000 193000.0n 0.3000 193249.9n 0.3000 193250.0n 0.7000 193499.9n 0.7000 193500.0n 0.7000 193749.9n 0.7000 193750.0n 0.3000 193999.9n 0.3000 194000.0n 0.7000 194249.9n 0.7000 194250.0n 0.3000 194499.9n 0.3000 194500.0n 0.3000 194749.9n 0.3000 194750.0n 0.3000 194999.9n 0.3000 195000.0n 0.7000 195249.9n 0.7000 195250.0n 0.3000 195499.9n 0.3000 195500.0n 0.3000 195749.9n 0.3000 195750.0n 0.3000 195999.9n 0.3000 196000.0n 0.3000 196249.9n 0.3000 196250.0n 0.7000 196499.9n 0.7000 196500.0n 0.3000 196749.9n 0.3000 196750.0n 0.7000 196999.9n 0.7000 197000.0n 0.7000 197249.9n 0.7000 197250.0n 0.7000 197499.9n 0.7000 197500.0n 0.3000 197749.9n 0.3000 197750.0n 0.3000 197999.9n 0.3000 198000.0n 0.7000 198249.9n 0.7000 198250.0n 0.7000 198499.9n 0.7000 198500.0n 0.7000 198749.9n 0.7000 198750.0n 0.7000 198999.9n 0.7000 199000.0n 0.7000 199249.9n 0.7000 199250.0n 0.3000 199499.9n 0.3000 199500.0n 0.3000 199749.9n 0.3000 199750.0n 0.7000 199999.9n 0.7000 200000.0n 0.3000 200249.9n 0.3000 200250.0n 0.7000 200499.9n 0.7000 200500.0n 0.3000 200749.9n 0.3000 200750.0n 0.7000 200999.9n 0.7000 201000.0n 0.7000 201249.9n 0.7000 201250.0n 0.3000 201499.9n 0.3000 201500.0n 0.7000 201749.9n 0.7000 201750.0n 0.3000 201999.9n 0.3000 202000.0n 0.3000 202249.9n 0.3000 202250.0n 0.3000 202499.9n 0.3000 202500.0n 0.7000 202749.9n 0.7000 202750.0n 0.3000 202999.9n 0.3000 203000.0n 0.3000 203249.9n 0.3000 203250.0n 0.3000 203499.9n 0.3000 203500.0n 0.3000 203749.9n 0.3000 203750.0n 0.7000 203999.9n 0.7000 204000.0n 0.3000 204249.9n 0.3000 204250.0n 0.7000 204499.9n 0.7000 204500.0n 0.7000 204749.9n 0.7000 204750.0n 0.7000 204999.9n 0.7000 205000.0n 0.3000 205249.9n 0.3000 205250.0n 0.3000 205499.9n 0.3000 205500.0n 0.7000 205749.9n 0.7000 205750.0n 0.7000 205999.9n 0.7000 206000.0n 0.7000 206249.9n 0.7000 206250.0n 0.7000 206499.9n 0.7000 206500.0n 0.7000 206749.9n 0.7000 206750.0n 0.3000 206999.9n 0.3000 207000.0n 0.3000 207249.9n 0.3000 207250.0n 0.7000 207499.9n 0.7000 207500.0n 0.3000 207749.9n 0.3000 207750.0n 0.7000 207999.9n 0.7000 208000.0n 0.3000 208249.9n 0.3000 208250.0n 0.7000 208499.9n 0.7000 208500.0n 0.7000 208749.9n 0.7000 208750.0n 0.3000 208999.9n 0.3000 209000.0n 0.7000 209249.9n 0.7000 209250.0n 0.3000 209499.9n 0.3000 209500.0n 0.3000 209749.9n 0.3000 209750.0n 0.3000 209999.9n 0.3000 210000.0n 0.7000 210249.9n 0.7000 210250.0n 0.3000 210499.9n 0.3000 210500.0n 0.3000 210749.9n 0.3000 210750.0n 0.3000 210999.9n 0.3000 211000.0n 0.3000 211249.9n 0.3000 211250.0n 0.7000 211499.9n 0.7000 211500.0n 0.3000 211749.9n 0.3000 211750.0n 0.7000 211999.9n 0.7000 212000.0n 0.7000 212249.9n 0.7000 212250.0n 0.7000 212499.9n 0.7000 212500.0n 0.3000 212749.9n 0.3000 212750.0n 0.3000 212999.9n 0.3000 213000.0n 0.7000 213249.9n 0.7000 213250.0n 0.7000 213499.9n 0.7000 213500.0n 0.7000 213749.9n 0.7000 213750.0n 0.7000 213999.9n 0.7000 214000.0n 0.7000 214249.9n 0.7000 214250.0n 0.3000 214499.9n 0.3000 214500.0n 0.3000 214749.9n 0.3000 214750.0n 0.7000 214999.9n 0.7000 215000.0n 0.3000 215249.9n 0.3000 215250.0n 0.7000 215499.9n 0.7000 215500.0n 0.3000 215749.9n 0.3000 215750.0n 0.7000 215999.9n 0.7000 216000.0n 0.7000 216249.9n 0.7000 216250.0n 0.3000 216499.9n 0.3000 216500.0n 0.7000 216749.9n 0.7000 216750.0n 0.3000 216999.9n 0.3000 217000.0n 0.3000 217249.9n 0.3000 217250.0n 0.3000 217499.9n 0.3000 217500.0n 0.7000 217749.9n 0.7000 217750.0n 0.3000 217999.9n 0.3000 218000.0n 0.3000 218249.9n 0.3000 218250.0n 0.3000 218499.9n 0.3000 218500.0n 0.3000 218749.9n 0.3000 218750.0n 0.7000 218999.9n 0.7000 219000.0n 0.3000 219249.9n 0.3000 219250.0n 0.7000 219499.9n 0.7000 219500.0n 0.7000 219749.9n 0.7000 219750.0n 0.7000 219999.9n 0.7000 220000.0n 0.3000 220249.9n 0.3000 220250.0n 0.3000 220499.9n 0.3000 220500.0n 0.7000 220749.9n 0.7000 220750.0n 0.7000 220999.9n 0.7000 221000.0n 0.7000 221249.9n 0.7000 221250.0n 0.7000 221499.9n 0.7000 221500.0n 0.7000 221749.9n 0.7000 221750.0n 0.3000 221999.9n 0.3000 222000.0n 0.3000 222249.9n 0.3000 222250.0n 0.7000 222499.9n 0.7000 222500.0n 0.3000 222749.9n 0.3000 222750.0n 0.7000 222999.9n 0.7000 223000.0n 0.3000 223249.9n 0.3000 223250.0n 0.7000 223499.9n 0.7000 223500.0n 0.7000 223749.9n 0.7000 223750.0n 0.3000 223999.9n 0.3000 224000.0n 0.7000 224249.9n 0.7000 224250.0n 0.3000 224499.9n 0.3000 224500.0n 0.3000 224749.9n 0.3000 224750.0n 0.3000 224999.9n 0.3000 225000.0n 0.7000 225249.9n 0.7000 225250.0n 0.3000 225499.9n 0.3000 225500.0n 0.3000 225749.9n 0.3000 225750.0n 0.3000 225999.9n 0.3000 226000.0n 0.3000 226249.9n 0.3000 226250.0n 0.7000 226499.9n 0.7000 226500.0n 0.3000 226749.9n 0.3000 226750.0n 0.7000 226999.9n 0.7000 227000.0n 0.7000 227249.9n 0.7000 227250.0n 0.7000 227499.9n 0.7000 227500.0n 0.3000 227749.9n 0.3000 227750.0n 0.3000 227999.9n 0.3000 228000.0n 0.7000 228249.9n 0.7000 228250.0n 0.7000 228499.9n 0.7000 228500.0n 0.7000 228749.9n 0.7000 228750.0n 0.7000 228999.9n 0.7000 229000.0n 0.7000 229249.9n 0.7000 229250.0n 0.3000 229499.9n 0.3000 229500.0n 0.3000 229749.9n 0.3000 229750.0n 0.7000 229999.9n 0.7000 230000.0n 0.3000 230249.9n 0.3000 230250.0n 0.7000 230499.9n 0.7000 230500.0n 0.3000 230749.9n 0.3000 230750.0n 0.7000 230999.9n 0.7000 231000.0n 0.7000 231249.9n 0.7000 231250.0n 0.3000 231499.9n 0.3000 231500.0n 0.7000 231749.9n 0.7000 231750.0n 0.3000 231999.9n 0.3000 232000.0n 0.3000 232249.9n 0.3000 232250.0n 0.3000 232499.9n 0.3000 232500.0n 0.7000 232749.9n 0.7000 232750.0n 0.3000 232999.9n 0.3000 233000.0n 0.3000 233249.9n 0.3000 233250.0n 0.3000 233499.9n 0.3000 233500.0n 0.3000 233749.9n 0.3000 233750.0n 0.7000 233999.9n 0.7000 234000.0n 0.3000 234249.9n 0.3000 234250.0n 0.7000 234499.9n 0.7000 234500.0n 0.7000 234749.9n 0.7000 234750.0n 0.7000 234999.9n 0.7000 235000.0n 0.3000 235249.9n 0.3000 235250.0n 0.3000 235499.9n 0.3000 235500.0n 0.7000 235749.9n 0.7000 235750.0n 0.7000 235999.9n 0.7000 236000.0n 0.7000 236249.9n 0.7000 236250.0n 0.7000 236499.9n 0.7000 236500.0n 0.7000 236749.9n 0.7000 236750.0n 0.3000 236999.9n 0.3000 237000.0n 0.3000 237249.9n 0.3000 237250.0n 0.7000 237499.9n 0.7000 237500.0n 0.3000 237749.9n 0.3000 237750.0n 0.7000 237999.9n 0.7000 238000.0n 0.3000 238249.9n 0.3000 238250.0n 0.7000 238499.9n 0.7000 238500.0n 0.7000 238749.9n 0.7000 238750.0n 0.3000 238999.9n 0.3000 239000.0n 0.7000 239249.9n 0.7000 239250.0n 0.3000 239499.9n 0.3000 239500.0n 0.3000 239749.9n 0.3000 239750.0n 0.3000 239999.9n 0.3000 240000.0n 0.7000 240249.9n 0.7000 240250.0n 0.3000 240499.9n 0.3000 240500.0n 0.3000 240749.9n 0.3000 240750.0n 0.3000 240999.9n 0.3000 241000.0n 0.3000 241249.9n 0.3000 241250.0n 0.7000 241499.9n 0.7000 241500.0n 0.3000 241749.9n 0.3000 241750.0n 0.7000 241999.9n 0.7000 242000.0n 0.7000 242249.9n 0.7000 242250.0n 0.7000 242499.9n 0.7000 242500.0n 0.3000 242749.9n 0.3000 242750.0n 0.3000 242999.9n 0.3000 243000.0n 0.7000 243249.9n 0.7000 243250.0n 0.7000 243499.9n 0.7000 243500.0n 0.7000 243749.9n 0.7000 243750.0n 0.7000 243999.9n 0.7000 244000.0n 0.7000 244249.9n 0.7000 244250.0n 0.3000 244499.9n 0.3000 244500.0n 0.3000 244749.9n 0.3000 244750.0n 0.7000 244999.9n 0.7000 245000.0n 0.3000 245249.9n 0.3000 245250.0n 0.7000 245499.9n 0.7000 245500.0n 0.3000 245749.9n 0.3000 245750.0n 0.7000 245999.9n 0.7000 246000.0n 0.7000 246249.9n 0.7000 246250.0n 0.3000 246499.9n 0.3000 246500.0n 0.7000 246749.9n 0.7000 246750.0n 0.3000 246999.9n 0.3000 247000.0n 0.3000 247249.9n 0.3000 247250.0n 0.3000 247499.9n 0.3000 247500.0n 0.7000 247749.9n 0.7000 247750.0n 0.3000 247999.9n 0.3000 248000.0n 0.3000 248249.9n 0.3000 248250.0n 0.3000 248499.9n 0.3000 248500.0n 0.3000 248749.9n 0.3000 248750.0n 0.7000 248999.9n 0.7000 249000.0n 0.3000 249249.9n 0.3000 249250.0n 0.7000 249499.9n 0.7000 249500.0n 0.7000 249749.9n 0.7000 249750.0n 0.7000 249999.9n 0.7000 250000.0n 0.3000 250249.9n 0.3000 250250.0n 0.3000 250499.9n 0.3000 250500.0n 0.7000 250749.9n 0.7000 250750.0n 0.7000 250999.9n 0.7000 251000.0n 0.7000 251249.9n 0.7000 251250.0n 0.7000 251499.9n 0.7000 251500.0n 0.7000 251749.9n 0.7000 251750.0n 0.3000 251999.9n 0.3000 252000.0n 0.3000 252249.9n 0.3000 252250.0n 0.7000 252499.9n 0.7000 252500.0n 0.3000 252749.9n 0.3000 252750.0n 0.7000 252999.9n 0.7000 253000.0n 0.3000 253249.9n 0.3000 253250.0n 0.7000 253499.9n 0.7000 253500.0n 0.7000 253749.9n 0.7000 253750.0n 0.3000 253999.9n 0.3000 254000.0n 0.7000 254249.9n 0.7000 254250.0n 0.3000 254499.9n 0.3000 254500.0n 0.3000 254749.9n 0.3000 254750.0n 0.3000 254999.9n 0.3000 255000.0n 0.7000 255249.9n 0.7000 255250.0n 0.3000 255499.9n 0.3000 255500.0n 0.3000 255749.9n 0.3000 255750.0n 0.3000 255999.9n 0.3000 256000.0n 0.3000 256249.9n 0.3000 256250.0n 0.7000 256499.9n 0.7000 256500.0n 0.3000 256749.9n 0.3000 256750.0n 0.7000 256999.9n 0.7000 257000.0n 0.7000 257249.9n 0.7000 257250.0n 0.7000 257499.9n 0.7000 257500.0n 0.3000 257749.9n 0.3000 257750.0n 0.3000 257999.9n 0.3000 258000.0n 0.7000 258249.9n 0.7000 258250.0n 0.7000 258499.9n 0.7000 258500.0n 0.7000 258749.9n 0.7000 258750.0n 0.7000 258999.9n 0.7000 259000.0n 0.7000 259249.9n 0.7000 259250.0n 0.3000 259499.9n 0.3000 259500.0n 0.3000 259749.9n 0.3000 259750.0n 0.7000 259999.9n 0.7000 260000.0n 0.3000 260249.9n 0.3000 260250.0n 0.7000 260499.9n 0.7000 260500.0n 0.3000 260749.9n 0.3000 260750.0n 0.7000 260999.9n 0.7000 261000.0n 0.7000 261249.9n 0.7000 261250.0n 0.3000 261499.9n 0.3000 261500.0n 0.7000 261749.9n 0.7000 261750.0n 0.3000 261999.9n 0.3000 262000.0n 0.3000 262249.9n 0.3000 262250.0n 0.3000 262499.9n 0.3000 262500.0n 0.7000 262749.9n 0.7000 262750.0n 0.3000 262999.9n 0.3000 263000.0n 0.3000 263249.9n 0.3000 263250.0n 0.3000 263499.9n 0.3000 263500.0n 0.3000 263749.9n 0.3000 263750.0n 0.7000 263999.9n 0.7000 264000.0n 0.3000 264249.9n 0.3000 264250.0n 0.7000 264499.9n 0.7000 264500.0n 0.7000 264749.9n 0.7000 264750.0n 0.7000 264999.9n 0.7000 265000.0n 0.3000 265249.9n 0.3000 265250.0n 0.3000 265499.9n 0.3000 265500.0n 0.7000 265749.9n 0.7000 265750.0n 0.7000 265999.9n 0.7000 266000.0n 0.7000 266249.9n 0.7000 266250.0n 0.7000 266499.9n 0.7000 266500.0n 0.7000 266749.9n 0.7000 266750.0n 0.3000 266999.9n 0.3000 267000.0n 0.3000 267249.9n 0.3000 267250.0n 0.7000 267499.9n 0.7000 267500.0n 0.3000 267749.9n 0.3000 267750.0n 0.7000 267999.9n 0.7000 268000.0n 0.3000 268249.9n 0.3000 268250.0n 0.7000 268499.9n 0.7000 268500.0n 0.7000 268749.9n 0.7000 268750.0n 0.3000 268999.9n 0.3000 269000.0n 0.7000 269249.9n 0.7000 269250.0n 0.3000 269499.9n 0.3000 269500.0n 0.3000 269749.9n 0.3000 269750.0n 0.3000 269999.9n 0.3000 270000.0n 0.7000 270249.9n 0.7000 270250.0n 0.3000 270499.9n 0.3000 270500.0n 0.3000 270749.9n 0.3000 270750.0n 0.3000 270999.9n 0.3000 271000.0n 0.3000 271249.9n 0.3000 271250.0n 0.7000 271499.9n 0.7000 271500.0n 0.3000 271749.9n 0.3000 271750.0n 0.7000 271999.9n 0.7000 272000.0n 0.7000 272249.9n 0.7000 272250.0n 0.7000 272499.9n 0.7000 272500.0n 0.3000 272749.9n 0.3000 272750.0n 0.3000 272999.9n 0.3000 273000.0n 0.7000 273249.9n 0.7000 273250.0n 0.7000 273499.9n 0.7000 273500.0n 0.7000 273749.9n 0.7000 273750.0n 0.7000 273999.9n 0.7000 274000.0n 0.7000 274249.9n 0.7000 274250.0n 0.3000 274499.9n 0.3000 274500.0n 0.3000 274749.9n 0.3000 274750.0n 0.7000 274999.9n 0.7000 275000.0n 0.3000 275249.9n 0.3000 275250.0n 0.7000 275499.9n 0.7000 275500.0n 0.3000 275749.9n 0.3000 275750.0n 0.7000 275999.9n 0.7000 276000.0n 0.7000 276249.9n 0.7000 276250.0n 0.3000 276499.9n 0.3000 276500.0n 0.7000 276749.9n 0.7000 276750.0n 0.3000 276999.9n 0.3000 277000.0n 0.3000 277249.9n 0.3000 277250.0n 0.3000 277499.9n 0.3000 277500.0n 0.7000 277749.9n 0.7000 277750.0n 0.3000 277999.9n 0.3000 278000.0n 0.3000 278249.9n 0.3000 278250.0n 0.3000 278499.9n 0.3000 278500.0n 0.3000 278749.9n 0.3000 278750.0n 0.7000 278999.9n 0.7000 279000.0n 0.3000 279249.9n 0.3000 279250.0n 0.7000 279499.9n 0.7000 279500.0n 0.7000 279749.9n 0.7000 279750.0n 0.7000 279999.9n 0.7000 280000.0n 0.3000 280249.9n 0.3000 280250.0n 0.3000 280499.9n 0.3000 280500.0n 0.7000 280749.9n 0.7000 280750.0n 0.7000 280999.9n 0.7000 281000.0n 0.7000 281249.9n 0.7000 281250.0n 0.7000 281499.9n 0.7000 281500.0n 0.7000 281749.9n 0.7000 281750.0n 0.3000 281999.9n 0.3000 282000.0n 0.3000 282249.9n 0.3000 282250.0n 0.7000 282499.9n 0.7000 282500.0n 0.3000 282749.9n 0.3000 282750.0n 0.7000 282999.9n 0.7000 283000.0n 0.3000 283249.9n 0.3000 283250.0n 0.7000 283499.9n 0.7000 283500.0n 0.7000 283749.9n 0.7000 283750.0n 0.3000 283999.9n 0.3000 284000.0n 0.7000 284249.9n 0.7000 284250.0n 0.3000 284499.9n 0.3000 284500.0n 0.3000 284749.9n 0.3000 284750.0n 0.3000 284999.9n 0.3000 285000.0n 0.7000 285249.9n 0.7000 285250.0n 0.3000 285499.9n 0.3000 285500.0n 0.3000 285749.9n 0.3000 285750.0n 0.3000 285999.9n 0.3000 286000.0n 0.3000 286249.9n 0.3000 286250.0n 0.7000 286499.9n 0.7000 286500.0n 0.3000 286749.9n 0.3000 286750.0n 0.7000 286999.9n 0.7000 287000.0n 0.7000 287249.9n 0.7000 287250.0n 0.7000 287499.9n 0.7000 287500.0n 0.3000 287749.9n 0.3000 287750.0n 0.3000 287999.9n 0.3000 288000.0n 0.7000 288249.9n 0.7000 288250.0n 0.7000 288499.9n 0.7000 288500.0n 0.7000 288749.9n 0.7000 288750.0n 0.7000 288999.9n 0.7000 289000.0n 0.7000 289249.9n 0.7000 289250.0n 0.3000 289499.9n 0.3000 289500.0n 0.3000 289749.9n 0.3000 289750.0n 0.7000 289999.9n 0.7000 290000.0n 0.3000 290249.9n 0.3000 290250.0n 0.7000 290499.9n 0.7000 290500.0n 0.3000 290749.9n 0.3000 290750.0n 0.7000 290999.9n 0.7000 291000.0n 0.7000 291249.9n 0.7000 291250.0n 0.3000 291499.9n 0.3000 291500.0n 0.7000 291749.9n 0.7000 291750.0n 0.3000 291999.9n 0.3000 292000.0n 0.3000 292249.9n 0.3000 292250.0n 0.3000 292499.9n 0.3000 292500.0n 0.7000 292749.9n 0.7000 292750.0n 0.3000 292999.9n 0.3000 293000.0n 0.3000 293249.9n 0.3000 293250.0n 0.3000 293499.9n 0.3000 293500.0n 0.3000 293749.9n 0.3000 293750.0n 0.7000 293999.9n 0.7000 294000.0n 0.3000 294249.9n 0.3000 294250.0n 0.7000 294499.9n 0.7000 294500.0n 0.7000 294749.9n 0.7000 294750.0n 0.7000 294999.9n 0.7000 295000.0n 0.3000 295249.9n 0.3000 295250.0n 0.3000 295499.9n 0.3000 295500.0n 0.7000 295749.9n 0.7000 295750.0n 0.7000 295999.9n 0.7000 296000.0n 0.7000 296249.9n 0.7000 296250.0n 0.7000 296499.9n 0.7000 296500.0n 0.7000 296749.9n 0.7000 296750.0n 0.3000 296999.9n 0.3000 297000.0n 0.3000 297249.9n 0.3000 297250.0n 0.7000 297499.9n 0.7000 297500.0n 0.3000 297749.9n 0.3000 297750.0n 0.7000 297999.9n 0.7000 298000.0n 0.3000 298249.9n 0.3000 298250.0n 0.7000 298499.9n 0.7000 298500.0n 0.7000 298749.9n 0.7000 298750.0n 0.3000 298999.9n 0.3000 299000.0n 0.7000 299249.9n 0.7000 299250.0n 0.3000 299499.9n 0.3000 299500.0n 0.3000 299749.9n 0.3000 299750.0n 0.3000)
Vtn1 xon1 0 PWL(0.0n 0.3000 249.9n 0.3000 250.0n 0.7000 499.9n 0.7000 500.0n 0.7000 749.9n 0.7000 750.0n 0.7000 999.9n 0.7000 1000.0n 0.7000 1249.9n 0.7000 1250.0n 0.3000 1499.9n 0.3000 1500.0n 0.7000 1749.9n 0.7000 1750.0n 0.3000 1999.9n 0.3000 2000.0n 0.3000 2249.9n 0.3000 2250.0n 0.3000 2499.9n 0.3000 2500.0n 0.7000 2749.9n 0.7000 2750.0n 0.7000 2999.9n 0.7000 3000.0n 0.3000 3249.9n 0.3000 3250.0n 0.3000 3499.9n 0.3000 3500.0n 0.3000 3749.9n 0.3000 3750.0n 0.3000 3999.9n 0.3000 4000.0n 0.3000 4249.9n 0.3000 4250.0n 0.7000 4499.9n 0.7000 4500.0n 0.7000 4749.9n 0.7000 4750.0n 0.3000 4999.9n 0.3000 5000.0n 0.7000 5249.9n 0.7000 5250.0n 0.3000 5499.9n 0.3000 5500.0n 0.7000 5749.9n 0.7000 5750.0n 0.3000 5999.9n 0.3000 6000.0n 0.3000 6249.9n 0.3000 6250.0n 0.7000 6499.9n 0.7000 6500.0n 0.3000 6749.9n 0.3000 6750.0n 0.7000 6999.9n 0.7000 7000.0n 0.7000 7249.9n 0.7000 7250.0n 0.7000 7499.9n 0.7000 7500.0n 0.3000 7749.9n 0.3000 7750.0n 0.7000 7999.9n 0.7000 8000.0n 0.7000 8249.9n 0.7000 8250.0n 0.7000 8499.9n 0.7000 8500.0n 0.7000 8749.9n 0.7000 8750.0n 0.3000 8999.9n 0.3000 9000.0n 0.7000 9249.9n 0.7000 9250.0n 0.3000 9499.9n 0.3000 9500.0n 0.3000 9749.9n 0.3000 9750.0n 0.3000 9999.9n 0.3000 10000.0n 0.7000 10249.9n 0.7000 10250.0n 0.7000 10499.9n 0.7000 10500.0n 0.3000 10749.9n 0.3000 10750.0n 0.3000 10999.9n 0.3000 11000.0n 0.3000 11249.9n 0.3000 11250.0n 0.3000 11499.9n 0.3000 11500.0n 0.3000 11749.9n 0.3000 11750.0n 0.7000 11999.9n 0.7000 12000.0n 0.7000 12249.9n 0.7000 12250.0n 0.3000 12499.9n 0.3000 12500.0n 0.7000 12749.9n 0.7000 12750.0n 0.3000 12999.9n 0.3000 13000.0n 0.7000 13249.9n 0.7000 13250.0n 0.3000 13499.9n 0.3000 13500.0n 0.3000 13749.9n 0.3000 13750.0n 0.7000 13999.9n 0.7000 14000.0n 0.3000 14249.9n 0.3000 14250.0n 0.7000 14499.9n 0.7000 14500.0n 0.7000 14749.9n 0.7000 14750.0n 0.7000 14999.9n 0.7000 15000.0n 0.3000 15249.9n 0.3000 15250.0n 0.7000 15499.9n 0.7000 15500.0n 0.7000 15749.9n 0.7000 15750.0n 0.7000 15999.9n 0.7000 16000.0n 0.7000 16249.9n 0.7000 16250.0n 0.3000 16499.9n 0.3000 16500.0n 0.7000 16749.9n 0.7000 16750.0n 0.3000 16999.9n 0.3000 17000.0n 0.3000 17249.9n 0.3000 17250.0n 0.3000 17499.9n 0.3000 17500.0n 0.7000 17749.9n 0.7000 17750.0n 0.7000 17999.9n 0.7000 18000.0n 0.3000 18249.9n 0.3000 18250.0n 0.3000 18499.9n 0.3000 18500.0n 0.3000 18749.9n 0.3000 18750.0n 0.3000 18999.9n 0.3000 19000.0n 0.3000 19249.9n 0.3000 19250.0n 0.7000 19499.9n 0.7000 19500.0n 0.7000 19749.9n 0.7000 19750.0n 0.3000 19999.9n 0.3000 20000.0n 0.7000 20249.9n 0.7000 20250.0n 0.3000 20499.9n 0.3000 20500.0n 0.7000 20749.9n 0.7000 20750.0n 0.3000 20999.9n 0.3000 21000.0n 0.3000 21249.9n 0.3000 21250.0n 0.7000 21499.9n 0.7000 21500.0n 0.3000 21749.9n 0.3000 21750.0n 0.7000 21999.9n 0.7000 22000.0n 0.7000 22249.9n 0.7000 22250.0n 0.7000 22499.9n 0.7000 22500.0n 0.3000 22749.9n 0.3000 22750.0n 0.7000 22999.9n 0.7000 23000.0n 0.7000 23249.9n 0.7000 23250.0n 0.7000 23499.9n 0.7000 23500.0n 0.7000 23749.9n 0.7000 23750.0n 0.3000 23999.9n 0.3000 24000.0n 0.7000 24249.9n 0.7000 24250.0n 0.3000 24499.9n 0.3000 24500.0n 0.3000 24749.9n 0.3000 24750.0n 0.3000 24999.9n 0.3000 25000.0n 0.7000 25249.9n 0.7000 25250.0n 0.7000 25499.9n 0.7000 25500.0n 0.3000 25749.9n 0.3000 25750.0n 0.3000 25999.9n 0.3000 26000.0n 0.3000 26249.9n 0.3000 26250.0n 0.3000 26499.9n 0.3000 26500.0n 0.3000 26749.9n 0.3000 26750.0n 0.7000 26999.9n 0.7000 27000.0n 0.7000 27249.9n 0.7000 27250.0n 0.3000 27499.9n 0.3000 27500.0n 0.7000 27749.9n 0.7000 27750.0n 0.3000 27999.9n 0.3000 28000.0n 0.7000 28249.9n 0.7000 28250.0n 0.3000 28499.9n 0.3000 28500.0n 0.3000 28749.9n 0.3000 28750.0n 0.7000 28999.9n 0.7000 29000.0n 0.3000 29249.9n 0.3000 29250.0n 0.7000 29499.9n 0.7000 29500.0n 0.7000 29749.9n 0.7000 29750.0n 0.7000 29999.9n 0.7000 30000.0n 0.3000 30249.9n 0.3000 30250.0n 0.7000 30499.9n 0.7000 30500.0n 0.7000 30749.9n 0.7000 30750.0n 0.7000 30999.9n 0.7000 31000.0n 0.7000 31249.9n 0.7000 31250.0n 0.3000 31499.9n 0.3000 31500.0n 0.7000 31749.9n 0.7000 31750.0n 0.3000 31999.9n 0.3000 32000.0n 0.3000 32249.9n 0.3000 32250.0n 0.3000 32499.9n 0.3000 32500.0n 0.7000 32749.9n 0.7000 32750.0n 0.7000 32999.9n 0.7000 33000.0n 0.3000 33249.9n 0.3000 33250.0n 0.3000 33499.9n 0.3000 33500.0n 0.3000 33749.9n 0.3000 33750.0n 0.3000 33999.9n 0.3000 34000.0n 0.3000 34249.9n 0.3000 34250.0n 0.7000 34499.9n 0.7000 34500.0n 0.7000 34749.9n 0.7000 34750.0n 0.3000 34999.9n 0.3000 35000.0n 0.7000 35249.9n 0.7000 35250.0n 0.3000 35499.9n 0.3000 35500.0n 0.7000 35749.9n 0.7000 35750.0n 0.3000 35999.9n 0.3000 36000.0n 0.3000 36249.9n 0.3000 36250.0n 0.7000 36499.9n 0.7000 36500.0n 0.3000 36749.9n 0.3000 36750.0n 0.7000 36999.9n 0.7000 37000.0n 0.7000 37249.9n 0.7000 37250.0n 0.7000 37499.9n 0.7000 37500.0n 0.3000 37749.9n 0.3000 37750.0n 0.7000 37999.9n 0.7000 38000.0n 0.7000 38249.9n 0.7000 38250.0n 0.7000 38499.9n 0.7000 38500.0n 0.7000 38749.9n 0.7000 38750.0n 0.3000 38999.9n 0.3000 39000.0n 0.7000 39249.9n 0.7000 39250.0n 0.3000 39499.9n 0.3000 39500.0n 0.3000 39749.9n 0.3000 39750.0n 0.3000 39999.9n 0.3000 40000.0n 0.7000 40249.9n 0.7000 40250.0n 0.7000 40499.9n 0.7000 40500.0n 0.3000 40749.9n 0.3000 40750.0n 0.3000 40999.9n 0.3000 41000.0n 0.3000 41249.9n 0.3000 41250.0n 0.3000 41499.9n 0.3000 41500.0n 0.3000 41749.9n 0.3000 41750.0n 0.7000 41999.9n 0.7000 42000.0n 0.7000 42249.9n 0.7000 42250.0n 0.3000 42499.9n 0.3000 42500.0n 0.7000 42749.9n 0.7000 42750.0n 0.3000 42999.9n 0.3000 43000.0n 0.7000 43249.9n 0.7000 43250.0n 0.3000 43499.9n 0.3000 43500.0n 0.3000 43749.9n 0.3000 43750.0n 0.7000 43999.9n 0.7000 44000.0n 0.3000 44249.9n 0.3000 44250.0n 0.7000 44499.9n 0.7000 44500.0n 0.7000 44749.9n 0.7000 44750.0n 0.7000 44999.9n 0.7000 45000.0n 0.3000 45249.9n 0.3000 45250.0n 0.7000 45499.9n 0.7000 45500.0n 0.7000 45749.9n 0.7000 45750.0n 0.7000 45999.9n 0.7000 46000.0n 0.7000 46249.9n 0.7000 46250.0n 0.3000 46499.9n 0.3000 46500.0n 0.7000 46749.9n 0.7000 46750.0n 0.3000 46999.9n 0.3000 47000.0n 0.3000 47249.9n 0.3000 47250.0n 0.3000 47499.9n 0.3000 47500.0n 0.7000 47749.9n 0.7000 47750.0n 0.7000 47999.9n 0.7000 48000.0n 0.3000 48249.9n 0.3000 48250.0n 0.3000 48499.9n 0.3000 48500.0n 0.3000 48749.9n 0.3000 48750.0n 0.3000 48999.9n 0.3000 49000.0n 0.3000 49249.9n 0.3000 49250.0n 0.7000 49499.9n 0.7000 49500.0n 0.7000 49749.9n 0.7000 49750.0n 0.3000 49999.9n 0.3000 50000.0n 0.7000 50249.9n 0.7000 50250.0n 0.3000 50499.9n 0.3000 50500.0n 0.7000 50749.9n 0.7000 50750.0n 0.3000 50999.9n 0.3000 51000.0n 0.3000 51249.9n 0.3000 51250.0n 0.7000 51499.9n 0.7000 51500.0n 0.3000 51749.9n 0.3000 51750.0n 0.7000 51999.9n 0.7000 52000.0n 0.7000 52249.9n 0.7000 52250.0n 0.7000 52499.9n 0.7000 52500.0n 0.3000 52749.9n 0.3000 52750.0n 0.7000 52999.9n 0.7000 53000.0n 0.7000 53249.9n 0.7000 53250.0n 0.7000 53499.9n 0.7000 53500.0n 0.7000 53749.9n 0.7000 53750.0n 0.3000 53999.9n 0.3000 54000.0n 0.7000 54249.9n 0.7000 54250.0n 0.3000 54499.9n 0.3000 54500.0n 0.3000 54749.9n 0.3000 54750.0n 0.3000 54999.9n 0.3000 55000.0n 0.7000 55249.9n 0.7000 55250.0n 0.7000 55499.9n 0.7000 55500.0n 0.3000 55749.9n 0.3000 55750.0n 0.3000 55999.9n 0.3000 56000.0n 0.3000 56249.9n 0.3000 56250.0n 0.3000 56499.9n 0.3000 56500.0n 0.3000 56749.9n 0.3000 56750.0n 0.7000 56999.9n 0.7000 57000.0n 0.7000 57249.9n 0.7000 57250.0n 0.3000 57499.9n 0.3000 57500.0n 0.7000 57749.9n 0.7000 57750.0n 0.3000 57999.9n 0.3000 58000.0n 0.7000 58249.9n 0.7000 58250.0n 0.3000 58499.9n 0.3000 58500.0n 0.3000 58749.9n 0.3000 58750.0n 0.7000 58999.9n 0.7000 59000.0n 0.3000 59249.9n 0.3000 59250.0n 0.7000 59499.9n 0.7000 59500.0n 0.7000 59749.9n 0.7000 59750.0n 0.7000 59999.9n 0.7000 60000.0n 0.3000 60249.9n 0.3000 60250.0n 0.7000 60499.9n 0.7000 60500.0n 0.7000 60749.9n 0.7000 60750.0n 0.7000 60999.9n 0.7000 61000.0n 0.7000 61249.9n 0.7000 61250.0n 0.3000 61499.9n 0.3000 61500.0n 0.7000 61749.9n 0.7000 61750.0n 0.3000 61999.9n 0.3000 62000.0n 0.3000 62249.9n 0.3000 62250.0n 0.3000 62499.9n 0.3000 62500.0n 0.7000 62749.9n 0.7000 62750.0n 0.7000 62999.9n 0.7000 63000.0n 0.3000 63249.9n 0.3000 63250.0n 0.3000 63499.9n 0.3000 63500.0n 0.3000 63749.9n 0.3000 63750.0n 0.3000 63999.9n 0.3000 64000.0n 0.3000 64249.9n 0.3000 64250.0n 0.7000 64499.9n 0.7000 64500.0n 0.7000 64749.9n 0.7000 64750.0n 0.3000 64999.9n 0.3000 65000.0n 0.7000 65249.9n 0.7000 65250.0n 0.3000 65499.9n 0.3000 65500.0n 0.7000 65749.9n 0.7000 65750.0n 0.3000 65999.9n 0.3000 66000.0n 0.3000 66249.9n 0.3000 66250.0n 0.7000 66499.9n 0.7000 66500.0n 0.3000 66749.9n 0.3000 66750.0n 0.7000 66999.9n 0.7000 67000.0n 0.7000 67249.9n 0.7000 67250.0n 0.7000 67499.9n 0.7000 67500.0n 0.3000 67749.9n 0.3000 67750.0n 0.7000 67999.9n 0.7000 68000.0n 0.7000 68249.9n 0.7000 68250.0n 0.7000 68499.9n 0.7000 68500.0n 0.7000 68749.9n 0.7000 68750.0n 0.3000 68999.9n 0.3000 69000.0n 0.7000 69249.9n 0.7000 69250.0n 0.3000 69499.9n 0.3000 69500.0n 0.3000 69749.9n 0.3000 69750.0n 0.3000 69999.9n 0.3000 70000.0n 0.7000 70249.9n 0.7000 70250.0n 0.7000 70499.9n 0.7000 70500.0n 0.3000 70749.9n 0.3000 70750.0n 0.3000 70999.9n 0.3000 71000.0n 0.3000 71249.9n 0.3000 71250.0n 0.3000 71499.9n 0.3000 71500.0n 0.3000 71749.9n 0.3000 71750.0n 0.7000 71999.9n 0.7000 72000.0n 0.7000 72249.9n 0.7000 72250.0n 0.3000 72499.9n 0.3000 72500.0n 0.7000 72749.9n 0.7000 72750.0n 0.3000 72999.9n 0.3000 73000.0n 0.7000 73249.9n 0.7000 73250.0n 0.3000 73499.9n 0.3000 73500.0n 0.3000 73749.9n 0.3000 73750.0n 0.7000 73999.9n 0.7000 74000.0n 0.3000 74249.9n 0.3000 74250.0n 0.7000 74499.9n 0.7000 74500.0n 0.7000 74749.9n 0.7000 74750.0n 0.7000 74999.9n 0.7000 75000.0n 0.3000 75249.9n 0.3000 75250.0n 0.7000 75499.9n 0.7000 75500.0n 0.7000 75749.9n 0.7000 75750.0n 0.7000 75999.9n 0.7000 76000.0n 0.7000 76249.9n 0.7000 76250.0n 0.3000 76499.9n 0.3000 76500.0n 0.7000 76749.9n 0.7000 76750.0n 0.3000 76999.9n 0.3000 77000.0n 0.3000 77249.9n 0.3000 77250.0n 0.3000 77499.9n 0.3000 77500.0n 0.7000 77749.9n 0.7000 77750.0n 0.7000 77999.9n 0.7000 78000.0n 0.3000 78249.9n 0.3000 78250.0n 0.3000 78499.9n 0.3000 78500.0n 0.3000 78749.9n 0.3000 78750.0n 0.3000 78999.9n 0.3000 79000.0n 0.3000 79249.9n 0.3000 79250.0n 0.7000 79499.9n 0.7000 79500.0n 0.7000 79749.9n 0.7000 79750.0n 0.3000 79999.9n 0.3000 80000.0n 0.7000 80249.9n 0.7000 80250.0n 0.3000 80499.9n 0.3000 80500.0n 0.7000 80749.9n 0.7000 80750.0n 0.3000 80999.9n 0.3000 81000.0n 0.3000 81249.9n 0.3000 81250.0n 0.7000 81499.9n 0.7000 81500.0n 0.3000 81749.9n 0.3000 81750.0n 0.7000 81999.9n 0.7000 82000.0n 0.7000 82249.9n 0.7000 82250.0n 0.7000 82499.9n 0.7000 82500.0n 0.3000 82749.9n 0.3000 82750.0n 0.7000 82999.9n 0.7000 83000.0n 0.7000 83249.9n 0.7000 83250.0n 0.7000 83499.9n 0.7000 83500.0n 0.7000 83749.9n 0.7000 83750.0n 0.3000 83999.9n 0.3000 84000.0n 0.7000 84249.9n 0.7000 84250.0n 0.3000 84499.9n 0.3000 84500.0n 0.3000 84749.9n 0.3000 84750.0n 0.3000 84999.9n 0.3000 85000.0n 0.7000 85249.9n 0.7000 85250.0n 0.7000 85499.9n 0.7000 85500.0n 0.3000 85749.9n 0.3000 85750.0n 0.3000 85999.9n 0.3000 86000.0n 0.3000 86249.9n 0.3000 86250.0n 0.3000 86499.9n 0.3000 86500.0n 0.3000 86749.9n 0.3000 86750.0n 0.7000 86999.9n 0.7000 87000.0n 0.7000 87249.9n 0.7000 87250.0n 0.3000 87499.9n 0.3000 87500.0n 0.7000 87749.9n 0.7000 87750.0n 0.3000 87999.9n 0.3000 88000.0n 0.7000 88249.9n 0.7000 88250.0n 0.3000 88499.9n 0.3000 88500.0n 0.3000 88749.9n 0.3000 88750.0n 0.7000 88999.9n 0.7000 89000.0n 0.3000 89249.9n 0.3000 89250.0n 0.7000 89499.9n 0.7000 89500.0n 0.7000 89749.9n 0.7000 89750.0n 0.7000 89999.9n 0.7000 90000.0n 0.3000 90249.9n 0.3000 90250.0n 0.7000 90499.9n 0.7000 90500.0n 0.7000 90749.9n 0.7000 90750.0n 0.7000 90999.9n 0.7000 91000.0n 0.7000 91249.9n 0.7000 91250.0n 0.3000 91499.9n 0.3000 91500.0n 0.7000 91749.9n 0.7000 91750.0n 0.3000 91999.9n 0.3000 92000.0n 0.3000 92249.9n 0.3000 92250.0n 0.3000 92499.9n 0.3000 92500.0n 0.7000 92749.9n 0.7000 92750.0n 0.7000 92999.9n 0.7000 93000.0n 0.3000 93249.9n 0.3000 93250.0n 0.3000 93499.9n 0.3000 93500.0n 0.3000 93749.9n 0.3000 93750.0n 0.3000 93999.9n 0.3000 94000.0n 0.3000 94249.9n 0.3000 94250.0n 0.7000 94499.9n 0.7000 94500.0n 0.7000 94749.9n 0.7000 94750.0n 0.3000 94999.9n 0.3000 95000.0n 0.7000 95249.9n 0.7000 95250.0n 0.3000 95499.9n 0.3000 95500.0n 0.7000 95749.9n 0.7000 95750.0n 0.3000 95999.9n 0.3000 96000.0n 0.3000 96249.9n 0.3000 96250.0n 0.7000 96499.9n 0.7000 96500.0n 0.3000 96749.9n 0.3000 96750.0n 0.7000 96999.9n 0.7000 97000.0n 0.7000 97249.9n 0.7000 97250.0n 0.7000 97499.9n 0.7000 97500.0n 0.3000 97749.9n 0.3000 97750.0n 0.7000 97999.9n 0.7000 98000.0n 0.7000 98249.9n 0.7000 98250.0n 0.7000 98499.9n 0.7000 98500.0n 0.7000 98749.9n 0.7000 98750.0n 0.3000 98999.9n 0.3000 99000.0n 0.7000 99249.9n 0.7000 99250.0n 0.3000 99499.9n 0.3000 99500.0n 0.3000 99749.9n 0.3000 99750.0n 0.3000 99999.9n 0.3000 100000.0n 0.7000 100249.9n 0.7000 100250.0n 0.7000 100499.9n 0.7000 100500.0n 0.3000 100749.9n 0.3000 100750.0n 0.3000 100999.9n 0.3000 101000.0n 0.3000 101249.9n 0.3000 101250.0n 0.3000 101499.9n 0.3000 101500.0n 0.3000 101749.9n 0.3000 101750.0n 0.7000 101999.9n 0.7000 102000.0n 0.7000 102249.9n 0.7000 102250.0n 0.3000 102499.9n 0.3000 102500.0n 0.7000 102749.9n 0.7000 102750.0n 0.3000 102999.9n 0.3000 103000.0n 0.7000 103249.9n 0.7000 103250.0n 0.3000 103499.9n 0.3000 103500.0n 0.3000 103749.9n 0.3000 103750.0n 0.7000 103999.9n 0.7000 104000.0n 0.3000 104249.9n 0.3000 104250.0n 0.7000 104499.9n 0.7000 104500.0n 0.7000 104749.9n 0.7000 104750.0n 0.7000 104999.9n 0.7000 105000.0n 0.3000 105249.9n 0.3000 105250.0n 0.7000 105499.9n 0.7000 105500.0n 0.7000 105749.9n 0.7000 105750.0n 0.7000 105999.9n 0.7000 106000.0n 0.7000 106249.9n 0.7000 106250.0n 0.3000 106499.9n 0.3000 106500.0n 0.7000 106749.9n 0.7000 106750.0n 0.3000 106999.9n 0.3000 107000.0n 0.3000 107249.9n 0.3000 107250.0n 0.3000 107499.9n 0.3000 107500.0n 0.7000 107749.9n 0.7000 107750.0n 0.7000 107999.9n 0.7000 108000.0n 0.3000 108249.9n 0.3000 108250.0n 0.3000 108499.9n 0.3000 108500.0n 0.3000 108749.9n 0.3000 108750.0n 0.3000 108999.9n 0.3000 109000.0n 0.3000 109249.9n 0.3000 109250.0n 0.7000 109499.9n 0.7000 109500.0n 0.7000 109749.9n 0.7000 109750.0n 0.3000 109999.9n 0.3000 110000.0n 0.7000 110249.9n 0.7000 110250.0n 0.3000 110499.9n 0.3000 110500.0n 0.7000 110749.9n 0.7000 110750.0n 0.3000 110999.9n 0.3000 111000.0n 0.3000 111249.9n 0.3000 111250.0n 0.7000 111499.9n 0.7000 111500.0n 0.3000 111749.9n 0.3000 111750.0n 0.7000 111999.9n 0.7000 112000.0n 0.7000 112249.9n 0.7000 112250.0n 0.7000 112499.9n 0.7000 112500.0n 0.3000 112749.9n 0.3000 112750.0n 0.7000 112999.9n 0.7000 113000.0n 0.7000 113249.9n 0.7000 113250.0n 0.7000 113499.9n 0.7000 113500.0n 0.7000 113749.9n 0.7000 113750.0n 0.3000 113999.9n 0.3000 114000.0n 0.7000 114249.9n 0.7000 114250.0n 0.3000 114499.9n 0.3000 114500.0n 0.3000 114749.9n 0.3000 114750.0n 0.3000 114999.9n 0.3000 115000.0n 0.7000 115249.9n 0.7000 115250.0n 0.7000 115499.9n 0.7000 115500.0n 0.3000 115749.9n 0.3000 115750.0n 0.3000 115999.9n 0.3000 116000.0n 0.3000 116249.9n 0.3000 116250.0n 0.3000 116499.9n 0.3000 116500.0n 0.3000 116749.9n 0.3000 116750.0n 0.7000 116999.9n 0.7000 117000.0n 0.7000 117249.9n 0.7000 117250.0n 0.3000 117499.9n 0.3000 117500.0n 0.7000 117749.9n 0.7000 117750.0n 0.3000 117999.9n 0.3000 118000.0n 0.7000 118249.9n 0.7000 118250.0n 0.3000 118499.9n 0.3000 118500.0n 0.3000 118749.9n 0.3000 118750.0n 0.7000 118999.9n 0.7000 119000.0n 0.3000 119249.9n 0.3000 119250.0n 0.7000 119499.9n 0.7000 119500.0n 0.7000 119749.9n 0.7000 119750.0n 0.7000 119999.9n 0.7000 120000.0n 0.3000 120249.9n 0.3000 120250.0n 0.7000 120499.9n 0.7000 120500.0n 0.7000 120749.9n 0.7000 120750.0n 0.7000 120999.9n 0.7000 121000.0n 0.7000 121249.9n 0.7000 121250.0n 0.3000 121499.9n 0.3000 121500.0n 0.7000 121749.9n 0.7000 121750.0n 0.3000 121999.9n 0.3000 122000.0n 0.3000 122249.9n 0.3000 122250.0n 0.3000 122499.9n 0.3000 122500.0n 0.7000 122749.9n 0.7000 122750.0n 0.7000 122999.9n 0.7000 123000.0n 0.3000 123249.9n 0.3000 123250.0n 0.3000 123499.9n 0.3000 123500.0n 0.3000 123749.9n 0.3000 123750.0n 0.3000 123999.9n 0.3000 124000.0n 0.3000 124249.9n 0.3000 124250.0n 0.7000 124499.9n 0.7000 124500.0n 0.7000 124749.9n 0.7000 124750.0n 0.3000 124999.9n 0.3000 125000.0n 0.7000 125249.9n 0.7000 125250.0n 0.3000 125499.9n 0.3000 125500.0n 0.7000 125749.9n 0.7000 125750.0n 0.3000 125999.9n 0.3000 126000.0n 0.3000 126249.9n 0.3000 126250.0n 0.7000 126499.9n 0.7000 126500.0n 0.3000 126749.9n 0.3000 126750.0n 0.7000 126999.9n 0.7000 127000.0n 0.7000 127249.9n 0.7000 127250.0n 0.7000 127499.9n 0.7000 127500.0n 0.3000 127749.9n 0.3000 127750.0n 0.7000 127999.9n 0.7000 128000.0n 0.7000 128249.9n 0.7000 128250.0n 0.7000 128499.9n 0.7000 128500.0n 0.7000 128749.9n 0.7000 128750.0n 0.3000 128999.9n 0.3000 129000.0n 0.7000 129249.9n 0.7000 129250.0n 0.3000 129499.9n 0.3000 129500.0n 0.3000 129749.9n 0.3000 129750.0n 0.3000 129999.9n 0.3000 130000.0n 0.7000 130249.9n 0.7000 130250.0n 0.7000 130499.9n 0.7000 130500.0n 0.3000 130749.9n 0.3000 130750.0n 0.3000 130999.9n 0.3000 131000.0n 0.3000 131249.9n 0.3000 131250.0n 0.3000 131499.9n 0.3000 131500.0n 0.3000 131749.9n 0.3000 131750.0n 0.7000 131999.9n 0.7000 132000.0n 0.7000 132249.9n 0.7000 132250.0n 0.3000 132499.9n 0.3000 132500.0n 0.7000 132749.9n 0.7000 132750.0n 0.3000 132999.9n 0.3000 133000.0n 0.7000 133249.9n 0.7000 133250.0n 0.3000 133499.9n 0.3000 133500.0n 0.3000 133749.9n 0.3000 133750.0n 0.7000 133999.9n 0.7000 134000.0n 0.3000 134249.9n 0.3000 134250.0n 0.7000 134499.9n 0.7000 134500.0n 0.7000 134749.9n 0.7000 134750.0n 0.7000 134999.9n 0.7000 135000.0n 0.3000 135249.9n 0.3000 135250.0n 0.7000 135499.9n 0.7000 135500.0n 0.7000 135749.9n 0.7000 135750.0n 0.7000 135999.9n 0.7000 136000.0n 0.7000 136249.9n 0.7000 136250.0n 0.3000 136499.9n 0.3000 136500.0n 0.7000 136749.9n 0.7000 136750.0n 0.3000 136999.9n 0.3000 137000.0n 0.3000 137249.9n 0.3000 137250.0n 0.3000 137499.9n 0.3000 137500.0n 0.7000 137749.9n 0.7000 137750.0n 0.7000 137999.9n 0.7000 138000.0n 0.3000 138249.9n 0.3000 138250.0n 0.3000 138499.9n 0.3000 138500.0n 0.3000 138749.9n 0.3000 138750.0n 0.3000 138999.9n 0.3000 139000.0n 0.3000 139249.9n 0.3000 139250.0n 0.7000 139499.9n 0.7000 139500.0n 0.7000 139749.9n 0.7000 139750.0n 0.3000 139999.9n 0.3000 140000.0n 0.7000 140249.9n 0.7000 140250.0n 0.3000 140499.9n 0.3000 140500.0n 0.7000 140749.9n 0.7000 140750.0n 0.3000 140999.9n 0.3000 141000.0n 0.3000 141249.9n 0.3000 141250.0n 0.7000 141499.9n 0.7000 141500.0n 0.3000 141749.9n 0.3000 141750.0n 0.7000 141999.9n 0.7000 142000.0n 0.7000 142249.9n 0.7000 142250.0n 0.7000 142499.9n 0.7000 142500.0n 0.3000 142749.9n 0.3000 142750.0n 0.7000 142999.9n 0.7000 143000.0n 0.7000 143249.9n 0.7000 143250.0n 0.7000 143499.9n 0.7000 143500.0n 0.7000 143749.9n 0.7000 143750.0n 0.3000 143999.9n 0.3000 144000.0n 0.7000 144249.9n 0.7000 144250.0n 0.3000 144499.9n 0.3000 144500.0n 0.3000 144749.9n 0.3000 144750.0n 0.3000 144999.9n 0.3000 145000.0n 0.7000 145249.9n 0.7000 145250.0n 0.7000 145499.9n 0.7000 145500.0n 0.3000 145749.9n 0.3000 145750.0n 0.3000 145999.9n 0.3000 146000.0n 0.3000 146249.9n 0.3000 146250.0n 0.3000 146499.9n 0.3000 146500.0n 0.3000 146749.9n 0.3000 146750.0n 0.7000 146999.9n 0.7000 147000.0n 0.7000 147249.9n 0.7000 147250.0n 0.3000 147499.9n 0.3000 147500.0n 0.7000 147749.9n 0.7000 147750.0n 0.3000 147999.9n 0.3000 148000.0n 0.7000 148249.9n 0.7000 148250.0n 0.3000 148499.9n 0.3000 148500.0n 0.3000 148749.9n 0.3000 148750.0n 0.7000 148999.9n 0.7000 149000.0n 0.3000 149249.9n 0.3000 149250.0n 0.7000 149499.9n 0.7000 149500.0n 0.7000 149749.9n 0.7000 149750.0n 0.7000 149999.9n 0.7000 150000.0n 0.3000 150249.9n 0.3000 150250.0n 0.7000 150499.9n 0.7000 150500.0n 0.7000 150749.9n 0.7000 150750.0n 0.7000 150999.9n 0.7000 151000.0n 0.7000 151249.9n 0.7000 151250.0n 0.3000 151499.9n 0.3000 151500.0n 0.7000 151749.9n 0.7000 151750.0n 0.3000 151999.9n 0.3000 152000.0n 0.3000 152249.9n 0.3000 152250.0n 0.3000 152499.9n 0.3000 152500.0n 0.7000 152749.9n 0.7000 152750.0n 0.7000 152999.9n 0.7000 153000.0n 0.3000 153249.9n 0.3000 153250.0n 0.3000 153499.9n 0.3000 153500.0n 0.3000 153749.9n 0.3000 153750.0n 0.3000 153999.9n 0.3000 154000.0n 0.3000 154249.9n 0.3000 154250.0n 0.7000 154499.9n 0.7000 154500.0n 0.7000 154749.9n 0.7000 154750.0n 0.3000 154999.9n 0.3000 155000.0n 0.7000 155249.9n 0.7000 155250.0n 0.3000 155499.9n 0.3000 155500.0n 0.7000 155749.9n 0.7000 155750.0n 0.3000 155999.9n 0.3000 156000.0n 0.3000 156249.9n 0.3000 156250.0n 0.7000 156499.9n 0.7000 156500.0n 0.3000 156749.9n 0.3000 156750.0n 0.7000 156999.9n 0.7000 157000.0n 0.7000 157249.9n 0.7000 157250.0n 0.7000 157499.9n 0.7000 157500.0n 0.3000 157749.9n 0.3000 157750.0n 0.7000 157999.9n 0.7000 158000.0n 0.7000 158249.9n 0.7000 158250.0n 0.7000 158499.9n 0.7000 158500.0n 0.7000 158749.9n 0.7000 158750.0n 0.3000 158999.9n 0.3000 159000.0n 0.7000 159249.9n 0.7000 159250.0n 0.3000 159499.9n 0.3000 159500.0n 0.3000 159749.9n 0.3000 159750.0n 0.3000 159999.9n 0.3000 160000.0n 0.7000 160249.9n 0.7000 160250.0n 0.7000 160499.9n 0.7000 160500.0n 0.3000 160749.9n 0.3000 160750.0n 0.3000 160999.9n 0.3000 161000.0n 0.3000 161249.9n 0.3000 161250.0n 0.3000 161499.9n 0.3000 161500.0n 0.3000 161749.9n 0.3000 161750.0n 0.7000 161999.9n 0.7000 162000.0n 0.7000 162249.9n 0.7000 162250.0n 0.3000 162499.9n 0.3000 162500.0n 0.7000 162749.9n 0.7000 162750.0n 0.3000 162999.9n 0.3000 163000.0n 0.7000 163249.9n 0.7000 163250.0n 0.3000 163499.9n 0.3000 163500.0n 0.3000 163749.9n 0.3000 163750.0n 0.7000 163999.9n 0.7000 164000.0n 0.3000 164249.9n 0.3000 164250.0n 0.7000 164499.9n 0.7000 164500.0n 0.7000 164749.9n 0.7000 164750.0n 0.7000 164999.9n 0.7000 165000.0n 0.3000 165249.9n 0.3000 165250.0n 0.7000 165499.9n 0.7000 165500.0n 0.7000 165749.9n 0.7000 165750.0n 0.7000 165999.9n 0.7000 166000.0n 0.7000 166249.9n 0.7000 166250.0n 0.3000 166499.9n 0.3000 166500.0n 0.7000 166749.9n 0.7000 166750.0n 0.3000 166999.9n 0.3000 167000.0n 0.3000 167249.9n 0.3000 167250.0n 0.3000 167499.9n 0.3000 167500.0n 0.7000 167749.9n 0.7000 167750.0n 0.7000 167999.9n 0.7000 168000.0n 0.3000 168249.9n 0.3000 168250.0n 0.3000 168499.9n 0.3000 168500.0n 0.3000 168749.9n 0.3000 168750.0n 0.3000 168999.9n 0.3000 169000.0n 0.3000 169249.9n 0.3000 169250.0n 0.7000 169499.9n 0.7000 169500.0n 0.7000 169749.9n 0.7000 169750.0n 0.3000 169999.9n 0.3000 170000.0n 0.7000 170249.9n 0.7000 170250.0n 0.3000 170499.9n 0.3000 170500.0n 0.7000 170749.9n 0.7000 170750.0n 0.3000 170999.9n 0.3000 171000.0n 0.3000 171249.9n 0.3000 171250.0n 0.7000 171499.9n 0.7000 171500.0n 0.3000 171749.9n 0.3000 171750.0n 0.7000 171999.9n 0.7000 172000.0n 0.7000 172249.9n 0.7000 172250.0n 0.7000 172499.9n 0.7000 172500.0n 0.3000 172749.9n 0.3000 172750.0n 0.7000 172999.9n 0.7000 173000.0n 0.7000 173249.9n 0.7000 173250.0n 0.7000 173499.9n 0.7000 173500.0n 0.7000 173749.9n 0.7000 173750.0n 0.3000 173999.9n 0.3000 174000.0n 0.7000 174249.9n 0.7000 174250.0n 0.3000 174499.9n 0.3000 174500.0n 0.3000 174749.9n 0.3000 174750.0n 0.3000 174999.9n 0.3000 175000.0n 0.7000 175249.9n 0.7000 175250.0n 0.7000 175499.9n 0.7000 175500.0n 0.3000 175749.9n 0.3000 175750.0n 0.3000 175999.9n 0.3000 176000.0n 0.3000 176249.9n 0.3000 176250.0n 0.3000 176499.9n 0.3000 176500.0n 0.3000 176749.9n 0.3000 176750.0n 0.7000 176999.9n 0.7000 177000.0n 0.7000 177249.9n 0.7000 177250.0n 0.3000 177499.9n 0.3000 177500.0n 0.7000 177749.9n 0.7000 177750.0n 0.3000 177999.9n 0.3000 178000.0n 0.7000 178249.9n 0.7000 178250.0n 0.3000 178499.9n 0.3000 178500.0n 0.3000 178749.9n 0.3000 178750.0n 0.7000 178999.9n 0.7000 179000.0n 0.3000 179249.9n 0.3000 179250.0n 0.7000 179499.9n 0.7000 179500.0n 0.7000 179749.9n 0.7000 179750.0n 0.7000 179999.9n 0.7000 180000.0n 0.3000 180249.9n 0.3000 180250.0n 0.7000 180499.9n 0.7000 180500.0n 0.7000 180749.9n 0.7000 180750.0n 0.7000 180999.9n 0.7000 181000.0n 0.7000 181249.9n 0.7000 181250.0n 0.3000 181499.9n 0.3000 181500.0n 0.7000 181749.9n 0.7000 181750.0n 0.3000 181999.9n 0.3000 182000.0n 0.3000 182249.9n 0.3000 182250.0n 0.3000 182499.9n 0.3000 182500.0n 0.7000 182749.9n 0.7000 182750.0n 0.7000 182999.9n 0.7000 183000.0n 0.3000 183249.9n 0.3000 183250.0n 0.3000 183499.9n 0.3000 183500.0n 0.3000 183749.9n 0.3000 183750.0n 0.3000 183999.9n 0.3000 184000.0n 0.3000 184249.9n 0.3000 184250.0n 0.7000 184499.9n 0.7000 184500.0n 0.7000 184749.9n 0.7000 184750.0n 0.3000 184999.9n 0.3000 185000.0n 0.7000 185249.9n 0.7000 185250.0n 0.3000 185499.9n 0.3000 185500.0n 0.7000 185749.9n 0.7000 185750.0n 0.3000 185999.9n 0.3000 186000.0n 0.3000 186249.9n 0.3000 186250.0n 0.7000 186499.9n 0.7000 186500.0n 0.3000 186749.9n 0.3000 186750.0n 0.7000 186999.9n 0.7000 187000.0n 0.7000 187249.9n 0.7000 187250.0n 0.7000 187499.9n 0.7000 187500.0n 0.3000 187749.9n 0.3000 187750.0n 0.7000 187999.9n 0.7000 188000.0n 0.7000 188249.9n 0.7000 188250.0n 0.7000 188499.9n 0.7000 188500.0n 0.7000 188749.9n 0.7000 188750.0n 0.3000 188999.9n 0.3000 189000.0n 0.7000 189249.9n 0.7000 189250.0n 0.3000 189499.9n 0.3000 189500.0n 0.3000 189749.9n 0.3000 189750.0n 0.3000 189999.9n 0.3000 190000.0n 0.7000 190249.9n 0.7000 190250.0n 0.7000 190499.9n 0.7000 190500.0n 0.3000 190749.9n 0.3000 190750.0n 0.3000 190999.9n 0.3000 191000.0n 0.3000 191249.9n 0.3000 191250.0n 0.3000 191499.9n 0.3000 191500.0n 0.3000 191749.9n 0.3000 191750.0n 0.7000 191999.9n 0.7000 192000.0n 0.7000 192249.9n 0.7000 192250.0n 0.3000 192499.9n 0.3000 192500.0n 0.7000 192749.9n 0.7000 192750.0n 0.3000 192999.9n 0.3000 193000.0n 0.7000 193249.9n 0.7000 193250.0n 0.3000 193499.9n 0.3000 193500.0n 0.3000 193749.9n 0.3000 193750.0n 0.7000 193999.9n 0.7000 194000.0n 0.3000 194249.9n 0.3000 194250.0n 0.7000 194499.9n 0.7000 194500.0n 0.7000 194749.9n 0.7000 194750.0n 0.7000 194999.9n 0.7000 195000.0n 0.3000 195249.9n 0.3000 195250.0n 0.7000 195499.9n 0.7000 195500.0n 0.7000 195749.9n 0.7000 195750.0n 0.7000 195999.9n 0.7000 196000.0n 0.7000 196249.9n 0.7000 196250.0n 0.3000 196499.9n 0.3000 196500.0n 0.7000 196749.9n 0.7000 196750.0n 0.3000 196999.9n 0.3000 197000.0n 0.3000 197249.9n 0.3000 197250.0n 0.3000 197499.9n 0.3000 197500.0n 0.7000 197749.9n 0.7000 197750.0n 0.7000 197999.9n 0.7000 198000.0n 0.3000 198249.9n 0.3000 198250.0n 0.3000 198499.9n 0.3000 198500.0n 0.3000 198749.9n 0.3000 198750.0n 0.3000 198999.9n 0.3000 199000.0n 0.3000 199249.9n 0.3000 199250.0n 0.7000 199499.9n 0.7000 199500.0n 0.7000 199749.9n 0.7000 199750.0n 0.3000 199999.9n 0.3000 200000.0n 0.7000 200249.9n 0.7000 200250.0n 0.3000 200499.9n 0.3000 200500.0n 0.7000 200749.9n 0.7000 200750.0n 0.3000 200999.9n 0.3000 201000.0n 0.3000 201249.9n 0.3000 201250.0n 0.7000 201499.9n 0.7000 201500.0n 0.3000 201749.9n 0.3000 201750.0n 0.7000 201999.9n 0.7000 202000.0n 0.7000 202249.9n 0.7000 202250.0n 0.7000 202499.9n 0.7000 202500.0n 0.3000 202749.9n 0.3000 202750.0n 0.7000 202999.9n 0.7000 203000.0n 0.7000 203249.9n 0.7000 203250.0n 0.7000 203499.9n 0.7000 203500.0n 0.7000 203749.9n 0.7000 203750.0n 0.3000 203999.9n 0.3000 204000.0n 0.7000 204249.9n 0.7000 204250.0n 0.3000 204499.9n 0.3000 204500.0n 0.3000 204749.9n 0.3000 204750.0n 0.3000 204999.9n 0.3000 205000.0n 0.7000 205249.9n 0.7000 205250.0n 0.7000 205499.9n 0.7000 205500.0n 0.3000 205749.9n 0.3000 205750.0n 0.3000 205999.9n 0.3000 206000.0n 0.3000 206249.9n 0.3000 206250.0n 0.3000 206499.9n 0.3000 206500.0n 0.3000 206749.9n 0.3000 206750.0n 0.7000 206999.9n 0.7000 207000.0n 0.7000 207249.9n 0.7000 207250.0n 0.3000 207499.9n 0.3000 207500.0n 0.7000 207749.9n 0.7000 207750.0n 0.3000 207999.9n 0.3000 208000.0n 0.7000 208249.9n 0.7000 208250.0n 0.3000 208499.9n 0.3000 208500.0n 0.3000 208749.9n 0.3000 208750.0n 0.7000 208999.9n 0.7000 209000.0n 0.3000 209249.9n 0.3000 209250.0n 0.7000 209499.9n 0.7000 209500.0n 0.7000 209749.9n 0.7000 209750.0n 0.7000 209999.9n 0.7000 210000.0n 0.3000 210249.9n 0.3000 210250.0n 0.7000 210499.9n 0.7000 210500.0n 0.7000 210749.9n 0.7000 210750.0n 0.7000 210999.9n 0.7000 211000.0n 0.7000 211249.9n 0.7000 211250.0n 0.3000 211499.9n 0.3000 211500.0n 0.7000 211749.9n 0.7000 211750.0n 0.3000 211999.9n 0.3000 212000.0n 0.3000 212249.9n 0.3000 212250.0n 0.3000 212499.9n 0.3000 212500.0n 0.7000 212749.9n 0.7000 212750.0n 0.7000 212999.9n 0.7000 213000.0n 0.3000 213249.9n 0.3000 213250.0n 0.3000 213499.9n 0.3000 213500.0n 0.3000 213749.9n 0.3000 213750.0n 0.3000 213999.9n 0.3000 214000.0n 0.3000 214249.9n 0.3000 214250.0n 0.7000 214499.9n 0.7000 214500.0n 0.7000 214749.9n 0.7000 214750.0n 0.3000 214999.9n 0.3000 215000.0n 0.7000 215249.9n 0.7000 215250.0n 0.3000 215499.9n 0.3000 215500.0n 0.7000 215749.9n 0.7000 215750.0n 0.3000 215999.9n 0.3000 216000.0n 0.3000 216249.9n 0.3000 216250.0n 0.7000 216499.9n 0.7000 216500.0n 0.3000 216749.9n 0.3000 216750.0n 0.7000 216999.9n 0.7000 217000.0n 0.7000 217249.9n 0.7000 217250.0n 0.7000 217499.9n 0.7000 217500.0n 0.3000 217749.9n 0.3000 217750.0n 0.7000 217999.9n 0.7000 218000.0n 0.7000 218249.9n 0.7000 218250.0n 0.7000 218499.9n 0.7000 218500.0n 0.7000 218749.9n 0.7000 218750.0n 0.3000 218999.9n 0.3000 219000.0n 0.7000 219249.9n 0.7000 219250.0n 0.3000 219499.9n 0.3000 219500.0n 0.3000 219749.9n 0.3000 219750.0n 0.3000 219999.9n 0.3000 220000.0n 0.7000 220249.9n 0.7000 220250.0n 0.7000 220499.9n 0.7000 220500.0n 0.3000 220749.9n 0.3000 220750.0n 0.3000 220999.9n 0.3000 221000.0n 0.3000 221249.9n 0.3000 221250.0n 0.3000 221499.9n 0.3000 221500.0n 0.3000 221749.9n 0.3000 221750.0n 0.7000 221999.9n 0.7000 222000.0n 0.7000 222249.9n 0.7000 222250.0n 0.3000 222499.9n 0.3000 222500.0n 0.7000 222749.9n 0.7000 222750.0n 0.3000 222999.9n 0.3000 223000.0n 0.7000 223249.9n 0.7000 223250.0n 0.3000 223499.9n 0.3000 223500.0n 0.3000 223749.9n 0.3000 223750.0n 0.7000 223999.9n 0.7000 224000.0n 0.3000 224249.9n 0.3000 224250.0n 0.7000 224499.9n 0.7000 224500.0n 0.7000 224749.9n 0.7000 224750.0n 0.7000 224999.9n 0.7000 225000.0n 0.3000 225249.9n 0.3000 225250.0n 0.7000 225499.9n 0.7000 225500.0n 0.7000 225749.9n 0.7000 225750.0n 0.7000 225999.9n 0.7000 226000.0n 0.7000 226249.9n 0.7000 226250.0n 0.3000 226499.9n 0.3000 226500.0n 0.7000 226749.9n 0.7000 226750.0n 0.3000 226999.9n 0.3000 227000.0n 0.3000 227249.9n 0.3000 227250.0n 0.3000 227499.9n 0.3000 227500.0n 0.7000 227749.9n 0.7000 227750.0n 0.7000 227999.9n 0.7000 228000.0n 0.3000 228249.9n 0.3000 228250.0n 0.3000 228499.9n 0.3000 228500.0n 0.3000 228749.9n 0.3000 228750.0n 0.3000 228999.9n 0.3000 229000.0n 0.3000 229249.9n 0.3000 229250.0n 0.7000 229499.9n 0.7000 229500.0n 0.7000 229749.9n 0.7000 229750.0n 0.3000 229999.9n 0.3000 230000.0n 0.7000 230249.9n 0.7000 230250.0n 0.3000 230499.9n 0.3000 230500.0n 0.7000 230749.9n 0.7000 230750.0n 0.3000 230999.9n 0.3000 231000.0n 0.3000 231249.9n 0.3000 231250.0n 0.7000 231499.9n 0.7000 231500.0n 0.3000 231749.9n 0.3000 231750.0n 0.7000 231999.9n 0.7000 232000.0n 0.7000 232249.9n 0.7000 232250.0n 0.7000 232499.9n 0.7000 232500.0n 0.3000 232749.9n 0.3000 232750.0n 0.7000 232999.9n 0.7000 233000.0n 0.7000 233249.9n 0.7000 233250.0n 0.7000 233499.9n 0.7000 233500.0n 0.7000 233749.9n 0.7000 233750.0n 0.3000 233999.9n 0.3000 234000.0n 0.7000 234249.9n 0.7000 234250.0n 0.3000 234499.9n 0.3000 234500.0n 0.3000 234749.9n 0.3000 234750.0n 0.3000 234999.9n 0.3000 235000.0n 0.7000 235249.9n 0.7000 235250.0n 0.7000 235499.9n 0.7000 235500.0n 0.3000 235749.9n 0.3000 235750.0n 0.3000 235999.9n 0.3000 236000.0n 0.3000 236249.9n 0.3000 236250.0n 0.3000 236499.9n 0.3000 236500.0n 0.3000 236749.9n 0.3000 236750.0n 0.7000 236999.9n 0.7000 237000.0n 0.7000 237249.9n 0.7000 237250.0n 0.3000 237499.9n 0.3000 237500.0n 0.7000 237749.9n 0.7000 237750.0n 0.3000 237999.9n 0.3000 238000.0n 0.7000 238249.9n 0.7000 238250.0n 0.3000 238499.9n 0.3000 238500.0n 0.3000 238749.9n 0.3000 238750.0n 0.7000 238999.9n 0.7000 239000.0n 0.3000 239249.9n 0.3000 239250.0n 0.7000 239499.9n 0.7000 239500.0n 0.7000 239749.9n 0.7000 239750.0n 0.7000 239999.9n 0.7000 240000.0n 0.3000 240249.9n 0.3000 240250.0n 0.7000 240499.9n 0.7000 240500.0n 0.7000 240749.9n 0.7000 240750.0n 0.7000 240999.9n 0.7000 241000.0n 0.7000 241249.9n 0.7000 241250.0n 0.3000 241499.9n 0.3000 241500.0n 0.7000 241749.9n 0.7000 241750.0n 0.3000 241999.9n 0.3000 242000.0n 0.3000 242249.9n 0.3000 242250.0n 0.3000 242499.9n 0.3000 242500.0n 0.7000 242749.9n 0.7000 242750.0n 0.7000 242999.9n 0.7000 243000.0n 0.3000 243249.9n 0.3000 243250.0n 0.3000 243499.9n 0.3000 243500.0n 0.3000 243749.9n 0.3000 243750.0n 0.3000 243999.9n 0.3000 244000.0n 0.3000 244249.9n 0.3000 244250.0n 0.7000 244499.9n 0.7000 244500.0n 0.7000 244749.9n 0.7000 244750.0n 0.3000 244999.9n 0.3000 245000.0n 0.7000 245249.9n 0.7000 245250.0n 0.3000 245499.9n 0.3000 245500.0n 0.7000 245749.9n 0.7000 245750.0n 0.3000 245999.9n 0.3000 246000.0n 0.3000 246249.9n 0.3000 246250.0n 0.7000 246499.9n 0.7000 246500.0n 0.3000 246749.9n 0.3000 246750.0n 0.7000 246999.9n 0.7000 247000.0n 0.7000 247249.9n 0.7000 247250.0n 0.7000 247499.9n 0.7000 247500.0n 0.3000 247749.9n 0.3000 247750.0n 0.7000 247999.9n 0.7000 248000.0n 0.7000 248249.9n 0.7000 248250.0n 0.7000 248499.9n 0.7000 248500.0n 0.7000 248749.9n 0.7000 248750.0n 0.3000 248999.9n 0.3000 249000.0n 0.7000 249249.9n 0.7000 249250.0n 0.3000 249499.9n 0.3000 249500.0n 0.3000 249749.9n 0.3000 249750.0n 0.3000 249999.9n 0.3000 250000.0n 0.7000 250249.9n 0.7000 250250.0n 0.7000 250499.9n 0.7000 250500.0n 0.3000 250749.9n 0.3000 250750.0n 0.3000 250999.9n 0.3000 251000.0n 0.3000 251249.9n 0.3000 251250.0n 0.3000 251499.9n 0.3000 251500.0n 0.3000 251749.9n 0.3000 251750.0n 0.7000 251999.9n 0.7000 252000.0n 0.7000 252249.9n 0.7000 252250.0n 0.3000 252499.9n 0.3000 252500.0n 0.7000 252749.9n 0.7000 252750.0n 0.3000 252999.9n 0.3000 253000.0n 0.7000 253249.9n 0.7000 253250.0n 0.3000 253499.9n 0.3000 253500.0n 0.3000 253749.9n 0.3000 253750.0n 0.7000 253999.9n 0.7000 254000.0n 0.3000 254249.9n 0.3000 254250.0n 0.7000 254499.9n 0.7000 254500.0n 0.7000 254749.9n 0.7000 254750.0n 0.7000 254999.9n 0.7000 255000.0n 0.3000 255249.9n 0.3000 255250.0n 0.7000 255499.9n 0.7000 255500.0n 0.7000 255749.9n 0.7000 255750.0n 0.7000 255999.9n 0.7000 256000.0n 0.7000 256249.9n 0.7000 256250.0n 0.3000 256499.9n 0.3000 256500.0n 0.7000 256749.9n 0.7000 256750.0n 0.3000 256999.9n 0.3000 257000.0n 0.3000 257249.9n 0.3000 257250.0n 0.3000 257499.9n 0.3000 257500.0n 0.7000 257749.9n 0.7000 257750.0n 0.7000 257999.9n 0.7000 258000.0n 0.3000 258249.9n 0.3000 258250.0n 0.3000 258499.9n 0.3000 258500.0n 0.3000 258749.9n 0.3000 258750.0n 0.3000 258999.9n 0.3000 259000.0n 0.3000 259249.9n 0.3000 259250.0n 0.7000 259499.9n 0.7000 259500.0n 0.7000 259749.9n 0.7000 259750.0n 0.3000 259999.9n 0.3000 260000.0n 0.7000 260249.9n 0.7000 260250.0n 0.3000 260499.9n 0.3000 260500.0n 0.7000 260749.9n 0.7000 260750.0n 0.3000 260999.9n 0.3000 261000.0n 0.3000 261249.9n 0.3000 261250.0n 0.7000 261499.9n 0.7000 261500.0n 0.3000 261749.9n 0.3000 261750.0n 0.7000 261999.9n 0.7000 262000.0n 0.7000 262249.9n 0.7000 262250.0n 0.7000 262499.9n 0.7000 262500.0n 0.3000 262749.9n 0.3000 262750.0n 0.7000 262999.9n 0.7000 263000.0n 0.7000 263249.9n 0.7000 263250.0n 0.7000 263499.9n 0.7000 263500.0n 0.7000 263749.9n 0.7000 263750.0n 0.3000 263999.9n 0.3000 264000.0n 0.7000 264249.9n 0.7000 264250.0n 0.3000 264499.9n 0.3000 264500.0n 0.3000 264749.9n 0.3000 264750.0n 0.3000 264999.9n 0.3000 265000.0n 0.7000 265249.9n 0.7000 265250.0n 0.7000 265499.9n 0.7000 265500.0n 0.3000 265749.9n 0.3000 265750.0n 0.3000 265999.9n 0.3000 266000.0n 0.3000 266249.9n 0.3000 266250.0n 0.3000 266499.9n 0.3000 266500.0n 0.3000 266749.9n 0.3000 266750.0n 0.7000 266999.9n 0.7000 267000.0n 0.7000 267249.9n 0.7000 267250.0n 0.3000 267499.9n 0.3000 267500.0n 0.7000 267749.9n 0.7000 267750.0n 0.3000 267999.9n 0.3000 268000.0n 0.7000 268249.9n 0.7000 268250.0n 0.3000 268499.9n 0.3000 268500.0n 0.3000 268749.9n 0.3000 268750.0n 0.7000 268999.9n 0.7000 269000.0n 0.3000 269249.9n 0.3000 269250.0n 0.7000 269499.9n 0.7000 269500.0n 0.7000 269749.9n 0.7000 269750.0n 0.7000 269999.9n 0.7000 270000.0n 0.3000 270249.9n 0.3000 270250.0n 0.7000 270499.9n 0.7000 270500.0n 0.7000 270749.9n 0.7000 270750.0n 0.7000 270999.9n 0.7000 271000.0n 0.7000 271249.9n 0.7000 271250.0n 0.3000 271499.9n 0.3000 271500.0n 0.7000 271749.9n 0.7000 271750.0n 0.3000 271999.9n 0.3000 272000.0n 0.3000 272249.9n 0.3000 272250.0n 0.3000 272499.9n 0.3000 272500.0n 0.7000 272749.9n 0.7000 272750.0n 0.7000 272999.9n 0.7000 273000.0n 0.3000 273249.9n 0.3000 273250.0n 0.3000 273499.9n 0.3000 273500.0n 0.3000 273749.9n 0.3000 273750.0n 0.3000 273999.9n 0.3000 274000.0n 0.3000 274249.9n 0.3000 274250.0n 0.7000 274499.9n 0.7000 274500.0n 0.7000 274749.9n 0.7000 274750.0n 0.3000 274999.9n 0.3000 275000.0n 0.7000 275249.9n 0.7000 275250.0n 0.3000 275499.9n 0.3000 275500.0n 0.7000 275749.9n 0.7000 275750.0n 0.3000 275999.9n 0.3000 276000.0n 0.3000 276249.9n 0.3000 276250.0n 0.7000 276499.9n 0.7000 276500.0n 0.3000 276749.9n 0.3000 276750.0n 0.7000 276999.9n 0.7000 277000.0n 0.7000 277249.9n 0.7000 277250.0n 0.7000 277499.9n 0.7000 277500.0n 0.3000 277749.9n 0.3000 277750.0n 0.7000 277999.9n 0.7000 278000.0n 0.7000 278249.9n 0.7000 278250.0n 0.7000 278499.9n 0.7000 278500.0n 0.7000 278749.9n 0.7000 278750.0n 0.3000 278999.9n 0.3000 279000.0n 0.7000 279249.9n 0.7000 279250.0n 0.3000 279499.9n 0.3000 279500.0n 0.3000 279749.9n 0.3000 279750.0n 0.3000 279999.9n 0.3000 280000.0n 0.7000 280249.9n 0.7000 280250.0n 0.7000 280499.9n 0.7000 280500.0n 0.3000 280749.9n 0.3000 280750.0n 0.3000 280999.9n 0.3000 281000.0n 0.3000 281249.9n 0.3000 281250.0n 0.3000 281499.9n 0.3000 281500.0n 0.3000 281749.9n 0.3000 281750.0n 0.7000 281999.9n 0.7000 282000.0n 0.7000 282249.9n 0.7000 282250.0n 0.3000 282499.9n 0.3000 282500.0n 0.7000 282749.9n 0.7000 282750.0n 0.3000 282999.9n 0.3000 283000.0n 0.7000 283249.9n 0.7000 283250.0n 0.3000 283499.9n 0.3000 283500.0n 0.3000 283749.9n 0.3000 283750.0n 0.7000 283999.9n 0.7000 284000.0n 0.3000 284249.9n 0.3000 284250.0n 0.7000 284499.9n 0.7000 284500.0n 0.7000 284749.9n 0.7000 284750.0n 0.7000 284999.9n 0.7000 285000.0n 0.3000 285249.9n 0.3000 285250.0n 0.7000 285499.9n 0.7000 285500.0n 0.7000 285749.9n 0.7000 285750.0n 0.7000 285999.9n 0.7000 286000.0n 0.7000 286249.9n 0.7000 286250.0n 0.3000 286499.9n 0.3000 286500.0n 0.7000 286749.9n 0.7000 286750.0n 0.3000 286999.9n 0.3000 287000.0n 0.3000 287249.9n 0.3000 287250.0n 0.3000 287499.9n 0.3000 287500.0n 0.7000 287749.9n 0.7000 287750.0n 0.7000 287999.9n 0.7000 288000.0n 0.3000 288249.9n 0.3000 288250.0n 0.3000 288499.9n 0.3000 288500.0n 0.3000 288749.9n 0.3000 288750.0n 0.3000 288999.9n 0.3000 289000.0n 0.3000 289249.9n 0.3000 289250.0n 0.7000 289499.9n 0.7000 289500.0n 0.7000 289749.9n 0.7000 289750.0n 0.3000 289999.9n 0.3000 290000.0n 0.7000 290249.9n 0.7000 290250.0n 0.3000 290499.9n 0.3000 290500.0n 0.7000 290749.9n 0.7000 290750.0n 0.3000 290999.9n 0.3000 291000.0n 0.3000 291249.9n 0.3000 291250.0n 0.7000 291499.9n 0.7000 291500.0n 0.3000 291749.9n 0.3000 291750.0n 0.7000 291999.9n 0.7000 292000.0n 0.7000 292249.9n 0.7000 292250.0n 0.7000 292499.9n 0.7000 292500.0n 0.3000 292749.9n 0.3000 292750.0n 0.7000 292999.9n 0.7000 293000.0n 0.7000 293249.9n 0.7000 293250.0n 0.7000 293499.9n 0.7000 293500.0n 0.7000 293749.9n 0.7000 293750.0n 0.3000 293999.9n 0.3000 294000.0n 0.7000 294249.9n 0.7000 294250.0n 0.3000 294499.9n 0.3000 294500.0n 0.3000 294749.9n 0.3000 294750.0n 0.3000 294999.9n 0.3000 295000.0n 0.7000 295249.9n 0.7000 295250.0n 0.7000 295499.9n 0.7000 295500.0n 0.3000 295749.9n 0.3000 295750.0n 0.3000 295999.9n 0.3000 296000.0n 0.3000 296249.9n 0.3000 296250.0n 0.3000 296499.9n 0.3000 296500.0n 0.3000 296749.9n 0.3000 296750.0n 0.7000 296999.9n 0.7000 297000.0n 0.7000 297249.9n 0.7000 297250.0n 0.3000 297499.9n 0.3000 297500.0n 0.7000 297749.9n 0.7000 297750.0n 0.3000 297999.9n 0.3000 298000.0n 0.7000 298249.9n 0.7000 298250.0n 0.3000 298499.9n 0.3000 298500.0n 0.3000 298749.9n 0.3000 298750.0n 0.7000 298999.9n 0.7000 299000.0n 0.3000 299249.9n 0.3000 299250.0n 0.7000 299499.9n 0.7000 299500.0n 0.7000 299749.9n 0.7000 299750.0n 0.7000)
Cwp_wih_0_0 wp_wih_0_0 0 30p
Cwn_wih_0_0 wn_wih_0_0 0 30p
Rwp_wih_0_0 wp_wih_0_0 wcm 2g
Rwn_wih_0_0 wn_wih_0_0 wcm 2g
Cwp_wih_1_0 wp_wih_1_0 0 30p
Cwn_wih_1_0 wn_wih_1_0 0 30p
Rwp_wih_1_0 wp_wih_1_0 wcm 2g
Rwn_wih_1_0 wn_wih_1_0 wcm 2g
Cwp_wih_2_0 wp_wih_2_0 0 30p
Cwn_wih_2_0 wn_wih_2_0 0 30p
Rwp_wih_2_0 wp_wih_2_0 wcm 2g
Rwn_wih_2_0 wn_wih_2_0 wcm 2g
Cwp_wih_3_0 wp_wih_3_0 0 30p
Cwn_wih_3_0 wn_wih_3_0 0 30p
Rwp_wih_3_0 wp_wih_3_0 wcm 2g
Rwn_wih_3_0 wn_wih_3_0 wcm 2g
Cwp_wih_4_0 wp_wih_4_0 0 30p
Cwn_wih_4_0 wn_wih_4_0 0 30p
Rwp_wih_4_0 wp_wih_4_0 wcm 2g
Rwn_wih_4_0 wn_wih_4_0 wcm 2g
Cwp_wih_5_0 wp_wih_5_0 0 30p
Cwn_wih_5_0 wn_wih_5_0 0 30p
Rwp_wih_5_0 wp_wih_5_0 wcm 2g
Rwn_wih_5_0 wn_wih_5_0 wcm 2g
Cwp_wih_6_0 wp_wih_6_0 0 30p
Cwn_wih_6_0 wn_wih_6_0 0 30p
Rwp_wih_6_0 wp_wih_6_0 wcm 2g
Rwn_wih_6_0 wn_wih_6_0 wcm 2g
Cwp_wih_7_0 wp_wih_7_0 0 30p
Cwn_wih_7_0 wn_wih_7_0 0 30p
Rwp_wih_7_0 wp_wih_7_0 wcm 2g
Rwn_wih_7_0 wn_wih_7_0 wcm 2g
Cwp_wih_8_0 wp_wih_8_0 0 30p
Cwn_wih_8_0 wn_wih_8_0 0 30p
Rwp_wih_8_0 wp_wih_8_0 wcm 2g
Rwn_wih_8_0 wn_wih_8_0 wcm 2g
Cwp_wih_9_0 wp_wih_9_0 0 30p
Cwn_wih_9_0 wn_wih_9_0 0 30p
Rwp_wih_9_0 wp_wih_9_0 wcm 2g
Rwn_wih_9_0 wn_wih_9_0 wcm 2g
Cwp_wih_10_0 wp_wih_10_0 0 30p
Cwn_wih_10_0 wn_wih_10_0 0 30p
Rwp_wih_10_0 wp_wih_10_0 wcm 2g
Rwn_wih_10_0 wn_wih_10_0 wcm 2g
Cwp_wih_11_0 wp_wih_11_0 0 30p
Cwn_wih_11_0 wn_wih_11_0 0 30p
Rwp_wih_11_0 wp_wih_11_0 wcm 2g
Rwn_wih_11_0 wn_wih_11_0 wcm 2g
Cwp_wih_12_0 wp_wih_12_0 0 30p
Cwn_wih_12_0 wn_wih_12_0 0 30p
Rwp_wih_12_0 wp_wih_12_0 wcm 2g
Rwn_wih_12_0 wn_wih_12_0 wcm 2g
Cwp_wih_13_0 wp_wih_13_0 0 30p
Cwn_wih_13_0 wn_wih_13_0 0 30p
Rwp_wih_13_0 wp_wih_13_0 wcm 2g
Rwn_wih_13_0 wn_wih_13_0 wcm 2g
Cwp_wih_14_0 wp_wih_14_0 0 30p
Cwn_wih_14_0 wn_wih_14_0 0 30p
Rwp_wih_14_0 wp_wih_14_0 wcm 2g
Rwn_wih_14_0 wn_wih_14_0 wcm 2g
Cwp_wih_15_0 wp_wih_15_0 0 30p
Cwn_wih_15_0 wn_wih_15_0 0 30p
Rwp_wih_15_0 wp_wih_15_0 wcm 2g
Rwn_wih_15_0 wn_wih_15_0 wcm 2g
Cwp_who_0_0 wp_who_0_0 0 30p
Cwn_who_0_0 wn_who_0_0 0 30p
Rwp_who_0_0 wp_who_0_0 wcm 2g
Rwn_who_0_0 wn_who_0_0 wcm 2g
Cwp_who_0_1 wp_who_0_1 0 30p
Cwn_who_0_1 wn_who_0_1 0 30p
Rwp_who_0_1 wp_who_0_1 wcm 2g
Rwn_who_0_1 wn_who_0_1 wcm 2g
Cwp_wih_0_1 wp_wih_0_1 0 30p
Cwn_wih_0_1 wn_wih_0_1 0 30p
Rwp_wih_0_1 wp_wih_0_1 wcm 2g
Rwn_wih_0_1 wn_wih_0_1 wcm 2g
Cwp_wih_1_1 wp_wih_1_1 0 30p
Cwn_wih_1_1 wn_wih_1_1 0 30p
Rwp_wih_1_1 wp_wih_1_1 wcm 2g
Rwn_wih_1_1 wn_wih_1_1 wcm 2g
Cwp_wih_2_1 wp_wih_2_1 0 30p
Cwn_wih_2_1 wn_wih_2_1 0 30p
Rwp_wih_2_1 wp_wih_2_1 wcm 2g
Rwn_wih_2_1 wn_wih_2_1 wcm 2g
Cwp_wih_3_1 wp_wih_3_1 0 30p
Cwn_wih_3_1 wn_wih_3_1 0 30p
Rwp_wih_3_1 wp_wih_3_1 wcm 2g
Rwn_wih_3_1 wn_wih_3_1 wcm 2g
Cwp_wih_4_1 wp_wih_4_1 0 30p
Cwn_wih_4_1 wn_wih_4_1 0 30p
Rwp_wih_4_1 wp_wih_4_1 wcm 2g
Rwn_wih_4_1 wn_wih_4_1 wcm 2g
Cwp_wih_5_1 wp_wih_5_1 0 30p
Cwn_wih_5_1 wn_wih_5_1 0 30p
Rwp_wih_5_1 wp_wih_5_1 wcm 2g
Rwn_wih_5_1 wn_wih_5_1 wcm 2g
Cwp_wih_6_1 wp_wih_6_1 0 30p
Cwn_wih_6_1 wn_wih_6_1 0 30p
Rwp_wih_6_1 wp_wih_6_1 wcm 2g
Rwn_wih_6_1 wn_wih_6_1 wcm 2g
Cwp_wih_7_1 wp_wih_7_1 0 30p
Cwn_wih_7_1 wn_wih_7_1 0 30p
Rwp_wih_7_1 wp_wih_7_1 wcm 2g
Rwn_wih_7_1 wn_wih_7_1 wcm 2g
Cwp_wih_8_1 wp_wih_8_1 0 30p
Cwn_wih_8_1 wn_wih_8_1 0 30p
Rwp_wih_8_1 wp_wih_8_1 wcm 2g
Rwn_wih_8_1 wn_wih_8_1 wcm 2g
Cwp_wih_9_1 wp_wih_9_1 0 30p
Cwn_wih_9_1 wn_wih_9_1 0 30p
Rwp_wih_9_1 wp_wih_9_1 wcm 2g
Rwn_wih_9_1 wn_wih_9_1 wcm 2g
Cwp_wih_10_1 wp_wih_10_1 0 30p
Cwn_wih_10_1 wn_wih_10_1 0 30p
Rwp_wih_10_1 wp_wih_10_1 wcm 2g
Rwn_wih_10_1 wn_wih_10_1 wcm 2g
Cwp_wih_11_1 wp_wih_11_1 0 30p
Cwn_wih_11_1 wn_wih_11_1 0 30p
Rwp_wih_11_1 wp_wih_11_1 wcm 2g
Rwn_wih_11_1 wn_wih_11_1 wcm 2g
Cwp_wih_12_1 wp_wih_12_1 0 30p
Cwn_wih_12_1 wn_wih_12_1 0 30p
Rwp_wih_12_1 wp_wih_12_1 wcm 2g
Rwn_wih_12_1 wn_wih_12_1 wcm 2g
Cwp_wih_13_1 wp_wih_13_1 0 30p
Cwn_wih_13_1 wn_wih_13_1 0 30p
Rwp_wih_13_1 wp_wih_13_1 wcm 2g
Rwn_wih_13_1 wn_wih_13_1 wcm 2g
Cwp_wih_14_1 wp_wih_14_1 0 30p
Cwn_wih_14_1 wn_wih_14_1 0 30p
Rwp_wih_14_1 wp_wih_14_1 wcm 2g
Rwn_wih_14_1 wn_wih_14_1 wcm 2g
Cwp_wih_15_1 wp_wih_15_1 0 30p
Cwn_wih_15_1 wn_wih_15_1 0 30p
Rwp_wih_15_1 wp_wih_15_1 wcm 2g
Rwn_wih_15_1 wn_wih_15_1 wcm 2g
Cwp_who_1_0 wp_who_1_0 0 30p
Cwn_who_1_0 wn_who_1_0 0 30p
Rwp_who_1_0 wp_who_1_0 wcm 2g
Rwn_who_1_0 wn_who_1_0 wcm 2g
Cwp_who_1_1 wp_who_1_1 0 30p
Cwn_who_1_1 wn_who_1_1 0 30p
Rwp_who_1_1 wp_who_1_1 wcm 2g
Rwn_who_1_1 wn_who_1_1 wcm 2g
Cwp_wih_0_2 wp_wih_0_2 0 30p
Cwn_wih_0_2 wn_wih_0_2 0 30p
Rwp_wih_0_2 wp_wih_0_2 wcm 2g
Rwn_wih_0_2 wn_wih_0_2 wcm 2g
Cwp_wih_1_2 wp_wih_1_2 0 30p
Cwn_wih_1_2 wn_wih_1_2 0 30p
Rwp_wih_1_2 wp_wih_1_2 wcm 2g
Rwn_wih_1_2 wn_wih_1_2 wcm 2g
Cwp_wih_2_2 wp_wih_2_2 0 30p
Cwn_wih_2_2 wn_wih_2_2 0 30p
Rwp_wih_2_2 wp_wih_2_2 wcm 2g
Rwn_wih_2_2 wn_wih_2_2 wcm 2g
Cwp_wih_3_2 wp_wih_3_2 0 30p
Cwn_wih_3_2 wn_wih_3_2 0 30p
Rwp_wih_3_2 wp_wih_3_2 wcm 2g
Rwn_wih_3_2 wn_wih_3_2 wcm 2g
Cwp_wih_4_2 wp_wih_4_2 0 30p
Cwn_wih_4_2 wn_wih_4_2 0 30p
Rwp_wih_4_2 wp_wih_4_2 wcm 2g
Rwn_wih_4_2 wn_wih_4_2 wcm 2g
Cwp_wih_5_2 wp_wih_5_2 0 30p
Cwn_wih_5_2 wn_wih_5_2 0 30p
Rwp_wih_5_2 wp_wih_5_2 wcm 2g
Rwn_wih_5_2 wn_wih_5_2 wcm 2g
Cwp_wih_6_2 wp_wih_6_2 0 30p
Cwn_wih_6_2 wn_wih_6_2 0 30p
Rwp_wih_6_2 wp_wih_6_2 wcm 2g
Rwn_wih_6_2 wn_wih_6_2 wcm 2g
Cwp_wih_7_2 wp_wih_7_2 0 30p
Cwn_wih_7_2 wn_wih_7_2 0 30p
Rwp_wih_7_2 wp_wih_7_2 wcm 2g
Rwn_wih_7_2 wn_wih_7_2 wcm 2g
Cwp_wih_8_2 wp_wih_8_2 0 30p
Cwn_wih_8_2 wn_wih_8_2 0 30p
Rwp_wih_8_2 wp_wih_8_2 wcm 2g
Rwn_wih_8_2 wn_wih_8_2 wcm 2g
Cwp_wih_9_2 wp_wih_9_2 0 30p
Cwn_wih_9_2 wn_wih_9_2 0 30p
Rwp_wih_9_2 wp_wih_9_2 wcm 2g
Rwn_wih_9_2 wn_wih_9_2 wcm 2g
Cwp_wih_10_2 wp_wih_10_2 0 30p
Cwn_wih_10_2 wn_wih_10_2 0 30p
Rwp_wih_10_2 wp_wih_10_2 wcm 2g
Rwn_wih_10_2 wn_wih_10_2 wcm 2g
Cwp_wih_11_2 wp_wih_11_2 0 30p
Cwn_wih_11_2 wn_wih_11_2 0 30p
Rwp_wih_11_2 wp_wih_11_2 wcm 2g
Rwn_wih_11_2 wn_wih_11_2 wcm 2g
Cwp_wih_12_2 wp_wih_12_2 0 30p
Cwn_wih_12_2 wn_wih_12_2 0 30p
Rwp_wih_12_2 wp_wih_12_2 wcm 2g
Rwn_wih_12_2 wn_wih_12_2 wcm 2g
Cwp_wih_13_2 wp_wih_13_2 0 30p
Cwn_wih_13_2 wn_wih_13_2 0 30p
Rwp_wih_13_2 wp_wih_13_2 wcm 2g
Rwn_wih_13_2 wn_wih_13_2 wcm 2g
Cwp_wih_14_2 wp_wih_14_2 0 30p
Cwn_wih_14_2 wn_wih_14_2 0 30p
Rwp_wih_14_2 wp_wih_14_2 wcm 2g
Rwn_wih_14_2 wn_wih_14_2 wcm 2g
Cwp_wih_15_2 wp_wih_15_2 0 30p
Cwn_wih_15_2 wn_wih_15_2 0 30p
Rwp_wih_15_2 wp_wih_15_2 wcm 2g
Rwn_wih_15_2 wn_wih_15_2 wcm 2g
Cwp_who_2_0 wp_who_2_0 0 30p
Cwn_who_2_0 wn_who_2_0 0 30p
Rwp_who_2_0 wp_who_2_0 wcm 2g
Rwn_who_2_0 wn_who_2_0 wcm 2g
Cwp_who_2_1 wp_who_2_1 0 30p
Cwn_who_2_1 wn_who_2_1 0 30p
Rwp_who_2_1 wp_who_2_1 wcm 2g
Rwn_who_2_1 wn_who_2_1 wcm 2g
Cwp_wih_0_3 wp_wih_0_3 0 30p
Cwn_wih_0_3 wn_wih_0_3 0 30p
Rwp_wih_0_3 wp_wih_0_3 wcm 2g
Rwn_wih_0_3 wn_wih_0_3 wcm 2g
Cwp_wih_1_3 wp_wih_1_3 0 30p
Cwn_wih_1_3 wn_wih_1_3 0 30p
Rwp_wih_1_3 wp_wih_1_3 wcm 2g
Rwn_wih_1_3 wn_wih_1_3 wcm 2g
Cwp_wih_2_3 wp_wih_2_3 0 30p
Cwn_wih_2_3 wn_wih_2_3 0 30p
Rwp_wih_2_3 wp_wih_2_3 wcm 2g
Rwn_wih_2_3 wn_wih_2_3 wcm 2g
Cwp_wih_3_3 wp_wih_3_3 0 30p
Cwn_wih_3_3 wn_wih_3_3 0 30p
Rwp_wih_3_3 wp_wih_3_3 wcm 2g
Rwn_wih_3_3 wn_wih_3_3 wcm 2g
Cwp_wih_4_3 wp_wih_4_3 0 30p
Cwn_wih_4_3 wn_wih_4_3 0 30p
Rwp_wih_4_3 wp_wih_4_3 wcm 2g
Rwn_wih_4_3 wn_wih_4_3 wcm 2g
Cwp_wih_5_3 wp_wih_5_3 0 30p
Cwn_wih_5_3 wn_wih_5_3 0 30p
Rwp_wih_5_3 wp_wih_5_3 wcm 2g
Rwn_wih_5_3 wn_wih_5_3 wcm 2g
Cwp_wih_6_3 wp_wih_6_3 0 30p
Cwn_wih_6_3 wn_wih_6_3 0 30p
Rwp_wih_6_3 wp_wih_6_3 wcm 2g
Rwn_wih_6_3 wn_wih_6_3 wcm 2g
Cwp_wih_7_3 wp_wih_7_3 0 30p
Cwn_wih_7_3 wn_wih_7_3 0 30p
Rwp_wih_7_3 wp_wih_7_3 wcm 2g
Rwn_wih_7_3 wn_wih_7_3 wcm 2g
Cwp_wih_8_3 wp_wih_8_3 0 30p
Cwn_wih_8_3 wn_wih_8_3 0 30p
Rwp_wih_8_3 wp_wih_8_3 wcm 2g
Rwn_wih_8_3 wn_wih_8_3 wcm 2g
Cwp_wih_9_3 wp_wih_9_3 0 30p
Cwn_wih_9_3 wn_wih_9_3 0 30p
Rwp_wih_9_3 wp_wih_9_3 wcm 2g
Rwn_wih_9_3 wn_wih_9_3 wcm 2g
Cwp_wih_10_3 wp_wih_10_3 0 30p
Cwn_wih_10_3 wn_wih_10_3 0 30p
Rwp_wih_10_3 wp_wih_10_3 wcm 2g
Rwn_wih_10_3 wn_wih_10_3 wcm 2g
Cwp_wih_11_3 wp_wih_11_3 0 30p
Cwn_wih_11_3 wn_wih_11_3 0 30p
Rwp_wih_11_3 wp_wih_11_3 wcm 2g
Rwn_wih_11_3 wn_wih_11_3 wcm 2g
Cwp_wih_12_3 wp_wih_12_3 0 30p
Cwn_wih_12_3 wn_wih_12_3 0 30p
Rwp_wih_12_3 wp_wih_12_3 wcm 2g
Rwn_wih_12_3 wn_wih_12_3 wcm 2g
Cwp_wih_13_3 wp_wih_13_3 0 30p
Cwn_wih_13_3 wn_wih_13_3 0 30p
Rwp_wih_13_3 wp_wih_13_3 wcm 2g
Rwn_wih_13_3 wn_wih_13_3 wcm 2g
Cwp_wih_14_3 wp_wih_14_3 0 30p
Cwn_wih_14_3 wn_wih_14_3 0 30p
Rwp_wih_14_3 wp_wih_14_3 wcm 2g
Rwn_wih_14_3 wn_wih_14_3 wcm 2g
Cwp_wih_15_3 wp_wih_15_3 0 30p
Cwn_wih_15_3 wn_wih_15_3 0 30p
Rwp_wih_15_3 wp_wih_15_3 wcm 2g
Rwn_wih_15_3 wn_wih_15_3 wcm 2g
Cwp_who_3_0 wp_who_3_0 0 30p
Cwn_who_3_0 wn_who_3_0 0 30p
Rwp_who_3_0 wp_who_3_0 wcm 2g
Rwn_who_3_0 wn_who_3_0 wcm 2g
Cwp_who_3_1 wp_who_3_1 0 30p
Cwn_who_3_1 wn_who_3_1 0 30p
Rwp_who_3_1 wp_who_3_1 wcm 2g
Rwn_who_3_1 wn_who_3_1 wcm 2g
Cwp_wih_0_4 wp_wih_0_4 0 30p
Cwn_wih_0_4 wn_wih_0_4 0 30p
Rwp_wih_0_4 wp_wih_0_4 wcm 2g
Rwn_wih_0_4 wn_wih_0_4 wcm 2g
Cwp_wih_1_4 wp_wih_1_4 0 30p
Cwn_wih_1_4 wn_wih_1_4 0 30p
Rwp_wih_1_4 wp_wih_1_4 wcm 2g
Rwn_wih_1_4 wn_wih_1_4 wcm 2g
Cwp_wih_2_4 wp_wih_2_4 0 30p
Cwn_wih_2_4 wn_wih_2_4 0 30p
Rwp_wih_2_4 wp_wih_2_4 wcm 2g
Rwn_wih_2_4 wn_wih_2_4 wcm 2g
Cwp_wih_3_4 wp_wih_3_4 0 30p
Cwn_wih_3_4 wn_wih_3_4 0 30p
Rwp_wih_3_4 wp_wih_3_4 wcm 2g
Rwn_wih_3_4 wn_wih_3_4 wcm 2g
Cwp_wih_4_4 wp_wih_4_4 0 30p
Cwn_wih_4_4 wn_wih_4_4 0 30p
Rwp_wih_4_4 wp_wih_4_4 wcm 2g
Rwn_wih_4_4 wn_wih_4_4 wcm 2g
Cwp_wih_5_4 wp_wih_5_4 0 30p
Cwn_wih_5_4 wn_wih_5_4 0 30p
Rwp_wih_5_4 wp_wih_5_4 wcm 2g
Rwn_wih_5_4 wn_wih_5_4 wcm 2g
Cwp_wih_6_4 wp_wih_6_4 0 30p
Cwn_wih_6_4 wn_wih_6_4 0 30p
Rwp_wih_6_4 wp_wih_6_4 wcm 2g
Rwn_wih_6_4 wn_wih_6_4 wcm 2g
Cwp_wih_7_4 wp_wih_7_4 0 30p
Cwn_wih_7_4 wn_wih_7_4 0 30p
Rwp_wih_7_4 wp_wih_7_4 wcm 2g
Rwn_wih_7_4 wn_wih_7_4 wcm 2g
Cwp_wih_8_4 wp_wih_8_4 0 30p
Cwn_wih_8_4 wn_wih_8_4 0 30p
Rwp_wih_8_4 wp_wih_8_4 wcm 2g
Rwn_wih_8_4 wn_wih_8_4 wcm 2g
Cwp_wih_9_4 wp_wih_9_4 0 30p
Cwn_wih_9_4 wn_wih_9_4 0 30p
Rwp_wih_9_4 wp_wih_9_4 wcm 2g
Rwn_wih_9_4 wn_wih_9_4 wcm 2g
Cwp_wih_10_4 wp_wih_10_4 0 30p
Cwn_wih_10_4 wn_wih_10_4 0 30p
Rwp_wih_10_4 wp_wih_10_4 wcm 2g
Rwn_wih_10_4 wn_wih_10_4 wcm 2g
Cwp_wih_11_4 wp_wih_11_4 0 30p
Cwn_wih_11_4 wn_wih_11_4 0 30p
Rwp_wih_11_4 wp_wih_11_4 wcm 2g
Rwn_wih_11_4 wn_wih_11_4 wcm 2g
Cwp_wih_12_4 wp_wih_12_4 0 30p
Cwn_wih_12_4 wn_wih_12_4 0 30p
Rwp_wih_12_4 wp_wih_12_4 wcm 2g
Rwn_wih_12_4 wn_wih_12_4 wcm 2g
Cwp_wih_13_4 wp_wih_13_4 0 30p
Cwn_wih_13_4 wn_wih_13_4 0 30p
Rwp_wih_13_4 wp_wih_13_4 wcm 2g
Rwn_wih_13_4 wn_wih_13_4 wcm 2g
Cwp_wih_14_4 wp_wih_14_4 0 30p
Cwn_wih_14_4 wn_wih_14_4 0 30p
Rwp_wih_14_4 wp_wih_14_4 wcm 2g
Rwn_wih_14_4 wn_wih_14_4 wcm 2g
Cwp_wih_15_4 wp_wih_15_4 0 30p
Cwn_wih_15_4 wn_wih_15_4 0 30p
Rwp_wih_15_4 wp_wih_15_4 wcm 2g
Rwn_wih_15_4 wn_wih_15_4 wcm 2g
Cwp_who_4_0 wp_who_4_0 0 30p
Cwn_who_4_0 wn_who_4_0 0 30p
Rwp_who_4_0 wp_who_4_0 wcm 2g
Rwn_who_4_0 wn_who_4_0 wcm 2g
Cwp_who_4_1 wp_who_4_1 0 30p
Cwn_who_4_1 wn_who_4_1 0 30p
Rwp_who_4_1 wp_who_4_1 wcm 2g
Rwn_who_4_1 wn_who_4_1 wcm 2g
Cwp_wih_0_5 wp_wih_0_5 0 30p
Cwn_wih_0_5 wn_wih_0_5 0 30p
Rwp_wih_0_5 wp_wih_0_5 wcm 2g
Rwn_wih_0_5 wn_wih_0_5 wcm 2g
Cwp_wih_1_5 wp_wih_1_5 0 30p
Cwn_wih_1_5 wn_wih_1_5 0 30p
Rwp_wih_1_5 wp_wih_1_5 wcm 2g
Rwn_wih_1_5 wn_wih_1_5 wcm 2g
Cwp_wih_2_5 wp_wih_2_5 0 30p
Cwn_wih_2_5 wn_wih_2_5 0 30p
Rwp_wih_2_5 wp_wih_2_5 wcm 2g
Rwn_wih_2_5 wn_wih_2_5 wcm 2g
Cwp_wih_3_5 wp_wih_3_5 0 30p
Cwn_wih_3_5 wn_wih_3_5 0 30p
Rwp_wih_3_5 wp_wih_3_5 wcm 2g
Rwn_wih_3_5 wn_wih_3_5 wcm 2g
Cwp_wih_4_5 wp_wih_4_5 0 30p
Cwn_wih_4_5 wn_wih_4_5 0 30p
Rwp_wih_4_5 wp_wih_4_5 wcm 2g
Rwn_wih_4_5 wn_wih_4_5 wcm 2g
Cwp_wih_5_5 wp_wih_5_5 0 30p
Cwn_wih_5_5 wn_wih_5_5 0 30p
Rwp_wih_5_5 wp_wih_5_5 wcm 2g
Rwn_wih_5_5 wn_wih_5_5 wcm 2g
Cwp_wih_6_5 wp_wih_6_5 0 30p
Cwn_wih_6_5 wn_wih_6_5 0 30p
Rwp_wih_6_5 wp_wih_6_5 wcm 2g
Rwn_wih_6_5 wn_wih_6_5 wcm 2g
Cwp_wih_7_5 wp_wih_7_5 0 30p
Cwn_wih_7_5 wn_wih_7_5 0 30p
Rwp_wih_7_5 wp_wih_7_5 wcm 2g
Rwn_wih_7_5 wn_wih_7_5 wcm 2g
Cwp_wih_8_5 wp_wih_8_5 0 30p
Cwn_wih_8_5 wn_wih_8_5 0 30p
Rwp_wih_8_5 wp_wih_8_5 wcm 2g
Rwn_wih_8_5 wn_wih_8_5 wcm 2g
Cwp_wih_9_5 wp_wih_9_5 0 30p
Cwn_wih_9_5 wn_wih_9_5 0 30p
Rwp_wih_9_5 wp_wih_9_5 wcm 2g
Rwn_wih_9_5 wn_wih_9_5 wcm 2g
Cwp_wih_10_5 wp_wih_10_5 0 30p
Cwn_wih_10_5 wn_wih_10_5 0 30p
Rwp_wih_10_5 wp_wih_10_5 wcm 2g
Rwn_wih_10_5 wn_wih_10_5 wcm 2g
Cwp_wih_11_5 wp_wih_11_5 0 30p
Cwn_wih_11_5 wn_wih_11_5 0 30p
Rwp_wih_11_5 wp_wih_11_5 wcm 2g
Rwn_wih_11_5 wn_wih_11_5 wcm 2g
Cwp_wih_12_5 wp_wih_12_5 0 30p
Cwn_wih_12_5 wn_wih_12_5 0 30p
Rwp_wih_12_5 wp_wih_12_5 wcm 2g
Rwn_wih_12_5 wn_wih_12_5 wcm 2g
Cwp_wih_13_5 wp_wih_13_5 0 30p
Cwn_wih_13_5 wn_wih_13_5 0 30p
Rwp_wih_13_5 wp_wih_13_5 wcm 2g
Rwn_wih_13_5 wn_wih_13_5 wcm 2g
Cwp_wih_14_5 wp_wih_14_5 0 30p
Cwn_wih_14_5 wn_wih_14_5 0 30p
Rwp_wih_14_5 wp_wih_14_5 wcm 2g
Rwn_wih_14_5 wn_wih_14_5 wcm 2g
Cwp_wih_15_5 wp_wih_15_5 0 30p
Cwn_wih_15_5 wn_wih_15_5 0 30p
Rwp_wih_15_5 wp_wih_15_5 wcm 2g
Rwn_wih_15_5 wn_wih_15_5 wcm 2g
Cwp_who_5_0 wp_who_5_0 0 30p
Cwn_who_5_0 wn_who_5_0 0 30p
Rwp_who_5_0 wp_who_5_0 wcm 2g
Rwn_who_5_0 wn_who_5_0 wcm 2g
Cwp_who_5_1 wp_who_5_1 0 30p
Cwn_who_5_1 wn_who_5_1 0 30p
Rwp_who_5_1 wp_who_5_1 wcm 2g
Rwn_who_5_1 wn_who_5_1 wcm 2g
Cwp_wih_0_6 wp_wih_0_6 0 30p
Cwn_wih_0_6 wn_wih_0_6 0 30p
Rwp_wih_0_6 wp_wih_0_6 wcm 2g
Rwn_wih_0_6 wn_wih_0_6 wcm 2g
Cwp_wih_1_6 wp_wih_1_6 0 30p
Cwn_wih_1_6 wn_wih_1_6 0 30p
Rwp_wih_1_6 wp_wih_1_6 wcm 2g
Rwn_wih_1_6 wn_wih_1_6 wcm 2g
Cwp_wih_2_6 wp_wih_2_6 0 30p
Cwn_wih_2_6 wn_wih_2_6 0 30p
Rwp_wih_2_6 wp_wih_2_6 wcm 2g
Rwn_wih_2_6 wn_wih_2_6 wcm 2g
Cwp_wih_3_6 wp_wih_3_6 0 30p
Cwn_wih_3_6 wn_wih_3_6 0 30p
Rwp_wih_3_6 wp_wih_3_6 wcm 2g
Rwn_wih_3_6 wn_wih_3_6 wcm 2g
Cwp_wih_4_6 wp_wih_4_6 0 30p
Cwn_wih_4_6 wn_wih_4_6 0 30p
Rwp_wih_4_6 wp_wih_4_6 wcm 2g
Rwn_wih_4_6 wn_wih_4_6 wcm 2g
Cwp_wih_5_6 wp_wih_5_6 0 30p
Cwn_wih_5_6 wn_wih_5_6 0 30p
Rwp_wih_5_6 wp_wih_5_6 wcm 2g
Rwn_wih_5_6 wn_wih_5_6 wcm 2g
Cwp_wih_6_6 wp_wih_6_6 0 30p
Cwn_wih_6_6 wn_wih_6_6 0 30p
Rwp_wih_6_6 wp_wih_6_6 wcm 2g
Rwn_wih_6_6 wn_wih_6_6 wcm 2g
Cwp_wih_7_6 wp_wih_7_6 0 30p
Cwn_wih_7_6 wn_wih_7_6 0 30p
Rwp_wih_7_6 wp_wih_7_6 wcm 2g
Rwn_wih_7_6 wn_wih_7_6 wcm 2g
Cwp_wih_8_6 wp_wih_8_6 0 30p
Cwn_wih_8_6 wn_wih_8_6 0 30p
Rwp_wih_8_6 wp_wih_8_6 wcm 2g
Rwn_wih_8_6 wn_wih_8_6 wcm 2g
Cwp_wih_9_6 wp_wih_9_6 0 30p
Cwn_wih_9_6 wn_wih_9_6 0 30p
Rwp_wih_9_6 wp_wih_9_6 wcm 2g
Rwn_wih_9_6 wn_wih_9_6 wcm 2g
Cwp_wih_10_6 wp_wih_10_6 0 30p
Cwn_wih_10_6 wn_wih_10_6 0 30p
Rwp_wih_10_6 wp_wih_10_6 wcm 2g
Rwn_wih_10_6 wn_wih_10_6 wcm 2g
Cwp_wih_11_6 wp_wih_11_6 0 30p
Cwn_wih_11_6 wn_wih_11_6 0 30p
Rwp_wih_11_6 wp_wih_11_6 wcm 2g
Rwn_wih_11_6 wn_wih_11_6 wcm 2g
Cwp_wih_12_6 wp_wih_12_6 0 30p
Cwn_wih_12_6 wn_wih_12_6 0 30p
Rwp_wih_12_6 wp_wih_12_6 wcm 2g
Rwn_wih_12_6 wn_wih_12_6 wcm 2g
Cwp_wih_13_6 wp_wih_13_6 0 30p
Cwn_wih_13_6 wn_wih_13_6 0 30p
Rwp_wih_13_6 wp_wih_13_6 wcm 2g
Rwn_wih_13_6 wn_wih_13_6 wcm 2g
Cwp_wih_14_6 wp_wih_14_6 0 30p
Cwn_wih_14_6 wn_wih_14_6 0 30p
Rwp_wih_14_6 wp_wih_14_6 wcm 2g
Rwn_wih_14_6 wn_wih_14_6 wcm 2g
Cwp_wih_15_6 wp_wih_15_6 0 30p
Cwn_wih_15_6 wn_wih_15_6 0 30p
Rwp_wih_15_6 wp_wih_15_6 wcm 2g
Rwn_wih_15_6 wn_wih_15_6 wcm 2g
Cwp_who_6_0 wp_who_6_0 0 30p
Cwn_who_6_0 wn_who_6_0 0 30p
Rwp_who_6_0 wp_who_6_0 wcm 2g
Rwn_who_6_0 wn_who_6_0 wcm 2g
Cwp_who_6_1 wp_who_6_1 0 30p
Cwn_who_6_1 wn_who_6_1 0 30p
Rwp_who_6_1 wp_who_6_1 wcm 2g
Rwn_who_6_1 wn_who_6_1 wcm 2g
Cwp_wih_0_7 wp_wih_0_7 0 30p
Cwn_wih_0_7 wn_wih_0_7 0 30p
Rwp_wih_0_7 wp_wih_0_7 wcm 2g
Rwn_wih_0_7 wn_wih_0_7 wcm 2g
Cwp_wih_1_7 wp_wih_1_7 0 30p
Cwn_wih_1_7 wn_wih_1_7 0 30p
Rwp_wih_1_7 wp_wih_1_7 wcm 2g
Rwn_wih_1_7 wn_wih_1_7 wcm 2g
Cwp_wih_2_7 wp_wih_2_7 0 30p
Cwn_wih_2_7 wn_wih_2_7 0 30p
Rwp_wih_2_7 wp_wih_2_7 wcm 2g
Rwn_wih_2_7 wn_wih_2_7 wcm 2g
Cwp_wih_3_7 wp_wih_3_7 0 30p
Cwn_wih_3_7 wn_wih_3_7 0 30p
Rwp_wih_3_7 wp_wih_3_7 wcm 2g
Rwn_wih_3_7 wn_wih_3_7 wcm 2g
Cwp_wih_4_7 wp_wih_4_7 0 30p
Cwn_wih_4_7 wn_wih_4_7 0 30p
Rwp_wih_4_7 wp_wih_4_7 wcm 2g
Rwn_wih_4_7 wn_wih_4_7 wcm 2g
Cwp_wih_5_7 wp_wih_5_7 0 30p
Cwn_wih_5_7 wn_wih_5_7 0 30p
Rwp_wih_5_7 wp_wih_5_7 wcm 2g
Rwn_wih_5_7 wn_wih_5_7 wcm 2g
Cwp_wih_6_7 wp_wih_6_7 0 30p
Cwn_wih_6_7 wn_wih_6_7 0 30p
Rwp_wih_6_7 wp_wih_6_7 wcm 2g
Rwn_wih_6_7 wn_wih_6_7 wcm 2g
Cwp_wih_7_7 wp_wih_7_7 0 30p
Cwn_wih_7_7 wn_wih_7_7 0 30p
Rwp_wih_7_7 wp_wih_7_7 wcm 2g
Rwn_wih_7_7 wn_wih_7_7 wcm 2g
Cwp_wih_8_7 wp_wih_8_7 0 30p
Cwn_wih_8_7 wn_wih_8_7 0 30p
Rwp_wih_8_7 wp_wih_8_7 wcm 2g
Rwn_wih_8_7 wn_wih_8_7 wcm 2g
Cwp_wih_9_7 wp_wih_9_7 0 30p
Cwn_wih_9_7 wn_wih_9_7 0 30p
Rwp_wih_9_7 wp_wih_9_7 wcm 2g
Rwn_wih_9_7 wn_wih_9_7 wcm 2g
Cwp_wih_10_7 wp_wih_10_7 0 30p
Cwn_wih_10_7 wn_wih_10_7 0 30p
Rwp_wih_10_7 wp_wih_10_7 wcm 2g
Rwn_wih_10_7 wn_wih_10_7 wcm 2g
Cwp_wih_11_7 wp_wih_11_7 0 30p
Cwn_wih_11_7 wn_wih_11_7 0 30p
Rwp_wih_11_7 wp_wih_11_7 wcm 2g
Rwn_wih_11_7 wn_wih_11_7 wcm 2g
Cwp_wih_12_7 wp_wih_12_7 0 30p
Cwn_wih_12_7 wn_wih_12_7 0 30p
Rwp_wih_12_7 wp_wih_12_7 wcm 2g
Rwn_wih_12_7 wn_wih_12_7 wcm 2g
Cwp_wih_13_7 wp_wih_13_7 0 30p
Cwn_wih_13_7 wn_wih_13_7 0 30p
Rwp_wih_13_7 wp_wih_13_7 wcm 2g
Rwn_wih_13_7 wn_wih_13_7 wcm 2g
Cwp_wih_14_7 wp_wih_14_7 0 30p
Cwn_wih_14_7 wn_wih_14_7 0 30p
Rwp_wih_14_7 wp_wih_14_7 wcm 2g
Rwn_wih_14_7 wn_wih_14_7 wcm 2g
Cwp_wih_15_7 wp_wih_15_7 0 30p
Cwn_wih_15_7 wn_wih_15_7 0 30p
Rwp_wih_15_7 wp_wih_15_7 wcm 2g
Rwn_wih_15_7 wn_wih_15_7 wcm 2g
Cwp_who_7_0 wp_who_7_0 0 30p
Cwn_who_7_0 wn_who_7_0 0 30p
Rwp_who_7_0 wp_who_7_0 wcm 2g
Rwn_who_7_0 wn_who_7_0 wcm 2g
Cwp_who_7_1 wp_who_7_1 0 30p
Cwn_who_7_1 wn_who_7_1 0 30p
Rwp_who_7_1 wp_who_7_1 wcm 2g
Rwn_who_7_1 wn_who_7_1 wcm 2g
Xcm_mh0 mhp0 mhn0 vdd cmld
Xcm_xh0 xhp0 xhn0 vdd cmld
Rnd_mh0 mhp0 mhn0 20k
Rnd_xh0 xhp0 xhn0 20k
Cxhp0 xhp0 0 0.4p
Cxhn0 xhn0 0 0.4p
X_ihm_0_0 a_xp0 a_xn0 wp_wih_0_0 wn_wih_0_0 mhp0 mhn0 vdd vbsyn gsyn
X_ihx_0_0 a_xp0 a_xn0 wp_wih_0_0 wn_wih_0_0 xhp0 xhn0 vdd vbsyn gsyn
X_ihm_1_0 a_xp1 a_xn1 wp_wih_1_0 wn_wih_1_0 mhp0 mhn0 vdd vbsyn gsyn
X_ihx_1_0 a_xp1 a_xn1 wp_wih_1_0 wn_wih_1_0 xhp0 xhn0 vdd vbsyn gsyn
X_ihm_2_0 a_xp2 a_xn2 wp_wih_2_0 wn_wih_2_0 mhp0 mhn0 vdd vbsyn gsyn
X_ihx_2_0 a_xp2 a_xn2 wp_wih_2_0 wn_wih_2_0 xhp0 xhn0 vdd vbsyn gsyn
X_ihm_3_0 a_xp3 a_xn3 wp_wih_3_0 wn_wih_3_0 mhp0 mhn0 vdd vbsyn gsyn
X_ihx_3_0 a_xp3 a_xn3 wp_wih_3_0 wn_wih_3_0 xhp0 xhn0 vdd vbsyn gsyn
X_ihm_4_0 a_xp4 a_xn4 wp_wih_4_0 wn_wih_4_0 mhp0 mhn0 vdd vbsyn gsyn
X_ihx_4_0 a_xp4 a_xn4 wp_wih_4_0 wn_wih_4_0 xhp0 xhn0 vdd vbsyn gsyn
X_ihm_5_0 a_xp5 a_xn5 wp_wih_5_0 wn_wih_5_0 mhp0 mhn0 vdd vbsyn gsyn
X_ihx_5_0 a_xp5 a_xn5 wp_wih_5_0 wn_wih_5_0 xhp0 xhn0 vdd vbsyn gsyn
X_ihm_6_0 a_xp6 a_xn6 wp_wih_6_0 wn_wih_6_0 mhp0 mhn0 vdd vbsyn gsyn
X_ihx_6_0 a_xp6 a_xn6 wp_wih_6_0 wn_wih_6_0 xhp0 xhn0 vdd vbsyn gsyn
X_ihm_7_0 a_xp7 a_xn7 wp_wih_7_0 wn_wih_7_0 mhp0 mhn0 vdd vbsyn gsyn
X_ihx_7_0 a_xp7 a_xn7 wp_wih_7_0 wn_wih_7_0 xhp0 xhn0 vdd vbsyn gsyn
X_ihm_8_0 a_xp8 a_xn8 wp_wih_8_0 wn_wih_8_0 mhp0 mhn0 vdd vbsyn gsyn
X_ihx_8_0 a_xp8 a_xn8 wp_wih_8_0 wn_wih_8_0 xhp0 xhn0 vdd vbsyn gsyn
X_ihm_9_0 a_xp9 a_xn9 wp_wih_9_0 wn_wih_9_0 mhp0 mhn0 vdd vbsyn gsyn
X_ihx_9_0 a_xp9 a_xn9 wp_wih_9_0 wn_wih_9_0 xhp0 xhn0 vdd vbsyn gsyn
X_ihm_10_0 a_xp10 a_xn10 wp_wih_10_0 wn_wih_10_0 mhp0 mhn0 vdd vbsyn gsyn
X_ihx_10_0 a_xp10 a_xn10 wp_wih_10_0 wn_wih_10_0 xhp0 xhn0 vdd vbsyn gsyn
X_ihm_11_0 a_xp11 a_xn11 wp_wih_11_0 wn_wih_11_0 mhp0 mhn0 vdd vbsyn gsyn
X_ihx_11_0 a_xp11 a_xn11 wp_wih_11_0 wn_wih_11_0 xhp0 xhn0 vdd vbsyn gsyn
X_ihm_12_0 a_xp12 a_xn12 wp_wih_12_0 wn_wih_12_0 mhp0 mhn0 vdd vbsyn gsyn
X_ihx_12_0 a_xp12 a_xn12 wp_wih_12_0 wn_wih_12_0 xhp0 xhn0 vdd vbsyn gsyn
X_ihm_13_0 a_xp13 a_xn13 wp_wih_13_0 wn_wih_13_0 mhp0 mhn0 vdd vbsyn gsyn
X_ihx_13_0 a_xp13 a_xn13 wp_wih_13_0 wn_wih_13_0 xhp0 xhn0 vdd vbsyn gsyn
X_ihm_14_0 a_xp14 a_xn14 wp_wih_14_0 wn_wih_14_0 mhp0 mhn0 vdd vbsyn gsyn
X_ihx_14_0 a_xp14 a_xn14 wp_wih_14_0 wn_wih_14_0 xhp0 xhn0 vdd vbsyn gsyn
X_ihm_15_0 a_xp15 a_xn15 wp_wih_15_0 wn_wih_15_0 mhp0 mhn0 vdd vbsyn gsyn
X_ihx_15_0 a_xp15 a_xn15 wp_wih_15_0 wn_wih_15_0 xhp0 xhn0 vdd vbsyn gsyn
X_bk_0_0 eop0 eon0 wp_who_0_0 wn_who_0_0 xhp0 xhn0 vdd vbsyn gsyn
X_bk_0_1 eop1 eon1 wp_who_0_1 wn_who_0_1 xhp0 xhn0 vdd vbsyn gsyn
Xn0 xhp0 xhn0 ahp0 ahn0 vdd vbneu dneuron
Xeh0 xhp0 xhn0 mhp0 mhn0 ehp0 ehn0 vdd gm esub
Xcm_mh1 mhp1 mhn1 vdd cmld
Xcm_xh1 xhp1 xhn1 vdd cmld
Rnd_mh1 mhp1 mhn1 20k
Rnd_xh1 xhp1 xhn1 20k
Cxhp1 xhp1 0 0.4p
Cxhn1 xhn1 0 0.4p
X_ihm_0_1 a_xp0 a_xn0 wp_wih_0_1 wn_wih_0_1 mhp1 mhn1 vdd vbsyn gsyn
X_ihx_0_1 a_xp0 a_xn0 wp_wih_0_1 wn_wih_0_1 xhp1 xhn1 vdd vbsyn gsyn
X_ihm_1_1 a_xp1 a_xn1 wp_wih_1_1 wn_wih_1_1 mhp1 mhn1 vdd vbsyn gsyn
X_ihx_1_1 a_xp1 a_xn1 wp_wih_1_1 wn_wih_1_1 xhp1 xhn1 vdd vbsyn gsyn
X_ihm_2_1 a_xp2 a_xn2 wp_wih_2_1 wn_wih_2_1 mhp1 mhn1 vdd vbsyn gsyn
X_ihx_2_1 a_xp2 a_xn2 wp_wih_2_1 wn_wih_2_1 xhp1 xhn1 vdd vbsyn gsyn
X_ihm_3_1 a_xp3 a_xn3 wp_wih_3_1 wn_wih_3_1 mhp1 mhn1 vdd vbsyn gsyn
X_ihx_3_1 a_xp3 a_xn3 wp_wih_3_1 wn_wih_3_1 xhp1 xhn1 vdd vbsyn gsyn
X_ihm_4_1 a_xp4 a_xn4 wp_wih_4_1 wn_wih_4_1 mhp1 mhn1 vdd vbsyn gsyn
X_ihx_4_1 a_xp4 a_xn4 wp_wih_4_1 wn_wih_4_1 xhp1 xhn1 vdd vbsyn gsyn
X_ihm_5_1 a_xp5 a_xn5 wp_wih_5_1 wn_wih_5_1 mhp1 mhn1 vdd vbsyn gsyn
X_ihx_5_1 a_xp5 a_xn5 wp_wih_5_1 wn_wih_5_1 xhp1 xhn1 vdd vbsyn gsyn
X_ihm_6_1 a_xp6 a_xn6 wp_wih_6_1 wn_wih_6_1 mhp1 mhn1 vdd vbsyn gsyn
X_ihx_6_1 a_xp6 a_xn6 wp_wih_6_1 wn_wih_6_1 xhp1 xhn1 vdd vbsyn gsyn
X_ihm_7_1 a_xp7 a_xn7 wp_wih_7_1 wn_wih_7_1 mhp1 mhn1 vdd vbsyn gsyn
X_ihx_7_1 a_xp7 a_xn7 wp_wih_7_1 wn_wih_7_1 xhp1 xhn1 vdd vbsyn gsyn
X_ihm_8_1 a_xp8 a_xn8 wp_wih_8_1 wn_wih_8_1 mhp1 mhn1 vdd vbsyn gsyn
X_ihx_8_1 a_xp8 a_xn8 wp_wih_8_1 wn_wih_8_1 xhp1 xhn1 vdd vbsyn gsyn
X_ihm_9_1 a_xp9 a_xn9 wp_wih_9_1 wn_wih_9_1 mhp1 mhn1 vdd vbsyn gsyn
X_ihx_9_1 a_xp9 a_xn9 wp_wih_9_1 wn_wih_9_1 xhp1 xhn1 vdd vbsyn gsyn
X_ihm_10_1 a_xp10 a_xn10 wp_wih_10_1 wn_wih_10_1 mhp1 mhn1 vdd vbsyn gsyn
X_ihx_10_1 a_xp10 a_xn10 wp_wih_10_1 wn_wih_10_1 xhp1 xhn1 vdd vbsyn gsyn
X_ihm_11_1 a_xp11 a_xn11 wp_wih_11_1 wn_wih_11_1 mhp1 mhn1 vdd vbsyn gsyn
X_ihx_11_1 a_xp11 a_xn11 wp_wih_11_1 wn_wih_11_1 xhp1 xhn1 vdd vbsyn gsyn
X_ihm_12_1 a_xp12 a_xn12 wp_wih_12_1 wn_wih_12_1 mhp1 mhn1 vdd vbsyn gsyn
X_ihx_12_1 a_xp12 a_xn12 wp_wih_12_1 wn_wih_12_1 xhp1 xhn1 vdd vbsyn gsyn
X_ihm_13_1 a_xp13 a_xn13 wp_wih_13_1 wn_wih_13_1 mhp1 mhn1 vdd vbsyn gsyn
X_ihx_13_1 a_xp13 a_xn13 wp_wih_13_1 wn_wih_13_1 xhp1 xhn1 vdd vbsyn gsyn
X_ihm_14_1 a_xp14 a_xn14 wp_wih_14_1 wn_wih_14_1 mhp1 mhn1 vdd vbsyn gsyn
X_ihx_14_1 a_xp14 a_xn14 wp_wih_14_1 wn_wih_14_1 xhp1 xhn1 vdd vbsyn gsyn
X_ihm_15_1 a_xp15 a_xn15 wp_wih_15_1 wn_wih_15_1 mhp1 mhn1 vdd vbsyn gsyn
X_ihx_15_1 a_xp15 a_xn15 wp_wih_15_1 wn_wih_15_1 xhp1 xhn1 vdd vbsyn gsyn
X_bk_1_0 eop0 eon0 wp_who_1_0 wn_who_1_0 xhp1 xhn1 vdd vbsyn gsyn
X_bk_1_1 eop1 eon1 wp_who_1_1 wn_who_1_1 xhp1 xhn1 vdd vbsyn gsyn
Xn1 xhp1 xhn1 ahp1 ahn1 vdd vbneu dneuron
Xeh1 xhp1 xhn1 mhp1 mhn1 ehp1 ehn1 vdd gm esub
Xcm_mh2 mhp2 mhn2 vdd cmld
Xcm_xh2 xhp2 xhn2 vdd cmld
Rnd_mh2 mhp2 mhn2 20k
Rnd_xh2 xhp2 xhn2 20k
Cxhp2 xhp2 0 0.4p
Cxhn2 xhn2 0 0.4p
X_ihm_0_2 a_xp0 a_xn0 wp_wih_0_2 wn_wih_0_2 mhp2 mhn2 vdd vbsyn gsyn
X_ihx_0_2 a_xp0 a_xn0 wp_wih_0_2 wn_wih_0_2 xhp2 xhn2 vdd vbsyn gsyn
X_ihm_1_2 a_xp1 a_xn1 wp_wih_1_2 wn_wih_1_2 mhp2 mhn2 vdd vbsyn gsyn
X_ihx_1_2 a_xp1 a_xn1 wp_wih_1_2 wn_wih_1_2 xhp2 xhn2 vdd vbsyn gsyn
X_ihm_2_2 a_xp2 a_xn2 wp_wih_2_2 wn_wih_2_2 mhp2 mhn2 vdd vbsyn gsyn
X_ihx_2_2 a_xp2 a_xn2 wp_wih_2_2 wn_wih_2_2 xhp2 xhn2 vdd vbsyn gsyn
X_ihm_3_2 a_xp3 a_xn3 wp_wih_3_2 wn_wih_3_2 mhp2 mhn2 vdd vbsyn gsyn
X_ihx_3_2 a_xp3 a_xn3 wp_wih_3_2 wn_wih_3_2 xhp2 xhn2 vdd vbsyn gsyn
X_ihm_4_2 a_xp4 a_xn4 wp_wih_4_2 wn_wih_4_2 mhp2 mhn2 vdd vbsyn gsyn
X_ihx_4_2 a_xp4 a_xn4 wp_wih_4_2 wn_wih_4_2 xhp2 xhn2 vdd vbsyn gsyn
X_ihm_5_2 a_xp5 a_xn5 wp_wih_5_2 wn_wih_5_2 mhp2 mhn2 vdd vbsyn gsyn
X_ihx_5_2 a_xp5 a_xn5 wp_wih_5_2 wn_wih_5_2 xhp2 xhn2 vdd vbsyn gsyn
X_ihm_6_2 a_xp6 a_xn6 wp_wih_6_2 wn_wih_6_2 mhp2 mhn2 vdd vbsyn gsyn
X_ihx_6_2 a_xp6 a_xn6 wp_wih_6_2 wn_wih_6_2 xhp2 xhn2 vdd vbsyn gsyn
X_ihm_7_2 a_xp7 a_xn7 wp_wih_7_2 wn_wih_7_2 mhp2 mhn2 vdd vbsyn gsyn
X_ihx_7_2 a_xp7 a_xn7 wp_wih_7_2 wn_wih_7_2 xhp2 xhn2 vdd vbsyn gsyn
X_ihm_8_2 a_xp8 a_xn8 wp_wih_8_2 wn_wih_8_2 mhp2 mhn2 vdd vbsyn gsyn
X_ihx_8_2 a_xp8 a_xn8 wp_wih_8_2 wn_wih_8_2 xhp2 xhn2 vdd vbsyn gsyn
X_ihm_9_2 a_xp9 a_xn9 wp_wih_9_2 wn_wih_9_2 mhp2 mhn2 vdd vbsyn gsyn
X_ihx_9_2 a_xp9 a_xn9 wp_wih_9_2 wn_wih_9_2 xhp2 xhn2 vdd vbsyn gsyn
X_ihm_10_2 a_xp10 a_xn10 wp_wih_10_2 wn_wih_10_2 mhp2 mhn2 vdd vbsyn gsyn
X_ihx_10_2 a_xp10 a_xn10 wp_wih_10_2 wn_wih_10_2 xhp2 xhn2 vdd vbsyn gsyn
X_ihm_11_2 a_xp11 a_xn11 wp_wih_11_2 wn_wih_11_2 mhp2 mhn2 vdd vbsyn gsyn
X_ihx_11_2 a_xp11 a_xn11 wp_wih_11_2 wn_wih_11_2 xhp2 xhn2 vdd vbsyn gsyn
X_ihm_12_2 a_xp12 a_xn12 wp_wih_12_2 wn_wih_12_2 mhp2 mhn2 vdd vbsyn gsyn
X_ihx_12_2 a_xp12 a_xn12 wp_wih_12_2 wn_wih_12_2 xhp2 xhn2 vdd vbsyn gsyn
X_ihm_13_2 a_xp13 a_xn13 wp_wih_13_2 wn_wih_13_2 mhp2 mhn2 vdd vbsyn gsyn
X_ihx_13_2 a_xp13 a_xn13 wp_wih_13_2 wn_wih_13_2 xhp2 xhn2 vdd vbsyn gsyn
X_ihm_14_2 a_xp14 a_xn14 wp_wih_14_2 wn_wih_14_2 mhp2 mhn2 vdd vbsyn gsyn
X_ihx_14_2 a_xp14 a_xn14 wp_wih_14_2 wn_wih_14_2 xhp2 xhn2 vdd vbsyn gsyn
X_ihm_15_2 a_xp15 a_xn15 wp_wih_15_2 wn_wih_15_2 mhp2 mhn2 vdd vbsyn gsyn
X_ihx_15_2 a_xp15 a_xn15 wp_wih_15_2 wn_wih_15_2 xhp2 xhn2 vdd vbsyn gsyn
X_bk_2_0 eop0 eon0 wp_who_2_0 wn_who_2_0 xhp2 xhn2 vdd vbsyn gsyn
X_bk_2_1 eop1 eon1 wp_who_2_1 wn_who_2_1 xhp2 xhn2 vdd vbsyn gsyn
Xn2 xhp2 xhn2 ahp2 ahn2 vdd vbneu dneuron
Xeh2 xhp2 xhn2 mhp2 mhn2 ehp2 ehn2 vdd gm esub
Xcm_mh3 mhp3 mhn3 vdd cmld
Xcm_xh3 xhp3 xhn3 vdd cmld
Rnd_mh3 mhp3 mhn3 20k
Rnd_xh3 xhp3 xhn3 20k
Cxhp3 xhp3 0 0.4p
Cxhn3 xhn3 0 0.4p
X_ihm_0_3 a_xp0 a_xn0 wp_wih_0_3 wn_wih_0_3 mhp3 mhn3 vdd vbsyn gsyn
X_ihx_0_3 a_xp0 a_xn0 wp_wih_0_3 wn_wih_0_3 xhp3 xhn3 vdd vbsyn gsyn
X_ihm_1_3 a_xp1 a_xn1 wp_wih_1_3 wn_wih_1_3 mhp3 mhn3 vdd vbsyn gsyn
X_ihx_1_3 a_xp1 a_xn1 wp_wih_1_3 wn_wih_1_3 xhp3 xhn3 vdd vbsyn gsyn
X_ihm_2_3 a_xp2 a_xn2 wp_wih_2_3 wn_wih_2_3 mhp3 mhn3 vdd vbsyn gsyn
X_ihx_2_3 a_xp2 a_xn2 wp_wih_2_3 wn_wih_2_3 xhp3 xhn3 vdd vbsyn gsyn
X_ihm_3_3 a_xp3 a_xn3 wp_wih_3_3 wn_wih_3_3 mhp3 mhn3 vdd vbsyn gsyn
X_ihx_3_3 a_xp3 a_xn3 wp_wih_3_3 wn_wih_3_3 xhp3 xhn3 vdd vbsyn gsyn
X_ihm_4_3 a_xp4 a_xn4 wp_wih_4_3 wn_wih_4_3 mhp3 mhn3 vdd vbsyn gsyn
X_ihx_4_3 a_xp4 a_xn4 wp_wih_4_3 wn_wih_4_3 xhp3 xhn3 vdd vbsyn gsyn
X_ihm_5_3 a_xp5 a_xn5 wp_wih_5_3 wn_wih_5_3 mhp3 mhn3 vdd vbsyn gsyn
X_ihx_5_3 a_xp5 a_xn5 wp_wih_5_3 wn_wih_5_3 xhp3 xhn3 vdd vbsyn gsyn
X_ihm_6_3 a_xp6 a_xn6 wp_wih_6_3 wn_wih_6_3 mhp3 mhn3 vdd vbsyn gsyn
X_ihx_6_3 a_xp6 a_xn6 wp_wih_6_3 wn_wih_6_3 xhp3 xhn3 vdd vbsyn gsyn
X_ihm_7_3 a_xp7 a_xn7 wp_wih_7_3 wn_wih_7_3 mhp3 mhn3 vdd vbsyn gsyn
X_ihx_7_3 a_xp7 a_xn7 wp_wih_7_3 wn_wih_7_3 xhp3 xhn3 vdd vbsyn gsyn
X_ihm_8_3 a_xp8 a_xn8 wp_wih_8_3 wn_wih_8_3 mhp3 mhn3 vdd vbsyn gsyn
X_ihx_8_3 a_xp8 a_xn8 wp_wih_8_3 wn_wih_8_3 xhp3 xhn3 vdd vbsyn gsyn
X_ihm_9_3 a_xp9 a_xn9 wp_wih_9_3 wn_wih_9_3 mhp3 mhn3 vdd vbsyn gsyn
X_ihx_9_3 a_xp9 a_xn9 wp_wih_9_3 wn_wih_9_3 xhp3 xhn3 vdd vbsyn gsyn
X_ihm_10_3 a_xp10 a_xn10 wp_wih_10_3 wn_wih_10_3 mhp3 mhn3 vdd vbsyn gsyn
X_ihx_10_3 a_xp10 a_xn10 wp_wih_10_3 wn_wih_10_3 xhp3 xhn3 vdd vbsyn gsyn
X_ihm_11_3 a_xp11 a_xn11 wp_wih_11_3 wn_wih_11_3 mhp3 mhn3 vdd vbsyn gsyn
X_ihx_11_3 a_xp11 a_xn11 wp_wih_11_3 wn_wih_11_3 xhp3 xhn3 vdd vbsyn gsyn
X_ihm_12_3 a_xp12 a_xn12 wp_wih_12_3 wn_wih_12_3 mhp3 mhn3 vdd vbsyn gsyn
X_ihx_12_3 a_xp12 a_xn12 wp_wih_12_3 wn_wih_12_3 xhp3 xhn3 vdd vbsyn gsyn
X_ihm_13_3 a_xp13 a_xn13 wp_wih_13_3 wn_wih_13_3 mhp3 mhn3 vdd vbsyn gsyn
X_ihx_13_3 a_xp13 a_xn13 wp_wih_13_3 wn_wih_13_3 xhp3 xhn3 vdd vbsyn gsyn
X_ihm_14_3 a_xp14 a_xn14 wp_wih_14_3 wn_wih_14_3 mhp3 mhn3 vdd vbsyn gsyn
X_ihx_14_3 a_xp14 a_xn14 wp_wih_14_3 wn_wih_14_3 xhp3 xhn3 vdd vbsyn gsyn
X_ihm_15_3 a_xp15 a_xn15 wp_wih_15_3 wn_wih_15_3 mhp3 mhn3 vdd vbsyn gsyn
X_ihx_15_3 a_xp15 a_xn15 wp_wih_15_3 wn_wih_15_3 xhp3 xhn3 vdd vbsyn gsyn
X_bk_3_0 eop0 eon0 wp_who_3_0 wn_who_3_0 xhp3 xhn3 vdd vbsyn gsyn
X_bk_3_1 eop1 eon1 wp_who_3_1 wn_who_3_1 xhp3 xhn3 vdd vbsyn gsyn
Xn3 xhp3 xhn3 ahp3 ahn3 vdd vbneu dneuron
Xeh3 xhp3 xhn3 mhp3 mhn3 ehp3 ehn3 vdd gm esub
Xcm_mh4 mhp4 mhn4 vdd cmld
Xcm_xh4 xhp4 xhn4 vdd cmld
Rnd_mh4 mhp4 mhn4 20k
Rnd_xh4 xhp4 xhn4 20k
Cxhp4 xhp4 0 0.4p
Cxhn4 xhn4 0 0.4p
X_ihm_0_4 a_xp0 a_xn0 wp_wih_0_4 wn_wih_0_4 mhp4 mhn4 vdd vbsyn gsyn
X_ihx_0_4 a_xp0 a_xn0 wp_wih_0_4 wn_wih_0_4 xhp4 xhn4 vdd vbsyn gsyn
X_ihm_1_4 a_xp1 a_xn1 wp_wih_1_4 wn_wih_1_4 mhp4 mhn4 vdd vbsyn gsyn
X_ihx_1_4 a_xp1 a_xn1 wp_wih_1_4 wn_wih_1_4 xhp4 xhn4 vdd vbsyn gsyn
X_ihm_2_4 a_xp2 a_xn2 wp_wih_2_4 wn_wih_2_4 mhp4 mhn4 vdd vbsyn gsyn
X_ihx_2_4 a_xp2 a_xn2 wp_wih_2_4 wn_wih_2_4 xhp4 xhn4 vdd vbsyn gsyn
X_ihm_3_4 a_xp3 a_xn3 wp_wih_3_4 wn_wih_3_4 mhp4 mhn4 vdd vbsyn gsyn
X_ihx_3_4 a_xp3 a_xn3 wp_wih_3_4 wn_wih_3_4 xhp4 xhn4 vdd vbsyn gsyn
X_ihm_4_4 a_xp4 a_xn4 wp_wih_4_4 wn_wih_4_4 mhp4 mhn4 vdd vbsyn gsyn
X_ihx_4_4 a_xp4 a_xn4 wp_wih_4_4 wn_wih_4_4 xhp4 xhn4 vdd vbsyn gsyn
X_ihm_5_4 a_xp5 a_xn5 wp_wih_5_4 wn_wih_5_4 mhp4 mhn4 vdd vbsyn gsyn
X_ihx_5_4 a_xp5 a_xn5 wp_wih_5_4 wn_wih_5_4 xhp4 xhn4 vdd vbsyn gsyn
X_ihm_6_4 a_xp6 a_xn6 wp_wih_6_4 wn_wih_6_4 mhp4 mhn4 vdd vbsyn gsyn
X_ihx_6_4 a_xp6 a_xn6 wp_wih_6_4 wn_wih_6_4 xhp4 xhn4 vdd vbsyn gsyn
X_ihm_7_4 a_xp7 a_xn7 wp_wih_7_4 wn_wih_7_4 mhp4 mhn4 vdd vbsyn gsyn
X_ihx_7_4 a_xp7 a_xn7 wp_wih_7_4 wn_wih_7_4 xhp4 xhn4 vdd vbsyn gsyn
X_ihm_8_4 a_xp8 a_xn8 wp_wih_8_4 wn_wih_8_4 mhp4 mhn4 vdd vbsyn gsyn
X_ihx_8_4 a_xp8 a_xn8 wp_wih_8_4 wn_wih_8_4 xhp4 xhn4 vdd vbsyn gsyn
X_ihm_9_4 a_xp9 a_xn9 wp_wih_9_4 wn_wih_9_4 mhp4 mhn4 vdd vbsyn gsyn
X_ihx_9_4 a_xp9 a_xn9 wp_wih_9_4 wn_wih_9_4 xhp4 xhn4 vdd vbsyn gsyn
X_ihm_10_4 a_xp10 a_xn10 wp_wih_10_4 wn_wih_10_4 mhp4 mhn4 vdd vbsyn gsyn
X_ihx_10_4 a_xp10 a_xn10 wp_wih_10_4 wn_wih_10_4 xhp4 xhn4 vdd vbsyn gsyn
X_ihm_11_4 a_xp11 a_xn11 wp_wih_11_4 wn_wih_11_4 mhp4 mhn4 vdd vbsyn gsyn
X_ihx_11_4 a_xp11 a_xn11 wp_wih_11_4 wn_wih_11_4 xhp4 xhn4 vdd vbsyn gsyn
X_ihm_12_4 a_xp12 a_xn12 wp_wih_12_4 wn_wih_12_4 mhp4 mhn4 vdd vbsyn gsyn
X_ihx_12_4 a_xp12 a_xn12 wp_wih_12_4 wn_wih_12_4 xhp4 xhn4 vdd vbsyn gsyn
X_ihm_13_4 a_xp13 a_xn13 wp_wih_13_4 wn_wih_13_4 mhp4 mhn4 vdd vbsyn gsyn
X_ihx_13_4 a_xp13 a_xn13 wp_wih_13_4 wn_wih_13_4 xhp4 xhn4 vdd vbsyn gsyn
X_ihm_14_4 a_xp14 a_xn14 wp_wih_14_4 wn_wih_14_4 mhp4 mhn4 vdd vbsyn gsyn
X_ihx_14_4 a_xp14 a_xn14 wp_wih_14_4 wn_wih_14_4 xhp4 xhn4 vdd vbsyn gsyn
X_ihm_15_4 a_xp15 a_xn15 wp_wih_15_4 wn_wih_15_4 mhp4 mhn4 vdd vbsyn gsyn
X_ihx_15_4 a_xp15 a_xn15 wp_wih_15_4 wn_wih_15_4 xhp4 xhn4 vdd vbsyn gsyn
X_bk_4_0 eop0 eon0 wp_who_4_0 wn_who_4_0 xhp4 xhn4 vdd vbsyn gsyn
X_bk_4_1 eop1 eon1 wp_who_4_1 wn_who_4_1 xhp4 xhn4 vdd vbsyn gsyn
Xn4 xhp4 xhn4 ahp4 ahn4 vdd vbneu dneuron
Xeh4 xhp4 xhn4 mhp4 mhn4 ehp4 ehn4 vdd gm esub
Xcm_mh5 mhp5 mhn5 vdd cmld
Xcm_xh5 xhp5 xhn5 vdd cmld
Rnd_mh5 mhp5 mhn5 20k
Rnd_xh5 xhp5 xhn5 20k
Cxhp5 xhp5 0 0.4p
Cxhn5 xhn5 0 0.4p
X_ihm_0_5 a_xp0 a_xn0 wp_wih_0_5 wn_wih_0_5 mhp5 mhn5 vdd vbsyn gsyn
X_ihx_0_5 a_xp0 a_xn0 wp_wih_0_5 wn_wih_0_5 xhp5 xhn5 vdd vbsyn gsyn
X_ihm_1_5 a_xp1 a_xn1 wp_wih_1_5 wn_wih_1_5 mhp5 mhn5 vdd vbsyn gsyn
X_ihx_1_5 a_xp1 a_xn1 wp_wih_1_5 wn_wih_1_5 xhp5 xhn5 vdd vbsyn gsyn
X_ihm_2_5 a_xp2 a_xn2 wp_wih_2_5 wn_wih_2_5 mhp5 mhn5 vdd vbsyn gsyn
X_ihx_2_5 a_xp2 a_xn2 wp_wih_2_5 wn_wih_2_5 xhp5 xhn5 vdd vbsyn gsyn
X_ihm_3_5 a_xp3 a_xn3 wp_wih_3_5 wn_wih_3_5 mhp5 mhn5 vdd vbsyn gsyn
X_ihx_3_5 a_xp3 a_xn3 wp_wih_3_5 wn_wih_3_5 xhp5 xhn5 vdd vbsyn gsyn
X_ihm_4_5 a_xp4 a_xn4 wp_wih_4_5 wn_wih_4_5 mhp5 mhn5 vdd vbsyn gsyn
X_ihx_4_5 a_xp4 a_xn4 wp_wih_4_5 wn_wih_4_5 xhp5 xhn5 vdd vbsyn gsyn
X_ihm_5_5 a_xp5 a_xn5 wp_wih_5_5 wn_wih_5_5 mhp5 mhn5 vdd vbsyn gsyn
X_ihx_5_5 a_xp5 a_xn5 wp_wih_5_5 wn_wih_5_5 xhp5 xhn5 vdd vbsyn gsyn
X_ihm_6_5 a_xp6 a_xn6 wp_wih_6_5 wn_wih_6_5 mhp5 mhn5 vdd vbsyn gsyn
X_ihx_6_5 a_xp6 a_xn6 wp_wih_6_5 wn_wih_6_5 xhp5 xhn5 vdd vbsyn gsyn
X_ihm_7_5 a_xp7 a_xn7 wp_wih_7_5 wn_wih_7_5 mhp5 mhn5 vdd vbsyn gsyn
X_ihx_7_5 a_xp7 a_xn7 wp_wih_7_5 wn_wih_7_5 xhp5 xhn5 vdd vbsyn gsyn
X_ihm_8_5 a_xp8 a_xn8 wp_wih_8_5 wn_wih_8_5 mhp5 mhn5 vdd vbsyn gsyn
X_ihx_8_5 a_xp8 a_xn8 wp_wih_8_5 wn_wih_8_5 xhp5 xhn5 vdd vbsyn gsyn
X_ihm_9_5 a_xp9 a_xn9 wp_wih_9_5 wn_wih_9_5 mhp5 mhn5 vdd vbsyn gsyn
X_ihx_9_5 a_xp9 a_xn9 wp_wih_9_5 wn_wih_9_5 xhp5 xhn5 vdd vbsyn gsyn
X_ihm_10_5 a_xp10 a_xn10 wp_wih_10_5 wn_wih_10_5 mhp5 mhn5 vdd vbsyn gsyn
X_ihx_10_5 a_xp10 a_xn10 wp_wih_10_5 wn_wih_10_5 xhp5 xhn5 vdd vbsyn gsyn
X_ihm_11_5 a_xp11 a_xn11 wp_wih_11_5 wn_wih_11_5 mhp5 mhn5 vdd vbsyn gsyn
X_ihx_11_5 a_xp11 a_xn11 wp_wih_11_5 wn_wih_11_5 xhp5 xhn5 vdd vbsyn gsyn
X_ihm_12_5 a_xp12 a_xn12 wp_wih_12_5 wn_wih_12_5 mhp5 mhn5 vdd vbsyn gsyn
X_ihx_12_5 a_xp12 a_xn12 wp_wih_12_5 wn_wih_12_5 xhp5 xhn5 vdd vbsyn gsyn
X_ihm_13_5 a_xp13 a_xn13 wp_wih_13_5 wn_wih_13_5 mhp5 mhn5 vdd vbsyn gsyn
X_ihx_13_5 a_xp13 a_xn13 wp_wih_13_5 wn_wih_13_5 xhp5 xhn5 vdd vbsyn gsyn
X_ihm_14_5 a_xp14 a_xn14 wp_wih_14_5 wn_wih_14_5 mhp5 mhn5 vdd vbsyn gsyn
X_ihx_14_5 a_xp14 a_xn14 wp_wih_14_5 wn_wih_14_5 xhp5 xhn5 vdd vbsyn gsyn
X_ihm_15_5 a_xp15 a_xn15 wp_wih_15_5 wn_wih_15_5 mhp5 mhn5 vdd vbsyn gsyn
X_ihx_15_5 a_xp15 a_xn15 wp_wih_15_5 wn_wih_15_5 xhp5 xhn5 vdd vbsyn gsyn
X_bk_5_0 eop0 eon0 wp_who_5_0 wn_who_5_0 xhp5 xhn5 vdd vbsyn gsyn
X_bk_5_1 eop1 eon1 wp_who_5_1 wn_who_5_1 xhp5 xhn5 vdd vbsyn gsyn
Xn5 xhp5 xhn5 ahp5 ahn5 vdd vbneu dneuron
Xeh5 xhp5 xhn5 mhp5 mhn5 ehp5 ehn5 vdd gm esub
Xcm_mh6 mhp6 mhn6 vdd cmld
Xcm_xh6 xhp6 xhn6 vdd cmld
Rnd_mh6 mhp6 mhn6 20k
Rnd_xh6 xhp6 xhn6 20k
Cxhp6 xhp6 0 0.4p
Cxhn6 xhn6 0 0.4p
X_ihm_0_6 a_xp0 a_xn0 wp_wih_0_6 wn_wih_0_6 mhp6 mhn6 vdd vbsyn gsyn
X_ihx_0_6 a_xp0 a_xn0 wp_wih_0_6 wn_wih_0_6 xhp6 xhn6 vdd vbsyn gsyn
X_ihm_1_6 a_xp1 a_xn1 wp_wih_1_6 wn_wih_1_6 mhp6 mhn6 vdd vbsyn gsyn
X_ihx_1_6 a_xp1 a_xn1 wp_wih_1_6 wn_wih_1_6 xhp6 xhn6 vdd vbsyn gsyn
X_ihm_2_6 a_xp2 a_xn2 wp_wih_2_6 wn_wih_2_6 mhp6 mhn6 vdd vbsyn gsyn
X_ihx_2_6 a_xp2 a_xn2 wp_wih_2_6 wn_wih_2_6 xhp6 xhn6 vdd vbsyn gsyn
X_ihm_3_6 a_xp3 a_xn3 wp_wih_3_6 wn_wih_3_6 mhp6 mhn6 vdd vbsyn gsyn
X_ihx_3_6 a_xp3 a_xn3 wp_wih_3_6 wn_wih_3_6 xhp6 xhn6 vdd vbsyn gsyn
X_ihm_4_6 a_xp4 a_xn4 wp_wih_4_6 wn_wih_4_6 mhp6 mhn6 vdd vbsyn gsyn
X_ihx_4_6 a_xp4 a_xn4 wp_wih_4_6 wn_wih_4_6 xhp6 xhn6 vdd vbsyn gsyn
X_ihm_5_6 a_xp5 a_xn5 wp_wih_5_6 wn_wih_5_6 mhp6 mhn6 vdd vbsyn gsyn
X_ihx_5_6 a_xp5 a_xn5 wp_wih_5_6 wn_wih_5_6 xhp6 xhn6 vdd vbsyn gsyn
X_ihm_6_6 a_xp6 a_xn6 wp_wih_6_6 wn_wih_6_6 mhp6 mhn6 vdd vbsyn gsyn
X_ihx_6_6 a_xp6 a_xn6 wp_wih_6_6 wn_wih_6_6 xhp6 xhn6 vdd vbsyn gsyn
X_ihm_7_6 a_xp7 a_xn7 wp_wih_7_6 wn_wih_7_6 mhp6 mhn6 vdd vbsyn gsyn
X_ihx_7_6 a_xp7 a_xn7 wp_wih_7_6 wn_wih_7_6 xhp6 xhn6 vdd vbsyn gsyn
X_ihm_8_6 a_xp8 a_xn8 wp_wih_8_6 wn_wih_8_6 mhp6 mhn6 vdd vbsyn gsyn
X_ihx_8_6 a_xp8 a_xn8 wp_wih_8_6 wn_wih_8_6 xhp6 xhn6 vdd vbsyn gsyn
X_ihm_9_6 a_xp9 a_xn9 wp_wih_9_6 wn_wih_9_6 mhp6 mhn6 vdd vbsyn gsyn
X_ihx_9_6 a_xp9 a_xn9 wp_wih_9_6 wn_wih_9_6 xhp6 xhn6 vdd vbsyn gsyn
X_ihm_10_6 a_xp10 a_xn10 wp_wih_10_6 wn_wih_10_6 mhp6 mhn6 vdd vbsyn gsyn
X_ihx_10_6 a_xp10 a_xn10 wp_wih_10_6 wn_wih_10_6 xhp6 xhn6 vdd vbsyn gsyn
X_ihm_11_6 a_xp11 a_xn11 wp_wih_11_6 wn_wih_11_6 mhp6 mhn6 vdd vbsyn gsyn
X_ihx_11_6 a_xp11 a_xn11 wp_wih_11_6 wn_wih_11_6 xhp6 xhn6 vdd vbsyn gsyn
X_ihm_12_6 a_xp12 a_xn12 wp_wih_12_6 wn_wih_12_6 mhp6 mhn6 vdd vbsyn gsyn
X_ihx_12_6 a_xp12 a_xn12 wp_wih_12_6 wn_wih_12_6 xhp6 xhn6 vdd vbsyn gsyn
X_ihm_13_6 a_xp13 a_xn13 wp_wih_13_6 wn_wih_13_6 mhp6 mhn6 vdd vbsyn gsyn
X_ihx_13_6 a_xp13 a_xn13 wp_wih_13_6 wn_wih_13_6 xhp6 xhn6 vdd vbsyn gsyn
X_ihm_14_6 a_xp14 a_xn14 wp_wih_14_6 wn_wih_14_6 mhp6 mhn6 vdd vbsyn gsyn
X_ihx_14_6 a_xp14 a_xn14 wp_wih_14_6 wn_wih_14_6 xhp6 xhn6 vdd vbsyn gsyn
X_ihm_15_6 a_xp15 a_xn15 wp_wih_15_6 wn_wih_15_6 mhp6 mhn6 vdd vbsyn gsyn
X_ihx_15_6 a_xp15 a_xn15 wp_wih_15_6 wn_wih_15_6 xhp6 xhn6 vdd vbsyn gsyn
X_bk_6_0 eop0 eon0 wp_who_6_0 wn_who_6_0 xhp6 xhn6 vdd vbsyn gsyn
X_bk_6_1 eop1 eon1 wp_who_6_1 wn_who_6_1 xhp6 xhn6 vdd vbsyn gsyn
Xn6 xhp6 xhn6 ahp6 ahn6 vdd vbneu dneuron
Xeh6 xhp6 xhn6 mhp6 mhn6 ehp6 ehn6 vdd gm esub
Xcm_mh7 mhp7 mhn7 vdd cmld
Xcm_xh7 xhp7 xhn7 vdd cmld
Rnd_mh7 mhp7 mhn7 20k
Rnd_xh7 xhp7 xhn7 20k
Cxhp7 xhp7 0 0.4p
Cxhn7 xhn7 0 0.4p
X_ihm_0_7 a_xp0 a_xn0 wp_wih_0_7 wn_wih_0_7 mhp7 mhn7 vdd vbsyn gsyn
X_ihx_0_7 a_xp0 a_xn0 wp_wih_0_7 wn_wih_0_7 xhp7 xhn7 vdd vbsyn gsyn
X_ihm_1_7 a_xp1 a_xn1 wp_wih_1_7 wn_wih_1_7 mhp7 mhn7 vdd vbsyn gsyn
X_ihx_1_7 a_xp1 a_xn1 wp_wih_1_7 wn_wih_1_7 xhp7 xhn7 vdd vbsyn gsyn
X_ihm_2_7 a_xp2 a_xn2 wp_wih_2_7 wn_wih_2_7 mhp7 mhn7 vdd vbsyn gsyn
X_ihx_2_7 a_xp2 a_xn2 wp_wih_2_7 wn_wih_2_7 xhp7 xhn7 vdd vbsyn gsyn
X_ihm_3_7 a_xp3 a_xn3 wp_wih_3_7 wn_wih_3_7 mhp7 mhn7 vdd vbsyn gsyn
X_ihx_3_7 a_xp3 a_xn3 wp_wih_3_7 wn_wih_3_7 xhp7 xhn7 vdd vbsyn gsyn
X_ihm_4_7 a_xp4 a_xn4 wp_wih_4_7 wn_wih_4_7 mhp7 mhn7 vdd vbsyn gsyn
X_ihx_4_7 a_xp4 a_xn4 wp_wih_4_7 wn_wih_4_7 xhp7 xhn7 vdd vbsyn gsyn
X_ihm_5_7 a_xp5 a_xn5 wp_wih_5_7 wn_wih_5_7 mhp7 mhn7 vdd vbsyn gsyn
X_ihx_5_7 a_xp5 a_xn5 wp_wih_5_7 wn_wih_5_7 xhp7 xhn7 vdd vbsyn gsyn
X_ihm_6_7 a_xp6 a_xn6 wp_wih_6_7 wn_wih_6_7 mhp7 mhn7 vdd vbsyn gsyn
X_ihx_6_7 a_xp6 a_xn6 wp_wih_6_7 wn_wih_6_7 xhp7 xhn7 vdd vbsyn gsyn
X_ihm_7_7 a_xp7 a_xn7 wp_wih_7_7 wn_wih_7_7 mhp7 mhn7 vdd vbsyn gsyn
X_ihx_7_7 a_xp7 a_xn7 wp_wih_7_7 wn_wih_7_7 xhp7 xhn7 vdd vbsyn gsyn
X_ihm_8_7 a_xp8 a_xn8 wp_wih_8_7 wn_wih_8_7 mhp7 mhn7 vdd vbsyn gsyn
X_ihx_8_7 a_xp8 a_xn8 wp_wih_8_7 wn_wih_8_7 xhp7 xhn7 vdd vbsyn gsyn
X_ihm_9_7 a_xp9 a_xn9 wp_wih_9_7 wn_wih_9_7 mhp7 mhn7 vdd vbsyn gsyn
X_ihx_9_7 a_xp9 a_xn9 wp_wih_9_7 wn_wih_9_7 xhp7 xhn7 vdd vbsyn gsyn
X_ihm_10_7 a_xp10 a_xn10 wp_wih_10_7 wn_wih_10_7 mhp7 mhn7 vdd vbsyn gsyn
X_ihx_10_7 a_xp10 a_xn10 wp_wih_10_7 wn_wih_10_7 xhp7 xhn7 vdd vbsyn gsyn
X_ihm_11_7 a_xp11 a_xn11 wp_wih_11_7 wn_wih_11_7 mhp7 mhn7 vdd vbsyn gsyn
X_ihx_11_7 a_xp11 a_xn11 wp_wih_11_7 wn_wih_11_7 xhp7 xhn7 vdd vbsyn gsyn
X_ihm_12_7 a_xp12 a_xn12 wp_wih_12_7 wn_wih_12_7 mhp7 mhn7 vdd vbsyn gsyn
X_ihx_12_7 a_xp12 a_xn12 wp_wih_12_7 wn_wih_12_7 xhp7 xhn7 vdd vbsyn gsyn
X_ihm_13_7 a_xp13 a_xn13 wp_wih_13_7 wn_wih_13_7 mhp7 mhn7 vdd vbsyn gsyn
X_ihx_13_7 a_xp13 a_xn13 wp_wih_13_7 wn_wih_13_7 xhp7 xhn7 vdd vbsyn gsyn
X_ihm_14_7 a_xp14 a_xn14 wp_wih_14_7 wn_wih_14_7 mhp7 mhn7 vdd vbsyn gsyn
X_ihx_14_7 a_xp14 a_xn14 wp_wih_14_7 wn_wih_14_7 xhp7 xhn7 vdd vbsyn gsyn
X_ihm_15_7 a_xp15 a_xn15 wp_wih_15_7 wn_wih_15_7 mhp7 mhn7 vdd vbsyn gsyn
X_ihx_15_7 a_xp15 a_xn15 wp_wih_15_7 wn_wih_15_7 xhp7 xhn7 vdd vbsyn gsyn
X_bk_7_0 eop0 eon0 wp_who_7_0 wn_who_7_0 xhp7 xhn7 vdd vbsyn gsyn
X_bk_7_1 eop1 eon1 wp_who_7_1 wn_who_7_1 xhp7 xhn7 vdd vbsyn gsyn
Xn7 xhp7 xhn7 ahp7 ahn7 vdd vbneu dneuron
Xeh7 xhp7 xhn7 mhp7 mhn7 ehp7 ehn7 vdd gm esub
Xcm_mo0 mop0 mon0 vdd cmld
Rnd_mo0 mop0 mon0 20k
X_ho_0_0 ahp0 ahn0 wp_who_0_0 wn_who_0_0 mop0 mon0 vdd vbsyn gsyn
X_ho_1_0 ahp1 ahn1 wp_who_1_0 wn_who_1_0 mop0 mon0 vdd vbsyn gsyn
X_ho_2_0 ahp2 ahn2 wp_who_2_0 wn_who_2_0 mop0 mon0 vdd vbsyn gsyn
X_ho_3_0 ahp3 ahn3 wp_who_3_0 wn_who_3_0 mop0 mon0 vdd vbsyn gsyn
X_ho_4_0 ahp4 ahn4 wp_who_4_0 wn_who_4_0 mop0 mon0 vdd vbsyn gsyn
X_ho_5_0 ahp5 ahn5 wp_who_5_0 wn_who_5_0 mop0 mon0 vdd vbsyn gsyn
X_ho_6_0 ahp6 ahn6 wp_who_6_0 wn_who_6_0 mop0 mon0 vdd vbsyn gsyn
X_ho_7_0 ahp7 ahn7 wp_who_7_0 wn_who_7_0 mop0 mon0 vdd vbsyn gsyn
Xeo0 xop0 xon0 mop0 mon0 eop0 eon0 vdd gm esub
Xcm_mo1 mop1 mon1 vdd cmld
Rnd_mo1 mop1 mon1 20k
X_ho_0_1 ahp0 ahn0 wp_who_0_1 wn_who_0_1 mop1 mon1 vdd vbsyn gsyn
X_ho_1_1 ahp1 ahn1 wp_who_1_1 wn_who_1_1 mop1 mon1 vdd vbsyn gsyn
X_ho_2_1 ahp2 ahn2 wp_who_2_1 wn_who_2_1 mop1 mon1 vdd vbsyn gsyn
X_ho_3_1 ahp3 ahn3 wp_who_3_1 wn_who_3_1 mop1 mon1 vdd vbsyn gsyn
X_ho_4_1 ahp4 ahn4 wp_who_4_1 wn_who_4_1 mop1 mon1 vdd vbsyn gsyn
X_ho_5_1 ahp5 ahn5 wp_who_5_1 wn_who_5_1 mop1 mon1 vdd vbsyn gsyn
X_ho_6_1 ahp6 ahn6 wp_who_6_1 wn_who_6_1 mop1 mon1 vdd vbsyn gsyn
X_ho_7_1 ahp7 ahn7 wp_who_7_1 wn_who_7_1 mop1 mon1 vdd vbsyn gsyn
Xeo1 xop1 xon1 mop1 mon1 eop1 eon1 vdd gm esub
Xlih_0_0 ehp0 ehn0 a_xp0 a_xn0 wp_wih_0_0 wn_wih_0_0 vdd gblh gprod
Xlih_1_0 ehp0 ehn0 a_xp1 a_xn1 wp_wih_1_0 wn_wih_1_0 vdd gblh gprod
Xlih_2_0 ehp0 ehn0 a_xp2 a_xn2 wp_wih_2_0 wn_wih_2_0 vdd gblh gprod
Xlih_3_0 ehp0 ehn0 a_xp3 a_xn3 wp_wih_3_0 wn_wih_3_0 vdd gblh gprod
Xlih_4_0 ehp0 ehn0 a_xp4 a_xn4 wp_wih_4_0 wn_wih_4_0 vdd gblh gprod
Xlih_5_0 ehp0 ehn0 a_xp5 a_xn5 wp_wih_5_0 wn_wih_5_0 vdd gblh gprod
Xlih_6_0 ehp0 ehn0 a_xp6 a_xn6 wp_wih_6_0 wn_wih_6_0 vdd gblh gprod
Xlih_7_0 ehp0 ehn0 a_xp7 a_xn7 wp_wih_7_0 wn_wih_7_0 vdd gblh gprod
Xlih_8_0 ehp0 ehn0 a_xp8 a_xn8 wp_wih_8_0 wn_wih_8_0 vdd gblh gprod
Xlih_9_0 ehp0 ehn0 a_xp9 a_xn9 wp_wih_9_0 wn_wih_9_0 vdd gblh gprod
Xlih_10_0 ehp0 ehn0 a_xp10 a_xn10 wp_wih_10_0 wn_wih_10_0 vdd gblh gprod
Xlih_11_0 ehp0 ehn0 a_xp11 a_xn11 wp_wih_11_0 wn_wih_11_0 vdd gblh gprod
Xlih_12_0 ehp0 ehn0 a_xp12 a_xn12 wp_wih_12_0 wn_wih_12_0 vdd gblh gprod
Xlih_13_0 ehp0 ehn0 a_xp13 a_xn13 wp_wih_13_0 wn_wih_13_0 vdd gblh gprod
Xlih_14_0 ehp0 ehn0 a_xp14 a_xn14 wp_wih_14_0 wn_wih_14_0 vdd gblh gprod
Xlih_15_0 ehp0 ehn0 a_xp15 a_xn15 wp_wih_15_0 wn_wih_15_0 vdd gblh gprod
Xlho_0_0 eon0 eop0 ahp0 ahn0 wp_who_0_0 wn_who_0_0 vdd gblo gprod
Xlho_0_1 eon1 eop1 ahp0 ahn0 wp_who_0_1 wn_who_0_1 vdd gblo gprod
Xlih_0_1 ehp1 ehn1 a_xp0 a_xn0 wp_wih_0_1 wn_wih_0_1 vdd gblh gprod
Xlih_1_1 ehp1 ehn1 a_xp1 a_xn1 wp_wih_1_1 wn_wih_1_1 vdd gblh gprod
Xlih_2_1 ehp1 ehn1 a_xp2 a_xn2 wp_wih_2_1 wn_wih_2_1 vdd gblh gprod
Xlih_3_1 ehp1 ehn1 a_xp3 a_xn3 wp_wih_3_1 wn_wih_3_1 vdd gblh gprod
Xlih_4_1 ehp1 ehn1 a_xp4 a_xn4 wp_wih_4_1 wn_wih_4_1 vdd gblh gprod
Xlih_5_1 ehp1 ehn1 a_xp5 a_xn5 wp_wih_5_1 wn_wih_5_1 vdd gblh gprod
Xlih_6_1 ehp1 ehn1 a_xp6 a_xn6 wp_wih_6_1 wn_wih_6_1 vdd gblh gprod
Xlih_7_1 ehp1 ehn1 a_xp7 a_xn7 wp_wih_7_1 wn_wih_7_1 vdd gblh gprod
Xlih_8_1 ehp1 ehn1 a_xp8 a_xn8 wp_wih_8_1 wn_wih_8_1 vdd gblh gprod
Xlih_9_1 ehp1 ehn1 a_xp9 a_xn9 wp_wih_9_1 wn_wih_9_1 vdd gblh gprod
Xlih_10_1 ehp1 ehn1 a_xp10 a_xn10 wp_wih_10_1 wn_wih_10_1 vdd gblh gprod
Xlih_11_1 ehp1 ehn1 a_xp11 a_xn11 wp_wih_11_1 wn_wih_11_1 vdd gblh gprod
Xlih_12_1 ehp1 ehn1 a_xp12 a_xn12 wp_wih_12_1 wn_wih_12_1 vdd gblh gprod
Xlih_13_1 ehp1 ehn1 a_xp13 a_xn13 wp_wih_13_1 wn_wih_13_1 vdd gblh gprod
Xlih_14_1 ehp1 ehn1 a_xp14 a_xn14 wp_wih_14_1 wn_wih_14_1 vdd gblh gprod
Xlih_15_1 ehp1 ehn1 a_xp15 a_xn15 wp_wih_15_1 wn_wih_15_1 vdd gblh gprod
Xlho_1_0 eon0 eop0 ahp1 ahn1 wp_who_1_0 wn_who_1_0 vdd gblo gprod
Xlho_1_1 eon1 eop1 ahp1 ahn1 wp_who_1_1 wn_who_1_1 vdd gblo gprod
Xlih_0_2 ehp2 ehn2 a_xp0 a_xn0 wp_wih_0_2 wn_wih_0_2 vdd gblh gprod
Xlih_1_2 ehp2 ehn2 a_xp1 a_xn1 wp_wih_1_2 wn_wih_1_2 vdd gblh gprod
Xlih_2_2 ehp2 ehn2 a_xp2 a_xn2 wp_wih_2_2 wn_wih_2_2 vdd gblh gprod
Xlih_3_2 ehp2 ehn2 a_xp3 a_xn3 wp_wih_3_2 wn_wih_3_2 vdd gblh gprod
Xlih_4_2 ehp2 ehn2 a_xp4 a_xn4 wp_wih_4_2 wn_wih_4_2 vdd gblh gprod
Xlih_5_2 ehp2 ehn2 a_xp5 a_xn5 wp_wih_5_2 wn_wih_5_2 vdd gblh gprod
Xlih_6_2 ehp2 ehn2 a_xp6 a_xn6 wp_wih_6_2 wn_wih_6_2 vdd gblh gprod
Xlih_7_2 ehp2 ehn2 a_xp7 a_xn7 wp_wih_7_2 wn_wih_7_2 vdd gblh gprod
Xlih_8_2 ehp2 ehn2 a_xp8 a_xn8 wp_wih_8_2 wn_wih_8_2 vdd gblh gprod
Xlih_9_2 ehp2 ehn2 a_xp9 a_xn9 wp_wih_9_2 wn_wih_9_2 vdd gblh gprod
Xlih_10_2 ehp2 ehn2 a_xp10 a_xn10 wp_wih_10_2 wn_wih_10_2 vdd gblh gprod
Xlih_11_2 ehp2 ehn2 a_xp11 a_xn11 wp_wih_11_2 wn_wih_11_2 vdd gblh gprod
Xlih_12_2 ehp2 ehn2 a_xp12 a_xn12 wp_wih_12_2 wn_wih_12_2 vdd gblh gprod
Xlih_13_2 ehp2 ehn2 a_xp13 a_xn13 wp_wih_13_2 wn_wih_13_2 vdd gblh gprod
Xlih_14_2 ehp2 ehn2 a_xp14 a_xn14 wp_wih_14_2 wn_wih_14_2 vdd gblh gprod
Xlih_15_2 ehp2 ehn2 a_xp15 a_xn15 wp_wih_15_2 wn_wih_15_2 vdd gblh gprod
Xlho_2_0 eon0 eop0 ahp2 ahn2 wp_who_2_0 wn_who_2_0 vdd gblo gprod
Xlho_2_1 eon1 eop1 ahp2 ahn2 wp_who_2_1 wn_who_2_1 vdd gblo gprod
Xlih_0_3 ehp3 ehn3 a_xp0 a_xn0 wp_wih_0_3 wn_wih_0_3 vdd gblh gprod
Xlih_1_3 ehp3 ehn3 a_xp1 a_xn1 wp_wih_1_3 wn_wih_1_3 vdd gblh gprod
Xlih_2_3 ehp3 ehn3 a_xp2 a_xn2 wp_wih_2_3 wn_wih_2_3 vdd gblh gprod
Xlih_3_3 ehp3 ehn3 a_xp3 a_xn3 wp_wih_3_3 wn_wih_3_3 vdd gblh gprod
Xlih_4_3 ehp3 ehn3 a_xp4 a_xn4 wp_wih_4_3 wn_wih_4_3 vdd gblh gprod
Xlih_5_3 ehp3 ehn3 a_xp5 a_xn5 wp_wih_5_3 wn_wih_5_3 vdd gblh gprod
Xlih_6_3 ehp3 ehn3 a_xp6 a_xn6 wp_wih_6_3 wn_wih_6_3 vdd gblh gprod
Xlih_7_3 ehp3 ehn3 a_xp7 a_xn7 wp_wih_7_3 wn_wih_7_3 vdd gblh gprod
Xlih_8_3 ehp3 ehn3 a_xp8 a_xn8 wp_wih_8_3 wn_wih_8_3 vdd gblh gprod
Xlih_9_3 ehp3 ehn3 a_xp9 a_xn9 wp_wih_9_3 wn_wih_9_3 vdd gblh gprod
Xlih_10_3 ehp3 ehn3 a_xp10 a_xn10 wp_wih_10_3 wn_wih_10_3 vdd gblh gprod
Xlih_11_3 ehp3 ehn3 a_xp11 a_xn11 wp_wih_11_3 wn_wih_11_3 vdd gblh gprod
Xlih_12_3 ehp3 ehn3 a_xp12 a_xn12 wp_wih_12_3 wn_wih_12_3 vdd gblh gprod
Xlih_13_3 ehp3 ehn3 a_xp13 a_xn13 wp_wih_13_3 wn_wih_13_3 vdd gblh gprod
Xlih_14_3 ehp3 ehn3 a_xp14 a_xn14 wp_wih_14_3 wn_wih_14_3 vdd gblh gprod
Xlih_15_3 ehp3 ehn3 a_xp15 a_xn15 wp_wih_15_3 wn_wih_15_3 vdd gblh gprod
Xlho_3_0 eon0 eop0 ahp3 ahn3 wp_who_3_0 wn_who_3_0 vdd gblo gprod
Xlho_3_1 eon1 eop1 ahp3 ahn3 wp_who_3_1 wn_who_3_1 vdd gblo gprod
Xlih_0_4 ehp4 ehn4 a_xp0 a_xn0 wp_wih_0_4 wn_wih_0_4 vdd gblh gprod
Xlih_1_4 ehp4 ehn4 a_xp1 a_xn1 wp_wih_1_4 wn_wih_1_4 vdd gblh gprod
Xlih_2_4 ehp4 ehn4 a_xp2 a_xn2 wp_wih_2_4 wn_wih_2_4 vdd gblh gprod
Xlih_3_4 ehp4 ehn4 a_xp3 a_xn3 wp_wih_3_4 wn_wih_3_4 vdd gblh gprod
Xlih_4_4 ehp4 ehn4 a_xp4 a_xn4 wp_wih_4_4 wn_wih_4_4 vdd gblh gprod
Xlih_5_4 ehp4 ehn4 a_xp5 a_xn5 wp_wih_5_4 wn_wih_5_4 vdd gblh gprod
Xlih_6_4 ehp4 ehn4 a_xp6 a_xn6 wp_wih_6_4 wn_wih_6_4 vdd gblh gprod
Xlih_7_4 ehp4 ehn4 a_xp7 a_xn7 wp_wih_7_4 wn_wih_7_4 vdd gblh gprod
Xlih_8_4 ehp4 ehn4 a_xp8 a_xn8 wp_wih_8_4 wn_wih_8_4 vdd gblh gprod
Xlih_9_4 ehp4 ehn4 a_xp9 a_xn9 wp_wih_9_4 wn_wih_9_4 vdd gblh gprod
Xlih_10_4 ehp4 ehn4 a_xp10 a_xn10 wp_wih_10_4 wn_wih_10_4 vdd gblh gprod
Xlih_11_4 ehp4 ehn4 a_xp11 a_xn11 wp_wih_11_4 wn_wih_11_4 vdd gblh gprod
Xlih_12_4 ehp4 ehn4 a_xp12 a_xn12 wp_wih_12_4 wn_wih_12_4 vdd gblh gprod
Xlih_13_4 ehp4 ehn4 a_xp13 a_xn13 wp_wih_13_4 wn_wih_13_4 vdd gblh gprod
Xlih_14_4 ehp4 ehn4 a_xp14 a_xn14 wp_wih_14_4 wn_wih_14_4 vdd gblh gprod
Xlih_15_4 ehp4 ehn4 a_xp15 a_xn15 wp_wih_15_4 wn_wih_15_4 vdd gblh gprod
Xlho_4_0 eon0 eop0 ahp4 ahn4 wp_who_4_0 wn_who_4_0 vdd gblo gprod
Xlho_4_1 eon1 eop1 ahp4 ahn4 wp_who_4_1 wn_who_4_1 vdd gblo gprod
Xlih_0_5 ehp5 ehn5 a_xp0 a_xn0 wp_wih_0_5 wn_wih_0_5 vdd gblh gprod
Xlih_1_5 ehp5 ehn5 a_xp1 a_xn1 wp_wih_1_5 wn_wih_1_5 vdd gblh gprod
Xlih_2_5 ehp5 ehn5 a_xp2 a_xn2 wp_wih_2_5 wn_wih_2_5 vdd gblh gprod
Xlih_3_5 ehp5 ehn5 a_xp3 a_xn3 wp_wih_3_5 wn_wih_3_5 vdd gblh gprod
Xlih_4_5 ehp5 ehn5 a_xp4 a_xn4 wp_wih_4_5 wn_wih_4_5 vdd gblh gprod
Xlih_5_5 ehp5 ehn5 a_xp5 a_xn5 wp_wih_5_5 wn_wih_5_5 vdd gblh gprod
Xlih_6_5 ehp5 ehn5 a_xp6 a_xn6 wp_wih_6_5 wn_wih_6_5 vdd gblh gprod
Xlih_7_5 ehp5 ehn5 a_xp7 a_xn7 wp_wih_7_5 wn_wih_7_5 vdd gblh gprod
Xlih_8_5 ehp5 ehn5 a_xp8 a_xn8 wp_wih_8_5 wn_wih_8_5 vdd gblh gprod
Xlih_9_5 ehp5 ehn5 a_xp9 a_xn9 wp_wih_9_5 wn_wih_9_5 vdd gblh gprod
Xlih_10_5 ehp5 ehn5 a_xp10 a_xn10 wp_wih_10_5 wn_wih_10_5 vdd gblh gprod
Xlih_11_5 ehp5 ehn5 a_xp11 a_xn11 wp_wih_11_5 wn_wih_11_5 vdd gblh gprod
Xlih_12_5 ehp5 ehn5 a_xp12 a_xn12 wp_wih_12_5 wn_wih_12_5 vdd gblh gprod
Xlih_13_5 ehp5 ehn5 a_xp13 a_xn13 wp_wih_13_5 wn_wih_13_5 vdd gblh gprod
Xlih_14_5 ehp5 ehn5 a_xp14 a_xn14 wp_wih_14_5 wn_wih_14_5 vdd gblh gprod
Xlih_15_5 ehp5 ehn5 a_xp15 a_xn15 wp_wih_15_5 wn_wih_15_5 vdd gblh gprod
Xlho_5_0 eon0 eop0 ahp5 ahn5 wp_who_5_0 wn_who_5_0 vdd gblo gprod
Xlho_5_1 eon1 eop1 ahp5 ahn5 wp_who_5_1 wn_who_5_1 vdd gblo gprod
Xlih_0_6 ehp6 ehn6 a_xp0 a_xn0 wp_wih_0_6 wn_wih_0_6 vdd gblh gprod
Xlih_1_6 ehp6 ehn6 a_xp1 a_xn1 wp_wih_1_6 wn_wih_1_6 vdd gblh gprod
Xlih_2_6 ehp6 ehn6 a_xp2 a_xn2 wp_wih_2_6 wn_wih_2_6 vdd gblh gprod
Xlih_3_6 ehp6 ehn6 a_xp3 a_xn3 wp_wih_3_6 wn_wih_3_6 vdd gblh gprod
Xlih_4_6 ehp6 ehn6 a_xp4 a_xn4 wp_wih_4_6 wn_wih_4_6 vdd gblh gprod
Xlih_5_6 ehp6 ehn6 a_xp5 a_xn5 wp_wih_5_6 wn_wih_5_6 vdd gblh gprod
Xlih_6_6 ehp6 ehn6 a_xp6 a_xn6 wp_wih_6_6 wn_wih_6_6 vdd gblh gprod
Xlih_7_6 ehp6 ehn6 a_xp7 a_xn7 wp_wih_7_6 wn_wih_7_6 vdd gblh gprod
Xlih_8_6 ehp6 ehn6 a_xp8 a_xn8 wp_wih_8_6 wn_wih_8_6 vdd gblh gprod
Xlih_9_6 ehp6 ehn6 a_xp9 a_xn9 wp_wih_9_6 wn_wih_9_6 vdd gblh gprod
Xlih_10_6 ehp6 ehn6 a_xp10 a_xn10 wp_wih_10_6 wn_wih_10_6 vdd gblh gprod
Xlih_11_6 ehp6 ehn6 a_xp11 a_xn11 wp_wih_11_6 wn_wih_11_6 vdd gblh gprod
Xlih_12_6 ehp6 ehn6 a_xp12 a_xn12 wp_wih_12_6 wn_wih_12_6 vdd gblh gprod
Xlih_13_6 ehp6 ehn6 a_xp13 a_xn13 wp_wih_13_6 wn_wih_13_6 vdd gblh gprod
Xlih_14_6 ehp6 ehn6 a_xp14 a_xn14 wp_wih_14_6 wn_wih_14_6 vdd gblh gprod
Xlih_15_6 ehp6 ehn6 a_xp15 a_xn15 wp_wih_15_6 wn_wih_15_6 vdd gblh gprod
Xlho_6_0 eon0 eop0 ahp6 ahn6 wp_who_6_0 wn_who_6_0 vdd gblo gprod
Xlho_6_1 eon1 eop1 ahp6 ahn6 wp_who_6_1 wn_who_6_1 vdd gblo gprod
Xlih_0_7 ehp7 ehn7 a_xp0 a_xn0 wp_wih_0_7 wn_wih_0_7 vdd gblh gprod
Xlih_1_7 ehp7 ehn7 a_xp1 a_xn1 wp_wih_1_7 wn_wih_1_7 vdd gblh gprod
Xlih_2_7 ehp7 ehn7 a_xp2 a_xn2 wp_wih_2_7 wn_wih_2_7 vdd gblh gprod
Xlih_3_7 ehp7 ehn7 a_xp3 a_xn3 wp_wih_3_7 wn_wih_3_7 vdd gblh gprod
Xlih_4_7 ehp7 ehn7 a_xp4 a_xn4 wp_wih_4_7 wn_wih_4_7 vdd gblh gprod
Xlih_5_7 ehp7 ehn7 a_xp5 a_xn5 wp_wih_5_7 wn_wih_5_7 vdd gblh gprod
Xlih_6_7 ehp7 ehn7 a_xp6 a_xn6 wp_wih_6_7 wn_wih_6_7 vdd gblh gprod
Xlih_7_7 ehp7 ehn7 a_xp7 a_xn7 wp_wih_7_7 wn_wih_7_7 vdd gblh gprod
Xlih_8_7 ehp7 ehn7 a_xp8 a_xn8 wp_wih_8_7 wn_wih_8_7 vdd gblh gprod
Xlih_9_7 ehp7 ehn7 a_xp9 a_xn9 wp_wih_9_7 wn_wih_9_7 vdd gblh gprod
Xlih_10_7 ehp7 ehn7 a_xp10 a_xn10 wp_wih_10_7 wn_wih_10_7 vdd gblh gprod
Xlih_11_7 ehp7 ehn7 a_xp11 a_xn11 wp_wih_11_7 wn_wih_11_7 vdd gblh gprod
Xlih_12_7 ehp7 ehn7 a_xp12 a_xn12 wp_wih_12_7 wn_wih_12_7 vdd gblh gprod
Xlih_13_7 ehp7 ehn7 a_xp13 a_xn13 wp_wih_13_7 wn_wih_13_7 vdd gblh gprod
Xlih_14_7 ehp7 ehn7 a_xp14 a_xn14 wp_wih_14_7 wn_wih_14_7 vdd gblh gprod
Xlih_15_7 ehp7 ehn7 a_xp15 a_xn15 wp_wih_15_7 wn_wih_15_7 vdd gblh gprod
Xlho_7_0 eon0 eop0 ahp7 ahn7 wp_who_7_0 wn_who_7_0 vdd gblo gprod
Xlho_7_1 eon1 eop1 ahp7 ahn7 wp_who_7_1 wn_who_7_1 vdd gblo gprod
.ic v(wp_wih_0_0)=0.4456 v(wn_wih_0_0)=0.5544
.ic v(wp_wih_1_0)=0.3721 v(wn_wih_1_0)=0.6279
.ic v(wp_wih_2_0)=0.4585 v(wn_wih_2_0)=0.5415
.ic v(wp_wih_3_0)=0.4993 v(wn_wih_3_0)=0.5007
.ic v(wp_wih_4_0)=0.5921 v(wn_wih_4_0)=0.4079
.ic v(wp_wih_5_0)=0.4267 v(wn_wih_5_0)=0.5733
.ic v(wp_wih_6_0)=0.4777 v(wn_wih_6_0)=0.5223
.ic v(wp_wih_7_0)=0.3300 v(wn_wih_7_0)=0.6700
.ic v(wp_wih_8_0)=0.4007 v(wn_wih_8_0)=0.5993
.ic v(wp_wih_9_0)=0.8307 v(wn_wih_9_0)=0.3000
.ic v(wp_wih_10_0)=0.6249 v(wn_wih_10_0)=0.3751
.ic v(wp_wih_11_0)=0.4062 v(wn_wih_11_0)=0.5938
.ic v(wp_wih_12_0)=0.3395 v(wn_wih_12_0)=0.6605
.ic v(wp_wih_13_0)=0.3829 v(wn_wih_13_0)=0.6171
.ic v(wp_wih_14_0)=0.4974 v(wn_wih_14_0)=0.5026
.ic v(wp_wih_15_0)=0.5042 v(wn_wih_15_0)=0.4958
.ic v(wp_who_0_0)=0.4107 v(wn_who_0_0)=0.5893
.ic v(wp_who_0_1)=0.3456 v(wn_who_0_1)=0.6544
.ic v(wp_wih_0_1)=0.6707 v(wn_wih_0_1)=0.3293
.ic v(wp_wih_1_1)=0.5542 v(wn_wih_1_1)=0.4458
.ic v(wp_wih_2_1)=0.4551 v(wn_wih_2_1)=0.5449
.ic v(wp_wih_3_1)=0.4735 v(wn_wih_3_1)=0.5265
.ic v(wp_wih_4_1)=0.4365 v(wn_wih_4_1)=0.5635
.ic v(wp_wih_5_1)=0.3000 v(wn_wih_5_1)=0.8523
.ic v(wp_wih_6_1)=0.5139 v(wn_wih_6_1)=0.4861
.ic v(wp_wih_7_1)=0.3715 v(wn_wih_7_1)=0.6285
.ic v(wp_wih_8_1)=0.3797 v(wn_wih_8_1)=0.6203
.ic v(wp_wih_9_1)=0.4232 v(wn_wih_9_1)=0.5768
.ic v(wp_wih_10_1)=0.5879 v(wn_wih_10_1)=0.4121
.ic v(wp_wih_11_1)=0.3595 v(wn_wih_11_1)=0.6405
.ic v(wp_wih_12_1)=0.3279 v(wn_wih_12_1)=0.6721
.ic v(wp_wih_13_1)=0.5768 v(wn_wih_13_1)=0.4232
.ic v(wp_wih_14_1)=0.5905 v(wn_wih_14_1)=0.4095
.ic v(wp_wih_15_1)=0.3849 v(wn_wih_15_1)=0.6151
.ic v(wp_who_1_0)=0.5675 v(wn_who_1_0)=0.4325
.ic v(wp_who_1_1)=0.4650 v(wn_who_1_1)=0.5350
.ic v(wp_wih_0_2)=0.5362 v(wn_wih_0_2)=0.4638
.ic v(wp_wih_1_2)=0.3487 v(wn_wih_1_2)=0.6513
.ic v(wp_wih_2_2)=0.5999 v(wn_wih_2_2)=0.4001
.ic v(wp_wih_3_2)=0.6444 v(wn_wih_3_2)=0.3556
.ic v(wp_wih_4_2)=0.5764 v(wn_wih_4_2)=0.4236
.ic v(wp_wih_5_2)=0.5670 v(wn_wih_5_2)=0.4330
.ic v(wp_wih_6_2)=0.3000 v(wn_wih_6_2)=0.9000
.ic v(wp_wih_7_2)=0.5313 v(wn_wih_7_2)=0.4687
.ic v(wp_wih_8_2)=0.4969 v(wn_wih_8_2)=0.5031
.ic v(wp_wih_9_2)=0.4824 v(wn_wih_9_2)=0.5176
.ic v(wp_wih_10_2)=0.4243 v(wn_wih_10_2)=0.5757
.ic v(wp_wih_11_2)=0.5066 v(wn_wih_11_2)=0.4934
.ic v(wp_wih_12_2)=0.5495 v(wn_wih_12_2)=0.4505
.ic v(wp_wih_13_2)=0.4683 v(wn_wih_13_2)=0.5317
.ic v(wp_wih_14_2)=0.4444 v(wn_wih_14_2)=0.5556
.ic v(wp_wih_15_2)=0.6476 v(wn_wih_15_2)=0.3524
.ic v(wp_who_2_0)=0.3674 v(wn_who_2_0)=0.6326
.ic v(wp_who_2_1)=0.6236 v(wn_who_2_1)=0.3764
.ic v(wp_wih_0_3)=0.5212 v(wn_wih_0_3)=0.4788
.ic v(wp_wih_1_3)=0.4035 v(wn_wih_1_3)=0.5965
.ic v(wp_wih_2_3)=0.4652 v(wn_wih_2_3)=0.5348
.ic v(wp_wih_3_3)=0.3896 v(wn_wih_3_3)=0.6104
.ic v(wp_wih_4_3)=0.5810 v(wn_wih_4_3)=0.4190
.ic v(wp_wih_5_3)=0.5417 v(wn_wih_5_3)=0.4583
.ic v(wp_wih_6_3)=0.4332 v(wn_wih_6_3)=0.5668
.ic v(wp_wih_7_3)=0.3677 v(wn_wih_7_3)=0.6323
.ic v(wp_wih_8_3)=0.5362 v(wn_wih_8_3)=0.4638
.ic v(wp_wih_9_3)=0.6149 v(wn_wih_9_3)=0.3851
.ic v(wp_wih_10_3)=0.4863 v(wn_wih_10_3)=0.5137
.ic v(wp_wih_11_3)=0.5502 v(wn_wih_11_3)=0.4498
.ic v(wp_wih_12_3)=0.4549 v(wn_wih_12_3)=0.5451
.ic v(wp_wih_13_3)=0.5081 v(wn_wih_13_3)=0.4919
.ic v(wp_wih_14_3)=0.4650 v(wn_wih_14_3)=0.5350
.ic v(wp_wih_15_3)=0.5353 v(wn_wih_15_3)=0.4647
.ic v(wp_who_3_0)=0.3188 v(wn_who_3_0)=0.6812
.ic v(wp_who_3_1)=0.5773 v(wn_who_3_1)=0.4227
.ic v(wp_wih_0_4)=0.4724 v(wn_wih_0_4)=0.5276
.ic v(wp_wih_1_4)=0.5430 v(wn_wih_1_4)=0.4570
.ic v(wp_wih_2_4)=0.4592 v(wn_wih_2_4)=0.5408
.ic v(wp_wih_3_4)=0.5384 v(wn_wih_3_4)=0.4616
.ic v(wp_wih_4_4)=0.3713 v(wn_wih_4_4)=0.6287
.ic v(wp_wih_5_4)=0.6427 v(wn_wih_5_4)=0.3573
.ic v(wp_wih_6_4)=0.3000 v(wn_wih_6_4)=0.7044
.ic v(wp_wih_7_4)=0.3753 v(wn_wih_7_4)=0.6247
.ic v(wp_wih_8_4)=0.5283 v(wn_wih_8_4)=0.4717
.ic v(wp_wih_9_4)=0.6755 v(wn_wih_9_4)=0.3245
.ic v(wp_wih_10_4)=0.5334 v(wn_wih_10_4)=0.4666
.ic v(wp_wih_11_4)=0.4703 v(wn_wih_11_4)=0.5297
.ic v(wp_wih_12_4)=0.3290 v(wn_wih_12_4)=0.6710
.ic v(wp_wih_13_4)=0.4770 v(wn_wih_13_4)=0.5230
.ic v(wp_wih_14_4)=0.4976 v(wn_wih_14_4)=0.5024
.ic v(wp_wih_15_4)=0.7029 v(wn_wih_15_4)=0.3000
.ic v(wp_who_4_0)=0.5747 v(wn_who_4_0)=0.4253
.ic v(wp_who_4_1)=0.3165 v(wn_who_4_1)=0.6835
.ic v(wp_wih_0_5)=0.7432 v(wn_wih_0_5)=0.3000
.ic v(wp_wih_1_5)=0.4526 v(wn_wih_1_5)=0.5474
.ic v(wp_wih_2_5)=0.3945 v(wn_wih_2_5)=0.6055
.ic v(wp_wih_3_5)=0.6770 v(wn_wih_3_5)=0.3230
.ic v(wp_wih_4_5)=0.4940 v(wn_wih_4_5)=0.5060
.ic v(wp_wih_5_5)=0.4559 v(wn_wih_5_5)=0.5441
.ic v(wp_wih_6_5)=0.5263 v(wn_wih_6_5)=0.4737
.ic v(wp_wih_7_5)=0.6014 v(wn_wih_7_5)=0.3986
.ic v(wp_wih_8_5)=0.6192 v(wn_wih_8_5)=0.3808
.ic v(wp_wih_9_5)=0.3350 v(wn_wih_9_5)=0.6650
.ic v(wp_wih_10_5)=0.7398 v(wn_wih_10_5)=0.3000
.ic v(wp_wih_11_5)=0.6136 v(wn_wih_11_5)=0.3864
.ic v(wp_wih_12_5)=0.4545 v(wn_wih_12_5)=0.5455
.ic v(wp_wih_13_5)=0.4018 v(wn_wih_13_5)=0.5982
.ic v(wp_wih_14_5)=0.3837 v(wn_wih_14_5)=0.6163
.ic v(wp_wih_15_5)=0.5148 v(wn_wih_15_5)=0.4852
.ic v(wp_who_5_0)=0.4222 v(wn_who_5_0)=0.5778
.ic v(wp_who_5_1)=0.4082 v(wn_who_5_1)=0.5918
.ic v(wp_wih_0_6)=0.5974 v(wn_wih_0_6)=0.4026
.ic v(wp_wih_1_6)=0.5437 v(wn_wih_1_6)=0.4563
.ic v(wp_wih_2_6)=0.4527 v(wn_wih_2_6)=0.5473
.ic v(wp_wih_3_6)=0.5881 v(wn_wih_3_6)=0.4119
.ic v(wp_wih_4_6)=0.6641 v(wn_wih_4_6)=0.3359
.ic v(wp_wih_5_6)=0.3687 v(wn_wih_5_6)=0.6313
.ic v(wp_wih_6_6)=0.4276 v(wn_wih_6_6)=0.5724
.ic v(wp_wih_7_6)=0.6131 v(wn_wih_7_6)=0.3869
.ic v(wp_wih_8_6)=0.5863 v(wn_wih_8_6)=0.4137
.ic v(wp_wih_9_6)=0.5272 v(wn_wih_9_6)=0.4728
.ic v(wp_wih_10_6)=0.6395 v(wn_wih_10_6)=0.3605
.ic v(wp_wih_11_6)=0.3694 v(wn_wih_11_6)=0.6306
.ic v(wp_wih_12_6)=0.3225 v(wn_wih_12_6)=0.6775
.ic v(wp_wih_13_6)=0.3960 v(wn_wih_13_6)=0.6040
.ic v(wp_wih_14_6)=0.5147 v(wn_wih_14_6)=0.4853
.ic v(wp_wih_15_6)=0.4045 v(wn_wih_15_6)=0.5955
.ic v(wp_who_6_0)=0.4415 v(wn_who_6_0)=0.5585
.ic v(wp_who_6_1)=0.3830 v(wn_who_6_1)=0.6170
.ic v(wp_wih_0_7)=0.4255 v(wn_wih_0_7)=0.5745
.ic v(wp_wih_1_7)=0.3794 v(wn_wih_1_7)=0.6206
.ic v(wp_wih_2_7)=0.5441 v(wn_wih_2_7)=0.4559
.ic v(wp_wih_3_7)=0.5954 v(wn_wih_3_7)=0.4046
.ic v(wp_wih_4_7)=0.4423 v(wn_wih_4_7)=0.5577
.ic v(wp_wih_5_7)=0.4751 v(wn_wih_5_7)=0.5249
.ic v(wp_wih_6_7)=0.4303 v(wn_wih_6_7)=0.5697
.ic v(wp_wih_7_7)=0.5638 v(wn_wih_7_7)=0.4362
.ic v(wp_wih_8_7)=0.5107 v(wn_wih_8_7)=0.4893
.ic v(wp_wih_9_7)=0.6913 v(wn_wih_9_7)=0.3087
.ic v(wp_wih_10_7)=0.3685 v(wn_wih_10_7)=0.6315
.ic v(wp_wih_11_7)=0.5435 v(wn_wih_11_7)=0.4565
.ic v(wp_wih_12_7)=0.5533 v(wn_wih_12_7)=0.4467
.ic v(wp_wih_13_7)=0.4567 v(wn_wih_13_7)=0.5433
.ic v(wp_wih_14_7)=0.5700 v(wn_wih_14_7)=0.4300
.ic v(wp_wih_15_7)=0.3274 v(wn_wih_15_7)=0.6726
.ic v(wp_who_7_0)=0.7543 v(wn_who_7_0)=0.3000
.ic v(wp_who_7_1)=0.3390 v(wn_who_7_1)=0.6610
.options gmin=1e-10 reltol=2e-3
.tran 2n 300000n uic
.control
run
wrdata pcMt2.dat v(mop0) v(mon0) v(mop1) v(mon1) v(wp_wih_0_0) v(wn_wih_0_0) v(wp_wih_1_0) v(wn_wih_1_0) v(wp_wih_2_0) v(wn_wih_2_0) v(wp_wih_3_0) v(wn_wih_3_0) v(wp_wih_4_0) v(wn_wih_4_0) v(wp_wih_5_0) v(wn_wih_5_0) v(wp_wih_6_0) v(wn_wih_6_0) v(wp_wih_7_0) v(wn_wih_7_0) v(wp_wih_8_0) v(wn_wih_8_0) v(wp_wih_9_0) v(wn_wih_9_0) v(wp_wih_10_0) v(wn_wih_10_0) v(wp_wih_11_0) v(wn_wih_11_0) v(wp_wih_12_0) v(wn_wih_12_0) v(wp_wih_13_0) v(wn_wih_13_0) v(wp_wih_14_0) v(wn_wih_14_0) v(wp_wih_15_0) v(wn_wih_15_0) v(wp_who_0_0) v(wn_who_0_0) v(wp_who_0_1) v(wn_who_0_1) v(wp_wih_0_1) v(wn_wih_0_1) v(wp_wih_1_1) v(wn_wih_1_1) v(wp_wih_2_1) v(wn_wih_2_1) v(wp_wih_3_1) v(wn_wih_3_1) v(wp_wih_4_1) v(wn_wih_4_1) v(wp_wih_5_1) v(wn_wih_5_1) v(wp_wih_6_1) v(wn_wih_6_1) v(wp_wih_7_1) v(wn_wih_7_1) v(wp_wih_8_1) v(wn_wih_8_1) v(wp_wih_9_1) v(wn_wih_9_1) v(wp_wih_10_1) v(wn_wih_10_1) v(wp_wih_11_1) v(wn_wih_11_1) v(wp_wih_12_1) v(wn_wih_12_1) v(wp_wih_13_1) v(wn_wih_13_1) v(wp_wih_14_1) v(wn_wih_14_1) v(wp_wih_15_1) v(wn_wih_15_1) v(wp_who_1_0) v(wn_who_1_0) v(wp_who_1_1) v(wn_who_1_1) v(wp_wih_0_2) v(wn_wih_0_2) v(wp_wih_1_2) v(wn_wih_1_2) v(wp_wih_2_2) v(wn_wih_2_2) v(wp_wih_3_2) v(wn_wih_3_2) v(wp_wih_4_2) v(wn_wih_4_2) v(wp_wih_5_2) v(wn_wih_5_2) v(wp_wih_6_2) v(wn_wih_6_2) v(wp_wih_7_2) v(wn_wih_7_2) v(wp_wih_8_2) v(wn_wih_8_2) v(wp_wih_9_2) v(wn_wih_9_2) v(wp_wih_10_2) v(wn_wih_10_2) v(wp_wih_11_2) v(wn_wih_11_2) v(wp_wih_12_2) v(wn_wih_12_2) v(wp_wih_13_2) v(wn_wih_13_2) v(wp_wih_14_2) v(wn_wih_14_2) v(wp_wih_15_2) v(wn_wih_15_2) v(wp_who_2_0) v(wn_who_2_0) v(wp_who_2_1) v(wn_who_2_1) v(wp_wih_0_3) v(wn_wih_0_3) v(wp_wih_1_3) v(wn_wih_1_3) v(wp_wih_2_3) v(wn_wih_2_3) v(wp_wih_3_3) v(wn_wih_3_3) v(wp_wih_4_3) v(wn_wih_4_3) v(wp_wih_5_3) v(wn_wih_5_3) v(wp_wih_6_3) v(wn_wih_6_3) v(wp_wih_7_3) v(wn_wih_7_3) v(wp_wih_8_3) v(wn_wih_8_3) v(wp_wih_9_3) v(wn_wih_9_3) v(wp_wih_10_3) v(wn_wih_10_3) v(wp_wih_11_3) v(wn_wih_11_3) v(wp_wih_12_3) v(wn_wih_12_3) v(wp_wih_13_3) v(wn_wih_13_3) v(wp_wih_14_3) v(wn_wih_14_3) v(wp_wih_15_3) v(wn_wih_15_3) v(wp_who_3_0) v(wn_who_3_0) v(wp_who_3_1) v(wn_who_3_1) v(wp_wih_0_4) v(wn_wih_0_4) v(wp_wih_1_4) v(wn_wih_1_4) v(wp_wih_2_4) v(wn_wih_2_4) v(wp_wih_3_4) v(wn_wih_3_4) v(wp_wih_4_4) v(wn_wih_4_4) v(wp_wih_5_4) v(wn_wih_5_4) v(wp_wih_6_4) v(wn_wih_6_4) v(wp_wih_7_4) v(wn_wih_7_4) v(wp_wih_8_4) v(wn_wih_8_4) v(wp_wih_9_4) v(wn_wih_9_4) v(wp_wih_10_4) v(wn_wih_10_4) v(wp_wih_11_4) v(wn_wih_11_4) v(wp_wih_12_4) v(wn_wih_12_4) v(wp_wih_13_4) v(wn_wih_13_4) v(wp_wih_14_4) v(wn_wih_14_4) v(wp_wih_15_4) v(wn_wih_15_4) v(wp_who_4_0) v(wn_who_4_0) v(wp_who_4_1) v(wn_who_4_1) v(wp_wih_0_5) v(wn_wih_0_5) v(wp_wih_1_5) v(wn_wih_1_5) v(wp_wih_2_5) v(wn_wih_2_5) v(wp_wih_3_5) v(wn_wih_3_5) v(wp_wih_4_5) v(wn_wih_4_5) v(wp_wih_5_5) v(wn_wih_5_5) v(wp_wih_6_5) v(wn_wih_6_5) v(wp_wih_7_5) v(wn_wih_7_5) v(wp_wih_8_5) v(wn_wih_8_5) v(wp_wih_9_5) v(wn_wih_9_5) v(wp_wih_10_5) v(wn_wih_10_5) v(wp_wih_11_5) v(wn_wih_11_5) v(wp_wih_12_5) v(wn_wih_12_5) v(wp_wih_13_5) v(wn_wih_13_5) v(wp_wih_14_5) v(wn_wih_14_5) v(wp_wih_15_5) v(wn_wih_15_5) v(wp_who_5_0) v(wn_who_5_0) v(wp_who_5_1) v(wn_who_5_1) v(wp_wih_0_6) v(wn_wih_0_6) v(wp_wih_1_6) v(wn_wih_1_6) v(wp_wih_2_6) v(wn_wih_2_6) v(wp_wih_3_6) v(wn_wih_3_6) v(wp_wih_4_6) v(wn_wih_4_6) v(wp_wih_5_6) v(wn_wih_5_6) v(wp_wih_6_6) v(wn_wih_6_6) v(wp_wih_7_6) v(wn_wih_7_6) v(wp_wih_8_6) v(wn_wih_8_6) v(wp_wih_9_6) v(wn_wih_9_6) v(wp_wih_10_6) v(wn_wih_10_6) v(wp_wih_11_6) v(wn_wih_11_6) v(wp_wih_12_6) v(wn_wih_12_6) v(wp_wih_13_6) v(wn_wih_13_6) v(wp_wih_14_6) v(wn_wih_14_6) v(wp_wih_15_6) v(wn_wih_15_6) v(wp_who_6_0) v(wn_who_6_0) v(wp_who_6_1) v(wn_who_6_1) v(wp_wih_0_7) v(wn_wih_0_7) v(wp_wih_1_7) v(wn_wih_1_7) v(wp_wih_2_7) v(wn_wih_2_7) v(wp_wih_3_7) v(wn_wih_3_7) v(wp_wih_4_7) v(wn_wih_4_7) v(wp_wih_5_7) v(wn_wih_5_7) v(wp_wih_6_7) v(wn_wih_6_7) v(wp_wih_7_7) v(wn_wih_7_7) v(wp_wih_8_7) v(wn_wih_8_7) v(wp_wih_9_7) v(wn_wih_9_7) v(wp_wih_10_7) v(wn_wih_10_7) v(wp_wih_11_7) v(wn_wih_11_7) v(wp_wih_12_7) v(wn_wih_12_7) v(wp_wih_13_7) v(wn_wih_13_7) v(wp_wih_14_7) v(wn_wih_14_7) v(wp_wih_15_7) v(wn_wih_15_7) v(wp_who_7_0) v(wn_who_7_0) v(wp_who_7_1) v(wn_who_7_1)
.endc
.end
