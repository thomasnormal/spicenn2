EP XOR2 t-gate + one-port neuron
.model NSYN NMOS (LEVEL=1 VTO=0.2  KP=50u LAMBDA=0 GAMMA=0 PHI=0.7)
.model PSYN PMOS (LEVEL=1 VTO=-0.2 KP=40u LAMBDA=0 GAMMA=0 PHI=0.7)
.model DCL D (IS=1e-9 N=0.25)
Vdd vdd 0 1.5
Vhi vhi 0 1.0
Vlo vlo 0 0.0
Vmid nmid 0 0.5
Vclo nclo 0 0.08
Vchi nchi 0 0.92
Vhclo nhclo 0 0.08
Vhchi nhchi 0 0.92
Vt vt 0 0.5
Vx1 x1 0 0.5
Vx2 x2 0 0.5
Vx1b x1b 0 0.5
Vx2b x2b 0 0.5
Vgn_w11p gn_w11p 0 0.95692
Vgp_w11p gp_w11p 0 0.04308
Vgn_w11n gn_w11n 0 1.38627
Vgp_w11n gp_w11n 0 -0.38627
Vgn_w12p gn_w12p 0 1.24953
Vgp_w12p gp_w12p 0 -0.24953
Vgn_w12n gn_w12n 0 0.87351
Vgp_w12n gp_w12n 0 0.12649
Vgn_w21p gn_w21p 0 1.44884
Vgp_w21p gp_w21p 0 -0.44884
Vgn_w21n gn_w21n 0 1.15879
Vgp_w21n gp_w21n 0 -0.15879
Vgn_w22p gn_w22p 0 1.25117
Vgp_w22p gp_w22p 0 -0.25117
Vgn_w22n gn_w22n 0 1.18922
Vgp_w22n gp_w22n 0 -0.18922
Vgn_o1p gn_o1p 0 0.82875
Vgp_o1p gp_o1p 0 0.17125
Vgn_o1n gn_o1n 0 0.78383
Vgp_o1n gp_o1n 0 0.21617
Vgn_o2p gn_o2p 0 1.07279
Vgp_o2p gp_o2p 0 -0.07279
Vgn_o2n gn_o2n 0 0.92815
Vgp_o2n gp_o2n 0 0.07185
Vgn_bh1p gn_bh1p 0 1.46999
Vgp_bh1p gp_bh1p 0 -0.46999
Vgn_bh1n gn_bh1n 0 1.40663
Vgp_bh1n gp_bh1n 0 -0.40663
Vgn_bh2p gn_bh2p 0 1.52748
Vgp_bh2p gp_bh2p 0 -0.52748
Vgn_bh2n gn_bh2n 0 0.90505
Vgp_bh2n gp_bh2n 0 0.09495
Vgn_bop gn_bop 0 1.02486
Vgp_bop gp_bop 0 -0.02486
Vgn_bon gn_bon 0 1.31313
Vgp_bon gp_bon 0 -0.31313
Mn0 x1 gn_w11p h1 0   NSYN W=200u L=100u
Mp0 x1 gp_w11p h1 vdd PSYN W=250u L=100u
Mn1 x1b gn_w11n h1 0   NSYN W=200u L=100u
Mp1 x1b gp_w11n h1 vdd PSYN W=250u L=100u
Mn2 x1b gn_w11p h1b 0   NSYN W=200u L=100u
Mp2 x1b gp_w11p h1b vdd PSYN W=250u L=100u
Mn3 x1 gn_w11n h1b 0   NSYN W=200u L=100u
Mp3 x1 gp_w11n h1b vdd PSYN W=250u L=100u
Mn4 x1 gn_w12p h2 0   NSYN W=200u L=100u
Mp4 x1 gp_w12p h2 vdd PSYN W=250u L=100u
Mn5 x1b gn_w12n h2 0   NSYN W=200u L=100u
Mp5 x1b gp_w12n h2 vdd PSYN W=250u L=100u
Mn6 x1b gn_w12p h2b 0   NSYN W=200u L=100u
Mp6 x1b gp_w12p h2b vdd PSYN W=250u L=100u
Mn7 x1 gn_w12n h2b 0   NSYN W=200u L=100u
Mp7 x1 gp_w12n h2b vdd PSYN W=250u L=100u
Mn8 x2 gn_w21p h1 0   NSYN W=200u L=100u
Mp8 x2 gp_w21p h1 vdd PSYN W=250u L=100u
Mn9 x2b gn_w21n h1 0   NSYN W=200u L=100u
Mp9 x2b gp_w21n h1 vdd PSYN W=250u L=100u
Mn10 x2b gn_w21p h1b 0   NSYN W=200u L=100u
Mp10 x2b gp_w21p h1b vdd PSYN W=250u L=100u
Mn11 x2 gn_w21n h1b 0   NSYN W=200u L=100u
Mp11 x2 gp_w21n h1b vdd PSYN W=250u L=100u
Mn12 x2 gn_w22p h2 0   NSYN W=200u L=100u
Mp12 x2 gp_w22p h2 vdd PSYN W=250u L=100u
Mn13 x2b gn_w22n h2 0   NSYN W=200u L=100u
Mp13 x2b gp_w22n h2 vdd PSYN W=250u L=100u
Mn14 x2b gn_w22p h2b 0   NSYN W=200u L=100u
Mp14 x2b gp_w22p h2b vdd PSYN W=250u L=100u
Mn15 x2 gn_w22n h2b 0   NSYN W=200u L=100u
Mp15 x2 gp_w22n h2b vdd PSYN W=250u L=100u
Mn16 h1 gn_o1p o 0   NSYN W=200u L=100u
Mp16 h1 gp_o1p o vdd PSYN W=250u L=100u
Mn17 h1b gn_o1n o 0   NSYN W=200u L=100u
Mp17 h1b gp_o1n o vdd PSYN W=250u L=100u
Mn18 vhi gn_bh1p h1 0   NSYN W=200u L=100u
Mp18 vhi gp_bh1p h1 vdd PSYN W=250u L=100u
Mn19 vlo gn_bh1n h1 0   NSYN W=200u L=100u
Mp19 vlo gp_bh1n h1 vdd PSYN W=250u L=100u
Mn20 vlo gn_bh1p h1b 0   NSYN W=200u L=100u
Mp20 vlo gp_bh1p h1b vdd PSYN W=250u L=100u
Mn21 vhi gn_bh1n h1b 0   NSYN W=200u L=100u
Mp21 vhi gp_bh1n h1b vdd PSYN W=250u L=100u
Mn22 h2 gn_o2p o 0   NSYN W=200u L=100u
Mp22 h2 gp_o2p o vdd PSYN W=250u L=100u
Mn23 h2b gn_o2n o 0   NSYN W=200u L=100u
Mp23 h2b gp_o2n o vdd PSYN W=250u L=100u
Mn24 vhi gn_bh2p h2 0   NSYN W=200u L=100u
Mp24 vhi gp_bh2p h2 vdd PSYN W=250u L=100u
Mn25 vlo gn_bh2n h2 0   NSYN W=200u L=100u
Mp25 vlo gp_bh2n h2 vdd PSYN W=250u L=100u
Mn26 vlo gn_bh2p h2b 0   NSYN W=200u L=100u
Mp26 vlo gp_bh2p h2b vdd PSYN W=250u L=100u
Mn27 vhi gn_bh2n h2b 0   NSYN W=200u L=100u
Mp27 vhi gp_bh2n h2b vdd PSYN W=250u L=100u
Mn28 vhi gn_bop o 0   NSYN W=200u L=100u
Mp28 vhi gp_bop o vdd PSYN W=250u L=100u
Mn29 vlo gn_bon o 0   NSYN W=200u L=100u
Mp29 vlo gp_bon o vdd PSYN W=250u L=100u
Rlh1 h1 nmid 300000.0
Dloh1 nhclo h1 DCL
Dhih1 h1 nhchi DCL
Rlh1b h1b nmid 300000.0
Dloh1b nhclo h1b DCL
Dhih1b h1b nhchi DCL
Rlh2 h2 nmid 300000.0
Dloh2 nhclo h2 DCL
Dhih2 h2 nhchi DCL
Rlh2b h2b nmid 300000.0
Dloh2b nhclo h2b DCL
Dhih2b h2b nhchi DCL
Rlo o nmid 300000.0
Dloo nclo o DCL
Dhio o nchi DCL
Rb o vt 1e12
.control
alter Vx1 0.15
alter Vx2 0.15
alter Vx1b 0.85
alter Vx2b 0.85
alter Rb 1e12
op
wrdata x2f0.dat v(h1) v(h1b) v(h2) v(h2b) v(o)
alter Vt 0.15
alter Rb 20000.0
op
wrdata x2n0.dat v(h1) v(h1b) v(h2) v(h2b) v(o)
alter Vx1 0.15
alter Vx2 0.85
alter Vx1b 0.85
alter Vx2b 0.15
alter Rb 1e12
op
wrdata x2f1.dat v(h1) v(h1b) v(h2) v(h2b) v(o)
alter Vt 0.85
alter Rb 20000.0
op
wrdata x2n1.dat v(h1) v(h1b) v(h2) v(h2b) v(o)
alter Vx1 0.85
alter Vx2 0.15
alter Vx1b 0.15
alter Vx2b 0.85
alter Rb 1e12
op
wrdata x2f2.dat v(h1) v(h1b) v(h2) v(h2b) v(o)
alter Vt 0.85
alter Rb 20000.0
op
wrdata x2n2.dat v(h1) v(h1b) v(h2) v(h2b) v(o)
alter Vx1 0.85
alter Vx2 0.85
alter Vx1b 0.15
alter Vx2b 0.15
alter Rb 1e12
op
wrdata x2f3.dat v(h1) v(h1b) v(h2) v(h2b) v(o)
alter Vt 0.15
alter Rb 20000.0
op
wrdata x2n3.dat v(h1) v(h1b) v(h2) v(h2b) v(o)
.endc
.end
