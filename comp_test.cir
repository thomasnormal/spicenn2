* competition cell standalone test
.model NSYN NMOS (LEVEL=1 VTO=0.2 KP=50u LAMBDA=0 GAMMA=0 PHI=0.7)
.model NMIR NMOS (LEVEL=1 VTO=0.5 KP=120u LAMBDA=0.02 GAMMA=0 PHI=0.7)
.model PMIR PMOS (LEVEL=1 VTO=-0.5 KP=40u LAMBDA=0.02 GAMMA=0 PHI=0.7)
Vvdd vdd 0 3
Vrefo vrefo 0 0.5
Vvc vcn 0 1.8
Vrefd vrefd 0 1.2
Vboff boff 0 1.9
Vbx bx 0 dc 1.5
Vhv1 hv_1 0 PWL(0.000 2.200 0.250 2.200 0.300 0.800 0.550 0.800 0.600 1.400 0.850 1.400 0.900 1.400)
Vhv2 hv_2 0 PWL(0.000 0.800 0.250 0.800 0.300 2.200 0.550 2.200 0.600 1.400 0.850 1.400 0.900 1.400)
Vhv3 hv_3 0 PWL(0.000 0.800 0.250 0.800 0.300 0.800 0.550 0.800 0.600 1.400 0.850 1.400 0.900 1.400)
Vtg1 tg1 0 dc 0
Vtg2 tg2 0 dc 0
Vtg3 tg3 0 dc 0
Vg_2_1_1 g_2_1_1 0 2.760
Mp_2_1_1 hv_1 g_2_1_1 colpo1 0 NSYN W=10u L=1u
Mn_2_1_1 hv_1 vcn colno1 0 NSYN W=10u L=1u
Vg_2_1_2 g_2_1_2 0 1.320
Mp_2_1_2 hv_2 g_2_1_2 colpo1 0 NSYN W=10u L=1u
Mn_2_1_2 hv_2 vcn colno1 0 NSYN W=10u L=1u
Vg_2_1_3 g_2_1_3 0 1.320
Mp_2_1_3 hv_3 g_2_1_3 colpo1 0 NSYN W=10u L=1u
Mn_2_1_3 hv_3 vcn colno1 0 NSYN W=10u L=1u
Vg_2_1_b g_2_1_b 0 1.800
Mp_2_1_b bx g_2_1_b colpo1 0 NSYN W=10u L=1u
Mn_2_1_b bx vcn colno1 0 NSYN W=10u L=1u
Msa_o1 colno1 colno1 0 0 NMIR W=20u L=1u
Msb_o1 y_1 colno1 0 0 NMIR W=20u L=1u
Msc_o1 colpo1 colpo1 0 0 NMIR W=20u L=1u
Msd_o1 dpf_o1 colpo1 0 0 NMIR W=20u L=1u
Mse_o1 dpf_o1 dpf_o1 vdd vdd PMIR W=60u L=1u
Msf_o1 y_1 dpf_o1 vdd vdd PMIR W=60u L=1u
R_o1 y_1 vrefo 7000.0
Vg_2_2_1 g_2_2_1 0 1.320
Mp_2_2_1 hv_1 g_2_2_1 colpo2 0 NSYN W=10u L=1u
Mn_2_2_1 hv_1 vcn colno2 0 NSYN W=10u L=1u
Vg_2_2_2 g_2_2_2 0 2.760
Mp_2_2_2 hv_2 g_2_2_2 colpo2 0 NSYN W=10u L=1u
Mn_2_2_2 hv_2 vcn colno2 0 NSYN W=10u L=1u
Vg_2_2_3 g_2_2_3 0 1.320
Mp_2_2_3 hv_3 g_2_2_3 colpo2 0 NSYN W=10u L=1u
Mn_2_2_3 hv_3 vcn colno2 0 NSYN W=10u L=1u
Vg_2_2_b g_2_2_b 0 1.800
Mp_2_2_b bx g_2_2_b colpo2 0 NSYN W=10u L=1u
Mn_2_2_b bx vcn colno2 0 NSYN W=10u L=1u
Msa_o2 colno2 colno2 0 0 NMIR W=20u L=1u
Msb_o2 y_2 colno2 0 0 NMIR W=20u L=1u
Msc_o2 colpo2 colpo2 0 0 NMIR W=20u L=1u
Msd_o2 dpf_o2 colpo2 0 0 NMIR W=20u L=1u
Mse_o2 dpf_o2 dpf_o2 vdd vdd PMIR W=60u L=1u
Msf_o2 y_2 dpf_o2 vdd vdd PMIR W=60u L=1u
R_o2 y_2 vrefo 7000.0
Vg_2_3_1 g_2_3_1 0 1.320
Mp_2_3_1 hv_1 g_2_3_1 colpo3 0 NSYN W=10u L=1u
Mn_2_3_1 hv_1 vcn colno3 0 NSYN W=10u L=1u
Vg_2_3_2 g_2_3_2 0 1.320
Mp_2_3_2 hv_2 g_2_3_2 colpo3 0 NSYN W=10u L=1u
Mn_2_3_2 hv_2 vcn colno3 0 NSYN W=10u L=1u
Vg_2_3_3 g_2_3_3 0 2.760
Mp_2_3_3 hv_3 g_2_3_3 colpo3 0 NSYN W=10u L=1u
Mn_2_3_3 hv_3 vcn colno3 0 NSYN W=10u L=1u
Vg_2_3_b g_2_3_b 0 1.800
Mp_2_3_b bx g_2_3_b colpo3 0 NSYN W=10u L=1u
Mn_2_3_b bx vcn colno3 0 NSYN W=10u L=1u
Msa_o3 colno3 colno3 0 0 NMIR W=20u L=1u
Msb_o3 y_3 colno3 0 0 NMIR W=20u L=1u
Msc_o3 colpo3 colpo3 0 0 NMIR W=20u L=1u
Msd_o3 dpf_o3 colpo3 0 0 NMIR W=20u L=1u
Mse_o3 dpf_o3 dpf_o3 vdd vdd PMIR W=60u L=1u
Msf_o3 y_3 dpf_o3 vdd vdd PMIR W=60u L=1u
R_o3 y_3 vrefo 7000.0
Mcmp_1 cm_ps colno1 0 0 NMIR W=20u L=1u
Mcmq_1 cm_ps tg1    0 0 NMIR W=10u L=1u
Mcmr_1 cm_ns dpf_o1 vdd vdd PMIR W=60u L=1u
Mcms_1 cm_ns boff     vdd vdd PMIR W=10u L=1u
Mcmp_2 cm_ps colno2 0 0 NMIR W=20u L=1u
Mcmq_2 cm_ps tg2    0 0 NMIR W=10u L=1u
Mcmr_2 cm_ns dpf_o2 vdd vdd PMIR W=60u L=1u
Mcms_2 cm_ns boff     vdd vdd PMIR W=10u L=1u
Mcmp_3 cm_ps colno3 0 0 NMIR W=20u L=1u
Mcmq_3 cm_ps tg3    0 0 NMIR W=10u L=1u
Mcmr_3 cm_ns dpf_o3 vdd vdd PMIR W=60u L=1u
Mcms_3 cm_ns boff     vdd vdd PMIR W=10u L=1u
Mcmpd cm_ps cm_ps vdd vdd PMIR W=60u L=1u
Mcmnd cm_ns cm_ns 0 0 NMIR W=20u L=1u
Mcmsrc cmv cm_ps vdd vdd PMIR W=60u L=1u
Mcmsnk cmv cm_ns 0 0 NMIR W=20u L=1u
Rcm cmv vrefd 2333.3333333333335
Mcmcp cmvn cm_ns vdd vdd PMIR W=60u L=1u
Mcmcn cmvn cm_ps 0 0 NMIR W=20u L=1u
Rcmn cmvn vrefd 2333.3333333333335
Msf2_1 d2e_1 dpf_o1 vdd vdd PMIR W=60u L=1u
Msb2_1 d2e_1 colno1 0 0 NMIR W=20u L=1u
Moff_1 d2e_1 boff vdd vdd PMIR W=10u L=1u
Mtge_1 d2e_1 tg1 0 0 NMIR W=10u L=1u
Rde_1 d2e_1 cmv 7000.0
Msf2_2 d2e_2 dpf_o2 vdd vdd PMIR W=60u L=1u
Msb2_2 d2e_2 colno2 0 0 NMIR W=20u L=1u
Moff_2 d2e_2 boff vdd vdd PMIR W=10u L=1u
Mtge_2 d2e_2 tg2 0 0 NMIR W=10u L=1u
Rde_2 d2e_2 cmv 7000.0
Msf2_3 d2e_3 dpf_o3 vdd vdd PMIR W=60u L=1u
Msb2_3 d2e_3 colno3 0 0 NMIR W=20u L=1u
Moff_3 d2e_3 boff vdd vdd PMIR W=10u L=1u
Mtge_3 d2e_3 tg3 0 0 NMIR W=10u L=1u
Rde_3 d2e_3 cmv 7000.0
.control
  tran 0.05 0.8999999999999999 uic
  wrdata comp_trace.txt v(y_1) v(y_2) v(y_3) v(d2e_1) v(d2e_2) v(d2e_3) v(cmv)
  echo COMP_OK
.endc
.end
