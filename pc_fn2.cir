PC inference
.model NNR NMOS (LEVEL=1 VTO=0.2 KP=120u LAMBDA=0.02 GAMMA=0 PHI=0.7)
.model PNR PMOS (LEVEL=1 VTO=-0.2 KP=40u LAMBDA=0.02 GAMMA=0 PHI=0.7)
.subckt dsyn inp inn wp wn outp outn vdd vbn
* Gilbert synapse: out current ~ (inp-inn)(wp-wn), CONSTANT tail (gate vbn) so the common-mode
* current it sinks is the SAME regardless of weight -> every node sits at one common mode.
Mtail nt vbn 0 0 NNR W=400u L=100u
M5 na wp nt 0 NNR W=200u L=100u
M6 nb wn nt 0 NNR W=200u L=100u
M1 outp inp na 0 NNR W=200u L=100u
M2 outn inn na 0 NNR W=200u L=100u
M3 outn inp nb 0 NNR W=200u L=100u
M4 outp inn nb 0 NNR W=200u L=100u
.ends
.subckt cmld p n vdd
Rcs1 p cmx 300k
Rcs2 n cmx 300k
MLp p cmx vdd vdd PNR W=1000u L=100u
MLn n cmx vdd vdd PNR W=1000u L=100u
.ends
.subckt dneuron up un ap an vdd vbn
M1 an up tn 0 NNR W=200u L=100u
M2 ap un tn 0 NNR W=200u L=100u
Mt tn vbn 0 0 NNR W=200u L=100u
Xcm ap an vdd cmld
.ends
.subckt esub xp xn mp mn ep en vdd vbn
Mt nt vbn 0 0 NNR W=400u L=100u
M1x ep xn nt 0 NNR W=200u L=100u
M2x en xp nt 0 NNR W=200u L=100u
M1m ep mp nt 0 NNR W=200u L=100u
M2m en mn nt 0 NNR W=200u L=100u
RLp vdd ep 50k
RLn vdd en 50k
.ends
Vdd vdd 0 1.0
Vgm gm 0 0.6
Vbneu vbneu 0 0.40
Vbsyn vbsyn 0 0.45
Vrefn vrefn 0 0.5
Vbe vbe 0 0.45
Vx1p a_xp1 0 0.8
Vx1n a_xn1 0 0.2
Vx2p a_xp2 0 0.2
Vx2n a_xn2 0 0.8
Xcm_mh0 mhp0 mhn0 vdd cmld
Xcm_xh0 xhp0 xhn0 vdd cmld
Rnd_mh0 mhp0 mhn0 20k
Rnd_xh0 xhp0 xhn0 20k
Cxhp0 xhp0 0 0.4p
Cxhn0 xhn0 0 0.4p
Vwp_ihm_1_0 wp_ihm_1_0 0 0.5518
Vwn_ihm_1_0 wn_ihm_1_0 0 0.4482
X_ihm_1_0 a_xp1 a_xn1 wp_ihm_1_0 wn_ihm_1_0 mhp0 mhn0 vdd vbsyn dsyn
Vwp_ihx_1_0 wp_ihx_1_0 0 0.5518
Vwn_ihx_1_0 wn_ihx_1_0 0 0.4482
X_ihx_1_0 a_xp1 a_xn1 wp_ihx_1_0 wn_ihx_1_0 xhp0 xhn0 vdd vbsyn dsyn
Vwp_ihm_2_0 wp_ihm_2_0 0 0.6232
Vwn_ihm_2_0 wn_ihm_2_0 0 0.3768
X_ihm_2_0 a_xp2 a_xn2 wp_ihm_2_0 wn_ihm_2_0 mhp0 mhn0 vdd vbsyn dsyn
Vwp_ihx_2_0 wp_ihx_2_0 0 0.6232
Vwn_ihx_2_0 wn_ihx_2_0 0 0.3768
X_ihx_2_0 a_xp2 a_xn2 wp_ihx_2_0 wn_ihx_2_0 xhp0 xhn0 vdd vbsyn dsyn
Vwp_bk_0 wp_bk_0 0 0.5496
Vwn_bk_0 wn_bk_0 0 0.4504
X_bk_0 eop eon wp_bk_0 wn_bk_0 xhp0 xhn0 vdd vbsyn dsyn
Xn0 xhp0 xhn0 ahp0 ahn0 vdd vbneu dneuron
Xeh0 xhp0 xhn0 mhp0 mhn0 ehp0 ehn0 vdd gm esub
Xcm_mh1 mhp1 mhn1 vdd cmld
Xcm_xh1 xhp1 xhn1 vdd cmld
Rnd_mh1 mhp1 mhn1 20k
Rnd_xh1 xhp1 xhn1 20k
Cxhp1 xhp1 0 0.4p
Cxhn1 xhn1 0 0.4p
Vwp_ihm_1_1 wp_ihm_1_1 0 0.3045
Vwn_ihm_1_1 wn_ihm_1_1 0 0.6955
X_ihm_1_1 a_xp1 a_xn1 wp_ihm_1_1 wn_ihm_1_1 mhp1 mhn1 vdd vbsyn dsyn
Vwp_ihx_1_1 wp_ihx_1_1 0 0.3045
Vwn_ihx_1_1 wn_ihx_1_1 0 0.6955
X_ihx_1_1 a_xp1 a_xn1 wp_ihx_1_1 wn_ihx_1_1 xhp1 xhn1 vdd vbsyn dsyn
Vwp_ihm_2_1 wp_ihm_2_1 0 0.6358
Vwn_ihm_2_1 wn_ihm_2_1 0 0.3642
X_ihm_2_1 a_xp2 a_xn2 wp_ihm_2_1 wn_ihm_2_1 mhp1 mhn1 vdd vbsyn dsyn
Vwp_ihx_2_1 wp_ihx_2_1 0 0.6358
Vwn_ihx_2_1 wn_ihx_2_1 0 0.3642
X_ihx_2_1 a_xp2 a_xn2 wp_ihx_2_1 wn_ihx_2_1 xhp1 xhn1 vdd vbsyn dsyn
Vwp_bk_1 wp_bk_1 0 0.5670
Vwn_bk_1 wn_bk_1 0 0.4330
X_bk_1 eop eon wp_bk_1 wn_bk_1 xhp1 xhn1 vdd vbsyn dsyn
Xn1 xhp1 xhn1 ahp1 ahn1 vdd vbneu dneuron
Xeh1 xhp1 xhn1 mhp1 mhn1 ehp1 ehn1 vdd gm esub
Xcm_mh2 mhp2 mhn2 vdd cmld
Xcm_xh2 xhp2 xhn2 vdd cmld
Rnd_mh2 mhp2 mhn2 20k
Rnd_xh2 xhp2 xhn2 20k
Cxhp2 xhp2 0 0.4p
Cxhn2 xhn2 0 0.4p
Vwp_ihm_1_2 wp_ihm_1_2 0 0.4195
Vwn_ihm_1_2 wn_ihm_1_2 0 0.5805
X_ihm_1_2 a_xp1 a_xn1 wp_ihm_1_2 wn_ihm_1_2 mhp2 mhn2 vdd vbsyn dsyn
Vwp_ihx_1_2 wp_ihx_1_2 0 0.4195
Vwn_ihx_1_2 wn_ihx_1_2 0 0.5805
X_ihx_1_2 a_xp1 a_xn1 wp_ihx_1_2 wn_ihx_1_2 xhp2 xhn2 vdd vbsyn dsyn
Vwp_ihm_2_2 wp_ihm_2_2 0 0.5872
Vwn_ihm_2_2 wn_ihm_2_2 0 0.4128
X_ihm_2_2 a_xp2 a_xn2 wp_ihm_2_2 wn_ihm_2_2 mhp2 mhn2 vdd vbsyn dsyn
Vwp_ihx_2_2 wp_ihx_2_2 0 0.5872
Vwn_ihx_2_2 wn_ihx_2_2 0 0.4128
X_ihx_2_2 a_xp2 a_xn2 wp_ihx_2_2 wn_ihx_2_2 xhp2 xhn2 vdd vbsyn dsyn
Vwp_bk_2 wp_bk_2 0 0.5547
Vwn_bk_2 wn_bk_2 0 0.4453
X_bk_2 eop eon wp_bk_2 wn_bk_2 xhp2 xhn2 vdd vbsyn dsyn
Xn2 xhp2 xhn2 ahp2 ahn2 vdd vbneu dneuron
Xeh2 xhp2 xhn2 mhp2 mhn2 ehp2 ehn2 vdd gm esub
Xcm_mh3 mhp3 mhn3 vdd cmld
Xcm_xh3 xhp3 xhn3 vdd cmld
Rnd_mh3 mhp3 mhn3 20k
Rnd_xh3 xhp3 xhn3 20k
Cxhp3 xhp3 0 0.4p
Cxhn3 xhn3 0 0.4p
Vwp_ihm_1_3 wp_ihm_1_3 0 0.5441
Vwn_ihm_1_3 wn_ihm_1_3 0 0.4559
X_ihm_1_3 a_xp1 a_xn1 wp_ihm_1_3 wn_ihm_1_3 mhp3 mhn3 vdd vbsyn dsyn
Vwp_ihx_1_3 wp_ihx_1_3 0 0.5441
Vwn_ihx_1_3 wn_ihx_1_3 0 0.4559
X_ihx_1_3 a_xp1 a_xn1 wp_ihx_1_3 wn_ihx_1_3 xhp3 xhn3 vdd vbsyn dsyn
Vwp_ihm_2_3 wp_ihm_2_3 0 0.5043
Vwn_ihm_2_3 wn_ihm_2_3 0 0.4957
X_ihm_2_3 a_xp2 a_xn2 wp_ihm_2_3 wn_ihm_2_3 mhp3 mhn3 vdd vbsyn dsyn
Vwp_ihx_2_3 wp_ihx_2_3 0 0.5043
Vwn_ihx_2_3 wn_ihx_2_3 0 0.4957
X_ihx_2_3 a_xp2 a_xn2 wp_ihx_2_3 wn_ihx_2_3 xhp3 xhn3 vdd vbsyn dsyn
Vwp_bk_3 wp_bk_3 0 0.5820
Vwn_bk_3 wn_bk_3 0 0.4180
X_bk_3 eop eon wp_bk_3 wn_bk_3 xhp3 xhn3 vdd vbsyn dsyn
Xn3 xhp3 xhn3 ahp3 ahn3 vdd vbneu dneuron
Xeh3 xhp3 xhn3 mhp3 mhn3 ehp3 ehn3 vdd gm esub
Xcm_mo mop mon vdd cmld
Rnd_mo mop mon 20k
Vwp_ho_0 wp_ho_0 0 0.5496
Vwn_ho_0 wn_ho_0 0 0.4504
X_ho_0 ahp0 ahn0 wp_ho_0 wn_ho_0 mop mon vdd vbsyn dsyn
Vwp_ho_1 wp_ho_1 0 0.5670
Vwn_ho_1 wn_ho_1 0 0.4330
X_ho_1 ahp1 ahn1 wp_ho_1 wn_ho_1 mop mon vdd vbsyn dsyn
Vwp_ho_2 wp_ho_2 0 0.5547
Vwn_ho_2 wn_ho_2 0 0.4453
X_ho_2 ahp2 ahn2 wp_ho_2 wn_ho_2 mop mon vdd vbsyn dsyn
Vwp_ho_3 wp_ho_3 0 0.5820
Vwn_ho_3 wn_ho_3 0 0.4180
X_ho_3 ahp3 ahn3 wp_ho_3 wn_ho_3 mop mon vdd vbsyn dsyn
Veop eop 0 0.5
Veon eon 0 0.5
.save v(ahp0) v(ahn0) v(ahp1) v(ahn1)
.control
op
wrdata pcfn2.dat v(ahp0) v(ahn0) v(ahp1) v(ahn1) v(ahp2) v(ahn2) v(ahp3) v(ahn3) v(xhp0) v(xhn0) v(ehp0) v(ehn0) v(xhp1) v(xhn1) v(ehp1) v(ehn1) v(xhp2) v(xhn2) v(ehp2) v(ehn2) v(xhp3) v(xhn3) v(ehp3) v(ehn3) v(mop) v(mon) v(eop) v(eon)
.endc
.end
