diag
.model NNR NMOS (LEVEL=1 VTO=0.2 KP=120u LAMBDA=0.02 GAMMA=0 PHI=0.7)
.model PNR PMOS (LEVEL=1 VTO=-0.2 KP=40u LAMBDA=0.02 GAMMA=0 PHI=0.7)
.subckt gsyn inp inn wp wn outp outn vdd vbn
Mtail nt vbn 0 0 NNR W=400u L=100u
M5 na wp nt 0 NNR W=200u L=100u
M6 nb wn nt 0 NNR W=200u L=100u
M1 outp inp na 0 NNR W=200u L=100u
M2 outn inn na 0 NNR W=200u L=100u
M3 outn inp nb 0 NNR W=200u L=100u
M4 outp inn nb 0 NNR W=200u L=100u
.ends
.subckt cmld p n vdd
Rcs1 p cmx 300k
Rcs2 n cmx 300k
MLp p cmx vdd vdd PNR W=1000u L=100u
MLn n cmx vdd vdd PNR W=1000u L=100u
.ends
.subckt dneuron up un ap an vdd vbn
M1 an up tn 0 NNR W=200u L=100u
M2 ap un tn 0 NNR W=200u L=100u
Mt tn vbn 0 0 NNR W=200u L=100u
Xcm ap an vdd cmld
.ends
Vdd vdd 0 1.0
Vbsyn vbsyn 0 0.45
Vbneu vbneu 0 0.35
Vxp0 a_xp0 0 0.5
Vxn0 a_xn0 0 0.5
Vxp1 a_xp1 0 0.5
Vxn1 a_xn1 0 0.5
Vxp2 a_xp2 0 0.5
Vxn2 a_xn2 0 0.5
Vxp3 a_xp3 0 0.5
Vxn3 a_xn3 0 0.5
Vxp4 a_xp4 0 0.5
Vxn4 a_xn4 0 0.5
Vxp5 a_xp5 0 0.5
Vxn5 a_xn5 0 0.5
Vxp6 a_xp6 0 0.5
Vxn6 a_xn6 0 0.5
Vxp7 a_xp7 0 0.5
Vxn7 a_xn7 0 0.5
Vxp8 a_xp8 0 0.5
Vxn8 a_xn8 0 0.5
Vxp9 a_xp9 0 0.5
Vxn9 a_xn9 0 0.5
Vxp10 a_xp10 0 0.5
Vxn10 a_xn10 0 0.5
Vxp11 a_xp11 0 0.5
Vxn11 a_xn11 0 0.5
Vxp12 a_xp12 0 0.5
Vxn12 a_xn12 0 0.5
Vxp13 a_xp13 0 0.5
Vxn13 a_xn13 0 0.5
Vxp14 a_xp14 0 0.5
Vxn14 a_xn14 0 0.5
Vxp15 a_xp15 0 0.5
Vxn15 a_xn15 0 0.5
Vxp16 a_xp16 0 0.5
Vxn16 a_xn16 0 0.5
Vxp17 a_xp17 0 0.5
Vxn17 a_xn17 0 0.5
Vxp18 a_xp18 0 0.5
Vxn18 a_xn18 0 0.5
Vxp19 a_xp19 0 0.5
Vxn19 a_xn19 0 0.5
Vxp20 a_xp20 0 0.5
Vxn20 a_xn20 0 0.5
Vxp21 a_xp21 0 0.5
Vxn21 a_xn21 0 0.5
Vxp22 a_xp22 0 0.5
Vxn22 a_xn22 0 0.5
Vxp23 a_xp23 0 0.5
Vxn23 a_xn23 0 0.5
Vxp24 a_xp24 0 0.5
Vxn24 a_xn24 0 0.5
Vxp25 a_xp25 0 0.5
Vxn25 a_xn25 0 0.5
Vxp26 a_xp26 0 0.5
Vxn26 a_xn26 0 0.5
Vxp27 a_xp27 0 0.5
Vxn27 a_xn27 0 0.5
Vxp28 a_xp28 0 0.5
Vxn28 a_xn28 0 0.5
Vxp29 a_xp29 0 0.5
Vxn29 a_xn29 0 0.5
Vxp30 a_xp30 0 0.5
Vxn30 a_xn30 0 0.5
Vxp31 a_xp31 0 0.5
Vxn31 a_xn31 0 0.5
Vxp32 a_xp32 0 0.5
Vxn32 a_xn32 0 0.5
Vxp33 a_xp33 0 0.5
Vxn33 a_xn33 0 0.5
Vxp34 a_xp34 0 0.5
Vxn34 a_xn34 0 0.5
Vxp35 a_xp35 0 0.5
Vxn35 a_xn35 0 0.5
Vxp36 a_xp36 0 0.5
Vxn36 a_xn36 0 0.5
Vxp37 a_xp37 0 0.5
Vxn37 a_xn37 0 0.5
Vxp38 a_xp38 0 0.5
Vxn38 a_xn38 0 0.5
Vxp39 a_xp39 0 0.5
Vxn39 a_xn39 0 0.5
Vxp40 a_xp40 0 0.5
Vxn40 a_xn40 0 0.5
Vxp41 a_xp41 0 0.5
Vxn41 a_xn41 0 0.5
Vxp42 a_xp42 0 0.5
Vxn42 a_xn42 0 0.5
Vxp43 a_xp43 0 0.5
Vxn43 a_xn43 0 0.5
Vxp44 a_xp44 0 0.5
Vxn44 a_xn44 0 0.5
Vxp45 a_xp45 0 0.5
Vxn45 a_xn45 0 0.5
Vxp46 a_xp46 0 0.5
Vxn46 a_xn46 0 0.5
Vxp47 a_xp47 0 0.5
Vxn47 a_xn47 0 0.5
Vxp48 a_xp48 0 0.5
Vxn48 a_xn48 0 0.5
Vxp49 a_xp49 0 0.5
Vxn49 a_xn49 0 0.5
Vxp50 a_xp50 0 0.5
Vxn50 a_xn50 0 0.5
Vxp51 a_xp51 0 0.5
Vxn51 a_xn51 0 0.5
Vxp52 a_xp52 0 0.5
Vxn52 a_xn52 0 0.5
Vxp53 a_xp53 0 0.5
Vxn53 a_xn53 0 0.5
Vxp54 a_xp54 0 0.5
Vxn54 a_xn54 0 0.5
Vxp55 a_xp55 0 0.5
Vxn55 a_xn55 0 0.5
Vxp56 a_xp56 0 0.5
Vxn56 a_xn56 0 0.5
Vxp57 a_xp57 0 0.5
Vxn57 a_xn57 0 0.5
Vxp58 a_xp58 0 0.5
Vxn58 a_xn58 0 0.5
Vxp59 a_xp59 0 0.5
Vxn59 a_xn59 0 0.5
Vxp60 a_xp60 0 0.5
Vxn60 a_xn60 0 0.5
Vxp61 a_xp61 0 0.5
Vxn61 a_xn61 0 0.5
Vxp62 a_xp62 0 0.5
Vxn62 a_xn62 0 0.5
Vxp63 a_xp63 0 0.5
Vxn63 a_xn63 0 0.5
Vwp_ih_0_0 wp_ih_0_0 0 0.5428087644986996
Vwn_ih_0_0 wn_ih_0_0 0 0.4571912355013004
Vwp_ih_1_0 wp_ih_1_0 0 0.6289966999248773
Vwn_ih_1_0 wn_ih_1_0 0 0.3710033000751228
Vwp_ih_2_0 wp_ih_2_0 0 0.655502119532515
Vwn_ih_2_0 wn_ih_2_0 0 0.3444978804674849
Vwp_ih_3_0 wp_ih_3_0 0 0.49484165511464645
Vwn_ih_3_0 wn_ih_3_0 0 0.5051583448853535
Vwp_ih_4_0 wp_ih_4_0 0 0.5584882985952832
Vwn_ih_4_0 wn_ih_4_0 0 0.44151170140471685
Vwp_ih_5_0 wp_ih_5_0 0 0.5933244341170788
Vwn_ih_5_0 wn_ih_5_0 0 0.4066755658829212
Vwp_ih_6_0 wp_ih_6_0 0 0.46980764130905067
Vwn_ih_6_0 wn_ih_6_0 0 0.5301923586909493
Vwp_ih_7_0 wp_ih_7_0 0 0.3642231424193935
Vwn_ih_7_0 wn_ih_7_0 0 0.6357768575806064
Vwp_ih_8_0 wp_ih_8_0 0 0.5111738183532121
Vwn_ih_8_0 wn_ih_8_0 0 0.4888261816467879
Vwp_ih_9_0 wp_ih_9_0 0 0.3
Vwn_ih_9_0 wn_ih_9_0 0 0.7067791938728413
Vwp_ih_10_0 wp_ih_10_0 0 0.48881568296252453
Vwn_ih_10_0 wn_ih_10_0 0 0.5111843170374755
Vwp_ih_11_0 wp_ih_11_0 0 0.5655206783239688
Vwn_ih_11_0 wn_ih_11_0 0 0.4344793216760312
Vwp_ih_12_0 wp_ih_12_0 0 0.3720189022586843
Vwn_ih_12_0 wn_ih_12_0 0 0.6279810977413157
Vwp_ih_13_0 wp_ih_13_0 0 0.5093963250612117
Vwn_ih_13_0 wn_ih_13_0 0 0.4906036749387883
Vwp_ih_14_0 wp_ih_14_0 0 0.6079754258950669
Vwn_ih_14_0 wn_ih_14_0 0 0.3920245741049331
Vwp_ih_15_0 wp_ih_15_0 0 0.5334744234681449
Vwn_ih_15_0 wn_ih_15_0 0 0.46652557653185506
Vwp_ih_16_0 wp_ih_16_0 0 0.5534317389507961
Vwn_ih_16_0 wn_ih_16_0 0 0.4465682610492039
Vwp_ih_17_0 wp_ih_17_0 0 0.5426154452469747
Vwn_ih_17_0 wn_ih_17_0 0 0.4573845547530253
Vwp_ih_18_0 wp_ih_18_0 0 0.6679888165790134
Vwn_ih_18_0 wn_ih_18_0 0 0.33201118342098657
Vwp_ih_19_0 wp_ih_19_0 0 0.5075785223273436
Vwn_ih_19_0 wn_ih_19_0 0 0.4924214776726564
Vwp_ih_20_0 wp_ih_20_0 0 0.5740020319789624
Vwn_ih_20_0 wn_ih_20_0 0 0.4259979680210376
Vwp_ih_21_0 wp_ih_21_0 0 0.4990193287793464
Vwn_ih_21_0 wn_ih_21_0 0 0.5009806712206536
Vwp_ih_22_0 wp_ih_22_0 0 0.46641996778898814
Vwn_ih_22_0 wn_ih_22_0 0 0.5335800322110119
Vwp_ih_23_0 wp_ih_23_0 0 0.5214130216640928
Vwn_ih_23_0 wn_ih_23_0 0 0.47858697833590724
Vwp_ih_24_0 wp_ih_24_0 0 0.45002559479480514
Vwn_ih_24_0 wn_ih_24_0 0 0.5499744052051949
Vwp_ih_25_0 wp_ih_25_0 0 0.48436081996242625
Vwn_ih_25_0 wn_ih_25_0 0 0.5156391800375738
Vwp_ih_26_0 wp_ih_26_0 0 0.4932939220059835
Vwn_ih_26_0 wn_ih_26_0 0 0.5067060779940166
Vwp_ih_27_0 wp_ih_27_0 0 0.3074231945089014
Vwn_ih_27_0 wn_ih_27_0 0 0.6925768054910986
Vwp_ih_28_0 wp_ih_28_0 0 0.47608947677628355
Vwn_ih_28_0 wn_ih_28_0 0 0.5239105232237165
Vwp_ih_29_0 wp_ih_29_0 0 0.4027328501017063
Vwn_ih_29_0 wn_ih_29_0 0 0.5972671498982938
Vwp_ih_30_0 wp_ih_30_0 0 0.504513764131384
Vwn_ih_30_0 wn_ih_30_0 0 0.49548623586861595
Vwp_ih_31_0 wp_ih_31_0 0 0.6218822877657406
Vwn_ih_31_0 wn_ih_31_0 0 0.37811771223425933
Vwp_ih_32_0 wp_ih_32_0 0 0.4531099709203439
Vwn_ih_32_0 wn_ih_32_0 0 0.5468900290796561
Vwp_ih_33_0 wp_ih_33_0 0 0.4783279260332566
Vwn_ih_33_0 wn_ih_33_0 0 0.5216720739667434
Vwp_ih_34_0 wp_ih_34_0 0 0.6424122290750709
Vwn_ih_34_0 wn_ih_34_0 0 0.3575877709249291
Vwp_ih_35_0 wp_ih_35_0 0 0.5564247305480304
Vwn_ih_35_0 wn_ih_35_0 0 0.4435752694519696
Vwp_ih_36_0 wp_ih_36_0 0 0.5808469659158946
Vwn_ih_36_0 wn_ih_36_0 0 0.4191530340841054
Vwp_ih_37_0 wp_ih_37_0 0 0.4968803496437131
Vwn_ih_37_0 wn_ih_37_0 0 0.5031196503562869
Vwp_ih_38_0 wp_ih_38_0 0 0.5974936590347718
Vwn_ih_38_0 wn_ih_38_0 0 0.40250634096522825
Vwp_ih_39_0 wp_ih_39_0 0 0.4382448269758878
Vwn_ih_39_0 wn_ih_39_0 0 0.5617551730241122
Vwp_ih_40_0 wp_ih_40_0 0 0.44360845718330616
Vwn_ih_40_0 wn_ih_40_0 0 0.5563915428166939
Vwp_ih_41_0 wp_ih_41_0 0 0.5506106791857095
Vwn_ih_41_0 wn_ih_41_0 0 0.4493893208142905
Vwp_ih_42_0 wp_ih_42_0 0 0.4492981550706713
Vwn_ih_42_0 wn_ih_42_0 0 0.5507018449293287
Vwp_ih_43_0 wp_ih_43_0 0 0.5373649446717306
Vwn_ih_43_0 wn_ih_43_0 0 0.46263505532826943
Vwp_ih_44_0 wp_ih_44_0 0 0.7186737618486739
Vwn_ih_44_0 wn_ih_44_0 0 0.3
Vwp_ih_45_0 wp_ih_45_0 0 0.3772113525916569
Vwn_ih_45_0 wn_ih_45_0 0 0.622788647408343
Vwp_ih_46_0 wp_ih_46_0 0 0.43622912875291275
Vwn_ih_46_0 wn_ih_46_0 0 0.5637708712470872
Vwp_ih_47_0 wp_ih_47_0 0 0.6129065545889635
Vwn_ih_47_0 wn_ih_47_0 0 0.3870934454110365
Vwp_ih_48_0 wp_ih_48_0 0 0.489910131805162
Vwn_ih_48_0 wn_ih_48_0 0 0.5100898681948379
Vwp_ih_49_0 wp_ih_49_0 0 0.6198665565522217
Vwn_ih_49_0 wn_ih_49_0 0 0.38013344344777833
Vwp_ih_50_0 wp_ih_50_0 0 0.4143296792253039
Vwn_ih_50_0 wn_ih_50_0 0 0.585670320774696
Vwp_ih_51_0 wp_ih_51_0 0 0.4992613566453447
Vwn_ih_51_0 wn_ih_51_0 0 0.5007386433546552
Vwp_ih_52_0 wp_ih_52_0 0 0.4782614013056154
Vwn_ih_52_0 wn_ih_52_0 0 0.5217385986943845
Vwp_ih_53_0 wp_ih_53_0 0 0.5094190783110067
Vwn_ih_53_0 wn_ih_53_0 0 0.4905809216889932
Vwp_ih_54_0 wp_ih_54_0 0 0.5053800577441272
Vwn_ih_54_0 wn_ih_54_0 0 0.49461994225587286
Vwp_ih_55_0 wp_ih_55_0 0 0.4128551849931336
Vwn_ih_55_0 wn_ih_55_0 0 0.5871448150068663
Vwp_ih_56_0 wp_ih_56_0 0 0.4065431435955971
Vwn_ih_56_0 wn_ih_56_0 0 0.5934568564044028
Vwp_ih_57_0 wp_ih_57_0 0 0.6117108242349114
Vwn_ih_57_0 wn_ih_57_0 0 0.3882891757650886
Vwp_ih_58_0 wp_ih_58_0 0 0.4996856807479827
Vwn_ih_58_0 wn_ih_58_0 0 0.5003143192520173
Vwp_ih_59_0 wp_ih_59_0 0 0.4943425999224162
Vwn_ih_59_0 wn_ih_59_0 0 0.5056574000775839
Vwp_ih_60_0 wp_ih_60_0 0 0.4799323873443403
Vwn_ih_60_0 wn_ih_60_0 0 0.5200676126556597
Vwp_ih_61_0 wp_ih_61_0 0 0.5304584823434061
Vwn_ih_61_0 wn_ih_61_0 0 0.4695415176565939
Vwp_ih_62_0 wp_ih_62_0 0 0.3564439312303065
Vwn_ih_62_0 wn_ih_62_0 0 0.6435560687696935
Vwp_ih_63_0 wp_ih_63_0 0 0.4014656843300476
Vwn_ih_63_0 wn_ih_63_0 0 0.5985343156699524
Vwp_ho_0_0 wp_ho_0_0 0 0.4692688386292687
Vwn_ho_0_0 wn_ho_0_0 0 0.5307311613707313
Vwp_ho_0_1 wp_ho_0_1 0 0.4717258985149243
Vwn_ho_0_1 wn_ho_0_1 0 0.5282741014850757
Vwp_ho_0_2 wp_ho_0_2 0 0.46059524701701443
Vwn_ho_0_2 wn_ho_0_2 0 0.5394047529829856
Vwp_ho_0_3 wp_ho_0_3 0 0.5548598331433923
Vwn_ho_0_3 wn_ho_0_3 0 0.44514016685660773
Vwp_ho_0_4 wp_ho_0_4 0 0.4566212267706461
Vwn_ho_0_4 wn_ho_0_4 0 0.5433787732293539
Vwp_ih_0_1 wp_ih_0_1 0 0.617405742248579
Vwn_ih_0_1 wn_ih_0_1 0 0.38259425775142103
Vwp_ih_1_1 wp_ih_1_1 0 0.5173459072613676
Vwn_ih_1_1 wn_ih_1_1 0 0.48265409273863236
Vwp_ih_2_1 wp_ih_2_1 0 0.5715830561080342
Vwn_ih_2_1 wn_ih_2_1 0 0.42841694389196583
Vwp_ih_3_1 wp_ih_3_1 0 0.4715266750527102
Vwn_ih_3_1 wn_ih_3_1 0 0.5284733249472898
Vwp_ih_4_1 wp_ih_4_1 0 0.6613620324271924
Vwn_ih_4_1 wn_ih_4_1 0 0.3386379675728076
Vwp_ih_5_1 wp_ih_5_1 0 0.551923004112107
Vwn_ih_5_1 wn_ih_5_1 0 0.44807699588789296
Vwp_ih_6_1 wp_ih_6_1 0 0.5063285306470869
Vwn_ih_6_1 wn_ih_6_1 0 0.493671469352913
Vwp_ih_7_1 wp_ih_7_1 0 0.5276807422839236
Vwn_ih_7_1 wn_ih_7_1 0 0.4723192577160764
Vwp_ih_8_1 wp_ih_8_1 0 0.4213726467549151
Vwn_ih_8_1 wn_ih_8_1 0 0.5786273532450849
Vwp_ih_9_1 wp_ih_9_1 0 0.3796325215763312
Vwn_ih_9_1 wn_ih_9_1 0 0.6203674784236688
Vwp_ih_10_1 wp_ih_10_1 0 0.40556737271115206
Vwn_ih_10_1 wn_ih_10_1 0 0.5944326272888479
Vwp_ih_11_1 wp_ih_11_1 0 0.6355819365602416
Vwn_ih_11_1 wn_ih_11_1 0 0.36441806343975836
Vwp_ih_12_1 wp_ih_12_1 0 0.6426658640460383
Vwn_ih_12_1 wn_ih_12_1 0 0.35733413595396174
Vwp_ih_13_1 wp_ih_13_1 0 0.5108028417552881
Vwn_ih_13_1 wn_ih_13_1 0 0.48919715824471194
Vwp_ih_14_1 wp_ih_14_1 0 0.4421544418551225
Vwn_ih_14_1 wn_ih_14_1 0 0.5578455581448775
Vwp_ih_15_1 wp_ih_15_1 0 0.5718282155126241
Vwn_ih_15_1 wn_ih_15_1 0 0.4281717844873759
Vwp_ih_16_1 wp_ih_16_1 0 0.4804397921710568
Vwn_ih_16_1 wn_ih_16_1 0 0.5195602078289432
Vwp_ih_17_1 wp_ih_17_1 0 0.43580219595305875
Vwn_ih_17_1 wn_ih_17_1 0 0.5641978040469412
Vwp_ih_18_1 wp_ih_18_1 0 0.6140254523753831
Vwn_ih_18_1 wn_ih_18_1 0 0.3859745476246169
Vwp_ih_19_1 wp_ih_19_1 0 0.5768469545566612
Vwn_ih_19_1 wn_ih_19_1 0 0.42315304544333876
Vwp_ih_20_1 wp_ih_20_1 0 0.3470314263292691
Vwn_ih_20_1 wn_ih_20_1 0 0.6529685736707309
Vwp_ih_21_1 wp_ih_21_1 0 0.4713759716566317
Vwn_ih_21_1 wn_ih_21_1 0 0.5286240283433683
Vwp_ih_22_1 wp_ih_22_1 0 0.5036181065418329
Vwn_ih_22_1 wn_ih_22_1 0 0.4963818934581671
Vwp_ih_23_1 wp_ih_23_1 0 0.5335509850018088
Vwn_ih_23_1 wn_ih_23_1 0 0.46644901499819125
Vwp_ih_24_1 wp_ih_24_1 0 0.5078988094967728
Vwn_ih_24_1 wn_ih_24_1 0 0.49210119050322726
Vwp_ih_25_1 wp_ih_25_1 0 0.41766032267359043
Vwn_ih_25_1 wn_ih_25_1 0 0.5823396773264096
Vwp_ih_26_1 wp_ih_26_1 0 0.454550696590281
Vwn_ih_26_1 wn_ih_26_1 0 0.545449303409719
Vwp_ih_27_1 wp_ih_27_1 0 0.5649207878492009
Vwn_ih_27_1 wn_ih_27_1 0 0.4350792121507992
Vwp_ih_28_1 wp_ih_28_1 0 0.516819507340114
Vwn_ih_28_1 wn_ih_28_1 0 0.4831804926598861
Vwp_ih_29_1 wp_ih_29_1 0 0.4701409151783136
Vwn_ih_29_1 wn_ih_29_1 0 0.5298590848216864
Vwp_ih_30_1 wp_ih_30_1 0 0.6324143931806054
Vwn_ih_30_1 wn_ih_30_1 0 0.3675856068193945
Vwp_ih_31_1 wp_ih_31_1 0 0.40796735161540515
Vwn_ih_31_1 wn_ih_31_1 0 0.5920326483845949
Vwp_ih_32_1 wp_ih_32_1 0 0.4685482876001079
Vwn_ih_32_1 wn_ih_32_1 0 0.5314517123998921
Vwp_ih_33_1 wp_ih_33_1 0 0.3
Vwn_ih_33_1 wn_ih_33_1 0 0.7066054817805791
Vwp_ih_34_1 wp_ih_34_1 0 0.5267635879419256
Vwn_ih_34_1 wn_ih_34_1 0 0.47323641205807443
Vwp_ih_35_1 wp_ih_35_1 0 0.5440843465866834
Vwn_ih_35_1 wn_ih_35_1 0 0.4559156534133167
Vwp_ih_36_1 wp_ih_36_1 0 0.5417539382411798
Vwn_ih_36_1 wn_ih_36_1 0 0.45824606175882027
Vwp_ih_37_1 wp_ih_37_1 0 0.6166762193614233
Vwn_ih_37_1 wn_ih_37_1 0 0.38332378063857675
Vwp_ih_38_1 wp_ih_38_1 0 0.5210918655628911
Vwn_ih_38_1 wn_ih_38_1 0 0.47890813443710883
Vwp_ih_39_1 wp_ih_39_1 0 0.530826385185807
Vwn_ih_39_1 wn_ih_39_1 0 0.4691736148141929
Vwp_ih_40_1 wp_ih_40_1 0 0.5245555999202188
Vwn_ih_40_1 wn_ih_40_1 0 0.4754444000797812
Vwp_ih_41_1 wp_ih_41_1 0 0.4347722247628324
Vwn_ih_41_1 wn_ih_41_1 0 0.5652277752371676
Vwp_ih_42_1 wp_ih_42_1 0 0.5963512247009675
Vwn_ih_42_1 wn_ih_42_1 0 0.4036487752990326
Vwp_ih_43_1 wp_ih_43_1 0 0.4389175892356073
Vwn_ih_43_1 wn_ih_43_1 0 0.5610824107643927
Vwp_ih_44_1 wp_ih_44_1 0 0.34541604969725226
Vwn_ih_44_1 wn_ih_44_1 0 0.6545839503027477
Vwp_ih_45_1 wp_ih_45_1 0 0.5713514875860054
Vwn_ih_45_1 wn_ih_45_1 0 0.4286485124139946
Vwp_ih_46_1 wp_ih_46_1 0 0.7286140853576952
Vwn_ih_46_1 wn_ih_46_1 0 0.3
Vwp_ih_47_1 wp_ih_47_1 0 0.3981802377632804
Vwn_ih_47_1 wn_ih_47_1 0 0.6018197622367196
Vwp_ih_48_1 wp_ih_48_1 0 0.48673016631746413
Vwn_ih_48_1 wn_ih_48_1 0 0.5132698336825359
Vwp_ih_49_1 wp_ih_49_1 0 0.39004587626115195
Vwn_ih_49_1 wn_ih_49_1 0 0.609954123738848
Vwp_ih_50_1 wp_ih_50_1 0 0.49237374233662484
Vwn_ih_50_1 wn_ih_50_1 0 0.5076262576633752
Vwp_ih_51_1 wp_ih_51_1 0 0.534536245575159
Vwn_ih_51_1 wn_ih_51_1 0 0.465463754424841
Vwp_ih_52_1 wp_ih_52_1 0 0.3965629347435894
Vwn_ih_52_1 wn_ih_52_1 0 0.6034370652564106
Vwp_ih_53_1 wp_ih_53_1 0 0.4932645993081928
Vwn_ih_53_1 wn_ih_53_1 0 0.5067354006918072
Vwp_ih_54_1 wp_ih_54_1 0 0.4488947206403462
Vwn_ih_54_1 wn_ih_54_1 0 0.5511052793596538
Vwp_ih_55_1 wp_ih_55_1 0 0.4422923829007722
Vwn_ih_55_1 wn_ih_55_1 0 0.5577076170992278
Vwp_ih_56_1 wp_ih_56_1 0 0.3891573822426092
Vwn_ih_56_1 wn_ih_56_1 0 0.6108426177573908
Vwp_ih_57_1 wp_ih_57_1 0 0.41258908879155676
Vwn_ih_57_1 wn_ih_57_1 0 0.5874109112084432
Vwp_ih_58_1 wp_ih_58_1 0 0.34653344250916607
Vwn_ih_58_1 wn_ih_58_1 0 0.6534665574908339
Vwp_ih_59_1 wp_ih_59_1 0 0.635579364434907
Vwn_ih_59_1 wn_ih_59_1 0 0.36442063556509297
Vwp_ih_60_1 wp_ih_60_1 0 0.5948949408859829
Vwn_ih_60_1 wn_ih_60_1 0 0.40510505911401706
Vwp_ih_61_1 wp_ih_61_1 0 0.40416356805923903
Vwn_ih_61_1 wn_ih_61_1 0 0.595836431940761
Vwp_ih_62_1 wp_ih_62_1 0 0.49100870061777174
Vwn_ih_62_1 wn_ih_62_1 0 0.5089912993822282
Vwp_ih_63_1 wp_ih_63_1 0 0.43838457767259936
Vwn_ih_63_1 wn_ih_63_1 0 0.5616154223274006
Vwp_ho_1_0 wp_ho_1_0 0 0.3541678468961017
Vwn_ho_1_0 wn_ho_1_0 0 0.6458321531038983
Vwp_ho_1_1 wp_ho_1_1 0 0.33354101417903603
Vwn_ho_1_1 wn_ho_1_1 0 0.666458985820964
Vwp_ho_1_2 wp_ho_1_2 0 0.3
Vwn_ho_1_2 wn_ho_1_2 0 0.7350083323383103
Vwp_ho_1_3 wp_ho_1_3 0 0.37949290324635254
Vwn_ho_1_3 wn_ho_1_3 0 0.6205070967536475
Vwp_ho_1_4 wp_ho_1_4 0 0.42858175581188174
Vwn_ho_1_4 wn_ho_1_4 0 0.5714182441881183
Vwp_ih_0_2 wp_ih_0_2 0 0.4378150284648263
Vwn_ih_0_2 wn_ih_0_2 0 0.5621849715351737
Vwp_ih_1_2 wp_ih_1_2 0 0.3663178330020361
Vwn_ih_1_2 wn_ih_1_2 0 0.633682166997964
Vwp_ih_2_2 wp_ih_2_2 0 0.5709322474677441
Vwn_ih_2_2 wn_ih_2_2 0 0.429067752532256
Vwp_ih_3_2 wp_ih_3_2 0 0.4682771396960798
Vwn_ih_3_2 wn_ih_3_2 0 0.5317228603039201
Vwp_ih_4_2 wp_ih_4_2 0 0.5151003480095492
Vwn_ih_4_2 wn_ih_4_2 0 0.4848996519904508
Vwp_ih_5_2 wp_ih_5_2 0 0.5490246157120653
Vwn_ih_5_2 wn_ih_5_2 0 0.45097538428793466
Vwp_ih_6_2 wp_ih_6_2 0 0.6346301659396656
Vwn_ih_6_2 wn_ih_6_2 0 0.3653698340603344
Vwp_ih_7_2 wp_ih_7_2 0 0.34190876187873176
Vwn_ih_7_2 wn_ih_7_2 0 0.6580912381212682
Vwp_ih_8_2 wp_ih_8_2 0 0.6585888073649071
Vwn_ih_8_2 wn_ih_8_2 0 0.3414111926350929
Vwp_ih_9_2 wp_ih_9_2 0 0.6075610031379981
Vwn_ih_9_2 wn_ih_9_2 0 0.3924389968620019
Vwp_ih_10_2 wp_ih_10_2 0 0.5513845914405857
Vwn_ih_10_2 wn_ih_10_2 0 0.44861540855941423
Vwp_ih_11_2 wp_ih_11_2 0 0.6988800272846019
Vwn_ih_11_2 wn_ih_11_2 0 0.30111997271539814
Vwp_ih_12_2 wp_ih_12_2 0 0.5257008313118032
Vwn_ih_12_2 wn_ih_12_2 0 0.47429916868819677
Vwp_ih_13_2 wp_ih_13_2 0 0.5721224450184447
Vwn_ih_13_2 wn_ih_13_2 0 0.4278775549815553
Vwp_ih_14_2 wp_ih_14_2 0 0.4078601938869476
Vwn_ih_14_2 wn_ih_14_2 0 0.5921398061130524
Vwp_ih_15_2 wp_ih_15_2 0 0.5922604965155287
Vwn_ih_15_2 wn_ih_15_2 0 0.4077395034844713
Vwp_ih_16_2 wp_ih_16_2 0 0.5166140970537411
Vwn_ih_16_2 wn_ih_16_2 0 0.48338590294625894
Vwp_ih_17_2 wp_ih_17_2 0 0.4673720117909132
Vwn_ih_17_2 wn_ih_17_2 0 0.5326279882090867
Vwp_ih_18_2 wp_ih_18_2 0 0.6705570744278118
Vwn_ih_18_2 wn_ih_18_2 0 0.32944292557218824
Vwp_ih_19_2 wp_ih_19_2 0 0.4881847040304735
Vwn_ih_19_2 wn_ih_19_2 0 0.5118152959695265
Vwp_ih_20_2 wp_ih_20_2 0 0.5427367447939807
Vwn_ih_20_2 wn_ih_20_2 0 0.45726325520601935
Vwp_ih_21_2 wp_ih_21_2 0 0.4671365162705951
Vwn_ih_21_2 wn_ih_21_2 0 0.5328634837294048
Vwp_ih_22_2 wp_ih_22_2 0 0.44316105036123393
Vwn_ih_22_2 wn_ih_22_2 0 0.5568389496387661
Vwp_ih_23_2 wp_ih_23_2 0 0.5257490084423994
Vwn_ih_23_2 wn_ih_23_2 0 0.4742509915576006
Vwp_ih_24_2 wp_ih_24_2 0 0.5678577854107385
Vwn_ih_24_2 wn_ih_24_2 0 0.4321422145892615
Vwp_ih_25_2 wp_ih_25_2 0 0.5321654832636432
Vwn_ih_25_2 wn_ih_25_2 0 0.4678345167363568
Vwp_ih_26_2 wp_ih_26_2 0 0.3
Vwn_ih_26_2 wn_ih_26_2 0 0.7054673028161467
Vwp_ih_27_2 wp_ih_27_2 0 0.6196672548343413
Vwn_ih_27_2 wn_ih_27_2 0 0.38033274516565874
Vwp_ih_28_2 wp_ih_28_2 0 0.4703730059666365
Vwn_ih_28_2 wn_ih_28_2 0 0.5296269940333634
Vwp_ih_29_2 wp_ih_29_2 0 0.4014348989326074
Vwn_ih_29_2 wn_ih_29_2 0 0.5985651010673926
Vwp_ih_30_2 wp_ih_30_2 0 0.5562051884999382
Vwn_ih_30_2 wn_ih_30_2 0 0.4437948115000618
Vwp_ih_31_2 wp_ih_31_2 0 0.5412249995885617
Vwn_ih_31_2 wn_ih_31_2 0 0.4587750004114383
Vwp_ih_32_2 wp_ih_32_2 0 0.4061233667946797
Vwn_ih_32_2 wn_ih_32_2 0 0.5938766332053202
Vwp_ih_33_2 wp_ih_33_2 0 0.7122076095911775
Vwn_ih_33_2 wn_ih_33_2 0 0.3
Vwp_ih_34_2 wp_ih_34_2 0 0.3851611289986432
Vwn_ih_34_2 wn_ih_34_2 0 0.6148388710013568
Vwp_ih_35_2 wp_ih_35_2 0 0.35102716380679944
Vwn_ih_35_2 wn_ih_35_2 0 0.6489728361932006
Vwp_ih_36_2 wp_ih_36_2 0 0.42127231287938516
Vwn_ih_36_2 wn_ih_36_2 0 0.5787276871206148
Vwp_ih_37_2 wp_ih_37_2 0 0.6412170567369294
Vwn_ih_37_2 wn_ih_37_2 0 0.3587829432630706
Vwp_ih_38_2 wp_ih_38_2 0 0.4496371746904997
Vwn_ih_38_2 wn_ih_38_2 0 0.5503628253095003
Vwp_ih_39_2 wp_ih_39_2 0 0.46651489809366276
Vwn_ih_39_2 wn_ih_39_2 0 0.5334851019063372
Vwp_ih_40_2 wp_ih_40_2 0 0.5088338557480646
Vwn_ih_40_2 wn_ih_40_2 0 0.4911661442519354
Vwp_ih_41_2 wp_ih_41_2 0 0.4461923400404801
Vwn_ih_41_2 wn_ih_41_2 0 0.5538076599595199
Vwp_ih_42_2 wp_ih_42_2 0 0.44429549414581154
Vwn_ih_42_2 wn_ih_42_2 0 0.5557045058541885
Vwp_ih_43_2 wp_ih_43_2 0 0.45229203802018925
Vwn_ih_43_2 wn_ih_43_2 0 0.5477079619798108
Vwp_ih_44_2 wp_ih_44_2 0 0.5860397820047977
Vwn_ih_44_2 wn_ih_44_2 0 0.41396021799520233
Vwp_ih_45_2 wp_ih_45_2 0 0.5629437727173445
Vwn_ih_45_2 wn_ih_45_2 0 0.4370562272826554
Vwp_ih_46_2 wp_ih_46_2 0 0.3979813571134848
Vwn_ih_46_2 wn_ih_46_2 0 0.6020186428865152
Vwp_ih_47_2 wp_ih_47_2 0 0.525255033485543
Vwn_ih_47_2 wn_ih_47_2 0 0.47474496651445697
Vwp_ih_48_2 wp_ih_48_2 0 0.5707139014800542
Vwn_ih_48_2 wn_ih_48_2 0 0.4292860985199458
Vwp_ih_49_2 wp_ih_49_2 0 0.4219561621230894
Vwn_ih_49_2 wn_ih_49_2 0 0.5780438378769106
Vwp_ih_50_2 wp_ih_50_2 0 0.45804212088991175
Vwn_ih_50_2 wn_ih_50_2 0 0.5419578791100882
Vwp_ih_51_2 wp_ih_51_2 0 0.40193604032465013
Vwn_ih_51_2 wn_ih_51_2 0 0.5980639596753499
Vwp_ih_52_2 wp_ih_52_2 0 0.3750118586655058
Vwn_ih_52_2 wn_ih_52_2 0 0.6249881413344942
Vwp_ih_53_2 wp_ih_53_2 0 0.4914613340354093
Vwn_ih_53_2 wn_ih_53_2 0 0.5085386659645906
Vwp_ih_54_2 wp_ih_54_2 0 0.4287956704729088
Vwn_ih_54_2 wn_ih_54_2 0 0.5712043295270912
Vwp_ih_55_2 wp_ih_55_2 0 0.5576942144024981
Vwn_ih_55_2 wn_ih_55_2 0 0.44230578559750183
Vwp_ih_56_2 wp_ih_56_2 0 0.49834233964783325
Vwn_ih_56_2 wn_ih_56_2 0 0.5016576603521667
Vwp_ih_57_2 wp_ih_57_2 0 0.5470636738124702
Vwn_ih_57_2 wn_ih_57_2 0 0.45293632618752977
Vwp_ih_58_2 wp_ih_58_2 0 0.45641032378947743
Vwn_ih_58_2 wn_ih_58_2 0 0.5435896762105226
Vwp_ih_59_2 wp_ih_59_2 0 0.42272282398183125
Vwn_ih_59_2 wn_ih_59_2 0 0.5772771760181687
Vwp_ih_60_2 wp_ih_60_2 0 0.4849384903400557
Vwn_ih_60_2 wn_ih_60_2 0 0.5150615096599443
Vwp_ih_61_2 wp_ih_61_2 0 0.5157442259539571
Vwn_ih_61_2 wn_ih_61_2 0 0.4842557740460429
Vwp_ih_62_2 wp_ih_62_2 0 0.4223336736034439
Vwn_ih_62_2 wn_ih_62_2 0 0.577666326396556
Vwp_ih_63_2 wp_ih_63_2 0 0.530352746222032
Vwn_ih_63_2 wn_ih_63_2 0 0.469647253777968
Vwp_ho_2_0 wp_ho_2_0 0 0.3224462588097235
Vwn_ho_2_0 wn_ho_2_0 0 0.6775537411902766
Vwp_ho_2_1 wp_ho_2_1 0 0.5848964270865862
Vwn_ho_2_1 wn_ho_2_1 0 0.4151035729134138
Vwp_ho_2_2 wp_ho_2_2 0 0.35688070473707545
Vwn_ho_2_2 wn_ho_2_2 0 0.6431192952629246
Vwp_ho_2_3 wp_ho_2_3 0 0.4833192217773981
Vwn_ho_2_3 wn_ho_2_3 0 0.5166807782226019
Vwp_ho_2_4 wp_ho_2_4 0 0.4986073073406655
Vwn_ho_2_4 wn_ho_2_4 0 0.5013926926593345
Vwp_ih_0_3 wp_ih_0_3 0 0.5671935370378822
Vwn_ih_0_3 wn_ih_0_3 0 0.43280646296211783
Vwp_ih_1_3 wp_ih_1_3 0 0.5042058854186243
Vwn_ih_1_3 wn_ih_1_3 0 0.4957941145813757
Vwp_ih_2_3 wp_ih_2_3 0 0.6520673025189903
Vwn_ih_2_3 wn_ih_2_3 0 0.34793269748100975
Vwp_ih_3_3 wp_ih_3_3 0 0.46990241999374344
Vwn_ih_3_3 wn_ih_3_3 0 0.5300975800062566
Vwp_ih_4_3 wp_ih_4_3 0 0.5154743416861401
Vwn_ih_4_3 wn_ih_4_3 0 0.48452565831385985
Vwp_ih_5_3 wp_ih_5_3 0 0.4176863963526233
Vwn_ih_5_3 wn_ih_5_3 0 0.5823136036473767
Vwp_ih_6_3 wp_ih_6_3 0 0.49258146734200753
Vwn_ih_6_3 wn_ih_6_3 0 0.5074185326579925
Vwp_ih_7_3 wp_ih_7_3 0 0.4224802566220049
Vwn_ih_7_3 wn_ih_7_3 0 0.5775197433779952
Vwp_ih_8_3 wp_ih_8_3 0 0.6011419526664487
Vwn_ih_8_3 wn_ih_8_3 0 0.3988580473335513
Vwp_ih_9_3 wp_ih_9_3 0 0.5456364213878107
Vwn_ih_9_3 wn_ih_9_3 0 0.4543635786121893
Vwp_ih_10_3 wp_ih_10_3 0 0.5536179390943409
Vwn_ih_10_3 wn_ih_10_3 0 0.4463820609056592
Vwp_ih_11_3 wp_ih_11_3 0 0.40349975128165694
Vwn_ih_11_3 wn_ih_11_3 0 0.5965002487183431
Vwp_ih_12_3 wp_ih_12_3 0 0.4773957964994297
Vwn_ih_12_3 wn_ih_12_3 0 0.5226042035005704
Vwp_ih_13_3 wp_ih_13_3 0 0.42479373811691895
Vwn_ih_13_3 wn_ih_13_3 0 0.5752062618830811
Vwp_ih_14_3 wp_ih_14_3 0 0.449374128869073
Vwn_ih_14_3 wn_ih_14_3 0 0.550625871130927
Vwp_ih_15_3 wp_ih_15_3 0 0.43697418323887827
Vwn_ih_15_3 wn_ih_15_3 0 0.5630258167611217
Vwp_ih_16_3 wp_ih_16_3 0 0.4902486583360542
Vwn_ih_16_3 wn_ih_16_3 0 0.5097513416639458
Vwp_ih_17_3 wp_ih_17_3 0 0.562216734065513
Vwn_ih_17_3 wn_ih_17_3 0 0.437783265934487
Vwp_ih_18_3 wp_ih_18_3 0 0.5111082075847526
Vwn_ih_18_3 wn_ih_18_3 0 0.48889179241524733
Vwp_ih_19_3 wp_ih_19_3 0 0.4909785260064553
Vwn_ih_19_3 wn_ih_19_3 0 0.5090214739935447
Vwp_ih_20_3 wp_ih_20_3 0 0.531481988978662
Vwn_ih_20_3 wn_ih_20_3 0 0.4685180110213381
Vwp_ih_21_3 wp_ih_21_3 0 0.5788299551169683
Vwn_ih_21_3 wn_ih_21_3 0 0.4211700448830317
Vwp_ih_22_3 wp_ih_22_3 0 0.42690387385192097
Vwn_ih_22_3 wn_ih_22_3 0 0.573096126148079
Vwp_ih_23_3 wp_ih_23_3 0 0.5090797211748056
Vwn_ih_23_3 wn_ih_23_3 0 0.4909202788251944
Vwp_ih_24_3 wp_ih_24_3 0 0.4925795845058457
Vwn_ih_24_3 wn_ih_24_3 0 0.5074204154941543
Vwp_ih_25_3 wp_ih_25_3 0 0.5080111482405274
Vwn_ih_25_3 wn_ih_25_3 0 0.4919888517594726
Vwp_ih_26_3 wp_ih_26_3 0 0.48874842730210466
Vwn_ih_26_3 wn_ih_26_3 0 0.5112515726978953
Vwp_ih_27_3 wp_ih_27_3 0 0.46827922517415577
Vwn_ih_27_3 wn_ih_27_3 0 0.5317207748258442
Vwp_ih_28_3 wp_ih_28_3 0 0.422110217134806
Vwn_ih_28_3 wn_ih_28_3 0 0.577889782865194
Vwp_ih_29_3 wp_ih_29_3 0 0.4617081761638097
Vwn_ih_29_3 wn_ih_29_3 0 0.5382918238361903
Vwp_ih_30_3 wp_ih_30_3 0 0.4590400974911238
Vwn_ih_30_3 wn_ih_30_3 0 0.5409599025088762
Vwp_ih_31_3 wp_ih_31_3 0 0.5470049031125966
Vwn_ih_31_3 wn_ih_31_3 0 0.45299509688740336
Vwp_ih_32_3 wp_ih_32_3 0 0.49071029591421306
Vwn_ih_32_3 wn_ih_32_3 0 0.5092897040857869
Vwp_ih_33_3 wp_ih_33_3 0 0.5160910422415044
Vwn_ih_33_3 wn_ih_33_3 0 0.48390895775849563
Vwp_ih_34_3 wp_ih_34_3 0 0.4371433331976463
Vwn_ih_34_3 wn_ih_34_3 0 0.5628566668023537
Vwp_ih_35_3 wp_ih_35_3 0 0.5266289724532968
Vwn_ih_35_3 wn_ih_35_3 0 0.4733710275467033
Vwp_ih_36_3 wp_ih_36_3 0 0.5396094802024182
Vwn_ih_36_3 wn_ih_36_3 0 0.46039051979758183
Vwp_ih_37_3 wp_ih_37_3 0 0.5435383687112787
Vwn_ih_37_3 wn_ih_37_3 0 0.4564616312887213
Vwp_ih_38_3 wp_ih_38_3 0 0.6950175453355685
Vwn_ih_38_3 wn_ih_38_3 0 0.3049824546644315
Vwp_ih_39_3 wp_ih_39_3 0 0.4952732555936234
Vwn_ih_39_3 wn_ih_39_3 0 0.5047267444063767
Vwp_ih_40_3 wp_ih_40_3 0 0.6075594959621214
Vwn_ih_40_3 wn_ih_40_3 0 0.3924405040378785
Vwp_ih_41_3 wp_ih_41_3 0 0.5488570759466798
Vwn_ih_41_3 wn_ih_41_3 0 0.45114292405332024
Vwp_ih_42_3 wp_ih_42_3 0 0.5042169811117402
Vwn_ih_42_3 wn_ih_42_3 0 0.49578301888825976
Vwp_ih_43_3 wp_ih_43_3 0 0.5485511272270255
Vwn_ih_43_3 wn_ih_43_3 0 0.4514488727729745
Vwp_ih_44_3 wp_ih_44_3 0 0.5310327355339817
Vwn_ih_44_3 wn_ih_44_3 0 0.4689672644660183
Vwp_ih_45_3 wp_ih_45_3 0 0.5418998939153141
Vwn_ih_45_3 wn_ih_45_3 0 0.4581001060846859
Vwp_ih_46_3 wp_ih_46_3 0 0.47510126178668005
Vwn_ih_46_3 wn_ih_46_3 0 0.52489873821332
Vwp_ih_47_3 wp_ih_47_3 0 0.5016792119739409
Vwn_ih_47_3 wn_ih_47_3 0 0.49832078802605906
Vwp_ih_48_3 wp_ih_48_3 0 0.5511539582627055
Vwn_ih_48_3 wn_ih_48_3 0 0.4488460417372945
Vwp_ih_49_3 wp_ih_49_3 0 0.6103429398811459
Vwn_ih_49_3 wn_ih_49_3 0 0.38965706011885415
Vwp_ih_50_3 wp_ih_50_3 0 0.41701882082806824
Vwn_ih_50_3 wn_ih_50_3 0 0.5829811791719318
Vwp_ih_51_3 wp_ih_51_3 0 0.3866686597344391
Vwn_ih_51_3 wn_ih_51_3 0 0.6133313402655609
Vwp_ih_52_3 wp_ih_52_3 0 0.4371457048704798
Vwn_ih_52_3 wn_ih_52_3 0 0.5628542951295202
Vwp_ih_53_3 wp_ih_53_3 0 0.5159146864683536
Vwn_ih_53_3 wn_ih_53_3 0 0.4840853135316464
Vwp_ih_54_3 wp_ih_54_3 0 0.5700646538757147
Vwn_ih_54_3 wn_ih_54_3 0 0.42993534612428524
Vwp_ih_55_3 wp_ih_55_3 0 0.4865758225481325
Vwn_ih_55_3 wn_ih_55_3 0 0.5134241774518675
Vwp_ih_56_3 wp_ih_56_3 0 0.6059180825205628
Vwn_ih_56_3 wn_ih_56_3 0 0.39408191747943727
Vwp_ih_57_3 wp_ih_57_3 0 0.5826561571752944
Vwn_ih_57_3 wn_ih_57_3 0 0.4173438428247056
Vwp_ih_58_3 wp_ih_58_3 0 0.5207371024208223
Vwn_ih_58_3 wn_ih_58_3 0 0.4792628975791777
Vwp_ih_59_3 wp_ih_59_3 0 0.477449849244587
Vwn_ih_59_3 wn_ih_59_3 0 0.522550150755413
Vwp_ih_60_3 wp_ih_60_3 0 0.47584994629599275
Vwn_ih_60_3 wn_ih_60_3 0 0.5241500537040072
Vwp_ih_61_3 wp_ih_61_3 0 0.45563480889244423
Vwn_ih_61_3 wn_ih_61_3 0 0.5443651911075558
Vwp_ih_62_3 wp_ih_62_3 0 0.5024738034974453
Vwn_ih_62_3 wn_ih_62_3 0 0.4975261965025547
Vwp_ih_63_3 wp_ih_63_3 0 0.3608305598738228
Vwn_ih_63_3 wn_ih_63_3 0 0.6391694401261772
Vwp_ho_3_0 wp_ho_3_0 0 0.59971229832204
Vwn_ho_3_0 wn_ho_3_0 0 0.40028770167795996
Vwp_ho_3_1 wp_ho_3_1 0 0.4972486360537796
Vwn_ho_3_1 wn_ho_3_1 0 0.5027513639462203
Vwp_ho_3_2 wp_ho_3_2 0 0.38094832853950017
Vwn_ho_3_2 wn_ho_3_2 0 0.6190516714604998
Vwp_ho_3_3 wp_ho_3_3 0 0.4319568274755684
Vwn_ho_3_3 wn_ho_3_3 0 0.5680431725244316
Vwp_ho_3_4 wp_ho_3_4 0 0.8252017861457228
Vwn_ho_3_4 wn_ho_3_4 0 0.3
Vwp_ih_0_4 wp_ih_0_4 0 0.45850633307216393
Vwn_ih_0_4 wn_ih_0_4 0 0.5414936669278361
Vwp_ih_1_4 wp_ih_1_4 0 0.4759667391131834
Vwn_ih_1_4 wn_ih_1_4 0 0.5240332608868167
Vwp_ih_2_4 wp_ih_2_4 0 0.5049605182895219
Vwn_ih_2_4 wn_ih_2_4 0 0.49503948171047807
Vwp_ih_3_4 wp_ih_3_4 0 0.42942213380283567
Vwn_ih_3_4 wn_ih_3_4 0 0.5705778661971643
Vwp_ih_4_4 wp_ih_4_4 0 0.5149735186801683
Vwn_ih_4_4 wn_ih_4_4 0 0.4850264813198317
Vwp_ih_5_4 wp_ih_5_4 0 0.4535961072579927
Vwn_ih_5_4 wn_ih_5_4 0 0.5464038927420073
Vwp_ih_6_4 wp_ih_6_4 0 0.435373889706981
Vwn_ih_6_4 wn_ih_6_4 0 0.564626110293019
Vwp_ih_7_4 wp_ih_7_4 0 0.5307496752833646
Vwn_ih_7_4 wn_ih_7_4 0 0.46925032471663536
Vwp_ih_8_4 wp_ih_8_4 0 0.48611381542759763
Vwn_ih_8_4 wn_ih_8_4 0 0.5138861845724024
Vwp_ih_9_4 wp_ih_9_4 0 0.49636525602138576
Vwn_ih_9_4 wn_ih_9_4 0 0.5036347439786142
Vwp_ih_10_4 wp_ih_10_4 0 0.5359127587663194
Vwn_ih_10_4 wn_ih_10_4 0 0.46408724123368056
Vwp_ih_11_4 wp_ih_11_4 0 0.557866749375508
Vwn_ih_11_4 wn_ih_11_4 0 0.44213325062449205
Vwp_ih_12_4 wp_ih_12_4 0 0.5891400852240772
Vwn_ih_12_4 wn_ih_12_4 0 0.4108599147759228
Vwp_ih_13_4 wp_ih_13_4 0 0.486732074584726
Vwn_ih_13_4 wn_ih_13_4 0 0.513267925415274
Vwp_ih_14_4 wp_ih_14_4 0 0.58658798305347
Vwn_ih_14_4 wn_ih_14_4 0 0.4134120169465299
Vwp_ih_15_4 wp_ih_15_4 0 0.4917670317321437
Vwn_ih_15_4 wn_ih_15_4 0 0.5082329682678564
Vwp_ih_16_4 wp_ih_16_4 0 0.4638643718730607
Vwn_ih_16_4 wn_ih_16_4 0 0.5361356281269394
Vwp_ih_17_4 wp_ih_17_4 0 0.5364549730661652
Vwn_ih_17_4 wn_ih_17_4 0 0.4635450269338348
Vwp_ih_18_4 wp_ih_18_4 0 0.3700998092766725
Vwn_ih_18_4 wn_ih_18_4 0 0.6299001907233275
Vwp_ih_19_4 wp_ih_19_4 0 0.4373511084918303
Vwn_ih_19_4 wn_ih_19_4 0 0.5626488915081698
Vwp_ih_20_4 wp_ih_20_4 0 0.39616226363455054
Vwn_ih_20_4 wn_ih_20_4 0 0.6038377363654495
Vwp_ih_21_4 wp_ih_21_4 0 0.4920796912141659
Vwn_ih_21_4 wn_ih_21_4 0 0.507920308785834
Vwp_ih_22_4 wp_ih_22_4 0 0.6051247446795635
Vwn_ih_22_4 wn_ih_22_4 0 0.39487525532043655
Vwp_ih_23_4 wp_ih_23_4 0 0.4263938223810222
Vwn_ih_23_4 wn_ih_23_4 0 0.5736061776189778
Vwp_ih_24_4 wp_ih_24_4 0 0.5660663892604743
Vwn_ih_24_4 wn_ih_24_4 0 0.4339336107395257
Vwp_ih_25_4 wp_ih_25_4 0 0.5319807482169975
Vwn_ih_25_4 wn_ih_25_4 0 0.4680192517830025
Vwp_ih_26_4 wp_ih_26_4 0 0.38486236848570204
Vwn_ih_26_4 wn_ih_26_4 0 0.615137631514298
Vwp_ih_27_4 wp_ih_27_4 0 0.5772286098509359
Vwn_ih_27_4 wn_ih_27_4 0 0.42277139014906406
Vwp_ih_28_4 wp_ih_28_4 0 0.551794075714407
Vwn_ih_28_4 wn_ih_28_4 0 0.448205924285593
Vwp_ih_29_4 wp_ih_29_4 0 0.36817686894314683
Vwn_ih_29_4 wn_ih_29_4 0 0.6318231310568532
Vwp_ih_30_4 wp_ih_30_4 0 0.5817622744492378
Vwn_ih_30_4 wn_ih_30_4 0 0.4182377255507622
Vwp_ih_31_4 wp_ih_31_4 0 0.3958456121207446
Vwn_ih_31_4 wn_ih_31_4 0 0.6041543878792555
Vwp_ih_32_4 wp_ih_32_4 0 0.4839877448075632
Vwn_ih_32_4 wn_ih_32_4 0 0.5160122551924368
Vwp_ih_33_4 wp_ih_33_4 0 0.574795266378877
Vwn_ih_33_4 wn_ih_33_4 0 0.42520473362112304
Vwp_ih_34_4 wp_ih_34_4 0 0.4433638679803761
Vwn_ih_34_4 wn_ih_34_4 0 0.5566361320196239
Vwp_ih_35_4 wp_ih_35_4 0 0.5646927836136059
Vwn_ih_35_4 wn_ih_35_4 0 0.43530721638639414
Vwp_ih_36_4 wp_ih_36_4 0 0.5473225258141279
Vwn_ih_36_4 wn_ih_36_4 0 0.4526774741858721
Vwp_ih_37_4 wp_ih_37_4 0 0.3852287312288084
Vwn_ih_37_4 wn_ih_37_4 0 0.6147712687711916
Vwp_ih_38_4 wp_ih_38_4 0 0.5149486014959707
Vwn_ih_38_4 wn_ih_38_4 0 0.4850513985040294
Vwp_ih_39_4 wp_ih_39_4 0 0.5253866359899229
Vwn_ih_39_4 wn_ih_39_4 0 0.4746133640100772
Vwp_ih_40_4 wp_ih_40_4 0 0.43576936572700586
Vwn_ih_40_4 wn_ih_40_4 0 0.5642306342729941
Vwp_ih_41_4 wp_ih_41_4 0 0.4811262678386733
Vwn_ih_41_4 wn_ih_41_4 0 0.5188737321613267
Vwp_ih_42_4 wp_ih_42_4 0 0.5569812549228885
Vwn_ih_42_4 wn_ih_42_4 0 0.4430187450771114
Vwp_ih_43_4 wp_ih_43_4 0 0.4735248507573169
Vwn_ih_43_4 wn_ih_43_4 0 0.5264751492426831
Vwp_ih_44_4 wp_ih_44_4 0 0.41712606711443584
Vwn_ih_44_4 wn_ih_44_4 0 0.5828739328855642
Vwp_ih_45_4 wp_ih_45_4 0 0.5131781635986852
Vwn_ih_45_4 wn_ih_45_4 0 0.4868218364013149
Vwp_ih_46_4 wp_ih_46_4 0 0.514669064639259
Vwn_ih_46_4 wn_ih_46_4 0 0.48533093536074107
Vwp_ih_47_4 wp_ih_47_4 0 0.37783865504665304
Vwn_ih_47_4 wn_ih_47_4 0 0.622161344953347
Vwp_ih_48_4 wp_ih_48_4 0 0.39826034884704814
Vwn_ih_48_4 wn_ih_48_4 0 0.6017396511529518
Vwp_ih_49_4 wp_ih_49_4 0 0.5120246312304686
Vwn_ih_49_4 wn_ih_49_4 0 0.4879753687695314
Vwp_ih_50_4 wp_ih_50_4 0 0.5104234126939782
Vwn_ih_50_4 wn_ih_50_4 0 0.48957658730602177
Vwp_ih_51_4 wp_ih_51_4 0 0.5372111052946361
Vwn_ih_51_4 wn_ih_51_4 0 0.46278889470536394
Vwp_ih_52_4 wp_ih_52_4 0 0.46075794927226027
Vwn_ih_52_4 wn_ih_52_4 0 0.5392420507277398
Vwp_ih_53_4 wp_ih_53_4 0 0.49880871429158447
Vwn_ih_53_4 wn_ih_53_4 0 0.5011912857084155
Vwp_ih_54_4 wp_ih_54_4 0 0.4232524732160676
Vwn_ih_54_4 wn_ih_54_4 0 0.5767475267839324
Vwp_ih_55_4 wp_ih_55_4 0 0.3949183323935498
Vwn_ih_55_4 wn_ih_55_4 0 0.6050816676064502
Vwp_ih_56_4 wp_ih_56_4 0 0.48173678272042814
Vwn_ih_56_4 wn_ih_56_4 0 0.5182632172795719
Vwp_ih_57_4 wp_ih_57_4 0 0.4326342369510886
Vwn_ih_57_4 wn_ih_57_4 0 0.5673657630489114
Vwp_ih_58_4 wp_ih_58_4 0 0.5573840131242809
Vwn_ih_58_4 wn_ih_58_4 0 0.4426159868757191
Vwp_ih_59_4 wp_ih_59_4 0 0.6659132954135656
Vwn_ih_59_4 wn_ih_59_4 0 0.33408670458643447
Vwp_ih_60_4 wp_ih_60_4 0 0.5165644701363883
Vwn_ih_60_4 wn_ih_60_4 0 0.4834355298636117
Vwp_ih_61_4 wp_ih_61_4 0 0.4248145963385827
Vwn_ih_61_4 wn_ih_61_4 0 0.5751854036614172
Vwp_ih_62_4 wp_ih_62_4 0 0.4692419929606651
Vwn_ih_62_4 wn_ih_62_4 0 0.530758007039335
Vwp_ih_63_4 wp_ih_63_4 0 0.3570134632665985
Vwn_ih_63_4 wn_ih_63_4 0 0.6429865367334016
Vwp_ho_4_0 wp_ho_4_0 0 0.4245110164395122
Vwn_ho_4_0 wn_ho_4_0 0 0.5754889835604878
Vwp_ho_4_1 wp_ho_4_1 0 0.5003536930811323
Vwn_ho_4_1 wn_ho_4_1 0 0.49964630691886763
Vwp_ho_4_2 wp_ho_4_2 0 0.36036058822330574
Vwn_ho_4_2 wn_ho_4_2 0 0.6396394117766943
Vwp_ho_4_3 wp_ho_4_3 0 0.7397465292954838
Vwn_ho_4_3 wn_ho_4_3 0 0.3
Vwp_ho_4_4 wp_ho_4_4 0 0.5181450364054703
Vwn_ho_4_4 wn_ho_4_4 0 0.48185496359452973
Vwp_ih_0_5 wp_ih_0_5 0 0.46601452568370005
Vwn_ih_0_5 wn_ih_0_5 0 0.5339854743163
Vwp_ih_1_5 wp_ih_1_5 0 0.5257482253438172
Vwn_ih_1_5 wn_ih_1_5 0 0.47425177465618285
Vwp_ih_2_5 wp_ih_2_5 0 0.5026952800480595
Vwn_ih_2_5 wn_ih_2_5 0 0.4973047199519405
Vwp_ih_3_5 wp_ih_3_5 0 0.3935363455112559
Vwn_ih_3_5 wn_ih_3_5 0 0.6064636544887442
Vwp_ih_4_5 wp_ih_4_5 0 0.5482882414296286
Vwn_ih_4_5 wn_ih_4_5 0 0.4517117585703714
Vwp_ih_5_5 wp_ih_5_5 0 0.6052014958875893
Vwn_ih_5_5 wn_ih_5_5 0 0.39479850411241074
Vwp_ih_6_5 wp_ih_6_5 0 0.6606211492595968
Vwn_ih_6_5 wn_ih_6_5 0 0.3393788507404032
Vwp_ih_7_5 wp_ih_7_5 0 0.4383830853702858
Vwn_ih_7_5 wn_ih_7_5 0 0.5616169146297142
Vwp_ih_8_5 wp_ih_8_5 0 0.4206063289862537
Vwn_ih_8_5 wn_ih_8_5 0 0.5793936710137463
Vwp_ih_9_5 wp_ih_9_5 0 0.4662386563214415
Vwn_ih_9_5 wn_ih_9_5 0 0.5337613436785585
Vwp_ih_10_5 wp_ih_10_5 0 0.3
Vwn_ih_10_5 wn_ih_10_5 0 0.7959873785058609
Vwp_ih_11_5 wp_ih_11_5 0 0.4755151791570819
Vwn_ih_11_5 wn_ih_11_5 0 0.5244848208429181
Vwp_ih_12_5 wp_ih_12_5 0 0.47162739660391484
Vwn_ih_12_5 wn_ih_12_5 0 0.5283726033960852
Vwp_ih_13_5 wp_ih_13_5 0 0.477560644374254
Vwn_ih_13_5 wn_ih_13_5 0 0.5224393556257461
Vwp_ih_14_5 wp_ih_14_5 0 0.3428862224764213
Vwn_ih_14_5 wn_ih_14_5 0 0.6571137775235787
Vwp_ih_15_5 wp_ih_15_5 0 0.4792296666021412
Vwn_ih_15_5 wn_ih_15_5 0 0.5207703333978588
Vwp_ih_16_5 wp_ih_16_5 0 0.42833228098337733
Vwn_ih_16_5 wn_ih_16_5 0 0.5716677190166226
Vwp_ih_17_5 wp_ih_17_5 0 0.5457916832529602
Vwn_ih_17_5 wn_ih_17_5 0 0.45420831674703976
Vwp_ih_18_5 wp_ih_18_5 0 0.44378671544918885
Vwn_ih_18_5 wn_ih_18_5 0 0.5562132845508111
Vwp_ih_19_5 wp_ih_19_5 0 0.4830780825766142
Vwn_ih_19_5 wn_ih_19_5 0 0.5169219174233858
Vwp_ih_20_5 wp_ih_20_5 0 0.4884621005499987
Vwn_ih_20_5 wn_ih_20_5 0 0.5115378994500013
Vwp_ih_21_5 wp_ih_21_5 0 0.562371352003473
Vwn_ih_21_5 wn_ih_21_5 0 0.43762864799652706
Vwp_ih_22_5 wp_ih_22_5 0 0.3
Vwn_ih_22_5 wn_ih_22_5 0 0.7281915074070684
Vwp_ih_23_5 wp_ih_23_5 0 0.46940273773608
Vwn_ih_23_5 wn_ih_23_5 0 0.53059726226392
Vwp_ih_24_5 wp_ih_24_5 0 0.5687537207652168
Vwn_ih_24_5 wn_ih_24_5 0 0.4312462792347832
Vwp_ih_25_5 wp_ih_25_5 0 0.5191783192787797
Vwn_ih_25_5 wn_ih_25_5 0 0.48082168072122033
Vwp_ih_26_5 wp_ih_26_5 0 0.40584267302361077
Vwn_ih_26_5 wn_ih_26_5 0 0.5941573269763892
Vwp_ih_27_5 wp_ih_27_5 0 0.5226604735274164
Vwn_ih_27_5 wn_ih_27_5 0 0.47733952647258365
Vwp_ih_28_5 wp_ih_28_5 0 0.5495188030216194
Vwn_ih_28_5 wn_ih_28_5 0 0.4504811969783807
Vwp_ih_29_5 wp_ih_29_5 0 0.4849097915841753
Vwn_ih_29_5 wn_ih_29_5 0 0.5150902084158246
Vwp_ih_30_5 wp_ih_30_5 0 0.39849645764569935
Vwn_ih_30_5 wn_ih_30_5 0 0.6015035423543007
Vwp_ih_31_5 wp_ih_31_5 0 0.4335563032929359
Vwn_ih_31_5 wn_ih_31_5 0 0.5664436967070642
Vwp_ih_32_5 wp_ih_32_5 0 0.47176191419572155
Vwn_ih_32_5 wn_ih_32_5 0 0.5282380858042784
Vwp_ih_33_5 wp_ih_33_5 0 0.4588330358045806
Vwn_ih_33_5 wn_ih_33_5 0 0.5411669641954193
Vwp_ih_34_5 wp_ih_34_5 0 0.34662442383144565
Vwn_ih_34_5 wn_ih_34_5 0 0.6533755761685544
Vwp_ih_35_5 wp_ih_35_5 0 0.43105226791253887
Vwn_ih_35_5 wn_ih_35_5 0 0.5689477320874611
Vwp_ih_36_5 wp_ih_36_5 0 0.528477826290185
Vwn_ih_36_5 wn_ih_36_5 0 0.4715221737098149
Vwp_ih_37_5 wp_ih_37_5 0 0.4521096810786403
Vwn_ih_37_5 wn_ih_37_5 0 0.5478903189213596
Vwp_ih_38_5 wp_ih_38_5 0 0.5077509621301579
Vwn_ih_38_5 wn_ih_38_5 0 0.4922490378698421
Vwp_ih_39_5 wp_ih_39_5 0 0.5075292181066632
Vwn_ih_39_5 wn_ih_39_5 0 0.4924707818933369
Vwp_ih_40_5 wp_ih_40_5 0 0.5675403644243517
Vwn_ih_40_5 wn_ih_40_5 0 0.4324596355756482
Vwp_ih_41_5 wp_ih_41_5 0 0.7000251929972212
Vwn_ih_41_5 wn_ih_41_5 0 0.3
Vwp_ih_42_5 wp_ih_42_5 0 0.5908345754767075
Vwn_ih_42_5 wn_ih_42_5 0 0.40916542452329246
Vwp_ih_43_5 wp_ih_43_5 0 0.38618513379398245
Vwn_ih_43_5 wn_ih_43_5 0 0.6138148662060176
Vwp_ih_44_5 wp_ih_44_5 0 0.30127403328777125
Vwn_ih_44_5 wn_ih_44_5 0 0.6987259667122288
Vwp_ih_45_5 wp_ih_45_5 0 0.48336598680334797
Vwn_ih_45_5 wn_ih_45_5 0 0.516634013196652
Vwp_ih_46_5 wp_ih_46_5 0 0.48240228018278486
Vwn_ih_46_5 wn_ih_46_5 0 0.5175977198172151
Vwp_ih_47_5 wp_ih_47_5 0 0.39646389683078576
Vwn_ih_47_5 wn_ih_47_5 0 0.6035361031692142
Vwp_ih_48_5 wp_ih_48_5 0 0.524299676890624
Vwn_ih_48_5 wn_ih_48_5 0 0.47570032310937604
Vwp_ih_49_5 wp_ih_49_5 0 0.4140376138067416
Vwn_ih_49_5 wn_ih_49_5 0 0.5859623861932584
Vwp_ih_50_5 wp_ih_50_5 0 0.5161277186570006
Vwn_ih_50_5 wn_ih_50_5 0 0.48387228134299937
Vwp_ih_51_5 wp_ih_51_5 0 0.4448306244503934
Vwn_ih_51_5 wn_ih_51_5 0 0.5551693755496067
Vwp_ih_52_5 wp_ih_52_5 0 0.5515718821712292
Vwn_ih_52_5 wn_ih_52_5 0 0.44842811782877084
Vwp_ih_53_5 wp_ih_53_5 0 0.31972783611043976
Vwn_ih_53_5 wn_ih_53_5 0 0.6802721638895602
Vwp_ih_54_5 wp_ih_54_5 0 0.4317878869039948
Vwn_ih_54_5 wn_ih_54_5 0 0.5682121130960052
Vwp_ih_55_5 wp_ih_55_5 0 0.50410438486831
Vwn_ih_55_5 wn_ih_55_5 0 0.49589561513169006
Vwp_ih_56_5 wp_ih_56_5 0 0.37203580497473393
Vwn_ih_56_5 wn_ih_56_5 0 0.6279641950252661
Vwp_ih_57_5 wp_ih_57_5 0 0.6346552391579348
Vwn_ih_57_5 wn_ih_57_5 0 0.36534476084206524
Vwp_ih_58_5 wp_ih_58_5 0 0.3985403916138157
Vwn_ih_58_5 wn_ih_58_5 0 0.6014596083861843
Vwp_ih_59_5 wp_ih_59_5 0 0.6130614807720586
Vwn_ih_59_5 wn_ih_59_5 0 0.3869385192279414
Vwp_ih_60_5 wp_ih_60_5 0 0.4507318332771224
Vwn_ih_60_5 wn_ih_60_5 0 0.5492681667228776
Vwp_ih_61_5 wp_ih_61_5 0 0.4738074204864818
Vwn_ih_61_5 wn_ih_61_5 0 0.5261925795135182
Vwp_ih_62_5 wp_ih_62_5 0 0.5665896628381671
Vwn_ih_62_5 wn_ih_62_5 0 0.4334103371618328
Vwp_ih_63_5 wp_ih_63_5 0 0.5115764077362793
Vwn_ih_63_5 wn_ih_63_5 0 0.4884235922637207
Vwp_ho_5_0 wp_ho_5_0 0 0.5403561842326279
Vwn_ho_5_0 wn_ho_5_0 0 0.45964381576737207
Vwp_ho_5_1 wp_ho_5_1 0 0.558060419609773
Vwn_ho_5_1 wn_ho_5_1 0 0.441939580390227
Vwp_ho_5_2 wp_ho_5_2 0 0.46360679265641414
Vwn_ho_5_2 wn_ho_5_2 0 0.5363932073435859
Vwp_ho_5_3 wp_ho_5_3 0 0.4070677296562284
Vwn_ho_5_3 wn_ho_5_3 0 0.5929322703437716
Vwp_ho_5_4 wp_ho_5_4 0 0.392658874464528
Vwn_ho_5_4 wn_ho_5_4 0 0.6073411255354719
Vwp_ih_0_6 wp_ih_0_6 0 0.5172848915260875
Vwn_ih_0_6 wn_ih_0_6 0 0.4827151084739125
Vwp_ih_1_6 wp_ih_1_6 0 0.5476799642602023
Vwn_ih_1_6 wn_ih_1_6 0 0.4523200357397978
Vwp_ih_2_6 wp_ih_2_6 0 0.3913355290169045
Vwn_ih_2_6 wn_ih_2_6 0 0.6086644709830955
Vwp_ih_3_6 wp_ih_3_6 0 0.4694282978358198
Vwn_ih_3_6 wn_ih_3_6 0 0.5305717021641801
Vwp_ih_4_6 wp_ih_4_6 0 0.40383082421883715
Vwn_ih_4_6 wn_ih_4_6 0 0.5961691757811629
Vwp_ih_5_6 wp_ih_5_6 0 0.5096813856417974
Vwn_ih_5_6 wn_ih_5_6 0 0.49031861435820256
Vwp_ih_6_6 wp_ih_6_6 0 0.4179690825551477
Vwn_ih_6_6 wn_ih_6_6 0 0.5820309174448522
Vwp_ih_7_6 wp_ih_7_6 0 0.4607649986271353
Vwn_ih_7_6 wn_ih_7_6 0 0.5392350013728647
Vwp_ih_8_6 wp_ih_8_6 0 0.4762484285049583
Vwn_ih_8_6 wn_ih_8_6 0 0.5237515714950417
Vwp_ih_9_6 wp_ih_9_6 0 0.5269213132943888
Vwn_ih_9_6 wn_ih_9_6 0 0.4730786867056112
Vwp_ih_10_6 wp_ih_10_6 0 0.4726999504122269
Vwn_ih_10_6 wn_ih_10_6 0 0.5273000495877731
Vwp_ih_11_6 wp_ih_11_6 0 0.339560860695869
Vwn_ih_11_6 wn_ih_11_6 0 0.660439139304131
Vwp_ih_12_6 wp_ih_12_6 0 0.3562696917933119
Vwn_ih_12_6 wn_ih_12_6 0 0.6437303082066881
Vwp_ih_13_6 wp_ih_13_6 0 0.476547248070187
Vwn_ih_13_6 wn_ih_13_6 0 0.523452751929813
Vwp_ih_14_6 wp_ih_14_6 0 0.612549245830185
Vwn_ih_14_6 wn_ih_14_6 0 0.387450754169815
Vwp_ih_15_6 wp_ih_15_6 0 0.4999705207351977
Vwn_ih_15_6 wn_ih_15_6 0 0.5000294792648023
Vwp_ih_16_6 wp_ih_16_6 0 0.5401085095690875
Vwn_ih_16_6 wn_ih_16_6 0 0.4598914904309125
Vwp_ih_17_6 wp_ih_17_6 0 0.6625789175406223
Vwn_ih_17_6 wn_ih_17_6 0 0.3374210824593777
Vwp_ih_18_6 wp_ih_18_6 0 0.38820397674414014
Vwn_ih_18_6 wn_ih_18_6 0 0.6117960232558598
Vwp_ih_19_6 wp_ih_19_6 0 0.5210173730949735
Vwn_ih_19_6 wn_ih_19_6 0 0.4789826269050264
Vwp_ih_20_6 wp_ih_20_6 0 0.5001626892837727
Vwn_ih_20_6 wn_ih_20_6 0 0.4998373107162273
Vwp_ih_21_6 wp_ih_21_6 0 0.5127996795464607
Vwn_ih_21_6 wn_ih_21_6 0 0.48720032045353934
Vwp_ih_22_6 wp_ih_22_6 0 0.5109408148661667
Vwn_ih_22_6 wn_ih_22_6 0 0.4890591851338333
Vwp_ih_23_6 wp_ih_23_6 0 0.6244520110725365
Vwn_ih_23_6 wn_ih_23_6 0 0.37554798892746355
Vwp_ih_24_6 wp_ih_24_6 0 0.42018881714871353
Vwn_ih_24_6 wn_ih_24_6 0 0.5798111828512864
Vwp_ih_25_6 wp_ih_25_6 0 0.5223829817154886
Vwn_ih_25_6 wn_ih_25_6 0 0.4776170182845114
Vwp_ih_26_6 wp_ih_26_6 0 0.5520847040078835
Vwn_ih_26_6 wn_ih_26_6 0 0.44791529599211655
Vwp_ih_27_6 wp_ih_27_6 0 0.38461273232734666
Vwn_ih_27_6 wn_ih_27_6 0 0.6153872676726534
Vwp_ih_28_6 wp_ih_28_6 0 0.6198880549536019
Vwn_ih_28_6 wn_ih_28_6 0 0.3801119450463981
Vwp_ih_29_6 wp_ih_29_6 0 0.47565717359570175
Vwn_ih_29_6 wn_ih_29_6 0 0.5243428264042983
Vwp_ih_30_6 wp_ih_30_6 0 0.3812389838579561
Vwn_ih_30_6 wn_ih_30_6 0 0.6187610161420438
Vwp_ih_31_6 wp_ih_31_6 0 0.5023496587830244
Vwn_ih_31_6 wn_ih_31_6 0 0.4976503412169756
Vwp_ih_32_6 wp_ih_32_6 0 0.5535433275662142
Vwn_ih_32_6 wn_ih_32_6 0 0.44645667243378584
Vwp_ih_33_6 wp_ih_33_6 0 0.415605975118828
Vwn_ih_33_6 wn_ih_33_6 0 0.584394024881172
Vwp_ih_34_6 wp_ih_34_6 0 0.5019215477090097
Vwn_ih_34_6 wn_ih_34_6 0 0.4980784522909903
Vwp_ih_35_6 wp_ih_35_6 0 0.5003155562634083
Vwn_ih_35_6 wn_ih_35_6 0 0.4996844437365917
Vwp_ih_36_6 wp_ih_36_6 0 0.40423987290074204
Vwn_ih_36_6 wn_ih_36_6 0 0.595760127099258
Vwp_ih_37_6 wp_ih_37_6 0 0.6406104541159576
Vwn_ih_37_6 wn_ih_37_6 0 0.35938954588404237
Vwp_ih_38_6 wp_ih_38_6 0 0.5681651068960991
Vwn_ih_38_6 wn_ih_38_6 0 0.43183489310390083
Vwp_ih_39_6 wp_ih_39_6 0 0.4226065926899794
Vwn_ih_39_6 wn_ih_39_6 0 0.5773934073100206
Vwp_ih_40_6 wp_ih_40_6 0 0.415846022169746
Vwn_ih_40_6 wn_ih_40_6 0 0.584153977830254
Vwp_ih_41_6 wp_ih_41_6 0 0.5117908104110148
Vwn_ih_41_6 wn_ih_41_6 0 0.4882091895889851
Vwp_ih_42_6 wp_ih_42_6 0 0.42783639361055253
Vwn_ih_42_6 wn_ih_42_6 0 0.5721636063894475
Vwp_ih_43_6 wp_ih_43_6 0 0.3
Vwn_ih_43_6 wn_ih_43_6 0 0.7070065226546669
Vwp_ih_44_6 wp_ih_44_6 0 0.6237348367486371
Vwn_ih_44_6 wn_ih_44_6 0 0.376265163251363
Vwp_ih_45_6 wp_ih_45_6 0 0.48276967321685393
Vwn_ih_45_6 wn_ih_45_6 0 0.5172303267831461
Vwp_ih_46_6 wp_ih_46_6 0 0.6685961518675678
Vwn_ih_46_6 wn_ih_46_6 0 0.33140384813243223
Vwp_ih_47_6 wp_ih_47_6 0 0.5071375815759723
Vwn_ih_47_6 wn_ih_47_6 0 0.49286241842402767
Vwp_ih_48_6 wp_ih_48_6 0 0.5067939183375123
Vwn_ih_48_6 wn_ih_48_6 0 0.49320608166248764
Vwp_ih_49_6 wp_ih_49_6 0 0.6818323191624626
Vwn_ih_49_6 wn_ih_49_6 0 0.31816768083753744
Vwp_ih_50_6 wp_ih_50_6 0 0.46219139812756704
Vwn_ih_50_6 wn_ih_50_6 0 0.537808601872433
Vwp_ih_51_6 wp_ih_51_6 0 0.3914622538760384
Vwn_ih_51_6 wn_ih_51_6 0 0.6085377461239616
Vwp_ih_52_6 wp_ih_52_6 0 0.5331818821816897
Vwn_ih_52_6 wn_ih_52_6 0 0.46681811781831023
Vwp_ih_53_6 wp_ih_53_6 0 0.6041170489422665
Vwn_ih_53_6 wn_ih_53_6 0 0.3958829510577335
Vwp_ih_54_6 wp_ih_54_6 0 0.4518605877435257
Vwn_ih_54_6 wn_ih_54_6 0 0.5481394122564742
Vwp_ih_55_6 wp_ih_55_6 0 0.4291138730341542
Vwn_ih_55_6 wn_ih_55_6 0 0.5708861269658457
Vwp_ih_56_6 wp_ih_56_6 0 0.5338235189121477
Vwn_ih_56_6 wn_ih_56_6 0 0.4661764810878522
Vwp_ih_57_6 wp_ih_57_6 0 0.3
Vwn_ih_57_6 wn_ih_57_6 0 0.740374674386931
Vwp_ih_58_6 wp_ih_58_6 0 0.4260173787973828
Vwn_ih_58_6 wn_ih_58_6 0 0.5739826212026172
Vwp_ih_59_6 wp_ih_59_6 0 0.59014926521217
Vwn_ih_59_6 wn_ih_59_6 0 0.40985073478782996
Vwp_ih_60_6 wp_ih_60_6 0 0.4676223149023994
Vwn_ih_60_6 wn_ih_60_6 0 0.5323776850976005
Vwp_ih_61_6 wp_ih_61_6 0 0.42548718254218426
Vwn_ih_61_6 wn_ih_61_6 0 0.5745128174578158
Vwp_ih_62_6 wp_ih_62_6 0 0.7390529196350459
Vwn_ih_62_6 wn_ih_62_6 0 0.3
Vwp_ih_63_6 wp_ih_63_6 0 0.4026821976568063
Vwn_ih_63_6 wn_ih_63_6 0 0.5973178023431938
Vwp_ho_6_0 wp_ho_6_0 0 0.42035906510849547
Vwn_ho_6_0 wn_ho_6_0 0 0.5796409348915045
Vwp_ho_6_1 wp_ho_6_1 0 0.35082688457056815
Vwn_ho_6_1 wn_ho_6_1 0 0.6491731154294318
Vwp_ho_6_2 wp_ho_6_2 0 0.3
Vwn_ho_6_2 wn_ho_6_2 0 0.743307172443577
Vwp_ho_6_3 wp_ho_6_3 0 0.3351815945433708
Vwn_ho_6_3 wn_ho_6_3 0 0.6648184054566292
Vwp_ho_6_4 wp_ho_6_4 0 0.3286958015914768
Vwn_ho_6_4 wn_ho_6_4 0 0.6713041984085232
Vwp_ih_0_7 wp_ih_0_7 0 0.45289710077360845
Vwn_ih_0_7 wn_ih_0_7 0 0.5471028992263915
Vwp_ih_1_7 wp_ih_1_7 0 0.4283224866073496
Vwn_ih_1_7 wn_ih_1_7 0 0.5716775133926504
Vwp_ih_2_7 wp_ih_2_7 0 0.4986356070835715
Vwn_ih_2_7 wn_ih_2_7 0 0.5013643929164285
Vwp_ih_3_7 wp_ih_3_7 0 0.4570635944218981
Vwn_ih_3_7 wn_ih_3_7 0 0.5429364055781019
Vwp_ih_4_7 wp_ih_4_7 0 0.4970967734578669
Vwn_ih_4_7 wn_ih_4_7 0 0.502903226542133
Vwp_ih_5_7 wp_ih_5_7 0 0.5136503047189721
Vwn_ih_5_7 wn_ih_5_7 0 0.4863496952810279
Vwp_ih_6_7 wp_ih_6_7 0 0.5310935710573218
Vwn_ih_6_7 wn_ih_6_7 0 0.4689064289426782
Vwp_ih_7_7 wp_ih_7_7 0 0.5255441493241829
Vwn_ih_7_7 wn_ih_7_7 0 0.474455850675817
Vwp_ih_8_7 wp_ih_8_7 0 0.3
Vwn_ih_8_7 wn_ih_8_7 0 0.7099724398163646
Vwp_ih_9_7 wp_ih_9_7 0 0.5211385546603159
Vwn_ih_9_7 wn_ih_9_7 0 0.47886144533968417
Vwp_ih_10_7 wp_ih_10_7 0 0.43635244417203617
Vwn_ih_10_7 wn_ih_10_7 0 0.5636475558279639
Vwp_ih_11_7 wp_ih_11_7 0 0.3
Vwn_ih_11_7 wn_ih_11_7 0 0.7095207731195596
Vwp_ih_12_7 wp_ih_12_7 0 0.5715506281925643
Vwn_ih_12_7 wn_ih_12_7 0 0.42844937180743575
Vwp_ih_13_7 wp_ih_13_7 0 0.37171201554993466
Vwn_ih_13_7 wn_ih_13_7 0 0.6282879844500653
Vwp_ih_14_7 wp_ih_14_7 0 0.5032073567374515
Vwn_ih_14_7 wn_ih_14_7 0 0.4967926432625485
Vwp_ih_15_7 wp_ih_15_7 0 0.44522916718173194
Vwn_ih_15_7 wn_ih_15_7 0 0.5547708328182681
Vwp_ih_16_7 wp_ih_16_7 0 0.44110520806664133
Vwn_ih_16_7 wn_ih_16_7 0 0.5588947919333587
Vwp_ih_17_7 wp_ih_17_7 0 0.5041711538191052
Vwn_ih_17_7 wn_ih_17_7 0 0.49582884618089484
Vwp_ih_18_7 wp_ih_18_7 0 0.4573999522312352
Vwn_ih_18_7 wn_ih_18_7 0 0.5426000477687648
Vwp_ih_19_7 wp_ih_19_7 0 0.48941569608649904
Vwn_ih_19_7 wn_ih_19_7 0 0.510584303913501
Vwp_ih_20_7 wp_ih_20_7 0 0.4357771400838013
Vwn_ih_20_7 wn_ih_20_7 0 0.5642228599161987
Vwp_ih_21_7 wp_ih_21_7 0 0.5877207751846757
Vwn_ih_21_7 wn_ih_21_7 0 0.4122792248153243
Vwp_ih_22_7 wp_ih_22_7 0 0.5031818543971984
Vwn_ih_22_7 wn_ih_22_7 0 0.49681814560280163
Vwp_ih_23_7 wp_ih_23_7 0 0.6023563326935052
Vwn_ih_23_7 wn_ih_23_7 0 0.3976436673064948
Vwp_ih_24_7 wp_ih_24_7 0 0.659441116933854
Vwn_ih_24_7 wn_ih_24_7 0 0.340558883066146
Vwp_ih_25_7 wp_ih_25_7 0 0.65209686961951
Vwn_ih_25_7 wn_ih_25_7 0 0.3479031303804901
Vwp_ih_26_7 wp_ih_26_7 0 0.6136380404439056
Vwn_ih_26_7 wn_ih_26_7 0 0.3863619595560944
Vwp_ih_27_7 wp_ih_27_7 0 0.5251832664873409
Vwn_ih_27_7 wn_ih_27_7 0 0.47481673351265913
Vwp_ih_28_7 wp_ih_28_7 0 0.6682190331028721
Vwn_ih_28_7 wn_ih_28_7 0 0.3317809668971279
Vwp_ih_29_7 wp_ih_29_7 0 0.736382152422083
Vwn_ih_29_7 wn_ih_29_7 0 0.3
Vwp_ih_30_7 wp_ih_30_7 0 0.4883653758836274
Vwn_ih_30_7 wn_ih_30_7 0 0.5116346241163726
Vwp_ih_31_7 wp_ih_31_7 0 0.586946318854493
Vwn_ih_31_7 wn_ih_31_7 0 0.41305368114550706
Vwp_ih_32_7 wp_ih_32_7 0 0.5541763308857212
Vwn_ih_32_7 wn_ih_32_7 0 0.4458236691142789
Vwp_ih_33_7 wp_ih_33_7 0 0.5320183916309845
Vwn_ih_33_7 wn_ih_33_7 0 0.4679816083690155
Vwp_ih_34_7 wp_ih_34_7 0 0.5531141351203775
Vwn_ih_34_7 wn_ih_34_7 0 0.44688586487962245
Vwp_ih_35_7 wp_ih_35_7 0 0.5480399641927229
Vwn_ih_35_7 wn_ih_35_7 0 0.45196003580727706
Vwp_ih_36_7 wp_ih_36_7 0 0.5438667739832687
Vwn_ih_36_7 wn_ih_36_7 0 0.45613322601673134
Vwp_ih_37_7 wp_ih_37_7 0 0.5575323700400365
Vwn_ih_37_7 wn_ih_37_7 0 0.44246762995996347
Vwp_ih_38_7 wp_ih_38_7 0 0.5366661957040104
Vwn_ih_38_7 wn_ih_38_7 0 0.4633338042959896
Vwp_ih_39_7 wp_ih_39_7 0 0.6252926282728377
Vwn_ih_39_7 wn_ih_39_7 0 0.37470737172716234
Vwp_ih_40_7 wp_ih_40_7 0 0.5559512808602781
Vwn_ih_40_7 wn_ih_40_7 0 0.4440487191397219
Vwp_ih_41_7 wp_ih_41_7 0 0.5829686464904267
Vwn_ih_41_7 wn_ih_41_7 0 0.4170313535095733
Vwp_ih_42_7 wp_ih_42_7 0 0.6285622301185525
Vwn_ih_42_7 wn_ih_42_7 0 0.3714377698814475
Vwp_ih_43_7 wp_ih_43_7 0 0.6573592899025793
Vwn_ih_43_7 wn_ih_43_7 0 0.3426407100974207
Vwp_ih_44_7 wp_ih_44_7 0 0.5469355463569635
Vwn_ih_44_7 wn_ih_44_7 0 0.4530644536430365
Vwp_ih_45_7 wp_ih_45_7 0 0.5458679471037223
Vwn_ih_45_7 wn_ih_45_7 0 0.4541320528962777
Vwp_ih_46_7 wp_ih_46_7 0 0.4946237072738919
Vwn_ih_46_7 wn_ih_46_7 0 0.5053762927261081
Vwp_ih_47_7 wp_ih_47_7 0 0.4020484153046928
Vwn_ih_47_7 wn_ih_47_7 0 0.5979515846953072
Vwp_ih_48_7 wp_ih_48_7 0 0.5285326943629693
Vwn_ih_48_7 wn_ih_48_7 0 0.4714673056370307
Vwp_ih_49_7 wp_ih_49_7 0 0.4573989612843076
Vwn_ih_49_7 wn_ih_49_7 0 0.5426010387156923
Vwp_ih_50_7 wp_ih_50_7 0 0.4252000342920332
Vwn_ih_50_7 wn_ih_50_7 0 0.5747999657079668
Vwp_ih_51_7 wp_ih_51_7 0 0.5272144746541637
Vwn_ih_51_7 wn_ih_51_7 0 0.4727855253458363
Vwp_ih_52_7 wp_ih_52_7 0 0.4337985476950391
Vwn_ih_52_7 wn_ih_52_7 0 0.5662014523049609
Vwp_ih_53_7 wp_ih_53_7 0 0.5588983381747064
Vwn_ih_53_7 wn_ih_53_7 0 0.44110166182529364
Vwp_ih_54_7 wp_ih_54_7 0 0.39369091189262295
Vwn_ih_54_7 wn_ih_54_7 0 0.606309088107377
Vwp_ih_55_7 wp_ih_55_7 0 0.5715119290371221
Vwn_ih_55_7 wn_ih_55_7 0 0.42848807096287783
Vwp_ih_56_7 wp_ih_56_7 0 0.5161761089769338
Vwn_ih_56_7 wn_ih_56_7 0 0.4838238910230662
Vwp_ih_57_7 wp_ih_57_7 0 0.5668906326241406
Vwn_ih_57_7 wn_ih_57_7 0 0.43310936737585937
Vwp_ih_58_7 wp_ih_58_7 0 0.5546109513908171
Vwn_ih_58_7 wn_ih_58_7 0 0.44538904860918294
Vwp_ih_59_7 wp_ih_59_7 0 0.5152059253473215
Vwn_ih_59_7 wn_ih_59_7 0 0.48479407465267854
Vwp_ih_60_7 wp_ih_60_7 0 0.4552810392640398
Vwn_ih_60_7 wn_ih_60_7 0 0.5447189607359603
Vwp_ih_61_7 wp_ih_61_7 0 0.4884375293445958
Vwn_ih_61_7 wn_ih_61_7 0 0.5115624706554043
Vwp_ih_62_7 wp_ih_62_7 0 0.5746881808312773
Vwn_ih_62_7 wn_ih_62_7 0 0.4253118191687228
Vwp_ih_63_7 wp_ih_63_7 0 0.553876300698799
Vwn_ih_63_7 wn_ih_63_7 0 0.44612369930120105
Vwp_ho_7_0 wp_ho_7_0 0 0.3799931302959939
Vwn_ho_7_0 wn_ho_7_0 0 0.6200068697040061
Vwp_ho_7_1 wp_ho_7_1 0 0.3636829620974951
Vwn_ho_7_1 wn_ho_7_1 0 0.6363170379025049
Vwp_ho_7_2 wp_ho_7_2 0 0.7543535401145609
Vwn_ho_7_2 wn_ho_7_2 0 0.3
Vwp_ho_7_3 wp_ho_7_3 0 0.4007452789807068
Vwn_ho_7_3 wn_ho_7_3 0 0.5992547210192932
Vwp_ho_7_4 wp_ho_7_4 0 0.5864308475874933
Vwn_ho_7_4 wn_ho_7_4 0 0.4135691524125067
Vwp_ih_0_8 wp_ih_0_8 0 0.3923973812746632
Vwn_ih_0_8 wn_ih_0_8 0 0.6076026187253368
Vwp_ih_1_8 wp_ih_1_8 0 0.5895657871253167
Vwn_ih_1_8 wn_ih_1_8 0 0.41043421287468335
Vwp_ih_2_8 wp_ih_2_8 0 0.5022840703285228
Vwn_ih_2_8 wn_ih_2_8 0 0.49771592967147715
Vwp_ih_3_8 wp_ih_3_8 0 0.6051346116326276
Vwn_ih_3_8 wn_ih_3_8 0 0.39486538836737245
Vwp_ih_4_8 wp_ih_4_8 0 0.3945333872630172
Vwn_ih_4_8 wn_ih_4_8 0 0.6054666127369829
Vwp_ih_5_8 wp_ih_5_8 0 0.5244061001149825
Vwn_ih_5_8 wn_ih_5_8 0 0.4755938998850176
Vwp_ih_6_8 wp_ih_6_8 0 0.4211363158192632
Vwn_ih_6_8 wn_ih_6_8 0 0.5788636841807367
Vwp_ih_7_8 wp_ih_7_8 0 0.5190252447494164
Vwn_ih_7_8 wn_ih_7_8 0 0.48097475525058364
Vwp_ih_8_8 wp_ih_8_8 0 0.48578033011195393
Vwn_ih_8_8 wn_ih_8_8 0 0.514219669888046
Vwp_ih_9_8 wp_ih_9_8 0 0.5036860180259942
Vwn_ih_9_8 wn_ih_9_8 0 0.4963139819740057
Vwp_ih_10_8 wp_ih_10_8 0 0.47629313816458846
Vwn_ih_10_8 wn_ih_10_8 0 0.5237068618354115
Vwp_ih_11_8 wp_ih_11_8 0 0.4942736395356803
Vwn_ih_11_8 wn_ih_11_8 0 0.5057263604643196
Vwp_ih_12_8 wp_ih_12_8 0 0.3259187273643638
Vwn_ih_12_8 wn_ih_12_8 0 0.6740812726356362
Vwp_ih_13_8 wp_ih_13_8 0 0.5794390692898505
Vwn_ih_13_8 wn_ih_13_8 0 0.42056093071014955
Vwp_ih_14_8 wp_ih_14_8 0 0.5769451406504754
Vwn_ih_14_8 wn_ih_14_8 0 0.4230548593495245
Vwp_ih_15_8 wp_ih_15_8 0 0.4576352314157581
Vwn_ih_15_8 wn_ih_15_8 0 0.5423647685842419
Vwp_ih_16_8 wp_ih_16_8 0 0.38752855007594633
Vwn_ih_16_8 wn_ih_16_8 0 0.6124714499240537
Vwp_ih_17_8 wp_ih_17_8 0 0.5034938747776316
Vwn_ih_17_8 wn_ih_17_8 0 0.49650612522236837
Vwp_ih_18_8 wp_ih_18_8 0 0.6072173881977276
Vwn_ih_18_8 wn_ih_18_8 0 0.39278261180227236
Vwp_ih_19_8 wp_ih_19_8 0 0.5465084549157424
Vwn_ih_19_8 wn_ih_19_8 0 0.4534915450842576
Vwp_ih_20_8 wp_ih_20_8 0 0.4463201270031945
Vwn_ih_20_8 wn_ih_20_8 0 0.5536798729968054
Vwp_ih_21_8 wp_ih_21_8 0 0.5831467061312642
Vwn_ih_21_8 wn_ih_21_8 0 0.4168532938687358
Vwp_ih_22_8 wp_ih_22_8 0 0.4255431431178124
Vwn_ih_22_8 wn_ih_22_8 0 0.5744568568821876
Vwp_ih_23_8 wp_ih_23_8 0 0.44699484457947475
Vwn_ih_23_8 wn_ih_23_8 0 0.5530051554205253
Vwp_ih_24_8 wp_ih_24_8 0 0.5446858083329146
Vwn_ih_24_8 wn_ih_24_8 0 0.4553141916670854
Vwp_ih_25_8 wp_ih_25_8 0 0.5072491162128953
Vwn_ih_25_8 wn_ih_25_8 0 0.4927508837871047
Vwp_ih_26_8 wp_ih_26_8 0 0.47379222052771874
Vwn_ih_26_8 wn_ih_26_8 0 0.5262077794722813
Vwp_ih_27_8 wp_ih_27_8 0 0.3
Vwn_ih_27_8 wn_ih_27_8 0 0.7180847208430535
Vwp_ih_28_8 wp_ih_28_8 0 0.5568575659931913
Vwn_ih_28_8 wn_ih_28_8 0 0.44314243400680875
Vwp_ih_29_8 wp_ih_29_8 0 0.5119026300049714
Vwn_ih_29_8 wn_ih_29_8 0 0.4880973699950286
Vwp_ih_30_8 wp_ih_30_8 0 0.3874622195483165
Vwn_ih_30_8 wn_ih_30_8 0 0.6125377804516835
Vwp_ih_31_8 wp_ih_31_8 0 0.5472845836758732
Vwn_ih_31_8 wn_ih_31_8 0 0.4527154163241268
Vwp_ih_32_8 wp_ih_32_8 0 0.4987072617117272
Vwn_ih_32_8 wn_ih_32_8 0 0.5012927382882728
Vwp_ih_33_8 wp_ih_33_8 0 0.5611538005790382
Vwn_ih_33_8 wn_ih_33_8 0 0.4388461994209618
Vwp_ih_34_8 wp_ih_34_8 0 0.6051956075188176
Vwn_ih_34_8 wn_ih_34_8 0 0.39480439248118243
Vwp_ih_35_8 wp_ih_35_8 0 0.3988740429413662
Vwn_ih_35_8 wn_ih_35_8 0 0.6011259570586338
Vwp_ih_36_8 wp_ih_36_8 0 0.5433105337975329
Vwn_ih_36_8 wn_ih_36_8 0 0.4566894662024671
Vwp_ih_37_8 wp_ih_37_8 0 0.5798461620823477
Vwn_ih_37_8 wn_ih_37_8 0 0.42015383791765226
Vwp_ih_38_8 wp_ih_38_8 0 0.5681289119784876
Vwn_ih_38_8 wn_ih_38_8 0 0.43187108802151236
Vwp_ih_39_8 wp_ih_39_8 0 0.6472360200475555
Vwn_ih_39_8 wn_ih_39_8 0 0.35276397995244446
Vwp_ih_40_8 wp_ih_40_8 0 0.5693169760467955
Vwn_ih_40_8 wn_ih_40_8 0 0.43068302395320446
Vwp_ih_41_8 wp_ih_41_8 0 0.4570707437956594
Vwn_ih_41_8 wn_ih_41_8 0 0.5429292562043406
Vwp_ih_42_8 wp_ih_42_8 0 0.6105340454687491
Vwn_ih_42_8 wn_ih_42_8 0 0.3894659545312509
Vwp_ih_43_8 wp_ih_43_8 0 0.36594095714210295
Vwn_ih_43_8 wn_ih_43_8 0 0.634059042857897
Vwp_ih_44_8 wp_ih_44_8 0 0.4582690714085691
Vwn_ih_44_8 wn_ih_44_8 0 0.5417309285914309
Vwp_ih_45_8 wp_ih_45_8 0 0.4513671680160424
Vwn_ih_45_8 wn_ih_45_8 0 0.5486328319839576
Vwp_ih_46_8 wp_ih_46_8 0 0.5044454464855893
Vwn_ih_46_8 wn_ih_46_8 0 0.4955545535144107
Vwp_ih_47_8 wp_ih_47_8 0 0.6026402895353639
Vwn_ih_47_8 wn_ih_47_8 0 0.39735971046463614
Vwp_ih_48_8 wp_ih_48_8 0 0.6201880957744593
Vwn_ih_48_8 wn_ih_48_8 0 0.3798119042255407
Vwp_ih_49_8 wp_ih_49_8 0 0.5022715424201925
Vwn_ih_49_8 wn_ih_49_8 0 0.4977284575798076
Vwp_ih_50_8 wp_ih_50_8 0 0.4492630113839877
Vwn_ih_50_8 wn_ih_50_8 0 0.5507369886160123
Vwp_ih_51_8 wp_ih_51_8 0 0.45688837452546344
Vwn_ih_51_8 wn_ih_51_8 0 0.5431116254745366
Vwp_ih_52_8 wp_ih_52_8 0 0.41446674788860294
Vwn_ih_52_8 wn_ih_52_8 0 0.5855332521113971
Vwp_ih_53_8 wp_ih_53_8 0 0.5953231852933653
Vwn_ih_53_8 wn_ih_53_8 0 0.40467681470663475
Vwp_ih_54_8 wp_ih_54_8 0 0.4725869281409443
Vwn_ih_54_8 wn_ih_54_8 0 0.5274130718590557
Vwp_ih_55_8 wp_ih_55_8 0 0.5963201098960067
Vwn_ih_55_8 wn_ih_55_8 0 0.4036798901039933
Vwp_ih_56_8 wp_ih_56_8 0 0.4984599460398152
Vwn_ih_56_8 wn_ih_56_8 0 0.5015400539601849
Vwp_ih_57_8 wp_ih_57_8 0 0.5066377543052035
Vwn_ih_57_8 wn_ih_57_8 0 0.49336224569479653
Vwp_ih_58_8 wp_ih_58_8 0 0.6568663631420107
Vwn_ih_58_8 wn_ih_58_8 0 0.34313363685798925
Vwp_ih_59_8 wp_ih_59_8 0 0.4931877098906258
Vwn_ih_59_8 wn_ih_59_8 0 0.5068122901093741
Vwp_ih_60_8 wp_ih_60_8 0 0.6538520963628558
Vwn_ih_60_8 wn_ih_60_8 0 0.34614790363714415
Vwp_ih_61_8 wp_ih_61_8 0 0.37447979285639454
Vwn_ih_61_8 wn_ih_61_8 0 0.6255202071436055
Vwp_ih_62_8 wp_ih_62_8 0 0.42963129872821704
Vwn_ih_62_8 wn_ih_62_8 0 0.570368701271783
Vwp_ih_63_8 wp_ih_63_8 0 0.36349644408496173
Vwn_ih_63_8 wn_ih_63_8 0 0.6365035559150383
Vwp_ho_8_0 wp_ho_8_0 0 0.4474976861915868
Vwn_ho_8_0 wn_ho_8_0 0 0.5525023138084132
Vwp_ho_8_1 wp_ho_8_1 0 0.3
Vwn_ho_8_1 wn_ho_8_1 0 0.7040738690778078
Vwp_ho_8_2 wp_ho_8_2 0 0.3
Vwn_ho_8_2 wn_ho_8_2 0 0.7486039420087426
Vwp_ho_8_3 wp_ho_8_3 0 0.41580705126466344
Vwn_ho_8_3 wn_ho_8_3 0 0.5841929487353366
Vwp_ho_8_4 wp_ho_8_4 0 0.5525934287333871
Vwn_ho_8_4 wn_ho_8_4 0 0.4474065712666129
Vwp_ih_0_9 wp_ih_0_9 0 0.4327896304355102
Vwn_ih_0_9 wn_ih_0_9 0 0.5672103695644898
Vwp_ih_1_9 wp_ih_1_9 0 0.5720713558635089
Vwn_ih_1_9 wn_ih_1_9 0 0.42792864413649107
Vwp_ih_2_9 wp_ih_2_9 0 0.5712061900902915
Vwn_ih_2_9 wn_ih_2_9 0 0.4287938099097085
Vwp_ih_3_9 wp_ih_3_9 0 0.5289278817994618
Vwn_ih_3_9 wn_ih_3_9 0 0.4710721182005382
Vwp_ih_4_9 wp_ih_4_9 0 0.5587344685655725
Vwn_ih_4_9 wn_ih_4_9 0 0.4412655314344275
Vwp_ih_5_9 wp_ih_5_9 0 0.423231908815876
Vwn_ih_5_9 wn_ih_5_9 0 0.576768091184124
Vwp_ih_6_9 wp_ih_6_9 0 0.3945013040558464
Vwn_ih_6_9 wn_ih_6_9 0 0.6054986959441536
Vwp_ih_7_9 wp_ih_7_9 0 0.5193115360836258
Vwn_ih_7_9 wn_ih_7_9 0 0.4806884639163742
Vwp_ih_8_9 wp_ih_8_9 0 0.6088273750076736
Vwn_ih_8_9 wn_ih_8_9 0 0.39117262499232636
Vwp_ih_9_9 wp_ih_9_9 0 0.48591136319508604
Vwn_ih_9_9 wn_ih_9_9 0 0.5140886368049139
Vwp_ih_10_9 wp_ih_10_9 0 0.419384839469261
Vwn_ih_10_9 wn_ih_10_9 0 0.580615160530739
Vwp_ih_11_9 wp_ih_11_9 0 0.35837935354685935
Vwn_ih_11_9 wn_ih_11_9 0 0.6416206464531407
Vwp_ih_12_9 wp_ih_12_9 0 0.426167358556346
Vwn_ih_12_9 wn_ih_12_9 0 0.573832641443654
Vwp_ih_13_9 wp_ih_13_9 0 0.6323028124265095
Vwn_ih_13_9 wn_ih_13_9 0 0.3676971875734905
Vwp_ih_14_9 wp_ih_14_9 0 0.4749999004268308
Vwn_ih_14_9 wn_ih_14_9 0 0.5250000995731692
Vwp_ih_15_9 wp_ih_15_9 0 0.4086412379862657
Vwn_ih_15_9 wn_ih_15_9 0 0.5913587620137343
Vwp_ih_16_9 wp_ih_16_9 0 0.4336426184706218
Vwn_ih_16_9 wn_ih_16_9 0 0.5663573815293782
Vwp_ih_17_9 wp_ih_17_9 0 0.4436813443411037
Vwn_ih_17_9 wn_ih_17_9 0 0.5563186556588963
Vwp_ih_18_9 wp_ih_18_9 0 0.5348055480616706
Vwn_ih_18_9 wn_ih_18_9 0 0.4651944519383295
Vwp_ih_19_9 wp_ih_19_9 0 0.425452418947122
Vwn_ih_19_9 wn_ih_19_9 0 0.574547581052878
Vwp_ih_20_9 wp_ih_20_9 0 0.4616090295459361
Vwn_ih_20_9 wn_ih_20_9 0 0.5383909704540639
Vwp_ih_21_9 wp_ih_21_9 0 0.4639324630353885
Vwn_ih_21_9 wn_ih_21_9 0 0.5360675369646115
Vwp_ih_22_9 wp_ih_22_9 0 0.5281544567757765
Vwn_ih_22_9 wn_ih_22_9 0 0.47184554322422345
Vwp_ih_23_9 wp_ih_23_9 0 0.5613842884815736
Vwn_ih_23_9 wn_ih_23_9 0 0.4386157115184263
Vwp_ih_24_9 wp_ih_24_9 0 0.5474017366590571
Vwn_ih_24_9 wn_ih_24_9 0 0.4525982633409429
Vwp_ih_25_9 wp_ih_25_9 0 0.46130950524857434
Vwn_ih_25_9 wn_ih_25_9 0 0.5386904947514257
Vwp_ih_26_9 wp_ih_26_9 0 0.3324685381940916
Vwn_ih_26_9 wn_ih_26_9 0 0.6675314618059084
Vwp_ih_27_9 wp_ih_27_9 0 0.45088156187138184
Vwn_ih_27_9 wn_ih_27_9 0 0.5491184381286182
Vwp_ih_28_9 wp_ih_28_9 0 0.5651517083999152
Vwn_ih_28_9 wn_ih_28_9 0 0.4348482916000848
Vwp_ih_29_9 wp_ih_29_9 0 0.4094274228855471
Vwn_ih_29_9 wn_ih_29_9 0 0.5905725771144529
Vwp_ih_30_9 wp_ih_30_9 0 0.4842871324038887
Vwn_ih_30_9 wn_ih_30_9 0 0.5157128675961113
Vwp_ih_31_9 wp_ih_31_9 0 0.4534478465832984
Vwn_ih_31_9 wn_ih_31_9 0 0.5465521534167016
Vwp_ih_32_9 wp_ih_32_9 0 0.4476052441847225
Vwn_ih_32_9 wn_ih_32_9 0 0.5523947558152775
Vwp_ih_33_9 wp_ih_33_9 0 0.5631940764178985
Vwn_ih_33_9 wn_ih_33_9 0 0.43680592358210146
Vwp_ih_34_9 wp_ih_34_9 0 0.47828372637429534
Vwn_ih_34_9 wn_ih_34_9 0 0.5217162736257047
Vwp_ih_35_9 wp_ih_35_9 0 0.6465036939208326
Vwn_ih_35_9 wn_ih_35_9 0 0.3534963060791674
Vwp_ih_36_9 wp_ih_36_9 0 0.4736085396269853
Vwn_ih_36_9 wn_ih_36_9 0 0.5263914603730147
Vwp_ih_37_9 wp_ih_37_9 0 0.6184621816966007
Vwn_ih_37_9 wn_ih_37_9 0 0.3815378183033993
Vwp_ih_38_9 wp_ih_38_9 0 0.5491915033675467
Vwn_ih_38_9 wn_ih_38_9 0 0.45080849663245326
Vwp_ih_39_9 wp_ih_39_9 0 0.3
Vwn_ih_39_9 wn_ih_39_9 0 0.7695502501878255
Vwp_ih_40_9 wp_ih_40_9 0 0.4923645538950093
Vwn_ih_40_9 wn_ih_40_9 0 0.5076354461049907
Vwp_ih_41_9 wp_ih_41_9 0 0.557517674064383
Vwn_ih_41_9 wn_ih_41_9 0 0.44248232593561704
Vwp_ih_42_9 wp_ih_42_9 0 0.561028826309237
Vwn_ih_42_9 wn_ih_42_9 0 0.438971173690763
Vwp_ih_43_9 wp_ih_43_9 0 0.481003590985752
Vwn_ih_43_9 wn_ih_43_9 0 0.5189964090142479
Vwp_ih_44_9 wp_ih_44_9 0 0.4895684554111827
Vwn_ih_44_9 wn_ih_44_9 0 0.5104315445888173
Vwp_ih_45_9 wp_ih_45_9 0 0.3674933080269338
Vwn_ih_45_9 wn_ih_45_9 0 0.6325066919730662
Vwp_ih_46_9 wp_ih_46_9 0 0.5131418907327461
Vwn_ih_46_9 wn_ih_46_9 0 0.486858109267254
Vwp_ih_47_9 wp_ih_47_9 0 0.33290873035067575
Vwn_ih_47_9 wn_ih_47_9 0 0.6670912696493243
Vwp_ih_48_9 wp_ih_48_9 0 0.3994489764071517
Vwn_ih_48_9 wn_ih_48_9 0 0.6005510235928483
Vwp_ih_49_9 wp_ih_49_9 0 0.5821542647941207
Vwn_ih_49_9 wn_ih_49_9 0 0.41784573520587925
Vwp_ih_50_9 wp_ih_50_9 0 0.48037679080868173
Vwn_ih_50_9 wn_ih_50_9 0 0.5196232091913183
Vwp_ih_51_9 wp_ih_51_9 0 0.45953205203080905
Vwn_ih_51_9 wn_ih_51_9 0 0.540467947969191
Vwp_ih_52_9 wp_ih_52_9 0 0.5234782692856295
Vwn_ih_52_9 wn_ih_52_9 0 0.47652173071437054
Vwp_ih_53_9 wp_ih_53_9 0 0.7439668889354477
Vwn_ih_53_9 wn_ih_53_9 0 0.3
Vwp_ih_54_9 wp_ih_54_9 0 0.5901630446816538
Vwn_ih_54_9 wn_ih_54_9 0 0.40983695531834613
Vwp_ih_55_9 wp_ih_55_9 0 0.4421105302769731
Vwn_ih_55_9 wn_ih_55_9 0 0.5578894697230269
Vwp_ih_56_9 wp_ih_56_9 0 0.6484903653679841
Vwn_ih_56_9 wn_ih_56_9 0 0.3515096346320159
Vwp_ih_57_9 wp_ih_57_9 0 0.4967836363099282
Vwn_ih_57_9 wn_ih_57_9 0 0.5032163636900718
Vwp_ih_58_9 wp_ih_58_9 0 0.5617883248249393
Vwn_ih_58_9 wn_ih_58_9 0 0.43821167517506066
Vwp_ih_59_9 wp_ih_59_9 0 0.44721013792705644
Vwn_ih_59_9 wn_ih_59_9 0 0.5527898620729436
Vwp_ih_60_9 wp_ih_60_9 0 0.4383334308268363
Vwn_ih_60_9 wn_ih_60_9 0 0.5616665691731637
Vwp_ih_61_9 wp_ih_61_9 0 0.6043304997674233
Vwn_ih_61_9 wn_ih_61_9 0 0.39566950023257674
Vwp_ih_62_9 wp_ih_62_9 0 0.446134159297861
Vwn_ih_62_9 wn_ih_62_9 0 0.5538658407021391
Vwp_ih_63_9 wp_ih_63_9 0 0.436555853351239
Vwn_ih_63_9 wn_ih_63_9 0 0.563444146648761
Vwp_ho_9_0 wp_ho_9_0 0 0.3773916380826989
Vwn_ho_9_0 wn_ho_9_0 0 0.6226083619173011
Vwp_ho_9_1 wp_ho_9_1 0 0.5777339792104687
Vwn_ho_9_1 wn_ho_9_1 0 0.42226602078953135
Vwp_ho_9_2 wp_ho_9_2 0 0.6100555771075858
Vwn_ho_9_2 wn_ho_9_2 0 0.38994442289241416
Vwp_ho_9_3 wp_ho_9_3 0 0.3937820208455521
Vwn_ho_9_3 wn_ho_9_3 0 0.606217979154448
Vwp_ho_9_4 wp_ho_9_4 0 0.3
Vwn_ho_9_4 wn_ho_9_4 0 0.7236551895779777
Vwp_ih_0_10 wp_ih_0_10 0 0.5808050869243284
Vwn_ih_0_10 wn_ih_0_10 0 0.4191949130756715
Vwp_ih_1_10 wp_ih_1_10 0 0.42866538833984696
Vwn_ih_1_10 wn_ih_1_10 0 0.571334611660153
Vwp_ih_2_10 wp_ih_2_10 0 0.4040238277082033
Vwn_ih_2_10 wn_ih_2_10 0 0.5959761722917967
Vwp_ih_3_10 wp_ih_3_10 0 0.5597747628310819
Vwn_ih_3_10 wn_ih_3_10 0 0.44022523716891815
Vwp_ih_4_10 wp_ih_4_10 0 0.3294893626097717
Vwn_ih_4_10 wn_ih_4_10 0 0.6705106373902283
Vwp_ih_5_10 wp_ih_5_10 0 0.412502640477223
Vwn_ih_5_10 wn_ih_5_10 0 0.5874973595227769
Vwp_ih_6_10 wp_ih_6_10 0 0.4425202685574827
Vwn_ih_6_10 wn_ih_6_10 0 0.5574797314425173
Vwp_ih_7_10 wp_ih_7_10 0 0.3662791036790509
Vwn_ih_7_10 wn_ih_7_10 0 0.6337208963209491
Vwp_ih_8_10 wp_ih_8_10 0 0.39389347060391533
Vwn_ih_8_10 wn_ih_8_10 0 0.6061065293960847
Vwp_ih_9_10 wp_ih_9_10 0 0.5980214094898699
Vwn_ih_9_10 wn_ih_9_10 0 0.4019785905101301
Vwp_ih_10_10 wp_ih_10_10 0 0.5483133154434984
Vwn_ih_10_10 wn_ih_10_10 0 0.4516866845565016
Vwp_ih_11_10 wp_ih_11_10 0 0.4171815298310803
Vwn_ih_11_10 wn_ih_11_10 0 0.5828184701689196
Vwp_ih_12_10 wp_ih_12_10 0 0.5540643390955167
Vwn_ih_12_10 wn_ih_12_10 0 0.4459356609044833
Vwp_ih_13_10 wp_ih_13_10 0 0.621204383449925
Vwn_ih_13_10 wn_ih_13_10 0 0.37879561655007493
Vwp_ih_14_10 wp_ih_14_10 0 0.4060040448330588
Vwn_ih_14_10 wn_ih_14_10 0 0.5939959551669411
Vwp_ih_15_10 wp_ih_15_10 0 0.5122528784650558
Vwn_ih_15_10 wn_ih_15_10 0 0.4877471215349441
Vwp_ih_16_10 wp_ih_16_10 0 0.6738167486882007
Vwn_ih_16_10 wn_ih_16_10 0 0.32618325131179926
Vwp_ih_17_10 wp_ih_17_10 0 0.5593419346650617
Vwn_ih_17_10 wn_ih_17_10 0 0.4406580653349383
Vwp_ih_18_10 wp_ih_18_10 0 0.5573307097293178
Vwn_ih_18_10 wn_ih_18_10 0 0.44266929027068225
Vwp_ih_19_10 wp_ih_19_10 0 0.4611049458373364
Vwn_ih_19_10 wn_ih_19_10 0 0.5388950541626636
Vwp_ih_20_10 wp_ih_20_10 0 0.42403877814777235
Vwn_ih_20_10 wn_ih_20_10 0 0.5759612218522276
Vwp_ih_21_10 wp_ih_21_10 0 0.6032342220898346
Vwn_ih_21_10 wn_ih_21_10 0 0.3967657779101655
Vwp_ih_22_10 wp_ih_22_10 0 0.558612368576475
Vwn_ih_22_10 wn_ih_22_10 0 0.441387631423525
Vwp_ih_23_10 wp_ih_23_10 0 0.5148916521538833
Vwn_ih_23_10 wn_ih_23_10 0 0.4851083478461166
Vwp_ih_24_10 wp_ih_24_10 0 0.4547442713925833
Vwn_ih_24_10 wn_ih_24_10 0 0.5452557286074167
Vwp_ih_25_10 wp_ih_25_10 0 0.3442666174893189
Vwn_ih_25_10 wn_ih_25_10 0 0.655733382510681
Vwp_ih_26_10 wp_ih_26_10 0 0.483030118912395
Vwn_ih_26_10 wn_ih_26_10 0 0.516969881087605
Vwp_ih_27_10 wp_ih_27_10 0 0.44027914493074827
Vwn_ih_27_10 wn_ih_27_10 0 0.5597208550692517
Vwp_ih_28_10 wp_ih_28_10 0 0.5018129588011864
Vwn_ih_28_10 wn_ih_28_10 0 0.49818704119881363
Vwp_ih_29_10 wp_ih_29_10 0 0.5466168077909326
Vwn_ih_29_10 wn_ih_29_10 0 0.4533831922090674
Vwp_ih_30_10 wp_ih_30_10 0 0.5731769967619479
Vwn_ih_30_10 wn_ih_30_10 0 0.4268230032380521
Vwp_ih_31_10 wp_ih_31_10 0 0.576019695404397
Vwn_ih_31_10 wn_ih_31_10 0 0.42398030459560304
Vwp_ih_32_10 wp_ih_32_10 0 0.7029557898984747
Vwn_ih_32_10 wn_ih_32_10 0 0.3
Vwp_ih_33_10 wp_ih_33_10 0 0.6089326717389673
Vwn_ih_33_10 wn_ih_33_10 0 0.39106732826103274
Vwp_ih_34_10 wp_ih_34_10 0 0.4326339268340702
Vwn_ih_34_10 wn_ih_34_10 0 0.5673660731659298
Vwp_ih_35_10 wp_ih_35_10 0 0.44362829345801663
Vwn_ih_35_10 wn_ih_35_10 0 0.5563717065419834
Vwp_ih_36_10 wp_ih_36_10 0 0.6893774383241281
Vwn_ih_36_10 wn_ih_36_10 0 0.3106225616758719
Vwp_ih_37_10 wp_ih_37_10 0 0.42852690451199793
Vwn_ih_37_10 wn_ih_37_10 0 0.5714730954880021
Vwp_ih_38_10 wp_ih_38_10 0 0.5127511218080224
Vwn_ih_38_10 wn_ih_38_10 0 0.48724887819197765
Vwp_ih_39_10 wp_ih_39_10 0 0.6570373178980723
Vwn_ih_39_10 wn_ih_39_10 0 0.3429626821019277
Vwp_ih_40_10 wp_ih_40_10 0 0.640359138998753
Vwn_ih_40_10 wn_ih_40_10 0 0.35964086100124704
Vwp_ih_41_10 wp_ih_41_10 0 0.48292858182537796
Vwn_ih_41_10 wn_ih_41_10 0 0.5170714181746221
Vwp_ih_42_10 wp_ih_42_10 0 0.521207401465464
Vwn_ih_42_10 wn_ih_42_10 0 0.478792598534536
Vwp_ih_43_10 wp_ih_43_10 0 0.34192607830836297
Vwn_ih_43_10 wn_ih_43_10 0 0.658073921691637
Vwp_ih_44_10 wp_ih_44_10 0 0.38874623926525426
Vwn_ih_44_10 wn_ih_44_10 0 0.6112537607347458
Vwp_ih_45_10 wp_ih_45_10 0 0.4878362814749341
Vwn_ih_45_10 wn_ih_45_10 0 0.5121637185250659
Vwp_ih_46_10 wp_ih_46_10 0 0.5134898060087829
Vwn_ih_46_10 wn_ih_46_10 0 0.4865101939912171
Vwp_ih_47_10 wp_ih_47_10 0 0.461926951618565
Vwn_ih_47_10 wn_ih_47_10 0 0.538073048381435
Vwp_ih_48_10 wp_ih_48_10 0 0.5100783725218972
Vwn_ih_48_10 wn_ih_48_10 0 0.48992162747810275
Vwp_ih_49_10 wp_ih_49_10 0 0.6967513527033965
Vwn_ih_49_10 wn_ih_49_10 0 0.3032486472966035
Vwp_ih_50_10 wp_ih_50_10 0 0.5674749977827899
Vwn_ih_50_10 wn_ih_50_10 0 0.43252500221721013
Vwp_ih_51_10 wp_ih_51_10 0 0.5440906622582644
Vwn_ih_51_10 wn_ih_51_10 0 0.45590933774173564
Vwp_ih_52_10 wp_ih_52_10 0 0.533292454028008
Vwn_ih_52_10 wn_ih_52_10 0 0.46670754597199204
Vwp_ih_53_10 wp_ih_53_10 0 0.5169863265223392
Vwn_ih_53_10 wn_ih_53_10 0 0.4830136734776607
Vwp_ih_54_10 wp_ih_54_10 0 0.6170370870998777
Vwn_ih_54_10 wn_ih_54_10 0 0.3829629129001223
Vwp_ih_55_10 wp_ih_55_10 0 0.39771600787318573
Vwn_ih_55_10 wn_ih_55_10 0 0.6022839921268143
Vwp_ih_56_10 wp_ih_56_10 0 0.48631168854444173
Vwn_ih_56_10 wn_ih_56_10 0 0.5136883114555583
Vwp_ih_57_10 wp_ih_57_10 0 0.42666956616231566
Vwn_ih_57_10 wn_ih_57_10 0 0.5733304338376843
Vwp_ih_58_10 wp_ih_58_10 0 0.5485231266556551
Vwn_ih_58_10 wn_ih_58_10 0 0.45147687334434494
Vwp_ih_59_10 wp_ih_59_10 0 0.5446682933813843
Vwn_ih_59_10 wn_ih_59_10 0 0.45533170661861566
Vwp_ih_60_10 wp_ih_60_10 0 0.5981434264201376
Vwn_ih_60_10 wn_ih_60_10 0 0.4018565735798624
Vwp_ih_61_10 wp_ih_61_10 0 0.599954780734935
Vwn_ih_61_10 wn_ih_61_10 0 0.400045219265065
Vwp_ih_62_10 wp_ih_62_10 0 0.5640295408479686
Vwn_ih_62_10 wn_ih_62_10 0 0.4359704591520313
Vwp_ih_63_10 wp_ih_63_10 0 0.6384317779287592
Vwn_ih_63_10 wn_ih_63_10 0 0.3615682220712408
Vwp_ho_10_0 wp_ho_10_0 0 0.5514559676776706
Vwn_ho_10_0 wn_ho_10_0 0 0.4485440323223294
Vwp_ho_10_1 wp_ho_10_1 0 0.36854838839435144
Vwn_ho_10_1 wn_ho_10_1 0 0.6314516116056486
Vwp_ho_10_2 wp_ho_10_2 0 0.5580119680133812
Vwn_ho_10_2 wn_ho_10_2 0 0.44198803198661885
Vwp_ho_10_3 wp_ho_10_3 0 0.5295405278573488
Vwn_ho_10_3 wn_ho_10_3 0 0.47045947214265116
Vwp_ho_10_4 wp_ho_10_4 0 0.4619407360710852
Vwn_ho_10_4 wn_ho_10_4 0 0.5380592639289148
Vwp_ih_0_11 wp_ih_0_11 0 0.6429652941175528
Vwn_ih_0_11 wn_ih_0_11 0 0.3570347058824472
Vwp_ih_1_11 wp_ih_1_11 0 0.5150583544808526
Vwn_ih_1_11 wn_ih_1_11 0 0.4849416455191475
Vwp_ih_2_11 wp_ih_2_11 0 0.5389534370491594
Vwn_ih_2_11 wn_ih_2_11 0 0.46104656295084057
Vwp_ih_3_11 wp_ih_3_11 0 0.37334572313562014
Vwn_ih_3_11 wn_ih_3_11 0 0.6266542768643799
Vwp_ih_4_11 wp_ih_4_11 0 0.527393464311243
Vwn_ih_4_11 wn_ih_4_11 0 0.472606535688757
Vwp_ih_5_11 wp_ih_5_11 0 0.465074695495896
Vwn_ih_5_11 wn_ih_5_11 0 0.534925304504104
Vwp_ih_6_11 wp_ih_6_11 0 0.3754350651120757
Vwn_ih_6_11 wn_ih_6_11 0 0.6245649348879243
Vwp_ih_7_11 wp_ih_7_11 0 0.4782237638286783
Vwn_ih_7_11 wn_ih_7_11 0 0.5217762361713217
Vwp_ih_8_11 wp_ih_8_11 0 0.5852872483333261
Vwn_ih_8_11 wn_ih_8_11 0 0.4147127516666739
Vwp_ih_9_11 wp_ih_9_11 0 0.440996282727973
Vwn_ih_9_11 wn_ih_9_11 0 0.559003717272027
Vwp_ih_10_11 wp_ih_10_11 0 0.6248219463391599
Vwn_ih_10_11 wn_ih_10_11 0 0.3751780536608401
Vwp_ih_11_11 wp_ih_11_11 0 0.5422492831650496
Vwn_ih_11_11 wn_ih_11_11 0 0.4577507168349504
Vwp_ih_12_11 wp_ih_12_11 0 0.42917979911592435
Vwn_ih_12_11 wn_ih_12_11 0 0.5708202008840757
Vwp_ih_13_11 wp_ih_13_11 0 0.45735082330707827
Vwn_ih_13_11 wn_ih_13_11 0 0.5426491766929217
Vwp_ih_14_11 wp_ih_14_11 0 0.5507110053712867
Vwn_ih_14_11 wn_ih_14_11 0 0.4492889946287133
Vwp_ih_15_11 wp_ih_15_11 0 0.3899995846757148
Vwn_ih_15_11 wn_ih_15_11 0 0.6100004153242852
Vwp_ih_16_11 wp_ih_16_11 0 0.6808590891471815
Vwn_ih_16_11 wn_ih_16_11 0 0.3191409108528185
Vwp_ih_17_11 wp_ih_17_11 0 0.45044186985002255
Vwn_ih_17_11 wn_ih_17_11 0 0.5495581301499775
Vwp_ih_18_11 wp_ih_18_11 0 0.4765397717675635
Vwn_ih_18_11 wn_ih_18_11 0 0.5234602282324364
Vwp_ih_19_11 wp_ih_19_11 0 0.5850340977367073
Vwn_ih_19_11 wn_ih_19_11 0 0.41496590226329266
Vwp_ih_20_11 wp_ih_20_11 0 0.5014819386735064
Vwn_ih_20_11 wn_ih_20_11 0 0.4985180613264936
Vwp_ih_21_11 wp_ih_21_11 0 0.5774381860642309
Vwn_ih_21_11 wn_ih_21_11 0 0.42256181393576914
Vwp_ih_22_11 wp_ih_22_11 0 0.5937305032589384
Vwn_ih_22_11 wn_ih_22_11 0 0.4062694967410616
Vwp_ih_23_11 wp_ih_23_11 0 0.5524273434705353
Vwn_ih_23_11 wn_ih_23_11 0 0.4475726565294646
Vwp_ih_24_11 wp_ih_24_11 0 0.38967705584969803
Vwn_ih_24_11 wn_ih_24_11 0 0.610322944150302
Vwp_ih_25_11 wp_ih_25_11 0 0.4150585334716975
Vwn_ih_25_11 wn_ih_25_11 0 0.5849414665283025
Vwp_ih_26_11 wp_ih_26_11 0 0.5606774920415896
Vwn_ih_26_11 wn_ih_26_11 0 0.43932250795841044
Vwp_ih_27_11 wp_ih_27_11 0 0.4780759121828345
Vwn_ih_27_11 wn_ih_27_11 0 0.5219240878171655
Vwp_ih_28_11 wp_ih_28_11 0 0.3
Vwn_ih_28_11 wn_ih_28_11 0 0.7049975269922207
Vwp_ih_29_11 wp_ih_29_11 0 0.5603478674364873
Vwn_ih_29_11 wn_ih_29_11 0 0.43965213256351265
Vwp_ih_30_11 wp_ih_30_11 0 0.686387550657921
Vwn_ih_30_11 wn_ih_30_11 0 0.313612449342079
Vwp_ih_31_11 wp_ih_31_11 0 0.6385019362163455
Vwn_ih_31_11 wn_ih_31_11 0 0.3614980637836544
Vwp_ih_32_11 wp_ih_32_11 0 0.408392633617081
Vwn_ih_32_11 wn_ih_32_11 0 0.591607366382919
Vwp_ih_33_11 wp_ih_33_11 0 0.5392451821085417
Vwn_ih_33_11 wn_ih_33_11 0 0.46075481789145833
Vwp_ih_34_11 wp_ih_34_11 0 0.33188163545147886
Vwn_ih_34_11 wn_ih_34_11 0 0.6681183645485211
Vwp_ih_35_11 wp_ih_35_11 0 0.6293937860937288
Vwn_ih_35_11 wn_ih_35_11 0 0.37060621390627124
Vwp_ih_36_11 wp_ih_36_11 0 0.31276103558583834
Vwn_ih_36_11 wn_ih_36_11 0 0.6872389644141617
Vwp_ih_37_11 wp_ih_37_11 0 0.5294743939093851
Vwn_ih_37_11 wn_ih_37_11 0 0.4705256060906149
Vwp_ih_38_11 wp_ih_38_11 0 0.53413029521309
Vwn_ih_38_11 wn_ih_38_11 0 0.46586970478691003
Vwp_ih_39_11 wp_ih_39_11 0 0.6162189557837662
Vwn_ih_39_11 wn_ih_39_11 0 0.3837810442162338
Vwp_ih_40_11 wp_ih_40_11 0 0.5535712978797208
Vwn_ih_40_11 wn_ih_40_11 0 0.44642870212027913
Vwp_ih_41_11 wp_ih_41_11 0 0.43348366222428786
Vwn_ih_41_11 wn_ih_41_11 0 0.5665163377757121
Vwp_ih_42_11 wp_ih_42_11 0 0.46375217213535685
Vwn_ih_42_11 wn_ih_42_11 0 0.5362478278646431
Vwp_ih_43_11 wp_ih_43_11 0 0.5428882558939995
Vwn_ih_43_11 wn_ih_43_11 0 0.4571117441060006
Vwp_ih_44_11 wp_ih_44_11 0 0.5137409084272716
Vwn_ih_44_11 wn_ih_44_11 0 0.48625909157272845
Vwp_ih_45_11 wp_ih_45_11 0 0.6048658486746041
Vwn_ih_45_11 wn_ih_45_11 0 0.3951341513253958
Vwp_ih_46_11 wp_ih_46_11 0 0.5003059600301586
Vwn_ih_46_11 wn_ih_46_11 0 0.49969403996984146
Vwp_ih_47_11 wp_ih_47_11 0 0.703046539738652
Vwn_ih_47_11 wn_ih_47_11 0 0.3
Vwp_ih_48_11 wp_ih_48_11 0 0.5673078428819038
Vwn_ih_48_11 wn_ih_48_11 0 0.4326921571180962
Vwp_ih_49_11 wp_ih_49_11 0 0.48237894683894794
Vwn_ih_49_11 wn_ih_49_11 0 0.5176210531610521
Vwp_ih_50_11 wp_ih_50_11 0 0.6103667011057157
Vwn_ih_50_11 wn_ih_50_11 0 0.3896332988942843
Vwp_ih_51_11 wp_ih_51_11 0 0.4952452759877428
Vwn_ih_51_11 wn_ih_51_11 0 0.5047547240122572
Vwp_ih_52_11 wp_ih_52_11 0 0.4556745804259142
Vwn_ih_52_11 wn_ih_52_11 0 0.5443254195740859
Vwp_ih_53_11 wp_ih_53_11 0 0.5243156864992158
Vwn_ih_53_11 wn_ih_53_11 0 0.47568431350078416
Vwp_ih_54_11 wp_ih_54_11 0 0.3
Vwn_ih_54_11 wn_ih_54_11 0 0.704784443208744
Vwp_ih_55_11 wp_ih_55_11 0 0.5066727127627831
Vwn_ih_55_11 wn_ih_55_11 0 0.49332728723721686
Vwp_ih_56_11 wp_ih_56_11 0 0.529267147506157
Vwn_ih_56_11 wn_ih_56_11 0 0.470732852493843
Vwp_ih_57_11 wp_ih_57_11 0 0.45122129955197576
Vwn_ih_57_11 wn_ih_57_11 0 0.5487787004480242
Vwp_ih_58_11 wp_ih_58_11 0 0.5210893540319085
Vwn_ih_58_11 wn_ih_58_11 0 0.47891064596809146
Vwp_ih_59_11 wp_ih_59_11 0 0.4322009376186546
Vwn_ih_59_11 wn_ih_59_11 0 0.5677990623813454
Vwp_ih_60_11 wp_ih_60_11 0 0.5118880093356943
Vwn_ih_60_11 wn_ih_60_11 0 0.48811199066430566
Vwp_ih_61_11 wp_ih_61_11 0 0.6024209707361062
Vwn_ih_61_11 wn_ih_61_11 0 0.3975790292638938
Vwp_ih_62_11 wp_ih_62_11 0 0.5121207107135373
Vwn_ih_62_11 wn_ih_62_11 0 0.4878792892864628
Vwp_ih_63_11 wp_ih_63_11 0 0.46324436704568156
Vwn_ih_63_11 wn_ih_63_11 0 0.5367556329543184
Vwp_ho_11_0 wp_ho_11_0 0 0.5670332607497668
Vwn_ho_11_0 wn_ho_11_0 0 0.43296673925023316
Vwp_ho_11_1 wp_ho_11_1 0 0.4196622737924668
Vwn_ho_11_1 wn_ho_11_1 0 0.5803377262075332
Vwp_ho_11_2 wp_ho_11_2 0 0.5701182076552813
Vwn_ho_11_2 wn_ho_11_2 0 0.4298817923447187
Vwp_ho_11_3 wp_ho_11_3 0 0.3
Vwn_ho_11_3 wn_ho_11_3 0 0.7468032016528691
Vwp_ho_11_4 wp_ho_11_4 0 0.6869484814519833
Vwn_ho_11_4 wn_ho_11_4 0 0.3130515185480167
Vwp_ih_0_12 wp_ih_0_12 0 0.4453043994670909
Vwn_ih_0_12 wn_ih_0_12 0 0.5546956005329091
Vwp_ih_1_12 wp_ih_1_12 0 0.626785174592047
Vwn_ih_1_12 wn_ih_1_12 0 0.373214825407953
Vwp_ih_2_12 wp_ih_2_12 0 0.31726186623194597
Vwn_ih_2_12 wn_ih_2_12 0 0.682738133768054
Vwp_ih_3_12 wp_ih_3_12 0 0.521677055139214
Vwn_ih_3_12 wn_ih_3_12 0 0.478322944860786
Vwp_ih_4_12 wp_ih_4_12 0 0.5201236503281634
Vwn_ih_4_12 wn_ih_4_12 0 0.4798763496718365
Vwp_ih_5_12 wp_ih_5_12 0 0.6726673072405067
Vwn_ih_5_12 wn_ih_5_12 0 0.3273326927594932
Vwp_ih_6_12 wp_ih_6_12 0 0.6716044016643833
Vwn_ih_6_12 wn_ih_6_12 0 0.3283955983356167
Vwp_ih_7_12 wp_ih_7_12 0 0.5176032013082994
Vwn_ih_7_12 wn_ih_7_12 0 0.48239679869170066
Vwp_ih_8_12 wp_ih_8_12 0 0.36658980428829147
Vwn_ih_8_12 wn_ih_8_12 0 0.6334101957117085
Vwp_ih_9_12 wp_ih_9_12 0 0.5485636513477951
Vwn_ih_9_12 wn_ih_9_12 0 0.4514363486522049
Vwp_ih_10_12 wp_ih_10_12 0 0.6022768951313541
Vwn_ih_10_12 wn_ih_10_12 0 0.3977231048686459
Vwp_ih_11_12 wp_ih_11_12 0 0.43060326183602726
Vwn_ih_11_12 wn_ih_11_12 0 0.5693967381639727
Vwp_ih_12_12 wp_ih_12_12 0 0.5793560328740632
Vwn_ih_12_12 wn_ih_12_12 0 0.42064396712593677
Vwp_ih_13_12 wp_ih_13_12 0 0.40594329036125476
Vwn_ih_13_12 wn_ih_13_12 0 0.5940567096387452
Vwp_ih_14_12 wp_ih_14_12 0 0.4258671553650014
Vwn_ih_14_12 wn_ih_14_12 0 0.5741328446349986
Vwp_ih_15_12 wp_ih_15_12 0 0.3766221838456051
Vwn_ih_15_12 wn_ih_15_12 0 0.6233778161543949
Vwp_ih_16_12 wp_ih_16_12 0 0.5863615740886703
Vwn_ih_16_12 wn_ih_16_12 0 0.4136384259113297
Vwp_ih_17_12 wp_ih_17_12 0 0.4884411721386555
Vwn_ih_17_12 wn_ih_17_12 0 0.5115588278613445
Vwp_ih_18_12 wp_ih_18_12 0 0.5882305098220764
Vwn_ih_18_12 wn_ih_18_12 0 0.4117694901779236
Vwp_ih_19_12 wp_ih_19_12 0 0.6648436325500204
Vwn_ih_19_12 wn_ih_19_12 0 0.3351563674499796
Vwp_ih_20_12 wp_ih_20_12 0 0.48283014047888645
Vwn_ih_20_12 wn_ih_20_12 0 0.5171698595211136
Vwp_ih_21_12 wp_ih_21_12 0 0.5378516074271931
Vwn_ih_21_12 wn_ih_21_12 0 0.46214839257280693
Vwp_ih_22_12 wp_ih_22_12 0 0.617207692278589
Vwn_ih_22_12 wn_ih_22_12 0 0.382792307721411
Vwp_ih_23_12 wp_ih_23_12 0 0.4114635225054396
Vwn_ih_23_12 wn_ih_23_12 0 0.5885364774945604
Vwp_ih_24_12 wp_ih_24_12 0 0.5037199918310397
Vwn_ih_24_12 wn_ih_24_12 0 0.4962800081689604
Vwp_ih_25_12 wp_ih_25_12 0 0.43510503842736914
Vwn_ih_25_12 wn_ih_25_12 0 0.5648949615726309
Vwp_ih_26_12 wp_ih_26_12 0 0.5330974591390686
Vwn_ih_26_12 wn_ih_26_12 0 0.46690254086093136
Vwp_ih_27_12 wp_ih_27_12 0 0.4820322695570131
Vwn_ih_27_12 wn_ih_27_12 0 0.5179677304429869
Vwp_ih_28_12 wp_ih_28_12 0 0.5014668519196338
Vwn_ih_28_12 wn_ih_28_12 0 0.4985331480803662
Vwp_ih_29_12 wp_ih_29_12 0 0.737690586728857
Vwn_ih_29_12 wn_ih_29_12 0 0.3
Vwp_ih_30_12 wp_ih_30_12 0 0.45235182490890746
Vwn_ih_30_12 wn_ih_30_12 0 0.5476481750910925
Vwp_ih_31_12 wp_ih_31_12 0 0.520582690331598
Vwn_ih_31_12 wn_ih_31_12 0 0.47941730966840196
Vwp_ih_32_12 wp_ih_32_12 0 0.4936180607414475
Vwn_ih_32_12 wn_ih_32_12 0 0.5063819392585525
Vwp_ih_33_12 wp_ih_33_12 0 0.5842677302482304
Vwn_ih_33_12 wn_ih_33_12 0 0.41573226975176963
Vwp_ih_34_12 wp_ih_34_12 0 0.6079153903785116
Vwn_ih_34_12 wn_ih_34_12 0 0.39208460962148844
Vwp_ih_35_12 wp_ih_35_12 0 0.5160547306178757
Vwn_ih_35_12 wn_ih_35_12 0 0.48394526938212434
Vwp_ih_36_12 wp_ih_36_12 0 0.3967846114160217
Vwn_ih_36_12 wn_ih_36_12 0 0.6032153885839783
Vwp_ih_37_12 wp_ih_37_12 0 0.5835017608061418
Vwn_ih_37_12 wn_ih_37_12 0 0.4164982391938582
Vwp_ih_38_12 wp_ih_38_12 0 0.63570170150114
Vwn_ih_38_12 wn_ih_38_12 0 0.36429829849886
Vwp_ih_39_12 wp_ih_39_12 0 0.4537948250798148
Vwn_ih_39_12 wn_ih_39_12 0 0.5462051749201853
Vwp_ih_40_12 wp_ih_40_12 0 0.6969173530441463
Vwn_ih_40_12 wn_ih_40_12 0 0.30308264695585374
Vwp_ih_41_12 wp_ih_41_12 0 0.5231086109715823
Vwn_ih_41_12 wn_ih_41_12 0 0.4768913890284177
Vwp_ih_42_12 wp_ih_42_12 0 0.4810442226709075
Vwn_ih_42_12 wn_ih_42_12 0 0.5189557773290925
Vwp_ih_43_12 wp_ih_43_12 0 0.5278043526267933
Vwn_ih_43_12 wn_ih_43_12 0 0.47219564737320674
Vwp_ih_44_12 wp_ih_44_12 0 0.4861759046022653
Vwn_ih_44_12 wn_ih_44_12 0 0.5138240953977347
Vwp_ih_45_12 wp_ih_45_12 0 0.415637184856106
Vwn_ih_45_12 wn_ih_45_12 0 0.584362815143894
Vwp_ih_46_12 wp_ih_46_12 0 0.48006391328015946
Vwn_ih_46_12 wn_ih_46_12 0 0.5199360867198405
Vwp_ih_47_12 wp_ih_47_12 0 0.6617499333250718
Vwn_ih_47_12 wn_ih_47_12 0 0.3382500666749282
Vwp_ih_48_12 wp_ih_48_12 0 0.6860113977708755
Vwn_ih_48_12 wn_ih_48_12 0 0.31398860222912456
Vwp_ih_49_12 wp_ih_49_12 0 0.4749003968757515
Vwn_ih_49_12 wn_ih_49_12 0 0.5250996031242485
Vwp_ih_50_12 wp_ih_50_12 0 0.5550780891695403
Vwn_ih_50_12 wn_ih_50_12 0 0.44492191083045973
Vwp_ih_51_12 wp_ih_51_12 0 0.46255276800970885
Vwn_ih_51_12 wn_ih_51_12 0 0.5374472319902912
Vwp_ih_52_12 wp_ih_52_12 0 0.5009411421799804
Vwn_ih_52_12 wn_ih_52_12 0 0.4990588578200195
Vwp_ih_53_12 wp_ih_53_12 0 0.6041975566036089
Vwn_ih_53_12 wn_ih_53_12 0 0.3958024433963911
Vwp_ih_54_12 wp_ih_54_12 0 0.4889816540997508
Vwn_ih_54_12 wn_ih_54_12 0 0.5110183459002492
Vwp_ih_55_12 wp_ih_55_12 0 0.5140719489617228
Vwn_ih_55_12 wn_ih_55_12 0 0.4859280510382772
Vwp_ih_56_12 wp_ih_56_12 0 0.4212353905147269
Vwn_ih_56_12 wn_ih_56_12 0 0.5787646094852731
Vwp_ih_57_12 wp_ih_57_12 0 0.3528850302802265
Vwn_ih_57_12 wn_ih_57_12 0 0.6471149697197736
Vwp_ih_58_12 wp_ih_58_12 0 0.41930922033755114
Vwn_ih_58_12 wn_ih_58_12 0 0.5806907796624489
Vwp_ih_59_12 wp_ih_59_12 0 0.4692305487513066
Vwn_ih_59_12 wn_ih_59_12 0 0.5307694512486935
Vwp_ih_60_12 wp_ih_60_12 0 0.5405559105441089
Vwn_ih_60_12 wn_ih_60_12 0 0.45944408945589105
Vwp_ih_61_12 wp_ih_61_12 0 0.5147431543129956
Vwn_ih_61_12 wn_ih_61_12 0 0.4852568456870044
Vwp_ih_62_12 wp_ih_62_12 0 0.511008794873071
Vwn_ih_62_12 wn_ih_62_12 0 0.48899120512692895
Vwp_ih_63_12 wp_ih_63_12 0 0.3
Vwn_ih_63_12 wn_ih_63_12 0 0.7245180695419046
Vwp_ho_12_0 wp_ho_12_0 0 0.4871790290727362
Vwn_ho_12_0 wn_ho_12_0 0 0.5128209709272638
Vwp_ho_12_1 wp_ho_12_1 0 0.6812669892826675
Vwn_ho_12_1 wn_ho_12_1 0 0.3187330107173325
Vwp_ho_12_2 wp_ho_12_2 0 0.6672866011653231
Vwn_ho_12_2 wn_ho_12_2 0 0.3327133988346769
Vwp_ho_12_3 wp_ho_12_3 0 0.48279270859941864
Vwn_ho_12_3 wn_ho_12_3 0 0.5172072914005814
Vwp_ho_12_4 wp_ho_12_4 0 0.5455426897798576
Vwn_ho_12_4 wn_ho_12_4 0 0.4544573102201424
Vwp_ih_0_13 wp_ih_0_13 0 0.5813096299726668
Vwn_ih_0_13 wn_ih_0_13 0 0.4186903700273332
Vwp_ih_1_13 wp_ih_1_13 0 0.381870912799844
Vwn_ih_1_13 wn_ih_1_13 0 0.618129087200156
Vwp_ih_2_13 wp_ih_2_13 0 0.5653503052616143
Vwn_ih_2_13 wn_ih_2_13 0 0.43464969473838566
Vwp_ih_3_13 wp_ih_3_13 0 0.5066667398091307
Vwn_ih_3_13 wn_ih_3_13 0 0.4933332601908693
Vwp_ih_4_13 wp_ih_4_13 0 0.5579362055435143
Vwn_ih_4_13 wn_ih_4_13 0 0.44206379445648575
Vwp_ih_5_13 wp_ih_5_13 0 0.4621445178486157
Vwn_ih_5_13 wn_ih_5_13 0 0.5378554821513842
Vwp_ih_6_13 wp_ih_6_13 0 0.5781756579440582
Vwn_ih_6_13 wn_ih_6_13 0 0.42182434205594177
Vwp_ih_7_13 wp_ih_7_13 0 0.3727885209656788
Vwn_ih_7_13 wn_ih_7_13 0 0.6272114790343212
Vwp_ih_8_13 wp_ih_8_13 0 0.6182053587465262
Vwn_ih_8_13 wn_ih_8_13 0 0.3817946412534738
Vwp_ih_9_13 wp_ih_9_13 0 0.4582615336698031
Vwn_ih_9_13 wn_ih_9_13 0 0.541738466330197
Vwp_ih_10_13 wp_ih_10_13 0 0.31843930473983245
Vwn_ih_10_13 wn_ih_10_13 0 0.6815606952601676
Vwp_ih_11_13 wp_ih_11_13 0 0.6012666258104331
Vwn_ih_11_13 wn_ih_11_13 0 0.39873337418956684
Vwp_ih_12_13 wp_ih_12_13 0 0.6137872352735788
Vwn_ih_12_13 wn_ih_12_13 0 0.3862127647264212
Vwp_ih_13_13 wp_ih_13_13 0 0.4410416778434098
Vwn_ih_13_13 wn_ih_13_13 0 0.5589583221565901
Vwp_ih_14_13 wp_ih_14_13 0 0.5816374610996791
Vwn_ih_14_13 wn_ih_14_13 0 0.41836253890032093
Vwp_ih_15_13 wp_ih_15_13 0 0.4509972011892891
Vwn_ih_15_13 wn_ih_15_13 0 0.5490027988107109
Vwp_ih_16_13 wp_ih_16_13 0 0.31092390636305656
Vwn_ih_16_13 wn_ih_16_13 0 0.6890760936369434
Vwp_ih_17_13 wp_ih_17_13 0 0.4517007279799004
Vwn_ih_17_13 wn_ih_17_13 0 0.5482992720200996
Vwp_ih_18_13 wp_ih_18_13 0 0.5920718792782479
Vwn_ih_18_13 wn_ih_18_13 0 0.4079281207217521
Vwp_ih_19_13 wp_ih_19_13 0 0.4365907758327966
Vwn_ih_19_13 wn_ih_19_13 0 0.5634092241672034
Vwp_ih_20_13 wp_ih_20_13 0 0.37622326120904304
Vwn_ih_20_13 wn_ih_20_13 0 0.623776738790957
Vwp_ih_21_13 wp_ih_21_13 0 0.542175828131241
Vwn_ih_21_13 wn_ih_21_13 0 0.457824171868759
Vwp_ih_22_13 wp_ih_22_13 0 0.5267602029881874
Vwn_ih_22_13 wn_ih_22_13 0 0.4732397970118127
Vwp_ih_23_13 wp_ih_23_13 0 0.49238651461691324
Vwn_ih_23_13 wn_ih_23_13 0 0.5076134853830868
Vwp_ih_24_13 wp_ih_24_13 0 0.4567785579055871
Vwn_ih_24_13 wn_ih_24_13 0 0.5432214420944129
Vwp_ih_25_13 wp_ih_25_13 0 0.5402182513220836
Vwn_ih_25_13 wn_ih_25_13 0 0.45978174867791644
Vwp_ih_26_13 wp_ih_26_13 0 0.569851551607526
Vwn_ih_26_13 wn_ih_26_13 0 0.43014844839247407
Vwp_ih_27_13 wp_ih_27_13 0 0.4646685761928387
Vwn_ih_27_13 wn_ih_27_13 0 0.5353314238071613
Vwp_ih_28_13 wp_ih_28_13 0 0.35153748839036725
Vwn_ih_28_13 wn_ih_28_13 0 0.6484625116096328
Vwp_ih_29_13 wp_ih_29_13 0 0.48645813518392994
Vwn_ih_29_13 wn_ih_29_13 0 0.5135418648160701
Vwp_ih_30_13 wp_ih_30_13 0 0.5458221334570122
Vwn_ih_30_13 wn_ih_30_13 0 0.45417786654298775
Vwp_ih_31_13 wp_ih_31_13 0 0.5192222827725482
Vwn_ih_31_13 wn_ih_31_13 0 0.4807777172274518
Vwp_ih_32_13 wp_ih_32_13 0 0.4942373947233185
Vwn_ih_32_13 wn_ih_32_13 0 0.5057626052766815
Vwp_ih_33_13 wp_ih_33_13 0 0.5630853614237203
Vwn_ih_33_13 wn_ih_33_13 0 0.43691463857627966
Vwp_ih_34_13 wp_ih_34_13 0 0.6035985398520207
Vwn_ih_34_13 wn_ih_34_13 0 0.3964014601479792
Vwp_ih_35_13 wp_ih_35_13 0 0.5436169330226005
Vwn_ih_35_13 wn_ih_35_13 0 0.45638306697739955
Vwp_ih_36_13 wp_ih_36_13 0 0.5255580204208894
Vwn_ih_36_13 wn_ih_36_13 0 0.47444197957911066
Vwp_ih_37_13 wp_ih_37_13 0 0.4119352373116271
Vwn_ih_37_13 wn_ih_37_13 0 0.5880647626883728
Vwp_ih_38_13 wp_ih_38_13 0 0.538490466760834
Vwn_ih_38_13 wn_ih_38_13 0 0.46150953323916594
Vwp_ih_39_13 wp_ih_39_13 0 0.5635089128331793
Vwn_ih_39_13 wn_ih_39_13 0 0.4364910871668207
Vwp_ih_40_13 wp_ih_40_13 0 0.5547378680721432
Vwn_ih_40_13 wn_ih_40_13 0 0.44526213192785674
Vwp_ih_41_13 wp_ih_41_13 0 0.583334682080522
Vwn_ih_41_13 wn_ih_41_13 0 0.41666531791947803
Vwp_ih_42_13 wp_ih_42_13 0 0.5332573039512365
Vwn_ih_42_13 wn_ih_42_13 0 0.46674269604876345
Vwp_ih_43_13 wp_ih_43_13 0 0.3949371848222263
Vwn_ih_43_13 wn_ih_43_13 0 0.6050628151777737
Vwp_ih_44_13 wp_ih_44_13 0 0.5899456758173469
Vwn_ih_44_13 wn_ih_44_13 0 0.4100543241826531
Vwp_ih_45_13 wp_ih_45_13 0 0.4590414183732118
Vwn_ih_45_13 wn_ih_45_13 0 0.5409585816267882
Vwp_ih_46_13 wp_ih_46_13 0 0.612541159489998
Vwn_ih_46_13 wn_ih_46_13 0 0.387458840510002
Vwp_ih_47_13 wp_ih_47_13 0 0.5275128510683564
Vwn_ih_47_13 wn_ih_47_13 0 0.47248714893164356
Vwp_ih_48_13 wp_ih_48_13 0 0.37345005754211863
Vwn_ih_48_13 wn_ih_48_13 0 0.6265499424578813
Vwp_ih_49_13 wp_ih_49_13 0 0.46231471082986064
Vwn_ih_49_13 wn_ih_49_13 0 0.5376852891701394
Vwp_ih_50_13 wp_ih_50_13 0 0.5970387682529331
Vwn_ih_50_13 wn_ih_50_13 0 0.4029612317470669
Vwp_ih_51_13 wp_ih_51_13 0 0.4081282756167728
Vwn_ih_51_13 wn_ih_51_13 0 0.5918717243832272
Vwp_ih_52_13 wp_ih_52_13 0 0.35954550199788304
Vwn_ih_52_13 wn_ih_52_13 0 0.640454498002117
Vwp_ih_53_13 wp_ih_53_13 0 0.4824735135002923
Vwn_ih_53_13 wn_ih_53_13 0 0.5175264864997078
Vwp_ih_54_13 wp_ih_54_13 0 0.429336833594604
Vwn_ih_54_13 wn_ih_54_13 0 0.5706631664053959
Vwp_ih_55_13 wp_ih_55_13 0 0.434915555936983
Vwn_ih_55_13 wn_ih_55_13 0 0.5650844440630169
Vwp_ih_56_13 wp_ih_56_13 0 0.5470856568863729
Vwn_ih_56_13 wn_ih_56_13 0 0.4529143431136271
Vwp_ih_57_13 wp_ih_57_13 0 0.5057970460994813
Vwn_ih_57_13 wn_ih_57_13 0 0.49420295390051877
Vwp_ih_58_13 wp_ih_58_13 0 0.4096116730812149
Vwn_ih_58_13 wn_ih_58_13 0 0.5903883269187852
Vwp_ih_59_13 wp_ih_59_13 0 0.5295022090194328
Vwn_ih_59_13 wn_ih_59_13 0 0.47049779098056715
Vwp_ih_60_13 wp_ih_60_13 0 0.44916114243959604
Vwn_ih_60_13 wn_ih_60_13 0 0.550838857560404
Vwp_ih_61_13 wp_ih_61_13 0 0.4781612617333203
Vwn_ih_61_13 wn_ih_61_13 0 0.5218387382666797
Vwp_ih_62_13 wp_ih_62_13 0 0.4678541216841228
Vwn_ih_62_13 wn_ih_62_13 0 0.5321458783158772
Vwp_ih_63_13 wp_ih_63_13 0 0.626029305201039
Vwn_ih_63_13 wn_ih_63_13 0 0.37397069479896095
Vwp_ho_13_0 wp_ho_13_0 0 0.6261893235941748
Vwn_ho_13_0 wn_ho_13_0 0 0.3738106764058252
Vwp_ho_13_1 wp_ho_13_1 0 0.3592259015878653
Vwn_ho_13_1 wn_ho_13_1 0 0.6407740984121346
Vwp_ho_13_2 wp_ho_13_2 0 0.3813093795552335
Vwn_ho_13_2 wn_ho_13_2 0 0.6186906204447665
Vwp_ho_13_3 wp_ho_13_3 0 0.4104646264519345
Vwn_ho_13_3 wn_ho_13_3 0 0.5895353735480655
Vwp_ho_13_4 wp_ho_13_4 0 0.30478745503762394
Vwn_ho_13_4 wn_ho_13_4 0 0.6952125449623761
Vwp_ih_0_14 wp_ih_0_14 0 0.5456802978654826
Vwn_ih_0_14 wn_ih_0_14 0 0.4543197021345174
Vwp_ih_1_14 wp_ih_1_14 0 0.3690116468761766
Vwn_ih_1_14 wn_ih_1_14 0 0.6309883531238234
Vwp_ih_2_14 wp_ih_2_14 0 0.5290308034755465
Vwn_ih_2_14 wn_ih_2_14 0 0.47096919652445346
Vwp_ih_3_14 wp_ih_3_14 0 0.4535729621517467
Vwn_ih_3_14 wn_ih_3_14 0 0.5464270378482533
Vwp_ih_4_14 wp_ih_4_14 0 0.4309958996206636
Vwn_ih_4_14 wn_ih_4_14 0 0.5690041003793365
Vwp_ih_5_14 wp_ih_5_14 0 0.4097030470013028
Vwn_ih_5_14 wn_ih_5_14 0 0.5902969529986972
Vwp_ih_6_14 wp_ih_6_14 0 0.5534128714056898
Vwn_ih_6_14 wn_ih_6_14 0 0.4465871285943101
Vwp_ih_7_14 wp_ih_7_14 0 0.5401842013243522
Vwn_ih_7_14 wn_ih_7_14 0 0.4598157986756478
Vwp_ih_8_14 wp_ih_8_14 0 0.48973406850244844
Vwn_ih_8_14 wn_ih_8_14 0 0.5102659314975516
Vwp_ih_9_14 wp_ih_9_14 0 0.3662749823474511
Vwn_ih_9_14 wn_ih_9_14 0 0.6337250176525488
Vwp_ih_10_14 wp_ih_10_14 0 0.38466270576055267
Vwn_ih_10_14 wn_ih_10_14 0 0.6153372942394473
Vwp_ih_11_14 wp_ih_11_14 0 0.5389384078523511
Vwn_ih_11_14 wn_ih_11_14 0 0.46106159214764886
Vwp_ih_12_14 wp_ih_12_14 0 0.4831627679611261
Vwn_ih_12_14 wn_ih_12_14 0 0.5168372320388739
Vwp_ih_13_14 wp_ih_13_14 0 0.6466222353098556
Vwn_ih_13_14 wn_ih_13_14 0 0.35337776469014437
Vwp_ih_14_14 wp_ih_14_14 0 0.47328160476776376
Vwn_ih_14_14 wn_ih_14_14 0 0.5267183952322363
Vwp_ih_15_14 wp_ih_15_14 0 0.6299131219772585
Vwn_ih_15_14 wn_ih_15_14 0 0.3700868780227415
Vwp_ih_16_14 wp_ih_16_14 0 0.6282072112037151
Vwn_ih_16_14 wn_ih_16_14 0 0.37179278879628486
Vwp_ih_17_14 wp_ih_17_14 0 0.5099640428483795
Vwn_ih_17_14 wn_ih_17_14 0 0.4900359571516205
Vwp_ih_18_14 wp_ih_18_14 0 0.5637056058712426
Vwn_ih_18_14 wn_ih_18_14 0 0.43629439412875737
Vwp_ih_19_14 wp_ih_19_14 0 0.4412920848620165
Vwn_ih_19_14 wn_ih_19_14 0 0.5587079151379836
Vwp_ih_20_14 wp_ih_20_14 0 0.49995966471874836
Vwn_ih_20_14 wn_ih_20_14 0 0.5000403352812516
Vwp_ih_21_14 wp_ih_21_14 0 0.3248741816883279
Vwn_ih_21_14 wn_ih_21_14 0 0.6751258183116722
Vwp_ih_22_14 wp_ih_22_14 0 0.5329686175810079
Vwn_ih_22_14 wn_ih_22_14 0 0.4670313824189921
Vwp_ih_23_14 wp_ih_23_14 0 0.6509008319673617
Vwn_ih_23_14 wn_ih_23_14 0 0.34909916803263824
Vwp_ih_24_14 wp_ih_24_14 0 0.5024820966403455
Vwn_ih_24_14 wn_ih_24_14 0 0.4975179033596545
Vwp_ih_25_14 wp_ih_25_14 0 0.4525760921486738
Vwn_ih_25_14 wn_ih_25_14 0 0.5474239078513262
Vwp_ih_26_14 wp_ih_26_14 0 0.6040254619214811
Vwn_ih_26_14 wn_ih_26_14 0 0.3959745380785189
Vwp_ih_27_14 wp_ih_27_14 0 0.5334712777521345
Vwn_ih_27_14 wn_ih_27_14 0 0.46652872224786546
Vwp_ih_28_14 wp_ih_28_14 0 0.45781274973317204
Vwn_ih_28_14 wn_ih_28_14 0 0.542187250266828
Vwp_ih_29_14 wp_ih_29_14 0 0.5417057928005022
Vwn_ih_29_14 wn_ih_29_14 0 0.45829420719949776
Vwp_ih_30_14 wp_ih_30_14 0 0.619366597006264
Vwn_ih_30_14 wn_ih_30_14 0 0.38063340299373605
Vwp_ih_31_14 wp_ih_31_14 0 0.5951017068421787
Vwn_ih_31_14 wn_ih_31_14 0 0.40489829315782133
Vwp_ih_32_14 wp_ih_32_14 0 0.4003805378858761
Vwn_ih_32_14 wn_ih_32_14 0 0.5996194621141239
Vwp_ih_33_14 wp_ih_33_14 0 0.4844574913058606
Vwn_ih_33_14 wn_ih_33_14 0 0.5155425086941394
Vwp_ih_34_14 wp_ih_34_14 0 0.6031588387922376
Vwn_ih_34_14 wn_ih_34_14 0 0.39684116120776236
Vwp_ih_35_14 wp_ih_35_14 0 0.5094477073472665
Vwn_ih_35_14 wn_ih_35_14 0 0.49055229265273353
Vwp_ih_36_14 wp_ih_36_14 0 0.47892759537780466
Vwn_ih_36_14 wn_ih_36_14 0 0.5210724046221953
Vwp_ih_37_14 wp_ih_37_14 0 0.616166763712783
Vwn_ih_37_14 wn_ih_37_14 0 0.38383323628721705
Vwp_ih_38_14 wp_ih_38_14 0 0.603259337228585
Vwn_ih_38_14 wn_ih_38_14 0 0.39674066277141495
Vwp_ih_39_14 wp_ih_39_14 0 0.42277576468398953
Vwn_ih_39_14 wn_ih_39_14 0 0.5772242353160105
Vwp_ih_40_14 wp_ih_40_14 0 0.42562111400449054
Vwn_ih_40_14 wn_ih_40_14 0 0.5743788859955095
Vwp_ih_41_14 wp_ih_41_14 0 0.4532026769919097
Vwn_ih_41_14 wn_ih_41_14 0 0.5467973230080904
Vwp_ih_42_14 wp_ih_42_14 0 0.6047012438432229
Vwn_ih_42_14 wn_ih_42_14 0 0.3952987561567772
Vwp_ih_43_14 wp_ih_43_14 0 0.38042187367412916
Vwn_ih_43_14 wn_ih_43_14 0 0.6195781263258708
Vwp_ih_44_14 wp_ih_44_14 0 0.4584591887326425
Vwn_ih_44_14 wn_ih_44_14 0 0.5415408112673575
Vwp_ih_45_14 wp_ih_45_14 0 0.5510223243086481
Vwn_ih_45_14 wn_ih_45_14 0 0.4489776756913519
Vwp_ih_46_14 wp_ih_46_14 0 0.5939426906087119
Vwn_ih_46_14 wn_ih_46_14 0 0.40605730939128815
Vwp_ih_47_14 wp_ih_47_14 0 0.3759152795736677
Vwn_ih_47_14 wn_ih_47_14 0 0.6240847204263323
Vwp_ih_48_14 wp_ih_48_14 0 0.5105820277631606
Vwn_ih_48_14 wn_ih_48_14 0 0.4894179722368393
Vwp_ih_49_14 wp_ih_49_14 0 0.6463254069389062
Vwn_ih_49_14 wn_ih_49_14 0 0.35367459306109383
Vwp_ih_50_14 wp_ih_50_14 0 0.5701932586465981
Vwn_ih_50_14 wn_ih_50_14 0 0.4298067413534019
Vwp_ih_51_14 wp_ih_51_14 0 0.5226258181656451
Vwn_ih_51_14 wn_ih_51_14 0 0.4773741818343548
Vwp_ih_52_14 wp_ih_52_14 0 0.4012421354668305
Vwn_ih_52_14 wn_ih_52_14 0 0.5987578645331695
Vwp_ih_53_14 wp_ih_53_14 0 0.6449389119338798
Vwn_ih_53_14 wn_ih_53_14 0 0.35506108806612025
Vwp_ih_54_14 wp_ih_54_14 0 0.3659990436941231
Vwn_ih_54_14 wn_ih_54_14 0 0.6340009563058768
Vwp_ih_55_14 wp_ih_55_14 0 0.6056967999133098
Vwn_ih_55_14 wn_ih_55_14 0 0.3943032000866902
Vwp_ih_56_14 wp_ih_56_14 0 0.5543413310923152
Vwn_ih_56_14 wn_ih_56_14 0 0.4456586689076848
Vwp_ih_57_14 wp_ih_57_14 0 0.5157412332019893
Vwn_ih_57_14 wn_ih_57_14 0 0.48425876679801066
Vwp_ih_58_14 wp_ih_58_14 0 0.5075190322146119
Vwn_ih_58_14 wn_ih_58_14 0 0.4924809677853881
Vwp_ih_59_14 wp_ih_59_14 0 0.49325751998190764
Vwn_ih_59_14 wn_ih_59_14 0 0.5067424800180923
Vwp_ih_60_14 wp_ih_60_14 0 0.5474940380163559
Vwn_ih_60_14 wn_ih_60_14 0 0.4525059619836441
Vwp_ih_61_14 wp_ih_61_14 0 0.3562051974700552
Vwn_ih_61_14 wn_ih_61_14 0 0.6437948025299448
Vwp_ih_62_14 wp_ih_62_14 0 0.394733088748311
Vwn_ih_62_14 wn_ih_62_14 0 0.6052669112516891
Vwp_ih_63_14 wp_ih_63_14 0 0.5378503369693342
Vwn_ih_63_14 wn_ih_63_14 0 0.46214966303066585
Vwp_ho_14_0 wp_ho_14_0 0 0.6173097182318686
Vwn_ho_14_0 wn_ho_14_0 0 0.38269028176813136
Vwp_ho_14_1 wp_ho_14_1 0 0.5535314187439477
Vwn_ho_14_1 wn_ho_14_1 0 0.4464685812560522
Vwp_ho_14_2 wp_ho_14_2 0 0.4610196771370289
Vwn_ho_14_2 wn_ho_14_2 0 0.538980322862971
Vwp_ho_14_3 wp_ho_14_3 0 0.4625432097105536
Vwn_ho_14_3 wn_ho_14_3 0 0.5374567902894464
Vwp_ho_14_4 wp_ho_14_4 0 0.5932973610159589
Vwn_ho_14_4 wn_ho_14_4 0 0.40670263898404113
Vwp_ih_0_15 wp_ih_0_15 0 0.5046935712514021
Vwn_ih_0_15 wn_ih_0_15 0 0.4953064287485979
Vwp_ih_1_15 wp_ih_1_15 0 0.5136370807939391
Vwn_ih_1_15 wn_ih_1_15 0 0.4863629192060609
Vwp_ih_2_15 wp_ih_2_15 0 0.6351923163664778
Vwn_ih_2_15 wn_ih_2_15 0 0.36480768363352223
Vwp_ih_3_15 wp_ih_3_15 0 0.4541573022678317
Vwn_ih_3_15 wn_ih_3_15 0 0.5458426977321683
Vwp_ih_4_15 wp_ih_4_15 0 0.5732927181003934
Vwn_ih_4_15 wn_ih_4_15 0 0.4267072818996066
Vwp_ih_5_15 wp_ih_5_15 0 0.5279611028915737
Vwn_ih_5_15 wn_ih_5_15 0 0.4720388971084262
Vwp_ih_6_15 wp_ih_6_15 0 0.6791870649061661
Vwn_ih_6_15 wn_ih_6_15 0 0.3208129350938339
Vwp_ih_7_15 wp_ih_7_15 0 0.3614193293002209
Vwn_ih_7_15 wn_ih_7_15 0 0.6385806706997791
Vwp_ih_8_15 wp_ih_8_15 0 0.4491294032972287
Vwn_ih_8_15 wn_ih_8_15 0 0.5508705967027713
Vwp_ih_9_15 wp_ih_9_15 0 0.4617108113304493
Vwn_ih_9_15 wn_ih_9_15 0 0.5382891886695508
Vwp_ih_10_15 wp_ih_10_15 0 0.6039844846629382
Vwn_ih_10_15 wn_ih_10_15 0 0.3960155153370618
Vwp_ih_11_15 wp_ih_11_15 0 0.4356708281107502
Vwn_ih_11_15 wn_ih_11_15 0 0.5643291718892498
Vwp_ih_12_15 wp_ih_12_15 0 0.6545004499682596
Vwn_ih_12_15 wn_ih_12_15 0 0.3454995500317403
Vwp_ih_13_15 wp_ih_13_15 0 0.6527043940729399
Vwn_ih_13_15 wn_ih_13_15 0 0.3472956059270601
Vwp_ih_14_15 wp_ih_14_15 0 0.5741764670438398
Vwn_ih_14_15 wn_ih_14_15 0 0.4258235329561601
Vwp_ih_15_15 wp_ih_15_15 0 0.5309005271035555
Vwn_ih_15_15 wn_ih_15_15 0 0.46909947289644455
Vwp_ih_16_15 wp_ih_16_15 0 0.35962610292442765
Vwn_ih_16_15 wn_ih_16_15 0 0.6403738970755724
Vwp_ih_17_15 wp_ih_17_15 0 0.5419544562828801
Vwn_ih_17_15 wn_ih_17_15 0 0.45804554371711986
Vwp_ih_18_15 wp_ih_18_15 0 0.39036538184899566
Vwn_ih_18_15 wn_ih_18_15 0 0.6096346181510043
Vwp_ih_19_15 wp_ih_19_15 0 0.47036852969526266
Vwn_ih_19_15 wn_ih_19_15 0 0.5296314703047373
Vwp_ih_20_15 wp_ih_20_15 0 0.542310655870124
Vwn_ih_20_15 wn_ih_20_15 0 0.4576893441298761
Vwp_ih_21_15 wp_ih_21_15 0 0.49178123807325164
Vwn_ih_21_15 wn_ih_21_15 0 0.5082187619267484
Vwp_ih_22_15 wp_ih_22_15 0 0.5774406380412488
Vwn_ih_22_15 wn_ih_22_15 0 0.4225593619587512
Vwp_ih_23_15 wp_ih_23_15 0 0.48398196960871337
Vwn_ih_23_15 wn_ih_23_15 0 0.5160180303912866
Vwp_ih_24_15 wp_ih_24_15 0 0.35732134040751473
Vwn_ih_24_15 wn_ih_24_15 0 0.6426786595924853
Vwp_ih_25_15 wp_ih_25_15 0 0.41795084397011917
Vwn_ih_25_15 wn_ih_25_15 0 0.5820491560298808
Vwp_ih_26_15 wp_ih_26_15 0 0.36852091705469536
Vwn_ih_26_15 wn_ih_26_15 0 0.6314790829453046
Vwp_ih_27_15 wp_ih_27_15 0 0.44699433311364406
Vwn_ih_27_15 wn_ih_27_15 0 0.5530056668863559
Vwp_ih_28_15 wp_ih_28_15 0 0.6224292939565353
Vwn_ih_28_15 wn_ih_28_15 0 0.37757070604346465
Vwp_ih_29_15 wp_ih_29_15 0 0.5472205109891171
Vwn_ih_29_15 wn_ih_29_15 0 0.45277948901088294
Vwp_ih_30_15 wp_ih_30_15 0 0.5209134440048367
Vwn_ih_30_15 wn_ih_30_15 0 0.47908655599516325
Vwp_ih_31_15 wp_ih_31_15 0 0.38445434791587463
Vwn_ih_31_15 wn_ih_31_15 0 0.6155456520841254
Vwp_ih_32_15 wp_ih_32_15 0 0.7132247467691177
Vwn_ih_32_15 wn_ih_32_15 0 0.3
Vwp_ih_33_15 wp_ih_33_15 0 0.5085467738133046
Vwn_ih_33_15 wn_ih_33_15 0 0.49145322618669546
Vwp_ih_34_15 wp_ih_34_15 0 0.713510097619469
Vwn_ih_34_15 wn_ih_34_15 0 0.3
Vwp_ih_35_15 wp_ih_35_15 0 0.4154836366853809
Vwn_ih_35_15 wn_ih_35_15 0 0.5845163633146191
Vwp_ih_36_15 wp_ih_36_15 0 0.44769886992599756
Vwn_ih_36_15 wn_ih_36_15 0 0.5523011300740024
Vwp_ih_37_15 wp_ih_37_15 0 0.7210272725840192
Vwn_ih_37_15 wn_ih_37_15 0 0.3
Vwp_ih_38_15 wp_ih_38_15 0 0.4351874471374697
Vwn_ih_38_15 wn_ih_38_15 0 0.5648125528625303
Vwp_ih_39_15 wp_ih_39_15 0 0.5376835238622691
Vwn_ih_39_15 wn_ih_39_15 0 0.46231647613773086
Vwp_ih_40_15 wp_ih_40_15 0 0.45208963902071225
Vwn_ih_40_15 wn_ih_40_15 0 0.5479103609792878
Vwp_ih_41_15 wp_ih_41_15 0 0.41452404314451885
Vwn_ih_41_15 wn_ih_41_15 0 0.5854759568554811
Vwp_ih_42_15 wp_ih_42_15 0 0.7079934994571229
Vwn_ih_42_15 wn_ih_42_15 0 0.3
Vwp_ih_43_15 wp_ih_43_15 0 0.40513723796624634
Vwn_ih_43_15 wn_ih_43_15 0 0.5948627620337537
Vwp_ih_44_15 wp_ih_44_15 0 0.601113567243637
Vwn_ih_44_15 wn_ih_44_15 0 0.39888643275636304
Vwp_ih_45_15 wp_ih_45_15 0 0.5659889997550017
Vwn_ih_45_15 wn_ih_45_15 0 0.4340110002449983
Vwp_ih_46_15 wp_ih_46_15 0 0.4325886589561702
Vwn_ih_46_15 wn_ih_46_15 0 0.5674113410438298
Vwp_ih_47_15 wp_ih_47_15 0 0.3204596372692573
Vwn_ih_47_15 wn_ih_47_15 0 0.6795403627307427
Vwp_ih_48_15 wp_ih_48_15 0 0.33652911281255016
Vwn_ih_48_15 wn_ih_48_15 0 0.6634708871874498
Vwp_ih_49_15 wp_ih_49_15 0 0.3987044699577542
Vwn_ih_49_15 wn_ih_49_15 0 0.6012955300422458
Vwp_ih_50_15 wp_ih_50_15 0 0.5281352522804867
Vwn_ih_50_15 wn_ih_50_15 0 0.4718647477195133
Vwp_ih_51_15 wp_ih_51_15 0 0.5499621781763436
Vwn_ih_51_15 wn_ih_51_15 0 0.4500378218236564
Vwp_ih_52_15 wp_ih_52_15 0 0.5118540547541622
Vwn_ih_52_15 wn_ih_52_15 0 0.48814594524583776
Vwp_ih_53_15 wp_ih_53_15 0 0.47367869395657947
Vwn_ih_53_15 wn_ih_53_15 0 0.5263213060434205
Vwp_ih_54_15 wp_ih_54_15 0 0.6030125654960804
Vwn_ih_54_15 wn_ih_54_15 0 0.3969874345039196
Vwp_ih_55_15 wp_ih_55_15 0 0.5723608112649752
Vwn_ih_55_15 wn_ih_55_15 0 0.4276391887350249
Vwp_ih_56_15 wp_ih_56_15 0 0.5317506815145614
Vwn_ih_56_15 wn_ih_56_15 0 0.4682493184854386
Vwp_ih_57_15 wp_ih_57_15 0 0.4568563077089729
Vwn_ih_57_15 wn_ih_57_15 0 0.5431436922910271
Vwp_ih_58_15 wp_ih_58_15 0 0.5610377951662672
Vwn_ih_58_15 wn_ih_58_15 0 0.4389622048337328
Vwp_ih_59_15 wp_ih_59_15 0 0.5158687296251988
Vwn_ih_59_15 wn_ih_59_15 0 0.48413127037480114
Vwp_ih_60_15 wp_ih_60_15 0 0.4283404141253032
Vwn_ih_60_15 wn_ih_60_15 0 0.5716595858746968
Vwp_ih_61_15 wp_ih_61_15 0 0.4560819542269767
Vwn_ih_61_15 wn_ih_61_15 0 0.5439180457730233
Vwp_ih_62_15 wp_ih_62_15 0 0.6046761158856284
Vwn_ih_62_15 wn_ih_62_15 0 0.3953238841143715
Vwp_ih_63_15 wp_ih_63_15 0 0.6620707699395637
Vwn_ih_63_15 wn_ih_63_15 0 0.3379292300604363
Vwp_ho_15_0 wp_ho_15_0 0 0.530001294594362
Vwn_ho_15_0 wn_ho_15_0 0 0.4699987054056381
Vwp_ho_15_1 wp_ho_15_1 0 0.5905027908258302
Vwn_ho_15_1 wn_ho_15_1 0 0.40949720917416976
Vwp_ho_15_2 wp_ho_15_2 0 0.3956483366979641
Vwn_ho_15_2 wn_ho_15_2 0 0.6043516633020358
Vwp_ho_15_3 wp_ho_15_3 0 0.5751914150844462
Vwn_ho_15_3 wn_ho_15_3 0 0.4248085849155538
Vwp_ho_15_4 wp_ho_15_4 0 0.48279970043425247
Vwn_ho_15_4 wn_ho_15_4 0 0.5172002995657475
Vwp_ih_0_16 wp_ih_0_16 0 0.4523245940812576
Vwn_ih_0_16 wn_ih_0_16 0 0.5476754059187424
Vwp_ih_1_16 wp_ih_1_16 0 0.3220427253023558
Vwn_ih_1_16 wn_ih_1_16 0 0.6779572746976442
Vwp_ih_2_16 wp_ih_2_16 0 0.5624931523490578
Vwn_ih_2_16 wn_ih_2_16 0 0.43750684765094217
Vwp_ih_3_16 wp_ih_3_16 0 0.43069872184036406
Vwn_ih_3_16 wn_ih_3_16 0 0.5693012781596359
Vwp_ih_4_16 wp_ih_4_16 0 0.5799695792843665
Vwn_ih_4_16 wn_ih_4_16 0 0.42003042071563346
Vwp_ih_5_16 wp_ih_5_16 0 0.45634983248305594
Vwn_ih_5_16 wn_ih_5_16 0 0.5436501675169441
Vwp_ih_6_16 wp_ih_6_16 0 0.6835201205110575
Vwn_ih_6_16 wn_ih_6_16 0 0.3164798794889425
Vwp_ih_7_16 wp_ih_7_16 0 0.49650386730033985
Vwn_ih_7_16 wn_ih_7_16 0 0.5034961326996601
Vwp_ih_8_16 wp_ih_8_16 0 0.5708396672765212
Vwn_ih_8_16 wn_ih_8_16 0 0.4291603327234788
Vwp_ih_9_16 wp_ih_9_16 0 0.38713133948890976
Vwn_ih_9_16 wn_ih_9_16 0 0.6128686605110902
Vwp_ih_10_16 wp_ih_10_16 0 0.3
Vwn_ih_10_16 wn_ih_10_16 0 0.733165215867241
Vwp_ih_11_16 wp_ih_11_16 0 0.5045755159393689
Vwn_ih_11_16 wn_ih_11_16 0 0.49542448406063105
Vwp_ih_12_16 wp_ih_12_16 0 0.528803779340278
Vwn_ih_12_16 wn_ih_12_16 0 0.47119622065972205
Vwp_ih_13_16 wp_ih_13_16 0 0.5494449255822655
Vwn_ih_13_16 wn_ih_13_16 0 0.45055507441773446
Vwp_ih_14_16 wp_ih_14_16 0 0.45631693863394834
Vwn_ih_14_16 wn_ih_14_16 0 0.5436830613660516
Vwp_ih_15_16 wp_ih_15_16 0 0.3776228379446069
Vwn_ih_15_16 wn_ih_15_16 0 0.6223771620553931
Vwp_ih_16_16 wp_ih_16_16 0 0.3471293154206274
Vwn_ih_16_16 wn_ih_16_16 0 0.6528706845793726
Vwp_ih_17_16 wp_ih_17_16 0 0.5447502660853518
Vwn_ih_17_16 wn_ih_17_16 0 0.4552497339146481
Vwp_ih_18_16 wp_ih_18_16 0 0.5590086359715574
Vwn_ih_18_16 wn_ih_18_16 0 0.44099136402844263
Vwp_ih_19_16 wp_ih_19_16 0 0.39646964894884584
Vwn_ih_19_16 wn_ih_19_16 0 0.6035303510511542
Vwp_ih_20_16 wp_ih_20_16 0 0.4714225516595935
Vwn_ih_20_16 wn_ih_20_16 0 0.5285774483404065
Vwp_ih_21_16 wp_ih_21_16 0 0.43176076773001637
Vwn_ih_21_16 wn_ih_21_16 0 0.5682392322699836
Vwp_ih_22_16 wp_ih_22_16 0 0.328507364718369
Vwn_ih_22_16 wn_ih_22_16 0 0.6714926352816311
Vwp_ih_23_16 wp_ih_23_16 0 0.5127810644654551
Vwn_ih_23_16 wn_ih_23_16 0 0.4872189355345449
Vwp_ih_24_16 wp_ih_24_16 0 0.5725110046257715
Vwn_ih_24_16 wn_ih_24_16 0 0.4274889953742284
Vwp_ih_25_16 wp_ih_25_16 0 0.49518222599038086
Vwn_ih_25_16 wn_ih_25_16 0 0.5048177740096191
Vwp_ih_26_16 wp_ih_26_16 0 0.34687952915374826
Vwn_ih_26_16 wn_ih_26_16 0 0.6531204708462517
Vwp_ih_27_16 wp_ih_27_16 0 0.45057908431840066
Vwn_ih_27_16 wn_ih_27_16 0 0.5494209156815993
Vwp_ih_28_16 wp_ih_28_16 0 0.6156854411560275
Vwn_ih_28_16 wn_ih_28_16 0 0.3843145588439725
Vwp_ih_29_16 wp_ih_29_16 0 0.6894548730055029
Vwn_ih_29_16 wn_ih_29_16 0 0.3105451269944971
Vwp_ih_30_16 wp_ih_30_16 0 0.5274941430740155
Vwn_ih_30_16 wn_ih_30_16 0 0.4725058569259844
Vwp_ih_31_16 wp_ih_31_16 0 0.4312398901456471
Vwn_ih_31_16 wn_ih_31_16 0 0.5687601098543529
Vwp_ih_32_16 wp_ih_32_16 0 0.32129820856064195
Vwn_ih_32_16 wn_ih_32_16 0 0.678701791439358
Vwp_ih_33_16 wp_ih_33_16 0 0.3684946791451665
Vwn_ih_33_16 wn_ih_33_16 0 0.6315053208548336
Vwp_ih_34_16 wp_ih_34_16 0 0.47749311865377436
Vwn_ih_34_16 wn_ih_34_16 0 0.5225068813462256
Vwp_ih_35_16 wp_ih_35_16 0 0.5109899607514293
Vwn_ih_35_16 wn_ih_35_16 0 0.48901003924857067
Vwp_ih_36_16 wp_ih_36_16 0 0.5114400043103757
Vwn_ih_36_16 wn_ih_36_16 0 0.48855999568962427
Vwp_ih_37_16 wp_ih_37_16 0 0.474524992585926
Vwn_ih_37_16 wn_ih_37_16 0 0.5254750074140739
Vwp_ih_38_16 wp_ih_38_16 0 0.3845170246839192
Vwn_ih_38_16 wn_ih_38_16 0 0.6154829753160809
Vwp_ih_39_16 wp_ih_39_16 0 0.3581189663243478
Vwn_ih_39_16 wn_ih_39_16 0 0.6418810336756522
Vwp_ih_40_16 wp_ih_40_16 0 0.5082553837537185
Vwn_ih_40_16 wn_ih_40_16 0 0.4917446162462816
Vwp_ih_41_16 wp_ih_41_16 0 0.4133126189001528
Vwn_ih_41_16 wn_ih_41_16 0 0.5866873810998472
Vwp_ih_42_16 wp_ih_42_16 0 0.6318301417585537
Vwn_ih_42_16 wn_ih_42_16 0 0.36816985824144627
Vwp_ih_43_16 wp_ih_43_16 0 0.36589695279866297
Vwn_ih_43_16 wn_ih_43_16 0 0.634103047201337
Vwp_ih_44_16 wp_ih_44_16 0 0.6283142564611326
Vwn_ih_44_16 wn_ih_44_16 0 0.37168574353886735
Vwp_ih_45_16 wp_ih_45_16 0 0.4390037782278002
Vwn_ih_45_16 wn_ih_45_16 0 0.5609962217721999
Vwp_ih_46_16 wp_ih_46_16 0 0.537091454221795
Vwn_ih_46_16 wn_ih_46_16 0 0.4629085457782049
Vwp_ih_47_16 wp_ih_47_16 0 0.5104325996061234
Vwn_ih_47_16 wn_ih_47_16 0 0.48956740039387664
Vwp_ih_48_16 wp_ih_48_16 0 0.46459273530075523
Vwn_ih_48_16 wn_ih_48_16 0 0.5354072646992447
Vwp_ih_49_16 wp_ih_49_16 0 0.32064880972885723
Vwn_ih_49_16 wn_ih_49_16 0 0.6793511902711428
Vwp_ih_50_16 wp_ih_50_16 0 0.4648440647480762
Vwn_ih_50_16 wn_ih_50_16 0 0.5351559352519238
Vwp_ih_51_16 wp_ih_51_16 0 0.638665646797061
Vwn_ih_51_16 wn_ih_51_16 0 0.36133435320293905
Vwp_ih_52_16 wp_ih_52_16 0 0.40556567069874166
Vwn_ih_52_16 wn_ih_52_16 0 0.5944343293012584
Vwp_ih_53_16 wp_ih_53_16 0 0.34697155013757397
Vwn_ih_53_16 wn_ih_53_16 0 0.653028449862426
Vwp_ih_54_16 wp_ih_54_16 0 0.4563507036600982
Vwn_ih_54_16 wn_ih_54_16 0 0.5436492963399018
Vwp_ih_55_16 wp_ih_55_16 0 0.4417212152100215
Vwn_ih_55_16 wn_ih_55_16 0 0.5582787847899785
Vwp_ih_56_16 wp_ih_56_16 0 0.3810778755061423
Vwn_ih_56_16 wn_ih_56_16 0 0.6189221244938578
Vwp_ih_57_16 wp_ih_57_16 0 0.4484418855691321
Vwn_ih_57_16 wn_ih_57_16 0 0.5515581144308679
Vwp_ih_58_16 wp_ih_58_16 0 0.46363486272446947
Vwn_ih_58_16 wn_ih_58_16 0 0.5363651372755305
Vwp_ih_59_16 wp_ih_59_16 0 0.4769070657535084
Vwn_ih_59_16 wn_ih_59_16 0 0.5230929342464916
Vwp_ih_60_16 wp_ih_60_16 0 0.5249760695654329
Vwn_ih_60_16 wn_ih_60_16 0 0.47502393043456714
Vwp_ih_61_16 wp_ih_61_16 0 0.5431973070510062
Vwn_ih_61_16 wn_ih_61_16 0 0.4568026929489938
Vwp_ih_62_16 wp_ih_62_16 0 0.5174658823964451
Vwn_ih_62_16 wn_ih_62_16 0 0.48253411760355497
Vwp_ih_63_16 wp_ih_63_16 0 0.5192221706308309
Vwn_ih_63_16 wn_ih_63_16 0 0.4807778293691691
Vwp_ho_16_0 wp_ho_16_0 0 0.4011094087323587
Vwn_ho_16_0 wn_ho_16_0 0 0.5988905912676413
Vwp_ho_16_1 wp_ho_16_1 0 0.40890987627710496
Vwn_ho_16_1 wn_ho_16_1 0 0.591090123722895
Vwp_ho_16_2 wp_ho_16_2 0 0.613550278707632
Vwn_ho_16_2 wn_ho_16_2 0 0.386449721292368
Vwp_ho_16_3 wp_ho_16_3 0 0.513313889984719
Vwn_ho_16_3 wn_ho_16_3 0 0.48668611001528095
Vwp_ho_16_4 wp_ho_16_4 0 0.5294902805211185
Vwn_ho_16_4 wn_ho_16_4 0 0.47050971947888154
Vwp_ih_0_17 wp_ih_0_17 0 0.6512128659976909
Vwn_ih_0_17 wn_ih_0_17 0 0.3487871340023091
Vwp_ih_1_17 wp_ih_1_17 0 0.6079408432267847
Vwn_ih_1_17 wn_ih_1_17 0 0.39205915677321534
Vwp_ih_2_17 wp_ih_2_17 0 0.3
Vwn_ih_2_17 wn_ih_2_17 0 0.7348790607403192
Vwp_ih_3_17 wp_ih_3_17 0 0.4336160529117292
Vwn_ih_3_17 wn_ih_3_17 0 0.5663839470882708
Vwp_ih_4_17 wp_ih_4_17 0 0.36965144423241203
Vwn_ih_4_17 wn_ih_4_17 0 0.630348555767588
Vwp_ih_5_17 wp_ih_5_17 0 0.4535005602986549
Vwn_ih_5_17 wn_ih_5_17 0 0.5464994397013452
Vwp_ih_6_17 wp_ih_6_17 0 0.5986365111545109
Vwn_ih_6_17 wn_ih_6_17 0 0.40136348884548917
Vwp_ih_7_17 wp_ih_7_17 0 0.49849534966962794
Vwn_ih_7_17 wn_ih_7_17 0 0.5015046503303721
Vwp_ih_8_17 wp_ih_8_17 0 0.4779591770872241
Vwn_ih_8_17 wn_ih_8_17 0 0.5220408229127759
Vwp_ih_9_17 wp_ih_9_17 0 0.6023433662817992
Vwn_ih_9_17 wn_ih_9_17 0 0.39765663371820076
Vwp_ih_10_17 wp_ih_10_17 0 0.444680657133377
Vwn_ih_10_17 wn_ih_10_17 0 0.555319342866623
Vwp_ih_11_17 wp_ih_11_17 0 0.49560440068977735
Vwn_ih_11_17 wn_ih_11_17 0 0.5043955993102227
Vwp_ih_12_17 wp_ih_12_17 0 0.5463296076094641
Vwn_ih_12_17 wn_ih_12_17 0 0.45367039239053586
Vwp_ih_13_17 wp_ih_13_17 0 0.47007591054342135
Vwn_ih_13_17 wn_ih_13_17 0 0.5299240894565787
Vwp_ih_14_17 wp_ih_14_17 0 0.43415450695513474
Vwn_ih_14_17 wn_ih_14_17 0 0.5658454930448653
Vwp_ih_15_17 wp_ih_15_17 0 0.5053590138454619
Vwn_ih_15_17 wn_ih_15_17 0 0.49464098615453816
Vwp_ih_16_17 wp_ih_16_17 0 0.5872301544737327
Vwn_ih_16_17 wn_ih_16_17 0 0.4127698455262673
Vwp_ih_17_17 wp_ih_17_17 0 0.5077668082700338
Vwn_ih_17_17 wn_ih_17_17 0 0.49223319172996616
Vwp_ih_18_17 wp_ih_18_17 0 0.510040818599153
Vwn_ih_18_17 wn_ih_18_17 0 0.48995918140084704
Vwp_ih_19_17 wp_ih_19_17 0 0.47837058880047095
Vwn_ih_19_17 wn_ih_19_17 0 0.5216294111995291
Vwp_ih_20_17 wp_ih_20_17 0 0.40596655355433064
Vwn_ih_20_17 wn_ih_20_17 0 0.5940334464456694
Vwp_ih_21_17 wp_ih_21_17 0 0.3951895426634822
Vwn_ih_21_17 wn_ih_21_17 0 0.6048104573365178
Vwp_ih_22_17 wp_ih_22_17 0 0.5018821592758564
Vwn_ih_22_17 wn_ih_22_17 0 0.4981178407241435
Vwp_ih_23_17 wp_ih_23_17 0 0.5443614261326384
Vwn_ih_23_17 wn_ih_23_17 0 0.4556385738673616
Vwp_ih_24_17 wp_ih_24_17 0 0.3
Vwn_ih_24_17 wn_ih_24_17 0 0.7758733811101559
Vwp_ih_25_17 wp_ih_25_17 0 0.5879739528786884
Vwn_ih_25_17 wn_ih_25_17 0 0.41202604712131163
Vwp_ih_26_17 wp_ih_26_17 0 0.5338842317277861
Vwn_ih_26_17 wn_ih_26_17 0 0.46611576827221396
Vwp_ih_27_17 wp_ih_27_17 0 0.40411781595769836
Vwn_ih_27_17 wn_ih_27_17 0 0.5958821840423016
Vwp_ih_28_17 wp_ih_28_17 0 0.3708283075092611
Vwn_ih_28_17 wn_ih_28_17 0 0.6291716924907389
Vwp_ih_29_17 wp_ih_29_17 0 0.522231826362098
Vwn_ih_29_17 wn_ih_29_17 0 0.477768173637902
Vwp_ih_30_17 wp_ih_30_17 0 0.5646538236161656
Vwn_ih_30_17 wn_ih_30_17 0 0.43534617638383444
Vwp_ih_31_17 wp_ih_31_17 0 0.464444472485561
Vwn_ih_31_17 wn_ih_31_17 0 0.535555527514439
Vwp_ih_32_17 wp_ih_32_17 0 0.6050302797167156
Vwn_ih_32_17 wn_ih_32_17 0 0.3949697202832844
Vwp_ih_33_17 wp_ih_33_17 0 0.5543951619583171
Vwn_ih_33_17 wn_ih_33_17 0 0.445604838041683
Vwp_ih_34_17 wp_ih_34_17 0 0.4449517066525015
Vwn_ih_34_17 wn_ih_34_17 0 0.5550482933474985
Vwp_ih_35_17 wp_ih_35_17 0 0.49383350988827396
Vwn_ih_35_17 wn_ih_35_17 0 0.506166490111726
Vwp_ih_36_17 wp_ih_36_17 0 0.49296474691822617
Vwn_ih_36_17 wn_ih_36_17 0 0.5070352530817739
Vwp_ih_37_17 wp_ih_37_17 0 0.6328511098964456
Vwn_ih_37_17 wn_ih_37_17 0 0.3671488901035545
Vwp_ih_38_17 wp_ih_38_17 0 0.6056569618759844
Vwn_ih_38_17 wn_ih_38_17 0 0.39434303812401567
Vwp_ih_39_17 wp_ih_39_17 0 0.49121656234960337
Vwn_ih_39_17 wn_ih_39_17 0 0.5087834376503966
Vwp_ih_40_17 wp_ih_40_17 0 0.5285335060693546
Vwn_ih_40_17 wn_ih_40_17 0 0.47146649393064544
Vwp_ih_41_17 wp_ih_41_17 0 0.4997914291661434
Vwn_ih_41_17 wn_ih_41_17 0 0.5002085708338566
Vwp_ih_42_17 wp_ih_42_17 0 0.5567648605366685
Vwn_ih_42_17 wn_ih_42_17 0 0.4432351394633315
Vwp_ih_43_17 wp_ih_43_17 0 0.36677904715814297
Vwn_ih_43_17 wn_ih_43_17 0 0.6332209528418571
Vwp_ih_44_17 wp_ih_44_17 0 0.5018541854437741
Vwn_ih_44_17 wn_ih_44_17 0 0.4981458145562259
Vwp_ih_45_17 wp_ih_45_17 0 0.3905025561729665
Vwn_ih_45_17 wn_ih_45_17 0 0.6094974438270335
Vwp_ih_46_17 wp_ih_46_17 0 0.5795949178405714
Vwn_ih_46_17 wn_ih_46_17 0 0.4204050821594286
Vwp_ih_47_17 wp_ih_47_17 0 0.534843343569348
Vwn_ih_47_17 wn_ih_47_17 0 0.4651566564306519
Vwp_ih_48_17 wp_ih_48_17 0 0.5021532332753611
Vwn_ih_48_17 wn_ih_48_17 0 0.49784676672463896
Vwp_ih_49_17 wp_ih_49_17 0 0.3447155446832898
Vwn_ih_49_17 wn_ih_49_17 0 0.6552844553167102
Vwp_ih_50_17 wp_ih_50_17 0 0.648881143969043
Vwn_ih_50_17 wn_ih_50_17 0 0.35111885603095705
Vwp_ih_51_17 wp_ih_51_17 0 0.5865051937224478
Vwn_ih_51_17 wn_ih_51_17 0 0.4134948062775522
Vwp_ih_52_17 wp_ih_52_17 0 0.4807209718996174
Vwn_ih_52_17 wn_ih_52_17 0 0.5192790281003826
Vwp_ih_53_17 wp_ih_53_17 0 0.5319502196498181
Vwn_ih_53_17 wn_ih_53_17 0 0.46804978035018185
Vwp_ih_54_17 wp_ih_54_17 0 0.4041522308423241
Vwn_ih_54_17 wn_ih_54_17 0 0.5958477691576759
Vwp_ih_55_17 wp_ih_55_17 0 0.5525294270914831
Vwn_ih_55_17 wn_ih_55_17 0 0.44747057290851683
Vwp_ih_56_17 wp_ih_56_17 0 0.6435411450942294
Vwn_ih_56_17 wn_ih_56_17 0 0.35645885490577056
Vwp_ih_57_17 wp_ih_57_17 0 0.40630031549389817
Vwn_ih_57_17 wn_ih_57_17 0 0.5936996845061018
Vwp_ih_58_17 wp_ih_58_17 0 0.7551770633347015
Vwn_ih_58_17 wn_ih_58_17 0 0.3
Vwp_ih_59_17 wp_ih_59_17 0 0.4425154701997773
Vwn_ih_59_17 wn_ih_59_17 0 0.5574845298002227
Vwp_ih_60_17 wp_ih_60_17 0 0.5424757411487588
Vwn_ih_60_17 wn_ih_60_17 0 0.45752425885124115
Vwp_ih_61_17 wp_ih_61_17 0 0.4078176705646036
Vwn_ih_61_17 wn_ih_61_17 0 0.5921823294353964
Vwp_ih_62_17 wp_ih_62_17 0 0.5490119613257701
Vwn_ih_62_17 wn_ih_62_17 0 0.4509880386742299
Vwp_ih_63_17 wp_ih_63_17 0 0.39418869438262805
Vwn_ih_63_17 wn_ih_63_17 0 0.605811305617372
Vwp_ho_17_0 wp_ho_17_0 0 0.49661400525625726
Vwn_ho_17_0 wn_ho_17_0 0 0.5033859947437428
Vwp_ho_17_1 wp_ho_17_1 0 0.3
Vwn_ho_17_1 wn_ho_17_1 0 0.735522819368251
Vwp_ho_17_2 wp_ho_17_2 0 0.571319715244537
Vwn_ho_17_2 wn_ho_17_2 0 0.42868028475546305
Vwp_ho_17_3 wp_ho_17_3 0 0.7480281454174625
Vwn_ho_17_3 wn_ho_17_3 0 0.3
Vwp_ho_17_4 wp_ho_17_4 0 0.43672162419136684
Vwn_ho_17_4 wn_ho_17_4 0 0.5632783758086332
Vwp_ih_0_18 wp_ih_0_18 0 0.4406905387760682
Vwn_ih_0_18 wn_ih_0_18 0 0.5593094612239318
Vwp_ih_1_18 wp_ih_1_18 0 0.4573831769989582
Vwn_ih_1_18 wn_ih_1_18 0 0.5426168230010419
Vwp_ih_2_18 wp_ih_2_18 0 0.40590282949590756
Vwn_ih_2_18 wn_ih_2_18 0 0.5940971705040925
Vwp_ih_3_18 wp_ih_3_18 0 0.46733011967221605
Vwn_ih_3_18 wn_ih_3_18 0 0.532669880327784
Vwp_ih_4_18 wp_ih_4_18 0 0.5933532015633431
Vwn_ih_4_18 wn_ih_4_18 0 0.40664679843665685
Vwp_ih_5_18 wp_ih_5_18 0 0.41539178076326866
Vwn_ih_5_18 wn_ih_5_18 0 0.5846082192367313
Vwp_ih_6_18 wp_ih_6_18 0 0.40280602317535347
Vwn_ih_6_18 wn_ih_6_18 0 0.5971939768246465
Vwp_ih_7_18 wp_ih_7_18 0 0.5069266177550482
Vwn_ih_7_18 wn_ih_7_18 0 0.49307338224495173
Vwp_ih_8_18 wp_ih_8_18 0 0.44740464988109996
Vwn_ih_8_18 wn_ih_8_18 0 0.5525953501189
Vwp_ih_9_18 wp_ih_9_18 0 0.38938912669509174
Vwn_ih_9_18 wn_ih_9_18 0 0.6106108733049083
Vwp_ih_10_18 wp_ih_10_18 0 0.4659784632746201
Vwn_ih_10_18 wn_ih_10_18 0 0.5340215367253799
Vwp_ih_11_18 wp_ih_11_18 0 0.4311574815451526
Vwn_ih_11_18 wn_ih_11_18 0 0.5688425184548473
Vwp_ih_12_18 wp_ih_12_18 0 0.5327804497034435
Vwn_ih_12_18 wn_ih_12_18 0 0.4672195502965565
Vwp_ih_13_18 wp_ih_13_18 0 0.5622903397104387
Vwn_ih_13_18 wn_ih_13_18 0 0.43770966028956126
Vwp_ih_14_18 wp_ih_14_18 0 0.4647998807629775
Vwn_ih_14_18 wn_ih_14_18 0 0.5352001192370225
Vwp_ih_15_18 wp_ih_15_18 0 0.4994858594017033
Vwn_ih_15_18 wn_ih_15_18 0 0.5005141405982967
Vwp_ih_16_18 wp_ih_16_18 0 0.5899768450821661
Vwn_ih_16_18 wn_ih_16_18 0 0.41002315491783387
Vwp_ih_17_18 wp_ih_17_18 0 0.6128677263267174
Vwn_ih_17_18 wn_ih_17_18 0 0.3871322736732826
Vwp_ih_18_18 wp_ih_18_18 0 0.5341418456345015
Vwn_ih_18_18 wn_ih_18_18 0 0.4658581543654985
Vwp_ih_19_18 wp_ih_19_18 0 0.40529704053329463
Vwn_ih_19_18 wn_ih_19_18 0 0.5947029594667054
Vwp_ih_20_18 wp_ih_20_18 0 0.42419268539436594
Vwn_ih_20_18 wn_ih_20_18 0 0.5758073146056341
Vwp_ih_21_18 wp_ih_21_18 0 0.33070678235051587
Vwn_ih_21_18 wn_ih_21_18 0 0.6692932176494841
Vwp_ih_22_18 wp_ih_22_18 0 0.35795471959750724
Vwn_ih_22_18 wn_ih_22_18 0 0.6420452804024928
Vwp_ih_23_18 wp_ih_23_18 0 0.42786022003933866
Vwn_ih_23_18 wn_ih_23_18 0 0.5721397799606613
Vwp_ih_24_18 wp_ih_24_18 0 0.49599032277724153
Vwn_ih_24_18 wn_ih_24_18 0 0.5040096772227585
Vwp_ih_25_18 wp_ih_25_18 0 0.353726235461294
Vwn_ih_25_18 wn_ih_25_18 0 0.646273764538706
Vwp_ih_26_18 wp_ih_26_18 0 0.6555070889813961
Vwn_ih_26_18 wn_ih_26_18 0 0.3444929110186039
Vwp_ih_27_18 wp_ih_27_18 0 0.599786717396432
Vwn_ih_27_18 wn_ih_27_18 0 0.400213282603568
Vwp_ih_28_18 wp_ih_28_18 0 0.688999620582937
Vwn_ih_28_18 wn_ih_28_18 0 0.3110003794170631
Vwp_ih_29_18 wp_ih_29_18 0 0.4581317518299708
Vwn_ih_29_18 wn_ih_29_18 0 0.5418682481700292
Vwp_ih_30_18 wp_ih_30_18 0 0.45882196701183087
Vwn_ih_30_18 wn_ih_30_18 0 0.5411780329881691
Vwp_ih_31_18 wp_ih_31_18 0 0.4166829357021631
Vwn_ih_31_18 wn_ih_31_18 0 0.5833170642978369
Vwp_ih_32_18 wp_ih_32_18 0 0.6394828609041303
Vwn_ih_32_18 wn_ih_32_18 0 0.3605171390958697
Vwp_ih_33_18 wp_ih_33_18 0 0.38647225783824435
Vwn_ih_33_18 wn_ih_33_18 0 0.6135277421617557
Vwp_ih_34_18 wp_ih_34_18 0 0.44531587628759733
Vwn_ih_34_18 wn_ih_34_18 0 0.5546841237124027
Vwp_ih_35_18 wp_ih_35_18 0 0.589890216627015
Vwn_ih_35_18 wn_ih_35_18 0 0.41010978337298504
Vwp_ih_36_18 wp_ih_36_18 0 0.7634991681487798
Vwn_ih_36_18 wn_ih_36_18 0 0.3
Vwp_ih_37_18 wp_ih_37_18 0 0.48590210111504184
Vwn_ih_37_18 wn_ih_37_18 0 0.5140978988849582
Vwp_ih_38_18 wp_ih_38_18 0 0.46616150004474427
Vwn_ih_38_18 wn_ih_38_18 0 0.5338384999552558
Vwp_ih_39_18 wp_ih_39_18 0 0.3
Vwn_ih_39_18 wn_ih_39_18 0 0.7256418743282784
Vwp_ih_40_18 wp_ih_40_18 0 0.6262780350233704
Vwn_ih_40_18 wn_ih_40_18 0 0.3737219649766296
Vwp_ih_41_18 wp_ih_41_18 0 0.5188774459973933
Vwn_ih_41_18 wn_ih_41_18 0 0.4811225540026068
Vwp_ih_42_18 wp_ih_42_18 0 0.34771578647602874
Vwn_ih_42_18 wn_ih_42_18 0 0.6522842135239713
Vwp_ih_43_18 wp_ih_43_18 0 0.5579384992142126
Vwn_ih_43_18 wn_ih_43_18 0 0.44206150078578743
Vwp_ih_44_18 wp_ih_44_18 0 0.5903673139535257
Vwn_ih_44_18 wn_ih_44_18 0 0.4096326860464743
Vwp_ih_45_18 wp_ih_45_18 0 0.4706122995897212
Vwn_ih_45_18 wn_ih_45_18 0 0.5293877004102788
Vwp_ih_46_18 wp_ih_46_18 0 0.4570361030252582
Vwn_ih_46_18 wn_ih_46_18 0 0.5429638969747418
Vwp_ih_47_18 wp_ih_47_18 0 0.5676215562739161
Vwn_ih_47_18 wn_ih_47_18 0 0.4323784437260839
Vwp_ih_48_18 wp_ih_48_18 0 0.5213069418636291
Vwn_ih_48_18 wn_ih_48_18 0 0.4786930581363708
Vwp_ih_49_18 wp_ih_49_18 0 0.49971059442587273
Vwn_ih_49_18 wn_ih_49_18 0 0.5002894055741273
Vwp_ih_50_18 wp_ih_50_18 0 0.5935317013840155
Vwn_ih_50_18 wn_ih_50_18 0 0.40646829861598455
Vwp_ih_51_18 wp_ih_51_18 0 0.5554000158001844
Vwn_ih_51_18 wn_ih_51_18 0 0.44459998419981556
Vwp_ih_52_18 wp_ih_52_18 0 0.5599262788417252
Vwn_ih_52_18 wn_ih_52_18 0 0.4400737211582748
Vwp_ih_53_18 wp_ih_53_18 0 0.5693822783139192
Vwn_ih_53_18 wn_ih_53_18 0 0.4306177216860808
Vwp_ih_54_18 wp_ih_54_18 0 0.41823886969545876
Vwn_ih_54_18 wn_ih_54_18 0 0.5817611303045412
Vwp_ih_55_18 wp_ih_55_18 0 0.4422303640273916
Vwn_ih_55_18 wn_ih_55_18 0 0.5577696359726084
Vwp_ih_56_18 wp_ih_56_18 0 0.5741749687546791
Vwn_ih_56_18 wn_ih_56_18 0 0.4258250312453209
Vwp_ih_57_18 wp_ih_57_18 0 0.5282712123687261
Vwn_ih_57_18 wn_ih_57_18 0 0.4717287876312739
Vwp_ih_58_18 wp_ih_58_18 0 0.5108917415584608
Vwn_ih_58_18 wn_ih_58_18 0 0.48910825844153916
Vwp_ih_59_18 wp_ih_59_18 0 0.5560450313339061
Vwn_ih_59_18 wn_ih_59_18 0 0.44395496866609385
Vwp_ih_60_18 wp_ih_60_18 0 0.4587968748731323
Vwn_ih_60_18 wn_ih_60_18 0 0.5412031251268676
Vwp_ih_61_18 wp_ih_61_18 0 0.591212798200584
Vwn_ih_61_18 wn_ih_61_18 0 0.40878720179941597
Vwp_ih_62_18 wp_ih_62_18 0 0.4063605430006554
Vwn_ih_62_18 wn_ih_62_18 0 0.5936394569993446
Vwp_ih_63_18 wp_ih_63_18 0 0.5176597530525985
Vwn_ih_63_18 wn_ih_63_18 0 0.4823402469474015
Vwp_ho_18_0 wp_ho_18_0 0 0.6612332112622915
Vwn_ho_18_0 wn_ho_18_0 0 0.3387667887377085
Vwp_ho_18_1 wp_ho_18_1 0 0.7304225033990741
Vwn_ho_18_1 wn_ho_18_1 0 0.3
Vwp_ho_18_2 wp_ho_18_2 0 0.49310268626251536
Vwn_ho_18_2 wn_ho_18_2 0 0.5068973137374846
Vwp_ho_18_3 wp_ho_18_3 0 0.4246170181294866
Vwn_ho_18_3 wn_ho_18_3 0 0.5753829818705134
Vwp_ho_18_4 wp_ho_18_4 0 0.47615396392030507
Vwn_ho_18_4 wn_ho_18_4 0 0.5238460360796949
Vwp_ih_0_19 wp_ih_0_19 0 0.5836393354934876
Vwn_ih_0_19 wn_ih_0_19 0 0.41636066450651243
Vwp_ih_1_19 wp_ih_1_19 0 0.46129556454121823
Vwn_ih_1_19 wn_ih_1_19 0 0.5387044354587818
Vwp_ih_2_19 wp_ih_2_19 0 0.6999736696342794
Vwn_ih_2_19 wn_ih_2_19 0 0.3000263303657206
Vwp_ih_3_19 wp_ih_3_19 0 0.6076330315297094
Vwn_ih_3_19 wn_ih_3_19 0 0.39236696847029057
Vwp_ih_4_19 wp_ih_4_19 0 0.642723716621734
Vwn_ih_4_19 wn_ih_4_19 0 0.357276283378266
Vwp_ih_5_19 wp_ih_5_19 0 0.4847373075941373
Vwn_ih_5_19 wn_ih_5_19 0 0.5152626924058628
Vwp_ih_6_19 wp_ih_6_19 0 0.3747024182618175
Vwn_ih_6_19 wn_ih_6_19 0 0.6252975817381825
Vwp_ih_7_19 wp_ih_7_19 0 0.43458512304602515
Vwn_ih_7_19 wn_ih_7_19 0 0.5654148769539749
Vwp_ih_8_19 wp_ih_8_19 0 0.5471475379997267
Vwn_ih_8_19 wn_ih_8_19 0 0.45285246200027335
Vwp_ih_9_19 wp_ih_9_19 0 0.4985954988979407
Vwn_ih_9_19 wn_ih_9_19 0 0.5014045011020593
Vwp_ih_10_19 wp_ih_10_19 0 0.5978801890511516
Vwn_ih_10_19 wn_ih_10_19 0 0.4021198109488484
Vwp_ih_11_19 wp_ih_11_19 0 0.4974527570035276
Vwn_ih_11_19 wn_ih_11_19 0 0.5025472429964725
Vwp_ih_12_19 wp_ih_12_19 0 0.46371770027946263
Vwn_ih_12_19 wn_ih_12_19 0 0.5362822997205374
Vwp_ih_13_19 wp_ih_13_19 0 0.5672427436523733
Vwn_ih_13_19 wn_ih_13_19 0 0.4327572563476267
Vwp_ih_14_19 wp_ih_14_19 0 0.6056242963867514
Vwn_ih_14_19 wn_ih_14_19 0 0.39437570361324864
Vwp_ih_15_19 wp_ih_15_19 0 0.4372424948123911
Vwn_ih_15_19 wn_ih_15_19 0 0.5627575051876089
Vwp_ih_16_19 wp_ih_16_19 0 0.5438691749523021
Vwn_ih_16_19 wn_ih_16_19 0 0.45613082504769786
Vwp_ih_17_19 wp_ih_17_19 0 0.4795515461569988
Vwn_ih_17_19 wn_ih_17_19 0 0.5204484538430012
Vwp_ih_18_19 wp_ih_18_19 0 0.5018916317801749
Vwn_ih_18_19 wn_ih_18_19 0 0.49810836821982507
Vwp_ih_19_19 wp_ih_19_19 0 0.4731640504941952
Vwn_ih_19_19 wn_ih_19_19 0 0.5268359495058048
Vwp_ih_20_19 wp_ih_20_19 0 0.408483432026151
Vwn_ih_20_19 wn_ih_20_19 0 0.591516567973849
Vwp_ih_21_19 wp_ih_21_19 0 0.5986602806956416
Vwn_ih_21_19 wn_ih_21_19 0 0.40133971930435836
Vwp_ih_22_19 wp_ih_22_19 0 0.3767242475989207
Vwn_ih_22_19 wn_ih_22_19 0 0.6232757524010794
Vwp_ih_23_19 wp_ih_23_19 0 0.42744426743951486
Vwn_ih_23_19 wn_ih_23_19 0 0.5725557325604851
Vwp_ih_24_19 wp_ih_24_19 0 0.5583857428473129
Vwn_ih_24_19 wn_ih_24_19 0 0.44161425715268704
Vwp_ih_25_19 wp_ih_25_19 0 0.49572898568129325
Vwn_ih_25_19 wn_ih_25_19 0 0.5042710143187068
Vwp_ih_26_19 wp_ih_26_19 0 0.40989310086181624
Vwn_ih_26_19 wn_ih_26_19 0 0.5901068991381837
Vwp_ih_27_19 wp_ih_27_19 0 0.47733219155801226
Vwn_ih_27_19 wn_ih_27_19 0 0.5226678084419878
Vwp_ih_28_19 wp_ih_28_19 0 0.5212063379376589
Vwn_ih_28_19 wn_ih_28_19 0 0.47879366206234103
Vwp_ih_29_19 wp_ih_29_19 0 0.43857426662899757
Vwn_ih_29_19 wn_ih_29_19 0 0.5614257333710024
Vwp_ih_30_19 wp_ih_30_19 0 0.5263708492969983
Vwn_ih_30_19 wn_ih_30_19 0 0.47362915070300177
Vwp_ih_31_19 wp_ih_31_19 0 0.3974809185920298
Vwn_ih_31_19 wn_ih_31_19 0 0.6025190814079702
Vwp_ih_32_19 wp_ih_32_19 0 0.5326988611235381
Vwn_ih_32_19 wn_ih_32_19 0 0.4673011388764619
Vwp_ih_33_19 wp_ih_33_19 0 0.6032256940913561
Vwn_ih_33_19 wn_ih_33_19 0 0.39677430590864393
Vwp_ih_34_19 wp_ih_34_19 0 0.5065667745645082
Vwn_ih_34_19 wn_ih_34_19 0 0.4934332254354918
Vwp_ih_35_19 wp_ih_35_19 0 0.46342702050165757
Vwn_ih_35_19 wn_ih_35_19 0 0.5365729794983424
Vwp_ih_36_19 wp_ih_36_19 0 0.4513766080372901
Vwn_ih_36_19 wn_ih_36_19 0 0.5486233919627099
Vwp_ih_37_19 wp_ih_37_19 0 0.4767910057815952
Vwn_ih_37_19 wn_ih_37_19 0 0.5232089942184047
Vwp_ih_38_19 wp_ih_38_19 0 0.4099126721706349
Vwn_ih_38_19 wn_ih_38_19 0 0.5900873278293651
Vwp_ih_39_19 wp_ih_39_19 0 0.6111142044802871
Vwn_ih_39_19 wn_ih_39_19 0 0.388885795519713
Vwp_ih_40_19 wp_ih_40_19 0 0.3309892235898221
Vwn_ih_40_19 wn_ih_40_19 0 0.6690107764101779
Vwp_ih_41_19 wp_ih_41_19 0 0.598218653659421
Vwn_ih_41_19 wn_ih_41_19 0 0.4017813463405791
Vwp_ih_42_19 wp_ih_42_19 0 0.3272083093023713
Vwn_ih_42_19 wn_ih_42_19 0 0.6727916906976287
Vwp_ih_43_19 wp_ih_43_19 0 0.5275244524855814
Vwn_ih_43_19 wn_ih_43_19 0 0.47247554751441856
Vwp_ih_44_19 wp_ih_44_19 0 0.3958518362206397
Vwn_ih_44_19 wn_ih_44_19 0 0.6041481637793603
Vwp_ih_45_19 wp_ih_45_19 0 0.566838675773086
Vwn_ih_45_19 wn_ih_45_19 0 0.433161324226914
Vwp_ih_46_19 wp_ih_46_19 0 0.4008225613490505
Vwn_ih_46_19 wn_ih_46_19 0 0.5991774386509495
Vwp_ih_47_19 wp_ih_47_19 0 0.3962197266949473
Vwn_ih_47_19 wn_ih_47_19 0 0.6037802733050527
Vwp_ih_48_19 wp_ih_48_19 0 0.4631626238657346
Vwn_ih_48_19 wn_ih_48_19 0 0.5368373761342654
Vwp_ih_49_19 wp_ih_49_19 0 0.4799666847712988
Vwn_ih_49_19 wn_ih_49_19 0 0.5200333152287012
Vwp_ih_50_19 wp_ih_50_19 0 0.3501175268611886
Vwn_ih_50_19 wn_ih_50_19 0 0.6498824731388114
Vwp_ih_51_19 wp_ih_51_19 0 0.5410555636581481
Vwn_ih_51_19 wn_ih_51_19 0 0.4589444363418519
Vwp_ih_52_19 wp_ih_52_19 0 0.3106756884172013
Vwn_ih_52_19 wn_ih_52_19 0 0.6893243115827987
Vwp_ih_53_19 wp_ih_53_19 0 0.6264829566391323
Vwn_ih_53_19 wn_ih_53_19 0 0.37351704336086766
Vwp_ih_54_19 wp_ih_54_19 0 0.4608137526855715
Vwn_ih_54_19 wn_ih_54_19 0 0.5391862473144284
Vwp_ih_55_19 wp_ih_55_19 0 0.5950319250649707
Vwn_ih_55_19 wn_ih_55_19 0 0.4049680749350293
Vwp_ih_56_19 wp_ih_56_19 0 0.4454700528341167
Vwn_ih_56_19 wn_ih_56_19 0 0.5545299471658833
Vwp_ih_57_19 wp_ih_57_19 0 0.4236980260772406
Vwn_ih_57_19 wn_ih_57_19 0 0.5763019739227594
Vwp_ih_58_19 wp_ih_58_19 0 0.5869079436619765
Vwn_ih_58_19 wn_ih_58_19 0 0.4130920563380235
Vwp_ih_59_19 wp_ih_59_19 0 0.4565391303870254
Vwn_ih_59_19 wn_ih_59_19 0 0.5434608696129746
Vwp_ih_60_19 wp_ih_60_19 0 0.39058588080521284
Vwn_ih_60_19 wn_ih_60_19 0 0.6094141191947872
Vwp_ih_61_19 wp_ih_61_19 0 0.5228425762218105
Vwn_ih_61_19 wn_ih_61_19 0 0.4771574237781895
Vwp_ih_62_19 wp_ih_62_19 0 0.4075412208296663
Vwn_ih_62_19 wn_ih_62_19 0 0.5924587791703336
Vwp_ih_63_19 wp_ih_63_19 0 0.5052187107144683
Vwn_ih_63_19 wn_ih_63_19 0 0.49478128928553167
Vwp_ho_19_0 wp_ho_19_0 0 0.5173887202006062
Vwn_ho_19_0 wn_ho_19_0 0 0.4826112797993937
Vwp_ho_19_1 wp_ho_19_1 0 0.42691255521888577
Vwn_ho_19_1 wn_ho_19_1 0 0.5730874447811143
Vwp_ho_19_2 wp_ho_19_2 0 0.6058131861826815
Vwn_ho_19_2 wn_ho_19_2 0 0.39418681381731846
Vwp_ho_19_3 wp_ho_19_3 0 0.4256563093366448
Vwn_ho_19_3 wn_ho_19_3 0 0.5743436906633552
Vwp_ho_19_4 wp_ho_19_4 0 0.3823827643179374
Vwn_ho_19_4 wn_ho_19_4 0 0.6176172356820626
Vwp_ih_0_20 wp_ih_0_20 0 0.6241045551152886
Vwn_ih_0_20 wn_ih_0_20 0 0.3758954448847114
Vwp_ih_1_20 wp_ih_1_20 0 0.553730569165717
Vwn_ih_1_20 wn_ih_1_20 0 0.44626943083428305
Vwp_ih_2_20 wp_ih_2_20 0 0.5084995646161234
Vwn_ih_2_20 wn_ih_2_20 0 0.49150043538387655
Vwp_ih_3_20 wp_ih_3_20 0 0.49263782841156467
Vwn_ih_3_20 wn_ih_3_20 0 0.5073621715884353
Vwp_ih_4_20 wp_ih_4_20 0 0.4563109264052323
Vwn_ih_4_20 wn_ih_4_20 0 0.5436890735947677
Vwp_ih_5_20 wp_ih_5_20 0 0.4239828429724175
Vwn_ih_5_20 wn_ih_5_20 0 0.5760171570275825
Vwp_ih_6_20 wp_ih_6_20 0 0.5429054669781063
Vwn_ih_6_20 wn_ih_6_20 0 0.4570945330218938
Vwp_ih_7_20 wp_ih_7_20 0 0.5025368527479934
Vwn_ih_7_20 wn_ih_7_20 0 0.4974631472520065
Vwp_ih_8_20 wp_ih_8_20 0 0.47308053486974494
Vwn_ih_8_20 wn_ih_8_20 0 0.526919465130255
Vwp_ih_9_20 wp_ih_9_20 0 0.5441302582565598
Vwn_ih_9_20 wn_ih_9_20 0 0.45586974174344014
Vwp_ih_10_20 wp_ih_10_20 0 0.3552750067932158
Vwn_ih_10_20 wn_ih_10_20 0 0.6447249932067842
Vwp_ih_11_20 wp_ih_11_20 0 0.6872491452759096
Vwn_ih_11_20 wn_ih_11_20 0 0.31275085472409037
Vwp_ih_12_20 wp_ih_12_20 0 0.5334634538966025
Vwn_ih_12_20 wn_ih_12_20 0 0.46653654610339745
Vwp_ih_13_20 wp_ih_13_20 0 0.3587426008930586
Vwn_ih_13_20 wn_ih_13_20 0 0.6412573991069415
Vwp_ih_14_20 wp_ih_14_20 0 0.4974797757394161
Vwn_ih_14_20 wn_ih_14_20 0 0.502520224260584
Vwp_ih_15_20 wp_ih_15_20 0 0.4156566822509617
Vwn_ih_15_20 wn_ih_15_20 0 0.5843433177490382
Vwp_ih_16_20 wp_ih_16_20 0 0.4569656863145636
Vwn_ih_16_20 wn_ih_16_20 0 0.5430343136854364
Vwp_ih_17_20 wp_ih_17_20 0 0.4202106378358813
Vwn_ih_17_20 wn_ih_17_20 0 0.5797893621641187
Vwp_ih_18_20 wp_ih_18_20 0 0.6231263091509194
Vwn_ih_18_20 wn_ih_18_20 0 0.3768736908490806
Vwp_ih_19_20 wp_ih_19_20 0 0.3121874109886176
Vwn_ih_19_20 wn_ih_19_20 0 0.6878125890113824
Vwp_ih_20_20 wp_ih_20_20 0 0.3774606605301547
Vwn_ih_20_20 wn_ih_20_20 0 0.6225393394698453
Vwp_ih_21_20 wp_ih_21_20 0 0.3442101787790982
Vwn_ih_21_20 wn_ih_21_20 0 0.6557898212209018
Vwp_ih_22_20 wp_ih_22_20 0 0.5066678814643548
Vwn_ih_22_20 wn_ih_22_20 0 0.4933321185356452
Vwp_ih_23_20 wp_ih_23_20 0 0.48704557830116246
Vwn_ih_23_20 wn_ih_23_20 0 0.5129544216988375
Vwp_ih_24_20 wp_ih_24_20 0 0.3778662094280561
Vwn_ih_24_20 wn_ih_24_20 0 0.622133790571944
Vwp_ih_25_20 wp_ih_25_20 0 0.6261100309433741
Vwn_ih_25_20 wn_ih_25_20 0 0.37388996905662586
Vwp_ih_26_20 wp_ih_26_20 0 0.673520762835886
Vwn_ih_26_20 wn_ih_26_20 0 0.326479237164114
Vwp_ih_27_20 wp_ih_27_20 0 0.429616529705702
Vwn_ih_27_20 wn_ih_27_20 0 0.570383470294298
Vwp_ih_28_20 wp_ih_28_20 0 0.4859527333805845
Vwn_ih_28_20 wn_ih_28_20 0 0.5140472666194155
Vwp_ih_29_20 wp_ih_29_20 0 0.5079966060964525
Vwn_ih_29_20 wn_ih_29_20 0 0.4920033939035475
Vwp_ih_30_20 wp_ih_30_20 0 0.556413343243059
Vwn_ih_30_20 wn_ih_30_20 0 0.443586656756941
Vwp_ih_31_20 wp_ih_31_20 0 0.6437462327774258
Vwn_ih_31_20 wn_ih_31_20 0 0.3562537672225742
Vwp_ih_32_20 wp_ih_32_20 0 0.47582234475897556
Vwn_ih_32_20 wn_ih_32_20 0 0.5241776552410244
Vwp_ih_33_20 wp_ih_33_20 0 0.6937818546067174
Vwn_ih_33_20 wn_ih_33_20 0 0.3062181453932826
Vwp_ih_34_20 wp_ih_34_20 0 0.5081326188721436
Vwn_ih_34_20 wn_ih_34_20 0 0.49186738112785644
Vwp_ih_35_20 wp_ih_35_20 0 0.4803458668887368
Vwn_ih_35_20 wn_ih_35_20 0 0.5196541331112632
Vwp_ih_36_20 wp_ih_36_20 0 0.6214663585239878
Vwn_ih_36_20 wn_ih_36_20 0 0.3785336414760122
Vwp_ih_37_20 wp_ih_37_20 0 0.5583370940173968
Vwn_ih_37_20 wn_ih_37_20 0 0.4416629059826032
Vwp_ih_38_20 wp_ih_38_20 0 0.3387135221265247
Vwn_ih_38_20 wn_ih_38_20 0 0.6612864778734753
Vwp_ih_39_20 wp_ih_39_20 0 0.5202322587413907
Vwn_ih_39_20 wn_ih_39_20 0 0.47976774125860927
Vwp_ih_40_20 wp_ih_40_20 0 0.40515661930964697
Vwn_ih_40_20 wn_ih_40_20 0 0.594843380690353
Vwp_ih_41_20 wp_ih_41_20 0 0.4013404853075688
Vwn_ih_41_20 wn_ih_41_20 0 0.5986595146924313
Vwp_ih_42_20 wp_ih_42_20 0 0.43159213142409547
Vwn_ih_42_20 wn_ih_42_20 0 0.5684078685759045
Vwp_ih_43_20 wp_ih_43_20 0 0.536522067388257
Vwn_ih_43_20 wn_ih_43_20 0 0.46347793261174297
Vwp_ih_44_20 wp_ih_44_20 0 0.356217100994894
Vwn_ih_44_20 wn_ih_44_20 0 0.643782899005106
Vwp_ih_45_20 wp_ih_45_20 0 0.41746906016931984
Vwn_ih_45_20 wn_ih_45_20 0 0.5825309398306802
Vwp_ih_46_20 wp_ih_46_20 0 0.4664945898791479
Vwn_ih_46_20 wn_ih_46_20 0 0.5335054101208521
Vwp_ih_47_20 wp_ih_47_20 0 0.548301651283251
Vwn_ih_47_20 wn_ih_47_20 0 0.45169834871674897
Vwp_ih_48_20 wp_ih_48_20 0 0.4430217137631017
Vwn_ih_48_20 wn_ih_48_20 0 0.5569782862368983
Vwp_ih_49_20 wp_ih_49_20 0 0.4171756441437633
Vwn_ih_49_20 wn_ih_49_20 0 0.5828243558562367
Vwp_ih_50_20 wp_ih_50_20 0 0.3135099748543096
Vwn_ih_50_20 wn_ih_50_20 0 0.6864900251456905
Vwp_ih_51_20 wp_ih_51_20 0 0.4146472221224041
Vwn_ih_51_20 wn_ih_51_20 0 0.5853527778775959
Vwp_ih_52_20 wp_ih_52_20 0 0.5290347362997296
Vwn_ih_52_20 wn_ih_52_20 0 0.47096526370027036
Vwp_ih_53_20 wp_ih_53_20 0 0.6160292573527009
Vwn_ih_53_20 wn_ih_53_20 0 0.38397074264729913
Vwp_ih_54_20 wp_ih_54_20 0 0.5661030681975062
Vwn_ih_54_20 wn_ih_54_20 0 0.4338969318024938
Vwp_ih_55_20 wp_ih_55_20 0 0.4608624817937344
Vwn_ih_55_20 wn_ih_55_20 0 0.5391375182062657
Vwp_ih_56_20 wp_ih_56_20 0 0.5148021808828471
Vwn_ih_56_20 wn_ih_56_20 0 0.48519781911715293
Vwp_ih_57_20 wp_ih_57_20 0 0.5724041727426824
Vwn_ih_57_20 wn_ih_57_20 0 0.4275958272573176
Vwp_ih_58_20 wp_ih_58_20 0 0.44598107843520407
Vwn_ih_58_20 wn_ih_58_20 0 0.5540189215647959
Vwp_ih_59_20 wp_ih_59_20 0 0.5662889217244946
Vwn_ih_59_20 wn_ih_59_20 0 0.43371107827550537
Vwp_ih_60_20 wp_ih_60_20 0 0.32231760012369165
Vwn_ih_60_20 wn_ih_60_20 0 0.6776823998763084
Vwp_ih_61_20 wp_ih_61_20 0 0.5311791267475512
Vwn_ih_61_20 wn_ih_61_20 0 0.4688208732524488
Vwp_ih_62_20 wp_ih_62_20 0 0.4645492301623434
Vwn_ih_62_20 wn_ih_62_20 0 0.5354507698376566
Vwp_ih_63_20 wp_ih_63_20 0 0.39322062525614915
Vwn_ih_63_20 wn_ih_63_20 0 0.6067793747438508
Vwp_ho_20_0 wp_ho_20_0 0 0.591754777990814
Vwn_ho_20_0 wn_ho_20_0 0 0.40824522200918606
Vwp_ho_20_1 wp_ho_20_1 0 0.40351094936367105
Vwn_ho_20_1 wn_ho_20_1 0 0.596489050636329
Vwp_ho_20_2 wp_ho_20_2 0 0.6569720766707874
Vwn_ho_20_2 wn_ho_20_2 0 0.34302792332921267
Vwp_ho_20_3 wp_ho_20_3 0 0.45882632390504874
Vwn_ho_20_3 wn_ho_20_3 0 0.5411736760949513
Vwp_ho_20_4 wp_ho_20_4 0 0.6122653289738987
Vwn_ho_20_4 wn_ho_20_4 0 0.38773467102610126
Vwp_ih_0_21 wp_ih_0_21 0 0.5695550553440369
Vwn_ih_0_21 wn_ih_0_21 0 0.43044494465596306
Vwp_ih_1_21 wp_ih_1_21 0 0.4590867858975569
Vwn_ih_1_21 wn_ih_1_21 0 0.5409132141024431
Vwp_ih_2_21 wp_ih_2_21 0 0.46856848076763036
Vwn_ih_2_21 wn_ih_2_21 0 0.5314315192323696
Vwp_ih_3_21 wp_ih_3_21 0 0.6463832525338469
Vwn_ih_3_21 wn_ih_3_21 0 0.3536167474661531
Vwp_ih_4_21 wp_ih_4_21 0 0.37744174105842176
Vwn_ih_4_21 wn_ih_4_21 0 0.6225582589415782
Vwp_ih_5_21 wp_ih_5_21 0 0.41906544313274585
Vwn_ih_5_21 wn_ih_5_21 0 0.5809345568672541
Vwp_ih_6_21 wp_ih_6_21 0 0.40684326100164186
Vwn_ih_6_21 wn_ih_6_21 0 0.5931567389983582
Vwp_ih_7_21 wp_ih_7_21 0 0.5495394081191585
Vwn_ih_7_21 wn_ih_7_21 0 0.45046059188084153
Vwp_ih_8_21 wp_ih_8_21 0 0.32787422103398595
Vwn_ih_8_21 wn_ih_8_21 0 0.672125778966014
Vwp_ih_9_21 wp_ih_9_21 0 0.6395874264423355
Vwn_ih_9_21 wn_ih_9_21 0 0.36041257355766454
Vwp_ih_10_21 wp_ih_10_21 0 0.4606293559183602
Vwn_ih_10_21 wn_ih_10_21 0 0.5393706440816398
Vwp_ih_11_21 wp_ih_11_21 0 0.44599587325599355
Vwn_ih_11_21 wn_ih_11_21 0 0.5540041267440065
Vwp_ih_12_21 wp_ih_12_21 0 0.38541211906589956
Vwn_ih_12_21 wn_ih_12_21 0 0.6145878809341004
Vwp_ih_13_21 wp_ih_13_21 0 0.44502029092436013
Vwn_ih_13_21 wn_ih_13_21 0 0.5549797090756399
Vwp_ih_14_21 wp_ih_14_21 0 0.6425351549735459
Vwn_ih_14_21 wn_ih_14_21 0 0.3574648450264542
Vwp_ih_15_21 wp_ih_15_21 0 0.4964741752520124
Vwn_ih_15_21 wn_ih_15_21 0 0.5035258247479876
Vwp_ih_16_21 wp_ih_16_21 0 0.41160144011426925
Vwn_ih_16_21 wn_ih_16_21 0 0.5883985598857308
Vwp_ih_17_21 wp_ih_17_21 0 0.5060438870166133
Vwn_ih_17_21 wn_ih_17_21 0 0.49395611298338665
Vwp_ih_18_21 wp_ih_18_21 0 0.5124085090332638
Vwn_ih_18_21 wn_ih_18_21 0 0.48759149096673615
Vwp_ih_19_21 wp_ih_19_21 0 0.49650618565145826
Vwn_ih_19_21 wn_ih_19_21 0 0.5034938143485417
Vwp_ih_20_21 wp_ih_20_21 0 0.540844247923917
Vwn_ih_20_21 wn_ih_20_21 0 0.45915575207608295
Vwp_ih_21_21 wp_ih_21_21 0 0.5324559859931292
Vwn_ih_21_21 wn_ih_21_21 0 0.46754401400687085
Vwp_ih_22_21 wp_ih_22_21 0 0.5162241447335126
Vwn_ih_22_21 wn_ih_22_21 0 0.4837758552664873
Vwp_ih_23_21 wp_ih_23_21 0 0.3821904293951195
Vwn_ih_23_21 wn_ih_23_21 0 0.6178095706048805
Vwp_ih_24_21 wp_ih_24_21 0 0.32202618205983613
Vwn_ih_24_21 wn_ih_24_21 0 0.6779738179401639
Vwp_ih_25_21 wp_ih_25_21 0 0.5523293112122996
Vwn_ih_25_21 wn_ih_25_21 0 0.44767068878770044
Vwp_ih_26_21 wp_ih_26_21 0 0.5885133374794252
Vwn_ih_26_21 wn_ih_26_21 0 0.41148666252057475
Vwp_ih_27_21 wp_ih_27_21 0 0.41228075131030273
Vwn_ih_27_21 wn_ih_27_21 0 0.5877192486896973
Vwp_ih_28_21 wp_ih_28_21 0 0.5417552095006393
Vwn_ih_28_21 wn_ih_28_21 0 0.45824479049936073
Vwp_ih_29_21 wp_ih_29_21 0 0.6109516443304117
Vwn_ih_29_21 wn_ih_29_21 0 0.38904835566958834
Vwp_ih_30_21 wp_ih_30_21 0 0.6269135915014108
Vwn_ih_30_21 wn_ih_30_21 0 0.37308640849858926
Vwp_ih_31_21 wp_ih_31_21 0 0.4998718079983171
Vwn_ih_31_21 wn_ih_31_21 0 0.5001281920016829
Vwp_ih_32_21 wp_ih_32_21 0 0.6124752746658463
Vwn_ih_32_21 wn_ih_32_21 0 0.3875247253341538
Vwp_ih_33_21 wp_ih_33_21 0 0.5634209944658242
Vwn_ih_33_21 wn_ih_33_21 0 0.4365790055341759
Vwp_ih_34_21 wp_ih_34_21 0 0.4053999844340127
Vwn_ih_34_21 wn_ih_34_21 0 0.5946000155659873
Vwp_ih_35_21 wp_ih_35_21 0 0.3102251785604502
Vwn_ih_35_21 wn_ih_35_21 0 0.6897748214395498
Vwp_ih_36_21 wp_ih_36_21 0 0.45035694262763937
Vwn_ih_36_21 wn_ih_36_21 0 0.5496430573723606
Vwp_ih_37_21 wp_ih_37_21 0 0.5497854648527185
Vwn_ih_37_21 wn_ih_37_21 0 0.4502145351472815
Vwp_ih_38_21 wp_ih_38_21 0 0.5308132309834718
Vwn_ih_38_21 wn_ih_38_21 0 0.4691867690165283
Vwp_ih_39_21 wp_ih_39_21 0 0.45479799034600665
Vwn_ih_39_21 wn_ih_39_21 0 0.5452020096539933
Vwp_ih_40_21 wp_ih_40_21 0 0.4129643839560244
Vwn_ih_40_21 wn_ih_40_21 0 0.5870356160439756
Vwp_ih_41_21 wp_ih_41_21 0 0.35960859301441717
Vwn_ih_41_21 wn_ih_41_21 0 0.6403914069855828
Vwp_ih_42_21 wp_ih_42_21 0 0.3305684383451424
Vwn_ih_42_21 wn_ih_42_21 0 0.6694315616548576
Vwp_ih_43_21 wp_ih_43_21 0 0.47470467740781924
Vwn_ih_43_21 wn_ih_43_21 0 0.5252953225921807
Vwp_ih_44_21 wp_ih_44_21 0 0.39431154791790635
Vwn_ih_44_21 wn_ih_44_21 0 0.6056884520820937
Vwp_ih_45_21 wp_ih_45_21 0 0.4800792881068268
Vwn_ih_45_21 wn_ih_45_21 0 0.5199207118931731
Vwp_ih_46_21 wp_ih_46_21 0 0.458519712338311
Vwn_ih_46_21 wn_ih_46_21 0 0.541480287661689
Vwp_ih_47_21 wp_ih_47_21 0 0.44667358448393996
Vwn_ih_47_21 wn_ih_47_21 0 0.55332641551606
Vwp_ih_48_21 wp_ih_48_21 0 0.6884322780092074
Vwn_ih_48_21 wn_ih_48_21 0 0.3115677219907926
Vwp_ih_49_21 wp_ih_49_21 0 0.5079808139543307
Vwn_ih_49_21 wn_ih_49_21 0 0.49201918604566935
Vwp_ih_50_21 wp_ih_50_21 0 0.44884104531142954
Vwn_ih_50_21 wn_ih_50_21 0 0.5511589546885705
Vwp_ih_51_21 wp_ih_51_21 0 0.48852013627584967
Vwn_ih_51_21 wn_ih_51_21 0 0.5114798637241503
Vwp_ih_52_21 wp_ih_52_21 0 0.42560587162303276
Vwn_ih_52_21 wn_ih_52_21 0 0.5743941283769672
Vwp_ih_53_21 wp_ih_53_21 0 0.5953073519647226
Vwn_ih_53_21 wn_ih_53_21 0 0.40469264803527744
Vwp_ih_54_21 wp_ih_54_21 0 0.6080155414051931
Vwn_ih_54_21 wn_ih_54_21 0 0.39198445859480685
Vwp_ih_55_21 wp_ih_55_21 0 0.4590957374543711
Vwn_ih_55_21 wn_ih_55_21 0 0.5409042625456288
Vwp_ih_56_21 wp_ih_56_21 0 0.5166551302184773
Vwn_ih_56_21 wn_ih_56_21 0 0.4833448697815227
Vwp_ih_57_21 wp_ih_57_21 0 0.5531035299149264
Vwn_ih_57_21 wn_ih_57_21 0 0.4468964700850736
Vwp_ih_58_21 wp_ih_58_21 0 0.573691554533077
Vwn_ih_58_21 wn_ih_58_21 0 0.4263084454669231
Vwp_ih_59_21 wp_ih_59_21 0 0.389540450360451
Vwn_ih_59_21 wn_ih_59_21 0 0.610459549639549
Vwp_ih_60_21 wp_ih_60_21 0 0.5050801807320113
Vwn_ih_60_21 wn_ih_60_21 0 0.4949198192679886
Vwp_ih_61_21 wp_ih_61_21 0 0.6269172584137362
Vwn_ih_61_21 wn_ih_61_21 0 0.37308274158626376
Vwp_ih_62_21 wp_ih_62_21 0 0.5499909868732474
Vwn_ih_62_21 wn_ih_62_21 0 0.45000901312675257
Vwp_ih_63_21 wp_ih_63_21 0 0.4584111740107035
Vwn_ih_63_21 wn_ih_63_21 0 0.5415888259892965
Vwp_ho_21_0 wp_ho_21_0 0 0.3838027731161236
Vwn_ho_21_0 wn_ho_21_0 0 0.6161972268838763
Vwp_ho_21_1 wp_ho_21_1 0 0.6259908992471646
Vwn_ho_21_1 wn_ho_21_1 0 0.37400910075283544
Vwp_ho_21_2 wp_ho_21_2 0 0.394722103788185
Vwn_ho_21_2 wn_ho_21_2 0 0.6052778962118149
Vwp_ho_21_3 wp_ho_21_3 0 0.5595442891072321
Vwn_ho_21_3 wn_ho_21_3 0 0.4404557108927679
Vwp_ho_21_4 wp_ho_21_4 0 0.5067601587059977
Vwn_ho_21_4 wn_ho_21_4 0 0.49323984129400233
Vwp_ih_0_22 wp_ih_0_22 0 0.5854792981493204
Vwn_ih_0_22 wn_ih_0_22 0 0.4145207018506795
Vwp_ih_1_22 wp_ih_1_22 0 0.6215017624303747
Vwn_ih_1_22 wn_ih_1_22 0 0.3784982375696253
Vwp_ih_2_22 wp_ih_2_22 0 0.49593553912832244
Vwn_ih_2_22 wn_ih_2_22 0 0.5040644608716776
Vwp_ih_3_22 wp_ih_3_22 0 0.4966198257819472
Vwn_ih_3_22 wn_ih_3_22 0 0.5033801742180528
Vwp_ih_4_22 wp_ih_4_22 0 0.45344430103773464
Vwn_ih_4_22 wn_ih_4_22 0 0.5465556989622653
Vwp_ih_5_22 wp_ih_5_22 0 0.5418527904996878
Vwn_ih_5_22 wn_ih_5_22 0 0.45814720950031224
Vwp_ih_6_22 wp_ih_6_22 0 0.6621882734940702
Vwn_ih_6_22 wn_ih_6_22 0 0.33781172650592983
Vwp_ih_7_22 wp_ih_7_22 0 0.32163012935393426
Vwn_ih_7_22 wn_ih_7_22 0 0.6783698706460657
Vwp_ih_8_22 wp_ih_8_22 0 0.5897119216883981
Vwn_ih_8_22 wn_ih_8_22 0 0.4102880783116019
Vwp_ih_9_22 wp_ih_9_22 0 0.46922417951825734
Vwn_ih_9_22 wn_ih_9_22 0 0.5307758204817427
Vwp_ih_10_22 wp_ih_10_22 0 0.5297228622975559
Vwn_ih_10_22 wn_ih_10_22 0 0.47027713770244406
Vwp_ih_11_22 wp_ih_11_22 0 0.5087145807203968
Vwn_ih_11_22 wn_ih_11_22 0 0.49128541927960323
Vwp_ih_12_22 wp_ih_12_22 0 0.3
Vwn_ih_12_22 wn_ih_12_22 0 0.7011591039676306
Vwp_ih_13_22 wp_ih_13_22 0 0.7207115512755758
Vwn_ih_13_22 wn_ih_13_22 0 0.3
Vwp_ih_14_22 wp_ih_14_22 0 0.39159010889412416
Vwn_ih_14_22 wn_ih_14_22 0 0.6084098911058758
Vwp_ih_15_22 wp_ih_15_22 0 0.5751023180787933
Vwn_ih_15_22 wn_ih_15_22 0 0.4248976819212067
Vwp_ih_16_22 wp_ih_16_22 0 0.48990922073252063
Vwn_ih_16_22 wn_ih_16_22 0 0.5100907792674794
Vwp_ih_17_22 wp_ih_17_22 0 0.4909364512835777
Vwn_ih_17_22 wn_ih_17_22 0 0.5090635487164222
Vwp_ih_18_22 wp_ih_18_22 0 0.5281498044913768
Vwn_ih_18_22 wn_ih_18_22 0 0.4718501955086231
Vwp_ih_19_22 wp_ih_19_22 0 0.49180955887807726
Vwn_ih_19_22 wn_ih_19_22 0 0.5081904411219227
Vwp_ih_20_22 wp_ih_20_22 0 0.5066956763023049
Vwn_ih_20_22 wn_ih_20_22 0 0.49330432369769506
Vwp_ih_21_22 wp_ih_21_22 0 0.547726285925543
Vwn_ih_21_22 wn_ih_21_22 0 0.45227371407445704
Vwp_ih_22_22 wp_ih_22_22 0 0.5908793053810579
Vwn_ih_22_22 wn_ih_22_22 0 0.40912069461894207
Vwp_ih_23_22 wp_ih_23_22 0 0.5210255899031155
Vwn_ih_23_22 wn_ih_23_22 0 0.47897441009688446
Vwp_ih_24_22 wp_ih_24_22 0 0.5295231097021931
Vwn_ih_24_22 wn_ih_24_22 0 0.470476890297807
Vwp_ih_25_22 wp_ih_25_22 0 0.6357215486025647
Vwn_ih_25_22 wn_ih_25_22 0 0.3642784513974353
Vwp_ih_26_22 wp_ih_26_22 0 0.4482019273902521
Vwn_ih_26_22 wn_ih_26_22 0 0.5517980726097479
Vwp_ih_27_22 wp_ih_27_22 0 0.4839563508460734
Vwn_ih_27_22 wn_ih_27_22 0 0.5160436491539265
Vwp_ih_28_22 wp_ih_28_22 0 0.5367606097740545
Vwn_ih_28_22 wn_ih_28_22 0 0.4632393902259455
Vwp_ih_29_22 wp_ih_29_22 0 0.5819035806277657
Vwn_ih_29_22 wn_ih_29_22 0 0.4180964193722343
Vwp_ih_30_22 wp_ih_30_22 0 0.5231482604234826
Vwn_ih_30_22 wn_ih_30_22 0 0.4768517395765174
Vwp_ih_31_22 wp_ih_31_22 0 0.5083769138980098
Vwn_ih_31_22 wn_ih_31_22 0 0.49162308610199024
Vwp_ih_32_22 wp_ih_32_22 0 0.46895477610844594
Vwn_ih_32_22 wn_ih_32_22 0 0.5310452238915541
Vwp_ih_33_22 wp_ih_33_22 0 0.6470354597278662
Vwn_ih_33_22 wn_ih_33_22 0 0.35296454027213375
Vwp_ih_34_22 wp_ih_34_22 0 0.4984869673420246
Vwn_ih_34_22 wn_ih_34_22 0 0.5015130326579754
Vwp_ih_35_22 wp_ih_35_22 0 0.5224494410857327
Vwn_ih_35_22 wn_ih_35_22 0 0.4775505589142674
Vwp_ih_36_22 wp_ih_36_22 0 0.4921819151330114
Vwn_ih_36_22 wn_ih_36_22 0 0.5078180848669885
Vwp_ih_37_22 wp_ih_37_22 0 0.4780878579982105
Vwn_ih_37_22 wn_ih_37_22 0 0.5219121420017895
Vwp_ih_38_22 wp_ih_38_22 0 0.42339268240212463
Vwn_ih_38_22 wn_ih_38_22 0 0.5766073175978754
Vwp_ih_39_22 wp_ih_39_22 0 0.5051040870980913
Vwn_ih_39_22 wn_ih_39_22 0 0.49489591290190865
Vwp_ih_40_22 wp_ih_40_22 0 0.49190456179152814
Vwn_ih_40_22 wn_ih_40_22 0 0.5080954382084718
Vwp_ih_41_22 wp_ih_41_22 0 0.4145278659122032
Vwn_ih_41_22 wn_ih_41_22 0 0.5854721340877969
Vwp_ih_42_22 wp_ih_42_22 0 0.45240051245766943
Vwn_ih_42_22 wn_ih_42_22 0 0.5475994875423306
Vwp_ih_43_22 wp_ih_43_22 0 0.46340280316250915
Vwn_ih_43_22 wn_ih_43_22 0 0.5365971968374909
Vwp_ih_44_22 wp_ih_44_22 0 0.42701830151071274
Vwn_ih_44_22 wn_ih_44_22 0 0.5729816984892873
Vwp_ih_45_22 wp_ih_45_22 0 0.39386513241314536
Vwn_ih_45_22 wn_ih_45_22 0 0.6061348675868546
Vwp_ih_46_22 wp_ih_46_22 0 0.6101534766085822
Vwn_ih_46_22 wn_ih_46_22 0 0.38984652339141784
Vwp_ih_47_22 wp_ih_47_22 0 0.4095369901528867
Vwn_ih_47_22 wn_ih_47_22 0 0.5904630098471133
Vwp_ih_48_22 wp_ih_48_22 0 0.42559281092614787
Vwn_ih_48_22 wn_ih_48_22 0 0.5744071890738521
Vwp_ih_49_22 wp_ih_49_22 0 0.3450717915548226
Vwn_ih_49_22 wn_ih_49_22 0 0.6549282084451774
Vwp_ih_50_22 wp_ih_50_22 0 0.5814490092777483
Vwn_ih_50_22 wn_ih_50_22 0 0.41855099072225166
Vwp_ih_51_22 wp_ih_51_22 0 0.5798989694902211
Vwn_ih_51_22 wn_ih_51_22 0 0.42010103050977887
Vwp_ih_52_22 wp_ih_52_22 0 0.5351312008716727
Vwn_ih_52_22 wn_ih_52_22 0 0.46486879912832735
Vwp_ih_53_22 wp_ih_53_22 0 0.496251344949839
Vwn_ih_53_22 wn_ih_53_22 0 0.503748655050161
Vwp_ih_54_22 wp_ih_54_22 0 0.44873038755033917
Vwn_ih_54_22 wn_ih_54_22 0 0.5512696124496609
Vwp_ih_55_22 wp_ih_55_22 0 0.48110836816290165
Vwn_ih_55_22 wn_ih_55_22 0 0.5188916318370984
Vwp_ih_56_22 wp_ih_56_22 0 0.4399204467642054
Vwn_ih_56_22 wn_ih_56_22 0 0.5600795532357946
Vwp_ih_57_22 wp_ih_57_22 0 0.5034580483074075
Vwn_ih_57_22 wn_ih_57_22 0 0.4965419516925925
Vwp_ih_58_22 wp_ih_58_22 0 0.511967720904246
Vwn_ih_58_22 wn_ih_58_22 0 0.4880322790957539
Vwp_ih_59_22 wp_ih_59_22 0 0.5597873759314823
Vwn_ih_59_22 wn_ih_59_22 0 0.4402126240685177
Vwp_ih_60_22 wp_ih_60_22 0 0.6972265112855831
Vwn_ih_60_22 wn_ih_60_22 0 0.30277348871441684
Vwp_ih_61_22 wp_ih_61_22 0 0.5558323780229175
Vwn_ih_61_22 wn_ih_61_22 0 0.4441676219770824
Vwp_ih_62_22 wp_ih_62_22 0 0.5371222021866491
Vwn_ih_62_22 wn_ih_62_22 0 0.4628777978133509
Vwp_ih_63_22 wp_ih_63_22 0 0.5878365856968414
Vwn_ih_63_22 wn_ih_63_22 0 0.41216341430315856
Vwp_ho_22_0 wp_ho_22_0 0 0.7253431061813717
Vwn_ho_22_0 wn_ho_22_0 0 0.3
Vwp_ho_22_1 wp_ho_22_1 0 0.752569543343429
Vwn_ho_22_1 wn_ho_22_1 0 0.3
Vwp_ho_22_2 wp_ho_22_2 0 0.5189471954646159
Vwn_ho_22_2 wn_ho_22_2 0 0.4810528045353841
Vwp_ho_22_3 wp_ho_22_3 0 0.5145005412911072
Vwn_ho_22_3 wn_ho_22_3 0 0.4854994587088927
Vwp_ho_22_4 wp_ho_22_4 0 0.610948064455861
Vwn_ho_22_4 wn_ho_22_4 0 0.38905193554413897
Vwp_ih_0_23 wp_ih_0_23 0 0.3612191127938432
Vwn_ih_0_23 wn_ih_0_23 0 0.6387808872061568
Vwp_ih_1_23 wp_ih_1_23 0 0.5117967421375482
Vwn_ih_1_23 wn_ih_1_23 0 0.4882032578624517
Vwp_ih_2_23 wp_ih_2_23 0 0.359576785353089
Vwn_ih_2_23 wn_ih_2_23 0 0.640423214646911
Vwp_ih_3_23 wp_ih_3_23 0 0.6335782374104626
Vwn_ih_3_23 wn_ih_3_23 0 0.3664217625895374
Vwp_ih_4_23 wp_ih_4_23 0 0.4199579353648435
Vwn_ih_4_23 wn_ih_4_23 0 0.5800420646351565
Vwp_ih_5_23 wp_ih_5_23 0 0.6390030622226577
Vwn_ih_5_23 wn_ih_5_23 0 0.3609969377773423
Vwp_ih_6_23 wp_ih_6_23 0 0.6149802993950292
Vwn_ih_6_23 wn_ih_6_23 0 0.3850197006049708
Vwp_ih_7_23 wp_ih_7_23 0 0.4671326485885744
Vwn_ih_7_23 wn_ih_7_23 0 0.5328673514114256
Vwp_ih_8_23 wp_ih_8_23 0 0.3653312235557599
Vwn_ih_8_23 wn_ih_8_23 0 0.63466877644424
Vwp_ih_9_23 wp_ih_9_23 0 0.3624697262347844
Vwn_ih_9_23 wn_ih_9_23 0 0.6375302737652155
Vwp_ih_10_23 wp_ih_10_23 0 0.5890516541230167
Vwn_ih_10_23 wn_ih_10_23 0 0.41094834587698326
Vwp_ih_11_23 wp_ih_11_23 0 0.5524937719199425
Vwn_ih_11_23 wn_ih_11_23 0 0.44750622808005747
Vwp_ih_12_23 wp_ih_12_23 0 0.4036853036941549
Vwn_ih_12_23 wn_ih_12_23 0 0.5963146963058451
Vwp_ih_13_23 wp_ih_13_23 0 0.46970487089557017
Vwn_ih_13_23 wn_ih_13_23 0 0.5302951291044298
Vwp_ih_14_23 wp_ih_14_23 0 0.6588633729601183
Vwn_ih_14_23 wn_ih_14_23 0 0.3411366270398817
Vwp_ih_15_23 wp_ih_15_23 0 0.6551680684214692
Vwn_ih_15_23 wn_ih_15_23 0 0.34483193157853076
Vwp_ih_16_23 wp_ih_16_23 0 0.47015454597737083
Vwn_ih_16_23 wn_ih_16_23 0 0.5298454540226292
Vwp_ih_17_23 wp_ih_17_23 0 0.5165980317466098
Vwn_ih_17_23 wn_ih_17_23 0 0.48340196825339016
Vwp_ih_18_23 wp_ih_18_23 0 0.5847382420063647
Vwn_ih_18_23 wn_ih_18_23 0 0.41526175799363524
Vwp_ih_19_23 wp_ih_19_23 0 0.3806382543466741
Vwn_ih_19_23 wn_ih_19_23 0 0.6193617456533259
Vwp_ih_20_23 wp_ih_20_23 0 0.39751494598664866
Vwn_ih_20_23 wn_ih_20_23 0 0.6024850540133513
Vwp_ih_21_23 wp_ih_21_23 0 0.48931927476820364
Vwn_ih_21_23 wn_ih_21_23 0 0.5106807252317963
Vwp_ih_22_23 wp_ih_22_23 0 0.5371848466673732
Vwn_ih_22_23 wn_ih_22_23 0 0.46281515333262674
Vwp_ih_23_23 wp_ih_23_23 0 0.4636218280033214
Vwn_ih_23_23 wn_ih_23_23 0 0.5363781719966786
Vwp_ih_24_23 wp_ih_24_23 0 0.37872950532462724
Vwn_ih_24_23 wn_ih_24_23 0 0.6212704946753728
Vwp_ih_25_23 wp_ih_25_23 0 0.5828490798322977
Vwn_ih_25_23 wn_ih_25_23 0 0.4171509201677023
Vwp_ih_26_23 wp_ih_26_23 0 0.501879957843593
Vwn_ih_26_23 wn_ih_26_23 0 0.49812004215640704
Vwp_ih_27_23 wp_ih_27_23 0 0.3888261655136354
Vwn_ih_27_23 wn_ih_27_23 0 0.6111738344863646
Vwp_ih_28_23 wp_ih_28_23 0 0.3571533276690384
Vwn_ih_28_23 wn_ih_28_23 0 0.6428466723309616
Vwp_ih_29_23 wp_ih_29_23 0 0.4808082063701365
Vwn_ih_29_23 wn_ih_29_23 0 0.5191917936298636
Vwp_ih_30_23 wp_ih_30_23 0 0.6281312326509626
Vwn_ih_30_23 wn_ih_30_23 0 0.3718687673490374
Vwp_ih_31_23 wp_ih_31_23 0 0.48280129571611247
Vwn_ih_31_23 wn_ih_31_23 0 0.5171987042838876
Vwp_ih_32_23 wp_ih_32_23 0 0.5965812575649528
Vwn_ih_32_23 wn_ih_32_23 0 0.40341874243504716
Vwp_ih_33_23 wp_ih_33_23 0 0.3403098782575224
Vwn_ih_33_23 wn_ih_33_23 0 0.6596901217424775
Vwp_ih_34_23 wp_ih_34_23 0 0.48489266374353135
Vwn_ih_34_23 wn_ih_34_23 0 0.5151073362564687
Vwp_ih_35_23 wp_ih_35_23 0 0.41658544039817114
Vwn_ih_35_23 wn_ih_35_23 0 0.5834145596018289
Vwp_ih_36_23 wp_ih_36_23 0 0.43548761188035917
Vwn_ih_36_23 wn_ih_36_23 0 0.5645123881196408
Vwp_ih_37_23 wp_ih_37_23 0 0.5507592241368453
Vwn_ih_37_23 wn_ih_37_23 0 0.44924077586315464
Vwp_ih_38_23 wp_ih_38_23 0 0.5125876694908001
Vwn_ih_38_23 wn_ih_38_23 0 0.4874123305091998
Vwp_ih_39_23 wp_ih_39_23 0 0.38799574933826064
Vwn_ih_39_23 wn_ih_39_23 0 0.6120042506617394
Vwp_ih_40_23 wp_ih_40_23 0 0.5604515443078799
Vwn_ih_40_23 wn_ih_40_23 0 0.43954845569212014
Vwp_ih_41_23 wp_ih_41_23 0 0.45110623615927326
Vwn_ih_41_23 wn_ih_41_23 0 0.5488937638407267
Vwp_ih_42_23 wp_ih_42_23 0 0.5775317939995434
Vwn_ih_42_23 wn_ih_42_23 0 0.42246820600045665
Vwp_ih_43_23 wp_ih_43_23 0 0.4308245205220047
Vwn_ih_43_23 wn_ih_43_23 0 0.5691754794779953
Vwp_ih_44_23 wp_ih_44_23 0 0.5390118133107987
Vwn_ih_44_23 wn_ih_44_23 0 0.4609881866892012
Vwp_ih_45_23 wp_ih_45_23 0 0.4840679536087408
Vwn_ih_45_23 wn_ih_45_23 0 0.5159320463912592
Vwp_ih_46_23 wp_ih_46_23 0 0.5927033035473619
Vwn_ih_46_23 wn_ih_46_23 0 0.40729669645263805
Vwp_ih_47_23 wp_ih_47_23 0 0.5678391243983782
Vwn_ih_47_23 wn_ih_47_23 0 0.43216087560162175
Vwp_ih_48_23 wp_ih_48_23 0 0.7035098306933425
Vwn_ih_48_23 wn_ih_48_23 0 0.3
Vwp_ih_49_23 wp_ih_49_23 0 0.5068840201549444
Vwn_ih_49_23 wn_ih_49_23 0 0.49311597984505556
Vwp_ih_50_23 wp_ih_50_23 0 0.4540262876356775
Vwn_ih_50_23 wn_ih_50_23 0 0.5459737123643225
Vwp_ih_51_23 wp_ih_51_23 0 0.4092808232152659
Vwn_ih_51_23 wn_ih_51_23 0 0.5907191767847341
Vwp_ih_52_23 wp_ih_52_23 0 0.4517462387329527
Vwn_ih_52_23 wn_ih_52_23 0 0.5482537612670473
Vwp_ih_53_23 wp_ih_53_23 0 0.5107921393354748
Vwn_ih_53_23 wn_ih_53_23 0 0.4892078606645252
Vwp_ih_54_23 wp_ih_54_23 0 0.4245146459686918
Vwn_ih_54_23 wn_ih_54_23 0 0.5754853540313082
Vwp_ih_55_23 wp_ih_55_23 0 0.6679299877738042
Vwn_ih_55_23 wn_ih_55_23 0 0.3320700122261958
Vwp_ih_56_23 wp_ih_56_23 0 0.52120568537375
Vwn_ih_56_23 wn_ih_56_23 0 0.47879431462625
Vwp_ih_57_23 wp_ih_57_23 0 0.41443248023402113
Vwn_ih_57_23 wn_ih_57_23 0 0.5855675197659789
Vwp_ih_58_23 wp_ih_58_23 0 0.4409230481195353
Vwn_ih_58_23 wn_ih_58_23 0 0.5590769518804647
Vwp_ih_59_23 wp_ih_59_23 0 0.4393386266043998
Vwn_ih_59_23 wn_ih_59_23 0 0.5606613733956002
Vwp_ih_60_23 wp_ih_60_23 0 0.49155303884406126
Vwn_ih_60_23 wn_ih_60_23 0 0.5084469611559388
Vwp_ih_61_23 wp_ih_61_23 0 0.3811233872338204
Vwn_ih_61_23 wn_ih_61_23 0 0.6188766127661796
Vwp_ih_62_23 wp_ih_62_23 0 0.5638979237015133
Vwn_ih_62_23 wn_ih_62_23 0 0.43610207629848674
Vwp_ih_63_23 wp_ih_63_23 0 0.44190573221853285
Vwn_ih_63_23 wn_ih_63_23 0 0.5580942677814671
Vwp_ho_23_0 wp_ho_23_0 0 0.6754920930908487
Vwn_ho_23_0 wn_ho_23_0 0 0.3245079069091513
Vwp_ho_23_1 wp_ho_23_1 0 0.6560904392241643
Vwn_ho_23_1 wn_ho_23_1 0 0.3439095607758357
Vwp_ho_23_2 wp_ho_23_2 0 0.49158023039513427
Vwn_ho_23_2 wn_ho_23_2 0 0.5084197696048658
Vwp_ho_23_3 wp_ho_23_3 0 0.6026060410897136
Vwn_ho_23_3 wn_ho_23_3 0 0.39739395891028634
Vwp_ho_23_4 wp_ho_23_4 0 0.38387340749330195
Vwn_ho_23_4 wn_ho_23_4 0 0.6161265925066981
Vwp_ih_0_24 wp_ih_0_24 0 0.4786448286491866
Vwn_ih_0_24 wn_ih_0_24 0 0.5213551713508133
Vwp_ih_1_24 wp_ih_1_24 0 0.5803734496571745
Vwn_ih_1_24 wn_ih_1_24 0 0.4196265503428255
Vwp_ih_2_24 wp_ih_2_24 0 0.46250922345994544
Vwn_ih_2_24 wn_ih_2_24 0 0.5374907765400545
Vwp_ih_3_24 wp_ih_3_24 0 0.509304379071765
Vwn_ih_3_24 wn_ih_3_24 0 0.4906956209282351
Vwp_ih_4_24 wp_ih_4_24 0 0.6772762856567763
Vwn_ih_4_24 wn_ih_4_24 0 0.32272371434322367
Vwp_ih_5_24 wp_ih_5_24 0 0.5551934206523997
Vwn_ih_5_24 wn_ih_5_24 0 0.44480657934760026
Vwp_ih_6_24 wp_ih_6_24 0 0.5381400476485668
Vwn_ih_6_24 wn_ih_6_24 0 0.46185995235143323
Vwp_ih_7_24 wp_ih_7_24 0 0.46877996956838747
Vwn_ih_7_24 wn_ih_7_24 0 0.5312200304316126
Vwp_ih_8_24 wp_ih_8_24 0 0.41598421157694576
Vwn_ih_8_24 wn_ih_8_24 0 0.5840157884230542
Vwp_ih_9_24 wp_ih_9_24 0 0.6693281525319089
Vwn_ih_9_24 wn_ih_9_24 0 0.3306718474680911
Vwp_ih_10_24 wp_ih_10_24 0 0.5649807321558674
Vwn_ih_10_24 wn_ih_10_24 0 0.4350192678441326
Vwp_ih_11_24 wp_ih_11_24 0 0.6696959504348307
Vwn_ih_11_24 wn_ih_11_24 0 0.33030404956516934
Vwp_ih_12_24 wp_ih_12_24 0 0.4550618100375356
Vwn_ih_12_24 wn_ih_12_24 0 0.5449381899624645
Vwp_ih_13_24 wp_ih_13_24 0 0.6090132671625589
Vwn_ih_13_24 wn_ih_13_24 0 0.3909867328374411
Vwp_ih_14_24 wp_ih_14_24 0 0.48769399238582534
Vwn_ih_14_24 wn_ih_14_24 0 0.5123060076141747
Vwp_ih_15_24 wp_ih_15_24 0 0.5483352873789159
Vwn_ih_15_24 wn_ih_15_24 0 0.4516647126210841
Vwp_ih_16_24 wp_ih_16_24 0 0.6136224153843005
Vwn_ih_16_24 wn_ih_16_24 0 0.3863775846156995
Vwp_ih_17_24 wp_ih_17_24 0 0.5277509945436714
Vwn_ih_17_24 wn_ih_17_24 0 0.47224900545632864
Vwp_ih_18_24 wp_ih_18_24 0 0.5527291345142126
Vwn_ih_18_24 wn_ih_18_24 0 0.4472708654857874
Vwp_ih_19_24 wp_ih_19_24 0 0.30499401547268123
Vwn_ih_19_24 wn_ih_19_24 0 0.6950059845273188
Vwp_ih_20_24 wp_ih_20_24 0 0.42487568615662386
Vwn_ih_20_24 wn_ih_20_24 0 0.5751243138433761
Vwp_ih_21_24 wp_ih_21_24 0 0.6516398241751626
Vwn_ih_21_24 wn_ih_21_24 0 0.34836017582483736
Vwp_ih_22_24 wp_ih_22_24 0 0.48188013093562926
Vwn_ih_22_24 wn_ih_22_24 0 0.5181198690643707
Vwp_ih_23_24 wp_ih_23_24 0 0.5356110584806829
Vwn_ih_23_24 wn_ih_23_24 0 0.4643889415193171
Vwp_ih_24_24 wp_ih_24_24 0 0.4884337329117183
Vwn_ih_24_24 wn_ih_24_24 0 0.5115662670882817
Vwp_ih_25_24 wp_ih_25_24 0 0.44497904832340274
Vwn_ih_25_24 wn_ih_25_24 0 0.5550209516765973
Vwp_ih_26_24 wp_ih_26_24 0 0.3580850431194732
Vwn_ih_26_24 wn_ih_26_24 0 0.6419149568805268
Vwp_ih_27_24 wp_ih_27_24 0 0.38008085692816357
Vwn_ih_27_24 wn_ih_27_24 0 0.6199191430718364
Vwp_ih_28_24 wp_ih_28_24 0 0.6103714730286822
Vwn_ih_28_24 wn_ih_28_24 0 0.3896285269713178
Vwp_ih_29_24 wp_ih_29_24 0 0.45018109547074253
Vwn_ih_29_24 wn_ih_29_24 0 0.5498189045292575
Vwp_ih_30_24 wp_ih_30_24 0 0.3827888054540036
Vwn_ih_30_24 wn_ih_30_24 0 0.6172111945459964
Vwp_ih_31_24 wp_ih_31_24 0 0.421718122196339
Vwn_ih_31_24 wn_ih_31_24 0 0.578281877803661
Vwp_ih_32_24 wp_ih_32_24 0 0.578608575767999
Vwn_ih_32_24 wn_ih_32_24 0 0.42139142423200104
Vwp_ih_33_24 wp_ih_33_24 0 0.3960895626844245
Vwn_ih_33_24 wn_ih_33_24 0 0.6039104373155755
Vwp_ih_34_24 wp_ih_34_24 0 0.41464527900128234
Vwn_ih_34_24 wn_ih_34_24 0 0.5853547209987177
Vwp_ih_35_24 wp_ih_35_24 0 0.3842418494090951
Vwn_ih_35_24 wn_ih_35_24 0 0.6157581505909049
Vwp_ih_36_24 wp_ih_36_24 0 0.37301510777466607
Vwn_ih_36_24 wn_ih_36_24 0 0.6269848922253339
Vwp_ih_37_24 wp_ih_37_24 0 0.645436213985229
Vwn_ih_37_24 wn_ih_37_24 0 0.35456378601477095
Vwp_ih_38_24 wp_ih_38_24 0 0.485444903895829
Vwn_ih_38_24 wn_ih_38_24 0 0.5145550961041709
Vwp_ih_39_24 wp_ih_39_24 0 0.471064377363539
Vwn_ih_39_24 wn_ih_39_24 0 0.528935622636461
Vwp_ih_40_24 wp_ih_40_24 0 0.4534499927868628
Vwn_ih_40_24 wn_ih_40_24 0 0.5465500072131372
Vwp_ih_41_24 wp_ih_41_24 0 0.5503452041079983
Vwn_ih_41_24 wn_ih_41_24 0 0.4496547958920018
Vwp_ih_42_24 wp_ih_42_24 0 0.4687840741265381
Vwn_ih_42_24 wn_ih_42_24 0 0.5312159258734619
Vwp_ih_43_24 wp_ih_43_24 0 0.466657161467117
Vwn_ih_43_24 wn_ih_43_24 0 0.533342838532883
Vwp_ih_44_24 wp_ih_44_24 0 0.44538614974955454
Vwn_ih_44_24 wn_ih_44_24 0 0.5546138502504454
Vwp_ih_45_24 wp_ih_45_24 0 0.5111712464391123
Vwn_ih_45_24 wn_ih_45_24 0 0.48882875356088773
Vwp_ih_46_24 wp_ih_46_24 0 0.47428925524871324
Vwn_ih_46_24 wn_ih_46_24 0 0.5257107447512868
Vwp_ih_47_24 wp_ih_47_24 0 0.3521319326299008
Vwn_ih_47_24 wn_ih_47_24 0 0.6478680673700992
Vwp_ih_48_24 wp_ih_48_24 0 0.4566989538643271
Vwn_ih_48_24 wn_ih_48_24 0 0.5433010461356729
Vwp_ih_49_24 wp_ih_49_24 0 0.7342374044860113
Vwn_ih_49_24 wn_ih_49_24 0 0.3
Vwp_ih_50_24 wp_ih_50_24 0 0.4104333624965152
Vwn_ih_50_24 wn_ih_50_24 0 0.5895666375034848
Vwp_ih_51_24 wp_ih_51_24 0 0.4578223843842073
Vwn_ih_51_24 wn_ih_51_24 0 0.5421776156157927
Vwp_ih_52_24 wp_ih_52_24 0 0.5006905757761869
Vwn_ih_52_24 wn_ih_52_24 0 0.4993094242238131
Vwp_ih_53_24 wp_ih_53_24 0 0.6544565246621806
Vwn_ih_53_24 wn_ih_53_24 0 0.3455434753378194
Vwp_ih_54_24 wp_ih_54_24 0 0.7200712462756798
Vwn_ih_54_24 wn_ih_54_24 0 0.3
Vwp_ih_55_24 wp_ih_55_24 0 0.45287703908604277
Vwn_ih_55_24 wn_ih_55_24 0 0.5471229609139573
Vwp_ih_56_24 wp_ih_56_24 0 0.4232604474192446
Vwn_ih_56_24 wn_ih_56_24 0 0.5767395525807554
Vwp_ih_57_24 wp_ih_57_24 0 0.5680140813700764
Vwn_ih_57_24 wn_ih_57_24 0 0.43198591862992364
Vwp_ih_58_24 wp_ih_58_24 0 0.5380168948885877
Vwn_ih_58_24 wn_ih_58_24 0 0.4619831051114122
Vwp_ih_59_24 wp_ih_59_24 0 0.7012943201672015
Vwn_ih_59_24 wn_ih_59_24 0 0.3
Vwp_ih_60_24 wp_ih_60_24 0 0.5755954372821263
Vwn_ih_60_24 wn_ih_60_24 0 0.4244045627178738
Vwp_ih_61_24 wp_ih_61_24 0 0.43156801640480064
Vwn_ih_61_24 wn_ih_61_24 0 0.5684319835951994
Vwp_ih_62_24 wp_ih_62_24 0 0.4661515946279956
Vwn_ih_62_24 wn_ih_62_24 0 0.5338484053720044
Vwp_ih_63_24 wp_ih_63_24 0 0.5272064310644172
Vwn_ih_63_24 wn_ih_63_24 0 0.4727935689355828
Vwp_ho_24_0 wp_ho_24_0 0 0.5596123973714752
Vwn_ho_24_0 wn_ho_24_0 0 0.44038760262852483
Vwp_ho_24_1 wp_ho_24_1 0 0.4584243358825065
Vwn_ho_24_1 wn_ho_24_1 0 0.5415756641174935
Vwp_ho_24_2 wp_ho_24_2 0 0.7108219398310326
Vwn_ho_24_2 wn_ho_24_2 0 0.3
Vwp_ho_24_3 wp_ho_24_3 0 0.593684818623964
Vwn_ho_24_3 wn_ho_24_3 0 0.4063151813760359
Vwp_ho_24_4 wp_ho_24_4 0 0.5376396501216536
Vwn_ho_24_4 wn_ho_24_4 0 0.4623603498783464
Vwp_ih_0_25 wp_ih_0_25 0 0.5450619973330146
Vwn_ih_0_25 wn_ih_0_25 0 0.4549380026669853
Vwp_ih_1_25 wp_ih_1_25 0 0.4359486212306148
Vwn_ih_1_25 wn_ih_1_25 0 0.5640513787693853
Vwp_ih_2_25 wp_ih_2_25 0 0.3614188864764373
Vwn_ih_2_25 wn_ih_2_25 0 0.6385811135235627
Vwp_ih_3_25 wp_ih_3_25 0 0.33613148274059323
Vwn_ih_3_25 wn_ih_3_25 0 0.6638685172594068
Vwp_ih_4_25 wp_ih_4_25 0 0.5206081313251634
Vwn_ih_4_25 wn_ih_4_25 0 0.47939186867483663
Vwp_ih_5_25 wp_ih_5_25 0 0.48996019948538105
Vwn_ih_5_25 wn_ih_5_25 0 0.510039800514619
Vwp_ih_6_25 wp_ih_6_25 0 0.3370536779976885
Vwn_ih_6_25 wn_ih_6_25 0 0.6629463220023115
Vwp_ih_7_25 wp_ih_7_25 0 0.44053121507483495
Vwn_ih_7_25 wn_ih_7_25 0 0.559468784925165
Vwp_ih_8_25 wp_ih_8_25 0 0.3233966296456786
Vwn_ih_8_25 wn_ih_8_25 0 0.6766033703543214
Vwp_ih_9_25 wp_ih_9_25 0 0.4605902240503754
Vwn_ih_9_25 wn_ih_9_25 0 0.5394097759496246
Vwp_ih_10_25 wp_ih_10_25 0 0.4455213509167975
Vwn_ih_10_25 wn_ih_10_25 0 0.5544786490832025
Vwp_ih_11_25 wp_ih_11_25 0 0.46244440248003105
Vwn_ih_11_25 wn_ih_11_25 0 0.537555597519969
Vwp_ih_12_25 wp_ih_12_25 0 0.49940666074239826
Vwn_ih_12_25 wn_ih_12_25 0 0.5005933392576017
Vwp_ih_13_25 wp_ih_13_25 0 0.4900599957586148
Vwn_ih_13_25 wn_ih_13_25 0 0.5099400042413852
Vwp_ih_14_25 wp_ih_14_25 0 0.5288052722472454
Vwn_ih_14_25 wn_ih_14_25 0 0.4711947277527546
Vwp_ih_15_25 wp_ih_15_25 0 0.6033157266192557
Vwn_ih_15_25 wn_ih_15_25 0 0.39668427338074436
Vwp_ih_16_25 wp_ih_16_25 0 0.7149528497128781
Vwn_ih_16_25 wn_ih_16_25 0 0.3
Vwp_ih_17_25 wp_ih_17_25 0 0.5575427090362721
Vwn_ih_17_25 wn_ih_17_25 0 0.4424572909637279
Vwp_ih_18_25 wp_ih_18_25 0 0.4403826249212402
Vwn_ih_18_25 wn_ih_18_25 0 0.5596173750787599
Vwp_ih_19_25 wp_ih_19_25 0 0.5829809169871488
Vwn_ih_19_25 wn_ih_19_25 0 0.41701908301285123
Vwp_ih_20_25 wp_ih_20_25 0 0.48114442919768924
Vwn_ih_20_25 wn_ih_20_25 0 0.5188555708023107
Vwp_ih_21_25 wp_ih_21_25 0 0.4411872290504982
Vwn_ih_21_25 wn_ih_21_25 0 0.5588127709495019
Vwp_ih_22_25 wp_ih_22_25 0 0.4280211461647479
Vwn_ih_22_25 wn_ih_22_25 0 0.5719788538352522
Vwp_ih_23_25 wp_ih_23_25 0 0.5125258896984992
Vwn_ih_23_25 wn_ih_23_25 0 0.48747411030150073
Vwp_ih_24_25 wp_ih_24_25 0 0.6088242328952581
Vwn_ih_24_25 wn_ih_24_25 0 0.3911757671047419
Vwp_ih_25_25 wp_ih_25_25 0 0.700457708551472
Vwn_ih_25_25 wn_ih_25_25 0 0.3
Vwp_ih_26_25 wp_ih_26_25 0 0.5914236692708351
Vwn_ih_26_25 wn_ih_26_25 0 0.4085763307291649
Vwp_ih_27_25 wp_ih_27_25 0 0.5933340599044369
Vwn_ih_27_25 wn_ih_27_25 0 0.4066659400955631
Vwp_ih_28_25 wp_ih_28_25 0 0.46583806885040974
Vwn_ih_28_25 wn_ih_28_25 0 0.5341619311495903
Vwp_ih_29_25 wp_ih_29_25 0 0.5332957486957683
Vwn_ih_29_25 wn_ih_29_25 0 0.4667042513042317
Vwp_ih_30_25 wp_ih_30_25 0 0.5268275808607044
Vwn_ih_30_25 wn_ih_30_25 0 0.4731724191392957
Vwp_ih_31_25 wp_ih_31_25 0 0.4846934152376904
Vwn_ih_31_25 wn_ih_31_25 0 0.5153065847623096
Vwp_ih_32_25 wp_ih_32_25 0 0.6676575509368776
Vwn_ih_32_25 wn_ih_32_25 0 0.3323424490631224
Vwp_ih_33_25 wp_ih_33_25 0 0.42269941175623865
Vwn_ih_33_25 wn_ih_33_25 0 0.5773005882437613
Vwp_ih_34_25 wp_ih_34_25 0 0.4334170521027775
Vwn_ih_34_25 wn_ih_34_25 0 0.5665829478972225
Vwp_ih_35_25 wp_ih_35_25 0 0.5793831033972251
Vwn_ih_35_25 wn_ih_35_25 0 0.42061689660277485
Vwp_ih_36_25 wp_ih_36_25 0 0.7207048745233018
Vwn_ih_36_25 wn_ih_36_25 0 0.3
Vwp_ih_37_25 wp_ih_37_25 0 0.35920314770720235
Vwn_ih_37_25 wn_ih_37_25 0 0.6407968522927976
Vwp_ih_38_25 wp_ih_38_25 0 0.4134550955696103
Vwn_ih_38_25 wn_ih_38_25 0 0.5865449044303898
Vwp_ih_39_25 wp_ih_39_25 0 0.6159112710823165
Vwn_ih_39_25 wn_ih_39_25 0 0.38408872891768353
Vwp_ih_40_25 wp_ih_40_25 0 0.43754442756807954
Vwn_ih_40_25 wn_ih_40_25 0 0.5624555724319205
Vwp_ih_41_25 wp_ih_41_25 0 0.6555946184348963
Vwn_ih_41_25 wn_ih_41_25 0 0.3444053815651037
Vwp_ih_42_25 wp_ih_42_25 0 0.4230388256476809
Vwn_ih_42_25 wn_ih_42_25 0 0.5769611743523191
Vwp_ih_43_25 wp_ih_43_25 0 0.5871357211335858
Vwn_ih_43_25 wn_ih_43_25 0 0.4128642788664142
Vwp_ih_44_25 wp_ih_44_25 0 0.523444208482224
Vwn_ih_44_25 wn_ih_44_25 0 0.4765557915177761
Vwp_ih_45_25 wp_ih_45_25 0 0.5226697663462712
Vwn_ih_45_25 wn_ih_45_25 0 0.4773302336537288
Vwp_ih_46_25 wp_ih_46_25 0 0.42408405076285727
Vwn_ih_46_25 wn_ih_46_25 0 0.5759159492371427
Vwp_ih_47_25 wp_ih_47_25 0 0.34841914646615624
Vwn_ih_47_25 wn_ih_47_25 0 0.6515808535338438
Vwp_ih_48_25 wp_ih_48_25 0 0.5663252202481799
Vwn_ih_48_25 wn_ih_48_25 0 0.43367477975182006
Vwp_ih_49_25 wp_ih_49_25 0 0.4621146779289943
Vwn_ih_49_25 wn_ih_49_25 0 0.5378853220710057
Vwp_ih_50_25 wp_ih_50_25 0 0.43695108321021336
Vwn_ih_50_25 wn_ih_50_25 0 0.5630489167897866
Vwp_ih_51_25 wp_ih_51_25 0 0.42463225842593205
Vwn_ih_51_25 wn_ih_51_25 0 0.5753677415740679
Vwp_ih_52_25 wp_ih_52_25 0 0.45090450661564485
Vwn_ih_52_25 wn_ih_52_25 0 0.5490954933843551
Vwp_ih_53_25 wp_ih_53_25 0 0.5702955254102847
Vwn_ih_53_25 wn_ih_53_25 0 0.4297044745897153
Vwp_ih_54_25 wp_ih_54_25 0 0.41149787721667797
Vwn_ih_54_25 wn_ih_54_25 0 0.588502122783322
Vwp_ih_55_25 wp_ih_55_25 0 0.46115543704880435
Vwn_ih_55_25 wn_ih_55_25 0 0.5388445629511956
Vwp_ih_56_25 wp_ih_56_25 0 0.6751344675031156
Vwn_ih_56_25 wn_ih_56_25 0 0.32486553249688443
Vwp_ih_57_25 wp_ih_57_25 0 0.5227322268059351
Vwn_ih_57_25 wn_ih_57_25 0 0.4772677731940649
Vwp_ih_58_25 wp_ih_58_25 0 0.5131645016396362
Vwn_ih_58_25 wn_ih_58_25 0 0.4868354983603638
Vwp_ih_59_25 wp_ih_59_25 0 0.5038564429033711
Vwn_ih_59_25 wn_ih_59_25 0 0.49614355709662894
Vwp_ih_60_25 wp_ih_60_25 0 0.4327304715344327
Vwn_ih_60_25 wn_ih_60_25 0 0.5672695284655673
Vwp_ih_61_25 wp_ih_61_25 0 0.4257487043609365
Vwn_ih_61_25 wn_ih_61_25 0 0.5742512956390635
Vwp_ih_62_25 wp_ih_62_25 0 0.6044456316184984
Vwn_ih_62_25 wn_ih_62_25 0 0.3955543683815016
Vwp_ih_63_25 wp_ih_63_25 0 0.5279006321639755
Vwn_ih_63_25 wn_ih_63_25 0 0.47209936783602446
Vwp_ho_25_0 wp_ho_25_0 0 0.3
Vwn_ho_25_0 wn_ho_25_0 0 0.7234838654058211
Vwp_ho_25_1 wp_ho_25_1 0 0.3606948240381746
Vwn_ho_25_1 wn_ho_25_1 0 0.6393051759618253
Vwp_ho_25_2 wp_ho_25_2 0 0.3340790832220647
Vwn_ho_25_2 wn_ho_25_2 0 0.6659209167779353
Vwp_ho_25_3 wp_ho_25_3 0 0.6036030832709951
Vwn_ho_25_3 wn_ho_25_3 0 0.39639691672900484
Vwp_ho_25_4 wp_ho_25_4 0 0.4091069303870427
Vwn_ho_25_4 wn_ho_25_4 0 0.5908930696129573
Vwp_ih_0_26 wp_ih_0_26 0 0.4433455755800771
Vwn_ih_0_26 wn_ih_0_26 0 0.556654424419923
Vwp_ih_1_26 wp_ih_1_26 0 0.3442918500518436
Vwn_ih_1_26 wn_ih_1_26 0 0.6557081499481564
Vwp_ih_2_26 wp_ih_2_26 0 0.3635164302882732
Vwn_ih_2_26 wn_ih_2_26 0 0.6364835697117268
Vwp_ih_3_26 wp_ih_3_26 0 0.39300555302330475
Vwn_ih_3_26 wn_ih_3_26 0 0.6069944469766952
Vwp_ih_4_26 wp_ih_4_26 0 0.3296667894233367
Vwn_ih_4_26 wn_ih_4_26 0 0.6703332105766633
Vwp_ih_5_26 wp_ih_5_26 0 0.6321018368750833
Vwn_ih_5_26 wn_ih_5_26 0 0.3678981631249168
Vwp_ih_6_26 wp_ih_6_26 0 0.553126980529292
Vwn_ih_6_26 wn_ih_6_26 0 0.44687301947070796
Vwp_ih_7_26 wp_ih_7_26 0 0.56331229917728
Vwn_ih_7_26 wn_ih_7_26 0 0.43668770082272
Vwp_ih_8_26 wp_ih_8_26 0 0.3787999607473378
Vwn_ih_8_26 wn_ih_8_26 0 0.6212000392526622
Vwp_ih_9_26 wp_ih_9_26 0 0.4177881134502487
Vwn_ih_9_26 wn_ih_9_26 0 0.5822118865497513
Vwp_ih_10_26 wp_ih_10_26 0 0.4607693821216655
Vwn_ih_10_26 wn_ih_10_26 0 0.5392306178783345
Vwp_ih_11_26 wp_ih_11_26 0 0.5225306666838175
Vwn_ih_11_26 wn_ih_11_26 0 0.4774693333161825
Vwp_ih_12_26 wp_ih_12_26 0 0.4718634589257563
Vwn_ih_12_26 wn_ih_12_26 0 0.5281365410742437
Vwp_ih_13_26 wp_ih_13_26 0 0.41218051675703854
Vwn_ih_13_26 wn_ih_13_26 0 0.5878194832429615
Vwp_ih_14_26 wp_ih_14_26 0 0.6095010939143728
Vwn_ih_14_26 wn_ih_14_26 0 0.3904989060856272
Vwp_ih_15_26 wp_ih_15_26 0 0.5751995037393677
Vwn_ih_15_26 wn_ih_15_26 0 0.4248004962606323
Vwp_ih_16_26 wp_ih_16_26 0 0.5115033177372365
Vwn_ih_16_26 wn_ih_16_26 0 0.48849668226276355
Vwp_ih_17_26 wp_ih_17_26 0 0.5482556134885765
Vwn_ih_17_26 wn_ih_17_26 0 0.45174438651142346
Vwp_ih_18_26 wp_ih_18_26 0 0.6252701060206665
Vwn_ih_18_26 wn_ih_18_26 0 0.37472989397933354
Vwp_ih_19_26 wp_ih_19_26 0 0.6325031012685463
Vwn_ih_19_26 wn_ih_19_26 0 0.3674968987314537
Vwp_ih_20_26 wp_ih_20_26 0 0.4989994307254055
Vwn_ih_20_26 wn_ih_20_26 0 0.5010005692745946
Vwp_ih_21_26 wp_ih_21_26 0 0.47734073613655925
Vwn_ih_21_26 wn_ih_21_26 0 0.5226592638634407
Vwp_ih_22_26 wp_ih_22_26 0 0.4577342570148141
Vwn_ih_22_26 wn_ih_22_26 0 0.5422657429851859
Vwp_ih_23_26 wp_ih_23_26 0 0.5866459800620952
Vwn_ih_23_26 wn_ih_23_26 0 0.4133540199379047
Vwp_ih_24_26 wp_ih_24_26 0 0.4408764670675251
Vwn_ih_24_26 wn_ih_24_26 0 0.5591235329324749
Vwp_ih_25_26 wp_ih_25_26 0 0.4448205080881073
Vwn_ih_25_26 wn_ih_25_26 0 0.5551794919118928
Vwp_ih_26_26 wp_ih_26_26 0 0.6000168653116432
Vwn_ih_26_26 wn_ih_26_26 0 0.3999831346883568
Vwp_ih_27_26 wp_ih_27_26 0 0.5738589165064799
Vwn_ih_27_26 wn_ih_27_26 0 0.4261410834935201
Vwp_ih_28_26 wp_ih_28_26 0 0.5715750710697216
Vwn_ih_28_26 wn_ih_28_26 0 0.4284249289302784
Vwp_ih_29_26 wp_ih_29_26 0 0.44414926836364016
Vwn_ih_29_26 wn_ih_29_26 0 0.5558507316363599
Vwp_ih_30_26 wp_ih_30_26 0 0.5166335187888712
Vwn_ih_30_26 wn_ih_30_26 0 0.48336648121112885
Vwp_ih_31_26 wp_ih_31_26 0 0.5826066856964013
Vwn_ih_31_26 wn_ih_31_26 0 0.4173933143035987
Vwp_ih_32_26 wp_ih_32_26 0 0.4568151680135642
Vwn_ih_32_26 wn_ih_32_26 0 0.5431848319864359
Vwp_ih_33_26 wp_ih_33_26 0 0.48518920326980286
Vwn_ih_33_26 wn_ih_33_26 0 0.5148107967301971
Vwp_ih_34_26 wp_ih_34_26 0 0.4974202323772513
Vwn_ih_34_26 wn_ih_34_26 0 0.5025797676227487
Vwp_ih_35_26 wp_ih_35_26 0 0.6500195859494458
Vwn_ih_35_26 wn_ih_35_26 0 0.34998041405055424
Vwp_ih_36_26 wp_ih_36_26 0 0.6149571830374438
Vwn_ih_36_26 wn_ih_36_26 0 0.38504281696255616
Vwp_ih_37_26 wp_ih_37_26 0 0.39650074148015296
Vwn_ih_37_26 wn_ih_37_26 0 0.6034992585198471
Vwp_ih_38_26 wp_ih_38_26 0 0.36860507894691363
Vwn_ih_38_26 wn_ih_38_26 0 0.6313949210530864
Vwp_ih_39_26 wp_ih_39_26 0 0.5585099638561261
Vwn_ih_39_26 wn_ih_39_26 0 0.44149003614387394
Vwp_ih_40_26 wp_ih_40_26 0 0.48099055059729257
Vwn_ih_40_26 wn_ih_40_26 0 0.5190094494027074
Vwp_ih_41_26 wp_ih_41_26 0 0.543009072452421
Vwn_ih_41_26 wn_ih_41_26 0 0.45699092754757903
Vwp_ih_42_26 wp_ih_42_26 0 0.5349665418114216
Vwn_ih_42_26 wn_ih_42_26 0 0.46503345818857844
Vwp_ih_43_26 wp_ih_43_26 0 0.5971506306785173
Vwn_ih_43_26 wn_ih_43_26 0 0.4028493693214827
Vwp_ih_44_26 wp_ih_44_26 0 0.3822083447036754
Vwn_ih_44_26 wn_ih_44_26 0 0.6177916552963246
Vwp_ih_45_26 wp_ih_45_26 0 0.45451002793218426
Vwn_ih_45_26 wn_ih_45_26 0 0.5454899720678157
Vwp_ih_46_26 wp_ih_46_26 0 0.5028801168183108
Vwn_ih_46_26 wn_ih_46_26 0 0.4971198831816892
Vwp_ih_47_26 wp_ih_47_26 0 0.5317588228926455
Vwn_ih_47_26 wn_ih_47_26 0 0.4682411771073545
Vwp_ih_48_26 wp_ih_48_26 0 0.41469776965170596
Vwn_ih_48_26 wn_ih_48_26 0 0.5853022303482941
Vwp_ih_49_26 wp_ih_49_26 0 0.45818052966535455
Vwn_ih_49_26 wn_ih_49_26 0 0.5418194703346455
Vwp_ih_50_26 wp_ih_50_26 0 0.41350379100894497
Vwn_ih_50_26 wn_ih_50_26 0 0.586496208991055
Vwp_ih_51_26 wp_ih_51_26 0 0.46240747860272524
Vwn_ih_51_26 wn_ih_51_26 0 0.5375925213972748
Vwp_ih_52_26 wp_ih_52_26 0 0.5650734119047618
Vwn_ih_52_26 wn_ih_52_26 0 0.4349265880952382
Vwp_ih_53_26 wp_ih_53_26 0 0.4669885949621837
Vwn_ih_53_26 wn_ih_53_26 0 0.5330114050378163
Vwp_ih_54_26 wp_ih_54_26 0 0.4448128079067109
Vwn_ih_54_26 wn_ih_54_26 0 0.555187192093289
Vwp_ih_55_26 wp_ih_55_26 0 0.3241713333786306
Vwn_ih_55_26 wn_ih_55_26 0 0.6758286666213694
Vwp_ih_56_26 wp_ih_56_26 0 0.4073341678172343
Vwn_ih_56_26 wn_ih_56_26 0 0.5926658321827657
Vwp_ih_57_26 wp_ih_57_26 0 0.6232583266883012
Vwn_ih_57_26 wn_ih_57_26 0 0.37674167331169883
Vwp_ih_58_26 wp_ih_58_26 0 0.30934745962275545
Vwn_ih_58_26 wn_ih_58_26 0 0.6906525403772446
Vwp_ih_59_26 wp_ih_59_26 0 0.6082101847952873
Vwn_ih_59_26 wn_ih_59_26 0 0.3917898152047126
Vwp_ih_60_26 wp_ih_60_26 0 0.4761543368810996
Vwn_ih_60_26 wn_ih_60_26 0 0.5238456631189005
Vwp_ih_61_26 wp_ih_61_26 0 0.31259471364508834
Vwn_ih_61_26 wn_ih_61_26 0 0.6874052863549116
Vwp_ih_62_26 wp_ih_62_26 0 0.585699881440269
Vwn_ih_62_26 wn_ih_62_26 0 0.41430011855973103
Vwp_ih_63_26 wp_ih_63_26 0 0.6114558318639501
Vwn_ih_63_26 wn_ih_63_26 0 0.38854416813604986
Vwp_ho_26_0 wp_ho_26_0 0 0.6194031192302245
Vwn_ho_26_0 wn_ho_26_0 0 0.38059688076977555
Vwp_ho_26_1 wp_ho_26_1 0 0.600187271151572
Vwn_ho_26_1 wn_ho_26_1 0 0.39981272884842806
Vwp_ho_26_2 wp_ho_26_2 0 0.6725205749301821
Vwn_ho_26_2 wn_ho_26_2 0 0.3274794250698179
Vwp_ho_26_3 wp_ho_26_3 0 0.4731849780259767
Vwn_ho_26_3 wn_ho_26_3 0 0.5268150219740233
Vwp_ho_26_4 wp_ho_26_4 0 0.46547552493704225
Vwn_ho_26_4 wn_ho_26_4 0 0.5345244750629577
Vwp_ih_0_27 wp_ih_0_27 0 0.4547076599904588
Vwn_ih_0_27 wn_ih_0_27 0 0.5452923400095412
Vwp_ih_1_27 wp_ih_1_27 0 0.5540448760962103
Vwn_ih_1_27 wn_ih_1_27 0 0.44595512390378966
Vwp_ih_2_27 wp_ih_2_27 0 0.4547136384751857
Vwn_ih_2_27 wn_ih_2_27 0 0.5452863615248142
Vwp_ih_3_27 wp_ih_3_27 0 0.4956107692051567
Vwn_ih_3_27 wn_ih_3_27 0 0.5043892307948433
Vwp_ih_4_27 wp_ih_4_27 0 0.5116419467839871
Vwn_ih_4_27 wn_ih_4_27 0 0.4883580532160129
Vwp_ih_5_27 wp_ih_5_27 0 0.4792046176249433
Vwn_ih_5_27 wn_ih_5_27 0 0.5207953823750566
Vwp_ih_6_27 wp_ih_6_27 0 0.5720264201692633
Vwn_ih_6_27 wn_ih_6_27 0 0.4279735798307367
Vwp_ih_7_27 wp_ih_7_27 0 0.5442128610409507
Vwn_ih_7_27 wn_ih_7_27 0 0.4557871389590493
Vwp_ih_8_27 wp_ih_8_27 0 0.4475149378987128
Vwn_ih_8_27 wn_ih_8_27 0 0.5524850621012872
Vwp_ih_9_27 wp_ih_9_27 0 0.539033895682351
Vwn_ih_9_27 wn_ih_9_27 0 0.46096610431764895
Vwp_ih_10_27 wp_ih_10_27 0 0.463818930514189
Vwn_ih_10_27 wn_ih_10_27 0 0.536181069485811
Vwp_ih_11_27 wp_ih_11_27 0 0.5072752612399889
Vwn_ih_11_27 wn_ih_11_27 0 0.49272473876001116
Vwp_ih_12_27 wp_ih_12_27 0 0.439476764965403
Vwn_ih_12_27 wn_ih_12_27 0 0.560523235034597
Vwp_ih_13_27 wp_ih_13_27 0 0.4975756127066066
Vwn_ih_13_27 wn_ih_13_27 0 0.5024243872933933
Vwp_ih_14_27 wp_ih_14_27 0 0.6332209066932746
Vwn_ih_14_27 wn_ih_14_27 0 0.3667790933067254
Vwp_ih_15_27 wp_ih_15_27 0 0.4578017089134896
Vwn_ih_15_27 wn_ih_15_27 0 0.5421982910865104
Vwp_ih_16_27 wp_ih_16_27 0 0.3618423047876168
Vwn_ih_16_27 wn_ih_16_27 0 0.6381576952123832
Vwp_ih_17_27 wp_ih_17_27 0 0.6395773187357019
Vwn_ih_17_27 wn_ih_17_27 0 0.3604226812642981
Vwp_ih_18_27 wp_ih_18_27 0 0.5670278917067034
Vwn_ih_18_27 wn_ih_18_27 0 0.4329721082932966
Vwp_ih_19_27 wp_ih_19_27 0 0.47115488400297745
Vwn_ih_19_27 wn_ih_19_27 0 0.5288451159970226
Vwp_ih_20_27 wp_ih_20_27 0 0.4334619330426278
Vwn_ih_20_27 wn_ih_20_27 0 0.5665380669573722
Vwp_ih_21_27 wp_ih_21_27 0 0.4009807760294333
Vwn_ih_21_27 wn_ih_21_27 0 0.5990192239705667
Vwp_ih_22_27 wp_ih_22_27 0 0.6015179955482932
Vwn_ih_22_27 wn_ih_22_27 0 0.3984820044517068
Vwp_ih_23_27 wp_ih_23_27 0 0.5739560433235787
Vwn_ih_23_27 wn_ih_23_27 0 0.42604395667642125
Vwp_ih_24_27 wp_ih_24_27 0 0.5591066179933802
Vwn_ih_24_27 wn_ih_24_27 0 0.44089338200661976
Vwp_ih_25_27 wp_ih_25_27 0 0.4883395516348724
Vwn_ih_25_27 wn_ih_25_27 0 0.5116604483651276
Vwp_ih_26_27 wp_ih_26_27 0 0.37297256727114203
Vwn_ih_26_27 wn_ih_26_27 0 0.627027432728858
Vwp_ih_27_27 wp_ih_27_27 0 0.4044897028649585
Vwn_ih_27_27 wn_ih_27_27 0 0.5955102971350416
Vwp_ih_28_27 wp_ih_28_27 0 0.4772951980530045
Vwn_ih_28_27 wn_ih_28_27 0 0.5227048019469955
Vwp_ih_29_27 wp_ih_29_27 0 0.3
Vwn_ih_29_27 wn_ih_29_27 0 0.7048008431975981
Vwp_ih_30_27 wp_ih_30_27 0 0.5259672715387018
Vwn_ih_30_27 wn_ih_30_27 0 0.4740327284612982
Vwp_ih_31_27 wp_ih_31_27 0 0.41859476794506173
Vwn_ih_31_27 wn_ih_31_27 0 0.5814052320549383
Vwp_ih_32_27 wp_ih_32_27 0 0.556996433038816
Vwn_ih_32_27 wn_ih_32_27 0 0.443003566961184
Vwp_ih_33_27 wp_ih_33_27 0 0.45107522367211084
Vwn_ih_33_27 wn_ih_33_27 0 0.5489247763278892
Vwp_ih_34_27 wp_ih_34_27 0 0.6149366770476652
Vwn_ih_34_27 wn_ih_34_27 0 0.38506332295233475
Vwp_ih_35_27 wp_ih_35_27 0 0.5096583925184973
Vwn_ih_35_27 wn_ih_35_27 0 0.4903416074815027
Vwp_ih_36_27 wp_ih_36_27 0 0.5072100495695366
Vwn_ih_36_27 wn_ih_36_27 0 0.4927899504304633
Vwp_ih_37_27 wp_ih_37_27 0 0.4510664663874434
Vwn_ih_37_27 wn_ih_37_27 0 0.5489335336125566
Vwp_ih_38_27 wp_ih_38_27 0 0.5008543598721353
Vwn_ih_38_27 wn_ih_38_27 0 0.4991456401278646
Vwp_ih_39_27 wp_ih_39_27 0 0.7141354347734676
Vwn_ih_39_27 wn_ih_39_27 0 0.3
Vwp_ih_40_27 wp_ih_40_27 0 0.3819498266582827
Vwn_ih_40_27 wn_ih_40_27 0 0.6180501733417173
Vwp_ih_41_27 wp_ih_41_27 0 0.43421702049577965
Vwn_ih_41_27 wn_ih_41_27 0 0.5657829795042204
Vwp_ih_42_27 wp_ih_42_27 0 0.6249457483760444
Vwn_ih_42_27 wn_ih_42_27 0 0.37505425162395556
Vwp_ih_43_27 wp_ih_43_27 0 0.5518672189472245
Vwn_ih_43_27 wn_ih_43_27 0 0.4481327810527756
Vwp_ih_44_27 wp_ih_44_27 0 0.4294719051320961
Vwn_ih_44_27 wn_ih_44_27 0 0.5705280948679039
Vwp_ih_45_27 wp_ih_45_27 0 0.5911241216915926
Vwn_ih_45_27 wn_ih_45_27 0 0.40887587830840744
Vwp_ih_46_27 wp_ih_46_27 0 0.49592403364827725
Vwn_ih_46_27 wn_ih_46_27 0 0.5040759663517228
Vwp_ih_47_27 wp_ih_47_27 0 0.4480039067667501
Vwn_ih_47_27 wn_ih_47_27 0 0.5519960932332498
Vwp_ih_48_27 wp_ih_48_27 0 0.4445399063195444
Vwn_ih_48_27 wn_ih_48_27 0 0.5554600936804556
Vwp_ih_49_27 wp_ih_49_27 0 0.5976180861327212
Vwn_ih_49_27 wn_ih_49_27 0 0.40238191386727884
Vwp_ih_50_27 wp_ih_50_27 0 0.5039741202993306
Vwn_ih_50_27 wn_ih_50_27 0 0.4960258797006694
Vwp_ih_51_27 wp_ih_51_27 0 0.5896068111064761
Vwn_ih_51_27 wn_ih_51_27 0 0.41039318889352394
Vwp_ih_52_27 wp_ih_52_27 0 0.48590949150110935
Vwn_ih_52_27 wn_ih_52_27 0 0.5140905084988906
Vwp_ih_53_27 wp_ih_53_27 0 0.463991711617249
Vwn_ih_53_27 wn_ih_53_27 0 0.5360082883827509
Vwp_ih_54_27 wp_ih_54_27 0 0.6177866901653439
Vwn_ih_54_27 wn_ih_54_27 0 0.382213309834656
Vwp_ih_55_27 wp_ih_55_27 0 0.3757762562657633
Vwn_ih_55_27 wn_ih_55_27 0 0.6242237437342367
Vwp_ih_56_27 wp_ih_56_27 0 0.4609955122740021
Vwn_ih_56_27 wn_ih_56_27 0 0.5390044877259978
Vwp_ih_57_27 wp_ih_57_27 0 0.4154783880982734
Vwn_ih_57_27 wn_ih_57_27 0 0.5845216119017266
Vwp_ih_58_27 wp_ih_58_27 0 0.3756378247015558
Vwn_ih_58_27 wn_ih_58_27 0 0.6243621752984442
Vwp_ih_59_27 wp_ih_59_27 0 0.5395521990746659
Vwn_ih_59_27 wn_ih_59_27 0 0.4604478009253341
Vwp_ih_60_27 wp_ih_60_27 0 0.41453361964126345
Vwn_ih_60_27 wn_ih_60_27 0 0.5854663803587365
Vwp_ih_61_27 wp_ih_61_27 0 0.42804060003930555
Vwn_ih_61_27 wn_ih_61_27 0 0.5719593999606944
Vwp_ih_62_27 wp_ih_62_27 0 0.6094564746209092
Vwn_ih_62_27 wn_ih_62_27 0 0.3905435253790908
Vwp_ih_63_27 wp_ih_63_27 0 0.5903947850757274
Vwn_ih_63_27 wn_ih_63_27 0 0.4096052149242726
Vwp_ho_27_0 wp_ho_27_0 0 0.34730532584192975
Vwn_ho_27_0 wn_ho_27_0 0 0.6526946741580703
Vwp_ho_27_1 wp_ho_27_1 0 0.42262872401388574
Vwn_ho_27_1 wn_ho_27_1 0 0.5773712759861143
Vwp_ho_27_2 wp_ho_27_2 0 0.6382868930375043
Vwn_ho_27_2 wn_ho_27_2 0 0.3617131069624957
Vwp_ho_27_3 wp_ho_27_3 0 0.3229139125054745
Vwn_ho_27_3 wn_ho_27_3 0 0.6770860874945255
Vwp_ho_27_4 wp_ho_27_4 0 0.6976150356924672
Vwn_ho_27_4 wn_ho_27_4 0 0.3023849643075328
Vwp_ih_0_28 wp_ih_0_28 0 0.44407182076909835
Vwn_ih_0_28 wn_ih_0_28 0 0.5559281792309017
Vwp_ih_1_28 wp_ih_1_28 0 0.40700674080966315
Vwn_ih_1_28 wn_ih_1_28 0 0.5929932591903369
Vwp_ih_2_28 wp_ih_2_28 0 0.5065976653903834
Vwn_ih_2_28 wn_ih_2_28 0 0.4934023346096166
Vwp_ih_3_28 wp_ih_3_28 0 0.36928067017638044
Vwn_ih_3_28 wn_ih_3_28 0 0.6307193298236196
Vwp_ih_4_28 wp_ih_4_28 0 0.41467942992851053
Vwn_ih_4_28 wn_ih_4_28 0 0.5853205700714894
Vwp_ih_5_28 wp_ih_5_28 0 0.4535096247881847
Vwn_ih_5_28 wn_ih_5_28 0 0.5464903752118153
Vwp_ih_6_28 wp_ih_6_28 0 0.44402163826388635
Vwn_ih_6_28 wn_ih_6_28 0 0.5559783617361136
Vwp_ih_7_28 wp_ih_7_28 0 0.4218949918266914
Vwn_ih_7_28 wn_ih_7_28 0 0.5781050081733086
Vwp_ih_8_28 wp_ih_8_28 0 0.4713850872273122
Vwn_ih_8_28 wn_ih_8_28 0 0.5286149127726878
Vwp_ih_9_28 wp_ih_9_28 0 0.693721030645018
Vwn_ih_9_28 wn_ih_9_28 0 0.306278969354982
Vwp_ih_10_28 wp_ih_10_28 0 0.540432795001949
Vwn_ih_10_28 wn_ih_10_28 0 0.4595672049980511
Vwp_ih_11_28 wp_ih_11_28 0 0.5777684366689804
Vwn_ih_11_28 wn_ih_11_28 0 0.42223156333101963
Vwp_ih_12_28 wp_ih_12_28 0 0.5632062138530004
Vwn_ih_12_28 wn_ih_12_28 0 0.4367937861469996
Vwp_ih_13_28 wp_ih_13_28 0 0.5273406765208303
Vwn_ih_13_28 wn_ih_13_28 0 0.47265932347916967
Vwp_ih_14_28 wp_ih_14_28 0 0.37995244195212846
Vwn_ih_14_28 wn_ih_14_28 0 0.6200475580478715
Vwp_ih_15_28 wp_ih_15_28 0 0.3756073726488965
Vwn_ih_15_28 wn_ih_15_28 0 0.6243926273511035
Vwp_ih_16_28 wp_ih_16_28 0 0.4858763437448473
Vwn_ih_16_28 wn_ih_16_28 0 0.5141236562551527
Vwp_ih_17_28 wp_ih_17_28 0 0.5139557171639878
Vwn_ih_17_28 wn_ih_17_28 0 0.4860442828360122
Vwp_ih_18_28 wp_ih_18_28 0 0.4143722047263265
Vwn_ih_18_28 wn_ih_18_28 0 0.5856277952736735
Vwp_ih_19_28 wp_ih_19_28 0 0.5594830249220523
Vwn_ih_19_28 wn_ih_19_28 0 0.4405169750779477
Vwp_ih_20_28 wp_ih_20_28 0 0.6846894745827646
Vwn_ih_20_28 wn_ih_20_28 0 0.31531052541723537
Vwp_ih_21_28 wp_ih_21_28 0 0.48854794548082603
Vwn_ih_21_28 wn_ih_21_28 0 0.511452054519174
Vwp_ih_22_28 wp_ih_22_28 0 0.48372462969621105
Vwn_ih_22_28 wn_ih_22_28 0 0.516275370303789
Vwp_ih_23_28 wp_ih_23_28 0 0.45969967525775235
Vwn_ih_23_28 wn_ih_23_28 0 0.5403003247422477
Vwp_ih_24_28 wp_ih_24_28 0 0.430573994899587
Vwn_ih_24_28 wn_ih_24_28 0 0.5694260051004131
Vwp_ih_25_28 wp_ih_25_28 0 0.6405277974932181
Vwn_ih_25_28 wn_ih_25_28 0 0.3594722025067819
Vwp_ih_26_28 wp_ih_26_28 0 0.3363392089689706
Vwn_ih_26_28 wn_ih_26_28 0 0.6636607910310294
Vwp_ih_27_28 wp_ih_27_28 0 0.48652116917489907
Vwn_ih_27_28 wn_ih_27_28 0 0.5134788308251009
Vwp_ih_28_28 wp_ih_28_28 0 0.5190051433904119
Vwn_ih_28_28 wn_ih_28_28 0 0.4809948566095881
Vwp_ih_29_28 wp_ih_29_28 0 0.4705784001888829
Vwn_ih_29_28 wn_ih_29_28 0 0.5294215998111171
Vwp_ih_30_28 wp_ih_30_28 0 0.5867203734226969
Vwn_ih_30_28 wn_ih_30_28 0 0.41327962657730316
Vwp_ih_31_28 wp_ih_31_28 0 0.6014893286377263
Vwn_ih_31_28 wn_ih_31_28 0 0.39851067136227375
Vwp_ih_32_28 wp_ih_32_28 0 0.4873899202199009
Vwn_ih_32_28 wn_ih_32_28 0 0.5126100797800991
Vwp_ih_33_28 wp_ih_33_28 0 0.5664065740396578
Vwn_ih_33_28 wn_ih_33_28 0 0.4335934259603423
Vwp_ih_34_28 wp_ih_34_28 0 0.3958161058098503
Vwn_ih_34_28 wn_ih_34_28 0 0.6041838941901496
Vwp_ih_35_28 wp_ih_35_28 0 0.5213587200574701
Vwn_ih_35_28 wn_ih_35_28 0 0.4786412799425299
Vwp_ih_36_28 wp_ih_36_28 0 0.6801263116986316
Vwn_ih_36_28 wn_ih_36_28 0 0.3198736883013684
Vwp_ih_37_28 wp_ih_37_28 0 0.4195416374166645
Vwn_ih_37_28 wn_ih_37_28 0 0.5804583625833355
Vwp_ih_38_28 wp_ih_38_28 0 0.45374710458944956
Vwn_ih_38_28 wn_ih_38_28 0 0.5462528954105504
Vwp_ih_39_28 wp_ih_39_28 0 0.6348721941509439
Vwn_ih_39_28 wn_ih_39_28 0 0.36512780584905613
Vwp_ih_40_28 wp_ih_40_28 0 0.42018144713109684
Vwn_ih_40_28 wn_ih_40_28 0 0.5798185528689032
Vwp_ih_41_28 wp_ih_41_28 0 0.49961386076915043
Vwn_ih_41_28 wn_ih_41_28 0 0.5003861392308495
Vwp_ih_42_28 wp_ih_42_28 0 0.45400784863639454
Vwn_ih_42_28 wn_ih_42_28 0 0.5459921513636055
Vwp_ih_43_28 wp_ih_43_28 0 0.4274715120985193
Vwn_ih_43_28 wn_ih_43_28 0 0.5725284879014807
Vwp_ih_44_28 wp_ih_44_28 0 0.525903799404284
Vwn_ih_44_28 wn_ih_44_28 0 0.47409620059571606
Vwp_ih_45_28 wp_ih_45_28 0 0.384421034281675
Vwn_ih_45_28 wn_ih_45_28 0 0.615578965718325
Vwp_ih_46_28 wp_ih_46_28 0 0.6171490534203964
Vwn_ih_46_28 wn_ih_46_28 0 0.3828509465796036
Vwp_ih_47_28 wp_ih_47_28 0 0.48188975665762207
Vwn_ih_47_28 wn_ih_47_28 0 0.518110243342378
Vwp_ih_48_28 wp_ih_48_28 0 0.47557801444500836
Vwn_ih_48_28 wn_ih_48_28 0 0.5244219855549916
Vwp_ih_49_28 wp_ih_49_28 0 0.4868651947172758
Vwn_ih_49_28 wn_ih_49_28 0 0.5131348052827243
Vwp_ih_50_28 wp_ih_50_28 0 0.5030906439946349
Vwn_ih_50_28 wn_ih_50_28 0 0.4969093560053651
Vwp_ih_51_28 wp_ih_51_28 0 0.502501794324545
Vwn_ih_51_28 wn_ih_51_28 0 0.497498205675455
Vwp_ih_52_28 wp_ih_52_28 0 0.5067809741551491
Vwn_ih_52_28 wn_ih_52_28 0 0.4932190258448509
Vwp_ih_53_28 wp_ih_53_28 0 0.4763650066267481
Vwn_ih_53_28 wn_ih_53_28 0 0.5236349933732519
Vwp_ih_54_28 wp_ih_54_28 0 0.4967176087253148
Vwn_ih_54_28 wn_ih_54_28 0 0.5032823912746852
Vwp_ih_55_28 wp_ih_55_28 0 0.5208165420057452
Vwn_ih_55_28 wn_ih_55_28 0 0.4791834579942548
Vwp_ih_56_28 wp_ih_56_28 0 0.3024187084932237
Vwn_ih_56_28 wn_ih_56_28 0 0.6975812915067763
Vwp_ih_57_28 wp_ih_57_28 0 0.44846462492308203
Vwn_ih_57_28 wn_ih_57_28 0 0.551535375076918
Vwp_ih_58_28 wp_ih_58_28 0 0.5362917914011799
Vwn_ih_58_28 wn_ih_58_28 0 0.46370820859882006
Vwp_ih_59_28 wp_ih_59_28 0 0.5473027155212056
Vwn_ih_59_28 wn_ih_59_28 0 0.4526972844787944
Vwp_ih_60_28 wp_ih_60_28 0 0.49724869164738583
Vwn_ih_60_28 wn_ih_60_28 0 0.5027513083526142
Vwp_ih_61_28 wp_ih_61_28 0 0.5638945618630321
Vwn_ih_61_28 wn_ih_61_28 0 0.4361054381369679
Vwp_ih_62_28 wp_ih_62_28 0 0.5576257856797966
Vwn_ih_62_28 wn_ih_62_28 0 0.4423742143202034
Vwp_ih_63_28 wp_ih_63_28 0 0.3559899908750428
Vwn_ih_63_28 wn_ih_63_28 0 0.6440100091249572
Vwp_ho_28_0 wp_ho_28_0 0 0.4207317826075864
Vwn_ho_28_0 wn_ho_28_0 0 0.5792682173924135
Vwp_ho_28_1 wp_ho_28_1 0 0.35556042723573744
Vwn_ho_28_1 wn_ho_28_1 0 0.6444395727642626
Vwp_ho_28_2 wp_ho_28_2 0 0.5283667323721544
Vwn_ho_28_2 wn_ho_28_2 0 0.47163326762784563
Vwp_ho_28_3 wp_ho_28_3 0 0.44060459349059167
Vwn_ho_28_3 wn_ho_28_3 0 0.5593954065094083
Vwp_ho_28_4 wp_ho_28_4 0 0.5972792371654693
Vwn_ho_28_4 wn_ho_28_4 0 0.40272076283453073
Vwp_ih_0_29 wp_ih_0_29 0 0.5846423763076011
Vwn_ih_0_29 wn_ih_0_29 0 0.4153576236923989
Vwp_ih_1_29 wp_ih_1_29 0 0.5060824383325108
Vwn_ih_1_29 wn_ih_1_29 0 0.49391756166748924
Vwp_ih_2_29 wp_ih_2_29 0 0.4048452590412131
Vwn_ih_2_29 wn_ih_2_29 0 0.5951547409587868
Vwp_ih_3_29 wp_ih_3_29 0 0.6250289824806704
Vwn_ih_3_29 wn_ih_3_29 0 0.3749710175193296
Vwp_ih_4_29 wp_ih_4_29 0 0.5694232893673156
Vwn_ih_4_29 wn_ih_4_29 0 0.43057671063268443
Vwp_ih_5_29 wp_ih_5_29 0 0.4530743542455994
Vwn_ih_5_29 wn_ih_5_29 0 0.5469256457544006
Vwp_ih_6_29 wp_ih_6_29 0 0.6114093442754867
Vwn_ih_6_29 wn_ih_6_29 0 0.38859065572451335
Vwp_ih_7_29 wp_ih_7_29 0 0.5543308609122098
Vwn_ih_7_29 wn_ih_7_29 0 0.44566913908779016
Vwp_ih_8_29 wp_ih_8_29 0 0.5760723631118552
Vwn_ih_8_29 wn_ih_8_29 0 0.42392763688814483
Vwp_ih_9_29 wp_ih_9_29 0 0.4507766492289599
Vwn_ih_9_29 wn_ih_9_29 0 0.5492233507710401
Vwp_ih_10_29 wp_ih_10_29 0 0.44948047899388677
Vwn_ih_10_29 wn_ih_10_29 0 0.5505195210061132
Vwp_ih_11_29 wp_ih_11_29 0 0.41563327272546824
Vwn_ih_11_29 wn_ih_11_29 0 0.5843667272745318
Vwp_ih_12_29 wp_ih_12_29 0 0.4328095374379661
Vwn_ih_12_29 wn_ih_12_29 0 0.567190462562034
Vwp_ih_13_29 wp_ih_13_29 0 0.3
Vwn_ih_13_29 wn_ih_13_29 0 0.7039299072181536
Vwp_ih_14_29 wp_ih_14_29 0 0.5981672838714204
Vwn_ih_14_29 wn_ih_14_29 0 0.4018327161285796
Vwp_ih_15_29 wp_ih_15_29 0 0.399830870212408
Vwn_ih_15_29 wn_ih_15_29 0 0.6001691297875921
Vwp_ih_16_29 wp_ih_16_29 0 0.5520811771411616
Vwn_ih_16_29 wn_ih_16_29 0 0.44791882285883844
Vwp_ih_17_29 wp_ih_17_29 0 0.3798447510099795
Vwn_ih_17_29 wn_ih_17_29 0 0.6201552489900205
Vwp_ih_18_29 wp_ih_18_29 0 0.5160941500013698
Vwn_ih_18_29 wn_ih_18_29 0 0.4839058499986302
Vwp_ih_19_29 wp_ih_19_29 0 0.3975183425906843
Vwn_ih_19_29 wn_ih_19_29 0 0.6024816574093157
Vwp_ih_20_29 wp_ih_20_29 0 0.46810715187590646
Vwn_ih_20_29 wn_ih_20_29 0 0.5318928481240935
Vwp_ih_21_29 wp_ih_21_29 0 0.3484264435706568
Vwn_ih_21_29 wn_ih_21_29 0 0.6515735564293432
Vwp_ih_22_29 wp_ih_22_29 0 0.45956501513011094
Vwn_ih_22_29 wn_ih_22_29 0 0.5404349848698891
Vwp_ih_23_29 wp_ih_23_29 0 0.5651140621048217
Vwn_ih_23_29 wn_ih_23_29 0 0.43488593789517827
Vwp_ih_24_29 wp_ih_24_29 0 0.5208040516621664
Vwn_ih_24_29 wn_ih_24_29 0 0.47919594833783363
Vwp_ih_25_29 wp_ih_25_29 0 0.48713566348485093
Vwn_ih_25_29 wn_ih_25_29 0 0.5128643365151491
Vwp_ih_26_29 wp_ih_26_29 0 0.43867975969075346
Vwn_ih_26_29 wn_ih_26_29 0 0.5613202403092465
Vwp_ih_27_29 wp_ih_27_29 0 0.30654628977964105
Vwn_ih_27_29 wn_ih_27_29 0 0.693453710220359
Vwp_ih_28_29 wp_ih_28_29 0 0.4049560569640194
Vwn_ih_28_29 wn_ih_28_29 0 0.5950439430359806
Vwp_ih_29_29 wp_ih_29_29 0 0.4580195708005612
Vwn_ih_29_29 wn_ih_29_29 0 0.5419804291994388
Vwp_ih_30_29 wp_ih_30_29 0 0.6400625602739443
Vwn_ih_30_29 wn_ih_30_29 0 0.35993743972605574
Vwp_ih_31_29 wp_ih_31_29 0 0.5532917989359563
Vwn_ih_31_29 wn_ih_31_29 0 0.4467082010640437
Vwp_ih_32_29 wp_ih_32_29 0 0.5284816129803818
Vwn_ih_32_29 wn_ih_32_29 0 0.47151838701961823
Vwp_ih_33_29 wp_ih_33_29 0 0.4422360312329163
Vwn_ih_33_29 wn_ih_33_29 0 0.5577639687670837
Vwp_ih_34_29 wp_ih_34_29 0 0.44488482895314646
Vwn_ih_34_29 wn_ih_34_29 0 0.5551151710468535
Vwp_ih_35_29 wp_ih_35_29 0 0.5541137471845393
Vwn_ih_35_29 wn_ih_35_29 0 0.4458862528154606
Vwp_ih_36_29 wp_ih_36_29 0 0.46667247827566294
Vwn_ih_36_29 wn_ih_36_29 0 0.5333275217243371
Vwp_ih_37_29 wp_ih_37_29 0 0.4802533205624994
Vwn_ih_37_29 wn_ih_37_29 0 0.5197466794375005
Vwp_ih_38_29 wp_ih_38_29 0 0.6422138722013151
Vwn_ih_38_29 wn_ih_38_29 0 0.3577861277986849
Vwp_ih_39_29 wp_ih_39_29 0 0.4116362573232292
Vwn_ih_39_29 wn_ih_39_29 0 0.5883637426767707
Vwp_ih_40_29 wp_ih_40_29 0 0.49226578973559526
Vwn_ih_40_29 wn_ih_40_29 0 0.5077342102644048
Vwp_ih_41_29 wp_ih_41_29 0 0.4977623634022683
Vwn_ih_41_29 wn_ih_41_29 0 0.5022376365977317
Vwp_ih_42_29 wp_ih_42_29 0 0.43494699050684976
Vwn_ih_42_29 wn_ih_42_29 0 0.5650530094931503
Vwp_ih_43_29 wp_ih_43_29 0 0.3848173254069287
Vwn_ih_43_29 wn_ih_43_29 0 0.6151826745930713
Vwp_ih_44_29 wp_ih_44_29 0 0.6093550066092809
Vwn_ih_44_29 wn_ih_44_29 0 0.3906449933907192
Vwp_ih_45_29 wp_ih_45_29 0 0.39241583317462414
Vwn_ih_45_29 wn_ih_45_29 0 0.6075841668253759
Vwp_ih_46_29 wp_ih_46_29 0 0.39764518703072943
Vwn_ih_46_29 wn_ih_46_29 0 0.6023548129692705
Vwp_ih_47_29 wp_ih_47_29 0 0.5271937459337127
Vwn_ih_47_29 wn_ih_47_29 0 0.47280625406628723
Vwp_ih_48_29 wp_ih_48_29 0 0.3896491068306889
Vwn_ih_48_29 wn_ih_48_29 0 0.6103508931693111
Vwp_ih_49_29 wp_ih_49_29 0 0.4889643619495844
Vwn_ih_49_29 wn_ih_49_29 0 0.5110356380504155
Vwp_ih_50_29 wp_ih_50_29 0 0.4625619060673037
Vwn_ih_50_29 wn_ih_50_29 0 0.5374380939326964
Vwp_ih_51_29 wp_ih_51_29 0 0.46975558407556706
Vwn_ih_51_29 wn_ih_51_29 0 0.5302444159244329
Vwp_ih_52_29 wp_ih_52_29 0 0.46613553217958775
Vwn_ih_52_29 wn_ih_52_29 0 0.5338644678204123
Vwp_ih_53_29 wp_ih_53_29 0 0.385218599799712
Vwn_ih_53_29 wn_ih_53_29 0 0.6147814002002879
Vwp_ih_54_29 wp_ih_54_29 0 0.4475004122901534
Vwn_ih_54_29 wn_ih_54_29 0 0.5524995877098466
Vwp_ih_55_29 wp_ih_55_29 0 0.6021667527290555
Vwn_ih_55_29 wn_ih_55_29 0 0.3978332472709445
Vwp_ih_56_29 wp_ih_56_29 0 0.6058530125038216
Vwn_ih_56_29 wn_ih_56_29 0 0.3941469874961783
Vwp_ih_57_29 wp_ih_57_29 0 0.42782495108504653
Vwn_ih_57_29 wn_ih_57_29 0 0.5721750489149535
Vwp_ih_58_29 wp_ih_58_29 0 0.6009162931821681
Vwn_ih_58_29 wn_ih_58_29 0 0.3990837068178319
Vwp_ih_59_29 wp_ih_59_29 0 0.41256265506682716
Vwn_ih_59_29 wn_ih_59_29 0 0.5874373449331729
Vwp_ih_60_29 wp_ih_60_29 0 0.37998508406965026
Vwn_ih_60_29 wn_ih_60_29 0 0.6200149159303497
Vwp_ih_61_29 wp_ih_61_29 0 0.3204938221808643
Vwn_ih_61_29 wn_ih_61_29 0 0.6795061778191357
Vwp_ih_62_29 wp_ih_62_29 0 0.4230228004088322
Vwn_ih_62_29 wn_ih_62_29 0 0.5769771995911678
Vwp_ih_63_29 wp_ih_63_29 0 0.5504979528816716
Vwn_ih_63_29 wn_ih_63_29 0 0.44950204711832836
Vwp_ho_29_0 wp_ho_29_0 0 0.5089215583056524
Vwn_ho_29_0 wn_ho_29_0 0 0.49107844169434756
Vwp_ho_29_1 wp_ho_29_1 0 0.4937375134081441
Vwn_ho_29_1 wn_ho_29_1 0 0.5062624865918559
Vwp_ho_29_2 wp_ho_29_2 0 0.5370086361386541
Vwn_ho_29_2 wn_ho_29_2 0 0.4629913638613459
Vwp_ho_29_3 wp_ho_29_3 0 0.41674216152773813
Vwn_ho_29_3 wn_ho_29_3 0 0.5832578384722619
Vwp_ho_29_4 wp_ho_29_4 0 0.5681586778152999
Vwn_ho_29_4 wn_ho_29_4 0 0.43184132218470006
Vwp_ih_0_30 wp_ih_0_30 0 0.47070068627212214
Vwn_ih_0_30 wn_ih_0_30 0 0.5292993137278779
Vwp_ih_1_30 wp_ih_1_30 0 0.6496259770202204
Vwn_ih_1_30 wn_ih_1_30 0 0.35037402297977954
Vwp_ih_2_30 wp_ih_2_30 0 0.5988209083580673
Vwn_ih_2_30 wn_ih_2_30 0 0.4011790916419327
Vwp_ih_3_30 wp_ih_3_30 0 0.5130360438876466
Vwn_ih_3_30 wn_ih_3_30 0 0.48696395611235344
Vwp_ih_4_30 wp_ih_4_30 0 0.5111962469456587
Vwn_ih_4_30 wn_ih_4_30 0 0.48880375305434126
Vwp_ih_5_30 wp_ih_5_30 0 0.4655671386839195
Vwn_ih_5_30 wn_ih_5_30 0 0.5344328613160805
Vwp_ih_6_30 wp_ih_6_30 0 0.5699671603449854
Vwn_ih_6_30 wn_ih_6_30 0 0.43003283965501454
Vwp_ih_7_30 wp_ih_7_30 0 0.454993660913825
Vwn_ih_7_30 wn_ih_7_30 0 0.545006339086175
Vwp_ih_8_30 wp_ih_8_30 0 0.4934471514011857
Vwn_ih_8_30 wn_ih_8_30 0 0.5065528485988142
Vwp_ih_9_30 wp_ih_9_30 0 0.46690463061999027
Vwn_ih_9_30 wn_ih_9_30 0 0.5330953693800098
Vwp_ih_10_30 wp_ih_10_30 0 0.6381056258854182
Vwn_ih_10_30 wn_ih_10_30 0 0.3618943741145818
Vwp_ih_11_30 wp_ih_11_30 0 0.456190174273929
Vwn_ih_11_30 wn_ih_11_30 0 0.543809825726071
Vwp_ih_12_30 wp_ih_12_30 0 0.43982161304248024
Vwn_ih_12_30 wn_ih_12_30 0 0.5601783869575198
Vwp_ih_13_30 wp_ih_13_30 0 0.3605892088827267
Vwn_ih_13_30 wn_ih_13_30 0 0.6394107911172733
Vwp_ih_14_30 wp_ih_14_30 0 0.5495250059644681
Vwn_ih_14_30 wn_ih_14_30 0 0.45047499403553193
Vwp_ih_15_30 wp_ih_15_30 0 0.43583536991178606
Vwn_ih_15_30 wn_ih_15_30 0 0.5641646300882139
Vwp_ih_16_30 wp_ih_16_30 0 0.48962452764673325
Vwn_ih_16_30 wn_ih_16_30 0 0.5103754723532667
Vwp_ih_17_30 wp_ih_17_30 0 0.47691330204487686
Vwn_ih_17_30 wn_ih_17_30 0 0.5230866979551232
Vwp_ih_18_30 wp_ih_18_30 0 0.4696016603922729
Vwn_ih_18_30 wn_ih_18_30 0 0.5303983396077271
Vwp_ih_19_30 wp_ih_19_30 0 0.31747698637955346
Vwn_ih_19_30 wn_ih_19_30 0 0.6825230136204465
Vwp_ih_20_30 wp_ih_20_30 0 0.4948099700615979
Vwn_ih_20_30 wn_ih_20_30 0 0.5051900299384021
Vwp_ih_21_30 wp_ih_21_30 0 0.3833975090957134
Vwn_ih_21_30 wn_ih_21_30 0 0.6166024909042866
Vwp_ih_22_30 wp_ih_22_30 0 0.6636214219849453
Vwn_ih_22_30 wn_ih_22_30 0 0.33637857801505466
Vwp_ih_23_30 wp_ih_23_30 0 0.6092012903623499
Vwn_ih_23_30 wn_ih_23_30 0 0.39079870963765007
Vwp_ih_24_30 wp_ih_24_30 0 0.5366424962219111
Vwn_ih_24_30 wn_ih_24_30 0 0.4633575037780889
Vwp_ih_25_30 wp_ih_25_30 0 0.683470522519467
Vwn_ih_25_30 wn_ih_25_30 0 0.31652947748053295
Vwp_ih_26_30 wp_ih_26_30 0 0.5719685992750763
Vwn_ih_26_30 wn_ih_26_30 0 0.4280314007249237
Vwp_ih_27_30 wp_ih_27_30 0 0.40864778289840675
Vwn_ih_27_30 wn_ih_27_30 0 0.5913522171015932
Vwp_ih_28_30 wp_ih_28_30 0 0.4336598075904168
Vwn_ih_28_30 wn_ih_28_30 0 0.5663401924095832
Vwp_ih_29_30 wp_ih_29_30 0 0.5076712639949125
Vwn_ih_29_30 wn_ih_29_30 0 0.49232873600508753
Vwp_ih_30_30 wp_ih_30_30 0 0.4488400756541541
Vwn_ih_30_30 wn_ih_30_30 0 0.5511599243458459
Vwp_ih_31_30 wp_ih_31_30 0 0.5155852956023398
Vwn_ih_31_30 wn_ih_31_30 0 0.48441470439766016
Vwp_ih_32_30 wp_ih_32_30 0 0.42575619545124704
Vwn_ih_32_30 wn_ih_32_30 0 0.5742438045487529
Vwp_ih_33_30 wp_ih_33_30 0 0.6143920519341003
Vwn_ih_33_30 wn_ih_33_30 0 0.38560794806589965
Vwp_ih_34_30 wp_ih_34_30 0 0.42831235147955604
Vwn_ih_34_30 wn_ih_34_30 0 0.571687648520444
Vwp_ih_35_30 wp_ih_35_30 0 0.6039637898247885
Vwn_ih_35_30 wn_ih_35_30 0 0.39603621017521146
Vwp_ih_36_30 wp_ih_36_30 0 0.6581042140724097
Vwn_ih_36_30 wn_ih_36_30 0 0.3418957859275903
Vwp_ih_37_30 wp_ih_37_30 0 0.43170726986666086
Vwn_ih_37_30 wn_ih_37_30 0 0.5682927301333391
Vwp_ih_38_30 wp_ih_38_30 0 0.501632591417781
Vwn_ih_38_30 wn_ih_38_30 0 0.49836740858221895
Vwp_ih_39_30 wp_ih_39_30 0 0.6433680570876726
Vwn_ih_39_30 wn_ih_39_30 0 0.35663194291232736
Vwp_ih_40_30 wp_ih_40_30 0 0.6277731102088845
Vwn_ih_40_30 wn_ih_40_30 0 0.3722268897911155
Vwp_ih_41_30 wp_ih_41_30 0 0.5328084865503059
Vwn_ih_41_30 wn_ih_41_30 0 0.46719151344969406
Vwp_ih_42_30 wp_ih_42_30 0 0.5485110827982461
Vwn_ih_42_30 wn_ih_42_30 0 0.45148891720175394
Vwp_ih_43_30 wp_ih_43_30 0 0.5289455912816062
Vwn_ih_43_30 wn_ih_43_30 0 0.4710544087183937
Vwp_ih_44_30 wp_ih_44_30 0 0.6025680085021018
Vwn_ih_44_30 wn_ih_44_30 0 0.3974319914978982
Vwp_ih_45_30 wp_ih_45_30 0 0.49968048667042586
Vwn_ih_45_30 wn_ih_45_30 0 0.5003195133295741
Vwp_ih_46_30 wp_ih_46_30 0 0.5152156697209176
Vwn_ih_46_30 wn_ih_46_30 0 0.4847843302790824
Vwp_ih_47_30 wp_ih_47_30 0 0.45005367342836056
Vwn_ih_47_30 wn_ih_47_30 0 0.5499463265716394
Vwp_ih_48_30 wp_ih_48_30 0 0.37499134928074085
Vwn_ih_48_30 wn_ih_48_30 0 0.6250086507192592
Vwp_ih_49_30 wp_ih_49_30 0 0.48792261621942673
Vwn_ih_49_30 wn_ih_49_30 0 0.5120773837805732
Vwp_ih_50_30 wp_ih_50_30 0 0.6918384836494424
Vwn_ih_50_30 wn_ih_50_30 0 0.30816151635055755
Vwp_ih_51_30 wp_ih_51_30 0 0.4789120385853692
Vwn_ih_51_30 wn_ih_51_30 0 0.5210879614146308
Vwp_ih_52_30 wp_ih_52_30 0 0.4434737198648057
Vwn_ih_52_30 wn_ih_52_30 0 0.5565262801351942
Vwp_ih_53_30 wp_ih_53_30 0 0.466347406104962
Vwn_ih_53_30 wn_ih_53_30 0 0.533652593895038
Vwp_ih_54_30 wp_ih_54_30 0 0.5059250080258679
Vwn_ih_54_30 wn_ih_54_30 0 0.49407499197413207
Vwp_ih_55_30 wp_ih_55_30 0 0.4523986395354358
Vwn_ih_55_30 wn_ih_55_30 0 0.5476013604645642
Vwp_ih_56_30 wp_ih_56_30 0 0.5559230805169032
Vwn_ih_56_30 wn_ih_56_30 0 0.4440769194830968
Vwp_ih_57_30 wp_ih_57_30 0 0.5444194566825987
Vwn_ih_57_30 wn_ih_57_30 0 0.4555805433174013
Vwp_ih_58_30 wp_ih_58_30 0 0.6220057838832745
Vwn_ih_58_30 wn_ih_58_30 0 0.3779942161167254
Vwp_ih_59_30 wp_ih_59_30 0 0.590361499241499
Vwn_ih_59_30 wn_ih_59_30 0 0.40963850075850095
Vwp_ih_60_30 wp_ih_60_30 0 0.5589657176274045
Vwn_ih_60_30 wn_ih_60_30 0 0.44103428237259545
Vwp_ih_61_30 wp_ih_61_30 0 0.3395052621358303
Vwn_ih_61_30 wn_ih_61_30 0 0.6604947378641697
Vwp_ih_62_30 wp_ih_62_30 0 0.5504853469792973
Vwn_ih_62_30 wn_ih_62_30 0 0.44951465302070265
Vwp_ih_63_30 wp_ih_63_30 0 0.457409038455298
Vwn_ih_63_30 wn_ih_63_30 0 0.542590961544702
Vwp_ho_30_0 wp_ho_30_0 0 0.37207612676862906
Vwn_ho_30_0 wn_ho_30_0 0 0.627923873231371
Vwp_ho_30_1 wp_ho_30_1 0 0.6827929677527627
Vwn_ho_30_1 wn_ho_30_1 0 0.31720703224723734
Vwp_ho_30_2 wp_ho_30_2 0 0.48825679084618956
Vwn_ho_30_2 wn_ho_30_2 0 0.5117432091538104
Vwp_ho_30_3 wp_ho_30_3 0 0.4324640735932397
Vwn_ho_30_3 wn_ho_30_3 0 0.5675359264067603
Vwp_ho_30_4 wp_ho_30_4 0 0.39582040602264573
Vwn_ho_30_4 wn_ho_30_4 0 0.6041795939773542
Vwp_ih_0_31 wp_ih_0_31 0 0.5969955072098304
Vwn_ih_0_31 wn_ih_0_31 0 0.4030044927901696
Vwp_ih_1_31 wp_ih_1_31 0 0.463186816733975
Vwn_ih_1_31 wn_ih_1_31 0 0.536813183266025
Vwp_ih_2_31 wp_ih_2_31 0 0.37972582610285743
Vwn_ih_2_31 wn_ih_2_31 0 0.6202741738971426
Vwp_ih_3_31 wp_ih_3_31 0 0.459976363248229
Vwn_ih_3_31 wn_ih_3_31 0 0.540023636751771
Vwp_ih_4_31 wp_ih_4_31 0 0.4250416353654509
Vwn_ih_4_31 wn_ih_4_31 0 0.5749583646345491
Vwp_ih_5_31 wp_ih_5_31 0 0.48729462336958645
Vwn_ih_5_31 wn_ih_5_31 0 0.5127053766304135
Vwp_ih_6_31 wp_ih_6_31 0 0.5329074984694875
Vwn_ih_6_31 wn_ih_6_31 0 0.46709250153051257
Vwp_ih_7_31 wp_ih_7_31 0 0.6157709146465258
Vwn_ih_7_31 wn_ih_7_31 0 0.3842290853534743
Vwp_ih_8_31 wp_ih_8_31 0 0.5502695028310155
Vwn_ih_8_31 wn_ih_8_31 0 0.44973049716898456
Vwp_ih_9_31 wp_ih_9_31 0 0.5557863512863911
Vwn_ih_9_31 wn_ih_9_31 0 0.44421364871360886
Vwp_ih_10_31 wp_ih_10_31 0 0.5262574851100097
Vwn_ih_10_31 wn_ih_10_31 0 0.47374251488999036
Vwp_ih_11_31 wp_ih_11_31 0 0.46746030524421356
Vwn_ih_11_31 wn_ih_11_31 0 0.5325396947557864
Vwp_ih_12_31 wp_ih_12_31 0 0.6248487315716793
Vwn_ih_12_31 wn_ih_12_31 0 0.3751512684283207
Vwp_ih_13_31 wp_ih_13_31 0 0.46095865704255307
Vwn_ih_13_31 wn_ih_13_31 0 0.539041342957447
Vwp_ih_14_31 wp_ih_14_31 0 0.4738141716190339
Vwn_ih_14_31 wn_ih_14_31 0 0.5261858283809662
Vwp_ih_15_31 wp_ih_15_31 0 0.4630053873845737
Vwn_ih_15_31 wn_ih_15_31 0 0.5369946126154262
Vwp_ih_16_31 wp_ih_16_31 0 0.32547889498687677
Vwn_ih_16_31 wn_ih_16_31 0 0.6745211050131232
Vwp_ih_17_31 wp_ih_17_31 0 0.6383750620306687
Vwn_ih_17_31 wn_ih_17_31 0 0.3616249379693312
Vwp_ih_18_31 wp_ih_18_31 0 0.3679011185517086
Vwn_ih_18_31 wn_ih_18_31 0 0.6320988814482914
Vwp_ih_19_31 wp_ih_19_31 0 0.5603049207511119
Vwn_ih_19_31 wn_ih_19_31 0 0.43969507924888807
Vwp_ih_20_31 wp_ih_20_31 0 0.6849113095125752
Vwn_ih_20_31 wn_ih_20_31 0 0.3150886904874249
Vwp_ih_21_31 wp_ih_21_31 0 0.4983601426912288
Vwn_ih_21_31 wn_ih_21_31 0 0.5016398573087711
Vwp_ih_22_31 wp_ih_22_31 0 0.4531116615507209
Vwn_ih_22_31 wn_ih_22_31 0 0.5468883384492791
Vwp_ih_23_31 wp_ih_23_31 0 0.34457259157739345
Vwn_ih_23_31 wn_ih_23_31 0 0.6554274084226066
Vwp_ih_24_31 wp_ih_24_31 0 0.4801008909453149
Vwn_ih_24_31 wn_ih_24_31 0 0.5198991090546852
Vwp_ih_25_31 wp_ih_25_31 0 0.6511085450500864
Vwn_ih_25_31 wn_ih_25_31 0 0.3488914549499136
Vwp_ih_26_31 wp_ih_26_31 0 0.49618275334965545
Vwn_ih_26_31 wn_ih_26_31 0 0.5038172466503446
Vwp_ih_27_31 wp_ih_27_31 0 0.43108896776577527
Vwn_ih_27_31 wn_ih_27_31 0 0.5689110322342247
Vwp_ih_28_31 wp_ih_28_31 0 0.3577175199675926
Vwn_ih_28_31 wn_ih_28_31 0 0.6422824800324074
Vwp_ih_29_31 wp_ih_29_31 0 0.5889501850516076
Vwn_ih_29_31 wn_ih_29_31 0 0.4110498149483924
Vwp_ih_30_31 wp_ih_30_31 0 0.5069096745306946
Vwn_ih_30_31 wn_ih_30_31 0 0.4930903254693054
Vwp_ih_31_31 wp_ih_31_31 0 0.4723939409752173
Vwn_ih_31_31 wn_ih_31_31 0 0.5276060590247827
Vwp_ih_32_31 wp_ih_32_31 0 0.5938505477361526
Vwn_ih_32_31 wn_ih_32_31 0 0.4061494522638474
Vwp_ih_33_31 wp_ih_33_31 0 0.4614924441320534
Vwn_ih_33_31 wn_ih_33_31 0 0.5385075558679466
Vwp_ih_34_31 wp_ih_34_31 0 0.4731033595352162
Vwn_ih_34_31 wn_ih_34_31 0 0.5268966404647838
Vwp_ih_35_31 wp_ih_35_31 0 0.659882484607848
Vwn_ih_35_31 wn_ih_35_31 0 0.34011751539215196
Vwp_ih_36_31 wp_ih_36_31 0 0.4473620151925546
Vwn_ih_36_31 wn_ih_36_31 0 0.5526379848074454
Vwp_ih_37_31 wp_ih_37_31 0 0.4929197381102849
Vwn_ih_37_31 wn_ih_37_31 0 0.5070802618897151
Vwp_ih_38_31 wp_ih_38_31 0 0.4935074219499951
Vwn_ih_38_31 wn_ih_38_31 0 0.5064925780500049
Vwp_ih_39_31 wp_ih_39_31 0 0.508769783687899
Vwn_ih_39_31 wn_ih_39_31 0 0.491230216312101
Vwp_ih_40_31 wp_ih_40_31 0 0.4705902702336295
Vwn_ih_40_31 wn_ih_40_31 0 0.5294097297663705
Vwp_ih_41_31 wp_ih_41_31 0 0.3576986082697108
Vwn_ih_41_31 wn_ih_41_31 0 0.6423013917302892
Vwp_ih_42_31 wp_ih_42_31 0 0.4765553190979603
Vwn_ih_42_31 wn_ih_42_31 0 0.5234446809020398
Vwp_ih_43_31 wp_ih_43_31 0 0.4853258643693201
Vwn_ih_43_31 wn_ih_43_31 0 0.5146741356306799
Vwp_ih_44_31 wp_ih_44_31 0 0.49163451063118935
Vwn_ih_44_31 wn_ih_44_31 0 0.5083654893688107
Vwp_ih_45_31 wp_ih_45_31 0 0.44266411511147413
Vwn_ih_45_31 wn_ih_45_31 0 0.5573358848885259
Vwp_ih_46_31 wp_ih_46_31 0 0.36931798580444103
Vwn_ih_46_31 wn_ih_46_31 0 0.6306820141955589
Vwp_ih_47_31 wp_ih_47_31 0 0.43402017971953377
Vwn_ih_47_31 wn_ih_47_31 0 0.5659798202804662
Vwp_ih_48_31 wp_ih_48_31 0 0.537030949097716
Vwn_ih_48_31 wn_ih_48_31 0 0.46296905090228396
Vwp_ih_49_31 wp_ih_49_31 0 0.44822883001733776
Vwn_ih_49_31 wn_ih_49_31 0 0.5517711699826622
Vwp_ih_50_31 wp_ih_50_31 0 0.621443767548803
Vwn_ih_50_31 wn_ih_50_31 0 0.37855623245119696
Vwp_ih_51_31 wp_ih_51_31 0 0.5097926593383344
Vwn_ih_51_31 wn_ih_51_31 0 0.49020734066166566
Vwp_ih_52_31 wp_ih_52_31 0 0.4480431577317275
Vwn_ih_52_31 wn_ih_52_31 0 0.5519568422682726
Vwp_ih_53_31 wp_ih_53_31 0 0.4882029003188319
Vwn_ih_53_31 wn_ih_53_31 0 0.511797099681168
Vwp_ih_54_31 wp_ih_54_31 0 0.5266028477584134
Vwn_ih_54_31 wn_ih_54_31 0 0.47339715224158657
Vwp_ih_55_31 wp_ih_55_31 0 0.5295917726554308
Vwn_ih_55_31 wn_ih_55_31 0 0.4704082273445692
Vwp_ih_56_31 wp_ih_56_31 0 0.502158757203996
Vwn_ih_56_31 wn_ih_56_31 0 0.497841242796004
Vwp_ih_57_31 wp_ih_57_31 0 0.5717595362175647
Vwn_ih_57_31 wn_ih_57_31 0 0.42824046378243535
Vwp_ih_58_31 wp_ih_58_31 0 0.4468112892252266
Vwn_ih_58_31 wn_ih_58_31 0 0.5531887107747734
Vwp_ih_59_31 wp_ih_59_31 0 0.52517272688896
Vwn_ih_59_31 wn_ih_59_31 0 0.47482727311104
Vwp_ih_60_31 wp_ih_60_31 0 0.45571579470909274
Vwn_ih_60_31 wn_ih_60_31 0 0.5442842052909073
Vwp_ih_61_31 wp_ih_61_31 0 0.4503663320977211
Vwn_ih_61_31 wn_ih_61_31 0 0.549633667902279
Vwp_ih_62_31 wp_ih_62_31 0 0.5054493578008307
Vwn_ih_62_31 wn_ih_62_31 0 0.4945506421991693
Vwp_ih_63_31 wp_ih_63_31 0 0.4794235321849585
Vwn_ih_63_31 wn_ih_63_31 0 0.5205764678150415
Vwp_ho_31_0 wp_ho_31_0 0 0.705786010116965
Vwn_ho_31_0 wn_ho_31_0 0 0.3
Vwp_ho_31_1 wp_ho_31_1 0 0.6304345899573904
Vwn_ho_31_1 wn_ho_31_1 0 0.36956541004260957
Vwp_ho_31_2 wp_ho_31_2 0 0.4040035582696133
Vwn_ho_31_2 wn_ho_31_2 0 0.5959964417303867
Vwp_ho_31_3 wp_ho_31_3 0 0.3
Vwn_ho_31_3 wn_ho_31_3 0 0.7056242696088616
Vwp_ho_31_4 wp_ho_31_4 0 0.3509702417108142
Vwn_ho_31_4 wn_ho_31_4 0 0.6490297582891857
Vwp_ih_0_32 wp_ih_0_32 0 0.5181533796957906
Vwn_ih_0_32 wn_ih_0_32 0 0.48184662030420944
Vwp_ih_1_32 wp_ih_1_32 0 0.6680598016333428
Vwn_ih_1_32 wn_ih_1_32 0 0.3319401983666572
Vwp_ih_2_32 wp_ih_2_32 0 0.49554190676564946
Vwn_ih_2_32 wn_ih_2_32 0 0.5044580932343505
Vwp_ih_3_32 wp_ih_3_32 0 0.4621612520341993
Vwn_ih_3_32 wn_ih_3_32 0 0.5378387479658008
Vwp_ih_4_32 wp_ih_4_32 0 0.6174771905306333
Vwn_ih_4_32 wn_ih_4_32 0 0.3825228094693667
Vwp_ih_5_32 wp_ih_5_32 0 0.4814369332470771
Vwn_ih_5_32 wn_ih_5_32 0 0.518563066752923
Vwp_ih_6_32 wp_ih_6_32 0 0.4608592179519677
Vwn_ih_6_32 wn_ih_6_32 0 0.5391407820480323
Vwp_ih_7_32 wp_ih_7_32 0 0.4555280441599275
Vwn_ih_7_32 wn_ih_7_32 0 0.5444719558400725
Vwp_ih_8_32 wp_ih_8_32 0 0.6539920649040563
Vwn_ih_8_32 wn_ih_8_32 0 0.34600793509594374
Vwp_ih_9_32 wp_ih_9_32 0 0.4177571805525797
Vwn_ih_9_32 wn_ih_9_32 0 0.5822428194474203
Vwp_ih_10_32 wp_ih_10_32 0 0.4187829589983383
Vwn_ih_10_32 wn_ih_10_32 0 0.5812170410016617
Vwp_ih_11_32 wp_ih_11_32 0 0.4958375010453037
Vwn_ih_11_32 wn_ih_11_32 0 0.5041624989546962
Vwp_ih_12_32 wp_ih_12_32 0 0.6124305688280695
Vwn_ih_12_32 wn_ih_12_32 0 0.38756943117193055
Vwp_ih_13_32 wp_ih_13_32 0 0.4301559241793513
Vwn_ih_13_32 wn_ih_13_32 0 0.5698440758206487
Vwp_ih_14_32 wp_ih_14_32 0 0.6077749770496002
Vwn_ih_14_32 wn_ih_14_32 0 0.3922250229503999
Vwp_ih_15_32 wp_ih_15_32 0 0.4381247648037671
Vwn_ih_15_32 wn_ih_15_32 0 0.561875235196233
Vwp_ih_16_32 wp_ih_16_32 0 0.42353680693994045
Vwn_ih_16_32 wn_ih_16_32 0 0.5764631930600596
Vwp_ih_17_32 wp_ih_17_32 0 0.48049564151006635
Vwn_ih_17_32 wn_ih_17_32 0 0.5195043584899337
Vwp_ih_18_32 wp_ih_18_32 0 0.4858112840289369
Vwn_ih_18_32 wn_ih_18_32 0 0.5141887159710631
Vwp_ih_19_32 wp_ih_19_32 0 0.5441373686755997
Vwn_ih_19_32 wn_ih_19_32 0 0.45586263132440025
Vwp_ih_20_32 wp_ih_20_32 0 0.5437497109288231
Vwn_ih_20_32 wn_ih_20_32 0 0.45625028907117693
Vwp_ih_21_32 wp_ih_21_32 0 0.5251896288557905
Vwn_ih_21_32 wn_ih_21_32 0 0.47481037114420954
Vwp_ih_22_32 wp_ih_22_32 0 0.42923446072950394
Vwn_ih_22_32 wn_ih_22_32 0 0.570765539270496
Vwp_ih_23_32 wp_ih_23_32 0 0.382350578315212
Vwn_ih_23_32 wn_ih_23_32 0 0.617649421684788
Vwp_ih_24_32 wp_ih_24_32 0 0.642926898633971
Vwn_ih_24_32 wn_ih_24_32 0 0.357073101366029
Vwp_ih_25_32 wp_ih_25_32 0 0.3586405011808328
Vwn_ih_25_32 wn_ih_25_32 0 0.6413594988191672
Vwp_ih_26_32 wp_ih_26_32 0 0.39564297501683965
Vwn_ih_26_32 wn_ih_26_32 0 0.6043570249831604
Vwp_ih_27_32 wp_ih_27_32 0 0.40920834541578316
Vwn_ih_27_32 wn_ih_27_32 0 0.5907916545842169
Vwp_ih_28_32 wp_ih_28_32 0 0.5566814191839402
Vwn_ih_28_32 wn_ih_28_32 0 0.44331858081605974
Vwp_ih_29_32 wp_ih_29_32 0 0.49000583045378354
Vwn_ih_29_32 wn_ih_29_32 0 0.5099941695462165
Vwp_ih_30_32 wp_ih_30_32 0 0.4581014359325548
Vwn_ih_30_32 wn_ih_30_32 0 0.5418985640674452
Vwp_ih_31_32 wp_ih_31_32 0 0.4110120900637187
Vwn_ih_31_32 wn_ih_31_32 0 0.5889879099362814
Vwp_ih_32_32 wp_ih_32_32 0 0.4892114233470831
Vwn_ih_32_32 wn_ih_32_32 0 0.5107885766529169
Vwp_ih_33_32 wp_ih_33_32 0 0.4663564481509569
Vwn_ih_33_32 wn_ih_33_32 0 0.5336435518490431
Vwp_ih_34_32 wp_ih_34_32 0 0.5557396467007156
Vwn_ih_34_32 wn_ih_34_32 0 0.44426035329928437
Vwp_ih_35_32 wp_ih_35_32 0 0.5812580885606019
Vwn_ih_35_32 wn_ih_35_32 0 0.41874191143939815
Vwp_ih_36_32 wp_ih_36_32 0 0.63575721393508
Vwn_ih_36_32 wn_ih_36_32 0 0.36424278606491994
Vwp_ih_37_32 wp_ih_37_32 0 0.5333853504905486
Vwn_ih_37_32 wn_ih_37_32 0 0.4666146495094514
Vwp_ih_38_32 wp_ih_38_32 0 0.3753843668792194
Vwn_ih_38_32 wn_ih_38_32 0 0.6246156331207806
Vwp_ih_39_32 wp_ih_39_32 0 0.47044693719685166
Vwn_ih_39_32 wn_ih_39_32 0 0.5295530628031483
Vwp_ih_40_32 wp_ih_40_32 0 0.5679182194849386
Vwn_ih_40_32 wn_ih_40_32 0 0.43208178051506135
Vwp_ih_41_32 wp_ih_41_32 0 0.3829747581824123
Vwn_ih_41_32 wn_ih_41_32 0 0.6170252418175877
Vwp_ih_42_32 wp_ih_42_32 0 0.3729887464938214
Vwn_ih_42_32 wn_ih_42_32 0 0.6270112535061786
Vwp_ih_43_32 wp_ih_43_32 0 0.5192773538159562
Vwn_ih_43_32 wn_ih_43_32 0 0.4807226461840438
Vwp_ih_44_32 wp_ih_44_32 0 0.3468865415461067
Vwn_ih_44_32 wn_ih_44_32 0 0.6531134584538933
Vwp_ih_45_32 wp_ih_45_32 0 0.38677032118039245
Vwn_ih_45_32 wn_ih_45_32 0 0.6132296788196075
Vwp_ih_46_32 wp_ih_46_32 0 0.4157243902385986
Vwn_ih_46_32 wn_ih_46_32 0 0.5842756097614014
Vwp_ih_47_32 wp_ih_47_32 0 0.4380601101984764
Vwn_ih_47_32 wn_ih_47_32 0 0.5619398898015237
Vwp_ih_48_32 wp_ih_48_32 0 0.6094774915223434
Vwn_ih_48_32 wn_ih_48_32 0 0.39052250847765657
Vwp_ih_49_32 wp_ih_49_32 0 0.6745151577421307
Vwn_ih_49_32 wn_ih_49_32 0 0.3254848422578693
Vwp_ih_50_32 wp_ih_50_32 0 0.552639807767937
Vwn_ih_50_32 wn_ih_50_32 0 0.447360192232063
Vwp_ih_51_32 wp_ih_51_32 0 0.4384957526373101
Vwn_ih_51_32 wn_ih_51_32 0 0.5615042473626899
Vwp_ih_52_32 wp_ih_52_32 0 0.6103203236203698
Vwn_ih_52_32 wn_ih_52_32 0 0.3896796763796302
Vwp_ih_53_32 wp_ih_53_32 0 0.564394610163839
Vwn_ih_53_32 wn_ih_53_32 0 0.43560538983616104
Vwp_ih_54_32 wp_ih_54_32 0 0.5140170432699172
Vwn_ih_54_32 wn_ih_54_32 0 0.4859829567300829
Vwp_ih_55_32 wp_ih_55_32 0 0.5726731464113135
Vwn_ih_55_32 wn_ih_55_32 0 0.42732685358868655
Vwp_ih_56_32 wp_ih_56_32 0 0.44988113922885264
Vwn_ih_56_32 wn_ih_56_32 0 0.5501188607711474
Vwp_ih_57_32 wp_ih_57_32 0 0.500936009854019
Vwn_ih_57_32 wn_ih_57_32 0 0.499063990145981
Vwp_ih_58_32 wp_ih_58_32 0 0.5519004860719965
Vwn_ih_58_32 wn_ih_58_32 0 0.44809951392800346
Vwp_ih_59_32 wp_ih_59_32 0 0.576721010295053
Vwn_ih_59_32 wn_ih_59_32 0 0.42327898970494704
Vwp_ih_60_32 wp_ih_60_32 0 0.4879478133706865
Vwn_ih_60_32 wn_ih_60_32 0 0.5120521866293135
Vwp_ih_61_32 wp_ih_61_32 0 0.6039437260654527
Vwn_ih_61_32 wn_ih_61_32 0 0.39605627393454734
Vwp_ih_62_32 wp_ih_62_32 0 0.40738018700263345
Vwn_ih_62_32 wn_ih_62_32 0 0.5926198129973665
Vwp_ih_63_32 wp_ih_63_32 0 0.5359375007700049
Vwn_ih_63_32 wn_ih_63_32 0 0.4640624992299951
Vwp_ho_32_0 wp_ho_32_0 0 0.3686175016618606
Vwn_ho_32_0 wn_ho_32_0 0 0.6313824983381394
Vwp_ho_32_1 wp_ho_32_1 0 0.39756192851508715
Vwn_ho_32_1 wn_ho_32_1 0 0.6024380714849129
Vwp_ho_32_2 wp_ho_32_2 0 0.4332125028098008
Vwn_ho_32_2 wn_ho_32_2 0 0.5667874971901992
Vwp_ho_32_3 wp_ho_32_3 0 0.46883991835108607
Vwn_ho_32_3 wn_ho_32_3 0 0.5311600816489139
Vwp_ho_32_4 wp_ho_32_4 0 0.4834186111970147
Vwn_ho_32_4 wn_ho_32_4 0 0.5165813888029853
Vwp_ih_0_33 wp_ih_0_33 0 0.4569403701716873
Vwn_ih_0_33 wn_ih_0_33 0 0.5430596298283127
Vwp_ih_1_33 wp_ih_1_33 0 0.43062917324600336
Vwn_ih_1_33 wn_ih_1_33 0 0.5693708267539966
Vwp_ih_2_33 wp_ih_2_33 0 0.3
Vwn_ih_2_33 wn_ih_2_33 0 0.7396099780443883
Vwp_ih_3_33 wp_ih_3_33 0 0.3992984321515218
Vwn_ih_3_33 wn_ih_3_33 0 0.6007015678484782
Vwp_ih_4_33 wp_ih_4_33 0 0.3424270013780794
Vwn_ih_4_33 wn_ih_4_33 0 0.6575729986219205
Vwp_ih_5_33 wp_ih_5_33 0 0.5668490764277513
Vwn_ih_5_33 wn_ih_5_33 0 0.4331509235722487
Vwp_ih_6_33 wp_ih_6_33 0 0.4509092230297762
Vwn_ih_6_33 wn_ih_6_33 0 0.5490907769702238
Vwp_ih_7_33 wp_ih_7_33 0 0.5365619057427623
Vwn_ih_7_33 wn_ih_7_33 0 0.46343809425723764
Vwp_ih_8_33 wp_ih_8_33 0 0.5564594415770712
Vwn_ih_8_33 wn_ih_8_33 0 0.44354055842292883
Vwp_ih_9_33 wp_ih_9_33 0 0.39001057211269224
Vwn_ih_9_33 wn_ih_9_33 0 0.6099894278873078
Vwp_ih_10_33 wp_ih_10_33 0 0.37508527975120864
Vwn_ih_10_33 wn_ih_10_33 0 0.6249147202487914
Vwp_ih_11_33 wp_ih_11_33 0 0.6104183037963058
Vwn_ih_11_33 wn_ih_11_33 0 0.38958169620369415
Vwp_ih_12_33 wp_ih_12_33 0 0.5473847278167466
Vwn_ih_12_33 wn_ih_12_33 0 0.4526152721832533
Vwp_ih_13_33 wp_ih_13_33 0 0.4030234009928564
Vwn_ih_13_33 wn_ih_13_33 0 0.5969765990071436
Vwp_ih_14_33 wp_ih_14_33 0 0.5031650368591222
Vwn_ih_14_33 wn_ih_14_33 0 0.49683496314087777
Vwp_ih_15_33 wp_ih_15_33 0 0.4228264440684366
Vwn_ih_15_33 wn_ih_15_33 0 0.5771735559315634
Vwp_ih_16_33 wp_ih_16_33 0 0.5376550708989152
Vwn_ih_16_33 wn_ih_16_33 0 0.4623449291010848
Vwp_ih_17_33 wp_ih_17_33 0 0.5582123019579253
Vwn_ih_17_33 wn_ih_17_33 0 0.44178769804207474
Vwp_ih_18_33 wp_ih_18_33 0 0.4369497493150834
Vwn_ih_18_33 wn_ih_18_33 0 0.5630502506849167
Vwp_ih_19_33 wp_ih_19_33 0 0.5889991158018869
Vwn_ih_19_33 wn_ih_19_33 0 0.4110008841981131
Vwp_ih_20_33 wp_ih_20_33 0 0.3163424390708038
Vwn_ih_20_33 wn_ih_20_33 0 0.6836575609291962
Vwp_ih_21_33 wp_ih_21_33 0 0.5356572795631136
Vwn_ih_21_33 wn_ih_21_33 0 0.46434272043688646
Vwp_ih_22_33 wp_ih_22_33 0 0.35206635342678827
Vwn_ih_22_33 wn_ih_22_33 0 0.6479336465732117
Vwp_ih_23_33 wp_ih_23_33 0 0.6873868581094231
Vwn_ih_23_33 wn_ih_23_33 0 0.3126131418905769
Vwp_ih_24_33 wp_ih_24_33 0 0.5350685586621898
Vwn_ih_24_33 wn_ih_24_33 0 0.4649314413378101
Vwp_ih_25_33 wp_ih_25_33 0 0.47357338805379595
Vwn_ih_25_33 wn_ih_25_33 0 0.526426611946204
Vwp_ih_26_33 wp_ih_26_33 0 0.6380128838619777
Vwn_ih_26_33 wn_ih_26_33 0 0.36198711613802226
Vwp_ih_27_33 wp_ih_27_33 0 0.45667958373501427
Vwn_ih_27_33 wn_ih_27_33 0 0.5433204162649857
Vwp_ih_28_33 wp_ih_28_33 0 0.5100714747381543
Vwn_ih_28_33 wn_ih_28_33 0 0.48992852526184566
Vwp_ih_29_33 wp_ih_29_33 0 0.4976616067971484
Vwn_ih_29_33 wn_ih_29_33 0 0.5023383932028517
Vwp_ih_30_33 wp_ih_30_33 0 0.509036132167865
Vwn_ih_30_33 wn_ih_30_33 0 0.49096386783213497
Vwp_ih_31_33 wp_ih_31_33 0 0.4309339431272304
Vwn_ih_31_33 wn_ih_31_33 0 0.5690660568727697
Vwp_ih_32_33 wp_ih_32_33 0 0.5394325820291589
Vwn_ih_32_33 wn_ih_32_33 0 0.4605674179708411
Vwp_ih_33_33 wp_ih_33_33 0 0.42617892197300894
Vwn_ih_33_33 wn_ih_33_33 0 0.5738210780269911
Vwp_ih_34_33 wp_ih_34_33 0 0.5130916899964173
Vwn_ih_34_33 wn_ih_34_33 0 0.48690831000358265
Vwp_ih_35_33 wp_ih_35_33 0 0.5716646751100735
Vwn_ih_35_33 wn_ih_35_33 0 0.4283353248899265
Vwp_ih_36_33 wp_ih_36_33 0 0.4851708761843394
Vwn_ih_36_33 wn_ih_36_33 0 0.5148291238156606
Vwp_ih_37_33 wp_ih_37_33 0 0.5836968112288586
Vwn_ih_37_33 wn_ih_37_33 0 0.41630318877114136
Vwp_ih_38_33 wp_ih_38_33 0 0.5100239479154117
Vwn_ih_38_33 wn_ih_38_33 0 0.4899760520845883
Vwp_ih_39_33 wp_ih_39_33 0 0.47340290427482346
Vwn_ih_39_33 wn_ih_39_33 0 0.5265970957251765
Vwp_ih_40_33 wp_ih_40_33 0 0.47520559372805393
Vwn_ih_40_33 wn_ih_40_33 0 0.5247944062719461
Vwp_ih_41_33 wp_ih_41_33 0 0.49028822531610217
Vwn_ih_41_33 wn_ih_41_33 0 0.5097117746838978
Vwp_ih_42_33 wp_ih_42_33 0 0.5041155060355128
Vwn_ih_42_33 wn_ih_42_33 0 0.4958844939644872
Vwp_ih_43_33 wp_ih_43_33 0 0.48538814663118146
Vwn_ih_43_33 wn_ih_43_33 0 0.5146118533688185
Vwp_ih_44_33 wp_ih_44_33 0 0.5418131326449962
Vwn_ih_44_33 wn_ih_44_33 0 0.4581868673550038
Vwp_ih_45_33 wp_ih_45_33 0 0.4034037925785176
Vwn_ih_45_33 wn_ih_45_33 0 0.5965962074214823
Vwp_ih_46_33 wp_ih_46_33 0 0.46422278487090046
Vwn_ih_46_33 wn_ih_46_33 0 0.5357772151290995
Vwp_ih_47_33 wp_ih_47_33 0 0.6362722978397508
Vwn_ih_47_33 wn_ih_47_33 0 0.3637277021602492
Vwp_ih_48_33 wp_ih_48_33 0 0.5833859212071532
Vwn_ih_48_33 wn_ih_48_33 0 0.4166140787928468
Vwp_ih_49_33 wp_ih_49_33 0 0.5945164376005678
Vwn_ih_49_33 wn_ih_49_33 0 0.4054835623994321
Vwp_ih_50_33 wp_ih_50_33 0 0.533378151258793
Vwn_ih_50_33 wn_ih_50_33 0 0.4666218487412071
Vwp_ih_51_33 wp_ih_51_33 0 0.42531658188238003
Vwn_ih_51_33 wn_ih_51_33 0 0.5746834181176199
Vwp_ih_52_33 wp_ih_52_33 0 0.3951200477512965
Vwn_ih_52_33 wn_ih_52_33 0 0.6048799522487035
Vwp_ih_53_33 wp_ih_53_33 0 0.4034913789407816
Vwn_ih_53_33 wn_ih_53_33 0 0.5965086210592184
Vwp_ih_54_33 wp_ih_54_33 0 0.5201991666007421
Vwn_ih_54_33 wn_ih_54_33 0 0.4798008333992579
Vwp_ih_55_33 wp_ih_55_33 0 0.5941265106661429
Vwn_ih_55_33 wn_ih_55_33 0 0.40587348933385714
Vwp_ih_56_33 wp_ih_56_33 0 0.3710358609517951
Vwn_ih_56_33 wn_ih_56_33 0 0.6289641390482049
Vwp_ih_57_33 wp_ih_57_33 0 0.34866880828183633
Vwn_ih_57_33 wn_ih_57_33 0 0.6513311917181637
Vwp_ih_58_33 wp_ih_58_33 0 0.6008245634114069
Vwn_ih_58_33 wn_ih_58_33 0 0.3991754365885931
Vwp_ih_59_33 wp_ih_59_33 0 0.6020983853165167
Vwn_ih_59_33 wn_ih_59_33 0 0.3979016146834833
Vwp_ih_60_33 wp_ih_60_33 0 0.4185073400806983
Vwn_ih_60_33 wn_ih_60_33 0 0.5814926599193018
Vwp_ih_61_33 wp_ih_61_33 0 0.45975907058022236
Vwn_ih_61_33 wn_ih_61_33 0 0.5402409294197776
Vwp_ih_62_33 wp_ih_62_33 0 0.4073417062781758
Vwn_ih_62_33 wn_ih_62_33 0 0.5926582937218242
Vwp_ih_63_33 wp_ih_63_33 0 0.5625246006656307
Vwn_ih_63_33 wn_ih_63_33 0 0.4374753993343693
Vwp_ho_33_0 wp_ho_33_0 0 0.3136612203430805
Vwn_ho_33_0 wn_ho_33_0 0 0.6863387796569195
Vwp_ho_33_1 wp_ho_33_1 0 0.7800452694267866
Vwn_ho_33_1 wn_ho_33_1 0 0.3
Vwp_ho_33_2 wp_ho_33_2 0 0.4719908520400659
Vwn_ho_33_2 wn_ho_33_2 0 0.5280091479599341
Vwp_ho_33_3 wp_ho_33_3 0 0.534491858684725
Vwn_ho_33_3 wn_ho_33_3 0 0.46550814131527496
Vwp_ho_33_4 wp_ho_33_4 0 0.5964868713178135
Vwn_ho_33_4 wn_ho_33_4 0 0.4035131286821864
Vwp_ih_0_34 wp_ih_0_34 0 0.45608212791561853
Vwn_ih_0_34 wn_ih_0_34 0 0.5439178720843815
Vwp_ih_1_34 wp_ih_1_34 0 0.5159748058208544
Vwn_ih_1_34 wn_ih_1_34 0 0.4840251941791455
Vwp_ih_2_34 wp_ih_2_34 0 0.47709687915008003
Vwn_ih_2_34 wn_ih_2_34 0 0.52290312084992
Vwp_ih_3_34 wp_ih_3_34 0 0.5271560550767467
Vwn_ih_3_34 wn_ih_3_34 0 0.4728439449232533
Vwp_ih_4_34 wp_ih_4_34 0 0.581284170237962
Vwn_ih_4_34 wn_ih_4_34 0 0.4187158297620381
Vwp_ih_5_34 wp_ih_5_34 0 0.513979794849364
Vwn_ih_5_34 wn_ih_5_34 0 0.4860202051506361
Vwp_ih_6_34 wp_ih_6_34 0 0.42943539592942226
Vwn_ih_6_34 wn_ih_6_34 0 0.5705646040705777
Vwp_ih_7_34 wp_ih_7_34 0 0.6192230638609593
Vwn_ih_7_34 wn_ih_7_34 0 0.3807769361390408
Vwp_ih_8_34 wp_ih_8_34 0 0.47275166711983874
Vwn_ih_8_34 wn_ih_8_34 0 0.5272483328801613
Vwp_ih_9_34 wp_ih_9_34 0 0.5149991471089804
Vwn_ih_9_34 wn_ih_9_34 0 0.4850008528910196
Vwp_ih_10_34 wp_ih_10_34 0 0.45994156732242897
Vwn_ih_10_34 wn_ih_10_34 0 0.540058432677571
Vwp_ih_11_34 wp_ih_11_34 0 0.44954096197687105
Vwn_ih_11_34 wn_ih_11_34 0 0.550459038023129
Vwp_ih_12_34 wp_ih_12_34 0 0.5362283620847185
Vwn_ih_12_34 wn_ih_12_34 0 0.4637716379152816
Vwp_ih_13_34 wp_ih_13_34 0 0.47499306851268164
Vwn_ih_13_34 wn_ih_13_34 0 0.5250069314873184
Vwp_ih_14_34 wp_ih_14_34 0 0.47779282553873553
Vwn_ih_14_34 wn_ih_14_34 0 0.5222071744612645
Vwp_ih_15_34 wp_ih_15_34 0 0.47270004166154017
Vwn_ih_15_34 wn_ih_15_34 0 0.5272999583384598
Vwp_ih_16_34 wp_ih_16_34 0 0.6031034604619608
Vwn_ih_16_34 wn_ih_16_34 0 0.39689653953803916
Vwp_ih_17_34 wp_ih_17_34 0 0.40513949857405673
Vwn_ih_17_34 wn_ih_17_34 0 0.5948605014259433
Vwp_ih_18_34 wp_ih_18_34 0 0.4912275245986774
Vwn_ih_18_34 wn_ih_18_34 0 0.5087724754013226
Vwp_ih_19_34 wp_ih_19_34 0 0.49501837942406546
Vwn_ih_19_34 wn_ih_19_34 0 0.5049816205759345
Vwp_ih_20_34 wp_ih_20_34 0 0.40621055568390807
Vwn_ih_20_34 wn_ih_20_34 0 0.5937894443160919
Vwp_ih_21_34 wp_ih_21_34 0 0.4427497378189141
Vwn_ih_21_34 wn_ih_21_34 0 0.557250262181086
Vwp_ih_22_34 wp_ih_22_34 0 0.5359445879450824
Vwn_ih_22_34 wn_ih_22_34 0 0.46405541205491757
Vwp_ih_23_34 wp_ih_23_34 0 0.5470545999725864
Vwn_ih_23_34 wn_ih_23_34 0 0.4529454000274135
Vwp_ih_24_34 wp_ih_24_34 0 0.5147405343229225
Vwn_ih_24_34 wn_ih_24_34 0 0.48525946567707745
Vwp_ih_25_34 wp_ih_25_34 0 0.4790532300185865
Vwn_ih_25_34 wn_ih_25_34 0 0.5209467699814135
Vwp_ih_26_34 wp_ih_26_34 0 0.4650905732395229
Vwn_ih_26_34 wn_ih_26_34 0 0.534909426760477
Vwp_ih_27_34 wp_ih_27_34 0 0.6304689265221676
Vwn_ih_27_34 wn_ih_27_34 0 0.36953107347783243
Vwp_ih_28_34 wp_ih_28_34 0 0.42870673328618186
Vwn_ih_28_34 wn_ih_28_34 0 0.5712932667138182
Vwp_ih_29_34 wp_ih_29_34 0 0.5158799623418289
Vwn_ih_29_34 wn_ih_29_34 0 0.48412003765817113
Vwp_ih_30_34 wp_ih_30_34 0 0.4402965179337004
Vwn_ih_30_34 wn_ih_30_34 0 0.5597034820662996
Vwp_ih_31_34 wp_ih_31_34 0 0.6215856142118791
Vwn_ih_31_34 wn_ih_31_34 0 0.3784143857881209
Vwp_ih_32_34 wp_ih_32_34 0 0.5622399852200995
Vwn_ih_32_34 wn_ih_32_34 0 0.43776001477990045
Vwp_ih_33_34 wp_ih_33_34 0 0.461966659474293
Vwn_ih_33_34 wn_ih_33_34 0 0.538033340525707
Vwp_ih_34_34 wp_ih_34_34 0 0.5868369596132624
Vwn_ih_34_34 wn_ih_34_34 0 0.4131630403867376
Vwp_ih_35_34 wp_ih_35_34 0 0.6059102623791724
Vwn_ih_35_34 wn_ih_35_34 0 0.3940897376208276
Vwp_ih_36_34 wp_ih_36_34 0 0.49270529512062283
Vwn_ih_36_34 wn_ih_36_34 0 0.5072947048793772
Vwp_ih_37_34 wp_ih_37_34 0 0.34949187734924003
Vwn_ih_37_34 wn_ih_37_34 0 0.65050812265076
Vwp_ih_38_34 wp_ih_38_34 0 0.5473181101634469
Vwn_ih_38_34 wn_ih_38_34 0 0.45268188983655316
Vwp_ih_39_34 wp_ih_39_34 0 0.6662668374359526
Vwn_ih_39_34 wn_ih_39_34 0 0.3337331625640474
Vwp_ih_40_34 wp_ih_40_34 0 0.36468327354690383
Vwn_ih_40_34 wn_ih_40_34 0 0.6353167264530961
Vwp_ih_41_34 wp_ih_41_34 0 0.6439030930750326
Vwn_ih_41_34 wn_ih_41_34 0 0.3560969069249674
Vwp_ih_42_34 wp_ih_42_34 0 0.5002619431067789
Vwn_ih_42_34 wn_ih_42_34 0 0.49973805689322115
Vwp_ih_43_34 wp_ih_43_34 0 0.5006772091191917
Vwn_ih_43_34 wn_ih_43_34 0 0.49932279088080833
Vwp_ih_44_34 wp_ih_44_34 0 0.5751426528100424
Vwn_ih_44_34 wn_ih_44_34 0 0.4248573471899576
Vwp_ih_45_34 wp_ih_45_34 0 0.5095493688660221
Vwn_ih_45_34 wn_ih_45_34 0 0.49045063113397785
Vwp_ih_46_34 wp_ih_46_34 0 0.5324003321563098
Vwn_ih_46_34 wn_ih_46_34 0 0.4675996678436902
Vwp_ih_47_34 wp_ih_47_34 0 0.422166161885728
Vwn_ih_47_34 wn_ih_47_34 0 0.577833838114272
Vwp_ih_48_34 wp_ih_48_34 0 0.5032475970150752
Vwn_ih_48_34 wn_ih_48_34 0 0.49675240298492485
Vwp_ih_49_34 wp_ih_49_34 0 0.43358024208279966
Vwn_ih_49_34 wn_ih_49_34 0 0.5664197579172003
Vwp_ih_50_34 wp_ih_50_34 0 0.43844022545139943
Vwn_ih_50_34 wn_ih_50_34 0 0.5615597745486006
Vwp_ih_51_34 wp_ih_51_34 0 0.7206549167684227
Vwn_ih_51_34 wn_ih_51_34 0 0.3
Vwp_ih_52_34 wp_ih_52_34 0 0.3844787485083364
Vwn_ih_52_34 wn_ih_52_34 0 0.6155212514916636
Vwp_ih_53_34 wp_ih_53_34 0 0.5009995827036898
Vwn_ih_53_34 wn_ih_53_34 0 0.4990004172963102
Vwp_ih_54_34 wp_ih_54_34 0 0.505202595678403
Vwn_ih_54_34 wn_ih_54_34 0 0.494797404321597
Vwp_ih_55_34 wp_ih_55_34 0 0.37352378950157533
Vwn_ih_55_34 wn_ih_55_34 0 0.6264762104984247
Vwp_ih_56_34 wp_ih_56_34 0 0.40392340613800465
Vwn_ih_56_34 wn_ih_56_34 0 0.5960765938619954
Vwp_ih_57_34 wp_ih_57_34 0 0.3
Vwn_ih_57_34 wn_ih_57_34 0 0.7084113529268267
Vwp_ih_58_34 wp_ih_58_34 0 0.4348593285841976
Vwn_ih_58_34 wn_ih_58_34 0 0.5651406714158024
Vwp_ih_59_34 wp_ih_59_34 0 0.35700683772497716
Vwn_ih_59_34 wn_ih_59_34 0 0.6429931622750229
Vwp_ih_60_34 wp_ih_60_34 0 0.4012025479839457
Vwn_ih_60_34 wn_ih_60_34 0 0.5987974520160543
Vwp_ih_61_34 wp_ih_61_34 0 0.3454450033513524
Vwn_ih_61_34 wn_ih_61_34 0 0.6545549966486476
Vwp_ih_62_34 wp_ih_62_34 0 0.49405406852296047
Vwn_ih_62_34 wn_ih_62_34 0 0.5059459314770396
Vwp_ih_63_34 wp_ih_63_34 0 0.5475197648782781
Vwn_ih_63_34 wn_ih_63_34 0 0.45248023512172186
Vwp_ho_34_0 wp_ho_34_0 0 0.6008088480182567
Vwn_ho_34_0 wn_ho_34_0 0 0.39919115198174326
Vwp_ho_34_1 wp_ho_34_1 0 0.5987082730550025
Vwn_ho_34_1 wn_ho_34_1 0 0.40129172694499743
Vwp_ho_34_2 wp_ho_34_2 0 0.3302131377603686
Vwn_ho_34_2 wn_ho_34_2 0 0.6697868622396315
Vwp_ho_34_3 wp_ho_34_3 0 0.3660030770780943
Vwn_ho_34_3 wn_ho_34_3 0 0.6339969229219057
Vwp_ho_34_4 wp_ho_34_4 0 0.5606053109874214
Vwn_ho_34_4 wn_ho_34_4 0 0.43939468901257855
Vwp_ih_0_35 wp_ih_0_35 0 0.6337720851776296
Vwn_ih_0_35 wn_ih_0_35 0 0.3662279148223704
Vwp_ih_1_35 wp_ih_1_35 0 0.4711265965085538
Vwn_ih_1_35 wn_ih_1_35 0 0.5288734034914462
Vwp_ih_2_35 wp_ih_2_35 0 0.5591038135326215
Vwn_ih_2_35 wn_ih_2_35 0 0.44089618646737855
Vwp_ih_3_35 wp_ih_3_35 0 0.5452782993969015
Vwn_ih_3_35 wn_ih_3_35 0 0.4547217006030984
Vwp_ih_4_35 wp_ih_4_35 0 0.7058413776792961
Vwn_ih_4_35 wn_ih_4_35 0 0.3
Vwp_ih_5_35 wp_ih_5_35 0 0.4408876221374698
Vwn_ih_5_35 wn_ih_5_35 0 0.5591123778625302
Vwp_ih_6_35 wp_ih_6_35 0 0.49109435728758166
Vwn_ih_6_35 wn_ih_6_35 0 0.5089056427124183
Vwp_ih_7_35 wp_ih_7_35 0 0.4444539301085509
Vwn_ih_7_35 wn_ih_7_35 0 0.5555460698914492
Vwp_ih_8_35 wp_ih_8_35 0 0.3923231948258841
Vwn_ih_8_35 wn_ih_8_35 0 0.6076768051741158
Vwp_ih_9_35 wp_ih_9_35 0 0.4882500170194967
Vwn_ih_9_35 wn_ih_9_35 0 0.5117499829805032
Vwp_ih_10_35 wp_ih_10_35 0 0.5695070043561906
Vwn_ih_10_35 wn_ih_10_35 0 0.4304929956438094
Vwp_ih_11_35 wp_ih_11_35 0 0.43182947872534716
Vwn_ih_11_35 wn_ih_11_35 0 0.5681705212746528
Vwp_ih_12_35 wp_ih_12_35 0 0.40908524807115854
Vwn_ih_12_35 wn_ih_12_35 0 0.5909147519288415
Vwp_ih_13_35 wp_ih_13_35 0 0.48534828817907405
Vwn_ih_13_35 wn_ih_13_35 0 0.514651711820926
Vwp_ih_14_35 wp_ih_14_35 0 0.5512475618789953
Vwn_ih_14_35 wn_ih_14_35 0 0.44875243812100474
Vwp_ih_15_35 wp_ih_15_35 0 0.5525066691700697
Vwn_ih_15_35 wn_ih_15_35 0 0.4474933308299303
Vwp_ih_16_35 wp_ih_16_35 0 0.4981103774916085
Vwn_ih_16_35 wn_ih_16_35 0 0.5018896225083914
Vwp_ih_17_35 wp_ih_17_35 0 0.5274253012502317
Vwn_ih_17_35 wn_ih_17_35 0 0.4725746987497683
Vwp_ih_18_35 wp_ih_18_35 0 0.5536334000246341
Vwn_ih_18_35 wn_ih_18_35 0 0.4463665999753659
Vwp_ih_19_35 wp_ih_19_35 0 0.3595602103804315
Vwn_ih_19_35 wn_ih_19_35 0 0.6404397896195685
Vwp_ih_20_35 wp_ih_20_35 0 0.511634912645648
Vwn_ih_20_35 wn_ih_20_35 0 0.488365087354352
Vwp_ih_21_35 wp_ih_21_35 0 0.44024363951732176
Vwn_ih_21_35 wn_ih_21_35 0 0.5597563604826782
Vwp_ih_22_35 wp_ih_22_35 0 0.3995512976605097
Vwn_ih_22_35 wn_ih_22_35 0 0.6004487023394903
Vwp_ih_23_35 wp_ih_23_35 0 0.5785692720366115
Vwn_ih_23_35 wn_ih_23_35 0 0.42143072796338854
Vwp_ih_24_35 wp_ih_24_35 0 0.42056811464561783
Vwn_ih_24_35 wn_ih_24_35 0 0.5794318853543822
Vwp_ih_25_35 wp_ih_25_35 0 0.37590805456231235
Vwn_ih_25_35 wn_ih_25_35 0 0.6240919454376876
Vwp_ih_26_35 wp_ih_26_35 0 0.5083567108619771
Vwn_ih_26_35 wn_ih_26_35 0 0.4916432891380229
Vwp_ih_27_35 wp_ih_27_35 0 0.6902754867301456
Vwn_ih_27_35 wn_ih_27_35 0 0.3097245132698544
Vwp_ih_28_35 wp_ih_28_35 0 0.3
Vwn_ih_28_35 wn_ih_28_35 0 0.7117049801266624
Vwp_ih_29_35 wp_ih_29_35 0 0.4048153064069751
Vwn_ih_29_35 wn_ih_29_35 0 0.595184693593025
Vwp_ih_30_35 wp_ih_30_35 0 0.333789015850854
Vwn_ih_30_35 wn_ih_30_35 0 0.6662109841491459
Vwp_ih_31_35 wp_ih_31_35 0 0.4020745116066915
Vwn_ih_31_35 wn_ih_31_35 0 0.5979254883933085
Vwp_ih_32_35 wp_ih_32_35 0 0.4866295180972249
Vwn_ih_32_35 wn_ih_32_35 0 0.5133704819027751
Vwp_ih_33_35 wp_ih_33_35 0 0.34281941133177574
Vwn_ih_33_35 wn_ih_33_35 0 0.6571805886682243
Vwp_ih_34_35 wp_ih_34_35 0 0.5495758834105879
Vwn_ih_34_35 wn_ih_34_35 0 0.450424116589412
Vwp_ih_35_35 wp_ih_35_35 0 0.5824481428769556
Vwn_ih_35_35 wn_ih_35_35 0 0.41755185712304443
Vwp_ih_36_35 wp_ih_36_35 0 0.5619466363444063
Vwn_ih_36_35 wn_ih_36_35 0 0.43805336365559366
Vwp_ih_37_35 wp_ih_37_35 0 0.7054442561766063
Vwn_ih_37_35 wn_ih_37_35 0 0.3
Vwp_ih_38_35 wp_ih_38_35 0 0.4501263269679139
Vwn_ih_38_35 wn_ih_38_35 0 0.5498736730320861
Vwp_ih_39_35 wp_ih_39_35 0 0.4567156964853087
Vwn_ih_39_35 wn_ih_39_35 0 0.5432843035146913
Vwp_ih_40_35 wp_ih_40_35 0 0.4564522228153866
Vwn_ih_40_35 wn_ih_40_35 0 0.5435477771846133
Vwp_ih_41_35 wp_ih_41_35 0 0.41725746862656615
Vwn_ih_41_35 wn_ih_41_35 0 0.5827425313734338
Vwp_ih_42_35 wp_ih_42_35 0 0.4599633895896327
Vwn_ih_42_35 wn_ih_42_35 0 0.5400366104103673
Vwp_ih_43_35 wp_ih_43_35 0 0.47445849939190815
Vwn_ih_43_35 wn_ih_43_35 0 0.5255415006080919
Vwp_ih_44_35 wp_ih_44_35 0 0.43992028275021505
Vwn_ih_44_35 wn_ih_44_35 0 0.560079717249785
Vwp_ih_45_35 wp_ih_45_35 0 0.6927017046133198
Vwn_ih_45_35 wn_ih_45_35 0 0.3072982953866802
Vwp_ih_46_35 wp_ih_46_35 0 0.530878342217469
Vwn_ih_46_35 wn_ih_46_35 0 0.469121657782531
Vwp_ih_47_35 wp_ih_47_35 0 0.512809020628334
Vwn_ih_47_35 wn_ih_47_35 0 0.487190979371666
Vwp_ih_48_35 wp_ih_48_35 0 0.42746786406634674
Vwn_ih_48_35 wn_ih_48_35 0 0.5725321359336533
Vwp_ih_49_35 wp_ih_49_35 0 0.578825450329765
Vwn_ih_49_35 wn_ih_49_35 0 0.4211745496702351
Vwp_ih_50_35 wp_ih_50_35 0 0.5062249440781856
Vwn_ih_50_35 wn_ih_50_35 0 0.49377505592181437
Vwp_ih_51_35 wp_ih_51_35 0 0.4453361964110954
Vwn_ih_51_35 wn_ih_51_35 0 0.5546638035889047
Vwp_ih_52_35 wp_ih_52_35 0 0.3
Vwn_ih_52_35 wn_ih_52_35 0 0.7284018297010906
Vwp_ih_53_35 wp_ih_53_35 0 0.47234357479881567
Vwn_ih_53_35 wn_ih_53_35 0 0.5276564252011844
Vwp_ih_54_35 wp_ih_54_35 0 0.5215068232805575
Vwn_ih_54_35 wn_ih_54_35 0 0.47849317671944247
Vwp_ih_55_35 wp_ih_55_35 0 0.4626668474262461
Vwn_ih_55_35 wn_ih_55_35 0 0.5373331525737539
Vwp_ih_56_35 wp_ih_56_35 0 0.49747347902073946
Vwn_ih_56_35 wn_ih_56_35 0 0.5025265209792605
Vwp_ih_57_35 wp_ih_57_35 0 0.5456061864104274
Vwn_ih_57_35 wn_ih_57_35 0 0.45439381358957265
Vwp_ih_58_35 wp_ih_58_35 0 0.3241418370164562
Vwn_ih_58_35 wn_ih_58_35 0 0.6758581629835438
Vwp_ih_59_35 wp_ih_59_35 0 0.5297466763681774
Vwn_ih_59_35 wn_ih_59_35 0 0.47025332363182254
Vwp_ih_60_35 wp_ih_60_35 0 0.3
Vwn_ih_60_35 wn_ih_60_35 0 0.7170296288049203
Vwp_ih_61_35 wp_ih_61_35 0 0.44330924555413287
Vwn_ih_61_35 wn_ih_61_35 0 0.5566907544458671
Vwp_ih_62_35 wp_ih_62_35 0 0.4687748171901599
Vwn_ih_62_35 wn_ih_62_35 0 0.5312251828098401
Vwp_ih_63_35 wp_ih_63_35 0 0.42617838030399263
Vwn_ih_63_35 wn_ih_63_35 0 0.5738216196960073
Vwp_ho_35_0 wp_ho_35_0 0 0.6337021714962855
Vwn_ho_35_0 wn_ho_35_0 0 0.3662978285037145
Vwp_ho_35_1 wp_ho_35_1 0 0.5961692677933075
Vwn_ho_35_1 wn_ho_35_1 0 0.40383073220669247
Vwp_ho_35_2 wp_ho_35_2 0 0.735566481253648
Vwn_ho_35_2 wn_ho_35_2 0 0.3
Vwp_ho_35_3 wp_ho_35_3 0 0.8807329232193088
Vwn_ho_35_3 wn_ho_35_3 0 0.3
Vwp_ho_35_4 wp_ho_35_4 0 0.645917281128422
Vwn_ho_35_4 wn_ho_35_4 0 0.35408271887157805
Vwp_ih_0_36 wp_ih_0_36 0 0.542043437098436
Vwn_ih_0_36 wn_ih_0_36 0 0.457956562901564
Vwp_ih_1_36 wp_ih_1_36 0 0.5466463173146242
Vwn_ih_1_36 wn_ih_1_36 0 0.45335368268537585
Vwp_ih_2_36 wp_ih_2_36 0 0.4631660910130993
Vwn_ih_2_36 wn_ih_2_36 0 0.5368339089869008
Vwp_ih_3_36 wp_ih_3_36 0 0.4312016307824849
Vwn_ih_3_36 wn_ih_3_36 0 0.5687983692175151
Vwp_ih_4_36 wp_ih_4_36 0 0.5264390336933032
Vwn_ih_4_36 wn_ih_4_36 0 0.4735609663066967
Vwp_ih_5_36 wp_ih_5_36 0 0.5414331785636113
Vwn_ih_5_36 wn_ih_5_36 0 0.4585668214363887
Vwp_ih_6_36 wp_ih_6_36 0 0.5768241869302788
Vwn_ih_6_36 wn_ih_6_36 0 0.4231758130697212
Vwp_ih_7_36 wp_ih_7_36 0 0.5538492949291138
Vwn_ih_7_36 wn_ih_7_36 0 0.4461507050708861
Vwp_ih_8_36 wp_ih_8_36 0 0.46476191429642305
Vwn_ih_8_36 wn_ih_8_36 0 0.5352380857035769
Vwp_ih_9_36 wp_ih_9_36 0 0.3506789759554586
Vwn_ih_9_36 wn_ih_9_36 0 0.6493210240445414
Vwp_ih_10_36 wp_ih_10_36 0 0.38872120611771166
Vwn_ih_10_36 wn_ih_10_36 0 0.6112787938822883
Vwp_ih_11_36 wp_ih_11_36 0 0.4066890844743601
Vwn_ih_11_36 wn_ih_11_36 0 0.59331091552564
Vwp_ih_12_36 wp_ih_12_36 0 0.38326573684889964
Vwn_ih_12_36 wn_ih_12_36 0 0.6167342631511004
Vwp_ih_13_36 wp_ih_13_36 0 0.4473545555449819
Vwn_ih_13_36 wn_ih_13_36 0 0.5526454444550181
Vwp_ih_14_36 wp_ih_14_36 0 0.4232875714807198
Vwn_ih_14_36 wn_ih_14_36 0 0.5767124285192802
Vwp_ih_15_36 wp_ih_15_36 0 0.4898063310438097
Vwn_ih_15_36 wn_ih_15_36 0 0.5101936689561903
Vwp_ih_16_36 wp_ih_16_36 0 0.49346743258454906
Vwn_ih_16_36 wn_ih_16_36 0 0.5065325674154509
Vwp_ih_17_36 wp_ih_17_36 0 0.5271716709830165
Vwn_ih_17_36 wn_ih_17_36 0 0.4728283290169835
Vwp_ih_18_36 wp_ih_18_36 0 0.5554686554001362
Vwn_ih_18_36 wn_ih_18_36 0 0.4445313445998638
Vwp_ih_19_36 wp_ih_19_36 0 0.4322900776915549
Vwn_ih_19_36 wn_ih_19_36 0 0.5677099223084451
Vwp_ih_20_36 wp_ih_20_36 0 0.4957012255084649
Vwn_ih_20_36 wn_ih_20_36 0 0.5042987744915352
Vwp_ih_21_36 wp_ih_21_36 0 0.46920058086716016
Vwn_ih_21_36 wn_ih_21_36 0 0.5307994191328399
Vwp_ih_22_36 wp_ih_22_36 0 0.42160532939276074
Vwn_ih_22_36 wn_ih_22_36 0 0.5783946706072393
Vwp_ih_23_36 wp_ih_23_36 0 0.36215889961019426
Vwn_ih_23_36 wn_ih_23_36 0 0.6378411003898057
Vwp_ih_24_36 wp_ih_24_36 0 0.5098734328976021
Vwn_ih_24_36 wn_ih_24_36 0 0.49012656710239794
Vwp_ih_25_36 wp_ih_25_36 0 0.5333898849171501
Vwn_ih_25_36 wn_ih_25_36 0 0.46661011508284994
Vwp_ih_26_36 wp_ih_26_36 0 0.4688675005696448
Vwn_ih_26_36 wn_ih_26_36 0 0.5311324994303551
Vwp_ih_27_36 wp_ih_27_36 0 0.5584294559259795
Vwn_ih_27_36 wn_ih_27_36 0 0.4415705440740205
Vwp_ih_28_36 wp_ih_28_36 0 0.5127645692674477
Vwn_ih_28_36 wn_ih_28_36 0 0.4872354307325522
Vwp_ih_29_36 wp_ih_29_36 0 0.5785254542012342
Vwn_ih_29_36 wn_ih_29_36 0 0.4214745457987658
Vwp_ih_30_36 wp_ih_30_36 0 0.4795255581652682
Vwn_ih_30_36 wn_ih_30_36 0 0.5204744418347318
Vwp_ih_31_36 wp_ih_31_36 0 0.49266640836514275
Vwn_ih_31_36 wn_ih_31_36 0 0.5073335916348573
Vwp_ih_32_36 wp_ih_32_36 0 0.6008716074909413
Vwn_ih_32_36 wn_ih_32_36 0 0.39912839250905874
Vwp_ih_33_36 wp_ih_33_36 0 0.4530338834524113
Vwn_ih_33_36 wn_ih_33_36 0 0.5469661165475886
Vwp_ih_34_36 wp_ih_34_36 0 0.5273157453974447
Vwn_ih_34_36 wn_ih_34_36 0 0.4726842546025553
Vwp_ih_35_36 wp_ih_35_36 0 0.5967095444134238
Vwn_ih_35_36 wn_ih_35_36 0 0.4032904555865761
Vwp_ih_36_36 wp_ih_36_36 0 0.5823588864144322
Vwn_ih_36_36 wn_ih_36_36 0 0.4176411135855678
Vwp_ih_37_36 wp_ih_37_36 0 0.5638819128591414
Vwn_ih_37_36 wn_ih_37_36 0 0.4361180871408587
Vwp_ih_38_36 wp_ih_38_36 0 0.5791205210840316
Vwn_ih_38_36 wn_ih_38_36 0 0.4208794789159685
Vwp_ih_39_36 wp_ih_39_36 0 0.47461016570588627
Vwn_ih_39_36 wn_ih_39_36 0 0.5253898342941137
Vwp_ih_40_36 wp_ih_40_36 0 0.5914189752215395
Vwn_ih_40_36 wn_ih_40_36 0 0.4085810247784605
Vwp_ih_41_36 wp_ih_41_36 0 0.46202811798394805
Vwn_ih_41_36 wn_ih_41_36 0 0.537971882016052
Vwp_ih_42_36 wp_ih_42_36 0 0.4583055643163731
Vwn_ih_42_36 wn_ih_42_36 0 0.5416944356836269
Vwp_ih_43_36 wp_ih_43_36 0 0.44883204706086705
Vwn_ih_43_36 wn_ih_43_36 0 0.551167952939133
Vwp_ih_44_36 wp_ih_44_36 0 0.5632443698258112
Vwn_ih_44_36 wn_ih_44_36 0 0.4367556301741889
Vwp_ih_45_36 wp_ih_45_36 0 0.62241889749226
Vwn_ih_45_36 wn_ih_45_36 0 0.37758110250774
Vwp_ih_46_36 wp_ih_46_36 0 0.6331697057467518
Vwn_ih_46_36 wn_ih_46_36 0 0.3668302942532482
Vwp_ih_47_36 wp_ih_47_36 0 0.6266723779336743
Vwn_ih_47_36 wn_ih_47_36 0 0.37332762206632575
Vwp_ih_48_36 wp_ih_48_36 0 0.5674569853398637
Vwn_ih_48_36 wn_ih_48_36 0 0.43254301466013634
Vwp_ih_49_36 wp_ih_49_36 0 0.5301306205157196
Vwn_ih_49_36 wn_ih_49_36 0 0.4698693794842804
Vwp_ih_50_36 wp_ih_50_36 0 0.43470376482027007
Vwn_ih_50_36 wn_ih_50_36 0 0.5652962351797299
Vwp_ih_51_36 wp_ih_51_36 0 0.4410442595424578
Vwn_ih_51_36 wn_ih_51_36 0 0.5589557404575423
Vwp_ih_52_36 wp_ih_52_36 0 0.4997019435930775
Vwn_ih_52_36 wn_ih_52_36 0 0.5002980564069225
Vwp_ih_53_36 wp_ih_53_36 0 0.6248767934343111
Vwn_ih_53_36 wn_ih_53_36 0 0.37512320656568887
Vwp_ih_54_36 wp_ih_54_36 0 0.5474881453985156
Vwn_ih_54_36 wn_ih_54_36 0 0.4525118546014843
Vwp_ih_55_36 wp_ih_55_36 0 0.55998548825341
Vwn_ih_55_36 wn_ih_55_36 0 0.44001451174658995
Vwp_ih_56_36 wp_ih_56_36 0 0.5555283888050392
Vwn_ih_56_36 wn_ih_56_36 0 0.44447161119496087
Vwp_ih_57_36 wp_ih_57_36 0 0.40296078484852477
Vwn_ih_57_36 wn_ih_57_36 0 0.5970392151514753
Vwp_ih_58_36 wp_ih_58_36 0 0.42813777623646454
Vwn_ih_58_36 wn_ih_58_36 0 0.5718622237635355
Vwp_ih_59_36 wp_ih_59_36 0 0.5029700551156239
Vwn_ih_59_36 wn_ih_59_36 0 0.49702994488437613
Vwp_ih_60_36 wp_ih_60_36 0 0.5679938887035824
Vwn_ih_60_36 wn_ih_60_36 0 0.4320061112964176
Vwp_ih_61_36 wp_ih_61_36 0 0.4726884755058644
Vwn_ih_61_36 wn_ih_61_36 0 0.5273115244941355
Vwp_ih_62_36 wp_ih_62_36 0 0.5273699531520694
Vwn_ih_62_36 wn_ih_62_36 0 0.47263004684793064
Vwp_ih_63_36 wp_ih_63_36 0 0.32655617972342754
Vwn_ih_63_36 wn_ih_63_36 0 0.6734438202765725
Vwp_ho_36_0 wp_ho_36_0 0 0.4932383812888334
Vwn_ho_36_0 wn_ho_36_0 0 0.5067616187111665
Vwp_ho_36_1 wp_ho_36_1 0 0.5872458800384761
Vwn_ho_36_1 wn_ho_36_1 0 0.4127541199615239
Vwp_ho_36_2 wp_ho_36_2 0 0.40815364285292055
Vwn_ho_36_2 wn_ho_36_2 0 0.5918463571470794
Vwp_ho_36_3 wp_ho_36_3 0 0.6757266764567252
Vwn_ho_36_3 wn_ho_36_3 0 0.32427332354327476
Vwp_ho_36_4 wp_ho_36_4 0 0.5893285329522105
Vwn_ho_36_4 wn_ho_36_4 0 0.41067146704778945
Vwp_ih_0_37 wp_ih_0_37 0 0.5453997607482147
Vwn_ih_0_37 wn_ih_0_37 0 0.4546002392517853
Vwp_ih_1_37 wp_ih_1_37 0 0.6189252467914588
Vwn_ih_1_37 wn_ih_1_37 0 0.38107475320854123
Vwp_ih_2_37 wp_ih_2_37 0 0.47967465446295093
Vwn_ih_2_37 wn_ih_2_37 0 0.5203253455370491
Vwp_ih_3_37 wp_ih_3_37 0 0.434810256714417
Vwn_ih_3_37 wn_ih_3_37 0 0.565189743285583
Vwp_ih_4_37 wp_ih_4_37 0 0.682131979307526
Vwn_ih_4_37 wn_ih_4_37 0 0.317868020692474
Vwp_ih_5_37 wp_ih_5_37 0 0.4809531014405095
Vwn_ih_5_37 wn_ih_5_37 0 0.5190468985594905
Vwp_ih_6_37 wp_ih_6_37 0 0.6338753443207497
Vwn_ih_6_37 wn_ih_6_37 0 0.3661246556792503
Vwp_ih_7_37 wp_ih_7_37 0 0.45802401859205166
Vwn_ih_7_37 wn_ih_7_37 0 0.5419759814079483
Vwp_ih_8_37 wp_ih_8_37 0 0.40148656358722634
Vwn_ih_8_37 wn_ih_8_37 0 0.5985134364127737
Vwp_ih_9_37 wp_ih_9_37 0 0.35127175145108597
Vwn_ih_9_37 wn_ih_9_37 0 0.6487282485489141
Vwp_ih_10_37 wp_ih_10_37 0 0.5647924743592404
Vwn_ih_10_37 wn_ih_10_37 0 0.43520752564075954
Vwp_ih_11_37 wp_ih_11_37 0 0.35946328463149446
Vwn_ih_11_37 wn_ih_11_37 0 0.6405367153685055
Vwp_ih_12_37 wp_ih_12_37 0 0.31092169529212177
Vwn_ih_12_37 wn_ih_12_37 0 0.6890783047078782
Vwp_ih_13_37 wp_ih_13_37 0 0.41186019027610965
Vwn_ih_13_37 wn_ih_13_37 0 0.5881398097238903
Vwp_ih_14_37 wp_ih_14_37 0 0.4672907747277275
Vwn_ih_14_37 wn_ih_14_37 0 0.5327092252722725
Vwp_ih_15_37 wp_ih_15_37 0 0.48095085604537857
Vwn_ih_15_37 wn_ih_15_37 0 0.5190491439546214
Vwp_ih_16_37 wp_ih_16_37 0 0.3949156634999766
Vwn_ih_16_37 wn_ih_16_37 0 0.6050843365000235
Vwp_ih_17_37 wp_ih_17_37 0 0.44041936670499876
Vwn_ih_17_37 wn_ih_17_37 0 0.5595806332950012
Vwp_ih_18_37 wp_ih_18_37 0 0.48702657816381867
Vwn_ih_18_37 wn_ih_18_37 0 0.5129734218361813
Vwp_ih_19_37 wp_ih_19_37 0 0.34985412015053124
Vwn_ih_19_37 wn_ih_19_37 0 0.6501458798494688
Vwp_ih_20_37 wp_ih_20_37 0 0.4604829368429358
Vwn_ih_20_37 wn_ih_20_37 0 0.5395170631570642
Vwp_ih_21_37 wp_ih_21_37 0 0.5400484648053412
Vwn_ih_21_37 wn_ih_21_37 0 0.45995153519465876
Vwp_ih_22_37 wp_ih_22_37 0 0.6219897395180234
Vwn_ih_22_37 wn_ih_22_37 0 0.37801026048197667
Vwp_ih_23_37 wp_ih_23_37 0 0.5441724009108326
Vwn_ih_23_37 wn_ih_23_37 0 0.45582759908916737
Vwp_ih_24_37 wp_ih_24_37 0 0.6085667310066072
Vwn_ih_24_37 wn_ih_24_37 0 0.39143326899339287
Vwp_ih_25_37 wp_ih_25_37 0 0.48434575859446755
Vwn_ih_25_37 wn_ih_25_37 0 0.5156542414055325
Vwp_ih_26_37 wp_ih_26_37 0 0.6296167002377925
Vwn_ih_26_37 wn_ih_26_37 0 0.3703832997622075
Vwp_ih_27_37 wp_ih_27_37 0 0.5179794802815253
Vwn_ih_27_37 wn_ih_27_37 0 0.4820205197184747
Vwp_ih_28_37 wp_ih_28_37 0 0.6546105193980287
Vwn_ih_28_37 wn_ih_28_37 0 0.3453894806019713
Vwp_ih_29_37 wp_ih_29_37 0 0.5535253092492651
Vwn_ih_29_37 wn_ih_29_37 0 0.44647469075073487
Vwp_ih_30_37 wp_ih_30_37 0 0.4731320891089601
Vwn_ih_30_37 wn_ih_30_37 0 0.5268679108910399
Vwp_ih_31_37 wp_ih_31_37 0 0.512614907526575
Vwn_ih_31_37 wn_ih_31_37 0 0.487385092473425
Vwp_ih_32_37 wp_ih_32_37 0 0.34324705292097346
Vwn_ih_32_37 wn_ih_32_37 0 0.6567529470790265
Vwp_ih_33_37 wp_ih_33_37 0 0.6059791934358528
Vwn_ih_33_37 wn_ih_33_37 0 0.3940208065641472
Vwp_ih_34_37 wp_ih_34_37 0 0.49351079240567364
Vwn_ih_34_37 wn_ih_34_37 0 0.5064892075943264
Vwp_ih_35_37 wp_ih_35_37 0 0.6033432588611914
Vwn_ih_35_37 wn_ih_35_37 0 0.39665674113880856
Vwp_ih_36_37 wp_ih_36_37 0 0.6769409714303514
Vwn_ih_36_37 wn_ih_36_37 0 0.32305902856964863
Vwp_ih_37_37 wp_ih_37_37 0 0.52123218003221
Vwn_ih_37_37 wn_ih_37_37 0 0.47876781996779
Vwp_ih_38_37 wp_ih_38_37 0 0.5175453096107099
Vwn_ih_38_37 wn_ih_38_37 0 0.4824546903892902
Vwp_ih_39_37 wp_ih_39_37 0 0.48641042565285525
Vwn_ih_39_37 wn_ih_39_37 0 0.5135895743471447
Vwp_ih_40_37 wp_ih_40_37 0 0.553196965559368
Vwn_ih_40_37 wn_ih_40_37 0 0.44680303444063196
Vwp_ih_41_37 wp_ih_41_37 0 0.7386182566158611
Vwn_ih_41_37 wn_ih_41_37 0 0.3
Vwp_ih_42_37 wp_ih_42_37 0 0.574526973053489
Vwn_ih_42_37 wn_ih_42_37 0 0.425473026946511
Vwp_ih_43_37 wp_ih_43_37 0 0.5067595636929036
Vwn_ih_43_37 wn_ih_43_37 0 0.49324043630709635
Vwp_ih_44_37 wp_ih_44_37 0 0.5956071351447053
Vwn_ih_44_37 wn_ih_44_37 0 0.4043928648552947
Vwp_ih_45_37 wp_ih_45_37 0 0.35314168482181363
Vwn_ih_45_37 wn_ih_45_37 0 0.6468583151781864
Vwp_ih_46_37 wp_ih_46_37 0 0.5205697109335221
Vwn_ih_46_37 wn_ih_46_37 0 0.4794302890664779
Vwp_ih_47_37 wp_ih_47_37 0 0.3
Vwn_ih_47_37 wn_ih_47_37 0 0.7429649702522714
Vwp_ih_48_37 wp_ih_48_37 0 0.6071155174284407
Vwn_ih_48_37 wn_ih_48_37 0 0.3928844825715593
Vwp_ih_49_37 wp_ih_49_37 0 0.30955120916405476
Vwn_ih_49_37 wn_ih_49_37 0 0.6904487908359452
Vwp_ih_50_37 wp_ih_50_37 0 0.5248040660457671
Vwn_ih_50_37 wn_ih_50_37 0 0.4751959339542329
Vwp_ih_51_37 wp_ih_51_37 0 0.4403745124164651
Vwn_ih_51_37 wn_ih_51_37 0 0.5596254875835349
Vwp_ih_52_37 wp_ih_52_37 0 0.6917093272433023
Vwn_ih_52_37 wn_ih_52_37 0 0.30829067275669775
Vwp_ih_53_37 wp_ih_53_37 0 0.40788331068361183
Vwn_ih_53_37 wn_ih_53_37 0 0.5921166893163882
Vwp_ih_54_37 wp_ih_54_37 0 0.4885846603681868
Vwn_ih_54_37 wn_ih_54_37 0 0.5114153396318132
Vwp_ih_55_37 wp_ih_55_37 0 0.6432168107246319
Vwn_ih_55_37 wn_ih_55_37 0 0.3567831892753681
Vwp_ih_56_37 wp_ih_56_37 0 0.5430396937489735
Vwn_ih_56_37 wn_ih_56_37 0 0.45696030625102646
Vwp_ih_57_37 wp_ih_57_37 0 0.5233807408133013
Vwn_ih_57_37 wn_ih_57_37 0 0.47661925918669873
Vwp_ih_58_37 wp_ih_58_37 0 0.4830531503672377
Vwn_ih_58_37 wn_ih_58_37 0 0.5169468496327623
Vwp_ih_59_37 wp_ih_59_37 0 0.497009139082104
Vwn_ih_59_37 wn_ih_59_37 0 0.502990860917896
Vwp_ih_60_37 wp_ih_60_37 0 0.4007629795812436
Vwn_ih_60_37 wn_ih_60_37 0 0.5992370204187565
Vwp_ih_61_37 wp_ih_61_37 0 0.4680092095937612
Vwn_ih_61_37 wn_ih_61_37 0 0.5319907904062388
Vwp_ih_62_37 wp_ih_62_37 0 0.49798223079171444
Vwn_ih_62_37 wn_ih_62_37 0 0.5020177692082856
Vwp_ih_63_37 wp_ih_63_37 0 0.5791610801421356
Vwn_ih_63_37 wn_ih_63_37 0 0.4208389198578644
Vwp_ho_37_0 wp_ho_37_0 0 0.5176802716950912
Vwn_ho_37_0 wn_ho_37_0 0 0.4823197283049088
Vwp_ho_37_1 wp_ho_37_1 0 0.4149396185113982
Vwn_ho_37_1 wn_ho_37_1 0 0.5850603814886018
Vwp_ho_37_2 wp_ho_37_2 0 0.3897453921440843
Vwn_ho_37_2 wn_ho_37_2 0 0.6102546078559157
Vwp_ho_37_3 wp_ho_37_3 0 0.5821153843588697
Vwn_ho_37_3 wn_ho_37_3 0 0.41788461564113033
Vwp_ho_37_4 wp_ho_37_4 0 0.74892136717158
Vwn_ho_37_4 wn_ho_37_4 0 0.3
Vwp_ih_0_38 wp_ih_0_38 0 0.5073113961902959
Vwn_ih_0_38 wn_ih_0_38 0 0.49268860380970414
Vwp_ih_1_38 wp_ih_1_38 0 0.6055881629734866
Vwn_ih_1_38 wn_ih_1_38 0 0.3944118370265134
Vwp_ih_2_38 wp_ih_2_38 0 0.40212595905464815
Vwn_ih_2_38 wn_ih_2_38 0 0.5978740409453518
Vwp_ih_3_38 wp_ih_3_38 0 0.6343887795490226
Vwn_ih_3_38 wn_ih_3_38 0 0.3656112204509774
Vwp_ih_4_38 wp_ih_4_38 0 0.5128666319677013
Vwn_ih_4_38 wn_ih_4_38 0 0.48713336803229873
Vwp_ih_5_38 wp_ih_5_38 0 0.6488961210491746
Vwn_ih_5_38 wn_ih_5_38 0 0.35110387895082534
Vwp_ih_6_38 wp_ih_6_38 0 0.5269774727853909
Vwn_ih_6_38 wn_ih_6_38 0 0.47302252721460913
Vwp_ih_7_38 wp_ih_7_38 0 0.48404112699613683
Vwn_ih_7_38 wn_ih_7_38 0 0.5159588730038632
Vwp_ih_8_38 wp_ih_8_38 0 0.5159902080241746
Vwn_ih_8_38 wn_ih_8_38 0 0.48400979197582533
Vwp_ih_9_38 wp_ih_9_38 0 0.430954116416528
Vwn_ih_9_38 wn_ih_9_38 0 0.5690458835834721
Vwp_ih_10_38 wp_ih_10_38 0 0.46916953596305455
Vwn_ih_10_38 wn_ih_10_38 0 0.5308304640369454
Vwp_ih_11_38 wp_ih_11_38 0 0.50339057190528
Vwn_ih_11_38 wn_ih_11_38 0 0.49660942809472003
Vwp_ih_12_38 wp_ih_12_38 0 0.5201715976280588
Vwn_ih_12_38 wn_ih_12_38 0 0.47982840237194124
Vwp_ih_13_38 wp_ih_13_38 0 0.3712499930303123
Vwn_ih_13_38 wn_ih_13_38 0 0.6287500069696876
Vwp_ih_14_38 wp_ih_14_38 0 0.5457268414568198
Vwn_ih_14_38 wn_ih_14_38 0 0.45427315854318023
Vwp_ih_15_38 wp_ih_15_38 0 0.4016967310361115
Vwn_ih_15_38 wn_ih_15_38 0 0.5983032689638885
Vwp_ih_16_38 wp_ih_16_38 0 0.4847218729045773
Vwn_ih_16_38 wn_ih_16_38 0 0.5152781270954226
Vwp_ih_17_38 wp_ih_17_38 0 0.6165724230811906
Vwn_ih_17_38 wn_ih_17_38 0 0.3834275769188093
Vwp_ih_18_38 wp_ih_18_38 0 0.4086030360232837
Vwn_ih_18_38 wn_ih_18_38 0 0.5913969639767164
Vwp_ih_19_38 wp_ih_19_38 0 0.5024543456515845
Vwn_ih_19_38 wn_ih_19_38 0 0.49754565434841547
Vwp_ih_20_38 wp_ih_20_38 0 0.5026555182445963
Vwn_ih_20_38 wn_ih_20_38 0 0.4973444817554037
Vwp_ih_21_38 wp_ih_21_38 0 0.5576978452946707
Vwn_ih_21_38 wn_ih_21_38 0 0.44230215470532924
Vwp_ih_22_38 wp_ih_22_38 0 0.39010706487954766
Vwn_ih_22_38 wn_ih_22_38 0 0.6098929351204524
Vwp_ih_23_38 wp_ih_23_38 0 0.3584987276399799
Vwn_ih_23_38 wn_ih_23_38 0 0.6415012723600201
Vwp_ih_24_38 wp_ih_24_38 0 0.3114952852483945
Vwn_ih_24_38 wn_ih_24_38 0 0.6885047147516055
Vwp_ih_25_38 wp_ih_25_38 0 0.6787928123904494
Vwn_ih_25_38 wn_ih_25_38 0 0.3212071876095506
Vwp_ih_26_38 wp_ih_26_38 0 0.5157713310912325
Vwn_ih_26_38 wn_ih_26_38 0 0.4842286689087675
Vwp_ih_27_38 wp_ih_27_38 0 0.664626423932149
Vwn_ih_27_38 wn_ih_27_38 0 0.335373576067851
Vwp_ih_28_38 wp_ih_28_38 0 0.505641993019098
Vwn_ih_28_38 wn_ih_28_38 0 0.49435800698090204
Vwp_ih_29_38 wp_ih_29_38 0 0.5841370879914899
Vwn_ih_29_38 wn_ih_29_38 0 0.4158629120085101
Vwp_ih_30_38 wp_ih_30_38 0 0.4524410168152639
Vwn_ih_30_38 wn_ih_30_38 0 0.5475589831847362
Vwp_ih_31_38 wp_ih_31_38 0 0.3832894396683004
Vwn_ih_31_38 wn_ih_31_38 0 0.6167105603316996
Vwp_ih_32_38 wp_ih_32_38 0 0.5762264460066215
Vwn_ih_32_38 wn_ih_32_38 0 0.42377355399337846
Vwp_ih_33_38 wp_ih_33_38 0 0.4612505112394321
Vwn_ih_33_38 wn_ih_33_38 0 0.5387494887605678
Vwp_ih_34_38 wp_ih_34_38 0 0.4941296614321746
Vwn_ih_34_38 wn_ih_34_38 0 0.5058703385678254
Vwp_ih_35_38 wp_ih_35_38 0 0.5321016191429239
Vwn_ih_35_38 wn_ih_35_38 0 0.4678983808570761
Vwp_ih_36_38 wp_ih_36_38 0 0.559514053460342
Vwn_ih_36_38 wn_ih_36_38 0 0.440485946539658
Vwp_ih_37_38 wp_ih_37_38 0 0.4743627914658136
Vwn_ih_37_38 wn_ih_37_38 0 0.5256372085341864
Vwp_ih_38_38 wp_ih_38_38 0 0.3
Vwn_ih_38_38 wn_ih_38_38 0 0.7242909395381721
Vwp_ih_39_38 wp_ih_39_38 0 0.39307586564545316
Vwn_ih_39_38 wn_ih_39_38 0 0.6069241343545468
Vwp_ih_40_38 wp_ih_40_38 0 0.5485822961252789
Vwn_ih_40_38 wn_ih_40_38 0 0.45141770387472113
Vwp_ih_41_38 wp_ih_41_38 0 0.6626791685137087
Vwn_ih_41_38 wn_ih_41_38 0 0.33732083148629133
Vwp_ih_42_38 wp_ih_42_38 0 0.4575940885097161
Vwn_ih_42_38 wn_ih_42_38 0 0.5424059114902839
Vwp_ih_43_38 wp_ih_43_38 0 0.6059907777013351
Vwn_ih_43_38 wn_ih_43_38 0 0.39400922229866486
Vwp_ih_44_38 wp_ih_44_38 0 0.30656758149345636
Vwn_ih_44_38 wn_ih_44_38 0 0.6934324185065437
Vwp_ih_45_38 wp_ih_45_38 0 0.6250345176556844
Vwn_ih_45_38 wn_ih_45_38 0 0.3749654823443156
Vwp_ih_46_38 wp_ih_46_38 0 0.4083309887452892
Vwn_ih_46_38 wn_ih_46_38 0 0.5916690112547108
Vwp_ih_47_38 wp_ih_47_38 0 0.40394324975478274
Vwn_ih_47_38 wn_ih_47_38 0 0.5960567502452173
Vwp_ih_48_38 wp_ih_48_38 0 0.4735403253258778
Vwn_ih_48_38 wn_ih_48_38 0 0.5264596746741222
Vwp_ih_49_38 wp_ih_49_38 0 0.5128406731188758
Vwn_ih_49_38 wn_ih_49_38 0 0.4871593268811241
Vwp_ih_50_38 wp_ih_50_38 0 0.4117689834458018
Vwn_ih_50_38 wn_ih_50_38 0 0.5882310165541982
Vwp_ih_51_38 wp_ih_51_38 0 0.6161189060028601
Vwn_ih_51_38 wn_ih_51_38 0 0.3838810939971399
Vwp_ih_52_38 wp_ih_52_38 0 0.3879199239778134
Vwn_ih_52_38 wn_ih_52_38 0 0.6120800760221866
Vwp_ih_53_38 wp_ih_53_38 0 0.5128013538057723
Vwn_ih_53_38 wn_ih_53_38 0 0.4871986461942277
Vwp_ih_54_38 wp_ih_54_38 0 0.47983225159770526
Vwn_ih_54_38 wn_ih_54_38 0 0.5201677484022947
Vwp_ih_55_38 wp_ih_55_38 0 0.5352555673329294
Vwn_ih_55_38 wn_ih_55_38 0 0.4647444326670706
Vwp_ih_56_38 wp_ih_56_38 0 0.3171311404991721
Vwn_ih_56_38 wn_ih_56_38 0 0.6828688595008279
Vwp_ih_57_38 wp_ih_57_38 0 0.4435231355674146
Vwn_ih_57_38 wn_ih_57_38 0 0.5564768644325855
Vwp_ih_58_38 wp_ih_58_38 0 0.42393878477184127
Vwn_ih_58_38 wn_ih_58_38 0 0.5760612152281587
Vwp_ih_59_38 wp_ih_59_38 0 0.5881163139590871
Vwn_ih_59_38 wn_ih_59_38 0 0.41188368604091286
Vwp_ih_60_38 wp_ih_60_38 0 0.3
Vwn_ih_60_38 wn_ih_60_38 0 0.7026305366263812
Vwp_ih_61_38 wp_ih_61_38 0 0.6982028896200869
Vwn_ih_61_38 wn_ih_61_38 0 0.3017971103799131
Vwp_ih_62_38 wp_ih_62_38 0 0.5001509224082897
Vwn_ih_62_38 wn_ih_62_38 0 0.49984907759171027
Vwp_ih_63_38 wp_ih_63_38 0 0.5378878917549178
Vwn_ih_63_38 wn_ih_63_38 0 0.46211210824508214
Vwp_ho_38_0 wp_ho_38_0 0 0.4653521314051075
Vwn_ho_38_0 wn_ho_38_0 0 0.5346478685948924
Vwp_ho_38_1 wp_ho_38_1 0 0.41772323615699125
Vwn_ho_38_1 wn_ho_38_1 0 0.5822767638430087
Vwp_ho_38_2 wp_ho_38_2 0 0.3745242477336146
Vwn_ho_38_2 wn_ho_38_2 0 0.6254757522663854
Vwp_ho_38_3 wp_ho_38_3 0 0.5421358333034508
Vwn_ho_38_3 wn_ho_38_3 0 0.4578641666965492
Vwp_ho_38_4 wp_ho_38_4 0 0.5497611678578822
Vwn_ho_38_4 wn_ho_38_4 0 0.45023883214211785
Vwp_ih_0_39 wp_ih_0_39 0 0.3
Vwn_ih_0_39 wn_ih_0_39 0 0.7292764170760939
Vwp_ih_1_39 wp_ih_1_39 0 0.429602307929372
Vwn_ih_1_39 wn_ih_1_39 0 0.5703976920706281
Vwp_ih_2_39 wp_ih_2_39 0 0.5657177408575828
Vwn_ih_2_39 wn_ih_2_39 0 0.4342822591424172
Vwp_ih_3_39 wp_ih_3_39 0 0.6487468036551913
Vwn_ih_3_39 wn_ih_3_39 0 0.35125319634480867
Vwp_ih_4_39 wp_ih_4_39 0 0.4115594885997272
Vwn_ih_4_39 wn_ih_4_39 0 0.5884405114002729
Vwp_ih_5_39 wp_ih_5_39 0 0.5935825780172554
Vwn_ih_5_39 wn_ih_5_39 0 0.40641742198274455
Vwp_ih_6_39 wp_ih_6_39 0 0.49064420744311316
Vwn_ih_6_39 wn_ih_6_39 0 0.5093557925568869
Vwp_ih_7_39 wp_ih_7_39 0 0.5499319154540439
Vwn_ih_7_39 wn_ih_7_39 0 0.4500680845459562
Vwp_ih_8_39 wp_ih_8_39 0 0.4758946786754139
Vwn_ih_8_39 wn_ih_8_39 0 0.5241053213245861
Vwp_ih_9_39 wp_ih_9_39 0 0.6169023628522425
Vwn_ih_9_39 wn_ih_9_39 0 0.38309763714775746
Vwp_ih_10_39 wp_ih_10_39 0 0.32338929455554144
Vwn_ih_10_39 wn_ih_10_39 0 0.6766107054444586
Vwp_ih_11_39 wp_ih_11_39 0 0.5515577839036325
Vwn_ih_11_39 wn_ih_11_39 0 0.4484422160963674
Vwp_ih_12_39 wp_ih_12_39 0 0.6402900851455335
Vwn_ih_12_39 wn_ih_12_39 0 0.3597099148544665
Vwp_ih_13_39 wp_ih_13_39 0 0.5894586077910364
Vwn_ih_13_39 wn_ih_13_39 0 0.4105413922089635
Vwp_ih_14_39 wp_ih_14_39 0 0.43723666575651665
Vwn_ih_14_39 wn_ih_14_39 0 0.5627633342434833
Vwp_ih_15_39 wp_ih_15_39 0 0.5369676413227932
Vwn_ih_15_39 wn_ih_15_39 0 0.4630323586772068
Vwp_ih_16_39 wp_ih_16_39 0 0.5194598541310826
Vwn_ih_16_39 wn_ih_16_39 0 0.4805401458689173
Vwp_ih_17_39 wp_ih_17_39 0 0.47565385858225767
Vwn_ih_17_39 wn_ih_17_39 0 0.5243461414177423
Vwp_ih_18_39 wp_ih_18_39 0 0.5957067733574992
Vwn_ih_18_39 wn_ih_18_39 0 0.4042932266425008
Vwp_ih_19_39 wp_ih_19_39 0 0.6420587530299038
Vwn_ih_19_39 wn_ih_19_39 0 0.3579412469700962
Vwp_ih_20_39 wp_ih_20_39 0 0.44293526153065754
Vwn_ih_20_39 wn_ih_20_39 0 0.5570647384693425
Vwp_ih_21_39 wp_ih_21_39 0 0.6546721351242377
Vwn_ih_21_39 wn_ih_21_39 0 0.3453278648757623
Vwp_ih_22_39 wp_ih_22_39 0 0.4983241379787007
Vwn_ih_22_39 wn_ih_22_39 0 0.5016758620212993
Vwp_ih_23_39 wp_ih_23_39 0 0.4729958783538692
Vwn_ih_23_39 wn_ih_23_39 0 0.5270041216461308
Vwp_ih_24_39 wp_ih_24_39 0 0.5812834729246704
Vwn_ih_24_39 wn_ih_24_39 0 0.4187165270753295
Vwp_ih_25_39 wp_ih_25_39 0 0.46299530616679185
Vwn_ih_25_39 wn_ih_25_39 0 0.5370046938332081
Vwp_ih_26_39 wp_ih_26_39 0 0.5470311503783192
Vwn_ih_26_39 wn_ih_26_39 0 0.4529688496216808
Vwp_ih_27_39 wp_ih_27_39 0 0.4981423228525755
Vwn_ih_27_39 wn_ih_27_39 0 0.5018576771474245
Vwp_ih_28_39 wp_ih_28_39 0 0.5352534169439748
Vwn_ih_28_39 wn_ih_28_39 0 0.4647465830560253
Vwp_ih_29_39 wp_ih_29_39 0 0.5164165435994328
Vwn_ih_29_39 wn_ih_29_39 0 0.4835834564005672
Vwp_ih_30_39 wp_ih_30_39 0 0.49488904961947583
Vwn_ih_30_39 wn_ih_30_39 0 0.5051109503805242
Vwp_ih_31_39 wp_ih_31_39 0 0.4660398787318333
Vwn_ih_31_39 wn_ih_31_39 0 0.5339601212681667
Vwp_ih_32_39 wp_ih_32_39 0 0.6084662380893078
Vwn_ih_32_39 wn_ih_32_39 0 0.3915337619106923
Vwp_ih_33_39 wp_ih_33_39 0 0.5670390610799956
Vwn_ih_33_39 wn_ih_33_39 0 0.4329609389200044
Vwp_ih_34_39 wp_ih_34_39 0 0.5523425712331848
Vwn_ih_34_39 wn_ih_34_39 0 0.44765742876681525
Vwp_ih_35_39 wp_ih_35_39 0 0.5825499615223978
Vwn_ih_35_39 wn_ih_35_39 0 0.41745003847760215
Vwp_ih_36_39 wp_ih_36_39 0 0.3298492251220261
Vwn_ih_36_39 wn_ih_36_39 0 0.6701507748779739
Vwp_ih_37_39 wp_ih_37_39 0 0.5614691639642324
Vwn_ih_37_39 wn_ih_37_39 0 0.43853083603576765
Vwp_ih_38_39 wp_ih_38_39 0 0.722937619714959
Vwn_ih_38_39 wn_ih_38_39 0 0.3
Vwp_ih_39_39 wp_ih_39_39 0 0.40691442722022353
Vwn_ih_39_39 wn_ih_39_39 0 0.5930855727797765
Vwp_ih_40_39 wp_ih_40_39 0 0.7111779929562683
Vwn_ih_40_39 wn_ih_40_39 0 0.3
Vwp_ih_41_39 wp_ih_41_39 0 0.3258699398959447
Vwn_ih_41_39 wn_ih_41_39 0 0.6741300601040553
Vwp_ih_42_39 wp_ih_42_39 0 0.48643782331539376
Vwn_ih_42_39 wn_ih_42_39 0 0.5135621766846062
Vwp_ih_43_39 wp_ih_43_39 0 0.5656983834683553
Vwn_ih_43_39 wn_ih_43_39 0 0.4343016165316447
Vwp_ih_44_39 wp_ih_44_39 0 0.48060969680179955
Vwn_ih_44_39 wn_ih_44_39 0 0.5193903031982005
Vwp_ih_45_39 wp_ih_45_39 0 0.3916576239287657
Vwn_ih_45_39 wn_ih_45_39 0 0.6083423760712343
Vwp_ih_46_39 wp_ih_46_39 0 0.5076436413708624
Vwn_ih_46_39 wn_ih_46_39 0 0.49235635862913757
Vwp_ih_47_39 wp_ih_47_39 0 0.5337849518842717
Vwn_ih_47_39 wn_ih_47_39 0 0.4662150481157283
Vwp_ih_48_39 wp_ih_48_39 0 0.575127538992279
Vwn_ih_48_39 wn_ih_48_39 0 0.4248724610077211
Vwp_ih_49_39 wp_ih_49_39 0 0.4684043490241549
Vwn_ih_49_39 wn_ih_49_39 0 0.5315956509758452
Vwp_ih_50_39 wp_ih_50_39 0 0.34672434752331804
Vwn_ih_50_39 wn_ih_50_39 0 0.653275652476682
Vwp_ih_51_39 wp_ih_51_39 0 0.5429677306840067
Vwn_ih_51_39 wn_ih_51_39 0 0.4570322693159932
Vwp_ih_52_39 wp_ih_52_39 0 0.6483424370356545
Vwn_ih_52_39 wn_ih_52_39 0 0.35165756296434547
Vwp_ih_53_39 wp_ih_53_39 0 0.43679103455262125
Vwn_ih_53_39 wn_ih_53_39 0 0.5632089654473788
Vwp_ih_54_39 wp_ih_54_39 0 0.5704709157473367
Vwn_ih_54_39 wn_ih_54_39 0 0.4295290842526634
Vwp_ih_55_39 wp_ih_55_39 0 0.4069956877080666
Vwn_ih_55_39 wn_ih_55_39 0 0.5930043122919334
Vwp_ih_56_39 wp_ih_56_39 0 0.4335054523436065
Vwn_ih_56_39 wn_ih_56_39 0 0.5664945476563935
Vwp_ih_57_39 wp_ih_57_39 0 0.3920539145042494
Vwn_ih_57_39 wn_ih_57_39 0 0.6079460854957506
Vwp_ih_58_39 wp_ih_58_39 0 0.4877019628315162
Vwn_ih_58_39 wn_ih_58_39 0 0.5122980371684839
Vwp_ih_59_39 wp_ih_59_39 0 0.40064648151211724
Vwn_ih_59_39 wn_ih_59_39 0 0.5993535184878828
Vwp_ih_60_39 wp_ih_60_39 0 0.6719839604093849
Vwn_ih_60_39 wn_ih_60_39 0 0.3280160395906151
Vwp_ih_61_39 wp_ih_61_39 0 0.5654095873084339
Vwn_ih_61_39 wn_ih_61_39 0 0.43459041269156606
Vwp_ih_62_39 wp_ih_62_39 0 0.4884209501655182
Vwn_ih_62_39 wn_ih_62_39 0 0.5115790498344819
Vwp_ih_63_39 wp_ih_63_39 0 0.5625178290402333
Vwn_ih_63_39 wn_ih_63_39 0 0.4374821709597667
Vwp_ho_39_0 wp_ho_39_0 0 0.4669770890773699
Vwn_ho_39_0 wn_ho_39_0 0 0.5330229109226301
Vwp_ho_39_1 wp_ho_39_1 0 0.5935889221027236
Vwn_ho_39_1 wn_ho_39_1 0 0.4064110778972763
Vwp_ho_39_2 wp_ho_39_2 0 0.46525734263767843
Vwn_ho_39_2 wn_ho_39_2 0 0.5347426573623215
Vwp_ho_39_3 wp_ho_39_3 0 0.4700387795093017
Vwn_ho_39_3 wn_ho_39_3 0 0.5299612204906984
Vwp_ho_39_4 wp_ho_39_4 0 0.4153654818313315
Vwn_ho_39_4 wn_ho_39_4 0 0.5846345181686685
Xcm_xh0 xhp0 xhn0 vdd cmld
Rnd_xh0 xhp0 xhn0 20k
X_ihx_0_0 a_xp0 a_xn0 wp_ih_0_0 wn_ih_0_0 xhp0 xhn0 vdd vbsyn gsyn
X_ihx_1_0 a_xp1 a_xn1 wp_ih_1_0 wn_ih_1_0 xhp0 xhn0 vdd vbsyn gsyn
X_ihx_2_0 a_xp2 a_xn2 wp_ih_2_0 wn_ih_2_0 xhp0 xhn0 vdd vbsyn gsyn
X_ihx_3_0 a_xp3 a_xn3 wp_ih_3_0 wn_ih_3_0 xhp0 xhn0 vdd vbsyn gsyn
X_ihx_4_0 a_xp4 a_xn4 wp_ih_4_0 wn_ih_4_0 xhp0 xhn0 vdd vbsyn gsyn
X_ihx_5_0 a_xp5 a_xn5 wp_ih_5_0 wn_ih_5_0 xhp0 xhn0 vdd vbsyn gsyn
X_ihx_6_0 a_xp6 a_xn6 wp_ih_6_0 wn_ih_6_0 xhp0 xhn0 vdd vbsyn gsyn
X_ihx_7_0 a_xp7 a_xn7 wp_ih_7_0 wn_ih_7_0 xhp0 xhn0 vdd vbsyn gsyn
X_ihx_8_0 a_xp8 a_xn8 wp_ih_8_0 wn_ih_8_0 xhp0 xhn0 vdd vbsyn gsyn
X_ihx_9_0 a_xp9 a_xn9 wp_ih_9_0 wn_ih_9_0 xhp0 xhn0 vdd vbsyn gsyn
X_ihx_10_0 a_xp10 a_xn10 wp_ih_10_0 wn_ih_10_0 xhp0 xhn0 vdd vbsyn gsyn
X_ihx_11_0 a_xp11 a_xn11 wp_ih_11_0 wn_ih_11_0 xhp0 xhn0 vdd vbsyn gsyn
X_ihx_12_0 a_xp12 a_xn12 wp_ih_12_0 wn_ih_12_0 xhp0 xhn0 vdd vbsyn gsyn
X_ihx_13_0 a_xp13 a_xn13 wp_ih_13_0 wn_ih_13_0 xhp0 xhn0 vdd vbsyn gsyn
X_ihx_14_0 a_xp14 a_xn14 wp_ih_14_0 wn_ih_14_0 xhp0 xhn0 vdd vbsyn gsyn
X_ihx_15_0 a_xp15 a_xn15 wp_ih_15_0 wn_ih_15_0 xhp0 xhn0 vdd vbsyn gsyn
X_ihx_16_0 a_xp16 a_xn16 wp_ih_16_0 wn_ih_16_0 xhp0 xhn0 vdd vbsyn gsyn
X_ihx_17_0 a_xp17 a_xn17 wp_ih_17_0 wn_ih_17_0 xhp0 xhn0 vdd vbsyn gsyn
X_ihx_18_0 a_xp18 a_xn18 wp_ih_18_0 wn_ih_18_0 xhp0 xhn0 vdd vbsyn gsyn
X_ihx_19_0 a_xp19 a_xn19 wp_ih_19_0 wn_ih_19_0 xhp0 xhn0 vdd vbsyn gsyn
X_ihx_20_0 a_xp20 a_xn20 wp_ih_20_0 wn_ih_20_0 xhp0 xhn0 vdd vbsyn gsyn
X_ihx_21_0 a_xp21 a_xn21 wp_ih_21_0 wn_ih_21_0 xhp0 xhn0 vdd vbsyn gsyn
X_ihx_22_0 a_xp22 a_xn22 wp_ih_22_0 wn_ih_22_0 xhp0 xhn0 vdd vbsyn gsyn
X_ihx_23_0 a_xp23 a_xn23 wp_ih_23_0 wn_ih_23_0 xhp0 xhn0 vdd vbsyn gsyn
X_ihx_24_0 a_xp24 a_xn24 wp_ih_24_0 wn_ih_24_0 xhp0 xhn0 vdd vbsyn gsyn
X_ihx_25_0 a_xp25 a_xn25 wp_ih_25_0 wn_ih_25_0 xhp0 xhn0 vdd vbsyn gsyn
X_ihx_26_0 a_xp26 a_xn26 wp_ih_26_0 wn_ih_26_0 xhp0 xhn0 vdd vbsyn gsyn
X_ihx_27_0 a_xp27 a_xn27 wp_ih_27_0 wn_ih_27_0 xhp0 xhn0 vdd vbsyn gsyn
X_ihx_28_0 a_xp28 a_xn28 wp_ih_28_0 wn_ih_28_0 xhp0 xhn0 vdd vbsyn gsyn
X_ihx_29_0 a_xp29 a_xn29 wp_ih_29_0 wn_ih_29_0 xhp0 xhn0 vdd vbsyn gsyn
X_ihx_30_0 a_xp30 a_xn30 wp_ih_30_0 wn_ih_30_0 xhp0 xhn0 vdd vbsyn gsyn
X_ihx_31_0 a_xp31 a_xn31 wp_ih_31_0 wn_ih_31_0 xhp0 xhn0 vdd vbsyn gsyn
X_ihx_32_0 a_xp32 a_xn32 wp_ih_32_0 wn_ih_32_0 xhp0 xhn0 vdd vbsyn gsyn
X_ihx_33_0 a_xp33 a_xn33 wp_ih_33_0 wn_ih_33_0 xhp0 xhn0 vdd vbsyn gsyn
X_ihx_34_0 a_xp34 a_xn34 wp_ih_34_0 wn_ih_34_0 xhp0 xhn0 vdd vbsyn gsyn
X_ihx_35_0 a_xp35 a_xn35 wp_ih_35_0 wn_ih_35_0 xhp0 xhn0 vdd vbsyn gsyn
X_ihx_36_0 a_xp36 a_xn36 wp_ih_36_0 wn_ih_36_0 xhp0 xhn0 vdd vbsyn gsyn
X_ihx_37_0 a_xp37 a_xn37 wp_ih_37_0 wn_ih_37_0 xhp0 xhn0 vdd vbsyn gsyn
X_ihx_38_0 a_xp38 a_xn38 wp_ih_38_0 wn_ih_38_0 xhp0 xhn0 vdd vbsyn gsyn
X_ihx_39_0 a_xp39 a_xn39 wp_ih_39_0 wn_ih_39_0 xhp0 xhn0 vdd vbsyn gsyn
X_ihx_40_0 a_xp40 a_xn40 wp_ih_40_0 wn_ih_40_0 xhp0 xhn0 vdd vbsyn gsyn
X_ihx_41_0 a_xp41 a_xn41 wp_ih_41_0 wn_ih_41_0 xhp0 xhn0 vdd vbsyn gsyn
X_ihx_42_0 a_xp42 a_xn42 wp_ih_42_0 wn_ih_42_0 xhp0 xhn0 vdd vbsyn gsyn
X_ihx_43_0 a_xp43 a_xn43 wp_ih_43_0 wn_ih_43_0 xhp0 xhn0 vdd vbsyn gsyn
X_ihx_44_0 a_xp44 a_xn44 wp_ih_44_0 wn_ih_44_0 xhp0 xhn0 vdd vbsyn gsyn
X_ihx_45_0 a_xp45 a_xn45 wp_ih_45_0 wn_ih_45_0 xhp0 xhn0 vdd vbsyn gsyn
X_ihx_46_0 a_xp46 a_xn46 wp_ih_46_0 wn_ih_46_0 xhp0 xhn0 vdd vbsyn gsyn
X_ihx_47_0 a_xp47 a_xn47 wp_ih_47_0 wn_ih_47_0 xhp0 xhn0 vdd vbsyn gsyn
X_ihx_48_0 a_xp48 a_xn48 wp_ih_48_0 wn_ih_48_0 xhp0 xhn0 vdd vbsyn gsyn
X_ihx_49_0 a_xp49 a_xn49 wp_ih_49_0 wn_ih_49_0 xhp0 xhn0 vdd vbsyn gsyn
X_ihx_50_0 a_xp50 a_xn50 wp_ih_50_0 wn_ih_50_0 xhp0 xhn0 vdd vbsyn gsyn
X_ihx_51_0 a_xp51 a_xn51 wp_ih_51_0 wn_ih_51_0 xhp0 xhn0 vdd vbsyn gsyn
X_ihx_52_0 a_xp52 a_xn52 wp_ih_52_0 wn_ih_52_0 xhp0 xhn0 vdd vbsyn gsyn
X_ihx_53_0 a_xp53 a_xn53 wp_ih_53_0 wn_ih_53_0 xhp0 xhn0 vdd vbsyn gsyn
X_ihx_54_0 a_xp54 a_xn54 wp_ih_54_0 wn_ih_54_0 xhp0 xhn0 vdd vbsyn gsyn
X_ihx_55_0 a_xp55 a_xn55 wp_ih_55_0 wn_ih_55_0 xhp0 xhn0 vdd vbsyn gsyn
X_ihx_56_0 a_xp56 a_xn56 wp_ih_56_0 wn_ih_56_0 xhp0 xhn0 vdd vbsyn gsyn
X_ihx_57_0 a_xp57 a_xn57 wp_ih_57_0 wn_ih_57_0 xhp0 xhn0 vdd vbsyn gsyn
X_ihx_58_0 a_xp58 a_xn58 wp_ih_58_0 wn_ih_58_0 xhp0 xhn0 vdd vbsyn gsyn
X_ihx_59_0 a_xp59 a_xn59 wp_ih_59_0 wn_ih_59_0 xhp0 xhn0 vdd vbsyn gsyn
X_ihx_60_0 a_xp60 a_xn60 wp_ih_60_0 wn_ih_60_0 xhp0 xhn0 vdd vbsyn gsyn
X_ihx_61_0 a_xp61 a_xn61 wp_ih_61_0 wn_ih_61_0 xhp0 xhn0 vdd vbsyn gsyn
X_ihx_62_0 a_xp62 a_xn62 wp_ih_62_0 wn_ih_62_0 xhp0 xhn0 vdd vbsyn gsyn
X_ihx_63_0 a_xp63 a_xn63 wp_ih_63_0 wn_ih_63_0 xhp0 xhn0 vdd vbsyn gsyn
Xn0 xhp0 xhn0 ahp0 ahn0 vdd vbneu dneuron
Xcm_xh1 xhp1 xhn1 vdd cmld
Rnd_xh1 xhp1 xhn1 20k
X_ihx_0_1 a_xp0 a_xn0 wp_ih_0_1 wn_ih_0_1 xhp1 xhn1 vdd vbsyn gsyn
X_ihx_1_1 a_xp1 a_xn1 wp_ih_1_1 wn_ih_1_1 xhp1 xhn1 vdd vbsyn gsyn
X_ihx_2_1 a_xp2 a_xn2 wp_ih_2_1 wn_ih_2_1 xhp1 xhn1 vdd vbsyn gsyn
X_ihx_3_1 a_xp3 a_xn3 wp_ih_3_1 wn_ih_3_1 xhp1 xhn1 vdd vbsyn gsyn
X_ihx_4_1 a_xp4 a_xn4 wp_ih_4_1 wn_ih_4_1 xhp1 xhn1 vdd vbsyn gsyn
X_ihx_5_1 a_xp5 a_xn5 wp_ih_5_1 wn_ih_5_1 xhp1 xhn1 vdd vbsyn gsyn
X_ihx_6_1 a_xp6 a_xn6 wp_ih_6_1 wn_ih_6_1 xhp1 xhn1 vdd vbsyn gsyn
X_ihx_7_1 a_xp7 a_xn7 wp_ih_7_1 wn_ih_7_1 xhp1 xhn1 vdd vbsyn gsyn
X_ihx_8_1 a_xp8 a_xn8 wp_ih_8_1 wn_ih_8_1 xhp1 xhn1 vdd vbsyn gsyn
X_ihx_9_1 a_xp9 a_xn9 wp_ih_9_1 wn_ih_9_1 xhp1 xhn1 vdd vbsyn gsyn
X_ihx_10_1 a_xp10 a_xn10 wp_ih_10_1 wn_ih_10_1 xhp1 xhn1 vdd vbsyn gsyn
X_ihx_11_1 a_xp11 a_xn11 wp_ih_11_1 wn_ih_11_1 xhp1 xhn1 vdd vbsyn gsyn
X_ihx_12_1 a_xp12 a_xn12 wp_ih_12_1 wn_ih_12_1 xhp1 xhn1 vdd vbsyn gsyn
X_ihx_13_1 a_xp13 a_xn13 wp_ih_13_1 wn_ih_13_1 xhp1 xhn1 vdd vbsyn gsyn
X_ihx_14_1 a_xp14 a_xn14 wp_ih_14_1 wn_ih_14_1 xhp1 xhn1 vdd vbsyn gsyn
X_ihx_15_1 a_xp15 a_xn15 wp_ih_15_1 wn_ih_15_1 xhp1 xhn1 vdd vbsyn gsyn
X_ihx_16_1 a_xp16 a_xn16 wp_ih_16_1 wn_ih_16_1 xhp1 xhn1 vdd vbsyn gsyn
X_ihx_17_1 a_xp17 a_xn17 wp_ih_17_1 wn_ih_17_1 xhp1 xhn1 vdd vbsyn gsyn
X_ihx_18_1 a_xp18 a_xn18 wp_ih_18_1 wn_ih_18_1 xhp1 xhn1 vdd vbsyn gsyn
X_ihx_19_1 a_xp19 a_xn19 wp_ih_19_1 wn_ih_19_1 xhp1 xhn1 vdd vbsyn gsyn
X_ihx_20_1 a_xp20 a_xn20 wp_ih_20_1 wn_ih_20_1 xhp1 xhn1 vdd vbsyn gsyn
X_ihx_21_1 a_xp21 a_xn21 wp_ih_21_1 wn_ih_21_1 xhp1 xhn1 vdd vbsyn gsyn
X_ihx_22_1 a_xp22 a_xn22 wp_ih_22_1 wn_ih_22_1 xhp1 xhn1 vdd vbsyn gsyn
X_ihx_23_1 a_xp23 a_xn23 wp_ih_23_1 wn_ih_23_1 xhp1 xhn1 vdd vbsyn gsyn
X_ihx_24_1 a_xp24 a_xn24 wp_ih_24_1 wn_ih_24_1 xhp1 xhn1 vdd vbsyn gsyn
X_ihx_25_1 a_xp25 a_xn25 wp_ih_25_1 wn_ih_25_1 xhp1 xhn1 vdd vbsyn gsyn
X_ihx_26_1 a_xp26 a_xn26 wp_ih_26_1 wn_ih_26_1 xhp1 xhn1 vdd vbsyn gsyn
X_ihx_27_1 a_xp27 a_xn27 wp_ih_27_1 wn_ih_27_1 xhp1 xhn1 vdd vbsyn gsyn
X_ihx_28_1 a_xp28 a_xn28 wp_ih_28_1 wn_ih_28_1 xhp1 xhn1 vdd vbsyn gsyn
X_ihx_29_1 a_xp29 a_xn29 wp_ih_29_1 wn_ih_29_1 xhp1 xhn1 vdd vbsyn gsyn
X_ihx_30_1 a_xp30 a_xn30 wp_ih_30_1 wn_ih_30_1 xhp1 xhn1 vdd vbsyn gsyn
X_ihx_31_1 a_xp31 a_xn31 wp_ih_31_1 wn_ih_31_1 xhp1 xhn1 vdd vbsyn gsyn
X_ihx_32_1 a_xp32 a_xn32 wp_ih_32_1 wn_ih_32_1 xhp1 xhn1 vdd vbsyn gsyn
X_ihx_33_1 a_xp33 a_xn33 wp_ih_33_1 wn_ih_33_1 xhp1 xhn1 vdd vbsyn gsyn
X_ihx_34_1 a_xp34 a_xn34 wp_ih_34_1 wn_ih_34_1 xhp1 xhn1 vdd vbsyn gsyn
X_ihx_35_1 a_xp35 a_xn35 wp_ih_35_1 wn_ih_35_1 xhp1 xhn1 vdd vbsyn gsyn
X_ihx_36_1 a_xp36 a_xn36 wp_ih_36_1 wn_ih_36_1 xhp1 xhn1 vdd vbsyn gsyn
X_ihx_37_1 a_xp37 a_xn37 wp_ih_37_1 wn_ih_37_1 xhp1 xhn1 vdd vbsyn gsyn
X_ihx_38_1 a_xp38 a_xn38 wp_ih_38_1 wn_ih_38_1 xhp1 xhn1 vdd vbsyn gsyn
X_ihx_39_1 a_xp39 a_xn39 wp_ih_39_1 wn_ih_39_1 xhp1 xhn1 vdd vbsyn gsyn
X_ihx_40_1 a_xp40 a_xn40 wp_ih_40_1 wn_ih_40_1 xhp1 xhn1 vdd vbsyn gsyn
X_ihx_41_1 a_xp41 a_xn41 wp_ih_41_1 wn_ih_41_1 xhp1 xhn1 vdd vbsyn gsyn
X_ihx_42_1 a_xp42 a_xn42 wp_ih_42_1 wn_ih_42_1 xhp1 xhn1 vdd vbsyn gsyn
X_ihx_43_1 a_xp43 a_xn43 wp_ih_43_1 wn_ih_43_1 xhp1 xhn1 vdd vbsyn gsyn
X_ihx_44_1 a_xp44 a_xn44 wp_ih_44_1 wn_ih_44_1 xhp1 xhn1 vdd vbsyn gsyn
X_ihx_45_1 a_xp45 a_xn45 wp_ih_45_1 wn_ih_45_1 xhp1 xhn1 vdd vbsyn gsyn
X_ihx_46_1 a_xp46 a_xn46 wp_ih_46_1 wn_ih_46_1 xhp1 xhn1 vdd vbsyn gsyn
X_ihx_47_1 a_xp47 a_xn47 wp_ih_47_1 wn_ih_47_1 xhp1 xhn1 vdd vbsyn gsyn
X_ihx_48_1 a_xp48 a_xn48 wp_ih_48_1 wn_ih_48_1 xhp1 xhn1 vdd vbsyn gsyn
X_ihx_49_1 a_xp49 a_xn49 wp_ih_49_1 wn_ih_49_1 xhp1 xhn1 vdd vbsyn gsyn
X_ihx_50_1 a_xp50 a_xn50 wp_ih_50_1 wn_ih_50_1 xhp1 xhn1 vdd vbsyn gsyn
X_ihx_51_1 a_xp51 a_xn51 wp_ih_51_1 wn_ih_51_1 xhp1 xhn1 vdd vbsyn gsyn
X_ihx_52_1 a_xp52 a_xn52 wp_ih_52_1 wn_ih_52_1 xhp1 xhn1 vdd vbsyn gsyn
X_ihx_53_1 a_xp53 a_xn53 wp_ih_53_1 wn_ih_53_1 xhp1 xhn1 vdd vbsyn gsyn
X_ihx_54_1 a_xp54 a_xn54 wp_ih_54_1 wn_ih_54_1 xhp1 xhn1 vdd vbsyn gsyn
X_ihx_55_1 a_xp55 a_xn55 wp_ih_55_1 wn_ih_55_1 xhp1 xhn1 vdd vbsyn gsyn
X_ihx_56_1 a_xp56 a_xn56 wp_ih_56_1 wn_ih_56_1 xhp1 xhn1 vdd vbsyn gsyn
X_ihx_57_1 a_xp57 a_xn57 wp_ih_57_1 wn_ih_57_1 xhp1 xhn1 vdd vbsyn gsyn
X_ihx_58_1 a_xp58 a_xn58 wp_ih_58_1 wn_ih_58_1 xhp1 xhn1 vdd vbsyn gsyn
X_ihx_59_1 a_xp59 a_xn59 wp_ih_59_1 wn_ih_59_1 xhp1 xhn1 vdd vbsyn gsyn
X_ihx_60_1 a_xp60 a_xn60 wp_ih_60_1 wn_ih_60_1 xhp1 xhn1 vdd vbsyn gsyn
X_ihx_61_1 a_xp61 a_xn61 wp_ih_61_1 wn_ih_61_1 xhp1 xhn1 vdd vbsyn gsyn
X_ihx_62_1 a_xp62 a_xn62 wp_ih_62_1 wn_ih_62_1 xhp1 xhn1 vdd vbsyn gsyn
X_ihx_63_1 a_xp63 a_xn63 wp_ih_63_1 wn_ih_63_1 xhp1 xhn1 vdd vbsyn gsyn
Xn1 xhp1 xhn1 ahp1 ahn1 vdd vbneu dneuron
Xcm_xh2 xhp2 xhn2 vdd cmld
Rnd_xh2 xhp2 xhn2 20k
X_ihx_0_2 a_xp0 a_xn0 wp_ih_0_2 wn_ih_0_2 xhp2 xhn2 vdd vbsyn gsyn
X_ihx_1_2 a_xp1 a_xn1 wp_ih_1_2 wn_ih_1_2 xhp2 xhn2 vdd vbsyn gsyn
X_ihx_2_2 a_xp2 a_xn2 wp_ih_2_2 wn_ih_2_2 xhp2 xhn2 vdd vbsyn gsyn
X_ihx_3_2 a_xp3 a_xn3 wp_ih_3_2 wn_ih_3_2 xhp2 xhn2 vdd vbsyn gsyn
X_ihx_4_2 a_xp4 a_xn4 wp_ih_4_2 wn_ih_4_2 xhp2 xhn2 vdd vbsyn gsyn
X_ihx_5_2 a_xp5 a_xn5 wp_ih_5_2 wn_ih_5_2 xhp2 xhn2 vdd vbsyn gsyn
X_ihx_6_2 a_xp6 a_xn6 wp_ih_6_2 wn_ih_6_2 xhp2 xhn2 vdd vbsyn gsyn
X_ihx_7_2 a_xp7 a_xn7 wp_ih_7_2 wn_ih_7_2 xhp2 xhn2 vdd vbsyn gsyn
X_ihx_8_2 a_xp8 a_xn8 wp_ih_8_2 wn_ih_8_2 xhp2 xhn2 vdd vbsyn gsyn
X_ihx_9_2 a_xp9 a_xn9 wp_ih_9_2 wn_ih_9_2 xhp2 xhn2 vdd vbsyn gsyn
X_ihx_10_2 a_xp10 a_xn10 wp_ih_10_2 wn_ih_10_2 xhp2 xhn2 vdd vbsyn gsyn
X_ihx_11_2 a_xp11 a_xn11 wp_ih_11_2 wn_ih_11_2 xhp2 xhn2 vdd vbsyn gsyn
X_ihx_12_2 a_xp12 a_xn12 wp_ih_12_2 wn_ih_12_2 xhp2 xhn2 vdd vbsyn gsyn
X_ihx_13_2 a_xp13 a_xn13 wp_ih_13_2 wn_ih_13_2 xhp2 xhn2 vdd vbsyn gsyn
X_ihx_14_2 a_xp14 a_xn14 wp_ih_14_2 wn_ih_14_2 xhp2 xhn2 vdd vbsyn gsyn
X_ihx_15_2 a_xp15 a_xn15 wp_ih_15_2 wn_ih_15_2 xhp2 xhn2 vdd vbsyn gsyn
X_ihx_16_2 a_xp16 a_xn16 wp_ih_16_2 wn_ih_16_2 xhp2 xhn2 vdd vbsyn gsyn
X_ihx_17_2 a_xp17 a_xn17 wp_ih_17_2 wn_ih_17_2 xhp2 xhn2 vdd vbsyn gsyn
X_ihx_18_2 a_xp18 a_xn18 wp_ih_18_2 wn_ih_18_2 xhp2 xhn2 vdd vbsyn gsyn
X_ihx_19_2 a_xp19 a_xn19 wp_ih_19_2 wn_ih_19_2 xhp2 xhn2 vdd vbsyn gsyn
X_ihx_20_2 a_xp20 a_xn20 wp_ih_20_2 wn_ih_20_2 xhp2 xhn2 vdd vbsyn gsyn
X_ihx_21_2 a_xp21 a_xn21 wp_ih_21_2 wn_ih_21_2 xhp2 xhn2 vdd vbsyn gsyn
X_ihx_22_2 a_xp22 a_xn22 wp_ih_22_2 wn_ih_22_2 xhp2 xhn2 vdd vbsyn gsyn
X_ihx_23_2 a_xp23 a_xn23 wp_ih_23_2 wn_ih_23_2 xhp2 xhn2 vdd vbsyn gsyn
X_ihx_24_2 a_xp24 a_xn24 wp_ih_24_2 wn_ih_24_2 xhp2 xhn2 vdd vbsyn gsyn
X_ihx_25_2 a_xp25 a_xn25 wp_ih_25_2 wn_ih_25_2 xhp2 xhn2 vdd vbsyn gsyn
X_ihx_26_2 a_xp26 a_xn26 wp_ih_26_2 wn_ih_26_2 xhp2 xhn2 vdd vbsyn gsyn
X_ihx_27_2 a_xp27 a_xn27 wp_ih_27_2 wn_ih_27_2 xhp2 xhn2 vdd vbsyn gsyn
X_ihx_28_2 a_xp28 a_xn28 wp_ih_28_2 wn_ih_28_2 xhp2 xhn2 vdd vbsyn gsyn
X_ihx_29_2 a_xp29 a_xn29 wp_ih_29_2 wn_ih_29_2 xhp2 xhn2 vdd vbsyn gsyn
X_ihx_30_2 a_xp30 a_xn30 wp_ih_30_2 wn_ih_30_2 xhp2 xhn2 vdd vbsyn gsyn
X_ihx_31_2 a_xp31 a_xn31 wp_ih_31_2 wn_ih_31_2 xhp2 xhn2 vdd vbsyn gsyn
X_ihx_32_2 a_xp32 a_xn32 wp_ih_32_2 wn_ih_32_2 xhp2 xhn2 vdd vbsyn gsyn
X_ihx_33_2 a_xp33 a_xn33 wp_ih_33_2 wn_ih_33_2 xhp2 xhn2 vdd vbsyn gsyn
X_ihx_34_2 a_xp34 a_xn34 wp_ih_34_2 wn_ih_34_2 xhp2 xhn2 vdd vbsyn gsyn
X_ihx_35_2 a_xp35 a_xn35 wp_ih_35_2 wn_ih_35_2 xhp2 xhn2 vdd vbsyn gsyn
X_ihx_36_2 a_xp36 a_xn36 wp_ih_36_2 wn_ih_36_2 xhp2 xhn2 vdd vbsyn gsyn
X_ihx_37_2 a_xp37 a_xn37 wp_ih_37_2 wn_ih_37_2 xhp2 xhn2 vdd vbsyn gsyn
X_ihx_38_2 a_xp38 a_xn38 wp_ih_38_2 wn_ih_38_2 xhp2 xhn2 vdd vbsyn gsyn
X_ihx_39_2 a_xp39 a_xn39 wp_ih_39_2 wn_ih_39_2 xhp2 xhn2 vdd vbsyn gsyn
X_ihx_40_2 a_xp40 a_xn40 wp_ih_40_2 wn_ih_40_2 xhp2 xhn2 vdd vbsyn gsyn
X_ihx_41_2 a_xp41 a_xn41 wp_ih_41_2 wn_ih_41_2 xhp2 xhn2 vdd vbsyn gsyn
X_ihx_42_2 a_xp42 a_xn42 wp_ih_42_2 wn_ih_42_2 xhp2 xhn2 vdd vbsyn gsyn
X_ihx_43_2 a_xp43 a_xn43 wp_ih_43_2 wn_ih_43_2 xhp2 xhn2 vdd vbsyn gsyn
X_ihx_44_2 a_xp44 a_xn44 wp_ih_44_2 wn_ih_44_2 xhp2 xhn2 vdd vbsyn gsyn
X_ihx_45_2 a_xp45 a_xn45 wp_ih_45_2 wn_ih_45_2 xhp2 xhn2 vdd vbsyn gsyn
X_ihx_46_2 a_xp46 a_xn46 wp_ih_46_2 wn_ih_46_2 xhp2 xhn2 vdd vbsyn gsyn
X_ihx_47_2 a_xp47 a_xn47 wp_ih_47_2 wn_ih_47_2 xhp2 xhn2 vdd vbsyn gsyn
X_ihx_48_2 a_xp48 a_xn48 wp_ih_48_2 wn_ih_48_2 xhp2 xhn2 vdd vbsyn gsyn
X_ihx_49_2 a_xp49 a_xn49 wp_ih_49_2 wn_ih_49_2 xhp2 xhn2 vdd vbsyn gsyn
X_ihx_50_2 a_xp50 a_xn50 wp_ih_50_2 wn_ih_50_2 xhp2 xhn2 vdd vbsyn gsyn
X_ihx_51_2 a_xp51 a_xn51 wp_ih_51_2 wn_ih_51_2 xhp2 xhn2 vdd vbsyn gsyn
X_ihx_52_2 a_xp52 a_xn52 wp_ih_52_2 wn_ih_52_2 xhp2 xhn2 vdd vbsyn gsyn
X_ihx_53_2 a_xp53 a_xn53 wp_ih_53_2 wn_ih_53_2 xhp2 xhn2 vdd vbsyn gsyn
X_ihx_54_2 a_xp54 a_xn54 wp_ih_54_2 wn_ih_54_2 xhp2 xhn2 vdd vbsyn gsyn
X_ihx_55_2 a_xp55 a_xn55 wp_ih_55_2 wn_ih_55_2 xhp2 xhn2 vdd vbsyn gsyn
X_ihx_56_2 a_xp56 a_xn56 wp_ih_56_2 wn_ih_56_2 xhp2 xhn2 vdd vbsyn gsyn
X_ihx_57_2 a_xp57 a_xn57 wp_ih_57_2 wn_ih_57_2 xhp2 xhn2 vdd vbsyn gsyn
X_ihx_58_2 a_xp58 a_xn58 wp_ih_58_2 wn_ih_58_2 xhp2 xhn2 vdd vbsyn gsyn
X_ihx_59_2 a_xp59 a_xn59 wp_ih_59_2 wn_ih_59_2 xhp2 xhn2 vdd vbsyn gsyn
X_ihx_60_2 a_xp60 a_xn60 wp_ih_60_2 wn_ih_60_2 xhp2 xhn2 vdd vbsyn gsyn
X_ihx_61_2 a_xp61 a_xn61 wp_ih_61_2 wn_ih_61_2 xhp2 xhn2 vdd vbsyn gsyn
X_ihx_62_2 a_xp62 a_xn62 wp_ih_62_2 wn_ih_62_2 xhp2 xhn2 vdd vbsyn gsyn
X_ihx_63_2 a_xp63 a_xn63 wp_ih_63_2 wn_ih_63_2 xhp2 xhn2 vdd vbsyn gsyn
Xn2 xhp2 xhn2 ahp2 ahn2 vdd vbneu dneuron
Xcm_xh3 xhp3 xhn3 vdd cmld
Rnd_xh3 xhp3 xhn3 20k
X_ihx_0_3 a_xp0 a_xn0 wp_ih_0_3 wn_ih_0_3 xhp3 xhn3 vdd vbsyn gsyn
X_ihx_1_3 a_xp1 a_xn1 wp_ih_1_3 wn_ih_1_3 xhp3 xhn3 vdd vbsyn gsyn
X_ihx_2_3 a_xp2 a_xn2 wp_ih_2_3 wn_ih_2_3 xhp3 xhn3 vdd vbsyn gsyn
X_ihx_3_3 a_xp3 a_xn3 wp_ih_3_3 wn_ih_3_3 xhp3 xhn3 vdd vbsyn gsyn
X_ihx_4_3 a_xp4 a_xn4 wp_ih_4_3 wn_ih_4_3 xhp3 xhn3 vdd vbsyn gsyn
X_ihx_5_3 a_xp5 a_xn5 wp_ih_5_3 wn_ih_5_3 xhp3 xhn3 vdd vbsyn gsyn
X_ihx_6_3 a_xp6 a_xn6 wp_ih_6_3 wn_ih_6_3 xhp3 xhn3 vdd vbsyn gsyn
X_ihx_7_3 a_xp7 a_xn7 wp_ih_7_3 wn_ih_7_3 xhp3 xhn3 vdd vbsyn gsyn
X_ihx_8_3 a_xp8 a_xn8 wp_ih_8_3 wn_ih_8_3 xhp3 xhn3 vdd vbsyn gsyn
X_ihx_9_3 a_xp9 a_xn9 wp_ih_9_3 wn_ih_9_3 xhp3 xhn3 vdd vbsyn gsyn
X_ihx_10_3 a_xp10 a_xn10 wp_ih_10_3 wn_ih_10_3 xhp3 xhn3 vdd vbsyn gsyn
X_ihx_11_3 a_xp11 a_xn11 wp_ih_11_3 wn_ih_11_3 xhp3 xhn3 vdd vbsyn gsyn
X_ihx_12_3 a_xp12 a_xn12 wp_ih_12_3 wn_ih_12_3 xhp3 xhn3 vdd vbsyn gsyn
X_ihx_13_3 a_xp13 a_xn13 wp_ih_13_3 wn_ih_13_3 xhp3 xhn3 vdd vbsyn gsyn
X_ihx_14_3 a_xp14 a_xn14 wp_ih_14_3 wn_ih_14_3 xhp3 xhn3 vdd vbsyn gsyn
X_ihx_15_3 a_xp15 a_xn15 wp_ih_15_3 wn_ih_15_3 xhp3 xhn3 vdd vbsyn gsyn
X_ihx_16_3 a_xp16 a_xn16 wp_ih_16_3 wn_ih_16_3 xhp3 xhn3 vdd vbsyn gsyn
X_ihx_17_3 a_xp17 a_xn17 wp_ih_17_3 wn_ih_17_3 xhp3 xhn3 vdd vbsyn gsyn
X_ihx_18_3 a_xp18 a_xn18 wp_ih_18_3 wn_ih_18_3 xhp3 xhn3 vdd vbsyn gsyn
X_ihx_19_3 a_xp19 a_xn19 wp_ih_19_3 wn_ih_19_3 xhp3 xhn3 vdd vbsyn gsyn
X_ihx_20_3 a_xp20 a_xn20 wp_ih_20_3 wn_ih_20_3 xhp3 xhn3 vdd vbsyn gsyn
X_ihx_21_3 a_xp21 a_xn21 wp_ih_21_3 wn_ih_21_3 xhp3 xhn3 vdd vbsyn gsyn
X_ihx_22_3 a_xp22 a_xn22 wp_ih_22_3 wn_ih_22_3 xhp3 xhn3 vdd vbsyn gsyn
X_ihx_23_3 a_xp23 a_xn23 wp_ih_23_3 wn_ih_23_3 xhp3 xhn3 vdd vbsyn gsyn
X_ihx_24_3 a_xp24 a_xn24 wp_ih_24_3 wn_ih_24_3 xhp3 xhn3 vdd vbsyn gsyn
X_ihx_25_3 a_xp25 a_xn25 wp_ih_25_3 wn_ih_25_3 xhp3 xhn3 vdd vbsyn gsyn
X_ihx_26_3 a_xp26 a_xn26 wp_ih_26_3 wn_ih_26_3 xhp3 xhn3 vdd vbsyn gsyn
X_ihx_27_3 a_xp27 a_xn27 wp_ih_27_3 wn_ih_27_3 xhp3 xhn3 vdd vbsyn gsyn
X_ihx_28_3 a_xp28 a_xn28 wp_ih_28_3 wn_ih_28_3 xhp3 xhn3 vdd vbsyn gsyn
X_ihx_29_3 a_xp29 a_xn29 wp_ih_29_3 wn_ih_29_3 xhp3 xhn3 vdd vbsyn gsyn
X_ihx_30_3 a_xp30 a_xn30 wp_ih_30_3 wn_ih_30_3 xhp3 xhn3 vdd vbsyn gsyn
X_ihx_31_3 a_xp31 a_xn31 wp_ih_31_3 wn_ih_31_3 xhp3 xhn3 vdd vbsyn gsyn
X_ihx_32_3 a_xp32 a_xn32 wp_ih_32_3 wn_ih_32_3 xhp3 xhn3 vdd vbsyn gsyn
X_ihx_33_3 a_xp33 a_xn33 wp_ih_33_3 wn_ih_33_3 xhp3 xhn3 vdd vbsyn gsyn
X_ihx_34_3 a_xp34 a_xn34 wp_ih_34_3 wn_ih_34_3 xhp3 xhn3 vdd vbsyn gsyn
X_ihx_35_3 a_xp35 a_xn35 wp_ih_35_3 wn_ih_35_3 xhp3 xhn3 vdd vbsyn gsyn
X_ihx_36_3 a_xp36 a_xn36 wp_ih_36_3 wn_ih_36_3 xhp3 xhn3 vdd vbsyn gsyn
X_ihx_37_3 a_xp37 a_xn37 wp_ih_37_3 wn_ih_37_3 xhp3 xhn3 vdd vbsyn gsyn
X_ihx_38_3 a_xp38 a_xn38 wp_ih_38_3 wn_ih_38_3 xhp3 xhn3 vdd vbsyn gsyn
X_ihx_39_3 a_xp39 a_xn39 wp_ih_39_3 wn_ih_39_3 xhp3 xhn3 vdd vbsyn gsyn
X_ihx_40_3 a_xp40 a_xn40 wp_ih_40_3 wn_ih_40_3 xhp3 xhn3 vdd vbsyn gsyn
X_ihx_41_3 a_xp41 a_xn41 wp_ih_41_3 wn_ih_41_3 xhp3 xhn3 vdd vbsyn gsyn
X_ihx_42_3 a_xp42 a_xn42 wp_ih_42_3 wn_ih_42_3 xhp3 xhn3 vdd vbsyn gsyn
X_ihx_43_3 a_xp43 a_xn43 wp_ih_43_3 wn_ih_43_3 xhp3 xhn3 vdd vbsyn gsyn
X_ihx_44_3 a_xp44 a_xn44 wp_ih_44_3 wn_ih_44_3 xhp3 xhn3 vdd vbsyn gsyn
X_ihx_45_3 a_xp45 a_xn45 wp_ih_45_3 wn_ih_45_3 xhp3 xhn3 vdd vbsyn gsyn
X_ihx_46_3 a_xp46 a_xn46 wp_ih_46_3 wn_ih_46_3 xhp3 xhn3 vdd vbsyn gsyn
X_ihx_47_3 a_xp47 a_xn47 wp_ih_47_3 wn_ih_47_3 xhp3 xhn3 vdd vbsyn gsyn
X_ihx_48_3 a_xp48 a_xn48 wp_ih_48_3 wn_ih_48_3 xhp3 xhn3 vdd vbsyn gsyn
X_ihx_49_3 a_xp49 a_xn49 wp_ih_49_3 wn_ih_49_3 xhp3 xhn3 vdd vbsyn gsyn
X_ihx_50_3 a_xp50 a_xn50 wp_ih_50_3 wn_ih_50_3 xhp3 xhn3 vdd vbsyn gsyn
X_ihx_51_3 a_xp51 a_xn51 wp_ih_51_3 wn_ih_51_3 xhp3 xhn3 vdd vbsyn gsyn
X_ihx_52_3 a_xp52 a_xn52 wp_ih_52_3 wn_ih_52_3 xhp3 xhn3 vdd vbsyn gsyn
X_ihx_53_3 a_xp53 a_xn53 wp_ih_53_3 wn_ih_53_3 xhp3 xhn3 vdd vbsyn gsyn
X_ihx_54_3 a_xp54 a_xn54 wp_ih_54_3 wn_ih_54_3 xhp3 xhn3 vdd vbsyn gsyn
X_ihx_55_3 a_xp55 a_xn55 wp_ih_55_3 wn_ih_55_3 xhp3 xhn3 vdd vbsyn gsyn
X_ihx_56_3 a_xp56 a_xn56 wp_ih_56_3 wn_ih_56_3 xhp3 xhn3 vdd vbsyn gsyn
X_ihx_57_3 a_xp57 a_xn57 wp_ih_57_3 wn_ih_57_3 xhp3 xhn3 vdd vbsyn gsyn
X_ihx_58_3 a_xp58 a_xn58 wp_ih_58_3 wn_ih_58_3 xhp3 xhn3 vdd vbsyn gsyn
X_ihx_59_3 a_xp59 a_xn59 wp_ih_59_3 wn_ih_59_3 xhp3 xhn3 vdd vbsyn gsyn
X_ihx_60_3 a_xp60 a_xn60 wp_ih_60_3 wn_ih_60_3 xhp3 xhn3 vdd vbsyn gsyn
X_ihx_61_3 a_xp61 a_xn61 wp_ih_61_3 wn_ih_61_3 xhp3 xhn3 vdd vbsyn gsyn
X_ihx_62_3 a_xp62 a_xn62 wp_ih_62_3 wn_ih_62_3 xhp3 xhn3 vdd vbsyn gsyn
X_ihx_63_3 a_xp63 a_xn63 wp_ih_63_3 wn_ih_63_3 xhp3 xhn3 vdd vbsyn gsyn
Xn3 xhp3 xhn3 ahp3 ahn3 vdd vbneu dneuron
Xcm_xh4 xhp4 xhn4 vdd cmld
Rnd_xh4 xhp4 xhn4 20k
X_ihx_0_4 a_xp0 a_xn0 wp_ih_0_4 wn_ih_0_4 xhp4 xhn4 vdd vbsyn gsyn
X_ihx_1_4 a_xp1 a_xn1 wp_ih_1_4 wn_ih_1_4 xhp4 xhn4 vdd vbsyn gsyn
X_ihx_2_4 a_xp2 a_xn2 wp_ih_2_4 wn_ih_2_4 xhp4 xhn4 vdd vbsyn gsyn
X_ihx_3_4 a_xp3 a_xn3 wp_ih_3_4 wn_ih_3_4 xhp4 xhn4 vdd vbsyn gsyn
X_ihx_4_4 a_xp4 a_xn4 wp_ih_4_4 wn_ih_4_4 xhp4 xhn4 vdd vbsyn gsyn
X_ihx_5_4 a_xp5 a_xn5 wp_ih_5_4 wn_ih_5_4 xhp4 xhn4 vdd vbsyn gsyn
X_ihx_6_4 a_xp6 a_xn6 wp_ih_6_4 wn_ih_6_4 xhp4 xhn4 vdd vbsyn gsyn
X_ihx_7_4 a_xp7 a_xn7 wp_ih_7_4 wn_ih_7_4 xhp4 xhn4 vdd vbsyn gsyn
X_ihx_8_4 a_xp8 a_xn8 wp_ih_8_4 wn_ih_8_4 xhp4 xhn4 vdd vbsyn gsyn
X_ihx_9_4 a_xp9 a_xn9 wp_ih_9_4 wn_ih_9_4 xhp4 xhn4 vdd vbsyn gsyn
X_ihx_10_4 a_xp10 a_xn10 wp_ih_10_4 wn_ih_10_4 xhp4 xhn4 vdd vbsyn gsyn
X_ihx_11_4 a_xp11 a_xn11 wp_ih_11_4 wn_ih_11_4 xhp4 xhn4 vdd vbsyn gsyn
X_ihx_12_4 a_xp12 a_xn12 wp_ih_12_4 wn_ih_12_4 xhp4 xhn4 vdd vbsyn gsyn
X_ihx_13_4 a_xp13 a_xn13 wp_ih_13_4 wn_ih_13_4 xhp4 xhn4 vdd vbsyn gsyn
X_ihx_14_4 a_xp14 a_xn14 wp_ih_14_4 wn_ih_14_4 xhp4 xhn4 vdd vbsyn gsyn
X_ihx_15_4 a_xp15 a_xn15 wp_ih_15_4 wn_ih_15_4 xhp4 xhn4 vdd vbsyn gsyn
X_ihx_16_4 a_xp16 a_xn16 wp_ih_16_4 wn_ih_16_4 xhp4 xhn4 vdd vbsyn gsyn
X_ihx_17_4 a_xp17 a_xn17 wp_ih_17_4 wn_ih_17_4 xhp4 xhn4 vdd vbsyn gsyn
X_ihx_18_4 a_xp18 a_xn18 wp_ih_18_4 wn_ih_18_4 xhp4 xhn4 vdd vbsyn gsyn
X_ihx_19_4 a_xp19 a_xn19 wp_ih_19_4 wn_ih_19_4 xhp4 xhn4 vdd vbsyn gsyn
X_ihx_20_4 a_xp20 a_xn20 wp_ih_20_4 wn_ih_20_4 xhp4 xhn4 vdd vbsyn gsyn
X_ihx_21_4 a_xp21 a_xn21 wp_ih_21_4 wn_ih_21_4 xhp4 xhn4 vdd vbsyn gsyn
X_ihx_22_4 a_xp22 a_xn22 wp_ih_22_4 wn_ih_22_4 xhp4 xhn4 vdd vbsyn gsyn
X_ihx_23_4 a_xp23 a_xn23 wp_ih_23_4 wn_ih_23_4 xhp4 xhn4 vdd vbsyn gsyn
X_ihx_24_4 a_xp24 a_xn24 wp_ih_24_4 wn_ih_24_4 xhp4 xhn4 vdd vbsyn gsyn
X_ihx_25_4 a_xp25 a_xn25 wp_ih_25_4 wn_ih_25_4 xhp4 xhn4 vdd vbsyn gsyn
X_ihx_26_4 a_xp26 a_xn26 wp_ih_26_4 wn_ih_26_4 xhp4 xhn4 vdd vbsyn gsyn
X_ihx_27_4 a_xp27 a_xn27 wp_ih_27_4 wn_ih_27_4 xhp4 xhn4 vdd vbsyn gsyn
X_ihx_28_4 a_xp28 a_xn28 wp_ih_28_4 wn_ih_28_4 xhp4 xhn4 vdd vbsyn gsyn
X_ihx_29_4 a_xp29 a_xn29 wp_ih_29_4 wn_ih_29_4 xhp4 xhn4 vdd vbsyn gsyn
X_ihx_30_4 a_xp30 a_xn30 wp_ih_30_4 wn_ih_30_4 xhp4 xhn4 vdd vbsyn gsyn
X_ihx_31_4 a_xp31 a_xn31 wp_ih_31_4 wn_ih_31_4 xhp4 xhn4 vdd vbsyn gsyn
X_ihx_32_4 a_xp32 a_xn32 wp_ih_32_4 wn_ih_32_4 xhp4 xhn4 vdd vbsyn gsyn
X_ihx_33_4 a_xp33 a_xn33 wp_ih_33_4 wn_ih_33_4 xhp4 xhn4 vdd vbsyn gsyn
X_ihx_34_4 a_xp34 a_xn34 wp_ih_34_4 wn_ih_34_4 xhp4 xhn4 vdd vbsyn gsyn
X_ihx_35_4 a_xp35 a_xn35 wp_ih_35_4 wn_ih_35_4 xhp4 xhn4 vdd vbsyn gsyn
X_ihx_36_4 a_xp36 a_xn36 wp_ih_36_4 wn_ih_36_4 xhp4 xhn4 vdd vbsyn gsyn
X_ihx_37_4 a_xp37 a_xn37 wp_ih_37_4 wn_ih_37_4 xhp4 xhn4 vdd vbsyn gsyn
X_ihx_38_4 a_xp38 a_xn38 wp_ih_38_4 wn_ih_38_4 xhp4 xhn4 vdd vbsyn gsyn
X_ihx_39_4 a_xp39 a_xn39 wp_ih_39_4 wn_ih_39_4 xhp4 xhn4 vdd vbsyn gsyn
X_ihx_40_4 a_xp40 a_xn40 wp_ih_40_4 wn_ih_40_4 xhp4 xhn4 vdd vbsyn gsyn
X_ihx_41_4 a_xp41 a_xn41 wp_ih_41_4 wn_ih_41_4 xhp4 xhn4 vdd vbsyn gsyn
X_ihx_42_4 a_xp42 a_xn42 wp_ih_42_4 wn_ih_42_4 xhp4 xhn4 vdd vbsyn gsyn
X_ihx_43_4 a_xp43 a_xn43 wp_ih_43_4 wn_ih_43_4 xhp4 xhn4 vdd vbsyn gsyn
X_ihx_44_4 a_xp44 a_xn44 wp_ih_44_4 wn_ih_44_4 xhp4 xhn4 vdd vbsyn gsyn
X_ihx_45_4 a_xp45 a_xn45 wp_ih_45_4 wn_ih_45_4 xhp4 xhn4 vdd vbsyn gsyn
X_ihx_46_4 a_xp46 a_xn46 wp_ih_46_4 wn_ih_46_4 xhp4 xhn4 vdd vbsyn gsyn
X_ihx_47_4 a_xp47 a_xn47 wp_ih_47_4 wn_ih_47_4 xhp4 xhn4 vdd vbsyn gsyn
X_ihx_48_4 a_xp48 a_xn48 wp_ih_48_4 wn_ih_48_4 xhp4 xhn4 vdd vbsyn gsyn
X_ihx_49_4 a_xp49 a_xn49 wp_ih_49_4 wn_ih_49_4 xhp4 xhn4 vdd vbsyn gsyn
X_ihx_50_4 a_xp50 a_xn50 wp_ih_50_4 wn_ih_50_4 xhp4 xhn4 vdd vbsyn gsyn
X_ihx_51_4 a_xp51 a_xn51 wp_ih_51_4 wn_ih_51_4 xhp4 xhn4 vdd vbsyn gsyn
X_ihx_52_4 a_xp52 a_xn52 wp_ih_52_4 wn_ih_52_4 xhp4 xhn4 vdd vbsyn gsyn
X_ihx_53_4 a_xp53 a_xn53 wp_ih_53_4 wn_ih_53_4 xhp4 xhn4 vdd vbsyn gsyn
X_ihx_54_4 a_xp54 a_xn54 wp_ih_54_4 wn_ih_54_4 xhp4 xhn4 vdd vbsyn gsyn
X_ihx_55_4 a_xp55 a_xn55 wp_ih_55_4 wn_ih_55_4 xhp4 xhn4 vdd vbsyn gsyn
X_ihx_56_4 a_xp56 a_xn56 wp_ih_56_4 wn_ih_56_4 xhp4 xhn4 vdd vbsyn gsyn
X_ihx_57_4 a_xp57 a_xn57 wp_ih_57_4 wn_ih_57_4 xhp4 xhn4 vdd vbsyn gsyn
X_ihx_58_4 a_xp58 a_xn58 wp_ih_58_4 wn_ih_58_4 xhp4 xhn4 vdd vbsyn gsyn
X_ihx_59_4 a_xp59 a_xn59 wp_ih_59_4 wn_ih_59_4 xhp4 xhn4 vdd vbsyn gsyn
X_ihx_60_4 a_xp60 a_xn60 wp_ih_60_4 wn_ih_60_4 xhp4 xhn4 vdd vbsyn gsyn
X_ihx_61_4 a_xp61 a_xn61 wp_ih_61_4 wn_ih_61_4 xhp4 xhn4 vdd vbsyn gsyn
X_ihx_62_4 a_xp62 a_xn62 wp_ih_62_4 wn_ih_62_4 xhp4 xhn4 vdd vbsyn gsyn
X_ihx_63_4 a_xp63 a_xn63 wp_ih_63_4 wn_ih_63_4 xhp4 xhn4 vdd vbsyn gsyn
Xn4 xhp4 xhn4 ahp4 ahn4 vdd vbneu dneuron
Xcm_xh5 xhp5 xhn5 vdd cmld
Rnd_xh5 xhp5 xhn5 20k
X_ihx_0_5 a_xp0 a_xn0 wp_ih_0_5 wn_ih_0_5 xhp5 xhn5 vdd vbsyn gsyn
X_ihx_1_5 a_xp1 a_xn1 wp_ih_1_5 wn_ih_1_5 xhp5 xhn5 vdd vbsyn gsyn
X_ihx_2_5 a_xp2 a_xn2 wp_ih_2_5 wn_ih_2_5 xhp5 xhn5 vdd vbsyn gsyn
X_ihx_3_5 a_xp3 a_xn3 wp_ih_3_5 wn_ih_3_5 xhp5 xhn5 vdd vbsyn gsyn
X_ihx_4_5 a_xp4 a_xn4 wp_ih_4_5 wn_ih_4_5 xhp5 xhn5 vdd vbsyn gsyn
X_ihx_5_5 a_xp5 a_xn5 wp_ih_5_5 wn_ih_5_5 xhp5 xhn5 vdd vbsyn gsyn
X_ihx_6_5 a_xp6 a_xn6 wp_ih_6_5 wn_ih_6_5 xhp5 xhn5 vdd vbsyn gsyn
X_ihx_7_5 a_xp7 a_xn7 wp_ih_7_5 wn_ih_7_5 xhp5 xhn5 vdd vbsyn gsyn
X_ihx_8_5 a_xp8 a_xn8 wp_ih_8_5 wn_ih_8_5 xhp5 xhn5 vdd vbsyn gsyn
X_ihx_9_5 a_xp9 a_xn9 wp_ih_9_5 wn_ih_9_5 xhp5 xhn5 vdd vbsyn gsyn
X_ihx_10_5 a_xp10 a_xn10 wp_ih_10_5 wn_ih_10_5 xhp5 xhn5 vdd vbsyn gsyn
X_ihx_11_5 a_xp11 a_xn11 wp_ih_11_5 wn_ih_11_5 xhp5 xhn5 vdd vbsyn gsyn
X_ihx_12_5 a_xp12 a_xn12 wp_ih_12_5 wn_ih_12_5 xhp5 xhn5 vdd vbsyn gsyn
X_ihx_13_5 a_xp13 a_xn13 wp_ih_13_5 wn_ih_13_5 xhp5 xhn5 vdd vbsyn gsyn
X_ihx_14_5 a_xp14 a_xn14 wp_ih_14_5 wn_ih_14_5 xhp5 xhn5 vdd vbsyn gsyn
X_ihx_15_5 a_xp15 a_xn15 wp_ih_15_5 wn_ih_15_5 xhp5 xhn5 vdd vbsyn gsyn
X_ihx_16_5 a_xp16 a_xn16 wp_ih_16_5 wn_ih_16_5 xhp5 xhn5 vdd vbsyn gsyn
X_ihx_17_5 a_xp17 a_xn17 wp_ih_17_5 wn_ih_17_5 xhp5 xhn5 vdd vbsyn gsyn
X_ihx_18_5 a_xp18 a_xn18 wp_ih_18_5 wn_ih_18_5 xhp5 xhn5 vdd vbsyn gsyn
X_ihx_19_5 a_xp19 a_xn19 wp_ih_19_5 wn_ih_19_5 xhp5 xhn5 vdd vbsyn gsyn
X_ihx_20_5 a_xp20 a_xn20 wp_ih_20_5 wn_ih_20_5 xhp5 xhn5 vdd vbsyn gsyn
X_ihx_21_5 a_xp21 a_xn21 wp_ih_21_5 wn_ih_21_5 xhp5 xhn5 vdd vbsyn gsyn
X_ihx_22_5 a_xp22 a_xn22 wp_ih_22_5 wn_ih_22_5 xhp5 xhn5 vdd vbsyn gsyn
X_ihx_23_5 a_xp23 a_xn23 wp_ih_23_5 wn_ih_23_5 xhp5 xhn5 vdd vbsyn gsyn
X_ihx_24_5 a_xp24 a_xn24 wp_ih_24_5 wn_ih_24_5 xhp5 xhn5 vdd vbsyn gsyn
X_ihx_25_5 a_xp25 a_xn25 wp_ih_25_5 wn_ih_25_5 xhp5 xhn5 vdd vbsyn gsyn
X_ihx_26_5 a_xp26 a_xn26 wp_ih_26_5 wn_ih_26_5 xhp5 xhn5 vdd vbsyn gsyn
X_ihx_27_5 a_xp27 a_xn27 wp_ih_27_5 wn_ih_27_5 xhp5 xhn5 vdd vbsyn gsyn
X_ihx_28_5 a_xp28 a_xn28 wp_ih_28_5 wn_ih_28_5 xhp5 xhn5 vdd vbsyn gsyn
X_ihx_29_5 a_xp29 a_xn29 wp_ih_29_5 wn_ih_29_5 xhp5 xhn5 vdd vbsyn gsyn
X_ihx_30_5 a_xp30 a_xn30 wp_ih_30_5 wn_ih_30_5 xhp5 xhn5 vdd vbsyn gsyn
X_ihx_31_5 a_xp31 a_xn31 wp_ih_31_5 wn_ih_31_5 xhp5 xhn5 vdd vbsyn gsyn
X_ihx_32_5 a_xp32 a_xn32 wp_ih_32_5 wn_ih_32_5 xhp5 xhn5 vdd vbsyn gsyn
X_ihx_33_5 a_xp33 a_xn33 wp_ih_33_5 wn_ih_33_5 xhp5 xhn5 vdd vbsyn gsyn
X_ihx_34_5 a_xp34 a_xn34 wp_ih_34_5 wn_ih_34_5 xhp5 xhn5 vdd vbsyn gsyn
X_ihx_35_5 a_xp35 a_xn35 wp_ih_35_5 wn_ih_35_5 xhp5 xhn5 vdd vbsyn gsyn
X_ihx_36_5 a_xp36 a_xn36 wp_ih_36_5 wn_ih_36_5 xhp5 xhn5 vdd vbsyn gsyn
X_ihx_37_5 a_xp37 a_xn37 wp_ih_37_5 wn_ih_37_5 xhp5 xhn5 vdd vbsyn gsyn
X_ihx_38_5 a_xp38 a_xn38 wp_ih_38_5 wn_ih_38_5 xhp5 xhn5 vdd vbsyn gsyn
X_ihx_39_5 a_xp39 a_xn39 wp_ih_39_5 wn_ih_39_5 xhp5 xhn5 vdd vbsyn gsyn
X_ihx_40_5 a_xp40 a_xn40 wp_ih_40_5 wn_ih_40_5 xhp5 xhn5 vdd vbsyn gsyn
X_ihx_41_5 a_xp41 a_xn41 wp_ih_41_5 wn_ih_41_5 xhp5 xhn5 vdd vbsyn gsyn
X_ihx_42_5 a_xp42 a_xn42 wp_ih_42_5 wn_ih_42_5 xhp5 xhn5 vdd vbsyn gsyn
X_ihx_43_5 a_xp43 a_xn43 wp_ih_43_5 wn_ih_43_5 xhp5 xhn5 vdd vbsyn gsyn
X_ihx_44_5 a_xp44 a_xn44 wp_ih_44_5 wn_ih_44_5 xhp5 xhn5 vdd vbsyn gsyn
X_ihx_45_5 a_xp45 a_xn45 wp_ih_45_5 wn_ih_45_5 xhp5 xhn5 vdd vbsyn gsyn
X_ihx_46_5 a_xp46 a_xn46 wp_ih_46_5 wn_ih_46_5 xhp5 xhn5 vdd vbsyn gsyn
X_ihx_47_5 a_xp47 a_xn47 wp_ih_47_5 wn_ih_47_5 xhp5 xhn5 vdd vbsyn gsyn
X_ihx_48_5 a_xp48 a_xn48 wp_ih_48_5 wn_ih_48_5 xhp5 xhn5 vdd vbsyn gsyn
X_ihx_49_5 a_xp49 a_xn49 wp_ih_49_5 wn_ih_49_5 xhp5 xhn5 vdd vbsyn gsyn
X_ihx_50_5 a_xp50 a_xn50 wp_ih_50_5 wn_ih_50_5 xhp5 xhn5 vdd vbsyn gsyn
X_ihx_51_5 a_xp51 a_xn51 wp_ih_51_5 wn_ih_51_5 xhp5 xhn5 vdd vbsyn gsyn
X_ihx_52_5 a_xp52 a_xn52 wp_ih_52_5 wn_ih_52_5 xhp5 xhn5 vdd vbsyn gsyn
X_ihx_53_5 a_xp53 a_xn53 wp_ih_53_5 wn_ih_53_5 xhp5 xhn5 vdd vbsyn gsyn
X_ihx_54_5 a_xp54 a_xn54 wp_ih_54_5 wn_ih_54_5 xhp5 xhn5 vdd vbsyn gsyn
X_ihx_55_5 a_xp55 a_xn55 wp_ih_55_5 wn_ih_55_5 xhp5 xhn5 vdd vbsyn gsyn
X_ihx_56_5 a_xp56 a_xn56 wp_ih_56_5 wn_ih_56_5 xhp5 xhn5 vdd vbsyn gsyn
X_ihx_57_5 a_xp57 a_xn57 wp_ih_57_5 wn_ih_57_5 xhp5 xhn5 vdd vbsyn gsyn
X_ihx_58_5 a_xp58 a_xn58 wp_ih_58_5 wn_ih_58_5 xhp5 xhn5 vdd vbsyn gsyn
X_ihx_59_5 a_xp59 a_xn59 wp_ih_59_5 wn_ih_59_5 xhp5 xhn5 vdd vbsyn gsyn
X_ihx_60_5 a_xp60 a_xn60 wp_ih_60_5 wn_ih_60_5 xhp5 xhn5 vdd vbsyn gsyn
X_ihx_61_5 a_xp61 a_xn61 wp_ih_61_5 wn_ih_61_5 xhp5 xhn5 vdd vbsyn gsyn
X_ihx_62_5 a_xp62 a_xn62 wp_ih_62_5 wn_ih_62_5 xhp5 xhn5 vdd vbsyn gsyn
X_ihx_63_5 a_xp63 a_xn63 wp_ih_63_5 wn_ih_63_5 xhp5 xhn5 vdd vbsyn gsyn
Xn5 xhp5 xhn5 ahp5 ahn5 vdd vbneu dneuron
Xcm_xh6 xhp6 xhn6 vdd cmld
Rnd_xh6 xhp6 xhn6 20k
X_ihx_0_6 a_xp0 a_xn0 wp_ih_0_6 wn_ih_0_6 xhp6 xhn6 vdd vbsyn gsyn
X_ihx_1_6 a_xp1 a_xn1 wp_ih_1_6 wn_ih_1_6 xhp6 xhn6 vdd vbsyn gsyn
X_ihx_2_6 a_xp2 a_xn2 wp_ih_2_6 wn_ih_2_6 xhp6 xhn6 vdd vbsyn gsyn
X_ihx_3_6 a_xp3 a_xn3 wp_ih_3_6 wn_ih_3_6 xhp6 xhn6 vdd vbsyn gsyn
X_ihx_4_6 a_xp4 a_xn4 wp_ih_4_6 wn_ih_4_6 xhp6 xhn6 vdd vbsyn gsyn
X_ihx_5_6 a_xp5 a_xn5 wp_ih_5_6 wn_ih_5_6 xhp6 xhn6 vdd vbsyn gsyn
X_ihx_6_6 a_xp6 a_xn6 wp_ih_6_6 wn_ih_6_6 xhp6 xhn6 vdd vbsyn gsyn
X_ihx_7_6 a_xp7 a_xn7 wp_ih_7_6 wn_ih_7_6 xhp6 xhn6 vdd vbsyn gsyn
X_ihx_8_6 a_xp8 a_xn8 wp_ih_8_6 wn_ih_8_6 xhp6 xhn6 vdd vbsyn gsyn
X_ihx_9_6 a_xp9 a_xn9 wp_ih_9_6 wn_ih_9_6 xhp6 xhn6 vdd vbsyn gsyn
X_ihx_10_6 a_xp10 a_xn10 wp_ih_10_6 wn_ih_10_6 xhp6 xhn6 vdd vbsyn gsyn
X_ihx_11_6 a_xp11 a_xn11 wp_ih_11_6 wn_ih_11_6 xhp6 xhn6 vdd vbsyn gsyn
X_ihx_12_6 a_xp12 a_xn12 wp_ih_12_6 wn_ih_12_6 xhp6 xhn6 vdd vbsyn gsyn
X_ihx_13_6 a_xp13 a_xn13 wp_ih_13_6 wn_ih_13_6 xhp6 xhn6 vdd vbsyn gsyn
X_ihx_14_6 a_xp14 a_xn14 wp_ih_14_6 wn_ih_14_6 xhp6 xhn6 vdd vbsyn gsyn
X_ihx_15_6 a_xp15 a_xn15 wp_ih_15_6 wn_ih_15_6 xhp6 xhn6 vdd vbsyn gsyn
X_ihx_16_6 a_xp16 a_xn16 wp_ih_16_6 wn_ih_16_6 xhp6 xhn6 vdd vbsyn gsyn
X_ihx_17_6 a_xp17 a_xn17 wp_ih_17_6 wn_ih_17_6 xhp6 xhn6 vdd vbsyn gsyn
X_ihx_18_6 a_xp18 a_xn18 wp_ih_18_6 wn_ih_18_6 xhp6 xhn6 vdd vbsyn gsyn
X_ihx_19_6 a_xp19 a_xn19 wp_ih_19_6 wn_ih_19_6 xhp6 xhn6 vdd vbsyn gsyn
X_ihx_20_6 a_xp20 a_xn20 wp_ih_20_6 wn_ih_20_6 xhp6 xhn6 vdd vbsyn gsyn
X_ihx_21_6 a_xp21 a_xn21 wp_ih_21_6 wn_ih_21_6 xhp6 xhn6 vdd vbsyn gsyn
X_ihx_22_6 a_xp22 a_xn22 wp_ih_22_6 wn_ih_22_6 xhp6 xhn6 vdd vbsyn gsyn
X_ihx_23_6 a_xp23 a_xn23 wp_ih_23_6 wn_ih_23_6 xhp6 xhn6 vdd vbsyn gsyn
X_ihx_24_6 a_xp24 a_xn24 wp_ih_24_6 wn_ih_24_6 xhp6 xhn6 vdd vbsyn gsyn
X_ihx_25_6 a_xp25 a_xn25 wp_ih_25_6 wn_ih_25_6 xhp6 xhn6 vdd vbsyn gsyn
X_ihx_26_6 a_xp26 a_xn26 wp_ih_26_6 wn_ih_26_6 xhp6 xhn6 vdd vbsyn gsyn
X_ihx_27_6 a_xp27 a_xn27 wp_ih_27_6 wn_ih_27_6 xhp6 xhn6 vdd vbsyn gsyn
X_ihx_28_6 a_xp28 a_xn28 wp_ih_28_6 wn_ih_28_6 xhp6 xhn6 vdd vbsyn gsyn
X_ihx_29_6 a_xp29 a_xn29 wp_ih_29_6 wn_ih_29_6 xhp6 xhn6 vdd vbsyn gsyn
X_ihx_30_6 a_xp30 a_xn30 wp_ih_30_6 wn_ih_30_6 xhp6 xhn6 vdd vbsyn gsyn
X_ihx_31_6 a_xp31 a_xn31 wp_ih_31_6 wn_ih_31_6 xhp6 xhn6 vdd vbsyn gsyn
X_ihx_32_6 a_xp32 a_xn32 wp_ih_32_6 wn_ih_32_6 xhp6 xhn6 vdd vbsyn gsyn
X_ihx_33_6 a_xp33 a_xn33 wp_ih_33_6 wn_ih_33_6 xhp6 xhn6 vdd vbsyn gsyn
X_ihx_34_6 a_xp34 a_xn34 wp_ih_34_6 wn_ih_34_6 xhp6 xhn6 vdd vbsyn gsyn
X_ihx_35_6 a_xp35 a_xn35 wp_ih_35_6 wn_ih_35_6 xhp6 xhn6 vdd vbsyn gsyn
X_ihx_36_6 a_xp36 a_xn36 wp_ih_36_6 wn_ih_36_6 xhp6 xhn6 vdd vbsyn gsyn
X_ihx_37_6 a_xp37 a_xn37 wp_ih_37_6 wn_ih_37_6 xhp6 xhn6 vdd vbsyn gsyn
X_ihx_38_6 a_xp38 a_xn38 wp_ih_38_6 wn_ih_38_6 xhp6 xhn6 vdd vbsyn gsyn
X_ihx_39_6 a_xp39 a_xn39 wp_ih_39_6 wn_ih_39_6 xhp6 xhn6 vdd vbsyn gsyn
X_ihx_40_6 a_xp40 a_xn40 wp_ih_40_6 wn_ih_40_6 xhp6 xhn6 vdd vbsyn gsyn
X_ihx_41_6 a_xp41 a_xn41 wp_ih_41_6 wn_ih_41_6 xhp6 xhn6 vdd vbsyn gsyn
X_ihx_42_6 a_xp42 a_xn42 wp_ih_42_6 wn_ih_42_6 xhp6 xhn6 vdd vbsyn gsyn
X_ihx_43_6 a_xp43 a_xn43 wp_ih_43_6 wn_ih_43_6 xhp6 xhn6 vdd vbsyn gsyn
X_ihx_44_6 a_xp44 a_xn44 wp_ih_44_6 wn_ih_44_6 xhp6 xhn6 vdd vbsyn gsyn
X_ihx_45_6 a_xp45 a_xn45 wp_ih_45_6 wn_ih_45_6 xhp6 xhn6 vdd vbsyn gsyn
X_ihx_46_6 a_xp46 a_xn46 wp_ih_46_6 wn_ih_46_6 xhp6 xhn6 vdd vbsyn gsyn
X_ihx_47_6 a_xp47 a_xn47 wp_ih_47_6 wn_ih_47_6 xhp6 xhn6 vdd vbsyn gsyn
X_ihx_48_6 a_xp48 a_xn48 wp_ih_48_6 wn_ih_48_6 xhp6 xhn6 vdd vbsyn gsyn
X_ihx_49_6 a_xp49 a_xn49 wp_ih_49_6 wn_ih_49_6 xhp6 xhn6 vdd vbsyn gsyn
X_ihx_50_6 a_xp50 a_xn50 wp_ih_50_6 wn_ih_50_6 xhp6 xhn6 vdd vbsyn gsyn
X_ihx_51_6 a_xp51 a_xn51 wp_ih_51_6 wn_ih_51_6 xhp6 xhn6 vdd vbsyn gsyn
X_ihx_52_6 a_xp52 a_xn52 wp_ih_52_6 wn_ih_52_6 xhp6 xhn6 vdd vbsyn gsyn
X_ihx_53_6 a_xp53 a_xn53 wp_ih_53_6 wn_ih_53_6 xhp6 xhn6 vdd vbsyn gsyn
X_ihx_54_6 a_xp54 a_xn54 wp_ih_54_6 wn_ih_54_6 xhp6 xhn6 vdd vbsyn gsyn
X_ihx_55_6 a_xp55 a_xn55 wp_ih_55_6 wn_ih_55_6 xhp6 xhn6 vdd vbsyn gsyn
X_ihx_56_6 a_xp56 a_xn56 wp_ih_56_6 wn_ih_56_6 xhp6 xhn6 vdd vbsyn gsyn
X_ihx_57_6 a_xp57 a_xn57 wp_ih_57_6 wn_ih_57_6 xhp6 xhn6 vdd vbsyn gsyn
X_ihx_58_6 a_xp58 a_xn58 wp_ih_58_6 wn_ih_58_6 xhp6 xhn6 vdd vbsyn gsyn
X_ihx_59_6 a_xp59 a_xn59 wp_ih_59_6 wn_ih_59_6 xhp6 xhn6 vdd vbsyn gsyn
X_ihx_60_6 a_xp60 a_xn60 wp_ih_60_6 wn_ih_60_6 xhp6 xhn6 vdd vbsyn gsyn
X_ihx_61_6 a_xp61 a_xn61 wp_ih_61_6 wn_ih_61_6 xhp6 xhn6 vdd vbsyn gsyn
X_ihx_62_6 a_xp62 a_xn62 wp_ih_62_6 wn_ih_62_6 xhp6 xhn6 vdd vbsyn gsyn
X_ihx_63_6 a_xp63 a_xn63 wp_ih_63_6 wn_ih_63_6 xhp6 xhn6 vdd vbsyn gsyn
Xn6 xhp6 xhn6 ahp6 ahn6 vdd vbneu dneuron
Xcm_xh7 xhp7 xhn7 vdd cmld
Rnd_xh7 xhp7 xhn7 20k
X_ihx_0_7 a_xp0 a_xn0 wp_ih_0_7 wn_ih_0_7 xhp7 xhn7 vdd vbsyn gsyn
X_ihx_1_7 a_xp1 a_xn1 wp_ih_1_7 wn_ih_1_7 xhp7 xhn7 vdd vbsyn gsyn
X_ihx_2_7 a_xp2 a_xn2 wp_ih_2_7 wn_ih_2_7 xhp7 xhn7 vdd vbsyn gsyn
X_ihx_3_7 a_xp3 a_xn3 wp_ih_3_7 wn_ih_3_7 xhp7 xhn7 vdd vbsyn gsyn
X_ihx_4_7 a_xp4 a_xn4 wp_ih_4_7 wn_ih_4_7 xhp7 xhn7 vdd vbsyn gsyn
X_ihx_5_7 a_xp5 a_xn5 wp_ih_5_7 wn_ih_5_7 xhp7 xhn7 vdd vbsyn gsyn
X_ihx_6_7 a_xp6 a_xn6 wp_ih_6_7 wn_ih_6_7 xhp7 xhn7 vdd vbsyn gsyn
X_ihx_7_7 a_xp7 a_xn7 wp_ih_7_7 wn_ih_7_7 xhp7 xhn7 vdd vbsyn gsyn
X_ihx_8_7 a_xp8 a_xn8 wp_ih_8_7 wn_ih_8_7 xhp7 xhn7 vdd vbsyn gsyn
X_ihx_9_7 a_xp9 a_xn9 wp_ih_9_7 wn_ih_9_7 xhp7 xhn7 vdd vbsyn gsyn
X_ihx_10_7 a_xp10 a_xn10 wp_ih_10_7 wn_ih_10_7 xhp7 xhn7 vdd vbsyn gsyn
X_ihx_11_7 a_xp11 a_xn11 wp_ih_11_7 wn_ih_11_7 xhp7 xhn7 vdd vbsyn gsyn
X_ihx_12_7 a_xp12 a_xn12 wp_ih_12_7 wn_ih_12_7 xhp7 xhn7 vdd vbsyn gsyn
X_ihx_13_7 a_xp13 a_xn13 wp_ih_13_7 wn_ih_13_7 xhp7 xhn7 vdd vbsyn gsyn
X_ihx_14_7 a_xp14 a_xn14 wp_ih_14_7 wn_ih_14_7 xhp7 xhn7 vdd vbsyn gsyn
X_ihx_15_7 a_xp15 a_xn15 wp_ih_15_7 wn_ih_15_7 xhp7 xhn7 vdd vbsyn gsyn
X_ihx_16_7 a_xp16 a_xn16 wp_ih_16_7 wn_ih_16_7 xhp7 xhn7 vdd vbsyn gsyn
X_ihx_17_7 a_xp17 a_xn17 wp_ih_17_7 wn_ih_17_7 xhp7 xhn7 vdd vbsyn gsyn
X_ihx_18_7 a_xp18 a_xn18 wp_ih_18_7 wn_ih_18_7 xhp7 xhn7 vdd vbsyn gsyn
X_ihx_19_7 a_xp19 a_xn19 wp_ih_19_7 wn_ih_19_7 xhp7 xhn7 vdd vbsyn gsyn
X_ihx_20_7 a_xp20 a_xn20 wp_ih_20_7 wn_ih_20_7 xhp7 xhn7 vdd vbsyn gsyn
X_ihx_21_7 a_xp21 a_xn21 wp_ih_21_7 wn_ih_21_7 xhp7 xhn7 vdd vbsyn gsyn
X_ihx_22_7 a_xp22 a_xn22 wp_ih_22_7 wn_ih_22_7 xhp7 xhn7 vdd vbsyn gsyn
X_ihx_23_7 a_xp23 a_xn23 wp_ih_23_7 wn_ih_23_7 xhp7 xhn7 vdd vbsyn gsyn
X_ihx_24_7 a_xp24 a_xn24 wp_ih_24_7 wn_ih_24_7 xhp7 xhn7 vdd vbsyn gsyn
X_ihx_25_7 a_xp25 a_xn25 wp_ih_25_7 wn_ih_25_7 xhp7 xhn7 vdd vbsyn gsyn
X_ihx_26_7 a_xp26 a_xn26 wp_ih_26_7 wn_ih_26_7 xhp7 xhn7 vdd vbsyn gsyn
X_ihx_27_7 a_xp27 a_xn27 wp_ih_27_7 wn_ih_27_7 xhp7 xhn7 vdd vbsyn gsyn
X_ihx_28_7 a_xp28 a_xn28 wp_ih_28_7 wn_ih_28_7 xhp7 xhn7 vdd vbsyn gsyn
X_ihx_29_7 a_xp29 a_xn29 wp_ih_29_7 wn_ih_29_7 xhp7 xhn7 vdd vbsyn gsyn
X_ihx_30_7 a_xp30 a_xn30 wp_ih_30_7 wn_ih_30_7 xhp7 xhn7 vdd vbsyn gsyn
X_ihx_31_7 a_xp31 a_xn31 wp_ih_31_7 wn_ih_31_7 xhp7 xhn7 vdd vbsyn gsyn
X_ihx_32_7 a_xp32 a_xn32 wp_ih_32_7 wn_ih_32_7 xhp7 xhn7 vdd vbsyn gsyn
X_ihx_33_7 a_xp33 a_xn33 wp_ih_33_7 wn_ih_33_7 xhp7 xhn7 vdd vbsyn gsyn
X_ihx_34_7 a_xp34 a_xn34 wp_ih_34_7 wn_ih_34_7 xhp7 xhn7 vdd vbsyn gsyn
X_ihx_35_7 a_xp35 a_xn35 wp_ih_35_7 wn_ih_35_7 xhp7 xhn7 vdd vbsyn gsyn
X_ihx_36_7 a_xp36 a_xn36 wp_ih_36_7 wn_ih_36_7 xhp7 xhn7 vdd vbsyn gsyn
X_ihx_37_7 a_xp37 a_xn37 wp_ih_37_7 wn_ih_37_7 xhp7 xhn7 vdd vbsyn gsyn
X_ihx_38_7 a_xp38 a_xn38 wp_ih_38_7 wn_ih_38_7 xhp7 xhn7 vdd vbsyn gsyn
X_ihx_39_7 a_xp39 a_xn39 wp_ih_39_7 wn_ih_39_7 xhp7 xhn7 vdd vbsyn gsyn
X_ihx_40_7 a_xp40 a_xn40 wp_ih_40_7 wn_ih_40_7 xhp7 xhn7 vdd vbsyn gsyn
X_ihx_41_7 a_xp41 a_xn41 wp_ih_41_7 wn_ih_41_7 xhp7 xhn7 vdd vbsyn gsyn
X_ihx_42_7 a_xp42 a_xn42 wp_ih_42_7 wn_ih_42_7 xhp7 xhn7 vdd vbsyn gsyn
X_ihx_43_7 a_xp43 a_xn43 wp_ih_43_7 wn_ih_43_7 xhp7 xhn7 vdd vbsyn gsyn
X_ihx_44_7 a_xp44 a_xn44 wp_ih_44_7 wn_ih_44_7 xhp7 xhn7 vdd vbsyn gsyn
X_ihx_45_7 a_xp45 a_xn45 wp_ih_45_7 wn_ih_45_7 xhp7 xhn7 vdd vbsyn gsyn
X_ihx_46_7 a_xp46 a_xn46 wp_ih_46_7 wn_ih_46_7 xhp7 xhn7 vdd vbsyn gsyn
X_ihx_47_7 a_xp47 a_xn47 wp_ih_47_7 wn_ih_47_7 xhp7 xhn7 vdd vbsyn gsyn
X_ihx_48_7 a_xp48 a_xn48 wp_ih_48_7 wn_ih_48_7 xhp7 xhn7 vdd vbsyn gsyn
X_ihx_49_7 a_xp49 a_xn49 wp_ih_49_7 wn_ih_49_7 xhp7 xhn7 vdd vbsyn gsyn
X_ihx_50_7 a_xp50 a_xn50 wp_ih_50_7 wn_ih_50_7 xhp7 xhn7 vdd vbsyn gsyn
X_ihx_51_7 a_xp51 a_xn51 wp_ih_51_7 wn_ih_51_7 xhp7 xhn7 vdd vbsyn gsyn
X_ihx_52_7 a_xp52 a_xn52 wp_ih_52_7 wn_ih_52_7 xhp7 xhn7 vdd vbsyn gsyn
X_ihx_53_7 a_xp53 a_xn53 wp_ih_53_7 wn_ih_53_7 xhp7 xhn7 vdd vbsyn gsyn
X_ihx_54_7 a_xp54 a_xn54 wp_ih_54_7 wn_ih_54_7 xhp7 xhn7 vdd vbsyn gsyn
X_ihx_55_7 a_xp55 a_xn55 wp_ih_55_7 wn_ih_55_7 xhp7 xhn7 vdd vbsyn gsyn
X_ihx_56_7 a_xp56 a_xn56 wp_ih_56_7 wn_ih_56_7 xhp7 xhn7 vdd vbsyn gsyn
X_ihx_57_7 a_xp57 a_xn57 wp_ih_57_7 wn_ih_57_7 xhp7 xhn7 vdd vbsyn gsyn
X_ihx_58_7 a_xp58 a_xn58 wp_ih_58_7 wn_ih_58_7 xhp7 xhn7 vdd vbsyn gsyn
X_ihx_59_7 a_xp59 a_xn59 wp_ih_59_7 wn_ih_59_7 xhp7 xhn7 vdd vbsyn gsyn
X_ihx_60_7 a_xp60 a_xn60 wp_ih_60_7 wn_ih_60_7 xhp7 xhn7 vdd vbsyn gsyn
X_ihx_61_7 a_xp61 a_xn61 wp_ih_61_7 wn_ih_61_7 xhp7 xhn7 vdd vbsyn gsyn
X_ihx_62_7 a_xp62 a_xn62 wp_ih_62_7 wn_ih_62_7 xhp7 xhn7 vdd vbsyn gsyn
X_ihx_63_7 a_xp63 a_xn63 wp_ih_63_7 wn_ih_63_7 xhp7 xhn7 vdd vbsyn gsyn
Xn7 xhp7 xhn7 ahp7 ahn7 vdd vbneu dneuron
Xcm_xh8 xhp8 xhn8 vdd cmld
Rnd_xh8 xhp8 xhn8 20k
X_ihx_0_8 a_xp0 a_xn0 wp_ih_0_8 wn_ih_0_8 xhp8 xhn8 vdd vbsyn gsyn
X_ihx_1_8 a_xp1 a_xn1 wp_ih_1_8 wn_ih_1_8 xhp8 xhn8 vdd vbsyn gsyn
X_ihx_2_8 a_xp2 a_xn2 wp_ih_2_8 wn_ih_2_8 xhp8 xhn8 vdd vbsyn gsyn
X_ihx_3_8 a_xp3 a_xn3 wp_ih_3_8 wn_ih_3_8 xhp8 xhn8 vdd vbsyn gsyn
X_ihx_4_8 a_xp4 a_xn4 wp_ih_4_8 wn_ih_4_8 xhp8 xhn8 vdd vbsyn gsyn
X_ihx_5_8 a_xp5 a_xn5 wp_ih_5_8 wn_ih_5_8 xhp8 xhn8 vdd vbsyn gsyn
X_ihx_6_8 a_xp6 a_xn6 wp_ih_6_8 wn_ih_6_8 xhp8 xhn8 vdd vbsyn gsyn
X_ihx_7_8 a_xp7 a_xn7 wp_ih_7_8 wn_ih_7_8 xhp8 xhn8 vdd vbsyn gsyn
X_ihx_8_8 a_xp8 a_xn8 wp_ih_8_8 wn_ih_8_8 xhp8 xhn8 vdd vbsyn gsyn
X_ihx_9_8 a_xp9 a_xn9 wp_ih_9_8 wn_ih_9_8 xhp8 xhn8 vdd vbsyn gsyn
X_ihx_10_8 a_xp10 a_xn10 wp_ih_10_8 wn_ih_10_8 xhp8 xhn8 vdd vbsyn gsyn
X_ihx_11_8 a_xp11 a_xn11 wp_ih_11_8 wn_ih_11_8 xhp8 xhn8 vdd vbsyn gsyn
X_ihx_12_8 a_xp12 a_xn12 wp_ih_12_8 wn_ih_12_8 xhp8 xhn8 vdd vbsyn gsyn
X_ihx_13_8 a_xp13 a_xn13 wp_ih_13_8 wn_ih_13_8 xhp8 xhn8 vdd vbsyn gsyn
X_ihx_14_8 a_xp14 a_xn14 wp_ih_14_8 wn_ih_14_8 xhp8 xhn8 vdd vbsyn gsyn
X_ihx_15_8 a_xp15 a_xn15 wp_ih_15_8 wn_ih_15_8 xhp8 xhn8 vdd vbsyn gsyn
X_ihx_16_8 a_xp16 a_xn16 wp_ih_16_8 wn_ih_16_8 xhp8 xhn8 vdd vbsyn gsyn
X_ihx_17_8 a_xp17 a_xn17 wp_ih_17_8 wn_ih_17_8 xhp8 xhn8 vdd vbsyn gsyn
X_ihx_18_8 a_xp18 a_xn18 wp_ih_18_8 wn_ih_18_8 xhp8 xhn8 vdd vbsyn gsyn
X_ihx_19_8 a_xp19 a_xn19 wp_ih_19_8 wn_ih_19_8 xhp8 xhn8 vdd vbsyn gsyn
X_ihx_20_8 a_xp20 a_xn20 wp_ih_20_8 wn_ih_20_8 xhp8 xhn8 vdd vbsyn gsyn
X_ihx_21_8 a_xp21 a_xn21 wp_ih_21_8 wn_ih_21_8 xhp8 xhn8 vdd vbsyn gsyn
X_ihx_22_8 a_xp22 a_xn22 wp_ih_22_8 wn_ih_22_8 xhp8 xhn8 vdd vbsyn gsyn
X_ihx_23_8 a_xp23 a_xn23 wp_ih_23_8 wn_ih_23_8 xhp8 xhn8 vdd vbsyn gsyn
X_ihx_24_8 a_xp24 a_xn24 wp_ih_24_8 wn_ih_24_8 xhp8 xhn8 vdd vbsyn gsyn
X_ihx_25_8 a_xp25 a_xn25 wp_ih_25_8 wn_ih_25_8 xhp8 xhn8 vdd vbsyn gsyn
X_ihx_26_8 a_xp26 a_xn26 wp_ih_26_8 wn_ih_26_8 xhp8 xhn8 vdd vbsyn gsyn
X_ihx_27_8 a_xp27 a_xn27 wp_ih_27_8 wn_ih_27_8 xhp8 xhn8 vdd vbsyn gsyn
X_ihx_28_8 a_xp28 a_xn28 wp_ih_28_8 wn_ih_28_8 xhp8 xhn8 vdd vbsyn gsyn
X_ihx_29_8 a_xp29 a_xn29 wp_ih_29_8 wn_ih_29_8 xhp8 xhn8 vdd vbsyn gsyn
X_ihx_30_8 a_xp30 a_xn30 wp_ih_30_8 wn_ih_30_8 xhp8 xhn8 vdd vbsyn gsyn
X_ihx_31_8 a_xp31 a_xn31 wp_ih_31_8 wn_ih_31_8 xhp8 xhn8 vdd vbsyn gsyn
X_ihx_32_8 a_xp32 a_xn32 wp_ih_32_8 wn_ih_32_8 xhp8 xhn8 vdd vbsyn gsyn
X_ihx_33_8 a_xp33 a_xn33 wp_ih_33_8 wn_ih_33_8 xhp8 xhn8 vdd vbsyn gsyn
X_ihx_34_8 a_xp34 a_xn34 wp_ih_34_8 wn_ih_34_8 xhp8 xhn8 vdd vbsyn gsyn
X_ihx_35_8 a_xp35 a_xn35 wp_ih_35_8 wn_ih_35_8 xhp8 xhn8 vdd vbsyn gsyn
X_ihx_36_8 a_xp36 a_xn36 wp_ih_36_8 wn_ih_36_8 xhp8 xhn8 vdd vbsyn gsyn
X_ihx_37_8 a_xp37 a_xn37 wp_ih_37_8 wn_ih_37_8 xhp8 xhn8 vdd vbsyn gsyn
X_ihx_38_8 a_xp38 a_xn38 wp_ih_38_8 wn_ih_38_8 xhp8 xhn8 vdd vbsyn gsyn
X_ihx_39_8 a_xp39 a_xn39 wp_ih_39_8 wn_ih_39_8 xhp8 xhn8 vdd vbsyn gsyn
X_ihx_40_8 a_xp40 a_xn40 wp_ih_40_8 wn_ih_40_8 xhp8 xhn8 vdd vbsyn gsyn
X_ihx_41_8 a_xp41 a_xn41 wp_ih_41_8 wn_ih_41_8 xhp8 xhn8 vdd vbsyn gsyn
X_ihx_42_8 a_xp42 a_xn42 wp_ih_42_8 wn_ih_42_8 xhp8 xhn8 vdd vbsyn gsyn
X_ihx_43_8 a_xp43 a_xn43 wp_ih_43_8 wn_ih_43_8 xhp8 xhn8 vdd vbsyn gsyn
X_ihx_44_8 a_xp44 a_xn44 wp_ih_44_8 wn_ih_44_8 xhp8 xhn8 vdd vbsyn gsyn
X_ihx_45_8 a_xp45 a_xn45 wp_ih_45_8 wn_ih_45_8 xhp8 xhn8 vdd vbsyn gsyn
X_ihx_46_8 a_xp46 a_xn46 wp_ih_46_8 wn_ih_46_8 xhp8 xhn8 vdd vbsyn gsyn
X_ihx_47_8 a_xp47 a_xn47 wp_ih_47_8 wn_ih_47_8 xhp8 xhn8 vdd vbsyn gsyn
X_ihx_48_8 a_xp48 a_xn48 wp_ih_48_8 wn_ih_48_8 xhp8 xhn8 vdd vbsyn gsyn
X_ihx_49_8 a_xp49 a_xn49 wp_ih_49_8 wn_ih_49_8 xhp8 xhn8 vdd vbsyn gsyn
X_ihx_50_8 a_xp50 a_xn50 wp_ih_50_8 wn_ih_50_8 xhp8 xhn8 vdd vbsyn gsyn
X_ihx_51_8 a_xp51 a_xn51 wp_ih_51_8 wn_ih_51_8 xhp8 xhn8 vdd vbsyn gsyn
X_ihx_52_8 a_xp52 a_xn52 wp_ih_52_8 wn_ih_52_8 xhp8 xhn8 vdd vbsyn gsyn
X_ihx_53_8 a_xp53 a_xn53 wp_ih_53_8 wn_ih_53_8 xhp8 xhn8 vdd vbsyn gsyn
X_ihx_54_8 a_xp54 a_xn54 wp_ih_54_8 wn_ih_54_8 xhp8 xhn8 vdd vbsyn gsyn
X_ihx_55_8 a_xp55 a_xn55 wp_ih_55_8 wn_ih_55_8 xhp8 xhn8 vdd vbsyn gsyn
X_ihx_56_8 a_xp56 a_xn56 wp_ih_56_8 wn_ih_56_8 xhp8 xhn8 vdd vbsyn gsyn
X_ihx_57_8 a_xp57 a_xn57 wp_ih_57_8 wn_ih_57_8 xhp8 xhn8 vdd vbsyn gsyn
X_ihx_58_8 a_xp58 a_xn58 wp_ih_58_8 wn_ih_58_8 xhp8 xhn8 vdd vbsyn gsyn
X_ihx_59_8 a_xp59 a_xn59 wp_ih_59_8 wn_ih_59_8 xhp8 xhn8 vdd vbsyn gsyn
X_ihx_60_8 a_xp60 a_xn60 wp_ih_60_8 wn_ih_60_8 xhp8 xhn8 vdd vbsyn gsyn
X_ihx_61_8 a_xp61 a_xn61 wp_ih_61_8 wn_ih_61_8 xhp8 xhn8 vdd vbsyn gsyn
X_ihx_62_8 a_xp62 a_xn62 wp_ih_62_8 wn_ih_62_8 xhp8 xhn8 vdd vbsyn gsyn
X_ihx_63_8 a_xp63 a_xn63 wp_ih_63_8 wn_ih_63_8 xhp8 xhn8 vdd vbsyn gsyn
Xn8 xhp8 xhn8 ahp8 ahn8 vdd vbneu dneuron
Xcm_xh9 xhp9 xhn9 vdd cmld
Rnd_xh9 xhp9 xhn9 20k
X_ihx_0_9 a_xp0 a_xn0 wp_ih_0_9 wn_ih_0_9 xhp9 xhn9 vdd vbsyn gsyn
X_ihx_1_9 a_xp1 a_xn1 wp_ih_1_9 wn_ih_1_9 xhp9 xhn9 vdd vbsyn gsyn
X_ihx_2_9 a_xp2 a_xn2 wp_ih_2_9 wn_ih_2_9 xhp9 xhn9 vdd vbsyn gsyn
X_ihx_3_9 a_xp3 a_xn3 wp_ih_3_9 wn_ih_3_9 xhp9 xhn9 vdd vbsyn gsyn
X_ihx_4_9 a_xp4 a_xn4 wp_ih_4_9 wn_ih_4_9 xhp9 xhn9 vdd vbsyn gsyn
X_ihx_5_9 a_xp5 a_xn5 wp_ih_5_9 wn_ih_5_9 xhp9 xhn9 vdd vbsyn gsyn
X_ihx_6_9 a_xp6 a_xn6 wp_ih_6_9 wn_ih_6_9 xhp9 xhn9 vdd vbsyn gsyn
X_ihx_7_9 a_xp7 a_xn7 wp_ih_7_9 wn_ih_7_9 xhp9 xhn9 vdd vbsyn gsyn
X_ihx_8_9 a_xp8 a_xn8 wp_ih_8_9 wn_ih_8_9 xhp9 xhn9 vdd vbsyn gsyn
X_ihx_9_9 a_xp9 a_xn9 wp_ih_9_9 wn_ih_9_9 xhp9 xhn9 vdd vbsyn gsyn
X_ihx_10_9 a_xp10 a_xn10 wp_ih_10_9 wn_ih_10_9 xhp9 xhn9 vdd vbsyn gsyn
X_ihx_11_9 a_xp11 a_xn11 wp_ih_11_9 wn_ih_11_9 xhp9 xhn9 vdd vbsyn gsyn
X_ihx_12_9 a_xp12 a_xn12 wp_ih_12_9 wn_ih_12_9 xhp9 xhn9 vdd vbsyn gsyn
X_ihx_13_9 a_xp13 a_xn13 wp_ih_13_9 wn_ih_13_9 xhp9 xhn9 vdd vbsyn gsyn
X_ihx_14_9 a_xp14 a_xn14 wp_ih_14_9 wn_ih_14_9 xhp9 xhn9 vdd vbsyn gsyn
X_ihx_15_9 a_xp15 a_xn15 wp_ih_15_9 wn_ih_15_9 xhp9 xhn9 vdd vbsyn gsyn
X_ihx_16_9 a_xp16 a_xn16 wp_ih_16_9 wn_ih_16_9 xhp9 xhn9 vdd vbsyn gsyn
X_ihx_17_9 a_xp17 a_xn17 wp_ih_17_9 wn_ih_17_9 xhp9 xhn9 vdd vbsyn gsyn
X_ihx_18_9 a_xp18 a_xn18 wp_ih_18_9 wn_ih_18_9 xhp9 xhn9 vdd vbsyn gsyn
X_ihx_19_9 a_xp19 a_xn19 wp_ih_19_9 wn_ih_19_9 xhp9 xhn9 vdd vbsyn gsyn
X_ihx_20_9 a_xp20 a_xn20 wp_ih_20_9 wn_ih_20_9 xhp9 xhn9 vdd vbsyn gsyn
X_ihx_21_9 a_xp21 a_xn21 wp_ih_21_9 wn_ih_21_9 xhp9 xhn9 vdd vbsyn gsyn
X_ihx_22_9 a_xp22 a_xn22 wp_ih_22_9 wn_ih_22_9 xhp9 xhn9 vdd vbsyn gsyn
X_ihx_23_9 a_xp23 a_xn23 wp_ih_23_9 wn_ih_23_9 xhp9 xhn9 vdd vbsyn gsyn
X_ihx_24_9 a_xp24 a_xn24 wp_ih_24_9 wn_ih_24_9 xhp9 xhn9 vdd vbsyn gsyn
X_ihx_25_9 a_xp25 a_xn25 wp_ih_25_9 wn_ih_25_9 xhp9 xhn9 vdd vbsyn gsyn
X_ihx_26_9 a_xp26 a_xn26 wp_ih_26_9 wn_ih_26_9 xhp9 xhn9 vdd vbsyn gsyn
X_ihx_27_9 a_xp27 a_xn27 wp_ih_27_9 wn_ih_27_9 xhp9 xhn9 vdd vbsyn gsyn
X_ihx_28_9 a_xp28 a_xn28 wp_ih_28_9 wn_ih_28_9 xhp9 xhn9 vdd vbsyn gsyn
X_ihx_29_9 a_xp29 a_xn29 wp_ih_29_9 wn_ih_29_9 xhp9 xhn9 vdd vbsyn gsyn
X_ihx_30_9 a_xp30 a_xn30 wp_ih_30_9 wn_ih_30_9 xhp9 xhn9 vdd vbsyn gsyn
X_ihx_31_9 a_xp31 a_xn31 wp_ih_31_9 wn_ih_31_9 xhp9 xhn9 vdd vbsyn gsyn
X_ihx_32_9 a_xp32 a_xn32 wp_ih_32_9 wn_ih_32_9 xhp9 xhn9 vdd vbsyn gsyn
X_ihx_33_9 a_xp33 a_xn33 wp_ih_33_9 wn_ih_33_9 xhp9 xhn9 vdd vbsyn gsyn
X_ihx_34_9 a_xp34 a_xn34 wp_ih_34_9 wn_ih_34_9 xhp9 xhn9 vdd vbsyn gsyn
X_ihx_35_9 a_xp35 a_xn35 wp_ih_35_9 wn_ih_35_9 xhp9 xhn9 vdd vbsyn gsyn
X_ihx_36_9 a_xp36 a_xn36 wp_ih_36_9 wn_ih_36_9 xhp9 xhn9 vdd vbsyn gsyn
X_ihx_37_9 a_xp37 a_xn37 wp_ih_37_9 wn_ih_37_9 xhp9 xhn9 vdd vbsyn gsyn
X_ihx_38_9 a_xp38 a_xn38 wp_ih_38_9 wn_ih_38_9 xhp9 xhn9 vdd vbsyn gsyn
X_ihx_39_9 a_xp39 a_xn39 wp_ih_39_9 wn_ih_39_9 xhp9 xhn9 vdd vbsyn gsyn
X_ihx_40_9 a_xp40 a_xn40 wp_ih_40_9 wn_ih_40_9 xhp9 xhn9 vdd vbsyn gsyn
X_ihx_41_9 a_xp41 a_xn41 wp_ih_41_9 wn_ih_41_9 xhp9 xhn9 vdd vbsyn gsyn
X_ihx_42_9 a_xp42 a_xn42 wp_ih_42_9 wn_ih_42_9 xhp9 xhn9 vdd vbsyn gsyn
X_ihx_43_9 a_xp43 a_xn43 wp_ih_43_9 wn_ih_43_9 xhp9 xhn9 vdd vbsyn gsyn
X_ihx_44_9 a_xp44 a_xn44 wp_ih_44_9 wn_ih_44_9 xhp9 xhn9 vdd vbsyn gsyn
X_ihx_45_9 a_xp45 a_xn45 wp_ih_45_9 wn_ih_45_9 xhp9 xhn9 vdd vbsyn gsyn
X_ihx_46_9 a_xp46 a_xn46 wp_ih_46_9 wn_ih_46_9 xhp9 xhn9 vdd vbsyn gsyn
X_ihx_47_9 a_xp47 a_xn47 wp_ih_47_9 wn_ih_47_9 xhp9 xhn9 vdd vbsyn gsyn
X_ihx_48_9 a_xp48 a_xn48 wp_ih_48_9 wn_ih_48_9 xhp9 xhn9 vdd vbsyn gsyn
X_ihx_49_9 a_xp49 a_xn49 wp_ih_49_9 wn_ih_49_9 xhp9 xhn9 vdd vbsyn gsyn
X_ihx_50_9 a_xp50 a_xn50 wp_ih_50_9 wn_ih_50_9 xhp9 xhn9 vdd vbsyn gsyn
X_ihx_51_9 a_xp51 a_xn51 wp_ih_51_9 wn_ih_51_9 xhp9 xhn9 vdd vbsyn gsyn
X_ihx_52_9 a_xp52 a_xn52 wp_ih_52_9 wn_ih_52_9 xhp9 xhn9 vdd vbsyn gsyn
X_ihx_53_9 a_xp53 a_xn53 wp_ih_53_9 wn_ih_53_9 xhp9 xhn9 vdd vbsyn gsyn
X_ihx_54_9 a_xp54 a_xn54 wp_ih_54_9 wn_ih_54_9 xhp9 xhn9 vdd vbsyn gsyn
X_ihx_55_9 a_xp55 a_xn55 wp_ih_55_9 wn_ih_55_9 xhp9 xhn9 vdd vbsyn gsyn
X_ihx_56_9 a_xp56 a_xn56 wp_ih_56_9 wn_ih_56_9 xhp9 xhn9 vdd vbsyn gsyn
X_ihx_57_9 a_xp57 a_xn57 wp_ih_57_9 wn_ih_57_9 xhp9 xhn9 vdd vbsyn gsyn
X_ihx_58_9 a_xp58 a_xn58 wp_ih_58_9 wn_ih_58_9 xhp9 xhn9 vdd vbsyn gsyn
X_ihx_59_9 a_xp59 a_xn59 wp_ih_59_9 wn_ih_59_9 xhp9 xhn9 vdd vbsyn gsyn
X_ihx_60_9 a_xp60 a_xn60 wp_ih_60_9 wn_ih_60_9 xhp9 xhn9 vdd vbsyn gsyn
X_ihx_61_9 a_xp61 a_xn61 wp_ih_61_9 wn_ih_61_9 xhp9 xhn9 vdd vbsyn gsyn
X_ihx_62_9 a_xp62 a_xn62 wp_ih_62_9 wn_ih_62_9 xhp9 xhn9 vdd vbsyn gsyn
X_ihx_63_9 a_xp63 a_xn63 wp_ih_63_9 wn_ih_63_9 xhp9 xhn9 vdd vbsyn gsyn
Xn9 xhp9 xhn9 ahp9 ahn9 vdd vbneu dneuron
Xcm_xh10 xhp10 xhn10 vdd cmld
Rnd_xh10 xhp10 xhn10 20k
X_ihx_0_10 a_xp0 a_xn0 wp_ih_0_10 wn_ih_0_10 xhp10 xhn10 vdd vbsyn gsyn
X_ihx_1_10 a_xp1 a_xn1 wp_ih_1_10 wn_ih_1_10 xhp10 xhn10 vdd vbsyn gsyn
X_ihx_2_10 a_xp2 a_xn2 wp_ih_2_10 wn_ih_2_10 xhp10 xhn10 vdd vbsyn gsyn
X_ihx_3_10 a_xp3 a_xn3 wp_ih_3_10 wn_ih_3_10 xhp10 xhn10 vdd vbsyn gsyn
X_ihx_4_10 a_xp4 a_xn4 wp_ih_4_10 wn_ih_4_10 xhp10 xhn10 vdd vbsyn gsyn
X_ihx_5_10 a_xp5 a_xn5 wp_ih_5_10 wn_ih_5_10 xhp10 xhn10 vdd vbsyn gsyn
X_ihx_6_10 a_xp6 a_xn6 wp_ih_6_10 wn_ih_6_10 xhp10 xhn10 vdd vbsyn gsyn
X_ihx_7_10 a_xp7 a_xn7 wp_ih_7_10 wn_ih_7_10 xhp10 xhn10 vdd vbsyn gsyn
X_ihx_8_10 a_xp8 a_xn8 wp_ih_8_10 wn_ih_8_10 xhp10 xhn10 vdd vbsyn gsyn
X_ihx_9_10 a_xp9 a_xn9 wp_ih_9_10 wn_ih_9_10 xhp10 xhn10 vdd vbsyn gsyn
X_ihx_10_10 a_xp10 a_xn10 wp_ih_10_10 wn_ih_10_10 xhp10 xhn10 vdd vbsyn gsyn
X_ihx_11_10 a_xp11 a_xn11 wp_ih_11_10 wn_ih_11_10 xhp10 xhn10 vdd vbsyn gsyn
X_ihx_12_10 a_xp12 a_xn12 wp_ih_12_10 wn_ih_12_10 xhp10 xhn10 vdd vbsyn gsyn
X_ihx_13_10 a_xp13 a_xn13 wp_ih_13_10 wn_ih_13_10 xhp10 xhn10 vdd vbsyn gsyn
X_ihx_14_10 a_xp14 a_xn14 wp_ih_14_10 wn_ih_14_10 xhp10 xhn10 vdd vbsyn gsyn
X_ihx_15_10 a_xp15 a_xn15 wp_ih_15_10 wn_ih_15_10 xhp10 xhn10 vdd vbsyn gsyn
X_ihx_16_10 a_xp16 a_xn16 wp_ih_16_10 wn_ih_16_10 xhp10 xhn10 vdd vbsyn gsyn
X_ihx_17_10 a_xp17 a_xn17 wp_ih_17_10 wn_ih_17_10 xhp10 xhn10 vdd vbsyn gsyn
X_ihx_18_10 a_xp18 a_xn18 wp_ih_18_10 wn_ih_18_10 xhp10 xhn10 vdd vbsyn gsyn
X_ihx_19_10 a_xp19 a_xn19 wp_ih_19_10 wn_ih_19_10 xhp10 xhn10 vdd vbsyn gsyn
X_ihx_20_10 a_xp20 a_xn20 wp_ih_20_10 wn_ih_20_10 xhp10 xhn10 vdd vbsyn gsyn
X_ihx_21_10 a_xp21 a_xn21 wp_ih_21_10 wn_ih_21_10 xhp10 xhn10 vdd vbsyn gsyn
X_ihx_22_10 a_xp22 a_xn22 wp_ih_22_10 wn_ih_22_10 xhp10 xhn10 vdd vbsyn gsyn
X_ihx_23_10 a_xp23 a_xn23 wp_ih_23_10 wn_ih_23_10 xhp10 xhn10 vdd vbsyn gsyn
X_ihx_24_10 a_xp24 a_xn24 wp_ih_24_10 wn_ih_24_10 xhp10 xhn10 vdd vbsyn gsyn
X_ihx_25_10 a_xp25 a_xn25 wp_ih_25_10 wn_ih_25_10 xhp10 xhn10 vdd vbsyn gsyn
X_ihx_26_10 a_xp26 a_xn26 wp_ih_26_10 wn_ih_26_10 xhp10 xhn10 vdd vbsyn gsyn
X_ihx_27_10 a_xp27 a_xn27 wp_ih_27_10 wn_ih_27_10 xhp10 xhn10 vdd vbsyn gsyn
X_ihx_28_10 a_xp28 a_xn28 wp_ih_28_10 wn_ih_28_10 xhp10 xhn10 vdd vbsyn gsyn
X_ihx_29_10 a_xp29 a_xn29 wp_ih_29_10 wn_ih_29_10 xhp10 xhn10 vdd vbsyn gsyn
X_ihx_30_10 a_xp30 a_xn30 wp_ih_30_10 wn_ih_30_10 xhp10 xhn10 vdd vbsyn gsyn
X_ihx_31_10 a_xp31 a_xn31 wp_ih_31_10 wn_ih_31_10 xhp10 xhn10 vdd vbsyn gsyn
X_ihx_32_10 a_xp32 a_xn32 wp_ih_32_10 wn_ih_32_10 xhp10 xhn10 vdd vbsyn gsyn
X_ihx_33_10 a_xp33 a_xn33 wp_ih_33_10 wn_ih_33_10 xhp10 xhn10 vdd vbsyn gsyn
X_ihx_34_10 a_xp34 a_xn34 wp_ih_34_10 wn_ih_34_10 xhp10 xhn10 vdd vbsyn gsyn
X_ihx_35_10 a_xp35 a_xn35 wp_ih_35_10 wn_ih_35_10 xhp10 xhn10 vdd vbsyn gsyn
X_ihx_36_10 a_xp36 a_xn36 wp_ih_36_10 wn_ih_36_10 xhp10 xhn10 vdd vbsyn gsyn
X_ihx_37_10 a_xp37 a_xn37 wp_ih_37_10 wn_ih_37_10 xhp10 xhn10 vdd vbsyn gsyn
X_ihx_38_10 a_xp38 a_xn38 wp_ih_38_10 wn_ih_38_10 xhp10 xhn10 vdd vbsyn gsyn
X_ihx_39_10 a_xp39 a_xn39 wp_ih_39_10 wn_ih_39_10 xhp10 xhn10 vdd vbsyn gsyn
X_ihx_40_10 a_xp40 a_xn40 wp_ih_40_10 wn_ih_40_10 xhp10 xhn10 vdd vbsyn gsyn
X_ihx_41_10 a_xp41 a_xn41 wp_ih_41_10 wn_ih_41_10 xhp10 xhn10 vdd vbsyn gsyn
X_ihx_42_10 a_xp42 a_xn42 wp_ih_42_10 wn_ih_42_10 xhp10 xhn10 vdd vbsyn gsyn
X_ihx_43_10 a_xp43 a_xn43 wp_ih_43_10 wn_ih_43_10 xhp10 xhn10 vdd vbsyn gsyn
X_ihx_44_10 a_xp44 a_xn44 wp_ih_44_10 wn_ih_44_10 xhp10 xhn10 vdd vbsyn gsyn
X_ihx_45_10 a_xp45 a_xn45 wp_ih_45_10 wn_ih_45_10 xhp10 xhn10 vdd vbsyn gsyn
X_ihx_46_10 a_xp46 a_xn46 wp_ih_46_10 wn_ih_46_10 xhp10 xhn10 vdd vbsyn gsyn
X_ihx_47_10 a_xp47 a_xn47 wp_ih_47_10 wn_ih_47_10 xhp10 xhn10 vdd vbsyn gsyn
X_ihx_48_10 a_xp48 a_xn48 wp_ih_48_10 wn_ih_48_10 xhp10 xhn10 vdd vbsyn gsyn
X_ihx_49_10 a_xp49 a_xn49 wp_ih_49_10 wn_ih_49_10 xhp10 xhn10 vdd vbsyn gsyn
X_ihx_50_10 a_xp50 a_xn50 wp_ih_50_10 wn_ih_50_10 xhp10 xhn10 vdd vbsyn gsyn
X_ihx_51_10 a_xp51 a_xn51 wp_ih_51_10 wn_ih_51_10 xhp10 xhn10 vdd vbsyn gsyn
X_ihx_52_10 a_xp52 a_xn52 wp_ih_52_10 wn_ih_52_10 xhp10 xhn10 vdd vbsyn gsyn
X_ihx_53_10 a_xp53 a_xn53 wp_ih_53_10 wn_ih_53_10 xhp10 xhn10 vdd vbsyn gsyn
X_ihx_54_10 a_xp54 a_xn54 wp_ih_54_10 wn_ih_54_10 xhp10 xhn10 vdd vbsyn gsyn
X_ihx_55_10 a_xp55 a_xn55 wp_ih_55_10 wn_ih_55_10 xhp10 xhn10 vdd vbsyn gsyn
X_ihx_56_10 a_xp56 a_xn56 wp_ih_56_10 wn_ih_56_10 xhp10 xhn10 vdd vbsyn gsyn
X_ihx_57_10 a_xp57 a_xn57 wp_ih_57_10 wn_ih_57_10 xhp10 xhn10 vdd vbsyn gsyn
X_ihx_58_10 a_xp58 a_xn58 wp_ih_58_10 wn_ih_58_10 xhp10 xhn10 vdd vbsyn gsyn
X_ihx_59_10 a_xp59 a_xn59 wp_ih_59_10 wn_ih_59_10 xhp10 xhn10 vdd vbsyn gsyn
X_ihx_60_10 a_xp60 a_xn60 wp_ih_60_10 wn_ih_60_10 xhp10 xhn10 vdd vbsyn gsyn
X_ihx_61_10 a_xp61 a_xn61 wp_ih_61_10 wn_ih_61_10 xhp10 xhn10 vdd vbsyn gsyn
X_ihx_62_10 a_xp62 a_xn62 wp_ih_62_10 wn_ih_62_10 xhp10 xhn10 vdd vbsyn gsyn
X_ihx_63_10 a_xp63 a_xn63 wp_ih_63_10 wn_ih_63_10 xhp10 xhn10 vdd vbsyn gsyn
Xn10 xhp10 xhn10 ahp10 ahn10 vdd vbneu dneuron
Xcm_xh11 xhp11 xhn11 vdd cmld
Rnd_xh11 xhp11 xhn11 20k
X_ihx_0_11 a_xp0 a_xn0 wp_ih_0_11 wn_ih_0_11 xhp11 xhn11 vdd vbsyn gsyn
X_ihx_1_11 a_xp1 a_xn1 wp_ih_1_11 wn_ih_1_11 xhp11 xhn11 vdd vbsyn gsyn
X_ihx_2_11 a_xp2 a_xn2 wp_ih_2_11 wn_ih_2_11 xhp11 xhn11 vdd vbsyn gsyn
X_ihx_3_11 a_xp3 a_xn3 wp_ih_3_11 wn_ih_3_11 xhp11 xhn11 vdd vbsyn gsyn
X_ihx_4_11 a_xp4 a_xn4 wp_ih_4_11 wn_ih_4_11 xhp11 xhn11 vdd vbsyn gsyn
X_ihx_5_11 a_xp5 a_xn5 wp_ih_5_11 wn_ih_5_11 xhp11 xhn11 vdd vbsyn gsyn
X_ihx_6_11 a_xp6 a_xn6 wp_ih_6_11 wn_ih_6_11 xhp11 xhn11 vdd vbsyn gsyn
X_ihx_7_11 a_xp7 a_xn7 wp_ih_7_11 wn_ih_7_11 xhp11 xhn11 vdd vbsyn gsyn
X_ihx_8_11 a_xp8 a_xn8 wp_ih_8_11 wn_ih_8_11 xhp11 xhn11 vdd vbsyn gsyn
X_ihx_9_11 a_xp9 a_xn9 wp_ih_9_11 wn_ih_9_11 xhp11 xhn11 vdd vbsyn gsyn
X_ihx_10_11 a_xp10 a_xn10 wp_ih_10_11 wn_ih_10_11 xhp11 xhn11 vdd vbsyn gsyn
X_ihx_11_11 a_xp11 a_xn11 wp_ih_11_11 wn_ih_11_11 xhp11 xhn11 vdd vbsyn gsyn
X_ihx_12_11 a_xp12 a_xn12 wp_ih_12_11 wn_ih_12_11 xhp11 xhn11 vdd vbsyn gsyn
X_ihx_13_11 a_xp13 a_xn13 wp_ih_13_11 wn_ih_13_11 xhp11 xhn11 vdd vbsyn gsyn
X_ihx_14_11 a_xp14 a_xn14 wp_ih_14_11 wn_ih_14_11 xhp11 xhn11 vdd vbsyn gsyn
X_ihx_15_11 a_xp15 a_xn15 wp_ih_15_11 wn_ih_15_11 xhp11 xhn11 vdd vbsyn gsyn
X_ihx_16_11 a_xp16 a_xn16 wp_ih_16_11 wn_ih_16_11 xhp11 xhn11 vdd vbsyn gsyn
X_ihx_17_11 a_xp17 a_xn17 wp_ih_17_11 wn_ih_17_11 xhp11 xhn11 vdd vbsyn gsyn
X_ihx_18_11 a_xp18 a_xn18 wp_ih_18_11 wn_ih_18_11 xhp11 xhn11 vdd vbsyn gsyn
X_ihx_19_11 a_xp19 a_xn19 wp_ih_19_11 wn_ih_19_11 xhp11 xhn11 vdd vbsyn gsyn
X_ihx_20_11 a_xp20 a_xn20 wp_ih_20_11 wn_ih_20_11 xhp11 xhn11 vdd vbsyn gsyn
X_ihx_21_11 a_xp21 a_xn21 wp_ih_21_11 wn_ih_21_11 xhp11 xhn11 vdd vbsyn gsyn
X_ihx_22_11 a_xp22 a_xn22 wp_ih_22_11 wn_ih_22_11 xhp11 xhn11 vdd vbsyn gsyn
X_ihx_23_11 a_xp23 a_xn23 wp_ih_23_11 wn_ih_23_11 xhp11 xhn11 vdd vbsyn gsyn
X_ihx_24_11 a_xp24 a_xn24 wp_ih_24_11 wn_ih_24_11 xhp11 xhn11 vdd vbsyn gsyn
X_ihx_25_11 a_xp25 a_xn25 wp_ih_25_11 wn_ih_25_11 xhp11 xhn11 vdd vbsyn gsyn
X_ihx_26_11 a_xp26 a_xn26 wp_ih_26_11 wn_ih_26_11 xhp11 xhn11 vdd vbsyn gsyn
X_ihx_27_11 a_xp27 a_xn27 wp_ih_27_11 wn_ih_27_11 xhp11 xhn11 vdd vbsyn gsyn
X_ihx_28_11 a_xp28 a_xn28 wp_ih_28_11 wn_ih_28_11 xhp11 xhn11 vdd vbsyn gsyn
X_ihx_29_11 a_xp29 a_xn29 wp_ih_29_11 wn_ih_29_11 xhp11 xhn11 vdd vbsyn gsyn
X_ihx_30_11 a_xp30 a_xn30 wp_ih_30_11 wn_ih_30_11 xhp11 xhn11 vdd vbsyn gsyn
X_ihx_31_11 a_xp31 a_xn31 wp_ih_31_11 wn_ih_31_11 xhp11 xhn11 vdd vbsyn gsyn
X_ihx_32_11 a_xp32 a_xn32 wp_ih_32_11 wn_ih_32_11 xhp11 xhn11 vdd vbsyn gsyn
X_ihx_33_11 a_xp33 a_xn33 wp_ih_33_11 wn_ih_33_11 xhp11 xhn11 vdd vbsyn gsyn
X_ihx_34_11 a_xp34 a_xn34 wp_ih_34_11 wn_ih_34_11 xhp11 xhn11 vdd vbsyn gsyn
X_ihx_35_11 a_xp35 a_xn35 wp_ih_35_11 wn_ih_35_11 xhp11 xhn11 vdd vbsyn gsyn
X_ihx_36_11 a_xp36 a_xn36 wp_ih_36_11 wn_ih_36_11 xhp11 xhn11 vdd vbsyn gsyn
X_ihx_37_11 a_xp37 a_xn37 wp_ih_37_11 wn_ih_37_11 xhp11 xhn11 vdd vbsyn gsyn
X_ihx_38_11 a_xp38 a_xn38 wp_ih_38_11 wn_ih_38_11 xhp11 xhn11 vdd vbsyn gsyn
X_ihx_39_11 a_xp39 a_xn39 wp_ih_39_11 wn_ih_39_11 xhp11 xhn11 vdd vbsyn gsyn
X_ihx_40_11 a_xp40 a_xn40 wp_ih_40_11 wn_ih_40_11 xhp11 xhn11 vdd vbsyn gsyn
X_ihx_41_11 a_xp41 a_xn41 wp_ih_41_11 wn_ih_41_11 xhp11 xhn11 vdd vbsyn gsyn
X_ihx_42_11 a_xp42 a_xn42 wp_ih_42_11 wn_ih_42_11 xhp11 xhn11 vdd vbsyn gsyn
X_ihx_43_11 a_xp43 a_xn43 wp_ih_43_11 wn_ih_43_11 xhp11 xhn11 vdd vbsyn gsyn
X_ihx_44_11 a_xp44 a_xn44 wp_ih_44_11 wn_ih_44_11 xhp11 xhn11 vdd vbsyn gsyn
X_ihx_45_11 a_xp45 a_xn45 wp_ih_45_11 wn_ih_45_11 xhp11 xhn11 vdd vbsyn gsyn
X_ihx_46_11 a_xp46 a_xn46 wp_ih_46_11 wn_ih_46_11 xhp11 xhn11 vdd vbsyn gsyn
X_ihx_47_11 a_xp47 a_xn47 wp_ih_47_11 wn_ih_47_11 xhp11 xhn11 vdd vbsyn gsyn
X_ihx_48_11 a_xp48 a_xn48 wp_ih_48_11 wn_ih_48_11 xhp11 xhn11 vdd vbsyn gsyn
X_ihx_49_11 a_xp49 a_xn49 wp_ih_49_11 wn_ih_49_11 xhp11 xhn11 vdd vbsyn gsyn
X_ihx_50_11 a_xp50 a_xn50 wp_ih_50_11 wn_ih_50_11 xhp11 xhn11 vdd vbsyn gsyn
X_ihx_51_11 a_xp51 a_xn51 wp_ih_51_11 wn_ih_51_11 xhp11 xhn11 vdd vbsyn gsyn
X_ihx_52_11 a_xp52 a_xn52 wp_ih_52_11 wn_ih_52_11 xhp11 xhn11 vdd vbsyn gsyn
X_ihx_53_11 a_xp53 a_xn53 wp_ih_53_11 wn_ih_53_11 xhp11 xhn11 vdd vbsyn gsyn
X_ihx_54_11 a_xp54 a_xn54 wp_ih_54_11 wn_ih_54_11 xhp11 xhn11 vdd vbsyn gsyn
X_ihx_55_11 a_xp55 a_xn55 wp_ih_55_11 wn_ih_55_11 xhp11 xhn11 vdd vbsyn gsyn
X_ihx_56_11 a_xp56 a_xn56 wp_ih_56_11 wn_ih_56_11 xhp11 xhn11 vdd vbsyn gsyn
X_ihx_57_11 a_xp57 a_xn57 wp_ih_57_11 wn_ih_57_11 xhp11 xhn11 vdd vbsyn gsyn
X_ihx_58_11 a_xp58 a_xn58 wp_ih_58_11 wn_ih_58_11 xhp11 xhn11 vdd vbsyn gsyn
X_ihx_59_11 a_xp59 a_xn59 wp_ih_59_11 wn_ih_59_11 xhp11 xhn11 vdd vbsyn gsyn
X_ihx_60_11 a_xp60 a_xn60 wp_ih_60_11 wn_ih_60_11 xhp11 xhn11 vdd vbsyn gsyn
X_ihx_61_11 a_xp61 a_xn61 wp_ih_61_11 wn_ih_61_11 xhp11 xhn11 vdd vbsyn gsyn
X_ihx_62_11 a_xp62 a_xn62 wp_ih_62_11 wn_ih_62_11 xhp11 xhn11 vdd vbsyn gsyn
X_ihx_63_11 a_xp63 a_xn63 wp_ih_63_11 wn_ih_63_11 xhp11 xhn11 vdd vbsyn gsyn
Xn11 xhp11 xhn11 ahp11 ahn11 vdd vbneu dneuron
Xcm_xh12 xhp12 xhn12 vdd cmld
Rnd_xh12 xhp12 xhn12 20k
X_ihx_0_12 a_xp0 a_xn0 wp_ih_0_12 wn_ih_0_12 xhp12 xhn12 vdd vbsyn gsyn
X_ihx_1_12 a_xp1 a_xn1 wp_ih_1_12 wn_ih_1_12 xhp12 xhn12 vdd vbsyn gsyn
X_ihx_2_12 a_xp2 a_xn2 wp_ih_2_12 wn_ih_2_12 xhp12 xhn12 vdd vbsyn gsyn
X_ihx_3_12 a_xp3 a_xn3 wp_ih_3_12 wn_ih_3_12 xhp12 xhn12 vdd vbsyn gsyn
X_ihx_4_12 a_xp4 a_xn4 wp_ih_4_12 wn_ih_4_12 xhp12 xhn12 vdd vbsyn gsyn
X_ihx_5_12 a_xp5 a_xn5 wp_ih_5_12 wn_ih_5_12 xhp12 xhn12 vdd vbsyn gsyn
X_ihx_6_12 a_xp6 a_xn6 wp_ih_6_12 wn_ih_6_12 xhp12 xhn12 vdd vbsyn gsyn
X_ihx_7_12 a_xp7 a_xn7 wp_ih_7_12 wn_ih_7_12 xhp12 xhn12 vdd vbsyn gsyn
X_ihx_8_12 a_xp8 a_xn8 wp_ih_8_12 wn_ih_8_12 xhp12 xhn12 vdd vbsyn gsyn
X_ihx_9_12 a_xp9 a_xn9 wp_ih_9_12 wn_ih_9_12 xhp12 xhn12 vdd vbsyn gsyn
X_ihx_10_12 a_xp10 a_xn10 wp_ih_10_12 wn_ih_10_12 xhp12 xhn12 vdd vbsyn gsyn
X_ihx_11_12 a_xp11 a_xn11 wp_ih_11_12 wn_ih_11_12 xhp12 xhn12 vdd vbsyn gsyn
X_ihx_12_12 a_xp12 a_xn12 wp_ih_12_12 wn_ih_12_12 xhp12 xhn12 vdd vbsyn gsyn
X_ihx_13_12 a_xp13 a_xn13 wp_ih_13_12 wn_ih_13_12 xhp12 xhn12 vdd vbsyn gsyn
X_ihx_14_12 a_xp14 a_xn14 wp_ih_14_12 wn_ih_14_12 xhp12 xhn12 vdd vbsyn gsyn
X_ihx_15_12 a_xp15 a_xn15 wp_ih_15_12 wn_ih_15_12 xhp12 xhn12 vdd vbsyn gsyn
X_ihx_16_12 a_xp16 a_xn16 wp_ih_16_12 wn_ih_16_12 xhp12 xhn12 vdd vbsyn gsyn
X_ihx_17_12 a_xp17 a_xn17 wp_ih_17_12 wn_ih_17_12 xhp12 xhn12 vdd vbsyn gsyn
X_ihx_18_12 a_xp18 a_xn18 wp_ih_18_12 wn_ih_18_12 xhp12 xhn12 vdd vbsyn gsyn
X_ihx_19_12 a_xp19 a_xn19 wp_ih_19_12 wn_ih_19_12 xhp12 xhn12 vdd vbsyn gsyn
X_ihx_20_12 a_xp20 a_xn20 wp_ih_20_12 wn_ih_20_12 xhp12 xhn12 vdd vbsyn gsyn
X_ihx_21_12 a_xp21 a_xn21 wp_ih_21_12 wn_ih_21_12 xhp12 xhn12 vdd vbsyn gsyn
X_ihx_22_12 a_xp22 a_xn22 wp_ih_22_12 wn_ih_22_12 xhp12 xhn12 vdd vbsyn gsyn
X_ihx_23_12 a_xp23 a_xn23 wp_ih_23_12 wn_ih_23_12 xhp12 xhn12 vdd vbsyn gsyn
X_ihx_24_12 a_xp24 a_xn24 wp_ih_24_12 wn_ih_24_12 xhp12 xhn12 vdd vbsyn gsyn
X_ihx_25_12 a_xp25 a_xn25 wp_ih_25_12 wn_ih_25_12 xhp12 xhn12 vdd vbsyn gsyn
X_ihx_26_12 a_xp26 a_xn26 wp_ih_26_12 wn_ih_26_12 xhp12 xhn12 vdd vbsyn gsyn
X_ihx_27_12 a_xp27 a_xn27 wp_ih_27_12 wn_ih_27_12 xhp12 xhn12 vdd vbsyn gsyn
X_ihx_28_12 a_xp28 a_xn28 wp_ih_28_12 wn_ih_28_12 xhp12 xhn12 vdd vbsyn gsyn
X_ihx_29_12 a_xp29 a_xn29 wp_ih_29_12 wn_ih_29_12 xhp12 xhn12 vdd vbsyn gsyn
X_ihx_30_12 a_xp30 a_xn30 wp_ih_30_12 wn_ih_30_12 xhp12 xhn12 vdd vbsyn gsyn
X_ihx_31_12 a_xp31 a_xn31 wp_ih_31_12 wn_ih_31_12 xhp12 xhn12 vdd vbsyn gsyn
X_ihx_32_12 a_xp32 a_xn32 wp_ih_32_12 wn_ih_32_12 xhp12 xhn12 vdd vbsyn gsyn
X_ihx_33_12 a_xp33 a_xn33 wp_ih_33_12 wn_ih_33_12 xhp12 xhn12 vdd vbsyn gsyn
X_ihx_34_12 a_xp34 a_xn34 wp_ih_34_12 wn_ih_34_12 xhp12 xhn12 vdd vbsyn gsyn
X_ihx_35_12 a_xp35 a_xn35 wp_ih_35_12 wn_ih_35_12 xhp12 xhn12 vdd vbsyn gsyn
X_ihx_36_12 a_xp36 a_xn36 wp_ih_36_12 wn_ih_36_12 xhp12 xhn12 vdd vbsyn gsyn
X_ihx_37_12 a_xp37 a_xn37 wp_ih_37_12 wn_ih_37_12 xhp12 xhn12 vdd vbsyn gsyn
X_ihx_38_12 a_xp38 a_xn38 wp_ih_38_12 wn_ih_38_12 xhp12 xhn12 vdd vbsyn gsyn
X_ihx_39_12 a_xp39 a_xn39 wp_ih_39_12 wn_ih_39_12 xhp12 xhn12 vdd vbsyn gsyn
X_ihx_40_12 a_xp40 a_xn40 wp_ih_40_12 wn_ih_40_12 xhp12 xhn12 vdd vbsyn gsyn
X_ihx_41_12 a_xp41 a_xn41 wp_ih_41_12 wn_ih_41_12 xhp12 xhn12 vdd vbsyn gsyn
X_ihx_42_12 a_xp42 a_xn42 wp_ih_42_12 wn_ih_42_12 xhp12 xhn12 vdd vbsyn gsyn
X_ihx_43_12 a_xp43 a_xn43 wp_ih_43_12 wn_ih_43_12 xhp12 xhn12 vdd vbsyn gsyn
X_ihx_44_12 a_xp44 a_xn44 wp_ih_44_12 wn_ih_44_12 xhp12 xhn12 vdd vbsyn gsyn
X_ihx_45_12 a_xp45 a_xn45 wp_ih_45_12 wn_ih_45_12 xhp12 xhn12 vdd vbsyn gsyn
X_ihx_46_12 a_xp46 a_xn46 wp_ih_46_12 wn_ih_46_12 xhp12 xhn12 vdd vbsyn gsyn
X_ihx_47_12 a_xp47 a_xn47 wp_ih_47_12 wn_ih_47_12 xhp12 xhn12 vdd vbsyn gsyn
X_ihx_48_12 a_xp48 a_xn48 wp_ih_48_12 wn_ih_48_12 xhp12 xhn12 vdd vbsyn gsyn
X_ihx_49_12 a_xp49 a_xn49 wp_ih_49_12 wn_ih_49_12 xhp12 xhn12 vdd vbsyn gsyn
X_ihx_50_12 a_xp50 a_xn50 wp_ih_50_12 wn_ih_50_12 xhp12 xhn12 vdd vbsyn gsyn
X_ihx_51_12 a_xp51 a_xn51 wp_ih_51_12 wn_ih_51_12 xhp12 xhn12 vdd vbsyn gsyn
X_ihx_52_12 a_xp52 a_xn52 wp_ih_52_12 wn_ih_52_12 xhp12 xhn12 vdd vbsyn gsyn
X_ihx_53_12 a_xp53 a_xn53 wp_ih_53_12 wn_ih_53_12 xhp12 xhn12 vdd vbsyn gsyn
X_ihx_54_12 a_xp54 a_xn54 wp_ih_54_12 wn_ih_54_12 xhp12 xhn12 vdd vbsyn gsyn
X_ihx_55_12 a_xp55 a_xn55 wp_ih_55_12 wn_ih_55_12 xhp12 xhn12 vdd vbsyn gsyn
X_ihx_56_12 a_xp56 a_xn56 wp_ih_56_12 wn_ih_56_12 xhp12 xhn12 vdd vbsyn gsyn
X_ihx_57_12 a_xp57 a_xn57 wp_ih_57_12 wn_ih_57_12 xhp12 xhn12 vdd vbsyn gsyn
X_ihx_58_12 a_xp58 a_xn58 wp_ih_58_12 wn_ih_58_12 xhp12 xhn12 vdd vbsyn gsyn
X_ihx_59_12 a_xp59 a_xn59 wp_ih_59_12 wn_ih_59_12 xhp12 xhn12 vdd vbsyn gsyn
X_ihx_60_12 a_xp60 a_xn60 wp_ih_60_12 wn_ih_60_12 xhp12 xhn12 vdd vbsyn gsyn
X_ihx_61_12 a_xp61 a_xn61 wp_ih_61_12 wn_ih_61_12 xhp12 xhn12 vdd vbsyn gsyn
X_ihx_62_12 a_xp62 a_xn62 wp_ih_62_12 wn_ih_62_12 xhp12 xhn12 vdd vbsyn gsyn
X_ihx_63_12 a_xp63 a_xn63 wp_ih_63_12 wn_ih_63_12 xhp12 xhn12 vdd vbsyn gsyn
Xn12 xhp12 xhn12 ahp12 ahn12 vdd vbneu dneuron
Xcm_xh13 xhp13 xhn13 vdd cmld
Rnd_xh13 xhp13 xhn13 20k
X_ihx_0_13 a_xp0 a_xn0 wp_ih_0_13 wn_ih_0_13 xhp13 xhn13 vdd vbsyn gsyn
X_ihx_1_13 a_xp1 a_xn1 wp_ih_1_13 wn_ih_1_13 xhp13 xhn13 vdd vbsyn gsyn
X_ihx_2_13 a_xp2 a_xn2 wp_ih_2_13 wn_ih_2_13 xhp13 xhn13 vdd vbsyn gsyn
X_ihx_3_13 a_xp3 a_xn3 wp_ih_3_13 wn_ih_3_13 xhp13 xhn13 vdd vbsyn gsyn
X_ihx_4_13 a_xp4 a_xn4 wp_ih_4_13 wn_ih_4_13 xhp13 xhn13 vdd vbsyn gsyn
X_ihx_5_13 a_xp5 a_xn5 wp_ih_5_13 wn_ih_5_13 xhp13 xhn13 vdd vbsyn gsyn
X_ihx_6_13 a_xp6 a_xn6 wp_ih_6_13 wn_ih_6_13 xhp13 xhn13 vdd vbsyn gsyn
X_ihx_7_13 a_xp7 a_xn7 wp_ih_7_13 wn_ih_7_13 xhp13 xhn13 vdd vbsyn gsyn
X_ihx_8_13 a_xp8 a_xn8 wp_ih_8_13 wn_ih_8_13 xhp13 xhn13 vdd vbsyn gsyn
X_ihx_9_13 a_xp9 a_xn9 wp_ih_9_13 wn_ih_9_13 xhp13 xhn13 vdd vbsyn gsyn
X_ihx_10_13 a_xp10 a_xn10 wp_ih_10_13 wn_ih_10_13 xhp13 xhn13 vdd vbsyn gsyn
X_ihx_11_13 a_xp11 a_xn11 wp_ih_11_13 wn_ih_11_13 xhp13 xhn13 vdd vbsyn gsyn
X_ihx_12_13 a_xp12 a_xn12 wp_ih_12_13 wn_ih_12_13 xhp13 xhn13 vdd vbsyn gsyn
X_ihx_13_13 a_xp13 a_xn13 wp_ih_13_13 wn_ih_13_13 xhp13 xhn13 vdd vbsyn gsyn
X_ihx_14_13 a_xp14 a_xn14 wp_ih_14_13 wn_ih_14_13 xhp13 xhn13 vdd vbsyn gsyn
X_ihx_15_13 a_xp15 a_xn15 wp_ih_15_13 wn_ih_15_13 xhp13 xhn13 vdd vbsyn gsyn
X_ihx_16_13 a_xp16 a_xn16 wp_ih_16_13 wn_ih_16_13 xhp13 xhn13 vdd vbsyn gsyn
X_ihx_17_13 a_xp17 a_xn17 wp_ih_17_13 wn_ih_17_13 xhp13 xhn13 vdd vbsyn gsyn
X_ihx_18_13 a_xp18 a_xn18 wp_ih_18_13 wn_ih_18_13 xhp13 xhn13 vdd vbsyn gsyn
X_ihx_19_13 a_xp19 a_xn19 wp_ih_19_13 wn_ih_19_13 xhp13 xhn13 vdd vbsyn gsyn
X_ihx_20_13 a_xp20 a_xn20 wp_ih_20_13 wn_ih_20_13 xhp13 xhn13 vdd vbsyn gsyn
X_ihx_21_13 a_xp21 a_xn21 wp_ih_21_13 wn_ih_21_13 xhp13 xhn13 vdd vbsyn gsyn
X_ihx_22_13 a_xp22 a_xn22 wp_ih_22_13 wn_ih_22_13 xhp13 xhn13 vdd vbsyn gsyn
X_ihx_23_13 a_xp23 a_xn23 wp_ih_23_13 wn_ih_23_13 xhp13 xhn13 vdd vbsyn gsyn
X_ihx_24_13 a_xp24 a_xn24 wp_ih_24_13 wn_ih_24_13 xhp13 xhn13 vdd vbsyn gsyn
X_ihx_25_13 a_xp25 a_xn25 wp_ih_25_13 wn_ih_25_13 xhp13 xhn13 vdd vbsyn gsyn
X_ihx_26_13 a_xp26 a_xn26 wp_ih_26_13 wn_ih_26_13 xhp13 xhn13 vdd vbsyn gsyn
X_ihx_27_13 a_xp27 a_xn27 wp_ih_27_13 wn_ih_27_13 xhp13 xhn13 vdd vbsyn gsyn
X_ihx_28_13 a_xp28 a_xn28 wp_ih_28_13 wn_ih_28_13 xhp13 xhn13 vdd vbsyn gsyn
X_ihx_29_13 a_xp29 a_xn29 wp_ih_29_13 wn_ih_29_13 xhp13 xhn13 vdd vbsyn gsyn
X_ihx_30_13 a_xp30 a_xn30 wp_ih_30_13 wn_ih_30_13 xhp13 xhn13 vdd vbsyn gsyn
X_ihx_31_13 a_xp31 a_xn31 wp_ih_31_13 wn_ih_31_13 xhp13 xhn13 vdd vbsyn gsyn
X_ihx_32_13 a_xp32 a_xn32 wp_ih_32_13 wn_ih_32_13 xhp13 xhn13 vdd vbsyn gsyn
X_ihx_33_13 a_xp33 a_xn33 wp_ih_33_13 wn_ih_33_13 xhp13 xhn13 vdd vbsyn gsyn
X_ihx_34_13 a_xp34 a_xn34 wp_ih_34_13 wn_ih_34_13 xhp13 xhn13 vdd vbsyn gsyn
X_ihx_35_13 a_xp35 a_xn35 wp_ih_35_13 wn_ih_35_13 xhp13 xhn13 vdd vbsyn gsyn
X_ihx_36_13 a_xp36 a_xn36 wp_ih_36_13 wn_ih_36_13 xhp13 xhn13 vdd vbsyn gsyn
X_ihx_37_13 a_xp37 a_xn37 wp_ih_37_13 wn_ih_37_13 xhp13 xhn13 vdd vbsyn gsyn
X_ihx_38_13 a_xp38 a_xn38 wp_ih_38_13 wn_ih_38_13 xhp13 xhn13 vdd vbsyn gsyn
X_ihx_39_13 a_xp39 a_xn39 wp_ih_39_13 wn_ih_39_13 xhp13 xhn13 vdd vbsyn gsyn
X_ihx_40_13 a_xp40 a_xn40 wp_ih_40_13 wn_ih_40_13 xhp13 xhn13 vdd vbsyn gsyn
X_ihx_41_13 a_xp41 a_xn41 wp_ih_41_13 wn_ih_41_13 xhp13 xhn13 vdd vbsyn gsyn
X_ihx_42_13 a_xp42 a_xn42 wp_ih_42_13 wn_ih_42_13 xhp13 xhn13 vdd vbsyn gsyn
X_ihx_43_13 a_xp43 a_xn43 wp_ih_43_13 wn_ih_43_13 xhp13 xhn13 vdd vbsyn gsyn
X_ihx_44_13 a_xp44 a_xn44 wp_ih_44_13 wn_ih_44_13 xhp13 xhn13 vdd vbsyn gsyn
X_ihx_45_13 a_xp45 a_xn45 wp_ih_45_13 wn_ih_45_13 xhp13 xhn13 vdd vbsyn gsyn
X_ihx_46_13 a_xp46 a_xn46 wp_ih_46_13 wn_ih_46_13 xhp13 xhn13 vdd vbsyn gsyn
X_ihx_47_13 a_xp47 a_xn47 wp_ih_47_13 wn_ih_47_13 xhp13 xhn13 vdd vbsyn gsyn
X_ihx_48_13 a_xp48 a_xn48 wp_ih_48_13 wn_ih_48_13 xhp13 xhn13 vdd vbsyn gsyn
X_ihx_49_13 a_xp49 a_xn49 wp_ih_49_13 wn_ih_49_13 xhp13 xhn13 vdd vbsyn gsyn
X_ihx_50_13 a_xp50 a_xn50 wp_ih_50_13 wn_ih_50_13 xhp13 xhn13 vdd vbsyn gsyn
X_ihx_51_13 a_xp51 a_xn51 wp_ih_51_13 wn_ih_51_13 xhp13 xhn13 vdd vbsyn gsyn
X_ihx_52_13 a_xp52 a_xn52 wp_ih_52_13 wn_ih_52_13 xhp13 xhn13 vdd vbsyn gsyn
X_ihx_53_13 a_xp53 a_xn53 wp_ih_53_13 wn_ih_53_13 xhp13 xhn13 vdd vbsyn gsyn
X_ihx_54_13 a_xp54 a_xn54 wp_ih_54_13 wn_ih_54_13 xhp13 xhn13 vdd vbsyn gsyn
X_ihx_55_13 a_xp55 a_xn55 wp_ih_55_13 wn_ih_55_13 xhp13 xhn13 vdd vbsyn gsyn
X_ihx_56_13 a_xp56 a_xn56 wp_ih_56_13 wn_ih_56_13 xhp13 xhn13 vdd vbsyn gsyn
X_ihx_57_13 a_xp57 a_xn57 wp_ih_57_13 wn_ih_57_13 xhp13 xhn13 vdd vbsyn gsyn
X_ihx_58_13 a_xp58 a_xn58 wp_ih_58_13 wn_ih_58_13 xhp13 xhn13 vdd vbsyn gsyn
X_ihx_59_13 a_xp59 a_xn59 wp_ih_59_13 wn_ih_59_13 xhp13 xhn13 vdd vbsyn gsyn
X_ihx_60_13 a_xp60 a_xn60 wp_ih_60_13 wn_ih_60_13 xhp13 xhn13 vdd vbsyn gsyn
X_ihx_61_13 a_xp61 a_xn61 wp_ih_61_13 wn_ih_61_13 xhp13 xhn13 vdd vbsyn gsyn
X_ihx_62_13 a_xp62 a_xn62 wp_ih_62_13 wn_ih_62_13 xhp13 xhn13 vdd vbsyn gsyn
X_ihx_63_13 a_xp63 a_xn63 wp_ih_63_13 wn_ih_63_13 xhp13 xhn13 vdd vbsyn gsyn
Xn13 xhp13 xhn13 ahp13 ahn13 vdd vbneu dneuron
Xcm_xh14 xhp14 xhn14 vdd cmld
Rnd_xh14 xhp14 xhn14 20k
X_ihx_0_14 a_xp0 a_xn0 wp_ih_0_14 wn_ih_0_14 xhp14 xhn14 vdd vbsyn gsyn
X_ihx_1_14 a_xp1 a_xn1 wp_ih_1_14 wn_ih_1_14 xhp14 xhn14 vdd vbsyn gsyn
X_ihx_2_14 a_xp2 a_xn2 wp_ih_2_14 wn_ih_2_14 xhp14 xhn14 vdd vbsyn gsyn
X_ihx_3_14 a_xp3 a_xn3 wp_ih_3_14 wn_ih_3_14 xhp14 xhn14 vdd vbsyn gsyn
X_ihx_4_14 a_xp4 a_xn4 wp_ih_4_14 wn_ih_4_14 xhp14 xhn14 vdd vbsyn gsyn
X_ihx_5_14 a_xp5 a_xn5 wp_ih_5_14 wn_ih_5_14 xhp14 xhn14 vdd vbsyn gsyn
X_ihx_6_14 a_xp6 a_xn6 wp_ih_6_14 wn_ih_6_14 xhp14 xhn14 vdd vbsyn gsyn
X_ihx_7_14 a_xp7 a_xn7 wp_ih_7_14 wn_ih_7_14 xhp14 xhn14 vdd vbsyn gsyn
X_ihx_8_14 a_xp8 a_xn8 wp_ih_8_14 wn_ih_8_14 xhp14 xhn14 vdd vbsyn gsyn
X_ihx_9_14 a_xp9 a_xn9 wp_ih_9_14 wn_ih_9_14 xhp14 xhn14 vdd vbsyn gsyn
X_ihx_10_14 a_xp10 a_xn10 wp_ih_10_14 wn_ih_10_14 xhp14 xhn14 vdd vbsyn gsyn
X_ihx_11_14 a_xp11 a_xn11 wp_ih_11_14 wn_ih_11_14 xhp14 xhn14 vdd vbsyn gsyn
X_ihx_12_14 a_xp12 a_xn12 wp_ih_12_14 wn_ih_12_14 xhp14 xhn14 vdd vbsyn gsyn
X_ihx_13_14 a_xp13 a_xn13 wp_ih_13_14 wn_ih_13_14 xhp14 xhn14 vdd vbsyn gsyn
X_ihx_14_14 a_xp14 a_xn14 wp_ih_14_14 wn_ih_14_14 xhp14 xhn14 vdd vbsyn gsyn
X_ihx_15_14 a_xp15 a_xn15 wp_ih_15_14 wn_ih_15_14 xhp14 xhn14 vdd vbsyn gsyn
X_ihx_16_14 a_xp16 a_xn16 wp_ih_16_14 wn_ih_16_14 xhp14 xhn14 vdd vbsyn gsyn
X_ihx_17_14 a_xp17 a_xn17 wp_ih_17_14 wn_ih_17_14 xhp14 xhn14 vdd vbsyn gsyn
X_ihx_18_14 a_xp18 a_xn18 wp_ih_18_14 wn_ih_18_14 xhp14 xhn14 vdd vbsyn gsyn
X_ihx_19_14 a_xp19 a_xn19 wp_ih_19_14 wn_ih_19_14 xhp14 xhn14 vdd vbsyn gsyn
X_ihx_20_14 a_xp20 a_xn20 wp_ih_20_14 wn_ih_20_14 xhp14 xhn14 vdd vbsyn gsyn
X_ihx_21_14 a_xp21 a_xn21 wp_ih_21_14 wn_ih_21_14 xhp14 xhn14 vdd vbsyn gsyn
X_ihx_22_14 a_xp22 a_xn22 wp_ih_22_14 wn_ih_22_14 xhp14 xhn14 vdd vbsyn gsyn
X_ihx_23_14 a_xp23 a_xn23 wp_ih_23_14 wn_ih_23_14 xhp14 xhn14 vdd vbsyn gsyn
X_ihx_24_14 a_xp24 a_xn24 wp_ih_24_14 wn_ih_24_14 xhp14 xhn14 vdd vbsyn gsyn
X_ihx_25_14 a_xp25 a_xn25 wp_ih_25_14 wn_ih_25_14 xhp14 xhn14 vdd vbsyn gsyn
X_ihx_26_14 a_xp26 a_xn26 wp_ih_26_14 wn_ih_26_14 xhp14 xhn14 vdd vbsyn gsyn
X_ihx_27_14 a_xp27 a_xn27 wp_ih_27_14 wn_ih_27_14 xhp14 xhn14 vdd vbsyn gsyn
X_ihx_28_14 a_xp28 a_xn28 wp_ih_28_14 wn_ih_28_14 xhp14 xhn14 vdd vbsyn gsyn
X_ihx_29_14 a_xp29 a_xn29 wp_ih_29_14 wn_ih_29_14 xhp14 xhn14 vdd vbsyn gsyn
X_ihx_30_14 a_xp30 a_xn30 wp_ih_30_14 wn_ih_30_14 xhp14 xhn14 vdd vbsyn gsyn
X_ihx_31_14 a_xp31 a_xn31 wp_ih_31_14 wn_ih_31_14 xhp14 xhn14 vdd vbsyn gsyn
X_ihx_32_14 a_xp32 a_xn32 wp_ih_32_14 wn_ih_32_14 xhp14 xhn14 vdd vbsyn gsyn
X_ihx_33_14 a_xp33 a_xn33 wp_ih_33_14 wn_ih_33_14 xhp14 xhn14 vdd vbsyn gsyn
X_ihx_34_14 a_xp34 a_xn34 wp_ih_34_14 wn_ih_34_14 xhp14 xhn14 vdd vbsyn gsyn
X_ihx_35_14 a_xp35 a_xn35 wp_ih_35_14 wn_ih_35_14 xhp14 xhn14 vdd vbsyn gsyn
X_ihx_36_14 a_xp36 a_xn36 wp_ih_36_14 wn_ih_36_14 xhp14 xhn14 vdd vbsyn gsyn
X_ihx_37_14 a_xp37 a_xn37 wp_ih_37_14 wn_ih_37_14 xhp14 xhn14 vdd vbsyn gsyn
X_ihx_38_14 a_xp38 a_xn38 wp_ih_38_14 wn_ih_38_14 xhp14 xhn14 vdd vbsyn gsyn
X_ihx_39_14 a_xp39 a_xn39 wp_ih_39_14 wn_ih_39_14 xhp14 xhn14 vdd vbsyn gsyn
X_ihx_40_14 a_xp40 a_xn40 wp_ih_40_14 wn_ih_40_14 xhp14 xhn14 vdd vbsyn gsyn
X_ihx_41_14 a_xp41 a_xn41 wp_ih_41_14 wn_ih_41_14 xhp14 xhn14 vdd vbsyn gsyn
X_ihx_42_14 a_xp42 a_xn42 wp_ih_42_14 wn_ih_42_14 xhp14 xhn14 vdd vbsyn gsyn
X_ihx_43_14 a_xp43 a_xn43 wp_ih_43_14 wn_ih_43_14 xhp14 xhn14 vdd vbsyn gsyn
X_ihx_44_14 a_xp44 a_xn44 wp_ih_44_14 wn_ih_44_14 xhp14 xhn14 vdd vbsyn gsyn
X_ihx_45_14 a_xp45 a_xn45 wp_ih_45_14 wn_ih_45_14 xhp14 xhn14 vdd vbsyn gsyn
X_ihx_46_14 a_xp46 a_xn46 wp_ih_46_14 wn_ih_46_14 xhp14 xhn14 vdd vbsyn gsyn
X_ihx_47_14 a_xp47 a_xn47 wp_ih_47_14 wn_ih_47_14 xhp14 xhn14 vdd vbsyn gsyn
X_ihx_48_14 a_xp48 a_xn48 wp_ih_48_14 wn_ih_48_14 xhp14 xhn14 vdd vbsyn gsyn
X_ihx_49_14 a_xp49 a_xn49 wp_ih_49_14 wn_ih_49_14 xhp14 xhn14 vdd vbsyn gsyn
X_ihx_50_14 a_xp50 a_xn50 wp_ih_50_14 wn_ih_50_14 xhp14 xhn14 vdd vbsyn gsyn
X_ihx_51_14 a_xp51 a_xn51 wp_ih_51_14 wn_ih_51_14 xhp14 xhn14 vdd vbsyn gsyn
X_ihx_52_14 a_xp52 a_xn52 wp_ih_52_14 wn_ih_52_14 xhp14 xhn14 vdd vbsyn gsyn
X_ihx_53_14 a_xp53 a_xn53 wp_ih_53_14 wn_ih_53_14 xhp14 xhn14 vdd vbsyn gsyn
X_ihx_54_14 a_xp54 a_xn54 wp_ih_54_14 wn_ih_54_14 xhp14 xhn14 vdd vbsyn gsyn
X_ihx_55_14 a_xp55 a_xn55 wp_ih_55_14 wn_ih_55_14 xhp14 xhn14 vdd vbsyn gsyn
X_ihx_56_14 a_xp56 a_xn56 wp_ih_56_14 wn_ih_56_14 xhp14 xhn14 vdd vbsyn gsyn
X_ihx_57_14 a_xp57 a_xn57 wp_ih_57_14 wn_ih_57_14 xhp14 xhn14 vdd vbsyn gsyn
X_ihx_58_14 a_xp58 a_xn58 wp_ih_58_14 wn_ih_58_14 xhp14 xhn14 vdd vbsyn gsyn
X_ihx_59_14 a_xp59 a_xn59 wp_ih_59_14 wn_ih_59_14 xhp14 xhn14 vdd vbsyn gsyn
X_ihx_60_14 a_xp60 a_xn60 wp_ih_60_14 wn_ih_60_14 xhp14 xhn14 vdd vbsyn gsyn
X_ihx_61_14 a_xp61 a_xn61 wp_ih_61_14 wn_ih_61_14 xhp14 xhn14 vdd vbsyn gsyn
X_ihx_62_14 a_xp62 a_xn62 wp_ih_62_14 wn_ih_62_14 xhp14 xhn14 vdd vbsyn gsyn
X_ihx_63_14 a_xp63 a_xn63 wp_ih_63_14 wn_ih_63_14 xhp14 xhn14 vdd vbsyn gsyn
Xn14 xhp14 xhn14 ahp14 ahn14 vdd vbneu dneuron
Xcm_xh15 xhp15 xhn15 vdd cmld
Rnd_xh15 xhp15 xhn15 20k
X_ihx_0_15 a_xp0 a_xn0 wp_ih_0_15 wn_ih_0_15 xhp15 xhn15 vdd vbsyn gsyn
X_ihx_1_15 a_xp1 a_xn1 wp_ih_1_15 wn_ih_1_15 xhp15 xhn15 vdd vbsyn gsyn
X_ihx_2_15 a_xp2 a_xn2 wp_ih_2_15 wn_ih_2_15 xhp15 xhn15 vdd vbsyn gsyn
X_ihx_3_15 a_xp3 a_xn3 wp_ih_3_15 wn_ih_3_15 xhp15 xhn15 vdd vbsyn gsyn
X_ihx_4_15 a_xp4 a_xn4 wp_ih_4_15 wn_ih_4_15 xhp15 xhn15 vdd vbsyn gsyn
X_ihx_5_15 a_xp5 a_xn5 wp_ih_5_15 wn_ih_5_15 xhp15 xhn15 vdd vbsyn gsyn
X_ihx_6_15 a_xp6 a_xn6 wp_ih_6_15 wn_ih_6_15 xhp15 xhn15 vdd vbsyn gsyn
X_ihx_7_15 a_xp7 a_xn7 wp_ih_7_15 wn_ih_7_15 xhp15 xhn15 vdd vbsyn gsyn
X_ihx_8_15 a_xp8 a_xn8 wp_ih_8_15 wn_ih_8_15 xhp15 xhn15 vdd vbsyn gsyn
X_ihx_9_15 a_xp9 a_xn9 wp_ih_9_15 wn_ih_9_15 xhp15 xhn15 vdd vbsyn gsyn
X_ihx_10_15 a_xp10 a_xn10 wp_ih_10_15 wn_ih_10_15 xhp15 xhn15 vdd vbsyn gsyn
X_ihx_11_15 a_xp11 a_xn11 wp_ih_11_15 wn_ih_11_15 xhp15 xhn15 vdd vbsyn gsyn
X_ihx_12_15 a_xp12 a_xn12 wp_ih_12_15 wn_ih_12_15 xhp15 xhn15 vdd vbsyn gsyn
X_ihx_13_15 a_xp13 a_xn13 wp_ih_13_15 wn_ih_13_15 xhp15 xhn15 vdd vbsyn gsyn
X_ihx_14_15 a_xp14 a_xn14 wp_ih_14_15 wn_ih_14_15 xhp15 xhn15 vdd vbsyn gsyn
X_ihx_15_15 a_xp15 a_xn15 wp_ih_15_15 wn_ih_15_15 xhp15 xhn15 vdd vbsyn gsyn
X_ihx_16_15 a_xp16 a_xn16 wp_ih_16_15 wn_ih_16_15 xhp15 xhn15 vdd vbsyn gsyn
X_ihx_17_15 a_xp17 a_xn17 wp_ih_17_15 wn_ih_17_15 xhp15 xhn15 vdd vbsyn gsyn
X_ihx_18_15 a_xp18 a_xn18 wp_ih_18_15 wn_ih_18_15 xhp15 xhn15 vdd vbsyn gsyn
X_ihx_19_15 a_xp19 a_xn19 wp_ih_19_15 wn_ih_19_15 xhp15 xhn15 vdd vbsyn gsyn
X_ihx_20_15 a_xp20 a_xn20 wp_ih_20_15 wn_ih_20_15 xhp15 xhn15 vdd vbsyn gsyn
X_ihx_21_15 a_xp21 a_xn21 wp_ih_21_15 wn_ih_21_15 xhp15 xhn15 vdd vbsyn gsyn
X_ihx_22_15 a_xp22 a_xn22 wp_ih_22_15 wn_ih_22_15 xhp15 xhn15 vdd vbsyn gsyn
X_ihx_23_15 a_xp23 a_xn23 wp_ih_23_15 wn_ih_23_15 xhp15 xhn15 vdd vbsyn gsyn
X_ihx_24_15 a_xp24 a_xn24 wp_ih_24_15 wn_ih_24_15 xhp15 xhn15 vdd vbsyn gsyn
X_ihx_25_15 a_xp25 a_xn25 wp_ih_25_15 wn_ih_25_15 xhp15 xhn15 vdd vbsyn gsyn
X_ihx_26_15 a_xp26 a_xn26 wp_ih_26_15 wn_ih_26_15 xhp15 xhn15 vdd vbsyn gsyn
X_ihx_27_15 a_xp27 a_xn27 wp_ih_27_15 wn_ih_27_15 xhp15 xhn15 vdd vbsyn gsyn
X_ihx_28_15 a_xp28 a_xn28 wp_ih_28_15 wn_ih_28_15 xhp15 xhn15 vdd vbsyn gsyn
X_ihx_29_15 a_xp29 a_xn29 wp_ih_29_15 wn_ih_29_15 xhp15 xhn15 vdd vbsyn gsyn
X_ihx_30_15 a_xp30 a_xn30 wp_ih_30_15 wn_ih_30_15 xhp15 xhn15 vdd vbsyn gsyn
X_ihx_31_15 a_xp31 a_xn31 wp_ih_31_15 wn_ih_31_15 xhp15 xhn15 vdd vbsyn gsyn
X_ihx_32_15 a_xp32 a_xn32 wp_ih_32_15 wn_ih_32_15 xhp15 xhn15 vdd vbsyn gsyn
X_ihx_33_15 a_xp33 a_xn33 wp_ih_33_15 wn_ih_33_15 xhp15 xhn15 vdd vbsyn gsyn
X_ihx_34_15 a_xp34 a_xn34 wp_ih_34_15 wn_ih_34_15 xhp15 xhn15 vdd vbsyn gsyn
X_ihx_35_15 a_xp35 a_xn35 wp_ih_35_15 wn_ih_35_15 xhp15 xhn15 vdd vbsyn gsyn
X_ihx_36_15 a_xp36 a_xn36 wp_ih_36_15 wn_ih_36_15 xhp15 xhn15 vdd vbsyn gsyn
X_ihx_37_15 a_xp37 a_xn37 wp_ih_37_15 wn_ih_37_15 xhp15 xhn15 vdd vbsyn gsyn
X_ihx_38_15 a_xp38 a_xn38 wp_ih_38_15 wn_ih_38_15 xhp15 xhn15 vdd vbsyn gsyn
X_ihx_39_15 a_xp39 a_xn39 wp_ih_39_15 wn_ih_39_15 xhp15 xhn15 vdd vbsyn gsyn
X_ihx_40_15 a_xp40 a_xn40 wp_ih_40_15 wn_ih_40_15 xhp15 xhn15 vdd vbsyn gsyn
X_ihx_41_15 a_xp41 a_xn41 wp_ih_41_15 wn_ih_41_15 xhp15 xhn15 vdd vbsyn gsyn
X_ihx_42_15 a_xp42 a_xn42 wp_ih_42_15 wn_ih_42_15 xhp15 xhn15 vdd vbsyn gsyn
X_ihx_43_15 a_xp43 a_xn43 wp_ih_43_15 wn_ih_43_15 xhp15 xhn15 vdd vbsyn gsyn
X_ihx_44_15 a_xp44 a_xn44 wp_ih_44_15 wn_ih_44_15 xhp15 xhn15 vdd vbsyn gsyn
X_ihx_45_15 a_xp45 a_xn45 wp_ih_45_15 wn_ih_45_15 xhp15 xhn15 vdd vbsyn gsyn
X_ihx_46_15 a_xp46 a_xn46 wp_ih_46_15 wn_ih_46_15 xhp15 xhn15 vdd vbsyn gsyn
X_ihx_47_15 a_xp47 a_xn47 wp_ih_47_15 wn_ih_47_15 xhp15 xhn15 vdd vbsyn gsyn
X_ihx_48_15 a_xp48 a_xn48 wp_ih_48_15 wn_ih_48_15 xhp15 xhn15 vdd vbsyn gsyn
X_ihx_49_15 a_xp49 a_xn49 wp_ih_49_15 wn_ih_49_15 xhp15 xhn15 vdd vbsyn gsyn
X_ihx_50_15 a_xp50 a_xn50 wp_ih_50_15 wn_ih_50_15 xhp15 xhn15 vdd vbsyn gsyn
X_ihx_51_15 a_xp51 a_xn51 wp_ih_51_15 wn_ih_51_15 xhp15 xhn15 vdd vbsyn gsyn
X_ihx_52_15 a_xp52 a_xn52 wp_ih_52_15 wn_ih_52_15 xhp15 xhn15 vdd vbsyn gsyn
X_ihx_53_15 a_xp53 a_xn53 wp_ih_53_15 wn_ih_53_15 xhp15 xhn15 vdd vbsyn gsyn
X_ihx_54_15 a_xp54 a_xn54 wp_ih_54_15 wn_ih_54_15 xhp15 xhn15 vdd vbsyn gsyn
X_ihx_55_15 a_xp55 a_xn55 wp_ih_55_15 wn_ih_55_15 xhp15 xhn15 vdd vbsyn gsyn
X_ihx_56_15 a_xp56 a_xn56 wp_ih_56_15 wn_ih_56_15 xhp15 xhn15 vdd vbsyn gsyn
X_ihx_57_15 a_xp57 a_xn57 wp_ih_57_15 wn_ih_57_15 xhp15 xhn15 vdd vbsyn gsyn
X_ihx_58_15 a_xp58 a_xn58 wp_ih_58_15 wn_ih_58_15 xhp15 xhn15 vdd vbsyn gsyn
X_ihx_59_15 a_xp59 a_xn59 wp_ih_59_15 wn_ih_59_15 xhp15 xhn15 vdd vbsyn gsyn
X_ihx_60_15 a_xp60 a_xn60 wp_ih_60_15 wn_ih_60_15 xhp15 xhn15 vdd vbsyn gsyn
X_ihx_61_15 a_xp61 a_xn61 wp_ih_61_15 wn_ih_61_15 xhp15 xhn15 vdd vbsyn gsyn
X_ihx_62_15 a_xp62 a_xn62 wp_ih_62_15 wn_ih_62_15 xhp15 xhn15 vdd vbsyn gsyn
X_ihx_63_15 a_xp63 a_xn63 wp_ih_63_15 wn_ih_63_15 xhp15 xhn15 vdd vbsyn gsyn
Xn15 xhp15 xhn15 ahp15 ahn15 vdd vbneu dneuron
Xcm_xh16 xhp16 xhn16 vdd cmld
Rnd_xh16 xhp16 xhn16 20k
X_ihx_0_16 a_xp0 a_xn0 wp_ih_0_16 wn_ih_0_16 xhp16 xhn16 vdd vbsyn gsyn
X_ihx_1_16 a_xp1 a_xn1 wp_ih_1_16 wn_ih_1_16 xhp16 xhn16 vdd vbsyn gsyn
X_ihx_2_16 a_xp2 a_xn2 wp_ih_2_16 wn_ih_2_16 xhp16 xhn16 vdd vbsyn gsyn
X_ihx_3_16 a_xp3 a_xn3 wp_ih_3_16 wn_ih_3_16 xhp16 xhn16 vdd vbsyn gsyn
X_ihx_4_16 a_xp4 a_xn4 wp_ih_4_16 wn_ih_4_16 xhp16 xhn16 vdd vbsyn gsyn
X_ihx_5_16 a_xp5 a_xn5 wp_ih_5_16 wn_ih_5_16 xhp16 xhn16 vdd vbsyn gsyn
X_ihx_6_16 a_xp6 a_xn6 wp_ih_6_16 wn_ih_6_16 xhp16 xhn16 vdd vbsyn gsyn
X_ihx_7_16 a_xp7 a_xn7 wp_ih_7_16 wn_ih_7_16 xhp16 xhn16 vdd vbsyn gsyn
X_ihx_8_16 a_xp8 a_xn8 wp_ih_8_16 wn_ih_8_16 xhp16 xhn16 vdd vbsyn gsyn
X_ihx_9_16 a_xp9 a_xn9 wp_ih_9_16 wn_ih_9_16 xhp16 xhn16 vdd vbsyn gsyn
X_ihx_10_16 a_xp10 a_xn10 wp_ih_10_16 wn_ih_10_16 xhp16 xhn16 vdd vbsyn gsyn
X_ihx_11_16 a_xp11 a_xn11 wp_ih_11_16 wn_ih_11_16 xhp16 xhn16 vdd vbsyn gsyn
X_ihx_12_16 a_xp12 a_xn12 wp_ih_12_16 wn_ih_12_16 xhp16 xhn16 vdd vbsyn gsyn
X_ihx_13_16 a_xp13 a_xn13 wp_ih_13_16 wn_ih_13_16 xhp16 xhn16 vdd vbsyn gsyn
X_ihx_14_16 a_xp14 a_xn14 wp_ih_14_16 wn_ih_14_16 xhp16 xhn16 vdd vbsyn gsyn
X_ihx_15_16 a_xp15 a_xn15 wp_ih_15_16 wn_ih_15_16 xhp16 xhn16 vdd vbsyn gsyn
X_ihx_16_16 a_xp16 a_xn16 wp_ih_16_16 wn_ih_16_16 xhp16 xhn16 vdd vbsyn gsyn
X_ihx_17_16 a_xp17 a_xn17 wp_ih_17_16 wn_ih_17_16 xhp16 xhn16 vdd vbsyn gsyn
X_ihx_18_16 a_xp18 a_xn18 wp_ih_18_16 wn_ih_18_16 xhp16 xhn16 vdd vbsyn gsyn
X_ihx_19_16 a_xp19 a_xn19 wp_ih_19_16 wn_ih_19_16 xhp16 xhn16 vdd vbsyn gsyn
X_ihx_20_16 a_xp20 a_xn20 wp_ih_20_16 wn_ih_20_16 xhp16 xhn16 vdd vbsyn gsyn
X_ihx_21_16 a_xp21 a_xn21 wp_ih_21_16 wn_ih_21_16 xhp16 xhn16 vdd vbsyn gsyn
X_ihx_22_16 a_xp22 a_xn22 wp_ih_22_16 wn_ih_22_16 xhp16 xhn16 vdd vbsyn gsyn
X_ihx_23_16 a_xp23 a_xn23 wp_ih_23_16 wn_ih_23_16 xhp16 xhn16 vdd vbsyn gsyn
X_ihx_24_16 a_xp24 a_xn24 wp_ih_24_16 wn_ih_24_16 xhp16 xhn16 vdd vbsyn gsyn
X_ihx_25_16 a_xp25 a_xn25 wp_ih_25_16 wn_ih_25_16 xhp16 xhn16 vdd vbsyn gsyn
X_ihx_26_16 a_xp26 a_xn26 wp_ih_26_16 wn_ih_26_16 xhp16 xhn16 vdd vbsyn gsyn
X_ihx_27_16 a_xp27 a_xn27 wp_ih_27_16 wn_ih_27_16 xhp16 xhn16 vdd vbsyn gsyn
X_ihx_28_16 a_xp28 a_xn28 wp_ih_28_16 wn_ih_28_16 xhp16 xhn16 vdd vbsyn gsyn
X_ihx_29_16 a_xp29 a_xn29 wp_ih_29_16 wn_ih_29_16 xhp16 xhn16 vdd vbsyn gsyn
X_ihx_30_16 a_xp30 a_xn30 wp_ih_30_16 wn_ih_30_16 xhp16 xhn16 vdd vbsyn gsyn
X_ihx_31_16 a_xp31 a_xn31 wp_ih_31_16 wn_ih_31_16 xhp16 xhn16 vdd vbsyn gsyn
X_ihx_32_16 a_xp32 a_xn32 wp_ih_32_16 wn_ih_32_16 xhp16 xhn16 vdd vbsyn gsyn
X_ihx_33_16 a_xp33 a_xn33 wp_ih_33_16 wn_ih_33_16 xhp16 xhn16 vdd vbsyn gsyn
X_ihx_34_16 a_xp34 a_xn34 wp_ih_34_16 wn_ih_34_16 xhp16 xhn16 vdd vbsyn gsyn
X_ihx_35_16 a_xp35 a_xn35 wp_ih_35_16 wn_ih_35_16 xhp16 xhn16 vdd vbsyn gsyn
X_ihx_36_16 a_xp36 a_xn36 wp_ih_36_16 wn_ih_36_16 xhp16 xhn16 vdd vbsyn gsyn
X_ihx_37_16 a_xp37 a_xn37 wp_ih_37_16 wn_ih_37_16 xhp16 xhn16 vdd vbsyn gsyn
X_ihx_38_16 a_xp38 a_xn38 wp_ih_38_16 wn_ih_38_16 xhp16 xhn16 vdd vbsyn gsyn
X_ihx_39_16 a_xp39 a_xn39 wp_ih_39_16 wn_ih_39_16 xhp16 xhn16 vdd vbsyn gsyn
X_ihx_40_16 a_xp40 a_xn40 wp_ih_40_16 wn_ih_40_16 xhp16 xhn16 vdd vbsyn gsyn
X_ihx_41_16 a_xp41 a_xn41 wp_ih_41_16 wn_ih_41_16 xhp16 xhn16 vdd vbsyn gsyn
X_ihx_42_16 a_xp42 a_xn42 wp_ih_42_16 wn_ih_42_16 xhp16 xhn16 vdd vbsyn gsyn
X_ihx_43_16 a_xp43 a_xn43 wp_ih_43_16 wn_ih_43_16 xhp16 xhn16 vdd vbsyn gsyn
X_ihx_44_16 a_xp44 a_xn44 wp_ih_44_16 wn_ih_44_16 xhp16 xhn16 vdd vbsyn gsyn
X_ihx_45_16 a_xp45 a_xn45 wp_ih_45_16 wn_ih_45_16 xhp16 xhn16 vdd vbsyn gsyn
X_ihx_46_16 a_xp46 a_xn46 wp_ih_46_16 wn_ih_46_16 xhp16 xhn16 vdd vbsyn gsyn
X_ihx_47_16 a_xp47 a_xn47 wp_ih_47_16 wn_ih_47_16 xhp16 xhn16 vdd vbsyn gsyn
X_ihx_48_16 a_xp48 a_xn48 wp_ih_48_16 wn_ih_48_16 xhp16 xhn16 vdd vbsyn gsyn
X_ihx_49_16 a_xp49 a_xn49 wp_ih_49_16 wn_ih_49_16 xhp16 xhn16 vdd vbsyn gsyn
X_ihx_50_16 a_xp50 a_xn50 wp_ih_50_16 wn_ih_50_16 xhp16 xhn16 vdd vbsyn gsyn
X_ihx_51_16 a_xp51 a_xn51 wp_ih_51_16 wn_ih_51_16 xhp16 xhn16 vdd vbsyn gsyn
X_ihx_52_16 a_xp52 a_xn52 wp_ih_52_16 wn_ih_52_16 xhp16 xhn16 vdd vbsyn gsyn
X_ihx_53_16 a_xp53 a_xn53 wp_ih_53_16 wn_ih_53_16 xhp16 xhn16 vdd vbsyn gsyn
X_ihx_54_16 a_xp54 a_xn54 wp_ih_54_16 wn_ih_54_16 xhp16 xhn16 vdd vbsyn gsyn
X_ihx_55_16 a_xp55 a_xn55 wp_ih_55_16 wn_ih_55_16 xhp16 xhn16 vdd vbsyn gsyn
X_ihx_56_16 a_xp56 a_xn56 wp_ih_56_16 wn_ih_56_16 xhp16 xhn16 vdd vbsyn gsyn
X_ihx_57_16 a_xp57 a_xn57 wp_ih_57_16 wn_ih_57_16 xhp16 xhn16 vdd vbsyn gsyn
X_ihx_58_16 a_xp58 a_xn58 wp_ih_58_16 wn_ih_58_16 xhp16 xhn16 vdd vbsyn gsyn
X_ihx_59_16 a_xp59 a_xn59 wp_ih_59_16 wn_ih_59_16 xhp16 xhn16 vdd vbsyn gsyn
X_ihx_60_16 a_xp60 a_xn60 wp_ih_60_16 wn_ih_60_16 xhp16 xhn16 vdd vbsyn gsyn
X_ihx_61_16 a_xp61 a_xn61 wp_ih_61_16 wn_ih_61_16 xhp16 xhn16 vdd vbsyn gsyn
X_ihx_62_16 a_xp62 a_xn62 wp_ih_62_16 wn_ih_62_16 xhp16 xhn16 vdd vbsyn gsyn
X_ihx_63_16 a_xp63 a_xn63 wp_ih_63_16 wn_ih_63_16 xhp16 xhn16 vdd vbsyn gsyn
Xn16 xhp16 xhn16 ahp16 ahn16 vdd vbneu dneuron
Xcm_xh17 xhp17 xhn17 vdd cmld
Rnd_xh17 xhp17 xhn17 20k
X_ihx_0_17 a_xp0 a_xn0 wp_ih_0_17 wn_ih_0_17 xhp17 xhn17 vdd vbsyn gsyn
X_ihx_1_17 a_xp1 a_xn1 wp_ih_1_17 wn_ih_1_17 xhp17 xhn17 vdd vbsyn gsyn
X_ihx_2_17 a_xp2 a_xn2 wp_ih_2_17 wn_ih_2_17 xhp17 xhn17 vdd vbsyn gsyn
X_ihx_3_17 a_xp3 a_xn3 wp_ih_3_17 wn_ih_3_17 xhp17 xhn17 vdd vbsyn gsyn
X_ihx_4_17 a_xp4 a_xn4 wp_ih_4_17 wn_ih_4_17 xhp17 xhn17 vdd vbsyn gsyn
X_ihx_5_17 a_xp5 a_xn5 wp_ih_5_17 wn_ih_5_17 xhp17 xhn17 vdd vbsyn gsyn
X_ihx_6_17 a_xp6 a_xn6 wp_ih_6_17 wn_ih_6_17 xhp17 xhn17 vdd vbsyn gsyn
X_ihx_7_17 a_xp7 a_xn7 wp_ih_7_17 wn_ih_7_17 xhp17 xhn17 vdd vbsyn gsyn
X_ihx_8_17 a_xp8 a_xn8 wp_ih_8_17 wn_ih_8_17 xhp17 xhn17 vdd vbsyn gsyn
X_ihx_9_17 a_xp9 a_xn9 wp_ih_9_17 wn_ih_9_17 xhp17 xhn17 vdd vbsyn gsyn
X_ihx_10_17 a_xp10 a_xn10 wp_ih_10_17 wn_ih_10_17 xhp17 xhn17 vdd vbsyn gsyn
X_ihx_11_17 a_xp11 a_xn11 wp_ih_11_17 wn_ih_11_17 xhp17 xhn17 vdd vbsyn gsyn
X_ihx_12_17 a_xp12 a_xn12 wp_ih_12_17 wn_ih_12_17 xhp17 xhn17 vdd vbsyn gsyn
X_ihx_13_17 a_xp13 a_xn13 wp_ih_13_17 wn_ih_13_17 xhp17 xhn17 vdd vbsyn gsyn
X_ihx_14_17 a_xp14 a_xn14 wp_ih_14_17 wn_ih_14_17 xhp17 xhn17 vdd vbsyn gsyn
X_ihx_15_17 a_xp15 a_xn15 wp_ih_15_17 wn_ih_15_17 xhp17 xhn17 vdd vbsyn gsyn
X_ihx_16_17 a_xp16 a_xn16 wp_ih_16_17 wn_ih_16_17 xhp17 xhn17 vdd vbsyn gsyn
X_ihx_17_17 a_xp17 a_xn17 wp_ih_17_17 wn_ih_17_17 xhp17 xhn17 vdd vbsyn gsyn
X_ihx_18_17 a_xp18 a_xn18 wp_ih_18_17 wn_ih_18_17 xhp17 xhn17 vdd vbsyn gsyn
X_ihx_19_17 a_xp19 a_xn19 wp_ih_19_17 wn_ih_19_17 xhp17 xhn17 vdd vbsyn gsyn
X_ihx_20_17 a_xp20 a_xn20 wp_ih_20_17 wn_ih_20_17 xhp17 xhn17 vdd vbsyn gsyn
X_ihx_21_17 a_xp21 a_xn21 wp_ih_21_17 wn_ih_21_17 xhp17 xhn17 vdd vbsyn gsyn
X_ihx_22_17 a_xp22 a_xn22 wp_ih_22_17 wn_ih_22_17 xhp17 xhn17 vdd vbsyn gsyn
X_ihx_23_17 a_xp23 a_xn23 wp_ih_23_17 wn_ih_23_17 xhp17 xhn17 vdd vbsyn gsyn
X_ihx_24_17 a_xp24 a_xn24 wp_ih_24_17 wn_ih_24_17 xhp17 xhn17 vdd vbsyn gsyn
X_ihx_25_17 a_xp25 a_xn25 wp_ih_25_17 wn_ih_25_17 xhp17 xhn17 vdd vbsyn gsyn
X_ihx_26_17 a_xp26 a_xn26 wp_ih_26_17 wn_ih_26_17 xhp17 xhn17 vdd vbsyn gsyn
X_ihx_27_17 a_xp27 a_xn27 wp_ih_27_17 wn_ih_27_17 xhp17 xhn17 vdd vbsyn gsyn
X_ihx_28_17 a_xp28 a_xn28 wp_ih_28_17 wn_ih_28_17 xhp17 xhn17 vdd vbsyn gsyn
X_ihx_29_17 a_xp29 a_xn29 wp_ih_29_17 wn_ih_29_17 xhp17 xhn17 vdd vbsyn gsyn
X_ihx_30_17 a_xp30 a_xn30 wp_ih_30_17 wn_ih_30_17 xhp17 xhn17 vdd vbsyn gsyn
X_ihx_31_17 a_xp31 a_xn31 wp_ih_31_17 wn_ih_31_17 xhp17 xhn17 vdd vbsyn gsyn
X_ihx_32_17 a_xp32 a_xn32 wp_ih_32_17 wn_ih_32_17 xhp17 xhn17 vdd vbsyn gsyn
X_ihx_33_17 a_xp33 a_xn33 wp_ih_33_17 wn_ih_33_17 xhp17 xhn17 vdd vbsyn gsyn
X_ihx_34_17 a_xp34 a_xn34 wp_ih_34_17 wn_ih_34_17 xhp17 xhn17 vdd vbsyn gsyn
X_ihx_35_17 a_xp35 a_xn35 wp_ih_35_17 wn_ih_35_17 xhp17 xhn17 vdd vbsyn gsyn
X_ihx_36_17 a_xp36 a_xn36 wp_ih_36_17 wn_ih_36_17 xhp17 xhn17 vdd vbsyn gsyn
X_ihx_37_17 a_xp37 a_xn37 wp_ih_37_17 wn_ih_37_17 xhp17 xhn17 vdd vbsyn gsyn
X_ihx_38_17 a_xp38 a_xn38 wp_ih_38_17 wn_ih_38_17 xhp17 xhn17 vdd vbsyn gsyn
X_ihx_39_17 a_xp39 a_xn39 wp_ih_39_17 wn_ih_39_17 xhp17 xhn17 vdd vbsyn gsyn
X_ihx_40_17 a_xp40 a_xn40 wp_ih_40_17 wn_ih_40_17 xhp17 xhn17 vdd vbsyn gsyn
X_ihx_41_17 a_xp41 a_xn41 wp_ih_41_17 wn_ih_41_17 xhp17 xhn17 vdd vbsyn gsyn
X_ihx_42_17 a_xp42 a_xn42 wp_ih_42_17 wn_ih_42_17 xhp17 xhn17 vdd vbsyn gsyn
X_ihx_43_17 a_xp43 a_xn43 wp_ih_43_17 wn_ih_43_17 xhp17 xhn17 vdd vbsyn gsyn
X_ihx_44_17 a_xp44 a_xn44 wp_ih_44_17 wn_ih_44_17 xhp17 xhn17 vdd vbsyn gsyn
X_ihx_45_17 a_xp45 a_xn45 wp_ih_45_17 wn_ih_45_17 xhp17 xhn17 vdd vbsyn gsyn
X_ihx_46_17 a_xp46 a_xn46 wp_ih_46_17 wn_ih_46_17 xhp17 xhn17 vdd vbsyn gsyn
X_ihx_47_17 a_xp47 a_xn47 wp_ih_47_17 wn_ih_47_17 xhp17 xhn17 vdd vbsyn gsyn
X_ihx_48_17 a_xp48 a_xn48 wp_ih_48_17 wn_ih_48_17 xhp17 xhn17 vdd vbsyn gsyn
X_ihx_49_17 a_xp49 a_xn49 wp_ih_49_17 wn_ih_49_17 xhp17 xhn17 vdd vbsyn gsyn
X_ihx_50_17 a_xp50 a_xn50 wp_ih_50_17 wn_ih_50_17 xhp17 xhn17 vdd vbsyn gsyn
X_ihx_51_17 a_xp51 a_xn51 wp_ih_51_17 wn_ih_51_17 xhp17 xhn17 vdd vbsyn gsyn
X_ihx_52_17 a_xp52 a_xn52 wp_ih_52_17 wn_ih_52_17 xhp17 xhn17 vdd vbsyn gsyn
X_ihx_53_17 a_xp53 a_xn53 wp_ih_53_17 wn_ih_53_17 xhp17 xhn17 vdd vbsyn gsyn
X_ihx_54_17 a_xp54 a_xn54 wp_ih_54_17 wn_ih_54_17 xhp17 xhn17 vdd vbsyn gsyn
X_ihx_55_17 a_xp55 a_xn55 wp_ih_55_17 wn_ih_55_17 xhp17 xhn17 vdd vbsyn gsyn
X_ihx_56_17 a_xp56 a_xn56 wp_ih_56_17 wn_ih_56_17 xhp17 xhn17 vdd vbsyn gsyn
X_ihx_57_17 a_xp57 a_xn57 wp_ih_57_17 wn_ih_57_17 xhp17 xhn17 vdd vbsyn gsyn
X_ihx_58_17 a_xp58 a_xn58 wp_ih_58_17 wn_ih_58_17 xhp17 xhn17 vdd vbsyn gsyn
X_ihx_59_17 a_xp59 a_xn59 wp_ih_59_17 wn_ih_59_17 xhp17 xhn17 vdd vbsyn gsyn
X_ihx_60_17 a_xp60 a_xn60 wp_ih_60_17 wn_ih_60_17 xhp17 xhn17 vdd vbsyn gsyn
X_ihx_61_17 a_xp61 a_xn61 wp_ih_61_17 wn_ih_61_17 xhp17 xhn17 vdd vbsyn gsyn
X_ihx_62_17 a_xp62 a_xn62 wp_ih_62_17 wn_ih_62_17 xhp17 xhn17 vdd vbsyn gsyn
X_ihx_63_17 a_xp63 a_xn63 wp_ih_63_17 wn_ih_63_17 xhp17 xhn17 vdd vbsyn gsyn
Xn17 xhp17 xhn17 ahp17 ahn17 vdd vbneu dneuron
Xcm_xh18 xhp18 xhn18 vdd cmld
Rnd_xh18 xhp18 xhn18 20k
X_ihx_0_18 a_xp0 a_xn0 wp_ih_0_18 wn_ih_0_18 xhp18 xhn18 vdd vbsyn gsyn
X_ihx_1_18 a_xp1 a_xn1 wp_ih_1_18 wn_ih_1_18 xhp18 xhn18 vdd vbsyn gsyn
X_ihx_2_18 a_xp2 a_xn2 wp_ih_2_18 wn_ih_2_18 xhp18 xhn18 vdd vbsyn gsyn
X_ihx_3_18 a_xp3 a_xn3 wp_ih_3_18 wn_ih_3_18 xhp18 xhn18 vdd vbsyn gsyn
X_ihx_4_18 a_xp4 a_xn4 wp_ih_4_18 wn_ih_4_18 xhp18 xhn18 vdd vbsyn gsyn
X_ihx_5_18 a_xp5 a_xn5 wp_ih_5_18 wn_ih_5_18 xhp18 xhn18 vdd vbsyn gsyn
X_ihx_6_18 a_xp6 a_xn6 wp_ih_6_18 wn_ih_6_18 xhp18 xhn18 vdd vbsyn gsyn
X_ihx_7_18 a_xp7 a_xn7 wp_ih_7_18 wn_ih_7_18 xhp18 xhn18 vdd vbsyn gsyn
X_ihx_8_18 a_xp8 a_xn8 wp_ih_8_18 wn_ih_8_18 xhp18 xhn18 vdd vbsyn gsyn
X_ihx_9_18 a_xp9 a_xn9 wp_ih_9_18 wn_ih_9_18 xhp18 xhn18 vdd vbsyn gsyn
X_ihx_10_18 a_xp10 a_xn10 wp_ih_10_18 wn_ih_10_18 xhp18 xhn18 vdd vbsyn gsyn
X_ihx_11_18 a_xp11 a_xn11 wp_ih_11_18 wn_ih_11_18 xhp18 xhn18 vdd vbsyn gsyn
X_ihx_12_18 a_xp12 a_xn12 wp_ih_12_18 wn_ih_12_18 xhp18 xhn18 vdd vbsyn gsyn
X_ihx_13_18 a_xp13 a_xn13 wp_ih_13_18 wn_ih_13_18 xhp18 xhn18 vdd vbsyn gsyn
X_ihx_14_18 a_xp14 a_xn14 wp_ih_14_18 wn_ih_14_18 xhp18 xhn18 vdd vbsyn gsyn
X_ihx_15_18 a_xp15 a_xn15 wp_ih_15_18 wn_ih_15_18 xhp18 xhn18 vdd vbsyn gsyn
X_ihx_16_18 a_xp16 a_xn16 wp_ih_16_18 wn_ih_16_18 xhp18 xhn18 vdd vbsyn gsyn
X_ihx_17_18 a_xp17 a_xn17 wp_ih_17_18 wn_ih_17_18 xhp18 xhn18 vdd vbsyn gsyn
X_ihx_18_18 a_xp18 a_xn18 wp_ih_18_18 wn_ih_18_18 xhp18 xhn18 vdd vbsyn gsyn
X_ihx_19_18 a_xp19 a_xn19 wp_ih_19_18 wn_ih_19_18 xhp18 xhn18 vdd vbsyn gsyn
X_ihx_20_18 a_xp20 a_xn20 wp_ih_20_18 wn_ih_20_18 xhp18 xhn18 vdd vbsyn gsyn
X_ihx_21_18 a_xp21 a_xn21 wp_ih_21_18 wn_ih_21_18 xhp18 xhn18 vdd vbsyn gsyn
X_ihx_22_18 a_xp22 a_xn22 wp_ih_22_18 wn_ih_22_18 xhp18 xhn18 vdd vbsyn gsyn
X_ihx_23_18 a_xp23 a_xn23 wp_ih_23_18 wn_ih_23_18 xhp18 xhn18 vdd vbsyn gsyn
X_ihx_24_18 a_xp24 a_xn24 wp_ih_24_18 wn_ih_24_18 xhp18 xhn18 vdd vbsyn gsyn
X_ihx_25_18 a_xp25 a_xn25 wp_ih_25_18 wn_ih_25_18 xhp18 xhn18 vdd vbsyn gsyn
X_ihx_26_18 a_xp26 a_xn26 wp_ih_26_18 wn_ih_26_18 xhp18 xhn18 vdd vbsyn gsyn
X_ihx_27_18 a_xp27 a_xn27 wp_ih_27_18 wn_ih_27_18 xhp18 xhn18 vdd vbsyn gsyn
X_ihx_28_18 a_xp28 a_xn28 wp_ih_28_18 wn_ih_28_18 xhp18 xhn18 vdd vbsyn gsyn
X_ihx_29_18 a_xp29 a_xn29 wp_ih_29_18 wn_ih_29_18 xhp18 xhn18 vdd vbsyn gsyn
X_ihx_30_18 a_xp30 a_xn30 wp_ih_30_18 wn_ih_30_18 xhp18 xhn18 vdd vbsyn gsyn
X_ihx_31_18 a_xp31 a_xn31 wp_ih_31_18 wn_ih_31_18 xhp18 xhn18 vdd vbsyn gsyn
X_ihx_32_18 a_xp32 a_xn32 wp_ih_32_18 wn_ih_32_18 xhp18 xhn18 vdd vbsyn gsyn
X_ihx_33_18 a_xp33 a_xn33 wp_ih_33_18 wn_ih_33_18 xhp18 xhn18 vdd vbsyn gsyn
X_ihx_34_18 a_xp34 a_xn34 wp_ih_34_18 wn_ih_34_18 xhp18 xhn18 vdd vbsyn gsyn
X_ihx_35_18 a_xp35 a_xn35 wp_ih_35_18 wn_ih_35_18 xhp18 xhn18 vdd vbsyn gsyn
X_ihx_36_18 a_xp36 a_xn36 wp_ih_36_18 wn_ih_36_18 xhp18 xhn18 vdd vbsyn gsyn
X_ihx_37_18 a_xp37 a_xn37 wp_ih_37_18 wn_ih_37_18 xhp18 xhn18 vdd vbsyn gsyn
X_ihx_38_18 a_xp38 a_xn38 wp_ih_38_18 wn_ih_38_18 xhp18 xhn18 vdd vbsyn gsyn
X_ihx_39_18 a_xp39 a_xn39 wp_ih_39_18 wn_ih_39_18 xhp18 xhn18 vdd vbsyn gsyn
X_ihx_40_18 a_xp40 a_xn40 wp_ih_40_18 wn_ih_40_18 xhp18 xhn18 vdd vbsyn gsyn
X_ihx_41_18 a_xp41 a_xn41 wp_ih_41_18 wn_ih_41_18 xhp18 xhn18 vdd vbsyn gsyn
X_ihx_42_18 a_xp42 a_xn42 wp_ih_42_18 wn_ih_42_18 xhp18 xhn18 vdd vbsyn gsyn
X_ihx_43_18 a_xp43 a_xn43 wp_ih_43_18 wn_ih_43_18 xhp18 xhn18 vdd vbsyn gsyn
X_ihx_44_18 a_xp44 a_xn44 wp_ih_44_18 wn_ih_44_18 xhp18 xhn18 vdd vbsyn gsyn
X_ihx_45_18 a_xp45 a_xn45 wp_ih_45_18 wn_ih_45_18 xhp18 xhn18 vdd vbsyn gsyn
X_ihx_46_18 a_xp46 a_xn46 wp_ih_46_18 wn_ih_46_18 xhp18 xhn18 vdd vbsyn gsyn
X_ihx_47_18 a_xp47 a_xn47 wp_ih_47_18 wn_ih_47_18 xhp18 xhn18 vdd vbsyn gsyn
X_ihx_48_18 a_xp48 a_xn48 wp_ih_48_18 wn_ih_48_18 xhp18 xhn18 vdd vbsyn gsyn
X_ihx_49_18 a_xp49 a_xn49 wp_ih_49_18 wn_ih_49_18 xhp18 xhn18 vdd vbsyn gsyn
X_ihx_50_18 a_xp50 a_xn50 wp_ih_50_18 wn_ih_50_18 xhp18 xhn18 vdd vbsyn gsyn
X_ihx_51_18 a_xp51 a_xn51 wp_ih_51_18 wn_ih_51_18 xhp18 xhn18 vdd vbsyn gsyn
X_ihx_52_18 a_xp52 a_xn52 wp_ih_52_18 wn_ih_52_18 xhp18 xhn18 vdd vbsyn gsyn
X_ihx_53_18 a_xp53 a_xn53 wp_ih_53_18 wn_ih_53_18 xhp18 xhn18 vdd vbsyn gsyn
X_ihx_54_18 a_xp54 a_xn54 wp_ih_54_18 wn_ih_54_18 xhp18 xhn18 vdd vbsyn gsyn
X_ihx_55_18 a_xp55 a_xn55 wp_ih_55_18 wn_ih_55_18 xhp18 xhn18 vdd vbsyn gsyn
X_ihx_56_18 a_xp56 a_xn56 wp_ih_56_18 wn_ih_56_18 xhp18 xhn18 vdd vbsyn gsyn
X_ihx_57_18 a_xp57 a_xn57 wp_ih_57_18 wn_ih_57_18 xhp18 xhn18 vdd vbsyn gsyn
X_ihx_58_18 a_xp58 a_xn58 wp_ih_58_18 wn_ih_58_18 xhp18 xhn18 vdd vbsyn gsyn
X_ihx_59_18 a_xp59 a_xn59 wp_ih_59_18 wn_ih_59_18 xhp18 xhn18 vdd vbsyn gsyn
X_ihx_60_18 a_xp60 a_xn60 wp_ih_60_18 wn_ih_60_18 xhp18 xhn18 vdd vbsyn gsyn
X_ihx_61_18 a_xp61 a_xn61 wp_ih_61_18 wn_ih_61_18 xhp18 xhn18 vdd vbsyn gsyn
X_ihx_62_18 a_xp62 a_xn62 wp_ih_62_18 wn_ih_62_18 xhp18 xhn18 vdd vbsyn gsyn
X_ihx_63_18 a_xp63 a_xn63 wp_ih_63_18 wn_ih_63_18 xhp18 xhn18 vdd vbsyn gsyn
Xn18 xhp18 xhn18 ahp18 ahn18 vdd vbneu dneuron
Xcm_xh19 xhp19 xhn19 vdd cmld
Rnd_xh19 xhp19 xhn19 20k
X_ihx_0_19 a_xp0 a_xn0 wp_ih_0_19 wn_ih_0_19 xhp19 xhn19 vdd vbsyn gsyn
X_ihx_1_19 a_xp1 a_xn1 wp_ih_1_19 wn_ih_1_19 xhp19 xhn19 vdd vbsyn gsyn
X_ihx_2_19 a_xp2 a_xn2 wp_ih_2_19 wn_ih_2_19 xhp19 xhn19 vdd vbsyn gsyn
X_ihx_3_19 a_xp3 a_xn3 wp_ih_3_19 wn_ih_3_19 xhp19 xhn19 vdd vbsyn gsyn
X_ihx_4_19 a_xp4 a_xn4 wp_ih_4_19 wn_ih_4_19 xhp19 xhn19 vdd vbsyn gsyn
X_ihx_5_19 a_xp5 a_xn5 wp_ih_5_19 wn_ih_5_19 xhp19 xhn19 vdd vbsyn gsyn
X_ihx_6_19 a_xp6 a_xn6 wp_ih_6_19 wn_ih_6_19 xhp19 xhn19 vdd vbsyn gsyn
X_ihx_7_19 a_xp7 a_xn7 wp_ih_7_19 wn_ih_7_19 xhp19 xhn19 vdd vbsyn gsyn
X_ihx_8_19 a_xp8 a_xn8 wp_ih_8_19 wn_ih_8_19 xhp19 xhn19 vdd vbsyn gsyn
X_ihx_9_19 a_xp9 a_xn9 wp_ih_9_19 wn_ih_9_19 xhp19 xhn19 vdd vbsyn gsyn
X_ihx_10_19 a_xp10 a_xn10 wp_ih_10_19 wn_ih_10_19 xhp19 xhn19 vdd vbsyn gsyn
X_ihx_11_19 a_xp11 a_xn11 wp_ih_11_19 wn_ih_11_19 xhp19 xhn19 vdd vbsyn gsyn
X_ihx_12_19 a_xp12 a_xn12 wp_ih_12_19 wn_ih_12_19 xhp19 xhn19 vdd vbsyn gsyn
X_ihx_13_19 a_xp13 a_xn13 wp_ih_13_19 wn_ih_13_19 xhp19 xhn19 vdd vbsyn gsyn
X_ihx_14_19 a_xp14 a_xn14 wp_ih_14_19 wn_ih_14_19 xhp19 xhn19 vdd vbsyn gsyn
X_ihx_15_19 a_xp15 a_xn15 wp_ih_15_19 wn_ih_15_19 xhp19 xhn19 vdd vbsyn gsyn
X_ihx_16_19 a_xp16 a_xn16 wp_ih_16_19 wn_ih_16_19 xhp19 xhn19 vdd vbsyn gsyn
X_ihx_17_19 a_xp17 a_xn17 wp_ih_17_19 wn_ih_17_19 xhp19 xhn19 vdd vbsyn gsyn
X_ihx_18_19 a_xp18 a_xn18 wp_ih_18_19 wn_ih_18_19 xhp19 xhn19 vdd vbsyn gsyn
X_ihx_19_19 a_xp19 a_xn19 wp_ih_19_19 wn_ih_19_19 xhp19 xhn19 vdd vbsyn gsyn
X_ihx_20_19 a_xp20 a_xn20 wp_ih_20_19 wn_ih_20_19 xhp19 xhn19 vdd vbsyn gsyn
X_ihx_21_19 a_xp21 a_xn21 wp_ih_21_19 wn_ih_21_19 xhp19 xhn19 vdd vbsyn gsyn
X_ihx_22_19 a_xp22 a_xn22 wp_ih_22_19 wn_ih_22_19 xhp19 xhn19 vdd vbsyn gsyn
X_ihx_23_19 a_xp23 a_xn23 wp_ih_23_19 wn_ih_23_19 xhp19 xhn19 vdd vbsyn gsyn
X_ihx_24_19 a_xp24 a_xn24 wp_ih_24_19 wn_ih_24_19 xhp19 xhn19 vdd vbsyn gsyn
X_ihx_25_19 a_xp25 a_xn25 wp_ih_25_19 wn_ih_25_19 xhp19 xhn19 vdd vbsyn gsyn
X_ihx_26_19 a_xp26 a_xn26 wp_ih_26_19 wn_ih_26_19 xhp19 xhn19 vdd vbsyn gsyn
X_ihx_27_19 a_xp27 a_xn27 wp_ih_27_19 wn_ih_27_19 xhp19 xhn19 vdd vbsyn gsyn
X_ihx_28_19 a_xp28 a_xn28 wp_ih_28_19 wn_ih_28_19 xhp19 xhn19 vdd vbsyn gsyn
X_ihx_29_19 a_xp29 a_xn29 wp_ih_29_19 wn_ih_29_19 xhp19 xhn19 vdd vbsyn gsyn
X_ihx_30_19 a_xp30 a_xn30 wp_ih_30_19 wn_ih_30_19 xhp19 xhn19 vdd vbsyn gsyn
X_ihx_31_19 a_xp31 a_xn31 wp_ih_31_19 wn_ih_31_19 xhp19 xhn19 vdd vbsyn gsyn
X_ihx_32_19 a_xp32 a_xn32 wp_ih_32_19 wn_ih_32_19 xhp19 xhn19 vdd vbsyn gsyn
X_ihx_33_19 a_xp33 a_xn33 wp_ih_33_19 wn_ih_33_19 xhp19 xhn19 vdd vbsyn gsyn
X_ihx_34_19 a_xp34 a_xn34 wp_ih_34_19 wn_ih_34_19 xhp19 xhn19 vdd vbsyn gsyn
X_ihx_35_19 a_xp35 a_xn35 wp_ih_35_19 wn_ih_35_19 xhp19 xhn19 vdd vbsyn gsyn
X_ihx_36_19 a_xp36 a_xn36 wp_ih_36_19 wn_ih_36_19 xhp19 xhn19 vdd vbsyn gsyn
X_ihx_37_19 a_xp37 a_xn37 wp_ih_37_19 wn_ih_37_19 xhp19 xhn19 vdd vbsyn gsyn
X_ihx_38_19 a_xp38 a_xn38 wp_ih_38_19 wn_ih_38_19 xhp19 xhn19 vdd vbsyn gsyn
X_ihx_39_19 a_xp39 a_xn39 wp_ih_39_19 wn_ih_39_19 xhp19 xhn19 vdd vbsyn gsyn
X_ihx_40_19 a_xp40 a_xn40 wp_ih_40_19 wn_ih_40_19 xhp19 xhn19 vdd vbsyn gsyn
X_ihx_41_19 a_xp41 a_xn41 wp_ih_41_19 wn_ih_41_19 xhp19 xhn19 vdd vbsyn gsyn
X_ihx_42_19 a_xp42 a_xn42 wp_ih_42_19 wn_ih_42_19 xhp19 xhn19 vdd vbsyn gsyn
X_ihx_43_19 a_xp43 a_xn43 wp_ih_43_19 wn_ih_43_19 xhp19 xhn19 vdd vbsyn gsyn
X_ihx_44_19 a_xp44 a_xn44 wp_ih_44_19 wn_ih_44_19 xhp19 xhn19 vdd vbsyn gsyn
X_ihx_45_19 a_xp45 a_xn45 wp_ih_45_19 wn_ih_45_19 xhp19 xhn19 vdd vbsyn gsyn
X_ihx_46_19 a_xp46 a_xn46 wp_ih_46_19 wn_ih_46_19 xhp19 xhn19 vdd vbsyn gsyn
X_ihx_47_19 a_xp47 a_xn47 wp_ih_47_19 wn_ih_47_19 xhp19 xhn19 vdd vbsyn gsyn
X_ihx_48_19 a_xp48 a_xn48 wp_ih_48_19 wn_ih_48_19 xhp19 xhn19 vdd vbsyn gsyn
X_ihx_49_19 a_xp49 a_xn49 wp_ih_49_19 wn_ih_49_19 xhp19 xhn19 vdd vbsyn gsyn
X_ihx_50_19 a_xp50 a_xn50 wp_ih_50_19 wn_ih_50_19 xhp19 xhn19 vdd vbsyn gsyn
X_ihx_51_19 a_xp51 a_xn51 wp_ih_51_19 wn_ih_51_19 xhp19 xhn19 vdd vbsyn gsyn
X_ihx_52_19 a_xp52 a_xn52 wp_ih_52_19 wn_ih_52_19 xhp19 xhn19 vdd vbsyn gsyn
X_ihx_53_19 a_xp53 a_xn53 wp_ih_53_19 wn_ih_53_19 xhp19 xhn19 vdd vbsyn gsyn
X_ihx_54_19 a_xp54 a_xn54 wp_ih_54_19 wn_ih_54_19 xhp19 xhn19 vdd vbsyn gsyn
X_ihx_55_19 a_xp55 a_xn55 wp_ih_55_19 wn_ih_55_19 xhp19 xhn19 vdd vbsyn gsyn
X_ihx_56_19 a_xp56 a_xn56 wp_ih_56_19 wn_ih_56_19 xhp19 xhn19 vdd vbsyn gsyn
X_ihx_57_19 a_xp57 a_xn57 wp_ih_57_19 wn_ih_57_19 xhp19 xhn19 vdd vbsyn gsyn
X_ihx_58_19 a_xp58 a_xn58 wp_ih_58_19 wn_ih_58_19 xhp19 xhn19 vdd vbsyn gsyn
X_ihx_59_19 a_xp59 a_xn59 wp_ih_59_19 wn_ih_59_19 xhp19 xhn19 vdd vbsyn gsyn
X_ihx_60_19 a_xp60 a_xn60 wp_ih_60_19 wn_ih_60_19 xhp19 xhn19 vdd vbsyn gsyn
X_ihx_61_19 a_xp61 a_xn61 wp_ih_61_19 wn_ih_61_19 xhp19 xhn19 vdd vbsyn gsyn
X_ihx_62_19 a_xp62 a_xn62 wp_ih_62_19 wn_ih_62_19 xhp19 xhn19 vdd vbsyn gsyn
X_ihx_63_19 a_xp63 a_xn63 wp_ih_63_19 wn_ih_63_19 xhp19 xhn19 vdd vbsyn gsyn
Xn19 xhp19 xhn19 ahp19 ahn19 vdd vbneu dneuron
Xcm_xh20 xhp20 xhn20 vdd cmld
Rnd_xh20 xhp20 xhn20 20k
X_ihx_0_20 a_xp0 a_xn0 wp_ih_0_20 wn_ih_0_20 xhp20 xhn20 vdd vbsyn gsyn
X_ihx_1_20 a_xp1 a_xn1 wp_ih_1_20 wn_ih_1_20 xhp20 xhn20 vdd vbsyn gsyn
X_ihx_2_20 a_xp2 a_xn2 wp_ih_2_20 wn_ih_2_20 xhp20 xhn20 vdd vbsyn gsyn
X_ihx_3_20 a_xp3 a_xn3 wp_ih_3_20 wn_ih_3_20 xhp20 xhn20 vdd vbsyn gsyn
X_ihx_4_20 a_xp4 a_xn4 wp_ih_4_20 wn_ih_4_20 xhp20 xhn20 vdd vbsyn gsyn
X_ihx_5_20 a_xp5 a_xn5 wp_ih_5_20 wn_ih_5_20 xhp20 xhn20 vdd vbsyn gsyn
X_ihx_6_20 a_xp6 a_xn6 wp_ih_6_20 wn_ih_6_20 xhp20 xhn20 vdd vbsyn gsyn
X_ihx_7_20 a_xp7 a_xn7 wp_ih_7_20 wn_ih_7_20 xhp20 xhn20 vdd vbsyn gsyn
X_ihx_8_20 a_xp8 a_xn8 wp_ih_8_20 wn_ih_8_20 xhp20 xhn20 vdd vbsyn gsyn
X_ihx_9_20 a_xp9 a_xn9 wp_ih_9_20 wn_ih_9_20 xhp20 xhn20 vdd vbsyn gsyn
X_ihx_10_20 a_xp10 a_xn10 wp_ih_10_20 wn_ih_10_20 xhp20 xhn20 vdd vbsyn gsyn
X_ihx_11_20 a_xp11 a_xn11 wp_ih_11_20 wn_ih_11_20 xhp20 xhn20 vdd vbsyn gsyn
X_ihx_12_20 a_xp12 a_xn12 wp_ih_12_20 wn_ih_12_20 xhp20 xhn20 vdd vbsyn gsyn
X_ihx_13_20 a_xp13 a_xn13 wp_ih_13_20 wn_ih_13_20 xhp20 xhn20 vdd vbsyn gsyn
X_ihx_14_20 a_xp14 a_xn14 wp_ih_14_20 wn_ih_14_20 xhp20 xhn20 vdd vbsyn gsyn
X_ihx_15_20 a_xp15 a_xn15 wp_ih_15_20 wn_ih_15_20 xhp20 xhn20 vdd vbsyn gsyn
X_ihx_16_20 a_xp16 a_xn16 wp_ih_16_20 wn_ih_16_20 xhp20 xhn20 vdd vbsyn gsyn
X_ihx_17_20 a_xp17 a_xn17 wp_ih_17_20 wn_ih_17_20 xhp20 xhn20 vdd vbsyn gsyn
X_ihx_18_20 a_xp18 a_xn18 wp_ih_18_20 wn_ih_18_20 xhp20 xhn20 vdd vbsyn gsyn
X_ihx_19_20 a_xp19 a_xn19 wp_ih_19_20 wn_ih_19_20 xhp20 xhn20 vdd vbsyn gsyn
X_ihx_20_20 a_xp20 a_xn20 wp_ih_20_20 wn_ih_20_20 xhp20 xhn20 vdd vbsyn gsyn
X_ihx_21_20 a_xp21 a_xn21 wp_ih_21_20 wn_ih_21_20 xhp20 xhn20 vdd vbsyn gsyn
X_ihx_22_20 a_xp22 a_xn22 wp_ih_22_20 wn_ih_22_20 xhp20 xhn20 vdd vbsyn gsyn
X_ihx_23_20 a_xp23 a_xn23 wp_ih_23_20 wn_ih_23_20 xhp20 xhn20 vdd vbsyn gsyn
X_ihx_24_20 a_xp24 a_xn24 wp_ih_24_20 wn_ih_24_20 xhp20 xhn20 vdd vbsyn gsyn
X_ihx_25_20 a_xp25 a_xn25 wp_ih_25_20 wn_ih_25_20 xhp20 xhn20 vdd vbsyn gsyn
X_ihx_26_20 a_xp26 a_xn26 wp_ih_26_20 wn_ih_26_20 xhp20 xhn20 vdd vbsyn gsyn
X_ihx_27_20 a_xp27 a_xn27 wp_ih_27_20 wn_ih_27_20 xhp20 xhn20 vdd vbsyn gsyn
X_ihx_28_20 a_xp28 a_xn28 wp_ih_28_20 wn_ih_28_20 xhp20 xhn20 vdd vbsyn gsyn
X_ihx_29_20 a_xp29 a_xn29 wp_ih_29_20 wn_ih_29_20 xhp20 xhn20 vdd vbsyn gsyn
X_ihx_30_20 a_xp30 a_xn30 wp_ih_30_20 wn_ih_30_20 xhp20 xhn20 vdd vbsyn gsyn
X_ihx_31_20 a_xp31 a_xn31 wp_ih_31_20 wn_ih_31_20 xhp20 xhn20 vdd vbsyn gsyn
X_ihx_32_20 a_xp32 a_xn32 wp_ih_32_20 wn_ih_32_20 xhp20 xhn20 vdd vbsyn gsyn
X_ihx_33_20 a_xp33 a_xn33 wp_ih_33_20 wn_ih_33_20 xhp20 xhn20 vdd vbsyn gsyn
X_ihx_34_20 a_xp34 a_xn34 wp_ih_34_20 wn_ih_34_20 xhp20 xhn20 vdd vbsyn gsyn
X_ihx_35_20 a_xp35 a_xn35 wp_ih_35_20 wn_ih_35_20 xhp20 xhn20 vdd vbsyn gsyn
X_ihx_36_20 a_xp36 a_xn36 wp_ih_36_20 wn_ih_36_20 xhp20 xhn20 vdd vbsyn gsyn
X_ihx_37_20 a_xp37 a_xn37 wp_ih_37_20 wn_ih_37_20 xhp20 xhn20 vdd vbsyn gsyn
X_ihx_38_20 a_xp38 a_xn38 wp_ih_38_20 wn_ih_38_20 xhp20 xhn20 vdd vbsyn gsyn
X_ihx_39_20 a_xp39 a_xn39 wp_ih_39_20 wn_ih_39_20 xhp20 xhn20 vdd vbsyn gsyn
X_ihx_40_20 a_xp40 a_xn40 wp_ih_40_20 wn_ih_40_20 xhp20 xhn20 vdd vbsyn gsyn
X_ihx_41_20 a_xp41 a_xn41 wp_ih_41_20 wn_ih_41_20 xhp20 xhn20 vdd vbsyn gsyn
X_ihx_42_20 a_xp42 a_xn42 wp_ih_42_20 wn_ih_42_20 xhp20 xhn20 vdd vbsyn gsyn
X_ihx_43_20 a_xp43 a_xn43 wp_ih_43_20 wn_ih_43_20 xhp20 xhn20 vdd vbsyn gsyn
X_ihx_44_20 a_xp44 a_xn44 wp_ih_44_20 wn_ih_44_20 xhp20 xhn20 vdd vbsyn gsyn
X_ihx_45_20 a_xp45 a_xn45 wp_ih_45_20 wn_ih_45_20 xhp20 xhn20 vdd vbsyn gsyn
X_ihx_46_20 a_xp46 a_xn46 wp_ih_46_20 wn_ih_46_20 xhp20 xhn20 vdd vbsyn gsyn
X_ihx_47_20 a_xp47 a_xn47 wp_ih_47_20 wn_ih_47_20 xhp20 xhn20 vdd vbsyn gsyn
X_ihx_48_20 a_xp48 a_xn48 wp_ih_48_20 wn_ih_48_20 xhp20 xhn20 vdd vbsyn gsyn
X_ihx_49_20 a_xp49 a_xn49 wp_ih_49_20 wn_ih_49_20 xhp20 xhn20 vdd vbsyn gsyn
X_ihx_50_20 a_xp50 a_xn50 wp_ih_50_20 wn_ih_50_20 xhp20 xhn20 vdd vbsyn gsyn
X_ihx_51_20 a_xp51 a_xn51 wp_ih_51_20 wn_ih_51_20 xhp20 xhn20 vdd vbsyn gsyn
X_ihx_52_20 a_xp52 a_xn52 wp_ih_52_20 wn_ih_52_20 xhp20 xhn20 vdd vbsyn gsyn
X_ihx_53_20 a_xp53 a_xn53 wp_ih_53_20 wn_ih_53_20 xhp20 xhn20 vdd vbsyn gsyn
X_ihx_54_20 a_xp54 a_xn54 wp_ih_54_20 wn_ih_54_20 xhp20 xhn20 vdd vbsyn gsyn
X_ihx_55_20 a_xp55 a_xn55 wp_ih_55_20 wn_ih_55_20 xhp20 xhn20 vdd vbsyn gsyn
X_ihx_56_20 a_xp56 a_xn56 wp_ih_56_20 wn_ih_56_20 xhp20 xhn20 vdd vbsyn gsyn
X_ihx_57_20 a_xp57 a_xn57 wp_ih_57_20 wn_ih_57_20 xhp20 xhn20 vdd vbsyn gsyn
X_ihx_58_20 a_xp58 a_xn58 wp_ih_58_20 wn_ih_58_20 xhp20 xhn20 vdd vbsyn gsyn
X_ihx_59_20 a_xp59 a_xn59 wp_ih_59_20 wn_ih_59_20 xhp20 xhn20 vdd vbsyn gsyn
X_ihx_60_20 a_xp60 a_xn60 wp_ih_60_20 wn_ih_60_20 xhp20 xhn20 vdd vbsyn gsyn
X_ihx_61_20 a_xp61 a_xn61 wp_ih_61_20 wn_ih_61_20 xhp20 xhn20 vdd vbsyn gsyn
X_ihx_62_20 a_xp62 a_xn62 wp_ih_62_20 wn_ih_62_20 xhp20 xhn20 vdd vbsyn gsyn
X_ihx_63_20 a_xp63 a_xn63 wp_ih_63_20 wn_ih_63_20 xhp20 xhn20 vdd vbsyn gsyn
Xn20 xhp20 xhn20 ahp20 ahn20 vdd vbneu dneuron
Xcm_xh21 xhp21 xhn21 vdd cmld
Rnd_xh21 xhp21 xhn21 20k
X_ihx_0_21 a_xp0 a_xn0 wp_ih_0_21 wn_ih_0_21 xhp21 xhn21 vdd vbsyn gsyn
X_ihx_1_21 a_xp1 a_xn1 wp_ih_1_21 wn_ih_1_21 xhp21 xhn21 vdd vbsyn gsyn
X_ihx_2_21 a_xp2 a_xn2 wp_ih_2_21 wn_ih_2_21 xhp21 xhn21 vdd vbsyn gsyn
X_ihx_3_21 a_xp3 a_xn3 wp_ih_3_21 wn_ih_3_21 xhp21 xhn21 vdd vbsyn gsyn
X_ihx_4_21 a_xp4 a_xn4 wp_ih_4_21 wn_ih_4_21 xhp21 xhn21 vdd vbsyn gsyn
X_ihx_5_21 a_xp5 a_xn5 wp_ih_5_21 wn_ih_5_21 xhp21 xhn21 vdd vbsyn gsyn
X_ihx_6_21 a_xp6 a_xn6 wp_ih_6_21 wn_ih_6_21 xhp21 xhn21 vdd vbsyn gsyn
X_ihx_7_21 a_xp7 a_xn7 wp_ih_7_21 wn_ih_7_21 xhp21 xhn21 vdd vbsyn gsyn
X_ihx_8_21 a_xp8 a_xn8 wp_ih_8_21 wn_ih_8_21 xhp21 xhn21 vdd vbsyn gsyn
X_ihx_9_21 a_xp9 a_xn9 wp_ih_9_21 wn_ih_9_21 xhp21 xhn21 vdd vbsyn gsyn
X_ihx_10_21 a_xp10 a_xn10 wp_ih_10_21 wn_ih_10_21 xhp21 xhn21 vdd vbsyn gsyn
X_ihx_11_21 a_xp11 a_xn11 wp_ih_11_21 wn_ih_11_21 xhp21 xhn21 vdd vbsyn gsyn
X_ihx_12_21 a_xp12 a_xn12 wp_ih_12_21 wn_ih_12_21 xhp21 xhn21 vdd vbsyn gsyn
X_ihx_13_21 a_xp13 a_xn13 wp_ih_13_21 wn_ih_13_21 xhp21 xhn21 vdd vbsyn gsyn
X_ihx_14_21 a_xp14 a_xn14 wp_ih_14_21 wn_ih_14_21 xhp21 xhn21 vdd vbsyn gsyn
X_ihx_15_21 a_xp15 a_xn15 wp_ih_15_21 wn_ih_15_21 xhp21 xhn21 vdd vbsyn gsyn
X_ihx_16_21 a_xp16 a_xn16 wp_ih_16_21 wn_ih_16_21 xhp21 xhn21 vdd vbsyn gsyn
X_ihx_17_21 a_xp17 a_xn17 wp_ih_17_21 wn_ih_17_21 xhp21 xhn21 vdd vbsyn gsyn
X_ihx_18_21 a_xp18 a_xn18 wp_ih_18_21 wn_ih_18_21 xhp21 xhn21 vdd vbsyn gsyn
X_ihx_19_21 a_xp19 a_xn19 wp_ih_19_21 wn_ih_19_21 xhp21 xhn21 vdd vbsyn gsyn
X_ihx_20_21 a_xp20 a_xn20 wp_ih_20_21 wn_ih_20_21 xhp21 xhn21 vdd vbsyn gsyn
X_ihx_21_21 a_xp21 a_xn21 wp_ih_21_21 wn_ih_21_21 xhp21 xhn21 vdd vbsyn gsyn
X_ihx_22_21 a_xp22 a_xn22 wp_ih_22_21 wn_ih_22_21 xhp21 xhn21 vdd vbsyn gsyn
X_ihx_23_21 a_xp23 a_xn23 wp_ih_23_21 wn_ih_23_21 xhp21 xhn21 vdd vbsyn gsyn
X_ihx_24_21 a_xp24 a_xn24 wp_ih_24_21 wn_ih_24_21 xhp21 xhn21 vdd vbsyn gsyn
X_ihx_25_21 a_xp25 a_xn25 wp_ih_25_21 wn_ih_25_21 xhp21 xhn21 vdd vbsyn gsyn
X_ihx_26_21 a_xp26 a_xn26 wp_ih_26_21 wn_ih_26_21 xhp21 xhn21 vdd vbsyn gsyn
X_ihx_27_21 a_xp27 a_xn27 wp_ih_27_21 wn_ih_27_21 xhp21 xhn21 vdd vbsyn gsyn
X_ihx_28_21 a_xp28 a_xn28 wp_ih_28_21 wn_ih_28_21 xhp21 xhn21 vdd vbsyn gsyn
X_ihx_29_21 a_xp29 a_xn29 wp_ih_29_21 wn_ih_29_21 xhp21 xhn21 vdd vbsyn gsyn
X_ihx_30_21 a_xp30 a_xn30 wp_ih_30_21 wn_ih_30_21 xhp21 xhn21 vdd vbsyn gsyn
X_ihx_31_21 a_xp31 a_xn31 wp_ih_31_21 wn_ih_31_21 xhp21 xhn21 vdd vbsyn gsyn
X_ihx_32_21 a_xp32 a_xn32 wp_ih_32_21 wn_ih_32_21 xhp21 xhn21 vdd vbsyn gsyn
X_ihx_33_21 a_xp33 a_xn33 wp_ih_33_21 wn_ih_33_21 xhp21 xhn21 vdd vbsyn gsyn
X_ihx_34_21 a_xp34 a_xn34 wp_ih_34_21 wn_ih_34_21 xhp21 xhn21 vdd vbsyn gsyn
X_ihx_35_21 a_xp35 a_xn35 wp_ih_35_21 wn_ih_35_21 xhp21 xhn21 vdd vbsyn gsyn
X_ihx_36_21 a_xp36 a_xn36 wp_ih_36_21 wn_ih_36_21 xhp21 xhn21 vdd vbsyn gsyn
X_ihx_37_21 a_xp37 a_xn37 wp_ih_37_21 wn_ih_37_21 xhp21 xhn21 vdd vbsyn gsyn
X_ihx_38_21 a_xp38 a_xn38 wp_ih_38_21 wn_ih_38_21 xhp21 xhn21 vdd vbsyn gsyn
X_ihx_39_21 a_xp39 a_xn39 wp_ih_39_21 wn_ih_39_21 xhp21 xhn21 vdd vbsyn gsyn
X_ihx_40_21 a_xp40 a_xn40 wp_ih_40_21 wn_ih_40_21 xhp21 xhn21 vdd vbsyn gsyn
X_ihx_41_21 a_xp41 a_xn41 wp_ih_41_21 wn_ih_41_21 xhp21 xhn21 vdd vbsyn gsyn
X_ihx_42_21 a_xp42 a_xn42 wp_ih_42_21 wn_ih_42_21 xhp21 xhn21 vdd vbsyn gsyn
X_ihx_43_21 a_xp43 a_xn43 wp_ih_43_21 wn_ih_43_21 xhp21 xhn21 vdd vbsyn gsyn
X_ihx_44_21 a_xp44 a_xn44 wp_ih_44_21 wn_ih_44_21 xhp21 xhn21 vdd vbsyn gsyn
X_ihx_45_21 a_xp45 a_xn45 wp_ih_45_21 wn_ih_45_21 xhp21 xhn21 vdd vbsyn gsyn
X_ihx_46_21 a_xp46 a_xn46 wp_ih_46_21 wn_ih_46_21 xhp21 xhn21 vdd vbsyn gsyn
X_ihx_47_21 a_xp47 a_xn47 wp_ih_47_21 wn_ih_47_21 xhp21 xhn21 vdd vbsyn gsyn
X_ihx_48_21 a_xp48 a_xn48 wp_ih_48_21 wn_ih_48_21 xhp21 xhn21 vdd vbsyn gsyn
X_ihx_49_21 a_xp49 a_xn49 wp_ih_49_21 wn_ih_49_21 xhp21 xhn21 vdd vbsyn gsyn
X_ihx_50_21 a_xp50 a_xn50 wp_ih_50_21 wn_ih_50_21 xhp21 xhn21 vdd vbsyn gsyn
X_ihx_51_21 a_xp51 a_xn51 wp_ih_51_21 wn_ih_51_21 xhp21 xhn21 vdd vbsyn gsyn
X_ihx_52_21 a_xp52 a_xn52 wp_ih_52_21 wn_ih_52_21 xhp21 xhn21 vdd vbsyn gsyn
X_ihx_53_21 a_xp53 a_xn53 wp_ih_53_21 wn_ih_53_21 xhp21 xhn21 vdd vbsyn gsyn
X_ihx_54_21 a_xp54 a_xn54 wp_ih_54_21 wn_ih_54_21 xhp21 xhn21 vdd vbsyn gsyn
X_ihx_55_21 a_xp55 a_xn55 wp_ih_55_21 wn_ih_55_21 xhp21 xhn21 vdd vbsyn gsyn
X_ihx_56_21 a_xp56 a_xn56 wp_ih_56_21 wn_ih_56_21 xhp21 xhn21 vdd vbsyn gsyn
X_ihx_57_21 a_xp57 a_xn57 wp_ih_57_21 wn_ih_57_21 xhp21 xhn21 vdd vbsyn gsyn
X_ihx_58_21 a_xp58 a_xn58 wp_ih_58_21 wn_ih_58_21 xhp21 xhn21 vdd vbsyn gsyn
X_ihx_59_21 a_xp59 a_xn59 wp_ih_59_21 wn_ih_59_21 xhp21 xhn21 vdd vbsyn gsyn
X_ihx_60_21 a_xp60 a_xn60 wp_ih_60_21 wn_ih_60_21 xhp21 xhn21 vdd vbsyn gsyn
X_ihx_61_21 a_xp61 a_xn61 wp_ih_61_21 wn_ih_61_21 xhp21 xhn21 vdd vbsyn gsyn
X_ihx_62_21 a_xp62 a_xn62 wp_ih_62_21 wn_ih_62_21 xhp21 xhn21 vdd vbsyn gsyn
X_ihx_63_21 a_xp63 a_xn63 wp_ih_63_21 wn_ih_63_21 xhp21 xhn21 vdd vbsyn gsyn
Xn21 xhp21 xhn21 ahp21 ahn21 vdd vbneu dneuron
Xcm_xh22 xhp22 xhn22 vdd cmld
Rnd_xh22 xhp22 xhn22 20k
X_ihx_0_22 a_xp0 a_xn0 wp_ih_0_22 wn_ih_0_22 xhp22 xhn22 vdd vbsyn gsyn
X_ihx_1_22 a_xp1 a_xn1 wp_ih_1_22 wn_ih_1_22 xhp22 xhn22 vdd vbsyn gsyn
X_ihx_2_22 a_xp2 a_xn2 wp_ih_2_22 wn_ih_2_22 xhp22 xhn22 vdd vbsyn gsyn
X_ihx_3_22 a_xp3 a_xn3 wp_ih_3_22 wn_ih_3_22 xhp22 xhn22 vdd vbsyn gsyn
X_ihx_4_22 a_xp4 a_xn4 wp_ih_4_22 wn_ih_4_22 xhp22 xhn22 vdd vbsyn gsyn
X_ihx_5_22 a_xp5 a_xn5 wp_ih_5_22 wn_ih_5_22 xhp22 xhn22 vdd vbsyn gsyn
X_ihx_6_22 a_xp6 a_xn6 wp_ih_6_22 wn_ih_6_22 xhp22 xhn22 vdd vbsyn gsyn
X_ihx_7_22 a_xp7 a_xn7 wp_ih_7_22 wn_ih_7_22 xhp22 xhn22 vdd vbsyn gsyn
X_ihx_8_22 a_xp8 a_xn8 wp_ih_8_22 wn_ih_8_22 xhp22 xhn22 vdd vbsyn gsyn
X_ihx_9_22 a_xp9 a_xn9 wp_ih_9_22 wn_ih_9_22 xhp22 xhn22 vdd vbsyn gsyn
X_ihx_10_22 a_xp10 a_xn10 wp_ih_10_22 wn_ih_10_22 xhp22 xhn22 vdd vbsyn gsyn
X_ihx_11_22 a_xp11 a_xn11 wp_ih_11_22 wn_ih_11_22 xhp22 xhn22 vdd vbsyn gsyn
X_ihx_12_22 a_xp12 a_xn12 wp_ih_12_22 wn_ih_12_22 xhp22 xhn22 vdd vbsyn gsyn
X_ihx_13_22 a_xp13 a_xn13 wp_ih_13_22 wn_ih_13_22 xhp22 xhn22 vdd vbsyn gsyn
X_ihx_14_22 a_xp14 a_xn14 wp_ih_14_22 wn_ih_14_22 xhp22 xhn22 vdd vbsyn gsyn
X_ihx_15_22 a_xp15 a_xn15 wp_ih_15_22 wn_ih_15_22 xhp22 xhn22 vdd vbsyn gsyn
X_ihx_16_22 a_xp16 a_xn16 wp_ih_16_22 wn_ih_16_22 xhp22 xhn22 vdd vbsyn gsyn
X_ihx_17_22 a_xp17 a_xn17 wp_ih_17_22 wn_ih_17_22 xhp22 xhn22 vdd vbsyn gsyn
X_ihx_18_22 a_xp18 a_xn18 wp_ih_18_22 wn_ih_18_22 xhp22 xhn22 vdd vbsyn gsyn
X_ihx_19_22 a_xp19 a_xn19 wp_ih_19_22 wn_ih_19_22 xhp22 xhn22 vdd vbsyn gsyn
X_ihx_20_22 a_xp20 a_xn20 wp_ih_20_22 wn_ih_20_22 xhp22 xhn22 vdd vbsyn gsyn
X_ihx_21_22 a_xp21 a_xn21 wp_ih_21_22 wn_ih_21_22 xhp22 xhn22 vdd vbsyn gsyn
X_ihx_22_22 a_xp22 a_xn22 wp_ih_22_22 wn_ih_22_22 xhp22 xhn22 vdd vbsyn gsyn
X_ihx_23_22 a_xp23 a_xn23 wp_ih_23_22 wn_ih_23_22 xhp22 xhn22 vdd vbsyn gsyn
X_ihx_24_22 a_xp24 a_xn24 wp_ih_24_22 wn_ih_24_22 xhp22 xhn22 vdd vbsyn gsyn
X_ihx_25_22 a_xp25 a_xn25 wp_ih_25_22 wn_ih_25_22 xhp22 xhn22 vdd vbsyn gsyn
X_ihx_26_22 a_xp26 a_xn26 wp_ih_26_22 wn_ih_26_22 xhp22 xhn22 vdd vbsyn gsyn
X_ihx_27_22 a_xp27 a_xn27 wp_ih_27_22 wn_ih_27_22 xhp22 xhn22 vdd vbsyn gsyn
X_ihx_28_22 a_xp28 a_xn28 wp_ih_28_22 wn_ih_28_22 xhp22 xhn22 vdd vbsyn gsyn
X_ihx_29_22 a_xp29 a_xn29 wp_ih_29_22 wn_ih_29_22 xhp22 xhn22 vdd vbsyn gsyn
X_ihx_30_22 a_xp30 a_xn30 wp_ih_30_22 wn_ih_30_22 xhp22 xhn22 vdd vbsyn gsyn
X_ihx_31_22 a_xp31 a_xn31 wp_ih_31_22 wn_ih_31_22 xhp22 xhn22 vdd vbsyn gsyn
X_ihx_32_22 a_xp32 a_xn32 wp_ih_32_22 wn_ih_32_22 xhp22 xhn22 vdd vbsyn gsyn
X_ihx_33_22 a_xp33 a_xn33 wp_ih_33_22 wn_ih_33_22 xhp22 xhn22 vdd vbsyn gsyn
X_ihx_34_22 a_xp34 a_xn34 wp_ih_34_22 wn_ih_34_22 xhp22 xhn22 vdd vbsyn gsyn
X_ihx_35_22 a_xp35 a_xn35 wp_ih_35_22 wn_ih_35_22 xhp22 xhn22 vdd vbsyn gsyn
X_ihx_36_22 a_xp36 a_xn36 wp_ih_36_22 wn_ih_36_22 xhp22 xhn22 vdd vbsyn gsyn
X_ihx_37_22 a_xp37 a_xn37 wp_ih_37_22 wn_ih_37_22 xhp22 xhn22 vdd vbsyn gsyn
X_ihx_38_22 a_xp38 a_xn38 wp_ih_38_22 wn_ih_38_22 xhp22 xhn22 vdd vbsyn gsyn
X_ihx_39_22 a_xp39 a_xn39 wp_ih_39_22 wn_ih_39_22 xhp22 xhn22 vdd vbsyn gsyn
X_ihx_40_22 a_xp40 a_xn40 wp_ih_40_22 wn_ih_40_22 xhp22 xhn22 vdd vbsyn gsyn
X_ihx_41_22 a_xp41 a_xn41 wp_ih_41_22 wn_ih_41_22 xhp22 xhn22 vdd vbsyn gsyn
X_ihx_42_22 a_xp42 a_xn42 wp_ih_42_22 wn_ih_42_22 xhp22 xhn22 vdd vbsyn gsyn
X_ihx_43_22 a_xp43 a_xn43 wp_ih_43_22 wn_ih_43_22 xhp22 xhn22 vdd vbsyn gsyn
X_ihx_44_22 a_xp44 a_xn44 wp_ih_44_22 wn_ih_44_22 xhp22 xhn22 vdd vbsyn gsyn
X_ihx_45_22 a_xp45 a_xn45 wp_ih_45_22 wn_ih_45_22 xhp22 xhn22 vdd vbsyn gsyn
X_ihx_46_22 a_xp46 a_xn46 wp_ih_46_22 wn_ih_46_22 xhp22 xhn22 vdd vbsyn gsyn
X_ihx_47_22 a_xp47 a_xn47 wp_ih_47_22 wn_ih_47_22 xhp22 xhn22 vdd vbsyn gsyn
X_ihx_48_22 a_xp48 a_xn48 wp_ih_48_22 wn_ih_48_22 xhp22 xhn22 vdd vbsyn gsyn
X_ihx_49_22 a_xp49 a_xn49 wp_ih_49_22 wn_ih_49_22 xhp22 xhn22 vdd vbsyn gsyn
X_ihx_50_22 a_xp50 a_xn50 wp_ih_50_22 wn_ih_50_22 xhp22 xhn22 vdd vbsyn gsyn
X_ihx_51_22 a_xp51 a_xn51 wp_ih_51_22 wn_ih_51_22 xhp22 xhn22 vdd vbsyn gsyn
X_ihx_52_22 a_xp52 a_xn52 wp_ih_52_22 wn_ih_52_22 xhp22 xhn22 vdd vbsyn gsyn
X_ihx_53_22 a_xp53 a_xn53 wp_ih_53_22 wn_ih_53_22 xhp22 xhn22 vdd vbsyn gsyn
X_ihx_54_22 a_xp54 a_xn54 wp_ih_54_22 wn_ih_54_22 xhp22 xhn22 vdd vbsyn gsyn
X_ihx_55_22 a_xp55 a_xn55 wp_ih_55_22 wn_ih_55_22 xhp22 xhn22 vdd vbsyn gsyn
X_ihx_56_22 a_xp56 a_xn56 wp_ih_56_22 wn_ih_56_22 xhp22 xhn22 vdd vbsyn gsyn
X_ihx_57_22 a_xp57 a_xn57 wp_ih_57_22 wn_ih_57_22 xhp22 xhn22 vdd vbsyn gsyn
X_ihx_58_22 a_xp58 a_xn58 wp_ih_58_22 wn_ih_58_22 xhp22 xhn22 vdd vbsyn gsyn
X_ihx_59_22 a_xp59 a_xn59 wp_ih_59_22 wn_ih_59_22 xhp22 xhn22 vdd vbsyn gsyn
X_ihx_60_22 a_xp60 a_xn60 wp_ih_60_22 wn_ih_60_22 xhp22 xhn22 vdd vbsyn gsyn
X_ihx_61_22 a_xp61 a_xn61 wp_ih_61_22 wn_ih_61_22 xhp22 xhn22 vdd vbsyn gsyn
X_ihx_62_22 a_xp62 a_xn62 wp_ih_62_22 wn_ih_62_22 xhp22 xhn22 vdd vbsyn gsyn
X_ihx_63_22 a_xp63 a_xn63 wp_ih_63_22 wn_ih_63_22 xhp22 xhn22 vdd vbsyn gsyn
Xn22 xhp22 xhn22 ahp22 ahn22 vdd vbneu dneuron
Xcm_xh23 xhp23 xhn23 vdd cmld
Rnd_xh23 xhp23 xhn23 20k
X_ihx_0_23 a_xp0 a_xn0 wp_ih_0_23 wn_ih_0_23 xhp23 xhn23 vdd vbsyn gsyn
X_ihx_1_23 a_xp1 a_xn1 wp_ih_1_23 wn_ih_1_23 xhp23 xhn23 vdd vbsyn gsyn
X_ihx_2_23 a_xp2 a_xn2 wp_ih_2_23 wn_ih_2_23 xhp23 xhn23 vdd vbsyn gsyn
X_ihx_3_23 a_xp3 a_xn3 wp_ih_3_23 wn_ih_3_23 xhp23 xhn23 vdd vbsyn gsyn
X_ihx_4_23 a_xp4 a_xn4 wp_ih_4_23 wn_ih_4_23 xhp23 xhn23 vdd vbsyn gsyn
X_ihx_5_23 a_xp5 a_xn5 wp_ih_5_23 wn_ih_5_23 xhp23 xhn23 vdd vbsyn gsyn
X_ihx_6_23 a_xp6 a_xn6 wp_ih_6_23 wn_ih_6_23 xhp23 xhn23 vdd vbsyn gsyn
X_ihx_7_23 a_xp7 a_xn7 wp_ih_7_23 wn_ih_7_23 xhp23 xhn23 vdd vbsyn gsyn
X_ihx_8_23 a_xp8 a_xn8 wp_ih_8_23 wn_ih_8_23 xhp23 xhn23 vdd vbsyn gsyn
X_ihx_9_23 a_xp9 a_xn9 wp_ih_9_23 wn_ih_9_23 xhp23 xhn23 vdd vbsyn gsyn
X_ihx_10_23 a_xp10 a_xn10 wp_ih_10_23 wn_ih_10_23 xhp23 xhn23 vdd vbsyn gsyn
X_ihx_11_23 a_xp11 a_xn11 wp_ih_11_23 wn_ih_11_23 xhp23 xhn23 vdd vbsyn gsyn
X_ihx_12_23 a_xp12 a_xn12 wp_ih_12_23 wn_ih_12_23 xhp23 xhn23 vdd vbsyn gsyn
X_ihx_13_23 a_xp13 a_xn13 wp_ih_13_23 wn_ih_13_23 xhp23 xhn23 vdd vbsyn gsyn
X_ihx_14_23 a_xp14 a_xn14 wp_ih_14_23 wn_ih_14_23 xhp23 xhn23 vdd vbsyn gsyn
X_ihx_15_23 a_xp15 a_xn15 wp_ih_15_23 wn_ih_15_23 xhp23 xhn23 vdd vbsyn gsyn
X_ihx_16_23 a_xp16 a_xn16 wp_ih_16_23 wn_ih_16_23 xhp23 xhn23 vdd vbsyn gsyn
X_ihx_17_23 a_xp17 a_xn17 wp_ih_17_23 wn_ih_17_23 xhp23 xhn23 vdd vbsyn gsyn
X_ihx_18_23 a_xp18 a_xn18 wp_ih_18_23 wn_ih_18_23 xhp23 xhn23 vdd vbsyn gsyn
X_ihx_19_23 a_xp19 a_xn19 wp_ih_19_23 wn_ih_19_23 xhp23 xhn23 vdd vbsyn gsyn
X_ihx_20_23 a_xp20 a_xn20 wp_ih_20_23 wn_ih_20_23 xhp23 xhn23 vdd vbsyn gsyn
X_ihx_21_23 a_xp21 a_xn21 wp_ih_21_23 wn_ih_21_23 xhp23 xhn23 vdd vbsyn gsyn
X_ihx_22_23 a_xp22 a_xn22 wp_ih_22_23 wn_ih_22_23 xhp23 xhn23 vdd vbsyn gsyn
X_ihx_23_23 a_xp23 a_xn23 wp_ih_23_23 wn_ih_23_23 xhp23 xhn23 vdd vbsyn gsyn
X_ihx_24_23 a_xp24 a_xn24 wp_ih_24_23 wn_ih_24_23 xhp23 xhn23 vdd vbsyn gsyn
X_ihx_25_23 a_xp25 a_xn25 wp_ih_25_23 wn_ih_25_23 xhp23 xhn23 vdd vbsyn gsyn
X_ihx_26_23 a_xp26 a_xn26 wp_ih_26_23 wn_ih_26_23 xhp23 xhn23 vdd vbsyn gsyn
X_ihx_27_23 a_xp27 a_xn27 wp_ih_27_23 wn_ih_27_23 xhp23 xhn23 vdd vbsyn gsyn
X_ihx_28_23 a_xp28 a_xn28 wp_ih_28_23 wn_ih_28_23 xhp23 xhn23 vdd vbsyn gsyn
X_ihx_29_23 a_xp29 a_xn29 wp_ih_29_23 wn_ih_29_23 xhp23 xhn23 vdd vbsyn gsyn
X_ihx_30_23 a_xp30 a_xn30 wp_ih_30_23 wn_ih_30_23 xhp23 xhn23 vdd vbsyn gsyn
X_ihx_31_23 a_xp31 a_xn31 wp_ih_31_23 wn_ih_31_23 xhp23 xhn23 vdd vbsyn gsyn
X_ihx_32_23 a_xp32 a_xn32 wp_ih_32_23 wn_ih_32_23 xhp23 xhn23 vdd vbsyn gsyn
X_ihx_33_23 a_xp33 a_xn33 wp_ih_33_23 wn_ih_33_23 xhp23 xhn23 vdd vbsyn gsyn
X_ihx_34_23 a_xp34 a_xn34 wp_ih_34_23 wn_ih_34_23 xhp23 xhn23 vdd vbsyn gsyn
X_ihx_35_23 a_xp35 a_xn35 wp_ih_35_23 wn_ih_35_23 xhp23 xhn23 vdd vbsyn gsyn
X_ihx_36_23 a_xp36 a_xn36 wp_ih_36_23 wn_ih_36_23 xhp23 xhn23 vdd vbsyn gsyn
X_ihx_37_23 a_xp37 a_xn37 wp_ih_37_23 wn_ih_37_23 xhp23 xhn23 vdd vbsyn gsyn
X_ihx_38_23 a_xp38 a_xn38 wp_ih_38_23 wn_ih_38_23 xhp23 xhn23 vdd vbsyn gsyn
X_ihx_39_23 a_xp39 a_xn39 wp_ih_39_23 wn_ih_39_23 xhp23 xhn23 vdd vbsyn gsyn
X_ihx_40_23 a_xp40 a_xn40 wp_ih_40_23 wn_ih_40_23 xhp23 xhn23 vdd vbsyn gsyn
X_ihx_41_23 a_xp41 a_xn41 wp_ih_41_23 wn_ih_41_23 xhp23 xhn23 vdd vbsyn gsyn
X_ihx_42_23 a_xp42 a_xn42 wp_ih_42_23 wn_ih_42_23 xhp23 xhn23 vdd vbsyn gsyn
X_ihx_43_23 a_xp43 a_xn43 wp_ih_43_23 wn_ih_43_23 xhp23 xhn23 vdd vbsyn gsyn
X_ihx_44_23 a_xp44 a_xn44 wp_ih_44_23 wn_ih_44_23 xhp23 xhn23 vdd vbsyn gsyn
X_ihx_45_23 a_xp45 a_xn45 wp_ih_45_23 wn_ih_45_23 xhp23 xhn23 vdd vbsyn gsyn
X_ihx_46_23 a_xp46 a_xn46 wp_ih_46_23 wn_ih_46_23 xhp23 xhn23 vdd vbsyn gsyn
X_ihx_47_23 a_xp47 a_xn47 wp_ih_47_23 wn_ih_47_23 xhp23 xhn23 vdd vbsyn gsyn
X_ihx_48_23 a_xp48 a_xn48 wp_ih_48_23 wn_ih_48_23 xhp23 xhn23 vdd vbsyn gsyn
X_ihx_49_23 a_xp49 a_xn49 wp_ih_49_23 wn_ih_49_23 xhp23 xhn23 vdd vbsyn gsyn
X_ihx_50_23 a_xp50 a_xn50 wp_ih_50_23 wn_ih_50_23 xhp23 xhn23 vdd vbsyn gsyn
X_ihx_51_23 a_xp51 a_xn51 wp_ih_51_23 wn_ih_51_23 xhp23 xhn23 vdd vbsyn gsyn
X_ihx_52_23 a_xp52 a_xn52 wp_ih_52_23 wn_ih_52_23 xhp23 xhn23 vdd vbsyn gsyn
X_ihx_53_23 a_xp53 a_xn53 wp_ih_53_23 wn_ih_53_23 xhp23 xhn23 vdd vbsyn gsyn
X_ihx_54_23 a_xp54 a_xn54 wp_ih_54_23 wn_ih_54_23 xhp23 xhn23 vdd vbsyn gsyn
X_ihx_55_23 a_xp55 a_xn55 wp_ih_55_23 wn_ih_55_23 xhp23 xhn23 vdd vbsyn gsyn
X_ihx_56_23 a_xp56 a_xn56 wp_ih_56_23 wn_ih_56_23 xhp23 xhn23 vdd vbsyn gsyn
X_ihx_57_23 a_xp57 a_xn57 wp_ih_57_23 wn_ih_57_23 xhp23 xhn23 vdd vbsyn gsyn
X_ihx_58_23 a_xp58 a_xn58 wp_ih_58_23 wn_ih_58_23 xhp23 xhn23 vdd vbsyn gsyn
X_ihx_59_23 a_xp59 a_xn59 wp_ih_59_23 wn_ih_59_23 xhp23 xhn23 vdd vbsyn gsyn
X_ihx_60_23 a_xp60 a_xn60 wp_ih_60_23 wn_ih_60_23 xhp23 xhn23 vdd vbsyn gsyn
X_ihx_61_23 a_xp61 a_xn61 wp_ih_61_23 wn_ih_61_23 xhp23 xhn23 vdd vbsyn gsyn
X_ihx_62_23 a_xp62 a_xn62 wp_ih_62_23 wn_ih_62_23 xhp23 xhn23 vdd vbsyn gsyn
X_ihx_63_23 a_xp63 a_xn63 wp_ih_63_23 wn_ih_63_23 xhp23 xhn23 vdd vbsyn gsyn
Xn23 xhp23 xhn23 ahp23 ahn23 vdd vbneu dneuron
Xcm_xh24 xhp24 xhn24 vdd cmld
Rnd_xh24 xhp24 xhn24 20k
X_ihx_0_24 a_xp0 a_xn0 wp_ih_0_24 wn_ih_0_24 xhp24 xhn24 vdd vbsyn gsyn
X_ihx_1_24 a_xp1 a_xn1 wp_ih_1_24 wn_ih_1_24 xhp24 xhn24 vdd vbsyn gsyn
X_ihx_2_24 a_xp2 a_xn2 wp_ih_2_24 wn_ih_2_24 xhp24 xhn24 vdd vbsyn gsyn
X_ihx_3_24 a_xp3 a_xn3 wp_ih_3_24 wn_ih_3_24 xhp24 xhn24 vdd vbsyn gsyn
X_ihx_4_24 a_xp4 a_xn4 wp_ih_4_24 wn_ih_4_24 xhp24 xhn24 vdd vbsyn gsyn
X_ihx_5_24 a_xp5 a_xn5 wp_ih_5_24 wn_ih_5_24 xhp24 xhn24 vdd vbsyn gsyn
X_ihx_6_24 a_xp6 a_xn6 wp_ih_6_24 wn_ih_6_24 xhp24 xhn24 vdd vbsyn gsyn
X_ihx_7_24 a_xp7 a_xn7 wp_ih_7_24 wn_ih_7_24 xhp24 xhn24 vdd vbsyn gsyn
X_ihx_8_24 a_xp8 a_xn8 wp_ih_8_24 wn_ih_8_24 xhp24 xhn24 vdd vbsyn gsyn
X_ihx_9_24 a_xp9 a_xn9 wp_ih_9_24 wn_ih_9_24 xhp24 xhn24 vdd vbsyn gsyn
X_ihx_10_24 a_xp10 a_xn10 wp_ih_10_24 wn_ih_10_24 xhp24 xhn24 vdd vbsyn gsyn
X_ihx_11_24 a_xp11 a_xn11 wp_ih_11_24 wn_ih_11_24 xhp24 xhn24 vdd vbsyn gsyn
X_ihx_12_24 a_xp12 a_xn12 wp_ih_12_24 wn_ih_12_24 xhp24 xhn24 vdd vbsyn gsyn
X_ihx_13_24 a_xp13 a_xn13 wp_ih_13_24 wn_ih_13_24 xhp24 xhn24 vdd vbsyn gsyn
X_ihx_14_24 a_xp14 a_xn14 wp_ih_14_24 wn_ih_14_24 xhp24 xhn24 vdd vbsyn gsyn
X_ihx_15_24 a_xp15 a_xn15 wp_ih_15_24 wn_ih_15_24 xhp24 xhn24 vdd vbsyn gsyn
X_ihx_16_24 a_xp16 a_xn16 wp_ih_16_24 wn_ih_16_24 xhp24 xhn24 vdd vbsyn gsyn
X_ihx_17_24 a_xp17 a_xn17 wp_ih_17_24 wn_ih_17_24 xhp24 xhn24 vdd vbsyn gsyn
X_ihx_18_24 a_xp18 a_xn18 wp_ih_18_24 wn_ih_18_24 xhp24 xhn24 vdd vbsyn gsyn
X_ihx_19_24 a_xp19 a_xn19 wp_ih_19_24 wn_ih_19_24 xhp24 xhn24 vdd vbsyn gsyn
X_ihx_20_24 a_xp20 a_xn20 wp_ih_20_24 wn_ih_20_24 xhp24 xhn24 vdd vbsyn gsyn
X_ihx_21_24 a_xp21 a_xn21 wp_ih_21_24 wn_ih_21_24 xhp24 xhn24 vdd vbsyn gsyn
X_ihx_22_24 a_xp22 a_xn22 wp_ih_22_24 wn_ih_22_24 xhp24 xhn24 vdd vbsyn gsyn
X_ihx_23_24 a_xp23 a_xn23 wp_ih_23_24 wn_ih_23_24 xhp24 xhn24 vdd vbsyn gsyn
X_ihx_24_24 a_xp24 a_xn24 wp_ih_24_24 wn_ih_24_24 xhp24 xhn24 vdd vbsyn gsyn
X_ihx_25_24 a_xp25 a_xn25 wp_ih_25_24 wn_ih_25_24 xhp24 xhn24 vdd vbsyn gsyn
X_ihx_26_24 a_xp26 a_xn26 wp_ih_26_24 wn_ih_26_24 xhp24 xhn24 vdd vbsyn gsyn
X_ihx_27_24 a_xp27 a_xn27 wp_ih_27_24 wn_ih_27_24 xhp24 xhn24 vdd vbsyn gsyn
X_ihx_28_24 a_xp28 a_xn28 wp_ih_28_24 wn_ih_28_24 xhp24 xhn24 vdd vbsyn gsyn
X_ihx_29_24 a_xp29 a_xn29 wp_ih_29_24 wn_ih_29_24 xhp24 xhn24 vdd vbsyn gsyn
X_ihx_30_24 a_xp30 a_xn30 wp_ih_30_24 wn_ih_30_24 xhp24 xhn24 vdd vbsyn gsyn
X_ihx_31_24 a_xp31 a_xn31 wp_ih_31_24 wn_ih_31_24 xhp24 xhn24 vdd vbsyn gsyn
X_ihx_32_24 a_xp32 a_xn32 wp_ih_32_24 wn_ih_32_24 xhp24 xhn24 vdd vbsyn gsyn
X_ihx_33_24 a_xp33 a_xn33 wp_ih_33_24 wn_ih_33_24 xhp24 xhn24 vdd vbsyn gsyn
X_ihx_34_24 a_xp34 a_xn34 wp_ih_34_24 wn_ih_34_24 xhp24 xhn24 vdd vbsyn gsyn
X_ihx_35_24 a_xp35 a_xn35 wp_ih_35_24 wn_ih_35_24 xhp24 xhn24 vdd vbsyn gsyn
X_ihx_36_24 a_xp36 a_xn36 wp_ih_36_24 wn_ih_36_24 xhp24 xhn24 vdd vbsyn gsyn
X_ihx_37_24 a_xp37 a_xn37 wp_ih_37_24 wn_ih_37_24 xhp24 xhn24 vdd vbsyn gsyn
X_ihx_38_24 a_xp38 a_xn38 wp_ih_38_24 wn_ih_38_24 xhp24 xhn24 vdd vbsyn gsyn
X_ihx_39_24 a_xp39 a_xn39 wp_ih_39_24 wn_ih_39_24 xhp24 xhn24 vdd vbsyn gsyn
X_ihx_40_24 a_xp40 a_xn40 wp_ih_40_24 wn_ih_40_24 xhp24 xhn24 vdd vbsyn gsyn
X_ihx_41_24 a_xp41 a_xn41 wp_ih_41_24 wn_ih_41_24 xhp24 xhn24 vdd vbsyn gsyn
X_ihx_42_24 a_xp42 a_xn42 wp_ih_42_24 wn_ih_42_24 xhp24 xhn24 vdd vbsyn gsyn
X_ihx_43_24 a_xp43 a_xn43 wp_ih_43_24 wn_ih_43_24 xhp24 xhn24 vdd vbsyn gsyn
X_ihx_44_24 a_xp44 a_xn44 wp_ih_44_24 wn_ih_44_24 xhp24 xhn24 vdd vbsyn gsyn
X_ihx_45_24 a_xp45 a_xn45 wp_ih_45_24 wn_ih_45_24 xhp24 xhn24 vdd vbsyn gsyn
X_ihx_46_24 a_xp46 a_xn46 wp_ih_46_24 wn_ih_46_24 xhp24 xhn24 vdd vbsyn gsyn
X_ihx_47_24 a_xp47 a_xn47 wp_ih_47_24 wn_ih_47_24 xhp24 xhn24 vdd vbsyn gsyn
X_ihx_48_24 a_xp48 a_xn48 wp_ih_48_24 wn_ih_48_24 xhp24 xhn24 vdd vbsyn gsyn
X_ihx_49_24 a_xp49 a_xn49 wp_ih_49_24 wn_ih_49_24 xhp24 xhn24 vdd vbsyn gsyn
X_ihx_50_24 a_xp50 a_xn50 wp_ih_50_24 wn_ih_50_24 xhp24 xhn24 vdd vbsyn gsyn
X_ihx_51_24 a_xp51 a_xn51 wp_ih_51_24 wn_ih_51_24 xhp24 xhn24 vdd vbsyn gsyn
X_ihx_52_24 a_xp52 a_xn52 wp_ih_52_24 wn_ih_52_24 xhp24 xhn24 vdd vbsyn gsyn
X_ihx_53_24 a_xp53 a_xn53 wp_ih_53_24 wn_ih_53_24 xhp24 xhn24 vdd vbsyn gsyn
X_ihx_54_24 a_xp54 a_xn54 wp_ih_54_24 wn_ih_54_24 xhp24 xhn24 vdd vbsyn gsyn
X_ihx_55_24 a_xp55 a_xn55 wp_ih_55_24 wn_ih_55_24 xhp24 xhn24 vdd vbsyn gsyn
X_ihx_56_24 a_xp56 a_xn56 wp_ih_56_24 wn_ih_56_24 xhp24 xhn24 vdd vbsyn gsyn
X_ihx_57_24 a_xp57 a_xn57 wp_ih_57_24 wn_ih_57_24 xhp24 xhn24 vdd vbsyn gsyn
X_ihx_58_24 a_xp58 a_xn58 wp_ih_58_24 wn_ih_58_24 xhp24 xhn24 vdd vbsyn gsyn
X_ihx_59_24 a_xp59 a_xn59 wp_ih_59_24 wn_ih_59_24 xhp24 xhn24 vdd vbsyn gsyn
X_ihx_60_24 a_xp60 a_xn60 wp_ih_60_24 wn_ih_60_24 xhp24 xhn24 vdd vbsyn gsyn
X_ihx_61_24 a_xp61 a_xn61 wp_ih_61_24 wn_ih_61_24 xhp24 xhn24 vdd vbsyn gsyn
X_ihx_62_24 a_xp62 a_xn62 wp_ih_62_24 wn_ih_62_24 xhp24 xhn24 vdd vbsyn gsyn
X_ihx_63_24 a_xp63 a_xn63 wp_ih_63_24 wn_ih_63_24 xhp24 xhn24 vdd vbsyn gsyn
Xn24 xhp24 xhn24 ahp24 ahn24 vdd vbneu dneuron
Xcm_xh25 xhp25 xhn25 vdd cmld
Rnd_xh25 xhp25 xhn25 20k
X_ihx_0_25 a_xp0 a_xn0 wp_ih_0_25 wn_ih_0_25 xhp25 xhn25 vdd vbsyn gsyn
X_ihx_1_25 a_xp1 a_xn1 wp_ih_1_25 wn_ih_1_25 xhp25 xhn25 vdd vbsyn gsyn
X_ihx_2_25 a_xp2 a_xn2 wp_ih_2_25 wn_ih_2_25 xhp25 xhn25 vdd vbsyn gsyn
X_ihx_3_25 a_xp3 a_xn3 wp_ih_3_25 wn_ih_3_25 xhp25 xhn25 vdd vbsyn gsyn
X_ihx_4_25 a_xp4 a_xn4 wp_ih_4_25 wn_ih_4_25 xhp25 xhn25 vdd vbsyn gsyn
X_ihx_5_25 a_xp5 a_xn5 wp_ih_5_25 wn_ih_5_25 xhp25 xhn25 vdd vbsyn gsyn
X_ihx_6_25 a_xp6 a_xn6 wp_ih_6_25 wn_ih_6_25 xhp25 xhn25 vdd vbsyn gsyn
X_ihx_7_25 a_xp7 a_xn7 wp_ih_7_25 wn_ih_7_25 xhp25 xhn25 vdd vbsyn gsyn
X_ihx_8_25 a_xp8 a_xn8 wp_ih_8_25 wn_ih_8_25 xhp25 xhn25 vdd vbsyn gsyn
X_ihx_9_25 a_xp9 a_xn9 wp_ih_9_25 wn_ih_9_25 xhp25 xhn25 vdd vbsyn gsyn
X_ihx_10_25 a_xp10 a_xn10 wp_ih_10_25 wn_ih_10_25 xhp25 xhn25 vdd vbsyn gsyn
X_ihx_11_25 a_xp11 a_xn11 wp_ih_11_25 wn_ih_11_25 xhp25 xhn25 vdd vbsyn gsyn
X_ihx_12_25 a_xp12 a_xn12 wp_ih_12_25 wn_ih_12_25 xhp25 xhn25 vdd vbsyn gsyn
X_ihx_13_25 a_xp13 a_xn13 wp_ih_13_25 wn_ih_13_25 xhp25 xhn25 vdd vbsyn gsyn
X_ihx_14_25 a_xp14 a_xn14 wp_ih_14_25 wn_ih_14_25 xhp25 xhn25 vdd vbsyn gsyn
X_ihx_15_25 a_xp15 a_xn15 wp_ih_15_25 wn_ih_15_25 xhp25 xhn25 vdd vbsyn gsyn
X_ihx_16_25 a_xp16 a_xn16 wp_ih_16_25 wn_ih_16_25 xhp25 xhn25 vdd vbsyn gsyn
X_ihx_17_25 a_xp17 a_xn17 wp_ih_17_25 wn_ih_17_25 xhp25 xhn25 vdd vbsyn gsyn
X_ihx_18_25 a_xp18 a_xn18 wp_ih_18_25 wn_ih_18_25 xhp25 xhn25 vdd vbsyn gsyn
X_ihx_19_25 a_xp19 a_xn19 wp_ih_19_25 wn_ih_19_25 xhp25 xhn25 vdd vbsyn gsyn
X_ihx_20_25 a_xp20 a_xn20 wp_ih_20_25 wn_ih_20_25 xhp25 xhn25 vdd vbsyn gsyn
X_ihx_21_25 a_xp21 a_xn21 wp_ih_21_25 wn_ih_21_25 xhp25 xhn25 vdd vbsyn gsyn
X_ihx_22_25 a_xp22 a_xn22 wp_ih_22_25 wn_ih_22_25 xhp25 xhn25 vdd vbsyn gsyn
X_ihx_23_25 a_xp23 a_xn23 wp_ih_23_25 wn_ih_23_25 xhp25 xhn25 vdd vbsyn gsyn
X_ihx_24_25 a_xp24 a_xn24 wp_ih_24_25 wn_ih_24_25 xhp25 xhn25 vdd vbsyn gsyn
X_ihx_25_25 a_xp25 a_xn25 wp_ih_25_25 wn_ih_25_25 xhp25 xhn25 vdd vbsyn gsyn
X_ihx_26_25 a_xp26 a_xn26 wp_ih_26_25 wn_ih_26_25 xhp25 xhn25 vdd vbsyn gsyn
X_ihx_27_25 a_xp27 a_xn27 wp_ih_27_25 wn_ih_27_25 xhp25 xhn25 vdd vbsyn gsyn
X_ihx_28_25 a_xp28 a_xn28 wp_ih_28_25 wn_ih_28_25 xhp25 xhn25 vdd vbsyn gsyn
X_ihx_29_25 a_xp29 a_xn29 wp_ih_29_25 wn_ih_29_25 xhp25 xhn25 vdd vbsyn gsyn
X_ihx_30_25 a_xp30 a_xn30 wp_ih_30_25 wn_ih_30_25 xhp25 xhn25 vdd vbsyn gsyn
X_ihx_31_25 a_xp31 a_xn31 wp_ih_31_25 wn_ih_31_25 xhp25 xhn25 vdd vbsyn gsyn
X_ihx_32_25 a_xp32 a_xn32 wp_ih_32_25 wn_ih_32_25 xhp25 xhn25 vdd vbsyn gsyn
X_ihx_33_25 a_xp33 a_xn33 wp_ih_33_25 wn_ih_33_25 xhp25 xhn25 vdd vbsyn gsyn
X_ihx_34_25 a_xp34 a_xn34 wp_ih_34_25 wn_ih_34_25 xhp25 xhn25 vdd vbsyn gsyn
X_ihx_35_25 a_xp35 a_xn35 wp_ih_35_25 wn_ih_35_25 xhp25 xhn25 vdd vbsyn gsyn
X_ihx_36_25 a_xp36 a_xn36 wp_ih_36_25 wn_ih_36_25 xhp25 xhn25 vdd vbsyn gsyn
X_ihx_37_25 a_xp37 a_xn37 wp_ih_37_25 wn_ih_37_25 xhp25 xhn25 vdd vbsyn gsyn
X_ihx_38_25 a_xp38 a_xn38 wp_ih_38_25 wn_ih_38_25 xhp25 xhn25 vdd vbsyn gsyn
X_ihx_39_25 a_xp39 a_xn39 wp_ih_39_25 wn_ih_39_25 xhp25 xhn25 vdd vbsyn gsyn
X_ihx_40_25 a_xp40 a_xn40 wp_ih_40_25 wn_ih_40_25 xhp25 xhn25 vdd vbsyn gsyn
X_ihx_41_25 a_xp41 a_xn41 wp_ih_41_25 wn_ih_41_25 xhp25 xhn25 vdd vbsyn gsyn
X_ihx_42_25 a_xp42 a_xn42 wp_ih_42_25 wn_ih_42_25 xhp25 xhn25 vdd vbsyn gsyn
X_ihx_43_25 a_xp43 a_xn43 wp_ih_43_25 wn_ih_43_25 xhp25 xhn25 vdd vbsyn gsyn
X_ihx_44_25 a_xp44 a_xn44 wp_ih_44_25 wn_ih_44_25 xhp25 xhn25 vdd vbsyn gsyn
X_ihx_45_25 a_xp45 a_xn45 wp_ih_45_25 wn_ih_45_25 xhp25 xhn25 vdd vbsyn gsyn
X_ihx_46_25 a_xp46 a_xn46 wp_ih_46_25 wn_ih_46_25 xhp25 xhn25 vdd vbsyn gsyn
X_ihx_47_25 a_xp47 a_xn47 wp_ih_47_25 wn_ih_47_25 xhp25 xhn25 vdd vbsyn gsyn
X_ihx_48_25 a_xp48 a_xn48 wp_ih_48_25 wn_ih_48_25 xhp25 xhn25 vdd vbsyn gsyn
X_ihx_49_25 a_xp49 a_xn49 wp_ih_49_25 wn_ih_49_25 xhp25 xhn25 vdd vbsyn gsyn
X_ihx_50_25 a_xp50 a_xn50 wp_ih_50_25 wn_ih_50_25 xhp25 xhn25 vdd vbsyn gsyn
X_ihx_51_25 a_xp51 a_xn51 wp_ih_51_25 wn_ih_51_25 xhp25 xhn25 vdd vbsyn gsyn
X_ihx_52_25 a_xp52 a_xn52 wp_ih_52_25 wn_ih_52_25 xhp25 xhn25 vdd vbsyn gsyn
X_ihx_53_25 a_xp53 a_xn53 wp_ih_53_25 wn_ih_53_25 xhp25 xhn25 vdd vbsyn gsyn
X_ihx_54_25 a_xp54 a_xn54 wp_ih_54_25 wn_ih_54_25 xhp25 xhn25 vdd vbsyn gsyn
X_ihx_55_25 a_xp55 a_xn55 wp_ih_55_25 wn_ih_55_25 xhp25 xhn25 vdd vbsyn gsyn
X_ihx_56_25 a_xp56 a_xn56 wp_ih_56_25 wn_ih_56_25 xhp25 xhn25 vdd vbsyn gsyn
X_ihx_57_25 a_xp57 a_xn57 wp_ih_57_25 wn_ih_57_25 xhp25 xhn25 vdd vbsyn gsyn
X_ihx_58_25 a_xp58 a_xn58 wp_ih_58_25 wn_ih_58_25 xhp25 xhn25 vdd vbsyn gsyn
X_ihx_59_25 a_xp59 a_xn59 wp_ih_59_25 wn_ih_59_25 xhp25 xhn25 vdd vbsyn gsyn
X_ihx_60_25 a_xp60 a_xn60 wp_ih_60_25 wn_ih_60_25 xhp25 xhn25 vdd vbsyn gsyn
X_ihx_61_25 a_xp61 a_xn61 wp_ih_61_25 wn_ih_61_25 xhp25 xhn25 vdd vbsyn gsyn
X_ihx_62_25 a_xp62 a_xn62 wp_ih_62_25 wn_ih_62_25 xhp25 xhn25 vdd vbsyn gsyn
X_ihx_63_25 a_xp63 a_xn63 wp_ih_63_25 wn_ih_63_25 xhp25 xhn25 vdd vbsyn gsyn
Xn25 xhp25 xhn25 ahp25 ahn25 vdd vbneu dneuron
Xcm_xh26 xhp26 xhn26 vdd cmld
Rnd_xh26 xhp26 xhn26 20k
X_ihx_0_26 a_xp0 a_xn0 wp_ih_0_26 wn_ih_0_26 xhp26 xhn26 vdd vbsyn gsyn
X_ihx_1_26 a_xp1 a_xn1 wp_ih_1_26 wn_ih_1_26 xhp26 xhn26 vdd vbsyn gsyn
X_ihx_2_26 a_xp2 a_xn2 wp_ih_2_26 wn_ih_2_26 xhp26 xhn26 vdd vbsyn gsyn
X_ihx_3_26 a_xp3 a_xn3 wp_ih_3_26 wn_ih_3_26 xhp26 xhn26 vdd vbsyn gsyn
X_ihx_4_26 a_xp4 a_xn4 wp_ih_4_26 wn_ih_4_26 xhp26 xhn26 vdd vbsyn gsyn
X_ihx_5_26 a_xp5 a_xn5 wp_ih_5_26 wn_ih_5_26 xhp26 xhn26 vdd vbsyn gsyn
X_ihx_6_26 a_xp6 a_xn6 wp_ih_6_26 wn_ih_6_26 xhp26 xhn26 vdd vbsyn gsyn
X_ihx_7_26 a_xp7 a_xn7 wp_ih_7_26 wn_ih_7_26 xhp26 xhn26 vdd vbsyn gsyn
X_ihx_8_26 a_xp8 a_xn8 wp_ih_8_26 wn_ih_8_26 xhp26 xhn26 vdd vbsyn gsyn
X_ihx_9_26 a_xp9 a_xn9 wp_ih_9_26 wn_ih_9_26 xhp26 xhn26 vdd vbsyn gsyn
X_ihx_10_26 a_xp10 a_xn10 wp_ih_10_26 wn_ih_10_26 xhp26 xhn26 vdd vbsyn gsyn
X_ihx_11_26 a_xp11 a_xn11 wp_ih_11_26 wn_ih_11_26 xhp26 xhn26 vdd vbsyn gsyn
X_ihx_12_26 a_xp12 a_xn12 wp_ih_12_26 wn_ih_12_26 xhp26 xhn26 vdd vbsyn gsyn
X_ihx_13_26 a_xp13 a_xn13 wp_ih_13_26 wn_ih_13_26 xhp26 xhn26 vdd vbsyn gsyn
X_ihx_14_26 a_xp14 a_xn14 wp_ih_14_26 wn_ih_14_26 xhp26 xhn26 vdd vbsyn gsyn
X_ihx_15_26 a_xp15 a_xn15 wp_ih_15_26 wn_ih_15_26 xhp26 xhn26 vdd vbsyn gsyn
X_ihx_16_26 a_xp16 a_xn16 wp_ih_16_26 wn_ih_16_26 xhp26 xhn26 vdd vbsyn gsyn
X_ihx_17_26 a_xp17 a_xn17 wp_ih_17_26 wn_ih_17_26 xhp26 xhn26 vdd vbsyn gsyn
X_ihx_18_26 a_xp18 a_xn18 wp_ih_18_26 wn_ih_18_26 xhp26 xhn26 vdd vbsyn gsyn
X_ihx_19_26 a_xp19 a_xn19 wp_ih_19_26 wn_ih_19_26 xhp26 xhn26 vdd vbsyn gsyn
X_ihx_20_26 a_xp20 a_xn20 wp_ih_20_26 wn_ih_20_26 xhp26 xhn26 vdd vbsyn gsyn
X_ihx_21_26 a_xp21 a_xn21 wp_ih_21_26 wn_ih_21_26 xhp26 xhn26 vdd vbsyn gsyn
X_ihx_22_26 a_xp22 a_xn22 wp_ih_22_26 wn_ih_22_26 xhp26 xhn26 vdd vbsyn gsyn
X_ihx_23_26 a_xp23 a_xn23 wp_ih_23_26 wn_ih_23_26 xhp26 xhn26 vdd vbsyn gsyn
X_ihx_24_26 a_xp24 a_xn24 wp_ih_24_26 wn_ih_24_26 xhp26 xhn26 vdd vbsyn gsyn
X_ihx_25_26 a_xp25 a_xn25 wp_ih_25_26 wn_ih_25_26 xhp26 xhn26 vdd vbsyn gsyn
X_ihx_26_26 a_xp26 a_xn26 wp_ih_26_26 wn_ih_26_26 xhp26 xhn26 vdd vbsyn gsyn
X_ihx_27_26 a_xp27 a_xn27 wp_ih_27_26 wn_ih_27_26 xhp26 xhn26 vdd vbsyn gsyn
X_ihx_28_26 a_xp28 a_xn28 wp_ih_28_26 wn_ih_28_26 xhp26 xhn26 vdd vbsyn gsyn
X_ihx_29_26 a_xp29 a_xn29 wp_ih_29_26 wn_ih_29_26 xhp26 xhn26 vdd vbsyn gsyn
X_ihx_30_26 a_xp30 a_xn30 wp_ih_30_26 wn_ih_30_26 xhp26 xhn26 vdd vbsyn gsyn
X_ihx_31_26 a_xp31 a_xn31 wp_ih_31_26 wn_ih_31_26 xhp26 xhn26 vdd vbsyn gsyn
X_ihx_32_26 a_xp32 a_xn32 wp_ih_32_26 wn_ih_32_26 xhp26 xhn26 vdd vbsyn gsyn
X_ihx_33_26 a_xp33 a_xn33 wp_ih_33_26 wn_ih_33_26 xhp26 xhn26 vdd vbsyn gsyn
X_ihx_34_26 a_xp34 a_xn34 wp_ih_34_26 wn_ih_34_26 xhp26 xhn26 vdd vbsyn gsyn
X_ihx_35_26 a_xp35 a_xn35 wp_ih_35_26 wn_ih_35_26 xhp26 xhn26 vdd vbsyn gsyn
X_ihx_36_26 a_xp36 a_xn36 wp_ih_36_26 wn_ih_36_26 xhp26 xhn26 vdd vbsyn gsyn
X_ihx_37_26 a_xp37 a_xn37 wp_ih_37_26 wn_ih_37_26 xhp26 xhn26 vdd vbsyn gsyn
X_ihx_38_26 a_xp38 a_xn38 wp_ih_38_26 wn_ih_38_26 xhp26 xhn26 vdd vbsyn gsyn
X_ihx_39_26 a_xp39 a_xn39 wp_ih_39_26 wn_ih_39_26 xhp26 xhn26 vdd vbsyn gsyn
X_ihx_40_26 a_xp40 a_xn40 wp_ih_40_26 wn_ih_40_26 xhp26 xhn26 vdd vbsyn gsyn
X_ihx_41_26 a_xp41 a_xn41 wp_ih_41_26 wn_ih_41_26 xhp26 xhn26 vdd vbsyn gsyn
X_ihx_42_26 a_xp42 a_xn42 wp_ih_42_26 wn_ih_42_26 xhp26 xhn26 vdd vbsyn gsyn
X_ihx_43_26 a_xp43 a_xn43 wp_ih_43_26 wn_ih_43_26 xhp26 xhn26 vdd vbsyn gsyn
X_ihx_44_26 a_xp44 a_xn44 wp_ih_44_26 wn_ih_44_26 xhp26 xhn26 vdd vbsyn gsyn
X_ihx_45_26 a_xp45 a_xn45 wp_ih_45_26 wn_ih_45_26 xhp26 xhn26 vdd vbsyn gsyn
X_ihx_46_26 a_xp46 a_xn46 wp_ih_46_26 wn_ih_46_26 xhp26 xhn26 vdd vbsyn gsyn
X_ihx_47_26 a_xp47 a_xn47 wp_ih_47_26 wn_ih_47_26 xhp26 xhn26 vdd vbsyn gsyn
X_ihx_48_26 a_xp48 a_xn48 wp_ih_48_26 wn_ih_48_26 xhp26 xhn26 vdd vbsyn gsyn
X_ihx_49_26 a_xp49 a_xn49 wp_ih_49_26 wn_ih_49_26 xhp26 xhn26 vdd vbsyn gsyn
X_ihx_50_26 a_xp50 a_xn50 wp_ih_50_26 wn_ih_50_26 xhp26 xhn26 vdd vbsyn gsyn
X_ihx_51_26 a_xp51 a_xn51 wp_ih_51_26 wn_ih_51_26 xhp26 xhn26 vdd vbsyn gsyn
X_ihx_52_26 a_xp52 a_xn52 wp_ih_52_26 wn_ih_52_26 xhp26 xhn26 vdd vbsyn gsyn
X_ihx_53_26 a_xp53 a_xn53 wp_ih_53_26 wn_ih_53_26 xhp26 xhn26 vdd vbsyn gsyn
X_ihx_54_26 a_xp54 a_xn54 wp_ih_54_26 wn_ih_54_26 xhp26 xhn26 vdd vbsyn gsyn
X_ihx_55_26 a_xp55 a_xn55 wp_ih_55_26 wn_ih_55_26 xhp26 xhn26 vdd vbsyn gsyn
X_ihx_56_26 a_xp56 a_xn56 wp_ih_56_26 wn_ih_56_26 xhp26 xhn26 vdd vbsyn gsyn
X_ihx_57_26 a_xp57 a_xn57 wp_ih_57_26 wn_ih_57_26 xhp26 xhn26 vdd vbsyn gsyn
X_ihx_58_26 a_xp58 a_xn58 wp_ih_58_26 wn_ih_58_26 xhp26 xhn26 vdd vbsyn gsyn
X_ihx_59_26 a_xp59 a_xn59 wp_ih_59_26 wn_ih_59_26 xhp26 xhn26 vdd vbsyn gsyn
X_ihx_60_26 a_xp60 a_xn60 wp_ih_60_26 wn_ih_60_26 xhp26 xhn26 vdd vbsyn gsyn
X_ihx_61_26 a_xp61 a_xn61 wp_ih_61_26 wn_ih_61_26 xhp26 xhn26 vdd vbsyn gsyn
X_ihx_62_26 a_xp62 a_xn62 wp_ih_62_26 wn_ih_62_26 xhp26 xhn26 vdd vbsyn gsyn
X_ihx_63_26 a_xp63 a_xn63 wp_ih_63_26 wn_ih_63_26 xhp26 xhn26 vdd vbsyn gsyn
Xn26 xhp26 xhn26 ahp26 ahn26 vdd vbneu dneuron
Xcm_xh27 xhp27 xhn27 vdd cmld
Rnd_xh27 xhp27 xhn27 20k
X_ihx_0_27 a_xp0 a_xn0 wp_ih_0_27 wn_ih_0_27 xhp27 xhn27 vdd vbsyn gsyn
X_ihx_1_27 a_xp1 a_xn1 wp_ih_1_27 wn_ih_1_27 xhp27 xhn27 vdd vbsyn gsyn
X_ihx_2_27 a_xp2 a_xn2 wp_ih_2_27 wn_ih_2_27 xhp27 xhn27 vdd vbsyn gsyn
X_ihx_3_27 a_xp3 a_xn3 wp_ih_3_27 wn_ih_3_27 xhp27 xhn27 vdd vbsyn gsyn
X_ihx_4_27 a_xp4 a_xn4 wp_ih_4_27 wn_ih_4_27 xhp27 xhn27 vdd vbsyn gsyn
X_ihx_5_27 a_xp5 a_xn5 wp_ih_5_27 wn_ih_5_27 xhp27 xhn27 vdd vbsyn gsyn
X_ihx_6_27 a_xp6 a_xn6 wp_ih_6_27 wn_ih_6_27 xhp27 xhn27 vdd vbsyn gsyn
X_ihx_7_27 a_xp7 a_xn7 wp_ih_7_27 wn_ih_7_27 xhp27 xhn27 vdd vbsyn gsyn
X_ihx_8_27 a_xp8 a_xn8 wp_ih_8_27 wn_ih_8_27 xhp27 xhn27 vdd vbsyn gsyn
X_ihx_9_27 a_xp9 a_xn9 wp_ih_9_27 wn_ih_9_27 xhp27 xhn27 vdd vbsyn gsyn
X_ihx_10_27 a_xp10 a_xn10 wp_ih_10_27 wn_ih_10_27 xhp27 xhn27 vdd vbsyn gsyn
X_ihx_11_27 a_xp11 a_xn11 wp_ih_11_27 wn_ih_11_27 xhp27 xhn27 vdd vbsyn gsyn
X_ihx_12_27 a_xp12 a_xn12 wp_ih_12_27 wn_ih_12_27 xhp27 xhn27 vdd vbsyn gsyn
X_ihx_13_27 a_xp13 a_xn13 wp_ih_13_27 wn_ih_13_27 xhp27 xhn27 vdd vbsyn gsyn
X_ihx_14_27 a_xp14 a_xn14 wp_ih_14_27 wn_ih_14_27 xhp27 xhn27 vdd vbsyn gsyn
X_ihx_15_27 a_xp15 a_xn15 wp_ih_15_27 wn_ih_15_27 xhp27 xhn27 vdd vbsyn gsyn
X_ihx_16_27 a_xp16 a_xn16 wp_ih_16_27 wn_ih_16_27 xhp27 xhn27 vdd vbsyn gsyn
X_ihx_17_27 a_xp17 a_xn17 wp_ih_17_27 wn_ih_17_27 xhp27 xhn27 vdd vbsyn gsyn
X_ihx_18_27 a_xp18 a_xn18 wp_ih_18_27 wn_ih_18_27 xhp27 xhn27 vdd vbsyn gsyn
X_ihx_19_27 a_xp19 a_xn19 wp_ih_19_27 wn_ih_19_27 xhp27 xhn27 vdd vbsyn gsyn
X_ihx_20_27 a_xp20 a_xn20 wp_ih_20_27 wn_ih_20_27 xhp27 xhn27 vdd vbsyn gsyn
X_ihx_21_27 a_xp21 a_xn21 wp_ih_21_27 wn_ih_21_27 xhp27 xhn27 vdd vbsyn gsyn
X_ihx_22_27 a_xp22 a_xn22 wp_ih_22_27 wn_ih_22_27 xhp27 xhn27 vdd vbsyn gsyn
X_ihx_23_27 a_xp23 a_xn23 wp_ih_23_27 wn_ih_23_27 xhp27 xhn27 vdd vbsyn gsyn
X_ihx_24_27 a_xp24 a_xn24 wp_ih_24_27 wn_ih_24_27 xhp27 xhn27 vdd vbsyn gsyn
X_ihx_25_27 a_xp25 a_xn25 wp_ih_25_27 wn_ih_25_27 xhp27 xhn27 vdd vbsyn gsyn
X_ihx_26_27 a_xp26 a_xn26 wp_ih_26_27 wn_ih_26_27 xhp27 xhn27 vdd vbsyn gsyn
X_ihx_27_27 a_xp27 a_xn27 wp_ih_27_27 wn_ih_27_27 xhp27 xhn27 vdd vbsyn gsyn
X_ihx_28_27 a_xp28 a_xn28 wp_ih_28_27 wn_ih_28_27 xhp27 xhn27 vdd vbsyn gsyn
X_ihx_29_27 a_xp29 a_xn29 wp_ih_29_27 wn_ih_29_27 xhp27 xhn27 vdd vbsyn gsyn
X_ihx_30_27 a_xp30 a_xn30 wp_ih_30_27 wn_ih_30_27 xhp27 xhn27 vdd vbsyn gsyn
X_ihx_31_27 a_xp31 a_xn31 wp_ih_31_27 wn_ih_31_27 xhp27 xhn27 vdd vbsyn gsyn
X_ihx_32_27 a_xp32 a_xn32 wp_ih_32_27 wn_ih_32_27 xhp27 xhn27 vdd vbsyn gsyn
X_ihx_33_27 a_xp33 a_xn33 wp_ih_33_27 wn_ih_33_27 xhp27 xhn27 vdd vbsyn gsyn
X_ihx_34_27 a_xp34 a_xn34 wp_ih_34_27 wn_ih_34_27 xhp27 xhn27 vdd vbsyn gsyn
X_ihx_35_27 a_xp35 a_xn35 wp_ih_35_27 wn_ih_35_27 xhp27 xhn27 vdd vbsyn gsyn
X_ihx_36_27 a_xp36 a_xn36 wp_ih_36_27 wn_ih_36_27 xhp27 xhn27 vdd vbsyn gsyn
X_ihx_37_27 a_xp37 a_xn37 wp_ih_37_27 wn_ih_37_27 xhp27 xhn27 vdd vbsyn gsyn
X_ihx_38_27 a_xp38 a_xn38 wp_ih_38_27 wn_ih_38_27 xhp27 xhn27 vdd vbsyn gsyn
X_ihx_39_27 a_xp39 a_xn39 wp_ih_39_27 wn_ih_39_27 xhp27 xhn27 vdd vbsyn gsyn
X_ihx_40_27 a_xp40 a_xn40 wp_ih_40_27 wn_ih_40_27 xhp27 xhn27 vdd vbsyn gsyn
X_ihx_41_27 a_xp41 a_xn41 wp_ih_41_27 wn_ih_41_27 xhp27 xhn27 vdd vbsyn gsyn
X_ihx_42_27 a_xp42 a_xn42 wp_ih_42_27 wn_ih_42_27 xhp27 xhn27 vdd vbsyn gsyn
X_ihx_43_27 a_xp43 a_xn43 wp_ih_43_27 wn_ih_43_27 xhp27 xhn27 vdd vbsyn gsyn
X_ihx_44_27 a_xp44 a_xn44 wp_ih_44_27 wn_ih_44_27 xhp27 xhn27 vdd vbsyn gsyn
X_ihx_45_27 a_xp45 a_xn45 wp_ih_45_27 wn_ih_45_27 xhp27 xhn27 vdd vbsyn gsyn
X_ihx_46_27 a_xp46 a_xn46 wp_ih_46_27 wn_ih_46_27 xhp27 xhn27 vdd vbsyn gsyn
X_ihx_47_27 a_xp47 a_xn47 wp_ih_47_27 wn_ih_47_27 xhp27 xhn27 vdd vbsyn gsyn
X_ihx_48_27 a_xp48 a_xn48 wp_ih_48_27 wn_ih_48_27 xhp27 xhn27 vdd vbsyn gsyn
X_ihx_49_27 a_xp49 a_xn49 wp_ih_49_27 wn_ih_49_27 xhp27 xhn27 vdd vbsyn gsyn
X_ihx_50_27 a_xp50 a_xn50 wp_ih_50_27 wn_ih_50_27 xhp27 xhn27 vdd vbsyn gsyn
X_ihx_51_27 a_xp51 a_xn51 wp_ih_51_27 wn_ih_51_27 xhp27 xhn27 vdd vbsyn gsyn
X_ihx_52_27 a_xp52 a_xn52 wp_ih_52_27 wn_ih_52_27 xhp27 xhn27 vdd vbsyn gsyn
X_ihx_53_27 a_xp53 a_xn53 wp_ih_53_27 wn_ih_53_27 xhp27 xhn27 vdd vbsyn gsyn
X_ihx_54_27 a_xp54 a_xn54 wp_ih_54_27 wn_ih_54_27 xhp27 xhn27 vdd vbsyn gsyn
X_ihx_55_27 a_xp55 a_xn55 wp_ih_55_27 wn_ih_55_27 xhp27 xhn27 vdd vbsyn gsyn
X_ihx_56_27 a_xp56 a_xn56 wp_ih_56_27 wn_ih_56_27 xhp27 xhn27 vdd vbsyn gsyn
X_ihx_57_27 a_xp57 a_xn57 wp_ih_57_27 wn_ih_57_27 xhp27 xhn27 vdd vbsyn gsyn
X_ihx_58_27 a_xp58 a_xn58 wp_ih_58_27 wn_ih_58_27 xhp27 xhn27 vdd vbsyn gsyn
X_ihx_59_27 a_xp59 a_xn59 wp_ih_59_27 wn_ih_59_27 xhp27 xhn27 vdd vbsyn gsyn
X_ihx_60_27 a_xp60 a_xn60 wp_ih_60_27 wn_ih_60_27 xhp27 xhn27 vdd vbsyn gsyn
X_ihx_61_27 a_xp61 a_xn61 wp_ih_61_27 wn_ih_61_27 xhp27 xhn27 vdd vbsyn gsyn
X_ihx_62_27 a_xp62 a_xn62 wp_ih_62_27 wn_ih_62_27 xhp27 xhn27 vdd vbsyn gsyn
X_ihx_63_27 a_xp63 a_xn63 wp_ih_63_27 wn_ih_63_27 xhp27 xhn27 vdd vbsyn gsyn
Xn27 xhp27 xhn27 ahp27 ahn27 vdd vbneu dneuron
Xcm_xh28 xhp28 xhn28 vdd cmld
Rnd_xh28 xhp28 xhn28 20k
X_ihx_0_28 a_xp0 a_xn0 wp_ih_0_28 wn_ih_0_28 xhp28 xhn28 vdd vbsyn gsyn
X_ihx_1_28 a_xp1 a_xn1 wp_ih_1_28 wn_ih_1_28 xhp28 xhn28 vdd vbsyn gsyn
X_ihx_2_28 a_xp2 a_xn2 wp_ih_2_28 wn_ih_2_28 xhp28 xhn28 vdd vbsyn gsyn
X_ihx_3_28 a_xp3 a_xn3 wp_ih_3_28 wn_ih_3_28 xhp28 xhn28 vdd vbsyn gsyn
X_ihx_4_28 a_xp4 a_xn4 wp_ih_4_28 wn_ih_4_28 xhp28 xhn28 vdd vbsyn gsyn
X_ihx_5_28 a_xp5 a_xn5 wp_ih_5_28 wn_ih_5_28 xhp28 xhn28 vdd vbsyn gsyn
X_ihx_6_28 a_xp6 a_xn6 wp_ih_6_28 wn_ih_6_28 xhp28 xhn28 vdd vbsyn gsyn
X_ihx_7_28 a_xp7 a_xn7 wp_ih_7_28 wn_ih_7_28 xhp28 xhn28 vdd vbsyn gsyn
X_ihx_8_28 a_xp8 a_xn8 wp_ih_8_28 wn_ih_8_28 xhp28 xhn28 vdd vbsyn gsyn
X_ihx_9_28 a_xp9 a_xn9 wp_ih_9_28 wn_ih_9_28 xhp28 xhn28 vdd vbsyn gsyn
X_ihx_10_28 a_xp10 a_xn10 wp_ih_10_28 wn_ih_10_28 xhp28 xhn28 vdd vbsyn gsyn
X_ihx_11_28 a_xp11 a_xn11 wp_ih_11_28 wn_ih_11_28 xhp28 xhn28 vdd vbsyn gsyn
X_ihx_12_28 a_xp12 a_xn12 wp_ih_12_28 wn_ih_12_28 xhp28 xhn28 vdd vbsyn gsyn
X_ihx_13_28 a_xp13 a_xn13 wp_ih_13_28 wn_ih_13_28 xhp28 xhn28 vdd vbsyn gsyn
X_ihx_14_28 a_xp14 a_xn14 wp_ih_14_28 wn_ih_14_28 xhp28 xhn28 vdd vbsyn gsyn
X_ihx_15_28 a_xp15 a_xn15 wp_ih_15_28 wn_ih_15_28 xhp28 xhn28 vdd vbsyn gsyn
X_ihx_16_28 a_xp16 a_xn16 wp_ih_16_28 wn_ih_16_28 xhp28 xhn28 vdd vbsyn gsyn
X_ihx_17_28 a_xp17 a_xn17 wp_ih_17_28 wn_ih_17_28 xhp28 xhn28 vdd vbsyn gsyn
X_ihx_18_28 a_xp18 a_xn18 wp_ih_18_28 wn_ih_18_28 xhp28 xhn28 vdd vbsyn gsyn
X_ihx_19_28 a_xp19 a_xn19 wp_ih_19_28 wn_ih_19_28 xhp28 xhn28 vdd vbsyn gsyn
X_ihx_20_28 a_xp20 a_xn20 wp_ih_20_28 wn_ih_20_28 xhp28 xhn28 vdd vbsyn gsyn
X_ihx_21_28 a_xp21 a_xn21 wp_ih_21_28 wn_ih_21_28 xhp28 xhn28 vdd vbsyn gsyn
X_ihx_22_28 a_xp22 a_xn22 wp_ih_22_28 wn_ih_22_28 xhp28 xhn28 vdd vbsyn gsyn
X_ihx_23_28 a_xp23 a_xn23 wp_ih_23_28 wn_ih_23_28 xhp28 xhn28 vdd vbsyn gsyn
X_ihx_24_28 a_xp24 a_xn24 wp_ih_24_28 wn_ih_24_28 xhp28 xhn28 vdd vbsyn gsyn
X_ihx_25_28 a_xp25 a_xn25 wp_ih_25_28 wn_ih_25_28 xhp28 xhn28 vdd vbsyn gsyn
X_ihx_26_28 a_xp26 a_xn26 wp_ih_26_28 wn_ih_26_28 xhp28 xhn28 vdd vbsyn gsyn
X_ihx_27_28 a_xp27 a_xn27 wp_ih_27_28 wn_ih_27_28 xhp28 xhn28 vdd vbsyn gsyn
X_ihx_28_28 a_xp28 a_xn28 wp_ih_28_28 wn_ih_28_28 xhp28 xhn28 vdd vbsyn gsyn
X_ihx_29_28 a_xp29 a_xn29 wp_ih_29_28 wn_ih_29_28 xhp28 xhn28 vdd vbsyn gsyn
X_ihx_30_28 a_xp30 a_xn30 wp_ih_30_28 wn_ih_30_28 xhp28 xhn28 vdd vbsyn gsyn
X_ihx_31_28 a_xp31 a_xn31 wp_ih_31_28 wn_ih_31_28 xhp28 xhn28 vdd vbsyn gsyn
X_ihx_32_28 a_xp32 a_xn32 wp_ih_32_28 wn_ih_32_28 xhp28 xhn28 vdd vbsyn gsyn
X_ihx_33_28 a_xp33 a_xn33 wp_ih_33_28 wn_ih_33_28 xhp28 xhn28 vdd vbsyn gsyn
X_ihx_34_28 a_xp34 a_xn34 wp_ih_34_28 wn_ih_34_28 xhp28 xhn28 vdd vbsyn gsyn
X_ihx_35_28 a_xp35 a_xn35 wp_ih_35_28 wn_ih_35_28 xhp28 xhn28 vdd vbsyn gsyn
X_ihx_36_28 a_xp36 a_xn36 wp_ih_36_28 wn_ih_36_28 xhp28 xhn28 vdd vbsyn gsyn
X_ihx_37_28 a_xp37 a_xn37 wp_ih_37_28 wn_ih_37_28 xhp28 xhn28 vdd vbsyn gsyn
X_ihx_38_28 a_xp38 a_xn38 wp_ih_38_28 wn_ih_38_28 xhp28 xhn28 vdd vbsyn gsyn
X_ihx_39_28 a_xp39 a_xn39 wp_ih_39_28 wn_ih_39_28 xhp28 xhn28 vdd vbsyn gsyn
X_ihx_40_28 a_xp40 a_xn40 wp_ih_40_28 wn_ih_40_28 xhp28 xhn28 vdd vbsyn gsyn
X_ihx_41_28 a_xp41 a_xn41 wp_ih_41_28 wn_ih_41_28 xhp28 xhn28 vdd vbsyn gsyn
X_ihx_42_28 a_xp42 a_xn42 wp_ih_42_28 wn_ih_42_28 xhp28 xhn28 vdd vbsyn gsyn
X_ihx_43_28 a_xp43 a_xn43 wp_ih_43_28 wn_ih_43_28 xhp28 xhn28 vdd vbsyn gsyn
X_ihx_44_28 a_xp44 a_xn44 wp_ih_44_28 wn_ih_44_28 xhp28 xhn28 vdd vbsyn gsyn
X_ihx_45_28 a_xp45 a_xn45 wp_ih_45_28 wn_ih_45_28 xhp28 xhn28 vdd vbsyn gsyn
X_ihx_46_28 a_xp46 a_xn46 wp_ih_46_28 wn_ih_46_28 xhp28 xhn28 vdd vbsyn gsyn
X_ihx_47_28 a_xp47 a_xn47 wp_ih_47_28 wn_ih_47_28 xhp28 xhn28 vdd vbsyn gsyn
X_ihx_48_28 a_xp48 a_xn48 wp_ih_48_28 wn_ih_48_28 xhp28 xhn28 vdd vbsyn gsyn
X_ihx_49_28 a_xp49 a_xn49 wp_ih_49_28 wn_ih_49_28 xhp28 xhn28 vdd vbsyn gsyn
X_ihx_50_28 a_xp50 a_xn50 wp_ih_50_28 wn_ih_50_28 xhp28 xhn28 vdd vbsyn gsyn
X_ihx_51_28 a_xp51 a_xn51 wp_ih_51_28 wn_ih_51_28 xhp28 xhn28 vdd vbsyn gsyn
X_ihx_52_28 a_xp52 a_xn52 wp_ih_52_28 wn_ih_52_28 xhp28 xhn28 vdd vbsyn gsyn
X_ihx_53_28 a_xp53 a_xn53 wp_ih_53_28 wn_ih_53_28 xhp28 xhn28 vdd vbsyn gsyn
X_ihx_54_28 a_xp54 a_xn54 wp_ih_54_28 wn_ih_54_28 xhp28 xhn28 vdd vbsyn gsyn
X_ihx_55_28 a_xp55 a_xn55 wp_ih_55_28 wn_ih_55_28 xhp28 xhn28 vdd vbsyn gsyn
X_ihx_56_28 a_xp56 a_xn56 wp_ih_56_28 wn_ih_56_28 xhp28 xhn28 vdd vbsyn gsyn
X_ihx_57_28 a_xp57 a_xn57 wp_ih_57_28 wn_ih_57_28 xhp28 xhn28 vdd vbsyn gsyn
X_ihx_58_28 a_xp58 a_xn58 wp_ih_58_28 wn_ih_58_28 xhp28 xhn28 vdd vbsyn gsyn
X_ihx_59_28 a_xp59 a_xn59 wp_ih_59_28 wn_ih_59_28 xhp28 xhn28 vdd vbsyn gsyn
X_ihx_60_28 a_xp60 a_xn60 wp_ih_60_28 wn_ih_60_28 xhp28 xhn28 vdd vbsyn gsyn
X_ihx_61_28 a_xp61 a_xn61 wp_ih_61_28 wn_ih_61_28 xhp28 xhn28 vdd vbsyn gsyn
X_ihx_62_28 a_xp62 a_xn62 wp_ih_62_28 wn_ih_62_28 xhp28 xhn28 vdd vbsyn gsyn
X_ihx_63_28 a_xp63 a_xn63 wp_ih_63_28 wn_ih_63_28 xhp28 xhn28 vdd vbsyn gsyn
Xn28 xhp28 xhn28 ahp28 ahn28 vdd vbneu dneuron
Xcm_xh29 xhp29 xhn29 vdd cmld
Rnd_xh29 xhp29 xhn29 20k
X_ihx_0_29 a_xp0 a_xn0 wp_ih_0_29 wn_ih_0_29 xhp29 xhn29 vdd vbsyn gsyn
X_ihx_1_29 a_xp1 a_xn1 wp_ih_1_29 wn_ih_1_29 xhp29 xhn29 vdd vbsyn gsyn
X_ihx_2_29 a_xp2 a_xn2 wp_ih_2_29 wn_ih_2_29 xhp29 xhn29 vdd vbsyn gsyn
X_ihx_3_29 a_xp3 a_xn3 wp_ih_3_29 wn_ih_3_29 xhp29 xhn29 vdd vbsyn gsyn
X_ihx_4_29 a_xp4 a_xn4 wp_ih_4_29 wn_ih_4_29 xhp29 xhn29 vdd vbsyn gsyn
X_ihx_5_29 a_xp5 a_xn5 wp_ih_5_29 wn_ih_5_29 xhp29 xhn29 vdd vbsyn gsyn
X_ihx_6_29 a_xp6 a_xn6 wp_ih_6_29 wn_ih_6_29 xhp29 xhn29 vdd vbsyn gsyn
X_ihx_7_29 a_xp7 a_xn7 wp_ih_7_29 wn_ih_7_29 xhp29 xhn29 vdd vbsyn gsyn
X_ihx_8_29 a_xp8 a_xn8 wp_ih_8_29 wn_ih_8_29 xhp29 xhn29 vdd vbsyn gsyn
X_ihx_9_29 a_xp9 a_xn9 wp_ih_9_29 wn_ih_9_29 xhp29 xhn29 vdd vbsyn gsyn
X_ihx_10_29 a_xp10 a_xn10 wp_ih_10_29 wn_ih_10_29 xhp29 xhn29 vdd vbsyn gsyn
X_ihx_11_29 a_xp11 a_xn11 wp_ih_11_29 wn_ih_11_29 xhp29 xhn29 vdd vbsyn gsyn
X_ihx_12_29 a_xp12 a_xn12 wp_ih_12_29 wn_ih_12_29 xhp29 xhn29 vdd vbsyn gsyn
X_ihx_13_29 a_xp13 a_xn13 wp_ih_13_29 wn_ih_13_29 xhp29 xhn29 vdd vbsyn gsyn
X_ihx_14_29 a_xp14 a_xn14 wp_ih_14_29 wn_ih_14_29 xhp29 xhn29 vdd vbsyn gsyn
X_ihx_15_29 a_xp15 a_xn15 wp_ih_15_29 wn_ih_15_29 xhp29 xhn29 vdd vbsyn gsyn
X_ihx_16_29 a_xp16 a_xn16 wp_ih_16_29 wn_ih_16_29 xhp29 xhn29 vdd vbsyn gsyn
X_ihx_17_29 a_xp17 a_xn17 wp_ih_17_29 wn_ih_17_29 xhp29 xhn29 vdd vbsyn gsyn
X_ihx_18_29 a_xp18 a_xn18 wp_ih_18_29 wn_ih_18_29 xhp29 xhn29 vdd vbsyn gsyn
X_ihx_19_29 a_xp19 a_xn19 wp_ih_19_29 wn_ih_19_29 xhp29 xhn29 vdd vbsyn gsyn
X_ihx_20_29 a_xp20 a_xn20 wp_ih_20_29 wn_ih_20_29 xhp29 xhn29 vdd vbsyn gsyn
X_ihx_21_29 a_xp21 a_xn21 wp_ih_21_29 wn_ih_21_29 xhp29 xhn29 vdd vbsyn gsyn
X_ihx_22_29 a_xp22 a_xn22 wp_ih_22_29 wn_ih_22_29 xhp29 xhn29 vdd vbsyn gsyn
X_ihx_23_29 a_xp23 a_xn23 wp_ih_23_29 wn_ih_23_29 xhp29 xhn29 vdd vbsyn gsyn
X_ihx_24_29 a_xp24 a_xn24 wp_ih_24_29 wn_ih_24_29 xhp29 xhn29 vdd vbsyn gsyn
X_ihx_25_29 a_xp25 a_xn25 wp_ih_25_29 wn_ih_25_29 xhp29 xhn29 vdd vbsyn gsyn
X_ihx_26_29 a_xp26 a_xn26 wp_ih_26_29 wn_ih_26_29 xhp29 xhn29 vdd vbsyn gsyn
X_ihx_27_29 a_xp27 a_xn27 wp_ih_27_29 wn_ih_27_29 xhp29 xhn29 vdd vbsyn gsyn
X_ihx_28_29 a_xp28 a_xn28 wp_ih_28_29 wn_ih_28_29 xhp29 xhn29 vdd vbsyn gsyn
X_ihx_29_29 a_xp29 a_xn29 wp_ih_29_29 wn_ih_29_29 xhp29 xhn29 vdd vbsyn gsyn
X_ihx_30_29 a_xp30 a_xn30 wp_ih_30_29 wn_ih_30_29 xhp29 xhn29 vdd vbsyn gsyn
X_ihx_31_29 a_xp31 a_xn31 wp_ih_31_29 wn_ih_31_29 xhp29 xhn29 vdd vbsyn gsyn
X_ihx_32_29 a_xp32 a_xn32 wp_ih_32_29 wn_ih_32_29 xhp29 xhn29 vdd vbsyn gsyn
X_ihx_33_29 a_xp33 a_xn33 wp_ih_33_29 wn_ih_33_29 xhp29 xhn29 vdd vbsyn gsyn
X_ihx_34_29 a_xp34 a_xn34 wp_ih_34_29 wn_ih_34_29 xhp29 xhn29 vdd vbsyn gsyn
X_ihx_35_29 a_xp35 a_xn35 wp_ih_35_29 wn_ih_35_29 xhp29 xhn29 vdd vbsyn gsyn
X_ihx_36_29 a_xp36 a_xn36 wp_ih_36_29 wn_ih_36_29 xhp29 xhn29 vdd vbsyn gsyn
X_ihx_37_29 a_xp37 a_xn37 wp_ih_37_29 wn_ih_37_29 xhp29 xhn29 vdd vbsyn gsyn
X_ihx_38_29 a_xp38 a_xn38 wp_ih_38_29 wn_ih_38_29 xhp29 xhn29 vdd vbsyn gsyn
X_ihx_39_29 a_xp39 a_xn39 wp_ih_39_29 wn_ih_39_29 xhp29 xhn29 vdd vbsyn gsyn
X_ihx_40_29 a_xp40 a_xn40 wp_ih_40_29 wn_ih_40_29 xhp29 xhn29 vdd vbsyn gsyn
X_ihx_41_29 a_xp41 a_xn41 wp_ih_41_29 wn_ih_41_29 xhp29 xhn29 vdd vbsyn gsyn
X_ihx_42_29 a_xp42 a_xn42 wp_ih_42_29 wn_ih_42_29 xhp29 xhn29 vdd vbsyn gsyn
X_ihx_43_29 a_xp43 a_xn43 wp_ih_43_29 wn_ih_43_29 xhp29 xhn29 vdd vbsyn gsyn
X_ihx_44_29 a_xp44 a_xn44 wp_ih_44_29 wn_ih_44_29 xhp29 xhn29 vdd vbsyn gsyn
X_ihx_45_29 a_xp45 a_xn45 wp_ih_45_29 wn_ih_45_29 xhp29 xhn29 vdd vbsyn gsyn
X_ihx_46_29 a_xp46 a_xn46 wp_ih_46_29 wn_ih_46_29 xhp29 xhn29 vdd vbsyn gsyn
X_ihx_47_29 a_xp47 a_xn47 wp_ih_47_29 wn_ih_47_29 xhp29 xhn29 vdd vbsyn gsyn
X_ihx_48_29 a_xp48 a_xn48 wp_ih_48_29 wn_ih_48_29 xhp29 xhn29 vdd vbsyn gsyn
X_ihx_49_29 a_xp49 a_xn49 wp_ih_49_29 wn_ih_49_29 xhp29 xhn29 vdd vbsyn gsyn
X_ihx_50_29 a_xp50 a_xn50 wp_ih_50_29 wn_ih_50_29 xhp29 xhn29 vdd vbsyn gsyn
X_ihx_51_29 a_xp51 a_xn51 wp_ih_51_29 wn_ih_51_29 xhp29 xhn29 vdd vbsyn gsyn
X_ihx_52_29 a_xp52 a_xn52 wp_ih_52_29 wn_ih_52_29 xhp29 xhn29 vdd vbsyn gsyn
X_ihx_53_29 a_xp53 a_xn53 wp_ih_53_29 wn_ih_53_29 xhp29 xhn29 vdd vbsyn gsyn
X_ihx_54_29 a_xp54 a_xn54 wp_ih_54_29 wn_ih_54_29 xhp29 xhn29 vdd vbsyn gsyn
X_ihx_55_29 a_xp55 a_xn55 wp_ih_55_29 wn_ih_55_29 xhp29 xhn29 vdd vbsyn gsyn
X_ihx_56_29 a_xp56 a_xn56 wp_ih_56_29 wn_ih_56_29 xhp29 xhn29 vdd vbsyn gsyn
X_ihx_57_29 a_xp57 a_xn57 wp_ih_57_29 wn_ih_57_29 xhp29 xhn29 vdd vbsyn gsyn
X_ihx_58_29 a_xp58 a_xn58 wp_ih_58_29 wn_ih_58_29 xhp29 xhn29 vdd vbsyn gsyn
X_ihx_59_29 a_xp59 a_xn59 wp_ih_59_29 wn_ih_59_29 xhp29 xhn29 vdd vbsyn gsyn
X_ihx_60_29 a_xp60 a_xn60 wp_ih_60_29 wn_ih_60_29 xhp29 xhn29 vdd vbsyn gsyn
X_ihx_61_29 a_xp61 a_xn61 wp_ih_61_29 wn_ih_61_29 xhp29 xhn29 vdd vbsyn gsyn
X_ihx_62_29 a_xp62 a_xn62 wp_ih_62_29 wn_ih_62_29 xhp29 xhn29 vdd vbsyn gsyn
X_ihx_63_29 a_xp63 a_xn63 wp_ih_63_29 wn_ih_63_29 xhp29 xhn29 vdd vbsyn gsyn
Xn29 xhp29 xhn29 ahp29 ahn29 vdd vbneu dneuron
Xcm_xh30 xhp30 xhn30 vdd cmld
Rnd_xh30 xhp30 xhn30 20k
X_ihx_0_30 a_xp0 a_xn0 wp_ih_0_30 wn_ih_0_30 xhp30 xhn30 vdd vbsyn gsyn
X_ihx_1_30 a_xp1 a_xn1 wp_ih_1_30 wn_ih_1_30 xhp30 xhn30 vdd vbsyn gsyn
X_ihx_2_30 a_xp2 a_xn2 wp_ih_2_30 wn_ih_2_30 xhp30 xhn30 vdd vbsyn gsyn
X_ihx_3_30 a_xp3 a_xn3 wp_ih_3_30 wn_ih_3_30 xhp30 xhn30 vdd vbsyn gsyn
X_ihx_4_30 a_xp4 a_xn4 wp_ih_4_30 wn_ih_4_30 xhp30 xhn30 vdd vbsyn gsyn
X_ihx_5_30 a_xp5 a_xn5 wp_ih_5_30 wn_ih_5_30 xhp30 xhn30 vdd vbsyn gsyn
X_ihx_6_30 a_xp6 a_xn6 wp_ih_6_30 wn_ih_6_30 xhp30 xhn30 vdd vbsyn gsyn
X_ihx_7_30 a_xp7 a_xn7 wp_ih_7_30 wn_ih_7_30 xhp30 xhn30 vdd vbsyn gsyn
X_ihx_8_30 a_xp8 a_xn8 wp_ih_8_30 wn_ih_8_30 xhp30 xhn30 vdd vbsyn gsyn
X_ihx_9_30 a_xp9 a_xn9 wp_ih_9_30 wn_ih_9_30 xhp30 xhn30 vdd vbsyn gsyn
X_ihx_10_30 a_xp10 a_xn10 wp_ih_10_30 wn_ih_10_30 xhp30 xhn30 vdd vbsyn gsyn
X_ihx_11_30 a_xp11 a_xn11 wp_ih_11_30 wn_ih_11_30 xhp30 xhn30 vdd vbsyn gsyn
X_ihx_12_30 a_xp12 a_xn12 wp_ih_12_30 wn_ih_12_30 xhp30 xhn30 vdd vbsyn gsyn
X_ihx_13_30 a_xp13 a_xn13 wp_ih_13_30 wn_ih_13_30 xhp30 xhn30 vdd vbsyn gsyn
X_ihx_14_30 a_xp14 a_xn14 wp_ih_14_30 wn_ih_14_30 xhp30 xhn30 vdd vbsyn gsyn
X_ihx_15_30 a_xp15 a_xn15 wp_ih_15_30 wn_ih_15_30 xhp30 xhn30 vdd vbsyn gsyn
X_ihx_16_30 a_xp16 a_xn16 wp_ih_16_30 wn_ih_16_30 xhp30 xhn30 vdd vbsyn gsyn
X_ihx_17_30 a_xp17 a_xn17 wp_ih_17_30 wn_ih_17_30 xhp30 xhn30 vdd vbsyn gsyn
X_ihx_18_30 a_xp18 a_xn18 wp_ih_18_30 wn_ih_18_30 xhp30 xhn30 vdd vbsyn gsyn
X_ihx_19_30 a_xp19 a_xn19 wp_ih_19_30 wn_ih_19_30 xhp30 xhn30 vdd vbsyn gsyn
X_ihx_20_30 a_xp20 a_xn20 wp_ih_20_30 wn_ih_20_30 xhp30 xhn30 vdd vbsyn gsyn
X_ihx_21_30 a_xp21 a_xn21 wp_ih_21_30 wn_ih_21_30 xhp30 xhn30 vdd vbsyn gsyn
X_ihx_22_30 a_xp22 a_xn22 wp_ih_22_30 wn_ih_22_30 xhp30 xhn30 vdd vbsyn gsyn
X_ihx_23_30 a_xp23 a_xn23 wp_ih_23_30 wn_ih_23_30 xhp30 xhn30 vdd vbsyn gsyn
X_ihx_24_30 a_xp24 a_xn24 wp_ih_24_30 wn_ih_24_30 xhp30 xhn30 vdd vbsyn gsyn
X_ihx_25_30 a_xp25 a_xn25 wp_ih_25_30 wn_ih_25_30 xhp30 xhn30 vdd vbsyn gsyn
X_ihx_26_30 a_xp26 a_xn26 wp_ih_26_30 wn_ih_26_30 xhp30 xhn30 vdd vbsyn gsyn
X_ihx_27_30 a_xp27 a_xn27 wp_ih_27_30 wn_ih_27_30 xhp30 xhn30 vdd vbsyn gsyn
X_ihx_28_30 a_xp28 a_xn28 wp_ih_28_30 wn_ih_28_30 xhp30 xhn30 vdd vbsyn gsyn
X_ihx_29_30 a_xp29 a_xn29 wp_ih_29_30 wn_ih_29_30 xhp30 xhn30 vdd vbsyn gsyn
X_ihx_30_30 a_xp30 a_xn30 wp_ih_30_30 wn_ih_30_30 xhp30 xhn30 vdd vbsyn gsyn
X_ihx_31_30 a_xp31 a_xn31 wp_ih_31_30 wn_ih_31_30 xhp30 xhn30 vdd vbsyn gsyn
X_ihx_32_30 a_xp32 a_xn32 wp_ih_32_30 wn_ih_32_30 xhp30 xhn30 vdd vbsyn gsyn
X_ihx_33_30 a_xp33 a_xn33 wp_ih_33_30 wn_ih_33_30 xhp30 xhn30 vdd vbsyn gsyn
X_ihx_34_30 a_xp34 a_xn34 wp_ih_34_30 wn_ih_34_30 xhp30 xhn30 vdd vbsyn gsyn
X_ihx_35_30 a_xp35 a_xn35 wp_ih_35_30 wn_ih_35_30 xhp30 xhn30 vdd vbsyn gsyn
X_ihx_36_30 a_xp36 a_xn36 wp_ih_36_30 wn_ih_36_30 xhp30 xhn30 vdd vbsyn gsyn
X_ihx_37_30 a_xp37 a_xn37 wp_ih_37_30 wn_ih_37_30 xhp30 xhn30 vdd vbsyn gsyn
X_ihx_38_30 a_xp38 a_xn38 wp_ih_38_30 wn_ih_38_30 xhp30 xhn30 vdd vbsyn gsyn
X_ihx_39_30 a_xp39 a_xn39 wp_ih_39_30 wn_ih_39_30 xhp30 xhn30 vdd vbsyn gsyn
X_ihx_40_30 a_xp40 a_xn40 wp_ih_40_30 wn_ih_40_30 xhp30 xhn30 vdd vbsyn gsyn
X_ihx_41_30 a_xp41 a_xn41 wp_ih_41_30 wn_ih_41_30 xhp30 xhn30 vdd vbsyn gsyn
X_ihx_42_30 a_xp42 a_xn42 wp_ih_42_30 wn_ih_42_30 xhp30 xhn30 vdd vbsyn gsyn
X_ihx_43_30 a_xp43 a_xn43 wp_ih_43_30 wn_ih_43_30 xhp30 xhn30 vdd vbsyn gsyn
X_ihx_44_30 a_xp44 a_xn44 wp_ih_44_30 wn_ih_44_30 xhp30 xhn30 vdd vbsyn gsyn
X_ihx_45_30 a_xp45 a_xn45 wp_ih_45_30 wn_ih_45_30 xhp30 xhn30 vdd vbsyn gsyn
X_ihx_46_30 a_xp46 a_xn46 wp_ih_46_30 wn_ih_46_30 xhp30 xhn30 vdd vbsyn gsyn
X_ihx_47_30 a_xp47 a_xn47 wp_ih_47_30 wn_ih_47_30 xhp30 xhn30 vdd vbsyn gsyn
X_ihx_48_30 a_xp48 a_xn48 wp_ih_48_30 wn_ih_48_30 xhp30 xhn30 vdd vbsyn gsyn
X_ihx_49_30 a_xp49 a_xn49 wp_ih_49_30 wn_ih_49_30 xhp30 xhn30 vdd vbsyn gsyn
X_ihx_50_30 a_xp50 a_xn50 wp_ih_50_30 wn_ih_50_30 xhp30 xhn30 vdd vbsyn gsyn
X_ihx_51_30 a_xp51 a_xn51 wp_ih_51_30 wn_ih_51_30 xhp30 xhn30 vdd vbsyn gsyn
X_ihx_52_30 a_xp52 a_xn52 wp_ih_52_30 wn_ih_52_30 xhp30 xhn30 vdd vbsyn gsyn
X_ihx_53_30 a_xp53 a_xn53 wp_ih_53_30 wn_ih_53_30 xhp30 xhn30 vdd vbsyn gsyn
X_ihx_54_30 a_xp54 a_xn54 wp_ih_54_30 wn_ih_54_30 xhp30 xhn30 vdd vbsyn gsyn
X_ihx_55_30 a_xp55 a_xn55 wp_ih_55_30 wn_ih_55_30 xhp30 xhn30 vdd vbsyn gsyn
X_ihx_56_30 a_xp56 a_xn56 wp_ih_56_30 wn_ih_56_30 xhp30 xhn30 vdd vbsyn gsyn
X_ihx_57_30 a_xp57 a_xn57 wp_ih_57_30 wn_ih_57_30 xhp30 xhn30 vdd vbsyn gsyn
X_ihx_58_30 a_xp58 a_xn58 wp_ih_58_30 wn_ih_58_30 xhp30 xhn30 vdd vbsyn gsyn
X_ihx_59_30 a_xp59 a_xn59 wp_ih_59_30 wn_ih_59_30 xhp30 xhn30 vdd vbsyn gsyn
X_ihx_60_30 a_xp60 a_xn60 wp_ih_60_30 wn_ih_60_30 xhp30 xhn30 vdd vbsyn gsyn
X_ihx_61_30 a_xp61 a_xn61 wp_ih_61_30 wn_ih_61_30 xhp30 xhn30 vdd vbsyn gsyn
X_ihx_62_30 a_xp62 a_xn62 wp_ih_62_30 wn_ih_62_30 xhp30 xhn30 vdd vbsyn gsyn
X_ihx_63_30 a_xp63 a_xn63 wp_ih_63_30 wn_ih_63_30 xhp30 xhn30 vdd vbsyn gsyn
Xn30 xhp30 xhn30 ahp30 ahn30 vdd vbneu dneuron
Xcm_xh31 xhp31 xhn31 vdd cmld
Rnd_xh31 xhp31 xhn31 20k
X_ihx_0_31 a_xp0 a_xn0 wp_ih_0_31 wn_ih_0_31 xhp31 xhn31 vdd vbsyn gsyn
X_ihx_1_31 a_xp1 a_xn1 wp_ih_1_31 wn_ih_1_31 xhp31 xhn31 vdd vbsyn gsyn
X_ihx_2_31 a_xp2 a_xn2 wp_ih_2_31 wn_ih_2_31 xhp31 xhn31 vdd vbsyn gsyn
X_ihx_3_31 a_xp3 a_xn3 wp_ih_3_31 wn_ih_3_31 xhp31 xhn31 vdd vbsyn gsyn
X_ihx_4_31 a_xp4 a_xn4 wp_ih_4_31 wn_ih_4_31 xhp31 xhn31 vdd vbsyn gsyn
X_ihx_5_31 a_xp5 a_xn5 wp_ih_5_31 wn_ih_5_31 xhp31 xhn31 vdd vbsyn gsyn
X_ihx_6_31 a_xp6 a_xn6 wp_ih_6_31 wn_ih_6_31 xhp31 xhn31 vdd vbsyn gsyn
X_ihx_7_31 a_xp7 a_xn7 wp_ih_7_31 wn_ih_7_31 xhp31 xhn31 vdd vbsyn gsyn
X_ihx_8_31 a_xp8 a_xn8 wp_ih_8_31 wn_ih_8_31 xhp31 xhn31 vdd vbsyn gsyn
X_ihx_9_31 a_xp9 a_xn9 wp_ih_9_31 wn_ih_9_31 xhp31 xhn31 vdd vbsyn gsyn
X_ihx_10_31 a_xp10 a_xn10 wp_ih_10_31 wn_ih_10_31 xhp31 xhn31 vdd vbsyn gsyn
X_ihx_11_31 a_xp11 a_xn11 wp_ih_11_31 wn_ih_11_31 xhp31 xhn31 vdd vbsyn gsyn
X_ihx_12_31 a_xp12 a_xn12 wp_ih_12_31 wn_ih_12_31 xhp31 xhn31 vdd vbsyn gsyn
X_ihx_13_31 a_xp13 a_xn13 wp_ih_13_31 wn_ih_13_31 xhp31 xhn31 vdd vbsyn gsyn
X_ihx_14_31 a_xp14 a_xn14 wp_ih_14_31 wn_ih_14_31 xhp31 xhn31 vdd vbsyn gsyn
X_ihx_15_31 a_xp15 a_xn15 wp_ih_15_31 wn_ih_15_31 xhp31 xhn31 vdd vbsyn gsyn
X_ihx_16_31 a_xp16 a_xn16 wp_ih_16_31 wn_ih_16_31 xhp31 xhn31 vdd vbsyn gsyn
X_ihx_17_31 a_xp17 a_xn17 wp_ih_17_31 wn_ih_17_31 xhp31 xhn31 vdd vbsyn gsyn
X_ihx_18_31 a_xp18 a_xn18 wp_ih_18_31 wn_ih_18_31 xhp31 xhn31 vdd vbsyn gsyn
X_ihx_19_31 a_xp19 a_xn19 wp_ih_19_31 wn_ih_19_31 xhp31 xhn31 vdd vbsyn gsyn
X_ihx_20_31 a_xp20 a_xn20 wp_ih_20_31 wn_ih_20_31 xhp31 xhn31 vdd vbsyn gsyn
X_ihx_21_31 a_xp21 a_xn21 wp_ih_21_31 wn_ih_21_31 xhp31 xhn31 vdd vbsyn gsyn
X_ihx_22_31 a_xp22 a_xn22 wp_ih_22_31 wn_ih_22_31 xhp31 xhn31 vdd vbsyn gsyn
X_ihx_23_31 a_xp23 a_xn23 wp_ih_23_31 wn_ih_23_31 xhp31 xhn31 vdd vbsyn gsyn
X_ihx_24_31 a_xp24 a_xn24 wp_ih_24_31 wn_ih_24_31 xhp31 xhn31 vdd vbsyn gsyn
X_ihx_25_31 a_xp25 a_xn25 wp_ih_25_31 wn_ih_25_31 xhp31 xhn31 vdd vbsyn gsyn
X_ihx_26_31 a_xp26 a_xn26 wp_ih_26_31 wn_ih_26_31 xhp31 xhn31 vdd vbsyn gsyn
X_ihx_27_31 a_xp27 a_xn27 wp_ih_27_31 wn_ih_27_31 xhp31 xhn31 vdd vbsyn gsyn
X_ihx_28_31 a_xp28 a_xn28 wp_ih_28_31 wn_ih_28_31 xhp31 xhn31 vdd vbsyn gsyn
X_ihx_29_31 a_xp29 a_xn29 wp_ih_29_31 wn_ih_29_31 xhp31 xhn31 vdd vbsyn gsyn
X_ihx_30_31 a_xp30 a_xn30 wp_ih_30_31 wn_ih_30_31 xhp31 xhn31 vdd vbsyn gsyn
X_ihx_31_31 a_xp31 a_xn31 wp_ih_31_31 wn_ih_31_31 xhp31 xhn31 vdd vbsyn gsyn
X_ihx_32_31 a_xp32 a_xn32 wp_ih_32_31 wn_ih_32_31 xhp31 xhn31 vdd vbsyn gsyn
X_ihx_33_31 a_xp33 a_xn33 wp_ih_33_31 wn_ih_33_31 xhp31 xhn31 vdd vbsyn gsyn
X_ihx_34_31 a_xp34 a_xn34 wp_ih_34_31 wn_ih_34_31 xhp31 xhn31 vdd vbsyn gsyn
X_ihx_35_31 a_xp35 a_xn35 wp_ih_35_31 wn_ih_35_31 xhp31 xhn31 vdd vbsyn gsyn
X_ihx_36_31 a_xp36 a_xn36 wp_ih_36_31 wn_ih_36_31 xhp31 xhn31 vdd vbsyn gsyn
X_ihx_37_31 a_xp37 a_xn37 wp_ih_37_31 wn_ih_37_31 xhp31 xhn31 vdd vbsyn gsyn
X_ihx_38_31 a_xp38 a_xn38 wp_ih_38_31 wn_ih_38_31 xhp31 xhn31 vdd vbsyn gsyn
X_ihx_39_31 a_xp39 a_xn39 wp_ih_39_31 wn_ih_39_31 xhp31 xhn31 vdd vbsyn gsyn
X_ihx_40_31 a_xp40 a_xn40 wp_ih_40_31 wn_ih_40_31 xhp31 xhn31 vdd vbsyn gsyn
X_ihx_41_31 a_xp41 a_xn41 wp_ih_41_31 wn_ih_41_31 xhp31 xhn31 vdd vbsyn gsyn
X_ihx_42_31 a_xp42 a_xn42 wp_ih_42_31 wn_ih_42_31 xhp31 xhn31 vdd vbsyn gsyn
X_ihx_43_31 a_xp43 a_xn43 wp_ih_43_31 wn_ih_43_31 xhp31 xhn31 vdd vbsyn gsyn
X_ihx_44_31 a_xp44 a_xn44 wp_ih_44_31 wn_ih_44_31 xhp31 xhn31 vdd vbsyn gsyn
X_ihx_45_31 a_xp45 a_xn45 wp_ih_45_31 wn_ih_45_31 xhp31 xhn31 vdd vbsyn gsyn
X_ihx_46_31 a_xp46 a_xn46 wp_ih_46_31 wn_ih_46_31 xhp31 xhn31 vdd vbsyn gsyn
X_ihx_47_31 a_xp47 a_xn47 wp_ih_47_31 wn_ih_47_31 xhp31 xhn31 vdd vbsyn gsyn
X_ihx_48_31 a_xp48 a_xn48 wp_ih_48_31 wn_ih_48_31 xhp31 xhn31 vdd vbsyn gsyn
X_ihx_49_31 a_xp49 a_xn49 wp_ih_49_31 wn_ih_49_31 xhp31 xhn31 vdd vbsyn gsyn
X_ihx_50_31 a_xp50 a_xn50 wp_ih_50_31 wn_ih_50_31 xhp31 xhn31 vdd vbsyn gsyn
X_ihx_51_31 a_xp51 a_xn51 wp_ih_51_31 wn_ih_51_31 xhp31 xhn31 vdd vbsyn gsyn
X_ihx_52_31 a_xp52 a_xn52 wp_ih_52_31 wn_ih_52_31 xhp31 xhn31 vdd vbsyn gsyn
X_ihx_53_31 a_xp53 a_xn53 wp_ih_53_31 wn_ih_53_31 xhp31 xhn31 vdd vbsyn gsyn
X_ihx_54_31 a_xp54 a_xn54 wp_ih_54_31 wn_ih_54_31 xhp31 xhn31 vdd vbsyn gsyn
X_ihx_55_31 a_xp55 a_xn55 wp_ih_55_31 wn_ih_55_31 xhp31 xhn31 vdd vbsyn gsyn
X_ihx_56_31 a_xp56 a_xn56 wp_ih_56_31 wn_ih_56_31 xhp31 xhn31 vdd vbsyn gsyn
X_ihx_57_31 a_xp57 a_xn57 wp_ih_57_31 wn_ih_57_31 xhp31 xhn31 vdd vbsyn gsyn
X_ihx_58_31 a_xp58 a_xn58 wp_ih_58_31 wn_ih_58_31 xhp31 xhn31 vdd vbsyn gsyn
X_ihx_59_31 a_xp59 a_xn59 wp_ih_59_31 wn_ih_59_31 xhp31 xhn31 vdd vbsyn gsyn
X_ihx_60_31 a_xp60 a_xn60 wp_ih_60_31 wn_ih_60_31 xhp31 xhn31 vdd vbsyn gsyn
X_ihx_61_31 a_xp61 a_xn61 wp_ih_61_31 wn_ih_61_31 xhp31 xhn31 vdd vbsyn gsyn
X_ihx_62_31 a_xp62 a_xn62 wp_ih_62_31 wn_ih_62_31 xhp31 xhn31 vdd vbsyn gsyn
X_ihx_63_31 a_xp63 a_xn63 wp_ih_63_31 wn_ih_63_31 xhp31 xhn31 vdd vbsyn gsyn
Xn31 xhp31 xhn31 ahp31 ahn31 vdd vbneu dneuron
Xcm_xh32 xhp32 xhn32 vdd cmld
Rnd_xh32 xhp32 xhn32 20k
X_ihx_0_32 a_xp0 a_xn0 wp_ih_0_32 wn_ih_0_32 xhp32 xhn32 vdd vbsyn gsyn
X_ihx_1_32 a_xp1 a_xn1 wp_ih_1_32 wn_ih_1_32 xhp32 xhn32 vdd vbsyn gsyn
X_ihx_2_32 a_xp2 a_xn2 wp_ih_2_32 wn_ih_2_32 xhp32 xhn32 vdd vbsyn gsyn
X_ihx_3_32 a_xp3 a_xn3 wp_ih_3_32 wn_ih_3_32 xhp32 xhn32 vdd vbsyn gsyn
X_ihx_4_32 a_xp4 a_xn4 wp_ih_4_32 wn_ih_4_32 xhp32 xhn32 vdd vbsyn gsyn
X_ihx_5_32 a_xp5 a_xn5 wp_ih_5_32 wn_ih_5_32 xhp32 xhn32 vdd vbsyn gsyn
X_ihx_6_32 a_xp6 a_xn6 wp_ih_6_32 wn_ih_6_32 xhp32 xhn32 vdd vbsyn gsyn
X_ihx_7_32 a_xp7 a_xn7 wp_ih_7_32 wn_ih_7_32 xhp32 xhn32 vdd vbsyn gsyn
X_ihx_8_32 a_xp8 a_xn8 wp_ih_8_32 wn_ih_8_32 xhp32 xhn32 vdd vbsyn gsyn
X_ihx_9_32 a_xp9 a_xn9 wp_ih_9_32 wn_ih_9_32 xhp32 xhn32 vdd vbsyn gsyn
X_ihx_10_32 a_xp10 a_xn10 wp_ih_10_32 wn_ih_10_32 xhp32 xhn32 vdd vbsyn gsyn
X_ihx_11_32 a_xp11 a_xn11 wp_ih_11_32 wn_ih_11_32 xhp32 xhn32 vdd vbsyn gsyn
X_ihx_12_32 a_xp12 a_xn12 wp_ih_12_32 wn_ih_12_32 xhp32 xhn32 vdd vbsyn gsyn
X_ihx_13_32 a_xp13 a_xn13 wp_ih_13_32 wn_ih_13_32 xhp32 xhn32 vdd vbsyn gsyn
X_ihx_14_32 a_xp14 a_xn14 wp_ih_14_32 wn_ih_14_32 xhp32 xhn32 vdd vbsyn gsyn
X_ihx_15_32 a_xp15 a_xn15 wp_ih_15_32 wn_ih_15_32 xhp32 xhn32 vdd vbsyn gsyn
X_ihx_16_32 a_xp16 a_xn16 wp_ih_16_32 wn_ih_16_32 xhp32 xhn32 vdd vbsyn gsyn
X_ihx_17_32 a_xp17 a_xn17 wp_ih_17_32 wn_ih_17_32 xhp32 xhn32 vdd vbsyn gsyn
X_ihx_18_32 a_xp18 a_xn18 wp_ih_18_32 wn_ih_18_32 xhp32 xhn32 vdd vbsyn gsyn
X_ihx_19_32 a_xp19 a_xn19 wp_ih_19_32 wn_ih_19_32 xhp32 xhn32 vdd vbsyn gsyn
X_ihx_20_32 a_xp20 a_xn20 wp_ih_20_32 wn_ih_20_32 xhp32 xhn32 vdd vbsyn gsyn
X_ihx_21_32 a_xp21 a_xn21 wp_ih_21_32 wn_ih_21_32 xhp32 xhn32 vdd vbsyn gsyn
X_ihx_22_32 a_xp22 a_xn22 wp_ih_22_32 wn_ih_22_32 xhp32 xhn32 vdd vbsyn gsyn
X_ihx_23_32 a_xp23 a_xn23 wp_ih_23_32 wn_ih_23_32 xhp32 xhn32 vdd vbsyn gsyn
X_ihx_24_32 a_xp24 a_xn24 wp_ih_24_32 wn_ih_24_32 xhp32 xhn32 vdd vbsyn gsyn
X_ihx_25_32 a_xp25 a_xn25 wp_ih_25_32 wn_ih_25_32 xhp32 xhn32 vdd vbsyn gsyn
X_ihx_26_32 a_xp26 a_xn26 wp_ih_26_32 wn_ih_26_32 xhp32 xhn32 vdd vbsyn gsyn
X_ihx_27_32 a_xp27 a_xn27 wp_ih_27_32 wn_ih_27_32 xhp32 xhn32 vdd vbsyn gsyn
X_ihx_28_32 a_xp28 a_xn28 wp_ih_28_32 wn_ih_28_32 xhp32 xhn32 vdd vbsyn gsyn
X_ihx_29_32 a_xp29 a_xn29 wp_ih_29_32 wn_ih_29_32 xhp32 xhn32 vdd vbsyn gsyn
X_ihx_30_32 a_xp30 a_xn30 wp_ih_30_32 wn_ih_30_32 xhp32 xhn32 vdd vbsyn gsyn
X_ihx_31_32 a_xp31 a_xn31 wp_ih_31_32 wn_ih_31_32 xhp32 xhn32 vdd vbsyn gsyn
X_ihx_32_32 a_xp32 a_xn32 wp_ih_32_32 wn_ih_32_32 xhp32 xhn32 vdd vbsyn gsyn
X_ihx_33_32 a_xp33 a_xn33 wp_ih_33_32 wn_ih_33_32 xhp32 xhn32 vdd vbsyn gsyn
X_ihx_34_32 a_xp34 a_xn34 wp_ih_34_32 wn_ih_34_32 xhp32 xhn32 vdd vbsyn gsyn
X_ihx_35_32 a_xp35 a_xn35 wp_ih_35_32 wn_ih_35_32 xhp32 xhn32 vdd vbsyn gsyn
X_ihx_36_32 a_xp36 a_xn36 wp_ih_36_32 wn_ih_36_32 xhp32 xhn32 vdd vbsyn gsyn
X_ihx_37_32 a_xp37 a_xn37 wp_ih_37_32 wn_ih_37_32 xhp32 xhn32 vdd vbsyn gsyn
X_ihx_38_32 a_xp38 a_xn38 wp_ih_38_32 wn_ih_38_32 xhp32 xhn32 vdd vbsyn gsyn
X_ihx_39_32 a_xp39 a_xn39 wp_ih_39_32 wn_ih_39_32 xhp32 xhn32 vdd vbsyn gsyn
X_ihx_40_32 a_xp40 a_xn40 wp_ih_40_32 wn_ih_40_32 xhp32 xhn32 vdd vbsyn gsyn
X_ihx_41_32 a_xp41 a_xn41 wp_ih_41_32 wn_ih_41_32 xhp32 xhn32 vdd vbsyn gsyn
X_ihx_42_32 a_xp42 a_xn42 wp_ih_42_32 wn_ih_42_32 xhp32 xhn32 vdd vbsyn gsyn
X_ihx_43_32 a_xp43 a_xn43 wp_ih_43_32 wn_ih_43_32 xhp32 xhn32 vdd vbsyn gsyn
X_ihx_44_32 a_xp44 a_xn44 wp_ih_44_32 wn_ih_44_32 xhp32 xhn32 vdd vbsyn gsyn
X_ihx_45_32 a_xp45 a_xn45 wp_ih_45_32 wn_ih_45_32 xhp32 xhn32 vdd vbsyn gsyn
X_ihx_46_32 a_xp46 a_xn46 wp_ih_46_32 wn_ih_46_32 xhp32 xhn32 vdd vbsyn gsyn
X_ihx_47_32 a_xp47 a_xn47 wp_ih_47_32 wn_ih_47_32 xhp32 xhn32 vdd vbsyn gsyn
X_ihx_48_32 a_xp48 a_xn48 wp_ih_48_32 wn_ih_48_32 xhp32 xhn32 vdd vbsyn gsyn
X_ihx_49_32 a_xp49 a_xn49 wp_ih_49_32 wn_ih_49_32 xhp32 xhn32 vdd vbsyn gsyn
X_ihx_50_32 a_xp50 a_xn50 wp_ih_50_32 wn_ih_50_32 xhp32 xhn32 vdd vbsyn gsyn
X_ihx_51_32 a_xp51 a_xn51 wp_ih_51_32 wn_ih_51_32 xhp32 xhn32 vdd vbsyn gsyn
X_ihx_52_32 a_xp52 a_xn52 wp_ih_52_32 wn_ih_52_32 xhp32 xhn32 vdd vbsyn gsyn
X_ihx_53_32 a_xp53 a_xn53 wp_ih_53_32 wn_ih_53_32 xhp32 xhn32 vdd vbsyn gsyn
X_ihx_54_32 a_xp54 a_xn54 wp_ih_54_32 wn_ih_54_32 xhp32 xhn32 vdd vbsyn gsyn
X_ihx_55_32 a_xp55 a_xn55 wp_ih_55_32 wn_ih_55_32 xhp32 xhn32 vdd vbsyn gsyn
X_ihx_56_32 a_xp56 a_xn56 wp_ih_56_32 wn_ih_56_32 xhp32 xhn32 vdd vbsyn gsyn
X_ihx_57_32 a_xp57 a_xn57 wp_ih_57_32 wn_ih_57_32 xhp32 xhn32 vdd vbsyn gsyn
X_ihx_58_32 a_xp58 a_xn58 wp_ih_58_32 wn_ih_58_32 xhp32 xhn32 vdd vbsyn gsyn
X_ihx_59_32 a_xp59 a_xn59 wp_ih_59_32 wn_ih_59_32 xhp32 xhn32 vdd vbsyn gsyn
X_ihx_60_32 a_xp60 a_xn60 wp_ih_60_32 wn_ih_60_32 xhp32 xhn32 vdd vbsyn gsyn
X_ihx_61_32 a_xp61 a_xn61 wp_ih_61_32 wn_ih_61_32 xhp32 xhn32 vdd vbsyn gsyn
X_ihx_62_32 a_xp62 a_xn62 wp_ih_62_32 wn_ih_62_32 xhp32 xhn32 vdd vbsyn gsyn
X_ihx_63_32 a_xp63 a_xn63 wp_ih_63_32 wn_ih_63_32 xhp32 xhn32 vdd vbsyn gsyn
Xn32 xhp32 xhn32 ahp32 ahn32 vdd vbneu dneuron
Xcm_xh33 xhp33 xhn33 vdd cmld
Rnd_xh33 xhp33 xhn33 20k
X_ihx_0_33 a_xp0 a_xn0 wp_ih_0_33 wn_ih_0_33 xhp33 xhn33 vdd vbsyn gsyn
X_ihx_1_33 a_xp1 a_xn1 wp_ih_1_33 wn_ih_1_33 xhp33 xhn33 vdd vbsyn gsyn
X_ihx_2_33 a_xp2 a_xn2 wp_ih_2_33 wn_ih_2_33 xhp33 xhn33 vdd vbsyn gsyn
X_ihx_3_33 a_xp3 a_xn3 wp_ih_3_33 wn_ih_3_33 xhp33 xhn33 vdd vbsyn gsyn
X_ihx_4_33 a_xp4 a_xn4 wp_ih_4_33 wn_ih_4_33 xhp33 xhn33 vdd vbsyn gsyn
X_ihx_5_33 a_xp5 a_xn5 wp_ih_5_33 wn_ih_5_33 xhp33 xhn33 vdd vbsyn gsyn
X_ihx_6_33 a_xp6 a_xn6 wp_ih_6_33 wn_ih_6_33 xhp33 xhn33 vdd vbsyn gsyn
X_ihx_7_33 a_xp7 a_xn7 wp_ih_7_33 wn_ih_7_33 xhp33 xhn33 vdd vbsyn gsyn
X_ihx_8_33 a_xp8 a_xn8 wp_ih_8_33 wn_ih_8_33 xhp33 xhn33 vdd vbsyn gsyn
X_ihx_9_33 a_xp9 a_xn9 wp_ih_9_33 wn_ih_9_33 xhp33 xhn33 vdd vbsyn gsyn
X_ihx_10_33 a_xp10 a_xn10 wp_ih_10_33 wn_ih_10_33 xhp33 xhn33 vdd vbsyn gsyn
X_ihx_11_33 a_xp11 a_xn11 wp_ih_11_33 wn_ih_11_33 xhp33 xhn33 vdd vbsyn gsyn
X_ihx_12_33 a_xp12 a_xn12 wp_ih_12_33 wn_ih_12_33 xhp33 xhn33 vdd vbsyn gsyn
X_ihx_13_33 a_xp13 a_xn13 wp_ih_13_33 wn_ih_13_33 xhp33 xhn33 vdd vbsyn gsyn
X_ihx_14_33 a_xp14 a_xn14 wp_ih_14_33 wn_ih_14_33 xhp33 xhn33 vdd vbsyn gsyn
X_ihx_15_33 a_xp15 a_xn15 wp_ih_15_33 wn_ih_15_33 xhp33 xhn33 vdd vbsyn gsyn
X_ihx_16_33 a_xp16 a_xn16 wp_ih_16_33 wn_ih_16_33 xhp33 xhn33 vdd vbsyn gsyn
X_ihx_17_33 a_xp17 a_xn17 wp_ih_17_33 wn_ih_17_33 xhp33 xhn33 vdd vbsyn gsyn
X_ihx_18_33 a_xp18 a_xn18 wp_ih_18_33 wn_ih_18_33 xhp33 xhn33 vdd vbsyn gsyn
X_ihx_19_33 a_xp19 a_xn19 wp_ih_19_33 wn_ih_19_33 xhp33 xhn33 vdd vbsyn gsyn
X_ihx_20_33 a_xp20 a_xn20 wp_ih_20_33 wn_ih_20_33 xhp33 xhn33 vdd vbsyn gsyn
X_ihx_21_33 a_xp21 a_xn21 wp_ih_21_33 wn_ih_21_33 xhp33 xhn33 vdd vbsyn gsyn
X_ihx_22_33 a_xp22 a_xn22 wp_ih_22_33 wn_ih_22_33 xhp33 xhn33 vdd vbsyn gsyn
X_ihx_23_33 a_xp23 a_xn23 wp_ih_23_33 wn_ih_23_33 xhp33 xhn33 vdd vbsyn gsyn
X_ihx_24_33 a_xp24 a_xn24 wp_ih_24_33 wn_ih_24_33 xhp33 xhn33 vdd vbsyn gsyn
X_ihx_25_33 a_xp25 a_xn25 wp_ih_25_33 wn_ih_25_33 xhp33 xhn33 vdd vbsyn gsyn
X_ihx_26_33 a_xp26 a_xn26 wp_ih_26_33 wn_ih_26_33 xhp33 xhn33 vdd vbsyn gsyn
X_ihx_27_33 a_xp27 a_xn27 wp_ih_27_33 wn_ih_27_33 xhp33 xhn33 vdd vbsyn gsyn
X_ihx_28_33 a_xp28 a_xn28 wp_ih_28_33 wn_ih_28_33 xhp33 xhn33 vdd vbsyn gsyn
X_ihx_29_33 a_xp29 a_xn29 wp_ih_29_33 wn_ih_29_33 xhp33 xhn33 vdd vbsyn gsyn
X_ihx_30_33 a_xp30 a_xn30 wp_ih_30_33 wn_ih_30_33 xhp33 xhn33 vdd vbsyn gsyn
X_ihx_31_33 a_xp31 a_xn31 wp_ih_31_33 wn_ih_31_33 xhp33 xhn33 vdd vbsyn gsyn
X_ihx_32_33 a_xp32 a_xn32 wp_ih_32_33 wn_ih_32_33 xhp33 xhn33 vdd vbsyn gsyn
X_ihx_33_33 a_xp33 a_xn33 wp_ih_33_33 wn_ih_33_33 xhp33 xhn33 vdd vbsyn gsyn
X_ihx_34_33 a_xp34 a_xn34 wp_ih_34_33 wn_ih_34_33 xhp33 xhn33 vdd vbsyn gsyn
X_ihx_35_33 a_xp35 a_xn35 wp_ih_35_33 wn_ih_35_33 xhp33 xhn33 vdd vbsyn gsyn
X_ihx_36_33 a_xp36 a_xn36 wp_ih_36_33 wn_ih_36_33 xhp33 xhn33 vdd vbsyn gsyn
X_ihx_37_33 a_xp37 a_xn37 wp_ih_37_33 wn_ih_37_33 xhp33 xhn33 vdd vbsyn gsyn
X_ihx_38_33 a_xp38 a_xn38 wp_ih_38_33 wn_ih_38_33 xhp33 xhn33 vdd vbsyn gsyn
X_ihx_39_33 a_xp39 a_xn39 wp_ih_39_33 wn_ih_39_33 xhp33 xhn33 vdd vbsyn gsyn
X_ihx_40_33 a_xp40 a_xn40 wp_ih_40_33 wn_ih_40_33 xhp33 xhn33 vdd vbsyn gsyn
X_ihx_41_33 a_xp41 a_xn41 wp_ih_41_33 wn_ih_41_33 xhp33 xhn33 vdd vbsyn gsyn
X_ihx_42_33 a_xp42 a_xn42 wp_ih_42_33 wn_ih_42_33 xhp33 xhn33 vdd vbsyn gsyn
X_ihx_43_33 a_xp43 a_xn43 wp_ih_43_33 wn_ih_43_33 xhp33 xhn33 vdd vbsyn gsyn
X_ihx_44_33 a_xp44 a_xn44 wp_ih_44_33 wn_ih_44_33 xhp33 xhn33 vdd vbsyn gsyn
X_ihx_45_33 a_xp45 a_xn45 wp_ih_45_33 wn_ih_45_33 xhp33 xhn33 vdd vbsyn gsyn
X_ihx_46_33 a_xp46 a_xn46 wp_ih_46_33 wn_ih_46_33 xhp33 xhn33 vdd vbsyn gsyn
X_ihx_47_33 a_xp47 a_xn47 wp_ih_47_33 wn_ih_47_33 xhp33 xhn33 vdd vbsyn gsyn
X_ihx_48_33 a_xp48 a_xn48 wp_ih_48_33 wn_ih_48_33 xhp33 xhn33 vdd vbsyn gsyn
X_ihx_49_33 a_xp49 a_xn49 wp_ih_49_33 wn_ih_49_33 xhp33 xhn33 vdd vbsyn gsyn
X_ihx_50_33 a_xp50 a_xn50 wp_ih_50_33 wn_ih_50_33 xhp33 xhn33 vdd vbsyn gsyn
X_ihx_51_33 a_xp51 a_xn51 wp_ih_51_33 wn_ih_51_33 xhp33 xhn33 vdd vbsyn gsyn
X_ihx_52_33 a_xp52 a_xn52 wp_ih_52_33 wn_ih_52_33 xhp33 xhn33 vdd vbsyn gsyn
X_ihx_53_33 a_xp53 a_xn53 wp_ih_53_33 wn_ih_53_33 xhp33 xhn33 vdd vbsyn gsyn
X_ihx_54_33 a_xp54 a_xn54 wp_ih_54_33 wn_ih_54_33 xhp33 xhn33 vdd vbsyn gsyn
X_ihx_55_33 a_xp55 a_xn55 wp_ih_55_33 wn_ih_55_33 xhp33 xhn33 vdd vbsyn gsyn
X_ihx_56_33 a_xp56 a_xn56 wp_ih_56_33 wn_ih_56_33 xhp33 xhn33 vdd vbsyn gsyn
X_ihx_57_33 a_xp57 a_xn57 wp_ih_57_33 wn_ih_57_33 xhp33 xhn33 vdd vbsyn gsyn
X_ihx_58_33 a_xp58 a_xn58 wp_ih_58_33 wn_ih_58_33 xhp33 xhn33 vdd vbsyn gsyn
X_ihx_59_33 a_xp59 a_xn59 wp_ih_59_33 wn_ih_59_33 xhp33 xhn33 vdd vbsyn gsyn
X_ihx_60_33 a_xp60 a_xn60 wp_ih_60_33 wn_ih_60_33 xhp33 xhn33 vdd vbsyn gsyn
X_ihx_61_33 a_xp61 a_xn61 wp_ih_61_33 wn_ih_61_33 xhp33 xhn33 vdd vbsyn gsyn
X_ihx_62_33 a_xp62 a_xn62 wp_ih_62_33 wn_ih_62_33 xhp33 xhn33 vdd vbsyn gsyn
X_ihx_63_33 a_xp63 a_xn63 wp_ih_63_33 wn_ih_63_33 xhp33 xhn33 vdd vbsyn gsyn
Xn33 xhp33 xhn33 ahp33 ahn33 vdd vbneu dneuron
Xcm_xh34 xhp34 xhn34 vdd cmld
Rnd_xh34 xhp34 xhn34 20k
X_ihx_0_34 a_xp0 a_xn0 wp_ih_0_34 wn_ih_0_34 xhp34 xhn34 vdd vbsyn gsyn
X_ihx_1_34 a_xp1 a_xn1 wp_ih_1_34 wn_ih_1_34 xhp34 xhn34 vdd vbsyn gsyn
X_ihx_2_34 a_xp2 a_xn2 wp_ih_2_34 wn_ih_2_34 xhp34 xhn34 vdd vbsyn gsyn
X_ihx_3_34 a_xp3 a_xn3 wp_ih_3_34 wn_ih_3_34 xhp34 xhn34 vdd vbsyn gsyn
X_ihx_4_34 a_xp4 a_xn4 wp_ih_4_34 wn_ih_4_34 xhp34 xhn34 vdd vbsyn gsyn
X_ihx_5_34 a_xp5 a_xn5 wp_ih_5_34 wn_ih_5_34 xhp34 xhn34 vdd vbsyn gsyn
X_ihx_6_34 a_xp6 a_xn6 wp_ih_6_34 wn_ih_6_34 xhp34 xhn34 vdd vbsyn gsyn
X_ihx_7_34 a_xp7 a_xn7 wp_ih_7_34 wn_ih_7_34 xhp34 xhn34 vdd vbsyn gsyn
X_ihx_8_34 a_xp8 a_xn8 wp_ih_8_34 wn_ih_8_34 xhp34 xhn34 vdd vbsyn gsyn
X_ihx_9_34 a_xp9 a_xn9 wp_ih_9_34 wn_ih_9_34 xhp34 xhn34 vdd vbsyn gsyn
X_ihx_10_34 a_xp10 a_xn10 wp_ih_10_34 wn_ih_10_34 xhp34 xhn34 vdd vbsyn gsyn
X_ihx_11_34 a_xp11 a_xn11 wp_ih_11_34 wn_ih_11_34 xhp34 xhn34 vdd vbsyn gsyn
X_ihx_12_34 a_xp12 a_xn12 wp_ih_12_34 wn_ih_12_34 xhp34 xhn34 vdd vbsyn gsyn
X_ihx_13_34 a_xp13 a_xn13 wp_ih_13_34 wn_ih_13_34 xhp34 xhn34 vdd vbsyn gsyn
X_ihx_14_34 a_xp14 a_xn14 wp_ih_14_34 wn_ih_14_34 xhp34 xhn34 vdd vbsyn gsyn
X_ihx_15_34 a_xp15 a_xn15 wp_ih_15_34 wn_ih_15_34 xhp34 xhn34 vdd vbsyn gsyn
X_ihx_16_34 a_xp16 a_xn16 wp_ih_16_34 wn_ih_16_34 xhp34 xhn34 vdd vbsyn gsyn
X_ihx_17_34 a_xp17 a_xn17 wp_ih_17_34 wn_ih_17_34 xhp34 xhn34 vdd vbsyn gsyn
X_ihx_18_34 a_xp18 a_xn18 wp_ih_18_34 wn_ih_18_34 xhp34 xhn34 vdd vbsyn gsyn
X_ihx_19_34 a_xp19 a_xn19 wp_ih_19_34 wn_ih_19_34 xhp34 xhn34 vdd vbsyn gsyn
X_ihx_20_34 a_xp20 a_xn20 wp_ih_20_34 wn_ih_20_34 xhp34 xhn34 vdd vbsyn gsyn
X_ihx_21_34 a_xp21 a_xn21 wp_ih_21_34 wn_ih_21_34 xhp34 xhn34 vdd vbsyn gsyn
X_ihx_22_34 a_xp22 a_xn22 wp_ih_22_34 wn_ih_22_34 xhp34 xhn34 vdd vbsyn gsyn
X_ihx_23_34 a_xp23 a_xn23 wp_ih_23_34 wn_ih_23_34 xhp34 xhn34 vdd vbsyn gsyn
X_ihx_24_34 a_xp24 a_xn24 wp_ih_24_34 wn_ih_24_34 xhp34 xhn34 vdd vbsyn gsyn
X_ihx_25_34 a_xp25 a_xn25 wp_ih_25_34 wn_ih_25_34 xhp34 xhn34 vdd vbsyn gsyn
X_ihx_26_34 a_xp26 a_xn26 wp_ih_26_34 wn_ih_26_34 xhp34 xhn34 vdd vbsyn gsyn
X_ihx_27_34 a_xp27 a_xn27 wp_ih_27_34 wn_ih_27_34 xhp34 xhn34 vdd vbsyn gsyn
X_ihx_28_34 a_xp28 a_xn28 wp_ih_28_34 wn_ih_28_34 xhp34 xhn34 vdd vbsyn gsyn
X_ihx_29_34 a_xp29 a_xn29 wp_ih_29_34 wn_ih_29_34 xhp34 xhn34 vdd vbsyn gsyn
X_ihx_30_34 a_xp30 a_xn30 wp_ih_30_34 wn_ih_30_34 xhp34 xhn34 vdd vbsyn gsyn
X_ihx_31_34 a_xp31 a_xn31 wp_ih_31_34 wn_ih_31_34 xhp34 xhn34 vdd vbsyn gsyn
X_ihx_32_34 a_xp32 a_xn32 wp_ih_32_34 wn_ih_32_34 xhp34 xhn34 vdd vbsyn gsyn
X_ihx_33_34 a_xp33 a_xn33 wp_ih_33_34 wn_ih_33_34 xhp34 xhn34 vdd vbsyn gsyn
X_ihx_34_34 a_xp34 a_xn34 wp_ih_34_34 wn_ih_34_34 xhp34 xhn34 vdd vbsyn gsyn
X_ihx_35_34 a_xp35 a_xn35 wp_ih_35_34 wn_ih_35_34 xhp34 xhn34 vdd vbsyn gsyn
X_ihx_36_34 a_xp36 a_xn36 wp_ih_36_34 wn_ih_36_34 xhp34 xhn34 vdd vbsyn gsyn
X_ihx_37_34 a_xp37 a_xn37 wp_ih_37_34 wn_ih_37_34 xhp34 xhn34 vdd vbsyn gsyn
X_ihx_38_34 a_xp38 a_xn38 wp_ih_38_34 wn_ih_38_34 xhp34 xhn34 vdd vbsyn gsyn
X_ihx_39_34 a_xp39 a_xn39 wp_ih_39_34 wn_ih_39_34 xhp34 xhn34 vdd vbsyn gsyn
X_ihx_40_34 a_xp40 a_xn40 wp_ih_40_34 wn_ih_40_34 xhp34 xhn34 vdd vbsyn gsyn
X_ihx_41_34 a_xp41 a_xn41 wp_ih_41_34 wn_ih_41_34 xhp34 xhn34 vdd vbsyn gsyn
X_ihx_42_34 a_xp42 a_xn42 wp_ih_42_34 wn_ih_42_34 xhp34 xhn34 vdd vbsyn gsyn
X_ihx_43_34 a_xp43 a_xn43 wp_ih_43_34 wn_ih_43_34 xhp34 xhn34 vdd vbsyn gsyn
X_ihx_44_34 a_xp44 a_xn44 wp_ih_44_34 wn_ih_44_34 xhp34 xhn34 vdd vbsyn gsyn
X_ihx_45_34 a_xp45 a_xn45 wp_ih_45_34 wn_ih_45_34 xhp34 xhn34 vdd vbsyn gsyn
X_ihx_46_34 a_xp46 a_xn46 wp_ih_46_34 wn_ih_46_34 xhp34 xhn34 vdd vbsyn gsyn
X_ihx_47_34 a_xp47 a_xn47 wp_ih_47_34 wn_ih_47_34 xhp34 xhn34 vdd vbsyn gsyn
X_ihx_48_34 a_xp48 a_xn48 wp_ih_48_34 wn_ih_48_34 xhp34 xhn34 vdd vbsyn gsyn
X_ihx_49_34 a_xp49 a_xn49 wp_ih_49_34 wn_ih_49_34 xhp34 xhn34 vdd vbsyn gsyn
X_ihx_50_34 a_xp50 a_xn50 wp_ih_50_34 wn_ih_50_34 xhp34 xhn34 vdd vbsyn gsyn
X_ihx_51_34 a_xp51 a_xn51 wp_ih_51_34 wn_ih_51_34 xhp34 xhn34 vdd vbsyn gsyn
X_ihx_52_34 a_xp52 a_xn52 wp_ih_52_34 wn_ih_52_34 xhp34 xhn34 vdd vbsyn gsyn
X_ihx_53_34 a_xp53 a_xn53 wp_ih_53_34 wn_ih_53_34 xhp34 xhn34 vdd vbsyn gsyn
X_ihx_54_34 a_xp54 a_xn54 wp_ih_54_34 wn_ih_54_34 xhp34 xhn34 vdd vbsyn gsyn
X_ihx_55_34 a_xp55 a_xn55 wp_ih_55_34 wn_ih_55_34 xhp34 xhn34 vdd vbsyn gsyn
X_ihx_56_34 a_xp56 a_xn56 wp_ih_56_34 wn_ih_56_34 xhp34 xhn34 vdd vbsyn gsyn
X_ihx_57_34 a_xp57 a_xn57 wp_ih_57_34 wn_ih_57_34 xhp34 xhn34 vdd vbsyn gsyn
X_ihx_58_34 a_xp58 a_xn58 wp_ih_58_34 wn_ih_58_34 xhp34 xhn34 vdd vbsyn gsyn
X_ihx_59_34 a_xp59 a_xn59 wp_ih_59_34 wn_ih_59_34 xhp34 xhn34 vdd vbsyn gsyn
X_ihx_60_34 a_xp60 a_xn60 wp_ih_60_34 wn_ih_60_34 xhp34 xhn34 vdd vbsyn gsyn
X_ihx_61_34 a_xp61 a_xn61 wp_ih_61_34 wn_ih_61_34 xhp34 xhn34 vdd vbsyn gsyn
X_ihx_62_34 a_xp62 a_xn62 wp_ih_62_34 wn_ih_62_34 xhp34 xhn34 vdd vbsyn gsyn
X_ihx_63_34 a_xp63 a_xn63 wp_ih_63_34 wn_ih_63_34 xhp34 xhn34 vdd vbsyn gsyn
Xn34 xhp34 xhn34 ahp34 ahn34 vdd vbneu dneuron
Xcm_xh35 xhp35 xhn35 vdd cmld
Rnd_xh35 xhp35 xhn35 20k
X_ihx_0_35 a_xp0 a_xn0 wp_ih_0_35 wn_ih_0_35 xhp35 xhn35 vdd vbsyn gsyn
X_ihx_1_35 a_xp1 a_xn1 wp_ih_1_35 wn_ih_1_35 xhp35 xhn35 vdd vbsyn gsyn
X_ihx_2_35 a_xp2 a_xn2 wp_ih_2_35 wn_ih_2_35 xhp35 xhn35 vdd vbsyn gsyn
X_ihx_3_35 a_xp3 a_xn3 wp_ih_3_35 wn_ih_3_35 xhp35 xhn35 vdd vbsyn gsyn
X_ihx_4_35 a_xp4 a_xn4 wp_ih_4_35 wn_ih_4_35 xhp35 xhn35 vdd vbsyn gsyn
X_ihx_5_35 a_xp5 a_xn5 wp_ih_5_35 wn_ih_5_35 xhp35 xhn35 vdd vbsyn gsyn
X_ihx_6_35 a_xp6 a_xn6 wp_ih_6_35 wn_ih_6_35 xhp35 xhn35 vdd vbsyn gsyn
X_ihx_7_35 a_xp7 a_xn7 wp_ih_7_35 wn_ih_7_35 xhp35 xhn35 vdd vbsyn gsyn
X_ihx_8_35 a_xp8 a_xn8 wp_ih_8_35 wn_ih_8_35 xhp35 xhn35 vdd vbsyn gsyn
X_ihx_9_35 a_xp9 a_xn9 wp_ih_9_35 wn_ih_9_35 xhp35 xhn35 vdd vbsyn gsyn
X_ihx_10_35 a_xp10 a_xn10 wp_ih_10_35 wn_ih_10_35 xhp35 xhn35 vdd vbsyn gsyn
X_ihx_11_35 a_xp11 a_xn11 wp_ih_11_35 wn_ih_11_35 xhp35 xhn35 vdd vbsyn gsyn
X_ihx_12_35 a_xp12 a_xn12 wp_ih_12_35 wn_ih_12_35 xhp35 xhn35 vdd vbsyn gsyn
X_ihx_13_35 a_xp13 a_xn13 wp_ih_13_35 wn_ih_13_35 xhp35 xhn35 vdd vbsyn gsyn
X_ihx_14_35 a_xp14 a_xn14 wp_ih_14_35 wn_ih_14_35 xhp35 xhn35 vdd vbsyn gsyn
X_ihx_15_35 a_xp15 a_xn15 wp_ih_15_35 wn_ih_15_35 xhp35 xhn35 vdd vbsyn gsyn
X_ihx_16_35 a_xp16 a_xn16 wp_ih_16_35 wn_ih_16_35 xhp35 xhn35 vdd vbsyn gsyn
X_ihx_17_35 a_xp17 a_xn17 wp_ih_17_35 wn_ih_17_35 xhp35 xhn35 vdd vbsyn gsyn
X_ihx_18_35 a_xp18 a_xn18 wp_ih_18_35 wn_ih_18_35 xhp35 xhn35 vdd vbsyn gsyn
X_ihx_19_35 a_xp19 a_xn19 wp_ih_19_35 wn_ih_19_35 xhp35 xhn35 vdd vbsyn gsyn
X_ihx_20_35 a_xp20 a_xn20 wp_ih_20_35 wn_ih_20_35 xhp35 xhn35 vdd vbsyn gsyn
X_ihx_21_35 a_xp21 a_xn21 wp_ih_21_35 wn_ih_21_35 xhp35 xhn35 vdd vbsyn gsyn
X_ihx_22_35 a_xp22 a_xn22 wp_ih_22_35 wn_ih_22_35 xhp35 xhn35 vdd vbsyn gsyn
X_ihx_23_35 a_xp23 a_xn23 wp_ih_23_35 wn_ih_23_35 xhp35 xhn35 vdd vbsyn gsyn
X_ihx_24_35 a_xp24 a_xn24 wp_ih_24_35 wn_ih_24_35 xhp35 xhn35 vdd vbsyn gsyn
X_ihx_25_35 a_xp25 a_xn25 wp_ih_25_35 wn_ih_25_35 xhp35 xhn35 vdd vbsyn gsyn
X_ihx_26_35 a_xp26 a_xn26 wp_ih_26_35 wn_ih_26_35 xhp35 xhn35 vdd vbsyn gsyn
X_ihx_27_35 a_xp27 a_xn27 wp_ih_27_35 wn_ih_27_35 xhp35 xhn35 vdd vbsyn gsyn
X_ihx_28_35 a_xp28 a_xn28 wp_ih_28_35 wn_ih_28_35 xhp35 xhn35 vdd vbsyn gsyn
X_ihx_29_35 a_xp29 a_xn29 wp_ih_29_35 wn_ih_29_35 xhp35 xhn35 vdd vbsyn gsyn
X_ihx_30_35 a_xp30 a_xn30 wp_ih_30_35 wn_ih_30_35 xhp35 xhn35 vdd vbsyn gsyn
X_ihx_31_35 a_xp31 a_xn31 wp_ih_31_35 wn_ih_31_35 xhp35 xhn35 vdd vbsyn gsyn
X_ihx_32_35 a_xp32 a_xn32 wp_ih_32_35 wn_ih_32_35 xhp35 xhn35 vdd vbsyn gsyn
X_ihx_33_35 a_xp33 a_xn33 wp_ih_33_35 wn_ih_33_35 xhp35 xhn35 vdd vbsyn gsyn
X_ihx_34_35 a_xp34 a_xn34 wp_ih_34_35 wn_ih_34_35 xhp35 xhn35 vdd vbsyn gsyn
X_ihx_35_35 a_xp35 a_xn35 wp_ih_35_35 wn_ih_35_35 xhp35 xhn35 vdd vbsyn gsyn
X_ihx_36_35 a_xp36 a_xn36 wp_ih_36_35 wn_ih_36_35 xhp35 xhn35 vdd vbsyn gsyn
X_ihx_37_35 a_xp37 a_xn37 wp_ih_37_35 wn_ih_37_35 xhp35 xhn35 vdd vbsyn gsyn
X_ihx_38_35 a_xp38 a_xn38 wp_ih_38_35 wn_ih_38_35 xhp35 xhn35 vdd vbsyn gsyn
X_ihx_39_35 a_xp39 a_xn39 wp_ih_39_35 wn_ih_39_35 xhp35 xhn35 vdd vbsyn gsyn
X_ihx_40_35 a_xp40 a_xn40 wp_ih_40_35 wn_ih_40_35 xhp35 xhn35 vdd vbsyn gsyn
X_ihx_41_35 a_xp41 a_xn41 wp_ih_41_35 wn_ih_41_35 xhp35 xhn35 vdd vbsyn gsyn
X_ihx_42_35 a_xp42 a_xn42 wp_ih_42_35 wn_ih_42_35 xhp35 xhn35 vdd vbsyn gsyn
X_ihx_43_35 a_xp43 a_xn43 wp_ih_43_35 wn_ih_43_35 xhp35 xhn35 vdd vbsyn gsyn
X_ihx_44_35 a_xp44 a_xn44 wp_ih_44_35 wn_ih_44_35 xhp35 xhn35 vdd vbsyn gsyn
X_ihx_45_35 a_xp45 a_xn45 wp_ih_45_35 wn_ih_45_35 xhp35 xhn35 vdd vbsyn gsyn
X_ihx_46_35 a_xp46 a_xn46 wp_ih_46_35 wn_ih_46_35 xhp35 xhn35 vdd vbsyn gsyn
X_ihx_47_35 a_xp47 a_xn47 wp_ih_47_35 wn_ih_47_35 xhp35 xhn35 vdd vbsyn gsyn
X_ihx_48_35 a_xp48 a_xn48 wp_ih_48_35 wn_ih_48_35 xhp35 xhn35 vdd vbsyn gsyn
X_ihx_49_35 a_xp49 a_xn49 wp_ih_49_35 wn_ih_49_35 xhp35 xhn35 vdd vbsyn gsyn
X_ihx_50_35 a_xp50 a_xn50 wp_ih_50_35 wn_ih_50_35 xhp35 xhn35 vdd vbsyn gsyn
X_ihx_51_35 a_xp51 a_xn51 wp_ih_51_35 wn_ih_51_35 xhp35 xhn35 vdd vbsyn gsyn
X_ihx_52_35 a_xp52 a_xn52 wp_ih_52_35 wn_ih_52_35 xhp35 xhn35 vdd vbsyn gsyn
X_ihx_53_35 a_xp53 a_xn53 wp_ih_53_35 wn_ih_53_35 xhp35 xhn35 vdd vbsyn gsyn
X_ihx_54_35 a_xp54 a_xn54 wp_ih_54_35 wn_ih_54_35 xhp35 xhn35 vdd vbsyn gsyn
X_ihx_55_35 a_xp55 a_xn55 wp_ih_55_35 wn_ih_55_35 xhp35 xhn35 vdd vbsyn gsyn
X_ihx_56_35 a_xp56 a_xn56 wp_ih_56_35 wn_ih_56_35 xhp35 xhn35 vdd vbsyn gsyn
X_ihx_57_35 a_xp57 a_xn57 wp_ih_57_35 wn_ih_57_35 xhp35 xhn35 vdd vbsyn gsyn
X_ihx_58_35 a_xp58 a_xn58 wp_ih_58_35 wn_ih_58_35 xhp35 xhn35 vdd vbsyn gsyn
X_ihx_59_35 a_xp59 a_xn59 wp_ih_59_35 wn_ih_59_35 xhp35 xhn35 vdd vbsyn gsyn
X_ihx_60_35 a_xp60 a_xn60 wp_ih_60_35 wn_ih_60_35 xhp35 xhn35 vdd vbsyn gsyn
X_ihx_61_35 a_xp61 a_xn61 wp_ih_61_35 wn_ih_61_35 xhp35 xhn35 vdd vbsyn gsyn
X_ihx_62_35 a_xp62 a_xn62 wp_ih_62_35 wn_ih_62_35 xhp35 xhn35 vdd vbsyn gsyn
X_ihx_63_35 a_xp63 a_xn63 wp_ih_63_35 wn_ih_63_35 xhp35 xhn35 vdd vbsyn gsyn
Xn35 xhp35 xhn35 ahp35 ahn35 vdd vbneu dneuron
Xcm_xh36 xhp36 xhn36 vdd cmld
Rnd_xh36 xhp36 xhn36 20k
X_ihx_0_36 a_xp0 a_xn0 wp_ih_0_36 wn_ih_0_36 xhp36 xhn36 vdd vbsyn gsyn
X_ihx_1_36 a_xp1 a_xn1 wp_ih_1_36 wn_ih_1_36 xhp36 xhn36 vdd vbsyn gsyn
X_ihx_2_36 a_xp2 a_xn2 wp_ih_2_36 wn_ih_2_36 xhp36 xhn36 vdd vbsyn gsyn
X_ihx_3_36 a_xp3 a_xn3 wp_ih_3_36 wn_ih_3_36 xhp36 xhn36 vdd vbsyn gsyn
X_ihx_4_36 a_xp4 a_xn4 wp_ih_4_36 wn_ih_4_36 xhp36 xhn36 vdd vbsyn gsyn
X_ihx_5_36 a_xp5 a_xn5 wp_ih_5_36 wn_ih_5_36 xhp36 xhn36 vdd vbsyn gsyn
X_ihx_6_36 a_xp6 a_xn6 wp_ih_6_36 wn_ih_6_36 xhp36 xhn36 vdd vbsyn gsyn
X_ihx_7_36 a_xp7 a_xn7 wp_ih_7_36 wn_ih_7_36 xhp36 xhn36 vdd vbsyn gsyn
X_ihx_8_36 a_xp8 a_xn8 wp_ih_8_36 wn_ih_8_36 xhp36 xhn36 vdd vbsyn gsyn
X_ihx_9_36 a_xp9 a_xn9 wp_ih_9_36 wn_ih_9_36 xhp36 xhn36 vdd vbsyn gsyn
X_ihx_10_36 a_xp10 a_xn10 wp_ih_10_36 wn_ih_10_36 xhp36 xhn36 vdd vbsyn gsyn
X_ihx_11_36 a_xp11 a_xn11 wp_ih_11_36 wn_ih_11_36 xhp36 xhn36 vdd vbsyn gsyn
X_ihx_12_36 a_xp12 a_xn12 wp_ih_12_36 wn_ih_12_36 xhp36 xhn36 vdd vbsyn gsyn
X_ihx_13_36 a_xp13 a_xn13 wp_ih_13_36 wn_ih_13_36 xhp36 xhn36 vdd vbsyn gsyn
X_ihx_14_36 a_xp14 a_xn14 wp_ih_14_36 wn_ih_14_36 xhp36 xhn36 vdd vbsyn gsyn
X_ihx_15_36 a_xp15 a_xn15 wp_ih_15_36 wn_ih_15_36 xhp36 xhn36 vdd vbsyn gsyn
X_ihx_16_36 a_xp16 a_xn16 wp_ih_16_36 wn_ih_16_36 xhp36 xhn36 vdd vbsyn gsyn
X_ihx_17_36 a_xp17 a_xn17 wp_ih_17_36 wn_ih_17_36 xhp36 xhn36 vdd vbsyn gsyn
X_ihx_18_36 a_xp18 a_xn18 wp_ih_18_36 wn_ih_18_36 xhp36 xhn36 vdd vbsyn gsyn
X_ihx_19_36 a_xp19 a_xn19 wp_ih_19_36 wn_ih_19_36 xhp36 xhn36 vdd vbsyn gsyn
X_ihx_20_36 a_xp20 a_xn20 wp_ih_20_36 wn_ih_20_36 xhp36 xhn36 vdd vbsyn gsyn
X_ihx_21_36 a_xp21 a_xn21 wp_ih_21_36 wn_ih_21_36 xhp36 xhn36 vdd vbsyn gsyn
X_ihx_22_36 a_xp22 a_xn22 wp_ih_22_36 wn_ih_22_36 xhp36 xhn36 vdd vbsyn gsyn
X_ihx_23_36 a_xp23 a_xn23 wp_ih_23_36 wn_ih_23_36 xhp36 xhn36 vdd vbsyn gsyn
X_ihx_24_36 a_xp24 a_xn24 wp_ih_24_36 wn_ih_24_36 xhp36 xhn36 vdd vbsyn gsyn
X_ihx_25_36 a_xp25 a_xn25 wp_ih_25_36 wn_ih_25_36 xhp36 xhn36 vdd vbsyn gsyn
X_ihx_26_36 a_xp26 a_xn26 wp_ih_26_36 wn_ih_26_36 xhp36 xhn36 vdd vbsyn gsyn
X_ihx_27_36 a_xp27 a_xn27 wp_ih_27_36 wn_ih_27_36 xhp36 xhn36 vdd vbsyn gsyn
X_ihx_28_36 a_xp28 a_xn28 wp_ih_28_36 wn_ih_28_36 xhp36 xhn36 vdd vbsyn gsyn
X_ihx_29_36 a_xp29 a_xn29 wp_ih_29_36 wn_ih_29_36 xhp36 xhn36 vdd vbsyn gsyn
X_ihx_30_36 a_xp30 a_xn30 wp_ih_30_36 wn_ih_30_36 xhp36 xhn36 vdd vbsyn gsyn
X_ihx_31_36 a_xp31 a_xn31 wp_ih_31_36 wn_ih_31_36 xhp36 xhn36 vdd vbsyn gsyn
X_ihx_32_36 a_xp32 a_xn32 wp_ih_32_36 wn_ih_32_36 xhp36 xhn36 vdd vbsyn gsyn
X_ihx_33_36 a_xp33 a_xn33 wp_ih_33_36 wn_ih_33_36 xhp36 xhn36 vdd vbsyn gsyn
X_ihx_34_36 a_xp34 a_xn34 wp_ih_34_36 wn_ih_34_36 xhp36 xhn36 vdd vbsyn gsyn
X_ihx_35_36 a_xp35 a_xn35 wp_ih_35_36 wn_ih_35_36 xhp36 xhn36 vdd vbsyn gsyn
X_ihx_36_36 a_xp36 a_xn36 wp_ih_36_36 wn_ih_36_36 xhp36 xhn36 vdd vbsyn gsyn
X_ihx_37_36 a_xp37 a_xn37 wp_ih_37_36 wn_ih_37_36 xhp36 xhn36 vdd vbsyn gsyn
X_ihx_38_36 a_xp38 a_xn38 wp_ih_38_36 wn_ih_38_36 xhp36 xhn36 vdd vbsyn gsyn
X_ihx_39_36 a_xp39 a_xn39 wp_ih_39_36 wn_ih_39_36 xhp36 xhn36 vdd vbsyn gsyn
X_ihx_40_36 a_xp40 a_xn40 wp_ih_40_36 wn_ih_40_36 xhp36 xhn36 vdd vbsyn gsyn
X_ihx_41_36 a_xp41 a_xn41 wp_ih_41_36 wn_ih_41_36 xhp36 xhn36 vdd vbsyn gsyn
X_ihx_42_36 a_xp42 a_xn42 wp_ih_42_36 wn_ih_42_36 xhp36 xhn36 vdd vbsyn gsyn
X_ihx_43_36 a_xp43 a_xn43 wp_ih_43_36 wn_ih_43_36 xhp36 xhn36 vdd vbsyn gsyn
X_ihx_44_36 a_xp44 a_xn44 wp_ih_44_36 wn_ih_44_36 xhp36 xhn36 vdd vbsyn gsyn
X_ihx_45_36 a_xp45 a_xn45 wp_ih_45_36 wn_ih_45_36 xhp36 xhn36 vdd vbsyn gsyn
X_ihx_46_36 a_xp46 a_xn46 wp_ih_46_36 wn_ih_46_36 xhp36 xhn36 vdd vbsyn gsyn
X_ihx_47_36 a_xp47 a_xn47 wp_ih_47_36 wn_ih_47_36 xhp36 xhn36 vdd vbsyn gsyn
X_ihx_48_36 a_xp48 a_xn48 wp_ih_48_36 wn_ih_48_36 xhp36 xhn36 vdd vbsyn gsyn
X_ihx_49_36 a_xp49 a_xn49 wp_ih_49_36 wn_ih_49_36 xhp36 xhn36 vdd vbsyn gsyn
X_ihx_50_36 a_xp50 a_xn50 wp_ih_50_36 wn_ih_50_36 xhp36 xhn36 vdd vbsyn gsyn
X_ihx_51_36 a_xp51 a_xn51 wp_ih_51_36 wn_ih_51_36 xhp36 xhn36 vdd vbsyn gsyn
X_ihx_52_36 a_xp52 a_xn52 wp_ih_52_36 wn_ih_52_36 xhp36 xhn36 vdd vbsyn gsyn
X_ihx_53_36 a_xp53 a_xn53 wp_ih_53_36 wn_ih_53_36 xhp36 xhn36 vdd vbsyn gsyn
X_ihx_54_36 a_xp54 a_xn54 wp_ih_54_36 wn_ih_54_36 xhp36 xhn36 vdd vbsyn gsyn
X_ihx_55_36 a_xp55 a_xn55 wp_ih_55_36 wn_ih_55_36 xhp36 xhn36 vdd vbsyn gsyn
X_ihx_56_36 a_xp56 a_xn56 wp_ih_56_36 wn_ih_56_36 xhp36 xhn36 vdd vbsyn gsyn
X_ihx_57_36 a_xp57 a_xn57 wp_ih_57_36 wn_ih_57_36 xhp36 xhn36 vdd vbsyn gsyn
X_ihx_58_36 a_xp58 a_xn58 wp_ih_58_36 wn_ih_58_36 xhp36 xhn36 vdd vbsyn gsyn
X_ihx_59_36 a_xp59 a_xn59 wp_ih_59_36 wn_ih_59_36 xhp36 xhn36 vdd vbsyn gsyn
X_ihx_60_36 a_xp60 a_xn60 wp_ih_60_36 wn_ih_60_36 xhp36 xhn36 vdd vbsyn gsyn
X_ihx_61_36 a_xp61 a_xn61 wp_ih_61_36 wn_ih_61_36 xhp36 xhn36 vdd vbsyn gsyn
X_ihx_62_36 a_xp62 a_xn62 wp_ih_62_36 wn_ih_62_36 xhp36 xhn36 vdd vbsyn gsyn
X_ihx_63_36 a_xp63 a_xn63 wp_ih_63_36 wn_ih_63_36 xhp36 xhn36 vdd vbsyn gsyn
Xn36 xhp36 xhn36 ahp36 ahn36 vdd vbneu dneuron
Xcm_xh37 xhp37 xhn37 vdd cmld
Rnd_xh37 xhp37 xhn37 20k
X_ihx_0_37 a_xp0 a_xn0 wp_ih_0_37 wn_ih_0_37 xhp37 xhn37 vdd vbsyn gsyn
X_ihx_1_37 a_xp1 a_xn1 wp_ih_1_37 wn_ih_1_37 xhp37 xhn37 vdd vbsyn gsyn
X_ihx_2_37 a_xp2 a_xn2 wp_ih_2_37 wn_ih_2_37 xhp37 xhn37 vdd vbsyn gsyn
X_ihx_3_37 a_xp3 a_xn3 wp_ih_3_37 wn_ih_3_37 xhp37 xhn37 vdd vbsyn gsyn
X_ihx_4_37 a_xp4 a_xn4 wp_ih_4_37 wn_ih_4_37 xhp37 xhn37 vdd vbsyn gsyn
X_ihx_5_37 a_xp5 a_xn5 wp_ih_5_37 wn_ih_5_37 xhp37 xhn37 vdd vbsyn gsyn
X_ihx_6_37 a_xp6 a_xn6 wp_ih_6_37 wn_ih_6_37 xhp37 xhn37 vdd vbsyn gsyn
X_ihx_7_37 a_xp7 a_xn7 wp_ih_7_37 wn_ih_7_37 xhp37 xhn37 vdd vbsyn gsyn
X_ihx_8_37 a_xp8 a_xn8 wp_ih_8_37 wn_ih_8_37 xhp37 xhn37 vdd vbsyn gsyn
X_ihx_9_37 a_xp9 a_xn9 wp_ih_9_37 wn_ih_9_37 xhp37 xhn37 vdd vbsyn gsyn
X_ihx_10_37 a_xp10 a_xn10 wp_ih_10_37 wn_ih_10_37 xhp37 xhn37 vdd vbsyn gsyn
X_ihx_11_37 a_xp11 a_xn11 wp_ih_11_37 wn_ih_11_37 xhp37 xhn37 vdd vbsyn gsyn
X_ihx_12_37 a_xp12 a_xn12 wp_ih_12_37 wn_ih_12_37 xhp37 xhn37 vdd vbsyn gsyn
X_ihx_13_37 a_xp13 a_xn13 wp_ih_13_37 wn_ih_13_37 xhp37 xhn37 vdd vbsyn gsyn
X_ihx_14_37 a_xp14 a_xn14 wp_ih_14_37 wn_ih_14_37 xhp37 xhn37 vdd vbsyn gsyn
X_ihx_15_37 a_xp15 a_xn15 wp_ih_15_37 wn_ih_15_37 xhp37 xhn37 vdd vbsyn gsyn
X_ihx_16_37 a_xp16 a_xn16 wp_ih_16_37 wn_ih_16_37 xhp37 xhn37 vdd vbsyn gsyn
X_ihx_17_37 a_xp17 a_xn17 wp_ih_17_37 wn_ih_17_37 xhp37 xhn37 vdd vbsyn gsyn
X_ihx_18_37 a_xp18 a_xn18 wp_ih_18_37 wn_ih_18_37 xhp37 xhn37 vdd vbsyn gsyn
X_ihx_19_37 a_xp19 a_xn19 wp_ih_19_37 wn_ih_19_37 xhp37 xhn37 vdd vbsyn gsyn
X_ihx_20_37 a_xp20 a_xn20 wp_ih_20_37 wn_ih_20_37 xhp37 xhn37 vdd vbsyn gsyn
X_ihx_21_37 a_xp21 a_xn21 wp_ih_21_37 wn_ih_21_37 xhp37 xhn37 vdd vbsyn gsyn
X_ihx_22_37 a_xp22 a_xn22 wp_ih_22_37 wn_ih_22_37 xhp37 xhn37 vdd vbsyn gsyn
X_ihx_23_37 a_xp23 a_xn23 wp_ih_23_37 wn_ih_23_37 xhp37 xhn37 vdd vbsyn gsyn
X_ihx_24_37 a_xp24 a_xn24 wp_ih_24_37 wn_ih_24_37 xhp37 xhn37 vdd vbsyn gsyn
X_ihx_25_37 a_xp25 a_xn25 wp_ih_25_37 wn_ih_25_37 xhp37 xhn37 vdd vbsyn gsyn
X_ihx_26_37 a_xp26 a_xn26 wp_ih_26_37 wn_ih_26_37 xhp37 xhn37 vdd vbsyn gsyn
X_ihx_27_37 a_xp27 a_xn27 wp_ih_27_37 wn_ih_27_37 xhp37 xhn37 vdd vbsyn gsyn
X_ihx_28_37 a_xp28 a_xn28 wp_ih_28_37 wn_ih_28_37 xhp37 xhn37 vdd vbsyn gsyn
X_ihx_29_37 a_xp29 a_xn29 wp_ih_29_37 wn_ih_29_37 xhp37 xhn37 vdd vbsyn gsyn
X_ihx_30_37 a_xp30 a_xn30 wp_ih_30_37 wn_ih_30_37 xhp37 xhn37 vdd vbsyn gsyn
X_ihx_31_37 a_xp31 a_xn31 wp_ih_31_37 wn_ih_31_37 xhp37 xhn37 vdd vbsyn gsyn
X_ihx_32_37 a_xp32 a_xn32 wp_ih_32_37 wn_ih_32_37 xhp37 xhn37 vdd vbsyn gsyn
X_ihx_33_37 a_xp33 a_xn33 wp_ih_33_37 wn_ih_33_37 xhp37 xhn37 vdd vbsyn gsyn
X_ihx_34_37 a_xp34 a_xn34 wp_ih_34_37 wn_ih_34_37 xhp37 xhn37 vdd vbsyn gsyn
X_ihx_35_37 a_xp35 a_xn35 wp_ih_35_37 wn_ih_35_37 xhp37 xhn37 vdd vbsyn gsyn
X_ihx_36_37 a_xp36 a_xn36 wp_ih_36_37 wn_ih_36_37 xhp37 xhn37 vdd vbsyn gsyn
X_ihx_37_37 a_xp37 a_xn37 wp_ih_37_37 wn_ih_37_37 xhp37 xhn37 vdd vbsyn gsyn
X_ihx_38_37 a_xp38 a_xn38 wp_ih_38_37 wn_ih_38_37 xhp37 xhn37 vdd vbsyn gsyn
X_ihx_39_37 a_xp39 a_xn39 wp_ih_39_37 wn_ih_39_37 xhp37 xhn37 vdd vbsyn gsyn
X_ihx_40_37 a_xp40 a_xn40 wp_ih_40_37 wn_ih_40_37 xhp37 xhn37 vdd vbsyn gsyn
X_ihx_41_37 a_xp41 a_xn41 wp_ih_41_37 wn_ih_41_37 xhp37 xhn37 vdd vbsyn gsyn
X_ihx_42_37 a_xp42 a_xn42 wp_ih_42_37 wn_ih_42_37 xhp37 xhn37 vdd vbsyn gsyn
X_ihx_43_37 a_xp43 a_xn43 wp_ih_43_37 wn_ih_43_37 xhp37 xhn37 vdd vbsyn gsyn
X_ihx_44_37 a_xp44 a_xn44 wp_ih_44_37 wn_ih_44_37 xhp37 xhn37 vdd vbsyn gsyn
X_ihx_45_37 a_xp45 a_xn45 wp_ih_45_37 wn_ih_45_37 xhp37 xhn37 vdd vbsyn gsyn
X_ihx_46_37 a_xp46 a_xn46 wp_ih_46_37 wn_ih_46_37 xhp37 xhn37 vdd vbsyn gsyn
X_ihx_47_37 a_xp47 a_xn47 wp_ih_47_37 wn_ih_47_37 xhp37 xhn37 vdd vbsyn gsyn
X_ihx_48_37 a_xp48 a_xn48 wp_ih_48_37 wn_ih_48_37 xhp37 xhn37 vdd vbsyn gsyn
X_ihx_49_37 a_xp49 a_xn49 wp_ih_49_37 wn_ih_49_37 xhp37 xhn37 vdd vbsyn gsyn
X_ihx_50_37 a_xp50 a_xn50 wp_ih_50_37 wn_ih_50_37 xhp37 xhn37 vdd vbsyn gsyn
X_ihx_51_37 a_xp51 a_xn51 wp_ih_51_37 wn_ih_51_37 xhp37 xhn37 vdd vbsyn gsyn
X_ihx_52_37 a_xp52 a_xn52 wp_ih_52_37 wn_ih_52_37 xhp37 xhn37 vdd vbsyn gsyn
X_ihx_53_37 a_xp53 a_xn53 wp_ih_53_37 wn_ih_53_37 xhp37 xhn37 vdd vbsyn gsyn
X_ihx_54_37 a_xp54 a_xn54 wp_ih_54_37 wn_ih_54_37 xhp37 xhn37 vdd vbsyn gsyn
X_ihx_55_37 a_xp55 a_xn55 wp_ih_55_37 wn_ih_55_37 xhp37 xhn37 vdd vbsyn gsyn
X_ihx_56_37 a_xp56 a_xn56 wp_ih_56_37 wn_ih_56_37 xhp37 xhn37 vdd vbsyn gsyn
X_ihx_57_37 a_xp57 a_xn57 wp_ih_57_37 wn_ih_57_37 xhp37 xhn37 vdd vbsyn gsyn
X_ihx_58_37 a_xp58 a_xn58 wp_ih_58_37 wn_ih_58_37 xhp37 xhn37 vdd vbsyn gsyn
X_ihx_59_37 a_xp59 a_xn59 wp_ih_59_37 wn_ih_59_37 xhp37 xhn37 vdd vbsyn gsyn
X_ihx_60_37 a_xp60 a_xn60 wp_ih_60_37 wn_ih_60_37 xhp37 xhn37 vdd vbsyn gsyn
X_ihx_61_37 a_xp61 a_xn61 wp_ih_61_37 wn_ih_61_37 xhp37 xhn37 vdd vbsyn gsyn
X_ihx_62_37 a_xp62 a_xn62 wp_ih_62_37 wn_ih_62_37 xhp37 xhn37 vdd vbsyn gsyn
X_ihx_63_37 a_xp63 a_xn63 wp_ih_63_37 wn_ih_63_37 xhp37 xhn37 vdd vbsyn gsyn
Xn37 xhp37 xhn37 ahp37 ahn37 vdd vbneu dneuron
Xcm_xh38 xhp38 xhn38 vdd cmld
Rnd_xh38 xhp38 xhn38 20k
X_ihx_0_38 a_xp0 a_xn0 wp_ih_0_38 wn_ih_0_38 xhp38 xhn38 vdd vbsyn gsyn
X_ihx_1_38 a_xp1 a_xn1 wp_ih_1_38 wn_ih_1_38 xhp38 xhn38 vdd vbsyn gsyn
X_ihx_2_38 a_xp2 a_xn2 wp_ih_2_38 wn_ih_2_38 xhp38 xhn38 vdd vbsyn gsyn
X_ihx_3_38 a_xp3 a_xn3 wp_ih_3_38 wn_ih_3_38 xhp38 xhn38 vdd vbsyn gsyn
X_ihx_4_38 a_xp4 a_xn4 wp_ih_4_38 wn_ih_4_38 xhp38 xhn38 vdd vbsyn gsyn
X_ihx_5_38 a_xp5 a_xn5 wp_ih_5_38 wn_ih_5_38 xhp38 xhn38 vdd vbsyn gsyn
X_ihx_6_38 a_xp6 a_xn6 wp_ih_6_38 wn_ih_6_38 xhp38 xhn38 vdd vbsyn gsyn
X_ihx_7_38 a_xp7 a_xn7 wp_ih_7_38 wn_ih_7_38 xhp38 xhn38 vdd vbsyn gsyn
X_ihx_8_38 a_xp8 a_xn8 wp_ih_8_38 wn_ih_8_38 xhp38 xhn38 vdd vbsyn gsyn
X_ihx_9_38 a_xp9 a_xn9 wp_ih_9_38 wn_ih_9_38 xhp38 xhn38 vdd vbsyn gsyn
X_ihx_10_38 a_xp10 a_xn10 wp_ih_10_38 wn_ih_10_38 xhp38 xhn38 vdd vbsyn gsyn
X_ihx_11_38 a_xp11 a_xn11 wp_ih_11_38 wn_ih_11_38 xhp38 xhn38 vdd vbsyn gsyn
X_ihx_12_38 a_xp12 a_xn12 wp_ih_12_38 wn_ih_12_38 xhp38 xhn38 vdd vbsyn gsyn
X_ihx_13_38 a_xp13 a_xn13 wp_ih_13_38 wn_ih_13_38 xhp38 xhn38 vdd vbsyn gsyn
X_ihx_14_38 a_xp14 a_xn14 wp_ih_14_38 wn_ih_14_38 xhp38 xhn38 vdd vbsyn gsyn
X_ihx_15_38 a_xp15 a_xn15 wp_ih_15_38 wn_ih_15_38 xhp38 xhn38 vdd vbsyn gsyn
X_ihx_16_38 a_xp16 a_xn16 wp_ih_16_38 wn_ih_16_38 xhp38 xhn38 vdd vbsyn gsyn
X_ihx_17_38 a_xp17 a_xn17 wp_ih_17_38 wn_ih_17_38 xhp38 xhn38 vdd vbsyn gsyn
X_ihx_18_38 a_xp18 a_xn18 wp_ih_18_38 wn_ih_18_38 xhp38 xhn38 vdd vbsyn gsyn
X_ihx_19_38 a_xp19 a_xn19 wp_ih_19_38 wn_ih_19_38 xhp38 xhn38 vdd vbsyn gsyn
X_ihx_20_38 a_xp20 a_xn20 wp_ih_20_38 wn_ih_20_38 xhp38 xhn38 vdd vbsyn gsyn
X_ihx_21_38 a_xp21 a_xn21 wp_ih_21_38 wn_ih_21_38 xhp38 xhn38 vdd vbsyn gsyn
X_ihx_22_38 a_xp22 a_xn22 wp_ih_22_38 wn_ih_22_38 xhp38 xhn38 vdd vbsyn gsyn
X_ihx_23_38 a_xp23 a_xn23 wp_ih_23_38 wn_ih_23_38 xhp38 xhn38 vdd vbsyn gsyn
X_ihx_24_38 a_xp24 a_xn24 wp_ih_24_38 wn_ih_24_38 xhp38 xhn38 vdd vbsyn gsyn
X_ihx_25_38 a_xp25 a_xn25 wp_ih_25_38 wn_ih_25_38 xhp38 xhn38 vdd vbsyn gsyn
X_ihx_26_38 a_xp26 a_xn26 wp_ih_26_38 wn_ih_26_38 xhp38 xhn38 vdd vbsyn gsyn
X_ihx_27_38 a_xp27 a_xn27 wp_ih_27_38 wn_ih_27_38 xhp38 xhn38 vdd vbsyn gsyn
X_ihx_28_38 a_xp28 a_xn28 wp_ih_28_38 wn_ih_28_38 xhp38 xhn38 vdd vbsyn gsyn
X_ihx_29_38 a_xp29 a_xn29 wp_ih_29_38 wn_ih_29_38 xhp38 xhn38 vdd vbsyn gsyn
X_ihx_30_38 a_xp30 a_xn30 wp_ih_30_38 wn_ih_30_38 xhp38 xhn38 vdd vbsyn gsyn
X_ihx_31_38 a_xp31 a_xn31 wp_ih_31_38 wn_ih_31_38 xhp38 xhn38 vdd vbsyn gsyn
X_ihx_32_38 a_xp32 a_xn32 wp_ih_32_38 wn_ih_32_38 xhp38 xhn38 vdd vbsyn gsyn
X_ihx_33_38 a_xp33 a_xn33 wp_ih_33_38 wn_ih_33_38 xhp38 xhn38 vdd vbsyn gsyn
X_ihx_34_38 a_xp34 a_xn34 wp_ih_34_38 wn_ih_34_38 xhp38 xhn38 vdd vbsyn gsyn
X_ihx_35_38 a_xp35 a_xn35 wp_ih_35_38 wn_ih_35_38 xhp38 xhn38 vdd vbsyn gsyn
X_ihx_36_38 a_xp36 a_xn36 wp_ih_36_38 wn_ih_36_38 xhp38 xhn38 vdd vbsyn gsyn
X_ihx_37_38 a_xp37 a_xn37 wp_ih_37_38 wn_ih_37_38 xhp38 xhn38 vdd vbsyn gsyn
X_ihx_38_38 a_xp38 a_xn38 wp_ih_38_38 wn_ih_38_38 xhp38 xhn38 vdd vbsyn gsyn
X_ihx_39_38 a_xp39 a_xn39 wp_ih_39_38 wn_ih_39_38 xhp38 xhn38 vdd vbsyn gsyn
X_ihx_40_38 a_xp40 a_xn40 wp_ih_40_38 wn_ih_40_38 xhp38 xhn38 vdd vbsyn gsyn
X_ihx_41_38 a_xp41 a_xn41 wp_ih_41_38 wn_ih_41_38 xhp38 xhn38 vdd vbsyn gsyn
X_ihx_42_38 a_xp42 a_xn42 wp_ih_42_38 wn_ih_42_38 xhp38 xhn38 vdd vbsyn gsyn
X_ihx_43_38 a_xp43 a_xn43 wp_ih_43_38 wn_ih_43_38 xhp38 xhn38 vdd vbsyn gsyn
X_ihx_44_38 a_xp44 a_xn44 wp_ih_44_38 wn_ih_44_38 xhp38 xhn38 vdd vbsyn gsyn
X_ihx_45_38 a_xp45 a_xn45 wp_ih_45_38 wn_ih_45_38 xhp38 xhn38 vdd vbsyn gsyn
X_ihx_46_38 a_xp46 a_xn46 wp_ih_46_38 wn_ih_46_38 xhp38 xhn38 vdd vbsyn gsyn
X_ihx_47_38 a_xp47 a_xn47 wp_ih_47_38 wn_ih_47_38 xhp38 xhn38 vdd vbsyn gsyn
X_ihx_48_38 a_xp48 a_xn48 wp_ih_48_38 wn_ih_48_38 xhp38 xhn38 vdd vbsyn gsyn
X_ihx_49_38 a_xp49 a_xn49 wp_ih_49_38 wn_ih_49_38 xhp38 xhn38 vdd vbsyn gsyn
X_ihx_50_38 a_xp50 a_xn50 wp_ih_50_38 wn_ih_50_38 xhp38 xhn38 vdd vbsyn gsyn
X_ihx_51_38 a_xp51 a_xn51 wp_ih_51_38 wn_ih_51_38 xhp38 xhn38 vdd vbsyn gsyn
X_ihx_52_38 a_xp52 a_xn52 wp_ih_52_38 wn_ih_52_38 xhp38 xhn38 vdd vbsyn gsyn
X_ihx_53_38 a_xp53 a_xn53 wp_ih_53_38 wn_ih_53_38 xhp38 xhn38 vdd vbsyn gsyn
X_ihx_54_38 a_xp54 a_xn54 wp_ih_54_38 wn_ih_54_38 xhp38 xhn38 vdd vbsyn gsyn
X_ihx_55_38 a_xp55 a_xn55 wp_ih_55_38 wn_ih_55_38 xhp38 xhn38 vdd vbsyn gsyn
X_ihx_56_38 a_xp56 a_xn56 wp_ih_56_38 wn_ih_56_38 xhp38 xhn38 vdd vbsyn gsyn
X_ihx_57_38 a_xp57 a_xn57 wp_ih_57_38 wn_ih_57_38 xhp38 xhn38 vdd vbsyn gsyn
X_ihx_58_38 a_xp58 a_xn58 wp_ih_58_38 wn_ih_58_38 xhp38 xhn38 vdd vbsyn gsyn
X_ihx_59_38 a_xp59 a_xn59 wp_ih_59_38 wn_ih_59_38 xhp38 xhn38 vdd vbsyn gsyn
X_ihx_60_38 a_xp60 a_xn60 wp_ih_60_38 wn_ih_60_38 xhp38 xhn38 vdd vbsyn gsyn
X_ihx_61_38 a_xp61 a_xn61 wp_ih_61_38 wn_ih_61_38 xhp38 xhn38 vdd vbsyn gsyn
X_ihx_62_38 a_xp62 a_xn62 wp_ih_62_38 wn_ih_62_38 xhp38 xhn38 vdd vbsyn gsyn
X_ihx_63_38 a_xp63 a_xn63 wp_ih_63_38 wn_ih_63_38 xhp38 xhn38 vdd vbsyn gsyn
Xn38 xhp38 xhn38 ahp38 ahn38 vdd vbneu dneuron
Xcm_xh39 xhp39 xhn39 vdd cmld
Rnd_xh39 xhp39 xhn39 20k
X_ihx_0_39 a_xp0 a_xn0 wp_ih_0_39 wn_ih_0_39 xhp39 xhn39 vdd vbsyn gsyn
X_ihx_1_39 a_xp1 a_xn1 wp_ih_1_39 wn_ih_1_39 xhp39 xhn39 vdd vbsyn gsyn
X_ihx_2_39 a_xp2 a_xn2 wp_ih_2_39 wn_ih_2_39 xhp39 xhn39 vdd vbsyn gsyn
X_ihx_3_39 a_xp3 a_xn3 wp_ih_3_39 wn_ih_3_39 xhp39 xhn39 vdd vbsyn gsyn
X_ihx_4_39 a_xp4 a_xn4 wp_ih_4_39 wn_ih_4_39 xhp39 xhn39 vdd vbsyn gsyn
X_ihx_5_39 a_xp5 a_xn5 wp_ih_5_39 wn_ih_5_39 xhp39 xhn39 vdd vbsyn gsyn
X_ihx_6_39 a_xp6 a_xn6 wp_ih_6_39 wn_ih_6_39 xhp39 xhn39 vdd vbsyn gsyn
X_ihx_7_39 a_xp7 a_xn7 wp_ih_7_39 wn_ih_7_39 xhp39 xhn39 vdd vbsyn gsyn
X_ihx_8_39 a_xp8 a_xn8 wp_ih_8_39 wn_ih_8_39 xhp39 xhn39 vdd vbsyn gsyn
X_ihx_9_39 a_xp9 a_xn9 wp_ih_9_39 wn_ih_9_39 xhp39 xhn39 vdd vbsyn gsyn
X_ihx_10_39 a_xp10 a_xn10 wp_ih_10_39 wn_ih_10_39 xhp39 xhn39 vdd vbsyn gsyn
X_ihx_11_39 a_xp11 a_xn11 wp_ih_11_39 wn_ih_11_39 xhp39 xhn39 vdd vbsyn gsyn
X_ihx_12_39 a_xp12 a_xn12 wp_ih_12_39 wn_ih_12_39 xhp39 xhn39 vdd vbsyn gsyn
X_ihx_13_39 a_xp13 a_xn13 wp_ih_13_39 wn_ih_13_39 xhp39 xhn39 vdd vbsyn gsyn
X_ihx_14_39 a_xp14 a_xn14 wp_ih_14_39 wn_ih_14_39 xhp39 xhn39 vdd vbsyn gsyn
X_ihx_15_39 a_xp15 a_xn15 wp_ih_15_39 wn_ih_15_39 xhp39 xhn39 vdd vbsyn gsyn
X_ihx_16_39 a_xp16 a_xn16 wp_ih_16_39 wn_ih_16_39 xhp39 xhn39 vdd vbsyn gsyn
X_ihx_17_39 a_xp17 a_xn17 wp_ih_17_39 wn_ih_17_39 xhp39 xhn39 vdd vbsyn gsyn
X_ihx_18_39 a_xp18 a_xn18 wp_ih_18_39 wn_ih_18_39 xhp39 xhn39 vdd vbsyn gsyn
X_ihx_19_39 a_xp19 a_xn19 wp_ih_19_39 wn_ih_19_39 xhp39 xhn39 vdd vbsyn gsyn
X_ihx_20_39 a_xp20 a_xn20 wp_ih_20_39 wn_ih_20_39 xhp39 xhn39 vdd vbsyn gsyn
X_ihx_21_39 a_xp21 a_xn21 wp_ih_21_39 wn_ih_21_39 xhp39 xhn39 vdd vbsyn gsyn
X_ihx_22_39 a_xp22 a_xn22 wp_ih_22_39 wn_ih_22_39 xhp39 xhn39 vdd vbsyn gsyn
X_ihx_23_39 a_xp23 a_xn23 wp_ih_23_39 wn_ih_23_39 xhp39 xhn39 vdd vbsyn gsyn
X_ihx_24_39 a_xp24 a_xn24 wp_ih_24_39 wn_ih_24_39 xhp39 xhn39 vdd vbsyn gsyn
X_ihx_25_39 a_xp25 a_xn25 wp_ih_25_39 wn_ih_25_39 xhp39 xhn39 vdd vbsyn gsyn
X_ihx_26_39 a_xp26 a_xn26 wp_ih_26_39 wn_ih_26_39 xhp39 xhn39 vdd vbsyn gsyn
X_ihx_27_39 a_xp27 a_xn27 wp_ih_27_39 wn_ih_27_39 xhp39 xhn39 vdd vbsyn gsyn
X_ihx_28_39 a_xp28 a_xn28 wp_ih_28_39 wn_ih_28_39 xhp39 xhn39 vdd vbsyn gsyn
X_ihx_29_39 a_xp29 a_xn29 wp_ih_29_39 wn_ih_29_39 xhp39 xhn39 vdd vbsyn gsyn
X_ihx_30_39 a_xp30 a_xn30 wp_ih_30_39 wn_ih_30_39 xhp39 xhn39 vdd vbsyn gsyn
X_ihx_31_39 a_xp31 a_xn31 wp_ih_31_39 wn_ih_31_39 xhp39 xhn39 vdd vbsyn gsyn
X_ihx_32_39 a_xp32 a_xn32 wp_ih_32_39 wn_ih_32_39 xhp39 xhn39 vdd vbsyn gsyn
X_ihx_33_39 a_xp33 a_xn33 wp_ih_33_39 wn_ih_33_39 xhp39 xhn39 vdd vbsyn gsyn
X_ihx_34_39 a_xp34 a_xn34 wp_ih_34_39 wn_ih_34_39 xhp39 xhn39 vdd vbsyn gsyn
X_ihx_35_39 a_xp35 a_xn35 wp_ih_35_39 wn_ih_35_39 xhp39 xhn39 vdd vbsyn gsyn
X_ihx_36_39 a_xp36 a_xn36 wp_ih_36_39 wn_ih_36_39 xhp39 xhn39 vdd vbsyn gsyn
X_ihx_37_39 a_xp37 a_xn37 wp_ih_37_39 wn_ih_37_39 xhp39 xhn39 vdd vbsyn gsyn
X_ihx_38_39 a_xp38 a_xn38 wp_ih_38_39 wn_ih_38_39 xhp39 xhn39 vdd vbsyn gsyn
X_ihx_39_39 a_xp39 a_xn39 wp_ih_39_39 wn_ih_39_39 xhp39 xhn39 vdd vbsyn gsyn
X_ihx_40_39 a_xp40 a_xn40 wp_ih_40_39 wn_ih_40_39 xhp39 xhn39 vdd vbsyn gsyn
X_ihx_41_39 a_xp41 a_xn41 wp_ih_41_39 wn_ih_41_39 xhp39 xhn39 vdd vbsyn gsyn
X_ihx_42_39 a_xp42 a_xn42 wp_ih_42_39 wn_ih_42_39 xhp39 xhn39 vdd vbsyn gsyn
X_ihx_43_39 a_xp43 a_xn43 wp_ih_43_39 wn_ih_43_39 xhp39 xhn39 vdd vbsyn gsyn
X_ihx_44_39 a_xp44 a_xn44 wp_ih_44_39 wn_ih_44_39 xhp39 xhn39 vdd vbsyn gsyn
X_ihx_45_39 a_xp45 a_xn45 wp_ih_45_39 wn_ih_45_39 xhp39 xhn39 vdd vbsyn gsyn
X_ihx_46_39 a_xp46 a_xn46 wp_ih_46_39 wn_ih_46_39 xhp39 xhn39 vdd vbsyn gsyn
X_ihx_47_39 a_xp47 a_xn47 wp_ih_47_39 wn_ih_47_39 xhp39 xhn39 vdd vbsyn gsyn
X_ihx_48_39 a_xp48 a_xn48 wp_ih_48_39 wn_ih_48_39 xhp39 xhn39 vdd vbsyn gsyn
X_ihx_49_39 a_xp49 a_xn49 wp_ih_49_39 wn_ih_49_39 xhp39 xhn39 vdd vbsyn gsyn
X_ihx_50_39 a_xp50 a_xn50 wp_ih_50_39 wn_ih_50_39 xhp39 xhn39 vdd vbsyn gsyn
X_ihx_51_39 a_xp51 a_xn51 wp_ih_51_39 wn_ih_51_39 xhp39 xhn39 vdd vbsyn gsyn
X_ihx_52_39 a_xp52 a_xn52 wp_ih_52_39 wn_ih_52_39 xhp39 xhn39 vdd vbsyn gsyn
X_ihx_53_39 a_xp53 a_xn53 wp_ih_53_39 wn_ih_53_39 xhp39 xhn39 vdd vbsyn gsyn
X_ihx_54_39 a_xp54 a_xn54 wp_ih_54_39 wn_ih_54_39 xhp39 xhn39 vdd vbsyn gsyn
X_ihx_55_39 a_xp55 a_xn55 wp_ih_55_39 wn_ih_55_39 xhp39 xhn39 vdd vbsyn gsyn
X_ihx_56_39 a_xp56 a_xn56 wp_ih_56_39 wn_ih_56_39 xhp39 xhn39 vdd vbsyn gsyn
X_ihx_57_39 a_xp57 a_xn57 wp_ih_57_39 wn_ih_57_39 xhp39 xhn39 vdd vbsyn gsyn
X_ihx_58_39 a_xp58 a_xn58 wp_ih_58_39 wn_ih_58_39 xhp39 xhn39 vdd vbsyn gsyn
X_ihx_59_39 a_xp59 a_xn59 wp_ih_59_39 wn_ih_59_39 xhp39 xhn39 vdd vbsyn gsyn
X_ihx_60_39 a_xp60 a_xn60 wp_ih_60_39 wn_ih_60_39 xhp39 xhn39 vdd vbsyn gsyn
X_ihx_61_39 a_xp61 a_xn61 wp_ih_61_39 wn_ih_61_39 xhp39 xhn39 vdd vbsyn gsyn
X_ihx_62_39 a_xp62 a_xn62 wp_ih_62_39 wn_ih_62_39 xhp39 xhn39 vdd vbsyn gsyn
X_ihx_63_39 a_xp63 a_xn63 wp_ih_63_39 wn_ih_63_39 xhp39 xhn39 vdd vbsyn gsyn
Xn39 xhp39 xhn39 ahp39 ahn39 vdd vbneu dneuron
Xcm_mo0 mop0 mon0 vdd cmld
Rnd_mo0 mop0 mon0 20k
X_ho_0_0 ahp0 ahn0 wp_ho_0_0 wn_ho_0_0 mop0 mon0 vdd vbsyn gsyn
X_ho_1_0 ahp1 ahn1 wp_ho_1_0 wn_ho_1_0 mop0 mon0 vdd vbsyn gsyn
X_ho_2_0 ahp2 ahn2 wp_ho_2_0 wn_ho_2_0 mop0 mon0 vdd vbsyn gsyn
X_ho_3_0 ahp3 ahn3 wp_ho_3_0 wn_ho_3_0 mop0 mon0 vdd vbsyn gsyn
X_ho_4_0 ahp4 ahn4 wp_ho_4_0 wn_ho_4_0 mop0 mon0 vdd vbsyn gsyn
X_ho_5_0 ahp5 ahn5 wp_ho_5_0 wn_ho_5_0 mop0 mon0 vdd vbsyn gsyn
X_ho_6_0 ahp6 ahn6 wp_ho_6_0 wn_ho_6_0 mop0 mon0 vdd vbsyn gsyn
X_ho_7_0 ahp7 ahn7 wp_ho_7_0 wn_ho_7_0 mop0 mon0 vdd vbsyn gsyn
X_ho_8_0 ahp8 ahn8 wp_ho_8_0 wn_ho_8_0 mop0 mon0 vdd vbsyn gsyn
X_ho_9_0 ahp9 ahn9 wp_ho_9_0 wn_ho_9_0 mop0 mon0 vdd vbsyn gsyn
X_ho_10_0 ahp10 ahn10 wp_ho_10_0 wn_ho_10_0 mop0 mon0 vdd vbsyn gsyn
X_ho_11_0 ahp11 ahn11 wp_ho_11_0 wn_ho_11_0 mop0 mon0 vdd vbsyn gsyn
X_ho_12_0 ahp12 ahn12 wp_ho_12_0 wn_ho_12_0 mop0 mon0 vdd vbsyn gsyn
X_ho_13_0 ahp13 ahn13 wp_ho_13_0 wn_ho_13_0 mop0 mon0 vdd vbsyn gsyn
X_ho_14_0 ahp14 ahn14 wp_ho_14_0 wn_ho_14_0 mop0 mon0 vdd vbsyn gsyn
X_ho_15_0 ahp15 ahn15 wp_ho_15_0 wn_ho_15_0 mop0 mon0 vdd vbsyn gsyn
X_ho_16_0 ahp16 ahn16 wp_ho_16_0 wn_ho_16_0 mop0 mon0 vdd vbsyn gsyn
X_ho_17_0 ahp17 ahn17 wp_ho_17_0 wn_ho_17_0 mop0 mon0 vdd vbsyn gsyn
X_ho_18_0 ahp18 ahn18 wp_ho_18_0 wn_ho_18_0 mop0 mon0 vdd vbsyn gsyn
X_ho_19_0 ahp19 ahn19 wp_ho_19_0 wn_ho_19_0 mop0 mon0 vdd vbsyn gsyn
X_ho_20_0 ahp20 ahn20 wp_ho_20_0 wn_ho_20_0 mop0 mon0 vdd vbsyn gsyn
X_ho_21_0 ahp21 ahn21 wp_ho_21_0 wn_ho_21_0 mop0 mon0 vdd vbsyn gsyn
X_ho_22_0 ahp22 ahn22 wp_ho_22_0 wn_ho_22_0 mop0 mon0 vdd vbsyn gsyn
X_ho_23_0 ahp23 ahn23 wp_ho_23_0 wn_ho_23_0 mop0 mon0 vdd vbsyn gsyn
X_ho_24_0 ahp24 ahn24 wp_ho_24_0 wn_ho_24_0 mop0 mon0 vdd vbsyn gsyn
X_ho_25_0 ahp25 ahn25 wp_ho_25_0 wn_ho_25_0 mop0 mon0 vdd vbsyn gsyn
X_ho_26_0 ahp26 ahn26 wp_ho_26_0 wn_ho_26_0 mop0 mon0 vdd vbsyn gsyn
X_ho_27_0 ahp27 ahn27 wp_ho_27_0 wn_ho_27_0 mop0 mon0 vdd vbsyn gsyn
X_ho_28_0 ahp28 ahn28 wp_ho_28_0 wn_ho_28_0 mop0 mon0 vdd vbsyn gsyn
X_ho_29_0 ahp29 ahn29 wp_ho_29_0 wn_ho_29_0 mop0 mon0 vdd vbsyn gsyn
X_ho_30_0 ahp30 ahn30 wp_ho_30_0 wn_ho_30_0 mop0 mon0 vdd vbsyn gsyn
X_ho_31_0 ahp31 ahn31 wp_ho_31_0 wn_ho_31_0 mop0 mon0 vdd vbsyn gsyn
X_ho_32_0 ahp32 ahn32 wp_ho_32_0 wn_ho_32_0 mop0 mon0 vdd vbsyn gsyn
X_ho_33_0 ahp33 ahn33 wp_ho_33_0 wn_ho_33_0 mop0 mon0 vdd vbsyn gsyn
X_ho_34_0 ahp34 ahn34 wp_ho_34_0 wn_ho_34_0 mop0 mon0 vdd vbsyn gsyn
X_ho_35_0 ahp35 ahn35 wp_ho_35_0 wn_ho_35_0 mop0 mon0 vdd vbsyn gsyn
X_ho_36_0 ahp36 ahn36 wp_ho_36_0 wn_ho_36_0 mop0 mon0 vdd vbsyn gsyn
X_ho_37_0 ahp37 ahn37 wp_ho_37_0 wn_ho_37_0 mop0 mon0 vdd vbsyn gsyn
X_ho_38_0 ahp38 ahn38 wp_ho_38_0 wn_ho_38_0 mop0 mon0 vdd vbsyn gsyn
X_ho_39_0 ahp39 ahn39 wp_ho_39_0 wn_ho_39_0 mop0 mon0 vdd vbsyn gsyn
Xcm_mo1 mop1 mon1 vdd cmld
Rnd_mo1 mop1 mon1 20k
X_ho_0_1 ahp0 ahn0 wp_ho_0_1 wn_ho_0_1 mop1 mon1 vdd vbsyn gsyn
X_ho_1_1 ahp1 ahn1 wp_ho_1_1 wn_ho_1_1 mop1 mon1 vdd vbsyn gsyn
X_ho_2_1 ahp2 ahn2 wp_ho_2_1 wn_ho_2_1 mop1 mon1 vdd vbsyn gsyn
X_ho_3_1 ahp3 ahn3 wp_ho_3_1 wn_ho_3_1 mop1 mon1 vdd vbsyn gsyn
X_ho_4_1 ahp4 ahn4 wp_ho_4_1 wn_ho_4_1 mop1 mon1 vdd vbsyn gsyn
X_ho_5_1 ahp5 ahn5 wp_ho_5_1 wn_ho_5_1 mop1 mon1 vdd vbsyn gsyn
X_ho_6_1 ahp6 ahn6 wp_ho_6_1 wn_ho_6_1 mop1 mon1 vdd vbsyn gsyn
X_ho_7_1 ahp7 ahn7 wp_ho_7_1 wn_ho_7_1 mop1 mon1 vdd vbsyn gsyn
X_ho_8_1 ahp8 ahn8 wp_ho_8_1 wn_ho_8_1 mop1 mon1 vdd vbsyn gsyn
X_ho_9_1 ahp9 ahn9 wp_ho_9_1 wn_ho_9_1 mop1 mon1 vdd vbsyn gsyn
X_ho_10_1 ahp10 ahn10 wp_ho_10_1 wn_ho_10_1 mop1 mon1 vdd vbsyn gsyn
X_ho_11_1 ahp11 ahn11 wp_ho_11_1 wn_ho_11_1 mop1 mon1 vdd vbsyn gsyn
X_ho_12_1 ahp12 ahn12 wp_ho_12_1 wn_ho_12_1 mop1 mon1 vdd vbsyn gsyn
X_ho_13_1 ahp13 ahn13 wp_ho_13_1 wn_ho_13_1 mop1 mon1 vdd vbsyn gsyn
X_ho_14_1 ahp14 ahn14 wp_ho_14_1 wn_ho_14_1 mop1 mon1 vdd vbsyn gsyn
X_ho_15_1 ahp15 ahn15 wp_ho_15_1 wn_ho_15_1 mop1 mon1 vdd vbsyn gsyn
X_ho_16_1 ahp16 ahn16 wp_ho_16_1 wn_ho_16_1 mop1 mon1 vdd vbsyn gsyn
X_ho_17_1 ahp17 ahn17 wp_ho_17_1 wn_ho_17_1 mop1 mon1 vdd vbsyn gsyn
X_ho_18_1 ahp18 ahn18 wp_ho_18_1 wn_ho_18_1 mop1 mon1 vdd vbsyn gsyn
X_ho_19_1 ahp19 ahn19 wp_ho_19_1 wn_ho_19_1 mop1 mon1 vdd vbsyn gsyn
X_ho_20_1 ahp20 ahn20 wp_ho_20_1 wn_ho_20_1 mop1 mon1 vdd vbsyn gsyn
X_ho_21_1 ahp21 ahn21 wp_ho_21_1 wn_ho_21_1 mop1 mon1 vdd vbsyn gsyn
X_ho_22_1 ahp22 ahn22 wp_ho_22_1 wn_ho_22_1 mop1 mon1 vdd vbsyn gsyn
X_ho_23_1 ahp23 ahn23 wp_ho_23_1 wn_ho_23_1 mop1 mon1 vdd vbsyn gsyn
X_ho_24_1 ahp24 ahn24 wp_ho_24_1 wn_ho_24_1 mop1 mon1 vdd vbsyn gsyn
X_ho_25_1 ahp25 ahn25 wp_ho_25_1 wn_ho_25_1 mop1 mon1 vdd vbsyn gsyn
X_ho_26_1 ahp26 ahn26 wp_ho_26_1 wn_ho_26_1 mop1 mon1 vdd vbsyn gsyn
X_ho_27_1 ahp27 ahn27 wp_ho_27_1 wn_ho_27_1 mop1 mon1 vdd vbsyn gsyn
X_ho_28_1 ahp28 ahn28 wp_ho_28_1 wn_ho_28_1 mop1 mon1 vdd vbsyn gsyn
X_ho_29_1 ahp29 ahn29 wp_ho_29_1 wn_ho_29_1 mop1 mon1 vdd vbsyn gsyn
X_ho_30_1 ahp30 ahn30 wp_ho_30_1 wn_ho_30_1 mop1 mon1 vdd vbsyn gsyn
X_ho_31_1 ahp31 ahn31 wp_ho_31_1 wn_ho_31_1 mop1 mon1 vdd vbsyn gsyn
X_ho_32_1 ahp32 ahn32 wp_ho_32_1 wn_ho_32_1 mop1 mon1 vdd vbsyn gsyn
X_ho_33_1 ahp33 ahn33 wp_ho_33_1 wn_ho_33_1 mop1 mon1 vdd vbsyn gsyn
X_ho_34_1 ahp34 ahn34 wp_ho_34_1 wn_ho_34_1 mop1 mon1 vdd vbsyn gsyn
X_ho_35_1 ahp35 ahn35 wp_ho_35_1 wn_ho_35_1 mop1 mon1 vdd vbsyn gsyn
X_ho_36_1 ahp36 ahn36 wp_ho_36_1 wn_ho_36_1 mop1 mon1 vdd vbsyn gsyn
X_ho_37_1 ahp37 ahn37 wp_ho_37_1 wn_ho_37_1 mop1 mon1 vdd vbsyn gsyn
X_ho_38_1 ahp38 ahn38 wp_ho_38_1 wn_ho_38_1 mop1 mon1 vdd vbsyn gsyn
X_ho_39_1 ahp39 ahn39 wp_ho_39_1 wn_ho_39_1 mop1 mon1 vdd vbsyn gsyn
Xcm_mo2 mop2 mon2 vdd cmld
Rnd_mo2 mop2 mon2 20k
X_ho_0_2 ahp0 ahn0 wp_ho_0_2 wn_ho_0_2 mop2 mon2 vdd vbsyn gsyn
X_ho_1_2 ahp1 ahn1 wp_ho_1_2 wn_ho_1_2 mop2 mon2 vdd vbsyn gsyn
X_ho_2_2 ahp2 ahn2 wp_ho_2_2 wn_ho_2_2 mop2 mon2 vdd vbsyn gsyn
X_ho_3_2 ahp3 ahn3 wp_ho_3_2 wn_ho_3_2 mop2 mon2 vdd vbsyn gsyn
X_ho_4_2 ahp4 ahn4 wp_ho_4_2 wn_ho_4_2 mop2 mon2 vdd vbsyn gsyn
X_ho_5_2 ahp5 ahn5 wp_ho_5_2 wn_ho_5_2 mop2 mon2 vdd vbsyn gsyn
X_ho_6_2 ahp6 ahn6 wp_ho_6_2 wn_ho_6_2 mop2 mon2 vdd vbsyn gsyn
X_ho_7_2 ahp7 ahn7 wp_ho_7_2 wn_ho_7_2 mop2 mon2 vdd vbsyn gsyn
X_ho_8_2 ahp8 ahn8 wp_ho_8_2 wn_ho_8_2 mop2 mon2 vdd vbsyn gsyn
X_ho_9_2 ahp9 ahn9 wp_ho_9_2 wn_ho_9_2 mop2 mon2 vdd vbsyn gsyn
X_ho_10_2 ahp10 ahn10 wp_ho_10_2 wn_ho_10_2 mop2 mon2 vdd vbsyn gsyn
X_ho_11_2 ahp11 ahn11 wp_ho_11_2 wn_ho_11_2 mop2 mon2 vdd vbsyn gsyn
X_ho_12_2 ahp12 ahn12 wp_ho_12_2 wn_ho_12_2 mop2 mon2 vdd vbsyn gsyn
X_ho_13_2 ahp13 ahn13 wp_ho_13_2 wn_ho_13_2 mop2 mon2 vdd vbsyn gsyn
X_ho_14_2 ahp14 ahn14 wp_ho_14_2 wn_ho_14_2 mop2 mon2 vdd vbsyn gsyn
X_ho_15_2 ahp15 ahn15 wp_ho_15_2 wn_ho_15_2 mop2 mon2 vdd vbsyn gsyn
X_ho_16_2 ahp16 ahn16 wp_ho_16_2 wn_ho_16_2 mop2 mon2 vdd vbsyn gsyn
X_ho_17_2 ahp17 ahn17 wp_ho_17_2 wn_ho_17_2 mop2 mon2 vdd vbsyn gsyn
X_ho_18_2 ahp18 ahn18 wp_ho_18_2 wn_ho_18_2 mop2 mon2 vdd vbsyn gsyn
X_ho_19_2 ahp19 ahn19 wp_ho_19_2 wn_ho_19_2 mop2 mon2 vdd vbsyn gsyn
X_ho_20_2 ahp20 ahn20 wp_ho_20_2 wn_ho_20_2 mop2 mon2 vdd vbsyn gsyn
X_ho_21_2 ahp21 ahn21 wp_ho_21_2 wn_ho_21_2 mop2 mon2 vdd vbsyn gsyn
X_ho_22_2 ahp22 ahn22 wp_ho_22_2 wn_ho_22_2 mop2 mon2 vdd vbsyn gsyn
X_ho_23_2 ahp23 ahn23 wp_ho_23_2 wn_ho_23_2 mop2 mon2 vdd vbsyn gsyn
X_ho_24_2 ahp24 ahn24 wp_ho_24_2 wn_ho_24_2 mop2 mon2 vdd vbsyn gsyn
X_ho_25_2 ahp25 ahn25 wp_ho_25_2 wn_ho_25_2 mop2 mon2 vdd vbsyn gsyn
X_ho_26_2 ahp26 ahn26 wp_ho_26_2 wn_ho_26_2 mop2 mon2 vdd vbsyn gsyn
X_ho_27_2 ahp27 ahn27 wp_ho_27_2 wn_ho_27_2 mop2 mon2 vdd vbsyn gsyn
X_ho_28_2 ahp28 ahn28 wp_ho_28_2 wn_ho_28_2 mop2 mon2 vdd vbsyn gsyn
X_ho_29_2 ahp29 ahn29 wp_ho_29_2 wn_ho_29_2 mop2 mon2 vdd vbsyn gsyn
X_ho_30_2 ahp30 ahn30 wp_ho_30_2 wn_ho_30_2 mop2 mon2 vdd vbsyn gsyn
X_ho_31_2 ahp31 ahn31 wp_ho_31_2 wn_ho_31_2 mop2 mon2 vdd vbsyn gsyn
X_ho_32_2 ahp32 ahn32 wp_ho_32_2 wn_ho_32_2 mop2 mon2 vdd vbsyn gsyn
X_ho_33_2 ahp33 ahn33 wp_ho_33_2 wn_ho_33_2 mop2 mon2 vdd vbsyn gsyn
X_ho_34_2 ahp34 ahn34 wp_ho_34_2 wn_ho_34_2 mop2 mon2 vdd vbsyn gsyn
X_ho_35_2 ahp35 ahn35 wp_ho_35_2 wn_ho_35_2 mop2 mon2 vdd vbsyn gsyn
X_ho_36_2 ahp36 ahn36 wp_ho_36_2 wn_ho_36_2 mop2 mon2 vdd vbsyn gsyn
X_ho_37_2 ahp37 ahn37 wp_ho_37_2 wn_ho_37_2 mop2 mon2 vdd vbsyn gsyn
X_ho_38_2 ahp38 ahn38 wp_ho_38_2 wn_ho_38_2 mop2 mon2 vdd vbsyn gsyn
X_ho_39_2 ahp39 ahn39 wp_ho_39_2 wn_ho_39_2 mop2 mon2 vdd vbsyn gsyn
Xcm_mo3 mop3 mon3 vdd cmld
Rnd_mo3 mop3 mon3 20k
X_ho_0_3 ahp0 ahn0 wp_ho_0_3 wn_ho_0_3 mop3 mon3 vdd vbsyn gsyn
X_ho_1_3 ahp1 ahn1 wp_ho_1_3 wn_ho_1_3 mop3 mon3 vdd vbsyn gsyn
X_ho_2_3 ahp2 ahn2 wp_ho_2_3 wn_ho_2_3 mop3 mon3 vdd vbsyn gsyn
X_ho_3_3 ahp3 ahn3 wp_ho_3_3 wn_ho_3_3 mop3 mon3 vdd vbsyn gsyn
X_ho_4_3 ahp4 ahn4 wp_ho_4_3 wn_ho_4_3 mop3 mon3 vdd vbsyn gsyn
X_ho_5_3 ahp5 ahn5 wp_ho_5_3 wn_ho_5_3 mop3 mon3 vdd vbsyn gsyn
X_ho_6_3 ahp6 ahn6 wp_ho_6_3 wn_ho_6_3 mop3 mon3 vdd vbsyn gsyn
X_ho_7_3 ahp7 ahn7 wp_ho_7_3 wn_ho_7_3 mop3 mon3 vdd vbsyn gsyn
X_ho_8_3 ahp8 ahn8 wp_ho_8_3 wn_ho_8_3 mop3 mon3 vdd vbsyn gsyn
X_ho_9_3 ahp9 ahn9 wp_ho_9_3 wn_ho_9_3 mop3 mon3 vdd vbsyn gsyn
X_ho_10_3 ahp10 ahn10 wp_ho_10_3 wn_ho_10_3 mop3 mon3 vdd vbsyn gsyn
X_ho_11_3 ahp11 ahn11 wp_ho_11_3 wn_ho_11_3 mop3 mon3 vdd vbsyn gsyn
X_ho_12_3 ahp12 ahn12 wp_ho_12_3 wn_ho_12_3 mop3 mon3 vdd vbsyn gsyn
X_ho_13_3 ahp13 ahn13 wp_ho_13_3 wn_ho_13_3 mop3 mon3 vdd vbsyn gsyn
X_ho_14_3 ahp14 ahn14 wp_ho_14_3 wn_ho_14_3 mop3 mon3 vdd vbsyn gsyn
X_ho_15_3 ahp15 ahn15 wp_ho_15_3 wn_ho_15_3 mop3 mon3 vdd vbsyn gsyn
X_ho_16_3 ahp16 ahn16 wp_ho_16_3 wn_ho_16_3 mop3 mon3 vdd vbsyn gsyn
X_ho_17_3 ahp17 ahn17 wp_ho_17_3 wn_ho_17_3 mop3 mon3 vdd vbsyn gsyn
X_ho_18_3 ahp18 ahn18 wp_ho_18_3 wn_ho_18_3 mop3 mon3 vdd vbsyn gsyn
X_ho_19_3 ahp19 ahn19 wp_ho_19_3 wn_ho_19_3 mop3 mon3 vdd vbsyn gsyn
X_ho_20_3 ahp20 ahn20 wp_ho_20_3 wn_ho_20_3 mop3 mon3 vdd vbsyn gsyn
X_ho_21_3 ahp21 ahn21 wp_ho_21_3 wn_ho_21_3 mop3 mon3 vdd vbsyn gsyn
X_ho_22_3 ahp22 ahn22 wp_ho_22_3 wn_ho_22_3 mop3 mon3 vdd vbsyn gsyn
X_ho_23_3 ahp23 ahn23 wp_ho_23_3 wn_ho_23_3 mop3 mon3 vdd vbsyn gsyn
X_ho_24_3 ahp24 ahn24 wp_ho_24_3 wn_ho_24_3 mop3 mon3 vdd vbsyn gsyn
X_ho_25_3 ahp25 ahn25 wp_ho_25_3 wn_ho_25_3 mop3 mon3 vdd vbsyn gsyn
X_ho_26_3 ahp26 ahn26 wp_ho_26_3 wn_ho_26_3 mop3 mon3 vdd vbsyn gsyn
X_ho_27_3 ahp27 ahn27 wp_ho_27_3 wn_ho_27_3 mop3 mon3 vdd vbsyn gsyn
X_ho_28_3 ahp28 ahn28 wp_ho_28_3 wn_ho_28_3 mop3 mon3 vdd vbsyn gsyn
X_ho_29_3 ahp29 ahn29 wp_ho_29_3 wn_ho_29_3 mop3 mon3 vdd vbsyn gsyn
X_ho_30_3 ahp30 ahn30 wp_ho_30_3 wn_ho_30_3 mop3 mon3 vdd vbsyn gsyn
X_ho_31_3 ahp31 ahn31 wp_ho_31_3 wn_ho_31_3 mop3 mon3 vdd vbsyn gsyn
X_ho_32_3 ahp32 ahn32 wp_ho_32_3 wn_ho_32_3 mop3 mon3 vdd vbsyn gsyn
X_ho_33_3 ahp33 ahn33 wp_ho_33_3 wn_ho_33_3 mop3 mon3 vdd vbsyn gsyn
X_ho_34_3 ahp34 ahn34 wp_ho_34_3 wn_ho_34_3 mop3 mon3 vdd vbsyn gsyn
X_ho_35_3 ahp35 ahn35 wp_ho_35_3 wn_ho_35_3 mop3 mon3 vdd vbsyn gsyn
X_ho_36_3 ahp36 ahn36 wp_ho_36_3 wn_ho_36_3 mop3 mon3 vdd vbsyn gsyn
X_ho_37_3 ahp37 ahn37 wp_ho_37_3 wn_ho_37_3 mop3 mon3 vdd vbsyn gsyn
X_ho_38_3 ahp38 ahn38 wp_ho_38_3 wn_ho_38_3 mop3 mon3 vdd vbsyn gsyn
X_ho_39_3 ahp39 ahn39 wp_ho_39_3 wn_ho_39_3 mop3 mon3 vdd vbsyn gsyn
Xcm_mo4 mop4 mon4 vdd cmld
Rnd_mo4 mop4 mon4 20k
X_ho_0_4 ahp0 ahn0 wp_ho_0_4 wn_ho_0_4 mop4 mon4 vdd vbsyn gsyn
X_ho_1_4 ahp1 ahn1 wp_ho_1_4 wn_ho_1_4 mop4 mon4 vdd vbsyn gsyn
X_ho_2_4 ahp2 ahn2 wp_ho_2_4 wn_ho_2_4 mop4 mon4 vdd vbsyn gsyn
X_ho_3_4 ahp3 ahn3 wp_ho_3_4 wn_ho_3_4 mop4 mon4 vdd vbsyn gsyn
X_ho_4_4 ahp4 ahn4 wp_ho_4_4 wn_ho_4_4 mop4 mon4 vdd vbsyn gsyn
X_ho_5_4 ahp5 ahn5 wp_ho_5_4 wn_ho_5_4 mop4 mon4 vdd vbsyn gsyn
X_ho_6_4 ahp6 ahn6 wp_ho_6_4 wn_ho_6_4 mop4 mon4 vdd vbsyn gsyn
X_ho_7_4 ahp7 ahn7 wp_ho_7_4 wn_ho_7_4 mop4 mon4 vdd vbsyn gsyn
X_ho_8_4 ahp8 ahn8 wp_ho_8_4 wn_ho_8_4 mop4 mon4 vdd vbsyn gsyn
X_ho_9_4 ahp9 ahn9 wp_ho_9_4 wn_ho_9_4 mop4 mon4 vdd vbsyn gsyn
X_ho_10_4 ahp10 ahn10 wp_ho_10_4 wn_ho_10_4 mop4 mon4 vdd vbsyn gsyn
X_ho_11_4 ahp11 ahn11 wp_ho_11_4 wn_ho_11_4 mop4 mon4 vdd vbsyn gsyn
X_ho_12_4 ahp12 ahn12 wp_ho_12_4 wn_ho_12_4 mop4 mon4 vdd vbsyn gsyn
X_ho_13_4 ahp13 ahn13 wp_ho_13_4 wn_ho_13_4 mop4 mon4 vdd vbsyn gsyn
X_ho_14_4 ahp14 ahn14 wp_ho_14_4 wn_ho_14_4 mop4 mon4 vdd vbsyn gsyn
X_ho_15_4 ahp15 ahn15 wp_ho_15_4 wn_ho_15_4 mop4 mon4 vdd vbsyn gsyn
X_ho_16_4 ahp16 ahn16 wp_ho_16_4 wn_ho_16_4 mop4 mon4 vdd vbsyn gsyn
X_ho_17_4 ahp17 ahn17 wp_ho_17_4 wn_ho_17_4 mop4 mon4 vdd vbsyn gsyn
X_ho_18_4 ahp18 ahn18 wp_ho_18_4 wn_ho_18_4 mop4 mon4 vdd vbsyn gsyn
X_ho_19_4 ahp19 ahn19 wp_ho_19_4 wn_ho_19_4 mop4 mon4 vdd vbsyn gsyn
X_ho_20_4 ahp20 ahn20 wp_ho_20_4 wn_ho_20_4 mop4 mon4 vdd vbsyn gsyn
X_ho_21_4 ahp21 ahn21 wp_ho_21_4 wn_ho_21_4 mop4 mon4 vdd vbsyn gsyn
X_ho_22_4 ahp22 ahn22 wp_ho_22_4 wn_ho_22_4 mop4 mon4 vdd vbsyn gsyn
X_ho_23_4 ahp23 ahn23 wp_ho_23_4 wn_ho_23_4 mop4 mon4 vdd vbsyn gsyn
X_ho_24_4 ahp24 ahn24 wp_ho_24_4 wn_ho_24_4 mop4 mon4 vdd vbsyn gsyn
X_ho_25_4 ahp25 ahn25 wp_ho_25_4 wn_ho_25_4 mop4 mon4 vdd vbsyn gsyn
X_ho_26_4 ahp26 ahn26 wp_ho_26_4 wn_ho_26_4 mop4 mon4 vdd vbsyn gsyn
X_ho_27_4 ahp27 ahn27 wp_ho_27_4 wn_ho_27_4 mop4 mon4 vdd vbsyn gsyn
X_ho_28_4 ahp28 ahn28 wp_ho_28_4 wn_ho_28_4 mop4 mon4 vdd vbsyn gsyn
X_ho_29_4 ahp29 ahn29 wp_ho_29_4 wn_ho_29_4 mop4 mon4 vdd vbsyn gsyn
X_ho_30_4 ahp30 ahn30 wp_ho_30_4 wn_ho_30_4 mop4 mon4 vdd vbsyn gsyn
X_ho_31_4 ahp31 ahn31 wp_ho_31_4 wn_ho_31_4 mop4 mon4 vdd vbsyn gsyn
X_ho_32_4 ahp32 ahn32 wp_ho_32_4 wn_ho_32_4 mop4 mon4 vdd vbsyn gsyn
X_ho_33_4 ahp33 ahn33 wp_ho_33_4 wn_ho_33_4 mop4 mon4 vdd vbsyn gsyn
X_ho_34_4 ahp34 ahn34 wp_ho_34_4 wn_ho_34_4 mop4 mon4 vdd vbsyn gsyn
X_ho_35_4 ahp35 ahn35 wp_ho_35_4 wn_ho_35_4 mop4 mon4 vdd vbsyn gsyn
X_ho_36_4 ahp36 ahn36 wp_ho_36_4 wn_ho_36_4 mop4 mon4 vdd vbsyn gsyn
X_ho_37_4 ahp37 ahn37 wp_ho_37_4 wn_ho_37_4 mop4 mon4 vdd vbsyn gsyn
X_ho_38_4 ahp38 ahn38 wp_ho_38_4 wn_ho_38_4 mop4 mon4 vdd vbsyn gsyn
X_ho_39_4 ahp39 ahn39 wp_ho_39_4 wn_ho_39_4 mop4 mon4 vdd vbsyn gsyn
.options gmin=1e-10
.end
