fully in-spice PC learner
.model NNR NMOS (LEVEL=1 VTO=0.2 KP=120u LAMBDA=0.02 GAMMA=0 PHI=0.7)
.model PNR PMOS (LEVEL=1 VTO=-0.2 KP=40u LAMBDA=0.02 GAMMA=0 PHI=0.7)
.subckt gsyn inp inn wp wn outp outn vdd vbn
Mtail nt vbn 0 0 NNR W=400u L=100u
M5 na wp s5 0 NNR W=200u L=100u
Rd5 s5 nt 12k
M6 nb wn s6 0 NNR W=200u L=100u
Rd6 s6 nt 12k
M1 outp inp s1 0 NNR W=200u L=100u
Rd1 s1 na 12k
M2 outn inn s2 0 NNR W=200u L=100u
Rd2 s2 na 12k
M3 outn inp s3 0 NNR W=200u L=100u
Rd3 s3 nb 12k
M4 outp inn s4 0 NNR W=200u L=100u
Rd4 s4 nb 12k
.ends
.subckt cmld p n vdd
Rcs1 p cmx 300k
Rcs2 n cmx 300k
MLp p cmx vdd vdd PNR W=5000u L=100u
MLn n cmx vdd vdd PNR W=5000u L=100u
.ends
.subckt dneuron up un ap an vdd vbn
M1 an up tn 0 NNR W=200u L=100u
M2 ap un tn 0 NNR W=200u L=100u
Mt tn vbn 0 0 NNR W=200u L=100u
Xcm ap an vdd cmld
.ends
.subckt esub xp xn mp mn ep en vdd vbn
Mt nt vbn 0 0 NNR W=400u L=100u
M1x ep xn nt 0 NNR W=200u L=100u
M2x en xp nt 0 NNR W=200u L=100u
M1m ep mp nt 0 NNR W=200u L=100u
M2m en mn nt 0 NNR W=200u L=100u
RLp vdd ep 50k
RLn vdd en 50k
.ends
.subckt gprod xp xn yp yn wp wn vdd vbn
Mtail nt vbn 0 0 NNR W=400u L=100u
M5 na yp nt 0 NNR W=200u L=100u
M6 nb yn nt 0 NNR W=200u L=100u
M1 iop xp na 0 NNR W=200u L=100u
M2 ion xn na 0 NNR W=200u L=100u
M3 ion xp nb 0 NNR W=200u L=100u
M4 iop xn nb 0 NNR W=200u L=100u
Mlp iop iop vdd vdd PNR W=200u L=100u
Mln ion ion vdd vdd PNR W=200u L=100u
Mpu_wp wp iop vdd vdd PNR W=200u L=100u
MpRn nrn ion vdd vdd PNR W=200u L=100u
MnRn nrn nrn 0 0 NNR W=200u L=100u
Mpd_wp wp nrn 0 0 NNR W=200u L=100u
Mpu_wn wn ion vdd vdd PNR W=200u L=100u
MpRp nrp iop vdd vdd PNR W=200u L=100u
MnRp nrp nrp 0 0 NNR W=200u L=100u
Mpd_wn wn nrp 0 0 NNR W=200u L=100u
.ends
Vdd vdd 0 1.0
Vbsyn vbsyn 0 0.6
Vbneu vbneu 0 0.35
Vgm gm 0 0.6
Vwcm wcm 0 0.5
Vgbl gbl 0 PWL(0.0n 0.80000 179.9n 0.80000 180.0n 0.80000 359.9n 0.80000 360.0n 0.80000 539.9n 0.80000 540.0n 0.80000 719.9n 0.80000 720.0n 0.80000 899.9n 0.80000 900.0n 0.80000 1079.9n 0.80000 1080.0n 0.80000 1259.9n 0.80000 1260.0n 0.80000 1439.9n 0.80000 1440.0n 0.80000 1619.9n 0.80000 1620.0n 0.80000 1799.9n 0.80000 1800.0n 0.80000 1979.9n 0.80000 1980.0n 0.80000 2159.9n 0.80000 2160.0n 0.80000 2339.9n 0.80000 2340.0n 0.80000 2519.9n 0.80000 2520.0n 0.80000 2699.9n 0.80000 2700.0n 0.80000 2879.9n 0.80000 2880.0n 0.80000 3059.9n 0.80000 3060.0n 0.80000 3239.9n 0.80000 3240.0n 0.80000 3419.9n 0.80000 3420.0n 0.80000 3599.9n 0.80000 3600.0n 0.80000 3779.9n 0.80000 3780.0n 0.80000 3959.9n 0.80000 3960.0n 0.80000 4139.9n 0.80000 4140.0n 0.80000 4319.9n 0.80000 4320.0n 0.80000 4499.9n 0.80000 4500.0n 0.80000 4679.9n 0.80000 4680.0n 0.80000 4859.9n 0.80000 4860.0n 0.80000 5039.9n 0.80000 5040.0n 0.80000 5219.9n 0.80000 5220.0n 0.80000 5399.9n 0.80000 5400.0n 0.80000 5579.9n 0.80000 5580.0n 0.80000 5759.9n 0.80000 5760.0n 0.80000 5939.9n 0.80000 5940.0n 0.80000 6119.9n 0.80000 6120.0n 0.80000 6299.9n 0.80000 6300.0n 0.80000 6479.9n 0.80000 6480.0n 0.80000 6659.9n 0.80000 6660.0n 0.80000 6839.9n 0.80000 6840.0n 0.80000 7019.9n 0.80000 7020.0n 0.80000 7199.9n 0.80000 7200.0n 0.80000 7379.9n 0.80000 7380.0n 0.80000 7559.9n 0.80000 7560.0n 0.80000 7739.9n 0.80000 7740.0n 0.80000 7919.9n 0.80000 7920.0n 0.80000 8099.9n 0.80000 8100.0n 0.80000 8279.9n 0.80000 8280.0n 0.80000 8459.9n 0.80000 8460.0n 0.80000 8639.9n 0.80000 8640.0n 0.80000 8819.9n 0.80000 8820.0n 0.80000 8999.9n 0.80000 9000.0n 0.80000 9179.9n 0.80000 9180.0n 0.80000 9359.9n 0.80000 9360.0n 0.80000 9539.9n 0.80000 9540.0n 0.80000 9719.9n 0.80000 9720.0n 0.80000 9899.9n 0.80000 9900.0n 0.80000 10079.9n 0.80000 10080.0n 0.80000 10259.9n 0.80000 10260.0n 0.80000 10439.9n 0.80000 10440.0n 0.80000 10619.9n 0.80000 10620.0n 0.80000 10799.9n 0.80000 10800.0n 0.80000 10979.9n 0.80000 10980.0n 0.80000 11159.9n 0.80000 11160.0n 0.80000 11339.9n 0.80000 11340.0n 0.80000 11519.9n 0.80000 11520.0n 0.80000 11699.9n 0.80000 11700.0n 0.80000 11879.9n 0.80000 11880.0n 0.80000 12059.9n 0.80000 12060.0n 0.80000 12239.9n 0.80000 12240.0n 0.80000 12419.9n 0.80000 12420.0n 0.80000 12599.9n 0.80000 12600.0n 0.80000 12779.9n 0.80000 12780.0n 0.80000 12959.9n 0.80000 12960.0n 0.80000 13139.9n 0.80000 13140.0n 0.80000 13319.9n 0.80000 13320.0n 0.80000 13499.9n 0.80000 13500.0n 0.80000 13679.9n 0.80000 13680.0n 0.80000 13859.9n 0.80000 13860.0n 0.80000 14039.9n 0.80000 14040.0n 0.80000 14219.9n 0.80000 14220.0n 0.80000 14399.9n 0.80000 14400.0n 0.80000 14579.9n 0.80000 14580.0n 0.80000 14759.9n 0.80000 14760.0n 0.80000 14939.9n 0.80000 14940.0n 0.80000 15119.9n 0.80000 15120.0n 0.80000 15299.9n 0.80000 15300.0n 0.80000 15479.9n 0.80000 15480.0n 0.80000 15659.9n 0.80000 15660.0n 0.80000 15839.9n 0.80000 15840.0n 0.80000 16019.9n 0.80000 16020.0n 0.80000 16199.9n 0.80000 16200.0n 0.80000 16379.9n 0.80000 16380.0n 0.80000 16559.9n 0.80000 16560.0n 0.80000 16739.9n 0.80000 16740.0n 0.80000 16919.9n 0.80000 16920.0n 0.80000 17099.9n 0.80000 17100.0n 0.80000 17279.9n 0.80000 17280.0n 0.80000 17459.9n 0.80000 17460.0n 0.80000 17639.9n 0.80000 17640.0n 0.80000 17819.9n 0.80000 17820.0n 0.80000 17999.9n 0.80000 18000.0n 0.80000 18179.9n 0.80000 18180.0n 0.80000 18359.9n 0.80000 18360.0n 0.80000 18539.9n 0.80000 18540.0n 0.80000 18719.9n 0.80000 18720.0n 0.80000 18899.9n 0.80000 18900.0n 0.80000 19079.9n 0.80000 19080.0n 0.80000 19259.9n 0.80000 19260.0n 0.80000 19439.9n 0.80000 19440.0n 0.80000 19619.9n 0.80000 19620.0n 0.80000 19799.9n 0.80000 19800.0n 0.80000 19979.9n 0.80000 19980.0n 0.80000 20159.9n 0.80000 20160.0n 0.80000 20339.9n 0.80000 20340.0n 0.80000 20519.9n 0.80000 20520.0n 0.80000 20699.9n 0.80000 20700.0n 0.80000 20879.9n 0.80000 20880.0n 0.80000 21059.9n 0.80000 21060.0n 0.80000 21239.9n 0.80000 21240.0n 0.80000 21419.9n 0.80000 21420.0n 0.80000 21599.9n 0.80000 21600.0n 0.80000 21779.9n 0.80000 21780.0n 0.80000 21959.9n 0.80000 21960.0n 0.80000 22139.9n 0.80000 22140.0n 0.80000 22319.9n 0.80000 22320.0n 0.80000 22499.9n 0.80000 22500.0n 0.80000 22679.9n 0.80000 22680.0n 0.80000 22859.9n 0.80000 22860.0n 0.80000 23039.9n 0.80000 23040.0n 0.80000 23219.9n 0.80000 23220.0n 0.80000 23399.9n 0.80000 23400.0n 0.80000 23579.9n 0.80000 23580.0n 0.80000 23759.9n 0.80000 23760.0n 0.80000 23939.9n 0.80000 23940.0n 0.80000 24119.9n 0.80000 24120.0n 0.80000 24299.9n 0.80000 24300.0n 0.80000 24479.9n 0.80000 24480.0n 0.80000 24659.9n 0.80000 24660.0n 0.80000 24839.9n 0.80000 24840.0n 0.80000 25019.9n 0.80000 25020.0n 0.80000 25199.9n 0.80000 25200.0n 0.80000 25379.9n 0.80000 25380.0n 0.80000 25559.9n 0.80000 25560.0n 0.80000 25739.9n 0.80000 25740.0n 0.80000 25919.9n 0.80000 25920.0n 0.80000 26099.9n 0.80000 26100.0n 0.80000 26279.9n 0.80000 26280.0n 0.80000 26459.9n 0.80000 26460.0n 0.80000 26639.9n 0.80000 26640.0n 0.80000 26819.9n 0.80000 26820.0n 0.80000 26999.9n 0.80000 27000.0n 0.80000 27179.9n 0.80000 27180.0n 0.80000 27359.9n 0.80000 27360.0n 0.80000 27539.9n 0.80000 27540.0n 0.80000 27719.9n 0.80000 27720.0n 0.80000 27899.9n 0.80000 27900.0n 0.80000 28079.9n 0.80000 28080.0n 0.80000 28259.9n 0.80000 28260.0n 0.80000 28439.9n 0.80000 28440.0n 0.80000 28619.9n 0.80000 28620.0n 0.80000 28799.9n 0.80000 28800.0n 0.80000 28979.9n 0.80000 28980.0n 0.80000 29159.9n 0.80000 29160.0n 0.80000 29339.9n 0.80000 29340.0n 0.80000 29519.9n 0.80000 29520.0n 0.80000 29699.9n 0.80000 29700.0n 0.80000 29879.9n 0.80000 29880.0n 0.80000 30059.9n 0.80000 30060.0n 0.80000 30239.9n 0.80000 30240.0n 0.80000 30419.9n 0.80000 30420.0n 0.80000 30599.9n 0.80000 30600.0n 0.80000 30779.9n 0.80000 30780.0n 0.80000 30959.9n 0.80000 30960.0n 0.80000 31139.9n 0.80000 31140.0n 0.80000 31319.9n 0.80000 31320.0n 0.80000 31499.9n 0.80000 31500.0n 0.80000 31679.9n 0.80000 31680.0n 0.80000 31859.9n 0.80000 31860.0n 0.80000 32039.9n 0.80000 32040.0n 0.80000 32219.9n 0.80000 32220.0n 0.80000 32399.9n 0.80000 32400.0n 0.80000 32579.9n 0.80000 32580.0n 0.80000 32759.9n 0.80000 32760.0n 0.80000 32939.9n 0.80000 32940.0n 0.80000 33119.9n 0.80000 33120.0n 0.80000 33299.9n 0.80000 33300.0n 0.80000 33479.9n 0.80000 33480.0n 0.80000 33659.9n 0.80000 33660.0n 0.80000 33839.9n 0.80000 33840.0n 0.80000 34019.9n 0.80000 34020.0n 0.80000 34199.9n 0.80000 34200.0n 0.80000 34379.9n 0.80000 34380.0n 0.80000 34559.9n 0.80000 34560.0n 0.80000 34739.9n 0.80000 34740.0n 0.80000 34919.9n 0.80000 34920.0n 0.80000 35099.9n 0.80000 35100.0n 0.80000 35279.9n 0.80000 35280.0n 0.80000 35459.9n 0.80000 35460.0n 0.80000 35639.9n 0.80000 35640.0n 0.80000 35819.9n 0.80000 35820.0n 0.80000 35999.9n 0.80000 36000.0n 0.80000 36179.9n 0.80000 36180.0n 0.80000 36359.9n 0.80000 36360.0n 0.80000 36539.9n 0.80000 36540.0n 0.80000 36719.9n 0.80000 36720.0n 0.80000 36899.9n 0.80000 36900.0n 0.80000 37079.9n 0.80000 37080.0n 0.80000 37259.9n 0.80000 37260.0n 0.80000 37439.9n 0.80000 37440.0n 0.80000 37619.9n 0.80000 37620.0n 0.80000 37799.9n 0.80000 37800.0n 0.80000 37979.9n 0.80000 37980.0n 0.80000 38159.9n 0.80000 38160.0n 0.80000 38339.9n 0.80000 38340.0n 0.80000 38519.9n 0.80000 38520.0n 0.80000 38699.9n 0.80000 38700.0n 0.80000 38879.9n 0.80000 38880.0n 0.80000 39059.9n 0.80000 39060.0n 0.80000 39239.9n 0.80000 39240.0n 0.80000 39419.9n 0.80000 39420.0n 0.80000 39599.9n 0.80000 39600.0n 0.80000 39779.9n 0.80000 39780.0n 0.80000 39959.9n 0.80000 39960.0n 0.80000 40139.9n 0.80000 40140.0n 0.80000 40319.9n 0.80000 40320.0n 0.80000 40499.9n 0.80000 40500.0n 0.80000 40679.9n 0.80000 40680.0n 0.80000 40859.9n 0.80000 40860.0n 0.80000 41039.9n 0.80000 41040.0n 0.80000 41219.9n 0.80000 41220.0n 0.80000 41399.9n 0.80000 41400.0n 0.80000 41579.9n 0.80000 41580.0n 0.80000 41759.9n 0.80000 41760.0n 0.80000 41939.9n 0.80000 41940.0n 0.80000 42119.9n 0.80000 42120.0n 0.80000 42299.9n 0.80000 42300.0n 0.80000 42479.9n 0.80000 42480.0n 0.80000 42659.9n 0.80000 42660.0n 0.80000 42839.9n 0.80000 42840.0n 0.80000 43019.9n 0.80000 43020.0n 0.80000 43199.9n 0.80000 43200.0n 0.80000 43379.9n 0.80000 43380.0n 0.80000 43559.9n 0.80000 43560.0n 0.80000 43739.9n 0.80000 43740.0n 0.80000 43919.9n 0.80000 43920.0n 0.80000 44099.9n 0.80000 44100.0n 0.80000 44279.9n 0.80000 44280.0n 0.80000 44459.9n 0.80000 44460.0n 0.80000 44639.9n 0.80000 44640.0n 0.80000 44819.9n 0.80000 44820.0n 0.80000 44999.9n 0.80000 45000.0n 0.80000 45179.9n 0.80000 45180.0n 0.80000 45359.9n 0.80000 45360.0n 0.80000 45539.9n 0.80000 45540.0n 0.80000 45719.9n 0.80000 45720.0n 0.80000 45899.9n 0.80000 45900.0n 0.80000 46079.9n 0.80000 46080.0n 0.80000 46259.9n 0.80000 46260.0n 0.80000 46439.9n 0.80000 46440.0n 0.80000 46619.9n 0.80000 46620.0n 0.80000 46799.9n 0.80000 46800.0n 0.80000 46979.9n 0.80000 46980.0n 0.80000 47159.9n 0.80000 47160.0n 0.80000 47339.9n 0.80000 47340.0n 0.80000 47519.9n 0.80000 47520.0n 0.80000 47699.9n 0.80000 47700.0n 0.80000 47879.9n 0.80000 47880.0n 0.80000 48059.9n 0.80000 48060.0n 0.80000 48239.9n 0.80000 48240.0n 0.80000 48419.9n 0.80000 48420.0n 0.80000 48599.9n 0.80000 48600.0n 0.80000 48779.9n 0.80000 48780.0n 0.80000 48959.9n 0.80000 48960.0n 0.80000 49139.9n 0.80000 49140.0n 0.80000 49319.9n 0.80000 49320.0n 0.80000 49499.9n 0.80000 49500.0n 0.80000 49679.9n 0.80000 49680.0n 0.80000 49859.9n 0.80000 49860.0n 0.80000 50039.9n 0.80000 50040.0n 0.80000 50219.9n 0.80000 50220.0n 0.80000 50399.9n 0.80000 50400.0n 0.80000 50579.9n 0.80000 50580.0n 0.80000 50759.9n 0.80000 50760.0n 0.80000 50939.9n 0.80000 50940.0n 0.80000 51119.9n 0.80000 51120.0n 0.80000 51299.9n 0.80000 51300.0n 0.80000 51479.9n 0.80000 51480.0n 0.80000 51659.9n 0.80000 51660.0n 0.80000 51839.9n 0.80000 51840.0n 0.80000 52019.9n 0.80000 52020.0n 0.80000 52199.9n 0.80000 52200.0n 0.80000 52379.9n 0.80000 52380.0n 0.80000 52559.9n 0.80000 52560.0n 0.80000 52739.9n 0.80000 52740.0n 0.80000 52919.9n 0.80000 52920.0n 0.80000 53099.9n 0.80000 53100.0n 0.80000 53279.9n 0.80000 53280.0n 0.80000 53459.9n 0.80000 53460.0n 0.80000 53639.9n 0.80000 53640.0n 0.80000 53819.9n 0.80000 53820.0n 0.80000 53999.9n 0.80000 54000.0n 0.80000 54179.9n 0.80000 54180.0n 0.80000 54359.9n 0.80000 54360.0n 0.80000 54539.9n 0.80000 54540.0n 0.80000 54719.9n 0.80000 54720.0n 0.80000 54899.9n 0.80000 54900.0n 0.80000 55079.9n 0.80000 55080.0n 0.80000 55259.9n 0.80000 55260.0n 0.80000 55439.9n 0.80000 55440.0n 0.80000 55619.9n 0.80000 55620.0n 0.80000 55799.9n 0.80000 55800.0n 0.80000 55979.9n 0.80000 55980.0n 0.80000 56159.9n 0.80000 56160.0n 0.80000 56339.9n 0.80000 56340.0n 0.80000 56519.9n 0.80000 56520.0n 0.80000 56699.9n 0.80000 56700.0n 0.80000 56879.9n 0.80000 56880.0n 0.80000 57059.9n 0.80000 57060.0n 0.80000 57239.9n 0.80000 57240.0n 0.80000 57419.9n 0.80000 57420.0n 0.80000 57599.9n 0.80000 57600.0n 0.80000 57779.9n 0.80000 57780.0n 0.80000 57959.9n 0.80000 57960.0n 0.80000 58139.9n 0.80000 58140.0n 0.80000 58319.9n 0.80000 58320.0n 0.80000 58499.9n 0.80000 58500.0n 0.80000 58679.9n 0.80000 58680.0n 0.80000 58859.9n 0.80000 58860.0n 0.80000 59039.9n 0.80000 59040.0n 0.80000 59219.9n 0.80000 59220.0n 0.80000 59399.9n 0.80000 59400.0n 0.80000 59579.9n 0.80000 59580.0n 0.80000 59759.9n 0.80000 59760.0n 0.80000 59939.9n 0.80000 59940.0n 0.80000 60119.9n 0.80000 60120.0n 0.80000 60299.9n 0.80000 60300.0n 0.80000 60479.9n 0.80000 60480.0n 0.80000 60659.9n 0.80000 60660.0n 0.80000 60839.9n 0.80000 60840.0n 0.80000 61019.9n 0.80000 61020.0n 0.80000 61199.9n 0.80000 61200.0n 0.80000 61379.9n 0.80000 61380.0n 0.80000 61559.9n 0.80000 61560.0n 0.80000 61739.9n 0.80000 61740.0n 0.80000 61919.9n 0.80000 61920.0n 0.80000 62099.9n 0.80000 62100.0n 0.80000 62279.9n 0.80000 62280.0n 0.80000 62459.9n 0.80000 62460.0n 0.80000 62639.9n 0.80000 62640.0n 0.80000 62819.9n 0.80000 62820.0n 0.80000 62999.9n 0.80000 63000.0n 0.80000 63179.9n 0.80000 63180.0n 0.80000 63359.9n 0.80000 63360.0n 0.80000 63539.9n 0.80000 63540.0n 0.80000 63719.9n 0.80000 63720.0n 0.80000 63899.9n 0.80000 63900.0n 0.80000 64079.9n 0.80000 64080.0n 0.80000 64259.9n 0.80000 64260.0n 0.80000 64439.9n 0.80000 64440.0n 0.80000 64619.9n 0.80000 64620.0n 0.80000 64799.9n 0.80000 64800.0n 0.80000 64979.9n 0.80000 64980.0n 0.80000 65159.9n 0.80000 65160.0n 0.80000 65339.9n 0.80000 65340.0n 0.80000 65519.9n 0.80000 65520.0n 0.80000 65699.9n 0.80000 65700.0n 0.80000 65879.9n 0.80000 65880.0n 0.80000 66059.9n 0.80000 66060.0n 0.80000 66239.9n 0.80000 66240.0n 0.80000 66419.9n 0.80000 66420.0n 0.80000 66599.9n 0.80000 66600.0n 0.80000 66779.9n 0.80000 66780.0n 0.80000 66959.9n 0.80000 66960.0n 0.80000 67139.9n 0.80000 67140.0n 0.80000 67319.9n 0.80000 67320.0n 0.80000 67499.9n 0.80000 67500.0n 0.80000 67679.9n 0.80000 67680.0n 0.80000 67859.9n 0.80000 67860.0n 0.80000 68039.9n 0.80000 68040.0n 0.80000 68219.9n 0.80000 68220.0n 0.80000 68399.9n 0.80000 68400.0n 0.80000 68579.9n 0.80000 68580.0n 0.80000 68759.9n 0.80000 68760.0n 0.80000 68939.9n 0.80000 68940.0n 0.80000 69119.9n 0.80000 69120.0n 0.80000 69299.9n 0.80000 69300.0n 0.80000 69479.9n 0.80000 69480.0n 0.80000 69659.9n 0.80000 69660.0n 0.80000 69839.9n 0.80000 69840.0n 0.80000 70019.9n 0.80000 70020.0n 0.80000 70199.9n 0.80000 70200.0n 0.80000 70379.9n 0.80000 70380.0n 0.80000 70559.9n 0.80000 70560.0n 0.80000 70739.9n 0.80000 70740.0n 0.80000 70919.9n 0.80000 70920.0n 0.80000 71099.9n 0.80000 71100.0n 0.80000 71279.9n 0.80000 71280.0n 0.80000 71459.9n 0.80000 71460.0n 0.80000 71639.9n 0.80000 71640.0n 0.80000 71819.9n 0.80000 71820.0n 0.80000 71999.9n 0.80000 72000.0n 0.80000 72179.9n 0.80000 72180.0n 0.80000 72359.9n 0.80000 72360.0n 0.80000 72539.9n 0.80000 72540.0n 0.80000 72719.9n 0.80000 72720.0n 0.80000 72899.9n 0.80000 72900.0n 0.80000 73079.9n 0.80000 73080.0n 0.80000 73259.9n 0.80000 73260.0n 0.80000 73439.9n 0.80000 73440.0n 0.80000 73619.9n 0.80000 73620.0n 0.80000 73799.9n 0.80000 73800.0n 0.80000 73979.9n 0.80000 73980.0n 0.80000 74159.9n 0.80000 74160.0n 0.80000 74339.9n 0.80000 74340.0n 0.80000 74519.9n 0.80000 74520.0n 0.80000 74699.9n 0.80000 74700.0n 0.80000 74879.9n 0.80000 74880.0n 0.80000 75059.9n 0.80000 75060.0n 0.80000 75239.9n 0.80000 75240.0n 0.80000 75419.9n 0.80000 75420.0n 0.80000 75599.9n 0.80000 75600.0n 0.80000 75779.9n 0.80000 75780.0n 0.80000 75959.9n 0.80000 75960.0n 0.80000 76139.9n 0.80000 76140.0n 0.80000 76319.9n 0.80000 76320.0n 0.80000 76499.9n 0.80000 76500.0n 0.80000 76679.9n 0.80000 76680.0n 0.80000 76859.9n 0.80000 76860.0n 0.80000 77039.9n 0.80000 77040.0n 0.80000 77219.9n 0.80000 77220.0n 0.80000 77399.9n 0.80000 77400.0n 0.80000 77579.9n 0.80000 77580.0n 0.80000 77759.9n 0.80000 77760.0n 0.80000 77939.9n 0.80000 77940.0n 0.80000 78119.9n 0.80000 78120.0n 0.80000 78299.9n 0.80000 78300.0n 0.80000 78479.9n 0.80000 78480.0n 0.80000 78659.9n 0.80000 78660.0n 0.80000 78839.9n 0.80000 78840.0n 0.80000 79019.9n 0.80000 79020.0n 0.80000 79199.9n 0.80000 79200.0n 0.80000 79379.9n 0.80000 79380.0n 0.80000 79559.9n 0.80000 79560.0n 0.80000 79739.9n 0.80000 79740.0n 0.80000 79919.9n 0.80000 79920.0n 0.80000 80099.9n 0.80000 80100.0n 0.80000 80279.9n 0.80000 80280.0n 0.80000 80459.9n 0.80000 80460.0n 0.80000 80639.9n 0.80000 80640.0n 0.80000 80819.9n 0.80000 80820.0n 0.80000 80999.9n 0.80000 81000.0n 0.80000 81179.9n 0.80000 81180.0n 0.80000 81359.9n 0.80000 81360.0n 0.80000 81539.9n 0.80000 81540.0n 0.80000 81719.9n 0.80000 81720.0n 0.80000 81899.9n 0.80000 81900.0n 0.80000 82079.9n 0.80000 82080.0n 0.80000 82259.9n 0.80000 82260.0n 0.80000 82439.9n 0.80000 82440.0n 0.80000 82619.9n 0.80000 82620.0n 0.80000 82799.9n 0.80000 82800.0n 0.80000 82979.9n 0.80000 82980.0n 0.80000 83159.9n 0.80000 83160.0n 0.80000 83339.9n 0.80000 83340.0n 0.80000 83519.9n 0.80000 83520.0n 0.80000 83699.9n 0.80000 83700.0n 0.80000 83879.9n 0.80000 83880.0n 0.80000 84059.9n 0.80000 84060.0n 0.80000 84239.9n 0.80000 84240.0n 0.80000 84419.9n 0.80000 84420.0n 0.80000 84599.9n 0.80000 84600.0n 0.80000 84779.9n 0.80000 84780.0n 0.80000 84959.9n 0.80000 84960.0n 0.80000 85139.9n 0.80000 85140.0n 0.80000 85319.9n 0.80000 85320.0n 0.80000 85499.9n 0.80000 85500.0n 0.80000 85679.9n 0.80000 85680.0n 0.80000 85859.9n 0.80000 85860.0n 0.80000 86039.9n 0.80000 86040.0n 0.80000 86219.9n 0.80000 86220.0n 0.80000 86399.9n 0.80000 86400.0n 0.80000 86579.9n 0.80000 86580.0n 0.80000 86759.9n 0.80000 86760.0n 0.80000 86939.9n 0.80000 86940.0n 0.80000 87119.9n 0.80000 87120.0n 0.80000 87299.9n 0.80000 87300.0n 0.80000 87479.9n 0.80000 87480.0n 0.80000 87659.9n 0.80000 87660.0n 0.80000 87839.9n 0.80000 87840.0n 0.80000 88019.9n 0.80000 88020.0n 0.80000 88199.9n 0.80000 88200.0n 0.80000 88379.9n 0.80000 88380.0n 0.80000 88559.9n 0.80000 88560.0n 0.80000 88739.9n 0.80000 88740.0n 0.80000 88919.9n 0.80000 88920.0n 0.80000 89099.9n 0.80000 89100.0n 0.80000 89279.9n 0.80000 89280.0n 0.80000 89459.9n 0.80000 89460.0n 0.80000 89639.9n 0.80000 89640.0n 0.80000 89819.9n 0.80000 89820.0n 0.80000 89999.9n 0.80000 90000.0n 0.80000 90179.9n 0.80000 90180.0n 0.80000 90359.9n 0.80000 90360.0n 0.80000 90539.9n 0.80000 90540.0n 0.80000 90719.9n 0.80000 90720.0n 0.80000 90899.9n 0.80000 90900.0n 0.80000 91079.9n 0.80000 91080.0n 0.80000 91259.9n 0.80000 91260.0n 0.80000 91439.9n 0.80000 91440.0n 0.80000 91619.9n 0.80000 91620.0n 0.80000 91799.9n 0.80000 91800.0n 0.80000 91979.9n 0.80000 91980.0n 0.80000 92159.9n 0.80000 92160.0n 0.80000 92339.9n 0.80000 92340.0n 0.80000 92519.9n 0.80000 92520.0n 0.80000 92699.9n 0.80000 92700.0n 0.80000 92879.9n 0.80000 92880.0n 0.80000 93059.9n 0.80000 93060.0n 0.80000 93239.9n 0.80000 93240.0n 0.80000 93419.9n 0.80000 93420.0n 0.80000 93599.9n 0.80000 93600.0n 0.80000 93779.9n 0.80000 93780.0n 0.80000 93959.9n 0.80000 93960.0n 0.80000 94139.9n 0.80000 94140.0n 0.80000 94319.9n 0.80000 94320.0n 0.80000 94499.9n 0.80000 94500.0n 0.80000 94679.9n 0.80000 94680.0n 0.80000 94859.9n 0.80000 94860.0n 0.80000 95039.9n 0.80000 95040.0n 0.80000 95219.9n 0.80000 95220.0n 0.80000 95399.9n 0.80000 95400.0n 0.80000 95579.9n 0.80000 95580.0n 0.80000 95759.9n 0.80000 95760.0n 0.80000 95939.9n 0.80000 95940.0n 0.80000 96119.9n 0.80000 96120.0n 0.80000 96299.9n 0.80000 96300.0n 0.80000 96479.9n 0.80000 96480.0n 0.80000 96659.9n 0.80000 96660.0n 0.80000 96839.9n 0.80000 96840.0n 0.80000 97019.9n 0.80000 97020.0n 0.80000 97199.9n 0.80000 97200.0n 0.80000 97379.9n 0.80000 97380.0n 0.80000 97559.9n 0.80000 97560.0n 0.80000 97739.9n 0.80000 97740.0n 0.80000 97919.9n 0.80000 97920.0n 0.80000 98099.9n 0.80000 98100.0n 0.80000 98279.9n 0.80000 98280.0n 0.80000 98459.9n 0.80000 98460.0n 0.80000 98639.9n 0.80000 98640.0n 0.80000 98819.9n 0.80000 98820.0n 0.80000 98999.9n 0.80000 99000.0n 0.80000 99179.9n 0.80000 99180.0n 0.80000 99359.9n 0.80000 99360.0n 0.80000 99539.9n 0.80000 99540.0n 0.80000 99719.9n 0.80000 99720.0n 0.80000 99899.9n 0.80000 99900.0n 0.80000 100079.9n 0.80000 100080.0n 0.80000 100259.9n 0.80000 100260.0n 0.80000 100439.9n 0.80000 100440.0n 0.80000 100619.9n 0.80000 100620.0n 0.80000 100799.9n 0.80000 100800.0n 0.80000 100979.9n 0.80000 100980.0n 0.80000 101159.9n 0.80000 101160.0n 0.80000 101339.9n 0.80000 101340.0n 0.80000 101519.9n 0.80000 101520.0n 0.80000 101699.9n 0.80000 101700.0n 0.80000 101879.9n 0.80000 101880.0n 0.80000 102059.9n 0.80000 102060.0n 0.80000 102239.9n 0.80000 102240.0n 0.80000 102419.9n 0.80000 102420.0n 0.80000 102599.9n 0.80000 102600.0n 0.80000 102779.9n 0.80000 102780.0n 0.80000 102959.9n 0.80000 102960.0n 0.80000 103139.9n 0.80000 103140.0n 0.80000 103319.9n 0.80000 103320.0n 0.80000 103499.9n 0.80000 103500.0n 0.80000 103679.9n 0.80000 103680.0n 0.80000 103859.9n 0.80000 103860.0n 0.80000 104039.9n 0.80000 104040.0n 0.80000 104219.9n 0.80000 104220.0n 0.80000 104399.9n 0.80000 104400.0n 0.80000 104579.9n 0.80000 104580.0n 0.80000 104759.9n 0.80000 104760.0n 0.80000 104939.9n 0.80000 104940.0n 0.80000 105119.9n 0.80000 105120.0n 0.80000 105299.9n 0.80000 105300.0n 0.80000 105479.9n 0.80000 105480.0n 0.80000 105659.9n 0.80000 105660.0n 0.80000 105839.9n 0.80000 105840.0n 0.80000 106019.9n 0.80000 106020.0n 0.80000 106199.9n 0.80000 106200.0n 0.80000 106379.9n 0.80000 106380.0n 0.80000 106559.9n 0.80000 106560.0n 0.80000 106739.9n 0.80000 106740.0n 0.80000 106919.9n 0.80000 106920.0n 0.80000 107099.9n 0.80000 107100.0n 0.80000 107279.9n 0.80000 107280.0n 0.80000 107459.9n 0.80000 107460.0n 0.80000 107639.9n 0.80000 107640.0n 0.80000 107819.9n 0.80000 107820.0n 0.80000 107999.9n 0.80000 108000.0n 0.80000 108179.9n 0.80000 108180.0n 0.80000 108359.9n 0.80000 108360.0n 0.80000 108539.9n 0.80000 108540.0n 0.80000 108719.9n 0.80000 108720.0n 0.80000 108899.9n 0.80000 108900.0n 0.80000 109079.9n 0.80000 109080.0n 0.80000 109259.9n 0.80000 109260.0n 0.80000 109439.9n 0.80000 109440.0n 0.80000 109619.9n 0.80000 109620.0n 0.80000 109799.9n 0.80000 109800.0n 0.80000 109979.9n 0.80000 109980.0n 0.80000 110159.9n 0.80000 110160.0n 0.80000 110339.9n 0.80000 110340.0n 0.80000 110519.9n 0.80000 110520.0n 0.80000 110699.9n 0.80000 110700.0n 0.80000 110879.9n 0.80000 110880.0n 0.80000 111059.9n 0.80000 111060.0n 0.80000 111239.9n 0.80000 111240.0n 0.80000 111419.9n 0.80000 111420.0n 0.80000 111599.9n 0.80000 111600.0n 0.80000 111779.9n 0.80000 111780.0n 0.80000 111959.9n 0.80000 111960.0n 0.80000 112139.9n 0.80000 112140.0n 0.80000 112319.9n 0.80000 112320.0n 0.80000 112499.9n 0.80000 112500.0n 0.80000 112679.9n 0.80000 112680.0n 0.80000 112859.9n 0.80000 112860.0n 0.80000 113039.9n 0.80000 113040.0n 0.80000 113219.9n 0.80000 113220.0n 0.80000 113399.9n 0.80000 113400.0n 0.80000 113579.9n 0.80000 113580.0n 0.80000 113759.9n 0.80000 113760.0n 0.80000 113939.9n 0.80000 113940.0n 0.80000 114119.9n 0.80000 114120.0n 0.80000 114299.9n 0.80000 114300.0n 0.80000 114479.9n 0.80000 114480.0n 0.80000 114659.9n 0.80000 114660.0n 0.80000 114839.9n 0.80000 114840.0n 0.80000 115019.9n 0.80000 115020.0n 0.80000 115199.9n 0.80000 115200.0n 0.80000 115379.9n 0.80000 115380.0n 0.80000 115559.9n 0.80000 115560.0n 0.80000 115739.9n 0.80000 115740.0n 0.80000 115919.9n 0.80000 115920.0n 0.80000 116099.9n 0.80000 116100.0n 0.80000 116279.9n 0.80000 116280.0n 0.80000 116459.9n 0.80000 116460.0n 0.80000 116639.9n 0.80000 116640.0n 0.80000 116819.9n 0.80000 116820.0n 0.80000 116999.9n 0.80000 117000.0n 0.80000 117179.9n 0.80000 117180.0n 0.80000 117359.9n 0.80000 117360.0n 0.80000 117539.9n 0.80000 117540.0n 0.80000 117719.9n 0.80000 117720.0n 0.80000 117899.9n 0.80000 117900.0n 0.80000 118079.9n 0.80000 118080.0n 0.80000 118259.9n 0.80000 118260.0n 0.80000 118439.9n 0.80000 118440.0n 0.80000 118619.9n 0.80000 118620.0n 0.80000 118799.9n 0.80000 118800.0n 0.80000 118979.9n 0.80000 118980.0n 0.80000 119159.9n 0.80000 119160.0n 0.80000 119339.9n 0.80000 119340.0n 0.80000 119519.9n 0.80000 119520.0n 0.80000 119699.9n 0.80000 119700.0n 0.80000 119879.9n 0.80000 119880.0n 0.80000 120059.9n 0.80000 120060.0n 0.80000 120239.9n 0.80000 120240.0n 0.80000 120419.9n 0.80000 120420.0n 0.80000 120599.9n 0.80000 120600.0n 0.80000 120779.9n 0.80000 120780.0n 0.80000 120959.9n 0.80000 120960.0n 0.80000 121139.9n 0.80000 121140.0n 0.80000 121319.9n 0.80000 121320.0n 0.80000 121499.9n 0.80000 121500.0n 0.80000 121679.9n 0.80000 121680.0n 0.80000 121859.9n 0.80000 121860.0n 0.80000 122039.9n 0.80000 122040.0n 0.80000 122219.9n 0.80000 122220.0n 0.80000 122399.9n 0.80000 122400.0n 0.80000 122579.9n 0.80000 122580.0n 0.80000 122759.9n 0.80000 122760.0n 0.80000 122939.9n 0.80000 122940.0n 0.80000 123119.9n 0.80000 123120.0n 0.80000 123299.9n 0.80000 123300.0n 0.80000 123479.9n 0.80000 123480.0n 0.80000 123659.9n 0.80000 123660.0n 0.80000 123839.9n 0.80000 123840.0n 0.80000 124019.9n 0.80000 124020.0n 0.80000 124199.9n 0.80000 124200.0n 0.80000 124379.9n 0.80000 124380.0n 0.80000 124559.9n 0.80000 124560.0n 0.80000 124739.9n 0.80000 124740.0n 0.80000 124919.9n 0.80000 124920.0n 0.80000 125099.9n 0.80000 125100.0n 0.80000 125279.9n 0.80000 125280.0n 0.80000 125459.9n 0.80000 125460.0n 0.80000 125639.9n 0.80000 125640.0n 0.80000 125819.9n 0.80000 125820.0n 0.80000 125999.9n 0.80000 126000.0n 0.80000 126179.9n 0.80000 126180.0n 0.80000 126359.9n 0.80000 126360.0n 0.80000 126539.9n 0.80000 126540.0n 0.80000 126719.9n 0.80000 126720.0n 0.80000 126899.9n 0.80000 126900.0n 0.80000 127079.9n 0.80000 127080.0n 0.80000 127259.9n 0.80000 127260.0n 0.80000 127439.9n 0.80000 127440.0n 0.80000 127619.9n 0.80000 127620.0n 0.80000 127799.9n 0.80000 127800.0n 0.80000 127979.9n 0.80000 127980.0n 0.80000 128159.9n 0.80000 128160.0n 0.80000 128339.9n 0.80000 128340.0n 0.80000 128519.9n 0.80000 128520.0n 0.80000 128699.9n 0.80000 128700.0n 0.80000 128879.9n 0.80000 128880.0n 0.80000 129059.9n 0.80000 129060.0n 0.80000 129239.9n 0.80000 129240.0n 0.80000 129419.9n 0.80000 129420.0n 0.80000 129599.9n 0.80000 129600.0n 0.80000 129779.9n 0.80000 129780.0n 0.80000 129959.9n 0.80000 129960.0n 0.80000 130139.9n 0.80000 130140.0n 0.80000 130319.9n 0.80000 130320.0n 0.80000 130499.9n 0.80000 130500.0n 0.80000 130679.9n 0.80000 130680.0n 0.80000 130859.9n 0.80000 130860.0n 0.80000 131039.9n 0.80000 131040.0n 0.80000 131219.9n 0.80000 131220.0n 0.80000 131399.9n 0.80000 131400.0n 0.80000 131579.9n 0.80000 131580.0n 0.80000 131759.9n 0.80000 131760.0n 0.80000 131939.9n 0.80000 131940.0n 0.80000 132119.9n 0.80000 132120.0n 0.80000 132299.9n 0.80000 132300.0n 0.80000 132479.9n 0.80000 132480.0n 0.80000 132659.9n 0.80000 132660.0n 0.80000 132839.9n 0.80000 132840.0n 0.80000 133019.9n 0.80000 133020.0n 0.80000 133199.9n 0.80000 133200.0n 0.80000 133379.9n 0.80000 133380.0n 0.80000 133559.9n 0.80000 133560.0n 0.80000 133739.9n 0.80000 133740.0n 0.80000 133919.9n 0.80000 133920.0n 0.80000 134099.9n 0.80000 134100.0n 0.80000 134279.9n 0.80000 134280.0n 0.80000 134459.9n 0.80000 134460.0n 0.80000 134639.9n 0.80000 134640.0n 0.80000 134819.9n 0.80000 134820.0n 0.80000 134999.9n 0.80000 135000.0n 0.80000 135179.9n 0.80000 135180.0n 0.80000 135359.9n 0.80000 135360.0n 0.80000 135539.9n 0.80000 135540.0n 0.80000 135719.9n 0.80000 135720.0n 0.80000 135899.9n 0.80000 135900.0n 0.80000 136079.9n 0.80000 136080.0n 0.80000 136259.9n 0.80000 136260.0n 0.80000 136439.9n 0.80000 136440.0n 0.80000 136619.9n 0.80000 136620.0n 0.80000 136799.9n 0.80000 136800.0n 0.80000 136979.9n 0.80000 136980.0n 0.80000 137159.9n 0.80000 137160.0n 0.80000 137339.9n 0.80000 137340.0n 0.80000 137519.9n 0.80000 137520.0n 0.80000 137699.9n 0.80000 137700.0n 0.80000 137879.9n 0.80000 137880.0n 0.80000 138059.9n 0.80000 138060.0n 0.80000 138239.9n 0.80000 138240.0n 0.80000 138419.9n 0.80000 138420.0n 0.80000 138599.9n 0.80000 138600.0n 0.80000 138779.9n 0.80000 138780.0n 0.80000 138959.9n 0.80000 138960.0n 0.80000 139139.9n 0.80000 139140.0n 0.80000 139319.9n 0.80000 139320.0n 0.80000 139499.9n 0.80000 139500.0n 0.80000 139679.9n 0.80000 139680.0n 0.80000 139859.9n 0.80000 139860.0n 0.80000 140039.9n 0.80000 140040.0n 0.80000 140219.9n 0.80000 140220.0n 0.80000 140399.9n 0.80000 140400.0n 0.80000 140579.9n 0.80000 140580.0n 0.80000 140759.9n 0.80000 140760.0n 0.80000 140939.9n 0.80000 140940.0n 0.80000 141119.9n 0.80000 141120.0n 0.80000 141299.9n 0.80000 141300.0n 0.80000 141479.9n 0.80000 141480.0n 0.80000 141659.9n 0.80000 141660.0n 0.80000 141839.9n 0.80000 141840.0n 0.80000 142019.9n 0.80000 142020.0n 0.80000 142199.9n 0.80000 142200.0n 0.80000 142379.9n 0.80000 142380.0n 0.80000 142559.9n 0.80000 142560.0n 0.80000 142739.9n 0.80000 142740.0n 0.80000 142919.9n 0.80000 142920.0n 0.80000 143099.9n 0.80000 143100.0n 0.80000 143279.9n 0.80000 143280.0n 0.80000 143459.9n 0.80000 143460.0n 0.80000 143639.9n 0.80000 143640.0n 0.80000 143819.9n 0.80000 143820.0n 0.80000 143999.9n 0.80000 144000.0n 0.80000 144179.9n 0.80000 144180.0n 0.80000 144359.9n 0.80000 144360.0n 0.80000 144539.9n 0.80000 144540.0n 0.80000 144719.9n 0.80000 144720.0n 0.80000 144899.9n 0.80000 144900.0n 0.80000 145079.9n 0.80000 145080.0n 0.80000 145259.9n 0.80000 145260.0n 0.80000 145439.9n 0.80000 145440.0n 0.80000 145619.9n 0.80000 145620.0n 0.80000 145799.9n 0.80000 145800.0n 0.80000 145979.9n 0.80000 145980.0n 0.80000 146159.9n 0.80000 146160.0n 0.80000 146339.9n 0.80000 146340.0n 0.80000 146519.9n 0.80000 146520.0n 0.80000 146699.9n 0.80000 146700.0n 0.80000 146879.9n 0.80000 146880.0n 0.80000 147059.9n 0.80000 147060.0n 0.80000 147239.9n 0.80000 147240.0n 0.80000 147419.9n 0.80000 147420.0n 0.80000 147599.9n 0.80000 147600.0n 0.80000 147779.9n 0.80000 147780.0n 0.80000 147959.9n 0.80000 147960.0n 0.80000 148139.9n 0.80000 148140.0n 0.80000 148319.9n 0.80000 148320.0n 0.80000 148499.9n 0.80000 148500.0n 0.80000 148679.9n 0.80000 148680.0n 0.80000 148859.9n 0.80000 148860.0n 0.80000 149039.9n 0.80000 149040.0n 0.80000 149219.9n 0.80000 149220.0n 0.80000 149399.9n 0.80000 149400.0n 0.80000 149579.9n 0.80000 149580.0n 0.80000 149759.9n 0.80000 149760.0n 0.80000 149939.9n 0.80000 149940.0n 0.80000 150119.9n 0.80000 150120.0n 0.80000 150299.9n 0.80000 150300.0n 0.80000 150479.9n 0.80000 150480.0n 0.80000 150659.9n 0.80000 150660.0n 0.80000 150839.9n 0.80000 150840.0n 0.80000 151019.9n 0.80000 151020.0n 0.80000 151199.9n 0.80000 151200.0n 0.80000 151379.9n 0.80000 151380.0n 0.80000 151559.9n 0.80000 151560.0n 0.80000 151739.9n 0.80000 151740.0n 0.80000 151919.9n 0.80000 151920.0n 0.80000 152099.9n 0.80000 152100.0n 0.80000 152279.9n 0.80000 152280.0n 0.80000 152459.9n 0.80000 152460.0n 0.80000 152639.9n 0.80000 152640.0n 0.80000 152819.9n 0.80000 152820.0n 0.80000 152999.9n 0.80000 153000.0n 0.80000 153179.9n 0.80000 153180.0n 0.80000 153359.9n 0.80000 153360.0n 0.80000 153539.9n 0.80000 153540.0n 0.80000 153719.9n 0.80000 153720.0n 0.80000 153899.9n 0.80000 153900.0n 0.80000 154079.9n 0.80000 154080.0n 0.80000 154259.9n 0.80000 154260.0n 0.80000 154439.9n 0.80000 154440.0n 0.80000 154619.9n 0.80000 154620.0n 0.80000 154799.9n 0.80000 154800.0n 0.80000 154979.9n 0.80000 154980.0n 0.80000 155159.9n 0.80000 155160.0n 0.80000 155339.9n 0.80000 155340.0n 0.80000 155519.9n 0.80000 155520.0n 0.80000 155699.9n 0.80000 155700.0n 0.80000 155879.9n 0.80000 155880.0n 0.80000 156059.9n 0.80000 156060.0n 0.80000 156239.9n 0.80000 156240.0n 0.80000 156419.9n 0.80000 156420.0n 0.80000 156599.9n 0.80000 156600.0n 0.80000 156779.9n 0.80000 156780.0n 0.80000 156959.9n 0.80000 156960.0n 0.80000 157139.9n 0.80000 157140.0n 0.80000 157319.9n 0.80000 157320.0n 0.80000 157499.9n 0.80000 157500.0n 0.80000 157679.9n 0.80000 157680.0n 0.80000 157859.9n 0.80000 157860.0n 0.80000 158039.9n 0.80000 158040.0n 0.80000 158219.9n 0.80000 158220.0n 0.80000 158399.9n 0.80000 158400.0n 0.80000 158579.9n 0.80000 158580.0n 0.80000 158759.9n 0.80000 158760.0n 0.80000 158939.9n 0.80000 158940.0n 0.80000 159119.9n 0.80000 159120.0n 0.80000 159299.9n 0.80000 159300.0n 0.80000 159479.9n 0.80000 159480.0n 0.80000 159659.9n 0.80000 159660.0n 0.80000 159839.9n 0.80000 159840.0n 0.80000 160019.9n 0.80000 160020.0n 0.80000 160199.9n 0.80000 160200.0n 0.80000 160379.9n 0.80000 160380.0n 0.80000 160559.9n 0.80000 160560.0n 0.80000 160739.9n 0.80000 160740.0n 0.80000 160919.9n 0.80000 160920.0n 0.80000 161099.9n 0.80000 161100.0n 0.80000 161279.9n 0.80000 161280.0n 0.80000 161459.9n 0.80000 161460.0n 0.80000 161639.9n 0.80000 161640.0n 0.80000 161819.9n 0.80000 161820.0n 0.80000 161999.9n 0.80000 162000.0n 0.80000 162179.9n 0.80000 162180.0n 0.80000 162359.9n 0.80000 162360.0n 0.80000 162539.9n 0.80000 162540.0n 0.80000 162719.9n 0.80000 162720.0n 0.80000 162899.9n 0.80000 162900.0n 0.80000 163079.9n 0.80000 163080.0n 0.80000 163259.9n 0.80000 163260.0n 0.80000 163439.9n 0.80000 163440.0n 0.80000 163619.9n 0.80000 163620.0n 0.80000 163799.9n 0.80000 163800.0n 0.80000 163979.9n 0.80000 163980.0n 0.80000 164159.9n 0.80000 164160.0n 0.80000 164339.9n 0.80000 164340.0n 0.80000 164519.9n 0.80000 164520.0n 0.80000 164699.9n 0.80000 164700.0n 0.80000 164879.9n 0.80000 164880.0n 0.80000 165059.9n 0.80000 165060.0n 0.80000 165239.9n 0.80000 165240.0n 0.80000 165419.9n 0.80000 165420.0n 0.80000 165599.9n 0.80000 165600.0n 0.80000 165779.9n 0.80000 165780.0n 0.80000 165959.9n 0.80000 165960.0n 0.80000 166139.9n 0.80000 166140.0n 0.80000 166319.9n 0.80000 166320.0n 0.80000 166499.9n 0.80000 166500.0n 0.80000 166679.9n 0.80000 166680.0n 0.80000 166859.9n 0.80000 166860.0n 0.80000 167039.9n 0.80000 167040.0n 0.80000 167219.9n 0.80000 167220.0n 0.80000 167399.9n 0.80000 167400.0n 0.80000 167579.9n 0.80000 167580.0n 0.80000 167759.9n 0.80000 167760.0n 0.80000 167939.9n 0.80000 167940.0n 0.80000 168119.9n 0.80000 168120.0n 0.80000 168299.9n 0.80000 168300.0n 0.80000 168479.9n 0.80000 168480.0n 0.80000 168659.9n 0.80000 168660.0n 0.80000 168839.9n 0.80000 168840.0n 0.80000 169019.9n 0.80000 169020.0n 0.80000 169199.9n 0.80000 169200.0n 0.80000 169379.9n 0.80000 169380.0n 0.80000 169559.9n 0.80000 169560.0n 0.80000 169739.9n 0.80000 169740.0n 0.80000 169919.9n 0.80000 169920.0n 0.80000 170099.9n 0.80000 170100.0n 0.80000 170279.9n 0.80000 170280.0n 0.80000 170459.9n 0.80000 170460.0n 0.80000 170639.9n 0.80000 170640.0n 0.80000 170819.9n 0.80000 170820.0n 0.80000 170999.9n 0.80000 171000.0n 0.80000 171179.9n 0.80000 171180.0n 0.80000 171359.9n 0.80000 171360.0n 0.80000 171539.9n 0.80000 171540.0n 0.80000 171719.9n 0.80000 171720.0n 0.80000 171899.9n 0.80000 171900.0n 0.80000 172079.9n 0.80000 172080.0n 0.80000 172259.9n 0.80000 172260.0n 0.80000 172439.9n 0.80000 172440.0n 0.80000 172619.9n 0.80000 172620.0n 0.80000 172799.9n 0.80000 172800.0n 0.00000 172979.9n 0.00000 172980.0n 0.00000 173159.9n 0.00000 173160.0n 0.00000 173339.9n 0.00000 173340.0n 0.00000 173519.9n 0.00000 173520.0n 0.00000 173699.9n 0.00000 173700.0n 0.00000 173879.9n 0.00000 173880.0n 0.00000 174059.9n 0.00000 174060.0n 0.00000 174239.9n 0.00000 174240.0n 0.00000 174419.9n 0.00000 174420.0n 0.00000 174599.9n 0.00000 174600.0n 0.00000 174779.9n 0.00000 174780.0n 0.00000 174959.9n 0.00000 174960.0n 0.00000 175139.9n 0.00000 175140.0n 0.00000 175319.9n 0.00000 175320.0n 0.00000 175499.9n 0.00000 175500.0n 0.00000 175679.9n 0.00000 175680.0n 0.00000 175859.9n 0.00000 175860.0n 0.00000 176039.9n 0.00000 176040.0n 0.00000 176219.9n 0.00000 176220.0n 0.00000 176399.9n 0.00000 176400.0n 0.00000 176579.9n 0.00000 176580.0n 0.00000 176759.9n 0.00000 176760.0n 0.00000 176939.9n 0.00000 176940.0n 0.00000 177119.9n 0.00000 177120.0n 0.00000 177299.9n 0.00000 177300.0n 0.00000 177479.9n 0.00000 177480.0n 0.00000 177659.9n 0.00000 177660.0n 0.00000 177839.9n 0.00000 177840.0n 0.00000 178019.9n 0.00000 178020.0n 0.00000 178199.9n 0.00000 178200.0n 0.00000 178379.9n 0.00000 178380.0n 0.00000 178559.9n 0.00000 178560.0n 0.00000 178739.9n 0.00000 178740.0n 0.00000 178919.9n 0.00000 178920.0n 0.00000 179099.9n 0.00000 179100.0n 0.00000 179279.9n 0.00000 179280.0n 0.00000 179459.9n 0.00000 179460.0n 0.00000 179639.9n 0.00000 179640.0n 0.00000 179819.9n 0.00000 179820.0n 0.00000 179999.9n 0.00000 180000.0n 0.00000 180179.9n 0.00000 180180.0n 0.00000 180359.9n 0.00000 180360.0n 0.00000 180539.9n 0.00000 180540.0n 0.00000 180719.9n 0.00000 180720.0n 0.00000 180899.9n 0.00000 180900.0n 0.00000 181079.9n 0.00000 181080.0n 0.00000 181259.9n 0.00000 181260.0n 0.00000 181439.9n 0.00000 181440.0n 0.00000 181619.9n 0.00000 181620.0n 0.00000 181799.9n 0.00000 181800.0n 0.00000 181979.9n 0.00000 181980.0n 0.00000 182159.9n 0.00000 182160.0n 0.00000 182339.9n 0.00000 182340.0n 0.00000 182519.9n 0.00000 182520.0n 0.00000 182699.9n 0.00000 182700.0n 0.00000 182879.9n 0.00000 182880.0n 0.00000 183059.9n 0.00000 183060.0n 0.00000 183239.9n 0.00000 183240.0n 0.00000 183419.9n 0.00000 183420.0n 0.00000)
Vxp0 a_xp0 0 PWL(0.0n -0.31038 179.9n -0.31038 180.0n 0.47556 359.9n 0.47556 360.0n 0.56449 539.9n 0.56449 540.0n -0.04662 719.9n -0.04662 720.0n 1.36668 899.9n 1.36668 900.0n 1.38855 1079.9n 1.38855 1080.0n 0.35630 1259.9n 0.35630 1260.0n 0.55066 1439.9n 0.55066 1440.0n 0.73600 1619.9n 0.73600 1620.0n 0.26419 1799.9n 0.26419 1800.0n 1.07007 1979.9n 1.07007 1980.0n 0.31139 2159.9n 0.31139 2160.0n 0.17082 2339.9n 0.17082 2340.0n 0.52079 2519.9n 0.52079 2520.0n 0.96459 2699.9n 0.96459 2700.0n 0.86030 2879.9n 0.86030 2880.0n 0.69502 3059.9n 0.69502 3060.0n 0.27076 3239.9n 0.27076 3240.0n 0.27643 3419.9n 0.27643 3420.0n 0.69969 3599.9n 0.69969 3600.0n 0.21498 3779.9n 0.21498 3780.0n 1.21890 3959.9n 1.21890 3960.0n 0.10559 4139.9n 0.10559 4140.0n 0.24079 4319.9n 0.24079 4320.0n 0.43581 4499.9n 0.43581 4500.0n 0.88832 4679.9n 0.88832 4680.0n 0.48508 4859.9n 0.48508 4860.0n 0.70685 5039.9n 0.70685 5040.0n 0.55006 5219.9n 0.55006 5220.0n 0.20119 5399.9n 0.20119 5400.0n 0.53141 5579.9n 0.53141 5580.0n -0.14927 5759.9n -0.14927 5760.0n 0.10559 5939.9n 0.10559 5940.0n 1.38855 6119.9n 1.38855 6120.0n 0.96459 6299.9n 0.96459 6300.0n 0.24079 6479.9n 0.24079 6480.0n 0.52079 6659.9n 0.52079 6660.0n 0.27076 6839.9n 0.27076 6840.0n 0.69969 7019.9n 0.69969 7020.0n 0.35630 7199.9n 0.35630 7200.0n 0.86030 7379.9n 0.86030 7380.0n 0.55066 7559.9n 0.55066 7560.0n 0.88832 7739.9n 0.88832 7740.0n 0.53141 7919.9n 0.53141 7920.0n 1.36668 8099.9n 1.36668 8100.0n 0.31139 8279.9n 0.31139 8280.0n 0.27643 8459.9n 0.27643 8460.0n 0.43581 8639.9n 0.43581 8640.0n 0.47556 8819.9n 0.47556 8820.0n 0.48508 8999.9n 0.48508 9000.0n 0.21498 9179.9n 0.21498 9180.0n 0.20119 9359.9n 0.20119 9360.0n 0.70685 9539.9n 0.70685 9540.0n 0.55006 9719.9n 0.55006 9720.0n -0.14927 9899.9n -0.14927 9900.0n 0.26419 10079.9n 0.26419 10080.0n 1.07007 10259.9n 1.07007 10260.0n 0.56449 10439.9n 0.56449 10440.0n 0.69502 10619.9n 0.69502 10620.0n 1.21890 10799.9n 1.21890 10800.0n 0.17082 10979.9n 0.17082 10980.0n 0.73600 11159.9n 0.73600 11160.0n -0.04662 11339.9n -0.04662 11340.0n -0.31038 11519.9n -0.31038 11520.0n -0.14927 11699.9n -0.14927 11700.0n 0.86030 11879.9n 0.86030 11880.0n 0.73600 12059.9n 0.73600 12060.0n 0.43581 12239.9n 0.43581 12240.0n 1.07007 12419.9n 1.07007 12420.0n 1.21890 12599.9n 1.21890 12600.0n 0.55066 12779.9n 0.55066 12780.0n -0.31038 12959.9n -0.31038 12960.0n 0.27076 13139.9n 0.27076 13140.0n 0.56449 13319.9n 0.56449 13320.0n 0.69969 13499.9n 0.69969 13500.0n 0.21498 13679.9n 0.21498 13680.0n 0.52079 13859.9n 0.52079 13860.0n 0.20119 14039.9n 0.20119 14040.0n 0.35630 14219.9n 0.35630 14220.0n 0.88832 14399.9n 0.88832 14400.0n 0.24079 14579.9n 0.24079 14580.0n 0.70685 14759.9n 0.70685 14760.0n -0.04662 14939.9n -0.04662 14940.0n 0.53141 15119.9n 0.53141 15120.0n 0.96459 15299.9n 0.96459 15300.0n 0.69502 15479.9n 0.69502 15480.0n 0.31139 15659.9n 0.31139 15660.0n 0.47556 15839.9n 0.47556 15840.0n 0.27643 16019.9n 0.27643 16020.0n 0.17082 16199.9n 0.17082 16200.0n 0.10559 16379.9n 0.10559 16380.0n 0.55006 16559.9n 0.55006 16560.0n 0.48508 16739.9n 0.48508 16740.0n 1.36668 16919.9n 1.36668 16920.0n 0.26419 17099.9n 0.26419 17100.0n 1.38855 17279.9n 1.38855 17280.0n 0.53141 17459.9n 0.53141 17460.0n 0.55006 17639.9n 0.55006 17640.0n 0.20119 17819.9n 0.20119 17820.0n 0.27643 17999.9n 0.27643 18000.0n 0.56449 18179.9n 0.56449 18180.0n -0.31038 18359.9n -0.31038 18360.0n 1.21890 18539.9n 1.21890 18540.0n 0.55066 18719.9n 0.55066 18720.0n 0.70685 18899.9n 0.70685 18900.0n 0.69502 19079.9n 0.69502 19080.0n 0.21498 19259.9n 0.21498 19260.0n 0.31139 19439.9n 0.31139 19440.0n 0.35630 19619.9n 0.35630 19620.0n 0.27076 19799.9n 0.27076 19800.0n 0.88832 19979.9n 0.88832 19980.0n 0.43581 20159.9n 0.43581 20160.0n -0.04662 20339.9n -0.04662 20340.0n 0.24079 20519.9n 0.24079 20520.0n 0.52079 20699.9n 0.52079 20700.0n 0.47556 20879.9n 0.47556 20880.0n 0.10559 21059.9n 0.10559 21060.0n 0.48508 21239.9n 0.48508 21240.0n 0.86030 21419.9n 0.86030 21420.0n 1.07007 21599.9n 1.07007 21600.0n 1.36668 21779.9n 1.36668 21780.0n 1.38855 21959.9n 1.38855 21960.0n -0.14927 22139.9n -0.14927 22140.0n 0.69969 22319.9n 0.69969 22320.0n 0.17082 22499.9n 0.17082 22500.0n 0.26419 22679.9n 0.26419 22680.0n 0.73600 22859.9n 0.73600 22860.0n 0.96459 23039.9n 0.96459 23040.0n 0.43581 23219.9n 0.43581 23220.0n 0.86030 23399.9n 0.86030 23400.0n 0.17082 23579.9n 0.17082 23580.0n 0.27643 23759.9n 0.27643 23760.0n 0.48508 23939.9n 0.48508 23940.0n 0.20119 24119.9n 0.20119 24120.0n 0.35630 24299.9n 0.35630 24300.0n 1.21890 24479.9n 1.21890 24480.0n 0.70685 24659.9n 0.70685 24660.0n 0.56449 24839.9n 0.56449 24840.0n 0.21498 25019.9n 0.21498 25020.0n 0.55066 25199.9n 0.55066 25200.0n 1.07007 25379.9n 1.07007 25380.0n 0.27076 25559.9n 0.27076 25560.0n 1.36668 25739.9n 1.36668 25740.0n 0.73600 25919.9n 0.73600 25920.0n 0.24079 26099.9n 0.24079 26100.0n 0.69502 26279.9n 0.69502 26280.0n 0.88832 26459.9n 0.88832 26460.0n -0.04662 26639.9n -0.04662 26640.0n 0.69969 26819.9n 0.69969 26820.0n 0.31139 26999.9n 0.31139 27000.0n 0.55006 27179.9n 0.55006 27180.0n 0.52079 27359.9n 0.52079 27360.0n 0.53141 27539.9n 0.53141 27540.0n -0.31038 27719.9n -0.31038 27720.0n 0.47556 27899.9n 0.47556 27900.0n -0.14927 28079.9n -0.14927 28080.0n 0.10559 28259.9n 0.10559 28260.0n 1.38855 28439.9n 1.38855 28440.0n 0.96459 28619.9n 0.96459 28620.0n 0.26419 28799.9n 0.26419 28800.0n 1.21890 28979.9n 1.21890 28980.0n 0.31139 29159.9n 0.31139 29160.0n 0.69502 29339.9n 0.69502 29340.0n 0.86030 29519.9n 0.86030 29520.0n 0.26419 29699.9n 0.26419 29700.0n 0.52079 29879.9n 0.52079 29880.0n 0.47556 30059.9n 0.47556 30060.0n 0.27076 30239.9n 0.27076 30240.0n -0.04662 30419.9n -0.04662 30420.0n 0.56449 30599.9n 0.56449 30600.0n 0.48508 30779.9n 0.48508 30780.0n 0.55006 30959.9n 0.55006 30960.0n 0.27643 31139.9n 0.27643 31140.0n 0.96459 31319.9n 0.96459 31320.0n 0.55066 31499.9n 0.55066 31500.0n -0.14927 31679.9n -0.14927 31680.0n 0.73600 31859.9n 0.73600 31860.0n 0.88832 32039.9n 0.88832 32040.0n -0.31038 32219.9n -0.31038 32220.0n 0.43581 32399.9n 0.43581 32400.0n 0.70685 32579.9n 0.70685 32580.0n 0.21498 32759.9n 0.21498 32760.0n 0.20119 32939.9n 0.20119 32940.0n 0.35630 33119.9n 0.35630 33120.0n 0.17082 33299.9n 0.17082 33300.0n 0.10559 33479.9n 0.10559 33480.0n 0.69969 33659.9n 0.69969 33660.0n 1.07007 33839.9n 1.07007 33840.0n 1.36668 34019.9n 1.36668 34020.0n 0.24079 34199.9n 0.24079 34200.0n 1.38855 34379.9n 1.38855 34380.0n 0.53141 34559.9n 0.53141 34560.0n 0.69502 34739.9n 0.69502 34740.0n 0.70685 34919.9n 0.70685 34920.0n 0.10559 35099.9n 0.10559 35100.0n -0.31038 35279.9n -0.31038 35280.0n 1.07007 35459.9n 1.07007 35460.0n 0.69969 35639.9n 0.69969 35640.0n 0.52079 35819.9n 0.52079 35820.0n 0.55066 35999.9n 0.55066 36000.0n 0.31139 36179.9n 0.31139 36180.0n 0.73600 36359.9n 0.73600 36360.0n 0.17082 36539.9n 0.17082 36540.0n 0.24079 36719.9n 0.24079 36720.0n 0.56449 36899.9n 0.56449 36900.0n 0.20119 37079.9n 0.20119 37080.0n -0.14927 37259.9n -0.14927 37260.0n 0.86030 37439.9n 0.86030 37440.0n 1.38855 37619.9n 1.38855 37620.0n 0.27076 37799.9n 0.27076 37800.0n 0.26419 37979.9n 0.26419 37980.0n 1.21890 38159.9n 1.21890 38160.0n 0.55006 38339.9n 0.55006 38340.0n 0.43581 38519.9n 0.43581 38520.0n 0.47556 38699.9n 0.47556 38700.0n 0.21498 38879.9n 0.21498 38880.0n 1.36668 39059.9n 1.36668 39060.0n 0.35630 39239.9n 0.35630 39240.0n 0.27643 39419.9n 0.27643 39420.0n 0.48508 39599.9n 0.48508 39600.0n 0.88832 39779.9n 0.88832 39780.0n 0.53141 39959.9n 0.53141 39960.0n -0.04662 40139.9n -0.04662 40140.0n 0.96459 40319.9n 0.96459 40320.0n 0.20119 40499.9n 0.20119 40500.0n 0.55066 40679.9n 0.55066 40680.0n 1.07007 40859.9n 1.07007 40860.0n 0.10559 41039.9n 0.10559 41040.0n 0.26419 41219.9n 0.26419 41220.0n 0.70685 41399.9n 0.70685 41400.0n 0.21498 41579.9n 0.21498 41580.0n 1.21890 41759.9n 1.21890 41760.0n 0.88832 41939.9n 0.88832 41940.0n 0.47556 42119.9n 0.47556 42120.0n 0.35630 42299.9n 0.35630 42300.0n 0.69969 42479.9n 0.69969 42480.0n 0.31139 42659.9n 0.31139 42660.0n 0.56449 42839.9n 0.56449 42840.0n 0.86030 43019.9n 0.86030 43020.0n 0.69502 43199.9n 0.69502 43200.0n -0.04662 43379.9n -0.04662 43380.0n 0.48508 43559.9n 0.48508 43560.0n 0.43581 43739.9n 0.43581 43740.0n -0.14927 43919.9n -0.14927 43920.0n 0.52079 44099.9n 0.52079 44100.0n -0.31038 44279.9n -0.31038 44280.0n 0.27076 44459.9n 0.27076 44460.0n 0.53141 44639.9n 0.53141 44640.0n 0.17082 44819.9n 0.17082 44820.0n 1.36668 44999.9n 1.36668 45000.0n 0.73600 45179.9n 0.73600 45180.0n 0.55006 45359.9n 0.55006 45360.0n 1.38855 45539.9n 1.38855 45540.0n 0.24079 45719.9n 0.24079 45720.0n 0.27643 45899.9n 0.27643 45900.0n 0.96459 46079.9n 0.96459 46080.0n 0.52079 46259.9n 0.52079 46260.0n 0.86030 46439.9n 0.86030 46440.0n 0.70685 46619.9n 0.70685 46620.0n 0.88832 46799.9n 0.88832 46800.0n 0.73600 46979.9n 0.73600 46980.0n 1.38855 47159.9n 1.38855 47160.0n 0.47556 47339.9n 0.47556 47340.0n 0.21498 47519.9n 0.21498 47520.0n 0.48508 47699.9n 0.48508 47700.0n 0.24079 47879.9n 0.24079 47880.0n 0.56449 48059.9n 0.56449 48060.0n -0.14927 48239.9n -0.14927 48240.0n 0.27643 48419.9n 0.27643 48420.0n 0.96459 48599.9n 0.96459 48600.0n 0.53141 48779.9n 0.53141 48780.0n 0.17082 48959.9n 0.17082 48960.0n -0.04662 49139.9n -0.04662 49140.0n 0.26419 49319.9n 0.26419 49320.0n 1.07007 49499.9n 1.07007 49500.0n -0.31038 49679.9n -0.31038 49680.0n 0.35630 49859.9n 0.35630 49860.0n 0.55006 50039.9n 0.55006 50040.0n 0.31139 50219.9n 0.31139 50220.0n 0.43581 50399.9n 0.43581 50400.0n 0.20119 50579.9n 0.20119 50580.0n 1.36668 50759.9n 1.36668 50760.0n 1.21890 50939.9n 1.21890 50940.0n 0.69969 51119.9n 0.69969 51120.0n 0.10559 51299.9n 0.10559 51300.0n 0.55066 51479.9n 0.55066 51480.0n 0.27076 51659.9n 0.27076 51660.0n 0.69502 51839.9n 0.69502 51840.0n 0.53141 52019.9n 0.53141 52020.0n 0.88832 52199.9n 0.88832 52200.0n 0.48508 52379.9n 0.48508 52380.0n 0.21498 52559.9n 0.21498 52560.0n 1.21890 52739.9n 1.21890 52740.0n 0.43581 52919.9n 0.43581 52920.0n 0.35630 53099.9n 0.35630 53100.0n 0.27643 53279.9n 0.27643 53280.0n 0.96459 53459.9n 0.96459 53460.0n 0.27076 53639.9n 0.27076 53640.0n -0.14927 53819.9n -0.14927 53820.0n -0.31038 53999.9n -0.31038 54000.0n 0.26419 54179.9n 0.26419 54180.0n 0.70685 54359.9n 0.70685 54360.0n 0.47556 54539.9n 0.47556 54540.0n 0.55006 54719.9n 0.55006 54720.0n 0.52079 54899.9n 0.52079 54900.0n 0.69502 55079.9n 0.69502 55080.0n 0.17082 55259.9n 0.17082 55260.0n 0.86030 55439.9n 0.86030 55440.0n 0.20119 55619.9n 0.20119 55620.0n 0.31139 55799.9n 0.31139 55800.0n 1.07007 55979.9n 1.07007 55980.0n 1.36668 56159.9n 1.36668 56160.0n 0.10559 56339.9n 0.10559 56340.0n 1.38855 56519.9n 1.38855 56520.0n 0.73600 56699.9n 0.73600 56700.0n 0.55066 56879.9n 0.55066 56880.0n 0.56449 57059.9n 0.56449 57060.0n 0.69969 57239.9n 0.69969 57240.0n -0.04662 57419.9n -0.04662 57420.0n 0.24079 57599.9n 0.24079 57600.0n 0.56449 57779.9n 0.56449 57780.0n 0.70685 57959.9n 0.70685 57960.0n 0.27076 58139.9n 0.27076 58140.0n 0.55006 58319.9n 0.55006 58320.0n 0.52079 58499.9n 0.52079 58500.0n 0.26419 58679.9n 0.26419 58680.0n 0.21498 58859.9n 0.21498 58860.0n 0.47556 59039.9n 0.47556 59040.0n 0.24079 59219.9n 0.24079 59220.0n 0.69969 59399.9n 0.69969 59400.0n 0.53141 59579.9n 0.53141 59580.0n 1.21890 59759.9n 1.21890 59760.0n 1.38855 59939.9n 1.38855 59940.0n 0.69502 60119.9n 0.69502 60120.0n 1.07007 60299.9n 1.07007 60300.0n 0.96459 60479.9n 0.96459 60480.0n 0.86030 60659.9n 0.86030 60660.0n 0.48508 60839.9n 0.48508 60840.0n 0.35630 61019.9n 0.35630 61020.0n 0.73600 61199.9n 0.73600 61200.0n 0.10559 61379.9n 0.10559 61380.0n 0.88832 61559.9n 0.88832 61560.0n 0.27643 61739.9n 0.27643 61740.0n 0.20119 61919.9n 0.20119 61920.0n 0.55066 62099.9n 0.55066 62100.0n -0.14927 62279.9n -0.14927 62280.0n 0.17082 62459.9n 0.17082 62460.0n 1.36668 62639.9n 1.36668 62640.0n 0.31139 62819.9n 0.31139 62820.0n -0.31038 62999.9n -0.31038 63000.0n -0.04662 63179.9n -0.04662 63180.0n 0.43581 63359.9n 0.43581 63360.0n 0.27643 63539.9n 0.27643 63540.0n 0.35630 63719.9n 0.35630 63720.0n 0.55006 63899.9n 0.55006 63900.0n 0.86030 64079.9n 0.86030 64080.0n 0.20119 64259.9n 0.20119 64260.0n -0.14927 64439.9n -0.14927 64440.0n 0.10559 64619.9n 0.10559 64620.0n 0.27076 64799.9n 0.27076 64800.0n -0.04662 64979.9n -0.04662 64980.0n 0.88832 65159.9n 0.88832 65160.0n 0.17082 65339.9n 0.17082 65340.0n 0.69502 65519.9n 0.69502 65520.0n 0.56449 65699.9n 0.56449 65700.0n 0.73600 65879.9n 0.73600 65880.0n 1.38855 66059.9n 1.38855 66060.0n 0.47556 66239.9n 0.47556 66240.0n -0.31038 66419.9n -0.31038 66420.0n 0.31139 66599.9n 0.31139 66600.0n 0.24079 66779.9n 0.24079 66780.0n 1.07007 66959.9n 1.07007 66960.0n 0.96459 67139.9n 0.96459 67140.0n 0.21498 67319.9n 0.21498 67320.0n 0.70685 67499.9n 0.70685 67500.0n 1.36668 67679.9n 1.36668 67680.0n 0.26419 67859.9n 0.26419 67860.0n 0.55066 68039.9n 0.55066 68040.0n 0.48508 68219.9n 0.48508 68220.0n 0.53141 68399.9n 0.53141 68400.0n 0.69969 68579.9n 0.69969 68580.0n 0.52079 68759.9n 0.52079 68760.0n 0.43581 68939.9n 0.43581 68940.0n 1.21890 69119.9n 1.21890 69120.0n 0.47556 69299.9n 0.47556 69300.0n 0.31139 69479.9n 0.31139 69480.0n 0.43581 69659.9n 0.43581 69660.0n 0.17082 69839.9n 0.17082 69840.0n 0.55066 70019.9n 0.55066 70020.0n 0.21498 70199.9n 0.21498 70200.0n 0.35630 70379.9n 0.35630 70380.0n 0.56449 70559.9n 0.56449 70560.0n -0.31038 70739.9n -0.31038 70740.0n 0.69969 70919.9n 0.69969 70920.0n 0.70685 71099.9n 0.70685 71100.0n 0.86030 71279.9n 0.86030 71280.0n 0.20119 71459.9n 0.20119 71460.0n 1.21890 71639.9n 1.21890 71640.0n 0.27076 71819.9n 0.27076 71820.0n 0.24079 71999.9n 0.24079 72000.0n 0.96459 72179.9n 0.96459 72180.0n 0.10559 72359.9n 0.10559 72360.0n 1.38855 72539.9n 1.38855 72540.0n 0.73600 72719.9n 0.73600 72720.0n 0.26419 72899.9n 0.26419 72900.0n -0.04662 73079.9n -0.04662 73080.0n -0.14927 73259.9n -0.14927 73260.0n 0.55006 73439.9n 0.55006 73440.0n 1.36668 73619.9n 1.36668 73620.0n 0.27643 73799.9n 0.27643 73800.0n 0.52079 73979.9n 0.52079 73980.0n 0.48508 74159.9n 0.48508 74160.0n 0.53141 74339.9n 0.53141 74340.0n 1.07007 74519.9n 1.07007 74520.0n 0.88832 74699.9n 0.88832 74700.0n 0.69502 74879.9n 0.69502 74880.0n 1.36668 75059.9n 1.36668 75060.0n 0.88832 75239.9n 0.88832 75240.0n 0.27643 75419.9n 0.27643 75420.0n 0.55066 75599.9n 0.55066 75600.0n 0.55006 75779.9n 0.55006 75780.0n 0.20119 75959.9n 0.20119 75960.0n 0.47556 76139.9n 0.47556 76140.0n 1.38855 76319.9n 1.38855 76320.0n 0.52079 76499.9n 0.52079 76500.0n 0.35630 76679.9n 0.35630 76680.0n 0.56449 76859.9n 0.56449 76860.0n 0.73600 77039.9n 0.73600 77040.0n 0.86030 77219.9n 0.86030 77220.0n 1.21890 77399.9n 1.21890 77400.0n 0.27076 77579.9n 0.27076 77580.0n -0.04662 77759.9n -0.04662 77760.0n 0.24079 77939.9n 0.24079 77940.0n 0.43581 78119.9n 0.43581 78120.0n 0.96459 78299.9n 0.96459 78300.0n 0.69969 78479.9n 0.69969 78480.0n 0.48508 78659.9n 0.48508 78660.0n -0.31038 78839.9n -0.31038 78840.0n 1.07007 79019.9n 1.07007 79020.0n 0.70685 79199.9n 0.70685 79200.0n 0.31139 79379.9n 0.31139 79380.0n 0.21498 79559.9n 0.21498 79560.0n 0.17082 79739.9n 0.17082 79740.0n 0.26419 79919.9n 0.26419 79920.0n 0.10559 80099.9n 0.10559 80100.0n 0.53141 80279.9n 0.53141 80280.0n 0.69502 80459.9n 0.69502 80460.0n -0.14927 80639.9n -0.14927 80640.0n 0.27076 80819.9n 0.27076 80820.0n 1.38855 80999.9n 1.38855 81000.0n 0.69969 81179.9n 0.69969 81180.0n 0.31139 81359.9n 0.31139 81360.0n -0.04662 81539.9n -0.04662 81540.0n 1.36668 81719.9n 1.36668 81720.0n 0.53141 81899.9n 0.53141 81900.0n 0.26419 82079.9n 0.26419 82080.0n 0.17082 82259.9n 0.17082 82260.0n -0.14927 82439.9n -0.14927 82440.0n 0.48508 82619.9n 0.48508 82620.0n 0.70685 82799.9n 0.70685 82800.0n 0.55006 82979.9n 0.55006 82980.0n 0.69502 83159.9n 0.69502 83160.0n 0.27643 83339.9n 0.27643 83340.0n 0.35630 83519.9n 0.35630 83520.0n 0.86030 83699.9n 0.86030 83700.0n 0.10559 83879.9n 0.10559 83880.0n 0.88832 84059.9n 0.88832 84060.0n 0.24079 84239.9n 0.24079 84240.0n 0.21498 84419.9n 0.21498 84420.0n 0.20119 84599.9n 0.20119 84600.0n 0.43581 84779.9n 0.43581 84780.0n 0.47556 84959.9n 0.47556 84960.0n 0.73600 85139.9n 0.73600 85140.0n 0.55066 85319.9n 0.55066 85320.0n 1.21890 85499.9n 1.21890 85500.0n -0.31038 85679.9n -0.31038 85680.0n 1.07007 85859.9n 1.07007 85860.0n 0.52079 86039.9n 0.52079 86040.0n 0.96459 86219.9n 0.96459 86220.0n 0.56449 86399.9n 0.56449 86400.0n 0.96459 86579.9n 0.96459 86580.0n 0.48508 86759.9n 0.48508 86760.0n 0.20119 86939.9n 0.20119 86940.0n 0.70685 87119.9n 0.70685 87120.0n 1.07007 87299.9n 1.07007 87300.0n 0.10559 87479.9n 0.10559 87480.0n 0.27076 87659.9n 0.27076 87660.0n 0.69502 87839.9n 0.69502 87840.0n 0.17082 88019.9n 0.17082 88020.0n 0.88832 88199.9n 0.88832 88200.0n -0.14927 88379.9n -0.14927 88380.0n 0.73600 88559.9n 0.73600 88560.0n 0.26419 88739.9n 0.26419 88740.0n 0.55066 88919.9n 0.55066 88920.0n 0.24079 89099.9n 0.24079 89100.0n 0.52079 89279.9n 0.52079 89280.0n 0.35630 89459.9n 0.35630 89460.0n 0.21498 89639.9n 0.21498 89640.0n 0.55006 89819.9n 0.55006 89820.0n 0.53141 89999.9n 0.53141 90000.0n 0.27643 90179.9n 0.27643 90180.0n 0.69969 90359.9n 0.69969 90360.0n 0.43581 90539.9n 0.43581 90540.0n 0.86030 90719.9n 0.86030 90720.0n 0.31139 90899.9n 0.31139 90900.0n 1.21890 91079.9n 1.21890 91080.0n 1.36668 91259.9n 1.36668 91260.0n 1.38855 91439.9n 1.38855 91440.0n 0.56449 91619.9n 0.56449 91620.0n 0.47556 91799.9n 0.47556 91800.0n -0.31038 91979.9n -0.31038 91980.0n -0.04662 92159.9n -0.04662 92160.0n 1.38855 92339.9n 1.38855 92340.0n 0.96459 92519.9n 0.96459 92520.0n 0.10559 92699.9n 0.10559 92700.0n 0.47556 92879.9n 0.47556 92880.0n 0.27643 93059.9n 0.27643 93060.0n 0.53141 93239.9n 0.53141 93240.0n 1.07007 93419.9n 1.07007 93420.0n -0.14927 93599.9n -0.14927 93600.0n 0.26419 93779.9n 0.26419 93780.0n 0.31139 93959.9n 0.31139 93960.0n 0.73600 94139.9n 0.73600 94140.0n 1.21890 94319.9n 1.21890 94320.0n 0.48508 94499.9n 0.48508 94500.0n 0.56449 94679.9n 0.56449 94680.0n 1.36668 94859.9n 1.36668 94860.0n 0.69969 95039.9n 0.69969 95040.0n 0.20119 95219.9n 0.20119 95220.0n 0.43581 95399.9n 0.43581 95400.0n 0.70685 95579.9n 0.70685 95580.0n -0.04662 95759.9n -0.04662 95760.0n 0.27076 95939.9n 0.27076 95940.0n 0.52079 96119.9n 0.52079 96120.0n 0.55006 96299.9n 0.55006 96300.0n 0.55066 96479.9n 0.55066 96480.0n 0.88832 96659.9n 0.88832 96660.0n 0.86030 96839.9n 0.86030 96840.0n 0.69502 97019.9n 0.69502 97020.0n 0.24079 97199.9n 0.24079 97200.0n -0.31038 97379.9n -0.31038 97380.0n 0.35630 97559.9n 0.35630 97560.0n 0.17082 97739.9n 0.17082 97740.0n 0.21498 97919.9n 0.21498 97920.0n 0.27076 98099.9n 0.27076 98100.0n 0.47556 98279.9n 0.47556 98280.0n 0.53141 98459.9n 0.53141 98460.0n -0.31038 98639.9n -0.31038 98640.0n 0.70685 98819.9n 0.70685 98820.0n 0.55006 98999.9n 0.55006 99000.0n 0.56449 99179.9n 0.56449 99180.0n 0.20119 99359.9n 0.20119 99360.0n 1.21890 99539.9n 1.21890 99540.0n -0.04662 99719.9n -0.04662 99720.0n 0.24079 99899.9n 0.24079 99900.0n 0.10559 100079.9n 0.10559 100080.0n 0.21498 100259.9n 0.21498 100260.0n 0.96459 100439.9n 0.96459 100440.0n 0.73600 100619.9n 0.73600 100620.0n 1.38855 100799.9n 1.38855 100800.0n 0.88832 100979.9n 0.88832 100980.0n 0.43581 101159.9n 0.43581 101160.0n 0.69502 101339.9n 0.69502 101340.0n 0.69969 101519.9n 0.69969 101520.0n 0.17082 101699.9n 0.17082 101700.0n 0.48508 101879.9n 0.48508 101880.0n 0.31139 102059.9n 0.31139 102060.0n 0.27643 102239.9n 0.27643 102240.0n 0.26419 102419.9n 0.26419 102420.0n 1.07007 102599.9n 1.07007 102600.0n 0.52079 102779.9n 0.52079 102780.0n 1.36668 102959.9n 1.36668 102960.0n 0.55066 103139.9n 0.55066 103140.0n 0.35630 103319.9n 0.35630 103320.0n 0.86030 103499.9n 0.86030 103500.0n -0.14927 103679.9n -0.14927 103680.0n 1.21890 103859.9n 1.21890 103860.0n 0.10559 104039.9n 0.10559 104040.0n 0.56449 104219.9n 0.56449 104220.0n -0.04662 104399.9n -0.04662 104400.0n 1.07007 104579.9n 1.07007 104580.0n 0.96459 104759.9n 0.96459 104760.0n 0.24079 104939.9n 0.24079 104940.0n 0.27076 105119.9n 0.27076 105120.0n 0.53141 105299.9n 0.53141 105300.0n 0.43581 105479.9n 0.43581 105480.0n 0.20119 105659.9n 0.20119 105660.0n 1.38855 105839.9n 1.38855 105840.0n 0.48508 106019.9n 0.48508 106020.0n 0.55006 106199.9n 0.55006 106200.0n 0.70685 106379.9n 0.70685 106380.0n 0.21498 106559.9n 0.21498 106560.0n 0.73600 106739.9n 0.73600 106740.0n 0.17082 106919.9n 0.17082 106920.0n -0.14927 107099.9n -0.14927 107100.0n 0.27643 107279.9n 0.27643 107280.0n 0.69502 107459.9n 0.69502 107460.0n 0.69969 107639.9n 0.69969 107640.0n 0.35630 107819.9n 0.35630 107820.0n 0.31139 107999.9n 0.31139 108000.0n 0.26419 108179.9n 0.26419 108180.0n 1.36668 108359.9n 1.36668 108360.0n -0.31038 108539.9n -0.31038 108540.0n 0.55066 108719.9n 0.55066 108720.0n 0.88832 108899.9n 0.88832 108900.0n 0.52079 109079.9n 0.52079 109080.0n 0.86030 109259.9n 0.86030 109260.0n 0.47556 109439.9n 0.47556 109440.0n -0.14927 109619.9n -0.14927 109620.0n 0.53141 109799.9n 0.53141 109800.0n 0.48508 109979.9n 0.48508 109980.0n 0.35630 110159.9n 0.35630 110160.0n 0.47556 110339.9n 0.47556 110340.0n 0.24079 110519.9n 0.24079 110520.0n 0.27643 110699.9n 0.27643 110700.0n 0.69969 110879.9n 0.69969 110880.0n 0.56449 111059.9n 0.56449 111060.0n 0.52079 111239.9n 0.52079 111240.0n 1.21890 111419.9n 1.21890 111420.0n 1.38855 111599.9n 1.38855 111600.0n 0.55006 111779.9n 0.55006 111780.0n -0.31038 111959.9n -0.31038 111960.0n 0.86030 112139.9n 0.86030 112140.0n 1.36668 112319.9n 1.36668 112320.0n -0.04662 112499.9n -0.04662 112500.0n 0.17082 112679.9n 0.17082 112680.0n 0.27076 112859.9n 0.27076 112860.0n 0.10559 113039.9n 0.10559 113040.0n 0.70685 113219.9n 0.70685 113220.0n 0.73600 113399.9n 0.73600 113400.0n 0.21498 113579.9n 0.21498 113580.0n 0.55066 113759.9n 0.55066 113760.0n 0.69502 113939.9n 0.69502 113940.0n 0.20119 114119.9n 0.20119 114120.0n 0.26419 114299.9n 0.26419 114300.0n 1.07007 114479.9n 1.07007 114480.0n 0.43581 114659.9n 0.43581 114660.0n 0.31139 114839.9n 0.31139 114840.0n 0.88832 115019.9n 0.88832 115020.0n 0.96459 115199.9n 0.96459 115200.0n -0.14927 115379.9n -0.14927 115380.0n 0.27076 115559.9n 0.27076 115560.0n 0.73600 115739.9n 0.73600 115740.0n 0.26419 115919.9n 0.26419 115920.0n -0.04662 116099.9n -0.04662 116100.0n 0.56449 116279.9n 0.56449 116280.0n 0.20119 116459.9n 0.20119 116460.0n 0.43581 116639.9n 0.43581 116640.0n 0.53141 116819.9n 0.53141 116820.0n 0.55066 116999.9n 0.55066 117000.0n 0.17082 117179.9n 0.17082 117180.0n -0.31038 117359.9n -0.31038 117360.0n 0.55006 117539.9n 0.55006 117540.0n 0.10559 117719.9n 0.10559 117720.0n 0.47556 117899.9n 0.47556 117900.0n 0.27643 118079.9n 0.27643 118080.0n 0.48508 118259.9n 0.48508 118260.0n 0.86030 118439.9n 0.86030 118440.0n 1.36668 118619.9n 1.36668 118620.0n 0.52079 118799.9n 0.52079 118800.0n 0.21498 118979.9n 0.21498 118980.0n 0.24079 119159.9n 0.24079 119160.0n 1.38855 119339.9n 1.38855 119340.0n 0.88832 119519.9n 0.88832 119520.0n 1.07007 119699.9n 1.07007 119700.0n 1.21890 119879.9n 1.21890 119880.0n 0.35630 120059.9n 0.35630 120060.0n 0.31139 120239.9n 0.31139 120240.0n 0.96459 120419.9n 0.96459 120420.0n 0.70685 120599.9n 0.70685 120600.0n 0.69969 120779.9n 0.69969 120780.0n 0.69502 120959.9n 0.69502 120960.0n 0.27076 121139.9n 0.27076 121140.0n 0.88832 121319.9n 0.88832 121320.0n 0.47556 121499.9n 0.47556 121500.0n -0.14927 121679.9n -0.14927 121680.0n 1.36668 121859.9n 1.36668 121860.0n 0.43581 122039.9n 0.43581 122040.0n 1.07007 122219.9n 1.07007 122220.0n 1.38855 122399.9n 1.38855 122400.0n 0.24079 122579.9n 0.24079 122580.0n 0.35630 122759.9n 0.35630 122760.0n 0.21498 122939.9n 0.21498 122940.0n 0.56449 123119.9n 0.56449 123120.0n 0.53141 123299.9n 0.53141 123300.0n 0.20119 123479.9n 0.20119 123480.0n 0.55006 123659.9n 0.55006 123660.0n 0.70685 123839.9n 0.70685 123840.0n 0.27643 124019.9n 0.27643 124020.0n 0.17082 124199.9n 0.17082 124200.0n 0.69502 124379.9n 0.69502 124380.0n 0.86030 124559.9n 0.86030 124560.0n 0.73600 124739.9n 0.73600 124740.0n 1.21890 124919.9n 1.21890 124920.0n -0.31038 125099.9n -0.31038 125100.0n 0.10559 125279.9n 0.10559 125280.0n 0.55066 125459.9n 0.55066 125460.0n 0.31139 125639.9n 0.31139 125640.0n -0.04662 125819.9n -0.04662 125820.0n 0.48508 125999.9n 0.48508 126000.0n 0.69969 126179.9n 0.69969 126180.0n 0.96459 126359.9n 0.96459 126360.0n 0.52079 126539.9n 0.52079 126540.0n 0.26419 126719.9n 0.26419 126720.0n 1.36668 126899.9n 1.36668 126900.0n 0.96459 127079.9n 0.96459 127080.0n 0.17082 127259.9n 0.17082 127260.0n 0.21498 127439.9n 0.21498 127440.0n 0.53141 127619.9n 0.53141 127620.0n 0.26419 127799.9n 0.26419 127800.0n 0.10559 127979.9n 0.10559 127980.0n 0.27643 128159.9n 0.27643 128160.0n 1.38855 128339.9n 1.38855 128340.0n 0.88832 128519.9n 0.88832 128520.0n 0.69502 128699.9n 0.69502 128700.0n 0.86030 128879.9n 0.86030 128880.0n -0.14927 129059.9n -0.14927 129060.0n 0.69969 129239.9n 0.69969 129240.0n 0.20119 129419.9n 0.20119 129420.0n 0.43581 129599.9n 0.43581 129600.0n 0.35630 129779.9n 0.35630 129780.0n 0.56449 129959.9n 0.56449 129960.0n 0.47556 130139.9n 0.47556 130140.0n 0.31139 130319.9n 0.31139 130320.0n 1.21890 130499.9n 1.21890 130500.0n 0.70685 130679.9n 0.70685 130680.0n 0.27076 130859.9n 0.27076 130860.0n 0.55006 131039.9n 0.55006 131040.0n 0.52079 131219.9n 0.52079 131220.0n 0.55066 131399.9n 0.55066 131400.0n 0.24079 131579.9n 0.24079 131580.0n 0.48508 131759.9n 0.48508 131760.0n 1.07007 131939.9n 1.07007 131940.0n 0.73600 132119.9n 0.73600 132120.0n -0.04662 132299.9n -0.04662 132300.0n -0.31038 132479.9n -0.31038 132480.0n 0.56449 132659.9n 0.56449 132660.0n 0.24079 132839.9n 0.24079 132840.0n 0.73600 133019.9n 0.73600 133020.0n 0.48508 133199.9n 0.48508 133200.0n 0.55066 133379.9n 0.55066 133380.0n 0.88832 133559.9n 0.88832 133560.0n 0.53141 133739.9n 0.53141 133740.0n 0.35630 133919.9n 0.35630 133920.0n 0.86030 134099.9n 0.86030 134100.0n 0.27076 134279.9n 0.27076 134280.0n -0.31038 134459.9n -0.31038 134460.0n 0.96459 134639.9n 0.96459 134640.0n 0.43581 134819.9n 0.43581 134820.0n 0.17082 134999.9n 0.17082 135000.0n 0.26419 135179.9n 0.26419 135180.0n 0.20119 135359.9n 0.20119 135360.0n -0.04662 135539.9n -0.04662 135540.0n 0.52079 135719.9n 0.52079 135720.0n 0.69502 135899.9n 0.69502 135900.0n -0.14927 136079.9n -0.14927 136080.0n 1.38855 136259.9n 1.38855 136260.0n 0.21498 136439.9n 0.21498 136440.0n 0.31139 136619.9n 0.31139 136620.0n 0.70685 136799.9n 0.70685 136800.0n 1.21890 136979.9n 1.21890 136980.0n 1.36668 137159.9n 1.36668 137160.0n 1.07007 137339.9n 1.07007 137340.0n 0.47556 137519.9n 0.47556 137520.0n 0.55006 137699.9n 0.55006 137700.0n 0.27643 137879.9n 0.27643 137880.0n 0.10559 138059.9n 0.10559 138060.0n 0.69969 138239.9n 0.69969 138240.0n 1.07007 138419.9n 1.07007 138420.0n 0.31139 138599.9n 0.31139 138600.0n 0.55006 138779.9n 0.55006 138780.0n 1.36668 138959.9n 1.36668 138960.0n 0.10559 139139.9n 0.10559 139140.0n 0.73600 139319.9n 0.73600 139320.0n 0.52079 139499.9n 0.52079 139500.0n 0.43581 139679.9n 0.43581 139680.0n 0.48508 139859.9n 0.48508 139860.0n 0.70685 140039.9n 0.70685 140040.0n 0.20119 140219.9n 0.20119 140220.0n 1.21890 140399.9n 1.21890 140400.0n 0.26419 140579.9n 0.26419 140580.0n 0.47556 140759.9n 0.47556 140760.0n 0.17082 140939.9n 0.17082 140940.0n 0.27643 141119.9n 0.27643 141120.0n 0.55066 141299.9n 0.55066 141300.0n 0.21498 141479.9n 0.21498 141480.0n 1.38855 141659.9n 1.38855 141660.0n 0.56449 141839.9n 0.56449 141840.0n 0.35630 142019.9n 0.35630 142020.0n 0.86030 142199.9n 0.86030 142200.0n 0.96459 142379.9n 0.96459 142380.0n 0.24079 142559.9n 0.24079 142560.0n -0.14927 142739.9n -0.14927 142740.0n -0.04662 142919.9n -0.04662 142920.0n -0.31038 143099.9n -0.31038 143100.0n 0.69969 143279.9n 0.69969 143280.0n 0.27076 143459.9n 0.27076 143460.0n 0.69502 143639.9n 0.69502 143640.0n 0.53141 143819.9n 0.53141 143820.0n 0.88832 143999.9n 0.88832 144000.0n -0.31038 144179.9n -0.31038 144180.0n 0.47556 144359.9n 0.47556 144360.0n 0.86030 144539.9n 0.86030 144540.0n 0.24079 144719.9n 0.24079 144720.0n 0.96459 144899.9n 0.96459 144900.0n 0.53141 145079.9n 0.53141 145080.0n 0.69502 145259.9n 0.69502 145260.0n 0.21498 145439.9n 0.21498 145440.0n 0.55006 145619.9n 0.55006 145620.0n 0.52079 145799.9n 0.52079 145800.0n 0.56449 145979.9n 0.56449 145980.0n 1.36668 146159.9n 1.36668 146160.0n 0.73600 146339.9n 0.73600 146340.0n 1.38855 146519.9n 1.38855 146520.0n 0.27643 146699.9n 0.27643 146700.0n 0.70685 146879.9n 0.70685 146880.0n 0.43581 147059.9n 0.43581 147060.0n 0.17082 147239.9n 0.17082 147240.0n 1.07007 147419.9n 1.07007 147420.0n 0.48508 147599.9n 0.48508 147600.0n 0.55066 147779.9n 0.55066 147780.0n 0.26419 147959.9n 0.26419 147960.0n 0.69969 148139.9n 0.69969 148140.0n 1.21890 148319.9n 1.21890 148320.0n -0.14927 148499.9n -0.14927 148500.0n 0.20119 148679.9n 0.20119 148680.0n 0.10559 148859.9n 0.10559 148860.0n 0.31139 149039.9n 0.31139 149040.0n 0.88832 149219.9n 0.88832 149220.0n 0.27076 149399.9n 0.27076 149400.0n -0.04662 149579.9n -0.04662 149580.0n 0.35630 149759.9n 0.35630 149760.0n 1.36668 149939.9n 1.36668 149940.0n 0.55006 150119.9n 0.55006 150120.0n 0.27076 150299.9n 0.27076 150300.0n 0.55066 150479.9n 0.55066 150480.0n 0.96459 150659.9n 0.96459 150660.0n 0.43581 150839.9n 0.43581 150840.0n 0.17082 151019.9n 0.17082 151020.0n 0.35630 151199.9n 0.35630 151200.0n 0.69502 151379.9n 0.69502 151380.0n 0.86030 151559.9n 0.86030 151560.0n 1.21890 151739.9n 1.21890 151740.0n 0.53141 151919.9n 0.53141 151920.0n 1.38855 152099.9n 1.38855 152100.0n 0.69969 152279.9n 0.69969 152280.0n 0.20119 152459.9n 0.20119 152460.0n 0.10559 152639.9n 0.10559 152640.0n 0.48508 152819.9n 0.48508 152820.0n 0.21498 152999.9n 0.21498 153000.0n 0.73600 153179.9n 0.73600 153180.0n 0.56449 153359.9n 0.56449 153360.0n 0.47556 153539.9n 0.47556 153540.0n 0.27643 153719.9n 0.27643 153720.0n 0.52079 153899.9n 0.52079 153900.0n 0.24079 154079.9n 0.24079 154080.0n 0.26419 154259.9n 0.26419 154260.0n -0.31038 154439.9n -0.31038 154440.0n -0.14927 154619.9n -0.14927 154620.0n -0.04662 154799.9n -0.04662 154800.0n 1.07007 154979.9n 1.07007 154980.0n 0.70685 155159.9n 0.70685 155160.0n 0.88832 155339.9n 0.88832 155340.0n 0.31139 155519.9n 0.31139 155520.0n 0.53141 155699.9n 0.53141 155700.0n -0.04662 155879.9n -0.04662 155880.0n 0.55066 156059.9n 0.55066 156060.0n 0.27643 156239.9n 0.27643 156240.0n 0.24079 156419.9n 0.24079 156420.0n 1.21890 156599.9n 1.21890 156600.0n 0.43581 156779.9n 0.43581 156780.0n 0.70685 156959.9n 0.70685 156960.0n 0.88832 157139.9n 0.88832 157140.0n 1.36668 157319.9n 1.36668 157320.0n 0.20119 157499.9n 0.20119 157500.0n 0.47556 157679.9n 0.47556 157680.0n 0.52079 157859.9n 0.52079 157860.0n 1.38855 158039.9n 1.38855 158040.0n 0.55006 158219.9n 0.55006 158220.0n 0.86030 158399.9n 0.86030 158400.0n -0.14927 158579.9n -0.14927 158580.0n 0.21498 158759.9n 0.21498 158760.0n 0.56449 158939.9n 0.56449 158940.0n 0.27076 159119.9n 0.27076 159120.0n 0.48508 159299.9n 0.48508 159300.0n 0.17082 159479.9n 0.17082 159480.0n 0.10559 159659.9n 0.10559 159660.0n 0.69502 159839.9n 0.69502 159840.0n 0.69969 160019.9n 0.69969 160020.0n 1.07007 160199.9n 1.07007 160200.0n 0.31139 160379.9n 0.31139 160380.0n 0.26419 160559.9n 0.26419 160560.0n 0.96459 160739.9n 0.96459 160740.0n 0.73600 160919.9n 0.73600 160920.0n -0.31038 161099.9n -0.31038 161100.0n 0.35630 161279.9n 0.35630 161280.0n 0.70685 161459.9n 0.70685 161460.0n 0.69502 161639.9n 0.69502 161640.0n 1.36668 161819.9n 1.36668 161820.0n 0.27643 161999.9n 0.27643 162000.0n 0.27076 162179.9n 0.27076 162180.0n 0.35630 162359.9n 0.35630 162360.0n 0.47556 162539.9n 0.47556 162540.0n 0.69969 162719.9n 0.69969 162720.0n 0.20119 162899.9n 0.20119 162900.0n 0.88832 163079.9n 0.88832 163080.0n 0.96459 163259.9n 0.96459 163260.0n 0.52079 163439.9n 0.52079 163440.0n 0.48508 163619.9n 0.48508 163620.0n 0.53141 163799.9n 0.53141 163800.0n 0.31139 163979.9n 0.31139 163980.0n 0.26419 164159.9n 0.26419 164160.0n -0.04662 164339.9n -0.04662 164340.0n 0.10559 164519.9n 0.10559 164520.0n -0.31038 164699.9n -0.31038 164700.0n 0.55006 164879.9n 0.55006 164880.0n 0.73600 165059.9n 0.73600 165060.0n 0.55066 165239.9n 0.55066 165240.0n 1.38855 165419.9n 1.38855 165420.0n 0.56449 165599.9n 0.56449 165600.0n 1.21890 165779.9n 1.21890 165780.0n 0.86030 165959.9n 0.86030 165960.0n 0.21498 166139.9n 0.21498 166140.0n 1.07007 166319.9n 1.07007 166320.0n -0.14927 166499.9n -0.14927 166500.0n 0.17082 166679.9n 0.17082 166680.0n 0.43581 166859.9n 0.43581 166860.0n 0.24079 167039.9n 0.24079 167040.0n 0.27643 167219.9n 0.27643 167220.0n 0.17082 167399.9n 0.17082 167400.0n 0.27076 167579.9n 0.27076 167580.0n 1.36668 167759.9n 1.36668 167760.0n 0.10559 167939.9n 0.10559 167940.0n 0.47556 168119.9n 0.47556 168120.0n 0.31139 168299.9n 0.31139 168300.0n 0.55006 168479.9n 0.55006 168480.0n 1.38855 168659.9n 1.38855 168660.0n 0.52079 168839.9n 0.52079 168840.0n 0.96459 169019.9n 0.96459 169020.0n 0.35630 169199.9n 0.35630 169200.0n 0.69502 169379.9n 0.69502 169380.0n 0.26419 169559.9n 0.26419 169560.0n 1.07007 169739.9n 1.07007 169740.0n 1.21890 169919.9n 1.21890 169920.0n 0.20119 170099.9n 0.20119 170100.0n 0.88832 170279.9n 0.88832 170280.0n 0.70685 170459.9n 0.70685 170460.0n -0.14927 170639.9n -0.14927 170640.0n -0.04662 170819.9n -0.04662 170820.0n 0.21498 170999.9n 0.21498 171000.0n 0.43581 171179.9n 0.43581 171180.0n 0.69969 171359.9n 0.69969 171360.0n 0.73600 171539.9n 0.73600 171540.0n 0.48508 171719.9n 0.48508 171720.0n 0.56449 171899.9n 0.56449 171900.0n 0.55066 172079.9n 0.55066 172080.0n 0.86030 172259.9n 0.86030 172260.0n 0.53141 172439.9n 0.53141 172440.0n -0.31038 172619.9n -0.31038 172620.0n 0.24079 172799.9n 0.24079 172800.0n 0.57742 172979.9n 0.57742 172980.0n 0.79287 173159.9n 0.79287 173160.0n 0.60090 173339.9n 0.60090 173340.0n 0.23371 173519.9n 0.23371 173520.0n 0.12484 173699.9n 0.12484 173700.0n 0.48351 173879.9n 0.48351 173880.0n 0.52272 174059.9n 0.52272 174060.0n 0.10421 174239.9n 0.10421 174240.0n 0.26187 174419.9n 0.26187 174420.0n 0.26993 174599.9n 0.26993 174600.0n 0.61195 174779.9n 0.61195 174780.0n 0.55435 174959.9n 0.55435 174960.0n 0.15028 175139.9n 0.15028 175140.0n 0.68626 175319.9n 0.68626 175320.0n 0.46500 175499.9n 0.46500 175500.0n 0.34619 175679.9n 0.34619 175680.0n 0.41172 175859.9n 0.41172 175860.0n 0.70707 176039.9n 0.70707 176040.0n 0.65136 176219.9n 0.65136 176220.0n 0.60081 176399.9n 0.60081 176400.0n 0.71496 176579.9n 0.71496 176580.0n 0.09082 176759.9n 0.09082 176760.0n 0.49669 176939.9n 0.49669 176940.0n 0.71193 177119.9n 0.71193 177120.0n 0.76576 177299.9n 0.76576 177300.0n 0.46112 177479.9n 0.46112 177480.0n 0.51272 177659.9n 0.51272 177660.0n 0.49148 177839.9n 0.49148 177840.0n 0.41550 178019.9n 0.41550 178020.0n 0.63432 178199.9n 0.63432 178200.0n 1.28851 178379.9n 1.28851 178380.0n 1.24585 178559.9n 1.24585 178560.0n -0.15208 178739.9n -0.15208 178740.0n 0.58159 178919.9n 0.58159 178920.0n 0.75662 179099.9n 0.75662 179100.0n -0.49277 179279.9n -0.49277 179280.0n -0.19260 179459.9n -0.19260 179460.0n 1.27962 179639.9n 1.27962 179640.0n 0.44267 179819.9n 0.44267 179820.0n 0.04400 179999.9n 0.04400 180000.0n 1.04710 180179.9n 1.04710 180180.0n 0.19758 180359.9n 0.19758 180360.0n 0.60264 180539.9n 0.60264 180540.0n -0.04029 180719.9n -0.04029 180720.0n 0.36851 180899.9n 0.36851 180900.0n 0.18248 181079.9n 0.18248 181080.0n -0.19808 181259.9n -0.19808 181260.0n -0.39872 181439.9n -0.39872 181440.0n 0.71881 181619.9n 0.71881 181620.0n -0.46004 181799.9n -0.46004 181800.0n 1.19303 181979.9n 1.19303 181980.0n 0.06458 182159.9n 0.06458 182160.0n -0.06311 182339.9n -0.06311 182340.0n -0.11193 182519.9n -0.11193 182520.0n -0.17413 182699.9n -0.17413 182700.0n -0.01300 182879.9n -0.01300 182880.0n -0.13586 183059.9n -0.13586 183060.0n -0.03731 183239.9n -0.03731 183240.0n 0.53061 183419.9n 0.53061 183420.0n 0.42812)
Vxn0 a_xn0 0 PWL(0.0n 1.31038 179.9n 1.31038 180.0n 0.52444 359.9n 0.52444 360.0n 0.43551 539.9n 0.43551 540.0n 1.04662 719.9n 1.04662 720.0n -0.36668 899.9n -0.36668 900.0n -0.38855 1079.9n -0.38855 1080.0n 0.64370 1259.9n 0.64370 1260.0n 0.44934 1439.9n 0.44934 1440.0n 0.26400 1619.9n 0.26400 1620.0n 0.73581 1799.9n 0.73581 1800.0n -0.07007 1979.9n -0.07007 1980.0n 0.68861 2159.9n 0.68861 2160.0n 0.82918 2339.9n 0.82918 2340.0n 0.47921 2519.9n 0.47921 2520.0n 0.03541 2699.9n 0.03541 2700.0n 0.13970 2879.9n 0.13970 2880.0n 0.30498 3059.9n 0.30498 3060.0n 0.72924 3239.9n 0.72924 3240.0n 0.72357 3419.9n 0.72357 3420.0n 0.30031 3599.9n 0.30031 3600.0n 0.78502 3779.9n 0.78502 3780.0n -0.21890 3959.9n -0.21890 3960.0n 0.89441 4139.9n 0.89441 4140.0n 0.75921 4319.9n 0.75921 4320.0n 0.56419 4499.9n 0.56419 4500.0n 0.11168 4679.9n 0.11168 4680.0n 0.51492 4859.9n 0.51492 4860.0n 0.29315 5039.9n 0.29315 5040.0n 0.44994 5219.9n 0.44994 5220.0n 0.79881 5399.9n 0.79881 5400.0n 0.46859 5579.9n 0.46859 5580.0n 1.14927 5759.9n 1.14927 5760.0n 0.89441 5939.9n 0.89441 5940.0n -0.38855 6119.9n -0.38855 6120.0n 0.03541 6299.9n 0.03541 6300.0n 0.75921 6479.9n 0.75921 6480.0n 0.47921 6659.9n 0.47921 6660.0n 0.72924 6839.9n 0.72924 6840.0n 0.30031 7019.9n 0.30031 7020.0n 0.64370 7199.9n 0.64370 7200.0n 0.13970 7379.9n 0.13970 7380.0n 0.44934 7559.9n 0.44934 7560.0n 0.11168 7739.9n 0.11168 7740.0n 0.46859 7919.9n 0.46859 7920.0n -0.36668 8099.9n -0.36668 8100.0n 0.68861 8279.9n 0.68861 8280.0n 0.72357 8459.9n 0.72357 8460.0n 0.56419 8639.9n 0.56419 8640.0n 0.52444 8819.9n 0.52444 8820.0n 0.51492 8999.9n 0.51492 9000.0n 0.78502 9179.9n 0.78502 9180.0n 0.79881 9359.9n 0.79881 9360.0n 0.29315 9539.9n 0.29315 9540.0n 0.44994 9719.9n 0.44994 9720.0n 1.14927 9899.9n 1.14927 9900.0n 0.73581 10079.9n 0.73581 10080.0n -0.07007 10259.9n -0.07007 10260.0n 0.43551 10439.9n 0.43551 10440.0n 0.30498 10619.9n 0.30498 10620.0n -0.21890 10799.9n -0.21890 10800.0n 0.82918 10979.9n 0.82918 10980.0n 0.26400 11159.9n 0.26400 11160.0n 1.04662 11339.9n 1.04662 11340.0n 1.31038 11519.9n 1.31038 11520.0n 1.14927 11699.9n 1.14927 11700.0n 0.13970 11879.9n 0.13970 11880.0n 0.26400 12059.9n 0.26400 12060.0n 0.56419 12239.9n 0.56419 12240.0n -0.07007 12419.9n -0.07007 12420.0n -0.21890 12599.9n -0.21890 12600.0n 0.44934 12779.9n 0.44934 12780.0n 1.31038 12959.9n 1.31038 12960.0n 0.72924 13139.9n 0.72924 13140.0n 0.43551 13319.9n 0.43551 13320.0n 0.30031 13499.9n 0.30031 13500.0n 0.78502 13679.9n 0.78502 13680.0n 0.47921 13859.9n 0.47921 13860.0n 0.79881 14039.9n 0.79881 14040.0n 0.64370 14219.9n 0.64370 14220.0n 0.11168 14399.9n 0.11168 14400.0n 0.75921 14579.9n 0.75921 14580.0n 0.29315 14759.9n 0.29315 14760.0n 1.04662 14939.9n 1.04662 14940.0n 0.46859 15119.9n 0.46859 15120.0n 0.03541 15299.9n 0.03541 15300.0n 0.30498 15479.9n 0.30498 15480.0n 0.68861 15659.9n 0.68861 15660.0n 0.52444 15839.9n 0.52444 15840.0n 0.72357 16019.9n 0.72357 16020.0n 0.82918 16199.9n 0.82918 16200.0n 0.89441 16379.9n 0.89441 16380.0n 0.44994 16559.9n 0.44994 16560.0n 0.51492 16739.9n 0.51492 16740.0n -0.36668 16919.9n -0.36668 16920.0n 0.73581 17099.9n 0.73581 17100.0n -0.38855 17279.9n -0.38855 17280.0n 0.46859 17459.9n 0.46859 17460.0n 0.44994 17639.9n 0.44994 17640.0n 0.79881 17819.9n 0.79881 17820.0n 0.72357 17999.9n 0.72357 18000.0n 0.43551 18179.9n 0.43551 18180.0n 1.31038 18359.9n 1.31038 18360.0n -0.21890 18539.9n -0.21890 18540.0n 0.44934 18719.9n 0.44934 18720.0n 0.29315 18899.9n 0.29315 18900.0n 0.30498 19079.9n 0.30498 19080.0n 0.78502 19259.9n 0.78502 19260.0n 0.68861 19439.9n 0.68861 19440.0n 0.64370 19619.9n 0.64370 19620.0n 0.72924 19799.9n 0.72924 19800.0n 0.11168 19979.9n 0.11168 19980.0n 0.56419 20159.9n 0.56419 20160.0n 1.04662 20339.9n 1.04662 20340.0n 0.75921 20519.9n 0.75921 20520.0n 0.47921 20699.9n 0.47921 20700.0n 0.52444 20879.9n 0.52444 20880.0n 0.89441 21059.9n 0.89441 21060.0n 0.51492 21239.9n 0.51492 21240.0n 0.13970 21419.9n 0.13970 21420.0n -0.07007 21599.9n -0.07007 21600.0n -0.36668 21779.9n -0.36668 21780.0n -0.38855 21959.9n -0.38855 21960.0n 1.14927 22139.9n 1.14927 22140.0n 0.30031 22319.9n 0.30031 22320.0n 0.82918 22499.9n 0.82918 22500.0n 0.73581 22679.9n 0.73581 22680.0n 0.26400 22859.9n 0.26400 22860.0n 0.03541 23039.9n 0.03541 23040.0n 0.56419 23219.9n 0.56419 23220.0n 0.13970 23399.9n 0.13970 23400.0n 0.82918 23579.9n 0.82918 23580.0n 0.72357 23759.9n 0.72357 23760.0n 0.51492 23939.9n 0.51492 23940.0n 0.79881 24119.9n 0.79881 24120.0n 0.64370 24299.9n 0.64370 24300.0n -0.21890 24479.9n -0.21890 24480.0n 0.29315 24659.9n 0.29315 24660.0n 0.43551 24839.9n 0.43551 24840.0n 0.78502 25019.9n 0.78502 25020.0n 0.44934 25199.9n 0.44934 25200.0n -0.07007 25379.9n -0.07007 25380.0n 0.72924 25559.9n 0.72924 25560.0n -0.36668 25739.9n -0.36668 25740.0n 0.26400 25919.9n 0.26400 25920.0n 0.75921 26099.9n 0.75921 26100.0n 0.30498 26279.9n 0.30498 26280.0n 0.11168 26459.9n 0.11168 26460.0n 1.04662 26639.9n 1.04662 26640.0n 0.30031 26819.9n 0.30031 26820.0n 0.68861 26999.9n 0.68861 27000.0n 0.44994 27179.9n 0.44994 27180.0n 0.47921 27359.9n 0.47921 27360.0n 0.46859 27539.9n 0.46859 27540.0n 1.31038 27719.9n 1.31038 27720.0n 0.52444 27899.9n 0.52444 27900.0n 1.14927 28079.9n 1.14927 28080.0n 0.89441 28259.9n 0.89441 28260.0n -0.38855 28439.9n -0.38855 28440.0n 0.03541 28619.9n 0.03541 28620.0n 0.73581 28799.9n 0.73581 28800.0n -0.21890 28979.9n -0.21890 28980.0n 0.68861 29159.9n 0.68861 29160.0n 0.30498 29339.9n 0.30498 29340.0n 0.13970 29519.9n 0.13970 29520.0n 0.73581 29699.9n 0.73581 29700.0n 0.47921 29879.9n 0.47921 29880.0n 0.52444 30059.9n 0.52444 30060.0n 0.72924 30239.9n 0.72924 30240.0n 1.04662 30419.9n 1.04662 30420.0n 0.43551 30599.9n 0.43551 30600.0n 0.51492 30779.9n 0.51492 30780.0n 0.44994 30959.9n 0.44994 30960.0n 0.72357 31139.9n 0.72357 31140.0n 0.03541 31319.9n 0.03541 31320.0n 0.44934 31499.9n 0.44934 31500.0n 1.14927 31679.9n 1.14927 31680.0n 0.26400 31859.9n 0.26400 31860.0n 0.11168 32039.9n 0.11168 32040.0n 1.31038 32219.9n 1.31038 32220.0n 0.56419 32399.9n 0.56419 32400.0n 0.29315 32579.9n 0.29315 32580.0n 0.78502 32759.9n 0.78502 32760.0n 0.79881 32939.9n 0.79881 32940.0n 0.64370 33119.9n 0.64370 33120.0n 0.82918 33299.9n 0.82918 33300.0n 0.89441 33479.9n 0.89441 33480.0n 0.30031 33659.9n 0.30031 33660.0n -0.07007 33839.9n -0.07007 33840.0n -0.36668 34019.9n -0.36668 34020.0n 0.75921 34199.9n 0.75921 34200.0n -0.38855 34379.9n -0.38855 34380.0n 0.46859 34559.9n 0.46859 34560.0n 0.30498 34739.9n 0.30498 34740.0n 0.29315 34919.9n 0.29315 34920.0n 0.89441 35099.9n 0.89441 35100.0n 1.31038 35279.9n 1.31038 35280.0n -0.07007 35459.9n -0.07007 35460.0n 0.30031 35639.9n 0.30031 35640.0n 0.47921 35819.9n 0.47921 35820.0n 0.44934 35999.9n 0.44934 36000.0n 0.68861 36179.9n 0.68861 36180.0n 0.26400 36359.9n 0.26400 36360.0n 0.82918 36539.9n 0.82918 36540.0n 0.75921 36719.9n 0.75921 36720.0n 0.43551 36899.9n 0.43551 36900.0n 0.79881 37079.9n 0.79881 37080.0n 1.14927 37259.9n 1.14927 37260.0n 0.13970 37439.9n 0.13970 37440.0n -0.38855 37619.9n -0.38855 37620.0n 0.72924 37799.9n 0.72924 37800.0n 0.73581 37979.9n 0.73581 37980.0n -0.21890 38159.9n -0.21890 38160.0n 0.44994 38339.9n 0.44994 38340.0n 0.56419 38519.9n 0.56419 38520.0n 0.52444 38699.9n 0.52444 38700.0n 0.78502 38879.9n 0.78502 38880.0n -0.36668 39059.9n -0.36668 39060.0n 0.64370 39239.9n 0.64370 39240.0n 0.72357 39419.9n 0.72357 39420.0n 0.51492 39599.9n 0.51492 39600.0n 0.11168 39779.9n 0.11168 39780.0n 0.46859 39959.9n 0.46859 39960.0n 1.04662 40139.9n 1.04662 40140.0n 0.03541 40319.9n 0.03541 40320.0n 0.79881 40499.9n 0.79881 40500.0n 0.44934 40679.9n 0.44934 40680.0n -0.07007 40859.9n -0.07007 40860.0n 0.89441 41039.9n 0.89441 41040.0n 0.73581 41219.9n 0.73581 41220.0n 0.29315 41399.9n 0.29315 41400.0n 0.78502 41579.9n 0.78502 41580.0n -0.21890 41759.9n -0.21890 41760.0n 0.11168 41939.9n 0.11168 41940.0n 0.52444 42119.9n 0.52444 42120.0n 0.64370 42299.9n 0.64370 42300.0n 0.30031 42479.9n 0.30031 42480.0n 0.68861 42659.9n 0.68861 42660.0n 0.43551 42839.9n 0.43551 42840.0n 0.13970 43019.9n 0.13970 43020.0n 0.30498 43199.9n 0.30498 43200.0n 1.04662 43379.9n 1.04662 43380.0n 0.51492 43559.9n 0.51492 43560.0n 0.56419 43739.9n 0.56419 43740.0n 1.14927 43919.9n 1.14927 43920.0n 0.47921 44099.9n 0.47921 44100.0n 1.31038 44279.9n 1.31038 44280.0n 0.72924 44459.9n 0.72924 44460.0n 0.46859 44639.9n 0.46859 44640.0n 0.82918 44819.9n 0.82918 44820.0n -0.36668 44999.9n -0.36668 45000.0n 0.26400 45179.9n 0.26400 45180.0n 0.44994 45359.9n 0.44994 45360.0n -0.38855 45539.9n -0.38855 45540.0n 0.75921 45719.9n 0.75921 45720.0n 0.72357 45899.9n 0.72357 45900.0n 0.03541 46079.9n 0.03541 46080.0n 0.47921 46259.9n 0.47921 46260.0n 0.13970 46439.9n 0.13970 46440.0n 0.29315 46619.9n 0.29315 46620.0n 0.11168 46799.9n 0.11168 46800.0n 0.26400 46979.9n 0.26400 46980.0n -0.38855 47159.9n -0.38855 47160.0n 0.52444 47339.9n 0.52444 47340.0n 0.78502 47519.9n 0.78502 47520.0n 0.51492 47699.9n 0.51492 47700.0n 0.75921 47879.9n 0.75921 47880.0n 0.43551 48059.9n 0.43551 48060.0n 1.14927 48239.9n 1.14927 48240.0n 0.72357 48419.9n 0.72357 48420.0n 0.03541 48599.9n 0.03541 48600.0n 0.46859 48779.9n 0.46859 48780.0n 0.82918 48959.9n 0.82918 48960.0n 1.04662 49139.9n 1.04662 49140.0n 0.73581 49319.9n 0.73581 49320.0n -0.07007 49499.9n -0.07007 49500.0n 1.31038 49679.9n 1.31038 49680.0n 0.64370 49859.9n 0.64370 49860.0n 0.44994 50039.9n 0.44994 50040.0n 0.68861 50219.9n 0.68861 50220.0n 0.56419 50399.9n 0.56419 50400.0n 0.79881 50579.9n 0.79881 50580.0n -0.36668 50759.9n -0.36668 50760.0n -0.21890 50939.9n -0.21890 50940.0n 0.30031 51119.9n 0.30031 51120.0n 0.89441 51299.9n 0.89441 51300.0n 0.44934 51479.9n 0.44934 51480.0n 0.72924 51659.9n 0.72924 51660.0n 0.30498 51839.9n 0.30498 51840.0n 0.46859 52019.9n 0.46859 52020.0n 0.11168 52199.9n 0.11168 52200.0n 0.51492 52379.9n 0.51492 52380.0n 0.78502 52559.9n 0.78502 52560.0n -0.21890 52739.9n -0.21890 52740.0n 0.56419 52919.9n 0.56419 52920.0n 0.64370 53099.9n 0.64370 53100.0n 0.72357 53279.9n 0.72357 53280.0n 0.03541 53459.9n 0.03541 53460.0n 0.72924 53639.9n 0.72924 53640.0n 1.14927 53819.9n 1.14927 53820.0n 1.31038 53999.9n 1.31038 54000.0n 0.73581 54179.9n 0.73581 54180.0n 0.29315 54359.9n 0.29315 54360.0n 0.52444 54539.9n 0.52444 54540.0n 0.44994 54719.9n 0.44994 54720.0n 0.47921 54899.9n 0.47921 54900.0n 0.30498 55079.9n 0.30498 55080.0n 0.82918 55259.9n 0.82918 55260.0n 0.13970 55439.9n 0.13970 55440.0n 0.79881 55619.9n 0.79881 55620.0n 0.68861 55799.9n 0.68861 55800.0n -0.07007 55979.9n -0.07007 55980.0n -0.36668 56159.9n -0.36668 56160.0n 0.89441 56339.9n 0.89441 56340.0n -0.38855 56519.9n -0.38855 56520.0n 0.26400 56699.9n 0.26400 56700.0n 0.44934 56879.9n 0.44934 56880.0n 0.43551 57059.9n 0.43551 57060.0n 0.30031 57239.9n 0.30031 57240.0n 1.04662 57419.9n 1.04662 57420.0n 0.75921 57599.9n 0.75921 57600.0n 0.43551 57779.9n 0.43551 57780.0n 0.29315 57959.9n 0.29315 57960.0n 0.72924 58139.9n 0.72924 58140.0n 0.44994 58319.9n 0.44994 58320.0n 0.47921 58499.9n 0.47921 58500.0n 0.73581 58679.9n 0.73581 58680.0n 0.78502 58859.9n 0.78502 58860.0n 0.52444 59039.9n 0.52444 59040.0n 0.75921 59219.9n 0.75921 59220.0n 0.30031 59399.9n 0.30031 59400.0n 0.46859 59579.9n 0.46859 59580.0n -0.21890 59759.9n -0.21890 59760.0n -0.38855 59939.9n -0.38855 59940.0n 0.30498 60119.9n 0.30498 60120.0n -0.07007 60299.9n -0.07007 60300.0n 0.03541 60479.9n 0.03541 60480.0n 0.13970 60659.9n 0.13970 60660.0n 0.51492 60839.9n 0.51492 60840.0n 0.64370 61019.9n 0.64370 61020.0n 0.26400 61199.9n 0.26400 61200.0n 0.89441 61379.9n 0.89441 61380.0n 0.11168 61559.9n 0.11168 61560.0n 0.72357 61739.9n 0.72357 61740.0n 0.79881 61919.9n 0.79881 61920.0n 0.44934 62099.9n 0.44934 62100.0n 1.14927 62279.9n 1.14927 62280.0n 0.82918 62459.9n 0.82918 62460.0n -0.36668 62639.9n -0.36668 62640.0n 0.68861 62819.9n 0.68861 62820.0n 1.31038 62999.9n 1.31038 63000.0n 1.04662 63179.9n 1.04662 63180.0n 0.56419 63359.9n 0.56419 63360.0n 0.72357 63539.9n 0.72357 63540.0n 0.64370 63719.9n 0.64370 63720.0n 0.44994 63899.9n 0.44994 63900.0n 0.13970 64079.9n 0.13970 64080.0n 0.79881 64259.9n 0.79881 64260.0n 1.14927 64439.9n 1.14927 64440.0n 0.89441 64619.9n 0.89441 64620.0n 0.72924 64799.9n 0.72924 64800.0n 1.04662 64979.9n 1.04662 64980.0n 0.11168 65159.9n 0.11168 65160.0n 0.82918 65339.9n 0.82918 65340.0n 0.30498 65519.9n 0.30498 65520.0n 0.43551 65699.9n 0.43551 65700.0n 0.26400 65879.9n 0.26400 65880.0n -0.38855 66059.9n -0.38855 66060.0n 0.52444 66239.9n 0.52444 66240.0n 1.31038 66419.9n 1.31038 66420.0n 0.68861 66599.9n 0.68861 66600.0n 0.75921 66779.9n 0.75921 66780.0n -0.07007 66959.9n -0.07007 66960.0n 0.03541 67139.9n 0.03541 67140.0n 0.78502 67319.9n 0.78502 67320.0n 0.29315 67499.9n 0.29315 67500.0n -0.36668 67679.9n -0.36668 67680.0n 0.73581 67859.9n 0.73581 67860.0n 0.44934 68039.9n 0.44934 68040.0n 0.51492 68219.9n 0.51492 68220.0n 0.46859 68399.9n 0.46859 68400.0n 0.30031 68579.9n 0.30031 68580.0n 0.47921 68759.9n 0.47921 68760.0n 0.56419 68939.9n 0.56419 68940.0n -0.21890 69119.9n -0.21890 69120.0n 0.52444 69299.9n 0.52444 69300.0n 0.68861 69479.9n 0.68861 69480.0n 0.56419 69659.9n 0.56419 69660.0n 0.82918 69839.9n 0.82918 69840.0n 0.44934 70019.9n 0.44934 70020.0n 0.78502 70199.9n 0.78502 70200.0n 0.64370 70379.9n 0.64370 70380.0n 0.43551 70559.9n 0.43551 70560.0n 1.31038 70739.9n 1.31038 70740.0n 0.30031 70919.9n 0.30031 70920.0n 0.29315 71099.9n 0.29315 71100.0n 0.13970 71279.9n 0.13970 71280.0n 0.79881 71459.9n 0.79881 71460.0n -0.21890 71639.9n -0.21890 71640.0n 0.72924 71819.9n 0.72924 71820.0n 0.75921 71999.9n 0.75921 72000.0n 0.03541 72179.9n 0.03541 72180.0n 0.89441 72359.9n 0.89441 72360.0n -0.38855 72539.9n -0.38855 72540.0n 0.26400 72719.9n 0.26400 72720.0n 0.73581 72899.9n 0.73581 72900.0n 1.04662 73079.9n 1.04662 73080.0n 1.14927 73259.9n 1.14927 73260.0n 0.44994 73439.9n 0.44994 73440.0n -0.36668 73619.9n -0.36668 73620.0n 0.72357 73799.9n 0.72357 73800.0n 0.47921 73979.9n 0.47921 73980.0n 0.51492 74159.9n 0.51492 74160.0n 0.46859 74339.9n 0.46859 74340.0n -0.07007 74519.9n -0.07007 74520.0n 0.11168 74699.9n 0.11168 74700.0n 0.30498 74879.9n 0.30498 74880.0n -0.36668 75059.9n -0.36668 75060.0n 0.11168 75239.9n 0.11168 75240.0n 0.72357 75419.9n 0.72357 75420.0n 0.44934 75599.9n 0.44934 75600.0n 0.44994 75779.9n 0.44994 75780.0n 0.79881 75959.9n 0.79881 75960.0n 0.52444 76139.9n 0.52444 76140.0n -0.38855 76319.9n -0.38855 76320.0n 0.47921 76499.9n 0.47921 76500.0n 0.64370 76679.9n 0.64370 76680.0n 0.43551 76859.9n 0.43551 76860.0n 0.26400 77039.9n 0.26400 77040.0n 0.13970 77219.9n 0.13970 77220.0n -0.21890 77399.9n -0.21890 77400.0n 0.72924 77579.9n 0.72924 77580.0n 1.04662 77759.9n 1.04662 77760.0n 0.75921 77939.9n 0.75921 77940.0n 0.56419 78119.9n 0.56419 78120.0n 0.03541 78299.9n 0.03541 78300.0n 0.30031 78479.9n 0.30031 78480.0n 0.51492 78659.9n 0.51492 78660.0n 1.31038 78839.9n 1.31038 78840.0n -0.07007 79019.9n -0.07007 79020.0n 0.29315 79199.9n 0.29315 79200.0n 0.68861 79379.9n 0.68861 79380.0n 0.78502 79559.9n 0.78502 79560.0n 0.82918 79739.9n 0.82918 79740.0n 0.73581 79919.9n 0.73581 79920.0n 0.89441 80099.9n 0.89441 80100.0n 0.46859 80279.9n 0.46859 80280.0n 0.30498 80459.9n 0.30498 80460.0n 1.14927 80639.9n 1.14927 80640.0n 0.72924 80819.9n 0.72924 80820.0n -0.38855 80999.9n -0.38855 81000.0n 0.30031 81179.9n 0.30031 81180.0n 0.68861 81359.9n 0.68861 81360.0n 1.04662 81539.9n 1.04662 81540.0n -0.36668 81719.9n -0.36668 81720.0n 0.46859 81899.9n 0.46859 81900.0n 0.73581 82079.9n 0.73581 82080.0n 0.82918 82259.9n 0.82918 82260.0n 1.14927 82439.9n 1.14927 82440.0n 0.51492 82619.9n 0.51492 82620.0n 0.29315 82799.9n 0.29315 82800.0n 0.44994 82979.9n 0.44994 82980.0n 0.30498 83159.9n 0.30498 83160.0n 0.72357 83339.9n 0.72357 83340.0n 0.64370 83519.9n 0.64370 83520.0n 0.13970 83699.9n 0.13970 83700.0n 0.89441 83879.9n 0.89441 83880.0n 0.11168 84059.9n 0.11168 84060.0n 0.75921 84239.9n 0.75921 84240.0n 0.78502 84419.9n 0.78502 84420.0n 0.79881 84599.9n 0.79881 84600.0n 0.56419 84779.9n 0.56419 84780.0n 0.52444 84959.9n 0.52444 84960.0n 0.26400 85139.9n 0.26400 85140.0n 0.44934 85319.9n 0.44934 85320.0n -0.21890 85499.9n -0.21890 85500.0n 1.31038 85679.9n 1.31038 85680.0n -0.07007 85859.9n -0.07007 85860.0n 0.47921 86039.9n 0.47921 86040.0n 0.03541 86219.9n 0.03541 86220.0n 0.43551 86399.9n 0.43551 86400.0n 0.03541 86579.9n 0.03541 86580.0n 0.51492 86759.9n 0.51492 86760.0n 0.79881 86939.9n 0.79881 86940.0n 0.29315 87119.9n 0.29315 87120.0n -0.07007 87299.9n -0.07007 87300.0n 0.89441 87479.9n 0.89441 87480.0n 0.72924 87659.9n 0.72924 87660.0n 0.30498 87839.9n 0.30498 87840.0n 0.82918 88019.9n 0.82918 88020.0n 0.11168 88199.9n 0.11168 88200.0n 1.14927 88379.9n 1.14927 88380.0n 0.26400 88559.9n 0.26400 88560.0n 0.73581 88739.9n 0.73581 88740.0n 0.44934 88919.9n 0.44934 88920.0n 0.75921 89099.9n 0.75921 89100.0n 0.47921 89279.9n 0.47921 89280.0n 0.64370 89459.9n 0.64370 89460.0n 0.78502 89639.9n 0.78502 89640.0n 0.44994 89819.9n 0.44994 89820.0n 0.46859 89999.9n 0.46859 90000.0n 0.72357 90179.9n 0.72357 90180.0n 0.30031 90359.9n 0.30031 90360.0n 0.56419 90539.9n 0.56419 90540.0n 0.13970 90719.9n 0.13970 90720.0n 0.68861 90899.9n 0.68861 90900.0n -0.21890 91079.9n -0.21890 91080.0n -0.36668 91259.9n -0.36668 91260.0n -0.38855 91439.9n -0.38855 91440.0n 0.43551 91619.9n 0.43551 91620.0n 0.52444 91799.9n 0.52444 91800.0n 1.31038 91979.9n 1.31038 91980.0n 1.04662 92159.9n 1.04662 92160.0n -0.38855 92339.9n -0.38855 92340.0n 0.03541 92519.9n 0.03541 92520.0n 0.89441 92699.9n 0.89441 92700.0n 0.52444 92879.9n 0.52444 92880.0n 0.72357 93059.9n 0.72357 93060.0n 0.46859 93239.9n 0.46859 93240.0n -0.07007 93419.9n -0.07007 93420.0n 1.14927 93599.9n 1.14927 93600.0n 0.73581 93779.9n 0.73581 93780.0n 0.68861 93959.9n 0.68861 93960.0n 0.26400 94139.9n 0.26400 94140.0n -0.21890 94319.9n -0.21890 94320.0n 0.51492 94499.9n 0.51492 94500.0n 0.43551 94679.9n 0.43551 94680.0n -0.36668 94859.9n -0.36668 94860.0n 0.30031 95039.9n 0.30031 95040.0n 0.79881 95219.9n 0.79881 95220.0n 0.56419 95399.9n 0.56419 95400.0n 0.29315 95579.9n 0.29315 95580.0n 1.04662 95759.9n 1.04662 95760.0n 0.72924 95939.9n 0.72924 95940.0n 0.47921 96119.9n 0.47921 96120.0n 0.44994 96299.9n 0.44994 96300.0n 0.44934 96479.9n 0.44934 96480.0n 0.11168 96659.9n 0.11168 96660.0n 0.13970 96839.9n 0.13970 96840.0n 0.30498 97019.9n 0.30498 97020.0n 0.75921 97199.9n 0.75921 97200.0n 1.31038 97379.9n 1.31038 97380.0n 0.64370 97559.9n 0.64370 97560.0n 0.82918 97739.9n 0.82918 97740.0n 0.78502 97919.9n 0.78502 97920.0n 0.72924 98099.9n 0.72924 98100.0n 0.52444 98279.9n 0.52444 98280.0n 0.46859 98459.9n 0.46859 98460.0n 1.31038 98639.9n 1.31038 98640.0n 0.29315 98819.9n 0.29315 98820.0n 0.44994 98999.9n 0.44994 99000.0n 0.43551 99179.9n 0.43551 99180.0n 0.79881 99359.9n 0.79881 99360.0n -0.21890 99539.9n -0.21890 99540.0n 1.04662 99719.9n 1.04662 99720.0n 0.75921 99899.9n 0.75921 99900.0n 0.89441 100079.9n 0.89441 100080.0n 0.78502 100259.9n 0.78502 100260.0n 0.03541 100439.9n 0.03541 100440.0n 0.26400 100619.9n 0.26400 100620.0n -0.38855 100799.9n -0.38855 100800.0n 0.11168 100979.9n 0.11168 100980.0n 0.56419 101159.9n 0.56419 101160.0n 0.30498 101339.9n 0.30498 101340.0n 0.30031 101519.9n 0.30031 101520.0n 0.82918 101699.9n 0.82918 101700.0n 0.51492 101879.9n 0.51492 101880.0n 0.68861 102059.9n 0.68861 102060.0n 0.72357 102239.9n 0.72357 102240.0n 0.73581 102419.9n 0.73581 102420.0n -0.07007 102599.9n -0.07007 102600.0n 0.47921 102779.9n 0.47921 102780.0n -0.36668 102959.9n -0.36668 102960.0n 0.44934 103139.9n 0.44934 103140.0n 0.64370 103319.9n 0.64370 103320.0n 0.13970 103499.9n 0.13970 103500.0n 1.14927 103679.9n 1.14927 103680.0n -0.21890 103859.9n -0.21890 103860.0n 0.89441 104039.9n 0.89441 104040.0n 0.43551 104219.9n 0.43551 104220.0n 1.04662 104399.9n 1.04662 104400.0n -0.07007 104579.9n -0.07007 104580.0n 0.03541 104759.9n 0.03541 104760.0n 0.75921 104939.9n 0.75921 104940.0n 0.72924 105119.9n 0.72924 105120.0n 0.46859 105299.9n 0.46859 105300.0n 0.56419 105479.9n 0.56419 105480.0n 0.79881 105659.9n 0.79881 105660.0n -0.38855 105839.9n -0.38855 105840.0n 0.51492 106019.9n 0.51492 106020.0n 0.44994 106199.9n 0.44994 106200.0n 0.29315 106379.9n 0.29315 106380.0n 0.78502 106559.9n 0.78502 106560.0n 0.26400 106739.9n 0.26400 106740.0n 0.82918 106919.9n 0.82918 106920.0n 1.14927 107099.9n 1.14927 107100.0n 0.72357 107279.9n 0.72357 107280.0n 0.30498 107459.9n 0.30498 107460.0n 0.30031 107639.9n 0.30031 107640.0n 0.64370 107819.9n 0.64370 107820.0n 0.68861 107999.9n 0.68861 108000.0n 0.73581 108179.9n 0.73581 108180.0n -0.36668 108359.9n -0.36668 108360.0n 1.31038 108539.9n 1.31038 108540.0n 0.44934 108719.9n 0.44934 108720.0n 0.11168 108899.9n 0.11168 108900.0n 0.47921 109079.9n 0.47921 109080.0n 0.13970 109259.9n 0.13970 109260.0n 0.52444 109439.9n 0.52444 109440.0n 1.14927 109619.9n 1.14927 109620.0n 0.46859 109799.9n 0.46859 109800.0n 0.51492 109979.9n 0.51492 109980.0n 0.64370 110159.9n 0.64370 110160.0n 0.52444 110339.9n 0.52444 110340.0n 0.75921 110519.9n 0.75921 110520.0n 0.72357 110699.9n 0.72357 110700.0n 0.30031 110879.9n 0.30031 110880.0n 0.43551 111059.9n 0.43551 111060.0n 0.47921 111239.9n 0.47921 111240.0n -0.21890 111419.9n -0.21890 111420.0n -0.38855 111599.9n -0.38855 111600.0n 0.44994 111779.9n 0.44994 111780.0n 1.31038 111959.9n 1.31038 111960.0n 0.13970 112139.9n 0.13970 112140.0n -0.36668 112319.9n -0.36668 112320.0n 1.04662 112499.9n 1.04662 112500.0n 0.82918 112679.9n 0.82918 112680.0n 0.72924 112859.9n 0.72924 112860.0n 0.89441 113039.9n 0.89441 113040.0n 0.29315 113219.9n 0.29315 113220.0n 0.26400 113399.9n 0.26400 113400.0n 0.78502 113579.9n 0.78502 113580.0n 0.44934 113759.9n 0.44934 113760.0n 0.30498 113939.9n 0.30498 113940.0n 0.79881 114119.9n 0.79881 114120.0n 0.73581 114299.9n 0.73581 114300.0n -0.07007 114479.9n -0.07007 114480.0n 0.56419 114659.9n 0.56419 114660.0n 0.68861 114839.9n 0.68861 114840.0n 0.11168 115019.9n 0.11168 115020.0n 0.03541 115199.9n 0.03541 115200.0n 1.14927 115379.9n 1.14927 115380.0n 0.72924 115559.9n 0.72924 115560.0n 0.26400 115739.9n 0.26400 115740.0n 0.73581 115919.9n 0.73581 115920.0n 1.04662 116099.9n 1.04662 116100.0n 0.43551 116279.9n 0.43551 116280.0n 0.79881 116459.9n 0.79881 116460.0n 0.56419 116639.9n 0.56419 116640.0n 0.46859 116819.9n 0.46859 116820.0n 0.44934 116999.9n 0.44934 117000.0n 0.82918 117179.9n 0.82918 117180.0n 1.31038 117359.9n 1.31038 117360.0n 0.44994 117539.9n 0.44994 117540.0n 0.89441 117719.9n 0.89441 117720.0n 0.52444 117899.9n 0.52444 117900.0n 0.72357 118079.9n 0.72357 118080.0n 0.51492 118259.9n 0.51492 118260.0n 0.13970 118439.9n 0.13970 118440.0n -0.36668 118619.9n -0.36668 118620.0n 0.47921 118799.9n 0.47921 118800.0n 0.78502 118979.9n 0.78502 118980.0n 0.75921 119159.9n 0.75921 119160.0n -0.38855 119339.9n -0.38855 119340.0n 0.11168 119519.9n 0.11168 119520.0n -0.07007 119699.9n -0.07007 119700.0n -0.21890 119879.9n -0.21890 119880.0n 0.64370 120059.9n 0.64370 120060.0n 0.68861 120239.9n 0.68861 120240.0n 0.03541 120419.9n 0.03541 120420.0n 0.29315 120599.9n 0.29315 120600.0n 0.30031 120779.9n 0.30031 120780.0n 0.30498 120959.9n 0.30498 120960.0n 0.72924 121139.9n 0.72924 121140.0n 0.11168 121319.9n 0.11168 121320.0n 0.52444 121499.9n 0.52444 121500.0n 1.14927 121679.9n 1.14927 121680.0n -0.36668 121859.9n -0.36668 121860.0n 0.56419 122039.9n 0.56419 122040.0n -0.07007 122219.9n -0.07007 122220.0n -0.38855 122399.9n -0.38855 122400.0n 0.75921 122579.9n 0.75921 122580.0n 0.64370 122759.9n 0.64370 122760.0n 0.78502 122939.9n 0.78502 122940.0n 0.43551 123119.9n 0.43551 123120.0n 0.46859 123299.9n 0.46859 123300.0n 0.79881 123479.9n 0.79881 123480.0n 0.44994 123659.9n 0.44994 123660.0n 0.29315 123839.9n 0.29315 123840.0n 0.72357 124019.9n 0.72357 124020.0n 0.82918 124199.9n 0.82918 124200.0n 0.30498 124379.9n 0.30498 124380.0n 0.13970 124559.9n 0.13970 124560.0n 0.26400 124739.9n 0.26400 124740.0n -0.21890 124919.9n -0.21890 124920.0n 1.31038 125099.9n 1.31038 125100.0n 0.89441 125279.9n 0.89441 125280.0n 0.44934 125459.9n 0.44934 125460.0n 0.68861 125639.9n 0.68861 125640.0n 1.04662 125819.9n 1.04662 125820.0n 0.51492 125999.9n 0.51492 126000.0n 0.30031 126179.9n 0.30031 126180.0n 0.03541 126359.9n 0.03541 126360.0n 0.47921 126539.9n 0.47921 126540.0n 0.73581 126719.9n 0.73581 126720.0n -0.36668 126899.9n -0.36668 126900.0n 0.03541 127079.9n 0.03541 127080.0n 0.82918 127259.9n 0.82918 127260.0n 0.78502 127439.9n 0.78502 127440.0n 0.46859 127619.9n 0.46859 127620.0n 0.73581 127799.9n 0.73581 127800.0n 0.89441 127979.9n 0.89441 127980.0n 0.72357 128159.9n 0.72357 128160.0n -0.38855 128339.9n -0.38855 128340.0n 0.11168 128519.9n 0.11168 128520.0n 0.30498 128699.9n 0.30498 128700.0n 0.13970 128879.9n 0.13970 128880.0n 1.14927 129059.9n 1.14927 129060.0n 0.30031 129239.9n 0.30031 129240.0n 0.79881 129419.9n 0.79881 129420.0n 0.56419 129599.9n 0.56419 129600.0n 0.64370 129779.9n 0.64370 129780.0n 0.43551 129959.9n 0.43551 129960.0n 0.52444 130139.9n 0.52444 130140.0n 0.68861 130319.9n 0.68861 130320.0n -0.21890 130499.9n -0.21890 130500.0n 0.29315 130679.9n 0.29315 130680.0n 0.72924 130859.9n 0.72924 130860.0n 0.44994 131039.9n 0.44994 131040.0n 0.47921 131219.9n 0.47921 131220.0n 0.44934 131399.9n 0.44934 131400.0n 0.75921 131579.9n 0.75921 131580.0n 0.51492 131759.9n 0.51492 131760.0n -0.07007 131939.9n -0.07007 131940.0n 0.26400 132119.9n 0.26400 132120.0n 1.04662 132299.9n 1.04662 132300.0n 1.31038 132479.9n 1.31038 132480.0n 0.43551 132659.9n 0.43551 132660.0n 0.75921 132839.9n 0.75921 132840.0n 0.26400 133019.9n 0.26400 133020.0n 0.51492 133199.9n 0.51492 133200.0n 0.44934 133379.9n 0.44934 133380.0n 0.11168 133559.9n 0.11168 133560.0n 0.46859 133739.9n 0.46859 133740.0n 0.64370 133919.9n 0.64370 133920.0n 0.13970 134099.9n 0.13970 134100.0n 0.72924 134279.9n 0.72924 134280.0n 1.31038 134459.9n 1.31038 134460.0n 0.03541 134639.9n 0.03541 134640.0n 0.56419 134819.9n 0.56419 134820.0n 0.82918 134999.9n 0.82918 135000.0n 0.73581 135179.9n 0.73581 135180.0n 0.79881 135359.9n 0.79881 135360.0n 1.04662 135539.9n 1.04662 135540.0n 0.47921 135719.9n 0.47921 135720.0n 0.30498 135899.9n 0.30498 135900.0n 1.14927 136079.9n 1.14927 136080.0n -0.38855 136259.9n -0.38855 136260.0n 0.78502 136439.9n 0.78502 136440.0n 0.68861 136619.9n 0.68861 136620.0n 0.29315 136799.9n 0.29315 136800.0n -0.21890 136979.9n -0.21890 136980.0n -0.36668 137159.9n -0.36668 137160.0n -0.07007 137339.9n -0.07007 137340.0n 0.52444 137519.9n 0.52444 137520.0n 0.44994 137699.9n 0.44994 137700.0n 0.72357 137879.9n 0.72357 137880.0n 0.89441 138059.9n 0.89441 138060.0n 0.30031 138239.9n 0.30031 138240.0n -0.07007 138419.9n -0.07007 138420.0n 0.68861 138599.9n 0.68861 138600.0n 0.44994 138779.9n 0.44994 138780.0n -0.36668 138959.9n -0.36668 138960.0n 0.89441 139139.9n 0.89441 139140.0n 0.26400 139319.9n 0.26400 139320.0n 0.47921 139499.9n 0.47921 139500.0n 0.56419 139679.9n 0.56419 139680.0n 0.51492 139859.9n 0.51492 139860.0n 0.29315 140039.9n 0.29315 140040.0n 0.79881 140219.9n 0.79881 140220.0n -0.21890 140399.9n -0.21890 140400.0n 0.73581 140579.9n 0.73581 140580.0n 0.52444 140759.9n 0.52444 140760.0n 0.82918 140939.9n 0.82918 140940.0n 0.72357 141119.9n 0.72357 141120.0n 0.44934 141299.9n 0.44934 141300.0n 0.78502 141479.9n 0.78502 141480.0n -0.38855 141659.9n -0.38855 141660.0n 0.43551 141839.9n 0.43551 141840.0n 0.64370 142019.9n 0.64370 142020.0n 0.13970 142199.9n 0.13970 142200.0n 0.03541 142379.9n 0.03541 142380.0n 0.75921 142559.9n 0.75921 142560.0n 1.14927 142739.9n 1.14927 142740.0n 1.04662 142919.9n 1.04662 142920.0n 1.31038 143099.9n 1.31038 143100.0n 0.30031 143279.9n 0.30031 143280.0n 0.72924 143459.9n 0.72924 143460.0n 0.30498 143639.9n 0.30498 143640.0n 0.46859 143819.9n 0.46859 143820.0n 0.11168 143999.9n 0.11168 144000.0n 1.31038 144179.9n 1.31038 144180.0n 0.52444 144359.9n 0.52444 144360.0n 0.13970 144539.9n 0.13970 144540.0n 0.75921 144719.9n 0.75921 144720.0n 0.03541 144899.9n 0.03541 144900.0n 0.46859 145079.9n 0.46859 145080.0n 0.30498 145259.9n 0.30498 145260.0n 0.78502 145439.9n 0.78502 145440.0n 0.44994 145619.9n 0.44994 145620.0n 0.47921 145799.9n 0.47921 145800.0n 0.43551 145979.9n 0.43551 145980.0n -0.36668 146159.9n -0.36668 146160.0n 0.26400 146339.9n 0.26400 146340.0n -0.38855 146519.9n -0.38855 146520.0n 0.72357 146699.9n 0.72357 146700.0n 0.29315 146879.9n 0.29315 146880.0n 0.56419 147059.9n 0.56419 147060.0n 0.82918 147239.9n 0.82918 147240.0n -0.07007 147419.9n -0.07007 147420.0n 0.51492 147599.9n 0.51492 147600.0n 0.44934 147779.9n 0.44934 147780.0n 0.73581 147959.9n 0.73581 147960.0n 0.30031 148139.9n 0.30031 148140.0n -0.21890 148319.9n -0.21890 148320.0n 1.14927 148499.9n 1.14927 148500.0n 0.79881 148679.9n 0.79881 148680.0n 0.89441 148859.9n 0.89441 148860.0n 0.68861 149039.9n 0.68861 149040.0n 0.11168 149219.9n 0.11168 149220.0n 0.72924 149399.9n 0.72924 149400.0n 1.04662 149579.9n 1.04662 149580.0n 0.64370 149759.9n 0.64370 149760.0n -0.36668 149939.9n -0.36668 149940.0n 0.44994 150119.9n 0.44994 150120.0n 0.72924 150299.9n 0.72924 150300.0n 0.44934 150479.9n 0.44934 150480.0n 0.03541 150659.9n 0.03541 150660.0n 0.56419 150839.9n 0.56419 150840.0n 0.82918 151019.9n 0.82918 151020.0n 0.64370 151199.9n 0.64370 151200.0n 0.30498 151379.9n 0.30498 151380.0n 0.13970 151559.9n 0.13970 151560.0n -0.21890 151739.9n -0.21890 151740.0n 0.46859 151919.9n 0.46859 151920.0n -0.38855 152099.9n -0.38855 152100.0n 0.30031 152279.9n 0.30031 152280.0n 0.79881 152459.9n 0.79881 152460.0n 0.89441 152639.9n 0.89441 152640.0n 0.51492 152819.9n 0.51492 152820.0n 0.78502 152999.9n 0.78502 153000.0n 0.26400 153179.9n 0.26400 153180.0n 0.43551 153359.9n 0.43551 153360.0n 0.52444 153539.9n 0.52444 153540.0n 0.72357 153719.9n 0.72357 153720.0n 0.47921 153899.9n 0.47921 153900.0n 0.75921 154079.9n 0.75921 154080.0n 0.73581 154259.9n 0.73581 154260.0n 1.31038 154439.9n 1.31038 154440.0n 1.14927 154619.9n 1.14927 154620.0n 1.04662 154799.9n 1.04662 154800.0n -0.07007 154979.9n -0.07007 154980.0n 0.29315 155159.9n 0.29315 155160.0n 0.11168 155339.9n 0.11168 155340.0n 0.68861 155519.9n 0.68861 155520.0n 0.46859 155699.9n 0.46859 155700.0n 1.04662 155879.9n 1.04662 155880.0n 0.44934 156059.9n 0.44934 156060.0n 0.72357 156239.9n 0.72357 156240.0n 0.75921 156419.9n 0.75921 156420.0n -0.21890 156599.9n -0.21890 156600.0n 0.56419 156779.9n 0.56419 156780.0n 0.29315 156959.9n 0.29315 156960.0n 0.11168 157139.9n 0.11168 157140.0n -0.36668 157319.9n -0.36668 157320.0n 0.79881 157499.9n 0.79881 157500.0n 0.52444 157679.9n 0.52444 157680.0n 0.47921 157859.9n 0.47921 157860.0n -0.38855 158039.9n -0.38855 158040.0n 0.44994 158219.9n 0.44994 158220.0n 0.13970 158399.9n 0.13970 158400.0n 1.14927 158579.9n 1.14927 158580.0n 0.78502 158759.9n 0.78502 158760.0n 0.43551 158939.9n 0.43551 158940.0n 0.72924 159119.9n 0.72924 159120.0n 0.51492 159299.9n 0.51492 159300.0n 0.82918 159479.9n 0.82918 159480.0n 0.89441 159659.9n 0.89441 159660.0n 0.30498 159839.9n 0.30498 159840.0n 0.30031 160019.9n 0.30031 160020.0n -0.07007 160199.9n -0.07007 160200.0n 0.68861 160379.9n 0.68861 160380.0n 0.73581 160559.9n 0.73581 160560.0n 0.03541 160739.9n 0.03541 160740.0n 0.26400 160919.9n 0.26400 160920.0n 1.31038 161099.9n 1.31038 161100.0n 0.64370 161279.9n 0.64370 161280.0n 0.29315 161459.9n 0.29315 161460.0n 0.30498 161639.9n 0.30498 161640.0n -0.36668 161819.9n -0.36668 161820.0n 0.72357 161999.9n 0.72357 162000.0n 0.72924 162179.9n 0.72924 162180.0n 0.64370 162359.9n 0.64370 162360.0n 0.52444 162539.9n 0.52444 162540.0n 0.30031 162719.9n 0.30031 162720.0n 0.79881 162899.9n 0.79881 162900.0n 0.11168 163079.9n 0.11168 163080.0n 0.03541 163259.9n 0.03541 163260.0n 0.47921 163439.9n 0.47921 163440.0n 0.51492 163619.9n 0.51492 163620.0n 0.46859 163799.9n 0.46859 163800.0n 0.68861 163979.9n 0.68861 163980.0n 0.73581 164159.9n 0.73581 164160.0n 1.04662 164339.9n 1.04662 164340.0n 0.89441 164519.9n 0.89441 164520.0n 1.31038 164699.9n 1.31038 164700.0n 0.44994 164879.9n 0.44994 164880.0n 0.26400 165059.9n 0.26400 165060.0n 0.44934 165239.9n 0.44934 165240.0n -0.38855 165419.9n -0.38855 165420.0n 0.43551 165599.9n 0.43551 165600.0n -0.21890 165779.9n -0.21890 165780.0n 0.13970 165959.9n 0.13970 165960.0n 0.78502 166139.9n 0.78502 166140.0n -0.07007 166319.9n -0.07007 166320.0n 1.14927 166499.9n 1.14927 166500.0n 0.82918 166679.9n 0.82918 166680.0n 0.56419 166859.9n 0.56419 166860.0n 0.75921 167039.9n 0.75921 167040.0n 0.72357 167219.9n 0.72357 167220.0n 0.82918 167399.9n 0.82918 167400.0n 0.72924 167579.9n 0.72924 167580.0n -0.36668 167759.9n -0.36668 167760.0n 0.89441 167939.9n 0.89441 167940.0n 0.52444 168119.9n 0.52444 168120.0n 0.68861 168299.9n 0.68861 168300.0n 0.44994 168479.9n 0.44994 168480.0n -0.38855 168659.9n -0.38855 168660.0n 0.47921 168839.9n 0.47921 168840.0n 0.03541 169019.9n 0.03541 169020.0n 0.64370 169199.9n 0.64370 169200.0n 0.30498 169379.9n 0.30498 169380.0n 0.73581 169559.9n 0.73581 169560.0n -0.07007 169739.9n -0.07007 169740.0n -0.21890 169919.9n -0.21890 169920.0n 0.79881 170099.9n 0.79881 170100.0n 0.11168 170279.9n 0.11168 170280.0n 0.29315 170459.9n 0.29315 170460.0n 1.14927 170639.9n 1.14927 170640.0n 1.04662 170819.9n 1.04662 170820.0n 0.78502 170999.9n 0.78502 171000.0n 0.56419 171179.9n 0.56419 171180.0n 0.30031 171359.9n 0.30031 171360.0n 0.26400 171539.9n 0.26400 171540.0n 0.51492 171719.9n 0.51492 171720.0n 0.43551 171899.9n 0.43551 171900.0n 0.44934 172079.9n 0.44934 172080.0n 0.13970 172259.9n 0.13970 172260.0n 0.46859 172439.9n 0.46859 172440.0n 1.31038 172619.9n 1.31038 172620.0n 0.75921 172799.9n 0.75921 172800.0n 0.42258 172979.9n 0.42258 172980.0n 0.20713 173159.9n 0.20713 173160.0n 0.39910 173339.9n 0.39910 173340.0n 0.76629 173519.9n 0.76629 173520.0n 0.87516 173699.9n 0.87516 173700.0n 0.51649 173879.9n 0.51649 173880.0n 0.47728 174059.9n 0.47728 174060.0n 0.89579 174239.9n 0.89579 174240.0n 0.73813 174419.9n 0.73813 174420.0n 0.73007 174599.9n 0.73007 174600.0n 0.38805 174779.9n 0.38805 174780.0n 0.44565 174959.9n 0.44565 174960.0n 0.84972 175139.9n 0.84972 175140.0n 0.31374 175319.9n 0.31374 175320.0n 0.53500 175499.9n 0.53500 175500.0n 0.65381 175679.9n 0.65381 175680.0n 0.58828 175859.9n 0.58828 175860.0n 0.29293 176039.9n 0.29293 176040.0n 0.34864 176219.9n 0.34864 176220.0n 0.39919 176399.9n 0.39919 176400.0n 0.28504 176579.9n 0.28504 176580.0n 0.90918 176759.9n 0.90918 176760.0n 0.50331 176939.9n 0.50331 176940.0n 0.28807 177119.9n 0.28807 177120.0n 0.23424 177299.9n 0.23424 177300.0n 0.53888 177479.9n 0.53888 177480.0n 0.48728 177659.9n 0.48728 177660.0n 0.50852 177839.9n 0.50852 177840.0n 0.58450 178019.9n 0.58450 178020.0n 0.36568 178199.9n 0.36568 178200.0n -0.28851 178379.9n -0.28851 178380.0n -0.24585 178559.9n -0.24585 178560.0n 1.15208 178739.9n 1.15208 178740.0n 0.41841 178919.9n 0.41841 178920.0n 0.24338 179099.9n 0.24338 179100.0n 1.49277 179279.9n 1.49277 179280.0n 1.19260 179459.9n 1.19260 179460.0n -0.27962 179639.9n -0.27962 179640.0n 0.55733 179819.9n 0.55733 179820.0n 0.95600 179999.9n 0.95600 180000.0n -0.04710 180179.9n -0.04710 180180.0n 0.80242 180359.9n 0.80242 180360.0n 0.39736 180539.9n 0.39736 180540.0n 1.04029 180719.9n 1.04029 180720.0n 0.63149 180899.9n 0.63149 180900.0n 0.81752 181079.9n 0.81752 181080.0n 1.19808 181259.9n 1.19808 181260.0n 1.39872 181439.9n 1.39872 181440.0n 0.28119 181619.9n 0.28119 181620.0n 1.46004 181799.9n 1.46004 181800.0n -0.19303 181979.9n -0.19303 181980.0n 0.93542 182159.9n 0.93542 182160.0n 1.06311 182339.9n 1.06311 182340.0n 1.11193 182519.9n 1.11193 182520.0n 1.17413 182699.9n 1.17413 182700.0n 1.01300 182879.9n 1.01300 182880.0n 1.13586 183059.9n 1.13586 183060.0n 1.03731 183239.9n 1.03731 183240.0n 0.46939 183419.9n 0.46939 183420.0n 0.57188)
Vxp1 a_xp1 0 PWL(0.0n 0.28700 179.9n 0.28700 180.0n -0.37792 359.9n -0.37792 360.0n 0.28189 539.9n 0.28189 540.0n 1.18224 719.9n 1.18224 720.0n 0.13226 899.9n 0.13226 900.0n 0.59247 1079.9n 0.59247 1080.0n 0.42554 1259.9n 0.42554 1260.0n 0.76415 1439.9n 0.76415 1440.0n 0.23835 1619.9n 0.23835 1620.0n -0.15161 1799.9n -0.15161 1800.0n 1.28574 1979.9n 1.28574 1980.0n 0.70122 2159.9n 0.70122 2160.0n 0.66096 2339.9n 0.66096 2340.0n 0.34013 2519.9n 0.34013 2520.0n -0.33158 2699.9n -0.33158 2700.0n 0.40313 2879.9n 0.40313 2880.0n 0.48458 3059.9n 0.48458 3060.0n 1.27694 3239.9n 1.27694 3240.0n -0.23386 3419.9n -0.23386 3420.0n 1.23180 3599.9n 1.23180 3600.0n 0.65842 3779.9n 0.65842 3780.0n 1.20712 3959.9n 1.20712 3960.0n 1.11225 4139.9n 1.11225 4140.0n 0.56595 4319.9n 0.56595 4320.0n 0.67130 4499.9n 0.67130 4500.0n -0.08309 4679.9n -0.08309 4680.0n 0.29915 4859.9n 0.29915 4860.0n 0.33171 5039.9n 0.33171 5040.0n 0.63482 5219.9n 0.63482 5220.0n 0.25911 5399.9n 0.25911 5400.0n -0.21828 5579.9n -0.21828 5580.0n 1.17517 5759.9n 1.17517 5760.0n 1.11225 5939.9n 1.11225 5940.0n 0.59247 6119.9n 0.59247 6120.0n -0.33158 6299.9n -0.33158 6300.0n 0.56595 6479.9n 0.56595 6480.0n 0.34013 6659.9n 0.34013 6660.0n 1.27694 6839.9n 1.27694 6840.0n 1.23180 7019.9n 1.23180 7020.0n 0.42554 7199.9n 0.42554 7200.0n 0.40313 7379.9n 0.40313 7380.0n 0.76415 7559.9n 0.76415 7560.0n -0.08309 7739.9n -0.08309 7740.0n -0.21828 7919.9n -0.21828 7920.0n 0.13226 8099.9n 0.13226 8100.0n 0.70122 8279.9n 0.70122 8280.0n -0.23386 8459.9n -0.23386 8460.0n 0.67130 8639.9n 0.67130 8640.0n -0.37792 8819.9n -0.37792 8820.0n 0.29915 8999.9n 0.29915 9000.0n 0.65842 9179.9n 0.65842 9180.0n 0.25911 9359.9n 0.25911 9360.0n 0.33171 9539.9n 0.33171 9540.0n 0.63482 9719.9n 0.63482 9720.0n 1.17517 9899.9n 1.17517 9900.0n -0.15161 10079.9n -0.15161 10080.0n 1.28574 10259.9n 1.28574 10260.0n 0.28189 10439.9n 0.28189 10440.0n 0.48458 10619.9n 0.48458 10620.0n 1.20712 10799.9n 1.20712 10800.0n 0.66096 10979.9n 0.66096 10980.0n 0.23835 11159.9n 0.23835 11160.0n 1.18224 11339.9n 1.18224 11340.0n 0.28700 11519.9n 0.28700 11520.0n 1.17517 11699.9n 1.17517 11700.0n 0.40313 11879.9n 0.40313 11880.0n 0.23835 12059.9n 0.23835 12060.0n 0.67130 12239.9n 0.67130 12240.0n 1.28574 12419.9n 1.28574 12420.0n 1.20712 12599.9n 1.20712 12600.0n 0.76415 12779.9n 0.76415 12780.0n 0.28700 12959.9n 0.28700 12960.0n 1.27694 13139.9n 1.27694 13140.0n 0.28189 13319.9n 0.28189 13320.0n 1.23180 13499.9n 1.23180 13500.0n 0.65842 13679.9n 0.65842 13680.0n 0.34013 13859.9n 0.34013 13860.0n 0.25911 14039.9n 0.25911 14040.0n 0.42554 14219.9n 0.42554 14220.0n -0.08309 14399.9n -0.08309 14400.0n 0.56595 14579.9n 0.56595 14580.0n 0.33171 14759.9n 0.33171 14760.0n 1.18224 14939.9n 1.18224 14940.0n -0.21828 15119.9n -0.21828 15120.0n -0.33158 15299.9n -0.33158 15300.0n 0.48458 15479.9n 0.48458 15480.0n 0.70122 15659.9n 0.70122 15660.0n -0.37792 15839.9n -0.37792 15840.0n -0.23386 16019.9n -0.23386 16020.0n 0.66096 16199.9n 0.66096 16200.0n 1.11225 16379.9n 1.11225 16380.0n 0.63482 16559.9n 0.63482 16560.0n 0.29915 16739.9n 0.29915 16740.0n 0.13226 16919.9n 0.13226 16920.0n -0.15161 17099.9n -0.15161 17100.0n 0.59247 17279.9n 0.59247 17280.0n -0.21828 17459.9n -0.21828 17460.0n 0.63482 17639.9n 0.63482 17640.0n 0.25911 17819.9n 0.25911 17820.0n -0.23386 17999.9n -0.23386 18000.0n 0.28189 18179.9n 0.28189 18180.0n 0.28700 18359.9n 0.28700 18360.0n 1.20712 18539.9n 1.20712 18540.0n 0.76415 18719.9n 0.76415 18720.0n 0.33171 18899.9n 0.33171 18900.0n 0.48458 19079.9n 0.48458 19080.0n 0.65842 19259.9n 0.65842 19260.0n 0.70122 19439.9n 0.70122 19440.0n 0.42554 19619.9n 0.42554 19620.0n 1.27694 19799.9n 1.27694 19800.0n -0.08309 19979.9n -0.08309 19980.0n 0.67130 20159.9n 0.67130 20160.0n 1.18224 20339.9n 1.18224 20340.0n 0.56595 20519.9n 0.56595 20520.0n 0.34013 20699.9n 0.34013 20700.0n -0.37792 20879.9n -0.37792 20880.0n 1.11225 21059.9n 1.11225 21060.0n 0.29915 21239.9n 0.29915 21240.0n 0.40313 21419.9n 0.40313 21420.0n 1.28574 21599.9n 1.28574 21600.0n 0.13226 21779.9n 0.13226 21780.0n 0.59247 21959.9n 0.59247 21960.0n 1.17517 22139.9n 1.17517 22140.0n 1.23180 22319.9n 1.23180 22320.0n 0.66096 22499.9n 0.66096 22500.0n -0.15161 22679.9n -0.15161 22680.0n 0.23835 22859.9n 0.23835 22860.0n -0.33158 23039.9n -0.33158 23040.0n 0.67130 23219.9n 0.67130 23220.0n 0.40313 23399.9n 0.40313 23400.0n 0.66096 23579.9n 0.66096 23580.0n -0.23386 23759.9n -0.23386 23760.0n 0.29915 23939.9n 0.29915 23940.0n 0.25911 24119.9n 0.25911 24120.0n 0.42554 24299.9n 0.42554 24300.0n 1.20712 24479.9n 1.20712 24480.0n 0.33171 24659.9n 0.33171 24660.0n 0.28189 24839.9n 0.28189 24840.0n 0.65842 25019.9n 0.65842 25020.0n 0.76415 25199.9n 0.76415 25200.0n 1.28574 25379.9n 1.28574 25380.0n 1.27694 25559.9n 1.27694 25560.0n 0.13226 25739.9n 0.13226 25740.0n 0.23835 25919.9n 0.23835 25920.0n 0.56595 26099.9n 0.56595 26100.0n 0.48458 26279.9n 0.48458 26280.0n -0.08309 26459.9n -0.08309 26460.0n 1.18224 26639.9n 1.18224 26640.0n 1.23180 26819.9n 1.23180 26820.0n 0.70122 26999.9n 0.70122 27000.0n 0.63482 27179.9n 0.63482 27180.0n 0.34013 27359.9n 0.34013 27360.0n -0.21828 27539.9n -0.21828 27540.0n 0.28700 27719.9n 0.28700 27720.0n -0.37792 27899.9n -0.37792 27900.0n 1.17517 28079.9n 1.17517 28080.0n 1.11225 28259.9n 1.11225 28260.0n 0.59247 28439.9n 0.59247 28440.0n -0.33158 28619.9n -0.33158 28620.0n -0.15161 28799.9n -0.15161 28800.0n 1.20712 28979.9n 1.20712 28980.0n 0.70122 29159.9n 0.70122 29160.0n 0.48458 29339.9n 0.48458 29340.0n 0.40313 29519.9n 0.40313 29520.0n -0.15161 29699.9n -0.15161 29700.0n 0.34013 29879.9n 0.34013 29880.0n -0.37792 30059.9n -0.37792 30060.0n 1.27694 30239.9n 1.27694 30240.0n 1.18224 30419.9n 1.18224 30420.0n 0.28189 30599.9n 0.28189 30600.0n 0.29915 30779.9n 0.29915 30780.0n 0.63482 30959.9n 0.63482 30960.0n -0.23386 31139.9n -0.23386 31140.0n -0.33158 31319.9n -0.33158 31320.0n 0.76415 31499.9n 0.76415 31500.0n 1.17517 31679.9n 1.17517 31680.0n 0.23835 31859.9n 0.23835 31860.0n -0.08309 32039.9n -0.08309 32040.0n 0.28700 32219.9n 0.28700 32220.0n 0.67130 32399.9n 0.67130 32400.0n 0.33171 32579.9n 0.33171 32580.0n 0.65842 32759.9n 0.65842 32760.0n 0.25911 32939.9n 0.25911 32940.0n 0.42554 33119.9n 0.42554 33120.0n 0.66096 33299.9n 0.66096 33300.0n 1.11225 33479.9n 1.11225 33480.0n 1.23180 33659.9n 1.23180 33660.0n 1.28574 33839.9n 1.28574 33840.0n 0.13226 34019.9n 0.13226 34020.0n 0.56595 34199.9n 0.56595 34200.0n 0.59247 34379.9n 0.59247 34380.0n -0.21828 34559.9n -0.21828 34560.0n 0.48458 34739.9n 0.48458 34740.0n 0.33171 34919.9n 0.33171 34920.0n 1.11225 35099.9n 1.11225 35100.0n 0.28700 35279.9n 0.28700 35280.0n 1.28574 35459.9n 1.28574 35460.0n 1.23180 35639.9n 1.23180 35640.0n 0.34013 35819.9n 0.34013 35820.0n 0.76415 35999.9n 0.76415 36000.0n 0.70122 36179.9n 0.70122 36180.0n 0.23835 36359.9n 0.23835 36360.0n 0.66096 36539.9n 0.66096 36540.0n 0.56595 36719.9n 0.56595 36720.0n 0.28189 36899.9n 0.28189 36900.0n 0.25911 37079.9n 0.25911 37080.0n 1.17517 37259.9n 1.17517 37260.0n 0.40313 37439.9n 0.40313 37440.0n 0.59247 37619.9n 0.59247 37620.0n 1.27694 37799.9n 1.27694 37800.0n -0.15161 37979.9n -0.15161 37980.0n 1.20712 38159.9n 1.20712 38160.0n 0.63482 38339.9n 0.63482 38340.0n 0.67130 38519.9n 0.67130 38520.0n -0.37792 38699.9n -0.37792 38700.0n 0.65842 38879.9n 0.65842 38880.0n 0.13226 39059.9n 0.13226 39060.0n 0.42554 39239.9n 0.42554 39240.0n -0.23386 39419.9n -0.23386 39420.0n 0.29915 39599.9n 0.29915 39600.0n -0.08309 39779.9n -0.08309 39780.0n -0.21828 39959.9n -0.21828 39960.0n 1.18224 40139.9n 1.18224 40140.0n -0.33158 40319.9n -0.33158 40320.0n 0.25911 40499.9n 0.25911 40500.0n 0.76415 40679.9n 0.76415 40680.0n 1.28574 40859.9n 1.28574 40860.0n 1.11225 41039.9n 1.11225 41040.0n -0.15161 41219.9n -0.15161 41220.0n 0.33171 41399.9n 0.33171 41400.0n 0.65842 41579.9n 0.65842 41580.0n 1.20712 41759.9n 1.20712 41760.0n -0.08309 41939.9n -0.08309 41940.0n -0.37792 42119.9n -0.37792 42120.0n 0.42554 42299.9n 0.42554 42300.0n 1.23180 42479.9n 1.23180 42480.0n 0.70122 42659.9n 0.70122 42660.0n 0.28189 42839.9n 0.28189 42840.0n 0.40313 43019.9n 0.40313 43020.0n 0.48458 43199.9n 0.48458 43200.0n 1.18224 43379.9n 1.18224 43380.0n 0.29915 43559.9n 0.29915 43560.0n 0.67130 43739.9n 0.67130 43740.0n 1.17517 43919.9n 1.17517 43920.0n 0.34013 44099.9n 0.34013 44100.0n 0.28700 44279.9n 0.28700 44280.0n 1.27694 44459.9n 1.27694 44460.0n -0.21828 44639.9n -0.21828 44640.0n 0.66096 44819.9n 0.66096 44820.0n 0.13226 44999.9n 0.13226 45000.0n 0.23835 45179.9n 0.23835 45180.0n 0.63482 45359.9n 0.63482 45360.0n 0.59247 45539.9n 0.59247 45540.0n 0.56595 45719.9n 0.56595 45720.0n -0.23386 45899.9n -0.23386 45900.0n -0.33158 46079.9n -0.33158 46080.0n 0.34013 46259.9n 0.34013 46260.0n 0.40313 46439.9n 0.40313 46440.0n 0.33171 46619.9n 0.33171 46620.0n -0.08309 46799.9n -0.08309 46800.0n 0.23835 46979.9n 0.23835 46980.0n 0.59247 47159.9n 0.59247 47160.0n -0.37792 47339.9n -0.37792 47340.0n 0.65842 47519.9n 0.65842 47520.0n 0.29915 47699.9n 0.29915 47700.0n 0.56595 47879.9n 0.56595 47880.0n 0.28189 48059.9n 0.28189 48060.0n 1.17517 48239.9n 1.17517 48240.0n -0.23386 48419.9n -0.23386 48420.0n -0.33158 48599.9n -0.33158 48600.0n -0.21828 48779.9n -0.21828 48780.0n 0.66096 48959.9n 0.66096 48960.0n 1.18224 49139.9n 1.18224 49140.0n -0.15161 49319.9n -0.15161 49320.0n 1.28574 49499.9n 1.28574 49500.0n 0.28700 49679.9n 0.28700 49680.0n 0.42554 49859.9n 0.42554 49860.0n 0.63482 50039.9n 0.63482 50040.0n 0.70122 50219.9n 0.70122 50220.0n 0.67130 50399.9n 0.67130 50400.0n 0.25911 50579.9n 0.25911 50580.0n 0.13226 50759.9n 0.13226 50760.0n 1.20712 50939.9n 1.20712 50940.0n 1.23180 51119.9n 1.23180 51120.0n 1.11225 51299.9n 1.11225 51300.0n 0.76415 51479.9n 0.76415 51480.0n 1.27694 51659.9n 1.27694 51660.0n 0.48458 51839.9n 0.48458 51840.0n -0.21828 52019.9n -0.21828 52020.0n -0.08309 52199.9n -0.08309 52200.0n 0.29915 52379.9n 0.29915 52380.0n 0.65842 52559.9n 0.65842 52560.0n 1.20712 52739.9n 1.20712 52740.0n 0.67130 52919.9n 0.67130 52920.0n 0.42554 53099.9n 0.42554 53100.0n -0.23386 53279.9n -0.23386 53280.0n -0.33158 53459.9n -0.33158 53460.0n 1.27694 53639.9n 1.27694 53640.0n 1.17517 53819.9n 1.17517 53820.0n 0.28700 53999.9n 0.28700 54000.0n -0.15161 54179.9n -0.15161 54180.0n 0.33171 54359.9n 0.33171 54360.0n -0.37792 54539.9n -0.37792 54540.0n 0.63482 54719.9n 0.63482 54720.0n 0.34013 54899.9n 0.34013 54900.0n 0.48458 55079.9n 0.48458 55080.0n 0.66096 55259.9n 0.66096 55260.0n 0.40313 55439.9n 0.40313 55440.0n 0.25911 55619.9n 0.25911 55620.0n 0.70122 55799.9n 0.70122 55800.0n 1.28574 55979.9n 1.28574 55980.0n 0.13226 56159.9n 0.13226 56160.0n 1.11225 56339.9n 1.11225 56340.0n 0.59247 56519.9n 0.59247 56520.0n 0.23835 56699.9n 0.23835 56700.0n 0.76415 56879.9n 0.76415 56880.0n 0.28189 57059.9n 0.28189 57060.0n 1.23180 57239.9n 1.23180 57240.0n 1.18224 57419.9n 1.18224 57420.0n 0.56595 57599.9n 0.56595 57600.0n 0.28189 57779.9n 0.28189 57780.0n 0.33171 57959.9n 0.33171 57960.0n 1.27694 58139.9n 1.27694 58140.0n 0.63482 58319.9n 0.63482 58320.0n 0.34013 58499.9n 0.34013 58500.0n -0.15161 58679.9n -0.15161 58680.0n 0.65842 58859.9n 0.65842 58860.0n -0.37792 59039.9n -0.37792 59040.0n 0.56595 59219.9n 0.56595 59220.0n 1.23180 59399.9n 1.23180 59400.0n -0.21828 59579.9n -0.21828 59580.0n 1.20712 59759.9n 1.20712 59760.0n 0.59247 59939.9n 0.59247 59940.0n 0.48458 60119.9n 0.48458 60120.0n 1.28574 60299.9n 1.28574 60300.0n -0.33158 60479.9n -0.33158 60480.0n 0.40313 60659.9n 0.40313 60660.0n 0.29915 60839.9n 0.29915 60840.0n 0.42554 61019.9n 0.42554 61020.0n 0.23835 61199.9n 0.23835 61200.0n 1.11225 61379.9n 1.11225 61380.0n -0.08309 61559.9n -0.08309 61560.0n -0.23386 61739.9n -0.23386 61740.0n 0.25911 61919.9n 0.25911 61920.0n 0.76415 62099.9n 0.76415 62100.0n 1.17517 62279.9n 1.17517 62280.0n 0.66096 62459.9n 0.66096 62460.0n 0.13226 62639.9n 0.13226 62640.0n 0.70122 62819.9n 0.70122 62820.0n 0.28700 62999.9n 0.28700 63000.0n 1.18224 63179.9n 1.18224 63180.0n 0.67130 63359.9n 0.67130 63360.0n -0.23386 63539.9n -0.23386 63540.0n 0.42554 63719.9n 0.42554 63720.0n 0.63482 63899.9n 0.63482 63900.0n 0.40313 64079.9n 0.40313 64080.0n 0.25911 64259.9n 0.25911 64260.0n 1.17517 64439.9n 1.17517 64440.0n 1.11225 64619.9n 1.11225 64620.0n 1.27694 64799.9n 1.27694 64800.0n 1.18224 64979.9n 1.18224 64980.0n -0.08309 65159.9n -0.08309 65160.0n 0.66096 65339.9n 0.66096 65340.0n 0.48458 65519.9n 0.48458 65520.0n 0.28189 65699.9n 0.28189 65700.0n 0.23835 65879.9n 0.23835 65880.0n 0.59247 66059.9n 0.59247 66060.0n -0.37792 66239.9n -0.37792 66240.0n 0.28700 66419.9n 0.28700 66420.0n 0.70122 66599.9n 0.70122 66600.0n 0.56595 66779.9n 0.56595 66780.0n 1.28574 66959.9n 1.28574 66960.0n -0.33158 67139.9n -0.33158 67140.0n 0.65842 67319.9n 0.65842 67320.0n 0.33171 67499.9n 0.33171 67500.0n 0.13226 67679.9n 0.13226 67680.0n -0.15161 67859.9n -0.15161 67860.0n 0.76415 68039.9n 0.76415 68040.0n 0.29915 68219.9n 0.29915 68220.0n -0.21828 68399.9n -0.21828 68400.0n 1.23180 68579.9n 1.23180 68580.0n 0.34013 68759.9n 0.34013 68760.0n 0.67130 68939.9n 0.67130 68940.0n 1.20712 69119.9n 1.20712 69120.0n -0.37792 69299.9n -0.37792 69300.0n 0.70122 69479.9n 0.70122 69480.0n 0.67130 69659.9n 0.67130 69660.0n 0.66096 69839.9n 0.66096 69840.0n 0.76415 70019.9n 0.76415 70020.0n 0.65842 70199.9n 0.65842 70200.0n 0.42554 70379.9n 0.42554 70380.0n 0.28189 70559.9n 0.28189 70560.0n 0.28700 70739.9n 0.28700 70740.0n 1.23180 70919.9n 1.23180 70920.0n 0.33171 71099.9n 0.33171 71100.0n 0.40313 71279.9n 0.40313 71280.0n 0.25911 71459.9n 0.25911 71460.0n 1.20712 71639.9n 1.20712 71640.0n 1.27694 71819.9n 1.27694 71820.0n 0.56595 71999.9n 0.56595 72000.0n -0.33158 72179.9n -0.33158 72180.0n 1.11225 72359.9n 1.11225 72360.0n 0.59247 72539.9n 0.59247 72540.0n 0.23835 72719.9n 0.23835 72720.0n -0.15161 72899.9n -0.15161 72900.0n 1.18224 73079.9n 1.18224 73080.0n 1.17517 73259.9n 1.17517 73260.0n 0.63482 73439.9n 0.63482 73440.0n 0.13226 73619.9n 0.13226 73620.0n -0.23386 73799.9n -0.23386 73800.0n 0.34013 73979.9n 0.34013 73980.0n 0.29915 74159.9n 0.29915 74160.0n -0.21828 74339.9n -0.21828 74340.0n 1.28574 74519.9n 1.28574 74520.0n -0.08309 74699.9n -0.08309 74700.0n 0.48458 74879.9n 0.48458 74880.0n 0.13226 75059.9n 0.13226 75060.0n -0.08309 75239.9n -0.08309 75240.0n -0.23386 75419.9n -0.23386 75420.0n 0.76415 75599.9n 0.76415 75600.0n 0.63482 75779.9n 0.63482 75780.0n 0.25911 75959.9n 0.25911 75960.0n -0.37792 76139.9n -0.37792 76140.0n 0.59247 76319.9n 0.59247 76320.0n 0.34013 76499.9n 0.34013 76500.0n 0.42554 76679.9n 0.42554 76680.0n 0.28189 76859.9n 0.28189 76860.0n 0.23835 77039.9n 0.23835 77040.0n 0.40313 77219.9n 0.40313 77220.0n 1.20712 77399.9n 1.20712 77400.0n 1.27694 77579.9n 1.27694 77580.0n 1.18224 77759.9n 1.18224 77760.0n 0.56595 77939.9n 0.56595 77940.0n 0.67130 78119.9n 0.67130 78120.0n -0.33158 78299.9n -0.33158 78300.0n 1.23180 78479.9n 1.23180 78480.0n 0.29915 78659.9n 0.29915 78660.0n 0.28700 78839.9n 0.28700 78840.0n 1.28574 79019.9n 1.28574 79020.0n 0.33171 79199.9n 0.33171 79200.0n 0.70122 79379.9n 0.70122 79380.0n 0.65842 79559.9n 0.65842 79560.0n 0.66096 79739.9n 0.66096 79740.0n -0.15161 79919.9n -0.15161 79920.0n 1.11225 80099.9n 1.11225 80100.0n -0.21828 80279.9n -0.21828 80280.0n 0.48458 80459.9n 0.48458 80460.0n 1.17517 80639.9n 1.17517 80640.0n 1.27694 80819.9n 1.27694 80820.0n 0.59247 80999.9n 0.59247 81000.0n 1.23180 81179.9n 1.23180 81180.0n 0.70122 81359.9n 0.70122 81360.0n 1.18224 81539.9n 1.18224 81540.0n 0.13226 81719.9n 0.13226 81720.0n -0.21828 81899.9n -0.21828 81900.0n -0.15161 82079.9n -0.15161 82080.0n 0.66096 82259.9n 0.66096 82260.0n 1.17517 82439.9n 1.17517 82440.0n 0.29915 82619.9n 0.29915 82620.0n 0.33171 82799.9n 0.33171 82800.0n 0.63482 82979.9n 0.63482 82980.0n 0.48458 83159.9n 0.48458 83160.0n -0.23386 83339.9n -0.23386 83340.0n 0.42554 83519.9n 0.42554 83520.0n 0.40313 83699.9n 0.40313 83700.0n 1.11225 83879.9n 1.11225 83880.0n -0.08309 84059.9n -0.08309 84060.0n 0.56595 84239.9n 0.56595 84240.0n 0.65842 84419.9n 0.65842 84420.0n 0.25911 84599.9n 0.25911 84600.0n 0.67130 84779.9n 0.67130 84780.0n -0.37792 84959.9n -0.37792 84960.0n 0.23835 85139.9n 0.23835 85140.0n 0.76415 85319.9n 0.76415 85320.0n 1.20712 85499.9n 1.20712 85500.0n 0.28700 85679.9n 0.28700 85680.0n 1.28574 85859.9n 1.28574 85860.0n 0.34013 86039.9n 0.34013 86040.0n -0.33158 86219.9n -0.33158 86220.0n 0.28189 86399.9n 0.28189 86400.0n -0.33158 86579.9n -0.33158 86580.0n 0.29915 86759.9n 0.29915 86760.0n 0.25911 86939.9n 0.25911 86940.0n 0.33171 87119.9n 0.33171 87120.0n 1.28574 87299.9n 1.28574 87300.0n 1.11225 87479.9n 1.11225 87480.0n 1.27694 87659.9n 1.27694 87660.0n 0.48458 87839.9n 0.48458 87840.0n 0.66096 88019.9n 0.66096 88020.0n -0.08309 88199.9n -0.08309 88200.0n 1.17517 88379.9n 1.17517 88380.0n 0.23835 88559.9n 0.23835 88560.0n -0.15161 88739.9n -0.15161 88740.0n 0.76415 88919.9n 0.76415 88920.0n 0.56595 89099.9n 0.56595 89100.0n 0.34013 89279.9n 0.34013 89280.0n 0.42554 89459.9n 0.42554 89460.0n 0.65842 89639.9n 0.65842 89640.0n 0.63482 89819.9n 0.63482 89820.0n -0.21828 89999.9n -0.21828 90000.0n -0.23386 90179.9n -0.23386 90180.0n 1.23180 90359.9n 1.23180 90360.0n 0.67130 90539.9n 0.67130 90540.0n 0.40313 90719.9n 0.40313 90720.0n 0.70122 90899.9n 0.70122 90900.0n 1.20712 91079.9n 1.20712 91080.0n 0.13226 91259.9n 0.13226 91260.0n 0.59247 91439.9n 0.59247 91440.0n 0.28189 91619.9n 0.28189 91620.0n -0.37792 91799.9n -0.37792 91800.0n 0.28700 91979.9n 0.28700 91980.0n 1.18224 92159.9n 1.18224 92160.0n 0.59247 92339.9n 0.59247 92340.0n -0.33158 92519.9n -0.33158 92520.0n 1.11225 92699.9n 1.11225 92700.0n -0.37792 92879.9n -0.37792 92880.0n -0.23386 93059.9n -0.23386 93060.0n -0.21828 93239.9n -0.21828 93240.0n 1.28574 93419.9n 1.28574 93420.0n 1.17517 93599.9n 1.17517 93600.0n -0.15161 93779.9n -0.15161 93780.0n 0.70122 93959.9n 0.70122 93960.0n 0.23835 94139.9n 0.23835 94140.0n 1.20712 94319.9n 1.20712 94320.0n 0.29915 94499.9n 0.29915 94500.0n 0.28189 94679.9n 0.28189 94680.0n 0.13226 94859.9n 0.13226 94860.0n 1.23180 95039.9n 1.23180 95040.0n 0.25911 95219.9n 0.25911 95220.0n 0.67130 95399.9n 0.67130 95400.0n 0.33171 95579.9n 0.33171 95580.0n 1.18224 95759.9n 1.18224 95760.0n 1.27694 95939.9n 1.27694 95940.0n 0.34013 96119.9n 0.34013 96120.0n 0.63482 96299.9n 0.63482 96300.0n 0.76415 96479.9n 0.76415 96480.0n -0.08309 96659.9n -0.08309 96660.0n 0.40313 96839.9n 0.40313 96840.0n 0.48458 97019.9n 0.48458 97020.0n 0.56595 97199.9n 0.56595 97200.0n 0.28700 97379.9n 0.28700 97380.0n 0.42554 97559.9n 0.42554 97560.0n 0.66096 97739.9n 0.66096 97740.0n 0.65842 97919.9n 0.65842 97920.0n 1.27694 98099.9n 1.27694 98100.0n -0.37792 98279.9n -0.37792 98280.0n -0.21828 98459.9n -0.21828 98460.0n 0.28700 98639.9n 0.28700 98640.0n 0.33171 98819.9n 0.33171 98820.0n 0.63482 98999.9n 0.63482 99000.0n 0.28189 99179.9n 0.28189 99180.0n 0.25911 99359.9n 0.25911 99360.0n 1.20712 99539.9n 1.20712 99540.0n 1.18224 99719.9n 1.18224 99720.0n 0.56595 99899.9n 0.56595 99900.0n 1.11225 100079.9n 1.11225 100080.0n 0.65842 100259.9n 0.65842 100260.0n -0.33158 100439.9n -0.33158 100440.0n 0.23835 100619.9n 0.23835 100620.0n 0.59247 100799.9n 0.59247 100800.0n -0.08309 100979.9n -0.08309 100980.0n 0.67130 101159.9n 0.67130 101160.0n 0.48458 101339.9n 0.48458 101340.0n 1.23180 101519.9n 1.23180 101520.0n 0.66096 101699.9n 0.66096 101700.0n 0.29915 101879.9n 0.29915 101880.0n 0.70122 102059.9n 0.70122 102060.0n -0.23386 102239.9n -0.23386 102240.0n -0.15161 102419.9n -0.15161 102420.0n 1.28574 102599.9n 1.28574 102600.0n 0.34013 102779.9n 0.34013 102780.0n 0.13226 102959.9n 0.13226 102960.0n 0.76415 103139.9n 0.76415 103140.0n 0.42554 103319.9n 0.42554 103320.0n 0.40313 103499.9n 0.40313 103500.0n 1.17517 103679.9n 1.17517 103680.0n 1.20712 103859.9n 1.20712 103860.0n 1.11225 104039.9n 1.11225 104040.0n 0.28189 104219.9n 0.28189 104220.0n 1.18224 104399.9n 1.18224 104400.0n 1.28574 104579.9n 1.28574 104580.0n -0.33158 104759.9n -0.33158 104760.0n 0.56595 104939.9n 0.56595 104940.0n 1.27694 105119.9n 1.27694 105120.0n -0.21828 105299.9n -0.21828 105300.0n 0.67130 105479.9n 0.67130 105480.0n 0.25911 105659.9n 0.25911 105660.0n 0.59247 105839.9n 0.59247 105840.0n 0.29915 106019.9n 0.29915 106020.0n 0.63482 106199.9n 0.63482 106200.0n 0.33171 106379.9n 0.33171 106380.0n 0.65842 106559.9n 0.65842 106560.0n 0.23835 106739.9n 0.23835 106740.0n 0.66096 106919.9n 0.66096 106920.0n 1.17517 107099.9n 1.17517 107100.0n -0.23386 107279.9n -0.23386 107280.0n 0.48458 107459.9n 0.48458 107460.0n 1.23180 107639.9n 1.23180 107640.0n 0.42554 107819.9n 0.42554 107820.0n 0.70122 107999.9n 0.70122 108000.0n -0.15161 108179.9n -0.15161 108180.0n 0.13226 108359.9n 0.13226 108360.0n 0.28700 108539.9n 0.28700 108540.0n 0.76415 108719.9n 0.76415 108720.0n -0.08309 108899.9n -0.08309 108900.0n 0.34013 109079.9n 0.34013 109080.0n 0.40313 109259.9n 0.40313 109260.0n -0.37792 109439.9n -0.37792 109440.0n 1.17517 109619.9n 1.17517 109620.0n -0.21828 109799.9n -0.21828 109800.0n 0.29915 109979.9n 0.29915 109980.0n 0.42554 110159.9n 0.42554 110160.0n -0.37792 110339.9n -0.37792 110340.0n 0.56595 110519.9n 0.56595 110520.0n -0.23386 110699.9n -0.23386 110700.0n 1.23180 110879.9n 1.23180 110880.0n 0.28189 111059.9n 0.28189 111060.0n 0.34013 111239.9n 0.34013 111240.0n 1.20712 111419.9n 1.20712 111420.0n 0.59247 111599.9n 0.59247 111600.0n 0.63482 111779.9n 0.63482 111780.0n 0.28700 111959.9n 0.28700 111960.0n 0.40313 112139.9n 0.40313 112140.0n 0.13226 112319.9n 0.13226 112320.0n 1.18224 112499.9n 1.18224 112500.0n 0.66096 112679.9n 0.66096 112680.0n 1.27694 112859.9n 1.27694 112860.0n 1.11225 113039.9n 1.11225 113040.0n 0.33171 113219.9n 0.33171 113220.0n 0.23835 113399.9n 0.23835 113400.0n 0.65842 113579.9n 0.65842 113580.0n 0.76415 113759.9n 0.76415 113760.0n 0.48458 113939.9n 0.48458 113940.0n 0.25911 114119.9n 0.25911 114120.0n -0.15161 114299.9n -0.15161 114300.0n 1.28574 114479.9n 1.28574 114480.0n 0.67130 114659.9n 0.67130 114660.0n 0.70122 114839.9n 0.70122 114840.0n -0.08309 115019.9n -0.08309 115020.0n -0.33158 115199.9n -0.33158 115200.0n 1.17517 115379.9n 1.17517 115380.0n 1.27694 115559.9n 1.27694 115560.0n 0.23835 115739.9n 0.23835 115740.0n -0.15161 115919.9n -0.15161 115920.0n 1.18224 116099.9n 1.18224 116100.0n 0.28189 116279.9n 0.28189 116280.0n 0.25911 116459.9n 0.25911 116460.0n 0.67130 116639.9n 0.67130 116640.0n -0.21828 116819.9n -0.21828 116820.0n 0.76415 116999.9n 0.76415 117000.0n 0.66096 117179.9n 0.66096 117180.0n 0.28700 117359.9n 0.28700 117360.0n 0.63482 117539.9n 0.63482 117540.0n 1.11225 117719.9n 1.11225 117720.0n -0.37792 117899.9n -0.37792 117900.0n -0.23386 118079.9n -0.23386 118080.0n 0.29915 118259.9n 0.29915 118260.0n 0.40313 118439.9n 0.40313 118440.0n 0.13226 118619.9n 0.13226 118620.0n 0.34013 118799.9n 0.34013 118800.0n 0.65842 118979.9n 0.65842 118980.0n 0.56595 119159.9n 0.56595 119160.0n 0.59247 119339.9n 0.59247 119340.0n -0.08309 119519.9n -0.08309 119520.0n 1.28574 119699.9n 1.28574 119700.0n 1.20712 119879.9n 1.20712 119880.0n 0.42554 120059.9n 0.42554 120060.0n 0.70122 120239.9n 0.70122 120240.0n -0.33158 120419.9n -0.33158 120420.0n 0.33171 120599.9n 0.33171 120600.0n 1.23180 120779.9n 1.23180 120780.0n 0.48458 120959.9n 0.48458 120960.0n 1.27694 121139.9n 1.27694 121140.0n -0.08309 121319.9n -0.08309 121320.0n -0.37792 121499.9n -0.37792 121500.0n 1.17517 121679.9n 1.17517 121680.0n 0.13226 121859.9n 0.13226 121860.0n 0.67130 122039.9n 0.67130 122040.0n 1.28574 122219.9n 1.28574 122220.0n 0.59247 122399.9n 0.59247 122400.0n 0.56595 122579.9n 0.56595 122580.0n 0.42554 122759.9n 0.42554 122760.0n 0.65842 122939.9n 0.65842 122940.0n 0.28189 123119.9n 0.28189 123120.0n -0.21828 123299.9n -0.21828 123300.0n 0.25911 123479.9n 0.25911 123480.0n 0.63482 123659.9n 0.63482 123660.0n 0.33171 123839.9n 0.33171 123840.0n -0.23386 124019.9n -0.23386 124020.0n 0.66096 124199.9n 0.66096 124200.0n 0.48458 124379.9n 0.48458 124380.0n 0.40313 124559.9n 0.40313 124560.0n 0.23835 124739.9n 0.23835 124740.0n 1.20712 124919.9n 1.20712 124920.0n 0.28700 125099.9n 0.28700 125100.0n 1.11225 125279.9n 1.11225 125280.0n 0.76415 125459.9n 0.76415 125460.0n 0.70122 125639.9n 0.70122 125640.0n 1.18224 125819.9n 1.18224 125820.0n 0.29915 125999.9n 0.29915 126000.0n 1.23180 126179.9n 1.23180 126180.0n -0.33158 126359.9n -0.33158 126360.0n 0.34013 126539.9n 0.34013 126540.0n -0.15161 126719.9n -0.15161 126720.0n 0.13226 126899.9n 0.13226 126900.0n -0.33158 127079.9n -0.33158 127080.0n 0.66096 127259.9n 0.66096 127260.0n 0.65842 127439.9n 0.65842 127440.0n -0.21828 127619.9n -0.21828 127620.0n -0.15161 127799.9n -0.15161 127800.0n 1.11225 127979.9n 1.11225 127980.0n -0.23386 128159.9n -0.23386 128160.0n 0.59247 128339.9n 0.59247 128340.0n -0.08309 128519.9n -0.08309 128520.0n 0.48458 128699.9n 0.48458 128700.0n 0.40313 128879.9n 0.40313 128880.0n 1.17517 129059.9n 1.17517 129060.0n 1.23180 129239.9n 1.23180 129240.0n 0.25911 129419.9n 0.25911 129420.0n 0.67130 129599.9n 0.67130 129600.0n 0.42554 129779.9n 0.42554 129780.0n 0.28189 129959.9n 0.28189 129960.0n -0.37792 130139.9n -0.37792 130140.0n 0.70122 130319.9n 0.70122 130320.0n 1.20712 130499.9n 1.20712 130500.0n 0.33171 130679.9n 0.33171 130680.0n 1.27694 130859.9n 1.27694 130860.0n 0.63482 131039.9n 0.63482 131040.0n 0.34013 131219.9n 0.34013 131220.0n 0.76415 131399.9n 0.76415 131400.0n 0.56595 131579.9n 0.56595 131580.0n 0.29915 131759.9n 0.29915 131760.0n 1.28574 131939.9n 1.28574 131940.0n 0.23835 132119.9n 0.23835 132120.0n 1.18224 132299.9n 1.18224 132300.0n 0.28700 132479.9n 0.28700 132480.0n 0.28189 132659.9n 0.28189 132660.0n 0.56595 132839.9n 0.56595 132840.0n 0.23835 133019.9n 0.23835 133020.0n 0.29915 133199.9n 0.29915 133200.0n 0.76415 133379.9n 0.76415 133380.0n -0.08309 133559.9n -0.08309 133560.0n -0.21828 133739.9n -0.21828 133740.0n 0.42554 133919.9n 0.42554 133920.0n 0.40313 134099.9n 0.40313 134100.0n 1.27694 134279.9n 1.27694 134280.0n 0.28700 134459.9n 0.28700 134460.0n -0.33158 134639.9n -0.33158 134640.0n 0.67130 134819.9n 0.67130 134820.0n 0.66096 134999.9n 0.66096 135000.0n -0.15161 135179.9n -0.15161 135180.0n 0.25911 135359.9n 0.25911 135360.0n 1.18224 135539.9n 1.18224 135540.0n 0.34013 135719.9n 0.34013 135720.0n 0.48458 135899.9n 0.48458 135900.0n 1.17517 136079.9n 1.17517 136080.0n 0.59247 136259.9n 0.59247 136260.0n 0.65842 136439.9n 0.65842 136440.0n 0.70122 136619.9n 0.70122 136620.0n 0.33171 136799.9n 0.33171 136800.0n 1.20712 136979.9n 1.20712 136980.0n 0.13226 137159.9n 0.13226 137160.0n 1.28574 137339.9n 1.28574 137340.0n -0.37792 137519.9n -0.37792 137520.0n 0.63482 137699.9n 0.63482 137700.0n -0.23386 137879.9n -0.23386 137880.0n 1.11225 138059.9n 1.11225 138060.0n 1.23180 138239.9n 1.23180 138240.0n 1.28574 138419.9n 1.28574 138420.0n 0.70122 138599.9n 0.70122 138600.0n 0.63482 138779.9n 0.63482 138780.0n 0.13226 138959.9n 0.13226 138960.0n 1.11225 139139.9n 1.11225 139140.0n 0.23835 139319.9n 0.23835 139320.0n 0.34013 139499.9n 0.34013 139500.0n 0.67130 139679.9n 0.67130 139680.0n 0.29915 139859.9n 0.29915 139860.0n 0.33171 140039.9n 0.33171 140040.0n 0.25911 140219.9n 0.25911 140220.0n 1.20712 140399.9n 1.20712 140400.0n -0.15161 140579.9n -0.15161 140580.0n -0.37792 140759.9n -0.37792 140760.0n 0.66096 140939.9n 0.66096 140940.0n -0.23386 141119.9n -0.23386 141120.0n 0.76415 141299.9n 0.76415 141300.0n 0.65842 141479.9n 0.65842 141480.0n 0.59247 141659.9n 0.59247 141660.0n 0.28189 141839.9n 0.28189 141840.0n 0.42554 142019.9n 0.42554 142020.0n 0.40313 142199.9n 0.40313 142200.0n -0.33158 142379.9n -0.33158 142380.0n 0.56595 142559.9n 0.56595 142560.0n 1.17517 142739.9n 1.17517 142740.0n 1.18224 142919.9n 1.18224 142920.0n 0.28700 143099.9n 0.28700 143100.0n 1.23180 143279.9n 1.23180 143280.0n 1.27694 143459.9n 1.27694 143460.0n 0.48458 143639.9n 0.48458 143640.0n -0.21828 143819.9n -0.21828 143820.0n -0.08309 143999.9n -0.08309 144000.0n 0.28700 144179.9n 0.28700 144180.0n -0.37792 144359.9n -0.37792 144360.0n 0.40313 144539.9n 0.40313 144540.0n 0.56595 144719.9n 0.56595 144720.0n -0.33158 144899.9n -0.33158 144900.0n -0.21828 145079.9n -0.21828 145080.0n 0.48458 145259.9n 0.48458 145260.0n 0.65842 145439.9n 0.65842 145440.0n 0.63482 145619.9n 0.63482 145620.0n 0.34013 145799.9n 0.34013 145800.0n 0.28189 145979.9n 0.28189 145980.0n 0.13226 146159.9n 0.13226 146160.0n 0.23835 146339.9n 0.23835 146340.0n 0.59247 146519.9n 0.59247 146520.0n -0.23386 146699.9n -0.23386 146700.0n 0.33171 146879.9n 0.33171 146880.0n 0.67130 147059.9n 0.67130 147060.0n 0.66096 147239.9n 0.66096 147240.0n 1.28574 147419.9n 1.28574 147420.0n 0.29915 147599.9n 0.29915 147600.0n 0.76415 147779.9n 0.76415 147780.0n -0.15161 147959.9n -0.15161 147960.0n 1.23180 148139.9n 1.23180 148140.0n 1.20712 148319.9n 1.20712 148320.0n 1.17517 148499.9n 1.17517 148500.0n 0.25911 148679.9n 0.25911 148680.0n 1.11225 148859.9n 1.11225 148860.0n 0.70122 149039.9n 0.70122 149040.0n -0.08309 149219.9n -0.08309 149220.0n 1.27694 149399.9n 1.27694 149400.0n 1.18224 149579.9n 1.18224 149580.0n 0.42554 149759.9n 0.42554 149760.0n 0.13226 149939.9n 0.13226 149940.0n 0.63482 150119.9n 0.63482 150120.0n 1.27694 150299.9n 1.27694 150300.0n 0.76415 150479.9n 0.76415 150480.0n -0.33158 150659.9n -0.33158 150660.0n 0.67130 150839.9n 0.67130 150840.0n 0.66096 151019.9n 0.66096 151020.0n 0.42554 151199.9n 0.42554 151200.0n 0.48458 151379.9n 0.48458 151380.0n 0.40313 151559.9n 0.40313 151560.0n 1.20712 151739.9n 1.20712 151740.0n -0.21828 151919.9n -0.21828 151920.0n 0.59247 152099.9n 0.59247 152100.0n 1.23180 152279.9n 1.23180 152280.0n 0.25911 152459.9n 0.25911 152460.0n 1.11225 152639.9n 1.11225 152640.0n 0.29915 152819.9n 0.29915 152820.0n 0.65842 152999.9n 0.65842 153000.0n 0.23835 153179.9n 0.23835 153180.0n 0.28189 153359.9n 0.28189 153360.0n -0.37792 153539.9n -0.37792 153540.0n -0.23386 153719.9n -0.23386 153720.0n 0.34013 153899.9n 0.34013 153900.0n 0.56595 154079.9n 0.56595 154080.0n -0.15161 154259.9n -0.15161 154260.0n 0.28700 154439.9n 0.28700 154440.0n 1.17517 154619.9n 1.17517 154620.0n 1.18224 154799.9n 1.18224 154800.0n 1.28574 154979.9n 1.28574 154980.0n 0.33171 155159.9n 0.33171 155160.0n -0.08309 155339.9n -0.08309 155340.0n 0.70122 155519.9n 0.70122 155520.0n -0.21828 155699.9n -0.21828 155700.0n 1.18224 155879.9n 1.18224 155880.0n 0.76415 156059.9n 0.76415 156060.0n -0.23386 156239.9n -0.23386 156240.0n 0.56595 156419.9n 0.56595 156420.0n 1.20712 156599.9n 1.20712 156600.0n 0.67130 156779.9n 0.67130 156780.0n 0.33171 156959.9n 0.33171 156960.0n -0.08309 157139.9n -0.08309 157140.0n 0.13226 157319.9n 0.13226 157320.0n 0.25911 157499.9n 0.25911 157500.0n -0.37792 157679.9n -0.37792 157680.0n 0.34013 157859.9n 0.34013 157860.0n 0.59247 158039.9n 0.59247 158040.0n 0.63482 158219.9n 0.63482 158220.0n 0.40313 158399.9n 0.40313 158400.0n 1.17517 158579.9n 1.17517 158580.0n 0.65842 158759.9n 0.65842 158760.0n 0.28189 158939.9n 0.28189 158940.0n 1.27694 159119.9n 1.27694 159120.0n 0.29915 159299.9n 0.29915 159300.0n 0.66096 159479.9n 0.66096 159480.0n 1.11225 159659.9n 1.11225 159660.0n 0.48458 159839.9n 0.48458 159840.0n 1.23180 160019.9n 1.23180 160020.0n 1.28574 160199.9n 1.28574 160200.0n 0.70122 160379.9n 0.70122 160380.0n -0.15161 160559.9n -0.15161 160560.0n -0.33158 160739.9n -0.33158 160740.0n 0.23835 160919.9n 0.23835 160920.0n 0.28700 161099.9n 0.28700 161100.0n 0.42554 161279.9n 0.42554 161280.0n 0.33171 161459.9n 0.33171 161460.0n 0.48458 161639.9n 0.48458 161640.0n 0.13226 161819.9n 0.13226 161820.0n -0.23386 161999.9n -0.23386 162000.0n 1.27694 162179.9n 1.27694 162180.0n 0.42554 162359.9n 0.42554 162360.0n -0.37792 162539.9n -0.37792 162540.0n 1.23180 162719.9n 1.23180 162720.0n 0.25911 162899.9n 0.25911 162900.0n -0.08309 163079.9n -0.08309 163080.0n -0.33158 163259.9n -0.33158 163260.0n 0.34013 163439.9n 0.34013 163440.0n 0.29915 163619.9n 0.29915 163620.0n -0.21828 163799.9n -0.21828 163800.0n 0.70122 163979.9n 0.70122 163980.0n -0.15161 164159.9n -0.15161 164160.0n 1.18224 164339.9n 1.18224 164340.0n 1.11225 164519.9n 1.11225 164520.0n 0.28700 164699.9n 0.28700 164700.0n 0.63482 164879.9n 0.63482 164880.0n 0.23835 165059.9n 0.23835 165060.0n 0.76415 165239.9n 0.76415 165240.0n 0.59247 165419.9n 0.59247 165420.0n 0.28189 165599.9n 0.28189 165600.0n 1.20712 165779.9n 1.20712 165780.0n 0.40313 165959.9n 0.40313 165960.0n 0.65842 166139.9n 0.65842 166140.0n 1.28574 166319.9n 1.28574 166320.0n 1.17517 166499.9n 1.17517 166500.0n 0.66096 166679.9n 0.66096 166680.0n 0.67130 166859.9n 0.67130 166860.0n 0.56595 167039.9n 0.56595 167040.0n -0.23386 167219.9n -0.23386 167220.0n 0.66096 167399.9n 0.66096 167400.0n 1.27694 167579.9n 1.27694 167580.0n 0.13226 167759.9n 0.13226 167760.0n 1.11225 167939.9n 1.11225 167940.0n -0.37792 168119.9n -0.37792 168120.0n 0.70122 168299.9n 0.70122 168300.0n 0.63482 168479.9n 0.63482 168480.0n 0.59247 168659.9n 0.59247 168660.0n 0.34013 168839.9n 0.34013 168840.0n -0.33158 169019.9n -0.33158 169020.0n 0.42554 169199.9n 0.42554 169200.0n 0.48458 169379.9n 0.48458 169380.0n -0.15161 169559.9n -0.15161 169560.0n 1.28574 169739.9n 1.28574 169740.0n 1.20712 169919.9n 1.20712 169920.0n 0.25911 170099.9n 0.25911 170100.0n -0.08309 170279.9n -0.08309 170280.0n 0.33171 170459.9n 0.33171 170460.0n 1.17517 170639.9n 1.17517 170640.0n 1.18224 170819.9n 1.18224 170820.0n 0.65842 170999.9n 0.65842 171000.0n 0.67130 171179.9n 0.67130 171180.0n 1.23180 171359.9n 1.23180 171360.0n 0.23835 171539.9n 0.23835 171540.0n 0.29915 171719.9n 0.29915 171720.0n 0.28189 171899.9n 0.28189 171900.0n 0.76415 172079.9n 0.76415 172080.0n 0.40313 172259.9n 0.40313 172260.0n -0.21828 172439.9n -0.21828 172440.0n 0.28700 172619.9n 0.28700 172620.0n 0.56595 172799.9n 0.56595 172800.0n 0.36576 172979.9n 0.36576 172980.0n 0.33730 173159.9n 0.33730 173160.0n 0.38385 173339.9n 0.38385 173340.0n 0.59706 173519.9n 0.59706 173520.0n 0.62307 173699.9n 0.62307 173700.0n 0.67018 173879.9n 0.67018 173880.0n 0.70540 174059.9n 0.70540 174060.0n 0.53582 174239.9n 0.53582 174240.0n 0.33357 174419.9n 0.33357 174420.0n 0.52885 174599.9n 0.52885 174600.0n 0.74383 174779.9n 0.74383 174780.0n 0.78409 174959.9n 0.78409 174960.0n 0.51936 175139.9n 0.51936 175140.0n 0.50532 175319.9n 0.50532 175320.0n 0.68189 175499.9n 0.68189 175500.0n 0.79862 175679.9n 0.79862 175680.0n 0.35050 175859.9n 0.35050 175860.0n 0.16858 176039.9n 0.16858 176040.0n 0.55253 176219.9n 0.55253 176220.0n 0.60823 176399.9n 0.60823 176400.0n 0.63611 176579.9n 0.63611 176580.0n 0.41197 176759.9n 0.41197 176760.0n 0.69413 176939.9n 0.69413 176940.0n 0.58457 177119.9n 0.58457 177120.0n 0.33751 177299.9n 0.33751 177300.0n 0.71381 177479.9n 0.71381 177480.0n 0.64266 177659.9n 0.64266 177660.0n 0.16018 177839.9n 0.16018 177840.0n 0.78157 178019.9n 0.78157 178020.0n 0.22203 178199.9n 0.22203 178200.0n 0.87402 178379.9n 0.87402 178380.0n -0.10545 178559.9n -0.10545 178560.0n -0.25282 178739.9n -0.25282 178740.0n -0.37666 178919.9n -0.37666 178920.0n 1.43391 179099.9n 1.43391 179100.0n 0.37511 179279.9n 0.37511 179280.0n 0.35780 179459.9n 0.35780 179460.0n 1.04281 179639.9n 1.04281 179640.0n 1.30757 179819.9n 1.30757 179820.0n -0.27950 179999.9n -0.27950 180000.0n 0.10137 180179.9n 0.10137 180180.0n 1.20727 180359.9n 1.20727 180360.0n 1.40210 180539.9n 1.40210 180540.0n 1.03003 180719.9n 1.03003 180720.0n -0.27250 180899.9n -0.27250 180900.0n -0.24444 181079.9n -0.24444 181080.0n 0.81835 181259.9n 0.81835 181260.0n 0.11792 181439.9n 0.11792 181440.0n -0.41822 181619.9n -0.41822 181620.0n 0.75242 181799.9n 0.75242 181800.0n 0.57354 181979.9n 0.57354 181980.0n 1.22124 182159.9n 1.22124 182160.0n 1.07258 182339.9n 1.07258 182340.0n 1.14286 182519.9n 1.14286 182520.0n -0.14226 182699.9n -0.14226 182700.0n 1.32817 182879.9n 1.32817 182880.0n 1.08864 183059.9n 1.08864 183060.0n 1.09055 183239.9n 1.09055 183240.0n 1.50665 183419.9n 1.50665 183420.0n -0.21520)
Vxn1 a_xn1 0 PWL(0.0n 0.71300 179.9n 0.71300 180.0n 1.37792 359.9n 1.37792 360.0n 0.71811 539.9n 0.71811 540.0n -0.18224 719.9n -0.18224 720.0n 0.86774 899.9n 0.86774 900.0n 0.40753 1079.9n 0.40753 1080.0n 0.57446 1259.9n 0.57446 1260.0n 0.23585 1439.9n 0.23585 1440.0n 0.76165 1619.9n 0.76165 1620.0n 1.15161 1799.9n 1.15161 1800.0n -0.28574 1979.9n -0.28574 1980.0n 0.29878 2159.9n 0.29878 2160.0n 0.33904 2339.9n 0.33904 2340.0n 0.65987 2519.9n 0.65987 2520.0n 1.33158 2699.9n 1.33158 2700.0n 0.59687 2879.9n 0.59687 2880.0n 0.51542 3059.9n 0.51542 3060.0n -0.27694 3239.9n -0.27694 3240.0n 1.23386 3419.9n 1.23386 3420.0n -0.23180 3599.9n -0.23180 3600.0n 0.34158 3779.9n 0.34158 3780.0n -0.20712 3959.9n -0.20712 3960.0n -0.11225 4139.9n -0.11225 4140.0n 0.43405 4319.9n 0.43405 4320.0n 0.32870 4499.9n 0.32870 4500.0n 1.08309 4679.9n 1.08309 4680.0n 0.70085 4859.9n 0.70085 4860.0n 0.66829 5039.9n 0.66829 5040.0n 0.36518 5219.9n 0.36518 5220.0n 0.74089 5399.9n 0.74089 5400.0n 1.21828 5579.9n 1.21828 5580.0n -0.17517 5759.9n -0.17517 5760.0n -0.11225 5939.9n -0.11225 5940.0n 0.40753 6119.9n 0.40753 6120.0n 1.33158 6299.9n 1.33158 6300.0n 0.43405 6479.9n 0.43405 6480.0n 0.65987 6659.9n 0.65987 6660.0n -0.27694 6839.9n -0.27694 6840.0n -0.23180 7019.9n -0.23180 7020.0n 0.57446 7199.9n 0.57446 7200.0n 0.59687 7379.9n 0.59687 7380.0n 0.23585 7559.9n 0.23585 7560.0n 1.08309 7739.9n 1.08309 7740.0n 1.21828 7919.9n 1.21828 7920.0n 0.86774 8099.9n 0.86774 8100.0n 0.29878 8279.9n 0.29878 8280.0n 1.23386 8459.9n 1.23386 8460.0n 0.32870 8639.9n 0.32870 8640.0n 1.37792 8819.9n 1.37792 8820.0n 0.70085 8999.9n 0.70085 9000.0n 0.34158 9179.9n 0.34158 9180.0n 0.74089 9359.9n 0.74089 9360.0n 0.66829 9539.9n 0.66829 9540.0n 0.36518 9719.9n 0.36518 9720.0n -0.17517 9899.9n -0.17517 9900.0n 1.15161 10079.9n 1.15161 10080.0n -0.28574 10259.9n -0.28574 10260.0n 0.71811 10439.9n 0.71811 10440.0n 0.51542 10619.9n 0.51542 10620.0n -0.20712 10799.9n -0.20712 10800.0n 0.33904 10979.9n 0.33904 10980.0n 0.76165 11159.9n 0.76165 11160.0n -0.18224 11339.9n -0.18224 11340.0n 0.71300 11519.9n 0.71300 11520.0n -0.17517 11699.9n -0.17517 11700.0n 0.59687 11879.9n 0.59687 11880.0n 0.76165 12059.9n 0.76165 12060.0n 0.32870 12239.9n 0.32870 12240.0n -0.28574 12419.9n -0.28574 12420.0n -0.20712 12599.9n -0.20712 12600.0n 0.23585 12779.9n 0.23585 12780.0n 0.71300 12959.9n 0.71300 12960.0n -0.27694 13139.9n -0.27694 13140.0n 0.71811 13319.9n 0.71811 13320.0n -0.23180 13499.9n -0.23180 13500.0n 0.34158 13679.9n 0.34158 13680.0n 0.65987 13859.9n 0.65987 13860.0n 0.74089 14039.9n 0.74089 14040.0n 0.57446 14219.9n 0.57446 14220.0n 1.08309 14399.9n 1.08309 14400.0n 0.43405 14579.9n 0.43405 14580.0n 0.66829 14759.9n 0.66829 14760.0n -0.18224 14939.9n -0.18224 14940.0n 1.21828 15119.9n 1.21828 15120.0n 1.33158 15299.9n 1.33158 15300.0n 0.51542 15479.9n 0.51542 15480.0n 0.29878 15659.9n 0.29878 15660.0n 1.37792 15839.9n 1.37792 15840.0n 1.23386 16019.9n 1.23386 16020.0n 0.33904 16199.9n 0.33904 16200.0n -0.11225 16379.9n -0.11225 16380.0n 0.36518 16559.9n 0.36518 16560.0n 0.70085 16739.9n 0.70085 16740.0n 0.86774 16919.9n 0.86774 16920.0n 1.15161 17099.9n 1.15161 17100.0n 0.40753 17279.9n 0.40753 17280.0n 1.21828 17459.9n 1.21828 17460.0n 0.36518 17639.9n 0.36518 17640.0n 0.74089 17819.9n 0.74089 17820.0n 1.23386 17999.9n 1.23386 18000.0n 0.71811 18179.9n 0.71811 18180.0n 0.71300 18359.9n 0.71300 18360.0n -0.20712 18539.9n -0.20712 18540.0n 0.23585 18719.9n 0.23585 18720.0n 0.66829 18899.9n 0.66829 18900.0n 0.51542 19079.9n 0.51542 19080.0n 0.34158 19259.9n 0.34158 19260.0n 0.29878 19439.9n 0.29878 19440.0n 0.57446 19619.9n 0.57446 19620.0n -0.27694 19799.9n -0.27694 19800.0n 1.08309 19979.9n 1.08309 19980.0n 0.32870 20159.9n 0.32870 20160.0n -0.18224 20339.9n -0.18224 20340.0n 0.43405 20519.9n 0.43405 20520.0n 0.65987 20699.9n 0.65987 20700.0n 1.37792 20879.9n 1.37792 20880.0n -0.11225 21059.9n -0.11225 21060.0n 0.70085 21239.9n 0.70085 21240.0n 0.59687 21419.9n 0.59687 21420.0n -0.28574 21599.9n -0.28574 21600.0n 0.86774 21779.9n 0.86774 21780.0n 0.40753 21959.9n 0.40753 21960.0n -0.17517 22139.9n -0.17517 22140.0n -0.23180 22319.9n -0.23180 22320.0n 0.33904 22499.9n 0.33904 22500.0n 1.15161 22679.9n 1.15161 22680.0n 0.76165 22859.9n 0.76165 22860.0n 1.33158 23039.9n 1.33158 23040.0n 0.32870 23219.9n 0.32870 23220.0n 0.59687 23399.9n 0.59687 23400.0n 0.33904 23579.9n 0.33904 23580.0n 1.23386 23759.9n 1.23386 23760.0n 0.70085 23939.9n 0.70085 23940.0n 0.74089 24119.9n 0.74089 24120.0n 0.57446 24299.9n 0.57446 24300.0n -0.20712 24479.9n -0.20712 24480.0n 0.66829 24659.9n 0.66829 24660.0n 0.71811 24839.9n 0.71811 24840.0n 0.34158 25019.9n 0.34158 25020.0n 0.23585 25199.9n 0.23585 25200.0n -0.28574 25379.9n -0.28574 25380.0n -0.27694 25559.9n -0.27694 25560.0n 0.86774 25739.9n 0.86774 25740.0n 0.76165 25919.9n 0.76165 25920.0n 0.43405 26099.9n 0.43405 26100.0n 0.51542 26279.9n 0.51542 26280.0n 1.08309 26459.9n 1.08309 26460.0n -0.18224 26639.9n -0.18224 26640.0n -0.23180 26819.9n -0.23180 26820.0n 0.29878 26999.9n 0.29878 27000.0n 0.36518 27179.9n 0.36518 27180.0n 0.65987 27359.9n 0.65987 27360.0n 1.21828 27539.9n 1.21828 27540.0n 0.71300 27719.9n 0.71300 27720.0n 1.37792 27899.9n 1.37792 27900.0n -0.17517 28079.9n -0.17517 28080.0n -0.11225 28259.9n -0.11225 28260.0n 0.40753 28439.9n 0.40753 28440.0n 1.33158 28619.9n 1.33158 28620.0n 1.15161 28799.9n 1.15161 28800.0n -0.20712 28979.9n -0.20712 28980.0n 0.29878 29159.9n 0.29878 29160.0n 0.51542 29339.9n 0.51542 29340.0n 0.59687 29519.9n 0.59687 29520.0n 1.15161 29699.9n 1.15161 29700.0n 0.65987 29879.9n 0.65987 29880.0n 1.37792 30059.9n 1.37792 30060.0n -0.27694 30239.9n -0.27694 30240.0n -0.18224 30419.9n -0.18224 30420.0n 0.71811 30599.9n 0.71811 30600.0n 0.70085 30779.9n 0.70085 30780.0n 0.36518 30959.9n 0.36518 30960.0n 1.23386 31139.9n 1.23386 31140.0n 1.33158 31319.9n 1.33158 31320.0n 0.23585 31499.9n 0.23585 31500.0n -0.17517 31679.9n -0.17517 31680.0n 0.76165 31859.9n 0.76165 31860.0n 1.08309 32039.9n 1.08309 32040.0n 0.71300 32219.9n 0.71300 32220.0n 0.32870 32399.9n 0.32870 32400.0n 0.66829 32579.9n 0.66829 32580.0n 0.34158 32759.9n 0.34158 32760.0n 0.74089 32939.9n 0.74089 32940.0n 0.57446 33119.9n 0.57446 33120.0n 0.33904 33299.9n 0.33904 33300.0n -0.11225 33479.9n -0.11225 33480.0n -0.23180 33659.9n -0.23180 33660.0n -0.28574 33839.9n -0.28574 33840.0n 0.86774 34019.9n 0.86774 34020.0n 0.43405 34199.9n 0.43405 34200.0n 0.40753 34379.9n 0.40753 34380.0n 1.21828 34559.9n 1.21828 34560.0n 0.51542 34739.9n 0.51542 34740.0n 0.66829 34919.9n 0.66829 34920.0n -0.11225 35099.9n -0.11225 35100.0n 0.71300 35279.9n 0.71300 35280.0n -0.28574 35459.9n -0.28574 35460.0n -0.23180 35639.9n -0.23180 35640.0n 0.65987 35819.9n 0.65987 35820.0n 0.23585 35999.9n 0.23585 36000.0n 0.29878 36179.9n 0.29878 36180.0n 0.76165 36359.9n 0.76165 36360.0n 0.33904 36539.9n 0.33904 36540.0n 0.43405 36719.9n 0.43405 36720.0n 0.71811 36899.9n 0.71811 36900.0n 0.74089 37079.9n 0.74089 37080.0n -0.17517 37259.9n -0.17517 37260.0n 0.59687 37439.9n 0.59687 37440.0n 0.40753 37619.9n 0.40753 37620.0n -0.27694 37799.9n -0.27694 37800.0n 1.15161 37979.9n 1.15161 37980.0n -0.20712 38159.9n -0.20712 38160.0n 0.36518 38339.9n 0.36518 38340.0n 0.32870 38519.9n 0.32870 38520.0n 1.37792 38699.9n 1.37792 38700.0n 0.34158 38879.9n 0.34158 38880.0n 0.86774 39059.9n 0.86774 39060.0n 0.57446 39239.9n 0.57446 39240.0n 1.23386 39419.9n 1.23386 39420.0n 0.70085 39599.9n 0.70085 39600.0n 1.08309 39779.9n 1.08309 39780.0n 1.21828 39959.9n 1.21828 39960.0n -0.18224 40139.9n -0.18224 40140.0n 1.33158 40319.9n 1.33158 40320.0n 0.74089 40499.9n 0.74089 40500.0n 0.23585 40679.9n 0.23585 40680.0n -0.28574 40859.9n -0.28574 40860.0n -0.11225 41039.9n -0.11225 41040.0n 1.15161 41219.9n 1.15161 41220.0n 0.66829 41399.9n 0.66829 41400.0n 0.34158 41579.9n 0.34158 41580.0n -0.20712 41759.9n -0.20712 41760.0n 1.08309 41939.9n 1.08309 41940.0n 1.37792 42119.9n 1.37792 42120.0n 0.57446 42299.9n 0.57446 42300.0n -0.23180 42479.9n -0.23180 42480.0n 0.29878 42659.9n 0.29878 42660.0n 0.71811 42839.9n 0.71811 42840.0n 0.59687 43019.9n 0.59687 43020.0n 0.51542 43199.9n 0.51542 43200.0n -0.18224 43379.9n -0.18224 43380.0n 0.70085 43559.9n 0.70085 43560.0n 0.32870 43739.9n 0.32870 43740.0n -0.17517 43919.9n -0.17517 43920.0n 0.65987 44099.9n 0.65987 44100.0n 0.71300 44279.9n 0.71300 44280.0n -0.27694 44459.9n -0.27694 44460.0n 1.21828 44639.9n 1.21828 44640.0n 0.33904 44819.9n 0.33904 44820.0n 0.86774 44999.9n 0.86774 45000.0n 0.76165 45179.9n 0.76165 45180.0n 0.36518 45359.9n 0.36518 45360.0n 0.40753 45539.9n 0.40753 45540.0n 0.43405 45719.9n 0.43405 45720.0n 1.23386 45899.9n 1.23386 45900.0n 1.33158 46079.9n 1.33158 46080.0n 0.65987 46259.9n 0.65987 46260.0n 0.59687 46439.9n 0.59687 46440.0n 0.66829 46619.9n 0.66829 46620.0n 1.08309 46799.9n 1.08309 46800.0n 0.76165 46979.9n 0.76165 46980.0n 0.40753 47159.9n 0.40753 47160.0n 1.37792 47339.9n 1.37792 47340.0n 0.34158 47519.9n 0.34158 47520.0n 0.70085 47699.9n 0.70085 47700.0n 0.43405 47879.9n 0.43405 47880.0n 0.71811 48059.9n 0.71811 48060.0n -0.17517 48239.9n -0.17517 48240.0n 1.23386 48419.9n 1.23386 48420.0n 1.33158 48599.9n 1.33158 48600.0n 1.21828 48779.9n 1.21828 48780.0n 0.33904 48959.9n 0.33904 48960.0n -0.18224 49139.9n -0.18224 49140.0n 1.15161 49319.9n 1.15161 49320.0n -0.28574 49499.9n -0.28574 49500.0n 0.71300 49679.9n 0.71300 49680.0n 0.57446 49859.9n 0.57446 49860.0n 0.36518 50039.9n 0.36518 50040.0n 0.29878 50219.9n 0.29878 50220.0n 0.32870 50399.9n 0.32870 50400.0n 0.74089 50579.9n 0.74089 50580.0n 0.86774 50759.9n 0.86774 50760.0n -0.20712 50939.9n -0.20712 50940.0n -0.23180 51119.9n -0.23180 51120.0n -0.11225 51299.9n -0.11225 51300.0n 0.23585 51479.9n 0.23585 51480.0n -0.27694 51659.9n -0.27694 51660.0n 0.51542 51839.9n 0.51542 51840.0n 1.21828 52019.9n 1.21828 52020.0n 1.08309 52199.9n 1.08309 52200.0n 0.70085 52379.9n 0.70085 52380.0n 0.34158 52559.9n 0.34158 52560.0n -0.20712 52739.9n -0.20712 52740.0n 0.32870 52919.9n 0.32870 52920.0n 0.57446 53099.9n 0.57446 53100.0n 1.23386 53279.9n 1.23386 53280.0n 1.33158 53459.9n 1.33158 53460.0n -0.27694 53639.9n -0.27694 53640.0n -0.17517 53819.9n -0.17517 53820.0n 0.71300 53999.9n 0.71300 54000.0n 1.15161 54179.9n 1.15161 54180.0n 0.66829 54359.9n 0.66829 54360.0n 1.37792 54539.9n 1.37792 54540.0n 0.36518 54719.9n 0.36518 54720.0n 0.65987 54899.9n 0.65987 54900.0n 0.51542 55079.9n 0.51542 55080.0n 0.33904 55259.9n 0.33904 55260.0n 0.59687 55439.9n 0.59687 55440.0n 0.74089 55619.9n 0.74089 55620.0n 0.29878 55799.9n 0.29878 55800.0n -0.28574 55979.9n -0.28574 55980.0n 0.86774 56159.9n 0.86774 56160.0n -0.11225 56339.9n -0.11225 56340.0n 0.40753 56519.9n 0.40753 56520.0n 0.76165 56699.9n 0.76165 56700.0n 0.23585 56879.9n 0.23585 56880.0n 0.71811 57059.9n 0.71811 57060.0n -0.23180 57239.9n -0.23180 57240.0n -0.18224 57419.9n -0.18224 57420.0n 0.43405 57599.9n 0.43405 57600.0n 0.71811 57779.9n 0.71811 57780.0n 0.66829 57959.9n 0.66829 57960.0n -0.27694 58139.9n -0.27694 58140.0n 0.36518 58319.9n 0.36518 58320.0n 0.65987 58499.9n 0.65987 58500.0n 1.15161 58679.9n 1.15161 58680.0n 0.34158 58859.9n 0.34158 58860.0n 1.37792 59039.9n 1.37792 59040.0n 0.43405 59219.9n 0.43405 59220.0n -0.23180 59399.9n -0.23180 59400.0n 1.21828 59579.9n 1.21828 59580.0n -0.20712 59759.9n -0.20712 59760.0n 0.40753 59939.9n 0.40753 59940.0n 0.51542 60119.9n 0.51542 60120.0n -0.28574 60299.9n -0.28574 60300.0n 1.33158 60479.9n 1.33158 60480.0n 0.59687 60659.9n 0.59687 60660.0n 0.70085 60839.9n 0.70085 60840.0n 0.57446 61019.9n 0.57446 61020.0n 0.76165 61199.9n 0.76165 61200.0n -0.11225 61379.9n -0.11225 61380.0n 1.08309 61559.9n 1.08309 61560.0n 1.23386 61739.9n 1.23386 61740.0n 0.74089 61919.9n 0.74089 61920.0n 0.23585 62099.9n 0.23585 62100.0n -0.17517 62279.9n -0.17517 62280.0n 0.33904 62459.9n 0.33904 62460.0n 0.86774 62639.9n 0.86774 62640.0n 0.29878 62819.9n 0.29878 62820.0n 0.71300 62999.9n 0.71300 63000.0n -0.18224 63179.9n -0.18224 63180.0n 0.32870 63359.9n 0.32870 63360.0n 1.23386 63539.9n 1.23386 63540.0n 0.57446 63719.9n 0.57446 63720.0n 0.36518 63899.9n 0.36518 63900.0n 0.59687 64079.9n 0.59687 64080.0n 0.74089 64259.9n 0.74089 64260.0n -0.17517 64439.9n -0.17517 64440.0n -0.11225 64619.9n -0.11225 64620.0n -0.27694 64799.9n -0.27694 64800.0n -0.18224 64979.9n -0.18224 64980.0n 1.08309 65159.9n 1.08309 65160.0n 0.33904 65339.9n 0.33904 65340.0n 0.51542 65519.9n 0.51542 65520.0n 0.71811 65699.9n 0.71811 65700.0n 0.76165 65879.9n 0.76165 65880.0n 0.40753 66059.9n 0.40753 66060.0n 1.37792 66239.9n 1.37792 66240.0n 0.71300 66419.9n 0.71300 66420.0n 0.29878 66599.9n 0.29878 66600.0n 0.43405 66779.9n 0.43405 66780.0n -0.28574 66959.9n -0.28574 66960.0n 1.33158 67139.9n 1.33158 67140.0n 0.34158 67319.9n 0.34158 67320.0n 0.66829 67499.9n 0.66829 67500.0n 0.86774 67679.9n 0.86774 67680.0n 1.15161 67859.9n 1.15161 67860.0n 0.23585 68039.9n 0.23585 68040.0n 0.70085 68219.9n 0.70085 68220.0n 1.21828 68399.9n 1.21828 68400.0n -0.23180 68579.9n -0.23180 68580.0n 0.65987 68759.9n 0.65987 68760.0n 0.32870 68939.9n 0.32870 68940.0n -0.20712 69119.9n -0.20712 69120.0n 1.37792 69299.9n 1.37792 69300.0n 0.29878 69479.9n 0.29878 69480.0n 0.32870 69659.9n 0.32870 69660.0n 0.33904 69839.9n 0.33904 69840.0n 0.23585 70019.9n 0.23585 70020.0n 0.34158 70199.9n 0.34158 70200.0n 0.57446 70379.9n 0.57446 70380.0n 0.71811 70559.9n 0.71811 70560.0n 0.71300 70739.9n 0.71300 70740.0n -0.23180 70919.9n -0.23180 70920.0n 0.66829 71099.9n 0.66829 71100.0n 0.59687 71279.9n 0.59687 71280.0n 0.74089 71459.9n 0.74089 71460.0n -0.20712 71639.9n -0.20712 71640.0n -0.27694 71819.9n -0.27694 71820.0n 0.43405 71999.9n 0.43405 72000.0n 1.33158 72179.9n 1.33158 72180.0n -0.11225 72359.9n -0.11225 72360.0n 0.40753 72539.9n 0.40753 72540.0n 0.76165 72719.9n 0.76165 72720.0n 1.15161 72899.9n 1.15161 72900.0n -0.18224 73079.9n -0.18224 73080.0n -0.17517 73259.9n -0.17517 73260.0n 0.36518 73439.9n 0.36518 73440.0n 0.86774 73619.9n 0.86774 73620.0n 1.23386 73799.9n 1.23386 73800.0n 0.65987 73979.9n 0.65987 73980.0n 0.70085 74159.9n 0.70085 74160.0n 1.21828 74339.9n 1.21828 74340.0n -0.28574 74519.9n -0.28574 74520.0n 1.08309 74699.9n 1.08309 74700.0n 0.51542 74879.9n 0.51542 74880.0n 0.86774 75059.9n 0.86774 75060.0n 1.08309 75239.9n 1.08309 75240.0n 1.23386 75419.9n 1.23386 75420.0n 0.23585 75599.9n 0.23585 75600.0n 0.36518 75779.9n 0.36518 75780.0n 0.74089 75959.9n 0.74089 75960.0n 1.37792 76139.9n 1.37792 76140.0n 0.40753 76319.9n 0.40753 76320.0n 0.65987 76499.9n 0.65987 76500.0n 0.57446 76679.9n 0.57446 76680.0n 0.71811 76859.9n 0.71811 76860.0n 0.76165 77039.9n 0.76165 77040.0n 0.59687 77219.9n 0.59687 77220.0n -0.20712 77399.9n -0.20712 77400.0n -0.27694 77579.9n -0.27694 77580.0n -0.18224 77759.9n -0.18224 77760.0n 0.43405 77939.9n 0.43405 77940.0n 0.32870 78119.9n 0.32870 78120.0n 1.33158 78299.9n 1.33158 78300.0n -0.23180 78479.9n -0.23180 78480.0n 0.70085 78659.9n 0.70085 78660.0n 0.71300 78839.9n 0.71300 78840.0n -0.28574 79019.9n -0.28574 79020.0n 0.66829 79199.9n 0.66829 79200.0n 0.29878 79379.9n 0.29878 79380.0n 0.34158 79559.9n 0.34158 79560.0n 0.33904 79739.9n 0.33904 79740.0n 1.15161 79919.9n 1.15161 79920.0n -0.11225 80099.9n -0.11225 80100.0n 1.21828 80279.9n 1.21828 80280.0n 0.51542 80459.9n 0.51542 80460.0n -0.17517 80639.9n -0.17517 80640.0n -0.27694 80819.9n -0.27694 80820.0n 0.40753 80999.9n 0.40753 81000.0n -0.23180 81179.9n -0.23180 81180.0n 0.29878 81359.9n 0.29878 81360.0n -0.18224 81539.9n -0.18224 81540.0n 0.86774 81719.9n 0.86774 81720.0n 1.21828 81899.9n 1.21828 81900.0n 1.15161 82079.9n 1.15161 82080.0n 0.33904 82259.9n 0.33904 82260.0n -0.17517 82439.9n -0.17517 82440.0n 0.70085 82619.9n 0.70085 82620.0n 0.66829 82799.9n 0.66829 82800.0n 0.36518 82979.9n 0.36518 82980.0n 0.51542 83159.9n 0.51542 83160.0n 1.23386 83339.9n 1.23386 83340.0n 0.57446 83519.9n 0.57446 83520.0n 0.59687 83699.9n 0.59687 83700.0n -0.11225 83879.9n -0.11225 83880.0n 1.08309 84059.9n 1.08309 84060.0n 0.43405 84239.9n 0.43405 84240.0n 0.34158 84419.9n 0.34158 84420.0n 0.74089 84599.9n 0.74089 84600.0n 0.32870 84779.9n 0.32870 84780.0n 1.37792 84959.9n 1.37792 84960.0n 0.76165 85139.9n 0.76165 85140.0n 0.23585 85319.9n 0.23585 85320.0n -0.20712 85499.9n -0.20712 85500.0n 0.71300 85679.9n 0.71300 85680.0n -0.28574 85859.9n -0.28574 85860.0n 0.65987 86039.9n 0.65987 86040.0n 1.33158 86219.9n 1.33158 86220.0n 0.71811 86399.9n 0.71811 86400.0n 1.33158 86579.9n 1.33158 86580.0n 0.70085 86759.9n 0.70085 86760.0n 0.74089 86939.9n 0.74089 86940.0n 0.66829 87119.9n 0.66829 87120.0n -0.28574 87299.9n -0.28574 87300.0n -0.11225 87479.9n -0.11225 87480.0n -0.27694 87659.9n -0.27694 87660.0n 0.51542 87839.9n 0.51542 87840.0n 0.33904 88019.9n 0.33904 88020.0n 1.08309 88199.9n 1.08309 88200.0n -0.17517 88379.9n -0.17517 88380.0n 0.76165 88559.9n 0.76165 88560.0n 1.15161 88739.9n 1.15161 88740.0n 0.23585 88919.9n 0.23585 88920.0n 0.43405 89099.9n 0.43405 89100.0n 0.65987 89279.9n 0.65987 89280.0n 0.57446 89459.9n 0.57446 89460.0n 0.34158 89639.9n 0.34158 89640.0n 0.36518 89819.9n 0.36518 89820.0n 1.21828 89999.9n 1.21828 90000.0n 1.23386 90179.9n 1.23386 90180.0n -0.23180 90359.9n -0.23180 90360.0n 0.32870 90539.9n 0.32870 90540.0n 0.59687 90719.9n 0.59687 90720.0n 0.29878 90899.9n 0.29878 90900.0n -0.20712 91079.9n -0.20712 91080.0n 0.86774 91259.9n 0.86774 91260.0n 0.40753 91439.9n 0.40753 91440.0n 0.71811 91619.9n 0.71811 91620.0n 1.37792 91799.9n 1.37792 91800.0n 0.71300 91979.9n 0.71300 91980.0n -0.18224 92159.9n -0.18224 92160.0n 0.40753 92339.9n 0.40753 92340.0n 1.33158 92519.9n 1.33158 92520.0n -0.11225 92699.9n -0.11225 92700.0n 1.37792 92879.9n 1.37792 92880.0n 1.23386 93059.9n 1.23386 93060.0n 1.21828 93239.9n 1.21828 93240.0n -0.28574 93419.9n -0.28574 93420.0n -0.17517 93599.9n -0.17517 93600.0n 1.15161 93779.9n 1.15161 93780.0n 0.29878 93959.9n 0.29878 93960.0n 0.76165 94139.9n 0.76165 94140.0n -0.20712 94319.9n -0.20712 94320.0n 0.70085 94499.9n 0.70085 94500.0n 0.71811 94679.9n 0.71811 94680.0n 0.86774 94859.9n 0.86774 94860.0n -0.23180 95039.9n -0.23180 95040.0n 0.74089 95219.9n 0.74089 95220.0n 0.32870 95399.9n 0.32870 95400.0n 0.66829 95579.9n 0.66829 95580.0n -0.18224 95759.9n -0.18224 95760.0n -0.27694 95939.9n -0.27694 95940.0n 0.65987 96119.9n 0.65987 96120.0n 0.36518 96299.9n 0.36518 96300.0n 0.23585 96479.9n 0.23585 96480.0n 1.08309 96659.9n 1.08309 96660.0n 0.59687 96839.9n 0.59687 96840.0n 0.51542 97019.9n 0.51542 97020.0n 0.43405 97199.9n 0.43405 97200.0n 0.71300 97379.9n 0.71300 97380.0n 0.57446 97559.9n 0.57446 97560.0n 0.33904 97739.9n 0.33904 97740.0n 0.34158 97919.9n 0.34158 97920.0n -0.27694 98099.9n -0.27694 98100.0n 1.37792 98279.9n 1.37792 98280.0n 1.21828 98459.9n 1.21828 98460.0n 0.71300 98639.9n 0.71300 98640.0n 0.66829 98819.9n 0.66829 98820.0n 0.36518 98999.9n 0.36518 99000.0n 0.71811 99179.9n 0.71811 99180.0n 0.74089 99359.9n 0.74089 99360.0n -0.20712 99539.9n -0.20712 99540.0n -0.18224 99719.9n -0.18224 99720.0n 0.43405 99899.9n 0.43405 99900.0n -0.11225 100079.9n -0.11225 100080.0n 0.34158 100259.9n 0.34158 100260.0n 1.33158 100439.9n 1.33158 100440.0n 0.76165 100619.9n 0.76165 100620.0n 0.40753 100799.9n 0.40753 100800.0n 1.08309 100979.9n 1.08309 100980.0n 0.32870 101159.9n 0.32870 101160.0n 0.51542 101339.9n 0.51542 101340.0n -0.23180 101519.9n -0.23180 101520.0n 0.33904 101699.9n 0.33904 101700.0n 0.70085 101879.9n 0.70085 101880.0n 0.29878 102059.9n 0.29878 102060.0n 1.23386 102239.9n 1.23386 102240.0n 1.15161 102419.9n 1.15161 102420.0n -0.28574 102599.9n -0.28574 102600.0n 0.65987 102779.9n 0.65987 102780.0n 0.86774 102959.9n 0.86774 102960.0n 0.23585 103139.9n 0.23585 103140.0n 0.57446 103319.9n 0.57446 103320.0n 0.59687 103499.9n 0.59687 103500.0n -0.17517 103679.9n -0.17517 103680.0n -0.20712 103859.9n -0.20712 103860.0n -0.11225 104039.9n -0.11225 104040.0n 0.71811 104219.9n 0.71811 104220.0n -0.18224 104399.9n -0.18224 104400.0n -0.28574 104579.9n -0.28574 104580.0n 1.33158 104759.9n 1.33158 104760.0n 0.43405 104939.9n 0.43405 104940.0n -0.27694 105119.9n -0.27694 105120.0n 1.21828 105299.9n 1.21828 105300.0n 0.32870 105479.9n 0.32870 105480.0n 0.74089 105659.9n 0.74089 105660.0n 0.40753 105839.9n 0.40753 105840.0n 0.70085 106019.9n 0.70085 106020.0n 0.36518 106199.9n 0.36518 106200.0n 0.66829 106379.9n 0.66829 106380.0n 0.34158 106559.9n 0.34158 106560.0n 0.76165 106739.9n 0.76165 106740.0n 0.33904 106919.9n 0.33904 106920.0n -0.17517 107099.9n -0.17517 107100.0n 1.23386 107279.9n 1.23386 107280.0n 0.51542 107459.9n 0.51542 107460.0n -0.23180 107639.9n -0.23180 107640.0n 0.57446 107819.9n 0.57446 107820.0n 0.29878 107999.9n 0.29878 108000.0n 1.15161 108179.9n 1.15161 108180.0n 0.86774 108359.9n 0.86774 108360.0n 0.71300 108539.9n 0.71300 108540.0n 0.23585 108719.9n 0.23585 108720.0n 1.08309 108899.9n 1.08309 108900.0n 0.65987 109079.9n 0.65987 109080.0n 0.59687 109259.9n 0.59687 109260.0n 1.37792 109439.9n 1.37792 109440.0n -0.17517 109619.9n -0.17517 109620.0n 1.21828 109799.9n 1.21828 109800.0n 0.70085 109979.9n 0.70085 109980.0n 0.57446 110159.9n 0.57446 110160.0n 1.37792 110339.9n 1.37792 110340.0n 0.43405 110519.9n 0.43405 110520.0n 1.23386 110699.9n 1.23386 110700.0n -0.23180 110879.9n -0.23180 110880.0n 0.71811 111059.9n 0.71811 111060.0n 0.65987 111239.9n 0.65987 111240.0n -0.20712 111419.9n -0.20712 111420.0n 0.40753 111599.9n 0.40753 111600.0n 0.36518 111779.9n 0.36518 111780.0n 0.71300 111959.9n 0.71300 111960.0n 0.59687 112139.9n 0.59687 112140.0n 0.86774 112319.9n 0.86774 112320.0n -0.18224 112499.9n -0.18224 112500.0n 0.33904 112679.9n 0.33904 112680.0n -0.27694 112859.9n -0.27694 112860.0n -0.11225 113039.9n -0.11225 113040.0n 0.66829 113219.9n 0.66829 113220.0n 0.76165 113399.9n 0.76165 113400.0n 0.34158 113579.9n 0.34158 113580.0n 0.23585 113759.9n 0.23585 113760.0n 0.51542 113939.9n 0.51542 113940.0n 0.74089 114119.9n 0.74089 114120.0n 1.15161 114299.9n 1.15161 114300.0n -0.28574 114479.9n -0.28574 114480.0n 0.32870 114659.9n 0.32870 114660.0n 0.29878 114839.9n 0.29878 114840.0n 1.08309 115019.9n 1.08309 115020.0n 1.33158 115199.9n 1.33158 115200.0n -0.17517 115379.9n -0.17517 115380.0n -0.27694 115559.9n -0.27694 115560.0n 0.76165 115739.9n 0.76165 115740.0n 1.15161 115919.9n 1.15161 115920.0n -0.18224 116099.9n -0.18224 116100.0n 0.71811 116279.9n 0.71811 116280.0n 0.74089 116459.9n 0.74089 116460.0n 0.32870 116639.9n 0.32870 116640.0n 1.21828 116819.9n 1.21828 116820.0n 0.23585 116999.9n 0.23585 117000.0n 0.33904 117179.9n 0.33904 117180.0n 0.71300 117359.9n 0.71300 117360.0n 0.36518 117539.9n 0.36518 117540.0n -0.11225 117719.9n -0.11225 117720.0n 1.37792 117899.9n 1.37792 117900.0n 1.23386 118079.9n 1.23386 118080.0n 0.70085 118259.9n 0.70085 118260.0n 0.59687 118439.9n 0.59687 118440.0n 0.86774 118619.9n 0.86774 118620.0n 0.65987 118799.9n 0.65987 118800.0n 0.34158 118979.9n 0.34158 118980.0n 0.43405 119159.9n 0.43405 119160.0n 0.40753 119339.9n 0.40753 119340.0n 1.08309 119519.9n 1.08309 119520.0n -0.28574 119699.9n -0.28574 119700.0n -0.20712 119879.9n -0.20712 119880.0n 0.57446 120059.9n 0.57446 120060.0n 0.29878 120239.9n 0.29878 120240.0n 1.33158 120419.9n 1.33158 120420.0n 0.66829 120599.9n 0.66829 120600.0n -0.23180 120779.9n -0.23180 120780.0n 0.51542 120959.9n 0.51542 120960.0n -0.27694 121139.9n -0.27694 121140.0n 1.08309 121319.9n 1.08309 121320.0n 1.37792 121499.9n 1.37792 121500.0n -0.17517 121679.9n -0.17517 121680.0n 0.86774 121859.9n 0.86774 121860.0n 0.32870 122039.9n 0.32870 122040.0n -0.28574 122219.9n -0.28574 122220.0n 0.40753 122399.9n 0.40753 122400.0n 0.43405 122579.9n 0.43405 122580.0n 0.57446 122759.9n 0.57446 122760.0n 0.34158 122939.9n 0.34158 122940.0n 0.71811 123119.9n 0.71811 123120.0n 1.21828 123299.9n 1.21828 123300.0n 0.74089 123479.9n 0.74089 123480.0n 0.36518 123659.9n 0.36518 123660.0n 0.66829 123839.9n 0.66829 123840.0n 1.23386 124019.9n 1.23386 124020.0n 0.33904 124199.9n 0.33904 124200.0n 0.51542 124379.9n 0.51542 124380.0n 0.59687 124559.9n 0.59687 124560.0n 0.76165 124739.9n 0.76165 124740.0n -0.20712 124919.9n -0.20712 124920.0n 0.71300 125099.9n 0.71300 125100.0n -0.11225 125279.9n -0.11225 125280.0n 0.23585 125459.9n 0.23585 125460.0n 0.29878 125639.9n 0.29878 125640.0n -0.18224 125819.9n -0.18224 125820.0n 0.70085 125999.9n 0.70085 126000.0n -0.23180 126179.9n -0.23180 126180.0n 1.33158 126359.9n 1.33158 126360.0n 0.65987 126539.9n 0.65987 126540.0n 1.15161 126719.9n 1.15161 126720.0n 0.86774 126899.9n 0.86774 126900.0n 1.33158 127079.9n 1.33158 127080.0n 0.33904 127259.9n 0.33904 127260.0n 0.34158 127439.9n 0.34158 127440.0n 1.21828 127619.9n 1.21828 127620.0n 1.15161 127799.9n 1.15161 127800.0n -0.11225 127979.9n -0.11225 127980.0n 1.23386 128159.9n 1.23386 128160.0n 0.40753 128339.9n 0.40753 128340.0n 1.08309 128519.9n 1.08309 128520.0n 0.51542 128699.9n 0.51542 128700.0n 0.59687 128879.9n 0.59687 128880.0n -0.17517 129059.9n -0.17517 129060.0n -0.23180 129239.9n -0.23180 129240.0n 0.74089 129419.9n 0.74089 129420.0n 0.32870 129599.9n 0.32870 129600.0n 0.57446 129779.9n 0.57446 129780.0n 0.71811 129959.9n 0.71811 129960.0n 1.37792 130139.9n 1.37792 130140.0n 0.29878 130319.9n 0.29878 130320.0n -0.20712 130499.9n -0.20712 130500.0n 0.66829 130679.9n 0.66829 130680.0n -0.27694 130859.9n -0.27694 130860.0n 0.36518 131039.9n 0.36518 131040.0n 0.65987 131219.9n 0.65987 131220.0n 0.23585 131399.9n 0.23585 131400.0n 0.43405 131579.9n 0.43405 131580.0n 0.70085 131759.9n 0.70085 131760.0n -0.28574 131939.9n -0.28574 131940.0n 0.76165 132119.9n 0.76165 132120.0n -0.18224 132299.9n -0.18224 132300.0n 0.71300 132479.9n 0.71300 132480.0n 0.71811 132659.9n 0.71811 132660.0n 0.43405 132839.9n 0.43405 132840.0n 0.76165 133019.9n 0.76165 133020.0n 0.70085 133199.9n 0.70085 133200.0n 0.23585 133379.9n 0.23585 133380.0n 1.08309 133559.9n 1.08309 133560.0n 1.21828 133739.9n 1.21828 133740.0n 0.57446 133919.9n 0.57446 133920.0n 0.59687 134099.9n 0.59687 134100.0n -0.27694 134279.9n -0.27694 134280.0n 0.71300 134459.9n 0.71300 134460.0n 1.33158 134639.9n 1.33158 134640.0n 0.32870 134819.9n 0.32870 134820.0n 0.33904 134999.9n 0.33904 135000.0n 1.15161 135179.9n 1.15161 135180.0n 0.74089 135359.9n 0.74089 135360.0n -0.18224 135539.9n -0.18224 135540.0n 0.65987 135719.9n 0.65987 135720.0n 0.51542 135899.9n 0.51542 135900.0n -0.17517 136079.9n -0.17517 136080.0n 0.40753 136259.9n 0.40753 136260.0n 0.34158 136439.9n 0.34158 136440.0n 0.29878 136619.9n 0.29878 136620.0n 0.66829 136799.9n 0.66829 136800.0n -0.20712 136979.9n -0.20712 136980.0n 0.86774 137159.9n 0.86774 137160.0n -0.28574 137339.9n -0.28574 137340.0n 1.37792 137519.9n 1.37792 137520.0n 0.36518 137699.9n 0.36518 137700.0n 1.23386 137879.9n 1.23386 137880.0n -0.11225 138059.9n -0.11225 138060.0n -0.23180 138239.9n -0.23180 138240.0n -0.28574 138419.9n -0.28574 138420.0n 0.29878 138599.9n 0.29878 138600.0n 0.36518 138779.9n 0.36518 138780.0n 0.86774 138959.9n 0.86774 138960.0n -0.11225 139139.9n -0.11225 139140.0n 0.76165 139319.9n 0.76165 139320.0n 0.65987 139499.9n 0.65987 139500.0n 0.32870 139679.9n 0.32870 139680.0n 0.70085 139859.9n 0.70085 139860.0n 0.66829 140039.9n 0.66829 140040.0n 0.74089 140219.9n 0.74089 140220.0n -0.20712 140399.9n -0.20712 140400.0n 1.15161 140579.9n 1.15161 140580.0n 1.37792 140759.9n 1.37792 140760.0n 0.33904 140939.9n 0.33904 140940.0n 1.23386 141119.9n 1.23386 141120.0n 0.23585 141299.9n 0.23585 141300.0n 0.34158 141479.9n 0.34158 141480.0n 0.40753 141659.9n 0.40753 141660.0n 0.71811 141839.9n 0.71811 141840.0n 0.57446 142019.9n 0.57446 142020.0n 0.59687 142199.9n 0.59687 142200.0n 1.33158 142379.9n 1.33158 142380.0n 0.43405 142559.9n 0.43405 142560.0n -0.17517 142739.9n -0.17517 142740.0n -0.18224 142919.9n -0.18224 142920.0n 0.71300 143099.9n 0.71300 143100.0n -0.23180 143279.9n -0.23180 143280.0n -0.27694 143459.9n -0.27694 143460.0n 0.51542 143639.9n 0.51542 143640.0n 1.21828 143819.9n 1.21828 143820.0n 1.08309 143999.9n 1.08309 144000.0n 0.71300 144179.9n 0.71300 144180.0n 1.37792 144359.9n 1.37792 144360.0n 0.59687 144539.9n 0.59687 144540.0n 0.43405 144719.9n 0.43405 144720.0n 1.33158 144899.9n 1.33158 144900.0n 1.21828 145079.9n 1.21828 145080.0n 0.51542 145259.9n 0.51542 145260.0n 0.34158 145439.9n 0.34158 145440.0n 0.36518 145619.9n 0.36518 145620.0n 0.65987 145799.9n 0.65987 145800.0n 0.71811 145979.9n 0.71811 145980.0n 0.86774 146159.9n 0.86774 146160.0n 0.76165 146339.9n 0.76165 146340.0n 0.40753 146519.9n 0.40753 146520.0n 1.23386 146699.9n 1.23386 146700.0n 0.66829 146879.9n 0.66829 146880.0n 0.32870 147059.9n 0.32870 147060.0n 0.33904 147239.9n 0.33904 147240.0n -0.28574 147419.9n -0.28574 147420.0n 0.70085 147599.9n 0.70085 147600.0n 0.23585 147779.9n 0.23585 147780.0n 1.15161 147959.9n 1.15161 147960.0n -0.23180 148139.9n -0.23180 148140.0n -0.20712 148319.9n -0.20712 148320.0n -0.17517 148499.9n -0.17517 148500.0n 0.74089 148679.9n 0.74089 148680.0n -0.11225 148859.9n -0.11225 148860.0n 0.29878 149039.9n 0.29878 149040.0n 1.08309 149219.9n 1.08309 149220.0n -0.27694 149399.9n -0.27694 149400.0n -0.18224 149579.9n -0.18224 149580.0n 0.57446 149759.9n 0.57446 149760.0n 0.86774 149939.9n 0.86774 149940.0n 0.36518 150119.9n 0.36518 150120.0n -0.27694 150299.9n -0.27694 150300.0n 0.23585 150479.9n 0.23585 150480.0n 1.33158 150659.9n 1.33158 150660.0n 0.32870 150839.9n 0.32870 150840.0n 0.33904 151019.9n 0.33904 151020.0n 0.57446 151199.9n 0.57446 151200.0n 0.51542 151379.9n 0.51542 151380.0n 0.59687 151559.9n 0.59687 151560.0n -0.20712 151739.9n -0.20712 151740.0n 1.21828 151919.9n 1.21828 151920.0n 0.40753 152099.9n 0.40753 152100.0n -0.23180 152279.9n -0.23180 152280.0n 0.74089 152459.9n 0.74089 152460.0n -0.11225 152639.9n -0.11225 152640.0n 0.70085 152819.9n 0.70085 152820.0n 0.34158 152999.9n 0.34158 153000.0n 0.76165 153179.9n 0.76165 153180.0n 0.71811 153359.9n 0.71811 153360.0n 1.37792 153539.9n 1.37792 153540.0n 1.23386 153719.9n 1.23386 153720.0n 0.65987 153899.9n 0.65987 153900.0n 0.43405 154079.9n 0.43405 154080.0n 1.15161 154259.9n 1.15161 154260.0n 0.71300 154439.9n 0.71300 154440.0n -0.17517 154619.9n -0.17517 154620.0n -0.18224 154799.9n -0.18224 154800.0n -0.28574 154979.9n -0.28574 154980.0n 0.66829 155159.9n 0.66829 155160.0n 1.08309 155339.9n 1.08309 155340.0n 0.29878 155519.9n 0.29878 155520.0n 1.21828 155699.9n 1.21828 155700.0n -0.18224 155879.9n -0.18224 155880.0n 0.23585 156059.9n 0.23585 156060.0n 1.23386 156239.9n 1.23386 156240.0n 0.43405 156419.9n 0.43405 156420.0n -0.20712 156599.9n -0.20712 156600.0n 0.32870 156779.9n 0.32870 156780.0n 0.66829 156959.9n 0.66829 156960.0n 1.08309 157139.9n 1.08309 157140.0n 0.86774 157319.9n 0.86774 157320.0n 0.74089 157499.9n 0.74089 157500.0n 1.37792 157679.9n 1.37792 157680.0n 0.65987 157859.9n 0.65987 157860.0n 0.40753 158039.9n 0.40753 158040.0n 0.36518 158219.9n 0.36518 158220.0n 0.59687 158399.9n 0.59687 158400.0n -0.17517 158579.9n -0.17517 158580.0n 0.34158 158759.9n 0.34158 158760.0n 0.71811 158939.9n 0.71811 158940.0n -0.27694 159119.9n -0.27694 159120.0n 0.70085 159299.9n 0.70085 159300.0n 0.33904 159479.9n 0.33904 159480.0n -0.11225 159659.9n -0.11225 159660.0n 0.51542 159839.9n 0.51542 159840.0n -0.23180 160019.9n -0.23180 160020.0n -0.28574 160199.9n -0.28574 160200.0n 0.29878 160379.9n 0.29878 160380.0n 1.15161 160559.9n 1.15161 160560.0n 1.33158 160739.9n 1.33158 160740.0n 0.76165 160919.9n 0.76165 160920.0n 0.71300 161099.9n 0.71300 161100.0n 0.57446 161279.9n 0.57446 161280.0n 0.66829 161459.9n 0.66829 161460.0n 0.51542 161639.9n 0.51542 161640.0n 0.86774 161819.9n 0.86774 161820.0n 1.23386 161999.9n 1.23386 162000.0n -0.27694 162179.9n -0.27694 162180.0n 0.57446 162359.9n 0.57446 162360.0n 1.37792 162539.9n 1.37792 162540.0n -0.23180 162719.9n -0.23180 162720.0n 0.74089 162899.9n 0.74089 162900.0n 1.08309 163079.9n 1.08309 163080.0n 1.33158 163259.9n 1.33158 163260.0n 0.65987 163439.9n 0.65987 163440.0n 0.70085 163619.9n 0.70085 163620.0n 1.21828 163799.9n 1.21828 163800.0n 0.29878 163979.9n 0.29878 163980.0n 1.15161 164159.9n 1.15161 164160.0n -0.18224 164339.9n -0.18224 164340.0n -0.11225 164519.9n -0.11225 164520.0n 0.71300 164699.9n 0.71300 164700.0n 0.36518 164879.9n 0.36518 164880.0n 0.76165 165059.9n 0.76165 165060.0n 0.23585 165239.9n 0.23585 165240.0n 0.40753 165419.9n 0.40753 165420.0n 0.71811 165599.9n 0.71811 165600.0n -0.20712 165779.9n -0.20712 165780.0n 0.59687 165959.9n 0.59687 165960.0n 0.34158 166139.9n 0.34158 166140.0n -0.28574 166319.9n -0.28574 166320.0n -0.17517 166499.9n -0.17517 166500.0n 0.33904 166679.9n 0.33904 166680.0n 0.32870 166859.9n 0.32870 166860.0n 0.43405 167039.9n 0.43405 167040.0n 1.23386 167219.9n 1.23386 167220.0n 0.33904 167399.9n 0.33904 167400.0n -0.27694 167579.9n -0.27694 167580.0n 0.86774 167759.9n 0.86774 167760.0n -0.11225 167939.9n -0.11225 167940.0n 1.37792 168119.9n 1.37792 168120.0n 0.29878 168299.9n 0.29878 168300.0n 0.36518 168479.9n 0.36518 168480.0n 0.40753 168659.9n 0.40753 168660.0n 0.65987 168839.9n 0.65987 168840.0n 1.33158 169019.9n 1.33158 169020.0n 0.57446 169199.9n 0.57446 169200.0n 0.51542 169379.9n 0.51542 169380.0n 1.15161 169559.9n 1.15161 169560.0n -0.28574 169739.9n -0.28574 169740.0n -0.20712 169919.9n -0.20712 169920.0n 0.74089 170099.9n 0.74089 170100.0n 1.08309 170279.9n 1.08309 170280.0n 0.66829 170459.9n 0.66829 170460.0n -0.17517 170639.9n -0.17517 170640.0n -0.18224 170819.9n -0.18224 170820.0n 0.34158 170999.9n 0.34158 171000.0n 0.32870 171179.9n 0.32870 171180.0n -0.23180 171359.9n -0.23180 171360.0n 0.76165 171539.9n 0.76165 171540.0n 0.70085 171719.9n 0.70085 171720.0n 0.71811 171899.9n 0.71811 171900.0n 0.23585 172079.9n 0.23585 172080.0n 0.59687 172259.9n 0.59687 172260.0n 1.21828 172439.9n 1.21828 172440.0n 0.71300 172619.9n 0.71300 172620.0n 0.43405 172799.9n 0.43405 172800.0n 0.63424 172979.9n 0.63424 172980.0n 0.66270 173159.9n 0.66270 173160.0n 0.61615 173339.9n 0.61615 173340.0n 0.40294 173519.9n 0.40294 173520.0n 0.37693 173699.9n 0.37693 173700.0n 0.32982 173879.9n 0.32982 173880.0n 0.29460 174059.9n 0.29460 174060.0n 0.46418 174239.9n 0.46418 174240.0n 0.66643 174419.9n 0.66643 174420.0n 0.47115 174599.9n 0.47115 174600.0n 0.25617 174779.9n 0.25617 174780.0n 0.21591 174959.9n 0.21591 174960.0n 0.48064 175139.9n 0.48064 175140.0n 0.49468 175319.9n 0.49468 175320.0n 0.31811 175499.9n 0.31811 175500.0n 0.20138 175679.9n 0.20138 175680.0n 0.64950 175859.9n 0.64950 175860.0n 0.83142 176039.9n 0.83142 176040.0n 0.44747 176219.9n 0.44747 176220.0n 0.39177 176399.9n 0.39177 176400.0n 0.36389 176579.9n 0.36389 176580.0n 0.58803 176759.9n 0.58803 176760.0n 0.30587 176939.9n 0.30587 176940.0n 0.41543 177119.9n 0.41543 177120.0n 0.66249 177299.9n 0.66249 177300.0n 0.28619 177479.9n 0.28619 177480.0n 0.35734 177659.9n 0.35734 177660.0n 0.83982 177839.9n 0.83982 177840.0n 0.21843 178019.9n 0.21843 178020.0n 0.77797 178199.9n 0.77797 178200.0n 0.12598 178379.9n 0.12598 178380.0n 1.10545 178559.9n 1.10545 178560.0n 1.25282 178739.9n 1.25282 178740.0n 1.37666 178919.9n 1.37666 178920.0n -0.43391 179099.9n -0.43391 179100.0n 0.62489 179279.9n 0.62489 179280.0n 0.64220 179459.9n 0.64220 179460.0n -0.04281 179639.9n -0.04281 179640.0n -0.30757 179819.9n -0.30757 179820.0n 1.27950 179999.9n 1.27950 180000.0n 0.89863 180179.9n 0.89863 180180.0n -0.20727 180359.9n -0.20727 180360.0n -0.40210 180539.9n -0.40210 180540.0n -0.03003 180719.9n -0.03003 180720.0n 1.27250 180899.9n 1.27250 180900.0n 1.24444 181079.9n 1.24444 181080.0n 0.18165 181259.9n 0.18165 181260.0n 0.88208 181439.9n 0.88208 181440.0n 1.41822 181619.9n 1.41822 181620.0n 0.24758 181799.9n 0.24758 181800.0n 0.42646 181979.9n 0.42646 181980.0n -0.22124 182159.9n -0.22124 182160.0n -0.07258 182339.9n -0.07258 182340.0n -0.14286 182519.9n -0.14286 182520.0n 1.14226 182699.9n 1.14226 182700.0n -0.32817 182879.9n -0.32817 182880.0n -0.08864 183059.9n -0.08864 183060.0n -0.09055 183239.9n -0.09055 183240.0n -0.50665 183419.9n -0.50665 183420.0n 1.21520)
Vxp2 a_xp2 0 PWL(0.0n 0.80000 179.9n 0.80000 180.0n 0.80000 359.9n 0.80000 360.0n 0.80000 539.9n 0.80000 540.0n 0.80000 719.9n 0.80000 720.0n 0.80000 899.9n 0.80000 900.0n 0.80000 1079.9n 0.80000 1080.0n 0.80000 1259.9n 0.80000 1260.0n 0.80000 1439.9n 0.80000 1440.0n 0.80000 1619.9n 0.80000 1620.0n 0.80000 1799.9n 0.80000 1800.0n 0.80000 1979.9n 0.80000 1980.0n 0.80000 2159.9n 0.80000 2160.0n 0.80000 2339.9n 0.80000 2340.0n 0.80000 2519.9n 0.80000 2520.0n 0.80000 2699.9n 0.80000 2700.0n 0.80000 2879.9n 0.80000 2880.0n 0.80000 3059.9n 0.80000 3060.0n 0.80000 3239.9n 0.80000 3240.0n 0.80000 3419.9n 0.80000 3420.0n 0.80000 3599.9n 0.80000 3600.0n 0.80000 3779.9n 0.80000 3780.0n 0.80000 3959.9n 0.80000 3960.0n 0.80000 4139.9n 0.80000 4140.0n 0.80000 4319.9n 0.80000 4320.0n 0.80000 4499.9n 0.80000 4500.0n 0.80000 4679.9n 0.80000 4680.0n 0.80000 4859.9n 0.80000 4860.0n 0.80000 5039.9n 0.80000 5040.0n 0.80000 5219.9n 0.80000 5220.0n 0.80000 5399.9n 0.80000 5400.0n 0.80000 5579.9n 0.80000 5580.0n 0.80000 5759.9n 0.80000 5760.0n 0.80000 5939.9n 0.80000 5940.0n 0.80000 6119.9n 0.80000 6120.0n 0.80000 6299.9n 0.80000 6300.0n 0.80000 6479.9n 0.80000 6480.0n 0.80000 6659.9n 0.80000 6660.0n 0.80000 6839.9n 0.80000 6840.0n 0.80000 7019.9n 0.80000 7020.0n 0.80000 7199.9n 0.80000 7200.0n 0.80000 7379.9n 0.80000 7380.0n 0.80000 7559.9n 0.80000 7560.0n 0.80000 7739.9n 0.80000 7740.0n 0.80000 7919.9n 0.80000 7920.0n 0.80000 8099.9n 0.80000 8100.0n 0.80000 8279.9n 0.80000 8280.0n 0.80000 8459.9n 0.80000 8460.0n 0.80000 8639.9n 0.80000 8640.0n 0.80000 8819.9n 0.80000 8820.0n 0.80000 8999.9n 0.80000 9000.0n 0.80000 9179.9n 0.80000 9180.0n 0.80000 9359.9n 0.80000 9360.0n 0.80000 9539.9n 0.80000 9540.0n 0.80000 9719.9n 0.80000 9720.0n 0.80000 9899.9n 0.80000 9900.0n 0.80000 10079.9n 0.80000 10080.0n 0.80000 10259.9n 0.80000 10260.0n 0.80000 10439.9n 0.80000 10440.0n 0.80000 10619.9n 0.80000 10620.0n 0.80000 10799.9n 0.80000 10800.0n 0.80000 10979.9n 0.80000 10980.0n 0.80000 11159.9n 0.80000 11160.0n 0.80000 11339.9n 0.80000 11340.0n 0.80000 11519.9n 0.80000 11520.0n 0.80000 11699.9n 0.80000 11700.0n 0.80000 11879.9n 0.80000 11880.0n 0.80000 12059.9n 0.80000 12060.0n 0.80000 12239.9n 0.80000 12240.0n 0.80000 12419.9n 0.80000 12420.0n 0.80000 12599.9n 0.80000 12600.0n 0.80000 12779.9n 0.80000 12780.0n 0.80000 12959.9n 0.80000 12960.0n 0.80000 13139.9n 0.80000 13140.0n 0.80000 13319.9n 0.80000 13320.0n 0.80000 13499.9n 0.80000 13500.0n 0.80000 13679.9n 0.80000 13680.0n 0.80000 13859.9n 0.80000 13860.0n 0.80000 14039.9n 0.80000 14040.0n 0.80000 14219.9n 0.80000 14220.0n 0.80000 14399.9n 0.80000 14400.0n 0.80000 14579.9n 0.80000 14580.0n 0.80000 14759.9n 0.80000 14760.0n 0.80000 14939.9n 0.80000 14940.0n 0.80000 15119.9n 0.80000 15120.0n 0.80000 15299.9n 0.80000 15300.0n 0.80000 15479.9n 0.80000 15480.0n 0.80000 15659.9n 0.80000 15660.0n 0.80000 15839.9n 0.80000 15840.0n 0.80000 16019.9n 0.80000 16020.0n 0.80000 16199.9n 0.80000 16200.0n 0.80000 16379.9n 0.80000 16380.0n 0.80000 16559.9n 0.80000 16560.0n 0.80000 16739.9n 0.80000 16740.0n 0.80000 16919.9n 0.80000 16920.0n 0.80000 17099.9n 0.80000 17100.0n 0.80000 17279.9n 0.80000 17280.0n 0.80000 17459.9n 0.80000 17460.0n 0.80000 17639.9n 0.80000 17640.0n 0.80000 17819.9n 0.80000 17820.0n 0.80000 17999.9n 0.80000 18000.0n 0.80000 18179.9n 0.80000 18180.0n 0.80000 18359.9n 0.80000 18360.0n 0.80000 18539.9n 0.80000 18540.0n 0.80000 18719.9n 0.80000 18720.0n 0.80000 18899.9n 0.80000 18900.0n 0.80000 19079.9n 0.80000 19080.0n 0.80000 19259.9n 0.80000 19260.0n 0.80000 19439.9n 0.80000 19440.0n 0.80000 19619.9n 0.80000 19620.0n 0.80000 19799.9n 0.80000 19800.0n 0.80000 19979.9n 0.80000 19980.0n 0.80000 20159.9n 0.80000 20160.0n 0.80000 20339.9n 0.80000 20340.0n 0.80000 20519.9n 0.80000 20520.0n 0.80000 20699.9n 0.80000 20700.0n 0.80000 20879.9n 0.80000 20880.0n 0.80000 21059.9n 0.80000 21060.0n 0.80000 21239.9n 0.80000 21240.0n 0.80000 21419.9n 0.80000 21420.0n 0.80000 21599.9n 0.80000 21600.0n 0.80000 21779.9n 0.80000 21780.0n 0.80000 21959.9n 0.80000 21960.0n 0.80000 22139.9n 0.80000 22140.0n 0.80000 22319.9n 0.80000 22320.0n 0.80000 22499.9n 0.80000 22500.0n 0.80000 22679.9n 0.80000 22680.0n 0.80000 22859.9n 0.80000 22860.0n 0.80000 23039.9n 0.80000 23040.0n 0.80000 23219.9n 0.80000 23220.0n 0.80000 23399.9n 0.80000 23400.0n 0.80000 23579.9n 0.80000 23580.0n 0.80000 23759.9n 0.80000 23760.0n 0.80000 23939.9n 0.80000 23940.0n 0.80000 24119.9n 0.80000 24120.0n 0.80000 24299.9n 0.80000 24300.0n 0.80000 24479.9n 0.80000 24480.0n 0.80000 24659.9n 0.80000 24660.0n 0.80000 24839.9n 0.80000 24840.0n 0.80000 25019.9n 0.80000 25020.0n 0.80000 25199.9n 0.80000 25200.0n 0.80000 25379.9n 0.80000 25380.0n 0.80000 25559.9n 0.80000 25560.0n 0.80000 25739.9n 0.80000 25740.0n 0.80000 25919.9n 0.80000 25920.0n 0.80000 26099.9n 0.80000 26100.0n 0.80000 26279.9n 0.80000 26280.0n 0.80000 26459.9n 0.80000 26460.0n 0.80000 26639.9n 0.80000 26640.0n 0.80000 26819.9n 0.80000 26820.0n 0.80000 26999.9n 0.80000 27000.0n 0.80000 27179.9n 0.80000 27180.0n 0.80000 27359.9n 0.80000 27360.0n 0.80000 27539.9n 0.80000 27540.0n 0.80000 27719.9n 0.80000 27720.0n 0.80000 27899.9n 0.80000 27900.0n 0.80000 28079.9n 0.80000 28080.0n 0.80000 28259.9n 0.80000 28260.0n 0.80000 28439.9n 0.80000 28440.0n 0.80000 28619.9n 0.80000 28620.0n 0.80000 28799.9n 0.80000 28800.0n 0.80000 28979.9n 0.80000 28980.0n 0.80000 29159.9n 0.80000 29160.0n 0.80000 29339.9n 0.80000 29340.0n 0.80000 29519.9n 0.80000 29520.0n 0.80000 29699.9n 0.80000 29700.0n 0.80000 29879.9n 0.80000 29880.0n 0.80000 30059.9n 0.80000 30060.0n 0.80000 30239.9n 0.80000 30240.0n 0.80000 30419.9n 0.80000 30420.0n 0.80000 30599.9n 0.80000 30600.0n 0.80000 30779.9n 0.80000 30780.0n 0.80000 30959.9n 0.80000 30960.0n 0.80000 31139.9n 0.80000 31140.0n 0.80000 31319.9n 0.80000 31320.0n 0.80000 31499.9n 0.80000 31500.0n 0.80000 31679.9n 0.80000 31680.0n 0.80000 31859.9n 0.80000 31860.0n 0.80000 32039.9n 0.80000 32040.0n 0.80000 32219.9n 0.80000 32220.0n 0.80000 32399.9n 0.80000 32400.0n 0.80000 32579.9n 0.80000 32580.0n 0.80000 32759.9n 0.80000 32760.0n 0.80000 32939.9n 0.80000 32940.0n 0.80000 33119.9n 0.80000 33120.0n 0.80000 33299.9n 0.80000 33300.0n 0.80000 33479.9n 0.80000 33480.0n 0.80000 33659.9n 0.80000 33660.0n 0.80000 33839.9n 0.80000 33840.0n 0.80000 34019.9n 0.80000 34020.0n 0.80000 34199.9n 0.80000 34200.0n 0.80000 34379.9n 0.80000 34380.0n 0.80000 34559.9n 0.80000 34560.0n 0.80000 34739.9n 0.80000 34740.0n 0.80000 34919.9n 0.80000 34920.0n 0.80000 35099.9n 0.80000 35100.0n 0.80000 35279.9n 0.80000 35280.0n 0.80000 35459.9n 0.80000 35460.0n 0.80000 35639.9n 0.80000 35640.0n 0.80000 35819.9n 0.80000 35820.0n 0.80000 35999.9n 0.80000 36000.0n 0.80000 36179.9n 0.80000 36180.0n 0.80000 36359.9n 0.80000 36360.0n 0.80000 36539.9n 0.80000 36540.0n 0.80000 36719.9n 0.80000 36720.0n 0.80000 36899.9n 0.80000 36900.0n 0.80000 37079.9n 0.80000 37080.0n 0.80000 37259.9n 0.80000 37260.0n 0.80000 37439.9n 0.80000 37440.0n 0.80000 37619.9n 0.80000 37620.0n 0.80000 37799.9n 0.80000 37800.0n 0.80000 37979.9n 0.80000 37980.0n 0.80000 38159.9n 0.80000 38160.0n 0.80000 38339.9n 0.80000 38340.0n 0.80000 38519.9n 0.80000 38520.0n 0.80000 38699.9n 0.80000 38700.0n 0.80000 38879.9n 0.80000 38880.0n 0.80000 39059.9n 0.80000 39060.0n 0.80000 39239.9n 0.80000 39240.0n 0.80000 39419.9n 0.80000 39420.0n 0.80000 39599.9n 0.80000 39600.0n 0.80000 39779.9n 0.80000 39780.0n 0.80000 39959.9n 0.80000 39960.0n 0.80000 40139.9n 0.80000 40140.0n 0.80000 40319.9n 0.80000 40320.0n 0.80000 40499.9n 0.80000 40500.0n 0.80000 40679.9n 0.80000 40680.0n 0.80000 40859.9n 0.80000 40860.0n 0.80000 41039.9n 0.80000 41040.0n 0.80000 41219.9n 0.80000 41220.0n 0.80000 41399.9n 0.80000 41400.0n 0.80000 41579.9n 0.80000 41580.0n 0.80000 41759.9n 0.80000 41760.0n 0.80000 41939.9n 0.80000 41940.0n 0.80000 42119.9n 0.80000 42120.0n 0.80000 42299.9n 0.80000 42300.0n 0.80000 42479.9n 0.80000 42480.0n 0.80000 42659.9n 0.80000 42660.0n 0.80000 42839.9n 0.80000 42840.0n 0.80000 43019.9n 0.80000 43020.0n 0.80000 43199.9n 0.80000 43200.0n 0.80000 43379.9n 0.80000 43380.0n 0.80000 43559.9n 0.80000 43560.0n 0.80000 43739.9n 0.80000 43740.0n 0.80000 43919.9n 0.80000 43920.0n 0.80000 44099.9n 0.80000 44100.0n 0.80000 44279.9n 0.80000 44280.0n 0.80000 44459.9n 0.80000 44460.0n 0.80000 44639.9n 0.80000 44640.0n 0.80000 44819.9n 0.80000 44820.0n 0.80000 44999.9n 0.80000 45000.0n 0.80000 45179.9n 0.80000 45180.0n 0.80000 45359.9n 0.80000 45360.0n 0.80000 45539.9n 0.80000 45540.0n 0.80000 45719.9n 0.80000 45720.0n 0.80000 45899.9n 0.80000 45900.0n 0.80000 46079.9n 0.80000 46080.0n 0.80000 46259.9n 0.80000 46260.0n 0.80000 46439.9n 0.80000 46440.0n 0.80000 46619.9n 0.80000 46620.0n 0.80000 46799.9n 0.80000 46800.0n 0.80000 46979.9n 0.80000 46980.0n 0.80000 47159.9n 0.80000 47160.0n 0.80000 47339.9n 0.80000 47340.0n 0.80000 47519.9n 0.80000 47520.0n 0.80000 47699.9n 0.80000 47700.0n 0.80000 47879.9n 0.80000 47880.0n 0.80000 48059.9n 0.80000 48060.0n 0.80000 48239.9n 0.80000 48240.0n 0.80000 48419.9n 0.80000 48420.0n 0.80000 48599.9n 0.80000 48600.0n 0.80000 48779.9n 0.80000 48780.0n 0.80000 48959.9n 0.80000 48960.0n 0.80000 49139.9n 0.80000 49140.0n 0.80000 49319.9n 0.80000 49320.0n 0.80000 49499.9n 0.80000 49500.0n 0.80000 49679.9n 0.80000 49680.0n 0.80000 49859.9n 0.80000 49860.0n 0.80000 50039.9n 0.80000 50040.0n 0.80000 50219.9n 0.80000 50220.0n 0.80000 50399.9n 0.80000 50400.0n 0.80000 50579.9n 0.80000 50580.0n 0.80000 50759.9n 0.80000 50760.0n 0.80000 50939.9n 0.80000 50940.0n 0.80000 51119.9n 0.80000 51120.0n 0.80000 51299.9n 0.80000 51300.0n 0.80000 51479.9n 0.80000 51480.0n 0.80000 51659.9n 0.80000 51660.0n 0.80000 51839.9n 0.80000 51840.0n 0.80000 52019.9n 0.80000 52020.0n 0.80000 52199.9n 0.80000 52200.0n 0.80000 52379.9n 0.80000 52380.0n 0.80000 52559.9n 0.80000 52560.0n 0.80000 52739.9n 0.80000 52740.0n 0.80000 52919.9n 0.80000 52920.0n 0.80000 53099.9n 0.80000 53100.0n 0.80000 53279.9n 0.80000 53280.0n 0.80000 53459.9n 0.80000 53460.0n 0.80000 53639.9n 0.80000 53640.0n 0.80000 53819.9n 0.80000 53820.0n 0.80000 53999.9n 0.80000 54000.0n 0.80000 54179.9n 0.80000 54180.0n 0.80000 54359.9n 0.80000 54360.0n 0.80000 54539.9n 0.80000 54540.0n 0.80000 54719.9n 0.80000 54720.0n 0.80000 54899.9n 0.80000 54900.0n 0.80000 55079.9n 0.80000 55080.0n 0.80000 55259.9n 0.80000 55260.0n 0.80000 55439.9n 0.80000 55440.0n 0.80000 55619.9n 0.80000 55620.0n 0.80000 55799.9n 0.80000 55800.0n 0.80000 55979.9n 0.80000 55980.0n 0.80000 56159.9n 0.80000 56160.0n 0.80000 56339.9n 0.80000 56340.0n 0.80000 56519.9n 0.80000 56520.0n 0.80000 56699.9n 0.80000 56700.0n 0.80000 56879.9n 0.80000 56880.0n 0.80000 57059.9n 0.80000 57060.0n 0.80000 57239.9n 0.80000 57240.0n 0.80000 57419.9n 0.80000 57420.0n 0.80000 57599.9n 0.80000 57600.0n 0.80000 57779.9n 0.80000 57780.0n 0.80000 57959.9n 0.80000 57960.0n 0.80000 58139.9n 0.80000 58140.0n 0.80000 58319.9n 0.80000 58320.0n 0.80000 58499.9n 0.80000 58500.0n 0.80000 58679.9n 0.80000 58680.0n 0.80000 58859.9n 0.80000 58860.0n 0.80000 59039.9n 0.80000 59040.0n 0.80000 59219.9n 0.80000 59220.0n 0.80000 59399.9n 0.80000 59400.0n 0.80000 59579.9n 0.80000 59580.0n 0.80000 59759.9n 0.80000 59760.0n 0.80000 59939.9n 0.80000 59940.0n 0.80000 60119.9n 0.80000 60120.0n 0.80000 60299.9n 0.80000 60300.0n 0.80000 60479.9n 0.80000 60480.0n 0.80000 60659.9n 0.80000 60660.0n 0.80000 60839.9n 0.80000 60840.0n 0.80000 61019.9n 0.80000 61020.0n 0.80000 61199.9n 0.80000 61200.0n 0.80000 61379.9n 0.80000 61380.0n 0.80000 61559.9n 0.80000 61560.0n 0.80000 61739.9n 0.80000 61740.0n 0.80000 61919.9n 0.80000 61920.0n 0.80000 62099.9n 0.80000 62100.0n 0.80000 62279.9n 0.80000 62280.0n 0.80000 62459.9n 0.80000 62460.0n 0.80000 62639.9n 0.80000 62640.0n 0.80000 62819.9n 0.80000 62820.0n 0.80000 62999.9n 0.80000 63000.0n 0.80000 63179.9n 0.80000 63180.0n 0.80000 63359.9n 0.80000 63360.0n 0.80000 63539.9n 0.80000 63540.0n 0.80000 63719.9n 0.80000 63720.0n 0.80000 63899.9n 0.80000 63900.0n 0.80000 64079.9n 0.80000 64080.0n 0.80000 64259.9n 0.80000 64260.0n 0.80000 64439.9n 0.80000 64440.0n 0.80000 64619.9n 0.80000 64620.0n 0.80000 64799.9n 0.80000 64800.0n 0.80000 64979.9n 0.80000 64980.0n 0.80000 65159.9n 0.80000 65160.0n 0.80000 65339.9n 0.80000 65340.0n 0.80000 65519.9n 0.80000 65520.0n 0.80000 65699.9n 0.80000 65700.0n 0.80000 65879.9n 0.80000 65880.0n 0.80000 66059.9n 0.80000 66060.0n 0.80000 66239.9n 0.80000 66240.0n 0.80000 66419.9n 0.80000 66420.0n 0.80000 66599.9n 0.80000 66600.0n 0.80000 66779.9n 0.80000 66780.0n 0.80000 66959.9n 0.80000 66960.0n 0.80000 67139.9n 0.80000 67140.0n 0.80000 67319.9n 0.80000 67320.0n 0.80000 67499.9n 0.80000 67500.0n 0.80000 67679.9n 0.80000 67680.0n 0.80000 67859.9n 0.80000 67860.0n 0.80000 68039.9n 0.80000 68040.0n 0.80000 68219.9n 0.80000 68220.0n 0.80000 68399.9n 0.80000 68400.0n 0.80000 68579.9n 0.80000 68580.0n 0.80000 68759.9n 0.80000 68760.0n 0.80000 68939.9n 0.80000 68940.0n 0.80000 69119.9n 0.80000 69120.0n 0.80000 69299.9n 0.80000 69300.0n 0.80000 69479.9n 0.80000 69480.0n 0.80000 69659.9n 0.80000 69660.0n 0.80000 69839.9n 0.80000 69840.0n 0.80000 70019.9n 0.80000 70020.0n 0.80000 70199.9n 0.80000 70200.0n 0.80000 70379.9n 0.80000 70380.0n 0.80000 70559.9n 0.80000 70560.0n 0.80000 70739.9n 0.80000 70740.0n 0.80000 70919.9n 0.80000 70920.0n 0.80000 71099.9n 0.80000 71100.0n 0.80000 71279.9n 0.80000 71280.0n 0.80000 71459.9n 0.80000 71460.0n 0.80000 71639.9n 0.80000 71640.0n 0.80000 71819.9n 0.80000 71820.0n 0.80000 71999.9n 0.80000 72000.0n 0.80000 72179.9n 0.80000 72180.0n 0.80000 72359.9n 0.80000 72360.0n 0.80000 72539.9n 0.80000 72540.0n 0.80000 72719.9n 0.80000 72720.0n 0.80000 72899.9n 0.80000 72900.0n 0.80000 73079.9n 0.80000 73080.0n 0.80000 73259.9n 0.80000 73260.0n 0.80000 73439.9n 0.80000 73440.0n 0.80000 73619.9n 0.80000 73620.0n 0.80000 73799.9n 0.80000 73800.0n 0.80000 73979.9n 0.80000 73980.0n 0.80000 74159.9n 0.80000 74160.0n 0.80000 74339.9n 0.80000 74340.0n 0.80000 74519.9n 0.80000 74520.0n 0.80000 74699.9n 0.80000 74700.0n 0.80000 74879.9n 0.80000 74880.0n 0.80000 75059.9n 0.80000 75060.0n 0.80000 75239.9n 0.80000 75240.0n 0.80000 75419.9n 0.80000 75420.0n 0.80000 75599.9n 0.80000 75600.0n 0.80000 75779.9n 0.80000 75780.0n 0.80000 75959.9n 0.80000 75960.0n 0.80000 76139.9n 0.80000 76140.0n 0.80000 76319.9n 0.80000 76320.0n 0.80000 76499.9n 0.80000 76500.0n 0.80000 76679.9n 0.80000 76680.0n 0.80000 76859.9n 0.80000 76860.0n 0.80000 77039.9n 0.80000 77040.0n 0.80000 77219.9n 0.80000 77220.0n 0.80000 77399.9n 0.80000 77400.0n 0.80000 77579.9n 0.80000 77580.0n 0.80000 77759.9n 0.80000 77760.0n 0.80000 77939.9n 0.80000 77940.0n 0.80000 78119.9n 0.80000 78120.0n 0.80000 78299.9n 0.80000 78300.0n 0.80000 78479.9n 0.80000 78480.0n 0.80000 78659.9n 0.80000 78660.0n 0.80000 78839.9n 0.80000 78840.0n 0.80000 79019.9n 0.80000 79020.0n 0.80000 79199.9n 0.80000 79200.0n 0.80000 79379.9n 0.80000 79380.0n 0.80000 79559.9n 0.80000 79560.0n 0.80000 79739.9n 0.80000 79740.0n 0.80000 79919.9n 0.80000 79920.0n 0.80000 80099.9n 0.80000 80100.0n 0.80000 80279.9n 0.80000 80280.0n 0.80000 80459.9n 0.80000 80460.0n 0.80000 80639.9n 0.80000 80640.0n 0.80000 80819.9n 0.80000 80820.0n 0.80000 80999.9n 0.80000 81000.0n 0.80000 81179.9n 0.80000 81180.0n 0.80000 81359.9n 0.80000 81360.0n 0.80000 81539.9n 0.80000 81540.0n 0.80000 81719.9n 0.80000 81720.0n 0.80000 81899.9n 0.80000 81900.0n 0.80000 82079.9n 0.80000 82080.0n 0.80000 82259.9n 0.80000 82260.0n 0.80000 82439.9n 0.80000 82440.0n 0.80000 82619.9n 0.80000 82620.0n 0.80000 82799.9n 0.80000 82800.0n 0.80000 82979.9n 0.80000 82980.0n 0.80000 83159.9n 0.80000 83160.0n 0.80000 83339.9n 0.80000 83340.0n 0.80000 83519.9n 0.80000 83520.0n 0.80000 83699.9n 0.80000 83700.0n 0.80000 83879.9n 0.80000 83880.0n 0.80000 84059.9n 0.80000 84060.0n 0.80000 84239.9n 0.80000 84240.0n 0.80000 84419.9n 0.80000 84420.0n 0.80000 84599.9n 0.80000 84600.0n 0.80000 84779.9n 0.80000 84780.0n 0.80000 84959.9n 0.80000 84960.0n 0.80000 85139.9n 0.80000 85140.0n 0.80000 85319.9n 0.80000 85320.0n 0.80000 85499.9n 0.80000 85500.0n 0.80000 85679.9n 0.80000 85680.0n 0.80000 85859.9n 0.80000 85860.0n 0.80000 86039.9n 0.80000 86040.0n 0.80000 86219.9n 0.80000 86220.0n 0.80000 86399.9n 0.80000 86400.0n 0.80000 86579.9n 0.80000 86580.0n 0.80000 86759.9n 0.80000 86760.0n 0.80000 86939.9n 0.80000 86940.0n 0.80000 87119.9n 0.80000 87120.0n 0.80000 87299.9n 0.80000 87300.0n 0.80000 87479.9n 0.80000 87480.0n 0.80000 87659.9n 0.80000 87660.0n 0.80000 87839.9n 0.80000 87840.0n 0.80000 88019.9n 0.80000 88020.0n 0.80000 88199.9n 0.80000 88200.0n 0.80000 88379.9n 0.80000 88380.0n 0.80000 88559.9n 0.80000 88560.0n 0.80000 88739.9n 0.80000 88740.0n 0.80000 88919.9n 0.80000 88920.0n 0.80000 89099.9n 0.80000 89100.0n 0.80000 89279.9n 0.80000 89280.0n 0.80000 89459.9n 0.80000 89460.0n 0.80000 89639.9n 0.80000 89640.0n 0.80000 89819.9n 0.80000 89820.0n 0.80000 89999.9n 0.80000 90000.0n 0.80000 90179.9n 0.80000 90180.0n 0.80000 90359.9n 0.80000 90360.0n 0.80000 90539.9n 0.80000 90540.0n 0.80000 90719.9n 0.80000 90720.0n 0.80000 90899.9n 0.80000 90900.0n 0.80000 91079.9n 0.80000 91080.0n 0.80000 91259.9n 0.80000 91260.0n 0.80000 91439.9n 0.80000 91440.0n 0.80000 91619.9n 0.80000 91620.0n 0.80000 91799.9n 0.80000 91800.0n 0.80000 91979.9n 0.80000 91980.0n 0.80000 92159.9n 0.80000 92160.0n 0.80000 92339.9n 0.80000 92340.0n 0.80000 92519.9n 0.80000 92520.0n 0.80000 92699.9n 0.80000 92700.0n 0.80000 92879.9n 0.80000 92880.0n 0.80000 93059.9n 0.80000 93060.0n 0.80000 93239.9n 0.80000 93240.0n 0.80000 93419.9n 0.80000 93420.0n 0.80000 93599.9n 0.80000 93600.0n 0.80000 93779.9n 0.80000 93780.0n 0.80000 93959.9n 0.80000 93960.0n 0.80000 94139.9n 0.80000 94140.0n 0.80000 94319.9n 0.80000 94320.0n 0.80000 94499.9n 0.80000 94500.0n 0.80000 94679.9n 0.80000 94680.0n 0.80000 94859.9n 0.80000 94860.0n 0.80000 95039.9n 0.80000 95040.0n 0.80000 95219.9n 0.80000 95220.0n 0.80000 95399.9n 0.80000 95400.0n 0.80000 95579.9n 0.80000 95580.0n 0.80000 95759.9n 0.80000 95760.0n 0.80000 95939.9n 0.80000 95940.0n 0.80000 96119.9n 0.80000 96120.0n 0.80000 96299.9n 0.80000 96300.0n 0.80000 96479.9n 0.80000 96480.0n 0.80000 96659.9n 0.80000 96660.0n 0.80000 96839.9n 0.80000 96840.0n 0.80000 97019.9n 0.80000 97020.0n 0.80000 97199.9n 0.80000 97200.0n 0.80000 97379.9n 0.80000 97380.0n 0.80000 97559.9n 0.80000 97560.0n 0.80000 97739.9n 0.80000 97740.0n 0.80000 97919.9n 0.80000 97920.0n 0.80000 98099.9n 0.80000 98100.0n 0.80000 98279.9n 0.80000 98280.0n 0.80000 98459.9n 0.80000 98460.0n 0.80000 98639.9n 0.80000 98640.0n 0.80000 98819.9n 0.80000 98820.0n 0.80000 98999.9n 0.80000 99000.0n 0.80000 99179.9n 0.80000 99180.0n 0.80000 99359.9n 0.80000 99360.0n 0.80000 99539.9n 0.80000 99540.0n 0.80000 99719.9n 0.80000 99720.0n 0.80000 99899.9n 0.80000 99900.0n 0.80000 100079.9n 0.80000 100080.0n 0.80000 100259.9n 0.80000 100260.0n 0.80000 100439.9n 0.80000 100440.0n 0.80000 100619.9n 0.80000 100620.0n 0.80000 100799.9n 0.80000 100800.0n 0.80000 100979.9n 0.80000 100980.0n 0.80000 101159.9n 0.80000 101160.0n 0.80000 101339.9n 0.80000 101340.0n 0.80000 101519.9n 0.80000 101520.0n 0.80000 101699.9n 0.80000 101700.0n 0.80000 101879.9n 0.80000 101880.0n 0.80000 102059.9n 0.80000 102060.0n 0.80000 102239.9n 0.80000 102240.0n 0.80000 102419.9n 0.80000 102420.0n 0.80000 102599.9n 0.80000 102600.0n 0.80000 102779.9n 0.80000 102780.0n 0.80000 102959.9n 0.80000 102960.0n 0.80000 103139.9n 0.80000 103140.0n 0.80000 103319.9n 0.80000 103320.0n 0.80000 103499.9n 0.80000 103500.0n 0.80000 103679.9n 0.80000 103680.0n 0.80000 103859.9n 0.80000 103860.0n 0.80000 104039.9n 0.80000 104040.0n 0.80000 104219.9n 0.80000 104220.0n 0.80000 104399.9n 0.80000 104400.0n 0.80000 104579.9n 0.80000 104580.0n 0.80000 104759.9n 0.80000 104760.0n 0.80000 104939.9n 0.80000 104940.0n 0.80000 105119.9n 0.80000 105120.0n 0.80000 105299.9n 0.80000 105300.0n 0.80000 105479.9n 0.80000 105480.0n 0.80000 105659.9n 0.80000 105660.0n 0.80000 105839.9n 0.80000 105840.0n 0.80000 106019.9n 0.80000 106020.0n 0.80000 106199.9n 0.80000 106200.0n 0.80000 106379.9n 0.80000 106380.0n 0.80000 106559.9n 0.80000 106560.0n 0.80000 106739.9n 0.80000 106740.0n 0.80000 106919.9n 0.80000 106920.0n 0.80000 107099.9n 0.80000 107100.0n 0.80000 107279.9n 0.80000 107280.0n 0.80000 107459.9n 0.80000 107460.0n 0.80000 107639.9n 0.80000 107640.0n 0.80000 107819.9n 0.80000 107820.0n 0.80000 107999.9n 0.80000 108000.0n 0.80000 108179.9n 0.80000 108180.0n 0.80000 108359.9n 0.80000 108360.0n 0.80000 108539.9n 0.80000 108540.0n 0.80000 108719.9n 0.80000 108720.0n 0.80000 108899.9n 0.80000 108900.0n 0.80000 109079.9n 0.80000 109080.0n 0.80000 109259.9n 0.80000 109260.0n 0.80000 109439.9n 0.80000 109440.0n 0.80000 109619.9n 0.80000 109620.0n 0.80000 109799.9n 0.80000 109800.0n 0.80000 109979.9n 0.80000 109980.0n 0.80000 110159.9n 0.80000 110160.0n 0.80000 110339.9n 0.80000 110340.0n 0.80000 110519.9n 0.80000 110520.0n 0.80000 110699.9n 0.80000 110700.0n 0.80000 110879.9n 0.80000 110880.0n 0.80000 111059.9n 0.80000 111060.0n 0.80000 111239.9n 0.80000 111240.0n 0.80000 111419.9n 0.80000 111420.0n 0.80000 111599.9n 0.80000 111600.0n 0.80000 111779.9n 0.80000 111780.0n 0.80000 111959.9n 0.80000 111960.0n 0.80000 112139.9n 0.80000 112140.0n 0.80000 112319.9n 0.80000 112320.0n 0.80000 112499.9n 0.80000 112500.0n 0.80000 112679.9n 0.80000 112680.0n 0.80000 112859.9n 0.80000 112860.0n 0.80000 113039.9n 0.80000 113040.0n 0.80000 113219.9n 0.80000 113220.0n 0.80000 113399.9n 0.80000 113400.0n 0.80000 113579.9n 0.80000 113580.0n 0.80000 113759.9n 0.80000 113760.0n 0.80000 113939.9n 0.80000 113940.0n 0.80000 114119.9n 0.80000 114120.0n 0.80000 114299.9n 0.80000 114300.0n 0.80000 114479.9n 0.80000 114480.0n 0.80000 114659.9n 0.80000 114660.0n 0.80000 114839.9n 0.80000 114840.0n 0.80000 115019.9n 0.80000 115020.0n 0.80000 115199.9n 0.80000 115200.0n 0.80000 115379.9n 0.80000 115380.0n 0.80000 115559.9n 0.80000 115560.0n 0.80000 115739.9n 0.80000 115740.0n 0.80000 115919.9n 0.80000 115920.0n 0.80000 116099.9n 0.80000 116100.0n 0.80000 116279.9n 0.80000 116280.0n 0.80000 116459.9n 0.80000 116460.0n 0.80000 116639.9n 0.80000 116640.0n 0.80000 116819.9n 0.80000 116820.0n 0.80000 116999.9n 0.80000 117000.0n 0.80000 117179.9n 0.80000 117180.0n 0.80000 117359.9n 0.80000 117360.0n 0.80000 117539.9n 0.80000 117540.0n 0.80000 117719.9n 0.80000 117720.0n 0.80000 117899.9n 0.80000 117900.0n 0.80000 118079.9n 0.80000 118080.0n 0.80000 118259.9n 0.80000 118260.0n 0.80000 118439.9n 0.80000 118440.0n 0.80000 118619.9n 0.80000 118620.0n 0.80000 118799.9n 0.80000 118800.0n 0.80000 118979.9n 0.80000 118980.0n 0.80000 119159.9n 0.80000 119160.0n 0.80000 119339.9n 0.80000 119340.0n 0.80000 119519.9n 0.80000 119520.0n 0.80000 119699.9n 0.80000 119700.0n 0.80000 119879.9n 0.80000 119880.0n 0.80000 120059.9n 0.80000 120060.0n 0.80000 120239.9n 0.80000 120240.0n 0.80000 120419.9n 0.80000 120420.0n 0.80000 120599.9n 0.80000 120600.0n 0.80000 120779.9n 0.80000 120780.0n 0.80000 120959.9n 0.80000 120960.0n 0.80000 121139.9n 0.80000 121140.0n 0.80000 121319.9n 0.80000 121320.0n 0.80000 121499.9n 0.80000 121500.0n 0.80000 121679.9n 0.80000 121680.0n 0.80000 121859.9n 0.80000 121860.0n 0.80000 122039.9n 0.80000 122040.0n 0.80000 122219.9n 0.80000 122220.0n 0.80000 122399.9n 0.80000 122400.0n 0.80000 122579.9n 0.80000 122580.0n 0.80000 122759.9n 0.80000 122760.0n 0.80000 122939.9n 0.80000 122940.0n 0.80000 123119.9n 0.80000 123120.0n 0.80000 123299.9n 0.80000 123300.0n 0.80000 123479.9n 0.80000 123480.0n 0.80000 123659.9n 0.80000 123660.0n 0.80000 123839.9n 0.80000 123840.0n 0.80000 124019.9n 0.80000 124020.0n 0.80000 124199.9n 0.80000 124200.0n 0.80000 124379.9n 0.80000 124380.0n 0.80000 124559.9n 0.80000 124560.0n 0.80000 124739.9n 0.80000 124740.0n 0.80000 124919.9n 0.80000 124920.0n 0.80000 125099.9n 0.80000 125100.0n 0.80000 125279.9n 0.80000 125280.0n 0.80000 125459.9n 0.80000 125460.0n 0.80000 125639.9n 0.80000 125640.0n 0.80000 125819.9n 0.80000 125820.0n 0.80000 125999.9n 0.80000 126000.0n 0.80000 126179.9n 0.80000 126180.0n 0.80000 126359.9n 0.80000 126360.0n 0.80000 126539.9n 0.80000 126540.0n 0.80000 126719.9n 0.80000 126720.0n 0.80000 126899.9n 0.80000 126900.0n 0.80000 127079.9n 0.80000 127080.0n 0.80000 127259.9n 0.80000 127260.0n 0.80000 127439.9n 0.80000 127440.0n 0.80000 127619.9n 0.80000 127620.0n 0.80000 127799.9n 0.80000 127800.0n 0.80000 127979.9n 0.80000 127980.0n 0.80000 128159.9n 0.80000 128160.0n 0.80000 128339.9n 0.80000 128340.0n 0.80000 128519.9n 0.80000 128520.0n 0.80000 128699.9n 0.80000 128700.0n 0.80000 128879.9n 0.80000 128880.0n 0.80000 129059.9n 0.80000 129060.0n 0.80000 129239.9n 0.80000 129240.0n 0.80000 129419.9n 0.80000 129420.0n 0.80000 129599.9n 0.80000 129600.0n 0.80000 129779.9n 0.80000 129780.0n 0.80000 129959.9n 0.80000 129960.0n 0.80000 130139.9n 0.80000 130140.0n 0.80000 130319.9n 0.80000 130320.0n 0.80000 130499.9n 0.80000 130500.0n 0.80000 130679.9n 0.80000 130680.0n 0.80000 130859.9n 0.80000 130860.0n 0.80000 131039.9n 0.80000 131040.0n 0.80000 131219.9n 0.80000 131220.0n 0.80000 131399.9n 0.80000 131400.0n 0.80000 131579.9n 0.80000 131580.0n 0.80000 131759.9n 0.80000 131760.0n 0.80000 131939.9n 0.80000 131940.0n 0.80000 132119.9n 0.80000 132120.0n 0.80000 132299.9n 0.80000 132300.0n 0.80000 132479.9n 0.80000 132480.0n 0.80000 132659.9n 0.80000 132660.0n 0.80000 132839.9n 0.80000 132840.0n 0.80000 133019.9n 0.80000 133020.0n 0.80000 133199.9n 0.80000 133200.0n 0.80000 133379.9n 0.80000 133380.0n 0.80000 133559.9n 0.80000 133560.0n 0.80000 133739.9n 0.80000 133740.0n 0.80000 133919.9n 0.80000 133920.0n 0.80000 134099.9n 0.80000 134100.0n 0.80000 134279.9n 0.80000 134280.0n 0.80000 134459.9n 0.80000 134460.0n 0.80000 134639.9n 0.80000 134640.0n 0.80000 134819.9n 0.80000 134820.0n 0.80000 134999.9n 0.80000 135000.0n 0.80000 135179.9n 0.80000 135180.0n 0.80000 135359.9n 0.80000 135360.0n 0.80000 135539.9n 0.80000 135540.0n 0.80000 135719.9n 0.80000 135720.0n 0.80000 135899.9n 0.80000 135900.0n 0.80000 136079.9n 0.80000 136080.0n 0.80000 136259.9n 0.80000 136260.0n 0.80000 136439.9n 0.80000 136440.0n 0.80000 136619.9n 0.80000 136620.0n 0.80000 136799.9n 0.80000 136800.0n 0.80000 136979.9n 0.80000 136980.0n 0.80000 137159.9n 0.80000 137160.0n 0.80000 137339.9n 0.80000 137340.0n 0.80000 137519.9n 0.80000 137520.0n 0.80000 137699.9n 0.80000 137700.0n 0.80000 137879.9n 0.80000 137880.0n 0.80000 138059.9n 0.80000 138060.0n 0.80000 138239.9n 0.80000 138240.0n 0.80000 138419.9n 0.80000 138420.0n 0.80000 138599.9n 0.80000 138600.0n 0.80000 138779.9n 0.80000 138780.0n 0.80000 138959.9n 0.80000 138960.0n 0.80000 139139.9n 0.80000 139140.0n 0.80000 139319.9n 0.80000 139320.0n 0.80000 139499.9n 0.80000 139500.0n 0.80000 139679.9n 0.80000 139680.0n 0.80000 139859.9n 0.80000 139860.0n 0.80000 140039.9n 0.80000 140040.0n 0.80000 140219.9n 0.80000 140220.0n 0.80000 140399.9n 0.80000 140400.0n 0.80000 140579.9n 0.80000 140580.0n 0.80000 140759.9n 0.80000 140760.0n 0.80000 140939.9n 0.80000 140940.0n 0.80000 141119.9n 0.80000 141120.0n 0.80000 141299.9n 0.80000 141300.0n 0.80000 141479.9n 0.80000 141480.0n 0.80000 141659.9n 0.80000 141660.0n 0.80000 141839.9n 0.80000 141840.0n 0.80000 142019.9n 0.80000 142020.0n 0.80000 142199.9n 0.80000 142200.0n 0.80000 142379.9n 0.80000 142380.0n 0.80000 142559.9n 0.80000 142560.0n 0.80000 142739.9n 0.80000 142740.0n 0.80000 142919.9n 0.80000 142920.0n 0.80000 143099.9n 0.80000 143100.0n 0.80000 143279.9n 0.80000 143280.0n 0.80000 143459.9n 0.80000 143460.0n 0.80000 143639.9n 0.80000 143640.0n 0.80000 143819.9n 0.80000 143820.0n 0.80000 143999.9n 0.80000 144000.0n 0.80000 144179.9n 0.80000 144180.0n 0.80000 144359.9n 0.80000 144360.0n 0.80000 144539.9n 0.80000 144540.0n 0.80000 144719.9n 0.80000 144720.0n 0.80000 144899.9n 0.80000 144900.0n 0.80000 145079.9n 0.80000 145080.0n 0.80000 145259.9n 0.80000 145260.0n 0.80000 145439.9n 0.80000 145440.0n 0.80000 145619.9n 0.80000 145620.0n 0.80000 145799.9n 0.80000 145800.0n 0.80000 145979.9n 0.80000 145980.0n 0.80000 146159.9n 0.80000 146160.0n 0.80000 146339.9n 0.80000 146340.0n 0.80000 146519.9n 0.80000 146520.0n 0.80000 146699.9n 0.80000 146700.0n 0.80000 146879.9n 0.80000 146880.0n 0.80000 147059.9n 0.80000 147060.0n 0.80000 147239.9n 0.80000 147240.0n 0.80000 147419.9n 0.80000 147420.0n 0.80000 147599.9n 0.80000 147600.0n 0.80000 147779.9n 0.80000 147780.0n 0.80000 147959.9n 0.80000 147960.0n 0.80000 148139.9n 0.80000 148140.0n 0.80000 148319.9n 0.80000 148320.0n 0.80000 148499.9n 0.80000 148500.0n 0.80000 148679.9n 0.80000 148680.0n 0.80000 148859.9n 0.80000 148860.0n 0.80000 149039.9n 0.80000 149040.0n 0.80000 149219.9n 0.80000 149220.0n 0.80000 149399.9n 0.80000 149400.0n 0.80000 149579.9n 0.80000 149580.0n 0.80000 149759.9n 0.80000 149760.0n 0.80000 149939.9n 0.80000 149940.0n 0.80000 150119.9n 0.80000 150120.0n 0.80000 150299.9n 0.80000 150300.0n 0.80000 150479.9n 0.80000 150480.0n 0.80000 150659.9n 0.80000 150660.0n 0.80000 150839.9n 0.80000 150840.0n 0.80000 151019.9n 0.80000 151020.0n 0.80000 151199.9n 0.80000 151200.0n 0.80000 151379.9n 0.80000 151380.0n 0.80000 151559.9n 0.80000 151560.0n 0.80000 151739.9n 0.80000 151740.0n 0.80000 151919.9n 0.80000 151920.0n 0.80000 152099.9n 0.80000 152100.0n 0.80000 152279.9n 0.80000 152280.0n 0.80000 152459.9n 0.80000 152460.0n 0.80000 152639.9n 0.80000 152640.0n 0.80000 152819.9n 0.80000 152820.0n 0.80000 152999.9n 0.80000 153000.0n 0.80000 153179.9n 0.80000 153180.0n 0.80000 153359.9n 0.80000 153360.0n 0.80000 153539.9n 0.80000 153540.0n 0.80000 153719.9n 0.80000 153720.0n 0.80000 153899.9n 0.80000 153900.0n 0.80000 154079.9n 0.80000 154080.0n 0.80000 154259.9n 0.80000 154260.0n 0.80000 154439.9n 0.80000 154440.0n 0.80000 154619.9n 0.80000 154620.0n 0.80000 154799.9n 0.80000 154800.0n 0.80000 154979.9n 0.80000 154980.0n 0.80000 155159.9n 0.80000 155160.0n 0.80000 155339.9n 0.80000 155340.0n 0.80000 155519.9n 0.80000 155520.0n 0.80000 155699.9n 0.80000 155700.0n 0.80000 155879.9n 0.80000 155880.0n 0.80000 156059.9n 0.80000 156060.0n 0.80000 156239.9n 0.80000 156240.0n 0.80000 156419.9n 0.80000 156420.0n 0.80000 156599.9n 0.80000 156600.0n 0.80000 156779.9n 0.80000 156780.0n 0.80000 156959.9n 0.80000 156960.0n 0.80000 157139.9n 0.80000 157140.0n 0.80000 157319.9n 0.80000 157320.0n 0.80000 157499.9n 0.80000 157500.0n 0.80000 157679.9n 0.80000 157680.0n 0.80000 157859.9n 0.80000 157860.0n 0.80000 158039.9n 0.80000 158040.0n 0.80000 158219.9n 0.80000 158220.0n 0.80000 158399.9n 0.80000 158400.0n 0.80000 158579.9n 0.80000 158580.0n 0.80000 158759.9n 0.80000 158760.0n 0.80000 158939.9n 0.80000 158940.0n 0.80000 159119.9n 0.80000 159120.0n 0.80000 159299.9n 0.80000 159300.0n 0.80000 159479.9n 0.80000 159480.0n 0.80000 159659.9n 0.80000 159660.0n 0.80000 159839.9n 0.80000 159840.0n 0.80000 160019.9n 0.80000 160020.0n 0.80000 160199.9n 0.80000 160200.0n 0.80000 160379.9n 0.80000 160380.0n 0.80000 160559.9n 0.80000 160560.0n 0.80000 160739.9n 0.80000 160740.0n 0.80000 160919.9n 0.80000 160920.0n 0.80000 161099.9n 0.80000 161100.0n 0.80000 161279.9n 0.80000 161280.0n 0.80000 161459.9n 0.80000 161460.0n 0.80000 161639.9n 0.80000 161640.0n 0.80000 161819.9n 0.80000 161820.0n 0.80000 161999.9n 0.80000 162000.0n 0.80000 162179.9n 0.80000 162180.0n 0.80000 162359.9n 0.80000 162360.0n 0.80000 162539.9n 0.80000 162540.0n 0.80000 162719.9n 0.80000 162720.0n 0.80000 162899.9n 0.80000 162900.0n 0.80000 163079.9n 0.80000 163080.0n 0.80000 163259.9n 0.80000 163260.0n 0.80000 163439.9n 0.80000 163440.0n 0.80000 163619.9n 0.80000 163620.0n 0.80000 163799.9n 0.80000 163800.0n 0.80000 163979.9n 0.80000 163980.0n 0.80000 164159.9n 0.80000 164160.0n 0.80000 164339.9n 0.80000 164340.0n 0.80000 164519.9n 0.80000 164520.0n 0.80000 164699.9n 0.80000 164700.0n 0.80000 164879.9n 0.80000 164880.0n 0.80000 165059.9n 0.80000 165060.0n 0.80000 165239.9n 0.80000 165240.0n 0.80000 165419.9n 0.80000 165420.0n 0.80000 165599.9n 0.80000 165600.0n 0.80000 165779.9n 0.80000 165780.0n 0.80000 165959.9n 0.80000 165960.0n 0.80000 166139.9n 0.80000 166140.0n 0.80000 166319.9n 0.80000 166320.0n 0.80000 166499.9n 0.80000 166500.0n 0.80000 166679.9n 0.80000 166680.0n 0.80000 166859.9n 0.80000 166860.0n 0.80000 167039.9n 0.80000 167040.0n 0.80000 167219.9n 0.80000 167220.0n 0.80000 167399.9n 0.80000 167400.0n 0.80000 167579.9n 0.80000 167580.0n 0.80000 167759.9n 0.80000 167760.0n 0.80000 167939.9n 0.80000 167940.0n 0.80000 168119.9n 0.80000 168120.0n 0.80000 168299.9n 0.80000 168300.0n 0.80000 168479.9n 0.80000 168480.0n 0.80000 168659.9n 0.80000 168660.0n 0.80000 168839.9n 0.80000 168840.0n 0.80000 169019.9n 0.80000 169020.0n 0.80000 169199.9n 0.80000 169200.0n 0.80000 169379.9n 0.80000 169380.0n 0.80000 169559.9n 0.80000 169560.0n 0.80000 169739.9n 0.80000 169740.0n 0.80000 169919.9n 0.80000 169920.0n 0.80000 170099.9n 0.80000 170100.0n 0.80000 170279.9n 0.80000 170280.0n 0.80000 170459.9n 0.80000 170460.0n 0.80000 170639.9n 0.80000 170640.0n 0.80000 170819.9n 0.80000 170820.0n 0.80000 170999.9n 0.80000 171000.0n 0.80000 171179.9n 0.80000 171180.0n 0.80000 171359.9n 0.80000 171360.0n 0.80000 171539.9n 0.80000 171540.0n 0.80000 171719.9n 0.80000 171720.0n 0.80000 171899.9n 0.80000 171900.0n 0.80000 172079.9n 0.80000 172080.0n 0.80000 172259.9n 0.80000 172260.0n 0.80000 172439.9n 0.80000 172440.0n 0.80000 172619.9n 0.80000 172620.0n 0.80000 172799.9n 0.80000 172800.0n 0.80000 172979.9n 0.80000 172980.0n 0.80000 173159.9n 0.80000 173160.0n 0.80000 173339.9n 0.80000 173340.0n 0.80000 173519.9n 0.80000 173520.0n 0.80000 173699.9n 0.80000 173700.0n 0.80000 173879.9n 0.80000 173880.0n 0.80000 174059.9n 0.80000 174060.0n 0.80000 174239.9n 0.80000 174240.0n 0.80000 174419.9n 0.80000 174420.0n 0.80000 174599.9n 0.80000 174600.0n 0.80000 174779.9n 0.80000 174780.0n 0.80000 174959.9n 0.80000 174960.0n 0.80000 175139.9n 0.80000 175140.0n 0.80000 175319.9n 0.80000 175320.0n 0.80000 175499.9n 0.80000 175500.0n 0.80000 175679.9n 0.80000 175680.0n 0.80000 175859.9n 0.80000 175860.0n 0.80000 176039.9n 0.80000 176040.0n 0.80000 176219.9n 0.80000 176220.0n 0.80000 176399.9n 0.80000 176400.0n 0.80000 176579.9n 0.80000 176580.0n 0.80000 176759.9n 0.80000 176760.0n 0.80000 176939.9n 0.80000 176940.0n 0.80000 177119.9n 0.80000 177120.0n 0.80000 177299.9n 0.80000 177300.0n 0.80000 177479.9n 0.80000 177480.0n 0.80000 177659.9n 0.80000 177660.0n 0.80000 177839.9n 0.80000 177840.0n 0.80000 178019.9n 0.80000 178020.0n 0.80000 178199.9n 0.80000 178200.0n 0.80000 178379.9n 0.80000 178380.0n 0.80000 178559.9n 0.80000 178560.0n 0.80000 178739.9n 0.80000 178740.0n 0.80000 178919.9n 0.80000 178920.0n 0.80000 179099.9n 0.80000 179100.0n 0.80000 179279.9n 0.80000 179280.0n 0.80000 179459.9n 0.80000 179460.0n 0.80000 179639.9n 0.80000 179640.0n 0.80000 179819.9n 0.80000 179820.0n 0.80000 179999.9n 0.80000 180000.0n 0.80000 180179.9n 0.80000 180180.0n 0.80000 180359.9n 0.80000 180360.0n 0.80000 180539.9n 0.80000 180540.0n 0.80000 180719.9n 0.80000 180720.0n 0.80000 180899.9n 0.80000 180900.0n 0.80000 181079.9n 0.80000 181080.0n 0.80000 181259.9n 0.80000 181260.0n 0.80000 181439.9n 0.80000 181440.0n 0.80000 181619.9n 0.80000 181620.0n 0.80000 181799.9n 0.80000 181800.0n 0.80000 181979.9n 0.80000 181980.0n 0.80000 182159.9n 0.80000 182160.0n 0.80000 182339.9n 0.80000 182340.0n 0.80000 182519.9n 0.80000 182520.0n 0.80000 182699.9n 0.80000 182700.0n 0.80000 182879.9n 0.80000 182880.0n 0.80000 183059.9n 0.80000 183060.0n 0.80000 183239.9n 0.80000 183240.0n 0.80000 183419.9n 0.80000 183420.0n 0.80000)
Vxn2 a_xn2 0 PWL(0.0n 0.20000 179.9n 0.20000 180.0n 0.20000 359.9n 0.20000 360.0n 0.20000 539.9n 0.20000 540.0n 0.20000 719.9n 0.20000 720.0n 0.20000 899.9n 0.20000 900.0n 0.20000 1079.9n 0.20000 1080.0n 0.20000 1259.9n 0.20000 1260.0n 0.20000 1439.9n 0.20000 1440.0n 0.20000 1619.9n 0.20000 1620.0n 0.20000 1799.9n 0.20000 1800.0n 0.20000 1979.9n 0.20000 1980.0n 0.20000 2159.9n 0.20000 2160.0n 0.20000 2339.9n 0.20000 2340.0n 0.20000 2519.9n 0.20000 2520.0n 0.20000 2699.9n 0.20000 2700.0n 0.20000 2879.9n 0.20000 2880.0n 0.20000 3059.9n 0.20000 3060.0n 0.20000 3239.9n 0.20000 3240.0n 0.20000 3419.9n 0.20000 3420.0n 0.20000 3599.9n 0.20000 3600.0n 0.20000 3779.9n 0.20000 3780.0n 0.20000 3959.9n 0.20000 3960.0n 0.20000 4139.9n 0.20000 4140.0n 0.20000 4319.9n 0.20000 4320.0n 0.20000 4499.9n 0.20000 4500.0n 0.20000 4679.9n 0.20000 4680.0n 0.20000 4859.9n 0.20000 4860.0n 0.20000 5039.9n 0.20000 5040.0n 0.20000 5219.9n 0.20000 5220.0n 0.20000 5399.9n 0.20000 5400.0n 0.20000 5579.9n 0.20000 5580.0n 0.20000 5759.9n 0.20000 5760.0n 0.20000 5939.9n 0.20000 5940.0n 0.20000 6119.9n 0.20000 6120.0n 0.20000 6299.9n 0.20000 6300.0n 0.20000 6479.9n 0.20000 6480.0n 0.20000 6659.9n 0.20000 6660.0n 0.20000 6839.9n 0.20000 6840.0n 0.20000 7019.9n 0.20000 7020.0n 0.20000 7199.9n 0.20000 7200.0n 0.20000 7379.9n 0.20000 7380.0n 0.20000 7559.9n 0.20000 7560.0n 0.20000 7739.9n 0.20000 7740.0n 0.20000 7919.9n 0.20000 7920.0n 0.20000 8099.9n 0.20000 8100.0n 0.20000 8279.9n 0.20000 8280.0n 0.20000 8459.9n 0.20000 8460.0n 0.20000 8639.9n 0.20000 8640.0n 0.20000 8819.9n 0.20000 8820.0n 0.20000 8999.9n 0.20000 9000.0n 0.20000 9179.9n 0.20000 9180.0n 0.20000 9359.9n 0.20000 9360.0n 0.20000 9539.9n 0.20000 9540.0n 0.20000 9719.9n 0.20000 9720.0n 0.20000 9899.9n 0.20000 9900.0n 0.20000 10079.9n 0.20000 10080.0n 0.20000 10259.9n 0.20000 10260.0n 0.20000 10439.9n 0.20000 10440.0n 0.20000 10619.9n 0.20000 10620.0n 0.20000 10799.9n 0.20000 10800.0n 0.20000 10979.9n 0.20000 10980.0n 0.20000 11159.9n 0.20000 11160.0n 0.20000 11339.9n 0.20000 11340.0n 0.20000 11519.9n 0.20000 11520.0n 0.20000 11699.9n 0.20000 11700.0n 0.20000 11879.9n 0.20000 11880.0n 0.20000 12059.9n 0.20000 12060.0n 0.20000 12239.9n 0.20000 12240.0n 0.20000 12419.9n 0.20000 12420.0n 0.20000 12599.9n 0.20000 12600.0n 0.20000 12779.9n 0.20000 12780.0n 0.20000 12959.9n 0.20000 12960.0n 0.20000 13139.9n 0.20000 13140.0n 0.20000 13319.9n 0.20000 13320.0n 0.20000 13499.9n 0.20000 13500.0n 0.20000 13679.9n 0.20000 13680.0n 0.20000 13859.9n 0.20000 13860.0n 0.20000 14039.9n 0.20000 14040.0n 0.20000 14219.9n 0.20000 14220.0n 0.20000 14399.9n 0.20000 14400.0n 0.20000 14579.9n 0.20000 14580.0n 0.20000 14759.9n 0.20000 14760.0n 0.20000 14939.9n 0.20000 14940.0n 0.20000 15119.9n 0.20000 15120.0n 0.20000 15299.9n 0.20000 15300.0n 0.20000 15479.9n 0.20000 15480.0n 0.20000 15659.9n 0.20000 15660.0n 0.20000 15839.9n 0.20000 15840.0n 0.20000 16019.9n 0.20000 16020.0n 0.20000 16199.9n 0.20000 16200.0n 0.20000 16379.9n 0.20000 16380.0n 0.20000 16559.9n 0.20000 16560.0n 0.20000 16739.9n 0.20000 16740.0n 0.20000 16919.9n 0.20000 16920.0n 0.20000 17099.9n 0.20000 17100.0n 0.20000 17279.9n 0.20000 17280.0n 0.20000 17459.9n 0.20000 17460.0n 0.20000 17639.9n 0.20000 17640.0n 0.20000 17819.9n 0.20000 17820.0n 0.20000 17999.9n 0.20000 18000.0n 0.20000 18179.9n 0.20000 18180.0n 0.20000 18359.9n 0.20000 18360.0n 0.20000 18539.9n 0.20000 18540.0n 0.20000 18719.9n 0.20000 18720.0n 0.20000 18899.9n 0.20000 18900.0n 0.20000 19079.9n 0.20000 19080.0n 0.20000 19259.9n 0.20000 19260.0n 0.20000 19439.9n 0.20000 19440.0n 0.20000 19619.9n 0.20000 19620.0n 0.20000 19799.9n 0.20000 19800.0n 0.20000 19979.9n 0.20000 19980.0n 0.20000 20159.9n 0.20000 20160.0n 0.20000 20339.9n 0.20000 20340.0n 0.20000 20519.9n 0.20000 20520.0n 0.20000 20699.9n 0.20000 20700.0n 0.20000 20879.9n 0.20000 20880.0n 0.20000 21059.9n 0.20000 21060.0n 0.20000 21239.9n 0.20000 21240.0n 0.20000 21419.9n 0.20000 21420.0n 0.20000 21599.9n 0.20000 21600.0n 0.20000 21779.9n 0.20000 21780.0n 0.20000 21959.9n 0.20000 21960.0n 0.20000 22139.9n 0.20000 22140.0n 0.20000 22319.9n 0.20000 22320.0n 0.20000 22499.9n 0.20000 22500.0n 0.20000 22679.9n 0.20000 22680.0n 0.20000 22859.9n 0.20000 22860.0n 0.20000 23039.9n 0.20000 23040.0n 0.20000 23219.9n 0.20000 23220.0n 0.20000 23399.9n 0.20000 23400.0n 0.20000 23579.9n 0.20000 23580.0n 0.20000 23759.9n 0.20000 23760.0n 0.20000 23939.9n 0.20000 23940.0n 0.20000 24119.9n 0.20000 24120.0n 0.20000 24299.9n 0.20000 24300.0n 0.20000 24479.9n 0.20000 24480.0n 0.20000 24659.9n 0.20000 24660.0n 0.20000 24839.9n 0.20000 24840.0n 0.20000 25019.9n 0.20000 25020.0n 0.20000 25199.9n 0.20000 25200.0n 0.20000 25379.9n 0.20000 25380.0n 0.20000 25559.9n 0.20000 25560.0n 0.20000 25739.9n 0.20000 25740.0n 0.20000 25919.9n 0.20000 25920.0n 0.20000 26099.9n 0.20000 26100.0n 0.20000 26279.9n 0.20000 26280.0n 0.20000 26459.9n 0.20000 26460.0n 0.20000 26639.9n 0.20000 26640.0n 0.20000 26819.9n 0.20000 26820.0n 0.20000 26999.9n 0.20000 27000.0n 0.20000 27179.9n 0.20000 27180.0n 0.20000 27359.9n 0.20000 27360.0n 0.20000 27539.9n 0.20000 27540.0n 0.20000 27719.9n 0.20000 27720.0n 0.20000 27899.9n 0.20000 27900.0n 0.20000 28079.9n 0.20000 28080.0n 0.20000 28259.9n 0.20000 28260.0n 0.20000 28439.9n 0.20000 28440.0n 0.20000 28619.9n 0.20000 28620.0n 0.20000 28799.9n 0.20000 28800.0n 0.20000 28979.9n 0.20000 28980.0n 0.20000 29159.9n 0.20000 29160.0n 0.20000 29339.9n 0.20000 29340.0n 0.20000 29519.9n 0.20000 29520.0n 0.20000 29699.9n 0.20000 29700.0n 0.20000 29879.9n 0.20000 29880.0n 0.20000 30059.9n 0.20000 30060.0n 0.20000 30239.9n 0.20000 30240.0n 0.20000 30419.9n 0.20000 30420.0n 0.20000 30599.9n 0.20000 30600.0n 0.20000 30779.9n 0.20000 30780.0n 0.20000 30959.9n 0.20000 30960.0n 0.20000 31139.9n 0.20000 31140.0n 0.20000 31319.9n 0.20000 31320.0n 0.20000 31499.9n 0.20000 31500.0n 0.20000 31679.9n 0.20000 31680.0n 0.20000 31859.9n 0.20000 31860.0n 0.20000 32039.9n 0.20000 32040.0n 0.20000 32219.9n 0.20000 32220.0n 0.20000 32399.9n 0.20000 32400.0n 0.20000 32579.9n 0.20000 32580.0n 0.20000 32759.9n 0.20000 32760.0n 0.20000 32939.9n 0.20000 32940.0n 0.20000 33119.9n 0.20000 33120.0n 0.20000 33299.9n 0.20000 33300.0n 0.20000 33479.9n 0.20000 33480.0n 0.20000 33659.9n 0.20000 33660.0n 0.20000 33839.9n 0.20000 33840.0n 0.20000 34019.9n 0.20000 34020.0n 0.20000 34199.9n 0.20000 34200.0n 0.20000 34379.9n 0.20000 34380.0n 0.20000 34559.9n 0.20000 34560.0n 0.20000 34739.9n 0.20000 34740.0n 0.20000 34919.9n 0.20000 34920.0n 0.20000 35099.9n 0.20000 35100.0n 0.20000 35279.9n 0.20000 35280.0n 0.20000 35459.9n 0.20000 35460.0n 0.20000 35639.9n 0.20000 35640.0n 0.20000 35819.9n 0.20000 35820.0n 0.20000 35999.9n 0.20000 36000.0n 0.20000 36179.9n 0.20000 36180.0n 0.20000 36359.9n 0.20000 36360.0n 0.20000 36539.9n 0.20000 36540.0n 0.20000 36719.9n 0.20000 36720.0n 0.20000 36899.9n 0.20000 36900.0n 0.20000 37079.9n 0.20000 37080.0n 0.20000 37259.9n 0.20000 37260.0n 0.20000 37439.9n 0.20000 37440.0n 0.20000 37619.9n 0.20000 37620.0n 0.20000 37799.9n 0.20000 37800.0n 0.20000 37979.9n 0.20000 37980.0n 0.20000 38159.9n 0.20000 38160.0n 0.20000 38339.9n 0.20000 38340.0n 0.20000 38519.9n 0.20000 38520.0n 0.20000 38699.9n 0.20000 38700.0n 0.20000 38879.9n 0.20000 38880.0n 0.20000 39059.9n 0.20000 39060.0n 0.20000 39239.9n 0.20000 39240.0n 0.20000 39419.9n 0.20000 39420.0n 0.20000 39599.9n 0.20000 39600.0n 0.20000 39779.9n 0.20000 39780.0n 0.20000 39959.9n 0.20000 39960.0n 0.20000 40139.9n 0.20000 40140.0n 0.20000 40319.9n 0.20000 40320.0n 0.20000 40499.9n 0.20000 40500.0n 0.20000 40679.9n 0.20000 40680.0n 0.20000 40859.9n 0.20000 40860.0n 0.20000 41039.9n 0.20000 41040.0n 0.20000 41219.9n 0.20000 41220.0n 0.20000 41399.9n 0.20000 41400.0n 0.20000 41579.9n 0.20000 41580.0n 0.20000 41759.9n 0.20000 41760.0n 0.20000 41939.9n 0.20000 41940.0n 0.20000 42119.9n 0.20000 42120.0n 0.20000 42299.9n 0.20000 42300.0n 0.20000 42479.9n 0.20000 42480.0n 0.20000 42659.9n 0.20000 42660.0n 0.20000 42839.9n 0.20000 42840.0n 0.20000 43019.9n 0.20000 43020.0n 0.20000 43199.9n 0.20000 43200.0n 0.20000 43379.9n 0.20000 43380.0n 0.20000 43559.9n 0.20000 43560.0n 0.20000 43739.9n 0.20000 43740.0n 0.20000 43919.9n 0.20000 43920.0n 0.20000 44099.9n 0.20000 44100.0n 0.20000 44279.9n 0.20000 44280.0n 0.20000 44459.9n 0.20000 44460.0n 0.20000 44639.9n 0.20000 44640.0n 0.20000 44819.9n 0.20000 44820.0n 0.20000 44999.9n 0.20000 45000.0n 0.20000 45179.9n 0.20000 45180.0n 0.20000 45359.9n 0.20000 45360.0n 0.20000 45539.9n 0.20000 45540.0n 0.20000 45719.9n 0.20000 45720.0n 0.20000 45899.9n 0.20000 45900.0n 0.20000 46079.9n 0.20000 46080.0n 0.20000 46259.9n 0.20000 46260.0n 0.20000 46439.9n 0.20000 46440.0n 0.20000 46619.9n 0.20000 46620.0n 0.20000 46799.9n 0.20000 46800.0n 0.20000 46979.9n 0.20000 46980.0n 0.20000 47159.9n 0.20000 47160.0n 0.20000 47339.9n 0.20000 47340.0n 0.20000 47519.9n 0.20000 47520.0n 0.20000 47699.9n 0.20000 47700.0n 0.20000 47879.9n 0.20000 47880.0n 0.20000 48059.9n 0.20000 48060.0n 0.20000 48239.9n 0.20000 48240.0n 0.20000 48419.9n 0.20000 48420.0n 0.20000 48599.9n 0.20000 48600.0n 0.20000 48779.9n 0.20000 48780.0n 0.20000 48959.9n 0.20000 48960.0n 0.20000 49139.9n 0.20000 49140.0n 0.20000 49319.9n 0.20000 49320.0n 0.20000 49499.9n 0.20000 49500.0n 0.20000 49679.9n 0.20000 49680.0n 0.20000 49859.9n 0.20000 49860.0n 0.20000 50039.9n 0.20000 50040.0n 0.20000 50219.9n 0.20000 50220.0n 0.20000 50399.9n 0.20000 50400.0n 0.20000 50579.9n 0.20000 50580.0n 0.20000 50759.9n 0.20000 50760.0n 0.20000 50939.9n 0.20000 50940.0n 0.20000 51119.9n 0.20000 51120.0n 0.20000 51299.9n 0.20000 51300.0n 0.20000 51479.9n 0.20000 51480.0n 0.20000 51659.9n 0.20000 51660.0n 0.20000 51839.9n 0.20000 51840.0n 0.20000 52019.9n 0.20000 52020.0n 0.20000 52199.9n 0.20000 52200.0n 0.20000 52379.9n 0.20000 52380.0n 0.20000 52559.9n 0.20000 52560.0n 0.20000 52739.9n 0.20000 52740.0n 0.20000 52919.9n 0.20000 52920.0n 0.20000 53099.9n 0.20000 53100.0n 0.20000 53279.9n 0.20000 53280.0n 0.20000 53459.9n 0.20000 53460.0n 0.20000 53639.9n 0.20000 53640.0n 0.20000 53819.9n 0.20000 53820.0n 0.20000 53999.9n 0.20000 54000.0n 0.20000 54179.9n 0.20000 54180.0n 0.20000 54359.9n 0.20000 54360.0n 0.20000 54539.9n 0.20000 54540.0n 0.20000 54719.9n 0.20000 54720.0n 0.20000 54899.9n 0.20000 54900.0n 0.20000 55079.9n 0.20000 55080.0n 0.20000 55259.9n 0.20000 55260.0n 0.20000 55439.9n 0.20000 55440.0n 0.20000 55619.9n 0.20000 55620.0n 0.20000 55799.9n 0.20000 55800.0n 0.20000 55979.9n 0.20000 55980.0n 0.20000 56159.9n 0.20000 56160.0n 0.20000 56339.9n 0.20000 56340.0n 0.20000 56519.9n 0.20000 56520.0n 0.20000 56699.9n 0.20000 56700.0n 0.20000 56879.9n 0.20000 56880.0n 0.20000 57059.9n 0.20000 57060.0n 0.20000 57239.9n 0.20000 57240.0n 0.20000 57419.9n 0.20000 57420.0n 0.20000 57599.9n 0.20000 57600.0n 0.20000 57779.9n 0.20000 57780.0n 0.20000 57959.9n 0.20000 57960.0n 0.20000 58139.9n 0.20000 58140.0n 0.20000 58319.9n 0.20000 58320.0n 0.20000 58499.9n 0.20000 58500.0n 0.20000 58679.9n 0.20000 58680.0n 0.20000 58859.9n 0.20000 58860.0n 0.20000 59039.9n 0.20000 59040.0n 0.20000 59219.9n 0.20000 59220.0n 0.20000 59399.9n 0.20000 59400.0n 0.20000 59579.9n 0.20000 59580.0n 0.20000 59759.9n 0.20000 59760.0n 0.20000 59939.9n 0.20000 59940.0n 0.20000 60119.9n 0.20000 60120.0n 0.20000 60299.9n 0.20000 60300.0n 0.20000 60479.9n 0.20000 60480.0n 0.20000 60659.9n 0.20000 60660.0n 0.20000 60839.9n 0.20000 60840.0n 0.20000 61019.9n 0.20000 61020.0n 0.20000 61199.9n 0.20000 61200.0n 0.20000 61379.9n 0.20000 61380.0n 0.20000 61559.9n 0.20000 61560.0n 0.20000 61739.9n 0.20000 61740.0n 0.20000 61919.9n 0.20000 61920.0n 0.20000 62099.9n 0.20000 62100.0n 0.20000 62279.9n 0.20000 62280.0n 0.20000 62459.9n 0.20000 62460.0n 0.20000 62639.9n 0.20000 62640.0n 0.20000 62819.9n 0.20000 62820.0n 0.20000 62999.9n 0.20000 63000.0n 0.20000 63179.9n 0.20000 63180.0n 0.20000 63359.9n 0.20000 63360.0n 0.20000 63539.9n 0.20000 63540.0n 0.20000 63719.9n 0.20000 63720.0n 0.20000 63899.9n 0.20000 63900.0n 0.20000 64079.9n 0.20000 64080.0n 0.20000 64259.9n 0.20000 64260.0n 0.20000 64439.9n 0.20000 64440.0n 0.20000 64619.9n 0.20000 64620.0n 0.20000 64799.9n 0.20000 64800.0n 0.20000 64979.9n 0.20000 64980.0n 0.20000 65159.9n 0.20000 65160.0n 0.20000 65339.9n 0.20000 65340.0n 0.20000 65519.9n 0.20000 65520.0n 0.20000 65699.9n 0.20000 65700.0n 0.20000 65879.9n 0.20000 65880.0n 0.20000 66059.9n 0.20000 66060.0n 0.20000 66239.9n 0.20000 66240.0n 0.20000 66419.9n 0.20000 66420.0n 0.20000 66599.9n 0.20000 66600.0n 0.20000 66779.9n 0.20000 66780.0n 0.20000 66959.9n 0.20000 66960.0n 0.20000 67139.9n 0.20000 67140.0n 0.20000 67319.9n 0.20000 67320.0n 0.20000 67499.9n 0.20000 67500.0n 0.20000 67679.9n 0.20000 67680.0n 0.20000 67859.9n 0.20000 67860.0n 0.20000 68039.9n 0.20000 68040.0n 0.20000 68219.9n 0.20000 68220.0n 0.20000 68399.9n 0.20000 68400.0n 0.20000 68579.9n 0.20000 68580.0n 0.20000 68759.9n 0.20000 68760.0n 0.20000 68939.9n 0.20000 68940.0n 0.20000 69119.9n 0.20000 69120.0n 0.20000 69299.9n 0.20000 69300.0n 0.20000 69479.9n 0.20000 69480.0n 0.20000 69659.9n 0.20000 69660.0n 0.20000 69839.9n 0.20000 69840.0n 0.20000 70019.9n 0.20000 70020.0n 0.20000 70199.9n 0.20000 70200.0n 0.20000 70379.9n 0.20000 70380.0n 0.20000 70559.9n 0.20000 70560.0n 0.20000 70739.9n 0.20000 70740.0n 0.20000 70919.9n 0.20000 70920.0n 0.20000 71099.9n 0.20000 71100.0n 0.20000 71279.9n 0.20000 71280.0n 0.20000 71459.9n 0.20000 71460.0n 0.20000 71639.9n 0.20000 71640.0n 0.20000 71819.9n 0.20000 71820.0n 0.20000 71999.9n 0.20000 72000.0n 0.20000 72179.9n 0.20000 72180.0n 0.20000 72359.9n 0.20000 72360.0n 0.20000 72539.9n 0.20000 72540.0n 0.20000 72719.9n 0.20000 72720.0n 0.20000 72899.9n 0.20000 72900.0n 0.20000 73079.9n 0.20000 73080.0n 0.20000 73259.9n 0.20000 73260.0n 0.20000 73439.9n 0.20000 73440.0n 0.20000 73619.9n 0.20000 73620.0n 0.20000 73799.9n 0.20000 73800.0n 0.20000 73979.9n 0.20000 73980.0n 0.20000 74159.9n 0.20000 74160.0n 0.20000 74339.9n 0.20000 74340.0n 0.20000 74519.9n 0.20000 74520.0n 0.20000 74699.9n 0.20000 74700.0n 0.20000 74879.9n 0.20000 74880.0n 0.20000 75059.9n 0.20000 75060.0n 0.20000 75239.9n 0.20000 75240.0n 0.20000 75419.9n 0.20000 75420.0n 0.20000 75599.9n 0.20000 75600.0n 0.20000 75779.9n 0.20000 75780.0n 0.20000 75959.9n 0.20000 75960.0n 0.20000 76139.9n 0.20000 76140.0n 0.20000 76319.9n 0.20000 76320.0n 0.20000 76499.9n 0.20000 76500.0n 0.20000 76679.9n 0.20000 76680.0n 0.20000 76859.9n 0.20000 76860.0n 0.20000 77039.9n 0.20000 77040.0n 0.20000 77219.9n 0.20000 77220.0n 0.20000 77399.9n 0.20000 77400.0n 0.20000 77579.9n 0.20000 77580.0n 0.20000 77759.9n 0.20000 77760.0n 0.20000 77939.9n 0.20000 77940.0n 0.20000 78119.9n 0.20000 78120.0n 0.20000 78299.9n 0.20000 78300.0n 0.20000 78479.9n 0.20000 78480.0n 0.20000 78659.9n 0.20000 78660.0n 0.20000 78839.9n 0.20000 78840.0n 0.20000 79019.9n 0.20000 79020.0n 0.20000 79199.9n 0.20000 79200.0n 0.20000 79379.9n 0.20000 79380.0n 0.20000 79559.9n 0.20000 79560.0n 0.20000 79739.9n 0.20000 79740.0n 0.20000 79919.9n 0.20000 79920.0n 0.20000 80099.9n 0.20000 80100.0n 0.20000 80279.9n 0.20000 80280.0n 0.20000 80459.9n 0.20000 80460.0n 0.20000 80639.9n 0.20000 80640.0n 0.20000 80819.9n 0.20000 80820.0n 0.20000 80999.9n 0.20000 81000.0n 0.20000 81179.9n 0.20000 81180.0n 0.20000 81359.9n 0.20000 81360.0n 0.20000 81539.9n 0.20000 81540.0n 0.20000 81719.9n 0.20000 81720.0n 0.20000 81899.9n 0.20000 81900.0n 0.20000 82079.9n 0.20000 82080.0n 0.20000 82259.9n 0.20000 82260.0n 0.20000 82439.9n 0.20000 82440.0n 0.20000 82619.9n 0.20000 82620.0n 0.20000 82799.9n 0.20000 82800.0n 0.20000 82979.9n 0.20000 82980.0n 0.20000 83159.9n 0.20000 83160.0n 0.20000 83339.9n 0.20000 83340.0n 0.20000 83519.9n 0.20000 83520.0n 0.20000 83699.9n 0.20000 83700.0n 0.20000 83879.9n 0.20000 83880.0n 0.20000 84059.9n 0.20000 84060.0n 0.20000 84239.9n 0.20000 84240.0n 0.20000 84419.9n 0.20000 84420.0n 0.20000 84599.9n 0.20000 84600.0n 0.20000 84779.9n 0.20000 84780.0n 0.20000 84959.9n 0.20000 84960.0n 0.20000 85139.9n 0.20000 85140.0n 0.20000 85319.9n 0.20000 85320.0n 0.20000 85499.9n 0.20000 85500.0n 0.20000 85679.9n 0.20000 85680.0n 0.20000 85859.9n 0.20000 85860.0n 0.20000 86039.9n 0.20000 86040.0n 0.20000 86219.9n 0.20000 86220.0n 0.20000 86399.9n 0.20000 86400.0n 0.20000 86579.9n 0.20000 86580.0n 0.20000 86759.9n 0.20000 86760.0n 0.20000 86939.9n 0.20000 86940.0n 0.20000 87119.9n 0.20000 87120.0n 0.20000 87299.9n 0.20000 87300.0n 0.20000 87479.9n 0.20000 87480.0n 0.20000 87659.9n 0.20000 87660.0n 0.20000 87839.9n 0.20000 87840.0n 0.20000 88019.9n 0.20000 88020.0n 0.20000 88199.9n 0.20000 88200.0n 0.20000 88379.9n 0.20000 88380.0n 0.20000 88559.9n 0.20000 88560.0n 0.20000 88739.9n 0.20000 88740.0n 0.20000 88919.9n 0.20000 88920.0n 0.20000 89099.9n 0.20000 89100.0n 0.20000 89279.9n 0.20000 89280.0n 0.20000 89459.9n 0.20000 89460.0n 0.20000 89639.9n 0.20000 89640.0n 0.20000 89819.9n 0.20000 89820.0n 0.20000 89999.9n 0.20000 90000.0n 0.20000 90179.9n 0.20000 90180.0n 0.20000 90359.9n 0.20000 90360.0n 0.20000 90539.9n 0.20000 90540.0n 0.20000 90719.9n 0.20000 90720.0n 0.20000 90899.9n 0.20000 90900.0n 0.20000 91079.9n 0.20000 91080.0n 0.20000 91259.9n 0.20000 91260.0n 0.20000 91439.9n 0.20000 91440.0n 0.20000 91619.9n 0.20000 91620.0n 0.20000 91799.9n 0.20000 91800.0n 0.20000 91979.9n 0.20000 91980.0n 0.20000 92159.9n 0.20000 92160.0n 0.20000 92339.9n 0.20000 92340.0n 0.20000 92519.9n 0.20000 92520.0n 0.20000 92699.9n 0.20000 92700.0n 0.20000 92879.9n 0.20000 92880.0n 0.20000 93059.9n 0.20000 93060.0n 0.20000 93239.9n 0.20000 93240.0n 0.20000 93419.9n 0.20000 93420.0n 0.20000 93599.9n 0.20000 93600.0n 0.20000 93779.9n 0.20000 93780.0n 0.20000 93959.9n 0.20000 93960.0n 0.20000 94139.9n 0.20000 94140.0n 0.20000 94319.9n 0.20000 94320.0n 0.20000 94499.9n 0.20000 94500.0n 0.20000 94679.9n 0.20000 94680.0n 0.20000 94859.9n 0.20000 94860.0n 0.20000 95039.9n 0.20000 95040.0n 0.20000 95219.9n 0.20000 95220.0n 0.20000 95399.9n 0.20000 95400.0n 0.20000 95579.9n 0.20000 95580.0n 0.20000 95759.9n 0.20000 95760.0n 0.20000 95939.9n 0.20000 95940.0n 0.20000 96119.9n 0.20000 96120.0n 0.20000 96299.9n 0.20000 96300.0n 0.20000 96479.9n 0.20000 96480.0n 0.20000 96659.9n 0.20000 96660.0n 0.20000 96839.9n 0.20000 96840.0n 0.20000 97019.9n 0.20000 97020.0n 0.20000 97199.9n 0.20000 97200.0n 0.20000 97379.9n 0.20000 97380.0n 0.20000 97559.9n 0.20000 97560.0n 0.20000 97739.9n 0.20000 97740.0n 0.20000 97919.9n 0.20000 97920.0n 0.20000 98099.9n 0.20000 98100.0n 0.20000 98279.9n 0.20000 98280.0n 0.20000 98459.9n 0.20000 98460.0n 0.20000 98639.9n 0.20000 98640.0n 0.20000 98819.9n 0.20000 98820.0n 0.20000 98999.9n 0.20000 99000.0n 0.20000 99179.9n 0.20000 99180.0n 0.20000 99359.9n 0.20000 99360.0n 0.20000 99539.9n 0.20000 99540.0n 0.20000 99719.9n 0.20000 99720.0n 0.20000 99899.9n 0.20000 99900.0n 0.20000 100079.9n 0.20000 100080.0n 0.20000 100259.9n 0.20000 100260.0n 0.20000 100439.9n 0.20000 100440.0n 0.20000 100619.9n 0.20000 100620.0n 0.20000 100799.9n 0.20000 100800.0n 0.20000 100979.9n 0.20000 100980.0n 0.20000 101159.9n 0.20000 101160.0n 0.20000 101339.9n 0.20000 101340.0n 0.20000 101519.9n 0.20000 101520.0n 0.20000 101699.9n 0.20000 101700.0n 0.20000 101879.9n 0.20000 101880.0n 0.20000 102059.9n 0.20000 102060.0n 0.20000 102239.9n 0.20000 102240.0n 0.20000 102419.9n 0.20000 102420.0n 0.20000 102599.9n 0.20000 102600.0n 0.20000 102779.9n 0.20000 102780.0n 0.20000 102959.9n 0.20000 102960.0n 0.20000 103139.9n 0.20000 103140.0n 0.20000 103319.9n 0.20000 103320.0n 0.20000 103499.9n 0.20000 103500.0n 0.20000 103679.9n 0.20000 103680.0n 0.20000 103859.9n 0.20000 103860.0n 0.20000 104039.9n 0.20000 104040.0n 0.20000 104219.9n 0.20000 104220.0n 0.20000 104399.9n 0.20000 104400.0n 0.20000 104579.9n 0.20000 104580.0n 0.20000 104759.9n 0.20000 104760.0n 0.20000 104939.9n 0.20000 104940.0n 0.20000 105119.9n 0.20000 105120.0n 0.20000 105299.9n 0.20000 105300.0n 0.20000 105479.9n 0.20000 105480.0n 0.20000 105659.9n 0.20000 105660.0n 0.20000 105839.9n 0.20000 105840.0n 0.20000 106019.9n 0.20000 106020.0n 0.20000 106199.9n 0.20000 106200.0n 0.20000 106379.9n 0.20000 106380.0n 0.20000 106559.9n 0.20000 106560.0n 0.20000 106739.9n 0.20000 106740.0n 0.20000 106919.9n 0.20000 106920.0n 0.20000 107099.9n 0.20000 107100.0n 0.20000 107279.9n 0.20000 107280.0n 0.20000 107459.9n 0.20000 107460.0n 0.20000 107639.9n 0.20000 107640.0n 0.20000 107819.9n 0.20000 107820.0n 0.20000 107999.9n 0.20000 108000.0n 0.20000 108179.9n 0.20000 108180.0n 0.20000 108359.9n 0.20000 108360.0n 0.20000 108539.9n 0.20000 108540.0n 0.20000 108719.9n 0.20000 108720.0n 0.20000 108899.9n 0.20000 108900.0n 0.20000 109079.9n 0.20000 109080.0n 0.20000 109259.9n 0.20000 109260.0n 0.20000 109439.9n 0.20000 109440.0n 0.20000 109619.9n 0.20000 109620.0n 0.20000 109799.9n 0.20000 109800.0n 0.20000 109979.9n 0.20000 109980.0n 0.20000 110159.9n 0.20000 110160.0n 0.20000 110339.9n 0.20000 110340.0n 0.20000 110519.9n 0.20000 110520.0n 0.20000 110699.9n 0.20000 110700.0n 0.20000 110879.9n 0.20000 110880.0n 0.20000 111059.9n 0.20000 111060.0n 0.20000 111239.9n 0.20000 111240.0n 0.20000 111419.9n 0.20000 111420.0n 0.20000 111599.9n 0.20000 111600.0n 0.20000 111779.9n 0.20000 111780.0n 0.20000 111959.9n 0.20000 111960.0n 0.20000 112139.9n 0.20000 112140.0n 0.20000 112319.9n 0.20000 112320.0n 0.20000 112499.9n 0.20000 112500.0n 0.20000 112679.9n 0.20000 112680.0n 0.20000 112859.9n 0.20000 112860.0n 0.20000 113039.9n 0.20000 113040.0n 0.20000 113219.9n 0.20000 113220.0n 0.20000 113399.9n 0.20000 113400.0n 0.20000 113579.9n 0.20000 113580.0n 0.20000 113759.9n 0.20000 113760.0n 0.20000 113939.9n 0.20000 113940.0n 0.20000 114119.9n 0.20000 114120.0n 0.20000 114299.9n 0.20000 114300.0n 0.20000 114479.9n 0.20000 114480.0n 0.20000 114659.9n 0.20000 114660.0n 0.20000 114839.9n 0.20000 114840.0n 0.20000 115019.9n 0.20000 115020.0n 0.20000 115199.9n 0.20000 115200.0n 0.20000 115379.9n 0.20000 115380.0n 0.20000 115559.9n 0.20000 115560.0n 0.20000 115739.9n 0.20000 115740.0n 0.20000 115919.9n 0.20000 115920.0n 0.20000 116099.9n 0.20000 116100.0n 0.20000 116279.9n 0.20000 116280.0n 0.20000 116459.9n 0.20000 116460.0n 0.20000 116639.9n 0.20000 116640.0n 0.20000 116819.9n 0.20000 116820.0n 0.20000 116999.9n 0.20000 117000.0n 0.20000 117179.9n 0.20000 117180.0n 0.20000 117359.9n 0.20000 117360.0n 0.20000 117539.9n 0.20000 117540.0n 0.20000 117719.9n 0.20000 117720.0n 0.20000 117899.9n 0.20000 117900.0n 0.20000 118079.9n 0.20000 118080.0n 0.20000 118259.9n 0.20000 118260.0n 0.20000 118439.9n 0.20000 118440.0n 0.20000 118619.9n 0.20000 118620.0n 0.20000 118799.9n 0.20000 118800.0n 0.20000 118979.9n 0.20000 118980.0n 0.20000 119159.9n 0.20000 119160.0n 0.20000 119339.9n 0.20000 119340.0n 0.20000 119519.9n 0.20000 119520.0n 0.20000 119699.9n 0.20000 119700.0n 0.20000 119879.9n 0.20000 119880.0n 0.20000 120059.9n 0.20000 120060.0n 0.20000 120239.9n 0.20000 120240.0n 0.20000 120419.9n 0.20000 120420.0n 0.20000 120599.9n 0.20000 120600.0n 0.20000 120779.9n 0.20000 120780.0n 0.20000 120959.9n 0.20000 120960.0n 0.20000 121139.9n 0.20000 121140.0n 0.20000 121319.9n 0.20000 121320.0n 0.20000 121499.9n 0.20000 121500.0n 0.20000 121679.9n 0.20000 121680.0n 0.20000 121859.9n 0.20000 121860.0n 0.20000 122039.9n 0.20000 122040.0n 0.20000 122219.9n 0.20000 122220.0n 0.20000 122399.9n 0.20000 122400.0n 0.20000 122579.9n 0.20000 122580.0n 0.20000 122759.9n 0.20000 122760.0n 0.20000 122939.9n 0.20000 122940.0n 0.20000 123119.9n 0.20000 123120.0n 0.20000 123299.9n 0.20000 123300.0n 0.20000 123479.9n 0.20000 123480.0n 0.20000 123659.9n 0.20000 123660.0n 0.20000 123839.9n 0.20000 123840.0n 0.20000 124019.9n 0.20000 124020.0n 0.20000 124199.9n 0.20000 124200.0n 0.20000 124379.9n 0.20000 124380.0n 0.20000 124559.9n 0.20000 124560.0n 0.20000 124739.9n 0.20000 124740.0n 0.20000 124919.9n 0.20000 124920.0n 0.20000 125099.9n 0.20000 125100.0n 0.20000 125279.9n 0.20000 125280.0n 0.20000 125459.9n 0.20000 125460.0n 0.20000 125639.9n 0.20000 125640.0n 0.20000 125819.9n 0.20000 125820.0n 0.20000 125999.9n 0.20000 126000.0n 0.20000 126179.9n 0.20000 126180.0n 0.20000 126359.9n 0.20000 126360.0n 0.20000 126539.9n 0.20000 126540.0n 0.20000 126719.9n 0.20000 126720.0n 0.20000 126899.9n 0.20000 126900.0n 0.20000 127079.9n 0.20000 127080.0n 0.20000 127259.9n 0.20000 127260.0n 0.20000 127439.9n 0.20000 127440.0n 0.20000 127619.9n 0.20000 127620.0n 0.20000 127799.9n 0.20000 127800.0n 0.20000 127979.9n 0.20000 127980.0n 0.20000 128159.9n 0.20000 128160.0n 0.20000 128339.9n 0.20000 128340.0n 0.20000 128519.9n 0.20000 128520.0n 0.20000 128699.9n 0.20000 128700.0n 0.20000 128879.9n 0.20000 128880.0n 0.20000 129059.9n 0.20000 129060.0n 0.20000 129239.9n 0.20000 129240.0n 0.20000 129419.9n 0.20000 129420.0n 0.20000 129599.9n 0.20000 129600.0n 0.20000 129779.9n 0.20000 129780.0n 0.20000 129959.9n 0.20000 129960.0n 0.20000 130139.9n 0.20000 130140.0n 0.20000 130319.9n 0.20000 130320.0n 0.20000 130499.9n 0.20000 130500.0n 0.20000 130679.9n 0.20000 130680.0n 0.20000 130859.9n 0.20000 130860.0n 0.20000 131039.9n 0.20000 131040.0n 0.20000 131219.9n 0.20000 131220.0n 0.20000 131399.9n 0.20000 131400.0n 0.20000 131579.9n 0.20000 131580.0n 0.20000 131759.9n 0.20000 131760.0n 0.20000 131939.9n 0.20000 131940.0n 0.20000 132119.9n 0.20000 132120.0n 0.20000 132299.9n 0.20000 132300.0n 0.20000 132479.9n 0.20000 132480.0n 0.20000 132659.9n 0.20000 132660.0n 0.20000 132839.9n 0.20000 132840.0n 0.20000 133019.9n 0.20000 133020.0n 0.20000 133199.9n 0.20000 133200.0n 0.20000 133379.9n 0.20000 133380.0n 0.20000 133559.9n 0.20000 133560.0n 0.20000 133739.9n 0.20000 133740.0n 0.20000 133919.9n 0.20000 133920.0n 0.20000 134099.9n 0.20000 134100.0n 0.20000 134279.9n 0.20000 134280.0n 0.20000 134459.9n 0.20000 134460.0n 0.20000 134639.9n 0.20000 134640.0n 0.20000 134819.9n 0.20000 134820.0n 0.20000 134999.9n 0.20000 135000.0n 0.20000 135179.9n 0.20000 135180.0n 0.20000 135359.9n 0.20000 135360.0n 0.20000 135539.9n 0.20000 135540.0n 0.20000 135719.9n 0.20000 135720.0n 0.20000 135899.9n 0.20000 135900.0n 0.20000 136079.9n 0.20000 136080.0n 0.20000 136259.9n 0.20000 136260.0n 0.20000 136439.9n 0.20000 136440.0n 0.20000 136619.9n 0.20000 136620.0n 0.20000 136799.9n 0.20000 136800.0n 0.20000 136979.9n 0.20000 136980.0n 0.20000 137159.9n 0.20000 137160.0n 0.20000 137339.9n 0.20000 137340.0n 0.20000 137519.9n 0.20000 137520.0n 0.20000 137699.9n 0.20000 137700.0n 0.20000 137879.9n 0.20000 137880.0n 0.20000 138059.9n 0.20000 138060.0n 0.20000 138239.9n 0.20000 138240.0n 0.20000 138419.9n 0.20000 138420.0n 0.20000 138599.9n 0.20000 138600.0n 0.20000 138779.9n 0.20000 138780.0n 0.20000 138959.9n 0.20000 138960.0n 0.20000 139139.9n 0.20000 139140.0n 0.20000 139319.9n 0.20000 139320.0n 0.20000 139499.9n 0.20000 139500.0n 0.20000 139679.9n 0.20000 139680.0n 0.20000 139859.9n 0.20000 139860.0n 0.20000 140039.9n 0.20000 140040.0n 0.20000 140219.9n 0.20000 140220.0n 0.20000 140399.9n 0.20000 140400.0n 0.20000 140579.9n 0.20000 140580.0n 0.20000 140759.9n 0.20000 140760.0n 0.20000 140939.9n 0.20000 140940.0n 0.20000 141119.9n 0.20000 141120.0n 0.20000 141299.9n 0.20000 141300.0n 0.20000 141479.9n 0.20000 141480.0n 0.20000 141659.9n 0.20000 141660.0n 0.20000 141839.9n 0.20000 141840.0n 0.20000 142019.9n 0.20000 142020.0n 0.20000 142199.9n 0.20000 142200.0n 0.20000 142379.9n 0.20000 142380.0n 0.20000 142559.9n 0.20000 142560.0n 0.20000 142739.9n 0.20000 142740.0n 0.20000 142919.9n 0.20000 142920.0n 0.20000 143099.9n 0.20000 143100.0n 0.20000 143279.9n 0.20000 143280.0n 0.20000 143459.9n 0.20000 143460.0n 0.20000 143639.9n 0.20000 143640.0n 0.20000 143819.9n 0.20000 143820.0n 0.20000 143999.9n 0.20000 144000.0n 0.20000 144179.9n 0.20000 144180.0n 0.20000 144359.9n 0.20000 144360.0n 0.20000 144539.9n 0.20000 144540.0n 0.20000 144719.9n 0.20000 144720.0n 0.20000 144899.9n 0.20000 144900.0n 0.20000 145079.9n 0.20000 145080.0n 0.20000 145259.9n 0.20000 145260.0n 0.20000 145439.9n 0.20000 145440.0n 0.20000 145619.9n 0.20000 145620.0n 0.20000 145799.9n 0.20000 145800.0n 0.20000 145979.9n 0.20000 145980.0n 0.20000 146159.9n 0.20000 146160.0n 0.20000 146339.9n 0.20000 146340.0n 0.20000 146519.9n 0.20000 146520.0n 0.20000 146699.9n 0.20000 146700.0n 0.20000 146879.9n 0.20000 146880.0n 0.20000 147059.9n 0.20000 147060.0n 0.20000 147239.9n 0.20000 147240.0n 0.20000 147419.9n 0.20000 147420.0n 0.20000 147599.9n 0.20000 147600.0n 0.20000 147779.9n 0.20000 147780.0n 0.20000 147959.9n 0.20000 147960.0n 0.20000 148139.9n 0.20000 148140.0n 0.20000 148319.9n 0.20000 148320.0n 0.20000 148499.9n 0.20000 148500.0n 0.20000 148679.9n 0.20000 148680.0n 0.20000 148859.9n 0.20000 148860.0n 0.20000 149039.9n 0.20000 149040.0n 0.20000 149219.9n 0.20000 149220.0n 0.20000 149399.9n 0.20000 149400.0n 0.20000 149579.9n 0.20000 149580.0n 0.20000 149759.9n 0.20000 149760.0n 0.20000 149939.9n 0.20000 149940.0n 0.20000 150119.9n 0.20000 150120.0n 0.20000 150299.9n 0.20000 150300.0n 0.20000 150479.9n 0.20000 150480.0n 0.20000 150659.9n 0.20000 150660.0n 0.20000 150839.9n 0.20000 150840.0n 0.20000 151019.9n 0.20000 151020.0n 0.20000 151199.9n 0.20000 151200.0n 0.20000 151379.9n 0.20000 151380.0n 0.20000 151559.9n 0.20000 151560.0n 0.20000 151739.9n 0.20000 151740.0n 0.20000 151919.9n 0.20000 151920.0n 0.20000 152099.9n 0.20000 152100.0n 0.20000 152279.9n 0.20000 152280.0n 0.20000 152459.9n 0.20000 152460.0n 0.20000 152639.9n 0.20000 152640.0n 0.20000 152819.9n 0.20000 152820.0n 0.20000 152999.9n 0.20000 153000.0n 0.20000 153179.9n 0.20000 153180.0n 0.20000 153359.9n 0.20000 153360.0n 0.20000 153539.9n 0.20000 153540.0n 0.20000 153719.9n 0.20000 153720.0n 0.20000 153899.9n 0.20000 153900.0n 0.20000 154079.9n 0.20000 154080.0n 0.20000 154259.9n 0.20000 154260.0n 0.20000 154439.9n 0.20000 154440.0n 0.20000 154619.9n 0.20000 154620.0n 0.20000 154799.9n 0.20000 154800.0n 0.20000 154979.9n 0.20000 154980.0n 0.20000 155159.9n 0.20000 155160.0n 0.20000 155339.9n 0.20000 155340.0n 0.20000 155519.9n 0.20000 155520.0n 0.20000 155699.9n 0.20000 155700.0n 0.20000 155879.9n 0.20000 155880.0n 0.20000 156059.9n 0.20000 156060.0n 0.20000 156239.9n 0.20000 156240.0n 0.20000 156419.9n 0.20000 156420.0n 0.20000 156599.9n 0.20000 156600.0n 0.20000 156779.9n 0.20000 156780.0n 0.20000 156959.9n 0.20000 156960.0n 0.20000 157139.9n 0.20000 157140.0n 0.20000 157319.9n 0.20000 157320.0n 0.20000 157499.9n 0.20000 157500.0n 0.20000 157679.9n 0.20000 157680.0n 0.20000 157859.9n 0.20000 157860.0n 0.20000 158039.9n 0.20000 158040.0n 0.20000 158219.9n 0.20000 158220.0n 0.20000 158399.9n 0.20000 158400.0n 0.20000 158579.9n 0.20000 158580.0n 0.20000 158759.9n 0.20000 158760.0n 0.20000 158939.9n 0.20000 158940.0n 0.20000 159119.9n 0.20000 159120.0n 0.20000 159299.9n 0.20000 159300.0n 0.20000 159479.9n 0.20000 159480.0n 0.20000 159659.9n 0.20000 159660.0n 0.20000 159839.9n 0.20000 159840.0n 0.20000 160019.9n 0.20000 160020.0n 0.20000 160199.9n 0.20000 160200.0n 0.20000 160379.9n 0.20000 160380.0n 0.20000 160559.9n 0.20000 160560.0n 0.20000 160739.9n 0.20000 160740.0n 0.20000 160919.9n 0.20000 160920.0n 0.20000 161099.9n 0.20000 161100.0n 0.20000 161279.9n 0.20000 161280.0n 0.20000 161459.9n 0.20000 161460.0n 0.20000 161639.9n 0.20000 161640.0n 0.20000 161819.9n 0.20000 161820.0n 0.20000 161999.9n 0.20000 162000.0n 0.20000 162179.9n 0.20000 162180.0n 0.20000 162359.9n 0.20000 162360.0n 0.20000 162539.9n 0.20000 162540.0n 0.20000 162719.9n 0.20000 162720.0n 0.20000 162899.9n 0.20000 162900.0n 0.20000 163079.9n 0.20000 163080.0n 0.20000 163259.9n 0.20000 163260.0n 0.20000 163439.9n 0.20000 163440.0n 0.20000 163619.9n 0.20000 163620.0n 0.20000 163799.9n 0.20000 163800.0n 0.20000 163979.9n 0.20000 163980.0n 0.20000 164159.9n 0.20000 164160.0n 0.20000 164339.9n 0.20000 164340.0n 0.20000 164519.9n 0.20000 164520.0n 0.20000 164699.9n 0.20000 164700.0n 0.20000 164879.9n 0.20000 164880.0n 0.20000 165059.9n 0.20000 165060.0n 0.20000 165239.9n 0.20000 165240.0n 0.20000 165419.9n 0.20000 165420.0n 0.20000 165599.9n 0.20000 165600.0n 0.20000 165779.9n 0.20000 165780.0n 0.20000 165959.9n 0.20000 165960.0n 0.20000 166139.9n 0.20000 166140.0n 0.20000 166319.9n 0.20000 166320.0n 0.20000 166499.9n 0.20000 166500.0n 0.20000 166679.9n 0.20000 166680.0n 0.20000 166859.9n 0.20000 166860.0n 0.20000 167039.9n 0.20000 167040.0n 0.20000 167219.9n 0.20000 167220.0n 0.20000 167399.9n 0.20000 167400.0n 0.20000 167579.9n 0.20000 167580.0n 0.20000 167759.9n 0.20000 167760.0n 0.20000 167939.9n 0.20000 167940.0n 0.20000 168119.9n 0.20000 168120.0n 0.20000 168299.9n 0.20000 168300.0n 0.20000 168479.9n 0.20000 168480.0n 0.20000 168659.9n 0.20000 168660.0n 0.20000 168839.9n 0.20000 168840.0n 0.20000 169019.9n 0.20000 169020.0n 0.20000 169199.9n 0.20000 169200.0n 0.20000 169379.9n 0.20000 169380.0n 0.20000 169559.9n 0.20000 169560.0n 0.20000 169739.9n 0.20000 169740.0n 0.20000 169919.9n 0.20000 169920.0n 0.20000 170099.9n 0.20000 170100.0n 0.20000 170279.9n 0.20000 170280.0n 0.20000 170459.9n 0.20000 170460.0n 0.20000 170639.9n 0.20000 170640.0n 0.20000 170819.9n 0.20000 170820.0n 0.20000 170999.9n 0.20000 171000.0n 0.20000 171179.9n 0.20000 171180.0n 0.20000 171359.9n 0.20000 171360.0n 0.20000 171539.9n 0.20000 171540.0n 0.20000 171719.9n 0.20000 171720.0n 0.20000 171899.9n 0.20000 171900.0n 0.20000 172079.9n 0.20000 172080.0n 0.20000 172259.9n 0.20000 172260.0n 0.20000 172439.9n 0.20000 172440.0n 0.20000 172619.9n 0.20000 172620.0n 0.20000 172799.9n 0.20000 172800.0n 0.20000 172979.9n 0.20000 172980.0n 0.20000 173159.9n 0.20000 173160.0n 0.20000 173339.9n 0.20000 173340.0n 0.20000 173519.9n 0.20000 173520.0n 0.20000 173699.9n 0.20000 173700.0n 0.20000 173879.9n 0.20000 173880.0n 0.20000 174059.9n 0.20000 174060.0n 0.20000 174239.9n 0.20000 174240.0n 0.20000 174419.9n 0.20000 174420.0n 0.20000 174599.9n 0.20000 174600.0n 0.20000 174779.9n 0.20000 174780.0n 0.20000 174959.9n 0.20000 174960.0n 0.20000 175139.9n 0.20000 175140.0n 0.20000 175319.9n 0.20000 175320.0n 0.20000 175499.9n 0.20000 175500.0n 0.20000 175679.9n 0.20000 175680.0n 0.20000 175859.9n 0.20000 175860.0n 0.20000 176039.9n 0.20000 176040.0n 0.20000 176219.9n 0.20000 176220.0n 0.20000 176399.9n 0.20000 176400.0n 0.20000 176579.9n 0.20000 176580.0n 0.20000 176759.9n 0.20000 176760.0n 0.20000 176939.9n 0.20000 176940.0n 0.20000 177119.9n 0.20000 177120.0n 0.20000 177299.9n 0.20000 177300.0n 0.20000 177479.9n 0.20000 177480.0n 0.20000 177659.9n 0.20000 177660.0n 0.20000 177839.9n 0.20000 177840.0n 0.20000 178019.9n 0.20000 178020.0n 0.20000 178199.9n 0.20000 178200.0n 0.20000 178379.9n 0.20000 178380.0n 0.20000 178559.9n 0.20000 178560.0n 0.20000 178739.9n 0.20000 178740.0n 0.20000 178919.9n 0.20000 178920.0n 0.20000 179099.9n 0.20000 179100.0n 0.20000 179279.9n 0.20000 179280.0n 0.20000 179459.9n 0.20000 179460.0n 0.20000 179639.9n 0.20000 179640.0n 0.20000 179819.9n 0.20000 179820.0n 0.20000 179999.9n 0.20000 180000.0n 0.20000 180179.9n 0.20000 180180.0n 0.20000 180359.9n 0.20000 180360.0n 0.20000 180539.9n 0.20000 180540.0n 0.20000 180719.9n 0.20000 180720.0n 0.20000 180899.9n 0.20000 180900.0n 0.20000 181079.9n 0.20000 181080.0n 0.20000 181259.9n 0.20000 181260.0n 0.20000 181439.9n 0.20000 181440.0n 0.20000 181619.9n 0.20000 181620.0n 0.20000 181799.9n 0.20000 181800.0n 0.20000 181979.9n 0.20000 181980.0n 0.20000 182159.9n 0.20000 182160.0n 0.20000 182339.9n 0.20000 182340.0n 0.20000 182519.9n 0.20000 182520.0n 0.20000 182699.9n 0.20000 182700.0n 0.20000 182879.9n 0.20000 182880.0n 0.20000 183059.9n 0.20000 183060.0n 0.20000 183239.9n 0.20000 183240.0n 0.20000 183419.9n 0.20000 183420.0n 0.20000)
Vxop0 xop0 0 PWL(0.0n 0.30000 179.9n 0.30000 180.0n 0.30000 359.9n 0.30000 360.0n 0.70000 539.9n 0.70000 540.0n 0.30000 719.9n 0.30000 720.0n 0.30000 899.9n 0.30000 900.0n 0.30000 1079.9n 0.30000 1080.0n 0.70000 1259.9n 0.70000 1260.0n 0.70000 1439.9n 0.70000 1440.0n 0.70000 1619.9n 0.70000 1620.0n 0.30000 1799.9n 0.30000 1800.0n 0.30000 1979.9n 0.30000 1980.0n 0.70000 2159.9n 0.70000 2160.0n 0.70000 2339.9n 0.70000 2340.0n 0.70000 2519.9n 0.70000 2520.0n 0.30000 2699.9n 0.30000 2700.0n 0.70000 2879.9n 0.70000 2880.0n 0.70000 3059.9n 0.70000 3060.0n 0.30000 3239.9n 0.30000 3240.0n 0.30000 3419.9n 0.30000 3420.0n 0.30000 3599.9n 0.30000 3600.0n 0.70000 3779.9n 0.70000 3780.0n 0.30000 3959.9n 0.30000 3960.0n 0.30000 4139.9n 0.30000 4140.0n 0.70000 4319.9n 0.70000 4320.0n 0.70000 4499.9n 0.70000 4500.0n 0.30000 4679.9n 0.30000 4680.0n 0.70000 4859.9n 0.70000 4860.0n 0.70000 5039.9n 0.70000 5040.0n 0.70000 5219.9n 0.70000 5220.0n 0.70000 5399.9n 0.70000 5400.0n 0.30000 5579.9n 0.30000 5580.0n 0.30000 5759.9n 0.30000 5760.0n 0.30000 5939.9n 0.30000 5940.0n 0.30000 6119.9n 0.30000 6120.0n 0.30000 6299.9n 0.30000 6300.0n 0.70000 6479.9n 0.70000 6480.0n 0.70000 6659.9n 0.70000 6660.0n 0.30000 6839.9n 0.30000 6840.0n 0.30000 7019.9n 0.30000 7020.0n 0.70000 7199.9n 0.70000 7200.0n 0.70000 7379.9n 0.70000 7380.0n 0.70000 7559.9n 0.70000 7560.0n 0.30000 7739.9n 0.30000 7740.0n 0.30000 7919.9n 0.30000 7920.0n 0.30000 8099.9n 0.30000 8100.0n 0.70000 8279.9n 0.70000 8280.0n 0.30000 8459.9n 0.30000 8460.0n 0.70000 8639.9n 0.70000 8640.0n 0.30000 8819.9n 0.30000 8820.0n 0.70000 8999.9n 0.70000 9000.0n 0.70000 9179.9n 0.70000 9180.0n 0.70000 9359.9n 0.70000 9360.0n 0.70000 9539.9n 0.70000 9540.0n 0.70000 9719.9n 0.70000 9720.0n 0.30000 9899.9n 0.30000 9900.0n 0.30000 10079.9n 0.30000 10080.0n 0.30000 10259.9n 0.30000 10260.0n 0.70000 10439.9n 0.70000 10440.0n 0.70000 10619.9n 0.70000 10620.0n 0.30000 10799.9n 0.30000 10800.0n 0.70000 10979.9n 0.70000 10980.0n 0.70000 11159.9n 0.70000 11160.0n 0.30000 11339.9n 0.30000 11340.0n 0.30000 11519.9n 0.30000 11520.0n 0.30000 11699.9n 0.30000 11700.0n 0.70000 11879.9n 0.70000 11880.0n 0.70000 12059.9n 0.70000 12060.0n 0.70000 12239.9n 0.70000 12240.0n 0.30000 12419.9n 0.30000 12420.0n 0.30000 12599.9n 0.30000 12600.0n 0.70000 12779.9n 0.70000 12780.0n 0.30000 12959.9n 0.30000 12960.0n 0.30000 13139.9n 0.30000 13140.0n 0.70000 13319.9n 0.70000 13320.0n 0.30000 13499.9n 0.30000 13500.0n 0.70000 13679.9n 0.70000 13680.0n 0.70000 13859.9n 0.70000 13860.0n 0.70000 14039.9n 0.70000 14040.0n 0.70000 14219.9n 0.70000 14220.0n 0.30000 14399.9n 0.30000 14400.0n 0.70000 14579.9n 0.70000 14580.0n 0.70000 14759.9n 0.70000 14760.0n 0.30000 14939.9n 0.30000 14940.0n 0.30000 15119.9n 0.30000 15120.0n 0.30000 15299.9n 0.30000 15300.0n 0.70000 15479.9n 0.70000 15480.0n 0.70000 15659.9n 0.70000 15660.0n 0.30000 15839.9n 0.30000 15840.0n 0.30000 16019.9n 0.30000 16020.0n 0.70000 16199.9n 0.70000 16200.0n 0.30000 16379.9n 0.30000 16380.0n 0.70000 16559.9n 0.70000 16560.0n 0.70000 16739.9n 0.70000 16740.0n 0.30000 16919.9n 0.30000 16920.0n 0.30000 17099.9n 0.30000 17100.0n 0.30000 17279.9n 0.30000 17280.0n 0.30000 17459.9n 0.30000 17460.0n 0.70000 17639.9n 0.70000 17640.0n 0.70000 17819.9n 0.70000 17820.0n 0.30000 17999.9n 0.30000 18000.0n 0.70000 18179.9n 0.70000 18180.0n 0.30000 18359.9n 0.30000 18360.0n 0.30000 18539.9n 0.30000 18540.0n 0.70000 18719.9n 0.70000 18720.0n 0.70000 18899.9n 0.70000 18900.0n 0.70000 19079.9n 0.70000 19080.0n 0.70000 19259.9n 0.70000 19260.0n 0.70000 19439.9n 0.70000 19440.0n 0.70000 19619.9n 0.70000 19620.0n 0.30000 19799.9n 0.30000 19800.0n 0.30000 19979.9n 0.30000 19980.0n 0.70000 20159.9n 0.70000 20160.0n 0.30000 20339.9n 0.30000 20340.0n 0.70000 20519.9n 0.70000 20520.0n 0.70000 20699.9n 0.70000 20700.0n 0.30000 20879.9n 0.30000 20880.0n 0.30000 21059.9n 0.30000 21060.0n 0.70000 21239.9n 0.70000 21240.0n 0.70000 21419.9n 0.70000 21420.0n 0.30000 21599.9n 0.30000 21600.0n 0.30000 21779.9n 0.30000 21780.0n 0.30000 21959.9n 0.30000 21960.0n 0.30000 22139.9n 0.30000 22140.0n 0.30000 22319.9n 0.30000 22320.0n 0.70000 22499.9n 0.70000 22500.0n 0.30000 22679.9n 0.30000 22680.0n 0.70000 22859.9n 0.70000 22860.0n 0.30000 23039.9n 0.30000 23040.0n 0.70000 23219.9n 0.70000 23220.0n 0.70000 23399.9n 0.70000 23400.0n 0.70000 23579.9n 0.70000 23580.0n 0.30000 23759.9n 0.30000 23760.0n 0.70000 23939.9n 0.70000 23940.0n 0.70000 24119.9n 0.70000 24120.0n 0.70000 24299.9n 0.70000 24300.0n 0.30000 24479.9n 0.30000 24480.0n 0.70000 24659.9n 0.70000 24660.0n 0.70000 24839.9n 0.70000 24840.0n 0.70000 25019.9n 0.70000 25020.0n 0.70000 25199.9n 0.70000 25200.0n 0.30000 25379.9n 0.30000 25380.0n 0.30000 25559.9n 0.30000 25560.0n 0.30000 25739.9n 0.30000 25740.0n 0.70000 25919.9n 0.70000 25920.0n 0.70000 26099.9n 0.70000 26100.0n 0.70000 26279.9n 0.70000 26280.0n 0.30000 26459.9n 0.30000 26460.0n 0.30000 26639.9n 0.30000 26640.0n 0.30000 26819.9n 0.30000 26820.0n 0.70000 26999.9n 0.70000 27000.0n 0.70000 27179.9n 0.70000 27180.0n 0.70000 27359.9n 0.70000 27360.0n 0.30000 27539.9n 0.30000 27540.0n 0.30000 27719.9n 0.30000 27720.0n 0.30000 27899.9n 0.30000 27900.0n 0.30000 28079.9n 0.30000 28080.0n 0.30000 28259.9n 0.30000 28260.0n 0.30000 28439.9n 0.30000 28440.0n 0.30000 28619.9n 0.30000 28620.0n 0.30000 28799.9n 0.30000 28800.0n 0.30000 28979.9n 0.30000 28980.0n 0.70000 29159.9n 0.70000 29160.0n 0.70000 29339.9n 0.70000 29340.0n 0.70000 29519.9n 0.70000 29520.0n 0.30000 29699.9n 0.30000 29700.0n 0.70000 29879.9n 0.70000 29880.0n 0.30000 30059.9n 0.30000 30060.0n 0.30000 30239.9n 0.30000 30240.0n 0.30000 30419.9n 0.30000 30420.0n 0.70000 30599.9n 0.70000 30600.0n 0.70000 30779.9n 0.70000 30780.0n 0.70000 30959.9n 0.70000 30960.0n 0.30000 31139.9n 0.30000 31140.0n 0.30000 31319.9n 0.30000 31320.0n 0.70000 31499.9n 0.70000 31500.0n 0.30000 31679.9n 0.30000 31680.0n 0.70000 31859.9n 0.70000 31860.0n 0.30000 32039.9n 0.30000 32040.0n 0.30000 32219.9n 0.30000 32220.0n 0.70000 32399.9n 0.70000 32400.0n 0.70000 32579.9n 0.70000 32580.0n 0.70000 32759.9n 0.70000 32760.0n 0.70000 32939.9n 0.70000 32940.0n 0.70000 33119.9n 0.70000 33120.0n 0.70000 33299.9n 0.70000 33300.0n 0.30000 33479.9n 0.30000 33480.0n 0.30000 33659.9n 0.30000 33660.0n 0.30000 33839.9n 0.30000 33840.0n 0.30000 34019.9n 0.30000 34020.0n 0.70000 34199.9n 0.70000 34200.0n 0.30000 34379.9n 0.30000 34380.0n 0.30000 34559.9n 0.30000 34560.0n 0.70000 34739.9n 0.70000 34740.0n 0.70000 34919.9n 0.70000 34920.0n 0.30000 35099.9n 0.30000 35100.0n 0.30000 35279.9n 0.30000 35280.0n 0.30000 35459.9n 0.30000 35460.0n 0.30000 35639.9n 0.30000 35640.0n 0.70000 35819.9n 0.70000 35820.0n 0.70000 35999.9n 0.70000 36000.0n 0.70000 36179.9n 0.70000 36180.0n 0.70000 36359.9n 0.70000 36360.0n 0.70000 36539.9n 0.70000 36540.0n 0.70000 36719.9n 0.70000 36720.0n 0.70000 36899.9n 0.70000 36900.0n 0.70000 37079.9n 0.70000 37080.0n 0.30000 37259.9n 0.30000 37260.0n 0.70000 37439.9n 0.70000 37440.0n 0.30000 37619.9n 0.30000 37620.0n 0.30000 37799.9n 0.30000 37800.0n 0.30000 37979.9n 0.30000 37980.0n 0.30000 38159.9n 0.30000 38160.0n 0.70000 38339.9n 0.70000 38340.0n 0.70000 38519.9n 0.70000 38520.0n 0.30000 38699.9n 0.30000 38700.0n 0.70000 38879.9n 0.70000 38880.0n 0.30000 39059.9n 0.30000 39060.0n 0.70000 39239.9n 0.70000 39240.0n 0.30000 39419.9n 0.30000 39420.0n 0.70000 39599.9n 0.70000 39600.0n 0.30000 39779.9n 0.30000 39780.0n 0.30000 39959.9n 0.30000 39960.0n 0.30000 40139.9n 0.30000 40140.0n 0.30000 40319.9n 0.30000 40320.0n 0.70000 40499.9n 0.70000 40500.0n 0.70000 40679.9n 0.70000 40680.0n 0.30000 40859.9n 0.30000 40860.0n 0.30000 41039.9n 0.30000 41040.0n 0.30000 41219.9n 0.30000 41220.0n 0.70000 41399.9n 0.70000 41400.0n 0.70000 41579.9n 0.70000 41580.0n 0.30000 41759.9n 0.30000 41760.0n 0.30000 41939.9n 0.30000 41940.0n 0.30000 42119.9n 0.30000 42120.0n 0.70000 42299.9n 0.70000 42300.0n 0.30000 42479.9n 0.30000 42480.0n 0.70000 42659.9n 0.70000 42660.0n 0.70000 42839.9n 0.70000 42840.0n 0.70000 43019.9n 0.70000 43020.0n 0.70000 43199.9n 0.70000 43200.0n 0.30000 43379.9n 0.30000 43380.0n 0.70000 43559.9n 0.70000 43560.0n 0.70000 43739.9n 0.70000 43740.0n 0.30000 43919.9n 0.30000 43920.0n 0.70000 44099.9n 0.70000 44100.0n 0.30000 44279.9n 0.30000 44280.0n 0.30000 44459.9n 0.30000 44460.0n 0.30000 44639.9n 0.30000 44640.0n 0.70000 44819.9n 0.70000 44820.0n 0.30000 44999.9n 0.30000 45000.0n 0.70000 45179.9n 0.70000 45180.0n 0.70000 45359.9n 0.70000 45360.0n 0.30000 45539.9n 0.30000 45540.0n 0.70000 45719.9n 0.70000 45720.0n 0.30000 45899.9n 0.30000 45900.0n 0.30000 46079.9n 0.30000 46080.0n 0.70000 46259.9n 0.70000 46260.0n 0.70000 46439.9n 0.70000 46440.0n 0.70000 46619.9n 0.70000 46620.0n 0.30000 46799.9n 0.30000 46800.0n 0.70000 46979.9n 0.70000 46980.0n 0.30000 47159.9n 0.30000 47160.0n 0.30000 47339.9n 0.30000 47340.0n 0.70000 47519.9n 0.70000 47520.0n 0.70000 47699.9n 0.70000 47700.0n 0.70000 47879.9n 0.70000 47880.0n 0.70000 48059.9n 0.70000 48060.0n 0.30000 48239.9n 0.30000 48240.0n 0.30000 48419.9n 0.30000 48420.0n 0.30000 48599.9n 0.30000 48600.0n 0.30000 48779.9n 0.30000 48780.0n 0.70000 48959.9n 0.70000 48960.0n 0.30000 49139.9n 0.30000 49140.0n 0.30000 49319.9n 0.30000 49320.0n 0.30000 49499.9n 0.30000 49500.0n 0.30000 49679.9n 0.30000 49680.0n 0.70000 49859.9n 0.70000 49860.0n 0.70000 50039.9n 0.70000 50040.0n 0.70000 50219.9n 0.70000 50220.0n 0.70000 50399.9n 0.70000 50400.0n 0.70000 50579.9n 0.70000 50580.0n 0.30000 50759.9n 0.30000 50760.0n 0.30000 50939.9n 0.30000 50940.0n 0.30000 51119.9n 0.30000 51120.0n 0.30000 51299.9n 0.30000 51300.0n 0.70000 51479.9n 0.70000 51480.0n 0.30000 51659.9n 0.30000 51660.0n 0.70000 51839.9n 0.70000 51840.0n 0.30000 52019.9n 0.30000 52020.0n 0.30000 52199.9n 0.30000 52200.0n 0.70000 52379.9n 0.70000 52380.0n 0.70000 52559.9n 0.70000 52560.0n 0.30000 52739.9n 0.30000 52740.0n 0.70000 52919.9n 0.70000 52920.0n 0.70000 53099.9n 0.70000 53100.0n 0.30000 53279.9n 0.30000 53280.0n 0.30000 53459.9n 0.30000 53460.0n 0.30000 53639.9n 0.30000 53640.0n 0.30000 53819.9n 0.30000 53820.0n 0.30000 53999.9n 0.30000 54000.0n 0.30000 54179.9n 0.30000 54180.0n 0.70000 54359.9n 0.70000 54360.0n 0.30000 54539.9n 0.30000 54540.0n 0.70000 54719.9n 0.70000 54720.0n 0.70000 54899.9n 0.70000 54900.0n 0.70000 55079.9n 0.70000 55080.0n 0.70000 55259.9n 0.70000 55260.0n 0.70000 55439.9n 0.70000 55440.0n 0.70000 55619.9n 0.70000 55620.0n 0.70000 55799.9n 0.70000 55800.0n 0.30000 55979.9n 0.30000 55980.0n 0.30000 56159.9n 0.30000 56160.0n 0.30000 56339.9n 0.30000 56340.0n 0.30000 56519.9n 0.30000 56520.0n 0.70000 56699.9n 0.70000 56700.0n 0.70000 56879.9n 0.70000 56880.0n 0.70000 57059.9n 0.70000 57060.0n 0.30000 57239.9n 0.30000 57240.0n 0.30000 57419.9n 0.30000 57420.0n 0.70000 57599.9n 0.70000 57600.0n 0.70000 57779.9n 0.70000 57780.0n 0.70000 57959.9n 0.70000 57960.0n 0.30000 58139.9n 0.30000 58140.0n 0.70000 58319.9n 0.70000 58320.0n 0.70000 58499.9n 0.70000 58500.0n 0.30000 58679.9n 0.30000 58680.0n 0.70000 58859.9n 0.70000 58860.0n 0.30000 59039.9n 0.30000 59040.0n 0.70000 59219.9n 0.70000 59220.0n 0.30000 59399.9n 0.30000 59400.0n 0.30000 59579.9n 0.30000 59580.0n 0.30000 59759.9n 0.30000 59760.0n 0.30000 59939.9n 0.30000 59940.0n 0.70000 60119.9n 0.70000 60120.0n 0.30000 60299.9n 0.30000 60300.0n 0.30000 60479.9n 0.30000 60480.0n 0.70000 60659.9n 0.70000 60660.0n 0.70000 60839.9n 0.70000 60840.0n 0.70000 61019.9n 0.70000 61020.0n 0.70000 61199.9n 0.70000 61200.0n 0.30000 61379.9n 0.30000 61380.0n 0.30000 61559.9n 0.30000 61560.0n 0.30000 61739.9n 0.30000 61740.0n 0.70000 61919.9n 0.70000 61920.0n 0.70000 62099.9n 0.70000 62100.0n 0.30000 62279.9n 0.30000 62280.0n 0.70000 62459.9n 0.70000 62460.0n 0.30000 62639.9n 0.30000 62640.0n 0.70000 62819.9n 0.70000 62820.0n 0.30000 62999.9n 0.30000 63000.0n 0.30000 63179.9n 0.30000 63180.0n 0.70000 63359.9n 0.70000 63360.0n 0.30000 63539.9n 0.30000 63540.0n 0.70000 63719.9n 0.70000 63720.0n 0.70000 63899.9n 0.70000 63900.0n 0.70000 64079.9n 0.70000 64080.0n 0.70000 64259.9n 0.70000 64260.0n 0.30000 64439.9n 0.30000 64440.0n 0.30000 64619.9n 0.30000 64620.0n 0.30000 64799.9n 0.30000 64800.0n 0.30000 64979.9n 0.30000 64980.0n 0.30000 65159.9n 0.30000 65160.0n 0.70000 65339.9n 0.70000 65340.0n 0.70000 65519.9n 0.70000 65520.0n 0.70000 65699.9n 0.70000 65700.0n 0.70000 65879.9n 0.70000 65880.0n 0.30000 66059.9n 0.30000 66060.0n 0.30000 66239.9n 0.30000 66240.0n 0.30000 66419.9n 0.30000 66420.0n 0.70000 66599.9n 0.70000 66600.0n 0.70000 66779.9n 0.70000 66780.0n 0.30000 66959.9n 0.30000 66960.0n 0.30000 67139.9n 0.30000 67140.0n 0.70000 67319.9n 0.70000 67320.0n 0.70000 67499.9n 0.70000 67500.0n 0.30000 67679.9n 0.30000 67680.0n 0.30000 67859.9n 0.30000 67860.0n 0.70000 68039.9n 0.70000 68040.0n 0.70000 68219.9n 0.70000 68220.0n 0.30000 68399.9n 0.30000 68400.0n 0.30000 68579.9n 0.30000 68580.0n 0.70000 68759.9n 0.70000 68760.0n 0.70000 68939.9n 0.70000 68940.0n 0.30000 69119.9n 0.30000 69120.0n 0.30000 69299.9n 0.30000 69300.0n 0.70000 69479.9n 0.70000 69480.0n 0.70000 69659.9n 0.70000 69660.0n 0.70000 69839.9n 0.70000 69840.0n 0.70000 70019.9n 0.70000 70020.0n 0.70000 70199.9n 0.70000 70200.0n 0.70000 70379.9n 0.70000 70380.0n 0.70000 70559.9n 0.70000 70560.0n 0.30000 70739.9n 0.30000 70740.0n 0.30000 70919.9n 0.30000 70920.0n 0.70000 71099.9n 0.70000 71100.0n 0.70000 71279.9n 0.70000 71280.0n 0.70000 71459.9n 0.70000 71460.0n 0.30000 71639.9n 0.30000 71640.0n 0.30000 71819.9n 0.30000 71820.0n 0.70000 71999.9n 0.70000 72000.0n 0.30000 72179.9n 0.30000 72180.0n 0.30000 72359.9n 0.30000 72360.0n 0.30000 72539.9n 0.30000 72540.0n 0.70000 72719.9n 0.70000 72720.0n 0.30000 72899.9n 0.30000 72900.0n 0.30000 73079.9n 0.30000 73080.0n 0.30000 73259.9n 0.30000 73260.0n 0.70000 73439.9n 0.70000 73440.0n 0.30000 73619.9n 0.30000 73620.0n 0.30000 73799.9n 0.30000 73800.0n 0.70000 73979.9n 0.70000 73980.0n 0.70000 74159.9n 0.70000 74160.0n 0.30000 74339.9n 0.30000 74340.0n 0.30000 74519.9n 0.30000 74520.0n 0.30000 74699.9n 0.30000 74700.0n 0.70000 74879.9n 0.70000 74880.0n 0.30000 75059.9n 0.30000 75060.0n 0.30000 75239.9n 0.30000 75240.0n 0.30000 75419.9n 0.30000 75420.0n 0.70000 75599.9n 0.70000 75600.0n 0.70000 75779.9n 0.70000 75780.0n 0.70000 75959.9n 0.70000 75960.0n 0.30000 76139.9n 0.30000 76140.0n 0.30000 76319.9n 0.30000 76320.0n 0.70000 76499.9n 0.70000 76500.0n 0.70000 76679.9n 0.70000 76680.0n 0.70000 76859.9n 0.70000 76860.0n 0.70000 77039.9n 0.70000 77040.0n 0.70000 77219.9n 0.70000 77220.0n 0.30000 77399.9n 0.30000 77400.0n 0.30000 77579.9n 0.30000 77580.0n 0.30000 77759.9n 0.30000 77760.0n 0.70000 77939.9n 0.70000 77940.0n 0.70000 78119.9n 0.70000 78120.0n 0.30000 78299.9n 0.30000 78300.0n 0.30000 78479.9n 0.30000 78480.0n 0.70000 78659.9n 0.70000 78660.0n 0.30000 78839.9n 0.30000 78840.0n 0.30000 79019.9n 0.30000 79020.0n 0.70000 79199.9n 0.70000 79200.0n 0.70000 79379.9n 0.70000 79380.0n 0.70000 79559.9n 0.70000 79560.0n 0.70000 79739.9n 0.70000 79740.0n 0.30000 79919.9n 0.30000 79920.0n 0.30000 80099.9n 0.30000 80100.0n 0.30000 80279.9n 0.30000 80280.0n 0.70000 80459.9n 0.70000 80460.0n 0.30000 80639.9n 0.30000 80640.0n 0.30000 80819.9n 0.30000 80820.0n 0.30000 80999.9n 0.30000 81000.0n 0.30000 81179.9n 0.30000 81180.0n 0.70000 81359.9n 0.70000 81360.0n 0.30000 81539.9n 0.30000 81540.0n 0.30000 81719.9n 0.30000 81720.0n 0.30000 81899.9n 0.30000 81900.0n 0.30000 82079.9n 0.30000 82080.0n 0.70000 82259.9n 0.70000 82260.0n 0.30000 82439.9n 0.30000 82440.0n 0.70000 82619.9n 0.70000 82620.0n 0.70000 82799.9n 0.70000 82800.0n 0.70000 82979.9n 0.70000 82980.0n 0.70000 83159.9n 0.70000 83160.0n 0.30000 83339.9n 0.30000 83340.0n 0.70000 83519.9n 0.70000 83520.0n 0.70000 83699.9n 0.70000 83700.0n 0.30000 83879.9n 0.30000 83880.0n 0.30000 84059.9n 0.30000 84060.0n 0.70000 84239.9n 0.70000 84240.0n 0.70000 84419.9n 0.70000 84420.0n 0.70000 84599.9n 0.70000 84600.0n 0.70000 84779.9n 0.70000 84780.0n 0.30000 84959.9n 0.30000 84960.0n 0.70000 85139.9n 0.70000 85140.0n 0.70000 85319.9n 0.70000 85320.0n 0.30000 85499.9n 0.30000 85500.0n 0.30000 85679.9n 0.30000 85680.0n 0.30000 85859.9n 0.30000 85860.0n 0.70000 86039.9n 0.70000 86040.0n 0.30000 86219.9n 0.30000 86220.0n 0.70000 86399.9n 0.70000 86400.0n 0.30000 86579.9n 0.30000 86580.0n 0.70000 86759.9n 0.70000 86760.0n 0.70000 86939.9n 0.70000 86940.0n 0.70000 87119.9n 0.70000 87120.0n 0.30000 87299.9n 0.30000 87300.0n 0.30000 87479.9n 0.30000 87480.0n 0.30000 87659.9n 0.30000 87660.0n 0.70000 87839.9n 0.70000 87840.0n 0.70000 88019.9n 0.70000 88020.0n 0.30000 88199.9n 0.30000 88200.0n 0.30000 88379.9n 0.30000 88380.0n 0.70000 88559.9n 0.70000 88560.0n 0.30000 88739.9n 0.30000 88740.0n 0.70000 88919.9n 0.70000 88920.0n 0.70000 89099.9n 0.70000 89100.0n 0.70000 89279.9n 0.70000 89280.0n 0.70000 89459.9n 0.70000 89460.0n 0.70000 89639.9n 0.70000 89640.0n 0.70000 89819.9n 0.70000 89820.0n 0.30000 89999.9n 0.30000 90000.0n 0.30000 90179.9n 0.30000 90180.0n 0.30000 90359.9n 0.30000 90360.0n 0.70000 90539.9n 0.70000 90540.0n 0.70000 90719.9n 0.70000 90720.0n 0.70000 90899.9n 0.70000 90900.0n 0.30000 91079.9n 0.30000 91080.0n 0.30000 91259.9n 0.30000 91260.0n 0.30000 91439.9n 0.30000 91440.0n 0.70000 91619.9n 0.70000 91620.0n 0.30000 91799.9n 0.30000 91800.0n 0.30000 91979.9n 0.30000 91980.0n 0.30000 92159.9n 0.30000 92160.0n 0.30000 92339.9n 0.30000 92340.0n 0.30000 92519.9n 0.30000 92520.0n 0.30000 92699.9n 0.30000 92700.0n 0.30000 92879.9n 0.30000 92880.0n 0.30000 93059.9n 0.30000 93060.0n 0.30000 93239.9n 0.30000 93240.0n 0.30000 93419.9n 0.30000 93420.0n 0.30000 93599.9n 0.30000 93600.0n 0.30000 93779.9n 0.30000 93780.0n 0.70000 93959.9n 0.70000 93960.0n 0.70000 94139.9n 0.70000 94140.0n 0.30000 94319.9n 0.30000 94320.0n 0.70000 94499.9n 0.70000 94500.0n 0.70000 94679.9n 0.70000 94680.0n 0.30000 94859.9n 0.30000 94860.0n 0.30000 95039.9n 0.30000 95040.0n 0.70000 95219.9n 0.70000 95220.0n 0.70000 95399.9n 0.70000 95400.0n 0.70000 95579.9n 0.70000 95580.0n 0.30000 95759.9n 0.30000 95760.0n 0.30000 95939.9n 0.30000 95940.0n 0.70000 96119.9n 0.70000 96120.0n 0.70000 96299.9n 0.70000 96300.0n 0.70000 96479.9n 0.70000 96480.0n 0.30000 96659.9n 0.30000 96660.0n 0.70000 96839.9n 0.70000 96840.0n 0.70000 97019.9n 0.70000 97020.0n 0.70000 97199.9n 0.70000 97200.0n 0.30000 97379.9n 0.30000 97380.0n 0.70000 97559.9n 0.70000 97560.0n 0.70000 97739.9n 0.70000 97740.0n 0.70000 97919.9n 0.70000 97920.0n 0.30000 98099.9n 0.30000 98100.0n 0.30000 98279.9n 0.30000 98280.0n 0.30000 98459.9n 0.30000 98460.0n 0.30000 98639.9n 0.30000 98640.0n 0.70000 98819.9n 0.70000 98820.0n 0.70000 98999.9n 0.70000 99000.0n 0.70000 99179.9n 0.70000 99180.0n 0.70000 99359.9n 0.70000 99360.0n 0.30000 99539.9n 0.30000 99540.0n 0.30000 99719.9n 0.30000 99720.0n 0.70000 99899.9n 0.70000 99900.0n 0.30000 100079.9n 0.30000 100080.0n 0.70000 100259.9n 0.70000 100260.0n 0.30000 100439.9n 0.30000 100440.0n 0.70000 100619.9n 0.70000 100620.0n 0.30000 100799.9n 0.30000 100800.0n 0.30000 100979.9n 0.30000 100980.0n 0.70000 101159.9n 0.70000 101160.0n 0.70000 101339.9n 0.70000 101340.0n 0.30000 101519.9n 0.30000 101520.0n 0.70000 101699.9n 0.70000 101700.0n 0.70000 101879.9n 0.70000 101880.0n 0.70000 102059.9n 0.70000 102060.0n 0.30000 102239.9n 0.30000 102240.0n 0.30000 102419.9n 0.30000 102420.0n 0.30000 102599.9n 0.30000 102600.0n 0.70000 102779.9n 0.70000 102780.0n 0.30000 102959.9n 0.30000 102960.0n 0.70000 103139.9n 0.70000 103140.0n 0.70000 103319.9n 0.70000 103320.0n 0.70000 103499.9n 0.70000 103500.0n 0.30000 103679.9n 0.30000 103680.0n 0.30000 103859.9n 0.30000 103860.0n 0.30000 104039.9n 0.30000 104040.0n 0.70000 104219.9n 0.70000 104220.0n 0.30000 104399.9n 0.30000 104400.0n 0.30000 104579.9n 0.30000 104580.0n 0.30000 104759.9n 0.30000 104760.0n 0.70000 104939.9n 0.70000 104940.0n 0.30000 105119.9n 0.30000 105120.0n 0.30000 105299.9n 0.30000 105300.0n 0.70000 105479.9n 0.70000 105480.0n 0.70000 105659.9n 0.70000 105660.0n 0.30000 105839.9n 0.30000 105840.0n 0.70000 106019.9n 0.70000 106020.0n 0.70000 106199.9n 0.70000 106200.0n 0.70000 106379.9n 0.70000 106380.0n 0.70000 106559.9n 0.70000 106560.0n 0.70000 106739.9n 0.70000 106740.0n 0.70000 106919.9n 0.70000 106920.0n 0.30000 107099.9n 0.30000 107100.0n 0.30000 107279.9n 0.30000 107280.0n 0.70000 107459.9n 0.70000 107460.0n 0.30000 107639.9n 0.30000 107640.0n 0.70000 107819.9n 0.70000 107820.0n 0.70000 107999.9n 0.70000 108000.0n 0.30000 108179.9n 0.30000 108180.0n 0.30000 108359.9n 0.30000 108360.0n 0.30000 108539.9n 0.30000 108540.0n 0.70000 108719.9n 0.70000 108720.0n 0.30000 108899.9n 0.30000 108900.0n 0.70000 109079.9n 0.70000 109080.0n 0.70000 109259.9n 0.70000 109260.0n 0.30000 109439.9n 0.30000 109440.0n 0.30000 109619.9n 0.30000 109620.0n 0.30000 109799.9n 0.30000 109800.0n 0.70000 109979.9n 0.70000 109980.0n 0.70000 110159.9n 0.70000 110160.0n 0.30000 110339.9n 0.30000 110340.0n 0.70000 110519.9n 0.70000 110520.0n 0.30000 110699.9n 0.30000 110700.0n 0.30000 110879.9n 0.30000 110880.0n 0.70000 111059.9n 0.70000 111060.0n 0.70000 111239.9n 0.70000 111240.0n 0.30000 111419.9n 0.30000 111420.0n 0.30000 111599.9n 0.30000 111600.0n 0.70000 111779.9n 0.70000 111780.0n 0.30000 111959.9n 0.30000 111960.0n 0.70000 112139.9n 0.70000 112140.0n 0.30000 112319.9n 0.30000 112320.0n 0.30000 112499.9n 0.30000 112500.0n 0.70000 112679.9n 0.70000 112680.0n 0.30000 112859.9n 0.30000 112860.0n 0.30000 113039.9n 0.30000 113040.0n 0.70000 113219.9n 0.70000 113220.0n 0.70000 113399.9n 0.70000 113400.0n 0.70000 113579.9n 0.70000 113580.0n 0.70000 113759.9n 0.70000 113760.0n 0.70000 113939.9n 0.70000 113940.0n 0.70000 114119.9n 0.70000 114120.0n 0.30000 114299.9n 0.30000 114300.0n 0.30000 114479.9n 0.30000 114480.0n 0.70000 114659.9n 0.70000 114660.0n 0.70000 114839.9n 0.70000 114840.0n 0.30000 115019.9n 0.30000 115020.0n 0.30000 115199.9n 0.30000 115200.0n 0.30000 115379.9n 0.30000 115380.0n 0.30000 115559.9n 0.30000 115560.0n 0.70000 115739.9n 0.70000 115740.0n 0.30000 115919.9n 0.30000 115920.0n 0.30000 116099.9n 0.30000 116100.0n 0.70000 116279.9n 0.70000 116280.0n 0.70000 116459.9n 0.70000 116460.0n 0.70000 116639.9n 0.70000 116640.0n 0.30000 116819.9n 0.30000 116820.0n 0.70000 116999.9n 0.70000 117000.0n 0.70000 117179.9n 0.70000 117180.0n 0.30000 117359.9n 0.30000 117360.0n 0.70000 117539.9n 0.70000 117540.0n 0.30000 117719.9n 0.30000 117720.0n 0.30000 117899.9n 0.30000 117900.0n 0.30000 118079.9n 0.30000 118080.0n 0.70000 118259.9n 0.70000 118260.0n 0.70000 118439.9n 0.70000 118440.0n 0.30000 118619.9n 0.30000 118620.0n 0.70000 118799.9n 0.70000 118800.0n 0.70000 118979.9n 0.70000 118980.0n 0.70000 119159.9n 0.70000 119160.0n 0.30000 119339.9n 0.30000 119340.0n 0.30000 119519.9n 0.30000 119520.0n 0.30000 119699.9n 0.30000 119700.0n 0.30000 119879.9n 0.30000 119880.0n 0.70000 120059.9n 0.70000 120060.0n 0.70000 120239.9n 0.70000 120240.0n 0.30000 120419.9n 0.30000 120420.0n 0.70000 120599.9n 0.70000 120600.0n 0.30000 120779.9n 0.30000 120780.0n 0.70000 120959.9n 0.70000 120960.0n 0.30000 121139.9n 0.30000 121140.0n 0.30000 121319.9n 0.30000 121320.0n 0.30000 121499.9n 0.30000 121500.0n 0.30000 121679.9n 0.30000 121680.0n 0.30000 121859.9n 0.30000 121860.0n 0.70000 122039.9n 0.70000 122040.0n 0.30000 122219.9n 0.30000 122220.0n 0.30000 122399.9n 0.30000 122400.0n 0.70000 122579.9n 0.70000 122580.0n 0.70000 122759.9n 0.70000 122760.0n 0.70000 122939.9n 0.70000 122940.0n 0.70000 123119.9n 0.70000 123120.0n 0.30000 123299.9n 0.30000 123300.0n 0.70000 123479.9n 0.70000 123480.0n 0.70000 123659.9n 0.70000 123660.0n 0.70000 123839.9n 0.70000 123840.0n 0.30000 124019.9n 0.30000 124020.0n 0.70000 124199.9n 0.70000 124200.0n 0.70000 124379.9n 0.70000 124380.0n 0.70000 124559.9n 0.70000 124560.0n 0.70000 124739.9n 0.70000 124740.0n 0.30000 124919.9n 0.30000 124920.0n 0.30000 125099.9n 0.30000 125100.0n 0.30000 125279.9n 0.30000 125280.0n 0.70000 125459.9n 0.70000 125460.0n 0.70000 125639.9n 0.70000 125640.0n 0.30000 125819.9n 0.30000 125820.0n 0.70000 125999.9n 0.70000 126000.0n 0.30000 126179.9n 0.30000 126180.0n 0.30000 126359.9n 0.30000 126360.0n 0.70000 126539.9n 0.70000 126540.0n 0.30000 126719.9n 0.30000 126720.0n 0.30000 126899.9n 0.30000 126900.0n 0.30000 127079.9n 0.30000 127080.0n 0.70000 127259.9n 0.70000 127260.0n 0.70000 127439.9n 0.70000 127440.0n 0.30000 127619.9n 0.30000 127620.0n 0.30000 127799.9n 0.30000 127800.0n 0.30000 127979.9n 0.30000 127980.0n 0.30000 128159.9n 0.30000 128160.0n 0.30000 128339.9n 0.30000 128340.0n 0.30000 128519.9n 0.30000 128520.0n 0.70000 128699.9n 0.70000 128700.0n 0.70000 128879.9n 0.70000 128880.0n 0.30000 129059.9n 0.30000 129060.0n 0.30000 129239.9n 0.30000 129240.0n 0.70000 129419.9n 0.70000 129420.0n 0.70000 129599.9n 0.70000 129600.0n 0.70000 129779.9n 0.70000 129780.0n 0.70000 129959.9n 0.70000 129960.0n 0.30000 130139.9n 0.30000 130140.0n 0.70000 130319.9n 0.70000 130320.0n 0.30000 130499.9n 0.30000 130500.0n 0.70000 130679.9n 0.70000 130680.0n 0.30000 130859.9n 0.30000 130860.0n 0.70000 131039.9n 0.70000 131040.0n 0.70000 131219.9n 0.70000 131220.0n 0.70000 131399.9n 0.70000 131400.0n 0.70000 131579.9n 0.70000 131580.0n 0.70000 131759.9n 0.70000 131760.0n 0.30000 131939.9n 0.30000 131940.0n 0.70000 132119.9n 0.70000 132120.0n 0.30000 132299.9n 0.30000 132300.0n 0.30000 132479.9n 0.30000 132480.0n 0.70000 132659.9n 0.70000 132660.0n 0.70000 132839.9n 0.70000 132840.0n 0.70000 133019.9n 0.70000 133020.0n 0.70000 133199.9n 0.70000 133200.0n 0.70000 133379.9n 0.70000 133380.0n 0.30000 133559.9n 0.30000 133560.0n 0.30000 133739.9n 0.30000 133740.0n 0.70000 133919.9n 0.70000 133920.0n 0.70000 134099.9n 0.70000 134100.0n 0.30000 134279.9n 0.30000 134280.0n 0.30000 134459.9n 0.30000 134460.0n 0.30000 134639.9n 0.30000 134640.0n 0.70000 134819.9n 0.70000 134820.0n 0.70000 134999.9n 0.70000 135000.0n 0.30000 135179.9n 0.30000 135180.0n 0.70000 135359.9n 0.70000 135360.0n 0.30000 135539.9n 0.30000 135540.0n 0.70000 135719.9n 0.70000 135720.0n 0.70000 135899.9n 0.70000 135900.0n 0.30000 136079.9n 0.30000 136080.0n 0.30000 136259.9n 0.30000 136260.0n 0.70000 136439.9n 0.70000 136440.0n 0.70000 136619.9n 0.70000 136620.0n 0.70000 136799.9n 0.70000 136800.0n 0.30000 136979.9n 0.30000 136980.0n 0.30000 137159.9n 0.30000 137160.0n 0.30000 137339.9n 0.30000 137340.0n 0.30000 137519.9n 0.30000 137520.0n 0.70000 137699.9n 0.70000 137700.0n 0.30000 137879.9n 0.30000 137880.0n 0.30000 138059.9n 0.30000 138060.0n 0.30000 138239.9n 0.30000 138240.0n 0.30000 138419.9n 0.30000 138420.0n 0.70000 138599.9n 0.70000 138600.0n 0.70000 138779.9n 0.70000 138780.0n 0.30000 138959.9n 0.30000 138960.0n 0.30000 139139.9n 0.30000 139140.0n 0.70000 139319.9n 0.70000 139320.0n 0.70000 139499.9n 0.70000 139500.0n 0.70000 139679.9n 0.70000 139680.0n 0.70000 139859.9n 0.70000 139860.0n 0.70000 140039.9n 0.70000 140040.0n 0.70000 140219.9n 0.70000 140220.0n 0.30000 140399.9n 0.30000 140400.0n 0.30000 140579.9n 0.30000 140580.0n 0.30000 140759.9n 0.30000 140760.0n 0.70000 140939.9n 0.70000 140940.0n 0.30000 141119.9n 0.30000 141120.0n 0.70000 141299.9n 0.70000 141300.0n 0.70000 141479.9n 0.70000 141480.0n 0.30000 141659.9n 0.30000 141660.0n 0.70000 141839.9n 0.70000 141840.0n 0.70000 142019.9n 0.70000 142020.0n 0.70000 142199.9n 0.70000 142200.0n 0.30000 142379.9n 0.30000 142380.0n 0.70000 142559.9n 0.70000 142560.0n 0.30000 142739.9n 0.30000 142740.0n 0.30000 142919.9n 0.30000 142920.0n 0.30000 143099.9n 0.30000 143100.0n 0.30000 143279.9n 0.30000 143280.0n 0.30000 143459.9n 0.30000 143460.0n 0.70000 143639.9n 0.70000 143640.0n 0.30000 143819.9n 0.30000 143820.0n 0.30000 143999.9n 0.30000 144000.0n 0.30000 144179.9n 0.30000 144180.0n 0.30000 144359.9n 0.30000 144360.0n 0.70000 144539.9n 0.70000 144540.0n 0.70000 144719.9n 0.70000 144720.0n 0.30000 144899.9n 0.30000 144900.0n 0.30000 145079.9n 0.30000 145080.0n 0.70000 145259.9n 0.70000 145260.0n 0.70000 145439.9n 0.70000 145440.0n 0.70000 145619.9n 0.70000 145620.0n 0.70000 145799.9n 0.70000 145800.0n 0.70000 145979.9n 0.70000 145980.0n 0.30000 146159.9n 0.30000 146160.0n 0.70000 146339.9n 0.70000 146340.0n 0.30000 146519.9n 0.30000 146520.0n 0.30000 146699.9n 0.30000 146700.0n 0.70000 146879.9n 0.70000 146880.0n 0.70000 147059.9n 0.70000 147060.0n 0.70000 147239.9n 0.70000 147240.0n 0.30000 147419.9n 0.30000 147420.0n 0.70000 147599.9n 0.70000 147600.0n 0.70000 147779.9n 0.70000 147780.0n 0.30000 147959.9n 0.30000 147960.0n 0.30000 148139.9n 0.30000 148140.0n 0.30000 148319.9n 0.30000 148320.0n 0.30000 148499.9n 0.30000 148500.0n 0.70000 148679.9n 0.70000 148680.0n 0.30000 148859.9n 0.30000 148860.0n 0.70000 149039.9n 0.70000 149040.0n 0.30000 149219.9n 0.30000 149220.0n 0.30000 149399.9n 0.30000 149400.0n 0.30000 149579.9n 0.30000 149580.0n 0.70000 149759.9n 0.70000 149760.0n 0.30000 149939.9n 0.30000 149940.0n 0.70000 150119.9n 0.70000 150120.0n 0.30000 150299.9n 0.30000 150300.0n 0.70000 150479.9n 0.70000 150480.0n 0.30000 150659.9n 0.30000 150660.0n 0.70000 150839.9n 0.70000 150840.0n 0.70000 151019.9n 0.70000 151020.0n 0.70000 151199.9n 0.70000 151200.0n 0.70000 151379.9n 0.70000 151380.0n 0.70000 151559.9n 0.70000 151560.0n 0.30000 151739.9n 0.30000 151740.0n 0.30000 151919.9n 0.30000 151920.0n 0.30000 152099.9n 0.30000 152100.0n 0.30000 152279.9n 0.30000 152280.0n 0.70000 152459.9n 0.70000 152460.0n 0.30000 152639.9n 0.30000 152640.0n 0.70000 152819.9n 0.70000 152820.0n 0.70000 152999.9n 0.70000 153000.0n 0.70000 153179.9n 0.70000 153180.0n 0.70000 153359.9n 0.70000 153360.0n 0.30000 153539.9n 0.30000 153540.0n 0.30000 153719.9n 0.30000 153720.0n 0.70000 153899.9n 0.70000 153900.0n 0.70000 154079.9n 0.70000 154080.0n 0.30000 154259.9n 0.30000 154260.0n 0.30000 154439.9n 0.30000 154440.0n 0.30000 154619.9n 0.30000 154620.0n 0.30000 154799.9n 0.30000 154800.0n 0.30000 154979.9n 0.30000 154980.0n 0.70000 155159.9n 0.70000 155160.0n 0.30000 155339.9n 0.30000 155340.0n 0.70000 155519.9n 0.70000 155520.0n 0.30000 155699.9n 0.30000 155700.0n 0.30000 155879.9n 0.30000 155880.0n 0.70000 156059.9n 0.70000 156060.0n 0.30000 156239.9n 0.30000 156240.0n 0.70000 156419.9n 0.70000 156420.0n 0.30000 156599.9n 0.30000 156600.0n 0.70000 156779.9n 0.70000 156780.0n 0.70000 156959.9n 0.70000 156960.0n 0.30000 157139.9n 0.30000 157140.0n 0.30000 157319.9n 0.30000 157320.0n 0.70000 157499.9n 0.70000 157500.0n 0.30000 157679.9n 0.30000 157680.0n 0.70000 157859.9n 0.70000 157860.0n 0.30000 158039.9n 0.30000 158040.0n 0.70000 158219.9n 0.70000 158220.0n 0.70000 158399.9n 0.70000 158400.0n 0.30000 158579.9n 0.30000 158580.0n 0.70000 158759.9n 0.70000 158760.0n 0.70000 158939.9n 0.70000 158940.0n 0.30000 159119.9n 0.30000 159120.0n 0.70000 159299.9n 0.70000 159300.0n 0.70000 159479.9n 0.70000 159480.0n 0.30000 159659.9n 0.30000 159660.0n 0.70000 159839.9n 0.70000 159840.0n 0.30000 160019.9n 0.30000 160020.0n 0.30000 160199.9n 0.30000 160200.0n 0.70000 160379.9n 0.70000 160380.0n 0.30000 160559.9n 0.30000 160560.0n 0.30000 160739.9n 0.30000 160740.0n 0.70000 160919.9n 0.70000 160920.0n 0.30000 161099.9n 0.30000 161100.0n 0.70000 161279.9n 0.70000 161280.0n 0.70000 161459.9n 0.70000 161460.0n 0.70000 161639.9n 0.70000 161640.0n 0.30000 161819.9n 0.30000 161820.0n 0.30000 161999.9n 0.30000 162000.0n 0.30000 162179.9n 0.30000 162180.0n 0.70000 162359.9n 0.70000 162360.0n 0.30000 162539.9n 0.30000 162540.0n 0.30000 162719.9n 0.30000 162720.0n 0.70000 162899.9n 0.70000 162900.0n 0.30000 163079.9n 0.30000 163080.0n 0.30000 163259.9n 0.30000 163260.0n 0.70000 163439.9n 0.70000 163440.0n 0.70000 163619.9n 0.70000 163620.0n 0.30000 163799.9n 0.30000 163800.0n 0.70000 163979.9n 0.70000 163980.0n 0.30000 164159.9n 0.30000 164160.0n 0.30000 164339.9n 0.30000 164340.0n 0.30000 164519.9n 0.30000 164520.0n 0.30000 164699.9n 0.30000 164700.0n 0.70000 164879.9n 0.70000 164880.0n 0.70000 165059.9n 0.70000 165060.0n 0.70000 165239.9n 0.70000 165240.0n 0.30000 165419.9n 0.30000 165420.0n 0.70000 165599.9n 0.70000 165600.0n 0.30000 165779.9n 0.30000 165780.0n 0.70000 165959.9n 0.70000 165960.0n 0.70000 166139.9n 0.70000 166140.0n 0.30000 166319.9n 0.30000 166320.0n 0.30000 166499.9n 0.30000 166500.0n 0.70000 166679.9n 0.70000 166680.0n 0.70000 166859.9n 0.70000 166860.0n 0.70000 167039.9n 0.70000 167040.0n 0.30000 167219.9n 0.30000 167220.0n 0.70000 167399.9n 0.70000 167400.0n 0.30000 167579.9n 0.30000 167580.0n 0.30000 167759.9n 0.30000 167760.0n 0.30000 167939.9n 0.30000 167940.0n 0.30000 168119.9n 0.30000 168120.0n 0.70000 168299.9n 0.70000 168300.0n 0.70000 168479.9n 0.70000 168480.0n 0.30000 168659.9n 0.30000 168660.0n 0.70000 168839.9n 0.70000 168840.0n 0.30000 169019.9n 0.30000 169020.0n 0.70000 169199.9n 0.70000 169200.0n 0.70000 169379.9n 0.70000 169380.0n 0.30000 169559.9n 0.30000 169560.0n 0.30000 169739.9n 0.30000 169740.0n 0.30000 169919.9n 0.30000 169920.0n 0.70000 170099.9n 0.70000 170100.0n 0.30000 170279.9n 0.30000 170280.0n 0.70000 170459.9n 0.70000 170460.0n 0.30000 170639.9n 0.30000 170640.0n 0.30000 170819.9n 0.30000 170820.0n 0.70000 170999.9n 0.70000 171000.0n 0.70000 171179.9n 0.70000 171180.0n 0.30000 171359.9n 0.30000 171360.0n 0.70000 171539.9n 0.70000 171540.0n 0.70000 171719.9n 0.70000 171720.0n 0.70000 171899.9n 0.70000 171900.0n 0.70000 172079.9n 0.70000 172080.0n 0.70000 172259.9n 0.70000 172260.0n 0.30000 172439.9n 0.30000 172440.0n 0.30000 172619.9n 0.30000 172620.0n 0.70000 172799.9n 0.70000 172800.0n 0.50000 172979.9n 0.50000 172980.0n 0.50000 173159.9n 0.50000 173160.0n 0.50000 173339.9n 0.50000 173340.0n 0.50000 173519.9n 0.50000 173520.0n 0.50000 173699.9n 0.50000 173700.0n 0.50000 173879.9n 0.50000 173880.0n 0.50000 174059.9n 0.50000 174060.0n 0.50000 174239.9n 0.50000 174240.0n 0.50000 174419.9n 0.50000 174420.0n 0.50000 174599.9n 0.50000 174600.0n 0.50000 174779.9n 0.50000 174780.0n 0.50000 174959.9n 0.50000 174960.0n 0.50000 175139.9n 0.50000 175140.0n 0.50000 175319.9n 0.50000 175320.0n 0.50000 175499.9n 0.50000 175500.0n 0.50000 175679.9n 0.50000 175680.0n 0.50000 175859.9n 0.50000 175860.0n 0.50000 176039.9n 0.50000 176040.0n 0.50000 176219.9n 0.50000 176220.0n 0.50000 176399.9n 0.50000 176400.0n 0.50000 176579.9n 0.50000 176580.0n 0.50000 176759.9n 0.50000 176760.0n 0.50000 176939.9n 0.50000 176940.0n 0.50000 177119.9n 0.50000 177120.0n 0.50000 177299.9n 0.50000 177300.0n 0.50000 177479.9n 0.50000 177480.0n 0.50000 177659.9n 0.50000 177660.0n 0.50000 177839.9n 0.50000 177840.0n 0.50000 178019.9n 0.50000 178020.0n 0.50000 178199.9n 0.50000 178200.0n 0.50000 178379.9n 0.50000 178380.0n 0.50000 178559.9n 0.50000 178560.0n 0.50000 178739.9n 0.50000 178740.0n 0.50000 178919.9n 0.50000 178920.0n 0.50000 179099.9n 0.50000 179100.0n 0.50000 179279.9n 0.50000 179280.0n 0.50000 179459.9n 0.50000 179460.0n 0.50000 179639.9n 0.50000 179640.0n 0.50000 179819.9n 0.50000 179820.0n 0.50000 179999.9n 0.50000 180000.0n 0.50000 180179.9n 0.50000 180180.0n 0.50000 180359.9n 0.50000 180360.0n 0.50000 180539.9n 0.50000 180540.0n 0.50000 180719.9n 0.50000 180720.0n 0.50000 180899.9n 0.50000 180900.0n 0.50000 181079.9n 0.50000 181080.0n 0.50000 181259.9n 0.50000 181260.0n 0.50000 181439.9n 0.50000 181440.0n 0.50000 181619.9n 0.50000 181620.0n 0.50000 181799.9n 0.50000 181800.0n 0.50000 181979.9n 0.50000 181980.0n 0.50000 182159.9n 0.50000 182160.0n 0.50000 182339.9n 0.50000 182340.0n 0.50000 182519.9n 0.50000 182520.0n 0.50000 182699.9n 0.50000 182700.0n 0.50000 182879.9n 0.50000 182880.0n 0.50000 183059.9n 0.50000 183060.0n 0.50000 183239.9n 0.50000 183240.0n 0.50000 183419.9n 0.50000 183420.0n 0.50000)
Vxon0 xon0 0 PWL(0.0n 0.70000 179.9n 0.70000 180.0n 0.70000 359.9n 0.70000 360.0n 0.30000 539.9n 0.30000 540.0n 0.70000 719.9n 0.70000 720.0n 0.70000 899.9n 0.70000 900.0n 0.70000 1079.9n 0.70000 1080.0n 0.30000 1259.9n 0.30000 1260.0n 0.30000 1439.9n 0.30000 1440.0n 0.30000 1619.9n 0.30000 1620.0n 0.70000 1799.9n 0.70000 1800.0n 0.70000 1979.9n 0.70000 1980.0n 0.30000 2159.9n 0.30000 2160.0n 0.30000 2339.9n 0.30000 2340.0n 0.30000 2519.9n 0.30000 2520.0n 0.70000 2699.9n 0.70000 2700.0n 0.30000 2879.9n 0.30000 2880.0n 0.30000 3059.9n 0.30000 3060.0n 0.70000 3239.9n 0.70000 3240.0n 0.70000 3419.9n 0.70000 3420.0n 0.70000 3599.9n 0.70000 3600.0n 0.30000 3779.9n 0.30000 3780.0n 0.70000 3959.9n 0.70000 3960.0n 0.70000 4139.9n 0.70000 4140.0n 0.30000 4319.9n 0.30000 4320.0n 0.30000 4499.9n 0.30000 4500.0n 0.70000 4679.9n 0.70000 4680.0n 0.30000 4859.9n 0.30000 4860.0n 0.30000 5039.9n 0.30000 5040.0n 0.30000 5219.9n 0.30000 5220.0n 0.30000 5399.9n 0.30000 5400.0n 0.70000 5579.9n 0.70000 5580.0n 0.70000 5759.9n 0.70000 5760.0n 0.70000 5939.9n 0.70000 5940.0n 0.70000 6119.9n 0.70000 6120.0n 0.70000 6299.9n 0.70000 6300.0n 0.30000 6479.9n 0.30000 6480.0n 0.30000 6659.9n 0.30000 6660.0n 0.70000 6839.9n 0.70000 6840.0n 0.70000 7019.9n 0.70000 7020.0n 0.30000 7199.9n 0.30000 7200.0n 0.30000 7379.9n 0.30000 7380.0n 0.30000 7559.9n 0.30000 7560.0n 0.70000 7739.9n 0.70000 7740.0n 0.70000 7919.9n 0.70000 7920.0n 0.70000 8099.9n 0.70000 8100.0n 0.30000 8279.9n 0.30000 8280.0n 0.70000 8459.9n 0.70000 8460.0n 0.30000 8639.9n 0.30000 8640.0n 0.70000 8819.9n 0.70000 8820.0n 0.30000 8999.9n 0.30000 9000.0n 0.30000 9179.9n 0.30000 9180.0n 0.30000 9359.9n 0.30000 9360.0n 0.30000 9539.9n 0.30000 9540.0n 0.30000 9719.9n 0.30000 9720.0n 0.70000 9899.9n 0.70000 9900.0n 0.70000 10079.9n 0.70000 10080.0n 0.70000 10259.9n 0.70000 10260.0n 0.30000 10439.9n 0.30000 10440.0n 0.30000 10619.9n 0.30000 10620.0n 0.70000 10799.9n 0.70000 10800.0n 0.30000 10979.9n 0.30000 10980.0n 0.30000 11159.9n 0.30000 11160.0n 0.70000 11339.9n 0.70000 11340.0n 0.70000 11519.9n 0.70000 11520.0n 0.70000 11699.9n 0.70000 11700.0n 0.30000 11879.9n 0.30000 11880.0n 0.30000 12059.9n 0.30000 12060.0n 0.30000 12239.9n 0.30000 12240.0n 0.70000 12419.9n 0.70000 12420.0n 0.70000 12599.9n 0.70000 12600.0n 0.30000 12779.9n 0.30000 12780.0n 0.70000 12959.9n 0.70000 12960.0n 0.70000 13139.9n 0.70000 13140.0n 0.30000 13319.9n 0.30000 13320.0n 0.70000 13499.9n 0.70000 13500.0n 0.30000 13679.9n 0.30000 13680.0n 0.30000 13859.9n 0.30000 13860.0n 0.30000 14039.9n 0.30000 14040.0n 0.30000 14219.9n 0.30000 14220.0n 0.70000 14399.9n 0.70000 14400.0n 0.30000 14579.9n 0.30000 14580.0n 0.30000 14759.9n 0.30000 14760.0n 0.70000 14939.9n 0.70000 14940.0n 0.70000 15119.9n 0.70000 15120.0n 0.70000 15299.9n 0.70000 15300.0n 0.30000 15479.9n 0.30000 15480.0n 0.30000 15659.9n 0.30000 15660.0n 0.70000 15839.9n 0.70000 15840.0n 0.70000 16019.9n 0.70000 16020.0n 0.30000 16199.9n 0.30000 16200.0n 0.70000 16379.9n 0.70000 16380.0n 0.30000 16559.9n 0.30000 16560.0n 0.30000 16739.9n 0.30000 16740.0n 0.70000 16919.9n 0.70000 16920.0n 0.70000 17099.9n 0.70000 17100.0n 0.70000 17279.9n 0.70000 17280.0n 0.70000 17459.9n 0.70000 17460.0n 0.30000 17639.9n 0.30000 17640.0n 0.30000 17819.9n 0.30000 17820.0n 0.70000 17999.9n 0.70000 18000.0n 0.30000 18179.9n 0.30000 18180.0n 0.70000 18359.9n 0.70000 18360.0n 0.70000 18539.9n 0.70000 18540.0n 0.30000 18719.9n 0.30000 18720.0n 0.30000 18899.9n 0.30000 18900.0n 0.30000 19079.9n 0.30000 19080.0n 0.30000 19259.9n 0.30000 19260.0n 0.30000 19439.9n 0.30000 19440.0n 0.30000 19619.9n 0.30000 19620.0n 0.70000 19799.9n 0.70000 19800.0n 0.70000 19979.9n 0.70000 19980.0n 0.30000 20159.9n 0.30000 20160.0n 0.70000 20339.9n 0.70000 20340.0n 0.30000 20519.9n 0.30000 20520.0n 0.30000 20699.9n 0.30000 20700.0n 0.70000 20879.9n 0.70000 20880.0n 0.70000 21059.9n 0.70000 21060.0n 0.30000 21239.9n 0.30000 21240.0n 0.30000 21419.9n 0.30000 21420.0n 0.70000 21599.9n 0.70000 21600.0n 0.70000 21779.9n 0.70000 21780.0n 0.70000 21959.9n 0.70000 21960.0n 0.70000 22139.9n 0.70000 22140.0n 0.70000 22319.9n 0.70000 22320.0n 0.30000 22499.9n 0.30000 22500.0n 0.70000 22679.9n 0.70000 22680.0n 0.30000 22859.9n 0.30000 22860.0n 0.70000 23039.9n 0.70000 23040.0n 0.30000 23219.9n 0.30000 23220.0n 0.30000 23399.9n 0.30000 23400.0n 0.30000 23579.9n 0.30000 23580.0n 0.70000 23759.9n 0.70000 23760.0n 0.30000 23939.9n 0.30000 23940.0n 0.30000 24119.9n 0.30000 24120.0n 0.30000 24299.9n 0.30000 24300.0n 0.70000 24479.9n 0.70000 24480.0n 0.30000 24659.9n 0.30000 24660.0n 0.30000 24839.9n 0.30000 24840.0n 0.30000 25019.9n 0.30000 25020.0n 0.30000 25199.9n 0.30000 25200.0n 0.70000 25379.9n 0.70000 25380.0n 0.70000 25559.9n 0.70000 25560.0n 0.70000 25739.9n 0.70000 25740.0n 0.30000 25919.9n 0.30000 25920.0n 0.30000 26099.9n 0.30000 26100.0n 0.30000 26279.9n 0.30000 26280.0n 0.70000 26459.9n 0.70000 26460.0n 0.70000 26639.9n 0.70000 26640.0n 0.70000 26819.9n 0.70000 26820.0n 0.30000 26999.9n 0.30000 27000.0n 0.30000 27179.9n 0.30000 27180.0n 0.30000 27359.9n 0.30000 27360.0n 0.70000 27539.9n 0.70000 27540.0n 0.70000 27719.9n 0.70000 27720.0n 0.70000 27899.9n 0.70000 27900.0n 0.70000 28079.9n 0.70000 28080.0n 0.70000 28259.9n 0.70000 28260.0n 0.70000 28439.9n 0.70000 28440.0n 0.70000 28619.9n 0.70000 28620.0n 0.70000 28799.9n 0.70000 28800.0n 0.70000 28979.9n 0.70000 28980.0n 0.30000 29159.9n 0.30000 29160.0n 0.30000 29339.9n 0.30000 29340.0n 0.30000 29519.9n 0.30000 29520.0n 0.70000 29699.9n 0.70000 29700.0n 0.30000 29879.9n 0.30000 29880.0n 0.70000 30059.9n 0.70000 30060.0n 0.70000 30239.9n 0.70000 30240.0n 0.70000 30419.9n 0.70000 30420.0n 0.30000 30599.9n 0.30000 30600.0n 0.30000 30779.9n 0.30000 30780.0n 0.30000 30959.9n 0.30000 30960.0n 0.70000 31139.9n 0.70000 31140.0n 0.70000 31319.9n 0.70000 31320.0n 0.30000 31499.9n 0.30000 31500.0n 0.70000 31679.9n 0.70000 31680.0n 0.30000 31859.9n 0.30000 31860.0n 0.70000 32039.9n 0.70000 32040.0n 0.70000 32219.9n 0.70000 32220.0n 0.30000 32399.9n 0.30000 32400.0n 0.30000 32579.9n 0.30000 32580.0n 0.30000 32759.9n 0.30000 32760.0n 0.30000 32939.9n 0.30000 32940.0n 0.30000 33119.9n 0.30000 33120.0n 0.30000 33299.9n 0.30000 33300.0n 0.70000 33479.9n 0.70000 33480.0n 0.70000 33659.9n 0.70000 33660.0n 0.70000 33839.9n 0.70000 33840.0n 0.70000 34019.9n 0.70000 34020.0n 0.30000 34199.9n 0.30000 34200.0n 0.70000 34379.9n 0.70000 34380.0n 0.70000 34559.9n 0.70000 34560.0n 0.30000 34739.9n 0.30000 34740.0n 0.30000 34919.9n 0.30000 34920.0n 0.70000 35099.9n 0.70000 35100.0n 0.70000 35279.9n 0.70000 35280.0n 0.70000 35459.9n 0.70000 35460.0n 0.70000 35639.9n 0.70000 35640.0n 0.30000 35819.9n 0.30000 35820.0n 0.30000 35999.9n 0.30000 36000.0n 0.30000 36179.9n 0.30000 36180.0n 0.30000 36359.9n 0.30000 36360.0n 0.30000 36539.9n 0.30000 36540.0n 0.30000 36719.9n 0.30000 36720.0n 0.30000 36899.9n 0.30000 36900.0n 0.30000 37079.9n 0.30000 37080.0n 0.70000 37259.9n 0.70000 37260.0n 0.30000 37439.9n 0.30000 37440.0n 0.70000 37619.9n 0.70000 37620.0n 0.70000 37799.9n 0.70000 37800.0n 0.70000 37979.9n 0.70000 37980.0n 0.70000 38159.9n 0.70000 38160.0n 0.30000 38339.9n 0.30000 38340.0n 0.30000 38519.9n 0.30000 38520.0n 0.70000 38699.9n 0.70000 38700.0n 0.30000 38879.9n 0.30000 38880.0n 0.70000 39059.9n 0.70000 39060.0n 0.30000 39239.9n 0.30000 39240.0n 0.70000 39419.9n 0.70000 39420.0n 0.30000 39599.9n 0.30000 39600.0n 0.70000 39779.9n 0.70000 39780.0n 0.70000 39959.9n 0.70000 39960.0n 0.70000 40139.9n 0.70000 40140.0n 0.70000 40319.9n 0.70000 40320.0n 0.30000 40499.9n 0.30000 40500.0n 0.30000 40679.9n 0.30000 40680.0n 0.70000 40859.9n 0.70000 40860.0n 0.70000 41039.9n 0.70000 41040.0n 0.70000 41219.9n 0.70000 41220.0n 0.30000 41399.9n 0.30000 41400.0n 0.30000 41579.9n 0.30000 41580.0n 0.70000 41759.9n 0.70000 41760.0n 0.70000 41939.9n 0.70000 41940.0n 0.70000 42119.9n 0.70000 42120.0n 0.30000 42299.9n 0.30000 42300.0n 0.70000 42479.9n 0.70000 42480.0n 0.30000 42659.9n 0.30000 42660.0n 0.30000 42839.9n 0.30000 42840.0n 0.30000 43019.9n 0.30000 43020.0n 0.30000 43199.9n 0.30000 43200.0n 0.70000 43379.9n 0.70000 43380.0n 0.30000 43559.9n 0.30000 43560.0n 0.30000 43739.9n 0.30000 43740.0n 0.70000 43919.9n 0.70000 43920.0n 0.30000 44099.9n 0.30000 44100.0n 0.70000 44279.9n 0.70000 44280.0n 0.70000 44459.9n 0.70000 44460.0n 0.70000 44639.9n 0.70000 44640.0n 0.30000 44819.9n 0.30000 44820.0n 0.70000 44999.9n 0.70000 45000.0n 0.30000 45179.9n 0.30000 45180.0n 0.30000 45359.9n 0.30000 45360.0n 0.70000 45539.9n 0.70000 45540.0n 0.30000 45719.9n 0.30000 45720.0n 0.70000 45899.9n 0.70000 45900.0n 0.70000 46079.9n 0.70000 46080.0n 0.30000 46259.9n 0.30000 46260.0n 0.30000 46439.9n 0.30000 46440.0n 0.30000 46619.9n 0.30000 46620.0n 0.70000 46799.9n 0.70000 46800.0n 0.30000 46979.9n 0.30000 46980.0n 0.70000 47159.9n 0.70000 47160.0n 0.70000 47339.9n 0.70000 47340.0n 0.30000 47519.9n 0.30000 47520.0n 0.30000 47699.9n 0.30000 47700.0n 0.30000 47879.9n 0.30000 47880.0n 0.30000 48059.9n 0.30000 48060.0n 0.70000 48239.9n 0.70000 48240.0n 0.70000 48419.9n 0.70000 48420.0n 0.70000 48599.9n 0.70000 48600.0n 0.70000 48779.9n 0.70000 48780.0n 0.30000 48959.9n 0.30000 48960.0n 0.70000 49139.9n 0.70000 49140.0n 0.70000 49319.9n 0.70000 49320.0n 0.70000 49499.9n 0.70000 49500.0n 0.70000 49679.9n 0.70000 49680.0n 0.30000 49859.9n 0.30000 49860.0n 0.30000 50039.9n 0.30000 50040.0n 0.30000 50219.9n 0.30000 50220.0n 0.30000 50399.9n 0.30000 50400.0n 0.30000 50579.9n 0.30000 50580.0n 0.70000 50759.9n 0.70000 50760.0n 0.70000 50939.9n 0.70000 50940.0n 0.70000 51119.9n 0.70000 51120.0n 0.70000 51299.9n 0.70000 51300.0n 0.30000 51479.9n 0.30000 51480.0n 0.70000 51659.9n 0.70000 51660.0n 0.30000 51839.9n 0.30000 51840.0n 0.70000 52019.9n 0.70000 52020.0n 0.70000 52199.9n 0.70000 52200.0n 0.30000 52379.9n 0.30000 52380.0n 0.30000 52559.9n 0.30000 52560.0n 0.70000 52739.9n 0.70000 52740.0n 0.30000 52919.9n 0.30000 52920.0n 0.30000 53099.9n 0.30000 53100.0n 0.70000 53279.9n 0.70000 53280.0n 0.70000 53459.9n 0.70000 53460.0n 0.70000 53639.9n 0.70000 53640.0n 0.70000 53819.9n 0.70000 53820.0n 0.70000 53999.9n 0.70000 54000.0n 0.70000 54179.9n 0.70000 54180.0n 0.30000 54359.9n 0.30000 54360.0n 0.70000 54539.9n 0.70000 54540.0n 0.30000 54719.9n 0.30000 54720.0n 0.30000 54899.9n 0.30000 54900.0n 0.30000 55079.9n 0.30000 55080.0n 0.30000 55259.9n 0.30000 55260.0n 0.30000 55439.9n 0.30000 55440.0n 0.30000 55619.9n 0.30000 55620.0n 0.30000 55799.9n 0.30000 55800.0n 0.70000 55979.9n 0.70000 55980.0n 0.70000 56159.9n 0.70000 56160.0n 0.70000 56339.9n 0.70000 56340.0n 0.70000 56519.9n 0.70000 56520.0n 0.30000 56699.9n 0.30000 56700.0n 0.30000 56879.9n 0.30000 56880.0n 0.30000 57059.9n 0.30000 57060.0n 0.70000 57239.9n 0.70000 57240.0n 0.70000 57419.9n 0.70000 57420.0n 0.30000 57599.9n 0.30000 57600.0n 0.30000 57779.9n 0.30000 57780.0n 0.30000 57959.9n 0.30000 57960.0n 0.70000 58139.9n 0.70000 58140.0n 0.30000 58319.9n 0.30000 58320.0n 0.30000 58499.9n 0.30000 58500.0n 0.70000 58679.9n 0.70000 58680.0n 0.30000 58859.9n 0.30000 58860.0n 0.70000 59039.9n 0.70000 59040.0n 0.30000 59219.9n 0.30000 59220.0n 0.70000 59399.9n 0.70000 59400.0n 0.70000 59579.9n 0.70000 59580.0n 0.70000 59759.9n 0.70000 59760.0n 0.70000 59939.9n 0.70000 59940.0n 0.30000 60119.9n 0.30000 60120.0n 0.70000 60299.9n 0.70000 60300.0n 0.70000 60479.9n 0.70000 60480.0n 0.30000 60659.9n 0.30000 60660.0n 0.30000 60839.9n 0.30000 60840.0n 0.30000 61019.9n 0.30000 61020.0n 0.30000 61199.9n 0.30000 61200.0n 0.70000 61379.9n 0.70000 61380.0n 0.70000 61559.9n 0.70000 61560.0n 0.70000 61739.9n 0.70000 61740.0n 0.30000 61919.9n 0.30000 61920.0n 0.30000 62099.9n 0.30000 62100.0n 0.70000 62279.9n 0.70000 62280.0n 0.30000 62459.9n 0.30000 62460.0n 0.70000 62639.9n 0.70000 62640.0n 0.30000 62819.9n 0.30000 62820.0n 0.70000 62999.9n 0.70000 63000.0n 0.70000 63179.9n 0.70000 63180.0n 0.30000 63359.9n 0.30000 63360.0n 0.70000 63539.9n 0.70000 63540.0n 0.30000 63719.9n 0.30000 63720.0n 0.30000 63899.9n 0.30000 63900.0n 0.30000 64079.9n 0.30000 64080.0n 0.30000 64259.9n 0.30000 64260.0n 0.70000 64439.9n 0.70000 64440.0n 0.70000 64619.9n 0.70000 64620.0n 0.70000 64799.9n 0.70000 64800.0n 0.70000 64979.9n 0.70000 64980.0n 0.70000 65159.9n 0.70000 65160.0n 0.30000 65339.9n 0.30000 65340.0n 0.30000 65519.9n 0.30000 65520.0n 0.30000 65699.9n 0.30000 65700.0n 0.30000 65879.9n 0.30000 65880.0n 0.70000 66059.9n 0.70000 66060.0n 0.70000 66239.9n 0.70000 66240.0n 0.70000 66419.9n 0.70000 66420.0n 0.30000 66599.9n 0.30000 66600.0n 0.30000 66779.9n 0.30000 66780.0n 0.70000 66959.9n 0.70000 66960.0n 0.70000 67139.9n 0.70000 67140.0n 0.30000 67319.9n 0.30000 67320.0n 0.30000 67499.9n 0.30000 67500.0n 0.70000 67679.9n 0.70000 67680.0n 0.70000 67859.9n 0.70000 67860.0n 0.30000 68039.9n 0.30000 68040.0n 0.30000 68219.9n 0.30000 68220.0n 0.70000 68399.9n 0.70000 68400.0n 0.70000 68579.9n 0.70000 68580.0n 0.30000 68759.9n 0.30000 68760.0n 0.30000 68939.9n 0.30000 68940.0n 0.70000 69119.9n 0.70000 69120.0n 0.70000 69299.9n 0.70000 69300.0n 0.30000 69479.9n 0.30000 69480.0n 0.30000 69659.9n 0.30000 69660.0n 0.30000 69839.9n 0.30000 69840.0n 0.30000 70019.9n 0.30000 70020.0n 0.30000 70199.9n 0.30000 70200.0n 0.30000 70379.9n 0.30000 70380.0n 0.30000 70559.9n 0.30000 70560.0n 0.70000 70739.9n 0.70000 70740.0n 0.70000 70919.9n 0.70000 70920.0n 0.30000 71099.9n 0.30000 71100.0n 0.30000 71279.9n 0.30000 71280.0n 0.30000 71459.9n 0.30000 71460.0n 0.70000 71639.9n 0.70000 71640.0n 0.70000 71819.9n 0.70000 71820.0n 0.30000 71999.9n 0.30000 72000.0n 0.70000 72179.9n 0.70000 72180.0n 0.70000 72359.9n 0.70000 72360.0n 0.70000 72539.9n 0.70000 72540.0n 0.30000 72719.9n 0.30000 72720.0n 0.70000 72899.9n 0.70000 72900.0n 0.70000 73079.9n 0.70000 73080.0n 0.70000 73259.9n 0.70000 73260.0n 0.30000 73439.9n 0.30000 73440.0n 0.70000 73619.9n 0.70000 73620.0n 0.70000 73799.9n 0.70000 73800.0n 0.30000 73979.9n 0.30000 73980.0n 0.30000 74159.9n 0.30000 74160.0n 0.70000 74339.9n 0.70000 74340.0n 0.70000 74519.9n 0.70000 74520.0n 0.70000 74699.9n 0.70000 74700.0n 0.30000 74879.9n 0.30000 74880.0n 0.70000 75059.9n 0.70000 75060.0n 0.70000 75239.9n 0.70000 75240.0n 0.70000 75419.9n 0.70000 75420.0n 0.30000 75599.9n 0.30000 75600.0n 0.30000 75779.9n 0.30000 75780.0n 0.30000 75959.9n 0.30000 75960.0n 0.70000 76139.9n 0.70000 76140.0n 0.70000 76319.9n 0.70000 76320.0n 0.30000 76499.9n 0.30000 76500.0n 0.30000 76679.9n 0.30000 76680.0n 0.30000 76859.9n 0.30000 76860.0n 0.30000 77039.9n 0.30000 77040.0n 0.30000 77219.9n 0.30000 77220.0n 0.70000 77399.9n 0.70000 77400.0n 0.70000 77579.9n 0.70000 77580.0n 0.70000 77759.9n 0.70000 77760.0n 0.30000 77939.9n 0.30000 77940.0n 0.30000 78119.9n 0.30000 78120.0n 0.70000 78299.9n 0.70000 78300.0n 0.70000 78479.9n 0.70000 78480.0n 0.30000 78659.9n 0.30000 78660.0n 0.70000 78839.9n 0.70000 78840.0n 0.70000 79019.9n 0.70000 79020.0n 0.30000 79199.9n 0.30000 79200.0n 0.30000 79379.9n 0.30000 79380.0n 0.30000 79559.9n 0.30000 79560.0n 0.30000 79739.9n 0.30000 79740.0n 0.70000 79919.9n 0.70000 79920.0n 0.70000 80099.9n 0.70000 80100.0n 0.70000 80279.9n 0.70000 80280.0n 0.30000 80459.9n 0.30000 80460.0n 0.70000 80639.9n 0.70000 80640.0n 0.70000 80819.9n 0.70000 80820.0n 0.70000 80999.9n 0.70000 81000.0n 0.70000 81179.9n 0.70000 81180.0n 0.30000 81359.9n 0.30000 81360.0n 0.70000 81539.9n 0.70000 81540.0n 0.70000 81719.9n 0.70000 81720.0n 0.70000 81899.9n 0.70000 81900.0n 0.70000 82079.9n 0.70000 82080.0n 0.30000 82259.9n 0.30000 82260.0n 0.70000 82439.9n 0.70000 82440.0n 0.30000 82619.9n 0.30000 82620.0n 0.30000 82799.9n 0.30000 82800.0n 0.30000 82979.9n 0.30000 82980.0n 0.30000 83159.9n 0.30000 83160.0n 0.70000 83339.9n 0.70000 83340.0n 0.30000 83519.9n 0.30000 83520.0n 0.30000 83699.9n 0.30000 83700.0n 0.70000 83879.9n 0.70000 83880.0n 0.70000 84059.9n 0.70000 84060.0n 0.30000 84239.9n 0.30000 84240.0n 0.30000 84419.9n 0.30000 84420.0n 0.30000 84599.9n 0.30000 84600.0n 0.30000 84779.9n 0.30000 84780.0n 0.70000 84959.9n 0.70000 84960.0n 0.30000 85139.9n 0.30000 85140.0n 0.30000 85319.9n 0.30000 85320.0n 0.70000 85499.9n 0.70000 85500.0n 0.70000 85679.9n 0.70000 85680.0n 0.70000 85859.9n 0.70000 85860.0n 0.30000 86039.9n 0.30000 86040.0n 0.70000 86219.9n 0.70000 86220.0n 0.30000 86399.9n 0.30000 86400.0n 0.70000 86579.9n 0.70000 86580.0n 0.30000 86759.9n 0.30000 86760.0n 0.30000 86939.9n 0.30000 86940.0n 0.30000 87119.9n 0.30000 87120.0n 0.70000 87299.9n 0.70000 87300.0n 0.70000 87479.9n 0.70000 87480.0n 0.70000 87659.9n 0.70000 87660.0n 0.30000 87839.9n 0.30000 87840.0n 0.30000 88019.9n 0.30000 88020.0n 0.70000 88199.9n 0.70000 88200.0n 0.70000 88379.9n 0.70000 88380.0n 0.30000 88559.9n 0.30000 88560.0n 0.70000 88739.9n 0.70000 88740.0n 0.30000 88919.9n 0.30000 88920.0n 0.30000 89099.9n 0.30000 89100.0n 0.30000 89279.9n 0.30000 89280.0n 0.30000 89459.9n 0.30000 89460.0n 0.30000 89639.9n 0.30000 89640.0n 0.30000 89819.9n 0.30000 89820.0n 0.70000 89999.9n 0.70000 90000.0n 0.70000 90179.9n 0.70000 90180.0n 0.70000 90359.9n 0.70000 90360.0n 0.30000 90539.9n 0.30000 90540.0n 0.30000 90719.9n 0.30000 90720.0n 0.30000 90899.9n 0.30000 90900.0n 0.70000 91079.9n 0.70000 91080.0n 0.70000 91259.9n 0.70000 91260.0n 0.70000 91439.9n 0.70000 91440.0n 0.30000 91619.9n 0.30000 91620.0n 0.70000 91799.9n 0.70000 91800.0n 0.70000 91979.9n 0.70000 91980.0n 0.70000 92159.9n 0.70000 92160.0n 0.70000 92339.9n 0.70000 92340.0n 0.70000 92519.9n 0.70000 92520.0n 0.70000 92699.9n 0.70000 92700.0n 0.70000 92879.9n 0.70000 92880.0n 0.70000 93059.9n 0.70000 93060.0n 0.70000 93239.9n 0.70000 93240.0n 0.70000 93419.9n 0.70000 93420.0n 0.70000 93599.9n 0.70000 93600.0n 0.70000 93779.9n 0.70000 93780.0n 0.30000 93959.9n 0.30000 93960.0n 0.30000 94139.9n 0.30000 94140.0n 0.70000 94319.9n 0.70000 94320.0n 0.30000 94499.9n 0.30000 94500.0n 0.30000 94679.9n 0.30000 94680.0n 0.70000 94859.9n 0.70000 94860.0n 0.70000 95039.9n 0.70000 95040.0n 0.30000 95219.9n 0.30000 95220.0n 0.30000 95399.9n 0.30000 95400.0n 0.30000 95579.9n 0.30000 95580.0n 0.70000 95759.9n 0.70000 95760.0n 0.70000 95939.9n 0.70000 95940.0n 0.30000 96119.9n 0.30000 96120.0n 0.30000 96299.9n 0.30000 96300.0n 0.30000 96479.9n 0.30000 96480.0n 0.70000 96659.9n 0.70000 96660.0n 0.30000 96839.9n 0.30000 96840.0n 0.30000 97019.9n 0.30000 97020.0n 0.30000 97199.9n 0.30000 97200.0n 0.70000 97379.9n 0.70000 97380.0n 0.30000 97559.9n 0.30000 97560.0n 0.30000 97739.9n 0.30000 97740.0n 0.30000 97919.9n 0.30000 97920.0n 0.70000 98099.9n 0.70000 98100.0n 0.70000 98279.9n 0.70000 98280.0n 0.70000 98459.9n 0.70000 98460.0n 0.70000 98639.9n 0.70000 98640.0n 0.30000 98819.9n 0.30000 98820.0n 0.30000 98999.9n 0.30000 99000.0n 0.30000 99179.9n 0.30000 99180.0n 0.30000 99359.9n 0.30000 99360.0n 0.70000 99539.9n 0.70000 99540.0n 0.70000 99719.9n 0.70000 99720.0n 0.30000 99899.9n 0.30000 99900.0n 0.70000 100079.9n 0.70000 100080.0n 0.30000 100259.9n 0.30000 100260.0n 0.70000 100439.9n 0.70000 100440.0n 0.30000 100619.9n 0.30000 100620.0n 0.70000 100799.9n 0.70000 100800.0n 0.70000 100979.9n 0.70000 100980.0n 0.30000 101159.9n 0.30000 101160.0n 0.30000 101339.9n 0.30000 101340.0n 0.70000 101519.9n 0.70000 101520.0n 0.30000 101699.9n 0.30000 101700.0n 0.30000 101879.9n 0.30000 101880.0n 0.30000 102059.9n 0.30000 102060.0n 0.70000 102239.9n 0.70000 102240.0n 0.70000 102419.9n 0.70000 102420.0n 0.70000 102599.9n 0.70000 102600.0n 0.30000 102779.9n 0.30000 102780.0n 0.70000 102959.9n 0.70000 102960.0n 0.30000 103139.9n 0.30000 103140.0n 0.30000 103319.9n 0.30000 103320.0n 0.30000 103499.9n 0.30000 103500.0n 0.70000 103679.9n 0.70000 103680.0n 0.70000 103859.9n 0.70000 103860.0n 0.70000 104039.9n 0.70000 104040.0n 0.30000 104219.9n 0.30000 104220.0n 0.70000 104399.9n 0.70000 104400.0n 0.70000 104579.9n 0.70000 104580.0n 0.70000 104759.9n 0.70000 104760.0n 0.30000 104939.9n 0.30000 104940.0n 0.70000 105119.9n 0.70000 105120.0n 0.70000 105299.9n 0.70000 105300.0n 0.30000 105479.9n 0.30000 105480.0n 0.30000 105659.9n 0.30000 105660.0n 0.70000 105839.9n 0.70000 105840.0n 0.30000 106019.9n 0.30000 106020.0n 0.30000 106199.9n 0.30000 106200.0n 0.30000 106379.9n 0.30000 106380.0n 0.30000 106559.9n 0.30000 106560.0n 0.30000 106739.9n 0.30000 106740.0n 0.30000 106919.9n 0.30000 106920.0n 0.70000 107099.9n 0.70000 107100.0n 0.70000 107279.9n 0.70000 107280.0n 0.30000 107459.9n 0.30000 107460.0n 0.70000 107639.9n 0.70000 107640.0n 0.30000 107819.9n 0.30000 107820.0n 0.30000 107999.9n 0.30000 108000.0n 0.70000 108179.9n 0.70000 108180.0n 0.70000 108359.9n 0.70000 108360.0n 0.70000 108539.9n 0.70000 108540.0n 0.30000 108719.9n 0.30000 108720.0n 0.70000 108899.9n 0.70000 108900.0n 0.30000 109079.9n 0.30000 109080.0n 0.30000 109259.9n 0.30000 109260.0n 0.70000 109439.9n 0.70000 109440.0n 0.70000 109619.9n 0.70000 109620.0n 0.70000 109799.9n 0.70000 109800.0n 0.30000 109979.9n 0.30000 109980.0n 0.30000 110159.9n 0.30000 110160.0n 0.70000 110339.9n 0.70000 110340.0n 0.30000 110519.9n 0.30000 110520.0n 0.70000 110699.9n 0.70000 110700.0n 0.70000 110879.9n 0.70000 110880.0n 0.30000 111059.9n 0.30000 111060.0n 0.30000 111239.9n 0.30000 111240.0n 0.70000 111419.9n 0.70000 111420.0n 0.70000 111599.9n 0.70000 111600.0n 0.30000 111779.9n 0.30000 111780.0n 0.70000 111959.9n 0.70000 111960.0n 0.30000 112139.9n 0.30000 112140.0n 0.70000 112319.9n 0.70000 112320.0n 0.70000 112499.9n 0.70000 112500.0n 0.30000 112679.9n 0.30000 112680.0n 0.70000 112859.9n 0.70000 112860.0n 0.70000 113039.9n 0.70000 113040.0n 0.30000 113219.9n 0.30000 113220.0n 0.30000 113399.9n 0.30000 113400.0n 0.30000 113579.9n 0.30000 113580.0n 0.30000 113759.9n 0.30000 113760.0n 0.30000 113939.9n 0.30000 113940.0n 0.30000 114119.9n 0.30000 114120.0n 0.70000 114299.9n 0.70000 114300.0n 0.70000 114479.9n 0.70000 114480.0n 0.30000 114659.9n 0.30000 114660.0n 0.30000 114839.9n 0.30000 114840.0n 0.70000 115019.9n 0.70000 115020.0n 0.70000 115199.9n 0.70000 115200.0n 0.70000 115379.9n 0.70000 115380.0n 0.70000 115559.9n 0.70000 115560.0n 0.30000 115739.9n 0.30000 115740.0n 0.70000 115919.9n 0.70000 115920.0n 0.70000 116099.9n 0.70000 116100.0n 0.30000 116279.9n 0.30000 116280.0n 0.30000 116459.9n 0.30000 116460.0n 0.30000 116639.9n 0.30000 116640.0n 0.70000 116819.9n 0.70000 116820.0n 0.30000 116999.9n 0.30000 117000.0n 0.30000 117179.9n 0.30000 117180.0n 0.70000 117359.9n 0.70000 117360.0n 0.30000 117539.9n 0.30000 117540.0n 0.70000 117719.9n 0.70000 117720.0n 0.70000 117899.9n 0.70000 117900.0n 0.70000 118079.9n 0.70000 118080.0n 0.30000 118259.9n 0.30000 118260.0n 0.30000 118439.9n 0.30000 118440.0n 0.70000 118619.9n 0.70000 118620.0n 0.30000 118799.9n 0.30000 118800.0n 0.30000 118979.9n 0.30000 118980.0n 0.30000 119159.9n 0.30000 119160.0n 0.70000 119339.9n 0.70000 119340.0n 0.70000 119519.9n 0.70000 119520.0n 0.70000 119699.9n 0.70000 119700.0n 0.70000 119879.9n 0.70000 119880.0n 0.30000 120059.9n 0.30000 120060.0n 0.30000 120239.9n 0.30000 120240.0n 0.70000 120419.9n 0.70000 120420.0n 0.30000 120599.9n 0.30000 120600.0n 0.70000 120779.9n 0.70000 120780.0n 0.30000 120959.9n 0.30000 120960.0n 0.70000 121139.9n 0.70000 121140.0n 0.70000 121319.9n 0.70000 121320.0n 0.70000 121499.9n 0.70000 121500.0n 0.70000 121679.9n 0.70000 121680.0n 0.70000 121859.9n 0.70000 121860.0n 0.30000 122039.9n 0.30000 122040.0n 0.70000 122219.9n 0.70000 122220.0n 0.70000 122399.9n 0.70000 122400.0n 0.30000 122579.9n 0.30000 122580.0n 0.30000 122759.9n 0.30000 122760.0n 0.30000 122939.9n 0.30000 122940.0n 0.30000 123119.9n 0.30000 123120.0n 0.70000 123299.9n 0.70000 123300.0n 0.30000 123479.9n 0.30000 123480.0n 0.30000 123659.9n 0.30000 123660.0n 0.30000 123839.9n 0.30000 123840.0n 0.70000 124019.9n 0.70000 124020.0n 0.30000 124199.9n 0.30000 124200.0n 0.30000 124379.9n 0.30000 124380.0n 0.30000 124559.9n 0.30000 124560.0n 0.30000 124739.9n 0.30000 124740.0n 0.70000 124919.9n 0.70000 124920.0n 0.70000 125099.9n 0.70000 125100.0n 0.70000 125279.9n 0.70000 125280.0n 0.30000 125459.9n 0.30000 125460.0n 0.30000 125639.9n 0.30000 125640.0n 0.70000 125819.9n 0.70000 125820.0n 0.30000 125999.9n 0.30000 126000.0n 0.70000 126179.9n 0.70000 126180.0n 0.70000 126359.9n 0.70000 126360.0n 0.30000 126539.9n 0.30000 126540.0n 0.70000 126719.9n 0.70000 126720.0n 0.70000 126899.9n 0.70000 126900.0n 0.70000 127079.9n 0.70000 127080.0n 0.30000 127259.9n 0.30000 127260.0n 0.30000 127439.9n 0.30000 127440.0n 0.70000 127619.9n 0.70000 127620.0n 0.70000 127799.9n 0.70000 127800.0n 0.70000 127979.9n 0.70000 127980.0n 0.70000 128159.9n 0.70000 128160.0n 0.70000 128339.9n 0.70000 128340.0n 0.70000 128519.9n 0.70000 128520.0n 0.30000 128699.9n 0.30000 128700.0n 0.30000 128879.9n 0.30000 128880.0n 0.70000 129059.9n 0.70000 129060.0n 0.70000 129239.9n 0.70000 129240.0n 0.30000 129419.9n 0.30000 129420.0n 0.30000 129599.9n 0.30000 129600.0n 0.30000 129779.9n 0.30000 129780.0n 0.30000 129959.9n 0.30000 129960.0n 0.70000 130139.9n 0.70000 130140.0n 0.30000 130319.9n 0.30000 130320.0n 0.70000 130499.9n 0.70000 130500.0n 0.30000 130679.9n 0.30000 130680.0n 0.70000 130859.9n 0.70000 130860.0n 0.30000 131039.9n 0.30000 131040.0n 0.30000 131219.9n 0.30000 131220.0n 0.30000 131399.9n 0.30000 131400.0n 0.30000 131579.9n 0.30000 131580.0n 0.30000 131759.9n 0.30000 131760.0n 0.70000 131939.9n 0.70000 131940.0n 0.30000 132119.9n 0.30000 132120.0n 0.70000 132299.9n 0.70000 132300.0n 0.70000 132479.9n 0.70000 132480.0n 0.30000 132659.9n 0.30000 132660.0n 0.30000 132839.9n 0.30000 132840.0n 0.30000 133019.9n 0.30000 133020.0n 0.30000 133199.9n 0.30000 133200.0n 0.30000 133379.9n 0.30000 133380.0n 0.70000 133559.9n 0.70000 133560.0n 0.70000 133739.9n 0.70000 133740.0n 0.30000 133919.9n 0.30000 133920.0n 0.30000 134099.9n 0.30000 134100.0n 0.70000 134279.9n 0.70000 134280.0n 0.70000 134459.9n 0.70000 134460.0n 0.70000 134639.9n 0.70000 134640.0n 0.30000 134819.9n 0.30000 134820.0n 0.30000 134999.9n 0.30000 135000.0n 0.70000 135179.9n 0.70000 135180.0n 0.30000 135359.9n 0.30000 135360.0n 0.70000 135539.9n 0.70000 135540.0n 0.30000 135719.9n 0.30000 135720.0n 0.30000 135899.9n 0.30000 135900.0n 0.70000 136079.9n 0.70000 136080.0n 0.70000 136259.9n 0.70000 136260.0n 0.30000 136439.9n 0.30000 136440.0n 0.30000 136619.9n 0.30000 136620.0n 0.30000 136799.9n 0.30000 136800.0n 0.70000 136979.9n 0.70000 136980.0n 0.70000 137159.9n 0.70000 137160.0n 0.70000 137339.9n 0.70000 137340.0n 0.70000 137519.9n 0.70000 137520.0n 0.30000 137699.9n 0.30000 137700.0n 0.70000 137879.9n 0.70000 137880.0n 0.70000 138059.9n 0.70000 138060.0n 0.70000 138239.9n 0.70000 138240.0n 0.70000 138419.9n 0.70000 138420.0n 0.30000 138599.9n 0.30000 138600.0n 0.30000 138779.9n 0.30000 138780.0n 0.70000 138959.9n 0.70000 138960.0n 0.70000 139139.9n 0.70000 139140.0n 0.30000 139319.9n 0.30000 139320.0n 0.30000 139499.9n 0.30000 139500.0n 0.30000 139679.9n 0.30000 139680.0n 0.30000 139859.9n 0.30000 139860.0n 0.30000 140039.9n 0.30000 140040.0n 0.30000 140219.9n 0.30000 140220.0n 0.70000 140399.9n 0.70000 140400.0n 0.70000 140579.9n 0.70000 140580.0n 0.70000 140759.9n 0.70000 140760.0n 0.30000 140939.9n 0.30000 140940.0n 0.70000 141119.9n 0.70000 141120.0n 0.30000 141299.9n 0.30000 141300.0n 0.30000 141479.9n 0.30000 141480.0n 0.70000 141659.9n 0.70000 141660.0n 0.30000 141839.9n 0.30000 141840.0n 0.30000 142019.9n 0.30000 142020.0n 0.30000 142199.9n 0.30000 142200.0n 0.70000 142379.9n 0.70000 142380.0n 0.30000 142559.9n 0.30000 142560.0n 0.70000 142739.9n 0.70000 142740.0n 0.70000 142919.9n 0.70000 142920.0n 0.70000 143099.9n 0.70000 143100.0n 0.70000 143279.9n 0.70000 143280.0n 0.70000 143459.9n 0.70000 143460.0n 0.30000 143639.9n 0.30000 143640.0n 0.70000 143819.9n 0.70000 143820.0n 0.70000 143999.9n 0.70000 144000.0n 0.70000 144179.9n 0.70000 144180.0n 0.70000 144359.9n 0.70000 144360.0n 0.30000 144539.9n 0.30000 144540.0n 0.30000 144719.9n 0.30000 144720.0n 0.70000 144899.9n 0.70000 144900.0n 0.70000 145079.9n 0.70000 145080.0n 0.30000 145259.9n 0.30000 145260.0n 0.30000 145439.9n 0.30000 145440.0n 0.30000 145619.9n 0.30000 145620.0n 0.30000 145799.9n 0.30000 145800.0n 0.30000 145979.9n 0.30000 145980.0n 0.70000 146159.9n 0.70000 146160.0n 0.30000 146339.9n 0.30000 146340.0n 0.70000 146519.9n 0.70000 146520.0n 0.70000 146699.9n 0.70000 146700.0n 0.30000 146879.9n 0.30000 146880.0n 0.30000 147059.9n 0.30000 147060.0n 0.30000 147239.9n 0.30000 147240.0n 0.70000 147419.9n 0.70000 147420.0n 0.30000 147599.9n 0.30000 147600.0n 0.30000 147779.9n 0.30000 147780.0n 0.70000 147959.9n 0.70000 147960.0n 0.70000 148139.9n 0.70000 148140.0n 0.70000 148319.9n 0.70000 148320.0n 0.70000 148499.9n 0.70000 148500.0n 0.30000 148679.9n 0.30000 148680.0n 0.70000 148859.9n 0.70000 148860.0n 0.30000 149039.9n 0.30000 149040.0n 0.70000 149219.9n 0.70000 149220.0n 0.70000 149399.9n 0.70000 149400.0n 0.70000 149579.9n 0.70000 149580.0n 0.30000 149759.9n 0.30000 149760.0n 0.70000 149939.9n 0.70000 149940.0n 0.30000 150119.9n 0.30000 150120.0n 0.70000 150299.9n 0.70000 150300.0n 0.30000 150479.9n 0.30000 150480.0n 0.70000 150659.9n 0.70000 150660.0n 0.30000 150839.9n 0.30000 150840.0n 0.30000 151019.9n 0.30000 151020.0n 0.30000 151199.9n 0.30000 151200.0n 0.30000 151379.9n 0.30000 151380.0n 0.30000 151559.9n 0.30000 151560.0n 0.70000 151739.9n 0.70000 151740.0n 0.70000 151919.9n 0.70000 151920.0n 0.70000 152099.9n 0.70000 152100.0n 0.70000 152279.9n 0.70000 152280.0n 0.30000 152459.9n 0.30000 152460.0n 0.70000 152639.9n 0.70000 152640.0n 0.30000 152819.9n 0.30000 152820.0n 0.30000 152999.9n 0.30000 153000.0n 0.30000 153179.9n 0.30000 153180.0n 0.30000 153359.9n 0.30000 153360.0n 0.70000 153539.9n 0.70000 153540.0n 0.70000 153719.9n 0.70000 153720.0n 0.30000 153899.9n 0.30000 153900.0n 0.30000 154079.9n 0.30000 154080.0n 0.70000 154259.9n 0.70000 154260.0n 0.70000 154439.9n 0.70000 154440.0n 0.70000 154619.9n 0.70000 154620.0n 0.70000 154799.9n 0.70000 154800.0n 0.70000 154979.9n 0.70000 154980.0n 0.30000 155159.9n 0.30000 155160.0n 0.70000 155339.9n 0.70000 155340.0n 0.30000 155519.9n 0.30000 155520.0n 0.70000 155699.9n 0.70000 155700.0n 0.70000 155879.9n 0.70000 155880.0n 0.30000 156059.9n 0.30000 156060.0n 0.70000 156239.9n 0.70000 156240.0n 0.30000 156419.9n 0.30000 156420.0n 0.70000 156599.9n 0.70000 156600.0n 0.30000 156779.9n 0.30000 156780.0n 0.30000 156959.9n 0.30000 156960.0n 0.70000 157139.9n 0.70000 157140.0n 0.70000 157319.9n 0.70000 157320.0n 0.30000 157499.9n 0.30000 157500.0n 0.70000 157679.9n 0.70000 157680.0n 0.30000 157859.9n 0.30000 157860.0n 0.70000 158039.9n 0.70000 158040.0n 0.30000 158219.9n 0.30000 158220.0n 0.30000 158399.9n 0.30000 158400.0n 0.70000 158579.9n 0.70000 158580.0n 0.30000 158759.9n 0.30000 158760.0n 0.30000 158939.9n 0.30000 158940.0n 0.70000 159119.9n 0.70000 159120.0n 0.30000 159299.9n 0.30000 159300.0n 0.30000 159479.9n 0.30000 159480.0n 0.70000 159659.9n 0.70000 159660.0n 0.30000 159839.9n 0.30000 159840.0n 0.70000 160019.9n 0.70000 160020.0n 0.70000 160199.9n 0.70000 160200.0n 0.30000 160379.9n 0.30000 160380.0n 0.70000 160559.9n 0.70000 160560.0n 0.70000 160739.9n 0.70000 160740.0n 0.30000 160919.9n 0.30000 160920.0n 0.70000 161099.9n 0.70000 161100.0n 0.30000 161279.9n 0.30000 161280.0n 0.30000 161459.9n 0.30000 161460.0n 0.30000 161639.9n 0.30000 161640.0n 0.70000 161819.9n 0.70000 161820.0n 0.70000 161999.9n 0.70000 162000.0n 0.70000 162179.9n 0.70000 162180.0n 0.30000 162359.9n 0.30000 162360.0n 0.70000 162539.9n 0.70000 162540.0n 0.70000 162719.9n 0.70000 162720.0n 0.30000 162899.9n 0.30000 162900.0n 0.70000 163079.9n 0.70000 163080.0n 0.70000 163259.9n 0.70000 163260.0n 0.30000 163439.9n 0.30000 163440.0n 0.30000 163619.9n 0.30000 163620.0n 0.70000 163799.9n 0.70000 163800.0n 0.30000 163979.9n 0.30000 163980.0n 0.70000 164159.9n 0.70000 164160.0n 0.70000 164339.9n 0.70000 164340.0n 0.70000 164519.9n 0.70000 164520.0n 0.70000 164699.9n 0.70000 164700.0n 0.30000 164879.9n 0.30000 164880.0n 0.30000 165059.9n 0.30000 165060.0n 0.30000 165239.9n 0.30000 165240.0n 0.70000 165419.9n 0.70000 165420.0n 0.30000 165599.9n 0.30000 165600.0n 0.70000 165779.9n 0.70000 165780.0n 0.30000 165959.9n 0.30000 165960.0n 0.30000 166139.9n 0.30000 166140.0n 0.70000 166319.9n 0.70000 166320.0n 0.70000 166499.9n 0.70000 166500.0n 0.30000 166679.9n 0.30000 166680.0n 0.30000 166859.9n 0.30000 166860.0n 0.30000 167039.9n 0.30000 167040.0n 0.70000 167219.9n 0.70000 167220.0n 0.30000 167399.9n 0.30000 167400.0n 0.70000 167579.9n 0.70000 167580.0n 0.70000 167759.9n 0.70000 167760.0n 0.70000 167939.9n 0.70000 167940.0n 0.70000 168119.9n 0.70000 168120.0n 0.30000 168299.9n 0.30000 168300.0n 0.30000 168479.9n 0.30000 168480.0n 0.70000 168659.9n 0.70000 168660.0n 0.30000 168839.9n 0.30000 168840.0n 0.70000 169019.9n 0.70000 169020.0n 0.30000 169199.9n 0.30000 169200.0n 0.30000 169379.9n 0.30000 169380.0n 0.70000 169559.9n 0.70000 169560.0n 0.70000 169739.9n 0.70000 169740.0n 0.70000 169919.9n 0.70000 169920.0n 0.30000 170099.9n 0.30000 170100.0n 0.70000 170279.9n 0.70000 170280.0n 0.30000 170459.9n 0.30000 170460.0n 0.70000 170639.9n 0.70000 170640.0n 0.70000 170819.9n 0.70000 170820.0n 0.30000 170999.9n 0.30000 171000.0n 0.30000 171179.9n 0.30000 171180.0n 0.70000 171359.9n 0.70000 171360.0n 0.30000 171539.9n 0.30000 171540.0n 0.30000 171719.9n 0.30000 171720.0n 0.30000 171899.9n 0.30000 171900.0n 0.30000 172079.9n 0.30000 172080.0n 0.30000 172259.9n 0.30000 172260.0n 0.70000 172439.9n 0.70000 172440.0n 0.70000 172619.9n 0.70000 172620.0n 0.30000 172799.9n 0.30000 172800.0n 0.50000 172979.9n 0.50000 172980.0n 0.50000 173159.9n 0.50000 173160.0n 0.50000 173339.9n 0.50000 173340.0n 0.50000 173519.9n 0.50000 173520.0n 0.50000 173699.9n 0.50000 173700.0n 0.50000 173879.9n 0.50000 173880.0n 0.50000 174059.9n 0.50000 174060.0n 0.50000 174239.9n 0.50000 174240.0n 0.50000 174419.9n 0.50000 174420.0n 0.50000 174599.9n 0.50000 174600.0n 0.50000 174779.9n 0.50000 174780.0n 0.50000 174959.9n 0.50000 174960.0n 0.50000 175139.9n 0.50000 175140.0n 0.50000 175319.9n 0.50000 175320.0n 0.50000 175499.9n 0.50000 175500.0n 0.50000 175679.9n 0.50000 175680.0n 0.50000 175859.9n 0.50000 175860.0n 0.50000 176039.9n 0.50000 176040.0n 0.50000 176219.9n 0.50000 176220.0n 0.50000 176399.9n 0.50000 176400.0n 0.50000 176579.9n 0.50000 176580.0n 0.50000 176759.9n 0.50000 176760.0n 0.50000 176939.9n 0.50000 176940.0n 0.50000 177119.9n 0.50000 177120.0n 0.50000 177299.9n 0.50000 177300.0n 0.50000 177479.9n 0.50000 177480.0n 0.50000 177659.9n 0.50000 177660.0n 0.50000 177839.9n 0.50000 177840.0n 0.50000 178019.9n 0.50000 178020.0n 0.50000 178199.9n 0.50000 178200.0n 0.50000 178379.9n 0.50000 178380.0n 0.50000 178559.9n 0.50000 178560.0n 0.50000 178739.9n 0.50000 178740.0n 0.50000 178919.9n 0.50000 178920.0n 0.50000 179099.9n 0.50000 179100.0n 0.50000 179279.9n 0.50000 179280.0n 0.50000 179459.9n 0.50000 179460.0n 0.50000 179639.9n 0.50000 179640.0n 0.50000 179819.9n 0.50000 179820.0n 0.50000 179999.9n 0.50000 180000.0n 0.50000 180179.9n 0.50000 180180.0n 0.50000 180359.9n 0.50000 180360.0n 0.50000 180539.9n 0.50000 180540.0n 0.50000 180719.9n 0.50000 180720.0n 0.50000 180899.9n 0.50000 180900.0n 0.50000 181079.9n 0.50000 181080.0n 0.50000 181259.9n 0.50000 181260.0n 0.50000 181439.9n 0.50000 181440.0n 0.50000 181619.9n 0.50000 181620.0n 0.50000 181799.9n 0.50000 181800.0n 0.50000 181979.9n 0.50000 181980.0n 0.50000 182159.9n 0.50000 182160.0n 0.50000 182339.9n 0.50000 182340.0n 0.50000 182519.9n 0.50000 182520.0n 0.50000 182699.9n 0.50000 182700.0n 0.50000 182879.9n 0.50000 182880.0n 0.50000 183059.9n 0.50000 183060.0n 0.50000 183239.9n 0.50000 183240.0n 0.50000 183419.9n 0.50000 183420.0n 0.50000)
Vxop1 xop1 0 PWL(0.0n 0.70000 179.9n 0.70000 180.0n 0.70000 359.9n 0.70000 360.0n 0.30000 539.9n 0.30000 540.0n 0.70000 719.9n 0.70000 720.0n 0.70000 899.9n 0.70000 900.0n 0.70000 1079.9n 0.70000 1080.0n 0.30000 1259.9n 0.30000 1260.0n 0.30000 1439.9n 0.30000 1440.0n 0.30000 1619.9n 0.30000 1620.0n 0.70000 1799.9n 0.70000 1800.0n 0.70000 1979.9n 0.70000 1980.0n 0.30000 2159.9n 0.30000 2160.0n 0.30000 2339.9n 0.30000 2340.0n 0.30000 2519.9n 0.30000 2520.0n 0.70000 2699.9n 0.70000 2700.0n 0.30000 2879.9n 0.30000 2880.0n 0.30000 3059.9n 0.30000 3060.0n 0.70000 3239.9n 0.70000 3240.0n 0.70000 3419.9n 0.70000 3420.0n 0.70000 3599.9n 0.70000 3600.0n 0.30000 3779.9n 0.30000 3780.0n 0.70000 3959.9n 0.70000 3960.0n 0.70000 4139.9n 0.70000 4140.0n 0.30000 4319.9n 0.30000 4320.0n 0.30000 4499.9n 0.30000 4500.0n 0.70000 4679.9n 0.70000 4680.0n 0.30000 4859.9n 0.30000 4860.0n 0.30000 5039.9n 0.30000 5040.0n 0.30000 5219.9n 0.30000 5220.0n 0.30000 5399.9n 0.30000 5400.0n 0.70000 5579.9n 0.70000 5580.0n 0.70000 5759.9n 0.70000 5760.0n 0.70000 5939.9n 0.70000 5940.0n 0.70000 6119.9n 0.70000 6120.0n 0.70000 6299.9n 0.70000 6300.0n 0.30000 6479.9n 0.30000 6480.0n 0.30000 6659.9n 0.30000 6660.0n 0.70000 6839.9n 0.70000 6840.0n 0.70000 7019.9n 0.70000 7020.0n 0.30000 7199.9n 0.30000 7200.0n 0.30000 7379.9n 0.30000 7380.0n 0.30000 7559.9n 0.30000 7560.0n 0.70000 7739.9n 0.70000 7740.0n 0.70000 7919.9n 0.70000 7920.0n 0.70000 8099.9n 0.70000 8100.0n 0.30000 8279.9n 0.30000 8280.0n 0.70000 8459.9n 0.70000 8460.0n 0.30000 8639.9n 0.30000 8640.0n 0.70000 8819.9n 0.70000 8820.0n 0.30000 8999.9n 0.30000 9000.0n 0.30000 9179.9n 0.30000 9180.0n 0.30000 9359.9n 0.30000 9360.0n 0.30000 9539.9n 0.30000 9540.0n 0.30000 9719.9n 0.30000 9720.0n 0.70000 9899.9n 0.70000 9900.0n 0.70000 10079.9n 0.70000 10080.0n 0.70000 10259.9n 0.70000 10260.0n 0.30000 10439.9n 0.30000 10440.0n 0.30000 10619.9n 0.30000 10620.0n 0.70000 10799.9n 0.70000 10800.0n 0.30000 10979.9n 0.30000 10980.0n 0.30000 11159.9n 0.30000 11160.0n 0.70000 11339.9n 0.70000 11340.0n 0.70000 11519.9n 0.70000 11520.0n 0.70000 11699.9n 0.70000 11700.0n 0.30000 11879.9n 0.30000 11880.0n 0.30000 12059.9n 0.30000 12060.0n 0.30000 12239.9n 0.30000 12240.0n 0.70000 12419.9n 0.70000 12420.0n 0.70000 12599.9n 0.70000 12600.0n 0.30000 12779.9n 0.30000 12780.0n 0.70000 12959.9n 0.70000 12960.0n 0.70000 13139.9n 0.70000 13140.0n 0.30000 13319.9n 0.30000 13320.0n 0.70000 13499.9n 0.70000 13500.0n 0.30000 13679.9n 0.30000 13680.0n 0.30000 13859.9n 0.30000 13860.0n 0.30000 14039.9n 0.30000 14040.0n 0.30000 14219.9n 0.30000 14220.0n 0.70000 14399.9n 0.70000 14400.0n 0.30000 14579.9n 0.30000 14580.0n 0.30000 14759.9n 0.30000 14760.0n 0.70000 14939.9n 0.70000 14940.0n 0.70000 15119.9n 0.70000 15120.0n 0.70000 15299.9n 0.70000 15300.0n 0.30000 15479.9n 0.30000 15480.0n 0.30000 15659.9n 0.30000 15660.0n 0.70000 15839.9n 0.70000 15840.0n 0.70000 16019.9n 0.70000 16020.0n 0.30000 16199.9n 0.30000 16200.0n 0.70000 16379.9n 0.70000 16380.0n 0.30000 16559.9n 0.30000 16560.0n 0.30000 16739.9n 0.30000 16740.0n 0.70000 16919.9n 0.70000 16920.0n 0.70000 17099.9n 0.70000 17100.0n 0.70000 17279.9n 0.70000 17280.0n 0.70000 17459.9n 0.70000 17460.0n 0.30000 17639.9n 0.30000 17640.0n 0.30000 17819.9n 0.30000 17820.0n 0.70000 17999.9n 0.70000 18000.0n 0.30000 18179.9n 0.30000 18180.0n 0.70000 18359.9n 0.70000 18360.0n 0.70000 18539.9n 0.70000 18540.0n 0.30000 18719.9n 0.30000 18720.0n 0.30000 18899.9n 0.30000 18900.0n 0.30000 19079.9n 0.30000 19080.0n 0.30000 19259.9n 0.30000 19260.0n 0.30000 19439.9n 0.30000 19440.0n 0.30000 19619.9n 0.30000 19620.0n 0.70000 19799.9n 0.70000 19800.0n 0.70000 19979.9n 0.70000 19980.0n 0.30000 20159.9n 0.30000 20160.0n 0.70000 20339.9n 0.70000 20340.0n 0.30000 20519.9n 0.30000 20520.0n 0.30000 20699.9n 0.30000 20700.0n 0.70000 20879.9n 0.70000 20880.0n 0.70000 21059.9n 0.70000 21060.0n 0.30000 21239.9n 0.30000 21240.0n 0.30000 21419.9n 0.30000 21420.0n 0.70000 21599.9n 0.70000 21600.0n 0.70000 21779.9n 0.70000 21780.0n 0.70000 21959.9n 0.70000 21960.0n 0.70000 22139.9n 0.70000 22140.0n 0.70000 22319.9n 0.70000 22320.0n 0.30000 22499.9n 0.30000 22500.0n 0.70000 22679.9n 0.70000 22680.0n 0.30000 22859.9n 0.30000 22860.0n 0.70000 23039.9n 0.70000 23040.0n 0.30000 23219.9n 0.30000 23220.0n 0.30000 23399.9n 0.30000 23400.0n 0.30000 23579.9n 0.30000 23580.0n 0.70000 23759.9n 0.70000 23760.0n 0.30000 23939.9n 0.30000 23940.0n 0.30000 24119.9n 0.30000 24120.0n 0.30000 24299.9n 0.30000 24300.0n 0.70000 24479.9n 0.70000 24480.0n 0.30000 24659.9n 0.30000 24660.0n 0.30000 24839.9n 0.30000 24840.0n 0.30000 25019.9n 0.30000 25020.0n 0.30000 25199.9n 0.30000 25200.0n 0.70000 25379.9n 0.70000 25380.0n 0.70000 25559.9n 0.70000 25560.0n 0.70000 25739.9n 0.70000 25740.0n 0.30000 25919.9n 0.30000 25920.0n 0.30000 26099.9n 0.30000 26100.0n 0.30000 26279.9n 0.30000 26280.0n 0.70000 26459.9n 0.70000 26460.0n 0.70000 26639.9n 0.70000 26640.0n 0.70000 26819.9n 0.70000 26820.0n 0.30000 26999.9n 0.30000 27000.0n 0.30000 27179.9n 0.30000 27180.0n 0.30000 27359.9n 0.30000 27360.0n 0.70000 27539.9n 0.70000 27540.0n 0.70000 27719.9n 0.70000 27720.0n 0.70000 27899.9n 0.70000 27900.0n 0.70000 28079.9n 0.70000 28080.0n 0.70000 28259.9n 0.70000 28260.0n 0.70000 28439.9n 0.70000 28440.0n 0.70000 28619.9n 0.70000 28620.0n 0.70000 28799.9n 0.70000 28800.0n 0.70000 28979.9n 0.70000 28980.0n 0.30000 29159.9n 0.30000 29160.0n 0.30000 29339.9n 0.30000 29340.0n 0.30000 29519.9n 0.30000 29520.0n 0.70000 29699.9n 0.70000 29700.0n 0.30000 29879.9n 0.30000 29880.0n 0.70000 30059.9n 0.70000 30060.0n 0.70000 30239.9n 0.70000 30240.0n 0.70000 30419.9n 0.70000 30420.0n 0.30000 30599.9n 0.30000 30600.0n 0.30000 30779.9n 0.30000 30780.0n 0.30000 30959.9n 0.30000 30960.0n 0.70000 31139.9n 0.70000 31140.0n 0.70000 31319.9n 0.70000 31320.0n 0.30000 31499.9n 0.30000 31500.0n 0.70000 31679.9n 0.70000 31680.0n 0.30000 31859.9n 0.30000 31860.0n 0.70000 32039.9n 0.70000 32040.0n 0.70000 32219.9n 0.70000 32220.0n 0.30000 32399.9n 0.30000 32400.0n 0.30000 32579.9n 0.30000 32580.0n 0.30000 32759.9n 0.30000 32760.0n 0.30000 32939.9n 0.30000 32940.0n 0.30000 33119.9n 0.30000 33120.0n 0.30000 33299.9n 0.30000 33300.0n 0.70000 33479.9n 0.70000 33480.0n 0.70000 33659.9n 0.70000 33660.0n 0.70000 33839.9n 0.70000 33840.0n 0.70000 34019.9n 0.70000 34020.0n 0.30000 34199.9n 0.30000 34200.0n 0.70000 34379.9n 0.70000 34380.0n 0.70000 34559.9n 0.70000 34560.0n 0.30000 34739.9n 0.30000 34740.0n 0.30000 34919.9n 0.30000 34920.0n 0.70000 35099.9n 0.70000 35100.0n 0.70000 35279.9n 0.70000 35280.0n 0.70000 35459.9n 0.70000 35460.0n 0.70000 35639.9n 0.70000 35640.0n 0.30000 35819.9n 0.30000 35820.0n 0.30000 35999.9n 0.30000 36000.0n 0.30000 36179.9n 0.30000 36180.0n 0.30000 36359.9n 0.30000 36360.0n 0.30000 36539.9n 0.30000 36540.0n 0.30000 36719.9n 0.30000 36720.0n 0.30000 36899.9n 0.30000 36900.0n 0.30000 37079.9n 0.30000 37080.0n 0.70000 37259.9n 0.70000 37260.0n 0.30000 37439.9n 0.30000 37440.0n 0.70000 37619.9n 0.70000 37620.0n 0.70000 37799.9n 0.70000 37800.0n 0.70000 37979.9n 0.70000 37980.0n 0.70000 38159.9n 0.70000 38160.0n 0.30000 38339.9n 0.30000 38340.0n 0.30000 38519.9n 0.30000 38520.0n 0.70000 38699.9n 0.70000 38700.0n 0.30000 38879.9n 0.30000 38880.0n 0.70000 39059.9n 0.70000 39060.0n 0.30000 39239.9n 0.30000 39240.0n 0.70000 39419.9n 0.70000 39420.0n 0.30000 39599.9n 0.30000 39600.0n 0.70000 39779.9n 0.70000 39780.0n 0.70000 39959.9n 0.70000 39960.0n 0.70000 40139.9n 0.70000 40140.0n 0.70000 40319.9n 0.70000 40320.0n 0.30000 40499.9n 0.30000 40500.0n 0.30000 40679.9n 0.30000 40680.0n 0.70000 40859.9n 0.70000 40860.0n 0.70000 41039.9n 0.70000 41040.0n 0.70000 41219.9n 0.70000 41220.0n 0.30000 41399.9n 0.30000 41400.0n 0.30000 41579.9n 0.30000 41580.0n 0.70000 41759.9n 0.70000 41760.0n 0.70000 41939.9n 0.70000 41940.0n 0.70000 42119.9n 0.70000 42120.0n 0.30000 42299.9n 0.30000 42300.0n 0.70000 42479.9n 0.70000 42480.0n 0.30000 42659.9n 0.30000 42660.0n 0.30000 42839.9n 0.30000 42840.0n 0.30000 43019.9n 0.30000 43020.0n 0.30000 43199.9n 0.30000 43200.0n 0.70000 43379.9n 0.70000 43380.0n 0.30000 43559.9n 0.30000 43560.0n 0.30000 43739.9n 0.30000 43740.0n 0.70000 43919.9n 0.70000 43920.0n 0.30000 44099.9n 0.30000 44100.0n 0.70000 44279.9n 0.70000 44280.0n 0.70000 44459.9n 0.70000 44460.0n 0.70000 44639.9n 0.70000 44640.0n 0.30000 44819.9n 0.30000 44820.0n 0.70000 44999.9n 0.70000 45000.0n 0.30000 45179.9n 0.30000 45180.0n 0.30000 45359.9n 0.30000 45360.0n 0.70000 45539.9n 0.70000 45540.0n 0.30000 45719.9n 0.30000 45720.0n 0.70000 45899.9n 0.70000 45900.0n 0.70000 46079.9n 0.70000 46080.0n 0.30000 46259.9n 0.30000 46260.0n 0.30000 46439.9n 0.30000 46440.0n 0.30000 46619.9n 0.30000 46620.0n 0.70000 46799.9n 0.70000 46800.0n 0.30000 46979.9n 0.30000 46980.0n 0.70000 47159.9n 0.70000 47160.0n 0.70000 47339.9n 0.70000 47340.0n 0.30000 47519.9n 0.30000 47520.0n 0.30000 47699.9n 0.30000 47700.0n 0.30000 47879.9n 0.30000 47880.0n 0.30000 48059.9n 0.30000 48060.0n 0.70000 48239.9n 0.70000 48240.0n 0.70000 48419.9n 0.70000 48420.0n 0.70000 48599.9n 0.70000 48600.0n 0.70000 48779.9n 0.70000 48780.0n 0.30000 48959.9n 0.30000 48960.0n 0.70000 49139.9n 0.70000 49140.0n 0.70000 49319.9n 0.70000 49320.0n 0.70000 49499.9n 0.70000 49500.0n 0.70000 49679.9n 0.70000 49680.0n 0.30000 49859.9n 0.30000 49860.0n 0.30000 50039.9n 0.30000 50040.0n 0.30000 50219.9n 0.30000 50220.0n 0.30000 50399.9n 0.30000 50400.0n 0.30000 50579.9n 0.30000 50580.0n 0.70000 50759.9n 0.70000 50760.0n 0.70000 50939.9n 0.70000 50940.0n 0.70000 51119.9n 0.70000 51120.0n 0.70000 51299.9n 0.70000 51300.0n 0.30000 51479.9n 0.30000 51480.0n 0.70000 51659.9n 0.70000 51660.0n 0.30000 51839.9n 0.30000 51840.0n 0.70000 52019.9n 0.70000 52020.0n 0.70000 52199.9n 0.70000 52200.0n 0.30000 52379.9n 0.30000 52380.0n 0.30000 52559.9n 0.30000 52560.0n 0.70000 52739.9n 0.70000 52740.0n 0.30000 52919.9n 0.30000 52920.0n 0.30000 53099.9n 0.30000 53100.0n 0.70000 53279.9n 0.70000 53280.0n 0.70000 53459.9n 0.70000 53460.0n 0.70000 53639.9n 0.70000 53640.0n 0.70000 53819.9n 0.70000 53820.0n 0.70000 53999.9n 0.70000 54000.0n 0.70000 54179.9n 0.70000 54180.0n 0.30000 54359.9n 0.30000 54360.0n 0.70000 54539.9n 0.70000 54540.0n 0.30000 54719.9n 0.30000 54720.0n 0.30000 54899.9n 0.30000 54900.0n 0.30000 55079.9n 0.30000 55080.0n 0.30000 55259.9n 0.30000 55260.0n 0.30000 55439.9n 0.30000 55440.0n 0.30000 55619.9n 0.30000 55620.0n 0.30000 55799.9n 0.30000 55800.0n 0.70000 55979.9n 0.70000 55980.0n 0.70000 56159.9n 0.70000 56160.0n 0.70000 56339.9n 0.70000 56340.0n 0.70000 56519.9n 0.70000 56520.0n 0.30000 56699.9n 0.30000 56700.0n 0.30000 56879.9n 0.30000 56880.0n 0.30000 57059.9n 0.30000 57060.0n 0.70000 57239.9n 0.70000 57240.0n 0.70000 57419.9n 0.70000 57420.0n 0.30000 57599.9n 0.30000 57600.0n 0.30000 57779.9n 0.30000 57780.0n 0.30000 57959.9n 0.30000 57960.0n 0.70000 58139.9n 0.70000 58140.0n 0.30000 58319.9n 0.30000 58320.0n 0.30000 58499.9n 0.30000 58500.0n 0.70000 58679.9n 0.70000 58680.0n 0.30000 58859.9n 0.30000 58860.0n 0.70000 59039.9n 0.70000 59040.0n 0.30000 59219.9n 0.30000 59220.0n 0.70000 59399.9n 0.70000 59400.0n 0.70000 59579.9n 0.70000 59580.0n 0.70000 59759.9n 0.70000 59760.0n 0.70000 59939.9n 0.70000 59940.0n 0.30000 60119.9n 0.30000 60120.0n 0.70000 60299.9n 0.70000 60300.0n 0.70000 60479.9n 0.70000 60480.0n 0.30000 60659.9n 0.30000 60660.0n 0.30000 60839.9n 0.30000 60840.0n 0.30000 61019.9n 0.30000 61020.0n 0.30000 61199.9n 0.30000 61200.0n 0.70000 61379.9n 0.70000 61380.0n 0.70000 61559.9n 0.70000 61560.0n 0.70000 61739.9n 0.70000 61740.0n 0.30000 61919.9n 0.30000 61920.0n 0.30000 62099.9n 0.30000 62100.0n 0.70000 62279.9n 0.70000 62280.0n 0.30000 62459.9n 0.30000 62460.0n 0.70000 62639.9n 0.70000 62640.0n 0.30000 62819.9n 0.30000 62820.0n 0.70000 62999.9n 0.70000 63000.0n 0.70000 63179.9n 0.70000 63180.0n 0.30000 63359.9n 0.30000 63360.0n 0.70000 63539.9n 0.70000 63540.0n 0.30000 63719.9n 0.30000 63720.0n 0.30000 63899.9n 0.30000 63900.0n 0.30000 64079.9n 0.30000 64080.0n 0.30000 64259.9n 0.30000 64260.0n 0.70000 64439.9n 0.70000 64440.0n 0.70000 64619.9n 0.70000 64620.0n 0.70000 64799.9n 0.70000 64800.0n 0.70000 64979.9n 0.70000 64980.0n 0.70000 65159.9n 0.70000 65160.0n 0.30000 65339.9n 0.30000 65340.0n 0.30000 65519.9n 0.30000 65520.0n 0.30000 65699.9n 0.30000 65700.0n 0.30000 65879.9n 0.30000 65880.0n 0.70000 66059.9n 0.70000 66060.0n 0.70000 66239.9n 0.70000 66240.0n 0.70000 66419.9n 0.70000 66420.0n 0.30000 66599.9n 0.30000 66600.0n 0.30000 66779.9n 0.30000 66780.0n 0.70000 66959.9n 0.70000 66960.0n 0.70000 67139.9n 0.70000 67140.0n 0.30000 67319.9n 0.30000 67320.0n 0.30000 67499.9n 0.30000 67500.0n 0.70000 67679.9n 0.70000 67680.0n 0.70000 67859.9n 0.70000 67860.0n 0.30000 68039.9n 0.30000 68040.0n 0.30000 68219.9n 0.30000 68220.0n 0.70000 68399.9n 0.70000 68400.0n 0.70000 68579.9n 0.70000 68580.0n 0.30000 68759.9n 0.30000 68760.0n 0.30000 68939.9n 0.30000 68940.0n 0.70000 69119.9n 0.70000 69120.0n 0.70000 69299.9n 0.70000 69300.0n 0.30000 69479.9n 0.30000 69480.0n 0.30000 69659.9n 0.30000 69660.0n 0.30000 69839.9n 0.30000 69840.0n 0.30000 70019.9n 0.30000 70020.0n 0.30000 70199.9n 0.30000 70200.0n 0.30000 70379.9n 0.30000 70380.0n 0.30000 70559.9n 0.30000 70560.0n 0.70000 70739.9n 0.70000 70740.0n 0.70000 70919.9n 0.70000 70920.0n 0.30000 71099.9n 0.30000 71100.0n 0.30000 71279.9n 0.30000 71280.0n 0.30000 71459.9n 0.30000 71460.0n 0.70000 71639.9n 0.70000 71640.0n 0.70000 71819.9n 0.70000 71820.0n 0.30000 71999.9n 0.30000 72000.0n 0.70000 72179.9n 0.70000 72180.0n 0.70000 72359.9n 0.70000 72360.0n 0.70000 72539.9n 0.70000 72540.0n 0.30000 72719.9n 0.30000 72720.0n 0.70000 72899.9n 0.70000 72900.0n 0.70000 73079.9n 0.70000 73080.0n 0.70000 73259.9n 0.70000 73260.0n 0.30000 73439.9n 0.30000 73440.0n 0.70000 73619.9n 0.70000 73620.0n 0.70000 73799.9n 0.70000 73800.0n 0.30000 73979.9n 0.30000 73980.0n 0.30000 74159.9n 0.30000 74160.0n 0.70000 74339.9n 0.70000 74340.0n 0.70000 74519.9n 0.70000 74520.0n 0.70000 74699.9n 0.70000 74700.0n 0.30000 74879.9n 0.30000 74880.0n 0.70000 75059.9n 0.70000 75060.0n 0.70000 75239.9n 0.70000 75240.0n 0.70000 75419.9n 0.70000 75420.0n 0.30000 75599.9n 0.30000 75600.0n 0.30000 75779.9n 0.30000 75780.0n 0.30000 75959.9n 0.30000 75960.0n 0.70000 76139.9n 0.70000 76140.0n 0.70000 76319.9n 0.70000 76320.0n 0.30000 76499.9n 0.30000 76500.0n 0.30000 76679.9n 0.30000 76680.0n 0.30000 76859.9n 0.30000 76860.0n 0.30000 77039.9n 0.30000 77040.0n 0.30000 77219.9n 0.30000 77220.0n 0.70000 77399.9n 0.70000 77400.0n 0.70000 77579.9n 0.70000 77580.0n 0.70000 77759.9n 0.70000 77760.0n 0.30000 77939.9n 0.30000 77940.0n 0.30000 78119.9n 0.30000 78120.0n 0.70000 78299.9n 0.70000 78300.0n 0.70000 78479.9n 0.70000 78480.0n 0.30000 78659.9n 0.30000 78660.0n 0.70000 78839.9n 0.70000 78840.0n 0.70000 79019.9n 0.70000 79020.0n 0.30000 79199.9n 0.30000 79200.0n 0.30000 79379.9n 0.30000 79380.0n 0.30000 79559.9n 0.30000 79560.0n 0.30000 79739.9n 0.30000 79740.0n 0.70000 79919.9n 0.70000 79920.0n 0.70000 80099.9n 0.70000 80100.0n 0.70000 80279.9n 0.70000 80280.0n 0.30000 80459.9n 0.30000 80460.0n 0.70000 80639.9n 0.70000 80640.0n 0.70000 80819.9n 0.70000 80820.0n 0.70000 80999.9n 0.70000 81000.0n 0.70000 81179.9n 0.70000 81180.0n 0.30000 81359.9n 0.30000 81360.0n 0.70000 81539.9n 0.70000 81540.0n 0.70000 81719.9n 0.70000 81720.0n 0.70000 81899.9n 0.70000 81900.0n 0.70000 82079.9n 0.70000 82080.0n 0.30000 82259.9n 0.30000 82260.0n 0.70000 82439.9n 0.70000 82440.0n 0.30000 82619.9n 0.30000 82620.0n 0.30000 82799.9n 0.30000 82800.0n 0.30000 82979.9n 0.30000 82980.0n 0.30000 83159.9n 0.30000 83160.0n 0.70000 83339.9n 0.70000 83340.0n 0.30000 83519.9n 0.30000 83520.0n 0.30000 83699.9n 0.30000 83700.0n 0.70000 83879.9n 0.70000 83880.0n 0.70000 84059.9n 0.70000 84060.0n 0.30000 84239.9n 0.30000 84240.0n 0.30000 84419.9n 0.30000 84420.0n 0.30000 84599.9n 0.30000 84600.0n 0.30000 84779.9n 0.30000 84780.0n 0.70000 84959.9n 0.70000 84960.0n 0.30000 85139.9n 0.30000 85140.0n 0.30000 85319.9n 0.30000 85320.0n 0.70000 85499.9n 0.70000 85500.0n 0.70000 85679.9n 0.70000 85680.0n 0.70000 85859.9n 0.70000 85860.0n 0.30000 86039.9n 0.30000 86040.0n 0.70000 86219.9n 0.70000 86220.0n 0.30000 86399.9n 0.30000 86400.0n 0.70000 86579.9n 0.70000 86580.0n 0.30000 86759.9n 0.30000 86760.0n 0.30000 86939.9n 0.30000 86940.0n 0.30000 87119.9n 0.30000 87120.0n 0.70000 87299.9n 0.70000 87300.0n 0.70000 87479.9n 0.70000 87480.0n 0.70000 87659.9n 0.70000 87660.0n 0.30000 87839.9n 0.30000 87840.0n 0.30000 88019.9n 0.30000 88020.0n 0.70000 88199.9n 0.70000 88200.0n 0.70000 88379.9n 0.70000 88380.0n 0.30000 88559.9n 0.30000 88560.0n 0.70000 88739.9n 0.70000 88740.0n 0.30000 88919.9n 0.30000 88920.0n 0.30000 89099.9n 0.30000 89100.0n 0.30000 89279.9n 0.30000 89280.0n 0.30000 89459.9n 0.30000 89460.0n 0.30000 89639.9n 0.30000 89640.0n 0.30000 89819.9n 0.30000 89820.0n 0.70000 89999.9n 0.70000 90000.0n 0.70000 90179.9n 0.70000 90180.0n 0.70000 90359.9n 0.70000 90360.0n 0.30000 90539.9n 0.30000 90540.0n 0.30000 90719.9n 0.30000 90720.0n 0.30000 90899.9n 0.30000 90900.0n 0.70000 91079.9n 0.70000 91080.0n 0.70000 91259.9n 0.70000 91260.0n 0.70000 91439.9n 0.70000 91440.0n 0.30000 91619.9n 0.30000 91620.0n 0.70000 91799.9n 0.70000 91800.0n 0.70000 91979.9n 0.70000 91980.0n 0.70000 92159.9n 0.70000 92160.0n 0.70000 92339.9n 0.70000 92340.0n 0.70000 92519.9n 0.70000 92520.0n 0.70000 92699.9n 0.70000 92700.0n 0.70000 92879.9n 0.70000 92880.0n 0.70000 93059.9n 0.70000 93060.0n 0.70000 93239.9n 0.70000 93240.0n 0.70000 93419.9n 0.70000 93420.0n 0.70000 93599.9n 0.70000 93600.0n 0.70000 93779.9n 0.70000 93780.0n 0.30000 93959.9n 0.30000 93960.0n 0.30000 94139.9n 0.30000 94140.0n 0.70000 94319.9n 0.70000 94320.0n 0.30000 94499.9n 0.30000 94500.0n 0.30000 94679.9n 0.30000 94680.0n 0.70000 94859.9n 0.70000 94860.0n 0.70000 95039.9n 0.70000 95040.0n 0.30000 95219.9n 0.30000 95220.0n 0.30000 95399.9n 0.30000 95400.0n 0.30000 95579.9n 0.30000 95580.0n 0.70000 95759.9n 0.70000 95760.0n 0.70000 95939.9n 0.70000 95940.0n 0.30000 96119.9n 0.30000 96120.0n 0.30000 96299.9n 0.30000 96300.0n 0.30000 96479.9n 0.30000 96480.0n 0.70000 96659.9n 0.70000 96660.0n 0.30000 96839.9n 0.30000 96840.0n 0.30000 97019.9n 0.30000 97020.0n 0.30000 97199.9n 0.30000 97200.0n 0.70000 97379.9n 0.70000 97380.0n 0.30000 97559.9n 0.30000 97560.0n 0.30000 97739.9n 0.30000 97740.0n 0.30000 97919.9n 0.30000 97920.0n 0.70000 98099.9n 0.70000 98100.0n 0.70000 98279.9n 0.70000 98280.0n 0.70000 98459.9n 0.70000 98460.0n 0.70000 98639.9n 0.70000 98640.0n 0.30000 98819.9n 0.30000 98820.0n 0.30000 98999.9n 0.30000 99000.0n 0.30000 99179.9n 0.30000 99180.0n 0.30000 99359.9n 0.30000 99360.0n 0.70000 99539.9n 0.70000 99540.0n 0.70000 99719.9n 0.70000 99720.0n 0.30000 99899.9n 0.30000 99900.0n 0.70000 100079.9n 0.70000 100080.0n 0.30000 100259.9n 0.30000 100260.0n 0.70000 100439.9n 0.70000 100440.0n 0.30000 100619.9n 0.30000 100620.0n 0.70000 100799.9n 0.70000 100800.0n 0.70000 100979.9n 0.70000 100980.0n 0.30000 101159.9n 0.30000 101160.0n 0.30000 101339.9n 0.30000 101340.0n 0.70000 101519.9n 0.70000 101520.0n 0.30000 101699.9n 0.30000 101700.0n 0.30000 101879.9n 0.30000 101880.0n 0.30000 102059.9n 0.30000 102060.0n 0.70000 102239.9n 0.70000 102240.0n 0.70000 102419.9n 0.70000 102420.0n 0.70000 102599.9n 0.70000 102600.0n 0.30000 102779.9n 0.30000 102780.0n 0.70000 102959.9n 0.70000 102960.0n 0.30000 103139.9n 0.30000 103140.0n 0.30000 103319.9n 0.30000 103320.0n 0.30000 103499.9n 0.30000 103500.0n 0.70000 103679.9n 0.70000 103680.0n 0.70000 103859.9n 0.70000 103860.0n 0.70000 104039.9n 0.70000 104040.0n 0.30000 104219.9n 0.30000 104220.0n 0.70000 104399.9n 0.70000 104400.0n 0.70000 104579.9n 0.70000 104580.0n 0.70000 104759.9n 0.70000 104760.0n 0.30000 104939.9n 0.30000 104940.0n 0.70000 105119.9n 0.70000 105120.0n 0.70000 105299.9n 0.70000 105300.0n 0.30000 105479.9n 0.30000 105480.0n 0.30000 105659.9n 0.30000 105660.0n 0.70000 105839.9n 0.70000 105840.0n 0.30000 106019.9n 0.30000 106020.0n 0.30000 106199.9n 0.30000 106200.0n 0.30000 106379.9n 0.30000 106380.0n 0.30000 106559.9n 0.30000 106560.0n 0.30000 106739.9n 0.30000 106740.0n 0.30000 106919.9n 0.30000 106920.0n 0.70000 107099.9n 0.70000 107100.0n 0.70000 107279.9n 0.70000 107280.0n 0.30000 107459.9n 0.30000 107460.0n 0.70000 107639.9n 0.70000 107640.0n 0.30000 107819.9n 0.30000 107820.0n 0.30000 107999.9n 0.30000 108000.0n 0.70000 108179.9n 0.70000 108180.0n 0.70000 108359.9n 0.70000 108360.0n 0.70000 108539.9n 0.70000 108540.0n 0.30000 108719.9n 0.30000 108720.0n 0.70000 108899.9n 0.70000 108900.0n 0.30000 109079.9n 0.30000 109080.0n 0.30000 109259.9n 0.30000 109260.0n 0.70000 109439.9n 0.70000 109440.0n 0.70000 109619.9n 0.70000 109620.0n 0.70000 109799.9n 0.70000 109800.0n 0.30000 109979.9n 0.30000 109980.0n 0.30000 110159.9n 0.30000 110160.0n 0.70000 110339.9n 0.70000 110340.0n 0.30000 110519.9n 0.30000 110520.0n 0.70000 110699.9n 0.70000 110700.0n 0.70000 110879.9n 0.70000 110880.0n 0.30000 111059.9n 0.30000 111060.0n 0.30000 111239.9n 0.30000 111240.0n 0.70000 111419.9n 0.70000 111420.0n 0.70000 111599.9n 0.70000 111600.0n 0.30000 111779.9n 0.30000 111780.0n 0.70000 111959.9n 0.70000 111960.0n 0.30000 112139.9n 0.30000 112140.0n 0.70000 112319.9n 0.70000 112320.0n 0.70000 112499.9n 0.70000 112500.0n 0.30000 112679.9n 0.30000 112680.0n 0.70000 112859.9n 0.70000 112860.0n 0.70000 113039.9n 0.70000 113040.0n 0.30000 113219.9n 0.30000 113220.0n 0.30000 113399.9n 0.30000 113400.0n 0.30000 113579.9n 0.30000 113580.0n 0.30000 113759.9n 0.30000 113760.0n 0.30000 113939.9n 0.30000 113940.0n 0.30000 114119.9n 0.30000 114120.0n 0.70000 114299.9n 0.70000 114300.0n 0.70000 114479.9n 0.70000 114480.0n 0.30000 114659.9n 0.30000 114660.0n 0.30000 114839.9n 0.30000 114840.0n 0.70000 115019.9n 0.70000 115020.0n 0.70000 115199.9n 0.70000 115200.0n 0.70000 115379.9n 0.70000 115380.0n 0.70000 115559.9n 0.70000 115560.0n 0.30000 115739.9n 0.30000 115740.0n 0.70000 115919.9n 0.70000 115920.0n 0.70000 116099.9n 0.70000 116100.0n 0.30000 116279.9n 0.30000 116280.0n 0.30000 116459.9n 0.30000 116460.0n 0.30000 116639.9n 0.30000 116640.0n 0.70000 116819.9n 0.70000 116820.0n 0.30000 116999.9n 0.30000 117000.0n 0.30000 117179.9n 0.30000 117180.0n 0.70000 117359.9n 0.70000 117360.0n 0.30000 117539.9n 0.30000 117540.0n 0.70000 117719.9n 0.70000 117720.0n 0.70000 117899.9n 0.70000 117900.0n 0.70000 118079.9n 0.70000 118080.0n 0.30000 118259.9n 0.30000 118260.0n 0.30000 118439.9n 0.30000 118440.0n 0.70000 118619.9n 0.70000 118620.0n 0.30000 118799.9n 0.30000 118800.0n 0.30000 118979.9n 0.30000 118980.0n 0.30000 119159.9n 0.30000 119160.0n 0.70000 119339.9n 0.70000 119340.0n 0.70000 119519.9n 0.70000 119520.0n 0.70000 119699.9n 0.70000 119700.0n 0.70000 119879.9n 0.70000 119880.0n 0.30000 120059.9n 0.30000 120060.0n 0.30000 120239.9n 0.30000 120240.0n 0.70000 120419.9n 0.70000 120420.0n 0.30000 120599.9n 0.30000 120600.0n 0.70000 120779.9n 0.70000 120780.0n 0.30000 120959.9n 0.30000 120960.0n 0.70000 121139.9n 0.70000 121140.0n 0.70000 121319.9n 0.70000 121320.0n 0.70000 121499.9n 0.70000 121500.0n 0.70000 121679.9n 0.70000 121680.0n 0.70000 121859.9n 0.70000 121860.0n 0.30000 122039.9n 0.30000 122040.0n 0.70000 122219.9n 0.70000 122220.0n 0.70000 122399.9n 0.70000 122400.0n 0.30000 122579.9n 0.30000 122580.0n 0.30000 122759.9n 0.30000 122760.0n 0.30000 122939.9n 0.30000 122940.0n 0.30000 123119.9n 0.30000 123120.0n 0.70000 123299.9n 0.70000 123300.0n 0.30000 123479.9n 0.30000 123480.0n 0.30000 123659.9n 0.30000 123660.0n 0.30000 123839.9n 0.30000 123840.0n 0.70000 124019.9n 0.70000 124020.0n 0.30000 124199.9n 0.30000 124200.0n 0.30000 124379.9n 0.30000 124380.0n 0.30000 124559.9n 0.30000 124560.0n 0.30000 124739.9n 0.30000 124740.0n 0.70000 124919.9n 0.70000 124920.0n 0.70000 125099.9n 0.70000 125100.0n 0.70000 125279.9n 0.70000 125280.0n 0.30000 125459.9n 0.30000 125460.0n 0.30000 125639.9n 0.30000 125640.0n 0.70000 125819.9n 0.70000 125820.0n 0.30000 125999.9n 0.30000 126000.0n 0.70000 126179.9n 0.70000 126180.0n 0.70000 126359.9n 0.70000 126360.0n 0.30000 126539.9n 0.30000 126540.0n 0.70000 126719.9n 0.70000 126720.0n 0.70000 126899.9n 0.70000 126900.0n 0.70000 127079.9n 0.70000 127080.0n 0.30000 127259.9n 0.30000 127260.0n 0.30000 127439.9n 0.30000 127440.0n 0.70000 127619.9n 0.70000 127620.0n 0.70000 127799.9n 0.70000 127800.0n 0.70000 127979.9n 0.70000 127980.0n 0.70000 128159.9n 0.70000 128160.0n 0.70000 128339.9n 0.70000 128340.0n 0.70000 128519.9n 0.70000 128520.0n 0.30000 128699.9n 0.30000 128700.0n 0.30000 128879.9n 0.30000 128880.0n 0.70000 129059.9n 0.70000 129060.0n 0.70000 129239.9n 0.70000 129240.0n 0.30000 129419.9n 0.30000 129420.0n 0.30000 129599.9n 0.30000 129600.0n 0.30000 129779.9n 0.30000 129780.0n 0.30000 129959.9n 0.30000 129960.0n 0.70000 130139.9n 0.70000 130140.0n 0.30000 130319.9n 0.30000 130320.0n 0.70000 130499.9n 0.70000 130500.0n 0.30000 130679.9n 0.30000 130680.0n 0.70000 130859.9n 0.70000 130860.0n 0.30000 131039.9n 0.30000 131040.0n 0.30000 131219.9n 0.30000 131220.0n 0.30000 131399.9n 0.30000 131400.0n 0.30000 131579.9n 0.30000 131580.0n 0.30000 131759.9n 0.30000 131760.0n 0.70000 131939.9n 0.70000 131940.0n 0.30000 132119.9n 0.30000 132120.0n 0.70000 132299.9n 0.70000 132300.0n 0.70000 132479.9n 0.70000 132480.0n 0.30000 132659.9n 0.30000 132660.0n 0.30000 132839.9n 0.30000 132840.0n 0.30000 133019.9n 0.30000 133020.0n 0.30000 133199.9n 0.30000 133200.0n 0.30000 133379.9n 0.30000 133380.0n 0.70000 133559.9n 0.70000 133560.0n 0.70000 133739.9n 0.70000 133740.0n 0.30000 133919.9n 0.30000 133920.0n 0.30000 134099.9n 0.30000 134100.0n 0.70000 134279.9n 0.70000 134280.0n 0.70000 134459.9n 0.70000 134460.0n 0.70000 134639.9n 0.70000 134640.0n 0.30000 134819.9n 0.30000 134820.0n 0.30000 134999.9n 0.30000 135000.0n 0.70000 135179.9n 0.70000 135180.0n 0.30000 135359.9n 0.30000 135360.0n 0.70000 135539.9n 0.70000 135540.0n 0.30000 135719.9n 0.30000 135720.0n 0.30000 135899.9n 0.30000 135900.0n 0.70000 136079.9n 0.70000 136080.0n 0.70000 136259.9n 0.70000 136260.0n 0.30000 136439.9n 0.30000 136440.0n 0.30000 136619.9n 0.30000 136620.0n 0.30000 136799.9n 0.30000 136800.0n 0.70000 136979.9n 0.70000 136980.0n 0.70000 137159.9n 0.70000 137160.0n 0.70000 137339.9n 0.70000 137340.0n 0.70000 137519.9n 0.70000 137520.0n 0.30000 137699.9n 0.30000 137700.0n 0.70000 137879.9n 0.70000 137880.0n 0.70000 138059.9n 0.70000 138060.0n 0.70000 138239.9n 0.70000 138240.0n 0.70000 138419.9n 0.70000 138420.0n 0.30000 138599.9n 0.30000 138600.0n 0.30000 138779.9n 0.30000 138780.0n 0.70000 138959.9n 0.70000 138960.0n 0.70000 139139.9n 0.70000 139140.0n 0.30000 139319.9n 0.30000 139320.0n 0.30000 139499.9n 0.30000 139500.0n 0.30000 139679.9n 0.30000 139680.0n 0.30000 139859.9n 0.30000 139860.0n 0.30000 140039.9n 0.30000 140040.0n 0.30000 140219.9n 0.30000 140220.0n 0.70000 140399.9n 0.70000 140400.0n 0.70000 140579.9n 0.70000 140580.0n 0.70000 140759.9n 0.70000 140760.0n 0.30000 140939.9n 0.30000 140940.0n 0.70000 141119.9n 0.70000 141120.0n 0.30000 141299.9n 0.30000 141300.0n 0.30000 141479.9n 0.30000 141480.0n 0.70000 141659.9n 0.70000 141660.0n 0.30000 141839.9n 0.30000 141840.0n 0.30000 142019.9n 0.30000 142020.0n 0.30000 142199.9n 0.30000 142200.0n 0.70000 142379.9n 0.70000 142380.0n 0.30000 142559.9n 0.30000 142560.0n 0.70000 142739.9n 0.70000 142740.0n 0.70000 142919.9n 0.70000 142920.0n 0.70000 143099.9n 0.70000 143100.0n 0.70000 143279.9n 0.70000 143280.0n 0.70000 143459.9n 0.70000 143460.0n 0.30000 143639.9n 0.30000 143640.0n 0.70000 143819.9n 0.70000 143820.0n 0.70000 143999.9n 0.70000 144000.0n 0.70000 144179.9n 0.70000 144180.0n 0.70000 144359.9n 0.70000 144360.0n 0.30000 144539.9n 0.30000 144540.0n 0.30000 144719.9n 0.30000 144720.0n 0.70000 144899.9n 0.70000 144900.0n 0.70000 145079.9n 0.70000 145080.0n 0.30000 145259.9n 0.30000 145260.0n 0.30000 145439.9n 0.30000 145440.0n 0.30000 145619.9n 0.30000 145620.0n 0.30000 145799.9n 0.30000 145800.0n 0.30000 145979.9n 0.30000 145980.0n 0.70000 146159.9n 0.70000 146160.0n 0.30000 146339.9n 0.30000 146340.0n 0.70000 146519.9n 0.70000 146520.0n 0.70000 146699.9n 0.70000 146700.0n 0.30000 146879.9n 0.30000 146880.0n 0.30000 147059.9n 0.30000 147060.0n 0.30000 147239.9n 0.30000 147240.0n 0.70000 147419.9n 0.70000 147420.0n 0.30000 147599.9n 0.30000 147600.0n 0.30000 147779.9n 0.30000 147780.0n 0.70000 147959.9n 0.70000 147960.0n 0.70000 148139.9n 0.70000 148140.0n 0.70000 148319.9n 0.70000 148320.0n 0.70000 148499.9n 0.70000 148500.0n 0.30000 148679.9n 0.30000 148680.0n 0.70000 148859.9n 0.70000 148860.0n 0.30000 149039.9n 0.30000 149040.0n 0.70000 149219.9n 0.70000 149220.0n 0.70000 149399.9n 0.70000 149400.0n 0.70000 149579.9n 0.70000 149580.0n 0.30000 149759.9n 0.30000 149760.0n 0.70000 149939.9n 0.70000 149940.0n 0.30000 150119.9n 0.30000 150120.0n 0.70000 150299.9n 0.70000 150300.0n 0.30000 150479.9n 0.30000 150480.0n 0.70000 150659.9n 0.70000 150660.0n 0.30000 150839.9n 0.30000 150840.0n 0.30000 151019.9n 0.30000 151020.0n 0.30000 151199.9n 0.30000 151200.0n 0.30000 151379.9n 0.30000 151380.0n 0.30000 151559.9n 0.30000 151560.0n 0.70000 151739.9n 0.70000 151740.0n 0.70000 151919.9n 0.70000 151920.0n 0.70000 152099.9n 0.70000 152100.0n 0.70000 152279.9n 0.70000 152280.0n 0.30000 152459.9n 0.30000 152460.0n 0.70000 152639.9n 0.70000 152640.0n 0.30000 152819.9n 0.30000 152820.0n 0.30000 152999.9n 0.30000 153000.0n 0.30000 153179.9n 0.30000 153180.0n 0.30000 153359.9n 0.30000 153360.0n 0.70000 153539.9n 0.70000 153540.0n 0.70000 153719.9n 0.70000 153720.0n 0.30000 153899.9n 0.30000 153900.0n 0.30000 154079.9n 0.30000 154080.0n 0.70000 154259.9n 0.70000 154260.0n 0.70000 154439.9n 0.70000 154440.0n 0.70000 154619.9n 0.70000 154620.0n 0.70000 154799.9n 0.70000 154800.0n 0.70000 154979.9n 0.70000 154980.0n 0.30000 155159.9n 0.30000 155160.0n 0.70000 155339.9n 0.70000 155340.0n 0.30000 155519.9n 0.30000 155520.0n 0.70000 155699.9n 0.70000 155700.0n 0.70000 155879.9n 0.70000 155880.0n 0.30000 156059.9n 0.30000 156060.0n 0.70000 156239.9n 0.70000 156240.0n 0.30000 156419.9n 0.30000 156420.0n 0.70000 156599.9n 0.70000 156600.0n 0.30000 156779.9n 0.30000 156780.0n 0.30000 156959.9n 0.30000 156960.0n 0.70000 157139.9n 0.70000 157140.0n 0.70000 157319.9n 0.70000 157320.0n 0.30000 157499.9n 0.30000 157500.0n 0.70000 157679.9n 0.70000 157680.0n 0.30000 157859.9n 0.30000 157860.0n 0.70000 158039.9n 0.70000 158040.0n 0.30000 158219.9n 0.30000 158220.0n 0.30000 158399.9n 0.30000 158400.0n 0.70000 158579.9n 0.70000 158580.0n 0.30000 158759.9n 0.30000 158760.0n 0.30000 158939.9n 0.30000 158940.0n 0.70000 159119.9n 0.70000 159120.0n 0.30000 159299.9n 0.30000 159300.0n 0.30000 159479.9n 0.30000 159480.0n 0.70000 159659.9n 0.70000 159660.0n 0.30000 159839.9n 0.30000 159840.0n 0.70000 160019.9n 0.70000 160020.0n 0.70000 160199.9n 0.70000 160200.0n 0.30000 160379.9n 0.30000 160380.0n 0.70000 160559.9n 0.70000 160560.0n 0.70000 160739.9n 0.70000 160740.0n 0.30000 160919.9n 0.30000 160920.0n 0.70000 161099.9n 0.70000 161100.0n 0.30000 161279.9n 0.30000 161280.0n 0.30000 161459.9n 0.30000 161460.0n 0.30000 161639.9n 0.30000 161640.0n 0.70000 161819.9n 0.70000 161820.0n 0.70000 161999.9n 0.70000 162000.0n 0.70000 162179.9n 0.70000 162180.0n 0.30000 162359.9n 0.30000 162360.0n 0.70000 162539.9n 0.70000 162540.0n 0.70000 162719.9n 0.70000 162720.0n 0.30000 162899.9n 0.30000 162900.0n 0.70000 163079.9n 0.70000 163080.0n 0.70000 163259.9n 0.70000 163260.0n 0.30000 163439.9n 0.30000 163440.0n 0.30000 163619.9n 0.30000 163620.0n 0.70000 163799.9n 0.70000 163800.0n 0.30000 163979.9n 0.30000 163980.0n 0.70000 164159.9n 0.70000 164160.0n 0.70000 164339.9n 0.70000 164340.0n 0.70000 164519.9n 0.70000 164520.0n 0.70000 164699.9n 0.70000 164700.0n 0.30000 164879.9n 0.30000 164880.0n 0.30000 165059.9n 0.30000 165060.0n 0.30000 165239.9n 0.30000 165240.0n 0.70000 165419.9n 0.70000 165420.0n 0.30000 165599.9n 0.30000 165600.0n 0.70000 165779.9n 0.70000 165780.0n 0.30000 165959.9n 0.30000 165960.0n 0.30000 166139.9n 0.30000 166140.0n 0.70000 166319.9n 0.70000 166320.0n 0.70000 166499.9n 0.70000 166500.0n 0.30000 166679.9n 0.30000 166680.0n 0.30000 166859.9n 0.30000 166860.0n 0.30000 167039.9n 0.30000 167040.0n 0.70000 167219.9n 0.70000 167220.0n 0.30000 167399.9n 0.30000 167400.0n 0.70000 167579.9n 0.70000 167580.0n 0.70000 167759.9n 0.70000 167760.0n 0.70000 167939.9n 0.70000 167940.0n 0.70000 168119.9n 0.70000 168120.0n 0.30000 168299.9n 0.30000 168300.0n 0.30000 168479.9n 0.30000 168480.0n 0.70000 168659.9n 0.70000 168660.0n 0.30000 168839.9n 0.30000 168840.0n 0.70000 169019.9n 0.70000 169020.0n 0.30000 169199.9n 0.30000 169200.0n 0.30000 169379.9n 0.30000 169380.0n 0.70000 169559.9n 0.70000 169560.0n 0.70000 169739.9n 0.70000 169740.0n 0.70000 169919.9n 0.70000 169920.0n 0.30000 170099.9n 0.30000 170100.0n 0.70000 170279.9n 0.70000 170280.0n 0.30000 170459.9n 0.30000 170460.0n 0.70000 170639.9n 0.70000 170640.0n 0.70000 170819.9n 0.70000 170820.0n 0.30000 170999.9n 0.30000 171000.0n 0.30000 171179.9n 0.30000 171180.0n 0.70000 171359.9n 0.70000 171360.0n 0.30000 171539.9n 0.30000 171540.0n 0.30000 171719.9n 0.30000 171720.0n 0.30000 171899.9n 0.30000 171900.0n 0.30000 172079.9n 0.30000 172080.0n 0.30000 172259.9n 0.30000 172260.0n 0.70000 172439.9n 0.70000 172440.0n 0.70000 172619.9n 0.70000 172620.0n 0.30000 172799.9n 0.30000 172800.0n 0.50000 172979.9n 0.50000 172980.0n 0.50000 173159.9n 0.50000 173160.0n 0.50000 173339.9n 0.50000 173340.0n 0.50000 173519.9n 0.50000 173520.0n 0.50000 173699.9n 0.50000 173700.0n 0.50000 173879.9n 0.50000 173880.0n 0.50000 174059.9n 0.50000 174060.0n 0.50000 174239.9n 0.50000 174240.0n 0.50000 174419.9n 0.50000 174420.0n 0.50000 174599.9n 0.50000 174600.0n 0.50000 174779.9n 0.50000 174780.0n 0.50000 174959.9n 0.50000 174960.0n 0.50000 175139.9n 0.50000 175140.0n 0.50000 175319.9n 0.50000 175320.0n 0.50000 175499.9n 0.50000 175500.0n 0.50000 175679.9n 0.50000 175680.0n 0.50000 175859.9n 0.50000 175860.0n 0.50000 176039.9n 0.50000 176040.0n 0.50000 176219.9n 0.50000 176220.0n 0.50000 176399.9n 0.50000 176400.0n 0.50000 176579.9n 0.50000 176580.0n 0.50000 176759.9n 0.50000 176760.0n 0.50000 176939.9n 0.50000 176940.0n 0.50000 177119.9n 0.50000 177120.0n 0.50000 177299.9n 0.50000 177300.0n 0.50000 177479.9n 0.50000 177480.0n 0.50000 177659.9n 0.50000 177660.0n 0.50000 177839.9n 0.50000 177840.0n 0.50000 178019.9n 0.50000 178020.0n 0.50000 178199.9n 0.50000 178200.0n 0.50000 178379.9n 0.50000 178380.0n 0.50000 178559.9n 0.50000 178560.0n 0.50000 178739.9n 0.50000 178740.0n 0.50000 178919.9n 0.50000 178920.0n 0.50000 179099.9n 0.50000 179100.0n 0.50000 179279.9n 0.50000 179280.0n 0.50000 179459.9n 0.50000 179460.0n 0.50000 179639.9n 0.50000 179640.0n 0.50000 179819.9n 0.50000 179820.0n 0.50000 179999.9n 0.50000 180000.0n 0.50000 180179.9n 0.50000 180180.0n 0.50000 180359.9n 0.50000 180360.0n 0.50000 180539.9n 0.50000 180540.0n 0.50000 180719.9n 0.50000 180720.0n 0.50000 180899.9n 0.50000 180900.0n 0.50000 181079.9n 0.50000 181080.0n 0.50000 181259.9n 0.50000 181260.0n 0.50000 181439.9n 0.50000 181440.0n 0.50000 181619.9n 0.50000 181620.0n 0.50000 181799.9n 0.50000 181800.0n 0.50000 181979.9n 0.50000 181980.0n 0.50000 182159.9n 0.50000 182160.0n 0.50000 182339.9n 0.50000 182340.0n 0.50000 182519.9n 0.50000 182520.0n 0.50000 182699.9n 0.50000 182700.0n 0.50000 182879.9n 0.50000 182880.0n 0.50000 183059.9n 0.50000 183060.0n 0.50000 183239.9n 0.50000 183240.0n 0.50000 183419.9n 0.50000 183420.0n 0.50000)
Vxon1 xon1 0 PWL(0.0n 0.30000 179.9n 0.30000 180.0n 0.30000 359.9n 0.30000 360.0n 0.70000 539.9n 0.70000 540.0n 0.30000 719.9n 0.30000 720.0n 0.30000 899.9n 0.30000 900.0n 0.30000 1079.9n 0.30000 1080.0n 0.70000 1259.9n 0.70000 1260.0n 0.70000 1439.9n 0.70000 1440.0n 0.70000 1619.9n 0.70000 1620.0n 0.30000 1799.9n 0.30000 1800.0n 0.30000 1979.9n 0.30000 1980.0n 0.70000 2159.9n 0.70000 2160.0n 0.70000 2339.9n 0.70000 2340.0n 0.70000 2519.9n 0.70000 2520.0n 0.30000 2699.9n 0.30000 2700.0n 0.70000 2879.9n 0.70000 2880.0n 0.70000 3059.9n 0.70000 3060.0n 0.30000 3239.9n 0.30000 3240.0n 0.30000 3419.9n 0.30000 3420.0n 0.30000 3599.9n 0.30000 3600.0n 0.70000 3779.9n 0.70000 3780.0n 0.30000 3959.9n 0.30000 3960.0n 0.30000 4139.9n 0.30000 4140.0n 0.70000 4319.9n 0.70000 4320.0n 0.70000 4499.9n 0.70000 4500.0n 0.30000 4679.9n 0.30000 4680.0n 0.70000 4859.9n 0.70000 4860.0n 0.70000 5039.9n 0.70000 5040.0n 0.70000 5219.9n 0.70000 5220.0n 0.70000 5399.9n 0.70000 5400.0n 0.30000 5579.9n 0.30000 5580.0n 0.30000 5759.9n 0.30000 5760.0n 0.30000 5939.9n 0.30000 5940.0n 0.30000 6119.9n 0.30000 6120.0n 0.30000 6299.9n 0.30000 6300.0n 0.70000 6479.9n 0.70000 6480.0n 0.70000 6659.9n 0.70000 6660.0n 0.30000 6839.9n 0.30000 6840.0n 0.30000 7019.9n 0.30000 7020.0n 0.70000 7199.9n 0.70000 7200.0n 0.70000 7379.9n 0.70000 7380.0n 0.70000 7559.9n 0.70000 7560.0n 0.30000 7739.9n 0.30000 7740.0n 0.30000 7919.9n 0.30000 7920.0n 0.30000 8099.9n 0.30000 8100.0n 0.70000 8279.9n 0.70000 8280.0n 0.30000 8459.9n 0.30000 8460.0n 0.70000 8639.9n 0.70000 8640.0n 0.30000 8819.9n 0.30000 8820.0n 0.70000 8999.9n 0.70000 9000.0n 0.70000 9179.9n 0.70000 9180.0n 0.70000 9359.9n 0.70000 9360.0n 0.70000 9539.9n 0.70000 9540.0n 0.70000 9719.9n 0.70000 9720.0n 0.30000 9899.9n 0.30000 9900.0n 0.30000 10079.9n 0.30000 10080.0n 0.30000 10259.9n 0.30000 10260.0n 0.70000 10439.9n 0.70000 10440.0n 0.70000 10619.9n 0.70000 10620.0n 0.30000 10799.9n 0.30000 10800.0n 0.70000 10979.9n 0.70000 10980.0n 0.70000 11159.9n 0.70000 11160.0n 0.30000 11339.9n 0.30000 11340.0n 0.30000 11519.9n 0.30000 11520.0n 0.30000 11699.9n 0.30000 11700.0n 0.70000 11879.9n 0.70000 11880.0n 0.70000 12059.9n 0.70000 12060.0n 0.70000 12239.9n 0.70000 12240.0n 0.30000 12419.9n 0.30000 12420.0n 0.30000 12599.9n 0.30000 12600.0n 0.70000 12779.9n 0.70000 12780.0n 0.30000 12959.9n 0.30000 12960.0n 0.30000 13139.9n 0.30000 13140.0n 0.70000 13319.9n 0.70000 13320.0n 0.30000 13499.9n 0.30000 13500.0n 0.70000 13679.9n 0.70000 13680.0n 0.70000 13859.9n 0.70000 13860.0n 0.70000 14039.9n 0.70000 14040.0n 0.70000 14219.9n 0.70000 14220.0n 0.30000 14399.9n 0.30000 14400.0n 0.70000 14579.9n 0.70000 14580.0n 0.70000 14759.9n 0.70000 14760.0n 0.30000 14939.9n 0.30000 14940.0n 0.30000 15119.9n 0.30000 15120.0n 0.30000 15299.9n 0.30000 15300.0n 0.70000 15479.9n 0.70000 15480.0n 0.70000 15659.9n 0.70000 15660.0n 0.30000 15839.9n 0.30000 15840.0n 0.30000 16019.9n 0.30000 16020.0n 0.70000 16199.9n 0.70000 16200.0n 0.30000 16379.9n 0.30000 16380.0n 0.70000 16559.9n 0.70000 16560.0n 0.70000 16739.9n 0.70000 16740.0n 0.30000 16919.9n 0.30000 16920.0n 0.30000 17099.9n 0.30000 17100.0n 0.30000 17279.9n 0.30000 17280.0n 0.30000 17459.9n 0.30000 17460.0n 0.70000 17639.9n 0.70000 17640.0n 0.70000 17819.9n 0.70000 17820.0n 0.30000 17999.9n 0.30000 18000.0n 0.70000 18179.9n 0.70000 18180.0n 0.30000 18359.9n 0.30000 18360.0n 0.30000 18539.9n 0.30000 18540.0n 0.70000 18719.9n 0.70000 18720.0n 0.70000 18899.9n 0.70000 18900.0n 0.70000 19079.9n 0.70000 19080.0n 0.70000 19259.9n 0.70000 19260.0n 0.70000 19439.9n 0.70000 19440.0n 0.70000 19619.9n 0.70000 19620.0n 0.30000 19799.9n 0.30000 19800.0n 0.30000 19979.9n 0.30000 19980.0n 0.70000 20159.9n 0.70000 20160.0n 0.30000 20339.9n 0.30000 20340.0n 0.70000 20519.9n 0.70000 20520.0n 0.70000 20699.9n 0.70000 20700.0n 0.30000 20879.9n 0.30000 20880.0n 0.30000 21059.9n 0.30000 21060.0n 0.70000 21239.9n 0.70000 21240.0n 0.70000 21419.9n 0.70000 21420.0n 0.30000 21599.9n 0.30000 21600.0n 0.30000 21779.9n 0.30000 21780.0n 0.30000 21959.9n 0.30000 21960.0n 0.30000 22139.9n 0.30000 22140.0n 0.30000 22319.9n 0.30000 22320.0n 0.70000 22499.9n 0.70000 22500.0n 0.30000 22679.9n 0.30000 22680.0n 0.70000 22859.9n 0.70000 22860.0n 0.30000 23039.9n 0.30000 23040.0n 0.70000 23219.9n 0.70000 23220.0n 0.70000 23399.9n 0.70000 23400.0n 0.70000 23579.9n 0.70000 23580.0n 0.30000 23759.9n 0.30000 23760.0n 0.70000 23939.9n 0.70000 23940.0n 0.70000 24119.9n 0.70000 24120.0n 0.70000 24299.9n 0.70000 24300.0n 0.30000 24479.9n 0.30000 24480.0n 0.70000 24659.9n 0.70000 24660.0n 0.70000 24839.9n 0.70000 24840.0n 0.70000 25019.9n 0.70000 25020.0n 0.70000 25199.9n 0.70000 25200.0n 0.30000 25379.9n 0.30000 25380.0n 0.30000 25559.9n 0.30000 25560.0n 0.30000 25739.9n 0.30000 25740.0n 0.70000 25919.9n 0.70000 25920.0n 0.70000 26099.9n 0.70000 26100.0n 0.70000 26279.9n 0.70000 26280.0n 0.30000 26459.9n 0.30000 26460.0n 0.30000 26639.9n 0.30000 26640.0n 0.30000 26819.9n 0.30000 26820.0n 0.70000 26999.9n 0.70000 27000.0n 0.70000 27179.9n 0.70000 27180.0n 0.70000 27359.9n 0.70000 27360.0n 0.30000 27539.9n 0.30000 27540.0n 0.30000 27719.9n 0.30000 27720.0n 0.30000 27899.9n 0.30000 27900.0n 0.30000 28079.9n 0.30000 28080.0n 0.30000 28259.9n 0.30000 28260.0n 0.30000 28439.9n 0.30000 28440.0n 0.30000 28619.9n 0.30000 28620.0n 0.30000 28799.9n 0.30000 28800.0n 0.30000 28979.9n 0.30000 28980.0n 0.70000 29159.9n 0.70000 29160.0n 0.70000 29339.9n 0.70000 29340.0n 0.70000 29519.9n 0.70000 29520.0n 0.30000 29699.9n 0.30000 29700.0n 0.70000 29879.9n 0.70000 29880.0n 0.30000 30059.9n 0.30000 30060.0n 0.30000 30239.9n 0.30000 30240.0n 0.30000 30419.9n 0.30000 30420.0n 0.70000 30599.9n 0.70000 30600.0n 0.70000 30779.9n 0.70000 30780.0n 0.70000 30959.9n 0.70000 30960.0n 0.30000 31139.9n 0.30000 31140.0n 0.30000 31319.9n 0.30000 31320.0n 0.70000 31499.9n 0.70000 31500.0n 0.30000 31679.9n 0.30000 31680.0n 0.70000 31859.9n 0.70000 31860.0n 0.30000 32039.9n 0.30000 32040.0n 0.30000 32219.9n 0.30000 32220.0n 0.70000 32399.9n 0.70000 32400.0n 0.70000 32579.9n 0.70000 32580.0n 0.70000 32759.9n 0.70000 32760.0n 0.70000 32939.9n 0.70000 32940.0n 0.70000 33119.9n 0.70000 33120.0n 0.70000 33299.9n 0.70000 33300.0n 0.30000 33479.9n 0.30000 33480.0n 0.30000 33659.9n 0.30000 33660.0n 0.30000 33839.9n 0.30000 33840.0n 0.30000 34019.9n 0.30000 34020.0n 0.70000 34199.9n 0.70000 34200.0n 0.30000 34379.9n 0.30000 34380.0n 0.30000 34559.9n 0.30000 34560.0n 0.70000 34739.9n 0.70000 34740.0n 0.70000 34919.9n 0.70000 34920.0n 0.30000 35099.9n 0.30000 35100.0n 0.30000 35279.9n 0.30000 35280.0n 0.30000 35459.9n 0.30000 35460.0n 0.30000 35639.9n 0.30000 35640.0n 0.70000 35819.9n 0.70000 35820.0n 0.70000 35999.9n 0.70000 36000.0n 0.70000 36179.9n 0.70000 36180.0n 0.70000 36359.9n 0.70000 36360.0n 0.70000 36539.9n 0.70000 36540.0n 0.70000 36719.9n 0.70000 36720.0n 0.70000 36899.9n 0.70000 36900.0n 0.70000 37079.9n 0.70000 37080.0n 0.30000 37259.9n 0.30000 37260.0n 0.70000 37439.9n 0.70000 37440.0n 0.30000 37619.9n 0.30000 37620.0n 0.30000 37799.9n 0.30000 37800.0n 0.30000 37979.9n 0.30000 37980.0n 0.30000 38159.9n 0.30000 38160.0n 0.70000 38339.9n 0.70000 38340.0n 0.70000 38519.9n 0.70000 38520.0n 0.30000 38699.9n 0.30000 38700.0n 0.70000 38879.9n 0.70000 38880.0n 0.30000 39059.9n 0.30000 39060.0n 0.70000 39239.9n 0.70000 39240.0n 0.30000 39419.9n 0.30000 39420.0n 0.70000 39599.9n 0.70000 39600.0n 0.30000 39779.9n 0.30000 39780.0n 0.30000 39959.9n 0.30000 39960.0n 0.30000 40139.9n 0.30000 40140.0n 0.30000 40319.9n 0.30000 40320.0n 0.70000 40499.9n 0.70000 40500.0n 0.70000 40679.9n 0.70000 40680.0n 0.30000 40859.9n 0.30000 40860.0n 0.30000 41039.9n 0.30000 41040.0n 0.30000 41219.9n 0.30000 41220.0n 0.70000 41399.9n 0.70000 41400.0n 0.70000 41579.9n 0.70000 41580.0n 0.30000 41759.9n 0.30000 41760.0n 0.30000 41939.9n 0.30000 41940.0n 0.30000 42119.9n 0.30000 42120.0n 0.70000 42299.9n 0.70000 42300.0n 0.30000 42479.9n 0.30000 42480.0n 0.70000 42659.9n 0.70000 42660.0n 0.70000 42839.9n 0.70000 42840.0n 0.70000 43019.9n 0.70000 43020.0n 0.70000 43199.9n 0.70000 43200.0n 0.30000 43379.9n 0.30000 43380.0n 0.70000 43559.9n 0.70000 43560.0n 0.70000 43739.9n 0.70000 43740.0n 0.30000 43919.9n 0.30000 43920.0n 0.70000 44099.9n 0.70000 44100.0n 0.30000 44279.9n 0.30000 44280.0n 0.30000 44459.9n 0.30000 44460.0n 0.30000 44639.9n 0.30000 44640.0n 0.70000 44819.9n 0.70000 44820.0n 0.30000 44999.9n 0.30000 45000.0n 0.70000 45179.9n 0.70000 45180.0n 0.70000 45359.9n 0.70000 45360.0n 0.30000 45539.9n 0.30000 45540.0n 0.70000 45719.9n 0.70000 45720.0n 0.30000 45899.9n 0.30000 45900.0n 0.30000 46079.9n 0.30000 46080.0n 0.70000 46259.9n 0.70000 46260.0n 0.70000 46439.9n 0.70000 46440.0n 0.70000 46619.9n 0.70000 46620.0n 0.30000 46799.9n 0.30000 46800.0n 0.70000 46979.9n 0.70000 46980.0n 0.30000 47159.9n 0.30000 47160.0n 0.30000 47339.9n 0.30000 47340.0n 0.70000 47519.9n 0.70000 47520.0n 0.70000 47699.9n 0.70000 47700.0n 0.70000 47879.9n 0.70000 47880.0n 0.70000 48059.9n 0.70000 48060.0n 0.30000 48239.9n 0.30000 48240.0n 0.30000 48419.9n 0.30000 48420.0n 0.30000 48599.9n 0.30000 48600.0n 0.30000 48779.9n 0.30000 48780.0n 0.70000 48959.9n 0.70000 48960.0n 0.30000 49139.9n 0.30000 49140.0n 0.30000 49319.9n 0.30000 49320.0n 0.30000 49499.9n 0.30000 49500.0n 0.30000 49679.9n 0.30000 49680.0n 0.70000 49859.9n 0.70000 49860.0n 0.70000 50039.9n 0.70000 50040.0n 0.70000 50219.9n 0.70000 50220.0n 0.70000 50399.9n 0.70000 50400.0n 0.70000 50579.9n 0.70000 50580.0n 0.30000 50759.9n 0.30000 50760.0n 0.30000 50939.9n 0.30000 50940.0n 0.30000 51119.9n 0.30000 51120.0n 0.30000 51299.9n 0.30000 51300.0n 0.70000 51479.9n 0.70000 51480.0n 0.30000 51659.9n 0.30000 51660.0n 0.70000 51839.9n 0.70000 51840.0n 0.30000 52019.9n 0.30000 52020.0n 0.30000 52199.9n 0.30000 52200.0n 0.70000 52379.9n 0.70000 52380.0n 0.70000 52559.9n 0.70000 52560.0n 0.30000 52739.9n 0.30000 52740.0n 0.70000 52919.9n 0.70000 52920.0n 0.70000 53099.9n 0.70000 53100.0n 0.30000 53279.9n 0.30000 53280.0n 0.30000 53459.9n 0.30000 53460.0n 0.30000 53639.9n 0.30000 53640.0n 0.30000 53819.9n 0.30000 53820.0n 0.30000 53999.9n 0.30000 54000.0n 0.30000 54179.9n 0.30000 54180.0n 0.70000 54359.9n 0.70000 54360.0n 0.30000 54539.9n 0.30000 54540.0n 0.70000 54719.9n 0.70000 54720.0n 0.70000 54899.9n 0.70000 54900.0n 0.70000 55079.9n 0.70000 55080.0n 0.70000 55259.9n 0.70000 55260.0n 0.70000 55439.9n 0.70000 55440.0n 0.70000 55619.9n 0.70000 55620.0n 0.70000 55799.9n 0.70000 55800.0n 0.30000 55979.9n 0.30000 55980.0n 0.30000 56159.9n 0.30000 56160.0n 0.30000 56339.9n 0.30000 56340.0n 0.30000 56519.9n 0.30000 56520.0n 0.70000 56699.9n 0.70000 56700.0n 0.70000 56879.9n 0.70000 56880.0n 0.70000 57059.9n 0.70000 57060.0n 0.30000 57239.9n 0.30000 57240.0n 0.30000 57419.9n 0.30000 57420.0n 0.70000 57599.9n 0.70000 57600.0n 0.70000 57779.9n 0.70000 57780.0n 0.70000 57959.9n 0.70000 57960.0n 0.30000 58139.9n 0.30000 58140.0n 0.70000 58319.9n 0.70000 58320.0n 0.70000 58499.9n 0.70000 58500.0n 0.30000 58679.9n 0.30000 58680.0n 0.70000 58859.9n 0.70000 58860.0n 0.30000 59039.9n 0.30000 59040.0n 0.70000 59219.9n 0.70000 59220.0n 0.30000 59399.9n 0.30000 59400.0n 0.30000 59579.9n 0.30000 59580.0n 0.30000 59759.9n 0.30000 59760.0n 0.30000 59939.9n 0.30000 59940.0n 0.70000 60119.9n 0.70000 60120.0n 0.30000 60299.9n 0.30000 60300.0n 0.30000 60479.9n 0.30000 60480.0n 0.70000 60659.9n 0.70000 60660.0n 0.70000 60839.9n 0.70000 60840.0n 0.70000 61019.9n 0.70000 61020.0n 0.70000 61199.9n 0.70000 61200.0n 0.30000 61379.9n 0.30000 61380.0n 0.30000 61559.9n 0.30000 61560.0n 0.30000 61739.9n 0.30000 61740.0n 0.70000 61919.9n 0.70000 61920.0n 0.70000 62099.9n 0.70000 62100.0n 0.30000 62279.9n 0.30000 62280.0n 0.70000 62459.9n 0.70000 62460.0n 0.30000 62639.9n 0.30000 62640.0n 0.70000 62819.9n 0.70000 62820.0n 0.30000 62999.9n 0.30000 63000.0n 0.30000 63179.9n 0.30000 63180.0n 0.70000 63359.9n 0.70000 63360.0n 0.30000 63539.9n 0.30000 63540.0n 0.70000 63719.9n 0.70000 63720.0n 0.70000 63899.9n 0.70000 63900.0n 0.70000 64079.9n 0.70000 64080.0n 0.70000 64259.9n 0.70000 64260.0n 0.30000 64439.9n 0.30000 64440.0n 0.30000 64619.9n 0.30000 64620.0n 0.30000 64799.9n 0.30000 64800.0n 0.30000 64979.9n 0.30000 64980.0n 0.30000 65159.9n 0.30000 65160.0n 0.70000 65339.9n 0.70000 65340.0n 0.70000 65519.9n 0.70000 65520.0n 0.70000 65699.9n 0.70000 65700.0n 0.70000 65879.9n 0.70000 65880.0n 0.30000 66059.9n 0.30000 66060.0n 0.30000 66239.9n 0.30000 66240.0n 0.30000 66419.9n 0.30000 66420.0n 0.70000 66599.9n 0.70000 66600.0n 0.70000 66779.9n 0.70000 66780.0n 0.30000 66959.9n 0.30000 66960.0n 0.30000 67139.9n 0.30000 67140.0n 0.70000 67319.9n 0.70000 67320.0n 0.70000 67499.9n 0.70000 67500.0n 0.30000 67679.9n 0.30000 67680.0n 0.30000 67859.9n 0.30000 67860.0n 0.70000 68039.9n 0.70000 68040.0n 0.70000 68219.9n 0.70000 68220.0n 0.30000 68399.9n 0.30000 68400.0n 0.30000 68579.9n 0.30000 68580.0n 0.70000 68759.9n 0.70000 68760.0n 0.70000 68939.9n 0.70000 68940.0n 0.30000 69119.9n 0.30000 69120.0n 0.30000 69299.9n 0.30000 69300.0n 0.70000 69479.9n 0.70000 69480.0n 0.70000 69659.9n 0.70000 69660.0n 0.70000 69839.9n 0.70000 69840.0n 0.70000 70019.9n 0.70000 70020.0n 0.70000 70199.9n 0.70000 70200.0n 0.70000 70379.9n 0.70000 70380.0n 0.70000 70559.9n 0.70000 70560.0n 0.30000 70739.9n 0.30000 70740.0n 0.30000 70919.9n 0.30000 70920.0n 0.70000 71099.9n 0.70000 71100.0n 0.70000 71279.9n 0.70000 71280.0n 0.70000 71459.9n 0.70000 71460.0n 0.30000 71639.9n 0.30000 71640.0n 0.30000 71819.9n 0.30000 71820.0n 0.70000 71999.9n 0.70000 72000.0n 0.30000 72179.9n 0.30000 72180.0n 0.30000 72359.9n 0.30000 72360.0n 0.30000 72539.9n 0.30000 72540.0n 0.70000 72719.9n 0.70000 72720.0n 0.30000 72899.9n 0.30000 72900.0n 0.30000 73079.9n 0.30000 73080.0n 0.30000 73259.9n 0.30000 73260.0n 0.70000 73439.9n 0.70000 73440.0n 0.30000 73619.9n 0.30000 73620.0n 0.30000 73799.9n 0.30000 73800.0n 0.70000 73979.9n 0.70000 73980.0n 0.70000 74159.9n 0.70000 74160.0n 0.30000 74339.9n 0.30000 74340.0n 0.30000 74519.9n 0.30000 74520.0n 0.30000 74699.9n 0.30000 74700.0n 0.70000 74879.9n 0.70000 74880.0n 0.30000 75059.9n 0.30000 75060.0n 0.30000 75239.9n 0.30000 75240.0n 0.30000 75419.9n 0.30000 75420.0n 0.70000 75599.9n 0.70000 75600.0n 0.70000 75779.9n 0.70000 75780.0n 0.70000 75959.9n 0.70000 75960.0n 0.30000 76139.9n 0.30000 76140.0n 0.30000 76319.9n 0.30000 76320.0n 0.70000 76499.9n 0.70000 76500.0n 0.70000 76679.9n 0.70000 76680.0n 0.70000 76859.9n 0.70000 76860.0n 0.70000 77039.9n 0.70000 77040.0n 0.70000 77219.9n 0.70000 77220.0n 0.30000 77399.9n 0.30000 77400.0n 0.30000 77579.9n 0.30000 77580.0n 0.30000 77759.9n 0.30000 77760.0n 0.70000 77939.9n 0.70000 77940.0n 0.70000 78119.9n 0.70000 78120.0n 0.30000 78299.9n 0.30000 78300.0n 0.30000 78479.9n 0.30000 78480.0n 0.70000 78659.9n 0.70000 78660.0n 0.30000 78839.9n 0.30000 78840.0n 0.30000 79019.9n 0.30000 79020.0n 0.70000 79199.9n 0.70000 79200.0n 0.70000 79379.9n 0.70000 79380.0n 0.70000 79559.9n 0.70000 79560.0n 0.70000 79739.9n 0.70000 79740.0n 0.30000 79919.9n 0.30000 79920.0n 0.30000 80099.9n 0.30000 80100.0n 0.30000 80279.9n 0.30000 80280.0n 0.70000 80459.9n 0.70000 80460.0n 0.30000 80639.9n 0.30000 80640.0n 0.30000 80819.9n 0.30000 80820.0n 0.30000 80999.9n 0.30000 81000.0n 0.30000 81179.9n 0.30000 81180.0n 0.70000 81359.9n 0.70000 81360.0n 0.30000 81539.9n 0.30000 81540.0n 0.30000 81719.9n 0.30000 81720.0n 0.30000 81899.9n 0.30000 81900.0n 0.30000 82079.9n 0.30000 82080.0n 0.70000 82259.9n 0.70000 82260.0n 0.30000 82439.9n 0.30000 82440.0n 0.70000 82619.9n 0.70000 82620.0n 0.70000 82799.9n 0.70000 82800.0n 0.70000 82979.9n 0.70000 82980.0n 0.70000 83159.9n 0.70000 83160.0n 0.30000 83339.9n 0.30000 83340.0n 0.70000 83519.9n 0.70000 83520.0n 0.70000 83699.9n 0.70000 83700.0n 0.30000 83879.9n 0.30000 83880.0n 0.30000 84059.9n 0.30000 84060.0n 0.70000 84239.9n 0.70000 84240.0n 0.70000 84419.9n 0.70000 84420.0n 0.70000 84599.9n 0.70000 84600.0n 0.70000 84779.9n 0.70000 84780.0n 0.30000 84959.9n 0.30000 84960.0n 0.70000 85139.9n 0.70000 85140.0n 0.70000 85319.9n 0.70000 85320.0n 0.30000 85499.9n 0.30000 85500.0n 0.30000 85679.9n 0.30000 85680.0n 0.30000 85859.9n 0.30000 85860.0n 0.70000 86039.9n 0.70000 86040.0n 0.30000 86219.9n 0.30000 86220.0n 0.70000 86399.9n 0.70000 86400.0n 0.30000 86579.9n 0.30000 86580.0n 0.70000 86759.9n 0.70000 86760.0n 0.70000 86939.9n 0.70000 86940.0n 0.70000 87119.9n 0.70000 87120.0n 0.30000 87299.9n 0.30000 87300.0n 0.30000 87479.9n 0.30000 87480.0n 0.30000 87659.9n 0.30000 87660.0n 0.70000 87839.9n 0.70000 87840.0n 0.70000 88019.9n 0.70000 88020.0n 0.30000 88199.9n 0.30000 88200.0n 0.30000 88379.9n 0.30000 88380.0n 0.70000 88559.9n 0.70000 88560.0n 0.30000 88739.9n 0.30000 88740.0n 0.70000 88919.9n 0.70000 88920.0n 0.70000 89099.9n 0.70000 89100.0n 0.70000 89279.9n 0.70000 89280.0n 0.70000 89459.9n 0.70000 89460.0n 0.70000 89639.9n 0.70000 89640.0n 0.70000 89819.9n 0.70000 89820.0n 0.30000 89999.9n 0.30000 90000.0n 0.30000 90179.9n 0.30000 90180.0n 0.30000 90359.9n 0.30000 90360.0n 0.70000 90539.9n 0.70000 90540.0n 0.70000 90719.9n 0.70000 90720.0n 0.70000 90899.9n 0.70000 90900.0n 0.30000 91079.9n 0.30000 91080.0n 0.30000 91259.9n 0.30000 91260.0n 0.30000 91439.9n 0.30000 91440.0n 0.70000 91619.9n 0.70000 91620.0n 0.30000 91799.9n 0.30000 91800.0n 0.30000 91979.9n 0.30000 91980.0n 0.30000 92159.9n 0.30000 92160.0n 0.30000 92339.9n 0.30000 92340.0n 0.30000 92519.9n 0.30000 92520.0n 0.30000 92699.9n 0.30000 92700.0n 0.30000 92879.9n 0.30000 92880.0n 0.30000 93059.9n 0.30000 93060.0n 0.30000 93239.9n 0.30000 93240.0n 0.30000 93419.9n 0.30000 93420.0n 0.30000 93599.9n 0.30000 93600.0n 0.30000 93779.9n 0.30000 93780.0n 0.70000 93959.9n 0.70000 93960.0n 0.70000 94139.9n 0.70000 94140.0n 0.30000 94319.9n 0.30000 94320.0n 0.70000 94499.9n 0.70000 94500.0n 0.70000 94679.9n 0.70000 94680.0n 0.30000 94859.9n 0.30000 94860.0n 0.30000 95039.9n 0.30000 95040.0n 0.70000 95219.9n 0.70000 95220.0n 0.70000 95399.9n 0.70000 95400.0n 0.70000 95579.9n 0.70000 95580.0n 0.30000 95759.9n 0.30000 95760.0n 0.30000 95939.9n 0.30000 95940.0n 0.70000 96119.9n 0.70000 96120.0n 0.70000 96299.9n 0.70000 96300.0n 0.70000 96479.9n 0.70000 96480.0n 0.30000 96659.9n 0.30000 96660.0n 0.70000 96839.9n 0.70000 96840.0n 0.70000 97019.9n 0.70000 97020.0n 0.70000 97199.9n 0.70000 97200.0n 0.30000 97379.9n 0.30000 97380.0n 0.70000 97559.9n 0.70000 97560.0n 0.70000 97739.9n 0.70000 97740.0n 0.70000 97919.9n 0.70000 97920.0n 0.30000 98099.9n 0.30000 98100.0n 0.30000 98279.9n 0.30000 98280.0n 0.30000 98459.9n 0.30000 98460.0n 0.30000 98639.9n 0.30000 98640.0n 0.70000 98819.9n 0.70000 98820.0n 0.70000 98999.9n 0.70000 99000.0n 0.70000 99179.9n 0.70000 99180.0n 0.70000 99359.9n 0.70000 99360.0n 0.30000 99539.9n 0.30000 99540.0n 0.30000 99719.9n 0.30000 99720.0n 0.70000 99899.9n 0.70000 99900.0n 0.30000 100079.9n 0.30000 100080.0n 0.70000 100259.9n 0.70000 100260.0n 0.30000 100439.9n 0.30000 100440.0n 0.70000 100619.9n 0.70000 100620.0n 0.30000 100799.9n 0.30000 100800.0n 0.30000 100979.9n 0.30000 100980.0n 0.70000 101159.9n 0.70000 101160.0n 0.70000 101339.9n 0.70000 101340.0n 0.30000 101519.9n 0.30000 101520.0n 0.70000 101699.9n 0.70000 101700.0n 0.70000 101879.9n 0.70000 101880.0n 0.70000 102059.9n 0.70000 102060.0n 0.30000 102239.9n 0.30000 102240.0n 0.30000 102419.9n 0.30000 102420.0n 0.30000 102599.9n 0.30000 102600.0n 0.70000 102779.9n 0.70000 102780.0n 0.30000 102959.9n 0.30000 102960.0n 0.70000 103139.9n 0.70000 103140.0n 0.70000 103319.9n 0.70000 103320.0n 0.70000 103499.9n 0.70000 103500.0n 0.30000 103679.9n 0.30000 103680.0n 0.30000 103859.9n 0.30000 103860.0n 0.30000 104039.9n 0.30000 104040.0n 0.70000 104219.9n 0.70000 104220.0n 0.30000 104399.9n 0.30000 104400.0n 0.30000 104579.9n 0.30000 104580.0n 0.30000 104759.9n 0.30000 104760.0n 0.70000 104939.9n 0.70000 104940.0n 0.30000 105119.9n 0.30000 105120.0n 0.30000 105299.9n 0.30000 105300.0n 0.70000 105479.9n 0.70000 105480.0n 0.70000 105659.9n 0.70000 105660.0n 0.30000 105839.9n 0.30000 105840.0n 0.70000 106019.9n 0.70000 106020.0n 0.70000 106199.9n 0.70000 106200.0n 0.70000 106379.9n 0.70000 106380.0n 0.70000 106559.9n 0.70000 106560.0n 0.70000 106739.9n 0.70000 106740.0n 0.70000 106919.9n 0.70000 106920.0n 0.30000 107099.9n 0.30000 107100.0n 0.30000 107279.9n 0.30000 107280.0n 0.70000 107459.9n 0.70000 107460.0n 0.30000 107639.9n 0.30000 107640.0n 0.70000 107819.9n 0.70000 107820.0n 0.70000 107999.9n 0.70000 108000.0n 0.30000 108179.9n 0.30000 108180.0n 0.30000 108359.9n 0.30000 108360.0n 0.30000 108539.9n 0.30000 108540.0n 0.70000 108719.9n 0.70000 108720.0n 0.30000 108899.9n 0.30000 108900.0n 0.70000 109079.9n 0.70000 109080.0n 0.70000 109259.9n 0.70000 109260.0n 0.30000 109439.9n 0.30000 109440.0n 0.30000 109619.9n 0.30000 109620.0n 0.30000 109799.9n 0.30000 109800.0n 0.70000 109979.9n 0.70000 109980.0n 0.70000 110159.9n 0.70000 110160.0n 0.30000 110339.9n 0.30000 110340.0n 0.70000 110519.9n 0.70000 110520.0n 0.30000 110699.9n 0.30000 110700.0n 0.30000 110879.9n 0.30000 110880.0n 0.70000 111059.9n 0.70000 111060.0n 0.70000 111239.9n 0.70000 111240.0n 0.30000 111419.9n 0.30000 111420.0n 0.30000 111599.9n 0.30000 111600.0n 0.70000 111779.9n 0.70000 111780.0n 0.30000 111959.9n 0.30000 111960.0n 0.70000 112139.9n 0.70000 112140.0n 0.30000 112319.9n 0.30000 112320.0n 0.30000 112499.9n 0.30000 112500.0n 0.70000 112679.9n 0.70000 112680.0n 0.30000 112859.9n 0.30000 112860.0n 0.30000 113039.9n 0.30000 113040.0n 0.70000 113219.9n 0.70000 113220.0n 0.70000 113399.9n 0.70000 113400.0n 0.70000 113579.9n 0.70000 113580.0n 0.70000 113759.9n 0.70000 113760.0n 0.70000 113939.9n 0.70000 113940.0n 0.70000 114119.9n 0.70000 114120.0n 0.30000 114299.9n 0.30000 114300.0n 0.30000 114479.9n 0.30000 114480.0n 0.70000 114659.9n 0.70000 114660.0n 0.70000 114839.9n 0.70000 114840.0n 0.30000 115019.9n 0.30000 115020.0n 0.30000 115199.9n 0.30000 115200.0n 0.30000 115379.9n 0.30000 115380.0n 0.30000 115559.9n 0.30000 115560.0n 0.70000 115739.9n 0.70000 115740.0n 0.30000 115919.9n 0.30000 115920.0n 0.30000 116099.9n 0.30000 116100.0n 0.70000 116279.9n 0.70000 116280.0n 0.70000 116459.9n 0.70000 116460.0n 0.70000 116639.9n 0.70000 116640.0n 0.30000 116819.9n 0.30000 116820.0n 0.70000 116999.9n 0.70000 117000.0n 0.70000 117179.9n 0.70000 117180.0n 0.30000 117359.9n 0.30000 117360.0n 0.70000 117539.9n 0.70000 117540.0n 0.30000 117719.9n 0.30000 117720.0n 0.30000 117899.9n 0.30000 117900.0n 0.30000 118079.9n 0.30000 118080.0n 0.70000 118259.9n 0.70000 118260.0n 0.70000 118439.9n 0.70000 118440.0n 0.30000 118619.9n 0.30000 118620.0n 0.70000 118799.9n 0.70000 118800.0n 0.70000 118979.9n 0.70000 118980.0n 0.70000 119159.9n 0.70000 119160.0n 0.30000 119339.9n 0.30000 119340.0n 0.30000 119519.9n 0.30000 119520.0n 0.30000 119699.9n 0.30000 119700.0n 0.30000 119879.9n 0.30000 119880.0n 0.70000 120059.9n 0.70000 120060.0n 0.70000 120239.9n 0.70000 120240.0n 0.30000 120419.9n 0.30000 120420.0n 0.70000 120599.9n 0.70000 120600.0n 0.30000 120779.9n 0.30000 120780.0n 0.70000 120959.9n 0.70000 120960.0n 0.30000 121139.9n 0.30000 121140.0n 0.30000 121319.9n 0.30000 121320.0n 0.30000 121499.9n 0.30000 121500.0n 0.30000 121679.9n 0.30000 121680.0n 0.30000 121859.9n 0.30000 121860.0n 0.70000 122039.9n 0.70000 122040.0n 0.30000 122219.9n 0.30000 122220.0n 0.30000 122399.9n 0.30000 122400.0n 0.70000 122579.9n 0.70000 122580.0n 0.70000 122759.9n 0.70000 122760.0n 0.70000 122939.9n 0.70000 122940.0n 0.70000 123119.9n 0.70000 123120.0n 0.30000 123299.9n 0.30000 123300.0n 0.70000 123479.9n 0.70000 123480.0n 0.70000 123659.9n 0.70000 123660.0n 0.70000 123839.9n 0.70000 123840.0n 0.30000 124019.9n 0.30000 124020.0n 0.70000 124199.9n 0.70000 124200.0n 0.70000 124379.9n 0.70000 124380.0n 0.70000 124559.9n 0.70000 124560.0n 0.70000 124739.9n 0.70000 124740.0n 0.30000 124919.9n 0.30000 124920.0n 0.30000 125099.9n 0.30000 125100.0n 0.30000 125279.9n 0.30000 125280.0n 0.70000 125459.9n 0.70000 125460.0n 0.70000 125639.9n 0.70000 125640.0n 0.30000 125819.9n 0.30000 125820.0n 0.70000 125999.9n 0.70000 126000.0n 0.30000 126179.9n 0.30000 126180.0n 0.30000 126359.9n 0.30000 126360.0n 0.70000 126539.9n 0.70000 126540.0n 0.30000 126719.9n 0.30000 126720.0n 0.30000 126899.9n 0.30000 126900.0n 0.30000 127079.9n 0.30000 127080.0n 0.70000 127259.9n 0.70000 127260.0n 0.70000 127439.9n 0.70000 127440.0n 0.30000 127619.9n 0.30000 127620.0n 0.30000 127799.9n 0.30000 127800.0n 0.30000 127979.9n 0.30000 127980.0n 0.30000 128159.9n 0.30000 128160.0n 0.30000 128339.9n 0.30000 128340.0n 0.30000 128519.9n 0.30000 128520.0n 0.70000 128699.9n 0.70000 128700.0n 0.70000 128879.9n 0.70000 128880.0n 0.30000 129059.9n 0.30000 129060.0n 0.30000 129239.9n 0.30000 129240.0n 0.70000 129419.9n 0.70000 129420.0n 0.70000 129599.9n 0.70000 129600.0n 0.70000 129779.9n 0.70000 129780.0n 0.70000 129959.9n 0.70000 129960.0n 0.30000 130139.9n 0.30000 130140.0n 0.70000 130319.9n 0.70000 130320.0n 0.30000 130499.9n 0.30000 130500.0n 0.70000 130679.9n 0.70000 130680.0n 0.30000 130859.9n 0.30000 130860.0n 0.70000 131039.9n 0.70000 131040.0n 0.70000 131219.9n 0.70000 131220.0n 0.70000 131399.9n 0.70000 131400.0n 0.70000 131579.9n 0.70000 131580.0n 0.70000 131759.9n 0.70000 131760.0n 0.30000 131939.9n 0.30000 131940.0n 0.70000 132119.9n 0.70000 132120.0n 0.30000 132299.9n 0.30000 132300.0n 0.30000 132479.9n 0.30000 132480.0n 0.70000 132659.9n 0.70000 132660.0n 0.70000 132839.9n 0.70000 132840.0n 0.70000 133019.9n 0.70000 133020.0n 0.70000 133199.9n 0.70000 133200.0n 0.70000 133379.9n 0.70000 133380.0n 0.30000 133559.9n 0.30000 133560.0n 0.30000 133739.9n 0.30000 133740.0n 0.70000 133919.9n 0.70000 133920.0n 0.70000 134099.9n 0.70000 134100.0n 0.30000 134279.9n 0.30000 134280.0n 0.30000 134459.9n 0.30000 134460.0n 0.30000 134639.9n 0.30000 134640.0n 0.70000 134819.9n 0.70000 134820.0n 0.70000 134999.9n 0.70000 135000.0n 0.30000 135179.9n 0.30000 135180.0n 0.70000 135359.9n 0.70000 135360.0n 0.30000 135539.9n 0.30000 135540.0n 0.70000 135719.9n 0.70000 135720.0n 0.70000 135899.9n 0.70000 135900.0n 0.30000 136079.9n 0.30000 136080.0n 0.30000 136259.9n 0.30000 136260.0n 0.70000 136439.9n 0.70000 136440.0n 0.70000 136619.9n 0.70000 136620.0n 0.70000 136799.9n 0.70000 136800.0n 0.30000 136979.9n 0.30000 136980.0n 0.30000 137159.9n 0.30000 137160.0n 0.30000 137339.9n 0.30000 137340.0n 0.30000 137519.9n 0.30000 137520.0n 0.70000 137699.9n 0.70000 137700.0n 0.30000 137879.9n 0.30000 137880.0n 0.30000 138059.9n 0.30000 138060.0n 0.30000 138239.9n 0.30000 138240.0n 0.30000 138419.9n 0.30000 138420.0n 0.70000 138599.9n 0.70000 138600.0n 0.70000 138779.9n 0.70000 138780.0n 0.30000 138959.9n 0.30000 138960.0n 0.30000 139139.9n 0.30000 139140.0n 0.70000 139319.9n 0.70000 139320.0n 0.70000 139499.9n 0.70000 139500.0n 0.70000 139679.9n 0.70000 139680.0n 0.70000 139859.9n 0.70000 139860.0n 0.70000 140039.9n 0.70000 140040.0n 0.70000 140219.9n 0.70000 140220.0n 0.30000 140399.9n 0.30000 140400.0n 0.30000 140579.9n 0.30000 140580.0n 0.30000 140759.9n 0.30000 140760.0n 0.70000 140939.9n 0.70000 140940.0n 0.30000 141119.9n 0.30000 141120.0n 0.70000 141299.9n 0.70000 141300.0n 0.70000 141479.9n 0.70000 141480.0n 0.30000 141659.9n 0.30000 141660.0n 0.70000 141839.9n 0.70000 141840.0n 0.70000 142019.9n 0.70000 142020.0n 0.70000 142199.9n 0.70000 142200.0n 0.30000 142379.9n 0.30000 142380.0n 0.70000 142559.9n 0.70000 142560.0n 0.30000 142739.9n 0.30000 142740.0n 0.30000 142919.9n 0.30000 142920.0n 0.30000 143099.9n 0.30000 143100.0n 0.30000 143279.9n 0.30000 143280.0n 0.30000 143459.9n 0.30000 143460.0n 0.70000 143639.9n 0.70000 143640.0n 0.30000 143819.9n 0.30000 143820.0n 0.30000 143999.9n 0.30000 144000.0n 0.30000 144179.9n 0.30000 144180.0n 0.30000 144359.9n 0.30000 144360.0n 0.70000 144539.9n 0.70000 144540.0n 0.70000 144719.9n 0.70000 144720.0n 0.30000 144899.9n 0.30000 144900.0n 0.30000 145079.9n 0.30000 145080.0n 0.70000 145259.9n 0.70000 145260.0n 0.70000 145439.9n 0.70000 145440.0n 0.70000 145619.9n 0.70000 145620.0n 0.70000 145799.9n 0.70000 145800.0n 0.70000 145979.9n 0.70000 145980.0n 0.30000 146159.9n 0.30000 146160.0n 0.70000 146339.9n 0.70000 146340.0n 0.30000 146519.9n 0.30000 146520.0n 0.30000 146699.9n 0.30000 146700.0n 0.70000 146879.9n 0.70000 146880.0n 0.70000 147059.9n 0.70000 147060.0n 0.70000 147239.9n 0.70000 147240.0n 0.30000 147419.9n 0.30000 147420.0n 0.70000 147599.9n 0.70000 147600.0n 0.70000 147779.9n 0.70000 147780.0n 0.30000 147959.9n 0.30000 147960.0n 0.30000 148139.9n 0.30000 148140.0n 0.30000 148319.9n 0.30000 148320.0n 0.30000 148499.9n 0.30000 148500.0n 0.70000 148679.9n 0.70000 148680.0n 0.30000 148859.9n 0.30000 148860.0n 0.70000 149039.9n 0.70000 149040.0n 0.30000 149219.9n 0.30000 149220.0n 0.30000 149399.9n 0.30000 149400.0n 0.30000 149579.9n 0.30000 149580.0n 0.70000 149759.9n 0.70000 149760.0n 0.30000 149939.9n 0.30000 149940.0n 0.70000 150119.9n 0.70000 150120.0n 0.30000 150299.9n 0.30000 150300.0n 0.70000 150479.9n 0.70000 150480.0n 0.30000 150659.9n 0.30000 150660.0n 0.70000 150839.9n 0.70000 150840.0n 0.70000 151019.9n 0.70000 151020.0n 0.70000 151199.9n 0.70000 151200.0n 0.70000 151379.9n 0.70000 151380.0n 0.70000 151559.9n 0.70000 151560.0n 0.30000 151739.9n 0.30000 151740.0n 0.30000 151919.9n 0.30000 151920.0n 0.30000 152099.9n 0.30000 152100.0n 0.30000 152279.9n 0.30000 152280.0n 0.70000 152459.9n 0.70000 152460.0n 0.30000 152639.9n 0.30000 152640.0n 0.70000 152819.9n 0.70000 152820.0n 0.70000 152999.9n 0.70000 153000.0n 0.70000 153179.9n 0.70000 153180.0n 0.70000 153359.9n 0.70000 153360.0n 0.30000 153539.9n 0.30000 153540.0n 0.30000 153719.9n 0.30000 153720.0n 0.70000 153899.9n 0.70000 153900.0n 0.70000 154079.9n 0.70000 154080.0n 0.30000 154259.9n 0.30000 154260.0n 0.30000 154439.9n 0.30000 154440.0n 0.30000 154619.9n 0.30000 154620.0n 0.30000 154799.9n 0.30000 154800.0n 0.30000 154979.9n 0.30000 154980.0n 0.70000 155159.9n 0.70000 155160.0n 0.30000 155339.9n 0.30000 155340.0n 0.70000 155519.9n 0.70000 155520.0n 0.30000 155699.9n 0.30000 155700.0n 0.30000 155879.9n 0.30000 155880.0n 0.70000 156059.9n 0.70000 156060.0n 0.30000 156239.9n 0.30000 156240.0n 0.70000 156419.9n 0.70000 156420.0n 0.30000 156599.9n 0.30000 156600.0n 0.70000 156779.9n 0.70000 156780.0n 0.70000 156959.9n 0.70000 156960.0n 0.30000 157139.9n 0.30000 157140.0n 0.30000 157319.9n 0.30000 157320.0n 0.70000 157499.9n 0.70000 157500.0n 0.30000 157679.9n 0.30000 157680.0n 0.70000 157859.9n 0.70000 157860.0n 0.30000 158039.9n 0.30000 158040.0n 0.70000 158219.9n 0.70000 158220.0n 0.70000 158399.9n 0.70000 158400.0n 0.30000 158579.9n 0.30000 158580.0n 0.70000 158759.9n 0.70000 158760.0n 0.70000 158939.9n 0.70000 158940.0n 0.30000 159119.9n 0.30000 159120.0n 0.70000 159299.9n 0.70000 159300.0n 0.70000 159479.9n 0.70000 159480.0n 0.30000 159659.9n 0.30000 159660.0n 0.70000 159839.9n 0.70000 159840.0n 0.30000 160019.9n 0.30000 160020.0n 0.30000 160199.9n 0.30000 160200.0n 0.70000 160379.9n 0.70000 160380.0n 0.30000 160559.9n 0.30000 160560.0n 0.30000 160739.9n 0.30000 160740.0n 0.70000 160919.9n 0.70000 160920.0n 0.30000 161099.9n 0.30000 161100.0n 0.70000 161279.9n 0.70000 161280.0n 0.70000 161459.9n 0.70000 161460.0n 0.70000 161639.9n 0.70000 161640.0n 0.30000 161819.9n 0.30000 161820.0n 0.30000 161999.9n 0.30000 162000.0n 0.30000 162179.9n 0.30000 162180.0n 0.70000 162359.9n 0.70000 162360.0n 0.30000 162539.9n 0.30000 162540.0n 0.30000 162719.9n 0.30000 162720.0n 0.70000 162899.9n 0.70000 162900.0n 0.30000 163079.9n 0.30000 163080.0n 0.30000 163259.9n 0.30000 163260.0n 0.70000 163439.9n 0.70000 163440.0n 0.70000 163619.9n 0.70000 163620.0n 0.30000 163799.9n 0.30000 163800.0n 0.70000 163979.9n 0.70000 163980.0n 0.30000 164159.9n 0.30000 164160.0n 0.30000 164339.9n 0.30000 164340.0n 0.30000 164519.9n 0.30000 164520.0n 0.30000 164699.9n 0.30000 164700.0n 0.70000 164879.9n 0.70000 164880.0n 0.70000 165059.9n 0.70000 165060.0n 0.70000 165239.9n 0.70000 165240.0n 0.30000 165419.9n 0.30000 165420.0n 0.70000 165599.9n 0.70000 165600.0n 0.30000 165779.9n 0.30000 165780.0n 0.70000 165959.9n 0.70000 165960.0n 0.70000 166139.9n 0.70000 166140.0n 0.30000 166319.9n 0.30000 166320.0n 0.30000 166499.9n 0.30000 166500.0n 0.70000 166679.9n 0.70000 166680.0n 0.70000 166859.9n 0.70000 166860.0n 0.70000 167039.9n 0.70000 167040.0n 0.30000 167219.9n 0.30000 167220.0n 0.70000 167399.9n 0.70000 167400.0n 0.30000 167579.9n 0.30000 167580.0n 0.30000 167759.9n 0.30000 167760.0n 0.30000 167939.9n 0.30000 167940.0n 0.30000 168119.9n 0.30000 168120.0n 0.70000 168299.9n 0.70000 168300.0n 0.70000 168479.9n 0.70000 168480.0n 0.30000 168659.9n 0.30000 168660.0n 0.70000 168839.9n 0.70000 168840.0n 0.30000 169019.9n 0.30000 169020.0n 0.70000 169199.9n 0.70000 169200.0n 0.70000 169379.9n 0.70000 169380.0n 0.30000 169559.9n 0.30000 169560.0n 0.30000 169739.9n 0.30000 169740.0n 0.30000 169919.9n 0.30000 169920.0n 0.70000 170099.9n 0.70000 170100.0n 0.30000 170279.9n 0.30000 170280.0n 0.70000 170459.9n 0.70000 170460.0n 0.30000 170639.9n 0.30000 170640.0n 0.30000 170819.9n 0.30000 170820.0n 0.70000 170999.9n 0.70000 171000.0n 0.70000 171179.9n 0.70000 171180.0n 0.30000 171359.9n 0.30000 171360.0n 0.70000 171539.9n 0.70000 171540.0n 0.70000 171719.9n 0.70000 171720.0n 0.70000 171899.9n 0.70000 171900.0n 0.70000 172079.9n 0.70000 172080.0n 0.70000 172259.9n 0.70000 172260.0n 0.30000 172439.9n 0.30000 172440.0n 0.30000 172619.9n 0.30000 172620.0n 0.70000 172799.9n 0.70000 172800.0n 0.50000 172979.9n 0.50000 172980.0n 0.50000 173159.9n 0.50000 173160.0n 0.50000 173339.9n 0.50000 173340.0n 0.50000 173519.9n 0.50000 173520.0n 0.50000 173699.9n 0.50000 173700.0n 0.50000 173879.9n 0.50000 173880.0n 0.50000 174059.9n 0.50000 174060.0n 0.50000 174239.9n 0.50000 174240.0n 0.50000 174419.9n 0.50000 174420.0n 0.50000 174599.9n 0.50000 174600.0n 0.50000 174779.9n 0.50000 174780.0n 0.50000 174959.9n 0.50000 174960.0n 0.50000 175139.9n 0.50000 175140.0n 0.50000 175319.9n 0.50000 175320.0n 0.50000 175499.9n 0.50000 175500.0n 0.50000 175679.9n 0.50000 175680.0n 0.50000 175859.9n 0.50000 175860.0n 0.50000 176039.9n 0.50000 176040.0n 0.50000 176219.9n 0.50000 176220.0n 0.50000 176399.9n 0.50000 176400.0n 0.50000 176579.9n 0.50000 176580.0n 0.50000 176759.9n 0.50000 176760.0n 0.50000 176939.9n 0.50000 176940.0n 0.50000 177119.9n 0.50000 177120.0n 0.50000 177299.9n 0.50000 177300.0n 0.50000 177479.9n 0.50000 177480.0n 0.50000 177659.9n 0.50000 177660.0n 0.50000 177839.9n 0.50000 177840.0n 0.50000 178019.9n 0.50000 178020.0n 0.50000 178199.9n 0.50000 178200.0n 0.50000 178379.9n 0.50000 178380.0n 0.50000 178559.9n 0.50000 178560.0n 0.50000 178739.9n 0.50000 178740.0n 0.50000 178919.9n 0.50000 178920.0n 0.50000 179099.9n 0.50000 179100.0n 0.50000 179279.9n 0.50000 179280.0n 0.50000 179459.9n 0.50000 179460.0n 0.50000 179639.9n 0.50000 179640.0n 0.50000 179819.9n 0.50000 179820.0n 0.50000 179999.9n 0.50000 180000.0n 0.50000 180179.9n 0.50000 180180.0n 0.50000 180359.9n 0.50000 180360.0n 0.50000 180539.9n 0.50000 180540.0n 0.50000 180719.9n 0.50000 180720.0n 0.50000 180899.9n 0.50000 180900.0n 0.50000 181079.9n 0.50000 181080.0n 0.50000 181259.9n 0.50000 181260.0n 0.50000 181439.9n 0.50000 181440.0n 0.50000 181619.9n 0.50000 181620.0n 0.50000 181799.9n 0.50000 181800.0n 0.50000 181979.9n 0.50000 181980.0n 0.50000 182159.9n 0.50000 182160.0n 0.50000 182339.9n 0.50000 182340.0n 0.50000 182519.9n 0.50000 182520.0n 0.50000 182699.9n 0.50000 182700.0n 0.50000 182879.9n 0.50000 182880.0n 0.50000 183059.9n 0.50000 183060.0n 0.50000 183239.9n 0.50000 183240.0n 0.50000 183419.9n 0.50000 183420.0n 0.50000)
Vwih_p_0_0 wih_p_0_0 0 0.9
Vwih_n_0_0 wih_n_0_0 0 0.3
Vwih_p_1_0 wih_p_1_0 0 0.3
Vwih_n_1_0 wih_n_1_0 0 0.8077526372768347
Vwih_p_2_0 wih_p_2_0 0 0.9
Vwih_n_2_0 wih_n_2_0 0 0.3
Xcm_xh0 xhp0 xhn0 vdd cmld
Rnd_xh0 xhp0 xhn0 20k
Cxh0p xhp0 0 1e-13
Cxh0n xhn0 0 1e-13
Xih_0_0 a_xp0 a_xn0 wih_p_0_0 wih_n_0_0 xhp0 xhn0 vdd vbsyn gsyn
Xih_1_0 a_xp1 a_xn1 wih_p_1_0 wih_n_1_0 xhp0 xhn0 vdd vbsyn gsyn
Xih_2_0 a_xp2 a_xn2 wih_p_2_0 wih_n_2_0 xhp0 xhn0 vdd vbsyn gsyn
Xn0 xhp0 xhn0 ahp0 ahn0 vdd vbneu dneuron
Vwih_p_0_1 wih_p_0_1 0 0.4076074543279496
Vwih_n_0_1 wih_n_0_1 0 0.5923925456720505
Vwih_p_1_1 wih_p_1_1 0 0.6875517955179162
Vwih_n_1_1 wih_n_1_1 0 0.31244820448208377
Vwih_p_2_1 wih_p_2_1 0 0.9
Vwih_n_2_1 wih_n_2_1 0 0.3
Xcm_xh1 xhp1 xhn1 vdd cmld
Rnd_xh1 xhp1 xhn1 20k
Cxh1p xhp1 0 1e-13
Cxh1n xhn1 0 1e-13
Xih_0_1 a_xp0 a_xn0 wih_p_0_1 wih_n_0_1 xhp1 xhn1 vdd vbsyn gsyn
Xih_1_1 a_xp1 a_xn1 wih_p_1_1 wih_n_1_1 xhp1 xhn1 vdd vbsyn gsyn
Xih_2_1 a_xp2 a_xn2 wih_p_2_1 wih_n_2_1 xhp1 xhn1 vdd vbsyn gsyn
Xn1 xhp1 xhn1 ahp1 ahn1 vdd vbneu dneuron
Vwih_p_0_2 wih_p_0_2 0 0.6986905748958001
Vwih_n_0_2 wih_n_0_2 0 0.30130942510419984
Vwih_p_1_2 wih_p_1_2 0 0.8611596583173695
Vwih_n_1_2 wih_n_1_2 0 0.3
Vwih_p_2_2 wih_p_2_2 0 0.3
Vwih_n_2_2 wih_n_2_2 0 0.9
Xcm_xh2 xhp2 xhn2 vdd cmld
Rnd_xh2 xhp2 xhn2 20k
Cxh2p xhp2 0 1e-13
Cxh2n xhn2 0 1e-13
Xih_0_2 a_xp0 a_xn0 wih_p_0_2 wih_n_0_2 xhp2 xhn2 vdd vbsyn gsyn
Xih_1_2 a_xp1 a_xn1 wih_p_1_2 wih_n_1_2 xhp2 xhn2 vdd vbsyn gsyn
Xih_2_2 a_xp2 a_xn2 wih_p_2_2 wih_n_2_2 xhp2 xhn2 vdd vbsyn gsyn
Xn2 xhp2 xhn2 ahp2 ahn2 vdd vbneu dneuron
Vwih_p_0_3 wih_p_0_3 0 0.3
Vwih_n_0_3 wih_n_0_3 0 0.7073156875091838
Vwih_p_1_3 wih_p_1_3 0 0.9
Vwih_n_1_3 wih_n_1_3 0 0.3
Vwih_p_2_3 wih_p_2_3 0 0.3968886139217385
Vwih_n_2_3 wih_n_2_3 0 0.6031113860782614
Xcm_xh3 xhp3 xhn3 vdd cmld
Rnd_xh3 xhp3 xhn3 20k
Cxh3p xhp3 0 1e-13
Cxh3n xhn3 0 1e-13
Xih_0_3 a_xp0 a_xn0 wih_p_0_3 wih_n_0_3 xhp3 xhn3 vdd vbsyn gsyn
Xih_1_3 a_xp1 a_xn1 wih_p_1_3 wih_n_1_3 xhp3 xhn3 vdd vbsyn gsyn
Xih_2_3 a_xp2 a_xn2 wih_p_2_3 wih_n_2_3 xhp3 xhn3 vdd vbsyn gsyn
Xn3 xhp3 xhn3 ahp3 ahn3 vdd vbneu dneuron
Vwih_p_0_4 wih_p_0_4 0 0.643383333655023
Vwih_n_0_4 wih_n_0_4 0 0.356616666344977
Vwih_p_1_4 wih_p_1_4 0 0.426609605197966
Vwih_n_1_4 wih_n_1_4 0 0.573390394802034
Vwih_p_2_4 wih_p_2_4 0 0.3
Vwih_n_2_4 wih_n_2_4 0 0.779710110256914
Xcm_xh4 xhp4 xhn4 vdd cmld
Rnd_xh4 xhp4 xhn4 20k
Cxh4p xhp4 0 1e-13
Cxh4n xhn4 0 1e-13
Xih_0_4 a_xp0 a_xn0 wih_p_0_4 wih_n_0_4 xhp4 xhn4 vdd vbsyn gsyn
Xih_1_4 a_xp1 a_xn1 wih_p_1_4 wih_n_1_4 xhp4 xhn4 vdd vbsyn gsyn
Xih_2_4 a_xp2 a_xn2 wih_p_2_4 wih_n_2_4 xhp4 xhn4 vdd vbsyn gsyn
Xn4 xhp4 xhn4 ahp4 ahn4 vdd vbneu dneuron
Vwih_p_0_5 wih_p_0_5 0 0.3
Vwih_n_0_5 wih_n_0_5 0 0.9
Vwih_p_1_5 wih_p_1_5 0 0.3
Vwih_n_1_5 wih_n_1_5 0 0.9
Vwih_p_2_5 wih_p_2_5 0 0.9
Vwih_n_2_5 wih_n_2_5 0 0.3
Xcm_xh5 xhp5 xhn5 vdd cmld
Rnd_xh5 xhp5 xhn5 20k
Cxh5p xhp5 0 1e-13
Cxh5n xhn5 0 1e-13
Xih_0_5 a_xp0 a_xn0 wih_p_0_5 wih_n_0_5 xhp5 xhn5 vdd vbsyn gsyn
Xih_1_5 a_xp1 a_xn1 wih_p_1_5 wih_n_1_5 xhp5 xhn5 vdd vbsyn gsyn
Xih_2_5 a_xp2 a_xn2 wih_p_2_5 wih_n_2_5 xhp5 xhn5 vdd vbsyn gsyn
Xn5 xhp5 xhn5 ahp5 ahn5 vdd vbneu dneuron
Vwih_p_0_6 wih_p_0_6 0 0.4644227134047597
Vwih_n_0_6 wih_n_0_6 0 0.5355772865952403
Vwih_p_1_6 wih_p_1_6 0 0.3
Vwih_n_1_6 wih_n_1_6 0 0.9
Vwih_p_2_6 wih_p_2_6 0 0.3
Vwih_n_2_6 wih_n_2_6 0 0.9
Xcm_xh6 xhp6 xhn6 vdd cmld
Rnd_xh6 xhp6 xhn6 20k
Cxh6p xhp6 0 1e-13
Cxh6n xhn6 0 1e-13
Xih_0_6 a_xp0 a_xn0 wih_p_0_6 wih_n_0_6 xhp6 xhn6 vdd vbsyn gsyn
Xih_1_6 a_xp1 a_xn1 wih_p_1_6 wih_n_1_6 xhp6 xhn6 vdd vbsyn gsyn
Xih_2_6 a_xp2 a_xn2 wih_p_2_6 wih_n_2_6 xhp6 xhn6 vdd vbsyn gsyn
Xn6 xhp6 xhn6 ahp6 ahn6 vdd vbneu dneuron
Vwih_p_0_7 wih_p_0_7 0 0.8930428788399948
Vwih_n_0_7 wih_n_0_7 0 0.3
Vwih_p_1_7 wih_p_1_7 0 0.3
Vwih_n_1_7 wih_n_1_7 0 0.9
Vwih_p_2_7 wih_p_2_7 0 0.3
Vwih_n_2_7 wih_n_2_7 0 0.7814083238372862
Xcm_xh7 xhp7 xhn7 vdd cmld
Rnd_xh7 xhp7 xhn7 20k
Cxh7p xhp7 0 1e-13
Cxh7n xhn7 0 1e-13
Xih_0_7 a_xp0 a_xn0 wih_p_0_7 wih_n_0_7 xhp7 xhn7 vdd vbsyn gsyn
Xih_1_7 a_xp1 a_xn1 wih_p_1_7 wih_n_1_7 xhp7 xhn7 vdd vbsyn gsyn
Xih_2_7 a_xp2 a_xn2 wih_p_2_7 wih_n_2_7 xhp7 xhn7 vdd vbsyn gsyn
Xn7 xhp7 xhn7 ahp7 ahn7 vdd vbneu dneuron
Vwih_p_0_8 wih_p_0_8 0 0.3
Vwih_n_0_8 wih_n_0_8 0 0.9
Vwih_p_1_8 wih_p_1_8 0 0.3
Vwih_n_1_8 wih_n_1_8 0 0.9
Vwih_p_2_8 wih_p_2_8 0 0.9
Vwih_n_2_8 wih_n_2_8 0 0.3
Xcm_xh8 xhp8 xhn8 vdd cmld
Rnd_xh8 xhp8 xhn8 20k
Cxh8p xhp8 0 1e-13
Cxh8n xhn8 0 1e-13
Xih_0_8 a_xp0 a_xn0 wih_p_0_8 wih_n_0_8 xhp8 xhn8 vdd vbsyn gsyn
Xih_1_8 a_xp1 a_xn1 wih_p_1_8 wih_n_1_8 xhp8 xhn8 vdd vbsyn gsyn
Xih_2_8 a_xp2 a_xn2 wih_p_2_8 wih_n_2_8 xhp8 xhn8 vdd vbsyn gsyn
Xn8 xhp8 xhn8 ahp8 ahn8 vdd vbneu dneuron
Vwih_p_0_9 wih_p_0_9 0 0.43659969851895275
Vwih_n_0_9 wih_n_0_9 0 0.5634003014810472
Vwih_p_1_9 wih_p_1_9 0 0.35532188681769517
Vwih_n_1_9 wih_n_1_9 0 0.6446781131823048
Vwih_p_2_9 wih_p_2_9 0 0.3
Vwih_n_2_9 wih_n_2_9 0 0.770652332104687
Xcm_xh9 xhp9 xhn9 vdd cmld
Rnd_xh9 xhp9 xhn9 20k
Cxh9p xhp9 0 1e-13
Cxh9n xhn9 0 1e-13
Xih_0_9 a_xp0 a_xn0 wih_p_0_9 wih_n_0_9 xhp9 xhn9 vdd vbsyn gsyn
Xih_1_9 a_xp1 a_xn1 wih_p_1_9 wih_n_1_9 xhp9 xhn9 vdd vbsyn gsyn
Xih_2_9 a_xp2 a_xn2 wih_p_2_9 wih_n_2_9 xhp9 xhn9 vdd vbsyn gsyn
Xn9 xhp9 xhn9 ahp9 ahn9 vdd vbneu dneuron
Vwih_p_0_10 wih_p_0_10 0 0.8206037983083873
Vwih_n_0_10 wih_n_0_10 0 0.3
Vwih_p_1_10 wih_p_1_10 0 0.5276620970012434
Vwih_n_1_10 wih_n_1_10 0 0.47233790299875655
Vwih_p_2_10 wih_p_2_10 0 0.6315537008964082
Vwih_n_2_10 wih_n_2_10 0 0.36844629910359183
Xcm_xh10 xhp10 xhn10 vdd cmld
Rnd_xh10 xhp10 xhn10 20k
Cxh10p xhp10 0 1e-13
Cxh10n xhn10 0 1e-13
Xih_0_10 a_xp0 a_xn0 wih_p_0_10 wih_n_0_10 xhp10 xhn10 vdd vbsyn gsyn
Xih_1_10 a_xp1 a_xn1 wih_p_1_10 wih_n_1_10 xhp10 xhn10 vdd vbsyn gsyn
Xih_2_10 a_xp2 a_xn2 wih_p_2_10 wih_n_2_10 xhp10 xhn10 vdd vbsyn gsyn
Xn10 xhp10 xhn10 ahp10 ahn10 vdd vbneu dneuron
Vwih_p_0_11 wih_p_0_11 0 0.5615896328228672
Vwih_n_0_11 wih_n_0_11 0 0.4384103671771328
Vwih_p_1_11 wih_p_1_11 0 0.3392052445189821
Vwih_n_1_11 wih_n_1_11 0 0.6607947554810178
Vwih_p_2_11 wih_p_2_11 0 0.3
Vwih_n_2_11 wih_n_2_11 0 0.7163998120574444
Xcm_xh11 xhp11 xhn11 vdd cmld
Rnd_xh11 xhp11 xhn11 20k
Cxh11p xhp11 0 1e-13
Cxh11n xhn11 0 1e-13
Xih_0_11 a_xp0 a_xn0 wih_p_0_11 wih_n_0_11 xhp11 xhn11 vdd vbsyn gsyn
Xih_1_11 a_xp1 a_xn1 wih_p_1_11 wih_n_1_11 xhp11 xhn11 vdd vbsyn gsyn
Xih_2_11 a_xp2 a_xn2 wih_p_2_11 wih_n_2_11 xhp11 xhn11 vdd vbsyn gsyn
Xn11 xhp11 xhn11 ahp11 ahn11 vdd vbneu dneuron
Vwih_p_0_12 wih_p_0_12 0 0.3
Vwih_n_0_12 wih_n_0_12 0 0.9
Vwih_p_1_12 wih_p_1_12 0 0.3
Vwih_n_1_12 wih_n_1_12 0 0.7213002021183876
Vwih_p_2_12 wih_p_2_12 0 0.9
Vwih_n_2_12 wih_n_2_12 0 0.3
Xcm_xh12 xhp12 xhn12 vdd cmld
Rnd_xh12 xhp12 xhn12 20k
Cxh12p xhp12 0 1e-13
Cxh12n xhn12 0 1e-13
Xih_0_12 a_xp0 a_xn0 wih_p_0_12 wih_n_0_12 xhp12 xhn12 vdd vbsyn gsyn
Xih_1_12 a_xp1 a_xn1 wih_p_1_12 wih_n_1_12 xhp12 xhn12 vdd vbsyn gsyn
Xih_2_12 a_xp2 a_xn2 wih_p_2_12 wih_n_2_12 xhp12 xhn12 vdd vbsyn gsyn
Xn12 xhp12 xhn12 ahp12 ahn12 vdd vbneu dneuron
Vwih_p_0_13 wih_p_0_13 0 0.3
Vwih_n_0_13 wih_n_0_13 0 0.9
Vwih_p_1_13 wih_p_1_13 0 0.5019673310802524
Vwih_n_1_13 wih_n_1_13 0 0.4980326689197476
Vwih_p_2_13 wih_p_2_13 0 0.6510764412903762
Vwih_n_2_13 wih_n_2_13 0 0.3489235587096237
Xcm_xh13 xhp13 xhn13 vdd cmld
Rnd_xh13 xhp13 xhn13 20k
Cxh13p xhp13 0 1e-13
Cxh13n xhn13 0 1e-13
Xih_0_13 a_xp0 a_xn0 wih_p_0_13 wih_n_0_13 xhp13 xhn13 vdd vbsyn gsyn
Xih_1_13 a_xp1 a_xn1 wih_p_1_13 wih_n_1_13 xhp13 xhn13 vdd vbsyn gsyn
Xih_2_13 a_xp2 a_xn2 wih_p_2_13 wih_n_2_13 xhp13 xhn13 vdd vbsyn gsyn
Xn13 xhp13 xhn13 ahp13 ahn13 vdd vbneu dneuron
Vwih_p_0_14 wih_p_0_14 0 0.9
Vwih_n_0_14 wih_n_0_14 0 0.3
Vwih_p_1_14 wih_p_1_14 0 0.9
Vwih_n_1_14 wih_n_1_14 0 0.3
Vwih_p_2_14 wih_p_2_14 0 0.321441830538693
Vwih_n_2_14 wih_n_2_14 0 0.678558169461307
Xcm_xh14 xhp14 xhn14 vdd cmld
Rnd_xh14 xhp14 xhn14 20k
Cxh14p xhp14 0 1e-13
Cxh14n xhn14 0 1e-13
Xih_0_14 a_xp0 a_xn0 wih_p_0_14 wih_n_0_14 xhp14 xhn14 vdd vbsyn gsyn
Xih_1_14 a_xp1 a_xn1 wih_p_1_14 wih_n_1_14 xhp14 xhn14 vdd vbsyn gsyn
Xih_2_14 a_xp2 a_xn2 wih_p_2_14 wih_n_2_14 xhp14 xhn14 vdd vbsyn gsyn
Xn14 xhp14 xhn14 ahp14 ahn14 vdd vbneu dneuron
Vwih_p_0_15 wih_p_0_15 0 0.3
Vwih_n_0_15 wih_n_0_15 0 0.8946964794631206
Vwih_p_1_15 wih_p_1_15 0 0.9
Vwih_n_1_15 wih_n_1_15 0 0.3
Vwih_p_2_15 wih_p_2_15 0 0.5958540050197993
Vwih_n_2_15 wih_n_2_15 0 0.4041459949802006
Xcm_xh15 xhp15 xhn15 vdd cmld
Rnd_xh15 xhp15 xhn15 20k
Cxh15p xhp15 0 1e-13
Cxh15n xhn15 0 1e-13
Xih_0_15 a_xp0 a_xn0 wih_p_0_15 wih_n_0_15 xhp15 xhn15 vdd vbsyn gsyn
Xih_1_15 a_xp1 a_xn1 wih_p_1_15 wih_n_1_15 xhp15 xhn15 vdd vbsyn gsyn
Xih_2_15 a_xp2 a_xn2 wih_p_2_15 wih_n_2_15 xhp15 xhn15 vdd vbsyn gsyn
Xn15 xhp15 xhn15 ahp15 ahn15 vdd vbneu dneuron
Xcm_mo0 mop0 mon0 vdd cmld
Rmo0 mop0 mon0 22k
Cmo0p mop0 0 1e-13
Cmo0n mon0 0 1e-13
Cwp_0_0 who_p_0_0 0 20p
Cwn_0_0 who_n_0_0 0 20p
Rwp_0_0 who_p_0_0 wcm 200meg
Rwn_0_0 who_n_0_0 wcm 200meg
Xsyn_0_0 ahp0 ahn0 who_p_0_0 who_n_0_0 mop0 mon0 vdd vbsyn gsyn
Cwp_1_0 who_p_1_0 0 20p
Cwn_1_0 who_n_1_0 0 20p
Rwp_1_0 who_p_1_0 wcm 200meg
Rwn_1_0 who_n_1_0 wcm 200meg
Xsyn_1_0 ahp1 ahn1 who_p_1_0 who_n_1_0 mop0 mon0 vdd vbsyn gsyn
Cwp_2_0 who_p_2_0 0 20p
Cwn_2_0 who_n_2_0 0 20p
Rwp_2_0 who_p_2_0 wcm 200meg
Rwn_2_0 who_n_2_0 wcm 200meg
Xsyn_2_0 ahp2 ahn2 who_p_2_0 who_n_2_0 mop0 mon0 vdd vbsyn gsyn
Cwp_3_0 who_p_3_0 0 20p
Cwn_3_0 who_n_3_0 0 20p
Rwp_3_0 who_p_3_0 wcm 200meg
Rwn_3_0 who_n_3_0 wcm 200meg
Xsyn_3_0 ahp3 ahn3 who_p_3_0 who_n_3_0 mop0 mon0 vdd vbsyn gsyn
Cwp_4_0 who_p_4_0 0 20p
Cwn_4_0 who_n_4_0 0 20p
Rwp_4_0 who_p_4_0 wcm 200meg
Rwn_4_0 who_n_4_0 wcm 200meg
Xsyn_4_0 ahp4 ahn4 who_p_4_0 who_n_4_0 mop0 mon0 vdd vbsyn gsyn
Cwp_5_0 who_p_5_0 0 20p
Cwn_5_0 who_n_5_0 0 20p
Rwp_5_0 who_p_5_0 wcm 200meg
Rwn_5_0 who_n_5_0 wcm 200meg
Xsyn_5_0 ahp5 ahn5 who_p_5_0 who_n_5_0 mop0 mon0 vdd vbsyn gsyn
Cwp_6_0 who_p_6_0 0 20p
Cwn_6_0 who_n_6_0 0 20p
Rwp_6_0 who_p_6_0 wcm 200meg
Rwn_6_0 who_n_6_0 wcm 200meg
Xsyn_6_0 ahp6 ahn6 who_p_6_0 who_n_6_0 mop0 mon0 vdd vbsyn gsyn
Cwp_7_0 who_p_7_0 0 20p
Cwn_7_0 who_n_7_0 0 20p
Rwp_7_0 who_p_7_0 wcm 200meg
Rwn_7_0 who_n_7_0 wcm 200meg
Xsyn_7_0 ahp7 ahn7 who_p_7_0 who_n_7_0 mop0 mon0 vdd vbsyn gsyn
Cwp_8_0 who_p_8_0 0 20p
Cwn_8_0 who_n_8_0 0 20p
Rwp_8_0 who_p_8_0 wcm 200meg
Rwn_8_0 who_n_8_0 wcm 200meg
Xsyn_8_0 ahp8 ahn8 who_p_8_0 who_n_8_0 mop0 mon0 vdd vbsyn gsyn
Cwp_9_0 who_p_9_0 0 20p
Cwn_9_0 who_n_9_0 0 20p
Rwp_9_0 who_p_9_0 wcm 200meg
Rwn_9_0 who_n_9_0 wcm 200meg
Xsyn_9_0 ahp9 ahn9 who_p_9_0 who_n_9_0 mop0 mon0 vdd vbsyn gsyn
Cwp_10_0 who_p_10_0 0 20p
Cwn_10_0 who_n_10_0 0 20p
Rwp_10_0 who_p_10_0 wcm 200meg
Rwn_10_0 who_n_10_0 wcm 200meg
Xsyn_10_0 ahp10 ahn10 who_p_10_0 who_n_10_0 mop0 mon0 vdd vbsyn gsyn
Cwp_11_0 who_p_11_0 0 20p
Cwn_11_0 who_n_11_0 0 20p
Rwp_11_0 who_p_11_0 wcm 200meg
Rwn_11_0 who_n_11_0 wcm 200meg
Xsyn_11_0 ahp11 ahn11 who_p_11_0 who_n_11_0 mop0 mon0 vdd vbsyn gsyn
Cwp_12_0 who_p_12_0 0 20p
Cwn_12_0 who_n_12_0 0 20p
Rwp_12_0 who_p_12_0 wcm 200meg
Rwn_12_0 who_n_12_0 wcm 200meg
Xsyn_12_0 ahp12 ahn12 who_p_12_0 who_n_12_0 mop0 mon0 vdd vbsyn gsyn
Cwp_13_0 who_p_13_0 0 20p
Cwn_13_0 who_n_13_0 0 20p
Rwp_13_0 who_p_13_0 wcm 200meg
Rwn_13_0 who_n_13_0 wcm 200meg
Xsyn_13_0 ahp13 ahn13 who_p_13_0 who_n_13_0 mop0 mon0 vdd vbsyn gsyn
Cwp_14_0 who_p_14_0 0 20p
Cwn_14_0 who_n_14_0 0 20p
Rwp_14_0 who_p_14_0 wcm 200meg
Rwn_14_0 who_n_14_0 wcm 200meg
Xsyn_14_0 ahp14 ahn14 who_p_14_0 who_n_14_0 mop0 mon0 vdd vbsyn gsyn
Cwp_15_0 who_p_15_0 0 20p
Cwn_15_0 who_n_15_0 0 20p
Rwp_15_0 who_p_15_0 wcm 200meg
Rwn_15_0 who_n_15_0 wcm 200meg
Xsyn_15_0 ahp15 ahn15 who_p_15_0 who_n_15_0 mop0 mon0 vdd vbsyn gsyn
Xeo0 xop0 xon0 mop0 mon0 eop0 eon0 vdd gm esub
Xcm_mo1 mop1 mon1 vdd cmld
Rmo1 mop1 mon1 22k
Cmo1p mop1 0 1e-13
Cmo1n mon1 0 1e-13
Cwp_0_1 who_p_0_1 0 20p
Cwn_0_1 who_n_0_1 0 20p
Rwp_0_1 who_p_0_1 wcm 200meg
Rwn_0_1 who_n_0_1 wcm 200meg
Xsyn_0_1 ahp0 ahn0 who_p_0_1 who_n_0_1 mop1 mon1 vdd vbsyn gsyn
Cwp_1_1 who_p_1_1 0 20p
Cwn_1_1 who_n_1_1 0 20p
Rwp_1_1 who_p_1_1 wcm 200meg
Rwn_1_1 who_n_1_1 wcm 200meg
Xsyn_1_1 ahp1 ahn1 who_p_1_1 who_n_1_1 mop1 mon1 vdd vbsyn gsyn
Cwp_2_1 who_p_2_1 0 20p
Cwn_2_1 who_n_2_1 0 20p
Rwp_2_1 who_p_2_1 wcm 200meg
Rwn_2_1 who_n_2_1 wcm 200meg
Xsyn_2_1 ahp2 ahn2 who_p_2_1 who_n_2_1 mop1 mon1 vdd vbsyn gsyn
Cwp_3_1 who_p_3_1 0 20p
Cwn_3_1 who_n_3_1 0 20p
Rwp_3_1 who_p_3_1 wcm 200meg
Rwn_3_1 who_n_3_1 wcm 200meg
Xsyn_3_1 ahp3 ahn3 who_p_3_1 who_n_3_1 mop1 mon1 vdd vbsyn gsyn
Cwp_4_1 who_p_4_1 0 20p
Cwn_4_1 who_n_4_1 0 20p
Rwp_4_1 who_p_4_1 wcm 200meg
Rwn_4_1 who_n_4_1 wcm 200meg
Xsyn_4_1 ahp4 ahn4 who_p_4_1 who_n_4_1 mop1 mon1 vdd vbsyn gsyn
Cwp_5_1 who_p_5_1 0 20p
Cwn_5_1 who_n_5_1 0 20p
Rwp_5_1 who_p_5_1 wcm 200meg
Rwn_5_1 who_n_5_1 wcm 200meg
Xsyn_5_1 ahp5 ahn5 who_p_5_1 who_n_5_1 mop1 mon1 vdd vbsyn gsyn
Cwp_6_1 who_p_6_1 0 20p
Cwn_6_1 who_n_6_1 0 20p
Rwp_6_1 who_p_6_1 wcm 200meg
Rwn_6_1 who_n_6_1 wcm 200meg
Xsyn_6_1 ahp6 ahn6 who_p_6_1 who_n_6_1 mop1 mon1 vdd vbsyn gsyn
Cwp_7_1 who_p_7_1 0 20p
Cwn_7_1 who_n_7_1 0 20p
Rwp_7_1 who_p_7_1 wcm 200meg
Rwn_7_1 who_n_7_1 wcm 200meg
Xsyn_7_1 ahp7 ahn7 who_p_7_1 who_n_7_1 mop1 mon1 vdd vbsyn gsyn
Cwp_8_1 who_p_8_1 0 20p
Cwn_8_1 who_n_8_1 0 20p
Rwp_8_1 who_p_8_1 wcm 200meg
Rwn_8_1 who_n_8_1 wcm 200meg
Xsyn_8_1 ahp8 ahn8 who_p_8_1 who_n_8_1 mop1 mon1 vdd vbsyn gsyn
Cwp_9_1 who_p_9_1 0 20p
Cwn_9_1 who_n_9_1 0 20p
Rwp_9_1 who_p_9_1 wcm 200meg
Rwn_9_1 who_n_9_1 wcm 200meg
Xsyn_9_1 ahp9 ahn9 who_p_9_1 who_n_9_1 mop1 mon1 vdd vbsyn gsyn
Cwp_10_1 who_p_10_1 0 20p
Cwn_10_1 who_n_10_1 0 20p
Rwp_10_1 who_p_10_1 wcm 200meg
Rwn_10_1 who_n_10_1 wcm 200meg
Xsyn_10_1 ahp10 ahn10 who_p_10_1 who_n_10_1 mop1 mon1 vdd vbsyn gsyn
Cwp_11_1 who_p_11_1 0 20p
Cwn_11_1 who_n_11_1 0 20p
Rwp_11_1 who_p_11_1 wcm 200meg
Rwn_11_1 who_n_11_1 wcm 200meg
Xsyn_11_1 ahp11 ahn11 who_p_11_1 who_n_11_1 mop1 mon1 vdd vbsyn gsyn
Cwp_12_1 who_p_12_1 0 20p
Cwn_12_1 who_n_12_1 0 20p
Rwp_12_1 who_p_12_1 wcm 200meg
Rwn_12_1 who_n_12_1 wcm 200meg
Xsyn_12_1 ahp12 ahn12 who_p_12_1 who_n_12_1 mop1 mon1 vdd vbsyn gsyn
Cwp_13_1 who_p_13_1 0 20p
Cwn_13_1 who_n_13_1 0 20p
Rwp_13_1 who_p_13_1 wcm 200meg
Rwn_13_1 who_n_13_1 wcm 200meg
Xsyn_13_1 ahp13 ahn13 who_p_13_1 who_n_13_1 mop1 mon1 vdd vbsyn gsyn
Cwp_14_1 who_p_14_1 0 20p
Cwn_14_1 who_n_14_1 0 20p
Rwp_14_1 who_p_14_1 wcm 200meg
Rwn_14_1 who_n_14_1 wcm 200meg
Xsyn_14_1 ahp14 ahn14 who_p_14_1 who_n_14_1 mop1 mon1 vdd vbsyn gsyn
Cwp_15_1 who_p_15_1 0 20p
Cwn_15_1 who_n_15_1 0 20p
Rwp_15_1 who_p_15_1 wcm 200meg
Rwn_15_1 who_n_15_1 wcm 200meg
Xsyn_15_1 ahp15 ahn15 who_p_15_1 who_n_15_1 mop1 mon1 vdd vbsyn gsyn
Xeo1 xop1 xon1 mop1 mon1 eop1 eon1 vdd gm esub
Xlrn_0_0 eop0 eon0 ahp0 ahn0 who_p_0_0 who_n_0_0 vdd gbl gprod
Xlrn_1_0 eop0 eon0 ahp1 ahn1 who_p_1_0 who_n_1_0 vdd gbl gprod
Xlrn_2_0 eop0 eon0 ahp2 ahn2 who_p_2_0 who_n_2_0 vdd gbl gprod
Xlrn_3_0 eop0 eon0 ahp3 ahn3 who_p_3_0 who_n_3_0 vdd gbl gprod
Xlrn_4_0 eop0 eon0 ahp4 ahn4 who_p_4_0 who_n_4_0 vdd gbl gprod
Xlrn_5_0 eop0 eon0 ahp5 ahn5 who_p_5_0 who_n_5_0 vdd gbl gprod
Xlrn_6_0 eop0 eon0 ahp6 ahn6 who_p_6_0 who_n_6_0 vdd gbl gprod
Xlrn_7_0 eop0 eon0 ahp7 ahn7 who_p_7_0 who_n_7_0 vdd gbl gprod
Xlrn_8_0 eop0 eon0 ahp8 ahn8 who_p_8_0 who_n_8_0 vdd gbl gprod
Xlrn_9_0 eop0 eon0 ahp9 ahn9 who_p_9_0 who_n_9_0 vdd gbl gprod
Xlrn_10_0 eop0 eon0 ahp10 ahn10 who_p_10_0 who_n_10_0 vdd gbl gprod
Xlrn_11_0 eop0 eon0 ahp11 ahn11 who_p_11_0 who_n_11_0 vdd gbl gprod
Xlrn_12_0 eop0 eon0 ahp12 ahn12 who_p_12_0 who_n_12_0 vdd gbl gprod
Xlrn_13_0 eop0 eon0 ahp13 ahn13 who_p_13_0 who_n_13_0 vdd gbl gprod
Xlrn_14_0 eop0 eon0 ahp14 ahn14 who_p_14_0 who_n_14_0 vdd gbl gprod
Xlrn_15_0 eop0 eon0 ahp15 ahn15 who_p_15_0 who_n_15_0 vdd gbl gprod
Xlrn_0_1 eop1 eon1 ahp0 ahn0 who_p_0_1 who_n_0_1 vdd gbl gprod
Xlrn_1_1 eop1 eon1 ahp1 ahn1 who_p_1_1 who_n_1_1 vdd gbl gprod
Xlrn_2_1 eop1 eon1 ahp2 ahn2 who_p_2_1 who_n_2_1 vdd gbl gprod
Xlrn_3_1 eop1 eon1 ahp3 ahn3 who_p_3_1 who_n_3_1 vdd gbl gprod
Xlrn_4_1 eop1 eon1 ahp4 ahn4 who_p_4_1 who_n_4_1 vdd gbl gprod
Xlrn_5_1 eop1 eon1 ahp5 ahn5 who_p_5_1 who_n_5_1 vdd gbl gprod
Xlrn_6_1 eop1 eon1 ahp6 ahn6 who_p_6_1 who_n_6_1 vdd gbl gprod
Xlrn_7_1 eop1 eon1 ahp7 ahn7 who_p_7_1 who_n_7_1 vdd gbl gprod
Xlrn_8_1 eop1 eon1 ahp8 ahn8 who_p_8_1 who_n_8_1 vdd gbl gprod
Xlrn_9_1 eop1 eon1 ahp9 ahn9 who_p_9_1 who_n_9_1 vdd gbl gprod
Xlrn_10_1 eop1 eon1 ahp10 ahn10 who_p_10_1 who_n_10_1 vdd gbl gprod
Xlrn_11_1 eop1 eon1 ahp11 ahn11 who_p_11_1 who_n_11_1 vdd gbl gprod
Xlrn_12_1 eop1 eon1 ahp12 ahn12 who_p_12_1 who_n_12_1 vdd gbl gprod
Xlrn_13_1 eop1 eon1 ahp13 ahn13 who_p_13_1 who_n_13_1 vdd gbl gprod
Xlrn_14_1 eop1 eon1 ahp14 ahn14 who_p_14_1 who_n_14_1 vdd gbl gprod
Xlrn_15_1 eop1 eon1 ahp15 ahn15 who_p_15_1 who_n_15_1 vdd gbl gprod
.ic v(who_p_0_0)=0.5 v(who_n_0_0)=0.5
.ic v(who_p_1_0)=0.5 v(who_n_1_0)=0.5
.ic v(who_p_2_0)=0.5 v(who_n_2_0)=0.5
.ic v(who_p_3_0)=0.5 v(who_n_3_0)=0.5
.ic v(who_p_4_0)=0.5 v(who_n_4_0)=0.5
.ic v(who_p_5_0)=0.5 v(who_n_5_0)=0.5
.ic v(who_p_6_0)=0.5 v(who_n_6_0)=0.5
.ic v(who_p_7_0)=0.5 v(who_n_7_0)=0.5
.ic v(who_p_8_0)=0.5 v(who_n_8_0)=0.5
.ic v(who_p_9_0)=0.5 v(who_n_9_0)=0.5
.ic v(who_p_10_0)=0.5 v(who_n_10_0)=0.5
.ic v(who_p_11_0)=0.5 v(who_n_11_0)=0.5
.ic v(who_p_12_0)=0.5 v(who_n_12_0)=0.5
.ic v(who_p_13_0)=0.5 v(who_n_13_0)=0.5
.ic v(who_p_14_0)=0.5 v(who_n_14_0)=0.5
.ic v(who_p_15_0)=0.5 v(who_n_15_0)=0.5
.ic v(who_p_0_1)=0.5 v(who_n_0_1)=0.5
.ic v(who_p_1_1)=0.5 v(who_n_1_1)=0.5
.ic v(who_p_2_1)=0.5 v(who_n_2_1)=0.5
.ic v(who_p_3_1)=0.5 v(who_n_3_1)=0.5
.ic v(who_p_4_1)=0.5 v(who_n_4_1)=0.5
.ic v(who_p_5_1)=0.5 v(who_n_5_1)=0.5
.ic v(who_p_6_1)=0.5 v(who_n_6_1)=0.5
.ic v(who_p_7_1)=0.5 v(who_n_7_1)=0.5
.ic v(who_p_8_1)=0.5 v(who_n_8_1)=0.5
.ic v(who_p_9_1)=0.5 v(who_n_9_1)=0.5
.ic v(who_p_10_1)=0.5 v(who_n_10_1)=0.5
.ic v(who_p_11_1)=0.5 v(who_n_11_1)=0.5
.ic v(who_p_12_1)=0.5 v(who_n_12_1)=0.5
.ic v(who_p_13_1)=0.5 v(who_n_13_1)=0.5
.ic v(who_p_14_1)=0.5 v(who_n_14_1)=0.5
.ic v(who_p_15_1)=0.5 v(who_n_15_1)=0.5
.options gmin=1e-10 reltol=2e-3 cshunt=1e-14 method=gear
.control
tran 2n 183600n uic
wrdata ps_h16.dat v(mop0) v(mon0) v(mop1) v(mon1) v(ahp0) v(ahn0) v(ahp1) v(ahn1) v(ahp2) v(ahn2) v(ahp3) v(ahn3) v(ahp4) v(ahn4) v(ahp5) v(ahn5) v(ahp6) v(ahn6) v(ahp7) v(ahn7) v(ahp8) v(ahn8) v(ahp9) v(ahn9) v(ahp10) v(ahn10) v(ahp11) v(ahn11) v(ahp12) v(ahn12) v(ahp13) v(ahn13) v(ahp14) v(ahn14) v(ahp15) v(ahn15) v(who_p_0_0) v(who_n_0_0) v(who_p_1_0) v(who_n_1_0) v(who_p_2_0) v(who_n_2_0) v(who_p_3_0) v(who_n_3_0) v(who_p_4_0) v(who_n_4_0) v(who_p_5_0) v(who_n_5_0) v(who_p_6_0) v(who_n_6_0) v(who_p_7_0) v(who_n_7_0) v(who_p_8_0) v(who_n_8_0) v(who_p_9_0) v(who_n_9_0) v(who_p_10_0) v(who_n_10_0) v(who_p_11_0) v(who_n_11_0) v(who_p_12_0) v(who_n_12_0) v(who_p_13_0) v(who_n_13_0) v(who_p_14_0) v(who_n_14_0) v(who_p_15_0) v(who_n_15_0) v(who_p_0_1) v(who_n_0_1) v(who_p_1_1) v(who_n_1_1) v(who_p_2_1) v(who_n_2_1) v(who_p_3_1) v(who_n_3_1) v(who_p_4_1) v(who_n_4_1) v(who_p_5_1) v(who_n_5_1) v(who_p_6_1) v(who_n_6_1) v(who_p_7_1) v(who_n_7_1) v(who_p_8_1) v(who_n_8_1) v(who_p_9_1) v(who_n_9_1) v(who_p_10_1) v(who_n_10_1) v(who_p_11_1) v(who_n_11_1) v(who_p_12_1) v(who_n_12_1) v(who_p_13_1) v(who_n_13_1) v(who_p_14_1) v(who_n_14_1) v(who_p_15_1) v(who_n_15_1)
.endc
.end
