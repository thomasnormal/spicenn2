digits differential current-mode EP (live)
.model NNR NMOS (LEVEL=1 VTO=0.2  KP=120u LAMBDA=0.02 GAMMA=0 PHI=0.7)
.model PNR PMOS (LEVEL=1 VTO=-0.2 KP=40u  LAMBDA=0.02 GAMMA=0 PHI=0.7)
.subckt dsyn inp inn outp outn wp wn vdd
M1 outp inp tp 0 NNR W=200u L=100u
M2 outn inn tp 0 NNR W=200u L=100u
Mtp tp wp 0 0 NNR W=200u L=100u
M3 outn inp tn 0 NNR W=200u L=100u
M4 outp inn tn 0 NNR W=200u L=100u
Mtn tn wn 0 0 NNR W=200u L=100u
.ends
.subckt dneuron up un ap an vdd vbn
M1 an up tn 0 NNR W=200u L=100u
M2 ap un tn 0 NNR W=200u L=100u
Mt tn vbn 0 0 NNR W=200u L=100u
RLa vdd ap 800k
RLb vdd an 800k
.ends

Vdd vdd 0 1.0
Vbn vbn 0 0.30
Vbp_hi bp_hi 0 0.8
Vbp_lo bp_lo 0 0.2
Vaxp0 a_xp0 0 0.5
Vaxn0 a_xn0 0 0.5
Vaxp1 a_xp1 0 0.5
Vaxn1 a_xn1 0 0.5
Vtp0 vtp0 0 0.5
Vtn0 vtn0 0 0.5
Vtp1 vtp1 0 0.5
Vtn1 vtn1 0 0.5
Mlp_h0 up_h0 up_h0 vdd vdd PNR W=1500u L=100u
Mln_h0 un_h0 un_h0 vdd vdd PNR W=1500u L=100u
Xn_h0 up_h0 un_h0 ap_h0 an_h0 vdd vbn dneuron
Vwp_ih_0_0 wp_ih_0_0 0 0.4250
Vwn_ih_0_0 wn_ih_0_0 0 0.4150
X_ih_0_0 a_xp0 a_xn0 up_h0 un_h0 wp_ih_0_0 wn_ih_0_0 vdd dsyn
Vwp_ih_1_0 wp_ih_1_0 0 0.4147
Vwn_ih_1_0 wn_ih_1_0 0 0.4253
X_ih_1_0 a_xp1 a_xn1 up_h0 un_h0 wp_ih_1_0 wn_ih_1_0 vdd dsyn
Vwp_bk_0_0 wp_bk_0_0 0 0.4456
Vwn_bk_0_0 wn_bk_0_0 0 0.3944
X_bk_0_0 up_o0 un_o0 up_h0 un_h0 wp_bk_0_0 wn_bk_0_0 vdd dsyn
Vwp_bk_0_1 wp_bk_0_1 0 0.4242
Vwn_bk_0_1 wn_bk_0_1 0 0.4158
X_bk_0_1 up_o1 un_o1 up_h0 un_h0 wp_bk_0_1 wn_bk_0_1 vdd dsyn
Vwp_bh_0 wp_bh_0 0 0.3986
Vwn_bh_0 wn_bh_0 0 0.4414
X_bh_0 bp_hi bp_lo up_h0 un_h0 wp_bh_0 wn_bh_0 vdd dsyn
Mlp_h1 up_h1 up_h1 vdd vdd PNR W=1500u L=100u
Mln_h1 un_h1 un_h1 vdd vdd PNR W=1500u L=100u
Xn_h1 up_h1 un_h1 ap_h1 an_h1 vdd vbn dneuron
Vwp_ih_0_1 wp_ih_0_1 0 0.4345
Vwn_ih_0_1 wn_ih_0_1 0 0.4055
X_ih_0_1 a_xp0 a_xn0 up_h1 un_h1 wp_ih_0_1 wn_ih_0_1 vdd dsyn
Vwp_ih_1_1 wp_ih_1_1 0 0.4722
Vwn_ih_1_1 wn_ih_1_1 0 0.3678
X_ih_1_1 a_xp1 a_xn1 up_h1 un_h1 wp_ih_1_1 wn_ih_1_1 vdd dsyn
Vwp_bk_1_0 wp_bk_1_0 0 0.4579
Vwn_bk_1_0 wn_bk_1_0 0 0.3821
X_bk_1_0 up_o0 un_o0 up_h1 un_h1 wp_bk_1_0 wn_bk_1_0 vdd dsyn
Vwp_bk_1_1 wp_bk_1_1 0 0.3919
Vwn_bk_1_1 wn_bk_1_1 0 0.4481
X_bk_1_1 up_o1 un_o1 up_h1 un_h1 wp_bk_1_1 wn_bk_1_1 vdd dsyn
Vwp_bh_1 wp_bh_1 0 0.3694
Vwn_bh_1 wn_bh_1 0 0.4706
X_bh_1 bp_hi bp_lo up_h1 un_h1 wp_bh_1 wn_bh_1 vdd dsyn
Mlp_h2 up_h2 up_h2 vdd vdd PNR W=1500u L=100u
Mln_h2 un_h2 un_h2 vdd vdd PNR W=1500u L=100u
Xn_h2 up_h2 un_h2 ap_h2 an_h2 vdd vbn dneuron
Vwp_ih_0_2 wp_ih_0_2 0 0.3951
Vwn_ih_0_2 wn_ih_0_2 0 0.4449
X_ih_0_2 a_xp0 a_xn0 up_h2 un_h2 wp_ih_0_2 wn_ih_0_2 vdd dsyn
Vwp_ih_1_2 wp_ih_1_2 0 0.4217
Vwn_ih_1_2 wn_ih_1_2 0 0.4183
X_ih_1_2 a_xp1 a_xn1 up_h2 un_h2 wp_ih_1_2 wn_ih_1_2 vdd dsyn
Vwp_bk_2_0 wp_bk_2_0 0 0.3270
Vwn_bk_2_0 wn_bk_2_0 0 0.5130
X_bk_2_0 up_o0 un_o0 up_h2 un_h2 wp_bk_2_0 wn_bk_2_0 vdd dsyn
Vwp_bk_2_1 wp_bk_2_1 0 0.4112
Vwn_bk_2_1 wn_bk_2_1 0 0.4288
X_bk_2_1 up_o1 un_o1 up_h2 un_h2 wp_bk_2_1 wn_bk_2_1 vdd dsyn
Vwp_bh_2 wp_bh_2 0 0.3702
Vwn_bh_2 wn_bh_2 0 0.4698
X_bh_2 bp_hi bp_lo up_h2 un_h2 wp_bh_2 wn_bh_2 vdd dsyn
Mlp_h3 up_h3 up_h3 vdd vdd PNR W=1500u L=100u
Mln_h3 un_h3 un_h3 vdd vdd PNR W=1500u L=100u
Xn_h3 up_h3 un_h3 ap_h3 an_h3 vdd vbn dneuron
Vwp_ih_0_3 wp_ih_0_3 0 0.3907
Vwn_ih_0_3 wn_ih_0_3 0 0.4493
X_ih_0_3 a_xp0 a_xn0 up_h3 un_h3 wp_ih_0_3 wn_ih_0_3 vdd dsyn
Vwp_ih_1_3 wp_ih_1_3 0 0.3982
Vwn_ih_1_3 wn_ih_1_3 0 0.4418
X_ih_1_3 a_xp1 a_xn1 up_h3 un_h3 wp_ih_1_3 wn_ih_1_3 vdd dsyn
Vwp_bk_3_0 wp_bk_3_0 0 0.4073
Vwn_bk_3_0 wn_bk_3_0 0 0.4327
X_bk_3_0 up_o0 un_o0 up_h3 un_h3 wp_bk_3_0 wn_bk_3_0 vdd dsyn
Vwp_bk_3_1 wp_bk_3_1 0 0.4365
Vwn_bk_3_1 wn_bk_3_1 0 0.4035
X_bk_3_1 up_o1 un_o1 up_h3 un_h3 wp_bk_3_1 wn_bk_3_1 vdd dsyn
Vwp_bh_3 wp_bh_3 0 0.4617
Vwn_bh_3 wn_bh_3 0 0.3783
X_bh_3 bp_hi bp_lo up_h3 un_h3 wp_bh_3 wn_bh_3 vdd dsyn
Mlp_h4 up_h4 up_h4 vdd vdd PNR W=1500u L=100u
Mln_h4 un_h4 un_h4 vdd vdd PNR W=1500u L=100u
Xn_h4 up_h4 un_h4 ap_h4 an_h4 vdd vbn dneuron
Vwp_ih_0_4 wp_ih_0_4 0 0.4149
Vwn_ih_0_4 wn_ih_0_4 0 0.4251
X_ih_0_4 a_xp0 a_xn0 up_h4 un_h4 wp_ih_0_4 wn_ih_0_4 vdd dsyn
Vwp_ih_1_4 wp_ih_1_4 0 0.4747
Vwn_ih_1_4 wn_ih_1_4 0 0.3653
X_ih_1_4 a_xp1 a_xn1 up_h4 un_h4 wp_ih_1_4 wn_ih_1_4 vdd dsyn
Vwp_bk_4_0 wp_bk_4_0 0 0.3934
Vwn_bk_4_0 wn_bk_4_0 0 0.4466
X_bk_4_0 up_o0 un_o0 up_h4 un_h4 wp_bk_4_0 wn_bk_4_0 vdd dsyn
Vwp_bk_4_1 wp_bk_4_1 0 0.4341
Vwn_bk_4_1 wn_bk_4_1 0 0.4059
X_bk_4_1 up_o1 un_o1 up_h4 un_h4 wp_bk_4_1 wn_bk_4_1 vdd dsyn
Vwp_bh_4 wp_bh_4 0 0.4561
Vwn_bh_4 wn_bh_4 0 0.3839
X_bh_4 bp_hi bp_lo up_h4 un_h4 wp_bh_4 wn_bh_4 vdd dsyn
Mlp_h5 up_h5 up_h5 vdd vdd PNR W=1500u L=100u
Mln_h5 un_h5 un_h5 vdd vdd PNR W=1500u L=100u
Xn_h5 up_h5 un_h5 ap_h5 an_h5 vdd vbn dneuron
Vwp_ih_0_5 wp_ih_0_5 0 0.4238
Vwn_ih_0_5 wn_ih_0_5 0 0.4162
X_ih_0_5 a_xp0 a_xn0 up_h5 un_h5 wp_ih_0_5 wn_ih_0_5 vdd dsyn
Vwp_ih_1_5 wp_ih_1_5 0 0.3903
Vwn_ih_1_5 wn_ih_1_5 0 0.4497
X_ih_1_5 a_xp1 a_xn1 up_h5 un_h5 wp_ih_1_5 wn_ih_1_5 vdd dsyn
Vwp_bk_5_0 wp_bk_5_0 0 0.3831
Vwn_bk_5_0 wn_bk_5_0 0 0.4569
X_bk_5_0 up_o0 un_o0 up_h5 un_h5 wp_bk_5_0 wn_bk_5_0 vdd dsyn
Vwp_bk_5_1 wp_bk_5_1 0 0.4017
Vwn_bk_5_1 wn_bk_5_1 0 0.4383
X_bk_5_1 up_o1 un_o1 up_h5 un_h5 wp_bk_5_1 wn_bk_5_1 vdd dsyn
Vwp_bh_5 wp_bh_5 0 0.4288
Vwn_bh_5 wn_bh_5 0 0.4112
X_bh_5 bp_hi bp_lo up_h5 un_h5 wp_bh_5 wn_bh_5 vdd dsyn
Mlp_h6 up_h6 up_h6 vdd vdd PNR W=1500u L=100u
Mln_h6 un_h6 un_h6 vdd vdd PNR W=1500u L=100u
Xn_h6 up_h6 un_h6 ap_h6 an_h6 vdd vbn dneuron
Vwp_ih_0_6 wp_ih_0_6 0 0.3796
Vwn_ih_0_6 wn_ih_0_6 0 0.4604
X_ih_0_6 a_xp0 a_xn0 up_h6 un_h6 wp_ih_0_6 wn_ih_0_6 vdd dsyn
Vwp_ih_1_6 wp_ih_1_6 0 0.4116
Vwn_ih_1_6 wn_ih_1_6 0 0.4284
X_ih_1_6 a_xp1 a_xn1 up_h6 un_h6 wp_ih_1_6 wn_ih_1_6 vdd dsyn
Vwp_bk_6_0 wp_bk_6_0 0 0.4136
Vwn_bk_6_0 wn_bk_6_0 0 0.4264
X_bk_6_0 up_o0 un_o0 up_h6 un_h6 wp_bk_6_0 wn_bk_6_0 vdd dsyn
Vwp_bk_6_1 wp_bk_6_1 0 0.4416
Vwn_bk_6_1 wn_bk_6_1 0 0.3984
X_bk_6_1 up_o1 un_o1 up_h6 un_h6 wp_bk_6_1 wn_bk_6_1 vdd dsyn
Vwp_bh_6 wp_bh_6 0 0.4286
Vwn_bh_6 wn_bh_6 0 0.4114
X_bh_6 bp_hi bp_lo up_h6 un_h6 wp_bh_6 wn_bh_6 vdd dsyn
Mlp_h7 up_h7 up_h7 vdd vdd PNR W=1500u L=100u
Mln_h7 un_h7 un_h7 vdd vdd PNR W=1500u L=100u
Xn_h7 up_h7 un_h7 ap_h7 an_h7 vdd vbn dneuron
Vwp_ih_0_7 wp_ih_0_7 0 0.4342
Vwn_ih_0_7 wn_ih_0_7 0 0.4058
X_ih_0_7 a_xp0 a_xn0 up_h7 un_h7 wp_ih_0_7 wn_ih_0_7 vdd dsyn
Vwp_ih_1_7 wp_ih_1_7 0 0.3938
Vwn_ih_1_7 wn_ih_1_7 0 0.4462
X_ih_1_7 a_xp1 a_xn1 up_h7 un_h7 wp_ih_1_7 wn_ih_1_7 vdd dsyn
Vwp_bk_7_0 wp_bk_7_0 0 0.4148
Vwn_bk_7_0 wn_bk_7_0 0 0.4252
X_bk_7_0 up_o0 un_o0 up_h7 un_h7 wp_bk_7_0 wn_bk_7_0 vdd dsyn
Vwp_bk_7_1 wp_bk_7_1 0 0.4514
Vwn_bk_7_1 wn_bk_7_1 0 0.3886
X_bk_7_1 up_o1 un_o1 up_h7 un_h7 wp_bk_7_1 wn_bk_7_1 vdd dsyn
Vwp_bh_7 wp_bh_7 0 0.4797
Vwn_bh_7 wn_bh_7 0 0.3603
X_bh_7 bp_hi bp_lo up_h7 un_h7 wp_bh_7 wn_bh_7 vdd dsyn
Mlp_h8 up_h8 up_h8 vdd vdd PNR W=1500u L=100u
Mln_h8 un_h8 un_h8 vdd vdd PNR W=1500u L=100u
Xn_h8 up_h8 un_h8 ap_h8 an_h8 vdd vbn dneuron
Vwp_ih_0_8 wp_ih_0_8 0 0.3696
Vwn_ih_0_8 wn_ih_0_8 0 0.4704
X_ih_0_8 a_xp0 a_xn0 up_h8 un_h8 wp_ih_0_8 wn_ih_0_8 vdd dsyn
Vwp_ih_1_8 wp_ih_1_8 0 0.4806
Vwn_ih_1_8 wn_ih_1_8 0 0.3594
X_ih_1_8 a_xp1 a_xn1 up_h8 un_h8 wp_ih_1_8 wn_ih_1_8 vdd dsyn
Vwp_bk_8_0 wp_bk_8_0 0 0.4738
Vwn_bk_8_0 wn_bk_8_0 0 0.3662
X_bk_8_0 up_o0 un_o0 up_h8 un_h8 wp_bk_8_0 wn_bk_8_0 vdd dsyn
Vwp_bk_8_1 wp_bk_8_1 0 0.4513
Vwn_bk_8_1 wn_bk_8_1 0 0.3887
X_bk_8_1 up_o1 un_o1 up_h8 un_h8 wp_bk_8_1 wn_bk_8_1 vdd dsyn
Vwp_bh_8 wp_bh_8 0 0.4306
Vwn_bh_8 wn_bh_8 0 0.4094
X_bh_8 bp_hi bp_lo up_h8 un_h8 wp_bh_8 wn_bh_8 vdd dsyn
Mlp_h9 up_h9 up_h9 vdd vdd PNR W=1500u L=100u
Mln_h9 un_h9 un_h9 vdd vdd PNR W=1500u L=100u
Xn_h9 up_h9 un_h9 ap_h9 an_h9 vdd vbn dneuron
Vwp_ih_0_9 wp_ih_0_9 0 0.4074
Vwn_ih_0_9 wn_ih_0_9 0 0.4326
X_ih_0_9 a_xp0 a_xn0 up_h9 un_h9 wp_ih_0_9 wn_ih_0_9 vdd dsyn
Vwp_ih_1_9 wp_ih_1_9 0 0.4783
Vwn_ih_1_9 wn_ih_1_9 0 0.3617
X_ih_1_9 a_xp1 a_xn1 up_h9 un_h9 wp_ih_1_9 wn_ih_1_9 vdd dsyn
Vwp_bk_9_0 wp_bk_9_0 0 0.4984
Vwn_bk_9_0 wn_bk_9_0 0 0.3416
X_bk_9_0 up_o0 un_o0 up_h9 un_h9 wp_bk_9_0 wn_bk_9_0 vdd dsyn
Vwp_bk_9_1 wp_bk_9_1 0 0.4921
Vwn_bk_9_1 wn_bk_9_1 0 0.3479
X_bk_9_1 up_o1 un_o1 up_h9 un_h9 wp_bk_9_1 wn_bk_9_1 vdd dsyn
Vwp_bh_9 wp_bh_9 0 0.4726
Vwn_bh_9 wn_bh_9 0 0.3674
X_bh_9 bp_hi bp_lo up_h9 un_h9 wp_bh_9 wn_bh_9 vdd dsyn
Mlp_h10 up_h10 up_h10 vdd vdd PNR W=1500u L=100u
Mln_h10 un_h10 un_h10 vdd vdd PNR W=1500u L=100u
Xn_h10 up_h10 un_h10 ap_h10 an_h10 vdd vbn dneuron
Vwp_ih_0_10 wp_ih_0_10 0 0.4343
Vwn_ih_0_10 wn_ih_0_10 0 0.4057
X_ih_0_10 a_xp0 a_xn0 up_h10 un_h10 wp_ih_0_10 wn_ih_0_10 vdd dsyn
Vwp_ih_1_10 wp_ih_1_10 0 0.3717
Vwn_ih_1_10 wn_ih_1_10 0 0.4683
X_ih_1_10 a_xp1 a_xn1 up_h10 un_h10 wp_ih_1_10 wn_ih_1_10 vdd dsyn
Vwp_bk_10_0 wp_bk_10_0 0 0.4198
Vwn_bk_10_0 wn_bk_10_0 0 0.4202
X_bk_10_0 up_o0 un_o0 up_h10 un_h10 wp_bk_10_0 wn_bk_10_0 vdd dsyn
Vwp_bk_10_1 wp_bk_10_1 0 0.4463
Vwn_bk_10_1 wn_bk_10_1 0 0.3937
X_bk_10_1 up_o1 un_o1 up_h10 un_h10 wp_bk_10_1 wn_bk_10_1 vdd dsyn
Vwp_bh_10 wp_bh_10 0 0.3685
Vwn_bh_10 wn_bh_10 0 0.4715
X_bh_10 bp_hi bp_lo up_h10 un_h10 wp_bh_10 wn_bh_10 vdd dsyn
Mlp_h11 up_h11 up_h11 vdd vdd PNR W=1500u L=100u
Mln_h11 un_h11 un_h11 vdd vdd PNR W=1500u L=100u
Xn_h11 up_h11 un_h11 ap_h11 an_h11 vdd vbn dneuron
Vwp_ih_0_11 wp_ih_0_11 0 0.4358
Vwn_ih_0_11 wn_ih_0_11 0 0.4042
X_ih_0_11 a_xp0 a_xn0 up_h11 un_h11 wp_ih_0_11 wn_ih_0_11 vdd dsyn
Vwp_ih_1_11 wp_ih_1_11 0 0.4372
Vwn_ih_1_11 wn_ih_1_11 0 0.4028
X_ih_1_11 a_xp1 a_xn1 up_h11 un_h11 wp_ih_1_11 wn_ih_1_11 vdd dsyn
Vwp_bk_11_0 wp_bk_11_0 0 0.4478
Vwn_bk_11_0 wn_bk_11_0 0 0.3922
X_bk_11_0 up_o0 un_o0 up_h11 un_h11 wp_bk_11_0 wn_bk_11_0 vdd dsyn
Vwp_bk_11_1 wp_bk_11_1 0 0.3726
Vwn_bk_11_1 wn_bk_11_1 0 0.4674
X_bk_11_1 up_o1 un_o1 up_h11 un_h11 wp_bk_11_1 wn_bk_11_1 vdd dsyn
Vwp_bh_11 wp_bh_11 0 0.3935
Vwn_bh_11 wn_bh_11 0 0.4465
X_bh_11 bp_hi bp_lo up_h11 un_h11 wp_bh_11 wn_bh_11 vdd dsyn
Mlp_h12 up_h12 up_h12 vdd vdd PNR W=1500u L=100u
Mln_h12 un_h12 un_h12 vdd vdd PNR W=1500u L=100u
Xn_h12 up_h12 un_h12 ap_h12 an_h12 vdd vbn dneuron
Vwp_ih_0_12 wp_ih_0_12 0 0.4025
Vwn_ih_0_12 wn_ih_0_12 0 0.4375
X_ih_0_12 a_xp0 a_xn0 up_h12 un_h12 wp_ih_0_12 wn_ih_0_12 vdd dsyn
Vwp_ih_1_12 wp_ih_1_12 0 0.3732
Vwn_ih_1_12 wn_ih_1_12 0 0.4668
X_ih_1_12 a_xp1 a_xn1 up_h12 un_h12 wp_ih_1_12 wn_ih_1_12 vdd dsyn
Vwp_bk_12_0 wp_bk_12_0 0 0.4896
Vwn_bk_12_0 wn_bk_12_0 0 0.3504
X_bk_12_0 up_o0 un_o0 up_h12 un_h12 wp_bk_12_0 wn_bk_12_0 vdd dsyn
Vwp_bk_12_1 wp_bk_12_1 0 0.4002
Vwn_bk_12_1 wn_bk_12_1 0 0.4398
X_bk_12_1 up_o1 un_o1 up_h12 un_h12 wp_bk_12_1 wn_bk_12_1 vdd dsyn
Vwp_bh_12 wp_bh_12 0 0.4332
Vwn_bh_12 wn_bh_12 0 0.4068
X_bh_12 bp_hi bp_lo up_h12 un_h12 wp_bh_12 wn_bh_12 vdd dsyn
Mlp_h13 up_h13 up_h13 vdd vdd PNR W=1500u L=100u
Mln_h13 un_h13 un_h13 vdd vdd PNR W=1500u L=100u
Xn_h13 up_h13 un_h13 ap_h13 an_h13 vdd vbn dneuron
Vwp_ih_0_13 wp_ih_0_13 0 0.4097
Vwn_ih_0_13 wn_ih_0_13 0 0.4303
X_ih_0_13 a_xp0 a_xn0 up_h13 un_h13 wp_ih_0_13 wn_ih_0_13 vdd dsyn
Vwp_ih_1_13 wp_ih_1_13 0 0.4833
Vwn_ih_1_13 wn_ih_1_13 0 0.3567
X_ih_1_13 a_xp1 a_xn1 up_h13 un_h13 wp_ih_1_13 wn_ih_1_13 vdd dsyn
Vwp_bk_13_0 wp_bk_13_0 0 0.4728
Vwn_bk_13_0 wn_bk_13_0 0 0.3672
X_bk_13_0 up_o0 un_o0 up_h13 un_h13 wp_bk_13_0 wn_bk_13_0 vdd dsyn
Vwp_bk_13_1 wp_bk_13_1 0 0.4453
Vwn_bk_13_1 wn_bk_13_1 0 0.3947
X_bk_13_1 up_o1 un_o1 up_h13 un_h13 wp_bk_13_1 wn_bk_13_1 vdd dsyn
Vwp_bh_13 wp_bh_13 0 0.3319
Vwn_bh_13 wn_bh_13 0 0.5081
X_bh_13 bp_hi bp_lo up_h13 un_h13 wp_bh_13 wn_bh_13 vdd dsyn
Mlp_h14 up_h14 up_h14 vdd vdd PNR W=1500u L=100u
Mln_h14 un_h14 un_h14 vdd vdd PNR W=1500u L=100u
Xn_h14 up_h14 un_h14 ap_h14 an_h14 vdd vbn dneuron
Vwp_ih_0_14 wp_ih_0_14 0 0.4221
Vwn_ih_0_14 wn_ih_0_14 0 0.4179
X_ih_0_14 a_xp0 a_xn0 up_h14 un_h14 wp_ih_0_14 wn_ih_0_14 vdd dsyn
Vwp_ih_1_14 wp_ih_1_14 0 0.4473
Vwn_ih_1_14 wn_ih_1_14 0 0.3927
X_ih_1_14 a_xp1 a_xn1 up_h14 un_h14 wp_ih_1_14 wn_ih_1_14 vdd dsyn
Vwp_bk_14_0 wp_bk_14_0 0 0.4602
Vwn_bk_14_0 wn_bk_14_0 0 0.3798
X_bk_14_0 up_o0 un_o0 up_h14 un_h14 wp_bk_14_0 wn_bk_14_0 vdd dsyn
Vwp_bk_14_1 wp_bk_14_1 0 0.3953
Vwn_bk_14_1 wn_bk_14_1 0 0.4447
X_bk_14_1 up_o1 un_o1 up_h14 un_h14 wp_bk_14_1 wn_bk_14_1 vdd dsyn
Vwp_bh_14 wp_bh_14 0 0.4929
Vwn_bh_14 wn_bh_14 0 0.3471
X_bh_14 bp_hi bp_lo up_h14 un_h14 wp_bh_14 wn_bh_14 vdd dsyn
Mlp_h15 up_h15 up_h15 vdd vdd PNR W=1500u L=100u
Mln_h15 un_h15 un_h15 vdd vdd PNR W=1500u L=100u
Xn_h15 up_h15 un_h15 ap_h15 an_h15 vdd vbn dneuron
Vwp_ih_0_15 wp_ih_0_15 0 0.3672
Vwn_ih_0_15 wn_ih_0_15 0 0.4728
X_ih_0_15 a_xp0 a_xn0 up_h15 un_h15 wp_ih_0_15 wn_ih_0_15 vdd dsyn
Vwp_ih_1_15 wp_ih_1_15 0 0.3935
Vwn_ih_1_15 wn_ih_1_15 0 0.4465
X_ih_1_15 a_xp1 a_xn1 up_h15 un_h15 wp_ih_1_15 wn_ih_1_15 vdd dsyn
Vwp_bk_15_0 wp_bk_15_0 0 0.4574
Vwn_bk_15_0 wn_bk_15_0 0 0.3826
X_bk_15_0 up_o0 un_o0 up_h15 un_h15 wp_bk_15_0 wn_bk_15_0 vdd dsyn
Vwp_bk_15_1 wp_bk_15_1 0 0.4220
Vwn_bk_15_1 wn_bk_15_1 0 0.4180
X_bk_15_1 up_o1 un_o1 up_h15 un_h15 wp_bk_15_1 wn_bk_15_1 vdd dsyn
Vwp_bh_15 wp_bh_15 0 0.5001
Vwn_bh_15 wn_bh_15 0 0.3399
X_bh_15 bp_hi bp_lo up_h15 un_h15 wp_bh_15 wn_bh_15 vdd dsyn
Mlp_h16 up_h16 up_h16 vdd vdd PNR W=1500u L=100u
Mln_h16 un_h16 un_h16 vdd vdd PNR W=1500u L=100u
Xn_h16 up_h16 un_h16 ap_h16 an_h16 vdd vbn dneuron
Vwp_ih_0_16 wp_ih_0_16 0 0.4275
Vwn_ih_0_16 wn_ih_0_16 0 0.4125
X_ih_0_16 a_xp0 a_xn0 up_h16 un_h16 wp_ih_0_16 wn_ih_0_16 vdd dsyn
Vwp_ih_1_16 wp_ih_1_16 0 0.3947
Vwn_ih_1_16 wn_ih_1_16 0 0.4453
X_ih_1_16 a_xp1 a_xn1 up_h16 un_h16 wp_ih_1_16 wn_ih_1_16 vdd dsyn
Vwp_bk_16_0 wp_bk_16_0 0 0.4049
Vwn_bk_16_0 wn_bk_16_0 0 0.4351
X_bk_16_0 up_o0 un_o0 up_h16 un_h16 wp_bk_16_0 wn_bk_16_0 vdd dsyn
Vwp_bk_16_1 wp_bk_16_1 0 0.3764
Vwn_bk_16_1 wn_bk_16_1 0 0.4636
X_bk_16_1 up_o1 un_o1 up_h16 un_h16 wp_bk_16_1 wn_bk_16_1 vdd dsyn
Vwp_bh_16 wp_bh_16 0 0.3689
Vwn_bh_16 wn_bh_16 0 0.4711
X_bh_16 bp_hi bp_lo up_h16 un_h16 wp_bh_16 wn_bh_16 vdd dsyn
Mlp_h17 up_h17 up_h17 vdd vdd PNR W=1500u L=100u
Mln_h17 un_h17 un_h17 vdd vdd PNR W=1500u L=100u
Xn_h17 up_h17 un_h17 ap_h17 an_h17 vdd vbn dneuron
Vwp_ih_0_17 wp_ih_0_17 0 0.4452
Vwn_ih_0_17 wn_ih_0_17 0 0.3948
X_ih_0_17 a_xp0 a_xn0 up_h17 un_h17 wp_ih_0_17 wn_ih_0_17 vdd dsyn
Vwp_ih_1_17 wp_ih_1_17 0 0.4432
Vwn_ih_1_17 wn_ih_1_17 0 0.3968
X_ih_1_17 a_xp1 a_xn1 up_h17 un_h17 wp_ih_1_17 wn_ih_1_17 vdd dsyn
Vwp_bk_17_0 wp_bk_17_0 0 0.4718
Vwn_bk_17_0 wn_bk_17_0 0 0.3682
X_bk_17_0 up_o0 un_o0 up_h17 un_h17 wp_bk_17_0 wn_bk_17_0 vdd dsyn
Vwp_bk_17_1 wp_bk_17_1 0 0.3898
Vwn_bk_17_1 wn_bk_17_1 0 0.4502
X_bk_17_1 up_o1 un_o1 up_h17 un_h17 wp_bk_17_1 wn_bk_17_1 vdd dsyn
Vwp_bh_17 wp_bh_17 0 0.4876
Vwn_bh_17 wn_bh_17 0 0.3524
X_bh_17 bp_hi bp_lo up_h17 un_h17 wp_bh_17 wn_bh_17 vdd dsyn
Mlp_h18 up_h18 up_h18 vdd vdd PNR W=1500u L=100u
Mln_h18 un_h18 un_h18 vdd vdd PNR W=1500u L=100u
Xn_h18 up_h18 un_h18 ap_h18 an_h18 vdd vbn dneuron
Vwp_ih_0_18 wp_ih_0_18 0 0.4085
Vwn_ih_0_18 wn_ih_0_18 0 0.4315
X_ih_0_18 a_xp0 a_xn0 up_h18 un_h18 wp_ih_0_18 wn_ih_0_18 vdd dsyn
Vwp_ih_1_18 wp_ih_1_18 0 0.4830
Vwn_ih_1_18 wn_ih_1_18 0 0.3570
X_ih_1_18 a_xp1 a_xn1 up_h18 un_h18 wp_ih_1_18 wn_ih_1_18 vdd dsyn
Vwp_bk_18_0 wp_bk_18_0 0 0.4027
Vwn_bk_18_0 wn_bk_18_0 0 0.4373
X_bk_18_0 up_o0 un_o0 up_h18 un_h18 wp_bk_18_0 wn_bk_18_0 vdd dsyn
Vwp_bk_18_1 wp_bk_18_1 0 0.3906
Vwn_bk_18_1 wn_bk_18_1 0 0.4494
X_bk_18_1 up_o1 un_o1 up_h18 un_h18 wp_bk_18_1 wn_bk_18_1 vdd dsyn
Vwp_bh_18 wp_bh_18 0 0.4300
Vwn_bh_18 wn_bh_18 0 0.4100
X_bh_18 bp_hi bp_lo up_h18 un_h18 wp_bh_18 wn_bh_18 vdd dsyn
Mlp_h19 up_h19 up_h19 vdd vdd PNR W=1500u L=100u
Mln_h19 un_h19 un_h19 vdd vdd PNR W=1500u L=100u
Xn_h19 up_h19 un_h19 ap_h19 an_h19 vdd vbn dneuron
Vwp_ih_0_19 wp_ih_0_19 0 0.4613
Vwn_ih_0_19 wn_ih_0_19 0 0.3787
X_ih_0_19 a_xp0 a_xn0 up_h19 un_h19 wp_ih_0_19 wn_ih_0_19 vdd dsyn
Vwp_ih_1_19 wp_ih_1_19 0 0.4264
Vwn_ih_1_19 wn_ih_1_19 0 0.4136
X_ih_1_19 a_xp1 a_xn1 up_h19 un_h19 wp_ih_1_19 wn_ih_1_19 vdd dsyn
Vwp_bk_19_0 wp_bk_19_0 0 0.3966
Vwn_bk_19_0 wn_bk_19_0 0 0.4434
X_bk_19_0 up_o0 un_o0 up_h19 un_h19 wp_bk_19_0 wn_bk_19_0 vdd dsyn
Vwp_bk_19_1 wp_bk_19_1 0 0.3664
Vwn_bk_19_1 wn_bk_19_1 0 0.4736
X_bk_19_1 up_o1 un_o1 up_h19 un_h19 wp_bk_19_1 wn_bk_19_1 vdd dsyn
Vwp_bh_19 wp_bh_19 0 0.3639
Vwn_bh_19 wn_bh_19 0 0.4761
X_bh_19 bp_hi bp_lo up_h19 un_h19 wp_bh_19 wn_bh_19 vdd dsyn
Mlp_h20 up_h20 up_h20 vdd vdd PNR W=1500u L=100u
Mln_h20 un_h20 un_h20 vdd vdd PNR W=1500u L=100u
Xn_h20 up_h20 un_h20 ap_h20 an_h20 vdd vbn dneuron
Vwp_ih_0_20 wp_ih_0_20 0 0.4401
Vwn_ih_0_20 wn_ih_0_20 0 0.3999
X_ih_0_20 a_xp0 a_xn0 up_h20 un_h20 wp_ih_0_20 wn_ih_0_20 vdd dsyn
Vwp_ih_1_20 wp_ih_1_20 0 0.4596
Vwn_ih_1_20 wn_ih_1_20 0 0.3804
X_ih_1_20 a_xp1 a_xn1 up_h20 un_h20 wp_ih_1_20 wn_ih_1_20 vdd dsyn
Vwp_bk_20_0 wp_bk_20_0 0 0.4134
Vwn_bk_20_0 wn_bk_20_0 0 0.4266
X_bk_20_0 up_o0 un_o0 up_h20 un_h20 wp_bk_20_0 wn_bk_20_0 vdd dsyn
Vwp_bk_20_1 wp_bk_20_1 0 0.3770
Vwn_bk_20_1 wn_bk_20_1 0 0.4630
X_bk_20_1 up_o1 un_o1 up_h20 un_h20 wp_bk_20_1 wn_bk_20_1 vdd dsyn
Vwp_bh_20 wp_bh_20 0 0.4549
Vwn_bh_20 wn_bh_20 0 0.3851
X_bh_20 bp_hi bp_lo up_h20 un_h20 wp_bh_20 wn_bh_20 vdd dsyn
Mlp_h21 up_h21 up_h21 vdd vdd PNR W=1500u L=100u
Mln_h21 un_h21 un_h21 vdd vdd PNR W=1500u L=100u
Xn_h21 up_h21 un_h21 ap_h21 an_h21 vdd vbn dneuron
Vwp_ih_0_21 wp_ih_0_21 0 0.3688
Vwn_ih_0_21 wn_ih_0_21 0 0.4712
X_ih_0_21 a_xp0 a_xn0 up_h21 un_h21 wp_ih_0_21 wn_ih_0_21 vdd dsyn
Vwp_ih_1_21 wp_ih_1_21 0 0.3915
Vwn_ih_1_21 wn_ih_1_21 0 0.4485
X_ih_1_21 a_xp1 a_xn1 up_h21 un_h21 wp_ih_1_21 wn_ih_1_21 vdd dsyn
Vwp_bk_21_0 wp_bk_21_0 0 0.4448
Vwn_bk_21_0 wn_bk_21_0 0 0.3952
X_bk_21_0 up_o0 un_o0 up_h21 un_h21 wp_bk_21_0 wn_bk_21_0 vdd dsyn
Vwp_bk_21_1 wp_bk_21_1 0 0.3300
Vwn_bk_21_1 wn_bk_21_1 0 0.5100
X_bk_21_1 up_o1 un_o1 up_h21 un_h21 wp_bk_21_1 wn_bk_21_1 vdd dsyn
Vwp_bh_21 wp_bh_21 0 0.4355
Vwn_bh_21 wn_bh_21 0 0.4045
X_bh_21 bp_hi bp_lo up_h21 un_h21 wp_bh_21 wn_bh_21 vdd dsyn
Mlp_h22 up_h22 up_h22 vdd vdd PNR W=1500u L=100u
Mln_h22 un_h22 un_h22 vdd vdd PNR W=1500u L=100u
Xn_h22 up_h22 un_h22 ap_h22 an_h22 vdd vbn dneuron
Vwp_ih_0_22 wp_ih_0_22 0 0.3967
Vwn_ih_0_22 wn_ih_0_22 0 0.4433
X_ih_0_22 a_xp0 a_xn0 up_h22 un_h22 wp_ih_0_22 wn_ih_0_22 vdd dsyn
Vwp_ih_1_22 wp_ih_1_22 0 0.4244
Vwn_ih_1_22 wn_ih_1_22 0 0.4156
X_ih_1_22 a_xp1 a_xn1 up_h22 un_h22 wp_ih_1_22 wn_ih_1_22 vdd dsyn
Vwp_bk_22_0 wp_bk_22_0 0 0.4170
Vwn_bk_22_0 wn_bk_22_0 0 0.4230
X_bk_22_0 up_o0 un_o0 up_h22 un_h22 wp_bk_22_0 wn_bk_22_0 vdd dsyn
Vwp_bk_22_1 wp_bk_22_1 0 0.4281
Vwn_bk_22_1 wn_bk_22_1 0 0.4119
X_bk_22_1 up_o1 un_o1 up_h22 un_h22 wp_bk_22_1 wn_bk_22_1 vdd dsyn
Vwp_bh_22 wp_bh_22 0 0.4478
Vwn_bh_22 wn_bh_22 0 0.3922
X_bh_22 bp_hi bp_lo up_h22 un_h22 wp_bh_22 wn_bh_22 vdd dsyn
Mlp_h23 up_h23 up_h23 vdd vdd PNR W=1500u L=100u
Mln_h23 un_h23 un_h23 vdd vdd PNR W=1500u L=100u
Xn_h23 up_h23 un_h23 ap_h23 an_h23 vdd vbn dneuron
Vwp_ih_0_23 wp_ih_0_23 0 0.3897
Vwn_ih_0_23 wn_ih_0_23 0 0.4503
X_ih_0_23 a_xp0 a_xn0 up_h23 un_h23 wp_ih_0_23 wn_ih_0_23 vdd dsyn
Vwp_ih_1_23 wp_ih_1_23 0 0.4768
Vwn_ih_1_23 wn_ih_1_23 0 0.3632
X_ih_1_23 a_xp1 a_xn1 up_h23 un_h23 wp_ih_1_23 wn_ih_1_23 vdd dsyn
Vwp_bk_23_0 wp_bk_23_0 0 0.4490
Vwn_bk_23_0 wn_bk_23_0 0 0.3910
X_bk_23_0 up_o0 un_o0 up_h23 un_h23 wp_bk_23_0 wn_bk_23_0 vdd dsyn
Vwp_bk_23_1 wp_bk_23_1 0 0.4537
Vwn_bk_23_1 wn_bk_23_1 0 0.3863
X_bk_23_1 up_o1 un_o1 up_h23 un_h23 wp_bk_23_1 wn_bk_23_1 vdd dsyn
Vwp_bh_23 wp_bh_23 0 0.4666
Vwn_bh_23 wn_bh_23 0 0.3734
X_bh_23 bp_hi bp_lo up_h23 un_h23 wp_bh_23 wn_bh_23 vdd dsyn
Mlp_o0 up_o0 up_o0 vdd vdd PNR W=7500u L=100u
Mln_o0 un_o0 un_o0 vdd vdd PNR W=7500u L=100u
Vwp_fo_0_0 wp_fo_0_0 0 0.4456
Vwn_fo_0_0 wn_fo_0_0 0 0.3944
X_fo_0_0 ap_h0 an_h0 up_o0 un_o0 wp_fo_0_0 wn_fo_0_0 vdd dsyn
Vwp_fo_1_0 wp_fo_1_0 0 0.4579
Vwn_fo_1_0 wn_fo_1_0 0 0.3821
X_fo_1_0 ap_h1 an_h1 up_o0 un_o0 wp_fo_1_0 wn_fo_1_0 vdd dsyn
Vwp_fo_2_0 wp_fo_2_0 0 0.3270
Vwn_fo_2_0 wn_fo_2_0 0 0.5130
X_fo_2_0 ap_h2 an_h2 up_o0 un_o0 wp_fo_2_0 wn_fo_2_0 vdd dsyn
Vwp_fo_3_0 wp_fo_3_0 0 0.4073
Vwn_fo_3_0 wn_fo_3_0 0 0.4327
X_fo_3_0 ap_h3 an_h3 up_o0 un_o0 wp_fo_3_0 wn_fo_3_0 vdd dsyn
Vwp_fo_4_0 wp_fo_4_0 0 0.3934
Vwn_fo_4_0 wn_fo_4_0 0 0.4466
X_fo_4_0 ap_h4 an_h4 up_o0 un_o0 wp_fo_4_0 wn_fo_4_0 vdd dsyn
Vwp_fo_5_0 wp_fo_5_0 0 0.3831
Vwn_fo_5_0 wn_fo_5_0 0 0.4569
X_fo_5_0 ap_h5 an_h5 up_o0 un_o0 wp_fo_5_0 wn_fo_5_0 vdd dsyn
Vwp_fo_6_0 wp_fo_6_0 0 0.4136
Vwn_fo_6_0 wn_fo_6_0 0 0.4264
X_fo_6_0 ap_h6 an_h6 up_o0 un_o0 wp_fo_6_0 wn_fo_6_0 vdd dsyn
Vwp_fo_7_0 wp_fo_7_0 0 0.4148
Vwn_fo_7_0 wn_fo_7_0 0 0.4252
X_fo_7_0 ap_h7 an_h7 up_o0 un_o0 wp_fo_7_0 wn_fo_7_0 vdd dsyn
Vwp_fo_8_0 wp_fo_8_0 0 0.4738
Vwn_fo_8_0 wn_fo_8_0 0 0.3662
X_fo_8_0 ap_h8 an_h8 up_o0 un_o0 wp_fo_8_0 wn_fo_8_0 vdd dsyn
Vwp_fo_9_0 wp_fo_9_0 0 0.4984
Vwn_fo_9_0 wn_fo_9_0 0 0.3416
X_fo_9_0 ap_h9 an_h9 up_o0 un_o0 wp_fo_9_0 wn_fo_9_0 vdd dsyn
Vwp_fo_10_0 wp_fo_10_0 0 0.4198
Vwn_fo_10_0 wn_fo_10_0 0 0.4202
X_fo_10_0 ap_h10 an_h10 up_o0 un_o0 wp_fo_10_0 wn_fo_10_0 vdd dsyn
Vwp_fo_11_0 wp_fo_11_0 0 0.4478
Vwn_fo_11_0 wn_fo_11_0 0 0.3922
X_fo_11_0 ap_h11 an_h11 up_o0 un_o0 wp_fo_11_0 wn_fo_11_0 vdd dsyn
Vwp_fo_12_0 wp_fo_12_0 0 0.4896
Vwn_fo_12_0 wn_fo_12_0 0 0.3504
X_fo_12_0 ap_h12 an_h12 up_o0 un_o0 wp_fo_12_0 wn_fo_12_0 vdd dsyn
Vwp_fo_13_0 wp_fo_13_0 0 0.4728
Vwn_fo_13_0 wn_fo_13_0 0 0.3672
X_fo_13_0 ap_h13 an_h13 up_o0 un_o0 wp_fo_13_0 wn_fo_13_0 vdd dsyn
Vwp_fo_14_0 wp_fo_14_0 0 0.4602
Vwn_fo_14_0 wn_fo_14_0 0 0.3798
X_fo_14_0 ap_h14 an_h14 up_o0 un_o0 wp_fo_14_0 wn_fo_14_0 vdd dsyn
Vwp_fo_15_0 wp_fo_15_0 0 0.4574
Vwn_fo_15_0 wn_fo_15_0 0 0.3826
X_fo_15_0 ap_h15 an_h15 up_o0 un_o0 wp_fo_15_0 wn_fo_15_0 vdd dsyn
Vwp_fo_16_0 wp_fo_16_0 0 0.4049
Vwn_fo_16_0 wn_fo_16_0 0 0.4351
X_fo_16_0 ap_h16 an_h16 up_o0 un_o0 wp_fo_16_0 wn_fo_16_0 vdd dsyn
Vwp_fo_17_0 wp_fo_17_0 0 0.4718
Vwn_fo_17_0 wn_fo_17_0 0 0.3682
X_fo_17_0 ap_h17 an_h17 up_o0 un_o0 wp_fo_17_0 wn_fo_17_0 vdd dsyn
Vwp_fo_18_0 wp_fo_18_0 0 0.4027
Vwn_fo_18_0 wn_fo_18_0 0 0.4373
X_fo_18_0 ap_h18 an_h18 up_o0 un_o0 wp_fo_18_0 wn_fo_18_0 vdd dsyn
Vwp_fo_19_0 wp_fo_19_0 0 0.3966
Vwn_fo_19_0 wn_fo_19_0 0 0.4434
X_fo_19_0 ap_h19 an_h19 up_o0 un_o0 wp_fo_19_0 wn_fo_19_0 vdd dsyn
Vwp_fo_20_0 wp_fo_20_0 0 0.4134
Vwn_fo_20_0 wn_fo_20_0 0 0.4266
X_fo_20_0 ap_h20 an_h20 up_o0 un_o0 wp_fo_20_0 wn_fo_20_0 vdd dsyn
Vwp_fo_21_0 wp_fo_21_0 0 0.4448
Vwn_fo_21_0 wn_fo_21_0 0 0.3952
X_fo_21_0 ap_h21 an_h21 up_o0 un_o0 wp_fo_21_0 wn_fo_21_0 vdd dsyn
Vwp_fo_22_0 wp_fo_22_0 0 0.4170
Vwn_fo_22_0 wn_fo_22_0 0 0.4230
X_fo_22_0 ap_h22 an_h22 up_o0 un_o0 wp_fo_22_0 wn_fo_22_0 vdd dsyn
Vwp_fo_23_0 wp_fo_23_0 0 0.4490
Vwn_fo_23_0 wn_fo_23_0 0 0.3910
X_fo_23_0 ap_h23 an_h23 up_o0 un_o0 wp_fo_23_0 wn_fo_23_0 vdd dsyn
Vwp_bo_0 wp_bo_0 0 0.4515
Vwn_bo_0 wn_bo_0 0 0.3885
X_bo_0 bp_hi bp_lo up_o0 un_o0 wp_bo_0 wn_bo_0 vdd dsyn
Rbp0 up_o0 vtp0 1e10
Rbn0 un_o0 vtn0 1e10
Mlp_o1 up_o1 up_o1 vdd vdd PNR W=7500u L=100u
Mln_o1 un_o1 un_o1 vdd vdd PNR W=7500u L=100u
Vwp_fo_0_1 wp_fo_0_1 0 0.4242
Vwn_fo_0_1 wn_fo_0_1 0 0.4158
X_fo_0_1 ap_h0 an_h0 up_o1 un_o1 wp_fo_0_1 wn_fo_0_1 vdd dsyn
Vwp_fo_1_1 wp_fo_1_1 0 0.3919
Vwn_fo_1_1 wn_fo_1_1 0 0.4481
X_fo_1_1 ap_h1 an_h1 up_o1 un_o1 wp_fo_1_1 wn_fo_1_1 vdd dsyn
Vwp_fo_2_1 wp_fo_2_1 0 0.4112
Vwn_fo_2_1 wn_fo_2_1 0 0.4288
X_fo_2_1 ap_h2 an_h2 up_o1 un_o1 wp_fo_2_1 wn_fo_2_1 vdd dsyn
Vwp_fo_3_1 wp_fo_3_1 0 0.4365
Vwn_fo_3_1 wn_fo_3_1 0 0.4035
X_fo_3_1 ap_h3 an_h3 up_o1 un_o1 wp_fo_3_1 wn_fo_3_1 vdd dsyn
Vwp_fo_4_1 wp_fo_4_1 0 0.4341
Vwn_fo_4_1 wn_fo_4_1 0 0.4059
X_fo_4_1 ap_h4 an_h4 up_o1 un_o1 wp_fo_4_1 wn_fo_4_1 vdd dsyn
Vwp_fo_5_1 wp_fo_5_1 0 0.4017
Vwn_fo_5_1 wn_fo_5_1 0 0.4383
X_fo_5_1 ap_h5 an_h5 up_o1 un_o1 wp_fo_5_1 wn_fo_5_1 vdd dsyn
Vwp_fo_6_1 wp_fo_6_1 0 0.4416
Vwn_fo_6_1 wn_fo_6_1 0 0.3984
X_fo_6_1 ap_h6 an_h6 up_o1 un_o1 wp_fo_6_1 wn_fo_6_1 vdd dsyn
Vwp_fo_7_1 wp_fo_7_1 0 0.4514
Vwn_fo_7_1 wn_fo_7_1 0 0.3886
X_fo_7_1 ap_h7 an_h7 up_o1 un_o1 wp_fo_7_1 wn_fo_7_1 vdd dsyn
Vwp_fo_8_1 wp_fo_8_1 0 0.4513
Vwn_fo_8_1 wn_fo_8_1 0 0.3887
X_fo_8_1 ap_h8 an_h8 up_o1 un_o1 wp_fo_8_1 wn_fo_8_1 vdd dsyn
Vwp_fo_9_1 wp_fo_9_1 0 0.4921
Vwn_fo_9_1 wn_fo_9_1 0 0.3479
X_fo_9_1 ap_h9 an_h9 up_o1 un_o1 wp_fo_9_1 wn_fo_9_1 vdd dsyn
Vwp_fo_10_1 wp_fo_10_1 0 0.4463
Vwn_fo_10_1 wn_fo_10_1 0 0.3937
X_fo_10_1 ap_h10 an_h10 up_o1 un_o1 wp_fo_10_1 wn_fo_10_1 vdd dsyn
Vwp_fo_11_1 wp_fo_11_1 0 0.3726
Vwn_fo_11_1 wn_fo_11_1 0 0.4674
X_fo_11_1 ap_h11 an_h11 up_o1 un_o1 wp_fo_11_1 wn_fo_11_1 vdd dsyn
Vwp_fo_12_1 wp_fo_12_1 0 0.4002
Vwn_fo_12_1 wn_fo_12_1 0 0.4398
X_fo_12_1 ap_h12 an_h12 up_o1 un_o1 wp_fo_12_1 wn_fo_12_1 vdd dsyn
Vwp_fo_13_1 wp_fo_13_1 0 0.4453
Vwn_fo_13_1 wn_fo_13_1 0 0.3947
X_fo_13_1 ap_h13 an_h13 up_o1 un_o1 wp_fo_13_1 wn_fo_13_1 vdd dsyn
Vwp_fo_14_1 wp_fo_14_1 0 0.3953
Vwn_fo_14_1 wn_fo_14_1 0 0.4447
X_fo_14_1 ap_h14 an_h14 up_o1 un_o1 wp_fo_14_1 wn_fo_14_1 vdd dsyn
Vwp_fo_15_1 wp_fo_15_1 0 0.4220
Vwn_fo_15_1 wn_fo_15_1 0 0.4180
X_fo_15_1 ap_h15 an_h15 up_o1 un_o1 wp_fo_15_1 wn_fo_15_1 vdd dsyn
Vwp_fo_16_1 wp_fo_16_1 0 0.3764
Vwn_fo_16_1 wn_fo_16_1 0 0.4636
X_fo_16_1 ap_h16 an_h16 up_o1 un_o1 wp_fo_16_1 wn_fo_16_1 vdd dsyn
Vwp_fo_17_1 wp_fo_17_1 0 0.3898
Vwn_fo_17_1 wn_fo_17_1 0 0.4502
X_fo_17_1 ap_h17 an_h17 up_o1 un_o1 wp_fo_17_1 wn_fo_17_1 vdd dsyn
Vwp_fo_18_1 wp_fo_18_1 0 0.3906
Vwn_fo_18_1 wn_fo_18_1 0 0.4494
X_fo_18_1 ap_h18 an_h18 up_o1 un_o1 wp_fo_18_1 wn_fo_18_1 vdd dsyn
Vwp_fo_19_1 wp_fo_19_1 0 0.3664
Vwn_fo_19_1 wn_fo_19_1 0 0.4736
X_fo_19_1 ap_h19 an_h19 up_o1 un_o1 wp_fo_19_1 wn_fo_19_1 vdd dsyn
Vwp_fo_20_1 wp_fo_20_1 0 0.3770
Vwn_fo_20_1 wn_fo_20_1 0 0.4630
X_fo_20_1 ap_h20 an_h20 up_o1 un_o1 wp_fo_20_1 wn_fo_20_1 vdd dsyn
Vwp_fo_21_1 wp_fo_21_1 0 0.3300
Vwn_fo_21_1 wn_fo_21_1 0 0.5100
X_fo_21_1 ap_h21 an_h21 up_o1 un_o1 wp_fo_21_1 wn_fo_21_1 vdd dsyn
Vwp_fo_22_1 wp_fo_22_1 0 0.4281
Vwn_fo_22_1 wn_fo_22_1 0 0.4119
X_fo_22_1 ap_h22 an_h22 up_o1 un_o1 wp_fo_22_1 wn_fo_22_1 vdd dsyn
Vwp_fo_23_1 wp_fo_23_1 0 0.4537
Vwn_fo_23_1 wn_fo_23_1 0 0.3863
X_fo_23_1 ap_h23 an_h23 up_o1 un_o1 wp_fo_23_1 wn_fo_23_1 vdd dsyn
Vwp_bo_1 wp_bo_1 0 0.4538
Vwn_bo_1 wn_bo_1 0 0.3862
X_bo_1 bp_hi bp_lo up_o1 un_o1 wp_bo_1 wn_bo_1 vdd dsyn
Rbp1 up_o1 vtp1 1e10
Rbn1 un_o1 vtn1 1e10
.nodeset v(up_h0)=0.5 v(un_h0)=0.5 v(ap_h0)=0.5 v(an_h0)=0.5 v(up_h1)=0.5 v(un_h1)=0.5 v(ap_h1)=0.5 v(an_h1)=0.5 v(up_h2)=0.5 v(un_h2)=0.5 v(ap_h2)=0.5 v(an_h2)=0.5 v(up_h3)=0.5 v(un_h3)=0.5 v(ap_h3)=0.5 v(an_h3)=0.5 v(up_h4)=0.5 v(un_h4)=0.5 v(ap_h4)=0.5 v(an_h4)=0.5 v(up_h5)=0.5 v(un_h5)=0.5 v(ap_h5)=0.5 v(an_h5)=0.5 v(up_h6)=0.5 v(un_h6)=0.5 v(ap_h6)=0.5 v(an_h6)=0.5 v(up_h7)=0.5 v(un_h7)=0.5 v(ap_h7)=0.5 v(an_h7)=0.5 v(up_h8)=0.5 v(un_h8)=0.5 v(ap_h8)=0.5 v(an_h8)=0.5 v(up_h9)=0.5 v(un_h9)=0.5 v(ap_h9)=0.5 v(an_h9)=0.5 v(up_h10)=0.5 v(un_h10)=0.5 v(ap_h10)=0.5 v(an_h10)=0.5 v(up_h11)=0.5 v(un_h11)=0.5 v(ap_h11)=0.5 v(an_h11)=0.5 v(up_h12)=0.5 v(un_h12)=0.5 v(ap_h12)=0.5 v(an_h12)=0.5 v(up_h13)=0.5 v(un_h13)=0.5 v(ap_h13)=0.5 v(an_h13)=0.5 v(up_h14)=0.5 v(un_h14)=0.5 v(ap_h14)=0.5 v(an_h14)=0.5 v(up_h15)=0.5 v(un_h15)=0.5 v(ap_h15)=0.5 v(an_h15)=0.5 v(up_h16)=0.5 v(un_h16)=0.5 v(ap_h16)=0.5 v(an_h16)=0.5 v(up_h17)=0.5 v(un_h17)=0.5 v(ap_h17)=0.5 v(an_h17)=0.5 v(up_h18)=0.5 v(un_h18)=0.5 v(ap_h18)=0.5 v(an_h18)=0.5 v(up_h19)=0.5 v(un_h19)=0.5 v(ap_h19)=0.5 v(an_h19)=0.5 v(up_h20)=0.5 v(un_h20)=0.5 v(ap_h20)=0.5 v(an_h20)=0.5 v(up_h21)=0.5 v(un_h21)=0.5 v(ap_h21)=0.5 v(an_h21)=0.5 v(up_h22)=0.5 v(un_h22)=0.5 v(ap_h22)=0.5 v(an_h22)=0.5 v(up_h23)=0.5 v(un_h23)=0.5 v(ap_h23)=0.5 v(an_h23)=0.5 v(up_o0)=0.5 v(un_o0)=0.5 v(up_o1)=0.5 v(un_o1)=0.5
.end
