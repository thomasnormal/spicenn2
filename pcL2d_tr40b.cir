pcL 2D
.model NNR NMOS (LEVEL=1 VTO=0.2 KP=120u LAMBDA=0.02 GAMMA=0 PHI=0.7)
.model PNR PMOS (LEVEL=1 VTO=-0.2 KP=40u LAMBDA=0.02 GAMMA=0 PHI=0.7)
.subckt gsyn inp inn wp wn outp outn vdd vbn
Mtail nt vbn 0 0 NNR W=400u L=100u
M5 na wp nt 0 NNR W=200u L=100u
M6 nb wn nt 0 NNR W=200u L=100u
M1 outp inp na 0 NNR W=200u L=100u
M2 outn inn na 0 NNR W=200u L=100u
M3 outn inp nb 0 NNR W=200u L=100u
M4 outp inn nb 0 NNR W=200u L=100u
.ends
.subckt cmld p n vdd
Rcs1 p cmx 300k
Rcs2 n cmx 300k
MLp p cmx vdd vdd PNR W=1000u L=100u
MLn n cmx vdd vdd PNR W=1000u L=100u
.ends
.subckt dneuron up un ap an vdd vbn
M1 an up tn 0 NNR W=200u L=100u
M2 ap un tn 0 NNR W=200u L=100u
Mt tn vbn 0 0 NNR W=200u L=100u
Xcm ap an vdd cmld
.ends
.subckt esub xp xn mp mn ep en vdd vbn
Mt nt vbn 0 0 NNR W=400u L=100u
M1x ep xn nt 0 NNR W=200u L=100u
M2x en xp nt 0 NNR W=200u L=100u
M1m ep mp nt 0 NNR W=200u L=100u
M2m en mn nt 0 NNR W=200u L=100u
RLp vdd ep 50k
RLn vdd en 50k
.ends
.subckt gprod xp xn yp yn wp wn vdd vbn
Mtail nt vbn 0 0 NNR W=400u L=100u
M5 na yp nt 0 NNR W=200u L=100u
M6 nb yn nt 0 NNR W=200u L=100u
M1 iop xp na 0 NNR W=200u L=100u
M2 ion xn na 0 NNR W=200u L=100u
M3 ion xp nb 0 NNR W=200u L=100u
M4 iop xn nb 0 NNR W=200u L=100u
Mlp iop iop vdd vdd PNR W=200u L=100u
Mln ion ion vdd vdd PNR W=200u L=100u
Mpu_wp wp iop vdd vdd PNR W=200u L=100u
MpRn nrn ion vdd vdd PNR W=200u L=100u
MnRn nrn nrn 0 0 NNR W=200u L=100u
Mpd_wp wp nrn 0 0 NNR W=200u L=100u
Mpu_wn wn ion vdd vdd PNR W=200u L=100u
MpRp nrp iop vdd vdd PNR W=200u L=100u
MnRp nrp nrp 0 0 NNR W=200u L=100u
Mpd_wn wn nrp 0 0 NNR W=200u L=100u
.ends
Vdd vdd 0 1.0
Vbsyn vbsyn 0 0.7
Vbneu vbneu 0 0.45
Vgm_h gm_h 0 0.6
Vgm_o gm_o 0 PWL(0 0.6 179999.9n 0.6 180000.0n 0)
Vgblh gblh 0 PWL(0 0.001 179999.9n 0.001 180000.0n 0)
Vgblo gblo 0 PWL(0 1.5 179999.9n 1.5 180000.0n 0)
Vwcm wcm 0 0.5
Vx1p a_xp1 0 PWL(0.0n 0.5864 249.9n 0.5864 250.0n 0.8333 499.9n 0.8333 500.0n 0.4240 749.9n 0.4240 750.0n 0.5367 999.9n 0.5367 1000.0n 0.4110 1249.9n 0.4110 1250.0n 0.3422 1499.9n 0.3422 1500.0n 0.5717 1749.9n 0.5717 1750.0n 0.8420 1999.9n 0.8420 2000.0n 0.5883 2249.9n 0.5883 2250.0n 0.4947 2499.9n 0.4947 2500.0n 0.6176 2749.9n 0.6176 2750.0n 0.4596 2999.9n 0.4596 3000.0n 0.1318 3249.9n 0.1318 3250.0n 0.3655 3499.9n 0.3655 3500.0n 0.0923 3749.9n 0.0923 3750.0n 0.1528 3999.9n 0.1528 4000.0n 0.8948 4249.9n 0.8948 4250.0n 0.2018 4499.9n 0.2018 4500.0n 0.6530 4749.9n 0.6530 4750.0n 0.5727 4999.9n 0.5727 5000.0n 0.0334 5249.9n 0.0334 5250.0n 0.4972 5499.9n 0.4972 5500.0n 0.6701 5749.9n 0.6701 5750.0n 0.6068 5999.9n 0.6068 6000.0n 0.4847 6249.9n 0.4847 6250.0n 0.5908 6499.9n 0.5908 6500.0n 0.3464 6749.9n 0.3464 6750.0n 0.4093 6999.9n 0.4093 7000.0n 0.6016 7249.9n 0.6016 7250.0n 0.8150 7499.9n 0.8150 7500.0n 0.3276 7749.9n 0.3276 7750.0n 0.7979 7999.9n 0.7979 8000.0n 0.4823 8249.9n 0.4823 8250.0n 0.4603 8499.9n 0.4603 8500.0n 0.9157 8749.9n 0.9157 8750.0n 0.7782 8999.9n 0.7782 9000.0n 0.5398 9249.9n 0.5398 9250.0n 0.5523 9499.9n 0.5523 9500.0n 0.2980 9749.9n 0.2980 9750.0n 0.7410 9999.9n 0.7410 10000.0n 0.1439 10249.9n 0.1439 10250.0n 0.2987 10499.9n 0.2987 10500.0n 0.4957 10749.9n 0.4957 10750.0n 0.4561 10999.9n 0.4561 11000.0n 0.1515 11249.9n 0.1515 11250.0n 0.6779 11499.9n 0.6779 11500.0n 0.5115 11749.9n 0.5115 11750.0n 0.4907 11999.9n 0.4907 12000.0n 0.9093 12249.9n 0.9093 12250.0n 0.4410 12499.9n 0.4410 12500.0n 0.6589 12749.9n 0.6589 12750.0n 0.4319 12999.9n 0.4319 13000.0n 0.6110 13249.9n 0.6110 13250.0n 0.5495 13499.9n 0.5495 13500.0n 0.4460 13749.9n 0.4460 13750.0n 0.1581 13999.9n 0.1581 14000.0n 0.3897 14249.9n 0.3897 14250.0n 0.3756 14499.9n 0.3756 14500.0n 0.3359 14749.9n 0.3359 14750.0n 0.6871 14999.9n 0.6871 15000.0n 0.5367 15249.9n 0.5367 15250.0n 0.5864 15499.9n 0.5864 15500.0n 0.8333 15749.9n 0.8333 15750.0n 0.1515 15999.9n 0.1515 16000.0n 0.4561 16249.9n 0.4561 16250.0n 0.9157 16499.9n 0.9157 16500.0n 0.4596 16749.9n 0.4596 16750.0n 0.4847 16999.9n 0.4847 17000.0n 0.3897 17249.9n 0.3897 17250.0n 0.6016 17499.9n 0.6016 17500.0n 0.4460 17749.9n 0.4460 17750.0n 0.3276 17999.9n 0.3276 18000.0n 0.4823 18249.9n 0.4823 18250.0n 0.7782 18499.9n 0.7782 18500.0n 0.4907 18749.9n 0.4907 18750.0n 0.1581 18999.9n 0.1581 19000.0n 0.6530 19249.9n 0.6530 19250.0n 0.4603 19499.9n 0.4603 19500.0n 0.3422 19749.9n 0.3422 19750.0n 0.5727 19999.9n 0.5727 20000.0n 0.3655 20249.9n 0.3655 20250.0n 0.1439 20499.9n 0.1439 20500.0n 0.2018 20749.9n 0.2018 20750.0n 0.3464 20999.9n 0.3464 21000.0n 0.4972 21249.9n 0.4972 21250.0n 0.9093 21499.9n 0.9093 21500.0n 0.0334 21749.9n 0.0334 21750.0n 0.5398 21999.9n 0.5398 22000.0n 0.6871 22249.9n 0.6871 22250.0n 0.7410 22499.9n 0.7410 22500.0n 0.4947 22749.9n 0.4947 22750.0n 0.5523 22999.9n 0.5523 23000.0n 0.4410 23249.9n 0.4410 23250.0n 0.2980 23499.9n 0.2980 23500.0n 0.8420 23749.9n 0.8420 23750.0n 0.5883 23999.9n 0.5883 24000.0n 0.4110 24249.9n 0.4110 24250.0n 0.3756 24499.9n 0.3756 24500.0n 0.6176 24749.9n 0.6176 24750.0n 0.4240 24999.9n 0.4240 25000.0n 0.6779 25249.9n 0.6779 25250.0n 0.6068 25499.9n 0.6068 25500.0n 0.5717 25749.9n 0.5717 25750.0n 0.5495 25999.9n 0.5495 26000.0n 0.4319 26249.9n 0.4319 26250.0n 0.6701 26499.9n 0.6701 26500.0n 0.4093 26749.9n 0.4093 26750.0n 0.1528 26999.9n 0.1528 27000.0n 0.5115 27249.9n 0.5115 27250.0n 0.6589 27499.9n 0.6589 27500.0n 0.0923 27749.9n 0.0923 27750.0n 0.4957 27999.9n 0.4957 28000.0n 0.8948 28249.9n 0.8948 28250.0n 0.3359 28499.9n 0.3359 28500.0n 0.8150 28749.9n 0.8150 28750.0n 0.2987 28999.9n 0.2987 29000.0n 0.5908 29249.9n 0.5908 29250.0n 0.7979 29499.9n 0.7979 29500.0n 0.6110 29749.9n 0.6110 29750.0n 0.1318 29999.9n 0.1318 30000.0n 0.8420 30249.9n 0.8420 30250.0n 0.4947 30499.9n 0.4947 30500.0n 0.5864 30749.9n 0.5864 30750.0n 0.9157 30999.9n 0.9157 31000.0n 0.1439 31249.9n 0.1439 31250.0n 0.5367 31499.9n 0.5367 31500.0n 0.2980 31749.9n 0.2980 31750.0n 0.0334 31999.9n 0.0334 32000.0n 0.7782 32249.9n 0.7782 32250.0n 0.6016 32499.9n 0.6016 32500.0n 0.3422 32749.9n 0.3422 32750.0n 0.4561 32999.9n 0.4561 33000.0n 0.4847 33249.9n 0.4847 33250.0n 0.8333 33499.9n 0.8333 33500.0n 0.6589 33749.9n 0.6589 33750.0n 0.2987 33999.9n 0.2987 34000.0n 0.1318 34249.9n 0.1318 34250.0n 0.5908 34499.9n 0.5908 34500.0n 0.7410 34749.9n 0.7410 34750.0n 0.6530 34999.9n 0.6530 35000.0n 0.5727 35249.9n 0.5727 35250.0n 0.6871 35499.9n 0.6871 35500.0n 0.5495 35749.9n 0.5495 35750.0n 0.3359 35999.9n 0.3359 36000.0n 0.2018 36249.9n 0.2018 36250.0n 0.3276 36499.9n 0.3276 36500.0n 0.5523 36749.9n 0.5523 36750.0n 0.4410 36999.9n 0.4410 37000.0n 0.9093 37249.9n 0.9093 37250.0n 0.3756 37499.9n 0.3756 37500.0n 0.5883 37749.9n 0.5883 37750.0n 0.4823 37999.9n 0.4823 38000.0n 0.5717 38249.9n 0.5717 38250.0n 0.0923 38499.9n 0.0923 38500.0n 0.4093 38749.9n 0.4093 38750.0n 0.4460 38999.9n 0.4460 39000.0n 0.4110 39249.9n 0.4110 39250.0n 0.6701 39499.9n 0.6701 39500.0n 0.4957 39749.9n 0.4957 39750.0n 0.6110 39999.9n 0.6110 40000.0n 0.1515 40249.9n 0.1515 40250.0n 0.4319 40499.9n 0.4319 40500.0n 0.4907 40749.9n 0.4907 40750.0n 0.3897 40999.9n 0.3897 41000.0n 0.3464 41249.9n 0.3464 41250.0n 0.4240 41499.9n 0.4240 41500.0n 0.6176 41749.9n 0.6176 41750.0n 0.5398 41999.9n 0.5398 42000.0n 0.1581 42249.9n 0.1581 42250.0n 0.4972 42499.9n 0.4972 42500.0n 0.8150 42749.9n 0.8150 42750.0n 0.6779 42999.9n 0.6779 43000.0n 0.4596 43249.9n 0.4596 43250.0n 0.7979 43499.9n 0.7979 43500.0n 0.6068 43749.9n 0.6068 43750.0n 0.1528 43999.9n 0.1528 44000.0n 0.8948 44249.9n 0.8948 44250.0n 0.5115 44499.9n 0.5115 44500.0n 0.4603 44749.9n 0.4603 44750.0n 0.3655 44999.9n 0.3655 45000.0n 0.6068 45249.9n 0.6068 45250.0n 0.4460 45499.9n 0.4460 45500.0n 0.5523 45749.9n 0.5523 45750.0n 0.3756 45999.9n 0.3756 46000.0n 0.4319 46249.9n 0.4319 46250.0n 0.3359 46499.9n 0.3359 46500.0n 0.0923 46749.9n 0.0923 46750.0n 0.4596 46999.9n 0.4596 47000.0n 0.7979 47249.9n 0.7979 47250.0n 0.2987 47499.9n 0.2987 47500.0n 0.9093 47749.9n 0.9093 47750.0n 0.6701 47999.9n 0.6701 48000.0n 0.3897 48249.9n 0.3897 48250.0n 0.1515 48499.9n 0.1515 48500.0n 0.8333 48749.9n 0.8333 48750.0n 0.2980 48999.9n 0.2980 49000.0n 0.3464 49249.9n 0.3464 49250.0n 0.9157 49499.9n 0.9157 49500.0n 0.4957 49749.9n 0.4957 49750.0n 0.1439 49999.9n 0.1439 50000.0n 0.1528 50249.9n 0.1528 50250.0n 0.1318 50499.9n 0.1318 50500.0n 0.6016 50749.9n 0.6016 50750.0n 0.4603 50999.9n 0.4603 51000.0n 0.1581 51249.9n 0.1581 51250.0n 0.7410 51499.9n 0.7410 51500.0n 0.4110 51749.9n 0.4110 51750.0n 0.3655 51999.9n 0.3655 52000.0n 0.6871 52249.9n 0.6871 52250.0n 0.5864 52499.9n 0.5864 52500.0n 0.3422 52749.9n 0.3422 52750.0n 0.8150 52999.9n 0.8150 53000.0n 0.4410 53249.9n 0.4410 53250.0n 0.4823 53499.9n 0.4823 53500.0n 0.5367 53749.9n 0.5367 53750.0n 0.3276 53999.9n 0.3276 54000.0n 0.2018 54249.9n 0.2018 54250.0n 0.7782 54499.9n 0.7782 54500.0n 0.8420 54749.9n 0.8420 54750.0n 0.4093 54999.9n 0.4093 55000.0n 0.6110 55249.9n 0.6110 55250.0n 0.6779 55499.9n 0.6779 55500.0n 0.4240 55749.9n 0.4240 55750.0n 0.4907 55999.9n 0.4907 56000.0n 0.5908 56249.9n 0.5908 56250.0n 0.4847 56499.9n 0.4847 56500.0n 0.6589 56749.9n 0.6589 56750.0n 0.5717 56999.9n 0.5717 57000.0n 0.6530 57249.9n 0.6530 57250.0n 0.5115 57499.9n 0.5115 57500.0n 0.4972 57749.9n 0.4972 57750.0n 0.8948 57999.9n 0.8948 58000.0n 0.0334 58249.9n 0.0334 58250.0n 0.4947 58499.9n 0.4947 58500.0n 0.4561 58749.9n 0.4561 58750.0n 0.5398 58999.9n 0.5398 59000.0n 0.5883 59249.9n 0.5883 59250.0n 0.6176 59499.9n 0.6176 59500.0n 0.5495 59749.9n 0.5495 59750.0n 0.5727 59999.9n 0.5727 60000.0n 0.1318 60249.9n 0.1318 60250.0n 0.2987 60499.9n 0.2987 60500.0n 0.5883 60749.9n 0.5883 60750.0n 0.1528 60999.9n 0.1528 61000.0n 0.5398 61249.9n 0.5398 61250.0n 0.6779 61499.9n 0.6779 61500.0n 0.4561 61749.9n 0.4561 61750.0n 0.3359 61999.9n 0.3359 62000.0n 0.4240 62249.9n 0.4240 62250.0n 0.5727 62499.9n 0.5727 62500.0n 0.5717 62749.9n 0.5717 62750.0n 0.4847 62999.9n 0.4847 63000.0n 0.3655 63249.9n 0.3655 63250.0n 0.4972 63499.9n 0.4972 63500.0n 0.9093 63749.9n 0.9093 63750.0n 0.0923 63999.9n 0.0923 64000.0n 0.3422 64249.9n 0.3422 64250.0n 0.6871 64499.9n 0.6871 64500.0n 0.7782 64749.9n 0.7782 64750.0n 0.3756 64999.9n 0.3756 65000.0n 0.1439 65249.9n 0.1439 65250.0n 0.8333 65499.9n 0.8333 65500.0n 0.3276 65749.9n 0.3276 65750.0n 0.5908 65999.9n 0.5908 66000.0n 0.4093 66249.9n 0.4093 66250.0n 0.5523 66499.9n 0.5523 66500.0n 0.3897 66749.9n 0.3897 66750.0n 0.5115 66999.9n 0.5115 67000.0n 0.6701 67249.9n 0.6701 67250.0n 0.2980 67499.9n 0.2980 67500.0n 0.4460 67749.9n 0.4460 67750.0n 0.4947 67999.9n 0.4947 68000.0n 0.2018 68249.9n 0.2018 68250.0n 0.7410 68499.9n 0.7410 68500.0n 0.8150 68749.9n 0.8150 68750.0n 0.3464 68999.9n 0.3464 69000.0n 0.1581 69249.9n 0.1581 69250.0n 0.8948 69499.9n 0.8948 69500.0n 0.5495 69749.9n 0.5495 69750.0n 0.7979 69999.9n 0.7979 70000.0n 0.4823 70249.9n 0.4823 70250.0n 0.6016 70499.9n 0.6016 70500.0n 0.9157 70749.9n 0.9157 70750.0n 0.6110 70999.9n 0.6110 71000.0n 0.4110 71249.9n 0.4110 71250.0n 0.6176 71499.9n 0.6176 71500.0n 0.8420 71749.9n 0.8420 71750.0n 0.6068 71999.9n 0.6068 72000.0n 0.4603 72249.9n 0.4603 72250.0n 0.5864 72499.9n 0.5864 72500.0n 0.6530 72749.9n 0.6530 72750.0n 0.1515 72999.9n 0.1515 73000.0n 0.5367 73249.9n 0.5367 73250.0n 0.4596 73499.9n 0.4596 73500.0n 0.4957 73749.9n 0.4957 73750.0n 0.6589 73999.9n 0.6589 74000.0n 0.4319 74249.9n 0.4319 74250.0n 0.4907 74499.9n 0.4907 74500.0n 0.4410 74749.9n 0.4410 74750.0n 0.0334 74999.9n 0.0334 75000.0n 0.4240 75249.9n 0.4240 75250.0n 0.0334 75499.9n 0.0334 75500.0n 0.4972 75749.9n 0.4972 75750.0n 0.8420 75999.9n 0.8420 76000.0n 0.1581 76249.9n 0.1581 76250.0n 0.4957 76499.9n 0.4957 76500.0n 0.7782 76749.9n 0.7782 76750.0n 0.4947 76999.9n 0.4947 77000.0n 0.4823 77249.9n 0.4823 77250.0n 0.9157 77499.9n 0.9157 77500.0n 0.3897 77749.9n 0.3897 77750.0n 0.3276 77999.9n 0.3276 78000.0n 0.3422 78249.9n 0.3422 78250.0n 0.5727 78499.9n 0.5727 78500.0n 0.5367 78749.9n 0.5367 78750.0n 0.3655 78999.9n 0.3655 79000.0n 0.8333 79249.9n 0.8333 79250.0n 0.5523 79499.9n 0.5523 79500.0n 0.8150 79749.9n 0.8150 79750.0n 0.4460 79999.9n 0.4460 80000.0n 0.1318 80249.9n 0.1318 80250.0n 0.3464 80499.9n 0.3464 80500.0n 0.6176 80749.9n 0.6176 80750.0n 0.4847 80999.9n 0.4847 81000.0n 0.4907 81249.9n 0.4907 81250.0n 0.5717 81499.9n 0.5717 81500.0n 0.5115 81749.9n 0.5115 81750.0n 0.9093 81999.9n 0.9093 82000.0n 0.4596 82249.9n 0.4596 82250.0n 0.6701 82499.9n 0.6701 82500.0n 0.0923 82749.9n 0.0923 82750.0n 0.6589 82999.9n 0.6589 83000.0n 0.4093 83249.9n 0.4093 83250.0n 0.1439 83499.9n 0.1439 83500.0n 0.6068 83749.9n 0.6068 83750.0n 0.4110 83999.9n 0.4110 84000.0n 0.1528 84249.9n 0.1528 84250.0n 0.2980 84499.9n 0.2980 84500.0n 0.6530 84749.9n 0.6530 84750.0n 0.5495 84999.9n 0.5495 85000.0n 0.4410 85249.9n 0.4410 85250.0n 0.6871 85499.9n 0.6871 85500.0n 0.4319 85749.9n 0.4319 85750.0n 0.7410 85999.9n 0.7410 86000.0n 0.8948 86249.9n 0.8948 86250.0n 0.5864 86499.9n 0.5864 86500.0n 0.6110 86749.9n 0.6110 86750.0n 0.2987 86999.9n 0.2987 87000.0n 0.4603 87249.9n 0.4603 87250.0n 0.5398 87499.9n 0.5398 87500.0n 0.3756 87749.9n 0.3756 87750.0n 0.6016 87999.9n 0.6016 88000.0n 0.6779 88249.9n 0.6779 88250.0n 0.1515 88499.9n 0.1515 88500.0n 0.2018 88749.9n 0.2018 88750.0n 0.3359 88999.9n 0.3359 89000.0n 0.4561 89249.9n 0.4561 89250.0n 0.7979 89499.9n 0.7979 89500.0n 0.5883 89749.9n 0.5883 89750.0n 0.5908 89999.9n 0.5908 90000.0n 0.3655 90249.9n 0.3655 90250.0n 0.8333 90499.9n 0.8333 90500.0n 0.5883 90749.9n 0.5883 90750.0n 0.4972 90999.9n 0.4972 91000.0n 0.6068 91249.9n 0.6068 91250.0n 0.5367 91499.9n 0.5367 91500.0n 0.3422 91749.9n 0.3422 91750.0n 0.5717 91999.9n 0.5717 92000.0n 0.1515 92249.9n 0.1515 92250.0n 0.6016 92499.9n 0.6016 92500.0n 0.3756 92749.9n 0.3756 92750.0n 0.5864 92999.9n 0.5864 93000.0n 0.4319 93249.9n 0.4319 93250.0n 0.5727 93499.9n 0.5727 93500.0n 0.1528 93749.9n 0.1528 93750.0n 0.8420 93999.9n 0.8420 94000.0n 0.4561 94249.9n 0.4561 94250.0n 0.4823 94499.9n 0.4823 94500.0n 0.6589 94749.9n 0.6589 94750.0n 0.2987 94999.9n 0.2987 95000.0n 0.4907 95249.9n 0.4907 95250.0n 0.5908 95499.9n 0.5908 95500.0n 0.6176 95749.9n 0.6176 95750.0n 0.1581 95999.9n 0.1581 96000.0n 0.6871 96249.9n 0.6871 96250.0n 0.7782 96499.9n 0.7782 96500.0n 0.0334 96749.9n 0.0334 96750.0n 0.6701 96999.9n 0.6701 97000.0n 0.4110 97249.9n 0.4110 97250.0n 0.4603 97499.9n 0.4603 97500.0n 0.5523 97749.9n 0.5523 97750.0n 0.2018 97999.9n 0.2018 98000.0n 0.6110 98249.9n 0.6110 98250.0n 0.6779 98499.9n 0.6779 98500.0n 0.5495 98749.9n 0.5495 98750.0n 0.3276 98999.9n 0.3276 99000.0n 0.5398 99249.9n 0.5398 99250.0n 0.7410 99499.9n 0.7410 99500.0n 0.1318 99749.9n 0.1318 99750.0n 0.8948 99999.9n 0.8948 100000.0n 0.5115 100249.9n 0.5115 100250.0n 0.4947 100499.9n 0.4947 100500.0n 0.4957 100749.9n 0.4957 100750.0n 0.9157 100999.9n 0.9157 101000.0n 0.4596 101249.9n 0.4596 101250.0n 0.2980 101499.9n 0.2980 101500.0n 0.7979 101749.9n 0.7979 101750.0n 0.0923 101999.9n 0.0923 102000.0n 0.1439 102249.9n 0.1439 102250.0n 0.4240 102499.9n 0.4240 102500.0n 0.9093 102749.9n 0.9093 102750.0n 0.4093 102999.9n 0.4093 103000.0n 0.3359 103249.9n 0.3359 103250.0n 0.3897 103499.9n 0.3897 103500.0n 0.4847 103749.9n 0.4847 103750.0n 0.8150 103999.9n 0.8150 104000.0n 0.6530 104249.9n 0.6530 104250.0n 0.3464 104499.9n 0.3464 104500.0n 0.4410 104749.9n 0.4410 104750.0n 0.4460 104999.9n 0.4460 105000.0n 0.4957 105249.9n 0.4957 105250.0n 0.3464 105499.9n 0.3464 105500.0n 0.7782 105749.9n 0.7782 105750.0n 0.2987 105999.9n 0.2987 106000.0n 0.8150 106249.9n 0.8150 106250.0n 0.4110 106499.9n 0.4110 106500.0n 0.3756 106749.9n 0.3756 106750.0n 0.1528 106999.9n 0.1528 107000.0n 0.2980 107249.9n 0.2980 107250.0n 0.4410 107499.9n 0.4410 107500.0n 0.3276 107749.9n 0.3276 107750.0n 0.5115 107999.9n 0.5115 108000.0n 0.3897 108249.9n 0.3897 108250.0n 0.3359 108499.9n 0.3359 108500.0n 0.4460 108749.9n 0.4460 108750.0n 0.9157 108999.9n 0.9157 109000.0n 0.0334 109249.9n 0.0334 109250.0n 0.6110 109499.9n 0.6110 109500.0n 0.4240 109749.9n 0.4240 109750.0n 0.5523 109999.9n 0.5523 110000.0n 0.8333 110249.9n 0.8333 110250.0n 0.5727 110499.9n 0.5727 110500.0n 0.6701 110749.9n 0.6701 110750.0n 0.5398 110999.9n 0.5398 111000.0n 0.8420 111249.9n 0.8420 111250.0n 0.6871 111499.9n 0.6871 111500.0n 0.5367 111749.9n 0.5367 111750.0n 0.7979 111999.9n 0.7979 112000.0n 0.4561 112249.9n 0.4561 112250.0n 0.0923 112499.9n 0.0923 112500.0n 0.4847 112749.9n 0.4847 112750.0n 0.2018 112999.9n 0.2018 113000.0n 0.4093 113249.9n 0.4093 113250.0n 0.5908 113499.9n 0.5908 113500.0n 0.3422 113749.9n 0.3422 113750.0n 0.6068 113999.9n 0.6068 114000.0n 0.4603 114249.9n 0.4603 114250.0n 0.6530 114499.9n 0.6530 114500.0n 0.4972 114749.9n 0.4972 114750.0n 0.8948 114999.9n 0.8948 115000.0n 0.5717 115249.9n 0.5717 115250.0n 0.4907 115499.9n 0.4907 115500.0n 0.9093 115749.9n 0.9093 115750.0n 0.4319 115999.9n 0.4319 116000.0n 0.1318 116249.9n 0.1318 116250.0n 0.5495 116499.9n 0.5495 116500.0n 0.6176 116749.9n 0.6176 116750.0n 0.4596 116999.9n 0.4596 117000.0n 0.6779 117249.9n 0.6779 117250.0n 0.4823 117499.9n 0.4823 117500.0n 0.1515 117749.9n 0.1515 117750.0n 0.3655 117999.9n 0.3655 118000.0n 0.4947 118249.9n 0.4947 118250.0n 0.1439 118499.9n 0.1439 118500.0n 0.6016 118749.9n 0.6016 118750.0n 0.6589 118999.9n 0.6589 119000.0n 0.1581 119249.9n 0.1581 119250.0n 0.5883 119499.9n 0.5883 119500.0n 0.5864 119749.9n 0.5864 119750.0n 0.7410 119999.9n 0.7410 120000.0n 0.5523 120249.9n 0.5523 120250.0n 0.2980 120499.9n 0.2980 120500.0n 0.4240 120749.9n 0.4240 120750.0n 0.4972 120999.9n 0.4972 121000.0n 0.8420 121249.9n 0.8420 121250.0n 0.4957 121499.9n 0.4957 121500.0n 0.9093 121749.9n 0.9093 121750.0n 0.1318 121999.9n 0.1318 122000.0n 0.6589 122249.9n 0.6589 122250.0n 0.8150 122499.9n 0.8150 122500.0n 0.3464 122749.9n 0.3464 122750.0n 0.8948 122999.9n 0.8948 123000.0n 0.7410 123249.9n 0.7410 123250.0n 0.9157 123499.9n 0.9157 123500.0n 0.4603 123749.9n 0.4603 123750.0n 0.1439 123999.9n 0.1439 124000.0n 0.4847 124249.9n 0.4847 124250.0n 0.4460 124499.9n 0.4460 124500.0n 0.7782 124749.9n 0.7782 124750.0n 0.4093 124999.9n 0.4093 125000.0n 0.6701 125249.9n 0.6701 125250.0n 0.3276 125499.9n 0.3276 125500.0n 0.6530 125749.9n 0.6530 125750.0n 0.0334 125999.9n 0.0334 126000.0n 0.5908 126249.9n 0.5908 126250.0n 0.3359 126499.9n 0.3359 126500.0n 0.6871 126749.9n 0.6871 126750.0n 0.4110 126999.9n 0.4110 127000.0n 0.4319 127249.9n 0.4319 127250.0n 0.5398 127499.9n 0.5398 127500.0n 0.3897 127749.9n 0.3897 127750.0n 0.2018 127999.9n 0.2018 128000.0n 0.5367 128249.9n 0.5367 128250.0n 0.3756 128499.9n 0.3756 128500.0n 0.1581 128749.9n 0.1581 128750.0n 0.4596 128999.9n 0.4596 129000.0n 0.6068 129249.9n 0.6068 129250.0n 0.3422 129499.9n 0.3422 129500.0n 0.4561 129749.9n 0.4561 129750.0n 0.4907 129999.9n 0.4907 130000.0n 0.5495 130249.9n 0.5495 130250.0n 0.5115 130499.9n 0.5115 130500.0n 0.3655 130749.9n 0.3655 130750.0n 0.5717 130999.9n 0.5717 131000.0n 0.5727 131249.9n 0.5727 131250.0n 0.6176 131499.9n 0.6176 131500.0n 0.5883 131749.9n 0.5883 131750.0n 0.4410 131999.9n 0.4410 132000.0n 0.6779 132249.9n 0.6779 132250.0n 0.0923 132499.9n 0.0923 132500.0n 0.4823 132749.9n 0.4823 132750.0n 0.2987 132999.9n 0.2987 133000.0n 0.7979 133249.9n 0.7979 133250.0n 0.6110 133499.9n 0.6110 133500.0n 0.8333 133749.9n 0.8333 133750.0n 0.1515 133999.9n 0.1515 134000.0n 0.1528 134249.9n 0.1528 134250.0n 0.6016 134499.9n 0.6016 134500.0n 0.4947 134749.9n 0.4947 134750.0n 0.5864 134999.9n 0.5864 135000.0n 0.2987 135249.9n 0.2987 135250.0n 0.6589 135499.9n 0.6589 135500.0n 0.5717 135749.9n 0.5717 135750.0n 0.3756 135999.9n 0.3756 136000.0n 0.4110 136249.9n 0.4110 136250.0n 0.6871 136499.9n 0.6871 136500.0n 0.4596 136749.9n 0.4596 136750.0n 0.6701 136999.9n 0.6701 137000.0n 0.0334 137249.9n 0.0334 137250.0n 0.5495 137499.9n 0.5495 137500.0n 0.4947 137749.9n 0.4947 137750.0n 0.2980 137999.9n 0.2980 138000.0n 0.8420 138249.9n 0.8420 138250.0n 0.4410 138499.9n 0.4410 138500.0n 0.8333 138749.9n 0.8333 138750.0n 0.2018 138999.9n 0.2018 139000.0n 0.4561 139249.9n 0.4561 139250.0n 0.6068 139499.9n 0.6068 139500.0n 0.3897 139749.9n 0.3897 139750.0n 0.6110 139999.9n 0.6110 140000.0n 0.3464 140249.9n 0.3464 140250.0n 0.7410 140499.9n 0.7410 140500.0n 0.7782 140749.9n 0.7782 140750.0n 0.6016 140999.9n 0.6016 141000.0n 0.5883 141249.9n 0.5883 141250.0n 0.5727 141499.9n 0.5727 141500.0n 0.8150 141749.9n 0.8150 141750.0n 0.3359 141999.9n 0.3359 142000.0n 0.4093 142249.9n 0.4093 142250.0n 0.4823 142499.9n 0.4823 142500.0n 0.6530 142749.9n 0.6530 142750.0n 0.9093 142999.9n 0.9093 143000.0n 0.9157 143249.9n 0.9157 143250.0n 0.4460 143499.9n 0.4460 143500.0n 0.5908 143749.9n 0.5908 143750.0n 0.4972 143999.9n 0.4972 144000.0n 0.6779 144249.9n 0.6779 144250.0n 0.4603 144499.9n 0.4603 144500.0n 0.3655 144749.9n 0.3655 144750.0n 0.3422 144999.9n 0.3422 145000.0n 0.5523 145249.9n 0.5523 145250.0n 0.5864 145499.9n 0.5864 145500.0n 0.1318 145749.9n 0.1318 145750.0n 0.8948 145999.9n 0.8948 146000.0n 0.4907 146249.9n 0.4907 146250.0n 0.7979 146499.9n 0.7979 146500.0n 0.4847 146749.9n 0.4847 146750.0n 0.5398 146999.9n 0.5398 147000.0n 0.1515 147249.9n 0.1515 147250.0n 0.1439 147499.9n 0.1439 147500.0n 0.1581 147749.9n 0.1581 147750.0n 0.4240 147999.9n 0.4240 148000.0n 0.4957 148249.9n 0.4957 148250.0n 0.0923 148499.9n 0.0923 148500.0n 0.3276 148749.9n 0.3276 148750.0n 0.5367 148999.9n 0.5367 149000.0n 0.1528 149249.9n 0.1528 149250.0n 0.6176 149499.9n 0.6176 149500.0n 0.5115 149749.9n 0.5115 149750.0n 0.4319 149999.9n 0.4319 150000.0n 0.5883 150249.9n 0.5883 150250.0n 0.5115 150499.9n 0.5115 150500.0n 0.3359 150749.9n 0.3359 150750.0n 0.3276 150999.9n 0.3276 151000.0n 0.6016 151249.9n 0.6016 151250.0n 0.8420 151499.9n 0.8420 151500.0n 0.8150 151749.9n 0.8150 151750.0n 0.3756 151999.9n 0.3756 152000.0n 0.2018 152249.9n 0.2018 152250.0n 0.6530 152499.9n 0.6530 152500.0n 0.1581 152749.9n 0.1581 152750.0n 0.4460 152999.9n 0.4460 153000.0n 0.2987 153249.9n 0.2987 153250.0n 0.6871 153499.9n 0.6871 153500.0n 0.2980 153749.9n 0.2980 153750.0n 0.7410 153999.9n 0.7410 154000.0n 0.5495 154249.9n 0.5495 154250.0n 0.7782 154499.9n 0.7782 154500.0n 0.4093 154749.9n 0.4093 154750.0n 0.4110 154999.9n 0.4110 155000.0n 0.4603 155249.9n 0.4603 155250.0n 0.6701 155499.9n 0.6701 155500.0n 0.0334 155749.9n 0.0334 155750.0n 0.3655 155999.9n 0.3655 156000.0n 0.6779 156249.9n 0.6779 156250.0n 0.4847 156499.9n 0.4847 156500.0n 0.5398 156749.9n 0.5398 156750.0n 0.8333 156999.9n 0.8333 157000.0n 0.1528 157249.9n 0.1528 157250.0n 0.6589 157499.9n 0.6589 157500.0n 0.5908 157749.9n 0.5908 157750.0n 0.4596 157999.9n 0.4596 158000.0n 0.5727 158249.9n 0.5727 158250.0n 0.1318 158499.9n 0.1318 158500.0n 0.5864 158749.9n 0.5864 158750.0n 0.4319 158999.9n 0.4319 159000.0n 0.4972 159249.9n 0.4972 159250.0n 0.5367 159499.9n 0.5367 159500.0n 0.5523 159749.9n 0.5523 159750.0n 0.4410 159999.9n 0.4410 160000.0n 0.8948 160249.9n 0.8948 160250.0n 0.7979 160499.9n 0.7979 160500.0n 0.9093 160749.9n 0.9093 160750.0n 0.3464 160999.9n 0.3464 161000.0n 0.4823 161249.9n 0.4823 161250.0n 0.3422 161499.9n 0.3422 161500.0n 0.6110 161749.9n 0.6110 161750.0n 0.4561 161999.9n 0.4561 162000.0n 0.1439 162249.9n 0.1439 162250.0n 0.6176 162499.9n 0.6176 162500.0n 0.4907 162749.9n 0.4907 162750.0n 0.9157 162999.9n 0.9157 163000.0n 0.1515 163249.9n 0.1515 163250.0n 0.4240 163499.9n 0.4240 163500.0n 0.5717 163749.9n 0.5717 163750.0n 0.4957 163999.9n 0.4957 164000.0n 0.0923 164249.9n 0.0923 164250.0n 0.4947 164499.9n 0.4947 164500.0n 0.6068 164749.9n 0.6068 164750.0n 0.3897 164999.9n 0.3897 165000.0n 0.4460 165249.9n 0.4460 165250.0n 0.3655 165499.9n 0.3655 165500.0n 0.7410 165749.9n 0.7410 165750.0n 0.3897 165999.9n 0.3897 166000.0n 0.5495 166249.9n 0.5495 166250.0n 0.4596 166499.9n 0.4596 166500.0n 0.3756 166749.9n 0.3756 166750.0n 0.5115 166999.9n 0.5115 167000.0n 0.4319 167249.9n 0.4319 167250.0n 0.6176 167499.9n 0.6176 167500.0n 0.5367 167749.9n 0.5367 167750.0n 0.5523 167999.9n 0.5523 168000.0n 0.2987 168249.9n 0.2987 168250.0n 0.0334 168499.9n 0.0334 168500.0n 0.7979 168749.9n 0.7979 168750.0n 0.3359 168999.9n 0.3359 169000.0n 0.4110 169249.9n 0.4110 169250.0n 0.8948 169499.9n 0.8948 169500.0n 0.4947 169749.9n 0.4947 169750.0n 0.4823 169999.9n 0.4823 170000.0n 0.4240 170249.9n 0.4240 170250.0n 0.2018 170499.9n 0.2018 170500.0n 0.5883 170749.9n 0.5883 170750.0n 0.6530 170999.9n 0.6530 171000.0n 0.1318 171249.9n 0.1318 171250.0n 0.4561 171499.9n 0.4561 171500.0n 0.0923 171749.9n 0.0923 171750.0n 0.7782 171999.9n 0.7782 172000.0n 0.6016 172249.9n 0.6016 172250.0n 0.5908 172499.9n 0.5908 172500.0n 0.5727 172749.9n 0.5727 172750.0n 0.1528 172999.9n 0.1528 173000.0n 0.8420 173249.9n 0.8420 173250.0n 0.6871 173499.9n 0.6871 173500.0n 0.3276 173749.9n 0.3276 173750.0n 0.9157 173999.9n 0.9157 174000.0n 0.5398 174249.9n 0.5398 174250.0n 0.1515 174499.9n 0.1515 174500.0n 0.6110 174749.9n 0.6110 174750.0n 0.3422 174999.9n 0.3422 175000.0n 0.6589 175249.9n 0.6589 175250.0n 0.6701 175499.9n 0.6701 175500.0n 0.1439 175749.9n 0.1439 175750.0n 0.8150 175999.9n 0.8150 176000.0n 0.4410 176249.9n 0.4410 176250.0n 0.4847 176499.9n 0.4847 176500.0n 0.8333 176749.9n 0.8333 176750.0n 0.4093 176999.9n 0.4093 177000.0n 0.2980 177249.9n 0.2980 177250.0n 0.5717 177499.9n 0.5717 177500.0n 0.1581 177749.9n 0.1581 177750.0n 0.4972 177999.9n 0.4972 178000.0n 0.4603 178249.9n 0.4603 178250.0n 0.4907 178499.9n 0.4907 178500.0n 0.6068 178749.9n 0.6068 178750.0n 0.6779 178999.9n 0.6779 179000.0n 0.3464 179249.9n 0.3464 179250.0n 0.5864 179499.9n 0.5864 179500.0n 0.9093 179749.9n 0.9093 179750.0n 0.4957 179999.9n 0.4957 180000.0n 0.7862 180249.9n 0.7862 180250.0n 0.2681 180499.9n 0.2681 180500.0n 0.7669 180749.9n 0.7669 180750.0n 0.5529 180999.9n 0.5529 181000.0n 0.5987 181249.9n 0.5987 181250.0n 0.0543 181499.9n 0.0543 181500.0n 0.4903 181749.9n 0.4903 181750.0n 0.1277 181999.9n 0.1277 182000.0n 0.5027 182249.9n 0.5027 182250.0n 0.3940 182499.9n 0.3940 182500.0n 0.7589 182749.9n 0.7589 182750.0n 0.4688 182999.9n 0.4688 183000.0n 0.6135 183249.9n 0.6135 183250.0n 0.4859 183499.9n 0.4859 183500.0n 0.8917 183749.9n 0.8917 183750.0n 0.9386 183999.9n 0.9386 184000.0n 0.1432 184249.9n 0.1432 184250.0n 0.3736 184499.9n 0.3736 184500.0n 0.6971 184749.9n 0.6971 184750.0n 0.3183 184999.9n 0.3183 185000.0n 0.5646 185249.9n 0.5646 185250.0n 0.4138 185499.9n 0.4138 185500.0n 0.3857 185749.9n 0.3857 185750.0n 0.6198 185999.9n 0.6198 186000.0n 0.6320 186249.9n 0.6320 186250.0n 0.1879 186499.9n 0.1879 186500.0n 0.5510 186749.9n 0.5510 186750.0n 0.4071 186999.9n 0.4071 187000.0n 0.6952 187249.9n 0.6952 187250.0n 0.1733 187499.9n 0.1733 187500.0n 0.5260 187749.9n 0.5260 187750.0n 0.4479 187999.9n 0.4479 188000.0n 0.0662 188249.9n 0.0662 188250.0n 0.6344 188499.9n 0.6344 188500.0n 0.4378 188749.9n 0.4378 188750.0n 0.4666 188999.9n 0.4666 189000.0n 0.2226 189249.9n 0.2226 189250.0n 0.1684 189499.9n 0.1684 189500.0n 0.4887 189749.9n 0.4887 189750.0n 0.3912 189999.9n 0.3912 190000.0n 0.6331 190249.9n 0.6331 190250.0n 0.0916 190499.9n 0.0916 190500.0n 0.1896 190749.9n 0.1896 190750.0n 0.3937 190999.9n 0.3937 191000.0n 0.8125 191249.9n 0.8125 191250.0n 0.8888 191499.9n 0.8888 191500.0n 0.5216 191749.9n 0.5216 191750.0n 0.9119 191999.9n 0.9119 192000.0n 0.4149 192249.9n 0.4149 192250.0n 0.5958 192499.9n 0.5958 192500.0n 0.3037 192749.9n 0.3037 192750.0n 0.8943 192999.9n 0.8943 193000.0n 0.5708 193249.9n 0.5708 193250.0n 0.3608 193499.9n 0.3608 193500.0n 0.4865 193749.9n 0.4865 193750.0n 0.5433 193999.9n 0.5433 194000.0n 0.5941 194249.9n 0.5941 194250.0n 0.1528 194499.9n 0.1528 194500.0n 0.6346 194749.9n 0.6346 194750.0n 0.5209 194999.9n 0.5209 195000.0n 0.4645 195249.9n 0.4645 195250.0n 0.4957 195499.9n 0.4957 195500.0n 0.3720 195749.9n 0.3720 195750.0n 0.3352 195999.9n 0.3352 196000.0n 0.9541 196249.9n 0.9541 196250.0n 0.6681 196499.9n 0.6681 196500.0n 0.3664 196749.9n 0.3664 196750.0n 0.7930 196999.9n 0.7930 197000.0n 0.3627 197249.9n 0.3627 197250.0n 0.3181 197499.9n 0.3181 197500.0n 0.4717 197749.9n 0.4717 197750.0n 0.4193 197999.9n 0.4193 198000.0n 0.5941 198249.9n 0.5941 198250.0n 0.1752 198499.9n 0.1752 198500.0n 0.3574 198749.9n 0.3574 198750.0n 0.7938 198999.9n 0.7938 199000.0n 0.6578 199249.9n 0.6578 199250.0n 0.4866 199499.9n 0.4866 199500.0n 0.1821 199749.9n 0.1821 199750.0n 0.9426 199999.9n 0.9426 200000.0n 0.5574 200249.9n 0.5574 200250.0n 0.5475 200499.9n 0.5475 200500.0n 0.4601 200749.9n 0.4601 200750.0n 0.5278 200999.9n 0.5278 201000.0n 0.6854 201249.9n 0.6854 201250.0n 0.5603 201499.9n 0.5603 201500.0n 0.5420 201749.9n 0.5420 201750.0n 0.4338 201999.9n 0.4338 202000.0n 0.6646 202249.9n 0.6646 202250.0n 0.3749 202499.9n 0.3749 202500.0n 0.1742 202749.9n 0.1742 202750.0n 0.4073 202999.9n 0.4073 203000.0n 0.7919 203249.9n 0.7919 203250.0n 0.4282 203499.9n 0.4282 203500.0n 0.5414 203749.9n 0.5414 203750.0n 0.8375 203999.9n 0.8375 204000.0n 0.3672 204249.9n 0.3672 204250.0n 0.6522 204499.9n 0.6522 204500.0n 0.2097 204749.9n 0.2097 204750.0n 0.5170 204999.9n 0.5170 205000.0n 0.4734 205249.9n 0.4734 205250.0n 0.4382 205499.9n 0.4382 205500.0n 0.5660 205749.9n 0.5660 205750.0n 0.4134 205999.9n 0.4134 206000.0n 0.2348 206249.9n 0.2348 206250.0n 0.4806 206499.9n 0.4806 206500.0n 0.4131 206749.9n 0.4131 206750.0n 0.2064 206999.9n 0.2064 207000.0n 0.9118 207249.9n 0.9118 207250.0n 0.5609 207499.9n 0.5609 207500.0n 0.1784 207749.9n 0.1784 207750.0n 0.3829 207999.9n 0.3829 208000.0n 0.2288 208249.9n 0.2288 208250.0n 0.5872 208499.9n 0.5872 208500.0n 0.6060 208749.9n 0.6060 208750.0n 0.5092 208999.9n 0.5092 209000.0n 0.4833 209249.9n 0.4833 209250.0n 0.4728 209499.9n 0.4728 209500.0n 0.5093 209749.9n 0.5093 209750.0n 0.8176)
Vx1n a_xn1 0 PWL(0.0n 0.4136 249.9n 0.4136 250.0n 0.1667 499.9n 0.1667 500.0n 0.5760 749.9n 0.5760 750.0n 0.4633 999.9n 0.4633 1000.0n 0.5890 1249.9n 0.5890 1250.0n 0.6578 1499.9n 0.6578 1500.0n 0.4283 1749.9n 0.4283 1750.0n 0.1580 1999.9n 0.1580 2000.0n 0.4117 2249.9n 0.4117 2250.0n 0.5053 2499.9n 0.5053 2500.0n 0.3824 2749.9n 0.3824 2750.0n 0.5404 2999.9n 0.5404 3000.0n 0.8682 3249.9n 0.8682 3250.0n 0.6345 3499.9n 0.6345 3500.0n 0.9077 3749.9n 0.9077 3750.0n 0.8472 3999.9n 0.8472 4000.0n 0.1052 4249.9n 0.1052 4250.0n 0.7982 4499.9n 0.7982 4500.0n 0.3470 4749.9n 0.3470 4750.0n 0.4273 4999.9n 0.4273 5000.0n 0.9666 5249.9n 0.9666 5250.0n 0.5028 5499.9n 0.5028 5500.0n 0.3299 5749.9n 0.3299 5750.0n 0.3932 5999.9n 0.3932 6000.0n 0.5153 6249.9n 0.5153 6250.0n 0.4092 6499.9n 0.4092 6500.0n 0.6536 6749.9n 0.6536 6750.0n 0.5907 6999.9n 0.5907 7000.0n 0.3984 7249.9n 0.3984 7250.0n 0.1850 7499.9n 0.1850 7500.0n 0.6724 7749.9n 0.6724 7750.0n 0.2021 7999.9n 0.2021 8000.0n 0.5177 8249.9n 0.5177 8250.0n 0.5397 8499.9n 0.5397 8500.0n 0.0843 8749.9n 0.0843 8750.0n 0.2218 8999.9n 0.2218 9000.0n 0.4602 9249.9n 0.4602 9250.0n 0.4477 9499.9n 0.4477 9500.0n 0.7020 9749.9n 0.7020 9750.0n 0.2590 9999.9n 0.2590 10000.0n 0.8561 10249.9n 0.8561 10250.0n 0.7013 10499.9n 0.7013 10500.0n 0.5043 10749.9n 0.5043 10750.0n 0.5439 10999.9n 0.5439 11000.0n 0.8485 11249.9n 0.8485 11250.0n 0.3221 11499.9n 0.3221 11500.0n 0.4885 11749.9n 0.4885 11750.0n 0.5093 11999.9n 0.5093 12000.0n 0.0907 12249.9n 0.0907 12250.0n 0.5590 12499.9n 0.5590 12500.0n 0.3411 12749.9n 0.3411 12750.0n 0.5681 12999.9n 0.5681 13000.0n 0.3890 13249.9n 0.3890 13250.0n 0.4505 13499.9n 0.4505 13500.0n 0.5540 13749.9n 0.5540 13750.0n 0.8419 13999.9n 0.8419 14000.0n 0.6103 14249.9n 0.6103 14250.0n 0.6244 14499.9n 0.6244 14500.0n 0.6641 14749.9n 0.6641 14750.0n 0.3129 14999.9n 0.3129 15000.0n 0.4633 15249.9n 0.4633 15250.0n 0.4136 15499.9n 0.4136 15500.0n 0.1667 15749.9n 0.1667 15750.0n 0.8485 15999.9n 0.8485 16000.0n 0.5439 16249.9n 0.5439 16250.0n 0.0843 16499.9n 0.0843 16500.0n 0.5404 16749.9n 0.5404 16750.0n 0.5153 16999.9n 0.5153 17000.0n 0.6103 17249.9n 0.6103 17250.0n 0.3984 17499.9n 0.3984 17500.0n 0.5540 17749.9n 0.5540 17750.0n 0.6724 17999.9n 0.6724 18000.0n 0.5177 18249.9n 0.5177 18250.0n 0.2218 18499.9n 0.2218 18500.0n 0.5093 18749.9n 0.5093 18750.0n 0.8419 18999.9n 0.8419 19000.0n 0.3470 19249.9n 0.3470 19250.0n 0.5397 19499.9n 0.5397 19500.0n 0.6578 19749.9n 0.6578 19750.0n 0.4273 19999.9n 0.4273 20000.0n 0.6345 20249.9n 0.6345 20250.0n 0.8561 20499.9n 0.8561 20500.0n 0.7982 20749.9n 0.7982 20750.0n 0.6536 20999.9n 0.6536 21000.0n 0.5028 21249.9n 0.5028 21250.0n 0.0907 21499.9n 0.0907 21500.0n 0.9666 21749.9n 0.9666 21750.0n 0.4602 21999.9n 0.4602 22000.0n 0.3129 22249.9n 0.3129 22250.0n 0.2590 22499.9n 0.2590 22500.0n 0.5053 22749.9n 0.5053 22750.0n 0.4477 22999.9n 0.4477 23000.0n 0.5590 23249.9n 0.5590 23250.0n 0.7020 23499.9n 0.7020 23500.0n 0.1580 23749.9n 0.1580 23750.0n 0.4117 23999.9n 0.4117 24000.0n 0.5890 24249.9n 0.5890 24250.0n 0.6244 24499.9n 0.6244 24500.0n 0.3824 24749.9n 0.3824 24750.0n 0.5760 24999.9n 0.5760 25000.0n 0.3221 25249.9n 0.3221 25250.0n 0.3932 25499.9n 0.3932 25500.0n 0.4283 25749.9n 0.4283 25750.0n 0.4505 25999.9n 0.4505 26000.0n 0.5681 26249.9n 0.5681 26250.0n 0.3299 26499.9n 0.3299 26500.0n 0.5907 26749.9n 0.5907 26750.0n 0.8472 26999.9n 0.8472 27000.0n 0.4885 27249.9n 0.4885 27250.0n 0.3411 27499.9n 0.3411 27500.0n 0.9077 27749.9n 0.9077 27750.0n 0.5043 27999.9n 0.5043 28000.0n 0.1052 28249.9n 0.1052 28250.0n 0.6641 28499.9n 0.6641 28500.0n 0.1850 28749.9n 0.1850 28750.0n 0.7013 28999.9n 0.7013 29000.0n 0.4092 29249.9n 0.4092 29250.0n 0.2021 29499.9n 0.2021 29500.0n 0.3890 29749.9n 0.3890 29750.0n 0.8682 29999.9n 0.8682 30000.0n 0.1580 30249.9n 0.1580 30250.0n 0.5053 30499.9n 0.5053 30500.0n 0.4136 30749.9n 0.4136 30750.0n 0.0843 30999.9n 0.0843 31000.0n 0.8561 31249.9n 0.8561 31250.0n 0.4633 31499.9n 0.4633 31500.0n 0.7020 31749.9n 0.7020 31750.0n 0.9666 31999.9n 0.9666 32000.0n 0.2218 32249.9n 0.2218 32250.0n 0.3984 32499.9n 0.3984 32500.0n 0.6578 32749.9n 0.6578 32750.0n 0.5439 32999.9n 0.5439 33000.0n 0.5153 33249.9n 0.5153 33250.0n 0.1667 33499.9n 0.1667 33500.0n 0.3411 33749.9n 0.3411 33750.0n 0.7013 33999.9n 0.7013 34000.0n 0.8682 34249.9n 0.8682 34250.0n 0.4092 34499.9n 0.4092 34500.0n 0.2590 34749.9n 0.2590 34750.0n 0.3470 34999.9n 0.3470 35000.0n 0.4273 35249.9n 0.4273 35250.0n 0.3129 35499.9n 0.3129 35500.0n 0.4505 35749.9n 0.4505 35750.0n 0.6641 35999.9n 0.6641 36000.0n 0.7982 36249.9n 0.7982 36250.0n 0.6724 36499.9n 0.6724 36500.0n 0.4477 36749.9n 0.4477 36750.0n 0.5590 36999.9n 0.5590 37000.0n 0.0907 37249.9n 0.0907 37250.0n 0.6244 37499.9n 0.6244 37500.0n 0.4117 37749.9n 0.4117 37750.0n 0.5177 37999.9n 0.5177 38000.0n 0.4283 38249.9n 0.4283 38250.0n 0.9077 38499.9n 0.9077 38500.0n 0.5907 38749.9n 0.5907 38750.0n 0.5540 38999.9n 0.5540 39000.0n 0.5890 39249.9n 0.5890 39250.0n 0.3299 39499.9n 0.3299 39500.0n 0.5043 39749.9n 0.5043 39750.0n 0.3890 39999.9n 0.3890 40000.0n 0.8485 40249.9n 0.8485 40250.0n 0.5681 40499.9n 0.5681 40500.0n 0.5093 40749.9n 0.5093 40750.0n 0.6103 40999.9n 0.6103 41000.0n 0.6536 41249.9n 0.6536 41250.0n 0.5760 41499.9n 0.5760 41500.0n 0.3824 41749.9n 0.3824 41750.0n 0.4602 41999.9n 0.4602 42000.0n 0.8419 42249.9n 0.8419 42250.0n 0.5028 42499.9n 0.5028 42500.0n 0.1850 42749.9n 0.1850 42750.0n 0.3221 42999.9n 0.3221 43000.0n 0.5404 43249.9n 0.5404 43250.0n 0.2021 43499.9n 0.2021 43500.0n 0.3932 43749.9n 0.3932 43750.0n 0.8472 43999.9n 0.8472 44000.0n 0.1052 44249.9n 0.1052 44250.0n 0.4885 44499.9n 0.4885 44500.0n 0.5397 44749.9n 0.5397 44750.0n 0.6345 44999.9n 0.6345 45000.0n 0.3932 45249.9n 0.3932 45250.0n 0.5540 45499.9n 0.5540 45500.0n 0.4477 45749.9n 0.4477 45750.0n 0.6244 45999.9n 0.6244 46000.0n 0.5681 46249.9n 0.5681 46250.0n 0.6641 46499.9n 0.6641 46500.0n 0.9077 46749.9n 0.9077 46750.0n 0.5404 46999.9n 0.5404 47000.0n 0.2021 47249.9n 0.2021 47250.0n 0.7013 47499.9n 0.7013 47500.0n 0.0907 47749.9n 0.0907 47750.0n 0.3299 47999.9n 0.3299 48000.0n 0.6103 48249.9n 0.6103 48250.0n 0.8485 48499.9n 0.8485 48500.0n 0.1667 48749.9n 0.1667 48750.0n 0.7020 48999.9n 0.7020 49000.0n 0.6536 49249.9n 0.6536 49250.0n 0.0843 49499.9n 0.0843 49500.0n 0.5043 49749.9n 0.5043 49750.0n 0.8561 49999.9n 0.8561 50000.0n 0.8472 50249.9n 0.8472 50250.0n 0.8682 50499.9n 0.8682 50500.0n 0.3984 50749.9n 0.3984 50750.0n 0.5397 50999.9n 0.5397 51000.0n 0.8419 51249.9n 0.8419 51250.0n 0.2590 51499.9n 0.2590 51500.0n 0.5890 51749.9n 0.5890 51750.0n 0.6345 51999.9n 0.6345 52000.0n 0.3129 52249.9n 0.3129 52250.0n 0.4136 52499.9n 0.4136 52500.0n 0.6578 52749.9n 0.6578 52750.0n 0.1850 52999.9n 0.1850 53000.0n 0.5590 53249.9n 0.5590 53250.0n 0.5177 53499.9n 0.5177 53500.0n 0.4633 53749.9n 0.4633 53750.0n 0.6724 53999.9n 0.6724 54000.0n 0.7982 54249.9n 0.7982 54250.0n 0.2218 54499.9n 0.2218 54500.0n 0.1580 54749.9n 0.1580 54750.0n 0.5907 54999.9n 0.5907 55000.0n 0.3890 55249.9n 0.3890 55250.0n 0.3221 55499.9n 0.3221 55500.0n 0.5760 55749.9n 0.5760 55750.0n 0.5093 55999.9n 0.5093 56000.0n 0.4092 56249.9n 0.4092 56250.0n 0.5153 56499.9n 0.5153 56500.0n 0.3411 56749.9n 0.3411 56750.0n 0.4283 56999.9n 0.4283 57000.0n 0.3470 57249.9n 0.3470 57250.0n 0.4885 57499.9n 0.4885 57500.0n 0.5028 57749.9n 0.5028 57750.0n 0.1052 57999.9n 0.1052 58000.0n 0.9666 58249.9n 0.9666 58250.0n 0.5053 58499.9n 0.5053 58500.0n 0.5439 58749.9n 0.5439 58750.0n 0.4602 58999.9n 0.4602 59000.0n 0.4117 59249.9n 0.4117 59250.0n 0.3824 59499.9n 0.3824 59500.0n 0.4505 59749.9n 0.4505 59750.0n 0.4273 59999.9n 0.4273 60000.0n 0.8682 60249.9n 0.8682 60250.0n 0.7013 60499.9n 0.7013 60500.0n 0.4117 60749.9n 0.4117 60750.0n 0.8472 60999.9n 0.8472 61000.0n 0.4602 61249.9n 0.4602 61250.0n 0.3221 61499.9n 0.3221 61500.0n 0.5439 61749.9n 0.5439 61750.0n 0.6641 61999.9n 0.6641 62000.0n 0.5760 62249.9n 0.5760 62250.0n 0.4273 62499.9n 0.4273 62500.0n 0.4283 62749.9n 0.4283 62750.0n 0.5153 62999.9n 0.5153 63000.0n 0.6345 63249.9n 0.6345 63250.0n 0.5028 63499.9n 0.5028 63500.0n 0.0907 63749.9n 0.0907 63750.0n 0.9077 63999.9n 0.9077 64000.0n 0.6578 64249.9n 0.6578 64250.0n 0.3129 64499.9n 0.3129 64500.0n 0.2218 64749.9n 0.2218 64750.0n 0.6244 64999.9n 0.6244 65000.0n 0.8561 65249.9n 0.8561 65250.0n 0.1667 65499.9n 0.1667 65500.0n 0.6724 65749.9n 0.6724 65750.0n 0.4092 65999.9n 0.4092 66000.0n 0.5907 66249.9n 0.5907 66250.0n 0.4477 66499.9n 0.4477 66500.0n 0.6103 66749.9n 0.6103 66750.0n 0.4885 66999.9n 0.4885 67000.0n 0.3299 67249.9n 0.3299 67250.0n 0.7020 67499.9n 0.7020 67500.0n 0.5540 67749.9n 0.5540 67750.0n 0.5053 67999.9n 0.5053 68000.0n 0.7982 68249.9n 0.7982 68250.0n 0.2590 68499.9n 0.2590 68500.0n 0.1850 68749.9n 0.1850 68750.0n 0.6536 68999.9n 0.6536 69000.0n 0.8419 69249.9n 0.8419 69250.0n 0.1052 69499.9n 0.1052 69500.0n 0.4505 69749.9n 0.4505 69750.0n 0.2021 69999.9n 0.2021 70000.0n 0.5177 70249.9n 0.5177 70250.0n 0.3984 70499.9n 0.3984 70500.0n 0.0843 70749.9n 0.0843 70750.0n 0.3890 70999.9n 0.3890 71000.0n 0.5890 71249.9n 0.5890 71250.0n 0.3824 71499.9n 0.3824 71500.0n 0.1580 71749.9n 0.1580 71750.0n 0.3932 71999.9n 0.3932 72000.0n 0.5397 72249.9n 0.5397 72250.0n 0.4136 72499.9n 0.4136 72500.0n 0.3470 72749.9n 0.3470 72750.0n 0.8485 72999.9n 0.8485 73000.0n 0.4633 73249.9n 0.4633 73250.0n 0.5404 73499.9n 0.5404 73500.0n 0.5043 73749.9n 0.5043 73750.0n 0.3411 73999.9n 0.3411 74000.0n 0.5681 74249.9n 0.5681 74250.0n 0.5093 74499.9n 0.5093 74500.0n 0.5590 74749.9n 0.5590 74750.0n 0.9666 74999.9n 0.9666 75000.0n 0.5760 75249.9n 0.5760 75250.0n 0.9666 75499.9n 0.9666 75500.0n 0.5028 75749.9n 0.5028 75750.0n 0.1580 75999.9n 0.1580 76000.0n 0.8419 76249.9n 0.8419 76250.0n 0.5043 76499.9n 0.5043 76500.0n 0.2218 76749.9n 0.2218 76750.0n 0.5053 76999.9n 0.5053 77000.0n 0.5177 77249.9n 0.5177 77250.0n 0.0843 77499.9n 0.0843 77500.0n 0.6103 77749.9n 0.6103 77750.0n 0.6724 77999.9n 0.6724 78000.0n 0.6578 78249.9n 0.6578 78250.0n 0.4273 78499.9n 0.4273 78500.0n 0.4633 78749.9n 0.4633 78750.0n 0.6345 78999.9n 0.6345 79000.0n 0.1667 79249.9n 0.1667 79250.0n 0.4477 79499.9n 0.4477 79500.0n 0.1850 79749.9n 0.1850 79750.0n 0.5540 79999.9n 0.5540 80000.0n 0.8682 80249.9n 0.8682 80250.0n 0.6536 80499.9n 0.6536 80500.0n 0.3824 80749.9n 0.3824 80750.0n 0.5153 80999.9n 0.5153 81000.0n 0.5093 81249.9n 0.5093 81250.0n 0.4283 81499.9n 0.4283 81500.0n 0.4885 81749.9n 0.4885 81750.0n 0.0907 81999.9n 0.0907 82000.0n 0.5404 82249.9n 0.5404 82250.0n 0.3299 82499.9n 0.3299 82500.0n 0.9077 82749.9n 0.9077 82750.0n 0.3411 82999.9n 0.3411 83000.0n 0.5907 83249.9n 0.5907 83250.0n 0.8561 83499.9n 0.8561 83500.0n 0.3932 83749.9n 0.3932 83750.0n 0.5890 83999.9n 0.5890 84000.0n 0.8472 84249.9n 0.8472 84250.0n 0.7020 84499.9n 0.7020 84500.0n 0.3470 84749.9n 0.3470 84750.0n 0.4505 84999.9n 0.4505 85000.0n 0.5590 85249.9n 0.5590 85250.0n 0.3129 85499.9n 0.3129 85500.0n 0.5681 85749.9n 0.5681 85750.0n 0.2590 85999.9n 0.2590 86000.0n 0.1052 86249.9n 0.1052 86250.0n 0.4136 86499.9n 0.4136 86500.0n 0.3890 86749.9n 0.3890 86750.0n 0.7013 86999.9n 0.7013 87000.0n 0.5397 87249.9n 0.5397 87250.0n 0.4602 87499.9n 0.4602 87500.0n 0.6244 87749.9n 0.6244 87750.0n 0.3984 87999.9n 0.3984 88000.0n 0.3221 88249.9n 0.3221 88250.0n 0.8485 88499.9n 0.8485 88500.0n 0.7982 88749.9n 0.7982 88750.0n 0.6641 88999.9n 0.6641 89000.0n 0.5439 89249.9n 0.5439 89250.0n 0.2021 89499.9n 0.2021 89500.0n 0.4117 89749.9n 0.4117 89750.0n 0.4092 89999.9n 0.4092 90000.0n 0.6345 90249.9n 0.6345 90250.0n 0.1667 90499.9n 0.1667 90500.0n 0.4117 90749.9n 0.4117 90750.0n 0.5028 90999.9n 0.5028 91000.0n 0.3932 91249.9n 0.3932 91250.0n 0.4633 91499.9n 0.4633 91500.0n 0.6578 91749.9n 0.6578 91750.0n 0.4283 91999.9n 0.4283 92000.0n 0.8485 92249.9n 0.8485 92250.0n 0.3984 92499.9n 0.3984 92500.0n 0.6244 92749.9n 0.6244 92750.0n 0.4136 92999.9n 0.4136 93000.0n 0.5681 93249.9n 0.5681 93250.0n 0.4273 93499.9n 0.4273 93500.0n 0.8472 93749.9n 0.8472 93750.0n 0.1580 93999.9n 0.1580 94000.0n 0.5439 94249.9n 0.5439 94250.0n 0.5177 94499.9n 0.5177 94500.0n 0.3411 94749.9n 0.3411 94750.0n 0.7013 94999.9n 0.7013 95000.0n 0.5093 95249.9n 0.5093 95250.0n 0.4092 95499.9n 0.4092 95500.0n 0.3824 95749.9n 0.3824 95750.0n 0.8419 95999.9n 0.8419 96000.0n 0.3129 96249.9n 0.3129 96250.0n 0.2218 96499.9n 0.2218 96500.0n 0.9666 96749.9n 0.9666 96750.0n 0.3299 96999.9n 0.3299 97000.0n 0.5890 97249.9n 0.5890 97250.0n 0.5397 97499.9n 0.5397 97500.0n 0.4477 97749.9n 0.4477 97750.0n 0.7982 97999.9n 0.7982 98000.0n 0.3890 98249.9n 0.3890 98250.0n 0.3221 98499.9n 0.3221 98500.0n 0.4505 98749.9n 0.4505 98750.0n 0.6724 98999.9n 0.6724 99000.0n 0.4602 99249.9n 0.4602 99250.0n 0.2590 99499.9n 0.2590 99500.0n 0.8682 99749.9n 0.8682 99750.0n 0.1052 99999.9n 0.1052 100000.0n 0.4885 100249.9n 0.4885 100250.0n 0.5053 100499.9n 0.5053 100500.0n 0.5043 100749.9n 0.5043 100750.0n 0.0843 100999.9n 0.0843 101000.0n 0.5404 101249.9n 0.5404 101250.0n 0.7020 101499.9n 0.7020 101500.0n 0.2021 101749.9n 0.2021 101750.0n 0.9077 101999.9n 0.9077 102000.0n 0.8561 102249.9n 0.8561 102250.0n 0.5760 102499.9n 0.5760 102500.0n 0.0907 102749.9n 0.0907 102750.0n 0.5907 102999.9n 0.5907 103000.0n 0.6641 103249.9n 0.6641 103250.0n 0.6103 103499.9n 0.6103 103500.0n 0.5153 103749.9n 0.5153 103750.0n 0.1850 103999.9n 0.1850 104000.0n 0.3470 104249.9n 0.3470 104250.0n 0.6536 104499.9n 0.6536 104500.0n 0.5590 104749.9n 0.5590 104750.0n 0.5540 104999.9n 0.5540 105000.0n 0.5043 105249.9n 0.5043 105250.0n 0.6536 105499.9n 0.6536 105500.0n 0.2218 105749.9n 0.2218 105750.0n 0.7013 105999.9n 0.7013 106000.0n 0.1850 106249.9n 0.1850 106250.0n 0.5890 106499.9n 0.5890 106500.0n 0.6244 106749.9n 0.6244 106750.0n 0.8472 106999.9n 0.8472 107000.0n 0.7020 107249.9n 0.7020 107250.0n 0.5590 107499.9n 0.5590 107500.0n 0.6724 107749.9n 0.6724 107750.0n 0.4885 107999.9n 0.4885 108000.0n 0.6103 108249.9n 0.6103 108250.0n 0.6641 108499.9n 0.6641 108500.0n 0.5540 108749.9n 0.5540 108750.0n 0.0843 108999.9n 0.0843 109000.0n 0.9666 109249.9n 0.9666 109250.0n 0.3890 109499.9n 0.3890 109500.0n 0.5760 109749.9n 0.5760 109750.0n 0.4477 109999.9n 0.4477 110000.0n 0.1667 110249.9n 0.1667 110250.0n 0.4273 110499.9n 0.4273 110500.0n 0.3299 110749.9n 0.3299 110750.0n 0.4602 110999.9n 0.4602 111000.0n 0.1580 111249.9n 0.1580 111250.0n 0.3129 111499.9n 0.3129 111500.0n 0.4633 111749.9n 0.4633 111750.0n 0.2021 111999.9n 0.2021 112000.0n 0.5439 112249.9n 0.5439 112250.0n 0.9077 112499.9n 0.9077 112500.0n 0.5153 112749.9n 0.5153 112750.0n 0.7982 112999.9n 0.7982 113000.0n 0.5907 113249.9n 0.5907 113250.0n 0.4092 113499.9n 0.4092 113500.0n 0.6578 113749.9n 0.6578 113750.0n 0.3932 113999.9n 0.3932 114000.0n 0.5397 114249.9n 0.5397 114250.0n 0.3470 114499.9n 0.3470 114500.0n 0.5028 114749.9n 0.5028 114750.0n 0.1052 114999.9n 0.1052 115000.0n 0.4283 115249.9n 0.4283 115250.0n 0.5093 115499.9n 0.5093 115500.0n 0.0907 115749.9n 0.0907 115750.0n 0.5681 115999.9n 0.5681 116000.0n 0.8682 116249.9n 0.8682 116250.0n 0.4505 116499.9n 0.4505 116500.0n 0.3824 116749.9n 0.3824 116750.0n 0.5404 116999.9n 0.5404 117000.0n 0.3221 117249.9n 0.3221 117250.0n 0.5177 117499.9n 0.5177 117500.0n 0.8485 117749.9n 0.8485 117750.0n 0.6345 117999.9n 0.6345 118000.0n 0.5053 118249.9n 0.5053 118250.0n 0.8561 118499.9n 0.8561 118500.0n 0.3984 118749.9n 0.3984 118750.0n 0.3411 118999.9n 0.3411 119000.0n 0.8419 119249.9n 0.8419 119250.0n 0.4117 119499.9n 0.4117 119500.0n 0.4136 119749.9n 0.4136 119750.0n 0.2590 119999.9n 0.2590 120000.0n 0.4477 120249.9n 0.4477 120250.0n 0.7020 120499.9n 0.7020 120500.0n 0.5760 120749.9n 0.5760 120750.0n 0.5028 120999.9n 0.5028 121000.0n 0.1580 121249.9n 0.1580 121250.0n 0.5043 121499.9n 0.5043 121500.0n 0.0907 121749.9n 0.0907 121750.0n 0.8682 121999.9n 0.8682 122000.0n 0.3411 122249.9n 0.3411 122250.0n 0.1850 122499.9n 0.1850 122500.0n 0.6536 122749.9n 0.6536 122750.0n 0.1052 122999.9n 0.1052 123000.0n 0.2590 123249.9n 0.2590 123250.0n 0.0843 123499.9n 0.0843 123500.0n 0.5397 123749.9n 0.5397 123750.0n 0.8561 123999.9n 0.8561 124000.0n 0.5153 124249.9n 0.5153 124250.0n 0.5540 124499.9n 0.5540 124500.0n 0.2218 124749.9n 0.2218 124750.0n 0.5907 124999.9n 0.5907 125000.0n 0.3299 125249.9n 0.3299 125250.0n 0.6724 125499.9n 0.6724 125500.0n 0.3470 125749.9n 0.3470 125750.0n 0.9666 125999.9n 0.9666 126000.0n 0.4092 126249.9n 0.4092 126250.0n 0.6641 126499.9n 0.6641 126500.0n 0.3129 126749.9n 0.3129 126750.0n 0.5890 126999.9n 0.5890 127000.0n 0.5681 127249.9n 0.5681 127250.0n 0.4602 127499.9n 0.4602 127500.0n 0.6103 127749.9n 0.6103 127750.0n 0.7982 127999.9n 0.7982 128000.0n 0.4633 128249.9n 0.4633 128250.0n 0.6244 128499.9n 0.6244 128500.0n 0.8419 128749.9n 0.8419 128750.0n 0.5404 128999.9n 0.5404 129000.0n 0.3932 129249.9n 0.3932 129250.0n 0.6578 129499.9n 0.6578 129500.0n 0.5439 129749.9n 0.5439 129750.0n 0.5093 129999.9n 0.5093 130000.0n 0.4505 130249.9n 0.4505 130250.0n 0.4885 130499.9n 0.4885 130500.0n 0.6345 130749.9n 0.6345 130750.0n 0.4283 130999.9n 0.4283 131000.0n 0.4273 131249.9n 0.4273 131250.0n 0.3824 131499.9n 0.3824 131500.0n 0.4117 131749.9n 0.4117 131750.0n 0.5590 131999.9n 0.5590 132000.0n 0.3221 132249.9n 0.3221 132250.0n 0.9077 132499.9n 0.9077 132500.0n 0.5177 132749.9n 0.5177 132750.0n 0.7013 132999.9n 0.7013 133000.0n 0.2021 133249.9n 0.2021 133250.0n 0.3890 133499.9n 0.3890 133500.0n 0.1667 133749.9n 0.1667 133750.0n 0.8485 133999.9n 0.8485 134000.0n 0.8472 134249.9n 0.8472 134250.0n 0.3984 134499.9n 0.3984 134500.0n 0.5053 134749.9n 0.5053 134750.0n 0.4136 134999.9n 0.4136 135000.0n 0.7013 135249.9n 0.7013 135250.0n 0.3411 135499.9n 0.3411 135500.0n 0.4283 135749.9n 0.4283 135750.0n 0.6244 135999.9n 0.6244 136000.0n 0.5890 136249.9n 0.5890 136250.0n 0.3129 136499.9n 0.3129 136500.0n 0.5404 136749.9n 0.5404 136750.0n 0.3299 136999.9n 0.3299 137000.0n 0.9666 137249.9n 0.9666 137250.0n 0.4505 137499.9n 0.4505 137500.0n 0.5053 137749.9n 0.5053 137750.0n 0.7020 137999.9n 0.7020 138000.0n 0.1580 138249.9n 0.1580 138250.0n 0.5590 138499.9n 0.5590 138500.0n 0.1667 138749.9n 0.1667 138750.0n 0.7982 138999.9n 0.7982 139000.0n 0.5439 139249.9n 0.5439 139250.0n 0.3932 139499.9n 0.3932 139500.0n 0.6103 139749.9n 0.6103 139750.0n 0.3890 139999.9n 0.3890 140000.0n 0.6536 140249.9n 0.6536 140250.0n 0.2590 140499.9n 0.2590 140500.0n 0.2218 140749.9n 0.2218 140750.0n 0.3984 140999.9n 0.3984 141000.0n 0.4117 141249.9n 0.4117 141250.0n 0.4273 141499.9n 0.4273 141500.0n 0.1850 141749.9n 0.1850 141750.0n 0.6641 141999.9n 0.6641 142000.0n 0.5907 142249.9n 0.5907 142250.0n 0.5177 142499.9n 0.5177 142500.0n 0.3470 142749.9n 0.3470 142750.0n 0.0907 142999.9n 0.0907 143000.0n 0.0843 143249.9n 0.0843 143250.0n 0.5540 143499.9n 0.5540 143500.0n 0.4092 143749.9n 0.4092 143750.0n 0.5028 143999.9n 0.5028 144000.0n 0.3221 144249.9n 0.3221 144250.0n 0.5397 144499.9n 0.5397 144500.0n 0.6345 144749.9n 0.6345 144750.0n 0.6578 144999.9n 0.6578 145000.0n 0.4477 145249.9n 0.4477 145250.0n 0.4136 145499.9n 0.4136 145500.0n 0.8682 145749.9n 0.8682 145750.0n 0.1052 145999.9n 0.1052 146000.0n 0.5093 146249.9n 0.5093 146250.0n 0.2021 146499.9n 0.2021 146500.0n 0.5153 146749.9n 0.5153 146750.0n 0.4602 146999.9n 0.4602 147000.0n 0.8485 147249.9n 0.8485 147250.0n 0.8561 147499.9n 0.8561 147500.0n 0.8419 147749.9n 0.8419 147750.0n 0.5760 147999.9n 0.5760 148000.0n 0.5043 148249.9n 0.5043 148250.0n 0.9077 148499.9n 0.9077 148500.0n 0.6724 148749.9n 0.6724 148750.0n 0.4633 148999.9n 0.4633 149000.0n 0.8472 149249.9n 0.8472 149250.0n 0.3824 149499.9n 0.3824 149500.0n 0.4885 149749.9n 0.4885 149750.0n 0.5681 149999.9n 0.5681 150000.0n 0.4117 150249.9n 0.4117 150250.0n 0.4885 150499.9n 0.4885 150500.0n 0.6641 150749.9n 0.6641 150750.0n 0.6724 150999.9n 0.6724 151000.0n 0.3984 151249.9n 0.3984 151250.0n 0.1580 151499.9n 0.1580 151500.0n 0.1850 151749.9n 0.1850 151750.0n 0.6244 151999.9n 0.6244 152000.0n 0.7982 152249.9n 0.7982 152250.0n 0.3470 152499.9n 0.3470 152500.0n 0.8419 152749.9n 0.8419 152750.0n 0.5540 152999.9n 0.5540 153000.0n 0.7013 153249.9n 0.7013 153250.0n 0.3129 153499.9n 0.3129 153500.0n 0.7020 153749.9n 0.7020 153750.0n 0.2590 153999.9n 0.2590 154000.0n 0.4505 154249.9n 0.4505 154250.0n 0.2218 154499.9n 0.2218 154500.0n 0.5907 154749.9n 0.5907 154750.0n 0.5890 154999.9n 0.5890 155000.0n 0.5397 155249.9n 0.5397 155250.0n 0.3299 155499.9n 0.3299 155500.0n 0.9666 155749.9n 0.9666 155750.0n 0.6345 155999.9n 0.6345 156000.0n 0.3221 156249.9n 0.3221 156250.0n 0.5153 156499.9n 0.5153 156500.0n 0.4602 156749.9n 0.4602 156750.0n 0.1667 156999.9n 0.1667 157000.0n 0.8472 157249.9n 0.8472 157250.0n 0.3411 157499.9n 0.3411 157500.0n 0.4092 157749.9n 0.4092 157750.0n 0.5404 157999.9n 0.5404 158000.0n 0.4273 158249.9n 0.4273 158250.0n 0.8682 158499.9n 0.8682 158500.0n 0.4136 158749.9n 0.4136 158750.0n 0.5681 158999.9n 0.5681 159000.0n 0.5028 159249.9n 0.5028 159250.0n 0.4633 159499.9n 0.4633 159500.0n 0.4477 159749.9n 0.4477 159750.0n 0.5590 159999.9n 0.5590 160000.0n 0.1052 160249.9n 0.1052 160250.0n 0.2021 160499.9n 0.2021 160500.0n 0.0907 160749.9n 0.0907 160750.0n 0.6536 160999.9n 0.6536 161000.0n 0.5177 161249.9n 0.5177 161250.0n 0.6578 161499.9n 0.6578 161500.0n 0.3890 161749.9n 0.3890 161750.0n 0.5439 161999.9n 0.5439 162000.0n 0.8561 162249.9n 0.8561 162250.0n 0.3824 162499.9n 0.3824 162500.0n 0.5093 162749.9n 0.5093 162750.0n 0.0843 162999.9n 0.0843 163000.0n 0.8485 163249.9n 0.8485 163250.0n 0.5760 163499.9n 0.5760 163500.0n 0.4283 163749.9n 0.4283 163750.0n 0.5043 163999.9n 0.5043 164000.0n 0.9077 164249.9n 0.9077 164250.0n 0.5053 164499.9n 0.5053 164500.0n 0.3932 164749.9n 0.3932 164750.0n 0.6103 164999.9n 0.6103 165000.0n 0.5540 165249.9n 0.5540 165250.0n 0.6345 165499.9n 0.6345 165500.0n 0.2590 165749.9n 0.2590 165750.0n 0.6103 165999.9n 0.6103 166000.0n 0.4505 166249.9n 0.4505 166250.0n 0.5404 166499.9n 0.5404 166500.0n 0.6244 166749.9n 0.6244 166750.0n 0.4885 166999.9n 0.4885 167000.0n 0.5681 167249.9n 0.5681 167250.0n 0.3824 167499.9n 0.3824 167500.0n 0.4633 167749.9n 0.4633 167750.0n 0.4477 167999.9n 0.4477 168000.0n 0.7013 168249.9n 0.7013 168250.0n 0.9666 168499.9n 0.9666 168500.0n 0.2021 168749.9n 0.2021 168750.0n 0.6641 168999.9n 0.6641 169000.0n 0.5890 169249.9n 0.5890 169250.0n 0.1052 169499.9n 0.1052 169500.0n 0.5053 169749.9n 0.5053 169750.0n 0.5177 169999.9n 0.5177 170000.0n 0.5760 170249.9n 0.5760 170250.0n 0.7982 170499.9n 0.7982 170500.0n 0.4117 170749.9n 0.4117 170750.0n 0.3470 170999.9n 0.3470 171000.0n 0.8682 171249.9n 0.8682 171250.0n 0.5439 171499.9n 0.5439 171500.0n 0.9077 171749.9n 0.9077 171750.0n 0.2218 171999.9n 0.2218 172000.0n 0.3984 172249.9n 0.3984 172250.0n 0.4092 172499.9n 0.4092 172500.0n 0.4273 172749.9n 0.4273 172750.0n 0.8472 172999.9n 0.8472 173000.0n 0.1580 173249.9n 0.1580 173250.0n 0.3129 173499.9n 0.3129 173500.0n 0.6724 173749.9n 0.6724 173750.0n 0.0843 173999.9n 0.0843 174000.0n 0.4602 174249.9n 0.4602 174250.0n 0.8485 174499.9n 0.8485 174500.0n 0.3890 174749.9n 0.3890 174750.0n 0.6578 174999.9n 0.6578 175000.0n 0.3411 175249.9n 0.3411 175250.0n 0.3299 175499.9n 0.3299 175500.0n 0.8561 175749.9n 0.8561 175750.0n 0.1850 175999.9n 0.1850 176000.0n 0.5590 176249.9n 0.5590 176250.0n 0.5153 176499.9n 0.5153 176500.0n 0.1667 176749.9n 0.1667 176750.0n 0.5907 176999.9n 0.5907 177000.0n 0.7020 177249.9n 0.7020 177250.0n 0.4283 177499.9n 0.4283 177500.0n 0.8419 177749.9n 0.8419 177750.0n 0.5028 177999.9n 0.5028 178000.0n 0.5397 178249.9n 0.5397 178250.0n 0.5093 178499.9n 0.5093 178500.0n 0.3932 178749.9n 0.3932 178750.0n 0.3221 178999.9n 0.3221 179000.0n 0.6536 179249.9n 0.6536 179250.0n 0.4136 179499.9n 0.4136 179500.0n 0.0907 179749.9n 0.0907 179750.0n 0.5043 179999.9n 0.5043 180000.0n 0.2138 180249.9n 0.2138 180250.0n 0.7319 180499.9n 0.7319 180500.0n 0.2331 180749.9n 0.2331 180750.0n 0.4471 180999.9n 0.4471 181000.0n 0.4013 181249.9n 0.4013 181250.0n 0.9457 181499.9n 0.9457 181500.0n 0.5097 181749.9n 0.5097 181750.0n 0.8723 181999.9n 0.8723 182000.0n 0.4973 182249.9n 0.4973 182250.0n 0.6060 182499.9n 0.6060 182500.0n 0.2411 182749.9n 0.2411 182750.0n 0.5312 182999.9n 0.5312 183000.0n 0.3865 183249.9n 0.3865 183250.0n 0.5141 183499.9n 0.5141 183500.0n 0.1083 183749.9n 0.1083 183750.0n 0.0614 183999.9n 0.0614 184000.0n 0.8568 184249.9n 0.8568 184250.0n 0.6264 184499.9n 0.6264 184500.0n 0.3029 184749.9n 0.3029 184750.0n 0.6817 184999.9n 0.6817 185000.0n 0.4354 185249.9n 0.4354 185250.0n 0.5862 185499.9n 0.5862 185500.0n 0.6143 185749.9n 0.6143 185750.0n 0.3802 185999.9n 0.3802 186000.0n 0.3680 186249.9n 0.3680 186250.0n 0.8121 186499.9n 0.8121 186500.0n 0.4490 186749.9n 0.4490 186750.0n 0.5929 186999.9n 0.5929 187000.0n 0.3048 187249.9n 0.3048 187250.0n 0.8267 187499.9n 0.8267 187500.0n 0.4740 187749.9n 0.4740 187750.0n 0.5521 187999.9n 0.5521 188000.0n 0.9338 188249.9n 0.9338 188250.0n 0.3656 188499.9n 0.3656 188500.0n 0.5622 188749.9n 0.5622 188750.0n 0.5334 188999.9n 0.5334 189000.0n 0.7774 189249.9n 0.7774 189250.0n 0.8316 189499.9n 0.8316 189500.0n 0.5113 189749.9n 0.5113 189750.0n 0.6088 189999.9n 0.6088 190000.0n 0.3669 190249.9n 0.3669 190250.0n 0.9084 190499.9n 0.9084 190500.0n 0.8104 190749.9n 0.8104 190750.0n 0.6063 190999.9n 0.6063 191000.0n 0.1875 191249.9n 0.1875 191250.0n 0.1112 191499.9n 0.1112 191500.0n 0.4784 191749.9n 0.4784 191750.0n 0.0881 191999.9n 0.0881 192000.0n 0.5851 192249.9n 0.5851 192250.0n 0.4042 192499.9n 0.4042 192500.0n 0.6963 192749.9n 0.6963 192750.0n 0.1057 192999.9n 0.1057 193000.0n 0.4292 193249.9n 0.4292 193250.0n 0.6392 193499.9n 0.6392 193500.0n 0.5135 193749.9n 0.5135 193750.0n 0.4567 193999.9n 0.4567 194000.0n 0.4059 194249.9n 0.4059 194250.0n 0.8472 194499.9n 0.8472 194500.0n 0.3654 194749.9n 0.3654 194750.0n 0.4791 194999.9n 0.4791 195000.0n 0.5355 195249.9n 0.5355 195250.0n 0.5043 195499.9n 0.5043 195500.0n 0.6280 195749.9n 0.6280 195750.0n 0.6648 195999.9n 0.6648 196000.0n 0.0459 196249.9n 0.0459 196250.0n 0.3319 196499.9n 0.3319 196500.0n 0.6336 196749.9n 0.6336 196750.0n 0.2070 196999.9n 0.2070 197000.0n 0.6373 197249.9n 0.6373 197250.0n 0.6819 197499.9n 0.6819 197500.0n 0.5283 197749.9n 0.5283 197750.0n 0.5807 197999.9n 0.5807 198000.0n 0.4059 198249.9n 0.4059 198250.0n 0.8248 198499.9n 0.8248 198500.0n 0.6426 198749.9n 0.6426 198750.0n 0.2062 198999.9n 0.2062 199000.0n 0.3422 199249.9n 0.3422 199250.0n 0.5134 199499.9n 0.5134 199500.0n 0.8179 199749.9n 0.8179 199750.0n 0.0574 199999.9n 0.0574 200000.0n 0.4426 200249.9n 0.4426 200250.0n 0.4525 200499.9n 0.4525 200500.0n 0.5399 200749.9n 0.5399 200750.0n 0.4722 200999.9n 0.4722 201000.0n 0.3146 201249.9n 0.3146 201250.0n 0.4397 201499.9n 0.4397 201500.0n 0.4580 201749.9n 0.4580 201750.0n 0.5662 201999.9n 0.5662 202000.0n 0.3354 202249.9n 0.3354 202250.0n 0.6251 202499.9n 0.6251 202500.0n 0.8258 202749.9n 0.8258 202750.0n 0.5927 202999.9n 0.5927 203000.0n 0.2081 203249.9n 0.2081 203250.0n 0.5718 203499.9n 0.5718 203500.0n 0.4586 203749.9n 0.4586 203750.0n 0.1625 203999.9n 0.1625 204000.0n 0.6328 204249.9n 0.6328 204250.0n 0.3478 204499.9n 0.3478 204500.0n 0.7903 204749.9n 0.7903 204750.0n 0.4830 204999.9n 0.4830 205000.0n 0.5266 205249.9n 0.5266 205250.0n 0.5618 205499.9n 0.5618 205500.0n 0.4340 205749.9n 0.4340 205750.0n 0.5866 205999.9n 0.5866 206000.0n 0.7652 206249.9n 0.7652 206250.0n 0.5194 206499.9n 0.5194 206500.0n 0.5869 206749.9n 0.5869 206750.0n 0.7936 206999.9n 0.7936 207000.0n 0.0882 207249.9n 0.0882 207250.0n 0.4391 207499.9n 0.4391 207500.0n 0.8216 207749.9n 0.8216 207750.0n 0.6171 207999.9n 0.6171 208000.0n 0.7712 208249.9n 0.7712 208250.0n 0.4128 208499.9n 0.4128 208500.0n 0.3940 208749.9n 0.3940 208750.0n 0.4908 208999.9n 0.4908 209000.0n 0.5167 209249.9n 0.5167 209250.0n 0.5272 209499.9n 0.5272 209500.0n 0.4907 209749.9n 0.4907 209750.0n 0.1824)
Vx2p a_xp2 0 PWL(0.0n 0.1182 249.9n 0.1182 250.0n 0.3572 499.9n 0.3572 500.0n 0.4086 749.9n 0.4086 750.0n 0.8443 999.9n 0.8443 1000.0n 0.4369 1249.9n 0.4369 1250.0n 0.8241 1499.9n 0.8241 1500.0n 0.3295 1749.9n 0.3295 1750.0n 0.2909 1999.9n 0.2909 2000.0n 0.1922 2249.9n 0.1922 2250.0n 0.5070 2499.9n 0.5070 2500.0n 0.4504 2749.9n 0.4504 2750.0n 0.6174 2999.9n 0.6174 3000.0n 0.1790 3249.9n 0.1790 3250.0n 0.6111 3499.9n 0.6111 3500.0n 0.2303 3749.9n 0.2303 3750.0n 0.4072 3999.9n 0.4072 4000.0n 0.5771 4249.9n 0.5771 4250.0n 0.8736 4499.9n 0.8736 4500.0n 0.5018 4749.9n 0.5018 4750.0n 0.6122 4999.9n 0.6122 5000.0n 0.6552 5249.9n 0.6552 5250.0n 0.5289 5499.9n 0.5289 5500.0n 0.5510 5749.9n 0.5510 5750.0n 0.3642 5999.9n 0.3642 6000.0n 0.5224 6249.9n 0.5224 6250.0n 0.4102 6499.9n 0.4102 6500.0n 0.2279 6749.9n 0.2279 6750.0n 0.4813 6999.9n 0.4813 7000.0n 0.5670 7249.9n 0.5670 7250.0n 0.6290 7499.9n 0.6290 7500.0n 0.1086 7749.9n 0.1086 7750.0n 0.5364 7999.9n 0.5364 8000.0n 0.6126 8249.9n 0.6126 8250.0n 0.5365 8499.9n 0.5365 8500.0n 0.5119 8749.9n 0.5119 8750.0n 0.1732 8999.9n 0.1732 9000.0n 0.4674 9249.9n 0.4674 9250.0n 0.5168 9499.9n 0.5168 9500.0n 0.2725 9749.9n 0.2725 9750.0n 0.7861 9999.9n 0.7861 10000.0n 0.5363 10249.9n 0.5363 10250.0n 0.2292 10499.9n 0.2292 10500.0n 0.5046 10749.9n 0.5046 10750.0n 0.1967 10999.9n 0.1967 11000.0n 0.1648 11249.9n 0.1648 11250.0n 0.1824 11499.9n 0.1824 11500.0n 0.6158 11749.9n 0.6158 11750.0n 0.5072 11999.9n 0.5072 12000.0n 0.6463 12249.9n 0.6463 12250.0n 0.0756 12499.9n 0.0756 12500.0n 0.4846 12749.9n 0.4846 12750.0n 0.1493 12999.9n 0.1493 13000.0n 0.2269 13249.9n 0.2269 13250.0n 0.4597 13499.9n 0.4597 13500.0n 0.5880 13749.9n 0.5880 13750.0n 0.4498 13999.9n 0.4498 14000.0n 0.5943 14249.9n 0.5943 14250.0n 0.4461 14499.9n 0.4461 14500.0n 0.1083 14749.9n 0.1083 14750.0n 0.8881 14999.9n 0.8881 15000.0n 0.8443 15249.9n 0.8443 15250.0n 0.1182 15499.9n 0.1182 15500.0n 0.3572 15749.9n 0.3572 15750.0n 0.1648 15999.9n 0.1648 16000.0n 0.1967 16249.9n 0.1967 16250.0n 0.5119 16499.9n 0.5119 16500.0n 0.6174 16749.9n 0.6174 16750.0n 0.5224 16999.9n 0.5224 17000.0n 0.5943 17249.9n 0.5943 17250.0n 0.5670 17499.9n 0.5670 17500.0n 0.5880 17749.9n 0.5880 17750.0n 0.1086 17999.9n 0.1086 18000.0n 0.6126 18249.9n 0.6126 18250.0n 0.1732 18499.9n 0.1732 18500.0n 0.5072 18749.9n 0.5072 18750.0n 0.4498 18999.9n 0.4498 19000.0n 0.5018 19249.9n 0.5018 19250.0n 0.5365 19499.9n 0.5365 19500.0n 0.8241 19749.9n 0.8241 19750.0n 0.6122 19999.9n 0.6122 20000.0n 0.6111 20249.9n 0.6111 20250.0n 0.5363 20499.9n 0.5363 20500.0n 0.8736 20749.9n 0.8736 20750.0n 0.2279 20999.9n 0.2279 21000.0n 0.5289 21249.9n 0.5289 21250.0n 0.6463 21499.9n 0.6463 21500.0n 0.6552 21749.9n 0.6552 21750.0n 0.4674 21999.9n 0.4674 22000.0n 0.8881 22249.9n 0.8881 22250.0n 0.7861 22499.9n 0.7861 22500.0n 0.5070 22749.9n 0.5070 22750.0n 0.5168 22999.9n 0.5168 23000.0n 0.0756 23249.9n 0.0756 23250.0n 0.2725 23499.9n 0.2725 23500.0n 0.2909 23749.9n 0.2909 23750.0n 0.1922 23999.9n 0.1922 24000.0n 0.4369 24249.9n 0.4369 24250.0n 0.4461 24499.9n 0.4461 24500.0n 0.4504 24749.9n 0.4504 24750.0n 0.4086 24999.9n 0.4086 25000.0n 0.1824 25249.9n 0.1824 25250.0n 0.3642 25499.9n 0.3642 25500.0n 0.3295 25749.9n 0.3295 25750.0n 0.4597 25999.9n 0.4597 26000.0n 0.1493 26249.9n 0.1493 26250.0n 0.5510 26499.9n 0.5510 26500.0n 0.4813 26749.9n 0.4813 26750.0n 0.4072 26999.9n 0.4072 27000.0n 0.6158 27249.9n 0.6158 27250.0n 0.4846 27499.9n 0.4846 27500.0n 0.2303 27749.9n 0.2303 27750.0n 0.5046 27999.9n 0.5046 28000.0n 0.5771 28249.9n 0.5771 28250.0n 0.1083 28499.9n 0.1083 28500.0n 0.6290 28749.9n 0.6290 28750.0n 0.2292 28999.9n 0.2292 29000.0n 0.4102 29249.9n 0.4102 29250.0n 0.5364 29499.9n 0.5364 29500.0n 0.2269 29749.9n 0.2269 29750.0n 0.1790 29999.9n 0.1790 30000.0n 0.2909 30249.9n 0.2909 30250.0n 0.5070 30499.9n 0.5070 30500.0n 0.1182 30749.9n 0.1182 30750.0n 0.5119 30999.9n 0.5119 31000.0n 0.5363 31249.9n 0.5363 31250.0n 0.8443 31499.9n 0.8443 31500.0n 0.2725 31749.9n 0.2725 31750.0n 0.6552 31999.9n 0.6552 32000.0n 0.1732 32249.9n 0.1732 32250.0n 0.5670 32499.9n 0.5670 32500.0n 0.8241 32749.9n 0.8241 32750.0n 0.1967 32999.9n 0.1967 33000.0n 0.5224 33249.9n 0.5224 33250.0n 0.3572 33499.9n 0.3572 33500.0n 0.4846 33749.9n 0.4846 33750.0n 0.2292 33999.9n 0.2292 34000.0n 0.1790 34249.9n 0.1790 34250.0n 0.4102 34499.9n 0.4102 34500.0n 0.7861 34749.9n 0.7861 34750.0n 0.5018 34999.9n 0.5018 35000.0n 0.6122 35249.9n 0.6122 35250.0n 0.8881 35499.9n 0.8881 35500.0n 0.4597 35749.9n 0.4597 35750.0n 0.1083 35999.9n 0.1083 36000.0n 0.8736 36249.9n 0.8736 36250.0n 0.1086 36499.9n 0.1086 36500.0n 0.5168 36749.9n 0.5168 36750.0n 0.0756 36999.9n 0.0756 37000.0n 0.6463 37249.9n 0.6463 37250.0n 0.4461 37499.9n 0.4461 37500.0n 0.1922 37749.9n 0.1922 37750.0n 0.6126 37999.9n 0.6126 38000.0n 0.3295 38249.9n 0.3295 38250.0n 0.2303 38499.9n 0.2303 38500.0n 0.4813 38749.9n 0.4813 38750.0n 0.5880 38999.9n 0.5880 39000.0n 0.4369 39249.9n 0.4369 39250.0n 0.5510 39499.9n 0.5510 39500.0n 0.5046 39749.9n 0.5046 39750.0n 0.2269 39999.9n 0.2269 40000.0n 0.1648 40249.9n 0.1648 40250.0n 0.1493 40499.9n 0.1493 40500.0n 0.5072 40749.9n 0.5072 40750.0n 0.5943 40999.9n 0.5943 41000.0n 0.2279 41249.9n 0.2279 41250.0n 0.4086 41499.9n 0.4086 41500.0n 0.4504 41749.9n 0.4504 41750.0n 0.4674 41999.9n 0.4674 42000.0n 0.4498 42249.9n 0.4498 42250.0n 0.5289 42499.9n 0.5289 42500.0n 0.6290 42749.9n 0.6290 42750.0n 0.1824 42999.9n 0.1824 43000.0n 0.6174 43249.9n 0.6174 43250.0n 0.5364 43499.9n 0.5364 43500.0n 0.3642 43749.9n 0.3642 43750.0n 0.4072 43999.9n 0.4072 44000.0n 0.5771 44249.9n 0.5771 44250.0n 0.6158 44499.9n 0.6158 44500.0n 0.5365 44749.9n 0.5365 44750.0n 0.6111 44999.9n 0.6111 45000.0n 0.3642 45249.9n 0.3642 45250.0n 0.5880 45499.9n 0.5880 45500.0n 0.5168 45749.9n 0.5168 45750.0n 0.4461 45999.9n 0.4461 46000.0n 0.1493 46249.9n 0.1493 46250.0n 0.1083 46499.9n 0.1083 46500.0n 0.2303 46749.9n 0.2303 46750.0n 0.6174 46999.9n 0.6174 47000.0n 0.5364 47249.9n 0.5364 47250.0n 0.2292 47499.9n 0.2292 47500.0n 0.6463 47749.9n 0.6463 47750.0n 0.5510 47999.9n 0.5510 48000.0n 0.5943 48249.9n 0.5943 48250.0n 0.1648 48499.9n 0.1648 48500.0n 0.3572 48749.9n 0.3572 48750.0n 0.2725 48999.9n 0.2725 49000.0n 0.2279 49249.9n 0.2279 49250.0n 0.5119 49499.9n 0.5119 49500.0n 0.5046 49749.9n 0.5046 49750.0n 0.5363 49999.9n 0.5363 50000.0n 0.4072 50249.9n 0.4072 50250.0n 0.1790 50499.9n 0.1790 50500.0n 0.5670 50749.9n 0.5670 50750.0n 0.5365 50999.9n 0.5365 51000.0n 0.4498 51249.9n 0.4498 51250.0n 0.7861 51499.9n 0.7861 51500.0n 0.4369 51749.9n 0.4369 51750.0n 0.6111 51999.9n 0.6111 52000.0n 0.8881 52249.9n 0.8881 52250.0n 0.1182 52499.9n 0.1182 52500.0n 0.8241 52749.9n 0.8241 52750.0n 0.6290 52999.9n 0.6290 53000.0n 0.0756 53249.9n 0.0756 53250.0n 0.6126 53499.9n 0.6126 53500.0n 0.8443 53749.9n 0.8443 53750.0n 0.1086 53999.9n 0.1086 54000.0n 0.8736 54249.9n 0.8736 54250.0n 0.1732 54499.9n 0.1732 54500.0n 0.2909 54749.9n 0.2909 54750.0n 0.4813 54999.9n 0.4813 55000.0n 0.2269 55249.9n 0.2269 55250.0n 0.1824 55499.9n 0.1824 55500.0n 0.4086 55749.9n 0.4086 55750.0n 0.5072 55999.9n 0.5072 56000.0n 0.4102 56249.9n 0.4102 56250.0n 0.5224 56499.9n 0.5224 56500.0n 0.4846 56749.9n 0.4846 56750.0n 0.3295 56999.9n 0.3295 57000.0n 0.5018 57249.9n 0.5018 57250.0n 0.6158 57499.9n 0.6158 57500.0n 0.5289 57749.9n 0.5289 57750.0n 0.5771 57999.9n 0.5771 58000.0n 0.6552 58249.9n 0.6552 58250.0n 0.5070 58499.9n 0.5070 58500.0n 0.1967 58749.9n 0.1967 58750.0n 0.4674 58999.9n 0.4674 59000.0n 0.1922 59249.9n 0.1922 59250.0n 0.4504 59499.9n 0.4504 59500.0n 0.4597 59749.9n 0.4597 59750.0n 0.6122 59999.9n 0.6122 60000.0n 0.1790 60249.9n 0.1790 60250.0n 0.2292 60499.9n 0.2292 60500.0n 0.1922 60749.9n 0.1922 60750.0n 0.4072 60999.9n 0.4072 61000.0n 0.4674 61249.9n 0.4674 61250.0n 0.1824 61499.9n 0.1824 61500.0n 0.1967 61749.9n 0.1967 61750.0n 0.1083 61999.9n 0.1083 62000.0n 0.4086 62249.9n 0.4086 62250.0n 0.6122 62499.9n 0.6122 62500.0n 0.3295 62749.9n 0.3295 62750.0n 0.5224 62999.9n 0.5224 63000.0n 0.6111 63249.9n 0.6111 63250.0n 0.5289 63499.9n 0.5289 63500.0n 0.6463 63749.9n 0.6463 63750.0n 0.2303 63999.9n 0.2303 64000.0n 0.8241 64249.9n 0.8241 64250.0n 0.8881 64499.9n 0.8881 64500.0n 0.1732 64749.9n 0.1732 64750.0n 0.4461 64999.9n 0.4461 65000.0n 0.5363 65249.9n 0.5363 65250.0n 0.3572 65499.9n 0.3572 65500.0n 0.1086 65749.9n 0.1086 65750.0n 0.4102 65999.9n 0.4102 66000.0n 0.4813 66249.9n 0.4813 66250.0n 0.5168 66499.9n 0.5168 66500.0n 0.5943 66749.9n 0.5943 66750.0n 0.6158 66999.9n 0.6158 67000.0n 0.5510 67249.9n 0.5510 67250.0n 0.2725 67499.9n 0.2725 67500.0n 0.5880 67749.9n 0.5880 67750.0n 0.5070 67999.9n 0.5070 68000.0n 0.8736 68249.9n 0.8736 68250.0n 0.7861 68499.9n 0.7861 68500.0n 0.6290 68749.9n 0.6290 68750.0n 0.2279 68999.9n 0.2279 69000.0n 0.4498 69249.9n 0.4498 69250.0n 0.5771 69499.9n 0.5771 69500.0n 0.4597 69749.9n 0.4597 69750.0n 0.5364 69999.9n 0.5364 70000.0n 0.6126 70249.9n 0.6126 70250.0n 0.5670 70499.9n 0.5670 70500.0n 0.5119 70749.9n 0.5119 70750.0n 0.2269 70999.9n 0.2269 71000.0n 0.4369 71249.9n 0.4369 71250.0n 0.4504 71499.9n 0.4504 71500.0n 0.2909 71749.9n 0.2909 71750.0n 0.3642 71999.9n 0.3642 72000.0n 0.5365 72249.9n 0.5365 72250.0n 0.1182 72499.9n 0.1182 72500.0n 0.5018 72749.9n 0.5018 72750.0n 0.1648 72999.9n 0.1648 73000.0n 0.8443 73249.9n 0.8443 73250.0n 0.6174 73499.9n 0.6174 73500.0n 0.5046 73749.9n 0.5046 73750.0n 0.4846 73999.9n 0.4846 74000.0n 0.1493 74249.9n 0.1493 74250.0n 0.5072 74499.9n 0.5072 74500.0n 0.0756 74749.9n 0.0756 74750.0n 0.6552 74999.9n 0.6552 75000.0n 0.4086 75249.9n 0.4086 75250.0n 0.6552 75499.9n 0.6552 75500.0n 0.5289 75749.9n 0.5289 75750.0n 0.2909 75999.9n 0.2909 76000.0n 0.4498 76249.9n 0.4498 76250.0n 0.5046 76499.9n 0.5046 76500.0n 0.1732 76749.9n 0.1732 76750.0n 0.5070 76999.9n 0.5070 77000.0n 0.6126 77249.9n 0.6126 77250.0n 0.5119 77499.9n 0.5119 77500.0n 0.5943 77749.9n 0.5943 77750.0n 0.1086 77999.9n 0.1086 78000.0n 0.8241 78249.9n 0.8241 78250.0n 0.6122 78499.9n 0.6122 78500.0n 0.8443 78749.9n 0.8443 78750.0n 0.6111 78999.9n 0.6111 79000.0n 0.3572 79249.9n 0.3572 79250.0n 0.5168 79499.9n 0.5168 79500.0n 0.6290 79749.9n 0.6290 79750.0n 0.5880 79999.9n 0.5880 80000.0n 0.1790 80249.9n 0.1790 80250.0n 0.2279 80499.9n 0.2279 80500.0n 0.4504 80749.9n 0.4504 80750.0n 0.5224 80999.9n 0.5224 81000.0n 0.5072 81249.9n 0.5072 81250.0n 0.3295 81499.9n 0.3295 81500.0n 0.6158 81749.9n 0.6158 81750.0n 0.6463 81999.9n 0.6463 82000.0n 0.6174 82249.9n 0.6174 82250.0n 0.5510 82499.9n 0.5510 82500.0n 0.2303 82749.9n 0.2303 82750.0n 0.4846 82999.9n 0.4846 83000.0n 0.4813 83249.9n 0.4813 83250.0n 0.5363 83499.9n 0.5363 83500.0n 0.3642 83749.9n 0.3642 83750.0n 0.4369 83999.9n 0.4369 84000.0n 0.4072 84249.9n 0.4072 84250.0n 0.2725 84499.9n 0.2725 84500.0n 0.5018 84749.9n 0.5018 84750.0n 0.4597 84999.9n 0.4597 85000.0n 0.0756 85249.9n 0.0756 85250.0n 0.8881 85499.9n 0.8881 85500.0n 0.1493 85749.9n 0.1493 85750.0n 0.7861 85999.9n 0.7861 86000.0n 0.5771 86249.9n 0.5771 86250.0n 0.1182 86499.9n 0.1182 86500.0n 0.2269 86749.9n 0.2269 86750.0n 0.2292 86999.9n 0.2292 87000.0n 0.5365 87249.9n 0.5365 87250.0n 0.4674 87499.9n 0.4674 87500.0n 0.4461 87749.9n 0.4461 87750.0n 0.5670 87999.9n 0.5670 88000.0n 0.1824 88249.9n 0.1824 88250.0n 0.1648 88499.9n 0.1648 88500.0n 0.8736 88749.9n 0.8736 88750.0n 0.1083 88999.9n 0.1083 89000.0n 0.1967 89249.9n 0.1967 89250.0n 0.5364 89499.9n 0.5364 89500.0n 0.1922 89749.9n 0.1922 89750.0n 0.4102 89999.9n 0.4102 90000.0n 0.6111 90249.9n 0.6111 90250.0n 0.3572 90499.9n 0.3572 90500.0n 0.1922 90749.9n 0.1922 90750.0n 0.5289 90999.9n 0.5289 91000.0n 0.3642 91249.9n 0.3642 91250.0n 0.8443 91499.9n 0.8443 91500.0n 0.8241 91749.9n 0.8241 91750.0n 0.3295 91999.9n 0.3295 92000.0n 0.1648 92249.9n 0.1648 92250.0n 0.5670 92499.9n 0.5670 92500.0n 0.4461 92749.9n 0.4461 92750.0n 0.1182 92999.9n 0.1182 93000.0n 0.1493 93249.9n 0.1493 93250.0n 0.6122 93499.9n 0.6122 93500.0n 0.4072 93749.9n 0.4072 93750.0n 0.2909 93999.9n 0.2909 94000.0n 0.1967 94249.9n 0.1967 94250.0n 0.6126 94499.9n 0.6126 94500.0n 0.4846 94749.9n 0.4846 94750.0n 0.2292 94999.9n 0.2292 95000.0n 0.5072 95249.9n 0.5072 95250.0n 0.4102 95499.9n 0.4102 95500.0n 0.4504 95749.9n 0.4504 95750.0n 0.4498 95999.9n 0.4498 96000.0n 0.8881 96249.9n 0.8881 96250.0n 0.1732 96499.9n 0.1732 96500.0n 0.6552 96749.9n 0.6552 96750.0n 0.5510 96999.9n 0.5510 97000.0n 0.4369 97249.9n 0.4369 97250.0n 0.5365 97499.9n 0.5365 97500.0n 0.5168 97749.9n 0.5168 97750.0n 0.8736 97999.9n 0.8736 98000.0n 0.2269 98249.9n 0.2269 98250.0n 0.1824 98499.9n 0.1824 98500.0n 0.4597 98749.9n 0.4597 98750.0n 0.1086 98999.9n 0.1086 99000.0n 0.4674 99249.9n 0.4674 99250.0n 0.7861 99499.9n 0.7861 99500.0n 0.1790 99749.9n 0.1790 99750.0n 0.5771 99999.9n 0.5771 100000.0n 0.6158 100249.9n 0.6158 100250.0n 0.5070 100499.9n 0.5070 100500.0n 0.5046 100749.9n 0.5046 100750.0n 0.5119 100999.9n 0.5119 101000.0n 0.6174 101249.9n 0.6174 101250.0n 0.2725 101499.9n 0.2725 101500.0n 0.5364 101749.9n 0.5364 101750.0n 0.2303 101999.9n 0.2303 102000.0n 0.5363 102249.9n 0.5363 102250.0n 0.4086 102499.9n 0.4086 102500.0n 0.6463 102749.9n 0.6463 102750.0n 0.4813 102999.9n 0.4813 103000.0n 0.1083 103249.9n 0.1083 103250.0n 0.5943 103499.9n 0.5943 103500.0n 0.5224 103749.9n 0.5224 103750.0n 0.6290 103999.9n 0.6290 104000.0n 0.5018 104249.9n 0.5018 104250.0n 0.2279 104499.9n 0.2279 104500.0n 0.0756 104749.9n 0.0756 104750.0n 0.5880 104999.9n 0.5880 105000.0n 0.5046 105249.9n 0.5046 105250.0n 0.2279 105499.9n 0.2279 105500.0n 0.1732 105749.9n 0.1732 105750.0n 0.2292 105999.9n 0.2292 106000.0n 0.6290 106249.9n 0.6290 106250.0n 0.4369 106499.9n 0.4369 106500.0n 0.4461 106749.9n 0.4461 106750.0n 0.4072 106999.9n 0.4072 107000.0n 0.2725 107249.9n 0.2725 107250.0n 0.0756 107499.9n 0.0756 107500.0n 0.1086 107749.9n 0.1086 107750.0n 0.6158 107999.9n 0.6158 108000.0n 0.5943 108249.9n 0.5943 108250.0n 0.1083 108499.9n 0.1083 108500.0n 0.5880 108749.9n 0.5880 108750.0n 0.5119 108999.9n 0.5119 109000.0n 0.6552 109249.9n 0.6552 109250.0n 0.2269 109499.9n 0.2269 109500.0n 0.4086 109749.9n 0.4086 109750.0n 0.5168 109999.9n 0.5168 110000.0n 0.3572 110249.9n 0.3572 110250.0n 0.6122 110499.9n 0.6122 110500.0n 0.5510 110749.9n 0.5510 110750.0n 0.4674 110999.9n 0.4674 111000.0n 0.2909 111249.9n 0.2909 111250.0n 0.8881 111499.9n 0.8881 111500.0n 0.8443 111749.9n 0.8443 111750.0n 0.5364 111999.9n 0.5364 112000.0n 0.1967 112249.9n 0.1967 112250.0n 0.2303 112499.9n 0.2303 112500.0n 0.5224 112749.9n 0.5224 112750.0n 0.8736 112999.9n 0.8736 113000.0n 0.4813 113249.9n 0.4813 113250.0n 0.4102 113499.9n 0.4102 113500.0n 0.8241 113749.9n 0.8241 113750.0n 0.3642 113999.9n 0.3642 114000.0n 0.5365 114249.9n 0.5365 114250.0n 0.5018 114499.9n 0.5018 114500.0n 0.5289 114749.9n 0.5289 114750.0n 0.5771 114999.9n 0.5771 115000.0n 0.3295 115249.9n 0.3295 115250.0n 0.5072 115499.9n 0.5072 115500.0n 0.6463 115749.9n 0.6463 115750.0n 0.1493 115999.9n 0.1493 116000.0n 0.1790 116249.9n 0.1790 116250.0n 0.4597 116499.9n 0.4597 116500.0n 0.4504 116749.9n 0.4504 116750.0n 0.6174 116999.9n 0.6174 117000.0n 0.1824 117249.9n 0.1824 117250.0n 0.6126 117499.9n 0.6126 117500.0n 0.1648 117749.9n 0.1648 117750.0n 0.6111 117999.9n 0.6111 118000.0n 0.5070 118249.9n 0.5070 118250.0n 0.5363 118499.9n 0.5363 118500.0n 0.5670 118749.9n 0.5670 118750.0n 0.4846 118999.9n 0.4846 119000.0n 0.4498 119249.9n 0.4498 119250.0n 0.1922 119499.9n 0.1922 119500.0n 0.1182 119749.9n 0.1182 119750.0n 0.7861 119999.9n 0.7861 120000.0n 0.5168 120249.9n 0.5168 120250.0n 0.2725 120499.9n 0.2725 120500.0n 0.4086 120749.9n 0.4086 120750.0n 0.5289 120999.9n 0.5289 121000.0n 0.2909 121249.9n 0.2909 121250.0n 0.5046 121499.9n 0.5046 121500.0n 0.6463 121749.9n 0.6463 121750.0n 0.1790 121999.9n 0.1790 122000.0n 0.4846 122249.9n 0.4846 122250.0n 0.6290 122499.9n 0.6290 122500.0n 0.2279 122749.9n 0.2279 122750.0n 0.5771 122999.9n 0.5771 123000.0n 0.7861 123249.9n 0.7861 123250.0n 0.5119 123499.9n 0.5119 123500.0n 0.5365 123749.9n 0.5365 123750.0n 0.5363 123999.9n 0.5363 124000.0n 0.5224 124249.9n 0.5224 124250.0n 0.5880 124499.9n 0.5880 124500.0n 0.1732 124749.9n 0.1732 124750.0n 0.4813 124999.9n 0.4813 125000.0n 0.5510 125249.9n 0.5510 125250.0n 0.1086 125499.9n 0.1086 125500.0n 0.5018 125749.9n 0.5018 125750.0n 0.6552 125999.9n 0.6552 126000.0n 0.4102 126249.9n 0.4102 126250.0n 0.1083 126499.9n 0.1083 126500.0n 0.8881 126749.9n 0.8881 126750.0n 0.4369 126999.9n 0.4369 127000.0n 0.1493 127249.9n 0.1493 127250.0n 0.4674 127499.9n 0.4674 127500.0n 0.5943 127749.9n 0.5943 127750.0n 0.8736 127999.9n 0.8736 128000.0n 0.8443 128249.9n 0.8443 128250.0n 0.4461 128499.9n 0.4461 128500.0n 0.4498 128749.9n 0.4498 128750.0n 0.6174 128999.9n 0.6174 129000.0n 0.3642 129249.9n 0.3642 129250.0n 0.8241 129499.9n 0.8241 129500.0n 0.1967 129749.9n 0.1967 129750.0n 0.5072 129999.9n 0.5072 130000.0n 0.4597 130249.9n 0.4597 130250.0n 0.6158 130499.9n 0.6158 130500.0n 0.6111 130749.9n 0.6111 130750.0n 0.3295 130999.9n 0.3295 131000.0n 0.6122 131249.9n 0.6122 131250.0n 0.4504 131499.9n 0.4504 131500.0n 0.1922 131749.9n 0.1922 131750.0n 0.0756 131999.9n 0.0756 132000.0n 0.1824 132249.9n 0.1824 132250.0n 0.2303 132499.9n 0.2303 132500.0n 0.6126 132749.9n 0.6126 132750.0n 0.2292 132999.9n 0.2292 133000.0n 0.5364 133249.9n 0.5364 133250.0n 0.2269 133499.9n 0.2269 133500.0n 0.3572 133749.9n 0.3572 133750.0n 0.1648 133999.9n 0.1648 134000.0n 0.4072 134249.9n 0.4072 134250.0n 0.5670 134499.9n 0.5670 134500.0n 0.5070 134749.9n 0.5070 134750.0n 0.1182 134999.9n 0.1182 135000.0n 0.2292 135249.9n 0.2292 135250.0n 0.4846 135499.9n 0.4846 135500.0n 0.3295 135749.9n 0.3295 135750.0n 0.4461 135999.9n 0.4461 136000.0n 0.4369 136249.9n 0.4369 136250.0n 0.8881 136499.9n 0.8881 136500.0n 0.6174 136749.9n 0.6174 136750.0n 0.5510 136999.9n 0.5510 137000.0n 0.6552 137249.9n 0.6552 137250.0n 0.4597 137499.9n 0.4597 137500.0n 0.5070 137749.9n 0.5070 137750.0n 0.2725 137999.9n 0.2725 138000.0n 0.2909 138249.9n 0.2909 138250.0n 0.0756 138499.9n 0.0756 138500.0n 0.3572 138749.9n 0.3572 138750.0n 0.8736 138999.9n 0.8736 139000.0n 0.1967 139249.9n 0.1967 139250.0n 0.3642 139499.9n 0.3642 139500.0n 0.5943 139749.9n 0.5943 139750.0n 0.2269 139999.9n 0.2269 140000.0n 0.2279 140249.9n 0.2279 140250.0n 0.7861 140499.9n 0.7861 140500.0n 0.1732 140749.9n 0.1732 140750.0n 0.5670 140999.9n 0.5670 141000.0n 0.1922 141249.9n 0.1922 141250.0n 0.6122 141499.9n 0.6122 141500.0n 0.6290 141749.9n 0.6290 141750.0n 0.1083 141999.9n 0.1083 142000.0n 0.4813 142249.9n 0.4813 142250.0n 0.6126 142499.9n 0.6126 142500.0n 0.5018 142749.9n 0.5018 142750.0n 0.6463 142999.9n 0.6463 143000.0n 0.5119 143249.9n 0.5119 143250.0n 0.5880 143499.9n 0.5880 143500.0n 0.4102 143749.9n 0.4102 143750.0n 0.5289 143999.9n 0.5289 144000.0n 0.1824 144249.9n 0.1824 144250.0n 0.5365 144499.9n 0.5365 144500.0n 0.6111 144749.9n 0.6111 144750.0n 0.8241 144999.9n 0.8241 145000.0n 0.5168 145249.9n 0.5168 145250.0n 0.1182 145499.9n 0.1182 145500.0n 0.1790 145749.9n 0.1790 145750.0n 0.5771 145999.9n 0.5771 146000.0n 0.5072 146249.9n 0.5072 146250.0n 0.5364 146499.9n 0.5364 146500.0n 0.5224 146749.9n 0.5224 146750.0n 0.4674 146999.9n 0.4674 147000.0n 0.1648 147249.9n 0.1648 147250.0n 0.5363 147499.9n 0.5363 147500.0n 0.4498 147749.9n 0.4498 147750.0n 0.4086 147999.9n 0.4086 148000.0n 0.5046 148249.9n 0.5046 148250.0n 0.2303 148499.9n 0.2303 148500.0n 0.1086 148749.9n 0.1086 148750.0n 0.8443 148999.9n 0.8443 149000.0n 0.4072 149249.9n 0.4072 149250.0n 0.4504 149499.9n 0.4504 149500.0n 0.6158 149749.9n 0.6158 149750.0n 0.1493 149999.9n 0.1493 150000.0n 0.1922 150249.9n 0.1922 150250.0n 0.6158 150499.9n 0.6158 150500.0n 0.1083 150749.9n 0.1083 150750.0n 0.1086 150999.9n 0.1086 151000.0n 0.5670 151249.9n 0.5670 151250.0n 0.2909 151499.9n 0.2909 151500.0n 0.6290 151749.9n 0.6290 151750.0n 0.4461 151999.9n 0.4461 152000.0n 0.8736 152249.9n 0.8736 152250.0n 0.5018 152499.9n 0.5018 152500.0n 0.4498 152749.9n 0.4498 152750.0n 0.5880 152999.9n 0.5880 153000.0n 0.2292 153249.9n 0.2292 153250.0n 0.8881 153499.9n 0.8881 153500.0n 0.2725 153749.9n 0.2725 153750.0n 0.7861 153999.9n 0.7861 154000.0n 0.4597 154249.9n 0.4597 154250.0n 0.1732 154499.9n 0.1732 154500.0n 0.4813 154749.9n 0.4813 154750.0n 0.4369 154999.9n 0.4369 155000.0n 0.5365 155249.9n 0.5365 155250.0n 0.5510 155499.9n 0.5510 155500.0n 0.6552 155749.9n 0.6552 155750.0n 0.6111 155999.9n 0.6111 156000.0n 0.1824 156249.9n 0.1824 156250.0n 0.5224 156499.9n 0.5224 156500.0n 0.4674 156749.9n 0.4674 156750.0n 0.3572 156999.9n 0.3572 157000.0n 0.4072 157249.9n 0.4072 157250.0n 0.4846 157499.9n 0.4846 157500.0n 0.4102 157749.9n 0.4102 157750.0n 0.6174 157999.9n 0.6174 158000.0n 0.6122 158249.9n 0.6122 158250.0n 0.1790 158499.9n 0.1790 158500.0n 0.1182 158749.9n 0.1182 158750.0n 0.1493 158999.9n 0.1493 159000.0n 0.5289 159249.9n 0.5289 159250.0n 0.8443 159499.9n 0.8443 159500.0n 0.5168 159749.9n 0.5168 159750.0n 0.0756 159999.9n 0.0756 160000.0n 0.5771 160249.9n 0.5771 160250.0n 0.5364 160499.9n 0.5364 160500.0n 0.6463 160749.9n 0.6463 160750.0n 0.2279 160999.9n 0.2279 161000.0n 0.6126 161249.9n 0.6126 161250.0n 0.8241 161499.9n 0.8241 161500.0n 0.2269 161749.9n 0.2269 161750.0n 0.1967 161999.9n 0.1967 162000.0n 0.5363 162249.9n 0.5363 162250.0n 0.4504 162499.9n 0.4504 162500.0n 0.5072 162749.9n 0.5072 162750.0n 0.5119 162999.9n 0.5119 163000.0n 0.1648 163249.9n 0.1648 163250.0n 0.4086 163499.9n 0.4086 163500.0n 0.3295 163749.9n 0.3295 163750.0n 0.5046 163999.9n 0.5046 164000.0n 0.2303 164249.9n 0.2303 164250.0n 0.5070 164499.9n 0.5070 164500.0n 0.3642 164749.9n 0.3642 164750.0n 0.5943 164999.9n 0.5943 165000.0n 0.5880 165249.9n 0.5880 165250.0n 0.6111 165499.9n 0.6111 165500.0n 0.7861 165749.9n 0.7861 165750.0n 0.5943 165999.9n 0.5943 166000.0n 0.4597 166249.9n 0.4597 166250.0n 0.6174 166499.9n 0.6174 166500.0n 0.4461 166749.9n 0.4461 166750.0n 0.6158 166999.9n 0.6158 167000.0n 0.1493 167249.9n 0.1493 167250.0n 0.4504 167499.9n 0.4504 167500.0n 0.8443 167749.9n 0.8443 167750.0n 0.5168 167999.9n 0.5168 168000.0n 0.2292 168249.9n 0.2292 168250.0n 0.6552 168499.9n 0.6552 168500.0n 0.5364 168749.9n 0.5364 168750.0n 0.1083 168999.9n 0.1083 169000.0n 0.4369 169249.9n 0.4369 169250.0n 0.5771 169499.9n 0.5771 169500.0n 0.5070 169749.9n 0.5070 169750.0n 0.6126 169999.9n 0.6126 170000.0n 0.4086 170249.9n 0.4086 170250.0n 0.8736 170499.9n 0.8736 170500.0n 0.1922 170749.9n 0.1922 170750.0n 0.5018 170999.9n 0.5018 171000.0n 0.1790 171249.9n 0.1790 171250.0n 0.1967 171499.9n 0.1967 171500.0n 0.2303 171749.9n 0.2303 171750.0n 0.1732 171999.9n 0.1732 172000.0n 0.5670 172249.9n 0.5670 172250.0n 0.4102 172499.9n 0.4102 172500.0n 0.6122 172749.9n 0.6122 172750.0n 0.4072 172999.9n 0.4072 173000.0n 0.2909 173249.9n 0.2909 173250.0n 0.8881 173499.9n 0.8881 173500.0n 0.1086 173749.9n 0.1086 173750.0n 0.5119 173999.9n 0.5119 174000.0n 0.4674 174249.9n 0.4674 174250.0n 0.1648 174499.9n 0.1648 174500.0n 0.2269 174749.9n 0.2269 174750.0n 0.8241 174999.9n 0.8241 175000.0n 0.4846 175249.9n 0.4846 175250.0n 0.5510 175499.9n 0.5510 175500.0n 0.5363 175749.9n 0.5363 175750.0n 0.6290 175999.9n 0.6290 176000.0n 0.0756 176249.9n 0.0756 176250.0n 0.5224 176499.9n 0.5224 176500.0n 0.3572 176749.9n 0.3572 176750.0n 0.4813 176999.9n 0.4813 177000.0n 0.2725 177249.9n 0.2725 177250.0n 0.3295 177499.9n 0.3295 177500.0n 0.4498 177749.9n 0.4498 177750.0n 0.5289 177999.9n 0.5289 178000.0n 0.5365 178249.9n 0.5365 178250.0n 0.5072 178499.9n 0.5072 178500.0n 0.3642 178749.9n 0.3642 178750.0n 0.1824 178999.9n 0.1824 179000.0n 0.2279 179249.9n 0.2279 179250.0n 0.1182 179499.9n 0.1182 179500.0n 0.6463 179749.9n 0.6463 179750.0n 0.5046 179999.9n 0.5046 180000.0n 0.5628 180249.9n 0.5628 180250.0n 0.7224 180499.9n 0.7224 180500.0n 0.2013 180749.9n 0.2013 180750.0n 0.5698 180999.9n 0.5698 181000.0n 0.5080 181249.9n 0.5080 181250.0n 0.5550 181499.9n 0.5550 181500.0n 0.5064 181749.9n 0.5064 181750.0n 0.6573 181999.9n 0.6573 182000.0n 0.5605 182249.9n 0.5605 182250.0n 0.1019 182499.9n 0.1019 182500.0n 0.1465 182749.9n 0.1465 182750.0n 0.5126 182999.9n 0.5126 183000.0n 0.4447 183249.9n 0.4447 183250.0n 0.4585 183499.9n 0.4585 183500.0n 0.7141 183749.9n 0.7141 183750.0n 0.3288 183999.9n 0.3288 184000.0n 0.7884 184249.9n 0.7884 184250.0n 0.3762 184499.9n 0.3762 184500.0n 0.9071 184749.9n 0.9071 184750.0n 0.4805 184999.9n 0.4805 185000.0n 0.8757 185249.9n 0.8757 185250.0n 0.3833 185499.9n 0.3833 185500.0n 0.8079 185749.9n 0.8079 185750.0n 0.5021 185999.9n 0.5021 186000.0n 0.6169 186249.9n 0.6169 186250.0n 0.3723 186499.9n 0.3723 186500.0n 0.6307 186749.9n 0.6307 186750.0n 0.8091 186999.9n 0.8091 187000.0n 0.2620 187249.9n 0.2620 187250.0n 0.5020 187499.9n 0.5020 187500.0n 0.5238 187749.9n 0.5238 187750.0n 0.1481 187999.9n 0.1481 188000.0n 0.6635 188249.9n 0.6635 188250.0n 0.5848 188499.9n 0.5848 188500.0n 0.5103 188749.9n 0.5103 188750.0n 0.5150 188999.9n 0.5150 189000.0n 0.3443 189249.9n 0.3443 189250.0n 0.6492 189499.9n 0.6492 189500.0n 0.4994 189749.9n 0.4994 189750.0n 0.1510 189999.9n 0.1510 190000.0n 0.4954 190249.9n 0.4954 190250.0n 0.3500 190499.9n 0.3500 190500.0n 0.6256 190749.9n 0.6256 190750.0n 0.0810 190999.9n 0.0810 191000.0n 0.3122 191249.9n 0.3122 191250.0n 0.5624 191499.9n 0.5624 191500.0n 0.5106 191749.9n 0.5106 191750.0n 0.4443 191999.9n 0.4443 192000.0n 0.4803 192249.9n 0.4803 192250.0n 0.5387 192499.9n 0.5387 192500.0n 0.1975 192749.9n 0.1975 192750.0n 0.7840 192999.9n 0.7840 193000.0n 0.5644 193249.9n 0.5644 193250.0n 0.6000 193499.9n 0.6000 193500.0n 0.4892 193749.9n 0.4892 193750.0n 0.4024 193999.9n 0.4024 194000.0n 0.3745 194249.9n 0.3745 194250.0n 0.8031 194499.9n 0.8031 194500.0n 0.4870 194749.9n 0.4870 194750.0n 0.5352 194999.9n 0.5352 195000.0n 0.4469 195249.9n 0.4469 195250.0n 0.5053 195499.9n 0.5053 195500.0n 0.0397 195749.9n 0.0397 195750.0n 0.5362 195999.9n 0.5362 196000.0n 0.5938 196249.9n 0.5938 196250.0n 0.5548 196499.9n 0.5548 196500.0n 0.9446 196749.9n 0.9446 196750.0n 0.7154 196999.9n 0.7154 197000.0n 0.1771 197249.9n 0.1771 197250.0n 0.5497 197499.9n 0.5497 197500.0n 0.4738 197749.9n 0.4738 197750.0n 0.3712 197999.9n 0.3712 198000.0n 0.5352 198249.9n 0.5352 198250.0n 0.6972 198499.9n 0.6972 198500.0n 0.1934 198749.9n 0.1934 198750.0n 0.2946 198999.9n 0.2946 199000.0n 0.4468 199249.9n 0.4468 199250.0n 0.5128 199499.9n 0.5128 199500.0n 0.3398 199749.9n 0.3398 199750.0n 0.3059 199999.9n 0.3059 200000.0n 0.5228 200249.9n 0.5228 200250.0n 0.4967 200499.9n 0.4967 200500.0n 0.5150 200749.9n 0.5150 200750.0n 0.4595 200999.9n 0.4595 201000.0n 0.8423 201249.9n 0.8423 201250.0n 0.4767 201499.9n 0.4767 201500.0n 0.2020 201749.9n 0.2020 201750.0n 0.4152 201999.9n 0.4152 202000.0n 0.8297 202249.9n 0.8297 202250.0n 0.5544 202499.9n 0.5544 202500.0n 0.3106 202749.9n 0.3106 202750.0n 0.5677 202999.9n 0.5677 203000.0n 0.2659 203249.9n 0.2659 203250.0n 0.4821 203499.9n 0.4821 203500.0n 0.5335 203749.9n 0.5335 203750.0n 0.1607 203999.9n 0.1607 204000.0n 0.8245 204249.9n 0.8245 204250.0n 0.7992 204499.9n 0.7992 204500.0n 0.1423 204749.9n 0.1423 204750.0n 0.4480 204999.9n 0.4480 205000.0n 0.5915 205249.9n 0.5915 205250.0n 0.5092 205499.9n 0.5092 205500.0n 0.4901 205749.9n 0.4901 205750.0n 0.5363 205999.9n 0.5363 206000.0n 0.7746 206249.9n 0.7746 206250.0n 0.4996 206499.9n 0.4996 206500.0n 0.2029 206749.9n 0.2029 206750.0n 0.1365 206999.9n 0.1365 207000.0n 0.5936 207249.9n 0.5936 207250.0n 0.4783 207499.9n 0.4783 207500.0n 0.5901 207749.9n 0.5901 207750.0n 0.1198 207999.9n 0.1198 208000.0n 0.3122 208249.9n 0.3122 208250.0n 0.6592 208499.9n 0.6592 208500.0n 0.5009 208749.9n 0.5009 208750.0n 0.4467 208999.9n 0.4467 209000.0n 0.4810 209249.9n 0.4810 209250.0n 0.6896 209499.9n 0.6896 209500.0n 0.5404 209749.9n 0.5404 209750.0n 0.7100)
Vx2n a_xn2 0 PWL(0.0n 0.8818 249.9n 0.8818 250.0n 0.6428 499.9n 0.6428 500.0n 0.5914 749.9n 0.5914 750.0n 0.1557 999.9n 0.1557 1000.0n 0.5631 1249.9n 0.5631 1250.0n 0.1759 1499.9n 0.1759 1500.0n 0.6705 1749.9n 0.6705 1750.0n 0.7091 1999.9n 0.7091 2000.0n 0.8078 2249.9n 0.8078 2250.0n 0.4930 2499.9n 0.4930 2500.0n 0.5496 2749.9n 0.5496 2750.0n 0.3826 2999.9n 0.3826 3000.0n 0.8210 3249.9n 0.8210 3250.0n 0.3889 3499.9n 0.3889 3500.0n 0.7697 3749.9n 0.7697 3750.0n 0.5928 3999.9n 0.5928 4000.0n 0.4229 4249.9n 0.4229 4250.0n 0.1264 4499.9n 0.1264 4500.0n 0.4982 4749.9n 0.4982 4750.0n 0.3878 4999.9n 0.3878 5000.0n 0.3448 5249.9n 0.3448 5250.0n 0.4711 5499.9n 0.4711 5500.0n 0.4490 5749.9n 0.4490 5750.0n 0.6358 5999.9n 0.6358 6000.0n 0.4776 6249.9n 0.4776 6250.0n 0.5898 6499.9n 0.5898 6500.0n 0.7721 6749.9n 0.7721 6750.0n 0.5187 6999.9n 0.5187 7000.0n 0.4330 7249.9n 0.4330 7250.0n 0.3710 7499.9n 0.3710 7500.0n 0.8914 7749.9n 0.8914 7750.0n 0.4636 7999.9n 0.4636 8000.0n 0.3874 8249.9n 0.3874 8250.0n 0.4635 8499.9n 0.4635 8500.0n 0.4881 8749.9n 0.4881 8750.0n 0.8268 8999.9n 0.8268 9000.0n 0.5326 9249.9n 0.5326 9250.0n 0.4832 9499.9n 0.4832 9500.0n 0.7275 9749.9n 0.7275 9750.0n 0.2139 9999.9n 0.2139 10000.0n 0.4637 10249.9n 0.4637 10250.0n 0.7708 10499.9n 0.7708 10500.0n 0.4954 10749.9n 0.4954 10750.0n 0.8033 10999.9n 0.8033 11000.0n 0.8352 11249.9n 0.8352 11250.0n 0.8176 11499.9n 0.8176 11500.0n 0.3842 11749.9n 0.3842 11750.0n 0.4928 11999.9n 0.4928 12000.0n 0.3537 12249.9n 0.3537 12250.0n 0.9244 12499.9n 0.9244 12500.0n 0.5154 12749.9n 0.5154 12750.0n 0.8507 12999.9n 0.8507 13000.0n 0.7731 13249.9n 0.7731 13250.0n 0.5403 13499.9n 0.5403 13500.0n 0.4120 13749.9n 0.4120 13750.0n 0.5502 13999.9n 0.5502 14000.0n 0.4057 14249.9n 0.4057 14250.0n 0.5539 14499.9n 0.5539 14500.0n 0.8917 14749.9n 0.8917 14750.0n 0.1119 14999.9n 0.1119 15000.0n 0.1557 15249.9n 0.1557 15250.0n 0.8818 15499.9n 0.8818 15500.0n 0.6428 15749.9n 0.6428 15750.0n 0.8352 15999.9n 0.8352 16000.0n 0.8033 16249.9n 0.8033 16250.0n 0.4881 16499.9n 0.4881 16500.0n 0.3826 16749.9n 0.3826 16750.0n 0.4776 16999.9n 0.4776 17000.0n 0.4057 17249.9n 0.4057 17250.0n 0.4330 17499.9n 0.4330 17500.0n 0.4120 17749.9n 0.4120 17750.0n 0.8914 17999.9n 0.8914 18000.0n 0.3874 18249.9n 0.3874 18250.0n 0.8268 18499.9n 0.8268 18500.0n 0.4928 18749.9n 0.4928 18750.0n 0.5502 18999.9n 0.5502 19000.0n 0.4982 19249.9n 0.4982 19250.0n 0.4635 19499.9n 0.4635 19500.0n 0.1759 19749.9n 0.1759 19750.0n 0.3878 19999.9n 0.3878 20000.0n 0.3889 20249.9n 0.3889 20250.0n 0.4637 20499.9n 0.4637 20500.0n 0.1264 20749.9n 0.1264 20750.0n 0.7721 20999.9n 0.7721 21000.0n 0.4711 21249.9n 0.4711 21250.0n 0.3537 21499.9n 0.3537 21500.0n 0.3448 21749.9n 0.3448 21750.0n 0.5326 21999.9n 0.5326 22000.0n 0.1119 22249.9n 0.1119 22250.0n 0.2139 22499.9n 0.2139 22500.0n 0.4930 22749.9n 0.4930 22750.0n 0.4832 22999.9n 0.4832 23000.0n 0.9244 23249.9n 0.9244 23250.0n 0.7275 23499.9n 0.7275 23500.0n 0.7091 23749.9n 0.7091 23750.0n 0.8078 23999.9n 0.8078 24000.0n 0.5631 24249.9n 0.5631 24250.0n 0.5539 24499.9n 0.5539 24500.0n 0.5496 24749.9n 0.5496 24750.0n 0.5914 24999.9n 0.5914 25000.0n 0.8176 25249.9n 0.8176 25250.0n 0.6358 25499.9n 0.6358 25500.0n 0.6705 25749.9n 0.6705 25750.0n 0.5403 25999.9n 0.5403 26000.0n 0.8507 26249.9n 0.8507 26250.0n 0.4490 26499.9n 0.4490 26500.0n 0.5187 26749.9n 0.5187 26750.0n 0.5928 26999.9n 0.5928 27000.0n 0.3842 27249.9n 0.3842 27250.0n 0.5154 27499.9n 0.5154 27500.0n 0.7697 27749.9n 0.7697 27750.0n 0.4954 27999.9n 0.4954 28000.0n 0.4229 28249.9n 0.4229 28250.0n 0.8917 28499.9n 0.8917 28500.0n 0.3710 28749.9n 0.3710 28750.0n 0.7708 28999.9n 0.7708 29000.0n 0.5898 29249.9n 0.5898 29250.0n 0.4636 29499.9n 0.4636 29500.0n 0.7731 29749.9n 0.7731 29750.0n 0.8210 29999.9n 0.8210 30000.0n 0.7091 30249.9n 0.7091 30250.0n 0.4930 30499.9n 0.4930 30500.0n 0.8818 30749.9n 0.8818 30750.0n 0.4881 30999.9n 0.4881 31000.0n 0.4637 31249.9n 0.4637 31250.0n 0.1557 31499.9n 0.1557 31500.0n 0.7275 31749.9n 0.7275 31750.0n 0.3448 31999.9n 0.3448 32000.0n 0.8268 32249.9n 0.8268 32250.0n 0.4330 32499.9n 0.4330 32500.0n 0.1759 32749.9n 0.1759 32750.0n 0.8033 32999.9n 0.8033 33000.0n 0.4776 33249.9n 0.4776 33250.0n 0.6428 33499.9n 0.6428 33500.0n 0.5154 33749.9n 0.5154 33750.0n 0.7708 33999.9n 0.7708 34000.0n 0.8210 34249.9n 0.8210 34250.0n 0.5898 34499.9n 0.5898 34500.0n 0.2139 34749.9n 0.2139 34750.0n 0.4982 34999.9n 0.4982 35000.0n 0.3878 35249.9n 0.3878 35250.0n 0.1119 35499.9n 0.1119 35500.0n 0.5403 35749.9n 0.5403 35750.0n 0.8917 35999.9n 0.8917 36000.0n 0.1264 36249.9n 0.1264 36250.0n 0.8914 36499.9n 0.8914 36500.0n 0.4832 36749.9n 0.4832 36750.0n 0.9244 36999.9n 0.9244 37000.0n 0.3537 37249.9n 0.3537 37250.0n 0.5539 37499.9n 0.5539 37500.0n 0.8078 37749.9n 0.8078 37750.0n 0.3874 37999.9n 0.3874 38000.0n 0.6705 38249.9n 0.6705 38250.0n 0.7697 38499.9n 0.7697 38500.0n 0.5187 38749.9n 0.5187 38750.0n 0.4120 38999.9n 0.4120 39000.0n 0.5631 39249.9n 0.5631 39250.0n 0.4490 39499.9n 0.4490 39500.0n 0.4954 39749.9n 0.4954 39750.0n 0.7731 39999.9n 0.7731 40000.0n 0.8352 40249.9n 0.8352 40250.0n 0.8507 40499.9n 0.8507 40500.0n 0.4928 40749.9n 0.4928 40750.0n 0.4057 40999.9n 0.4057 41000.0n 0.7721 41249.9n 0.7721 41250.0n 0.5914 41499.9n 0.5914 41500.0n 0.5496 41749.9n 0.5496 41750.0n 0.5326 41999.9n 0.5326 42000.0n 0.5502 42249.9n 0.5502 42250.0n 0.4711 42499.9n 0.4711 42500.0n 0.3710 42749.9n 0.3710 42750.0n 0.8176 42999.9n 0.8176 43000.0n 0.3826 43249.9n 0.3826 43250.0n 0.4636 43499.9n 0.4636 43500.0n 0.6358 43749.9n 0.6358 43750.0n 0.5928 43999.9n 0.5928 44000.0n 0.4229 44249.9n 0.4229 44250.0n 0.3842 44499.9n 0.3842 44500.0n 0.4635 44749.9n 0.4635 44750.0n 0.3889 44999.9n 0.3889 45000.0n 0.6358 45249.9n 0.6358 45250.0n 0.4120 45499.9n 0.4120 45500.0n 0.4832 45749.9n 0.4832 45750.0n 0.5539 45999.9n 0.5539 46000.0n 0.8507 46249.9n 0.8507 46250.0n 0.8917 46499.9n 0.8917 46500.0n 0.7697 46749.9n 0.7697 46750.0n 0.3826 46999.9n 0.3826 47000.0n 0.4636 47249.9n 0.4636 47250.0n 0.7708 47499.9n 0.7708 47500.0n 0.3537 47749.9n 0.3537 47750.0n 0.4490 47999.9n 0.4490 48000.0n 0.4057 48249.9n 0.4057 48250.0n 0.8352 48499.9n 0.8352 48500.0n 0.6428 48749.9n 0.6428 48750.0n 0.7275 48999.9n 0.7275 49000.0n 0.7721 49249.9n 0.7721 49250.0n 0.4881 49499.9n 0.4881 49500.0n 0.4954 49749.9n 0.4954 49750.0n 0.4637 49999.9n 0.4637 50000.0n 0.5928 50249.9n 0.5928 50250.0n 0.8210 50499.9n 0.8210 50500.0n 0.4330 50749.9n 0.4330 50750.0n 0.4635 50999.9n 0.4635 51000.0n 0.5502 51249.9n 0.5502 51250.0n 0.2139 51499.9n 0.2139 51500.0n 0.5631 51749.9n 0.5631 51750.0n 0.3889 51999.9n 0.3889 52000.0n 0.1119 52249.9n 0.1119 52250.0n 0.8818 52499.9n 0.8818 52500.0n 0.1759 52749.9n 0.1759 52750.0n 0.3710 52999.9n 0.3710 53000.0n 0.9244 53249.9n 0.9244 53250.0n 0.3874 53499.9n 0.3874 53500.0n 0.1557 53749.9n 0.1557 53750.0n 0.8914 53999.9n 0.8914 54000.0n 0.1264 54249.9n 0.1264 54250.0n 0.8268 54499.9n 0.8268 54500.0n 0.7091 54749.9n 0.7091 54750.0n 0.5187 54999.9n 0.5187 55000.0n 0.7731 55249.9n 0.7731 55250.0n 0.8176 55499.9n 0.8176 55500.0n 0.5914 55749.9n 0.5914 55750.0n 0.4928 55999.9n 0.4928 56000.0n 0.5898 56249.9n 0.5898 56250.0n 0.4776 56499.9n 0.4776 56500.0n 0.5154 56749.9n 0.5154 56750.0n 0.6705 56999.9n 0.6705 57000.0n 0.4982 57249.9n 0.4982 57250.0n 0.3842 57499.9n 0.3842 57500.0n 0.4711 57749.9n 0.4711 57750.0n 0.4229 57999.9n 0.4229 58000.0n 0.3448 58249.9n 0.3448 58250.0n 0.4930 58499.9n 0.4930 58500.0n 0.8033 58749.9n 0.8033 58750.0n 0.5326 58999.9n 0.5326 59000.0n 0.8078 59249.9n 0.8078 59250.0n 0.5496 59499.9n 0.5496 59500.0n 0.5403 59749.9n 0.5403 59750.0n 0.3878 59999.9n 0.3878 60000.0n 0.8210 60249.9n 0.8210 60250.0n 0.7708 60499.9n 0.7708 60500.0n 0.8078 60749.9n 0.8078 60750.0n 0.5928 60999.9n 0.5928 61000.0n 0.5326 61249.9n 0.5326 61250.0n 0.8176 61499.9n 0.8176 61500.0n 0.8033 61749.9n 0.8033 61750.0n 0.8917 61999.9n 0.8917 62000.0n 0.5914 62249.9n 0.5914 62250.0n 0.3878 62499.9n 0.3878 62500.0n 0.6705 62749.9n 0.6705 62750.0n 0.4776 62999.9n 0.4776 63000.0n 0.3889 63249.9n 0.3889 63250.0n 0.4711 63499.9n 0.4711 63500.0n 0.3537 63749.9n 0.3537 63750.0n 0.7697 63999.9n 0.7697 64000.0n 0.1759 64249.9n 0.1759 64250.0n 0.1119 64499.9n 0.1119 64500.0n 0.8268 64749.9n 0.8268 64750.0n 0.5539 64999.9n 0.5539 65000.0n 0.4637 65249.9n 0.4637 65250.0n 0.6428 65499.9n 0.6428 65500.0n 0.8914 65749.9n 0.8914 65750.0n 0.5898 65999.9n 0.5898 66000.0n 0.5187 66249.9n 0.5187 66250.0n 0.4832 66499.9n 0.4832 66500.0n 0.4057 66749.9n 0.4057 66750.0n 0.3842 66999.9n 0.3842 67000.0n 0.4490 67249.9n 0.4490 67250.0n 0.7275 67499.9n 0.7275 67500.0n 0.4120 67749.9n 0.4120 67750.0n 0.4930 67999.9n 0.4930 68000.0n 0.1264 68249.9n 0.1264 68250.0n 0.2139 68499.9n 0.2139 68500.0n 0.3710 68749.9n 0.3710 68750.0n 0.7721 68999.9n 0.7721 69000.0n 0.5502 69249.9n 0.5502 69250.0n 0.4229 69499.9n 0.4229 69500.0n 0.5403 69749.9n 0.5403 69750.0n 0.4636 69999.9n 0.4636 70000.0n 0.3874 70249.9n 0.3874 70250.0n 0.4330 70499.9n 0.4330 70500.0n 0.4881 70749.9n 0.4881 70750.0n 0.7731 70999.9n 0.7731 71000.0n 0.5631 71249.9n 0.5631 71250.0n 0.5496 71499.9n 0.5496 71500.0n 0.7091 71749.9n 0.7091 71750.0n 0.6358 71999.9n 0.6358 72000.0n 0.4635 72249.9n 0.4635 72250.0n 0.8818 72499.9n 0.8818 72500.0n 0.4982 72749.9n 0.4982 72750.0n 0.8352 72999.9n 0.8352 73000.0n 0.1557 73249.9n 0.1557 73250.0n 0.3826 73499.9n 0.3826 73500.0n 0.4954 73749.9n 0.4954 73750.0n 0.5154 73999.9n 0.5154 74000.0n 0.8507 74249.9n 0.8507 74250.0n 0.4928 74499.9n 0.4928 74500.0n 0.9244 74749.9n 0.9244 74750.0n 0.3448 74999.9n 0.3448 75000.0n 0.5914 75249.9n 0.5914 75250.0n 0.3448 75499.9n 0.3448 75500.0n 0.4711 75749.9n 0.4711 75750.0n 0.7091 75999.9n 0.7091 76000.0n 0.5502 76249.9n 0.5502 76250.0n 0.4954 76499.9n 0.4954 76500.0n 0.8268 76749.9n 0.8268 76750.0n 0.4930 76999.9n 0.4930 77000.0n 0.3874 77249.9n 0.3874 77250.0n 0.4881 77499.9n 0.4881 77500.0n 0.4057 77749.9n 0.4057 77750.0n 0.8914 77999.9n 0.8914 78000.0n 0.1759 78249.9n 0.1759 78250.0n 0.3878 78499.9n 0.3878 78500.0n 0.1557 78749.9n 0.1557 78750.0n 0.3889 78999.9n 0.3889 79000.0n 0.6428 79249.9n 0.6428 79250.0n 0.4832 79499.9n 0.4832 79500.0n 0.3710 79749.9n 0.3710 79750.0n 0.4120 79999.9n 0.4120 80000.0n 0.8210 80249.9n 0.8210 80250.0n 0.7721 80499.9n 0.7721 80500.0n 0.5496 80749.9n 0.5496 80750.0n 0.4776 80999.9n 0.4776 81000.0n 0.4928 81249.9n 0.4928 81250.0n 0.6705 81499.9n 0.6705 81500.0n 0.3842 81749.9n 0.3842 81750.0n 0.3537 81999.9n 0.3537 82000.0n 0.3826 82249.9n 0.3826 82250.0n 0.4490 82499.9n 0.4490 82500.0n 0.7697 82749.9n 0.7697 82750.0n 0.5154 82999.9n 0.5154 83000.0n 0.5187 83249.9n 0.5187 83250.0n 0.4637 83499.9n 0.4637 83500.0n 0.6358 83749.9n 0.6358 83750.0n 0.5631 83999.9n 0.5631 84000.0n 0.5928 84249.9n 0.5928 84250.0n 0.7275 84499.9n 0.7275 84500.0n 0.4982 84749.9n 0.4982 84750.0n 0.5403 84999.9n 0.5403 85000.0n 0.9244 85249.9n 0.9244 85250.0n 0.1119 85499.9n 0.1119 85500.0n 0.8507 85749.9n 0.8507 85750.0n 0.2139 85999.9n 0.2139 86000.0n 0.4229 86249.9n 0.4229 86250.0n 0.8818 86499.9n 0.8818 86500.0n 0.7731 86749.9n 0.7731 86750.0n 0.7708 86999.9n 0.7708 87000.0n 0.4635 87249.9n 0.4635 87250.0n 0.5326 87499.9n 0.5326 87500.0n 0.5539 87749.9n 0.5539 87750.0n 0.4330 87999.9n 0.4330 88000.0n 0.8176 88249.9n 0.8176 88250.0n 0.8352 88499.9n 0.8352 88500.0n 0.1264 88749.9n 0.1264 88750.0n 0.8917 88999.9n 0.8917 89000.0n 0.8033 89249.9n 0.8033 89250.0n 0.4636 89499.9n 0.4636 89500.0n 0.8078 89749.9n 0.8078 89750.0n 0.5898 89999.9n 0.5898 90000.0n 0.3889 90249.9n 0.3889 90250.0n 0.6428 90499.9n 0.6428 90500.0n 0.8078 90749.9n 0.8078 90750.0n 0.4711 90999.9n 0.4711 91000.0n 0.6358 91249.9n 0.6358 91250.0n 0.1557 91499.9n 0.1557 91500.0n 0.1759 91749.9n 0.1759 91750.0n 0.6705 91999.9n 0.6705 92000.0n 0.8352 92249.9n 0.8352 92250.0n 0.4330 92499.9n 0.4330 92500.0n 0.5539 92749.9n 0.5539 92750.0n 0.8818 92999.9n 0.8818 93000.0n 0.8507 93249.9n 0.8507 93250.0n 0.3878 93499.9n 0.3878 93500.0n 0.5928 93749.9n 0.5928 93750.0n 0.7091 93999.9n 0.7091 94000.0n 0.8033 94249.9n 0.8033 94250.0n 0.3874 94499.9n 0.3874 94500.0n 0.5154 94749.9n 0.5154 94750.0n 0.7708 94999.9n 0.7708 95000.0n 0.4928 95249.9n 0.4928 95250.0n 0.5898 95499.9n 0.5898 95500.0n 0.5496 95749.9n 0.5496 95750.0n 0.5502 95999.9n 0.5502 96000.0n 0.1119 96249.9n 0.1119 96250.0n 0.8268 96499.9n 0.8268 96500.0n 0.3448 96749.9n 0.3448 96750.0n 0.4490 96999.9n 0.4490 97000.0n 0.5631 97249.9n 0.5631 97250.0n 0.4635 97499.9n 0.4635 97500.0n 0.4832 97749.9n 0.4832 97750.0n 0.1264 97999.9n 0.1264 98000.0n 0.7731 98249.9n 0.7731 98250.0n 0.8176 98499.9n 0.8176 98500.0n 0.5403 98749.9n 0.5403 98750.0n 0.8914 98999.9n 0.8914 99000.0n 0.5326 99249.9n 0.5326 99250.0n 0.2139 99499.9n 0.2139 99500.0n 0.8210 99749.9n 0.8210 99750.0n 0.4229 99999.9n 0.4229 100000.0n 0.3842 100249.9n 0.3842 100250.0n 0.4930 100499.9n 0.4930 100500.0n 0.4954 100749.9n 0.4954 100750.0n 0.4881 100999.9n 0.4881 101000.0n 0.3826 101249.9n 0.3826 101250.0n 0.7275 101499.9n 0.7275 101500.0n 0.4636 101749.9n 0.4636 101750.0n 0.7697 101999.9n 0.7697 102000.0n 0.4637 102249.9n 0.4637 102250.0n 0.5914 102499.9n 0.5914 102500.0n 0.3537 102749.9n 0.3537 102750.0n 0.5187 102999.9n 0.5187 103000.0n 0.8917 103249.9n 0.8917 103250.0n 0.4057 103499.9n 0.4057 103500.0n 0.4776 103749.9n 0.4776 103750.0n 0.3710 103999.9n 0.3710 104000.0n 0.4982 104249.9n 0.4982 104250.0n 0.7721 104499.9n 0.7721 104500.0n 0.9244 104749.9n 0.9244 104750.0n 0.4120 104999.9n 0.4120 105000.0n 0.4954 105249.9n 0.4954 105250.0n 0.7721 105499.9n 0.7721 105500.0n 0.8268 105749.9n 0.8268 105750.0n 0.7708 105999.9n 0.7708 106000.0n 0.3710 106249.9n 0.3710 106250.0n 0.5631 106499.9n 0.5631 106500.0n 0.5539 106749.9n 0.5539 106750.0n 0.5928 106999.9n 0.5928 107000.0n 0.7275 107249.9n 0.7275 107250.0n 0.9244 107499.9n 0.9244 107500.0n 0.8914 107749.9n 0.8914 107750.0n 0.3842 107999.9n 0.3842 108000.0n 0.4057 108249.9n 0.4057 108250.0n 0.8917 108499.9n 0.8917 108500.0n 0.4120 108749.9n 0.4120 108750.0n 0.4881 108999.9n 0.4881 109000.0n 0.3448 109249.9n 0.3448 109250.0n 0.7731 109499.9n 0.7731 109500.0n 0.5914 109749.9n 0.5914 109750.0n 0.4832 109999.9n 0.4832 110000.0n 0.6428 110249.9n 0.6428 110250.0n 0.3878 110499.9n 0.3878 110500.0n 0.4490 110749.9n 0.4490 110750.0n 0.5326 110999.9n 0.5326 111000.0n 0.7091 111249.9n 0.7091 111250.0n 0.1119 111499.9n 0.1119 111500.0n 0.1557 111749.9n 0.1557 111750.0n 0.4636 111999.9n 0.4636 112000.0n 0.8033 112249.9n 0.8033 112250.0n 0.7697 112499.9n 0.7697 112500.0n 0.4776 112749.9n 0.4776 112750.0n 0.1264 112999.9n 0.1264 113000.0n 0.5187 113249.9n 0.5187 113250.0n 0.5898 113499.9n 0.5898 113500.0n 0.1759 113749.9n 0.1759 113750.0n 0.6358 113999.9n 0.6358 114000.0n 0.4635 114249.9n 0.4635 114250.0n 0.4982 114499.9n 0.4982 114500.0n 0.4711 114749.9n 0.4711 114750.0n 0.4229 114999.9n 0.4229 115000.0n 0.6705 115249.9n 0.6705 115250.0n 0.4928 115499.9n 0.4928 115500.0n 0.3537 115749.9n 0.3537 115750.0n 0.8507 115999.9n 0.8507 116000.0n 0.8210 116249.9n 0.8210 116250.0n 0.5403 116499.9n 0.5403 116500.0n 0.5496 116749.9n 0.5496 116750.0n 0.3826 116999.9n 0.3826 117000.0n 0.8176 117249.9n 0.8176 117250.0n 0.3874 117499.9n 0.3874 117500.0n 0.8352 117749.9n 0.8352 117750.0n 0.3889 117999.9n 0.3889 118000.0n 0.4930 118249.9n 0.4930 118250.0n 0.4637 118499.9n 0.4637 118500.0n 0.4330 118749.9n 0.4330 118750.0n 0.5154 118999.9n 0.5154 119000.0n 0.5502 119249.9n 0.5502 119250.0n 0.8078 119499.9n 0.8078 119500.0n 0.8818 119749.9n 0.8818 119750.0n 0.2139 119999.9n 0.2139 120000.0n 0.4832 120249.9n 0.4832 120250.0n 0.7275 120499.9n 0.7275 120500.0n 0.5914 120749.9n 0.5914 120750.0n 0.4711 120999.9n 0.4711 121000.0n 0.7091 121249.9n 0.7091 121250.0n 0.4954 121499.9n 0.4954 121500.0n 0.3537 121749.9n 0.3537 121750.0n 0.8210 121999.9n 0.8210 122000.0n 0.5154 122249.9n 0.5154 122250.0n 0.3710 122499.9n 0.3710 122500.0n 0.7721 122749.9n 0.7721 122750.0n 0.4229 122999.9n 0.4229 123000.0n 0.2139 123249.9n 0.2139 123250.0n 0.4881 123499.9n 0.4881 123500.0n 0.4635 123749.9n 0.4635 123750.0n 0.4637 123999.9n 0.4637 124000.0n 0.4776 124249.9n 0.4776 124250.0n 0.4120 124499.9n 0.4120 124500.0n 0.8268 124749.9n 0.8268 124750.0n 0.5187 124999.9n 0.5187 125000.0n 0.4490 125249.9n 0.4490 125250.0n 0.8914 125499.9n 0.8914 125500.0n 0.4982 125749.9n 0.4982 125750.0n 0.3448 125999.9n 0.3448 126000.0n 0.5898 126249.9n 0.5898 126250.0n 0.8917 126499.9n 0.8917 126500.0n 0.1119 126749.9n 0.1119 126750.0n 0.5631 126999.9n 0.5631 127000.0n 0.8507 127249.9n 0.8507 127250.0n 0.5326 127499.9n 0.5326 127500.0n 0.4057 127749.9n 0.4057 127750.0n 0.1264 127999.9n 0.1264 128000.0n 0.1557 128249.9n 0.1557 128250.0n 0.5539 128499.9n 0.5539 128500.0n 0.5502 128749.9n 0.5502 128750.0n 0.3826 128999.9n 0.3826 129000.0n 0.6358 129249.9n 0.6358 129250.0n 0.1759 129499.9n 0.1759 129500.0n 0.8033 129749.9n 0.8033 129750.0n 0.4928 129999.9n 0.4928 130000.0n 0.5403 130249.9n 0.5403 130250.0n 0.3842 130499.9n 0.3842 130500.0n 0.3889 130749.9n 0.3889 130750.0n 0.6705 130999.9n 0.6705 131000.0n 0.3878 131249.9n 0.3878 131250.0n 0.5496 131499.9n 0.5496 131500.0n 0.8078 131749.9n 0.8078 131750.0n 0.9244 131999.9n 0.9244 132000.0n 0.8176 132249.9n 0.8176 132250.0n 0.7697 132499.9n 0.7697 132500.0n 0.3874 132749.9n 0.3874 132750.0n 0.7708 132999.9n 0.7708 133000.0n 0.4636 133249.9n 0.4636 133250.0n 0.7731 133499.9n 0.7731 133500.0n 0.6428 133749.9n 0.6428 133750.0n 0.8352 133999.9n 0.8352 134000.0n 0.5928 134249.9n 0.5928 134250.0n 0.4330 134499.9n 0.4330 134500.0n 0.4930 134749.9n 0.4930 134750.0n 0.8818 134999.9n 0.8818 135000.0n 0.7708 135249.9n 0.7708 135250.0n 0.5154 135499.9n 0.5154 135500.0n 0.6705 135749.9n 0.6705 135750.0n 0.5539 135999.9n 0.5539 136000.0n 0.5631 136249.9n 0.5631 136250.0n 0.1119 136499.9n 0.1119 136500.0n 0.3826 136749.9n 0.3826 136750.0n 0.4490 136999.9n 0.4490 137000.0n 0.3448 137249.9n 0.3448 137250.0n 0.5403 137499.9n 0.5403 137500.0n 0.4930 137749.9n 0.4930 137750.0n 0.7275 137999.9n 0.7275 138000.0n 0.7091 138249.9n 0.7091 138250.0n 0.9244 138499.9n 0.9244 138500.0n 0.6428 138749.9n 0.6428 138750.0n 0.1264 138999.9n 0.1264 139000.0n 0.8033 139249.9n 0.8033 139250.0n 0.6358 139499.9n 0.6358 139500.0n 0.4057 139749.9n 0.4057 139750.0n 0.7731 139999.9n 0.7731 140000.0n 0.7721 140249.9n 0.7721 140250.0n 0.2139 140499.9n 0.2139 140500.0n 0.8268 140749.9n 0.8268 140750.0n 0.4330 140999.9n 0.4330 141000.0n 0.8078 141249.9n 0.8078 141250.0n 0.3878 141499.9n 0.3878 141500.0n 0.3710 141749.9n 0.3710 141750.0n 0.8917 141999.9n 0.8917 142000.0n 0.5187 142249.9n 0.5187 142250.0n 0.3874 142499.9n 0.3874 142500.0n 0.4982 142749.9n 0.4982 142750.0n 0.3537 142999.9n 0.3537 143000.0n 0.4881 143249.9n 0.4881 143250.0n 0.4120 143499.9n 0.4120 143500.0n 0.5898 143749.9n 0.5898 143750.0n 0.4711 143999.9n 0.4711 144000.0n 0.8176 144249.9n 0.8176 144250.0n 0.4635 144499.9n 0.4635 144500.0n 0.3889 144749.9n 0.3889 144750.0n 0.1759 144999.9n 0.1759 145000.0n 0.4832 145249.9n 0.4832 145250.0n 0.8818 145499.9n 0.8818 145500.0n 0.8210 145749.9n 0.8210 145750.0n 0.4229 145999.9n 0.4229 146000.0n 0.4928 146249.9n 0.4928 146250.0n 0.4636 146499.9n 0.4636 146500.0n 0.4776 146749.9n 0.4776 146750.0n 0.5326 146999.9n 0.5326 147000.0n 0.8352 147249.9n 0.8352 147250.0n 0.4637 147499.9n 0.4637 147500.0n 0.5502 147749.9n 0.5502 147750.0n 0.5914 147999.9n 0.5914 148000.0n 0.4954 148249.9n 0.4954 148250.0n 0.7697 148499.9n 0.7697 148500.0n 0.8914 148749.9n 0.8914 148750.0n 0.1557 148999.9n 0.1557 149000.0n 0.5928 149249.9n 0.5928 149250.0n 0.5496 149499.9n 0.5496 149500.0n 0.3842 149749.9n 0.3842 149750.0n 0.8507 149999.9n 0.8507 150000.0n 0.8078 150249.9n 0.8078 150250.0n 0.3842 150499.9n 0.3842 150500.0n 0.8917 150749.9n 0.8917 150750.0n 0.8914 150999.9n 0.8914 151000.0n 0.4330 151249.9n 0.4330 151250.0n 0.7091 151499.9n 0.7091 151500.0n 0.3710 151749.9n 0.3710 151750.0n 0.5539 151999.9n 0.5539 152000.0n 0.1264 152249.9n 0.1264 152250.0n 0.4982 152499.9n 0.4982 152500.0n 0.5502 152749.9n 0.5502 152750.0n 0.4120 152999.9n 0.4120 153000.0n 0.7708 153249.9n 0.7708 153250.0n 0.1119 153499.9n 0.1119 153500.0n 0.7275 153749.9n 0.7275 153750.0n 0.2139 153999.9n 0.2139 154000.0n 0.5403 154249.9n 0.5403 154250.0n 0.8268 154499.9n 0.8268 154500.0n 0.5187 154749.9n 0.5187 154750.0n 0.5631 154999.9n 0.5631 155000.0n 0.4635 155249.9n 0.4635 155250.0n 0.4490 155499.9n 0.4490 155500.0n 0.3448 155749.9n 0.3448 155750.0n 0.3889 155999.9n 0.3889 156000.0n 0.8176 156249.9n 0.8176 156250.0n 0.4776 156499.9n 0.4776 156500.0n 0.5326 156749.9n 0.5326 156750.0n 0.6428 156999.9n 0.6428 157000.0n 0.5928 157249.9n 0.5928 157250.0n 0.5154 157499.9n 0.5154 157500.0n 0.5898 157749.9n 0.5898 157750.0n 0.3826 157999.9n 0.3826 158000.0n 0.3878 158249.9n 0.3878 158250.0n 0.8210 158499.9n 0.8210 158500.0n 0.8818 158749.9n 0.8818 158750.0n 0.8507 158999.9n 0.8507 159000.0n 0.4711 159249.9n 0.4711 159250.0n 0.1557 159499.9n 0.1557 159500.0n 0.4832 159749.9n 0.4832 159750.0n 0.9244 159999.9n 0.9244 160000.0n 0.4229 160249.9n 0.4229 160250.0n 0.4636 160499.9n 0.4636 160500.0n 0.3537 160749.9n 0.3537 160750.0n 0.7721 160999.9n 0.7721 161000.0n 0.3874 161249.9n 0.3874 161250.0n 0.1759 161499.9n 0.1759 161500.0n 0.7731 161749.9n 0.7731 161750.0n 0.8033 161999.9n 0.8033 162000.0n 0.4637 162249.9n 0.4637 162250.0n 0.5496 162499.9n 0.5496 162500.0n 0.4928 162749.9n 0.4928 162750.0n 0.4881 162999.9n 0.4881 163000.0n 0.8352 163249.9n 0.8352 163250.0n 0.5914 163499.9n 0.5914 163500.0n 0.6705 163749.9n 0.6705 163750.0n 0.4954 163999.9n 0.4954 164000.0n 0.7697 164249.9n 0.7697 164250.0n 0.4930 164499.9n 0.4930 164500.0n 0.6358 164749.9n 0.6358 164750.0n 0.4057 164999.9n 0.4057 165000.0n 0.4120 165249.9n 0.4120 165250.0n 0.3889 165499.9n 0.3889 165500.0n 0.2139 165749.9n 0.2139 165750.0n 0.4057 165999.9n 0.4057 166000.0n 0.5403 166249.9n 0.5403 166250.0n 0.3826 166499.9n 0.3826 166500.0n 0.5539 166749.9n 0.5539 166750.0n 0.3842 166999.9n 0.3842 167000.0n 0.8507 167249.9n 0.8507 167250.0n 0.5496 167499.9n 0.5496 167500.0n 0.1557 167749.9n 0.1557 167750.0n 0.4832 167999.9n 0.4832 168000.0n 0.7708 168249.9n 0.7708 168250.0n 0.3448 168499.9n 0.3448 168500.0n 0.4636 168749.9n 0.4636 168750.0n 0.8917 168999.9n 0.8917 169000.0n 0.5631 169249.9n 0.5631 169250.0n 0.4229 169499.9n 0.4229 169500.0n 0.4930 169749.9n 0.4930 169750.0n 0.3874 169999.9n 0.3874 170000.0n 0.5914 170249.9n 0.5914 170250.0n 0.1264 170499.9n 0.1264 170500.0n 0.8078 170749.9n 0.8078 170750.0n 0.4982 170999.9n 0.4982 171000.0n 0.8210 171249.9n 0.8210 171250.0n 0.8033 171499.9n 0.8033 171500.0n 0.7697 171749.9n 0.7697 171750.0n 0.8268 171999.9n 0.8268 172000.0n 0.4330 172249.9n 0.4330 172250.0n 0.5898 172499.9n 0.5898 172500.0n 0.3878 172749.9n 0.3878 172750.0n 0.5928 172999.9n 0.5928 173000.0n 0.7091 173249.9n 0.7091 173250.0n 0.1119 173499.9n 0.1119 173500.0n 0.8914 173749.9n 0.8914 173750.0n 0.4881 173999.9n 0.4881 174000.0n 0.5326 174249.9n 0.5326 174250.0n 0.8352 174499.9n 0.8352 174500.0n 0.7731 174749.9n 0.7731 174750.0n 0.1759 174999.9n 0.1759 175000.0n 0.5154 175249.9n 0.5154 175250.0n 0.4490 175499.9n 0.4490 175500.0n 0.4637 175749.9n 0.4637 175750.0n 0.3710 175999.9n 0.3710 176000.0n 0.9244 176249.9n 0.9244 176250.0n 0.4776 176499.9n 0.4776 176500.0n 0.6428 176749.9n 0.6428 176750.0n 0.5187 176999.9n 0.5187 177000.0n 0.7275 177249.9n 0.7275 177250.0n 0.6705 177499.9n 0.6705 177500.0n 0.5502 177749.9n 0.5502 177750.0n 0.4711 177999.9n 0.4711 178000.0n 0.4635 178249.9n 0.4635 178250.0n 0.4928 178499.9n 0.4928 178500.0n 0.6358 178749.9n 0.6358 178750.0n 0.8176 178999.9n 0.8176 179000.0n 0.7721 179249.9n 0.7721 179250.0n 0.8818 179499.9n 0.8818 179500.0n 0.3537 179749.9n 0.3537 179750.0n 0.4954 179999.9n 0.4954 180000.0n 0.4372 180249.9n 0.4372 180250.0n 0.2776 180499.9n 0.2776 180500.0n 0.7987 180749.9n 0.7987 180750.0n 0.4302 180999.9n 0.4302 181000.0n 0.4920 181249.9n 0.4920 181250.0n 0.4450 181499.9n 0.4450 181500.0n 0.4936 181749.9n 0.4936 181750.0n 0.3427 181999.9n 0.3427 182000.0n 0.4395 182249.9n 0.4395 182250.0n 0.8981 182499.9n 0.8981 182500.0n 0.8535 182749.9n 0.8535 182750.0n 0.4874 182999.9n 0.4874 183000.0n 0.5553 183249.9n 0.5553 183250.0n 0.5415 183499.9n 0.5415 183500.0n 0.2859 183749.9n 0.2859 183750.0n 0.6712 183999.9n 0.6712 184000.0n 0.2116 184249.9n 0.2116 184250.0n 0.6238 184499.9n 0.6238 184500.0n 0.0929 184749.9n 0.0929 184750.0n 0.5195 184999.9n 0.5195 185000.0n 0.1243 185249.9n 0.1243 185250.0n 0.6167 185499.9n 0.6167 185500.0n 0.1921 185749.9n 0.1921 185750.0n 0.4979 185999.9n 0.4979 186000.0n 0.3831 186249.9n 0.3831 186250.0n 0.6277 186499.9n 0.6277 186500.0n 0.3693 186749.9n 0.3693 186750.0n 0.1909 186999.9n 0.1909 187000.0n 0.7380 187249.9n 0.7380 187250.0n 0.4980 187499.9n 0.4980 187500.0n 0.4762 187749.9n 0.4762 187750.0n 0.8519 187999.9n 0.8519 188000.0n 0.3365 188249.9n 0.3365 188250.0n 0.4152 188499.9n 0.4152 188500.0n 0.4897 188749.9n 0.4897 188750.0n 0.4850 188999.9n 0.4850 189000.0n 0.6557 189249.9n 0.6557 189250.0n 0.3508 189499.9n 0.3508 189500.0n 0.5006 189749.9n 0.5006 189750.0n 0.8490 189999.9n 0.8490 190000.0n 0.5046 190249.9n 0.5046 190250.0n 0.6500 190499.9n 0.6500 190500.0n 0.3744 190749.9n 0.3744 190750.0n 0.9190 190999.9n 0.9190 191000.0n 0.6878 191249.9n 0.6878 191250.0n 0.4376 191499.9n 0.4376 191500.0n 0.4894 191749.9n 0.4894 191750.0n 0.5557 191999.9n 0.5557 192000.0n 0.5197 192249.9n 0.5197 192250.0n 0.4613 192499.9n 0.4613 192500.0n 0.8025 192749.9n 0.8025 192750.0n 0.2160 192999.9n 0.2160 193000.0n 0.4356 193249.9n 0.4356 193250.0n 0.4000 193499.9n 0.4000 193500.0n 0.5108 193749.9n 0.5108 193750.0n 0.5976 193999.9n 0.5976 194000.0n 0.6255 194249.9n 0.6255 194250.0n 0.1969 194499.9n 0.1969 194500.0n 0.5130 194749.9n 0.5130 194750.0n 0.4648 194999.9n 0.4648 195000.0n 0.5531 195249.9n 0.5531 195250.0n 0.4947 195499.9n 0.4947 195500.0n 0.9603 195749.9n 0.9603 195750.0n 0.4638 195999.9n 0.4638 196000.0n 0.4062 196249.9n 0.4062 196250.0n 0.4452 196499.9n 0.4452 196500.0n 0.0554 196749.9n 0.0554 196750.0n 0.2846 196999.9n 0.2846 197000.0n 0.8229 197249.9n 0.8229 197250.0n 0.4503 197499.9n 0.4503 197500.0n 0.5262 197749.9n 0.5262 197750.0n 0.6288 197999.9n 0.6288 198000.0n 0.4648 198249.9n 0.4648 198250.0n 0.3028 198499.9n 0.3028 198500.0n 0.8066 198749.9n 0.8066 198750.0n 0.7054 198999.9n 0.7054 199000.0n 0.5532 199249.9n 0.5532 199250.0n 0.4872 199499.9n 0.4872 199500.0n 0.6602 199749.9n 0.6602 199750.0n 0.6941 199999.9n 0.6941 200000.0n 0.4772 200249.9n 0.4772 200250.0n 0.5033 200499.9n 0.5033 200500.0n 0.4850 200749.9n 0.4850 200750.0n 0.5405 200999.9n 0.5405 201000.0n 0.1577 201249.9n 0.1577 201250.0n 0.5233 201499.9n 0.5233 201500.0n 0.7980 201749.9n 0.7980 201750.0n 0.5848 201999.9n 0.5848 202000.0n 0.1703 202249.9n 0.1703 202250.0n 0.4456 202499.9n 0.4456 202500.0n 0.6894 202749.9n 0.6894 202750.0n 0.4323 202999.9n 0.4323 203000.0n 0.7341 203249.9n 0.7341 203250.0n 0.5179 203499.9n 0.5179 203500.0n 0.4665 203749.9n 0.4665 203750.0n 0.8393 203999.9n 0.8393 204000.0n 0.1755 204249.9n 0.1755 204250.0n 0.2008 204499.9n 0.2008 204500.0n 0.8577 204749.9n 0.8577 204750.0n 0.5520 204999.9n 0.5520 205000.0n 0.4085 205249.9n 0.4085 205250.0n 0.4908 205499.9n 0.4908 205500.0n 0.5099 205749.9n 0.5099 205750.0n 0.4637 205999.9n 0.4637 206000.0n 0.2254 206249.9n 0.2254 206250.0n 0.5004 206499.9n 0.5004 206500.0n 0.7971 206749.9n 0.7971 206750.0n 0.8635 206999.9n 0.8635 207000.0n 0.4064 207249.9n 0.4064 207250.0n 0.5217 207499.9n 0.5217 207500.0n 0.4099 207749.9n 0.4099 207750.0n 0.8802 207999.9n 0.8802 208000.0n 0.6878 208249.9n 0.6878 208250.0n 0.3408 208499.9n 0.3408 208500.0n 0.4991 208749.9n 0.4991 208750.0n 0.5533 208999.9n 0.5533 209000.0n 0.5190 209249.9n 0.5190 209250.0n 0.3104 209499.9n 0.3104 209500.0n 0.4596 209749.9n 0.4596 209750.0n 0.2900)
Vx3p a_xp3 0 0.9800
Vx3n a_xn3 0 0.0200
Vxop xop 0 PWL(0.0n 0.7000 249.9n 0.7000 250.0n 0.7000 499.9n 0.7000 500.0n 0.3000 749.9n 0.3000 750.0n 0.7000 999.9n 0.7000 1000.0n 0.3000 1249.9n 0.3000 1250.0n 0.7000 1499.9n 0.7000 1500.0n 0.3000 1749.9n 0.3000 1750.0n 0.7000 1999.9n 0.7000 2000.0n 0.7000 2249.9n 0.7000 2250.0n 0.3000 2499.9n 0.3000 2500.0n 0.3000 2749.9n 0.3000 2750.0n 0.3000 2999.9n 0.3000 3000.0n 0.7000 3249.9n 0.7000 3250.0n 0.3000 3499.9n 0.3000 3500.0n 0.7000 3749.9n 0.7000 3750.0n 0.7000 3999.9n 0.7000 4000.0n 0.7000 4249.9n 0.7000 4250.0n 0.7000 4499.9n 0.7000 4500.0n 0.3000 4749.9n 0.3000 4750.0n 0.3000 4999.9n 0.3000 5000.0n 0.7000 5249.9n 0.7000 5250.0n 0.3000 5499.9n 0.3000 5500.0n 0.3000 5749.9n 0.3000 5750.0n 0.3000 5999.9n 0.3000 6000.0n 0.3000 6249.9n 0.3000 6250.0n 0.3000 6499.9n 0.3000 6500.0n 0.7000 6749.9n 0.7000 6750.0n 0.3000 6999.9n 0.3000 7000.0n 0.3000 7249.9n 0.3000 7250.0n 0.7000 7499.9n 0.7000 7500.0n 0.7000 7749.9n 0.7000 7750.0n 0.7000 7999.9n 0.7000 8000.0n 0.3000 8249.9n 0.3000 8250.0n 0.3000 8499.9n 0.3000 8500.0n 0.7000 8749.9n 0.7000 8750.0n 0.7000 8999.9n 0.7000 9000.0n 0.3000 9249.9n 0.3000 9250.0n 0.3000 9499.9n 0.3000 9500.0n 0.7000 9749.9n 0.7000 9750.0n 0.7000 9999.9n 0.7000 10000.0n 0.7000 10249.9n 0.7000 10250.0n 0.7000 10499.9n 0.7000 10500.0n 0.3000 10749.9n 0.3000 10750.0n 0.7000 10999.9n 0.7000 11000.0n 0.7000 11249.9n 0.7000 11250.0n 0.7000 11499.9n 0.7000 11500.0n 0.3000 11749.9n 0.3000 11750.0n 0.3000 11999.9n 0.3000 12000.0n 0.7000 12249.9n 0.7000 12250.0n 0.7000 12499.9n 0.7000 12500.0n 0.3000 12749.9n 0.3000 12750.0n 0.7000 12999.9n 0.7000 13000.0n 0.7000 13249.9n 0.7000 13250.0n 0.3000 13499.9n 0.3000 13500.0n 0.3000 13749.9n 0.3000 13750.0n 0.7000 13999.9n 0.7000 14000.0n 0.3000 14249.9n 0.3000 14250.0n 0.3000 14499.9n 0.3000 14500.0n 0.7000 14749.9n 0.7000 14750.0n 0.7000 14999.9n 0.7000 15000.0n 0.7000 15249.9n 0.7000 15250.0n 0.7000 15499.9n 0.7000 15500.0n 0.7000 15749.9n 0.7000 15750.0n 0.7000 15999.9n 0.7000 16000.0n 0.7000 16249.9n 0.7000 16250.0n 0.7000 16499.9n 0.7000 16500.0n 0.3000 16749.9n 0.3000 16750.0n 0.3000 16999.9n 0.3000 17000.0n 0.3000 17249.9n 0.3000 17250.0n 0.3000 17499.9n 0.3000 17500.0n 0.3000 17749.9n 0.3000 17750.0n 0.7000 17999.9n 0.7000 18000.0n 0.3000 18249.9n 0.3000 18250.0n 0.7000 18499.9n 0.7000 18500.0n 0.3000 18749.9n 0.3000 18750.0n 0.7000 18999.9n 0.7000 19000.0n 0.3000 19249.9n 0.3000 19250.0n 0.3000 19499.9n 0.3000 19500.0n 0.7000 19749.9n 0.7000 19750.0n 0.3000 19999.9n 0.3000 20000.0n 0.3000 20249.9n 0.3000 20250.0n 0.7000 20499.9n 0.7000 20500.0n 0.7000 20749.9n 0.7000 20750.0n 0.7000 20999.9n 0.7000 21000.0n 0.3000 21249.9n 0.3000 21250.0n 0.7000 21499.9n 0.7000 21500.0n 0.7000 21749.9n 0.7000 21750.0n 0.3000 21999.9n 0.3000 22000.0n 0.7000 22249.9n 0.7000 22250.0n 0.7000 22499.9n 0.7000 22500.0n 0.3000 22749.9n 0.3000 22750.0n 0.3000 22999.9n 0.3000 23000.0n 0.7000 23249.9n 0.7000 23250.0n 0.7000 23499.9n 0.7000 23500.0n 0.7000 23749.9n 0.7000 23750.0n 0.7000 23999.9n 0.7000 24000.0n 0.3000 24249.9n 0.3000 24250.0n 0.3000 24499.9n 0.3000 24500.0n 0.3000 24749.9n 0.3000 24750.0n 0.3000 24999.9n 0.3000 25000.0n 0.7000 25249.9n 0.7000 25250.0n 0.3000 25499.9n 0.3000 25500.0n 0.3000 25749.9n 0.3000 25750.0n 0.3000 25999.9n 0.3000 26000.0n 0.7000 26249.9n 0.7000 26250.0n 0.3000 26499.9n 0.3000 26500.0n 0.3000 26749.9n 0.3000 26750.0n 0.7000 26999.9n 0.7000 27000.0n 0.3000 27249.9n 0.3000 27250.0n 0.3000 27499.9n 0.3000 27500.0n 0.7000 27749.9n 0.7000 27750.0n 0.3000 27999.9n 0.3000 28000.0n 0.7000 28249.9n 0.7000 28250.0n 0.7000 28499.9n 0.7000 28500.0n 0.7000 28749.9n 0.7000 28750.0n 0.7000 28999.9n 0.7000 29000.0n 0.3000 29249.9n 0.3000 29250.0n 0.7000 29499.9n 0.7000 29500.0n 0.7000 29749.9n 0.7000 29750.0n 0.7000 29999.9n 0.7000 30000.0n 0.7000 30249.9n 0.7000 30250.0n 0.3000 30499.9n 0.3000 30500.0n 0.7000 30749.9n 0.7000 30750.0n 0.7000 30999.9n 0.7000 31000.0n 0.7000 31249.9n 0.7000 31250.0n 0.7000 31499.9n 0.7000 31500.0n 0.7000 31749.9n 0.7000 31750.0n 0.7000 31999.9n 0.7000 32000.0n 0.7000 32249.9n 0.7000 32250.0n 0.3000 32499.9n 0.3000 32500.0n 0.7000 32749.9n 0.7000 32750.0n 0.7000 32999.9n 0.7000 33000.0n 0.3000 33249.9n 0.3000 33250.0n 0.7000 33499.9n 0.7000 33500.0n 0.3000 33749.9n 0.3000 33750.0n 0.7000 33999.9n 0.7000 34000.0n 0.7000 34249.9n 0.7000 34250.0n 0.3000 34499.9n 0.3000 34500.0n 0.7000 34749.9n 0.7000 34750.0n 0.3000 34999.9n 0.3000 35000.0n 0.3000 35249.9n 0.3000 35250.0n 0.7000 35499.9n 0.7000 35500.0n 0.3000 35749.9n 0.3000 35750.0n 0.7000 35999.9n 0.7000 36000.0n 0.7000 36249.9n 0.7000 36250.0n 0.7000 36499.9n 0.7000 36500.0n 0.3000 36749.9n 0.3000 36750.0n 0.7000 36999.9n 0.7000 37000.0n 0.7000 37249.9n 0.7000 37250.0n 0.3000 37499.9n 0.3000 37500.0n 0.7000 37749.9n 0.7000 37750.0n 0.3000 37999.9n 0.3000 38000.0n 0.3000 38249.9n 0.3000 38250.0n 0.7000 38499.9n 0.7000 38500.0n 0.3000 38749.9n 0.3000 38750.0n 0.3000 38999.9n 0.3000 39000.0n 0.3000 39249.9n 0.3000 39250.0n 0.3000 39499.9n 0.3000 39500.0n 0.3000 39749.9n 0.3000 39750.0n 0.7000 39999.9n 0.7000 40000.0n 0.7000 40249.9n 0.7000 40250.0n 0.7000 40499.9n 0.7000 40500.0n 0.3000 40749.9n 0.3000 40750.0n 0.3000 40999.9n 0.3000 41000.0n 0.7000 41249.9n 0.7000 41250.0n 0.3000 41499.9n 0.3000 41500.0n 0.3000 41749.9n 0.3000 41750.0n 0.3000 41999.9n 0.3000 42000.0n 0.7000 42249.9n 0.7000 42250.0n 0.3000 42499.9n 0.3000 42500.0n 0.7000 42749.9n 0.7000 42750.0n 0.7000 42999.9n 0.7000 43000.0n 0.3000 43249.9n 0.3000 43250.0n 0.7000 43499.9n 0.7000 43500.0n 0.3000 43749.9n 0.3000 43750.0n 0.7000 43999.9n 0.7000 44000.0n 0.7000 44249.9n 0.7000 44250.0n 0.3000 44499.9n 0.3000 44500.0n 0.3000 44749.9n 0.3000 44750.0n 0.3000 44999.9n 0.3000 45000.0n 0.3000 45249.9n 0.3000 45250.0n 0.3000 45499.9n 0.3000 45500.0n 0.3000 45749.9n 0.3000 45750.0n 0.3000 45999.9n 0.3000 46000.0n 0.7000 46249.9n 0.7000 46250.0n 0.7000 46499.9n 0.7000 46500.0n 0.7000 46749.9n 0.7000 46750.0n 0.3000 46999.9n 0.3000 47000.0n 0.7000 47249.9n 0.7000 47250.0n 0.7000 47499.9n 0.7000 47500.0n 0.7000 47749.9n 0.7000 47750.0n 0.3000 47999.9n 0.3000 48000.0n 0.3000 48249.9n 0.3000 48250.0n 0.7000 48499.9n 0.7000 48500.0n 0.7000 48749.9n 0.7000 48750.0n 0.7000 48999.9n 0.7000 49000.0n 0.7000 49249.9n 0.7000 49250.0n 0.7000 49499.9n 0.7000 49500.0n 0.3000 49749.9n 0.3000 49750.0n 0.7000 49999.9n 0.7000 50000.0n 0.7000 50249.9n 0.7000 50250.0n 0.7000 50499.9n 0.7000 50500.0n 0.3000 50749.9n 0.3000 50750.0n 0.3000 50999.9n 0.3000 51000.0n 0.7000 51249.9n 0.7000 51250.0n 0.7000 51499.9n 0.7000 51500.0n 0.3000 51749.9n 0.3000 51750.0n 0.3000 51999.9n 0.3000 52000.0n 0.7000 52249.9n 0.7000 52250.0n 0.7000 52499.9n 0.7000 52500.0n 0.7000 52749.9n 0.7000 52750.0n 0.7000 52999.9n 0.7000 53000.0n 0.7000 53249.9n 0.7000 53250.0n 0.3000 53499.9n 0.3000 53500.0n 0.7000 53749.9n 0.7000 53750.0n 0.7000 53999.9n 0.7000 54000.0n 0.7000 54249.9n 0.7000 54250.0n 0.7000 54499.9n 0.7000 54500.0n 0.7000 54749.9n 0.7000 54750.0n 0.3000 54999.9n 0.3000 55000.0n 0.7000 55249.9n 0.7000 55250.0n 0.7000 55499.9n 0.7000 55500.0n 0.3000 55749.9n 0.3000 55750.0n 0.3000 55999.9n 0.3000 56000.0n 0.3000 56249.9n 0.3000 56250.0n 0.3000 56499.9n 0.3000 56500.0n 0.3000 56749.9n 0.3000 56750.0n 0.3000 56999.9n 0.3000 57000.0n 0.3000 57249.9n 0.3000 57250.0n 0.3000 57499.9n 0.3000 57500.0n 0.3000 57749.9n 0.3000 57750.0n 0.7000 57999.9n 0.7000 58000.0n 0.7000 58249.9n 0.7000 58250.0n 0.3000 58499.9n 0.3000 58500.0n 0.7000 58749.9n 0.7000 58750.0n 0.3000 58999.9n 0.3000 59000.0n 0.7000 59249.9n 0.7000 59250.0n 0.3000 59499.9n 0.3000 59500.0n 0.3000 59749.9n 0.3000 59750.0n 0.3000 59999.9n 0.3000 60000.0n 0.7000 60249.9n 0.7000 60250.0n 0.7000 60499.9n 0.7000 60500.0n 0.7000 60749.9n 0.7000 60750.0n 0.7000 60999.9n 0.7000 61000.0n 0.3000 61249.9n 0.3000 61250.0n 0.7000 61499.9n 0.7000 61500.0n 0.7000 61749.9n 0.7000 61750.0n 0.7000 61999.9n 0.7000 62000.0n 0.3000 62249.9n 0.3000 62250.0n 0.3000 62499.9n 0.3000 62500.0n 0.3000 62749.9n 0.3000 62750.0n 0.3000 62999.9n 0.3000 63000.0n 0.3000 63249.9n 0.3000 63250.0n 0.3000 63499.9n 0.3000 63500.0n 0.7000 63749.9n 0.7000 63750.0n 0.7000 63999.9n 0.7000 64000.0n 0.7000 64249.9n 0.7000 64250.0n 0.7000 64499.9n 0.7000 64500.0n 0.7000 64749.9n 0.7000 64750.0n 0.3000 64999.9n 0.3000 65000.0n 0.7000 65249.9n 0.7000 65250.0n 0.7000 65499.9n 0.7000 65500.0n 0.7000 65749.9n 0.7000 65750.0n 0.3000 65999.9n 0.3000 66000.0n 0.3000 66249.9n 0.3000 66250.0n 0.3000 66499.9n 0.3000 66500.0n 0.3000 66749.9n 0.3000 66750.0n 0.3000 66999.9n 0.3000 67000.0n 0.3000 67249.9n 0.3000 67250.0n 0.7000 67499.9n 0.7000 67500.0n 0.3000 67749.9n 0.3000 67750.0n 0.3000 67999.9n 0.3000 68000.0n 0.7000 68249.9n 0.7000 68250.0n 0.7000 68499.9n 0.7000 68500.0n 0.7000 68749.9n 0.7000 68750.0n 0.7000 68999.9n 0.7000 69000.0n 0.7000 69249.9n 0.7000 69250.0n 0.7000 69499.9n 0.7000 69500.0n 0.3000 69749.9n 0.3000 69750.0n 0.7000 69999.9n 0.7000 70000.0n 0.3000 70249.9n 0.3000 70250.0n 0.3000 70499.9n 0.3000 70500.0n 0.7000 70749.9n 0.7000 70750.0n 0.7000 70999.9n 0.7000 71000.0n 0.3000 71249.9n 0.3000 71250.0n 0.3000 71499.9n 0.3000 71500.0n 0.7000 71749.9n 0.7000 71750.0n 0.3000 71999.9n 0.3000 72000.0n 0.3000 72249.9n 0.3000 72250.0n 0.7000 72499.9n 0.7000 72500.0n 0.3000 72749.9n 0.3000 72750.0n 0.7000 72999.9n 0.7000 73000.0n 0.7000 73249.9n 0.7000 73250.0n 0.3000 73499.9n 0.3000 73500.0n 0.3000 73749.9n 0.3000 73750.0n 0.3000 73999.9n 0.3000 74000.0n 0.7000 74249.9n 0.7000 74250.0n 0.3000 74499.9n 0.3000 74500.0n 0.7000 74749.9n 0.7000 74750.0n 0.7000 74999.9n 0.7000 75000.0n 0.3000 75249.9n 0.3000 75250.0n 0.7000 75499.9n 0.7000 75500.0n 0.3000 75749.9n 0.3000 75750.0n 0.7000 75999.9n 0.7000 76000.0n 0.7000 76249.9n 0.7000 76250.0n 0.3000 76499.9n 0.3000 76500.0n 0.7000 76749.9n 0.7000 76750.0n 0.3000 76999.9n 0.3000 77000.0n 0.3000 77249.9n 0.3000 77250.0n 0.7000 77499.9n 0.7000 77500.0n 0.3000 77749.9n 0.3000 77750.0n 0.7000 77999.9n 0.7000 78000.0n 0.7000 78249.9n 0.7000 78250.0n 0.3000 78499.9n 0.3000 78500.0n 0.7000 78749.9n 0.7000 78750.0n 0.3000 78999.9n 0.3000 79000.0n 0.7000 79249.9n 0.7000 79250.0n 0.3000 79499.9n 0.3000 79500.0n 0.7000 79749.9n 0.7000 79750.0n 0.3000 79999.9n 0.3000 80000.0n 0.7000 80249.9n 0.7000 80250.0n 0.7000 80499.9n 0.7000 80500.0n 0.3000 80749.9n 0.3000 80750.0n 0.3000 80999.9n 0.3000 81000.0n 0.3000 81249.9n 0.3000 81250.0n 0.3000 81499.9n 0.3000 81500.0n 0.3000 81749.9n 0.3000 81750.0n 0.7000 81999.9n 0.7000 82000.0n 0.3000 82249.9n 0.3000 82250.0n 0.3000 82499.9n 0.3000 82500.0n 0.7000 82749.9n 0.7000 82750.0n 0.3000 82999.9n 0.3000 83000.0n 0.3000 83249.9n 0.3000 83250.0n 0.7000 83499.9n 0.7000 83500.0n 0.3000 83749.9n 0.3000 83750.0n 0.3000 83999.9n 0.3000 84000.0n 0.7000 84249.9n 0.7000 84250.0n 0.7000 84499.9n 0.7000 84500.0n 0.3000 84749.9n 0.3000 84750.0n 0.3000 84999.9n 0.3000 85000.0n 0.7000 85249.9n 0.7000 85250.0n 0.7000 85499.9n 0.7000 85500.0n 0.7000 85749.9n 0.7000 85750.0n 0.7000 85999.9n 0.7000 86000.0n 0.7000 86249.9n 0.7000 86250.0n 0.7000 86499.9n 0.7000 86500.0n 0.7000 86749.9n 0.7000 86750.0n 0.7000 86999.9n 0.7000 87000.0n 0.3000 87249.9n 0.3000 87250.0n 0.3000 87499.9n 0.3000 87500.0n 0.3000 87749.9n 0.3000 87750.0n 0.3000 87999.9n 0.3000 88000.0n 0.7000 88249.9n 0.7000 88250.0n 0.7000 88499.9n 0.7000 88500.0n 0.7000 88749.9n 0.7000 88750.0n 0.7000 88999.9n 0.7000 89000.0n 0.7000 89249.9n 0.7000 89250.0n 0.7000 89499.9n 0.7000 89500.0n 0.7000 89749.9n 0.7000 89750.0n 0.3000 89999.9n 0.3000 90000.0n 0.3000 90249.9n 0.3000 90250.0n 0.7000 90499.9n 0.7000 90500.0n 0.7000 90749.9n 0.7000 90750.0n 0.3000 90999.9n 0.3000 91000.0n 0.3000 91249.9n 0.3000 91250.0n 0.7000 91499.9n 0.7000 91500.0n 0.7000 91749.9n 0.7000 91750.0n 0.3000 91999.9n 0.3000 92000.0n 0.7000 92249.9n 0.7000 92250.0n 0.3000 92499.9n 0.3000 92500.0n 0.3000 92749.9n 0.3000 92750.0n 0.7000 92999.9n 0.7000 93000.0n 0.7000 93249.9n 0.7000 93250.0n 0.3000 93499.9n 0.3000 93500.0n 0.7000 93749.9n 0.7000 93750.0n 0.7000 93999.9n 0.7000 94000.0n 0.7000 94249.9n 0.7000 94250.0n 0.3000 94499.9n 0.3000 94500.0n 0.3000 94749.9n 0.3000 94750.0n 0.7000 94999.9n 0.7000 95000.0n 0.3000 95249.9n 0.3000 95250.0n 0.3000 95499.9n 0.3000 95500.0n 0.3000 95749.9n 0.3000 95750.0n 0.7000 95999.9n 0.7000 96000.0n 0.7000 96249.9n 0.7000 96250.0n 0.7000 96499.9n 0.7000 96500.0n 0.7000 96749.9n 0.7000 96750.0n 0.3000 96999.9n 0.3000 97000.0n 0.3000 97249.9n 0.3000 97250.0n 0.3000 97499.9n 0.3000 97500.0n 0.3000 97749.9n 0.3000 97750.0n 0.7000 97999.9n 0.7000 98000.0n 0.7000 98249.9n 0.7000 98250.0n 0.7000 98499.9n 0.7000 98500.0n 0.3000 98749.9n 0.3000 98750.0n 0.7000 98999.9n 0.7000 99000.0n 0.3000 99249.9n 0.3000 99250.0n 0.7000 99499.9n 0.7000 99500.0n 0.7000 99749.9n 0.7000 99750.0n 0.7000 99999.9n 0.7000 100000.0n 0.3000 100249.9n 0.3000 100250.0n 0.3000 100499.9n 0.3000 100500.0n 0.3000 100749.9n 0.3000 100750.0n 0.7000 100999.9n 0.7000 101000.0n 0.3000 101249.9n 0.3000 101250.0n 0.7000 101499.9n 0.7000 101500.0n 0.7000 101749.9n 0.7000 101750.0n 0.7000 101999.9n 0.7000 102000.0n 0.7000 102249.9n 0.7000 102250.0n 0.3000 102499.9n 0.3000 102500.0n 0.7000 102749.9n 0.7000 102750.0n 0.3000 102999.9n 0.3000 103000.0n 0.7000 103249.9n 0.7000 103250.0n 0.3000 103499.9n 0.3000 103500.0n 0.3000 103749.9n 0.3000 103750.0n 0.7000 103999.9n 0.7000 104000.0n 0.3000 104249.9n 0.3000 104250.0n 0.7000 104499.9n 0.7000 104500.0n 0.7000 104749.9n 0.7000 104750.0n 0.3000 104999.9n 0.3000 105000.0n 0.3000 105249.9n 0.3000 105250.0n 0.7000 105499.9n 0.7000 105500.0n 0.7000 105749.9n 0.7000 105750.0n 0.7000 105999.9n 0.7000 106000.0n 0.7000 106249.9n 0.7000 106250.0n 0.3000 106499.9n 0.3000 106500.0n 0.3000 106749.9n 0.3000 106750.0n 0.7000 106999.9n 0.7000 107000.0n 0.7000 107249.9n 0.7000 107250.0n 0.7000 107499.9n 0.7000 107500.0n 0.7000 107749.9n 0.7000 107750.0n 0.3000 107999.9n 0.3000 108000.0n 0.3000 108249.9n 0.3000 108250.0n 0.7000 108499.9n 0.7000 108500.0n 0.3000 108749.9n 0.3000 108750.0n 0.7000 108999.9n 0.7000 109000.0n 0.7000 109249.9n 0.7000 109250.0n 0.7000 109499.9n 0.7000 109500.0n 0.3000 109749.9n 0.3000 109750.0n 0.3000 109999.9n 0.3000 110000.0n 0.7000 110249.9n 0.7000 110250.0n 0.3000 110499.9n 0.3000 110500.0n 0.3000 110749.9n 0.3000 110750.0n 0.3000 110999.9n 0.3000 111000.0n 0.7000 111249.9n 0.7000 111250.0n 0.7000 111499.9n 0.7000 111500.0n 0.7000 111749.9n 0.7000 111750.0n 0.7000 111999.9n 0.7000 112000.0n 0.7000 112249.9n 0.7000 112250.0n 0.7000 112499.9n 0.7000 112500.0n 0.3000 112749.9n 0.3000 112750.0n 0.7000 112999.9n 0.7000 113000.0n 0.3000 113249.9n 0.3000 113250.0n 0.3000 113499.9n 0.3000 113500.0n 0.7000 113749.9n 0.7000 113750.0n 0.3000 113999.9n 0.3000 114000.0n 0.3000 114249.9n 0.3000 114250.0n 0.3000 114499.9n 0.3000 114500.0n 0.3000 114749.9n 0.3000 114750.0n 0.7000 114999.9n 0.7000 115000.0n 0.3000 115249.9n 0.3000 115250.0n 0.3000 115499.9n 0.3000 115500.0n 0.7000 115749.9n 0.7000 115750.0n 0.7000 115999.9n 0.7000 116000.0n 0.7000 116249.9n 0.7000 116250.0n 0.3000 116499.9n 0.3000 116500.0n 0.3000 116749.9n 0.3000 116750.0n 0.3000 116999.9n 0.3000 117000.0n 0.7000 117249.9n 0.7000 117250.0n 0.3000 117499.9n 0.3000 117500.0n 0.7000 117749.9n 0.7000 117750.0n 0.3000 117999.9n 0.3000 118000.0n 0.3000 118249.9n 0.3000 118250.0n 0.7000 118499.9n 0.7000 118500.0n 0.3000 118749.9n 0.3000 118750.0n 0.3000 118999.9n 0.3000 119000.0n 0.7000 119249.9n 0.7000 119250.0n 0.7000 119499.9n 0.7000 119500.0n 0.7000 119749.9n 0.7000 119750.0n 0.7000 119999.9n 0.7000 120000.0n 0.3000 120249.9n 0.3000 120250.0n 0.7000 120499.9n 0.7000 120500.0n 0.3000 120749.9n 0.3000 120750.0n 0.3000 120999.9n 0.3000 121000.0n 0.7000 121249.9n 0.7000 121250.0n 0.3000 121499.9n 0.3000 121500.0n 0.7000 121749.9n 0.7000 121750.0n 0.7000 121999.9n 0.7000 122000.0n 0.3000 122249.9n 0.3000 122250.0n 0.7000 122499.9n 0.7000 122500.0n 0.7000 122749.9n 0.7000 122750.0n 0.7000 122999.9n 0.7000 123000.0n 0.7000 123249.9n 0.7000 123250.0n 0.7000 123499.9n 0.7000 123500.0n 0.3000 123749.9n 0.3000 123750.0n 0.7000 123999.9n 0.7000 124000.0n 0.3000 124249.9n 0.3000 124250.0n 0.3000 124499.9n 0.3000 124500.0n 0.7000 124749.9n 0.7000 124750.0n 0.3000 124999.9n 0.3000 125000.0n 0.3000 125249.9n 0.3000 125250.0n 0.7000 125499.9n 0.7000 125500.0n 0.3000 125749.9n 0.3000 125750.0n 0.7000 125999.9n 0.7000 126000.0n 0.3000 126249.9n 0.3000 126250.0n 0.7000 126499.9n 0.7000 126500.0n 0.7000 126749.9n 0.7000 126750.0n 0.3000 126999.9n 0.3000 127000.0n 0.7000 127249.9n 0.7000 127250.0n 0.3000 127499.9n 0.3000 127500.0n 0.3000 127749.9n 0.3000 127750.0n 0.7000 127999.9n 0.7000 128000.0n 0.7000 128249.9n 0.7000 128250.0n 0.3000 128499.9n 0.3000 128500.0n 0.7000 128749.9n 0.7000 128750.0n 0.3000 128999.9n 0.3000 129000.0n 0.3000 129249.9n 0.3000 129250.0n 0.7000 129499.9n 0.7000 129500.0n 0.7000 129749.9n 0.7000 129750.0n 0.3000 129999.9n 0.3000 130000.0n 0.3000 130249.9n 0.3000 130250.0n 0.3000 130499.9n 0.3000 130500.0n 0.3000 130749.9n 0.3000 130750.0n 0.3000 130999.9n 0.3000 131000.0n 0.3000 131249.9n 0.3000 131250.0n 0.3000 131499.9n 0.3000 131500.0n 0.7000 131749.9n 0.7000 131750.0n 0.7000 131999.9n 0.7000 132000.0n 0.7000 132249.9n 0.7000 132250.0n 0.7000 132499.9n 0.7000 132500.0n 0.3000 132749.9n 0.3000 132750.0n 0.7000 132999.9n 0.7000 133000.0n 0.7000 133249.9n 0.7000 133250.0n 0.7000 133499.9n 0.7000 133500.0n 0.7000 133749.9n 0.7000 133750.0n 0.7000 133999.9n 0.7000 134000.0n 0.7000 134249.9n 0.7000 134250.0n 0.3000 134499.9n 0.3000 134500.0n 0.3000 134749.9n 0.3000 134750.0n 0.7000 134999.9n 0.7000 135000.0n 0.7000 135249.9n 0.7000 135250.0n 0.3000 135499.9n 0.3000 135500.0n 0.3000 135749.9n 0.3000 135750.0n 0.3000 135999.9n 0.3000 136000.0n 0.3000 136249.9n 0.3000 136250.0n 0.7000 136499.9n 0.7000 136500.0n 0.3000 136749.9n 0.3000 136750.0n 0.3000 136999.9n 0.3000 137000.0n 0.7000 137249.9n 0.7000 137250.0n 0.3000 137499.9n 0.3000 137500.0n 0.3000 137749.9n 0.3000 137750.0n 0.7000 137999.9n 0.7000 138000.0n 0.7000 138249.9n 0.7000 138250.0n 0.7000 138499.9n 0.7000 138500.0n 0.7000 138749.9n 0.7000 138750.0n 0.7000 138999.9n 0.7000 139000.0n 0.7000 139249.9n 0.7000 139250.0n 0.3000 139499.9n 0.3000 139500.0n 0.3000 139749.9n 0.3000 139750.0n 0.7000 139999.9n 0.7000 140000.0n 0.7000 140249.9n 0.7000 140250.0n 0.7000 140499.9n 0.7000 140500.0n 0.7000 140749.9n 0.7000 140750.0n 0.3000 140999.9n 0.3000 141000.0n 0.7000 141249.9n 0.7000 141250.0n 0.3000 141499.9n 0.3000 141500.0n 0.7000 141749.9n 0.7000 141750.0n 0.7000 141999.9n 0.7000 142000.0n 0.3000 142249.9n 0.3000 142250.0n 0.3000 142499.9n 0.3000 142500.0n 0.3000 142749.9n 0.3000 142750.0n 0.7000 142999.9n 0.7000 143000.0n 0.7000 143249.9n 0.7000 143250.0n 0.3000 143499.9n 0.3000 143500.0n 0.3000 143749.9n 0.3000 143750.0n 0.3000 143999.9n 0.3000 144000.0n 0.7000 144249.9n 0.7000 144250.0n 0.3000 144499.9n 0.3000 144500.0n 0.3000 144749.9n 0.3000 144750.0n 0.7000 144999.9n 0.7000 145000.0n 0.3000 145249.9n 0.3000 145250.0n 0.7000 145499.9n 0.7000 145500.0n 0.7000 145749.9n 0.7000 145750.0n 0.7000 145999.9n 0.7000 146000.0n 0.3000 146249.9n 0.3000 146250.0n 0.7000 146499.9n 0.7000 146500.0n 0.3000 146749.9n 0.3000 146750.0n 0.3000 146999.9n 0.3000 147000.0n 0.7000 147249.9n 0.7000 147250.0n 0.7000 147499.9n 0.7000 147500.0n 0.7000 147749.9n 0.7000 147750.0n 0.3000 147999.9n 0.3000 148000.0n 0.3000 148249.9n 0.3000 148250.0n 0.7000 148499.9n 0.7000 148500.0n 0.7000 148749.9n 0.7000 148750.0n 0.7000 148999.9n 0.7000 149000.0n 0.7000 149249.9n 0.7000 149250.0n 0.3000 149499.9n 0.3000 149500.0n 0.3000 149749.9n 0.3000 149750.0n 0.7000 149999.9n 0.7000 150000.0n 0.7000 150249.9n 0.7000 150250.0n 0.3000 150499.9n 0.3000 150500.0n 0.7000 150749.9n 0.7000 150750.0n 0.7000 150999.9n 0.7000 151000.0n 0.3000 151249.9n 0.3000 151250.0n 0.7000 151499.9n 0.7000 151500.0n 0.7000 151749.9n 0.7000 151750.0n 0.3000 151999.9n 0.3000 152000.0n 0.7000 152249.9n 0.7000 152250.0n 0.3000 152499.9n 0.3000 152500.0n 0.7000 152749.9n 0.7000 152750.0n 0.3000 152999.9n 0.3000 153000.0n 0.7000 153249.9n 0.7000 153250.0n 0.7000 153499.9n 0.7000 153500.0n 0.7000 153749.9n 0.7000 153750.0n 0.7000 153999.9n 0.7000 154000.0n 0.3000 154249.9n 0.3000 154250.0n 0.7000 154499.9n 0.7000 154500.0n 0.3000 154749.9n 0.3000 154750.0n 0.3000 154999.9n 0.3000 155000.0n 0.3000 155249.9n 0.3000 155250.0n 0.3000 155499.9n 0.3000 155500.0n 0.7000 155749.9n 0.7000 155750.0n 0.3000 155999.9n 0.3000 156000.0n 0.7000 156249.9n 0.7000 156250.0n 0.3000 156499.9n 0.3000 156500.0n 0.3000 156749.9n 0.3000 156750.0n 0.7000 156999.9n 0.7000 157000.0n 0.7000 157249.9n 0.7000 157250.0n 0.3000 157499.9n 0.3000 157500.0n 0.3000 157749.9n 0.3000 157750.0n 0.3000 157999.9n 0.3000 158000.0n 0.3000 158249.9n 0.3000 158250.0n 0.7000 158499.9n 0.7000 158500.0n 0.7000 158749.9n 0.7000 158750.0n 0.7000 158999.9n 0.7000 159000.0n 0.3000 159249.9n 0.3000 159250.0n 0.7000 159499.9n 0.7000 159500.0n 0.3000 159749.9n 0.3000 159750.0n 0.7000 159999.9n 0.7000 160000.0n 0.7000 160249.9n 0.7000 160250.0n 0.7000 160499.9n 0.7000 160500.0n 0.7000 160749.9n 0.7000 160750.0n 0.7000 160999.9n 0.7000 161000.0n 0.3000 161249.9n 0.3000 161250.0n 0.7000 161499.9n 0.7000 161500.0n 0.7000 161749.9n 0.7000 161750.0n 0.7000 161999.9n 0.7000 162000.0n 0.7000 162249.9n 0.7000 162250.0n 0.3000 162499.9n 0.3000 162500.0n 0.3000 162749.9n 0.3000 162750.0n 0.7000 162999.9n 0.7000 163000.0n 0.7000 163249.9n 0.7000 163250.0n 0.3000 163499.9n 0.3000 163500.0n 0.3000 163749.9n 0.3000 163750.0n 0.3000 163999.9n 0.3000 164000.0n 0.7000 164249.9n 0.7000 164250.0n 0.3000 164499.9n 0.3000 164500.0n 0.3000 164749.9n 0.3000 164750.0n 0.3000 164999.9n 0.3000 165000.0n 0.3000 165249.9n 0.3000 165250.0n 0.3000 165499.9n 0.3000 165500.0n 0.7000 165749.9n 0.7000 165750.0n 0.3000 165999.9n 0.3000 166000.0n 0.3000 166249.9n 0.3000 166250.0n 0.3000 166499.9n 0.3000 166500.0n 0.3000 166749.9n 0.3000 166750.0n 0.3000 166999.9n 0.3000 167000.0n 0.7000 167249.9n 0.7000 167250.0n 0.3000 167499.9n 0.3000 167500.0n 0.7000 167749.9n 0.7000 167750.0n 0.3000 167999.9n 0.3000 168000.0n 0.7000 168249.9n 0.7000 168250.0n 0.7000 168499.9n 0.7000 168500.0n 0.7000 168749.9n 0.7000 168750.0n 0.7000 168999.9n 0.7000 169000.0n 0.3000 169249.9n 0.3000 169250.0n 0.7000 169499.9n 0.7000 169500.0n 0.3000 169749.9n 0.3000 169750.0n 0.3000 169999.9n 0.3000 170000.0n 0.3000 170249.9n 0.3000 170250.0n 0.7000 170499.9n 0.7000 170500.0n 0.7000 170749.9n 0.7000 170750.0n 0.3000 170999.9n 0.3000 171000.0n 0.7000 171249.9n 0.7000 171250.0n 0.7000 171499.9n 0.7000 171500.0n 0.7000 171749.9n 0.7000 171750.0n 0.7000 171999.9n 0.7000 172000.0n 0.3000 172249.9n 0.3000 172250.0n 0.3000 172499.9n 0.3000 172500.0n 0.3000 172749.9n 0.3000 172750.0n 0.7000 172999.9n 0.7000 173000.0n 0.7000 173249.9n 0.7000 173250.0n 0.7000 173499.9n 0.7000 173500.0n 0.7000 173749.9n 0.7000 173750.0n 0.7000 173999.9n 0.7000 174000.0n 0.3000 174249.9n 0.3000 174250.0n 0.7000 174499.9n 0.7000 174500.0n 0.7000 174749.9n 0.7000 174750.0n 0.7000 174999.9n 0.7000 175000.0n 0.3000 175249.9n 0.3000 175250.0n 0.3000 175499.9n 0.3000 175500.0n 0.7000 175749.9n 0.7000 175750.0n 0.7000 175999.9n 0.7000 176000.0n 0.7000 176249.9n 0.7000 176250.0n 0.3000 176499.9n 0.3000 176500.0n 0.7000 176749.9n 0.7000 176750.0n 0.3000 176999.9n 0.3000 177000.0n 0.7000 177249.9n 0.7000 177250.0n 0.3000 177499.9n 0.3000 177500.0n 0.7000 177749.9n 0.7000 177750.0n 0.3000 177999.9n 0.3000 178000.0n 0.3000 178249.9n 0.3000 178250.0n 0.3000 178499.9n 0.3000 178500.0n 0.3000 178749.9n 0.3000 178750.0n 0.7000 178999.9n 0.7000 179000.0n 0.7000 179249.9n 0.7000 179250.0n 0.7000 179499.9n 0.7000 179500.0n 0.7000 179749.9n 0.7000 179750.0n 0.3000 179999.9n 0.3000 180000.0n 0.5000 180249.9n 0.5000 180250.0n 0.5000 180499.9n 0.5000 180500.0n 0.5000 180749.9n 0.5000 180750.0n 0.5000 180999.9n 0.5000 181000.0n 0.5000 181249.9n 0.5000 181250.0n 0.5000 181499.9n 0.5000 181500.0n 0.5000 181749.9n 0.5000 181750.0n 0.5000 181999.9n 0.5000 182000.0n 0.5000 182249.9n 0.5000 182250.0n 0.5000 182499.9n 0.5000 182500.0n 0.5000 182749.9n 0.5000 182750.0n 0.5000 182999.9n 0.5000 183000.0n 0.5000 183249.9n 0.5000 183250.0n 0.5000 183499.9n 0.5000 183500.0n 0.5000 183749.9n 0.5000 183750.0n 0.5000 183999.9n 0.5000 184000.0n 0.5000 184249.9n 0.5000 184250.0n 0.5000 184499.9n 0.5000 184500.0n 0.5000 184749.9n 0.5000 184750.0n 0.5000 184999.9n 0.5000 185000.0n 0.5000 185249.9n 0.5000 185250.0n 0.5000 185499.9n 0.5000 185500.0n 0.5000 185749.9n 0.5000 185750.0n 0.5000 185999.9n 0.5000 186000.0n 0.5000 186249.9n 0.5000 186250.0n 0.5000 186499.9n 0.5000 186500.0n 0.5000 186749.9n 0.5000 186750.0n 0.5000 186999.9n 0.5000 187000.0n 0.5000 187249.9n 0.5000 187250.0n 0.5000 187499.9n 0.5000 187500.0n 0.5000 187749.9n 0.5000 187750.0n 0.5000 187999.9n 0.5000 188000.0n 0.5000 188249.9n 0.5000 188250.0n 0.5000 188499.9n 0.5000 188500.0n 0.5000 188749.9n 0.5000 188750.0n 0.5000 188999.9n 0.5000 189000.0n 0.5000 189249.9n 0.5000 189250.0n 0.5000 189499.9n 0.5000 189500.0n 0.5000 189749.9n 0.5000 189750.0n 0.5000 189999.9n 0.5000 190000.0n 0.5000 190249.9n 0.5000 190250.0n 0.5000 190499.9n 0.5000 190500.0n 0.5000 190749.9n 0.5000 190750.0n 0.5000 190999.9n 0.5000 191000.0n 0.5000 191249.9n 0.5000 191250.0n 0.5000 191499.9n 0.5000 191500.0n 0.5000 191749.9n 0.5000 191750.0n 0.5000 191999.9n 0.5000 192000.0n 0.5000 192249.9n 0.5000 192250.0n 0.5000 192499.9n 0.5000 192500.0n 0.5000 192749.9n 0.5000 192750.0n 0.5000 192999.9n 0.5000 193000.0n 0.5000 193249.9n 0.5000 193250.0n 0.5000 193499.9n 0.5000 193500.0n 0.5000 193749.9n 0.5000 193750.0n 0.5000 193999.9n 0.5000 194000.0n 0.5000 194249.9n 0.5000 194250.0n 0.5000 194499.9n 0.5000 194500.0n 0.5000 194749.9n 0.5000 194750.0n 0.5000 194999.9n 0.5000 195000.0n 0.5000 195249.9n 0.5000 195250.0n 0.5000 195499.9n 0.5000 195500.0n 0.5000 195749.9n 0.5000 195750.0n 0.5000 195999.9n 0.5000 196000.0n 0.5000 196249.9n 0.5000 196250.0n 0.5000 196499.9n 0.5000 196500.0n 0.5000 196749.9n 0.5000 196750.0n 0.5000 196999.9n 0.5000 197000.0n 0.5000 197249.9n 0.5000 197250.0n 0.5000 197499.9n 0.5000 197500.0n 0.5000 197749.9n 0.5000 197750.0n 0.5000 197999.9n 0.5000 198000.0n 0.5000 198249.9n 0.5000 198250.0n 0.5000 198499.9n 0.5000 198500.0n 0.5000 198749.9n 0.5000 198750.0n 0.5000 198999.9n 0.5000 199000.0n 0.5000 199249.9n 0.5000 199250.0n 0.5000 199499.9n 0.5000 199500.0n 0.5000 199749.9n 0.5000 199750.0n 0.5000 199999.9n 0.5000 200000.0n 0.5000 200249.9n 0.5000 200250.0n 0.5000 200499.9n 0.5000 200500.0n 0.5000 200749.9n 0.5000 200750.0n 0.5000 200999.9n 0.5000 201000.0n 0.5000 201249.9n 0.5000 201250.0n 0.5000 201499.9n 0.5000 201500.0n 0.5000 201749.9n 0.5000 201750.0n 0.5000 201999.9n 0.5000 202000.0n 0.5000 202249.9n 0.5000 202250.0n 0.5000 202499.9n 0.5000 202500.0n 0.5000 202749.9n 0.5000 202750.0n 0.5000 202999.9n 0.5000 203000.0n 0.5000 203249.9n 0.5000 203250.0n 0.5000 203499.9n 0.5000 203500.0n 0.5000 203749.9n 0.5000 203750.0n 0.5000 203999.9n 0.5000 204000.0n 0.5000 204249.9n 0.5000 204250.0n 0.5000 204499.9n 0.5000 204500.0n 0.5000 204749.9n 0.5000 204750.0n 0.5000 204999.9n 0.5000 205000.0n 0.5000 205249.9n 0.5000 205250.0n 0.5000 205499.9n 0.5000 205500.0n 0.5000 205749.9n 0.5000 205750.0n 0.5000 205999.9n 0.5000 206000.0n 0.5000 206249.9n 0.5000 206250.0n 0.5000 206499.9n 0.5000 206500.0n 0.5000 206749.9n 0.5000 206750.0n 0.5000 206999.9n 0.5000 207000.0n 0.5000 207249.9n 0.5000 207250.0n 0.5000 207499.9n 0.5000 207500.0n 0.5000 207749.9n 0.5000 207750.0n 0.5000 207999.9n 0.5000 208000.0n 0.5000 208249.9n 0.5000 208250.0n 0.5000 208499.9n 0.5000 208500.0n 0.5000 208749.9n 0.5000 208750.0n 0.5000 208999.9n 0.5000 209000.0n 0.5000 209249.9n 0.5000 209250.0n 0.5000 209499.9n 0.5000 209500.0n 0.5000 209749.9n 0.5000 209750.0n 0.5000)
Vxon xon 0 PWL(0.0n 0.3000 249.9n 0.3000 250.0n 0.3000 499.9n 0.3000 500.0n 0.7000 749.9n 0.7000 750.0n 0.3000 999.9n 0.3000 1000.0n 0.7000 1249.9n 0.7000 1250.0n 0.3000 1499.9n 0.3000 1500.0n 0.7000 1749.9n 0.7000 1750.0n 0.3000 1999.9n 0.3000 2000.0n 0.3000 2249.9n 0.3000 2250.0n 0.7000 2499.9n 0.7000 2500.0n 0.7000 2749.9n 0.7000 2750.0n 0.7000 2999.9n 0.7000 3000.0n 0.3000 3249.9n 0.3000 3250.0n 0.7000 3499.9n 0.7000 3500.0n 0.3000 3749.9n 0.3000 3750.0n 0.3000 3999.9n 0.3000 4000.0n 0.3000 4249.9n 0.3000 4250.0n 0.3000 4499.9n 0.3000 4500.0n 0.7000 4749.9n 0.7000 4750.0n 0.7000 4999.9n 0.7000 5000.0n 0.3000 5249.9n 0.3000 5250.0n 0.7000 5499.9n 0.7000 5500.0n 0.7000 5749.9n 0.7000 5750.0n 0.7000 5999.9n 0.7000 6000.0n 0.7000 6249.9n 0.7000 6250.0n 0.7000 6499.9n 0.7000 6500.0n 0.3000 6749.9n 0.3000 6750.0n 0.7000 6999.9n 0.7000 7000.0n 0.7000 7249.9n 0.7000 7250.0n 0.3000 7499.9n 0.3000 7500.0n 0.3000 7749.9n 0.3000 7750.0n 0.3000 7999.9n 0.3000 8000.0n 0.7000 8249.9n 0.7000 8250.0n 0.7000 8499.9n 0.7000 8500.0n 0.3000 8749.9n 0.3000 8750.0n 0.3000 8999.9n 0.3000 9000.0n 0.7000 9249.9n 0.7000 9250.0n 0.7000 9499.9n 0.7000 9500.0n 0.3000 9749.9n 0.3000 9750.0n 0.3000 9999.9n 0.3000 10000.0n 0.3000 10249.9n 0.3000 10250.0n 0.3000 10499.9n 0.3000 10500.0n 0.7000 10749.9n 0.7000 10750.0n 0.3000 10999.9n 0.3000 11000.0n 0.3000 11249.9n 0.3000 11250.0n 0.3000 11499.9n 0.3000 11500.0n 0.7000 11749.9n 0.7000 11750.0n 0.7000 11999.9n 0.7000 12000.0n 0.3000 12249.9n 0.3000 12250.0n 0.3000 12499.9n 0.3000 12500.0n 0.7000 12749.9n 0.7000 12750.0n 0.3000 12999.9n 0.3000 13000.0n 0.3000 13249.9n 0.3000 13250.0n 0.7000 13499.9n 0.7000 13500.0n 0.7000 13749.9n 0.7000 13750.0n 0.3000 13999.9n 0.3000 14000.0n 0.7000 14249.9n 0.7000 14250.0n 0.7000 14499.9n 0.7000 14500.0n 0.3000 14749.9n 0.3000 14750.0n 0.3000 14999.9n 0.3000 15000.0n 0.3000 15249.9n 0.3000 15250.0n 0.3000 15499.9n 0.3000 15500.0n 0.3000 15749.9n 0.3000 15750.0n 0.3000 15999.9n 0.3000 16000.0n 0.3000 16249.9n 0.3000 16250.0n 0.3000 16499.9n 0.3000 16500.0n 0.7000 16749.9n 0.7000 16750.0n 0.7000 16999.9n 0.7000 17000.0n 0.7000 17249.9n 0.7000 17250.0n 0.7000 17499.9n 0.7000 17500.0n 0.7000 17749.9n 0.7000 17750.0n 0.3000 17999.9n 0.3000 18000.0n 0.7000 18249.9n 0.7000 18250.0n 0.3000 18499.9n 0.3000 18500.0n 0.7000 18749.9n 0.7000 18750.0n 0.3000 18999.9n 0.3000 19000.0n 0.7000 19249.9n 0.7000 19250.0n 0.7000 19499.9n 0.7000 19500.0n 0.3000 19749.9n 0.3000 19750.0n 0.7000 19999.9n 0.7000 20000.0n 0.7000 20249.9n 0.7000 20250.0n 0.3000 20499.9n 0.3000 20500.0n 0.3000 20749.9n 0.3000 20750.0n 0.3000 20999.9n 0.3000 21000.0n 0.7000 21249.9n 0.7000 21250.0n 0.3000 21499.9n 0.3000 21500.0n 0.3000 21749.9n 0.3000 21750.0n 0.7000 21999.9n 0.7000 22000.0n 0.3000 22249.9n 0.3000 22250.0n 0.3000 22499.9n 0.3000 22500.0n 0.7000 22749.9n 0.7000 22750.0n 0.7000 22999.9n 0.7000 23000.0n 0.3000 23249.9n 0.3000 23250.0n 0.3000 23499.9n 0.3000 23500.0n 0.3000 23749.9n 0.3000 23750.0n 0.3000 23999.9n 0.3000 24000.0n 0.7000 24249.9n 0.7000 24250.0n 0.7000 24499.9n 0.7000 24500.0n 0.7000 24749.9n 0.7000 24750.0n 0.7000 24999.9n 0.7000 25000.0n 0.3000 25249.9n 0.3000 25250.0n 0.7000 25499.9n 0.7000 25500.0n 0.7000 25749.9n 0.7000 25750.0n 0.7000 25999.9n 0.7000 26000.0n 0.3000 26249.9n 0.3000 26250.0n 0.7000 26499.9n 0.7000 26500.0n 0.7000 26749.9n 0.7000 26750.0n 0.3000 26999.9n 0.3000 27000.0n 0.7000 27249.9n 0.7000 27250.0n 0.7000 27499.9n 0.7000 27500.0n 0.3000 27749.9n 0.3000 27750.0n 0.7000 27999.9n 0.7000 28000.0n 0.3000 28249.9n 0.3000 28250.0n 0.3000 28499.9n 0.3000 28500.0n 0.3000 28749.9n 0.3000 28750.0n 0.3000 28999.9n 0.3000 29000.0n 0.7000 29249.9n 0.7000 29250.0n 0.3000 29499.9n 0.3000 29500.0n 0.3000 29749.9n 0.3000 29750.0n 0.3000 29999.9n 0.3000 30000.0n 0.3000 30249.9n 0.3000 30250.0n 0.7000 30499.9n 0.7000 30500.0n 0.3000 30749.9n 0.3000 30750.0n 0.3000 30999.9n 0.3000 31000.0n 0.3000 31249.9n 0.3000 31250.0n 0.3000 31499.9n 0.3000 31500.0n 0.3000 31749.9n 0.3000 31750.0n 0.3000 31999.9n 0.3000 32000.0n 0.3000 32249.9n 0.3000 32250.0n 0.7000 32499.9n 0.7000 32500.0n 0.3000 32749.9n 0.3000 32750.0n 0.3000 32999.9n 0.3000 33000.0n 0.7000 33249.9n 0.7000 33250.0n 0.3000 33499.9n 0.3000 33500.0n 0.7000 33749.9n 0.7000 33750.0n 0.3000 33999.9n 0.3000 34000.0n 0.3000 34249.9n 0.3000 34250.0n 0.7000 34499.9n 0.7000 34500.0n 0.3000 34749.9n 0.3000 34750.0n 0.7000 34999.9n 0.7000 35000.0n 0.7000 35249.9n 0.7000 35250.0n 0.3000 35499.9n 0.3000 35500.0n 0.7000 35749.9n 0.7000 35750.0n 0.3000 35999.9n 0.3000 36000.0n 0.3000 36249.9n 0.3000 36250.0n 0.3000 36499.9n 0.3000 36500.0n 0.7000 36749.9n 0.7000 36750.0n 0.3000 36999.9n 0.3000 37000.0n 0.3000 37249.9n 0.3000 37250.0n 0.7000 37499.9n 0.7000 37500.0n 0.3000 37749.9n 0.3000 37750.0n 0.7000 37999.9n 0.7000 38000.0n 0.7000 38249.9n 0.7000 38250.0n 0.3000 38499.9n 0.3000 38500.0n 0.7000 38749.9n 0.7000 38750.0n 0.7000 38999.9n 0.7000 39000.0n 0.7000 39249.9n 0.7000 39250.0n 0.7000 39499.9n 0.7000 39500.0n 0.7000 39749.9n 0.7000 39750.0n 0.3000 39999.9n 0.3000 40000.0n 0.3000 40249.9n 0.3000 40250.0n 0.3000 40499.9n 0.3000 40500.0n 0.7000 40749.9n 0.7000 40750.0n 0.7000 40999.9n 0.7000 41000.0n 0.3000 41249.9n 0.3000 41250.0n 0.7000 41499.9n 0.7000 41500.0n 0.7000 41749.9n 0.7000 41750.0n 0.7000 41999.9n 0.7000 42000.0n 0.3000 42249.9n 0.3000 42250.0n 0.7000 42499.9n 0.7000 42500.0n 0.3000 42749.9n 0.3000 42750.0n 0.3000 42999.9n 0.3000 43000.0n 0.7000 43249.9n 0.7000 43250.0n 0.3000 43499.9n 0.3000 43500.0n 0.7000 43749.9n 0.7000 43750.0n 0.3000 43999.9n 0.3000 44000.0n 0.3000 44249.9n 0.3000 44250.0n 0.7000 44499.9n 0.7000 44500.0n 0.7000 44749.9n 0.7000 44750.0n 0.7000 44999.9n 0.7000 45000.0n 0.7000 45249.9n 0.7000 45250.0n 0.7000 45499.9n 0.7000 45500.0n 0.7000 45749.9n 0.7000 45750.0n 0.7000 45999.9n 0.7000 46000.0n 0.3000 46249.9n 0.3000 46250.0n 0.3000 46499.9n 0.3000 46500.0n 0.3000 46749.9n 0.3000 46750.0n 0.7000 46999.9n 0.7000 47000.0n 0.3000 47249.9n 0.3000 47250.0n 0.3000 47499.9n 0.3000 47500.0n 0.3000 47749.9n 0.3000 47750.0n 0.7000 47999.9n 0.7000 48000.0n 0.7000 48249.9n 0.7000 48250.0n 0.3000 48499.9n 0.3000 48500.0n 0.3000 48749.9n 0.3000 48750.0n 0.3000 48999.9n 0.3000 49000.0n 0.3000 49249.9n 0.3000 49250.0n 0.3000 49499.9n 0.3000 49500.0n 0.7000 49749.9n 0.7000 49750.0n 0.3000 49999.9n 0.3000 50000.0n 0.3000 50249.9n 0.3000 50250.0n 0.3000 50499.9n 0.3000 50500.0n 0.7000 50749.9n 0.7000 50750.0n 0.7000 50999.9n 0.7000 51000.0n 0.3000 51249.9n 0.3000 51250.0n 0.3000 51499.9n 0.3000 51500.0n 0.7000 51749.9n 0.7000 51750.0n 0.7000 51999.9n 0.7000 52000.0n 0.3000 52249.9n 0.3000 52250.0n 0.3000 52499.9n 0.3000 52500.0n 0.3000 52749.9n 0.3000 52750.0n 0.3000 52999.9n 0.3000 53000.0n 0.3000 53249.9n 0.3000 53250.0n 0.7000 53499.9n 0.7000 53500.0n 0.3000 53749.9n 0.3000 53750.0n 0.3000 53999.9n 0.3000 54000.0n 0.3000 54249.9n 0.3000 54250.0n 0.3000 54499.9n 0.3000 54500.0n 0.3000 54749.9n 0.3000 54750.0n 0.7000 54999.9n 0.7000 55000.0n 0.3000 55249.9n 0.3000 55250.0n 0.3000 55499.9n 0.3000 55500.0n 0.7000 55749.9n 0.7000 55750.0n 0.7000 55999.9n 0.7000 56000.0n 0.7000 56249.9n 0.7000 56250.0n 0.7000 56499.9n 0.7000 56500.0n 0.7000 56749.9n 0.7000 56750.0n 0.7000 56999.9n 0.7000 57000.0n 0.7000 57249.9n 0.7000 57250.0n 0.7000 57499.9n 0.7000 57500.0n 0.7000 57749.9n 0.7000 57750.0n 0.3000 57999.9n 0.3000 58000.0n 0.3000 58249.9n 0.3000 58250.0n 0.7000 58499.9n 0.7000 58500.0n 0.3000 58749.9n 0.3000 58750.0n 0.7000 58999.9n 0.7000 59000.0n 0.3000 59249.9n 0.3000 59250.0n 0.7000 59499.9n 0.7000 59500.0n 0.7000 59749.9n 0.7000 59750.0n 0.7000 59999.9n 0.7000 60000.0n 0.3000 60249.9n 0.3000 60250.0n 0.3000 60499.9n 0.3000 60500.0n 0.3000 60749.9n 0.3000 60750.0n 0.3000 60999.9n 0.3000 61000.0n 0.7000 61249.9n 0.7000 61250.0n 0.3000 61499.9n 0.3000 61500.0n 0.3000 61749.9n 0.3000 61750.0n 0.3000 61999.9n 0.3000 62000.0n 0.7000 62249.9n 0.7000 62250.0n 0.7000 62499.9n 0.7000 62500.0n 0.7000 62749.9n 0.7000 62750.0n 0.7000 62999.9n 0.7000 63000.0n 0.7000 63249.9n 0.7000 63250.0n 0.7000 63499.9n 0.7000 63500.0n 0.3000 63749.9n 0.3000 63750.0n 0.3000 63999.9n 0.3000 64000.0n 0.3000 64249.9n 0.3000 64250.0n 0.3000 64499.9n 0.3000 64500.0n 0.3000 64749.9n 0.3000 64750.0n 0.7000 64999.9n 0.7000 65000.0n 0.3000 65249.9n 0.3000 65250.0n 0.3000 65499.9n 0.3000 65500.0n 0.3000 65749.9n 0.3000 65750.0n 0.7000 65999.9n 0.7000 66000.0n 0.7000 66249.9n 0.7000 66250.0n 0.7000 66499.9n 0.7000 66500.0n 0.7000 66749.9n 0.7000 66750.0n 0.7000 66999.9n 0.7000 67000.0n 0.7000 67249.9n 0.7000 67250.0n 0.3000 67499.9n 0.3000 67500.0n 0.7000 67749.9n 0.7000 67750.0n 0.7000 67999.9n 0.7000 68000.0n 0.3000 68249.9n 0.3000 68250.0n 0.3000 68499.9n 0.3000 68500.0n 0.3000 68749.9n 0.3000 68750.0n 0.3000 68999.9n 0.3000 69000.0n 0.3000 69249.9n 0.3000 69250.0n 0.3000 69499.9n 0.3000 69500.0n 0.7000 69749.9n 0.7000 69750.0n 0.3000 69999.9n 0.3000 70000.0n 0.7000 70249.9n 0.7000 70250.0n 0.7000 70499.9n 0.7000 70500.0n 0.3000 70749.9n 0.3000 70750.0n 0.3000 70999.9n 0.3000 71000.0n 0.7000 71249.9n 0.7000 71250.0n 0.7000 71499.9n 0.7000 71500.0n 0.3000 71749.9n 0.3000 71750.0n 0.7000 71999.9n 0.7000 72000.0n 0.7000 72249.9n 0.7000 72250.0n 0.3000 72499.9n 0.3000 72500.0n 0.7000 72749.9n 0.7000 72750.0n 0.3000 72999.9n 0.3000 73000.0n 0.3000 73249.9n 0.3000 73250.0n 0.7000 73499.9n 0.7000 73500.0n 0.7000 73749.9n 0.7000 73750.0n 0.7000 73999.9n 0.7000 74000.0n 0.3000 74249.9n 0.3000 74250.0n 0.7000 74499.9n 0.7000 74500.0n 0.3000 74749.9n 0.3000 74750.0n 0.3000 74999.9n 0.3000 75000.0n 0.7000 75249.9n 0.7000 75250.0n 0.3000 75499.9n 0.3000 75500.0n 0.7000 75749.9n 0.7000 75750.0n 0.3000 75999.9n 0.3000 76000.0n 0.3000 76249.9n 0.3000 76250.0n 0.7000 76499.9n 0.7000 76500.0n 0.3000 76749.9n 0.3000 76750.0n 0.7000 76999.9n 0.7000 77000.0n 0.7000 77249.9n 0.7000 77250.0n 0.3000 77499.9n 0.3000 77500.0n 0.7000 77749.9n 0.7000 77750.0n 0.3000 77999.9n 0.3000 78000.0n 0.3000 78249.9n 0.3000 78250.0n 0.7000 78499.9n 0.7000 78500.0n 0.3000 78749.9n 0.3000 78750.0n 0.7000 78999.9n 0.7000 79000.0n 0.3000 79249.9n 0.3000 79250.0n 0.7000 79499.9n 0.7000 79500.0n 0.3000 79749.9n 0.3000 79750.0n 0.7000 79999.9n 0.7000 80000.0n 0.3000 80249.9n 0.3000 80250.0n 0.3000 80499.9n 0.3000 80500.0n 0.7000 80749.9n 0.7000 80750.0n 0.7000 80999.9n 0.7000 81000.0n 0.7000 81249.9n 0.7000 81250.0n 0.7000 81499.9n 0.7000 81500.0n 0.7000 81749.9n 0.7000 81750.0n 0.3000 81999.9n 0.3000 82000.0n 0.7000 82249.9n 0.7000 82250.0n 0.7000 82499.9n 0.7000 82500.0n 0.3000 82749.9n 0.3000 82750.0n 0.7000 82999.9n 0.7000 83000.0n 0.7000 83249.9n 0.7000 83250.0n 0.3000 83499.9n 0.3000 83500.0n 0.7000 83749.9n 0.7000 83750.0n 0.7000 83999.9n 0.7000 84000.0n 0.3000 84249.9n 0.3000 84250.0n 0.3000 84499.9n 0.3000 84500.0n 0.7000 84749.9n 0.7000 84750.0n 0.7000 84999.9n 0.7000 85000.0n 0.3000 85249.9n 0.3000 85250.0n 0.3000 85499.9n 0.3000 85500.0n 0.3000 85749.9n 0.3000 85750.0n 0.3000 85999.9n 0.3000 86000.0n 0.3000 86249.9n 0.3000 86250.0n 0.3000 86499.9n 0.3000 86500.0n 0.3000 86749.9n 0.3000 86750.0n 0.3000 86999.9n 0.3000 87000.0n 0.7000 87249.9n 0.7000 87250.0n 0.7000 87499.9n 0.7000 87500.0n 0.7000 87749.9n 0.7000 87750.0n 0.7000 87999.9n 0.7000 88000.0n 0.3000 88249.9n 0.3000 88250.0n 0.3000 88499.9n 0.3000 88500.0n 0.3000 88749.9n 0.3000 88750.0n 0.3000 88999.9n 0.3000 89000.0n 0.3000 89249.9n 0.3000 89250.0n 0.3000 89499.9n 0.3000 89500.0n 0.3000 89749.9n 0.3000 89750.0n 0.7000 89999.9n 0.7000 90000.0n 0.7000 90249.9n 0.7000 90250.0n 0.3000 90499.9n 0.3000 90500.0n 0.3000 90749.9n 0.3000 90750.0n 0.7000 90999.9n 0.7000 91000.0n 0.7000 91249.9n 0.7000 91250.0n 0.3000 91499.9n 0.3000 91500.0n 0.3000 91749.9n 0.3000 91750.0n 0.7000 91999.9n 0.7000 92000.0n 0.3000 92249.9n 0.3000 92250.0n 0.7000 92499.9n 0.7000 92500.0n 0.7000 92749.9n 0.7000 92750.0n 0.3000 92999.9n 0.3000 93000.0n 0.3000 93249.9n 0.3000 93250.0n 0.7000 93499.9n 0.7000 93500.0n 0.3000 93749.9n 0.3000 93750.0n 0.3000 93999.9n 0.3000 94000.0n 0.3000 94249.9n 0.3000 94250.0n 0.7000 94499.9n 0.7000 94500.0n 0.7000 94749.9n 0.7000 94750.0n 0.3000 94999.9n 0.3000 95000.0n 0.7000 95249.9n 0.7000 95250.0n 0.7000 95499.9n 0.7000 95500.0n 0.7000 95749.9n 0.7000 95750.0n 0.3000 95999.9n 0.3000 96000.0n 0.3000 96249.9n 0.3000 96250.0n 0.3000 96499.9n 0.3000 96500.0n 0.3000 96749.9n 0.3000 96750.0n 0.7000 96999.9n 0.7000 97000.0n 0.7000 97249.9n 0.7000 97250.0n 0.7000 97499.9n 0.7000 97500.0n 0.7000 97749.9n 0.7000 97750.0n 0.3000 97999.9n 0.3000 98000.0n 0.3000 98249.9n 0.3000 98250.0n 0.3000 98499.9n 0.3000 98500.0n 0.7000 98749.9n 0.7000 98750.0n 0.3000 98999.9n 0.3000 99000.0n 0.7000 99249.9n 0.7000 99250.0n 0.3000 99499.9n 0.3000 99500.0n 0.3000 99749.9n 0.3000 99750.0n 0.3000 99999.9n 0.3000 100000.0n 0.7000 100249.9n 0.7000 100250.0n 0.7000 100499.9n 0.7000 100500.0n 0.7000 100749.9n 0.7000 100750.0n 0.3000 100999.9n 0.3000 101000.0n 0.7000 101249.9n 0.7000 101250.0n 0.3000 101499.9n 0.3000 101500.0n 0.3000 101749.9n 0.3000 101750.0n 0.3000 101999.9n 0.3000 102000.0n 0.3000 102249.9n 0.3000 102250.0n 0.7000 102499.9n 0.7000 102500.0n 0.3000 102749.9n 0.3000 102750.0n 0.7000 102999.9n 0.7000 103000.0n 0.3000 103249.9n 0.3000 103250.0n 0.7000 103499.9n 0.7000 103500.0n 0.7000 103749.9n 0.7000 103750.0n 0.3000 103999.9n 0.3000 104000.0n 0.7000 104249.9n 0.7000 104250.0n 0.3000 104499.9n 0.3000 104500.0n 0.3000 104749.9n 0.3000 104750.0n 0.7000 104999.9n 0.7000 105000.0n 0.7000 105249.9n 0.7000 105250.0n 0.3000 105499.9n 0.3000 105500.0n 0.3000 105749.9n 0.3000 105750.0n 0.3000 105999.9n 0.3000 106000.0n 0.3000 106249.9n 0.3000 106250.0n 0.7000 106499.9n 0.7000 106500.0n 0.7000 106749.9n 0.7000 106750.0n 0.3000 106999.9n 0.3000 107000.0n 0.3000 107249.9n 0.3000 107250.0n 0.3000 107499.9n 0.3000 107500.0n 0.3000 107749.9n 0.3000 107750.0n 0.7000 107999.9n 0.7000 108000.0n 0.7000 108249.9n 0.7000 108250.0n 0.3000 108499.9n 0.3000 108500.0n 0.7000 108749.9n 0.7000 108750.0n 0.3000 108999.9n 0.3000 109000.0n 0.3000 109249.9n 0.3000 109250.0n 0.3000 109499.9n 0.3000 109500.0n 0.7000 109749.9n 0.7000 109750.0n 0.7000 109999.9n 0.7000 110000.0n 0.3000 110249.9n 0.3000 110250.0n 0.7000 110499.9n 0.7000 110500.0n 0.7000 110749.9n 0.7000 110750.0n 0.7000 110999.9n 0.7000 111000.0n 0.3000 111249.9n 0.3000 111250.0n 0.3000 111499.9n 0.3000 111500.0n 0.3000 111749.9n 0.3000 111750.0n 0.3000 111999.9n 0.3000 112000.0n 0.3000 112249.9n 0.3000 112250.0n 0.3000 112499.9n 0.3000 112500.0n 0.7000 112749.9n 0.7000 112750.0n 0.3000 112999.9n 0.3000 113000.0n 0.7000 113249.9n 0.7000 113250.0n 0.7000 113499.9n 0.7000 113500.0n 0.3000 113749.9n 0.3000 113750.0n 0.7000 113999.9n 0.7000 114000.0n 0.7000 114249.9n 0.7000 114250.0n 0.7000 114499.9n 0.7000 114500.0n 0.7000 114749.9n 0.7000 114750.0n 0.3000 114999.9n 0.3000 115000.0n 0.7000 115249.9n 0.7000 115250.0n 0.7000 115499.9n 0.7000 115500.0n 0.3000 115749.9n 0.3000 115750.0n 0.3000 115999.9n 0.3000 116000.0n 0.3000 116249.9n 0.3000 116250.0n 0.7000 116499.9n 0.7000 116500.0n 0.7000 116749.9n 0.7000 116750.0n 0.7000 116999.9n 0.7000 117000.0n 0.3000 117249.9n 0.3000 117250.0n 0.7000 117499.9n 0.7000 117500.0n 0.3000 117749.9n 0.3000 117750.0n 0.7000 117999.9n 0.7000 118000.0n 0.7000 118249.9n 0.7000 118250.0n 0.3000 118499.9n 0.3000 118500.0n 0.7000 118749.9n 0.7000 118750.0n 0.7000 118999.9n 0.7000 119000.0n 0.3000 119249.9n 0.3000 119250.0n 0.3000 119499.9n 0.3000 119500.0n 0.3000 119749.9n 0.3000 119750.0n 0.3000 119999.9n 0.3000 120000.0n 0.7000 120249.9n 0.7000 120250.0n 0.3000 120499.9n 0.3000 120500.0n 0.7000 120749.9n 0.7000 120750.0n 0.7000 120999.9n 0.7000 121000.0n 0.3000 121249.9n 0.3000 121250.0n 0.7000 121499.9n 0.7000 121500.0n 0.3000 121749.9n 0.3000 121750.0n 0.3000 121999.9n 0.3000 122000.0n 0.7000 122249.9n 0.7000 122250.0n 0.3000 122499.9n 0.3000 122500.0n 0.3000 122749.9n 0.3000 122750.0n 0.3000 122999.9n 0.3000 123000.0n 0.3000 123249.9n 0.3000 123250.0n 0.3000 123499.9n 0.3000 123500.0n 0.7000 123749.9n 0.7000 123750.0n 0.3000 123999.9n 0.3000 124000.0n 0.7000 124249.9n 0.7000 124250.0n 0.7000 124499.9n 0.7000 124500.0n 0.3000 124749.9n 0.3000 124750.0n 0.7000 124999.9n 0.7000 125000.0n 0.7000 125249.9n 0.7000 125250.0n 0.3000 125499.9n 0.3000 125500.0n 0.7000 125749.9n 0.7000 125750.0n 0.3000 125999.9n 0.3000 126000.0n 0.7000 126249.9n 0.7000 126250.0n 0.3000 126499.9n 0.3000 126500.0n 0.3000 126749.9n 0.3000 126750.0n 0.7000 126999.9n 0.7000 127000.0n 0.3000 127249.9n 0.3000 127250.0n 0.7000 127499.9n 0.7000 127500.0n 0.7000 127749.9n 0.7000 127750.0n 0.3000 127999.9n 0.3000 128000.0n 0.3000 128249.9n 0.3000 128250.0n 0.7000 128499.9n 0.7000 128500.0n 0.3000 128749.9n 0.3000 128750.0n 0.7000 128999.9n 0.7000 129000.0n 0.7000 129249.9n 0.7000 129250.0n 0.3000 129499.9n 0.3000 129500.0n 0.3000 129749.9n 0.3000 129750.0n 0.7000 129999.9n 0.7000 130000.0n 0.7000 130249.9n 0.7000 130250.0n 0.7000 130499.9n 0.7000 130500.0n 0.7000 130749.9n 0.7000 130750.0n 0.7000 130999.9n 0.7000 131000.0n 0.7000 131249.9n 0.7000 131250.0n 0.7000 131499.9n 0.7000 131500.0n 0.3000 131749.9n 0.3000 131750.0n 0.3000 131999.9n 0.3000 132000.0n 0.3000 132249.9n 0.3000 132250.0n 0.3000 132499.9n 0.3000 132500.0n 0.7000 132749.9n 0.7000 132750.0n 0.3000 132999.9n 0.3000 133000.0n 0.3000 133249.9n 0.3000 133250.0n 0.3000 133499.9n 0.3000 133500.0n 0.3000 133749.9n 0.3000 133750.0n 0.3000 133999.9n 0.3000 134000.0n 0.3000 134249.9n 0.3000 134250.0n 0.7000 134499.9n 0.7000 134500.0n 0.7000 134749.9n 0.7000 134750.0n 0.3000 134999.9n 0.3000 135000.0n 0.3000 135249.9n 0.3000 135250.0n 0.7000 135499.9n 0.7000 135500.0n 0.7000 135749.9n 0.7000 135750.0n 0.7000 135999.9n 0.7000 136000.0n 0.7000 136249.9n 0.7000 136250.0n 0.3000 136499.9n 0.3000 136500.0n 0.7000 136749.9n 0.7000 136750.0n 0.7000 136999.9n 0.7000 137000.0n 0.3000 137249.9n 0.3000 137250.0n 0.7000 137499.9n 0.7000 137500.0n 0.7000 137749.9n 0.7000 137750.0n 0.3000 137999.9n 0.3000 138000.0n 0.3000 138249.9n 0.3000 138250.0n 0.3000 138499.9n 0.3000 138500.0n 0.3000 138749.9n 0.3000 138750.0n 0.3000 138999.9n 0.3000 139000.0n 0.3000 139249.9n 0.3000 139250.0n 0.7000 139499.9n 0.7000 139500.0n 0.7000 139749.9n 0.7000 139750.0n 0.3000 139999.9n 0.3000 140000.0n 0.3000 140249.9n 0.3000 140250.0n 0.3000 140499.9n 0.3000 140500.0n 0.3000 140749.9n 0.3000 140750.0n 0.7000 140999.9n 0.7000 141000.0n 0.3000 141249.9n 0.3000 141250.0n 0.7000 141499.9n 0.7000 141500.0n 0.3000 141749.9n 0.3000 141750.0n 0.3000 141999.9n 0.3000 142000.0n 0.7000 142249.9n 0.7000 142250.0n 0.7000 142499.9n 0.7000 142500.0n 0.7000 142749.9n 0.7000 142750.0n 0.3000 142999.9n 0.3000 143000.0n 0.3000 143249.9n 0.3000 143250.0n 0.7000 143499.9n 0.7000 143500.0n 0.7000 143749.9n 0.7000 143750.0n 0.7000 143999.9n 0.7000 144000.0n 0.3000 144249.9n 0.3000 144250.0n 0.7000 144499.9n 0.7000 144500.0n 0.7000 144749.9n 0.7000 144750.0n 0.3000 144999.9n 0.3000 145000.0n 0.7000 145249.9n 0.7000 145250.0n 0.3000 145499.9n 0.3000 145500.0n 0.3000 145749.9n 0.3000 145750.0n 0.3000 145999.9n 0.3000 146000.0n 0.7000 146249.9n 0.7000 146250.0n 0.3000 146499.9n 0.3000 146500.0n 0.7000 146749.9n 0.7000 146750.0n 0.7000 146999.9n 0.7000 147000.0n 0.3000 147249.9n 0.3000 147250.0n 0.3000 147499.9n 0.3000 147500.0n 0.3000 147749.9n 0.3000 147750.0n 0.7000 147999.9n 0.7000 148000.0n 0.7000 148249.9n 0.7000 148250.0n 0.3000 148499.9n 0.3000 148500.0n 0.3000 148749.9n 0.3000 148750.0n 0.3000 148999.9n 0.3000 149000.0n 0.3000 149249.9n 0.3000 149250.0n 0.7000 149499.9n 0.7000 149500.0n 0.7000 149749.9n 0.7000 149750.0n 0.3000 149999.9n 0.3000 150000.0n 0.3000 150249.9n 0.3000 150250.0n 0.7000 150499.9n 0.7000 150500.0n 0.3000 150749.9n 0.3000 150750.0n 0.3000 150999.9n 0.3000 151000.0n 0.7000 151249.9n 0.7000 151250.0n 0.3000 151499.9n 0.3000 151500.0n 0.3000 151749.9n 0.3000 151750.0n 0.7000 151999.9n 0.7000 152000.0n 0.3000 152249.9n 0.3000 152250.0n 0.7000 152499.9n 0.7000 152500.0n 0.3000 152749.9n 0.3000 152750.0n 0.7000 152999.9n 0.7000 153000.0n 0.3000 153249.9n 0.3000 153250.0n 0.3000 153499.9n 0.3000 153500.0n 0.3000 153749.9n 0.3000 153750.0n 0.3000 153999.9n 0.3000 154000.0n 0.7000 154249.9n 0.7000 154250.0n 0.3000 154499.9n 0.3000 154500.0n 0.7000 154749.9n 0.7000 154750.0n 0.7000 154999.9n 0.7000 155000.0n 0.7000 155249.9n 0.7000 155250.0n 0.7000 155499.9n 0.7000 155500.0n 0.3000 155749.9n 0.3000 155750.0n 0.7000 155999.9n 0.7000 156000.0n 0.3000 156249.9n 0.3000 156250.0n 0.7000 156499.9n 0.7000 156500.0n 0.7000 156749.9n 0.7000 156750.0n 0.3000 156999.9n 0.3000 157000.0n 0.3000 157249.9n 0.3000 157250.0n 0.7000 157499.9n 0.7000 157500.0n 0.7000 157749.9n 0.7000 157750.0n 0.7000 157999.9n 0.7000 158000.0n 0.7000 158249.9n 0.7000 158250.0n 0.3000 158499.9n 0.3000 158500.0n 0.3000 158749.9n 0.3000 158750.0n 0.3000 158999.9n 0.3000 159000.0n 0.7000 159249.9n 0.7000 159250.0n 0.3000 159499.9n 0.3000 159500.0n 0.7000 159749.9n 0.7000 159750.0n 0.3000 159999.9n 0.3000 160000.0n 0.3000 160249.9n 0.3000 160250.0n 0.3000 160499.9n 0.3000 160500.0n 0.3000 160749.9n 0.3000 160750.0n 0.3000 160999.9n 0.3000 161000.0n 0.7000 161249.9n 0.7000 161250.0n 0.3000 161499.9n 0.3000 161500.0n 0.3000 161749.9n 0.3000 161750.0n 0.3000 161999.9n 0.3000 162000.0n 0.3000 162249.9n 0.3000 162250.0n 0.7000 162499.9n 0.7000 162500.0n 0.7000 162749.9n 0.7000 162750.0n 0.3000 162999.9n 0.3000 163000.0n 0.3000 163249.9n 0.3000 163250.0n 0.7000 163499.9n 0.7000 163500.0n 0.7000 163749.9n 0.7000 163750.0n 0.7000 163999.9n 0.7000 164000.0n 0.3000 164249.9n 0.3000 164250.0n 0.7000 164499.9n 0.7000 164500.0n 0.7000 164749.9n 0.7000 164750.0n 0.7000 164999.9n 0.7000 165000.0n 0.7000 165249.9n 0.7000 165250.0n 0.7000 165499.9n 0.7000 165500.0n 0.3000 165749.9n 0.3000 165750.0n 0.7000 165999.9n 0.7000 166000.0n 0.7000 166249.9n 0.7000 166250.0n 0.7000 166499.9n 0.7000 166500.0n 0.7000 166749.9n 0.7000 166750.0n 0.7000 166999.9n 0.7000 167000.0n 0.3000 167249.9n 0.3000 167250.0n 0.7000 167499.9n 0.7000 167500.0n 0.3000 167749.9n 0.3000 167750.0n 0.7000 167999.9n 0.7000 168000.0n 0.3000 168249.9n 0.3000 168250.0n 0.3000 168499.9n 0.3000 168500.0n 0.3000 168749.9n 0.3000 168750.0n 0.3000 168999.9n 0.3000 169000.0n 0.7000 169249.9n 0.7000 169250.0n 0.3000 169499.9n 0.3000 169500.0n 0.7000 169749.9n 0.7000 169750.0n 0.7000 169999.9n 0.7000 170000.0n 0.7000 170249.9n 0.7000 170250.0n 0.3000 170499.9n 0.3000 170500.0n 0.3000 170749.9n 0.3000 170750.0n 0.7000 170999.9n 0.7000 171000.0n 0.3000 171249.9n 0.3000 171250.0n 0.3000 171499.9n 0.3000 171500.0n 0.3000 171749.9n 0.3000 171750.0n 0.3000 171999.9n 0.3000 172000.0n 0.7000 172249.9n 0.7000 172250.0n 0.7000 172499.9n 0.7000 172500.0n 0.7000 172749.9n 0.7000 172750.0n 0.3000 172999.9n 0.3000 173000.0n 0.3000 173249.9n 0.3000 173250.0n 0.3000 173499.9n 0.3000 173500.0n 0.3000 173749.9n 0.3000 173750.0n 0.3000 173999.9n 0.3000 174000.0n 0.7000 174249.9n 0.7000 174250.0n 0.3000 174499.9n 0.3000 174500.0n 0.3000 174749.9n 0.3000 174750.0n 0.3000 174999.9n 0.3000 175000.0n 0.7000 175249.9n 0.7000 175250.0n 0.7000 175499.9n 0.7000 175500.0n 0.3000 175749.9n 0.3000 175750.0n 0.3000 175999.9n 0.3000 176000.0n 0.3000 176249.9n 0.3000 176250.0n 0.7000 176499.9n 0.7000 176500.0n 0.3000 176749.9n 0.3000 176750.0n 0.7000 176999.9n 0.7000 177000.0n 0.3000 177249.9n 0.3000 177250.0n 0.7000 177499.9n 0.7000 177500.0n 0.3000 177749.9n 0.3000 177750.0n 0.7000 177999.9n 0.7000 178000.0n 0.7000 178249.9n 0.7000 178250.0n 0.7000 178499.9n 0.7000 178500.0n 0.7000 178749.9n 0.7000 178750.0n 0.3000 178999.9n 0.3000 179000.0n 0.3000 179249.9n 0.3000 179250.0n 0.3000 179499.9n 0.3000 179500.0n 0.3000 179749.9n 0.3000 179750.0n 0.7000 179999.9n 0.7000 180000.0n 0.5000 180249.9n 0.5000 180250.0n 0.5000 180499.9n 0.5000 180500.0n 0.5000 180749.9n 0.5000 180750.0n 0.5000 180999.9n 0.5000 181000.0n 0.5000 181249.9n 0.5000 181250.0n 0.5000 181499.9n 0.5000 181500.0n 0.5000 181749.9n 0.5000 181750.0n 0.5000 181999.9n 0.5000 182000.0n 0.5000 182249.9n 0.5000 182250.0n 0.5000 182499.9n 0.5000 182500.0n 0.5000 182749.9n 0.5000 182750.0n 0.5000 182999.9n 0.5000 183000.0n 0.5000 183249.9n 0.5000 183250.0n 0.5000 183499.9n 0.5000 183500.0n 0.5000 183749.9n 0.5000 183750.0n 0.5000 183999.9n 0.5000 184000.0n 0.5000 184249.9n 0.5000 184250.0n 0.5000 184499.9n 0.5000 184500.0n 0.5000 184749.9n 0.5000 184750.0n 0.5000 184999.9n 0.5000 185000.0n 0.5000 185249.9n 0.5000 185250.0n 0.5000 185499.9n 0.5000 185500.0n 0.5000 185749.9n 0.5000 185750.0n 0.5000 185999.9n 0.5000 186000.0n 0.5000 186249.9n 0.5000 186250.0n 0.5000 186499.9n 0.5000 186500.0n 0.5000 186749.9n 0.5000 186750.0n 0.5000 186999.9n 0.5000 187000.0n 0.5000 187249.9n 0.5000 187250.0n 0.5000 187499.9n 0.5000 187500.0n 0.5000 187749.9n 0.5000 187750.0n 0.5000 187999.9n 0.5000 188000.0n 0.5000 188249.9n 0.5000 188250.0n 0.5000 188499.9n 0.5000 188500.0n 0.5000 188749.9n 0.5000 188750.0n 0.5000 188999.9n 0.5000 189000.0n 0.5000 189249.9n 0.5000 189250.0n 0.5000 189499.9n 0.5000 189500.0n 0.5000 189749.9n 0.5000 189750.0n 0.5000 189999.9n 0.5000 190000.0n 0.5000 190249.9n 0.5000 190250.0n 0.5000 190499.9n 0.5000 190500.0n 0.5000 190749.9n 0.5000 190750.0n 0.5000 190999.9n 0.5000 191000.0n 0.5000 191249.9n 0.5000 191250.0n 0.5000 191499.9n 0.5000 191500.0n 0.5000 191749.9n 0.5000 191750.0n 0.5000 191999.9n 0.5000 192000.0n 0.5000 192249.9n 0.5000 192250.0n 0.5000 192499.9n 0.5000 192500.0n 0.5000 192749.9n 0.5000 192750.0n 0.5000 192999.9n 0.5000 193000.0n 0.5000 193249.9n 0.5000 193250.0n 0.5000 193499.9n 0.5000 193500.0n 0.5000 193749.9n 0.5000 193750.0n 0.5000 193999.9n 0.5000 194000.0n 0.5000 194249.9n 0.5000 194250.0n 0.5000 194499.9n 0.5000 194500.0n 0.5000 194749.9n 0.5000 194750.0n 0.5000 194999.9n 0.5000 195000.0n 0.5000 195249.9n 0.5000 195250.0n 0.5000 195499.9n 0.5000 195500.0n 0.5000 195749.9n 0.5000 195750.0n 0.5000 195999.9n 0.5000 196000.0n 0.5000 196249.9n 0.5000 196250.0n 0.5000 196499.9n 0.5000 196500.0n 0.5000 196749.9n 0.5000 196750.0n 0.5000 196999.9n 0.5000 197000.0n 0.5000 197249.9n 0.5000 197250.0n 0.5000 197499.9n 0.5000 197500.0n 0.5000 197749.9n 0.5000 197750.0n 0.5000 197999.9n 0.5000 198000.0n 0.5000 198249.9n 0.5000 198250.0n 0.5000 198499.9n 0.5000 198500.0n 0.5000 198749.9n 0.5000 198750.0n 0.5000 198999.9n 0.5000 199000.0n 0.5000 199249.9n 0.5000 199250.0n 0.5000 199499.9n 0.5000 199500.0n 0.5000 199749.9n 0.5000 199750.0n 0.5000 199999.9n 0.5000 200000.0n 0.5000 200249.9n 0.5000 200250.0n 0.5000 200499.9n 0.5000 200500.0n 0.5000 200749.9n 0.5000 200750.0n 0.5000 200999.9n 0.5000 201000.0n 0.5000 201249.9n 0.5000 201250.0n 0.5000 201499.9n 0.5000 201500.0n 0.5000 201749.9n 0.5000 201750.0n 0.5000 201999.9n 0.5000 202000.0n 0.5000 202249.9n 0.5000 202250.0n 0.5000 202499.9n 0.5000 202500.0n 0.5000 202749.9n 0.5000 202750.0n 0.5000 202999.9n 0.5000 203000.0n 0.5000 203249.9n 0.5000 203250.0n 0.5000 203499.9n 0.5000 203500.0n 0.5000 203749.9n 0.5000 203750.0n 0.5000 203999.9n 0.5000 204000.0n 0.5000 204249.9n 0.5000 204250.0n 0.5000 204499.9n 0.5000 204500.0n 0.5000 204749.9n 0.5000 204750.0n 0.5000 204999.9n 0.5000 205000.0n 0.5000 205249.9n 0.5000 205250.0n 0.5000 205499.9n 0.5000 205500.0n 0.5000 205749.9n 0.5000 205750.0n 0.5000 205999.9n 0.5000 206000.0n 0.5000 206249.9n 0.5000 206250.0n 0.5000 206499.9n 0.5000 206500.0n 0.5000 206749.9n 0.5000 206750.0n 0.5000 206999.9n 0.5000 207000.0n 0.5000 207249.9n 0.5000 207250.0n 0.5000 207499.9n 0.5000 207500.0n 0.5000 207749.9n 0.5000 207750.0n 0.5000 207999.9n 0.5000 208000.0n 0.5000 208249.9n 0.5000 208250.0n 0.5000 208499.9n 0.5000 208500.0n 0.5000 208749.9n 0.5000 208750.0n 0.5000 208999.9n 0.5000 209000.0n 0.5000 209249.9n 0.5000 209250.0n 0.5000 209499.9n 0.5000 209500.0n 0.5000 209749.9n 0.5000 209750.0n 0.5000)
Cwp_wih_1_0 wp_wih_1_0 0 30p
Cwn_wih_1_0 wn_wih_1_0 0 30p
Rwp_wih_1_0 wp_wih_1_0 wcm 2g
Rwn_wih_1_0 wn_wih_1_0 wcm 2g
Cwp_wih_2_0 wp_wih_2_0 0 30p
Cwn_wih_2_0 wn_wih_2_0 0 30p
Rwp_wih_2_0 wp_wih_2_0 wcm 2g
Rwn_wih_2_0 wn_wih_2_0 wcm 2g
Cwp_wih_3_0 wp_wih_3_0 0 30p
Cwn_wih_3_0 wn_wih_3_0 0 30p
Rwp_wih_3_0 wp_wih_3_0 wcm 2g
Rwn_wih_3_0 wn_wih_3_0 wcm 2g
Cwp_who_0 wp_who_0 0 30p
Cwn_who_0 wn_who_0 0 30p
Rwp_who_0 wp_who_0 wcm 2g
Rwn_who_0 wn_who_0 wcm 2g
Cwp_wih_1_1 wp_wih_1_1 0 30p
Cwn_wih_1_1 wn_wih_1_1 0 30p
Rwp_wih_1_1 wp_wih_1_1 wcm 2g
Rwn_wih_1_1 wn_wih_1_1 wcm 2g
Cwp_wih_2_1 wp_wih_2_1 0 30p
Cwn_wih_2_1 wn_wih_2_1 0 30p
Rwp_wih_2_1 wp_wih_2_1 wcm 2g
Rwn_wih_2_1 wn_wih_2_1 wcm 2g
Cwp_wih_3_1 wp_wih_3_1 0 30p
Cwn_wih_3_1 wn_wih_3_1 0 30p
Rwp_wih_3_1 wp_wih_3_1 wcm 2g
Rwn_wih_3_1 wn_wih_3_1 wcm 2g
Cwp_who_1 wp_who_1 0 30p
Cwn_who_1 wn_who_1 0 30p
Rwp_who_1 wp_who_1 wcm 2g
Rwn_who_1 wn_who_1 wcm 2g
Cwp_wih_1_2 wp_wih_1_2 0 30p
Cwn_wih_1_2 wn_wih_1_2 0 30p
Rwp_wih_1_2 wp_wih_1_2 wcm 2g
Rwn_wih_1_2 wn_wih_1_2 wcm 2g
Cwp_wih_2_2 wp_wih_2_2 0 30p
Cwn_wih_2_2 wn_wih_2_2 0 30p
Rwp_wih_2_2 wp_wih_2_2 wcm 2g
Rwn_wih_2_2 wn_wih_2_2 wcm 2g
Cwp_wih_3_2 wp_wih_3_2 0 30p
Cwn_wih_3_2 wn_wih_3_2 0 30p
Rwp_wih_3_2 wp_wih_3_2 wcm 2g
Rwn_wih_3_2 wn_wih_3_2 wcm 2g
Cwp_who_2 wp_who_2 0 30p
Cwn_who_2 wn_who_2 0 30p
Rwp_who_2 wp_who_2 wcm 2g
Rwn_who_2 wn_who_2 wcm 2g
Cwp_wih_1_3 wp_wih_1_3 0 30p
Cwn_wih_1_3 wn_wih_1_3 0 30p
Rwp_wih_1_3 wp_wih_1_3 wcm 2g
Rwn_wih_1_3 wn_wih_1_3 wcm 2g
Cwp_wih_2_3 wp_wih_2_3 0 30p
Cwn_wih_2_3 wn_wih_2_3 0 30p
Rwp_wih_2_3 wp_wih_2_3 wcm 2g
Rwn_wih_2_3 wn_wih_2_3 wcm 2g
Cwp_wih_3_3 wp_wih_3_3 0 30p
Cwn_wih_3_3 wn_wih_3_3 0 30p
Rwp_wih_3_3 wp_wih_3_3 wcm 2g
Rwn_wih_3_3 wn_wih_3_3 wcm 2g
Cwp_who_3 wp_who_3 0 30p
Cwn_who_3 wn_who_3 0 30p
Rwp_who_3 wp_who_3 wcm 2g
Rwn_who_3 wn_who_3 wcm 2g
Cwp_wih_1_4 wp_wih_1_4 0 30p
Cwn_wih_1_4 wn_wih_1_4 0 30p
Rwp_wih_1_4 wp_wih_1_4 wcm 2g
Rwn_wih_1_4 wn_wih_1_4 wcm 2g
Cwp_wih_2_4 wp_wih_2_4 0 30p
Cwn_wih_2_4 wn_wih_2_4 0 30p
Rwp_wih_2_4 wp_wih_2_4 wcm 2g
Rwn_wih_2_4 wn_wih_2_4 wcm 2g
Cwp_wih_3_4 wp_wih_3_4 0 30p
Cwn_wih_3_4 wn_wih_3_4 0 30p
Rwp_wih_3_4 wp_wih_3_4 wcm 2g
Rwn_wih_3_4 wn_wih_3_4 wcm 2g
Cwp_who_4 wp_who_4 0 30p
Cwn_who_4 wn_who_4 0 30p
Rwp_who_4 wp_who_4 wcm 2g
Rwn_who_4 wn_who_4 wcm 2g
Cwp_wih_1_5 wp_wih_1_5 0 30p
Cwn_wih_1_5 wn_wih_1_5 0 30p
Rwp_wih_1_5 wp_wih_1_5 wcm 2g
Rwn_wih_1_5 wn_wih_1_5 wcm 2g
Cwp_wih_2_5 wp_wih_2_5 0 30p
Cwn_wih_2_5 wn_wih_2_5 0 30p
Rwp_wih_2_5 wp_wih_2_5 wcm 2g
Rwn_wih_2_5 wn_wih_2_5 wcm 2g
Cwp_wih_3_5 wp_wih_3_5 0 30p
Cwn_wih_3_5 wn_wih_3_5 0 30p
Rwp_wih_3_5 wp_wih_3_5 wcm 2g
Rwn_wih_3_5 wn_wih_3_5 wcm 2g
Cwp_who_5 wp_who_5 0 30p
Cwn_who_5 wn_who_5 0 30p
Rwp_who_5 wp_who_5 wcm 2g
Rwn_who_5 wn_who_5 wcm 2g
Cwp_wih_1_6 wp_wih_1_6 0 30p
Cwn_wih_1_6 wn_wih_1_6 0 30p
Rwp_wih_1_6 wp_wih_1_6 wcm 2g
Rwn_wih_1_6 wn_wih_1_6 wcm 2g
Cwp_wih_2_6 wp_wih_2_6 0 30p
Cwn_wih_2_6 wn_wih_2_6 0 30p
Rwp_wih_2_6 wp_wih_2_6 wcm 2g
Rwn_wih_2_6 wn_wih_2_6 wcm 2g
Cwp_wih_3_6 wp_wih_3_6 0 30p
Cwn_wih_3_6 wn_wih_3_6 0 30p
Rwp_wih_3_6 wp_wih_3_6 wcm 2g
Rwn_wih_3_6 wn_wih_3_6 wcm 2g
Cwp_who_6 wp_who_6 0 30p
Cwn_who_6 wn_who_6 0 30p
Rwp_who_6 wp_who_6 wcm 2g
Rwn_who_6 wn_who_6 wcm 2g
Cwp_wih_1_7 wp_wih_1_7 0 30p
Cwn_wih_1_7 wn_wih_1_7 0 30p
Rwp_wih_1_7 wp_wih_1_7 wcm 2g
Rwn_wih_1_7 wn_wih_1_7 wcm 2g
Cwp_wih_2_7 wp_wih_2_7 0 30p
Cwn_wih_2_7 wn_wih_2_7 0 30p
Rwp_wih_2_7 wp_wih_2_7 wcm 2g
Rwn_wih_2_7 wn_wih_2_7 wcm 2g
Cwp_wih_3_7 wp_wih_3_7 0 30p
Cwn_wih_3_7 wn_wih_3_7 0 30p
Rwp_wih_3_7 wp_wih_3_7 wcm 2g
Rwn_wih_3_7 wn_wih_3_7 wcm 2g
Cwp_who_7 wp_who_7 0 30p
Cwn_who_7 wn_who_7 0 30p
Rwp_who_7 wp_who_7 wcm 2g
Rwn_who_7 wn_who_7 wcm 2g
Cwp_wih_1_8 wp_wih_1_8 0 30p
Cwn_wih_1_8 wn_wih_1_8 0 30p
Rwp_wih_1_8 wp_wih_1_8 wcm 2g
Rwn_wih_1_8 wn_wih_1_8 wcm 2g
Cwp_wih_2_8 wp_wih_2_8 0 30p
Cwn_wih_2_8 wn_wih_2_8 0 30p
Rwp_wih_2_8 wp_wih_2_8 wcm 2g
Rwn_wih_2_8 wn_wih_2_8 wcm 2g
Cwp_wih_3_8 wp_wih_3_8 0 30p
Cwn_wih_3_8 wn_wih_3_8 0 30p
Rwp_wih_3_8 wp_wih_3_8 wcm 2g
Rwn_wih_3_8 wn_wih_3_8 wcm 2g
Cwp_who_8 wp_who_8 0 30p
Cwn_who_8 wn_who_8 0 30p
Rwp_who_8 wp_who_8 wcm 2g
Rwn_who_8 wn_who_8 wcm 2g
Cwp_wih_1_9 wp_wih_1_9 0 30p
Cwn_wih_1_9 wn_wih_1_9 0 30p
Rwp_wih_1_9 wp_wih_1_9 wcm 2g
Rwn_wih_1_9 wn_wih_1_9 wcm 2g
Cwp_wih_2_9 wp_wih_2_9 0 30p
Cwn_wih_2_9 wn_wih_2_9 0 30p
Rwp_wih_2_9 wp_wih_2_9 wcm 2g
Rwn_wih_2_9 wn_wih_2_9 wcm 2g
Cwp_wih_3_9 wp_wih_3_9 0 30p
Cwn_wih_3_9 wn_wih_3_9 0 30p
Rwp_wih_3_9 wp_wih_3_9 wcm 2g
Rwn_wih_3_9 wn_wih_3_9 wcm 2g
Cwp_who_9 wp_who_9 0 30p
Cwn_who_9 wn_who_9 0 30p
Rwp_who_9 wp_who_9 wcm 2g
Rwn_who_9 wn_who_9 wcm 2g
Cwp_wih_1_10 wp_wih_1_10 0 30p
Cwn_wih_1_10 wn_wih_1_10 0 30p
Rwp_wih_1_10 wp_wih_1_10 wcm 2g
Rwn_wih_1_10 wn_wih_1_10 wcm 2g
Cwp_wih_2_10 wp_wih_2_10 0 30p
Cwn_wih_2_10 wn_wih_2_10 0 30p
Rwp_wih_2_10 wp_wih_2_10 wcm 2g
Rwn_wih_2_10 wn_wih_2_10 wcm 2g
Cwp_wih_3_10 wp_wih_3_10 0 30p
Cwn_wih_3_10 wn_wih_3_10 0 30p
Rwp_wih_3_10 wp_wih_3_10 wcm 2g
Rwn_wih_3_10 wn_wih_3_10 wcm 2g
Cwp_who_10 wp_who_10 0 30p
Cwn_who_10 wn_who_10 0 30p
Rwp_who_10 wp_who_10 wcm 2g
Rwn_who_10 wn_who_10 wcm 2g
Cwp_wih_1_11 wp_wih_1_11 0 30p
Cwn_wih_1_11 wn_wih_1_11 0 30p
Rwp_wih_1_11 wp_wih_1_11 wcm 2g
Rwn_wih_1_11 wn_wih_1_11 wcm 2g
Cwp_wih_2_11 wp_wih_2_11 0 30p
Cwn_wih_2_11 wn_wih_2_11 0 30p
Rwp_wih_2_11 wp_wih_2_11 wcm 2g
Rwn_wih_2_11 wn_wih_2_11 wcm 2g
Cwp_wih_3_11 wp_wih_3_11 0 30p
Cwn_wih_3_11 wn_wih_3_11 0 30p
Rwp_wih_3_11 wp_wih_3_11 wcm 2g
Rwn_wih_3_11 wn_wih_3_11 wcm 2g
Cwp_who_11 wp_who_11 0 30p
Cwn_who_11 wn_who_11 0 30p
Rwp_who_11 wp_who_11 wcm 2g
Rwn_who_11 wn_who_11 wcm 2g
Cwp_wih_1_12 wp_wih_1_12 0 30p
Cwn_wih_1_12 wn_wih_1_12 0 30p
Rwp_wih_1_12 wp_wih_1_12 wcm 2g
Rwn_wih_1_12 wn_wih_1_12 wcm 2g
Cwp_wih_2_12 wp_wih_2_12 0 30p
Cwn_wih_2_12 wn_wih_2_12 0 30p
Rwp_wih_2_12 wp_wih_2_12 wcm 2g
Rwn_wih_2_12 wn_wih_2_12 wcm 2g
Cwp_wih_3_12 wp_wih_3_12 0 30p
Cwn_wih_3_12 wn_wih_3_12 0 30p
Rwp_wih_3_12 wp_wih_3_12 wcm 2g
Rwn_wih_3_12 wn_wih_3_12 wcm 2g
Cwp_who_12 wp_who_12 0 30p
Cwn_who_12 wn_who_12 0 30p
Rwp_who_12 wp_who_12 wcm 2g
Rwn_who_12 wn_who_12 wcm 2g
Cwp_wih_1_13 wp_wih_1_13 0 30p
Cwn_wih_1_13 wn_wih_1_13 0 30p
Rwp_wih_1_13 wp_wih_1_13 wcm 2g
Rwn_wih_1_13 wn_wih_1_13 wcm 2g
Cwp_wih_2_13 wp_wih_2_13 0 30p
Cwn_wih_2_13 wn_wih_2_13 0 30p
Rwp_wih_2_13 wp_wih_2_13 wcm 2g
Rwn_wih_2_13 wn_wih_2_13 wcm 2g
Cwp_wih_3_13 wp_wih_3_13 0 30p
Cwn_wih_3_13 wn_wih_3_13 0 30p
Rwp_wih_3_13 wp_wih_3_13 wcm 2g
Rwn_wih_3_13 wn_wih_3_13 wcm 2g
Cwp_who_13 wp_who_13 0 30p
Cwn_who_13 wn_who_13 0 30p
Rwp_who_13 wp_who_13 wcm 2g
Rwn_who_13 wn_who_13 wcm 2g
Cwp_wih_1_14 wp_wih_1_14 0 30p
Cwn_wih_1_14 wn_wih_1_14 0 30p
Rwp_wih_1_14 wp_wih_1_14 wcm 2g
Rwn_wih_1_14 wn_wih_1_14 wcm 2g
Cwp_wih_2_14 wp_wih_2_14 0 30p
Cwn_wih_2_14 wn_wih_2_14 0 30p
Rwp_wih_2_14 wp_wih_2_14 wcm 2g
Rwn_wih_2_14 wn_wih_2_14 wcm 2g
Cwp_wih_3_14 wp_wih_3_14 0 30p
Cwn_wih_3_14 wn_wih_3_14 0 30p
Rwp_wih_3_14 wp_wih_3_14 wcm 2g
Rwn_wih_3_14 wn_wih_3_14 wcm 2g
Cwp_who_14 wp_who_14 0 30p
Cwn_who_14 wn_who_14 0 30p
Rwp_who_14 wp_who_14 wcm 2g
Rwn_who_14 wn_who_14 wcm 2g
Cwp_wih_1_15 wp_wih_1_15 0 30p
Cwn_wih_1_15 wn_wih_1_15 0 30p
Rwp_wih_1_15 wp_wih_1_15 wcm 2g
Rwn_wih_1_15 wn_wih_1_15 wcm 2g
Cwp_wih_2_15 wp_wih_2_15 0 30p
Cwn_wih_2_15 wn_wih_2_15 0 30p
Rwp_wih_2_15 wp_wih_2_15 wcm 2g
Rwn_wih_2_15 wn_wih_2_15 wcm 2g
Cwp_wih_3_15 wp_wih_3_15 0 30p
Cwn_wih_3_15 wn_wih_3_15 0 30p
Rwp_wih_3_15 wp_wih_3_15 wcm 2g
Rwn_wih_3_15 wn_wih_3_15 wcm 2g
Cwp_who_15 wp_who_15 0 30p
Cwn_who_15 wn_who_15 0 30p
Rwp_who_15 wp_who_15 wcm 2g
Rwn_who_15 wn_who_15 wcm 2g
Cwp_wih_1_16 wp_wih_1_16 0 30p
Cwn_wih_1_16 wn_wih_1_16 0 30p
Rwp_wih_1_16 wp_wih_1_16 wcm 2g
Rwn_wih_1_16 wn_wih_1_16 wcm 2g
Cwp_wih_2_16 wp_wih_2_16 0 30p
Cwn_wih_2_16 wn_wih_2_16 0 30p
Rwp_wih_2_16 wp_wih_2_16 wcm 2g
Rwn_wih_2_16 wn_wih_2_16 wcm 2g
Cwp_wih_3_16 wp_wih_3_16 0 30p
Cwn_wih_3_16 wn_wih_3_16 0 30p
Rwp_wih_3_16 wp_wih_3_16 wcm 2g
Rwn_wih_3_16 wn_wih_3_16 wcm 2g
Cwp_who_16 wp_who_16 0 30p
Cwn_who_16 wn_who_16 0 30p
Rwp_who_16 wp_who_16 wcm 2g
Rwn_who_16 wn_who_16 wcm 2g
Cwp_wih_1_17 wp_wih_1_17 0 30p
Cwn_wih_1_17 wn_wih_1_17 0 30p
Rwp_wih_1_17 wp_wih_1_17 wcm 2g
Rwn_wih_1_17 wn_wih_1_17 wcm 2g
Cwp_wih_2_17 wp_wih_2_17 0 30p
Cwn_wih_2_17 wn_wih_2_17 0 30p
Rwp_wih_2_17 wp_wih_2_17 wcm 2g
Rwn_wih_2_17 wn_wih_2_17 wcm 2g
Cwp_wih_3_17 wp_wih_3_17 0 30p
Cwn_wih_3_17 wn_wih_3_17 0 30p
Rwp_wih_3_17 wp_wih_3_17 wcm 2g
Rwn_wih_3_17 wn_wih_3_17 wcm 2g
Cwp_who_17 wp_who_17 0 30p
Cwn_who_17 wn_who_17 0 30p
Rwp_who_17 wp_who_17 wcm 2g
Rwn_who_17 wn_who_17 wcm 2g
Cwp_wih_1_18 wp_wih_1_18 0 30p
Cwn_wih_1_18 wn_wih_1_18 0 30p
Rwp_wih_1_18 wp_wih_1_18 wcm 2g
Rwn_wih_1_18 wn_wih_1_18 wcm 2g
Cwp_wih_2_18 wp_wih_2_18 0 30p
Cwn_wih_2_18 wn_wih_2_18 0 30p
Rwp_wih_2_18 wp_wih_2_18 wcm 2g
Rwn_wih_2_18 wn_wih_2_18 wcm 2g
Cwp_wih_3_18 wp_wih_3_18 0 30p
Cwn_wih_3_18 wn_wih_3_18 0 30p
Rwp_wih_3_18 wp_wih_3_18 wcm 2g
Rwn_wih_3_18 wn_wih_3_18 wcm 2g
Cwp_who_18 wp_who_18 0 30p
Cwn_who_18 wn_who_18 0 30p
Rwp_who_18 wp_who_18 wcm 2g
Rwn_who_18 wn_who_18 wcm 2g
Cwp_wih_1_19 wp_wih_1_19 0 30p
Cwn_wih_1_19 wn_wih_1_19 0 30p
Rwp_wih_1_19 wp_wih_1_19 wcm 2g
Rwn_wih_1_19 wn_wih_1_19 wcm 2g
Cwp_wih_2_19 wp_wih_2_19 0 30p
Cwn_wih_2_19 wn_wih_2_19 0 30p
Rwp_wih_2_19 wp_wih_2_19 wcm 2g
Rwn_wih_2_19 wn_wih_2_19 wcm 2g
Cwp_wih_3_19 wp_wih_3_19 0 30p
Cwn_wih_3_19 wn_wih_3_19 0 30p
Rwp_wih_3_19 wp_wih_3_19 wcm 2g
Rwn_wih_3_19 wn_wih_3_19 wcm 2g
Cwp_who_19 wp_who_19 0 30p
Cwn_who_19 wn_who_19 0 30p
Rwp_who_19 wp_who_19 wcm 2g
Rwn_who_19 wn_who_19 wcm 2g
Cwp_wih_1_20 wp_wih_1_20 0 30p
Cwn_wih_1_20 wn_wih_1_20 0 30p
Rwp_wih_1_20 wp_wih_1_20 wcm 2g
Rwn_wih_1_20 wn_wih_1_20 wcm 2g
Cwp_wih_2_20 wp_wih_2_20 0 30p
Cwn_wih_2_20 wn_wih_2_20 0 30p
Rwp_wih_2_20 wp_wih_2_20 wcm 2g
Rwn_wih_2_20 wn_wih_2_20 wcm 2g
Cwp_wih_3_20 wp_wih_3_20 0 30p
Cwn_wih_3_20 wn_wih_3_20 0 30p
Rwp_wih_3_20 wp_wih_3_20 wcm 2g
Rwn_wih_3_20 wn_wih_3_20 wcm 2g
Cwp_who_20 wp_who_20 0 30p
Cwn_who_20 wn_who_20 0 30p
Rwp_who_20 wp_who_20 wcm 2g
Rwn_who_20 wn_who_20 wcm 2g
Cwp_wih_1_21 wp_wih_1_21 0 30p
Cwn_wih_1_21 wn_wih_1_21 0 30p
Rwp_wih_1_21 wp_wih_1_21 wcm 2g
Rwn_wih_1_21 wn_wih_1_21 wcm 2g
Cwp_wih_2_21 wp_wih_2_21 0 30p
Cwn_wih_2_21 wn_wih_2_21 0 30p
Rwp_wih_2_21 wp_wih_2_21 wcm 2g
Rwn_wih_2_21 wn_wih_2_21 wcm 2g
Cwp_wih_3_21 wp_wih_3_21 0 30p
Cwn_wih_3_21 wn_wih_3_21 0 30p
Rwp_wih_3_21 wp_wih_3_21 wcm 2g
Rwn_wih_3_21 wn_wih_3_21 wcm 2g
Cwp_who_21 wp_who_21 0 30p
Cwn_who_21 wn_who_21 0 30p
Rwp_who_21 wp_who_21 wcm 2g
Rwn_who_21 wn_who_21 wcm 2g
Cwp_wih_1_22 wp_wih_1_22 0 30p
Cwn_wih_1_22 wn_wih_1_22 0 30p
Rwp_wih_1_22 wp_wih_1_22 wcm 2g
Rwn_wih_1_22 wn_wih_1_22 wcm 2g
Cwp_wih_2_22 wp_wih_2_22 0 30p
Cwn_wih_2_22 wn_wih_2_22 0 30p
Rwp_wih_2_22 wp_wih_2_22 wcm 2g
Rwn_wih_2_22 wn_wih_2_22 wcm 2g
Cwp_wih_3_22 wp_wih_3_22 0 30p
Cwn_wih_3_22 wn_wih_3_22 0 30p
Rwp_wih_3_22 wp_wih_3_22 wcm 2g
Rwn_wih_3_22 wn_wih_3_22 wcm 2g
Cwp_who_22 wp_who_22 0 30p
Cwn_who_22 wn_who_22 0 30p
Rwp_who_22 wp_who_22 wcm 2g
Rwn_who_22 wn_who_22 wcm 2g
Cwp_wih_1_23 wp_wih_1_23 0 30p
Cwn_wih_1_23 wn_wih_1_23 0 30p
Rwp_wih_1_23 wp_wih_1_23 wcm 2g
Rwn_wih_1_23 wn_wih_1_23 wcm 2g
Cwp_wih_2_23 wp_wih_2_23 0 30p
Cwn_wih_2_23 wn_wih_2_23 0 30p
Rwp_wih_2_23 wp_wih_2_23 wcm 2g
Rwn_wih_2_23 wn_wih_2_23 wcm 2g
Cwp_wih_3_23 wp_wih_3_23 0 30p
Cwn_wih_3_23 wn_wih_3_23 0 30p
Rwp_wih_3_23 wp_wih_3_23 wcm 2g
Rwn_wih_3_23 wn_wih_3_23 wcm 2g
Cwp_who_23 wp_who_23 0 30p
Cwn_who_23 wn_who_23 0 30p
Rwp_who_23 wp_who_23 wcm 2g
Rwn_who_23 wn_who_23 wcm 2g
Cwp_wih_1_24 wp_wih_1_24 0 30p
Cwn_wih_1_24 wn_wih_1_24 0 30p
Rwp_wih_1_24 wp_wih_1_24 wcm 2g
Rwn_wih_1_24 wn_wih_1_24 wcm 2g
Cwp_wih_2_24 wp_wih_2_24 0 30p
Cwn_wih_2_24 wn_wih_2_24 0 30p
Rwp_wih_2_24 wp_wih_2_24 wcm 2g
Rwn_wih_2_24 wn_wih_2_24 wcm 2g
Cwp_wih_3_24 wp_wih_3_24 0 30p
Cwn_wih_3_24 wn_wih_3_24 0 30p
Rwp_wih_3_24 wp_wih_3_24 wcm 2g
Rwn_wih_3_24 wn_wih_3_24 wcm 2g
Cwp_who_24 wp_who_24 0 30p
Cwn_who_24 wn_who_24 0 30p
Rwp_who_24 wp_who_24 wcm 2g
Rwn_who_24 wn_who_24 wcm 2g
Cwp_wih_1_25 wp_wih_1_25 0 30p
Cwn_wih_1_25 wn_wih_1_25 0 30p
Rwp_wih_1_25 wp_wih_1_25 wcm 2g
Rwn_wih_1_25 wn_wih_1_25 wcm 2g
Cwp_wih_2_25 wp_wih_2_25 0 30p
Cwn_wih_2_25 wn_wih_2_25 0 30p
Rwp_wih_2_25 wp_wih_2_25 wcm 2g
Rwn_wih_2_25 wn_wih_2_25 wcm 2g
Cwp_wih_3_25 wp_wih_3_25 0 30p
Cwn_wih_3_25 wn_wih_3_25 0 30p
Rwp_wih_3_25 wp_wih_3_25 wcm 2g
Rwn_wih_3_25 wn_wih_3_25 wcm 2g
Cwp_who_25 wp_who_25 0 30p
Cwn_who_25 wn_who_25 0 30p
Rwp_who_25 wp_who_25 wcm 2g
Rwn_who_25 wn_who_25 wcm 2g
Cwp_wih_1_26 wp_wih_1_26 0 30p
Cwn_wih_1_26 wn_wih_1_26 0 30p
Rwp_wih_1_26 wp_wih_1_26 wcm 2g
Rwn_wih_1_26 wn_wih_1_26 wcm 2g
Cwp_wih_2_26 wp_wih_2_26 0 30p
Cwn_wih_2_26 wn_wih_2_26 0 30p
Rwp_wih_2_26 wp_wih_2_26 wcm 2g
Rwn_wih_2_26 wn_wih_2_26 wcm 2g
Cwp_wih_3_26 wp_wih_3_26 0 30p
Cwn_wih_3_26 wn_wih_3_26 0 30p
Rwp_wih_3_26 wp_wih_3_26 wcm 2g
Rwn_wih_3_26 wn_wih_3_26 wcm 2g
Cwp_who_26 wp_who_26 0 30p
Cwn_who_26 wn_who_26 0 30p
Rwp_who_26 wp_who_26 wcm 2g
Rwn_who_26 wn_who_26 wcm 2g
Cwp_wih_1_27 wp_wih_1_27 0 30p
Cwn_wih_1_27 wn_wih_1_27 0 30p
Rwp_wih_1_27 wp_wih_1_27 wcm 2g
Rwn_wih_1_27 wn_wih_1_27 wcm 2g
Cwp_wih_2_27 wp_wih_2_27 0 30p
Cwn_wih_2_27 wn_wih_2_27 0 30p
Rwp_wih_2_27 wp_wih_2_27 wcm 2g
Rwn_wih_2_27 wn_wih_2_27 wcm 2g
Cwp_wih_3_27 wp_wih_3_27 0 30p
Cwn_wih_3_27 wn_wih_3_27 0 30p
Rwp_wih_3_27 wp_wih_3_27 wcm 2g
Rwn_wih_3_27 wn_wih_3_27 wcm 2g
Cwp_who_27 wp_who_27 0 30p
Cwn_who_27 wn_who_27 0 30p
Rwp_who_27 wp_who_27 wcm 2g
Rwn_who_27 wn_who_27 wcm 2g
Cwp_wih_1_28 wp_wih_1_28 0 30p
Cwn_wih_1_28 wn_wih_1_28 0 30p
Rwp_wih_1_28 wp_wih_1_28 wcm 2g
Rwn_wih_1_28 wn_wih_1_28 wcm 2g
Cwp_wih_2_28 wp_wih_2_28 0 30p
Cwn_wih_2_28 wn_wih_2_28 0 30p
Rwp_wih_2_28 wp_wih_2_28 wcm 2g
Rwn_wih_2_28 wn_wih_2_28 wcm 2g
Cwp_wih_3_28 wp_wih_3_28 0 30p
Cwn_wih_3_28 wn_wih_3_28 0 30p
Rwp_wih_3_28 wp_wih_3_28 wcm 2g
Rwn_wih_3_28 wn_wih_3_28 wcm 2g
Cwp_who_28 wp_who_28 0 30p
Cwn_who_28 wn_who_28 0 30p
Rwp_who_28 wp_who_28 wcm 2g
Rwn_who_28 wn_who_28 wcm 2g
Cwp_wih_1_29 wp_wih_1_29 0 30p
Cwn_wih_1_29 wn_wih_1_29 0 30p
Rwp_wih_1_29 wp_wih_1_29 wcm 2g
Rwn_wih_1_29 wn_wih_1_29 wcm 2g
Cwp_wih_2_29 wp_wih_2_29 0 30p
Cwn_wih_2_29 wn_wih_2_29 0 30p
Rwp_wih_2_29 wp_wih_2_29 wcm 2g
Rwn_wih_2_29 wn_wih_2_29 wcm 2g
Cwp_wih_3_29 wp_wih_3_29 0 30p
Cwn_wih_3_29 wn_wih_3_29 0 30p
Rwp_wih_3_29 wp_wih_3_29 wcm 2g
Rwn_wih_3_29 wn_wih_3_29 wcm 2g
Cwp_who_29 wp_who_29 0 30p
Cwn_who_29 wn_who_29 0 30p
Rwp_who_29 wp_who_29 wcm 2g
Rwn_who_29 wn_who_29 wcm 2g
Cwp_wih_1_30 wp_wih_1_30 0 30p
Cwn_wih_1_30 wn_wih_1_30 0 30p
Rwp_wih_1_30 wp_wih_1_30 wcm 2g
Rwn_wih_1_30 wn_wih_1_30 wcm 2g
Cwp_wih_2_30 wp_wih_2_30 0 30p
Cwn_wih_2_30 wn_wih_2_30 0 30p
Rwp_wih_2_30 wp_wih_2_30 wcm 2g
Rwn_wih_2_30 wn_wih_2_30 wcm 2g
Cwp_wih_3_30 wp_wih_3_30 0 30p
Cwn_wih_3_30 wn_wih_3_30 0 30p
Rwp_wih_3_30 wp_wih_3_30 wcm 2g
Rwn_wih_3_30 wn_wih_3_30 wcm 2g
Cwp_who_30 wp_who_30 0 30p
Cwn_who_30 wn_who_30 0 30p
Rwp_who_30 wp_who_30 wcm 2g
Rwn_who_30 wn_who_30 wcm 2g
Cwp_wih_1_31 wp_wih_1_31 0 30p
Cwn_wih_1_31 wn_wih_1_31 0 30p
Rwp_wih_1_31 wp_wih_1_31 wcm 2g
Rwn_wih_1_31 wn_wih_1_31 wcm 2g
Cwp_wih_2_31 wp_wih_2_31 0 30p
Cwn_wih_2_31 wn_wih_2_31 0 30p
Rwp_wih_2_31 wp_wih_2_31 wcm 2g
Rwn_wih_2_31 wn_wih_2_31 wcm 2g
Cwp_wih_3_31 wp_wih_3_31 0 30p
Cwn_wih_3_31 wn_wih_3_31 0 30p
Rwp_wih_3_31 wp_wih_3_31 wcm 2g
Rwn_wih_3_31 wn_wih_3_31 wcm 2g
Cwp_who_31 wp_who_31 0 30p
Cwn_who_31 wn_who_31 0 30p
Rwp_who_31 wp_who_31 wcm 2g
Rwn_who_31 wn_who_31 wcm 2g
Cwp_wih_1_32 wp_wih_1_32 0 30p
Cwn_wih_1_32 wn_wih_1_32 0 30p
Rwp_wih_1_32 wp_wih_1_32 wcm 2g
Rwn_wih_1_32 wn_wih_1_32 wcm 2g
Cwp_wih_2_32 wp_wih_2_32 0 30p
Cwn_wih_2_32 wn_wih_2_32 0 30p
Rwp_wih_2_32 wp_wih_2_32 wcm 2g
Rwn_wih_2_32 wn_wih_2_32 wcm 2g
Cwp_wih_3_32 wp_wih_3_32 0 30p
Cwn_wih_3_32 wn_wih_3_32 0 30p
Rwp_wih_3_32 wp_wih_3_32 wcm 2g
Rwn_wih_3_32 wn_wih_3_32 wcm 2g
Cwp_who_32 wp_who_32 0 30p
Cwn_who_32 wn_who_32 0 30p
Rwp_who_32 wp_who_32 wcm 2g
Rwn_who_32 wn_who_32 wcm 2g
Cwp_wih_1_33 wp_wih_1_33 0 30p
Cwn_wih_1_33 wn_wih_1_33 0 30p
Rwp_wih_1_33 wp_wih_1_33 wcm 2g
Rwn_wih_1_33 wn_wih_1_33 wcm 2g
Cwp_wih_2_33 wp_wih_2_33 0 30p
Cwn_wih_2_33 wn_wih_2_33 0 30p
Rwp_wih_2_33 wp_wih_2_33 wcm 2g
Rwn_wih_2_33 wn_wih_2_33 wcm 2g
Cwp_wih_3_33 wp_wih_3_33 0 30p
Cwn_wih_3_33 wn_wih_3_33 0 30p
Rwp_wih_3_33 wp_wih_3_33 wcm 2g
Rwn_wih_3_33 wn_wih_3_33 wcm 2g
Cwp_who_33 wp_who_33 0 30p
Cwn_who_33 wn_who_33 0 30p
Rwp_who_33 wp_who_33 wcm 2g
Rwn_who_33 wn_who_33 wcm 2g
Cwp_wih_1_34 wp_wih_1_34 0 30p
Cwn_wih_1_34 wn_wih_1_34 0 30p
Rwp_wih_1_34 wp_wih_1_34 wcm 2g
Rwn_wih_1_34 wn_wih_1_34 wcm 2g
Cwp_wih_2_34 wp_wih_2_34 0 30p
Cwn_wih_2_34 wn_wih_2_34 0 30p
Rwp_wih_2_34 wp_wih_2_34 wcm 2g
Rwn_wih_2_34 wn_wih_2_34 wcm 2g
Cwp_wih_3_34 wp_wih_3_34 0 30p
Cwn_wih_3_34 wn_wih_3_34 0 30p
Rwp_wih_3_34 wp_wih_3_34 wcm 2g
Rwn_wih_3_34 wn_wih_3_34 wcm 2g
Cwp_who_34 wp_who_34 0 30p
Cwn_who_34 wn_who_34 0 30p
Rwp_who_34 wp_who_34 wcm 2g
Rwn_who_34 wn_who_34 wcm 2g
Cwp_wih_1_35 wp_wih_1_35 0 30p
Cwn_wih_1_35 wn_wih_1_35 0 30p
Rwp_wih_1_35 wp_wih_1_35 wcm 2g
Rwn_wih_1_35 wn_wih_1_35 wcm 2g
Cwp_wih_2_35 wp_wih_2_35 0 30p
Cwn_wih_2_35 wn_wih_2_35 0 30p
Rwp_wih_2_35 wp_wih_2_35 wcm 2g
Rwn_wih_2_35 wn_wih_2_35 wcm 2g
Cwp_wih_3_35 wp_wih_3_35 0 30p
Cwn_wih_3_35 wn_wih_3_35 0 30p
Rwp_wih_3_35 wp_wih_3_35 wcm 2g
Rwn_wih_3_35 wn_wih_3_35 wcm 2g
Cwp_who_35 wp_who_35 0 30p
Cwn_who_35 wn_who_35 0 30p
Rwp_who_35 wp_who_35 wcm 2g
Rwn_who_35 wn_who_35 wcm 2g
Cwp_wih_1_36 wp_wih_1_36 0 30p
Cwn_wih_1_36 wn_wih_1_36 0 30p
Rwp_wih_1_36 wp_wih_1_36 wcm 2g
Rwn_wih_1_36 wn_wih_1_36 wcm 2g
Cwp_wih_2_36 wp_wih_2_36 0 30p
Cwn_wih_2_36 wn_wih_2_36 0 30p
Rwp_wih_2_36 wp_wih_2_36 wcm 2g
Rwn_wih_2_36 wn_wih_2_36 wcm 2g
Cwp_wih_3_36 wp_wih_3_36 0 30p
Cwn_wih_3_36 wn_wih_3_36 0 30p
Rwp_wih_3_36 wp_wih_3_36 wcm 2g
Rwn_wih_3_36 wn_wih_3_36 wcm 2g
Cwp_who_36 wp_who_36 0 30p
Cwn_who_36 wn_who_36 0 30p
Rwp_who_36 wp_who_36 wcm 2g
Rwn_who_36 wn_who_36 wcm 2g
Cwp_wih_1_37 wp_wih_1_37 0 30p
Cwn_wih_1_37 wn_wih_1_37 0 30p
Rwp_wih_1_37 wp_wih_1_37 wcm 2g
Rwn_wih_1_37 wn_wih_1_37 wcm 2g
Cwp_wih_2_37 wp_wih_2_37 0 30p
Cwn_wih_2_37 wn_wih_2_37 0 30p
Rwp_wih_2_37 wp_wih_2_37 wcm 2g
Rwn_wih_2_37 wn_wih_2_37 wcm 2g
Cwp_wih_3_37 wp_wih_3_37 0 30p
Cwn_wih_3_37 wn_wih_3_37 0 30p
Rwp_wih_3_37 wp_wih_3_37 wcm 2g
Rwn_wih_3_37 wn_wih_3_37 wcm 2g
Cwp_who_37 wp_who_37 0 30p
Cwn_who_37 wn_who_37 0 30p
Rwp_who_37 wp_who_37 wcm 2g
Rwn_who_37 wn_who_37 wcm 2g
Cwp_wih_1_38 wp_wih_1_38 0 30p
Cwn_wih_1_38 wn_wih_1_38 0 30p
Rwp_wih_1_38 wp_wih_1_38 wcm 2g
Rwn_wih_1_38 wn_wih_1_38 wcm 2g
Cwp_wih_2_38 wp_wih_2_38 0 30p
Cwn_wih_2_38 wn_wih_2_38 0 30p
Rwp_wih_2_38 wp_wih_2_38 wcm 2g
Rwn_wih_2_38 wn_wih_2_38 wcm 2g
Cwp_wih_3_38 wp_wih_3_38 0 30p
Cwn_wih_3_38 wn_wih_3_38 0 30p
Rwp_wih_3_38 wp_wih_3_38 wcm 2g
Rwn_wih_3_38 wn_wih_3_38 wcm 2g
Cwp_who_38 wp_who_38 0 30p
Cwn_who_38 wn_who_38 0 30p
Rwp_who_38 wp_who_38 wcm 2g
Rwn_who_38 wn_who_38 wcm 2g
Cwp_wih_1_39 wp_wih_1_39 0 30p
Cwn_wih_1_39 wn_wih_1_39 0 30p
Rwp_wih_1_39 wp_wih_1_39 wcm 2g
Rwn_wih_1_39 wn_wih_1_39 wcm 2g
Cwp_wih_2_39 wp_wih_2_39 0 30p
Cwn_wih_2_39 wn_wih_2_39 0 30p
Rwp_wih_2_39 wp_wih_2_39 wcm 2g
Rwn_wih_2_39 wn_wih_2_39 wcm 2g
Cwp_wih_3_39 wp_wih_3_39 0 30p
Cwn_wih_3_39 wn_wih_3_39 0 30p
Rwp_wih_3_39 wp_wih_3_39 wcm 2g
Rwn_wih_3_39 wn_wih_3_39 wcm 2g
Cwp_who_39 wp_who_39 0 30p
Cwn_who_39 wn_who_39 0 30p
Rwp_who_39 wp_who_39 wcm 2g
Rwn_who_39 wn_who_39 wcm 2g
Xcm_mh0 mhp0 mhn0 vdd cmld
Xcm_xh0 xhp0 xhn0 vdd cmld
Rnd_mh0 mhp0 mhn0 20k
Rnd_xh0 xhp0 xhn0 20k
Cxhp0 xhp0 0 0.4p
Cxhn0 xhn0 0 0.4p
X_ihm_1_0 a_xp1 a_xn1 wp_wih_1_0 wn_wih_1_0 mhp0 mhn0 vdd vbsyn gsyn
X_ihx_1_0 a_xp1 a_xn1 wp_wih_1_0 wn_wih_1_0 xhp0 xhn0 vdd vbsyn gsyn
X_ihm_2_0 a_xp2 a_xn2 wp_wih_2_0 wn_wih_2_0 mhp0 mhn0 vdd vbsyn gsyn
X_ihx_2_0 a_xp2 a_xn2 wp_wih_2_0 wn_wih_2_0 xhp0 xhn0 vdd vbsyn gsyn
X_ihm_3_0 a_xp3 a_xn3 wp_wih_3_0 wn_wih_3_0 mhp0 mhn0 vdd vbsyn gsyn
X_ihx_3_0 a_xp3 a_xn3 wp_wih_3_0 wn_wih_3_0 xhp0 xhn0 vdd vbsyn gsyn
X_bk_0 eop eon wp_who_0 wn_who_0 xhp0 xhn0 vdd vbsyn gsyn
Xn0 xhp0 xhn0 ahp0 ahn0 vdd vbneu dneuron
Xeh0 xhp0 xhn0 mhp0 mhn0 ehp0 ehn0 vdd gm_h esub
Xcm_mh1 mhp1 mhn1 vdd cmld
Xcm_xh1 xhp1 xhn1 vdd cmld
Rnd_mh1 mhp1 mhn1 20k
Rnd_xh1 xhp1 xhn1 20k
Cxhp1 xhp1 0 0.4p
Cxhn1 xhn1 0 0.4p
X_ihm_1_1 a_xp1 a_xn1 wp_wih_1_1 wn_wih_1_1 mhp1 mhn1 vdd vbsyn gsyn
X_ihx_1_1 a_xp1 a_xn1 wp_wih_1_1 wn_wih_1_1 xhp1 xhn1 vdd vbsyn gsyn
X_ihm_2_1 a_xp2 a_xn2 wp_wih_2_1 wn_wih_2_1 mhp1 mhn1 vdd vbsyn gsyn
X_ihx_2_1 a_xp2 a_xn2 wp_wih_2_1 wn_wih_2_1 xhp1 xhn1 vdd vbsyn gsyn
X_ihm_3_1 a_xp3 a_xn3 wp_wih_3_1 wn_wih_3_1 mhp1 mhn1 vdd vbsyn gsyn
X_ihx_3_1 a_xp3 a_xn3 wp_wih_3_1 wn_wih_3_1 xhp1 xhn1 vdd vbsyn gsyn
X_bk_1 eop eon wp_who_1 wn_who_1 xhp1 xhn1 vdd vbsyn gsyn
Xn1 xhp1 xhn1 ahp1 ahn1 vdd vbneu dneuron
Xeh1 xhp1 xhn1 mhp1 mhn1 ehp1 ehn1 vdd gm_h esub
Xcm_mh2 mhp2 mhn2 vdd cmld
Xcm_xh2 xhp2 xhn2 vdd cmld
Rnd_mh2 mhp2 mhn2 20k
Rnd_xh2 xhp2 xhn2 20k
Cxhp2 xhp2 0 0.4p
Cxhn2 xhn2 0 0.4p
X_ihm_1_2 a_xp1 a_xn1 wp_wih_1_2 wn_wih_1_2 mhp2 mhn2 vdd vbsyn gsyn
X_ihx_1_2 a_xp1 a_xn1 wp_wih_1_2 wn_wih_1_2 xhp2 xhn2 vdd vbsyn gsyn
X_ihm_2_2 a_xp2 a_xn2 wp_wih_2_2 wn_wih_2_2 mhp2 mhn2 vdd vbsyn gsyn
X_ihx_2_2 a_xp2 a_xn2 wp_wih_2_2 wn_wih_2_2 xhp2 xhn2 vdd vbsyn gsyn
X_ihm_3_2 a_xp3 a_xn3 wp_wih_3_2 wn_wih_3_2 mhp2 mhn2 vdd vbsyn gsyn
X_ihx_3_2 a_xp3 a_xn3 wp_wih_3_2 wn_wih_3_2 xhp2 xhn2 vdd vbsyn gsyn
X_bk_2 eop eon wp_who_2 wn_who_2 xhp2 xhn2 vdd vbsyn gsyn
Xn2 xhp2 xhn2 ahp2 ahn2 vdd vbneu dneuron
Xeh2 xhp2 xhn2 mhp2 mhn2 ehp2 ehn2 vdd gm_h esub
Xcm_mh3 mhp3 mhn3 vdd cmld
Xcm_xh3 xhp3 xhn3 vdd cmld
Rnd_mh3 mhp3 mhn3 20k
Rnd_xh3 xhp3 xhn3 20k
Cxhp3 xhp3 0 0.4p
Cxhn3 xhn3 0 0.4p
X_ihm_1_3 a_xp1 a_xn1 wp_wih_1_3 wn_wih_1_3 mhp3 mhn3 vdd vbsyn gsyn
X_ihx_1_3 a_xp1 a_xn1 wp_wih_1_3 wn_wih_1_3 xhp3 xhn3 vdd vbsyn gsyn
X_ihm_2_3 a_xp2 a_xn2 wp_wih_2_3 wn_wih_2_3 mhp3 mhn3 vdd vbsyn gsyn
X_ihx_2_3 a_xp2 a_xn2 wp_wih_2_3 wn_wih_2_3 xhp3 xhn3 vdd vbsyn gsyn
X_ihm_3_3 a_xp3 a_xn3 wp_wih_3_3 wn_wih_3_3 mhp3 mhn3 vdd vbsyn gsyn
X_ihx_3_3 a_xp3 a_xn3 wp_wih_3_3 wn_wih_3_3 xhp3 xhn3 vdd vbsyn gsyn
X_bk_3 eop eon wp_who_3 wn_who_3 xhp3 xhn3 vdd vbsyn gsyn
Xn3 xhp3 xhn3 ahp3 ahn3 vdd vbneu dneuron
Xeh3 xhp3 xhn3 mhp3 mhn3 ehp3 ehn3 vdd gm_h esub
Xcm_mh4 mhp4 mhn4 vdd cmld
Xcm_xh4 xhp4 xhn4 vdd cmld
Rnd_mh4 mhp4 mhn4 20k
Rnd_xh4 xhp4 xhn4 20k
Cxhp4 xhp4 0 0.4p
Cxhn4 xhn4 0 0.4p
X_ihm_1_4 a_xp1 a_xn1 wp_wih_1_4 wn_wih_1_4 mhp4 mhn4 vdd vbsyn gsyn
X_ihx_1_4 a_xp1 a_xn1 wp_wih_1_4 wn_wih_1_4 xhp4 xhn4 vdd vbsyn gsyn
X_ihm_2_4 a_xp2 a_xn2 wp_wih_2_4 wn_wih_2_4 mhp4 mhn4 vdd vbsyn gsyn
X_ihx_2_4 a_xp2 a_xn2 wp_wih_2_4 wn_wih_2_4 xhp4 xhn4 vdd vbsyn gsyn
X_ihm_3_4 a_xp3 a_xn3 wp_wih_3_4 wn_wih_3_4 mhp4 mhn4 vdd vbsyn gsyn
X_ihx_3_4 a_xp3 a_xn3 wp_wih_3_4 wn_wih_3_4 xhp4 xhn4 vdd vbsyn gsyn
X_bk_4 eop eon wp_who_4 wn_who_4 xhp4 xhn4 vdd vbsyn gsyn
Xn4 xhp4 xhn4 ahp4 ahn4 vdd vbneu dneuron
Xeh4 xhp4 xhn4 mhp4 mhn4 ehp4 ehn4 vdd gm_h esub
Xcm_mh5 mhp5 mhn5 vdd cmld
Xcm_xh5 xhp5 xhn5 vdd cmld
Rnd_mh5 mhp5 mhn5 20k
Rnd_xh5 xhp5 xhn5 20k
Cxhp5 xhp5 0 0.4p
Cxhn5 xhn5 0 0.4p
X_ihm_1_5 a_xp1 a_xn1 wp_wih_1_5 wn_wih_1_5 mhp5 mhn5 vdd vbsyn gsyn
X_ihx_1_5 a_xp1 a_xn1 wp_wih_1_5 wn_wih_1_5 xhp5 xhn5 vdd vbsyn gsyn
X_ihm_2_5 a_xp2 a_xn2 wp_wih_2_5 wn_wih_2_5 mhp5 mhn5 vdd vbsyn gsyn
X_ihx_2_5 a_xp2 a_xn2 wp_wih_2_5 wn_wih_2_5 xhp5 xhn5 vdd vbsyn gsyn
X_ihm_3_5 a_xp3 a_xn3 wp_wih_3_5 wn_wih_3_5 mhp5 mhn5 vdd vbsyn gsyn
X_ihx_3_5 a_xp3 a_xn3 wp_wih_3_5 wn_wih_3_5 xhp5 xhn5 vdd vbsyn gsyn
X_bk_5 eop eon wp_who_5 wn_who_5 xhp5 xhn5 vdd vbsyn gsyn
Xn5 xhp5 xhn5 ahp5 ahn5 vdd vbneu dneuron
Xeh5 xhp5 xhn5 mhp5 mhn5 ehp5 ehn5 vdd gm_h esub
Xcm_mh6 mhp6 mhn6 vdd cmld
Xcm_xh6 xhp6 xhn6 vdd cmld
Rnd_mh6 mhp6 mhn6 20k
Rnd_xh6 xhp6 xhn6 20k
Cxhp6 xhp6 0 0.4p
Cxhn6 xhn6 0 0.4p
X_ihm_1_6 a_xp1 a_xn1 wp_wih_1_6 wn_wih_1_6 mhp6 mhn6 vdd vbsyn gsyn
X_ihx_1_6 a_xp1 a_xn1 wp_wih_1_6 wn_wih_1_6 xhp6 xhn6 vdd vbsyn gsyn
X_ihm_2_6 a_xp2 a_xn2 wp_wih_2_6 wn_wih_2_6 mhp6 mhn6 vdd vbsyn gsyn
X_ihx_2_6 a_xp2 a_xn2 wp_wih_2_6 wn_wih_2_6 xhp6 xhn6 vdd vbsyn gsyn
X_ihm_3_6 a_xp3 a_xn3 wp_wih_3_6 wn_wih_3_6 mhp6 mhn6 vdd vbsyn gsyn
X_ihx_3_6 a_xp3 a_xn3 wp_wih_3_6 wn_wih_3_6 xhp6 xhn6 vdd vbsyn gsyn
X_bk_6 eop eon wp_who_6 wn_who_6 xhp6 xhn6 vdd vbsyn gsyn
Xn6 xhp6 xhn6 ahp6 ahn6 vdd vbneu dneuron
Xeh6 xhp6 xhn6 mhp6 mhn6 ehp6 ehn6 vdd gm_h esub
Xcm_mh7 mhp7 mhn7 vdd cmld
Xcm_xh7 xhp7 xhn7 vdd cmld
Rnd_mh7 mhp7 mhn7 20k
Rnd_xh7 xhp7 xhn7 20k
Cxhp7 xhp7 0 0.4p
Cxhn7 xhn7 0 0.4p
X_ihm_1_7 a_xp1 a_xn1 wp_wih_1_7 wn_wih_1_7 mhp7 mhn7 vdd vbsyn gsyn
X_ihx_1_7 a_xp1 a_xn1 wp_wih_1_7 wn_wih_1_7 xhp7 xhn7 vdd vbsyn gsyn
X_ihm_2_7 a_xp2 a_xn2 wp_wih_2_7 wn_wih_2_7 mhp7 mhn7 vdd vbsyn gsyn
X_ihx_2_7 a_xp2 a_xn2 wp_wih_2_7 wn_wih_2_7 xhp7 xhn7 vdd vbsyn gsyn
X_ihm_3_7 a_xp3 a_xn3 wp_wih_3_7 wn_wih_3_7 mhp7 mhn7 vdd vbsyn gsyn
X_ihx_3_7 a_xp3 a_xn3 wp_wih_3_7 wn_wih_3_7 xhp7 xhn7 vdd vbsyn gsyn
X_bk_7 eop eon wp_who_7 wn_who_7 xhp7 xhn7 vdd vbsyn gsyn
Xn7 xhp7 xhn7 ahp7 ahn7 vdd vbneu dneuron
Xeh7 xhp7 xhn7 mhp7 mhn7 ehp7 ehn7 vdd gm_h esub
Xcm_mh8 mhp8 mhn8 vdd cmld
Xcm_xh8 xhp8 xhn8 vdd cmld
Rnd_mh8 mhp8 mhn8 20k
Rnd_xh8 xhp8 xhn8 20k
Cxhp8 xhp8 0 0.4p
Cxhn8 xhn8 0 0.4p
X_ihm_1_8 a_xp1 a_xn1 wp_wih_1_8 wn_wih_1_8 mhp8 mhn8 vdd vbsyn gsyn
X_ihx_1_8 a_xp1 a_xn1 wp_wih_1_8 wn_wih_1_8 xhp8 xhn8 vdd vbsyn gsyn
X_ihm_2_8 a_xp2 a_xn2 wp_wih_2_8 wn_wih_2_8 mhp8 mhn8 vdd vbsyn gsyn
X_ihx_2_8 a_xp2 a_xn2 wp_wih_2_8 wn_wih_2_8 xhp8 xhn8 vdd vbsyn gsyn
X_ihm_3_8 a_xp3 a_xn3 wp_wih_3_8 wn_wih_3_8 mhp8 mhn8 vdd vbsyn gsyn
X_ihx_3_8 a_xp3 a_xn3 wp_wih_3_8 wn_wih_3_8 xhp8 xhn8 vdd vbsyn gsyn
X_bk_8 eop eon wp_who_8 wn_who_8 xhp8 xhn8 vdd vbsyn gsyn
Xn8 xhp8 xhn8 ahp8 ahn8 vdd vbneu dneuron
Xeh8 xhp8 xhn8 mhp8 mhn8 ehp8 ehn8 vdd gm_h esub
Xcm_mh9 mhp9 mhn9 vdd cmld
Xcm_xh9 xhp9 xhn9 vdd cmld
Rnd_mh9 mhp9 mhn9 20k
Rnd_xh9 xhp9 xhn9 20k
Cxhp9 xhp9 0 0.4p
Cxhn9 xhn9 0 0.4p
X_ihm_1_9 a_xp1 a_xn1 wp_wih_1_9 wn_wih_1_9 mhp9 mhn9 vdd vbsyn gsyn
X_ihx_1_9 a_xp1 a_xn1 wp_wih_1_9 wn_wih_1_9 xhp9 xhn9 vdd vbsyn gsyn
X_ihm_2_9 a_xp2 a_xn2 wp_wih_2_9 wn_wih_2_9 mhp9 mhn9 vdd vbsyn gsyn
X_ihx_2_9 a_xp2 a_xn2 wp_wih_2_9 wn_wih_2_9 xhp9 xhn9 vdd vbsyn gsyn
X_ihm_3_9 a_xp3 a_xn3 wp_wih_3_9 wn_wih_3_9 mhp9 mhn9 vdd vbsyn gsyn
X_ihx_3_9 a_xp3 a_xn3 wp_wih_3_9 wn_wih_3_9 xhp9 xhn9 vdd vbsyn gsyn
X_bk_9 eop eon wp_who_9 wn_who_9 xhp9 xhn9 vdd vbsyn gsyn
Xn9 xhp9 xhn9 ahp9 ahn9 vdd vbneu dneuron
Xeh9 xhp9 xhn9 mhp9 mhn9 ehp9 ehn9 vdd gm_h esub
Xcm_mh10 mhp10 mhn10 vdd cmld
Xcm_xh10 xhp10 xhn10 vdd cmld
Rnd_mh10 mhp10 mhn10 20k
Rnd_xh10 xhp10 xhn10 20k
Cxhp10 xhp10 0 0.4p
Cxhn10 xhn10 0 0.4p
X_ihm_1_10 a_xp1 a_xn1 wp_wih_1_10 wn_wih_1_10 mhp10 mhn10 vdd vbsyn gsyn
X_ihx_1_10 a_xp1 a_xn1 wp_wih_1_10 wn_wih_1_10 xhp10 xhn10 vdd vbsyn gsyn
X_ihm_2_10 a_xp2 a_xn2 wp_wih_2_10 wn_wih_2_10 mhp10 mhn10 vdd vbsyn gsyn
X_ihx_2_10 a_xp2 a_xn2 wp_wih_2_10 wn_wih_2_10 xhp10 xhn10 vdd vbsyn gsyn
X_ihm_3_10 a_xp3 a_xn3 wp_wih_3_10 wn_wih_3_10 mhp10 mhn10 vdd vbsyn gsyn
X_ihx_3_10 a_xp3 a_xn3 wp_wih_3_10 wn_wih_3_10 xhp10 xhn10 vdd vbsyn gsyn
X_bk_10 eop eon wp_who_10 wn_who_10 xhp10 xhn10 vdd vbsyn gsyn
Xn10 xhp10 xhn10 ahp10 ahn10 vdd vbneu dneuron
Xeh10 xhp10 xhn10 mhp10 mhn10 ehp10 ehn10 vdd gm_h esub
Xcm_mh11 mhp11 mhn11 vdd cmld
Xcm_xh11 xhp11 xhn11 vdd cmld
Rnd_mh11 mhp11 mhn11 20k
Rnd_xh11 xhp11 xhn11 20k
Cxhp11 xhp11 0 0.4p
Cxhn11 xhn11 0 0.4p
X_ihm_1_11 a_xp1 a_xn1 wp_wih_1_11 wn_wih_1_11 mhp11 mhn11 vdd vbsyn gsyn
X_ihx_1_11 a_xp1 a_xn1 wp_wih_1_11 wn_wih_1_11 xhp11 xhn11 vdd vbsyn gsyn
X_ihm_2_11 a_xp2 a_xn2 wp_wih_2_11 wn_wih_2_11 mhp11 mhn11 vdd vbsyn gsyn
X_ihx_2_11 a_xp2 a_xn2 wp_wih_2_11 wn_wih_2_11 xhp11 xhn11 vdd vbsyn gsyn
X_ihm_3_11 a_xp3 a_xn3 wp_wih_3_11 wn_wih_3_11 mhp11 mhn11 vdd vbsyn gsyn
X_ihx_3_11 a_xp3 a_xn3 wp_wih_3_11 wn_wih_3_11 xhp11 xhn11 vdd vbsyn gsyn
X_bk_11 eop eon wp_who_11 wn_who_11 xhp11 xhn11 vdd vbsyn gsyn
Xn11 xhp11 xhn11 ahp11 ahn11 vdd vbneu dneuron
Xeh11 xhp11 xhn11 mhp11 mhn11 ehp11 ehn11 vdd gm_h esub
Xcm_mh12 mhp12 mhn12 vdd cmld
Xcm_xh12 xhp12 xhn12 vdd cmld
Rnd_mh12 mhp12 mhn12 20k
Rnd_xh12 xhp12 xhn12 20k
Cxhp12 xhp12 0 0.4p
Cxhn12 xhn12 0 0.4p
X_ihm_1_12 a_xp1 a_xn1 wp_wih_1_12 wn_wih_1_12 mhp12 mhn12 vdd vbsyn gsyn
X_ihx_1_12 a_xp1 a_xn1 wp_wih_1_12 wn_wih_1_12 xhp12 xhn12 vdd vbsyn gsyn
X_ihm_2_12 a_xp2 a_xn2 wp_wih_2_12 wn_wih_2_12 mhp12 mhn12 vdd vbsyn gsyn
X_ihx_2_12 a_xp2 a_xn2 wp_wih_2_12 wn_wih_2_12 xhp12 xhn12 vdd vbsyn gsyn
X_ihm_3_12 a_xp3 a_xn3 wp_wih_3_12 wn_wih_3_12 mhp12 mhn12 vdd vbsyn gsyn
X_ihx_3_12 a_xp3 a_xn3 wp_wih_3_12 wn_wih_3_12 xhp12 xhn12 vdd vbsyn gsyn
X_bk_12 eop eon wp_who_12 wn_who_12 xhp12 xhn12 vdd vbsyn gsyn
Xn12 xhp12 xhn12 ahp12 ahn12 vdd vbneu dneuron
Xeh12 xhp12 xhn12 mhp12 mhn12 ehp12 ehn12 vdd gm_h esub
Xcm_mh13 mhp13 mhn13 vdd cmld
Xcm_xh13 xhp13 xhn13 vdd cmld
Rnd_mh13 mhp13 mhn13 20k
Rnd_xh13 xhp13 xhn13 20k
Cxhp13 xhp13 0 0.4p
Cxhn13 xhn13 0 0.4p
X_ihm_1_13 a_xp1 a_xn1 wp_wih_1_13 wn_wih_1_13 mhp13 mhn13 vdd vbsyn gsyn
X_ihx_1_13 a_xp1 a_xn1 wp_wih_1_13 wn_wih_1_13 xhp13 xhn13 vdd vbsyn gsyn
X_ihm_2_13 a_xp2 a_xn2 wp_wih_2_13 wn_wih_2_13 mhp13 mhn13 vdd vbsyn gsyn
X_ihx_2_13 a_xp2 a_xn2 wp_wih_2_13 wn_wih_2_13 xhp13 xhn13 vdd vbsyn gsyn
X_ihm_3_13 a_xp3 a_xn3 wp_wih_3_13 wn_wih_3_13 mhp13 mhn13 vdd vbsyn gsyn
X_ihx_3_13 a_xp3 a_xn3 wp_wih_3_13 wn_wih_3_13 xhp13 xhn13 vdd vbsyn gsyn
X_bk_13 eop eon wp_who_13 wn_who_13 xhp13 xhn13 vdd vbsyn gsyn
Xn13 xhp13 xhn13 ahp13 ahn13 vdd vbneu dneuron
Xeh13 xhp13 xhn13 mhp13 mhn13 ehp13 ehn13 vdd gm_h esub
Xcm_mh14 mhp14 mhn14 vdd cmld
Xcm_xh14 xhp14 xhn14 vdd cmld
Rnd_mh14 mhp14 mhn14 20k
Rnd_xh14 xhp14 xhn14 20k
Cxhp14 xhp14 0 0.4p
Cxhn14 xhn14 0 0.4p
X_ihm_1_14 a_xp1 a_xn1 wp_wih_1_14 wn_wih_1_14 mhp14 mhn14 vdd vbsyn gsyn
X_ihx_1_14 a_xp1 a_xn1 wp_wih_1_14 wn_wih_1_14 xhp14 xhn14 vdd vbsyn gsyn
X_ihm_2_14 a_xp2 a_xn2 wp_wih_2_14 wn_wih_2_14 mhp14 mhn14 vdd vbsyn gsyn
X_ihx_2_14 a_xp2 a_xn2 wp_wih_2_14 wn_wih_2_14 xhp14 xhn14 vdd vbsyn gsyn
X_ihm_3_14 a_xp3 a_xn3 wp_wih_3_14 wn_wih_3_14 mhp14 mhn14 vdd vbsyn gsyn
X_ihx_3_14 a_xp3 a_xn3 wp_wih_3_14 wn_wih_3_14 xhp14 xhn14 vdd vbsyn gsyn
X_bk_14 eop eon wp_who_14 wn_who_14 xhp14 xhn14 vdd vbsyn gsyn
Xn14 xhp14 xhn14 ahp14 ahn14 vdd vbneu dneuron
Xeh14 xhp14 xhn14 mhp14 mhn14 ehp14 ehn14 vdd gm_h esub
Xcm_mh15 mhp15 mhn15 vdd cmld
Xcm_xh15 xhp15 xhn15 vdd cmld
Rnd_mh15 mhp15 mhn15 20k
Rnd_xh15 xhp15 xhn15 20k
Cxhp15 xhp15 0 0.4p
Cxhn15 xhn15 0 0.4p
X_ihm_1_15 a_xp1 a_xn1 wp_wih_1_15 wn_wih_1_15 mhp15 mhn15 vdd vbsyn gsyn
X_ihx_1_15 a_xp1 a_xn1 wp_wih_1_15 wn_wih_1_15 xhp15 xhn15 vdd vbsyn gsyn
X_ihm_2_15 a_xp2 a_xn2 wp_wih_2_15 wn_wih_2_15 mhp15 mhn15 vdd vbsyn gsyn
X_ihx_2_15 a_xp2 a_xn2 wp_wih_2_15 wn_wih_2_15 xhp15 xhn15 vdd vbsyn gsyn
X_ihm_3_15 a_xp3 a_xn3 wp_wih_3_15 wn_wih_3_15 mhp15 mhn15 vdd vbsyn gsyn
X_ihx_3_15 a_xp3 a_xn3 wp_wih_3_15 wn_wih_3_15 xhp15 xhn15 vdd vbsyn gsyn
X_bk_15 eop eon wp_who_15 wn_who_15 xhp15 xhn15 vdd vbsyn gsyn
Xn15 xhp15 xhn15 ahp15 ahn15 vdd vbneu dneuron
Xeh15 xhp15 xhn15 mhp15 mhn15 ehp15 ehn15 vdd gm_h esub
Xcm_mh16 mhp16 mhn16 vdd cmld
Xcm_xh16 xhp16 xhn16 vdd cmld
Rnd_mh16 mhp16 mhn16 20k
Rnd_xh16 xhp16 xhn16 20k
Cxhp16 xhp16 0 0.4p
Cxhn16 xhn16 0 0.4p
X_ihm_1_16 a_xp1 a_xn1 wp_wih_1_16 wn_wih_1_16 mhp16 mhn16 vdd vbsyn gsyn
X_ihx_1_16 a_xp1 a_xn1 wp_wih_1_16 wn_wih_1_16 xhp16 xhn16 vdd vbsyn gsyn
X_ihm_2_16 a_xp2 a_xn2 wp_wih_2_16 wn_wih_2_16 mhp16 mhn16 vdd vbsyn gsyn
X_ihx_2_16 a_xp2 a_xn2 wp_wih_2_16 wn_wih_2_16 xhp16 xhn16 vdd vbsyn gsyn
X_ihm_3_16 a_xp3 a_xn3 wp_wih_3_16 wn_wih_3_16 mhp16 mhn16 vdd vbsyn gsyn
X_ihx_3_16 a_xp3 a_xn3 wp_wih_3_16 wn_wih_3_16 xhp16 xhn16 vdd vbsyn gsyn
X_bk_16 eop eon wp_who_16 wn_who_16 xhp16 xhn16 vdd vbsyn gsyn
Xn16 xhp16 xhn16 ahp16 ahn16 vdd vbneu dneuron
Xeh16 xhp16 xhn16 mhp16 mhn16 ehp16 ehn16 vdd gm_h esub
Xcm_mh17 mhp17 mhn17 vdd cmld
Xcm_xh17 xhp17 xhn17 vdd cmld
Rnd_mh17 mhp17 mhn17 20k
Rnd_xh17 xhp17 xhn17 20k
Cxhp17 xhp17 0 0.4p
Cxhn17 xhn17 0 0.4p
X_ihm_1_17 a_xp1 a_xn1 wp_wih_1_17 wn_wih_1_17 mhp17 mhn17 vdd vbsyn gsyn
X_ihx_1_17 a_xp1 a_xn1 wp_wih_1_17 wn_wih_1_17 xhp17 xhn17 vdd vbsyn gsyn
X_ihm_2_17 a_xp2 a_xn2 wp_wih_2_17 wn_wih_2_17 mhp17 mhn17 vdd vbsyn gsyn
X_ihx_2_17 a_xp2 a_xn2 wp_wih_2_17 wn_wih_2_17 xhp17 xhn17 vdd vbsyn gsyn
X_ihm_3_17 a_xp3 a_xn3 wp_wih_3_17 wn_wih_3_17 mhp17 mhn17 vdd vbsyn gsyn
X_ihx_3_17 a_xp3 a_xn3 wp_wih_3_17 wn_wih_3_17 xhp17 xhn17 vdd vbsyn gsyn
X_bk_17 eop eon wp_who_17 wn_who_17 xhp17 xhn17 vdd vbsyn gsyn
Xn17 xhp17 xhn17 ahp17 ahn17 vdd vbneu dneuron
Xeh17 xhp17 xhn17 mhp17 mhn17 ehp17 ehn17 vdd gm_h esub
Xcm_mh18 mhp18 mhn18 vdd cmld
Xcm_xh18 xhp18 xhn18 vdd cmld
Rnd_mh18 mhp18 mhn18 20k
Rnd_xh18 xhp18 xhn18 20k
Cxhp18 xhp18 0 0.4p
Cxhn18 xhn18 0 0.4p
X_ihm_1_18 a_xp1 a_xn1 wp_wih_1_18 wn_wih_1_18 mhp18 mhn18 vdd vbsyn gsyn
X_ihx_1_18 a_xp1 a_xn1 wp_wih_1_18 wn_wih_1_18 xhp18 xhn18 vdd vbsyn gsyn
X_ihm_2_18 a_xp2 a_xn2 wp_wih_2_18 wn_wih_2_18 mhp18 mhn18 vdd vbsyn gsyn
X_ihx_2_18 a_xp2 a_xn2 wp_wih_2_18 wn_wih_2_18 xhp18 xhn18 vdd vbsyn gsyn
X_ihm_3_18 a_xp3 a_xn3 wp_wih_3_18 wn_wih_3_18 mhp18 mhn18 vdd vbsyn gsyn
X_ihx_3_18 a_xp3 a_xn3 wp_wih_3_18 wn_wih_3_18 xhp18 xhn18 vdd vbsyn gsyn
X_bk_18 eop eon wp_who_18 wn_who_18 xhp18 xhn18 vdd vbsyn gsyn
Xn18 xhp18 xhn18 ahp18 ahn18 vdd vbneu dneuron
Xeh18 xhp18 xhn18 mhp18 mhn18 ehp18 ehn18 vdd gm_h esub
Xcm_mh19 mhp19 mhn19 vdd cmld
Xcm_xh19 xhp19 xhn19 vdd cmld
Rnd_mh19 mhp19 mhn19 20k
Rnd_xh19 xhp19 xhn19 20k
Cxhp19 xhp19 0 0.4p
Cxhn19 xhn19 0 0.4p
X_ihm_1_19 a_xp1 a_xn1 wp_wih_1_19 wn_wih_1_19 mhp19 mhn19 vdd vbsyn gsyn
X_ihx_1_19 a_xp1 a_xn1 wp_wih_1_19 wn_wih_1_19 xhp19 xhn19 vdd vbsyn gsyn
X_ihm_2_19 a_xp2 a_xn2 wp_wih_2_19 wn_wih_2_19 mhp19 mhn19 vdd vbsyn gsyn
X_ihx_2_19 a_xp2 a_xn2 wp_wih_2_19 wn_wih_2_19 xhp19 xhn19 vdd vbsyn gsyn
X_ihm_3_19 a_xp3 a_xn3 wp_wih_3_19 wn_wih_3_19 mhp19 mhn19 vdd vbsyn gsyn
X_ihx_3_19 a_xp3 a_xn3 wp_wih_3_19 wn_wih_3_19 xhp19 xhn19 vdd vbsyn gsyn
X_bk_19 eop eon wp_who_19 wn_who_19 xhp19 xhn19 vdd vbsyn gsyn
Xn19 xhp19 xhn19 ahp19 ahn19 vdd vbneu dneuron
Xeh19 xhp19 xhn19 mhp19 mhn19 ehp19 ehn19 vdd gm_h esub
Xcm_mh20 mhp20 mhn20 vdd cmld
Xcm_xh20 xhp20 xhn20 vdd cmld
Rnd_mh20 mhp20 mhn20 20k
Rnd_xh20 xhp20 xhn20 20k
Cxhp20 xhp20 0 0.4p
Cxhn20 xhn20 0 0.4p
X_ihm_1_20 a_xp1 a_xn1 wp_wih_1_20 wn_wih_1_20 mhp20 mhn20 vdd vbsyn gsyn
X_ihx_1_20 a_xp1 a_xn1 wp_wih_1_20 wn_wih_1_20 xhp20 xhn20 vdd vbsyn gsyn
X_ihm_2_20 a_xp2 a_xn2 wp_wih_2_20 wn_wih_2_20 mhp20 mhn20 vdd vbsyn gsyn
X_ihx_2_20 a_xp2 a_xn2 wp_wih_2_20 wn_wih_2_20 xhp20 xhn20 vdd vbsyn gsyn
X_ihm_3_20 a_xp3 a_xn3 wp_wih_3_20 wn_wih_3_20 mhp20 mhn20 vdd vbsyn gsyn
X_ihx_3_20 a_xp3 a_xn3 wp_wih_3_20 wn_wih_3_20 xhp20 xhn20 vdd vbsyn gsyn
X_bk_20 eop eon wp_who_20 wn_who_20 xhp20 xhn20 vdd vbsyn gsyn
Xn20 xhp20 xhn20 ahp20 ahn20 vdd vbneu dneuron
Xeh20 xhp20 xhn20 mhp20 mhn20 ehp20 ehn20 vdd gm_h esub
Xcm_mh21 mhp21 mhn21 vdd cmld
Xcm_xh21 xhp21 xhn21 vdd cmld
Rnd_mh21 mhp21 mhn21 20k
Rnd_xh21 xhp21 xhn21 20k
Cxhp21 xhp21 0 0.4p
Cxhn21 xhn21 0 0.4p
X_ihm_1_21 a_xp1 a_xn1 wp_wih_1_21 wn_wih_1_21 mhp21 mhn21 vdd vbsyn gsyn
X_ihx_1_21 a_xp1 a_xn1 wp_wih_1_21 wn_wih_1_21 xhp21 xhn21 vdd vbsyn gsyn
X_ihm_2_21 a_xp2 a_xn2 wp_wih_2_21 wn_wih_2_21 mhp21 mhn21 vdd vbsyn gsyn
X_ihx_2_21 a_xp2 a_xn2 wp_wih_2_21 wn_wih_2_21 xhp21 xhn21 vdd vbsyn gsyn
X_ihm_3_21 a_xp3 a_xn3 wp_wih_3_21 wn_wih_3_21 mhp21 mhn21 vdd vbsyn gsyn
X_ihx_3_21 a_xp3 a_xn3 wp_wih_3_21 wn_wih_3_21 xhp21 xhn21 vdd vbsyn gsyn
X_bk_21 eop eon wp_who_21 wn_who_21 xhp21 xhn21 vdd vbsyn gsyn
Xn21 xhp21 xhn21 ahp21 ahn21 vdd vbneu dneuron
Xeh21 xhp21 xhn21 mhp21 mhn21 ehp21 ehn21 vdd gm_h esub
Xcm_mh22 mhp22 mhn22 vdd cmld
Xcm_xh22 xhp22 xhn22 vdd cmld
Rnd_mh22 mhp22 mhn22 20k
Rnd_xh22 xhp22 xhn22 20k
Cxhp22 xhp22 0 0.4p
Cxhn22 xhn22 0 0.4p
X_ihm_1_22 a_xp1 a_xn1 wp_wih_1_22 wn_wih_1_22 mhp22 mhn22 vdd vbsyn gsyn
X_ihx_1_22 a_xp1 a_xn1 wp_wih_1_22 wn_wih_1_22 xhp22 xhn22 vdd vbsyn gsyn
X_ihm_2_22 a_xp2 a_xn2 wp_wih_2_22 wn_wih_2_22 mhp22 mhn22 vdd vbsyn gsyn
X_ihx_2_22 a_xp2 a_xn2 wp_wih_2_22 wn_wih_2_22 xhp22 xhn22 vdd vbsyn gsyn
X_ihm_3_22 a_xp3 a_xn3 wp_wih_3_22 wn_wih_3_22 mhp22 mhn22 vdd vbsyn gsyn
X_ihx_3_22 a_xp3 a_xn3 wp_wih_3_22 wn_wih_3_22 xhp22 xhn22 vdd vbsyn gsyn
X_bk_22 eop eon wp_who_22 wn_who_22 xhp22 xhn22 vdd vbsyn gsyn
Xn22 xhp22 xhn22 ahp22 ahn22 vdd vbneu dneuron
Xeh22 xhp22 xhn22 mhp22 mhn22 ehp22 ehn22 vdd gm_h esub
Xcm_mh23 mhp23 mhn23 vdd cmld
Xcm_xh23 xhp23 xhn23 vdd cmld
Rnd_mh23 mhp23 mhn23 20k
Rnd_xh23 xhp23 xhn23 20k
Cxhp23 xhp23 0 0.4p
Cxhn23 xhn23 0 0.4p
X_ihm_1_23 a_xp1 a_xn1 wp_wih_1_23 wn_wih_1_23 mhp23 mhn23 vdd vbsyn gsyn
X_ihx_1_23 a_xp1 a_xn1 wp_wih_1_23 wn_wih_1_23 xhp23 xhn23 vdd vbsyn gsyn
X_ihm_2_23 a_xp2 a_xn2 wp_wih_2_23 wn_wih_2_23 mhp23 mhn23 vdd vbsyn gsyn
X_ihx_2_23 a_xp2 a_xn2 wp_wih_2_23 wn_wih_2_23 xhp23 xhn23 vdd vbsyn gsyn
X_ihm_3_23 a_xp3 a_xn3 wp_wih_3_23 wn_wih_3_23 mhp23 mhn23 vdd vbsyn gsyn
X_ihx_3_23 a_xp3 a_xn3 wp_wih_3_23 wn_wih_3_23 xhp23 xhn23 vdd vbsyn gsyn
X_bk_23 eop eon wp_who_23 wn_who_23 xhp23 xhn23 vdd vbsyn gsyn
Xn23 xhp23 xhn23 ahp23 ahn23 vdd vbneu dneuron
Xeh23 xhp23 xhn23 mhp23 mhn23 ehp23 ehn23 vdd gm_h esub
Xcm_mh24 mhp24 mhn24 vdd cmld
Xcm_xh24 xhp24 xhn24 vdd cmld
Rnd_mh24 mhp24 mhn24 20k
Rnd_xh24 xhp24 xhn24 20k
Cxhp24 xhp24 0 0.4p
Cxhn24 xhn24 0 0.4p
X_ihm_1_24 a_xp1 a_xn1 wp_wih_1_24 wn_wih_1_24 mhp24 mhn24 vdd vbsyn gsyn
X_ihx_1_24 a_xp1 a_xn1 wp_wih_1_24 wn_wih_1_24 xhp24 xhn24 vdd vbsyn gsyn
X_ihm_2_24 a_xp2 a_xn2 wp_wih_2_24 wn_wih_2_24 mhp24 mhn24 vdd vbsyn gsyn
X_ihx_2_24 a_xp2 a_xn2 wp_wih_2_24 wn_wih_2_24 xhp24 xhn24 vdd vbsyn gsyn
X_ihm_3_24 a_xp3 a_xn3 wp_wih_3_24 wn_wih_3_24 mhp24 mhn24 vdd vbsyn gsyn
X_ihx_3_24 a_xp3 a_xn3 wp_wih_3_24 wn_wih_3_24 xhp24 xhn24 vdd vbsyn gsyn
X_bk_24 eop eon wp_who_24 wn_who_24 xhp24 xhn24 vdd vbsyn gsyn
Xn24 xhp24 xhn24 ahp24 ahn24 vdd vbneu dneuron
Xeh24 xhp24 xhn24 mhp24 mhn24 ehp24 ehn24 vdd gm_h esub
Xcm_mh25 mhp25 mhn25 vdd cmld
Xcm_xh25 xhp25 xhn25 vdd cmld
Rnd_mh25 mhp25 mhn25 20k
Rnd_xh25 xhp25 xhn25 20k
Cxhp25 xhp25 0 0.4p
Cxhn25 xhn25 0 0.4p
X_ihm_1_25 a_xp1 a_xn1 wp_wih_1_25 wn_wih_1_25 mhp25 mhn25 vdd vbsyn gsyn
X_ihx_1_25 a_xp1 a_xn1 wp_wih_1_25 wn_wih_1_25 xhp25 xhn25 vdd vbsyn gsyn
X_ihm_2_25 a_xp2 a_xn2 wp_wih_2_25 wn_wih_2_25 mhp25 mhn25 vdd vbsyn gsyn
X_ihx_2_25 a_xp2 a_xn2 wp_wih_2_25 wn_wih_2_25 xhp25 xhn25 vdd vbsyn gsyn
X_ihm_3_25 a_xp3 a_xn3 wp_wih_3_25 wn_wih_3_25 mhp25 mhn25 vdd vbsyn gsyn
X_ihx_3_25 a_xp3 a_xn3 wp_wih_3_25 wn_wih_3_25 xhp25 xhn25 vdd vbsyn gsyn
X_bk_25 eop eon wp_who_25 wn_who_25 xhp25 xhn25 vdd vbsyn gsyn
Xn25 xhp25 xhn25 ahp25 ahn25 vdd vbneu dneuron
Xeh25 xhp25 xhn25 mhp25 mhn25 ehp25 ehn25 vdd gm_h esub
Xcm_mh26 mhp26 mhn26 vdd cmld
Xcm_xh26 xhp26 xhn26 vdd cmld
Rnd_mh26 mhp26 mhn26 20k
Rnd_xh26 xhp26 xhn26 20k
Cxhp26 xhp26 0 0.4p
Cxhn26 xhn26 0 0.4p
X_ihm_1_26 a_xp1 a_xn1 wp_wih_1_26 wn_wih_1_26 mhp26 mhn26 vdd vbsyn gsyn
X_ihx_1_26 a_xp1 a_xn1 wp_wih_1_26 wn_wih_1_26 xhp26 xhn26 vdd vbsyn gsyn
X_ihm_2_26 a_xp2 a_xn2 wp_wih_2_26 wn_wih_2_26 mhp26 mhn26 vdd vbsyn gsyn
X_ihx_2_26 a_xp2 a_xn2 wp_wih_2_26 wn_wih_2_26 xhp26 xhn26 vdd vbsyn gsyn
X_ihm_3_26 a_xp3 a_xn3 wp_wih_3_26 wn_wih_3_26 mhp26 mhn26 vdd vbsyn gsyn
X_ihx_3_26 a_xp3 a_xn3 wp_wih_3_26 wn_wih_3_26 xhp26 xhn26 vdd vbsyn gsyn
X_bk_26 eop eon wp_who_26 wn_who_26 xhp26 xhn26 vdd vbsyn gsyn
Xn26 xhp26 xhn26 ahp26 ahn26 vdd vbneu dneuron
Xeh26 xhp26 xhn26 mhp26 mhn26 ehp26 ehn26 vdd gm_h esub
Xcm_mh27 mhp27 mhn27 vdd cmld
Xcm_xh27 xhp27 xhn27 vdd cmld
Rnd_mh27 mhp27 mhn27 20k
Rnd_xh27 xhp27 xhn27 20k
Cxhp27 xhp27 0 0.4p
Cxhn27 xhn27 0 0.4p
X_ihm_1_27 a_xp1 a_xn1 wp_wih_1_27 wn_wih_1_27 mhp27 mhn27 vdd vbsyn gsyn
X_ihx_1_27 a_xp1 a_xn1 wp_wih_1_27 wn_wih_1_27 xhp27 xhn27 vdd vbsyn gsyn
X_ihm_2_27 a_xp2 a_xn2 wp_wih_2_27 wn_wih_2_27 mhp27 mhn27 vdd vbsyn gsyn
X_ihx_2_27 a_xp2 a_xn2 wp_wih_2_27 wn_wih_2_27 xhp27 xhn27 vdd vbsyn gsyn
X_ihm_3_27 a_xp3 a_xn3 wp_wih_3_27 wn_wih_3_27 mhp27 mhn27 vdd vbsyn gsyn
X_ihx_3_27 a_xp3 a_xn3 wp_wih_3_27 wn_wih_3_27 xhp27 xhn27 vdd vbsyn gsyn
X_bk_27 eop eon wp_who_27 wn_who_27 xhp27 xhn27 vdd vbsyn gsyn
Xn27 xhp27 xhn27 ahp27 ahn27 vdd vbneu dneuron
Xeh27 xhp27 xhn27 mhp27 mhn27 ehp27 ehn27 vdd gm_h esub
Xcm_mh28 mhp28 mhn28 vdd cmld
Xcm_xh28 xhp28 xhn28 vdd cmld
Rnd_mh28 mhp28 mhn28 20k
Rnd_xh28 xhp28 xhn28 20k
Cxhp28 xhp28 0 0.4p
Cxhn28 xhn28 0 0.4p
X_ihm_1_28 a_xp1 a_xn1 wp_wih_1_28 wn_wih_1_28 mhp28 mhn28 vdd vbsyn gsyn
X_ihx_1_28 a_xp1 a_xn1 wp_wih_1_28 wn_wih_1_28 xhp28 xhn28 vdd vbsyn gsyn
X_ihm_2_28 a_xp2 a_xn2 wp_wih_2_28 wn_wih_2_28 mhp28 mhn28 vdd vbsyn gsyn
X_ihx_2_28 a_xp2 a_xn2 wp_wih_2_28 wn_wih_2_28 xhp28 xhn28 vdd vbsyn gsyn
X_ihm_3_28 a_xp3 a_xn3 wp_wih_3_28 wn_wih_3_28 mhp28 mhn28 vdd vbsyn gsyn
X_ihx_3_28 a_xp3 a_xn3 wp_wih_3_28 wn_wih_3_28 xhp28 xhn28 vdd vbsyn gsyn
X_bk_28 eop eon wp_who_28 wn_who_28 xhp28 xhn28 vdd vbsyn gsyn
Xn28 xhp28 xhn28 ahp28 ahn28 vdd vbneu dneuron
Xeh28 xhp28 xhn28 mhp28 mhn28 ehp28 ehn28 vdd gm_h esub
Xcm_mh29 mhp29 mhn29 vdd cmld
Xcm_xh29 xhp29 xhn29 vdd cmld
Rnd_mh29 mhp29 mhn29 20k
Rnd_xh29 xhp29 xhn29 20k
Cxhp29 xhp29 0 0.4p
Cxhn29 xhn29 0 0.4p
X_ihm_1_29 a_xp1 a_xn1 wp_wih_1_29 wn_wih_1_29 mhp29 mhn29 vdd vbsyn gsyn
X_ihx_1_29 a_xp1 a_xn1 wp_wih_1_29 wn_wih_1_29 xhp29 xhn29 vdd vbsyn gsyn
X_ihm_2_29 a_xp2 a_xn2 wp_wih_2_29 wn_wih_2_29 mhp29 mhn29 vdd vbsyn gsyn
X_ihx_2_29 a_xp2 a_xn2 wp_wih_2_29 wn_wih_2_29 xhp29 xhn29 vdd vbsyn gsyn
X_ihm_3_29 a_xp3 a_xn3 wp_wih_3_29 wn_wih_3_29 mhp29 mhn29 vdd vbsyn gsyn
X_ihx_3_29 a_xp3 a_xn3 wp_wih_3_29 wn_wih_3_29 xhp29 xhn29 vdd vbsyn gsyn
X_bk_29 eop eon wp_who_29 wn_who_29 xhp29 xhn29 vdd vbsyn gsyn
Xn29 xhp29 xhn29 ahp29 ahn29 vdd vbneu dneuron
Xeh29 xhp29 xhn29 mhp29 mhn29 ehp29 ehn29 vdd gm_h esub
Xcm_mh30 mhp30 mhn30 vdd cmld
Xcm_xh30 xhp30 xhn30 vdd cmld
Rnd_mh30 mhp30 mhn30 20k
Rnd_xh30 xhp30 xhn30 20k
Cxhp30 xhp30 0 0.4p
Cxhn30 xhn30 0 0.4p
X_ihm_1_30 a_xp1 a_xn1 wp_wih_1_30 wn_wih_1_30 mhp30 mhn30 vdd vbsyn gsyn
X_ihx_1_30 a_xp1 a_xn1 wp_wih_1_30 wn_wih_1_30 xhp30 xhn30 vdd vbsyn gsyn
X_ihm_2_30 a_xp2 a_xn2 wp_wih_2_30 wn_wih_2_30 mhp30 mhn30 vdd vbsyn gsyn
X_ihx_2_30 a_xp2 a_xn2 wp_wih_2_30 wn_wih_2_30 xhp30 xhn30 vdd vbsyn gsyn
X_ihm_3_30 a_xp3 a_xn3 wp_wih_3_30 wn_wih_3_30 mhp30 mhn30 vdd vbsyn gsyn
X_ihx_3_30 a_xp3 a_xn3 wp_wih_3_30 wn_wih_3_30 xhp30 xhn30 vdd vbsyn gsyn
X_bk_30 eop eon wp_who_30 wn_who_30 xhp30 xhn30 vdd vbsyn gsyn
Xn30 xhp30 xhn30 ahp30 ahn30 vdd vbneu dneuron
Xeh30 xhp30 xhn30 mhp30 mhn30 ehp30 ehn30 vdd gm_h esub
Xcm_mh31 mhp31 mhn31 vdd cmld
Xcm_xh31 xhp31 xhn31 vdd cmld
Rnd_mh31 mhp31 mhn31 20k
Rnd_xh31 xhp31 xhn31 20k
Cxhp31 xhp31 0 0.4p
Cxhn31 xhn31 0 0.4p
X_ihm_1_31 a_xp1 a_xn1 wp_wih_1_31 wn_wih_1_31 mhp31 mhn31 vdd vbsyn gsyn
X_ihx_1_31 a_xp1 a_xn1 wp_wih_1_31 wn_wih_1_31 xhp31 xhn31 vdd vbsyn gsyn
X_ihm_2_31 a_xp2 a_xn2 wp_wih_2_31 wn_wih_2_31 mhp31 mhn31 vdd vbsyn gsyn
X_ihx_2_31 a_xp2 a_xn2 wp_wih_2_31 wn_wih_2_31 xhp31 xhn31 vdd vbsyn gsyn
X_ihm_3_31 a_xp3 a_xn3 wp_wih_3_31 wn_wih_3_31 mhp31 mhn31 vdd vbsyn gsyn
X_ihx_3_31 a_xp3 a_xn3 wp_wih_3_31 wn_wih_3_31 xhp31 xhn31 vdd vbsyn gsyn
X_bk_31 eop eon wp_who_31 wn_who_31 xhp31 xhn31 vdd vbsyn gsyn
Xn31 xhp31 xhn31 ahp31 ahn31 vdd vbneu dneuron
Xeh31 xhp31 xhn31 mhp31 mhn31 ehp31 ehn31 vdd gm_h esub
Xcm_mh32 mhp32 mhn32 vdd cmld
Xcm_xh32 xhp32 xhn32 vdd cmld
Rnd_mh32 mhp32 mhn32 20k
Rnd_xh32 xhp32 xhn32 20k
Cxhp32 xhp32 0 0.4p
Cxhn32 xhn32 0 0.4p
X_ihm_1_32 a_xp1 a_xn1 wp_wih_1_32 wn_wih_1_32 mhp32 mhn32 vdd vbsyn gsyn
X_ihx_1_32 a_xp1 a_xn1 wp_wih_1_32 wn_wih_1_32 xhp32 xhn32 vdd vbsyn gsyn
X_ihm_2_32 a_xp2 a_xn2 wp_wih_2_32 wn_wih_2_32 mhp32 mhn32 vdd vbsyn gsyn
X_ihx_2_32 a_xp2 a_xn2 wp_wih_2_32 wn_wih_2_32 xhp32 xhn32 vdd vbsyn gsyn
X_ihm_3_32 a_xp3 a_xn3 wp_wih_3_32 wn_wih_3_32 mhp32 mhn32 vdd vbsyn gsyn
X_ihx_3_32 a_xp3 a_xn3 wp_wih_3_32 wn_wih_3_32 xhp32 xhn32 vdd vbsyn gsyn
X_bk_32 eop eon wp_who_32 wn_who_32 xhp32 xhn32 vdd vbsyn gsyn
Xn32 xhp32 xhn32 ahp32 ahn32 vdd vbneu dneuron
Xeh32 xhp32 xhn32 mhp32 mhn32 ehp32 ehn32 vdd gm_h esub
Xcm_mh33 mhp33 mhn33 vdd cmld
Xcm_xh33 xhp33 xhn33 vdd cmld
Rnd_mh33 mhp33 mhn33 20k
Rnd_xh33 xhp33 xhn33 20k
Cxhp33 xhp33 0 0.4p
Cxhn33 xhn33 0 0.4p
X_ihm_1_33 a_xp1 a_xn1 wp_wih_1_33 wn_wih_1_33 mhp33 mhn33 vdd vbsyn gsyn
X_ihx_1_33 a_xp1 a_xn1 wp_wih_1_33 wn_wih_1_33 xhp33 xhn33 vdd vbsyn gsyn
X_ihm_2_33 a_xp2 a_xn2 wp_wih_2_33 wn_wih_2_33 mhp33 mhn33 vdd vbsyn gsyn
X_ihx_2_33 a_xp2 a_xn2 wp_wih_2_33 wn_wih_2_33 xhp33 xhn33 vdd vbsyn gsyn
X_ihm_3_33 a_xp3 a_xn3 wp_wih_3_33 wn_wih_3_33 mhp33 mhn33 vdd vbsyn gsyn
X_ihx_3_33 a_xp3 a_xn3 wp_wih_3_33 wn_wih_3_33 xhp33 xhn33 vdd vbsyn gsyn
X_bk_33 eop eon wp_who_33 wn_who_33 xhp33 xhn33 vdd vbsyn gsyn
Xn33 xhp33 xhn33 ahp33 ahn33 vdd vbneu dneuron
Xeh33 xhp33 xhn33 mhp33 mhn33 ehp33 ehn33 vdd gm_h esub
Xcm_mh34 mhp34 mhn34 vdd cmld
Xcm_xh34 xhp34 xhn34 vdd cmld
Rnd_mh34 mhp34 mhn34 20k
Rnd_xh34 xhp34 xhn34 20k
Cxhp34 xhp34 0 0.4p
Cxhn34 xhn34 0 0.4p
X_ihm_1_34 a_xp1 a_xn1 wp_wih_1_34 wn_wih_1_34 mhp34 mhn34 vdd vbsyn gsyn
X_ihx_1_34 a_xp1 a_xn1 wp_wih_1_34 wn_wih_1_34 xhp34 xhn34 vdd vbsyn gsyn
X_ihm_2_34 a_xp2 a_xn2 wp_wih_2_34 wn_wih_2_34 mhp34 mhn34 vdd vbsyn gsyn
X_ihx_2_34 a_xp2 a_xn2 wp_wih_2_34 wn_wih_2_34 xhp34 xhn34 vdd vbsyn gsyn
X_ihm_3_34 a_xp3 a_xn3 wp_wih_3_34 wn_wih_3_34 mhp34 mhn34 vdd vbsyn gsyn
X_ihx_3_34 a_xp3 a_xn3 wp_wih_3_34 wn_wih_3_34 xhp34 xhn34 vdd vbsyn gsyn
X_bk_34 eop eon wp_who_34 wn_who_34 xhp34 xhn34 vdd vbsyn gsyn
Xn34 xhp34 xhn34 ahp34 ahn34 vdd vbneu dneuron
Xeh34 xhp34 xhn34 mhp34 mhn34 ehp34 ehn34 vdd gm_h esub
Xcm_mh35 mhp35 mhn35 vdd cmld
Xcm_xh35 xhp35 xhn35 vdd cmld
Rnd_mh35 mhp35 mhn35 20k
Rnd_xh35 xhp35 xhn35 20k
Cxhp35 xhp35 0 0.4p
Cxhn35 xhn35 0 0.4p
X_ihm_1_35 a_xp1 a_xn1 wp_wih_1_35 wn_wih_1_35 mhp35 mhn35 vdd vbsyn gsyn
X_ihx_1_35 a_xp1 a_xn1 wp_wih_1_35 wn_wih_1_35 xhp35 xhn35 vdd vbsyn gsyn
X_ihm_2_35 a_xp2 a_xn2 wp_wih_2_35 wn_wih_2_35 mhp35 mhn35 vdd vbsyn gsyn
X_ihx_2_35 a_xp2 a_xn2 wp_wih_2_35 wn_wih_2_35 xhp35 xhn35 vdd vbsyn gsyn
X_ihm_3_35 a_xp3 a_xn3 wp_wih_3_35 wn_wih_3_35 mhp35 mhn35 vdd vbsyn gsyn
X_ihx_3_35 a_xp3 a_xn3 wp_wih_3_35 wn_wih_3_35 xhp35 xhn35 vdd vbsyn gsyn
X_bk_35 eop eon wp_who_35 wn_who_35 xhp35 xhn35 vdd vbsyn gsyn
Xn35 xhp35 xhn35 ahp35 ahn35 vdd vbneu dneuron
Xeh35 xhp35 xhn35 mhp35 mhn35 ehp35 ehn35 vdd gm_h esub
Xcm_mh36 mhp36 mhn36 vdd cmld
Xcm_xh36 xhp36 xhn36 vdd cmld
Rnd_mh36 mhp36 mhn36 20k
Rnd_xh36 xhp36 xhn36 20k
Cxhp36 xhp36 0 0.4p
Cxhn36 xhn36 0 0.4p
X_ihm_1_36 a_xp1 a_xn1 wp_wih_1_36 wn_wih_1_36 mhp36 mhn36 vdd vbsyn gsyn
X_ihx_1_36 a_xp1 a_xn1 wp_wih_1_36 wn_wih_1_36 xhp36 xhn36 vdd vbsyn gsyn
X_ihm_2_36 a_xp2 a_xn2 wp_wih_2_36 wn_wih_2_36 mhp36 mhn36 vdd vbsyn gsyn
X_ihx_2_36 a_xp2 a_xn2 wp_wih_2_36 wn_wih_2_36 xhp36 xhn36 vdd vbsyn gsyn
X_ihm_3_36 a_xp3 a_xn3 wp_wih_3_36 wn_wih_3_36 mhp36 mhn36 vdd vbsyn gsyn
X_ihx_3_36 a_xp3 a_xn3 wp_wih_3_36 wn_wih_3_36 xhp36 xhn36 vdd vbsyn gsyn
X_bk_36 eop eon wp_who_36 wn_who_36 xhp36 xhn36 vdd vbsyn gsyn
Xn36 xhp36 xhn36 ahp36 ahn36 vdd vbneu dneuron
Xeh36 xhp36 xhn36 mhp36 mhn36 ehp36 ehn36 vdd gm_h esub
Xcm_mh37 mhp37 mhn37 vdd cmld
Xcm_xh37 xhp37 xhn37 vdd cmld
Rnd_mh37 mhp37 mhn37 20k
Rnd_xh37 xhp37 xhn37 20k
Cxhp37 xhp37 0 0.4p
Cxhn37 xhn37 0 0.4p
X_ihm_1_37 a_xp1 a_xn1 wp_wih_1_37 wn_wih_1_37 mhp37 mhn37 vdd vbsyn gsyn
X_ihx_1_37 a_xp1 a_xn1 wp_wih_1_37 wn_wih_1_37 xhp37 xhn37 vdd vbsyn gsyn
X_ihm_2_37 a_xp2 a_xn2 wp_wih_2_37 wn_wih_2_37 mhp37 mhn37 vdd vbsyn gsyn
X_ihx_2_37 a_xp2 a_xn2 wp_wih_2_37 wn_wih_2_37 xhp37 xhn37 vdd vbsyn gsyn
X_ihm_3_37 a_xp3 a_xn3 wp_wih_3_37 wn_wih_3_37 mhp37 mhn37 vdd vbsyn gsyn
X_ihx_3_37 a_xp3 a_xn3 wp_wih_3_37 wn_wih_3_37 xhp37 xhn37 vdd vbsyn gsyn
X_bk_37 eop eon wp_who_37 wn_who_37 xhp37 xhn37 vdd vbsyn gsyn
Xn37 xhp37 xhn37 ahp37 ahn37 vdd vbneu dneuron
Xeh37 xhp37 xhn37 mhp37 mhn37 ehp37 ehn37 vdd gm_h esub
Xcm_mh38 mhp38 mhn38 vdd cmld
Xcm_xh38 xhp38 xhn38 vdd cmld
Rnd_mh38 mhp38 mhn38 20k
Rnd_xh38 xhp38 xhn38 20k
Cxhp38 xhp38 0 0.4p
Cxhn38 xhn38 0 0.4p
X_ihm_1_38 a_xp1 a_xn1 wp_wih_1_38 wn_wih_1_38 mhp38 mhn38 vdd vbsyn gsyn
X_ihx_1_38 a_xp1 a_xn1 wp_wih_1_38 wn_wih_1_38 xhp38 xhn38 vdd vbsyn gsyn
X_ihm_2_38 a_xp2 a_xn2 wp_wih_2_38 wn_wih_2_38 mhp38 mhn38 vdd vbsyn gsyn
X_ihx_2_38 a_xp2 a_xn2 wp_wih_2_38 wn_wih_2_38 xhp38 xhn38 vdd vbsyn gsyn
X_ihm_3_38 a_xp3 a_xn3 wp_wih_3_38 wn_wih_3_38 mhp38 mhn38 vdd vbsyn gsyn
X_ihx_3_38 a_xp3 a_xn3 wp_wih_3_38 wn_wih_3_38 xhp38 xhn38 vdd vbsyn gsyn
X_bk_38 eop eon wp_who_38 wn_who_38 xhp38 xhn38 vdd vbsyn gsyn
Xn38 xhp38 xhn38 ahp38 ahn38 vdd vbneu dneuron
Xeh38 xhp38 xhn38 mhp38 mhn38 ehp38 ehn38 vdd gm_h esub
Xcm_mh39 mhp39 mhn39 vdd cmld
Xcm_xh39 xhp39 xhn39 vdd cmld
Rnd_mh39 mhp39 mhn39 20k
Rnd_xh39 xhp39 xhn39 20k
Cxhp39 xhp39 0 0.4p
Cxhn39 xhn39 0 0.4p
X_ihm_1_39 a_xp1 a_xn1 wp_wih_1_39 wn_wih_1_39 mhp39 mhn39 vdd vbsyn gsyn
X_ihx_1_39 a_xp1 a_xn1 wp_wih_1_39 wn_wih_1_39 xhp39 xhn39 vdd vbsyn gsyn
X_ihm_2_39 a_xp2 a_xn2 wp_wih_2_39 wn_wih_2_39 mhp39 mhn39 vdd vbsyn gsyn
X_ihx_2_39 a_xp2 a_xn2 wp_wih_2_39 wn_wih_2_39 xhp39 xhn39 vdd vbsyn gsyn
X_ihm_3_39 a_xp3 a_xn3 wp_wih_3_39 wn_wih_3_39 mhp39 mhn39 vdd vbsyn gsyn
X_ihx_3_39 a_xp3 a_xn3 wp_wih_3_39 wn_wih_3_39 xhp39 xhn39 vdd vbsyn gsyn
X_bk_39 eop eon wp_who_39 wn_who_39 xhp39 xhn39 vdd vbsyn gsyn
Xn39 xhp39 xhn39 ahp39 ahn39 vdd vbneu dneuron
Xeh39 xhp39 xhn39 mhp39 mhn39 ehp39 ehn39 vdd gm_h esub
Xcm_mo mop mon vdd cmld
Rnd_mo mop mon 20k
X_ho_0 ahp0 ahn0 wp_who_0 wn_who_0 mop mon vdd vbsyn gsyn
X_ho_1 ahp1 ahn1 wp_who_1 wn_who_1 mop mon vdd vbsyn gsyn
X_ho_2 ahp2 ahn2 wp_who_2 wn_who_2 mop mon vdd vbsyn gsyn
X_ho_3 ahp3 ahn3 wp_who_3 wn_who_3 mop mon vdd vbsyn gsyn
X_ho_4 ahp4 ahn4 wp_who_4 wn_who_4 mop mon vdd vbsyn gsyn
X_ho_5 ahp5 ahn5 wp_who_5 wn_who_5 mop mon vdd vbsyn gsyn
X_ho_6 ahp6 ahn6 wp_who_6 wn_who_6 mop mon vdd vbsyn gsyn
X_ho_7 ahp7 ahn7 wp_who_7 wn_who_7 mop mon vdd vbsyn gsyn
X_ho_8 ahp8 ahn8 wp_who_8 wn_who_8 mop mon vdd vbsyn gsyn
X_ho_9 ahp9 ahn9 wp_who_9 wn_who_9 mop mon vdd vbsyn gsyn
X_ho_10 ahp10 ahn10 wp_who_10 wn_who_10 mop mon vdd vbsyn gsyn
X_ho_11 ahp11 ahn11 wp_who_11 wn_who_11 mop mon vdd vbsyn gsyn
X_ho_12 ahp12 ahn12 wp_who_12 wn_who_12 mop mon vdd vbsyn gsyn
X_ho_13 ahp13 ahn13 wp_who_13 wn_who_13 mop mon vdd vbsyn gsyn
X_ho_14 ahp14 ahn14 wp_who_14 wn_who_14 mop mon vdd vbsyn gsyn
X_ho_15 ahp15 ahn15 wp_who_15 wn_who_15 mop mon vdd vbsyn gsyn
X_ho_16 ahp16 ahn16 wp_who_16 wn_who_16 mop mon vdd vbsyn gsyn
X_ho_17 ahp17 ahn17 wp_who_17 wn_who_17 mop mon vdd vbsyn gsyn
X_ho_18 ahp18 ahn18 wp_who_18 wn_who_18 mop mon vdd vbsyn gsyn
X_ho_19 ahp19 ahn19 wp_who_19 wn_who_19 mop mon vdd vbsyn gsyn
X_ho_20 ahp20 ahn20 wp_who_20 wn_who_20 mop mon vdd vbsyn gsyn
X_ho_21 ahp21 ahn21 wp_who_21 wn_who_21 mop mon vdd vbsyn gsyn
X_ho_22 ahp22 ahn22 wp_who_22 wn_who_22 mop mon vdd vbsyn gsyn
X_ho_23 ahp23 ahn23 wp_who_23 wn_who_23 mop mon vdd vbsyn gsyn
X_ho_24 ahp24 ahn24 wp_who_24 wn_who_24 mop mon vdd vbsyn gsyn
X_ho_25 ahp25 ahn25 wp_who_25 wn_who_25 mop mon vdd vbsyn gsyn
X_ho_26 ahp26 ahn26 wp_who_26 wn_who_26 mop mon vdd vbsyn gsyn
X_ho_27 ahp27 ahn27 wp_who_27 wn_who_27 mop mon vdd vbsyn gsyn
X_ho_28 ahp28 ahn28 wp_who_28 wn_who_28 mop mon vdd vbsyn gsyn
X_ho_29 ahp29 ahn29 wp_who_29 wn_who_29 mop mon vdd vbsyn gsyn
X_ho_30 ahp30 ahn30 wp_who_30 wn_who_30 mop mon vdd vbsyn gsyn
X_ho_31 ahp31 ahn31 wp_who_31 wn_who_31 mop mon vdd vbsyn gsyn
X_ho_32 ahp32 ahn32 wp_who_32 wn_who_32 mop mon vdd vbsyn gsyn
X_ho_33 ahp33 ahn33 wp_who_33 wn_who_33 mop mon vdd vbsyn gsyn
X_ho_34 ahp34 ahn34 wp_who_34 wn_who_34 mop mon vdd vbsyn gsyn
X_ho_35 ahp35 ahn35 wp_who_35 wn_who_35 mop mon vdd vbsyn gsyn
X_ho_36 ahp36 ahn36 wp_who_36 wn_who_36 mop mon vdd vbsyn gsyn
X_ho_37 ahp37 ahn37 wp_who_37 wn_who_37 mop mon vdd vbsyn gsyn
X_ho_38 ahp38 ahn38 wp_who_38 wn_who_38 mop mon vdd vbsyn gsyn
X_ho_39 ahp39 ahn39 wp_who_39 wn_who_39 mop mon vdd vbsyn gsyn
Xeo xop xon mop mon eop eon vdd gm_o esub
Xcm_mo2 mop2 mon2 vdd cmld
Rnd_mo2 mop2 mon2 20k
X_ho2_0 ahp0 ahn0 wp_who_0 wn_who_0 mop2 mon2 vdd vbsyn gsyn
X_ho2_1 ahp1 ahn1 wp_who_1 wn_who_1 mop2 mon2 vdd vbsyn gsyn
X_ho2_2 ahp2 ahn2 wp_who_2 wn_who_2 mop2 mon2 vdd vbsyn gsyn
X_ho2_3 ahp3 ahn3 wp_who_3 wn_who_3 mop2 mon2 vdd vbsyn gsyn
X_ho2_4 ahp4 ahn4 wp_who_4 wn_who_4 mop2 mon2 vdd vbsyn gsyn
X_ho2_5 ahp5 ahn5 wp_who_5 wn_who_5 mop2 mon2 vdd vbsyn gsyn
X_ho2_6 ahp6 ahn6 wp_who_6 wn_who_6 mop2 mon2 vdd vbsyn gsyn
X_ho2_7 ahp7 ahn7 wp_who_7 wn_who_7 mop2 mon2 vdd vbsyn gsyn
X_ho2_8 ahp8 ahn8 wp_who_8 wn_who_8 mop2 mon2 vdd vbsyn gsyn
X_ho2_9 ahp9 ahn9 wp_who_9 wn_who_9 mop2 mon2 vdd vbsyn gsyn
X_ho2_10 ahp10 ahn10 wp_who_10 wn_who_10 mop2 mon2 vdd vbsyn gsyn
X_ho2_11 ahp11 ahn11 wp_who_11 wn_who_11 mop2 mon2 vdd vbsyn gsyn
X_ho2_12 ahp12 ahn12 wp_who_12 wn_who_12 mop2 mon2 vdd vbsyn gsyn
X_ho2_13 ahp13 ahn13 wp_who_13 wn_who_13 mop2 mon2 vdd vbsyn gsyn
X_ho2_14 ahp14 ahn14 wp_who_14 wn_who_14 mop2 mon2 vdd vbsyn gsyn
X_ho2_15 ahp15 ahn15 wp_who_15 wn_who_15 mop2 mon2 vdd vbsyn gsyn
X_ho2_16 ahp16 ahn16 wp_who_16 wn_who_16 mop2 mon2 vdd vbsyn gsyn
X_ho2_17 ahp17 ahn17 wp_who_17 wn_who_17 mop2 mon2 vdd vbsyn gsyn
X_ho2_18 ahp18 ahn18 wp_who_18 wn_who_18 mop2 mon2 vdd vbsyn gsyn
X_ho2_19 ahp19 ahn19 wp_who_19 wn_who_19 mop2 mon2 vdd vbsyn gsyn
X_ho2_20 ahp20 ahn20 wp_who_20 wn_who_20 mop2 mon2 vdd vbsyn gsyn
X_ho2_21 ahp21 ahn21 wp_who_21 wn_who_21 mop2 mon2 vdd vbsyn gsyn
X_ho2_22 ahp22 ahn22 wp_who_22 wn_who_22 mop2 mon2 vdd vbsyn gsyn
X_ho2_23 ahp23 ahn23 wp_who_23 wn_who_23 mop2 mon2 vdd vbsyn gsyn
X_ho2_24 ahp24 ahn24 wp_who_24 wn_who_24 mop2 mon2 vdd vbsyn gsyn
X_ho2_25 ahp25 ahn25 wp_who_25 wn_who_25 mop2 mon2 vdd vbsyn gsyn
X_ho2_26 ahp26 ahn26 wp_who_26 wn_who_26 mop2 mon2 vdd vbsyn gsyn
X_ho2_27 ahp27 ahn27 wp_who_27 wn_who_27 mop2 mon2 vdd vbsyn gsyn
X_ho2_28 ahp28 ahn28 wp_who_28 wn_who_28 mop2 mon2 vdd vbsyn gsyn
X_ho2_29 ahp29 ahn29 wp_who_29 wn_who_29 mop2 mon2 vdd vbsyn gsyn
X_ho2_30 ahp30 ahn30 wp_who_30 wn_who_30 mop2 mon2 vdd vbsyn gsyn
X_ho2_31 ahp31 ahn31 wp_who_31 wn_who_31 mop2 mon2 vdd vbsyn gsyn
X_ho2_32 ahp32 ahn32 wp_who_32 wn_who_32 mop2 mon2 vdd vbsyn gsyn
X_ho2_33 ahp33 ahn33 wp_who_33 wn_who_33 mop2 mon2 vdd vbsyn gsyn
X_ho2_34 ahp34 ahn34 wp_who_34 wn_who_34 mop2 mon2 vdd vbsyn gsyn
X_ho2_35 ahp35 ahn35 wp_who_35 wn_who_35 mop2 mon2 vdd vbsyn gsyn
X_ho2_36 ahp36 ahn36 wp_who_36 wn_who_36 mop2 mon2 vdd vbsyn gsyn
X_ho2_37 ahp37 ahn37 wp_who_37 wn_who_37 mop2 mon2 vdd vbsyn gsyn
X_ho2_38 ahp38 ahn38 wp_who_38 wn_who_38 mop2 mon2 vdd vbsyn gsyn
X_ho2_39 ahp39 ahn39 wp_who_39 wn_who_39 mop2 mon2 vdd vbsyn gsyn
Xlih_1_0 ehp0 ehn0 a_xp1 a_xn1 wp_wih_1_0 wn_wih_1_0 vdd gblh gprod
Xlih_2_0 ehp0 ehn0 a_xp2 a_xn2 wp_wih_2_0 wn_wih_2_0 vdd gblh gprod
Xlih_3_0 ehp0 ehn0 a_xp3 a_xn3 wp_wih_3_0 wn_wih_3_0 vdd gblh gprod
Xlho_0 eon eop ahp0 ahn0 wp_who_0 wn_who_0 vdd gblo gprod
Xlih_1_1 ehp1 ehn1 a_xp1 a_xn1 wp_wih_1_1 wn_wih_1_1 vdd gblh gprod
Xlih_2_1 ehp1 ehn1 a_xp2 a_xn2 wp_wih_2_1 wn_wih_2_1 vdd gblh gprod
Xlih_3_1 ehp1 ehn1 a_xp3 a_xn3 wp_wih_3_1 wn_wih_3_1 vdd gblh gprod
Xlho_1 eon eop ahp1 ahn1 wp_who_1 wn_who_1 vdd gblo gprod
Xlih_1_2 ehp2 ehn2 a_xp1 a_xn1 wp_wih_1_2 wn_wih_1_2 vdd gblh gprod
Xlih_2_2 ehp2 ehn2 a_xp2 a_xn2 wp_wih_2_2 wn_wih_2_2 vdd gblh gprod
Xlih_3_2 ehp2 ehn2 a_xp3 a_xn3 wp_wih_3_2 wn_wih_3_2 vdd gblh gprod
Xlho_2 eon eop ahp2 ahn2 wp_who_2 wn_who_2 vdd gblo gprod
Xlih_1_3 ehp3 ehn3 a_xp1 a_xn1 wp_wih_1_3 wn_wih_1_3 vdd gblh gprod
Xlih_2_3 ehp3 ehn3 a_xp2 a_xn2 wp_wih_2_3 wn_wih_2_3 vdd gblh gprod
Xlih_3_3 ehp3 ehn3 a_xp3 a_xn3 wp_wih_3_3 wn_wih_3_3 vdd gblh gprod
Xlho_3 eon eop ahp3 ahn3 wp_who_3 wn_who_3 vdd gblo gprod
Xlih_1_4 ehp4 ehn4 a_xp1 a_xn1 wp_wih_1_4 wn_wih_1_4 vdd gblh gprod
Xlih_2_4 ehp4 ehn4 a_xp2 a_xn2 wp_wih_2_4 wn_wih_2_4 vdd gblh gprod
Xlih_3_4 ehp4 ehn4 a_xp3 a_xn3 wp_wih_3_4 wn_wih_3_4 vdd gblh gprod
Xlho_4 eon eop ahp4 ahn4 wp_who_4 wn_who_4 vdd gblo gprod
Xlih_1_5 ehp5 ehn5 a_xp1 a_xn1 wp_wih_1_5 wn_wih_1_5 vdd gblh gprod
Xlih_2_5 ehp5 ehn5 a_xp2 a_xn2 wp_wih_2_5 wn_wih_2_5 vdd gblh gprod
Xlih_3_5 ehp5 ehn5 a_xp3 a_xn3 wp_wih_3_5 wn_wih_3_5 vdd gblh gprod
Xlho_5 eon eop ahp5 ahn5 wp_who_5 wn_who_5 vdd gblo gprod
Xlih_1_6 ehp6 ehn6 a_xp1 a_xn1 wp_wih_1_6 wn_wih_1_6 vdd gblh gprod
Xlih_2_6 ehp6 ehn6 a_xp2 a_xn2 wp_wih_2_6 wn_wih_2_6 vdd gblh gprod
Xlih_3_6 ehp6 ehn6 a_xp3 a_xn3 wp_wih_3_6 wn_wih_3_6 vdd gblh gprod
Xlho_6 eon eop ahp6 ahn6 wp_who_6 wn_who_6 vdd gblo gprod
Xlih_1_7 ehp7 ehn7 a_xp1 a_xn1 wp_wih_1_7 wn_wih_1_7 vdd gblh gprod
Xlih_2_7 ehp7 ehn7 a_xp2 a_xn2 wp_wih_2_7 wn_wih_2_7 vdd gblh gprod
Xlih_3_7 ehp7 ehn7 a_xp3 a_xn3 wp_wih_3_7 wn_wih_3_7 vdd gblh gprod
Xlho_7 eon eop ahp7 ahn7 wp_who_7 wn_who_7 vdd gblo gprod
Xlih_1_8 ehp8 ehn8 a_xp1 a_xn1 wp_wih_1_8 wn_wih_1_8 vdd gblh gprod
Xlih_2_8 ehp8 ehn8 a_xp2 a_xn2 wp_wih_2_8 wn_wih_2_8 vdd gblh gprod
Xlih_3_8 ehp8 ehn8 a_xp3 a_xn3 wp_wih_3_8 wn_wih_3_8 vdd gblh gprod
Xlho_8 eon eop ahp8 ahn8 wp_who_8 wn_who_8 vdd gblo gprod
Xlih_1_9 ehp9 ehn9 a_xp1 a_xn1 wp_wih_1_9 wn_wih_1_9 vdd gblh gprod
Xlih_2_9 ehp9 ehn9 a_xp2 a_xn2 wp_wih_2_9 wn_wih_2_9 vdd gblh gprod
Xlih_3_9 ehp9 ehn9 a_xp3 a_xn3 wp_wih_3_9 wn_wih_3_9 vdd gblh gprod
Xlho_9 eon eop ahp9 ahn9 wp_who_9 wn_who_9 vdd gblo gprod
Xlih_1_10 ehp10 ehn10 a_xp1 a_xn1 wp_wih_1_10 wn_wih_1_10 vdd gblh gprod
Xlih_2_10 ehp10 ehn10 a_xp2 a_xn2 wp_wih_2_10 wn_wih_2_10 vdd gblh gprod
Xlih_3_10 ehp10 ehn10 a_xp3 a_xn3 wp_wih_3_10 wn_wih_3_10 vdd gblh gprod
Xlho_10 eon eop ahp10 ahn10 wp_who_10 wn_who_10 vdd gblo gprod
Xlih_1_11 ehp11 ehn11 a_xp1 a_xn1 wp_wih_1_11 wn_wih_1_11 vdd gblh gprod
Xlih_2_11 ehp11 ehn11 a_xp2 a_xn2 wp_wih_2_11 wn_wih_2_11 vdd gblh gprod
Xlih_3_11 ehp11 ehn11 a_xp3 a_xn3 wp_wih_3_11 wn_wih_3_11 vdd gblh gprod
Xlho_11 eon eop ahp11 ahn11 wp_who_11 wn_who_11 vdd gblo gprod
Xlih_1_12 ehp12 ehn12 a_xp1 a_xn1 wp_wih_1_12 wn_wih_1_12 vdd gblh gprod
Xlih_2_12 ehp12 ehn12 a_xp2 a_xn2 wp_wih_2_12 wn_wih_2_12 vdd gblh gprod
Xlih_3_12 ehp12 ehn12 a_xp3 a_xn3 wp_wih_3_12 wn_wih_3_12 vdd gblh gprod
Xlho_12 eon eop ahp12 ahn12 wp_who_12 wn_who_12 vdd gblo gprod
Xlih_1_13 ehp13 ehn13 a_xp1 a_xn1 wp_wih_1_13 wn_wih_1_13 vdd gblh gprod
Xlih_2_13 ehp13 ehn13 a_xp2 a_xn2 wp_wih_2_13 wn_wih_2_13 vdd gblh gprod
Xlih_3_13 ehp13 ehn13 a_xp3 a_xn3 wp_wih_3_13 wn_wih_3_13 vdd gblh gprod
Xlho_13 eon eop ahp13 ahn13 wp_who_13 wn_who_13 vdd gblo gprod
Xlih_1_14 ehp14 ehn14 a_xp1 a_xn1 wp_wih_1_14 wn_wih_1_14 vdd gblh gprod
Xlih_2_14 ehp14 ehn14 a_xp2 a_xn2 wp_wih_2_14 wn_wih_2_14 vdd gblh gprod
Xlih_3_14 ehp14 ehn14 a_xp3 a_xn3 wp_wih_3_14 wn_wih_3_14 vdd gblh gprod
Xlho_14 eon eop ahp14 ahn14 wp_who_14 wn_who_14 vdd gblo gprod
Xlih_1_15 ehp15 ehn15 a_xp1 a_xn1 wp_wih_1_15 wn_wih_1_15 vdd gblh gprod
Xlih_2_15 ehp15 ehn15 a_xp2 a_xn2 wp_wih_2_15 wn_wih_2_15 vdd gblh gprod
Xlih_3_15 ehp15 ehn15 a_xp3 a_xn3 wp_wih_3_15 wn_wih_3_15 vdd gblh gprod
Xlho_15 eon eop ahp15 ahn15 wp_who_15 wn_who_15 vdd gblo gprod
Xlih_1_16 ehp16 ehn16 a_xp1 a_xn1 wp_wih_1_16 wn_wih_1_16 vdd gblh gprod
Xlih_2_16 ehp16 ehn16 a_xp2 a_xn2 wp_wih_2_16 wn_wih_2_16 vdd gblh gprod
Xlih_3_16 ehp16 ehn16 a_xp3 a_xn3 wp_wih_3_16 wn_wih_3_16 vdd gblh gprod
Xlho_16 eon eop ahp16 ahn16 wp_who_16 wn_who_16 vdd gblo gprod
Xlih_1_17 ehp17 ehn17 a_xp1 a_xn1 wp_wih_1_17 wn_wih_1_17 vdd gblh gprod
Xlih_2_17 ehp17 ehn17 a_xp2 a_xn2 wp_wih_2_17 wn_wih_2_17 vdd gblh gprod
Xlih_3_17 ehp17 ehn17 a_xp3 a_xn3 wp_wih_3_17 wn_wih_3_17 vdd gblh gprod
Xlho_17 eon eop ahp17 ahn17 wp_who_17 wn_who_17 vdd gblo gprod
Xlih_1_18 ehp18 ehn18 a_xp1 a_xn1 wp_wih_1_18 wn_wih_1_18 vdd gblh gprod
Xlih_2_18 ehp18 ehn18 a_xp2 a_xn2 wp_wih_2_18 wn_wih_2_18 vdd gblh gprod
Xlih_3_18 ehp18 ehn18 a_xp3 a_xn3 wp_wih_3_18 wn_wih_3_18 vdd gblh gprod
Xlho_18 eon eop ahp18 ahn18 wp_who_18 wn_who_18 vdd gblo gprod
Xlih_1_19 ehp19 ehn19 a_xp1 a_xn1 wp_wih_1_19 wn_wih_1_19 vdd gblh gprod
Xlih_2_19 ehp19 ehn19 a_xp2 a_xn2 wp_wih_2_19 wn_wih_2_19 vdd gblh gprod
Xlih_3_19 ehp19 ehn19 a_xp3 a_xn3 wp_wih_3_19 wn_wih_3_19 vdd gblh gprod
Xlho_19 eon eop ahp19 ahn19 wp_who_19 wn_who_19 vdd gblo gprod
Xlih_1_20 ehp20 ehn20 a_xp1 a_xn1 wp_wih_1_20 wn_wih_1_20 vdd gblh gprod
Xlih_2_20 ehp20 ehn20 a_xp2 a_xn2 wp_wih_2_20 wn_wih_2_20 vdd gblh gprod
Xlih_3_20 ehp20 ehn20 a_xp3 a_xn3 wp_wih_3_20 wn_wih_3_20 vdd gblh gprod
Xlho_20 eon eop ahp20 ahn20 wp_who_20 wn_who_20 vdd gblo gprod
Xlih_1_21 ehp21 ehn21 a_xp1 a_xn1 wp_wih_1_21 wn_wih_1_21 vdd gblh gprod
Xlih_2_21 ehp21 ehn21 a_xp2 a_xn2 wp_wih_2_21 wn_wih_2_21 vdd gblh gprod
Xlih_3_21 ehp21 ehn21 a_xp3 a_xn3 wp_wih_3_21 wn_wih_3_21 vdd gblh gprod
Xlho_21 eon eop ahp21 ahn21 wp_who_21 wn_who_21 vdd gblo gprod
Xlih_1_22 ehp22 ehn22 a_xp1 a_xn1 wp_wih_1_22 wn_wih_1_22 vdd gblh gprod
Xlih_2_22 ehp22 ehn22 a_xp2 a_xn2 wp_wih_2_22 wn_wih_2_22 vdd gblh gprod
Xlih_3_22 ehp22 ehn22 a_xp3 a_xn3 wp_wih_3_22 wn_wih_3_22 vdd gblh gprod
Xlho_22 eon eop ahp22 ahn22 wp_who_22 wn_who_22 vdd gblo gprod
Xlih_1_23 ehp23 ehn23 a_xp1 a_xn1 wp_wih_1_23 wn_wih_1_23 vdd gblh gprod
Xlih_2_23 ehp23 ehn23 a_xp2 a_xn2 wp_wih_2_23 wn_wih_2_23 vdd gblh gprod
Xlih_3_23 ehp23 ehn23 a_xp3 a_xn3 wp_wih_3_23 wn_wih_3_23 vdd gblh gprod
Xlho_23 eon eop ahp23 ahn23 wp_who_23 wn_who_23 vdd gblo gprod
Xlih_1_24 ehp24 ehn24 a_xp1 a_xn1 wp_wih_1_24 wn_wih_1_24 vdd gblh gprod
Xlih_2_24 ehp24 ehn24 a_xp2 a_xn2 wp_wih_2_24 wn_wih_2_24 vdd gblh gprod
Xlih_3_24 ehp24 ehn24 a_xp3 a_xn3 wp_wih_3_24 wn_wih_3_24 vdd gblh gprod
Xlho_24 eon eop ahp24 ahn24 wp_who_24 wn_who_24 vdd gblo gprod
Xlih_1_25 ehp25 ehn25 a_xp1 a_xn1 wp_wih_1_25 wn_wih_1_25 vdd gblh gprod
Xlih_2_25 ehp25 ehn25 a_xp2 a_xn2 wp_wih_2_25 wn_wih_2_25 vdd gblh gprod
Xlih_3_25 ehp25 ehn25 a_xp3 a_xn3 wp_wih_3_25 wn_wih_3_25 vdd gblh gprod
Xlho_25 eon eop ahp25 ahn25 wp_who_25 wn_who_25 vdd gblo gprod
Xlih_1_26 ehp26 ehn26 a_xp1 a_xn1 wp_wih_1_26 wn_wih_1_26 vdd gblh gprod
Xlih_2_26 ehp26 ehn26 a_xp2 a_xn2 wp_wih_2_26 wn_wih_2_26 vdd gblh gprod
Xlih_3_26 ehp26 ehn26 a_xp3 a_xn3 wp_wih_3_26 wn_wih_3_26 vdd gblh gprod
Xlho_26 eon eop ahp26 ahn26 wp_who_26 wn_who_26 vdd gblo gprod
Xlih_1_27 ehp27 ehn27 a_xp1 a_xn1 wp_wih_1_27 wn_wih_1_27 vdd gblh gprod
Xlih_2_27 ehp27 ehn27 a_xp2 a_xn2 wp_wih_2_27 wn_wih_2_27 vdd gblh gprod
Xlih_3_27 ehp27 ehn27 a_xp3 a_xn3 wp_wih_3_27 wn_wih_3_27 vdd gblh gprod
Xlho_27 eon eop ahp27 ahn27 wp_who_27 wn_who_27 vdd gblo gprod
Xlih_1_28 ehp28 ehn28 a_xp1 a_xn1 wp_wih_1_28 wn_wih_1_28 vdd gblh gprod
Xlih_2_28 ehp28 ehn28 a_xp2 a_xn2 wp_wih_2_28 wn_wih_2_28 vdd gblh gprod
Xlih_3_28 ehp28 ehn28 a_xp3 a_xn3 wp_wih_3_28 wn_wih_3_28 vdd gblh gprod
Xlho_28 eon eop ahp28 ahn28 wp_who_28 wn_who_28 vdd gblo gprod
Xlih_1_29 ehp29 ehn29 a_xp1 a_xn1 wp_wih_1_29 wn_wih_1_29 vdd gblh gprod
Xlih_2_29 ehp29 ehn29 a_xp2 a_xn2 wp_wih_2_29 wn_wih_2_29 vdd gblh gprod
Xlih_3_29 ehp29 ehn29 a_xp3 a_xn3 wp_wih_3_29 wn_wih_3_29 vdd gblh gprod
Xlho_29 eon eop ahp29 ahn29 wp_who_29 wn_who_29 vdd gblo gprod
Xlih_1_30 ehp30 ehn30 a_xp1 a_xn1 wp_wih_1_30 wn_wih_1_30 vdd gblh gprod
Xlih_2_30 ehp30 ehn30 a_xp2 a_xn2 wp_wih_2_30 wn_wih_2_30 vdd gblh gprod
Xlih_3_30 ehp30 ehn30 a_xp3 a_xn3 wp_wih_3_30 wn_wih_3_30 vdd gblh gprod
Xlho_30 eon eop ahp30 ahn30 wp_who_30 wn_who_30 vdd gblo gprod
Xlih_1_31 ehp31 ehn31 a_xp1 a_xn1 wp_wih_1_31 wn_wih_1_31 vdd gblh gprod
Xlih_2_31 ehp31 ehn31 a_xp2 a_xn2 wp_wih_2_31 wn_wih_2_31 vdd gblh gprod
Xlih_3_31 ehp31 ehn31 a_xp3 a_xn3 wp_wih_3_31 wn_wih_3_31 vdd gblh gprod
Xlho_31 eon eop ahp31 ahn31 wp_who_31 wn_who_31 vdd gblo gprod
Xlih_1_32 ehp32 ehn32 a_xp1 a_xn1 wp_wih_1_32 wn_wih_1_32 vdd gblh gprod
Xlih_2_32 ehp32 ehn32 a_xp2 a_xn2 wp_wih_2_32 wn_wih_2_32 vdd gblh gprod
Xlih_3_32 ehp32 ehn32 a_xp3 a_xn3 wp_wih_3_32 wn_wih_3_32 vdd gblh gprod
Xlho_32 eon eop ahp32 ahn32 wp_who_32 wn_who_32 vdd gblo gprod
Xlih_1_33 ehp33 ehn33 a_xp1 a_xn1 wp_wih_1_33 wn_wih_1_33 vdd gblh gprod
Xlih_2_33 ehp33 ehn33 a_xp2 a_xn2 wp_wih_2_33 wn_wih_2_33 vdd gblh gprod
Xlih_3_33 ehp33 ehn33 a_xp3 a_xn3 wp_wih_3_33 wn_wih_3_33 vdd gblh gprod
Xlho_33 eon eop ahp33 ahn33 wp_who_33 wn_who_33 vdd gblo gprod
Xlih_1_34 ehp34 ehn34 a_xp1 a_xn1 wp_wih_1_34 wn_wih_1_34 vdd gblh gprod
Xlih_2_34 ehp34 ehn34 a_xp2 a_xn2 wp_wih_2_34 wn_wih_2_34 vdd gblh gprod
Xlih_3_34 ehp34 ehn34 a_xp3 a_xn3 wp_wih_3_34 wn_wih_3_34 vdd gblh gprod
Xlho_34 eon eop ahp34 ahn34 wp_who_34 wn_who_34 vdd gblo gprod
Xlih_1_35 ehp35 ehn35 a_xp1 a_xn1 wp_wih_1_35 wn_wih_1_35 vdd gblh gprod
Xlih_2_35 ehp35 ehn35 a_xp2 a_xn2 wp_wih_2_35 wn_wih_2_35 vdd gblh gprod
Xlih_3_35 ehp35 ehn35 a_xp3 a_xn3 wp_wih_3_35 wn_wih_3_35 vdd gblh gprod
Xlho_35 eon eop ahp35 ahn35 wp_who_35 wn_who_35 vdd gblo gprod
Xlih_1_36 ehp36 ehn36 a_xp1 a_xn1 wp_wih_1_36 wn_wih_1_36 vdd gblh gprod
Xlih_2_36 ehp36 ehn36 a_xp2 a_xn2 wp_wih_2_36 wn_wih_2_36 vdd gblh gprod
Xlih_3_36 ehp36 ehn36 a_xp3 a_xn3 wp_wih_3_36 wn_wih_3_36 vdd gblh gprod
Xlho_36 eon eop ahp36 ahn36 wp_who_36 wn_who_36 vdd gblo gprod
Xlih_1_37 ehp37 ehn37 a_xp1 a_xn1 wp_wih_1_37 wn_wih_1_37 vdd gblh gprod
Xlih_2_37 ehp37 ehn37 a_xp2 a_xn2 wp_wih_2_37 wn_wih_2_37 vdd gblh gprod
Xlih_3_37 ehp37 ehn37 a_xp3 a_xn3 wp_wih_3_37 wn_wih_3_37 vdd gblh gprod
Xlho_37 eon eop ahp37 ahn37 wp_who_37 wn_who_37 vdd gblo gprod
Xlih_1_38 ehp38 ehn38 a_xp1 a_xn1 wp_wih_1_38 wn_wih_1_38 vdd gblh gprod
Xlih_2_38 ehp38 ehn38 a_xp2 a_xn2 wp_wih_2_38 wn_wih_2_38 vdd gblh gprod
Xlih_3_38 ehp38 ehn38 a_xp3 a_xn3 wp_wih_3_38 wn_wih_3_38 vdd gblh gprod
Xlho_38 eon eop ahp38 ahn38 wp_who_38 wn_who_38 vdd gblo gprod
Xlih_1_39 ehp39 ehn39 a_xp1 a_xn1 wp_wih_1_39 wn_wih_1_39 vdd gblh gprod
Xlih_2_39 ehp39 ehn39 a_xp2 a_xn2 wp_wih_2_39 wn_wih_2_39 vdd gblh gprod
Xlih_3_39 ehp39 ehn39 a_xp3 a_xn3 wp_wih_3_39 wn_wih_3_39 vdd gblh gprod
Xlho_39 eon eop ahp39 ahn39 wp_who_39 wn_who_39 vdd gblo gprod
.ic v(wp_wih_1_0)=0.5864 v(wn_wih_1_0)=0.4136
.ic v(wp_wih_2_0)=0.7054 v(wn_wih_2_0)=0.2946
.ic v(wp_wih_3_0)=0.5826 v(wn_wih_3_0)=0.4174
.ic v(wp_who_0)=0.1742 v(wn_who_0)=0.8258
.ic v(wp_wih_1_1)=0.7263 v(wn_wih_1_1)=0.2737
.ic v(wp_wih_2_1)=0.6116 v(wn_wih_2_1)=0.3884
.ic v(wp_wih_3_1)=0.3658 v(wn_wih_3_1)=0.6342
.ic v(wp_who_1)=0.6453 v(wn_who_1)=0.3547
.ic v(wp_wih_1_2)=0.5911 v(wn_wih_1_2)=0.4089
.ic v(wp_wih_2_2)=0.5735 v(wn_wih_2_2)=0.4265
.ic v(wp_wih_3_2)=0.5071 v(wn_wih_3_2)=0.4929
.ic v(wp_who_2)=0.6367 v(wn_who_2)=0.3633
.ic v(wp_wih_1_3)=0.3159 v(wn_wih_1_3)=0.6841
.ic v(wp_wih_2_3)=0.4593 v(wn_wih_2_3)=0.5407
.ic v(wp_wih_3_3)=0.3795 v(wn_wih_3_3)=0.6205
.ic v(wp_who_3)=0.6497 v(wn_who_3)=0.3503
.ic v(wp_wih_1_4)=0.5099 v(wn_wih_1_4)=0.4901
.ic v(wp_wih_2_4)=0.4269 v(wn_wih_2_4)=0.5731
.ic v(wp_wih_3_4)=0.3045 v(wn_wih_3_4)=0.6955
.ic v(wp_who_4)=0.4357 v(wn_who_4)=0.5643
.ic v(wp_wih_1_5)=0.5020 v(wn_wih_1_5)=0.4980
.ic v(wp_wih_2_5)=0.4311 v(wn_wih_2_5)=0.5689
.ic v(wp_wih_3_5)=0.8235 v(wn_wih_3_5)=0.1765
.ic v(wp_who_5)=0.7517 v(wn_who_5)=0.2483
.ic v(wp_wih_1_6)=0.1500 v(wn_wih_1_6)=0.9500
.ic v(wp_wih_2_6)=0.1500 v(wn_wih_2_6)=0.9500
.ic v(wp_wih_3_6)=0.4563 v(wn_wih_3_6)=0.5437
.ic v(wp_who_6)=0.3945 v(wn_who_6)=0.6055
.ic v(wp_wih_1_7)=0.5534 v(wn_wih_1_7)=0.4466
.ic v(wp_wih_2_7)=0.5543 v(wn_wih_2_7)=0.4457
.ic v(wp_wih_3_7)=0.9500 v(wn_wih_3_7)=0.1500
.ic v(wp_who_7)=0.2220 v(wn_who_7)=0.7780
.ic v(wp_wih_1_8)=0.4056 v(wn_wih_1_8)=0.5944
.ic v(wp_wih_2_8)=0.9500 v(wn_wih_2_8)=0.1500
.ic v(wp_wih_3_8)=0.6617 v(wn_wih_3_8)=0.3383
.ic v(wp_who_8)=0.6658 v(wn_who_8)=0.3342
.ic v(wp_wih_1_9)=0.3715 v(wn_wih_1_9)=0.6285
.ic v(wp_wih_2_9)=0.1500 v(wn_wih_2_9)=0.9120
.ic v(wp_wih_3_9)=0.5419 v(wn_wih_3_9)=0.4581
.ic v(wp_who_9)=0.5273 v(wn_who_9)=0.4727
.ic v(wp_wih_1_10)=0.1932 v(wn_wih_1_10)=0.8068
.ic v(wp_wih_2_10)=0.3292 v(wn_wih_2_10)=0.6708
.ic v(wp_wih_3_10)=0.4820 v(wn_wih_3_10)=0.5180
.ic v(wp_who_10)=0.2638 v(wn_who_10)=0.7362
.ic v(wp_wih_1_11)=0.4754 v(wn_wih_1_11)=0.5246
.ic v(wp_wih_2_11)=0.5239 v(wn_wih_2_11)=0.4761
.ic v(wp_wih_3_11)=0.5089 v(wn_wih_3_11)=0.4911
.ic v(wp_who_11)=0.3734 v(wn_who_11)=0.6266
.ic v(wp_wih_1_12)=0.6484 v(wn_wih_1_12)=0.3516
.ic v(wp_wih_2_12)=0.7228 v(wn_wih_2_12)=0.2772
.ic v(wp_wih_3_12)=0.5802 v(wn_wih_3_12)=0.4198
.ic v(wp_who_12)=0.2954 v(wn_who_12)=0.7046
.ic v(wp_wih_1_13)=0.6829 v(wn_wih_1_13)=0.3171
.ic v(wp_wih_2_13)=0.3746 v(wn_wih_2_13)=0.6254
.ic v(wp_wih_3_13)=0.7198 v(wn_wih_3_13)=0.2802
.ic v(wp_who_13)=0.2321 v(wn_who_13)=0.7679
.ic v(wp_wih_1_14)=0.7286 v(wn_wih_1_14)=0.2714
.ic v(wp_wih_2_14)=0.4950 v(wn_wih_2_14)=0.5050
.ic v(wp_wih_3_14)=0.1878 v(wn_wih_3_14)=0.8122
.ic v(wp_who_14)=0.4215 v(wn_who_14)=0.5785
.ic v(wp_wih_1_15)=0.5135 v(wn_wih_1_15)=0.4865
.ic v(wp_wih_2_15)=0.5682 v(wn_wih_2_15)=0.4318
.ic v(wp_wih_3_15)=0.2545 v(wn_wih_3_15)=0.7455
.ic v(wp_who_15)=0.2232 v(wn_who_15)=0.7768
.ic v(wp_wih_1_16)=0.5499 v(wn_wih_1_16)=0.4501
.ic v(wp_wih_2_16)=0.3833 v(wn_wih_2_16)=0.6167
.ic v(wp_wih_3_16)=0.5589 v(wn_wih_3_16)=0.4411
.ic v(wp_who_16)=0.6899 v(wn_who_16)=0.3101
.ic v(wp_wih_1_17)=0.1500 v(wn_wih_1_17)=0.9122
.ic v(wp_wih_2_17)=0.5636 v(wn_wih_2_17)=0.4364
.ic v(wp_wih_3_17)=0.8062 v(wn_wih_3_17)=0.1938
.ic v(wp_who_17)=0.4256 v(wn_who_17)=0.5744
.ic v(wp_wih_1_18)=0.2973 v(wn_wih_1_18)=0.7027
.ic v(wp_wih_2_18)=0.6881 v(wn_wih_2_18)=0.3119
.ic v(wp_wih_3_18)=0.5634 v(wn_wih_3_18)=0.4366
.ic v(wp_who_18)=0.7240 v(wn_who_18)=0.2760
.ic v(wp_wih_1_19)=0.4137 v(wn_wih_1_19)=0.5863
.ic v(wp_wih_2_19)=0.1500 v(wn_wih_2_19)=0.8705
.ic v(wp_wih_3_19)=0.4725 v(wn_wih_3_19)=0.5275
.ic v(wp_who_19)=0.3885 v(wn_who_19)=0.6115
.ic v(wp_wih_1_20)=0.6938 v(wn_wih_1_20)=0.3062
.ic v(wp_wih_2_20)=0.5484 v(wn_wih_2_20)=0.4516
.ic v(wp_wih_3_20)=0.1500 v(wn_wih_3_20)=0.9077
.ic v(wp_who_20)=0.2012 v(wn_who_20)=0.7988
.ic v(wp_wih_1_21)=0.7209 v(wn_wih_1_21)=0.2791
.ic v(wp_wih_2_21)=0.6699 v(wn_wih_2_21)=0.3301
.ic v(wp_wih_3_21)=0.3399 v(wn_wih_3_21)=0.6601
.ic v(wp_who_21)=0.4997 v(wn_who_21)=0.5003
.ic v(wp_wih_1_22)=0.6114 v(wn_wih_1_22)=0.3886
.ic v(wp_wih_2_22)=0.6171 v(wn_wih_2_22)=0.3829
.ic v(wp_wih_3_22)=0.7191 v(wn_wih_3_22)=0.2809
.ic v(wp_who_22)=0.5641 v(wn_who_22)=0.4359
.ic v(wp_wih_1_23)=0.4763 v(wn_wih_1_23)=0.5237
.ic v(wp_wih_2_23)=0.4353 v(wn_wih_2_23)=0.5647
.ic v(wp_wih_3_23)=0.7639 v(wn_wih_3_23)=0.2361
.ic v(wp_who_23)=0.1500 v(wn_who_23)=0.9500
.ic v(wp_wih_1_24)=0.4653 v(wn_wih_1_24)=0.5347
.ic v(wp_wih_2_24)=0.5083 v(wn_wih_2_24)=0.4917
.ic v(wp_wih_3_24)=0.1500 v(wn_wih_3_24)=0.8563
.ic v(wp_who_24)=0.5832 v(wn_who_24)=0.4168
.ic v(wp_wih_1_25)=0.3372 v(wn_wih_1_25)=0.6628
.ic v(wp_wih_2_25)=0.7156 v(wn_wih_2_25)=0.2844
.ic v(wp_wih_3_25)=0.4686 v(wn_wih_3_25)=0.5314
.ic v(wp_who_25)=0.6673 v(wn_who_25)=0.3327
.ic v(wp_wih_1_26)=0.8047 v(wn_wih_1_26)=0.1953
.ic v(wp_wih_2_26)=0.5957 v(wn_wih_2_26)=0.4043
.ic v(wp_wih_3_26)=0.2811 v(wn_wih_3_26)=0.7189
.ic v(wp_who_26)=0.1500 v(wn_who_26)=0.8786
.ic v(wp_wih_1_27)=0.9383 v(wn_wih_1_27)=0.1500
.ic v(wp_wih_2_27)=0.4722 v(wn_wih_2_27)=0.5278
.ic v(wp_wih_3_27)=0.3279 v(wn_wih_3_27)=0.6721
.ic v(wp_who_27)=0.5361 v(wn_who_27)=0.4639
.ic v(wp_wih_1_28)=0.4521 v(wn_wih_1_28)=0.5479
.ic v(wp_wih_2_28)=0.7130 v(wn_wih_2_28)=0.2870
.ic v(wp_wih_3_28)=0.5085 v(wn_wih_3_28)=0.4915
.ic v(wp_who_28)=0.5034 v(wn_who_28)=0.4966
.ic v(wp_wih_1_29)=0.3214 v(wn_wih_1_29)=0.6786
.ic v(wp_wih_2_29)=0.6174 v(wn_wih_2_29)=0.3826
.ic v(wp_wih_3_29)=0.2415 v(wn_wih_3_29)=0.7585
.ic v(wp_who_29)=0.6665 v(wn_who_29)=0.3335
.ic v(wp_wih_1_30)=0.8810 v(wn_wih_1_30)=0.1500
.ic v(wp_wih_2_30)=0.1500 v(wn_wih_2_30)=0.8812
.ic v(wp_wih_3_30)=0.1500 v(wn_wih_3_30)=0.9500
.ic v(wp_who_30)=0.6542 v(wn_who_30)=0.3458
.ic v(wp_wih_1_31)=0.9500 v(wn_wih_1_31)=0.1500
.ic v(wp_wih_2_31)=0.2498 v(wn_wih_2_31)=0.7502
.ic v(wp_wih_3_31)=0.1873 v(wn_wih_3_31)=0.8127
.ic v(wp_who_31)=0.6472 v(wn_who_31)=0.3528
.ic v(wp_wih_1_32)=0.2898 v(wn_wih_1_32)=0.7102
.ic v(wp_wih_2_32)=0.3735 v(wn_wih_2_32)=0.6265
.ic v(wp_wih_3_32)=0.4130 v(wn_wih_3_32)=0.5870
.ic v(wp_who_32)=0.6330 v(wn_who_32)=0.3670
.ic v(wp_wih_1_33)=0.3987 v(wn_wih_1_33)=0.6013
.ic v(wp_wih_2_33)=0.5695 v(wn_wih_2_33)=0.4305
.ic v(wp_wih_3_33)=0.4559 v(wn_wih_3_33)=0.5441
.ic v(wp_who_33)=0.2888 v(wn_who_33)=0.7112
.ic v(wp_wih_1_34)=0.4200 v(wn_wih_1_34)=0.5800
.ic v(wp_wih_2_34)=0.2624 v(wn_wih_2_34)=0.7376
.ic v(wp_wih_3_34)=0.5016 v(wn_wih_3_34)=0.4984
.ic v(wp_who_34)=0.2190 v(wn_who_34)=0.7810
.ic v(wp_wih_1_35)=0.2268 v(wn_wih_1_35)=0.7732
.ic v(wp_wih_2_35)=0.8642 v(wn_wih_2_35)=0.1500
.ic v(wp_wih_3_35)=0.4867 v(wn_wih_3_35)=0.5133
.ic v(wp_who_35)=0.4865 v(wn_who_35)=0.5135
.ic v(wp_wih_1_36)=0.6279 v(wn_wih_1_36)=0.3721
.ic v(wp_wih_2_36)=0.3948 v(wn_wih_2_36)=0.6052
.ic v(wp_wih_3_36)=0.4429 v(wn_wih_3_36)=0.5571
.ic v(wp_who_36)=0.6063 v(wn_who_36)=0.3937
.ic v(wp_wih_1_37)=0.5706 v(wn_wih_1_37)=0.4294
.ic v(wp_wih_2_37)=0.2102 v(wn_wih_2_37)=0.7898
.ic v(wp_wih_3_37)=0.7083 v(wn_wih_3_37)=0.2917
.ic v(wp_who_37)=0.3524 v(wn_who_37)=0.6476
.ic v(wp_wih_1_38)=0.2360 v(wn_wih_1_38)=0.7640
.ic v(wp_wih_2_38)=0.2749 v(wn_wih_2_38)=0.7251
.ic v(wp_wih_3_38)=0.4024 v(wn_wih_3_38)=0.5976
.ic v(wp_who_38)=0.9068 v(wn_who_38)=0.1500
.ic v(wp_wih_1_39)=0.2061 v(wn_wih_1_39)=0.7939
.ic v(wp_wih_2_39)=0.5400 v(wn_wih_2_39)=0.4600
.ic v(wp_wih_3_39)=0.1500 v(wn_wih_3_39)=0.9500
.ic v(wp_who_39)=0.4996 v(wn_who_39)=0.5004
.options cshunt=1e-14 gmin=1e-10 reltol=2e-3
.tran 2n 210000n uic
.control
run
wrdata pcL2dtr40b.dat v(mop) v(mon) v(mop2) v(mon2)
wrdata pcL2dwtr40b.dat v(wp_wih_1_0) v(wn_wih_1_0) v(wp_wih_2_0) v(wn_wih_2_0) v(wp_wih_3_0) v(wn_wih_3_0) v(wp_who_0) v(wn_who_0) v(wp_wih_1_1) v(wn_wih_1_1) v(wp_wih_2_1) v(wn_wih_2_1) v(wp_wih_3_1) v(wn_wih_3_1) v(wp_who_1) v(wn_who_1) v(wp_wih_1_2) v(wn_wih_1_2) v(wp_wih_2_2) v(wn_wih_2_2) v(wp_wih_3_2) v(wn_wih_3_2) v(wp_who_2) v(wn_who_2) v(wp_wih_1_3) v(wn_wih_1_3) v(wp_wih_2_3) v(wn_wih_2_3) v(wp_wih_3_3) v(wn_wih_3_3) v(wp_who_3) v(wn_who_3) v(wp_wih_1_4) v(wn_wih_1_4) v(wp_wih_2_4) v(wn_wih_2_4) v(wp_wih_3_4) v(wn_wih_3_4) v(wp_who_4) v(wn_who_4) v(wp_wih_1_5) v(wn_wih_1_5) v(wp_wih_2_5) v(wn_wih_2_5) v(wp_wih_3_5) v(wn_wih_3_5) v(wp_who_5) v(wn_who_5) v(wp_wih_1_6) v(wn_wih_1_6) v(wp_wih_2_6) v(wn_wih_2_6) v(wp_wih_3_6) v(wn_wih_3_6) v(wp_who_6) v(wn_who_6) v(wp_wih_1_7) v(wn_wih_1_7) v(wp_wih_2_7) v(wn_wih_2_7) v(wp_wih_3_7) v(wn_wih_3_7) v(wp_who_7) v(wn_who_7) v(wp_wih_1_8) v(wn_wih_1_8) v(wp_wih_2_8) v(wn_wih_2_8) v(wp_wih_3_8) v(wn_wih_3_8) v(wp_who_8) v(wn_who_8) v(wp_wih_1_9) v(wn_wih_1_9) v(wp_wih_2_9) v(wn_wih_2_9) v(wp_wih_3_9) v(wn_wih_3_9) v(wp_who_9) v(wn_who_9) v(wp_wih_1_10) v(wn_wih_1_10) v(wp_wih_2_10) v(wn_wih_2_10) v(wp_wih_3_10) v(wn_wih_3_10) v(wp_who_10) v(wn_who_10) v(wp_wih_1_11) v(wn_wih_1_11) v(wp_wih_2_11) v(wn_wih_2_11) v(wp_wih_3_11) v(wn_wih_3_11) v(wp_who_11) v(wn_who_11) v(wp_wih_1_12) v(wn_wih_1_12) v(wp_wih_2_12) v(wn_wih_2_12) v(wp_wih_3_12) v(wn_wih_3_12) v(wp_who_12) v(wn_who_12) v(wp_wih_1_13) v(wn_wih_1_13) v(wp_wih_2_13) v(wn_wih_2_13) v(wp_wih_3_13) v(wn_wih_3_13) v(wp_who_13) v(wn_who_13) v(wp_wih_1_14) v(wn_wih_1_14) v(wp_wih_2_14) v(wn_wih_2_14) v(wp_wih_3_14) v(wn_wih_3_14) v(wp_who_14) v(wn_who_14) v(wp_wih_1_15) v(wn_wih_1_15) v(wp_wih_2_15) v(wn_wih_2_15) v(wp_wih_3_15) v(wn_wih_3_15) v(wp_who_15) v(wn_who_15) v(wp_wih_1_16) v(wn_wih_1_16) v(wp_wih_2_16) v(wn_wih_2_16) v(wp_wih_3_16) v(wn_wih_3_16) v(wp_who_16) v(wn_who_16) v(wp_wih_1_17) v(wn_wih_1_17) v(wp_wih_2_17) v(wn_wih_2_17) v(wp_wih_3_17) v(wn_wih_3_17) v(wp_who_17) v(wn_who_17) v(wp_wih_1_18) v(wn_wih_1_18) v(wp_wih_2_18) v(wn_wih_2_18) v(wp_wih_3_18) v(wn_wih_3_18) v(wp_who_18) v(wn_who_18) v(wp_wih_1_19) v(wn_wih_1_19) v(wp_wih_2_19) v(wn_wih_2_19) v(wp_wih_3_19) v(wn_wih_3_19) v(wp_who_19) v(wn_who_19) v(wp_wih_1_20) v(wn_wih_1_20) v(wp_wih_2_20) v(wn_wih_2_20) v(wp_wih_3_20) v(wn_wih_3_20) v(wp_who_20) v(wn_who_20) v(wp_wih_1_21) v(wn_wih_1_21) v(wp_wih_2_21) v(wn_wih_2_21) v(wp_wih_3_21) v(wn_wih_3_21) v(wp_who_21) v(wn_who_21) v(wp_wih_1_22) v(wn_wih_1_22) v(wp_wih_2_22) v(wn_wih_2_22) v(wp_wih_3_22) v(wn_wih_3_22) v(wp_who_22) v(wn_who_22) v(wp_wih_1_23) v(wn_wih_1_23) v(wp_wih_2_23) v(wn_wih_2_23) v(wp_wih_3_23) v(wn_wih_3_23) v(wp_who_23) v(wn_who_23) v(wp_wih_1_24) v(wn_wih_1_24) v(wp_wih_2_24) v(wn_wih_2_24) v(wp_wih_3_24) v(wn_wih_3_24) v(wp_who_24) v(wn_who_24) v(wp_wih_1_25) v(wn_wih_1_25) v(wp_wih_2_25) v(wn_wih_2_25) v(wp_wih_3_25) v(wn_wih_3_25) v(wp_who_25) v(wn_who_25) v(wp_wih_1_26) v(wn_wih_1_26) v(wp_wih_2_26) v(wn_wih_2_26) v(wp_wih_3_26) v(wn_wih_3_26) v(wp_who_26) v(wn_who_26) v(wp_wih_1_27) v(wn_wih_1_27) v(wp_wih_2_27) v(wn_wih_2_27) v(wp_wih_3_27) v(wn_wih_3_27) v(wp_who_27) v(wn_who_27) v(wp_wih_1_28) v(wn_wih_1_28) v(wp_wih_2_28) v(wn_wih_2_28) v(wp_wih_3_28) v(wn_wih_3_28) v(wp_who_28) v(wn_who_28) v(wp_wih_1_29) v(wn_wih_1_29) v(wp_wih_2_29) v(wn_wih_2_29) v(wp_wih_3_29) v(wn_wih_3_29) v(wp_who_29) v(wn_who_29) v(wp_wih_1_30) v(wn_wih_1_30) v(wp_wih_2_30) v(wn_wih_2_30) v(wp_wih_3_30) v(wn_wih_3_30) v(wp_who_30) v(wn_who_30) v(wp_wih_1_31) v(wn_wih_1_31) v(wp_wih_2_31) v(wn_wih_2_31) v(wp_wih_3_31) v(wn_wih_3_31) v(wp_who_31) v(wn_who_31) v(wp_wih_1_32) v(wn_wih_1_32) v(wp_wih_2_32) v(wn_wih_2_32) v(wp_wih_3_32) v(wn_wih_3_32) v(wp_who_32) v(wn_who_32) v(wp_wih_1_33) v(wn_wih_1_33) v(wp_wih_2_33) v(wn_wih_2_33) v(wp_wih_3_33) v(wn_wih_3_33) v(wp_who_33) v(wn_who_33) v(wp_wih_1_34) v(wn_wih_1_34) v(wp_wih_2_34) v(wn_wih_2_34) v(wp_wih_3_34) v(wn_wih_3_34) v(wp_who_34) v(wn_who_34) v(wp_wih_1_35) v(wn_wih_1_35) v(wp_wih_2_35) v(wn_wih_2_35) v(wp_wih_3_35) v(wn_wih_3_35) v(wp_who_35) v(wn_who_35) v(wp_wih_1_36) v(wn_wih_1_36) v(wp_wih_2_36) v(wn_wih_2_36) v(wp_wih_3_36) v(wn_wih_3_36) v(wp_who_36) v(wn_who_36) v(wp_wih_1_37) v(wn_wih_1_37) v(wp_wih_2_37) v(wn_wih_2_37) v(wp_wih_3_37) v(wn_wih_3_37) v(wp_who_37) v(wn_who_37) v(wp_wih_1_38) v(wn_wih_1_38) v(wp_wih_2_38) v(wn_wih_2_38) v(wp_wih_3_38) v(wn_wih_3_38) v(wp_who_38) v(wn_who_38) v(wp_wih_1_39) v(wn_wih_1_39) v(wp_wih_2_39) v(wn_wih_2_39) v(wp_wih_3_39) v(wn_wih_3_39) v(wp_who_39) v(wn_who_39)
.endc
.end
