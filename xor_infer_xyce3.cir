* frozen inference
.model NSYN NMOS (LEVEL=1 VTO=0.2 KP=50u LAMBDA=0 GAMMA=0 PHI=0.7)
.model NMIR NMOS (LEVEL=1 VTO=0.5 KP=120u LAMBDA=0.02 GAMMA=0 PHI=0.7)
.model PMIR PMOS (LEVEL=1 VTO=-0.5 KP=40u LAMBDA=0.02 GAMMA=0 PHI=0.7)
.model NREL NMOS (LEVEL=1 VTO=0.5 KP=120u LAMBDA=0.02 GAMMA=0 PHI=0.7)
Vvdd vdd 0 3
Vrefh vrefh 0 0.5
Vrefo vrefo 0 0.5
Vg0 vg0 0 0.7
Vvc vcn 0 1.8
Va1 a1 0 PWL(0.0000 0.7000 0.1800 0.7000 0.2000 0.7000 0.3800 0.7000 0.4000 1.3000 0.5800 1.3000 0.6000 1.3000 0.7800 1.3000 0.8000 1.3000)
Va2 a2 0 PWL(0.0000 0.7000 0.1800 0.7000 0.2000 1.3000 0.3800 1.3000 0.4000 0.7000 0.5800 0.7000 0.6000 1.3000 0.7800 1.3000 0.8000 1.3000)
Vtg tg 0 PWL(0.0000 0.0000 0.1800 0.0000 0.2000 1.0000 0.3800 1.0000 0.4000 1.0000 0.5800 1.0000 0.6000 0.0000 0.7800 0.0000 0.8000 0.0000)
Vbx bx 0 dc 1.3
Vg_1_1_1 g_1_1_1 0 2.2568
Mp_1_1_1 a1 g_1_1_1 colp1 0 NSYN W=10u L=1u
Mn_1_1_1 a1 vcn coln1 0 NSYN W=10u L=1u
Vg_1_1_2 g_1_1_2 0 0.5709
Mp_1_1_2 a2 g_1_1_2 colp1 0 NSYN W=10u L=1u
Mn_1_1_2 a2 vcn coln1 0 NSYN W=10u L=1u
Vg_1_1_b g_1_1_b 0 1.7267
Mp_1_1_b bx g_1_1_b colp1 0 NSYN W=10u L=1u
Mn_1_1_b bx vcn coln1 0 NSYN W=10u L=1u
Msa_h1 coln1 coln1 0 0 NMIR W=20u L=1u
Msb_h1 z1_1 coln1 0 0 NMIR W=20u L=1u
Msc_h1 colp1 colp1 0 0 NMIR W=20u L=1u
Msd_h1 dpf_h1 colp1 0 0 NMIR W=20u L=1u
Mse_h1 dpf_h1 dpf_h1 vdd vdd PMIR W=60u L=1u
Msf_h1 z1_1 dpf_h1 vdd vdd PMIR W=60u L=1u
R_h1 z1_1 vrefh 8000.0
Mr_1 hdd_1 z1_1 0 0 NREL W=12u L=1u
Mrp1_1 hdd_1 hdd_1 vdd vdd PMIR W=40u L=1u
Mrp2_1 hv_1 hdd_1 vdd vdd PMIR W=40u L=1u
Rhv_1 hv_1 vg0 8000.0
Vg_1_2_1 g_1_2_1 0 0.5980
Mp_1_2_1 a1 g_1_2_1 colp2 0 NSYN W=10u L=1u
Mn_1_2_1 a1 vcn coln2 0 NSYN W=10u L=1u
Vg_1_2_2 g_1_2_2 0 2.4900
Mp_1_2_2 a2 g_1_2_2 colp2 0 NSYN W=10u L=1u
Mn_1_2_2 a2 vcn coln2 0 NSYN W=10u L=1u
Vg_1_2_b g_1_2_b 0 1.4946
Mp_1_2_b bx g_1_2_b colp2 0 NSYN W=10u L=1u
Mn_1_2_b bx vcn coln2 0 NSYN W=10u L=1u
Msa_h2 coln2 coln2 0 0 NMIR W=20u L=1u
Msb_h2 z1_2 coln2 0 0 NMIR W=20u L=1u
Msc_h2 colp2 colp2 0 0 NMIR W=20u L=1u
Msd_h2 dpf_h2 colp2 0 0 NMIR W=20u L=1u
Mse_h2 dpf_h2 dpf_h2 vdd vdd PMIR W=60u L=1u
Msf_h2 z1_2 dpf_h2 vdd vdd PMIR W=60u L=1u
R_h2 z1_2 vrefh 8000.0
Mr_2 hdd_2 z1_2 0 0 NREL W=12u L=1u
Mrp1_2 hdd_2 hdd_2 vdd vdd PMIR W=40u L=1u
Mrp2_2 hv_2 hdd_2 vdd vdd PMIR W=40u L=1u
Rhv_2 hv_2 vg0 8000.0
Vg_1_3_1 g_1_3_1 0 1.1640
Mp_1_3_1 a1 g_1_3_1 colp3 0 NSYN W=10u L=1u
Mn_1_3_1 a1 vcn coln3 0 NSYN W=10u L=1u
Vg_1_3_2 g_1_3_2 0 1.8108
Mp_1_3_2 a2 g_1_3_2 colp3 0 NSYN W=10u L=1u
Mn_1_3_2 a2 vcn coln3 0 NSYN W=10u L=1u
Vg_1_3_b g_1_3_b 0 1.1340
Mp_1_3_b bx g_1_3_b colp3 0 NSYN W=10u L=1u
Mn_1_3_b bx vcn coln3 0 NSYN W=10u L=1u
Msa_h3 coln3 coln3 0 0 NMIR W=20u L=1u
Msb_h3 z1_3 coln3 0 0 NMIR W=20u L=1u
Msc_h3 colp3 colp3 0 0 NMIR W=20u L=1u
Msd_h3 dpf_h3 colp3 0 0 NMIR W=20u L=1u
Mse_h3 dpf_h3 dpf_h3 vdd vdd PMIR W=60u L=1u
Msf_h3 z1_3 dpf_h3 vdd vdd PMIR W=60u L=1u
R_h3 z1_3 vrefh 8000.0
Mr_3 hdd_3 z1_3 0 0 NREL W=12u L=1u
Mrp1_3 hdd_3 hdd_3 vdd vdd PMIR W=40u L=1u
Mrp2_3 hv_3 hdd_3 vdd vdd PMIR W=40u L=1u
Rhv_3 hv_3 vg0 8000.0
Vg_1_4_1 g_1_4_1 0 1.7040
Mp_1_4_1 a1 g_1_4_1 colp4 0 NSYN W=10u L=1u
Mn_1_4_1 a1 vcn coln4 0 NSYN W=10u L=1u
Vg_1_4_2 g_1_4_2 0 1.1808
Mp_1_4_2 a2 g_1_4_2 colp4 0 NSYN W=10u L=1u
Mn_1_4_2 a2 vcn coln4 0 NSYN W=10u L=1u
Vg_1_4_b g_1_4_b 0 1.2108
Mp_1_4_b bx g_1_4_b colp4 0 NSYN W=10u L=1u
Mn_1_4_b bx vcn coln4 0 NSYN W=10u L=1u
Msa_h4 coln4 coln4 0 0 NMIR W=20u L=1u
Msb_h4 z1_4 coln4 0 0 NMIR W=20u L=1u
Msc_h4 colp4 colp4 0 0 NMIR W=20u L=1u
Msd_h4 dpf_h4 colp4 0 0 NMIR W=20u L=1u
Mse_h4 dpf_h4 dpf_h4 vdd vdd PMIR W=60u L=1u
Msf_h4 z1_4 dpf_h4 vdd vdd PMIR W=60u L=1u
R_h4 z1_4 vrefh 8000.0
Mr_4 hdd_4 z1_4 0 0 NREL W=12u L=1u
Mrp1_4 hdd_4 hdd_4 vdd vdd PMIR W=40u L=1u
Mrp2_4 hv_4 hdd_4 vdd vdd PMIR W=40u L=1u
Rhv_4 hv_4 vg0 8000.0
Vg_1_5_1 g_1_5_1 0 0.5975
Mp_1_5_1 a1 g_1_5_1 colp5 0 NSYN W=10u L=1u
Mn_1_5_1 a1 vcn coln5 0 NSYN W=10u L=1u
Vg_1_5_2 g_1_5_2 0 2.4931
Mp_1_5_2 a2 g_1_5_2 colp5 0 NSYN W=10u L=1u
Mn_1_5_2 a2 vcn coln5 0 NSYN W=10u L=1u
Vg_1_5_b g_1_5_b 0 1.4955
Mp_1_5_b bx g_1_5_b colp5 0 NSYN W=10u L=1u
Mn_1_5_b bx vcn coln5 0 NSYN W=10u L=1u
Msa_h5 coln5 coln5 0 0 NMIR W=20u L=1u
Msb_h5 z1_5 coln5 0 0 NMIR W=20u L=1u
Msc_h5 colp5 colp5 0 0 NMIR W=20u L=1u
Msd_h5 dpf_h5 colp5 0 0 NMIR W=20u L=1u
Mse_h5 dpf_h5 dpf_h5 vdd vdd PMIR W=60u L=1u
Msf_h5 z1_5 dpf_h5 vdd vdd PMIR W=60u L=1u
R_h5 z1_5 vrefh 8000.0
Mr_5 hdd_5 z1_5 0 0 NREL W=12u L=1u
Mrp1_5 hdd_5 hdd_5 vdd vdd PMIR W=40u L=1u
Mrp2_5 hv_5 hdd_5 vdd vdd PMIR W=40u L=1u
Rhv_5 hv_5 vg0 8000.0
Vg_1_6_1 g_1_6_1 0 0.6890
Mp_1_6_1 a1 g_1_6_1 colp6 0 NSYN W=10u L=1u
Mn_1_6_1 a1 vcn coln6 0 NSYN W=10u L=1u
Vg_1_6_2 g_1_6_2 0 0.5675
Mp_1_6_2 a2 g_1_6_2 colp6 0 NSYN W=10u L=1u
Mn_1_6_2 a2 vcn coln6 0 NSYN W=10u L=1u
Vg_1_6_b g_1_6_b 0 1.9435
Mp_1_6_b bx g_1_6_b colp6 0 NSYN W=10u L=1u
Mn_1_6_b bx vcn coln6 0 NSYN W=10u L=1u
Msa_h6 coln6 coln6 0 0 NMIR W=20u L=1u
Msb_h6 z1_6 coln6 0 0 NMIR W=20u L=1u
Msc_h6 colp6 colp6 0 0 NMIR W=20u L=1u
Msd_h6 dpf_h6 colp6 0 0 NMIR W=20u L=1u
Mse_h6 dpf_h6 dpf_h6 vdd vdd PMIR W=60u L=1u
Msf_h6 z1_6 dpf_h6 vdd vdd PMIR W=60u L=1u
R_h6 z1_6 vrefh 8000.0
Mr_6 hdd_6 z1_6 0 0 NREL W=12u L=1u
Mrp1_6 hdd_6 hdd_6 vdd vdd PMIR W=40u L=1u
Mrp2_6 hv_6 hdd_6 vdd vdd PMIR W=40u L=1u
Rhv_6 hv_6 vg0 8000.0
Vg_2_1 g_2_1 0 2.8386
Mp_2_1 hv_1 g_2_1 colpo 0 NSYN W=10u L=1u
Mn_2_1 hv_1 vcn colno 0 NSYN W=10u L=1u
Vg_2_2 g_2_2 0 2.8208
Mp_2_2 hv_2 g_2_2 colpo 0 NSYN W=10u L=1u
Mn_2_2 hv_2 vcn colno 0 NSYN W=10u L=1u
Vg_2_3 g_2_3 0 2.8337
Mp_2_3 hv_3 g_2_3 colpo 0 NSYN W=10u L=1u
Mn_2_3 hv_3 vcn colno 0 NSYN W=10u L=1u
Vg_2_4 g_2_4 0 2.8337
Mp_2_4 hv_4 g_2_4 colpo 0 NSYN W=10u L=1u
Mn_2_4 hv_4 vcn colno 0 NSYN W=10u L=1u
Vg_2_5 g_2_5 0 2.8207
Mp_2_5 hv_5 g_2_5 colpo 0 NSYN W=10u L=1u
Mn_2_5 hv_5 vcn colno 0 NSYN W=10u L=1u
Vg_2_6 g_2_6 0 0.7163
Mp_2_6 hv_6 g_2_6 colpo 0 NSYN W=10u L=1u
Mn_2_6 hv_6 vcn colno 0 NSYN W=10u L=1u
Vg_2_b g_2_b 0 0.7190
Mp_2_b bx g_2_b colpo 0 NSYN W=10u L=1u
Mn_2_b bx vcn colno 0 NSYN W=10u L=1u
Msa_o colno colno 0 0 NMIR W=20u L=1u
Msb_o y colno 0 0 NMIR W=20u L=1u
Msc_o colpo colpo 0 0 NMIR W=20u L=1u
Msd_o dpf_o colpo 0 0 NMIR W=20u L=1u
Mse_o dpf_o dpf_o vdd vdd PMIR W=60u L=1u
Msf_o y dpf_o vdd vdd PMIR W=60u L=1u
R_o y vrefo 7000.0
.TRAN 0.005 0.8 0 0.005
.options TIMEINT reltol=1e-3 abstol=1e-6
.options DEVICE voltagelimiterflag=1
.PRINT TRAN FORMAT=NOINDEX FILE=xyce_out.prn V(y) V(a1) V(a2) V(tg) V(hv_1) V(hv_2) V(hv_3) V(hv_4) V(hv_5) V(hv_6)
.END
