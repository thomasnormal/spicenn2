EP XOR step
.model NSYN NMOS (LEVEL=1 VTO=0.2 KP=50u LAMBDA=0 GAMMA=0 PHI=0.7)
.model DCL D (IS=1e-9 N=0.2)
Vx1 x1 0 0.5
Vx2 x2 0 0.5
Vx1b x1b 0 0.5
Vx2b x2b 0 0.5
Vt vt 0 0.5
Vcl ncl 0 0.42
Vch nch 0 0.58
Vmid nmid 0 0.5
M0 x1 g11p h1 0 NSYN W=200u L=100u
M1 x1b g11n h1 0 NSYN W=200u L=100u
M2 x2 g21p h1 0 NSYN W=200u L=100u
M3 x2b g21n h1 0 NSYN W=200u L=100u
M4 x1b g11p h1b 0 NSYN W=200u L=100u
M5 x1 g11n h1b 0 NSYN W=200u L=100u
M6 x2b g21p h1b 0 NSYN W=200u L=100u
M7 x2 g21n h1b 0 NSYN W=200u L=100u
M8 x1 g12p h2 0 NSYN W=200u L=100u
M9 x1b g12n h2 0 NSYN W=200u L=100u
M10 x2 g22p h2 0 NSYN W=200u L=100u
M11 x2b g22n h2 0 NSYN W=200u L=100u
M12 x1b g12p h2b 0 NSYN W=200u L=100u
M13 x1 g12n h2b 0 NSYN W=200u L=100u
M14 x2b g22p h2b 0 NSYN W=200u L=100u
M15 x2 g22n h2b 0 NSYN W=200u L=100u
M16 h1 o1p o 0 NSYN W=200u L=100u
M17 h1b o1n o 0 NSYN W=200u L=100u
M18 h2 o2p o 0 NSYN W=200u L=100u
M19 h2b o2n o 0 NSYN W=200u L=100u
Vg11p g11p 0 2.02375
Vg11n g11n 0 2.02375
Vg21p g21p 0 2.02375
Vg21n g21n 0 2.02375
Vg12p g12p 0 2.02375
Vg12n g12n 0 2.02375
Vg22p g22p 0 2.02375
Vg22n g22n 0 2.02375
Vo1p o1p 0 0.90000
Vo1n o1n 0 0.90000
Vo2p o2p 0 0.90000
Vo2n o2n 0 0.90000
Rlh1 h1 nmid 80000.0
Dloh1 ncl h1 DCL
Dhih1 h1 nch DCL
Rlh1b h1b nmid 80000.0
Dloh1b ncl h1b DCL
Dhih1b h1b nch DCL
Rlh2 h2 nmid 80000.0
Dloh2 ncl h2 DCL
Dhih2 h2 nch DCL
Rlh2b h2b nmid 80000.0
Dloh2b ncl h2b DCL
Dhih2b h2b nch DCL
Rlo o nmid 80000.0
Dloo ncl o DCL
Dhio o nch DCL
Rb o vt 1e12
.control
alter Vx1 0.2
alter Vx2 0.2
alter Vx1b 0.8
alter Vx2b 0.8
alter Rb 1e12
op
wrdata xf0.dat v(h1) v(h1b) v(h2) v(h2b) v(o)
alter Vt 0.2
alter Rb 33000.0
op
wrdata xn0.dat v(h1) v(h1b) v(h2) v(h2b) v(o)
alter Vx1 0.2
alter Vx2 0.8
alter Vx1b 0.8
alter Vx2b 0.2
alter Rb 1e12
op
wrdata xf1.dat v(h1) v(h1b) v(h2) v(h2b) v(o)
alter Vt 0.8
alter Rb 33000.0
op
wrdata xn1.dat v(h1) v(h1b) v(h2) v(h2b) v(o)
alter Vx1 0.8
alter Vx2 0.2
alter Vx1b 0.2
alter Vx2b 0.8
alter Rb 1e12
op
wrdata xf2.dat v(h1) v(h1b) v(h2) v(h2b) v(o)
alter Vt 0.8
alter Rb 33000.0
op
wrdata xn2.dat v(h1) v(h1b) v(h2) v(h2b) v(o)
alter Vx1 0.8
alter Vx2 0.8
alter Vx1b 0.2
alter Vx2b 0.2
alter Rb 1e12
op
wrdata xf3.dat v(h1) v(h1b) v(h2) v(h2b) v(o)
alter Vt 0.2
alter Rb 33000.0
op
wrdata xn3.dat v(h1) v(h1b) v(h2) v(h2b) v(o)
.endc
.end
