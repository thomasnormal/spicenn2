EP training step
.model NSYN NMOS (LEVEL=1 VTO=0.2 KP=50u LAMBDA=0 GAMMA=0 PHI=0.7)
Vx1 x1 0 0.5
Vx2 x2 0 0.5
Vx1b x1b 0 0.5
Vx2b x2b 0 0.5
Vhi vhi 0 0.6
Vlo vlo 0 0.4
Vt vt 0 0.5
M1p o vg1p x1 0 NSYN W=200u L=100u
Vg1p vg1p 0 1.23315
M1n o vg1n x1b 0 NSYN W=200u L=100u
Vg1n vg1n 0 0.80000
M2p o vg2p x2 0 NSYN W=200u L=100u
Vg2p vg2p 0 1.23315
M2n o vg2n x2b 0 NSYN W=200u L=100u
Vg2n vg2n 0 0.80000
Mbp o vgbp vhi 0 NSYN W=200u L=100u
Vgbp vgbp 0 0.80000
Mbn o vgbn vlo 0 NSYN W=200u L=100u
Vgbn vgbn 0 1.60000
Rleak o nref 50000.0
Vnref nref 0 0.5
Rb o vt 1e12
.control
alter Vx1 0.4
alter Vx2 0.4
alter Vx1b 0.6
alter Vx2b 0.6
alter Rb 1e12
op
wrdata f0.dat v(o)
alter Vt 0.4
alter Rb 33000.0
op
wrdata n0.dat v(o)
alter Vx1 0.4
alter Vx2 0.6
alter Vx1b 0.6
alter Vx2b 0.4
alter Rb 1e12
op
wrdata f1.dat v(o)
alter Vt 0.4
alter Rb 33000.0
op
wrdata n1.dat v(o)
alter Vx1 0.6
alter Vx2 0.4
alter Vx1b 0.4
alter Vx2b 0.6
alter Rb 1e12
op
wrdata f2.dat v(o)
alter Vt 0.4
alter Rb 33000.0
op
wrdata n2.dat v(o)
alter Vx1 0.6
alter Vx2 0.6
alter Vx1b 0.4
alter Vx2b 0.4
alter Rb 1e12
op
wrdata f3.dat v(o)
alter Vt 0.6
alter Rb 33000.0
op
wrdata n3.dat v(o)
.endc
.end
